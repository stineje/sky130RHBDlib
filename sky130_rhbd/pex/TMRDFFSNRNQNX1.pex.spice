// File: TMRDFFSNRNQNX1.spi.pex
// Created: Sun Apr 12 08:37:23 2026
// Program "Calibre xRC"
// Version "v2023.2_27.15"
// Nominal Temperature: 30C
// Circuit Temperature: 30C
//
simulator lang=spectre
subckt PM_TMRDFFSNRNQNX1\%noxref_1 ( 1 3 6 7 9 10 11 12 14 15 16 17 18 19 20 \
 21 22 23 24 25 28 31 37 45 49 63 66 67 69 70 73 81 89 106 115 120 129 133 134 \
 135 136 137 138 139 140 141 142 143 145 151 152 153 154 158 159 160 161 162 \
 164 170 171 172 173 193 195 196 197 )
c414 ( 193 0 ) capacitor c=0.00885916f //x=3.885 //y=1.095
c415 ( 173 0 ) capacitor c=0.0612936f //x=11.495 //y=4.97
c416 ( 172 0 ) capacitor c=0.0376642f //x=11.785 //y=4.97
c417 ( 171 0 ) capacitor c=0.0346489f //x=11.45 //y=1.4
c418 ( 170 0 ) capacitor c=0.018692f //x=11.45 //y=1.055
c419 ( 164 0 ) capacitor c=0.0137077f //x=11.295 //y=1.555
c420 ( 162 0 ) capacitor c=0.0158585f //x=11.295 //y=0.9
c421 ( 161 0 ) capacitor c=0.0979536f //x=10.92 //y=2.095
c422 ( 160 0 ) capacitor c=0.0229444f //x=10.92 //y=1.71
c423 ( 159 0 ) capacitor c=0.0234359f //x=10.92 //y=1.4
c424 ( 158 0 ) capacitor c=0.019815f //x=10.92 //y=1.055
c425 ( 154 0 ) capacitor c=0.0612936f //x=6.685 //y=4.97
c426 ( 153 0 ) capacitor c=0.0376642f //x=6.975 //y=4.97
c427 ( 152 0 ) capacitor c=0.0346489f //x=6.64 //y=1.4
c428 ( 151 0 ) capacitor c=0.018692f //x=6.64 //y=1.055
c429 ( 145 0 ) capacitor c=0.0137077f //x=6.485 //y=1.555
c430 ( 143 0 ) capacitor c=0.0158585f //x=6.485 //y=0.9
c431 ( 142 0 ) capacitor c=0.0996161f //x=6.11 //y=2.095
c432 ( 141 0 ) capacitor c=0.0229444f //x=6.11 //y=1.71
c433 ( 140 0 ) capacitor c=0.0234359f //x=6.11 //y=1.4
c434 ( 139 0 ) capacitor c=0.019815f //x=6.11 //y=1.055
c435 ( 138 0 ) capacitor c=0.110208f //x=11.86 //y=6.2
c436 ( 137 0 ) capacitor c=0.158957f //x=11.42 //y=6.2
c437 ( 136 0 ) capacitor c=0.110208f //x=7.05 //y=6.2
c438 ( 135 0 ) capacitor c=0.158957f //x=6.61 //y=6.2
c439 ( 129 0 ) capacitor c=0.0014751f //x=11.22 //y=4.88
c440 ( 120 0 ) capacitor c=9.93222e-19 //x=11.22 //y=2.26
c441 ( 115 0 ) capacitor c=0.0014751f //x=6.41 //y=4.88
c442 ( 106 0 ) capacitor c=9.93222e-19 //x=6.41 //y=2.26
c443 ( 89 0 ) capacitor c=0.0293562f //x=3.78 //y=5.56
c444 ( 81 0 ) capacitor c=0.029137f //x=2.9 //y=5.56
c445 ( 73 0 ) capacitor c=0.0278099f //x=2.02 //y=5.56
c446 ( 70 0 ) capacitor c=0.0487028f //x=11.06 //y=2.785
c447 ( 69 0 ) capacitor c=7.81966e-19 //x=11.22 //y=2.785
c448 ( 67 0 ) capacitor c=7.81966e-19 //x=6.575 //y=2.785
c449 ( 66 0 ) capacitor c=0.0212437f //x=6.255 //y=2.785
c450 ( 63 0 ) capacitor c=0.00113895f //x=4.725 //y=2.785
c451 ( 49 0 ) capacitor c=0.0154699f //x=11.22 //y=2.77
c452 ( 45 0 ) capacitor c=0.0148628f //x=6.41 //y=2.77
c453 ( 37 0 ) capacitor c=0.0144706f //x=4.56 //y=2.77
c454 ( 31 0 ) capacitor c=0.00103877f //x=3.78 //y=5.335
c455 ( 28 0 ) capacitor c=0.00794348f //x=2.9 //y=5.335
c456 ( 25 0 ) capacitor c=0.0123281f //x=2.022 //y=5.335
c457 ( 24 0 ) capacitor c=0.0598642f //x=11.22 //y=4.755
c458 ( 23 0 ) capacitor c=0.0130987f //x=11.22 //y=2.945
c459 ( 22 0 ) capacitor c=0.00473602f //x=11.22 //y=2.625
c460 ( 21 0 ) capacitor c=0.00495287f //x=11.22 //y=2.375
c461 ( 20 0 ) capacitor c=0.0665949f //x=6.41 //y=4.755
c462 ( 19 0 ) capacitor c=0.0129702f //x=6.41 //y=2.945
c463 ( 18 0 ) capacitor c=0.00482124f //x=6.41 //y=2.625
c464 ( 17 0 ) capacitor c=0.00495287f //x=6.41 //y=2.375
c465 ( 16 0 ) capacitor c=0.070752f //x=4.56 //y=5.25
c466 ( 15 0 ) capacitor c=0.0123217f //x=4.56 //y=2.945
c467 ( 14 0 ) capacitor c=0.0179579f //x=4.56 //y=2.625
c468 ( 12 0 ) capacitor c=0.00584263f //x=4.16 //y=1.845
c469 ( 11 0 ) capacitor c=0.0129788f //x=4.475 //y=1.845
c470 ( 10 0 ) capacitor c=0.0167992f //x=4.075 //y=1.76
c471 ( 9 0 ) capacitor c=0.0110957f //x=4.075 //y=1.305
c472 ( 7 0 ) capacitor c=0.0248757f //x=4.475 //y=5.335
c473 ( 6 0 ) capacitor c=0.00933983f //x=3.78 //y=5.56
c474 ( 3 0 ) capacitor c=0.0200404f //x=3.665 //y=5.335
c475 ( 1 0 ) capacitor c=0.0155354f //x=2.78 //y=5.335
r476 (  172 174 ) resistor r=26.9307 //w=0.15 //l=0.106066 //layer=ply \
 //thickness=0.18 //x=11.785 //y=4.97 //x2=11.86 //y2=5.045
r477 (  172 173 ) resistor r=148.702 //w=0.094 //l=0.29 //layer=ply \
 //thickness=0.18 //x=11.785 //y=4.97 //x2=11.495 //y2=4.97
r478 (  171 192 ) resistor r=45.1352 //w=0.168 //l=0.173853 //layer=ply \
 //thickness=0.18 //x=11.45 //y=1.4 //x2=11.41 //y2=1.555
r479 (  170 191 ) resistor r=45.1352 //w=0.168 //l=0.173853 //layer=ply \
 //thickness=0.18 //x=11.45 //y=1.055 //x2=11.41 //y2=0.9
r480 (  170 171 ) resistor r=176.904 //w=0.094 //l=0.345 //layer=ply \
 //thickness=0.18 //x=11.45 //y=1.055 //x2=11.45 //y2=1.4
r481 (  167 173 ) resistor r=22.7971 //w=0.269 //l=0.106066 //layer=ply \
 //thickness=0.18 //x=11.42 //y=5.045 //x2=11.495 //y2=4.97
r482 (  167 190 ) resistor r=35.8364 //w=0.269 //l=0.270185 //layer=ply \
 //thickness=0.18 //x=11.42 //y=5.045 //x2=11.22 //y2=4.88
r483 (  165 186 ) resistor r=10.701 //w=0.21 //l=0.115 //layer=ply \
 //thickness=0.18 //x=11.075 //y=1.555 //x2=10.96 //y2=1.555
r484 (  164 192 ) resistor r=5.52526 //w=0.168 //l=0.115 //layer=ply \
 //thickness=0.18 //x=11.295 //y=1.555 //x2=11.41 //y2=1.555
r485 (  163 185 ) resistor r=5.52526 //w=0.168 //l=0.115 //layer=ply \
 //thickness=0.18 //x=11.075 //y=0.9 //x2=10.96 //y2=0.9
r486 (  162 191 ) resistor r=5.52526 //w=0.168 //l=0.115 //layer=ply \
 //thickness=0.18 //x=11.295 //y=0.9 //x2=11.41 //y2=0.9
r487 (  162 163 ) resistor r=112.809 //w=0.094 //l=0.22 //layer=ply \
 //thickness=0.18 //x=11.295 //y=0.9 //x2=11.075 //y2=0.9
r488 (  161 188 ) resistor r=58.7805 //w=0.246 //l=0.373497 //layer=ply \
 //thickness=0.18 //x=10.92 //y=2.095 //x2=11.22 //y2=2.26
r489 (  160 186 ) resistor r=39.5823 //w=0.21 //l=0.173853 //layer=ply \
 //thickness=0.18 //x=10.92 //y=1.71 //x2=10.96 //y2=1.555
r490 (  160 161 ) resistor r=197.415 //w=0.094 //l=0.385 //layer=ply \
 //thickness=0.18 //x=10.92 //y=1.71 //x2=10.92 //y2=2.095
r491 (  159 186 ) resistor r=39.5823 //w=0.21 //l=0.173853 //layer=ply \
 //thickness=0.18 //x=10.92 //y=1.4 //x2=10.96 //y2=1.555
r492 (  158 185 ) resistor r=45.1352 //w=0.168 //l=0.173853 //layer=ply \
 //thickness=0.18 //x=10.92 //y=1.055 //x2=10.96 //y2=0.9
r493 (  158 159 ) resistor r=176.904 //w=0.094 //l=0.345 //layer=ply \
 //thickness=0.18 //x=10.92 //y=1.055 //x2=10.92 //y2=1.4
r494 (  153 155 ) resistor r=26.9307 //w=0.15 //l=0.106066 //layer=ply \
 //thickness=0.18 //x=6.975 //y=4.97 //x2=7.05 //y2=5.045
r495 (  153 154 ) resistor r=148.702 //w=0.094 //l=0.29 //layer=ply \
 //thickness=0.18 //x=6.975 //y=4.97 //x2=6.685 //y2=4.97
r496 (  152 184 ) resistor r=45.1352 //w=0.168 //l=0.173853 //layer=ply \
 //thickness=0.18 //x=6.64 //y=1.4 //x2=6.6 //y2=1.555
r497 (  151 183 ) resistor r=45.1352 //w=0.168 //l=0.173853 //layer=ply \
 //thickness=0.18 //x=6.64 //y=1.055 //x2=6.6 //y2=0.9
r498 (  151 152 ) resistor r=176.904 //w=0.094 //l=0.345 //layer=ply \
 //thickness=0.18 //x=6.64 //y=1.055 //x2=6.64 //y2=1.4
r499 (  148 154 ) resistor r=22.7971 //w=0.269 //l=0.106066 //layer=ply \
 //thickness=0.18 //x=6.61 //y=5.045 //x2=6.685 //y2=4.97
r500 (  148 182 ) resistor r=35.8364 //w=0.269 //l=0.270185 //layer=ply \
 //thickness=0.18 //x=6.61 //y=5.045 //x2=6.41 //y2=4.88
r501 (  146 178 ) resistor r=10.701 //w=0.21 //l=0.115 //layer=ply \
 //thickness=0.18 //x=6.265 //y=1.555 //x2=6.15 //y2=1.555
r502 (  145 184 ) resistor r=5.52526 //w=0.168 //l=0.115 //layer=ply \
 //thickness=0.18 //x=6.485 //y=1.555 //x2=6.6 //y2=1.555
r503 (  144 177 ) resistor r=5.52526 //w=0.168 //l=0.115 //layer=ply \
 //thickness=0.18 //x=6.265 //y=0.9 //x2=6.15 //y2=0.9
r504 (  143 183 ) resistor r=5.52526 //w=0.168 //l=0.115 //layer=ply \
 //thickness=0.18 //x=6.485 //y=0.9 //x2=6.6 //y2=0.9
r505 (  143 144 ) resistor r=112.809 //w=0.094 //l=0.22 //layer=ply \
 //thickness=0.18 //x=6.485 //y=0.9 //x2=6.265 //y2=0.9
r506 (  142 180 ) resistor r=58.7805 //w=0.246 //l=0.373497 //layer=ply \
 //thickness=0.18 //x=6.11 //y=2.095 //x2=6.41 //y2=2.26
r507 (  141 178 ) resistor r=39.5823 //w=0.21 //l=0.173853 //layer=ply \
 //thickness=0.18 //x=6.11 //y=1.71 //x2=6.15 //y2=1.555
r508 (  141 142 ) resistor r=197.415 //w=0.094 //l=0.385 //layer=ply \
 //thickness=0.18 //x=6.11 //y=1.71 //x2=6.11 //y2=2.095
r509 (  140 178 ) resistor r=39.5823 //w=0.21 //l=0.173853 //layer=ply \
 //thickness=0.18 //x=6.11 //y=1.4 //x2=6.15 //y2=1.555
r510 (  139 177 ) resistor r=45.1352 //w=0.168 //l=0.173853 //layer=ply \
 //thickness=0.18 //x=6.11 //y=1.055 //x2=6.15 //y2=0.9
r511 (  139 140 ) resistor r=176.904 //w=0.094 //l=0.345 //layer=ply \
 //thickness=0.18 //x=6.11 //y=1.055 //x2=6.11 //y2=1.4
r512 (  138 174 ) resistor r=592.245 //w=0.094 //l=1.155 //layer=ply \
 //thickness=0.18 //x=11.86 //y=6.2 //x2=11.86 //y2=5.045
r513 (  137 167 ) resistor r=592.245 //w=0.094 //l=1.155 //layer=ply \
 //thickness=0.18 //x=11.42 //y=6.2 //x2=11.42 //y2=5.045
r514 (  136 155 ) resistor r=592.245 //w=0.094 //l=1.155 //layer=ply \
 //thickness=0.18 //x=7.05 //y=6.2 //x2=7.05 //y2=5.045
r515 (  135 148 ) resistor r=592.245 //w=0.094 //l=1.155 //layer=ply \
 //thickness=0.18 //x=6.61 //y=6.2 //x2=6.61 //y2=5.045
r516 (  134 164 ) resistor r=56.4043 //w=0.094 //l=0.11 //layer=ply \
 //thickness=0.18 //x=11.185 //y=1.555 //x2=11.295 //y2=1.555
r517 (  134 165 ) resistor r=56.4043 //w=0.094 //l=0.11 //layer=ply \
 //thickness=0.18 //x=11.185 //y=1.555 //x2=11.075 //y2=1.555
r518 (  133 145 ) resistor r=56.4043 //w=0.094 //l=0.11 //layer=ply \
 //thickness=0.18 //x=6.375 //y=1.555 //x2=6.485 //y2=1.555
r519 (  133 146 ) resistor r=56.4043 //w=0.094 //l=0.11 //layer=ply \
 //thickness=0.18 //x=6.375 //y=1.555 //x2=6.265 //y2=1.555
r520 (  129 190 ) resistor r=152 //w=0.17 //l=0.17 //layer=licon //count=1 \
 //x=11.22 //y=4.88 //x2=11.22 //y2=4.88
r521 (  120 188 ) resistor r=152 //w=0.17 //l=0.17 //layer=licon //count=1 \
 //x=11.22 //y=2.26 //x2=11.22 //y2=2.26
r522 (  115 182 ) resistor r=152 //w=0.17 //l=0.17 //layer=licon //count=1 \
 //x=6.41 //y=4.88 //x2=6.41 //y2=4.88
r523 (  106 180 ) resistor r=152 //w=0.17 //l=0.17 //layer=licon //count=1 \
 //x=6.41 //y=2.26 //x2=6.41 //y2=2.26
r524 (  89 197 ) resistor r=23.615 //w=0.187 //l=0.345 //layer=li \
 //thickness=0.1 //x=3.78 //y=5.56 //x2=3.78 //y2=5.905
r525 (  81 196 ) resistor r=23.615 //w=0.187 //l=0.345 //layer=li \
 //thickness=0.1 //x=2.9 //y=5.56 //x2=2.9 //y2=5.905
r526 (  73 195 ) resistor r=23.615 //w=0.187 //l=0.345 //layer=li \
 //thickness=0.1 //x=2.02 //y=5.56 //x2=2.02 //y2=5.905
r527 (  69 70 ) resistor r=0.10734 //w=0.281 //l=0.16 //layer=m2 \
 //thickness=0.36 //x=11.22 //y=2.785 //x2=11.06 //y2=2.785
r528 (  67 70 ) resistor r=4.27958 //w=0.131 //l=4.485 //layer=m2 \
 //thickness=0.36 //x=6.575 //y=2.77 //x2=11.06 //y2=2.77
r529 (  65 67 ) resistor r=0.10734 //w=0.281 //l=0.16 //layer=m2 \
 //thickness=0.36 //x=6.415 //y=2.785 //x2=6.575 //y2=2.785
r530 (  65 66 ) resistor r=0.10734 //w=0.281 //l=0.16 //layer=m2 \
 //thickness=0.36 //x=6.415 //y=2.785 //x2=6.255 //y2=2.785
r531 (  63 66 ) resistor r=1.45992 //w=0.131 //l=1.53 //layer=m2 \
 //thickness=0.36 //x=4.725 //y=2.77 //x2=6.255 //y2=2.77
r532 (  61 63 ) resistor r=0.10734 //w=0.281 //l=0.16 //layer=m2 \
 //thickness=0.36 //x=4.565 //y=2.785 //x2=4.725 //y2=2.785
r533 (  55 129 ) resistor r=9.3 //w=0.17 //l=0.17 //layer=mcon //count=1 \
 //x=11.22 //y=4.88 //x2=11.22 //y2=4.88
r534 (  53 120 ) resistor r=9.3 //w=0.17 //l=0.17 //layer=mcon //count=1 \
 //x=11.22 //y=2.26 //x2=11.22 //y2=2.26
r535 (  51 69 ) resistor r=4.5 //w=0.15 //l=0.15 //layer=via1 //count=1 \
 //x=11.22 //y=2.785 //x2=11.22 //y2=2.785
r536 (  49 51 ) resistor r=0.0049867 //w=0.376 //l=0.015 //layer=m1 \
 //thickness=0.36 //x=11.167 //y=2.77 //x2=11.167 //y2=2.785
r537 (  47 65 ) resistor r=4.5 //w=0.15 //l=0.15 //layer=via1 //count=1 \
 //x=6.415 //y=2.785 //x2=6.415 //y2=2.785
r538 (  45 47 ) resistor r=0.00501337 //w=0.374 //l=0.015 //layer=m1 \
 //thickness=0.36 //x=6.465 //y=2.77 //x2=6.465 //y2=2.785
r539 (  43 115 ) resistor r=9.3 //w=0.17 //l=0.17 //layer=mcon //count=1 \
 //x=6.41 //y=4.88 //x2=6.41 //y2=4.88
r540 (  41 106 ) resistor r=9.3 //w=0.17 //l=0.17 //layer=mcon //count=1 \
 //x=6.41 //y=2.26 //x2=6.41 //y2=2.26
r541 (  39 61 ) resistor r=4.5 //w=0.15 //l=0.15 //layer=via1 //count=1 \
 //x=4.565 //y=2.785 //x2=4.565 //y2=2.785
r542 (  37 39 ) resistor r=0.00501337 //w=0.374 //l=0.015 //layer=m1 \
 //thickness=0.36 //x=4.615 //y=2.77 //x2=4.615 //y2=2.785
r543 (  35 193 ) resistor r=9.3 //w=0.17 //l=0.17 //layer=mcon //count=1 \
 //x=4.075 //y=1.19 //x2=4.075 //y2=1.19
r544 (  33 89 ) resistor r=9.3 //w=0.17 //l=0.17 //layer=mcon //count=1 \
 //x=3.78 //y=5.56 //x2=3.78 //y2=5.56
r545 (  30 81 ) resistor r=9.3 //w=0.17 //l=0.17 //layer=mcon //count=1 \
 //x=2.9 //y=5.56 //x2=2.9 //y2=5.56
r546 (  28 30 ) resistor r=0.121228 //w=0.232 //l=0.225 //layer=m1 \
 //thickness=0.36 //x=2.9 //y=5.335 //x2=2.9 //y2=5.56
r547 (  27 73 ) resistor r=9.3 //w=0.17 //l=0.17 //layer=mcon //count=1 \
 //x=2.02 //y=5.56 //x2=2.02 //y2=5.56
r548 (  25 27 ) resistor r=0.129608 //w=0.217 //l=0.225 //layer=m1 \
 //thickness=0.36 //x=2.022 //y=5.335 //x2=2.022 //y2=5.56
r549 (  24 55 ) resistor r=0.0760407 //w=0.238 //l=0.125 //layer=m1 \
 //thickness=0.36 //x=11.22 //y=4.755 //x2=11.22 //y2=4.88
r550 (  23 51 ) resistor r=0.0911593 //w=0.376 //l=0.184608 //layer=m1 \
 //thickness=0.36 //x=11.22 //y=2.945 //x2=11.167 //y2=2.785
r551 (  23 24 ) resistor r=1.7271 //w=0.131 //l=1.81 //layer=m1 \
 //thickness=0.36 //x=11.22 //y=2.945 //x2=11.22 //y2=4.755
r552 (  22 49 ) resistor r=0.0861726 //w=0.376 //l=0.16944 //layer=m1 \
 //thickness=0.36 //x=11.22 //y=2.625 //x2=11.167 //y2=2.77
r553 (  21 53 ) resistor r=0.0719237 //w=0.222 //l=0.115 //layer=m1 \
 //thickness=0.36 //x=11.22 //y=2.375 //x2=11.22 //y2=2.26
r554 (  21 22 ) resistor r=0.23855 //w=0.131 //l=0.25 //layer=m1 \
 //thickness=0.36 //x=11.22 //y=2.375 //x2=11.22 //y2=2.625
r555 (  20 43 ) resistor r=0.0760407 //w=0.238 //l=0.125 //layer=m1 \
 //thickness=0.36 //x=6.41 //y=4.755 //x2=6.41 //y2=4.88
r556 (  19 47 ) resistor r=0.0910802 //w=0.374 //l=0.185472 //layer=m1 \
 //thickness=0.36 //x=6.41 //y=2.945 //x2=6.465 //y2=2.785
r557 (  19 20 ) resistor r=1.7271 //w=0.131 //l=1.81 //layer=m1 \
 //thickness=0.36 //x=6.41 //y=2.945 //x2=6.41 //y2=4.755
r558 (  18 45 ) resistor r=0.0860668 //w=0.374 //l=0.170294 //layer=m1 \
 //thickness=0.36 //x=6.41 //y=2.625 //x2=6.465 //y2=2.77
r559 (  17 41 ) resistor r=0.0719237 //w=0.222 //l=0.115 //layer=m1 \
 //thickness=0.36 //x=6.41 //y=2.375 //x2=6.41 //y2=2.26
r560 (  17 18 ) resistor r=0.23855 //w=0.131 //l=0.25 //layer=m1 \
 //thickness=0.36 //x=6.41 //y=2.375 //x2=6.41 //y2=2.625
r561 (  15 39 ) resistor r=0.0910802 //w=0.374 //l=0.185472 //layer=m1 \
 //thickness=0.36 //x=4.56 //y=2.945 //x2=4.615 //y2=2.785
r562 (  15 16 ) resistor r=2.19943 //w=0.131 //l=2.305 //layer=m1 \
 //thickness=0.36 //x=4.56 //y=2.945 //x2=4.56 //y2=5.25
r563 (  14 37 ) resistor r=0.0860668 //w=0.374 //l=0.170294 //layer=m1 \
 //thickness=0.36 //x=4.56 //y=2.625 //x2=4.615 //y2=2.77
r564 (  13 14 ) resistor r=0.663168 //w=0.131 //l=0.695 //layer=m1 \
 //thickness=0.36 //x=4.56 //y=1.93 //x2=4.56 //y2=2.625
r565 (  11 13 ) resistor r=0.0698411 //w=0.17 //l=0.120208 //layer=m1 \
 //thickness=0.36 //x=4.475 //y=1.845 //x2=4.56 //y2=1.93
r566 (  11 12 ) resistor r=0.300573 //w=0.131 //l=0.315 //layer=m1 \
 //thickness=0.36 //x=4.475 //y=1.845 //x2=4.16 //y2=1.845
r567 (  10 12 ) resistor r=0.0698411 //w=0.17 //l=0.120208 //layer=m1 \
 //thickness=0.36 //x=4.075 //y=1.76 //x2=4.16 //y2=1.845
r568 (  9 35 ) resistor r=0.0717383 //w=0.224 //l=0.115 //layer=m1 \
 //thickness=0.36 //x=4.075 //y=1.305 //x2=4.075 //y2=1.19
r569 (  9 10 ) resistor r=0.43416 //w=0.131 //l=0.455 //layer=m1 \
 //thickness=0.36 //x=4.075 //y=1.305 //x2=4.075 //y2=1.76
r570 (  8 31 ) resistor r=0.0675342 //w=0.23 //l=0.115 //layer=m1 \
 //thickness=0.36 //x=3.895 //y=5.335 //x2=3.78 //y2=5.335
r571 (  7 16 ) resistor r=0.0698411 //w=0.17 //l=0.120208 //layer=m1 \
 //thickness=0.36 //x=4.475 //y=5.335 //x2=4.56 //y2=5.25
r572 (  7 8 ) resistor r=0.553435 //w=0.131 //l=0.58 //layer=m1 \
 //thickness=0.36 //x=4.475 //y=5.335 //x2=3.895 //y2=5.335
r573 (  6 33 ) resistor r=0.00118313 //w=0.23 //layer=m1 //thickness=0.36 \
 //x=3.78 //y=5.56 //x2=3.78 //y2=5.56
r574 (  5 31 ) resistor r=0.002872 //w=0.34 //l=0.085 //layer=m1 \
 //thickness=0.36 //x=3.78 //y=5.42 //x2=3.78 //y2=5.335
r575 (  5 6 ) resistor r=0.091623 //w=0.191 //l=0.14 //layer=m1 \
 //thickness=0.36 //x=3.78 //y=5.42 //x2=3.78 //y2=5.56
r576 (  4 28 ) resistor r=0.0262263 //w=0.232 //l=0.12 //layer=m1 \
 //thickness=0.36 //x=3.02 //y=5.335 //x2=2.9 //y2=5.335
r577 (  3 31 ) resistor r=0.0675342 //w=0.23 //l=0.115 //layer=m1 \
 //thickness=0.36 //x=3.665 //y=5.335 //x2=3.78 //y2=5.335
r578 (  3 4 ) resistor r=0.615458 //w=0.131 //l=0.645 //layer=m1 \
 //thickness=0.36 //x=3.665 //y=5.335 //x2=3.02 //y2=5.335
r579 (  2 25 ) resistor r=0.0222262 //w=0.217 //l=0.118 //layer=m1 \
 //thickness=0.36 //x=2.14 //y=5.335 //x2=2.022 //y2=5.335
r580 (  1 28 ) resistor r=0.0262263 //w=0.232 //l=0.12 //layer=m1 \
 //thickness=0.36 //x=2.78 //y=5.335 //x2=2.9 //y2=5.335
r581 (  1 2 ) resistor r=0.610687 //w=0.131 //l=0.64 //layer=m1 \
 //thickness=0.36 //x=2.78 //y=5.335 //x2=2.14 //y2=5.335
ends PM_TMRDFFSNRNQNX1\%noxref_1

subckt PM_TMRDFFSNRNQNX1\%noxref_2 ( 1 3 6 7 9 10 11 12 14 15 16 17 18 19 20 \
 21 24 27 33 36 42 43 48 51 59 67 84 93 97 98 99 100 101 102 103 104 106 112 \
 113 114 115 127 129 130 131 )
c293 ( 127 0 ) capacitor c=0.00885916f //x=13.505 //y=1.095
c294 ( 115 0 ) capacitor c=0.0612936f //x=16.305 //y=4.97
c295 ( 114 0 ) capacitor c=0.0376642f //x=16.595 //y=4.97
c296 ( 113 0 ) capacitor c=0.0346489f //x=16.26 //y=1.4
c297 ( 112 0 ) capacitor c=0.018692f //x=16.26 //y=1.055
c298 ( 106 0 ) capacitor c=0.0137077f //x=16.105 //y=1.555
c299 ( 104 0 ) capacitor c=0.0158585f //x=16.105 //y=0.9
c300 ( 103 0 ) capacitor c=0.0979523f //x=15.73 //y=2.095
c301 ( 102 0 ) capacitor c=0.0229444f //x=15.73 //y=1.71
c302 ( 101 0 ) capacitor c=0.0234359f //x=15.73 //y=1.4
c303 ( 100 0 ) capacitor c=0.019815f //x=15.73 //y=1.055
c304 ( 99 0 ) capacitor c=0.110208f //x=16.67 //y=6.2
c305 ( 98 0 ) capacitor c=0.158957f //x=16.23 //y=6.2
c306 ( 93 0 ) capacitor c=0.0014751f //x=16.03 //y=4.88
c307 ( 84 0 ) capacitor c=9.93222e-19 //x=16.03 //y=2.26
c308 ( 67 0 ) capacitor c=0.0293723f //x=13.4 //y=5.56
c309 ( 59 0 ) capacitor c=0.029137f //x=12.52 //y=5.56
c310 ( 51 0 ) capacitor c=0.0278099f //x=11.64 //y=5.56
c311 ( 48 0 ) capacitor c=6.57651e-19 //x=16.04 //y=2.77
c312 ( 43 0 ) capacitor c=9.44624e-19 //x=14.34 //y=2.77
c313 ( 42 0 ) capacitor c=0.0155215f //x=15.88 //y=2.77
c314 ( 36 0 ) capacitor c=0.0146045f //x=16.03 //y=2.77
c315 ( 33 0 ) capacitor c=0.0146969f //x=14.18 //y=2.77
c316 ( 27 0 ) capacitor c=8.8245e-19 //x=13.4 //y=5.335
c317 ( 24 0 ) capacitor c=0.00726074f //x=12.52 //y=5.335
c318 ( 21 0 ) capacitor c=0.0111234f //x=11.642 //y=5.335
c319 ( 20 0 ) capacitor c=0.0633726f //x=16.03 //y=4.755
c320 ( 19 0 ) capacitor c=0.0131932f //x=16.03 //y=2.93
c321 ( 18 0 ) capacitor c=0.00432188f //x=16.03 //y=2.61
c322 ( 17 0 ) capacitor c=0.00485584f //x=16.03 //y=2.375
c323 ( 16 0 ) capacitor c=0.064515f //x=14.18 //y=5.25
c324 ( 15 0 ) capacitor c=0.0122936f //x=14.18 //y=2.93
c325 ( 14 0 ) capacitor c=0.0181662f //x=14.18 //y=2.61
c326 ( 12 0 ) capacitor c=0.00493487f //x=13.78 //y=1.845
c327 ( 11 0 ) capacitor c=0.0129068f //x=14.095 //y=1.845
c328 ( 10 0 ) capacitor c=0.0167992f //x=13.695 //y=1.76
c329 ( 9 0 ) capacitor c=0.0112867f //x=13.695 //y=1.305
c330 ( 7 0 ) capacitor c=0.0236685f //x=14.095 //y=5.335
c331 ( 6 0 ) capacitor c=0.00933983f //x=13.4 //y=5.56
c332 ( 3 0 ) capacitor c=0.0180822f //x=13.285 //y=5.335
c333 ( 1 0 ) capacitor c=0.0151332f //x=12.4 //y=5.335
r334 (  114 116 ) resistor r=26.9307 //w=0.15 //l=0.106066 //layer=ply \
 //thickness=0.18 //x=16.595 //y=4.97 //x2=16.67 //y2=5.045
r335 (  114 115 ) resistor r=148.702 //w=0.094 //l=0.29 //layer=ply \
 //thickness=0.18 //x=16.595 //y=4.97 //x2=16.305 //y2=4.97
r336 (  113 126 ) resistor r=45.1352 //w=0.168 //l=0.173853 //layer=ply \
 //thickness=0.18 //x=16.26 //y=1.4 //x2=16.22 //y2=1.555
r337 (  112 125 ) resistor r=45.1352 //w=0.168 //l=0.173853 //layer=ply \
 //thickness=0.18 //x=16.26 //y=1.055 //x2=16.22 //y2=0.9
r338 (  112 113 ) resistor r=176.904 //w=0.094 //l=0.345 //layer=ply \
 //thickness=0.18 //x=16.26 //y=1.055 //x2=16.26 //y2=1.4
r339 (  109 115 ) resistor r=22.7971 //w=0.269 //l=0.106066 //layer=ply \
 //thickness=0.18 //x=16.23 //y=5.045 //x2=16.305 //y2=4.97
r340 (  109 124 ) resistor r=35.8364 //w=0.269 //l=0.270185 //layer=ply \
 //thickness=0.18 //x=16.23 //y=5.045 //x2=16.03 //y2=4.88
r341 (  107 120 ) resistor r=10.701 //w=0.21 //l=0.115 //layer=ply \
 //thickness=0.18 //x=15.885 //y=1.555 //x2=15.77 //y2=1.555
r342 (  106 126 ) resistor r=5.52526 //w=0.168 //l=0.115 //layer=ply \
 //thickness=0.18 //x=16.105 //y=1.555 //x2=16.22 //y2=1.555
r343 (  105 119 ) resistor r=5.52526 //w=0.168 //l=0.115 //layer=ply \
 //thickness=0.18 //x=15.885 //y=0.9 //x2=15.77 //y2=0.9
r344 (  104 125 ) resistor r=5.52526 //w=0.168 //l=0.115 //layer=ply \
 //thickness=0.18 //x=16.105 //y=0.9 //x2=16.22 //y2=0.9
r345 (  104 105 ) resistor r=112.809 //w=0.094 //l=0.22 //layer=ply \
 //thickness=0.18 //x=16.105 //y=0.9 //x2=15.885 //y2=0.9
r346 (  103 122 ) resistor r=58.7805 //w=0.246 //l=0.373497 //layer=ply \
 //thickness=0.18 //x=15.73 //y=2.095 //x2=16.03 //y2=2.26
r347 (  102 120 ) resistor r=39.5823 //w=0.21 //l=0.173853 //layer=ply \
 //thickness=0.18 //x=15.73 //y=1.71 //x2=15.77 //y2=1.555
r348 (  102 103 ) resistor r=197.415 //w=0.094 //l=0.385 //layer=ply \
 //thickness=0.18 //x=15.73 //y=1.71 //x2=15.73 //y2=2.095
r349 (  101 120 ) resistor r=39.5823 //w=0.21 //l=0.173853 //layer=ply \
 //thickness=0.18 //x=15.73 //y=1.4 //x2=15.77 //y2=1.555
r350 (  100 119 ) resistor r=45.1352 //w=0.168 //l=0.173853 //layer=ply \
 //thickness=0.18 //x=15.73 //y=1.055 //x2=15.77 //y2=0.9
r351 (  100 101 ) resistor r=176.904 //w=0.094 //l=0.345 //layer=ply \
 //thickness=0.18 //x=15.73 //y=1.055 //x2=15.73 //y2=1.4
r352 (  99 116 ) resistor r=592.245 //w=0.094 //l=1.155 //layer=ply \
 //thickness=0.18 //x=16.67 //y=6.2 //x2=16.67 //y2=5.045
r353 (  98 109 ) resistor r=592.245 //w=0.094 //l=1.155 //layer=ply \
 //thickness=0.18 //x=16.23 //y=6.2 //x2=16.23 //y2=5.045
r354 (  97 106 ) resistor r=56.4043 //w=0.094 //l=0.11 //layer=ply \
 //thickness=0.18 //x=15.995 //y=1.555 //x2=16.105 //y2=1.555
r355 (  97 107 ) resistor r=56.4043 //w=0.094 //l=0.11 //layer=ply \
 //thickness=0.18 //x=15.995 //y=1.555 //x2=15.885 //y2=1.555
r356 (  93 124 ) resistor r=152 //w=0.17 //l=0.17 //layer=licon //count=1 \
 //x=16.03 //y=4.88 //x2=16.03 //y2=4.88
r357 (  84 122 ) resistor r=152 //w=0.17 //l=0.17 //layer=licon //count=1 \
 //x=16.03 //y=2.26 //x2=16.03 //y2=2.26
r358 (  67 131 ) resistor r=23.615 //w=0.187 //l=0.345 //layer=li \
 //thickness=0.1 //x=13.4 //y=5.56 //x2=13.4 //y2=5.905
r359 (  59 130 ) resistor r=23.615 //w=0.187 //l=0.345 //layer=li \
 //thickness=0.1 //x=12.52 //y=5.56 //x2=12.52 //y2=5.905
r360 (  51 129 ) resistor r=23.615 //w=0.187 //l=0.345 //layer=li \
 //thickness=0.1 //x=11.64 //y=5.56 //x2=11.64 //y2=5.905
r361 (  43 45 ) resistor r=0.10734 //w=0.281 //l=0.16 //layer=m2 \
 //thickness=0.36 //x=14.34 //y=2.77 //x2=14.18 //y2=2.77
r362 (  42 48 ) resistor r=0.10734 //w=0.281 //l=0.16 //layer=m2 \
 //thickness=0.36 //x=15.88 //y=2.77 //x2=16.04 //y2=2.77
r363 (  42 43 ) resistor r=1.46947 //w=0.131 //l=1.54 //layer=m2 \
 //thickness=0.36 //x=15.88 //y=2.77 //x2=14.34 //y2=2.77
r364 (  41 93 ) resistor r=9.3 //w=0.17 //l=0.17 //layer=mcon //count=1 \
 //x=16.03 //y=4.88 //x2=16.03 //y2=4.88
r365 (  39 84 ) resistor r=9.3 //w=0.17 //l=0.17 //layer=mcon //count=1 \
 //x=16.03 //y=2.26 //x2=16.03 //y2=2.26
r366 (  36 48 ) resistor r=4.5 //w=0.15 //l=0.15 //layer=via1 //count=1 \
 //x=16.04 //y=2.77 //x2=16.04 //y2=2.77
r367 (  33 45 ) resistor r=4.5 //w=0.15 //l=0.15 //layer=via1 //count=1 \
 //x=14.18 //y=2.77 //x2=14.18 //y2=2.77
r368 (  31 127 ) resistor r=9.3 //w=0.17 //l=0.17 //layer=mcon //count=1 \
 //x=13.695 //y=1.19 //x2=13.695 //y2=1.19
r369 (  29 67 ) resistor r=9.3 //w=0.17 //l=0.17 //layer=mcon //count=1 \
 //x=13.4 //y=5.56 //x2=13.4 //y2=5.56
r370 (  26 59 ) resistor r=9.3 //w=0.17 //l=0.17 //layer=mcon //count=1 \
 //x=12.52 //y=5.56 //x2=12.52 //y2=5.56
r371 (  24 26 ) resistor r=0.121228 //w=0.232 //l=0.225 //layer=m1 \
 //thickness=0.36 //x=12.52 //y=5.335 //x2=12.52 //y2=5.56
r372 (  23 51 ) resistor r=9.3 //w=0.17 //l=0.17 //layer=mcon //count=1 \
 //x=11.64 //y=5.56 //x2=11.64 //y2=5.56
r373 (  21 23 ) resistor r=0.129608 //w=0.217 //l=0.225 //layer=m1 \
 //thickness=0.36 //x=11.642 //y=5.335 //x2=11.642 //y2=5.56
r374 (  20 41 ) resistor r=0.0760407 //w=0.238 //l=0.125 //layer=m1 \
 //thickness=0.36 //x=16.03 //y=4.755 //x2=16.03 //y2=4.88
r375 (  19 36 ) resistor r=0.0914072 //w=0.382 //l=0.182428 //layer=m1 \
 //thickness=0.36 //x=16.03 //y=2.93 //x2=15.982 //y2=2.77
r376 (  19 20 ) resistor r=1.74141 //w=0.131 //l=1.825 //layer=m1 \
 //thickness=0.36 //x=16.03 //y=2.93 //x2=16.03 //y2=4.755
r377 (  18 36 ) resistor r=0.0914072 //w=0.382 //l=0.182428 //layer=m1 \
 //thickness=0.36 //x=16.03 //y=2.61 //x2=15.982 //y2=2.77
r378 (  17 39 ) resistor r=0.0719237 //w=0.222 //l=0.115 //layer=m1 \
 //thickness=0.36 //x=16.03 //y=2.375 //x2=16.03 //y2=2.26
r379 (  17 18 ) resistor r=0.224237 //w=0.131 //l=0.235 //layer=m1 \
 //thickness=0.36 //x=16.03 //y=2.375 //x2=16.03 //y2=2.61
r380 (  15 33 ) resistor r=0.0911593 //w=0.376 //l=0.184174 //layer=m1 \
 //thickness=0.36 //x=14.18 //y=2.93 //x2=14.232 //y2=2.77
r381 (  15 16 ) resistor r=2.21374 //w=0.131 //l=2.32 //layer=m1 \
 //thickness=0.36 //x=14.18 //y=2.93 //x2=14.18 //y2=5.25
r382 (  14 33 ) resistor r=0.0911593 //w=0.376 //l=0.184174 //layer=m1 \
 //thickness=0.36 //x=14.18 //y=2.61 //x2=14.232 //y2=2.77
r383 (  13 14 ) resistor r=0.648855 //w=0.131 //l=0.68 //layer=m1 \
 //thickness=0.36 //x=14.18 //y=1.93 //x2=14.18 //y2=2.61
r384 (  11 13 ) resistor r=0.0698411 //w=0.17 //l=0.120208 //layer=m1 \
 //thickness=0.36 //x=14.095 //y=1.845 //x2=14.18 //y2=1.93
r385 (  11 12 ) resistor r=0.300573 //w=0.131 //l=0.315 //layer=m1 \
 //thickness=0.36 //x=14.095 //y=1.845 //x2=13.78 //y2=1.845
r386 (  10 12 ) resistor r=0.0698411 //w=0.17 //l=0.120208 //layer=m1 \
 //thickness=0.36 //x=13.695 //y=1.76 //x2=13.78 //y2=1.845
r387 (  9 31 ) resistor r=0.0717383 //w=0.224 //l=0.115 //layer=m1 \
 //thickness=0.36 //x=13.695 //y=1.305 //x2=13.695 //y2=1.19
r388 (  9 10 ) resistor r=0.43416 //w=0.131 //l=0.455 //layer=m1 \
 //thickness=0.36 //x=13.695 //y=1.305 //x2=13.695 //y2=1.76
r389 (  8 27 ) resistor r=0.0675342 //w=0.23 //l=0.115 //layer=m1 \
 //thickness=0.36 //x=13.515 //y=5.335 //x2=13.4 //y2=5.335
r390 (  7 16 ) resistor r=0.0698411 //w=0.17 //l=0.120208 //layer=m1 \
 //thickness=0.36 //x=14.095 //y=5.335 //x2=14.18 //y2=5.25
r391 (  7 8 ) resistor r=0.553435 //w=0.131 //l=0.58 //layer=m1 \
 //thickness=0.36 //x=14.095 //y=5.335 //x2=13.515 //y2=5.335
r392 (  6 29 ) resistor r=0.00118313 //w=0.23 //layer=m1 //thickness=0.36 \
 //x=13.4 //y=5.56 //x2=13.4 //y2=5.56
r393 (  5 27 ) resistor r=0.002872 //w=0.34 //l=0.085 //layer=m1 \
 //thickness=0.36 //x=13.4 //y=5.42 //x2=13.4 //y2=5.335
r394 (  5 6 ) resistor r=0.091623 //w=0.191 //l=0.14 //layer=m1 \
 //thickness=0.36 //x=13.4 //y=5.42 //x2=13.4 //y2=5.56
r395 (  4 24 ) resistor r=0.0262263 //w=0.232 //l=0.12 //layer=m1 \
 //thickness=0.36 //x=12.64 //y=5.335 //x2=12.52 //y2=5.335
r396 (  3 27 ) resistor r=0.0675342 //w=0.23 //l=0.115 //layer=m1 \
 //thickness=0.36 //x=13.285 //y=5.335 //x2=13.4 //y2=5.335
r397 (  3 4 ) resistor r=0.615458 //w=0.131 //l=0.645 //layer=m1 \
 //thickness=0.36 //x=13.285 //y=5.335 //x2=12.64 //y2=5.335
r398 (  2 21 ) resistor r=0.0222262 //w=0.217 //l=0.118 //layer=m1 \
 //thickness=0.36 //x=11.76 //y=5.335 //x2=11.642 //y2=5.335
r399 (  1 24 ) resistor r=0.0262263 //w=0.232 //l=0.12 //layer=m1 \
 //thickness=0.36 //x=12.4 //y=5.335 //x2=12.52 //y2=5.335
r400 (  1 2 ) resistor r=0.610687 //w=0.131 //l=0.64 //layer=m1 \
 //thickness=0.36 //x=12.4 //y=5.335 //x2=11.76 //y2=5.335
ends PM_TMRDFFSNRNQNX1\%noxref_2

subckt PM_TMRDFFSNRNQNX1\%noxref_3 ( 1 2 3 4 5 7 10 11 13 14 15 16 18 19 20 21 \
 22 23 24 30 33 36 39 47 49 57 62 65 66 68 71 80 85 93 101 118 127 131 132 133 \
 134 135 136 140 141 142 147 149 152 153 154 155 156 157 158 160 166 167 168 \
 169 174 175 180 191 193 194 195 )
c470 ( 191 0 ) capacitor c=0.00885916f //x=8.695 //y=1.095
c471 ( 180 0 ) capacitor c=0.0710579f //x=3.82 //y=4.88
c472 ( 175 0 ) capacitor c=0.0278202f //x=3.82 //y=2.095
c473 ( 174 0 ) capacitor c=0.0479349f //x=3.82 //y=2.26
c474 ( 169 0 ) capacitor c=0.0612936f //x=21.115 //y=4.97
c475 ( 168 0 ) capacitor c=0.0376642f //x=21.405 //y=4.97
c476 ( 167 0 ) capacitor c=0.0346489f //x=21.07 //y=1.4
c477 ( 166 0 ) capacitor c=0.018692f //x=21.07 //y=1.055
c478 ( 160 0 ) capacitor c=0.0137077f //x=20.915 //y=1.555
c479 ( 158 0 ) capacitor c=0.0158585f //x=20.915 //y=0.9
c480 ( 157 0 ) capacitor c=0.10101f //x=20.54 //y=2.095
c481 ( 156 0 ) capacitor c=0.0229444f //x=20.54 //y=1.71
c482 ( 155 0 ) capacitor c=0.0234359f //x=20.54 //y=1.4
c483 ( 154 0 ) capacitor c=0.019815f //x=20.54 //y=1.055
c484 ( 153 0 ) capacitor c=0.0443175f //x=4.34 //y=1.44
c485 ( 152 0 ) capacitor c=0.0199703f //x=4.34 //y=1.095
c486 ( 149 0 ) capacitor c=0.0162526f //x=4.185 //y=1.595
c487 ( 147 0 ) capacitor c=0.0157807f //x=4.185 //y=0.94
c488 ( 142 0 ) capacitor c=0.0220935f //x=3.81 //y=1.75
c489 ( 141 0 ) capacitor c=0.0207489f //x=3.81 //y=1.44
c490 ( 140 0 ) capacitor c=0.0194091f //x=3.81 //y=1.095
c491 ( 136 0 ) capacitor c=0.110208f //x=21.48 //y=6.2
c492 ( 135 0 ) capacitor c=0.158957f //x=21.04 //y=6.2
c493 ( 134 0 ) capacitor c=0.159671f //x=4 //y=6.2
c494 ( 133 0 ) capacitor c=0.110208f //x=3.56 //y=6.2
c495 ( 127 0 ) capacitor c=0.0014751f //x=20.84 //y=4.88
c496 ( 118 0 ) capacitor c=0.0012618f //x=20.84 //y=2.26
c497 ( 101 0 ) capacitor c=0.0293723f //x=8.59 //y=5.56
c498 ( 93 0 ) capacitor c=0.029137f //x=7.71 //y=5.56
c499 ( 85 0 ) capacitor c=0.0278099f //x=6.83 //y=5.56
c500 ( 80 0 ) capacitor c=7.7417e-19 //x=3.82 //y=4.88
c501 ( 71 0 ) capacitor c=0.00101179f //x=3.82 //y=2.26
c502 ( 68 0 ) capacitor c=4.92288e-19 //x=20.835 //y=3.51
c503 ( 66 0 ) capacitor c=8.37596e-19 //x=9.53 //y=3.495
c504 ( 65 0 ) capacitor c=0.071237f //x=9.21 //y=3.495
c505 ( 62 0 ) capacitor c=9.84133e-19 //x=3.99 //y=3.515
c506 ( 57 0 ) capacitor c=0.121226f //x=20.675 //y=3.51
c507 ( 49 0 ) capacitor c=0.0169562f //x=20.835 //y=3.51
c508 ( 47 0 ) capacitor c=0.0158593f //x=9.37 //y=3.51
c509 ( 39 0 ) capacitor c=8.8245e-19 //x=8.59 //y=5.335
c510 ( 36 0 ) capacitor c=0.00740623f //x=7.71 //y=5.335
c511 ( 33 0 ) capacitor c=0.0113499f //x=6.832 //y=5.335
c512 ( 30 0 ) capacitor c=0.0150828f //x=3.82 //y=3.51
c513 ( 24 0 ) capacitor c=0.037614f //x=20.84 //y=4.755
c514 ( 23 0 ) capacitor c=0.0144231f //x=20.84 //y=3.67
c515 ( 22 0 ) capacitor c=0.0280962f //x=20.84 //y=3.35
c516 ( 21 0 ) capacitor c=0.00493552f //x=20.84 //y=2.375
c517 ( 20 0 ) capacitor c=0.0426794f //x=9.37 //y=5.25
c518 ( 19 0 ) capacitor c=0.0133594f //x=9.37 //y=3.655
c519 ( 18 0 ) capacitor c=0.0401079f //x=9.37 //y=3.335
c520 ( 16 0 ) capacitor c=0.0048771f //x=8.97 //y=1.845
c521 ( 15 0 ) capacitor c=0.0132685f //x=9.285 //y=1.845
c522 ( 14 0 ) capacitor c=0.0167992f //x=8.885 //y=1.76
c523 ( 13 0 ) capacitor c=0.0113147f //x=8.885 //y=1.305
c524 ( 11 0 ) capacitor c=0.0228465f //x=9.285 //y=5.335
c525 ( 10 0 ) capacitor c=0.00933983f //x=8.59 //y=5.56
c526 ( 7 0 ) capacitor c=0.019444f //x=8.475 //y=5.335
c527 ( 5 0 ) capacitor c=0.0149475f //x=7.59 //y=5.335
c528 ( 4 0 ) capacitor c=0.0329827f //x=3.82 //y=4.75
c529 ( 3 0 ) capacitor c=0.0122381f //x=3.82 //y=3.675
c530 ( 2 0 ) capacitor c=0.0243464f //x=3.82 //y=3.355
c531 ( 1 0 ) capacitor c=0.005545f //x=3.82 //y=2.375
r532 (  174 175 ) resistor r=52.7279 //w=0.214 //l=0.165 //layer=ply \
 //thickness=0.18 //x=3.82 //y=2.26 //x2=3.82 //y2=2.095
r533 (  168 170 ) resistor r=26.9307 //w=0.15 //l=0.106066 //layer=ply \
 //thickness=0.18 //x=21.405 //y=4.97 //x2=21.48 //y2=5.045
r534 (  168 169 ) resistor r=148.702 //w=0.094 //l=0.29 //layer=ply \
 //thickness=0.18 //x=21.405 //y=4.97 //x2=21.115 //y2=4.97
r535 (  167 190 ) resistor r=45.1352 //w=0.168 //l=0.173853 //layer=ply \
 //thickness=0.18 //x=21.07 //y=1.4 //x2=21.03 //y2=1.555
r536 (  166 189 ) resistor r=45.1352 //w=0.168 //l=0.173853 //layer=ply \
 //thickness=0.18 //x=21.07 //y=1.055 //x2=21.03 //y2=0.9
r537 (  166 167 ) resistor r=176.904 //w=0.094 //l=0.345 //layer=ply \
 //thickness=0.18 //x=21.07 //y=1.055 //x2=21.07 //y2=1.4
r538 (  163 169 ) resistor r=22.7971 //w=0.269 //l=0.106066 //layer=ply \
 //thickness=0.18 //x=21.04 //y=5.045 //x2=21.115 //y2=4.97
r539 (  163 188 ) resistor r=35.8364 //w=0.269 //l=0.270185 //layer=ply \
 //thickness=0.18 //x=21.04 //y=5.045 //x2=20.84 //y2=4.88
r540 (  161 184 ) resistor r=10.701 //w=0.21 //l=0.115 //layer=ply \
 //thickness=0.18 //x=20.695 //y=1.555 //x2=20.58 //y2=1.555
r541 (  160 190 ) resistor r=5.52526 //w=0.168 //l=0.115 //layer=ply \
 //thickness=0.18 //x=20.915 //y=1.555 //x2=21.03 //y2=1.555
r542 (  159 183 ) resistor r=5.52526 //w=0.168 //l=0.115 //layer=ply \
 //thickness=0.18 //x=20.695 //y=0.9 //x2=20.58 //y2=0.9
r543 (  158 189 ) resistor r=5.52526 //w=0.168 //l=0.115 //layer=ply \
 //thickness=0.18 //x=20.915 //y=0.9 //x2=21.03 //y2=0.9
r544 (  158 159 ) resistor r=112.809 //w=0.094 //l=0.22 //layer=ply \
 //thickness=0.18 //x=20.915 //y=0.9 //x2=20.695 //y2=0.9
r545 (  157 186 ) resistor r=58.7805 //w=0.246 //l=0.373497 //layer=ply \
 //thickness=0.18 //x=20.54 //y=2.095 //x2=20.84 //y2=2.26
r546 (  156 184 ) resistor r=39.5823 //w=0.21 //l=0.173853 //layer=ply \
 //thickness=0.18 //x=20.54 //y=1.71 //x2=20.58 //y2=1.555
r547 (  156 157 ) resistor r=197.415 //w=0.094 //l=0.385 //layer=ply \
 //thickness=0.18 //x=20.54 //y=1.71 //x2=20.54 //y2=2.095
r548 (  155 184 ) resistor r=39.5823 //w=0.21 //l=0.173853 //layer=ply \
 //thickness=0.18 //x=20.54 //y=1.4 //x2=20.58 //y2=1.555
r549 (  154 183 ) resistor r=45.1352 //w=0.168 //l=0.173853 //layer=ply \
 //thickness=0.18 //x=20.54 //y=1.055 //x2=20.58 //y2=0.9
r550 (  154 155 ) resistor r=176.904 //w=0.094 //l=0.345 //layer=ply \
 //thickness=0.18 //x=20.54 //y=1.055 //x2=20.54 //y2=1.4
r551 (  153 182 ) resistor r=45.1352 //w=0.168 //l=0.173853 //layer=ply \
 //thickness=0.18 //x=4.34 //y=1.44 //x2=4.3 //y2=1.595
r552 (  152 181 ) resistor r=45.1352 //w=0.168 //l=0.173853 //layer=ply \
 //thickness=0.18 //x=4.34 //y=1.095 //x2=4.3 //y2=0.94
r553 (  152 153 ) resistor r=176.904 //w=0.094 //l=0.345 //layer=ply \
 //thickness=0.18 //x=4.34 //y=1.095 //x2=4.34 //y2=1.44
r554 (  150 178 ) resistor r=10.701 //w=0.21 //l=0.115 //layer=ply \
 //thickness=0.18 //x=3.965 //y=1.595 //x2=3.85 //y2=1.595
r555 (  149 182 ) resistor r=5.52526 //w=0.168 //l=0.115 //layer=ply \
 //thickness=0.18 //x=4.185 //y=1.595 //x2=4.3 //y2=1.595
r556 (  148 177 ) resistor r=5.52526 //w=0.168 //l=0.115 //layer=ply \
 //thickness=0.18 //x=3.965 //y=0.94 //x2=3.85 //y2=0.94
r557 (  147 181 ) resistor r=5.52526 //w=0.168 //l=0.115 //layer=ply \
 //thickness=0.18 //x=4.185 //y=0.94 //x2=4.3 //y2=0.94
r558 (  147 148 ) resistor r=112.809 //w=0.094 //l=0.22 //layer=ply \
 //thickness=0.18 //x=4.185 //y=0.94 //x2=3.965 //y2=0.94
r559 (  144 180 ) resistor r=37.236 //w=0.233 //l=0.249199 //layer=ply \
 //thickness=0.18 //x=4 //y=5.045 //x2=3.82 //y2=4.88
r560 (  142 178 ) resistor r=39.5823 //w=0.21 //l=0.173853 //layer=ply \
 //thickness=0.18 //x=3.81 //y=1.75 //x2=3.85 //y2=1.595
r561 (  142 175 ) resistor r=176.904 //w=0.094 //l=0.345 //layer=ply \
 //thickness=0.18 //x=3.81 //y=1.75 //x2=3.81 //y2=2.095
r562 (  141 178 ) resistor r=39.5823 //w=0.21 //l=0.173853 //layer=ply \
 //thickness=0.18 //x=3.81 //y=1.44 //x2=3.85 //y2=1.595
r563 (  140 177 ) resistor r=45.1352 //w=0.168 //l=0.173853 //layer=ply \
 //thickness=0.18 //x=3.81 //y=1.095 //x2=3.85 //y2=0.94
r564 (  140 141 ) resistor r=176.904 //w=0.094 //l=0.345 //layer=ply \
 //thickness=0.18 //x=3.81 //y=1.095 //x2=3.81 //y2=1.44
r565 (  137 180 ) resistor r=53.7854 //w=0.233 //l=0.332415 //layer=ply \
 //thickness=0.18 //x=3.56 //y=5.045 //x2=3.82 //y2=4.88
r566 (  136 170 ) resistor r=592.245 //w=0.094 //l=1.155 //layer=ply \
 //thickness=0.18 //x=21.48 //y=6.2 //x2=21.48 //y2=5.045
r567 (  135 163 ) resistor r=592.245 //w=0.094 //l=1.155 //layer=ply \
 //thickness=0.18 //x=21.04 //y=6.2 //x2=21.04 //y2=5.045
r568 (  134 144 ) resistor r=592.245 //w=0.094 //l=1.155 //layer=ply \
 //thickness=0.18 //x=4 //y=6.2 //x2=4 //y2=5.045
r569 (  133 137 ) resistor r=592.245 //w=0.094 //l=1.155 //layer=ply \
 //thickness=0.18 //x=3.56 //y=6.2 //x2=3.56 //y2=5.045
r570 (  132 160 ) resistor r=56.4043 //w=0.094 //l=0.11 //layer=ply \
 //thickness=0.18 //x=20.805 //y=1.555 //x2=20.915 //y2=1.555
r571 (  132 161 ) resistor r=56.4043 //w=0.094 //l=0.11 //layer=ply \
 //thickness=0.18 //x=20.805 //y=1.555 //x2=20.695 //y2=1.555
r572 (  131 149 ) resistor r=56.4043 //w=0.094 //l=0.11 //layer=ply \
 //thickness=0.18 //x=4.075 //y=1.595 //x2=4.185 //y2=1.595
r573 (  131 150 ) resistor r=56.4043 //w=0.094 //l=0.11 //layer=ply \
 //thickness=0.18 //x=4.075 //y=1.595 //x2=3.965 //y2=1.595
r574 (  127 188 ) resistor r=152 //w=0.17 //l=0.17 //layer=licon //count=1 \
 //x=20.84 //y=4.88 //x2=20.84 //y2=4.88
r575 (  118 186 ) resistor r=152 //w=0.17 //l=0.17 //layer=licon //count=1 \
 //x=20.84 //y=2.26 //x2=20.84 //y2=2.26
r576 (  101 195 ) resistor r=23.615 //w=0.187 //l=0.345 //layer=li \
 //thickness=0.1 //x=8.59 //y=5.56 //x2=8.59 //y2=5.905
r577 (  93 194 ) resistor r=23.615 //w=0.187 //l=0.345 //layer=li \
 //thickness=0.1 //x=7.71 //y=5.56 //x2=7.71 //y2=5.905
r578 (  85 193 ) resistor r=23.615 //w=0.187 //l=0.345 //layer=li \
 //thickness=0.1 //x=6.83 //y=5.56 //x2=6.83 //y2=5.905
r579 (  80 180 ) resistor r=152 //w=0.17 //l=0.17 //layer=licon //count=1 \
 //x=3.82 //y=4.88 //x2=3.82 //y2=4.88
r580 (  71 174 ) resistor r=152 //w=0.17 //l=0.17 //layer=licon //count=1 \
 //x=3.82 //y=2.26 //x2=3.82 //y2=2.26
r581 (  64 66 ) resistor r=0.10734 //w=0.281 //l=0.16 //layer=m2 \
 //thickness=0.36 //x=9.37 //y=3.495 //x2=9.53 //y2=3.495
r582 (  64 65 ) resistor r=0.10734 //w=0.281 //l=0.16 //layer=m2 \
 //thickness=0.36 //x=9.37 //y=3.495 //x2=9.21 //y2=3.495
r583 (  62 65 ) resistor r=4.98092 //w=0.131 //l=5.22 //layer=m2 \
 //thickness=0.36 //x=3.99 //y=3.51 //x2=9.21 //y2=3.51
r584 (  60 62 ) resistor r=0.10734 //w=0.281 //l=0.16 //layer=m2 \
 //thickness=0.36 //x=3.83 //y=3.515 //x2=3.99 //y2=3.515
r585 (  57 68 ) resistor r=0.10734 //w=0.281 //l=0.16 //layer=m2 \
 //thickness=0.36 //x=20.675 //y=3.51 //x2=20.835 //y2=3.51
r586 (  57 66 ) resistor r=10.6345 //w=0.131 //l=11.145 //layer=m2 \
 //thickness=0.36 //x=20.675 //y=3.51 //x2=9.53 //y2=3.51
r587 (  54 127 ) resistor r=9.3 //w=0.17 //l=0.17 //layer=mcon //count=1 \
 //x=20.84 //y=4.88 //x2=20.84 //y2=4.88
r588 (  52 118 ) resistor r=9.3 //w=0.17 //l=0.17 //layer=mcon //count=1 \
 //x=20.84 //y=2.26 //x2=20.84 //y2=2.26
r589 (  49 68 ) resistor r=4.5 //w=0.15 //l=0.15 //layer=via1 //count=1 \
 //x=20.835 //y=3.51 //x2=20.835 //y2=3.51
r590 (  45 64 ) resistor r=4.5 //w=0.15 //l=0.15 //layer=via1 //count=1 \
 //x=9.37 //y=3.495 //x2=9.37 //y2=3.495
r591 (  45 47 ) resistor r=0.0049867 //w=0.376 //l=0.015 //layer=m1 \
 //thickness=0.36 //x=9.422 //y=3.495 //x2=9.422 //y2=3.51
r592 (  43 191 ) resistor r=9.3 //w=0.17 //l=0.17 //layer=mcon //count=1 \
 //x=8.885 //y=1.19 //x2=8.885 //y2=1.19
r593 (  41 101 ) resistor r=9.3 //w=0.17 //l=0.17 //layer=mcon //count=1 \
 //x=8.59 //y=5.56 //x2=8.59 //y2=5.56
r594 (  38 93 ) resistor r=9.3 //w=0.17 //l=0.17 //layer=mcon //count=1 \
 //x=7.71 //y=5.56 //x2=7.71 //y2=5.56
r595 (  36 38 ) resistor r=0.121228 //w=0.232 //l=0.225 //layer=m1 \
 //thickness=0.36 //x=7.71 //y=5.335 //x2=7.71 //y2=5.56
r596 (  35 85 ) resistor r=9.3 //w=0.17 //l=0.17 //layer=mcon //count=1 \
 //x=6.83 //y=5.56 //x2=6.83 //y2=5.56
r597 (  33 35 ) resistor r=0.129608 //w=0.217 //l=0.225 //layer=m1 \
 //thickness=0.36 //x=6.832 //y=5.335 //x2=6.832 //y2=5.56
r598 (  32 60 ) resistor r=4.5 //w=0.15 //l=0.15 //layer=via1 //count=1 \
 //x=3.83 //y=3.515 //x2=3.83 //y2=3.515
r599 (  30 32 ) resistor r=0.00168464 //w=0.371 //l=0.005 //layer=m1 \
 //thickness=0.36 //x=3.877 //y=3.51 //x2=3.877 //y2=3.515
r600 (  28 80 ) resistor r=9.3 //w=0.17 //l=0.17 //layer=mcon //count=1 \
 //x=3.82 //y=4.88 //x2=3.82 //y2=4.88
r601 (  26 71 ) resistor r=9.3 //w=0.17 //l=0.17 //layer=mcon //count=1 \
 //x=3.82 //y=2.26 //x2=3.82 //y2=2.26
r602 (  24 54 ) resistor r=0.0760407 //w=0.238 //l=0.125 //layer=m1 \
 //thickness=0.36 //x=20.84 //y=4.755 //x2=20.84 //y2=4.88
r603 (  23 49 ) resistor r=0.0910802 //w=0.374 //l=0.185472 //layer=m1 \
 //thickness=0.36 //x=20.84 //y=3.67 //x2=20.785 //y2=3.51
r604 (  23 24 ) resistor r=1.03531 //w=0.131 //l=1.085 //layer=m1 \
 //thickness=0.36 //x=20.84 //y=3.67 //x2=20.84 //y2=4.755
r605 (  22 49 ) resistor r=0.0910802 //w=0.374 //l=0.185472 //layer=m1 \
 //thickness=0.36 //x=20.84 //y=3.35 //x2=20.785 //y2=3.51
r606 (  21 52 ) resistor r=0.0719237 //w=0.222 //l=0.115 //layer=m1 \
 //thickness=0.36 //x=20.84 //y=2.375 //x2=20.84 //y2=2.26
r607 (  21 22 ) resistor r=0.930344 //w=0.131 //l=0.975 //layer=m1 \
 //thickness=0.36 //x=20.84 //y=2.375 //x2=20.84 //y2=3.35
r608 (  19 47 ) resistor r=0.0861726 //w=0.376 //l=0.169012 //layer=m1 \
 //thickness=0.36 //x=9.37 //y=3.655 //x2=9.422 //y2=3.51
r609 (  19 20 ) resistor r=1.52195 //w=0.131 //l=1.595 //layer=m1 \
 //thickness=0.36 //x=9.37 //y=3.655 //x2=9.37 //y2=5.25
r610 (  18 45 ) resistor r=0.0911593 //w=0.376 //l=0.184174 //layer=m1 \
 //thickness=0.36 //x=9.37 //y=3.335 //x2=9.422 //y2=3.495
r611 (  17 18 ) resistor r=1.34065 //w=0.131 //l=1.405 //layer=m1 \
 //thickness=0.36 //x=9.37 //y=1.93 //x2=9.37 //y2=3.335
r612 (  15 17 ) resistor r=0.0698411 //w=0.17 //l=0.120208 //layer=m1 \
 //thickness=0.36 //x=9.285 //y=1.845 //x2=9.37 //y2=1.93
r613 (  15 16 ) resistor r=0.300573 //w=0.131 //l=0.315 //layer=m1 \
 //thickness=0.36 //x=9.285 //y=1.845 //x2=8.97 //y2=1.845
r614 (  14 16 ) resistor r=0.0698411 //w=0.17 //l=0.120208 //layer=m1 \
 //thickness=0.36 //x=8.885 //y=1.76 //x2=8.97 //y2=1.845
r615 (  13 43 ) resistor r=0.0717383 //w=0.224 //l=0.115 //layer=m1 \
 //thickness=0.36 //x=8.885 //y=1.305 //x2=8.885 //y2=1.19
r616 (  13 14 ) resistor r=0.43416 //w=0.131 //l=0.455 //layer=m1 \
 //thickness=0.36 //x=8.885 //y=1.305 //x2=8.885 //y2=1.76
r617 (  12 39 ) resistor r=0.0675342 //w=0.23 //l=0.115 //layer=m1 \
 //thickness=0.36 //x=8.705 //y=5.335 //x2=8.59 //y2=5.335
r618 (  11 20 ) resistor r=0.0698411 //w=0.17 //l=0.120208 //layer=m1 \
 //thickness=0.36 //x=9.285 //y=5.335 //x2=9.37 //y2=5.25
r619 (  11 12 ) resistor r=0.553435 //w=0.131 //l=0.58 //layer=m1 \
 //thickness=0.36 //x=9.285 //y=5.335 //x2=8.705 //y2=5.335
r620 (  10 41 ) resistor r=0.00118313 //w=0.23 //layer=m1 //thickness=0.36 \
 //x=8.59 //y=5.56 //x2=8.59 //y2=5.56
r621 (  9 39 ) resistor r=0.002872 //w=0.34 //l=0.085 //layer=m1 \
 //thickness=0.36 //x=8.59 //y=5.42 //x2=8.59 //y2=5.335
r622 (  9 10 ) resistor r=0.091623 //w=0.191 //l=0.14 //layer=m1 \
 //thickness=0.36 //x=8.59 //y=5.42 //x2=8.59 //y2=5.56
r623 (  8 36 ) resistor r=0.0262263 //w=0.232 //l=0.12 //layer=m1 \
 //thickness=0.36 //x=7.83 //y=5.335 //x2=7.71 //y2=5.335
r624 (  7 39 ) resistor r=0.0675342 //w=0.23 //l=0.115 //layer=m1 \
 //thickness=0.36 //x=8.475 //y=5.335 //x2=8.59 //y2=5.335
r625 (  7 8 ) resistor r=0.615458 //w=0.131 //l=0.645 //layer=m1 \
 //thickness=0.36 //x=8.475 //y=5.335 //x2=7.83 //y2=5.335
r626 (  6 33 ) resistor r=0.0222262 //w=0.217 //l=0.118 //layer=m1 \
 //thickness=0.36 //x=6.95 //y=5.335 //x2=6.832 //y2=5.335
r627 (  5 36 ) resistor r=0.0262263 //w=0.232 //l=0.12 //layer=m1 \
 //thickness=0.36 //x=7.59 //y=5.335 //x2=7.71 //y2=5.335
r628 (  5 6 ) resistor r=0.610687 //w=0.131 //l=0.64 //layer=m1 \
 //thickness=0.36 //x=7.59 //y=5.335 //x2=6.95 //y2=5.335
r629 (  4 28 ) resistor r=0.0801089 //w=0.224 //l=0.13 //layer=m1 \
 //thickness=0.36 //x=3.82 //y=4.75 //x2=3.82 //y2=4.88
r630 (  3 32 ) resistor r=0.0909648 //w=0.371 //l=0.186333 //layer=m1 \
 //thickness=0.36 //x=3.82 //y=3.675 //x2=3.877 //y2=3.515
r631 (  3 4 ) resistor r=1.02576 //w=0.131 //l=1.075 //layer=m1 \
 //thickness=0.36 //x=3.82 //y=3.675 //x2=3.82 //y2=4.75
r632 (  2 30 ) resistor r=0.0892801 //w=0.371 //l=0.181273 //layer=m1 \
 //thickness=0.36 //x=3.82 //y=3.355 //x2=3.877 //y2=3.51
r633 (  1 26 ) resistor r=0.0719237 //w=0.222 //l=0.115 //layer=m1 \
 //thickness=0.36 //x=3.82 //y=2.375 //x2=3.82 //y2=2.26
r634 (  1 2 ) resistor r=0.935115 //w=0.131 //l=0.98 //layer=m1 \
 //thickness=0.36 //x=3.82 //y=2.375 //x2=3.82 //y2=3.355
ends PM_TMRDFFSNRNQNX1\%noxref_3

subckt PM_TMRDFFSNRNQNX1\%noxref_4 ( 1 3 6 7 9 10 11 12 14 15 16 17 18 19 20 \
 21 22 23 24 25 28 31 37 39 44 52 56 59 67 68 69 70 72 74 76 79 81 82 83 85 89 \
 91 94 95 100 105 106 109 117 125 146 155 160 165 171 176 181 182 183 184 185 \
 186 187 188 189 190 191 192 193 194 196 202 203 204 205 209 210 211 212 216 \
 218 221 222 223 224 228 229 230 231 235 237 243 244 254 267 270 272 273 274 )
c865 ( 270 0 ) capacitor c=0.00885916f //x=23.125 //y=1.095
c866 ( 267 0 ) capacitor c=0.0692896f //x=91.51 //y=4.885
c867 ( 254 0 ) capacitor c=0.0603371f //x=87.81 //y=2.26
c868 ( 244 0 ) capacitor c=0.0344584f //x=91.845 //y=1.39
c869 ( 243 0 ) capacitor c=0.0186809f //x=91.845 //y=1.045
c870 ( 237 0 ) capacitor c=0.0141797f //x=91.69 //y=1.545
c871 ( 235 0 ) capacitor c=0.0158553f //x=91.69 //y=0.89
c872 ( 231 0 ) capacitor c=0.104052f //x=91.315 //y=2.095
c873 ( 230 0 ) capacitor c=0.0227978f //x=91.315 //y=1.7
c874 ( 229 0 ) capacitor c=0.0234352f //x=91.315 //y=1.39
c875 ( 228 0 ) capacitor c=0.0198759f //x=91.315 //y=1.045
c876 ( 224 0 ) capacitor c=0.0318956f //x=88.515 //y=1.39
c877 ( 223 0 ) capacitor c=0.0186809f //x=88.515 //y=1.045
c878 ( 222 0 ) capacitor c=0.0624333f //x=88.155 //y=4.975
c879 ( 221 0 ) capacitor c=0.0375163f //x=88.445 //y=4.975
c880 ( 218 0 ) capacitor c=0.0157936f //x=88.36 //y=1.545
c881 ( 216 0 ) capacitor c=0.0158553f //x=88.36 //y=0.89
c882 ( 212 0 ) capacitor c=0.0302441f //x=87.985 //y=2.095
c883 ( 211 0 ) capacitor c=0.0238107f //x=87.985 //y=1.7
c884 ( 210 0 ) capacitor c=0.0234359f //x=87.985 //y=1.39
c885 ( 209 0 ) capacitor c=0.0199332f //x=87.985 //y=1.045
c886 ( 205 0 ) capacitor c=0.0612936f //x=25.925 //y=4.97
c887 ( 204 0 ) capacitor c=0.0376642f //x=26.215 //y=4.97
c888 ( 203 0 ) capacitor c=0.0346489f //x=25.88 //y=1.4
c889 ( 202 0 ) capacitor c=0.018692f //x=25.88 //y=1.055
c890 ( 196 0 ) capacitor c=0.0137077f //x=25.725 //y=1.555
c891 ( 194 0 ) capacitor c=0.0158585f //x=25.725 //y=0.9
c892 ( 193 0 ) capacitor c=0.097937f //x=25.35 //y=2.095
c893 ( 192 0 ) capacitor c=0.0229364f //x=25.35 //y=1.71
c894 ( 191 0 ) capacitor c=0.0234359f //x=25.35 //y=1.4
c895 ( 190 0 ) capacitor c=0.019815f //x=25.35 //y=1.055
c896 ( 189 0 ) capacitor c=0.110525f //x=91.84 //y=6.205
c897 ( 188 0 ) capacitor c=0.154978f //x=91.4 //y=6.205
c898 ( 187 0 ) capacitor c=0.110282f //x=88.52 //y=6.205
c899 ( 186 0 ) capacitor c=0.155219f //x=88.08 //y=6.205
c900 ( 185 0 ) capacitor c=0.110208f //x=26.29 //y=6.2
c901 ( 184 0 ) capacitor c=0.158957f //x=25.85 //y=6.2
c902 ( 176 0 ) capacitor c=0.0156222f //x=91.51 //y=4.62
c903 ( 171 0 ) capacitor c=0.00126053f //x=91.51 //y=2.26
c904 ( 165 0 ) capacitor c=0.0130807f //x=87.81 //y=4.62
c905 ( 160 0 ) capacitor c=8.37642e-19 //x=87.81 //y=2.26
c906 ( 155 0 ) capacitor c=0.0014751f //x=25.65 //y=4.88
c907 ( 146 0 ) capacitor c=9.93222e-19 //x=25.65 //y=2.26
c908 ( 125 0 ) capacitor c=0.0293555f //x=23.02 //y=5.56
c909 ( 117 0 ) capacitor c=0.029137f //x=22.14 //y=5.56
c910 ( 109 0 ) capacitor c=0.0278099f //x=21.26 //y=5.56
c911 ( 106 0 ) capacitor c=0.0683501f //x=91.355 //y=4.64
c912 ( 105 0 ) capacitor c=0.00642399f //x=91.515 //y=4.64
c913 ( 100 0 ) capacitor c=0.0128559f //x=75.6 //y=4.99
c914 ( 95 0 ) capacitor c=0.0150338f //x=25.445 //y=2.755
c915 ( 94 0 ) capacitor c=0.00484623f //x=25.605 //y=2.755
c916 ( 91 0 ) capacitor c=0.278305f //x=23.785 //y=5.095
c917 ( 89 0 ) capacitor c=0.00514732f //x=24.005 //y=2.755
c918 ( 85 0 ) capacitor c=0.00568391f //x=87.975 //y=4.62
c919 ( 83 0 ) capacitor c=0.002039f //x=75.685 //y=4.62
c920 ( 82 0 ) capacitor c=0.295984f //x=87.655 //y=4.62
c921 ( 81 0 ) capacitor c=0.00346713f //x=75.6 //y=4.905
c922 ( 79 0 ) capacitor c=0.00628346f //x=75.3 //y=5.215
c923 ( 76 0 ) capacitor c=0.276121f //x=65.64 //y=5.305
c924 ( 74 0 ) capacitor c=0.480668f //x=64.685 //y=5.31
c925 ( 72 0 ) capacitor c=0.0272169f //x=46.39 //y=5.305
c926 ( 70 0 ) capacitor c=0.185994f //x=45.445 //y=5.33
c927 ( 69 0 ) capacitor c=0.00676873f //x=35.975 //y=5.35
c928 ( 68 0 ) capacitor c=0.0243312f //x=36.835 //y=5.35
c929 ( 67 0 ) capacitor c=0.00853509f //x=35.89 //y=5.265
c930 ( 59 0 ) capacitor c=0.0127992f //x=91.51 //y=4.62
c931 ( 56 0 ) capacitor c=0.0137635f //x=87.81 //y=4.62
c932 ( 52 0 ) capacitor c=0.0148553f //x=25.65 //y=2.77
c933 ( 44 0 ) capacitor c=0.0144001f //x=23.8 //y=2.77
c934 ( 39 0 ) capacitor c=0.024777f //x=23.785 //y=5.095
c935 ( 37 0 ) capacitor c=0.014148f //x=23.8 //y=4.99
c936 ( 31 0 ) capacitor c=9.58516e-19 //x=23.02 //y=5.335
c937 ( 28 0 ) capacitor c=0.00778188f //x=22.14 //y=5.335
c938 ( 25 0 ) capacitor c=0.0111234f //x=21.262 //y=5.335
c939 ( 24 0 ) capacitor c=0.0838237f //x=91.51 //y=4.475
c940 ( 23 0 ) capacitor c=0.00607262f //x=91.51 //y=2.385
c941 ( 22 0 ) capacitor c=0.0626977f //x=87.81 //y=4.46
c942 ( 21 0 ) capacitor c=0.00377765f //x=87.81 //y=2.375
c943 ( 20 0 ) capacitor c=0.0579716f //x=25.65 //y=4.755
c944 ( 19 0 ) capacitor c=0.0139549f //x=25.65 //y=2.915
c945 ( 18 0 ) capacitor c=0.00427649f //x=25.65 //y=2.595
c946 ( 17 0 ) capacitor c=0.00437465f //x=25.65 //y=2.375
c947 ( 16 0 ) capacitor c=0.0515446f //x=23.8 //y=4.875
c948 ( 15 0 ) capacitor c=0.0140858f //x=23.8 //y=2.915
c949 ( 14 0 ) capacitor c=0.017505f //x=23.8 //y=2.595
c950 ( 12 0 ) capacitor c=0.0047266f //x=23.4 //y=1.845
c951 ( 11 0 ) capacitor c=0.0129783f //x=23.715 //y=1.845
c952 ( 10 0 ) capacitor c=0.0167992f //x=23.315 //y=1.76
c953 ( 9 0 ) capacitor c=0.0110975f //x=23.315 //y=1.305
c954 ( 7 0 ) capacitor c=0.0130988f //x=23.625 //y=5.335
c955 ( 6 0 ) capacitor c=0.00933983f //x=23.02 //y=5.56
c956 ( 3 0 ) capacitor c=0.019444f //x=22.905 //y=5.335
c957 ( 1 0 ) capacitor c=0.0151997f //x=22.02 //y=5.335
r958 (  265 267 ) resistor r=22.7554 //w=0.233 //l=0.11 //layer=ply \
 //thickness=0.18 //x=91.4 //y=4.885 //x2=91.51 //y2=4.885
r959 (  244 269 ) resistor r=45.1352 //w=0.168 //l=0.173853 //layer=ply \
 //thickness=0.18 //x=91.845 //y=1.39 //x2=91.805 //y2=1.545
r960 (  243 268 ) resistor r=45.1352 //w=0.168 //l=0.173853 //layer=ply \
 //thickness=0.18 //x=91.845 //y=1.045 //x2=91.805 //y2=0.89
r961 (  243 244 ) resistor r=176.904 //w=0.094 //l=0.345 //layer=ply \
 //thickness=0.18 //x=91.845 //y=1.045 //x2=91.845 //y2=1.39
r962 (  240 267 ) resistor r=68.2661 //w=0.233 //l=0.404166 //layer=ply \
 //thickness=0.18 //x=91.84 //y=5.05 //x2=91.51 //y2=4.885
r963 (  238 264 ) resistor r=10.701 //w=0.21 //l=0.115 //layer=ply \
 //thickness=0.18 //x=91.47 //y=1.545 //x2=91.355 //y2=1.545
r964 (  237 269 ) resistor r=5.52526 //w=0.168 //l=0.115 //layer=ply \
 //thickness=0.18 //x=91.69 //y=1.545 //x2=91.805 //y2=1.545
r965 (  236 263 ) resistor r=5.52526 //w=0.168 //l=0.115 //layer=ply \
 //thickness=0.18 //x=91.47 //y=0.89 //x2=91.355 //y2=0.89
r966 (  235 268 ) resistor r=5.52526 //w=0.168 //l=0.115 //layer=ply \
 //thickness=0.18 //x=91.69 //y=0.89 //x2=91.805 //y2=0.89
r967 (  235 236 ) resistor r=112.809 //w=0.094 //l=0.22 //layer=ply \
 //thickness=0.18 //x=91.69 //y=0.89 //x2=91.47 //y2=0.89
r968 (  232 265 ) resistor r=13.0941 //w=0.233 //l=0.165 //layer=ply \
 //thickness=0.18 //x=91.4 //y=5.05 //x2=91.4 //y2=4.885
r969 (  231 262 ) resistor r=34.8111 //w=0.27 //l=0.264953 //layer=ply \
 //thickness=0.18 //x=91.315 //y=2.095 //x2=91.51 //y2=2.26
r970 (  230 264 ) resistor r=39.5823 //w=0.21 //l=0.173853 //layer=ply \
 //thickness=0.18 //x=91.315 //y=1.7 //x2=91.355 //y2=1.545
r971 (  230 231 ) resistor r=202.543 //w=0.094 //l=0.395 //layer=ply \
 //thickness=0.18 //x=91.315 //y=1.7 //x2=91.315 //y2=2.095
r972 (  229 264 ) resistor r=39.5823 //w=0.21 //l=0.173853 //layer=ply \
 //thickness=0.18 //x=91.315 //y=1.39 //x2=91.355 //y2=1.545
r973 (  228 263 ) resistor r=45.1352 //w=0.168 //l=0.173853 //layer=ply \
 //thickness=0.18 //x=91.315 //y=1.045 //x2=91.355 //y2=0.89
r974 (  228 229 ) resistor r=176.904 //w=0.094 //l=0.345 //layer=ply \
 //thickness=0.18 //x=91.315 //y=1.045 //x2=91.315 //y2=1.39
r975 (  224 260 ) resistor r=45.1352 //w=0.168 //l=0.173853 //layer=ply \
 //thickness=0.18 //x=88.515 //y=1.39 //x2=88.475 //y2=1.545
r976 (  223 259 ) resistor r=45.1352 //w=0.168 //l=0.173853 //layer=ply \
 //thickness=0.18 //x=88.515 //y=1.045 //x2=88.475 //y2=0.89
r977 (  223 224 ) resistor r=176.904 //w=0.094 //l=0.345 //layer=ply \
 //thickness=0.18 //x=88.515 //y=1.045 //x2=88.515 //y2=1.39
r978 (  221 225 ) resistor r=26.9307 //w=0.15 //l=0.106066 //layer=ply \
 //thickness=0.18 //x=88.445 //y=4.975 //x2=88.52 //y2=5.05
r979 (  221 222 ) resistor r=148.702 //w=0.094 //l=0.29 //layer=ply \
 //thickness=0.18 //x=88.445 //y=4.975 //x2=88.155 //y2=4.975
r980 (  219 258 ) resistor r=10.701 //w=0.21 //l=0.115 //layer=ply \
 //thickness=0.18 //x=88.14 //y=1.545 //x2=88.025 //y2=1.545
r981 (  218 260 ) resistor r=5.52526 //w=0.168 //l=0.115 //layer=ply \
 //thickness=0.18 //x=88.36 //y=1.545 //x2=88.475 //y2=1.545
r982 (  217 257 ) resistor r=5.52526 //w=0.168 //l=0.115 //layer=ply \
 //thickness=0.18 //x=88.14 //y=0.89 //x2=88.025 //y2=0.89
r983 (  216 259 ) resistor r=5.52526 //w=0.168 //l=0.115 //layer=ply \
 //thickness=0.18 //x=88.36 //y=0.89 //x2=88.475 //y2=0.89
r984 (  216 217 ) resistor r=112.809 //w=0.094 //l=0.22 //layer=ply \
 //thickness=0.18 //x=88.36 //y=0.89 //x2=88.14 //y2=0.89
r985 (  213 222 ) resistor r=22.1787 //w=0.252 //l=0.106066 //layer=ply \
 //thickness=0.18 //x=88.08 //y=5.05 //x2=88.155 //y2=4.975
r986 (  213 256 ) resistor r=51.6429 //w=0.252 //l=0.34271 //layer=ply \
 //thickness=0.18 //x=88.08 //y=5.05 //x2=87.81 //y2=4.885
r987 (  212 254 ) resistor r=30.4513 //w=0.277 //l=0.243926 //layer=ply \
 //thickness=0.18 //x=87.985 //y=2.095 //x2=87.81 //y2=2.26
r988 (  211 258 ) resistor r=39.5823 //w=0.21 //l=0.173853 //layer=ply \
 //thickness=0.18 //x=87.985 //y=1.7 //x2=88.025 //y2=1.545
r989 (  211 212 ) resistor r=202.543 //w=0.094 //l=0.395 //layer=ply \
 //thickness=0.18 //x=87.985 //y=1.7 //x2=87.985 //y2=2.095
r990 (  210 258 ) resistor r=39.5823 //w=0.21 //l=0.173853 //layer=ply \
 //thickness=0.18 //x=87.985 //y=1.39 //x2=88.025 //y2=1.545
r991 (  209 257 ) resistor r=45.1352 //w=0.168 //l=0.173853 //layer=ply \
 //thickness=0.18 //x=87.985 //y=1.045 //x2=88.025 //y2=0.89
r992 (  209 210 ) resistor r=176.904 //w=0.094 //l=0.345 //layer=ply \
 //thickness=0.18 //x=87.985 //y=1.045 //x2=87.985 //y2=1.39
r993 (  204 206 ) resistor r=26.9307 //w=0.15 //l=0.106066 //layer=ply \
 //thickness=0.18 //x=26.215 //y=4.97 //x2=26.29 //y2=5.045
r994 (  204 205 ) resistor r=148.702 //w=0.094 //l=0.29 //layer=ply \
 //thickness=0.18 //x=26.215 //y=4.97 //x2=25.925 //y2=4.97
r995 (  203 252 ) resistor r=45.1352 //w=0.168 //l=0.173853 //layer=ply \
 //thickness=0.18 //x=25.88 //y=1.4 //x2=25.84 //y2=1.555
r996 (  202 251 ) resistor r=45.1352 //w=0.168 //l=0.173853 //layer=ply \
 //thickness=0.18 //x=25.88 //y=1.055 //x2=25.84 //y2=0.9
r997 (  202 203 ) resistor r=176.904 //w=0.094 //l=0.345 //layer=ply \
 //thickness=0.18 //x=25.88 //y=1.055 //x2=25.88 //y2=1.4
r998 (  199 205 ) resistor r=22.7971 //w=0.269 //l=0.106066 //layer=ply \
 //thickness=0.18 //x=25.85 //y=5.045 //x2=25.925 //y2=4.97
r999 (  199 250 ) resistor r=35.8364 //w=0.269 //l=0.270185 //layer=ply \
 //thickness=0.18 //x=25.85 //y=5.045 //x2=25.65 //y2=4.88
r1000 (  197 246 ) resistor r=10.701 //w=0.21 //l=0.115 //layer=ply \
 //thickness=0.18 //x=25.505 //y=1.555 //x2=25.39 //y2=1.555
r1001 (  196 252 ) resistor r=5.52526 //w=0.168 //l=0.115 //layer=ply \
 //thickness=0.18 //x=25.725 //y=1.555 //x2=25.84 //y2=1.555
r1002 (  195 245 ) resistor r=5.52526 //w=0.168 //l=0.115 //layer=ply \
 //thickness=0.18 //x=25.505 //y=0.9 //x2=25.39 //y2=0.9
r1003 (  194 251 ) resistor r=5.52526 //w=0.168 //l=0.115 //layer=ply \
 //thickness=0.18 //x=25.725 //y=0.9 //x2=25.84 //y2=0.9
r1004 (  194 195 ) resistor r=112.809 //w=0.094 //l=0.22 //layer=ply \
 //thickness=0.18 //x=25.725 //y=0.9 //x2=25.505 //y2=0.9
r1005 (  193 248 ) resistor r=58.7805 //w=0.246 //l=0.373497 //layer=ply \
 //thickness=0.18 //x=25.35 //y=2.095 //x2=25.65 //y2=2.26
r1006 (  192 246 ) resistor r=39.5823 //w=0.21 //l=0.173853 //layer=ply \
 //thickness=0.18 //x=25.35 //y=1.71 //x2=25.39 //y2=1.555
r1007 (  192 193 ) resistor r=197.415 //w=0.094 //l=0.385 //layer=ply \
 //thickness=0.18 //x=25.35 //y=1.71 //x2=25.35 //y2=2.095
r1008 (  191 246 ) resistor r=39.5823 //w=0.21 //l=0.173853 //layer=ply \
 //thickness=0.18 //x=25.35 //y=1.4 //x2=25.39 //y2=1.555
r1009 (  190 245 ) resistor r=45.1352 //w=0.168 //l=0.173853 //layer=ply \
 //thickness=0.18 //x=25.35 //y=1.055 //x2=25.39 //y2=0.9
r1010 (  190 191 ) resistor r=176.904 //w=0.094 //l=0.345 //layer=ply \
 //thickness=0.18 //x=25.35 //y=1.055 //x2=25.35 //y2=1.4
r1011 (  189 240 ) resistor r=592.245 //w=0.094 //l=1.155 //layer=ply \
 //thickness=0.18 //x=91.84 //y=6.205 //x2=91.84 //y2=5.05
r1012 (  188 232 ) resistor r=592.245 //w=0.094 //l=1.155 //layer=ply \
 //thickness=0.18 //x=91.4 //y=6.205 //x2=91.4 //y2=5.05
r1013 (  187 225 ) resistor r=592.245 //w=0.094 //l=1.155 //layer=ply \
 //thickness=0.18 //x=88.52 //y=6.205 //x2=88.52 //y2=5.05
r1014 (  186 213 ) resistor r=592.245 //w=0.094 //l=1.155 //layer=ply \
 //thickness=0.18 //x=88.08 //y=6.205 //x2=88.08 //y2=5.05
r1015 (  185 206 ) resistor r=592.245 //w=0.094 //l=1.155 //layer=ply \
 //thickness=0.18 //x=26.29 //y=6.2 //x2=26.29 //y2=5.045
r1016 (  184 199 ) resistor r=592.245 //w=0.094 //l=1.155 //layer=ply \
 //thickness=0.18 //x=25.85 //y=6.2 //x2=25.85 //y2=5.045
r1017 (  183 237 ) resistor r=56.4043 //w=0.094 //l=0.11 //layer=ply \
 //thickness=0.18 //x=91.58 //y=1.545 //x2=91.69 //y2=1.545
r1018 (  183 238 ) resistor r=56.4043 //w=0.094 //l=0.11 //layer=ply \
 //thickness=0.18 //x=91.58 //y=1.545 //x2=91.47 //y2=1.545
r1019 (  182 218 ) resistor r=56.4043 //w=0.094 //l=0.11 //layer=ply \
 //thickness=0.18 //x=88.25 //y=1.545 //x2=88.36 //y2=1.545
r1020 (  182 219 ) resistor r=56.4043 //w=0.094 //l=0.11 //layer=ply \
 //thickness=0.18 //x=88.25 //y=1.545 //x2=88.14 //y2=1.545
r1021 (  181 196 ) resistor r=56.4043 //w=0.094 //l=0.11 //layer=ply \
 //thickness=0.18 //x=25.615 //y=1.555 //x2=25.725 //y2=1.555
r1022 (  181 197 ) resistor r=56.4043 //w=0.094 //l=0.11 //layer=ply \
 //thickness=0.18 //x=25.615 //y=1.555 //x2=25.505 //y2=1.555
r1023 (  179 267 ) resistor r=152 //w=0.17 //l=0.17 //layer=licon //count=1 \
 //x=91.51 //y=4.885 //x2=91.51 //y2=4.885
r1024 (  176 179 ) resistor r=18.139 //w=0.187 //l=0.265 //layer=li \
 //thickness=0.1 //x=91.51 //y=4.62 //x2=91.51 //y2=4.885
r1025 (  171 262 ) resistor r=152 //w=0.17 //l=0.17 //layer=licon //count=1 \
 //x=91.51 //y=2.26 //x2=91.51 //y2=2.26
r1026 (  168 256 ) resistor r=152 //w=0.17 //l=0.17 //layer=licon //count=1 \
 //x=87.81 //y=4.885 //x2=87.81 //y2=4.885
r1027 (  165 168 ) resistor r=18.139 //w=0.187 //l=0.265 //layer=li \
 //thickness=0.1 //x=87.81 //y=4.62 //x2=87.81 //y2=4.885
r1028 (  160 254 ) resistor r=152 //w=0.17 //l=0.17 //layer=licon //count=1 \
 //x=87.81 //y=2.26 //x2=87.81 //y2=2.26
r1029 (  155 250 ) resistor r=152 //w=0.17 //l=0.17 //layer=licon //count=1 \
 //x=25.65 //y=4.88 //x2=25.65 //y2=4.88
r1030 (  146 248 ) resistor r=152 //w=0.17 //l=0.17 //layer=licon //count=1 \
 //x=25.65 //y=2.26 //x2=25.65 //y2=2.26
r1031 (  125 274 ) resistor r=23.615 //w=0.187 //l=0.345 //layer=li \
 //thickness=0.1 //x=23.02 //y=5.56 //x2=23.02 //y2=5.905
r1032 (  117 273 ) resistor r=23.615 //w=0.187 //l=0.345 //layer=li \
 //thickness=0.1 //x=22.14 //y=5.56 //x2=22.14 //y2=5.905
r1033 (  109 272 ) resistor r=23.615 //w=0.187 //l=0.345 //layer=li \
 //thickness=0.1 //x=21.26 //y=5.56 //x2=21.26 //y2=5.905
r1034 (  105 106 ) resistor r=0.10734 //w=0.281 //l=0.16 //layer=m2 \
 //thickness=0.36 //x=91.515 //y=4.64 //x2=91.355 //y2=4.64
r1035 (  98 100 ) resistor r=0.28626 //w=0.131 //l=0.3 //layer=m2 \
 //thickness=0.36 //x=75.3 //y=4.99 //x2=75.6 //y2=4.99
r1036 (  94 95 ) resistor r=0.10734 //w=0.281 //l=0.16 //layer=m2 \
 //thickness=0.36 //x=25.605 //y=2.755 //x2=25.445 //y2=2.755
r1037 (  89 95 ) resistor r=1.37405 //w=0.131 //l=1.44 //layer=m2 \
 //thickness=0.36 //x=24.005 //y=2.77 //x2=25.445 //y2=2.77
r1038 (  87 89 ) resistor r=0.10734 //w=0.281 //l=0.16 //layer=m2 \
 //thickness=0.36 //x=23.845 //y=2.755 //x2=24.005 //y2=2.755
r1039 (  85 103 ) resistor r=0.10734 //w=0.281 //l=0.16 //layer=m2 \
 //thickness=0.36 //x=87.975 //y=4.62 //x2=87.815 //y2=4.62
r1040 (  85 106 ) resistor r=3.22519 //w=0.131 //l=3.38 //layer=m2 \
 //thickness=0.36 //x=87.975 //y=4.62 //x2=91.355 //y2=4.62
r1041 (  82 103 ) resistor r=0.10734 //w=0.281 //l=0.16 //layer=m2 \
 //thickness=0.36 //x=87.655 //y=4.62 //x2=87.815 //y2=4.62
r1042 (  82 83 ) resistor r=11.4218 //w=0.131 //l=11.97 //layer=m2 \
 //thickness=0.36 //x=87.655 //y=4.62 //x2=75.685 //y2=4.62
r1043 (  81 100 ) resistor r=0.0073411 //w=0.17 //l=0.085 //layer=m2 \
 //thickness=0.36 //x=75.6 //y=4.905 //x2=75.6 //y2=4.99
r1044 (  80 83 ) resistor r=0.0718295 //w=0.17 //l=0.120208 //layer=m2 \
 //thickness=0.36 //x=75.6 //y=4.705 //x2=75.685 //y2=4.62
r1045 (  80 81 ) resistor r=0.19084 //w=0.131 //l=0.2 //layer=m2 \
 //thickness=0.36 //x=75.6 //y=4.705 //x2=75.6 //y2=4.905
r1046 (  79 97 ) resistor r=0.0073411 //w=0.17 //l=0.087 //layer=m2 \
 //thickness=0.36 //x=75.3 //y=5.215 //x2=75.3 //y2=5.302
r1047 (  78 98 ) resistor r=0.0073411 //w=0.17 //l=0.085 //layer=m2 \
 //thickness=0.36 //x=75.3 //y=5.075 //x2=75.3 //y2=4.99
r1048 (  78 79 ) resistor r=0.133588 //w=0.131 //l=0.14 //layer=m2 \
 //thickness=0.36 //x=75.3 //y=5.075 //x2=75.3 //y2=5.215
r1049 (  76 97 ) resistor r=7.10294 //w=0.17 //l=9.6615 //layer=m2 \
 //thickness=0.36 //x=65.64 //y=5.305 //x2=75.3 //y2=5.302
r1050 (  76 77 ) resistor r=0.749046 //w=0.131 //l=0.785 //layer=m2 \
 //thickness=0.36 //x=65.64 //y=5.305 //x2=64.855 //y2=5.305
r1051 (  74 77 ) resistor r=0.125 //w=0.17 //l=0.172482 //layer=m2 \
 //thickness=0.36 //x=64.685 //y=5.31 //x2=64.855 //y2=5.305
r1052 (  74 75 ) resistor r=17.2137 //w=0.131 //l=18.04 //layer=m2 \
 //thickness=0.36 //x=64.685 //y=5.31 //x2=46.645 //y2=5.31
r1053 (  72 75 ) resistor r=0.1875 //w=0.17 //l=0.257488 //layer=m2 \
 //thickness=0.36 //x=46.39 //y=5.305 //x2=46.645 //y2=5.31
r1054 (  72 73 ) resistor r=0.739504 //w=0.131 //l=0.775 //layer=m2 \
 //thickness=0.36 //x=46.39 //y=5.305 //x2=45.615 //y2=5.305
r1055 (  70 73 ) resistor r=0.125 //w=0.17 //l=0.182071 //layer=m2 \
 //thickness=0.36 //x=45.445 //y=5.33 //x2=45.615 //y2=5.305
r1056 (  70 71 ) resistor r=8.05344 //w=0.131 //l=8.44 //layer=m2 \
 //thickness=0.36 //x=45.445 //y=5.33 //x2=37.005 //y2=5.33
r1057 (  68 71 ) resistor r=0.125 //w=0.17 //l=0.179722 //layer=m2 \
 //thickness=0.36 //x=36.835 //y=5.35 //x2=37.005 //y2=5.33
r1058 (  68 69 ) resistor r=0.820611 //w=0.131 //l=0.86 //layer=m2 \
 //thickness=0.36 //x=36.835 //y=5.35 //x2=35.975 //y2=5.35
r1059 (  67 69 ) resistor r=0.0698411 //w=0.17 //l=0.120208 //layer=m2 \
 //thickness=0.36 //x=35.89 //y=5.265 //x2=35.975 //y2=5.35
r1060 (  66 91 ) resistor r=8.69612 //w=0.174 //l=12.105 //layer=m2 \
 //thickness=0.36 //x=35.89 //y=5.075 //x2=23.785 //y2=5.075
r1061 (  66 67 ) resistor r=0.181298 //w=0.131 //l=0.19 //layer=m2 \
 //thickness=0.36 //x=35.89 //y=5.075 //x2=35.89 //y2=5.265
r1062 (  63 171 ) resistor r=9.3 //w=0.17 //l=0.17 //layer=mcon //count=1 \
 //x=91.51 //y=2.26 //x2=91.51 //y2=2.26
r1063 (  61 105 ) resistor r=4.5 //w=0.15 //l=0.15 //layer=via1 //count=1 \
 //x=91.515 //y=4.64 //x2=91.515 //y2=4.64
r1064 (  59 176 ) resistor r=9.3 //w=0.17 //l=0.17 //layer=mcon //count=1 \
 //x=91.51 //y=4.62 //x2=91.51 //y2=4.62
r1065 (  59 61 ) resistor r=0.00659631 //w=0.379 //l=0.02 //layer=m1 \
 //thickness=0.36 //x=91.46 //y=4.62 //x2=91.46 //y2=4.64
r1066 (  56 165 ) resistor r=9.3 //w=0.17 //l=0.17 //layer=mcon //count=1 \
 //x=87.81 //y=4.62 //x2=87.81 //y2=4.62
r1067 (  56 103 ) resistor r=4.5 //w=0.15 //l=0.15 //layer=via1 //count=1 \
 //x=87.815 //y=4.62 //x2=87.815 //y2=4.62
r1068 (  54 160 ) resistor r=9.3 //w=0.17 //l=0.17 //layer=mcon //count=1 \
 //x=87.81 //y=2.26 //x2=87.81 //y2=2.26
r1069 (  50 94 ) resistor r=4.5 //w=0.15 //l=0.15 //layer=via1 //count=1 \
 //x=25.605 //y=2.755 //x2=25.605 //y2=2.755
r1070 (  50 52 ) resistor r=0.00509511 //w=0.368 //l=0.015 //layer=m1 \
 //thickness=0.36 //x=25.59 //y=2.755 //x2=25.59 //y2=2.77
r1071 (  48 155 ) resistor r=9.3 //w=0.17 //l=0.17 //layer=mcon //count=1 \
 //x=25.65 //y=4.88 //x2=25.65 //y2=4.88
r1072 (  46 146 ) resistor r=9.3 //w=0.17 //l=0.17 //layer=mcon //count=1 \
 //x=25.65 //y=2.26 //x2=25.65 //y2=2.26
r1073 (  42 87 ) resistor r=4.5 //w=0.15 //l=0.15 //layer=via1 //count=1 \
 //x=23.845 //y=2.755 //x2=23.845 //y2=2.755
r1074 (  42 44 ) resistor r=0.00509511 //w=0.368 //l=0.015 //layer=m1 \
 //thickness=0.36 //x=23.86 //y=2.755 //x2=23.86 //y2=2.77
r1075 (  39 91 ) resistor r=4.5 //w=0.15 //l=0.15 //layer=via1 //count=1 \
 //x=23.785 //y=5.095 //x2=23.785 //y2=5.095
r1076 (  39 40 ) resistor r=0.0900901 //w=0.333 //l=0.24 //layer=m1 \
 //thickness=0.36 //x=23.845 //y=5.095 //x2=23.845 //y2=5.335
r1077 (  37 39 ) resistor r=0.0394144 //w=0.333 //l=0.105 //layer=m1 \
 //thickness=0.36 //x=23.845 //y=4.99 //x2=23.845 //y2=5.095
r1078 (  35 270 ) resistor r=9.3 //w=0.17 //l=0.17 //layer=mcon //count=1 \
 //x=23.315 //y=1.19 //x2=23.315 //y2=1.19
r1079 (  33 125 ) resistor r=9.3 //w=0.17 //l=0.17 //layer=mcon //count=1 \
 //x=23.02 //y=5.56 //x2=23.02 //y2=5.56
r1080 (  30 117 ) resistor r=9.3 //w=0.17 //l=0.17 //layer=mcon //count=1 \
 //x=22.14 //y=5.56 //x2=22.14 //y2=5.56
r1081 (  28 30 ) resistor r=0.121228 //w=0.232 //l=0.225 //layer=m1 \
 //thickness=0.36 //x=22.14 //y=5.335 //x2=22.14 //y2=5.56
r1082 (  27 109 ) resistor r=9.3 //w=0.17 //l=0.17 //layer=mcon //count=1 \
 //x=21.26 //y=5.56 //x2=21.26 //y2=5.56
r1083 (  25 27 ) resistor r=0.129608 //w=0.217 //l=0.225 //layer=m1 \
 //thickness=0.36 //x=21.262 //y=5.335 //x2=21.262 //y2=5.56
r1084 (  24 59 ) resistor r=0.0863342 //w=0.379 //l=0.168152 //layer=m1 \
 //thickness=0.36 //x=91.51 //y=4.475 //x2=91.46 //y2=4.62
r1085 (  23 63 ) resistor r=0.0761125 //w=0.237 //l=0.126491 //layer=m1 \
 //thickness=0.36 //x=91.51 //y=2.385 //x2=91.507 //y2=2.26
r1086 (  23 24 ) resistor r=1.99427 //w=0.131 //l=2.09 //layer=m1 \
 //thickness=0.36 //x=91.51 //y=2.385 //x2=91.51 //y2=4.475
r1087 (  22 56 ) resistor r=0.0898201 //w=0.322 //l=0.185472 //layer=m1 \
 //thickness=0.36 //x=87.81 //y=4.46 //x2=87.865 //y2=4.62
r1088 (  21 54 ) resistor r=0.0717383 //w=0.224 //l=0.115 //layer=m1 \
 //thickness=0.36 //x=87.81 //y=2.375 //x2=87.81 //y2=2.26
r1089 (  21 22 ) resistor r=1.9895 //w=0.131 //l=2.085 //layer=m1 \
 //thickness=0.36 //x=87.81 //y=2.375 //x2=87.81 //y2=4.46
r1090 (  20 48 ) resistor r=0.0760407 //w=0.238 //l=0.125 //layer=m1 \
 //thickness=0.36 //x=25.65 //y=4.755 //x2=25.65 //y2=4.88
r1091 (  19 52 ) resistor r=0.0857585 //w=0.368 //l=0.172409 //layer=m1 \
 //thickness=0.36 //x=25.65 //y=2.915 //x2=25.59 //y2=2.77
r1092 (  19 20 ) resistor r=1.75573 //w=0.131 //l=1.84 //layer=m1 \
 //thickness=0.36 //x=25.65 //y=2.915 //x2=25.65 //y2=4.755
r1093 (  18 50 ) resistor r=0.0908536 //w=0.368 //l=0.187617 //layer=m1 \
 //thickness=0.36 //x=25.65 //y=2.595 //x2=25.59 //y2=2.755
r1094 (  17 46 ) resistor r=0.0719237 //w=0.222 //l=0.115 //layer=m1 \
 //thickness=0.36 //x=25.65 //y=2.375 //x2=25.65 //y2=2.26
r1095 (  17 18 ) resistor r=0.209924 //w=0.131 //l=0.22 //layer=m1 \
 //thickness=0.36 //x=25.65 //y=2.375 //x2=25.65 //y2=2.595
r1096 (  16 37 ) resistor r=0.0730397 //w=0.333 //l=0.135647 //layer=m1 \
 //thickness=0.36 //x=23.8 //y=4.875 //x2=23.845 //y2=4.99
r1097 (  15 44 ) resistor r=0.0857585 //w=0.368 //l=0.172409 //layer=m1 \
 //thickness=0.36 //x=23.8 //y=2.915 //x2=23.86 //y2=2.77
r1098 (  15 16 ) resistor r=1.87023 //w=0.131 //l=1.96 //layer=m1 \
 //thickness=0.36 //x=23.8 //y=2.915 //x2=23.8 //y2=4.875
r1099 (  14 42 ) resistor r=0.0908536 //w=0.368 //l=0.187617 //layer=m1 \
 //thickness=0.36 //x=23.8 //y=2.595 //x2=23.86 //y2=2.755
r1100 (  13 14 ) resistor r=0.634542 //w=0.131 //l=0.665 //layer=m1 \
 //thickness=0.36 //x=23.8 //y=1.93 //x2=23.8 //y2=2.595
r1101 (  11 13 ) resistor r=0.0698411 //w=0.17 //l=0.120208 //layer=m1 \
 //thickness=0.36 //x=23.715 //y=1.845 //x2=23.8 //y2=1.93
r1102 (  11 12 ) resistor r=0.300573 //w=0.131 //l=0.315 //layer=m1 \
 //thickness=0.36 //x=23.715 //y=1.845 //x2=23.4 //y2=1.845
r1103 (  10 12 ) resistor r=0.0698411 //w=0.17 //l=0.120208 //layer=m1 \
 //thickness=0.36 //x=23.315 //y=1.76 //x2=23.4 //y2=1.845
r1104 (  9 35 ) resistor r=0.0717383 //w=0.224 //l=0.115 //layer=m1 \
 //thickness=0.36 //x=23.315 //y=1.305 //x2=23.315 //y2=1.19
r1105 (  9 10 ) resistor r=0.43416 //w=0.131 //l=0.455 //layer=m1 \
 //thickness=0.36 //x=23.315 //y=1.305 //x2=23.315 //y2=1.76
r1106 (  8 31 ) resistor r=0.0675342 //w=0.23 //l=0.115 //layer=m1 \
 //thickness=0.36 //x=23.135 //y=5.335 //x2=23.02 //y2=5.335
r1107 (  7 40 ) resistor r=0.0479249 //w=0.333 //l=0.22 //layer=m1 \
 //thickness=0.36 //x=23.625 //y=5.335 //x2=23.845 //y2=5.335
r1108 (  7 8 ) resistor r=0.467557 //w=0.131 //l=0.49 //layer=m1 \
 //thickness=0.36 //x=23.625 //y=5.335 //x2=23.135 //y2=5.335
r1109 (  6 33 ) resistor r=0.00118313 //w=0.23 //layer=m1 //thickness=0.36 \
 //x=23.02 //y=5.56 //x2=23.02 //y2=5.56
r1110 (  5 31 ) resistor r=0.002872 //w=0.34 //l=0.085 //layer=m1 \
 //thickness=0.36 //x=23.02 //y=5.42 //x2=23.02 //y2=5.335
r1111 (  5 6 ) resistor r=0.091623 //w=0.191 //l=0.14 //layer=m1 \
 //thickness=0.36 //x=23.02 //y=5.42 //x2=23.02 //y2=5.56
r1112 (  4 28 ) resistor r=0.0262263 //w=0.232 //l=0.12 //layer=m1 \
 //thickness=0.36 //x=22.26 //y=5.335 //x2=22.14 //y2=5.335
r1113 (  3 31 ) resistor r=0.0675342 //w=0.23 //l=0.115 //layer=m1 \
 //thickness=0.36 //x=22.905 //y=5.335 //x2=23.02 //y2=5.335
r1114 (  3 4 ) resistor r=0.615458 //w=0.131 //l=0.645 //layer=m1 \
 //thickness=0.36 //x=22.905 //y=5.335 //x2=22.26 //y2=5.335
r1115 (  2 25 ) resistor r=0.0222262 //w=0.217 //l=0.118 //layer=m1 \
 //thickness=0.36 //x=21.38 //y=5.335 //x2=21.262 //y2=5.335
r1116 (  1 28 ) resistor r=0.0262263 //w=0.232 //l=0.12 //layer=m1 \
 //thickness=0.36 //x=22.02 //y=5.335 //x2=22.14 //y2=5.335
r1117 (  1 2 ) resistor r=0.610687 //w=0.131 //l=0.64 //layer=m1 \
 //thickness=0.36 //x=22.02 //y=5.335 //x2=21.38 //y2=5.335
ends PM_TMRDFFSNRNQNX1\%noxref_4

subckt PM_TMRDFFSNRNQNX1\%noxref_5 ( 1 2 3 4 5 6 7 8 9 11 14 15 17 18 19 20 22 \
 23 24 25 26 27 28 34 38 45 48 51 57 61 70 72 73 77 80 81 87 96 101 110 115 \
 123 131 148 157 161 162 163 164 165 166 167 168 169 173 174 175 180 182 185 \
 186 190 191 192 197 199 202 203 207 208 209 214 216 219 220 222 223 228 232 \
 233 238 242 243 248 251 253 254 255 )
c602 ( 251 0 ) capacitor c=0.00885916f //x=18.315 //y=1.095
c603 ( 248 0 ) capacitor c=0.0651477f //x=27.87 //y=4.88
c604 ( 243 0 ) capacitor c=0.0278202f //x=27.87 //y=2.095
c605 ( 242 0 ) capacitor c=0.0503043f //x=27.87 //y=2.26
c606 ( 238 0 ) capacitor c=0.0651406f //x=13.44 //y=4.88
c607 ( 233 0 ) capacitor c=0.0278202f //x=13.44 //y=2.095
c608 ( 232 0 ) capacitor c=0.0503043f //x=13.44 //y=2.26
c609 ( 228 0 ) capacitor c=0.0653609f //x=8.63 //y=4.88
c610 ( 223 0 ) capacitor c=0.0278202f //x=8.63 //y=2.095
c611 ( 222 0 ) capacitor c=0.0503043f //x=8.63 //y=2.26
c612 ( 220 0 ) capacitor c=0.0443175f //x=28.39 //y=1.44
c613 ( 219 0 ) capacitor c=0.0199703f //x=28.39 //y=1.095
c614 ( 216 0 ) capacitor c=0.0162526f //x=28.235 //y=1.595
c615 ( 214 0 ) capacitor c=0.0157807f //x=28.235 //y=0.94
c616 ( 209 0 ) capacitor c=0.0220935f //x=27.86 //y=1.75
c617 ( 208 0 ) capacitor c=0.0207489f //x=27.86 //y=1.44
c618 ( 207 0 ) capacitor c=0.0194091f //x=27.86 //y=1.095
c619 ( 203 0 ) capacitor c=0.0443175f //x=13.96 //y=1.44
c620 ( 202 0 ) capacitor c=0.0199703f //x=13.96 //y=1.095
c621 ( 199 0 ) capacitor c=0.0162526f //x=13.805 //y=1.595
c622 ( 197 0 ) capacitor c=0.0157807f //x=13.805 //y=0.94
c623 ( 192 0 ) capacitor c=0.0220935f //x=13.43 //y=1.75
c624 ( 191 0 ) capacitor c=0.0207489f //x=13.43 //y=1.44
c625 ( 190 0 ) capacitor c=0.0194091f //x=13.43 //y=1.095
c626 ( 186 0 ) capacitor c=0.0443175f //x=9.15 //y=1.44
c627 ( 185 0 ) capacitor c=0.0199703f //x=9.15 //y=1.095
c628 ( 182 0 ) capacitor c=0.0162526f //x=8.995 //y=1.595
c629 ( 180 0 ) capacitor c=0.0157807f //x=8.995 //y=0.94
c630 ( 175 0 ) capacitor c=0.0220935f //x=8.62 //y=1.75
c631 ( 174 0 ) capacitor c=0.0207489f //x=8.62 //y=1.44
c632 ( 173 0 ) capacitor c=0.0194091f //x=8.62 //y=1.095
c633 ( 169 0 ) capacitor c=0.159671f //x=28.05 //y=6.2
c634 ( 168 0 ) capacitor c=0.110208f //x=27.61 //y=6.2
c635 ( 167 0 ) capacitor c=0.159671f //x=13.62 //y=6.2
c636 ( 166 0 ) capacitor c=0.110208f //x=13.18 //y=6.2
c637 ( 165 0 ) capacitor c=0.159671f //x=8.81 //y=6.2
c638 ( 164 0 ) capacitor c=0.110208f //x=8.37 //y=6.2
c639 ( 157 0 ) capacitor c=9.5006e-19 //x=27.87 //y=4.88
c640 ( 148 0 ) capacitor c=0.00101179f //x=27.87 //y=2.26
c641 ( 131 0 ) capacitor c=0.0293124f //x=18.21 //y=5.56
c642 ( 123 0 ) capacitor c=0.029137f //x=17.33 //y=5.56
c643 ( 115 0 ) capacitor c=0.0278099f //x=16.45 //y=5.56
c644 ( 110 0 ) capacitor c=7.7417e-19 //x=13.44 //y=4.88
c645 ( 101 0 ) capacitor c=0.00101179f //x=13.44 //y=2.26
c646 ( 96 0 ) capacitor c=7.7417e-19 //x=8.63 //y=4.88
c647 ( 87 0 ) capacitor c=0.00101179f //x=8.63 //y=2.26
c648 ( 81 0 ) capacitor c=6.2466e-19 //x=13.6 //y=3.895
c649 ( 80 0 ) capacitor c=0.0446269f //x=13.28 //y=3.895
c650 ( 77 0 ) capacitor c=6.16295e-19 //x=8.79 //y=3.895
c651 ( 73 0 ) capacitor c=0.0212158f //x=20.705 //y=3.895
c652 ( 72 0 ) capacitor c=0.0710808f //x=21.05 //y=3.895
c653 ( 70 0 ) capacitor c=0.0535679f //x=18.82 //y=3.88
c654 ( 61 0 ) capacitor c=0.0149589f //x=27.87 //y=3.88
c655 ( 57 0 ) capacitor c=0.0158949f //x=18.99 //y=3.88
c656 ( 51 0 ) capacitor c=0.00111241f //x=18.21 //y=5.335
c657 ( 48 0 ) capacitor c=0.00731246f //x=17.33 //y=5.335
c658 ( 45 0 ) capacitor c=0.0111234f //x=16.452 //y=5.335
c659 ( 38 0 ) capacitor c=0.0149589f //x=13.44 //y=3.88
c660 ( 34 0 ) capacitor c=0.0149589f //x=8.63 //y=3.88
c661 ( 28 0 ) capacitor c=0.0180445f //x=27.87 //y=4.75
c662 ( 27 0 ) capacitor c=0.011467f //x=27.87 //y=4.045
c663 ( 26 0 ) capacitor c=0.0291048f //x=27.87 //y=3.725
c664 ( 25 0 ) capacitor c=0.00556102f //x=27.87 //y=2.375
c665 ( 24 0 ) capacitor c=0.0323149f //x=18.99 //y=5.25
c666 ( 23 0 ) capacitor c=0.0138897f //x=18.99 //y=4.055
c667 ( 22 0 ) capacitor c=0.0490588f //x=18.99 //y=3.735
c668 ( 20 0 ) capacitor c=0.00493487f //x=18.59 //y=1.845
c669 ( 19 0 ) capacitor c=0.0133342f //x=18.905 //y=1.845
c670 ( 18 0 ) capacitor c=0.0167992f //x=18.505 //y=1.76
c671 ( 17 0 ) capacitor c=0.0111491f //x=18.505 //y=1.305
c672 ( 15 0 ) capacitor c=0.0238276f //x=18.905 //y=5.335
c673 ( 14 0 ) capacitor c=0.00933983f //x=18.21 //y=5.56
c674 ( 11 0 ) capacitor c=0.019596f //x=18.095 //y=5.335
c675 ( 9 0 ) capacitor c=0.0148057f //x=17.21 //y=5.335
c676 ( 8 0 ) capacitor c=0.0195876f //x=13.44 //y=4.75
c677 ( 7 0 ) capacitor c=0.011494f //x=13.44 //y=4.055
c678 ( 6 0 ) capacitor c=0.029293f //x=13.44 //y=3.735
c679 ( 5 0 ) capacitor c=0.00556102f //x=13.44 //y=2.375
c680 ( 4 0 ) capacitor c=0.019633f //x=8.63 //y=4.75
c681 ( 3 0 ) capacitor c=0.0115187f //x=8.63 //y=4.055
c682 ( 2 0 ) capacitor c=0.0329467f //x=8.63 //y=3.735
c683 ( 1 0 ) capacitor c=0.00556102f //x=8.63 //y=2.375
r684 (  242 243 ) resistor r=52.7279 //w=0.214 //l=0.165 //layer=ply \
 //thickness=0.18 //x=27.87 //y=2.26 //x2=27.87 //y2=2.095
r685 (  232 233 ) resistor r=52.7279 //w=0.214 //l=0.165 //layer=ply \
 //thickness=0.18 //x=13.44 //y=2.26 //x2=13.44 //y2=2.095
r686 (  222 223 ) resistor r=52.7279 //w=0.214 //l=0.165 //layer=ply \
 //thickness=0.18 //x=8.63 //y=2.26 //x2=8.63 //y2=2.095
r687 (  220 250 ) resistor r=45.1352 //w=0.168 //l=0.173853 //layer=ply \
 //thickness=0.18 //x=28.39 //y=1.44 //x2=28.35 //y2=1.595
r688 (  219 249 ) resistor r=45.1352 //w=0.168 //l=0.173853 //layer=ply \
 //thickness=0.18 //x=28.39 //y=1.095 //x2=28.35 //y2=0.94
r689 (  219 220 ) resistor r=176.904 //w=0.094 //l=0.345 //layer=ply \
 //thickness=0.18 //x=28.39 //y=1.095 //x2=28.39 //y2=1.44
r690 (  217 246 ) resistor r=10.701 //w=0.21 //l=0.115 //layer=ply \
 //thickness=0.18 //x=28.015 //y=1.595 //x2=27.9 //y2=1.595
r691 (  216 250 ) resistor r=5.52526 //w=0.168 //l=0.115 //layer=ply \
 //thickness=0.18 //x=28.235 //y=1.595 //x2=28.35 //y2=1.595
r692 (  215 245 ) resistor r=5.52526 //w=0.168 //l=0.115 //layer=ply \
 //thickness=0.18 //x=28.015 //y=0.94 //x2=27.9 //y2=0.94
r693 (  214 249 ) resistor r=5.52526 //w=0.168 //l=0.115 //layer=ply \
 //thickness=0.18 //x=28.235 //y=0.94 //x2=28.35 //y2=0.94
r694 (  214 215 ) resistor r=112.809 //w=0.094 //l=0.22 //layer=ply \
 //thickness=0.18 //x=28.235 //y=0.94 //x2=28.015 //y2=0.94
r695 (  211 248 ) resistor r=37.236 //w=0.233 //l=0.249199 //layer=ply \
 //thickness=0.18 //x=28.05 //y=5.045 //x2=27.87 //y2=4.88
r696 (  209 246 ) resistor r=39.5823 //w=0.21 //l=0.173853 //layer=ply \
 //thickness=0.18 //x=27.86 //y=1.75 //x2=27.9 //y2=1.595
r697 (  209 243 ) resistor r=176.904 //w=0.094 //l=0.345 //layer=ply \
 //thickness=0.18 //x=27.86 //y=1.75 //x2=27.86 //y2=2.095
r698 (  208 246 ) resistor r=39.5823 //w=0.21 //l=0.173853 //layer=ply \
 //thickness=0.18 //x=27.86 //y=1.44 //x2=27.9 //y2=1.595
r699 (  207 245 ) resistor r=45.1352 //w=0.168 //l=0.173853 //layer=ply \
 //thickness=0.18 //x=27.86 //y=1.095 //x2=27.9 //y2=0.94
r700 (  207 208 ) resistor r=176.904 //w=0.094 //l=0.345 //layer=ply \
 //thickness=0.18 //x=27.86 //y=1.095 //x2=27.86 //y2=1.44
r701 (  204 248 ) resistor r=53.7854 //w=0.233 //l=0.332415 //layer=ply \
 //thickness=0.18 //x=27.61 //y=5.045 //x2=27.87 //y2=4.88
r702 (  203 240 ) resistor r=45.1352 //w=0.168 //l=0.173853 //layer=ply \
 //thickness=0.18 //x=13.96 //y=1.44 //x2=13.92 //y2=1.595
r703 (  202 239 ) resistor r=45.1352 //w=0.168 //l=0.173853 //layer=ply \
 //thickness=0.18 //x=13.96 //y=1.095 //x2=13.92 //y2=0.94
r704 (  202 203 ) resistor r=176.904 //w=0.094 //l=0.345 //layer=ply \
 //thickness=0.18 //x=13.96 //y=1.095 //x2=13.96 //y2=1.44
r705 (  200 236 ) resistor r=10.701 //w=0.21 //l=0.115 //layer=ply \
 //thickness=0.18 //x=13.585 //y=1.595 //x2=13.47 //y2=1.595
r706 (  199 240 ) resistor r=5.52526 //w=0.168 //l=0.115 //layer=ply \
 //thickness=0.18 //x=13.805 //y=1.595 //x2=13.92 //y2=1.595
r707 (  198 235 ) resistor r=5.52526 //w=0.168 //l=0.115 //layer=ply \
 //thickness=0.18 //x=13.585 //y=0.94 //x2=13.47 //y2=0.94
r708 (  197 239 ) resistor r=5.52526 //w=0.168 //l=0.115 //layer=ply \
 //thickness=0.18 //x=13.805 //y=0.94 //x2=13.92 //y2=0.94
r709 (  197 198 ) resistor r=112.809 //w=0.094 //l=0.22 //layer=ply \
 //thickness=0.18 //x=13.805 //y=0.94 //x2=13.585 //y2=0.94
r710 (  194 238 ) resistor r=37.236 //w=0.233 //l=0.249199 //layer=ply \
 //thickness=0.18 //x=13.62 //y=5.045 //x2=13.44 //y2=4.88
r711 (  192 236 ) resistor r=39.5823 //w=0.21 //l=0.173853 //layer=ply \
 //thickness=0.18 //x=13.43 //y=1.75 //x2=13.47 //y2=1.595
r712 (  192 233 ) resistor r=176.904 //w=0.094 //l=0.345 //layer=ply \
 //thickness=0.18 //x=13.43 //y=1.75 //x2=13.43 //y2=2.095
r713 (  191 236 ) resistor r=39.5823 //w=0.21 //l=0.173853 //layer=ply \
 //thickness=0.18 //x=13.43 //y=1.44 //x2=13.47 //y2=1.595
r714 (  190 235 ) resistor r=45.1352 //w=0.168 //l=0.173853 //layer=ply \
 //thickness=0.18 //x=13.43 //y=1.095 //x2=13.47 //y2=0.94
r715 (  190 191 ) resistor r=176.904 //w=0.094 //l=0.345 //layer=ply \
 //thickness=0.18 //x=13.43 //y=1.095 //x2=13.43 //y2=1.44
r716 (  187 238 ) resistor r=53.7854 //w=0.233 //l=0.332415 //layer=ply \
 //thickness=0.18 //x=13.18 //y=5.045 //x2=13.44 //y2=4.88
r717 (  186 230 ) resistor r=45.1352 //w=0.168 //l=0.173853 //layer=ply \
 //thickness=0.18 //x=9.15 //y=1.44 //x2=9.11 //y2=1.595
r718 (  185 229 ) resistor r=45.1352 //w=0.168 //l=0.173853 //layer=ply \
 //thickness=0.18 //x=9.15 //y=1.095 //x2=9.11 //y2=0.94
r719 (  185 186 ) resistor r=176.904 //w=0.094 //l=0.345 //layer=ply \
 //thickness=0.18 //x=9.15 //y=1.095 //x2=9.15 //y2=1.44
r720 (  183 226 ) resistor r=10.701 //w=0.21 //l=0.115 //layer=ply \
 //thickness=0.18 //x=8.775 //y=1.595 //x2=8.66 //y2=1.595
r721 (  182 230 ) resistor r=5.52526 //w=0.168 //l=0.115 //layer=ply \
 //thickness=0.18 //x=8.995 //y=1.595 //x2=9.11 //y2=1.595
r722 (  181 225 ) resistor r=5.52526 //w=0.168 //l=0.115 //layer=ply \
 //thickness=0.18 //x=8.775 //y=0.94 //x2=8.66 //y2=0.94
r723 (  180 229 ) resistor r=5.52526 //w=0.168 //l=0.115 //layer=ply \
 //thickness=0.18 //x=8.995 //y=0.94 //x2=9.11 //y2=0.94
r724 (  180 181 ) resistor r=112.809 //w=0.094 //l=0.22 //layer=ply \
 //thickness=0.18 //x=8.995 //y=0.94 //x2=8.775 //y2=0.94
r725 (  177 228 ) resistor r=37.236 //w=0.233 //l=0.249199 //layer=ply \
 //thickness=0.18 //x=8.81 //y=5.045 //x2=8.63 //y2=4.88
r726 (  175 226 ) resistor r=39.5823 //w=0.21 //l=0.173853 //layer=ply \
 //thickness=0.18 //x=8.62 //y=1.75 //x2=8.66 //y2=1.595
r727 (  175 223 ) resistor r=176.904 //w=0.094 //l=0.345 //layer=ply \
 //thickness=0.18 //x=8.62 //y=1.75 //x2=8.62 //y2=2.095
r728 (  174 226 ) resistor r=39.5823 //w=0.21 //l=0.173853 //layer=ply \
 //thickness=0.18 //x=8.62 //y=1.44 //x2=8.66 //y2=1.595
r729 (  173 225 ) resistor r=45.1352 //w=0.168 //l=0.173853 //layer=ply \
 //thickness=0.18 //x=8.62 //y=1.095 //x2=8.66 //y2=0.94
r730 (  173 174 ) resistor r=176.904 //w=0.094 //l=0.345 //layer=ply \
 //thickness=0.18 //x=8.62 //y=1.095 //x2=8.62 //y2=1.44
r731 (  170 228 ) resistor r=53.7854 //w=0.233 //l=0.332415 //layer=ply \
 //thickness=0.18 //x=8.37 //y=5.045 //x2=8.63 //y2=4.88
r732 (  169 211 ) resistor r=592.245 //w=0.094 //l=1.155 //layer=ply \
 //thickness=0.18 //x=28.05 //y=6.2 //x2=28.05 //y2=5.045
r733 (  168 204 ) resistor r=592.245 //w=0.094 //l=1.155 //layer=ply \
 //thickness=0.18 //x=27.61 //y=6.2 //x2=27.61 //y2=5.045
r734 (  167 194 ) resistor r=592.245 //w=0.094 //l=1.155 //layer=ply \
 //thickness=0.18 //x=13.62 //y=6.2 //x2=13.62 //y2=5.045
r735 (  166 187 ) resistor r=592.245 //w=0.094 //l=1.155 //layer=ply \
 //thickness=0.18 //x=13.18 //y=6.2 //x2=13.18 //y2=5.045
r736 (  165 177 ) resistor r=592.245 //w=0.094 //l=1.155 //layer=ply \
 //thickness=0.18 //x=8.81 //y=6.2 //x2=8.81 //y2=5.045
r737 (  164 170 ) resistor r=592.245 //w=0.094 //l=1.155 //layer=ply \
 //thickness=0.18 //x=8.37 //y=6.2 //x2=8.37 //y2=5.045
r738 (  163 216 ) resistor r=56.4043 //w=0.094 //l=0.11 //layer=ply \
 //thickness=0.18 //x=28.125 //y=1.595 //x2=28.235 //y2=1.595
r739 (  163 217 ) resistor r=56.4043 //w=0.094 //l=0.11 //layer=ply \
 //thickness=0.18 //x=28.125 //y=1.595 //x2=28.015 //y2=1.595
r740 (  162 199 ) resistor r=56.4043 //w=0.094 //l=0.11 //layer=ply \
 //thickness=0.18 //x=13.695 //y=1.595 //x2=13.805 //y2=1.595
r741 (  162 200 ) resistor r=56.4043 //w=0.094 //l=0.11 //layer=ply \
 //thickness=0.18 //x=13.695 //y=1.595 //x2=13.585 //y2=1.595
r742 (  161 182 ) resistor r=56.4043 //w=0.094 //l=0.11 //layer=ply \
 //thickness=0.18 //x=8.885 //y=1.595 //x2=8.995 //y2=1.595
r743 (  161 183 ) resistor r=56.4043 //w=0.094 //l=0.11 //layer=ply \
 //thickness=0.18 //x=8.885 //y=1.595 //x2=8.775 //y2=1.595
r744 (  157 248 ) resistor r=152 //w=0.17 //l=0.17 //layer=licon //count=1 \
 //x=27.87 //y=4.88 //x2=27.87 //y2=4.88
r745 (  148 242 ) resistor r=152 //w=0.17 //l=0.17 //layer=licon //count=1 \
 //x=27.87 //y=2.26 //x2=27.87 //y2=2.26
r746 (  131 255 ) resistor r=23.615 //w=0.187 //l=0.345 //layer=li \
 //thickness=0.1 //x=18.21 //y=5.56 //x2=18.21 //y2=5.905
r747 (  123 254 ) resistor r=23.615 //w=0.187 //l=0.345 //layer=li \
 //thickness=0.1 //x=17.33 //y=5.56 //x2=17.33 //y2=5.905
r748 (  115 253 ) resistor r=23.615 //w=0.187 //l=0.345 //layer=li \
 //thickness=0.1 //x=16.45 //y=5.56 //x2=16.45 //y2=5.905
r749 (  110 238 ) resistor r=152 //w=0.17 //l=0.17 //layer=licon //count=1 \
 //x=13.44 //y=4.88 //x2=13.44 //y2=4.88
r750 (  101 232 ) resistor r=152 //w=0.17 //l=0.17 //layer=licon //count=1 \
 //x=13.44 //y=2.26 //x2=13.44 //y2=2.26
r751 (  96 228 ) resistor r=152 //w=0.17 //l=0.17 //layer=licon //count=1 \
 //x=8.63 //y=4.88 //x2=8.63 //y2=4.88
r752 (  87 222 ) resistor r=152 //w=0.17 //l=0.17 //layer=licon //count=1 \
 //x=8.63 //y=2.26 //x2=8.63 //y2=2.26
r753 (  79 81 ) resistor r=0.10734 //w=0.281 //l=0.16 //layer=m2 \
 //thickness=0.36 //x=13.44 //y=3.895 //x2=13.6 //y2=3.895
r754 (  79 80 ) resistor r=0.10734 //w=0.281 //l=0.16 //layer=m2 \
 //thickness=0.36 //x=13.44 //y=3.895 //x2=13.28 //y2=3.895
r755 (  77 80 ) resistor r=4.28435 //w=0.131 //l=4.49 //layer=m2 \
 //thickness=0.36 //x=8.79 //y=3.88 //x2=13.28 //y2=3.88
r756 (  75 77 ) resistor r=0.10734 //w=0.281 //l=0.16 //layer=m2 \
 //thickness=0.36 //x=8.63 //y=3.895 //x2=8.79 //y2=3.895
r757 (  73 83 ) resistor r=1.10266 //w=0.196 //l=1.725 //layer=m2 \
 //thickness=0.36 //x=20.705 //y=3.895 //x2=18.98 //y2=3.895
r758 (  72 85 ) resistor r=4.81638 //w=0.177 //l=6.825 //layer=m2 \
 //thickness=0.36 //x=21.05 //y=3.895 //x2=27.87 //y2=3.885
r759 (  72 73 ) resistor r=0.329198 //w=0.131 //l=0.345 //layer=m2 \
 //thickness=0.36 //x=21.05 //y=3.895 //x2=20.705 //y2=3.895
r760 (  70 83 ) resistor r=0.104578 //w=0.196 //l=0.167332 //layer=m2 \
 //thickness=0.36 //x=18.82 //y=3.88 //x2=18.98 //y2=3.895
r761 (  70 81 ) resistor r=4.98092 //w=0.131 //l=5.22 //layer=m2 \
 //thickness=0.36 //x=18.82 //y=3.88 //x2=13.6 //y2=3.88
r762 (  67 157 ) resistor r=9.3 //w=0.17 //l=0.17 //layer=mcon //count=1 \
 //x=27.87 //y=4.88 //x2=27.87 //y2=4.88
r763 (  65 148 ) resistor r=9.3 //w=0.17 //l=0.17 //layer=mcon //count=1 \
 //x=27.87 //y=2.26 //x2=27.87 //y2=2.26
r764 (  63 85 ) resistor r=4.5 //w=0.15 //l=0.15 //layer=via1 //count=1 \
 //x=27.87 //y=3.885 //x2=27.87 //y2=3.885
r765 (  61 63 ) resistor r=0.00166223 //w=0.376 //l=0.005 //layer=m1 \
 //thickness=0.36 //x=27.817 //y=3.88 //x2=27.817 //y2=3.885
r766 (  59 83 ) resistor r=4.5 //w=0.15 //l=0.15 //layer=via1 //count=1 \
 //x=18.98 //y=3.895 //x2=18.98 //y2=3.895
r767 (  57 59 ) resistor r=0.00490838 //w=0.382 //l=0.015 //layer=m1 \
 //thickness=0.36 //x=19.037 //y=3.88 //x2=19.037 //y2=3.895
r768 (  55 251 ) resistor r=9.3 //w=0.17 //l=0.17 //layer=mcon //count=1 \
 //x=18.505 //y=1.19 //x2=18.505 //y2=1.19
r769 (  53 131 ) resistor r=9.3 //w=0.17 //l=0.17 //layer=mcon //count=1 \
 //x=18.21 //y=5.56 //x2=18.21 //y2=5.56
r770 (  50 123 ) resistor r=9.3 //w=0.17 //l=0.17 //layer=mcon //count=1 \
 //x=17.33 //y=5.56 //x2=17.33 //y2=5.56
r771 (  48 50 ) resistor r=0.121228 //w=0.232 //l=0.225 //layer=m1 \
 //thickness=0.36 //x=17.33 //y=5.335 //x2=17.33 //y2=5.56
r772 (  47 115 ) resistor r=9.3 //w=0.17 //l=0.17 //layer=mcon //count=1 \
 //x=16.45 //y=5.56 //x2=16.45 //y2=5.56
r773 (  45 47 ) resistor r=0.129608 //w=0.217 //l=0.225 //layer=m1 \
 //thickness=0.36 //x=16.452 //y=5.335 //x2=16.452 //y2=5.56
r774 (  44 110 ) resistor r=9.3 //w=0.17 //l=0.17 //layer=mcon //count=1 \
 //x=13.44 //y=4.88 //x2=13.44 //y2=4.88
r775 (  42 101 ) resistor r=9.3 //w=0.17 //l=0.17 //layer=mcon //count=1 \
 //x=13.44 //y=2.26 //x2=13.44 //y2=2.26
r776 (  40 79 ) resistor r=4.5 //w=0.15 //l=0.15 //layer=via1 //count=1 \
 //x=13.44 //y=3.895 //x2=13.44 //y2=3.895
r777 (  38 40 ) resistor r=0.0049867 //w=0.376 //l=0.015 //layer=m1 \
 //thickness=0.36 //x=13.387 //y=3.88 //x2=13.387 //y2=3.895
r778 (  36 75 ) resistor r=4.5 //w=0.15 //l=0.15 //layer=via1 //count=1 \
 //x=8.63 //y=3.895 //x2=8.63 //y2=3.895
r779 (  34 36 ) resistor r=0.0049867 //w=0.376 //l=0.015 //layer=m1 \
 //thickness=0.36 //x=8.682 //y=3.88 //x2=8.682 //y2=3.895
r780 (  32 96 ) resistor r=9.3 //w=0.17 //l=0.17 //layer=mcon //count=1 \
 //x=8.63 //y=4.88 //x2=8.63 //y2=4.88
r781 (  30 87 ) resistor r=9.3 //w=0.17 //l=0.17 //layer=mcon //count=1 \
 //x=8.63 //y=2.26 //x2=8.63 //y2=2.26
r782 (  28 67 ) resistor r=0.0801089 //w=0.224 //l=0.13 //layer=m1 \
 //thickness=0.36 //x=27.87 //y=4.75 //x2=27.87 //y2=4.88
r783 (  27 63 ) resistor r=0.0911593 //w=0.376 //l=0.184608 //layer=m1 \
 //thickness=0.36 //x=27.87 //y=4.045 //x2=27.817 //y2=3.885
r784 (  27 28 ) resistor r=0.67271 //w=0.131 //l=0.705 //layer=m1 \
 //thickness=0.36 //x=27.87 //y=4.045 //x2=27.87 //y2=4.75
r785 (  26 61 ) resistor r=0.0894971 //w=0.376 //l=0.179555 //layer=m1 \
 //thickness=0.36 //x=27.87 //y=3.725 //x2=27.817 //y2=3.88
r786 (  25 65 ) resistor r=0.0719237 //w=0.222 //l=0.115 //layer=m1 \
 //thickness=0.36 //x=27.87 //y=2.375 //x2=27.87 //y2=2.26
r787 (  25 26 ) resistor r=1.28817 //w=0.131 //l=1.35 //layer=m1 \
 //thickness=0.36 //x=27.87 //y=2.375 //x2=27.87 //y2=3.725
r788 (  23 59 ) resistor r=0.0914072 //w=0.382 //l=0.181989 //layer=m1 \
 //thickness=0.36 //x=18.99 //y=4.055 //x2=19.037 //y2=3.895
r789 (  23 24 ) resistor r=1.14027 //w=0.131 //l=1.195 //layer=m1 \
 //thickness=0.36 //x=18.99 //y=4.055 //x2=18.99 //y2=5.25
r790 (  22 57 ) resistor r=0.0864989 //w=0.382 //l=0.166853 //layer=m1 \
 //thickness=0.36 //x=18.99 //y=3.735 //x2=19.037 //y2=3.88
r791 (  21 22 ) resistor r=1.72233 //w=0.131 //l=1.805 //layer=m1 \
 //thickness=0.36 //x=18.99 //y=1.93 //x2=18.99 //y2=3.735
r792 (  19 21 ) resistor r=0.0698411 //w=0.17 //l=0.120208 //layer=m1 \
 //thickness=0.36 //x=18.905 //y=1.845 //x2=18.99 //y2=1.93
r793 (  19 20 ) resistor r=0.300573 //w=0.131 //l=0.315 //layer=m1 \
 //thickness=0.36 //x=18.905 //y=1.845 //x2=18.59 //y2=1.845
r794 (  18 20 ) resistor r=0.0698411 //w=0.17 //l=0.120208 //layer=m1 \
 //thickness=0.36 //x=18.505 //y=1.76 //x2=18.59 //y2=1.845
r795 (  17 55 ) resistor r=0.0717383 //w=0.224 //l=0.115 //layer=m1 \
 //thickness=0.36 //x=18.505 //y=1.305 //x2=18.505 //y2=1.19
r796 (  17 18 ) resistor r=0.43416 //w=0.131 //l=0.455 //layer=m1 \
 //thickness=0.36 //x=18.505 //y=1.305 //x2=18.505 //y2=1.76
r797 (  16 51 ) resistor r=0.0675342 //w=0.23 //l=0.115 //layer=m1 \
 //thickness=0.36 //x=18.325 //y=5.335 //x2=18.21 //y2=5.335
r798 (  15 24 ) resistor r=0.0698411 //w=0.17 //l=0.120208 //layer=m1 \
 //thickness=0.36 //x=18.905 //y=5.335 //x2=18.99 //y2=5.25
r799 (  15 16 ) resistor r=0.553435 //w=0.131 //l=0.58 //layer=m1 \
 //thickness=0.36 //x=18.905 //y=5.335 //x2=18.325 //y2=5.335
r800 (  14 53 ) resistor r=0.00118313 //w=0.23 //layer=m1 //thickness=0.36 \
 //x=18.21 //y=5.56 //x2=18.21 //y2=5.56
r801 (  13 51 ) resistor r=0.002872 //w=0.34 //l=0.085 //layer=m1 \
 //thickness=0.36 //x=18.21 //y=5.42 //x2=18.21 //y2=5.335
r802 (  13 14 ) resistor r=0.091623 //w=0.191 //l=0.14 //layer=m1 \
 //thickness=0.36 //x=18.21 //y=5.42 //x2=18.21 //y2=5.56
r803 (  12 48 ) resistor r=0.0262263 //w=0.232 //l=0.12 //layer=m1 \
 //thickness=0.36 //x=17.45 //y=5.335 //x2=17.33 //y2=5.335
r804 (  11 51 ) resistor r=0.0675342 //w=0.23 //l=0.115 //layer=m1 \
 //thickness=0.36 //x=18.095 //y=5.335 //x2=18.21 //y2=5.335
r805 (  11 12 ) resistor r=0.615458 //w=0.131 //l=0.645 //layer=m1 \
 //thickness=0.36 //x=18.095 //y=5.335 //x2=17.45 //y2=5.335
r806 (  10 45 ) resistor r=0.0222262 //w=0.217 //l=0.118 //layer=m1 \
 //thickness=0.36 //x=16.57 //y=5.335 //x2=16.452 //y2=5.335
r807 (  9 48 ) resistor r=0.0262263 //w=0.232 //l=0.12 //layer=m1 \
 //thickness=0.36 //x=17.21 //y=5.335 //x2=17.33 //y2=5.335
r808 (  9 10 ) resistor r=0.610687 //w=0.131 //l=0.64 //layer=m1 \
 //thickness=0.36 //x=17.21 //y=5.335 //x2=16.57 //y2=5.335
r809 (  8 44 ) resistor r=0.0801089 //w=0.224 //l=0.13 //layer=m1 \
 //thickness=0.36 //x=13.44 //y=4.75 //x2=13.44 //y2=4.88
r810 (  7 40 ) resistor r=0.0911593 //w=0.376 //l=0.184608 //layer=m1 \
 //thickness=0.36 //x=13.44 //y=4.055 //x2=13.387 //y2=3.895
r811 (  7 8 ) resistor r=0.663168 //w=0.131 //l=0.695 //layer=m1 \
 //thickness=0.36 //x=13.44 //y=4.055 //x2=13.44 //y2=4.75
r812 (  6 38 ) resistor r=0.0861726 //w=0.376 //l=0.16944 //layer=m1 \
 //thickness=0.36 //x=13.44 //y=3.735 //x2=13.387 //y2=3.88
r813 (  5 42 ) resistor r=0.0719237 //w=0.222 //l=0.115 //layer=m1 \
 //thickness=0.36 //x=13.44 //y=2.375 //x2=13.44 //y2=2.26
r814 (  5 6 ) resistor r=1.29771 //w=0.131 //l=1.36 //layer=m1 \
 //thickness=0.36 //x=13.44 //y=2.375 //x2=13.44 //y2=3.735
r815 (  4 32 ) resistor r=0.0801089 //w=0.224 //l=0.13 //layer=m1 \
 //thickness=0.36 //x=8.63 //y=4.75 //x2=8.63 //y2=4.88
r816 (  3 36 ) resistor r=0.0911593 //w=0.376 //l=0.184174 //layer=m1 \
 //thickness=0.36 //x=8.63 //y=4.055 //x2=8.682 //y2=3.895
r817 (  3 4 ) resistor r=0.663168 //w=0.131 //l=0.695 //layer=m1 \
 //thickness=0.36 //x=8.63 //y=4.055 //x2=8.63 //y2=4.75
r818 (  2 34 ) resistor r=0.0861726 //w=0.376 //l=0.169012 //layer=m1 \
 //thickness=0.36 //x=8.63 //y=3.735 //x2=8.682 //y2=3.88
r819 (  1 30 ) resistor r=0.0719237 //w=0.222 //l=0.115 //layer=m1 \
 //thickness=0.36 //x=8.63 //y=2.375 //x2=8.63 //y2=2.26
r820 (  1 2 ) resistor r=1.29771 //w=0.131 //l=1.36 //layer=m1 \
 //thickness=0.36 //x=8.63 //y=2.375 //x2=8.63 //y2=3.735
ends PM_TMRDFFSNRNQNX1\%noxref_5

subckt PM_TMRDFFSNRNQNX1\%noxref_6 ( 1 2 3 4 5 7 10 11 13 14 15 16 18 19 20 26 \
 28 31 34 40 43 44 45 47 49 57 66 71 79 87 103 104 105 109 110 111 116 118 121 \
 122 124 125 130 133 135 136 137 )
c324 ( 133 0 ) capacitor c=0.00885916f //x=27.935 //y=1.095
c325 ( 130 0 ) capacitor c=0.0693379f //x=23.06 //y=4.88
c326 ( 125 0 ) capacitor c=0.0278202f //x=23.06 //y=2.095
c327 ( 124 0 ) capacitor c=0.0479397f //x=23.06 //y=2.26
c328 ( 122 0 ) capacitor c=0.0443175f //x=23.58 //y=1.44
c329 ( 121 0 ) capacitor c=0.0199703f //x=23.58 //y=1.095
c330 ( 118 0 ) capacitor c=0.0162526f //x=23.425 //y=1.595
c331 ( 116 0 ) capacitor c=0.0157807f //x=23.425 //y=0.94
c332 ( 111 0 ) capacitor c=0.0220935f //x=23.05 //y=1.75
c333 ( 110 0 ) capacitor c=0.0207489f //x=23.05 //y=1.44
c334 ( 109 0 ) capacitor c=0.0194091f //x=23.05 //y=1.095
c335 ( 105 0 ) capacitor c=0.159306f //x=23.24 //y=6.2
c336 ( 104 0 ) capacitor c=0.110208f //x=22.8 //y=6.2
c337 ( 87 0 ) capacitor c=0.0293719f //x=27.83 //y=5.56
c338 ( 79 0 ) capacitor c=0.0292879f //x=26.95 //y=5.56
c339 ( 71 0 ) capacitor c=0.0278099f //x=26.07 //y=5.56
c340 ( 66 0 ) capacitor c=7.7417e-19 //x=23.06 //y=4.88
c341 ( 57 0 ) capacitor c=0.00101179f //x=23.06 //y=2.26
c342 ( 49 0 ) capacitor c=0.00614581f //x=28.09 //y=3.5
c343 ( 47 0 ) capacitor c=0.00512138f //x=27.485 //y=3.51
c344 ( 45 0 ) capacitor c=0.00323896f //x=26.98 //y=3.53
c345 ( 44 0 ) capacitor c=5.50259e-19 //x=23.22 //y=3.51
c346 ( 43 0 ) capacitor c=0.0352681f //x=26.375 //y=3.51
c347 ( 40 0 ) capacitor c=0.0158263f //x=28.61 //y=3.51
c348 ( 34 0 ) capacitor c=8.42472e-19 //x=27.83 //y=5.335
c349 ( 31 0 ) capacitor c=0.00753514f //x=26.95 //y=5.335
c350 ( 28 0 ) capacitor c=0.0109203f //x=26.072 //y=5.335
c351 ( 26 0 ) capacitor c=0.0166445f //x=23.06 //y=3.51
c352 ( 20 0 ) capacitor c=0.0425176f //x=28.61 //y=5.25
c353 ( 19 0 ) capacitor c=0.014234f //x=28.61 //y=3.685
c354 ( 18 0 ) capacitor c=0.0389407f //x=28.61 //y=3.365
c355 ( 16 0 ) capacitor c=0.00493487f //x=28.21 //y=1.845
c356 ( 15 0 ) capacitor c=0.0132922f //x=28.525 //y=1.845
c357 ( 14 0 ) capacitor c=0.0167992f //x=28.125 //y=1.76
c358 ( 13 0 ) capacitor c=0.0112869f //x=28.125 //y=1.305
c359 ( 11 0 ) capacitor c=0.0213481f //x=28.525 //y=5.335
c360 ( 10 0 ) capacitor c=0.00933983f //x=27.83 //y=5.56
c361 ( 7 0 ) capacitor c=0.0177111f //x=27.715 //y=5.335
c362 ( 5 0 ) capacitor c=0.0143796f //x=26.83 //y=5.335
c363 ( 4 0 ) capacitor c=0.0305793f //x=23.06 //y=4.75
c364 ( 3 0 ) capacitor c=0.0121604f //x=23.06 //y=3.655
c365 ( 2 0 ) capacitor c=0.0220277f //x=23.06 //y=3.365
c366 ( 1 0 ) capacitor c=0.00554887f //x=23.06 //y=2.375
r367 (  124 125 ) resistor r=52.7279 //w=0.214 //l=0.165 //layer=ply \
 //thickness=0.18 //x=23.06 //y=2.26 //x2=23.06 //y2=2.095
r368 (  122 132 ) resistor r=45.1352 //w=0.168 //l=0.173853 //layer=ply \
 //thickness=0.18 //x=23.58 //y=1.44 //x2=23.54 //y2=1.595
r369 (  121 131 ) resistor r=45.1352 //w=0.168 //l=0.173853 //layer=ply \
 //thickness=0.18 //x=23.58 //y=1.095 //x2=23.54 //y2=0.94
r370 (  121 122 ) resistor r=176.904 //w=0.094 //l=0.345 //layer=ply \
 //thickness=0.18 //x=23.58 //y=1.095 //x2=23.58 //y2=1.44
r371 (  119 128 ) resistor r=10.701 //w=0.21 //l=0.115 //layer=ply \
 //thickness=0.18 //x=23.205 //y=1.595 //x2=23.09 //y2=1.595
r372 (  118 132 ) resistor r=5.52526 //w=0.168 //l=0.115 //layer=ply \
 //thickness=0.18 //x=23.425 //y=1.595 //x2=23.54 //y2=1.595
r373 (  117 127 ) resistor r=5.52526 //w=0.168 //l=0.115 //layer=ply \
 //thickness=0.18 //x=23.205 //y=0.94 //x2=23.09 //y2=0.94
r374 (  116 131 ) resistor r=5.52526 //w=0.168 //l=0.115 //layer=ply \
 //thickness=0.18 //x=23.425 //y=0.94 //x2=23.54 //y2=0.94
r375 (  116 117 ) resistor r=112.809 //w=0.094 //l=0.22 //layer=ply \
 //thickness=0.18 //x=23.425 //y=0.94 //x2=23.205 //y2=0.94
r376 (  113 130 ) resistor r=37.236 //w=0.233 //l=0.249199 //layer=ply \
 //thickness=0.18 //x=23.24 //y=5.045 //x2=23.06 //y2=4.88
r377 (  111 128 ) resistor r=39.5823 //w=0.21 //l=0.173853 //layer=ply \
 //thickness=0.18 //x=23.05 //y=1.75 //x2=23.09 //y2=1.595
r378 (  111 125 ) resistor r=176.904 //w=0.094 //l=0.345 //layer=ply \
 //thickness=0.18 //x=23.05 //y=1.75 //x2=23.05 //y2=2.095
r379 (  110 128 ) resistor r=39.5823 //w=0.21 //l=0.173853 //layer=ply \
 //thickness=0.18 //x=23.05 //y=1.44 //x2=23.09 //y2=1.595
r380 (  109 127 ) resistor r=45.1352 //w=0.168 //l=0.173853 //layer=ply \
 //thickness=0.18 //x=23.05 //y=1.095 //x2=23.09 //y2=0.94
r381 (  109 110 ) resistor r=176.904 //w=0.094 //l=0.345 //layer=ply \
 //thickness=0.18 //x=23.05 //y=1.095 //x2=23.05 //y2=1.44
r382 (  106 130 ) resistor r=53.7854 //w=0.233 //l=0.332415 //layer=ply \
 //thickness=0.18 //x=22.8 //y=5.045 //x2=23.06 //y2=4.88
r383 (  105 113 ) resistor r=592.245 //w=0.094 //l=1.155 //layer=ply \
 //thickness=0.18 //x=23.24 //y=6.2 //x2=23.24 //y2=5.045
r384 (  104 106 ) resistor r=592.245 //w=0.094 //l=1.155 //layer=ply \
 //thickness=0.18 //x=22.8 //y=6.2 //x2=22.8 //y2=5.045
r385 (  103 118 ) resistor r=56.4043 //w=0.094 //l=0.11 //layer=ply \
 //thickness=0.18 //x=23.315 //y=1.595 //x2=23.425 //y2=1.595
r386 (  103 119 ) resistor r=56.4043 //w=0.094 //l=0.11 //layer=ply \
 //thickness=0.18 //x=23.315 //y=1.595 //x2=23.205 //y2=1.595
r387 (  87 137 ) resistor r=23.615 //w=0.187 //l=0.345 //layer=li \
 //thickness=0.1 //x=27.83 //y=5.56 //x2=27.83 //y2=5.905
r388 (  79 136 ) resistor r=23.615 //w=0.187 //l=0.345 //layer=li \
 //thickness=0.1 //x=26.95 //y=5.56 //x2=26.95 //y2=5.905
r389 (  71 135 ) resistor r=23.615 //w=0.187 //l=0.345 //layer=li \
 //thickness=0.1 //x=26.07 //y=5.56 //x2=26.07 //y2=5.905
r390 (  66 130 ) resistor r=152 //w=0.17 //l=0.17 //layer=licon //count=1 \
 //x=23.06 //y=4.88 //x2=23.06 //y2=4.88
r391 (  57 124 ) resistor r=152 //w=0.17 //l=0.17 //layer=licon //count=1 \
 //x=23.06 //y=2.26 //x2=23.06 //y2=2.26
r392 (  49 55 ) resistor r=0.293022 //w=0.239 //l=0.552359 //layer=m2 \
 //thickness=0.36 //x=28.09 //y=3.5 //x2=28.63 //y2=3.525
r393 (  49 50 ) resistor r=0.415076 //w=0.131 //l=0.435 //layer=m2 \
 //thickness=0.36 //x=28.09 //y=3.5 //x2=27.655 //y2=3.5
r394 (  47 50 ) resistor r=0.125 //w=0.17 //l=0.174929 //layer=m2 \
 //thickness=0.36 //x=27.485 //y=3.51 //x2=27.655 //y2=3.5
r395 (  47 48 ) resistor r=0.319656 //w=0.131 //l=0.335 //layer=m2 \
 //thickness=0.36 //x=27.485 //y=3.51 //x2=27.15 //y2=3.51
r396 (  45 48 ) resistor r=0.125 //w=0.17 //l=0.179722 //layer=m2 \
 //thickness=0.36 //x=26.98 //y=3.53 //x2=27.15 //y2=3.51
r397 (  45 46 ) resistor r=0.333969 //w=0.131 //l=0.35 //layer=m2 \
 //thickness=0.36 //x=26.98 //y=3.53 //x2=26.63 //y2=3.53
r398 (  44 52 ) resistor r=0.108362 //w=0.251 //l=0.16 //layer=m2 \
 //thickness=0.36 //x=23.22 //y=3.51 //x2=23.06 //y2=3.51
r399 (  43 46 ) resistor r=0.1875 //w=0.17 //l=0.264811 //layer=m2 \
 //thickness=0.36 //x=26.375 //y=3.51 //x2=26.63 //y2=3.53
r400 (  43 44 ) resistor r=3.0105 //w=0.131 //l=3.155 //layer=m2 \
 //thickness=0.36 //x=26.375 //y=3.51 //x2=23.22 //y2=3.51
r401 (  42 55 ) resistor r=4.5 //w=0.15 //l=0.15 //layer=via1 //count=1 \
 //x=28.63 //y=3.525 //x2=28.63 //y2=3.525
r402 (  40 42 ) resistor r=0.00484496 //w=0.387 //l=0.015 //layer=m1 \
 //thickness=0.36 //x=28.567 //y=3.51 //x2=28.567 //y2=3.525
r403 (  38 133 ) resistor r=9.3 //w=0.17 //l=0.17 //layer=mcon //count=1 \
 //x=28.125 //y=1.19 //x2=28.125 //y2=1.19
r404 (  36 87 ) resistor r=9.3 //w=0.17 //l=0.17 //layer=mcon //count=1 \
 //x=27.83 //y=5.56 //x2=27.83 //y2=5.56
r405 (  33 79 ) resistor r=9.3 //w=0.17 //l=0.17 //layer=mcon //count=1 \
 //x=26.95 //y=5.56 //x2=26.95 //y2=5.56
r406 (  31 33 ) resistor r=0.121228 //w=0.232 //l=0.225 //layer=m1 \
 //thickness=0.36 //x=26.95 //y=5.335 //x2=26.95 //y2=5.56
r407 (  30 71 ) resistor r=9.3 //w=0.17 //l=0.17 //layer=mcon //count=1 \
 //x=26.07 //y=5.56 //x2=26.07 //y2=5.56
r408 (  28 30 ) resistor r=0.129608 //w=0.217 //l=0.225 //layer=m1 \
 //thickness=0.36 //x=26.072 //y=5.335 //x2=26.072 //y2=5.56
r409 (  26 52 ) resistor r=4.5 //w=0.15 //l=0.15 //layer=via1 //count=1 \
 //x=23.06 //y=3.51 //x2=23.06 //y2=3.51
r410 (  24 66 ) resistor r=9.3 //w=0.17 //l=0.17 //layer=mcon //count=1 \
 //x=23.06 //y=4.88 //x2=23.06 //y2=4.88
r411 (  22 57 ) resistor r=9.3 //w=0.17 //l=0.17 //layer=mcon //count=1 \
 //x=23.06 //y=2.26 //x2=23.06 //y2=2.26
r412 (  19 42 ) resistor r=0.091625 //w=0.387 //l=0.180222 //layer=m1 \
 //thickness=0.36 //x=28.61 //y=3.685 //x2=28.567 //y2=3.525
r413 (  19 20 ) resistor r=1.49332 //w=0.131 //l=1.565 //layer=m1 \
 //thickness=0.36 //x=28.61 //y=3.685 //x2=28.61 //y2=5.25
r414 (  18 40 ) resistor r=0.08678 //w=0.387 //l=0.165106 //layer=m1 \
 //thickness=0.36 //x=28.61 //y=3.365 //x2=28.567 //y2=3.51
r415 (  17 18 ) resistor r=1.36927 //w=0.131 //l=1.435 //layer=m1 \
 //thickness=0.36 //x=28.61 //y=1.93 //x2=28.61 //y2=3.365
r416 (  15 17 ) resistor r=0.0698411 //w=0.17 //l=0.120208 //layer=m1 \
 //thickness=0.36 //x=28.525 //y=1.845 //x2=28.61 //y2=1.93
r417 (  15 16 ) resistor r=0.300573 //w=0.131 //l=0.315 //layer=m1 \
 //thickness=0.36 //x=28.525 //y=1.845 //x2=28.21 //y2=1.845
r418 (  14 16 ) resistor r=0.0698411 //w=0.17 //l=0.120208 //layer=m1 \
 //thickness=0.36 //x=28.125 //y=1.76 //x2=28.21 //y2=1.845
r419 (  13 38 ) resistor r=0.0717383 //w=0.224 //l=0.115 //layer=m1 \
 //thickness=0.36 //x=28.125 //y=1.305 //x2=28.125 //y2=1.19
r420 (  13 14 ) resistor r=0.43416 //w=0.131 //l=0.455 //layer=m1 \
 //thickness=0.36 //x=28.125 //y=1.305 //x2=28.125 //y2=1.76
r421 (  12 34 ) resistor r=0.0675342 //w=0.23 //l=0.115 //layer=m1 \
 //thickness=0.36 //x=27.945 //y=5.335 //x2=27.83 //y2=5.335
r422 (  11 20 ) resistor r=0.0698411 //w=0.17 //l=0.120208 //layer=m1 \
 //thickness=0.36 //x=28.525 //y=5.335 //x2=28.61 //y2=5.25
r423 (  11 12 ) resistor r=0.553435 //w=0.131 //l=0.58 //layer=m1 \
 //thickness=0.36 //x=28.525 //y=5.335 //x2=27.945 //y2=5.335
r424 (  10 36 ) resistor r=0.00118313 //w=0.23 //layer=m1 //thickness=0.36 \
 //x=27.83 //y=5.56 //x2=27.83 //y2=5.56
r425 (  9 34 ) resistor r=0.002872 //w=0.34 //l=0.085 //layer=m1 \
 //thickness=0.36 //x=27.83 //y=5.42 //x2=27.83 //y2=5.335
r426 (  9 10 ) resistor r=0.091623 //w=0.191 //l=0.14 //layer=m1 \
 //thickness=0.36 //x=27.83 //y=5.42 //x2=27.83 //y2=5.56
r427 (  8 31 ) resistor r=0.0262263 //w=0.232 //l=0.12 //layer=m1 \
 //thickness=0.36 //x=27.07 //y=5.335 //x2=26.95 //y2=5.335
r428 (  7 34 ) resistor r=0.0675342 //w=0.23 //l=0.115 //layer=m1 \
 //thickness=0.36 //x=27.715 //y=5.335 //x2=27.83 //y2=5.335
r429 (  7 8 ) resistor r=0.615458 //w=0.131 //l=0.645 //layer=m1 \
 //thickness=0.36 //x=27.715 //y=5.335 //x2=27.07 //y2=5.335
r430 (  6 28 ) resistor r=0.0222262 //w=0.217 //l=0.118 //layer=m1 \
 //thickness=0.36 //x=26.19 //y=5.335 //x2=26.072 //y2=5.335
r431 (  5 31 ) resistor r=0.0262263 //w=0.232 //l=0.12 //layer=m1 \
 //thickness=0.36 //x=26.83 //y=5.335 //x2=26.95 //y2=5.335
r432 (  5 6 ) resistor r=0.610687 //w=0.131 //l=0.64 //layer=m1 \
 //thickness=0.36 //x=26.83 //y=5.335 //x2=26.19 //y2=5.335
r433 (  4 24 ) resistor r=0.0801089 //w=0.224 //l=0.13 //layer=m1 \
 //thickness=0.36 //x=23.06 //y=4.75 //x2=23.06 //y2=4.88
r434 (  3 26 ) resistor r=0.0864989 //w=0.382 //l=0.169012 //layer=m1 \
 //thickness=0.36 //x=23.06 //y=3.655 //x2=23.112 //y2=3.51
r435 (  3 4 ) resistor r=1.04485 //w=0.131 //l=1.095 //layer=m1 \
 //thickness=0.36 //x=23.06 //y=3.655 //x2=23.06 //y2=4.75
r436 (  2 26 ) resistor r=0.0864989 //w=0.382 //l=0.169012 //layer=m1 \
 //thickness=0.36 //x=23.06 //y=3.365 //x2=23.112 //y2=3.51
r437 (  1 22 ) resistor r=0.0719237 //w=0.222 //l=0.115 //layer=m1 \
 //thickness=0.36 //x=23.06 //y=2.375 //x2=23.06 //y2=2.26
r438 (  1 2 ) resistor r=0.944656 //w=0.131 //l=0.99 //layer=m1 \
 //thickness=0.36 //x=23.06 //y=2.375 //x2=23.06 //y2=3.365
ends PM_TMRDFFSNRNQNX1\%noxref_6

subckt PM_TMRDFFSNRNQNX1\%noxref_7 ( 1 3 6 7 9 10 11 12 14 15 16 17 18 19 20 \
 21 22 23 24 25 28 31 37 45 49 63 66 67 69 70 73 81 89 106 115 120 129 133 134 \
 135 136 137 138 139 140 141 142 143 145 151 152 153 154 158 159 160 161 162 \
 164 170 171 172 173 193 195 196 197 )
c440 ( 193 0 ) capacitor c=0.00885916f //x=32.745 //y=1.095
c441 ( 173 0 ) capacitor c=0.0612936f //x=40.355 //y=4.97
c442 ( 172 0 ) capacitor c=0.0376642f //x=40.645 //y=4.97
c443 ( 171 0 ) capacitor c=0.0346489f //x=40.31 //y=1.4
c444 ( 170 0 ) capacitor c=0.018692f //x=40.31 //y=1.055
c445 ( 164 0 ) capacitor c=0.0137077f //x=40.155 //y=1.555
c446 ( 162 0 ) capacitor c=0.0158585f //x=40.155 //y=0.9
c447 ( 161 0 ) capacitor c=0.0979536f //x=39.78 //y=2.095
c448 ( 160 0 ) capacitor c=0.0229444f //x=39.78 //y=1.71
c449 ( 159 0 ) capacitor c=0.0234359f //x=39.78 //y=1.4
c450 ( 158 0 ) capacitor c=0.019815f //x=39.78 //y=1.055
c451 ( 154 0 ) capacitor c=0.0614625f //x=35.545 //y=4.97
c452 ( 153 0 ) capacitor c=0.0376642f //x=35.835 //y=4.97
c453 ( 152 0 ) capacitor c=0.0346489f //x=35.5 //y=1.4
c454 ( 151 0 ) capacitor c=0.018692f //x=35.5 //y=1.055
c455 ( 145 0 ) capacitor c=0.0137077f //x=35.345 //y=1.555
c456 ( 143 0 ) capacitor c=0.0158585f //x=35.345 //y=0.9
c457 ( 142 0 ) capacitor c=0.0996161f //x=34.97 //y=2.095
c458 ( 141 0 ) capacitor c=0.0229444f //x=34.97 //y=1.71
c459 ( 140 0 ) capacitor c=0.0234359f //x=34.97 //y=1.4
c460 ( 139 0 ) capacitor c=0.019815f //x=34.97 //y=1.055
c461 ( 138 0 ) capacitor c=0.110218f //x=40.72 //y=6.2
c462 ( 137 0 ) capacitor c=0.158957f //x=40.28 //y=6.2
c463 ( 136 0 ) capacitor c=0.110223f //x=35.91 //y=6.2
c464 ( 135 0 ) capacitor c=0.158957f //x=35.47 //y=6.2
c465 ( 129 0 ) capacitor c=0.0014751f //x=40.08 //y=4.88
c466 ( 120 0 ) capacitor c=9.93222e-19 //x=40.08 //y=2.26
c467 ( 115 0 ) capacitor c=0.00157967f //x=35.27 //y=4.88
c468 ( 106 0 ) capacitor c=9.93222e-19 //x=35.27 //y=2.26
c469 ( 89 0 ) capacitor c=0.0293562f //x=32.64 //y=5.56
c470 ( 81 0 ) capacitor c=0.029137f //x=31.76 //y=5.56
c471 ( 73 0 ) capacitor c=0.0278099f //x=30.88 //y=5.56
c472 ( 70 0 ) capacitor c=0.0393671f //x=39.92 //y=2.785
c473 ( 69 0 ) capacitor c=6.54212e-19 //x=40.08 //y=2.785
c474 ( 67 0 ) capacitor c=5.7546e-19 //x=35.435 //y=2.785
c475 ( 66 0 ) capacitor c=0.0167579f //x=35.115 //y=2.785
c476 ( 63 0 ) capacitor c=9.56892e-19 //x=33.585 //y=2.785
c477 ( 49 0 ) capacitor c=0.0154699f //x=40.08 //y=2.77
c478 ( 45 0 ) capacitor c=0.0148628f //x=35.27 //y=2.77
c479 ( 37 0 ) capacitor c=0.0144706f //x=33.42 //y=2.77
c480 ( 31 0 ) capacitor c=9.37498e-19 //x=32.64 //y=5.335
c481 ( 28 0 ) capacitor c=0.0076134f //x=31.76 //y=5.335
c482 ( 25 0 ) capacitor c=0.0109203f //x=30.882 //y=5.335
c483 ( 24 0 ) capacitor c=0.0580371f //x=40.08 //y=4.755
c484 ( 23 0 ) capacitor c=0.0131951f //x=40.08 //y=2.945
c485 ( 22 0 ) capacitor c=0.00473602f //x=40.08 //y=2.625
c486 ( 21 0 ) capacitor c=0.00495287f //x=40.08 //y=2.375
c487 ( 20 0 ) capacitor c=0.060164f //x=35.27 //y=4.755
c488 ( 19 0 ) capacitor c=0.0129478f //x=35.27 //y=2.945
c489 ( 18 0 ) capacitor c=0.00482124f //x=35.27 //y=2.625
c490 ( 17 0 ) capacitor c=0.00495287f //x=35.27 //y=2.375
c491 ( 16 0 ) capacitor c=0.0657499f //x=33.42 //y=5.25
c492 ( 15 0 ) capacitor c=0.0123004f //x=33.42 //y=2.945
c493 ( 14 0 ) capacitor c=0.0179579f //x=33.42 //y=2.625
c494 ( 12 0 ) capacitor c=0.0047266f //x=33.02 //y=1.845
c495 ( 11 0 ) capacitor c=0.0129788f //x=33.335 //y=1.845
c496 ( 10 0 ) capacitor c=0.0167992f //x=32.935 //y=1.76
c497 ( 9 0 ) capacitor c=0.0110957f //x=32.935 //y=1.305
c498 ( 7 0 ) capacitor c=0.0202877f //x=33.335 //y=5.335
c499 ( 6 0 ) capacitor c=0.00933983f //x=32.64 //y=5.56
c500 ( 3 0 ) capacitor c=0.0192055f //x=32.525 //y=5.335
c501 ( 1 0 ) capacitor c=0.0149267f //x=31.64 //y=5.335
r502 (  172 174 ) resistor r=26.9307 //w=0.15 //l=0.106066 //layer=ply \
 //thickness=0.18 //x=40.645 //y=4.97 //x2=40.72 //y2=5.045
r503 (  172 173 ) resistor r=148.702 //w=0.094 //l=0.29 //layer=ply \
 //thickness=0.18 //x=40.645 //y=4.97 //x2=40.355 //y2=4.97
r504 (  171 192 ) resistor r=45.1352 //w=0.168 //l=0.173853 //layer=ply \
 //thickness=0.18 //x=40.31 //y=1.4 //x2=40.27 //y2=1.555
r505 (  170 191 ) resistor r=45.1352 //w=0.168 //l=0.173853 //layer=ply \
 //thickness=0.18 //x=40.31 //y=1.055 //x2=40.27 //y2=0.9
r506 (  170 171 ) resistor r=176.904 //w=0.094 //l=0.345 //layer=ply \
 //thickness=0.18 //x=40.31 //y=1.055 //x2=40.31 //y2=1.4
r507 (  167 173 ) resistor r=22.7971 //w=0.269 //l=0.106066 //layer=ply \
 //thickness=0.18 //x=40.28 //y=5.045 //x2=40.355 //y2=4.97
r508 (  167 190 ) resistor r=35.8364 //w=0.269 //l=0.270185 //layer=ply \
 //thickness=0.18 //x=40.28 //y=5.045 //x2=40.08 //y2=4.88
r509 (  165 186 ) resistor r=10.701 //w=0.21 //l=0.115 //layer=ply \
 //thickness=0.18 //x=39.935 //y=1.555 //x2=39.82 //y2=1.555
r510 (  164 192 ) resistor r=5.52526 //w=0.168 //l=0.115 //layer=ply \
 //thickness=0.18 //x=40.155 //y=1.555 //x2=40.27 //y2=1.555
r511 (  163 185 ) resistor r=5.52526 //w=0.168 //l=0.115 //layer=ply \
 //thickness=0.18 //x=39.935 //y=0.9 //x2=39.82 //y2=0.9
r512 (  162 191 ) resistor r=5.52526 //w=0.168 //l=0.115 //layer=ply \
 //thickness=0.18 //x=40.155 //y=0.9 //x2=40.27 //y2=0.9
r513 (  162 163 ) resistor r=112.809 //w=0.094 //l=0.22 //layer=ply \
 //thickness=0.18 //x=40.155 //y=0.9 //x2=39.935 //y2=0.9
r514 (  161 188 ) resistor r=58.7805 //w=0.246 //l=0.373497 //layer=ply \
 //thickness=0.18 //x=39.78 //y=2.095 //x2=40.08 //y2=2.26
r515 (  160 186 ) resistor r=39.5823 //w=0.21 //l=0.173853 //layer=ply \
 //thickness=0.18 //x=39.78 //y=1.71 //x2=39.82 //y2=1.555
r516 (  160 161 ) resistor r=197.415 //w=0.094 //l=0.385 //layer=ply \
 //thickness=0.18 //x=39.78 //y=1.71 //x2=39.78 //y2=2.095
r517 (  159 186 ) resistor r=39.5823 //w=0.21 //l=0.173853 //layer=ply \
 //thickness=0.18 //x=39.78 //y=1.4 //x2=39.82 //y2=1.555
r518 (  158 185 ) resistor r=45.1352 //w=0.168 //l=0.173853 //layer=ply \
 //thickness=0.18 //x=39.78 //y=1.055 //x2=39.82 //y2=0.9
r519 (  158 159 ) resistor r=176.904 //w=0.094 //l=0.345 //layer=ply \
 //thickness=0.18 //x=39.78 //y=1.055 //x2=39.78 //y2=1.4
r520 (  153 155 ) resistor r=26.9307 //w=0.15 //l=0.106066 //layer=ply \
 //thickness=0.18 //x=35.835 //y=4.97 //x2=35.91 //y2=5.045
r521 (  153 154 ) resistor r=148.702 //w=0.094 //l=0.29 //layer=ply \
 //thickness=0.18 //x=35.835 //y=4.97 //x2=35.545 //y2=4.97
r522 (  152 184 ) resistor r=45.1352 //w=0.168 //l=0.173853 //layer=ply \
 //thickness=0.18 //x=35.5 //y=1.4 //x2=35.46 //y2=1.555
r523 (  151 183 ) resistor r=45.1352 //w=0.168 //l=0.173853 //layer=ply \
 //thickness=0.18 //x=35.5 //y=1.055 //x2=35.46 //y2=0.9
r524 (  151 152 ) resistor r=176.904 //w=0.094 //l=0.345 //layer=ply \
 //thickness=0.18 //x=35.5 //y=1.055 //x2=35.5 //y2=1.4
r525 (  148 154 ) resistor r=22.7971 //w=0.269 //l=0.106066 //layer=ply \
 //thickness=0.18 //x=35.47 //y=5.045 //x2=35.545 //y2=4.97
r526 (  148 182 ) resistor r=35.8364 //w=0.269 //l=0.270185 //layer=ply \
 //thickness=0.18 //x=35.47 //y=5.045 //x2=35.27 //y2=4.88
r527 (  146 178 ) resistor r=10.701 //w=0.21 //l=0.115 //layer=ply \
 //thickness=0.18 //x=35.125 //y=1.555 //x2=35.01 //y2=1.555
r528 (  145 184 ) resistor r=5.52526 //w=0.168 //l=0.115 //layer=ply \
 //thickness=0.18 //x=35.345 //y=1.555 //x2=35.46 //y2=1.555
r529 (  144 177 ) resistor r=5.52526 //w=0.168 //l=0.115 //layer=ply \
 //thickness=0.18 //x=35.125 //y=0.9 //x2=35.01 //y2=0.9
r530 (  143 183 ) resistor r=5.52526 //w=0.168 //l=0.115 //layer=ply \
 //thickness=0.18 //x=35.345 //y=0.9 //x2=35.46 //y2=0.9
r531 (  143 144 ) resistor r=112.809 //w=0.094 //l=0.22 //layer=ply \
 //thickness=0.18 //x=35.345 //y=0.9 //x2=35.125 //y2=0.9
r532 (  142 180 ) resistor r=58.7805 //w=0.246 //l=0.373497 //layer=ply \
 //thickness=0.18 //x=34.97 //y=2.095 //x2=35.27 //y2=2.26
r533 (  141 178 ) resistor r=39.5823 //w=0.21 //l=0.173853 //layer=ply \
 //thickness=0.18 //x=34.97 //y=1.71 //x2=35.01 //y2=1.555
r534 (  141 142 ) resistor r=197.415 //w=0.094 //l=0.385 //layer=ply \
 //thickness=0.18 //x=34.97 //y=1.71 //x2=34.97 //y2=2.095
r535 (  140 178 ) resistor r=39.5823 //w=0.21 //l=0.173853 //layer=ply \
 //thickness=0.18 //x=34.97 //y=1.4 //x2=35.01 //y2=1.555
r536 (  139 177 ) resistor r=45.1352 //w=0.168 //l=0.173853 //layer=ply \
 //thickness=0.18 //x=34.97 //y=1.055 //x2=35.01 //y2=0.9
r537 (  139 140 ) resistor r=176.904 //w=0.094 //l=0.345 //layer=ply \
 //thickness=0.18 //x=34.97 //y=1.055 //x2=34.97 //y2=1.4
r538 (  138 174 ) resistor r=592.245 //w=0.094 //l=1.155 //layer=ply \
 //thickness=0.18 //x=40.72 //y=6.2 //x2=40.72 //y2=5.045
r539 (  137 167 ) resistor r=592.245 //w=0.094 //l=1.155 //layer=ply \
 //thickness=0.18 //x=40.28 //y=6.2 //x2=40.28 //y2=5.045
r540 (  136 155 ) resistor r=592.245 //w=0.094 //l=1.155 //layer=ply \
 //thickness=0.18 //x=35.91 //y=6.2 //x2=35.91 //y2=5.045
r541 (  135 148 ) resistor r=592.245 //w=0.094 //l=1.155 //layer=ply \
 //thickness=0.18 //x=35.47 //y=6.2 //x2=35.47 //y2=5.045
r542 (  134 164 ) resistor r=56.4043 //w=0.094 //l=0.11 //layer=ply \
 //thickness=0.18 //x=40.045 //y=1.555 //x2=40.155 //y2=1.555
r543 (  134 165 ) resistor r=56.4043 //w=0.094 //l=0.11 //layer=ply \
 //thickness=0.18 //x=40.045 //y=1.555 //x2=39.935 //y2=1.555
r544 (  133 145 ) resistor r=56.4043 //w=0.094 //l=0.11 //layer=ply \
 //thickness=0.18 //x=35.235 //y=1.555 //x2=35.345 //y2=1.555
r545 (  133 146 ) resistor r=56.4043 //w=0.094 //l=0.11 //layer=ply \
 //thickness=0.18 //x=35.235 //y=1.555 //x2=35.125 //y2=1.555
r546 (  129 190 ) resistor r=152 //w=0.17 //l=0.17 //layer=licon //count=1 \
 //x=40.08 //y=4.88 //x2=40.08 //y2=4.88
r547 (  120 188 ) resistor r=152 //w=0.17 //l=0.17 //layer=licon //count=1 \
 //x=40.08 //y=2.26 //x2=40.08 //y2=2.26
r548 (  115 182 ) resistor r=152 //w=0.17 //l=0.17 //layer=licon //count=1 \
 //x=35.27 //y=4.88 //x2=35.27 //y2=4.88
r549 (  106 180 ) resistor r=152 //w=0.17 //l=0.17 //layer=licon //count=1 \
 //x=35.27 //y=2.26 //x2=35.27 //y2=2.26
r550 (  89 197 ) resistor r=23.615 //w=0.187 //l=0.345 //layer=li \
 //thickness=0.1 //x=32.64 //y=5.56 //x2=32.64 //y2=5.905
r551 (  81 196 ) resistor r=23.615 //w=0.187 //l=0.345 //layer=li \
 //thickness=0.1 //x=31.76 //y=5.56 //x2=31.76 //y2=5.905
r552 (  73 195 ) resistor r=23.615 //w=0.187 //l=0.345 //layer=li \
 //thickness=0.1 //x=30.88 //y=5.56 //x2=30.88 //y2=5.905
r553 (  69 70 ) resistor r=0.10734 //w=0.281 //l=0.16 //layer=m2 \
 //thickness=0.36 //x=40.08 //y=2.785 //x2=39.92 //y2=2.785
r554 (  67 70 ) resistor r=4.27958 //w=0.131 //l=4.485 //layer=m2 \
 //thickness=0.36 //x=35.435 //y=2.77 //x2=39.92 //y2=2.77
r555 (  65 67 ) resistor r=0.10734 //w=0.281 //l=0.16 //layer=m2 \
 //thickness=0.36 //x=35.275 //y=2.785 //x2=35.435 //y2=2.785
r556 (  65 66 ) resistor r=0.10734 //w=0.281 //l=0.16 //layer=m2 \
 //thickness=0.36 //x=35.275 //y=2.785 //x2=35.115 //y2=2.785
r557 (  63 66 ) resistor r=1.45992 //w=0.131 //l=1.53 //layer=m2 \
 //thickness=0.36 //x=33.585 //y=2.77 //x2=35.115 //y2=2.77
r558 (  61 63 ) resistor r=0.10734 //w=0.281 //l=0.16 //layer=m2 \
 //thickness=0.36 //x=33.425 //y=2.785 //x2=33.585 //y2=2.785
r559 (  55 129 ) resistor r=9.3 //w=0.17 //l=0.17 //layer=mcon //count=1 \
 //x=40.08 //y=4.88 //x2=40.08 //y2=4.88
r560 (  53 120 ) resistor r=9.3 //w=0.17 //l=0.17 //layer=mcon //count=1 \
 //x=40.08 //y=2.26 //x2=40.08 //y2=2.26
r561 (  51 69 ) resistor r=4.5 //w=0.15 //l=0.15 //layer=via1 //count=1 \
 //x=40.08 //y=2.785 //x2=40.08 //y2=2.785
r562 (  49 51 ) resistor r=0.0049867 //w=0.376 //l=0.015 //layer=m1 \
 //thickness=0.36 //x=40.027 //y=2.77 //x2=40.027 //y2=2.785
r563 (  47 65 ) resistor r=4.5 //w=0.15 //l=0.15 //layer=via1 //count=1 \
 //x=35.275 //y=2.785 //x2=35.275 //y2=2.785
r564 (  45 47 ) resistor r=0.00501337 //w=0.374 //l=0.015 //layer=m1 \
 //thickness=0.36 //x=35.325 //y=2.77 //x2=35.325 //y2=2.785
r565 (  43 115 ) resistor r=9.3 //w=0.17 //l=0.17 //layer=mcon //count=1 \
 //x=35.27 //y=4.88 //x2=35.27 //y2=4.88
r566 (  41 106 ) resistor r=9.3 //w=0.17 //l=0.17 //layer=mcon //count=1 \
 //x=35.27 //y=2.26 //x2=35.27 //y2=2.26
r567 (  39 61 ) resistor r=4.5 //w=0.15 //l=0.15 //layer=via1 //count=1 \
 //x=33.425 //y=2.785 //x2=33.425 //y2=2.785
r568 (  37 39 ) resistor r=0.00501337 //w=0.374 //l=0.015 //layer=m1 \
 //thickness=0.36 //x=33.475 //y=2.77 //x2=33.475 //y2=2.785
r569 (  35 193 ) resistor r=9.3 //w=0.17 //l=0.17 //layer=mcon //count=1 \
 //x=32.935 //y=1.19 //x2=32.935 //y2=1.19
r570 (  33 89 ) resistor r=9.3 //w=0.17 //l=0.17 //layer=mcon //count=1 \
 //x=32.64 //y=5.56 //x2=32.64 //y2=5.56
r571 (  30 81 ) resistor r=9.3 //w=0.17 //l=0.17 //layer=mcon //count=1 \
 //x=31.76 //y=5.56 //x2=31.76 //y2=5.56
r572 (  28 30 ) resistor r=0.121228 //w=0.232 //l=0.225 //layer=m1 \
 //thickness=0.36 //x=31.76 //y=5.335 //x2=31.76 //y2=5.56
r573 (  27 73 ) resistor r=9.3 //w=0.17 //l=0.17 //layer=mcon //count=1 \
 //x=30.88 //y=5.56 //x2=30.88 //y2=5.56
r574 (  25 27 ) resistor r=0.129608 //w=0.217 //l=0.225 //layer=m1 \
 //thickness=0.36 //x=30.882 //y=5.335 //x2=30.882 //y2=5.56
r575 (  24 55 ) resistor r=0.0760407 //w=0.238 //l=0.125 //layer=m1 \
 //thickness=0.36 //x=40.08 //y=4.755 //x2=40.08 //y2=4.88
r576 (  23 51 ) resistor r=0.0911593 //w=0.376 //l=0.184608 //layer=m1 \
 //thickness=0.36 //x=40.08 //y=2.945 //x2=40.027 //y2=2.785
r577 (  23 24 ) resistor r=1.7271 //w=0.131 //l=1.81 //layer=m1 \
 //thickness=0.36 //x=40.08 //y=2.945 //x2=40.08 //y2=4.755
r578 (  22 49 ) resistor r=0.0861726 //w=0.376 //l=0.16944 //layer=m1 \
 //thickness=0.36 //x=40.08 //y=2.625 //x2=40.027 //y2=2.77
r579 (  21 53 ) resistor r=0.0719237 //w=0.222 //l=0.115 //layer=m1 \
 //thickness=0.36 //x=40.08 //y=2.375 //x2=40.08 //y2=2.26
r580 (  21 22 ) resistor r=0.23855 //w=0.131 //l=0.25 //layer=m1 \
 //thickness=0.36 //x=40.08 //y=2.375 //x2=40.08 //y2=2.625
r581 (  20 43 ) resistor r=0.0760407 //w=0.238 //l=0.125 //layer=m1 \
 //thickness=0.36 //x=35.27 //y=4.755 //x2=35.27 //y2=4.88
r582 (  19 47 ) resistor r=0.0910802 //w=0.374 //l=0.185472 //layer=m1 \
 //thickness=0.36 //x=35.27 //y=2.945 //x2=35.325 //y2=2.785
r583 (  19 20 ) resistor r=1.7271 //w=0.131 //l=1.81 //layer=m1 \
 //thickness=0.36 //x=35.27 //y=2.945 //x2=35.27 //y2=4.755
r584 (  18 45 ) resistor r=0.0860668 //w=0.374 //l=0.170294 //layer=m1 \
 //thickness=0.36 //x=35.27 //y=2.625 //x2=35.325 //y2=2.77
r585 (  17 41 ) resistor r=0.0719237 //w=0.222 //l=0.115 //layer=m1 \
 //thickness=0.36 //x=35.27 //y=2.375 //x2=35.27 //y2=2.26
r586 (  17 18 ) resistor r=0.23855 //w=0.131 //l=0.25 //layer=m1 \
 //thickness=0.36 //x=35.27 //y=2.375 //x2=35.27 //y2=2.625
r587 (  15 39 ) resistor r=0.0910802 //w=0.374 //l=0.185472 //layer=m1 \
 //thickness=0.36 //x=33.42 //y=2.945 //x2=33.475 //y2=2.785
r588 (  15 16 ) resistor r=2.19943 //w=0.131 //l=2.305 //layer=m1 \
 //thickness=0.36 //x=33.42 //y=2.945 //x2=33.42 //y2=5.25
r589 (  14 37 ) resistor r=0.0860668 //w=0.374 //l=0.170294 //layer=m1 \
 //thickness=0.36 //x=33.42 //y=2.625 //x2=33.475 //y2=2.77
r590 (  13 14 ) resistor r=0.663168 //w=0.131 //l=0.695 //layer=m1 \
 //thickness=0.36 //x=33.42 //y=1.93 //x2=33.42 //y2=2.625
r591 (  11 13 ) resistor r=0.0698411 //w=0.17 //l=0.120208 //layer=m1 \
 //thickness=0.36 //x=33.335 //y=1.845 //x2=33.42 //y2=1.93
r592 (  11 12 ) resistor r=0.300573 //w=0.131 //l=0.315 //layer=m1 \
 //thickness=0.36 //x=33.335 //y=1.845 //x2=33.02 //y2=1.845
r593 (  10 12 ) resistor r=0.0698411 //w=0.17 //l=0.120208 //layer=m1 \
 //thickness=0.36 //x=32.935 //y=1.76 //x2=33.02 //y2=1.845
r594 (  9 35 ) resistor r=0.0717383 //w=0.224 //l=0.115 //layer=m1 \
 //thickness=0.36 //x=32.935 //y=1.305 //x2=32.935 //y2=1.19
r595 (  9 10 ) resistor r=0.43416 //w=0.131 //l=0.455 //layer=m1 \
 //thickness=0.36 //x=32.935 //y=1.305 //x2=32.935 //y2=1.76
r596 (  8 31 ) resistor r=0.0675342 //w=0.23 //l=0.115 //layer=m1 \
 //thickness=0.36 //x=32.755 //y=5.335 //x2=32.64 //y2=5.335
r597 (  7 16 ) resistor r=0.0698411 //w=0.17 //l=0.120208 //layer=m1 \
 //thickness=0.36 //x=33.335 //y=5.335 //x2=33.42 //y2=5.25
r598 (  7 8 ) resistor r=0.553435 //w=0.131 //l=0.58 //layer=m1 \
 //thickness=0.36 //x=33.335 //y=5.335 //x2=32.755 //y2=5.335
r599 (  6 33 ) resistor r=0.00118313 //w=0.23 //layer=m1 //thickness=0.36 \
 //x=32.64 //y=5.56 //x2=32.64 //y2=5.56
r600 (  5 31 ) resistor r=0.002872 //w=0.34 //l=0.085 //layer=m1 \
 //thickness=0.36 //x=32.64 //y=5.42 //x2=32.64 //y2=5.335
r601 (  5 6 ) resistor r=0.091623 //w=0.191 //l=0.14 //layer=m1 \
 //thickness=0.36 //x=32.64 //y=5.42 //x2=32.64 //y2=5.56
r602 (  4 28 ) resistor r=0.0262263 //w=0.232 //l=0.12 //layer=m1 \
 //thickness=0.36 //x=31.88 //y=5.335 //x2=31.76 //y2=5.335
r603 (  3 31 ) resistor r=0.0675342 //w=0.23 //l=0.115 //layer=m1 \
 //thickness=0.36 //x=32.525 //y=5.335 //x2=32.64 //y2=5.335
r604 (  3 4 ) resistor r=0.615458 //w=0.131 //l=0.645 //layer=m1 \
 //thickness=0.36 //x=32.525 //y=5.335 //x2=31.88 //y2=5.335
r605 (  2 25 ) resistor r=0.0222262 //w=0.217 //l=0.118 //layer=m1 \
 //thickness=0.36 //x=31 //y=5.335 //x2=30.882 //y2=5.335
r606 (  1 28 ) resistor r=0.0262263 //w=0.232 //l=0.12 //layer=m1 \
 //thickness=0.36 //x=31.64 //y=5.335 //x2=31.76 //y2=5.335
r607 (  1 2 ) resistor r=0.610687 //w=0.131 //l=0.64 //layer=m1 \
 //thickness=0.36 //x=31.64 //y=5.335 //x2=31 //y2=5.335
ends PM_TMRDFFSNRNQNX1\%noxref_7

subckt PM_TMRDFFSNRNQNX1\%noxref_8 ( 1 3 6 7 9 10 11 12 14 15 16 17 18 19 20 \
 21 24 27 33 36 42 43 48 51 59 67 84 93 97 98 99 100 101 102 103 104 106 112 \
 113 114 115 127 129 130 131 )
c300 ( 127 0 ) capacitor c=0.00885916f //x=42.365 //y=1.095
c301 ( 115 0 ) capacitor c=0.0612936f //x=45.165 //y=4.97
c302 ( 114 0 ) capacitor c=0.0376642f //x=45.455 //y=4.97
c303 ( 113 0 ) capacitor c=0.0346489f //x=45.12 //y=1.4
c304 ( 112 0 ) capacitor c=0.018692f //x=45.12 //y=1.055
c305 ( 106 0 ) capacitor c=0.0137077f //x=44.965 //y=1.555
c306 ( 104 0 ) capacitor c=0.0158585f //x=44.965 //y=0.9
c307 ( 103 0 ) capacitor c=0.0979523f //x=44.59 //y=2.095
c308 ( 102 0 ) capacitor c=0.0229444f //x=44.59 //y=1.71
c309 ( 101 0 ) capacitor c=0.0234359f //x=44.59 //y=1.4
c310 ( 100 0 ) capacitor c=0.019815f //x=44.59 //y=1.055
c311 ( 99 0 ) capacitor c=0.11022f //x=45.53 //y=6.2
c312 ( 98 0 ) capacitor c=0.158957f //x=45.09 //y=6.2
c313 ( 93 0 ) capacitor c=0.0014751f //x=44.89 //y=4.88
c314 ( 84 0 ) capacitor c=9.93222e-19 //x=44.89 //y=2.26
c315 ( 67 0 ) capacitor c=0.0293723f //x=42.26 //y=5.56
c316 ( 59 0 ) capacitor c=0.029137f //x=41.38 //y=5.56
c317 ( 51 0 ) capacitor c=0.0278099f //x=40.5 //y=5.56
c318 ( 48 0 ) capacitor c=6.57651e-19 //x=44.9 //y=2.77
c319 ( 43 0 ) capacitor c=9.44624e-19 //x=43.2 //y=2.77
c320 ( 42 0 ) capacitor c=0.0155215f //x=44.74 //y=2.77
c321 ( 36 0 ) capacitor c=0.0146045f //x=44.89 //y=2.77
c322 ( 33 0 ) capacitor c=0.0146969f //x=43.04 //y=2.77
c323 ( 27 0 ) capacitor c=0.00281023f //x=42.26 //y=5.335
c324 ( 24 0 ) capacitor c=0.00879456f //x=41.38 //y=5.335
c325 ( 21 0 ) capacitor c=0.0110651f //x=40.502 //y=5.335
c326 ( 20 0 ) capacitor c=0.0632513f //x=44.89 //y=4.755
c327 ( 19 0 ) capacitor c=0.0133106f //x=44.89 //y=2.93
c328 ( 18 0 ) capacitor c=0.00432188f //x=44.89 //y=2.61
c329 ( 17 0 ) capacitor c=0.00485584f //x=44.89 //y=2.375
c330 ( 16 0 ) capacitor c=0.0642086f //x=43.04 //y=5.25
c331 ( 15 0 ) capacitor c=0.0122936f //x=43.04 //y=2.93
c332 ( 14 0 ) capacitor c=0.0181662f //x=43.04 //y=2.61
c333 ( 12 0 ) capacitor c=0.00493487f //x=42.64 //y=1.845
c334 ( 11 0 ) capacitor c=0.0129068f //x=42.955 //y=1.845
c335 ( 10 0 ) capacitor c=0.0167992f //x=42.555 //y=1.76
c336 ( 9 0 ) capacitor c=0.0112867f //x=42.555 //y=1.305
c337 ( 7 0 ) capacitor c=0.0187905f //x=42.955 //y=5.335
c338 ( 6 0 ) capacitor c=0.00933983f //x=42.26 //y=5.56
c339 ( 3 0 ) capacitor c=0.0110686f //x=42.145 //y=5.335
c340 ( 1 0 ) capacitor c=0.0110938f //x=41.26 //y=5.335
r341 (  114 116 ) resistor r=26.9307 //w=0.15 //l=0.106066 //layer=ply \
 //thickness=0.18 //x=45.455 //y=4.97 //x2=45.53 //y2=5.045
r342 (  114 115 ) resistor r=148.702 //w=0.094 //l=0.29 //layer=ply \
 //thickness=0.18 //x=45.455 //y=4.97 //x2=45.165 //y2=4.97
r343 (  113 126 ) resistor r=45.1352 //w=0.168 //l=0.173853 //layer=ply \
 //thickness=0.18 //x=45.12 //y=1.4 //x2=45.08 //y2=1.555
r344 (  112 125 ) resistor r=45.1352 //w=0.168 //l=0.173853 //layer=ply \
 //thickness=0.18 //x=45.12 //y=1.055 //x2=45.08 //y2=0.9
r345 (  112 113 ) resistor r=176.904 //w=0.094 //l=0.345 //layer=ply \
 //thickness=0.18 //x=45.12 //y=1.055 //x2=45.12 //y2=1.4
r346 (  109 115 ) resistor r=22.7971 //w=0.269 //l=0.106066 //layer=ply \
 //thickness=0.18 //x=45.09 //y=5.045 //x2=45.165 //y2=4.97
r347 (  109 124 ) resistor r=35.8364 //w=0.269 //l=0.270185 //layer=ply \
 //thickness=0.18 //x=45.09 //y=5.045 //x2=44.89 //y2=4.88
r348 (  107 120 ) resistor r=10.701 //w=0.21 //l=0.115 //layer=ply \
 //thickness=0.18 //x=44.745 //y=1.555 //x2=44.63 //y2=1.555
r349 (  106 126 ) resistor r=5.52526 //w=0.168 //l=0.115 //layer=ply \
 //thickness=0.18 //x=44.965 //y=1.555 //x2=45.08 //y2=1.555
r350 (  105 119 ) resistor r=5.52526 //w=0.168 //l=0.115 //layer=ply \
 //thickness=0.18 //x=44.745 //y=0.9 //x2=44.63 //y2=0.9
r351 (  104 125 ) resistor r=5.52526 //w=0.168 //l=0.115 //layer=ply \
 //thickness=0.18 //x=44.965 //y=0.9 //x2=45.08 //y2=0.9
r352 (  104 105 ) resistor r=112.809 //w=0.094 //l=0.22 //layer=ply \
 //thickness=0.18 //x=44.965 //y=0.9 //x2=44.745 //y2=0.9
r353 (  103 122 ) resistor r=58.7805 //w=0.246 //l=0.373497 //layer=ply \
 //thickness=0.18 //x=44.59 //y=2.095 //x2=44.89 //y2=2.26
r354 (  102 120 ) resistor r=39.5823 //w=0.21 //l=0.173853 //layer=ply \
 //thickness=0.18 //x=44.59 //y=1.71 //x2=44.63 //y2=1.555
r355 (  102 103 ) resistor r=197.415 //w=0.094 //l=0.385 //layer=ply \
 //thickness=0.18 //x=44.59 //y=1.71 //x2=44.59 //y2=2.095
r356 (  101 120 ) resistor r=39.5823 //w=0.21 //l=0.173853 //layer=ply \
 //thickness=0.18 //x=44.59 //y=1.4 //x2=44.63 //y2=1.555
r357 (  100 119 ) resistor r=45.1352 //w=0.168 //l=0.173853 //layer=ply \
 //thickness=0.18 //x=44.59 //y=1.055 //x2=44.63 //y2=0.9
r358 (  100 101 ) resistor r=176.904 //w=0.094 //l=0.345 //layer=ply \
 //thickness=0.18 //x=44.59 //y=1.055 //x2=44.59 //y2=1.4
r359 (  99 116 ) resistor r=592.245 //w=0.094 //l=1.155 //layer=ply \
 //thickness=0.18 //x=45.53 //y=6.2 //x2=45.53 //y2=5.045
r360 (  98 109 ) resistor r=592.245 //w=0.094 //l=1.155 //layer=ply \
 //thickness=0.18 //x=45.09 //y=6.2 //x2=45.09 //y2=5.045
r361 (  97 106 ) resistor r=56.4043 //w=0.094 //l=0.11 //layer=ply \
 //thickness=0.18 //x=44.855 //y=1.555 //x2=44.965 //y2=1.555
r362 (  97 107 ) resistor r=56.4043 //w=0.094 //l=0.11 //layer=ply \
 //thickness=0.18 //x=44.855 //y=1.555 //x2=44.745 //y2=1.555
r363 (  93 124 ) resistor r=152 //w=0.17 //l=0.17 //layer=licon //count=1 \
 //x=44.89 //y=4.88 //x2=44.89 //y2=4.88
r364 (  84 122 ) resistor r=152 //w=0.17 //l=0.17 //layer=licon //count=1 \
 //x=44.89 //y=2.26 //x2=44.89 //y2=2.26
r365 (  67 131 ) resistor r=23.615 //w=0.187 //l=0.345 //layer=li \
 //thickness=0.1 //x=42.26 //y=5.56 //x2=42.26 //y2=5.905
r366 (  59 130 ) resistor r=23.615 //w=0.187 //l=0.345 //layer=li \
 //thickness=0.1 //x=41.38 //y=5.56 //x2=41.38 //y2=5.905
r367 (  51 129 ) resistor r=23.615 //w=0.187 //l=0.345 //layer=li \
 //thickness=0.1 //x=40.5 //y=5.56 //x2=40.5 //y2=5.905
r368 (  43 45 ) resistor r=0.10734 //w=0.281 //l=0.16 //layer=m2 \
 //thickness=0.36 //x=43.2 //y=2.77 //x2=43.04 //y2=2.77
r369 (  42 48 ) resistor r=0.10734 //w=0.281 //l=0.16 //layer=m2 \
 //thickness=0.36 //x=44.74 //y=2.77 //x2=44.9 //y2=2.77
r370 (  42 43 ) resistor r=1.46947 //w=0.131 //l=1.54 //layer=m2 \
 //thickness=0.36 //x=44.74 //y=2.77 //x2=43.2 //y2=2.77
r371 (  41 93 ) resistor r=9.3 //w=0.17 //l=0.17 //layer=mcon //count=1 \
 //x=44.89 //y=4.88 //x2=44.89 //y2=4.88
r372 (  39 84 ) resistor r=9.3 //w=0.17 //l=0.17 //layer=mcon //count=1 \
 //x=44.89 //y=2.26 //x2=44.89 //y2=2.26
r373 (  36 48 ) resistor r=4.5 //w=0.15 //l=0.15 //layer=via1 //count=1 \
 //x=44.9 //y=2.77 //x2=44.9 //y2=2.77
r374 (  33 45 ) resistor r=4.5 //w=0.15 //l=0.15 //layer=via1 //count=1 \
 //x=43.04 //y=2.77 //x2=43.04 //y2=2.77
r375 (  31 127 ) resistor r=9.3 //w=0.17 //l=0.17 //layer=mcon //count=1 \
 //x=42.555 //y=1.19 //x2=42.555 //y2=1.19
r376 (  29 67 ) resistor r=9.3 //w=0.17 //l=0.17 //layer=mcon //count=1 \
 //x=42.26 //y=5.56 //x2=42.26 //y2=5.56
r377 (  26 59 ) resistor r=9.3 //w=0.17 //l=0.17 //layer=mcon //count=1 \
 //x=41.38 //y=5.56 //x2=41.38 //y2=5.56
r378 (  24 26 ) resistor r=0.121228 //w=0.232 //l=0.225 //layer=m1 \
 //thickness=0.36 //x=41.38 //y=5.335 //x2=41.38 //y2=5.56
r379 (  23 51 ) resistor r=9.3 //w=0.17 //l=0.17 //layer=mcon //count=1 \
 //x=40.5 //y=5.56 //x2=40.5 //y2=5.56
r380 (  21 23 ) resistor r=0.129608 //w=0.217 //l=0.225 //layer=m1 \
 //thickness=0.36 //x=40.502 //y=5.335 //x2=40.502 //y2=5.56
r381 (  20 41 ) resistor r=0.0760407 //w=0.238 //l=0.125 //layer=m1 \
 //thickness=0.36 //x=44.89 //y=4.755 //x2=44.89 //y2=4.88
r382 (  19 36 ) resistor r=0.0914072 //w=0.382 //l=0.182428 //layer=m1 \
 //thickness=0.36 //x=44.89 //y=2.93 //x2=44.842 //y2=2.77
r383 (  19 20 ) resistor r=1.74141 //w=0.131 //l=1.825 //layer=m1 \
 //thickness=0.36 //x=44.89 //y=2.93 //x2=44.89 //y2=4.755
r384 (  18 36 ) resistor r=0.0914072 //w=0.382 //l=0.182428 //layer=m1 \
 //thickness=0.36 //x=44.89 //y=2.61 //x2=44.842 //y2=2.77
r385 (  17 39 ) resistor r=0.0719237 //w=0.222 //l=0.115 //layer=m1 \
 //thickness=0.36 //x=44.89 //y=2.375 //x2=44.89 //y2=2.26
r386 (  17 18 ) resistor r=0.224237 //w=0.131 //l=0.235 //layer=m1 \
 //thickness=0.36 //x=44.89 //y=2.375 //x2=44.89 //y2=2.61
r387 (  15 33 ) resistor r=0.0911593 //w=0.376 //l=0.184174 //layer=m1 \
 //thickness=0.36 //x=43.04 //y=2.93 //x2=43.092 //y2=2.77
r388 (  15 16 ) resistor r=2.21374 //w=0.131 //l=2.32 //layer=m1 \
 //thickness=0.36 //x=43.04 //y=2.93 //x2=43.04 //y2=5.25
r389 (  14 33 ) resistor r=0.0911593 //w=0.376 //l=0.184174 //layer=m1 \
 //thickness=0.36 //x=43.04 //y=2.61 //x2=43.092 //y2=2.77
r390 (  13 14 ) resistor r=0.648855 //w=0.131 //l=0.68 //layer=m1 \
 //thickness=0.36 //x=43.04 //y=1.93 //x2=43.04 //y2=2.61
r391 (  11 13 ) resistor r=0.0698411 //w=0.17 //l=0.120208 //layer=m1 \
 //thickness=0.36 //x=42.955 //y=1.845 //x2=43.04 //y2=1.93
r392 (  11 12 ) resistor r=0.300573 //w=0.131 //l=0.315 //layer=m1 \
 //thickness=0.36 //x=42.955 //y=1.845 //x2=42.64 //y2=1.845
r393 (  10 12 ) resistor r=0.0698411 //w=0.17 //l=0.120208 //layer=m1 \
 //thickness=0.36 //x=42.555 //y=1.76 //x2=42.64 //y2=1.845
r394 (  9 31 ) resistor r=0.0717383 //w=0.224 //l=0.115 //layer=m1 \
 //thickness=0.36 //x=42.555 //y=1.305 //x2=42.555 //y2=1.19
r395 (  9 10 ) resistor r=0.43416 //w=0.131 //l=0.455 //layer=m1 \
 //thickness=0.36 //x=42.555 //y=1.305 //x2=42.555 //y2=1.76
r396 (  8 27 ) resistor r=0.0675342 //w=0.23 //l=0.115 //layer=m1 \
 //thickness=0.36 //x=42.375 //y=5.335 //x2=42.26 //y2=5.335
r397 (  7 16 ) resistor r=0.0698411 //w=0.17 //l=0.120208 //layer=m1 \
 //thickness=0.36 //x=42.955 //y=5.335 //x2=43.04 //y2=5.25
r398 (  7 8 ) resistor r=0.553435 //w=0.131 //l=0.58 //layer=m1 \
 //thickness=0.36 //x=42.955 //y=5.335 //x2=42.375 //y2=5.335
r399 (  6 29 ) resistor r=0.00118313 //w=0.23 //layer=m1 //thickness=0.36 \
 //x=42.26 //y=5.56 //x2=42.26 //y2=5.56
r400 (  5 27 ) resistor r=0.002872 //w=0.34 //l=0.085 //layer=m1 \
 //thickness=0.36 //x=42.26 //y=5.42 //x2=42.26 //y2=5.335
r401 (  5 6 ) resistor r=0.091623 //w=0.191 //l=0.14 //layer=m1 \
 //thickness=0.36 //x=42.26 //y=5.42 //x2=42.26 //y2=5.56
r402 (  4 24 ) resistor r=0.0262263 //w=0.232 //l=0.12 //layer=m1 \
 //thickness=0.36 //x=41.5 //y=5.335 //x2=41.38 //y2=5.335
r403 (  3 27 ) resistor r=0.0675342 //w=0.23 //l=0.115 //layer=m1 \
 //thickness=0.36 //x=42.145 //y=5.335 //x2=42.26 //y2=5.335
r404 (  3 4 ) resistor r=0.615458 //w=0.131 //l=0.645 //layer=m1 \
 //thickness=0.36 //x=42.145 //y=5.335 //x2=41.5 //y2=5.335
r405 (  2 21 ) resistor r=0.0222262 //w=0.217 //l=0.118 //layer=m1 \
 //thickness=0.36 //x=40.62 //y=5.335 //x2=40.502 //y2=5.335
r406 (  1 24 ) resistor r=0.0262263 //w=0.232 //l=0.12 //layer=m1 \
 //thickness=0.36 //x=41.26 //y=5.335 //x2=41.38 //y2=5.335
r407 (  1 2 ) resistor r=0.610687 //w=0.131 //l=0.64 //layer=m1 \
 //thickness=0.36 //x=41.26 //y=5.335 //x2=40.62 //y2=5.335
ends PM_TMRDFFSNRNQNX1\%noxref_8

subckt PM_TMRDFFSNRNQNX1\%noxref_9 ( 1 2 3 4 5 7 10 11 13 14 15 16 18 19 20 21 \
 22 23 24 30 33 36 39 47 49 57 62 65 66 68 71 80 85 93 101 118 127 131 132 133 \
 134 135 136 140 141 142 147 149 152 153 154 155 156 157 158 160 166 167 168 \
 169 174 175 180 191 193 194 195 )
c493 ( 191 0 ) capacitor c=0.00885916f //x=37.555 //y=1.095
c494 ( 180 0 ) capacitor c=0.0710579f //x=32.68 //y=4.88
c495 ( 175 0 ) capacitor c=0.0278202f //x=32.68 //y=2.095
c496 ( 174 0 ) capacitor c=0.0479349f //x=32.68 //y=2.26
c497 ( 169 0 ) capacitor c=0.0612936f //x=49.975 //y=4.97
c498 ( 168 0 ) capacitor c=0.0376642f //x=50.265 //y=4.97
c499 ( 167 0 ) capacitor c=0.0346489f //x=49.93 //y=1.4
c500 ( 166 0 ) capacitor c=0.018692f //x=49.93 //y=1.055
c501 ( 160 0 ) capacitor c=0.0137077f //x=49.775 //y=1.555
c502 ( 158 0 ) capacitor c=0.0158585f //x=49.775 //y=0.9
c503 ( 157 0 ) capacitor c=0.10101f //x=49.4 //y=2.095
c504 ( 156 0 ) capacitor c=0.0229444f //x=49.4 //y=1.71
c505 ( 155 0 ) capacitor c=0.0234359f //x=49.4 //y=1.4
c506 ( 154 0 ) capacitor c=0.019815f //x=49.4 //y=1.055
c507 ( 153 0 ) capacitor c=0.0443175f //x=33.2 //y=1.44
c508 ( 152 0 ) capacitor c=0.0199703f //x=33.2 //y=1.095
c509 ( 149 0 ) capacitor c=0.0162526f //x=33.045 //y=1.595
c510 ( 147 0 ) capacitor c=0.0157807f //x=33.045 //y=0.94
c511 ( 142 0 ) capacitor c=0.0220935f //x=32.67 //y=1.75
c512 ( 141 0 ) capacitor c=0.0207489f //x=32.67 //y=1.44
c513 ( 140 0 ) capacitor c=0.0194091f //x=32.67 //y=1.095
c514 ( 136 0 ) capacitor c=0.110208f //x=50.34 //y=6.2
c515 ( 135 0 ) capacitor c=0.158957f //x=49.9 //y=6.2
c516 ( 134 0 ) capacitor c=0.159671f //x=32.86 //y=6.2
c517 ( 133 0 ) capacitor c=0.110208f //x=32.42 //y=6.2
c518 ( 127 0 ) capacitor c=0.0014751f //x=49.7 //y=4.88
c519 ( 118 0 ) capacitor c=0.0012618f //x=49.7 //y=2.26
c520 ( 101 0 ) capacitor c=0.0293723f //x=37.45 //y=5.56
c521 ( 93 0 ) capacitor c=0.029137f //x=36.57 //y=5.56
c522 ( 85 0 ) capacitor c=0.0278099f //x=35.69 //y=5.56
c523 ( 80 0 ) capacitor c=9.5006e-19 //x=32.68 //y=4.88
c524 ( 71 0 ) capacitor c=0.00101179f //x=32.68 //y=2.26
c525 ( 68 0 ) capacitor c=4.92288e-19 //x=49.695 //y=3.51
c526 ( 66 0 ) capacitor c=5.9275e-19 //x=38.39 //y=3.495
c527 ( 65 0 ) capacitor c=0.0609696f //x=38.07 //y=3.495
c528 ( 62 0 ) capacitor c=4.31985e-19 //x=32.85 //y=3.515
c529 ( 57 0 ) capacitor c=0.114129f //x=49.535 //y=3.51
c530 ( 49 0 ) capacitor c=0.0170797f //x=49.695 //y=3.51
c531 ( 47 0 ) capacitor c=0.0158593f //x=38.23 //y=3.51
c532 ( 39 0 ) capacitor c=0.00262776f //x=37.45 //y=5.335
c533 ( 36 0 ) capacitor c=0.00784956f //x=36.57 //y=5.335
c534 ( 33 0 ) capacitor c=0.0123748f //x=35.692 //y=5.335
c535 ( 30 0 ) capacitor c=0.0150828f //x=32.68 //y=3.51
c536 ( 24 0 ) capacitor c=0.0374925f //x=49.7 //y=4.755
c537 ( 23 0 ) capacitor c=0.0144231f //x=49.7 //y=3.67
c538 ( 22 0 ) capacitor c=0.026634f //x=49.7 //y=3.35
c539 ( 21 0 ) capacitor c=0.00493552f //x=49.7 //y=2.375
c540 ( 20 0 ) capacitor c=0.040988f //x=38.23 //y=5.25
c541 ( 19 0 ) capacitor c=0.0133594f //x=38.23 //y=3.655
c542 ( 18 0 ) capacitor c=0.0372097f //x=38.23 //y=3.335
c543 ( 16 0 ) capacitor c=0.0048771f //x=37.83 //y=1.845
c544 ( 15 0 ) capacitor c=0.0132684f //x=38.145 //y=1.845
c545 ( 14 0 ) capacitor c=0.0167992f //x=37.745 //y=1.76
c546 ( 13 0 ) capacitor c=0.0113147f //x=37.745 //y=1.305
c547 ( 11 0 ) capacitor c=0.0186897f //x=38.145 //y=5.335
c548 ( 10 0 ) capacitor c=0.00933848f //x=37.45 //y=5.56
c549 ( 7 0 ) capacitor c=0.0121511f //x=37.335 //y=5.335
c550 ( 5 0 ) capacitor c=0.00941481f //x=36.45 //y=5.335
c551 ( 4 0 ) capacitor c=0.0303415f //x=32.68 //y=4.75
c552 ( 3 0 ) capacitor c=0.0122376f //x=32.68 //y=3.675
c553 ( 2 0 ) capacitor c=0.0217875f //x=32.68 //y=3.355
c554 ( 1 0 ) capacitor c=0.005545f //x=32.68 //y=2.375
r555 (  174 175 ) resistor r=52.7279 //w=0.214 //l=0.165 //layer=ply \
 //thickness=0.18 //x=32.68 //y=2.26 //x2=32.68 //y2=2.095
r556 (  168 170 ) resistor r=26.9307 //w=0.15 //l=0.106066 //layer=ply \
 //thickness=0.18 //x=50.265 //y=4.97 //x2=50.34 //y2=5.045
r557 (  168 169 ) resistor r=148.702 //w=0.094 //l=0.29 //layer=ply \
 //thickness=0.18 //x=50.265 //y=4.97 //x2=49.975 //y2=4.97
r558 (  167 190 ) resistor r=45.1352 //w=0.168 //l=0.173853 //layer=ply \
 //thickness=0.18 //x=49.93 //y=1.4 //x2=49.89 //y2=1.555
r559 (  166 189 ) resistor r=45.1352 //w=0.168 //l=0.173853 //layer=ply \
 //thickness=0.18 //x=49.93 //y=1.055 //x2=49.89 //y2=0.9
r560 (  166 167 ) resistor r=176.904 //w=0.094 //l=0.345 //layer=ply \
 //thickness=0.18 //x=49.93 //y=1.055 //x2=49.93 //y2=1.4
r561 (  163 169 ) resistor r=22.7971 //w=0.269 //l=0.106066 //layer=ply \
 //thickness=0.18 //x=49.9 //y=5.045 //x2=49.975 //y2=4.97
r562 (  163 188 ) resistor r=35.8364 //w=0.269 //l=0.270185 //layer=ply \
 //thickness=0.18 //x=49.9 //y=5.045 //x2=49.7 //y2=4.88
r563 (  161 184 ) resistor r=10.701 //w=0.21 //l=0.115 //layer=ply \
 //thickness=0.18 //x=49.555 //y=1.555 //x2=49.44 //y2=1.555
r564 (  160 190 ) resistor r=5.52526 //w=0.168 //l=0.115 //layer=ply \
 //thickness=0.18 //x=49.775 //y=1.555 //x2=49.89 //y2=1.555
r565 (  159 183 ) resistor r=5.52526 //w=0.168 //l=0.115 //layer=ply \
 //thickness=0.18 //x=49.555 //y=0.9 //x2=49.44 //y2=0.9
r566 (  158 189 ) resistor r=5.52526 //w=0.168 //l=0.115 //layer=ply \
 //thickness=0.18 //x=49.775 //y=0.9 //x2=49.89 //y2=0.9
r567 (  158 159 ) resistor r=112.809 //w=0.094 //l=0.22 //layer=ply \
 //thickness=0.18 //x=49.775 //y=0.9 //x2=49.555 //y2=0.9
r568 (  157 186 ) resistor r=58.7805 //w=0.246 //l=0.373497 //layer=ply \
 //thickness=0.18 //x=49.4 //y=2.095 //x2=49.7 //y2=2.26
r569 (  156 184 ) resistor r=39.5823 //w=0.21 //l=0.173853 //layer=ply \
 //thickness=0.18 //x=49.4 //y=1.71 //x2=49.44 //y2=1.555
r570 (  156 157 ) resistor r=197.415 //w=0.094 //l=0.385 //layer=ply \
 //thickness=0.18 //x=49.4 //y=1.71 //x2=49.4 //y2=2.095
r571 (  155 184 ) resistor r=39.5823 //w=0.21 //l=0.173853 //layer=ply \
 //thickness=0.18 //x=49.4 //y=1.4 //x2=49.44 //y2=1.555
r572 (  154 183 ) resistor r=45.1352 //w=0.168 //l=0.173853 //layer=ply \
 //thickness=0.18 //x=49.4 //y=1.055 //x2=49.44 //y2=0.9
r573 (  154 155 ) resistor r=176.904 //w=0.094 //l=0.345 //layer=ply \
 //thickness=0.18 //x=49.4 //y=1.055 //x2=49.4 //y2=1.4
r574 (  153 182 ) resistor r=45.1352 //w=0.168 //l=0.173853 //layer=ply \
 //thickness=0.18 //x=33.2 //y=1.44 //x2=33.16 //y2=1.595
r575 (  152 181 ) resistor r=45.1352 //w=0.168 //l=0.173853 //layer=ply \
 //thickness=0.18 //x=33.2 //y=1.095 //x2=33.16 //y2=0.94
r576 (  152 153 ) resistor r=176.904 //w=0.094 //l=0.345 //layer=ply \
 //thickness=0.18 //x=33.2 //y=1.095 //x2=33.2 //y2=1.44
r577 (  150 178 ) resistor r=10.701 //w=0.21 //l=0.115 //layer=ply \
 //thickness=0.18 //x=32.825 //y=1.595 //x2=32.71 //y2=1.595
r578 (  149 182 ) resistor r=5.52526 //w=0.168 //l=0.115 //layer=ply \
 //thickness=0.18 //x=33.045 //y=1.595 //x2=33.16 //y2=1.595
r579 (  148 177 ) resistor r=5.52526 //w=0.168 //l=0.115 //layer=ply \
 //thickness=0.18 //x=32.825 //y=0.94 //x2=32.71 //y2=0.94
r580 (  147 181 ) resistor r=5.52526 //w=0.168 //l=0.115 //layer=ply \
 //thickness=0.18 //x=33.045 //y=0.94 //x2=33.16 //y2=0.94
r581 (  147 148 ) resistor r=112.809 //w=0.094 //l=0.22 //layer=ply \
 //thickness=0.18 //x=33.045 //y=0.94 //x2=32.825 //y2=0.94
r582 (  144 180 ) resistor r=37.236 //w=0.233 //l=0.249199 //layer=ply \
 //thickness=0.18 //x=32.86 //y=5.045 //x2=32.68 //y2=4.88
r583 (  142 178 ) resistor r=39.5823 //w=0.21 //l=0.173853 //layer=ply \
 //thickness=0.18 //x=32.67 //y=1.75 //x2=32.71 //y2=1.595
r584 (  142 175 ) resistor r=176.904 //w=0.094 //l=0.345 //layer=ply \
 //thickness=0.18 //x=32.67 //y=1.75 //x2=32.67 //y2=2.095
r585 (  141 178 ) resistor r=39.5823 //w=0.21 //l=0.173853 //layer=ply \
 //thickness=0.18 //x=32.67 //y=1.44 //x2=32.71 //y2=1.595
r586 (  140 177 ) resistor r=45.1352 //w=0.168 //l=0.173853 //layer=ply \
 //thickness=0.18 //x=32.67 //y=1.095 //x2=32.71 //y2=0.94
r587 (  140 141 ) resistor r=176.904 //w=0.094 //l=0.345 //layer=ply \
 //thickness=0.18 //x=32.67 //y=1.095 //x2=32.67 //y2=1.44
r588 (  137 180 ) resistor r=53.7854 //w=0.233 //l=0.332415 //layer=ply \
 //thickness=0.18 //x=32.42 //y=5.045 //x2=32.68 //y2=4.88
r589 (  136 170 ) resistor r=592.245 //w=0.094 //l=1.155 //layer=ply \
 //thickness=0.18 //x=50.34 //y=6.2 //x2=50.34 //y2=5.045
r590 (  135 163 ) resistor r=592.245 //w=0.094 //l=1.155 //layer=ply \
 //thickness=0.18 //x=49.9 //y=6.2 //x2=49.9 //y2=5.045
r591 (  134 144 ) resistor r=592.245 //w=0.094 //l=1.155 //layer=ply \
 //thickness=0.18 //x=32.86 //y=6.2 //x2=32.86 //y2=5.045
r592 (  133 137 ) resistor r=592.245 //w=0.094 //l=1.155 //layer=ply \
 //thickness=0.18 //x=32.42 //y=6.2 //x2=32.42 //y2=5.045
r593 (  132 160 ) resistor r=56.4043 //w=0.094 //l=0.11 //layer=ply \
 //thickness=0.18 //x=49.665 //y=1.555 //x2=49.775 //y2=1.555
r594 (  132 161 ) resistor r=56.4043 //w=0.094 //l=0.11 //layer=ply \
 //thickness=0.18 //x=49.665 //y=1.555 //x2=49.555 //y2=1.555
r595 (  131 149 ) resistor r=56.4043 //w=0.094 //l=0.11 //layer=ply \
 //thickness=0.18 //x=32.935 //y=1.595 //x2=33.045 //y2=1.595
r596 (  131 150 ) resistor r=56.4043 //w=0.094 //l=0.11 //layer=ply \
 //thickness=0.18 //x=32.935 //y=1.595 //x2=32.825 //y2=1.595
r597 (  127 188 ) resistor r=152 //w=0.17 //l=0.17 //layer=licon //count=1 \
 //x=49.7 //y=4.88 //x2=49.7 //y2=4.88
r598 (  118 186 ) resistor r=152 //w=0.17 //l=0.17 //layer=licon //count=1 \
 //x=49.7 //y=2.26 //x2=49.7 //y2=2.26
r599 (  101 195 ) resistor r=23.615 //w=0.187 //l=0.345 //layer=li \
 //thickness=0.1 //x=37.45 //y=5.56 //x2=37.45 //y2=5.905
r600 (  93 194 ) resistor r=23.615 //w=0.187 //l=0.345 //layer=li \
 //thickness=0.1 //x=36.57 //y=5.56 //x2=36.57 //y2=5.905
r601 (  85 193 ) resistor r=23.615 //w=0.187 //l=0.345 //layer=li \
 //thickness=0.1 //x=35.69 //y=5.56 //x2=35.69 //y2=5.905
r602 (  80 180 ) resistor r=152 //w=0.17 //l=0.17 //layer=licon //count=1 \
 //x=32.68 //y=4.88 //x2=32.68 //y2=4.88
r603 (  71 174 ) resistor r=152 //w=0.17 //l=0.17 //layer=licon //count=1 \
 //x=32.68 //y=2.26 //x2=32.68 //y2=2.26
r604 (  64 66 ) resistor r=0.10734 //w=0.281 //l=0.16 //layer=m2 \
 //thickness=0.36 //x=38.23 //y=3.495 //x2=38.39 //y2=3.495
r605 (  64 65 ) resistor r=0.10734 //w=0.281 //l=0.16 //layer=m2 \
 //thickness=0.36 //x=38.23 //y=3.495 //x2=38.07 //y2=3.495
r606 (  62 65 ) resistor r=4.98092 //w=0.131 //l=5.22 //layer=m2 \
 //thickness=0.36 //x=32.85 //y=3.51 //x2=38.07 //y2=3.51
r607 (  60 62 ) resistor r=0.10734 //w=0.281 //l=0.16 //layer=m2 \
 //thickness=0.36 //x=32.69 //y=3.515 //x2=32.85 //y2=3.515
r608 (  57 68 ) resistor r=0.10734 //w=0.281 //l=0.16 //layer=m2 \
 //thickness=0.36 //x=49.535 //y=3.51 //x2=49.695 //y2=3.51
r609 (  57 66 ) resistor r=10.6345 //w=0.131 //l=11.145 //layer=m2 \
 //thickness=0.36 //x=49.535 //y=3.51 //x2=38.39 //y2=3.51
r610 (  54 127 ) resistor r=9.3 //w=0.17 //l=0.17 //layer=mcon //count=1 \
 //x=49.7 //y=4.88 //x2=49.7 //y2=4.88
r611 (  52 118 ) resistor r=9.3 //w=0.17 //l=0.17 //layer=mcon //count=1 \
 //x=49.7 //y=2.26 //x2=49.7 //y2=2.26
r612 (  49 68 ) resistor r=4.5 //w=0.15 //l=0.15 //layer=via1 //count=1 \
 //x=49.695 //y=3.51 //x2=49.695 //y2=3.51
r613 (  45 64 ) resistor r=4.5 //w=0.15 //l=0.15 //layer=via1 //count=1 \
 //x=38.23 //y=3.495 //x2=38.23 //y2=3.495
r614 (  45 47 ) resistor r=0.0049867 //w=0.376 //l=0.015 //layer=m1 \
 //thickness=0.36 //x=38.282 //y=3.495 //x2=38.282 //y2=3.51
r615 (  43 191 ) resistor r=9.3 //w=0.17 //l=0.17 //layer=mcon //count=1 \
 //x=37.745 //y=1.19 //x2=37.745 //y2=1.19
r616 (  41 101 ) resistor r=9.3 //w=0.17 //l=0.17 //layer=mcon //count=1 \
 //x=37.45 //y=5.56 //x2=37.45 //y2=5.56
r617 (  38 93 ) resistor r=9.3 //w=0.17 //l=0.17 //layer=mcon //count=1 \
 //x=36.57 //y=5.56 //x2=36.57 //y2=5.56
r618 (  36 38 ) resistor r=0.121228 //w=0.232 //l=0.225 //layer=m1 \
 //thickness=0.36 //x=36.57 //y=5.335 //x2=36.57 //y2=5.56
r619 (  35 85 ) resistor r=9.3 //w=0.17 //l=0.17 //layer=mcon //count=1 \
 //x=35.69 //y=5.56 //x2=35.69 //y2=5.56
r620 (  33 35 ) resistor r=0.129608 //w=0.217 //l=0.225 //layer=m1 \
 //thickness=0.36 //x=35.692 //y=5.335 //x2=35.692 //y2=5.56
r621 (  32 60 ) resistor r=4.5 //w=0.15 //l=0.15 //layer=via1 //count=1 \
 //x=32.69 //y=3.515 //x2=32.69 //y2=3.515
r622 (  30 32 ) resistor r=0.00168464 //w=0.371 //l=0.005 //layer=m1 \
 //thickness=0.36 //x=32.737 //y=3.51 //x2=32.737 //y2=3.515
r623 (  28 80 ) resistor r=9.3 //w=0.17 //l=0.17 //layer=mcon //count=1 \
 //x=32.68 //y=4.88 //x2=32.68 //y2=4.88
r624 (  26 71 ) resistor r=9.3 //w=0.17 //l=0.17 //layer=mcon //count=1 \
 //x=32.68 //y=2.26 //x2=32.68 //y2=2.26
r625 (  24 54 ) resistor r=0.0760407 //w=0.238 //l=0.125 //layer=m1 \
 //thickness=0.36 //x=49.7 //y=4.755 //x2=49.7 //y2=4.88
r626 (  23 49 ) resistor r=0.0910802 //w=0.374 //l=0.185472 //layer=m1 \
 //thickness=0.36 //x=49.7 //y=3.67 //x2=49.645 //y2=3.51
r627 (  23 24 ) resistor r=1.03531 //w=0.131 //l=1.085 //layer=m1 \
 //thickness=0.36 //x=49.7 //y=3.67 //x2=49.7 //y2=4.755
r628 (  22 49 ) resistor r=0.0910802 //w=0.374 //l=0.185472 //layer=m1 \
 //thickness=0.36 //x=49.7 //y=3.35 //x2=49.645 //y2=3.51
r629 (  21 52 ) resistor r=0.0719237 //w=0.222 //l=0.115 //layer=m1 \
 //thickness=0.36 //x=49.7 //y=2.375 //x2=49.7 //y2=2.26
r630 (  21 22 ) resistor r=0.930344 //w=0.131 //l=0.975 //layer=m1 \
 //thickness=0.36 //x=49.7 //y=2.375 //x2=49.7 //y2=3.35
r631 (  19 47 ) resistor r=0.0861726 //w=0.376 //l=0.169012 //layer=m1 \
 //thickness=0.36 //x=38.23 //y=3.655 //x2=38.282 //y2=3.51
r632 (  19 20 ) resistor r=1.52195 //w=0.131 //l=1.595 //layer=m1 \
 //thickness=0.36 //x=38.23 //y=3.655 //x2=38.23 //y2=5.25
r633 (  18 45 ) resistor r=0.0911593 //w=0.376 //l=0.184174 //layer=m1 \
 //thickness=0.36 //x=38.23 //y=3.335 //x2=38.282 //y2=3.495
r634 (  17 18 ) resistor r=1.34065 //w=0.131 //l=1.405 //layer=m1 \
 //thickness=0.36 //x=38.23 //y=1.93 //x2=38.23 //y2=3.335
r635 (  15 17 ) resistor r=0.0698411 //w=0.17 //l=0.120208 //layer=m1 \
 //thickness=0.36 //x=38.145 //y=1.845 //x2=38.23 //y2=1.93
r636 (  15 16 ) resistor r=0.300573 //w=0.131 //l=0.315 //layer=m1 \
 //thickness=0.36 //x=38.145 //y=1.845 //x2=37.83 //y2=1.845
r637 (  14 16 ) resistor r=0.0698411 //w=0.17 //l=0.120208 //layer=m1 \
 //thickness=0.36 //x=37.745 //y=1.76 //x2=37.83 //y2=1.845
r638 (  13 43 ) resistor r=0.0717383 //w=0.224 //l=0.115 //layer=m1 \
 //thickness=0.36 //x=37.745 //y=1.305 //x2=37.745 //y2=1.19
r639 (  13 14 ) resistor r=0.43416 //w=0.131 //l=0.455 //layer=m1 \
 //thickness=0.36 //x=37.745 //y=1.305 //x2=37.745 //y2=1.76
r640 (  12 39 ) resistor r=0.0675342 //w=0.23 //l=0.115 //layer=m1 \
 //thickness=0.36 //x=37.565 //y=5.335 //x2=37.45 //y2=5.335
r641 (  11 20 ) resistor r=0.0698411 //w=0.17 //l=0.120208 //layer=m1 \
 //thickness=0.36 //x=38.145 //y=5.335 //x2=38.23 //y2=5.25
r642 (  11 12 ) resistor r=0.553435 //w=0.131 //l=0.58 //layer=m1 \
 //thickness=0.36 //x=38.145 //y=5.335 //x2=37.565 //y2=5.335
r643 (  10 41 ) resistor r=0.00118313 //w=0.23 //layer=m1 //thickness=0.36 \
 //x=37.45 //y=5.56 //x2=37.45 //y2=5.56
r644 (  9 39 ) resistor r=0.002872 //w=0.34 //l=0.085 //layer=m1 \
 //thickness=0.36 //x=37.45 //y=5.42 //x2=37.45 //y2=5.335
r645 (  9 10 ) resistor r=0.091623 //w=0.191 //l=0.14 //layer=m1 \
 //thickness=0.36 //x=37.45 //y=5.42 //x2=37.45 //y2=5.56
r646 (  8 36 ) resistor r=0.0262263 //w=0.232 //l=0.12 //layer=m1 \
 //thickness=0.36 //x=36.69 //y=5.335 //x2=36.57 //y2=5.335
r647 (  7 39 ) resistor r=0.0675342 //w=0.23 //l=0.115 //layer=m1 \
 //thickness=0.36 //x=37.335 //y=5.335 //x2=37.45 //y2=5.335
r648 (  7 8 ) resistor r=0.615458 //w=0.131 //l=0.645 //layer=m1 \
 //thickness=0.36 //x=37.335 //y=5.335 //x2=36.69 //y2=5.335
r649 (  6 33 ) resistor r=0.0222262 //w=0.217 //l=0.118 //layer=m1 \
 //thickness=0.36 //x=35.81 //y=5.335 //x2=35.692 //y2=5.335
r650 (  5 36 ) resistor r=0.0262263 //w=0.232 //l=0.12 //layer=m1 \
 //thickness=0.36 //x=36.45 //y=5.335 //x2=36.57 //y2=5.335
r651 (  5 6 ) resistor r=0.610687 //w=0.131 //l=0.64 //layer=m1 \
 //thickness=0.36 //x=36.45 //y=5.335 //x2=35.81 //y2=5.335
r652 (  4 28 ) resistor r=0.0801089 //w=0.224 //l=0.13 //layer=m1 \
 //thickness=0.36 //x=32.68 //y=4.75 //x2=32.68 //y2=4.88
r653 (  3 32 ) resistor r=0.0909648 //w=0.371 //l=0.186333 //layer=m1 \
 //thickness=0.36 //x=32.68 //y=3.675 //x2=32.737 //y2=3.515
r654 (  3 4 ) resistor r=1.02576 //w=0.131 //l=1.075 //layer=m1 \
 //thickness=0.36 //x=32.68 //y=3.675 //x2=32.68 //y2=4.75
r655 (  2 30 ) resistor r=0.0892801 //w=0.371 //l=0.181273 //layer=m1 \
 //thickness=0.36 //x=32.68 //y=3.355 //x2=32.737 //y2=3.51
r656 (  1 26 ) resistor r=0.0719237 //w=0.222 //l=0.115 //layer=m1 \
 //thickness=0.36 //x=32.68 //y=2.375 //x2=32.68 //y2=2.26
r657 (  1 2 ) resistor r=0.935115 //w=0.131 //l=0.98 //layer=m1 \
 //thickness=0.36 //x=32.68 //y=2.375 //x2=32.68 //y2=3.355
ends PM_TMRDFFSNRNQNX1\%noxref_9

subckt PM_TMRDFFSNRNQNX1\%noxref_10 ( 1 2 3 4 5 6 7 8 9 11 14 15 17 18 19 20 \
 22 23 24 25 26 27 28 34 38 45 48 51 57 61 70 72 73 77 80 81 87 96 101 110 115 \
 123 131 148 157 161 162 163 164 165 166 167 168 169 173 174 175 180 182 185 \
 186 190 191 192 197 199 202 203 207 208 209 214 216 219 220 222 223 228 232 \
 233 238 242 243 248 251 253 254 255 )
c618 ( 251 0 ) capacitor c=0.00885916f //x=47.175 //y=1.095
c619 ( 248 0 ) capacitor c=0.0651477f //x=56.73 //y=4.88
c620 ( 243 0 ) capacitor c=0.0278202f //x=56.73 //y=2.095
c621 ( 242 0 ) capacitor c=0.0503043f //x=56.73 //y=2.26
c622 ( 238 0 ) capacitor c=0.0650993f //x=42.3 //y=4.88
c623 ( 233 0 ) capacitor c=0.0278202f //x=42.3 //y=2.095
c624 ( 232 0 ) capacitor c=0.0503043f //x=42.3 //y=2.26
c625 ( 228 0 ) capacitor c=0.0653196f //x=37.49 //y=4.88
c626 ( 223 0 ) capacitor c=0.0278202f //x=37.49 //y=2.095
c627 ( 222 0 ) capacitor c=0.0503043f //x=37.49 //y=2.26
c628 ( 220 0 ) capacitor c=0.0443175f //x=57.25 //y=1.44
c629 ( 219 0 ) capacitor c=0.0199703f //x=57.25 //y=1.095
c630 ( 216 0 ) capacitor c=0.0162526f //x=57.095 //y=1.595
c631 ( 214 0 ) capacitor c=0.0157807f //x=57.095 //y=0.94
c632 ( 209 0 ) capacitor c=0.0220935f //x=56.72 //y=1.75
c633 ( 208 0 ) capacitor c=0.0207489f //x=56.72 //y=1.44
c634 ( 207 0 ) capacitor c=0.0194091f //x=56.72 //y=1.095
c635 ( 203 0 ) capacitor c=0.0443175f //x=42.82 //y=1.44
c636 ( 202 0 ) capacitor c=0.0199703f //x=42.82 //y=1.095
c637 ( 199 0 ) capacitor c=0.0162526f //x=42.665 //y=1.595
c638 ( 197 0 ) capacitor c=0.0157807f //x=42.665 //y=0.94
c639 ( 192 0 ) capacitor c=0.0220935f //x=42.29 //y=1.75
c640 ( 191 0 ) capacitor c=0.0207489f //x=42.29 //y=1.44
c641 ( 190 0 ) capacitor c=0.0194091f //x=42.29 //y=1.095
c642 ( 186 0 ) capacitor c=0.0443175f //x=38.01 //y=1.44
c643 ( 185 0 ) capacitor c=0.0199703f //x=38.01 //y=1.095
c644 ( 182 0 ) capacitor c=0.0162526f //x=37.855 //y=1.595
c645 ( 180 0 ) capacitor c=0.0157807f //x=37.855 //y=0.94
c646 ( 175 0 ) capacitor c=0.0220935f //x=37.48 //y=1.75
c647 ( 174 0 ) capacitor c=0.0207489f //x=37.48 //y=1.44
c648 ( 173 0 ) capacitor c=0.0194091f //x=37.48 //y=1.095
c649 ( 169 0 ) capacitor c=0.159671f //x=56.91 //y=6.2
c650 ( 168 0 ) capacitor c=0.110208f //x=56.47 //y=6.2
c651 ( 167 0 ) capacitor c=0.159857f //x=42.48 //y=6.2
c652 ( 166 0 ) capacitor c=0.110218f //x=42.04 //y=6.2
c653 ( 165 0 ) capacitor c=0.159857f //x=37.67 //y=6.2
c654 ( 164 0 ) capacitor c=0.110329f //x=37.23 //y=6.2
c655 ( 157 0 ) capacitor c=7.7417e-19 //x=56.73 //y=4.88
c656 ( 148 0 ) capacitor c=0.00101179f //x=56.73 //y=2.26
c657 ( 131 0 ) capacitor c=0.0293124f //x=47.07 //y=5.56
c658 ( 123 0 ) capacitor c=0.029137f //x=46.19 //y=5.56
c659 ( 115 0 ) capacitor c=0.0278099f //x=45.31 //y=5.56
c660 ( 110 0 ) capacitor c=7.74171e-19 //x=42.3 //y=4.88
c661 ( 101 0 ) capacitor c=0.00101179f //x=42.3 //y=2.26
c662 ( 96 0 ) capacitor c=7.74171e-19 //x=37.49 //y=4.88
c663 ( 87 0 ) capacitor c=0.00101179f //x=37.49 //y=2.26
c664 ( 81 0 ) capacitor c=6.2466e-19 //x=42.46 //y=3.895
c665 ( 80 0 ) capacitor c=0.0444774f //x=42.14 //y=3.895
c666 ( 77 0 ) capacitor c=6.16295e-19 //x=37.65 //y=3.895
c667 ( 73 0 ) capacitor c=0.0212158f //x=49.565 //y=3.895
c668 ( 72 0 ) capacitor c=0.0719582f //x=49.91 //y=3.895
c669 ( 70 0 ) capacitor c=0.0534192f //x=47.68 //y=3.88
c670 ( 61 0 ) capacitor c=0.0149589f //x=56.73 //y=3.88
c671 ( 57 0 ) capacitor c=0.0158949f //x=47.85 //y=3.88
c672 ( 51 0 ) capacitor c=0.0017739f //x=47.07 //y=5.335
c673 ( 48 0 ) capacitor c=0.00737416f //x=46.19 //y=5.335
c674 ( 45 0 ) capacitor c=0.0111362f //x=45.312 //y=5.335
c675 ( 38 0 ) capacitor c=0.0149589f //x=42.3 //y=3.88
c676 ( 34 0 ) capacitor c=0.0149589f //x=37.49 //y=3.88
c677 ( 28 0 ) capacitor c=0.0196207f //x=56.73 //y=4.75
c678 ( 27 0 ) capacitor c=0.013506f //x=56.73 //y=4.045
c679 ( 26 0 ) capacitor c=0.0288083f //x=56.73 //y=3.725
c680 ( 25 0 ) capacitor c=0.00556102f //x=56.73 //y=2.375
c681 ( 24 0 ) capacitor c=0.0318343f //x=47.85 //y=5.25
c682 ( 23 0 ) capacitor c=0.0138897f //x=47.85 //y=4.055
c683 ( 22 0 ) capacitor c=0.0490588f //x=47.85 //y=3.735
c684 ( 20 0 ) capacitor c=0.00493487f //x=47.45 //y=1.845
c685 ( 19 0 ) capacitor c=0.0133342f //x=47.765 //y=1.845
c686 ( 18 0 ) capacitor c=0.0167992f //x=47.365 //y=1.76
c687 ( 17 0 ) capacitor c=0.0111491f //x=47.365 //y=1.305
c688 ( 15 0 ) capacitor c=0.0261937f //x=47.765 //y=5.335
c689 ( 14 0 ) capacitor c=0.00933983f //x=47.07 //y=5.56
c690 ( 11 0 ) capacitor c=0.0172393f //x=46.955 //y=5.335
c691 ( 9 0 ) capacitor c=0.0153246f //x=46.07 //y=5.335
c692 ( 8 0 ) capacitor c=0.0195879f //x=42.3 //y=4.75
c693 ( 7 0 ) capacitor c=0.0114837f //x=42.3 //y=4.055
c694 ( 6 0 ) capacitor c=0.029293f //x=42.3 //y=3.735
c695 ( 5 0 ) capacitor c=0.00556102f //x=42.3 //y=2.375
c696 ( 4 0 ) capacitor c=0.0196331f //x=37.49 //y=4.75
c697 ( 3 0 ) capacitor c=0.0115084f //x=37.49 //y=4.055
c698 ( 2 0 ) capacitor c=0.0302471f //x=37.49 //y=3.735
c699 ( 1 0 ) capacitor c=0.00556102f //x=37.49 //y=2.375
r700 (  242 243 ) resistor r=52.7279 //w=0.214 //l=0.165 //layer=ply \
 //thickness=0.18 //x=56.73 //y=2.26 //x2=56.73 //y2=2.095
r701 (  232 233 ) resistor r=52.7279 //w=0.214 //l=0.165 //layer=ply \
 //thickness=0.18 //x=42.3 //y=2.26 //x2=42.3 //y2=2.095
r702 (  222 223 ) resistor r=52.7279 //w=0.214 //l=0.165 //layer=ply \
 //thickness=0.18 //x=37.49 //y=2.26 //x2=37.49 //y2=2.095
r703 (  220 250 ) resistor r=45.1352 //w=0.168 //l=0.173853 //layer=ply \
 //thickness=0.18 //x=57.25 //y=1.44 //x2=57.21 //y2=1.595
r704 (  219 249 ) resistor r=45.1352 //w=0.168 //l=0.173853 //layer=ply \
 //thickness=0.18 //x=57.25 //y=1.095 //x2=57.21 //y2=0.94
r705 (  219 220 ) resistor r=176.904 //w=0.094 //l=0.345 //layer=ply \
 //thickness=0.18 //x=57.25 //y=1.095 //x2=57.25 //y2=1.44
r706 (  217 246 ) resistor r=10.701 //w=0.21 //l=0.115 //layer=ply \
 //thickness=0.18 //x=56.875 //y=1.595 //x2=56.76 //y2=1.595
r707 (  216 250 ) resistor r=5.52526 //w=0.168 //l=0.115 //layer=ply \
 //thickness=0.18 //x=57.095 //y=1.595 //x2=57.21 //y2=1.595
r708 (  215 245 ) resistor r=5.52526 //w=0.168 //l=0.115 //layer=ply \
 //thickness=0.18 //x=56.875 //y=0.94 //x2=56.76 //y2=0.94
r709 (  214 249 ) resistor r=5.52526 //w=0.168 //l=0.115 //layer=ply \
 //thickness=0.18 //x=57.095 //y=0.94 //x2=57.21 //y2=0.94
r710 (  214 215 ) resistor r=112.809 //w=0.094 //l=0.22 //layer=ply \
 //thickness=0.18 //x=57.095 //y=0.94 //x2=56.875 //y2=0.94
r711 (  211 248 ) resistor r=37.236 //w=0.233 //l=0.249199 //layer=ply \
 //thickness=0.18 //x=56.91 //y=5.045 //x2=56.73 //y2=4.88
r712 (  209 246 ) resistor r=39.5823 //w=0.21 //l=0.173853 //layer=ply \
 //thickness=0.18 //x=56.72 //y=1.75 //x2=56.76 //y2=1.595
r713 (  209 243 ) resistor r=176.904 //w=0.094 //l=0.345 //layer=ply \
 //thickness=0.18 //x=56.72 //y=1.75 //x2=56.72 //y2=2.095
r714 (  208 246 ) resistor r=39.5823 //w=0.21 //l=0.173853 //layer=ply \
 //thickness=0.18 //x=56.72 //y=1.44 //x2=56.76 //y2=1.595
r715 (  207 245 ) resistor r=45.1352 //w=0.168 //l=0.173853 //layer=ply \
 //thickness=0.18 //x=56.72 //y=1.095 //x2=56.76 //y2=0.94
r716 (  207 208 ) resistor r=176.904 //w=0.094 //l=0.345 //layer=ply \
 //thickness=0.18 //x=56.72 //y=1.095 //x2=56.72 //y2=1.44
r717 (  204 248 ) resistor r=53.7854 //w=0.233 //l=0.332415 //layer=ply \
 //thickness=0.18 //x=56.47 //y=5.045 //x2=56.73 //y2=4.88
r718 (  203 240 ) resistor r=45.1352 //w=0.168 //l=0.173853 //layer=ply \
 //thickness=0.18 //x=42.82 //y=1.44 //x2=42.78 //y2=1.595
r719 (  202 239 ) resistor r=45.1352 //w=0.168 //l=0.173853 //layer=ply \
 //thickness=0.18 //x=42.82 //y=1.095 //x2=42.78 //y2=0.94
r720 (  202 203 ) resistor r=176.904 //w=0.094 //l=0.345 //layer=ply \
 //thickness=0.18 //x=42.82 //y=1.095 //x2=42.82 //y2=1.44
r721 (  200 236 ) resistor r=10.701 //w=0.21 //l=0.115 //layer=ply \
 //thickness=0.18 //x=42.445 //y=1.595 //x2=42.33 //y2=1.595
r722 (  199 240 ) resistor r=5.52526 //w=0.168 //l=0.115 //layer=ply \
 //thickness=0.18 //x=42.665 //y=1.595 //x2=42.78 //y2=1.595
r723 (  198 235 ) resistor r=5.52526 //w=0.168 //l=0.115 //layer=ply \
 //thickness=0.18 //x=42.445 //y=0.94 //x2=42.33 //y2=0.94
r724 (  197 239 ) resistor r=5.52526 //w=0.168 //l=0.115 //layer=ply \
 //thickness=0.18 //x=42.665 //y=0.94 //x2=42.78 //y2=0.94
r725 (  197 198 ) resistor r=112.809 //w=0.094 //l=0.22 //layer=ply \
 //thickness=0.18 //x=42.665 //y=0.94 //x2=42.445 //y2=0.94
r726 (  194 238 ) resistor r=37.236 //w=0.233 //l=0.249199 //layer=ply \
 //thickness=0.18 //x=42.48 //y=5.045 //x2=42.3 //y2=4.88
r727 (  192 236 ) resistor r=39.5823 //w=0.21 //l=0.173853 //layer=ply \
 //thickness=0.18 //x=42.29 //y=1.75 //x2=42.33 //y2=1.595
r728 (  192 233 ) resistor r=176.904 //w=0.094 //l=0.345 //layer=ply \
 //thickness=0.18 //x=42.29 //y=1.75 //x2=42.29 //y2=2.095
r729 (  191 236 ) resistor r=39.5823 //w=0.21 //l=0.173853 //layer=ply \
 //thickness=0.18 //x=42.29 //y=1.44 //x2=42.33 //y2=1.595
r730 (  190 235 ) resistor r=45.1352 //w=0.168 //l=0.173853 //layer=ply \
 //thickness=0.18 //x=42.29 //y=1.095 //x2=42.33 //y2=0.94
r731 (  190 191 ) resistor r=176.904 //w=0.094 //l=0.345 //layer=ply \
 //thickness=0.18 //x=42.29 //y=1.095 //x2=42.29 //y2=1.44
r732 (  187 238 ) resistor r=53.7854 //w=0.233 //l=0.332415 //layer=ply \
 //thickness=0.18 //x=42.04 //y=5.045 //x2=42.3 //y2=4.88
r733 (  186 230 ) resistor r=45.1352 //w=0.168 //l=0.173853 //layer=ply \
 //thickness=0.18 //x=38.01 //y=1.44 //x2=37.97 //y2=1.595
r734 (  185 229 ) resistor r=45.1352 //w=0.168 //l=0.173853 //layer=ply \
 //thickness=0.18 //x=38.01 //y=1.095 //x2=37.97 //y2=0.94
r735 (  185 186 ) resistor r=176.904 //w=0.094 //l=0.345 //layer=ply \
 //thickness=0.18 //x=38.01 //y=1.095 //x2=38.01 //y2=1.44
r736 (  183 226 ) resistor r=10.701 //w=0.21 //l=0.115 //layer=ply \
 //thickness=0.18 //x=37.635 //y=1.595 //x2=37.52 //y2=1.595
r737 (  182 230 ) resistor r=5.52526 //w=0.168 //l=0.115 //layer=ply \
 //thickness=0.18 //x=37.855 //y=1.595 //x2=37.97 //y2=1.595
r738 (  181 225 ) resistor r=5.52526 //w=0.168 //l=0.115 //layer=ply \
 //thickness=0.18 //x=37.635 //y=0.94 //x2=37.52 //y2=0.94
r739 (  180 229 ) resistor r=5.52526 //w=0.168 //l=0.115 //layer=ply \
 //thickness=0.18 //x=37.855 //y=0.94 //x2=37.97 //y2=0.94
r740 (  180 181 ) resistor r=112.809 //w=0.094 //l=0.22 //layer=ply \
 //thickness=0.18 //x=37.855 //y=0.94 //x2=37.635 //y2=0.94
r741 (  177 228 ) resistor r=37.236 //w=0.233 //l=0.249199 //layer=ply \
 //thickness=0.18 //x=37.67 //y=5.045 //x2=37.49 //y2=4.88
r742 (  175 226 ) resistor r=39.5823 //w=0.21 //l=0.173853 //layer=ply \
 //thickness=0.18 //x=37.48 //y=1.75 //x2=37.52 //y2=1.595
r743 (  175 223 ) resistor r=176.904 //w=0.094 //l=0.345 //layer=ply \
 //thickness=0.18 //x=37.48 //y=1.75 //x2=37.48 //y2=2.095
r744 (  174 226 ) resistor r=39.5823 //w=0.21 //l=0.173853 //layer=ply \
 //thickness=0.18 //x=37.48 //y=1.44 //x2=37.52 //y2=1.595
r745 (  173 225 ) resistor r=45.1352 //w=0.168 //l=0.173853 //layer=ply \
 //thickness=0.18 //x=37.48 //y=1.095 //x2=37.52 //y2=0.94
r746 (  173 174 ) resistor r=176.904 //w=0.094 //l=0.345 //layer=ply \
 //thickness=0.18 //x=37.48 //y=1.095 //x2=37.48 //y2=1.44
r747 (  170 228 ) resistor r=53.7854 //w=0.233 //l=0.332415 //layer=ply \
 //thickness=0.18 //x=37.23 //y=5.045 //x2=37.49 //y2=4.88
r748 (  169 211 ) resistor r=592.245 //w=0.094 //l=1.155 //layer=ply \
 //thickness=0.18 //x=56.91 //y=6.2 //x2=56.91 //y2=5.045
r749 (  168 204 ) resistor r=592.245 //w=0.094 //l=1.155 //layer=ply \
 //thickness=0.18 //x=56.47 //y=6.2 //x2=56.47 //y2=5.045
r750 (  167 194 ) resistor r=592.245 //w=0.094 //l=1.155 //layer=ply \
 //thickness=0.18 //x=42.48 //y=6.2 //x2=42.48 //y2=5.045
r751 (  166 187 ) resistor r=592.245 //w=0.094 //l=1.155 //layer=ply \
 //thickness=0.18 //x=42.04 //y=6.2 //x2=42.04 //y2=5.045
r752 (  165 177 ) resistor r=592.245 //w=0.094 //l=1.155 //layer=ply \
 //thickness=0.18 //x=37.67 //y=6.2 //x2=37.67 //y2=5.045
r753 (  164 170 ) resistor r=592.245 //w=0.094 //l=1.155 //layer=ply \
 //thickness=0.18 //x=37.23 //y=6.2 //x2=37.23 //y2=5.045
r754 (  163 216 ) resistor r=56.4043 //w=0.094 //l=0.11 //layer=ply \
 //thickness=0.18 //x=56.985 //y=1.595 //x2=57.095 //y2=1.595
r755 (  163 217 ) resistor r=56.4043 //w=0.094 //l=0.11 //layer=ply \
 //thickness=0.18 //x=56.985 //y=1.595 //x2=56.875 //y2=1.595
r756 (  162 199 ) resistor r=56.4043 //w=0.094 //l=0.11 //layer=ply \
 //thickness=0.18 //x=42.555 //y=1.595 //x2=42.665 //y2=1.595
r757 (  162 200 ) resistor r=56.4043 //w=0.094 //l=0.11 //layer=ply \
 //thickness=0.18 //x=42.555 //y=1.595 //x2=42.445 //y2=1.595
r758 (  161 182 ) resistor r=56.4043 //w=0.094 //l=0.11 //layer=ply \
 //thickness=0.18 //x=37.745 //y=1.595 //x2=37.855 //y2=1.595
r759 (  161 183 ) resistor r=56.4043 //w=0.094 //l=0.11 //layer=ply \
 //thickness=0.18 //x=37.745 //y=1.595 //x2=37.635 //y2=1.595
r760 (  157 248 ) resistor r=152 //w=0.17 //l=0.17 //layer=licon //count=1 \
 //x=56.73 //y=4.88 //x2=56.73 //y2=4.88
r761 (  148 242 ) resistor r=152 //w=0.17 //l=0.17 //layer=licon //count=1 \
 //x=56.73 //y=2.26 //x2=56.73 //y2=2.26
r762 (  131 255 ) resistor r=23.615 //w=0.187 //l=0.345 //layer=li \
 //thickness=0.1 //x=47.07 //y=5.56 //x2=47.07 //y2=5.905
r763 (  123 254 ) resistor r=23.615 //w=0.187 //l=0.345 //layer=li \
 //thickness=0.1 //x=46.19 //y=5.56 //x2=46.19 //y2=5.905
r764 (  115 253 ) resistor r=23.615 //w=0.187 //l=0.345 //layer=li \
 //thickness=0.1 //x=45.31 //y=5.56 //x2=45.31 //y2=5.905
r765 (  110 238 ) resistor r=152 //w=0.17 //l=0.17 //layer=licon //count=1 \
 //x=42.3 //y=4.88 //x2=42.3 //y2=4.88
r766 (  101 232 ) resistor r=152 //w=0.17 //l=0.17 //layer=licon //count=1 \
 //x=42.3 //y=2.26 //x2=42.3 //y2=2.26
r767 (  96 228 ) resistor r=152 //w=0.17 //l=0.17 //layer=licon //count=1 \
 //x=37.49 //y=4.88 //x2=37.49 //y2=4.88
r768 (  87 222 ) resistor r=152 //w=0.17 //l=0.17 //layer=licon //count=1 \
 //x=37.49 //y=2.26 //x2=37.49 //y2=2.26
r769 (  79 81 ) resistor r=0.10734 //w=0.281 //l=0.16 //layer=m2 \
 //thickness=0.36 //x=42.3 //y=3.895 //x2=42.46 //y2=3.895
r770 (  79 80 ) resistor r=0.10734 //w=0.281 //l=0.16 //layer=m2 \
 //thickness=0.36 //x=42.3 //y=3.895 //x2=42.14 //y2=3.895
r771 (  77 80 ) resistor r=4.28435 //w=0.131 //l=4.49 //layer=m2 \
 //thickness=0.36 //x=37.65 //y=3.88 //x2=42.14 //y2=3.88
r772 (  75 77 ) resistor r=0.10734 //w=0.281 //l=0.16 //layer=m2 \
 //thickness=0.36 //x=37.49 //y=3.895 //x2=37.65 //y2=3.895
r773 (  73 83 ) resistor r=1.10266 //w=0.196 //l=1.725 //layer=m2 \
 //thickness=0.36 //x=49.565 //y=3.895 //x2=47.84 //y2=3.895
r774 (  72 85 ) resistor r=4.81638 //w=0.177 //l=6.825 //layer=m2 \
 //thickness=0.36 //x=49.91 //y=3.895 //x2=56.73 //y2=3.885
r775 (  72 73 ) resistor r=0.329198 //w=0.131 //l=0.345 //layer=m2 \
 //thickness=0.36 //x=49.91 //y=3.895 //x2=49.565 //y2=3.895
r776 (  70 83 ) resistor r=0.104578 //w=0.196 //l=0.167332 //layer=m2 \
 //thickness=0.36 //x=47.68 //y=3.88 //x2=47.84 //y2=3.895
r777 (  70 81 ) resistor r=4.98092 //w=0.131 //l=5.22 //layer=m2 \
 //thickness=0.36 //x=47.68 //y=3.88 //x2=42.46 //y2=3.88
r778 (  67 157 ) resistor r=9.3 //w=0.17 //l=0.17 //layer=mcon //count=1 \
 //x=56.73 //y=4.88 //x2=56.73 //y2=4.88
r779 (  65 148 ) resistor r=9.3 //w=0.17 //l=0.17 //layer=mcon //count=1 \
 //x=56.73 //y=2.26 //x2=56.73 //y2=2.26
r780 (  63 85 ) resistor r=4.5 //w=0.15 //l=0.15 //layer=via1 //count=1 \
 //x=56.73 //y=3.885 //x2=56.73 //y2=3.885
r781 (  61 63 ) resistor r=0.00166223 //w=0.376 //l=0.005 //layer=m1 \
 //thickness=0.36 //x=56.677 //y=3.88 //x2=56.677 //y2=3.885
r782 (  59 83 ) resistor r=4.5 //w=0.15 //l=0.15 //layer=via1 //count=1 \
 //x=47.84 //y=3.895 //x2=47.84 //y2=3.895
r783 (  57 59 ) resistor r=0.00490838 //w=0.382 //l=0.015 //layer=m1 \
 //thickness=0.36 //x=47.897 //y=3.88 //x2=47.897 //y2=3.895
r784 (  55 251 ) resistor r=9.3 //w=0.17 //l=0.17 //layer=mcon //count=1 \
 //x=47.365 //y=1.19 //x2=47.365 //y2=1.19
r785 (  53 131 ) resistor r=9.3 //w=0.17 //l=0.17 //layer=mcon //count=1 \
 //x=47.07 //y=5.56 //x2=47.07 //y2=5.56
r786 (  50 123 ) resistor r=9.3 //w=0.17 //l=0.17 //layer=mcon //count=1 \
 //x=46.19 //y=5.56 //x2=46.19 //y2=5.56
r787 (  48 50 ) resistor r=0.121228 //w=0.232 //l=0.225 //layer=m1 \
 //thickness=0.36 //x=46.19 //y=5.335 //x2=46.19 //y2=5.56
r788 (  47 115 ) resistor r=9.3 //w=0.17 //l=0.17 //layer=mcon //count=1 \
 //x=45.31 //y=5.56 //x2=45.31 //y2=5.56
r789 (  45 47 ) resistor r=0.129608 //w=0.217 //l=0.225 //layer=m1 \
 //thickness=0.36 //x=45.312 //y=5.335 //x2=45.312 //y2=5.56
r790 (  44 110 ) resistor r=9.3 //w=0.17 //l=0.17 //layer=mcon //count=1 \
 //x=42.3 //y=4.88 //x2=42.3 //y2=4.88
r791 (  42 101 ) resistor r=9.3 //w=0.17 //l=0.17 //layer=mcon //count=1 \
 //x=42.3 //y=2.26 //x2=42.3 //y2=2.26
r792 (  40 79 ) resistor r=4.5 //w=0.15 //l=0.15 //layer=via1 //count=1 \
 //x=42.3 //y=3.895 //x2=42.3 //y2=3.895
r793 (  38 40 ) resistor r=0.0049867 //w=0.376 //l=0.015 //layer=m1 \
 //thickness=0.36 //x=42.247 //y=3.88 //x2=42.247 //y2=3.895
r794 (  36 75 ) resistor r=4.5 //w=0.15 //l=0.15 //layer=via1 //count=1 \
 //x=37.49 //y=3.895 //x2=37.49 //y2=3.895
r795 (  34 36 ) resistor r=0.0049867 //w=0.376 //l=0.015 //layer=m1 \
 //thickness=0.36 //x=37.542 //y=3.88 //x2=37.542 //y2=3.895
r796 (  32 96 ) resistor r=9.3 //w=0.17 //l=0.17 //layer=mcon //count=1 \
 //x=37.49 //y=4.88 //x2=37.49 //y2=4.88
r797 (  30 87 ) resistor r=9.3 //w=0.17 //l=0.17 //layer=mcon //count=1 \
 //x=37.49 //y=2.26 //x2=37.49 //y2=2.26
r798 (  28 67 ) resistor r=0.0801089 //w=0.224 //l=0.13 //layer=m1 \
 //thickness=0.36 //x=56.73 //y=4.75 //x2=56.73 //y2=4.88
r799 (  27 63 ) resistor r=0.0911593 //w=0.376 //l=0.184608 //layer=m1 \
 //thickness=0.36 //x=56.73 //y=4.045 //x2=56.677 //y2=3.885
r800 (  27 28 ) resistor r=0.67271 //w=0.131 //l=0.705 //layer=m1 \
 //thickness=0.36 //x=56.73 //y=4.045 //x2=56.73 //y2=4.75
r801 (  26 61 ) resistor r=0.0894971 //w=0.376 //l=0.179555 //layer=m1 \
 //thickness=0.36 //x=56.73 //y=3.725 //x2=56.677 //y2=3.88
r802 (  25 65 ) resistor r=0.0719237 //w=0.222 //l=0.115 //layer=m1 \
 //thickness=0.36 //x=56.73 //y=2.375 //x2=56.73 //y2=2.26
r803 (  25 26 ) resistor r=1.28817 //w=0.131 //l=1.35 //layer=m1 \
 //thickness=0.36 //x=56.73 //y=2.375 //x2=56.73 //y2=3.725
r804 (  23 59 ) resistor r=0.0914072 //w=0.382 //l=0.181989 //layer=m1 \
 //thickness=0.36 //x=47.85 //y=4.055 //x2=47.897 //y2=3.895
r805 (  23 24 ) resistor r=1.14027 //w=0.131 //l=1.195 //layer=m1 \
 //thickness=0.36 //x=47.85 //y=4.055 //x2=47.85 //y2=5.25
r806 (  22 57 ) resistor r=0.0864989 //w=0.382 //l=0.166853 //layer=m1 \
 //thickness=0.36 //x=47.85 //y=3.735 //x2=47.897 //y2=3.88
r807 (  21 22 ) resistor r=1.72233 //w=0.131 //l=1.805 //layer=m1 \
 //thickness=0.36 //x=47.85 //y=1.93 //x2=47.85 //y2=3.735
r808 (  19 21 ) resistor r=0.0698411 //w=0.17 //l=0.120208 //layer=m1 \
 //thickness=0.36 //x=47.765 //y=1.845 //x2=47.85 //y2=1.93
r809 (  19 20 ) resistor r=0.300573 //w=0.131 //l=0.315 //layer=m1 \
 //thickness=0.36 //x=47.765 //y=1.845 //x2=47.45 //y2=1.845
r810 (  18 20 ) resistor r=0.0698411 //w=0.17 //l=0.120208 //layer=m1 \
 //thickness=0.36 //x=47.365 //y=1.76 //x2=47.45 //y2=1.845
r811 (  17 55 ) resistor r=0.0717383 //w=0.224 //l=0.115 //layer=m1 \
 //thickness=0.36 //x=47.365 //y=1.305 //x2=47.365 //y2=1.19
r812 (  17 18 ) resistor r=0.43416 //w=0.131 //l=0.455 //layer=m1 \
 //thickness=0.36 //x=47.365 //y=1.305 //x2=47.365 //y2=1.76
r813 (  16 51 ) resistor r=0.0675342 //w=0.23 //l=0.115 //layer=m1 \
 //thickness=0.36 //x=47.185 //y=5.335 //x2=47.07 //y2=5.335
r814 (  15 24 ) resistor r=0.0698411 //w=0.17 //l=0.120208 //layer=m1 \
 //thickness=0.36 //x=47.765 //y=5.335 //x2=47.85 //y2=5.25
r815 (  15 16 ) resistor r=0.553435 //w=0.131 //l=0.58 //layer=m1 \
 //thickness=0.36 //x=47.765 //y=5.335 //x2=47.185 //y2=5.335
r816 (  14 53 ) resistor r=0.00118313 //w=0.23 //layer=m1 //thickness=0.36 \
 //x=47.07 //y=5.56 //x2=47.07 //y2=5.56
r817 (  13 51 ) resistor r=0.002872 //w=0.34 //l=0.085 //layer=m1 \
 //thickness=0.36 //x=47.07 //y=5.42 //x2=47.07 //y2=5.335
r818 (  13 14 ) resistor r=0.091623 //w=0.191 //l=0.14 //layer=m1 \
 //thickness=0.36 //x=47.07 //y=5.42 //x2=47.07 //y2=5.56
r819 (  12 48 ) resistor r=0.0262263 //w=0.232 //l=0.12 //layer=m1 \
 //thickness=0.36 //x=46.31 //y=5.335 //x2=46.19 //y2=5.335
r820 (  11 51 ) resistor r=0.0675342 //w=0.23 //l=0.115 //layer=m1 \
 //thickness=0.36 //x=46.955 //y=5.335 //x2=47.07 //y2=5.335
r821 (  11 12 ) resistor r=0.615458 //w=0.131 //l=0.645 //layer=m1 \
 //thickness=0.36 //x=46.955 //y=5.335 //x2=46.31 //y2=5.335
r822 (  10 45 ) resistor r=0.0222262 //w=0.217 //l=0.118 //layer=m1 \
 //thickness=0.36 //x=45.43 //y=5.335 //x2=45.312 //y2=5.335
r823 (  9 48 ) resistor r=0.0262263 //w=0.232 //l=0.12 //layer=m1 \
 //thickness=0.36 //x=46.07 //y=5.335 //x2=46.19 //y2=5.335
r824 (  9 10 ) resistor r=0.610687 //w=0.131 //l=0.64 //layer=m1 \
 //thickness=0.36 //x=46.07 //y=5.335 //x2=45.43 //y2=5.335
r825 (  8 44 ) resistor r=0.0801089 //w=0.224 //l=0.13 //layer=m1 \
 //thickness=0.36 //x=42.3 //y=4.75 //x2=42.3 //y2=4.88
r826 (  7 40 ) resistor r=0.0911593 //w=0.376 //l=0.184608 //layer=m1 \
 //thickness=0.36 //x=42.3 //y=4.055 //x2=42.247 //y2=3.895
r827 (  7 8 ) resistor r=0.663168 //w=0.131 //l=0.695 //layer=m1 \
 //thickness=0.36 //x=42.3 //y=4.055 //x2=42.3 //y2=4.75
r828 (  6 38 ) resistor r=0.0861726 //w=0.376 //l=0.16944 //layer=m1 \
 //thickness=0.36 //x=42.3 //y=3.735 //x2=42.247 //y2=3.88
r829 (  5 42 ) resistor r=0.0719237 //w=0.222 //l=0.115 //layer=m1 \
 //thickness=0.36 //x=42.3 //y=2.375 //x2=42.3 //y2=2.26
r830 (  5 6 ) resistor r=1.29771 //w=0.131 //l=1.36 //layer=m1 \
 //thickness=0.36 //x=42.3 //y=2.375 //x2=42.3 //y2=3.735
r831 (  4 32 ) resistor r=0.0801089 //w=0.224 //l=0.13 //layer=m1 \
 //thickness=0.36 //x=37.49 //y=4.75 //x2=37.49 //y2=4.88
r832 (  3 36 ) resistor r=0.0911593 //w=0.376 //l=0.184174 //layer=m1 \
 //thickness=0.36 //x=37.49 //y=4.055 //x2=37.542 //y2=3.895
r833 (  3 4 ) resistor r=0.663168 //w=0.131 //l=0.695 //layer=m1 \
 //thickness=0.36 //x=37.49 //y=4.055 //x2=37.49 //y2=4.75
r834 (  2 34 ) resistor r=0.0861726 //w=0.376 //l=0.169012 //layer=m1 \
 //thickness=0.36 //x=37.49 //y=3.735 //x2=37.542 //y2=3.88
r835 (  1 30 ) resistor r=0.0719237 //w=0.222 //l=0.115 //layer=m1 \
 //thickness=0.36 //x=37.49 //y=2.375 //x2=37.49 //y2=2.26
r836 (  1 2 ) resistor r=1.29771 //w=0.131 //l=1.36 //layer=m1 \
 //thickness=0.36 //x=37.49 //y=2.375 //x2=37.49 //y2=3.735
ends PM_TMRDFFSNRNQNX1\%noxref_10

subckt PM_TMRDFFSNRNQNX1\%noxref_11 ( 1 2 3 4 5 7 10 11 13 14 15 16 18 19 20 \
 28 29 32 35 43 44 46 51 55 64 69 77 85 101 102 103 107 108 109 114 116 119 \
 120 122 123 128 131 133 134 135 )
c323 ( 131 0 ) capacitor c=0.00885916f //x=56.795 //y=1.095
c324 ( 128 0 ) capacitor c=0.0710579f //x=51.92 //y=4.88
c325 ( 123 0 ) capacitor c=0.0278202f //x=51.92 //y=2.095
c326 ( 122 0 ) capacitor c=0.0467713f //x=51.92 //y=2.26
c327 ( 120 0 ) capacitor c=0.0443175f //x=52.44 //y=1.44
c328 ( 119 0 ) capacitor c=0.0199703f //x=52.44 //y=1.095
c329 ( 116 0 ) capacitor c=0.0161662f //x=52.285 //y=1.595
c330 ( 114 0 ) capacitor c=0.0157807f //x=52.285 //y=0.94
c331 ( 109 0 ) capacitor c=0.0220935f //x=51.91 //y=1.75
c332 ( 108 0 ) capacitor c=0.0207489f //x=51.91 //y=1.44
c333 ( 107 0 ) capacitor c=0.0194091f //x=51.91 //y=1.095
c334 ( 103 0 ) capacitor c=0.159671f //x=52.1 //y=6.2
c335 ( 102 0 ) capacitor c=0.110208f //x=51.66 //y=6.2
c336 ( 85 0 ) capacitor c=0.0293719f //x=56.69 //y=5.56
c337 ( 77 0 ) capacitor c=0.0292879f //x=55.81 //y=5.56
c338 ( 69 0 ) capacitor c=0.0278099f //x=54.93 //y=5.56
c339 ( 64 0 ) capacitor c=7.7417e-19 //x=51.92 //y=4.88
c340 ( 55 0 ) capacitor c=7.43216e-19 //x=51.92 //y=2.26
c341 ( 51 0 ) capacitor c=8.6381e-19 //x=52.075 //y=2.755
c342 ( 46 0 ) capacitor c=0.0152787f //x=55.835 //y=2.76
c343 ( 44 0 ) capacitor c=0.0298676f //x=55.235 //y=2.77
c344 ( 43 0 ) capacitor c=0.0144376f //x=57.47 //y=2.77
c345 ( 35 0 ) capacitor c=0.00157269f //x=56.69 //y=5.335
c346 ( 32 0 ) capacitor c=0.00788163f //x=55.81 //y=5.335
c347 ( 29 0 ) capacitor c=0.0102231f //x=54.932 //y=5.335
c348 ( 28 0 ) capacitor c=0.0151653f //x=51.92 //y=2.77
c349 ( 20 0 ) capacitor c=0.0616977f //x=57.47 //y=5.25
c350 ( 19 0 ) capacitor c=0.0128917f //x=57.47 //y=2.915
c351 ( 18 0 ) capacitor c=0.0177867f //x=57.47 //y=2.595
c352 ( 16 0 ) capacitor c=0.00493487f //x=57.07 //y=1.845
c353 ( 15 0 ) capacitor c=0.0125086f //x=57.385 //y=1.845
c354 ( 14 0 ) capacitor c=0.0167992f //x=56.985 //y=1.76
c355 ( 13 0 ) capacitor c=0.0112869f //x=56.985 //y=1.305
c356 ( 11 0 ) capacitor c=0.026208f //x=57.385 //y=5.335
c357 ( 10 0 ) capacitor c=0.00933983f //x=56.69 //y=5.56
c358 ( 7 0 ) capacitor c=0.0162372f //x=56.575 //y=5.335
c359 ( 5 0 ) capacitor c=0.0161143f //x=55.69 //y=5.335
c360 ( 4 0 ) capacitor c=0.0480934f //x=51.92 //y=4.75
c361 ( 3 0 ) capacitor c=0.01262f //x=51.92 //y=2.915
c362 ( 2 0 ) capacitor c=0.00283249f //x=51.92 //y=2.595
c363 ( 1 0 ) capacitor c=0.00514953f //x=51.92 //y=2.375
r364 (  122 123 ) resistor r=52.7279 //w=0.214 //l=0.165 //layer=ply \
 //thickness=0.18 //x=51.92 //y=2.26 //x2=51.92 //y2=2.095
r365 (  120 130 ) resistor r=45.1352 //w=0.168 //l=0.173853 //layer=ply \
 //thickness=0.18 //x=52.44 //y=1.44 //x2=52.4 //y2=1.595
r366 (  119 129 ) resistor r=45.1352 //w=0.168 //l=0.173853 //layer=ply \
 //thickness=0.18 //x=52.44 //y=1.095 //x2=52.4 //y2=0.94
r367 (  119 120 ) resistor r=176.904 //w=0.094 //l=0.345 //layer=ply \
 //thickness=0.18 //x=52.44 //y=1.095 //x2=52.44 //y2=1.44
r368 (  117 126 ) resistor r=10.701 //w=0.21 //l=0.115 //layer=ply \
 //thickness=0.18 //x=52.065 //y=1.595 //x2=51.95 //y2=1.595
r369 (  116 130 ) resistor r=5.52526 //w=0.168 //l=0.115 //layer=ply \
 //thickness=0.18 //x=52.285 //y=1.595 //x2=52.4 //y2=1.595
r370 (  115 125 ) resistor r=5.52526 //w=0.168 //l=0.115 //layer=ply \
 //thickness=0.18 //x=52.065 //y=0.94 //x2=51.95 //y2=0.94
r371 (  114 129 ) resistor r=5.52526 //w=0.168 //l=0.115 //layer=ply \
 //thickness=0.18 //x=52.285 //y=0.94 //x2=52.4 //y2=0.94
r372 (  114 115 ) resistor r=112.809 //w=0.094 //l=0.22 //layer=ply \
 //thickness=0.18 //x=52.285 //y=0.94 //x2=52.065 //y2=0.94
r373 (  111 128 ) resistor r=37.236 //w=0.233 //l=0.249199 //layer=ply \
 //thickness=0.18 //x=52.1 //y=5.045 //x2=51.92 //y2=4.88
r374 (  109 126 ) resistor r=39.5823 //w=0.21 //l=0.173853 //layer=ply \
 //thickness=0.18 //x=51.91 //y=1.75 //x2=51.95 //y2=1.595
r375 (  109 123 ) resistor r=176.904 //w=0.094 //l=0.345 //layer=ply \
 //thickness=0.18 //x=51.91 //y=1.75 //x2=51.91 //y2=2.095
r376 (  108 126 ) resistor r=39.5823 //w=0.21 //l=0.173853 //layer=ply \
 //thickness=0.18 //x=51.91 //y=1.44 //x2=51.95 //y2=1.595
r377 (  107 125 ) resistor r=45.1352 //w=0.168 //l=0.173853 //layer=ply \
 //thickness=0.18 //x=51.91 //y=1.095 //x2=51.95 //y2=0.94
r378 (  107 108 ) resistor r=176.904 //w=0.094 //l=0.345 //layer=ply \
 //thickness=0.18 //x=51.91 //y=1.095 //x2=51.91 //y2=1.44
r379 (  104 128 ) resistor r=53.7854 //w=0.233 //l=0.332415 //layer=ply \
 //thickness=0.18 //x=51.66 //y=5.045 //x2=51.92 //y2=4.88
r380 (  103 111 ) resistor r=592.245 //w=0.094 //l=1.155 //layer=ply \
 //thickness=0.18 //x=52.1 //y=6.2 //x2=52.1 //y2=5.045
r381 (  102 104 ) resistor r=592.245 //w=0.094 //l=1.155 //layer=ply \
 //thickness=0.18 //x=51.66 //y=6.2 //x2=51.66 //y2=5.045
r382 (  101 116 ) resistor r=56.4043 //w=0.094 //l=0.11 //layer=ply \
 //thickness=0.18 //x=52.175 //y=1.595 //x2=52.285 //y2=1.595
r383 (  101 117 ) resistor r=56.4043 //w=0.094 //l=0.11 //layer=ply \
 //thickness=0.18 //x=52.175 //y=1.595 //x2=52.065 //y2=1.595
r384 (  85 135 ) resistor r=23.615 //w=0.187 //l=0.345 //layer=li \
 //thickness=0.1 //x=56.69 //y=5.56 //x2=56.69 //y2=5.905
r385 (  77 134 ) resistor r=23.615 //w=0.187 //l=0.345 //layer=li \
 //thickness=0.1 //x=55.81 //y=5.56 //x2=55.81 //y2=5.905
r386 (  69 133 ) resistor r=23.615 //w=0.187 //l=0.345 //layer=li \
 //thickness=0.1 //x=54.93 //y=5.56 //x2=54.93 //y2=5.905
r387 (  64 128 ) resistor r=152 //w=0.17 //l=0.17 //layer=licon //count=1 \
 //x=51.92 //y=4.88 //x2=51.92 //y2=4.88
r388 (  55 122 ) resistor r=152 //w=0.17 //l=0.17 //layer=licon //count=1 \
 //x=51.92 //y=2.26 //x2=51.92 //y2=2.26
r389 (  49 51 ) resistor r=0.10734 //w=0.281 //l=0.16 //layer=m2 \
 //thickness=0.36 //x=51.915 //y=2.755 //x2=52.075 //y2=2.755
r390 (  46 53 ) resistor r=1.04013 //w=0.197 //l=1.6375 //layer=m2 \
 //thickness=0.36 //x=55.835 //y=2.76 //x2=57.47 //y2=2.755
r391 (  46 47 ) resistor r=0.410305 //w=0.131 //l=0.43 //layer=m2 \
 //thickness=0.36 //x=55.835 //y=2.76 //x2=55.405 //y2=2.76
r392 (  44 47 ) resistor r=0.125 //w=0.17 //l=0.174929 //layer=m2 \
 //thickness=0.36 //x=55.235 //y=2.77 //x2=55.405 //y2=2.76
r393 (  44 51 ) resistor r=3.01527 //w=0.131 //l=3.16 //layer=m2 \
 //thickness=0.36 //x=55.235 //y=2.77 //x2=52.075 //y2=2.77
r394 (  41 53 ) resistor r=4.5 //w=0.15 //l=0.15 //layer=via1 //count=1 \
 //x=57.47 //y=2.755 //x2=57.47 //y2=2.755
r395 (  41 43 ) resistor r=0.0049867 //w=0.376 //l=0.015 //layer=m1 \
 //thickness=0.36 //x=57.417 //y=2.755 //x2=57.417 //y2=2.77
r396 (  39 131 ) resistor r=9.3 //w=0.17 //l=0.17 //layer=mcon //count=1 \
 //x=56.985 //y=1.19 //x2=56.985 //y2=1.19
r397 (  37 85 ) resistor r=9.3 //w=0.17 //l=0.17 //layer=mcon //count=1 \
 //x=56.69 //y=5.56 //x2=56.69 //y2=5.56
r398 (  34 77 ) resistor r=9.3 //w=0.17 //l=0.17 //layer=mcon //count=1 \
 //x=55.81 //y=5.56 //x2=55.81 //y2=5.56
r399 (  32 34 ) resistor r=0.121228 //w=0.232 //l=0.225 //layer=m1 \
 //thickness=0.36 //x=55.81 //y=5.335 //x2=55.81 //y2=5.56
r400 (  31 69 ) resistor r=9.3 //w=0.17 //l=0.17 //layer=mcon //count=1 \
 //x=54.93 //y=5.56 //x2=54.93 //y2=5.56
r401 (  29 31 ) resistor r=0.129608 //w=0.217 //l=0.225 //layer=m1 \
 //thickness=0.36 //x=54.932 //y=5.335 //x2=54.932 //y2=5.56
r402 (  26 49 ) resistor r=4.5 //w=0.15 //l=0.15 //layer=via1 //count=1 \
 //x=51.915 //y=2.755 //x2=51.915 //y2=2.755
r403 (  26 28 ) resistor r=0.00494723 //w=0.379 //l=0.015 //layer=m1 \
 //thickness=0.36 //x=51.97 //y=2.755 //x2=51.97 //y2=2.77
r404 (  24 64 ) resistor r=9.3 //w=0.17 //l=0.17 //layer=mcon //count=1 \
 //x=51.92 //y=4.88 //x2=51.92 //y2=4.88
r405 (  22 55 ) resistor r=9.3 //w=0.17 //l=0.17 //layer=mcon //count=1 \
 //x=51.92 //y=2.26 //x2=51.92 //y2=2.26
r406 (  19 43 ) resistor r=0.0861726 //w=0.376 //l=0.16944 //layer=m1 \
 //thickness=0.36 //x=57.47 //y=2.915 //x2=57.417 //y2=2.77
r407 (  19 20 ) resistor r=2.22805 //w=0.131 //l=2.335 //layer=m1 \
 //thickness=0.36 //x=57.47 //y=2.915 //x2=57.47 //y2=5.25
r408 (  18 41 ) resistor r=0.0911593 //w=0.376 //l=0.184608 //layer=m1 \
 //thickness=0.36 //x=57.47 //y=2.595 //x2=57.417 //y2=2.755
r409 (  17 18 ) resistor r=0.634542 //w=0.131 //l=0.665 //layer=m1 \
 //thickness=0.36 //x=57.47 //y=1.93 //x2=57.47 //y2=2.595
r410 (  15 17 ) resistor r=0.0698411 //w=0.17 //l=0.120208 //layer=m1 \
 //thickness=0.36 //x=57.385 //y=1.845 //x2=57.47 //y2=1.93
r411 (  15 16 ) resistor r=0.300573 //w=0.131 //l=0.315 //layer=m1 \
 //thickness=0.36 //x=57.385 //y=1.845 //x2=57.07 //y2=1.845
r412 (  14 16 ) resistor r=0.0698411 //w=0.17 //l=0.120208 //layer=m1 \
 //thickness=0.36 //x=56.985 //y=1.76 //x2=57.07 //y2=1.845
r413 (  13 39 ) resistor r=0.0717383 //w=0.224 //l=0.115 //layer=m1 \
 //thickness=0.36 //x=56.985 //y=1.305 //x2=56.985 //y2=1.19
r414 (  13 14 ) resistor r=0.43416 //w=0.131 //l=0.455 //layer=m1 \
 //thickness=0.36 //x=56.985 //y=1.305 //x2=56.985 //y2=1.76
r415 (  12 35 ) resistor r=0.0675342 //w=0.23 //l=0.115 //layer=m1 \
 //thickness=0.36 //x=56.805 //y=5.335 //x2=56.69 //y2=5.335
r416 (  11 20 ) resistor r=0.0698411 //w=0.17 //l=0.120208 //layer=m1 \
 //thickness=0.36 //x=57.385 //y=5.335 //x2=57.47 //y2=5.25
r417 (  11 12 ) resistor r=0.553435 //w=0.131 //l=0.58 //layer=m1 \
 //thickness=0.36 //x=57.385 //y=5.335 //x2=56.805 //y2=5.335
r418 (  10 37 ) resistor r=0.00118313 //w=0.23 //layer=m1 //thickness=0.36 \
 //x=56.69 //y=5.56 //x2=56.69 //y2=5.56
r419 (  9 35 ) resistor r=0.002872 //w=0.34 //l=0.085 //layer=m1 \
 //thickness=0.36 //x=56.69 //y=5.42 //x2=56.69 //y2=5.335
r420 (  9 10 ) resistor r=0.091623 //w=0.191 //l=0.14 //layer=m1 \
 //thickness=0.36 //x=56.69 //y=5.42 //x2=56.69 //y2=5.56
r421 (  8 32 ) resistor r=0.0262263 //w=0.232 //l=0.12 //layer=m1 \
 //thickness=0.36 //x=55.93 //y=5.335 //x2=55.81 //y2=5.335
r422 (  7 35 ) resistor r=0.0675342 //w=0.23 //l=0.115 //layer=m1 \
 //thickness=0.36 //x=56.575 //y=5.335 //x2=56.69 //y2=5.335
r423 (  7 8 ) resistor r=0.615458 //w=0.131 //l=0.645 //layer=m1 \
 //thickness=0.36 //x=56.575 //y=5.335 //x2=55.93 //y2=5.335
r424 (  6 29 ) resistor r=0.0222262 //w=0.217 //l=0.118 //layer=m1 \
 //thickness=0.36 //x=55.05 //y=5.335 //x2=54.932 //y2=5.335
r425 (  5 32 ) resistor r=0.0262263 //w=0.232 //l=0.12 //layer=m1 \
 //thickness=0.36 //x=55.69 //y=5.335 //x2=55.81 //y2=5.335
r426 (  5 6 ) resistor r=0.610687 //w=0.131 //l=0.64 //layer=m1 \
 //thickness=0.36 //x=55.69 //y=5.335 //x2=55.05 //y2=5.335
r427 (  4 24 ) resistor r=0.0801089 //w=0.224 //l=0.13 //layer=m1 \
 //thickness=0.36 //x=51.92 //y=4.75 //x2=51.92 //y2=4.88
r428 (  3 28 ) resistor r=0.0863342 //w=0.379 //l=0.168152 //layer=m1 \
 //thickness=0.36 //x=51.92 //y=2.915 //x2=51.97 //y2=2.77
r429 (  3 4 ) resistor r=1.75095 //w=0.131 //l=1.835 //layer=m1 \
 //thickness=0.36 //x=51.92 //y=2.915 //x2=51.92 //y2=4.75
r430 (  2 26 ) resistor r=0.0912814 //w=0.379 //l=0.183303 //layer=m1 \
 //thickness=0.36 //x=51.92 //y=2.595 //x2=51.97 //y2=2.755
r431 (  1 22 ) resistor r=0.0719237 //w=0.222 //l=0.115 //layer=m1 \
 //thickness=0.36 //x=51.92 //y=2.375 //x2=51.92 //y2=2.26
r432 (  1 2 ) resistor r=0.209924 //w=0.131 //l=0.22 //layer=m1 \
 //thickness=0.36 //x=51.92 //y=2.375 //x2=51.92 //y2=2.595
ends PM_TMRDFFSNRNQNX1\%noxref_11

subckt PM_TMRDFFSNRNQNX1\%D ( 1 2 3 4 5 6 7 8 9 10 11 12 13 14 15 22 23 25 30 \
 31 32 36 37 62 64 66 68 70 72 74 76 77 78 80 82 84 86 91 97 106 111 120 125 \
 134 138 139 140 141 142 143 144 145 146 147 148 149 150 151 153 159 160 161 \
 162 166 167 168 169 170 172 178 179 180 181 185 186 187 188 189 191 197 198 \
 199 200 )
c550 ( 200 0 ) capacitor c=0.0573033f //x=59.595 //y=4.97
c551 ( 199 0 ) capacitor c=0.0376642f //x=59.885 //y=4.97
c552 ( 198 0 ) capacitor c=0.0346489f //x=59.55 //y=1.4
c553 ( 197 0 ) capacitor c=0.018692f //x=59.55 //y=1.055
c554 ( 191 0 ) capacitor c=0.0137077f //x=59.395 //y=1.555
c555 ( 189 0 ) capacitor c=0.0158585f //x=59.395 //y=0.9
c556 ( 188 0 ) capacitor c=0.103534f //x=59.02 //y=2.095
c557 ( 187 0 ) capacitor c=0.0229444f //x=59.02 //y=1.71
c558 ( 186 0 ) capacitor c=0.0234359f //x=59.02 //y=1.4
c559 ( 185 0 ) capacitor c=0.019815f //x=59.02 //y=1.055
c560 ( 181 0 ) capacitor c=0.0553409f //x=30.735 //y=4.97
c561 ( 180 0 ) capacitor c=0.0376642f //x=31.025 //y=4.97
c562 ( 179 0 ) capacitor c=0.0346489f //x=30.69 //y=1.4
c563 ( 178 0 ) capacitor c=0.018692f //x=30.69 //y=1.055
c564 ( 172 0 ) capacitor c=0.0137077f //x=30.535 //y=1.555
c565 ( 170 0 ) capacitor c=0.0158585f //x=30.535 //y=0.9
c566 ( 169 0 ) capacitor c=0.103534f //x=30.16 //y=2.095
c567 ( 168 0 ) capacitor c=0.0229444f //x=30.16 //y=1.71
c568 ( 167 0 ) capacitor c=0.0234359f //x=30.16 //y=1.4
c569 ( 166 0 ) capacitor c=0.019815f //x=30.16 //y=1.055
c570 ( 162 0 ) capacitor c=0.0571086f //x=1.875 //y=4.97
c571 ( 161 0 ) capacitor c=0.0376642f //x=2.165 //y=4.97
c572 ( 160 0 ) capacitor c=0.0346489f //x=1.83 //y=1.4
c573 ( 159 0 ) capacitor c=0.018692f //x=1.83 //y=1.055
c574 ( 153 0 ) capacitor c=0.0137077f //x=1.675 //y=1.555
c575 ( 151 0 ) capacitor c=0.0158585f //x=1.675 //y=0.9
c576 ( 150 0 ) capacitor c=0.103534f //x=1.3 //y=2.095
c577 ( 149 0 ) capacitor c=0.0229444f //x=1.3 //y=1.71
c578 ( 148 0 ) capacitor c=0.0234359f //x=1.3 //y=1.4
c579 ( 147 0 ) capacitor c=0.019815f //x=1.3 //y=1.055
c580 ( 146 0 ) capacitor c=0.110208f //x=59.96 //y=6.2
c581 ( 145 0 ) capacitor c=0.158957f //x=59.52 //y=6.2
c582 ( 144 0 ) capacitor c=0.110208f //x=31.1 //y=6.2
c583 ( 143 0 ) capacitor c=0.158957f //x=30.66 //y=6.2
c584 ( 142 0 ) capacitor c=0.110208f //x=2.24 //y=6.2
c585 ( 141 0 ) capacitor c=0.158957f //x=1.8 //y=6.2
c586 ( 134 0 ) capacitor c=0.00120653f //x=59.32 //y=4.88
c587 ( 125 0 ) capacitor c=0.0012618f //x=59.32 //y=2.26
c588 ( 120 0 ) capacitor c=0.00132168f //x=30.46 //y=4.88
c589 ( 111 0 ) capacitor c=0.0012618f //x=30.46 //y=2.26
c590 ( 106 0 ) capacitor c=0.00120653f //x=1.6 //y=4.88
c591 ( 97 0 ) capacitor c=0.0012618f //x=1.6 //y=2.26
c592 ( 91 0 ) capacitor c=0.0118755f //x=1.76 //y=4.255
c593 ( 86 0 ) capacitor c=0.0270345f //x=56.945 //y=4.27
c594 ( 84 0 ) capacitor c=0.0817592f //x=56.345 //y=4.25
c595 ( 82 0 ) capacitor c=0.00430603f //x=48.055 //y=4.28
c596 ( 80 0 ) capacitor c=0.0484368f //x=47.455 //y=4.25
c597 ( 78 0 ) capacitor c=0.00438783f //x=42.52 //y=4.31
c598 ( 77 0 ) capacitor c=0.115399f //x=37.36 //y=4.28
c599 ( 76 0 ) capacitor c=0.045697f //x=37.71 //y=4.28
c600 ( 74 0 ) capacitor c=0.00130957f //x=28.09 //y=4.27
c601 ( 72 0 ) capacitor c=0.0806645f //x=27.485 //y=4.25
c602 ( 70 0 ) capacitor c=0.00430603f //x=19.195 //y=4.28
c603 ( 68 0 ) capacitor c=0.0486924f //x=18.595 //y=4.25
c604 ( 66 0 ) capacitor c=0.00434239f //x=13.655 //y=4.31
c605 ( 64 0 ) capacitor c=0.045907f //x=8.845 //y=4.28
c606 ( 62 0 ) capacitor c=0.182353f //x=8.245 //y=4.25
c607 ( 37 0 ) capacitor c=0.0145042f //x=59.32 //y=4.755
c608 ( 36 0 ) capacitor c=0.0126596f //x=59.32 //y=4.395
c609 ( 32 0 ) capacitor c=0.00493485f //x=59.32 //y=2.375
c610 ( 31 0 ) capacitor c=0.0116931f //x=30.46 //y=4.755
c611 ( 30 0 ) capacitor c=0.0126796f //x=30.46 //y=4.395
c612 ( 25 0 ) capacitor c=0.00493485f //x=30.46 //y=2.375
c613 ( 23 0 ) capacitor c=0.010934f //x=1.6 //y=4.755
c614 ( 22 0 ) capacitor c=0.0204514f //x=1.6 //y=4.415
c615 ( 15 0 ) capacitor c=0.0113082f //x=1.6 //y=2.375
c616 ( 14 0 ) capacitor c=0.0148084f //x=59.32 //y=4.25
c617 ( 13 0 ) capacitor c=0.0148084f //x=30.46 //y=4.25
c618 ( 12 0 ) capacitor c=0.0158298f //x=1.6 //y=4.25
c619 ( 10 0 ) capacitor c=0.0495713f //x=59.32 //y=2.77
c620 ( 7 0 ) capacitor c=0.0516076f //x=30.46 //y=2.77
c621 ( 6 0 ) capacitor c=0.0130702f //x=1.6 //y=4.62
c622 ( 1 0 ) capacitor c=0.0853296f //x=1.6 //y=2.4
r623 (  199 201 ) resistor r=26.9307 //w=0.15 //l=0.106066 //layer=ply \
 //thickness=0.18 //x=59.885 //y=4.97 //x2=59.96 //y2=5.045
r624 (  199 200 ) resistor r=148.702 //w=0.094 //l=0.29 //layer=ply \
 //thickness=0.18 //x=59.885 //y=4.97 //x2=59.595 //y2=4.97
r625 (  198 227 ) resistor r=45.1352 //w=0.168 //l=0.173853 //layer=ply \
 //thickness=0.18 //x=59.55 //y=1.4 //x2=59.51 //y2=1.555
r626 (  197 226 ) resistor r=45.1352 //w=0.168 //l=0.173853 //layer=ply \
 //thickness=0.18 //x=59.55 //y=1.055 //x2=59.51 //y2=0.9
r627 (  197 198 ) resistor r=176.904 //w=0.094 //l=0.345 //layer=ply \
 //thickness=0.18 //x=59.55 //y=1.055 //x2=59.55 //y2=1.4
r628 (  194 200 ) resistor r=22.7971 //w=0.269 //l=0.106066 //layer=ply \
 //thickness=0.18 //x=59.52 //y=5.045 //x2=59.595 //y2=4.97
r629 (  194 225 ) resistor r=35.8364 //w=0.269 //l=0.270185 //layer=ply \
 //thickness=0.18 //x=59.52 //y=5.045 //x2=59.32 //y2=4.88
r630 (  192 221 ) resistor r=10.701 //w=0.21 //l=0.115 //layer=ply \
 //thickness=0.18 //x=59.175 //y=1.555 //x2=59.06 //y2=1.555
r631 (  191 227 ) resistor r=5.52526 //w=0.168 //l=0.115 //layer=ply \
 //thickness=0.18 //x=59.395 //y=1.555 //x2=59.51 //y2=1.555
r632 (  190 220 ) resistor r=5.52526 //w=0.168 //l=0.115 //layer=ply \
 //thickness=0.18 //x=59.175 //y=0.9 //x2=59.06 //y2=0.9
r633 (  189 226 ) resistor r=5.52526 //w=0.168 //l=0.115 //layer=ply \
 //thickness=0.18 //x=59.395 //y=0.9 //x2=59.51 //y2=0.9
r634 (  189 190 ) resistor r=112.809 //w=0.094 //l=0.22 //layer=ply \
 //thickness=0.18 //x=59.395 //y=0.9 //x2=59.175 //y2=0.9
r635 (  188 223 ) resistor r=58.7805 //w=0.246 //l=0.373497 //layer=ply \
 //thickness=0.18 //x=59.02 //y=2.095 //x2=59.32 //y2=2.26
r636 (  187 221 ) resistor r=39.5823 //w=0.21 //l=0.173853 //layer=ply \
 //thickness=0.18 //x=59.02 //y=1.71 //x2=59.06 //y2=1.555
r637 (  187 188 ) resistor r=197.415 //w=0.094 //l=0.385 //layer=ply \
 //thickness=0.18 //x=59.02 //y=1.71 //x2=59.02 //y2=2.095
r638 (  186 221 ) resistor r=39.5823 //w=0.21 //l=0.173853 //layer=ply \
 //thickness=0.18 //x=59.02 //y=1.4 //x2=59.06 //y2=1.555
r639 (  185 220 ) resistor r=45.1352 //w=0.168 //l=0.173853 //layer=ply \
 //thickness=0.18 //x=59.02 //y=1.055 //x2=59.06 //y2=0.9
r640 (  185 186 ) resistor r=176.904 //w=0.094 //l=0.345 //layer=ply \
 //thickness=0.18 //x=59.02 //y=1.055 //x2=59.02 //y2=1.4
r641 (  180 182 ) resistor r=26.9307 //w=0.15 //l=0.106066 //layer=ply \
 //thickness=0.18 //x=31.025 //y=4.97 //x2=31.1 //y2=5.045
r642 (  180 181 ) resistor r=148.702 //w=0.094 //l=0.29 //layer=ply \
 //thickness=0.18 //x=31.025 //y=4.97 //x2=30.735 //y2=4.97
r643 (  179 219 ) resistor r=45.1352 //w=0.168 //l=0.173853 //layer=ply \
 //thickness=0.18 //x=30.69 //y=1.4 //x2=30.65 //y2=1.555
r644 (  178 218 ) resistor r=45.1352 //w=0.168 //l=0.173853 //layer=ply \
 //thickness=0.18 //x=30.69 //y=1.055 //x2=30.65 //y2=0.9
r645 (  178 179 ) resistor r=176.904 //w=0.094 //l=0.345 //layer=ply \
 //thickness=0.18 //x=30.69 //y=1.055 //x2=30.69 //y2=1.4
r646 (  175 181 ) resistor r=22.7971 //w=0.269 //l=0.106066 //layer=ply \
 //thickness=0.18 //x=30.66 //y=5.045 //x2=30.735 //y2=4.97
r647 (  175 217 ) resistor r=35.8364 //w=0.269 //l=0.270185 //layer=ply \
 //thickness=0.18 //x=30.66 //y=5.045 //x2=30.46 //y2=4.88
r648 (  173 213 ) resistor r=10.701 //w=0.21 //l=0.115 //layer=ply \
 //thickness=0.18 //x=30.315 //y=1.555 //x2=30.2 //y2=1.555
r649 (  172 219 ) resistor r=5.52526 //w=0.168 //l=0.115 //layer=ply \
 //thickness=0.18 //x=30.535 //y=1.555 //x2=30.65 //y2=1.555
r650 (  171 212 ) resistor r=5.52526 //w=0.168 //l=0.115 //layer=ply \
 //thickness=0.18 //x=30.315 //y=0.9 //x2=30.2 //y2=0.9
r651 (  170 218 ) resistor r=5.52526 //w=0.168 //l=0.115 //layer=ply \
 //thickness=0.18 //x=30.535 //y=0.9 //x2=30.65 //y2=0.9
r652 (  170 171 ) resistor r=112.809 //w=0.094 //l=0.22 //layer=ply \
 //thickness=0.18 //x=30.535 //y=0.9 //x2=30.315 //y2=0.9
r653 (  169 215 ) resistor r=58.7805 //w=0.246 //l=0.373497 //layer=ply \
 //thickness=0.18 //x=30.16 //y=2.095 //x2=30.46 //y2=2.26
r654 (  168 213 ) resistor r=39.5823 //w=0.21 //l=0.173853 //layer=ply \
 //thickness=0.18 //x=30.16 //y=1.71 //x2=30.2 //y2=1.555
r655 (  168 169 ) resistor r=197.415 //w=0.094 //l=0.385 //layer=ply \
 //thickness=0.18 //x=30.16 //y=1.71 //x2=30.16 //y2=2.095
r656 (  167 213 ) resistor r=39.5823 //w=0.21 //l=0.173853 //layer=ply \
 //thickness=0.18 //x=30.16 //y=1.4 //x2=30.2 //y2=1.555
r657 (  166 212 ) resistor r=45.1352 //w=0.168 //l=0.173853 //layer=ply \
 //thickness=0.18 //x=30.16 //y=1.055 //x2=30.2 //y2=0.9
r658 (  166 167 ) resistor r=176.904 //w=0.094 //l=0.345 //layer=ply \
 //thickness=0.18 //x=30.16 //y=1.055 //x2=30.16 //y2=1.4
r659 (  161 163 ) resistor r=26.9307 //w=0.15 //l=0.106066 //layer=ply \
 //thickness=0.18 //x=2.165 //y=4.97 //x2=2.24 //y2=5.045
r660 (  161 162 ) resistor r=148.702 //w=0.094 //l=0.29 //layer=ply \
 //thickness=0.18 //x=2.165 //y=4.97 //x2=1.875 //y2=4.97
r661 (  160 211 ) resistor r=45.1352 //w=0.168 //l=0.173853 //layer=ply \
 //thickness=0.18 //x=1.83 //y=1.4 //x2=1.79 //y2=1.555
r662 (  159 210 ) resistor r=45.1352 //w=0.168 //l=0.173853 //layer=ply \
 //thickness=0.18 //x=1.83 //y=1.055 //x2=1.79 //y2=0.9
r663 (  159 160 ) resistor r=176.904 //w=0.094 //l=0.345 //layer=ply \
 //thickness=0.18 //x=1.83 //y=1.055 //x2=1.83 //y2=1.4
r664 (  156 162 ) resistor r=22.7971 //w=0.269 //l=0.106066 //layer=ply \
 //thickness=0.18 //x=1.8 //y=5.045 //x2=1.875 //y2=4.97
r665 (  156 209 ) resistor r=35.8364 //w=0.269 //l=0.270185 //layer=ply \
 //thickness=0.18 //x=1.8 //y=5.045 //x2=1.6 //y2=4.88
r666 (  154 205 ) resistor r=10.701 //w=0.21 //l=0.115 //layer=ply \
 //thickness=0.18 //x=1.455 //y=1.555 //x2=1.34 //y2=1.555
r667 (  153 211 ) resistor r=5.52526 //w=0.168 //l=0.115 //layer=ply \
 //thickness=0.18 //x=1.675 //y=1.555 //x2=1.79 //y2=1.555
r668 (  152 204 ) resistor r=5.52526 //w=0.168 //l=0.115 //layer=ply \
 //thickness=0.18 //x=1.455 //y=0.9 //x2=1.34 //y2=0.9
r669 (  151 210 ) resistor r=5.52526 //w=0.168 //l=0.115 //layer=ply \
 //thickness=0.18 //x=1.675 //y=0.9 //x2=1.79 //y2=0.9
r670 (  151 152 ) resistor r=112.809 //w=0.094 //l=0.22 //layer=ply \
 //thickness=0.18 //x=1.675 //y=0.9 //x2=1.455 //y2=0.9
r671 (  150 207 ) resistor r=58.7805 //w=0.246 //l=0.373497 //layer=ply \
 //thickness=0.18 //x=1.3 //y=2.095 //x2=1.6 //y2=2.26
r672 (  149 205 ) resistor r=39.5823 //w=0.21 //l=0.173853 //layer=ply \
 //thickness=0.18 //x=1.3 //y=1.71 //x2=1.34 //y2=1.555
r673 (  149 150 ) resistor r=197.415 //w=0.094 //l=0.385 //layer=ply \
 //thickness=0.18 //x=1.3 //y=1.71 //x2=1.3 //y2=2.095
r674 (  148 205 ) resistor r=39.5823 //w=0.21 //l=0.173853 //layer=ply \
 //thickness=0.18 //x=1.3 //y=1.4 //x2=1.34 //y2=1.555
r675 (  147 204 ) resistor r=45.1352 //w=0.168 //l=0.173853 //layer=ply \
 //thickness=0.18 //x=1.3 //y=1.055 //x2=1.34 //y2=0.9
r676 (  147 148 ) resistor r=176.904 //w=0.094 //l=0.345 //layer=ply \
 //thickness=0.18 //x=1.3 //y=1.055 //x2=1.3 //y2=1.4
r677 (  146 201 ) resistor r=592.245 //w=0.094 //l=1.155 //layer=ply \
 //thickness=0.18 //x=59.96 //y=6.2 //x2=59.96 //y2=5.045
r678 (  145 194 ) resistor r=592.245 //w=0.094 //l=1.155 //layer=ply \
 //thickness=0.18 //x=59.52 //y=6.2 //x2=59.52 //y2=5.045
r679 (  144 182 ) resistor r=592.245 //w=0.094 //l=1.155 //layer=ply \
 //thickness=0.18 //x=31.1 //y=6.2 //x2=31.1 //y2=5.045
r680 (  143 175 ) resistor r=592.245 //w=0.094 //l=1.155 //layer=ply \
 //thickness=0.18 //x=30.66 //y=6.2 //x2=30.66 //y2=5.045
r681 (  142 163 ) resistor r=592.245 //w=0.094 //l=1.155 //layer=ply \
 //thickness=0.18 //x=2.24 //y=6.2 //x2=2.24 //y2=5.045
r682 (  141 156 ) resistor r=592.245 //w=0.094 //l=1.155 //layer=ply \
 //thickness=0.18 //x=1.8 //y=6.2 //x2=1.8 //y2=5.045
r683 (  140 191 ) resistor r=56.4043 //w=0.094 //l=0.11 //layer=ply \
 //thickness=0.18 //x=59.285 //y=1.555 //x2=59.395 //y2=1.555
r684 (  140 192 ) resistor r=56.4043 //w=0.094 //l=0.11 //layer=ply \
 //thickness=0.18 //x=59.285 //y=1.555 //x2=59.175 //y2=1.555
r685 (  139 172 ) resistor r=56.4043 //w=0.094 //l=0.11 //layer=ply \
 //thickness=0.18 //x=30.425 //y=1.555 //x2=30.535 //y2=1.555
r686 (  139 173 ) resistor r=56.4043 //w=0.094 //l=0.11 //layer=ply \
 //thickness=0.18 //x=30.425 //y=1.555 //x2=30.315 //y2=1.555
r687 (  138 153 ) resistor r=56.4043 //w=0.094 //l=0.11 //layer=ply \
 //thickness=0.18 //x=1.565 //y=1.555 //x2=1.675 //y2=1.555
r688 (  138 154 ) resistor r=56.4043 //w=0.094 //l=0.11 //layer=ply \
 //thickness=0.18 //x=1.565 //y=1.555 //x2=1.455 //y2=1.555
r689 (  134 225 ) resistor r=152 //w=0.17 //l=0.17 //layer=licon //count=1 \
 //x=59.32 //y=4.88 //x2=59.32 //y2=4.88
r690 (  125 223 ) resistor r=152 //w=0.17 //l=0.17 //layer=licon //count=1 \
 //x=59.32 //y=2.26 //x2=59.32 //y2=2.26
r691 (  120 217 ) resistor r=152 //w=0.17 //l=0.17 //layer=licon //count=1 \
 //x=30.46 //y=4.88 //x2=30.46 //y2=4.88
r692 (  111 215 ) resistor r=152 //w=0.17 //l=0.17 //layer=licon //count=1 \
 //x=30.46 //y=2.26 //x2=30.46 //y2=2.26
r693 (  106 209 ) resistor r=152 //w=0.17 //l=0.17 //layer=licon //count=1 \
 //x=1.6 //y=4.88 //x2=1.6 //y2=4.88
r694 (  97 207 ) resistor r=152 //w=0.17 //l=0.17 //layer=licon //count=1 \
 //x=1.6 //y=2.26 //x2=1.6 //y2=2.26
r695 (  89 91 ) resistor r=0.10734 //w=0.281 //l=0.16 //layer=m2 \
 //thickness=0.36 //x=1.6 //y=4.255 //x2=1.76 //y2=4.255
r696 (  86 95 ) resistor r=1.55759 //w=0.19 //l=2.38244 //layer=m2 \
 //thickness=0.36 //x=56.945 //y=4.27 //x2=59.31 //y2=4.235
r697 (  86 87 ) resistor r=0.329198 //w=0.131 //l=0.345 //layer=m2 \
 //thickness=0.36 //x=56.945 //y=4.27 //x2=56.6 //y2=4.27
r698 (  84 87 ) resistor r=0.1875 //w=0.17 //l=0.264811 //layer=m2 \
 //thickness=0.36 //x=56.345 //y=4.25 //x2=56.6 //y2=4.27
r699 (  84 85 ) resistor r=7.74809 //w=0.131 //l=8.12 //layer=m2 \
 //thickness=0.36 //x=56.345 //y=4.25 //x2=48.225 //y2=4.25
r700 (  82 85 ) resistor r=0.125 //w=0.17 //l=0.184391 //layer=m2 \
 //thickness=0.36 //x=48.055 //y=4.28 //x2=48.225 //y2=4.25
r701 (  82 83 ) resistor r=0.329198 //w=0.131 //l=0.345 //layer=m2 \
 //thickness=0.36 //x=48.055 //y=4.28 //x2=47.71 //y2=4.28
r702 (  80 83 ) resistor r=0.1875 //w=0.17 //l=0.269583 //layer=m2 \
 //thickness=0.36 //x=47.455 //y=4.25 //x2=47.71 //y2=4.28
r703 (  80 81 ) resistor r=4.49427 //w=0.131 //l=4.71 //layer=m2 \
 //thickness=0.36 //x=47.455 //y=4.25 //x2=42.745 //y2=4.25
r704 (  78 81 ) resistor r=0.14881 //w=0.189 //l=0.253229 //layer=m2 \
 //thickness=0.36 //x=42.52 //y=4.31 //x2=42.745 //y2=4.25
r705 (  78 79 ) resistor r=0.333969 //w=0.131 //l=0.35 //layer=m2 \
 //thickness=0.36 //x=42.52 //y=4.31 //x2=42.17 //y2=4.31
r706 (  77 93 ) resistor r=4.89702 //w=0.176 //l=6.91746 //layer=m2 \
 //thickness=0.36 //x=37.36 //y=4.28 //x2=30.465 //y2=4.235
r707 (  76 79 ) resistor r=3.26023 //w=0.171 //l=4.47498 //layer=m2 \
 //thickness=0.36 //x=37.71 //y=4.28 //x2=42.17 //y2=4.31
r708 (  76 77 ) resistor r=0.333969 //w=0.131 //l=0.35 //layer=m2 \
 //thickness=0.36 //x=37.71 //y=4.28 //x2=37.36 //y2=4.28
r709 (  74 93 ) resistor r=1.68679 //w=0.176 //l=2.39244 //layer=m2 \
 //thickness=0.36 //x=28.09 //y=4.27 //x2=30.465 //y2=4.235
r710 (  74 75 ) resistor r=0.333969 //w=0.131 //l=0.35 //layer=m2 \
 //thickness=0.36 //x=28.09 //y=4.27 //x2=27.74 //y2=4.27
r711 (  72 75 ) resistor r=0.1875 //w=0.17 //l=0.264811 //layer=m2 \
 //thickness=0.36 //x=27.485 //y=4.25 //x2=27.74 //y2=4.27
r712 (  72 73 ) resistor r=7.74809 //w=0.131 //l=8.12 //layer=m2 \
 //thickness=0.36 //x=27.485 //y=4.25 //x2=19.365 //y2=4.25
r713 (  70 73 ) resistor r=0.125 //w=0.17 //l=0.184391 //layer=m2 \
 //thickness=0.36 //x=19.195 //y=4.28 //x2=19.365 //y2=4.25
r714 (  70 71 ) resistor r=0.329198 //w=0.131 //l=0.345 //layer=m2 \
 //thickness=0.36 //x=19.195 //y=4.28 //x2=18.85 //y2=4.28
r715 (  68 71 ) resistor r=0.1875 //w=0.17 //l=0.269583 //layer=m2 \
 //thickness=0.36 //x=18.595 //y=4.25 //x2=18.85 //y2=4.28
r716 (  68 69 ) resistor r=4.49905 //w=0.131 //l=4.715 //layer=m2 \
 //thickness=0.36 //x=18.595 //y=4.25 //x2=13.88 //y2=4.25
r717 (  66 69 ) resistor r=0.14881 //w=0.189 //l=0.253229 //layer=m2 \
 //thickness=0.36 //x=13.655 //y=4.31 //x2=13.88 //y2=4.25
r718 (  66 67 ) resistor r=0.329198 //w=0.131 //l=0.345 //layer=m2 \
 //thickness=0.36 //x=13.655 //y=4.31 //x2=13.31 //y2=4.31
r719 (  64 67 ) resistor r=3.26389 //w=0.171 //l=4.47998 //layer=m2 \
 //thickness=0.36 //x=8.845 //y=4.28 //x2=13.31 //y2=4.31
r720 (  64 65 ) resistor r=0.329198 //w=0.131 //l=0.345 //layer=m2 \
 //thickness=0.36 //x=8.845 //y=4.28 //x2=8.5 //y2=4.28
r721 (  62 65 ) resistor r=0.1875 //w=0.17 //l=0.269583 //layer=m2 \
 //thickness=0.36 //x=8.245 //y=4.25 //x2=8.5 //y2=4.28
r722 (  62 91 ) resistor r=6.18798 //w=0.131 //l=6.485 //layer=m2 \
 //thickness=0.36 //x=8.245 //y=4.25 //x2=1.76 //y2=4.25
r723 (  61 134 ) resistor r=9.3 //w=0.17 //l=0.17 //layer=mcon //count=1 \
 //x=59.32 //y=4.88 //x2=59.32 //y2=4.88
r724 (  59 125 ) resistor r=9.3 //w=0.17 //l=0.17 //layer=mcon //count=1 \
 //x=59.32 //y=2.26 //x2=59.32 //y2=2.26
r725 (  55 95 ) resistor r=4.5 //w=0.15 //l=0.15 //layer=via1 //count=1 \
 //x=59.31 //y=4.235 //x2=59.31 //y2=4.235
r726 (  51 93 ) resistor r=4.5 //w=0.15 //l=0.15 //layer=via1 //count=1 \
 //x=30.465 //y=4.235 //x2=30.465 //y2=4.235
r727 (  49 120 ) resistor r=9.3 //w=0.17 //l=0.17 //layer=mcon //count=1 \
 //x=30.46 //y=4.88 //x2=30.46 //y2=4.88
r728 (  47 111 ) resistor r=9.3 //w=0.17 //l=0.17 //layer=mcon //count=1 \
 //x=30.46 //y=2.26 //x2=30.46 //y2=2.26
r729 (  45 106 ) resistor r=9.3 //w=0.17 //l=0.17 //layer=mcon //count=1 \
 //x=1.6 //y=4.88 //x2=1.6 //y2=4.88
r730 (  43 97 ) resistor r=9.3 //w=0.17 //l=0.17 //layer=mcon //count=1 \
 //x=1.6 //y=2.26 //x2=1.6 //y2=2.26
r731 (  41 89 ) resistor r=4.5 //w=0.15 //l=0.15 //layer=via1 //count=1 \
 //x=1.6 //y=4.255 //x2=1.6 //y2=4.255
r732 (  37 61 ) resistor r=0.0760407 //w=0.238 //l=0.125 //layer=m1 \
 //thickness=0.36 //x=59.32 //y=4.755 //x2=59.32 //y2=4.88
r733 (  36 37 ) resistor r=0.343511 //w=0.131 //l=0.36 //layer=m1 \
 //thickness=0.36 //x=59.32 //y=4.395 //x2=59.32 //y2=4.755
r734 (  33 55 ) resistor r=0.0909648 //w=0.371 //l=0.186762 //layer=m1 \
 //thickness=0.36 //x=59.32 //y=4.075 //x2=59.262 //y2=4.235
r735 (  32 59 ) resistor r=0.0719237 //w=0.222 //l=0.115 //layer=m1 \
 //thickness=0.36 //x=59.32 //y=2.375 //x2=59.32 //y2=2.26
r736 (  31 49 ) resistor r=0.0760407 //w=0.238 //l=0.125 //layer=m1 \
 //thickness=0.36 //x=30.46 //y=4.755 //x2=30.46 //y2=4.88
r737 (  30 31 ) resistor r=0.343511 //w=0.131 //l=0.36 //layer=m1 \
 //thickness=0.36 //x=30.46 //y=4.395 //x2=30.46 //y2=4.755
r738 (  26 51 ) resistor r=0.0910802 //w=0.374 //l=0.185472 //layer=m1 \
 //thickness=0.36 //x=30.46 //y=4.075 //x2=30.515 //y2=4.235
r739 (  25 47 ) resistor r=0.0719237 //w=0.222 //l=0.115 //layer=m1 \
 //thickness=0.36 //x=30.46 //y=2.375 //x2=30.46 //y2=2.26
r740 (  23 45 ) resistor r=0.0760407 //w=0.238 //l=0.125 //layer=m1 \
 //thickness=0.36 //x=1.6 //y=4.755 //x2=1.6 //y2=4.88
r741 (  22 41 ) resistor r=0.0911593 //w=0.376 //l=0.184608 //layer=m1 \
 //thickness=0.36 //x=1.6 //y=4.415 //x2=1.547 //y2=4.255
r742 (  15 43 ) resistor r=0.0719237 //w=0.222 //l=0.115 //layer=m1 \
 //thickness=0.36 //x=1.6 //y=2.375 //x2=1.6 //y2=2.26
r743 (  14 36 ) resistor r=0.0859108 //w=0.371 //l=0.171566 //layer=m1 \
 //thickness=0.36 //x=59.262 //y=4.25 //x2=59.32 //y2=4.395
r744 (  14 55 ) resistor r=0.00505391 //w=0.371 //l=0.015 //layer=m1 \
 //thickness=0.36 //x=59.262 //y=4.25 //x2=59.262 //y2=4.235
r745 (  13 30 ) resistor r=0.0860668 //w=0.374 //l=0.170294 //layer=m1 \
 //thickness=0.36 //x=30.515 //y=4.25 //x2=30.46 //y2=4.395
r746 (  13 51 ) resistor r=0.00501337 //w=0.374 //l=0.015 //layer=m1 \
 //thickness=0.36 //x=30.515 //y=4.25 //x2=30.515 //y2=4.235
r747 (  12 41 ) resistor r=0.00166223 //w=0.376 //l=0.005 //layer=m1 \
 //thickness=0.36 //x=1.547 //y=4.25 //x2=1.547 //y2=4.255
r748 (  12 16 ) resistor r=0.0894971 //w=0.376 //l=0.179555 //layer=m1 \
 //thickness=0.36 //x=1.547 //y=4.25 //x2=1.6 //y2=4.095
r749 (  11 33 ) resistor r=0.539122 //w=0.131 //l=0.565 //layer=m1 \
 //thickness=0.36 //x=59.32 //y=3.51 //x2=59.32 //y2=4.075
r750 (  10 11 ) resistor r=0.706107 //w=0.131 //l=0.74 //layer=m1 \
 //thickness=0.36 //x=59.32 //y=2.77 //x2=59.32 //y2=3.51
r751 (  10 32 ) resistor r=0.376908 //w=0.131 //l=0.395 //layer=m1 \
 //thickness=0.36 //x=59.32 //y=2.77 //x2=59.32 //y2=2.375
r752 (  9 26 ) resistor r=0.186069 //w=0.131 //l=0.195 //layer=m1 \
 //thickness=0.36 //x=30.46 //y=3.88 //x2=30.46 //y2=4.075
r753 (  8 9 ) resistor r=0.353053 //w=0.131 //l=0.37 //layer=m1 \
 //thickness=0.36 //x=30.46 //y=3.51 //x2=30.46 //y2=3.88
r754 (  7 8 ) resistor r=0.706107 //w=0.131 //l=0.74 //layer=m1 \
 //thickness=0.36 //x=30.46 //y=2.77 //x2=30.46 //y2=3.51
r755 (  7 25 ) resistor r=0.376908 //w=0.131 //l=0.395 //layer=m1 \
 //thickness=0.36 //x=30.46 //y=2.77 //x2=30.46 //y2=2.375
r756 (  6 23 ) resistor r=0.128817 //w=0.131 //l=0.135 //layer=m1 \
 //thickness=0.36 //x=1.6 //y=4.62 //x2=1.6 //y2=4.755
r757 (  6 22 ) resistor r=0.195611 //w=0.131 //l=0.205 //layer=m1 \
 //thickness=0.36 //x=1.6 //y=4.62 //x2=1.6 //y2=4.415
r758 (  5 16 ) resistor r=0.205153 //w=0.131 //l=0.215 //layer=m1 \
 //thickness=0.36 //x=1.6 //y=3.88 //x2=1.6 //y2=4.095
r759 (  4 5 ) resistor r=0.353053 //w=0.131 //l=0.37 //layer=m1 \
 //thickness=0.36 //x=1.6 //y=3.51 //x2=1.6 //y2=3.88
r760 (  3 4 ) resistor r=0.353053 //w=0.131 //l=0.37 //layer=m1 \
 //thickness=0.36 //x=1.6 //y=3.14 //x2=1.6 //y2=3.51
r761 (  2 3 ) resistor r=0.353053 //w=0.131 //l=0.37 //layer=m1 \
 //thickness=0.36 //x=1.6 //y=2.77 //x2=1.6 //y2=3.14
r762 (  1 2 ) resistor r=0.353053 //w=0.131 //l=0.37 //layer=m1 \
 //thickness=0.36 //x=1.6 //y=2.4 //x2=1.6 //y2=2.77
r763 (  1 15 ) resistor r=0.023855 //w=0.131 //l=0.025 //layer=m1 \
 //thickness=0.36 //x=1.6 //y=2.4 //x2=1.6 //y2=2.375
ends PM_TMRDFFSNRNQNX1\%D

subckt PM_TMRDFFSNRNQNX1\%noxref_13 ( 1 3 6 7 9 10 11 12 14 15 16 17 18 19 20 \
 21 22 23 24 25 28 31 37 45 49 63 66 67 69 70 73 81 89 106 115 120 129 133 134 \
 135 136 137 138 139 140 141 142 143 145 151 152 153 154 158 159 160 161 162 \
 164 170 171 172 173 193 195 196 197 )
c439 ( 193 0 ) capacitor c=0.00885916f //x=61.605 //y=1.095
c440 ( 173 0 ) capacitor c=0.0612936f //x=69.215 //y=4.97
c441 ( 172 0 ) capacitor c=0.0376642f //x=69.505 //y=4.97
c442 ( 171 0 ) capacitor c=0.0346489f //x=69.17 //y=1.4
c443 ( 170 0 ) capacitor c=0.018692f //x=69.17 //y=1.055
c444 ( 164 0 ) capacitor c=0.0137077f //x=69.015 //y=1.555
c445 ( 162 0 ) capacitor c=0.0158585f //x=69.015 //y=0.9
c446 ( 161 0 ) capacitor c=0.0979536f //x=68.64 //y=2.095
c447 ( 160 0 ) capacitor c=0.0229444f //x=68.64 //y=1.71
c448 ( 159 0 ) capacitor c=0.0234359f //x=68.64 //y=1.4
c449 ( 158 0 ) capacitor c=0.019815f //x=68.64 //y=1.055
c450 ( 154 0 ) capacitor c=0.0612936f //x=64.405 //y=4.97
c451 ( 153 0 ) capacitor c=0.0376642f //x=64.695 //y=4.97
c452 ( 152 0 ) capacitor c=0.0346489f //x=64.36 //y=1.4
c453 ( 151 0 ) capacitor c=0.018692f //x=64.36 //y=1.055
c454 ( 145 0 ) capacitor c=0.0137077f //x=64.205 //y=1.555
c455 ( 143 0 ) capacitor c=0.0158585f //x=64.205 //y=0.9
c456 ( 142 0 ) capacitor c=0.0996161f //x=63.83 //y=2.095
c457 ( 141 0 ) capacitor c=0.0229444f //x=63.83 //y=1.71
c458 ( 140 0 ) capacitor c=0.0234359f //x=63.83 //y=1.4
c459 ( 139 0 ) capacitor c=0.019815f //x=63.83 //y=1.055
c460 ( 138 0 ) capacitor c=0.110208f //x=69.58 //y=6.2
c461 ( 137 0 ) capacitor c=0.158957f //x=69.14 //y=6.2
c462 ( 136 0 ) capacitor c=0.110208f //x=64.77 //y=6.2
c463 ( 135 0 ) capacitor c=0.158957f //x=64.33 //y=6.2
c464 ( 129 0 ) capacitor c=0.0014751f //x=68.94 //y=4.88
c465 ( 120 0 ) capacitor c=9.93222e-19 //x=68.94 //y=2.26
c466 ( 115 0 ) capacitor c=0.0014751f //x=64.13 //y=4.88
c467 ( 106 0 ) capacitor c=9.93222e-19 //x=64.13 //y=2.26
c468 ( 89 0 ) capacitor c=0.0293562f //x=61.5 //y=5.56
c469 ( 81 0 ) capacitor c=0.029137f //x=60.62 //y=5.56
c470 ( 73 0 ) capacitor c=0.0278099f //x=59.74 //y=5.56
c471 ( 70 0 ) capacitor c=0.0393584f //x=68.78 //y=2.785
c472 ( 69 0 ) capacitor c=6.54212e-19 //x=68.94 //y=2.785
c473 ( 67 0 ) capacitor c=6.54212e-19 //x=64.295 //y=2.785
c474 ( 66 0 ) capacitor c=0.016756f //x=63.975 //y=2.785
c475 ( 63 0 ) capacitor c=9.56892e-19 //x=62.445 //y=2.785
c476 ( 49 0 ) capacitor c=0.0154699f //x=68.94 //y=2.77
c477 ( 45 0 ) capacitor c=0.0148628f //x=64.13 //y=2.77
c478 ( 37 0 ) capacitor c=0.0144706f //x=62.28 //y=2.77
c479 ( 31 0 ) capacitor c=0.00157725f //x=61.5 //y=5.335
c480 ( 28 0 ) capacitor c=0.00784584f //x=60.62 //y=5.335
c481 ( 25 0 ) capacitor c=0.0102231f //x=59.742 //y=5.335
c482 ( 24 0 ) capacitor c=0.058037f //x=68.94 //y=4.755
c483 ( 23 0 ) capacitor c=0.0130763f //x=68.94 //y=2.945
c484 ( 22 0 ) capacitor c=0.00473602f //x=68.94 //y=2.625
c485 ( 21 0 ) capacitor c=0.00495287f //x=68.94 //y=2.375
c486 ( 20 0 ) capacitor c=0.0621094f //x=64.13 //y=4.755
c487 ( 19 0 ) capacitor c=0.0130666f //x=64.13 //y=2.945
c488 ( 18 0 ) capacitor c=0.00482124f //x=64.13 //y=2.625
c489 ( 17 0 ) capacitor c=0.00495287f //x=64.13 //y=2.375
c490 ( 16 0 ) capacitor c=0.0657254f //x=62.28 //y=5.25
c491 ( 15 0 ) capacitor c=0.0123004f //x=62.28 //y=2.945
c492 ( 14 0 ) capacitor c=0.0179579f //x=62.28 //y=2.625
c493 ( 12 0 ) capacitor c=0.0047266f //x=61.88 //y=1.845
c494 ( 11 0 ) capacitor c=0.0129788f //x=62.195 //y=1.845
c495 ( 10 0 ) capacitor c=0.0167992f //x=61.795 //y=1.76
c496 ( 9 0 ) capacitor c=0.0110957f //x=61.795 //y=1.305
c497 ( 7 0 ) capacitor c=0.0262531f //x=62.195 //y=5.335
c498 ( 6 0 ) capacitor c=0.00933983f //x=61.5 //y=5.56
c499 ( 3 0 ) capacitor c=0.0172643f //x=61.385 //y=5.335
c500 ( 1 0 ) capacitor c=0.0164014f //x=60.5 //y=5.335
r501 (  172 174 ) resistor r=26.9307 //w=0.15 //l=0.106066 //layer=ply \
 //thickness=0.18 //x=69.505 //y=4.97 //x2=69.58 //y2=5.045
r502 (  172 173 ) resistor r=148.702 //w=0.094 //l=0.29 //layer=ply \
 //thickness=0.18 //x=69.505 //y=4.97 //x2=69.215 //y2=4.97
r503 (  171 192 ) resistor r=45.1352 //w=0.168 //l=0.173853 //layer=ply \
 //thickness=0.18 //x=69.17 //y=1.4 //x2=69.13 //y2=1.555
r504 (  170 191 ) resistor r=45.1352 //w=0.168 //l=0.173853 //layer=ply \
 //thickness=0.18 //x=69.17 //y=1.055 //x2=69.13 //y2=0.9
r505 (  170 171 ) resistor r=176.904 //w=0.094 //l=0.345 //layer=ply \
 //thickness=0.18 //x=69.17 //y=1.055 //x2=69.17 //y2=1.4
r506 (  167 173 ) resistor r=22.7971 //w=0.269 //l=0.106066 //layer=ply \
 //thickness=0.18 //x=69.14 //y=5.045 //x2=69.215 //y2=4.97
r507 (  167 190 ) resistor r=35.8364 //w=0.269 //l=0.270185 //layer=ply \
 //thickness=0.18 //x=69.14 //y=5.045 //x2=68.94 //y2=4.88
r508 (  165 186 ) resistor r=10.701 //w=0.21 //l=0.115 //layer=ply \
 //thickness=0.18 //x=68.795 //y=1.555 //x2=68.68 //y2=1.555
r509 (  164 192 ) resistor r=5.52526 //w=0.168 //l=0.115 //layer=ply \
 //thickness=0.18 //x=69.015 //y=1.555 //x2=69.13 //y2=1.555
r510 (  163 185 ) resistor r=5.52526 //w=0.168 //l=0.115 //layer=ply \
 //thickness=0.18 //x=68.795 //y=0.9 //x2=68.68 //y2=0.9
r511 (  162 191 ) resistor r=5.52526 //w=0.168 //l=0.115 //layer=ply \
 //thickness=0.18 //x=69.015 //y=0.9 //x2=69.13 //y2=0.9
r512 (  162 163 ) resistor r=112.809 //w=0.094 //l=0.22 //layer=ply \
 //thickness=0.18 //x=69.015 //y=0.9 //x2=68.795 //y2=0.9
r513 (  161 188 ) resistor r=58.7805 //w=0.246 //l=0.373497 //layer=ply \
 //thickness=0.18 //x=68.64 //y=2.095 //x2=68.94 //y2=2.26
r514 (  160 186 ) resistor r=39.5823 //w=0.21 //l=0.173853 //layer=ply \
 //thickness=0.18 //x=68.64 //y=1.71 //x2=68.68 //y2=1.555
r515 (  160 161 ) resistor r=197.415 //w=0.094 //l=0.385 //layer=ply \
 //thickness=0.18 //x=68.64 //y=1.71 //x2=68.64 //y2=2.095
r516 (  159 186 ) resistor r=39.5823 //w=0.21 //l=0.173853 //layer=ply \
 //thickness=0.18 //x=68.64 //y=1.4 //x2=68.68 //y2=1.555
r517 (  158 185 ) resistor r=45.1352 //w=0.168 //l=0.173853 //layer=ply \
 //thickness=0.18 //x=68.64 //y=1.055 //x2=68.68 //y2=0.9
r518 (  158 159 ) resistor r=176.904 //w=0.094 //l=0.345 //layer=ply \
 //thickness=0.18 //x=68.64 //y=1.055 //x2=68.64 //y2=1.4
r519 (  153 155 ) resistor r=26.9307 //w=0.15 //l=0.106066 //layer=ply \
 //thickness=0.18 //x=64.695 //y=4.97 //x2=64.77 //y2=5.045
r520 (  153 154 ) resistor r=148.702 //w=0.094 //l=0.29 //layer=ply \
 //thickness=0.18 //x=64.695 //y=4.97 //x2=64.405 //y2=4.97
r521 (  152 184 ) resistor r=45.1352 //w=0.168 //l=0.173853 //layer=ply \
 //thickness=0.18 //x=64.36 //y=1.4 //x2=64.32 //y2=1.555
r522 (  151 183 ) resistor r=45.1352 //w=0.168 //l=0.173853 //layer=ply \
 //thickness=0.18 //x=64.36 //y=1.055 //x2=64.32 //y2=0.9
r523 (  151 152 ) resistor r=176.904 //w=0.094 //l=0.345 //layer=ply \
 //thickness=0.18 //x=64.36 //y=1.055 //x2=64.36 //y2=1.4
r524 (  148 154 ) resistor r=22.7971 //w=0.269 //l=0.106066 //layer=ply \
 //thickness=0.18 //x=64.33 //y=5.045 //x2=64.405 //y2=4.97
r525 (  148 182 ) resistor r=35.8364 //w=0.269 //l=0.270185 //layer=ply \
 //thickness=0.18 //x=64.33 //y=5.045 //x2=64.13 //y2=4.88
r526 (  146 178 ) resistor r=10.701 //w=0.21 //l=0.115 //layer=ply \
 //thickness=0.18 //x=63.985 //y=1.555 //x2=63.87 //y2=1.555
r527 (  145 184 ) resistor r=5.52526 //w=0.168 //l=0.115 //layer=ply \
 //thickness=0.18 //x=64.205 //y=1.555 //x2=64.32 //y2=1.555
r528 (  144 177 ) resistor r=5.52526 //w=0.168 //l=0.115 //layer=ply \
 //thickness=0.18 //x=63.985 //y=0.9 //x2=63.87 //y2=0.9
r529 (  143 183 ) resistor r=5.52526 //w=0.168 //l=0.115 //layer=ply \
 //thickness=0.18 //x=64.205 //y=0.9 //x2=64.32 //y2=0.9
r530 (  143 144 ) resistor r=112.809 //w=0.094 //l=0.22 //layer=ply \
 //thickness=0.18 //x=64.205 //y=0.9 //x2=63.985 //y2=0.9
r531 (  142 180 ) resistor r=58.7805 //w=0.246 //l=0.373497 //layer=ply \
 //thickness=0.18 //x=63.83 //y=2.095 //x2=64.13 //y2=2.26
r532 (  141 178 ) resistor r=39.5823 //w=0.21 //l=0.173853 //layer=ply \
 //thickness=0.18 //x=63.83 //y=1.71 //x2=63.87 //y2=1.555
r533 (  141 142 ) resistor r=197.415 //w=0.094 //l=0.385 //layer=ply \
 //thickness=0.18 //x=63.83 //y=1.71 //x2=63.83 //y2=2.095
r534 (  140 178 ) resistor r=39.5823 //w=0.21 //l=0.173853 //layer=ply \
 //thickness=0.18 //x=63.83 //y=1.4 //x2=63.87 //y2=1.555
r535 (  139 177 ) resistor r=45.1352 //w=0.168 //l=0.173853 //layer=ply \
 //thickness=0.18 //x=63.83 //y=1.055 //x2=63.87 //y2=0.9
r536 (  139 140 ) resistor r=176.904 //w=0.094 //l=0.345 //layer=ply \
 //thickness=0.18 //x=63.83 //y=1.055 //x2=63.83 //y2=1.4
r537 (  138 174 ) resistor r=592.245 //w=0.094 //l=1.155 //layer=ply \
 //thickness=0.18 //x=69.58 //y=6.2 //x2=69.58 //y2=5.045
r538 (  137 167 ) resistor r=592.245 //w=0.094 //l=1.155 //layer=ply \
 //thickness=0.18 //x=69.14 //y=6.2 //x2=69.14 //y2=5.045
r539 (  136 155 ) resistor r=592.245 //w=0.094 //l=1.155 //layer=ply \
 //thickness=0.18 //x=64.77 //y=6.2 //x2=64.77 //y2=5.045
r540 (  135 148 ) resistor r=592.245 //w=0.094 //l=1.155 //layer=ply \
 //thickness=0.18 //x=64.33 //y=6.2 //x2=64.33 //y2=5.045
r541 (  134 164 ) resistor r=56.4043 //w=0.094 //l=0.11 //layer=ply \
 //thickness=0.18 //x=68.905 //y=1.555 //x2=69.015 //y2=1.555
r542 (  134 165 ) resistor r=56.4043 //w=0.094 //l=0.11 //layer=ply \
 //thickness=0.18 //x=68.905 //y=1.555 //x2=68.795 //y2=1.555
r543 (  133 145 ) resistor r=56.4043 //w=0.094 //l=0.11 //layer=ply \
 //thickness=0.18 //x=64.095 //y=1.555 //x2=64.205 //y2=1.555
r544 (  133 146 ) resistor r=56.4043 //w=0.094 //l=0.11 //layer=ply \
 //thickness=0.18 //x=64.095 //y=1.555 //x2=63.985 //y2=1.555
r545 (  129 190 ) resistor r=152 //w=0.17 //l=0.17 //layer=licon //count=1 \
 //x=68.94 //y=4.88 //x2=68.94 //y2=4.88
r546 (  120 188 ) resistor r=152 //w=0.17 //l=0.17 //layer=licon //count=1 \
 //x=68.94 //y=2.26 //x2=68.94 //y2=2.26
r547 (  115 182 ) resistor r=152 //w=0.17 //l=0.17 //layer=licon //count=1 \
 //x=64.13 //y=4.88 //x2=64.13 //y2=4.88
r548 (  106 180 ) resistor r=152 //w=0.17 //l=0.17 //layer=licon //count=1 \
 //x=64.13 //y=2.26 //x2=64.13 //y2=2.26
r549 (  89 197 ) resistor r=23.615 //w=0.187 //l=0.345 //layer=li \
 //thickness=0.1 //x=61.5 //y=5.56 //x2=61.5 //y2=5.905
r550 (  81 196 ) resistor r=23.615 //w=0.187 //l=0.345 //layer=li \
 //thickness=0.1 //x=60.62 //y=5.56 //x2=60.62 //y2=5.905
r551 (  73 195 ) resistor r=23.615 //w=0.187 //l=0.345 //layer=li \
 //thickness=0.1 //x=59.74 //y=5.56 //x2=59.74 //y2=5.905
r552 (  69 70 ) resistor r=0.10734 //w=0.281 //l=0.16 //layer=m2 \
 //thickness=0.36 //x=68.94 //y=2.785 //x2=68.78 //y2=2.785
r553 (  67 70 ) resistor r=4.27958 //w=0.131 //l=4.485 //layer=m2 \
 //thickness=0.36 //x=64.295 //y=2.77 //x2=68.78 //y2=2.77
r554 (  65 67 ) resistor r=0.10734 //w=0.281 //l=0.16 //layer=m2 \
 //thickness=0.36 //x=64.135 //y=2.785 //x2=64.295 //y2=2.785
r555 (  65 66 ) resistor r=0.10734 //w=0.281 //l=0.16 //layer=m2 \
 //thickness=0.36 //x=64.135 //y=2.785 //x2=63.975 //y2=2.785
r556 (  63 66 ) resistor r=1.45992 //w=0.131 //l=1.53 //layer=m2 \
 //thickness=0.36 //x=62.445 //y=2.77 //x2=63.975 //y2=2.77
r557 (  61 63 ) resistor r=0.10734 //w=0.281 //l=0.16 //layer=m2 \
 //thickness=0.36 //x=62.285 //y=2.785 //x2=62.445 //y2=2.785
r558 (  55 129 ) resistor r=9.3 //w=0.17 //l=0.17 //layer=mcon //count=1 \
 //x=68.94 //y=4.88 //x2=68.94 //y2=4.88
r559 (  53 120 ) resistor r=9.3 //w=0.17 //l=0.17 //layer=mcon //count=1 \
 //x=68.94 //y=2.26 //x2=68.94 //y2=2.26
r560 (  51 69 ) resistor r=4.5 //w=0.15 //l=0.15 //layer=via1 //count=1 \
 //x=68.94 //y=2.785 //x2=68.94 //y2=2.785
r561 (  49 51 ) resistor r=0.0049867 //w=0.376 //l=0.015 //layer=m1 \
 //thickness=0.36 //x=68.887 //y=2.77 //x2=68.887 //y2=2.785
r562 (  47 65 ) resistor r=4.5 //w=0.15 //l=0.15 //layer=via1 //count=1 \
 //x=64.135 //y=2.785 //x2=64.135 //y2=2.785
r563 (  45 47 ) resistor r=0.00501337 //w=0.374 //l=0.015 //layer=m1 \
 //thickness=0.36 //x=64.185 //y=2.77 //x2=64.185 //y2=2.785
r564 (  43 115 ) resistor r=9.3 //w=0.17 //l=0.17 //layer=mcon //count=1 \
 //x=64.13 //y=4.88 //x2=64.13 //y2=4.88
r565 (  41 106 ) resistor r=9.3 //w=0.17 //l=0.17 //layer=mcon //count=1 \
 //x=64.13 //y=2.26 //x2=64.13 //y2=2.26
r566 (  39 61 ) resistor r=4.5 //w=0.15 //l=0.15 //layer=via1 //count=1 \
 //x=62.285 //y=2.785 //x2=62.285 //y2=2.785
r567 (  37 39 ) resistor r=0.00501337 //w=0.374 //l=0.015 //layer=m1 \
 //thickness=0.36 //x=62.335 //y=2.77 //x2=62.335 //y2=2.785
r568 (  35 193 ) resistor r=9.3 //w=0.17 //l=0.17 //layer=mcon //count=1 \
 //x=61.795 //y=1.19 //x2=61.795 //y2=1.19
r569 (  33 89 ) resistor r=9.3 //w=0.17 //l=0.17 //layer=mcon //count=1 \
 //x=61.5 //y=5.56 //x2=61.5 //y2=5.56
r570 (  30 81 ) resistor r=9.3 //w=0.17 //l=0.17 //layer=mcon //count=1 \
 //x=60.62 //y=5.56 //x2=60.62 //y2=5.56
r571 (  28 30 ) resistor r=0.121228 //w=0.232 //l=0.225 //layer=m1 \
 //thickness=0.36 //x=60.62 //y=5.335 //x2=60.62 //y2=5.56
r572 (  27 73 ) resistor r=9.3 //w=0.17 //l=0.17 //layer=mcon //count=1 \
 //x=59.74 //y=5.56 //x2=59.74 //y2=5.56
r573 (  25 27 ) resistor r=0.129608 //w=0.217 //l=0.225 //layer=m1 \
 //thickness=0.36 //x=59.742 //y=5.335 //x2=59.742 //y2=5.56
r574 (  24 55 ) resistor r=0.0760407 //w=0.238 //l=0.125 //layer=m1 \
 //thickness=0.36 //x=68.94 //y=4.755 //x2=68.94 //y2=4.88
r575 (  23 51 ) resistor r=0.0911593 //w=0.376 //l=0.184608 //layer=m1 \
 //thickness=0.36 //x=68.94 //y=2.945 //x2=68.887 //y2=2.785
r576 (  23 24 ) resistor r=1.7271 //w=0.131 //l=1.81 //layer=m1 \
 //thickness=0.36 //x=68.94 //y=2.945 //x2=68.94 //y2=4.755
r577 (  22 49 ) resistor r=0.0861726 //w=0.376 //l=0.16944 //layer=m1 \
 //thickness=0.36 //x=68.94 //y=2.625 //x2=68.887 //y2=2.77
r578 (  21 53 ) resistor r=0.0719237 //w=0.222 //l=0.115 //layer=m1 \
 //thickness=0.36 //x=68.94 //y=2.375 //x2=68.94 //y2=2.26
r579 (  21 22 ) resistor r=0.23855 //w=0.131 //l=0.25 //layer=m1 \
 //thickness=0.36 //x=68.94 //y=2.375 //x2=68.94 //y2=2.625
r580 (  20 43 ) resistor r=0.0760407 //w=0.238 //l=0.125 //layer=m1 \
 //thickness=0.36 //x=64.13 //y=4.755 //x2=64.13 //y2=4.88
r581 (  19 47 ) resistor r=0.0910802 //w=0.374 //l=0.185472 //layer=m1 \
 //thickness=0.36 //x=64.13 //y=2.945 //x2=64.185 //y2=2.785
r582 (  19 20 ) resistor r=1.7271 //w=0.131 //l=1.81 //layer=m1 \
 //thickness=0.36 //x=64.13 //y=2.945 //x2=64.13 //y2=4.755
r583 (  18 45 ) resistor r=0.0860668 //w=0.374 //l=0.170294 //layer=m1 \
 //thickness=0.36 //x=64.13 //y=2.625 //x2=64.185 //y2=2.77
r584 (  17 41 ) resistor r=0.0719237 //w=0.222 //l=0.115 //layer=m1 \
 //thickness=0.36 //x=64.13 //y=2.375 //x2=64.13 //y2=2.26
r585 (  17 18 ) resistor r=0.23855 //w=0.131 //l=0.25 //layer=m1 \
 //thickness=0.36 //x=64.13 //y=2.375 //x2=64.13 //y2=2.625
r586 (  15 39 ) resistor r=0.0910802 //w=0.374 //l=0.185472 //layer=m1 \
 //thickness=0.36 //x=62.28 //y=2.945 //x2=62.335 //y2=2.785
r587 (  15 16 ) resistor r=2.19943 //w=0.131 //l=2.305 //layer=m1 \
 //thickness=0.36 //x=62.28 //y=2.945 //x2=62.28 //y2=5.25
r588 (  14 37 ) resistor r=0.0860668 //w=0.374 //l=0.170294 //layer=m1 \
 //thickness=0.36 //x=62.28 //y=2.625 //x2=62.335 //y2=2.77
r589 (  13 14 ) resistor r=0.663168 //w=0.131 //l=0.695 //layer=m1 \
 //thickness=0.36 //x=62.28 //y=1.93 //x2=62.28 //y2=2.625
r590 (  11 13 ) resistor r=0.0698411 //w=0.17 //l=0.120208 //layer=m1 \
 //thickness=0.36 //x=62.195 //y=1.845 //x2=62.28 //y2=1.93
r591 (  11 12 ) resistor r=0.300573 //w=0.131 //l=0.315 //layer=m1 \
 //thickness=0.36 //x=62.195 //y=1.845 //x2=61.88 //y2=1.845
r592 (  10 12 ) resistor r=0.0698411 //w=0.17 //l=0.120208 //layer=m1 \
 //thickness=0.36 //x=61.795 //y=1.76 //x2=61.88 //y2=1.845
r593 (  9 35 ) resistor r=0.0717383 //w=0.224 //l=0.115 //layer=m1 \
 //thickness=0.36 //x=61.795 //y=1.305 //x2=61.795 //y2=1.19
r594 (  9 10 ) resistor r=0.43416 //w=0.131 //l=0.455 //layer=m1 \
 //thickness=0.36 //x=61.795 //y=1.305 //x2=61.795 //y2=1.76
r595 (  8 31 ) resistor r=0.0675342 //w=0.23 //l=0.115 //layer=m1 \
 //thickness=0.36 //x=61.615 //y=5.335 //x2=61.5 //y2=5.335
r596 (  7 16 ) resistor r=0.0698411 //w=0.17 //l=0.120208 //layer=m1 \
 //thickness=0.36 //x=62.195 //y=5.335 //x2=62.28 //y2=5.25
r597 (  7 8 ) resistor r=0.553435 //w=0.131 //l=0.58 //layer=m1 \
 //thickness=0.36 //x=62.195 //y=5.335 //x2=61.615 //y2=5.335
r598 (  6 33 ) resistor r=0.00118313 //w=0.23 //layer=m1 //thickness=0.36 \
 //x=61.5 //y=5.56 //x2=61.5 //y2=5.56
r599 (  5 31 ) resistor r=0.002872 //w=0.34 //l=0.085 //layer=m1 \
 //thickness=0.36 //x=61.5 //y=5.42 //x2=61.5 //y2=5.335
r600 (  5 6 ) resistor r=0.091623 //w=0.191 //l=0.14 //layer=m1 \
 //thickness=0.36 //x=61.5 //y=5.42 //x2=61.5 //y2=5.56
r601 (  4 28 ) resistor r=0.0262263 //w=0.232 //l=0.12 //layer=m1 \
 //thickness=0.36 //x=60.74 //y=5.335 //x2=60.62 //y2=5.335
r602 (  3 31 ) resistor r=0.0675342 //w=0.23 //l=0.115 //layer=m1 \
 //thickness=0.36 //x=61.385 //y=5.335 //x2=61.5 //y2=5.335
r603 (  3 4 ) resistor r=0.615458 //w=0.131 //l=0.645 //layer=m1 \
 //thickness=0.36 //x=61.385 //y=5.335 //x2=60.74 //y2=5.335
r604 (  2 25 ) resistor r=0.0222262 //w=0.217 //l=0.118 //layer=m1 \
 //thickness=0.36 //x=59.86 //y=5.335 //x2=59.742 //y2=5.335
r605 (  1 28 ) resistor r=0.0262263 //w=0.232 //l=0.12 //layer=m1 \
 //thickness=0.36 //x=60.5 //y=5.335 //x2=60.62 //y2=5.335
r606 (  1 2 ) resistor r=0.610687 //w=0.131 //l=0.64 //layer=m1 \
 //thickness=0.36 //x=60.5 //y=5.335 //x2=59.86 //y2=5.335
ends PM_TMRDFFSNRNQNX1\%noxref_13

subckt PM_TMRDFFSNRNQNX1\%noxref_14 ( 1 3 6 7 9 10 11 12 14 15 16 17 18 19 20 \
 21 24 27 33 36 42 43 48 51 59 67 84 93 97 98 99 100 101 102 103 104 106 112 \
 113 114 115 127 129 130 131 )
c300 ( 127 0 ) capacitor c=0.00885916f //x=71.225 //y=1.095
c301 ( 115 0 ) capacitor c=0.0612936f //x=74.025 //y=4.97
c302 ( 114 0 ) capacitor c=0.0376642f //x=74.315 //y=4.97
c303 ( 113 0 ) capacitor c=0.0346489f //x=73.98 //y=1.4
c304 ( 112 0 ) capacitor c=0.018692f //x=73.98 //y=1.055
c305 ( 106 0 ) capacitor c=0.0137077f //x=73.825 //y=1.555
c306 ( 104 0 ) capacitor c=0.0158585f //x=73.825 //y=0.9
c307 ( 103 0 ) capacitor c=0.0979523f //x=73.45 //y=2.095
c308 ( 102 0 ) capacitor c=0.0229444f //x=73.45 //y=1.71
c309 ( 101 0 ) capacitor c=0.0234359f //x=73.45 //y=1.4
c310 ( 100 0 ) capacitor c=0.019815f //x=73.45 //y=1.055
c311 ( 99 0 ) capacitor c=0.110208f //x=74.39 //y=6.2
c312 ( 98 0 ) capacitor c=0.158957f //x=73.95 //y=6.2
c313 ( 93 0 ) capacitor c=0.0014751f //x=73.75 //y=4.88
c314 ( 84 0 ) capacitor c=9.93222e-19 //x=73.75 //y=2.26
c315 ( 67 0 ) capacitor c=0.0293723f //x=71.12 //y=5.56
c316 ( 59 0 ) capacitor c=0.029137f //x=70.24 //y=5.56
c317 ( 51 0 ) capacitor c=0.0278099f //x=69.36 //y=5.56
c318 ( 48 0 ) capacitor c=6.57651e-19 //x=73.76 //y=2.77
c319 ( 43 0 ) capacitor c=9.44624e-19 //x=72.06 //y=2.77
c320 ( 42 0 ) capacitor c=0.0155215f //x=73.6 //y=2.77
c321 ( 36 0 ) capacitor c=0.0146045f //x=73.75 //y=2.77
c322 ( 33 0 ) capacitor c=0.0146969f //x=71.9 //y=2.77
c323 ( 27 0 ) capacitor c=0.00157165f //x=71.12 //y=5.335
c324 ( 24 0 ) capacitor c=0.00779411f //x=70.24 //y=5.335
c325 ( 21 0 ) capacitor c=0.0102414f //x=69.362 //y=5.335
c326 ( 20 0 ) capacitor c=0.0632509f //x=73.75 //y=4.755
c327 ( 19 0 ) capacitor c=0.0131932f //x=73.75 //y=2.93
c328 ( 18 0 ) capacitor c=0.00432188f //x=73.75 //y=2.61
c329 ( 17 0 ) capacitor c=0.00485584f //x=73.75 //y=2.375
c330 ( 16 0 ) capacitor c=0.0639604f //x=71.9 //y=5.25
c331 ( 15 0 ) capacitor c=0.0122936f //x=71.9 //y=2.93
c332 ( 14 0 ) capacitor c=0.0181662f //x=71.9 //y=2.61
c333 ( 12 0 ) capacitor c=0.00493487f //x=71.5 //y=1.845
c334 ( 11 0 ) capacitor c=0.0129068f //x=71.815 //y=1.845
c335 ( 10 0 ) capacitor c=0.0167992f //x=71.415 //y=1.76
c336 ( 9 0 ) capacitor c=0.0112867f //x=71.415 //y=1.305
c337 ( 7 0 ) capacitor c=0.0262524f //x=71.815 //y=5.335
c338 ( 6 0 ) capacitor c=0.00933983f //x=71.12 //y=5.56
c339 ( 3 0 ) capacitor c=0.0162372f //x=71.005 //y=5.335
c340 ( 1 0 ) capacitor c=0.0162465f //x=70.12 //y=5.335
r341 (  114 116 ) resistor r=26.9307 //w=0.15 //l=0.106066 //layer=ply \
 //thickness=0.18 //x=74.315 //y=4.97 //x2=74.39 //y2=5.045
r342 (  114 115 ) resistor r=148.702 //w=0.094 //l=0.29 //layer=ply \
 //thickness=0.18 //x=74.315 //y=4.97 //x2=74.025 //y2=4.97
r343 (  113 126 ) resistor r=45.1352 //w=0.168 //l=0.173853 //layer=ply \
 //thickness=0.18 //x=73.98 //y=1.4 //x2=73.94 //y2=1.555
r344 (  112 125 ) resistor r=45.1352 //w=0.168 //l=0.173853 //layer=ply \
 //thickness=0.18 //x=73.98 //y=1.055 //x2=73.94 //y2=0.9
r345 (  112 113 ) resistor r=176.904 //w=0.094 //l=0.345 //layer=ply \
 //thickness=0.18 //x=73.98 //y=1.055 //x2=73.98 //y2=1.4
r346 (  109 115 ) resistor r=22.7971 //w=0.269 //l=0.106066 //layer=ply \
 //thickness=0.18 //x=73.95 //y=5.045 //x2=74.025 //y2=4.97
r347 (  109 124 ) resistor r=35.8364 //w=0.269 //l=0.270185 //layer=ply \
 //thickness=0.18 //x=73.95 //y=5.045 //x2=73.75 //y2=4.88
r348 (  107 120 ) resistor r=10.701 //w=0.21 //l=0.115 //layer=ply \
 //thickness=0.18 //x=73.605 //y=1.555 //x2=73.49 //y2=1.555
r349 (  106 126 ) resistor r=5.52526 //w=0.168 //l=0.115 //layer=ply \
 //thickness=0.18 //x=73.825 //y=1.555 //x2=73.94 //y2=1.555
r350 (  105 119 ) resistor r=5.52526 //w=0.168 //l=0.115 //layer=ply \
 //thickness=0.18 //x=73.605 //y=0.9 //x2=73.49 //y2=0.9
r351 (  104 125 ) resistor r=5.52526 //w=0.168 //l=0.115 //layer=ply \
 //thickness=0.18 //x=73.825 //y=0.9 //x2=73.94 //y2=0.9
r352 (  104 105 ) resistor r=112.809 //w=0.094 //l=0.22 //layer=ply \
 //thickness=0.18 //x=73.825 //y=0.9 //x2=73.605 //y2=0.9
r353 (  103 122 ) resistor r=58.7805 //w=0.246 //l=0.373497 //layer=ply \
 //thickness=0.18 //x=73.45 //y=2.095 //x2=73.75 //y2=2.26
r354 (  102 120 ) resistor r=39.5823 //w=0.21 //l=0.173853 //layer=ply \
 //thickness=0.18 //x=73.45 //y=1.71 //x2=73.49 //y2=1.555
r355 (  102 103 ) resistor r=197.415 //w=0.094 //l=0.385 //layer=ply \
 //thickness=0.18 //x=73.45 //y=1.71 //x2=73.45 //y2=2.095
r356 (  101 120 ) resistor r=39.5823 //w=0.21 //l=0.173853 //layer=ply \
 //thickness=0.18 //x=73.45 //y=1.4 //x2=73.49 //y2=1.555
r357 (  100 119 ) resistor r=45.1352 //w=0.168 //l=0.173853 //layer=ply \
 //thickness=0.18 //x=73.45 //y=1.055 //x2=73.49 //y2=0.9
r358 (  100 101 ) resistor r=176.904 //w=0.094 //l=0.345 //layer=ply \
 //thickness=0.18 //x=73.45 //y=1.055 //x2=73.45 //y2=1.4
r359 (  99 116 ) resistor r=592.245 //w=0.094 //l=1.155 //layer=ply \
 //thickness=0.18 //x=74.39 //y=6.2 //x2=74.39 //y2=5.045
r360 (  98 109 ) resistor r=592.245 //w=0.094 //l=1.155 //layer=ply \
 //thickness=0.18 //x=73.95 //y=6.2 //x2=73.95 //y2=5.045
r361 (  97 106 ) resistor r=56.4043 //w=0.094 //l=0.11 //layer=ply \
 //thickness=0.18 //x=73.715 //y=1.555 //x2=73.825 //y2=1.555
r362 (  97 107 ) resistor r=56.4043 //w=0.094 //l=0.11 //layer=ply \
 //thickness=0.18 //x=73.715 //y=1.555 //x2=73.605 //y2=1.555
r363 (  93 124 ) resistor r=152 //w=0.17 //l=0.17 //layer=licon //count=1 \
 //x=73.75 //y=4.88 //x2=73.75 //y2=4.88
r364 (  84 122 ) resistor r=152 //w=0.17 //l=0.17 //layer=licon //count=1 \
 //x=73.75 //y=2.26 //x2=73.75 //y2=2.26
r365 (  67 131 ) resistor r=23.615 //w=0.187 //l=0.345 //layer=li \
 //thickness=0.1 //x=71.12 //y=5.56 //x2=71.12 //y2=5.905
r366 (  59 130 ) resistor r=23.615 //w=0.187 //l=0.345 //layer=li \
 //thickness=0.1 //x=70.24 //y=5.56 //x2=70.24 //y2=5.905
r367 (  51 129 ) resistor r=23.615 //w=0.187 //l=0.345 //layer=li \
 //thickness=0.1 //x=69.36 //y=5.56 //x2=69.36 //y2=5.905
r368 (  43 45 ) resistor r=0.10734 //w=0.281 //l=0.16 //layer=m2 \
 //thickness=0.36 //x=72.06 //y=2.77 //x2=71.9 //y2=2.77
r369 (  42 48 ) resistor r=0.10734 //w=0.281 //l=0.16 //layer=m2 \
 //thickness=0.36 //x=73.6 //y=2.77 //x2=73.76 //y2=2.77
r370 (  42 43 ) resistor r=1.46947 //w=0.131 //l=1.54 //layer=m2 \
 //thickness=0.36 //x=73.6 //y=2.77 //x2=72.06 //y2=2.77
r371 (  41 93 ) resistor r=9.3 //w=0.17 //l=0.17 //layer=mcon //count=1 \
 //x=73.75 //y=4.88 //x2=73.75 //y2=4.88
r372 (  39 84 ) resistor r=9.3 //w=0.17 //l=0.17 //layer=mcon //count=1 \
 //x=73.75 //y=2.26 //x2=73.75 //y2=2.26
r373 (  36 48 ) resistor r=4.5 //w=0.15 //l=0.15 //layer=via1 //count=1 \
 //x=73.76 //y=2.77 //x2=73.76 //y2=2.77
r374 (  33 45 ) resistor r=4.5 //w=0.15 //l=0.15 //layer=via1 //count=1 \
 //x=71.9 //y=2.77 //x2=71.9 //y2=2.77
r375 (  31 127 ) resistor r=9.3 //w=0.17 //l=0.17 //layer=mcon //count=1 \
 //x=71.415 //y=1.19 //x2=71.415 //y2=1.19
r376 (  29 67 ) resistor r=9.3 //w=0.17 //l=0.17 //layer=mcon //count=1 \
 //x=71.12 //y=5.56 //x2=71.12 //y2=5.56
r377 (  26 59 ) resistor r=9.3 //w=0.17 //l=0.17 //layer=mcon //count=1 \
 //x=70.24 //y=5.56 //x2=70.24 //y2=5.56
r378 (  24 26 ) resistor r=0.121228 //w=0.232 //l=0.225 //layer=m1 \
 //thickness=0.36 //x=70.24 //y=5.335 //x2=70.24 //y2=5.56
r379 (  23 51 ) resistor r=9.3 //w=0.17 //l=0.17 //layer=mcon //count=1 \
 //x=69.36 //y=5.56 //x2=69.36 //y2=5.56
r380 (  21 23 ) resistor r=0.129608 //w=0.217 //l=0.225 //layer=m1 \
 //thickness=0.36 //x=69.362 //y=5.335 //x2=69.362 //y2=5.56
r381 (  20 41 ) resistor r=0.0760407 //w=0.238 //l=0.125 //layer=m1 \
 //thickness=0.36 //x=73.75 //y=4.755 //x2=73.75 //y2=4.88
r382 (  19 36 ) resistor r=0.0914072 //w=0.382 //l=0.182428 //layer=m1 \
 //thickness=0.36 //x=73.75 //y=2.93 //x2=73.702 //y2=2.77
r383 (  19 20 ) resistor r=1.74141 //w=0.131 //l=1.825 //layer=m1 \
 //thickness=0.36 //x=73.75 //y=2.93 //x2=73.75 //y2=4.755
r384 (  18 36 ) resistor r=0.0914072 //w=0.382 //l=0.182428 //layer=m1 \
 //thickness=0.36 //x=73.75 //y=2.61 //x2=73.702 //y2=2.77
r385 (  17 39 ) resistor r=0.0719237 //w=0.222 //l=0.115 //layer=m1 \
 //thickness=0.36 //x=73.75 //y=2.375 //x2=73.75 //y2=2.26
r386 (  17 18 ) resistor r=0.224237 //w=0.131 //l=0.235 //layer=m1 \
 //thickness=0.36 //x=73.75 //y=2.375 //x2=73.75 //y2=2.61
r387 (  15 33 ) resistor r=0.0911593 //w=0.376 //l=0.184174 //layer=m1 \
 //thickness=0.36 //x=71.9 //y=2.93 //x2=71.952 //y2=2.77
r388 (  15 16 ) resistor r=2.21374 //w=0.131 //l=2.32 //layer=m1 \
 //thickness=0.36 //x=71.9 //y=2.93 //x2=71.9 //y2=5.25
r389 (  14 33 ) resistor r=0.0911593 //w=0.376 //l=0.184174 //layer=m1 \
 //thickness=0.36 //x=71.9 //y=2.61 //x2=71.952 //y2=2.77
r390 (  13 14 ) resistor r=0.648855 //w=0.131 //l=0.68 //layer=m1 \
 //thickness=0.36 //x=71.9 //y=1.93 //x2=71.9 //y2=2.61
r391 (  11 13 ) resistor r=0.0698411 //w=0.17 //l=0.120208 //layer=m1 \
 //thickness=0.36 //x=71.815 //y=1.845 //x2=71.9 //y2=1.93
r392 (  11 12 ) resistor r=0.300573 //w=0.131 //l=0.315 //layer=m1 \
 //thickness=0.36 //x=71.815 //y=1.845 //x2=71.5 //y2=1.845
r393 (  10 12 ) resistor r=0.0698411 //w=0.17 //l=0.120208 //layer=m1 \
 //thickness=0.36 //x=71.415 //y=1.76 //x2=71.5 //y2=1.845
r394 (  9 31 ) resistor r=0.0717383 //w=0.224 //l=0.115 //layer=m1 \
 //thickness=0.36 //x=71.415 //y=1.305 //x2=71.415 //y2=1.19
r395 (  9 10 ) resistor r=0.43416 //w=0.131 //l=0.455 //layer=m1 \
 //thickness=0.36 //x=71.415 //y=1.305 //x2=71.415 //y2=1.76
r396 (  8 27 ) resistor r=0.0675342 //w=0.23 //l=0.115 //layer=m1 \
 //thickness=0.36 //x=71.235 //y=5.335 //x2=71.12 //y2=5.335
r397 (  7 16 ) resistor r=0.0698411 //w=0.17 //l=0.120208 //layer=m1 \
 //thickness=0.36 //x=71.815 //y=5.335 //x2=71.9 //y2=5.25
r398 (  7 8 ) resistor r=0.553435 //w=0.131 //l=0.58 //layer=m1 \
 //thickness=0.36 //x=71.815 //y=5.335 //x2=71.235 //y2=5.335
r399 (  6 29 ) resistor r=0.00118313 //w=0.23 //layer=m1 //thickness=0.36 \
 //x=71.12 //y=5.56 //x2=71.12 //y2=5.56
r400 (  5 27 ) resistor r=0.002872 //w=0.34 //l=0.085 //layer=m1 \
 //thickness=0.36 //x=71.12 //y=5.42 //x2=71.12 //y2=5.335
r401 (  5 6 ) resistor r=0.091623 //w=0.191 //l=0.14 //layer=m1 \
 //thickness=0.36 //x=71.12 //y=5.42 //x2=71.12 //y2=5.56
r402 (  4 24 ) resistor r=0.0262263 //w=0.232 //l=0.12 //layer=m1 \
 //thickness=0.36 //x=70.36 //y=5.335 //x2=70.24 //y2=5.335
r403 (  3 27 ) resistor r=0.0675342 //w=0.23 //l=0.115 //layer=m1 \
 //thickness=0.36 //x=71.005 //y=5.335 //x2=71.12 //y2=5.335
r404 (  3 4 ) resistor r=0.615458 //w=0.131 //l=0.645 //layer=m1 \
 //thickness=0.36 //x=71.005 //y=5.335 //x2=70.36 //y2=5.335
r405 (  2 21 ) resistor r=0.0222262 //w=0.217 //l=0.118 //layer=m1 \
 //thickness=0.36 //x=69.48 //y=5.335 //x2=69.362 //y2=5.335
r406 (  1 24 ) resistor r=0.0262263 //w=0.232 //l=0.12 //layer=m1 \
 //thickness=0.36 //x=70.12 //y=5.335 //x2=70.24 //y2=5.335
r407 (  1 2 ) resistor r=0.610687 //w=0.131 //l=0.64 //layer=m1 \
 //thickness=0.36 //x=70.12 //y=5.335 //x2=69.48 //y2=5.335
ends PM_TMRDFFSNRNQNX1\%noxref_14

subckt PM_TMRDFFSNRNQNX1\%CLK ( 1 2 3 4 5 6 7 8 9 10 11 12 13 18 22 26 30 33 \
 40 46 52 58 64 70 73 75 77 79 81 83 86 91 96 101 106 110 115 120 125 130 135 \
 140 145 150 155 160 165 169 170 171 172 173 174 175 176 177 178 179 180 181 \
 182 183 184 185 186 187 188 189 191 197 198 199 200 201 206 207 208 210 216 \
 217 218 219 220 225 226 227 229 235 236 237 238 239 244 245 246 248 254 255 \
 256 257 258 263 264 265 267 273 274 275 276 277 282 283 284 286 292 293 294 \
 295 296 304 315 326 337 348 359 )
c954 ( 359 0 ) capacitor c=0.0357436f //x=74.86 //y=4.88
c955 ( 348 0 ) capacitor c=0.0357436f //x=65.24 //y=4.88
c956 ( 337 0 ) capacitor c=0.0357436f //x=46 //y=4.88
c957 ( 326 0 ) capacitor c=0.0357445f //x=36.38 //y=4.88
c958 ( 315 0 ) capacitor c=0.0357436f //x=17.14 //y=4.88
c959 ( 304 0 ) capacitor c=0.0357436f //x=7.52 //y=4.88
c960 ( 296 0 ) capacitor c=0.0305218f //x=75.195 //y=4.97
c961 ( 295 0 ) capacitor c=0.0863671f //x=74.95 //y=2.095
c962 ( 294 0 ) capacitor c=0.0170266f //x=74.95 //y=1.63
c963 ( 293 0 ) capacitor c=0.018609f //x=74.95 //y=1.4
c964 ( 292 0 ) capacitor c=0.0186599f //x=74.95 //y=1.09
c965 ( 286 0 ) capacitor c=0.0146988f //x=74.795 //y=1.555
c966 ( 284 0 ) capacitor c=0.0148531f //x=74.795 //y=0.935
c967 ( 283 0 ) capacitor c=0.0334406f //x=74.425 //y=1.4
c968 ( 282 0 ) capacitor c=0.0173191f //x=74.425 //y=1.09
c969 ( 277 0 ) capacitor c=0.0306608f //x=65.575 //y=4.97
c970 ( 276 0 ) capacitor c=0.0863671f //x=65.33 //y=2.095
c971 ( 275 0 ) capacitor c=0.0170266f //x=65.33 //y=1.63
c972 ( 274 0 ) capacitor c=0.018609f //x=65.33 //y=1.4
c973 ( 273 0 ) capacitor c=0.0186599f //x=65.33 //y=1.09
c974 ( 267 0 ) capacitor c=0.0146988f //x=65.175 //y=1.555
c975 ( 265 0 ) capacitor c=0.0148531f //x=65.175 //y=0.935
c976 ( 264 0 ) capacitor c=0.0334406f //x=64.805 //y=1.4
c977 ( 263 0 ) capacitor c=0.0173191f //x=64.805 //y=1.09
c978 ( 258 0 ) capacitor c=0.0305218f //x=46.335 //y=4.97
c979 ( 257 0 ) capacitor c=0.0863671f //x=46.09 //y=2.095
c980 ( 256 0 ) capacitor c=0.0170266f //x=46.09 //y=1.63
c981 ( 255 0 ) capacitor c=0.018609f //x=46.09 //y=1.4
c982 ( 254 0 ) capacitor c=0.0186599f //x=46.09 //y=1.09
c983 ( 248 0 ) capacitor c=0.0146988f //x=45.935 //y=1.555
c984 ( 246 0 ) capacitor c=0.0148531f //x=45.935 //y=0.935
c985 ( 245 0 ) capacitor c=0.0334406f //x=45.565 //y=1.4
c986 ( 244 0 ) capacitor c=0.0173191f //x=45.565 //y=1.09
c987 ( 239 0 ) capacitor c=0.0306608f //x=36.715 //y=4.97
c988 ( 238 0 ) capacitor c=0.0863671f //x=36.47 //y=2.095
c989 ( 237 0 ) capacitor c=0.0170266f //x=36.47 //y=1.63
c990 ( 236 0 ) capacitor c=0.018609f //x=36.47 //y=1.4
c991 ( 235 0 ) capacitor c=0.0186599f //x=36.47 //y=1.09
c992 ( 229 0 ) capacitor c=0.0146988f //x=36.315 //y=1.555
c993 ( 227 0 ) capacitor c=0.0148531f //x=36.315 //y=0.935
c994 ( 226 0 ) capacitor c=0.0334406f //x=35.945 //y=1.4
c995 ( 225 0 ) capacitor c=0.0173191f //x=35.945 //y=1.09
c996 ( 220 0 ) capacitor c=0.0305218f //x=17.475 //y=4.97
c997 ( 219 0 ) capacitor c=0.0863671f //x=17.23 //y=2.095
c998 ( 218 0 ) capacitor c=0.0170266f //x=17.23 //y=1.63
c999 ( 217 0 ) capacitor c=0.018609f //x=17.23 //y=1.4
c1000 ( 216 0 ) capacitor c=0.0186599f //x=17.23 //y=1.09
c1001 ( 210 0 ) capacitor c=0.0146988f //x=17.075 //y=1.555
c1002 ( 208 0 ) capacitor c=0.0148531f //x=17.075 //y=0.935
c1003 ( 207 0 ) capacitor c=0.0334406f //x=16.705 //y=1.4
c1004 ( 206 0 ) capacitor c=0.0173191f //x=16.705 //y=1.09
c1005 ( 201 0 ) capacitor c=0.0306608f //x=7.855 //y=4.97
c1006 ( 200 0 ) capacitor c=0.0863671f //x=7.61 //y=2.095
c1007 ( 199 0 ) capacitor c=0.0170266f //x=7.61 //y=1.63
c1008 ( 198 0 ) capacitor c=0.018609f //x=7.61 //y=1.4
c1009 ( 197 0 ) capacitor c=0.0186599f //x=7.61 //y=1.09
c1010 ( 191 0 ) capacitor c=0.0146988f //x=7.455 //y=1.555
c1011 ( 189 0 ) capacitor c=0.0148531f //x=7.455 //y=0.935
c1012 ( 188 0 ) capacitor c=0.0334406f //x=7.085 //y=1.4
c1013 ( 187 0 ) capacitor c=0.0173191f //x=7.085 //y=1.09
c1014 ( 186 0 ) capacitor c=0.110301f //x=75.27 //y=6.2
c1015 ( 185 0 ) capacitor c=0.110214f //x=74.83 //y=6.2
c1016 ( 184 0 ) capacitor c=0.110208f //x=65.65 //y=6.2
c1017 ( 183 0 ) capacitor c=0.110214f //x=65.21 //y=6.2
c1018 ( 182 0 ) capacitor c=0.110208f //x=46.41 //y=6.2
c1019 ( 181 0 ) capacitor c=0.110214f //x=45.97 //y=6.2
c1020 ( 180 0 ) capacitor c=0.110253f //x=36.79 //y=6.2
c1021 ( 179 0 ) capacitor c=0.110255f //x=36.35 //y=6.2
c1022 ( 178 0 ) capacitor c=0.110208f //x=17.55 //y=6.2
c1023 ( 177 0 ) capacitor c=0.110214f //x=17.11 //y=6.2
c1024 ( 176 0 ) capacitor c=0.110208f //x=7.93 //y=6.2
c1025 ( 175 0 ) capacitor c=0.110214f //x=7.49 //y=6.2
c1026 ( 165 0 ) capacitor c=0.00129935f //x=74.86 //y=4.88
c1027 ( 160 0 ) capacitor c=0.00121786f //x=74.86 //y=2.26
c1028 ( 155 0 ) capacitor c=0.00129935f //x=65.24 //y=4.88
c1029 ( 150 0 ) capacitor c=0.00121786f //x=65.24 //y=2.26
c1030 ( 145 0 ) capacitor c=0.00129935f //x=46 //y=4.88
c1031 ( 140 0 ) capacitor c=0.00121786f //x=46 //y=2.26
c1032 ( 135 0 ) capacitor c=0.00129935f //x=36.38 //y=4.88
c1033 ( 130 0 ) capacitor c=0.00121786f //x=36.38 //y=2.26
c1034 ( 125 0 ) capacitor c=0.00129935f //x=17.14 //y=4.88
c1035 ( 120 0 ) capacitor c=0.00121786f //x=17.14 //y=2.26
c1036 ( 115 0 ) capacitor c=0.00129935f //x=7.52 //y=4.88
c1037 ( 110 0 ) capacitor c=0.00121786f //x=7.52 //y=2.26
c1038 ( 106 0 ) capacitor c=0.00133493f //x=74.865 //y=4.62
c1039 ( 101 0 ) capacitor c=0.00199937f //x=65.235 //y=4.62
c1040 ( 96 0 ) capacitor c=0.00155307f //x=46.005 //y=4.62
c1041 ( 91 0 ) capacitor c=0.00158028f //x=36.375 //y=4.62
c1042 ( 86 0 ) capacitor c=0.00466776f //x=17.145 //y=4.62
c1043 ( 83 0 ) capacitor c=0.0105362f //x=7.515 //y=4.62
c1044 ( 81 0 ) capacitor c=0.105085f //x=74.705 //y=4.62
c1045 ( 79 0 ) capacitor c=0.229572f //x=65.075 //y=4.62
c1046 ( 77 0 ) capacitor c=0.105107f //x=45.845 //y=4.62
c1047 ( 75 0 ) capacitor c=0.269087f //x=36.215 //y=4.62
c1048 ( 73 0 ) capacitor c=0.232869f //x=16.985 //y=4.62
c1049 ( 70 0 ) capacitor c=0.00784074f //x=74.865 //y=4.835
c1050 ( 64 0 ) capacitor c=0.00819385f //x=65.235 //y=4.835
c1051 ( 58 0 ) capacitor c=0.00794951f //x=46.005 //y=4.835
c1052 ( 52 0 ) capacitor c=0.00797463f //x=36.375 //y=4.835
c1053 ( 46 0 ) capacitor c=0.0077588f //x=17.145 //y=4.835
c1054 ( 40 0 ) capacitor c=0.00779217f //x=7.515 //y=4.835
c1055 ( 33 0 ) capacitor c=0.00378707f //x=74.86 //y=2.375
c1056 ( 30 0 ) capacitor c=0.00380207f //x=65.24 //y=2.375
c1057 ( 26 0 ) capacitor c=0.00378707f //x=46 //y=2.375
c1058 ( 22 0 ) capacitor c=0.00380207f //x=36.38 //y=2.375
c1059 ( 18 0 ) capacitor c=0.00378707f //x=17.14 //y=2.375
c1060 ( 13 0 ) capacitor c=0.00380207f //x=7.52 //y=2.375
c1061 ( 11 0 ) capacitor c=0.0617495f //x=74.86 //y=2.77
c1062 ( 10 0 ) capacitor c=0.0599742f //x=65.24 //y=4.62
c1063 ( 8 0 ) capacitor c=0.0617495f //x=46 //y=2.77
c1064 ( 6 0 ) capacitor c=0.0604929f //x=36.38 //y=3.88
c1065 ( 4 0 ) capacitor c=0.0617495f //x=17.14 //y=2.77
c1066 ( 1 0 ) capacitor c=0.0633306f //x=7.52 //y=3.14
r1067 (  361 362 ) resistor r=32.4568 //w=0.214 //l=0.075 //layer=ply \
 //thickness=0.18 //x=74.86 //y=4.97 //x2=74.86 //y2=5.045
r1068 (  359 361 ) resistor r=20.271 //w=0.214 //l=0.09 //layer=ply \
 //thickness=0.18 //x=74.86 //y=4.88 //x2=74.86 //y2=4.97
r1069 (  350 351 ) resistor r=32.4568 //w=0.214 //l=0.075 //layer=ply \
 //thickness=0.18 //x=65.24 //y=4.97 //x2=65.24 //y2=5.045
r1070 (  348 350 ) resistor r=20.271 //w=0.214 //l=0.09 //layer=ply \
 //thickness=0.18 //x=65.24 //y=4.88 //x2=65.24 //y2=4.97
r1071 (  339 340 ) resistor r=32.4568 //w=0.214 //l=0.075 //layer=ply \
 //thickness=0.18 //x=46 //y=4.97 //x2=46 //y2=5.045
r1072 (  337 339 ) resistor r=20.271 //w=0.214 //l=0.09 //layer=ply \
 //thickness=0.18 //x=46 //y=4.88 //x2=46 //y2=4.97
r1073 (  328 329 ) resistor r=32.4568 //w=0.214 //l=0.075 //layer=ply \
 //thickness=0.18 //x=36.38 //y=4.97 //x2=36.38 //y2=5.045
r1074 (  326 328 ) resistor r=20.271 //w=0.214 //l=0.09 //layer=ply \
 //thickness=0.18 //x=36.38 //y=4.88 //x2=36.38 //y2=4.97
r1075 (  317 318 ) resistor r=32.4568 //w=0.214 //l=0.075 //layer=ply \
 //thickness=0.18 //x=17.14 //y=4.97 //x2=17.14 //y2=5.045
r1076 (  315 317 ) resistor r=20.271 //w=0.214 //l=0.09 //layer=ply \
 //thickness=0.18 //x=17.14 //y=4.88 //x2=17.14 //y2=4.97
r1077 (  306 307 ) resistor r=32.4568 //w=0.214 //l=0.075 //layer=ply \
 //thickness=0.18 //x=7.52 //y=4.97 //x2=7.52 //y2=5.045
r1078 (  304 306 ) resistor r=20.271 //w=0.214 //l=0.09 //layer=ply \
 //thickness=0.18 //x=7.52 //y=4.88 //x2=7.52 //y2=4.97
r1079 (  297 361 ) resistor r=16.5046 //w=0.27 //l=0.135 //layer=ply \
 //thickness=0.18 //x=74.995 //y=4.97 //x2=74.86 //y2=4.97
r1080 (  296 298 ) resistor r=26.9307 //w=0.15 //l=0.106066 //layer=ply \
 //thickness=0.18 //x=75.195 //y=4.97 //x2=75.27 //y2=5.045
r1081 (  296 297 ) resistor r=102.553 //w=0.094 //l=0.2 //layer=ply \
 //thickness=0.18 //x=75.195 //y=4.97 //x2=74.995 //y2=4.97
r1082 (  295 366 ) resistor r=38.6777 //w=0.284 //l=0.198997 //layer=ply \
 //thickness=0.18 //x=74.95 //y=2.095 //x2=74.875 //y2=2.26
r1083 (  294 364 ) resistor r=21.2976 //w=0.217 //l=0.0928709 //layer=ply \
 //thickness=0.18 //x=74.95 //y=1.63 //x2=74.91 //y2=1.555
r1084 (  294 295 ) resistor r=238.436 //w=0.094 //l=0.465 //layer=ply \
 //thickness=0.18 //x=74.95 //y=1.63 //x2=74.95 //y2=2.095
r1085 (  293 364 ) resistor r=39.0671 //w=0.217 //l=0.173853 //layer=ply \
 //thickness=0.18 //x=74.95 //y=1.4 //x2=74.91 //y2=1.555
r1086 (  292 363 ) resistor r=45.1352 //w=0.168 //l=0.173853 //layer=ply \
 //thickness=0.18 //x=74.95 //y=1.09 //x2=74.91 //y2=0.935
r1087 (  292 293 ) resistor r=158.957 //w=0.094 //l=0.31 //layer=ply \
 //thickness=0.18 //x=74.95 //y=1.09 //x2=74.95 //y2=1.4
r1088 (  287 357 ) resistor r=5.52526 //w=0.168 //l=0.115 //layer=ply \
 //thickness=0.18 //x=74.58 //y=1.555 //x2=74.465 //y2=1.555
r1089 (  286 364 ) resistor r=11.4558 //w=0.217 //l=0.115 //layer=ply \
 //thickness=0.18 //x=74.795 //y=1.555 //x2=74.91 //y2=1.555
r1090 (  285 356 ) resistor r=5.52526 //w=0.168 //l=0.115 //layer=ply \
 //thickness=0.18 //x=74.58 //y=0.935 //x2=74.465 //y2=0.935
r1091 (  284 363 ) resistor r=5.52526 //w=0.168 //l=0.115 //layer=ply \
 //thickness=0.18 //x=74.795 //y=0.935 //x2=74.91 //y2=0.935
r1092 (  284 285 ) resistor r=110.245 //w=0.094 //l=0.215 //layer=ply \
 //thickness=0.18 //x=74.795 //y=0.935 //x2=74.58 //y2=0.935
r1093 (  283 357 ) resistor r=45.1352 //w=0.168 //l=0.173853 //layer=ply \
 //thickness=0.18 //x=74.425 //y=1.4 //x2=74.465 //y2=1.555
r1094 (  282 356 ) resistor r=45.1352 //w=0.168 //l=0.173853 //layer=ply \
 //thickness=0.18 //x=74.425 //y=1.09 //x2=74.465 //y2=0.935
r1095 (  282 283 ) resistor r=158.957 //w=0.094 //l=0.31 //layer=ply \
 //thickness=0.18 //x=74.425 //y=1.09 //x2=74.425 //y2=1.4
r1096 (  278 350 ) resistor r=16.5046 //w=0.27 //l=0.135 //layer=ply \
 //thickness=0.18 //x=65.375 //y=4.97 //x2=65.24 //y2=4.97
r1097 (  277 279 ) resistor r=26.9307 //w=0.15 //l=0.106066 //layer=ply \
 //thickness=0.18 //x=65.575 //y=4.97 //x2=65.65 //y2=5.045
r1098 (  277 278 ) resistor r=102.553 //w=0.094 //l=0.2 //layer=ply \
 //thickness=0.18 //x=65.575 //y=4.97 //x2=65.375 //y2=4.97
r1099 (  276 355 ) resistor r=38.6777 //w=0.284 //l=0.198997 //layer=ply \
 //thickness=0.18 //x=65.33 //y=2.095 //x2=65.255 //y2=2.26
r1100 (  275 353 ) resistor r=21.2976 //w=0.217 //l=0.0928709 //layer=ply \
 //thickness=0.18 //x=65.33 //y=1.63 //x2=65.29 //y2=1.555
r1101 (  275 276 ) resistor r=238.436 //w=0.094 //l=0.465 //layer=ply \
 //thickness=0.18 //x=65.33 //y=1.63 //x2=65.33 //y2=2.095
r1102 (  274 353 ) resistor r=39.0671 //w=0.217 //l=0.173853 //layer=ply \
 //thickness=0.18 //x=65.33 //y=1.4 //x2=65.29 //y2=1.555
r1103 (  273 352 ) resistor r=45.1352 //w=0.168 //l=0.173853 //layer=ply \
 //thickness=0.18 //x=65.33 //y=1.09 //x2=65.29 //y2=0.935
r1104 (  273 274 ) resistor r=158.957 //w=0.094 //l=0.31 //layer=ply \
 //thickness=0.18 //x=65.33 //y=1.09 //x2=65.33 //y2=1.4
r1105 (  268 346 ) resistor r=5.52526 //w=0.168 //l=0.115 //layer=ply \
 //thickness=0.18 //x=64.96 //y=1.555 //x2=64.845 //y2=1.555
r1106 (  267 353 ) resistor r=11.4558 //w=0.217 //l=0.115 //layer=ply \
 //thickness=0.18 //x=65.175 //y=1.555 //x2=65.29 //y2=1.555
r1107 (  266 345 ) resistor r=5.52526 //w=0.168 //l=0.115 //layer=ply \
 //thickness=0.18 //x=64.96 //y=0.935 //x2=64.845 //y2=0.935
r1108 (  265 352 ) resistor r=5.52526 //w=0.168 //l=0.115 //layer=ply \
 //thickness=0.18 //x=65.175 //y=0.935 //x2=65.29 //y2=0.935
r1109 (  265 266 ) resistor r=110.245 //w=0.094 //l=0.215 //layer=ply \
 //thickness=0.18 //x=65.175 //y=0.935 //x2=64.96 //y2=0.935
r1110 (  264 346 ) resistor r=45.1352 //w=0.168 //l=0.173853 //layer=ply \
 //thickness=0.18 //x=64.805 //y=1.4 //x2=64.845 //y2=1.555
r1111 (  263 345 ) resistor r=45.1352 //w=0.168 //l=0.173853 //layer=ply \
 //thickness=0.18 //x=64.805 //y=1.09 //x2=64.845 //y2=0.935
r1112 (  263 264 ) resistor r=158.957 //w=0.094 //l=0.31 //layer=ply \
 //thickness=0.18 //x=64.805 //y=1.09 //x2=64.805 //y2=1.4
r1113 (  259 339 ) resistor r=16.5046 //w=0.27 //l=0.135 //layer=ply \
 //thickness=0.18 //x=46.135 //y=4.97 //x2=46 //y2=4.97
r1114 (  258 260 ) resistor r=26.9307 //w=0.15 //l=0.106066 //layer=ply \
 //thickness=0.18 //x=46.335 //y=4.97 //x2=46.41 //y2=5.045
r1115 (  258 259 ) resistor r=102.553 //w=0.094 //l=0.2 //layer=ply \
 //thickness=0.18 //x=46.335 //y=4.97 //x2=46.135 //y2=4.97
r1116 (  257 344 ) resistor r=38.6777 //w=0.284 //l=0.198997 //layer=ply \
 //thickness=0.18 //x=46.09 //y=2.095 //x2=46.015 //y2=2.26
r1117 (  256 342 ) resistor r=21.2976 //w=0.217 //l=0.0928709 //layer=ply \
 //thickness=0.18 //x=46.09 //y=1.63 //x2=46.05 //y2=1.555
r1118 (  256 257 ) resistor r=238.436 //w=0.094 //l=0.465 //layer=ply \
 //thickness=0.18 //x=46.09 //y=1.63 //x2=46.09 //y2=2.095
r1119 (  255 342 ) resistor r=39.0671 //w=0.217 //l=0.173853 //layer=ply \
 //thickness=0.18 //x=46.09 //y=1.4 //x2=46.05 //y2=1.555
r1120 (  254 341 ) resistor r=45.1352 //w=0.168 //l=0.173853 //layer=ply \
 //thickness=0.18 //x=46.09 //y=1.09 //x2=46.05 //y2=0.935
r1121 (  254 255 ) resistor r=158.957 //w=0.094 //l=0.31 //layer=ply \
 //thickness=0.18 //x=46.09 //y=1.09 //x2=46.09 //y2=1.4
r1122 (  249 335 ) resistor r=5.52526 //w=0.168 //l=0.115 //layer=ply \
 //thickness=0.18 //x=45.72 //y=1.555 //x2=45.605 //y2=1.555
r1123 (  248 342 ) resistor r=11.4558 //w=0.217 //l=0.115 //layer=ply \
 //thickness=0.18 //x=45.935 //y=1.555 //x2=46.05 //y2=1.555
r1124 (  247 334 ) resistor r=5.52526 //w=0.168 //l=0.115 //layer=ply \
 //thickness=0.18 //x=45.72 //y=0.935 //x2=45.605 //y2=0.935
r1125 (  246 341 ) resistor r=5.52526 //w=0.168 //l=0.115 //layer=ply \
 //thickness=0.18 //x=45.935 //y=0.935 //x2=46.05 //y2=0.935
r1126 (  246 247 ) resistor r=110.245 //w=0.094 //l=0.215 //layer=ply \
 //thickness=0.18 //x=45.935 //y=0.935 //x2=45.72 //y2=0.935
r1127 (  245 335 ) resistor r=45.1352 //w=0.168 //l=0.173853 //layer=ply \
 //thickness=0.18 //x=45.565 //y=1.4 //x2=45.605 //y2=1.555
r1128 (  244 334 ) resistor r=45.1352 //w=0.168 //l=0.173853 //layer=ply \
 //thickness=0.18 //x=45.565 //y=1.09 //x2=45.605 //y2=0.935
r1129 (  244 245 ) resistor r=158.957 //w=0.094 //l=0.31 //layer=ply \
 //thickness=0.18 //x=45.565 //y=1.09 //x2=45.565 //y2=1.4
r1130 (  240 328 ) resistor r=16.5046 //w=0.27 //l=0.135 //layer=ply \
 //thickness=0.18 //x=36.515 //y=4.97 //x2=36.38 //y2=4.97
r1131 (  239 241 ) resistor r=26.9307 //w=0.15 //l=0.106066 //layer=ply \
 //thickness=0.18 //x=36.715 //y=4.97 //x2=36.79 //y2=5.045
r1132 (  239 240 ) resistor r=102.553 //w=0.094 //l=0.2 //layer=ply \
 //thickness=0.18 //x=36.715 //y=4.97 //x2=36.515 //y2=4.97
r1133 (  238 333 ) resistor r=38.6777 //w=0.284 //l=0.198997 //layer=ply \
 //thickness=0.18 //x=36.47 //y=2.095 //x2=36.395 //y2=2.26
r1134 (  237 331 ) resistor r=21.2976 //w=0.217 //l=0.0928709 //layer=ply \
 //thickness=0.18 //x=36.47 //y=1.63 //x2=36.43 //y2=1.555
r1135 (  237 238 ) resistor r=238.436 //w=0.094 //l=0.465 //layer=ply \
 //thickness=0.18 //x=36.47 //y=1.63 //x2=36.47 //y2=2.095
r1136 (  236 331 ) resistor r=39.0671 //w=0.217 //l=0.173853 //layer=ply \
 //thickness=0.18 //x=36.47 //y=1.4 //x2=36.43 //y2=1.555
r1137 (  235 330 ) resistor r=45.1352 //w=0.168 //l=0.173853 //layer=ply \
 //thickness=0.18 //x=36.47 //y=1.09 //x2=36.43 //y2=0.935
r1138 (  235 236 ) resistor r=158.957 //w=0.094 //l=0.31 //layer=ply \
 //thickness=0.18 //x=36.47 //y=1.09 //x2=36.47 //y2=1.4
r1139 (  230 324 ) resistor r=5.52526 //w=0.168 //l=0.115 //layer=ply \
 //thickness=0.18 //x=36.1 //y=1.555 //x2=35.985 //y2=1.555
r1140 (  229 331 ) resistor r=11.4558 //w=0.217 //l=0.115 //layer=ply \
 //thickness=0.18 //x=36.315 //y=1.555 //x2=36.43 //y2=1.555
r1141 (  228 323 ) resistor r=5.52526 //w=0.168 //l=0.115 //layer=ply \
 //thickness=0.18 //x=36.1 //y=0.935 //x2=35.985 //y2=0.935
r1142 (  227 330 ) resistor r=5.52526 //w=0.168 //l=0.115 //layer=ply \
 //thickness=0.18 //x=36.315 //y=0.935 //x2=36.43 //y2=0.935
r1143 (  227 228 ) resistor r=110.245 //w=0.094 //l=0.215 //layer=ply \
 //thickness=0.18 //x=36.315 //y=0.935 //x2=36.1 //y2=0.935
r1144 (  226 324 ) resistor r=45.1352 //w=0.168 //l=0.173853 //layer=ply \
 //thickness=0.18 //x=35.945 //y=1.4 //x2=35.985 //y2=1.555
r1145 (  225 323 ) resistor r=45.1352 //w=0.168 //l=0.173853 //layer=ply \
 //thickness=0.18 //x=35.945 //y=1.09 //x2=35.985 //y2=0.935
r1146 (  225 226 ) resistor r=158.957 //w=0.094 //l=0.31 //layer=ply \
 //thickness=0.18 //x=35.945 //y=1.09 //x2=35.945 //y2=1.4
r1147 (  221 317 ) resistor r=16.5046 //w=0.27 //l=0.135 //layer=ply \
 //thickness=0.18 //x=17.275 //y=4.97 //x2=17.14 //y2=4.97
r1148 (  220 222 ) resistor r=26.9307 //w=0.15 //l=0.106066 //layer=ply \
 //thickness=0.18 //x=17.475 //y=4.97 //x2=17.55 //y2=5.045
r1149 (  220 221 ) resistor r=102.553 //w=0.094 //l=0.2 //layer=ply \
 //thickness=0.18 //x=17.475 //y=4.97 //x2=17.275 //y2=4.97
r1150 (  219 322 ) resistor r=38.6777 //w=0.284 //l=0.198997 //layer=ply \
 //thickness=0.18 //x=17.23 //y=2.095 //x2=17.155 //y2=2.26
r1151 (  218 320 ) resistor r=21.2976 //w=0.217 //l=0.0928709 //layer=ply \
 //thickness=0.18 //x=17.23 //y=1.63 //x2=17.19 //y2=1.555
r1152 (  218 219 ) resistor r=238.436 //w=0.094 //l=0.465 //layer=ply \
 //thickness=0.18 //x=17.23 //y=1.63 //x2=17.23 //y2=2.095
r1153 (  217 320 ) resistor r=39.0671 //w=0.217 //l=0.173853 //layer=ply \
 //thickness=0.18 //x=17.23 //y=1.4 //x2=17.19 //y2=1.555
r1154 (  216 319 ) resistor r=45.1352 //w=0.168 //l=0.173853 //layer=ply \
 //thickness=0.18 //x=17.23 //y=1.09 //x2=17.19 //y2=0.935
r1155 (  216 217 ) resistor r=158.957 //w=0.094 //l=0.31 //layer=ply \
 //thickness=0.18 //x=17.23 //y=1.09 //x2=17.23 //y2=1.4
r1156 (  211 313 ) resistor r=5.52526 //w=0.168 //l=0.115 //layer=ply \
 //thickness=0.18 //x=16.86 //y=1.555 //x2=16.745 //y2=1.555
r1157 (  210 320 ) resistor r=11.4558 //w=0.217 //l=0.115 //layer=ply \
 //thickness=0.18 //x=17.075 //y=1.555 //x2=17.19 //y2=1.555
r1158 (  209 312 ) resistor r=5.52526 //w=0.168 //l=0.115 //layer=ply \
 //thickness=0.18 //x=16.86 //y=0.935 //x2=16.745 //y2=0.935
r1159 (  208 319 ) resistor r=5.52526 //w=0.168 //l=0.115 //layer=ply \
 //thickness=0.18 //x=17.075 //y=0.935 //x2=17.19 //y2=0.935
r1160 (  208 209 ) resistor r=110.245 //w=0.094 //l=0.215 //layer=ply \
 //thickness=0.18 //x=17.075 //y=0.935 //x2=16.86 //y2=0.935
r1161 (  207 313 ) resistor r=45.1352 //w=0.168 //l=0.173853 //layer=ply \
 //thickness=0.18 //x=16.705 //y=1.4 //x2=16.745 //y2=1.555
r1162 (  206 312 ) resistor r=45.1352 //w=0.168 //l=0.173853 //layer=ply \
 //thickness=0.18 //x=16.705 //y=1.09 //x2=16.745 //y2=0.935
r1163 (  206 207 ) resistor r=158.957 //w=0.094 //l=0.31 //layer=ply \
 //thickness=0.18 //x=16.705 //y=1.09 //x2=16.705 //y2=1.4
r1164 (  202 306 ) resistor r=16.5046 //w=0.27 //l=0.135 //layer=ply \
 //thickness=0.18 //x=7.655 //y=4.97 //x2=7.52 //y2=4.97
r1165 (  201 203 ) resistor r=26.9307 //w=0.15 //l=0.106066 //layer=ply \
 //thickness=0.18 //x=7.855 //y=4.97 //x2=7.93 //y2=5.045
r1166 (  201 202 ) resistor r=102.553 //w=0.094 //l=0.2 //layer=ply \
 //thickness=0.18 //x=7.855 //y=4.97 //x2=7.655 //y2=4.97
r1167 (  200 311 ) resistor r=38.6777 //w=0.284 //l=0.198997 //layer=ply \
 //thickness=0.18 //x=7.61 //y=2.095 //x2=7.535 //y2=2.26
r1168 (  199 309 ) resistor r=21.2976 //w=0.217 //l=0.0928709 //layer=ply \
 //thickness=0.18 //x=7.61 //y=1.63 //x2=7.57 //y2=1.555
r1169 (  199 200 ) resistor r=238.436 //w=0.094 //l=0.465 //layer=ply \
 //thickness=0.18 //x=7.61 //y=1.63 //x2=7.61 //y2=2.095
r1170 (  198 309 ) resistor r=39.0671 //w=0.217 //l=0.173853 //layer=ply \
 //thickness=0.18 //x=7.61 //y=1.4 //x2=7.57 //y2=1.555
r1171 (  197 308 ) resistor r=45.1352 //w=0.168 //l=0.173853 //layer=ply \
 //thickness=0.18 //x=7.61 //y=1.09 //x2=7.57 //y2=0.935
r1172 (  197 198 ) resistor r=158.957 //w=0.094 //l=0.31 //layer=ply \
 //thickness=0.18 //x=7.61 //y=1.09 //x2=7.61 //y2=1.4
r1173 (  192 302 ) resistor r=5.52526 //w=0.168 //l=0.115 //layer=ply \
 //thickness=0.18 //x=7.24 //y=1.555 //x2=7.125 //y2=1.555
r1174 (  191 309 ) resistor r=11.4558 //w=0.217 //l=0.115 //layer=ply \
 //thickness=0.18 //x=7.455 //y=1.555 //x2=7.57 //y2=1.555
r1175 (  190 301 ) resistor r=5.52526 //w=0.168 //l=0.115 //layer=ply \
 //thickness=0.18 //x=7.24 //y=0.935 //x2=7.125 //y2=0.935
r1176 (  189 308 ) resistor r=5.52526 //w=0.168 //l=0.115 //layer=ply \
 //thickness=0.18 //x=7.455 //y=0.935 //x2=7.57 //y2=0.935
r1177 (  189 190 ) resistor r=110.245 //w=0.094 //l=0.215 //layer=ply \
 //thickness=0.18 //x=7.455 //y=0.935 //x2=7.24 //y2=0.935
r1178 (  188 302 ) resistor r=45.1352 //w=0.168 //l=0.173853 //layer=ply \
 //thickness=0.18 //x=7.085 //y=1.4 //x2=7.125 //y2=1.555
r1179 (  187 301 ) resistor r=45.1352 //w=0.168 //l=0.173853 //layer=ply \
 //thickness=0.18 //x=7.085 //y=1.09 //x2=7.125 //y2=0.935
r1180 (  187 188 ) resistor r=158.957 //w=0.094 //l=0.31 //layer=ply \
 //thickness=0.18 //x=7.085 //y=1.09 //x2=7.085 //y2=1.4
r1181 (  186 298 ) resistor r=592.245 //w=0.094 //l=1.155 //layer=ply \
 //thickness=0.18 //x=75.27 //y=6.2 //x2=75.27 //y2=5.045
r1182 (  185 362 ) resistor r=592.245 //w=0.094 //l=1.155 //layer=ply \
 //thickness=0.18 //x=74.83 //y=6.2 //x2=74.83 //y2=5.045
r1183 (  184 279 ) resistor r=592.245 //w=0.094 //l=1.155 //layer=ply \
 //thickness=0.18 //x=65.65 //y=6.2 //x2=65.65 //y2=5.045
r1184 (  183 351 ) resistor r=592.245 //w=0.094 //l=1.155 //layer=ply \
 //thickness=0.18 //x=65.21 //y=6.2 //x2=65.21 //y2=5.045
r1185 (  182 260 ) resistor r=592.245 //w=0.094 //l=1.155 //layer=ply \
 //thickness=0.18 //x=46.41 //y=6.2 //x2=46.41 //y2=5.045
r1186 (  181 340 ) resistor r=592.245 //w=0.094 //l=1.155 //layer=ply \
 //thickness=0.18 //x=45.97 //y=6.2 //x2=45.97 //y2=5.045
r1187 (  180 241 ) resistor r=592.245 //w=0.094 //l=1.155 //layer=ply \
 //thickness=0.18 //x=36.79 //y=6.2 //x2=36.79 //y2=5.045
r1188 (  179 329 ) resistor r=592.245 //w=0.094 //l=1.155 //layer=ply \
 //thickness=0.18 //x=36.35 //y=6.2 //x2=36.35 //y2=5.045
r1189 (  178 222 ) resistor r=592.245 //w=0.094 //l=1.155 //layer=ply \
 //thickness=0.18 //x=17.55 //y=6.2 //x2=17.55 //y2=5.045
r1190 (  177 318 ) resistor r=592.245 //w=0.094 //l=1.155 //layer=ply \
 //thickness=0.18 //x=17.11 //y=6.2 //x2=17.11 //y2=5.045
r1191 (  176 203 ) resistor r=592.245 //w=0.094 //l=1.155 //layer=ply \
 //thickness=0.18 //x=7.93 //y=6.2 //x2=7.93 //y2=5.045
r1192 (  175 307 ) resistor r=592.245 //w=0.094 //l=1.155 //layer=ply \
 //thickness=0.18 //x=7.49 //y=6.2 //x2=7.49 //y2=5.045
r1193 (  174 286 ) resistor r=55.3787 //w=0.094 //l=0.108 //layer=ply \
 //thickness=0.18 //x=74.687 //y=1.555 //x2=74.795 //y2=1.555
r1194 (  174 287 ) resistor r=54.866 //w=0.094 //l=0.107 //layer=ply \
 //thickness=0.18 //x=74.687 //y=1.555 //x2=74.58 //y2=1.555
r1195 (  173 267 ) resistor r=55.3787 //w=0.094 //l=0.108 //layer=ply \
 //thickness=0.18 //x=65.067 //y=1.555 //x2=65.175 //y2=1.555
r1196 (  173 268 ) resistor r=54.866 //w=0.094 //l=0.107 //layer=ply \
 //thickness=0.18 //x=65.067 //y=1.555 //x2=64.96 //y2=1.555
r1197 (  172 248 ) resistor r=55.3787 //w=0.094 //l=0.108 //layer=ply \
 //thickness=0.18 //x=45.827 //y=1.555 //x2=45.935 //y2=1.555
r1198 (  172 249 ) resistor r=54.866 //w=0.094 //l=0.107 //layer=ply \
 //thickness=0.18 //x=45.827 //y=1.555 //x2=45.72 //y2=1.555
r1199 (  171 229 ) resistor r=55.3787 //w=0.094 //l=0.108 //layer=ply \
 //thickness=0.18 //x=36.207 //y=1.555 //x2=36.315 //y2=1.555
r1200 (  171 230 ) resistor r=54.866 //w=0.094 //l=0.107 //layer=ply \
 //thickness=0.18 //x=36.207 //y=1.555 //x2=36.1 //y2=1.555
r1201 (  170 210 ) resistor r=55.3787 //w=0.094 //l=0.108 //layer=ply \
 //thickness=0.18 //x=16.967 //y=1.555 //x2=17.075 //y2=1.555
r1202 (  170 211 ) resistor r=54.866 //w=0.094 //l=0.107 //layer=ply \
 //thickness=0.18 //x=16.967 //y=1.555 //x2=16.86 //y2=1.555
r1203 (  169 191 ) resistor r=55.3787 //w=0.094 //l=0.108 //layer=ply \
 //thickness=0.18 //x=7.347 //y=1.555 //x2=7.455 //y2=1.555
r1204 (  169 192 ) resistor r=54.866 //w=0.094 //l=0.107 //layer=ply \
 //thickness=0.18 //x=7.347 //y=1.555 //x2=7.24 //y2=1.555
r1205 (  165 359 ) resistor r=152 //w=0.17 //l=0.17 //layer=licon //count=1 \
 //x=74.86 //y=4.88 //x2=74.86 //y2=4.88
r1206 (  160 366 ) resistor r=152 //w=0.17 //l=0.17 //layer=licon //count=1 \
 //x=74.86 //y=2.26 //x2=74.86 //y2=2.26
r1207 (  155 348 ) resistor r=152 //w=0.17 //l=0.17 //layer=licon //count=1 \
 //x=65.24 //y=4.88 //x2=65.24 //y2=4.88
r1208 (  150 355 ) resistor r=152 //w=0.17 //l=0.17 //layer=licon //count=1 \
 //x=65.24 //y=2.26 //x2=65.24 //y2=2.26
r1209 (  145 337 ) resistor r=152 //w=0.17 //l=0.17 //layer=licon //count=1 \
 //x=46 //y=4.88 //x2=46 //y2=4.88
r1210 (  140 344 ) resistor r=152 //w=0.17 //l=0.17 //layer=licon //count=1 \
 //x=46 //y=2.26 //x2=46 //y2=2.26
r1211 (  135 326 ) resistor r=152 //w=0.17 //l=0.17 //layer=licon //count=1 \
 //x=36.38 //y=4.88 //x2=36.38 //y2=4.88
r1212 (  130 333 ) resistor r=152 //w=0.17 //l=0.17 //layer=licon //count=1 \
 //x=36.38 //y=2.26 //x2=36.38 //y2=2.26
r1213 (  125 315 ) resistor r=152 //w=0.17 //l=0.17 //layer=licon //count=1 \
 //x=17.14 //y=4.88 //x2=17.14 //y2=4.88
r1214 (  120 322 ) resistor r=152 //w=0.17 //l=0.17 //layer=licon //count=1 \
 //x=17.14 //y=2.26 //x2=17.14 //y2=2.26
r1215 (  115 304 ) resistor r=152 //w=0.17 //l=0.17 //layer=licon //count=1 \
 //x=7.52 //y=4.88 //x2=7.52 //y2=4.88
r1216 (  110 311 ) resistor r=152 //w=0.17 //l=0.17 //layer=licon //count=1 \
 //x=7.52 //y=2.26 //x2=7.52 //y2=2.26
r1217 (  106 108 ) resistor r=0.0907939 //w=0.296 //l=0.215 //layer=m2 \
 //thickness=0.36 //x=74.865 //y=4.62 //x2=74.865 //y2=4.835
r1218 (  101 104 ) resistor r=0.0956406 //w=0.281 //l=0.215 //layer=m2 \
 //thickness=0.36 //x=65.235 //y=4.62 //x2=65.235 //y2=4.835
r1219 (  96 99 ) resistor r=0.0956406 //w=0.281 //l=0.215 //layer=m2 \
 //thickness=0.36 //x=46.005 //y=4.62 //x2=46.005 //y2=4.835
r1220 (  91 94 ) resistor r=0.0956406 //w=0.281 //l=0.215 //layer=m2 \
 //thickness=0.36 //x=36.375 //y=4.62 //x2=36.375 //y2=4.835
r1221 (  86 89 ) resistor r=0.0956406 //w=0.281 //l=0.215 //layer=m2 \
 //thickness=0.36 //x=17.145 //y=4.62 //x2=17.145 //y2=4.835
r1222 (  83 85 ) resistor r=0.0875407 //w=0.307 //l=0.215 //layer=m2 \
 //thickness=0.36 //x=7.515 //y=4.62 //x2=7.515 //y2=4.835
r1223 (  82 101 ) resistor r=0.0455071 //w=0.32 //l=0.16 //layer=m2 \
 //thickness=0.36 //x=65.395 //y=4.62 //x2=65.235 //y2=4.62
r1224 (  81 106 ) resistor r=0.0408006 //w=0.296 //l=0.16 //layer=m2 \
 //thickness=0.36 //x=74.705 //y=4.62 //x2=74.865 //y2=4.62
r1225 (  81 82 ) resistor r=8.88359 //w=0.131 //l=9.31 //layer=m2 \
 //thickness=0.36 //x=74.705 //y=4.62 //x2=65.395 //y2=4.62
r1226 (  80 96 ) resistor r=0.0455071 //w=0.32 //l=0.16 //layer=m2 \
 //thickness=0.36 //x=46.165 //y=4.62 //x2=46.005 //y2=4.62
r1227 (  79 101 ) resistor r=0.0455071 //w=0.32 //l=0.16 //layer=m2 \
 //thickness=0.36 //x=65.075 //y=4.62 //x2=65.235 //y2=4.62
r1228 (  79 80 ) resistor r=18.0439 //w=0.131 //l=18.91 //layer=m2 \
 //thickness=0.36 //x=65.075 //y=4.62 //x2=46.165 //y2=4.62
r1229 (  78 91 ) resistor r=0.0455071 //w=0.32 //l=0.16 //layer=m2 \
 //thickness=0.36 //x=36.535 //y=4.62 //x2=36.375 //y2=4.62
r1230 (  77 96 ) resistor r=0.0455071 //w=0.32 //l=0.16 //layer=m2 \
 //thickness=0.36 //x=45.845 //y=4.62 //x2=46.005 //y2=4.62
r1231 (  77 78 ) resistor r=8.88359 //w=0.131 //l=9.31 //layer=m2 \
 //thickness=0.36 //x=45.845 //y=4.62 //x2=36.535 //y2=4.62
r1232 (  76 86 ) resistor r=0.0455071 //w=0.32 //l=0.16 //layer=m2 \
 //thickness=0.36 //x=17.305 //y=4.62 //x2=17.145 //y2=4.62
r1233 (  75 91 ) resistor r=0.0455071 //w=0.32 //l=0.16 //layer=m2 \
 //thickness=0.36 //x=36.215 //y=4.62 //x2=36.375 //y2=4.62
r1234 (  75 76 ) resistor r=18.0439 //w=0.131 //l=18.91 //layer=m2 \
 //thickness=0.36 //x=36.215 //y=4.62 //x2=17.305 //y2=4.62
r1235 (  74 83 ) resistor r=0.0429992 //w=0.307 //l=0.16 //layer=m2 \
 //thickness=0.36 //x=7.675 //y=4.62 //x2=7.515 //y2=4.62
r1236 (  73 86 ) resistor r=0.0455071 //w=0.32 //l=0.16 //layer=m2 \
 //thickness=0.36 //x=16.985 //y=4.62 //x2=17.145 //y2=4.62
r1237 (  73 74 ) resistor r=8.88359 //w=0.131 //l=9.31 //layer=m2 \
 //thickness=0.36 //x=16.985 //y=4.62 //x2=7.675 //y2=4.62
r1238 (  72 165 ) resistor r=9.3 //w=0.17 //l=0.17 //layer=mcon //count=1 \
 //x=74.86 //y=4.88 //x2=74.86 //y2=4.88
r1239 (  70 108 ) resistor r=4.5 //w=0.15 //l=0.15 //layer=via1 //count=1 \
 //x=74.865 //y=4.835 //x2=74.865 //y2=4.835
r1240 (  70 72 ) resistor r=0.018263 //w=0.308 //l=0.045 //layer=m1 \
 //thickness=0.36 //x=74.865 //y=4.835 //x2=74.865 //y2=4.88
r1241 (  68 160 ) resistor r=9.3 //w=0.17 //l=0.17 //layer=mcon //count=1 \
 //x=74.86 //y=2.26 //x2=74.86 //y2=2.26
r1242 (  66 155 ) resistor r=9.3 //w=0.17 //l=0.17 //layer=mcon //count=1 \
 //x=65.24 //y=4.88 //x2=65.24 //y2=4.88
r1243 (  64 104 ) resistor r=4.5 //w=0.15 //l=0.15 //layer=via1 //count=1 \
 //x=65.235 //y=4.835 //x2=65.235 //y2=4.835
r1244 (  64 66 ) resistor r=0.018263 //w=0.308 //l=0.045 //layer=m1 \
 //thickness=0.36 //x=65.235 //y=4.835 //x2=65.235 //y2=4.88
r1245 (  62 150 ) resistor r=9.3 //w=0.17 //l=0.17 //layer=mcon //count=1 \
 //x=65.24 //y=2.26 //x2=65.24 //y2=2.26
r1246 (  60 145 ) resistor r=9.3 //w=0.17 //l=0.17 //layer=mcon //count=1 \
 //x=46 //y=4.88 //x2=46 //y2=4.88
r1247 (  58 99 ) resistor r=4.5 //w=0.15 //l=0.15 //layer=via1 //count=1 \
 //x=46.005 //y=4.835 //x2=46.005 //y2=4.835
r1248 (  58 60 ) resistor r=0.018263 //w=0.308 //l=0.045 //layer=m1 \
 //thickness=0.36 //x=46.005 //y=4.835 //x2=46.005 //y2=4.88
r1249 (  56 140 ) resistor r=9.3 //w=0.17 //l=0.17 //layer=mcon //count=1 \
 //x=46 //y=2.26 //x2=46 //y2=2.26
r1250 (  54 135 ) resistor r=9.3 //w=0.17 //l=0.17 //layer=mcon //count=1 \
 //x=36.38 //y=4.88 //x2=36.38 //y2=4.88
r1251 (  52 94 ) resistor r=4.5 //w=0.15 //l=0.15 //layer=via1 //count=1 \
 //x=36.375 //y=4.835 //x2=36.375 //y2=4.835
r1252 (  52 54 ) resistor r=0.018263 //w=0.308 //l=0.045 //layer=m1 \
 //thickness=0.36 //x=36.375 //y=4.835 //x2=36.375 //y2=4.88
r1253 (  50 130 ) resistor r=9.3 //w=0.17 //l=0.17 //layer=mcon //count=1 \
 //x=36.38 //y=2.26 //x2=36.38 //y2=2.26
r1254 (  48 125 ) resistor r=9.3 //w=0.17 //l=0.17 //layer=mcon //count=1 \
 //x=17.14 //y=4.88 //x2=17.14 //y2=4.88
r1255 (  46 89 ) resistor r=4.5 //w=0.15 //l=0.15 //layer=via1 //count=1 \
 //x=17.145 //y=4.835 //x2=17.145 //y2=4.835
r1256 (  46 48 ) resistor r=0.018263 //w=0.308 //l=0.045 //layer=m1 \
 //thickness=0.36 //x=17.145 //y=4.835 //x2=17.145 //y2=4.88
r1257 (  44 120 ) resistor r=9.3 //w=0.17 //l=0.17 //layer=mcon //count=1 \
 //x=17.14 //y=2.26 //x2=17.14 //y2=2.26
r1258 (  42 115 ) resistor r=9.3 //w=0.17 //l=0.17 //layer=mcon //count=1 \
 //x=7.52 //y=4.88 //x2=7.52 //y2=4.88
r1259 (  40 85 ) resistor r=4.5 //w=0.15 //l=0.15 //layer=via1 //count=1 \
 //x=7.515 //y=4.835 //x2=7.515 //y2=4.835
r1260 (  40 42 ) resistor r=0.018263 //w=0.308 //l=0.045 //layer=m1 \
 //thickness=0.36 //x=7.515 //y=4.835 //x2=7.515 //y2=4.88
r1261 (  38 110 ) resistor r=9.3 //w=0.17 //l=0.17 //layer=mcon //count=1 \
 //x=7.52 //y=2.26 //x2=7.52 //y2=2.26
r1262 (  34 70 ) resistor r=0.0898396 //w=0.308 //l=0.162481 //layer=m1 \
 //thickness=0.36 //x=74.86 //y=4.675 //x2=74.865 //y2=4.835
r1263 (  33 68 ) resistor r=0.0715665 //w=0.226 //l=0.115996 //layer=m1 \
 //thickness=0.36 //x=74.86 //y=2.375 //x2=74.862 //y2=2.26
r1264 (  31 64 ) resistor r=0.0898396 //w=0.308 //l=0.162481 //layer=m1 \
 //thickness=0.36 //x=65.24 //y=4.675 //x2=65.235 //y2=4.835
r1265 (  30 62 ) resistor r=0.0715665 //w=0.226 //l=0.115996 //layer=m1 \
 //thickness=0.36 //x=65.24 //y=2.375 //x2=65.242 //y2=2.26
r1266 (  27 58 ) resistor r=0.0898396 //w=0.308 //l=0.162481 //layer=m1 \
 //thickness=0.36 //x=46 //y=4.675 //x2=46.005 //y2=4.835
r1267 (  26 56 ) resistor r=0.0715665 //w=0.226 //l=0.115996 //layer=m1 \
 //thickness=0.36 //x=46 //y=2.375 //x2=46.002 //y2=2.26
r1268 (  23 52 ) resistor r=0.0898396 //w=0.308 //l=0.162481 //layer=m1 \
 //thickness=0.36 //x=36.38 //y=4.675 //x2=36.375 //y2=4.835
r1269 (  22 50 ) resistor r=0.0715665 //w=0.226 //l=0.115996 //layer=m1 \
 //thickness=0.36 //x=36.38 //y=2.375 //x2=36.382 //y2=2.26
r1270 (  19 46 ) resistor r=0.0898396 //w=0.308 //l=0.162481 //layer=m1 \
 //thickness=0.36 //x=17.14 //y=4.675 //x2=17.145 //y2=4.835
r1271 (  18 44 ) resistor r=0.0715665 //w=0.226 //l=0.115996 //layer=m1 \
 //thickness=0.36 //x=17.14 //y=2.375 //x2=17.142 //y2=2.26
r1272 (  14 40 ) resistor r=0.0898396 //w=0.308 //l=0.162481 //layer=m1 \
 //thickness=0.36 //x=7.52 //y=4.675 //x2=7.515 //y2=4.835
r1273 (  13 38 ) resistor r=0.0715665 //w=0.226 //l=0.115996 //layer=m1 \
 //thickness=0.36 //x=7.52 //y=2.375 //x2=7.522 //y2=2.26
r1274 (  12 34 ) resistor r=0.0524809 //w=0.131 //l=0.055 //layer=m1 \
 //thickness=0.36 //x=74.86 //y=4.62 //x2=74.86 //y2=4.675
r1275 (  11 12 ) resistor r=1.76527 //w=0.131 //l=1.85 //layer=m1 \
 //thickness=0.36 //x=74.86 //y=2.77 //x2=74.86 //y2=4.62
r1276 (  11 33 ) resistor r=0.376908 //w=0.131 //l=0.395 //layer=m1 \
 //thickness=0.36 //x=74.86 //y=2.77 //x2=74.86 //y2=2.375
r1277 (  10 31 ) resistor r=0.0524809 //w=0.131 //l=0.055 //layer=m1 \
 //thickness=0.36 //x=65.24 //y=4.62 //x2=65.24 //y2=4.675
r1278 (  10 30 ) resistor r=2.14218 //w=0.131 //l=2.245 //layer=m1 \
 //thickness=0.36 //x=65.24 //y=4.62 //x2=65.24 //y2=2.375
r1279 (  9 27 ) resistor r=0.0524809 //w=0.131 //l=0.055 //layer=m1 \
 //thickness=0.36 //x=46 //y=4.62 //x2=46 //y2=4.675
r1280 (  8 9 ) resistor r=1.76527 //w=0.131 //l=1.85 //layer=m1 \
 //thickness=0.36 //x=46 //y=2.77 //x2=46 //y2=4.62
r1281 (  8 26 ) resistor r=0.376908 //w=0.131 //l=0.395 //layer=m1 \
 //thickness=0.36 //x=46 //y=2.77 //x2=46 //y2=2.375
r1282 (  7 23 ) resistor r=0.0524809 //w=0.131 //l=0.055 //layer=m1 \
 //thickness=0.36 //x=36.38 //y=4.62 //x2=36.38 //y2=4.675
r1283 (  6 7 ) resistor r=0.706107 //w=0.131 //l=0.74 //layer=m1 \
 //thickness=0.36 //x=36.38 //y=3.88 //x2=36.38 //y2=4.62
r1284 (  6 22 ) resistor r=1.43607 //w=0.131 //l=1.505 //layer=m1 \
 //thickness=0.36 //x=36.38 //y=3.88 //x2=36.38 //y2=2.375
r1285 (  5 19 ) resistor r=0.0524809 //w=0.131 //l=0.055 //layer=m1 \
 //thickness=0.36 //x=17.14 //y=4.62 //x2=17.14 //y2=4.675
r1286 (  4 5 ) resistor r=1.76527 //w=0.131 //l=1.85 //layer=m1 \
 //thickness=0.36 //x=17.14 //y=2.77 //x2=17.14 //y2=4.62
r1287 (  4 18 ) resistor r=0.376908 //w=0.131 //l=0.395 //layer=m1 \
 //thickness=0.36 //x=17.14 //y=2.77 //x2=17.14 //y2=2.375
r1288 (  3 14 ) resistor r=0.0524809 //w=0.131 //l=0.055 //layer=m1 \
 //thickness=0.36 //x=7.52 //y=4.62 //x2=7.52 //y2=4.675
r1289 (  2 3 ) resistor r=0.706107 //w=0.131 //l=0.74 //layer=m1 \
 //thickness=0.36 //x=7.52 //y=3.88 //x2=7.52 //y2=4.62
r1290 (  1 2 ) resistor r=0.706107 //w=0.131 //l=0.74 //layer=m1 \
 //thickness=0.36 //x=7.52 //y=3.14 //x2=7.52 //y2=3.88
r1291 (  1 13 ) resistor r=0.729962 //w=0.131 //l=0.765 //layer=m1 \
 //thickness=0.36 //x=7.52 //y=3.14 //x2=7.52 //y2=2.375
ends PM_TMRDFFSNRNQNX1\%CLK

subckt PM_TMRDFFSNRNQNX1\%noxref_16 ( 1 2 3 4 5 7 10 11 13 14 15 16 18 19 20 \
 21 22 23 24 30 33 36 39 47 49 57 62 65 66 68 71 80 85 93 101 118 127 131 132 \
 133 134 135 136 140 141 142 147 149 152 153 154 155 156 157 158 160 166 167 \
 168 169 174 175 180 191 193 194 195 )
c479 ( 191 0 ) capacitor c=0.00885916f //x=66.415 //y=1.095
c480 ( 180 0 ) capacitor c=0.0710579f //x=61.54 //y=4.88
c481 ( 175 0 ) capacitor c=0.0278202f //x=61.54 //y=2.095
c482 ( 174 0 ) capacitor c=0.0479349f //x=61.54 //y=2.26
c483 ( 169 0 ) capacitor c=0.0612936f //x=78.835 //y=4.97
c484 ( 168 0 ) capacitor c=0.0376642f //x=79.125 //y=4.97
c485 ( 167 0 ) capacitor c=0.0346489f //x=78.79 //y=1.4
c486 ( 166 0 ) capacitor c=0.018692f //x=78.79 //y=1.055
c487 ( 160 0 ) capacitor c=0.0137077f //x=78.635 //y=1.555
c488 ( 158 0 ) capacitor c=0.0158585f //x=78.635 //y=0.9
c489 ( 157 0 ) capacitor c=0.10101f //x=78.26 //y=2.095
c490 ( 156 0 ) capacitor c=0.0229444f //x=78.26 //y=1.71
c491 ( 155 0 ) capacitor c=0.0234359f //x=78.26 //y=1.4
c492 ( 154 0 ) capacitor c=0.019815f //x=78.26 //y=1.055
c493 ( 153 0 ) capacitor c=0.0443175f //x=62.06 //y=1.44
c494 ( 152 0 ) capacitor c=0.0199703f //x=62.06 //y=1.095
c495 ( 149 0 ) capacitor c=0.0162526f //x=61.905 //y=1.595
c496 ( 147 0 ) capacitor c=0.0157807f //x=61.905 //y=0.94
c497 ( 142 0 ) capacitor c=0.0220935f //x=61.53 //y=1.75
c498 ( 141 0 ) capacitor c=0.0207489f //x=61.53 //y=1.44
c499 ( 140 0 ) capacitor c=0.0194091f //x=61.53 //y=1.095
c500 ( 136 0 ) capacitor c=0.110208f //x=79.2 //y=6.2
c501 ( 135 0 ) capacitor c=0.158957f //x=78.76 //y=6.2
c502 ( 134 0 ) capacitor c=0.159671f //x=61.72 //y=6.2
c503 ( 133 0 ) capacitor c=0.110208f //x=61.28 //y=6.2
c504 ( 127 0 ) capacitor c=0.0014751f //x=78.56 //y=4.88
c505 ( 118 0 ) capacitor c=0.0012618f //x=78.56 //y=2.26
c506 ( 101 0 ) capacitor c=0.0293723f //x=66.31 //y=5.56
c507 ( 93 0 ) capacitor c=0.029137f //x=65.43 //y=5.56
c508 ( 85 0 ) capacitor c=0.0278099f //x=64.55 //y=5.56
c509 ( 80 0 ) capacitor c=7.7417e-19 //x=61.54 //y=4.88
c510 ( 71 0 ) capacitor c=0.00101179f //x=61.54 //y=2.26
c511 ( 68 0 ) capacitor c=4.92288e-19 //x=78.555 //y=3.51
c512 ( 66 0 ) capacitor c=6.97864e-19 //x=67.25 //y=3.495
c513 ( 65 0 ) capacitor c=0.0520459f //x=66.93 //y=3.495
c514 ( 62 0 ) capacitor c=5.85752e-19 //x=61.71 //y=3.515
c515 ( 57 0 ) capacitor c=0.114235f //x=78.395 //y=3.51
c516 ( 49 0 ) capacitor c=0.015408f //x=78.555 //y=3.51
c517 ( 47 0 ) capacitor c=0.0158593f //x=67.09 //y=3.51
c518 ( 39 0 ) capacitor c=0.00157165f //x=66.31 //y=5.335
c519 ( 36 0 ) capacitor c=0.00746333f //x=65.43 //y=5.335
c520 ( 33 0 ) capacitor c=0.0102231f //x=64.552 //y=5.335
c521 ( 30 0 ) capacitor c=0.0150828f //x=61.54 //y=3.51
c522 ( 24 0 ) capacitor c=0.037614f //x=78.56 //y=4.755
c523 ( 23 0 ) capacitor c=0.0144231f //x=78.56 //y=3.67
c524 ( 22 0 ) capacitor c=0.0265596f //x=78.56 //y=3.35
c525 ( 21 0 ) capacitor c=0.00493552f //x=78.56 //y=2.375
c526 ( 20 0 ) capacitor c=0.0416157f //x=67.09 //y=5.25
c527 ( 19 0 ) capacitor c=0.0133594f //x=67.09 //y=3.655
c528 ( 18 0 ) capacitor c=0.0372096f //x=67.09 //y=3.335
c529 ( 16 0 ) capacitor c=0.0048771f //x=66.69 //y=1.845
c530 ( 15 0 ) capacitor c=0.0132685f //x=67.005 //y=1.845
c531 ( 14 0 ) capacitor c=0.0167992f //x=66.605 //y=1.76
c532 ( 13 0 ) capacitor c=0.0113147f //x=66.605 //y=1.305
c533 ( 11 0 ) capacitor c=0.0261546f //x=67.005 //y=5.335
c534 ( 10 0 ) capacitor c=0.00933983f //x=66.31 //y=5.56
c535 ( 7 0 ) capacitor c=0.0171085f //x=66.195 //y=5.335
c536 ( 5 0 ) capacitor c=0.0157728f //x=65.31 //y=5.335
c537 ( 4 0 ) capacitor c=0.0301049f //x=61.54 //y=4.75
c538 ( 3 0 ) capacitor c=0.0121725f //x=61.54 //y=3.675
c539 ( 2 0 ) capacitor c=0.0217874f //x=61.54 //y=3.355
c540 ( 1 0 ) capacitor c=0.005545f //x=61.54 //y=2.375
r541 (  174 175 ) resistor r=52.7279 //w=0.214 //l=0.165 //layer=ply \
 //thickness=0.18 //x=61.54 //y=2.26 //x2=61.54 //y2=2.095
r542 (  168 170 ) resistor r=26.9307 //w=0.15 //l=0.106066 //layer=ply \
 //thickness=0.18 //x=79.125 //y=4.97 //x2=79.2 //y2=5.045
r543 (  168 169 ) resistor r=148.702 //w=0.094 //l=0.29 //layer=ply \
 //thickness=0.18 //x=79.125 //y=4.97 //x2=78.835 //y2=4.97
r544 (  167 190 ) resistor r=45.1352 //w=0.168 //l=0.173853 //layer=ply \
 //thickness=0.18 //x=78.79 //y=1.4 //x2=78.75 //y2=1.555
r545 (  166 189 ) resistor r=45.1352 //w=0.168 //l=0.173853 //layer=ply \
 //thickness=0.18 //x=78.79 //y=1.055 //x2=78.75 //y2=0.9
r546 (  166 167 ) resistor r=176.904 //w=0.094 //l=0.345 //layer=ply \
 //thickness=0.18 //x=78.79 //y=1.055 //x2=78.79 //y2=1.4
r547 (  163 169 ) resistor r=22.7971 //w=0.269 //l=0.106066 //layer=ply \
 //thickness=0.18 //x=78.76 //y=5.045 //x2=78.835 //y2=4.97
r548 (  163 188 ) resistor r=35.8364 //w=0.269 //l=0.270185 //layer=ply \
 //thickness=0.18 //x=78.76 //y=5.045 //x2=78.56 //y2=4.88
r549 (  161 184 ) resistor r=10.701 //w=0.21 //l=0.115 //layer=ply \
 //thickness=0.18 //x=78.415 //y=1.555 //x2=78.3 //y2=1.555
r550 (  160 190 ) resistor r=5.52526 //w=0.168 //l=0.115 //layer=ply \
 //thickness=0.18 //x=78.635 //y=1.555 //x2=78.75 //y2=1.555
r551 (  159 183 ) resistor r=5.52526 //w=0.168 //l=0.115 //layer=ply \
 //thickness=0.18 //x=78.415 //y=0.9 //x2=78.3 //y2=0.9
r552 (  158 189 ) resistor r=5.52526 //w=0.168 //l=0.115 //layer=ply \
 //thickness=0.18 //x=78.635 //y=0.9 //x2=78.75 //y2=0.9
r553 (  158 159 ) resistor r=112.809 //w=0.094 //l=0.22 //layer=ply \
 //thickness=0.18 //x=78.635 //y=0.9 //x2=78.415 //y2=0.9
r554 (  157 186 ) resistor r=58.7805 //w=0.246 //l=0.373497 //layer=ply \
 //thickness=0.18 //x=78.26 //y=2.095 //x2=78.56 //y2=2.26
r555 (  156 184 ) resistor r=39.5823 //w=0.21 //l=0.173853 //layer=ply \
 //thickness=0.18 //x=78.26 //y=1.71 //x2=78.3 //y2=1.555
r556 (  156 157 ) resistor r=197.415 //w=0.094 //l=0.385 //layer=ply \
 //thickness=0.18 //x=78.26 //y=1.71 //x2=78.26 //y2=2.095
r557 (  155 184 ) resistor r=39.5823 //w=0.21 //l=0.173853 //layer=ply \
 //thickness=0.18 //x=78.26 //y=1.4 //x2=78.3 //y2=1.555
r558 (  154 183 ) resistor r=45.1352 //w=0.168 //l=0.173853 //layer=ply \
 //thickness=0.18 //x=78.26 //y=1.055 //x2=78.3 //y2=0.9
r559 (  154 155 ) resistor r=176.904 //w=0.094 //l=0.345 //layer=ply \
 //thickness=0.18 //x=78.26 //y=1.055 //x2=78.26 //y2=1.4
r560 (  153 182 ) resistor r=45.1352 //w=0.168 //l=0.173853 //layer=ply \
 //thickness=0.18 //x=62.06 //y=1.44 //x2=62.02 //y2=1.595
r561 (  152 181 ) resistor r=45.1352 //w=0.168 //l=0.173853 //layer=ply \
 //thickness=0.18 //x=62.06 //y=1.095 //x2=62.02 //y2=0.94
r562 (  152 153 ) resistor r=176.904 //w=0.094 //l=0.345 //layer=ply \
 //thickness=0.18 //x=62.06 //y=1.095 //x2=62.06 //y2=1.44
r563 (  150 178 ) resistor r=10.701 //w=0.21 //l=0.115 //layer=ply \
 //thickness=0.18 //x=61.685 //y=1.595 //x2=61.57 //y2=1.595
r564 (  149 182 ) resistor r=5.52526 //w=0.168 //l=0.115 //layer=ply \
 //thickness=0.18 //x=61.905 //y=1.595 //x2=62.02 //y2=1.595
r565 (  148 177 ) resistor r=5.52526 //w=0.168 //l=0.115 //layer=ply \
 //thickness=0.18 //x=61.685 //y=0.94 //x2=61.57 //y2=0.94
r566 (  147 181 ) resistor r=5.52526 //w=0.168 //l=0.115 //layer=ply \
 //thickness=0.18 //x=61.905 //y=0.94 //x2=62.02 //y2=0.94
r567 (  147 148 ) resistor r=112.809 //w=0.094 //l=0.22 //layer=ply \
 //thickness=0.18 //x=61.905 //y=0.94 //x2=61.685 //y2=0.94
r568 (  144 180 ) resistor r=37.236 //w=0.233 //l=0.249199 //layer=ply \
 //thickness=0.18 //x=61.72 //y=5.045 //x2=61.54 //y2=4.88
r569 (  142 178 ) resistor r=39.5823 //w=0.21 //l=0.173853 //layer=ply \
 //thickness=0.18 //x=61.53 //y=1.75 //x2=61.57 //y2=1.595
r570 (  142 175 ) resistor r=176.904 //w=0.094 //l=0.345 //layer=ply \
 //thickness=0.18 //x=61.53 //y=1.75 //x2=61.53 //y2=2.095
r571 (  141 178 ) resistor r=39.5823 //w=0.21 //l=0.173853 //layer=ply \
 //thickness=0.18 //x=61.53 //y=1.44 //x2=61.57 //y2=1.595
r572 (  140 177 ) resistor r=45.1352 //w=0.168 //l=0.173853 //layer=ply \
 //thickness=0.18 //x=61.53 //y=1.095 //x2=61.57 //y2=0.94
r573 (  140 141 ) resistor r=176.904 //w=0.094 //l=0.345 //layer=ply \
 //thickness=0.18 //x=61.53 //y=1.095 //x2=61.53 //y2=1.44
r574 (  137 180 ) resistor r=53.7854 //w=0.233 //l=0.332415 //layer=ply \
 //thickness=0.18 //x=61.28 //y=5.045 //x2=61.54 //y2=4.88
r575 (  136 170 ) resistor r=592.245 //w=0.094 //l=1.155 //layer=ply \
 //thickness=0.18 //x=79.2 //y=6.2 //x2=79.2 //y2=5.045
r576 (  135 163 ) resistor r=592.245 //w=0.094 //l=1.155 //layer=ply \
 //thickness=0.18 //x=78.76 //y=6.2 //x2=78.76 //y2=5.045
r577 (  134 144 ) resistor r=592.245 //w=0.094 //l=1.155 //layer=ply \
 //thickness=0.18 //x=61.72 //y=6.2 //x2=61.72 //y2=5.045
r578 (  133 137 ) resistor r=592.245 //w=0.094 //l=1.155 //layer=ply \
 //thickness=0.18 //x=61.28 //y=6.2 //x2=61.28 //y2=5.045
r579 (  132 160 ) resistor r=56.4043 //w=0.094 //l=0.11 //layer=ply \
 //thickness=0.18 //x=78.525 //y=1.555 //x2=78.635 //y2=1.555
r580 (  132 161 ) resistor r=56.4043 //w=0.094 //l=0.11 //layer=ply \
 //thickness=0.18 //x=78.525 //y=1.555 //x2=78.415 //y2=1.555
r581 (  131 149 ) resistor r=56.4043 //w=0.094 //l=0.11 //layer=ply \
 //thickness=0.18 //x=61.795 //y=1.595 //x2=61.905 //y2=1.595
r582 (  131 150 ) resistor r=56.4043 //w=0.094 //l=0.11 //layer=ply \
 //thickness=0.18 //x=61.795 //y=1.595 //x2=61.685 //y2=1.595
r583 (  127 188 ) resistor r=152 //w=0.17 //l=0.17 //layer=licon //count=1 \
 //x=78.56 //y=4.88 //x2=78.56 //y2=4.88
r584 (  118 186 ) resistor r=152 //w=0.17 //l=0.17 //layer=licon //count=1 \
 //x=78.56 //y=2.26 //x2=78.56 //y2=2.26
r585 (  101 195 ) resistor r=23.615 //w=0.187 //l=0.345 //layer=li \
 //thickness=0.1 //x=66.31 //y=5.56 //x2=66.31 //y2=5.905
r586 (  93 194 ) resistor r=23.615 //w=0.187 //l=0.345 //layer=li \
 //thickness=0.1 //x=65.43 //y=5.56 //x2=65.43 //y2=5.905
r587 (  85 193 ) resistor r=23.615 //w=0.187 //l=0.345 //layer=li \
 //thickness=0.1 //x=64.55 //y=5.56 //x2=64.55 //y2=5.905
r588 (  80 180 ) resistor r=152 //w=0.17 //l=0.17 //layer=licon //count=1 \
 //x=61.54 //y=4.88 //x2=61.54 //y2=4.88
r589 (  71 174 ) resistor r=152 //w=0.17 //l=0.17 //layer=licon //count=1 \
 //x=61.54 //y=2.26 //x2=61.54 //y2=2.26
r590 (  64 66 ) resistor r=0.10734 //w=0.281 //l=0.16 //layer=m2 \
 //thickness=0.36 //x=67.09 //y=3.495 //x2=67.25 //y2=3.495
r591 (  64 65 ) resistor r=0.10734 //w=0.281 //l=0.16 //layer=m2 \
 //thickness=0.36 //x=67.09 //y=3.495 //x2=66.93 //y2=3.495
r592 (  62 65 ) resistor r=4.98092 //w=0.131 //l=5.22 //layer=m2 \
 //thickness=0.36 //x=61.71 //y=3.51 //x2=66.93 //y2=3.51
r593 (  60 62 ) resistor r=0.10734 //w=0.281 //l=0.16 //layer=m2 \
 //thickness=0.36 //x=61.55 //y=3.515 //x2=61.71 //y2=3.515
r594 (  57 68 ) resistor r=0.10734 //w=0.281 //l=0.16 //layer=m2 \
 //thickness=0.36 //x=78.395 //y=3.51 //x2=78.555 //y2=3.51
r595 (  57 66 ) resistor r=10.6345 //w=0.131 //l=11.145 //layer=m2 \
 //thickness=0.36 //x=78.395 //y=3.51 //x2=67.25 //y2=3.51
r596 (  54 127 ) resistor r=9.3 //w=0.17 //l=0.17 //layer=mcon //count=1 \
 //x=78.56 //y=4.88 //x2=78.56 //y2=4.88
r597 (  52 118 ) resistor r=9.3 //w=0.17 //l=0.17 //layer=mcon //count=1 \
 //x=78.56 //y=2.26 //x2=78.56 //y2=2.26
r598 (  49 68 ) resistor r=4.5 //w=0.15 //l=0.15 //layer=via1 //count=1 \
 //x=78.555 //y=3.51 //x2=78.555 //y2=3.51
r599 (  45 64 ) resistor r=4.5 //w=0.15 //l=0.15 //layer=via1 //count=1 \
 //x=67.09 //y=3.495 //x2=67.09 //y2=3.495
r600 (  45 47 ) resistor r=0.0049867 //w=0.376 //l=0.015 //layer=m1 \
 //thickness=0.36 //x=67.142 //y=3.495 //x2=67.142 //y2=3.51
r601 (  43 191 ) resistor r=9.3 //w=0.17 //l=0.17 //layer=mcon //count=1 \
 //x=66.605 //y=1.19 //x2=66.605 //y2=1.19
r602 (  41 101 ) resistor r=9.3 //w=0.17 //l=0.17 //layer=mcon //count=1 \
 //x=66.31 //y=5.56 //x2=66.31 //y2=5.56
r603 (  38 93 ) resistor r=9.3 //w=0.17 //l=0.17 //layer=mcon //count=1 \
 //x=65.43 //y=5.56 //x2=65.43 //y2=5.56
r604 (  36 38 ) resistor r=0.121228 //w=0.232 //l=0.225 //layer=m1 \
 //thickness=0.36 //x=65.43 //y=5.335 //x2=65.43 //y2=5.56
r605 (  35 85 ) resistor r=9.3 //w=0.17 //l=0.17 //layer=mcon //count=1 \
 //x=64.55 //y=5.56 //x2=64.55 //y2=5.56
r606 (  33 35 ) resistor r=0.129608 //w=0.217 //l=0.225 //layer=m1 \
 //thickness=0.36 //x=64.552 //y=5.335 //x2=64.552 //y2=5.56
r607 (  32 60 ) resistor r=4.5 //w=0.15 //l=0.15 //layer=via1 //count=1 \
 //x=61.55 //y=3.515 //x2=61.55 //y2=3.515
r608 (  30 32 ) resistor r=0.00168464 //w=0.371 //l=0.005 //layer=m1 \
 //thickness=0.36 //x=61.597 //y=3.51 //x2=61.597 //y2=3.515
r609 (  28 80 ) resistor r=9.3 //w=0.17 //l=0.17 //layer=mcon //count=1 \
 //x=61.54 //y=4.88 //x2=61.54 //y2=4.88
r610 (  26 71 ) resistor r=9.3 //w=0.17 //l=0.17 //layer=mcon //count=1 \
 //x=61.54 //y=2.26 //x2=61.54 //y2=2.26
r611 (  24 54 ) resistor r=0.0760407 //w=0.238 //l=0.125 //layer=m1 \
 //thickness=0.36 //x=78.56 //y=4.755 //x2=78.56 //y2=4.88
r612 (  23 49 ) resistor r=0.0910802 //w=0.374 //l=0.185472 //layer=m1 \
 //thickness=0.36 //x=78.56 //y=3.67 //x2=78.505 //y2=3.51
r613 (  23 24 ) resistor r=1.03531 //w=0.131 //l=1.085 //layer=m1 \
 //thickness=0.36 //x=78.56 //y=3.67 //x2=78.56 //y2=4.755
r614 (  22 49 ) resistor r=0.0910802 //w=0.374 //l=0.185472 //layer=m1 \
 //thickness=0.36 //x=78.56 //y=3.35 //x2=78.505 //y2=3.51
r615 (  21 52 ) resistor r=0.0719237 //w=0.222 //l=0.115 //layer=m1 \
 //thickness=0.36 //x=78.56 //y=2.375 //x2=78.56 //y2=2.26
r616 (  21 22 ) resistor r=0.930344 //w=0.131 //l=0.975 //layer=m1 \
 //thickness=0.36 //x=78.56 //y=2.375 //x2=78.56 //y2=3.35
r617 (  19 47 ) resistor r=0.0861726 //w=0.376 //l=0.169012 //layer=m1 \
 //thickness=0.36 //x=67.09 //y=3.655 //x2=67.142 //y2=3.51
r618 (  19 20 ) resistor r=1.52195 //w=0.131 //l=1.595 //layer=m1 \
 //thickness=0.36 //x=67.09 //y=3.655 //x2=67.09 //y2=5.25
r619 (  18 45 ) resistor r=0.0911593 //w=0.376 //l=0.184174 //layer=m1 \
 //thickness=0.36 //x=67.09 //y=3.335 //x2=67.142 //y2=3.495
r620 (  17 18 ) resistor r=1.34065 //w=0.131 //l=1.405 //layer=m1 \
 //thickness=0.36 //x=67.09 //y=1.93 //x2=67.09 //y2=3.335
r621 (  15 17 ) resistor r=0.0698411 //w=0.17 //l=0.120208 //layer=m1 \
 //thickness=0.36 //x=67.005 //y=1.845 //x2=67.09 //y2=1.93
r622 (  15 16 ) resistor r=0.300573 //w=0.131 //l=0.315 //layer=m1 \
 //thickness=0.36 //x=67.005 //y=1.845 //x2=66.69 //y2=1.845
r623 (  14 16 ) resistor r=0.0698411 //w=0.17 //l=0.120208 //layer=m1 \
 //thickness=0.36 //x=66.605 //y=1.76 //x2=66.69 //y2=1.845
r624 (  13 43 ) resistor r=0.0717383 //w=0.224 //l=0.115 //layer=m1 \
 //thickness=0.36 //x=66.605 //y=1.305 //x2=66.605 //y2=1.19
r625 (  13 14 ) resistor r=0.43416 //w=0.131 //l=0.455 //layer=m1 \
 //thickness=0.36 //x=66.605 //y=1.305 //x2=66.605 //y2=1.76
r626 (  12 39 ) resistor r=0.0675342 //w=0.23 //l=0.115 //layer=m1 \
 //thickness=0.36 //x=66.425 //y=5.335 //x2=66.31 //y2=5.335
r627 (  11 20 ) resistor r=0.0698411 //w=0.17 //l=0.120208 //layer=m1 \
 //thickness=0.36 //x=67.005 //y=5.335 //x2=67.09 //y2=5.25
r628 (  11 12 ) resistor r=0.553435 //w=0.131 //l=0.58 //layer=m1 \
 //thickness=0.36 //x=67.005 //y=5.335 //x2=66.425 //y2=5.335
r629 (  10 41 ) resistor r=0.00118313 //w=0.23 //layer=m1 //thickness=0.36 \
 //x=66.31 //y=5.56 //x2=66.31 //y2=5.56
r630 (  9 39 ) resistor r=0.002872 //w=0.34 //l=0.085 //layer=m1 \
 //thickness=0.36 //x=66.31 //y=5.42 //x2=66.31 //y2=5.335
r631 (  9 10 ) resistor r=0.091623 //w=0.191 //l=0.14 //layer=m1 \
 //thickness=0.36 //x=66.31 //y=5.42 //x2=66.31 //y2=5.56
r632 (  8 36 ) resistor r=0.0262263 //w=0.232 //l=0.12 //layer=m1 \
 //thickness=0.36 //x=65.55 //y=5.335 //x2=65.43 //y2=5.335
r633 (  7 39 ) resistor r=0.0675342 //w=0.23 //l=0.115 //layer=m1 \
 //thickness=0.36 //x=66.195 //y=5.335 //x2=66.31 //y2=5.335
r634 (  7 8 ) resistor r=0.615458 //w=0.131 //l=0.645 //layer=m1 \
 //thickness=0.36 //x=66.195 //y=5.335 //x2=65.55 //y2=5.335
r635 (  6 33 ) resistor r=0.0222262 //w=0.217 //l=0.118 //layer=m1 \
 //thickness=0.36 //x=64.67 //y=5.335 //x2=64.552 //y2=5.335
r636 (  5 36 ) resistor r=0.0262263 //w=0.232 //l=0.12 //layer=m1 \
 //thickness=0.36 //x=65.31 //y=5.335 //x2=65.43 //y2=5.335
r637 (  5 6 ) resistor r=0.610687 //w=0.131 //l=0.64 //layer=m1 \
 //thickness=0.36 //x=65.31 //y=5.335 //x2=64.67 //y2=5.335
r638 (  4 28 ) resistor r=0.0801089 //w=0.224 //l=0.13 //layer=m1 \
 //thickness=0.36 //x=61.54 //y=4.75 //x2=61.54 //y2=4.88
r639 (  3 32 ) resistor r=0.0909648 //w=0.371 //l=0.186333 //layer=m1 \
 //thickness=0.36 //x=61.54 //y=3.675 //x2=61.597 //y2=3.515
r640 (  3 4 ) resistor r=1.02576 //w=0.131 //l=1.075 //layer=m1 \
 //thickness=0.36 //x=61.54 //y=3.675 //x2=61.54 //y2=4.75
r641 (  2 30 ) resistor r=0.0892801 //w=0.371 //l=0.181273 //layer=m1 \
 //thickness=0.36 //x=61.54 //y=3.355 //x2=61.597 //y2=3.51
r642 (  1 26 ) resistor r=0.0719237 //w=0.222 //l=0.115 //layer=m1 \
 //thickness=0.36 //x=61.54 //y=2.375 //x2=61.54 //y2=2.26
r643 (  1 2 ) resistor r=0.935115 //w=0.131 //l=0.98 //layer=m1 \
 //thickness=0.36 //x=61.54 //y=2.375 //x2=61.54 //y2=3.355
ends PM_TMRDFFSNRNQNX1\%noxref_16

subckt PM_TMRDFFSNRNQNX1\%RN ( 1 2 3 4 5 6 7 8 9 10 11 12 13 14 15 16 17 18 19 \
 20 21 22 23 24 25 26 27 28 29 30 31 37 38 40 41 44 45 49 50 52 53 56 57 61 62 \
 64 65 128 129 130 132 134 136 137 138 139 140 142 144 145 146 148 150 151 152 \
 153 154 156 158 159 160 162 165 184 185 188 193 198 203 208 213 218 223 228 \
 233 238 243 248 253 258 263 268 273 277 278 279 280 281 282 283 284 285 286 \
 287 288 289 290 291 292 293 294 295 296 297 298 299 300 301 302 303 304 305 \
 306 308 314 315 316 317 318 326 327 328 333 335 338 339 340 341 342 344 350 \
 351 352 353 354 359 360 361 363 369 370 371 372 373 381 382 383 388 390 393 \
 394 395 396 397 399 405 406 407 408 409 414 415 416 418 424 425 426 427 428 \
 436 437 438 443 445 448 449 450 451 452 454 460 461 462 463 464 472 481 482 \
 487 493 504 513 514 519 525 536 545 546 551 557 )
c1700 ( 557 0 ) capacitor c=0.0369044f //x=79.67 //y=4.88
c1701 ( 551 0 ) capacitor c=0.0711095f //x=75.97 //y=4.88
c1702 ( 546 0 ) capacitor c=0.0278202f //x=75.97 //y=2.095
c1703 ( 545 0 ) capacitor c=0.0491433f //x=75.97 //y=2.26
c1704 ( 536 0 ) capacitor c=0.0369044f //x=60.43 //y=4.88
c1705 ( 525 0 ) capacitor c=0.0369044f //x=50.81 //y=4.88
c1706 ( 519 0 ) capacitor c=0.0710579f //x=47.11 //y=4.88
c1707 ( 514 0 ) capacitor c=0.0278202f //x=47.11 //y=2.095
c1708 ( 513 0 ) capacitor c=0.0491433f //x=47.11 //y=2.26
c1709 ( 504 0 ) capacitor c=0.0369628f //x=31.57 //y=4.88
c1710 ( 493 0 ) capacitor c=0.0369044f //x=21.95 //y=4.88
c1711 ( 487 0 ) capacitor c=0.0710579f //x=18.25 //y=4.88
c1712 ( 482 0 ) capacitor c=0.0278202f //x=18.25 //y=2.095
c1713 ( 481 0 ) capacitor c=0.0491433f //x=18.25 //y=2.26
c1714 ( 472 0 ) capacitor c=0.0369044f //x=2.71 //y=4.88
c1715 ( 464 0 ) capacitor c=0.0309248f //x=80.005 //y=4.97
c1716 ( 463 0 ) capacitor c=0.0846044f //x=79.76 //y=2.095
c1717 ( 462 0 ) capacitor c=0.0170266f //x=79.76 //y=1.63
c1718 ( 461 0 ) capacitor c=0.018609f //x=79.76 //y=1.4
c1719 ( 460 0 ) capacitor c=0.0186599f //x=79.76 //y=1.09
c1720 ( 454 0 ) capacitor c=0.0146988f //x=79.605 //y=1.555
c1721 ( 452 0 ) capacitor c=0.0148531f //x=79.605 //y=0.935
c1722 ( 451 0 ) capacitor c=0.0334406f //x=79.235 //y=1.4
c1723 ( 450 0 ) capacitor c=0.0173191f //x=79.235 //y=1.09
c1724 ( 449 0 ) capacitor c=0.0443175f //x=76.49 //y=1.44
c1725 ( 448 0 ) capacitor c=0.0199703f //x=76.49 //y=1.095
c1726 ( 445 0 ) capacitor c=0.0160404f //x=76.335 //y=1.595
c1727 ( 443 0 ) capacitor c=0.0157807f //x=76.335 //y=0.94
c1728 ( 438 0 ) capacitor c=0.0220935f //x=75.96 //y=1.75
c1729 ( 437 0 ) capacitor c=0.0207489f //x=75.96 //y=1.44
c1730 ( 436 0 ) capacitor c=0.0194091f //x=75.96 //y=1.095
c1731 ( 428 0 ) capacitor c=0.0309248f //x=60.765 //y=4.97
c1732 ( 427 0 ) capacitor c=0.0844916f //x=60.52 //y=2.095
c1733 ( 426 0 ) capacitor c=0.0170266f //x=60.52 //y=1.63
c1734 ( 425 0 ) capacitor c=0.018609f //x=60.52 //y=1.4
c1735 ( 424 0 ) capacitor c=0.0186599f //x=60.52 //y=1.09
c1736 ( 418 0 ) capacitor c=0.0146988f //x=60.365 //y=1.555
c1737 ( 416 0 ) capacitor c=0.0148531f //x=60.365 //y=0.935
c1738 ( 415 0 ) capacitor c=0.0334406f //x=59.995 //y=1.4
c1739 ( 414 0 ) capacitor c=0.0173191f //x=59.995 //y=1.09
c1740 ( 409 0 ) capacitor c=0.0309248f //x=51.145 //y=4.97
c1741 ( 408 0 ) capacitor c=0.0846044f //x=50.9 //y=2.095
c1742 ( 407 0 ) capacitor c=0.0170266f //x=50.9 //y=1.63
c1743 ( 406 0 ) capacitor c=0.018609f //x=50.9 //y=1.4
c1744 ( 405 0 ) capacitor c=0.0186599f //x=50.9 //y=1.09
c1745 ( 399 0 ) capacitor c=0.0146988f //x=50.745 //y=1.555
c1746 ( 397 0 ) capacitor c=0.0148531f //x=50.745 //y=0.935
c1747 ( 396 0 ) capacitor c=0.0334406f //x=50.375 //y=1.4
c1748 ( 395 0 ) capacitor c=0.0173191f //x=50.375 //y=1.09
c1749 ( 394 0 ) capacitor c=0.0443175f //x=47.63 //y=1.44
c1750 ( 393 0 ) capacitor c=0.0199703f //x=47.63 //y=1.095
c1751 ( 390 0 ) capacitor c=0.0160404f //x=47.475 //y=1.595
c1752 ( 388 0 ) capacitor c=0.0157807f //x=47.475 //y=0.94
c1753 ( 383 0 ) capacitor c=0.0220935f //x=47.1 //y=1.75
c1754 ( 382 0 ) capacitor c=0.0207489f //x=47.1 //y=1.44
c1755 ( 381 0 ) capacitor c=0.0194091f //x=47.1 //y=1.095
c1756 ( 373 0 ) capacitor c=0.0309248f //x=31.905 //y=4.97
c1757 ( 372 0 ) capacitor c=0.0844916f //x=31.66 //y=2.095
c1758 ( 371 0 ) capacitor c=0.0170266f //x=31.66 //y=1.63
c1759 ( 370 0 ) capacitor c=0.018609f //x=31.66 //y=1.4
c1760 ( 369 0 ) capacitor c=0.0186599f //x=31.66 //y=1.09
c1761 ( 363 0 ) capacitor c=0.0146988f //x=31.505 //y=1.555
c1762 ( 361 0 ) capacitor c=0.0148531f //x=31.505 //y=0.935
c1763 ( 360 0 ) capacitor c=0.0334406f //x=31.135 //y=1.4
c1764 ( 359 0 ) capacitor c=0.0173191f //x=31.135 //y=1.09
c1765 ( 354 0 ) capacitor c=0.0309248f //x=22.285 //y=4.97
c1766 ( 353 0 ) capacitor c=0.0846044f //x=22.04 //y=2.095
c1767 ( 352 0 ) capacitor c=0.0170266f //x=22.04 //y=1.63
c1768 ( 351 0 ) capacitor c=0.018609f //x=22.04 //y=1.4
c1769 ( 350 0 ) capacitor c=0.0186599f //x=22.04 //y=1.09
c1770 ( 344 0 ) capacitor c=0.0146988f //x=21.885 //y=1.555
c1771 ( 342 0 ) capacitor c=0.0148531f //x=21.885 //y=0.935
c1772 ( 341 0 ) capacitor c=0.0334406f //x=21.515 //y=1.4
c1773 ( 340 0 ) capacitor c=0.0173191f //x=21.515 //y=1.09
c1774 ( 339 0 ) capacitor c=0.0443175f //x=18.77 //y=1.44
c1775 ( 338 0 ) capacitor c=0.0199703f //x=18.77 //y=1.095
c1776 ( 335 0 ) capacitor c=0.0160404f //x=18.615 //y=1.595
c1777 ( 333 0 ) capacitor c=0.0157807f //x=18.615 //y=0.94
c1778 ( 328 0 ) capacitor c=0.0220935f //x=18.24 //y=1.75
c1779 ( 327 0 ) capacitor c=0.0207489f //x=18.24 //y=1.44
c1780 ( 326 0 ) capacitor c=0.0194091f //x=18.24 //y=1.095
c1781 ( 318 0 ) capacitor c=0.0309248f //x=3.045 //y=4.97
c1782 ( 317 0 ) capacitor c=0.0844916f //x=2.8 //y=2.095
c1783 ( 316 0 ) capacitor c=0.0170266f //x=2.8 //y=1.63
c1784 ( 315 0 ) capacitor c=0.018609f //x=2.8 //y=1.4
c1785 ( 314 0 ) capacitor c=0.0186599f //x=2.8 //y=1.09
c1786 ( 308 0 ) capacitor c=0.0146988f //x=2.645 //y=1.555
c1787 ( 306 0 ) capacitor c=0.0148531f //x=2.645 //y=0.935
c1788 ( 305 0 ) capacitor c=0.0334406f //x=2.275 //y=1.4
c1789 ( 304 0 ) capacitor c=0.0173191f //x=2.275 //y=1.09
c1790 ( 303 0 ) capacitor c=0.110208f //x=80.08 //y=6.2
c1791 ( 302 0 ) capacitor c=0.110214f //x=79.64 //y=6.2
c1792 ( 301 0 ) capacitor c=0.159671f //x=76.15 //y=6.2
c1793 ( 300 0 ) capacitor c=0.110208f //x=75.71 //y=6.2
c1794 ( 299 0 ) capacitor c=0.110208f //x=60.84 //y=6.2
c1795 ( 298 0 ) capacitor c=0.110214f //x=60.4 //y=6.2
c1796 ( 297 0 ) capacitor c=0.110208f //x=51.22 //y=6.2
c1797 ( 296 0 ) capacitor c=0.110214f //x=50.78 //y=6.2
c1798 ( 295 0 ) capacitor c=0.159671f //x=47.29 //y=6.2
c1799 ( 294 0 ) capacitor c=0.110208f //x=46.85 //y=6.2
c1800 ( 293 0 ) capacitor c=0.110208f //x=31.98 //y=6.2
c1801 ( 292 0 ) capacitor c=0.110214f //x=31.54 //y=6.2
c1802 ( 291 0 ) capacitor c=0.110208f //x=22.36 //y=6.2
c1803 ( 290 0 ) capacitor c=0.110214f //x=21.92 //y=6.2
c1804 ( 289 0 ) capacitor c=0.159671f //x=18.43 //y=6.2
c1805 ( 288 0 ) capacitor c=0.110208f //x=17.99 //y=6.2
c1806 ( 287 0 ) capacitor c=0.110208f //x=3.12 //y=6.2
c1807 ( 286 0 ) capacitor c=0.110214f //x=2.68 //y=6.2
c1808 ( 273 0 ) capacitor c=0.00129935f //x=79.67 //y=4.88
c1809 ( 268 0 ) capacitor c=0.00121786f //x=79.67 //y=2.26
c1810 ( 263 0 ) capacitor c=7.7417e-19 //x=75.97 //y=4.88
c1811 ( 258 0 ) capacitor c=0.00101179f //x=75.97 //y=2.26
c1812 ( 253 0 ) capacitor c=0.00129935f //x=60.43 //y=4.88
c1813 ( 248 0 ) capacitor c=0.00121786f //x=60.43 //y=2.26
c1814 ( 243 0 ) capacitor c=0.00129935f //x=50.81 //y=4.88
c1815 ( 238 0 ) capacitor c=0.00121786f //x=50.81 //y=2.26
c1816 ( 233 0 ) capacitor c=7.7417e-19 //x=47.11 //y=4.88
c1817 ( 228 0 ) capacitor c=0.00101179f //x=47.11 //y=2.26
c1818 ( 223 0 ) capacitor c=0.00129935f //x=31.57 //y=4.88
c1819 ( 218 0 ) capacitor c=0.00121786f //x=31.57 //y=2.26
c1820 ( 213 0 ) capacitor c=0.00129935f //x=21.95 //y=4.88
c1821 ( 208 0 ) capacitor c=0.00121786f //x=21.95 //y=2.26
c1822 ( 203 0 ) capacitor c=7.7417e-19 //x=18.25 //y=4.88
c1823 ( 198 0 ) capacitor c=0.00101179f //x=18.25 //y=2.26
c1824 ( 193 0 ) capacitor c=0.00129935f //x=2.71 //y=4.88
c1825 ( 188 0 ) capacitor c=0.00121786f //x=2.71 //y=2.26
c1826 ( 185 0 ) capacitor c=0.0856406f //x=79.505 //y=2.41
c1827 ( 184 0 ) capacitor c=0.00498615f //x=79.665 //y=2.41
c1828 ( 165 0 ) capacitor c=0.0572008f //x=76.135 //y=2.4
c1829 ( 162 0 ) capacitor c=0.00875699f //x=73.975 //y=2.385
c1830 ( 160 0 ) capacitor c=0.0264842f //x=73.375 //y=2.4
c1831 ( 159 0 ) capacitor c=0.337144f //x=71.685 //y=2.385
c1832 ( 158 0 ) capacitor c=0.0147324f //x=72.115 //y=2.385
c1833 ( 156 0 ) capacitor c=0.00748096f //x=57.685 //y=2.37
c1834 ( 154 0 ) capacitor c=0.11012f //x=57.085 //y=2.4
c1835 ( 153 0 ) capacitor c=0.0267673f //x=51.7 //y=2.37
c1836 ( 152 0 ) capacitor c=0.0144094f //x=52.13 //y=2.37
c1837 ( 151 0 ) capacitor c=0.0572008f //x=47.275 //y=2.4
c1838 ( 150 0 ) capacitor c=0.0856406f //x=50.645 //y=2.4
c1839 ( 148 0 ) capacitor c=0.00875699f //x=45.115 //y=2.385
c1840 ( 146 0 ) capacitor c=0.0264842f //x=44.515 //y=2.4
c1841 ( 145 0 ) capacitor c=0.411855f //x=42.825 //y=2.385
c1842 ( 144 0 ) capacitor c=0.0147324f //x=43.255 //y=2.385
c1843 ( 142 0 ) capacitor c=0.00856815f //x=25.82 //y=2.37
c1844 ( 140 0 ) capacitor c=0.0240914f //x=25.22 //y=2.4
c1845 ( 139 0 ) capacitor c=0.0450305f //x=23.63 //y=2.37
c1846 ( 138 0 ) capacitor c=0.0149878f //x=24.06 //y=2.37
c1847 ( 137 0 ) capacitor c=0.0572008f //x=18.415 //y=2.4
c1848 ( 136 0 ) capacitor c=0.0856406f //x=21.785 //y=2.4
c1849 ( 134 0 ) capacitor c=0.00875699f //x=16.255 //y=2.385
c1850 ( 132 0 ) capacitor c=0.0264842f //x=15.655 //y=2.4
c1851 ( 130 0 ) capacitor c=0.0147324f //x=14.395 //y=2.385
c1852 ( 129 0 ) capacitor c=0.00551787f //x=2.87 //y=2.4
c1853 ( 128 0 ) capacitor c=0.271118f //x=13.795 //y=2.4
c1854 ( 65 0 ) capacitor c=0.00504675f //x=79.67 //y=4.765
c1855 ( 64 0 ) capacitor c=0.0121708f //x=79.67 //y=2.57
c1856 ( 62 0 ) capacitor c=0.00443476f //x=75.97 //y=4.75
c1857 ( 61 0 ) capacitor c=0.0133066f //x=75.97 //y=2.565
c1858 ( 57 0 ) capacitor c=0.00504926f //x=60.43 //y=4.765
c1859 ( 56 0 ) capacitor c=0.011781f //x=60.43 //y=2.56
c1860 ( 53 0 ) capacitor c=0.00504675f //x=50.81 //y=4.765
c1861 ( 52 0 ) capacitor c=0.0123881f //x=50.81 //y=2.57
c1862 ( 50 0 ) capacitor c=0.00443476f //x=47.11 //y=4.75
c1863 ( 49 0 ) capacitor c=0.013319f //x=47.11 //y=2.565
c1864 ( 45 0 ) capacitor c=0.00295423f //x=31.57 //y=4.765
c1865 ( 44 0 ) capacitor c=0.0115735f //x=31.57 //y=2.56
c1866 ( 41 0 ) capacitor c=0.00504675f //x=21.95 //y=4.765
c1867 ( 40 0 ) capacitor c=0.0121708f //x=21.95 //y=2.57
c1868 ( 38 0 ) capacitor c=0.00443476f //x=18.25 //y=4.75
c1869 ( 37 0 ) capacitor c=0.0133066f //x=18.25 //y=2.565
c1870 ( 31 0 ) capacitor c=0.00504926f //x=2.71 //y=4.765
c1871 ( 30 0 ) capacitor c=0.0116271f //x=2.71 //y=2.56
c1872 ( 19 0 ) capacitor c=0.0598746f //x=79.67 //y=2.77
c1873 ( 18 0 ) capacitor c=0.053007f //x=75.97 //y=2.77
c1874 ( 15 0 ) capacitor c=0.0603862f //x=60.43 //y=2.77
c1875 ( 13 0 ) capacitor c=0.0572226f //x=50.81 //y=2.77
c1876 ( 12 0 ) capacitor c=0.0530147f //x=47.11 //y=2.77
c1877 ( 9 0 ) capacitor c=0.0616901f //x=31.57 //y=2.77
c1878 ( 7 0 ) capacitor c=0.0573842f //x=21.95 //y=2.77
c1879 ( 6 0 ) capacitor c=0.0530147f //x=18.25 //y=2.77
c1880 ( 1 0 ) capacitor c=0.0666365f //x=2.71 //y=2.77
r1881 (  559 560 ) resistor r=32.4568 //w=0.214 //l=0.075 //layer=ply \
 //thickness=0.18 //x=79.67 //y=4.97 //x2=79.67 //y2=5.045
r1882 (  557 559 ) resistor r=20.271 //w=0.214 //l=0.09 //layer=ply \
 //thickness=0.18 //x=79.67 //y=4.88 //x2=79.67 //y2=4.97
r1883 (  545 546 ) resistor r=52.7279 //w=0.214 //l=0.165 //layer=ply \
 //thickness=0.18 //x=75.97 //y=2.26 //x2=75.97 //y2=2.095
r1884 (  538 539 ) resistor r=32.4568 //w=0.214 //l=0.075 //layer=ply \
 //thickness=0.18 //x=60.43 //y=4.97 //x2=60.43 //y2=5.045
r1885 (  536 538 ) resistor r=20.271 //w=0.214 //l=0.09 //layer=ply \
 //thickness=0.18 //x=60.43 //y=4.88 //x2=60.43 //y2=4.97
r1886 (  527 528 ) resistor r=32.4568 //w=0.214 //l=0.075 //layer=ply \
 //thickness=0.18 //x=50.81 //y=4.97 //x2=50.81 //y2=5.045
r1887 (  525 527 ) resistor r=20.271 //w=0.214 //l=0.09 //layer=ply \
 //thickness=0.18 //x=50.81 //y=4.88 //x2=50.81 //y2=4.97
r1888 (  513 514 ) resistor r=52.7279 //w=0.214 //l=0.165 //layer=ply \
 //thickness=0.18 //x=47.11 //y=2.26 //x2=47.11 //y2=2.095
r1889 (  506 507 ) resistor r=32.4568 //w=0.214 //l=0.075 //layer=ply \
 //thickness=0.18 //x=31.57 //y=4.97 //x2=31.57 //y2=5.045
r1890 (  504 506 ) resistor r=20.271 //w=0.214 //l=0.09 //layer=ply \
 //thickness=0.18 //x=31.57 //y=4.88 //x2=31.57 //y2=4.97
r1891 (  495 496 ) resistor r=32.4568 //w=0.214 //l=0.075 //layer=ply \
 //thickness=0.18 //x=21.95 //y=4.97 //x2=21.95 //y2=5.045
r1892 (  493 495 ) resistor r=20.271 //w=0.214 //l=0.09 //layer=ply \
 //thickness=0.18 //x=21.95 //y=4.88 //x2=21.95 //y2=4.97
r1893 (  481 482 ) resistor r=52.7279 //w=0.214 //l=0.165 //layer=ply \
 //thickness=0.18 //x=18.25 //y=2.26 //x2=18.25 //y2=2.095
r1894 (  474 475 ) resistor r=32.4568 //w=0.214 //l=0.075 //layer=ply \
 //thickness=0.18 //x=2.71 //y=4.97 //x2=2.71 //y2=5.045
r1895 (  472 474 ) resistor r=20.271 //w=0.214 //l=0.09 //layer=ply \
 //thickness=0.18 //x=2.71 //y=4.88 //x2=2.71 //y2=4.97
r1896 (  465 559 ) resistor r=16.5046 //w=0.27 //l=0.135 //layer=ply \
 //thickness=0.18 //x=79.805 //y=4.97 //x2=79.67 //y2=4.97
r1897 (  464 466 ) resistor r=26.9307 //w=0.15 //l=0.106066 //layer=ply \
 //thickness=0.18 //x=80.005 //y=4.97 //x2=80.08 //y2=5.045
r1898 (  464 465 ) resistor r=102.553 //w=0.094 //l=0.2 //layer=ply \
 //thickness=0.18 //x=80.005 //y=4.97 //x2=79.805 //y2=4.97
r1899 (  463 564 ) resistor r=38.6777 //w=0.284 //l=0.198997 //layer=ply \
 //thickness=0.18 //x=79.76 //y=2.095 //x2=79.685 //y2=2.26
r1900 (  462 562 ) resistor r=21.2976 //w=0.217 //l=0.0928709 //layer=ply \
 //thickness=0.18 //x=79.76 //y=1.63 //x2=79.72 //y2=1.555
r1901 (  462 463 ) resistor r=238.436 //w=0.094 //l=0.465 //layer=ply \
 //thickness=0.18 //x=79.76 //y=1.63 //x2=79.76 //y2=2.095
r1902 (  461 562 ) resistor r=39.0671 //w=0.217 //l=0.173853 //layer=ply \
 //thickness=0.18 //x=79.76 //y=1.4 //x2=79.72 //y2=1.555
r1903 (  460 561 ) resistor r=45.1352 //w=0.168 //l=0.173853 //layer=ply \
 //thickness=0.18 //x=79.76 //y=1.09 //x2=79.72 //y2=0.935
r1904 (  460 461 ) resistor r=158.957 //w=0.094 //l=0.31 //layer=ply \
 //thickness=0.18 //x=79.76 //y=1.09 //x2=79.76 //y2=1.4
r1905 (  455 555 ) resistor r=5.52526 //w=0.168 //l=0.115 //layer=ply \
 //thickness=0.18 //x=79.39 //y=1.555 //x2=79.275 //y2=1.555
r1906 (  454 562 ) resistor r=11.4558 //w=0.217 //l=0.115 //layer=ply \
 //thickness=0.18 //x=79.605 //y=1.555 //x2=79.72 //y2=1.555
r1907 (  453 554 ) resistor r=5.52526 //w=0.168 //l=0.115 //layer=ply \
 //thickness=0.18 //x=79.39 //y=0.935 //x2=79.275 //y2=0.935
r1908 (  452 561 ) resistor r=5.52526 //w=0.168 //l=0.115 //layer=ply \
 //thickness=0.18 //x=79.605 //y=0.935 //x2=79.72 //y2=0.935
r1909 (  452 453 ) resistor r=110.245 //w=0.094 //l=0.215 //layer=ply \
 //thickness=0.18 //x=79.605 //y=0.935 //x2=79.39 //y2=0.935
r1910 (  451 555 ) resistor r=45.1352 //w=0.168 //l=0.173853 //layer=ply \
 //thickness=0.18 //x=79.235 //y=1.4 //x2=79.275 //y2=1.555
r1911 (  450 554 ) resistor r=45.1352 //w=0.168 //l=0.173853 //layer=ply \
 //thickness=0.18 //x=79.235 //y=1.09 //x2=79.275 //y2=0.935
r1912 (  450 451 ) resistor r=158.957 //w=0.094 //l=0.31 //layer=ply \
 //thickness=0.18 //x=79.235 //y=1.09 //x2=79.235 //y2=1.4
r1913 (  449 553 ) resistor r=45.1352 //w=0.168 //l=0.173853 //layer=ply \
 //thickness=0.18 //x=76.49 //y=1.44 //x2=76.45 //y2=1.595
r1914 (  448 552 ) resistor r=45.1352 //w=0.168 //l=0.173853 //layer=ply \
 //thickness=0.18 //x=76.49 //y=1.095 //x2=76.45 //y2=0.94
r1915 (  448 449 ) resistor r=176.904 //w=0.094 //l=0.345 //layer=ply \
 //thickness=0.18 //x=76.49 //y=1.095 //x2=76.49 //y2=1.44
r1916 (  446 549 ) resistor r=10.701 //w=0.21 //l=0.115 //layer=ply \
 //thickness=0.18 //x=76.115 //y=1.595 //x2=76 //y2=1.595
r1917 (  445 553 ) resistor r=5.52526 //w=0.168 //l=0.115 //layer=ply \
 //thickness=0.18 //x=76.335 //y=1.595 //x2=76.45 //y2=1.595
r1918 (  444 548 ) resistor r=5.52526 //w=0.168 //l=0.115 //layer=ply \
 //thickness=0.18 //x=76.115 //y=0.94 //x2=76 //y2=0.94
r1919 (  443 552 ) resistor r=5.52526 //w=0.168 //l=0.115 //layer=ply \
 //thickness=0.18 //x=76.335 //y=0.94 //x2=76.45 //y2=0.94
r1920 (  443 444 ) resistor r=112.809 //w=0.094 //l=0.22 //layer=ply \
 //thickness=0.18 //x=76.335 //y=0.94 //x2=76.115 //y2=0.94
r1921 (  440 551 ) resistor r=37.236 //w=0.233 //l=0.249199 //layer=ply \
 //thickness=0.18 //x=76.15 //y=5.045 //x2=75.97 //y2=4.88
r1922 (  438 549 ) resistor r=39.5823 //w=0.21 //l=0.173853 //layer=ply \
 //thickness=0.18 //x=75.96 //y=1.75 //x2=76 //y2=1.595
r1923 (  438 546 ) resistor r=176.904 //w=0.094 //l=0.345 //layer=ply \
 //thickness=0.18 //x=75.96 //y=1.75 //x2=75.96 //y2=2.095
r1924 (  437 549 ) resistor r=39.5823 //w=0.21 //l=0.173853 //layer=ply \
 //thickness=0.18 //x=75.96 //y=1.44 //x2=76 //y2=1.595
r1925 (  436 548 ) resistor r=45.1352 //w=0.168 //l=0.173853 //layer=ply \
 //thickness=0.18 //x=75.96 //y=1.095 //x2=76 //y2=0.94
r1926 (  436 437 ) resistor r=176.904 //w=0.094 //l=0.345 //layer=ply \
 //thickness=0.18 //x=75.96 //y=1.095 //x2=75.96 //y2=1.44
r1927 (  433 551 ) resistor r=53.7854 //w=0.233 //l=0.332415 //layer=ply \
 //thickness=0.18 //x=75.71 //y=5.045 //x2=75.97 //y2=4.88
r1928 (  429 538 ) resistor r=16.5046 //w=0.27 //l=0.135 //layer=ply \
 //thickness=0.18 //x=60.565 //y=4.97 //x2=60.43 //y2=4.97
r1929 (  428 430 ) resistor r=26.9307 //w=0.15 //l=0.106066 //layer=ply \
 //thickness=0.18 //x=60.765 //y=4.97 //x2=60.84 //y2=5.045
r1930 (  428 429 ) resistor r=102.553 //w=0.094 //l=0.2 //layer=ply \
 //thickness=0.18 //x=60.765 //y=4.97 //x2=60.565 //y2=4.97
r1931 (  427 543 ) resistor r=38.6777 //w=0.284 //l=0.198997 //layer=ply \
 //thickness=0.18 //x=60.52 //y=2.095 //x2=60.445 //y2=2.26
r1932 (  426 541 ) resistor r=21.2976 //w=0.217 //l=0.0928709 //layer=ply \
 //thickness=0.18 //x=60.52 //y=1.63 //x2=60.48 //y2=1.555
r1933 (  426 427 ) resistor r=238.436 //w=0.094 //l=0.465 //layer=ply \
 //thickness=0.18 //x=60.52 //y=1.63 //x2=60.52 //y2=2.095
r1934 (  425 541 ) resistor r=39.0671 //w=0.217 //l=0.173853 //layer=ply \
 //thickness=0.18 //x=60.52 //y=1.4 //x2=60.48 //y2=1.555
r1935 (  424 540 ) resistor r=45.1352 //w=0.168 //l=0.173853 //layer=ply \
 //thickness=0.18 //x=60.52 //y=1.09 //x2=60.48 //y2=0.935
r1936 (  424 425 ) resistor r=158.957 //w=0.094 //l=0.31 //layer=ply \
 //thickness=0.18 //x=60.52 //y=1.09 //x2=60.52 //y2=1.4
r1937 (  419 534 ) resistor r=5.52526 //w=0.168 //l=0.115 //layer=ply \
 //thickness=0.18 //x=60.15 //y=1.555 //x2=60.035 //y2=1.555
r1938 (  418 541 ) resistor r=11.4558 //w=0.217 //l=0.115 //layer=ply \
 //thickness=0.18 //x=60.365 //y=1.555 //x2=60.48 //y2=1.555
r1939 (  417 533 ) resistor r=5.52526 //w=0.168 //l=0.115 //layer=ply \
 //thickness=0.18 //x=60.15 //y=0.935 //x2=60.035 //y2=0.935
r1940 (  416 540 ) resistor r=5.52526 //w=0.168 //l=0.115 //layer=ply \
 //thickness=0.18 //x=60.365 //y=0.935 //x2=60.48 //y2=0.935
r1941 (  416 417 ) resistor r=110.245 //w=0.094 //l=0.215 //layer=ply \
 //thickness=0.18 //x=60.365 //y=0.935 //x2=60.15 //y2=0.935
r1942 (  415 534 ) resistor r=45.1352 //w=0.168 //l=0.173853 //layer=ply \
 //thickness=0.18 //x=59.995 //y=1.4 //x2=60.035 //y2=1.555
r1943 (  414 533 ) resistor r=45.1352 //w=0.168 //l=0.173853 //layer=ply \
 //thickness=0.18 //x=59.995 //y=1.09 //x2=60.035 //y2=0.935
r1944 (  414 415 ) resistor r=158.957 //w=0.094 //l=0.31 //layer=ply \
 //thickness=0.18 //x=59.995 //y=1.09 //x2=59.995 //y2=1.4
r1945 (  410 527 ) resistor r=16.5046 //w=0.27 //l=0.135 //layer=ply \
 //thickness=0.18 //x=50.945 //y=4.97 //x2=50.81 //y2=4.97
r1946 (  409 411 ) resistor r=26.9307 //w=0.15 //l=0.106066 //layer=ply \
 //thickness=0.18 //x=51.145 //y=4.97 //x2=51.22 //y2=5.045
r1947 (  409 410 ) resistor r=102.553 //w=0.094 //l=0.2 //layer=ply \
 //thickness=0.18 //x=51.145 //y=4.97 //x2=50.945 //y2=4.97
r1948 (  408 532 ) resistor r=38.6777 //w=0.284 //l=0.198997 //layer=ply \
 //thickness=0.18 //x=50.9 //y=2.095 //x2=50.825 //y2=2.26
r1949 (  407 530 ) resistor r=21.2976 //w=0.217 //l=0.0928709 //layer=ply \
 //thickness=0.18 //x=50.9 //y=1.63 //x2=50.86 //y2=1.555
r1950 (  407 408 ) resistor r=238.436 //w=0.094 //l=0.465 //layer=ply \
 //thickness=0.18 //x=50.9 //y=1.63 //x2=50.9 //y2=2.095
r1951 (  406 530 ) resistor r=39.0671 //w=0.217 //l=0.173853 //layer=ply \
 //thickness=0.18 //x=50.9 //y=1.4 //x2=50.86 //y2=1.555
r1952 (  405 529 ) resistor r=45.1352 //w=0.168 //l=0.173853 //layer=ply \
 //thickness=0.18 //x=50.9 //y=1.09 //x2=50.86 //y2=0.935
r1953 (  405 406 ) resistor r=158.957 //w=0.094 //l=0.31 //layer=ply \
 //thickness=0.18 //x=50.9 //y=1.09 //x2=50.9 //y2=1.4
r1954 (  400 523 ) resistor r=5.52526 //w=0.168 //l=0.115 //layer=ply \
 //thickness=0.18 //x=50.53 //y=1.555 //x2=50.415 //y2=1.555
r1955 (  399 530 ) resistor r=11.4558 //w=0.217 //l=0.115 //layer=ply \
 //thickness=0.18 //x=50.745 //y=1.555 //x2=50.86 //y2=1.555
r1956 (  398 522 ) resistor r=5.52526 //w=0.168 //l=0.115 //layer=ply \
 //thickness=0.18 //x=50.53 //y=0.935 //x2=50.415 //y2=0.935
r1957 (  397 529 ) resistor r=5.52526 //w=0.168 //l=0.115 //layer=ply \
 //thickness=0.18 //x=50.745 //y=0.935 //x2=50.86 //y2=0.935
r1958 (  397 398 ) resistor r=110.245 //w=0.094 //l=0.215 //layer=ply \
 //thickness=0.18 //x=50.745 //y=0.935 //x2=50.53 //y2=0.935
r1959 (  396 523 ) resistor r=45.1352 //w=0.168 //l=0.173853 //layer=ply \
 //thickness=0.18 //x=50.375 //y=1.4 //x2=50.415 //y2=1.555
r1960 (  395 522 ) resistor r=45.1352 //w=0.168 //l=0.173853 //layer=ply \
 //thickness=0.18 //x=50.375 //y=1.09 //x2=50.415 //y2=0.935
r1961 (  395 396 ) resistor r=158.957 //w=0.094 //l=0.31 //layer=ply \
 //thickness=0.18 //x=50.375 //y=1.09 //x2=50.375 //y2=1.4
r1962 (  394 521 ) resistor r=45.1352 //w=0.168 //l=0.173853 //layer=ply \
 //thickness=0.18 //x=47.63 //y=1.44 //x2=47.59 //y2=1.595
r1963 (  393 520 ) resistor r=45.1352 //w=0.168 //l=0.173853 //layer=ply \
 //thickness=0.18 //x=47.63 //y=1.095 //x2=47.59 //y2=0.94
r1964 (  393 394 ) resistor r=176.904 //w=0.094 //l=0.345 //layer=ply \
 //thickness=0.18 //x=47.63 //y=1.095 //x2=47.63 //y2=1.44
r1965 (  391 517 ) resistor r=10.701 //w=0.21 //l=0.115 //layer=ply \
 //thickness=0.18 //x=47.255 //y=1.595 //x2=47.14 //y2=1.595
r1966 (  390 521 ) resistor r=5.52526 //w=0.168 //l=0.115 //layer=ply \
 //thickness=0.18 //x=47.475 //y=1.595 //x2=47.59 //y2=1.595
r1967 (  389 516 ) resistor r=5.52526 //w=0.168 //l=0.115 //layer=ply \
 //thickness=0.18 //x=47.255 //y=0.94 //x2=47.14 //y2=0.94
r1968 (  388 520 ) resistor r=5.52526 //w=0.168 //l=0.115 //layer=ply \
 //thickness=0.18 //x=47.475 //y=0.94 //x2=47.59 //y2=0.94
r1969 (  388 389 ) resistor r=112.809 //w=0.094 //l=0.22 //layer=ply \
 //thickness=0.18 //x=47.475 //y=0.94 //x2=47.255 //y2=0.94
r1970 (  385 519 ) resistor r=37.236 //w=0.233 //l=0.249199 //layer=ply \
 //thickness=0.18 //x=47.29 //y=5.045 //x2=47.11 //y2=4.88
r1971 (  383 517 ) resistor r=39.5823 //w=0.21 //l=0.173853 //layer=ply \
 //thickness=0.18 //x=47.1 //y=1.75 //x2=47.14 //y2=1.595
r1972 (  383 514 ) resistor r=176.904 //w=0.094 //l=0.345 //layer=ply \
 //thickness=0.18 //x=47.1 //y=1.75 //x2=47.1 //y2=2.095
r1973 (  382 517 ) resistor r=39.5823 //w=0.21 //l=0.173853 //layer=ply \
 //thickness=0.18 //x=47.1 //y=1.44 //x2=47.14 //y2=1.595
r1974 (  381 516 ) resistor r=45.1352 //w=0.168 //l=0.173853 //layer=ply \
 //thickness=0.18 //x=47.1 //y=1.095 //x2=47.14 //y2=0.94
r1975 (  381 382 ) resistor r=176.904 //w=0.094 //l=0.345 //layer=ply \
 //thickness=0.18 //x=47.1 //y=1.095 //x2=47.1 //y2=1.44
r1976 (  378 519 ) resistor r=53.7854 //w=0.233 //l=0.332415 //layer=ply \
 //thickness=0.18 //x=46.85 //y=5.045 //x2=47.11 //y2=4.88
r1977 (  374 506 ) resistor r=16.5046 //w=0.27 //l=0.135 //layer=ply \
 //thickness=0.18 //x=31.705 //y=4.97 //x2=31.57 //y2=4.97
r1978 (  373 375 ) resistor r=26.9307 //w=0.15 //l=0.106066 //layer=ply \
 //thickness=0.18 //x=31.905 //y=4.97 //x2=31.98 //y2=5.045
r1979 (  373 374 ) resistor r=102.553 //w=0.094 //l=0.2 //layer=ply \
 //thickness=0.18 //x=31.905 //y=4.97 //x2=31.705 //y2=4.97
r1980 (  372 511 ) resistor r=38.6777 //w=0.284 //l=0.198997 //layer=ply \
 //thickness=0.18 //x=31.66 //y=2.095 //x2=31.585 //y2=2.26
r1981 (  371 509 ) resistor r=21.2976 //w=0.217 //l=0.0928709 //layer=ply \
 //thickness=0.18 //x=31.66 //y=1.63 //x2=31.62 //y2=1.555
r1982 (  371 372 ) resistor r=238.436 //w=0.094 //l=0.465 //layer=ply \
 //thickness=0.18 //x=31.66 //y=1.63 //x2=31.66 //y2=2.095
r1983 (  370 509 ) resistor r=39.0671 //w=0.217 //l=0.173853 //layer=ply \
 //thickness=0.18 //x=31.66 //y=1.4 //x2=31.62 //y2=1.555
r1984 (  369 508 ) resistor r=45.1352 //w=0.168 //l=0.173853 //layer=ply \
 //thickness=0.18 //x=31.66 //y=1.09 //x2=31.62 //y2=0.935
r1985 (  369 370 ) resistor r=158.957 //w=0.094 //l=0.31 //layer=ply \
 //thickness=0.18 //x=31.66 //y=1.09 //x2=31.66 //y2=1.4
r1986 (  364 502 ) resistor r=5.52526 //w=0.168 //l=0.115 //layer=ply \
 //thickness=0.18 //x=31.29 //y=1.555 //x2=31.175 //y2=1.555
r1987 (  363 509 ) resistor r=11.4558 //w=0.217 //l=0.115 //layer=ply \
 //thickness=0.18 //x=31.505 //y=1.555 //x2=31.62 //y2=1.555
r1988 (  362 501 ) resistor r=5.52526 //w=0.168 //l=0.115 //layer=ply \
 //thickness=0.18 //x=31.29 //y=0.935 //x2=31.175 //y2=0.935
r1989 (  361 508 ) resistor r=5.52526 //w=0.168 //l=0.115 //layer=ply \
 //thickness=0.18 //x=31.505 //y=0.935 //x2=31.62 //y2=0.935
r1990 (  361 362 ) resistor r=110.245 //w=0.094 //l=0.215 //layer=ply \
 //thickness=0.18 //x=31.505 //y=0.935 //x2=31.29 //y2=0.935
r1991 (  360 502 ) resistor r=45.1352 //w=0.168 //l=0.173853 //layer=ply \
 //thickness=0.18 //x=31.135 //y=1.4 //x2=31.175 //y2=1.555
r1992 (  359 501 ) resistor r=45.1352 //w=0.168 //l=0.173853 //layer=ply \
 //thickness=0.18 //x=31.135 //y=1.09 //x2=31.175 //y2=0.935
r1993 (  359 360 ) resistor r=158.957 //w=0.094 //l=0.31 //layer=ply \
 //thickness=0.18 //x=31.135 //y=1.09 //x2=31.135 //y2=1.4
r1994 (  355 495 ) resistor r=16.5046 //w=0.27 //l=0.135 //layer=ply \
 //thickness=0.18 //x=22.085 //y=4.97 //x2=21.95 //y2=4.97
r1995 (  354 356 ) resistor r=26.9307 //w=0.15 //l=0.106066 //layer=ply \
 //thickness=0.18 //x=22.285 //y=4.97 //x2=22.36 //y2=5.045
r1996 (  354 355 ) resistor r=102.553 //w=0.094 //l=0.2 //layer=ply \
 //thickness=0.18 //x=22.285 //y=4.97 //x2=22.085 //y2=4.97
r1997 (  353 500 ) resistor r=38.6777 //w=0.284 //l=0.198997 //layer=ply \
 //thickness=0.18 //x=22.04 //y=2.095 //x2=21.965 //y2=2.26
r1998 (  352 498 ) resistor r=21.2976 //w=0.217 //l=0.0928709 //layer=ply \
 //thickness=0.18 //x=22.04 //y=1.63 //x2=22 //y2=1.555
r1999 (  352 353 ) resistor r=238.436 //w=0.094 //l=0.465 //layer=ply \
 //thickness=0.18 //x=22.04 //y=1.63 //x2=22.04 //y2=2.095
r2000 (  351 498 ) resistor r=39.0671 //w=0.217 //l=0.173853 //layer=ply \
 //thickness=0.18 //x=22.04 //y=1.4 //x2=22 //y2=1.555
r2001 (  350 497 ) resistor r=45.1352 //w=0.168 //l=0.173853 //layer=ply \
 //thickness=0.18 //x=22.04 //y=1.09 //x2=22 //y2=0.935
r2002 (  350 351 ) resistor r=158.957 //w=0.094 //l=0.31 //layer=ply \
 //thickness=0.18 //x=22.04 //y=1.09 //x2=22.04 //y2=1.4
r2003 (  345 491 ) resistor r=5.52526 //w=0.168 //l=0.115 //layer=ply \
 //thickness=0.18 //x=21.67 //y=1.555 //x2=21.555 //y2=1.555
r2004 (  344 498 ) resistor r=11.4558 //w=0.217 //l=0.115 //layer=ply \
 //thickness=0.18 //x=21.885 //y=1.555 //x2=22 //y2=1.555
r2005 (  343 490 ) resistor r=5.52526 //w=0.168 //l=0.115 //layer=ply \
 //thickness=0.18 //x=21.67 //y=0.935 //x2=21.555 //y2=0.935
r2006 (  342 497 ) resistor r=5.52526 //w=0.168 //l=0.115 //layer=ply \
 //thickness=0.18 //x=21.885 //y=0.935 //x2=22 //y2=0.935
r2007 (  342 343 ) resistor r=110.245 //w=0.094 //l=0.215 //layer=ply \
 //thickness=0.18 //x=21.885 //y=0.935 //x2=21.67 //y2=0.935
r2008 (  341 491 ) resistor r=45.1352 //w=0.168 //l=0.173853 //layer=ply \
 //thickness=0.18 //x=21.515 //y=1.4 //x2=21.555 //y2=1.555
r2009 (  340 490 ) resistor r=45.1352 //w=0.168 //l=0.173853 //layer=ply \
 //thickness=0.18 //x=21.515 //y=1.09 //x2=21.555 //y2=0.935
r2010 (  340 341 ) resistor r=158.957 //w=0.094 //l=0.31 //layer=ply \
 //thickness=0.18 //x=21.515 //y=1.09 //x2=21.515 //y2=1.4
r2011 (  339 489 ) resistor r=45.1352 //w=0.168 //l=0.173853 //layer=ply \
 //thickness=0.18 //x=18.77 //y=1.44 //x2=18.73 //y2=1.595
r2012 (  338 488 ) resistor r=45.1352 //w=0.168 //l=0.173853 //layer=ply \
 //thickness=0.18 //x=18.77 //y=1.095 //x2=18.73 //y2=0.94
r2013 (  338 339 ) resistor r=176.904 //w=0.094 //l=0.345 //layer=ply \
 //thickness=0.18 //x=18.77 //y=1.095 //x2=18.77 //y2=1.44
r2014 (  336 485 ) resistor r=10.701 //w=0.21 //l=0.115 //layer=ply \
 //thickness=0.18 //x=18.395 //y=1.595 //x2=18.28 //y2=1.595
r2015 (  335 489 ) resistor r=5.52526 //w=0.168 //l=0.115 //layer=ply \
 //thickness=0.18 //x=18.615 //y=1.595 //x2=18.73 //y2=1.595
r2016 (  334 484 ) resistor r=5.52526 //w=0.168 //l=0.115 //layer=ply \
 //thickness=0.18 //x=18.395 //y=0.94 //x2=18.28 //y2=0.94
r2017 (  333 488 ) resistor r=5.52526 //w=0.168 //l=0.115 //layer=ply \
 //thickness=0.18 //x=18.615 //y=0.94 //x2=18.73 //y2=0.94
r2018 (  333 334 ) resistor r=112.809 //w=0.094 //l=0.22 //layer=ply \
 //thickness=0.18 //x=18.615 //y=0.94 //x2=18.395 //y2=0.94
r2019 (  330 487 ) resistor r=37.236 //w=0.233 //l=0.249199 //layer=ply \
 //thickness=0.18 //x=18.43 //y=5.045 //x2=18.25 //y2=4.88
r2020 (  328 485 ) resistor r=39.5823 //w=0.21 //l=0.173853 //layer=ply \
 //thickness=0.18 //x=18.24 //y=1.75 //x2=18.28 //y2=1.595
r2021 (  328 482 ) resistor r=176.904 //w=0.094 //l=0.345 //layer=ply \
 //thickness=0.18 //x=18.24 //y=1.75 //x2=18.24 //y2=2.095
r2022 (  327 485 ) resistor r=39.5823 //w=0.21 //l=0.173853 //layer=ply \
 //thickness=0.18 //x=18.24 //y=1.44 //x2=18.28 //y2=1.595
r2023 (  326 484 ) resistor r=45.1352 //w=0.168 //l=0.173853 //layer=ply \
 //thickness=0.18 //x=18.24 //y=1.095 //x2=18.28 //y2=0.94
r2024 (  326 327 ) resistor r=176.904 //w=0.094 //l=0.345 //layer=ply \
 //thickness=0.18 //x=18.24 //y=1.095 //x2=18.24 //y2=1.44
r2025 (  323 487 ) resistor r=53.7854 //w=0.233 //l=0.332415 //layer=ply \
 //thickness=0.18 //x=17.99 //y=5.045 //x2=18.25 //y2=4.88
r2026 (  319 474 ) resistor r=16.5046 //w=0.27 //l=0.135 //layer=ply \
 //thickness=0.18 //x=2.845 //y=4.97 //x2=2.71 //y2=4.97
r2027 (  318 320 ) resistor r=26.9307 //w=0.15 //l=0.106066 //layer=ply \
 //thickness=0.18 //x=3.045 //y=4.97 //x2=3.12 //y2=5.045
r2028 (  318 319 ) resistor r=102.553 //w=0.094 //l=0.2 //layer=ply \
 //thickness=0.18 //x=3.045 //y=4.97 //x2=2.845 //y2=4.97
r2029 (  317 479 ) resistor r=38.6777 //w=0.284 //l=0.198997 //layer=ply \
 //thickness=0.18 //x=2.8 //y=2.095 //x2=2.725 //y2=2.26
r2030 (  316 477 ) resistor r=21.2976 //w=0.217 //l=0.0928709 //layer=ply \
 //thickness=0.18 //x=2.8 //y=1.63 //x2=2.76 //y2=1.555
r2031 (  316 317 ) resistor r=238.436 //w=0.094 //l=0.465 //layer=ply \
 //thickness=0.18 //x=2.8 //y=1.63 //x2=2.8 //y2=2.095
r2032 (  315 477 ) resistor r=39.0671 //w=0.217 //l=0.173853 //layer=ply \
 //thickness=0.18 //x=2.8 //y=1.4 //x2=2.76 //y2=1.555
r2033 (  314 476 ) resistor r=45.1352 //w=0.168 //l=0.173853 //layer=ply \
 //thickness=0.18 //x=2.8 //y=1.09 //x2=2.76 //y2=0.935
r2034 (  314 315 ) resistor r=158.957 //w=0.094 //l=0.31 //layer=ply \
 //thickness=0.18 //x=2.8 //y=1.09 //x2=2.8 //y2=1.4
r2035 (  309 470 ) resistor r=5.52526 //w=0.168 //l=0.115 //layer=ply \
 //thickness=0.18 //x=2.43 //y=1.555 //x2=2.315 //y2=1.555
r2036 (  308 477 ) resistor r=11.4558 //w=0.217 //l=0.115 //layer=ply \
 //thickness=0.18 //x=2.645 //y=1.555 //x2=2.76 //y2=1.555
r2037 (  307 469 ) resistor r=5.52526 //w=0.168 //l=0.115 //layer=ply \
 //thickness=0.18 //x=2.43 //y=0.935 //x2=2.315 //y2=0.935
r2038 (  306 476 ) resistor r=5.52526 //w=0.168 //l=0.115 //layer=ply \
 //thickness=0.18 //x=2.645 //y=0.935 //x2=2.76 //y2=0.935
r2039 (  306 307 ) resistor r=110.245 //w=0.094 //l=0.215 //layer=ply \
 //thickness=0.18 //x=2.645 //y=0.935 //x2=2.43 //y2=0.935
r2040 (  305 470 ) resistor r=45.1352 //w=0.168 //l=0.173853 //layer=ply \
 //thickness=0.18 //x=2.275 //y=1.4 //x2=2.315 //y2=1.555
r2041 (  304 469 ) resistor r=45.1352 //w=0.168 //l=0.173853 //layer=ply \
 //thickness=0.18 //x=2.275 //y=1.09 //x2=2.315 //y2=0.935
r2042 (  304 305 ) resistor r=158.957 //w=0.094 //l=0.31 //layer=ply \
 //thickness=0.18 //x=2.275 //y=1.09 //x2=2.275 //y2=1.4
r2043 (  303 466 ) resistor r=592.245 //w=0.094 //l=1.155 //layer=ply \
 //thickness=0.18 //x=80.08 //y=6.2 //x2=80.08 //y2=5.045
r2044 (  302 560 ) resistor r=592.245 //w=0.094 //l=1.155 //layer=ply \
 //thickness=0.18 //x=79.64 //y=6.2 //x2=79.64 //y2=5.045
r2045 (  301 440 ) resistor r=592.245 //w=0.094 //l=1.155 //layer=ply \
 //thickness=0.18 //x=76.15 //y=6.2 //x2=76.15 //y2=5.045
r2046 (  300 433 ) resistor r=592.245 //w=0.094 //l=1.155 //layer=ply \
 //thickness=0.18 //x=75.71 //y=6.2 //x2=75.71 //y2=5.045
r2047 (  299 430 ) resistor r=592.245 //w=0.094 //l=1.155 //layer=ply \
 //thickness=0.18 //x=60.84 //y=6.2 //x2=60.84 //y2=5.045
r2048 (  298 539 ) resistor r=592.245 //w=0.094 //l=1.155 //layer=ply \
 //thickness=0.18 //x=60.4 //y=6.2 //x2=60.4 //y2=5.045
r2049 (  297 411 ) resistor r=592.245 //w=0.094 //l=1.155 //layer=ply \
 //thickness=0.18 //x=51.22 //y=6.2 //x2=51.22 //y2=5.045
r2050 (  296 528 ) resistor r=592.245 //w=0.094 //l=1.155 //layer=ply \
 //thickness=0.18 //x=50.78 //y=6.2 //x2=50.78 //y2=5.045
r2051 (  295 385 ) resistor r=592.245 //w=0.094 //l=1.155 //layer=ply \
 //thickness=0.18 //x=47.29 //y=6.2 //x2=47.29 //y2=5.045
r2052 (  294 378 ) resistor r=592.245 //w=0.094 //l=1.155 //layer=ply \
 //thickness=0.18 //x=46.85 //y=6.2 //x2=46.85 //y2=5.045
r2053 (  293 375 ) resistor r=592.245 //w=0.094 //l=1.155 //layer=ply \
 //thickness=0.18 //x=31.98 //y=6.2 //x2=31.98 //y2=5.045
r2054 (  292 507 ) resistor r=592.245 //w=0.094 //l=1.155 //layer=ply \
 //thickness=0.18 //x=31.54 //y=6.2 //x2=31.54 //y2=5.045
r2055 (  291 356 ) resistor r=592.245 //w=0.094 //l=1.155 //layer=ply \
 //thickness=0.18 //x=22.36 //y=6.2 //x2=22.36 //y2=5.045
r2056 (  290 496 ) resistor r=592.245 //w=0.094 //l=1.155 //layer=ply \
 //thickness=0.18 //x=21.92 //y=6.2 //x2=21.92 //y2=5.045
r2057 (  289 330 ) resistor r=592.245 //w=0.094 //l=1.155 //layer=ply \
 //thickness=0.18 //x=18.43 //y=6.2 //x2=18.43 //y2=5.045
r2058 (  288 323 ) resistor r=592.245 //w=0.094 //l=1.155 //layer=ply \
 //thickness=0.18 //x=17.99 //y=6.2 //x2=17.99 //y2=5.045
r2059 (  287 320 ) resistor r=592.245 //w=0.094 //l=1.155 //layer=ply \
 //thickness=0.18 //x=3.12 //y=6.2 //x2=3.12 //y2=5.045
r2060 (  286 475 ) resistor r=592.245 //w=0.094 //l=1.155 //layer=ply \
 //thickness=0.18 //x=2.68 //y=6.2 //x2=2.68 //y2=5.045
r2061 (  285 454 ) resistor r=55.3787 //w=0.094 //l=0.108 //layer=ply \
 //thickness=0.18 //x=79.497 //y=1.555 //x2=79.605 //y2=1.555
r2062 (  285 455 ) resistor r=54.866 //w=0.094 //l=0.107 //layer=ply \
 //thickness=0.18 //x=79.497 //y=1.555 //x2=79.39 //y2=1.555
r2063 (  284 445 ) resistor r=56.4043 //w=0.094 //l=0.11 //layer=ply \
 //thickness=0.18 //x=76.225 //y=1.595 //x2=76.335 //y2=1.595
r2064 (  284 446 ) resistor r=56.4043 //w=0.094 //l=0.11 //layer=ply \
 //thickness=0.18 //x=76.225 //y=1.595 //x2=76.115 //y2=1.595
r2065 (  283 418 ) resistor r=55.3787 //w=0.094 //l=0.108 //layer=ply \
 //thickness=0.18 //x=60.257 //y=1.555 //x2=60.365 //y2=1.555
r2066 (  283 419 ) resistor r=54.866 //w=0.094 //l=0.107 //layer=ply \
 //thickness=0.18 //x=60.257 //y=1.555 //x2=60.15 //y2=1.555
r2067 (  282 399 ) resistor r=55.3787 //w=0.094 //l=0.108 //layer=ply \
 //thickness=0.18 //x=50.637 //y=1.555 //x2=50.745 //y2=1.555
r2068 (  282 400 ) resistor r=54.866 //w=0.094 //l=0.107 //layer=ply \
 //thickness=0.18 //x=50.637 //y=1.555 //x2=50.53 //y2=1.555
r2069 (  281 390 ) resistor r=56.4043 //w=0.094 //l=0.11 //layer=ply \
 //thickness=0.18 //x=47.365 //y=1.595 //x2=47.475 //y2=1.595
r2070 (  281 391 ) resistor r=56.4043 //w=0.094 //l=0.11 //layer=ply \
 //thickness=0.18 //x=47.365 //y=1.595 //x2=47.255 //y2=1.595
r2071 (  280 363 ) resistor r=55.3787 //w=0.094 //l=0.108 //layer=ply \
 //thickness=0.18 //x=31.397 //y=1.555 //x2=31.505 //y2=1.555
r2072 (  280 364 ) resistor r=54.866 //w=0.094 //l=0.107 //layer=ply \
 //thickness=0.18 //x=31.397 //y=1.555 //x2=31.29 //y2=1.555
r2073 (  279 344 ) resistor r=55.3787 //w=0.094 //l=0.108 //layer=ply \
 //thickness=0.18 //x=21.777 //y=1.555 //x2=21.885 //y2=1.555
r2074 (  279 345 ) resistor r=54.866 //w=0.094 //l=0.107 //layer=ply \
 //thickness=0.18 //x=21.777 //y=1.555 //x2=21.67 //y2=1.555
r2075 (  278 335 ) resistor r=56.4043 //w=0.094 //l=0.11 //layer=ply \
 //thickness=0.18 //x=18.505 //y=1.595 //x2=18.615 //y2=1.595
r2076 (  278 336 ) resistor r=56.4043 //w=0.094 //l=0.11 //layer=ply \
 //thickness=0.18 //x=18.505 //y=1.595 //x2=18.395 //y2=1.595
r2077 (  277 308 ) resistor r=55.3787 //w=0.094 //l=0.108 //layer=ply \
 //thickness=0.18 //x=2.537 //y=1.555 //x2=2.645 //y2=1.555
r2078 (  277 309 ) resistor r=54.866 //w=0.094 //l=0.107 //layer=ply \
 //thickness=0.18 //x=2.537 //y=1.555 //x2=2.43 //y2=1.555
r2079 (  273 557 ) resistor r=152 //w=0.17 //l=0.17 //layer=licon //count=1 \
 //x=79.67 //y=4.88 //x2=79.67 //y2=4.88
r2080 (  268 564 ) resistor r=152 //w=0.17 //l=0.17 //layer=licon //count=1 \
 //x=79.67 //y=2.26 //x2=79.67 //y2=2.26
r2081 (  263 551 ) resistor r=152 //w=0.17 //l=0.17 //layer=licon //count=1 \
 //x=75.97 //y=4.88 //x2=75.97 //y2=4.88
r2082 (  258 545 ) resistor r=152 //w=0.17 //l=0.17 //layer=licon //count=1 \
 //x=75.97 //y=2.26 //x2=75.97 //y2=2.26
r2083 (  253 536 ) resistor r=152 //w=0.17 //l=0.17 //layer=licon //count=1 \
 //x=60.43 //y=4.88 //x2=60.43 //y2=4.88
r2084 (  248 543 ) resistor r=152 //w=0.17 //l=0.17 //layer=licon //count=1 \
 //x=60.43 //y=2.26 //x2=60.43 //y2=2.26
r2085 (  243 525 ) resistor r=152 //w=0.17 //l=0.17 //layer=licon //count=1 \
 //x=50.81 //y=4.88 //x2=50.81 //y2=4.88
r2086 (  238 532 ) resistor r=152 //w=0.17 //l=0.17 //layer=licon //count=1 \
 //x=50.81 //y=2.26 //x2=50.81 //y2=2.26
r2087 (  233 519 ) resistor r=152 //w=0.17 //l=0.17 //layer=licon //count=1 \
 //x=47.11 //y=4.88 //x2=47.11 //y2=4.88
r2088 (  228 513 ) resistor r=152 //w=0.17 //l=0.17 //layer=licon //count=1 \
 //x=47.11 //y=2.26 //x2=47.11 //y2=2.26
r2089 (  223 504 ) resistor r=152 //w=0.17 //l=0.17 //layer=licon //count=1 \
 //x=31.57 //y=4.88 //x2=31.57 //y2=4.88
r2090 (  218 511 ) resistor r=152 //w=0.17 //l=0.17 //layer=licon //count=1 \
 //x=31.57 //y=2.26 //x2=31.57 //y2=2.26
r2091 (  213 493 ) resistor r=152 //w=0.17 //l=0.17 //layer=licon //count=1 \
 //x=21.95 //y=4.88 //x2=21.95 //y2=4.88
r2092 (  208 500 ) resistor r=152 //w=0.17 //l=0.17 //layer=licon //count=1 \
 //x=21.95 //y=2.26 //x2=21.95 //y2=2.26
r2093 (  203 487 ) resistor r=152 //w=0.17 //l=0.17 //layer=licon //count=1 \
 //x=18.25 //y=4.88 //x2=18.25 //y2=4.88
r2094 (  198 481 ) resistor r=152 //w=0.17 //l=0.17 //layer=licon //count=1 \
 //x=18.25 //y=2.26 //x2=18.25 //y2=2.26
r2095 (  193 472 ) resistor r=152 //w=0.17 //l=0.17 //layer=licon //count=1 \
 //x=2.71 //y=4.88 //x2=2.71 //y2=4.88
r2096 (  188 479 ) resistor r=152 //w=0.17 //l=0.17 //layer=licon //count=1 \
 //x=2.71 //y=2.26 //x2=2.71 //y2=2.26
r2097 (  184 185 ) resistor r=0.10734 //w=0.281 //l=0.16 //layer=m2 \
 //thickness=0.36 //x=79.665 //y=2.41 //x2=79.505 //y2=2.41
r2098 (  165 182 ) resistor r=0.105717 //w=0.193 //l=0.162481 //layer=m2 \
 //thickness=0.36 //x=76.135 //y=2.4 //x2=75.975 //y2=2.405
r2099 (  165 185 ) resistor r=3.21565 //w=0.131 //l=3.37 //layer=m2 \
 //thickness=0.36 //x=76.135 //y=2.4 //x2=79.505 //y2=2.4
r2100 (  162 182 ) resistor r=1.29743 //w=0.193 //l=2.00998 //layer=m2 \
 //thickness=0.36 //x=73.975 //y=2.385 //x2=75.975 //y2=2.405
r2101 (  162 163 ) resistor r=0.410305 //w=0.131 //l=0.43 //layer=m2 \
 //thickness=0.36 //x=73.975 //y=2.385 //x2=73.545 //y2=2.385
r2102 (  160 163 ) resistor r=0.125 //w=0.17 //l=0.177341 //layer=m2 \
 //thickness=0.36 //x=73.375 //y=2.4 //x2=73.545 //y2=2.385
r2103 (  160 161 ) resistor r=0.958969 //w=0.131 //l=1.005 //layer=m2 \
 //thickness=0.36 //x=73.375 //y=2.4 //x2=72.37 //y2=2.4
r2104 (  159 180 ) resistor r=8.08549 //w=0.174 //l=11.2625 //layer=m2 \
 //thickness=0.36 //x=71.685 //y=2.385 //x2=60.43 //y2=2.4
r2105 (  158 161 ) resistor r=0.1875 //w=0.17 //l=0.262393 //layer=m2 \
 //thickness=0.36 //x=72.115 //y=2.385 //x2=72.37 //y2=2.4
r2106 (  158 159 ) resistor r=0.410305 //w=0.131 //l=0.43 //layer=m2 \
 //thickness=0.36 //x=72.115 //y=2.385 //x2=71.685 //y2=2.385
r2107 (  156 180 ) resistor r=1.97198 //w=0.174 //l=2.75996 //layer=m2 \
 //thickness=0.36 //x=57.685 //y=2.37 //x2=60.43 //y2=2.4
r2108 (  156 157 ) resistor r=0.410305 //w=0.131 //l=0.43 //layer=m2 \
 //thickness=0.36 //x=57.685 //y=2.37 //x2=57.255 //y2=2.37
r2109 (  154 157 ) resistor r=0.125 //w=0.17 //l=0.184391 //layer=m2 \
 //thickness=0.36 //x=57.085 //y=2.4 //x2=57.255 //y2=2.37
r2110 (  154 155 ) resistor r=4.48473 //w=0.131 //l=4.7 //layer=m2 \
 //thickness=0.36 //x=57.085 //y=2.4 //x2=52.385 //y2=2.4
r2111 (  153 178 ) resistor r=0.523955 //w=0.216 //l=0.914781 //layer=m2 \
 //thickness=0.36 //x=51.7 //y=2.37 //x2=50.805 //y2=2.41
r2112 (  152 155 ) resistor r=0.1875 //w=0.17 //l=0.269583 //layer=m2 \
 //thickness=0.36 //x=52.13 //y=2.37 //x2=52.385 //y2=2.4
r2113 (  152 153 ) resistor r=0.410305 //w=0.131 //l=0.43 //layer=m2 \
 //thickness=0.36 //x=52.13 //y=2.37 //x2=51.7 //y2=2.37
r2114 (  151 176 ) resistor r=0.105717 //w=0.193 //l=0.162481 //layer=m2 \
 //thickness=0.36 //x=47.275 //y=2.4 //x2=47.115 //y2=2.405
r2115 (  150 178 ) resistor r=0.0986081 //w=0.216 //l=0.164924 //layer=m2 \
 //thickness=0.36 //x=50.645 //y=2.4 //x2=50.805 //y2=2.41
r2116 (  150 151 ) resistor r=3.21565 //w=0.131 //l=3.37 //layer=m2 \
 //thickness=0.36 //x=50.645 //y=2.4 //x2=47.275 //y2=2.4
r2117 (  148 176 ) resistor r=1.29743 //w=0.193 //l=2.00998 //layer=m2 \
 //thickness=0.36 //x=45.115 //y=2.385 //x2=47.115 //y2=2.405
r2118 (  148 149 ) resistor r=0.410305 //w=0.131 //l=0.43 //layer=m2 \
 //thickness=0.36 //x=45.115 //y=2.385 //x2=44.685 //y2=2.385
r2119 (  146 149 ) resistor r=0.125 //w=0.17 //l=0.177341 //layer=m2 \
 //thickness=0.36 //x=44.515 //y=2.4 //x2=44.685 //y2=2.385
r2120 (  146 147 ) resistor r=0.958969 //w=0.131 //l=1.005 //layer=m2 \
 //thickness=0.36 //x=44.515 //y=2.4 //x2=43.51 //y2=2.4
r2121 (  145 174 ) resistor r=8.13223 //w=0.173 //l=11.2625 //layer=m2 \
 //thickness=0.36 //x=42.825 //y=2.385 //x2=31.57 //y2=2.4
r2122 (  144 147 ) resistor r=0.1875 //w=0.17 //l=0.262393 //layer=m2 \
 //thickness=0.36 //x=43.255 //y=2.385 //x2=43.51 //y2=2.4
r2123 (  144 145 ) resistor r=0.410305 //w=0.131 //l=0.43 //layer=m2 \
 //thickness=0.36 //x=43.255 //y=2.385 //x2=42.825 //y2=2.385
r2124 (  142 174 ) resistor r=4.15462 //w=0.173 //l=5.76498 //layer=m2 \
 //thickness=0.36 //x=25.82 //y=2.37 //x2=31.57 //y2=2.4
r2125 (  142 143 ) resistor r=0.410305 //w=0.131 //l=0.43 //layer=m2 \
 //thickness=0.36 //x=25.82 //y=2.37 //x2=25.39 //y2=2.37
r2126 (  140 143 ) resistor r=0.125 //w=0.17 //l=0.184391 //layer=m2 \
 //thickness=0.36 //x=25.22 //y=2.4 //x2=25.39 //y2=2.37
r2127 (  140 141 ) resistor r=0.86355 //w=0.131 //l=0.905 //layer=m2 \
 //thickness=0.36 //x=25.22 //y=2.4 //x2=24.315 //y2=2.4
r2128 (  139 172 ) resistor r=1.07185 //w=0.197 //l=1.70488 //layer=m2 \
 //thickness=0.36 //x=23.63 //y=2.37 //x2=21.945 //y2=2.41
r2129 (  138 141 ) resistor r=0.1875 //w=0.17 //l=0.269583 //layer=m2 \
 //thickness=0.36 //x=24.06 //y=2.37 //x2=24.315 //y2=2.4
r2130 (  138 139 ) resistor r=0.410305 //w=0.131 //l=0.43 //layer=m2 \
 //thickness=0.36 //x=24.06 //y=2.37 //x2=23.63 //y2=2.37
r2131 (  137 170 ) resistor r=0.105717 //w=0.193 //l=0.162481 //layer=m2 \
 //thickness=0.36 //x=18.415 //y=2.4 //x2=18.255 //y2=2.405
r2132 (  136 172 ) resistor r=0.104215 //w=0.197 //l=0.164924 //layer=m2 \
 //thickness=0.36 //x=21.785 //y=2.4 //x2=21.945 //y2=2.41
r2133 (  136 137 ) resistor r=3.21565 //w=0.131 //l=3.37 //layer=m2 \
 //thickness=0.36 //x=21.785 //y=2.4 //x2=18.415 //y2=2.4
r2134 (  134 170 ) resistor r=1.29743 //w=0.193 //l=2.00998 //layer=m2 \
 //thickness=0.36 //x=16.255 //y=2.385 //x2=18.255 //y2=2.405
r2135 (  134 135 ) resistor r=0.410305 //w=0.131 //l=0.43 //layer=m2 \
 //thickness=0.36 //x=16.255 //y=2.385 //x2=15.825 //y2=2.385
r2136 (  132 135 ) resistor r=0.125 //w=0.17 //l=0.177341 //layer=m2 \
 //thickness=0.36 //x=15.655 //y=2.4 //x2=15.825 //y2=2.385
r2137 (  132 133 ) resistor r=0.958969 //w=0.131 //l=1.005 //layer=m2 \
 //thickness=0.36 //x=15.655 //y=2.4 //x2=14.65 //y2=2.4
r2138 (  130 133 ) resistor r=0.1875 //w=0.17 //l=0.262393 //layer=m2 \
 //thickness=0.36 //x=14.395 //y=2.385 //x2=14.65 //y2=2.4
r2139 (  130 131 ) resistor r=0.410305 //w=0.131 //l=0.43 //layer=m2 \
 //thickness=0.36 //x=14.395 //y=2.385 //x2=13.965 //y2=2.385
r2140 (  129 167 ) resistor r=0.10734 //w=0.281 //l=0.16 //layer=m2 \
 //thickness=0.36 //x=2.87 //y=2.4 //x2=2.71 //y2=2.4
r2141 (  128 131 ) resistor r=0.125 //w=0.17 //l=0.177341 //layer=m2 \
 //thickness=0.36 //x=13.795 //y=2.4 //x2=13.965 //y2=2.385
r2142 (  128 129 ) resistor r=10.4246 //w=0.131 //l=10.925 //layer=m2 \
 //thickness=0.36 //x=13.795 //y=2.4 //x2=2.87 //y2=2.4
r2143 (  127 184 ) resistor r=4.5 //w=0.15 //l=0.15 //layer=via1 //count=1 \
 //x=79.665 //y=2.41 //x2=79.665 //y2=2.41
r2144 (  124 268 ) resistor r=9.3 //w=0.17 //l=0.17 //layer=mcon //count=1 \
 //x=79.67 //y=2.26 //x2=79.67 //y2=2.26
r2145 (  122 273 ) resistor r=9.3 //w=0.17 //l=0.17 //layer=mcon //count=1 \
 //x=79.67 //y=4.88 //x2=79.67 //y2=4.88
r2146 (  120 182 ) resistor r=4.5 //w=0.15 //l=0.15 //layer=via1 //count=1 \
 //x=75.975 //y=2.405 //x2=75.975 //y2=2.405
r2147 (  117 258 ) resistor r=9.3 //w=0.17 //l=0.17 //layer=mcon //count=1 \
 //x=75.97 //y=2.26 //x2=75.97 //y2=2.26
r2148 (  115 263 ) resistor r=9.3 //w=0.17 //l=0.17 //layer=mcon //count=1 \
 //x=75.97 //y=4.88 //x2=75.97 //y2=4.88
r2149 (  111 248 ) resistor r=9.3 //w=0.17 //l=0.17 //layer=mcon //count=1 \
 //x=60.43 //y=2.26 //x2=60.43 //y2=2.26
r2150 (  109 253 ) resistor r=9.3 //w=0.17 //l=0.17 //layer=mcon //count=1 \
 //x=60.43 //y=4.88 //x2=60.43 //y2=4.88
r2151 (  107 178 ) resistor r=4.5 //w=0.15 //l=0.15 //layer=via1 //count=1 \
 //x=50.805 //y=2.41 //x2=50.805 //y2=2.41
r2152 (  104 238 ) resistor r=9.3 //w=0.17 //l=0.17 //layer=mcon //count=1 \
 //x=50.81 //y=2.26 //x2=50.81 //y2=2.26
r2153 (  102 243 ) resistor r=9.3 //w=0.17 //l=0.17 //layer=mcon //count=1 \
 //x=50.81 //y=4.88 //x2=50.81 //y2=4.88
r2154 (  100 176 ) resistor r=4.5 //w=0.15 //l=0.15 //layer=via1 //count=1 \
 //x=47.115 //y=2.405 //x2=47.115 //y2=2.405
r2155 (  97 228 ) resistor r=9.3 //w=0.17 //l=0.17 //layer=mcon //count=1 \
 //x=47.11 //y=2.26 //x2=47.11 //y2=2.26
r2156 (  95 233 ) resistor r=9.3 //w=0.17 //l=0.17 //layer=mcon //count=1 \
 //x=47.11 //y=4.88 //x2=47.11 //y2=4.88
r2157 (  91 218 ) resistor r=9.3 //w=0.17 //l=0.17 //layer=mcon //count=1 \
 //x=31.57 //y=2.26 //x2=31.57 //y2=2.26
r2158 (  89 223 ) resistor r=9.3 //w=0.17 //l=0.17 //layer=mcon //count=1 \
 //x=31.57 //y=4.88 //x2=31.57 //y2=4.88
r2159 (  87 172 ) resistor r=4.5 //w=0.15 //l=0.15 //layer=via1 //count=1 \
 //x=21.945 //y=2.41 //x2=21.945 //y2=2.41
r2160 (  84 208 ) resistor r=9.3 //w=0.17 //l=0.17 //layer=mcon //count=1 \
 //x=21.95 //y=2.26 //x2=21.95 //y2=2.26
r2161 (  82 213 ) resistor r=9.3 //w=0.17 //l=0.17 //layer=mcon //count=1 \
 //x=21.95 //y=4.88 //x2=21.95 //y2=4.88
r2162 (  80 170 ) resistor r=4.5 //w=0.15 //l=0.15 //layer=via1 //count=1 \
 //x=18.255 //y=2.405 //x2=18.255 //y2=2.405
r2163 (  77 198 ) resistor r=9.3 //w=0.17 //l=0.17 //layer=mcon //count=1 \
 //x=18.25 //y=2.26 //x2=18.25 //y2=2.26
r2164 (  75 203 ) resistor r=9.3 //w=0.17 //l=0.17 //layer=mcon //count=1 \
 //x=18.25 //y=4.88 //x2=18.25 //y2=4.88
r2165 (  71 188 ) resistor r=9.3 //w=0.17 //l=0.17 //layer=mcon //count=1 \
 //x=2.71 //y=2.26 //x2=2.71 //y2=2.26
r2166 (  69 193 ) resistor r=9.3 //w=0.17 //l=0.17 //layer=mcon //count=1 \
 //x=2.71 //y=4.88 //x2=2.71 //y2=4.88
r2167 (  65 122 ) resistor r=0.0717383 //w=0.224 //l=0.115 //layer=m1 \
 //thickness=0.36 //x=79.67 //y=4.765 //x2=79.67 //y2=4.88
r2168 (  64 127 ) resistor r=0.0902915 //w=0.287 //l=0.162481 //layer=m1 \
 //thickness=0.36 //x=79.67 //y=2.57 //x2=79.665 //y2=2.41
r2169 (  62 115 ) resistor r=0.0801089 //w=0.224 //l=0.13 //layer=m1 \
 //thickness=0.36 //x=75.97 //y=4.75 //x2=75.97 //y2=4.88
r2170 (  61 120 ) resistor r=0.0902915 //w=0.287 //l=0.162481 //layer=m1 \
 //thickness=0.36 //x=75.97 //y=2.565 //x2=75.975 //y2=2.405
r2171 (  57 109 ) resistor r=0.0717383 //w=0.224 //l=0.115 //layer=m1 \
 //thickness=0.36 //x=60.43 //y=4.765 //x2=60.43 //y2=4.88
r2172 (  53 102 ) resistor r=0.0717383 //w=0.224 //l=0.115 //layer=m1 \
 //thickness=0.36 //x=50.81 //y=4.765 //x2=50.81 //y2=4.88
r2173 (  52 107 ) resistor r=0.0902915 //w=0.287 //l=0.162481 //layer=m1 \
 //thickness=0.36 //x=50.81 //y=2.57 //x2=50.805 //y2=2.41
r2174 (  50 95 ) resistor r=0.0801089 //w=0.224 //l=0.13 //layer=m1 \
 //thickness=0.36 //x=47.11 //y=4.75 //x2=47.11 //y2=4.88
r2175 (  49 100 ) resistor r=0.0902915 //w=0.287 //l=0.162481 //layer=m1 \
 //thickness=0.36 //x=47.11 //y=2.565 //x2=47.115 //y2=2.405
r2176 (  45 89 ) resistor r=0.0717383 //w=0.224 //l=0.115 //layer=m1 \
 //thickness=0.36 //x=31.57 //y=4.765 //x2=31.57 //y2=4.88
r2177 (  41 82 ) resistor r=0.0717383 //w=0.224 //l=0.115 //layer=m1 \
 //thickness=0.36 //x=21.95 //y=4.765 //x2=21.95 //y2=4.88
r2178 (  40 87 ) resistor r=0.0902915 //w=0.287 //l=0.162481 //layer=m1 \
 //thickness=0.36 //x=21.95 //y=2.57 //x2=21.945 //y2=2.41
r2179 (  38 75 ) resistor r=0.0801089 //w=0.224 //l=0.13 //layer=m1 \
 //thickness=0.36 //x=18.25 //y=4.75 //x2=18.25 //y2=4.88
r2180 (  37 80 ) resistor r=0.0902915 //w=0.287 //l=0.162481 //layer=m1 \
 //thickness=0.36 //x=18.25 //y=2.565 //x2=18.255 //y2=2.405
r2181 (  31 69 ) resistor r=0.0717383 //w=0.224 //l=0.115 //layer=m1 \
 //thickness=0.36 //x=2.71 //y=4.765 //x2=2.71 //y2=4.88
r2182 (  29 127 ) resistor r=0.0043554 //w=0.287 //l=0.01 //layer=m1 \
 //thickness=0.36 //x=79.665 //y=2.4 //x2=79.665 //y2=2.41
r2183 (  29 124 ) resistor r=0.0609756 //w=0.287 //l=0.14 //layer=m1 \
 //thickness=0.36 //x=79.665 //y=2.4 //x2=79.665 //y2=2.26
r2184 (  28 120 ) resistor r=0.0021777 //w=0.287 //l=0.005 //layer=m1 \
 //thickness=0.36 //x=75.975 //y=2.4 //x2=75.975 //y2=2.405
r2185 (  28 117 ) resistor r=0.0609756 //w=0.287 //l=0.14 //layer=m1 \
 //thickness=0.36 //x=75.975 //y=2.4 //x2=75.975 //y2=2.26
r2186 (  27 180 ) resistor r=4.5 //w=0.15 //l=0.15 //layer=via1 //count=1 \
 //x=60.43 //y=2.4 //x2=60.43 //y2=2.4
r2187 (  27 56 ) resistor r=0.0902565 //w=0.288 //l=0.16 //layer=m1 \
 //thickness=0.36 //x=60.43 //y=2.4 //x2=60.43 //y2=2.56
r2188 (  27 111 ) resistor r=0.0607639 //w=0.288 //l=0.14 //layer=m1 \
 //thickness=0.36 //x=60.43 //y=2.4 //x2=60.43 //y2=2.26
r2189 (  26 107 ) resistor r=0.0043554 //w=0.287 //l=0.01 //layer=m1 \
 //thickness=0.36 //x=50.805 //y=2.4 //x2=50.805 //y2=2.41
r2190 (  26 104 ) resistor r=0.0609756 //w=0.287 //l=0.14 //layer=m1 \
 //thickness=0.36 //x=50.805 //y=2.4 //x2=50.805 //y2=2.26
r2191 (  25 100 ) resistor r=0.0021777 //w=0.287 //l=0.005 //layer=m1 \
 //thickness=0.36 //x=47.115 //y=2.4 //x2=47.115 //y2=2.405
r2192 (  25 97 ) resistor r=0.0609756 //w=0.287 //l=0.14 //layer=m1 \
 //thickness=0.36 //x=47.115 //y=2.4 //x2=47.115 //y2=2.26
r2193 (  24 174 ) resistor r=4.5 //w=0.15 //l=0.15 //layer=via1 //count=1 \
 //x=31.57 //y=2.4 //x2=31.57 //y2=2.4
r2194 (  24 44 ) resistor r=0.0902565 //w=0.288 //l=0.16 //layer=m1 \
 //thickness=0.36 //x=31.57 //y=2.4 //x2=31.57 //y2=2.56
r2195 (  24 91 ) resistor r=0.0607639 //w=0.288 //l=0.14 //layer=m1 \
 //thickness=0.36 //x=31.57 //y=2.4 //x2=31.57 //y2=2.26
r2196 (  23 87 ) resistor r=0.0043554 //w=0.287 //l=0.01 //layer=m1 \
 //thickness=0.36 //x=21.945 //y=2.4 //x2=21.945 //y2=2.41
r2197 (  23 84 ) resistor r=0.0609756 //w=0.287 //l=0.14 //layer=m1 \
 //thickness=0.36 //x=21.945 //y=2.4 //x2=21.945 //y2=2.26
r2198 (  22 80 ) resistor r=0.0021777 //w=0.287 //l=0.005 //layer=m1 \
 //thickness=0.36 //x=18.255 //y=2.4 //x2=18.255 //y2=2.405
r2199 (  22 77 ) resistor r=0.0609756 //w=0.287 //l=0.14 //layer=m1 \
 //thickness=0.36 //x=18.255 //y=2.4 //x2=18.255 //y2=2.26
r2200 (  21 167 ) resistor r=4.5 //w=0.15 //l=0.15 //layer=via1 //count=1 \
 //x=2.71 //y=2.4 //x2=2.71 //y2=2.4
r2201 (  21 30 ) resistor r=0.0902565 //w=0.288 //l=0.16 //layer=m1 \
 //thickness=0.36 //x=2.71 //y=2.4 //x2=2.71 //y2=2.56
r2202 (  21 71 ) resistor r=0.0607639 //w=0.288 //l=0.14 //layer=m1 \
 //thickness=0.36 //x=2.71 //y=2.4 //x2=2.71 //y2=2.26
r2203 (  20 65 ) resistor r=1.19752 //w=0.131 //l=1.255 //layer=m1 \
 //thickness=0.36 //x=79.67 //y=3.51 //x2=79.67 //y2=4.765
r2204 (  19 20 ) resistor r=0.706107 //w=0.131 //l=0.74 //layer=m1 \
 //thickness=0.36 //x=79.67 //y=2.77 //x2=79.67 //y2=3.51
r2205 (  19 64 ) resistor r=0.19084 //w=0.131 //l=0.2 //layer=m1 \
 //thickness=0.36 //x=79.67 //y=2.77 //x2=79.67 //y2=2.57
r2206 (  18 62 ) resistor r=1.88931 //w=0.131 //l=1.98 //layer=m1 \
 //thickness=0.36 //x=75.97 //y=2.77 //x2=75.97 //y2=4.75
r2207 (  18 61 ) resistor r=0.195611 //w=0.131 //l=0.205 //layer=m1 \
 //thickness=0.36 //x=75.97 //y=2.77 //x2=75.97 //y2=2.565
r2208 (  17 57 ) resistor r=0.491412 //w=0.131 //l=0.515 //layer=m1 \
 //thickness=0.36 //x=60.43 //y=4.25 //x2=60.43 //y2=4.765
r2209 (  16 17 ) resistor r=0.706107 //w=0.131 //l=0.74 //layer=m1 \
 //thickness=0.36 //x=60.43 //y=3.51 //x2=60.43 //y2=4.25
r2210 (  15 16 ) resistor r=0.706107 //w=0.131 //l=0.74 //layer=m1 \
 //thickness=0.36 //x=60.43 //y=2.77 //x2=60.43 //y2=3.51
r2211 (  15 56 ) resistor r=0.200382 //w=0.131 //l=0.21 //layer=m1 \
 //thickness=0.36 //x=60.43 //y=2.77 //x2=60.43 //y2=2.56
r2212 (  14 53 ) resistor r=1.19752 //w=0.131 //l=1.255 //layer=m1 \
 //thickness=0.36 //x=50.81 //y=3.51 //x2=50.81 //y2=4.765
r2213 (  13 14 ) resistor r=0.706107 //w=0.131 //l=0.74 //layer=m1 \
 //thickness=0.36 //x=50.81 //y=2.77 //x2=50.81 //y2=3.51
r2214 (  13 52 ) resistor r=0.19084 //w=0.131 //l=0.2 //layer=m1 \
 //thickness=0.36 //x=50.81 //y=2.77 //x2=50.81 //y2=2.57
r2215 (  12 50 ) resistor r=1.88931 //w=0.131 //l=1.98 //layer=m1 \
 //thickness=0.36 //x=47.11 //y=2.77 //x2=47.11 //y2=4.75
r2216 (  12 49 ) resistor r=0.195611 //w=0.131 //l=0.205 //layer=m1 \
 //thickness=0.36 //x=47.11 //y=2.77 //x2=47.11 //y2=2.565
r2217 (  11 45 ) resistor r=0.844466 //w=0.131 //l=0.885 //layer=m1 \
 //thickness=0.36 //x=31.57 //y=3.88 //x2=31.57 //y2=4.765
r2218 (  10 11 ) resistor r=0.353053 //w=0.131 //l=0.37 //layer=m1 \
 //thickness=0.36 //x=31.57 //y=3.51 //x2=31.57 //y2=3.88
r2219 (  9 10 ) resistor r=0.706107 //w=0.131 //l=0.74 //layer=m1 \
 //thickness=0.36 //x=31.57 //y=2.77 //x2=31.57 //y2=3.51
r2220 (  9 44 ) resistor r=0.200382 //w=0.131 //l=0.21 //layer=m1 \
 //thickness=0.36 //x=31.57 //y=2.77 //x2=31.57 //y2=2.56
r2221 (  8 41 ) resistor r=1.19752 //w=0.131 //l=1.255 //layer=m1 \
 //thickness=0.36 //x=21.95 //y=3.51 //x2=21.95 //y2=4.765
r2222 (  7 8 ) resistor r=0.706107 //w=0.131 //l=0.74 //layer=m1 \
 //thickness=0.36 //x=21.95 //y=2.77 //x2=21.95 //y2=3.51
r2223 (  7 40 ) resistor r=0.19084 //w=0.131 //l=0.2 //layer=m1 \
 //thickness=0.36 //x=21.95 //y=2.77 //x2=21.95 //y2=2.57
r2224 (  6 38 ) resistor r=1.88931 //w=0.131 //l=1.98 //layer=m1 \
 //thickness=0.36 //x=18.25 //y=2.77 //x2=18.25 //y2=4.75
r2225 (  6 37 ) resistor r=0.195611 //w=0.131 //l=0.205 //layer=m1 \
 //thickness=0.36 //x=18.25 //y=2.77 //x2=18.25 //y2=2.565
r2226 (  5 31 ) resistor r=0.138359 //w=0.131 //l=0.145 //layer=m1 \
 //thickness=0.36 //x=2.71 //y=4.62 //x2=2.71 //y2=4.765
r2227 (  4 5 ) resistor r=0.706107 //w=0.131 //l=0.74 //layer=m1 \
 //thickness=0.36 //x=2.71 //y=3.88 //x2=2.71 //y2=4.62
r2228 (  3 4 ) resistor r=0.353053 //w=0.131 //l=0.37 //layer=m1 \
 //thickness=0.36 //x=2.71 //y=3.51 //x2=2.71 //y2=3.88
r2229 (  2 3 ) resistor r=0.353053 //w=0.131 //l=0.37 //layer=m1 \
 //thickness=0.36 //x=2.71 //y=3.14 //x2=2.71 //y2=3.51
r2230 (  1 2 ) resistor r=0.353053 //w=0.131 //l=0.37 //layer=m1 \
 //thickness=0.36 //x=2.71 //y=2.77 //x2=2.71 //y2=3.14
r2231 (  1 30 ) resistor r=0.200382 //w=0.131 //l=0.21 //layer=m1 \
 //thickness=0.36 //x=2.71 //y=2.77 //x2=2.71 //y2=2.56
ends PM_TMRDFFSNRNQNX1\%RN

subckt PM_TMRDFFSNRNQNX1\%SN ( 1 2 3 4 5 6 7 8 9 10 11 12 13 14 15 18 19 20 23 \
 24 25 28 29 30 31 32 33 34 37 38 39 40 41 42 84 91 93 95 97 99 101 103 105 \
 107 108 109 111 113 115 117 119 121 123 124 125 127 129 131 133 135 137 138 \
 139 141 143 145 147 149 151 153 154 155 157 159 161 166 167 172 180 189 194 \
 203 208 217 222 231 236 245 250 259 263 264 265 266 267 268 269 270 271 272 \
 273 274 275 276 277 278 279 280 281 282 283 285 291 292 293 294 295 300 301 \
 302 304 310 311 312 313 314 319 320 321 323 329 330 331 332 333 338 339 340 \
 342 348 349 350 351 352 357 358 359 361 367 368 369 370 371 376 377 378 380 \
 386 387 388 389 390 398 409 420 431 442 453 )
c1231 ( 453 0 ) capacitor c=0.0369044f //x=84.48 //y=4.88
c1232 ( 442 0 ) capacitor c=0.0369044f //x=70.05 //y=4.88
c1233 ( 431 0 ) capacitor c=0.0369044f //x=55.62 //y=4.88
c1234 ( 420 0 ) capacitor c=0.0369044f //x=41.19 //y=4.88
c1235 ( 409 0 ) capacitor c=0.0369628f //x=26.76 //y=4.88
c1236 ( 398 0 ) capacitor c=0.0369044f //x=12.33 //y=4.88
c1237 ( 390 0 ) capacitor c=0.0309248f //x=84.815 //y=4.97
c1238 ( 389 0 ) capacitor c=0.0819978f //x=84.57 //y=2.095
c1239 ( 388 0 ) capacitor c=0.0170266f //x=84.57 //y=1.63
c1240 ( 387 0 ) capacitor c=0.018609f //x=84.57 //y=1.4
c1241 ( 386 0 ) capacitor c=0.0186599f //x=84.57 //y=1.09
c1242 ( 380 0 ) capacitor c=0.0146988f //x=84.415 //y=1.555
c1243 ( 378 0 ) capacitor c=0.0148531f //x=84.415 //y=0.935
c1244 ( 377 0 ) capacitor c=0.0334406f //x=84.045 //y=1.4
c1245 ( 376 0 ) capacitor c=0.0173191f //x=84.045 //y=1.09
c1246 ( 371 0 ) capacitor c=0.0309248f //x=70.385 //y=4.97
c1247 ( 370 0 ) capacitor c=0.0818898f //x=70.14 //y=2.095
c1248 ( 369 0 ) capacitor c=0.0170266f //x=70.14 //y=1.63
c1249 ( 368 0 ) capacitor c=0.018609f //x=70.14 //y=1.4
c1250 ( 367 0 ) capacitor c=0.0186599f //x=70.14 //y=1.09
c1251 ( 361 0 ) capacitor c=0.0146988f //x=69.985 //y=1.555
c1252 ( 359 0 ) capacitor c=0.0148531f //x=69.985 //y=0.935
c1253 ( 358 0 ) capacitor c=0.0334406f //x=69.615 //y=1.4
c1254 ( 357 0 ) capacitor c=0.0173191f //x=69.615 //y=1.09
c1255 ( 352 0 ) capacitor c=0.0309248f //x=55.955 //y=4.97
c1256 ( 351 0 ) capacitor c=0.0819978f //x=55.71 //y=2.095
c1257 ( 350 0 ) capacitor c=0.0170266f //x=55.71 //y=1.63
c1258 ( 349 0 ) capacitor c=0.018609f //x=55.71 //y=1.4
c1259 ( 348 0 ) capacitor c=0.0186599f //x=55.71 //y=1.09
c1260 ( 342 0 ) capacitor c=0.0146988f //x=55.555 //y=1.555
c1261 ( 340 0 ) capacitor c=0.0148531f //x=55.555 //y=0.935
c1262 ( 339 0 ) capacitor c=0.0334406f //x=55.185 //y=1.4
c1263 ( 338 0 ) capacitor c=0.0173191f //x=55.185 //y=1.09
c1264 ( 333 0 ) capacitor c=0.0309248f //x=41.525 //y=4.97
c1265 ( 332 0 ) capacitor c=0.0818898f //x=41.28 //y=2.095
c1266 ( 331 0 ) capacitor c=0.0170266f //x=41.28 //y=1.63
c1267 ( 330 0 ) capacitor c=0.018609f //x=41.28 //y=1.4
c1268 ( 329 0 ) capacitor c=0.0186599f //x=41.28 //y=1.09
c1269 ( 323 0 ) capacitor c=0.0146988f //x=41.125 //y=1.555
c1270 ( 321 0 ) capacitor c=0.0148531f //x=41.125 //y=0.935
c1271 ( 320 0 ) capacitor c=0.0334406f //x=40.755 //y=1.4
c1272 ( 319 0 ) capacitor c=0.0173191f //x=40.755 //y=1.09
c1273 ( 314 0 ) capacitor c=0.0309248f //x=27.095 //y=4.97
c1274 ( 313 0 ) capacitor c=0.0819978f //x=26.85 //y=2.095
c1275 ( 312 0 ) capacitor c=0.0170266f //x=26.85 //y=1.63
c1276 ( 311 0 ) capacitor c=0.018609f //x=26.85 //y=1.4
c1277 ( 310 0 ) capacitor c=0.0186599f //x=26.85 //y=1.09
c1278 ( 304 0 ) capacitor c=0.0146988f //x=26.695 //y=1.555
c1279 ( 302 0 ) capacitor c=0.0148531f //x=26.695 //y=0.935
c1280 ( 301 0 ) capacitor c=0.0334406f //x=26.325 //y=1.4
c1281 ( 300 0 ) capacitor c=0.0173191f //x=26.325 //y=1.09
c1282 ( 295 0 ) capacitor c=0.0309248f //x=12.665 //y=4.97
c1283 ( 294 0 ) capacitor c=0.0818898f //x=12.42 //y=2.095
c1284 ( 293 0 ) capacitor c=0.0170266f //x=12.42 //y=1.63
c1285 ( 292 0 ) capacitor c=0.018609f //x=12.42 //y=1.4
c1286 ( 291 0 ) capacitor c=0.0186599f //x=12.42 //y=1.09
c1287 ( 285 0 ) capacitor c=0.0146988f //x=12.265 //y=1.555
c1288 ( 283 0 ) capacitor c=0.0148531f //x=12.265 //y=0.935
c1289 ( 282 0 ) capacitor c=0.0334406f //x=11.895 //y=1.4
c1290 ( 281 0 ) capacitor c=0.0173191f //x=11.895 //y=1.09
c1291 ( 280 0 ) capacitor c=0.110208f //x=84.89 //y=6.2
c1292 ( 279 0 ) capacitor c=0.110214f //x=84.45 //y=6.2
c1293 ( 278 0 ) capacitor c=0.110208f //x=70.46 //y=6.2
c1294 ( 277 0 ) capacitor c=0.110214f //x=70.02 //y=6.2
c1295 ( 276 0 ) capacitor c=0.110208f //x=56.03 //y=6.2
c1296 ( 275 0 ) capacitor c=0.110214f //x=55.59 //y=6.2
c1297 ( 274 0 ) capacitor c=0.110218f //x=41.6 //y=6.2
c1298 ( 273 0 ) capacitor c=0.110225f //x=41.16 //y=6.2
c1299 ( 272 0 ) capacitor c=0.110208f //x=27.17 //y=6.2
c1300 ( 271 0 ) capacitor c=0.110214f //x=26.73 //y=6.2
c1301 ( 270 0 ) capacitor c=0.110208f //x=12.74 //y=6.2
c1302 ( 269 0 ) capacitor c=0.110214f //x=12.3 //y=6.2
c1303 ( 259 0 ) capacitor c=0.00129935f //x=84.48 //y=4.88
c1304 ( 250 0 ) capacitor c=9.49278e-19 //x=84.48 //y=2.26
c1305 ( 245 0 ) capacitor c=0.00129935f //x=70.05 //y=4.88
c1306 ( 236 0 ) capacitor c=9.49278e-19 //x=70.05 //y=2.26
c1307 ( 231 0 ) capacitor c=0.00129935f //x=55.62 //y=4.88
c1308 ( 222 0 ) capacitor c=9.49278e-19 //x=55.62 //y=2.26
c1309 ( 217 0 ) capacitor c=0.00129935f //x=41.19 //y=4.88
c1310 ( 208 0 ) capacitor c=9.49278e-19 //x=41.19 //y=2.26
c1311 ( 203 0 ) capacitor c=0.00129935f //x=26.76 //y=4.88
c1312 ( 194 0 ) capacitor c=9.49278e-19 //x=26.76 //y=2.26
c1313 ( 189 0 ) capacitor c=0.00129935f //x=12.33 //y=4.88
c1314 ( 180 0 ) capacitor c=9.49278e-19 //x=12.33 //y=2.26
c1315 ( 172 0 ) capacitor c=0.00163887f //x=52.955 //y=3.125
c1316 ( 167 0 ) capacitor c=0.00100396f //x=23.36 //y=3.132
c1317 ( 166 0 ) capacitor c=4.39244e-19 //x=12.49 //y=3.125
c1318 ( 161 0 ) capacitor c=0.0846858f //x=78.77 //y=3.125
c1319 ( 159 0 ) capacitor c=0.0514333f //x=78.17 //y=3.14
c1320 ( 157 0 ) capacitor c=0.00433851f //x=73.975 //y=3.155
c1321 ( 155 0 ) capacitor c=0.0179685f //x=73.375 //y=3.14
c1322 ( 154 0 ) capacitor c=0.0246231f //x=71.77 //y=3.155
c1323 ( 153 0 ) capacitor c=0.00413636f //x=72.115 //y=3.155
c1324 ( 151 0 ) capacitor c=0.00190549f //x=69.155 //y=3.17
c1325 ( 149 0 ) capacitor c=0.0169637f //x=68.555 //y=3.14
c1326 ( 147 0 ) capacitor c=0.0064451f //x=67.305 //y=3.11
c1327 ( 145 0 ) capacitor c=0.0208173f //x=66.705 //y=3.14
c1328 ( 143 0 ) capacitor c=0.00389089f //x=64.35 //y=3.17
c1329 ( 141 0 ) capacitor c=0.0184994f //x=63.75 //y=3.14
c1330 ( 139 0 ) capacitor c=0.00429578f //x=62.5 //y=3.17
c1331 ( 138 0 ) capacitor c=0.0730028f //x=61.335 //y=3.13
c1332 ( 137 0 ) capacitor c=0.00739569f //x=61.765 //y=3.13
c1333 ( 135 0 ) capacitor c=0.0270434f //x=55.46 //y=3.14
c1334 ( 133 0 ) capacitor c=0.00209667f //x=52.855 //y=3.125
c1335 ( 131 0 ) capacitor c=0.033529f //x=49.91 //y=3.125
c1336 ( 129 0 ) capacitor c=0.0514333f //x=49.31 //y=3.14
c1337 ( 127 0 ) capacitor c=0.00433851f //x=45.115 //y=3.155
c1338 ( 125 0 ) capacitor c=0.0179685f //x=44.515 //y=3.14
c1339 ( 124 0 ) capacitor c=0.0245537f //x=42.91 //y=3.155
c1340 ( 123 0 ) capacitor c=0.0040604f //x=43.255 //y=3.155
c1341 ( 121 0 ) capacitor c=0.00197356f //x=40.3 //y=3.17
c1342 ( 119 0 ) capacitor c=0.0168895f //x=39.695 //y=3.14
c1343 ( 117 0 ) capacitor c=0.0064507f //x=38.45 //y=3.11
c1344 ( 115 0 ) capacitor c=0.0207798f //x=37.845 //y=3.14
c1345 ( 113 0 ) capacitor c=0.00383048f //x=35.495 //y=3.17
c1346 ( 111 0 ) capacitor c=0.0184245f //x=34.89 //y=3.14
c1347 ( 109 0 ) capacitor c=0.0043698f //x=33.645 //y=3.17
c1348 ( 108 0 ) capacitor c=0.0817674f //x=32.475 //y=3.13
c1349 ( 107 0 ) capacitor c=0.00738888f //x=32.91 //y=3.13
c1350 ( 105 0 ) capacitor c=0.0342925f //x=26.6 //y=3.14
c1351 ( 103 0 ) capacitor c=0.0026996f //x=23.268 //y=3.132
c1352 ( 101 0 ) capacitor c=0.0270168f //x=21.05 //y=3.125
c1353 ( 99 0 ) capacitor c=0.0514333f //x=20.45 //y=3.14
c1354 ( 97 0 ) capacitor c=0.00433851f //x=16.255 //y=3.155
c1355 ( 95 0 ) capacitor c=0.0179685f //x=15.655 //y=3.14
c1356 ( 93 0 ) capacitor c=0.00413636f //x=14.395 //y=3.155
c1357 ( 91 0 ) capacitor c=0.0151172f //x=13.795 //y=3.14
c1358 ( 84 0 ) capacitor c=0.015039f //x=84.48 //y=3.14
c1359 ( 42 0 ) capacitor c=0.0415911f //x=84.48 //y=4.765
c1360 ( 41 0 ) capacitor c=0.012684f //x=84.48 //y=3.305
c1361 ( 40 0 ) capacitor c=0.013527f //x=84.48 //y=2.985
c1362 ( 39 0 ) capacitor c=0.00378284f //x=84.48 //y=2.375
c1363 ( 38 0 ) capacitor c=0.0388559f //x=70.05 //y=4.765
c1364 ( 37 0 ) capacitor c=0.0130261f //x=70.05 //y=3.285
c1365 ( 34 0 ) capacitor c=0.00380207f //x=70.05 //y=2.375
c1366 ( 33 0 ) capacitor c=0.0369297f //x=55.62 //y=4.765
c1367 ( 32 0 ) capacitor c=0.0126498f //x=55.62 //y=3.305
c1368 ( 31 0 ) capacitor c=0.0138904f //x=55.62 //y=2.985
c1369 ( 30 0 ) capacitor c=0.00380207f //x=55.62 //y=2.375
c1370 ( 29 0 ) capacitor c=0.0437064f //x=41.19 //y=4.765
c1371 ( 28 0 ) capacitor c=0.013026f //x=41.19 //y=3.285
c1372 ( 25 0 ) capacitor c=0.00380207f //x=41.19 //y=2.375
c1373 ( 24 0 ) capacitor c=0.0377629f //x=26.76 //y=4.765
c1374 ( 23 0 ) capacitor c=0.0125032f //x=26.76 //y=3.305
c1375 ( 20 0 ) capacitor c=0.00380207f //x=26.76 //y=2.375
c1376 ( 19 0 ) capacitor c=0.0388559f //x=12.33 //y=4.765
c1377 ( 18 0 ) capacitor c=0.0127247f //x=12.33 //y=3.285
c1378 ( 15 0 ) capacitor c=0.00380207f //x=12.33 //y=2.375
c1379 ( 14 0 ) capacitor c=0.00484457f //x=84.48 //y=4.88
c1380 ( 13 0 ) capacitor c=0.00485051f //x=70.05 //y=4.88
c1381 ( 12 0 ) capacitor c=0.015039f //x=70.05 //y=3.14
c1382 ( 11 0 ) capacitor c=0.00484457f //x=55.62 //y=4.88
c1383 ( 10 0 ) capacitor c=0.015039f //x=55.62 //y=3.14
c1384 ( 9 0 ) capacitor c=0.015039f //x=41.19 //y=3.14
c1385 ( 8 0 ) capacitor c=0.00274953f //x=26.76 //y=4.88
c1386 ( 7 0 ) capacitor c=0.015039f //x=26.76 //y=3.14
c1387 ( 6 0 ) capacitor c=0.00485051f //x=12.33 //y=4.88
c1388 ( 5 0 ) capacitor c=0.015039f //x=12.33 //y=3.14
c1389 ( 4 0 ) capacitor c=0.0114361f //x=70.05 //y=2.77
c1390 ( 3 0 ) capacitor c=0.0114361f //x=41.19 //y=2.77
c1391 ( 2 0 ) capacitor c=0.0136895f //x=26.76 //y=2.77
c1392 ( 1 0 ) capacitor c=0.0114361f //x=12.33 //y=2.77
r1393 (  455 456 ) resistor r=32.4568 //w=0.214 //l=0.075 //layer=ply \
 //thickness=0.18 //x=84.48 //y=4.97 //x2=84.48 //y2=5.045
r1394 (  453 455 ) resistor r=20.271 //w=0.214 //l=0.09 //layer=ply \
 //thickness=0.18 //x=84.48 //y=4.88 //x2=84.48 //y2=4.97
r1395 (  444 445 ) resistor r=32.4568 //w=0.214 //l=0.075 //layer=ply \
 //thickness=0.18 //x=70.05 //y=4.97 //x2=70.05 //y2=5.045
r1396 (  442 444 ) resistor r=20.271 //w=0.214 //l=0.09 //layer=ply \
 //thickness=0.18 //x=70.05 //y=4.88 //x2=70.05 //y2=4.97
r1397 (  433 434 ) resistor r=32.4568 //w=0.214 //l=0.075 //layer=ply \
 //thickness=0.18 //x=55.62 //y=4.97 //x2=55.62 //y2=5.045
r1398 (  431 433 ) resistor r=20.271 //w=0.214 //l=0.09 //layer=ply \
 //thickness=0.18 //x=55.62 //y=4.88 //x2=55.62 //y2=4.97
r1399 (  422 423 ) resistor r=32.4568 //w=0.214 //l=0.075 //layer=ply \
 //thickness=0.18 //x=41.19 //y=4.97 //x2=41.19 //y2=5.045
r1400 (  420 422 ) resistor r=20.271 //w=0.214 //l=0.09 //layer=ply \
 //thickness=0.18 //x=41.19 //y=4.88 //x2=41.19 //y2=4.97
r1401 (  411 412 ) resistor r=32.4568 //w=0.214 //l=0.075 //layer=ply \
 //thickness=0.18 //x=26.76 //y=4.97 //x2=26.76 //y2=5.045
r1402 (  409 411 ) resistor r=20.271 //w=0.214 //l=0.09 //layer=ply \
 //thickness=0.18 //x=26.76 //y=4.88 //x2=26.76 //y2=4.97
r1403 (  400 401 ) resistor r=32.4568 //w=0.214 //l=0.075 //layer=ply \
 //thickness=0.18 //x=12.33 //y=4.97 //x2=12.33 //y2=5.045
r1404 (  398 400 ) resistor r=20.271 //w=0.214 //l=0.09 //layer=ply \
 //thickness=0.18 //x=12.33 //y=4.88 //x2=12.33 //y2=4.97
r1405 (  391 455 ) resistor r=16.5046 //w=0.27 //l=0.135 //layer=ply \
 //thickness=0.18 //x=84.615 //y=4.97 //x2=84.48 //y2=4.97
r1406 (  390 392 ) resistor r=26.9307 //w=0.15 //l=0.106066 //layer=ply \
 //thickness=0.18 //x=84.815 //y=4.97 //x2=84.89 //y2=5.045
r1407 (  390 391 ) resistor r=102.553 //w=0.094 //l=0.2 //layer=ply \
 //thickness=0.18 //x=84.815 //y=4.97 //x2=84.615 //y2=4.97
r1408 (  389 460 ) resistor r=38.6777 //w=0.284 //l=0.198997 //layer=ply \
 //thickness=0.18 //x=84.57 //y=2.095 //x2=84.495 //y2=2.26
r1409 (  388 458 ) resistor r=21.2976 //w=0.217 //l=0.0928709 //layer=ply \
 //thickness=0.18 //x=84.57 //y=1.63 //x2=84.53 //y2=1.555
r1410 (  388 389 ) resistor r=238.436 //w=0.094 //l=0.465 //layer=ply \
 //thickness=0.18 //x=84.57 //y=1.63 //x2=84.57 //y2=2.095
r1411 (  387 458 ) resistor r=39.0671 //w=0.217 //l=0.173853 //layer=ply \
 //thickness=0.18 //x=84.57 //y=1.4 //x2=84.53 //y2=1.555
r1412 (  386 457 ) resistor r=45.1352 //w=0.168 //l=0.173853 //layer=ply \
 //thickness=0.18 //x=84.57 //y=1.09 //x2=84.53 //y2=0.935
r1413 (  386 387 ) resistor r=158.957 //w=0.094 //l=0.31 //layer=ply \
 //thickness=0.18 //x=84.57 //y=1.09 //x2=84.57 //y2=1.4
r1414 (  381 451 ) resistor r=5.52526 //w=0.168 //l=0.115 //layer=ply \
 //thickness=0.18 //x=84.2 //y=1.555 //x2=84.085 //y2=1.555
r1415 (  380 458 ) resistor r=11.4558 //w=0.217 //l=0.115 //layer=ply \
 //thickness=0.18 //x=84.415 //y=1.555 //x2=84.53 //y2=1.555
r1416 (  379 450 ) resistor r=5.52526 //w=0.168 //l=0.115 //layer=ply \
 //thickness=0.18 //x=84.2 //y=0.935 //x2=84.085 //y2=0.935
r1417 (  378 457 ) resistor r=5.52526 //w=0.168 //l=0.115 //layer=ply \
 //thickness=0.18 //x=84.415 //y=0.935 //x2=84.53 //y2=0.935
r1418 (  378 379 ) resistor r=110.245 //w=0.094 //l=0.215 //layer=ply \
 //thickness=0.18 //x=84.415 //y=0.935 //x2=84.2 //y2=0.935
r1419 (  377 451 ) resistor r=45.1352 //w=0.168 //l=0.173853 //layer=ply \
 //thickness=0.18 //x=84.045 //y=1.4 //x2=84.085 //y2=1.555
r1420 (  376 450 ) resistor r=45.1352 //w=0.168 //l=0.173853 //layer=ply \
 //thickness=0.18 //x=84.045 //y=1.09 //x2=84.085 //y2=0.935
r1421 (  376 377 ) resistor r=158.957 //w=0.094 //l=0.31 //layer=ply \
 //thickness=0.18 //x=84.045 //y=1.09 //x2=84.045 //y2=1.4
r1422 (  372 444 ) resistor r=16.5046 //w=0.27 //l=0.135 //layer=ply \
 //thickness=0.18 //x=70.185 //y=4.97 //x2=70.05 //y2=4.97
r1423 (  371 373 ) resistor r=26.9307 //w=0.15 //l=0.106066 //layer=ply \
 //thickness=0.18 //x=70.385 //y=4.97 //x2=70.46 //y2=5.045
r1424 (  371 372 ) resistor r=102.553 //w=0.094 //l=0.2 //layer=ply \
 //thickness=0.18 //x=70.385 //y=4.97 //x2=70.185 //y2=4.97
r1425 (  370 449 ) resistor r=38.6777 //w=0.284 //l=0.198997 //layer=ply \
 //thickness=0.18 //x=70.14 //y=2.095 //x2=70.065 //y2=2.26
r1426 (  369 447 ) resistor r=21.2976 //w=0.217 //l=0.0928709 //layer=ply \
 //thickness=0.18 //x=70.14 //y=1.63 //x2=70.1 //y2=1.555
r1427 (  369 370 ) resistor r=238.436 //w=0.094 //l=0.465 //layer=ply \
 //thickness=0.18 //x=70.14 //y=1.63 //x2=70.14 //y2=2.095
r1428 (  368 447 ) resistor r=39.0671 //w=0.217 //l=0.173853 //layer=ply \
 //thickness=0.18 //x=70.14 //y=1.4 //x2=70.1 //y2=1.555
r1429 (  367 446 ) resistor r=45.1352 //w=0.168 //l=0.173853 //layer=ply \
 //thickness=0.18 //x=70.14 //y=1.09 //x2=70.1 //y2=0.935
r1430 (  367 368 ) resistor r=158.957 //w=0.094 //l=0.31 //layer=ply \
 //thickness=0.18 //x=70.14 //y=1.09 //x2=70.14 //y2=1.4
r1431 (  362 440 ) resistor r=5.52526 //w=0.168 //l=0.115 //layer=ply \
 //thickness=0.18 //x=69.77 //y=1.555 //x2=69.655 //y2=1.555
r1432 (  361 447 ) resistor r=11.4558 //w=0.217 //l=0.115 //layer=ply \
 //thickness=0.18 //x=69.985 //y=1.555 //x2=70.1 //y2=1.555
r1433 (  360 439 ) resistor r=5.52526 //w=0.168 //l=0.115 //layer=ply \
 //thickness=0.18 //x=69.77 //y=0.935 //x2=69.655 //y2=0.935
r1434 (  359 446 ) resistor r=5.52526 //w=0.168 //l=0.115 //layer=ply \
 //thickness=0.18 //x=69.985 //y=0.935 //x2=70.1 //y2=0.935
r1435 (  359 360 ) resistor r=110.245 //w=0.094 //l=0.215 //layer=ply \
 //thickness=0.18 //x=69.985 //y=0.935 //x2=69.77 //y2=0.935
r1436 (  358 440 ) resistor r=45.1352 //w=0.168 //l=0.173853 //layer=ply \
 //thickness=0.18 //x=69.615 //y=1.4 //x2=69.655 //y2=1.555
r1437 (  357 439 ) resistor r=45.1352 //w=0.168 //l=0.173853 //layer=ply \
 //thickness=0.18 //x=69.615 //y=1.09 //x2=69.655 //y2=0.935
r1438 (  357 358 ) resistor r=158.957 //w=0.094 //l=0.31 //layer=ply \
 //thickness=0.18 //x=69.615 //y=1.09 //x2=69.615 //y2=1.4
r1439 (  353 433 ) resistor r=16.5046 //w=0.27 //l=0.135 //layer=ply \
 //thickness=0.18 //x=55.755 //y=4.97 //x2=55.62 //y2=4.97
r1440 (  352 354 ) resistor r=26.9307 //w=0.15 //l=0.106066 //layer=ply \
 //thickness=0.18 //x=55.955 //y=4.97 //x2=56.03 //y2=5.045
r1441 (  352 353 ) resistor r=102.553 //w=0.094 //l=0.2 //layer=ply \
 //thickness=0.18 //x=55.955 //y=4.97 //x2=55.755 //y2=4.97
r1442 (  351 438 ) resistor r=38.6777 //w=0.284 //l=0.198997 //layer=ply \
 //thickness=0.18 //x=55.71 //y=2.095 //x2=55.635 //y2=2.26
r1443 (  350 436 ) resistor r=21.2976 //w=0.217 //l=0.0928709 //layer=ply \
 //thickness=0.18 //x=55.71 //y=1.63 //x2=55.67 //y2=1.555
r1444 (  350 351 ) resistor r=238.436 //w=0.094 //l=0.465 //layer=ply \
 //thickness=0.18 //x=55.71 //y=1.63 //x2=55.71 //y2=2.095
r1445 (  349 436 ) resistor r=39.0671 //w=0.217 //l=0.173853 //layer=ply \
 //thickness=0.18 //x=55.71 //y=1.4 //x2=55.67 //y2=1.555
r1446 (  348 435 ) resistor r=45.1352 //w=0.168 //l=0.173853 //layer=ply \
 //thickness=0.18 //x=55.71 //y=1.09 //x2=55.67 //y2=0.935
r1447 (  348 349 ) resistor r=158.957 //w=0.094 //l=0.31 //layer=ply \
 //thickness=0.18 //x=55.71 //y=1.09 //x2=55.71 //y2=1.4
r1448 (  343 429 ) resistor r=5.52526 //w=0.168 //l=0.115 //layer=ply \
 //thickness=0.18 //x=55.34 //y=1.555 //x2=55.225 //y2=1.555
r1449 (  342 436 ) resistor r=11.4558 //w=0.217 //l=0.115 //layer=ply \
 //thickness=0.18 //x=55.555 //y=1.555 //x2=55.67 //y2=1.555
r1450 (  341 428 ) resistor r=5.52526 //w=0.168 //l=0.115 //layer=ply \
 //thickness=0.18 //x=55.34 //y=0.935 //x2=55.225 //y2=0.935
r1451 (  340 435 ) resistor r=5.52526 //w=0.168 //l=0.115 //layer=ply \
 //thickness=0.18 //x=55.555 //y=0.935 //x2=55.67 //y2=0.935
r1452 (  340 341 ) resistor r=110.245 //w=0.094 //l=0.215 //layer=ply \
 //thickness=0.18 //x=55.555 //y=0.935 //x2=55.34 //y2=0.935
r1453 (  339 429 ) resistor r=45.1352 //w=0.168 //l=0.173853 //layer=ply \
 //thickness=0.18 //x=55.185 //y=1.4 //x2=55.225 //y2=1.555
r1454 (  338 428 ) resistor r=45.1352 //w=0.168 //l=0.173853 //layer=ply \
 //thickness=0.18 //x=55.185 //y=1.09 //x2=55.225 //y2=0.935
r1455 (  338 339 ) resistor r=158.957 //w=0.094 //l=0.31 //layer=ply \
 //thickness=0.18 //x=55.185 //y=1.09 //x2=55.185 //y2=1.4
r1456 (  334 422 ) resistor r=16.5046 //w=0.27 //l=0.135 //layer=ply \
 //thickness=0.18 //x=41.325 //y=4.97 //x2=41.19 //y2=4.97
r1457 (  333 335 ) resistor r=26.9307 //w=0.15 //l=0.106066 //layer=ply \
 //thickness=0.18 //x=41.525 //y=4.97 //x2=41.6 //y2=5.045
r1458 (  333 334 ) resistor r=102.553 //w=0.094 //l=0.2 //layer=ply \
 //thickness=0.18 //x=41.525 //y=4.97 //x2=41.325 //y2=4.97
r1459 (  332 427 ) resistor r=38.6777 //w=0.284 //l=0.198997 //layer=ply \
 //thickness=0.18 //x=41.28 //y=2.095 //x2=41.205 //y2=2.26
r1460 (  331 425 ) resistor r=21.2976 //w=0.217 //l=0.0928709 //layer=ply \
 //thickness=0.18 //x=41.28 //y=1.63 //x2=41.24 //y2=1.555
r1461 (  331 332 ) resistor r=238.436 //w=0.094 //l=0.465 //layer=ply \
 //thickness=0.18 //x=41.28 //y=1.63 //x2=41.28 //y2=2.095
r1462 (  330 425 ) resistor r=39.0671 //w=0.217 //l=0.173853 //layer=ply \
 //thickness=0.18 //x=41.28 //y=1.4 //x2=41.24 //y2=1.555
r1463 (  329 424 ) resistor r=45.1352 //w=0.168 //l=0.173853 //layer=ply \
 //thickness=0.18 //x=41.28 //y=1.09 //x2=41.24 //y2=0.935
r1464 (  329 330 ) resistor r=158.957 //w=0.094 //l=0.31 //layer=ply \
 //thickness=0.18 //x=41.28 //y=1.09 //x2=41.28 //y2=1.4
r1465 (  324 418 ) resistor r=5.52526 //w=0.168 //l=0.115 //layer=ply \
 //thickness=0.18 //x=40.91 //y=1.555 //x2=40.795 //y2=1.555
r1466 (  323 425 ) resistor r=11.4558 //w=0.217 //l=0.115 //layer=ply \
 //thickness=0.18 //x=41.125 //y=1.555 //x2=41.24 //y2=1.555
r1467 (  322 417 ) resistor r=5.52526 //w=0.168 //l=0.115 //layer=ply \
 //thickness=0.18 //x=40.91 //y=0.935 //x2=40.795 //y2=0.935
r1468 (  321 424 ) resistor r=5.52526 //w=0.168 //l=0.115 //layer=ply \
 //thickness=0.18 //x=41.125 //y=0.935 //x2=41.24 //y2=0.935
r1469 (  321 322 ) resistor r=110.245 //w=0.094 //l=0.215 //layer=ply \
 //thickness=0.18 //x=41.125 //y=0.935 //x2=40.91 //y2=0.935
r1470 (  320 418 ) resistor r=45.1352 //w=0.168 //l=0.173853 //layer=ply \
 //thickness=0.18 //x=40.755 //y=1.4 //x2=40.795 //y2=1.555
r1471 (  319 417 ) resistor r=45.1352 //w=0.168 //l=0.173853 //layer=ply \
 //thickness=0.18 //x=40.755 //y=1.09 //x2=40.795 //y2=0.935
r1472 (  319 320 ) resistor r=158.957 //w=0.094 //l=0.31 //layer=ply \
 //thickness=0.18 //x=40.755 //y=1.09 //x2=40.755 //y2=1.4
r1473 (  315 411 ) resistor r=16.5046 //w=0.27 //l=0.135 //layer=ply \
 //thickness=0.18 //x=26.895 //y=4.97 //x2=26.76 //y2=4.97
r1474 (  314 316 ) resistor r=26.9307 //w=0.15 //l=0.106066 //layer=ply \
 //thickness=0.18 //x=27.095 //y=4.97 //x2=27.17 //y2=5.045
r1475 (  314 315 ) resistor r=102.553 //w=0.094 //l=0.2 //layer=ply \
 //thickness=0.18 //x=27.095 //y=4.97 //x2=26.895 //y2=4.97
r1476 (  313 416 ) resistor r=38.6777 //w=0.284 //l=0.198997 //layer=ply \
 //thickness=0.18 //x=26.85 //y=2.095 //x2=26.775 //y2=2.26
r1477 (  312 414 ) resistor r=21.2976 //w=0.217 //l=0.0928709 //layer=ply \
 //thickness=0.18 //x=26.85 //y=1.63 //x2=26.81 //y2=1.555
r1478 (  312 313 ) resistor r=238.436 //w=0.094 //l=0.465 //layer=ply \
 //thickness=0.18 //x=26.85 //y=1.63 //x2=26.85 //y2=2.095
r1479 (  311 414 ) resistor r=39.0671 //w=0.217 //l=0.173853 //layer=ply \
 //thickness=0.18 //x=26.85 //y=1.4 //x2=26.81 //y2=1.555
r1480 (  310 413 ) resistor r=45.1352 //w=0.168 //l=0.173853 //layer=ply \
 //thickness=0.18 //x=26.85 //y=1.09 //x2=26.81 //y2=0.935
r1481 (  310 311 ) resistor r=158.957 //w=0.094 //l=0.31 //layer=ply \
 //thickness=0.18 //x=26.85 //y=1.09 //x2=26.85 //y2=1.4
r1482 (  305 407 ) resistor r=5.52526 //w=0.168 //l=0.115 //layer=ply \
 //thickness=0.18 //x=26.48 //y=1.555 //x2=26.365 //y2=1.555
r1483 (  304 414 ) resistor r=11.4558 //w=0.217 //l=0.115 //layer=ply \
 //thickness=0.18 //x=26.695 //y=1.555 //x2=26.81 //y2=1.555
r1484 (  303 406 ) resistor r=5.52526 //w=0.168 //l=0.115 //layer=ply \
 //thickness=0.18 //x=26.48 //y=0.935 //x2=26.365 //y2=0.935
r1485 (  302 413 ) resistor r=5.52526 //w=0.168 //l=0.115 //layer=ply \
 //thickness=0.18 //x=26.695 //y=0.935 //x2=26.81 //y2=0.935
r1486 (  302 303 ) resistor r=110.245 //w=0.094 //l=0.215 //layer=ply \
 //thickness=0.18 //x=26.695 //y=0.935 //x2=26.48 //y2=0.935
r1487 (  301 407 ) resistor r=45.1352 //w=0.168 //l=0.173853 //layer=ply \
 //thickness=0.18 //x=26.325 //y=1.4 //x2=26.365 //y2=1.555
r1488 (  300 406 ) resistor r=45.1352 //w=0.168 //l=0.173853 //layer=ply \
 //thickness=0.18 //x=26.325 //y=1.09 //x2=26.365 //y2=0.935
r1489 (  300 301 ) resistor r=158.957 //w=0.094 //l=0.31 //layer=ply \
 //thickness=0.18 //x=26.325 //y=1.09 //x2=26.325 //y2=1.4
r1490 (  296 400 ) resistor r=16.5046 //w=0.27 //l=0.135 //layer=ply \
 //thickness=0.18 //x=12.465 //y=4.97 //x2=12.33 //y2=4.97
r1491 (  295 297 ) resistor r=26.9307 //w=0.15 //l=0.106066 //layer=ply \
 //thickness=0.18 //x=12.665 //y=4.97 //x2=12.74 //y2=5.045
r1492 (  295 296 ) resistor r=102.553 //w=0.094 //l=0.2 //layer=ply \
 //thickness=0.18 //x=12.665 //y=4.97 //x2=12.465 //y2=4.97
r1493 (  294 405 ) resistor r=38.6777 //w=0.284 //l=0.198997 //layer=ply \
 //thickness=0.18 //x=12.42 //y=2.095 //x2=12.345 //y2=2.26
r1494 (  293 403 ) resistor r=21.2976 //w=0.217 //l=0.0928709 //layer=ply \
 //thickness=0.18 //x=12.42 //y=1.63 //x2=12.38 //y2=1.555
r1495 (  293 294 ) resistor r=238.436 //w=0.094 //l=0.465 //layer=ply \
 //thickness=0.18 //x=12.42 //y=1.63 //x2=12.42 //y2=2.095
r1496 (  292 403 ) resistor r=39.0671 //w=0.217 //l=0.173853 //layer=ply \
 //thickness=0.18 //x=12.42 //y=1.4 //x2=12.38 //y2=1.555
r1497 (  291 402 ) resistor r=45.1352 //w=0.168 //l=0.173853 //layer=ply \
 //thickness=0.18 //x=12.42 //y=1.09 //x2=12.38 //y2=0.935
r1498 (  291 292 ) resistor r=158.957 //w=0.094 //l=0.31 //layer=ply \
 //thickness=0.18 //x=12.42 //y=1.09 //x2=12.42 //y2=1.4
r1499 (  286 396 ) resistor r=5.52526 //w=0.168 //l=0.115 //layer=ply \
 //thickness=0.18 //x=12.05 //y=1.555 //x2=11.935 //y2=1.555
r1500 (  285 403 ) resistor r=11.4558 //w=0.217 //l=0.115 //layer=ply \
 //thickness=0.18 //x=12.265 //y=1.555 //x2=12.38 //y2=1.555
r1501 (  284 395 ) resistor r=5.52526 //w=0.168 //l=0.115 //layer=ply \
 //thickness=0.18 //x=12.05 //y=0.935 //x2=11.935 //y2=0.935
r1502 (  283 402 ) resistor r=5.52526 //w=0.168 //l=0.115 //layer=ply \
 //thickness=0.18 //x=12.265 //y=0.935 //x2=12.38 //y2=0.935
r1503 (  283 284 ) resistor r=110.245 //w=0.094 //l=0.215 //layer=ply \
 //thickness=0.18 //x=12.265 //y=0.935 //x2=12.05 //y2=0.935
r1504 (  282 396 ) resistor r=45.1352 //w=0.168 //l=0.173853 //layer=ply \
 //thickness=0.18 //x=11.895 //y=1.4 //x2=11.935 //y2=1.555
r1505 (  281 395 ) resistor r=45.1352 //w=0.168 //l=0.173853 //layer=ply \
 //thickness=0.18 //x=11.895 //y=1.09 //x2=11.935 //y2=0.935
r1506 (  281 282 ) resistor r=158.957 //w=0.094 //l=0.31 //layer=ply \
 //thickness=0.18 //x=11.895 //y=1.09 //x2=11.895 //y2=1.4
r1507 (  280 392 ) resistor r=592.245 //w=0.094 //l=1.155 //layer=ply \
 //thickness=0.18 //x=84.89 //y=6.2 //x2=84.89 //y2=5.045
r1508 (  279 456 ) resistor r=592.245 //w=0.094 //l=1.155 //layer=ply \
 //thickness=0.18 //x=84.45 //y=6.2 //x2=84.45 //y2=5.045
r1509 (  278 373 ) resistor r=592.245 //w=0.094 //l=1.155 //layer=ply \
 //thickness=0.18 //x=70.46 //y=6.2 //x2=70.46 //y2=5.045
r1510 (  277 445 ) resistor r=592.245 //w=0.094 //l=1.155 //layer=ply \
 //thickness=0.18 //x=70.02 //y=6.2 //x2=70.02 //y2=5.045
r1511 (  276 354 ) resistor r=592.245 //w=0.094 //l=1.155 //layer=ply \
 //thickness=0.18 //x=56.03 //y=6.2 //x2=56.03 //y2=5.045
r1512 (  275 434 ) resistor r=592.245 //w=0.094 //l=1.155 //layer=ply \
 //thickness=0.18 //x=55.59 //y=6.2 //x2=55.59 //y2=5.045
r1513 (  274 335 ) resistor r=592.245 //w=0.094 //l=1.155 //layer=ply \
 //thickness=0.18 //x=41.6 //y=6.2 //x2=41.6 //y2=5.045
r1514 (  273 423 ) resistor r=592.245 //w=0.094 //l=1.155 //layer=ply \
 //thickness=0.18 //x=41.16 //y=6.2 //x2=41.16 //y2=5.045
r1515 (  272 316 ) resistor r=592.245 //w=0.094 //l=1.155 //layer=ply \
 //thickness=0.18 //x=27.17 //y=6.2 //x2=27.17 //y2=5.045
r1516 (  271 412 ) resistor r=592.245 //w=0.094 //l=1.155 //layer=ply \
 //thickness=0.18 //x=26.73 //y=6.2 //x2=26.73 //y2=5.045
r1517 (  270 297 ) resistor r=592.245 //w=0.094 //l=1.155 //layer=ply \
 //thickness=0.18 //x=12.74 //y=6.2 //x2=12.74 //y2=5.045
r1518 (  269 401 ) resistor r=592.245 //w=0.094 //l=1.155 //layer=ply \
 //thickness=0.18 //x=12.3 //y=6.2 //x2=12.3 //y2=5.045
r1519 (  268 380 ) resistor r=55.3787 //w=0.094 //l=0.108 //layer=ply \
 //thickness=0.18 //x=84.307 //y=1.555 //x2=84.415 //y2=1.555
r1520 (  268 381 ) resistor r=54.866 //w=0.094 //l=0.107 //layer=ply \
 //thickness=0.18 //x=84.307 //y=1.555 //x2=84.2 //y2=1.555
r1521 (  267 361 ) resistor r=55.3787 //w=0.094 //l=0.108 //layer=ply \
 //thickness=0.18 //x=69.877 //y=1.555 //x2=69.985 //y2=1.555
r1522 (  267 362 ) resistor r=54.866 //w=0.094 //l=0.107 //layer=ply \
 //thickness=0.18 //x=69.877 //y=1.555 //x2=69.77 //y2=1.555
r1523 (  266 342 ) resistor r=55.3787 //w=0.094 //l=0.108 //layer=ply \
 //thickness=0.18 //x=55.447 //y=1.555 //x2=55.555 //y2=1.555
r1524 (  266 343 ) resistor r=54.866 //w=0.094 //l=0.107 //layer=ply \
 //thickness=0.18 //x=55.447 //y=1.555 //x2=55.34 //y2=1.555
r1525 (  265 323 ) resistor r=55.3787 //w=0.094 //l=0.108 //layer=ply \
 //thickness=0.18 //x=41.017 //y=1.555 //x2=41.125 //y2=1.555
r1526 (  265 324 ) resistor r=54.866 //w=0.094 //l=0.107 //layer=ply \
 //thickness=0.18 //x=41.017 //y=1.555 //x2=40.91 //y2=1.555
r1527 (  264 304 ) resistor r=55.3787 //w=0.094 //l=0.108 //layer=ply \
 //thickness=0.18 //x=26.587 //y=1.555 //x2=26.695 //y2=1.555
r1528 (  264 305 ) resistor r=54.866 //w=0.094 //l=0.107 //layer=ply \
 //thickness=0.18 //x=26.587 //y=1.555 //x2=26.48 //y2=1.555
r1529 (  263 285 ) resistor r=55.3787 //w=0.094 //l=0.108 //layer=ply \
 //thickness=0.18 //x=12.157 //y=1.555 //x2=12.265 //y2=1.555
r1530 (  263 286 ) resistor r=54.866 //w=0.094 //l=0.107 //layer=ply \
 //thickness=0.18 //x=12.157 //y=1.555 //x2=12.05 //y2=1.555
r1531 (  259 453 ) resistor r=152 //w=0.17 //l=0.17 //layer=licon //count=1 \
 //x=84.48 //y=4.88 //x2=84.48 //y2=4.88
r1532 (  250 460 ) resistor r=152 //w=0.17 //l=0.17 //layer=licon //count=1 \
 //x=84.48 //y=2.26 //x2=84.48 //y2=2.26
r1533 (  245 442 ) resistor r=152 //w=0.17 //l=0.17 //layer=licon //count=1 \
 //x=70.05 //y=4.88 //x2=70.05 //y2=4.88
r1534 (  236 449 ) resistor r=152 //w=0.17 //l=0.17 //layer=licon //count=1 \
 //x=70.05 //y=2.26 //x2=70.05 //y2=2.26
r1535 (  231 431 ) resistor r=152 //w=0.17 //l=0.17 //layer=licon //count=1 \
 //x=55.62 //y=4.88 //x2=55.62 //y2=4.88
r1536 (  222 438 ) resistor r=152 //w=0.17 //l=0.17 //layer=licon //count=1 \
 //x=55.62 //y=2.26 //x2=55.62 //y2=2.26
r1537 (  217 420 ) resistor r=152 //w=0.17 //l=0.17 //layer=licon //count=1 \
 //x=41.19 //y=4.88 //x2=41.19 //y2=4.88
r1538 (  208 427 ) resistor r=152 //w=0.17 //l=0.17 //layer=licon //count=1 \
 //x=41.19 //y=2.26 //x2=41.19 //y2=2.26
r1539 (  203 409 ) resistor r=152 //w=0.17 //l=0.17 //layer=licon //count=1 \
 //x=26.76 //y=4.88 //x2=26.76 //y2=4.88
r1540 (  194 416 ) resistor r=152 //w=0.17 //l=0.17 //layer=licon //count=1 \
 //x=26.76 //y=2.26 //x2=26.76 //y2=2.26
r1541 (  189 398 ) resistor r=152 //w=0.17 //l=0.17 //layer=licon //count=1 \
 //x=12.33 //y=4.88 //x2=12.33 //y2=4.88
r1542 (  180 405 ) resistor r=152 //w=0.17 //l=0.17 //layer=licon //count=1 \
 //x=12.33 //y=2.26 //x2=12.33 //y2=2.26
r1543 (  164 166 ) resistor r=0.10734 //w=0.281 //l=0.16 //layer=m2 \
 //thickness=0.36 //x=12.33 //y=3.125 //x2=12.49 //y2=3.125
r1544 (  161 178 ) resistor r=3.98787 //w=0.179 //l=5.71999 //layer=m2 \
 //thickness=0.36 //x=78.77 //y=3.125 //x2=84.48 //y2=3.145
r1545 (  161 162 ) resistor r=0.410305 //w=0.131 //l=0.43 //layer=m2 \
 //thickness=0.36 //x=78.77 //y=3.125 //x2=78.34 //y2=3.125
r1546 (  159 162 ) resistor r=0.125 //w=0.17 //l=0.177341 //layer=m2 \
 //thickness=0.36 //x=78.17 //y=3.14 //x2=78.34 //y2=3.125
r1547 (  159 160 ) resistor r=3.84065 //w=0.131 //l=4.025 //layer=m2 \
 //thickness=0.36 //x=78.17 //y=3.14 //x2=74.145 //y2=3.14
r1548 (  157 160 ) resistor r=0.125 //w=0.17 //l=0.177341 //layer=m2 \
 //thickness=0.36 //x=73.975 //y=3.155 //x2=74.145 //y2=3.14
r1549 (  157 158 ) resistor r=0.329198 //w=0.131 //l=0.345 //layer=m2 \
 //thickness=0.36 //x=73.975 //y=3.155 //x2=73.63 //y2=3.155
r1550 (  155 158 ) resistor r=0.1875 //w=0.17 //l=0.262393 //layer=m2 \
 //thickness=0.36 //x=73.375 //y=3.14 //x2=73.63 //y2=3.155
r1551 (  155 156 ) resistor r=1.04008 //w=0.131 //l=1.09 //layer=m2 \
 //thickness=0.36 //x=73.375 //y=3.14 //x2=72.285 //y2=3.14
r1552 (  154 176 ) resistor r=1.1391 //w=0.189 //l=1.73494 //layer=m2 \
 //thickness=0.36 //x=71.77 //y=3.155 //x2=70.05 //y2=3.125
r1553 (  153 156 ) resistor r=0.125 //w=0.17 //l=0.177341 //layer=m2 \
 //thickness=0.36 //x=72.115 //y=3.155 //x2=72.285 //y2=3.14
r1554 (  153 154 ) resistor r=0.329198 //w=0.131 //l=0.345 //layer=m2 \
 //thickness=0.36 //x=72.115 //y=3.155 //x2=71.77 //y2=3.155
r1555 (  151 176 ) resistor r=0.593468 //w=0.189 //l=0.917224 //layer=m2 \
 //thickness=0.36 //x=69.155 //y=3.17 //x2=70.05 //y2=3.125
r1556 (  151 152 ) resistor r=0.329198 //w=0.131 //l=0.345 //layer=m2 \
 //thickness=0.36 //x=69.155 //y=3.17 //x2=68.81 //y2=3.17
r1557 (  149 152 ) resistor r=0.1875 //w=0.17 //l=0.269583 //layer=m2 \
 //thickness=0.36 //x=68.555 //y=3.14 //x2=68.81 //y2=3.17
r1558 (  149 150 ) resistor r=0.949427 //w=0.131 //l=0.995 //layer=m2 \
 //thickness=0.36 //x=68.555 //y=3.14 //x2=67.56 //y2=3.14
r1559 (  147 150 ) resistor r=0.1875 //w=0.17 //l=0.269583 //layer=m2 \
 //thickness=0.36 //x=67.305 //y=3.11 //x2=67.56 //y2=3.14
r1560 (  147 148 ) resistor r=0.410305 //w=0.131 //l=0.43 //layer=m2 \
 //thickness=0.36 //x=67.305 //y=3.11 //x2=66.875 //y2=3.11
r1561 (  145 148 ) resistor r=0.125 //w=0.17 //l=0.184391 //layer=m2 \
 //thickness=0.36 //x=66.705 //y=3.14 //x2=66.875 //y2=3.11
r1562 (  145 146 ) resistor r=2.08492 //w=0.131 //l=2.185 //layer=m2 \
 //thickness=0.36 //x=66.705 //y=3.14 //x2=64.52 //y2=3.14
r1563 (  143 146 ) resistor r=0.125 //w=0.17 //l=0.184391 //layer=m2 \
 //thickness=0.36 //x=64.35 //y=3.17 //x2=64.52 //y2=3.14
r1564 (  143 144 ) resistor r=0.329198 //w=0.131 //l=0.345 //layer=m2 \
 //thickness=0.36 //x=64.35 //y=3.17 //x2=64.005 //y2=3.17
r1565 (  141 144 ) resistor r=0.1875 //w=0.17 //l=0.269583 //layer=m2 \
 //thickness=0.36 //x=63.75 //y=3.14 //x2=64.005 //y2=3.17
r1566 (  141 142 ) resistor r=1.03053 //w=0.131 //l=1.08 //layer=m2 \
 //thickness=0.36 //x=63.75 //y=3.14 //x2=62.67 //y2=3.14
r1567 (  139 142 ) resistor r=0.125 //w=0.17 //l=0.184391 //layer=m2 \
 //thickness=0.36 //x=62.5 //y=3.17 //x2=62.67 //y2=3.14
r1568 (  139 140 ) resistor r=0.329198 //w=0.131 //l=0.345 //layer=m2 \
 //thickness=0.36 //x=62.5 //y=3.17 //x2=62.155 //y2=3.17
r1569 (  138 174 ) resistor r=3.99136 //w=0.179 //l=5.7225 //layer=m2 \
 //thickness=0.36 //x=61.335 //y=3.13 //x2=55.62 //y2=3.145
r1570 (  137 140 ) resistor r=0.286765 //w=0.17 //l=0.409512 //layer=m2 \
 //thickness=0.36 //x=61.765 //y=3.13 //x2=62.155 //y2=3.17
r1571 (  137 138 ) resistor r=0.410305 //w=0.131 //l=0.43 //layer=m2 \
 //thickness=0.36 //x=61.765 //y=3.13 //x2=61.335 //y2=3.13
r1572 (  135 174 ) resistor r=0.112172 //w=0.179 //l=0.162481 //layer=m2 \
 //thickness=0.36 //x=55.46 //y=3.14 //x2=55.62 //y2=3.145
r1573 (  135 172 ) resistor r=2.39027 //w=0.131 //l=2.505 //layer=m2 \
 //thickness=0.36 //x=55.46 //y=3.14 //x2=52.955 //y2=3.14
r1574 (  133 172 ) resistor r=0.0824018 //w=0.161 //l=0.1 //layer=m2 \
 //thickness=0.36 //x=52.855 //y=3.125 //x2=52.955 //y2=3.125
r1575 (  133 134 ) resistor r=0.310559 //w=0.161 //l=0.4 //layer=m2 \
 //thickness=0.36 //x=52.855 //y=3.125 //x2=52.455 //y2=3.125
r1576 (  131 134 ) resistor r=1.84956 //w=0.172 //l=2.545 //layer=m2 \
 //thickness=0.36 //x=49.91 //y=3.125 //x2=52.455 //y2=3.125
r1577 (  131 132 ) resistor r=0.410305 //w=0.131 //l=0.43 //layer=m2 \
 //thickness=0.36 //x=49.91 //y=3.125 //x2=49.48 //y2=3.125
r1578 (  129 132 ) resistor r=0.125 //w=0.17 //l=0.177341 //layer=m2 \
 //thickness=0.36 //x=49.31 //y=3.14 //x2=49.48 //y2=3.125
r1579 (  129 130 ) resistor r=3.84065 //w=0.131 //l=4.025 //layer=m2 \
 //thickness=0.36 //x=49.31 //y=3.14 //x2=45.285 //y2=3.14
r1580 (  127 130 ) resistor r=0.125 //w=0.17 //l=0.177341 //layer=m2 \
 //thickness=0.36 //x=45.115 //y=3.155 //x2=45.285 //y2=3.14
r1581 (  127 128 ) resistor r=0.329198 //w=0.131 //l=0.345 //layer=m2 \
 //thickness=0.36 //x=45.115 //y=3.155 //x2=44.77 //y2=3.155
r1582 (  125 128 ) resistor r=0.1875 //w=0.17 //l=0.262393 //layer=m2 \
 //thickness=0.36 //x=44.515 //y=3.14 //x2=44.77 //y2=3.155
r1583 (  125 126 ) resistor r=1.04008 //w=0.131 //l=1.09 //layer=m2 \
 //thickness=0.36 //x=44.515 //y=3.14 //x2=43.425 //y2=3.14
r1584 (  124 171 ) resistor r=1.1391 //w=0.189 //l=1.73494 //layer=m2 \
 //thickness=0.36 //x=42.91 //y=3.155 //x2=41.19 //y2=3.125
r1585 (  123 126 ) resistor r=0.125 //w=0.17 //l=0.177341 //layer=m2 \
 //thickness=0.36 //x=43.255 //y=3.155 //x2=43.425 //y2=3.14
r1586 (  123 124 ) resistor r=0.329198 //w=0.131 //l=0.345 //layer=m2 \
 //thickness=0.36 //x=43.255 //y=3.155 //x2=42.91 //y2=3.155
r1587 (  121 171 ) resistor r=0.590161 //w=0.189 //l=0.912223 //layer=m2 \
 //thickness=0.36 //x=40.3 //y=3.17 //x2=41.19 //y2=3.125
r1588 (  121 122 ) resistor r=0.333969 //w=0.131 //l=0.35 //layer=m2 \
 //thickness=0.36 //x=40.3 //y=3.17 //x2=39.95 //y2=3.17
r1589 (  119 122 ) resistor r=0.1875 //w=0.17 //l=0.269583 //layer=m2 \
 //thickness=0.36 //x=39.695 //y=3.14 //x2=39.95 //y2=3.17
r1590 (  119 120 ) resistor r=0.944656 //w=0.131 //l=0.99 //layer=m2 \
 //thickness=0.36 //x=39.695 //y=3.14 //x2=38.705 //y2=3.14
r1591 (  117 120 ) resistor r=0.1875 //w=0.17 //l=0.269583 //layer=m2 \
 //thickness=0.36 //x=38.45 //y=3.11 //x2=38.705 //y2=3.14
r1592 (  117 118 ) resistor r=0.415076 //w=0.131 //l=0.435 //layer=m2 \
 //thickness=0.36 //x=38.45 //y=3.11 //x2=38.015 //y2=3.11
r1593 (  115 118 ) resistor r=0.125 //w=0.17 //l=0.184391 //layer=m2 \
 //thickness=0.36 //x=37.845 //y=3.14 //x2=38.015 //y2=3.11
r1594 (  115 116 ) resistor r=2.08015 //w=0.131 //l=2.18 //layer=m2 \
 //thickness=0.36 //x=37.845 //y=3.14 //x2=35.665 //y2=3.14
r1595 (  113 116 ) resistor r=0.125 //w=0.17 //l=0.184391 //layer=m2 \
 //thickness=0.36 //x=35.495 //y=3.17 //x2=35.665 //y2=3.14
r1596 (  113 114 ) resistor r=0.333969 //w=0.131 //l=0.35 //layer=m2 \
 //thickness=0.36 //x=35.495 //y=3.17 //x2=35.145 //y2=3.17
r1597 (  111 114 ) resistor r=0.1875 //w=0.17 //l=0.269583 //layer=m2 \
 //thickness=0.36 //x=34.89 //y=3.14 //x2=35.145 //y2=3.17
r1598 (  111 112 ) resistor r=1.02576 //w=0.131 //l=1.075 //layer=m2 \
 //thickness=0.36 //x=34.89 //y=3.14 //x2=33.815 //y2=3.14
r1599 (  109 112 ) resistor r=0.125 //w=0.17 //l=0.184391 //layer=m2 \
 //thickness=0.36 //x=33.645 //y=3.17 //x2=33.815 //y2=3.14
r1600 (  109 110 ) resistor r=0.333969 //w=0.131 //l=0.35 //layer=m2 \
 //thickness=0.36 //x=33.645 //y=3.17 //x2=33.295 //y2=3.17
r1601 (  108 169 ) resistor r=3.99136 //w=0.179 //l=5.7225 //layer=m2 \
 //thickness=0.36 //x=32.475 //y=3.13 //x2=26.76 //y2=3.145
r1602 (  107 110 ) resistor r=0.283088 //w=0.17 //l=0.404506 //layer=m2 \
 //thickness=0.36 //x=32.91 //y=3.13 //x2=33.295 //y2=3.17
r1603 (  107 108 ) resistor r=0.415076 //w=0.131 //l=0.435 //layer=m2 \
 //thickness=0.36 //x=32.91 //y=3.13 //x2=32.475 //y2=3.13
r1604 (  105 169 ) resistor r=0.112172 //w=0.179 //l=0.162481 //layer=m2 \
 //thickness=0.36 //x=26.6 //y=3.14 //x2=26.76 //y2=3.145
r1605 (  105 167 ) resistor r=3.0916 //w=0.131 //l=3.24 //layer=m2 \
 //thickness=0.36 //x=26.6 //y=3.14 //x2=23.36 //y2=3.14
r1606 (  103 167 ) resistor r=0.0803857 //w=0.146 //l=0.092 //layer=m2 \
 //thickness=0.36 //x=23.268 //y=3.132 //x2=23.36 //y2=3.132
r1607 (  103 104 ) resistor r=0.356164 //w=0.146 //l=0.416 //layer=m2 \
 //thickness=0.36 //x=23.268 //y=3.132 //x2=22.852 //y2=3.132
r1608 (  101 104 ) resistor r=1.31725 //w=0.171 //l=1.8055 //layer=m2 \
 //thickness=0.36 //x=21.05 //y=3.125 //x2=22.852 //y2=3.132
r1609 (  101 102 ) resistor r=0.410305 //w=0.131 //l=0.43 //layer=m2 \
 //thickness=0.36 //x=21.05 //y=3.125 //x2=20.62 //y2=3.125
r1610 (  99 102 ) resistor r=0.125 //w=0.17 //l=0.177341 //layer=m2 \
 //thickness=0.36 //x=20.45 //y=3.14 //x2=20.62 //y2=3.125
r1611 (  99 100 ) resistor r=3.84065 //w=0.131 //l=4.025 //layer=m2 \
 //thickness=0.36 //x=20.45 //y=3.14 //x2=16.425 //y2=3.14
r1612 (  97 100 ) resistor r=0.125 //w=0.17 //l=0.177341 //layer=m2 \
 //thickness=0.36 //x=16.255 //y=3.155 //x2=16.425 //y2=3.14
r1613 (  97 98 ) resistor r=0.329198 //w=0.131 //l=0.345 //layer=m2 \
 //thickness=0.36 //x=16.255 //y=3.155 //x2=15.91 //y2=3.155
r1614 (  95 98 ) resistor r=0.1875 //w=0.17 //l=0.262393 //layer=m2 \
 //thickness=0.36 //x=15.655 //y=3.14 //x2=15.91 //y2=3.155
r1615 (  95 96 ) resistor r=1.04008 //w=0.131 //l=1.09 //layer=m2 \
 //thickness=0.36 //x=15.655 //y=3.14 //x2=14.565 //y2=3.14
r1616 (  93 96 ) resistor r=0.125 //w=0.17 //l=0.177341 //layer=m2 \
 //thickness=0.36 //x=14.395 //y=3.155 //x2=14.565 //y2=3.14
r1617 (  93 94 ) resistor r=0.329198 //w=0.131 //l=0.345 //layer=m2 \
 //thickness=0.36 //x=14.395 //y=3.155 //x2=14.05 //y2=3.155
r1618 (  91 94 ) resistor r=0.1875 //w=0.17 //l=0.262393 //layer=m2 \
 //thickness=0.36 //x=13.795 //y=3.14 //x2=14.05 //y2=3.155
r1619 (  91 166 ) resistor r=1.24523 //w=0.131 //l=1.305 //layer=m2 \
 //thickness=0.36 //x=13.795 //y=3.14 //x2=12.49 //y2=3.14
r1620 (  88 250 ) resistor r=9.3 //w=0.17 //l=0.17 //layer=mcon //count=1 \
 //x=84.48 //y=2.26 //x2=84.48 //y2=2.26
r1621 (  86 178 ) resistor r=4.5 //w=0.15 //l=0.15 //layer=via1 //count=1 \
 //x=84.48 //y=3.145 //x2=84.48 //y2=3.145
r1622 (  84 86 ) resistor r=0.00166223 //w=0.376 //l=0.005 //layer=m1 \
 //thickness=0.36 //x=84.427 //y=3.14 //x2=84.427 //y2=3.145
r1623 (  80 176 ) resistor r=4.5 //w=0.15 //l=0.15 //layer=via1 //count=1 \
 //x=70.05 //y=3.125 //x2=70.05 //y2=3.125
r1624 (  76 236 ) resistor r=9.3 //w=0.17 //l=0.17 //layer=mcon //count=1 \
 //x=70.05 //y=2.26 //x2=70.05 //y2=2.26
r1625 (  72 222 ) resistor r=9.3 //w=0.17 //l=0.17 //layer=mcon //count=1 \
 //x=55.62 //y=2.26 //x2=55.62 //y2=2.26
r1626 (  70 174 ) resistor r=4.5 //w=0.15 //l=0.15 //layer=via1 //count=1 \
 //x=55.62 //y=3.145 //x2=55.62 //y2=3.145
r1627 (  64 171 ) resistor r=4.5 //w=0.15 //l=0.15 //layer=via1 //count=1 \
 //x=41.19 //y=3.125 //x2=41.19 //y2=3.125
r1628 (  62 217 ) resistor r=9.3 //w=0.17 //l=0.17 //layer=mcon //count=1 \
 //x=41.19 //y=4.88 //x2=41.19 //y2=4.88
r1629 (  60 208 ) resistor r=9.3 //w=0.17 //l=0.17 //layer=mcon //count=1 \
 //x=41.19 //y=2.26 //x2=41.19 //y2=2.26
r1630 (  56 194 ) resistor r=9.3 //w=0.17 //l=0.17 //layer=mcon //count=1 \
 //x=26.76 //y=2.26 //x2=26.76 //y2=2.26
r1631 (  54 169 ) resistor r=4.5 //w=0.15 //l=0.15 //layer=via1 //count=1 \
 //x=26.76 //y=3.145 //x2=26.76 //y2=3.145
r1632 (  48 164 ) resistor r=4.5 //w=0.15 //l=0.15 //layer=via1 //count=1 \
 //x=12.33 //y=3.125 //x2=12.33 //y2=3.125
r1633 (  44 180 ) resistor r=9.3 //w=0.17 //l=0.17 //layer=mcon //count=1 \
 //x=12.33 //y=2.26 //x2=12.33 //y2=2.26
r1634 (  41 86 ) resistor r=0.0911593 //w=0.376 //l=0.184608 //layer=m1 \
 //thickness=0.36 //x=84.48 //y=3.305 //x2=84.427 //y2=3.145
r1635 (  41 42 ) resistor r=1.39313 //w=0.131 //l=1.46 //layer=m1 \
 //thickness=0.36 //x=84.48 //y=3.305 //x2=84.48 //y2=4.765
r1636 (  40 84 ) resistor r=0.0894971 //w=0.376 //l=0.179555 //layer=m1 \
 //thickness=0.36 //x=84.48 //y=2.985 //x2=84.427 //y2=3.14
r1637 (  39 88 ) resistor r=0.0715665 //w=0.226 //l=0.115996 //layer=m1 \
 //thickness=0.36 //x=84.48 //y=2.375 //x2=84.482 //y2=2.26
r1638 (  39 40 ) resistor r=0.582061 //w=0.131 //l=0.61 //layer=m1 \
 //thickness=0.36 //x=84.48 //y=2.375 //x2=84.48 //y2=2.985
r1639 (  37 38 ) resistor r=1.41221 //w=0.131 //l=1.48 //layer=m1 \
 //thickness=0.36 //x=70.05 //y=3.285 //x2=70.05 //y2=4.765
r1640 (  35 80 ) resistor r=0.0911593 //w=0.376 //l=0.184174 //layer=m1 \
 //thickness=0.36 //x=70.05 //y=2.965 //x2=70.102 //y2=3.125
r1641 (  34 76 ) resistor r=0.0715665 //w=0.226 //l=0.115996 //layer=m1 \
 //thickness=0.36 //x=70.05 //y=2.375 //x2=70.052 //y2=2.26
r1642 (  32 70 ) resistor r=0.0911593 //w=0.376 //l=0.184608 //layer=m1 \
 //thickness=0.36 //x=55.62 //y=3.305 //x2=55.567 //y2=3.145
r1643 (  32 33 ) resistor r=1.39313 //w=0.131 //l=1.46 //layer=m1 \
 //thickness=0.36 //x=55.62 //y=3.305 //x2=55.62 //y2=4.765
r1644 (  30 72 ) resistor r=0.0715665 //w=0.226 //l=0.115996 //layer=m1 \
 //thickness=0.36 //x=55.62 //y=2.375 //x2=55.622 //y2=2.26
r1645 (  30 31 ) resistor r=0.582061 //w=0.131 //l=0.61 //layer=m1 \
 //thickness=0.36 //x=55.62 //y=2.375 //x2=55.62 //y2=2.985
r1646 (  29 62 ) resistor r=0.0717383 //w=0.224 //l=0.115 //layer=m1 \
 //thickness=0.36 //x=41.19 //y=4.765 //x2=41.19 //y2=4.88
r1647 (  28 29 ) resistor r=1.41221 //w=0.131 //l=1.48 //layer=m1 \
 //thickness=0.36 //x=41.19 //y=3.285 //x2=41.19 //y2=4.765
r1648 (  26 64 ) resistor r=0.0911593 //w=0.376 //l=0.184174 //layer=m1 \
 //thickness=0.36 //x=41.19 //y=2.965 //x2=41.242 //y2=3.125
r1649 (  25 60 ) resistor r=0.0715665 //w=0.226 //l=0.115996 //layer=m1 \
 //thickness=0.36 //x=41.19 //y=2.375 //x2=41.192 //y2=2.26
r1650 (  23 54 ) resistor r=0.0911593 //w=0.376 //l=0.184608 //layer=m1 \
 //thickness=0.36 //x=26.76 //y=3.305 //x2=26.707 //y2=3.145
r1651 (  23 24 ) resistor r=1.39313 //w=0.131 //l=1.46 //layer=m1 \
 //thickness=0.36 //x=26.76 //y=3.305 //x2=26.76 //y2=4.765
r1652 (  20 56 ) resistor r=0.0715665 //w=0.226 //l=0.115996 //layer=m1 \
 //thickness=0.36 //x=26.76 //y=2.375 //x2=26.762 //y2=2.26
r1653 (  18 19 ) resistor r=1.41221 //w=0.131 //l=1.48 //layer=m1 \
 //thickness=0.36 //x=12.33 //y=3.285 //x2=12.33 //y2=4.765
r1654 (  16 48 ) resistor r=0.0911593 //w=0.376 //l=0.184174 //layer=m1 \
 //thickness=0.36 //x=12.33 //y=2.965 //x2=12.382 //y2=3.125
r1655 (  15 44 ) resistor r=0.0715665 //w=0.226 //l=0.115996 //layer=m1 \
 //thickness=0.36 //x=12.33 //y=2.375 //x2=12.332 //y2=2.26
r1656 (  14 259 ) resistor r=9.3 //w=0.17 //l=0.17 //layer=mcon //count=1 \
 //x=84.48 //y=4.88 //x2=84.48 //y2=4.88
r1657 (  14 42 ) resistor r=0.0717383 //w=0.224 //l=0.115 //layer=m1 \
 //thickness=0.36 //x=84.48 //y=4.88 //x2=84.48 //y2=4.765
r1658 (  13 245 ) resistor r=9.3 //w=0.17 //l=0.17 //layer=mcon //count=1 \
 //x=70.05 //y=4.88 //x2=70.05 //y2=4.88
r1659 (  13 38 ) resistor r=0.0717383 //w=0.224 //l=0.115 //layer=m1 \
 //thickness=0.36 //x=70.05 //y=4.88 //x2=70.05 //y2=4.765
r1660 (  12 37 ) resistor r=0.0861726 //w=0.376 //l=0.169012 //layer=m1 \
 //thickness=0.36 //x=70.102 //y=3.14 //x2=70.05 //y2=3.285
r1661 (  12 80 ) resistor r=0.0049867 //w=0.376 //l=0.015 //layer=m1 \
 //thickness=0.36 //x=70.102 //y=3.14 //x2=70.102 //y2=3.125
r1662 (  11 231 ) resistor r=9.3 //w=0.17 //l=0.17 //layer=mcon //count=1 \
 //x=55.62 //y=4.88 //x2=55.62 //y2=4.88
r1663 (  11 33 ) resistor r=0.0717383 //w=0.224 //l=0.115 //layer=m1 \
 //thickness=0.36 //x=55.62 //y=4.88 //x2=55.62 //y2=4.765
r1664 (  10 70 ) resistor r=0.00166223 //w=0.376 //l=0.005 //layer=m1 \
 //thickness=0.36 //x=55.567 //y=3.14 //x2=55.567 //y2=3.145
r1665 (  10 31 ) resistor r=0.0894971 //w=0.376 //l=0.179555 //layer=m1 \
 //thickness=0.36 //x=55.567 //y=3.14 //x2=55.62 //y2=2.985
r1666 (  9 28 ) resistor r=0.0861726 //w=0.376 //l=0.169012 //layer=m1 \
 //thickness=0.36 //x=41.242 //y=3.14 //x2=41.19 //y2=3.285
r1667 (  9 64 ) resistor r=0.0049867 //w=0.376 //l=0.015 //layer=m1 \
 //thickness=0.36 //x=41.242 //y=3.14 //x2=41.242 //y2=3.125
r1668 (  8 203 ) resistor r=9.3 //w=0.17 //l=0.17 //layer=mcon //count=1 \
 //x=26.76 //y=4.88 //x2=26.76 //y2=4.88
r1669 (  8 24 ) resistor r=0.0717383 //w=0.224 //l=0.115 //layer=m1 \
 //thickness=0.36 //x=26.76 //y=4.88 //x2=26.76 //y2=4.765
r1670 (  7 54 ) resistor r=0.00166223 //w=0.376 //l=0.005 //layer=m1 \
 //thickness=0.36 //x=26.707 //y=3.14 //x2=26.707 //y2=3.145
r1671 (  7 21 ) resistor r=0.0894971 //w=0.376 //l=0.179555 //layer=m1 \
 //thickness=0.36 //x=26.707 //y=3.14 //x2=26.76 //y2=2.985
r1672 (  6 189 ) resistor r=9.3 //w=0.17 //l=0.17 //layer=mcon //count=1 \
 //x=12.33 //y=4.88 //x2=12.33 //y2=4.88
r1673 (  6 19 ) resistor r=0.0717383 //w=0.224 //l=0.115 //layer=m1 \
 //thickness=0.36 //x=12.33 //y=4.88 //x2=12.33 //y2=4.765
r1674 (  5 18 ) resistor r=0.0861726 //w=0.376 //l=0.169012 //layer=m1 \
 //thickness=0.36 //x=12.382 //y=3.14 //x2=12.33 //y2=3.285
r1675 (  5 48 ) resistor r=0.0049867 //w=0.376 //l=0.015 //layer=m1 \
 //thickness=0.36 //x=12.382 //y=3.14 //x2=12.382 //y2=3.125
r1676 (  4 35 ) resistor r=0.186069 //w=0.131 //l=0.195 //layer=m1 \
 //thickness=0.36 //x=70.05 //y=2.77 //x2=70.05 //y2=2.965
r1677 (  4 34 ) resistor r=0.376908 //w=0.131 //l=0.395 //layer=m1 \
 //thickness=0.36 //x=70.05 //y=2.77 //x2=70.05 //y2=2.375
r1678 (  3 26 ) resistor r=0.186069 //w=0.131 //l=0.195 //layer=m1 \
 //thickness=0.36 //x=41.19 //y=2.77 //x2=41.19 //y2=2.965
r1679 (  3 25 ) resistor r=0.376908 //w=0.131 //l=0.395 //layer=m1 \
 //thickness=0.36 //x=41.19 //y=2.77 //x2=41.19 //y2=2.375
r1680 (  2 21 ) resistor r=0.205153 //w=0.131 //l=0.215 //layer=m1 \
 //thickness=0.36 //x=26.76 //y=2.77 //x2=26.76 //y2=2.985
r1681 (  2 20 ) resistor r=0.376908 //w=0.131 //l=0.395 //layer=m1 \
 //thickness=0.36 //x=26.76 //y=2.77 //x2=26.76 //y2=2.375
r1682 (  1 16 ) resistor r=0.186069 //w=0.131 //l=0.195 //layer=m1 \
 //thickness=0.36 //x=12.33 //y=2.77 //x2=12.33 //y2=2.965
r1683 (  1 15 ) resistor r=0.376908 //w=0.131 //l=0.395 //layer=m1 \
 //thickness=0.36 //x=12.33 //y=2.77 //x2=12.33 //y2=2.375
ends PM_TMRDFFSNRNQNX1\%SN

subckt PM_TMRDFFSNRNQNX1\%noxref_19 ( 1 2 3 4 5 6 7 8 9 11 14 15 17 18 19 20 \
 22 23 24 25 26 27 28 34 38 45 48 51 57 61 70 72 73 77 80 81 87 96 101 110 115 \
 123 131 148 157 161 162 163 164 165 166 167 168 169 173 174 175 180 182 185 \
 186 190 191 192 197 199 202 203 207 208 209 214 216 219 220 222 223 228 232 \
 233 238 242 243 248 251 253 254 255 )
c605 ( 251 0 ) capacitor c=0.00885916f //x=76.035 //y=1.095
c606 ( 248 0 ) capacitor c=0.0651477f //x=85.59 //y=4.88
c607 ( 243 0 ) capacitor c=0.0278202f //x=85.59 //y=2.095
c608 ( 242 0 ) capacitor c=0.0503043f //x=85.59 //y=2.26
c609 ( 238 0 ) capacitor c=0.0651406f //x=71.16 //y=4.88
c610 ( 233 0 ) capacitor c=0.0278202f //x=71.16 //y=2.095
c611 ( 232 0 ) capacitor c=0.0503043f //x=71.16 //y=2.26
c612 ( 228 0 ) capacitor c=0.0653609f //x=66.35 //y=4.88
c613 ( 223 0 ) capacitor c=0.0278202f //x=66.35 //y=2.095
c614 ( 222 0 ) capacitor c=0.0503043f //x=66.35 //y=2.26
c615 ( 220 0 ) capacitor c=0.0443175f //x=86.11 //y=1.44
c616 ( 219 0 ) capacitor c=0.0199703f //x=86.11 //y=1.095
c617 ( 216 0 ) capacitor c=0.0162526f //x=85.955 //y=1.595
c618 ( 214 0 ) capacitor c=0.0157807f //x=85.955 //y=0.94
c619 ( 209 0 ) capacitor c=0.0220935f //x=85.58 //y=1.75
c620 ( 208 0 ) capacitor c=0.0207489f //x=85.58 //y=1.44
c621 ( 207 0 ) capacitor c=0.0194091f //x=85.58 //y=1.095
c622 ( 203 0 ) capacitor c=0.0443175f //x=71.68 //y=1.44
c623 ( 202 0 ) capacitor c=0.0199703f //x=71.68 //y=1.095
c624 ( 199 0 ) capacitor c=0.0162526f //x=71.525 //y=1.595
c625 ( 197 0 ) capacitor c=0.0157807f //x=71.525 //y=0.94
c626 ( 192 0 ) capacitor c=0.0220935f //x=71.15 //y=1.75
c627 ( 191 0 ) capacitor c=0.0207489f //x=71.15 //y=1.44
c628 ( 190 0 ) capacitor c=0.0194091f //x=71.15 //y=1.095
c629 ( 186 0 ) capacitor c=0.0443175f //x=66.87 //y=1.44
c630 ( 185 0 ) capacitor c=0.0199703f //x=66.87 //y=1.095
c631 ( 182 0 ) capacitor c=0.0162526f //x=66.715 //y=1.595
c632 ( 180 0 ) capacitor c=0.0157807f //x=66.715 //y=0.94
c633 ( 175 0 ) capacitor c=0.0220935f //x=66.34 //y=1.75
c634 ( 174 0 ) capacitor c=0.0207489f //x=66.34 //y=1.44
c635 ( 173 0 ) capacitor c=0.0194091f //x=66.34 //y=1.095
c636 ( 169 0 ) capacitor c=0.159671f //x=85.77 //y=6.2
c637 ( 168 0 ) capacitor c=0.110208f //x=85.33 //y=6.2
c638 ( 167 0 ) capacitor c=0.159671f //x=71.34 //y=6.2
c639 ( 166 0 ) capacitor c=0.110208f //x=70.9 //y=6.2
c640 ( 165 0 ) capacitor c=0.159671f //x=66.53 //y=6.2
c641 ( 164 0 ) capacitor c=0.110208f //x=66.09 //y=6.2
c642 ( 157 0 ) capacitor c=7.7417e-19 //x=85.59 //y=4.88
c643 ( 148 0 ) capacitor c=0.00101179f //x=85.59 //y=2.26
c644 ( 131 0 ) capacitor c=0.0293124f //x=75.93 //y=5.56
c645 ( 123 0 ) capacitor c=0.029137f //x=75.05 //y=5.56
c646 ( 115 0 ) capacitor c=0.0278099f //x=74.17 //y=5.56
c647 ( 110 0 ) capacitor c=7.7417e-19 //x=71.16 //y=4.88
c648 ( 101 0 ) capacitor c=0.00101179f //x=71.16 //y=2.26
c649 ( 96 0 ) capacitor c=7.7417e-19 //x=66.35 //y=4.88
c650 ( 87 0 ) capacitor c=0.00101179f //x=66.35 //y=2.26
c651 ( 81 0 ) capacitor c=6.2466e-19 //x=71.32 //y=3.895
c652 ( 80 0 ) capacitor c=0.0446269f //x=71 //y=3.895
c653 ( 77 0 ) capacitor c=6.16295e-19 //x=66.51 //y=3.895
c654 ( 73 0 ) capacitor c=0.0212158f //x=78.425 //y=3.895
c655 ( 72 0 ) capacitor c=0.0852939f //x=78.77 //y=3.895
c656 ( 70 0 ) capacitor c=0.0535679f //x=76.54 //y=3.88
c657 ( 61 0 ) capacitor c=0.0149589f //x=85.59 //y=3.88
c658 ( 57 0 ) capacitor c=0.0158949f //x=76.71 //y=3.88
c659 ( 51 0 ) capacitor c=0.00111241f //x=75.93 //y=5.335
c660 ( 48 0 ) capacitor c=0.00737416f //x=75.05 //y=5.335
c661 ( 45 0 ) capacitor c=0.0102414f //x=74.172 //y=5.335
c662 ( 38 0 ) capacitor c=0.0149589f //x=71.16 //y=3.88
c663 ( 34 0 ) capacitor c=0.0149589f //x=66.35 //y=3.88
c664 ( 28 0 ) capacitor c=0.0197432f //x=85.59 //y=4.75
c665 ( 27 0 ) capacitor c=0.0115086f //x=85.59 //y=4.045
c666 ( 26 0 ) capacitor c=0.032949f //x=85.59 //y=3.725
c667 ( 25 0 ) capacitor c=0.00556102f //x=85.59 //y=2.375
c668 ( 24 0 ) capacitor c=0.0303433f //x=76.71 //y=5.25
c669 ( 23 0 ) capacitor c=0.0138897f //x=76.71 //y=4.055
c670 ( 22 0 ) capacitor c=0.0490588f //x=76.71 //y=3.735
c671 ( 20 0 ) capacitor c=0.00493487f //x=76.31 //y=1.845
c672 ( 19 0 ) capacitor c=0.0133342f //x=76.625 //y=1.845
c673 ( 18 0 ) capacitor c=0.0167992f //x=76.225 //y=1.76
c674 ( 17 0 ) capacitor c=0.0111491f //x=76.225 //y=1.305
c675 ( 15 0 ) capacitor c=0.0238276f //x=76.625 //y=5.335
c676 ( 14 0 ) capacitor c=0.00933983f //x=75.93 //y=5.56
c677 ( 11 0 ) capacitor c=0.0164307f //x=75.815 //y=5.335
c678 ( 9 0 ) capacitor c=0.0159044f //x=74.93 //y=5.335
c679 ( 8 0 ) capacitor c=0.0195876f //x=71.16 //y=4.75
c680 ( 7 0 ) capacitor c=0.011494f //x=71.16 //y=4.055
c681 ( 6 0 ) capacitor c=0.029293f //x=71.16 //y=3.735
c682 ( 5 0 ) capacitor c=0.00556102f //x=71.16 //y=2.375
c683 ( 4 0 ) capacitor c=0.0189001f //x=66.35 //y=4.75
c684 ( 3 0 ) capacitor c=0.0132847f //x=66.35 //y=4.055
c685 ( 2 0 ) capacitor c=0.0302473f //x=66.35 //y=3.735
c686 ( 1 0 ) capacitor c=0.00556102f //x=66.35 //y=2.375
r687 (  242 243 ) resistor r=52.7279 //w=0.214 //l=0.165 //layer=ply \
 //thickness=0.18 //x=85.59 //y=2.26 //x2=85.59 //y2=2.095
r688 (  232 233 ) resistor r=52.7279 //w=0.214 //l=0.165 //layer=ply \
 //thickness=0.18 //x=71.16 //y=2.26 //x2=71.16 //y2=2.095
r689 (  222 223 ) resistor r=52.7279 //w=0.214 //l=0.165 //layer=ply \
 //thickness=0.18 //x=66.35 //y=2.26 //x2=66.35 //y2=2.095
r690 (  220 250 ) resistor r=45.1352 //w=0.168 //l=0.173853 //layer=ply \
 //thickness=0.18 //x=86.11 //y=1.44 //x2=86.07 //y2=1.595
r691 (  219 249 ) resistor r=45.1352 //w=0.168 //l=0.173853 //layer=ply \
 //thickness=0.18 //x=86.11 //y=1.095 //x2=86.07 //y2=0.94
r692 (  219 220 ) resistor r=176.904 //w=0.094 //l=0.345 //layer=ply \
 //thickness=0.18 //x=86.11 //y=1.095 //x2=86.11 //y2=1.44
r693 (  217 246 ) resistor r=10.701 //w=0.21 //l=0.115 //layer=ply \
 //thickness=0.18 //x=85.735 //y=1.595 //x2=85.62 //y2=1.595
r694 (  216 250 ) resistor r=5.52526 //w=0.168 //l=0.115 //layer=ply \
 //thickness=0.18 //x=85.955 //y=1.595 //x2=86.07 //y2=1.595
r695 (  215 245 ) resistor r=5.52526 //w=0.168 //l=0.115 //layer=ply \
 //thickness=0.18 //x=85.735 //y=0.94 //x2=85.62 //y2=0.94
r696 (  214 249 ) resistor r=5.52526 //w=0.168 //l=0.115 //layer=ply \
 //thickness=0.18 //x=85.955 //y=0.94 //x2=86.07 //y2=0.94
r697 (  214 215 ) resistor r=112.809 //w=0.094 //l=0.22 //layer=ply \
 //thickness=0.18 //x=85.955 //y=0.94 //x2=85.735 //y2=0.94
r698 (  211 248 ) resistor r=37.236 //w=0.233 //l=0.249199 //layer=ply \
 //thickness=0.18 //x=85.77 //y=5.045 //x2=85.59 //y2=4.88
r699 (  209 246 ) resistor r=39.5823 //w=0.21 //l=0.173853 //layer=ply \
 //thickness=0.18 //x=85.58 //y=1.75 //x2=85.62 //y2=1.595
r700 (  209 243 ) resistor r=176.904 //w=0.094 //l=0.345 //layer=ply \
 //thickness=0.18 //x=85.58 //y=1.75 //x2=85.58 //y2=2.095
r701 (  208 246 ) resistor r=39.5823 //w=0.21 //l=0.173853 //layer=ply \
 //thickness=0.18 //x=85.58 //y=1.44 //x2=85.62 //y2=1.595
r702 (  207 245 ) resistor r=45.1352 //w=0.168 //l=0.173853 //layer=ply \
 //thickness=0.18 //x=85.58 //y=1.095 //x2=85.62 //y2=0.94
r703 (  207 208 ) resistor r=176.904 //w=0.094 //l=0.345 //layer=ply \
 //thickness=0.18 //x=85.58 //y=1.095 //x2=85.58 //y2=1.44
r704 (  204 248 ) resistor r=53.7854 //w=0.233 //l=0.332415 //layer=ply \
 //thickness=0.18 //x=85.33 //y=5.045 //x2=85.59 //y2=4.88
r705 (  203 240 ) resistor r=45.1352 //w=0.168 //l=0.173853 //layer=ply \
 //thickness=0.18 //x=71.68 //y=1.44 //x2=71.64 //y2=1.595
r706 (  202 239 ) resistor r=45.1352 //w=0.168 //l=0.173853 //layer=ply \
 //thickness=0.18 //x=71.68 //y=1.095 //x2=71.64 //y2=0.94
r707 (  202 203 ) resistor r=176.904 //w=0.094 //l=0.345 //layer=ply \
 //thickness=0.18 //x=71.68 //y=1.095 //x2=71.68 //y2=1.44
r708 (  200 236 ) resistor r=10.701 //w=0.21 //l=0.115 //layer=ply \
 //thickness=0.18 //x=71.305 //y=1.595 //x2=71.19 //y2=1.595
r709 (  199 240 ) resistor r=5.52526 //w=0.168 //l=0.115 //layer=ply \
 //thickness=0.18 //x=71.525 //y=1.595 //x2=71.64 //y2=1.595
r710 (  198 235 ) resistor r=5.52526 //w=0.168 //l=0.115 //layer=ply \
 //thickness=0.18 //x=71.305 //y=0.94 //x2=71.19 //y2=0.94
r711 (  197 239 ) resistor r=5.52526 //w=0.168 //l=0.115 //layer=ply \
 //thickness=0.18 //x=71.525 //y=0.94 //x2=71.64 //y2=0.94
r712 (  197 198 ) resistor r=112.809 //w=0.094 //l=0.22 //layer=ply \
 //thickness=0.18 //x=71.525 //y=0.94 //x2=71.305 //y2=0.94
r713 (  194 238 ) resistor r=37.236 //w=0.233 //l=0.249199 //layer=ply \
 //thickness=0.18 //x=71.34 //y=5.045 //x2=71.16 //y2=4.88
r714 (  192 236 ) resistor r=39.5823 //w=0.21 //l=0.173853 //layer=ply \
 //thickness=0.18 //x=71.15 //y=1.75 //x2=71.19 //y2=1.595
r715 (  192 233 ) resistor r=176.904 //w=0.094 //l=0.345 //layer=ply \
 //thickness=0.18 //x=71.15 //y=1.75 //x2=71.15 //y2=2.095
r716 (  191 236 ) resistor r=39.5823 //w=0.21 //l=0.173853 //layer=ply \
 //thickness=0.18 //x=71.15 //y=1.44 //x2=71.19 //y2=1.595
r717 (  190 235 ) resistor r=45.1352 //w=0.168 //l=0.173853 //layer=ply \
 //thickness=0.18 //x=71.15 //y=1.095 //x2=71.19 //y2=0.94
r718 (  190 191 ) resistor r=176.904 //w=0.094 //l=0.345 //layer=ply \
 //thickness=0.18 //x=71.15 //y=1.095 //x2=71.15 //y2=1.44
r719 (  187 238 ) resistor r=53.7854 //w=0.233 //l=0.332415 //layer=ply \
 //thickness=0.18 //x=70.9 //y=5.045 //x2=71.16 //y2=4.88
r720 (  186 230 ) resistor r=45.1352 //w=0.168 //l=0.173853 //layer=ply \
 //thickness=0.18 //x=66.87 //y=1.44 //x2=66.83 //y2=1.595
r721 (  185 229 ) resistor r=45.1352 //w=0.168 //l=0.173853 //layer=ply \
 //thickness=0.18 //x=66.87 //y=1.095 //x2=66.83 //y2=0.94
r722 (  185 186 ) resistor r=176.904 //w=0.094 //l=0.345 //layer=ply \
 //thickness=0.18 //x=66.87 //y=1.095 //x2=66.87 //y2=1.44
r723 (  183 226 ) resistor r=10.701 //w=0.21 //l=0.115 //layer=ply \
 //thickness=0.18 //x=66.495 //y=1.595 //x2=66.38 //y2=1.595
r724 (  182 230 ) resistor r=5.52526 //w=0.168 //l=0.115 //layer=ply \
 //thickness=0.18 //x=66.715 //y=1.595 //x2=66.83 //y2=1.595
r725 (  181 225 ) resistor r=5.52526 //w=0.168 //l=0.115 //layer=ply \
 //thickness=0.18 //x=66.495 //y=0.94 //x2=66.38 //y2=0.94
r726 (  180 229 ) resistor r=5.52526 //w=0.168 //l=0.115 //layer=ply \
 //thickness=0.18 //x=66.715 //y=0.94 //x2=66.83 //y2=0.94
r727 (  180 181 ) resistor r=112.809 //w=0.094 //l=0.22 //layer=ply \
 //thickness=0.18 //x=66.715 //y=0.94 //x2=66.495 //y2=0.94
r728 (  177 228 ) resistor r=37.236 //w=0.233 //l=0.249199 //layer=ply \
 //thickness=0.18 //x=66.53 //y=5.045 //x2=66.35 //y2=4.88
r729 (  175 226 ) resistor r=39.5823 //w=0.21 //l=0.173853 //layer=ply \
 //thickness=0.18 //x=66.34 //y=1.75 //x2=66.38 //y2=1.595
r730 (  175 223 ) resistor r=176.904 //w=0.094 //l=0.345 //layer=ply \
 //thickness=0.18 //x=66.34 //y=1.75 //x2=66.34 //y2=2.095
r731 (  174 226 ) resistor r=39.5823 //w=0.21 //l=0.173853 //layer=ply \
 //thickness=0.18 //x=66.34 //y=1.44 //x2=66.38 //y2=1.595
r732 (  173 225 ) resistor r=45.1352 //w=0.168 //l=0.173853 //layer=ply \
 //thickness=0.18 //x=66.34 //y=1.095 //x2=66.38 //y2=0.94
r733 (  173 174 ) resistor r=176.904 //w=0.094 //l=0.345 //layer=ply \
 //thickness=0.18 //x=66.34 //y=1.095 //x2=66.34 //y2=1.44
r734 (  170 228 ) resistor r=53.7854 //w=0.233 //l=0.332415 //layer=ply \
 //thickness=0.18 //x=66.09 //y=5.045 //x2=66.35 //y2=4.88
r735 (  169 211 ) resistor r=592.245 //w=0.094 //l=1.155 //layer=ply \
 //thickness=0.18 //x=85.77 //y=6.2 //x2=85.77 //y2=5.045
r736 (  168 204 ) resistor r=592.245 //w=0.094 //l=1.155 //layer=ply \
 //thickness=0.18 //x=85.33 //y=6.2 //x2=85.33 //y2=5.045
r737 (  167 194 ) resistor r=592.245 //w=0.094 //l=1.155 //layer=ply \
 //thickness=0.18 //x=71.34 //y=6.2 //x2=71.34 //y2=5.045
r738 (  166 187 ) resistor r=592.245 //w=0.094 //l=1.155 //layer=ply \
 //thickness=0.18 //x=70.9 //y=6.2 //x2=70.9 //y2=5.045
r739 (  165 177 ) resistor r=592.245 //w=0.094 //l=1.155 //layer=ply \
 //thickness=0.18 //x=66.53 //y=6.2 //x2=66.53 //y2=5.045
r740 (  164 170 ) resistor r=592.245 //w=0.094 //l=1.155 //layer=ply \
 //thickness=0.18 //x=66.09 //y=6.2 //x2=66.09 //y2=5.045
r741 (  163 216 ) resistor r=56.4043 //w=0.094 //l=0.11 //layer=ply \
 //thickness=0.18 //x=85.845 //y=1.595 //x2=85.955 //y2=1.595
r742 (  163 217 ) resistor r=56.4043 //w=0.094 //l=0.11 //layer=ply \
 //thickness=0.18 //x=85.845 //y=1.595 //x2=85.735 //y2=1.595
r743 (  162 199 ) resistor r=56.4043 //w=0.094 //l=0.11 //layer=ply \
 //thickness=0.18 //x=71.415 //y=1.595 //x2=71.525 //y2=1.595
r744 (  162 200 ) resistor r=56.4043 //w=0.094 //l=0.11 //layer=ply \
 //thickness=0.18 //x=71.415 //y=1.595 //x2=71.305 //y2=1.595
r745 (  161 182 ) resistor r=56.4043 //w=0.094 //l=0.11 //layer=ply \
 //thickness=0.18 //x=66.605 //y=1.595 //x2=66.715 //y2=1.595
r746 (  161 183 ) resistor r=56.4043 //w=0.094 //l=0.11 //layer=ply \
 //thickness=0.18 //x=66.605 //y=1.595 //x2=66.495 //y2=1.595
r747 (  157 248 ) resistor r=152 //w=0.17 //l=0.17 //layer=licon //count=1 \
 //x=85.59 //y=4.88 //x2=85.59 //y2=4.88
r748 (  148 242 ) resistor r=152 //w=0.17 //l=0.17 //layer=licon //count=1 \
 //x=85.59 //y=2.26 //x2=85.59 //y2=2.26
r749 (  131 255 ) resistor r=23.615 //w=0.187 //l=0.345 //layer=li \
 //thickness=0.1 //x=75.93 //y=5.56 //x2=75.93 //y2=5.905
r750 (  123 254 ) resistor r=23.615 //w=0.187 //l=0.345 //layer=li \
 //thickness=0.1 //x=75.05 //y=5.56 //x2=75.05 //y2=5.905
r751 (  115 253 ) resistor r=23.615 //w=0.187 //l=0.345 //layer=li \
 //thickness=0.1 //x=74.17 //y=5.56 //x2=74.17 //y2=5.905
r752 (  110 238 ) resistor r=152 //w=0.17 //l=0.17 //layer=licon //count=1 \
 //x=71.16 //y=4.88 //x2=71.16 //y2=4.88
r753 (  101 232 ) resistor r=152 //w=0.17 //l=0.17 //layer=licon //count=1 \
 //x=71.16 //y=2.26 //x2=71.16 //y2=2.26
r754 (  96 228 ) resistor r=152 //w=0.17 //l=0.17 //layer=licon //count=1 \
 //x=66.35 //y=4.88 //x2=66.35 //y2=4.88
r755 (  87 222 ) resistor r=152 //w=0.17 //l=0.17 //layer=licon //count=1 \
 //x=66.35 //y=2.26 //x2=66.35 //y2=2.26
r756 (  79 81 ) resistor r=0.10734 //w=0.281 //l=0.16 //layer=m2 \
 //thickness=0.36 //x=71.16 //y=3.895 //x2=71.32 //y2=3.895
r757 (  79 80 ) resistor r=0.10734 //w=0.281 //l=0.16 //layer=m2 \
 //thickness=0.36 //x=71.16 //y=3.895 //x2=71 //y2=3.895
r758 (  77 80 ) resistor r=4.28435 //w=0.131 //l=4.49 //layer=m2 \
 //thickness=0.36 //x=66.51 //y=3.88 //x2=71 //y2=3.88
r759 (  75 77 ) resistor r=0.10734 //w=0.281 //l=0.16 //layer=m2 \
 //thickness=0.36 //x=66.35 //y=3.895 //x2=66.51 //y2=3.895
r760 (  73 83 ) resistor r=1.10266 //w=0.196 //l=1.725 //layer=m2 \
 //thickness=0.36 //x=78.425 //y=3.895 //x2=76.7 //y2=3.895
r761 (  72 85 ) resistor r=4.81638 //w=0.177 //l=6.825 //layer=m2 \
 //thickness=0.36 //x=78.77 //y=3.895 //x2=85.59 //y2=3.885
r762 (  72 73 ) resistor r=0.329198 //w=0.131 //l=0.345 //layer=m2 \
 //thickness=0.36 //x=78.77 //y=3.895 //x2=78.425 //y2=3.895
r763 (  70 83 ) resistor r=0.104578 //w=0.196 //l=0.167332 //layer=m2 \
 //thickness=0.36 //x=76.54 //y=3.88 //x2=76.7 //y2=3.895
r764 (  70 81 ) resistor r=4.98092 //w=0.131 //l=5.22 //layer=m2 \
 //thickness=0.36 //x=76.54 //y=3.88 //x2=71.32 //y2=3.88
r765 (  67 157 ) resistor r=9.3 //w=0.17 //l=0.17 //layer=mcon //count=1 \
 //x=85.59 //y=4.88 //x2=85.59 //y2=4.88
r766 (  65 148 ) resistor r=9.3 //w=0.17 //l=0.17 //layer=mcon //count=1 \
 //x=85.59 //y=2.26 //x2=85.59 //y2=2.26
r767 (  63 85 ) resistor r=4.5 //w=0.15 //l=0.15 //layer=via1 //count=1 \
 //x=85.59 //y=3.885 //x2=85.59 //y2=3.885
r768 (  61 63 ) resistor r=0.00166223 //w=0.376 //l=0.005 //layer=m1 \
 //thickness=0.36 //x=85.537 //y=3.88 //x2=85.537 //y2=3.885
r769 (  59 83 ) resistor r=4.5 //w=0.15 //l=0.15 //layer=via1 //count=1 \
 //x=76.7 //y=3.895 //x2=76.7 //y2=3.895
r770 (  57 59 ) resistor r=0.00490838 //w=0.382 //l=0.015 //layer=m1 \
 //thickness=0.36 //x=76.757 //y=3.88 //x2=76.757 //y2=3.895
r771 (  55 251 ) resistor r=9.3 //w=0.17 //l=0.17 //layer=mcon //count=1 \
 //x=76.225 //y=1.19 //x2=76.225 //y2=1.19
r772 (  53 131 ) resistor r=9.3 //w=0.17 //l=0.17 //layer=mcon //count=1 \
 //x=75.93 //y=5.56 //x2=75.93 //y2=5.56
r773 (  50 123 ) resistor r=9.3 //w=0.17 //l=0.17 //layer=mcon //count=1 \
 //x=75.05 //y=5.56 //x2=75.05 //y2=5.56
r774 (  48 50 ) resistor r=0.121228 //w=0.232 //l=0.225 //layer=m1 \
 //thickness=0.36 //x=75.05 //y=5.335 //x2=75.05 //y2=5.56
r775 (  47 115 ) resistor r=9.3 //w=0.17 //l=0.17 //layer=mcon //count=1 \
 //x=74.17 //y=5.56 //x2=74.17 //y2=5.56
r776 (  45 47 ) resistor r=0.129608 //w=0.217 //l=0.225 //layer=m1 \
 //thickness=0.36 //x=74.172 //y=5.335 //x2=74.172 //y2=5.56
r777 (  44 110 ) resistor r=9.3 //w=0.17 //l=0.17 //layer=mcon //count=1 \
 //x=71.16 //y=4.88 //x2=71.16 //y2=4.88
r778 (  42 101 ) resistor r=9.3 //w=0.17 //l=0.17 //layer=mcon //count=1 \
 //x=71.16 //y=2.26 //x2=71.16 //y2=2.26
r779 (  40 79 ) resistor r=4.5 //w=0.15 //l=0.15 //layer=via1 //count=1 \
 //x=71.16 //y=3.895 //x2=71.16 //y2=3.895
r780 (  38 40 ) resistor r=0.0049867 //w=0.376 //l=0.015 //layer=m1 \
 //thickness=0.36 //x=71.107 //y=3.88 //x2=71.107 //y2=3.895
r781 (  36 75 ) resistor r=4.5 //w=0.15 //l=0.15 //layer=via1 //count=1 \
 //x=66.35 //y=3.895 //x2=66.35 //y2=3.895
r782 (  34 36 ) resistor r=0.0049867 //w=0.376 //l=0.015 //layer=m1 \
 //thickness=0.36 //x=66.402 //y=3.88 //x2=66.402 //y2=3.895
r783 (  32 96 ) resistor r=9.3 //w=0.17 //l=0.17 //layer=mcon //count=1 \
 //x=66.35 //y=4.88 //x2=66.35 //y2=4.88
r784 (  30 87 ) resistor r=9.3 //w=0.17 //l=0.17 //layer=mcon //count=1 \
 //x=66.35 //y=2.26 //x2=66.35 //y2=2.26
r785 (  28 67 ) resistor r=0.0801089 //w=0.224 //l=0.13 //layer=m1 \
 //thickness=0.36 //x=85.59 //y=4.75 //x2=85.59 //y2=4.88
r786 (  27 63 ) resistor r=0.0911593 //w=0.376 //l=0.184608 //layer=m1 \
 //thickness=0.36 //x=85.59 //y=4.045 //x2=85.537 //y2=3.885
r787 (  27 28 ) resistor r=0.67271 //w=0.131 //l=0.705 //layer=m1 \
 //thickness=0.36 //x=85.59 //y=4.045 //x2=85.59 //y2=4.75
r788 (  26 61 ) resistor r=0.0894971 //w=0.376 //l=0.179555 //layer=m1 \
 //thickness=0.36 //x=85.59 //y=3.725 //x2=85.537 //y2=3.88
r789 (  25 65 ) resistor r=0.0719237 //w=0.222 //l=0.115 //layer=m1 \
 //thickness=0.36 //x=85.59 //y=2.375 //x2=85.59 //y2=2.26
r790 (  25 26 ) resistor r=1.28817 //w=0.131 //l=1.35 //layer=m1 \
 //thickness=0.36 //x=85.59 //y=2.375 //x2=85.59 //y2=3.725
r791 (  23 59 ) resistor r=0.0914072 //w=0.382 //l=0.181989 //layer=m1 \
 //thickness=0.36 //x=76.71 //y=4.055 //x2=76.757 //y2=3.895
r792 (  23 24 ) resistor r=1.14027 //w=0.131 //l=1.195 //layer=m1 \
 //thickness=0.36 //x=76.71 //y=4.055 //x2=76.71 //y2=5.25
r793 (  22 57 ) resistor r=0.0864989 //w=0.382 //l=0.166853 //layer=m1 \
 //thickness=0.36 //x=76.71 //y=3.735 //x2=76.757 //y2=3.88
r794 (  21 22 ) resistor r=1.72233 //w=0.131 //l=1.805 //layer=m1 \
 //thickness=0.36 //x=76.71 //y=1.93 //x2=76.71 //y2=3.735
r795 (  19 21 ) resistor r=0.0698411 //w=0.17 //l=0.120208 //layer=m1 \
 //thickness=0.36 //x=76.625 //y=1.845 //x2=76.71 //y2=1.93
r796 (  19 20 ) resistor r=0.300573 //w=0.131 //l=0.315 //layer=m1 \
 //thickness=0.36 //x=76.625 //y=1.845 //x2=76.31 //y2=1.845
r797 (  18 20 ) resistor r=0.0698411 //w=0.17 //l=0.120208 //layer=m1 \
 //thickness=0.36 //x=76.225 //y=1.76 //x2=76.31 //y2=1.845
r798 (  17 55 ) resistor r=0.0717383 //w=0.224 //l=0.115 //layer=m1 \
 //thickness=0.36 //x=76.225 //y=1.305 //x2=76.225 //y2=1.19
r799 (  17 18 ) resistor r=0.43416 //w=0.131 //l=0.455 //layer=m1 \
 //thickness=0.36 //x=76.225 //y=1.305 //x2=76.225 //y2=1.76
r800 (  16 51 ) resistor r=0.0675342 //w=0.23 //l=0.115 //layer=m1 \
 //thickness=0.36 //x=76.045 //y=5.335 //x2=75.93 //y2=5.335
r801 (  15 24 ) resistor r=0.0698411 //w=0.17 //l=0.120208 //layer=m1 \
 //thickness=0.36 //x=76.625 //y=5.335 //x2=76.71 //y2=5.25
r802 (  15 16 ) resistor r=0.553435 //w=0.131 //l=0.58 //layer=m1 \
 //thickness=0.36 //x=76.625 //y=5.335 //x2=76.045 //y2=5.335
r803 (  14 53 ) resistor r=0.00118313 //w=0.23 //layer=m1 //thickness=0.36 \
 //x=75.93 //y=5.56 //x2=75.93 //y2=5.56
r804 (  13 51 ) resistor r=0.002872 //w=0.34 //l=0.085 //layer=m1 \
 //thickness=0.36 //x=75.93 //y=5.42 //x2=75.93 //y2=5.335
r805 (  13 14 ) resistor r=0.091623 //w=0.191 //l=0.14 //layer=m1 \
 //thickness=0.36 //x=75.93 //y=5.42 //x2=75.93 //y2=5.56
r806 (  12 48 ) resistor r=0.0262263 //w=0.232 //l=0.12 //layer=m1 \
 //thickness=0.36 //x=75.17 //y=5.335 //x2=75.05 //y2=5.335
r807 (  11 51 ) resistor r=0.0675342 //w=0.23 //l=0.115 //layer=m1 \
 //thickness=0.36 //x=75.815 //y=5.335 //x2=75.93 //y2=5.335
r808 (  11 12 ) resistor r=0.615458 //w=0.131 //l=0.645 //layer=m1 \
 //thickness=0.36 //x=75.815 //y=5.335 //x2=75.17 //y2=5.335
r809 (  10 45 ) resistor r=0.0222262 //w=0.217 //l=0.118 //layer=m1 \
 //thickness=0.36 //x=74.29 //y=5.335 //x2=74.172 //y2=5.335
r810 (  9 48 ) resistor r=0.0262263 //w=0.232 //l=0.12 //layer=m1 \
 //thickness=0.36 //x=74.93 //y=5.335 //x2=75.05 //y2=5.335
r811 (  9 10 ) resistor r=0.610687 //w=0.131 //l=0.64 //layer=m1 \
 //thickness=0.36 //x=74.93 //y=5.335 //x2=74.29 //y2=5.335
r812 (  8 44 ) resistor r=0.0801089 //w=0.224 //l=0.13 //layer=m1 \
 //thickness=0.36 //x=71.16 //y=4.75 //x2=71.16 //y2=4.88
r813 (  7 40 ) resistor r=0.0911593 //w=0.376 //l=0.184608 //layer=m1 \
 //thickness=0.36 //x=71.16 //y=4.055 //x2=71.107 //y2=3.895
r814 (  7 8 ) resistor r=0.663168 //w=0.131 //l=0.695 //layer=m1 \
 //thickness=0.36 //x=71.16 //y=4.055 //x2=71.16 //y2=4.75
r815 (  6 38 ) resistor r=0.0861726 //w=0.376 //l=0.16944 //layer=m1 \
 //thickness=0.36 //x=71.16 //y=3.735 //x2=71.107 //y2=3.88
r816 (  5 42 ) resistor r=0.0719237 //w=0.222 //l=0.115 //layer=m1 \
 //thickness=0.36 //x=71.16 //y=2.375 //x2=71.16 //y2=2.26
r817 (  5 6 ) resistor r=1.29771 //w=0.131 //l=1.36 //layer=m1 \
 //thickness=0.36 //x=71.16 //y=2.375 //x2=71.16 //y2=3.735
r818 (  4 32 ) resistor r=0.0801089 //w=0.224 //l=0.13 //layer=m1 \
 //thickness=0.36 //x=66.35 //y=4.75 //x2=66.35 //y2=4.88
r819 (  3 36 ) resistor r=0.0911593 //w=0.376 //l=0.184174 //layer=m1 \
 //thickness=0.36 //x=66.35 //y=4.055 //x2=66.402 //y2=3.895
r820 (  3 4 ) resistor r=0.663168 //w=0.131 //l=0.695 //layer=m1 \
 //thickness=0.36 //x=66.35 //y=4.055 //x2=66.35 //y2=4.75
r821 (  2 34 ) resistor r=0.0861726 //w=0.376 //l=0.169012 //layer=m1 \
 //thickness=0.36 //x=66.35 //y=3.735 //x2=66.402 //y2=3.88
r822 (  1 30 ) resistor r=0.0719237 //w=0.222 //l=0.115 //layer=m1 \
 //thickness=0.36 //x=66.35 //y=2.375 //x2=66.35 //y2=2.26
r823 (  1 2 ) resistor r=1.29771 //w=0.131 //l=1.36 //layer=m1 \
 //thickness=0.36 //x=66.35 //y=2.375 //x2=66.35 //y2=3.735
ends PM_TMRDFFSNRNQNX1\%noxref_19

subckt PM_TMRDFFSNRNQNX1\%noxref_20 ( 1 2 3 4 5 7 10 11 13 14 15 16 18 19 20 \
 28 29 32 35 41 44 46 51 55 64 69 77 85 101 102 103 107 108 109 114 116 119 \
 120 122 123 128 131 133 134 135 )
c317 ( 131 0 ) capacitor c=0.00885916f //x=85.655 //y=1.095
c318 ( 128 0 ) capacitor c=0.0710579f //x=80.78 //y=4.88
c319 ( 123 0 ) capacitor c=0.0278202f //x=80.78 //y=2.095
c320 ( 122 0 ) capacitor c=0.0451939f //x=80.78 //y=2.26
c321 ( 120 0 ) capacitor c=0.0443175f //x=81.3 //y=1.44
c322 ( 119 0 ) capacitor c=0.0199703f //x=81.3 //y=1.095
c323 ( 116 0 ) capacitor c=0.0160573f //x=81.145 //y=1.595
c324 ( 114 0 ) capacitor c=0.0157807f //x=81.145 //y=0.94
c325 ( 109 0 ) capacitor c=0.0220935f //x=80.77 //y=1.75
c326 ( 108 0 ) capacitor c=0.0207489f //x=80.77 //y=1.44
c327 ( 107 0 ) capacitor c=0.0194091f //x=80.77 //y=1.095
c328 ( 103 0 ) capacitor c=0.159671f //x=80.96 //y=6.2
c329 ( 102 0 ) capacitor c=0.110208f //x=80.52 //y=6.2
c330 ( 85 0 ) capacitor c=0.0292914f //x=85.55 //y=5.56
c331 ( 77 0 ) capacitor c=0.0292489f //x=84.67 //y=5.56
c332 ( 69 0 ) capacitor c=0.0278099f //x=83.79 //y=5.56
c333 ( 64 0 ) capacitor c=7.7417e-19 //x=80.78 //y=4.88
c334 ( 55 0 ) capacitor c=7.43216e-19 //x=80.78 //y=2.26
c335 ( 51 0 ) capacitor c=0.00388754f //x=80.93 //y=2.755
c336 ( 46 0 ) capacitor c=0.0215005f //x=84.695 //y=2.76
c337 ( 44 0 ) capacitor c=0.0345684f //x=84.095 //y=2.77
c338 ( 41 0 ) capacitor c=0.0143395f //x=86.33 //y=2.77
c339 ( 35 0 ) capacitor c=8.84507e-19 //x=85.55 //y=5.335
c340 ( 32 0 ) capacitor c=0.00788343f //x=84.67 //y=5.335
c341 ( 29 0 ) capacitor c=0.0111234f //x=83.792 //y=5.335
c342 ( 28 0 ) capacitor c=0.0151653f //x=80.78 //y=2.77
c343 ( 20 0 ) capacitor c=0.0662191f //x=86.33 //y=5.25
c344 ( 19 0 ) capacitor c=0.0124572f //x=86.33 //y=2.945
c345 ( 18 0 ) capacitor c=0.0181143f //x=86.33 //y=2.625
c346 ( 16 0 ) capacitor c=0.00493487f //x=85.93 //y=1.845
c347 ( 15 0 ) capacitor c=0.0134751f //x=86.245 //y=1.845
c348 ( 14 0 ) capacitor c=0.0150416f //x=85.845 //y=1.76
c349 ( 13 0 ) capacitor c=0.0113205f //x=85.845 //y=1.305
c350 ( 11 0 ) capacitor c=0.0237318f //x=86.245 //y=5.335
c351 ( 10 0 ) capacitor c=0.00906283f //x=85.55 //y=5.56
c352 ( 7 0 ) capacitor c=0.0180822f //x=85.435 //y=5.335
c353 ( 5 0 ) capacitor c=0.0146396f //x=84.55 //y=5.335
c354 ( 4 0 ) capacitor c=0.0514093f //x=80.78 //y=4.75
c355 ( 3 0 ) capacitor c=0.0125996f //x=80.78 //y=2.915
c356 ( 2 0 ) capacitor c=0.00290193f //x=80.78 //y=2.595
c357 ( 1 0 ) capacitor c=0.00657405f //x=80.78 //y=2.375
r358 (  122 123 ) resistor r=52.7279 //w=0.214 //l=0.165 //layer=ply \
 //thickness=0.18 //x=80.78 //y=2.26 //x2=80.78 //y2=2.095
r359 (  120 130 ) resistor r=45.1352 //w=0.168 //l=0.173853 //layer=ply \
 //thickness=0.18 //x=81.3 //y=1.44 //x2=81.26 //y2=1.595
r360 (  119 129 ) resistor r=45.1352 //w=0.168 //l=0.173853 //layer=ply \
 //thickness=0.18 //x=81.3 //y=1.095 //x2=81.26 //y2=0.94
r361 (  119 120 ) resistor r=176.904 //w=0.094 //l=0.345 //layer=ply \
 //thickness=0.18 //x=81.3 //y=1.095 //x2=81.3 //y2=1.44
r362 (  117 126 ) resistor r=10.701 //w=0.21 //l=0.115 //layer=ply \
 //thickness=0.18 //x=80.925 //y=1.595 //x2=80.81 //y2=1.595
r363 (  116 130 ) resistor r=5.52526 //w=0.168 //l=0.115 //layer=ply \
 //thickness=0.18 //x=81.145 //y=1.595 //x2=81.26 //y2=1.595
r364 (  115 125 ) resistor r=5.52526 //w=0.168 //l=0.115 //layer=ply \
 //thickness=0.18 //x=80.925 //y=0.94 //x2=80.81 //y2=0.94
r365 (  114 129 ) resistor r=5.52526 //w=0.168 //l=0.115 //layer=ply \
 //thickness=0.18 //x=81.145 //y=0.94 //x2=81.26 //y2=0.94
r366 (  114 115 ) resistor r=112.809 //w=0.094 //l=0.22 //layer=ply \
 //thickness=0.18 //x=81.145 //y=0.94 //x2=80.925 //y2=0.94
r367 (  111 128 ) resistor r=37.236 //w=0.233 //l=0.249199 //layer=ply \
 //thickness=0.18 //x=80.96 //y=5.045 //x2=80.78 //y2=4.88
r368 (  109 126 ) resistor r=39.5823 //w=0.21 //l=0.173853 //layer=ply \
 //thickness=0.18 //x=80.77 //y=1.75 //x2=80.81 //y2=1.595
r369 (  109 123 ) resistor r=176.904 //w=0.094 //l=0.345 //layer=ply \
 //thickness=0.18 //x=80.77 //y=1.75 //x2=80.77 //y2=2.095
r370 (  108 126 ) resistor r=39.5823 //w=0.21 //l=0.173853 //layer=ply \
 //thickness=0.18 //x=80.77 //y=1.44 //x2=80.81 //y2=1.595
r371 (  107 125 ) resistor r=45.1352 //w=0.168 //l=0.173853 //layer=ply \
 //thickness=0.18 //x=80.77 //y=1.095 //x2=80.81 //y2=0.94
r372 (  107 108 ) resistor r=176.904 //w=0.094 //l=0.345 //layer=ply \
 //thickness=0.18 //x=80.77 //y=1.095 //x2=80.77 //y2=1.44
r373 (  104 128 ) resistor r=53.7854 //w=0.233 //l=0.332415 //layer=ply \
 //thickness=0.18 //x=80.52 //y=5.045 //x2=80.78 //y2=4.88
r374 (  103 111 ) resistor r=592.245 //w=0.094 //l=1.155 //layer=ply \
 //thickness=0.18 //x=80.96 //y=6.2 //x2=80.96 //y2=5.045
r375 (  102 104 ) resistor r=592.245 //w=0.094 //l=1.155 //layer=ply \
 //thickness=0.18 //x=80.52 //y=6.2 //x2=80.52 //y2=5.045
r376 (  101 116 ) resistor r=56.4043 //w=0.094 //l=0.11 //layer=ply \
 //thickness=0.18 //x=81.035 //y=1.595 //x2=81.145 //y2=1.595
r377 (  101 117 ) resistor r=56.4043 //w=0.094 //l=0.11 //layer=ply \
 //thickness=0.18 //x=81.035 //y=1.595 //x2=80.925 //y2=1.595
r378 (  85 135 ) resistor r=23.615 //w=0.187 //l=0.345 //layer=li \
 //thickness=0.1 //x=85.55 //y=5.56 //x2=85.55 //y2=5.905
r379 (  77 134 ) resistor r=23.615 //w=0.187 //l=0.345 //layer=li \
 //thickness=0.1 //x=84.67 //y=5.56 //x2=84.67 //y2=5.905
r380 (  69 133 ) resistor r=23.615 //w=0.187 //l=0.345 //layer=li \
 //thickness=0.1 //x=83.79 //y=5.56 //x2=83.79 //y2=5.905
r381 (  64 128 ) resistor r=152 //w=0.17 //l=0.17 //layer=licon //count=1 \
 //x=80.78 //y=4.88 //x2=80.78 //y2=4.88
r382 (  55 122 ) resistor r=152 //w=0.17 //l=0.17 //layer=licon //count=1 \
 //x=80.78 //y=2.26 //x2=80.78 //y2=2.26
r383 (  49 51 ) resistor r=0.10734 //w=0.281 //l=0.16 //layer=m2 \
 //thickness=0.36 //x=80.77 //y=2.755 //x2=80.93 //y2=2.755
r384 (  46 53 ) resistor r=1.03378 //w=0.197 //l=1.63745 //layer=m2 \
 //thickness=0.36 //x=84.695 //y=2.76 //x2=86.32 //y2=2.785
r385 (  46 47 ) resistor r=0.410305 //w=0.131 //l=0.43 //layer=m2 \
 //thickness=0.36 //x=84.695 //y=2.76 //x2=84.265 //y2=2.76
r386 (  44 47 ) resistor r=0.125 //w=0.17 //l=0.174929 //layer=m2 \
 //thickness=0.36 //x=84.095 //y=2.77 //x2=84.265 //y2=2.76
r387 (  44 51 ) resistor r=3.02004 //w=0.131 //l=3.165 //layer=m2 \
 //thickness=0.36 //x=84.095 //y=2.77 //x2=80.93 //y2=2.77
r388 (  43 53 ) resistor r=4.5 //w=0.15 //l=0.15 //layer=via1 //count=1 \
 //x=86.32 //y=2.785 //x2=86.32 //y2=2.785
r389 (  41 43 ) resistor r=0.00505391 //w=0.371 //l=0.015 //layer=m1 \
 //thickness=0.36 //x=86.272 //y=2.77 //x2=86.272 //y2=2.785
r390 (  39 131 ) resistor r=9.3 //w=0.17 //l=0.17 //layer=mcon //count=1 \
 //x=85.845 //y=1.19 //x2=85.845 //y2=1.19
r391 (  37 85 ) resistor r=9.3 //w=0.17 //l=0.17 //layer=mcon //count=1 \
 //x=85.55 //y=5.56 //x2=85.55 //y2=5.56
r392 (  34 77 ) resistor r=9.3 //w=0.17 //l=0.17 //layer=mcon //count=1 \
 //x=84.67 //y=5.56 //x2=84.67 //y2=5.56
r393 (  32 34 ) resistor r=0.121228 //w=0.232 //l=0.225 //layer=m1 \
 //thickness=0.36 //x=84.67 //y=5.335 //x2=84.67 //y2=5.56
r394 (  31 69 ) resistor r=9.3 //w=0.17 //l=0.17 //layer=mcon //count=1 \
 //x=83.79 //y=5.56 //x2=83.79 //y2=5.56
r395 (  29 31 ) resistor r=0.129608 //w=0.217 //l=0.225 //layer=m1 \
 //thickness=0.36 //x=83.792 //y=5.335 //x2=83.792 //y2=5.56
r396 (  26 49 ) resistor r=4.5 //w=0.15 //l=0.15 //layer=via1 //count=1 \
 //x=80.77 //y=2.755 //x2=80.77 //y2=2.755
r397 (  26 28 ) resistor r=0.00490838 //w=0.382 //l=0.015 //layer=m1 \
 //thickness=0.36 //x=80.827 //y=2.755 //x2=80.827 //y2=2.77
r398 (  24 64 ) resistor r=9.3 //w=0.17 //l=0.17 //layer=mcon //count=1 \
 //x=80.78 //y=4.88 //x2=80.78 //y2=4.88
r399 (  22 55 ) resistor r=9.3 //w=0.17 //l=0.17 //layer=mcon //count=1 \
 //x=80.78 //y=2.26 //x2=80.78 //y2=2.26
r400 (  19 43 ) resistor r=0.0909648 //w=0.371 //l=0.186762 //layer=m1 \
 //thickness=0.36 //x=86.33 //y=2.945 //x2=86.272 //y2=2.785
r401 (  19 20 ) resistor r=2.19943 //w=0.131 //l=2.305 //layer=m1 \
 //thickness=0.36 //x=86.33 //y=2.945 //x2=86.33 //y2=5.25
r402 (  18 41 ) resistor r=0.0859108 //w=0.371 //l=0.171566 //layer=m1 \
 //thickness=0.36 //x=86.33 //y=2.625 //x2=86.272 //y2=2.77
r403 (  17 18 ) resistor r=0.663168 //w=0.131 //l=0.695 //layer=m1 \
 //thickness=0.36 //x=86.33 //y=1.93 //x2=86.33 //y2=2.625
r404 (  15 17 ) resistor r=0.0698411 //w=0.17 //l=0.120208 //layer=m1 \
 //thickness=0.36 //x=86.245 //y=1.845 //x2=86.33 //y2=1.93
r405 (  15 16 ) resistor r=0.300573 //w=0.131 //l=0.315 //layer=m1 \
 //thickness=0.36 //x=86.245 //y=1.845 //x2=85.93 //y2=1.845
r406 (  14 16 ) resistor r=0.0698411 //w=0.17 //l=0.120208 //layer=m1 \
 //thickness=0.36 //x=85.845 //y=1.76 //x2=85.93 //y2=1.845
r407 (  13 39 ) resistor r=0.0717383 //w=0.224 //l=0.115 //layer=m1 \
 //thickness=0.36 //x=85.845 //y=1.305 //x2=85.845 //y2=1.19
r408 (  13 14 ) resistor r=0.43416 //w=0.131 //l=0.455 //layer=m1 \
 //thickness=0.36 //x=85.845 //y=1.305 //x2=85.845 //y2=1.76
r409 (  12 35 ) resistor r=0.0675342 //w=0.23 //l=0.115 //layer=m1 \
 //thickness=0.36 //x=85.665 //y=5.335 //x2=85.55 //y2=5.335
r410 (  11 20 ) resistor r=0.0698411 //w=0.17 //l=0.120208 //layer=m1 \
 //thickness=0.36 //x=86.245 //y=5.335 //x2=86.33 //y2=5.25
r411 (  11 12 ) resistor r=0.553435 //w=0.131 //l=0.58 //layer=m1 \
 //thickness=0.36 //x=86.245 //y=5.335 //x2=85.665 //y2=5.335
r412 (  10 37 ) resistor r=0.00118313 //w=0.23 //layer=m1 //thickness=0.36 \
 //x=85.55 //y=5.56 //x2=85.55 //y2=5.56
r413 (  9 35 ) resistor r=0.002872 //w=0.34 //l=0.085 //layer=m1 \
 //thickness=0.36 //x=85.55 //y=5.42 //x2=85.55 //y2=5.335
r414 (  9 10 ) resistor r=0.091623 //w=0.191 //l=0.14 //layer=m1 \
 //thickness=0.36 //x=85.55 //y=5.42 //x2=85.55 //y2=5.56
r415 (  8 32 ) resistor r=0.0262263 //w=0.232 //l=0.12 //layer=m1 \
 //thickness=0.36 //x=84.79 //y=5.335 //x2=84.67 //y2=5.335
r416 (  7 35 ) resistor r=0.0675342 //w=0.23 //l=0.115 //layer=m1 \
 //thickness=0.36 //x=85.435 //y=5.335 //x2=85.55 //y2=5.335
r417 (  7 8 ) resistor r=0.615458 //w=0.131 //l=0.645 //layer=m1 \
 //thickness=0.36 //x=85.435 //y=5.335 //x2=84.79 //y2=5.335
r418 (  6 29 ) resistor r=0.0222262 //w=0.217 //l=0.118 //layer=m1 \
 //thickness=0.36 //x=83.91 //y=5.335 //x2=83.792 //y2=5.335
r419 (  5 32 ) resistor r=0.0262263 //w=0.232 //l=0.12 //layer=m1 \
 //thickness=0.36 //x=84.55 //y=5.335 //x2=84.67 //y2=5.335
r420 (  5 6 ) resistor r=0.610687 //w=0.131 //l=0.64 //layer=m1 \
 //thickness=0.36 //x=84.55 //y=5.335 //x2=83.91 //y2=5.335
r421 (  4 24 ) resistor r=0.0801089 //w=0.224 //l=0.13 //layer=m1 \
 //thickness=0.36 //x=80.78 //y=4.75 //x2=80.78 //y2=4.88
r422 (  3 28 ) resistor r=0.0864989 //w=0.382 //l=0.166853 //layer=m1 \
 //thickness=0.36 //x=80.78 //y=2.915 //x2=80.827 //y2=2.77
r423 (  3 4 ) resistor r=1.75095 //w=0.131 //l=1.835 //layer=m1 \
 //thickness=0.36 //x=80.78 //y=2.915 //x2=80.78 //y2=4.75
r424 (  2 26 ) resistor r=0.0914072 //w=0.382 //l=0.181989 //layer=m1 \
 //thickness=0.36 //x=80.78 //y=2.595 //x2=80.827 //y2=2.755
r425 (  1 22 ) resistor r=0.0719237 //w=0.222 //l=0.115 //layer=m1 \
 //thickness=0.36 //x=80.78 //y=2.375 //x2=80.78 //y2=2.26
r426 (  1 2 ) resistor r=0.209924 //w=0.131 //l=0.22 //layer=m1 \
 //thickness=0.36 //x=80.78 //y=2.375 //x2=80.78 //y2=2.595
ends PM_TMRDFFSNRNQNX1\%noxref_20

subckt PM_TMRDFFSNRNQNX1\%noxref_21 ( 1 3 6 7 9 10 11 12 14 15 16 17 18 19 20 \
 21 22 23 26 29 37 58 61 65 68 69 73 74 77 85 93 110 115 120 125 130 135 139 \
 140 141 142 143 144 145 146 147 148 149 150 151 152 154 160 161 162 163 170 \
 171 172 173 174 176 179 182 183 184 185 186 187 188 189 193 195 198 199 200 \
 201 222 229 231 232 233 )
c567 ( 229 0 ) capacitor c=0.00885916f //x=80.845 //y=1.095
c568 ( 222 0 ) capacitor c=0.0586737f //x=94.47 //y=2.26
c569 ( 201 0 ) capacitor c=0.0318956f //x=95.175 //y=1.39
c570 ( 200 0 ) capacitor c=0.0186809f //x=95.175 //y=1.045
c571 ( 199 0 ) capacitor c=0.0659968f //x=94.815 //y=4.975
c572 ( 198 0 ) capacitor c=0.0373387f //x=95.105 //y=4.975
c573 ( 195 0 ) capacitor c=0.0157936f //x=95.02 //y=1.545
c574 ( 193 0 ) capacitor c=0.0158553f //x=95.02 //y=0.89
c575 ( 189 0 ) capacitor c=0.0302441f //x=94.645 //y=2.095
c576 ( 188 0 ) capacitor c=0.0238107f //x=94.645 //y=1.7
c577 ( 187 0 ) capacitor c=0.0234359f //x=94.645 //y=1.39
c578 ( 186 0 ) capacitor c=0.0199332f //x=94.645 //y=1.045
c579 ( 185 0 ) capacitor c=0.0972519f //x=92.815 //y=2.095
c580 ( 184 0 ) capacitor c=0.0251353f //x=92.815 //y=1.74
c581 ( 183 0 ) capacitor c=0.0234318f //x=92.815 //y=1.43
c582 ( 182 0 ) capacitor c=0.0192547f //x=92.815 //y=1.085
c583 ( 179 0 ) capacitor c=0.0714656f //x=92.72 //y=5.05
c584 ( 176 0 ) capacitor c=0.0186579f //x=92.66 //y=1.585
c585 ( 174 0 ) capacitor c=0.0157803f //x=92.66 //y=0.93
c586 ( 173 0 ) capacitor c=0.0134011f //x=92.355 //y=4.975
c587 ( 172 0 ) capacitor c=0.0243282f //x=92.645 //y=4.975
c588 ( 171 0 ) capacitor c=0.0364928f //x=92.285 //y=1.43
c589 ( 170 0 ) capacitor c=0.0174823f //x=92.285 //y=1.085
c590 ( 163 0 ) capacitor c=0.0612936f //x=83.645 //y=4.97
c591 ( 162 0 ) capacitor c=0.0376642f //x=83.935 //y=4.97
c592 ( 161 0 ) capacitor c=0.0346489f //x=83.6 //y=1.4
c593 ( 160 0 ) capacitor c=0.018692f //x=83.6 //y=1.055
c594 ( 154 0 ) capacitor c=0.0137077f //x=83.445 //y=1.555
c595 ( 152 0 ) capacitor c=0.0158585f //x=83.445 //y=0.9
c596 ( 151 0 ) capacitor c=0.101556f //x=83.07 //y=2.095
c597 ( 150 0 ) capacitor c=0.0229444f //x=83.07 //y=1.71
c598 ( 149 0 ) capacitor c=0.0234359f //x=83.07 //y=1.4
c599 ( 148 0 ) capacitor c=0.019815f //x=83.07 //y=1.055
c600 ( 147 0 ) capacitor c=0.11081f //x=95.18 //y=6.205
c601 ( 146 0 ) capacitor c=0.154997f //x=94.74 //y=6.205
c602 ( 145 0 ) capacitor c=0.155934f //x=92.72 //y=6.205
c603 ( 144 0 ) capacitor c=0.110593f //x=92.28 //y=6.205
c604 ( 143 0 ) capacitor c=0.110208f //x=84.01 //y=6.2
c605 ( 142 0 ) capacitor c=0.158957f //x=83.57 //y=6.2
c606 ( 135 0 ) capacitor c=7.7962e-19 //x=94.47 //y=4.885
c607 ( 130 0 ) capacitor c=7.89145e-19 //x=94.47 //y=2.26
c608 ( 125 0 ) capacitor c=7.79163e-19 //x=92.99 //y=4.885
c609 ( 120 0 ) capacitor c=7.43216e-19 //x=92.99 //y=2.26
c610 ( 115 0 ) capacitor c=0.0014751f //x=83.37 //y=4.88
c611 ( 110 0 ) capacitor c=0.0012618f //x=83.37 //y=2.26
c612 ( 93 0 ) capacitor c=0.0293393f //x=80.74 //y=5.56
c613 ( 85 0 ) capacitor c=0.029137f //x=79.86 //y=5.56
c614 ( 77 0 ) capacitor c=0.0278099f //x=78.98 //y=5.56
c615 ( 74 0 ) capacitor c=0.0208859f //x=94.305 //y=2.27
c616 ( 73 0 ) capacitor c=0.00241177f //x=94.465 //y=2.27
c617 ( 69 0 ) capacitor c=0.00482391f //x=83.525 //y=2.385
c618 ( 68 0 ) capacitor c=0.0341094f //x=83.205 //y=2.385
c619 ( 65 0 ) capacitor c=0.00274939f //x=81.68 //y=2.385
c620 ( 61 0 ) capacitor c=0.00572072f //x=93.155 //y=2.26
c621 ( 58 0 ) capacitor c=0.233601f //x=92.835 //y=2.4
c622 ( 37 0 ) capacitor c=0.0140311f //x=81.52 //y=2.4
c623 ( 29 0 ) capacitor c=0.00107025f //x=80.74 //y=5.335
c624 ( 26 0 ) capacitor c=0.00778188f //x=79.86 //y=5.335
c625 ( 23 0 ) capacitor c=0.0111234f //x=78.982 //y=5.335
c626 ( 22 0 ) capacitor c=0.0783117f //x=94.47 //y=4.755
c627 ( 21 0 ) capacitor c=0.00995077f //x=94.47 //y=2.43
c628 ( 20 0 ) capacitor c=0.0863594f //x=92.99 //y=4.76
c629 ( 19 0 ) capacitor c=0.0102822f //x=92.99 //y=2.43
c630 ( 18 0 ) capacitor c=0.0761354f //x=83.37 //y=4.755
c631 ( 17 0 ) capacitor c=0.0127514f //x=83.37 //y=2.545
c632 ( 16 0 ) capacitor c=0.0769697f //x=81.52 //y=5.25
c633 ( 15 0 ) capacitor c=0.0131133f //x=81.52 //y=2.545
c634 ( 14 0 ) capacitor c=0.00947661f //x=81.52 //y=2.225
c635 ( 12 0 ) capacitor c=0.00481389f //x=81.12 //y=1.845
c636 ( 11 0 ) capacitor c=0.0139445f //x=81.435 //y=1.845
c637 ( 10 0 ) capacitor c=0.0167992f //x=81.035 //y=1.76
c638 ( 9 0 ) capacitor c=0.0111799f //x=81.035 //y=1.305
c639 ( 7 0 ) capacitor c=0.0235661f //x=81.435 //y=5.335
c640 ( 6 0 ) capacitor c=0.00933983f //x=80.74 //y=5.56
c641 ( 3 0 ) capacitor c=0.0195424f //x=80.625 //y=5.335
c642 ( 1 0 ) capacitor c=0.0151997f //x=79.74 //y=5.335
r643 (  201 228 ) resistor r=45.1352 //w=0.168 //l=0.173853 //layer=ply \
 //thickness=0.18 //x=95.175 //y=1.39 //x2=95.135 //y2=1.545
r644 (  200 227 ) resistor r=45.1352 //w=0.168 //l=0.173853 //layer=ply \
 //thickness=0.18 //x=95.175 //y=1.045 //x2=95.135 //y2=0.89
r645 (  200 201 ) resistor r=176.904 //w=0.094 //l=0.345 //layer=ply \
 //thickness=0.18 //x=95.175 //y=1.045 //x2=95.175 //y2=1.39
r646 (  198 202 ) resistor r=26.9307 //w=0.15 //l=0.106066 //layer=ply \
 //thickness=0.18 //x=95.105 //y=4.975 //x2=95.18 //y2=5.05
r647 (  198 199 ) resistor r=148.702 //w=0.094 //l=0.29 //layer=ply \
 //thickness=0.18 //x=95.105 //y=4.975 //x2=94.815 //y2=4.975
r648 (  196 226 ) resistor r=10.701 //w=0.21 //l=0.115 //layer=ply \
 //thickness=0.18 //x=94.8 //y=1.545 //x2=94.685 //y2=1.545
r649 (  195 228 ) resistor r=5.52526 //w=0.168 //l=0.115 //layer=ply \
 //thickness=0.18 //x=95.02 //y=1.545 //x2=95.135 //y2=1.545
r650 (  194 225 ) resistor r=5.52526 //w=0.168 //l=0.115 //layer=ply \
 //thickness=0.18 //x=94.8 //y=0.89 //x2=94.685 //y2=0.89
r651 (  193 227 ) resistor r=5.52526 //w=0.168 //l=0.115 //layer=ply \
 //thickness=0.18 //x=95.02 //y=0.89 //x2=95.135 //y2=0.89
r652 (  193 194 ) resistor r=112.809 //w=0.094 //l=0.22 //layer=ply \
 //thickness=0.18 //x=95.02 //y=0.89 //x2=94.8 //y2=0.89
r653 (  190 199 ) resistor r=22.1787 //w=0.252 //l=0.106066 //layer=ply \
 //thickness=0.18 //x=94.74 //y=5.05 //x2=94.815 //y2=4.975
r654 (  190 224 ) resistor r=51.6429 //w=0.252 //l=0.34271 //layer=ply \
 //thickness=0.18 //x=94.74 //y=5.05 //x2=94.47 //y2=4.885
r655 (  189 222 ) resistor r=30.4513 //w=0.277 //l=0.243926 //layer=ply \
 //thickness=0.18 //x=94.645 //y=2.095 //x2=94.47 //y2=2.26
r656 (  188 226 ) resistor r=39.5823 //w=0.21 //l=0.173853 //layer=ply \
 //thickness=0.18 //x=94.645 //y=1.7 //x2=94.685 //y2=1.545
r657 (  188 189 ) resistor r=202.543 //w=0.094 //l=0.395 //layer=ply \
 //thickness=0.18 //x=94.645 //y=1.7 //x2=94.645 //y2=2.095
r658 (  187 226 ) resistor r=39.5823 //w=0.21 //l=0.173853 //layer=ply \
 //thickness=0.18 //x=94.645 //y=1.39 //x2=94.685 //y2=1.545
r659 (  186 225 ) resistor r=45.1352 //w=0.168 //l=0.173853 //layer=ply \
 //thickness=0.18 //x=94.645 //y=1.045 //x2=94.685 //y2=0.89
r660 (  186 187 ) resistor r=176.904 //w=0.094 //l=0.345 //layer=ply \
 //thickness=0.18 //x=94.645 //y=1.045 //x2=94.645 //y2=1.39
r661 (  185 218 ) resistor r=30.4513 //w=0.277 //l=0.243926 //layer=ply \
 //thickness=0.18 //x=92.815 //y=2.095 //x2=92.99 //y2=2.26
r662 (  184 216 ) resistor r=39.5823 //w=0.21 //l=0.173853 //layer=ply \
 //thickness=0.18 //x=92.815 //y=1.74 //x2=92.775 //y2=1.585
r663 (  184 185 ) resistor r=182.032 //w=0.094 //l=0.355 //layer=ply \
 //thickness=0.18 //x=92.815 //y=1.74 //x2=92.815 //y2=2.095
r664 (  183 216 ) resistor r=39.5823 //w=0.21 //l=0.173853 //layer=ply \
 //thickness=0.18 //x=92.815 //y=1.43 //x2=92.775 //y2=1.585
r665 (  182 215 ) resistor r=45.1352 //w=0.168 //l=0.173853 //layer=ply \
 //thickness=0.18 //x=92.815 //y=1.085 //x2=92.775 //y2=0.93
r666 (  182 183 ) resistor r=176.904 //w=0.094 //l=0.345 //layer=ply \
 //thickness=0.18 //x=92.815 //y=1.085 //x2=92.815 //y2=1.43
r667 (  179 220 ) resistor r=51.6429 //w=0.252 //l=0.34271 //layer=ply \
 //thickness=0.18 //x=92.72 //y=5.05 //x2=92.99 //y2=4.885
r668 (  177 214 ) resistor r=5.52526 //w=0.168 //l=0.115 //layer=ply \
 //thickness=0.18 //x=92.44 //y=1.585 //x2=92.325 //y2=1.585
r669 (  176 216 ) resistor r=10.701 //w=0.21 //l=0.115 //layer=ply \
 //thickness=0.18 //x=92.66 //y=1.585 //x2=92.775 //y2=1.585
r670 (  175 213 ) resistor r=5.52526 //w=0.168 //l=0.115 //layer=ply \
 //thickness=0.18 //x=92.44 //y=0.93 //x2=92.325 //y2=0.93
r671 (  174 215 ) resistor r=5.52526 //w=0.168 //l=0.115 //layer=ply \
 //thickness=0.18 //x=92.66 //y=0.93 //x2=92.775 //y2=0.93
r672 (  174 175 ) resistor r=112.809 //w=0.094 //l=0.22 //layer=ply \
 //thickness=0.18 //x=92.66 //y=0.93 //x2=92.44 //y2=0.93
r673 (  172 179 ) resistor r=22.1787 //w=0.252 //l=0.106066 //layer=ply \
 //thickness=0.18 //x=92.645 //y=4.975 //x2=92.72 //y2=5.05
r674 (  172 173 ) resistor r=148.702 //w=0.094 //l=0.29 //layer=ply \
 //thickness=0.18 //x=92.645 //y=4.975 //x2=92.355 //y2=4.975
r675 (  171 214 ) resistor r=45.1352 //w=0.168 //l=0.173853 //layer=ply \
 //thickness=0.18 //x=92.285 //y=1.43 //x2=92.325 //y2=1.585
r676 (  170 213 ) resistor r=45.1352 //w=0.168 //l=0.173853 //layer=ply \
 //thickness=0.18 //x=92.285 //y=1.085 //x2=92.325 //y2=0.93
r677 (  170 171 ) resistor r=176.904 //w=0.094 //l=0.345 //layer=ply \
 //thickness=0.18 //x=92.285 //y=1.085 //x2=92.285 //y2=1.43
r678 (  167 173 ) resistor r=26.9307 //w=0.15 //l=0.106066 //layer=ply \
 //thickness=0.18 //x=92.28 //y=5.05 //x2=92.355 //y2=4.975
r679 (  162 164 ) resistor r=26.9307 //w=0.15 //l=0.106066 //layer=ply \
 //thickness=0.18 //x=83.935 //y=4.97 //x2=84.01 //y2=5.045
r680 (  162 163 ) resistor r=148.702 //w=0.094 //l=0.29 //layer=ply \
 //thickness=0.18 //x=83.935 //y=4.97 //x2=83.645 //y2=4.97
r681 (  161 212 ) resistor r=45.1352 //w=0.168 //l=0.173853 //layer=ply \
 //thickness=0.18 //x=83.6 //y=1.4 //x2=83.56 //y2=1.555
r682 (  160 211 ) resistor r=45.1352 //w=0.168 //l=0.173853 //layer=ply \
 //thickness=0.18 //x=83.6 //y=1.055 //x2=83.56 //y2=0.9
r683 (  160 161 ) resistor r=176.904 //w=0.094 //l=0.345 //layer=ply \
 //thickness=0.18 //x=83.6 //y=1.055 //x2=83.6 //y2=1.4
r684 (  157 163 ) resistor r=22.7971 //w=0.269 //l=0.106066 //layer=ply \
 //thickness=0.18 //x=83.57 //y=5.045 //x2=83.645 //y2=4.97
r685 (  157 210 ) resistor r=35.8364 //w=0.269 //l=0.270185 //layer=ply \
 //thickness=0.18 //x=83.57 //y=5.045 //x2=83.37 //y2=4.88
r686 (  155 206 ) resistor r=10.701 //w=0.21 //l=0.115 //layer=ply \
 //thickness=0.18 //x=83.225 //y=1.555 //x2=83.11 //y2=1.555
r687 (  154 212 ) resistor r=5.52526 //w=0.168 //l=0.115 //layer=ply \
 //thickness=0.18 //x=83.445 //y=1.555 //x2=83.56 //y2=1.555
r688 (  153 205 ) resistor r=5.52526 //w=0.168 //l=0.115 //layer=ply \
 //thickness=0.18 //x=83.225 //y=0.9 //x2=83.11 //y2=0.9
r689 (  152 211 ) resistor r=5.52526 //w=0.168 //l=0.115 //layer=ply \
 //thickness=0.18 //x=83.445 //y=0.9 //x2=83.56 //y2=0.9
r690 (  152 153 ) resistor r=112.809 //w=0.094 //l=0.22 //layer=ply \
 //thickness=0.18 //x=83.445 //y=0.9 //x2=83.225 //y2=0.9
r691 (  151 208 ) resistor r=58.7805 //w=0.246 //l=0.373497 //layer=ply \
 //thickness=0.18 //x=83.07 //y=2.095 //x2=83.37 //y2=2.26
r692 (  150 206 ) resistor r=39.5823 //w=0.21 //l=0.173853 //layer=ply \
 //thickness=0.18 //x=83.07 //y=1.71 //x2=83.11 //y2=1.555
r693 (  150 151 ) resistor r=197.415 //w=0.094 //l=0.385 //layer=ply \
 //thickness=0.18 //x=83.07 //y=1.71 //x2=83.07 //y2=2.095
r694 (  149 206 ) resistor r=39.5823 //w=0.21 //l=0.173853 //layer=ply \
 //thickness=0.18 //x=83.07 //y=1.4 //x2=83.11 //y2=1.555
r695 (  148 205 ) resistor r=45.1352 //w=0.168 //l=0.173853 //layer=ply \
 //thickness=0.18 //x=83.07 //y=1.055 //x2=83.11 //y2=0.9
r696 (  148 149 ) resistor r=176.904 //w=0.094 //l=0.345 //layer=ply \
 //thickness=0.18 //x=83.07 //y=1.055 //x2=83.07 //y2=1.4
r697 (  147 202 ) resistor r=592.245 //w=0.094 //l=1.155 //layer=ply \
 //thickness=0.18 //x=95.18 //y=6.205 //x2=95.18 //y2=5.05
r698 (  146 190 ) resistor r=592.245 //w=0.094 //l=1.155 //layer=ply \
 //thickness=0.18 //x=94.74 //y=6.205 //x2=94.74 //y2=5.05
r699 (  145 179 ) resistor r=592.245 //w=0.094 //l=1.155 //layer=ply \
 //thickness=0.18 //x=92.72 //y=6.205 //x2=92.72 //y2=5.05
r700 (  144 167 ) resistor r=592.245 //w=0.094 //l=1.155 //layer=ply \
 //thickness=0.18 //x=92.28 //y=6.205 //x2=92.28 //y2=5.05
r701 (  143 164 ) resistor r=592.245 //w=0.094 //l=1.155 //layer=ply \
 //thickness=0.18 //x=84.01 //y=6.2 //x2=84.01 //y2=5.045
r702 (  142 157 ) resistor r=592.245 //w=0.094 //l=1.155 //layer=ply \
 //thickness=0.18 //x=83.57 //y=6.2 //x2=83.57 //y2=5.045
r703 (  141 195 ) resistor r=56.4043 //w=0.094 //l=0.11 //layer=ply \
 //thickness=0.18 //x=94.91 //y=1.545 //x2=95.02 //y2=1.545
r704 (  141 196 ) resistor r=56.4043 //w=0.094 //l=0.11 //layer=ply \
 //thickness=0.18 //x=94.91 //y=1.545 //x2=94.8 //y2=1.545
r705 (  140 176 ) resistor r=56.4043 //w=0.094 //l=0.11 //layer=ply \
 //thickness=0.18 //x=92.55 //y=1.585 //x2=92.66 //y2=1.585
r706 (  140 177 ) resistor r=56.4043 //w=0.094 //l=0.11 //layer=ply \
 //thickness=0.18 //x=92.55 //y=1.585 //x2=92.44 //y2=1.585
r707 (  139 154 ) resistor r=56.4043 //w=0.094 //l=0.11 //layer=ply \
 //thickness=0.18 //x=83.335 //y=1.555 //x2=83.445 //y2=1.555
r708 (  139 155 ) resistor r=56.4043 //w=0.094 //l=0.11 //layer=ply \
 //thickness=0.18 //x=83.335 //y=1.555 //x2=83.225 //y2=1.555
r709 (  135 224 ) resistor r=152 //w=0.17 //l=0.17 //layer=licon //count=1 \
 //x=94.47 //y=4.885 //x2=94.47 //y2=4.885
r710 (  130 222 ) resistor r=152 //w=0.17 //l=0.17 //layer=licon //count=1 \
 //x=94.47 //y=2.26 //x2=94.47 //y2=2.26
r711 (  125 220 ) resistor r=152 //w=0.17 //l=0.17 //layer=licon //count=1 \
 //x=92.99 //y=4.885 //x2=92.99 //y2=4.885
r712 (  120 218 ) resistor r=152 //w=0.17 //l=0.17 //layer=licon //count=1 \
 //x=92.99 //y=2.26 //x2=92.99 //y2=2.26
r713 (  115 210 ) resistor r=152 //w=0.17 //l=0.17 //layer=licon //count=1 \
 //x=83.37 //y=4.88 //x2=83.37 //y2=4.88
r714 (  110 208 ) resistor r=152 //w=0.17 //l=0.17 //layer=licon //count=1 \
 //x=83.37 //y=2.26 //x2=83.37 //y2=2.26
r715 (  93 233 ) resistor r=23.615 //w=0.187 //l=0.345 //layer=li \
 //thickness=0.1 //x=80.74 //y=5.56 //x2=80.74 //y2=5.905
r716 (  85 232 ) resistor r=23.615 //w=0.187 //l=0.345 //layer=li \
 //thickness=0.1 //x=79.86 //y=5.56 //x2=79.86 //y2=5.905
r717 (  77 231 ) resistor r=23.615 //w=0.187 //l=0.345 //layer=li \
 //thickness=0.1 //x=78.98 //y=5.56 //x2=78.98 //y2=5.905
r718 (  73 74 ) resistor r=0.10734 //w=0.281 //l=0.16 //layer=m2 \
 //thickness=0.36 //x=94.465 //y=2.27 //x2=94.305 //y2=2.27
r719 (  67 69 ) resistor r=0.10734 //w=0.281 //l=0.16 //layer=m2 \
 //thickness=0.36 //x=83.365 //y=2.385 //x2=83.525 //y2=2.385
r720 (  67 68 ) resistor r=0.10734 //w=0.281 //l=0.16 //layer=m2 \
 //thickness=0.36 //x=83.365 //y=2.385 //x2=83.205 //y2=2.385
r721 (  65 68 ) resistor r=1.45515 //w=0.131 //l=1.525 //layer=m2 \
 //thickness=0.36 //x=81.68 //y=2.4 //x2=83.205 //y2=2.4
r722 (  63 65 ) resistor r=0.10734 //w=0.281 //l=0.16 //layer=m2 \
 //thickness=0.36 //x=81.52 //y=2.385 //x2=81.68 //y2=2.385
r723 (  61 71 ) resistor r=0.0908175 //w=0.367 //l=0.177539 //layer=m2 \
 //thickness=0.36 //x=93.155 //y=2.26 //x2=92.995 //y2=2.297
r724 (  61 74 ) resistor r=1.09733 //w=0.131 //l=1.15 //layer=m2 \
 //thickness=0.36 //x=93.155 //y=2.26 //x2=94.305 //y2=2.26
r725 (  58 71 ) resistor r=0.0908175 //w=0.367 //l=0.205134 //layer=m2 \
 //thickness=0.36 //x=92.835 //y=2.4 //x2=92.995 //y2=2.297
r726 (  58 69 ) resistor r=8.88359 //w=0.131 //l=9.31 //layer=m2 \
 //thickness=0.36 //x=92.835 //y=2.4 //x2=83.525 //y2=2.4
r727 (  55 135 ) resistor r=9.3 //w=0.17 //l=0.17 //layer=mcon //count=1 \
 //x=94.47 //y=4.885 //x2=94.47 //y2=4.885
r728 (  53 73 ) resistor r=4.5 //w=0.15 //l=0.15 //layer=via1 //count=1 \
 //x=94.465 //y=2.27 //x2=94.465 //y2=2.27
r729 (  51 130 ) resistor r=9.3 //w=0.17 //l=0.17 //layer=mcon //count=1 \
 //x=94.47 //y=2.26 //x2=94.47 //y2=2.26
r730 (  51 53 ) resistor r=0.00334225 //w=0.374 //l=0.01 //layer=m1 \
 //thickness=0.36 //x=94.415 //y=2.26 //x2=94.415 //y2=2.27
r731 (  49 71 ) resistor r=4.5 //w=0.15 //l=0.15 //layer=via1 //count=1 \
 //x=92.995 //y=2.27 //x2=92.995 //y2=2.27
r732 (  47 120 ) resistor r=9.3 //w=0.17 //l=0.17 //layer=mcon //count=1 \
 //x=92.99 //y=2.26 //x2=92.99 //y2=2.26
r733 (  47 49 ) resistor r=0.00334225 //w=0.374 //l=0.01 //layer=m1 \
 //thickness=0.36 //x=93.045 //y=2.26 //x2=93.045 //y2=2.27
r734 (  45 125 ) resistor r=9.3 //w=0.17 //l=0.17 //layer=mcon //count=1 \
 //x=92.99 //y=4.885 //x2=92.99 //y2=4.885
r735 (  43 67 ) resistor r=4.5 //w=0.15 //l=0.15 //layer=via1 //count=1 \
 //x=83.365 //y=2.385 //x2=83.365 //y2=2.385
r736 (  41 110 ) resistor r=9.3 //w=0.17 //l=0.17 //layer=mcon //count=1 \
 //x=83.37 //y=2.26 //x2=83.37 //y2=2.26
r737 (  41 43 ) resistor r=0.0540657 //w=0.289 //l=0.125 //layer=m1 \
 //thickness=0.36 //x=83.365 //y=2.26 //x2=83.365 //y2=2.385
r738 (  39 115 ) resistor r=9.3 //w=0.17 //l=0.17 //layer=mcon //count=1 \
 //x=83.37 //y=4.88 //x2=83.37 //y2=4.88
r739 (  35 63 ) resistor r=4.5 //w=0.15 //l=0.15 //layer=via1 //count=1 \
 //x=81.52 //y=2.385 //x2=81.52 //y2=2.385
r740 (  35 37 ) resistor r=0.0049867 //w=0.376 //l=0.015 //layer=m1 \
 //thickness=0.36 //x=81.572 //y=2.385 //x2=81.572 //y2=2.4
r741 (  33 229 ) resistor r=9.3 //w=0.17 //l=0.17 //layer=mcon //count=1 \
 //x=81.035 //y=1.19 //x2=81.035 //y2=1.19
r742 (  31 93 ) resistor r=9.3 //w=0.17 //l=0.17 //layer=mcon //count=1 \
 //x=80.74 //y=5.56 //x2=80.74 //y2=5.56
r743 (  28 85 ) resistor r=9.3 //w=0.17 //l=0.17 //layer=mcon //count=1 \
 //x=79.86 //y=5.56 //x2=79.86 //y2=5.56
r744 (  26 28 ) resistor r=0.121228 //w=0.232 //l=0.225 //layer=m1 \
 //thickness=0.36 //x=79.86 //y=5.335 //x2=79.86 //y2=5.56
r745 (  25 77 ) resistor r=9.3 //w=0.17 //l=0.17 //layer=mcon //count=1 \
 //x=78.98 //y=5.56 //x2=78.98 //y2=5.56
r746 (  23 25 ) resistor r=0.129608 //w=0.217 //l=0.225 //layer=m1 \
 //thickness=0.36 //x=78.982 //y=5.335 //x2=78.982 //y2=5.56
r747 (  22 55 ) resistor r=0.0777782 //w=0.252 //l=0.131491 //layer=m1 \
 //thickness=0.36 //x=94.47 //y=4.755 //x2=94.467 //y2=4.885
r748 (  21 53 ) resistor r=0.0910802 //w=0.374 //l=0.185472 //layer=m1 \
 //thickness=0.36 //x=94.47 //y=2.43 //x2=94.415 //y2=2.27
r749 (  21 22 ) resistor r=2.21851 //w=0.131 //l=2.325 //layer=m1 \
 //thickness=0.36 //x=94.47 //y=2.43 //x2=94.47 //y2=4.755
r750 (  20 45 ) resistor r=0.075298 //w=0.252 //l=0.125 //layer=m1 \
 //thickness=0.36 //x=92.99 //y=4.76 //x2=92.99 //y2=4.885
r751 (  19 49 ) resistor r=0.0910802 //w=0.374 //l=0.185472 //layer=m1 \
 //thickness=0.36 //x=92.99 //y=2.43 //x2=93.045 //y2=2.27
r752 (  19 20 ) resistor r=2.22328 //w=0.131 //l=2.33 //layer=m1 \
 //thickness=0.36 //x=92.99 //y=2.43 //x2=92.99 //y2=4.76
r753 (  18 39 ) resistor r=0.0760407 //w=0.238 //l=0.125 //layer=m1 \
 //thickness=0.36 //x=83.37 //y=4.755 //x2=83.37 //y2=4.88
r754 (  17 43 ) resistor r=0.0902229 //w=0.289 //l=0.162481 //layer=m1 \
 //thickness=0.36 //x=83.37 //y=2.545 //x2=83.365 //y2=2.385
r755 (  17 18 ) resistor r=2.10878 //w=0.131 //l=2.21 //layer=m1 \
 //thickness=0.36 //x=83.37 //y=2.545 //x2=83.37 //y2=4.755
r756 (  15 37 ) resistor r=0.0861726 //w=0.376 //l=0.169012 //layer=m1 \
 //thickness=0.36 //x=81.52 //y=2.545 //x2=81.572 //y2=2.4
r757 (  15 16 ) resistor r=2.58111 //w=0.131 //l=2.705 //layer=m1 \
 //thickness=0.36 //x=81.52 //y=2.545 //x2=81.52 //y2=5.25
r758 (  14 35 ) resistor r=0.0911593 //w=0.376 //l=0.184174 //layer=m1 \
 //thickness=0.36 //x=81.52 //y=2.225 //x2=81.572 //y2=2.385
r759 (  13 14 ) resistor r=0.281489 //w=0.131 //l=0.295 //layer=m1 \
 //thickness=0.36 //x=81.52 //y=1.93 //x2=81.52 //y2=2.225
r760 (  11 13 ) resistor r=0.0698411 //w=0.17 //l=0.120208 //layer=m1 \
 //thickness=0.36 //x=81.435 //y=1.845 //x2=81.52 //y2=1.93
r761 (  11 12 ) resistor r=0.300573 //w=0.131 //l=0.315 //layer=m1 \
 //thickness=0.36 //x=81.435 //y=1.845 //x2=81.12 //y2=1.845
r762 (  10 12 ) resistor r=0.0698411 //w=0.17 //l=0.120208 //layer=m1 \
 //thickness=0.36 //x=81.035 //y=1.76 //x2=81.12 //y2=1.845
r763 (  9 33 ) resistor r=0.0717383 //w=0.224 //l=0.115 //layer=m1 \
 //thickness=0.36 //x=81.035 //y=1.305 //x2=81.035 //y2=1.19
r764 (  9 10 ) resistor r=0.43416 //w=0.131 //l=0.455 //layer=m1 \
 //thickness=0.36 //x=81.035 //y=1.305 //x2=81.035 //y2=1.76
r765 (  8 29 ) resistor r=0.0675342 //w=0.23 //l=0.115 //layer=m1 \
 //thickness=0.36 //x=80.855 //y=5.335 //x2=80.74 //y2=5.335
r766 (  7 16 ) resistor r=0.0698411 //w=0.17 //l=0.120208 //layer=m1 \
 //thickness=0.36 //x=81.435 //y=5.335 //x2=81.52 //y2=5.25
r767 (  7 8 ) resistor r=0.553435 //w=0.131 //l=0.58 //layer=m1 \
 //thickness=0.36 //x=81.435 //y=5.335 //x2=80.855 //y2=5.335
r768 (  6 31 ) resistor r=0.00118313 //w=0.23 //layer=m1 //thickness=0.36 \
 //x=80.74 //y=5.56 //x2=80.74 //y2=5.56
r769 (  5 29 ) resistor r=0.002872 //w=0.34 //l=0.085 //layer=m1 \
 //thickness=0.36 //x=80.74 //y=5.42 //x2=80.74 //y2=5.335
r770 (  5 6 ) resistor r=0.091623 //w=0.191 //l=0.14 //layer=m1 \
 //thickness=0.36 //x=80.74 //y=5.42 //x2=80.74 //y2=5.56
r771 (  4 26 ) resistor r=0.0262263 //w=0.232 //l=0.12 //layer=m1 \
 //thickness=0.36 //x=79.98 //y=5.335 //x2=79.86 //y2=5.335
r772 (  3 29 ) resistor r=0.0675342 //w=0.23 //l=0.115 //layer=m1 \
 //thickness=0.36 //x=80.625 //y=5.335 //x2=80.74 //y2=5.335
r773 (  3 4 ) resistor r=0.615458 //w=0.131 //l=0.645 //layer=m1 \
 //thickness=0.36 //x=80.625 //y=5.335 //x2=79.98 //y2=5.335
r774 (  2 23 ) resistor r=0.0222262 //w=0.217 //l=0.118 //layer=m1 \
 //thickness=0.36 //x=79.1 //y=5.335 //x2=78.982 //y2=5.335
r775 (  1 26 ) resistor r=0.0262263 //w=0.232 //l=0.12 //layer=m1 \
 //thickness=0.36 //x=79.74 //y=5.335 //x2=79.86 //y2=5.335
r776 (  1 2 ) resistor r=0.610687 //w=0.131 //l=0.64 //layer=m1 \
 //thickness=0.36 //x=79.74 //y=5.335 //x2=79.1 //y2=5.335
ends PM_TMRDFFSNRNQNX1\%noxref_21

subckt PM_TMRDFFSNRNQNX1\%noxref_22 ( 1 3 6 7 9 10 11 12 14 15 16 17 18 19 20 \
 21 22 23 24 25 26 27 28 29 32 35 43 47 59 63 68 69 70 71 72 74 77 78 79 80 82 \
 84 87 88 89 90 92 94 96 98 100 102 104 107 118 119 122 130 138 155 164 169 \
 178 183 192 196 197 198 199 200 201 202 203 204 205 206 207 208 209 211 217 \
 218 219 220 224 225 226 231 233 235 241 242 243 244 245 250 252 254 260 261 \
 271 272 275 283 284 287 295 297 298 299 )
c743 ( 295 0 ) capacitor c=0.00885916f //x=51.985 //y=1.095
c744 ( 287 0 ) capacitor c=0.0370698f //x=95.6 //y=4.885
c745 ( 284 0 ) capacitor c=0.028421f //x=95.58 //y=2.095
c746 ( 283 0 ) capacitor c=0.0512002f //x=95.58 //y=2.26
c747 ( 275 0 ) capacitor c=0.0387879f //x=88.96 //y=4.885
c748 ( 272 0 ) capacitor c=0.0300885f //x=88.92 //y=2.095
c749 ( 271 0 ) capacitor c=0.0554483f //x=88.92 //y=2.26
c750 ( 261 0 ) capacitor c=0.0237734f //x=96.145 //y=1.435
c751 ( 260 0 ) capacitor c=0.0191782f //x=96.145 //y=1.085
c752 ( 254 0 ) capacitor c=0.0361171f //x=95.99 //y=1.585
c753 ( 252 0 ) capacitor c=0.0157803f //x=95.99 //y=0.93
c754 ( 250 0 ) capacitor c=0.0376354f //x=95.985 //y=4.975
c755 ( 245 0 ) capacitor c=0.020493f //x=95.615 //y=1.74
c756 ( 244 0 ) capacitor c=0.0167049f //x=95.615 //y=1.435
c757 ( 243 0 ) capacitor c=0.0174993f //x=95.615 //y=1.085
c758 ( 242 0 ) capacitor c=0.0443648f //x=89.485 //y=1.43
c759 ( 241 0 ) capacitor c=0.0192211f //x=89.485 //y=1.085
c760 ( 235 0 ) capacitor c=0.0186579f //x=89.33 //y=1.585
c761 ( 233 0 ) capacitor c=0.0157795f //x=89.33 //y=0.93
c762 ( 231 0 ) capacitor c=0.0351351f //x=89.325 //y=4.975
c763 ( 226 0 ) capacitor c=0.0209124f //x=88.955 //y=1.74
c764 ( 225 0 ) capacitor c=0.016848f //x=88.955 //y=1.43
c765 ( 224 0 ) capacitor c=0.0174777f //x=88.955 //y=1.085
c766 ( 220 0 ) capacitor c=0.0612936f //x=54.785 //y=4.97
c767 ( 219 0 ) capacitor c=0.0376642f //x=55.075 //y=4.97
c768 ( 218 0 ) capacitor c=0.0346489f //x=54.74 //y=1.4
c769 ( 217 0 ) capacitor c=0.018692f //x=54.74 //y=1.055
c770 ( 211 0 ) capacitor c=0.0137077f //x=54.585 //y=1.555
c771 ( 209 0 ) capacitor c=0.0158585f //x=54.585 //y=0.9
c772 ( 208 0 ) capacitor c=0.101017f //x=54.21 //y=2.095
c773 ( 207 0 ) capacitor c=0.0229444f //x=54.21 //y=1.71
c774 ( 206 0 ) capacitor c=0.0234359f //x=54.21 //y=1.4
c775 ( 205 0 ) capacitor c=0.019815f //x=54.21 //y=1.055
c776 ( 204 0 ) capacitor c=0.155887f //x=96.06 //y=6.205
c777 ( 203 0 ) capacitor c=0.1106f //x=95.62 //y=6.205
c778 ( 202 0 ) capacitor c=0.154859f //x=89.4 //y=6.205
c779 ( 201 0 ) capacitor c=0.110573f //x=88.96 //y=6.205
c780 ( 200 0 ) capacitor c=0.110208f //x=55.15 //y=6.2
c781 ( 199 0 ) capacitor c=0.158957f //x=54.71 //y=6.2
c782 ( 192 0 ) capacitor c=8.10734e-19 //x=95.6 //y=4.885
c783 ( 183 0 ) capacitor c=0.00105273f //x=95.58 //y=2.26
c784 ( 178 0 ) capacitor c=0.00173056f //x=88.96 //y=4.885
c785 ( 169 0 ) capacitor c=0.00152737f //x=88.92 //y=2.26
c786 ( 164 0 ) capacitor c=0.0014751f //x=54.51 //y=4.88
c787 ( 155 0 ) capacitor c=0.0012618f //x=54.51 //y=2.26
c788 ( 138 0 ) capacitor c=0.0293393f //x=51.88 //y=5.56
c789 ( 130 0 ) capacitor c=0.029137f //x=51 //y=5.56
c790 ( 122 0 ) capacitor c=0.0278099f //x=50.12 //y=5.56
c791 ( 119 0 ) capacitor c=0.162165f //x=95.435 //y=4.21
c792 ( 118 0 ) capacitor c=0.00479868f //x=95.595 //y=4.21
c793 ( 107 0 ) capacitor c=0.0165817f //x=89.08 //y=4.252
c794 ( 104 0 ) capacitor c=0.00498823f //x=88.03 //y=4.235
c795 ( 102 0 ) capacitor c=0.0289344f //x=87.43 //y=4.25
c796 ( 100 0 ) capacitor c=0.00458125f //x=85.805 //y=4.27
c797 ( 98 0 ) capacitor c=0.0828724f //x=85.205 //y=4.25
c798 ( 96 0 ) capacitor c=0.00430603f //x=76.915 //y=4.28
c799 ( 94 0 ) capacitor c=0.0496118f //x=76.315 //y=4.25
c800 ( 92 0 ) capacitor c=0.00434239f //x=71.375 //y=4.31
c801 ( 90 0 ) capacitor c=0.045907f //x=66.565 //y=4.28
c802 ( 89 0 ) capacitor c=0.00292689f //x=65.695 //y=4.25
c803 ( 88 0 ) capacitor c=0.00782061f //x=65.965 //y=4.25
c804 ( 87 0 ) capacitor c=0.00460873f //x=65.61 //y=4.165
c805 ( 84 0 ) capacitor c=0.0520408f //x=61.765 //y=3.9
c806 ( 82 0 ) capacitor c=0.0223033f //x=61.165 //y=3.88
c807 ( 80 0 ) capacitor c=0.00763326f //x=59.525 //y=3.85
c808 ( 79 0 ) capacitor c=1.50195e-19 //x=57.555 //y=3.88
c809 ( 78 0 ) capacitor c=0.0262859f //x=58.925 //y=3.88
c810 ( 74 0 ) capacitor c=0.00724477f //x=56.95 //y=3.5
c811 ( 72 0 ) capacitor c=0.00530231f //x=56.345 //y=3.51
c812 ( 71 0 ) capacitor c=0.00860398f //x=55.49 //y=3.53
c813 ( 70 0 ) capacitor c=0.00334703f //x=55.835 //y=3.53
c814 ( 69 0 ) capacitor c=6.63294e-19 //x=52.815 //y=3.51
c815 ( 68 0 ) capacitor c=0.0193329f //x=54.345 //y=3.51
c816 ( 63 0 ) capacitor c=0.0139164f //x=95.58 //y=4.25
c817 ( 59 0 ) capacitor c=0.0153807f //x=88.92 //y=4.25
c818 ( 47 0 ) capacitor c=0.0171627f //x=54.51 //y=3.51
c819 ( 43 0 ) capacitor c=0.0178187f //x=52.66 //y=3.51
c820 ( 35 0 ) capacitor c=0.00164584f //x=51.88 //y=5.335
c821 ( 32 0 ) capacitor c=0.00784028f //x=51 //y=5.335
c822 ( 29 0 ) capacitor c=0.0102231f //x=50.122 //y=5.335
c823 ( 28 0 ) capacitor c=0.0124358f //x=95.58 //y=4.74
c824 ( 27 0 ) capacitor c=0.0108569f //x=95.58 //y=4.37
c825 ( 26 0 ) capacitor c=0.0498276f //x=95.58 //y=4.05
c826 ( 25 0 ) capacitor c=0.00651439f //x=95.58 //y=2.38
c827 ( 24 0 ) capacitor c=0.0169891f //x=88.92 //y=4.71
c828 ( 23 0 ) capacitor c=0.0132636f //x=88.92 //y=4.365
c829 ( 22 0 ) capacitor c=0.0651938f //x=88.92 //y=4.045
c830 ( 21 0 ) capacitor c=0.00716889f //x=88.92 //y=2.375
c831 ( 20 0 ) capacitor c=0.0383076f //x=54.51 //y=4.755
c832 ( 19 0 ) capacitor c=0.0139769f //x=54.51 //y=3.655
c833 ( 18 0 ) capacitor c=0.0265366f //x=54.51 //y=3.365
c834 ( 17 0 ) capacitor c=0.00495287f //x=54.51 //y=2.375
c835 ( 16 0 ) capacitor c=0.0446391f //x=52.66 //y=5.25
c836 ( 15 0 ) capacitor c=0.0128677f //x=52.66 //y=3.655
c837 ( 14 0 ) capacitor c=0.0369704f //x=52.66 //y=3.365
c838 ( 12 0 ) capacitor c=0.00432784f //x=52.26 //y=1.845
c839 ( 11 0 ) capacitor c=0.0132749f //x=52.575 //y=1.845
c840 ( 10 0 ) capacitor c=0.0167992f //x=52.175 //y=1.76
c841 ( 9 0 ) capacitor c=0.011044f //x=52.175 //y=1.305
c842 ( 7 0 ) capacitor c=0.0261778f //x=52.575 //y=5.335
c843 ( 6 0 ) capacitor c=0.00933983f //x=51.88 //y=5.56
c844 ( 3 0 ) capacitor c=0.0175228f //x=51.765 //y=5.335
c845 ( 1 0 ) capacitor c=0.0164161f //x=50.88 //y=5.335
r846 (  289 290 ) resistor r=32.4568 //w=0.214 //l=0.075 //layer=ply \
 //thickness=0.18 //x=95.6 //y=4.975 //x2=95.6 //y2=5.05
r847 (  287 289 ) resistor r=20.271 //w=0.214 //l=0.09 //layer=ply \
 //thickness=0.18 //x=95.6 //y=4.885 //x2=95.6 //y2=4.975
r848 (  283 284 ) resistor r=52.7279 //w=0.214 //l=0.165 //layer=ply \
 //thickness=0.18 //x=95.58 //y=2.26 //x2=95.58 //y2=2.095
r849 (  275 277 ) resistor r=20.271 //w=0.214 //l=0.09 //layer=ply \
 //thickness=0.18 //x=88.96 //y=4.885 //x2=88.96 //y2=4.975
r850 (  271 272 ) resistor r=52.7279 //w=0.214 //l=0.165 //layer=ply \
 //thickness=0.18 //x=88.92 //y=2.26 //x2=88.92 //y2=2.095
r851 (  261 294 ) resistor r=4.95774 //w=0.164 //l=0.112 //layer=ply \
 //thickness=0.18 //x=96.145 //y=1.435 //x2=96.145 //y2=1.547
r852 (  260 293 ) resistor r=45.1352 //w=0.168 //l=0.173853 //layer=ply \
 //thickness=0.18 //x=96.145 //y=1.085 //x2=96.105 //y2=0.93
r853 (  260 261 ) resistor r=179.468 //w=0.094 //l=0.35 //layer=ply \
 //thickness=0.18 //x=96.145 //y=1.085 //x2=96.145 //y2=1.435
r854 (  255 292 ) resistor r=10.8103 //w=0.211 //l=0.115 //layer=ply \
 //thickness=0.18 //x=95.77 //y=1.585 //x2=95.655 //y2=1.585
r855 (  254 294 ) resistor r=45.9962 //w=0.164 //l=0.17296 //layer=ply \
 //thickness=0.18 //x=95.99 //y=1.585 //x2=96.145 //y2=1.547
r856 (  253 291 ) resistor r=5.52526 //w=0.168 //l=0.115 //layer=ply \
 //thickness=0.18 //x=95.77 //y=0.93 //x2=95.655 //y2=0.93
r857 (  252 293 ) resistor r=5.52526 //w=0.168 //l=0.115 //layer=ply \
 //thickness=0.18 //x=95.99 //y=0.93 //x2=96.105 //y2=0.93
r858 (  252 253 ) resistor r=112.809 //w=0.094 //l=0.22 //layer=ply \
 //thickness=0.18 //x=95.99 //y=0.93 //x2=95.77 //y2=0.93
r859 (  251 289 ) resistor r=16.5046 //w=0.27 //l=0.135 //layer=ply \
 //thickness=0.18 //x=95.735 //y=4.975 //x2=95.6 //y2=4.975
r860 (  250 257 ) resistor r=26.9307 //w=0.15 //l=0.106066 //layer=ply \
 //thickness=0.18 //x=95.985 //y=4.975 //x2=96.06 //y2=5.05
r861 (  250 251 ) resistor r=128.191 //w=0.094 //l=0.25 //layer=ply \
 //thickness=0.18 //x=95.985 //y=4.975 //x2=95.735 //y2=4.975
r862 (  245 292 ) resistor r=39.5036 //w=0.211 //l=0.173853 //layer=ply \
 //thickness=0.18 //x=95.615 //y=1.74 //x2=95.655 //y2=1.585
r863 (  245 284 ) resistor r=182.032 //w=0.094 //l=0.355 //layer=ply \
 //thickness=0.18 //x=95.615 //y=1.74 //x2=95.615 //y2=2.095
r864 (  244 292 ) resistor r=38.3614 //w=0.211 //l=0.168819 //layer=ply \
 //thickness=0.18 //x=95.615 //y=1.435 //x2=95.655 //y2=1.585
r865 (  243 291 ) resistor r=45.1352 //w=0.168 //l=0.173853 //layer=ply \
 //thickness=0.18 //x=95.615 //y=1.085 //x2=95.655 //y2=0.93
r866 (  243 244 ) resistor r=179.468 //w=0.094 //l=0.35 //layer=ply \
 //thickness=0.18 //x=95.615 //y=1.085 //x2=95.615 //y2=1.435
r867 (  242 281 ) resistor r=45.1352 //w=0.168 //l=0.173853 //layer=ply \
 //thickness=0.18 //x=89.485 //y=1.43 //x2=89.445 //y2=1.585
r868 (  241 280 ) resistor r=45.1352 //w=0.168 //l=0.173853 //layer=ply \
 //thickness=0.18 //x=89.485 //y=1.085 //x2=89.445 //y2=0.93
r869 (  241 242 ) resistor r=176.904 //w=0.094 //l=0.345 //layer=ply \
 //thickness=0.18 //x=89.485 //y=1.085 //x2=89.485 //y2=1.43
r870 (  236 279 ) resistor r=10.701 //w=0.21 //l=0.115 //layer=ply \
 //thickness=0.18 //x=89.11 //y=1.585 //x2=88.995 //y2=1.585
r871 (  235 281 ) resistor r=5.52526 //w=0.168 //l=0.115 //layer=ply \
 //thickness=0.18 //x=89.33 //y=1.585 //x2=89.445 //y2=1.585
r872 (  234 278 ) resistor r=5.52526 //w=0.168 //l=0.115 //layer=ply \
 //thickness=0.18 //x=89.11 //y=0.93 //x2=88.995 //y2=0.93
r873 (  233 280 ) resistor r=5.52526 //w=0.168 //l=0.115 //layer=ply \
 //thickness=0.18 //x=89.33 //y=0.93 //x2=89.445 //y2=0.93
r874 (  233 234 ) resistor r=112.809 //w=0.094 //l=0.22 //layer=ply \
 //thickness=0.18 //x=89.33 //y=0.93 //x2=89.11 //y2=0.93
r875 (  232 277 ) resistor r=16.5046 //w=0.27 //l=0.135 //layer=ply \
 //thickness=0.18 //x=89.095 //y=4.975 //x2=88.96 //y2=4.975
r876 (  231 238 ) resistor r=26.9307 //w=0.15 //l=0.106066 //layer=ply \
 //thickness=0.18 //x=89.325 //y=4.975 //x2=89.4 //y2=5.05
r877 (  231 232 ) resistor r=117.936 //w=0.094 //l=0.23 //layer=ply \
 //thickness=0.18 //x=89.325 //y=4.975 //x2=89.095 //y2=4.975
r878 (  228 277 ) resistor r=32.4568 //w=0.214 //l=0.075 //layer=ply \
 //thickness=0.18 //x=88.96 //y=5.05 //x2=88.96 //y2=4.975
r879 (  226 279 ) resistor r=39.5823 //w=0.21 //l=0.173853 //layer=ply \
 //thickness=0.18 //x=88.955 //y=1.74 //x2=88.995 //y2=1.585
r880 (  226 272 ) resistor r=182.032 //w=0.094 //l=0.355 //layer=ply \
 //thickness=0.18 //x=88.955 //y=1.74 //x2=88.955 //y2=2.095
r881 (  225 279 ) resistor r=39.5823 //w=0.21 //l=0.173853 //layer=ply \
 //thickness=0.18 //x=88.955 //y=1.43 //x2=88.995 //y2=1.585
r882 (  224 278 ) resistor r=45.1352 //w=0.168 //l=0.173853 //layer=ply \
 //thickness=0.18 //x=88.955 //y=1.085 //x2=88.995 //y2=0.93
r883 (  224 225 ) resistor r=176.904 //w=0.094 //l=0.345 //layer=ply \
 //thickness=0.18 //x=88.955 //y=1.085 //x2=88.955 //y2=1.43
r884 (  219 221 ) resistor r=26.9307 //w=0.15 //l=0.106066 //layer=ply \
 //thickness=0.18 //x=55.075 //y=4.97 //x2=55.15 //y2=5.045
r885 (  219 220 ) resistor r=148.702 //w=0.094 //l=0.29 //layer=ply \
 //thickness=0.18 //x=55.075 //y=4.97 //x2=54.785 //y2=4.97
r886 (  218 269 ) resistor r=45.1352 //w=0.168 //l=0.173853 //layer=ply \
 //thickness=0.18 //x=54.74 //y=1.4 //x2=54.7 //y2=1.555
r887 (  217 268 ) resistor r=45.1352 //w=0.168 //l=0.173853 //layer=ply \
 //thickness=0.18 //x=54.74 //y=1.055 //x2=54.7 //y2=0.9
r888 (  217 218 ) resistor r=176.904 //w=0.094 //l=0.345 //layer=ply \
 //thickness=0.18 //x=54.74 //y=1.055 //x2=54.74 //y2=1.4
r889 (  214 220 ) resistor r=22.7971 //w=0.269 //l=0.106066 //layer=ply \
 //thickness=0.18 //x=54.71 //y=5.045 //x2=54.785 //y2=4.97
r890 (  214 267 ) resistor r=35.8364 //w=0.269 //l=0.270185 //layer=ply \
 //thickness=0.18 //x=54.71 //y=5.045 //x2=54.51 //y2=4.88
r891 (  212 263 ) resistor r=10.701 //w=0.21 //l=0.115 //layer=ply \
 //thickness=0.18 //x=54.365 //y=1.555 //x2=54.25 //y2=1.555
r892 (  211 269 ) resistor r=5.52526 //w=0.168 //l=0.115 //layer=ply \
 //thickness=0.18 //x=54.585 //y=1.555 //x2=54.7 //y2=1.555
r893 (  210 262 ) resistor r=5.52526 //w=0.168 //l=0.115 //layer=ply \
 //thickness=0.18 //x=54.365 //y=0.9 //x2=54.25 //y2=0.9
r894 (  209 268 ) resistor r=5.52526 //w=0.168 //l=0.115 //layer=ply \
 //thickness=0.18 //x=54.585 //y=0.9 //x2=54.7 //y2=0.9
r895 (  209 210 ) resistor r=112.809 //w=0.094 //l=0.22 //layer=ply \
 //thickness=0.18 //x=54.585 //y=0.9 //x2=54.365 //y2=0.9
r896 (  208 265 ) resistor r=58.7805 //w=0.246 //l=0.373497 //layer=ply \
 //thickness=0.18 //x=54.21 //y=2.095 //x2=54.51 //y2=2.26
r897 (  207 263 ) resistor r=39.5823 //w=0.21 //l=0.173853 //layer=ply \
 //thickness=0.18 //x=54.21 //y=1.71 //x2=54.25 //y2=1.555
r898 (  207 208 ) resistor r=197.415 //w=0.094 //l=0.385 //layer=ply \
 //thickness=0.18 //x=54.21 //y=1.71 //x2=54.21 //y2=2.095
r899 (  206 263 ) resistor r=39.5823 //w=0.21 //l=0.173853 //layer=ply \
 //thickness=0.18 //x=54.21 //y=1.4 //x2=54.25 //y2=1.555
r900 (  205 262 ) resistor r=45.1352 //w=0.168 //l=0.173853 //layer=ply \
 //thickness=0.18 //x=54.21 //y=1.055 //x2=54.25 //y2=0.9
r901 (  205 206 ) resistor r=176.904 //w=0.094 //l=0.345 //layer=ply \
 //thickness=0.18 //x=54.21 //y=1.055 //x2=54.21 //y2=1.4
r902 (  204 257 ) resistor r=592.245 //w=0.094 //l=1.155 //layer=ply \
 //thickness=0.18 //x=96.06 //y=6.205 //x2=96.06 //y2=5.05
r903 (  203 290 ) resistor r=592.245 //w=0.094 //l=1.155 //layer=ply \
 //thickness=0.18 //x=95.62 //y=6.205 //x2=95.62 //y2=5.05
r904 (  202 238 ) resistor r=592.245 //w=0.094 //l=1.155 //layer=ply \
 //thickness=0.18 //x=89.4 //y=6.205 //x2=89.4 //y2=5.05
r905 (  201 228 ) resistor r=592.245 //w=0.094 //l=1.155 //layer=ply \
 //thickness=0.18 //x=88.96 //y=6.205 //x2=88.96 //y2=5.05
r906 (  200 221 ) resistor r=592.245 //w=0.094 //l=1.155 //layer=ply \
 //thickness=0.18 //x=55.15 //y=6.2 //x2=55.15 //y2=5.045
r907 (  199 214 ) resistor r=592.245 //w=0.094 //l=1.155 //layer=ply \
 //thickness=0.18 //x=54.71 //y=6.2 //x2=54.71 //y2=5.045
r908 (  198 254 ) resistor r=56.4043 //w=0.094 //l=0.11 //layer=ply \
 //thickness=0.18 //x=95.88 //y=1.585 //x2=95.99 //y2=1.585
r909 (  198 255 ) resistor r=56.4043 //w=0.094 //l=0.11 //layer=ply \
 //thickness=0.18 //x=95.88 //y=1.585 //x2=95.77 //y2=1.585
r910 (  197 235 ) resistor r=56.4043 //w=0.094 //l=0.11 //layer=ply \
 //thickness=0.18 //x=89.22 //y=1.585 //x2=89.33 //y2=1.585
r911 (  197 236 ) resistor r=56.4043 //w=0.094 //l=0.11 //layer=ply \
 //thickness=0.18 //x=89.22 //y=1.585 //x2=89.11 //y2=1.585
r912 (  196 211 ) resistor r=56.4043 //w=0.094 //l=0.11 //layer=ply \
 //thickness=0.18 //x=54.475 //y=1.555 //x2=54.585 //y2=1.555
r913 (  196 212 ) resistor r=56.4043 //w=0.094 //l=0.11 //layer=ply \
 //thickness=0.18 //x=54.475 //y=1.555 //x2=54.365 //y2=1.555
r914 (  192 287 ) resistor r=152 //w=0.17 //l=0.17 //layer=licon //count=1 \
 //x=95.6 //y=4.885 //x2=95.6 //y2=4.885
r915 (  183 283 ) resistor r=152 //w=0.17 //l=0.17 //layer=licon //count=1 \
 //x=95.58 //y=2.26 //x2=95.58 //y2=2.26
r916 (  178 275 ) resistor r=152 //w=0.17 //l=0.17 //layer=licon //count=1 \
 //x=88.96 //y=4.885 //x2=88.96 //y2=4.885
r917 (  169 271 ) resistor r=152 //w=0.17 //l=0.17 //layer=licon //count=1 \
 //x=88.92 //y=2.26 //x2=88.92 //y2=2.26
r918 (  164 267 ) resistor r=152 //w=0.17 //l=0.17 //layer=licon //count=1 \
 //x=54.51 //y=4.88 //x2=54.51 //y2=4.88
r919 (  155 265 ) resistor r=152 //w=0.17 //l=0.17 //layer=licon //count=1 \
 //x=54.51 //y=2.26 //x2=54.51 //y2=2.26
r920 (  138 299 ) resistor r=23.615 //w=0.187 //l=0.345 //layer=li \
 //thickness=0.1 //x=51.88 //y=5.56 //x2=51.88 //y2=5.905
r921 (  130 298 ) resistor r=23.615 //w=0.187 //l=0.345 //layer=li \
 //thickness=0.1 //x=51 //y=5.56 //x2=51 //y2=5.905
r922 (  122 297 ) resistor r=23.615 //w=0.187 //l=0.345 //layer=li \
 //thickness=0.1 //x=50.12 //y=5.56 //x2=50.12 //y2=5.905
r923 (  118 119 ) resistor r=0.104807 //w=0.281 //l=0.16 //layer=m2 \
 //thickness=0.36 //x=95.595 //y=4.21 //x2=95.435 //y2=4.21
r924 (  107 116 ) resistor r=0.0974628 //w=0.216 //l=0.181989 //layer=m2 \
 //thickness=0.36 //x=89.08 //y=4.252 //x2=88.92 //y2=4.205
r925 (  107 119 ) resistor r=5.84099 //w=0.136 //l=6.355 //layer=m2 \
 //thickness=0.36 //x=89.08 //y=4.252 //x2=95.435 //y2=4.252
r926 (  104 116 ) resistor r=0.521062 //w=0.216 //l=0.904876 //layer=m2 \
 //thickness=0.36 //x=88.03 //y=4.235 //x2=88.92 //y2=4.205
r927 (  104 105 ) resistor r=0.410305 //w=0.131 //l=0.43 //layer=m2 \
 //thickness=0.36 //x=88.03 //y=4.235 //x2=87.6 //y2=4.235
r928 (  102 105 ) resistor r=0.125 //w=0.17 //l=0.177341 //layer=m2 \
 //thickness=0.36 //x=87.43 //y=4.25 //x2=87.6 //y2=4.235
r929 (  102 103 ) resistor r=1.38836 //w=0.131 //l=1.455 //layer=m2 \
 //thickness=0.36 //x=87.43 //y=4.25 //x2=85.975 //y2=4.25
r930 (  100 103 ) resistor r=0.125 //w=0.17 //l=0.179722 //layer=m2 \
 //thickness=0.36 //x=85.805 //y=4.27 //x2=85.975 //y2=4.25
r931 (  100 101 ) resistor r=0.329198 //w=0.131 //l=0.345 //layer=m2 \
 //thickness=0.36 //x=85.805 //y=4.27 //x2=85.46 //y2=4.27
r932 (  98 101 ) resistor r=0.1875 //w=0.17 //l=0.264811 //layer=m2 \
 //thickness=0.36 //x=85.205 //y=4.25 //x2=85.46 //y2=4.27
r933 (  98 99 ) resistor r=7.74809 //w=0.131 //l=8.12 //layer=m2 \
 //thickness=0.36 //x=85.205 //y=4.25 //x2=77.085 //y2=4.25
r934 (  96 99 ) resistor r=0.125 //w=0.17 //l=0.184391 //layer=m2 \
 //thickness=0.36 //x=76.915 //y=4.28 //x2=77.085 //y2=4.25
r935 (  96 97 ) resistor r=0.329198 //w=0.131 //l=0.345 //layer=m2 \
 //thickness=0.36 //x=76.915 //y=4.28 //x2=76.57 //y2=4.28
r936 (  94 97 ) resistor r=0.1875 //w=0.17 //l=0.269583 //layer=m2 \
 //thickness=0.36 //x=76.315 //y=4.25 //x2=76.57 //y2=4.28
r937 (  94 95 ) resistor r=4.49905 //w=0.131 //l=4.715 //layer=m2 \
 //thickness=0.36 //x=76.315 //y=4.25 //x2=71.6 //y2=4.25
r938 (  92 95 ) resistor r=0.14881 //w=0.189 //l=0.253229 //layer=m2 \
 //thickness=0.36 //x=71.375 //y=4.31 //x2=71.6 //y2=4.25
r939 (  92 93 ) resistor r=0.329198 //w=0.131 //l=0.345 //layer=m2 \
 //thickness=0.36 //x=71.375 //y=4.31 //x2=71.03 //y2=4.31
r940 (  90 93 ) resistor r=3.26389 //w=0.171 //l=4.47998 //layer=m2 \
 //thickness=0.36 //x=66.565 //y=4.28 //x2=71.03 //y2=4.31
r941 (  90 91 ) resistor r=0.329198 //w=0.131 //l=0.345 //layer=m2 \
 //thickness=0.36 //x=66.565 //y=4.28 //x2=66.22 //y2=4.28
r942 (  88 91 ) resistor r=0.1875 //w=0.17 //l=0.269583 //layer=m2 \
 //thickness=0.36 //x=65.965 //y=4.25 //x2=66.22 //y2=4.28
r943 (  88 89 ) resistor r=0.257634 //w=0.131 //l=0.27 //layer=m2 \
 //thickness=0.36 //x=65.965 //y=4.25 //x2=65.695 //y2=4.25
r944 (  87 89 ) resistor r=0.0698411 //w=0.17 //l=0.120208 //layer=m2 \
 //thickness=0.36 //x=65.61 //y=4.165 //x2=65.695 //y2=4.25
r945 (  86 87 ) resistor r=0.19084 //w=0.131 //l=0.2 //layer=m2 \
 //thickness=0.36 //x=65.61 //y=3.965 //x2=65.61 //y2=4.165
r946 (  84 86 ) resistor r=2.82721 //w=0.17 //l=3.85 //layer=m2 \
 //thickness=0.36 //x=61.765 //y=3.9 //x2=65.61 //y2=3.89
r947 (  84 85 ) resistor r=0.329198 //w=0.131 //l=0.345 //layer=m2 \
 //thickness=0.36 //x=61.765 //y=3.9 //x2=61.42 //y2=3.9
r948 (  82 85 ) resistor r=0.1875 //w=0.17 //l=0.264811 //layer=m2 \
 //thickness=0.36 //x=61.165 //y=3.88 //x2=61.42 //y2=3.9
r949 (  82 83 ) resistor r=1.32156 //w=0.131 //l=1.385 //layer=m2 \
 //thickness=0.36 //x=61.165 //y=3.88 //x2=59.78 //y2=3.88
r950 (  80 83 ) resistor r=0.1875 //w=0.17 //l=0.269583 //layer=m2 \
 //thickness=0.36 //x=59.525 //y=3.85 //x2=59.78 //y2=3.88
r951 (  80 81 ) resistor r=0.410305 //w=0.131 //l=0.43 //layer=m2 \
 //thickness=0.36 //x=59.525 //y=3.85 //x2=59.095 //y2=3.85
r952 (  78 81 ) resistor r=0.125 //w=0.17 //l=0.184391 //layer=m2 \
 //thickness=0.36 //x=58.925 //y=3.88 //x2=59.095 //y2=3.85
r953 (  78 79 ) resistor r=1.30725 //w=0.131 //l=1.37 //layer=m2 \
 //thickness=0.36 //x=58.925 //y=3.88 //x2=57.555 //y2=3.88
r954 (  77 79 ) resistor r=0.0698411 //w=0.17 //l=0.120208 //layer=m2 \
 //thickness=0.36 //x=57.47 //y=3.795 //x2=57.555 //y2=3.88
r955 (  76 113 ) resistor r=0.0073411 //w=0.17 //l=0.09 //layer=m2 \
 //thickness=0.36 //x=57.47 //y=3.595 //x2=57.47 //y2=3.505
r956 (  76 77 ) resistor r=0.19084 //w=0.131 //l=0.2 //layer=m2 \
 //thickness=0.36 //x=57.47 //y=3.595 //x2=57.47 //y2=3.795
r957 (  74 113 ) resistor r=0.382353 //w=0.17 //l=0.522494 //layer=m2 \
 //thickness=0.36 //x=56.95 //y=3.5 //x2=57.47 //y2=3.505
r958 (  74 75 ) resistor r=0.415076 //w=0.131 //l=0.435 //layer=m2 \
 //thickness=0.36 //x=56.95 //y=3.5 //x2=56.515 //y2=3.5
r959 (  72 75 ) resistor r=0.125 //w=0.17 //l=0.174929 //layer=m2 \
 //thickness=0.36 //x=56.345 //y=3.51 //x2=56.515 //y2=3.5
r960 (  72 73 ) resistor r=0.324427 //w=0.131 //l=0.34 //layer=m2 \
 //thickness=0.36 //x=56.345 //y=3.51 //x2=56.005 //y2=3.51
r961 (  71 112 ) resistor r=0.607395 //w=0.204 //l=0.99495 //layer=m2 \
 //thickness=0.36 //x=55.49 //y=3.53 //x2=54.505 //y2=3.51
r962 (  70 73 ) resistor r=0.125 //w=0.17 //l=0.179722 //layer=m2 \
 //thickness=0.36 //x=55.835 //y=3.53 //x2=56.005 //y2=3.51
r963 (  70 71 ) resistor r=0.329198 //w=0.131 //l=0.345 //layer=m2 \
 //thickness=0.36 //x=55.835 //y=3.53 //x2=55.49 //y2=3.53
r964 (  69 109 ) resistor r=0.108362 //w=0.251 //l=0.16 //layer=m2 \
 //thickness=0.36 //x=52.815 //y=3.51 //x2=52.655 //y2=3.51
r965 (  68 112 ) resistor r=0.10188 //w=0.204 //l=0.16 //layer=m2 \
 //thickness=0.36 //x=54.345 //y=3.51 //x2=54.505 //y2=3.51
r966 (  68 69 ) resistor r=1.45992 //w=0.131 //l=1.53 //layer=m2 \
 //thickness=0.36 //x=54.345 //y=3.51 //x2=52.815 //y2=3.51
r967 (  67 192 ) resistor r=9.3 //w=0.17 //l=0.17 //layer=mcon //count=1 \
 //x=95.6 //y=4.885 //x2=95.6 //y2=4.885
r968 (  65 183 ) resistor r=9.3 //w=0.17 //l=0.17 //layer=mcon //count=1 \
 //x=95.58 //y=2.26 //x2=95.58 //y2=2.26
r969 (  61 118 ) resistor r=4.5 //w=0.15 //l=0.15 //layer=via1 //count=1 \
 //x=95.595 //y=4.21 //x2=95.595 //y2=4.21
r970 (  61 63 ) resistor r=0.0130208 //w=0.384 //l=0.04 //layer=m1 \
 //thickness=0.36 //x=95.535 //y=4.21 //x2=95.535 //y2=4.25
r971 (  57 116 ) resistor r=4.5 //w=0.15 //l=0.15 //layer=via1 //count=1 \
 //x=88.92 //y=4.205 //x2=88.92 //y2=4.205
r972 (  57 59 ) resistor r=0.0149601 //w=0.376 //l=0.045 //layer=m1 \
 //thickness=0.36 //x=88.972 //y=4.205 //x2=88.972 //y2=4.25
r973 (  55 178 ) resistor r=9.3 //w=0.17 //l=0.17 //layer=mcon //count=1 \
 //x=88.96 //y=4.885 //x2=88.96 //y2=4.885
r974 (  53 169 ) resistor r=9.3 //w=0.17 //l=0.17 //layer=mcon //count=1 \
 //x=88.92 //y=2.26 //x2=88.92 //y2=2.26
r975 (  51 164 ) resistor r=9.3 //w=0.17 //l=0.17 //layer=mcon //count=1 \
 //x=54.51 //y=4.88 //x2=54.51 //y2=4.88
r976 (  49 155 ) resistor r=9.3 //w=0.17 //l=0.17 //layer=mcon //count=1 \
 //x=54.51 //y=2.26 //x2=54.51 //y2=2.26
r977 (  45 112 ) resistor r=4.5 //w=0.15 //l=0.15 //layer=via1 //count=1 \
 //x=54.505 //y=3.495 //x2=54.505 //y2=3.495
r978 (  45 47 ) resistor r=0.00494723 //w=0.379 //l=0.015 //layer=m1 \
 //thickness=0.36 //x=54.455 //y=3.495 //x2=54.455 //y2=3.51
r979 (  41 109 ) resistor r=4.5 //w=0.15 //l=0.15 //layer=via1 //count=1 \
 //x=52.655 //y=3.495 //x2=52.655 //y2=3.495
r980 (  41 43 ) resistor r=0.00487013 //w=0.385 //l=0.015 //layer=m1 \
 //thickness=0.36 //x=52.71 //y=3.495 //x2=52.71 //y2=3.51
r981 (  39 295 ) resistor r=9.3 //w=0.17 //l=0.17 //layer=mcon //count=1 \
 //x=52.175 //y=1.19 //x2=52.175 //y2=1.19
r982 (  37 138 ) resistor r=9.3 //w=0.17 //l=0.17 //layer=mcon //count=1 \
 //x=51.88 //y=5.56 //x2=51.88 //y2=5.56
r983 (  34 130 ) resistor r=9.3 //w=0.17 //l=0.17 //layer=mcon //count=1 \
 //x=51 //y=5.56 //x2=51 //y2=5.56
r984 (  32 34 ) resistor r=0.121228 //w=0.232 //l=0.225 //layer=m1 \
 //thickness=0.36 //x=51 //y=5.335 //x2=51 //y2=5.56
r985 (  31 122 ) resistor r=9.3 //w=0.17 //l=0.17 //layer=mcon //count=1 \
 //x=50.12 //y=5.56 //x2=50.12 //y2=5.56
r986 (  29 31 ) resistor r=0.129608 //w=0.217 //l=0.225 //layer=m1 \
 //thickness=0.36 //x=50.122 //y=5.335 //x2=50.122 //y2=5.56
r987 (  28 67 ) resistor r=0.0893515 //w=0.219 //l=0.154677 //layer=m1 \
 //thickness=0.36 //x=95.58 //y=4.74 //x2=95.6 //y2=4.885
r988 (  27 63 ) resistor r=0.0784723 //w=0.384 //l=0.140712 //layer=m1 \
 //thickness=0.36 //x=95.58 //y=4.37 //x2=95.535 //y2=4.25
r989 (  27 28 ) resistor r=0.353053 //w=0.131 //l=0.37 //layer=m1 \
 //thickness=0.36 //x=95.58 //y=4.37 //x2=95.58 //y2=4.74
r990 (  26 61 ) resistor r=0.0914932 //w=0.384 //l=0.181108 //layer=m1 \
 //thickness=0.36 //x=95.58 //y=4.05 //x2=95.535 //y2=4.21
r991 (  25 65 ) resistor r=0.0744285 //w=0.225 //l=0.12 //layer=m1 \
 //thickness=0.36 //x=95.58 //y=2.38 //x2=95.58 //y2=2.26
r992 (  25 26 ) resistor r=1.59351 //w=0.131 //l=1.67 //layer=m1 \
 //thickness=0.36 //x=95.58 //y=2.38 //x2=95.58 //y2=4.05
r993 (  24 55 ) resistor r=0.100665 //w=0.248 //l=0.193972 //layer=m1 \
 //thickness=0.36 //x=88.92 //y=4.71 //x2=88.96 //y2=4.885
r994 (  23 59 ) resistor r=0.0761992 //w=0.376 //l=0.138582 //layer=m1 \
 //thickness=0.36 //x=88.92 //y=4.365 //x2=88.972 //y2=4.25
r995 (  23 24 ) resistor r=0.329198 //w=0.131 //l=0.345 //layer=m1 \
 //thickness=0.36 //x=88.92 //y=4.365 //x2=88.92 //y2=4.71
r996 (  22 57 ) resistor r=0.0911593 //w=0.376 //l=0.184174 //layer=m1 \
 //thickness=0.36 //x=88.92 //y=4.045 //x2=88.972 //y2=4.205
r997 (  21 53 ) resistor r=0.0717383 //w=0.224 //l=0.115 //layer=m1 \
 //thickness=0.36 //x=88.92 //y=2.375 //x2=88.92 //y2=2.26
r998 (  21 22 ) resistor r=1.59351 //w=0.131 //l=1.67 //layer=m1 \
 //thickness=0.36 //x=88.92 //y=2.375 //x2=88.92 //y2=4.045
r999 (  20 51 ) resistor r=0.0760407 //w=0.238 //l=0.125 //layer=m1 \
 //thickness=0.36 //x=54.51 //y=4.755 //x2=54.51 //y2=4.88
r1000 (  19 47 ) resistor r=0.0863342 //w=0.379 //l=0.170294 //layer=m1 \
 //thickness=0.36 //x=54.51 //y=3.655 //x2=54.455 //y2=3.51
r1001 (  19 20 ) resistor r=1.04962 //w=0.131 //l=1.1 //layer=m1 \
 //thickness=0.36 //x=54.51 //y=3.655 //x2=54.51 //y2=4.755
r1002 (  18 45 ) resistor r=0.0813869 //w=0.379 //l=0.155081 //layer=m1 \
 //thickness=0.36 //x=54.51 //y=3.365 //x2=54.455 //y2=3.495
r1003 (  17 49 ) resistor r=0.0719237 //w=0.222 //l=0.115 //layer=m1 \
 //thickness=0.36 //x=54.51 //y=2.375 //x2=54.51 //y2=2.26
r1004 (  17 18 ) resistor r=0.944656 //w=0.131 //l=0.99 //layer=m1 \
 //thickness=0.36 //x=54.51 //y=2.375 //x2=54.51 //y2=3.365
r1005 (  15 43 ) resistor r=0.0866666 //w=0.385 //l=0.168152 //layer=m1 \
 //thickness=0.36 //x=52.66 //y=3.655 //x2=52.71 //y2=3.51
r1006 (  15 16 ) resistor r=1.52195 //w=0.131 //l=1.595 //layer=m1 \
 //thickness=0.36 //x=52.66 //y=3.655 //x2=52.66 //y2=5.25
r1007 (  14 41 ) resistor r=0.0817965 //w=0.385 //l=0.152971 //layer=m1 \
 //thickness=0.36 //x=52.66 //y=3.365 //x2=52.71 //y2=3.495
r1008 (  13 14 ) resistor r=1.36927 //w=0.131 //l=1.435 //layer=m1 \
 //thickness=0.36 //x=52.66 //y=1.93 //x2=52.66 //y2=3.365
r1009 (  11 13 ) resistor r=0.0698411 //w=0.17 //l=0.120208 //layer=m1 \
 //thickness=0.36 //x=52.575 //y=1.845 //x2=52.66 //y2=1.93
r1010 (  11 12 ) resistor r=0.300573 //w=0.131 //l=0.315 //layer=m1 \
 //thickness=0.36 //x=52.575 //y=1.845 //x2=52.26 //y2=1.845
r1011 (  10 12 ) resistor r=0.0698411 //w=0.17 //l=0.120208 //layer=m1 \
 //thickness=0.36 //x=52.175 //y=1.76 //x2=52.26 //y2=1.845
r1012 (  9 39 ) resistor r=0.0717383 //w=0.224 //l=0.115 //layer=m1 \
 //thickness=0.36 //x=52.175 //y=1.305 //x2=52.175 //y2=1.19
r1013 (  9 10 ) resistor r=0.43416 //w=0.131 //l=0.455 //layer=m1 \
 //thickness=0.36 //x=52.175 //y=1.305 //x2=52.175 //y2=1.76
r1014 (  8 35 ) resistor r=0.0675342 //w=0.23 //l=0.115 //layer=m1 \
 //thickness=0.36 //x=51.995 //y=5.335 //x2=51.88 //y2=5.335
r1015 (  7 16 ) resistor r=0.0698411 //w=0.17 //l=0.120208 //layer=m1 \
 //thickness=0.36 //x=52.575 //y=5.335 //x2=52.66 //y2=5.25
r1016 (  7 8 ) resistor r=0.553435 //w=0.131 //l=0.58 //layer=m1 \
 //thickness=0.36 //x=52.575 //y=5.335 //x2=51.995 //y2=5.335
r1017 (  6 37 ) resistor r=0.00118313 //w=0.23 //layer=m1 //thickness=0.36 \
 //x=51.88 //y=5.56 //x2=51.88 //y2=5.56
r1018 (  5 35 ) resistor r=0.002872 //w=0.34 //l=0.085 //layer=m1 \
 //thickness=0.36 //x=51.88 //y=5.42 //x2=51.88 //y2=5.335
r1019 (  5 6 ) resistor r=0.091623 //w=0.191 //l=0.14 //layer=m1 \
 //thickness=0.36 //x=51.88 //y=5.42 //x2=51.88 //y2=5.56
r1020 (  4 32 ) resistor r=0.0262263 //w=0.232 //l=0.12 //layer=m1 \
 //thickness=0.36 //x=51.12 //y=5.335 //x2=51 //y2=5.335
r1021 (  3 35 ) resistor r=0.0675342 //w=0.23 //l=0.115 //layer=m1 \
 //thickness=0.36 //x=51.765 //y=5.335 //x2=51.88 //y2=5.335
r1022 (  3 4 ) resistor r=0.615458 //w=0.131 //l=0.645 //layer=m1 \
 //thickness=0.36 //x=51.765 //y=5.335 //x2=51.12 //y2=5.335
r1023 (  2 29 ) resistor r=0.0222262 //w=0.217 //l=0.118 //layer=m1 \
 //thickness=0.36 //x=50.24 //y=5.335 //x2=50.122 //y2=5.335
r1024 (  1 32 ) resistor r=0.0262263 //w=0.232 //l=0.12 //layer=m1 \
 //thickness=0.36 //x=50.88 //y=5.335 //x2=51 //y2=5.335
r1025 (  1 2 ) resistor r=0.610687 //w=0.131 //l=0.64 //layer=m1 \
 //thickness=0.36 //x=50.88 //y=5.335 //x2=50.24 //y2=5.335
ends PM_TMRDFFSNRNQNX1\%noxref_22

subckt PM_TMRDFFSNRNQNX1\%Q ( 1 2 4 5 6 8 9 11 12 13 15 19 22 25 35 47 50 51 \
 53 54 63 71 92 93 94 98 99 )
c231 ( 94 0 ) capacitor c=0.009897f //x=95.69 //y=1.085
c232 ( 93 0 ) capacitor c=0.0108927f //x=92.36 //y=1.085
c233 ( 92 0 ) capacitor c=0.011039f //x=89.03 //y=1.085
c234 ( 71 0 ) capacitor c=0.0265472f //x=95.84 //y=5.56
c235 ( 63 0 ) capacitor c=0.0232072f //x=94.96 //y=5.56
c236 ( 54 0 ) capacitor c=0.0842754f //x=95.715 //y=1.405
c237 ( 53 0 ) capacitor c=0.0257508f //x=95.875 //y=1.405
c238 ( 51 0 ) capacitor c=0.00655817f //x=92.68 //y=1.405
c239 ( 50 0 ) capacitor c=0.07438f //x=92.42 //y=1.405
c240 ( 47 0 ) capacitor c=0.00222181f //x=89.385 //y=1.405
c241 ( 35 0 ) capacitor c=0.011927f //x=96.32 //y=4.255
c242 ( 25 0 ) capacitor c=0.0156643f //x=95.837 //y=5.39
c243 ( 22 0 ) capacitor c=0.0155006f //x=94.96 //y=5.39
c244 ( 19 0 ) capacitor c=0.00903169f //x=92.55 //y=1.36
c245 ( 15 0 ) capacitor c=0.00590009f //x=89.22 //y=1.36
c246 ( 13 0 ) capacitor c=0.030072f //x=96.32 //y=5.305
c247 ( 12 0 ) capacitor c=0.0201673f //x=96.32 //y=4.415
c248 ( 11 0 ) capacitor c=0.0973385f //x=96.32 //y=4.095
c249 ( 9 0 ) capacitor c=0.00834076f //x=95.965 //y=1.825
c250 ( 8 0 ) capacitor c=0.0158331f //x=96.235 //y=1.825
c251 ( 6 0 ) capacitor c=0.0117302f //x=96.235 //y=5.39
c252 ( 5 0 ) capacitor c=0.00871794f //x=95.88 //y=1.74
c253 ( 4 0 ) capacitor c=0.00698506f //x=95.88 //y=1.535
c254 ( 2 0 ) capacitor c=0.0116295f //x=95.715 //y=5.39
c255 ( 1 0 ) capacitor c=0.0151866f //x=96.32 //y=4.25
r256 (  91 92 ) resistor r=13.3953 //w=0.172 //l=0.18 //layer=li \
 //thickness=0.1 //x=89.217 //y=1.36 //x2=89.217 //y2=1.18
r257 (  82 94 ) resistor r=12.3209 //w=0.187 //l=0.18 //layer=li \
 //thickness=0.1 //x=95.88 //y=1.36 //x2=95.88 //y2=1.18
r258 (  71 99 ) resistor r=23.2727 //w=0.187 //l=0.34 //layer=li \
 //thickness=0.1 //x=95.84 //y=5.56 //x2=95.84 //y2=5.9
r259 (  63 98 ) resistor r=23.2727 //w=0.187 //l=0.34 //layer=li \
 //thickness=0.1 //x=94.96 //y=5.56 //x2=94.96 //y2=5.9
r260 (  60 93 ) resistor r=12.3209 //w=0.187 //l=0.18 //layer=li \
 //thickness=0.1 //x=92.55 //y=1.36 //x2=92.55 //y2=1.18
r261 (  53 54 ) resistor r=0.10734 //w=0.281 //l=0.16 //layer=m2 \
 //thickness=0.36 //x=95.875 //y=1.405 //x2=95.715 //y2=1.405
r262 (  51 54 ) resistor r=2.89599 //w=0.131 //l=3.035 //layer=m2 \
 //thickness=0.36 //x=92.68 //y=1.36 //x2=95.715 //y2=1.36
r263 (  49 51 ) resistor r=0.0942778 //w=0.221 //l=0.13 //layer=m2 \
 //thickness=0.36 //x=92.55 //y=1.405 //x2=92.68 //y2=1.405
r264 (  49 50 ) resistor r=0.0942778 //w=0.221 //l=0.13 //layer=m2 \
 //thickness=0.36 //x=92.55 //y=1.405 //x2=92.42 //y2=1.405
r265 (  47 50 ) resistor r=2.89599 //w=0.131 //l=3.035 //layer=m2 \
 //thickness=0.36 //x=89.385 //y=1.36 //x2=92.42 //y2=1.36
r266 (  45 47 ) resistor r=0.10734 //w=0.281 //l=0.16 //layer=m2 \
 //thickness=0.36 //x=89.225 //y=1.405 //x2=89.385 //y2=1.405
r267 (  31 53 ) resistor r=4.5 //w=0.15 //l=0.15 //layer=via1 //count=1 \
 //x=95.875 //y=1.405 //x2=95.875 //y2=1.405
r268 (  29 82 ) resistor r=9.3 //w=0.17 //l=0.17 //layer=mcon //count=1 \
 //x=95.88 //y=1.36 //x2=95.88 //y2=1.36
r269 (  29 31 ) resistor r=0.0163043 //w=0.345 //l=0.045 //layer=m1 \
 //thickness=0.36 //x=95.82 //y=1.36 //x2=95.82 //y2=1.405
r270 (  27 71 ) resistor r=9.3 //w=0.17 //l=0.17 //layer=mcon //count=1 \
 //x=95.84 //y=5.56 //x2=95.84 //y2=5.56
r271 (  25 27 ) resistor r=0.0944444 //w=0.225 //l=0.17 //layer=m1 \
 //thickness=0.36 //x=95.837 //y=5.39 //x2=95.837 //y2=5.56
r272 (  24 63 ) resistor r=9.3 //w=0.17 //l=0.17 //layer=mcon //count=1 \
 //x=94.96 //y=5.56 //x2=94.96 //y2=5.56
r273 (  22 24 ) resistor r=0.0936123 //w=0.227 //l=0.17 //layer=m1 \
 //thickness=0.36 //x=94.96 //y=5.39 //x2=94.96 //y2=5.56
r274 (  21 49 ) resistor r=4.5 //w=0.15 //l=0.15 //layer=via1 //count=1 \
 //x=92.55 //y=1.405 //x2=92.55 //y2=1.405
r275 (  19 60 ) resistor r=9.3 //w=0.17 //l=0.17 //layer=mcon //count=1 \
 //x=92.55 //y=1.36 //x2=92.55 //y2=1.36
r276 (  19 21 ) resistor r=0.0163043 //w=0.345 //l=0.045 //layer=m1 \
 //thickness=0.36 //x=92.49 //y=1.36 //x2=92.49 //y2=1.405
r277 (  17 45 ) resistor r=4.5 //w=0.15 //l=0.15 //layer=via1 //count=1 \
 //x=89.225 //y=1.405 //x2=89.225 //y2=1.405
r278 (  15 91 ) resistor r=9.3 //w=0.17 //l=0.17 //layer=mcon //count=1 \
 //x=89.22 //y=1.36 //x2=89.22 //y2=1.36
r279 (  15 17 ) resistor r=0.0150401 //w=0.374 //l=0.045 //layer=m1 \
 //thickness=0.36 //x=89.275 //y=1.36 //x2=89.275 //y2=1.405
r280 (  12 35 ) resistor r=0.0911593 //w=0.376 //l=0.184174 //layer=m1 \
 //thickness=0.36 //x=96.32 //y=4.415 //x2=96.372 //y2=4.255
r281 (  12 13 ) resistor r=0.849237 //w=0.131 //l=0.89 //layer=m1 \
 //thickness=0.36 //x=96.32 //y=4.415 //x2=96.32 //y2=5.305
r282 (  10 11 ) resistor r=2.08492 //w=0.131 //l=2.185 //layer=m1 \
 //thickness=0.36 //x=96.32 //y=1.91 //x2=96.32 //y2=4.095
r283 (  8 10 ) resistor r=0.0698411 //w=0.17 //l=0.120208 //layer=m1 \
 //thickness=0.36 //x=96.235 //y=1.825 //x2=96.32 //y2=1.91
r284 (  8 9 ) resistor r=0.257634 //w=0.131 //l=0.27 //layer=m1 \
 //thickness=0.36 //x=96.235 //y=1.825 //x2=95.965 //y2=1.825
r285 (  7 25 ) resistor r=0.0243946 //w=0.225 //l=0.123 //layer=m1 \
 //thickness=0.36 //x=95.96 //y=5.39 //x2=95.837 //y2=5.39
r286 (  6 13 ) resistor r=0.0698411 //w=0.17 //l=0.120208 //layer=m1 \
 //thickness=0.36 //x=96.235 //y=5.39 //x2=96.32 //y2=5.305
r287 (  6 7 ) resistor r=0.262405 //w=0.131 //l=0.275 //layer=m1 \
 //thickness=0.36 //x=96.235 //y=5.39 //x2=95.96 //y2=5.39
r288 (  5 9 ) resistor r=0.0698411 //w=0.17 //l=0.120208 //layer=m1 \
 //thickness=0.36 //x=95.88 //y=1.74 //x2=95.965 //y2=1.825
r289 (  4 31 ) resistor r=0.0792909 //w=0.345 //l=0.157162 //layer=m1 \
 //thickness=0.36 //x=95.88 //y=1.535 //x2=95.82 //y2=1.405
r290 (  4 5 ) resistor r=0.195611 //w=0.131 //l=0.205 //layer=m1 \
 //thickness=0.36 //x=95.88 //y=1.535 //x2=95.88 //y2=1.74
r291 (  3 22 ) resistor r=0.0249239 //w=0.227 //l=0.125 //layer=m1 \
 //thickness=0.36 //x=95.085 //y=5.39 //x2=94.96 //y2=5.39
r292 (  2 25 ) resistor r=0.0243946 //w=0.225 //l=0.122 //layer=m1 \
 //thickness=0.36 //x=95.715 //y=5.39 //x2=95.837 //y2=5.39
r293 (  2 3 ) resistor r=0.601145 //w=0.131 //l=0.63 //layer=m1 \
 //thickness=0.36 //x=95.715 //y=5.39 //x2=95.085 //y2=5.39
r294 (  1 35 ) resistor r=0.00166223 //w=0.376 //l=0.005 //layer=m1 \
 //thickness=0.36 //x=96.372 //y=4.25 //x2=96.372 //y2=4.255
r295 (  1 11 ) resistor r=0.0894971 //w=0.376 //l=0.179123 //layer=m1 \
 //thickness=0.36 //x=96.372 //y=4.25 //x2=96.32 //y2=4.095
ends PM_TMRDFFSNRNQNX1\%Q

subckt PM_TMRDFFSNRNQNX1\%VDD ( 1 2 149 150 151 153 154 155 159 160 173 225 \
 228 237 247 255 265 283 293 301 311 329 339 347 357 375 385 393 403 421 431 \
 439 449 467 477 485 495 513 523 531 541 559 569 577 587 605 615 623 633 651 \
 661 669 679 697 707 715 725 743 753 761 771 777 789 799 807 817 835 845 853 \
 863 881 891 899 909 927 937 945 955 973 983 991 1001 1019 1029 1037 1047 1053 \
 1088 1103 1110 1115 1120 1125 1130 1135 1140 1145 1150 1155 1160 1165 1170 \
 1175 1180 1185 1190 1195 1196 1197 1198 1199 1200 1201 1202 1203 1204 1205 \
 1206 1207 1208 1209 1210 1211 1212 1213 1214 1215 1216 1217 1218 1219 1220 \
 1221 1222 1223 1224 1225 1226 1227 1228 1229 1230 1231 1232 1233 1234 1235 \
 1236 1237 1238 1239 1240 1241 1242 1243 1244 1245 1246 1247 1248 1249 1250 \
 1251 1252 1253 1254 1255 1256 1257 1258 1259 1260 1261 1262 1263 1264 1265 \
 1266 1267 1268 1269 1270 1271 1272 )
c1386 ( 1272 0 ) capacitor c=0.0424825f //x=89.475 //y=5.205
c1387 ( 1271 0 ) capacitor c=0.0224071f //x=88.595 //y=5.205
c1388 ( 1270 0 ) capacitor c=0.051473f //x=87.725 //y=5.205
c1389 ( 1269 0 ) capacitor c=0.046689f //x=85.845 //y=5.2
c1390 ( 1268 0 ) capacitor c=0.0255621f //x=84.965 //y=5.2
c1391 ( 1267 0 ) capacitor c=0.0256114f //x=84.085 //y=5.2
c1392 ( 1266 0 ) capacitor c=0.0676809f //x=83.215 //y=5.2
c1393 ( 1265 0 ) capacitor c=0.0466891f //x=81.035 //y=5.2
c1394 ( 1264 0 ) capacitor c=0.025617f //x=80.155 //y=5.2
c1395 ( 1263 0 ) capacitor c=0.0256114f //x=79.275 //y=5.2
c1396 ( 1262 0 ) capacitor c=0.0676623f //x=78.405 //y=5.2
c1397 ( 1261 0 ) capacitor c=0.0466891f //x=76.225 //y=5.2
c1398 ( 1260 0 ) capacitor c=0.025617f //x=75.345 //y=5.2
c1399 ( 1259 0 ) capacitor c=0.0256114f //x=74.465 //y=5.2
c1400 ( 1258 0 ) capacitor c=0.0676736f //x=73.595 //y=5.2
c1401 ( 1257 0 ) capacitor c=0.0466891f //x=71.415 //y=5.2
c1402 ( 1256 0 ) capacitor c=0.025617f //x=70.535 //y=5.2
c1403 ( 1255 0 ) capacitor c=0.0256114f //x=69.655 //y=5.2
c1404 ( 1254 0 ) capacitor c=0.0676727f //x=68.785 //y=5.2
c1405 ( 1253 0 ) capacitor c=0.0466891f //x=66.605 //y=5.2
c1406 ( 1252 0 ) capacitor c=0.025617f //x=65.725 //y=5.2
c1407 ( 1251 0 ) capacitor c=0.0256114f //x=64.845 //y=5.2
c1408 ( 1250 0 ) capacitor c=0.0678441f //x=63.975 //y=5.2
c1409 ( 1249 0 ) capacitor c=0.0466891f //x=61.795 //y=5.2
c1410 ( 1248 0 ) capacitor c=0.025617f //x=60.915 //y=5.2
c1411 ( 1247 0 ) capacitor c=0.0256114f //x=60.035 //y=5.2
c1412 ( 1246 0 ) capacitor c=0.067673f //x=59.165 //y=5.2
c1413 ( 1245 0 ) capacitor c=0.0466891f //x=56.985 //y=5.2
c1414 ( 1244 0 ) capacitor c=0.025617f //x=56.105 //y=5.2
c1415 ( 1243 0 ) capacitor c=0.0256114f //x=55.225 //y=5.2
c1416 ( 1242 0 ) capacitor c=0.0677041f //x=54.355 //y=5.2
c1417 ( 1241 0 ) capacitor c=0.0466891f //x=52.175 //y=5.2
c1418 ( 1240 0 ) capacitor c=0.025617f //x=51.295 //y=5.2
c1419 ( 1239 0 ) capacitor c=0.0256114f //x=50.415 //y=5.2
c1420 ( 1238 0 ) capacitor c=0.0677744f //x=49.545 //y=5.2
c1421 ( 1237 0 ) capacitor c=0.0466891f //x=47.365 //y=5.2
c1422 ( 1236 0 ) capacitor c=0.025617f //x=46.485 //y=5.2
c1423 ( 1235 0 ) capacitor c=0.0256114f //x=45.605 //y=5.2
c1424 ( 1234 0 ) capacitor c=0.0677902f //x=44.735 //y=5.2
c1425 ( 1233 0 ) capacitor c=0.0466929f //x=42.555 //y=5.2
c1426 ( 1232 0 ) capacitor c=0.0256208f //x=41.675 //y=5.2
c1427 ( 1231 0 ) capacitor c=0.0256152f //x=40.795 //y=5.2
c1428 ( 1230 0 ) capacitor c=0.0677914f //x=39.925 //y=5.2
c1429 ( 1229 0 ) capacitor c=0.0466929f //x=37.745 //y=5.2
c1430 ( 1228 0 ) capacitor c=0.0256208f //x=36.865 //y=5.2
c1431 ( 1227 0 ) capacitor c=0.0256114f //x=35.985 //y=5.2
c1432 ( 1226 0 ) capacitor c=0.0676862f //x=35.115 //y=5.2
c1433 ( 1225 0 ) capacitor c=0.0466891f //x=32.935 //y=5.2
c1434 ( 1224 0 ) capacitor c=0.025617f //x=32.055 //y=5.2
c1435 ( 1223 0 ) capacitor c=0.0256114f //x=31.175 //y=5.2
c1436 ( 1222 0 ) capacitor c=0.0675526f //x=30.305 //y=5.2
c1437 ( 1221 0 ) capacitor c=0.0466891f //x=28.125 //y=5.2
c1438 ( 1220 0 ) capacitor c=0.025617f //x=27.245 //y=5.2
c1439 ( 1219 0 ) capacitor c=0.0256114f //x=26.365 //y=5.2
c1440 ( 1218 0 ) capacitor c=0.0676881f //x=25.495 //y=5.2
c1441 ( 1217 0 ) capacitor c=0.0466891f //x=23.315 //y=5.2
c1442 ( 1216 0 ) capacitor c=0.025617f //x=22.435 //y=5.2
c1443 ( 1215 0 ) capacitor c=0.0256114f //x=21.555 //y=5.2
c1444 ( 1214 0 ) capacitor c=0.0676623f //x=20.685 //y=5.2
c1445 ( 1213 0 ) capacitor c=0.0466891f //x=18.505 //y=5.2
c1446 ( 1212 0 ) capacitor c=0.025617f //x=17.625 //y=5.2
c1447 ( 1211 0 ) capacitor c=0.0256114f //x=16.745 //y=5.2
c1448 ( 1210 0 ) capacitor c=0.0677138f //x=15.875 //y=5.2
c1449 ( 1209 0 ) capacitor c=0.0466891f //x=13.695 //y=5.2
c1450 ( 1208 0 ) capacitor c=0.025617f //x=12.815 //y=5.2
c1451 ( 1207 0 ) capacitor c=0.0256114f //x=11.935 //y=5.2
c1452 ( 1206 0 ) capacitor c=0.0676529f //x=11.065 //y=5.2
c1453 ( 1205 0 ) capacitor c=0.0466891f //x=8.885 //y=5.2
c1454 ( 1204 0 ) capacitor c=0.025617f //x=8.005 //y=5.2
c1455 ( 1203 0 ) capacitor c=0.0256114f //x=7.125 //y=5.2
c1456 ( 1202 0 ) capacitor c=0.0677384f //x=6.255 //y=5.2
c1457 ( 1201 0 ) capacitor c=0.0466891f //x=4.075 //y=5.2
c1458 ( 1200 0 ) capacitor c=0.025617f //x=3.195 //y=5.2
c1459 ( 1199 0 ) capacitor c=0.0256114f //x=2.315 //y=5.2
c1460 ( 1198 0 ) capacitor c=0.0693239f //x=1.445 //y=5.2
c1461 ( 1197 0 ) capacitor c=0.120784f //x=93.73 //y=7.585
c1462 ( 1196 0 ) capacitor c=0.125977f //x=90.4 //y=7.585
c1463 ( 1195 0 ) capacitor c=0.140972f //x=87.07 //y=7.585
c1464 ( 1194 0 ) capacitor c=0.00597439f //x=85.99 //y=7.585
c1465 ( 1193 0 ) capacitor c=0.00597439f //x=85.11 //y=7.585
c1466 ( 1192 0 ) capacitor c=0.00597439f //x=84.23 //y=7.585
c1467 ( 1191 0 ) capacitor c=0.00597439f //x=83.35 //y=7.585
c1468 ( 1190 0 ) capacitor c=0.163341f //x=82.26 //y=7.585
c1469 ( 1189 0 ) capacitor c=0.00597439f //x=81.18 //y=7.585
c1470 ( 1188 0 ) capacitor c=0.00597439f //x=80.3 //y=7.585
c1471 ( 1187 0 ) capacitor c=0.00597439f //x=79.42 //y=7.585
c1472 ( 1186 0 ) capacitor c=0.00597439f //x=78.54 //y=7.585
c1473 ( 1185 0 ) capacitor c=0.163341f //x=77.45 //y=7.585
c1474 ( 1184 0 ) capacitor c=0.00597439f //x=76.37 //y=7.585
c1475 ( 1183 0 ) capacitor c=0.00597439f //x=75.49 //y=7.585
c1476 ( 1182 0 ) capacitor c=0.00597439f //x=74.61 //y=7.585
c1477 ( 1181 0 ) capacitor c=0.00597439f //x=73.73 //y=7.585
c1478 ( 1180 0 ) capacitor c=0.16086f //x=72.64 //y=7.585
c1479 ( 1179 0 ) capacitor c=0.00597439f //x=71.56 //y=7.585
c1480 ( 1178 0 ) capacitor c=0.00597439f //x=70.68 //y=7.585
c1481 ( 1177 0 ) capacitor c=0.00597439f //x=69.8 //y=7.585
c1482 ( 1176 0 ) capacitor c=0.00597439f //x=68.92 //y=7.585
c1483 ( 1175 0 ) capacitor c=0.162601f //x=67.83 //y=7.585
c1484 ( 1174 0 ) capacitor c=0.00597439f //x=66.75 //y=7.585
c1485 ( 1173 0 ) capacitor c=0.00597439f //x=65.87 //y=7.585
c1486 ( 1172 0 ) capacitor c=0.00597439f //x=64.99 //y=7.585
c1487 ( 1171 0 ) capacitor c=0.00597439f //x=64.11 //y=7.585
c1488 ( 1170 0 ) capacitor c=0.1642f //x=63.02 //y=7.585
c1489 ( 1169 0 ) capacitor c=0.00597439f //x=61.94 //y=7.585
c1490 ( 1168 0 ) capacitor c=0.00597439f //x=61.06 //y=7.585
c1491 ( 1167 0 ) capacitor c=0.00597439f //x=60.18 //y=7.585
c1492 ( 1166 0 ) capacitor c=0.00597439f //x=59.3 //y=7.585
c1493 ( 1165 0 ) capacitor c=0.161982f //x=58.21 //y=7.585
c1494 ( 1164 0 ) capacitor c=0.00597439f //x=57.13 //y=7.585
c1495 ( 1163 0 ) capacitor c=0.00597439f //x=56.25 //y=7.585
c1496 ( 1162 0 ) capacitor c=0.00597439f //x=55.37 //y=7.585
c1497 ( 1161 0 ) capacitor c=0.00597439f //x=54.49 //y=7.585
c1498 ( 1160 0 ) capacitor c=0.162749f //x=53.4 //y=7.585
c1499 ( 1159 0 ) capacitor c=0.00597439f //x=52.32 //y=7.585
c1500 ( 1158 0 ) capacitor c=0.00597439f //x=51.44 //y=7.585
c1501 ( 1157 0 ) capacitor c=0.00597439f //x=50.56 //y=7.585
c1502 ( 1156 0 ) capacitor c=0.00597439f //x=49.68 //y=7.585
c1503 ( 1155 0 ) capacitor c=0.162749f //x=48.59 //y=7.585
c1504 ( 1154 0 ) capacitor c=0.00597439f //x=47.51 //y=7.585
c1505 ( 1153 0 ) capacitor c=0.00597439f //x=46.63 //y=7.585
c1506 ( 1152 0 ) capacitor c=0.00597439f //x=45.75 //y=7.585
c1507 ( 1151 0 ) capacitor c=0.00597439f //x=44.87 //y=7.585
c1508 ( 1150 0 ) capacitor c=0.16268f //x=43.78 //y=7.585
c1509 ( 1149 0 ) capacitor c=0.00597439f //x=42.7 //y=7.585
c1510 ( 1148 0 ) capacitor c=0.00597439f //x=41.82 //y=7.585
c1511 ( 1147 0 ) capacitor c=0.00597439f //x=40.94 //y=7.585
c1512 ( 1146 0 ) capacitor c=0.00597439f //x=40.06 //y=7.585
c1513 ( 1145 0 ) capacitor c=0.16299f //x=38.97 //y=7.585
c1514 ( 1144 0 ) capacitor c=0.00597439f //x=37.89 //y=7.585
c1515 ( 1143 0 ) capacitor c=0.00597439f //x=37.01 //y=7.585
c1516 ( 1142 0 ) capacitor c=0.00597439f //x=36.13 //y=7.585
c1517 ( 1141 0 ) capacitor c=0.00597439f //x=35.25 //y=7.585
c1518 ( 1140 0 ) capacitor c=0.161286f //x=34.16 //y=7.585
c1519 ( 1139 0 ) capacitor c=0.00597439f //x=33.08 //y=7.585
c1520 ( 1138 0 ) capacitor c=0.00597439f //x=32.2 //y=7.585
c1521 ( 1137 0 ) capacitor c=0.00597439f //x=31.32 //y=7.585
c1522 ( 1136 0 ) capacitor c=0.00597439f //x=30.44 //y=7.585
c1523 ( 1135 0 ) capacitor c=0.162814f //x=29.35 //y=7.585
c1524 ( 1134 0 ) capacitor c=0.00597439f //x=28.27 //y=7.585
c1525 ( 1133 0 ) capacitor c=0.00597439f //x=27.39 //y=7.585
c1526 ( 1132 0 ) capacitor c=0.00597439f //x=26.51 //y=7.585
c1527 ( 1131 0 ) capacitor c=0.00597439f //x=25.63 //y=7.585
c1528 ( 1130 0 ) capacitor c=0.160993f //x=24.54 //y=7.585
c1529 ( 1129 0 ) capacitor c=0.00597439f //x=23.46 //y=7.585
c1530 ( 1128 0 ) capacitor c=0.00597439f //x=22.58 //y=7.585
c1531 ( 1127 0 ) capacitor c=0.00597439f //x=21.7 //y=7.585
c1532 ( 1126 0 ) capacitor c=0.00597439f //x=20.82 //y=7.585
c1533 ( 1125 0 ) capacitor c=0.163341f //x=19.73 //y=7.585
c1534 ( 1124 0 ) capacitor c=0.00597439f //x=18.65 //y=7.585
c1535 ( 1123 0 ) capacitor c=0.00597439f //x=17.77 //y=7.585
c1536 ( 1122 0 ) capacitor c=0.00597439f //x=16.89 //y=7.585
c1537 ( 1121 0 ) capacitor c=0.00597439f //x=16.01 //y=7.585
c1538 ( 1120 0 ) capacitor c=0.163341f //x=14.92 //y=7.585
c1539 ( 1119 0 ) capacitor c=0.00597439f //x=13.84 //y=7.585
c1540 ( 1118 0 ) capacitor c=0.00597439f //x=12.96 //y=7.585
c1541 ( 1117 0 ) capacitor c=0.00597439f //x=12.08 //y=7.585
c1542 ( 1116 0 ) capacitor c=0.00597439f //x=11.2 //y=7.585
c1543 ( 1115 0 ) capacitor c=0.163341f //x=10.11 //y=7.585
c1544 ( 1114 0 ) capacitor c=0.00597439f //x=9.03 //y=7.585
c1545 ( 1113 0 ) capacitor c=0.00597439f //x=8.15 //y=7.585
c1546 ( 1112 0 ) capacitor c=0.00597439f //x=7.27 //y=7.585
c1547 ( 1111 0 ) capacitor c=0.00597439f //x=6.39 //y=7.585
c1548 ( 1110 0 ) capacitor c=0.163259f //x=5.3 //y=7.585
c1549 ( 1109 0 ) capacitor c=0.00597439f //x=4.22 //y=7.585
c1550 ( 1108 0 ) capacitor c=0.00597439f //x=3.34 //y=7.585
c1551 ( 1107 0 ) capacitor c=0.00597439f //x=2.46 //y=7.585
c1552 ( 1106 0 ) capacitor c=0.00597439f //x=1.58 //y=7.585
c1553 ( 1103 0 ) capacitor c=0.366847f //x=96.32 //y=7.58
c1554 ( 1088 0 ) capacitor c=0.131873f //x=93.56 //y=7.585
c1555 ( 1053 0 ) capacitor c=0.133054f //x=90.23 //y=7.585
c1556 ( 1047 0 ) capacitor c=0.042257f //x=86.9 //y=7.585
c1557 ( 1037 0 ) capacitor c=0.0288858f //x=85.905 //y=7.585
c1558 ( 1029 0 ) capacitor c=0.0289326f //x=85.025 //y=7.585
c1559 ( 1019 0 ) capacitor c=0.0290299f //x=84.145 //y=7.585
c1560 ( 1007 0 ) capacitor c=0.0455283f //x=83.265 //y=7.585
c1561 ( 1001 0 ) capacitor c=0.042257f //x=82.09 //y=7.585
c1562 ( 991 0 ) capacitor c=0.0288858f //x=81.095 //y=7.585
c1563 ( 983 0 ) capacitor c=0.0289326f //x=80.215 //y=7.585
c1564 ( 973 0 ) capacitor c=0.0290299f //x=79.335 //y=7.585
c1565 ( 961 0 ) capacitor c=0.0455283f //x=78.455 //y=7.585
c1566 ( 955 0 ) capacitor c=0.042257f //x=77.28 //y=7.585
c1567 ( 945 0 ) capacitor c=0.0288858f //x=76.285 //y=7.585
c1568 ( 937 0 ) capacitor c=0.0289326f //x=75.405 //y=7.585
c1569 ( 927 0 ) capacitor c=0.0287042f //x=74.525 //y=7.585
c1570 ( 915 0 ) capacitor c=0.0386886f //x=73.645 //y=7.585
c1571 ( 909 0 ) capacitor c=0.038209f //x=72.47 //y=7.585
c1572 ( 899 0 ) capacitor c=0.0288858f //x=71.475 //y=7.585
c1573 ( 891 0 ) capacitor c=0.0289326f //x=70.595 //y=7.585
c1574 ( 881 0 ) capacitor c=0.0287042f //x=69.715 //y=7.585
c1575 ( 869 0 ) capacitor c=0.0386886f //x=68.835 //y=7.585
c1576 ( 863 0 ) capacitor c=0.038209f //x=67.66 //y=7.585
c1577 ( 853 0 ) capacitor c=0.0288858f //x=66.665 //y=7.585
c1578 ( 845 0 ) capacitor c=0.0289326f //x=65.785 //y=7.585
c1579 ( 835 0 ) capacitor c=0.0287042f //x=64.905 //y=7.585
c1580 ( 823 0 ) capacitor c=0.0386886f //x=64.025 //y=7.585
c1581 ( 817 0 ) capacitor c=0.038209f //x=62.85 //y=7.585
c1582 ( 807 0 ) capacitor c=0.0288858f //x=61.855 //y=7.585
c1583 ( 799 0 ) capacitor c=0.0289326f //x=60.975 //y=7.585
c1584 ( 789 0 ) capacitor c=0.0287716f //x=60.095 //y=7.585
c1585 ( 777 0 ) capacitor c=0.0386886f //x=59.215 //y=7.585
c1586 ( 771 0 ) capacitor c=0.038209f //x=58.04 //y=7.585
c1587 ( 761 0 ) capacitor c=0.0288858f //x=57.045 //y=7.585
c1588 ( 753 0 ) capacitor c=0.0289326f //x=56.165 //y=7.585
c1589 ( 743 0 ) capacitor c=0.0287042f //x=55.285 //y=7.585
c1590 ( 731 0 ) capacitor c=0.0386886f //x=54.405 //y=7.585
c1591 ( 725 0 ) capacitor c=0.038209f //x=53.23 //y=7.585
c1592 ( 715 0 ) capacitor c=0.0288858f //x=52.235 //y=7.585
c1593 ( 707 0 ) capacitor c=0.0289326f //x=51.355 //y=7.585
c1594 ( 697 0 ) capacitor c=0.0287042f //x=50.475 //y=7.585
c1595 ( 685 0 ) capacitor c=0.0386886f //x=49.595 //y=7.585
c1596 ( 679 0 ) capacitor c=0.038209f //x=48.42 //y=7.585
c1597 ( 669 0 ) capacitor c=0.0288858f //x=47.425 //y=7.585
c1598 ( 661 0 ) capacitor c=0.0289326f //x=46.545 //y=7.585
c1599 ( 651 0 ) capacitor c=0.0287042f //x=45.665 //y=7.585
c1600 ( 639 0 ) capacitor c=0.0386886f //x=44.785 //y=7.585
c1601 ( 633 0 ) capacitor c=0.038209f //x=43.61 //y=7.585
c1602 ( 623 0 ) capacitor c=0.0288858f //x=42.615 //y=7.585
c1603 ( 615 0 ) capacitor c=0.0287926f //x=41.735 //y=7.585
c1604 ( 605 0 ) capacitor c=0.0287042f //x=40.855 //y=7.585
c1605 ( 593 0 ) capacitor c=0.0386886f //x=39.975 //y=7.585
c1606 ( 587 0 ) capacitor c=0.038209f //x=38.8 //y=7.585
c1607 ( 577 0 ) capacitor c=0.0288858f //x=37.805 //y=7.585
c1608 ( 569 0 ) capacitor c=0.0288437f //x=36.925 //y=7.585
c1609 ( 559 0 ) capacitor c=0.0286631f //x=36.045 //y=7.585
c1610 ( 547 0 ) capacitor c=0.0386886f //x=35.165 //y=7.585
c1611 ( 541 0 ) capacitor c=0.038209f //x=33.99 //y=7.585
c1612 ( 531 0 ) capacitor c=0.0288858f //x=32.995 //y=7.585
c1613 ( 523 0 ) capacitor c=0.0289326f //x=32.115 //y=7.585
c1614 ( 513 0 ) capacitor c=0.0286631f //x=31.235 //y=7.585
c1615 ( 501 0 ) capacitor c=0.0386886f //x=30.355 //y=7.585
c1616 ( 495 0 ) capacitor c=0.038209f //x=29.18 //y=7.585
c1617 ( 485 0 ) capacitor c=0.0288858f //x=28.185 //y=7.585
c1618 ( 477 0 ) capacitor c=0.0289326f //x=27.305 //y=7.585
c1619 ( 467 0 ) capacitor c=0.0286631f //x=26.425 //y=7.585
c1620 ( 455 0 ) capacitor c=0.0386886f //x=25.545 //y=7.585
c1621 ( 449 0 ) capacitor c=0.0390964f //x=24.37 //y=7.585
c1622 ( 439 0 ) capacitor c=0.0288858f //x=23.375 //y=7.585
c1623 ( 431 0 ) capacitor c=0.0289326f //x=22.495 //y=7.585
c1624 ( 421 0 ) capacitor c=0.0290299f //x=21.615 //y=7.585
c1625 ( 409 0 ) capacitor c=0.0455283f //x=20.735 //y=7.585
c1626 ( 403 0 ) capacitor c=0.042257f //x=19.56 //y=7.585
c1627 ( 393 0 ) capacitor c=0.0288858f //x=18.565 //y=7.585
c1628 ( 385 0 ) capacitor c=0.0289326f //x=17.685 //y=7.585
c1629 ( 375 0 ) capacitor c=0.0290299f //x=16.805 //y=7.585
c1630 ( 363 0 ) capacitor c=0.0455283f //x=15.925 //y=7.585
c1631 ( 357 0 ) capacitor c=0.042257f //x=14.75 //y=7.585
c1632 ( 347 0 ) capacitor c=0.0288858f //x=13.755 //y=7.585
c1633 ( 339 0 ) capacitor c=0.0289326f //x=12.875 //y=7.585
c1634 ( 329 0 ) capacitor c=0.0290299f //x=11.995 //y=7.585
c1635 ( 317 0 ) capacitor c=0.0455283f //x=11.115 //y=7.585
c1636 ( 311 0 ) capacitor c=0.042257f //x=9.94 //y=7.585
c1637 ( 301 0 ) capacitor c=0.0288858f //x=8.945 //y=7.585
c1638 ( 293 0 ) capacitor c=0.0289326f //x=8.065 //y=7.585
c1639 ( 283 0 ) capacitor c=0.0290299f //x=7.185 //y=7.585
c1640 ( 271 0 ) capacitor c=0.0455283f //x=6.305 //y=7.585
c1641 ( 265 0 ) capacitor c=0.042257f //x=5.13 //y=7.585
c1642 ( 255 0 ) capacitor c=0.0288858f //x=4.135 //y=7.585
c1643 ( 247 0 ) capacitor c=0.0289326f //x=3.255 //y=7.585
c1644 ( 237 0 ) capacitor c=0.029074f //x=2.375 //y=7.585
c1645 ( 228 0 ) capacitor c=0.25352f //x=1.23 //y=7.58
c1646 ( 225 0 ) capacitor c=0.0445047f //x=1.495 //y=7.585
c1647 ( 220 0 ) capacitor c=0.00499323f //x=89.62 //y=7.585
c1648 ( 217 0 ) capacitor c=0.00499323f //x=88.74 //y=7.585
c1649 ( 212 0 ) capacitor c=0.00499323f //x=87.81 //y=7.58
c1650 ( 173 0 ) capacitor c=0.268865f //x=96.32 //y=7.58
c1651 ( 160 0 ) capacitor c=0.00657976f //x=89.62 //y=7.41
c1652 ( 159 0 ) capacitor c=0.00827249f //x=89.62 //y=7.035
c1653 ( 155 0 ) capacitor c=0.0220779f //x=89.535 //y=7.585
c1654 ( 154 0 ) capacitor c=0.00369726f //x=88.74 //y=7.41
c1655 ( 153 0 ) capacitor c=0.00650208f //x=88.74 //y=7.035
c1656 ( 151 0 ) capacitor c=0.02242f //x=88.655 //y=7.585
c1657 ( 150 0 ) capacitor c=0.0090067f //x=87.86 //y=7.41
c1658 ( 149 0 ) capacitor c=0.0125184f //x=87.86 //y=7.035
c1659 ( 2 0 ) capacitor c=3.14223f //x=87.775 //y=7.585
r1660 (  1101 1103 ) resistor r=38.7139 //w=0.367 //l=1.11 //layer=li \
 //thickness=0.1 //x=95.21 //y=7.585 //x2=96.32 //y2=7.585
r1661 (  1099 1101 ) resistor r=38.7139 //w=0.367 //l=1.11 //layer=li \
 //thickness=0.1 //x=94.1 //y=7.585 //x2=95.21 //y2=7.585
r1662 (  1097 1197 ) resistor r=5.29055 //w=0.35 //l=0.17 //layer=li \
 //thickness=0.1 //x=93.9 //y=7.585 //x2=93.73 //y2=7.585
r1663 (  1097 1099 ) resistor r=6.97548 //w=0.367 //l=0.2 //layer=li \
 //thickness=0.1 //x=93.9 //y=7.585 //x2=94.1 //y2=7.585
r1664 (  1091 1093 ) resistor r=38.7139 //w=0.367 //l=1.11 //layer=li \
 //thickness=0.1 //x=91.51 //y=7.585 //x2=92.62 //y2=7.585
r1665 (  1089 1196 ) resistor r=5.29055 //w=0.35 //l=0.17 //layer=li \
 //thickness=0.1 //x=90.57 //y=7.585 //x2=90.4 //y2=7.585
r1666 (  1089 1091 ) resistor r=32.7847 //w=0.367 //l=0.94 //layer=li \
 //thickness=0.1 //x=90.57 //y=7.585 //x2=91.51 //y2=7.585
r1667 (  1088 1197 ) resistor r=5.29055 //w=0.35 //l=0.17 //layer=li \
 //thickness=0.1 //x=93.56 //y=7.585 //x2=93.73 //y2=7.585
r1668 (  1088 1093 ) resistor r=32.7847 //w=0.367 //l=0.94 //layer=li \
 //thickness=0.1 //x=93.56 //y=7.585 //x2=92.62 //y2=7.585
r1669 (  1084 1272 ) resistor r=23.2727 //w=0.187 //l=0.34 //layer=li \
 //thickness=0.1 //x=89.62 //y=6.92 //x2=89.62 //y2=6.58
r1670 (  1069 1270 ) resistor r=23.2727 //w=0.187 //l=0.34 //layer=li \
 //thickness=0.1 //x=87.86 //y=6.92 //x2=87.86 //y2=6.58
r1671 (  1058 1060 ) resistor r=38.7139 //w=0.367 //l=1.11 //layer=li \
 //thickness=0.1 //x=88.92 //y=7.585 //x2=90.03 //y2=7.585
r1672 (  1056 1058 ) resistor r=38.7139 //w=0.367 //l=1.11 //layer=li \
 //thickness=0.1 //x=87.81 //y=7.585 //x2=88.92 //y2=7.585
r1673 (  1054 1195 ) resistor r=5.29055 //w=0.35 //l=0.17 //layer=li \
 //thickness=0.1 //x=87.24 //y=7.585 //x2=87.07 //y2=7.585
r1674 (  1054 1056 ) resistor r=19.8801 //w=0.367 //l=0.57 //layer=li \
 //thickness=0.1 //x=87.24 //y=7.585 //x2=87.81 //y2=7.585
r1675 (  1053 1196 ) resistor r=5.29055 //w=0.35 //l=0.17 //layer=li \
 //thickness=0.1 //x=90.23 //y=7.585 //x2=90.4 //y2=7.585
r1676 (  1053 1060 ) resistor r=6.97548 //w=0.367 //l=0.2 //layer=li \
 //thickness=0.1 //x=90.23 //y=7.585 //x2=90.03 //y2=7.585
r1677 (  1048 1194 ) resistor r=2.87058 //w=0.35 //l=0.085 //layer=li \
 //thickness=0.1 //x=86.075 //y=7.585 //x2=85.99 //y2=7.585
r1678 (  1048 1050 ) resistor r=8.89373 //w=0.367 //l=0.255 //layer=li \
 //thickness=0.1 //x=86.075 //y=7.585 //x2=86.33 //y2=7.585
r1679 (  1047 1195 ) resistor r=5.29055 //w=0.35 //l=0.17 //layer=li \
 //thickness=0.1 //x=86.9 //y=7.585 //x2=87.07 //y2=7.585
r1680 (  1047 1050 ) resistor r=19.8801 //w=0.367 //l=0.57 //layer=li \
 //thickness=0.1 //x=86.9 //y=7.585 //x2=86.33 //y2=7.585
r1681 (  1041 1194 ) resistor r=4.23183 //w=0.7 //l=0.175 //layer=li \
 //thickness=0.1 //x=85.99 //y=7.41 //x2=85.99 //y2=7.585
r1682 (  1041 1269 ) resistor r=33.1979 //w=0.187 //l=0.485 //layer=li \
 //thickness=0.1 //x=85.99 //y=7.41 //x2=85.99 //y2=6.925
r1683 (  1038 1193 ) resistor r=2.87058 //w=0.35 //l=0.085 //layer=li \
 //thickness=0.1 //x=85.195 //y=7.585 //x2=85.11 //y2=7.585
r1684 (  1038 1040 ) resistor r=0.871935 //w=0.367 //l=0.025 //layer=li \
 //thickness=0.1 //x=85.195 //y=7.585 //x2=85.22 //y2=7.585
r1685 (  1037 1194 ) resistor r=2.87058 //w=0.35 //l=0.085 //layer=li \
 //thickness=0.1 //x=85.905 //y=7.585 //x2=85.99 //y2=7.585
r1686 (  1037 1040 ) resistor r=23.891 //w=0.367 //l=0.685 //layer=li \
 //thickness=0.1 //x=85.905 //y=7.585 //x2=85.22 //y2=7.585
r1687 (  1031 1193 ) resistor r=4.23183 //w=0.7 //l=0.175 //layer=li \
 //thickness=0.1 //x=85.11 //y=7.41 //x2=85.11 //y2=7.585
r1688 (  1031 1268 ) resistor r=33.1979 //w=0.187 //l=0.485 //layer=li \
 //thickness=0.1 //x=85.11 //y=7.41 //x2=85.11 //y2=6.925
r1689 (  1030 1192 ) resistor r=2.87058 //w=0.35 //l=0.085 //layer=li \
 //thickness=0.1 //x=84.315 //y=7.585 //x2=84.23 //y2=7.585
r1690 (  1029 1193 ) resistor r=2.87058 //w=0.35 //l=0.085 //layer=li \
 //thickness=0.1 //x=85.025 //y=7.585 //x2=85.11 //y2=7.585
r1691 (  1029 1030 ) resistor r=24.7629 //w=0.367 //l=0.71 //layer=li \
 //thickness=0.1 //x=85.025 //y=7.585 //x2=84.315 //y2=7.585
r1692 (  1023 1192 ) resistor r=4.23183 //w=0.7 //l=0.175 //layer=li \
 //thickness=0.1 //x=84.23 //y=7.41 //x2=84.23 //y2=7.585
r1693 (  1023 1267 ) resistor r=33.1979 //w=0.187 //l=0.485 //layer=li \
 //thickness=0.1 //x=84.23 //y=7.41 //x2=84.23 //y2=6.925
r1694 (  1020 1191 ) resistor r=2.87058 //w=0.35 //l=0.085 //layer=li \
 //thickness=0.1 //x=83.435 //y=7.585 //x2=83.35 //y2=7.585
r1695 (  1020 1022 ) resistor r=23.5422 //w=0.367 //l=0.675 //layer=li \
 //thickness=0.1 //x=83.435 //y=7.585 //x2=84.11 //y2=7.585
r1696 (  1019 1192 ) resistor r=2.87058 //w=0.35 //l=0.085 //layer=li \
 //thickness=0.1 //x=84.145 //y=7.585 //x2=84.23 //y2=7.585
r1697 (  1019 1022 ) resistor r=1.22071 //w=0.367 //l=0.035 //layer=li \
 //thickness=0.1 //x=84.145 //y=7.585 //x2=84.11 //y2=7.585
r1698 (  1011 1191 ) resistor r=4.23183 //w=0.7 //l=0.175 //layer=li \
 //thickness=0.1 //x=83.35 //y=7.41 //x2=83.35 //y2=7.585
r1699 (  1011 1266 ) resistor r=56.4706 //w=0.187 //l=0.825 //layer=li \
 //thickness=0.1 //x=83.35 //y=7.41 //x2=83.35 //y2=6.585
r1700 (  1008 1190 ) resistor r=5.29055 //w=0.35 //l=0.17 //layer=li \
 //thickness=0.1 //x=82.43 //y=7.585 //x2=82.26 //y2=7.585
r1701 (  1008 1010 ) resistor r=19.8801 //w=0.367 //l=0.57 //layer=li \
 //thickness=0.1 //x=82.43 //y=7.585 //x2=83 //y2=7.585
r1702 (  1007 1191 ) resistor r=2.87058 //w=0.35 //l=0.085 //layer=li \
 //thickness=0.1 //x=83.265 //y=7.585 //x2=83.35 //y2=7.585
r1703 (  1007 1010 ) resistor r=9.24251 //w=0.367 //l=0.265 //layer=li \
 //thickness=0.1 //x=83.265 //y=7.585 //x2=83 //y2=7.585
r1704 (  1002 1189 ) resistor r=2.87058 //w=0.35 //l=0.085 //layer=li \
 //thickness=0.1 //x=81.265 //y=7.585 //x2=81.18 //y2=7.585
r1705 (  1002 1004 ) resistor r=8.89373 //w=0.367 //l=0.255 //layer=li \
 //thickness=0.1 //x=81.265 //y=7.585 //x2=81.52 //y2=7.585
r1706 (  1001 1190 ) resistor r=5.29055 //w=0.35 //l=0.17 //layer=li \
 //thickness=0.1 //x=82.09 //y=7.585 //x2=82.26 //y2=7.585
r1707 (  1001 1004 ) resistor r=19.8801 //w=0.367 //l=0.57 //layer=li \
 //thickness=0.1 //x=82.09 //y=7.585 //x2=81.52 //y2=7.585
r1708 (  995 1189 ) resistor r=4.23183 //w=0.7 //l=0.175 //layer=li \
 //thickness=0.1 //x=81.18 //y=7.41 //x2=81.18 //y2=7.585
r1709 (  995 1265 ) resistor r=33.1979 //w=0.187 //l=0.485 //layer=li \
 //thickness=0.1 //x=81.18 //y=7.41 //x2=81.18 //y2=6.925
r1710 (  992 1188 ) resistor r=2.87058 //w=0.35 //l=0.085 //layer=li \
 //thickness=0.1 //x=80.385 //y=7.585 //x2=80.3 //y2=7.585
r1711 (  992 994 ) resistor r=0.871935 //w=0.367 //l=0.025 //layer=li \
 //thickness=0.1 //x=80.385 //y=7.585 //x2=80.41 //y2=7.585
r1712 (  991 1189 ) resistor r=2.87058 //w=0.35 //l=0.085 //layer=li \
 //thickness=0.1 //x=81.095 //y=7.585 //x2=81.18 //y2=7.585
r1713 (  991 994 ) resistor r=23.891 //w=0.367 //l=0.685 //layer=li \
 //thickness=0.1 //x=81.095 //y=7.585 //x2=80.41 //y2=7.585
r1714 (  985 1188 ) resistor r=4.23183 //w=0.7 //l=0.175 //layer=li \
 //thickness=0.1 //x=80.3 //y=7.41 //x2=80.3 //y2=7.585
r1715 (  985 1264 ) resistor r=33.1979 //w=0.187 //l=0.485 //layer=li \
 //thickness=0.1 //x=80.3 //y=7.41 //x2=80.3 //y2=6.925
r1716 (  984 1187 ) resistor r=2.87058 //w=0.35 //l=0.085 //layer=li \
 //thickness=0.1 //x=79.505 //y=7.585 //x2=79.42 //y2=7.585
r1717 (  983 1188 ) resistor r=2.87058 //w=0.35 //l=0.085 //layer=li \
 //thickness=0.1 //x=80.215 //y=7.585 //x2=80.3 //y2=7.585
r1718 (  983 984 ) resistor r=24.7629 //w=0.367 //l=0.71 //layer=li \
 //thickness=0.1 //x=80.215 //y=7.585 //x2=79.505 //y2=7.585
r1719 (  977 1187 ) resistor r=4.23183 //w=0.7 //l=0.175 //layer=li \
 //thickness=0.1 //x=79.42 //y=7.41 //x2=79.42 //y2=7.585
r1720 (  977 1263 ) resistor r=33.1979 //w=0.187 //l=0.485 //layer=li \
 //thickness=0.1 //x=79.42 //y=7.41 //x2=79.42 //y2=6.925
r1721 (  974 1186 ) resistor r=2.87058 //w=0.35 //l=0.085 //layer=li \
 //thickness=0.1 //x=78.625 //y=7.585 //x2=78.54 //y2=7.585
r1722 (  974 976 ) resistor r=23.5422 //w=0.367 //l=0.675 //layer=li \
 //thickness=0.1 //x=78.625 //y=7.585 //x2=79.3 //y2=7.585
r1723 (  973 1187 ) resistor r=2.87058 //w=0.35 //l=0.085 //layer=li \
 //thickness=0.1 //x=79.335 //y=7.585 //x2=79.42 //y2=7.585
r1724 (  973 976 ) resistor r=1.22071 //w=0.367 //l=0.035 //layer=li \
 //thickness=0.1 //x=79.335 //y=7.585 //x2=79.3 //y2=7.585
r1725 (  965 1186 ) resistor r=4.23183 //w=0.7 //l=0.175 //layer=li \
 //thickness=0.1 //x=78.54 //y=7.41 //x2=78.54 //y2=7.585
r1726 (  965 1262 ) resistor r=56.4706 //w=0.187 //l=0.825 //layer=li \
 //thickness=0.1 //x=78.54 //y=7.41 //x2=78.54 //y2=6.585
r1727 (  962 1185 ) resistor r=5.29055 //w=0.35 //l=0.17 //layer=li \
 //thickness=0.1 //x=77.62 //y=7.585 //x2=77.45 //y2=7.585
r1728 (  962 964 ) resistor r=19.8801 //w=0.367 //l=0.57 //layer=li \
 //thickness=0.1 //x=77.62 //y=7.585 //x2=78.19 //y2=7.585
r1729 (  961 1186 ) resistor r=2.87058 //w=0.35 //l=0.085 //layer=li \
 //thickness=0.1 //x=78.455 //y=7.585 //x2=78.54 //y2=7.585
r1730 (  961 964 ) resistor r=9.24251 //w=0.367 //l=0.265 //layer=li \
 //thickness=0.1 //x=78.455 //y=7.585 //x2=78.19 //y2=7.585
r1731 (  956 1184 ) resistor r=2.87058 //w=0.35 //l=0.085 //layer=li \
 //thickness=0.1 //x=76.455 //y=7.585 //x2=76.37 //y2=7.585
r1732 (  956 958 ) resistor r=8.89373 //w=0.367 //l=0.255 //layer=li \
 //thickness=0.1 //x=76.455 //y=7.585 //x2=76.71 //y2=7.585
r1733 (  955 1185 ) resistor r=5.29055 //w=0.35 //l=0.17 //layer=li \
 //thickness=0.1 //x=77.28 //y=7.585 //x2=77.45 //y2=7.585
r1734 (  955 958 ) resistor r=19.8801 //w=0.367 //l=0.57 //layer=li \
 //thickness=0.1 //x=77.28 //y=7.585 //x2=76.71 //y2=7.585
r1735 (  949 1184 ) resistor r=4.23183 //w=0.7 //l=0.175 //layer=li \
 //thickness=0.1 //x=76.37 //y=7.41 //x2=76.37 //y2=7.585
r1736 (  949 1261 ) resistor r=33.1979 //w=0.187 //l=0.485 //layer=li \
 //thickness=0.1 //x=76.37 //y=7.41 //x2=76.37 //y2=6.925
r1737 (  946 1183 ) resistor r=2.87058 //w=0.35 //l=0.085 //layer=li \
 //thickness=0.1 //x=75.575 //y=7.585 //x2=75.49 //y2=7.585
r1738 (  946 948 ) resistor r=0.871935 //w=0.367 //l=0.025 //layer=li \
 //thickness=0.1 //x=75.575 //y=7.585 //x2=75.6 //y2=7.585
r1739 (  945 1184 ) resistor r=2.87058 //w=0.35 //l=0.085 //layer=li \
 //thickness=0.1 //x=76.285 //y=7.585 //x2=76.37 //y2=7.585
r1740 (  945 948 ) resistor r=23.891 //w=0.367 //l=0.685 //layer=li \
 //thickness=0.1 //x=76.285 //y=7.585 //x2=75.6 //y2=7.585
r1741 (  939 1183 ) resistor r=4.23183 //w=0.7 //l=0.175 //layer=li \
 //thickness=0.1 //x=75.49 //y=7.41 //x2=75.49 //y2=7.585
r1742 (  939 1260 ) resistor r=33.1979 //w=0.187 //l=0.485 //layer=li \
 //thickness=0.1 //x=75.49 //y=7.41 //x2=75.49 //y2=6.925
r1743 (  938 1182 ) resistor r=2.87058 //w=0.35 //l=0.085 //layer=li \
 //thickness=0.1 //x=74.695 //y=7.585 //x2=74.61 //y2=7.585
r1744 (  937 1183 ) resistor r=2.87058 //w=0.35 //l=0.085 //layer=li \
 //thickness=0.1 //x=75.405 //y=7.585 //x2=75.49 //y2=7.585
r1745 (  937 938 ) resistor r=24.7629 //w=0.367 //l=0.71 //layer=li \
 //thickness=0.1 //x=75.405 //y=7.585 //x2=74.695 //y2=7.585
r1746 (  931 1182 ) resistor r=4.23183 //w=0.7 //l=0.175 //layer=li \
 //thickness=0.1 //x=74.61 //y=7.41 //x2=74.61 //y2=7.585
r1747 (  931 1259 ) resistor r=33.1979 //w=0.187 //l=0.485 //layer=li \
 //thickness=0.1 //x=74.61 //y=7.41 //x2=74.61 //y2=6.925
r1748 (  928 1181 ) resistor r=2.87058 //w=0.35 //l=0.085 //layer=li \
 //thickness=0.1 //x=73.815 //y=7.585 //x2=73.73 //y2=7.585
r1749 (  928 930 ) resistor r=23.5422 //w=0.367 //l=0.675 //layer=li \
 //thickness=0.1 //x=73.815 //y=7.585 //x2=74.49 //y2=7.585
r1750 (  927 1182 ) resistor r=2.87058 //w=0.35 //l=0.085 //layer=li \
 //thickness=0.1 //x=74.525 //y=7.585 //x2=74.61 //y2=7.585
r1751 (  927 930 ) resistor r=1.22071 //w=0.367 //l=0.035 //layer=li \
 //thickness=0.1 //x=74.525 //y=7.585 //x2=74.49 //y2=7.585
r1752 (  919 1181 ) resistor r=4.23183 //w=0.7 //l=0.175 //layer=li \
 //thickness=0.1 //x=73.73 //y=7.41 //x2=73.73 //y2=7.585
r1753 (  919 1258 ) resistor r=56.4706 //w=0.187 //l=0.825 //layer=li \
 //thickness=0.1 //x=73.73 //y=7.41 //x2=73.73 //y2=6.585
r1754 (  916 1180 ) resistor r=5.29055 //w=0.35 //l=0.17 //layer=li \
 //thickness=0.1 //x=72.81 //y=7.585 //x2=72.64 //y2=7.585
r1755 (  916 918 ) resistor r=19.8801 //w=0.367 //l=0.57 //layer=li \
 //thickness=0.1 //x=72.81 //y=7.585 //x2=73.38 //y2=7.585
r1756 (  915 1181 ) resistor r=2.87058 //w=0.35 //l=0.085 //layer=li \
 //thickness=0.1 //x=73.645 //y=7.585 //x2=73.73 //y2=7.585
r1757 (  915 918 ) resistor r=9.24251 //w=0.367 //l=0.265 //layer=li \
 //thickness=0.1 //x=73.645 //y=7.585 //x2=73.38 //y2=7.585
r1758 (  910 1179 ) resistor r=2.87058 //w=0.35 //l=0.085 //layer=li \
 //thickness=0.1 //x=71.645 //y=7.585 //x2=71.56 //y2=7.585
r1759 (  910 912 ) resistor r=8.89373 //w=0.367 //l=0.255 //layer=li \
 //thickness=0.1 //x=71.645 //y=7.585 //x2=71.9 //y2=7.585
r1760 (  909 1180 ) resistor r=5.29055 //w=0.35 //l=0.17 //layer=li \
 //thickness=0.1 //x=72.47 //y=7.585 //x2=72.64 //y2=7.585
r1761 (  909 912 ) resistor r=19.8801 //w=0.367 //l=0.57 //layer=li \
 //thickness=0.1 //x=72.47 //y=7.585 //x2=71.9 //y2=7.585
r1762 (  903 1179 ) resistor r=4.23183 //w=0.7 //l=0.175 //layer=li \
 //thickness=0.1 //x=71.56 //y=7.41 //x2=71.56 //y2=7.585
r1763 (  903 1257 ) resistor r=33.1979 //w=0.187 //l=0.485 //layer=li \
 //thickness=0.1 //x=71.56 //y=7.41 //x2=71.56 //y2=6.925
r1764 (  900 1178 ) resistor r=2.87058 //w=0.35 //l=0.085 //layer=li \
 //thickness=0.1 //x=70.765 //y=7.585 //x2=70.68 //y2=7.585
r1765 (  900 902 ) resistor r=0.871935 //w=0.367 //l=0.025 //layer=li \
 //thickness=0.1 //x=70.765 //y=7.585 //x2=70.79 //y2=7.585
r1766 (  899 1179 ) resistor r=2.87058 //w=0.35 //l=0.085 //layer=li \
 //thickness=0.1 //x=71.475 //y=7.585 //x2=71.56 //y2=7.585
r1767 (  899 902 ) resistor r=23.891 //w=0.367 //l=0.685 //layer=li \
 //thickness=0.1 //x=71.475 //y=7.585 //x2=70.79 //y2=7.585
r1768 (  893 1178 ) resistor r=4.23183 //w=0.7 //l=0.175 //layer=li \
 //thickness=0.1 //x=70.68 //y=7.41 //x2=70.68 //y2=7.585
r1769 (  893 1256 ) resistor r=33.1979 //w=0.187 //l=0.485 //layer=li \
 //thickness=0.1 //x=70.68 //y=7.41 //x2=70.68 //y2=6.925
r1770 (  892 1177 ) resistor r=2.87058 //w=0.35 //l=0.085 //layer=li \
 //thickness=0.1 //x=69.885 //y=7.585 //x2=69.8 //y2=7.585
r1771 (  891 1178 ) resistor r=2.87058 //w=0.35 //l=0.085 //layer=li \
 //thickness=0.1 //x=70.595 //y=7.585 //x2=70.68 //y2=7.585
r1772 (  891 892 ) resistor r=24.7629 //w=0.367 //l=0.71 //layer=li \
 //thickness=0.1 //x=70.595 //y=7.585 //x2=69.885 //y2=7.585
r1773 (  885 1177 ) resistor r=4.23183 //w=0.7 //l=0.175 //layer=li \
 //thickness=0.1 //x=69.8 //y=7.41 //x2=69.8 //y2=7.585
r1774 (  885 1255 ) resistor r=33.1979 //w=0.187 //l=0.485 //layer=li \
 //thickness=0.1 //x=69.8 //y=7.41 //x2=69.8 //y2=6.925
r1775 (  882 1176 ) resistor r=2.87058 //w=0.35 //l=0.085 //layer=li \
 //thickness=0.1 //x=69.005 //y=7.585 //x2=68.92 //y2=7.585
r1776 (  882 884 ) resistor r=23.5422 //w=0.367 //l=0.675 //layer=li \
 //thickness=0.1 //x=69.005 //y=7.585 //x2=69.68 //y2=7.585
r1777 (  881 1177 ) resistor r=2.87058 //w=0.35 //l=0.085 //layer=li \
 //thickness=0.1 //x=69.715 //y=7.585 //x2=69.8 //y2=7.585
r1778 (  881 884 ) resistor r=1.22071 //w=0.367 //l=0.035 //layer=li \
 //thickness=0.1 //x=69.715 //y=7.585 //x2=69.68 //y2=7.585
r1779 (  873 1176 ) resistor r=4.23183 //w=0.7 //l=0.175 //layer=li \
 //thickness=0.1 //x=68.92 //y=7.41 //x2=68.92 //y2=7.585
r1780 (  873 1254 ) resistor r=56.4706 //w=0.187 //l=0.825 //layer=li \
 //thickness=0.1 //x=68.92 //y=7.41 //x2=68.92 //y2=6.585
r1781 (  870 1175 ) resistor r=5.29055 //w=0.35 //l=0.17 //layer=li \
 //thickness=0.1 //x=68 //y=7.585 //x2=67.83 //y2=7.585
r1782 (  870 872 ) resistor r=19.8801 //w=0.367 //l=0.57 //layer=li \
 //thickness=0.1 //x=68 //y=7.585 //x2=68.57 //y2=7.585
r1783 (  869 1176 ) resistor r=2.87058 //w=0.35 //l=0.085 //layer=li \
 //thickness=0.1 //x=68.835 //y=7.585 //x2=68.92 //y2=7.585
r1784 (  869 872 ) resistor r=9.24251 //w=0.367 //l=0.265 //layer=li \
 //thickness=0.1 //x=68.835 //y=7.585 //x2=68.57 //y2=7.585
r1785 (  864 1174 ) resistor r=2.87058 //w=0.35 //l=0.085 //layer=li \
 //thickness=0.1 //x=66.835 //y=7.585 //x2=66.75 //y2=7.585
r1786 (  864 866 ) resistor r=8.89373 //w=0.367 //l=0.255 //layer=li \
 //thickness=0.1 //x=66.835 //y=7.585 //x2=67.09 //y2=7.585
r1787 (  863 1175 ) resistor r=5.29055 //w=0.35 //l=0.17 //layer=li \
 //thickness=0.1 //x=67.66 //y=7.585 //x2=67.83 //y2=7.585
r1788 (  863 866 ) resistor r=19.8801 //w=0.367 //l=0.57 //layer=li \
 //thickness=0.1 //x=67.66 //y=7.585 //x2=67.09 //y2=7.585
r1789 (  857 1174 ) resistor r=4.23183 //w=0.7 //l=0.175 //layer=li \
 //thickness=0.1 //x=66.75 //y=7.41 //x2=66.75 //y2=7.585
r1790 (  857 1253 ) resistor r=33.1979 //w=0.187 //l=0.485 //layer=li \
 //thickness=0.1 //x=66.75 //y=7.41 //x2=66.75 //y2=6.925
r1791 (  854 1173 ) resistor r=2.87058 //w=0.35 //l=0.085 //layer=li \
 //thickness=0.1 //x=65.955 //y=7.585 //x2=65.87 //y2=7.585
r1792 (  854 856 ) resistor r=0.871935 //w=0.367 //l=0.025 //layer=li \
 //thickness=0.1 //x=65.955 //y=7.585 //x2=65.98 //y2=7.585
r1793 (  853 1174 ) resistor r=2.87058 //w=0.35 //l=0.085 //layer=li \
 //thickness=0.1 //x=66.665 //y=7.585 //x2=66.75 //y2=7.585
r1794 (  853 856 ) resistor r=23.891 //w=0.367 //l=0.685 //layer=li \
 //thickness=0.1 //x=66.665 //y=7.585 //x2=65.98 //y2=7.585
r1795 (  847 1173 ) resistor r=4.23183 //w=0.7 //l=0.175 //layer=li \
 //thickness=0.1 //x=65.87 //y=7.41 //x2=65.87 //y2=7.585
r1796 (  847 1252 ) resistor r=33.1979 //w=0.187 //l=0.485 //layer=li \
 //thickness=0.1 //x=65.87 //y=7.41 //x2=65.87 //y2=6.925
r1797 (  846 1172 ) resistor r=2.87058 //w=0.35 //l=0.085 //layer=li \
 //thickness=0.1 //x=65.075 //y=7.585 //x2=64.99 //y2=7.585
r1798 (  845 1173 ) resistor r=2.87058 //w=0.35 //l=0.085 //layer=li \
 //thickness=0.1 //x=65.785 //y=7.585 //x2=65.87 //y2=7.585
r1799 (  845 846 ) resistor r=24.7629 //w=0.367 //l=0.71 //layer=li \
 //thickness=0.1 //x=65.785 //y=7.585 //x2=65.075 //y2=7.585
r1800 (  839 1172 ) resistor r=4.23183 //w=0.7 //l=0.175 //layer=li \
 //thickness=0.1 //x=64.99 //y=7.41 //x2=64.99 //y2=7.585
r1801 (  839 1251 ) resistor r=33.1979 //w=0.187 //l=0.485 //layer=li \
 //thickness=0.1 //x=64.99 //y=7.41 //x2=64.99 //y2=6.925
r1802 (  836 1171 ) resistor r=2.87058 //w=0.35 //l=0.085 //layer=li \
 //thickness=0.1 //x=64.195 //y=7.585 //x2=64.11 //y2=7.585
r1803 (  836 838 ) resistor r=23.5422 //w=0.367 //l=0.675 //layer=li \
 //thickness=0.1 //x=64.195 //y=7.585 //x2=64.87 //y2=7.585
r1804 (  835 1172 ) resistor r=2.87058 //w=0.35 //l=0.085 //layer=li \
 //thickness=0.1 //x=64.905 //y=7.585 //x2=64.99 //y2=7.585
r1805 (  835 838 ) resistor r=1.22071 //w=0.367 //l=0.035 //layer=li \
 //thickness=0.1 //x=64.905 //y=7.585 //x2=64.87 //y2=7.585
r1806 (  827 1171 ) resistor r=4.23183 //w=0.7 //l=0.175 //layer=li \
 //thickness=0.1 //x=64.11 //y=7.41 //x2=64.11 //y2=7.585
r1807 (  827 1250 ) resistor r=56.4706 //w=0.187 //l=0.825 //layer=li \
 //thickness=0.1 //x=64.11 //y=7.41 //x2=64.11 //y2=6.585
r1808 (  824 1170 ) resistor r=5.29055 //w=0.35 //l=0.17 //layer=li \
 //thickness=0.1 //x=63.19 //y=7.585 //x2=63.02 //y2=7.585
r1809 (  824 826 ) resistor r=19.8801 //w=0.367 //l=0.57 //layer=li \
 //thickness=0.1 //x=63.19 //y=7.585 //x2=63.76 //y2=7.585
r1810 (  823 1171 ) resistor r=2.87058 //w=0.35 //l=0.085 //layer=li \
 //thickness=0.1 //x=64.025 //y=7.585 //x2=64.11 //y2=7.585
r1811 (  823 826 ) resistor r=9.24251 //w=0.367 //l=0.265 //layer=li \
 //thickness=0.1 //x=64.025 //y=7.585 //x2=63.76 //y2=7.585
r1812 (  818 1169 ) resistor r=2.87058 //w=0.35 //l=0.085 //layer=li \
 //thickness=0.1 //x=62.025 //y=7.585 //x2=61.94 //y2=7.585
r1813 (  818 820 ) resistor r=8.89373 //w=0.367 //l=0.255 //layer=li \
 //thickness=0.1 //x=62.025 //y=7.585 //x2=62.28 //y2=7.585
r1814 (  817 1170 ) resistor r=5.29055 //w=0.35 //l=0.17 //layer=li \
 //thickness=0.1 //x=62.85 //y=7.585 //x2=63.02 //y2=7.585
r1815 (  817 820 ) resistor r=19.8801 //w=0.367 //l=0.57 //layer=li \
 //thickness=0.1 //x=62.85 //y=7.585 //x2=62.28 //y2=7.585
r1816 (  811 1169 ) resistor r=4.23183 //w=0.7 //l=0.175 //layer=li \
 //thickness=0.1 //x=61.94 //y=7.41 //x2=61.94 //y2=7.585
r1817 (  811 1249 ) resistor r=33.1979 //w=0.187 //l=0.485 //layer=li \
 //thickness=0.1 //x=61.94 //y=7.41 //x2=61.94 //y2=6.925
r1818 (  808 1168 ) resistor r=2.87058 //w=0.35 //l=0.085 //layer=li \
 //thickness=0.1 //x=61.145 //y=7.585 //x2=61.06 //y2=7.585
r1819 (  808 810 ) resistor r=0.871935 //w=0.367 //l=0.025 //layer=li \
 //thickness=0.1 //x=61.145 //y=7.585 //x2=61.17 //y2=7.585
r1820 (  807 1169 ) resistor r=2.87058 //w=0.35 //l=0.085 //layer=li \
 //thickness=0.1 //x=61.855 //y=7.585 //x2=61.94 //y2=7.585
r1821 (  807 810 ) resistor r=23.891 //w=0.367 //l=0.685 //layer=li \
 //thickness=0.1 //x=61.855 //y=7.585 //x2=61.17 //y2=7.585
r1822 (  801 1168 ) resistor r=4.23183 //w=0.7 //l=0.175 //layer=li \
 //thickness=0.1 //x=61.06 //y=7.41 //x2=61.06 //y2=7.585
r1823 (  801 1248 ) resistor r=33.1979 //w=0.187 //l=0.485 //layer=li \
 //thickness=0.1 //x=61.06 //y=7.41 //x2=61.06 //y2=6.925
r1824 (  800 1167 ) resistor r=2.87058 //w=0.35 //l=0.085 //layer=li \
 //thickness=0.1 //x=60.265 //y=7.585 //x2=60.18 //y2=7.585
r1825 (  799 1168 ) resistor r=2.87058 //w=0.35 //l=0.085 //layer=li \
 //thickness=0.1 //x=60.975 //y=7.585 //x2=61.06 //y2=7.585
r1826 (  799 800 ) resistor r=24.7629 //w=0.367 //l=0.71 //layer=li \
 //thickness=0.1 //x=60.975 //y=7.585 //x2=60.265 //y2=7.585
r1827 (  793 1167 ) resistor r=4.23183 //w=0.7 //l=0.175 //layer=li \
 //thickness=0.1 //x=60.18 //y=7.41 //x2=60.18 //y2=7.585
r1828 (  793 1247 ) resistor r=33.1979 //w=0.187 //l=0.485 //layer=li \
 //thickness=0.1 //x=60.18 //y=7.41 //x2=60.18 //y2=6.925
r1829 (  790 1166 ) resistor r=2.87058 //w=0.35 //l=0.085 //layer=li \
 //thickness=0.1 //x=59.385 //y=7.585 //x2=59.3 //y2=7.585
r1830 (  790 792 ) resistor r=23.5422 //w=0.367 //l=0.675 //layer=li \
 //thickness=0.1 //x=59.385 //y=7.585 //x2=60.06 //y2=7.585
r1831 (  789 1167 ) resistor r=2.87058 //w=0.35 //l=0.085 //layer=li \
 //thickness=0.1 //x=60.095 //y=7.585 //x2=60.18 //y2=7.585
r1832 (  789 792 ) resistor r=1.22071 //w=0.367 //l=0.035 //layer=li \
 //thickness=0.1 //x=60.095 //y=7.585 //x2=60.06 //y2=7.585
r1833 (  781 1166 ) resistor r=4.23183 //w=0.7 //l=0.175 //layer=li \
 //thickness=0.1 //x=59.3 //y=7.41 //x2=59.3 //y2=7.585
r1834 (  781 1246 ) resistor r=56.4706 //w=0.187 //l=0.825 //layer=li \
 //thickness=0.1 //x=59.3 //y=7.41 //x2=59.3 //y2=6.585
r1835 (  778 1165 ) resistor r=5.29055 //w=0.35 //l=0.17 //layer=li \
 //thickness=0.1 //x=58.38 //y=7.585 //x2=58.21 //y2=7.585
r1836 (  778 780 ) resistor r=19.8801 //w=0.367 //l=0.57 //layer=li \
 //thickness=0.1 //x=58.38 //y=7.585 //x2=58.95 //y2=7.585
r1837 (  777 1166 ) resistor r=2.87058 //w=0.35 //l=0.085 //layer=li \
 //thickness=0.1 //x=59.215 //y=7.585 //x2=59.3 //y2=7.585
r1838 (  777 780 ) resistor r=9.24251 //w=0.367 //l=0.265 //layer=li \
 //thickness=0.1 //x=59.215 //y=7.585 //x2=58.95 //y2=7.585
r1839 (  772 1164 ) resistor r=2.87058 //w=0.35 //l=0.085 //layer=li \
 //thickness=0.1 //x=57.215 //y=7.585 //x2=57.13 //y2=7.585
r1840 (  772 774 ) resistor r=8.89373 //w=0.367 //l=0.255 //layer=li \
 //thickness=0.1 //x=57.215 //y=7.585 //x2=57.47 //y2=7.585
r1841 (  771 1165 ) resistor r=5.29055 //w=0.35 //l=0.17 //layer=li \
 //thickness=0.1 //x=58.04 //y=7.585 //x2=58.21 //y2=7.585
r1842 (  771 774 ) resistor r=19.8801 //w=0.367 //l=0.57 //layer=li \
 //thickness=0.1 //x=58.04 //y=7.585 //x2=57.47 //y2=7.585
r1843 (  765 1164 ) resistor r=4.23183 //w=0.7 //l=0.175 //layer=li \
 //thickness=0.1 //x=57.13 //y=7.41 //x2=57.13 //y2=7.585
r1844 (  765 1245 ) resistor r=33.1979 //w=0.187 //l=0.485 //layer=li \
 //thickness=0.1 //x=57.13 //y=7.41 //x2=57.13 //y2=6.925
r1845 (  762 1163 ) resistor r=2.87058 //w=0.35 //l=0.085 //layer=li \
 //thickness=0.1 //x=56.335 //y=7.585 //x2=56.25 //y2=7.585
r1846 (  762 764 ) resistor r=0.871935 //w=0.367 //l=0.025 //layer=li \
 //thickness=0.1 //x=56.335 //y=7.585 //x2=56.36 //y2=7.585
r1847 (  761 1164 ) resistor r=2.87058 //w=0.35 //l=0.085 //layer=li \
 //thickness=0.1 //x=57.045 //y=7.585 //x2=57.13 //y2=7.585
r1848 (  761 764 ) resistor r=23.891 //w=0.367 //l=0.685 //layer=li \
 //thickness=0.1 //x=57.045 //y=7.585 //x2=56.36 //y2=7.585
r1849 (  755 1163 ) resistor r=4.23183 //w=0.7 //l=0.175 //layer=li \
 //thickness=0.1 //x=56.25 //y=7.41 //x2=56.25 //y2=7.585
r1850 (  755 1244 ) resistor r=33.1979 //w=0.187 //l=0.485 //layer=li \
 //thickness=0.1 //x=56.25 //y=7.41 //x2=56.25 //y2=6.925
r1851 (  754 1162 ) resistor r=2.87058 //w=0.35 //l=0.085 //layer=li \
 //thickness=0.1 //x=55.455 //y=7.585 //x2=55.37 //y2=7.585
r1852 (  753 1163 ) resistor r=2.87058 //w=0.35 //l=0.085 //layer=li \
 //thickness=0.1 //x=56.165 //y=7.585 //x2=56.25 //y2=7.585
r1853 (  753 754 ) resistor r=24.7629 //w=0.367 //l=0.71 //layer=li \
 //thickness=0.1 //x=56.165 //y=7.585 //x2=55.455 //y2=7.585
r1854 (  747 1162 ) resistor r=4.23183 //w=0.7 //l=0.175 //layer=li \
 //thickness=0.1 //x=55.37 //y=7.41 //x2=55.37 //y2=7.585
r1855 (  747 1243 ) resistor r=33.1979 //w=0.187 //l=0.485 //layer=li \
 //thickness=0.1 //x=55.37 //y=7.41 //x2=55.37 //y2=6.925
r1856 (  744 1161 ) resistor r=2.87058 //w=0.35 //l=0.085 //layer=li \
 //thickness=0.1 //x=54.575 //y=7.585 //x2=54.49 //y2=7.585
r1857 (  744 746 ) resistor r=23.5422 //w=0.367 //l=0.675 //layer=li \
 //thickness=0.1 //x=54.575 //y=7.585 //x2=55.25 //y2=7.585
r1858 (  743 1162 ) resistor r=2.87058 //w=0.35 //l=0.085 //layer=li \
 //thickness=0.1 //x=55.285 //y=7.585 //x2=55.37 //y2=7.585
r1859 (  743 746 ) resistor r=1.22071 //w=0.367 //l=0.035 //layer=li \
 //thickness=0.1 //x=55.285 //y=7.585 //x2=55.25 //y2=7.585
r1860 (  735 1161 ) resistor r=4.23183 //w=0.7 //l=0.175 //layer=li \
 //thickness=0.1 //x=54.49 //y=7.41 //x2=54.49 //y2=7.585
r1861 (  735 1242 ) resistor r=56.4706 //w=0.187 //l=0.825 //layer=li \
 //thickness=0.1 //x=54.49 //y=7.41 //x2=54.49 //y2=6.585
r1862 (  732 1160 ) resistor r=5.29055 //w=0.35 //l=0.17 //layer=li \
 //thickness=0.1 //x=53.57 //y=7.585 //x2=53.4 //y2=7.585
r1863 (  732 734 ) resistor r=19.8801 //w=0.367 //l=0.57 //layer=li \
 //thickness=0.1 //x=53.57 //y=7.585 //x2=54.14 //y2=7.585
r1864 (  731 1161 ) resistor r=2.87058 //w=0.35 //l=0.085 //layer=li \
 //thickness=0.1 //x=54.405 //y=7.585 //x2=54.49 //y2=7.585
r1865 (  731 734 ) resistor r=9.24251 //w=0.367 //l=0.265 //layer=li \
 //thickness=0.1 //x=54.405 //y=7.585 //x2=54.14 //y2=7.585
r1866 (  726 1159 ) resistor r=2.87058 //w=0.35 //l=0.085 //layer=li \
 //thickness=0.1 //x=52.405 //y=7.585 //x2=52.32 //y2=7.585
r1867 (  726 728 ) resistor r=8.89373 //w=0.367 //l=0.255 //layer=li \
 //thickness=0.1 //x=52.405 //y=7.585 //x2=52.66 //y2=7.585
r1868 (  725 1160 ) resistor r=5.29055 //w=0.35 //l=0.17 //layer=li \
 //thickness=0.1 //x=53.23 //y=7.585 //x2=53.4 //y2=7.585
r1869 (  725 728 ) resistor r=19.8801 //w=0.367 //l=0.57 //layer=li \
 //thickness=0.1 //x=53.23 //y=7.585 //x2=52.66 //y2=7.585
r1870 (  719 1159 ) resistor r=4.23183 //w=0.7 //l=0.175 //layer=li \
 //thickness=0.1 //x=52.32 //y=7.41 //x2=52.32 //y2=7.585
r1871 (  719 1241 ) resistor r=33.1979 //w=0.187 //l=0.485 //layer=li \
 //thickness=0.1 //x=52.32 //y=7.41 //x2=52.32 //y2=6.925
r1872 (  716 1158 ) resistor r=2.87058 //w=0.35 //l=0.085 //layer=li \
 //thickness=0.1 //x=51.525 //y=7.585 //x2=51.44 //y2=7.585
r1873 (  716 718 ) resistor r=0.871935 //w=0.367 //l=0.025 //layer=li \
 //thickness=0.1 //x=51.525 //y=7.585 //x2=51.55 //y2=7.585
r1874 (  715 1159 ) resistor r=2.87058 //w=0.35 //l=0.085 //layer=li \
 //thickness=0.1 //x=52.235 //y=7.585 //x2=52.32 //y2=7.585
r1875 (  715 718 ) resistor r=23.891 //w=0.367 //l=0.685 //layer=li \
 //thickness=0.1 //x=52.235 //y=7.585 //x2=51.55 //y2=7.585
r1876 (  709 1158 ) resistor r=4.23183 //w=0.7 //l=0.175 //layer=li \
 //thickness=0.1 //x=51.44 //y=7.41 //x2=51.44 //y2=7.585
r1877 (  709 1240 ) resistor r=33.1979 //w=0.187 //l=0.485 //layer=li \
 //thickness=0.1 //x=51.44 //y=7.41 //x2=51.44 //y2=6.925
r1878 (  708 1157 ) resistor r=2.87058 //w=0.35 //l=0.085 //layer=li \
 //thickness=0.1 //x=50.645 //y=7.585 //x2=50.56 //y2=7.585
r1879 (  707 1158 ) resistor r=2.87058 //w=0.35 //l=0.085 //layer=li \
 //thickness=0.1 //x=51.355 //y=7.585 //x2=51.44 //y2=7.585
r1880 (  707 708 ) resistor r=24.7629 //w=0.367 //l=0.71 //layer=li \
 //thickness=0.1 //x=51.355 //y=7.585 //x2=50.645 //y2=7.585
r1881 (  701 1157 ) resistor r=4.23183 //w=0.7 //l=0.175 //layer=li \
 //thickness=0.1 //x=50.56 //y=7.41 //x2=50.56 //y2=7.585
r1882 (  701 1239 ) resistor r=33.1979 //w=0.187 //l=0.485 //layer=li \
 //thickness=0.1 //x=50.56 //y=7.41 //x2=50.56 //y2=6.925
r1883 (  698 1156 ) resistor r=2.87058 //w=0.35 //l=0.085 //layer=li \
 //thickness=0.1 //x=49.765 //y=7.585 //x2=49.68 //y2=7.585
r1884 (  698 700 ) resistor r=23.5422 //w=0.367 //l=0.675 //layer=li \
 //thickness=0.1 //x=49.765 //y=7.585 //x2=50.44 //y2=7.585
r1885 (  697 1157 ) resistor r=2.87058 //w=0.35 //l=0.085 //layer=li \
 //thickness=0.1 //x=50.475 //y=7.585 //x2=50.56 //y2=7.585
r1886 (  697 700 ) resistor r=1.22071 //w=0.367 //l=0.035 //layer=li \
 //thickness=0.1 //x=50.475 //y=7.585 //x2=50.44 //y2=7.585
r1887 (  689 1156 ) resistor r=4.23183 //w=0.7 //l=0.175 //layer=li \
 //thickness=0.1 //x=49.68 //y=7.41 //x2=49.68 //y2=7.585
r1888 (  689 1238 ) resistor r=56.4706 //w=0.187 //l=0.825 //layer=li \
 //thickness=0.1 //x=49.68 //y=7.41 //x2=49.68 //y2=6.585
r1889 (  686 1155 ) resistor r=5.29055 //w=0.35 //l=0.17 //layer=li \
 //thickness=0.1 //x=48.76 //y=7.585 //x2=48.59 //y2=7.585
r1890 (  686 688 ) resistor r=19.8801 //w=0.367 //l=0.57 //layer=li \
 //thickness=0.1 //x=48.76 //y=7.585 //x2=49.33 //y2=7.585
r1891 (  685 1156 ) resistor r=2.87058 //w=0.35 //l=0.085 //layer=li \
 //thickness=0.1 //x=49.595 //y=7.585 //x2=49.68 //y2=7.585
r1892 (  685 688 ) resistor r=9.24251 //w=0.367 //l=0.265 //layer=li \
 //thickness=0.1 //x=49.595 //y=7.585 //x2=49.33 //y2=7.585
r1893 (  680 1154 ) resistor r=2.87058 //w=0.35 //l=0.085 //layer=li \
 //thickness=0.1 //x=47.595 //y=7.585 //x2=47.51 //y2=7.585
r1894 (  680 682 ) resistor r=8.89373 //w=0.367 //l=0.255 //layer=li \
 //thickness=0.1 //x=47.595 //y=7.585 //x2=47.85 //y2=7.585
r1895 (  679 1155 ) resistor r=5.29055 //w=0.35 //l=0.17 //layer=li \
 //thickness=0.1 //x=48.42 //y=7.585 //x2=48.59 //y2=7.585
r1896 (  679 682 ) resistor r=19.8801 //w=0.367 //l=0.57 //layer=li \
 //thickness=0.1 //x=48.42 //y=7.585 //x2=47.85 //y2=7.585
r1897 (  673 1154 ) resistor r=4.23183 //w=0.7 //l=0.175 //layer=li \
 //thickness=0.1 //x=47.51 //y=7.41 //x2=47.51 //y2=7.585
r1898 (  673 1237 ) resistor r=33.1979 //w=0.187 //l=0.485 //layer=li \
 //thickness=0.1 //x=47.51 //y=7.41 //x2=47.51 //y2=6.925
r1899 (  670 1153 ) resistor r=2.87058 //w=0.35 //l=0.085 //layer=li \
 //thickness=0.1 //x=46.715 //y=7.585 //x2=46.63 //y2=7.585
r1900 (  670 672 ) resistor r=0.871935 //w=0.367 //l=0.025 //layer=li \
 //thickness=0.1 //x=46.715 //y=7.585 //x2=46.74 //y2=7.585
r1901 (  669 1154 ) resistor r=2.87058 //w=0.35 //l=0.085 //layer=li \
 //thickness=0.1 //x=47.425 //y=7.585 //x2=47.51 //y2=7.585
r1902 (  669 672 ) resistor r=23.891 //w=0.367 //l=0.685 //layer=li \
 //thickness=0.1 //x=47.425 //y=7.585 //x2=46.74 //y2=7.585
r1903 (  663 1153 ) resistor r=4.23183 //w=0.7 //l=0.175 //layer=li \
 //thickness=0.1 //x=46.63 //y=7.41 //x2=46.63 //y2=7.585
r1904 (  663 1236 ) resistor r=33.1979 //w=0.187 //l=0.485 //layer=li \
 //thickness=0.1 //x=46.63 //y=7.41 //x2=46.63 //y2=6.925
r1905 (  662 1152 ) resistor r=2.87058 //w=0.35 //l=0.085 //layer=li \
 //thickness=0.1 //x=45.835 //y=7.585 //x2=45.75 //y2=7.585
r1906 (  661 1153 ) resistor r=2.87058 //w=0.35 //l=0.085 //layer=li \
 //thickness=0.1 //x=46.545 //y=7.585 //x2=46.63 //y2=7.585
r1907 (  661 662 ) resistor r=24.7629 //w=0.367 //l=0.71 //layer=li \
 //thickness=0.1 //x=46.545 //y=7.585 //x2=45.835 //y2=7.585
r1908 (  655 1152 ) resistor r=4.23183 //w=0.7 //l=0.175 //layer=li \
 //thickness=0.1 //x=45.75 //y=7.41 //x2=45.75 //y2=7.585
r1909 (  655 1235 ) resistor r=33.1979 //w=0.187 //l=0.485 //layer=li \
 //thickness=0.1 //x=45.75 //y=7.41 //x2=45.75 //y2=6.925
r1910 (  652 1151 ) resistor r=2.87058 //w=0.35 //l=0.085 //layer=li \
 //thickness=0.1 //x=44.955 //y=7.585 //x2=44.87 //y2=7.585
r1911 (  652 654 ) resistor r=23.5422 //w=0.367 //l=0.675 //layer=li \
 //thickness=0.1 //x=44.955 //y=7.585 //x2=45.63 //y2=7.585
r1912 (  651 1152 ) resistor r=2.87058 //w=0.35 //l=0.085 //layer=li \
 //thickness=0.1 //x=45.665 //y=7.585 //x2=45.75 //y2=7.585
r1913 (  651 654 ) resistor r=1.22071 //w=0.367 //l=0.035 //layer=li \
 //thickness=0.1 //x=45.665 //y=7.585 //x2=45.63 //y2=7.585
r1914 (  643 1151 ) resistor r=4.23183 //w=0.7 //l=0.175 //layer=li \
 //thickness=0.1 //x=44.87 //y=7.41 //x2=44.87 //y2=7.585
r1915 (  643 1234 ) resistor r=56.4706 //w=0.187 //l=0.825 //layer=li \
 //thickness=0.1 //x=44.87 //y=7.41 //x2=44.87 //y2=6.585
r1916 (  640 1150 ) resistor r=5.29055 //w=0.35 //l=0.17 //layer=li \
 //thickness=0.1 //x=43.95 //y=7.585 //x2=43.78 //y2=7.585
r1917 (  640 642 ) resistor r=19.8801 //w=0.367 //l=0.57 //layer=li \
 //thickness=0.1 //x=43.95 //y=7.585 //x2=44.52 //y2=7.585
r1918 (  639 1151 ) resistor r=2.87058 //w=0.35 //l=0.085 //layer=li \
 //thickness=0.1 //x=44.785 //y=7.585 //x2=44.87 //y2=7.585
r1919 (  639 642 ) resistor r=9.24251 //w=0.367 //l=0.265 //layer=li \
 //thickness=0.1 //x=44.785 //y=7.585 //x2=44.52 //y2=7.585
r1920 (  634 1149 ) resistor r=2.87058 //w=0.35 //l=0.085 //layer=li \
 //thickness=0.1 //x=42.785 //y=7.585 //x2=42.7 //y2=7.585
r1921 (  634 636 ) resistor r=8.89373 //w=0.367 //l=0.255 //layer=li \
 //thickness=0.1 //x=42.785 //y=7.585 //x2=43.04 //y2=7.585
r1922 (  633 1150 ) resistor r=5.29055 //w=0.35 //l=0.17 //layer=li \
 //thickness=0.1 //x=43.61 //y=7.585 //x2=43.78 //y2=7.585
r1923 (  633 636 ) resistor r=19.8801 //w=0.367 //l=0.57 //layer=li \
 //thickness=0.1 //x=43.61 //y=7.585 //x2=43.04 //y2=7.585
r1924 (  627 1149 ) resistor r=4.23183 //w=0.7 //l=0.175 //layer=li \
 //thickness=0.1 //x=42.7 //y=7.41 //x2=42.7 //y2=7.585
r1925 (  627 1233 ) resistor r=33.1979 //w=0.187 //l=0.485 //layer=li \
 //thickness=0.1 //x=42.7 //y=7.41 //x2=42.7 //y2=6.925
r1926 (  624 1148 ) resistor r=2.87058 //w=0.35 //l=0.085 //layer=li \
 //thickness=0.1 //x=41.905 //y=7.585 //x2=41.82 //y2=7.585
r1927 (  624 626 ) resistor r=0.871935 //w=0.367 //l=0.025 //layer=li \
 //thickness=0.1 //x=41.905 //y=7.585 //x2=41.93 //y2=7.585
r1928 (  623 1149 ) resistor r=2.87058 //w=0.35 //l=0.085 //layer=li \
 //thickness=0.1 //x=42.615 //y=7.585 //x2=42.7 //y2=7.585
r1929 (  623 626 ) resistor r=23.891 //w=0.367 //l=0.685 //layer=li \
 //thickness=0.1 //x=42.615 //y=7.585 //x2=41.93 //y2=7.585
r1930 (  617 1148 ) resistor r=4.23183 //w=0.7 //l=0.175 //layer=li \
 //thickness=0.1 //x=41.82 //y=7.41 //x2=41.82 //y2=7.585
r1931 (  617 1232 ) resistor r=33.1979 //w=0.187 //l=0.485 //layer=li \
 //thickness=0.1 //x=41.82 //y=7.41 //x2=41.82 //y2=6.925
r1932 (  616 1147 ) resistor r=2.87058 //w=0.35 //l=0.085 //layer=li \
 //thickness=0.1 //x=41.025 //y=7.585 //x2=40.94 //y2=7.585
r1933 (  615 1148 ) resistor r=2.87058 //w=0.35 //l=0.085 //layer=li \
 //thickness=0.1 //x=41.735 //y=7.585 //x2=41.82 //y2=7.585
r1934 (  615 616 ) resistor r=24.7629 //w=0.367 //l=0.71 //layer=li \
 //thickness=0.1 //x=41.735 //y=7.585 //x2=41.025 //y2=7.585
r1935 (  609 1147 ) resistor r=4.23183 //w=0.7 //l=0.175 //layer=li \
 //thickness=0.1 //x=40.94 //y=7.41 //x2=40.94 //y2=7.585
r1936 (  609 1231 ) resistor r=33.1979 //w=0.187 //l=0.485 //layer=li \
 //thickness=0.1 //x=40.94 //y=7.41 //x2=40.94 //y2=6.925
r1937 (  606 1146 ) resistor r=2.87058 //w=0.35 //l=0.085 //layer=li \
 //thickness=0.1 //x=40.145 //y=7.585 //x2=40.06 //y2=7.585
r1938 (  606 608 ) resistor r=23.5422 //w=0.367 //l=0.675 //layer=li \
 //thickness=0.1 //x=40.145 //y=7.585 //x2=40.82 //y2=7.585
r1939 (  605 1147 ) resistor r=2.87058 //w=0.35 //l=0.085 //layer=li \
 //thickness=0.1 //x=40.855 //y=7.585 //x2=40.94 //y2=7.585
r1940 (  605 608 ) resistor r=1.22071 //w=0.367 //l=0.035 //layer=li \
 //thickness=0.1 //x=40.855 //y=7.585 //x2=40.82 //y2=7.585
r1941 (  597 1146 ) resistor r=4.23183 //w=0.7 //l=0.175 //layer=li \
 //thickness=0.1 //x=40.06 //y=7.41 //x2=40.06 //y2=7.585
r1942 (  597 1230 ) resistor r=56.4706 //w=0.187 //l=0.825 //layer=li \
 //thickness=0.1 //x=40.06 //y=7.41 //x2=40.06 //y2=6.585
r1943 (  594 1145 ) resistor r=5.29055 //w=0.35 //l=0.17 //layer=li \
 //thickness=0.1 //x=39.14 //y=7.585 //x2=38.97 //y2=7.585
r1944 (  594 596 ) resistor r=19.8801 //w=0.367 //l=0.57 //layer=li \
 //thickness=0.1 //x=39.14 //y=7.585 //x2=39.71 //y2=7.585
r1945 (  593 1146 ) resistor r=2.87058 //w=0.35 //l=0.085 //layer=li \
 //thickness=0.1 //x=39.975 //y=7.585 //x2=40.06 //y2=7.585
r1946 (  593 596 ) resistor r=9.24251 //w=0.367 //l=0.265 //layer=li \
 //thickness=0.1 //x=39.975 //y=7.585 //x2=39.71 //y2=7.585
r1947 (  588 1144 ) resistor r=2.87058 //w=0.35 //l=0.085 //layer=li \
 //thickness=0.1 //x=37.975 //y=7.585 //x2=37.89 //y2=7.585
r1948 (  588 590 ) resistor r=8.89373 //w=0.367 //l=0.255 //layer=li \
 //thickness=0.1 //x=37.975 //y=7.585 //x2=38.23 //y2=7.585
r1949 (  587 1145 ) resistor r=5.29055 //w=0.35 //l=0.17 //layer=li \
 //thickness=0.1 //x=38.8 //y=7.585 //x2=38.97 //y2=7.585
r1950 (  587 590 ) resistor r=19.8801 //w=0.367 //l=0.57 //layer=li \
 //thickness=0.1 //x=38.8 //y=7.585 //x2=38.23 //y2=7.585
r1951 (  581 1144 ) resistor r=4.23183 //w=0.7 //l=0.175 //layer=li \
 //thickness=0.1 //x=37.89 //y=7.41 //x2=37.89 //y2=7.585
r1952 (  581 1229 ) resistor r=33.1979 //w=0.187 //l=0.485 //layer=li \
 //thickness=0.1 //x=37.89 //y=7.41 //x2=37.89 //y2=6.925
r1953 (  578 1143 ) resistor r=2.87058 //w=0.35 //l=0.085 //layer=li \
 //thickness=0.1 //x=37.095 //y=7.585 //x2=37.01 //y2=7.585
r1954 (  578 580 ) resistor r=0.871935 //w=0.367 //l=0.025 //layer=li \
 //thickness=0.1 //x=37.095 //y=7.585 //x2=37.12 //y2=7.585
r1955 (  577 1144 ) resistor r=2.87058 //w=0.35 //l=0.085 //layer=li \
 //thickness=0.1 //x=37.805 //y=7.585 //x2=37.89 //y2=7.585
r1956 (  577 580 ) resistor r=23.891 //w=0.367 //l=0.685 //layer=li \
 //thickness=0.1 //x=37.805 //y=7.585 //x2=37.12 //y2=7.585
r1957 (  571 1143 ) resistor r=4.23183 //w=0.7 //l=0.175 //layer=li \
 //thickness=0.1 //x=37.01 //y=7.41 //x2=37.01 //y2=7.585
r1958 (  571 1228 ) resistor r=33.1979 //w=0.187 //l=0.485 //layer=li \
 //thickness=0.1 //x=37.01 //y=7.41 //x2=37.01 //y2=6.925
r1959 (  570 1142 ) resistor r=2.87058 //w=0.35 //l=0.085 //layer=li \
 //thickness=0.1 //x=36.215 //y=7.585 //x2=36.13 //y2=7.585
r1960 (  569 1143 ) resistor r=2.87058 //w=0.35 //l=0.085 //layer=li \
 //thickness=0.1 //x=36.925 //y=7.585 //x2=37.01 //y2=7.585
r1961 (  569 570 ) resistor r=24.7629 //w=0.367 //l=0.71 //layer=li \
 //thickness=0.1 //x=36.925 //y=7.585 //x2=36.215 //y2=7.585
r1962 (  563 1142 ) resistor r=4.23183 //w=0.7 //l=0.175 //layer=li \
 //thickness=0.1 //x=36.13 //y=7.41 //x2=36.13 //y2=7.585
r1963 (  563 1227 ) resistor r=33.1979 //w=0.187 //l=0.485 //layer=li \
 //thickness=0.1 //x=36.13 //y=7.41 //x2=36.13 //y2=6.925
r1964 (  560 1141 ) resistor r=2.87058 //w=0.35 //l=0.085 //layer=li \
 //thickness=0.1 //x=35.335 //y=7.585 //x2=35.25 //y2=7.585
r1965 (  560 562 ) resistor r=23.5422 //w=0.367 //l=0.675 //layer=li \
 //thickness=0.1 //x=35.335 //y=7.585 //x2=36.01 //y2=7.585
r1966 (  559 1142 ) resistor r=2.87058 //w=0.35 //l=0.085 //layer=li \
 //thickness=0.1 //x=36.045 //y=7.585 //x2=36.13 //y2=7.585
r1967 (  559 562 ) resistor r=1.22071 //w=0.367 //l=0.035 //layer=li \
 //thickness=0.1 //x=36.045 //y=7.585 //x2=36.01 //y2=7.585
r1968 (  551 1141 ) resistor r=4.23183 //w=0.7 //l=0.175 //layer=li \
 //thickness=0.1 //x=35.25 //y=7.41 //x2=35.25 //y2=7.585
r1969 (  551 1226 ) resistor r=56.4706 //w=0.187 //l=0.825 //layer=li \
 //thickness=0.1 //x=35.25 //y=7.41 //x2=35.25 //y2=6.585
r1970 (  548 1140 ) resistor r=5.29055 //w=0.35 //l=0.17 //layer=li \
 //thickness=0.1 //x=34.33 //y=7.585 //x2=34.16 //y2=7.585
r1971 (  548 550 ) resistor r=19.8801 //w=0.367 //l=0.57 //layer=li \
 //thickness=0.1 //x=34.33 //y=7.585 //x2=34.9 //y2=7.585
r1972 (  547 1141 ) resistor r=2.87058 //w=0.35 //l=0.085 //layer=li \
 //thickness=0.1 //x=35.165 //y=7.585 //x2=35.25 //y2=7.585
r1973 (  547 550 ) resistor r=9.24251 //w=0.367 //l=0.265 //layer=li \
 //thickness=0.1 //x=35.165 //y=7.585 //x2=34.9 //y2=7.585
r1974 (  542 1139 ) resistor r=2.87058 //w=0.35 //l=0.085 //layer=li \
 //thickness=0.1 //x=33.165 //y=7.585 //x2=33.08 //y2=7.585
r1975 (  542 544 ) resistor r=8.89373 //w=0.367 //l=0.255 //layer=li \
 //thickness=0.1 //x=33.165 //y=7.585 //x2=33.42 //y2=7.585
r1976 (  541 1140 ) resistor r=5.29055 //w=0.35 //l=0.17 //layer=li \
 //thickness=0.1 //x=33.99 //y=7.585 //x2=34.16 //y2=7.585
r1977 (  541 544 ) resistor r=19.8801 //w=0.367 //l=0.57 //layer=li \
 //thickness=0.1 //x=33.99 //y=7.585 //x2=33.42 //y2=7.585
r1978 (  535 1139 ) resistor r=4.23183 //w=0.7 //l=0.175 //layer=li \
 //thickness=0.1 //x=33.08 //y=7.41 //x2=33.08 //y2=7.585
r1979 (  535 1225 ) resistor r=33.1979 //w=0.187 //l=0.485 //layer=li \
 //thickness=0.1 //x=33.08 //y=7.41 //x2=33.08 //y2=6.925
r1980 (  532 1138 ) resistor r=2.87058 //w=0.35 //l=0.085 //layer=li \
 //thickness=0.1 //x=32.285 //y=7.585 //x2=32.2 //y2=7.585
r1981 (  532 534 ) resistor r=0.871935 //w=0.367 //l=0.025 //layer=li \
 //thickness=0.1 //x=32.285 //y=7.585 //x2=32.31 //y2=7.585
r1982 (  531 1139 ) resistor r=2.87058 //w=0.35 //l=0.085 //layer=li \
 //thickness=0.1 //x=32.995 //y=7.585 //x2=33.08 //y2=7.585
r1983 (  531 534 ) resistor r=23.891 //w=0.367 //l=0.685 //layer=li \
 //thickness=0.1 //x=32.995 //y=7.585 //x2=32.31 //y2=7.585
r1984 (  525 1138 ) resistor r=4.23183 //w=0.7 //l=0.175 //layer=li \
 //thickness=0.1 //x=32.2 //y=7.41 //x2=32.2 //y2=7.585
r1985 (  525 1224 ) resistor r=33.1979 //w=0.187 //l=0.485 //layer=li \
 //thickness=0.1 //x=32.2 //y=7.41 //x2=32.2 //y2=6.925
r1986 (  524 1137 ) resistor r=2.87058 //w=0.35 //l=0.085 //layer=li \
 //thickness=0.1 //x=31.405 //y=7.585 //x2=31.32 //y2=7.585
r1987 (  523 1138 ) resistor r=2.87058 //w=0.35 //l=0.085 //layer=li \
 //thickness=0.1 //x=32.115 //y=7.585 //x2=32.2 //y2=7.585
r1988 (  523 524 ) resistor r=24.7629 //w=0.367 //l=0.71 //layer=li \
 //thickness=0.1 //x=32.115 //y=7.585 //x2=31.405 //y2=7.585
r1989 (  517 1137 ) resistor r=4.23183 //w=0.7 //l=0.175 //layer=li \
 //thickness=0.1 //x=31.32 //y=7.41 //x2=31.32 //y2=7.585
r1990 (  517 1223 ) resistor r=33.1979 //w=0.187 //l=0.485 //layer=li \
 //thickness=0.1 //x=31.32 //y=7.41 //x2=31.32 //y2=6.925
r1991 (  514 1136 ) resistor r=2.87058 //w=0.35 //l=0.085 //layer=li \
 //thickness=0.1 //x=30.525 //y=7.585 //x2=30.44 //y2=7.585
r1992 (  514 516 ) resistor r=23.5422 //w=0.367 //l=0.675 //layer=li \
 //thickness=0.1 //x=30.525 //y=7.585 //x2=31.2 //y2=7.585
r1993 (  513 1137 ) resistor r=2.87058 //w=0.35 //l=0.085 //layer=li \
 //thickness=0.1 //x=31.235 //y=7.585 //x2=31.32 //y2=7.585
r1994 (  513 516 ) resistor r=1.22071 //w=0.367 //l=0.035 //layer=li \
 //thickness=0.1 //x=31.235 //y=7.585 //x2=31.2 //y2=7.585
r1995 (  505 1136 ) resistor r=4.23183 //w=0.7 //l=0.175 //layer=li \
 //thickness=0.1 //x=30.44 //y=7.41 //x2=30.44 //y2=7.585
r1996 (  505 1222 ) resistor r=56.4706 //w=0.187 //l=0.825 //layer=li \
 //thickness=0.1 //x=30.44 //y=7.41 //x2=30.44 //y2=6.585
r1997 (  502 1135 ) resistor r=5.29055 //w=0.35 //l=0.17 //layer=li \
 //thickness=0.1 //x=29.52 //y=7.585 //x2=29.35 //y2=7.585
r1998 (  502 504 ) resistor r=19.8801 //w=0.367 //l=0.57 //layer=li \
 //thickness=0.1 //x=29.52 //y=7.585 //x2=30.09 //y2=7.585
r1999 (  501 1136 ) resistor r=2.87058 //w=0.35 //l=0.085 //layer=li \
 //thickness=0.1 //x=30.355 //y=7.585 //x2=30.44 //y2=7.585
r2000 (  501 504 ) resistor r=9.24251 //w=0.367 //l=0.265 //layer=li \
 //thickness=0.1 //x=30.355 //y=7.585 //x2=30.09 //y2=7.585
r2001 (  496 1134 ) resistor r=2.87058 //w=0.35 //l=0.085 //layer=li \
 //thickness=0.1 //x=28.355 //y=7.585 //x2=28.27 //y2=7.585
r2002 (  496 498 ) resistor r=8.89373 //w=0.367 //l=0.255 //layer=li \
 //thickness=0.1 //x=28.355 //y=7.585 //x2=28.61 //y2=7.585
r2003 (  495 1135 ) resistor r=5.29055 //w=0.35 //l=0.17 //layer=li \
 //thickness=0.1 //x=29.18 //y=7.585 //x2=29.35 //y2=7.585
r2004 (  495 498 ) resistor r=19.8801 //w=0.367 //l=0.57 //layer=li \
 //thickness=0.1 //x=29.18 //y=7.585 //x2=28.61 //y2=7.585
r2005 (  489 1134 ) resistor r=4.23183 //w=0.7 //l=0.175 //layer=li \
 //thickness=0.1 //x=28.27 //y=7.41 //x2=28.27 //y2=7.585
r2006 (  489 1221 ) resistor r=33.1979 //w=0.187 //l=0.485 //layer=li \
 //thickness=0.1 //x=28.27 //y=7.41 //x2=28.27 //y2=6.925
r2007 (  486 1133 ) resistor r=2.87058 //w=0.35 //l=0.085 //layer=li \
 //thickness=0.1 //x=27.475 //y=7.585 //x2=27.39 //y2=7.585
r2008 (  486 488 ) resistor r=0.871935 //w=0.367 //l=0.025 //layer=li \
 //thickness=0.1 //x=27.475 //y=7.585 //x2=27.5 //y2=7.585
r2009 (  485 1134 ) resistor r=2.87058 //w=0.35 //l=0.085 //layer=li \
 //thickness=0.1 //x=28.185 //y=7.585 //x2=28.27 //y2=7.585
r2010 (  485 488 ) resistor r=23.891 //w=0.367 //l=0.685 //layer=li \
 //thickness=0.1 //x=28.185 //y=7.585 //x2=27.5 //y2=7.585
r2011 (  479 1133 ) resistor r=4.23183 //w=0.7 //l=0.175 //layer=li \
 //thickness=0.1 //x=27.39 //y=7.41 //x2=27.39 //y2=7.585
r2012 (  479 1220 ) resistor r=33.1979 //w=0.187 //l=0.485 //layer=li \
 //thickness=0.1 //x=27.39 //y=7.41 //x2=27.39 //y2=6.925
r2013 (  478 1132 ) resistor r=2.87058 //w=0.35 //l=0.085 //layer=li \
 //thickness=0.1 //x=26.595 //y=7.585 //x2=26.51 //y2=7.585
r2014 (  477 1133 ) resistor r=2.87058 //w=0.35 //l=0.085 //layer=li \
 //thickness=0.1 //x=27.305 //y=7.585 //x2=27.39 //y2=7.585
r2015 (  477 478 ) resistor r=24.7629 //w=0.367 //l=0.71 //layer=li \
 //thickness=0.1 //x=27.305 //y=7.585 //x2=26.595 //y2=7.585
r2016 (  471 1132 ) resistor r=4.23183 //w=0.7 //l=0.175 //layer=li \
 //thickness=0.1 //x=26.51 //y=7.41 //x2=26.51 //y2=7.585
r2017 (  471 1219 ) resistor r=33.1979 //w=0.187 //l=0.485 //layer=li \
 //thickness=0.1 //x=26.51 //y=7.41 //x2=26.51 //y2=6.925
r2018 (  468 1131 ) resistor r=2.87058 //w=0.35 //l=0.085 //layer=li \
 //thickness=0.1 //x=25.715 //y=7.585 //x2=25.63 //y2=7.585
r2019 (  468 470 ) resistor r=23.5422 //w=0.367 //l=0.675 //layer=li \
 //thickness=0.1 //x=25.715 //y=7.585 //x2=26.39 //y2=7.585
r2020 (  467 1132 ) resistor r=2.87058 //w=0.35 //l=0.085 //layer=li \
 //thickness=0.1 //x=26.425 //y=7.585 //x2=26.51 //y2=7.585
r2021 (  467 470 ) resistor r=1.22071 //w=0.367 //l=0.035 //layer=li \
 //thickness=0.1 //x=26.425 //y=7.585 //x2=26.39 //y2=7.585
r2022 (  459 1131 ) resistor r=4.23183 //w=0.7 //l=0.175 //layer=li \
 //thickness=0.1 //x=25.63 //y=7.41 //x2=25.63 //y2=7.585
r2023 (  459 1218 ) resistor r=56.4706 //w=0.187 //l=0.825 //layer=li \
 //thickness=0.1 //x=25.63 //y=7.41 //x2=25.63 //y2=6.585
r2024 (  456 1130 ) resistor r=5.29055 //w=0.35 //l=0.17 //layer=li \
 //thickness=0.1 //x=24.71 //y=7.585 //x2=24.54 //y2=7.585
r2025 (  456 458 ) resistor r=19.8801 //w=0.367 //l=0.57 //layer=li \
 //thickness=0.1 //x=24.71 //y=7.585 //x2=25.28 //y2=7.585
r2026 (  455 1131 ) resistor r=2.87058 //w=0.35 //l=0.085 //layer=li \
 //thickness=0.1 //x=25.545 //y=7.585 //x2=25.63 //y2=7.585
r2027 (  455 458 ) resistor r=9.24251 //w=0.367 //l=0.265 //layer=li \
 //thickness=0.1 //x=25.545 //y=7.585 //x2=25.28 //y2=7.585
r2028 (  450 1129 ) resistor r=2.87058 //w=0.35 //l=0.085 //layer=li \
 //thickness=0.1 //x=23.545 //y=7.585 //x2=23.46 //y2=7.585
r2029 (  450 452 ) resistor r=8.89373 //w=0.367 //l=0.255 //layer=li \
 //thickness=0.1 //x=23.545 //y=7.585 //x2=23.8 //y2=7.585
r2030 (  449 1130 ) resistor r=5.29055 //w=0.35 //l=0.17 //layer=li \
 //thickness=0.1 //x=24.37 //y=7.585 //x2=24.54 //y2=7.585
r2031 (  449 452 ) resistor r=19.8801 //w=0.367 //l=0.57 //layer=li \
 //thickness=0.1 //x=24.37 //y=7.585 //x2=23.8 //y2=7.585
r2032 (  443 1129 ) resistor r=4.23183 //w=0.7 //l=0.175 //layer=li \
 //thickness=0.1 //x=23.46 //y=7.41 //x2=23.46 //y2=7.585
r2033 (  443 1217 ) resistor r=33.1979 //w=0.187 //l=0.485 //layer=li \
 //thickness=0.1 //x=23.46 //y=7.41 //x2=23.46 //y2=6.925
r2034 (  440 1128 ) resistor r=2.87058 //w=0.35 //l=0.085 //layer=li \
 //thickness=0.1 //x=22.665 //y=7.585 //x2=22.58 //y2=7.585
r2035 (  440 442 ) resistor r=0.871935 //w=0.367 //l=0.025 //layer=li \
 //thickness=0.1 //x=22.665 //y=7.585 //x2=22.69 //y2=7.585
r2036 (  439 1129 ) resistor r=2.87058 //w=0.35 //l=0.085 //layer=li \
 //thickness=0.1 //x=23.375 //y=7.585 //x2=23.46 //y2=7.585
r2037 (  439 442 ) resistor r=23.891 //w=0.367 //l=0.685 //layer=li \
 //thickness=0.1 //x=23.375 //y=7.585 //x2=22.69 //y2=7.585
r2038 (  433 1128 ) resistor r=4.23183 //w=0.7 //l=0.175 //layer=li \
 //thickness=0.1 //x=22.58 //y=7.41 //x2=22.58 //y2=7.585
r2039 (  433 1216 ) resistor r=33.1979 //w=0.187 //l=0.485 //layer=li \
 //thickness=0.1 //x=22.58 //y=7.41 //x2=22.58 //y2=6.925
r2040 (  432 1127 ) resistor r=2.87058 //w=0.35 //l=0.085 //layer=li \
 //thickness=0.1 //x=21.785 //y=7.585 //x2=21.7 //y2=7.585
r2041 (  431 1128 ) resistor r=2.87058 //w=0.35 //l=0.085 //layer=li \
 //thickness=0.1 //x=22.495 //y=7.585 //x2=22.58 //y2=7.585
r2042 (  431 432 ) resistor r=24.7629 //w=0.367 //l=0.71 //layer=li \
 //thickness=0.1 //x=22.495 //y=7.585 //x2=21.785 //y2=7.585
r2043 (  425 1127 ) resistor r=4.23183 //w=0.7 //l=0.175 //layer=li \
 //thickness=0.1 //x=21.7 //y=7.41 //x2=21.7 //y2=7.585
r2044 (  425 1215 ) resistor r=33.1979 //w=0.187 //l=0.485 //layer=li \
 //thickness=0.1 //x=21.7 //y=7.41 //x2=21.7 //y2=6.925
r2045 (  422 1126 ) resistor r=2.87058 //w=0.35 //l=0.085 //layer=li \
 //thickness=0.1 //x=20.905 //y=7.585 //x2=20.82 //y2=7.585
r2046 (  422 424 ) resistor r=23.5422 //w=0.367 //l=0.675 //layer=li \
 //thickness=0.1 //x=20.905 //y=7.585 //x2=21.58 //y2=7.585
r2047 (  421 1127 ) resistor r=2.87058 //w=0.35 //l=0.085 //layer=li \
 //thickness=0.1 //x=21.615 //y=7.585 //x2=21.7 //y2=7.585
r2048 (  421 424 ) resistor r=1.22071 //w=0.367 //l=0.035 //layer=li \
 //thickness=0.1 //x=21.615 //y=7.585 //x2=21.58 //y2=7.585
r2049 (  413 1126 ) resistor r=4.23183 //w=0.7 //l=0.175 //layer=li \
 //thickness=0.1 //x=20.82 //y=7.41 //x2=20.82 //y2=7.585
r2050 (  413 1214 ) resistor r=56.4706 //w=0.187 //l=0.825 //layer=li \
 //thickness=0.1 //x=20.82 //y=7.41 //x2=20.82 //y2=6.585
r2051 (  410 1125 ) resistor r=5.29055 //w=0.35 //l=0.17 //layer=li \
 //thickness=0.1 //x=19.9 //y=7.585 //x2=19.73 //y2=7.585
r2052 (  410 412 ) resistor r=19.8801 //w=0.367 //l=0.57 //layer=li \
 //thickness=0.1 //x=19.9 //y=7.585 //x2=20.47 //y2=7.585
r2053 (  409 1126 ) resistor r=2.87058 //w=0.35 //l=0.085 //layer=li \
 //thickness=0.1 //x=20.735 //y=7.585 //x2=20.82 //y2=7.585
r2054 (  409 412 ) resistor r=9.24251 //w=0.367 //l=0.265 //layer=li \
 //thickness=0.1 //x=20.735 //y=7.585 //x2=20.47 //y2=7.585
r2055 (  404 1124 ) resistor r=2.87058 //w=0.35 //l=0.085 //layer=li \
 //thickness=0.1 //x=18.735 //y=7.585 //x2=18.65 //y2=7.585
r2056 (  404 406 ) resistor r=8.89373 //w=0.367 //l=0.255 //layer=li \
 //thickness=0.1 //x=18.735 //y=7.585 //x2=18.99 //y2=7.585
r2057 (  403 1125 ) resistor r=5.29055 //w=0.35 //l=0.17 //layer=li \
 //thickness=0.1 //x=19.56 //y=7.585 //x2=19.73 //y2=7.585
r2058 (  403 406 ) resistor r=19.8801 //w=0.367 //l=0.57 //layer=li \
 //thickness=0.1 //x=19.56 //y=7.585 //x2=18.99 //y2=7.585
r2059 (  397 1124 ) resistor r=4.23183 //w=0.7 //l=0.175 //layer=li \
 //thickness=0.1 //x=18.65 //y=7.41 //x2=18.65 //y2=7.585
r2060 (  397 1213 ) resistor r=33.1979 //w=0.187 //l=0.485 //layer=li \
 //thickness=0.1 //x=18.65 //y=7.41 //x2=18.65 //y2=6.925
r2061 (  394 1123 ) resistor r=2.87058 //w=0.35 //l=0.085 //layer=li \
 //thickness=0.1 //x=17.855 //y=7.585 //x2=17.77 //y2=7.585
r2062 (  394 396 ) resistor r=0.871935 //w=0.367 //l=0.025 //layer=li \
 //thickness=0.1 //x=17.855 //y=7.585 //x2=17.88 //y2=7.585
r2063 (  393 1124 ) resistor r=2.87058 //w=0.35 //l=0.085 //layer=li \
 //thickness=0.1 //x=18.565 //y=7.585 //x2=18.65 //y2=7.585
r2064 (  393 396 ) resistor r=23.891 //w=0.367 //l=0.685 //layer=li \
 //thickness=0.1 //x=18.565 //y=7.585 //x2=17.88 //y2=7.585
r2065 (  387 1123 ) resistor r=4.23183 //w=0.7 //l=0.175 //layer=li \
 //thickness=0.1 //x=17.77 //y=7.41 //x2=17.77 //y2=7.585
r2066 (  387 1212 ) resistor r=33.1979 //w=0.187 //l=0.485 //layer=li \
 //thickness=0.1 //x=17.77 //y=7.41 //x2=17.77 //y2=6.925
r2067 (  386 1122 ) resistor r=2.87058 //w=0.35 //l=0.085 //layer=li \
 //thickness=0.1 //x=16.975 //y=7.585 //x2=16.89 //y2=7.585
r2068 (  385 1123 ) resistor r=2.87058 //w=0.35 //l=0.085 //layer=li \
 //thickness=0.1 //x=17.685 //y=7.585 //x2=17.77 //y2=7.585
r2069 (  385 386 ) resistor r=24.7629 //w=0.367 //l=0.71 //layer=li \
 //thickness=0.1 //x=17.685 //y=7.585 //x2=16.975 //y2=7.585
r2070 (  379 1122 ) resistor r=4.23183 //w=0.7 //l=0.175 //layer=li \
 //thickness=0.1 //x=16.89 //y=7.41 //x2=16.89 //y2=7.585
r2071 (  379 1211 ) resistor r=33.1979 //w=0.187 //l=0.485 //layer=li \
 //thickness=0.1 //x=16.89 //y=7.41 //x2=16.89 //y2=6.925
r2072 (  376 1121 ) resistor r=2.87058 //w=0.35 //l=0.085 //layer=li \
 //thickness=0.1 //x=16.095 //y=7.585 //x2=16.01 //y2=7.585
r2073 (  376 378 ) resistor r=23.5422 //w=0.367 //l=0.675 //layer=li \
 //thickness=0.1 //x=16.095 //y=7.585 //x2=16.77 //y2=7.585
r2074 (  375 1122 ) resistor r=2.87058 //w=0.35 //l=0.085 //layer=li \
 //thickness=0.1 //x=16.805 //y=7.585 //x2=16.89 //y2=7.585
r2075 (  375 378 ) resistor r=1.22071 //w=0.367 //l=0.035 //layer=li \
 //thickness=0.1 //x=16.805 //y=7.585 //x2=16.77 //y2=7.585
r2076 (  367 1121 ) resistor r=4.23183 //w=0.7 //l=0.175 //layer=li \
 //thickness=0.1 //x=16.01 //y=7.41 //x2=16.01 //y2=7.585
r2077 (  367 1210 ) resistor r=56.4706 //w=0.187 //l=0.825 //layer=li \
 //thickness=0.1 //x=16.01 //y=7.41 //x2=16.01 //y2=6.585
r2078 (  364 1120 ) resistor r=5.29055 //w=0.35 //l=0.17 //layer=li \
 //thickness=0.1 //x=15.09 //y=7.585 //x2=14.92 //y2=7.585
r2079 (  364 366 ) resistor r=19.8801 //w=0.367 //l=0.57 //layer=li \
 //thickness=0.1 //x=15.09 //y=7.585 //x2=15.66 //y2=7.585
r2080 (  363 1121 ) resistor r=2.87058 //w=0.35 //l=0.085 //layer=li \
 //thickness=0.1 //x=15.925 //y=7.585 //x2=16.01 //y2=7.585
r2081 (  363 366 ) resistor r=9.24251 //w=0.367 //l=0.265 //layer=li \
 //thickness=0.1 //x=15.925 //y=7.585 //x2=15.66 //y2=7.585
r2082 (  358 1119 ) resistor r=2.87058 //w=0.35 //l=0.085 //layer=li \
 //thickness=0.1 //x=13.925 //y=7.585 //x2=13.84 //y2=7.585
r2083 (  358 360 ) resistor r=8.89373 //w=0.367 //l=0.255 //layer=li \
 //thickness=0.1 //x=13.925 //y=7.585 //x2=14.18 //y2=7.585
r2084 (  357 1120 ) resistor r=5.29055 //w=0.35 //l=0.17 //layer=li \
 //thickness=0.1 //x=14.75 //y=7.585 //x2=14.92 //y2=7.585
r2085 (  357 360 ) resistor r=19.8801 //w=0.367 //l=0.57 //layer=li \
 //thickness=0.1 //x=14.75 //y=7.585 //x2=14.18 //y2=7.585
r2086 (  351 1119 ) resistor r=4.23183 //w=0.7 //l=0.175 //layer=li \
 //thickness=0.1 //x=13.84 //y=7.41 //x2=13.84 //y2=7.585
r2087 (  351 1209 ) resistor r=33.1979 //w=0.187 //l=0.485 //layer=li \
 //thickness=0.1 //x=13.84 //y=7.41 //x2=13.84 //y2=6.925
r2088 (  348 1118 ) resistor r=2.87058 //w=0.35 //l=0.085 //layer=li \
 //thickness=0.1 //x=13.045 //y=7.585 //x2=12.96 //y2=7.585
r2089 (  348 350 ) resistor r=0.871935 //w=0.367 //l=0.025 //layer=li \
 //thickness=0.1 //x=13.045 //y=7.585 //x2=13.07 //y2=7.585
r2090 (  347 1119 ) resistor r=2.87058 //w=0.35 //l=0.085 //layer=li \
 //thickness=0.1 //x=13.755 //y=7.585 //x2=13.84 //y2=7.585
r2091 (  347 350 ) resistor r=23.891 //w=0.367 //l=0.685 //layer=li \
 //thickness=0.1 //x=13.755 //y=7.585 //x2=13.07 //y2=7.585
r2092 (  341 1118 ) resistor r=4.23183 //w=0.7 //l=0.175 //layer=li \
 //thickness=0.1 //x=12.96 //y=7.41 //x2=12.96 //y2=7.585
r2093 (  341 1208 ) resistor r=33.1979 //w=0.187 //l=0.485 //layer=li \
 //thickness=0.1 //x=12.96 //y=7.41 //x2=12.96 //y2=6.925
r2094 (  340 1117 ) resistor r=2.87058 //w=0.35 //l=0.085 //layer=li \
 //thickness=0.1 //x=12.165 //y=7.585 //x2=12.08 //y2=7.585
r2095 (  339 1118 ) resistor r=2.87058 //w=0.35 //l=0.085 //layer=li \
 //thickness=0.1 //x=12.875 //y=7.585 //x2=12.96 //y2=7.585
r2096 (  339 340 ) resistor r=24.7629 //w=0.367 //l=0.71 //layer=li \
 //thickness=0.1 //x=12.875 //y=7.585 //x2=12.165 //y2=7.585
r2097 (  333 1117 ) resistor r=4.23183 //w=0.7 //l=0.175 //layer=li \
 //thickness=0.1 //x=12.08 //y=7.41 //x2=12.08 //y2=7.585
r2098 (  333 1207 ) resistor r=33.1979 //w=0.187 //l=0.485 //layer=li \
 //thickness=0.1 //x=12.08 //y=7.41 //x2=12.08 //y2=6.925
r2099 (  330 1116 ) resistor r=2.87058 //w=0.35 //l=0.085 //layer=li \
 //thickness=0.1 //x=11.285 //y=7.585 //x2=11.2 //y2=7.585
r2100 (  330 332 ) resistor r=23.5422 //w=0.367 //l=0.675 //layer=li \
 //thickness=0.1 //x=11.285 //y=7.585 //x2=11.96 //y2=7.585
r2101 (  329 1117 ) resistor r=2.87058 //w=0.35 //l=0.085 //layer=li \
 //thickness=0.1 //x=11.995 //y=7.585 //x2=12.08 //y2=7.585
r2102 (  329 332 ) resistor r=1.22071 //w=0.367 //l=0.035 //layer=li \
 //thickness=0.1 //x=11.995 //y=7.585 //x2=11.96 //y2=7.585
r2103 (  321 1116 ) resistor r=4.23183 //w=0.7 //l=0.175 //layer=li \
 //thickness=0.1 //x=11.2 //y=7.41 //x2=11.2 //y2=7.585
r2104 (  321 1206 ) resistor r=56.4706 //w=0.187 //l=0.825 //layer=li \
 //thickness=0.1 //x=11.2 //y=7.41 //x2=11.2 //y2=6.585
r2105 (  318 1115 ) resistor r=5.29055 //w=0.35 //l=0.17 //layer=li \
 //thickness=0.1 //x=10.28 //y=7.585 //x2=10.11 //y2=7.585
r2106 (  318 320 ) resistor r=19.8801 //w=0.367 //l=0.57 //layer=li \
 //thickness=0.1 //x=10.28 //y=7.585 //x2=10.85 //y2=7.585
r2107 (  317 1116 ) resistor r=2.87058 //w=0.35 //l=0.085 //layer=li \
 //thickness=0.1 //x=11.115 //y=7.585 //x2=11.2 //y2=7.585
r2108 (  317 320 ) resistor r=9.24251 //w=0.367 //l=0.265 //layer=li \
 //thickness=0.1 //x=11.115 //y=7.585 //x2=10.85 //y2=7.585
r2109 (  312 1114 ) resistor r=2.87058 //w=0.35 //l=0.085 //layer=li \
 //thickness=0.1 //x=9.115 //y=7.585 //x2=9.03 //y2=7.585
r2110 (  312 314 ) resistor r=8.89373 //w=0.367 //l=0.255 //layer=li \
 //thickness=0.1 //x=9.115 //y=7.585 //x2=9.37 //y2=7.585
r2111 (  311 1115 ) resistor r=5.29055 //w=0.35 //l=0.17 //layer=li \
 //thickness=0.1 //x=9.94 //y=7.585 //x2=10.11 //y2=7.585
r2112 (  311 314 ) resistor r=19.8801 //w=0.367 //l=0.57 //layer=li \
 //thickness=0.1 //x=9.94 //y=7.585 //x2=9.37 //y2=7.585
r2113 (  305 1114 ) resistor r=4.23183 //w=0.7 //l=0.175 //layer=li \
 //thickness=0.1 //x=9.03 //y=7.41 //x2=9.03 //y2=7.585
r2114 (  305 1205 ) resistor r=33.1979 //w=0.187 //l=0.485 //layer=li \
 //thickness=0.1 //x=9.03 //y=7.41 //x2=9.03 //y2=6.925
r2115 (  302 1113 ) resistor r=2.87058 //w=0.35 //l=0.085 //layer=li \
 //thickness=0.1 //x=8.235 //y=7.585 //x2=8.15 //y2=7.585
r2116 (  302 304 ) resistor r=0.871935 //w=0.367 //l=0.025 //layer=li \
 //thickness=0.1 //x=8.235 //y=7.585 //x2=8.26 //y2=7.585
r2117 (  301 1114 ) resistor r=2.87058 //w=0.35 //l=0.085 //layer=li \
 //thickness=0.1 //x=8.945 //y=7.585 //x2=9.03 //y2=7.585
r2118 (  301 304 ) resistor r=23.891 //w=0.367 //l=0.685 //layer=li \
 //thickness=0.1 //x=8.945 //y=7.585 //x2=8.26 //y2=7.585
r2119 (  295 1113 ) resistor r=4.23183 //w=0.7 //l=0.175 //layer=li \
 //thickness=0.1 //x=8.15 //y=7.41 //x2=8.15 //y2=7.585
r2120 (  295 1204 ) resistor r=33.1979 //w=0.187 //l=0.485 //layer=li \
 //thickness=0.1 //x=8.15 //y=7.41 //x2=8.15 //y2=6.925
r2121 (  294 1112 ) resistor r=2.87058 //w=0.35 //l=0.085 //layer=li \
 //thickness=0.1 //x=7.355 //y=7.585 //x2=7.27 //y2=7.585
r2122 (  293 1113 ) resistor r=2.87058 //w=0.35 //l=0.085 //layer=li \
 //thickness=0.1 //x=8.065 //y=7.585 //x2=8.15 //y2=7.585
r2123 (  293 294 ) resistor r=24.7629 //w=0.367 //l=0.71 //layer=li \
 //thickness=0.1 //x=8.065 //y=7.585 //x2=7.355 //y2=7.585
r2124 (  287 1112 ) resistor r=4.23183 //w=0.7 //l=0.175 //layer=li \
 //thickness=0.1 //x=7.27 //y=7.41 //x2=7.27 //y2=7.585
r2125 (  287 1203 ) resistor r=33.1979 //w=0.187 //l=0.485 //layer=li \
 //thickness=0.1 //x=7.27 //y=7.41 //x2=7.27 //y2=6.925
r2126 (  284 1111 ) resistor r=2.87058 //w=0.35 //l=0.085 //layer=li \
 //thickness=0.1 //x=6.475 //y=7.585 //x2=6.39 //y2=7.585
r2127 (  284 286 ) resistor r=23.5422 //w=0.367 //l=0.675 //layer=li \
 //thickness=0.1 //x=6.475 //y=7.585 //x2=7.15 //y2=7.585
r2128 (  283 1112 ) resistor r=2.87058 //w=0.35 //l=0.085 //layer=li \
 //thickness=0.1 //x=7.185 //y=7.585 //x2=7.27 //y2=7.585
r2129 (  283 286 ) resistor r=1.22071 //w=0.367 //l=0.035 //layer=li \
 //thickness=0.1 //x=7.185 //y=7.585 //x2=7.15 //y2=7.585
r2130 (  275 1111 ) resistor r=4.23183 //w=0.7 //l=0.175 //layer=li \
 //thickness=0.1 //x=6.39 //y=7.41 //x2=6.39 //y2=7.585
r2131 (  275 1202 ) resistor r=56.4706 //w=0.187 //l=0.825 //layer=li \
 //thickness=0.1 //x=6.39 //y=7.41 //x2=6.39 //y2=6.585
r2132 (  272 1110 ) resistor r=5.29055 //w=0.35 //l=0.17 //layer=li \
 //thickness=0.1 //x=5.47 //y=7.585 //x2=5.3 //y2=7.585
r2133 (  272 274 ) resistor r=19.8801 //w=0.367 //l=0.57 //layer=li \
 //thickness=0.1 //x=5.47 //y=7.585 //x2=6.04 //y2=7.585
r2134 (  271 1111 ) resistor r=2.87058 //w=0.35 //l=0.085 //layer=li \
 //thickness=0.1 //x=6.305 //y=7.585 //x2=6.39 //y2=7.585
r2135 (  271 274 ) resistor r=9.24251 //w=0.367 //l=0.265 //layer=li \
 //thickness=0.1 //x=6.305 //y=7.585 //x2=6.04 //y2=7.585
r2136 (  266 1109 ) resistor r=2.87058 //w=0.35 //l=0.085 //layer=li \
 //thickness=0.1 //x=4.305 //y=7.585 //x2=4.22 //y2=7.585
r2137 (  266 268 ) resistor r=8.89373 //w=0.367 //l=0.255 //layer=li \
 //thickness=0.1 //x=4.305 //y=7.585 //x2=4.56 //y2=7.585
r2138 (  265 1110 ) resistor r=5.29055 //w=0.35 //l=0.17 //layer=li \
 //thickness=0.1 //x=5.13 //y=7.585 //x2=5.3 //y2=7.585
r2139 (  265 268 ) resistor r=19.8801 //w=0.367 //l=0.57 //layer=li \
 //thickness=0.1 //x=5.13 //y=7.585 //x2=4.56 //y2=7.585
r2140 (  259 1109 ) resistor r=4.23183 //w=0.7 //l=0.175 //layer=li \
 //thickness=0.1 //x=4.22 //y=7.41 //x2=4.22 //y2=7.585
r2141 (  259 1201 ) resistor r=33.1979 //w=0.187 //l=0.485 //layer=li \
 //thickness=0.1 //x=4.22 //y=7.41 //x2=4.22 //y2=6.925
r2142 (  256 1108 ) resistor r=2.87058 //w=0.35 //l=0.085 //layer=li \
 //thickness=0.1 //x=3.425 //y=7.585 //x2=3.34 //y2=7.585
r2143 (  256 258 ) resistor r=0.871935 //w=0.367 //l=0.025 //layer=li \
 //thickness=0.1 //x=3.425 //y=7.585 //x2=3.45 //y2=7.585
r2144 (  255 1109 ) resistor r=2.87058 //w=0.35 //l=0.085 //layer=li \
 //thickness=0.1 //x=4.135 //y=7.585 //x2=4.22 //y2=7.585
r2145 (  255 258 ) resistor r=23.891 //w=0.367 //l=0.685 //layer=li \
 //thickness=0.1 //x=4.135 //y=7.585 //x2=3.45 //y2=7.585
r2146 (  249 1108 ) resistor r=4.23183 //w=0.7 //l=0.175 //layer=li \
 //thickness=0.1 //x=3.34 //y=7.41 //x2=3.34 //y2=7.585
r2147 (  249 1200 ) resistor r=33.1979 //w=0.187 //l=0.485 //layer=li \
 //thickness=0.1 //x=3.34 //y=7.41 //x2=3.34 //y2=6.925
r2148 (  248 1107 ) resistor r=2.87058 //w=0.35 //l=0.085 //layer=li \
 //thickness=0.1 //x=2.545 //y=7.585 //x2=2.46 //y2=7.585
r2149 (  247 1108 ) resistor r=2.87058 //w=0.35 //l=0.085 //layer=li \
 //thickness=0.1 //x=3.255 //y=7.585 //x2=3.34 //y2=7.585
r2150 (  247 248 ) resistor r=24.7629 //w=0.367 //l=0.71 //layer=li \
 //thickness=0.1 //x=3.255 //y=7.585 //x2=2.545 //y2=7.585
r2151 (  241 1107 ) resistor r=4.23183 //w=0.7 //l=0.175 //layer=li \
 //thickness=0.1 //x=2.46 //y=7.41 //x2=2.46 //y2=7.585
r2152 (  241 1199 ) resistor r=33.1979 //w=0.187 //l=0.485 //layer=li \
 //thickness=0.1 //x=2.46 //y=7.41 //x2=2.46 //y2=6.925
r2153 (  238 1106 ) resistor r=2.87058 //w=0.35 //l=0.085 //layer=li \
 //thickness=0.1 //x=1.665 //y=7.585 //x2=1.58 //y2=7.585
r2154 (  238 240 ) resistor r=23.5422 //w=0.367 //l=0.675 //layer=li \
 //thickness=0.1 //x=1.665 //y=7.585 //x2=2.34 //y2=7.585
r2155 (  237 1107 ) resistor r=2.87058 //w=0.35 //l=0.085 //layer=li \
 //thickness=0.1 //x=2.375 //y=7.585 //x2=2.46 //y2=7.585
r2156 (  237 240 ) resistor r=1.22071 //w=0.367 //l=0.035 //layer=li \
 //thickness=0.1 //x=2.375 //y=7.585 //x2=2.34 //y2=7.585
r2157 (  229 1106 ) resistor r=4.23183 //w=0.7 //l=0.175 //layer=li \
 //thickness=0.1 //x=1.58 //y=7.41 //x2=1.58 //y2=7.585
r2158 (  229 1198 ) resistor r=56.4706 //w=0.187 //l=0.825 //layer=li \
 //thickness=0.1 //x=1.58 //y=7.41 //x2=1.58 //y2=6.585
r2159 (  225 1106 ) resistor r=2.87058 //w=0.35 //l=0.085 //layer=li \
 //thickness=0.1 //x=1.495 //y=7.585 //x2=1.58 //y2=7.585
r2160 (  225 228 ) resistor r=9.24251 //w=0.367 //l=0.265 //layer=li \
 //thickness=0.1 //x=1.495 //y=7.585 //x2=1.23 //y2=7.585
r2161 (  222 1084 ) resistor r=9.3 //w=0.17 //l=0.17 //layer=mcon //count=1 \
 //x=89.62 //y=6.92 //x2=89.62 //y2=6.92
r2162 (  219 1271 ) resistor r=9.3 //w=0.17 //l=0.17 //layer=mcon //count=1 \
 //x=88.74 //y=6.92 //x2=88.74 //y2=6.92
r2163 (  216 1069 ) resistor r=9.3 //w=0.17 //l=0.17 //layer=mcon //count=1 \
 //x=87.86 //y=6.92 //x2=87.86 //y2=6.92
r2164 (  212 1056 ) resistor r=3.1 //w=0.17 //l=0.51 //layer=mcon //count=3 \
 //x=87.81 //y=7.58 //x2=87.81 //y2=7.58
r2165 (  173 1103 ) resistor r=3.1 //w=0.17 //l=0.51 //layer=mcon //count=3 \
 //x=96.32 //y=7.58 //x2=96.32 //y2=7.58
r2166 (  171 1101 ) resistor r=3.1 //w=0.17 //l=0.51 //layer=mcon //count=3 \
 //x=95.21 //y=7.58 //x2=95.21 //y2=7.58
r2167 (  171 173 ) resistor r=0.446141 //w=0.311 //l=1.11 //layer=m1 \
 //thickness=0.36 //x=95.21 //y=7.585 //x2=96.32 //y2=7.585
r2168 (  169 1099 ) resistor r=3.1 //w=0.17 //l=0.51 //layer=mcon //count=3 \
 //x=94.1 //y=7.58 //x2=94.1 //y2=7.58
r2169 (  169 171 ) resistor r=0.446141 //w=0.311 //l=1.11 //layer=m1 \
 //thickness=0.36 //x=94.1 //y=7.585 //x2=95.21 //y2=7.585
r2170 (  167 1093 ) resistor r=3.1 //w=0.17 //l=0.51 //layer=mcon //count=3 \
 //x=92.62 //y=7.58 //x2=92.62 //y2=7.58
r2171 (  167 169 ) resistor r=0.594855 //w=0.311 //l=1.48 //layer=m1 \
 //thickness=0.36 //x=92.62 //y=7.585 //x2=94.1 //y2=7.585
r2172 (  165 1091 ) resistor r=3.1 //w=0.17 //l=0.51 //layer=mcon //count=3 \
 //x=91.51 //y=7.58 //x2=91.51 //y2=7.58
r2173 (  165 167 ) resistor r=0.446141 //w=0.311 //l=1.11 //layer=m1 \
 //thickness=0.36 //x=91.51 //y=7.585 //x2=92.62 //y2=7.585
r2174 (  163 1060 ) resistor r=3.1 //w=0.17 //l=0.51 //layer=mcon //count=3 \
 //x=90.03 //y=7.58 //x2=90.03 //y2=7.58
r2175 (  163 165 ) resistor r=0.594855 //w=0.311 //l=1.48 //layer=m1 \
 //thickness=0.36 //x=90.03 //y=7.585 //x2=91.51 //y2=7.585
r2176 (  161 220 ) resistor r=0.028033 //w=0.35 //l=0.085 //layer=m1 \
 //thickness=0.36 //x=89.705 //y=7.585 //x2=89.62 //y2=7.585
r2177 (  161 163 ) resistor r=0.130627 //w=0.311 //l=0.325 //layer=m1 \
 //thickness=0.36 //x=89.705 //y=7.585 //x2=90.03 //y2=7.585
r2178 (  160 220 ) resistor r=0.0413265 //w=0.7 //l=0.175 //layer=m1 \
 //thickness=0.36 //x=89.62 //y=7.41 //x2=89.62 //y2=7.585
r2179 (  159 222 ) resistor r=0.0715665 //w=0.226 //l=0.115 //layer=m1 \
 //thickness=0.36 //x=89.62 //y=7.035 //x2=89.62 //y2=6.92
r2180 (  159 160 ) resistor r=0.357824 //w=0.131 //l=0.375 //layer=m1 \
 //thickness=0.36 //x=89.62 //y=7.035 //x2=89.62 //y2=7.41
r2181 (  158 1058 ) resistor r=3.1 //w=0.17 //l=0.51 //layer=mcon //count=3 \
 //x=88.92 //y=7.58 //x2=88.92 //y2=7.58
r2182 (  156 217 ) resistor r=0.028033 //w=0.35 //l=0.085 //layer=m1 \
 //thickness=0.36 //x=88.825 //y=7.585 //x2=88.74 //y2=7.585
r2183 (  156 158 ) resistor r=0.0381833 //w=0.311 //l=0.095 //layer=m1 \
 //thickness=0.36 //x=88.825 //y=7.585 //x2=88.92 //y2=7.585
r2184 (  155 220 ) resistor r=0.028033 //w=0.35 //l=0.085 //layer=m1 \
 //thickness=0.36 //x=89.535 //y=7.585 //x2=89.62 //y2=7.585
r2185 (  155 158 ) resistor r=0.247186 //w=0.311 //l=0.615 //layer=m1 \
 //thickness=0.36 //x=89.535 //y=7.585 //x2=88.92 //y2=7.585
r2186 (  154 217 ) resistor r=0.0413265 //w=0.7 //l=0.175 //layer=m1 \
 //thickness=0.36 //x=88.74 //y=7.41 //x2=88.74 //y2=7.585
r2187 (  153 219 ) resistor r=0.0715665 //w=0.226 //l=0.117473 //layer=m1 \
 //thickness=0.36 //x=88.74 //y=7.035 //x2=88.745 //y2=6.92
r2188 (  153 154 ) resistor r=0.357824 //w=0.131 //l=0.375 //layer=m1 \
 //thickness=0.36 //x=88.74 //y=7.035 //x2=88.74 //y2=7.41
r2189 (  152 212 ) resistor r=0.028033 //w=0.35 //l=0.085 //layer=m1 \
 //thickness=0.36 //x=87.945 //y=7.585 //x2=87.86 //y2=7.585
r2190 (  151 217 ) resistor r=0.028033 //w=0.35 //l=0.085 //layer=m1 \
 //thickness=0.36 //x=88.655 //y=7.585 //x2=88.74 //y2=7.585
r2191 (  151 152 ) resistor r=0.28537 //w=0.311 //l=0.71 //layer=m1 \
 //thickness=0.36 //x=88.655 //y=7.585 //x2=87.945 //y2=7.585
r2192 (  150 212 ) resistor r=0.0413265 //w=0.7 //l=0.175 //layer=m1 \
 //thickness=0.36 //x=87.86 //y=7.41 //x2=87.86 //y2=7.585
r2193 (  149 216 ) resistor r=0.0712609 //w=0.23 //l=0.11649 //layer=m1 \
 //thickness=0.36 //x=87.86 //y=7.035 //x2=87.857 //y2=6.92
r2194 (  149 150 ) resistor r=0.357824 //w=0.131 //l=0.375 //layer=m1 \
 //thickness=0.36 //x=87.86 //y=7.035 //x2=87.86 //y2=7.41
r2195 (  148 1050 ) resistor r=3.1 //w=0.17 //l=0.51 //layer=mcon //count=3 \
 //x=86.33 //y=7.58 //x2=86.33 //y2=7.58
r2196 (  146 1040 ) resistor r=3.1 //w=0.17 //l=0.51 //layer=mcon //count=3 \
 //x=85.22 //y=7.58 //x2=85.22 //y2=7.58
r2197 (  146 148 ) resistor r=0.446141 //w=0.311 //l=1.11 //layer=m1 \
 //thickness=0.36 //x=85.22 //y=7.585 //x2=86.33 //y2=7.585
r2198 (  144 1022 ) resistor r=3.1 //w=0.17 //l=0.51 //layer=mcon //count=3 \
 //x=84.11 //y=7.58 //x2=84.11 //y2=7.58
r2199 (  144 146 ) resistor r=0.446141 //w=0.311 //l=1.11 //layer=m1 \
 //thickness=0.36 //x=84.11 //y=7.585 //x2=85.22 //y2=7.585
r2200 (  142 1010 ) resistor r=3.1 //w=0.17 //l=0.51 //layer=mcon //count=3 \
 //x=83 //y=7.58 //x2=83 //y2=7.58
r2201 (  142 144 ) resistor r=0.446141 //w=0.311 //l=1.11 //layer=m1 \
 //thickness=0.36 //x=83 //y=7.585 //x2=84.11 //y2=7.585
r2202 (  140 1004 ) resistor r=3.1 //w=0.17 //l=0.51 //layer=mcon //count=3 \
 //x=81.52 //y=7.58 //x2=81.52 //y2=7.58
r2203 (  140 142 ) resistor r=0.594855 //w=0.311 //l=1.48 //layer=m1 \
 //thickness=0.36 //x=81.52 //y=7.585 //x2=83 //y2=7.585
r2204 (  138 994 ) resistor r=3.1 //w=0.17 //l=0.51 //layer=mcon //count=3 \
 //x=80.41 //y=7.58 //x2=80.41 //y2=7.58
r2205 (  138 140 ) resistor r=0.446141 //w=0.311 //l=1.11 //layer=m1 \
 //thickness=0.36 //x=80.41 //y=7.585 //x2=81.52 //y2=7.585
r2206 (  136 976 ) resistor r=3.1 //w=0.17 //l=0.51 //layer=mcon //count=3 \
 //x=79.3 //y=7.58 //x2=79.3 //y2=7.58
r2207 (  136 138 ) resistor r=0.446141 //w=0.311 //l=1.11 //layer=m1 \
 //thickness=0.36 //x=79.3 //y=7.585 //x2=80.41 //y2=7.585
r2208 (  134 964 ) resistor r=3.1 //w=0.17 //l=0.51 //layer=mcon //count=3 \
 //x=78.19 //y=7.58 //x2=78.19 //y2=7.58
r2209 (  134 136 ) resistor r=0.446141 //w=0.311 //l=1.11 //layer=m1 \
 //thickness=0.36 //x=78.19 //y=7.585 //x2=79.3 //y2=7.585
r2210 (  132 958 ) resistor r=3.1 //w=0.17 //l=0.51 //layer=mcon //count=3 \
 //x=76.71 //y=7.58 //x2=76.71 //y2=7.58
r2211 (  132 134 ) resistor r=0.594855 //w=0.311 //l=1.48 //layer=m1 \
 //thickness=0.36 //x=76.71 //y=7.585 //x2=78.19 //y2=7.585
r2212 (  130 948 ) resistor r=3.1 //w=0.17 //l=0.51 //layer=mcon //count=3 \
 //x=75.6 //y=7.58 //x2=75.6 //y2=7.58
r2213 (  130 132 ) resistor r=0.446141 //w=0.311 //l=1.11 //layer=m1 \
 //thickness=0.36 //x=75.6 //y=7.585 //x2=76.71 //y2=7.585
r2214 (  128 930 ) resistor r=3.1 //w=0.17 //l=0.51 //layer=mcon //count=3 \
 //x=74.49 //y=7.58 //x2=74.49 //y2=7.58
r2215 (  128 130 ) resistor r=0.446141 //w=0.311 //l=1.11 //layer=m1 \
 //thickness=0.36 //x=74.49 //y=7.585 //x2=75.6 //y2=7.585
r2216 (  126 918 ) resistor r=3.1 //w=0.17 //l=0.51 //layer=mcon //count=3 \
 //x=73.38 //y=7.58 //x2=73.38 //y2=7.58
r2217 (  126 128 ) resistor r=0.446141 //w=0.311 //l=1.11 //layer=m1 \
 //thickness=0.36 //x=73.38 //y=7.585 //x2=74.49 //y2=7.585
r2218 (  124 912 ) resistor r=3.1 //w=0.17 //l=0.51 //layer=mcon //count=3 \
 //x=71.9 //y=7.58 //x2=71.9 //y2=7.58
r2219 (  124 126 ) resistor r=0.594855 //w=0.311 //l=1.48 //layer=m1 \
 //thickness=0.36 //x=71.9 //y=7.585 //x2=73.38 //y2=7.585
r2220 (  122 902 ) resistor r=3.1 //w=0.17 //l=0.51 //layer=mcon //count=3 \
 //x=70.79 //y=7.58 //x2=70.79 //y2=7.58
r2221 (  122 124 ) resistor r=0.446141 //w=0.311 //l=1.11 //layer=m1 \
 //thickness=0.36 //x=70.79 //y=7.585 //x2=71.9 //y2=7.585
r2222 (  120 884 ) resistor r=3.1 //w=0.17 //l=0.51 //layer=mcon //count=3 \
 //x=69.68 //y=7.58 //x2=69.68 //y2=7.58
r2223 (  120 122 ) resistor r=0.446141 //w=0.311 //l=1.11 //layer=m1 \
 //thickness=0.36 //x=69.68 //y=7.585 //x2=70.79 //y2=7.585
r2224 (  118 872 ) resistor r=3.1 //w=0.17 //l=0.51 //layer=mcon //count=3 \
 //x=68.57 //y=7.58 //x2=68.57 //y2=7.58
r2225 (  118 120 ) resistor r=0.446141 //w=0.311 //l=1.11 //layer=m1 \
 //thickness=0.36 //x=68.57 //y=7.585 //x2=69.68 //y2=7.585
r2226 (  116 866 ) resistor r=3.1 //w=0.17 //l=0.51 //layer=mcon //count=3 \
 //x=67.09 //y=7.58 //x2=67.09 //y2=7.58
r2227 (  116 118 ) resistor r=0.594855 //w=0.311 //l=1.48 //layer=m1 \
 //thickness=0.36 //x=67.09 //y=7.585 //x2=68.57 //y2=7.585
r2228 (  114 856 ) resistor r=3.1 //w=0.17 //l=0.51 //layer=mcon //count=3 \
 //x=65.98 //y=7.58 //x2=65.98 //y2=7.58
r2229 (  114 116 ) resistor r=0.446141 //w=0.311 //l=1.11 //layer=m1 \
 //thickness=0.36 //x=65.98 //y=7.585 //x2=67.09 //y2=7.585
r2230 (  112 838 ) resistor r=3.1 //w=0.17 //l=0.51 //layer=mcon //count=3 \
 //x=64.87 //y=7.58 //x2=64.87 //y2=7.58
r2231 (  112 114 ) resistor r=0.446141 //w=0.311 //l=1.11 //layer=m1 \
 //thickness=0.36 //x=64.87 //y=7.585 //x2=65.98 //y2=7.585
r2232 (  110 826 ) resistor r=3.1 //w=0.17 //l=0.51 //layer=mcon //count=3 \
 //x=63.76 //y=7.58 //x2=63.76 //y2=7.58
r2233 (  110 112 ) resistor r=0.446141 //w=0.311 //l=1.11 //layer=m1 \
 //thickness=0.36 //x=63.76 //y=7.585 //x2=64.87 //y2=7.585
r2234 (  108 820 ) resistor r=3.1 //w=0.17 //l=0.51 //layer=mcon //count=3 \
 //x=62.28 //y=7.58 //x2=62.28 //y2=7.58
r2235 (  108 110 ) resistor r=0.594855 //w=0.311 //l=1.48 //layer=m1 \
 //thickness=0.36 //x=62.28 //y=7.585 //x2=63.76 //y2=7.585
r2236 (  106 810 ) resistor r=3.1 //w=0.17 //l=0.51 //layer=mcon //count=3 \
 //x=61.17 //y=7.58 //x2=61.17 //y2=7.58
r2237 (  106 108 ) resistor r=0.446141 //w=0.311 //l=1.11 //layer=m1 \
 //thickness=0.36 //x=61.17 //y=7.585 //x2=62.28 //y2=7.585
r2238 (  104 792 ) resistor r=3.1 //w=0.17 //l=0.51 //layer=mcon //count=3 \
 //x=60.06 //y=7.58 //x2=60.06 //y2=7.58
r2239 (  104 106 ) resistor r=0.446141 //w=0.311 //l=1.11 //layer=m1 \
 //thickness=0.36 //x=60.06 //y=7.585 //x2=61.17 //y2=7.585
r2240 (  102 780 ) resistor r=3.1 //w=0.17 //l=0.51 //layer=mcon //count=3 \
 //x=58.95 //y=7.58 //x2=58.95 //y2=7.58
r2241 (  102 104 ) resistor r=0.446141 //w=0.311 //l=1.11 //layer=m1 \
 //thickness=0.36 //x=58.95 //y=7.585 //x2=60.06 //y2=7.585
r2242 (  100 774 ) resistor r=3.1 //w=0.17 //l=0.51 //layer=mcon //count=3 \
 //x=57.47 //y=7.58 //x2=57.47 //y2=7.58
r2243 (  100 102 ) resistor r=0.594855 //w=0.311 //l=1.48 //layer=m1 \
 //thickness=0.36 //x=57.47 //y=7.585 //x2=58.95 //y2=7.585
r2244 (  98 764 ) resistor r=3.1 //w=0.17 //l=0.51 //layer=mcon //count=3 \
 //x=56.36 //y=7.58 //x2=56.36 //y2=7.58
r2245 (  98 100 ) resistor r=0.446141 //w=0.311 //l=1.11 //layer=m1 \
 //thickness=0.36 //x=56.36 //y=7.585 //x2=57.47 //y2=7.585
r2246 (  96 746 ) resistor r=3.1 //w=0.17 //l=0.51 //layer=mcon //count=3 \
 //x=55.25 //y=7.58 //x2=55.25 //y2=7.58
r2247 (  96 98 ) resistor r=0.446141 //w=0.311 //l=1.11 //layer=m1 \
 //thickness=0.36 //x=55.25 //y=7.585 //x2=56.36 //y2=7.585
r2248 (  94 734 ) resistor r=3.1 //w=0.17 //l=0.51 //layer=mcon //count=3 \
 //x=54.14 //y=7.58 //x2=54.14 //y2=7.58
r2249 (  94 96 ) resistor r=0.446141 //w=0.311 //l=1.11 //layer=m1 \
 //thickness=0.36 //x=54.14 //y=7.585 //x2=55.25 //y2=7.585
r2250 (  92 728 ) resistor r=3.1 //w=0.17 //l=0.51 //layer=mcon //count=3 \
 //x=52.66 //y=7.58 //x2=52.66 //y2=7.58
r2251 (  92 94 ) resistor r=0.594855 //w=0.311 //l=1.48 //layer=m1 \
 //thickness=0.36 //x=52.66 //y=7.585 //x2=54.14 //y2=7.585
r2252 (  90 718 ) resistor r=3.1 //w=0.17 //l=0.51 //layer=mcon //count=3 \
 //x=51.55 //y=7.58 //x2=51.55 //y2=7.58
r2253 (  90 92 ) resistor r=0.446141 //w=0.311 //l=1.11 //layer=m1 \
 //thickness=0.36 //x=51.55 //y=7.585 //x2=52.66 //y2=7.585
r2254 (  88 700 ) resistor r=3.1 //w=0.17 //l=0.51 //layer=mcon //count=3 \
 //x=50.44 //y=7.58 //x2=50.44 //y2=7.58
r2255 (  88 90 ) resistor r=0.446141 //w=0.311 //l=1.11 //layer=m1 \
 //thickness=0.36 //x=50.44 //y=7.585 //x2=51.55 //y2=7.585
r2256 (  86 688 ) resistor r=3.1 //w=0.17 //l=0.51 //layer=mcon //count=3 \
 //x=49.33 //y=7.58 //x2=49.33 //y2=7.58
r2257 (  86 88 ) resistor r=0.446141 //w=0.311 //l=1.11 //layer=m1 \
 //thickness=0.36 //x=49.33 //y=7.585 //x2=50.44 //y2=7.585
r2258 (  83 682 ) resistor r=3.1 //w=0.17 //l=0.51 //layer=mcon //count=3 \
 //x=47.85 //y=7.58 //x2=47.85 //y2=7.58
r2259 (  81 672 ) resistor r=3.1 //w=0.17 //l=0.51 //layer=mcon //count=3 \
 //x=46.74 //y=7.58 //x2=46.74 //y2=7.58
r2260 (  81 83 ) resistor r=0.446141 //w=0.311 //l=1.11 //layer=m1 \
 //thickness=0.36 //x=46.74 //y=7.585 //x2=47.85 //y2=7.585
r2261 (  79 654 ) resistor r=3.1 //w=0.17 //l=0.51 //layer=mcon //count=3 \
 //x=45.63 //y=7.58 //x2=45.63 //y2=7.58
r2262 (  79 81 ) resistor r=0.446141 //w=0.311 //l=1.11 //layer=m1 \
 //thickness=0.36 //x=45.63 //y=7.585 //x2=46.74 //y2=7.585
r2263 (  77 642 ) resistor r=3.1 //w=0.17 //l=0.51 //layer=mcon //count=3 \
 //x=44.52 //y=7.58 //x2=44.52 //y2=7.58
r2264 (  77 79 ) resistor r=0.446141 //w=0.311 //l=1.11 //layer=m1 \
 //thickness=0.36 //x=44.52 //y=7.585 //x2=45.63 //y2=7.585
r2265 (  75 636 ) resistor r=3.1 //w=0.17 //l=0.51 //layer=mcon //count=3 \
 //x=43.04 //y=7.58 //x2=43.04 //y2=7.58
r2266 (  75 77 ) resistor r=0.594855 //w=0.311 //l=1.48 //layer=m1 \
 //thickness=0.36 //x=43.04 //y=7.585 //x2=44.52 //y2=7.585
r2267 (  73 626 ) resistor r=3.1 //w=0.17 //l=0.51 //layer=mcon //count=3 \
 //x=41.93 //y=7.58 //x2=41.93 //y2=7.58
r2268 (  73 75 ) resistor r=0.446141 //w=0.311 //l=1.11 //layer=m1 \
 //thickness=0.36 //x=41.93 //y=7.585 //x2=43.04 //y2=7.585
r2269 (  71 608 ) resistor r=3.1 //w=0.17 //l=0.51 //layer=mcon //count=3 \
 //x=40.82 //y=7.58 //x2=40.82 //y2=7.58
r2270 (  71 73 ) resistor r=0.446141 //w=0.311 //l=1.11 //layer=m1 \
 //thickness=0.36 //x=40.82 //y=7.585 //x2=41.93 //y2=7.585
r2271 (  69 596 ) resistor r=3.1 //w=0.17 //l=0.51 //layer=mcon //count=3 \
 //x=39.71 //y=7.58 //x2=39.71 //y2=7.58
r2272 (  69 71 ) resistor r=0.446141 //w=0.311 //l=1.11 //layer=m1 \
 //thickness=0.36 //x=39.71 //y=7.585 //x2=40.82 //y2=7.585
r2273 (  67 590 ) resistor r=3.1 //w=0.17 //l=0.51 //layer=mcon //count=3 \
 //x=38.23 //y=7.58 //x2=38.23 //y2=7.58
r2274 (  67 69 ) resistor r=0.594855 //w=0.311 //l=1.48 //layer=m1 \
 //thickness=0.36 //x=38.23 //y=7.585 //x2=39.71 //y2=7.585
r2275 (  65 580 ) resistor r=3.1 //w=0.17 //l=0.51 //layer=mcon //count=3 \
 //x=37.12 //y=7.58 //x2=37.12 //y2=7.58
r2276 (  65 67 ) resistor r=0.446141 //w=0.311 //l=1.11 //layer=m1 \
 //thickness=0.36 //x=37.12 //y=7.585 //x2=38.23 //y2=7.585
r2277 (  63 562 ) resistor r=3.1 //w=0.17 //l=0.51 //layer=mcon //count=3 \
 //x=36.01 //y=7.58 //x2=36.01 //y2=7.58
r2278 (  63 65 ) resistor r=0.446141 //w=0.311 //l=1.11 //layer=m1 \
 //thickness=0.36 //x=36.01 //y=7.585 //x2=37.12 //y2=7.585
r2279 (  61 550 ) resistor r=3.1 //w=0.17 //l=0.51 //layer=mcon //count=3 \
 //x=34.9 //y=7.58 //x2=34.9 //y2=7.58
r2280 (  61 63 ) resistor r=0.446141 //w=0.311 //l=1.11 //layer=m1 \
 //thickness=0.36 //x=34.9 //y=7.585 //x2=36.01 //y2=7.585
r2281 (  59 544 ) resistor r=3.1 //w=0.17 //l=0.51 //layer=mcon //count=3 \
 //x=33.42 //y=7.58 //x2=33.42 //y2=7.58
r2282 (  59 61 ) resistor r=0.594855 //w=0.311 //l=1.48 //layer=m1 \
 //thickness=0.36 //x=33.42 //y=7.585 //x2=34.9 //y2=7.585
r2283 (  57 534 ) resistor r=3.1 //w=0.17 //l=0.51 //layer=mcon //count=3 \
 //x=32.31 //y=7.58 //x2=32.31 //y2=7.58
r2284 (  57 59 ) resistor r=0.446141 //w=0.311 //l=1.11 //layer=m1 \
 //thickness=0.36 //x=32.31 //y=7.585 //x2=33.42 //y2=7.585
r2285 (  55 516 ) resistor r=3.1 //w=0.17 //l=0.51 //layer=mcon //count=3 \
 //x=31.2 //y=7.58 //x2=31.2 //y2=7.58
r2286 (  55 57 ) resistor r=0.446141 //w=0.311 //l=1.11 //layer=m1 \
 //thickness=0.36 //x=31.2 //y=7.585 //x2=32.31 //y2=7.585
r2287 (  53 504 ) resistor r=3.1 //w=0.17 //l=0.51 //layer=mcon //count=3 \
 //x=30.09 //y=7.58 //x2=30.09 //y2=7.58
r2288 (  53 55 ) resistor r=0.446141 //w=0.311 //l=1.11 //layer=m1 \
 //thickness=0.36 //x=30.09 //y=7.585 //x2=31.2 //y2=7.585
r2289 (  51 498 ) resistor r=3.1 //w=0.17 //l=0.51 //layer=mcon //count=3 \
 //x=28.61 //y=7.58 //x2=28.61 //y2=7.58
r2290 (  51 53 ) resistor r=0.594855 //w=0.311 //l=1.48 //layer=m1 \
 //thickness=0.36 //x=28.61 //y=7.585 //x2=30.09 //y2=7.585
r2291 (  49 488 ) resistor r=3.1 //w=0.17 //l=0.51 //layer=mcon //count=3 \
 //x=27.5 //y=7.58 //x2=27.5 //y2=7.58
r2292 (  49 51 ) resistor r=0.446141 //w=0.311 //l=1.11 //layer=m1 \
 //thickness=0.36 //x=27.5 //y=7.585 //x2=28.61 //y2=7.585
r2293 (  47 470 ) resistor r=3.1 //w=0.17 //l=0.51 //layer=mcon //count=3 \
 //x=26.39 //y=7.58 //x2=26.39 //y2=7.58
r2294 (  47 49 ) resistor r=0.446141 //w=0.311 //l=1.11 //layer=m1 \
 //thickness=0.36 //x=26.39 //y=7.585 //x2=27.5 //y2=7.585
r2295 (  45 458 ) resistor r=3.1 //w=0.17 //l=0.51 //layer=mcon //count=3 \
 //x=25.28 //y=7.58 //x2=25.28 //y2=7.58
r2296 (  45 47 ) resistor r=0.446141 //w=0.311 //l=1.11 //layer=m1 \
 //thickness=0.36 //x=25.28 //y=7.585 //x2=26.39 //y2=7.585
r2297 (  43 452 ) resistor r=3.1 //w=0.17 //l=0.51 //layer=mcon //count=3 \
 //x=23.8 //y=7.58 //x2=23.8 //y2=7.58
r2298 (  43 45 ) resistor r=0.594855 //w=0.311 //l=1.48 //layer=m1 \
 //thickness=0.36 //x=23.8 //y=7.585 //x2=25.28 //y2=7.585
r2299 (  41 442 ) resistor r=3.1 //w=0.17 //l=0.51 //layer=mcon //count=3 \
 //x=22.69 //y=7.58 //x2=22.69 //y2=7.58
r2300 (  41 43 ) resistor r=0.446141 //w=0.311 //l=1.11 //layer=m1 \
 //thickness=0.36 //x=22.69 //y=7.585 //x2=23.8 //y2=7.585
r2301 (  39 424 ) resistor r=3.1 //w=0.17 //l=0.51 //layer=mcon //count=3 \
 //x=21.58 //y=7.58 //x2=21.58 //y2=7.58
r2302 (  39 41 ) resistor r=0.446141 //w=0.311 //l=1.11 //layer=m1 \
 //thickness=0.36 //x=21.58 //y=7.585 //x2=22.69 //y2=7.585
r2303 (  37 412 ) resistor r=3.1 //w=0.17 //l=0.51 //layer=mcon //count=3 \
 //x=20.47 //y=7.58 //x2=20.47 //y2=7.58
r2304 (  37 39 ) resistor r=0.446141 //w=0.311 //l=1.11 //layer=m1 \
 //thickness=0.36 //x=20.47 //y=7.585 //x2=21.58 //y2=7.585
r2305 (  35 406 ) resistor r=3.1 //w=0.17 //l=0.51 //layer=mcon //count=3 \
 //x=18.99 //y=7.58 //x2=18.99 //y2=7.58
r2306 (  35 37 ) resistor r=0.594855 //w=0.311 //l=1.48 //layer=m1 \
 //thickness=0.36 //x=18.99 //y=7.585 //x2=20.47 //y2=7.585
r2307 (  33 396 ) resistor r=3.1 //w=0.17 //l=0.51 //layer=mcon //count=3 \
 //x=17.88 //y=7.58 //x2=17.88 //y2=7.58
r2308 (  33 35 ) resistor r=0.446141 //w=0.311 //l=1.11 //layer=m1 \
 //thickness=0.36 //x=17.88 //y=7.585 //x2=18.99 //y2=7.585
r2309 (  31 378 ) resistor r=3.1 //w=0.17 //l=0.51 //layer=mcon //count=3 \
 //x=16.77 //y=7.58 //x2=16.77 //y2=7.58
r2310 (  31 33 ) resistor r=0.446141 //w=0.311 //l=1.11 //layer=m1 \
 //thickness=0.36 //x=16.77 //y=7.585 //x2=17.88 //y2=7.585
r2311 (  29 366 ) resistor r=3.1 //w=0.17 //l=0.51 //layer=mcon //count=3 \
 //x=15.66 //y=7.58 //x2=15.66 //y2=7.58
r2312 (  29 31 ) resistor r=0.446141 //w=0.311 //l=1.11 //layer=m1 \
 //thickness=0.36 //x=15.66 //y=7.585 //x2=16.77 //y2=7.585
r2313 (  27 360 ) resistor r=3.1 //w=0.17 //l=0.51 //layer=mcon //count=3 \
 //x=14.18 //y=7.58 //x2=14.18 //y2=7.58
r2314 (  27 29 ) resistor r=0.594855 //w=0.311 //l=1.48 //layer=m1 \
 //thickness=0.36 //x=14.18 //y=7.585 //x2=15.66 //y2=7.585
r2315 (  25 350 ) resistor r=3.1 //w=0.17 //l=0.51 //layer=mcon //count=3 \
 //x=13.07 //y=7.58 //x2=13.07 //y2=7.58
r2316 (  25 27 ) resistor r=0.446141 //w=0.311 //l=1.11 //layer=m1 \
 //thickness=0.36 //x=13.07 //y=7.585 //x2=14.18 //y2=7.585
r2317 (  23 332 ) resistor r=3.1 //w=0.17 //l=0.51 //layer=mcon //count=3 \
 //x=11.96 //y=7.58 //x2=11.96 //y2=7.58
r2318 (  23 25 ) resistor r=0.446141 //w=0.311 //l=1.11 //layer=m1 \
 //thickness=0.36 //x=11.96 //y=7.585 //x2=13.07 //y2=7.585
r2319 (  21 320 ) resistor r=3.1 //w=0.17 //l=0.51 //layer=mcon //count=3 \
 //x=10.85 //y=7.58 //x2=10.85 //y2=7.58
r2320 (  21 23 ) resistor r=0.446141 //w=0.311 //l=1.11 //layer=m1 \
 //thickness=0.36 //x=10.85 //y=7.585 //x2=11.96 //y2=7.585
r2321 (  19 314 ) resistor r=3.1 //w=0.17 //l=0.51 //layer=mcon //count=3 \
 //x=9.37 //y=7.58 //x2=9.37 //y2=7.58
r2322 (  19 21 ) resistor r=0.594855 //w=0.311 //l=1.48 //layer=m1 \
 //thickness=0.36 //x=9.37 //y=7.585 //x2=10.85 //y2=7.585
r2323 (  17 304 ) resistor r=3.1 //w=0.17 //l=0.51 //layer=mcon //count=3 \
 //x=8.26 //y=7.58 //x2=8.26 //y2=7.58
r2324 (  17 19 ) resistor r=0.446141 //w=0.311 //l=1.11 //layer=m1 \
 //thickness=0.36 //x=8.26 //y=7.585 //x2=9.37 //y2=7.585
r2325 (  15 286 ) resistor r=3.1 //w=0.17 //l=0.51 //layer=mcon //count=3 \
 //x=7.15 //y=7.58 //x2=7.15 //y2=7.58
r2326 (  15 17 ) resistor r=0.446141 //w=0.311 //l=1.11 //layer=m1 \
 //thickness=0.36 //x=7.15 //y=7.585 //x2=8.26 //y2=7.585
r2327 (  13 274 ) resistor r=3.1 //w=0.17 //l=0.51 //layer=mcon //count=3 \
 //x=6.04 //y=7.58 //x2=6.04 //y2=7.58
r2328 (  13 15 ) resistor r=0.446141 //w=0.311 //l=1.11 //layer=m1 \
 //thickness=0.36 //x=6.04 //y=7.585 //x2=7.15 //y2=7.585
r2329 (  11 268 ) resistor r=3.1 //w=0.17 //l=0.51 //layer=mcon //count=3 \
 //x=4.56 //y=7.58 //x2=4.56 //y2=7.58
r2330 (  11 13 ) resistor r=0.594855 //w=0.311 //l=1.48 //layer=m1 \
 //thickness=0.36 //x=4.56 //y=7.585 //x2=6.04 //y2=7.585
r2331 (  9 258 ) resistor r=3.1 //w=0.17 //l=0.51 //layer=mcon //count=3 \
 //x=3.45 //y=7.58 //x2=3.45 //y2=7.58
r2332 (  9 11 ) resistor r=0.446141 //w=0.311 //l=1.11 //layer=m1 \
 //thickness=0.36 //x=3.45 //y=7.585 //x2=4.56 //y2=7.585
r2333 (  7 240 ) resistor r=3.1 //w=0.17 //l=0.51 //layer=mcon //count=3 \
 //x=2.34 //y=7.58 //x2=2.34 //y2=7.58
r2334 (  7 9 ) resistor r=0.446141 //w=0.311 //l=1.11 //layer=m1 \
 //thickness=0.36 //x=2.34 //y=7.585 //x2=3.45 //y2=7.585
r2335 (  4 228 ) resistor r=3.1 //w=0.17 //l=0.51 //layer=mcon //count=3 \
 //x=1.23 //y=7.58 //x2=1.23 //y2=7.58
r2336 (  4 7 ) resistor r=0.446141 //w=0.311 //l=1.11 //layer=m1 \
 //thickness=0.36 //x=1.23 //y=7.585 //x2=2.34 //y2=7.585
r2337 (  2 212 ) resistor r=0.028033 //w=0.35 //l=0.085 //layer=m1 \
 //thickness=0.36 //x=87.775 //y=7.585 //x2=87.86 //y2=7.585
r2338 (  2 148 ) resistor r=0.580788 //w=0.311 //l=1.445 //layer=m1 \
 //thickness=0.36 //x=87.775 //y=7.585 //x2=86.33 //y2=7.585
r2339 (  1 86 ) resistor r=0.223071 //w=0.311 //l=0.555 //layer=m1 \
 //thickness=0.36 //x=48.775 //y=7.585 //x2=49.33 //y2=7.585
r2340 (  1 83 ) resistor r=0.371785 //w=0.311 //l=0.925 //layer=m1 \
 //thickness=0.36 //x=48.775 //y=7.585 //x2=47.85 //y2=7.585
ends PM_TMRDFFSNRNQNX1\%VDD

subckt PM_TMRDFFSNRNQNX1\%noxref_25 ( 5 7 15 19 30 33 34 )
c66 ( 34 0 ) capacitor c=0.0443556f //x=3.455 //y=0.555
c67 ( 33 0 ) capacitor c=0.0194217f //x=2.35 //y=1.09
c68 ( 30 0 ) capacitor c=0.00141302f //x=3.59 //y=1.175
c69 ( 19 0 ) capacitor c=0.00692795f //x=4.56 //y=0.805
c70 ( 15 0 ) capacitor c=0.0155078f //x=4.475 //y=0.72
c71 ( 7 0 ) capacitor c=0.00689459f //x=3.59 //y=0.805
c72 ( 5 0 ) capacitor c=0.0235962f //x=3.505 //y=1.175
r73 (  19 34 ) resistor r=3.57586 //w=0.17 //l=0.125 //layer=li \
 //thickness=0.1 //x=4.56 //y=0.805 //x2=4.56 //y2=0.68
r74 (  19 34 ) resistor r=18.139 //w=0.187 //l=0.265 //layer=li \
 //thickness=0.1 //x=4.56 //y=0.805 //x2=4.56 //y2=1.07
r75 (  16 34 ) resistor r=3.57586 //w=0.17 //l=0.103078 //layer=li \
 //thickness=0.1 //x=3.675 //y=0.72 //x2=3.59 //y2=0.68
r76 (  16 34 ) resistor r=27.3797 //w=0.187 //l=0.4 //layer=li //thickness=0.1 \
 //x=3.675 //y=0.72 //x2=4.075 //y2=0.72
r77 (  15 34 ) resistor r=3.57586 //w=0.17 //l=0.103078 //layer=li \
 //thickness=0.1 //x=4.475 //y=0.72 //x2=4.56 //y2=0.68
r78 (  15 34 ) resistor r=27.3797 //w=0.187 //l=0.4 //layer=li //thickness=0.1 \
 //x=4.475 //y=0.72 //x2=4.075 //y2=0.72
r79 (  11 30 ) resistor r=5.4201 //w=0.17 //l=0.085 //layer=li //thickness=0.1 \
 //x=3.59 //y=1.26 //x2=3.59 //y2=1.175
r80 (  11 34 ) resistor r=10.2674 //w=0.187 //l=0.15 //layer=li \
 //thickness=0.1 //x=3.59 //y=1.26 //x2=3.59 //y2=1.41
r81 (  8 30 ) resistor r=5.4201 //w=0.17 //l=0.085 //layer=li //thickness=0.1 \
 //x=3.59 //y=1.09 //x2=3.59 //y2=1.175
r82 (  8 34 ) resistor r=1.36898 //w=0.187 //l=0.02 //layer=li //thickness=0.1 \
 //x=3.59 //y=1.09 //x2=3.59 //y2=1.07
r83 (  7 34 ) resistor r=3.57586 //w=0.17 //l=0.125 //layer=li //thickness=0.1 \
 //x=3.59 //y=0.805 //x2=3.59 //y2=0.68
r84 (  7 34 ) resistor r=18.139 //w=0.187 //l=0.265 //layer=li //thickness=0.1 \
 //x=3.59 //y=0.805 //x2=3.59 //y2=1.07
r85 (  6 33 ) resistor r=0.751729 //w=0.17 //l=0.085 //layer=li \
 //thickness=0.1 //x=2.625 //y=1.175 //x2=2.54 //y2=1.175
r86 (  5 30 ) resistor r=1.40859 //w=0.34 //l=0.085 //layer=li //thickness=0.1 \
 //x=3.505 //y=1.175 //x2=3.59 //y2=1.175
r87 (  5 6 ) resistor r=60.2353 //w=0.187 //l=0.88 //layer=li //thickness=0.1 \
 //x=3.505 //y=1.175 //x2=2.625 //y2=1.175
ends PM_TMRDFFSNRNQNX1\%noxref_25

subckt PM_TMRDFFSNRNQNX1\%noxref_26 ( 5 7 15 19 30 33 34 )
c67 ( 34 0 ) capacitor c=0.0451719f //x=8.265 //y=0.555
c68 ( 33 0 ) capacitor c=0.0194945f //x=7.16 //y=1.09
c69 ( 30 0 ) capacitor c=0.00141302f //x=8.4 //y=1.175
c70 ( 19 0 ) capacitor c=0.00692795f //x=9.37 //y=0.805
c71 ( 15 0 ) capacitor c=0.0154868f //x=9.285 //y=0.72
c72 ( 7 0 ) capacitor c=0.00689459f //x=8.4 //y=0.805
c73 ( 5 0 ) capacitor c=0.0235962f //x=8.315 //y=1.175
r74 (  19 34 ) resistor r=3.57586 //w=0.17 //l=0.125 //layer=li \
 //thickness=0.1 //x=9.37 //y=0.805 //x2=9.37 //y2=0.68
r75 (  19 34 ) resistor r=18.139 //w=0.187 //l=0.265 //layer=li \
 //thickness=0.1 //x=9.37 //y=0.805 //x2=9.37 //y2=1.07
r76 (  16 34 ) resistor r=3.57586 //w=0.17 //l=0.103078 //layer=li \
 //thickness=0.1 //x=8.485 //y=0.72 //x2=8.4 //y2=0.68
r77 (  16 34 ) resistor r=27.3797 //w=0.187 //l=0.4 //layer=li //thickness=0.1 \
 //x=8.485 //y=0.72 //x2=8.885 //y2=0.72
r78 (  15 34 ) resistor r=3.57586 //w=0.17 //l=0.103078 //layer=li \
 //thickness=0.1 //x=9.285 //y=0.72 //x2=9.37 //y2=0.68
r79 (  15 34 ) resistor r=27.3797 //w=0.187 //l=0.4 //layer=li //thickness=0.1 \
 //x=9.285 //y=0.72 //x2=8.885 //y2=0.72
r80 (  11 30 ) resistor r=5.4201 //w=0.17 //l=0.085 //layer=li //thickness=0.1 \
 //x=8.4 //y=1.26 //x2=8.4 //y2=1.175
r81 (  11 34 ) resistor r=10.2674 //w=0.187 //l=0.15 //layer=li \
 //thickness=0.1 //x=8.4 //y=1.26 //x2=8.4 //y2=1.41
r82 (  8 30 ) resistor r=5.4201 //w=0.17 //l=0.085 //layer=li //thickness=0.1 \
 //x=8.4 //y=1.09 //x2=8.4 //y2=1.175
r83 (  8 34 ) resistor r=1.36898 //w=0.187 //l=0.02 //layer=li //thickness=0.1 \
 //x=8.4 //y=1.09 //x2=8.4 //y2=1.07
r84 (  7 34 ) resistor r=3.57586 //w=0.17 //l=0.125 //layer=li //thickness=0.1 \
 //x=8.4 //y=0.805 //x2=8.4 //y2=0.68
r85 (  7 34 ) resistor r=18.139 //w=0.187 //l=0.265 //layer=li //thickness=0.1 \
 //x=8.4 //y=0.805 //x2=8.4 //y2=1.07
r86 (  6 33 ) resistor r=0.751729 //w=0.17 //l=0.085 //layer=li \
 //thickness=0.1 //x=7.435 //y=1.175 //x2=7.35 //y2=1.175
r87 (  5 30 ) resistor r=1.40859 //w=0.34 //l=0.085 //layer=li //thickness=0.1 \
 //x=8.315 //y=1.175 //x2=8.4 //y2=1.175
r88 (  5 6 ) resistor r=60.2353 //w=0.187 //l=0.88 //layer=li //thickness=0.1 \
 //x=8.315 //y=1.175 //x2=7.435 //y2=1.175
ends PM_TMRDFFSNRNQNX1\%noxref_26

subckt PM_TMRDFFSNRNQNX1\%noxref_27 ( 5 7 15 19 30 33 34 )
c68 ( 34 0 ) capacitor c=0.0442917f //x=13.075 //y=0.555
c69 ( 33 0 ) capacitor c=0.0193551f //x=11.97 //y=1.09
c70 ( 30 0 ) capacitor c=0.00141302f //x=13.21 //y=1.175
c71 ( 19 0 ) capacitor c=0.00692795f //x=14.18 //y=0.805
c72 ( 15 0 ) capacitor c=0.0154868f //x=14.095 //y=0.72
c73 ( 7 0 ) capacitor c=0.00689459f //x=13.21 //y=0.805
c74 ( 5 0 ) capacitor c=0.0235962f //x=13.125 //y=1.175
r75 (  19 34 ) resistor r=3.57586 //w=0.17 //l=0.125 //layer=li \
 //thickness=0.1 //x=14.18 //y=0.805 //x2=14.18 //y2=0.68
r76 (  19 34 ) resistor r=18.139 //w=0.187 //l=0.265 //layer=li \
 //thickness=0.1 //x=14.18 //y=0.805 //x2=14.18 //y2=1.07
r77 (  16 34 ) resistor r=3.57586 //w=0.17 //l=0.103078 //layer=li \
 //thickness=0.1 //x=13.295 //y=0.72 //x2=13.21 //y2=0.68
r78 (  16 34 ) resistor r=27.3797 //w=0.187 //l=0.4 //layer=li //thickness=0.1 \
 //x=13.295 //y=0.72 //x2=13.695 //y2=0.72
r79 (  15 34 ) resistor r=3.57586 //w=0.17 //l=0.103078 //layer=li \
 //thickness=0.1 //x=14.095 //y=0.72 //x2=14.18 //y2=0.68
r80 (  15 34 ) resistor r=27.3797 //w=0.187 //l=0.4 //layer=li //thickness=0.1 \
 //x=14.095 //y=0.72 //x2=13.695 //y2=0.72
r81 (  11 30 ) resistor r=5.4201 //w=0.17 //l=0.085 //layer=li //thickness=0.1 \
 //x=13.21 //y=1.26 //x2=13.21 //y2=1.175
r82 (  11 34 ) resistor r=10.2674 //w=0.187 //l=0.15 //layer=li \
 //thickness=0.1 //x=13.21 //y=1.26 //x2=13.21 //y2=1.41
r83 (  8 30 ) resistor r=5.4201 //w=0.17 //l=0.085 //layer=li //thickness=0.1 \
 //x=13.21 //y=1.09 //x2=13.21 //y2=1.175
r84 (  8 34 ) resistor r=1.36898 //w=0.187 //l=0.02 //layer=li //thickness=0.1 \
 //x=13.21 //y=1.09 //x2=13.21 //y2=1.07
r85 (  7 34 ) resistor r=3.57586 //w=0.17 //l=0.125 //layer=li //thickness=0.1 \
 //x=13.21 //y=0.805 //x2=13.21 //y2=0.68
r86 (  7 34 ) resistor r=18.139 //w=0.187 //l=0.265 //layer=li //thickness=0.1 \
 //x=13.21 //y=0.805 //x2=13.21 //y2=1.07
r87 (  6 33 ) resistor r=0.751729 //w=0.17 //l=0.085 //layer=li \
 //thickness=0.1 //x=12.245 //y=1.175 //x2=12.16 //y2=1.175
r88 (  5 30 ) resistor r=1.40859 //w=0.34 //l=0.085 //layer=li //thickness=0.1 \
 //x=13.125 //y=1.175 //x2=13.21 //y2=1.175
r89 (  5 6 ) resistor r=60.2353 //w=0.187 //l=0.88 //layer=li //thickness=0.1 \
 //x=13.125 //y=1.175 //x2=12.245 //y2=1.175
ends PM_TMRDFFSNRNQNX1\%noxref_27

subckt PM_TMRDFFSNRNQNX1\%noxref_28 ( 5 7 15 19 30 33 34 )
c67 ( 34 0 ) capacitor c=0.0452753f //x=17.885 //y=0.555
c68 ( 33 0 ) capacitor c=0.0194988f //x=16.78 //y=1.09
c69 ( 30 0 ) capacitor c=0.00141302f //x=18.02 //y=1.175
c70 ( 19 0 ) capacitor c=0.00692795f //x=18.99 //y=0.805
c71 ( 15 0 ) capacitor c=0.0153812f //x=18.905 //y=0.72
c72 ( 7 0 ) capacitor c=0.00689459f //x=18.02 //y=0.805
c73 ( 5 0 ) capacitor c=0.0235962f //x=17.935 //y=1.175
r74 (  19 34 ) resistor r=3.57586 //w=0.17 //l=0.125 //layer=li \
 //thickness=0.1 //x=18.99 //y=0.805 //x2=18.99 //y2=0.68
r75 (  19 34 ) resistor r=18.139 //w=0.187 //l=0.265 //layer=li \
 //thickness=0.1 //x=18.99 //y=0.805 //x2=18.99 //y2=1.07
r76 (  16 34 ) resistor r=3.57586 //w=0.17 //l=0.103078 //layer=li \
 //thickness=0.1 //x=18.105 //y=0.72 //x2=18.02 //y2=0.68
r77 (  16 34 ) resistor r=27.3797 //w=0.187 //l=0.4 //layer=li //thickness=0.1 \
 //x=18.105 //y=0.72 //x2=18.505 //y2=0.72
r78 (  15 34 ) resistor r=3.57586 //w=0.17 //l=0.103078 //layer=li \
 //thickness=0.1 //x=18.905 //y=0.72 //x2=18.99 //y2=0.68
r79 (  15 34 ) resistor r=27.3797 //w=0.187 //l=0.4 //layer=li //thickness=0.1 \
 //x=18.905 //y=0.72 //x2=18.505 //y2=0.72
r80 (  11 30 ) resistor r=5.4201 //w=0.17 //l=0.085 //layer=li //thickness=0.1 \
 //x=18.02 //y=1.26 //x2=18.02 //y2=1.175
r81 (  11 34 ) resistor r=10.2674 //w=0.187 //l=0.15 //layer=li \
 //thickness=0.1 //x=18.02 //y=1.26 //x2=18.02 //y2=1.41
r82 (  8 30 ) resistor r=5.4201 //w=0.17 //l=0.085 //layer=li //thickness=0.1 \
 //x=18.02 //y=1.09 //x2=18.02 //y2=1.175
r83 (  8 34 ) resistor r=1.36898 //w=0.187 //l=0.02 //layer=li //thickness=0.1 \
 //x=18.02 //y=1.09 //x2=18.02 //y2=1.07
r84 (  7 34 ) resistor r=3.57586 //w=0.17 //l=0.125 //layer=li //thickness=0.1 \
 //x=18.02 //y=0.805 //x2=18.02 //y2=0.68
r85 (  7 34 ) resistor r=18.139 //w=0.187 //l=0.265 //layer=li //thickness=0.1 \
 //x=18.02 //y=0.805 //x2=18.02 //y2=1.07
r86 (  6 33 ) resistor r=0.751729 //w=0.17 //l=0.085 //layer=li \
 //thickness=0.1 //x=17.055 //y=1.175 //x2=16.97 //y2=1.175
r87 (  5 30 ) resistor r=1.40859 //w=0.34 //l=0.085 //layer=li //thickness=0.1 \
 //x=17.935 //y=1.175 //x2=18.02 //y2=1.175
r88 (  5 6 ) resistor r=60.2353 //w=0.187 //l=0.88 //layer=li //thickness=0.1 \
 //x=17.935 //y=1.175 //x2=17.055 //y2=1.175
ends PM_TMRDFFSNRNQNX1\%noxref_28

subckt PM_TMRDFFSNRNQNX1\%noxref_29 ( 5 7 15 19 30 33 34 )
c68 ( 34 0 ) capacitor c=0.0444783f //x=22.695 //y=0.555
c69 ( 33 0 ) capacitor c=0.0190261f //x=21.59 //y=1.09
c70 ( 30 0 ) capacitor c=0.00141302f //x=22.83 //y=1.175
c71 ( 19 0 ) capacitor c=0.00692795f //x=23.8 //y=0.805
c72 ( 15 0 ) capacitor c=0.0155062f //x=23.715 //y=0.72
c73 ( 7 0 ) capacitor c=0.00689459f //x=22.83 //y=0.805
c74 ( 5 0 ) capacitor c=0.0235962f //x=22.745 //y=1.175
r75 (  19 34 ) resistor r=3.57586 //w=0.17 //l=0.125 //layer=li \
 //thickness=0.1 //x=23.8 //y=0.805 //x2=23.8 //y2=0.68
r76 (  19 34 ) resistor r=18.139 //w=0.187 //l=0.265 //layer=li \
 //thickness=0.1 //x=23.8 //y=0.805 //x2=23.8 //y2=1.07
r77 (  16 34 ) resistor r=3.57586 //w=0.17 //l=0.103078 //layer=li \
 //thickness=0.1 //x=22.915 //y=0.72 //x2=22.83 //y2=0.68
r78 (  16 34 ) resistor r=27.3797 //w=0.187 //l=0.4 //layer=li //thickness=0.1 \
 //x=22.915 //y=0.72 //x2=23.315 //y2=0.72
r79 (  15 34 ) resistor r=3.57586 //w=0.17 //l=0.103078 //layer=li \
 //thickness=0.1 //x=23.715 //y=0.72 //x2=23.8 //y2=0.68
r80 (  15 34 ) resistor r=27.3797 //w=0.187 //l=0.4 //layer=li //thickness=0.1 \
 //x=23.715 //y=0.72 //x2=23.315 //y2=0.72
r81 (  11 30 ) resistor r=5.4201 //w=0.17 //l=0.085 //layer=li //thickness=0.1 \
 //x=22.83 //y=1.26 //x2=22.83 //y2=1.175
r82 (  11 34 ) resistor r=10.2674 //w=0.187 //l=0.15 //layer=li \
 //thickness=0.1 //x=22.83 //y=1.26 //x2=22.83 //y2=1.41
r83 (  8 30 ) resistor r=5.4201 //w=0.17 //l=0.085 //layer=li //thickness=0.1 \
 //x=22.83 //y=1.09 //x2=22.83 //y2=1.175
r84 (  8 34 ) resistor r=1.36898 //w=0.187 //l=0.02 //layer=li //thickness=0.1 \
 //x=22.83 //y=1.09 //x2=22.83 //y2=1.07
r85 (  7 34 ) resistor r=3.57586 //w=0.17 //l=0.125 //layer=li //thickness=0.1 \
 //x=22.83 //y=0.805 //x2=22.83 //y2=0.68
r86 (  7 34 ) resistor r=18.139 //w=0.187 //l=0.265 //layer=li //thickness=0.1 \
 //x=22.83 //y=0.805 //x2=22.83 //y2=1.07
r87 (  6 33 ) resistor r=0.751729 //w=0.17 //l=0.085 //layer=li \
 //thickness=0.1 //x=21.865 //y=1.175 //x2=21.78 //y2=1.175
r88 (  5 30 ) resistor r=1.40859 //w=0.34 //l=0.085 //layer=li //thickness=0.1 \
 //x=22.745 //y=1.175 //x2=22.83 //y2=1.175
r89 (  5 6 ) resistor r=60.2353 //w=0.187 //l=0.88 //layer=li //thickness=0.1 \
 //x=22.745 //y=1.175 //x2=21.865 //y2=1.175
ends PM_TMRDFFSNRNQNX1\%noxref_29

subckt PM_TMRDFFSNRNQNX1\%noxref_30 ( 5 7 15 19 30 33 34 )
c69 ( 34 0 ) capacitor c=0.0450311f //x=27.505 //y=0.555
c70 ( 33 0 ) capacitor c=0.018587f //x=26.4 //y=1.09
c71 ( 30 0 ) capacitor c=0.00141302f //x=27.64 //y=1.175
c72 ( 19 0 ) capacitor c=0.00692795f //x=28.61 //y=0.805
c73 ( 15 0 ) capacitor c=0.0154873f //x=28.525 //y=0.72
c74 ( 7 0 ) capacitor c=0.00689459f //x=27.64 //y=0.805
c75 ( 5 0 ) capacitor c=0.0235962f //x=27.555 //y=1.175
r76 (  19 34 ) resistor r=3.57586 //w=0.17 //l=0.125 //layer=li \
 //thickness=0.1 //x=28.61 //y=0.805 //x2=28.61 //y2=0.68
r77 (  19 34 ) resistor r=18.139 //w=0.187 //l=0.265 //layer=li \
 //thickness=0.1 //x=28.61 //y=0.805 //x2=28.61 //y2=1.07
r78 (  16 34 ) resistor r=3.57586 //w=0.17 //l=0.103078 //layer=li \
 //thickness=0.1 //x=27.725 //y=0.72 //x2=27.64 //y2=0.68
r79 (  16 34 ) resistor r=27.3797 //w=0.187 //l=0.4 //layer=li //thickness=0.1 \
 //x=27.725 //y=0.72 //x2=28.125 //y2=0.72
r80 (  15 34 ) resistor r=3.57586 //w=0.17 //l=0.103078 //layer=li \
 //thickness=0.1 //x=28.525 //y=0.72 //x2=28.61 //y2=0.68
r81 (  15 34 ) resistor r=27.3797 //w=0.187 //l=0.4 //layer=li //thickness=0.1 \
 //x=28.525 //y=0.72 //x2=28.125 //y2=0.72
r82 (  11 30 ) resistor r=5.4201 //w=0.17 //l=0.085 //layer=li //thickness=0.1 \
 //x=27.64 //y=1.26 //x2=27.64 //y2=1.175
r83 (  11 34 ) resistor r=10.2674 //w=0.187 //l=0.15 //layer=li \
 //thickness=0.1 //x=27.64 //y=1.26 //x2=27.64 //y2=1.41
r84 (  8 30 ) resistor r=5.4201 //w=0.17 //l=0.085 //layer=li //thickness=0.1 \
 //x=27.64 //y=1.09 //x2=27.64 //y2=1.175
r85 (  8 34 ) resistor r=1.36898 //w=0.187 //l=0.02 //layer=li //thickness=0.1 \
 //x=27.64 //y=1.09 //x2=27.64 //y2=1.07
r86 (  7 34 ) resistor r=3.57586 //w=0.17 //l=0.125 //layer=li //thickness=0.1 \
 //x=27.64 //y=0.805 //x2=27.64 //y2=0.68
r87 (  7 34 ) resistor r=18.139 //w=0.187 //l=0.265 //layer=li //thickness=0.1 \
 //x=27.64 //y=0.805 //x2=27.64 //y2=1.07
r88 (  6 33 ) resistor r=0.751729 //w=0.17 //l=0.085 //layer=li \
 //thickness=0.1 //x=26.675 //y=1.175 //x2=26.59 //y2=1.175
r89 (  5 30 ) resistor r=1.40859 //w=0.34 //l=0.085 //layer=li //thickness=0.1 \
 //x=27.555 //y=1.175 //x2=27.64 //y2=1.175
r90 (  5 6 ) resistor r=60.2353 //w=0.187 //l=0.88 //layer=li //thickness=0.1 \
 //x=27.555 //y=1.175 //x2=26.675 //y2=1.175
ends PM_TMRDFFSNRNQNX1\%noxref_30

subckt PM_TMRDFFSNRNQNX1\%noxref_31 ( 5 7 15 19 30 33 34 )
c67 ( 34 0 ) capacitor c=0.0443556f //x=32.315 //y=0.555
c68 ( 33 0 ) capacitor c=0.019073f //x=31.21 //y=1.09
c69 ( 30 0 ) capacitor c=0.00141302f //x=32.45 //y=1.175
c70 ( 19 0 ) capacitor c=0.00692795f //x=33.42 //y=0.805
c71 ( 15 0 ) capacitor c=0.0155078f //x=33.335 //y=0.72
c72 ( 7 0 ) capacitor c=0.00689459f //x=32.45 //y=0.805
c73 ( 5 0 ) capacitor c=0.0235962f //x=32.365 //y=1.175
r74 (  19 34 ) resistor r=3.57586 //w=0.17 //l=0.125 //layer=li \
 //thickness=0.1 //x=33.42 //y=0.805 //x2=33.42 //y2=0.68
r75 (  19 34 ) resistor r=18.139 //w=0.187 //l=0.265 //layer=li \
 //thickness=0.1 //x=33.42 //y=0.805 //x2=33.42 //y2=1.07
r76 (  16 34 ) resistor r=3.57586 //w=0.17 //l=0.103078 //layer=li \
 //thickness=0.1 //x=32.535 //y=0.72 //x2=32.45 //y2=0.68
r77 (  16 34 ) resistor r=27.3797 //w=0.187 //l=0.4 //layer=li //thickness=0.1 \
 //x=32.535 //y=0.72 //x2=32.935 //y2=0.72
r78 (  15 34 ) resistor r=3.57586 //w=0.17 //l=0.103078 //layer=li \
 //thickness=0.1 //x=33.335 //y=0.72 //x2=33.42 //y2=0.68
r79 (  15 34 ) resistor r=27.3797 //w=0.187 //l=0.4 //layer=li //thickness=0.1 \
 //x=33.335 //y=0.72 //x2=32.935 //y2=0.72
r80 (  11 30 ) resistor r=5.4201 //w=0.17 //l=0.085 //layer=li //thickness=0.1 \
 //x=32.45 //y=1.26 //x2=32.45 //y2=1.175
r81 (  11 34 ) resistor r=10.2674 //w=0.187 //l=0.15 //layer=li \
 //thickness=0.1 //x=32.45 //y=1.26 //x2=32.45 //y2=1.41
r82 (  8 30 ) resistor r=5.4201 //w=0.17 //l=0.085 //layer=li //thickness=0.1 \
 //x=32.45 //y=1.09 //x2=32.45 //y2=1.175
r83 (  8 34 ) resistor r=1.36898 //w=0.187 //l=0.02 //layer=li //thickness=0.1 \
 //x=32.45 //y=1.09 //x2=32.45 //y2=1.07
r84 (  7 34 ) resistor r=3.57586 //w=0.17 //l=0.125 //layer=li //thickness=0.1 \
 //x=32.45 //y=0.805 //x2=32.45 //y2=0.68
r85 (  7 34 ) resistor r=18.139 //w=0.187 //l=0.265 //layer=li //thickness=0.1 \
 //x=32.45 //y=0.805 //x2=32.45 //y2=1.07
r86 (  6 33 ) resistor r=0.751729 //w=0.17 //l=0.085 //layer=li \
 //thickness=0.1 //x=31.485 //y=1.175 //x2=31.4 //y2=1.175
r87 (  5 30 ) resistor r=1.40859 //w=0.34 //l=0.085 //layer=li //thickness=0.1 \
 //x=32.365 //y=1.175 //x2=32.45 //y2=1.175
r88 (  5 6 ) resistor r=60.2353 //w=0.187 //l=0.88 //layer=li //thickness=0.1 \
 //x=32.365 //y=1.175 //x2=31.485 //y2=1.175
ends PM_TMRDFFSNRNQNX1\%noxref_31

subckt PM_TMRDFFSNRNQNX1\%noxref_32 ( 5 7 15 19 30 33 34 )
c67 ( 34 0 ) capacitor c=0.0451719f //x=37.125 //y=0.555
c68 ( 33 0 ) capacitor c=0.0194981f //x=36.02 //y=1.09
c69 ( 30 0 ) capacitor c=0.00141302f //x=37.26 //y=1.175
c70 ( 19 0 ) capacitor c=0.00692795f //x=38.23 //y=0.805
c71 ( 15 0 ) capacitor c=0.0154868f //x=38.145 //y=0.72
c72 ( 7 0 ) capacitor c=0.00689459f //x=37.26 //y=0.805
c73 ( 5 0 ) capacitor c=0.0235962f //x=37.175 //y=1.175
r74 (  19 34 ) resistor r=3.57586 //w=0.17 //l=0.125 //layer=li \
 //thickness=0.1 //x=38.23 //y=0.805 //x2=38.23 //y2=0.68
r75 (  19 34 ) resistor r=18.139 //w=0.187 //l=0.265 //layer=li \
 //thickness=0.1 //x=38.23 //y=0.805 //x2=38.23 //y2=1.07
r76 (  16 34 ) resistor r=3.57586 //w=0.17 //l=0.103078 //layer=li \
 //thickness=0.1 //x=37.345 //y=0.72 //x2=37.26 //y2=0.68
r77 (  16 34 ) resistor r=27.3797 //w=0.187 //l=0.4 //layer=li //thickness=0.1 \
 //x=37.345 //y=0.72 //x2=37.745 //y2=0.72
r78 (  15 34 ) resistor r=3.57586 //w=0.17 //l=0.103078 //layer=li \
 //thickness=0.1 //x=38.145 //y=0.72 //x2=38.23 //y2=0.68
r79 (  15 34 ) resistor r=27.3797 //w=0.187 //l=0.4 //layer=li //thickness=0.1 \
 //x=38.145 //y=0.72 //x2=37.745 //y2=0.72
r80 (  11 30 ) resistor r=5.4201 //w=0.17 //l=0.085 //layer=li //thickness=0.1 \
 //x=37.26 //y=1.26 //x2=37.26 //y2=1.175
r81 (  11 34 ) resistor r=10.2674 //w=0.187 //l=0.15 //layer=li \
 //thickness=0.1 //x=37.26 //y=1.26 //x2=37.26 //y2=1.41
r82 (  8 30 ) resistor r=5.4201 //w=0.17 //l=0.085 //layer=li //thickness=0.1 \
 //x=37.26 //y=1.09 //x2=37.26 //y2=1.175
r83 (  8 34 ) resistor r=1.36898 //w=0.187 //l=0.02 //layer=li //thickness=0.1 \
 //x=37.26 //y=1.09 //x2=37.26 //y2=1.07
r84 (  7 34 ) resistor r=3.57586 //w=0.17 //l=0.125 //layer=li //thickness=0.1 \
 //x=37.26 //y=0.805 //x2=37.26 //y2=0.68
r85 (  7 34 ) resistor r=18.139 //w=0.187 //l=0.265 //layer=li //thickness=0.1 \
 //x=37.26 //y=0.805 //x2=37.26 //y2=1.07
r86 (  6 33 ) resistor r=0.751729 //w=0.17 //l=0.085 //layer=li \
 //thickness=0.1 //x=36.295 //y=1.175 //x2=36.21 //y2=1.175
r87 (  5 30 ) resistor r=1.40859 //w=0.34 //l=0.085 //layer=li //thickness=0.1 \
 //x=37.175 //y=1.175 //x2=37.26 //y2=1.175
r88 (  5 6 ) resistor r=60.2353 //w=0.187 //l=0.88 //layer=li //thickness=0.1 \
 //x=37.175 //y=1.175 //x2=36.295 //y2=1.175
ends PM_TMRDFFSNRNQNX1\%noxref_32

subckt PM_TMRDFFSNRNQNX1\%noxref_33 ( 5 7 15 19 30 33 34 )
c68 ( 34 0 ) capacitor c=0.0442917f //x=41.935 //y=0.555
c69 ( 33 0 ) capacitor c=0.0193551f //x=40.83 //y=1.09
c70 ( 30 0 ) capacitor c=0.00141302f //x=42.07 //y=1.175
c71 ( 19 0 ) capacitor c=0.00692795f //x=43.04 //y=0.805
c72 ( 15 0 ) capacitor c=0.0154868f //x=42.955 //y=0.72
c73 ( 7 0 ) capacitor c=0.00689459f //x=42.07 //y=0.805
c74 ( 5 0 ) capacitor c=0.0235962f //x=41.985 //y=1.175
r75 (  19 34 ) resistor r=3.57586 //w=0.17 //l=0.125 //layer=li \
 //thickness=0.1 //x=43.04 //y=0.805 //x2=43.04 //y2=0.68
r76 (  19 34 ) resistor r=18.139 //w=0.187 //l=0.265 //layer=li \
 //thickness=0.1 //x=43.04 //y=0.805 //x2=43.04 //y2=1.07
r77 (  16 34 ) resistor r=3.57586 //w=0.17 //l=0.103078 //layer=li \
 //thickness=0.1 //x=42.155 //y=0.72 //x2=42.07 //y2=0.68
r78 (  16 34 ) resistor r=27.3797 //w=0.187 //l=0.4 //layer=li //thickness=0.1 \
 //x=42.155 //y=0.72 //x2=42.555 //y2=0.72
r79 (  15 34 ) resistor r=3.57586 //w=0.17 //l=0.103078 //layer=li \
 //thickness=0.1 //x=42.955 //y=0.72 //x2=43.04 //y2=0.68
r80 (  15 34 ) resistor r=27.3797 //w=0.187 //l=0.4 //layer=li //thickness=0.1 \
 //x=42.955 //y=0.72 //x2=42.555 //y2=0.72
r81 (  11 30 ) resistor r=5.4201 //w=0.17 //l=0.085 //layer=li //thickness=0.1 \
 //x=42.07 //y=1.26 //x2=42.07 //y2=1.175
r82 (  11 34 ) resistor r=10.2674 //w=0.187 //l=0.15 //layer=li \
 //thickness=0.1 //x=42.07 //y=1.26 //x2=42.07 //y2=1.41
r83 (  8 30 ) resistor r=5.4201 //w=0.17 //l=0.085 //layer=li //thickness=0.1 \
 //x=42.07 //y=1.09 //x2=42.07 //y2=1.175
r84 (  8 34 ) resistor r=1.36898 //w=0.187 //l=0.02 //layer=li //thickness=0.1 \
 //x=42.07 //y=1.09 //x2=42.07 //y2=1.07
r85 (  7 34 ) resistor r=3.57586 //w=0.17 //l=0.125 //layer=li //thickness=0.1 \
 //x=42.07 //y=0.805 //x2=42.07 //y2=0.68
r86 (  7 34 ) resistor r=18.139 //w=0.187 //l=0.265 //layer=li //thickness=0.1 \
 //x=42.07 //y=0.805 //x2=42.07 //y2=1.07
r87 (  6 33 ) resistor r=0.751729 //w=0.17 //l=0.085 //layer=li \
 //thickness=0.1 //x=41.105 //y=1.175 //x2=41.02 //y2=1.175
r88 (  5 30 ) resistor r=1.40859 //w=0.34 //l=0.085 //layer=li //thickness=0.1 \
 //x=41.985 //y=1.175 //x2=42.07 //y2=1.175
r89 (  5 6 ) resistor r=60.2353 //w=0.187 //l=0.88 //layer=li //thickness=0.1 \
 //x=41.985 //y=1.175 //x2=41.105 //y2=1.175
ends PM_TMRDFFSNRNQNX1\%noxref_33

subckt PM_TMRDFFSNRNQNX1\%noxref_34 ( 5 7 15 19 30 33 34 )
c67 ( 34 0 ) capacitor c=0.0452753f //x=46.745 //y=0.555
c68 ( 33 0 ) capacitor c=0.0194988f //x=45.64 //y=1.09
c69 ( 30 0 ) capacitor c=0.00141302f //x=46.88 //y=1.175
c70 ( 19 0 ) capacitor c=0.00692795f //x=47.85 //y=0.805
c71 ( 15 0 ) capacitor c=0.0153812f //x=47.765 //y=0.72
c72 ( 7 0 ) capacitor c=0.00689459f //x=46.88 //y=0.805
c73 ( 5 0 ) capacitor c=0.0235962f //x=46.795 //y=1.175
r74 (  19 34 ) resistor r=3.57586 //w=0.17 //l=0.125 //layer=li \
 //thickness=0.1 //x=47.85 //y=0.805 //x2=47.85 //y2=0.68
r75 (  19 34 ) resistor r=18.139 //w=0.187 //l=0.265 //layer=li \
 //thickness=0.1 //x=47.85 //y=0.805 //x2=47.85 //y2=1.07
r76 (  16 34 ) resistor r=3.57586 //w=0.17 //l=0.103078 //layer=li \
 //thickness=0.1 //x=46.965 //y=0.72 //x2=46.88 //y2=0.68
r77 (  16 34 ) resistor r=27.3797 //w=0.187 //l=0.4 //layer=li //thickness=0.1 \
 //x=46.965 //y=0.72 //x2=47.365 //y2=0.72
r78 (  15 34 ) resistor r=3.57586 //w=0.17 //l=0.103078 //layer=li \
 //thickness=0.1 //x=47.765 //y=0.72 //x2=47.85 //y2=0.68
r79 (  15 34 ) resistor r=27.3797 //w=0.187 //l=0.4 //layer=li //thickness=0.1 \
 //x=47.765 //y=0.72 //x2=47.365 //y2=0.72
r80 (  11 30 ) resistor r=5.4201 //w=0.17 //l=0.085 //layer=li //thickness=0.1 \
 //x=46.88 //y=1.26 //x2=46.88 //y2=1.175
r81 (  11 34 ) resistor r=10.2674 //w=0.187 //l=0.15 //layer=li \
 //thickness=0.1 //x=46.88 //y=1.26 //x2=46.88 //y2=1.41
r82 (  8 30 ) resistor r=5.4201 //w=0.17 //l=0.085 //layer=li //thickness=0.1 \
 //x=46.88 //y=1.09 //x2=46.88 //y2=1.175
r83 (  8 34 ) resistor r=1.36898 //w=0.187 //l=0.02 //layer=li //thickness=0.1 \
 //x=46.88 //y=1.09 //x2=46.88 //y2=1.07
r84 (  7 34 ) resistor r=3.57586 //w=0.17 //l=0.125 //layer=li //thickness=0.1 \
 //x=46.88 //y=0.805 //x2=46.88 //y2=0.68
r85 (  7 34 ) resistor r=18.139 //w=0.187 //l=0.265 //layer=li //thickness=0.1 \
 //x=46.88 //y=0.805 //x2=46.88 //y2=1.07
r86 (  6 33 ) resistor r=0.751729 //w=0.17 //l=0.085 //layer=li \
 //thickness=0.1 //x=45.915 //y=1.175 //x2=45.83 //y2=1.175
r87 (  5 30 ) resistor r=1.40859 //w=0.34 //l=0.085 //layer=li //thickness=0.1 \
 //x=46.795 //y=1.175 //x2=46.88 //y2=1.175
r88 (  5 6 ) resistor r=60.2353 //w=0.187 //l=0.88 //layer=li //thickness=0.1 \
 //x=46.795 //y=1.175 //x2=45.915 //y2=1.175
ends PM_TMRDFFSNRNQNX1\%noxref_34

subckt PM_TMRDFFSNRNQNX1\%noxref_35 ( 5 7 15 19 30 33 34 )
c69 ( 34 0 ) capacitor c=0.0449889f //x=51.555 //y=0.555
c70 ( 33 0 ) capacitor c=0.0190261f //x=50.45 //y=1.09
c71 ( 30 0 ) capacitor c=0.00141302f //x=51.69 //y=1.175
c72 ( 19 0 ) capacitor c=0.00692795f //x=52.66 //y=0.805
c73 ( 15 0 ) capacitor c=0.0155872f //x=52.575 //y=0.72
c74 ( 7 0 ) capacitor c=0.00689459f //x=51.69 //y=0.805
c75 ( 5 0 ) capacitor c=0.0235962f //x=51.605 //y=1.175
r76 (  19 34 ) resistor r=3.57586 //w=0.17 //l=0.125 //layer=li \
 //thickness=0.1 //x=52.66 //y=0.805 //x2=52.66 //y2=0.68
r77 (  19 34 ) resistor r=18.139 //w=0.187 //l=0.265 //layer=li \
 //thickness=0.1 //x=52.66 //y=0.805 //x2=52.66 //y2=1.07
r78 (  16 34 ) resistor r=3.57586 //w=0.17 //l=0.103078 //layer=li \
 //thickness=0.1 //x=51.775 //y=0.72 //x2=51.69 //y2=0.68
r79 (  16 34 ) resistor r=27.3797 //w=0.187 //l=0.4 //layer=li //thickness=0.1 \
 //x=51.775 //y=0.72 //x2=52.175 //y2=0.72
r80 (  15 34 ) resistor r=3.57586 //w=0.17 //l=0.103078 //layer=li \
 //thickness=0.1 //x=52.575 //y=0.72 //x2=52.66 //y2=0.68
r81 (  15 34 ) resistor r=27.3797 //w=0.187 //l=0.4 //layer=li //thickness=0.1 \
 //x=52.575 //y=0.72 //x2=52.175 //y2=0.72
r82 (  11 30 ) resistor r=5.4201 //w=0.17 //l=0.085 //layer=li //thickness=0.1 \
 //x=51.69 //y=1.26 //x2=51.69 //y2=1.175
r83 (  11 34 ) resistor r=10.2674 //w=0.187 //l=0.15 //layer=li \
 //thickness=0.1 //x=51.69 //y=1.26 //x2=51.69 //y2=1.41
r84 (  8 30 ) resistor r=5.4201 //w=0.17 //l=0.085 //layer=li //thickness=0.1 \
 //x=51.69 //y=1.09 //x2=51.69 //y2=1.175
r85 (  8 34 ) resistor r=1.36898 //w=0.187 //l=0.02 //layer=li //thickness=0.1 \
 //x=51.69 //y=1.09 //x2=51.69 //y2=1.07
r86 (  7 34 ) resistor r=3.57586 //w=0.17 //l=0.125 //layer=li //thickness=0.1 \
 //x=51.69 //y=0.805 //x2=51.69 //y2=0.68
r87 (  7 34 ) resistor r=18.139 //w=0.187 //l=0.265 //layer=li //thickness=0.1 \
 //x=51.69 //y=0.805 //x2=51.69 //y2=1.07
r88 (  6 33 ) resistor r=0.751729 //w=0.17 //l=0.085 //layer=li \
 //thickness=0.1 //x=50.725 //y=1.175 //x2=50.64 //y2=1.175
r89 (  5 30 ) resistor r=1.40859 //w=0.34 //l=0.085 //layer=li //thickness=0.1 \
 //x=51.605 //y=1.175 //x2=51.69 //y2=1.175
r90 (  5 6 ) resistor r=60.2353 //w=0.187 //l=0.88 //layer=li //thickness=0.1 \
 //x=51.605 //y=1.175 //x2=50.725 //y2=1.175
ends PM_TMRDFFSNRNQNX1\%noxref_35

subckt PM_TMRDFFSNRNQNX1\%noxref_36 ( 5 7 15 19 30 33 34 )
c69 ( 34 0 ) capacitor c=0.0442917f //x=56.365 //y=0.555
c70 ( 33 0 ) capacitor c=0.018587f //x=55.26 //y=1.09
c71 ( 30 0 ) capacitor c=0.00141302f //x=56.5 //y=1.175
c72 ( 19 0 ) capacitor c=0.00692795f //x=57.47 //y=0.805
c73 ( 15 0 ) capacitor c=0.0154873f //x=57.385 //y=0.72
c74 ( 7 0 ) capacitor c=0.00689459f //x=56.5 //y=0.805
c75 ( 5 0 ) capacitor c=0.0235962f //x=56.415 //y=1.175
r76 (  19 34 ) resistor r=3.57586 //w=0.17 //l=0.125 //layer=li \
 //thickness=0.1 //x=57.47 //y=0.805 //x2=57.47 //y2=0.68
r77 (  19 34 ) resistor r=18.139 //w=0.187 //l=0.265 //layer=li \
 //thickness=0.1 //x=57.47 //y=0.805 //x2=57.47 //y2=1.07
r78 (  16 34 ) resistor r=3.57586 //w=0.17 //l=0.103078 //layer=li \
 //thickness=0.1 //x=56.585 //y=0.72 //x2=56.5 //y2=0.68
r79 (  16 34 ) resistor r=27.3797 //w=0.187 //l=0.4 //layer=li //thickness=0.1 \
 //x=56.585 //y=0.72 //x2=56.985 //y2=0.72
r80 (  15 34 ) resistor r=3.57586 //w=0.17 //l=0.103078 //layer=li \
 //thickness=0.1 //x=57.385 //y=0.72 //x2=57.47 //y2=0.68
r81 (  15 34 ) resistor r=27.3797 //w=0.187 //l=0.4 //layer=li //thickness=0.1 \
 //x=57.385 //y=0.72 //x2=56.985 //y2=0.72
r82 (  11 30 ) resistor r=5.4201 //w=0.17 //l=0.085 //layer=li //thickness=0.1 \
 //x=56.5 //y=1.26 //x2=56.5 //y2=1.175
r83 (  11 34 ) resistor r=10.2674 //w=0.187 //l=0.15 //layer=li \
 //thickness=0.1 //x=56.5 //y=1.26 //x2=56.5 //y2=1.41
r84 (  8 30 ) resistor r=5.4201 //w=0.17 //l=0.085 //layer=li //thickness=0.1 \
 //x=56.5 //y=1.09 //x2=56.5 //y2=1.175
r85 (  8 34 ) resistor r=1.36898 //w=0.187 //l=0.02 //layer=li //thickness=0.1 \
 //x=56.5 //y=1.09 //x2=56.5 //y2=1.07
r86 (  7 34 ) resistor r=3.57586 //w=0.17 //l=0.125 //layer=li //thickness=0.1 \
 //x=56.5 //y=0.805 //x2=56.5 //y2=0.68
r87 (  7 34 ) resistor r=18.139 //w=0.187 //l=0.265 //layer=li //thickness=0.1 \
 //x=56.5 //y=0.805 //x2=56.5 //y2=1.07
r88 (  6 33 ) resistor r=0.751729 //w=0.17 //l=0.085 //layer=li \
 //thickness=0.1 //x=55.535 //y=1.175 //x2=55.45 //y2=1.175
r89 (  5 30 ) resistor r=1.40859 //w=0.34 //l=0.085 //layer=li //thickness=0.1 \
 //x=56.415 //y=1.175 //x2=56.5 //y2=1.175
r90 (  5 6 ) resistor r=60.2353 //w=0.187 //l=0.88 //layer=li //thickness=0.1 \
 //x=56.415 //y=1.175 //x2=55.535 //y2=1.175
ends PM_TMRDFFSNRNQNX1\%noxref_36

subckt PM_TMRDFFSNRNQNX1\%noxref_37 ( 5 7 15 19 30 33 34 )
c67 ( 34 0 ) capacitor c=0.0443556f //x=61.175 //y=0.555
c68 ( 33 0 ) capacitor c=0.019073f //x=60.07 //y=1.09
c69 ( 30 0 ) capacitor c=0.00141302f //x=61.31 //y=1.175
c70 ( 19 0 ) capacitor c=0.00692795f //x=62.28 //y=0.805
c71 ( 15 0 ) capacitor c=0.0155078f //x=62.195 //y=0.72
c72 ( 7 0 ) capacitor c=0.00689459f //x=61.31 //y=0.805
c73 ( 5 0 ) capacitor c=0.0235962f //x=61.225 //y=1.175
r74 (  19 34 ) resistor r=3.57586 //w=0.17 //l=0.125 //layer=li \
 //thickness=0.1 //x=62.28 //y=0.805 //x2=62.28 //y2=0.68
r75 (  19 34 ) resistor r=18.139 //w=0.187 //l=0.265 //layer=li \
 //thickness=0.1 //x=62.28 //y=0.805 //x2=62.28 //y2=1.07
r76 (  16 34 ) resistor r=3.57586 //w=0.17 //l=0.103078 //layer=li \
 //thickness=0.1 //x=61.395 //y=0.72 //x2=61.31 //y2=0.68
r77 (  16 34 ) resistor r=27.3797 //w=0.187 //l=0.4 //layer=li //thickness=0.1 \
 //x=61.395 //y=0.72 //x2=61.795 //y2=0.72
r78 (  15 34 ) resistor r=3.57586 //w=0.17 //l=0.103078 //layer=li \
 //thickness=0.1 //x=62.195 //y=0.72 //x2=62.28 //y2=0.68
r79 (  15 34 ) resistor r=27.3797 //w=0.187 //l=0.4 //layer=li //thickness=0.1 \
 //x=62.195 //y=0.72 //x2=61.795 //y2=0.72
r80 (  11 30 ) resistor r=5.4201 //w=0.17 //l=0.085 //layer=li //thickness=0.1 \
 //x=61.31 //y=1.26 //x2=61.31 //y2=1.175
r81 (  11 34 ) resistor r=10.2674 //w=0.187 //l=0.15 //layer=li \
 //thickness=0.1 //x=61.31 //y=1.26 //x2=61.31 //y2=1.41
r82 (  8 30 ) resistor r=5.4201 //w=0.17 //l=0.085 //layer=li //thickness=0.1 \
 //x=61.31 //y=1.09 //x2=61.31 //y2=1.175
r83 (  8 34 ) resistor r=1.36898 //w=0.187 //l=0.02 //layer=li //thickness=0.1 \
 //x=61.31 //y=1.09 //x2=61.31 //y2=1.07
r84 (  7 34 ) resistor r=3.57586 //w=0.17 //l=0.125 //layer=li //thickness=0.1 \
 //x=61.31 //y=0.805 //x2=61.31 //y2=0.68
r85 (  7 34 ) resistor r=18.139 //w=0.187 //l=0.265 //layer=li //thickness=0.1 \
 //x=61.31 //y=0.805 //x2=61.31 //y2=1.07
r86 (  6 33 ) resistor r=0.751729 //w=0.17 //l=0.085 //layer=li \
 //thickness=0.1 //x=60.345 //y=1.175 //x2=60.26 //y2=1.175
r87 (  5 30 ) resistor r=1.40859 //w=0.34 //l=0.085 //layer=li //thickness=0.1 \
 //x=61.225 //y=1.175 //x2=61.31 //y2=1.175
r88 (  5 6 ) resistor r=60.2353 //w=0.187 //l=0.88 //layer=li //thickness=0.1 \
 //x=61.225 //y=1.175 //x2=60.345 //y2=1.175
ends PM_TMRDFFSNRNQNX1\%noxref_37

subckt PM_TMRDFFSNRNQNX1\%noxref_38 ( 5 7 15 19 30 33 34 )
c67 ( 34 0 ) capacitor c=0.0451719f //x=65.985 //y=0.555
c68 ( 33 0 ) capacitor c=0.0194945f //x=64.88 //y=1.09
c69 ( 30 0 ) capacitor c=0.00141302f //x=66.12 //y=1.175
c70 ( 19 0 ) capacitor c=0.00692795f //x=67.09 //y=0.805
c71 ( 15 0 ) capacitor c=0.0154868f //x=67.005 //y=0.72
c72 ( 7 0 ) capacitor c=0.00689459f //x=66.12 //y=0.805
c73 ( 5 0 ) capacitor c=0.0235962f //x=66.035 //y=1.175
r74 (  19 34 ) resistor r=3.57586 //w=0.17 //l=0.125 //layer=li \
 //thickness=0.1 //x=67.09 //y=0.805 //x2=67.09 //y2=0.68
r75 (  19 34 ) resistor r=18.139 //w=0.187 //l=0.265 //layer=li \
 //thickness=0.1 //x=67.09 //y=0.805 //x2=67.09 //y2=1.07
r76 (  16 34 ) resistor r=3.57586 //w=0.17 //l=0.103078 //layer=li \
 //thickness=0.1 //x=66.205 //y=0.72 //x2=66.12 //y2=0.68
r77 (  16 34 ) resistor r=27.3797 //w=0.187 //l=0.4 //layer=li //thickness=0.1 \
 //x=66.205 //y=0.72 //x2=66.605 //y2=0.72
r78 (  15 34 ) resistor r=3.57586 //w=0.17 //l=0.103078 //layer=li \
 //thickness=0.1 //x=67.005 //y=0.72 //x2=67.09 //y2=0.68
r79 (  15 34 ) resistor r=27.3797 //w=0.187 //l=0.4 //layer=li //thickness=0.1 \
 //x=67.005 //y=0.72 //x2=66.605 //y2=0.72
r80 (  11 30 ) resistor r=5.4201 //w=0.17 //l=0.085 //layer=li //thickness=0.1 \
 //x=66.12 //y=1.26 //x2=66.12 //y2=1.175
r81 (  11 34 ) resistor r=10.2674 //w=0.187 //l=0.15 //layer=li \
 //thickness=0.1 //x=66.12 //y=1.26 //x2=66.12 //y2=1.41
r82 (  8 30 ) resistor r=5.4201 //w=0.17 //l=0.085 //layer=li //thickness=0.1 \
 //x=66.12 //y=1.09 //x2=66.12 //y2=1.175
r83 (  8 34 ) resistor r=1.36898 //w=0.187 //l=0.02 //layer=li //thickness=0.1 \
 //x=66.12 //y=1.09 //x2=66.12 //y2=1.07
r84 (  7 34 ) resistor r=3.57586 //w=0.17 //l=0.125 //layer=li //thickness=0.1 \
 //x=66.12 //y=0.805 //x2=66.12 //y2=0.68
r85 (  7 34 ) resistor r=18.139 //w=0.187 //l=0.265 //layer=li //thickness=0.1 \
 //x=66.12 //y=0.805 //x2=66.12 //y2=1.07
r86 (  6 33 ) resistor r=0.751729 //w=0.17 //l=0.085 //layer=li \
 //thickness=0.1 //x=65.155 //y=1.175 //x2=65.07 //y2=1.175
r87 (  5 30 ) resistor r=1.40859 //w=0.34 //l=0.085 //layer=li //thickness=0.1 \
 //x=66.035 //y=1.175 //x2=66.12 //y2=1.175
r88 (  5 6 ) resistor r=60.2353 //w=0.187 //l=0.88 //layer=li //thickness=0.1 \
 //x=66.035 //y=1.175 //x2=65.155 //y2=1.175
ends PM_TMRDFFSNRNQNX1\%noxref_38

subckt PM_TMRDFFSNRNQNX1\%noxref_39 ( 5 7 15 19 30 33 34 )
c68 ( 34 0 ) capacitor c=0.0442917f //x=70.795 //y=0.555
c69 ( 33 0 ) capacitor c=0.0193551f //x=69.69 //y=1.09
c70 ( 30 0 ) capacitor c=0.00141302f //x=70.93 //y=1.175
c71 ( 19 0 ) capacitor c=0.00692795f //x=71.9 //y=0.805
c72 ( 15 0 ) capacitor c=0.0154868f //x=71.815 //y=0.72
c73 ( 7 0 ) capacitor c=0.00689459f //x=70.93 //y=0.805
c74 ( 5 0 ) capacitor c=0.0235962f //x=70.845 //y=1.175
r75 (  19 34 ) resistor r=3.57586 //w=0.17 //l=0.125 //layer=li \
 //thickness=0.1 //x=71.9 //y=0.805 //x2=71.9 //y2=0.68
r76 (  19 34 ) resistor r=18.139 //w=0.187 //l=0.265 //layer=li \
 //thickness=0.1 //x=71.9 //y=0.805 //x2=71.9 //y2=1.07
r77 (  16 34 ) resistor r=3.57586 //w=0.17 //l=0.103078 //layer=li \
 //thickness=0.1 //x=71.015 //y=0.72 //x2=70.93 //y2=0.68
r78 (  16 34 ) resistor r=27.3797 //w=0.187 //l=0.4 //layer=li //thickness=0.1 \
 //x=71.015 //y=0.72 //x2=71.415 //y2=0.72
r79 (  15 34 ) resistor r=3.57586 //w=0.17 //l=0.103078 //layer=li \
 //thickness=0.1 //x=71.815 //y=0.72 //x2=71.9 //y2=0.68
r80 (  15 34 ) resistor r=27.3797 //w=0.187 //l=0.4 //layer=li //thickness=0.1 \
 //x=71.815 //y=0.72 //x2=71.415 //y2=0.72
r81 (  11 30 ) resistor r=5.4201 //w=0.17 //l=0.085 //layer=li //thickness=0.1 \
 //x=70.93 //y=1.26 //x2=70.93 //y2=1.175
r82 (  11 34 ) resistor r=10.2674 //w=0.187 //l=0.15 //layer=li \
 //thickness=0.1 //x=70.93 //y=1.26 //x2=70.93 //y2=1.41
r83 (  8 30 ) resistor r=5.4201 //w=0.17 //l=0.085 //layer=li //thickness=0.1 \
 //x=70.93 //y=1.09 //x2=70.93 //y2=1.175
r84 (  8 34 ) resistor r=1.36898 //w=0.187 //l=0.02 //layer=li //thickness=0.1 \
 //x=70.93 //y=1.09 //x2=70.93 //y2=1.07
r85 (  7 34 ) resistor r=3.57586 //w=0.17 //l=0.125 //layer=li //thickness=0.1 \
 //x=70.93 //y=0.805 //x2=70.93 //y2=0.68
r86 (  7 34 ) resistor r=18.139 //w=0.187 //l=0.265 //layer=li //thickness=0.1 \
 //x=70.93 //y=0.805 //x2=70.93 //y2=1.07
r87 (  6 33 ) resistor r=0.751729 //w=0.17 //l=0.085 //layer=li \
 //thickness=0.1 //x=69.965 //y=1.175 //x2=69.88 //y2=1.175
r88 (  5 30 ) resistor r=1.40859 //w=0.34 //l=0.085 //layer=li //thickness=0.1 \
 //x=70.845 //y=1.175 //x2=70.93 //y2=1.175
r89 (  5 6 ) resistor r=60.2353 //w=0.187 //l=0.88 //layer=li //thickness=0.1 \
 //x=70.845 //y=1.175 //x2=69.965 //y2=1.175
ends PM_TMRDFFSNRNQNX1\%noxref_39

subckt PM_TMRDFFSNRNQNX1\%noxref_40 ( 5 7 15 19 30 33 34 )
c67 ( 34 0 ) capacitor c=0.0452753f //x=75.605 //y=0.555
c68 ( 33 0 ) capacitor c=0.0194988f //x=74.5 //y=1.09
c69 ( 30 0 ) capacitor c=0.00141302f //x=75.74 //y=1.175
c70 ( 19 0 ) capacitor c=0.00692795f //x=76.71 //y=0.805
c71 ( 15 0 ) capacitor c=0.0153812f //x=76.625 //y=0.72
c72 ( 7 0 ) capacitor c=0.00689459f //x=75.74 //y=0.805
c73 ( 5 0 ) capacitor c=0.0235962f //x=75.655 //y=1.175
r74 (  19 34 ) resistor r=3.57586 //w=0.17 //l=0.125 //layer=li \
 //thickness=0.1 //x=76.71 //y=0.805 //x2=76.71 //y2=0.68
r75 (  19 34 ) resistor r=18.139 //w=0.187 //l=0.265 //layer=li \
 //thickness=0.1 //x=76.71 //y=0.805 //x2=76.71 //y2=1.07
r76 (  16 34 ) resistor r=3.57586 //w=0.17 //l=0.103078 //layer=li \
 //thickness=0.1 //x=75.825 //y=0.72 //x2=75.74 //y2=0.68
r77 (  16 34 ) resistor r=27.3797 //w=0.187 //l=0.4 //layer=li //thickness=0.1 \
 //x=75.825 //y=0.72 //x2=76.225 //y2=0.72
r78 (  15 34 ) resistor r=3.57586 //w=0.17 //l=0.103078 //layer=li \
 //thickness=0.1 //x=76.625 //y=0.72 //x2=76.71 //y2=0.68
r79 (  15 34 ) resistor r=27.3797 //w=0.187 //l=0.4 //layer=li //thickness=0.1 \
 //x=76.625 //y=0.72 //x2=76.225 //y2=0.72
r80 (  11 30 ) resistor r=5.4201 //w=0.17 //l=0.085 //layer=li //thickness=0.1 \
 //x=75.74 //y=1.26 //x2=75.74 //y2=1.175
r81 (  11 34 ) resistor r=10.2674 //w=0.187 //l=0.15 //layer=li \
 //thickness=0.1 //x=75.74 //y=1.26 //x2=75.74 //y2=1.41
r82 (  8 30 ) resistor r=5.4201 //w=0.17 //l=0.085 //layer=li //thickness=0.1 \
 //x=75.74 //y=1.09 //x2=75.74 //y2=1.175
r83 (  8 34 ) resistor r=1.36898 //w=0.187 //l=0.02 //layer=li //thickness=0.1 \
 //x=75.74 //y=1.09 //x2=75.74 //y2=1.07
r84 (  7 34 ) resistor r=3.57586 //w=0.17 //l=0.125 //layer=li //thickness=0.1 \
 //x=75.74 //y=0.805 //x2=75.74 //y2=0.68
r85 (  7 34 ) resistor r=18.139 //w=0.187 //l=0.265 //layer=li //thickness=0.1 \
 //x=75.74 //y=0.805 //x2=75.74 //y2=1.07
r86 (  6 33 ) resistor r=0.751729 //w=0.17 //l=0.085 //layer=li \
 //thickness=0.1 //x=74.775 //y=1.175 //x2=74.69 //y2=1.175
r87 (  5 30 ) resistor r=1.40859 //w=0.34 //l=0.085 //layer=li //thickness=0.1 \
 //x=75.655 //y=1.175 //x2=75.74 //y2=1.175
r88 (  5 6 ) resistor r=60.2353 //w=0.187 //l=0.88 //layer=li //thickness=0.1 \
 //x=75.655 //y=1.175 //x2=74.775 //y2=1.175
ends PM_TMRDFFSNRNQNX1\%noxref_40

subckt PM_TMRDFFSNRNQNX1\%noxref_41 ( 5 7 15 19 30 33 34 )
c68 ( 34 0 ) capacitor c=0.0440892f //x=80.415 //y=0.555
c69 ( 33 0 ) capacitor c=0.0190261f //x=79.31 //y=1.09
c70 ( 30 0 ) capacitor c=0.00141302f //x=80.55 //y=1.175
c71 ( 19 0 ) capacitor c=0.00692795f //x=81.52 //y=0.805
c72 ( 15 0 ) capacitor c=0.0155864f //x=81.435 //y=0.72
c73 ( 7 0 ) capacitor c=0.00689459f //x=80.55 //y=0.805
c74 ( 5 0 ) capacitor c=0.0247635f //x=80.465 //y=1.175
r75 (  19 34 ) resistor r=3.57586 //w=0.17 //l=0.125 //layer=li \
 //thickness=0.1 //x=81.52 //y=0.805 //x2=81.52 //y2=0.68
r76 (  19 34 ) resistor r=18.139 //w=0.187 //l=0.265 //layer=li \
 //thickness=0.1 //x=81.52 //y=0.805 //x2=81.52 //y2=1.07
r77 (  16 34 ) resistor r=3.57586 //w=0.17 //l=0.103078 //layer=li \
 //thickness=0.1 //x=80.635 //y=0.72 //x2=80.55 //y2=0.68
r78 (  16 34 ) resistor r=27.3797 //w=0.187 //l=0.4 //layer=li //thickness=0.1 \
 //x=80.635 //y=0.72 //x2=81.035 //y2=0.72
r79 (  15 34 ) resistor r=3.57586 //w=0.17 //l=0.103078 //layer=li \
 //thickness=0.1 //x=81.435 //y=0.72 //x2=81.52 //y2=0.68
r80 (  15 34 ) resistor r=27.3797 //w=0.187 //l=0.4 //layer=li //thickness=0.1 \
 //x=81.435 //y=0.72 //x2=81.035 //y2=0.72
r81 (  11 30 ) resistor r=5.4201 //w=0.17 //l=0.085 //layer=li //thickness=0.1 \
 //x=80.55 //y=1.26 //x2=80.55 //y2=1.175
r82 (  11 34 ) resistor r=10.2674 //w=0.187 //l=0.15 //layer=li \
 //thickness=0.1 //x=80.55 //y=1.26 //x2=80.55 //y2=1.41
r83 (  8 30 ) resistor r=5.4201 //w=0.17 //l=0.085 //layer=li //thickness=0.1 \
 //x=80.55 //y=1.09 //x2=80.55 //y2=1.175
r84 (  8 34 ) resistor r=1.36898 //w=0.187 //l=0.02 //layer=li //thickness=0.1 \
 //x=80.55 //y=1.09 //x2=80.55 //y2=1.07
r85 (  7 34 ) resistor r=3.57586 //w=0.17 //l=0.125 //layer=li //thickness=0.1 \
 //x=80.55 //y=0.805 //x2=80.55 //y2=0.68
r86 (  7 34 ) resistor r=18.139 //w=0.187 //l=0.265 //layer=li //thickness=0.1 \
 //x=80.55 //y=0.805 //x2=80.55 //y2=1.07
r87 (  6 33 ) resistor r=0.751729 //w=0.17 //l=0.085 //layer=li \
 //thickness=0.1 //x=79.585 //y=1.175 //x2=79.5 //y2=1.175
r88 (  5 30 ) resistor r=1.40859 //w=0.34 //l=0.085 //layer=li //thickness=0.1 \
 //x=80.465 //y=1.175 //x2=80.55 //y2=1.175
r89 (  5 6 ) resistor r=60.2353 //w=0.187 //l=0.88 //layer=li //thickness=0.1 \
 //x=80.465 //y=1.175 //x2=79.585 //y2=1.175
ends PM_TMRDFFSNRNQNX1\%noxref_41

subckt PM_TMRDFFSNRNQNX1\%noxref_42 ( 5 7 15 19 30 33 34 )
c69 ( 34 0 ) capacitor c=0.0442064f //x=85.225 //y=0.555
c70 ( 33 0 ) capacitor c=0.0185765f //x=84.12 //y=1.09
c71 ( 30 0 ) capacitor c=0.00141302f //x=85.36 //y=1.175
c72 ( 19 0 ) capacitor c=0.00695768f //x=86.33 //y=0.805
c73 ( 15 0 ) capacitor c=0.0154873f //x=86.245 //y=0.72
c74 ( 7 0 ) capacitor c=0.00689476f //x=85.36 //y=0.805
c75 ( 5 0 ) capacitor c=0.0235962f //x=85.275 //y=1.175
r76 (  19 34 ) resistor r=3.57586 //w=0.17 //l=0.125 //layer=li \
 //thickness=0.1 //x=86.33 //y=0.805 //x2=86.33 //y2=0.68
r77 (  19 34 ) resistor r=18.139 //w=0.187 //l=0.265 //layer=li \
 //thickness=0.1 //x=86.33 //y=0.805 //x2=86.33 //y2=1.07
r78 (  16 34 ) resistor r=3.57586 //w=0.17 //l=0.103078 //layer=li \
 //thickness=0.1 //x=85.445 //y=0.72 //x2=85.36 //y2=0.68
r79 (  16 34 ) resistor r=27.3797 //w=0.187 //l=0.4 //layer=li //thickness=0.1 \
 //x=85.445 //y=0.72 //x2=85.845 //y2=0.72
r80 (  15 34 ) resistor r=3.57586 //w=0.17 //l=0.103078 //layer=li \
 //thickness=0.1 //x=86.245 //y=0.72 //x2=86.33 //y2=0.68
r81 (  15 34 ) resistor r=27.3797 //w=0.187 //l=0.4 //layer=li //thickness=0.1 \
 //x=86.245 //y=0.72 //x2=85.845 //y2=0.72
r82 (  11 30 ) resistor r=5.4201 //w=0.17 //l=0.085 //layer=li //thickness=0.1 \
 //x=85.36 //y=1.26 //x2=85.36 //y2=1.175
r83 (  11 34 ) resistor r=10.2674 //w=0.187 //l=0.15 //layer=li \
 //thickness=0.1 //x=85.36 //y=1.26 //x2=85.36 //y2=1.41
r84 (  8 30 ) resistor r=5.4201 //w=0.17 //l=0.085 //layer=li //thickness=0.1 \
 //x=85.36 //y=1.09 //x2=85.36 //y2=1.175
r85 (  8 34 ) resistor r=1.36898 //w=0.187 //l=0.02 //layer=li //thickness=0.1 \
 //x=85.36 //y=1.09 //x2=85.36 //y2=1.07
r86 (  7 34 ) resistor r=3.57586 //w=0.17 //l=0.125 //layer=li //thickness=0.1 \
 //x=85.36 //y=0.805 //x2=85.36 //y2=0.68
r87 (  7 34 ) resistor r=18.139 //w=0.187 //l=0.265 //layer=li //thickness=0.1 \
 //x=85.36 //y=0.805 //x2=85.36 //y2=1.07
r88 (  6 33 ) resistor r=0.751729 //w=0.17 //l=0.085 //layer=li \
 //thickness=0.1 //x=84.395 //y=1.175 //x2=84.31 //y2=1.175
r89 (  5 30 ) resistor r=1.40859 //w=0.34 //l=0.085 //layer=li //thickness=0.1 \
 //x=85.275 //y=1.175 //x2=85.36 //y2=1.175
r90 (  5 6 ) resistor r=60.2353 //w=0.187 //l=0.88 //layer=li //thickness=0.1 \
 //x=85.275 //y=1.175 //x2=84.395 //y2=1.175
ends PM_TMRDFFSNRNQNX1\%noxref_42

subckt PM_TMRDFFSNRNQNX1\%noxref_43 ( 1 3 4 5 7 9 19 25 27 30 40 49 71 72 73 \
 74 75 )
c160 ( 75 0 ) capacitor c=0.0354016f //x=92.795 //y=5.205
c161 ( 74 0 ) capacitor c=0.0241107f //x=91.915 //y=5.205
c162 ( 72 0 ) capacitor c=0.00544792f //x=89.035 //y=5.205
c163 ( 71 0 ) capacitor c=0.00516996f //x=88.155 //y=5.205
c164 ( 49 0 ) capacitor c=0.0509795f //x=91.18 //y=5.39
c165 ( 40 0 ) capacitor c=0.0363228f //x=89.18 //y=5.39
c166 ( 30 0 ) capacitor c=0.0294643f //x=88.3 //y=5.56
c167 ( 27 0 ) capacitor c=0.00984489f //x=92.94 //y=6.92
c168 ( 25 0 ) capacitor c=0.0059844f //x=92.057 //y=7.09
c169 ( 19 0 ) capacitor c=0.00975753f //x=91.18 //y=6.92
c170 ( 9 0 ) capacitor c=0.014892f //x=88.302 //y=5.39
c171 ( 7 0 ) capacitor c=0.00787288f //x=92.825 //y=7.09
c172 ( 5 0 ) capacitor c=0.00659042f //x=91.94 //y=7.09
c173 ( 4 0 ) capacitor c=0.00558326f //x=89.295 //y=5.39
c174 ( 3 0 ) capacitor c=0.0636102f //x=91.065 //y=5.39
c175 ( 1 0 ) capacitor c=0.0145996f //x=89.065 //y=5.39
r176 (  49 73 ) resistor r=58.1818 //w=0.187 //l=0.85 //layer=li \
 //thickness=0.1 //x=91.18 //y=5.39 //x2=91.18 //y2=6.24
r177 (  40 72 ) resistor r=58.1818 //w=0.187 //l=0.85 //layer=li \
 //thickness=0.1 //x=89.18 //y=5.39 //x2=89.18 //y2=6.24
r178 (  30 71 ) resistor r=23.2727 //w=0.187 //l=0.34 //layer=li \
 //thickness=0.1 //x=88.3 //y=5.56 //x2=88.3 //y2=5.9
r179 (  27 75 ) resistor r=9.3 //w=0.17 //l=0.17 //layer=mcon //count=1 \
 //x=92.94 //y=6.92 //x2=92.94 //y2=6.92
r180 (  27 28 ) resistor r=0.0988372 //w=0.215 //l=0.17 //layer=m1 \
 //thickness=0.36 //x=92.942 //y=6.92 //x2=92.942 //y2=7.09
r181 (  24 74 ) resistor r=9.3 //w=0.17 //l=0.17 //layer=mcon //count=1 \
 //x=92.06 //y=6.92 //x2=92.06 //y2=6.92
r182 (  24 25 ) resistor r=0.0940266 //w=0.226 //l=0.17 //layer=m1 \
 //thickness=0.36 //x=92.057 //y=6.92 //x2=92.057 //y2=7.09
r183 (  22 49 ) resistor r=9.3 //w=0.17 //l=0.17 //layer=mcon //count=1 \
 //x=91.18 //y=5.39 //x2=91.18 //y2=5.39
r184 (  19 73 ) resistor r=9.3 //w=0.17 //l=0.17 //layer=mcon //count=1 \
 //x=91.18 //y=6.92 //x2=91.18 //y2=6.92
r185 (  19 20 ) resistor r=0.0979263 //w=0.217 //l=0.17 //layer=m1 \
 //thickness=0.36 //x=91.182 //y=6.92 //x2=91.182 //y2=7.09
r186 (  15 40 ) resistor r=9.3 //w=0.17 //l=0.17 //layer=mcon //count=1 \
 //x=89.18 //y=5.39 //x2=89.18 //y2=5.39
r187 (  11 30 ) resistor r=9.3 //w=0.17 //l=0.17 //layer=mcon //count=1 \
 //x=88.3 //y=5.56 //x2=88.3 //y2=5.56
r188 (  9 11 ) resistor r=0.0944444 //w=0.225 //l=0.17 //layer=m1 \
 //thickness=0.36 //x=88.302 //y=5.39 //x2=88.302 //y2=5.56
r189 (  8 25 ) resistor r=0.0246599 //w=0.226 //l=0.118 //layer=m1 \
 //thickness=0.36 //x=92.175 //y=7.09 //x2=92.057 //y2=7.09
r190 (  7 28 ) resistor r=0.0216707 //w=0.215 //l=0.117 //layer=m1 \
 //thickness=0.36 //x=92.825 //y=7.09 //x2=92.942 //y2=7.09
r191 (  7 8 ) resistor r=0.620229 //w=0.131 //l=0.65 //layer=m1 \
 //thickness=0.36 //x=92.825 //y=7.09 //x2=92.175 //y2=7.09
r192 (  6 20 ) resistor r=0.0222262 //w=0.217 //l=0.118 //layer=m1 \
 //thickness=0.36 //x=91.3 //y=7.09 //x2=91.182 //y2=7.09
r193 (  5 25 ) resistor r=0.0246599 //w=0.226 //l=0.117 //layer=m1 \
 //thickness=0.36 //x=91.94 //y=7.09 //x2=92.057 //y2=7.09
r194 (  5 6 ) resistor r=0.610687 //w=0.131 //l=0.64 //layer=m1 \
 //thickness=0.36 //x=91.94 //y=7.09 //x2=91.3 //y2=7.09
r195 (  4 15 ) resistor r=0.0880901 //w=0.191 //l=0.115 //layer=m1 \
 //thickness=0.36 //x=89.295 //y=5.39 //x2=89.18 //y2=5.39
r196 (  3 22 ) resistor r=0.0717383 //w=0.224 //l=0.115 //layer=m1 \
 //thickness=0.36 //x=91.065 //y=5.39 //x2=91.18 //y2=5.39
r197 (  3 4 ) resistor r=1.68893 //w=0.131 //l=1.77 //layer=m1 \
 //thickness=0.36 //x=91.065 //y=5.39 //x2=89.295 //y2=5.39
r198 (  2 9 ) resistor r=0.0243946 //w=0.225 //l=0.123 //layer=m1 \
 //thickness=0.36 //x=88.425 //y=5.39 //x2=88.302 //y2=5.39
r199 (  1 15 ) resistor r=0.0880901 //w=0.191 //l=0.115 //layer=m1 \
 //thickness=0.36 //x=89.065 //y=5.39 //x2=89.18 //y2=5.39
r200 (  1 2 ) resistor r=0.610687 //w=0.131 //l=0.64 //layer=m1 \
 //thickness=0.36 //x=89.065 //y=5.39 //x2=88.425 //y2=5.39
ends PM_TMRDFFSNRNQNX1\%noxref_43

subckt PM_TMRDFFSNRNQNX1\%noxref_44 ( 1 3 4 5 7 9 15 21 23 26 34 40 62 63 64 \
 65 66 )
c125 ( 66 0 ) capacitor c=0.034392f //x=96.135 //y=5.205
c126 ( 65 0 ) capacitor c=0.0239063f //x=95.255 //y=5.205
c127 ( 40 0 ) capacitor c=0.0496553f //x=94.52 //y=5.39
c128 ( 34 0 ) capacitor c=0.0324071f //x=92.5 //y=5.39
c129 ( 26 0 ) capacitor c=0.0224248f //x=91.62 //y=5.56
c130 ( 23 0 ) capacitor c=0.0155899f //x=96.28 //y=6.92
c131 ( 21 0 ) capacitor c=0.00566376f //x=95.4 //y=7.09
c132 ( 15 0 ) capacitor c=0.00945187f //x=94.52 //y=6.92
c133 ( 9 0 ) capacitor c=0.0153397f //x=91.62 //y=5.39
c134 ( 7 0 ) capacitor c=0.0068287f //x=96.15 //y=7.09
c135 ( 5 0 ) capacitor c=0.00878908f //x=95.285 //y=7.09
c136 ( 4 0 ) capacitor c=0.00713333f //x=92.615 //y=5.39
c137 ( 3 0 ) capacitor c=0.0571322f //x=94.405 //y=5.39
c138 ( 1 0 ) capacitor c=0.0183133f //x=92.385 //y=5.39
r139 (  40 64 ) resistor r=58.1818 //w=0.187 //l=0.85 //layer=li \
 //thickness=0.1 //x=94.52 //y=5.39 //x2=94.52 //y2=6.24
r140 (  34 63 ) resistor r=58.1818 //w=0.187 //l=0.85 //layer=li \
 //thickness=0.1 //x=92.5 //y=5.39 //x2=92.5 //y2=6.24
r141 (  26 62 ) resistor r=23.2727 //w=0.187 //l=0.34 //layer=li \
 //thickness=0.1 //x=91.62 //y=5.56 //x2=91.62 //y2=5.9
r142 (  23 66 ) resistor r=9.3 //w=0.17 //l=0.17 //layer=mcon //count=1 \
 //x=96.28 //y=6.92 //x2=96.28 //y2=6.92
r143 (  23 24 ) resistor r=0.0923913 //w=0.23 //l=0.17 //layer=m1 \
 //thickness=0.36 //x=96.275 //y=6.92 //x2=96.275 //y2=7.09
r144 (  20 65 ) resistor r=9.3 //w=0.17 //l=0.17 //layer=mcon //count=1 \
 //x=95.4 //y=6.92 //x2=95.4 //y2=6.92
r145 (  20 21 ) resistor r=0.0957207 //w=0.222 //l=0.17 //layer=m1 \
 //thickness=0.36 //x=95.4 //y=6.92 //x2=95.4 //y2=7.09
r146 (  18 40 ) resistor r=9.3 //w=0.17 //l=0.17 //layer=mcon //count=1 \
 //x=94.52 //y=5.39 //x2=94.52 //y2=5.39
r147 (  15 64 ) resistor r=9.3 //w=0.17 //l=0.17 //layer=mcon //count=1 \
 //x=94.52 //y=6.92 //x2=94.52 //y2=6.92
r148 (  15 16 ) resistor r=0.100236 //w=0.212 //l=0.17 //layer=m1 \
 //thickness=0.36 //x=94.52 //y=6.92 //x2=94.52 //y2=7.09
r149 (  13 34 ) resistor r=9.3 //w=0.17 //l=0.17 //layer=mcon //count=1 \
 //x=92.5 //y=5.39 //x2=92.5 //y2=5.39
r150 (  11 26 ) resistor r=9.3 //w=0.17 //l=0.17 //layer=mcon //count=1 \
 //x=91.62 //y=5.56 //x2=91.62 //y2=5.56
r151 (  9 11 ) resistor r=0.100236 //w=0.212 //l=0.17 //layer=m1 \
 //thickness=0.36 //x=91.62 //y=5.39 //x2=91.62 //y2=5.56
r152 (  8 21 ) resistor r=0.0235912 //w=0.222 //l=0.115 //layer=m1 \
 //thickness=0.36 //x=95.515 //y=7.09 //x2=95.4 //y2=7.09
r153 (  7 24 ) resistor r=0.0257089 //w=0.23 //l=0.125 //layer=m1 \
 //thickness=0.36 //x=96.15 //y=7.09 //x2=96.275 //y2=7.09
r154 (  7 8 ) resistor r=0.605916 //w=0.131 //l=0.635 //layer=m1 \
 //thickness=0.36 //x=96.15 //y=7.09 //x2=95.515 //y2=7.09
r155 (  6 16 ) resistor r=0.0208269 //w=0.212 //l=0.115 //layer=m1 \
 //thickness=0.36 //x=94.635 //y=7.09 //x2=94.52 //y2=7.09
r156 (  5 21 ) resistor r=0.0235912 //w=0.222 //l=0.115 //layer=m1 \
 //thickness=0.36 //x=95.285 //y=7.09 //x2=95.4 //y2=7.09
r157 (  5 6 ) resistor r=0.620229 //w=0.131 //l=0.65 //layer=m1 \
 //thickness=0.36 //x=95.285 //y=7.09 //x2=94.635 //y2=7.09
r158 (  4 13 ) resistor r=0.0880901 //w=0.191 //l=0.115 //layer=m1 \
 //thickness=0.36 //x=92.615 //y=5.39 //x2=92.5 //y2=5.39
r159 (  3 18 ) resistor r=0.0717383 //w=0.224 //l=0.115 //layer=m1 \
 //thickness=0.36 //x=94.405 //y=5.39 //x2=94.52 //y2=5.39
r160 (  3 4 ) resistor r=1.70802 //w=0.131 //l=1.79 //layer=m1 \
 //thickness=0.36 //x=94.405 //y=5.39 //x2=92.615 //y2=5.39
r161 (  2 9 ) resistor r=0.0208269 //w=0.212 //l=0.115 //layer=m1 \
 //thickness=0.36 //x=91.735 //y=5.39 //x2=91.62 //y2=5.39
r162 (  1 13 ) resistor r=0.0880901 //w=0.191 //l=0.115 //layer=m1 \
 //thickness=0.36 //x=92.385 //y=5.39 //x2=92.5 //y2=5.39
r163 (  1 2 ) resistor r=0.620229 //w=0.131 //l=0.65 //layer=m1 \
 //thickness=0.36 //x=92.385 //y=5.39 //x2=91.735 //y2=5.39
ends PM_TMRDFFSNRNQNX1\%noxref_44

subckt PM_TMRDFFSNRNQNX1\%GND ( 1 2 6 7 18 19 30 31 42 43 54 55 66 67 78 79 90 \
 91 102 103 114 115 127 128 139 140 151 152 163 164 175 176 187 188 199 200 \
 211 212 223 224 231 232 239 244 247 251 255 259 263 267 271 275 279 283 287 \
 291 295 299 303 307 311 315 330 333 347 364 381 398 415 432 449 466 483 500 \
 517 534 551 568 585 602 619 636 651 671 679 680 681 682 683 684 685 686 687 \
 688 689 690 691 692 693 694 695 696 697 698 699 700 701 702 703 704 705 706 \
 707 708 709 710 711 712 713 714 715 716 717 718 719 )
c1694 ( 719 0 ) capacitor c=0.00828027f //x=94.72 //y=1.045
c1695 ( 718 0 ) capacitor c=0.00867576f //x=91.39 //y=1.045
c1696 ( 717 0 ) capacitor c=0.0083251f //x=88.06 //y=1.045
c1697 ( 716 0 ) capacitor c=0.00840423f //x=83.145 //y=1.055
c1698 ( 715 0 ) capacitor c=0.00840423f //x=78.335 //y=1.055
c1699 ( 714 0 ) capacitor c=0.00840423f //x=73.525 //y=1.055
c1700 ( 713 0 ) capacitor c=0.00840423f //x=68.715 //y=1.055
c1701 ( 712 0 ) capacitor c=0.00840423f //x=63.905 //y=1.055
c1702 ( 711 0 ) capacitor c=0.00840423f //x=59.095 //y=1.055
c1703 ( 710 0 ) capacitor c=0.00840423f //x=54.285 //y=1.055
c1704 ( 709 0 ) capacitor c=0.00840423f //x=49.475 //y=1.055
c1705 ( 708 0 ) capacitor c=0.00840423f //x=44.665 //y=1.055
c1706 ( 707 0 ) capacitor c=0.00840423f //x=39.855 //y=1.055
c1707 ( 706 0 ) capacitor c=0.00840423f //x=35.045 //y=1.055
c1708 ( 705 0 ) capacitor c=0.00840423f //x=30.235 //y=1.055
c1709 ( 704 0 ) capacitor c=0.00840423f //x=25.425 //y=1.055
c1710 ( 703 0 ) capacitor c=0.00840423f //x=20.615 //y=1.055
c1711 ( 702 0 ) capacitor c=0.00840423f //x=15.805 //y=1.055
c1712 ( 701 0 ) capacitor c=0.00840423f //x=10.995 //y=1.055
c1713 ( 700 0 ) capacitor c=0.00840423f //x=6.185 //y=1.055
c1714 ( 699 0 ) capacitor c=0.00840423f //x=1.375 //y=1.055
c1715 ( 698 0 ) capacitor c=0.110241f //x=93.73 //y=0.175
c1716 ( 697 0 ) capacitor c=0.123698f //x=90.4 //y=0.175
c1717 ( 696 0 ) capacitor c=0.114547f //x=87.07 //y=0.175
c1718 ( 695 0 ) capacitor c=0.110773f //x=82.26 //y=0.175
c1719 ( 694 0 ) capacitor c=0.115871f //x=77.45 //y=0.175
c1720 ( 693 0 ) capacitor c=0.109628f //x=72.64 //y=0.175
c1721 ( 692 0 ) capacitor c=0.112438f //x=67.83 //y=0.175
c1722 ( 691 0 ) capacitor c=0.109586f //x=63.02 //y=0.175
c1723 ( 690 0 ) capacitor c=0.111695f //x=58.21 //y=0.175
c1724 ( 689 0 ) capacitor c=0.113313f //x=53.4 //y=0.175
c1725 ( 688 0 ) capacitor c=0.115871f //x=48.59 //y=0.175
c1726 ( 687 0 ) capacitor c=0.109628f //x=43.78 //y=0.175
c1727 ( 686 0 ) capacitor c=0.112438f //x=38.97 //y=0.175
c1728 ( 685 0 ) capacitor c=0.109586f //x=34.16 //y=0.175
c1729 ( 684 0 ) capacitor c=0.114177f //x=29.35 //y=0.175
c1730 ( 683 0 ) capacitor c=0.109534f //x=24.54 //y=0.175
c1731 ( 682 0 ) capacitor c=0.114177f //x=19.73 //y=0.175
c1732 ( 681 0 ) capacitor c=0.109628f //x=14.92 //y=0.175
c1733 ( 680 0 ) capacitor c=0.112592f //x=10.11 //y=0.175
c1734 ( 679 0 ) capacitor c=0.10974f //x=5.3 //y=0.175
c1735 ( 671 0 ) capacitor c=0.333412f //x=96.32 //y=0.18
c1736 ( 651 0 ) capacitor c=0.118812f //x=93.56 //y=0.175
c1737 ( 636 0 ) capacitor c=0.119089f //x=90.23 //y=0.175
c1738 ( 619 0 ) capacitor c=0.176388f //x=86.9 //y=0.175
c1739 ( 602 0 ) capacitor c=0.174611f //x=82.09 //y=0.175
c1740 ( 585 0 ) capacitor c=0.176385f //x=77.28 //y=0.175
c1741 ( 568 0 ) capacitor c=0.176388f //x=72.47 //y=0.175
c1742 ( 551 0 ) capacitor c=0.176388f //x=67.66 //y=0.175
c1743 ( 534 0 ) capacitor c=0.17641f //x=62.85 //y=0.175
c1744 ( 517 0 ) capacitor c=0.176388f //x=58.04 //y=0.175
c1745 ( 500 0 ) capacitor c=0.176434f //x=53.23 //y=0.175
c1746 ( 483 0 ) capacitor c=0.176385f //x=48.42 //y=0.175
c1747 ( 466 0 ) capacitor c=0.176388f //x=43.61 //y=0.175
c1748 ( 449 0 ) capacitor c=0.176388f //x=38.8 //y=0.175
c1749 ( 432 0 ) capacitor c=0.17641f //x=33.99 //y=0.175
c1750 ( 415 0 ) capacitor c=0.176388f //x=29.18 //y=0.175
c1751 ( 398 0 ) capacitor c=0.176414f //x=24.37 //y=0.175
c1752 ( 381 0 ) capacitor c=0.176385f //x=19.56 //y=0.175
c1753 ( 364 0 ) capacitor c=0.176388f //x=14.75 //y=0.175
c1754 ( 347 0 ) capacitor c=0.176388f //x=9.94 //y=0.175
c1755 ( 333 0 ) capacitor c=0.197064f //x=1.23 //y=0.18
c1756 ( 330 0 ) capacitor c=0.17924f //x=5.13 //y=0.175
c1757 ( 325 0 ) capacitor c=0.00509083f //x=94.91 //y=0.175
c1758 ( 322 0 ) capacitor c=0.00510068f //x=91.51 //y=0.18
c1759 ( 318 0 ) capacitor c=0.00509083f //x=88.25 //y=0.175
c1760 ( 317 0 ) capacitor c=0.00509414f //x=83.335 //y=0.175
c1761 ( 315 0 ) capacitor c=0.0139218f //x=83.335 //y=1.145
c1762 ( 313 0 ) capacitor c=0.00509414f //x=78.525 //y=0.175
c1763 ( 311 0 ) capacitor c=0.0140686f //x=78.525 //y=1.145
c1764 ( 309 0 ) capacitor c=0.00509414f //x=73.715 //y=0.175
c1765 ( 307 0 ) capacitor c=0.0140105f //x=73.715 //y=1.145
c1766 ( 305 0 ) capacitor c=0.00509414f //x=68.905 //y=0.175
c1767 ( 303 0 ) capacitor c=0.0140108f //x=68.905 //y=1.145
c1768 ( 301 0 ) capacitor c=0.00509414f //x=64.095 //y=0.175
c1769 ( 299 0 ) capacitor c=0.0139796f //x=64.095 //y=1.145
c1770 ( 297 0 ) capacitor c=0.00509414f //x=59.285 //y=0.175
c1771 ( 295 0 ) capacitor c=0.0140089f //x=59.285 //y=1.145
c1772 ( 293 0 ) capacitor c=0.00509414f //x=54.475 //y=0.175
c1773 ( 291 0 ) capacitor c=0.0139694f //x=54.475 //y=1.145
c1774 ( 289 0 ) capacitor c=0.00509414f //x=49.665 //y=0.175
c1775 ( 287 0 ) capacitor c=0.0139684f //x=49.665 //y=1.145
c1776 ( 285 0 ) capacitor c=0.00509414f //x=44.855 //y=0.175
c1777 ( 283 0 ) capacitor c=0.0139141f //x=44.855 //y=1.145
c1778 ( 281 0 ) capacitor c=0.00509414f //x=40.045 //y=0.175
c1779 ( 279 0 ) capacitor c=0.0139145f //x=40.045 //y=1.145
c1780 ( 277 0 ) capacitor c=0.00509414f //x=35.235 //y=0.175
c1781 ( 275 0 ) capacitor c=0.0140783f //x=35.235 //y=1.145
c1782 ( 273 0 ) capacitor c=0.00509414f //x=30.425 //y=0.175
c1783 ( 271 0 ) capacitor c=0.0141008f //x=30.425 //y=1.145
c1784 ( 269 0 ) capacitor c=0.00509414f //x=25.615 //y=0.175
c1785 ( 267 0 ) capacitor c=0.0140088f //x=25.615 //y=1.145
c1786 ( 265 0 ) capacitor c=0.00509414f //x=20.805 //y=0.175
c1787 ( 263 0 ) capacitor c=0.0140686f //x=20.805 //y=1.145
c1788 ( 261 0 ) capacitor c=0.00509414f //x=15.995 //y=0.175
c1789 ( 259 0 ) capacitor c=0.0140168f //x=15.995 //y=1.145
c1790 ( 257 0 ) capacitor c=0.00509414f //x=11.185 //y=0.175
c1791 ( 255 0 ) capacitor c=0.0139572f //x=11.185 //y=1.145
c1792 ( 253 0 ) capacitor c=0.00509414f //x=6.375 //y=0.175
c1793 ( 251 0 ) capacitor c=0.0140851f //x=6.375 //y=1.145
c1794 ( 249 0 ) capacitor c=0.00509414f //x=1.565 //y=0.175
c1795 ( 247 0 ) capacitor c=0.0169996f //x=1.565 //y=1.145
c1796 ( 244 0 ) capacitor c=0.10135f //x=96.32 //y=0.18
c1797 ( 239 0 ) capacitor c=0.0371532f //x=94.91 //y=1.02
c1798 ( 232 0 ) capacitor c=0.107311f //x=94.825 //y=0.175
c1799 ( 231 0 ) capacitor c=0.0282975f //x=91.58 //y=1.015
c1800 ( 224 0 ) capacitor c=0.112329f //x=91.495 //y=0.175
c1801 ( 223 0 ) capacitor c=0.0347784f //x=88.25 //y=1.015
c1802 ( 212 0 ) capacitor c=0.154984f //x=88.165 //y=0.175
c1803 ( 211 0 ) capacitor c=0.0302305f //x=83.335 //y=1.015
c1804 ( 200 0 ) capacitor c=0.14844f //x=83.25 //y=0.175
c1805 ( 199 0 ) capacitor c=0.0302305f //x=78.525 //y=1.015
c1806 ( 188 0 ) capacitor c=0.14916f //x=78.44 //y=0.175
c1807 ( 187 0 ) capacitor c=0.0302305f //x=73.715 //y=1.015
c1808 ( 176 0 ) capacitor c=0.148704f //x=73.63 //y=0.175
c1809 ( 175 0 ) capacitor c=0.0302305f //x=68.905 //y=1.015
c1810 ( 164 0 ) capacitor c=0.149124f //x=68.82 //y=0.175
c1811 ( 163 0 ) capacitor c=0.0302305f //x=64.095 //y=1.015
c1812 ( 152 0 ) capacitor c=0.148598f //x=64.01 //y=0.175
c1813 ( 151 0 ) capacitor c=0.0302305f //x=59.285 //y=1.015
c1814 ( 140 0 ) capacitor c=0.150358f //x=59.2 //y=0.175
c1815 ( 139 0 ) capacitor c=0.0302305f //x=54.475 //y=1.015
c1816 ( 128 0 ) capacitor c=0.149093f //x=54.39 //y=0.175
c1817 ( 127 0 ) capacitor c=0.0302305f //x=49.665 //y=1.015
c1818 ( 115 0 ) capacitor c=0.14916f //x=49.58 //y=0.175
c1819 ( 114 0 ) capacitor c=0.0302305f //x=44.855 //y=1.015
c1820 ( 103 0 ) capacitor c=0.148704f //x=44.77 //y=0.175
c1821 ( 102 0 ) capacitor c=0.0302305f //x=40.045 //y=1.015
c1822 ( 91 0 ) capacitor c=0.149124f //x=39.96 //y=0.175
c1823 ( 90 0 ) capacitor c=0.0302305f //x=35.235 //y=1.015
c1824 ( 79 0 ) capacitor c=0.148636f //x=35.15 //y=0.175
c1825 ( 78 0 ) capacitor c=0.0302305f //x=30.425 //y=1.015
c1826 ( 67 0 ) capacitor c=0.150287f //x=30.34 //y=0.175
c1827 ( 66 0 ) capacitor c=0.0302305f //x=25.615 //y=1.015
c1828 ( 55 0 ) capacitor c=0.148588f //x=25.53 //y=0.175
c1829 ( 54 0 ) capacitor c=0.0302305f //x=20.805 //y=1.015
c1830 ( 43 0 ) capacitor c=0.14916f //x=20.72 //y=0.175
c1831 ( 42 0 ) capacitor c=0.0302305f //x=15.995 //y=1.015
c1832 ( 31 0 ) capacitor c=0.148704f //x=15.91 //y=0.175
c1833 ( 30 0 ) capacitor c=0.0302305f //x=11.185 //y=1.015
c1834 ( 19 0 ) capacitor c=0.149124f //x=11.1 //y=0.175
c1835 ( 18 0 ) capacitor c=0.0302305f //x=6.375 //y=1.015
c1836 ( 7 0 ) capacitor c=0.148598f //x=6.29 //y=0.175
c1837 ( 6 0 ) capacitor c=0.0302305f //x=1.565 //y=1.015
c1838 ( 2 0 ) capacitor c=0.0710427f //x=1.48 //y=0.175
r1839 (  669 671 ) resistor r=38.7139 //w=0.367 //l=1.11 //layer=li \
 //thickness=0.1 //x=95.21 //y=0.175 //x2=96.32 //y2=0.175
r1840 (  667 669 ) resistor r=38.7139 //w=0.367 //l=1.11 //layer=li \
 //thickness=0.1 //x=94.1 //y=0.175 //x2=95.21 //y2=0.175
r1841 (  665 698 ) resistor r=5.29055 //w=0.35 //l=0.17 //layer=li \
 //thickness=0.1 //x=93.9 //y=0.175 //x2=93.73 //y2=0.175
r1842 (  665 667 ) resistor r=6.97548 //w=0.367 //l=0.2 //layer=li \
 //thickness=0.1 //x=93.9 //y=0.175 //x2=94.1 //y2=0.175
r1843 (  654 656 ) resistor r=38.7139 //w=0.367 //l=1.11 //layer=li \
 //thickness=0.1 //x=91.51 //y=0.175 //x2=92.62 //y2=0.175
r1844 (  652 697 ) resistor r=5.29055 //w=0.35 //l=0.17 //layer=li \
 //thickness=0.1 //x=90.57 //y=0.175 //x2=90.4 //y2=0.175
r1845 (  652 654 ) resistor r=32.7847 //w=0.367 //l=0.94 //layer=li \
 //thickness=0.1 //x=90.57 //y=0.175 //x2=91.51 //y2=0.175
r1846 (  651 698 ) resistor r=5.29055 //w=0.35 //l=0.17 //layer=li \
 //thickness=0.1 //x=93.56 //y=0.175 //x2=93.73 //y2=0.175
r1847 (  651 656 ) resistor r=32.7847 //w=0.367 //l=0.94 //layer=li \
 //thickness=0.1 //x=93.56 //y=0.175 //x2=92.62 //y2=0.175
r1848 (  641 643 ) resistor r=38.7139 //w=0.367 //l=1.11 //layer=li \
 //thickness=0.1 //x=88.92 //y=0.175 //x2=90.03 //y2=0.175
r1849 (  639 641 ) resistor r=38.7139 //w=0.367 //l=1.11 //layer=li \
 //thickness=0.1 //x=87.81 //y=0.175 //x2=88.92 //y2=0.175
r1850 (  637 696 ) resistor r=5.29055 //w=0.35 //l=0.17 //layer=li \
 //thickness=0.1 //x=87.24 //y=0.175 //x2=87.07 //y2=0.175
r1851 (  637 639 ) resistor r=19.8801 //w=0.367 //l=0.57 //layer=li \
 //thickness=0.1 //x=87.24 //y=0.175 //x2=87.81 //y2=0.175
r1852 (  636 697 ) resistor r=5.29055 //w=0.35 //l=0.17 //layer=li \
 //thickness=0.1 //x=90.23 //y=0.175 //x2=90.4 //y2=0.175
r1853 (  636 643 ) resistor r=6.97548 //w=0.367 //l=0.2 //layer=li \
 //thickness=0.1 //x=90.23 //y=0.175 //x2=90.03 //y2=0.175
r1854 (  626 628 ) resistor r=38.7139 //w=0.367 //l=1.11 //layer=li \
 //thickness=0.1 //x=85.22 //y=0.175 //x2=86.33 //y2=0.175
r1855 (  624 626 ) resistor r=38.7139 //w=0.367 //l=1.11 //layer=li \
 //thickness=0.1 //x=84.11 //y=0.175 //x2=85.22 //y2=0.175
r1856 (  622 624 ) resistor r=38.7139 //w=0.367 //l=1.11 //layer=li \
 //thickness=0.1 //x=83 //y=0.175 //x2=84.11 //y2=0.175
r1857 (  620 695 ) resistor r=5.29055 //w=0.35 //l=0.17 //layer=li \
 //thickness=0.1 //x=82.43 //y=0.175 //x2=82.26 //y2=0.175
r1858 (  620 622 ) resistor r=19.8801 //w=0.367 //l=0.57 //layer=li \
 //thickness=0.1 //x=82.43 //y=0.175 //x2=83 //y2=0.175
r1859 (  619 696 ) resistor r=5.29055 //w=0.35 //l=0.17 //layer=li \
 //thickness=0.1 //x=86.9 //y=0.175 //x2=87.07 //y2=0.175
r1860 (  619 628 ) resistor r=19.8801 //w=0.367 //l=0.57 //layer=li \
 //thickness=0.1 //x=86.9 //y=0.175 //x2=86.33 //y2=0.175
r1861 (  609 611 ) resistor r=38.7139 //w=0.367 //l=1.11 //layer=li \
 //thickness=0.1 //x=80.41 //y=0.175 //x2=81.52 //y2=0.175
r1862 (  607 609 ) resistor r=38.7139 //w=0.367 //l=1.11 //layer=li \
 //thickness=0.1 //x=79.3 //y=0.175 //x2=80.41 //y2=0.175
r1863 (  605 607 ) resistor r=38.7139 //w=0.367 //l=1.11 //layer=li \
 //thickness=0.1 //x=78.19 //y=0.175 //x2=79.3 //y2=0.175
r1864 (  603 694 ) resistor r=5.29055 //w=0.35 //l=0.17 //layer=li \
 //thickness=0.1 //x=77.62 //y=0.175 //x2=77.45 //y2=0.175
r1865 (  603 605 ) resistor r=19.8801 //w=0.367 //l=0.57 //layer=li \
 //thickness=0.1 //x=77.62 //y=0.175 //x2=78.19 //y2=0.175
r1866 (  602 695 ) resistor r=5.29055 //w=0.35 //l=0.17 //layer=li \
 //thickness=0.1 //x=82.09 //y=0.175 //x2=82.26 //y2=0.175
r1867 (  602 611 ) resistor r=19.8801 //w=0.367 //l=0.57 //layer=li \
 //thickness=0.1 //x=82.09 //y=0.175 //x2=81.52 //y2=0.175
r1868 (  592 594 ) resistor r=38.7139 //w=0.367 //l=1.11 //layer=li \
 //thickness=0.1 //x=75.6 //y=0.175 //x2=76.71 //y2=0.175
r1869 (  590 592 ) resistor r=38.7139 //w=0.367 //l=1.11 //layer=li \
 //thickness=0.1 //x=74.49 //y=0.175 //x2=75.6 //y2=0.175
r1870 (  588 590 ) resistor r=38.7139 //w=0.367 //l=1.11 //layer=li \
 //thickness=0.1 //x=73.38 //y=0.175 //x2=74.49 //y2=0.175
r1871 (  586 693 ) resistor r=5.29055 //w=0.35 //l=0.17 //layer=li \
 //thickness=0.1 //x=72.81 //y=0.175 //x2=72.64 //y2=0.175
r1872 (  586 588 ) resistor r=19.8801 //w=0.367 //l=0.57 //layer=li \
 //thickness=0.1 //x=72.81 //y=0.175 //x2=73.38 //y2=0.175
r1873 (  585 694 ) resistor r=5.29055 //w=0.35 //l=0.17 //layer=li \
 //thickness=0.1 //x=77.28 //y=0.175 //x2=77.45 //y2=0.175
r1874 (  585 594 ) resistor r=19.8801 //w=0.367 //l=0.57 //layer=li \
 //thickness=0.1 //x=77.28 //y=0.175 //x2=76.71 //y2=0.175
r1875 (  575 577 ) resistor r=38.7139 //w=0.367 //l=1.11 //layer=li \
 //thickness=0.1 //x=70.79 //y=0.175 //x2=71.9 //y2=0.175
r1876 (  573 575 ) resistor r=38.7139 //w=0.367 //l=1.11 //layer=li \
 //thickness=0.1 //x=69.68 //y=0.175 //x2=70.79 //y2=0.175
r1877 (  571 573 ) resistor r=38.7139 //w=0.367 //l=1.11 //layer=li \
 //thickness=0.1 //x=68.57 //y=0.175 //x2=69.68 //y2=0.175
r1878 (  569 692 ) resistor r=5.29055 //w=0.35 //l=0.17 //layer=li \
 //thickness=0.1 //x=68 //y=0.175 //x2=67.83 //y2=0.175
r1879 (  569 571 ) resistor r=19.8801 //w=0.367 //l=0.57 //layer=li \
 //thickness=0.1 //x=68 //y=0.175 //x2=68.57 //y2=0.175
r1880 (  568 693 ) resistor r=5.29055 //w=0.35 //l=0.17 //layer=li \
 //thickness=0.1 //x=72.47 //y=0.175 //x2=72.64 //y2=0.175
r1881 (  568 577 ) resistor r=19.8801 //w=0.367 //l=0.57 //layer=li \
 //thickness=0.1 //x=72.47 //y=0.175 //x2=71.9 //y2=0.175
r1882 (  558 560 ) resistor r=38.7139 //w=0.367 //l=1.11 //layer=li \
 //thickness=0.1 //x=65.98 //y=0.175 //x2=67.09 //y2=0.175
r1883 (  556 558 ) resistor r=38.7139 //w=0.367 //l=1.11 //layer=li \
 //thickness=0.1 //x=64.87 //y=0.175 //x2=65.98 //y2=0.175
r1884 (  554 556 ) resistor r=38.7139 //w=0.367 //l=1.11 //layer=li \
 //thickness=0.1 //x=63.76 //y=0.175 //x2=64.87 //y2=0.175
r1885 (  552 691 ) resistor r=5.29055 //w=0.35 //l=0.17 //layer=li \
 //thickness=0.1 //x=63.19 //y=0.175 //x2=63.02 //y2=0.175
r1886 (  552 554 ) resistor r=19.8801 //w=0.367 //l=0.57 //layer=li \
 //thickness=0.1 //x=63.19 //y=0.175 //x2=63.76 //y2=0.175
r1887 (  551 692 ) resistor r=5.29055 //w=0.35 //l=0.17 //layer=li \
 //thickness=0.1 //x=67.66 //y=0.175 //x2=67.83 //y2=0.175
r1888 (  551 560 ) resistor r=19.8801 //w=0.367 //l=0.57 //layer=li \
 //thickness=0.1 //x=67.66 //y=0.175 //x2=67.09 //y2=0.175
r1889 (  541 543 ) resistor r=38.7139 //w=0.367 //l=1.11 //layer=li \
 //thickness=0.1 //x=61.17 //y=0.175 //x2=62.28 //y2=0.175
r1890 (  539 541 ) resistor r=38.7139 //w=0.367 //l=1.11 //layer=li \
 //thickness=0.1 //x=60.06 //y=0.175 //x2=61.17 //y2=0.175
r1891 (  537 539 ) resistor r=38.7139 //w=0.367 //l=1.11 //layer=li \
 //thickness=0.1 //x=58.95 //y=0.175 //x2=60.06 //y2=0.175
r1892 (  535 690 ) resistor r=5.29055 //w=0.35 //l=0.17 //layer=li \
 //thickness=0.1 //x=58.38 //y=0.175 //x2=58.21 //y2=0.175
r1893 (  535 537 ) resistor r=19.8801 //w=0.367 //l=0.57 //layer=li \
 //thickness=0.1 //x=58.38 //y=0.175 //x2=58.95 //y2=0.175
r1894 (  534 691 ) resistor r=5.29055 //w=0.35 //l=0.17 //layer=li \
 //thickness=0.1 //x=62.85 //y=0.175 //x2=63.02 //y2=0.175
r1895 (  534 543 ) resistor r=19.8801 //w=0.367 //l=0.57 //layer=li \
 //thickness=0.1 //x=62.85 //y=0.175 //x2=62.28 //y2=0.175
r1896 (  524 526 ) resistor r=38.7139 //w=0.367 //l=1.11 //layer=li \
 //thickness=0.1 //x=56.36 //y=0.175 //x2=57.47 //y2=0.175
r1897 (  522 524 ) resistor r=38.7139 //w=0.367 //l=1.11 //layer=li \
 //thickness=0.1 //x=55.25 //y=0.175 //x2=56.36 //y2=0.175
r1898 (  520 522 ) resistor r=38.7139 //w=0.367 //l=1.11 //layer=li \
 //thickness=0.1 //x=54.14 //y=0.175 //x2=55.25 //y2=0.175
r1899 (  518 689 ) resistor r=5.29055 //w=0.35 //l=0.17 //layer=li \
 //thickness=0.1 //x=53.57 //y=0.175 //x2=53.4 //y2=0.175
r1900 (  518 520 ) resistor r=19.8801 //w=0.367 //l=0.57 //layer=li \
 //thickness=0.1 //x=53.57 //y=0.175 //x2=54.14 //y2=0.175
r1901 (  517 690 ) resistor r=5.29055 //w=0.35 //l=0.17 //layer=li \
 //thickness=0.1 //x=58.04 //y=0.175 //x2=58.21 //y2=0.175
r1902 (  517 526 ) resistor r=19.8801 //w=0.367 //l=0.57 //layer=li \
 //thickness=0.1 //x=58.04 //y=0.175 //x2=57.47 //y2=0.175
r1903 (  507 509 ) resistor r=38.7139 //w=0.367 //l=1.11 //layer=li \
 //thickness=0.1 //x=51.55 //y=0.175 //x2=52.66 //y2=0.175
r1904 (  505 507 ) resistor r=38.7139 //w=0.367 //l=1.11 //layer=li \
 //thickness=0.1 //x=50.44 //y=0.175 //x2=51.55 //y2=0.175
r1905 (  503 505 ) resistor r=38.7139 //w=0.367 //l=1.11 //layer=li \
 //thickness=0.1 //x=49.33 //y=0.175 //x2=50.44 //y2=0.175
r1906 (  501 688 ) resistor r=5.29055 //w=0.35 //l=0.17 //layer=li \
 //thickness=0.1 //x=48.76 //y=0.175 //x2=48.59 //y2=0.175
r1907 (  501 503 ) resistor r=19.8801 //w=0.367 //l=0.57 //layer=li \
 //thickness=0.1 //x=48.76 //y=0.175 //x2=49.33 //y2=0.175
r1908 (  500 689 ) resistor r=5.29055 //w=0.35 //l=0.17 //layer=li \
 //thickness=0.1 //x=53.23 //y=0.175 //x2=53.4 //y2=0.175
r1909 (  500 509 ) resistor r=19.8801 //w=0.367 //l=0.57 //layer=li \
 //thickness=0.1 //x=53.23 //y=0.175 //x2=52.66 //y2=0.175
r1910 (  490 492 ) resistor r=38.7139 //w=0.367 //l=1.11 //layer=li \
 //thickness=0.1 //x=46.74 //y=0.175 //x2=47.85 //y2=0.175
r1911 (  488 490 ) resistor r=38.7139 //w=0.367 //l=1.11 //layer=li \
 //thickness=0.1 //x=45.63 //y=0.175 //x2=46.74 //y2=0.175
r1912 (  486 488 ) resistor r=38.7139 //w=0.367 //l=1.11 //layer=li \
 //thickness=0.1 //x=44.52 //y=0.175 //x2=45.63 //y2=0.175
r1913 (  484 687 ) resistor r=5.29055 //w=0.35 //l=0.17 //layer=li \
 //thickness=0.1 //x=43.95 //y=0.175 //x2=43.78 //y2=0.175
r1914 (  484 486 ) resistor r=19.8801 //w=0.367 //l=0.57 //layer=li \
 //thickness=0.1 //x=43.95 //y=0.175 //x2=44.52 //y2=0.175
r1915 (  483 688 ) resistor r=5.29055 //w=0.35 //l=0.17 //layer=li \
 //thickness=0.1 //x=48.42 //y=0.175 //x2=48.59 //y2=0.175
r1916 (  483 492 ) resistor r=19.8801 //w=0.367 //l=0.57 //layer=li \
 //thickness=0.1 //x=48.42 //y=0.175 //x2=47.85 //y2=0.175
r1917 (  473 475 ) resistor r=38.7139 //w=0.367 //l=1.11 //layer=li \
 //thickness=0.1 //x=41.93 //y=0.175 //x2=43.04 //y2=0.175
r1918 (  471 473 ) resistor r=38.7139 //w=0.367 //l=1.11 //layer=li \
 //thickness=0.1 //x=40.82 //y=0.175 //x2=41.93 //y2=0.175
r1919 (  469 471 ) resistor r=38.7139 //w=0.367 //l=1.11 //layer=li \
 //thickness=0.1 //x=39.71 //y=0.175 //x2=40.82 //y2=0.175
r1920 (  467 686 ) resistor r=5.29055 //w=0.35 //l=0.17 //layer=li \
 //thickness=0.1 //x=39.14 //y=0.175 //x2=38.97 //y2=0.175
r1921 (  467 469 ) resistor r=19.8801 //w=0.367 //l=0.57 //layer=li \
 //thickness=0.1 //x=39.14 //y=0.175 //x2=39.71 //y2=0.175
r1922 (  466 687 ) resistor r=5.29055 //w=0.35 //l=0.17 //layer=li \
 //thickness=0.1 //x=43.61 //y=0.175 //x2=43.78 //y2=0.175
r1923 (  466 475 ) resistor r=19.8801 //w=0.367 //l=0.57 //layer=li \
 //thickness=0.1 //x=43.61 //y=0.175 //x2=43.04 //y2=0.175
r1924 (  456 458 ) resistor r=38.7139 //w=0.367 //l=1.11 //layer=li \
 //thickness=0.1 //x=37.12 //y=0.175 //x2=38.23 //y2=0.175
r1925 (  454 456 ) resistor r=38.7139 //w=0.367 //l=1.11 //layer=li \
 //thickness=0.1 //x=36.01 //y=0.175 //x2=37.12 //y2=0.175
r1926 (  452 454 ) resistor r=38.7139 //w=0.367 //l=1.11 //layer=li \
 //thickness=0.1 //x=34.9 //y=0.175 //x2=36.01 //y2=0.175
r1927 (  450 685 ) resistor r=5.29055 //w=0.35 //l=0.17 //layer=li \
 //thickness=0.1 //x=34.33 //y=0.175 //x2=34.16 //y2=0.175
r1928 (  450 452 ) resistor r=19.8801 //w=0.367 //l=0.57 //layer=li \
 //thickness=0.1 //x=34.33 //y=0.175 //x2=34.9 //y2=0.175
r1929 (  449 686 ) resistor r=5.29055 //w=0.35 //l=0.17 //layer=li \
 //thickness=0.1 //x=38.8 //y=0.175 //x2=38.97 //y2=0.175
r1930 (  449 458 ) resistor r=19.8801 //w=0.367 //l=0.57 //layer=li \
 //thickness=0.1 //x=38.8 //y=0.175 //x2=38.23 //y2=0.175
r1931 (  439 441 ) resistor r=38.7139 //w=0.367 //l=1.11 //layer=li \
 //thickness=0.1 //x=32.31 //y=0.175 //x2=33.42 //y2=0.175
r1932 (  437 439 ) resistor r=38.7139 //w=0.367 //l=1.11 //layer=li \
 //thickness=0.1 //x=31.2 //y=0.175 //x2=32.31 //y2=0.175
r1933 (  435 437 ) resistor r=38.7139 //w=0.367 //l=1.11 //layer=li \
 //thickness=0.1 //x=30.09 //y=0.175 //x2=31.2 //y2=0.175
r1934 (  433 684 ) resistor r=5.29055 //w=0.35 //l=0.17 //layer=li \
 //thickness=0.1 //x=29.52 //y=0.175 //x2=29.35 //y2=0.175
r1935 (  433 435 ) resistor r=19.8801 //w=0.367 //l=0.57 //layer=li \
 //thickness=0.1 //x=29.52 //y=0.175 //x2=30.09 //y2=0.175
r1936 (  432 685 ) resistor r=5.29055 //w=0.35 //l=0.17 //layer=li \
 //thickness=0.1 //x=33.99 //y=0.175 //x2=34.16 //y2=0.175
r1937 (  432 441 ) resistor r=19.8801 //w=0.367 //l=0.57 //layer=li \
 //thickness=0.1 //x=33.99 //y=0.175 //x2=33.42 //y2=0.175
r1938 (  422 424 ) resistor r=38.7139 //w=0.367 //l=1.11 //layer=li \
 //thickness=0.1 //x=27.5 //y=0.175 //x2=28.61 //y2=0.175
r1939 (  420 422 ) resistor r=38.7139 //w=0.367 //l=1.11 //layer=li \
 //thickness=0.1 //x=26.39 //y=0.175 //x2=27.5 //y2=0.175
r1940 (  418 420 ) resistor r=38.7139 //w=0.367 //l=1.11 //layer=li \
 //thickness=0.1 //x=25.28 //y=0.175 //x2=26.39 //y2=0.175
r1941 (  416 683 ) resistor r=5.29055 //w=0.35 //l=0.17 //layer=li \
 //thickness=0.1 //x=24.71 //y=0.175 //x2=24.54 //y2=0.175
r1942 (  416 418 ) resistor r=19.8801 //w=0.367 //l=0.57 //layer=li \
 //thickness=0.1 //x=24.71 //y=0.175 //x2=25.28 //y2=0.175
r1943 (  415 684 ) resistor r=5.29055 //w=0.35 //l=0.17 //layer=li \
 //thickness=0.1 //x=29.18 //y=0.175 //x2=29.35 //y2=0.175
r1944 (  415 424 ) resistor r=19.8801 //w=0.367 //l=0.57 //layer=li \
 //thickness=0.1 //x=29.18 //y=0.175 //x2=28.61 //y2=0.175
r1945 (  405 407 ) resistor r=38.7139 //w=0.367 //l=1.11 //layer=li \
 //thickness=0.1 //x=22.69 //y=0.175 //x2=23.8 //y2=0.175
r1946 (  403 405 ) resistor r=38.7139 //w=0.367 //l=1.11 //layer=li \
 //thickness=0.1 //x=21.58 //y=0.175 //x2=22.69 //y2=0.175
r1947 (  401 403 ) resistor r=38.7139 //w=0.367 //l=1.11 //layer=li \
 //thickness=0.1 //x=20.47 //y=0.175 //x2=21.58 //y2=0.175
r1948 (  399 682 ) resistor r=5.29055 //w=0.35 //l=0.17 //layer=li \
 //thickness=0.1 //x=19.9 //y=0.175 //x2=19.73 //y2=0.175
r1949 (  399 401 ) resistor r=19.8801 //w=0.367 //l=0.57 //layer=li \
 //thickness=0.1 //x=19.9 //y=0.175 //x2=20.47 //y2=0.175
r1950 (  398 683 ) resistor r=5.29055 //w=0.35 //l=0.17 //layer=li \
 //thickness=0.1 //x=24.37 //y=0.175 //x2=24.54 //y2=0.175
r1951 (  398 407 ) resistor r=19.8801 //w=0.367 //l=0.57 //layer=li \
 //thickness=0.1 //x=24.37 //y=0.175 //x2=23.8 //y2=0.175
r1952 (  388 390 ) resistor r=38.7139 //w=0.367 //l=1.11 //layer=li \
 //thickness=0.1 //x=17.88 //y=0.175 //x2=18.99 //y2=0.175
r1953 (  386 388 ) resistor r=38.7139 //w=0.367 //l=1.11 //layer=li \
 //thickness=0.1 //x=16.77 //y=0.175 //x2=17.88 //y2=0.175
r1954 (  384 386 ) resistor r=38.7139 //w=0.367 //l=1.11 //layer=li \
 //thickness=0.1 //x=15.66 //y=0.175 //x2=16.77 //y2=0.175
r1955 (  382 681 ) resistor r=5.29055 //w=0.35 //l=0.17 //layer=li \
 //thickness=0.1 //x=15.09 //y=0.175 //x2=14.92 //y2=0.175
r1956 (  382 384 ) resistor r=19.8801 //w=0.367 //l=0.57 //layer=li \
 //thickness=0.1 //x=15.09 //y=0.175 //x2=15.66 //y2=0.175
r1957 (  381 682 ) resistor r=5.29055 //w=0.35 //l=0.17 //layer=li \
 //thickness=0.1 //x=19.56 //y=0.175 //x2=19.73 //y2=0.175
r1958 (  381 390 ) resistor r=19.8801 //w=0.367 //l=0.57 //layer=li \
 //thickness=0.1 //x=19.56 //y=0.175 //x2=18.99 //y2=0.175
r1959 (  371 373 ) resistor r=38.7139 //w=0.367 //l=1.11 //layer=li \
 //thickness=0.1 //x=13.07 //y=0.175 //x2=14.18 //y2=0.175
r1960 (  369 371 ) resistor r=38.7139 //w=0.367 //l=1.11 //layer=li \
 //thickness=0.1 //x=11.96 //y=0.175 //x2=13.07 //y2=0.175
r1961 (  367 369 ) resistor r=38.7139 //w=0.367 //l=1.11 //layer=li \
 //thickness=0.1 //x=10.85 //y=0.175 //x2=11.96 //y2=0.175
r1962 (  365 680 ) resistor r=5.29055 //w=0.35 //l=0.17 //layer=li \
 //thickness=0.1 //x=10.28 //y=0.175 //x2=10.11 //y2=0.175
r1963 (  365 367 ) resistor r=19.8801 //w=0.367 //l=0.57 //layer=li \
 //thickness=0.1 //x=10.28 //y=0.175 //x2=10.85 //y2=0.175
r1964 (  364 681 ) resistor r=5.29055 //w=0.35 //l=0.17 //layer=li \
 //thickness=0.1 //x=14.75 //y=0.175 //x2=14.92 //y2=0.175
r1965 (  364 373 ) resistor r=19.8801 //w=0.367 //l=0.57 //layer=li \
 //thickness=0.1 //x=14.75 //y=0.175 //x2=14.18 //y2=0.175
r1966 (  354 356 ) resistor r=38.7139 //w=0.367 //l=1.11 //layer=li \
 //thickness=0.1 //x=8.26 //y=0.175 //x2=9.37 //y2=0.175
r1967 (  352 354 ) resistor r=38.7139 //w=0.367 //l=1.11 //layer=li \
 //thickness=0.1 //x=7.15 //y=0.175 //x2=8.26 //y2=0.175
r1968 (  350 352 ) resistor r=38.7139 //w=0.367 //l=1.11 //layer=li \
 //thickness=0.1 //x=6.04 //y=0.175 //x2=7.15 //y2=0.175
r1969 (  348 679 ) resistor r=5.29055 //w=0.35 //l=0.17 //layer=li \
 //thickness=0.1 //x=5.47 //y=0.175 //x2=5.3 //y2=0.175
r1970 (  348 350 ) resistor r=19.8801 //w=0.367 //l=0.57 //layer=li \
 //thickness=0.1 //x=5.47 //y=0.175 //x2=6.04 //y2=0.175
r1971 (  347 680 ) resistor r=5.29055 //w=0.35 //l=0.17 //layer=li \
 //thickness=0.1 //x=9.94 //y=0.175 //x2=10.11 //y2=0.175
r1972 (  347 356 ) resistor r=19.8801 //w=0.367 //l=0.57 //layer=li \
 //thickness=0.1 //x=9.94 //y=0.175 //x2=9.37 //y2=0.175
r1973 (  337 339 ) resistor r=38.7139 //w=0.367 //l=1.11 //layer=li \
 //thickness=0.1 //x=3.45 //y=0.175 //x2=4.56 //y2=0.175
r1974 (  335 337 ) resistor r=38.7139 //w=0.367 //l=1.11 //layer=li \
 //thickness=0.1 //x=2.34 //y=0.175 //x2=3.45 //y2=0.175
r1975 (  333 335 ) resistor r=38.7139 //w=0.367 //l=1.11 //layer=li \
 //thickness=0.1 //x=1.23 //y=0.175 //x2=2.34 //y2=0.175
r1976 (  330 679 ) resistor r=5.29055 //w=0.35 //l=0.17 //layer=li \
 //thickness=0.1 //x=5.13 //y=0.175 //x2=5.3 //y2=0.175
r1977 (  330 339 ) resistor r=19.8801 //w=0.367 //l=0.57 //layer=li \
 //thickness=0.1 //x=5.13 //y=0.175 //x2=4.56 //y2=0.175
r1978 (  327 719 ) resistor r=9.3 //w=0.17 //l=0.17 //layer=mcon //count=1 \
 //x=94.91 //y=1.135 //x2=94.91 //y2=1.135
r1979 (  324 718 ) resistor r=9.3 //w=0.17 //l=0.17 //layer=mcon //count=1 \
 //x=91.58 //y=1.135 //x2=91.58 //y2=1.135
r1980 (  322 654 ) resistor r=3.1 //w=0.17 //l=0.51 //layer=mcon //count=3 \
 //x=91.51 //y=0.18 //x2=91.51 //y2=0.18
r1981 (  320 717 ) resistor r=9.3 //w=0.17 //l=0.17 //layer=mcon //count=1 \
 //x=88.25 //y=1.135 //x2=88.25 //y2=1.135
r1982 (  315 716 ) resistor r=9.3 //w=0.17 //l=0.17 //layer=mcon //count=1 \
 //x=83.335 //y=1.145 //x2=83.335 //y2=1.145
r1983 (  311 715 ) resistor r=9.3 //w=0.17 //l=0.17 //layer=mcon //count=1 \
 //x=78.525 //y=1.145 //x2=78.525 //y2=1.145
r1984 (  307 714 ) resistor r=9.3 //w=0.17 //l=0.17 //layer=mcon //count=1 \
 //x=73.715 //y=1.145 //x2=73.715 //y2=1.145
r1985 (  303 713 ) resistor r=9.3 //w=0.17 //l=0.17 //layer=mcon //count=1 \
 //x=68.905 //y=1.145 //x2=68.905 //y2=1.145
r1986 (  299 712 ) resistor r=9.3 //w=0.17 //l=0.17 //layer=mcon //count=1 \
 //x=64.095 //y=1.145 //x2=64.095 //y2=1.145
r1987 (  295 711 ) resistor r=9.3 //w=0.17 //l=0.17 //layer=mcon //count=1 \
 //x=59.285 //y=1.145 //x2=59.285 //y2=1.145
r1988 (  291 710 ) resistor r=9.3 //w=0.17 //l=0.17 //layer=mcon //count=1 \
 //x=54.475 //y=1.145 //x2=54.475 //y2=1.145
r1989 (  287 709 ) resistor r=9.3 //w=0.17 //l=0.17 //layer=mcon //count=1 \
 //x=49.665 //y=1.145 //x2=49.665 //y2=1.145
r1990 (  283 708 ) resistor r=9.3 //w=0.17 //l=0.17 //layer=mcon //count=1 \
 //x=44.855 //y=1.145 //x2=44.855 //y2=1.145
r1991 (  279 707 ) resistor r=9.3 //w=0.17 //l=0.17 //layer=mcon //count=1 \
 //x=40.045 //y=1.145 //x2=40.045 //y2=1.145
r1992 (  275 706 ) resistor r=9.3 //w=0.17 //l=0.17 //layer=mcon //count=1 \
 //x=35.235 //y=1.145 //x2=35.235 //y2=1.145
r1993 (  271 705 ) resistor r=9.3 //w=0.17 //l=0.17 //layer=mcon //count=1 \
 //x=30.425 //y=1.145 //x2=30.425 //y2=1.145
r1994 (  267 704 ) resistor r=9.3 //w=0.17 //l=0.17 //layer=mcon //count=1 \
 //x=25.615 //y=1.145 //x2=25.615 //y2=1.145
r1995 (  263 703 ) resistor r=9.3 //w=0.17 //l=0.17 //layer=mcon //count=1 \
 //x=20.805 //y=1.145 //x2=20.805 //y2=1.145
r1996 (  259 702 ) resistor r=9.3 //w=0.17 //l=0.17 //layer=mcon //count=1 \
 //x=15.995 //y=1.145 //x2=15.995 //y2=1.145
r1997 (  255 701 ) resistor r=9.3 //w=0.17 //l=0.17 //layer=mcon //count=1 \
 //x=11.185 //y=1.145 //x2=11.185 //y2=1.145
r1998 (  251 700 ) resistor r=9.3 //w=0.17 //l=0.17 //layer=mcon //count=1 \
 //x=6.375 //y=1.145 //x2=6.375 //y2=1.145
r1999 (  247 699 ) resistor r=9.3 //w=0.17 //l=0.17 //layer=mcon //count=1 \
 //x=1.565 //y=1.145 //x2=1.565 //y2=1.145
r2000 (  244 671 ) resistor r=3.1 //w=0.17 //l=0.51 //layer=mcon //count=3 \
 //x=96.32 //y=0.18 //x2=96.32 //y2=0.18
r2001 (  242 669 ) resistor r=3.1 //w=0.17 //l=0.51 //layer=mcon //count=3 \
 //x=95.21 //y=0.18 //x2=95.21 //y2=0.18
r2002 (  242 244 ) resistor r=0.446141 //w=0.311 //l=1.11 //layer=m1 \
 //thickness=0.36 //x=95.21 //y=0.175 //x2=96.32 //y2=0.175
r2003 (  240 325 ) resistor r=0.028033 //w=0.35 //l=0.085 //layer=m1 \
 //thickness=0.36 //x=94.995 //y=0.175 //x2=94.91 //y2=0.175
r2004 (  240 242 ) resistor r=0.0864148 //w=0.311 //l=0.215 //layer=m1 \
 //thickness=0.36 //x=94.995 //y=0.175 //x2=95.21 //y2=0.175
r2005 (  239 327 ) resistor r=0.0703067 //w=0.254 //l=0.11649 //layer=m1 \
 //thickness=0.36 //x=94.91 //y=1.02 //x2=94.907 //y2=1.135
r2006 (  238 325 ) resistor r=0.0413265 //w=0.7 //l=0.175 //layer=m1 \
 //thickness=0.36 //x=94.91 //y=0.35 //x2=94.91 //y2=0.175
r2007 (  238 239 ) resistor r=0.639313 //w=0.131 //l=0.67 //layer=m1 \
 //thickness=0.36 //x=94.91 //y=0.35 //x2=94.91 //y2=1.02
r2008 (  237 667 ) resistor r=3.1 //w=0.17 //l=0.51 //layer=mcon //count=3 \
 //x=94.1 //y=0.18 //x2=94.1 //y2=0.18
r2009 (  235 656 ) resistor r=3.1 //w=0.17 //l=0.51 //layer=mcon //count=3 \
 //x=92.62 //y=0.18 //x2=92.62 //y2=0.18
r2010 (  235 237 ) resistor r=0.594855 //w=0.311 //l=1.48 //layer=m1 \
 //thickness=0.36 //x=92.62 //y=0.175 //x2=94.1 //y2=0.175
r2011 (  233 322 ) resistor r=0.028033 //w=0.35 //l=0.085 //layer=m1 \
 //thickness=0.36 //x=91.665 //y=0.175 //x2=91.58 //y2=0.175
r2012 (  233 235 ) resistor r=0.383842 //w=0.311 //l=0.955 //layer=m1 \
 //thickness=0.36 //x=91.665 //y=0.175 //x2=92.62 //y2=0.175
r2013 (  232 325 ) resistor r=0.028033 //w=0.35 //l=0.085 //layer=m1 \
 //thickness=0.36 //x=94.825 //y=0.175 //x2=94.91 //y2=0.175
r2014 (  232 237 ) resistor r=0.291399 //w=0.311 //l=0.725 //layer=m1 \
 //thickness=0.36 //x=94.825 //y=0.175 //x2=94.1 //y2=0.175
r2015 (  231 324 ) resistor r=0.0727059 //w=0.257 //l=0.121491 //layer=m1 \
 //thickness=0.36 //x=91.58 //y=1.015 //x2=91.577 //y2=1.135
r2016 (  230 322 ) resistor r=0.0413265 //w=0.7 //l=0.175 //layer=m1 \
 //thickness=0.36 //x=91.58 //y=0.35 //x2=91.58 //y2=0.175
r2017 (  230 231 ) resistor r=0.634542 //w=0.131 //l=0.665 //layer=m1 \
 //thickness=0.36 //x=91.58 //y=0.35 //x2=91.58 //y2=1.015
r2018 (  229 643 ) resistor r=3.1 //w=0.17 //l=0.51 //layer=mcon //count=3 \
 //x=90.03 //y=0.18 //x2=90.03 //y2=0.18
r2019 (  227 641 ) resistor r=3.1 //w=0.17 //l=0.51 //layer=mcon //count=3 \
 //x=88.92 //y=0.18 //x2=88.92 //y2=0.18
r2020 (  227 229 ) resistor r=0.446141 //w=0.311 //l=1.11 //layer=m1 \
 //thickness=0.36 //x=88.92 //y=0.175 //x2=90.03 //y2=0.175
r2021 (  225 318 ) resistor r=0.028033 //w=0.35 //l=0.085 //layer=m1 \
 //thickness=0.36 //x=88.335 //y=0.175 //x2=88.25 //y2=0.175
r2022 (  225 227 ) resistor r=0.235129 //w=0.311 //l=0.585 //layer=m1 \
 //thickness=0.36 //x=88.335 //y=0.175 //x2=88.92 //y2=0.175
r2023 (  224 322 ) resistor r=0.028033 //w=0.35 //l=0.085 //layer=m1 \
 //thickness=0.36 //x=91.495 //y=0.175 //x2=91.58 //y2=0.175
r2024 (  224 229 ) resistor r=0.588826 //w=0.311 //l=1.465 //layer=m1 \
 //thickness=0.36 //x=91.495 //y=0.175 //x2=90.03 //y2=0.175
r2025 (  223 320 ) resistor r=0.0729089 //w=0.249 //l=0.120996 //layer=m1 \
 //thickness=0.36 //x=88.25 //y=1.015 //x2=88.252 //y2=1.135
r2026 (  222 318 ) resistor r=0.0413265 //w=0.7 //l=0.175 //layer=m1 \
 //thickness=0.36 //x=88.25 //y=0.35 //x2=88.25 //y2=0.175
r2027 (  222 223 ) resistor r=0.634542 //w=0.131 //l=0.665 //layer=m1 \
 //thickness=0.36 //x=88.25 //y=0.35 //x2=88.25 //y2=1.015
r2028 (  221 639 ) resistor r=3.1 //w=0.17 //l=0.51 //layer=mcon //count=3 \
 //x=87.81 //y=0.18 //x2=87.81 //y2=0.18
r2029 (  219 628 ) resistor r=3.1 //w=0.17 //l=0.51 //layer=mcon //count=3 \
 //x=86.33 //y=0.18 //x2=86.33 //y2=0.18
r2030 (  219 221 ) resistor r=0.594855 //w=0.311 //l=1.48 //layer=m1 \
 //thickness=0.36 //x=86.33 //y=0.175 //x2=87.81 //y2=0.175
r2031 (  217 626 ) resistor r=3.1 //w=0.17 //l=0.51 //layer=mcon //count=3 \
 //x=85.22 //y=0.18 //x2=85.22 //y2=0.18
r2032 (  217 219 ) resistor r=0.446141 //w=0.311 //l=1.11 //layer=m1 \
 //thickness=0.36 //x=85.22 //y=0.175 //x2=86.33 //y2=0.175
r2033 (  215 624 ) resistor r=3.1 //w=0.17 //l=0.51 //layer=mcon //count=3 \
 //x=84.11 //y=0.18 //x2=84.11 //y2=0.18
r2034 (  215 217 ) resistor r=0.446141 //w=0.311 //l=1.11 //layer=m1 \
 //thickness=0.36 //x=84.11 //y=0.175 //x2=85.22 //y2=0.175
r2035 (  213 317 ) resistor r=0.028033 //w=0.35 //l=0.085 //layer=m1 \
 //thickness=0.36 //x=83.42 //y=0.175 //x2=83.335 //y2=0.175
r2036 (  213 215 ) resistor r=0.277331 //w=0.311 //l=0.69 //layer=m1 \
 //thickness=0.36 //x=83.42 //y=0.175 //x2=84.11 //y2=0.175
r2037 (  212 318 ) resistor r=0.028033 //w=0.35 //l=0.085 //layer=m1 \
 //thickness=0.36 //x=88.165 //y=0.175 //x2=88.25 //y2=0.175
r2038 (  212 221 ) resistor r=0.142685 //w=0.311 //l=0.355 //layer=m1 \
 //thickness=0.36 //x=88.165 //y=0.175 //x2=87.81 //y2=0.175
r2039 (  211 315 ) resistor r=0.0942778 //w=0.221 //l=0.13 //layer=m1 \
 //thickness=0.36 //x=83.335 //y=1.015 //x2=83.335 //y2=1.145
r2040 (  210 317 ) resistor r=0.0413265 //w=0.7 //l=0.175 //layer=m1 \
 //thickness=0.36 //x=83.335 //y=0.35 //x2=83.335 //y2=0.175
r2041 (  210 211 ) resistor r=0.634542 //w=0.131 //l=0.665 //layer=m1 \
 //thickness=0.36 //x=83.335 //y=0.35 //x2=83.335 //y2=1.015
r2042 (  209 622 ) resistor r=3.1 //w=0.17 //l=0.51 //layer=mcon //count=3 \
 //x=83 //y=0.18 //x2=83 //y2=0.18
r2043 (  207 611 ) resistor r=3.1 //w=0.17 //l=0.51 //layer=mcon //count=3 \
 //x=81.52 //y=0.18 //x2=81.52 //y2=0.18
r2044 (  207 209 ) resistor r=0.594855 //w=0.311 //l=1.48 //layer=m1 \
 //thickness=0.36 //x=81.52 //y=0.175 //x2=83 //y2=0.175
r2045 (  205 609 ) resistor r=3.1 //w=0.17 //l=0.51 //layer=mcon //count=3 \
 //x=80.41 //y=0.18 //x2=80.41 //y2=0.18
r2046 (  205 207 ) resistor r=0.446141 //w=0.311 //l=1.11 //layer=m1 \
 //thickness=0.36 //x=80.41 //y=0.175 //x2=81.52 //y2=0.175
r2047 (  203 607 ) resistor r=3.1 //w=0.17 //l=0.51 //layer=mcon //count=3 \
 //x=79.3 //y=0.18 //x2=79.3 //y2=0.18
r2048 (  203 205 ) resistor r=0.446141 //w=0.311 //l=1.11 //layer=m1 \
 //thickness=0.36 //x=79.3 //y=0.175 //x2=80.41 //y2=0.175
r2049 (  201 313 ) resistor r=0.028033 //w=0.35 //l=0.085 //layer=m1 \
 //thickness=0.36 //x=78.61 //y=0.175 //x2=78.525 //y2=0.175
r2050 (  201 203 ) resistor r=0.277331 //w=0.311 //l=0.69 //layer=m1 \
 //thickness=0.36 //x=78.61 //y=0.175 //x2=79.3 //y2=0.175
r2051 (  200 317 ) resistor r=0.028033 //w=0.35 //l=0.085 //layer=m1 \
 //thickness=0.36 //x=83.25 //y=0.175 //x2=83.335 //y2=0.175
r2052 (  200 209 ) resistor r=0.100482 //w=0.311 //l=0.25 //layer=m1 \
 //thickness=0.36 //x=83.25 //y=0.175 //x2=83 //y2=0.175
r2053 (  199 311 ) resistor r=0.0942778 //w=0.221 //l=0.13 //layer=m1 \
 //thickness=0.36 //x=78.525 //y=1.015 //x2=78.525 //y2=1.145
r2054 (  198 313 ) resistor r=0.0413265 //w=0.7 //l=0.175 //layer=m1 \
 //thickness=0.36 //x=78.525 //y=0.35 //x2=78.525 //y2=0.175
r2055 (  198 199 ) resistor r=0.634542 //w=0.131 //l=0.665 //layer=m1 \
 //thickness=0.36 //x=78.525 //y=0.35 //x2=78.525 //y2=1.015
r2056 (  197 605 ) resistor r=3.1 //w=0.17 //l=0.51 //layer=mcon //count=3 \
 //x=78.19 //y=0.18 //x2=78.19 //y2=0.18
r2057 (  195 594 ) resistor r=3.1 //w=0.17 //l=0.51 //layer=mcon //count=3 \
 //x=76.71 //y=0.18 //x2=76.71 //y2=0.18
r2058 (  195 197 ) resistor r=0.594855 //w=0.311 //l=1.48 //layer=m1 \
 //thickness=0.36 //x=76.71 //y=0.175 //x2=78.19 //y2=0.175
r2059 (  193 592 ) resistor r=3.1 //w=0.17 //l=0.51 //layer=mcon //count=3 \
 //x=75.6 //y=0.18 //x2=75.6 //y2=0.18
r2060 (  193 195 ) resistor r=0.446141 //w=0.311 //l=1.11 //layer=m1 \
 //thickness=0.36 //x=75.6 //y=0.175 //x2=76.71 //y2=0.175
r2061 (  191 590 ) resistor r=3.1 //w=0.17 //l=0.51 //layer=mcon //count=3 \
 //x=74.49 //y=0.18 //x2=74.49 //y2=0.18
r2062 (  191 193 ) resistor r=0.446141 //w=0.311 //l=1.11 //layer=m1 \
 //thickness=0.36 //x=74.49 //y=0.175 //x2=75.6 //y2=0.175
r2063 (  189 309 ) resistor r=0.028033 //w=0.35 //l=0.085 //layer=m1 \
 //thickness=0.36 //x=73.8 //y=0.175 //x2=73.715 //y2=0.175
r2064 (  189 191 ) resistor r=0.277331 //w=0.311 //l=0.69 //layer=m1 \
 //thickness=0.36 //x=73.8 //y=0.175 //x2=74.49 //y2=0.175
r2065 (  188 313 ) resistor r=0.028033 //w=0.35 //l=0.085 //layer=m1 \
 //thickness=0.36 //x=78.44 //y=0.175 //x2=78.525 //y2=0.175
r2066 (  188 197 ) resistor r=0.100482 //w=0.311 //l=0.25 //layer=m1 \
 //thickness=0.36 //x=78.44 //y=0.175 //x2=78.19 //y2=0.175
r2067 (  187 307 ) resistor r=0.0942778 //w=0.221 //l=0.13 //layer=m1 \
 //thickness=0.36 //x=73.715 //y=1.015 //x2=73.715 //y2=1.145
r2068 (  186 309 ) resistor r=0.0413265 //w=0.7 //l=0.175 //layer=m1 \
 //thickness=0.36 //x=73.715 //y=0.35 //x2=73.715 //y2=0.175
r2069 (  186 187 ) resistor r=0.634542 //w=0.131 //l=0.665 //layer=m1 \
 //thickness=0.36 //x=73.715 //y=0.35 //x2=73.715 //y2=1.015
r2070 (  185 588 ) resistor r=3.1 //w=0.17 //l=0.51 //layer=mcon //count=3 \
 //x=73.38 //y=0.18 //x2=73.38 //y2=0.18
r2071 (  183 577 ) resistor r=3.1 //w=0.17 //l=0.51 //layer=mcon //count=3 \
 //x=71.9 //y=0.18 //x2=71.9 //y2=0.18
r2072 (  183 185 ) resistor r=0.594855 //w=0.311 //l=1.48 //layer=m1 \
 //thickness=0.36 //x=71.9 //y=0.175 //x2=73.38 //y2=0.175
r2073 (  181 575 ) resistor r=3.1 //w=0.17 //l=0.51 //layer=mcon //count=3 \
 //x=70.79 //y=0.18 //x2=70.79 //y2=0.18
r2074 (  181 183 ) resistor r=0.446141 //w=0.311 //l=1.11 //layer=m1 \
 //thickness=0.36 //x=70.79 //y=0.175 //x2=71.9 //y2=0.175
r2075 (  179 573 ) resistor r=3.1 //w=0.17 //l=0.51 //layer=mcon //count=3 \
 //x=69.68 //y=0.18 //x2=69.68 //y2=0.18
r2076 (  179 181 ) resistor r=0.446141 //w=0.311 //l=1.11 //layer=m1 \
 //thickness=0.36 //x=69.68 //y=0.175 //x2=70.79 //y2=0.175
r2077 (  177 305 ) resistor r=0.028033 //w=0.35 //l=0.085 //layer=m1 \
 //thickness=0.36 //x=68.99 //y=0.175 //x2=68.905 //y2=0.175
r2078 (  177 179 ) resistor r=0.277331 //w=0.311 //l=0.69 //layer=m1 \
 //thickness=0.36 //x=68.99 //y=0.175 //x2=69.68 //y2=0.175
r2079 (  176 309 ) resistor r=0.028033 //w=0.35 //l=0.085 //layer=m1 \
 //thickness=0.36 //x=73.63 //y=0.175 //x2=73.715 //y2=0.175
r2080 (  176 185 ) resistor r=0.100482 //w=0.311 //l=0.25 //layer=m1 \
 //thickness=0.36 //x=73.63 //y=0.175 //x2=73.38 //y2=0.175
r2081 (  175 303 ) resistor r=0.0942778 //w=0.221 //l=0.13 //layer=m1 \
 //thickness=0.36 //x=68.905 //y=1.015 //x2=68.905 //y2=1.145
r2082 (  174 305 ) resistor r=0.0413265 //w=0.7 //l=0.175 //layer=m1 \
 //thickness=0.36 //x=68.905 //y=0.35 //x2=68.905 //y2=0.175
r2083 (  174 175 ) resistor r=0.634542 //w=0.131 //l=0.665 //layer=m1 \
 //thickness=0.36 //x=68.905 //y=0.35 //x2=68.905 //y2=1.015
r2084 (  173 571 ) resistor r=3.1 //w=0.17 //l=0.51 //layer=mcon //count=3 \
 //x=68.57 //y=0.18 //x2=68.57 //y2=0.18
r2085 (  171 560 ) resistor r=3.1 //w=0.17 //l=0.51 //layer=mcon //count=3 \
 //x=67.09 //y=0.18 //x2=67.09 //y2=0.18
r2086 (  171 173 ) resistor r=0.594855 //w=0.311 //l=1.48 //layer=m1 \
 //thickness=0.36 //x=67.09 //y=0.175 //x2=68.57 //y2=0.175
r2087 (  169 558 ) resistor r=3.1 //w=0.17 //l=0.51 //layer=mcon //count=3 \
 //x=65.98 //y=0.18 //x2=65.98 //y2=0.18
r2088 (  169 171 ) resistor r=0.446141 //w=0.311 //l=1.11 //layer=m1 \
 //thickness=0.36 //x=65.98 //y=0.175 //x2=67.09 //y2=0.175
r2089 (  167 556 ) resistor r=3.1 //w=0.17 //l=0.51 //layer=mcon //count=3 \
 //x=64.87 //y=0.18 //x2=64.87 //y2=0.18
r2090 (  167 169 ) resistor r=0.446141 //w=0.311 //l=1.11 //layer=m1 \
 //thickness=0.36 //x=64.87 //y=0.175 //x2=65.98 //y2=0.175
r2091 (  165 301 ) resistor r=0.028033 //w=0.35 //l=0.085 //layer=m1 \
 //thickness=0.36 //x=64.18 //y=0.175 //x2=64.095 //y2=0.175
r2092 (  165 167 ) resistor r=0.277331 //w=0.311 //l=0.69 //layer=m1 \
 //thickness=0.36 //x=64.18 //y=0.175 //x2=64.87 //y2=0.175
r2093 (  164 305 ) resistor r=0.028033 //w=0.35 //l=0.085 //layer=m1 \
 //thickness=0.36 //x=68.82 //y=0.175 //x2=68.905 //y2=0.175
r2094 (  164 173 ) resistor r=0.100482 //w=0.311 //l=0.25 //layer=m1 \
 //thickness=0.36 //x=68.82 //y=0.175 //x2=68.57 //y2=0.175
r2095 (  163 299 ) resistor r=0.0942778 //w=0.221 //l=0.13 //layer=m1 \
 //thickness=0.36 //x=64.095 //y=1.015 //x2=64.095 //y2=1.145
r2096 (  162 301 ) resistor r=0.0413265 //w=0.7 //l=0.175 //layer=m1 \
 //thickness=0.36 //x=64.095 //y=0.35 //x2=64.095 //y2=0.175
r2097 (  162 163 ) resistor r=0.634542 //w=0.131 //l=0.665 //layer=m1 \
 //thickness=0.36 //x=64.095 //y=0.35 //x2=64.095 //y2=1.015
r2098 (  161 554 ) resistor r=3.1 //w=0.17 //l=0.51 //layer=mcon //count=3 \
 //x=63.76 //y=0.18 //x2=63.76 //y2=0.18
r2099 (  159 543 ) resistor r=3.1 //w=0.17 //l=0.51 //layer=mcon //count=3 \
 //x=62.28 //y=0.18 //x2=62.28 //y2=0.18
r2100 (  159 161 ) resistor r=0.594855 //w=0.311 //l=1.48 //layer=m1 \
 //thickness=0.36 //x=62.28 //y=0.175 //x2=63.76 //y2=0.175
r2101 (  157 541 ) resistor r=3.1 //w=0.17 //l=0.51 //layer=mcon //count=3 \
 //x=61.17 //y=0.18 //x2=61.17 //y2=0.18
r2102 (  157 159 ) resistor r=0.446141 //w=0.311 //l=1.11 //layer=m1 \
 //thickness=0.36 //x=61.17 //y=0.175 //x2=62.28 //y2=0.175
r2103 (  155 539 ) resistor r=3.1 //w=0.17 //l=0.51 //layer=mcon //count=3 \
 //x=60.06 //y=0.18 //x2=60.06 //y2=0.18
r2104 (  155 157 ) resistor r=0.446141 //w=0.311 //l=1.11 //layer=m1 \
 //thickness=0.36 //x=60.06 //y=0.175 //x2=61.17 //y2=0.175
r2105 (  153 297 ) resistor r=0.028033 //w=0.35 //l=0.085 //layer=m1 \
 //thickness=0.36 //x=59.37 //y=0.175 //x2=59.285 //y2=0.175
r2106 (  153 155 ) resistor r=0.277331 //w=0.311 //l=0.69 //layer=m1 \
 //thickness=0.36 //x=59.37 //y=0.175 //x2=60.06 //y2=0.175
r2107 (  152 301 ) resistor r=0.028033 //w=0.35 //l=0.085 //layer=m1 \
 //thickness=0.36 //x=64.01 //y=0.175 //x2=64.095 //y2=0.175
r2108 (  152 161 ) resistor r=0.100482 //w=0.311 //l=0.25 //layer=m1 \
 //thickness=0.36 //x=64.01 //y=0.175 //x2=63.76 //y2=0.175
r2109 (  151 295 ) resistor r=0.0942778 //w=0.221 //l=0.13 //layer=m1 \
 //thickness=0.36 //x=59.285 //y=1.015 //x2=59.285 //y2=1.145
r2110 (  150 297 ) resistor r=0.0413265 //w=0.7 //l=0.175 //layer=m1 \
 //thickness=0.36 //x=59.285 //y=0.35 //x2=59.285 //y2=0.175
r2111 (  150 151 ) resistor r=0.634542 //w=0.131 //l=0.665 //layer=m1 \
 //thickness=0.36 //x=59.285 //y=0.35 //x2=59.285 //y2=1.015
r2112 (  149 537 ) resistor r=3.1 //w=0.17 //l=0.51 //layer=mcon //count=3 \
 //x=58.95 //y=0.18 //x2=58.95 //y2=0.18
r2113 (  147 526 ) resistor r=3.1 //w=0.17 //l=0.51 //layer=mcon //count=3 \
 //x=57.47 //y=0.18 //x2=57.47 //y2=0.18
r2114 (  147 149 ) resistor r=0.594855 //w=0.311 //l=1.48 //layer=m1 \
 //thickness=0.36 //x=57.47 //y=0.175 //x2=58.95 //y2=0.175
r2115 (  145 524 ) resistor r=3.1 //w=0.17 //l=0.51 //layer=mcon //count=3 \
 //x=56.36 //y=0.18 //x2=56.36 //y2=0.18
r2116 (  145 147 ) resistor r=0.446141 //w=0.311 //l=1.11 //layer=m1 \
 //thickness=0.36 //x=56.36 //y=0.175 //x2=57.47 //y2=0.175
r2117 (  143 522 ) resistor r=3.1 //w=0.17 //l=0.51 //layer=mcon //count=3 \
 //x=55.25 //y=0.18 //x2=55.25 //y2=0.18
r2118 (  143 145 ) resistor r=0.446141 //w=0.311 //l=1.11 //layer=m1 \
 //thickness=0.36 //x=55.25 //y=0.175 //x2=56.36 //y2=0.175
r2119 (  141 293 ) resistor r=0.028033 //w=0.35 //l=0.085 //layer=m1 \
 //thickness=0.36 //x=54.56 //y=0.175 //x2=54.475 //y2=0.175
r2120 (  141 143 ) resistor r=0.277331 //w=0.311 //l=0.69 //layer=m1 \
 //thickness=0.36 //x=54.56 //y=0.175 //x2=55.25 //y2=0.175
r2121 (  140 297 ) resistor r=0.028033 //w=0.35 //l=0.085 //layer=m1 \
 //thickness=0.36 //x=59.2 //y=0.175 //x2=59.285 //y2=0.175
r2122 (  140 149 ) resistor r=0.100482 //w=0.311 //l=0.25 //layer=m1 \
 //thickness=0.36 //x=59.2 //y=0.175 //x2=58.95 //y2=0.175
r2123 (  139 291 ) resistor r=0.0942778 //w=0.221 //l=0.13 //layer=m1 \
 //thickness=0.36 //x=54.475 //y=1.015 //x2=54.475 //y2=1.145
r2124 (  138 293 ) resistor r=0.0413265 //w=0.7 //l=0.175 //layer=m1 \
 //thickness=0.36 //x=54.475 //y=0.35 //x2=54.475 //y2=0.175
r2125 (  138 139 ) resistor r=0.634542 //w=0.131 //l=0.665 //layer=m1 \
 //thickness=0.36 //x=54.475 //y=0.35 //x2=54.475 //y2=1.015
r2126 (  137 520 ) resistor r=3.1 //w=0.17 //l=0.51 //layer=mcon //count=3 \
 //x=54.14 //y=0.18 //x2=54.14 //y2=0.18
r2127 (  135 509 ) resistor r=3.1 //w=0.17 //l=0.51 //layer=mcon //count=3 \
 //x=52.66 //y=0.18 //x2=52.66 //y2=0.18
r2128 (  135 137 ) resistor r=0.594855 //w=0.311 //l=1.48 //layer=m1 \
 //thickness=0.36 //x=52.66 //y=0.175 //x2=54.14 //y2=0.175
r2129 (  133 507 ) resistor r=3.1 //w=0.17 //l=0.51 //layer=mcon //count=3 \
 //x=51.55 //y=0.18 //x2=51.55 //y2=0.18
r2130 (  133 135 ) resistor r=0.446141 //w=0.311 //l=1.11 //layer=m1 \
 //thickness=0.36 //x=51.55 //y=0.175 //x2=52.66 //y2=0.175
r2131 (  131 505 ) resistor r=3.1 //w=0.17 //l=0.51 //layer=mcon //count=3 \
 //x=50.44 //y=0.18 //x2=50.44 //y2=0.18
r2132 (  131 133 ) resistor r=0.446141 //w=0.311 //l=1.11 //layer=m1 \
 //thickness=0.36 //x=50.44 //y=0.175 //x2=51.55 //y2=0.175
r2133 (  129 289 ) resistor r=0.028033 //w=0.35 //l=0.085 //layer=m1 \
 //thickness=0.36 //x=49.75 //y=0.175 //x2=49.665 //y2=0.175
r2134 (  129 131 ) resistor r=0.277331 //w=0.311 //l=0.69 //layer=m1 \
 //thickness=0.36 //x=49.75 //y=0.175 //x2=50.44 //y2=0.175
r2135 (  128 293 ) resistor r=0.028033 //w=0.35 //l=0.085 //layer=m1 \
 //thickness=0.36 //x=54.39 //y=0.175 //x2=54.475 //y2=0.175
r2136 (  128 137 ) resistor r=0.100482 //w=0.311 //l=0.25 //layer=m1 \
 //thickness=0.36 //x=54.39 //y=0.175 //x2=54.14 //y2=0.175
r2137 (  127 287 ) resistor r=0.0942778 //w=0.221 //l=0.13 //layer=m1 \
 //thickness=0.36 //x=49.665 //y=1.015 //x2=49.665 //y2=1.145
r2138 (  126 289 ) resistor r=0.0413265 //w=0.7 //l=0.175 //layer=m1 \
 //thickness=0.36 //x=49.665 //y=0.35 //x2=49.665 //y2=0.175
r2139 (  126 127 ) resistor r=0.634542 //w=0.131 //l=0.665 //layer=m1 \
 //thickness=0.36 //x=49.665 //y=0.35 //x2=49.665 //y2=1.015
r2140 (  125 503 ) resistor r=3.1 //w=0.17 //l=0.51 //layer=mcon //count=3 \
 //x=49.33 //y=0.18 //x2=49.33 //y2=0.18
r2141 (  122 492 ) resistor r=3.1 //w=0.17 //l=0.51 //layer=mcon //count=3 \
 //x=47.85 //y=0.18 //x2=47.85 //y2=0.18
r2142 (  120 490 ) resistor r=3.1 //w=0.17 //l=0.51 //layer=mcon //count=3 \
 //x=46.74 //y=0.18 //x2=46.74 //y2=0.18
r2143 (  120 122 ) resistor r=0.446141 //w=0.311 //l=1.11 //layer=m1 \
 //thickness=0.36 //x=46.74 //y=0.175 //x2=47.85 //y2=0.175
r2144 (  118 488 ) resistor r=3.1 //w=0.17 //l=0.51 //layer=mcon //count=3 \
 //x=45.63 //y=0.18 //x2=45.63 //y2=0.18
r2145 (  118 120 ) resistor r=0.446141 //w=0.311 //l=1.11 //layer=m1 \
 //thickness=0.36 //x=45.63 //y=0.175 //x2=46.74 //y2=0.175
r2146 (  116 285 ) resistor r=0.028033 //w=0.35 //l=0.085 //layer=m1 \
 //thickness=0.36 //x=44.94 //y=0.175 //x2=44.855 //y2=0.175
r2147 (  116 118 ) resistor r=0.277331 //w=0.311 //l=0.69 //layer=m1 \
 //thickness=0.36 //x=44.94 //y=0.175 //x2=45.63 //y2=0.175
r2148 (  115 289 ) resistor r=0.028033 //w=0.35 //l=0.085 //layer=m1 \
 //thickness=0.36 //x=49.58 //y=0.175 //x2=49.665 //y2=0.175
r2149 (  115 125 ) resistor r=0.100482 //w=0.311 //l=0.25 //layer=m1 \
 //thickness=0.36 //x=49.58 //y=0.175 //x2=49.33 //y2=0.175
r2150 (  114 283 ) resistor r=0.0942778 //w=0.221 //l=0.13 //layer=m1 \
 //thickness=0.36 //x=44.855 //y=1.015 //x2=44.855 //y2=1.145
r2151 (  113 285 ) resistor r=0.0413265 //w=0.7 //l=0.175 //layer=m1 \
 //thickness=0.36 //x=44.855 //y=0.35 //x2=44.855 //y2=0.175
r2152 (  113 114 ) resistor r=0.634542 //w=0.131 //l=0.665 //layer=m1 \
 //thickness=0.36 //x=44.855 //y=0.35 //x2=44.855 //y2=1.015
r2153 (  112 486 ) resistor r=3.1 //w=0.17 //l=0.51 //layer=mcon //count=3 \
 //x=44.52 //y=0.18 //x2=44.52 //y2=0.18
r2154 (  110 475 ) resistor r=3.1 //w=0.17 //l=0.51 //layer=mcon //count=3 \
 //x=43.04 //y=0.18 //x2=43.04 //y2=0.18
r2155 (  110 112 ) resistor r=0.594855 //w=0.311 //l=1.48 //layer=m1 \
 //thickness=0.36 //x=43.04 //y=0.175 //x2=44.52 //y2=0.175
r2156 (  108 473 ) resistor r=3.1 //w=0.17 //l=0.51 //layer=mcon //count=3 \
 //x=41.93 //y=0.18 //x2=41.93 //y2=0.18
r2157 (  108 110 ) resistor r=0.446141 //w=0.311 //l=1.11 //layer=m1 \
 //thickness=0.36 //x=41.93 //y=0.175 //x2=43.04 //y2=0.175
r2158 (  106 471 ) resistor r=3.1 //w=0.17 //l=0.51 //layer=mcon //count=3 \
 //x=40.82 //y=0.18 //x2=40.82 //y2=0.18
r2159 (  106 108 ) resistor r=0.446141 //w=0.311 //l=1.11 //layer=m1 \
 //thickness=0.36 //x=40.82 //y=0.175 //x2=41.93 //y2=0.175
r2160 (  104 281 ) resistor r=0.028033 //w=0.35 //l=0.085 //layer=m1 \
 //thickness=0.36 //x=40.13 //y=0.175 //x2=40.045 //y2=0.175
r2161 (  104 106 ) resistor r=0.277331 //w=0.311 //l=0.69 //layer=m1 \
 //thickness=0.36 //x=40.13 //y=0.175 //x2=40.82 //y2=0.175
r2162 (  103 285 ) resistor r=0.028033 //w=0.35 //l=0.085 //layer=m1 \
 //thickness=0.36 //x=44.77 //y=0.175 //x2=44.855 //y2=0.175
r2163 (  103 112 ) resistor r=0.100482 //w=0.311 //l=0.25 //layer=m1 \
 //thickness=0.36 //x=44.77 //y=0.175 //x2=44.52 //y2=0.175
r2164 (  102 279 ) resistor r=0.0942778 //w=0.221 //l=0.13 //layer=m1 \
 //thickness=0.36 //x=40.045 //y=1.015 //x2=40.045 //y2=1.145
r2165 (  101 281 ) resistor r=0.0413265 //w=0.7 //l=0.175 //layer=m1 \
 //thickness=0.36 //x=40.045 //y=0.35 //x2=40.045 //y2=0.175
r2166 (  101 102 ) resistor r=0.634542 //w=0.131 //l=0.665 //layer=m1 \
 //thickness=0.36 //x=40.045 //y=0.35 //x2=40.045 //y2=1.015
r2167 (  100 469 ) resistor r=3.1 //w=0.17 //l=0.51 //layer=mcon //count=3 \
 //x=39.71 //y=0.18 //x2=39.71 //y2=0.18
r2168 (  98 458 ) resistor r=3.1 //w=0.17 //l=0.51 //layer=mcon //count=3 \
 //x=38.23 //y=0.18 //x2=38.23 //y2=0.18
r2169 (  98 100 ) resistor r=0.594855 //w=0.311 //l=1.48 //layer=m1 \
 //thickness=0.36 //x=38.23 //y=0.175 //x2=39.71 //y2=0.175
r2170 (  96 456 ) resistor r=3.1 //w=0.17 //l=0.51 //layer=mcon //count=3 \
 //x=37.12 //y=0.18 //x2=37.12 //y2=0.18
r2171 (  96 98 ) resistor r=0.446141 //w=0.311 //l=1.11 //layer=m1 \
 //thickness=0.36 //x=37.12 //y=0.175 //x2=38.23 //y2=0.175
r2172 (  94 454 ) resistor r=3.1 //w=0.17 //l=0.51 //layer=mcon //count=3 \
 //x=36.01 //y=0.18 //x2=36.01 //y2=0.18
r2173 (  94 96 ) resistor r=0.446141 //w=0.311 //l=1.11 //layer=m1 \
 //thickness=0.36 //x=36.01 //y=0.175 //x2=37.12 //y2=0.175
r2174 (  92 277 ) resistor r=0.028033 //w=0.35 //l=0.085 //layer=m1 \
 //thickness=0.36 //x=35.32 //y=0.175 //x2=35.235 //y2=0.175
r2175 (  92 94 ) resistor r=0.277331 //w=0.311 //l=0.69 //layer=m1 \
 //thickness=0.36 //x=35.32 //y=0.175 //x2=36.01 //y2=0.175
r2176 (  91 281 ) resistor r=0.028033 //w=0.35 //l=0.085 //layer=m1 \
 //thickness=0.36 //x=39.96 //y=0.175 //x2=40.045 //y2=0.175
r2177 (  91 100 ) resistor r=0.100482 //w=0.311 //l=0.25 //layer=m1 \
 //thickness=0.36 //x=39.96 //y=0.175 //x2=39.71 //y2=0.175
r2178 (  90 275 ) resistor r=0.0942778 //w=0.221 //l=0.13 //layer=m1 \
 //thickness=0.36 //x=35.235 //y=1.015 //x2=35.235 //y2=1.145
r2179 (  89 277 ) resistor r=0.0413265 //w=0.7 //l=0.175 //layer=m1 \
 //thickness=0.36 //x=35.235 //y=0.35 //x2=35.235 //y2=0.175
r2180 (  89 90 ) resistor r=0.634542 //w=0.131 //l=0.665 //layer=m1 \
 //thickness=0.36 //x=35.235 //y=0.35 //x2=35.235 //y2=1.015
r2181 (  88 452 ) resistor r=3.1 //w=0.17 //l=0.51 //layer=mcon //count=3 \
 //x=34.9 //y=0.18 //x2=34.9 //y2=0.18
r2182 (  86 441 ) resistor r=3.1 //w=0.17 //l=0.51 //layer=mcon //count=3 \
 //x=33.42 //y=0.18 //x2=33.42 //y2=0.18
r2183 (  86 88 ) resistor r=0.594855 //w=0.311 //l=1.48 //layer=m1 \
 //thickness=0.36 //x=33.42 //y=0.175 //x2=34.9 //y2=0.175
r2184 (  84 439 ) resistor r=3.1 //w=0.17 //l=0.51 //layer=mcon //count=3 \
 //x=32.31 //y=0.18 //x2=32.31 //y2=0.18
r2185 (  84 86 ) resistor r=0.446141 //w=0.311 //l=1.11 //layer=m1 \
 //thickness=0.36 //x=32.31 //y=0.175 //x2=33.42 //y2=0.175
r2186 (  82 437 ) resistor r=3.1 //w=0.17 //l=0.51 //layer=mcon //count=3 \
 //x=31.2 //y=0.18 //x2=31.2 //y2=0.18
r2187 (  82 84 ) resistor r=0.446141 //w=0.311 //l=1.11 //layer=m1 \
 //thickness=0.36 //x=31.2 //y=0.175 //x2=32.31 //y2=0.175
r2188 (  80 273 ) resistor r=0.028033 //w=0.35 //l=0.085 //layer=m1 \
 //thickness=0.36 //x=30.51 //y=0.175 //x2=30.425 //y2=0.175
r2189 (  80 82 ) resistor r=0.277331 //w=0.311 //l=0.69 //layer=m1 \
 //thickness=0.36 //x=30.51 //y=0.175 //x2=31.2 //y2=0.175
r2190 (  79 277 ) resistor r=0.028033 //w=0.35 //l=0.085 //layer=m1 \
 //thickness=0.36 //x=35.15 //y=0.175 //x2=35.235 //y2=0.175
r2191 (  79 88 ) resistor r=0.100482 //w=0.311 //l=0.25 //layer=m1 \
 //thickness=0.36 //x=35.15 //y=0.175 //x2=34.9 //y2=0.175
r2192 (  78 271 ) resistor r=0.0942778 //w=0.221 //l=0.13 //layer=m1 \
 //thickness=0.36 //x=30.425 //y=1.015 //x2=30.425 //y2=1.145
r2193 (  77 273 ) resistor r=0.0413265 //w=0.7 //l=0.175 //layer=m1 \
 //thickness=0.36 //x=30.425 //y=0.35 //x2=30.425 //y2=0.175
r2194 (  77 78 ) resistor r=0.634542 //w=0.131 //l=0.665 //layer=m1 \
 //thickness=0.36 //x=30.425 //y=0.35 //x2=30.425 //y2=1.015
r2195 (  76 435 ) resistor r=3.1 //w=0.17 //l=0.51 //layer=mcon //count=3 \
 //x=30.09 //y=0.18 //x2=30.09 //y2=0.18
r2196 (  74 424 ) resistor r=3.1 //w=0.17 //l=0.51 //layer=mcon //count=3 \
 //x=28.61 //y=0.18 //x2=28.61 //y2=0.18
r2197 (  74 76 ) resistor r=0.594855 //w=0.311 //l=1.48 //layer=m1 \
 //thickness=0.36 //x=28.61 //y=0.175 //x2=30.09 //y2=0.175
r2198 (  72 422 ) resistor r=3.1 //w=0.17 //l=0.51 //layer=mcon //count=3 \
 //x=27.5 //y=0.18 //x2=27.5 //y2=0.18
r2199 (  72 74 ) resistor r=0.446141 //w=0.311 //l=1.11 //layer=m1 \
 //thickness=0.36 //x=27.5 //y=0.175 //x2=28.61 //y2=0.175
r2200 (  70 420 ) resistor r=3.1 //w=0.17 //l=0.51 //layer=mcon //count=3 \
 //x=26.39 //y=0.18 //x2=26.39 //y2=0.18
r2201 (  70 72 ) resistor r=0.446141 //w=0.311 //l=1.11 //layer=m1 \
 //thickness=0.36 //x=26.39 //y=0.175 //x2=27.5 //y2=0.175
r2202 (  68 269 ) resistor r=0.028033 //w=0.35 //l=0.085 //layer=m1 \
 //thickness=0.36 //x=25.7 //y=0.175 //x2=25.615 //y2=0.175
r2203 (  68 70 ) resistor r=0.277331 //w=0.311 //l=0.69 //layer=m1 \
 //thickness=0.36 //x=25.7 //y=0.175 //x2=26.39 //y2=0.175
r2204 (  67 273 ) resistor r=0.028033 //w=0.35 //l=0.085 //layer=m1 \
 //thickness=0.36 //x=30.34 //y=0.175 //x2=30.425 //y2=0.175
r2205 (  67 76 ) resistor r=0.100482 //w=0.311 //l=0.25 //layer=m1 \
 //thickness=0.36 //x=30.34 //y=0.175 //x2=30.09 //y2=0.175
r2206 (  66 267 ) resistor r=0.0942778 //w=0.221 //l=0.13 //layer=m1 \
 //thickness=0.36 //x=25.615 //y=1.015 //x2=25.615 //y2=1.145
r2207 (  65 269 ) resistor r=0.0413265 //w=0.7 //l=0.175 //layer=m1 \
 //thickness=0.36 //x=25.615 //y=0.35 //x2=25.615 //y2=0.175
r2208 (  65 66 ) resistor r=0.634542 //w=0.131 //l=0.665 //layer=m1 \
 //thickness=0.36 //x=25.615 //y=0.35 //x2=25.615 //y2=1.015
r2209 (  64 418 ) resistor r=3.1 //w=0.17 //l=0.51 //layer=mcon //count=3 \
 //x=25.28 //y=0.18 //x2=25.28 //y2=0.18
r2210 (  62 407 ) resistor r=3.1 //w=0.17 //l=0.51 //layer=mcon //count=3 \
 //x=23.8 //y=0.18 //x2=23.8 //y2=0.18
r2211 (  62 64 ) resistor r=0.594855 //w=0.311 //l=1.48 //layer=m1 \
 //thickness=0.36 //x=23.8 //y=0.175 //x2=25.28 //y2=0.175
r2212 (  60 405 ) resistor r=3.1 //w=0.17 //l=0.51 //layer=mcon //count=3 \
 //x=22.69 //y=0.18 //x2=22.69 //y2=0.18
r2213 (  60 62 ) resistor r=0.446141 //w=0.311 //l=1.11 //layer=m1 \
 //thickness=0.36 //x=22.69 //y=0.175 //x2=23.8 //y2=0.175
r2214 (  58 403 ) resistor r=3.1 //w=0.17 //l=0.51 //layer=mcon //count=3 \
 //x=21.58 //y=0.18 //x2=21.58 //y2=0.18
r2215 (  58 60 ) resistor r=0.446141 //w=0.311 //l=1.11 //layer=m1 \
 //thickness=0.36 //x=21.58 //y=0.175 //x2=22.69 //y2=0.175
r2216 (  56 265 ) resistor r=0.028033 //w=0.35 //l=0.085 //layer=m1 \
 //thickness=0.36 //x=20.89 //y=0.175 //x2=20.805 //y2=0.175
r2217 (  56 58 ) resistor r=0.277331 //w=0.311 //l=0.69 //layer=m1 \
 //thickness=0.36 //x=20.89 //y=0.175 //x2=21.58 //y2=0.175
r2218 (  55 269 ) resistor r=0.028033 //w=0.35 //l=0.085 //layer=m1 \
 //thickness=0.36 //x=25.53 //y=0.175 //x2=25.615 //y2=0.175
r2219 (  55 64 ) resistor r=0.100482 //w=0.311 //l=0.25 //layer=m1 \
 //thickness=0.36 //x=25.53 //y=0.175 //x2=25.28 //y2=0.175
r2220 (  54 263 ) resistor r=0.0942778 //w=0.221 //l=0.13 //layer=m1 \
 //thickness=0.36 //x=20.805 //y=1.015 //x2=20.805 //y2=1.145
r2221 (  53 265 ) resistor r=0.0413265 //w=0.7 //l=0.175 //layer=m1 \
 //thickness=0.36 //x=20.805 //y=0.35 //x2=20.805 //y2=0.175
r2222 (  53 54 ) resistor r=0.634542 //w=0.131 //l=0.665 //layer=m1 \
 //thickness=0.36 //x=20.805 //y=0.35 //x2=20.805 //y2=1.015
r2223 (  52 401 ) resistor r=3.1 //w=0.17 //l=0.51 //layer=mcon //count=3 \
 //x=20.47 //y=0.18 //x2=20.47 //y2=0.18
r2224 (  50 390 ) resistor r=3.1 //w=0.17 //l=0.51 //layer=mcon //count=3 \
 //x=18.99 //y=0.18 //x2=18.99 //y2=0.18
r2225 (  50 52 ) resistor r=0.594855 //w=0.311 //l=1.48 //layer=m1 \
 //thickness=0.36 //x=18.99 //y=0.175 //x2=20.47 //y2=0.175
r2226 (  48 388 ) resistor r=3.1 //w=0.17 //l=0.51 //layer=mcon //count=3 \
 //x=17.88 //y=0.18 //x2=17.88 //y2=0.18
r2227 (  48 50 ) resistor r=0.446141 //w=0.311 //l=1.11 //layer=m1 \
 //thickness=0.36 //x=17.88 //y=0.175 //x2=18.99 //y2=0.175
r2228 (  46 386 ) resistor r=3.1 //w=0.17 //l=0.51 //layer=mcon //count=3 \
 //x=16.77 //y=0.18 //x2=16.77 //y2=0.18
r2229 (  46 48 ) resistor r=0.446141 //w=0.311 //l=1.11 //layer=m1 \
 //thickness=0.36 //x=16.77 //y=0.175 //x2=17.88 //y2=0.175
r2230 (  44 261 ) resistor r=0.028033 //w=0.35 //l=0.085 //layer=m1 \
 //thickness=0.36 //x=16.08 //y=0.175 //x2=15.995 //y2=0.175
r2231 (  44 46 ) resistor r=0.277331 //w=0.311 //l=0.69 //layer=m1 \
 //thickness=0.36 //x=16.08 //y=0.175 //x2=16.77 //y2=0.175
r2232 (  43 265 ) resistor r=0.028033 //w=0.35 //l=0.085 //layer=m1 \
 //thickness=0.36 //x=20.72 //y=0.175 //x2=20.805 //y2=0.175
r2233 (  43 52 ) resistor r=0.100482 //w=0.311 //l=0.25 //layer=m1 \
 //thickness=0.36 //x=20.72 //y=0.175 //x2=20.47 //y2=0.175
r2234 (  42 259 ) resistor r=0.0942778 //w=0.221 //l=0.13 //layer=m1 \
 //thickness=0.36 //x=15.995 //y=1.015 //x2=15.995 //y2=1.145
r2235 (  41 261 ) resistor r=0.0413265 //w=0.7 //l=0.175 //layer=m1 \
 //thickness=0.36 //x=15.995 //y=0.35 //x2=15.995 //y2=0.175
r2236 (  41 42 ) resistor r=0.634542 //w=0.131 //l=0.665 //layer=m1 \
 //thickness=0.36 //x=15.995 //y=0.35 //x2=15.995 //y2=1.015
r2237 (  40 384 ) resistor r=3.1 //w=0.17 //l=0.51 //layer=mcon //count=3 \
 //x=15.66 //y=0.18 //x2=15.66 //y2=0.18
r2238 (  38 373 ) resistor r=3.1 //w=0.17 //l=0.51 //layer=mcon //count=3 \
 //x=14.18 //y=0.18 //x2=14.18 //y2=0.18
r2239 (  38 40 ) resistor r=0.594855 //w=0.311 //l=1.48 //layer=m1 \
 //thickness=0.36 //x=14.18 //y=0.175 //x2=15.66 //y2=0.175
r2240 (  36 371 ) resistor r=3.1 //w=0.17 //l=0.51 //layer=mcon //count=3 \
 //x=13.07 //y=0.18 //x2=13.07 //y2=0.18
r2241 (  36 38 ) resistor r=0.446141 //w=0.311 //l=1.11 //layer=m1 \
 //thickness=0.36 //x=13.07 //y=0.175 //x2=14.18 //y2=0.175
r2242 (  34 369 ) resistor r=3.1 //w=0.17 //l=0.51 //layer=mcon //count=3 \
 //x=11.96 //y=0.18 //x2=11.96 //y2=0.18
r2243 (  34 36 ) resistor r=0.446141 //w=0.311 //l=1.11 //layer=m1 \
 //thickness=0.36 //x=11.96 //y=0.175 //x2=13.07 //y2=0.175
r2244 (  32 257 ) resistor r=0.028033 //w=0.35 //l=0.085 //layer=m1 \
 //thickness=0.36 //x=11.27 //y=0.175 //x2=11.185 //y2=0.175
r2245 (  32 34 ) resistor r=0.277331 //w=0.311 //l=0.69 //layer=m1 \
 //thickness=0.36 //x=11.27 //y=0.175 //x2=11.96 //y2=0.175
r2246 (  31 261 ) resistor r=0.028033 //w=0.35 //l=0.085 //layer=m1 \
 //thickness=0.36 //x=15.91 //y=0.175 //x2=15.995 //y2=0.175
r2247 (  31 40 ) resistor r=0.100482 //w=0.311 //l=0.25 //layer=m1 \
 //thickness=0.36 //x=15.91 //y=0.175 //x2=15.66 //y2=0.175
r2248 (  30 255 ) resistor r=0.0942778 //w=0.221 //l=0.13 //layer=m1 \
 //thickness=0.36 //x=11.185 //y=1.015 //x2=11.185 //y2=1.145
r2249 (  29 257 ) resistor r=0.0413265 //w=0.7 //l=0.175 //layer=m1 \
 //thickness=0.36 //x=11.185 //y=0.35 //x2=11.185 //y2=0.175
r2250 (  29 30 ) resistor r=0.634542 //w=0.131 //l=0.665 //layer=m1 \
 //thickness=0.36 //x=11.185 //y=0.35 //x2=11.185 //y2=1.015
r2251 (  28 367 ) resistor r=3.1 //w=0.17 //l=0.51 //layer=mcon //count=3 \
 //x=10.85 //y=0.18 //x2=10.85 //y2=0.18
r2252 (  26 356 ) resistor r=3.1 //w=0.17 //l=0.51 //layer=mcon //count=3 \
 //x=9.37 //y=0.18 //x2=9.37 //y2=0.18
r2253 (  26 28 ) resistor r=0.594855 //w=0.311 //l=1.48 //layer=m1 \
 //thickness=0.36 //x=9.37 //y=0.175 //x2=10.85 //y2=0.175
r2254 (  24 354 ) resistor r=3.1 //w=0.17 //l=0.51 //layer=mcon //count=3 \
 //x=8.26 //y=0.18 //x2=8.26 //y2=0.18
r2255 (  24 26 ) resistor r=0.446141 //w=0.311 //l=1.11 //layer=m1 \
 //thickness=0.36 //x=8.26 //y=0.175 //x2=9.37 //y2=0.175
r2256 (  22 352 ) resistor r=3.1 //w=0.17 //l=0.51 //layer=mcon //count=3 \
 //x=7.15 //y=0.18 //x2=7.15 //y2=0.18
r2257 (  22 24 ) resistor r=0.446141 //w=0.311 //l=1.11 //layer=m1 \
 //thickness=0.36 //x=7.15 //y=0.175 //x2=8.26 //y2=0.175
r2258 (  20 253 ) resistor r=0.028033 //w=0.35 //l=0.085 //layer=m1 \
 //thickness=0.36 //x=6.46 //y=0.175 //x2=6.375 //y2=0.175
r2259 (  20 22 ) resistor r=0.277331 //w=0.311 //l=0.69 //layer=m1 \
 //thickness=0.36 //x=6.46 //y=0.175 //x2=7.15 //y2=0.175
r2260 (  19 257 ) resistor r=0.028033 //w=0.35 //l=0.085 //layer=m1 \
 //thickness=0.36 //x=11.1 //y=0.175 //x2=11.185 //y2=0.175
r2261 (  19 28 ) resistor r=0.100482 //w=0.311 //l=0.25 //layer=m1 \
 //thickness=0.36 //x=11.1 //y=0.175 //x2=10.85 //y2=0.175
r2262 (  18 251 ) resistor r=0.0942778 //w=0.221 //l=0.13 //layer=m1 \
 //thickness=0.36 //x=6.375 //y=1.015 //x2=6.375 //y2=1.145
r2263 (  17 253 ) resistor r=0.0413265 //w=0.7 //l=0.175 //layer=m1 \
 //thickness=0.36 //x=6.375 //y=0.35 //x2=6.375 //y2=0.175
r2264 (  17 18 ) resistor r=0.634542 //w=0.131 //l=0.665 //layer=m1 \
 //thickness=0.36 //x=6.375 //y=0.35 //x2=6.375 //y2=1.015
r2265 (  16 350 ) resistor r=3.1 //w=0.17 //l=0.51 //layer=mcon //count=3 \
 //x=6.04 //y=0.18 //x2=6.04 //y2=0.18
r2266 (  14 339 ) resistor r=3.1 //w=0.17 //l=0.51 //layer=mcon //count=3 \
 //x=4.56 //y=0.18 //x2=4.56 //y2=0.18
r2267 (  14 16 ) resistor r=0.594855 //w=0.311 //l=1.48 //layer=m1 \
 //thickness=0.36 //x=4.56 //y=0.175 //x2=6.04 //y2=0.175
r2268 (  12 337 ) resistor r=3.1 //w=0.17 //l=0.51 //layer=mcon //count=3 \
 //x=3.45 //y=0.18 //x2=3.45 //y2=0.18
r2269 (  12 14 ) resistor r=0.446141 //w=0.311 //l=1.11 //layer=m1 \
 //thickness=0.36 //x=3.45 //y=0.175 //x2=4.56 //y2=0.175
r2270 (  10 335 ) resistor r=3.1 //w=0.17 //l=0.51 //layer=mcon //count=3 \
 //x=2.34 //y=0.18 //x2=2.34 //y2=0.18
r2271 (  10 12 ) resistor r=0.446141 //w=0.311 //l=1.11 //layer=m1 \
 //thickness=0.36 //x=2.34 //y=0.175 //x2=3.45 //y2=0.175
r2272 (  8 249 ) resistor r=0.028033 //w=0.35 //l=0.085 //layer=m1 \
 //thickness=0.36 //x=1.65 //y=0.175 //x2=1.565 //y2=0.175
r2273 (  8 10 ) resistor r=0.277331 //w=0.311 //l=0.69 //layer=m1 \
 //thickness=0.36 //x=1.65 //y=0.175 //x2=2.34 //y2=0.175
r2274 (  7 253 ) resistor r=0.028033 //w=0.35 //l=0.085 //layer=m1 \
 //thickness=0.36 //x=6.29 //y=0.175 //x2=6.375 //y2=0.175
r2275 (  7 16 ) resistor r=0.100482 //w=0.311 //l=0.25 //layer=m1 \
 //thickness=0.36 //x=6.29 //y=0.175 //x2=6.04 //y2=0.175
r2276 (  6 247 ) resistor r=0.0942778 //w=0.221 //l=0.13 //layer=m1 \
 //thickness=0.36 //x=1.565 //y=1.015 //x2=1.565 //y2=1.145
r2277 (  5 249 ) resistor r=0.0413265 //w=0.7 //l=0.175 //layer=m1 \
 //thickness=0.36 //x=1.565 //y=0.35 //x2=1.565 //y2=0.175
r2278 (  5 6 ) resistor r=0.634542 //w=0.131 //l=0.665 //layer=m1 \
 //thickness=0.36 //x=1.565 //y=0.35 //x2=1.565 //y2=1.015
r2279 (  4 333 ) resistor r=3.1 //w=0.17 //l=0.51 //layer=mcon //count=3 \
 //x=1.23 //y=0.18 //x2=1.23 //y2=0.18
r2280 (  2 249 ) resistor r=0.028033 //w=0.35 //l=0.085 //layer=m1 \
 //thickness=0.36 //x=1.48 //y=0.175 //x2=1.565 //y2=0.175
r2281 (  2 4 ) resistor r=0.0892857 //w=0.35 //l=0.25 //layer=m1 \
 //thickness=0.36 //x=1.48 //y=0.175 //x2=1.23 //y2=0.175
r2282 (  1 125 ) resistor r=0.223071 //w=0.311 //l=0.555 //layer=m1 \
 //thickness=0.36 //x=48.775 //y=0.175 //x2=49.33 //y2=0.175
r2283 (  1 122 ) resistor r=0.371785 //w=0.311 //l=0.925 //layer=m1 \
 //thickness=0.36 //x=48.775 //y=0.175 //x2=47.85 //y2=0.175
ends PM_TMRDFFSNRNQNX1\%GND

subckt PM_TMRDFFSNRNQNX1\%noxref_46 ( 1 5 9 13 17 35 )
c55 ( 35 0 ) capacitor c=0.0709164f //x=0.945 //y=0.555
c56 ( 17 0 ) capacitor c=0.0214613f //x=2.935 //y=1.77
c57 ( 13 0 ) capacitor c=0.0153216f //x=2.935 //y=0.72
c58 ( 9 0 ) capacitor c=0.00772076f //x=2.05 //y=0.805
c59 ( 5 0 ) capacitor c=0.0197372f //x=1.965 //y=1.77
c60 ( 1 0 ) capacitor c=0.0109947f //x=1.08 //y=1.685
r61 (  18 35 ) resistor r=5.4201 //w=0.17 //l=0.103078 //layer=li \
 //thickness=0.1 //x=2.135 //y=1.77 //x2=2.05 //y2=1.81
r62 (  18 35 ) resistor r=27.3797 //w=0.187 //l=0.4 //layer=li //thickness=0.1 \
 //x=2.135 //y=1.77 //x2=2.535 //y2=1.77
r63 (  17 35 ) resistor r=0.751729 //w=0.17 //l=0.085 //layer=li \
 //thickness=0.1 //x=2.935 //y=1.77 //x2=3.02 //y2=1.77
r64 (  17 35 ) resistor r=27.3797 //w=0.187 //l=0.4 //layer=li //thickness=0.1 \
 //x=2.935 //y=1.77 //x2=2.535 //y2=1.77
r65 (  14 35 ) resistor r=3.57586 //w=0.17 //l=0.103078 //layer=li \
 //thickness=0.1 //x=2.135 //y=0.72 //x2=2.05 //y2=0.68
r66 (  14 35 ) resistor r=27.3797 //w=0.187 //l=0.4 //layer=li //thickness=0.1 \
 //x=2.135 //y=0.72 //x2=2.535 //y2=0.72
r67 (  13 35 ) resistor r=0.751729 //w=0.17 //l=0.085 //layer=li \
 //thickness=0.1 //x=2.935 //y=0.72 //x2=3.02 //y2=0.72
r68 (  13 35 ) resistor r=27.3797 //w=0.187 //l=0.4 //layer=li //thickness=0.1 \
 //x=2.935 //y=0.72 //x2=2.535 //y2=0.72
r69 (  10 35 ) resistor r=1.40859 //w=0.34 //l=0.125 //layer=li \
 //thickness=0.1 //x=2.05 //y=1.685 //x2=2.05 //y2=1.81
r70 (  10 35 ) resistor r=42.0963 //w=0.187 //l=0.615 //layer=li \
 //thickness=0.1 //x=2.05 //y=1.685 //x2=2.05 //y2=1.07
r71 (  9 35 ) resistor r=3.57586 //w=0.17 //l=0.125 //layer=li //thickness=0.1 \
 //x=2.05 //y=0.805 //x2=2.05 //y2=0.68
r72 (  9 35 ) resistor r=18.139 //w=0.187 //l=0.265 //layer=li //thickness=0.1 \
 //x=2.05 //y=0.805 //x2=2.05 //y2=1.07
r73 (  6 35 ) resistor r=3.57586 //w=0.17 //l=0.103078 //layer=li \
 //thickness=0.1 //x=1.165 //y=1.77 //x2=1.08 //y2=1.81
r74 (  6 35 ) resistor r=27.3797 //w=0.187 //l=0.4 //layer=li //thickness=0.1 \
 //x=1.165 //y=1.77 //x2=1.565 //y2=1.77
r75 (  5 35 ) resistor r=5.4201 //w=0.17 //l=0.103078 //layer=li \
 //thickness=0.1 //x=1.965 //y=1.77 //x2=2.05 //y2=1.81
r76 (  5 35 ) resistor r=27.3797 //w=0.187 //l=0.4 //layer=li //thickness=0.1 \
 //x=1.965 //y=1.77 //x2=1.565 //y2=1.77
r77 (  1 35 ) resistor r=3.57586 //w=0.17 //l=0.125 //layer=li //thickness=0.1 \
 //x=1.08 //y=1.685 //x2=1.08 //y2=1.81
r78 (  1 35 ) resistor r=42.0963 //w=0.187 //l=0.615 //layer=li \
 //thickness=0.1 //x=1.08 //y=1.685 //x2=1.08 //y2=1.07
ends PM_TMRDFFSNRNQNX1\%noxref_46

subckt PM_TMRDFFSNRNQNX1\%noxref_47 ( 1 5 9 13 17 35 )
c57 ( 35 0 ) capacitor c=0.0691212f //x=5.755 //y=0.555
c58 ( 17 0 ) capacitor c=0.0190725f //x=7.745 //y=1.77
c59 ( 13 0 ) capacitor c=0.015325f //x=7.745 //y=0.72
c60 ( 9 0 ) capacitor c=0.00772076f //x=6.86 //y=0.805
c61 ( 5 0 ) capacitor c=0.0166941f //x=6.775 //y=1.77
c62 ( 1 0 ) capacitor c=0.00710458f //x=5.89 //y=1.685
r63 (  18 35 ) resistor r=5.4201 //w=0.17 //l=0.103078 //layer=li \
 //thickness=0.1 //x=6.945 //y=1.77 //x2=6.86 //y2=1.81
r64 (  18 35 ) resistor r=27.3797 //w=0.187 //l=0.4 //layer=li //thickness=0.1 \
 //x=6.945 //y=1.77 //x2=7.345 //y2=1.77
r65 (  17 35 ) resistor r=0.751729 //w=0.17 //l=0.085 //layer=li \
 //thickness=0.1 //x=7.745 //y=1.77 //x2=7.83 //y2=1.77
r66 (  17 35 ) resistor r=27.3797 //w=0.187 //l=0.4 //layer=li //thickness=0.1 \
 //x=7.745 //y=1.77 //x2=7.345 //y2=1.77
r67 (  14 35 ) resistor r=3.57586 //w=0.17 //l=0.103078 //layer=li \
 //thickness=0.1 //x=6.945 //y=0.72 //x2=6.86 //y2=0.68
r68 (  14 35 ) resistor r=27.3797 //w=0.187 //l=0.4 //layer=li //thickness=0.1 \
 //x=6.945 //y=0.72 //x2=7.345 //y2=0.72
r69 (  13 35 ) resistor r=0.751729 //w=0.17 //l=0.085 //layer=li \
 //thickness=0.1 //x=7.745 //y=0.72 //x2=7.83 //y2=0.72
r70 (  13 35 ) resistor r=27.3797 //w=0.187 //l=0.4 //layer=li //thickness=0.1 \
 //x=7.745 //y=0.72 //x2=7.345 //y2=0.72
r71 (  10 35 ) resistor r=1.40859 //w=0.34 //l=0.125 //layer=li \
 //thickness=0.1 //x=6.86 //y=1.685 //x2=6.86 //y2=1.81
r72 (  10 35 ) resistor r=42.0963 //w=0.187 //l=0.615 //layer=li \
 //thickness=0.1 //x=6.86 //y=1.685 //x2=6.86 //y2=1.07
r73 (  9 35 ) resistor r=3.57586 //w=0.17 //l=0.125 //layer=li //thickness=0.1 \
 //x=6.86 //y=0.805 //x2=6.86 //y2=0.68
r74 (  9 35 ) resistor r=18.139 //w=0.187 //l=0.265 //layer=li //thickness=0.1 \
 //x=6.86 //y=0.805 //x2=6.86 //y2=1.07
r75 (  6 35 ) resistor r=3.57586 //w=0.17 //l=0.103078 //layer=li \
 //thickness=0.1 //x=5.975 //y=1.77 //x2=5.89 //y2=1.81
r76 (  6 35 ) resistor r=27.3797 //w=0.187 //l=0.4 //layer=li //thickness=0.1 \
 //x=5.975 //y=1.77 //x2=6.375 //y2=1.77
r77 (  5 35 ) resistor r=5.4201 //w=0.17 //l=0.103078 //layer=li \
 //thickness=0.1 //x=6.775 //y=1.77 //x2=6.86 //y2=1.81
r78 (  5 35 ) resistor r=27.3797 //w=0.187 //l=0.4 //layer=li //thickness=0.1 \
 //x=6.775 //y=1.77 //x2=6.375 //y2=1.77
r79 (  1 35 ) resistor r=3.57586 //w=0.17 //l=0.125 //layer=li //thickness=0.1 \
 //x=5.89 //y=1.685 //x2=5.89 //y2=1.81
r80 (  1 35 ) resistor r=42.0963 //w=0.187 //l=0.615 //layer=li \
 //thickness=0.1 //x=5.89 //y=1.685 //x2=5.89 //y2=1.07
ends PM_TMRDFFSNRNQNX1\%noxref_47

subckt PM_TMRDFFSNRNQNX1\%noxref_48 ( 1 5 9 13 17 35 )
c58 ( 35 0 ) capacitor c=0.0691212f //x=10.565 //y=0.555
c59 ( 17 0 ) capacitor c=0.0190725f //x=12.555 //y=1.77
c60 ( 13 0 ) capacitor c=0.015325f //x=12.555 //y=0.72
c61 ( 9 0 ) capacitor c=0.00772076f //x=11.67 //y=0.805
c62 ( 5 0 ) capacitor c=0.0167789f //x=11.585 //y=1.77
c63 ( 1 0 ) capacitor c=0.00710458f //x=10.7 //y=1.685
r64 (  18 35 ) resistor r=5.4201 //w=0.17 //l=0.103078 //layer=li \
 //thickness=0.1 //x=11.755 //y=1.77 //x2=11.67 //y2=1.81
r65 (  18 35 ) resistor r=27.3797 //w=0.187 //l=0.4 //layer=li //thickness=0.1 \
 //x=11.755 //y=1.77 //x2=12.155 //y2=1.77
r66 (  17 35 ) resistor r=0.751729 //w=0.17 //l=0.085 //layer=li \
 //thickness=0.1 //x=12.555 //y=1.77 //x2=12.64 //y2=1.77
r67 (  17 35 ) resistor r=27.3797 //w=0.187 //l=0.4 //layer=li //thickness=0.1 \
 //x=12.555 //y=1.77 //x2=12.155 //y2=1.77
r68 (  14 35 ) resistor r=3.57586 //w=0.17 //l=0.103078 //layer=li \
 //thickness=0.1 //x=11.755 //y=0.72 //x2=11.67 //y2=0.68
r69 (  14 35 ) resistor r=27.3797 //w=0.187 //l=0.4 //layer=li //thickness=0.1 \
 //x=11.755 //y=0.72 //x2=12.155 //y2=0.72
r70 (  13 35 ) resistor r=0.751729 //w=0.17 //l=0.085 //layer=li \
 //thickness=0.1 //x=12.555 //y=0.72 //x2=12.64 //y2=0.72
r71 (  13 35 ) resistor r=27.3797 //w=0.187 //l=0.4 //layer=li //thickness=0.1 \
 //x=12.555 //y=0.72 //x2=12.155 //y2=0.72
r72 (  10 35 ) resistor r=1.40859 //w=0.34 //l=0.125 //layer=li \
 //thickness=0.1 //x=11.67 //y=1.685 //x2=11.67 //y2=1.81
r73 (  10 35 ) resistor r=42.0963 //w=0.187 //l=0.615 //layer=li \
 //thickness=0.1 //x=11.67 //y=1.685 //x2=11.67 //y2=1.07
r74 (  9 35 ) resistor r=3.57586 //w=0.17 //l=0.125 //layer=li //thickness=0.1 \
 //x=11.67 //y=0.805 //x2=11.67 //y2=0.68
r75 (  9 35 ) resistor r=18.139 //w=0.187 //l=0.265 //layer=li //thickness=0.1 \
 //x=11.67 //y=0.805 //x2=11.67 //y2=1.07
r76 (  6 35 ) resistor r=3.57586 //w=0.17 //l=0.103078 //layer=li \
 //thickness=0.1 //x=10.785 //y=1.77 //x2=10.7 //y2=1.81
r77 (  6 35 ) resistor r=27.3797 //w=0.187 //l=0.4 //layer=li //thickness=0.1 \
 //x=10.785 //y=1.77 //x2=11.185 //y2=1.77
r78 (  5 35 ) resistor r=5.4201 //w=0.17 //l=0.103078 //layer=li \
 //thickness=0.1 //x=11.585 //y=1.77 //x2=11.67 //y2=1.81
r79 (  5 35 ) resistor r=27.3797 //w=0.187 //l=0.4 //layer=li //thickness=0.1 \
 //x=11.585 //y=1.77 //x2=11.185 //y2=1.77
r80 (  1 35 ) resistor r=3.57586 //w=0.17 //l=0.125 //layer=li //thickness=0.1 \
 //x=10.7 //y=1.685 //x2=10.7 //y2=1.81
r81 (  1 35 ) resistor r=42.0963 //w=0.187 //l=0.615 //layer=li \
 //thickness=0.1 //x=10.7 //y=1.685 //x2=10.7 //y2=1.07
ends PM_TMRDFFSNRNQNX1\%noxref_48

subckt PM_TMRDFFSNRNQNX1\%noxref_49 ( 1 5 9 13 17 35 )
c59 ( 35 0 ) capacitor c=0.0691212f //x=15.375 //y=0.555
c60 ( 17 0 ) capacitor c=0.0190725f //x=17.365 //y=1.77
c61 ( 13 0 ) capacitor c=0.015325f //x=17.365 //y=0.72
c62 ( 9 0 ) capacitor c=0.00772076f //x=16.48 //y=0.805
c63 ( 5 0 ) capacitor c=0.0167589f //x=16.395 //y=1.77
c64 ( 1 0 ) capacitor c=0.00710458f //x=15.51 //y=1.685
r65 (  18 35 ) resistor r=5.4201 //w=0.17 //l=0.103078 //layer=li \
 //thickness=0.1 //x=16.565 //y=1.77 //x2=16.48 //y2=1.81
r66 (  18 35 ) resistor r=27.3797 //w=0.187 //l=0.4 //layer=li //thickness=0.1 \
 //x=16.565 //y=1.77 //x2=16.965 //y2=1.77
r67 (  17 35 ) resistor r=0.751729 //w=0.17 //l=0.085 //layer=li \
 //thickness=0.1 //x=17.365 //y=1.77 //x2=17.45 //y2=1.77
r68 (  17 35 ) resistor r=27.3797 //w=0.187 //l=0.4 //layer=li //thickness=0.1 \
 //x=17.365 //y=1.77 //x2=16.965 //y2=1.77
r69 (  14 35 ) resistor r=3.57586 //w=0.17 //l=0.103078 //layer=li \
 //thickness=0.1 //x=16.565 //y=0.72 //x2=16.48 //y2=0.68
r70 (  14 35 ) resistor r=27.3797 //w=0.187 //l=0.4 //layer=li //thickness=0.1 \
 //x=16.565 //y=0.72 //x2=16.965 //y2=0.72
r71 (  13 35 ) resistor r=0.751729 //w=0.17 //l=0.085 //layer=li \
 //thickness=0.1 //x=17.365 //y=0.72 //x2=17.45 //y2=0.72
r72 (  13 35 ) resistor r=27.3797 //w=0.187 //l=0.4 //layer=li //thickness=0.1 \
 //x=17.365 //y=0.72 //x2=16.965 //y2=0.72
r73 (  10 35 ) resistor r=1.40859 //w=0.34 //l=0.125 //layer=li \
 //thickness=0.1 //x=16.48 //y=1.685 //x2=16.48 //y2=1.81
r74 (  10 35 ) resistor r=42.0963 //w=0.187 //l=0.615 //layer=li \
 //thickness=0.1 //x=16.48 //y=1.685 //x2=16.48 //y2=1.07
r75 (  9 35 ) resistor r=3.57586 //w=0.17 //l=0.125 //layer=li //thickness=0.1 \
 //x=16.48 //y=0.805 //x2=16.48 //y2=0.68
r76 (  9 35 ) resistor r=18.139 //w=0.187 //l=0.265 //layer=li //thickness=0.1 \
 //x=16.48 //y=0.805 //x2=16.48 //y2=1.07
r77 (  6 35 ) resistor r=3.57586 //w=0.17 //l=0.103078 //layer=li \
 //thickness=0.1 //x=15.595 //y=1.77 //x2=15.51 //y2=1.81
r78 (  6 35 ) resistor r=27.3797 //w=0.187 //l=0.4 //layer=li //thickness=0.1 \
 //x=15.595 //y=1.77 //x2=15.995 //y2=1.77
r79 (  5 35 ) resistor r=5.4201 //w=0.17 //l=0.103078 //layer=li \
 //thickness=0.1 //x=16.395 //y=1.77 //x2=16.48 //y2=1.81
r80 (  5 35 ) resistor r=27.3797 //w=0.187 //l=0.4 //layer=li //thickness=0.1 \
 //x=16.395 //y=1.77 //x2=15.995 //y2=1.77
r81 (  1 35 ) resistor r=3.57586 //w=0.17 //l=0.125 //layer=li //thickness=0.1 \
 //x=15.51 //y=1.685 //x2=15.51 //y2=1.81
r82 (  1 35 ) resistor r=42.0963 //w=0.187 //l=0.615 //layer=li \
 //thickness=0.1 //x=15.51 //y=1.685 //x2=15.51 //y2=1.07
ends PM_TMRDFFSNRNQNX1\%noxref_49

subckt PM_TMRDFFSNRNQNX1\%noxref_50 ( 1 5 9 13 17 35 )
c58 ( 35 0 ) capacitor c=0.0691212f //x=20.185 //y=0.555
c59 ( 17 0 ) capacitor c=0.0189585f //x=22.175 //y=1.77
c60 ( 13 0 ) capacitor c=0.0153221f //x=22.175 //y=0.72
c61 ( 9 0 ) capacitor c=0.00772076f //x=21.29 //y=0.805
c62 ( 5 0 ) capacitor c=0.0168501f //x=21.205 //y=1.77
c63 ( 1 0 ) capacitor c=0.00710458f //x=20.32 //y=1.685
r64 (  18 35 ) resistor r=5.4201 //w=0.17 //l=0.103078 //layer=li \
 //thickness=0.1 //x=21.375 //y=1.77 //x2=21.29 //y2=1.81
r65 (  18 35 ) resistor r=27.3797 //w=0.187 //l=0.4 //layer=li //thickness=0.1 \
 //x=21.375 //y=1.77 //x2=21.775 //y2=1.77
r66 (  17 35 ) resistor r=0.751729 //w=0.17 //l=0.085 //layer=li \
 //thickness=0.1 //x=22.175 //y=1.77 //x2=22.26 //y2=1.77
r67 (  17 35 ) resistor r=27.3797 //w=0.187 //l=0.4 //layer=li //thickness=0.1 \
 //x=22.175 //y=1.77 //x2=21.775 //y2=1.77
r68 (  14 35 ) resistor r=3.57586 //w=0.17 //l=0.103078 //layer=li \
 //thickness=0.1 //x=21.375 //y=0.72 //x2=21.29 //y2=0.68
r69 (  14 35 ) resistor r=27.3797 //w=0.187 //l=0.4 //layer=li //thickness=0.1 \
 //x=21.375 //y=0.72 //x2=21.775 //y2=0.72
r70 (  13 35 ) resistor r=0.751729 //w=0.17 //l=0.085 //layer=li \
 //thickness=0.1 //x=22.175 //y=0.72 //x2=22.26 //y2=0.72
r71 (  13 35 ) resistor r=27.3797 //w=0.187 //l=0.4 //layer=li //thickness=0.1 \
 //x=22.175 //y=0.72 //x2=21.775 //y2=0.72
r72 (  10 35 ) resistor r=1.40859 //w=0.34 //l=0.125 //layer=li \
 //thickness=0.1 //x=21.29 //y=1.685 //x2=21.29 //y2=1.81
r73 (  10 35 ) resistor r=42.0963 //w=0.187 //l=0.615 //layer=li \
 //thickness=0.1 //x=21.29 //y=1.685 //x2=21.29 //y2=1.07
r74 (  9 35 ) resistor r=3.57586 //w=0.17 //l=0.125 //layer=li //thickness=0.1 \
 //x=21.29 //y=0.805 //x2=21.29 //y2=0.68
r75 (  9 35 ) resistor r=18.139 //w=0.187 //l=0.265 //layer=li //thickness=0.1 \
 //x=21.29 //y=0.805 //x2=21.29 //y2=1.07
r76 (  6 35 ) resistor r=3.57586 //w=0.17 //l=0.103078 //layer=li \
 //thickness=0.1 //x=20.405 //y=1.77 //x2=20.32 //y2=1.81
r77 (  6 35 ) resistor r=27.3797 //w=0.187 //l=0.4 //layer=li //thickness=0.1 \
 //x=20.405 //y=1.77 //x2=20.805 //y2=1.77
r78 (  5 35 ) resistor r=5.4201 //w=0.17 //l=0.103078 //layer=li \
 //thickness=0.1 //x=21.205 //y=1.77 //x2=21.29 //y2=1.81
r79 (  5 35 ) resistor r=27.3797 //w=0.187 //l=0.4 //layer=li //thickness=0.1 \
 //x=21.205 //y=1.77 //x2=20.805 //y2=1.77
r80 (  1 35 ) resistor r=3.57586 //w=0.17 //l=0.125 //layer=li //thickness=0.1 \
 //x=20.32 //y=1.685 //x2=20.32 //y2=1.81
r81 (  1 35 ) resistor r=42.0963 //w=0.187 //l=0.615 //layer=li \
 //thickness=0.1 //x=20.32 //y=1.685 //x2=20.32 //y2=1.07
ends PM_TMRDFFSNRNQNX1\%noxref_50

subckt PM_TMRDFFSNRNQNX1\%noxref_51 ( 1 5 9 13 17 35 )
c59 ( 35 0 ) capacitor c=0.0691212f //x=24.995 //y=0.555
c60 ( 17 0 ) capacitor c=0.0190725f //x=26.985 //y=1.77
c61 ( 13 0 ) capacitor c=0.015325f //x=26.985 //y=0.72
c62 ( 9 0 ) capacitor c=0.00772076f //x=26.1 //y=0.805
c63 ( 5 0 ) capacitor c=0.0167869f //x=26.015 //y=1.77
c64 ( 1 0 ) capacitor c=0.00710458f //x=25.13 //y=1.685
r65 (  18 35 ) resistor r=5.4201 //w=0.17 //l=0.103078 //layer=li \
 //thickness=0.1 //x=26.185 //y=1.77 //x2=26.1 //y2=1.81
r66 (  18 35 ) resistor r=27.3797 //w=0.187 //l=0.4 //layer=li //thickness=0.1 \
 //x=26.185 //y=1.77 //x2=26.585 //y2=1.77
r67 (  17 35 ) resistor r=0.751729 //w=0.17 //l=0.085 //layer=li \
 //thickness=0.1 //x=26.985 //y=1.77 //x2=27.07 //y2=1.77
r68 (  17 35 ) resistor r=27.3797 //w=0.187 //l=0.4 //layer=li //thickness=0.1 \
 //x=26.985 //y=1.77 //x2=26.585 //y2=1.77
r69 (  14 35 ) resistor r=3.57586 //w=0.17 //l=0.103078 //layer=li \
 //thickness=0.1 //x=26.185 //y=0.72 //x2=26.1 //y2=0.68
r70 (  14 35 ) resistor r=27.3797 //w=0.187 //l=0.4 //layer=li //thickness=0.1 \
 //x=26.185 //y=0.72 //x2=26.585 //y2=0.72
r71 (  13 35 ) resistor r=0.751729 //w=0.17 //l=0.085 //layer=li \
 //thickness=0.1 //x=26.985 //y=0.72 //x2=27.07 //y2=0.72
r72 (  13 35 ) resistor r=27.3797 //w=0.187 //l=0.4 //layer=li //thickness=0.1 \
 //x=26.985 //y=0.72 //x2=26.585 //y2=0.72
r73 (  10 35 ) resistor r=1.40859 //w=0.34 //l=0.125 //layer=li \
 //thickness=0.1 //x=26.1 //y=1.685 //x2=26.1 //y2=1.81
r74 (  10 35 ) resistor r=42.0963 //w=0.187 //l=0.615 //layer=li \
 //thickness=0.1 //x=26.1 //y=1.685 //x2=26.1 //y2=1.07
r75 (  9 35 ) resistor r=3.57586 //w=0.17 //l=0.125 //layer=li //thickness=0.1 \
 //x=26.1 //y=0.805 //x2=26.1 //y2=0.68
r76 (  9 35 ) resistor r=18.139 //w=0.187 //l=0.265 //layer=li //thickness=0.1 \
 //x=26.1 //y=0.805 //x2=26.1 //y2=1.07
r77 (  6 35 ) resistor r=3.57586 //w=0.17 //l=0.103078 //layer=li \
 //thickness=0.1 //x=25.215 //y=1.77 //x2=25.13 //y2=1.81
r78 (  6 35 ) resistor r=27.3797 //w=0.187 //l=0.4 //layer=li //thickness=0.1 \
 //x=25.215 //y=1.77 //x2=25.615 //y2=1.77
r79 (  5 35 ) resistor r=5.4201 //w=0.17 //l=0.103078 //layer=li \
 //thickness=0.1 //x=26.015 //y=1.77 //x2=26.1 //y2=1.81
r80 (  5 35 ) resistor r=27.3797 //w=0.187 //l=0.4 //layer=li //thickness=0.1 \
 //x=26.015 //y=1.77 //x2=25.615 //y2=1.77
r81 (  1 35 ) resistor r=3.57586 //w=0.17 //l=0.125 //layer=li //thickness=0.1 \
 //x=25.13 //y=1.685 //x2=25.13 //y2=1.81
r82 (  1 35 ) resistor r=42.0963 //w=0.187 //l=0.615 //layer=li \
 //thickness=0.1 //x=25.13 //y=1.685 //x2=25.13 //y2=1.07
ends PM_TMRDFFSNRNQNX1\%noxref_51

subckt PM_TMRDFFSNRNQNX1\%noxref_52 ( 1 5 9 13 17 35 )
c56 ( 35 0 ) capacitor c=0.0691212f //x=29.805 //y=0.555
c57 ( 17 0 ) capacitor c=0.0189725f //x=31.795 //y=1.77
c58 ( 13 0 ) capacitor c=0.0153216f //x=31.795 //y=0.72
c59 ( 9 0 ) capacitor c=0.00772076f //x=30.91 //y=0.805
c60 ( 5 0 ) capacitor c=0.0168501f //x=30.825 //y=1.77
c61 ( 1 0 ) capacitor c=0.00710458f //x=29.94 //y=1.685
r62 (  18 35 ) resistor r=5.4201 //w=0.17 //l=0.103078 //layer=li \
 //thickness=0.1 //x=30.995 //y=1.77 //x2=30.91 //y2=1.81
r63 (  18 35 ) resistor r=27.3797 //w=0.187 //l=0.4 //layer=li //thickness=0.1 \
 //x=30.995 //y=1.77 //x2=31.395 //y2=1.77
r64 (  17 35 ) resistor r=0.751729 //w=0.17 //l=0.085 //layer=li \
 //thickness=0.1 //x=31.795 //y=1.77 //x2=31.88 //y2=1.77
r65 (  17 35 ) resistor r=27.3797 //w=0.187 //l=0.4 //layer=li //thickness=0.1 \
 //x=31.795 //y=1.77 //x2=31.395 //y2=1.77
r66 (  14 35 ) resistor r=3.57586 //w=0.17 //l=0.103078 //layer=li \
 //thickness=0.1 //x=30.995 //y=0.72 //x2=30.91 //y2=0.68
r67 (  14 35 ) resistor r=27.3797 //w=0.187 //l=0.4 //layer=li //thickness=0.1 \
 //x=30.995 //y=0.72 //x2=31.395 //y2=0.72
r68 (  13 35 ) resistor r=0.751729 //w=0.17 //l=0.085 //layer=li \
 //thickness=0.1 //x=31.795 //y=0.72 //x2=31.88 //y2=0.72
r69 (  13 35 ) resistor r=27.3797 //w=0.187 //l=0.4 //layer=li //thickness=0.1 \
 //x=31.795 //y=0.72 //x2=31.395 //y2=0.72
r70 (  10 35 ) resistor r=1.40859 //w=0.34 //l=0.125 //layer=li \
 //thickness=0.1 //x=30.91 //y=1.685 //x2=30.91 //y2=1.81
r71 (  10 35 ) resistor r=42.0963 //w=0.187 //l=0.615 //layer=li \
 //thickness=0.1 //x=30.91 //y=1.685 //x2=30.91 //y2=1.07
r72 (  9 35 ) resistor r=3.57586 //w=0.17 //l=0.125 //layer=li //thickness=0.1 \
 //x=30.91 //y=0.805 //x2=30.91 //y2=0.68
r73 (  9 35 ) resistor r=18.139 //w=0.187 //l=0.265 //layer=li //thickness=0.1 \
 //x=30.91 //y=0.805 //x2=30.91 //y2=1.07
r74 (  6 35 ) resistor r=3.57586 //w=0.17 //l=0.103078 //layer=li \
 //thickness=0.1 //x=30.025 //y=1.77 //x2=29.94 //y2=1.81
r75 (  6 35 ) resistor r=27.3797 //w=0.187 //l=0.4 //layer=li //thickness=0.1 \
 //x=30.025 //y=1.77 //x2=30.425 //y2=1.77
r76 (  5 35 ) resistor r=5.4201 //w=0.17 //l=0.103078 //layer=li \
 //thickness=0.1 //x=30.825 //y=1.77 //x2=30.91 //y2=1.81
r77 (  5 35 ) resistor r=27.3797 //w=0.187 //l=0.4 //layer=li //thickness=0.1 \
 //x=30.825 //y=1.77 //x2=30.425 //y2=1.77
r78 (  1 35 ) resistor r=3.57586 //w=0.17 //l=0.125 //layer=li //thickness=0.1 \
 //x=29.94 //y=1.685 //x2=29.94 //y2=1.81
r79 (  1 35 ) resistor r=42.0963 //w=0.187 //l=0.615 //layer=li \
 //thickness=0.1 //x=29.94 //y=1.685 //x2=29.94 //y2=1.07
ends PM_TMRDFFSNRNQNX1\%noxref_52

subckt PM_TMRDFFSNRNQNX1\%noxref_53 ( 1 5 9 13 17 35 )
c57 ( 35 0 ) capacitor c=0.0691212f //x=34.615 //y=0.555
c58 ( 17 0 ) capacitor c=0.0190725f //x=36.605 //y=1.77
c59 ( 13 0 ) capacitor c=0.015325f //x=36.605 //y=0.72
c60 ( 9 0 ) capacitor c=0.00772076f //x=35.72 //y=0.805
c61 ( 5 0 ) capacitor c=0.0166941f //x=35.635 //y=1.77
c62 ( 1 0 ) capacitor c=0.00710458f //x=34.75 //y=1.685
r63 (  18 35 ) resistor r=5.4201 //w=0.17 //l=0.103078 //layer=li \
 //thickness=0.1 //x=35.805 //y=1.77 //x2=35.72 //y2=1.81
r64 (  18 35 ) resistor r=27.3797 //w=0.187 //l=0.4 //layer=li //thickness=0.1 \
 //x=35.805 //y=1.77 //x2=36.205 //y2=1.77
r65 (  17 35 ) resistor r=0.751729 //w=0.17 //l=0.085 //layer=li \
 //thickness=0.1 //x=36.605 //y=1.77 //x2=36.69 //y2=1.77
r66 (  17 35 ) resistor r=27.3797 //w=0.187 //l=0.4 //layer=li //thickness=0.1 \
 //x=36.605 //y=1.77 //x2=36.205 //y2=1.77
r67 (  14 35 ) resistor r=3.57586 //w=0.17 //l=0.103078 //layer=li \
 //thickness=0.1 //x=35.805 //y=0.72 //x2=35.72 //y2=0.68
r68 (  14 35 ) resistor r=27.3797 //w=0.187 //l=0.4 //layer=li //thickness=0.1 \
 //x=35.805 //y=0.72 //x2=36.205 //y2=0.72
r69 (  13 35 ) resistor r=0.751729 //w=0.17 //l=0.085 //layer=li \
 //thickness=0.1 //x=36.605 //y=0.72 //x2=36.69 //y2=0.72
r70 (  13 35 ) resistor r=27.3797 //w=0.187 //l=0.4 //layer=li //thickness=0.1 \
 //x=36.605 //y=0.72 //x2=36.205 //y2=0.72
r71 (  10 35 ) resistor r=1.40859 //w=0.34 //l=0.125 //layer=li \
 //thickness=0.1 //x=35.72 //y=1.685 //x2=35.72 //y2=1.81
r72 (  10 35 ) resistor r=42.0963 //w=0.187 //l=0.615 //layer=li \
 //thickness=0.1 //x=35.72 //y=1.685 //x2=35.72 //y2=1.07
r73 (  9 35 ) resistor r=3.57586 //w=0.17 //l=0.125 //layer=li //thickness=0.1 \
 //x=35.72 //y=0.805 //x2=35.72 //y2=0.68
r74 (  9 35 ) resistor r=18.139 //w=0.187 //l=0.265 //layer=li //thickness=0.1 \
 //x=35.72 //y=0.805 //x2=35.72 //y2=1.07
r75 (  6 35 ) resistor r=3.57586 //w=0.17 //l=0.103078 //layer=li \
 //thickness=0.1 //x=34.835 //y=1.77 //x2=34.75 //y2=1.81
r76 (  6 35 ) resistor r=27.3797 //w=0.187 //l=0.4 //layer=li //thickness=0.1 \
 //x=34.835 //y=1.77 //x2=35.235 //y2=1.77
r77 (  5 35 ) resistor r=5.4201 //w=0.17 //l=0.103078 //layer=li \
 //thickness=0.1 //x=35.635 //y=1.77 //x2=35.72 //y2=1.81
r78 (  5 35 ) resistor r=27.3797 //w=0.187 //l=0.4 //layer=li //thickness=0.1 \
 //x=35.635 //y=1.77 //x2=35.235 //y2=1.77
r79 (  1 35 ) resistor r=3.57586 //w=0.17 //l=0.125 //layer=li //thickness=0.1 \
 //x=34.75 //y=1.685 //x2=34.75 //y2=1.81
r80 (  1 35 ) resistor r=42.0963 //w=0.187 //l=0.615 //layer=li \
 //thickness=0.1 //x=34.75 //y=1.685 //x2=34.75 //y2=1.07
ends PM_TMRDFFSNRNQNX1\%noxref_53

subckt PM_TMRDFFSNRNQNX1\%noxref_54 ( 1 5 9 13 17 35 )
c58 ( 35 0 ) capacitor c=0.0691212f //x=39.425 //y=0.555
c59 ( 17 0 ) capacitor c=0.0190725f //x=41.415 //y=1.77
c60 ( 13 0 ) capacitor c=0.015325f //x=41.415 //y=0.72
c61 ( 9 0 ) capacitor c=0.00772076f //x=40.53 //y=0.805
c62 ( 5 0 ) capacitor c=0.0167789f //x=40.445 //y=1.77
c63 ( 1 0 ) capacitor c=0.00710458f //x=39.56 //y=1.685
r64 (  18 35 ) resistor r=5.4201 //w=0.17 //l=0.103078 //layer=li \
 //thickness=0.1 //x=40.615 //y=1.77 //x2=40.53 //y2=1.81
r65 (  18 35 ) resistor r=27.3797 //w=0.187 //l=0.4 //layer=li //thickness=0.1 \
 //x=40.615 //y=1.77 //x2=41.015 //y2=1.77
r66 (  17 35 ) resistor r=0.751729 //w=0.17 //l=0.085 //layer=li \
 //thickness=0.1 //x=41.415 //y=1.77 //x2=41.5 //y2=1.77
r67 (  17 35 ) resistor r=27.3797 //w=0.187 //l=0.4 //layer=li //thickness=0.1 \
 //x=41.415 //y=1.77 //x2=41.015 //y2=1.77
r68 (  14 35 ) resistor r=3.57586 //w=0.17 //l=0.103078 //layer=li \
 //thickness=0.1 //x=40.615 //y=0.72 //x2=40.53 //y2=0.68
r69 (  14 35 ) resistor r=27.3797 //w=0.187 //l=0.4 //layer=li //thickness=0.1 \
 //x=40.615 //y=0.72 //x2=41.015 //y2=0.72
r70 (  13 35 ) resistor r=0.751729 //w=0.17 //l=0.085 //layer=li \
 //thickness=0.1 //x=41.415 //y=0.72 //x2=41.5 //y2=0.72
r71 (  13 35 ) resistor r=27.3797 //w=0.187 //l=0.4 //layer=li //thickness=0.1 \
 //x=41.415 //y=0.72 //x2=41.015 //y2=0.72
r72 (  10 35 ) resistor r=1.40859 //w=0.34 //l=0.125 //layer=li \
 //thickness=0.1 //x=40.53 //y=1.685 //x2=40.53 //y2=1.81
r73 (  10 35 ) resistor r=42.0963 //w=0.187 //l=0.615 //layer=li \
 //thickness=0.1 //x=40.53 //y=1.685 //x2=40.53 //y2=1.07
r74 (  9 35 ) resistor r=3.57586 //w=0.17 //l=0.125 //layer=li //thickness=0.1 \
 //x=40.53 //y=0.805 //x2=40.53 //y2=0.68
r75 (  9 35 ) resistor r=18.139 //w=0.187 //l=0.265 //layer=li //thickness=0.1 \
 //x=40.53 //y=0.805 //x2=40.53 //y2=1.07
r76 (  6 35 ) resistor r=3.57586 //w=0.17 //l=0.103078 //layer=li \
 //thickness=0.1 //x=39.645 //y=1.77 //x2=39.56 //y2=1.81
r77 (  6 35 ) resistor r=27.3797 //w=0.187 //l=0.4 //layer=li //thickness=0.1 \
 //x=39.645 //y=1.77 //x2=40.045 //y2=1.77
r78 (  5 35 ) resistor r=5.4201 //w=0.17 //l=0.103078 //layer=li \
 //thickness=0.1 //x=40.445 //y=1.77 //x2=40.53 //y2=1.81
r79 (  5 35 ) resistor r=27.3797 //w=0.187 //l=0.4 //layer=li //thickness=0.1 \
 //x=40.445 //y=1.77 //x2=40.045 //y2=1.77
r80 (  1 35 ) resistor r=3.57586 //w=0.17 //l=0.125 //layer=li //thickness=0.1 \
 //x=39.56 //y=1.685 //x2=39.56 //y2=1.81
r81 (  1 35 ) resistor r=42.0963 //w=0.187 //l=0.615 //layer=li \
 //thickness=0.1 //x=39.56 //y=1.685 //x2=39.56 //y2=1.07
ends PM_TMRDFFSNRNQNX1\%noxref_54

subckt PM_TMRDFFSNRNQNX1\%noxref_55 ( 1 5 9 13 17 35 )
c59 ( 35 0 ) capacitor c=0.0691212f //x=44.235 //y=0.555
c60 ( 17 0 ) capacitor c=0.0190725f //x=46.225 //y=1.77
c61 ( 13 0 ) capacitor c=0.015325f //x=46.225 //y=0.72
c62 ( 9 0 ) capacitor c=0.00772076f //x=45.34 //y=0.805
c63 ( 5 0 ) capacitor c=0.0167589f //x=45.255 //y=1.77
c64 ( 1 0 ) capacitor c=0.00710458f //x=44.37 //y=1.685
r65 (  18 35 ) resistor r=5.4201 //w=0.17 //l=0.103078 //layer=li \
 //thickness=0.1 //x=45.425 //y=1.77 //x2=45.34 //y2=1.81
r66 (  18 35 ) resistor r=27.3797 //w=0.187 //l=0.4 //layer=li //thickness=0.1 \
 //x=45.425 //y=1.77 //x2=45.825 //y2=1.77
r67 (  17 35 ) resistor r=0.751729 //w=0.17 //l=0.085 //layer=li \
 //thickness=0.1 //x=46.225 //y=1.77 //x2=46.31 //y2=1.77
r68 (  17 35 ) resistor r=27.3797 //w=0.187 //l=0.4 //layer=li //thickness=0.1 \
 //x=46.225 //y=1.77 //x2=45.825 //y2=1.77
r69 (  14 35 ) resistor r=3.57586 //w=0.17 //l=0.103078 //layer=li \
 //thickness=0.1 //x=45.425 //y=0.72 //x2=45.34 //y2=0.68
r70 (  14 35 ) resistor r=27.3797 //w=0.187 //l=0.4 //layer=li //thickness=0.1 \
 //x=45.425 //y=0.72 //x2=45.825 //y2=0.72
r71 (  13 35 ) resistor r=0.751729 //w=0.17 //l=0.085 //layer=li \
 //thickness=0.1 //x=46.225 //y=0.72 //x2=46.31 //y2=0.72
r72 (  13 35 ) resistor r=27.3797 //w=0.187 //l=0.4 //layer=li //thickness=0.1 \
 //x=46.225 //y=0.72 //x2=45.825 //y2=0.72
r73 (  10 35 ) resistor r=1.40859 //w=0.34 //l=0.125 //layer=li \
 //thickness=0.1 //x=45.34 //y=1.685 //x2=45.34 //y2=1.81
r74 (  10 35 ) resistor r=42.0963 //w=0.187 //l=0.615 //layer=li \
 //thickness=0.1 //x=45.34 //y=1.685 //x2=45.34 //y2=1.07
r75 (  9 35 ) resistor r=3.57586 //w=0.17 //l=0.125 //layer=li //thickness=0.1 \
 //x=45.34 //y=0.805 //x2=45.34 //y2=0.68
r76 (  9 35 ) resistor r=18.139 //w=0.187 //l=0.265 //layer=li //thickness=0.1 \
 //x=45.34 //y=0.805 //x2=45.34 //y2=1.07
r77 (  6 35 ) resistor r=3.57586 //w=0.17 //l=0.103078 //layer=li \
 //thickness=0.1 //x=44.455 //y=1.77 //x2=44.37 //y2=1.81
r78 (  6 35 ) resistor r=27.3797 //w=0.187 //l=0.4 //layer=li //thickness=0.1 \
 //x=44.455 //y=1.77 //x2=44.855 //y2=1.77
r79 (  5 35 ) resistor r=5.4201 //w=0.17 //l=0.103078 //layer=li \
 //thickness=0.1 //x=45.255 //y=1.77 //x2=45.34 //y2=1.81
r80 (  5 35 ) resistor r=27.3797 //w=0.187 //l=0.4 //layer=li //thickness=0.1 \
 //x=45.255 //y=1.77 //x2=44.855 //y2=1.77
r81 (  1 35 ) resistor r=3.57586 //w=0.17 //l=0.125 //layer=li //thickness=0.1 \
 //x=44.37 //y=1.685 //x2=44.37 //y2=1.81
r82 (  1 35 ) resistor r=42.0963 //w=0.187 //l=0.615 //layer=li \
 //thickness=0.1 //x=44.37 //y=1.685 //x2=44.37 //y2=1.07
ends PM_TMRDFFSNRNQNX1\%noxref_55

subckt PM_TMRDFFSNRNQNX1\%noxref_56 ( 1 5 9 13 17 35 )
c58 ( 35 0 ) capacitor c=0.0691212f //x=49.045 //y=0.555
c59 ( 17 0 ) capacitor c=0.0189585f //x=51.035 //y=1.77
c60 ( 13 0 ) capacitor c=0.0153221f //x=51.035 //y=0.72
c61 ( 9 0 ) capacitor c=0.00772076f //x=50.15 //y=0.805
c62 ( 5 0 ) capacitor c=0.0168501f //x=50.065 //y=1.77
c63 ( 1 0 ) capacitor c=0.00710458f //x=49.18 //y=1.685
r64 (  18 35 ) resistor r=5.4201 //w=0.17 //l=0.103078 //layer=li \
 //thickness=0.1 //x=50.235 //y=1.77 //x2=50.15 //y2=1.81
r65 (  18 35 ) resistor r=27.3797 //w=0.187 //l=0.4 //layer=li //thickness=0.1 \
 //x=50.235 //y=1.77 //x2=50.635 //y2=1.77
r66 (  17 35 ) resistor r=0.751729 //w=0.17 //l=0.085 //layer=li \
 //thickness=0.1 //x=51.035 //y=1.77 //x2=51.12 //y2=1.77
r67 (  17 35 ) resistor r=27.3797 //w=0.187 //l=0.4 //layer=li //thickness=0.1 \
 //x=51.035 //y=1.77 //x2=50.635 //y2=1.77
r68 (  14 35 ) resistor r=3.57586 //w=0.17 //l=0.103078 //layer=li \
 //thickness=0.1 //x=50.235 //y=0.72 //x2=50.15 //y2=0.68
r69 (  14 35 ) resistor r=27.3797 //w=0.187 //l=0.4 //layer=li //thickness=0.1 \
 //x=50.235 //y=0.72 //x2=50.635 //y2=0.72
r70 (  13 35 ) resistor r=0.751729 //w=0.17 //l=0.085 //layer=li \
 //thickness=0.1 //x=51.035 //y=0.72 //x2=51.12 //y2=0.72
r71 (  13 35 ) resistor r=27.3797 //w=0.187 //l=0.4 //layer=li //thickness=0.1 \
 //x=51.035 //y=0.72 //x2=50.635 //y2=0.72
r72 (  10 35 ) resistor r=1.40859 //w=0.34 //l=0.125 //layer=li \
 //thickness=0.1 //x=50.15 //y=1.685 //x2=50.15 //y2=1.81
r73 (  10 35 ) resistor r=42.0963 //w=0.187 //l=0.615 //layer=li \
 //thickness=0.1 //x=50.15 //y=1.685 //x2=50.15 //y2=1.07
r74 (  9 35 ) resistor r=3.57586 //w=0.17 //l=0.125 //layer=li //thickness=0.1 \
 //x=50.15 //y=0.805 //x2=50.15 //y2=0.68
r75 (  9 35 ) resistor r=18.139 //w=0.187 //l=0.265 //layer=li //thickness=0.1 \
 //x=50.15 //y=0.805 //x2=50.15 //y2=1.07
r76 (  6 35 ) resistor r=3.57586 //w=0.17 //l=0.103078 //layer=li \
 //thickness=0.1 //x=49.265 //y=1.77 //x2=49.18 //y2=1.81
r77 (  6 35 ) resistor r=27.3797 //w=0.187 //l=0.4 //layer=li //thickness=0.1 \
 //x=49.265 //y=1.77 //x2=49.665 //y2=1.77
r78 (  5 35 ) resistor r=5.4201 //w=0.17 //l=0.103078 //layer=li \
 //thickness=0.1 //x=50.065 //y=1.77 //x2=50.15 //y2=1.81
r79 (  5 35 ) resistor r=27.3797 //w=0.187 //l=0.4 //layer=li //thickness=0.1 \
 //x=50.065 //y=1.77 //x2=49.665 //y2=1.77
r80 (  1 35 ) resistor r=3.57586 //w=0.17 //l=0.125 //layer=li //thickness=0.1 \
 //x=49.18 //y=1.685 //x2=49.18 //y2=1.81
r81 (  1 35 ) resistor r=42.0963 //w=0.187 //l=0.615 //layer=li \
 //thickness=0.1 //x=49.18 //y=1.685 //x2=49.18 //y2=1.07
ends PM_TMRDFFSNRNQNX1\%noxref_56

subckt PM_TMRDFFSNRNQNX1\%noxref_57 ( 1 5 9 13 17 35 )
c57 ( 35 0 ) capacitor c=0.0691212f //x=53.855 //y=0.555
c58 ( 17 0 ) capacitor c=0.0190725f //x=55.845 //y=1.77
c59 ( 13 0 ) capacitor c=0.015325f //x=55.845 //y=0.72
c60 ( 9 0 ) capacitor c=0.00772076f //x=54.96 //y=0.805
c61 ( 5 0 ) capacitor c=0.0168501f //x=54.875 //y=1.77
c62 ( 1 0 ) capacitor c=0.00710458f //x=53.99 //y=1.685
r63 (  18 35 ) resistor r=5.4201 //w=0.17 //l=0.103078 //layer=li \
 //thickness=0.1 //x=55.045 //y=1.77 //x2=54.96 //y2=1.81
r64 (  18 35 ) resistor r=27.3797 //w=0.187 //l=0.4 //layer=li //thickness=0.1 \
 //x=55.045 //y=1.77 //x2=55.445 //y2=1.77
r65 (  17 35 ) resistor r=0.751729 //w=0.17 //l=0.085 //layer=li \
 //thickness=0.1 //x=55.845 //y=1.77 //x2=55.93 //y2=1.77
r66 (  17 35 ) resistor r=27.3797 //w=0.187 //l=0.4 //layer=li //thickness=0.1 \
 //x=55.845 //y=1.77 //x2=55.445 //y2=1.77
r67 (  14 35 ) resistor r=3.57586 //w=0.17 //l=0.103078 //layer=li \
 //thickness=0.1 //x=55.045 //y=0.72 //x2=54.96 //y2=0.68
r68 (  14 35 ) resistor r=27.3797 //w=0.187 //l=0.4 //layer=li //thickness=0.1 \
 //x=55.045 //y=0.72 //x2=55.445 //y2=0.72
r69 (  13 35 ) resistor r=0.751729 //w=0.17 //l=0.085 //layer=li \
 //thickness=0.1 //x=55.845 //y=0.72 //x2=55.93 //y2=0.72
r70 (  13 35 ) resistor r=27.3797 //w=0.187 //l=0.4 //layer=li //thickness=0.1 \
 //x=55.845 //y=0.72 //x2=55.445 //y2=0.72
r71 (  10 35 ) resistor r=1.40859 //w=0.34 //l=0.125 //layer=li \
 //thickness=0.1 //x=54.96 //y=1.685 //x2=54.96 //y2=1.81
r72 (  10 35 ) resistor r=42.0963 //w=0.187 //l=0.615 //layer=li \
 //thickness=0.1 //x=54.96 //y=1.685 //x2=54.96 //y2=1.07
r73 (  9 35 ) resistor r=3.57586 //w=0.17 //l=0.125 //layer=li //thickness=0.1 \
 //x=54.96 //y=0.805 //x2=54.96 //y2=0.68
r74 (  9 35 ) resistor r=18.139 //w=0.187 //l=0.265 //layer=li //thickness=0.1 \
 //x=54.96 //y=0.805 //x2=54.96 //y2=1.07
r75 (  6 35 ) resistor r=3.57586 //w=0.17 //l=0.103078 //layer=li \
 //thickness=0.1 //x=54.075 //y=1.77 //x2=53.99 //y2=1.81
r76 (  6 35 ) resistor r=27.3797 //w=0.187 //l=0.4 //layer=li //thickness=0.1 \
 //x=54.075 //y=1.77 //x2=54.475 //y2=1.77
r77 (  5 35 ) resistor r=5.4201 //w=0.17 //l=0.103078 //layer=li \
 //thickness=0.1 //x=54.875 //y=1.77 //x2=54.96 //y2=1.81
r78 (  5 35 ) resistor r=27.3797 //w=0.187 //l=0.4 //layer=li //thickness=0.1 \
 //x=54.875 //y=1.77 //x2=54.475 //y2=1.77
r79 (  1 35 ) resistor r=3.57586 //w=0.17 //l=0.125 //layer=li //thickness=0.1 \
 //x=53.99 //y=1.685 //x2=53.99 //y2=1.81
r80 (  1 35 ) resistor r=42.0963 //w=0.187 //l=0.615 //layer=li \
 //thickness=0.1 //x=53.99 //y=1.685 //x2=53.99 //y2=1.07
ends PM_TMRDFFSNRNQNX1\%noxref_57

subckt PM_TMRDFFSNRNQNX1\%noxref_58 ( 1 5 9 13 17 35 )
c56 ( 35 0 ) capacitor c=0.0691212f //x=58.665 //y=0.555
c57 ( 17 0 ) capacitor c=0.0189725f //x=60.655 //y=1.77
c58 ( 13 0 ) capacitor c=0.0153216f //x=60.655 //y=0.72
c59 ( 9 0 ) capacitor c=0.00772076f //x=59.77 //y=0.805
c60 ( 5 0 ) capacitor c=0.0168501f //x=59.685 //y=1.77
c61 ( 1 0 ) capacitor c=0.00710458f //x=58.8 //y=1.685
r62 (  18 35 ) resistor r=5.4201 //w=0.17 //l=0.103078 //layer=li \
 //thickness=0.1 //x=59.855 //y=1.77 //x2=59.77 //y2=1.81
r63 (  18 35 ) resistor r=27.3797 //w=0.187 //l=0.4 //layer=li //thickness=0.1 \
 //x=59.855 //y=1.77 //x2=60.255 //y2=1.77
r64 (  17 35 ) resistor r=0.751729 //w=0.17 //l=0.085 //layer=li \
 //thickness=0.1 //x=60.655 //y=1.77 //x2=60.74 //y2=1.77
r65 (  17 35 ) resistor r=27.3797 //w=0.187 //l=0.4 //layer=li //thickness=0.1 \
 //x=60.655 //y=1.77 //x2=60.255 //y2=1.77
r66 (  14 35 ) resistor r=3.57586 //w=0.17 //l=0.103078 //layer=li \
 //thickness=0.1 //x=59.855 //y=0.72 //x2=59.77 //y2=0.68
r67 (  14 35 ) resistor r=27.3797 //w=0.187 //l=0.4 //layer=li //thickness=0.1 \
 //x=59.855 //y=0.72 //x2=60.255 //y2=0.72
r68 (  13 35 ) resistor r=0.751729 //w=0.17 //l=0.085 //layer=li \
 //thickness=0.1 //x=60.655 //y=0.72 //x2=60.74 //y2=0.72
r69 (  13 35 ) resistor r=27.3797 //w=0.187 //l=0.4 //layer=li //thickness=0.1 \
 //x=60.655 //y=0.72 //x2=60.255 //y2=0.72
r70 (  10 35 ) resistor r=1.40859 //w=0.34 //l=0.125 //layer=li \
 //thickness=0.1 //x=59.77 //y=1.685 //x2=59.77 //y2=1.81
r71 (  10 35 ) resistor r=42.0963 //w=0.187 //l=0.615 //layer=li \
 //thickness=0.1 //x=59.77 //y=1.685 //x2=59.77 //y2=1.07
r72 (  9 35 ) resistor r=3.57586 //w=0.17 //l=0.125 //layer=li //thickness=0.1 \
 //x=59.77 //y=0.805 //x2=59.77 //y2=0.68
r73 (  9 35 ) resistor r=18.139 //w=0.187 //l=0.265 //layer=li //thickness=0.1 \
 //x=59.77 //y=0.805 //x2=59.77 //y2=1.07
r74 (  6 35 ) resistor r=3.57586 //w=0.17 //l=0.103078 //layer=li \
 //thickness=0.1 //x=58.885 //y=1.77 //x2=58.8 //y2=1.81
r75 (  6 35 ) resistor r=27.3797 //w=0.187 //l=0.4 //layer=li //thickness=0.1 \
 //x=58.885 //y=1.77 //x2=59.285 //y2=1.77
r76 (  5 35 ) resistor r=5.4201 //w=0.17 //l=0.103078 //layer=li \
 //thickness=0.1 //x=59.685 //y=1.77 //x2=59.77 //y2=1.81
r77 (  5 35 ) resistor r=27.3797 //w=0.187 //l=0.4 //layer=li //thickness=0.1 \
 //x=59.685 //y=1.77 //x2=59.285 //y2=1.77
r78 (  1 35 ) resistor r=3.57586 //w=0.17 //l=0.125 //layer=li //thickness=0.1 \
 //x=58.8 //y=1.685 //x2=58.8 //y2=1.81
r79 (  1 35 ) resistor r=42.0963 //w=0.187 //l=0.615 //layer=li \
 //thickness=0.1 //x=58.8 //y=1.685 //x2=58.8 //y2=1.07
ends PM_TMRDFFSNRNQNX1\%noxref_58

subckt PM_TMRDFFSNRNQNX1\%noxref_59 ( 1 5 9 13 17 35 )
c57 ( 35 0 ) capacitor c=0.0691212f //x=63.475 //y=0.555
c58 ( 17 0 ) capacitor c=0.0190725f //x=65.465 //y=1.77
c59 ( 13 0 ) capacitor c=0.015325f //x=65.465 //y=0.72
c60 ( 9 0 ) capacitor c=0.00772076f //x=64.58 //y=0.805
c61 ( 5 0 ) capacitor c=0.0166941f //x=64.495 //y=1.77
c62 ( 1 0 ) capacitor c=0.00710458f //x=63.61 //y=1.685
r63 (  18 35 ) resistor r=5.4201 //w=0.17 //l=0.103078 //layer=li \
 //thickness=0.1 //x=64.665 //y=1.77 //x2=64.58 //y2=1.81
r64 (  18 35 ) resistor r=27.3797 //w=0.187 //l=0.4 //layer=li //thickness=0.1 \
 //x=64.665 //y=1.77 //x2=65.065 //y2=1.77
r65 (  17 35 ) resistor r=0.751729 //w=0.17 //l=0.085 //layer=li \
 //thickness=0.1 //x=65.465 //y=1.77 //x2=65.55 //y2=1.77
r66 (  17 35 ) resistor r=27.3797 //w=0.187 //l=0.4 //layer=li //thickness=0.1 \
 //x=65.465 //y=1.77 //x2=65.065 //y2=1.77
r67 (  14 35 ) resistor r=3.57586 //w=0.17 //l=0.103078 //layer=li \
 //thickness=0.1 //x=64.665 //y=0.72 //x2=64.58 //y2=0.68
r68 (  14 35 ) resistor r=27.3797 //w=0.187 //l=0.4 //layer=li //thickness=0.1 \
 //x=64.665 //y=0.72 //x2=65.065 //y2=0.72
r69 (  13 35 ) resistor r=0.751729 //w=0.17 //l=0.085 //layer=li \
 //thickness=0.1 //x=65.465 //y=0.72 //x2=65.55 //y2=0.72
r70 (  13 35 ) resistor r=27.3797 //w=0.187 //l=0.4 //layer=li //thickness=0.1 \
 //x=65.465 //y=0.72 //x2=65.065 //y2=0.72
r71 (  10 35 ) resistor r=1.40859 //w=0.34 //l=0.125 //layer=li \
 //thickness=0.1 //x=64.58 //y=1.685 //x2=64.58 //y2=1.81
r72 (  10 35 ) resistor r=42.0963 //w=0.187 //l=0.615 //layer=li \
 //thickness=0.1 //x=64.58 //y=1.685 //x2=64.58 //y2=1.07
r73 (  9 35 ) resistor r=3.57586 //w=0.17 //l=0.125 //layer=li //thickness=0.1 \
 //x=64.58 //y=0.805 //x2=64.58 //y2=0.68
r74 (  9 35 ) resistor r=18.139 //w=0.187 //l=0.265 //layer=li //thickness=0.1 \
 //x=64.58 //y=0.805 //x2=64.58 //y2=1.07
r75 (  6 35 ) resistor r=3.57586 //w=0.17 //l=0.103078 //layer=li \
 //thickness=0.1 //x=63.695 //y=1.77 //x2=63.61 //y2=1.81
r76 (  6 35 ) resistor r=27.3797 //w=0.187 //l=0.4 //layer=li //thickness=0.1 \
 //x=63.695 //y=1.77 //x2=64.095 //y2=1.77
r77 (  5 35 ) resistor r=5.4201 //w=0.17 //l=0.103078 //layer=li \
 //thickness=0.1 //x=64.495 //y=1.77 //x2=64.58 //y2=1.81
r78 (  5 35 ) resistor r=27.3797 //w=0.187 //l=0.4 //layer=li //thickness=0.1 \
 //x=64.495 //y=1.77 //x2=64.095 //y2=1.77
r79 (  1 35 ) resistor r=3.57586 //w=0.17 //l=0.125 //layer=li //thickness=0.1 \
 //x=63.61 //y=1.685 //x2=63.61 //y2=1.81
r80 (  1 35 ) resistor r=42.0963 //w=0.187 //l=0.615 //layer=li \
 //thickness=0.1 //x=63.61 //y=1.685 //x2=63.61 //y2=1.07
ends PM_TMRDFFSNRNQNX1\%noxref_59

subckt PM_TMRDFFSNRNQNX1\%noxref_60 ( 1 5 9 13 17 35 )
c58 ( 35 0 ) capacitor c=0.0691212f //x=68.285 //y=0.555
c59 ( 17 0 ) capacitor c=0.0190725f //x=70.275 //y=1.77
c60 ( 13 0 ) capacitor c=0.015325f //x=70.275 //y=0.72
c61 ( 9 0 ) capacitor c=0.00772076f //x=69.39 //y=0.805
c62 ( 5 0 ) capacitor c=0.0167789f //x=69.305 //y=1.77
c63 ( 1 0 ) capacitor c=0.00710458f //x=68.42 //y=1.685
r64 (  18 35 ) resistor r=5.4201 //w=0.17 //l=0.103078 //layer=li \
 //thickness=0.1 //x=69.475 //y=1.77 //x2=69.39 //y2=1.81
r65 (  18 35 ) resistor r=27.3797 //w=0.187 //l=0.4 //layer=li //thickness=0.1 \
 //x=69.475 //y=1.77 //x2=69.875 //y2=1.77
r66 (  17 35 ) resistor r=0.751729 //w=0.17 //l=0.085 //layer=li \
 //thickness=0.1 //x=70.275 //y=1.77 //x2=70.36 //y2=1.77
r67 (  17 35 ) resistor r=27.3797 //w=0.187 //l=0.4 //layer=li //thickness=0.1 \
 //x=70.275 //y=1.77 //x2=69.875 //y2=1.77
r68 (  14 35 ) resistor r=3.57586 //w=0.17 //l=0.103078 //layer=li \
 //thickness=0.1 //x=69.475 //y=0.72 //x2=69.39 //y2=0.68
r69 (  14 35 ) resistor r=27.3797 //w=0.187 //l=0.4 //layer=li //thickness=0.1 \
 //x=69.475 //y=0.72 //x2=69.875 //y2=0.72
r70 (  13 35 ) resistor r=0.751729 //w=0.17 //l=0.085 //layer=li \
 //thickness=0.1 //x=70.275 //y=0.72 //x2=70.36 //y2=0.72
r71 (  13 35 ) resistor r=27.3797 //w=0.187 //l=0.4 //layer=li //thickness=0.1 \
 //x=70.275 //y=0.72 //x2=69.875 //y2=0.72
r72 (  10 35 ) resistor r=1.40859 //w=0.34 //l=0.125 //layer=li \
 //thickness=0.1 //x=69.39 //y=1.685 //x2=69.39 //y2=1.81
r73 (  10 35 ) resistor r=42.0963 //w=0.187 //l=0.615 //layer=li \
 //thickness=0.1 //x=69.39 //y=1.685 //x2=69.39 //y2=1.07
r74 (  9 35 ) resistor r=3.57586 //w=0.17 //l=0.125 //layer=li //thickness=0.1 \
 //x=69.39 //y=0.805 //x2=69.39 //y2=0.68
r75 (  9 35 ) resistor r=18.139 //w=0.187 //l=0.265 //layer=li //thickness=0.1 \
 //x=69.39 //y=0.805 //x2=69.39 //y2=1.07
r76 (  6 35 ) resistor r=3.57586 //w=0.17 //l=0.103078 //layer=li \
 //thickness=0.1 //x=68.505 //y=1.77 //x2=68.42 //y2=1.81
r77 (  6 35 ) resistor r=27.3797 //w=0.187 //l=0.4 //layer=li //thickness=0.1 \
 //x=68.505 //y=1.77 //x2=68.905 //y2=1.77
r78 (  5 35 ) resistor r=5.4201 //w=0.17 //l=0.103078 //layer=li \
 //thickness=0.1 //x=69.305 //y=1.77 //x2=69.39 //y2=1.81
r79 (  5 35 ) resistor r=27.3797 //w=0.187 //l=0.4 //layer=li //thickness=0.1 \
 //x=69.305 //y=1.77 //x2=68.905 //y2=1.77
r80 (  1 35 ) resistor r=3.57586 //w=0.17 //l=0.125 //layer=li //thickness=0.1 \
 //x=68.42 //y=1.685 //x2=68.42 //y2=1.81
r81 (  1 35 ) resistor r=42.0963 //w=0.187 //l=0.615 //layer=li \
 //thickness=0.1 //x=68.42 //y=1.685 //x2=68.42 //y2=1.07
ends PM_TMRDFFSNRNQNX1\%noxref_60

subckt PM_TMRDFFSNRNQNX1\%noxref_61 ( 1 5 9 13 17 35 )
c59 ( 35 0 ) capacitor c=0.0691212f //x=73.095 //y=0.555
c60 ( 17 0 ) capacitor c=0.0190725f //x=75.085 //y=1.77
c61 ( 13 0 ) capacitor c=0.015325f //x=75.085 //y=0.72
c62 ( 9 0 ) capacitor c=0.00772076f //x=74.2 //y=0.805
c63 ( 5 0 ) capacitor c=0.0167589f //x=74.115 //y=1.77
c64 ( 1 0 ) capacitor c=0.00710458f //x=73.23 //y=1.685
r65 (  18 35 ) resistor r=5.4201 //w=0.17 //l=0.103078 //layer=li \
 //thickness=0.1 //x=74.285 //y=1.77 //x2=74.2 //y2=1.81
r66 (  18 35 ) resistor r=27.3797 //w=0.187 //l=0.4 //layer=li //thickness=0.1 \
 //x=74.285 //y=1.77 //x2=74.685 //y2=1.77
r67 (  17 35 ) resistor r=0.751729 //w=0.17 //l=0.085 //layer=li \
 //thickness=0.1 //x=75.085 //y=1.77 //x2=75.17 //y2=1.77
r68 (  17 35 ) resistor r=27.3797 //w=0.187 //l=0.4 //layer=li //thickness=0.1 \
 //x=75.085 //y=1.77 //x2=74.685 //y2=1.77
r69 (  14 35 ) resistor r=3.57586 //w=0.17 //l=0.103078 //layer=li \
 //thickness=0.1 //x=74.285 //y=0.72 //x2=74.2 //y2=0.68
r70 (  14 35 ) resistor r=27.3797 //w=0.187 //l=0.4 //layer=li //thickness=0.1 \
 //x=74.285 //y=0.72 //x2=74.685 //y2=0.72
r71 (  13 35 ) resistor r=0.751729 //w=0.17 //l=0.085 //layer=li \
 //thickness=0.1 //x=75.085 //y=0.72 //x2=75.17 //y2=0.72
r72 (  13 35 ) resistor r=27.3797 //w=0.187 //l=0.4 //layer=li //thickness=0.1 \
 //x=75.085 //y=0.72 //x2=74.685 //y2=0.72
r73 (  10 35 ) resistor r=1.40859 //w=0.34 //l=0.125 //layer=li \
 //thickness=0.1 //x=74.2 //y=1.685 //x2=74.2 //y2=1.81
r74 (  10 35 ) resistor r=42.0963 //w=0.187 //l=0.615 //layer=li \
 //thickness=0.1 //x=74.2 //y=1.685 //x2=74.2 //y2=1.07
r75 (  9 35 ) resistor r=3.57586 //w=0.17 //l=0.125 //layer=li //thickness=0.1 \
 //x=74.2 //y=0.805 //x2=74.2 //y2=0.68
r76 (  9 35 ) resistor r=18.139 //w=0.187 //l=0.265 //layer=li //thickness=0.1 \
 //x=74.2 //y=0.805 //x2=74.2 //y2=1.07
r77 (  6 35 ) resistor r=3.57586 //w=0.17 //l=0.103078 //layer=li \
 //thickness=0.1 //x=73.315 //y=1.77 //x2=73.23 //y2=1.81
r78 (  6 35 ) resistor r=27.3797 //w=0.187 //l=0.4 //layer=li //thickness=0.1 \
 //x=73.315 //y=1.77 //x2=73.715 //y2=1.77
r79 (  5 35 ) resistor r=5.4201 //w=0.17 //l=0.103078 //layer=li \
 //thickness=0.1 //x=74.115 //y=1.77 //x2=74.2 //y2=1.81
r80 (  5 35 ) resistor r=27.3797 //w=0.187 //l=0.4 //layer=li //thickness=0.1 \
 //x=74.115 //y=1.77 //x2=73.715 //y2=1.77
r81 (  1 35 ) resistor r=3.57586 //w=0.17 //l=0.125 //layer=li //thickness=0.1 \
 //x=73.23 //y=1.685 //x2=73.23 //y2=1.81
r82 (  1 35 ) resistor r=42.0963 //w=0.187 //l=0.615 //layer=li \
 //thickness=0.1 //x=73.23 //y=1.685 //x2=73.23 //y2=1.07
ends PM_TMRDFFSNRNQNX1\%noxref_61

subckt PM_TMRDFFSNRNQNX1\%noxref_62 ( 1 5 9 13 17 35 )
c58 ( 35 0 ) capacitor c=0.069559f //x=77.905 //y=0.555
c59 ( 17 0 ) capacitor c=0.0190918f //x=79.895 //y=1.77
c60 ( 13 0 ) capacitor c=0.0153483f //x=79.895 //y=0.72
c61 ( 9 0 ) capacitor c=0.00772076f //x=79.01 //y=0.805
c62 ( 5 0 ) capacitor c=0.0168501f //x=78.925 //y=1.77
c63 ( 1 0 ) capacitor c=0.00710458f //x=78.04 //y=1.685
r64 (  18 35 ) resistor r=5.4201 //w=0.17 //l=0.103078 //layer=li \
 //thickness=0.1 //x=79.095 //y=1.77 //x2=79.01 //y2=1.81
r65 (  18 35 ) resistor r=27.3797 //w=0.187 //l=0.4 //layer=li //thickness=0.1 \
 //x=79.095 //y=1.77 //x2=79.495 //y2=1.77
r66 (  17 35 ) resistor r=0.751729 //w=0.17 //l=0.085 //layer=li \
 //thickness=0.1 //x=79.895 //y=1.77 //x2=79.98 //y2=1.77
r67 (  17 35 ) resistor r=27.3797 //w=0.187 //l=0.4 //layer=li //thickness=0.1 \
 //x=79.895 //y=1.77 //x2=79.495 //y2=1.77
r68 (  14 35 ) resistor r=3.57586 //w=0.17 //l=0.103078 //layer=li \
 //thickness=0.1 //x=79.095 //y=0.72 //x2=79.01 //y2=0.68
r69 (  14 35 ) resistor r=27.3797 //w=0.187 //l=0.4 //layer=li //thickness=0.1 \
 //x=79.095 //y=0.72 //x2=79.495 //y2=0.72
r70 (  13 35 ) resistor r=0.751729 //w=0.17 //l=0.085 //layer=li \
 //thickness=0.1 //x=79.895 //y=0.72 //x2=79.98 //y2=0.72
r71 (  13 35 ) resistor r=27.3797 //w=0.187 //l=0.4 //layer=li //thickness=0.1 \
 //x=79.895 //y=0.72 //x2=79.495 //y2=0.72
r72 (  10 35 ) resistor r=1.40859 //w=0.34 //l=0.125 //layer=li \
 //thickness=0.1 //x=79.01 //y=1.685 //x2=79.01 //y2=1.81
r73 (  10 35 ) resistor r=42.0963 //w=0.187 //l=0.615 //layer=li \
 //thickness=0.1 //x=79.01 //y=1.685 //x2=79.01 //y2=1.07
r74 (  9 35 ) resistor r=3.57586 //w=0.17 //l=0.125 //layer=li //thickness=0.1 \
 //x=79.01 //y=0.805 //x2=79.01 //y2=0.68
r75 (  9 35 ) resistor r=18.139 //w=0.187 //l=0.265 //layer=li //thickness=0.1 \
 //x=79.01 //y=0.805 //x2=79.01 //y2=1.07
r76 (  6 35 ) resistor r=3.57586 //w=0.17 //l=0.103078 //layer=li \
 //thickness=0.1 //x=78.125 //y=1.77 //x2=78.04 //y2=1.81
r77 (  6 35 ) resistor r=27.3797 //w=0.187 //l=0.4 //layer=li //thickness=0.1 \
 //x=78.125 //y=1.77 //x2=78.525 //y2=1.77
r78 (  5 35 ) resistor r=5.4201 //w=0.17 //l=0.103078 //layer=li \
 //thickness=0.1 //x=78.925 //y=1.77 //x2=79.01 //y2=1.81
r79 (  5 35 ) resistor r=27.3797 //w=0.187 //l=0.4 //layer=li //thickness=0.1 \
 //x=78.925 //y=1.77 //x2=78.525 //y2=1.77
r80 (  1 35 ) resistor r=3.57586 //w=0.17 //l=0.125 //layer=li //thickness=0.1 \
 //x=78.04 //y=1.685 //x2=78.04 //y2=1.81
r81 (  1 35 ) resistor r=42.0963 //w=0.187 //l=0.615 //layer=li \
 //thickness=0.1 //x=78.04 //y=1.685 //x2=78.04 //y2=1.07
ends PM_TMRDFFSNRNQNX1\%noxref_62

subckt PM_TMRDFFSNRNQNX1\%noxref_63 ( 1 5 9 13 17 35 )
c57 ( 35 0 ) capacitor c=0.0691304f //x=82.715 //y=0.555
c58 ( 17 0 ) capacitor c=0.0190725f //x=84.705 //y=1.77
c59 ( 13 0 ) capacitor c=0.015325f //x=84.705 //y=0.72
c60 ( 9 0 ) capacitor c=0.00772076f //x=83.82 //y=0.805
c61 ( 5 0 ) capacitor c=0.0167091f //x=83.735 //y=1.77
c62 ( 1 0 ) capacitor c=0.00710458f //x=82.85 //y=1.685
r63 (  18 35 ) resistor r=5.4201 //w=0.17 //l=0.103078 //layer=li \
 //thickness=0.1 //x=83.905 //y=1.77 //x2=83.82 //y2=1.81
r64 (  18 35 ) resistor r=27.3797 //w=0.187 //l=0.4 //layer=li //thickness=0.1 \
 //x=83.905 //y=1.77 //x2=84.305 //y2=1.77
r65 (  17 35 ) resistor r=0.751729 //w=0.17 //l=0.085 //layer=li \
 //thickness=0.1 //x=84.705 //y=1.77 //x2=84.79 //y2=1.77
r66 (  17 35 ) resistor r=27.3797 //w=0.187 //l=0.4 //layer=li //thickness=0.1 \
 //x=84.705 //y=1.77 //x2=84.305 //y2=1.77
r67 (  14 35 ) resistor r=3.57586 //w=0.17 //l=0.103078 //layer=li \
 //thickness=0.1 //x=83.905 //y=0.72 //x2=83.82 //y2=0.68
r68 (  14 35 ) resistor r=27.3797 //w=0.187 //l=0.4 //layer=li //thickness=0.1 \
 //x=83.905 //y=0.72 //x2=84.305 //y2=0.72
r69 (  13 35 ) resistor r=0.751729 //w=0.17 //l=0.085 //layer=li \
 //thickness=0.1 //x=84.705 //y=0.72 //x2=84.79 //y2=0.72
r70 (  13 35 ) resistor r=27.3797 //w=0.187 //l=0.4 //layer=li //thickness=0.1 \
 //x=84.705 //y=0.72 //x2=84.305 //y2=0.72
r71 (  10 35 ) resistor r=1.40859 //w=0.34 //l=0.125 //layer=li \
 //thickness=0.1 //x=83.82 //y=1.685 //x2=83.82 //y2=1.81
r72 (  10 35 ) resistor r=42.0963 //w=0.187 //l=0.615 //layer=li \
 //thickness=0.1 //x=83.82 //y=1.685 //x2=83.82 //y2=1.07
r73 (  9 35 ) resistor r=3.57586 //w=0.17 //l=0.125 //layer=li //thickness=0.1 \
 //x=83.82 //y=0.805 //x2=83.82 //y2=0.68
r74 (  9 35 ) resistor r=18.139 //w=0.187 //l=0.265 //layer=li //thickness=0.1 \
 //x=83.82 //y=0.805 //x2=83.82 //y2=1.07
r75 (  6 35 ) resistor r=3.57586 //w=0.17 //l=0.103078 //layer=li \
 //thickness=0.1 //x=82.935 //y=1.77 //x2=82.85 //y2=1.81
r76 (  6 35 ) resistor r=27.3797 //w=0.187 //l=0.4 //layer=li //thickness=0.1 \
 //x=82.935 //y=1.77 //x2=83.335 //y2=1.77
r77 (  5 35 ) resistor r=5.4201 //w=0.17 //l=0.103078 //layer=li \
 //thickness=0.1 //x=83.735 //y=1.77 //x2=83.82 //y2=1.81
r78 (  5 35 ) resistor r=27.3797 //w=0.187 //l=0.4 //layer=li //thickness=0.1 \
 //x=83.735 //y=1.77 //x2=83.335 //y2=1.77
r79 (  1 35 ) resistor r=3.57586 //w=0.17 //l=0.125 //layer=li //thickness=0.1 \
 //x=82.85 //y=1.685 //x2=82.85 //y2=1.81
r80 (  1 35 ) resistor r=42.0963 //w=0.187 //l=0.615 //layer=li \
 //thickness=0.1 //x=82.85 //y=1.685 //x2=82.85 //y2=1.07
ends PM_TMRDFFSNRNQNX1\%noxref_63

subckt PM_TMRDFFSNRNQNX1\%noxref_64 ( 1 5 9 10 13 17 29 )
c67 ( 29 0 ) capacitor c=0.0764188f //x=87.63 //y=0.545
c68 ( 17 0 ) capacitor c=0.00678917f //x=89.705 //y=0.795
c69 ( 13 0 ) capacitor c=0.0154047f //x=89.62 //y=0.71
c70 ( 10 0 ) capacitor c=0.00748068f //x=88.735 //y=1.675
c71 ( 9 0 ) capacitor c=0.00770028f //x=88.735 //y=0.795
c72 ( 5 0 ) capacitor c=0.0203276f //x=88.65 //y=1.76
c73 ( 1 0 ) capacitor c=0.00454619f //x=87.765 //y=1.675
r74 (  17 29 ) resistor r=3.57586 //w=0.17 //l=0.125 //layer=li \
 //thickness=0.1 //x=89.705 //y=0.795 //x2=89.705 //y2=0.67
r75 (  17 29 ) resistor r=41.4118 //w=0.187 //l=0.605 //layer=li \
 //thickness=0.1 //x=89.705 //y=0.795 //x2=89.705 //y2=1.4
r76 (  14 29 ) resistor r=3.57586 //w=0.17 //l=0.103078 //layer=li \
 //thickness=0.1 //x=88.82 //y=0.71 //x2=88.735 //y2=0.67
r77 (  14 29 ) resistor r=27.0374 //w=0.187 //l=0.395 //layer=li \
 //thickness=0.1 //x=88.82 //y=0.71 //x2=89.215 //y2=0.71
r78 (  13 29 ) resistor r=3.57586 //w=0.17 //l=0.103078 //layer=li \
 //thickness=0.1 //x=89.62 //y=0.71 //x2=89.705 //y2=0.67
r79 (  13 29 ) resistor r=27.7219 //w=0.187 //l=0.405 //layer=li \
 //thickness=0.1 //x=89.62 //y=0.71 //x2=89.215 //y2=0.71
r80 (  10 29 ) resistor r=3.57586 //w=0.17 //l=0.125 //layer=li \
 //thickness=0.1 //x=88.735 //y=1.675 //x2=88.735 //y2=1.8
r81 (  10 29 ) resistor r=42.0963 //w=0.187 //l=0.615 //layer=li \
 //thickness=0.1 //x=88.735 //y=1.675 //x2=88.735 //y2=1.06
r82 (  9 29 ) resistor r=3.57586 //w=0.17 //l=0.125 //layer=li //thickness=0.1 \
 //x=88.735 //y=0.795 //x2=88.735 //y2=0.67
r83 (  9 29 ) resistor r=18.139 //w=0.187 //l=0.265 //layer=li //thickness=0.1 \
 //x=88.735 //y=0.795 //x2=88.735 //y2=1.06
r84 (  6 29 ) resistor r=3.57586 //w=0.17 //l=0.103078 //layer=li \
 //thickness=0.1 //x=87.85 //y=1.76 //x2=87.765 //y2=1.8
r85 (  6 29 ) resistor r=27.3797 //w=0.187 //l=0.4 //layer=li //thickness=0.1 \
 //x=87.85 //y=1.76 //x2=88.25 //y2=1.76
r86 (  5 29 ) resistor r=3.57586 //w=0.17 //l=0.103078 //layer=li \
 //thickness=0.1 //x=88.65 //y=1.76 //x2=88.735 //y2=1.8
r87 (  5 29 ) resistor r=27.3797 //w=0.187 //l=0.4 //layer=li //thickness=0.1 \
 //x=88.65 //y=1.76 //x2=88.25 //y2=1.76
r88 (  1 29 ) resistor r=3.57586 //w=0.17 //l=0.125 //layer=li //thickness=0.1 \
 //x=87.765 //y=1.675 //x2=87.765 //y2=1.8
r89 (  1 29 ) resistor r=42.0963 //w=0.187 //l=0.615 //layer=li \
 //thickness=0.1 //x=87.765 //y=1.675 //x2=87.765 //y2=1.06
ends PM_TMRDFFSNRNQNX1\%noxref_64

subckt PM_TMRDFFSNRNQNX1\%noxref_65 ( 1 5 9 10 13 17 29 )
c62 ( 29 0 ) capacitor c=0.0738182f //x=90.96 //y=0.545
c63 ( 17 0 ) capacitor c=0.00678917f //x=93.035 //y=0.795
c64 ( 13 0 ) capacitor c=0.0158009f //x=92.95 //y=0.71
c65 ( 10 0 ) capacitor c=0.00864691f //x=92.065 //y=1.675
c66 ( 9 0 ) capacitor c=0.00770028f //x=92.065 //y=0.795
c67 ( 5 0 ) capacitor c=0.01765f //x=91.98 //y=1.76
c68 ( 1 0 ) capacitor c=0.00845775f //x=91.095 //y=1.675
r69 (  17 29 ) resistor r=3.57586 //w=0.17 //l=0.125 //layer=li \
 //thickness=0.1 //x=93.035 //y=0.795 //x2=93.035 //y2=0.67
r70 (  17 29 ) resistor r=41.4118 //w=0.187 //l=0.605 //layer=li \
 //thickness=0.1 //x=93.035 //y=0.795 //x2=93.035 //y2=1.4
r71 (  14 29 ) resistor r=3.57586 //w=0.17 //l=0.103078 //layer=li \
 //thickness=0.1 //x=92.15 //y=0.71 //x2=92.065 //y2=0.67
r72 (  14 29 ) resistor r=27.3797 //w=0.187 //l=0.4 //layer=li //thickness=0.1 \
 //x=92.15 //y=0.71 //x2=92.55 //y2=0.71
r73 (  13 29 ) resistor r=3.57586 //w=0.17 //l=0.103078 //layer=li \
 //thickness=0.1 //x=92.95 //y=0.71 //x2=93.035 //y2=0.67
r74 (  13 29 ) resistor r=27.3797 //w=0.187 //l=0.4 //layer=li //thickness=0.1 \
 //x=92.95 //y=0.71 //x2=92.55 //y2=0.71
r75 (  10 29 ) resistor r=3.57586 //w=0.17 //l=0.125 //layer=li \
 //thickness=0.1 //x=92.065 //y=1.675 //x2=92.065 //y2=1.8
r76 (  10 29 ) resistor r=42.0963 //w=0.187 //l=0.615 //layer=li \
 //thickness=0.1 //x=92.065 //y=1.675 //x2=92.065 //y2=1.06
r77 (  9 29 ) resistor r=3.57586 //w=0.17 //l=0.125 //layer=li //thickness=0.1 \
 //x=92.065 //y=0.795 //x2=92.065 //y2=0.67
r78 (  9 29 ) resistor r=18.139 //w=0.187 //l=0.265 //layer=li //thickness=0.1 \
 //x=92.065 //y=0.795 //x2=92.065 //y2=1.06
r79 (  6 29 ) resistor r=3.57586 //w=0.17 //l=0.103078 //layer=li \
 //thickness=0.1 //x=91.18 //y=1.76 //x2=91.095 //y2=1.8
r80 (  6 29 ) resistor r=27.3797 //w=0.187 //l=0.4 //layer=li //thickness=0.1 \
 //x=91.18 //y=1.76 //x2=91.58 //y2=1.76
r81 (  5 29 ) resistor r=3.57586 //w=0.17 //l=0.103078 //layer=li \
 //thickness=0.1 //x=91.98 //y=1.76 //x2=92.065 //y2=1.8
r82 (  5 29 ) resistor r=27.3797 //w=0.187 //l=0.4 //layer=li //thickness=0.1 \
 //x=91.98 //y=1.76 //x2=91.58 //y2=1.76
r83 (  1 29 ) resistor r=3.57586 //w=0.17 //l=0.125 //layer=li //thickness=0.1 \
 //x=91.095 //y=1.675 //x2=91.095 //y2=1.8
r84 (  1 29 ) resistor r=42.0963 //w=0.187 //l=0.615 //layer=li \
 //thickness=0.1 //x=91.095 //y=1.675 //x2=91.095 //y2=1.06
ends PM_TMRDFFSNRNQNX1\%noxref_65

subckt PM_TMRDFFSNRNQNX1\%noxref_66 ( 1 5 9 10 13 17 29 )
c64 ( 29 0 ) capacitor c=0.0686856f //x=94.29 //y=0.545
c65 ( 17 0 ) capacitor c=0.00709795f //x=96.365 //y=0.795
c66 ( 13 0 ) capacitor c=0.0152565f //x=96.28 //y=0.71
c67 ( 10 0 ) capacitor c=0.00749806f //x=95.395 //y=1.675
c68 ( 9 0 ) capacitor c=0.00770028f //x=95.395 //y=0.795
c69 ( 5 0 ) capacitor c=0.0236235f //x=95.31 //y=1.76
c70 ( 1 0 ) capacitor c=0.00498238f //x=94.425 //y=1.675
r71 (  17 29 ) resistor r=3.57586 //w=0.17 //l=0.125 //layer=li \
 //thickness=0.1 //x=96.365 //y=0.795 //x2=96.365 //y2=0.67
r72 (  17 29 ) resistor r=18.139 //w=0.187 //l=0.265 //layer=li \
 //thickness=0.1 //x=96.365 //y=0.795 //x2=96.365 //y2=1.06
r73 (  14 29 ) resistor r=3.57586 //w=0.17 //l=0.103078 //layer=li \
 //thickness=0.1 //x=95.48 //y=0.71 //x2=95.395 //y2=0.67
r74 (  14 29 ) resistor r=27.3797 //w=0.187 //l=0.4 //layer=li //thickness=0.1 \
 //x=95.48 //y=0.71 //x2=95.88 //y2=0.71
r75 (  13 29 ) resistor r=3.57586 //w=0.17 //l=0.103078 //layer=li \
 //thickness=0.1 //x=96.28 //y=0.71 //x2=96.365 //y2=0.67
r76 (  13 29 ) resistor r=27.3797 //w=0.187 //l=0.4 //layer=li //thickness=0.1 \
 //x=96.28 //y=0.71 //x2=95.88 //y2=0.71
r77 (  10 29 ) resistor r=3.57586 //w=0.17 //l=0.125 //layer=li \
 //thickness=0.1 //x=95.395 //y=1.675 //x2=95.395 //y2=1.8
r78 (  10 29 ) resistor r=42.0963 //w=0.187 //l=0.615 //layer=li \
 //thickness=0.1 //x=95.395 //y=1.675 //x2=95.395 //y2=1.06
r79 (  9 29 ) resistor r=3.57586 //w=0.17 //l=0.125 //layer=li //thickness=0.1 \
 //x=95.395 //y=0.795 //x2=95.395 //y2=0.67
r80 (  9 29 ) resistor r=18.139 //w=0.187 //l=0.265 //layer=li //thickness=0.1 \
 //x=95.395 //y=0.795 //x2=95.395 //y2=1.06
r81 (  6 29 ) resistor r=3.57586 //w=0.17 //l=0.103078 //layer=li \
 //thickness=0.1 //x=94.51 //y=1.76 //x2=94.425 //y2=1.8
r82 (  6 29 ) resistor r=27.3797 //w=0.187 //l=0.4 //layer=li //thickness=0.1 \
 //x=94.51 //y=1.76 //x2=94.91 //y2=1.76
r83 (  5 29 ) resistor r=3.57586 //w=0.17 //l=0.103078 //layer=li \
 //thickness=0.1 //x=95.31 //y=1.76 //x2=95.395 //y2=1.8
r84 (  5 29 ) resistor r=27.3797 //w=0.187 //l=0.4 //layer=li //thickness=0.1 \
 //x=95.31 //y=1.76 //x2=94.91 //y2=1.76
r85 (  1 29 ) resistor r=3.57586 //w=0.17 //l=0.125 //layer=li //thickness=0.1 \
 //x=94.425 //y=1.675 //x2=94.425 //y2=1.8
r86 (  1 29 ) resistor r=42.0963 //w=0.187 //l=0.615 //layer=li \
 //thickness=0.1 //x=94.425 //y=1.675 //x2=94.425 //y2=1.06
ends PM_TMRDFFSNRNQNX1\%noxref_66
