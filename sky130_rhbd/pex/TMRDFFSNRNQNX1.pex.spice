// File: TMRDFFSNRNQNX1.spi.pex
// Created: Thu Jan 22 07:10:01 2026
// Program "Calibre xRC"
// Version "v2023.2_27.15"
// Nominal Temperature: 30C
// Circuit Temperature: 30C
//
simulator lang=spectre
subckt PM_TMRDFFSNRNQNX1\%noxref_1 ( 1 3 6 7 9 10 11 12 14 15 16 17 18 19 20 \
 21 22 23 24 25 28 31 37 45 49 63 66 67 69 70 73 81 89 106 115 120 129 133 134 \
 135 136 137 138 139 140 141 142 143 145 151 152 153 154 158 159 160 161 162 \
 164 170 171 172 173 193 195 196 197 )
c412 ( 193 0 ) capacitor c=0.00885916f //x=3.885 //y=1.095
c413 ( 173 0 ) capacitor c=0.0612936f //x=11.495 //y=4.97
c414 ( 172 0 ) capacitor c=0.0376642f //x=11.785 //y=4.97
c415 ( 171 0 ) capacitor c=0.0346489f //x=11.45 //y=1.4
c416 ( 170 0 ) capacitor c=0.018692f //x=11.45 //y=1.055
c417 ( 164 0 ) capacitor c=0.0137077f //x=11.295 //y=1.555
c418 ( 162 0 ) capacitor c=0.0158585f //x=11.295 //y=0.9
c419 ( 161 0 ) capacitor c=0.0979536f //x=10.92 //y=2.095
c420 ( 160 0 ) capacitor c=0.0229444f //x=10.92 //y=1.71
c421 ( 159 0 ) capacitor c=0.0234359f //x=10.92 //y=1.4
c422 ( 158 0 ) capacitor c=0.019815f //x=10.92 //y=1.055
c423 ( 154 0 ) capacitor c=0.0612936f //x=6.685 //y=4.97
c424 ( 153 0 ) capacitor c=0.0376642f //x=6.975 //y=4.97
c425 ( 152 0 ) capacitor c=0.0346489f //x=6.64 //y=1.4
c426 ( 151 0 ) capacitor c=0.018692f //x=6.64 //y=1.055
c427 ( 145 0 ) capacitor c=0.0137077f //x=6.485 //y=1.555
c428 ( 143 0 ) capacitor c=0.0158585f //x=6.485 //y=0.9
c429 ( 142 0 ) capacitor c=0.0996161f //x=6.11 //y=2.095
c430 ( 141 0 ) capacitor c=0.0229444f //x=6.11 //y=1.71
c431 ( 140 0 ) capacitor c=0.0234359f //x=6.11 //y=1.4
c432 ( 139 0 ) capacitor c=0.019815f //x=6.11 //y=1.055
c433 ( 138 0 ) capacitor c=0.110208f //x=11.86 //y=6.2
c434 ( 137 0 ) capacitor c=0.158957f //x=11.42 //y=6.2
c435 ( 136 0 ) capacitor c=0.110208f //x=7.05 //y=6.2
c436 ( 135 0 ) capacitor c=0.158957f //x=6.61 //y=6.2
c437 ( 129 0 ) capacitor c=0.0014751f //x=11.22 //y=4.88
c438 ( 120 0 ) capacitor c=9.93222e-19 //x=11.22 //y=2.26
c439 ( 115 0 ) capacitor c=0.0014751f //x=6.41 //y=4.88
c440 ( 106 0 ) capacitor c=9.93222e-19 //x=6.41 //y=2.26
c441 ( 89 0 ) capacitor c=0.0293562f //x=3.78 //y=5.56
c442 ( 81 0 ) capacitor c=0.029137f //x=2.9 //y=5.56
c443 ( 73 0 ) capacitor c=0.0278099f //x=2.02 //y=5.56
c444 ( 70 0 ) capacitor c=0.0487028f //x=11.06 //y=2.785
c445 ( 69 0 ) capacitor c=7.81966e-19 //x=11.22 //y=2.785
c446 ( 67 0 ) capacitor c=7.81966e-19 //x=6.575 //y=2.785
c447 ( 66 0 ) capacitor c=0.0212437f //x=6.255 //y=2.785
c448 ( 63 0 ) capacitor c=0.00113895f //x=4.725 //y=2.785
c449 ( 49 0 ) capacitor c=0.0154699f //x=11.22 //y=2.77
c450 ( 45 0 ) capacitor c=0.0148628f //x=6.41 //y=2.77
c451 ( 37 0 ) capacitor c=0.0144706f //x=4.56 //y=2.77
c452 ( 31 0 ) capacitor c=0.00103877f //x=3.78 //y=5.335
c453 ( 28 0 ) capacitor c=0.00794348f //x=2.9 //y=5.335
c454 ( 25 0 ) capacitor c=0.0123281f //x=2.022 //y=5.335
c455 ( 24 0 ) capacitor c=0.0598642f //x=11.22 //y=4.755
c456 ( 23 0 ) capacitor c=0.0130987f //x=11.22 //y=2.945
c457 ( 22 0 ) capacitor c=0.00473602f //x=11.22 //y=2.625
c458 ( 21 0 ) capacitor c=0.00495287f //x=11.22 //y=2.375
c459 ( 20 0 ) capacitor c=0.0665949f //x=6.41 //y=4.755
c460 ( 19 0 ) capacitor c=0.0129702f //x=6.41 //y=2.945
c461 ( 18 0 ) capacitor c=0.00482124f //x=6.41 //y=2.625
c462 ( 17 0 ) capacitor c=0.00495287f //x=6.41 //y=2.375
c463 ( 16 0 ) capacitor c=0.070752f //x=4.56 //y=5.25
c464 ( 15 0 ) capacitor c=0.0123217f //x=4.56 //y=2.945
c465 ( 14 0 ) capacitor c=0.0179579f //x=4.56 //y=2.625
c466 ( 12 0 ) capacitor c=0.00584263f //x=4.16 //y=1.845
c467 ( 11 0 ) capacitor c=0.0129788f //x=4.475 //y=1.845
c468 ( 10 0 ) capacitor c=0.0167992f //x=4.075 //y=1.76
c469 ( 9 0 ) capacitor c=0.0110957f //x=4.075 //y=1.305
c470 ( 7 0 ) capacitor c=0.0248757f //x=4.475 //y=5.335
c471 ( 6 0 ) capacitor c=0.00933983f //x=3.78 //y=5.56
c472 ( 3 0 ) capacitor c=0.0200404f //x=3.665 //y=5.335
c473 ( 1 0 ) capacitor c=0.0155354f //x=2.78 //y=5.335
r474 (  172 174 ) resistor r=26.9307 //w=0.15 //l=0.106066 //layer=ply \
 //thickness=0.18 //x=11.785 //y=4.97 //x2=11.86 //y2=5.045
r475 (  172 173 ) resistor r=148.702 //w=0.094 //l=0.29 //layer=ply \
 //thickness=0.18 //x=11.785 //y=4.97 //x2=11.495 //y2=4.97
r476 (  171 192 ) resistor r=45.1352 //w=0.168 //l=0.173853 //layer=ply \
 //thickness=0.18 //x=11.45 //y=1.4 //x2=11.41 //y2=1.555
r477 (  170 191 ) resistor r=45.1352 //w=0.168 //l=0.173853 //layer=ply \
 //thickness=0.18 //x=11.45 //y=1.055 //x2=11.41 //y2=0.9
r478 (  170 171 ) resistor r=176.904 //w=0.094 //l=0.345 //layer=ply \
 //thickness=0.18 //x=11.45 //y=1.055 //x2=11.45 //y2=1.4
r479 (  167 173 ) resistor r=22.7971 //w=0.269 //l=0.106066 //layer=ply \
 //thickness=0.18 //x=11.42 //y=5.045 //x2=11.495 //y2=4.97
r480 (  167 190 ) resistor r=35.8364 //w=0.269 //l=0.270185 //layer=ply \
 //thickness=0.18 //x=11.42 //y=5.045 //x2=11.22 //y2=4.88
r481 (  165 186 ) resistor r=10.701 //w=0.21 //l=0.115 //layer=ply \
 //thickness=0.18 //x=11.075 //y=1.555 //x2=10.96 //y2=1.555
r482 (  164 192 ) resistor r=5.52526 //w=0.168 //l=0.115 //layer=ply \
 //thickness=0.18 //x=11.295 //y=1.555 //x2=11.41 //y2=1.555
r483 (  163 185 ) resistor r=5.52526 //w=0.168 //l=0.115 //layer=ply \
 //thickness=0.18 //x=11.075 //y=0.9 //x2=10.96 //y2=0.9
r484 (  162 191 ) resistor r=5.52526 //w=0.168 //l=0.115 //layer=ply \
 //thickness=0.18 //x=11.295 //y=0.9 //x2=11.41 //y2=0.9
r485 (  162 163 ) resistor r=112.809 //w=0.094 //l=0.22 //layer=ply \
 //thickness=0.18 //x=11.295 //y=0.9 //x2=11.075 //y2=0.9
r486 (  161 188 ) resistor r=58.7805 //w=0.246 //l=0.373497 //layer=ply \
 //thickness=0.18 //x=10.92 //y=2.095 //x2=11.22 //y2=2.26
r487 (  160 186 ) resistor r=39.5823 //w=0.21 //l=0.173853 //layer=ply \
 //thickness=0.18 //x=10.92 //y=1.71 //x2=10.96 //y2=1.555
r488 (  160 161 ) resistor r=197.415 //w=0.094 //l=0.385 //layer=ply \
 //thickness=0.18 //x=10.92 //y=1.71 //x2=10.92 //y2=2.095
r489 (  159 186 ) resistor r=39.5823 //w=0.21 //l=0.173853 //layer=ply \
 //thickness=0.18 //x=10.92 //y=1.4 //x2=10.96 //y2=1.555
r490 (  158 185 ) resistor r=45.1352 //w=0.168 //l=0.173853 //layer=ply \
 //thickness=0.18 //x=10.92 //y=1.055 //x2=10.96 //y2=0.9
r491 (  158 159 ) resistor r=176.904 //w=0.094 //l=0.345 //layer=ply \
 //thickness=0.18 //x=10.92 //y=1.055 //x2=10.92 //y2=1.4
r492 (  153 155 ) resistor r=26.9307 //w=0.15 //l=0.106066 //layer=ply \
 //thickness=0.18 //x=6.975 //y=4.97 //x2=7.05 //y2=5.045
r493 (  153 154 ) resistor r=148.702 //w=0.094 //l=0.29 //layer=ply \
 //thickness=0.18 //x=6.975 //y=4.97 //x2=6.685 //y2=4.97
r494 (  152 184 ) resistor r=45.1352 //w=0.168 //l=0.173853 //layer=ply \
 //thickness=0.18 //x=6.64 //y=1.4 //x2=6.6 //y2=1.555
r495 (  151 183 ) resistor r=45.1352 //w=0.168 //l=0.173853 //layer=ply \
 //thickness=0.18 //x=6.64 //y=1.055 //x2=6.6 //y2=0.9
r496 (  151 152 ) resistor r=176.904 //w=0.094 //l=0.345 //layer=ply \
 //thickness=0.18 //x=6.64 //y=1.055 //x2=6.64 //y2=1.4
r497 (  148 154 ) resistor r=22.7971 //w=0.269 //l=0.106066 //layer=ply \
 //thickness=0.18 //x=6.61 //y=5.045 //x2=6.685 //y2=4.97
r498 (  148 182 ) resistor r=35.8364 //w=0.269 //l=0.270185 //layer=ply \
 //thickness=0.18 //x=6.61 //y=5.045 //x2=6.41 //y2=4.88
r499 (  146 178 ) resistor r=10.701 //w=0.21 //l=0.115 //layer=ply \
 //thickness=0.18 //x=6.265 //y=1.555 //x2=6.15 //y2=1.555
r500 (  145 184 ) resistor r=5.52526 //w=0.168 //l=0.115 //layer=ply \
 //thickness=0.18 //x=6.485 //y=1.555 //x2=6.6 //y2=1.555
r501 (  144 177 ) resistor r=5.52526 //w=0.168 //l=0.115 //layer=ply \
 //thickness=0.18 //x=6.265 //y=0.9 //x2=6.15 //y2=0.9
r502 (  143 183 ) resistor r=5.52526 //w=0.168 //l=0.115 //layer=ply \
 //thickness=0.18 //x=6.485 //y=0.9 //x2=6.6 //y2=0.9
r503 (  143 144 ) resistor r=112.809 //w=0.094 //l=0.22 //layer=ply \
 //thickness=0.18 //x=6.485 //y=0.9 //x2=6.265 //y2=0.9
r504 (  142 180 ) resistor r=58.7805 //w=0.246 //l=0.373497 //layer=ply \
 //thickness=0.18 //x=6.11 //y=2.095 //x2=6.41 //y2=2.26
r505 (  141 178 ) resistor r=39.5823 //w=0.21 //l=0.173853 //layer=ply \
 //thickness=0.18 //x=6.11 //y=1.71 //x2=6.15 //y2=1.555
r506 (  141 142 ) resistor r=197.415 //w=0.094 //l=0.385 //layer=ply \
 //thickness=0.18 //x=6.11 //y=1.71 //x2=6.11 //y2=2.095
r507 (  140 178 ) resistor r=39.5823 //w=0.21 //l=0.173853 //layer=ply \
 //thickness=0.18 //x=6.11 //y=1.4 //x2=6.15 //y2=1.555
r508 (  139 177 ) resistor r=45.1352 //w=0.168 //l=0.173853 //layer=ply \
 //thickness=0.18 //x=6.11 //y=1.055 //x2=6.15 //y2=0.9
r509 (  139 140 ) resistor r=176.904 //w=0.094 //l=0.345 //layer=ply \
 //thickness=0.18 //x=6.11 //y=1.055 //x2=6.11 //y2=1.4
r510 (  138 174 ) resistor r=592.245 //w=0.094 //l=1.155 //layer=ply \
 //thickness=0.18 //x=11.86 //y=6.2 //x2=11.86 //y2=5.045
r511 (  137 167 ) resistor r=592.245 //w=0.094 //l=1.155 //layer=ply \
 //thickness=0.18 //x=11.42 //y=6.2 //x2=11.42 //y2=5.045
r512 (  136 155 ) resistor r=592.245 //w=0.094 //l=1.155 //layer=ply \
 //thickness=0.18 //x=7.05 //y=6.2 //x2=7.05 //y2=5.045
r513 (  135 148 ) resistor r=592.245 //w=0.094 //l=1.155 //layer=ply \
 //thickness=0.18 //x=6.61 //y=6.2 //x2=6.61 //y2=5.045
r514 (  134 164 ) resistor r=56.4043 //w=0.094 //l=0.11 //layer=ply \
 //thickness=0.18 //x=11.185 //y=1.555 //x2=11.295 //y2=1.555
r515 (  134 165 ) resistor r=56.4043 //w=0.094 //l=0.11 //layer=ply \
 //thickness=0.18 //x=11.185 //y=1.555 //x2=11.075 //y2=1.555
r516 (  133 145 ) resistor r=56.4043 //w=0.094 //l=0.11 //layer=ply \
 //thickness=0.18 //x=6.375 //y=1.555 //x2=6.485 //y2=1.555
r517 (  133 146 ) resistor r=56.4043 //w=0.094 //l=0.11 //layer=ply \
 //thickness=0.18 //x=6.375 //y=1.555 //x2=6.265 //y2=1.555
r518 (  129 190 ) resistor r=152 //w=0.17 //l=0.17 //layer=licon //count=1 \
 //x=11.22 //y=4.88 //x2=11.22 //y2=4.88
r519 (  120 188 ) resistor r=152 //w=0.17 //l=0.17 //layer=licon //count=1 \
 //x=11.22 //y=2.26 //x2=11.22 //y2=2.26
r520 (  115 182 ) resistor r=152 //w=0.17 //l=0.17 //layer=licon //count=1 \
 //x=6.41 //y=4.88 //x2=6.41 //y2=4.88
r521 (  106 180 ) resistor r=152 //w=0.17 //l=0.17 //layer=licon //count=1 \
 //x=6.41 //y=2.26 //x2=6.41 //y2=2.26
r522 (  89 197 ) resistor r=23.615 //w=0.187 //l=0.345 //layer=li \
 //thickness=0.1 //x=3.78 //y=5.56 //x2=3.78 //y2=5.905
r523 (  81 196 ) resistor r=23.615 //w=0.187 //l=0.345 //layer=li \
 //thickness=0.1 //x=2.9 //y=5.56 //x2=2.9 //y2=5.905
r524 (  73 195 ) resistor r=23.615 //w=0.187 //l=0.345 //layer=li \
 //thickness=0.1 //x=2.02 //y=5.56 //x2=2.02 //y2=5.905
r525 (  69 70 ) resistor r=0.10734 //w=0.281 //l=0.16 //layer=m2 \
 //thickness=0.36 //x=11.22 //y=2.785 //x2=11.06 //y2=2.785
r526 (  67 70 ) resistor r=4.27958 //w=0.131 //l=4.485 //layer=m2 \
 //thickness=0.36 //x=6.575 //y=2.77 //x2=11.06 //y2=2.77
r527 (  65 67 ) resistor r=0.10734 //w=0.281 //l=0.16 //layer=m2 \
 //thickness=0.36 //x=6.415 //y=2.785 //x2=6.575 //y2=2.785
r528 (  65 66 ) resistor r=0.10734 //w=0.281 //l=0.16 //layer=m2 \
 //thickness=0.36 //x=6.415 //y=2.785 //x2=6.255 //y2=2.785
r529 (  63 66 ) resistor r=1.45992 //w=0.131 //l=1.53 //layer=m2 \
 //thickness=0.36 //x=4.725 //y=2.77 //x2=6.255 //y2=2.77
r530 (  61 63 ) resistor r=0.10734 //w=0.281 //l=0.16 //layer=m2 \
 //thickness=0.36 //x=4.565 //y=2.785 //x2=4.725 //y2=2.785
r531 (  55 129 ) resistor r=9.3 //w=0.17 //l=0.17 //layer=mcon //count=1 \
 //x=11.22 //y=4.88 //x2=11.22 //y2=4.88
r532 (  53 120 ) resistor r=9.3 //w=0.17 //l=0.17 //layer=mcon //count=1 \
 //x=11.22 //y=2.26 //x2=11.22 //y2=2.26
r533 (  51 69 ) resistor r=4.5 //w=0.15 //l=0.15 //layer=via1 //count=1 \
 //x=11.22 //y=2.785 //x2=11.22 //y2=2.785
r534 (  49 51 ) resistor r=0.0049867 //w=0.376 //l=0.015 //layer=m1 \
 //thickness=0.36 //x=11.167 //y=2.77 //x2=11.167 //y2=2.785
r535 (  47 65 ) resistor r=4.5 //w=0.15 //l=0.15 //layer=via1 //count=1 \
 //x=6.415 //y=2.785 //x2=6.415 //y2=2.785
r536 (  45 47 ) resistor r=0.00501337 //w=0.374 //l=0.015 //layer=m1 \
 //thickness=0.36 //x=6.465 //y=2.77 //x2=6.465 //y2=2.785
r537 (  43 115 ) resistor r=9.3 //w=0.17 //l=0.17 //layer=mcon //count=1 \
 //x=6.41 //y=4.88 //x2=6.41 //y2=4.88
r538 (  41 106 ) resistor r=9.3 //w=0.17 //l=0.17 //layer=mcon //count=1 \
 //x=6.41 //y=2.26 //x2=6.41 //y2=2.26
r539 (  39 61 ) resistor r=4.5 //w=0.15 //l=0.15 //layer=via1 //count=1 \
 //x=4.565 //y=2.785 //x2=4.565 //y2=2.785
r540 (  37 39 ) resistor r=0.00501337 //w=0.374 //l=0.015 //layer=m1 \
 //thickness=0.36 //x=4.615 //y=2.77 //x2=4.615 //y2=2.785
r541 (  35 193 ) resistor r=9.3 //w=0.17 //l=0.17 //layer=mcon //count=1 \
 //x=4.075 //y=1.19 //x2=4.075 //y2=1.19
r542 (  33 89 ) resistor r=9.3 //w=0.17 //l=0.17 //layer=mcon //count=1 \
 //x=3.78 //y=5.56 //x2=3.78 //y2=5.56
r543 (  30 81 ) resistor r=9.3 //w=0.17 //l=0.17 //layer=mcon //count=1 \
 //x=2.9 //y=5.56 //x2=2.9 //y2=5.56
r544 (  28 30 ) resistor r=0.121228 //w=0.232 //l=0.225 //layer=m1 \
 //thickness=0.36 //x=2.9 //y=5.335 //x2=2.9 //y2=5.56
r545 (  27 73 ) resistor r=9.3 //w=0.17 //l=0.17 //layer=mcon //count=1 \
 //x=2.02 //y=5.56 //x2=2.02 //y2=5.56
r546 (  25 27 ) resistor r=0.129608 //w=0.217 //l=0.225 //layer=m1 \
 //thickness=0.36 //x=2.022 //y=5.335 //x2=2.022 //y2=5.56
r547 (  24 55 ) resistor r=0.0760407 //w=0.238 //l=0.125 //layer=m1 \
 //thickness=0.36 //x=11.22 //y=4.755 //x2=11.22 //y2=4.88
r548 (  23 51 ) resistor r=0.0911593 //w=0.376 //l=0.184608 //layer=m1 \
 //thickness=0.36 //x=11.22 //y=2.945 //x2=11.167 //y2=2.785
r549 (  23 24 ) resistor r=1.7271 //w=0.131 //l=1.81 //layer=m1 \
 //thickness=0.36 //x=11.22 //y=2.945 //x2=11.22 //y2=4.755
r550 (  22 49 ) resistor r=0.0861726 //w=0.376 //l=0.16944 //layer=m1 \
 //thickness=0.36 //x=11.22 //y=2.625 //x2=11.167 //y2=2.77
r551 (  21 53 ) resistor r=0.0719237 //w=0.222 //l=0.115 //layer=m1 \
 //thickness=0.36 //x=11.22 //y=2.375 //x2=11.22 //y2=2.26
r552 (  21 22 ) resistor r=0.23855 //w=0.131 //l=0.25 //layer=m1 \
 //thickness=0.36 //x=11.22 //y=2.375 //x2=11.22 //y2=2.625
r553 (  20 43 ) resistor r=0.0760407 //w=0.238 //l=0.125 //layer=m1 \
 //thickness=0.36 //x=6.41 //y=4.755 //x2=6.41 //y2=4.88
r554 (  19 47 ) resistor r=0.0910802 //w=0.374 //l=0.185472 //layer=m1 \
 //thickness=0.36 //x=6.41 //y=2.945 //x2=6.465 //y2=2.785
r555 (  19 20 ) resistor r=1.7271 //w=0.131 //l=1.81 //layer=m1 \
 //thickness=0.36 //x=6.41 //y=2.945 //x2=6.41 //y2=4.755
r556 (  18 45 ) resistor r=0.0860668 //w=0.374 //l=0.170294 //layer=m1 \
 //thickness=0.36 //x=6.41 //y=2.625 //x2=6.465 //y2=2.77
r557 (  17 41 ) resistor r=0.0719237 //w=0.222 //l=0.115 //layer=m1 \
 //thickness=0.36 //x=6.41 //y=2.375 //x2=6.41 //y2=2.26
r558 (  17 18 ) resistor r=0.23855 //w=0.131 //l=0.25 //layer=m1 \
 //thickness=0.36 //x=6.41 //y=2.375 //x2=6.41 //y2=2.625
r559 (  15 39 ) resistor r=0.0910802 //w=0.374 //l=0.185472 //layer=m1 \
 //thickness=0.36 //x=4.56 //y=2.945 //x2=4.615 //y2=2.785
r560 (  15 16 ) resistor r=2.19943 //w=0.131 //l=2.305 //layer=m1 \
 //thickness=0.36 //x=4.56 //y=2.945 //x2=4.56 //y2=5.25
r561 (  14 37 ) resistor r=0.0860668 //w=0.374 //l=0.170294 //layer=m1 \
 //thickness=0.36 //x=4.56 //y=2.625 //x2=4.615 //y2=2.77
r562 (  13 14 ) resistor r=0.663168 //w=0.131 //l=0.695 //layer=m1 \
 //thickness=0.36 //x=4.56 //y=1.93 //x2=4.56 //y2=2.625
r563 (  11 13 ) resistor r=0.0698411 //w=0.17 //l=0.120208 //layer=m1 \
 //thickness=0.36 //x=4.475 //y=1.845 //x2=4.56 //y2=1.93
r564 (  11 12 ) resistor r=0.300573 //w=0.131 //l=0.315 //layer=m1 \
 //thickness=0.36 //x=4.475 //y=1.845 //x2=4.16 //y2=1.845
r565 (  10 12 ) resistor r=0.0698411 //w=0.17 //l=0.120208 //layer=m1 \
 //thickness=0.36 //x=4.075 //y=1.76 //x2=4.16 //y2=1.845
r566 (  9 35 ) resistor r=0.0717383 //w=0.224 //l=0.115 //layer=m1 \
 //thickness=0.36 //x=4.075 //y=1.305 //x2=4.075 //y2=1.19
r567 (  9 10 ) resistor r=0.43416 //w=0.131 //l=0.455 //layer=m1 \
 //thickness=0.36 //x=4.075 //y=1.305 //x2=4.075 //y2=1.76
r568 (  8 31 ) resistor r=0.0675342 //w=0.23 //l=0.115 //layer=m1 \
 //thickness=0.36 //x=3.895 //y=5.335 //x2=3.78 //y2=5.335
r569 (  7 16 ) resistor r=0.0698411 //w=0.17 //l=0.120208 //layer=m1 \
 //thickness=0.36 //x=4.475 //y=5.335 //x2=4.56 //y2=5.25
r570 (  7 8 ) resistor r=0.553435 //w=0.131 //l=0.58 //layer=m1 \
 //thickness=0.36 //x=4.475 //y=5.335 //x2=3.895 //y2=5.335
r571 (  6 33 ) resistor r=0.00118313 //w=0.23 //layer=m1 //thickness=0.36 \
 //x=3.78 //y=5.56 //x2=3.78 //y2=5.56
r572 (  5 31 ) resistor r=0.002872 //w=0.34 //l=0.085 //layer=m1 \
 //thickness=0.36 //x=3.78 //y=5.42 //x2=3.78 //y2=5.335
r573 (  5 6 ) resistor r=0.091623 //w=0.191 //l=0.14 //layer=m1 \
 //thickness=0.36 //x=3.78 //y=5.42 //x2=3.78 //y2=5.56
r574 (  4 28 ) resistor r=0.0262263 //w=0.232 //l=0.12 //layer=m1 \
 //thickness=0.36 //x=3.02 //y=5.335 //x2=2.9 //y2=5.335
r575 (  3 31 ) resistor r=0.0675342 //w=0.23 //l=0.115 //layer=m1 \
 //thickness=0.36 //x=3.665 //y=5.335 //x2=3.78 //y2=5.335
r576 (  3 4 ) resistor r=0.615458 //w=0.131 //l=0.645 //layer=m1 \
 //thickness=0.36 //x=3.665 //y=5.335 //x2=3.02 //y2=5.335
r577 (  2 25 ) resistor r=0.0222262 //w=0.217 //l=0.118 //layer=m1 \
 //thickness=0.36 //x=2.14 //y=5.335 //x2=2.022 //y2=5.335
r578 (  1 28 ) resistor r=0.0262263 //w=0.232 //l=0.12 //layer=m1 \
 //thickness=0.36 //x=2.78 //y=5.335 //x2=2.9 //y2=5.335
r579 (  1 2 ) resistor r=0.610687 //w=0.131 //l=0.64 //layer=m1 \
 //thickness=0.36 //x=2.78 //y=5.335 //x2=2.14 //y2=5.335
ends PM_TMRDFFSNRNQNX1\%noxref_1

subckt PM_TMRDFFSNRNQNX1\%noxref_2 ( 1 3 6 7 9 10 11 12 14 15 16 17 18 19 20 \
 21 24 27 33 36 42 43 48 51 59 67 84 93 97 98 99 100 101 102 103 104 106 112 \
 113 114 115 127 129 130 131 )
c293 ( 127 0 ) capacitor c=0.00885916f //x=13.505 //y=1.095
c294 ( 115 0 ) capacitor c=0.0612936f //x=16.305 //y=4.97
c295 ( 114 0 ) capacitor c=0.0376642f //x=16.595 //y=4.97
c296 ( 113 0 ) capacitor c=0.0346489f //x=16.26 //y=1.4
c297 ( 112 0 ) capacitor c=0.018692f //x=16.26 //y=1.055
c298 ( 106 0 ) capacitor c=0.0137077f //x=16.105 //y=1.555
c299 ( 104 0 ) capacitor c=0.0158585f //x=16.105 //y=0.9
c300 ( 103 0 ) capacitor c=0.0979523f //x=15.73 //y=2.095
c301 ( 102 0 ) capacitor c=0.0229444f //x=15.73 //y=1.71
c302 ( 101 0 ) capacitor c=0.0234359f //x=15.73 //y=1.4
c303 ( 100 0 ) capacitor c=0.019815f //x=15.73 //y=1.055
c304 ( 99 0 ) capacitor c=0.110208f //x=16.67 //y=6.2
c305 ( 98 0 ) capacitor c=0.158957f //x=16.23 //y=6.2
c306 ( 93 0 ) capacitor c=0.0014751f //x=16.03 //y=4.88
c307 ( 84 0 ) capacitor c=9.93222e-19 //x=16.03 //y=2.26
c308 ( 67 0 ) capacitor c=0.0293723f //x=13.4 //y=5.56
c309 ( 59 0 ) capacitor c=0.029137f //x=12.52 //y=5.56
c310 ( 51 0 ) capacitor c=0.0278099f //x=11.64 //y=5.56
c311 ( 48 0 ) capacitor c=6.57651e-19 //x=16.04 //y=2.77
c312 ( 43 0 ) capacitor c=9.44624e-19 //x=14.34 //y=2.77
c313 ( 42 0 ) capacitor c=0.0155215f //x=15.88 //y=2.77
c314 ( 36 0 ) capacitor c=0.0146045f //x=16.03 //y=2.77
c315 ( 33 0 ) capacitor c=0.0146969f //x=14.18 //y=2.77
c316 ( 27 0 ) capacitor c=8.8245e-19 //x=13.4 //y=5.335
c317 ( 24 0 ) capacitor c=0.00726074f //x=12.52 //y=5.335
c318 ( 21 0 ) capacitor c=0.0111234f //x=11.642 //y=5.335
c319 ( 20 0 ) capacitor c=0.0633726f //x=16.03 //y=4.755
c320 ( 19 0 ) capacitor c=0.0131932f //x=16.03 //y=2.93
c321 ( 18 0 ) capacitor c=0.00432188f //x=16.03 //y=2.61
c322 ( 17 0 ) capacitor c=0.00485584f //x=16.03 //y=2.375
c323 ( 16 0 ) capacitor c=0.064515f //x=14.18 //y=5.25
c324 ( 15 0 ) capacitor c=0.0122936f //x=14.18 //y=2.93
c325 ( 14 0 ) capacitor c=0.0181662f //x=14.18 //y=2.61
c326 ( 12 0 ) capacitor c=0.00493487f //x=13.78 //y=1.845
c327 ( 11 0 ) capacitor c=0.0129068f //x=14.095 //y=1.845
c328 ( 10 0 ) capacitor c=0.0167992f //x=13.695 //y=1.76
c329 ( 9 0 ) capacitor c=0.0112867f //x=13.695 //y=1.305
c330 ( 7 0 ) capacitor c=0.0236685f //x=14.095 //y=5.335
c331 ( 6 0 ) capacitor c=0.00933983f //x=13.4 //y=5.56
c332 ( 3 0 ) capacitor c=0.0180822f //x=13.285 //y=5.335
c333 ( 1 0 ) capacitor c=0.0151332f //x=12.4 //y=5.335
r334 (  114 116 ) resistor r=26.9307 //w=0.15 //l=0.106066 //layer=ply \
 //thickness=0.18 //x=16.595 //y=4.97 //x2=16.67 //y2=5.045
r335 (  114 115 ) resistor r=148.702 //w=0.094 //l=0.29 //layer=ply \
 //thickness=0.18 //x=16.595 //y=4.97 //x2=16.305 //y2=4.97
r336 (  113 126 ) resistor r=45.1352 //w=0.168 //l=0.173853 //layer=ply \
 //thickness=0.18 //x=16.26 //y=1.4 //x2=16.22 //y2=1.555
r337 (  112 125 ) resistor r=45.1352 //w=0.168 //l=0.173853 //layer=ply \
 //thickness=0.18 //x=16.26 //y=1.055 //x2=16.22 //y2=0.9
r338 (  112 113 ) resistor r=176.904 //w=0.094 //l=0.345 //layer=ply \
 //thickness=0.18 //x=16.26 //y=1.055 //x2=16.26 //y2=1.4
r339 (  109 115 ) resistor r=22.7971 //w=0.269 //l=0.106066 //layer=ply \
 //thickness=0.18 //x=16.23 //y=5.045 //x2=16.305 //y2=4.97
r340 (  109 124 ) resistor r=35.8364 //w=0.269 //l=0.270185 //layer=ply \
 //thickness=0.18 //x=16.23 //y=5.045 //x2=16.03 //y2=4.88
r341 (  107 120 ) resistor r=10.701 //w=0.21 //l=0.115 //layer=ply \
 //thickness=0.18 //x=15.885 //y=1.555 //x2=15.77 //y2=1.555
r342 (  106 126 ) resistor r=5.52526 //w=0.168 //l=0.115 //layer=ply \
 //thickness=0.18 //x=16.105 //y=1.555 //x2=16.22 //y2=1.555
r343 (  105 119 ) resistor r=5.52526 //w=0.168 //l=0.115 //layer=ply \
 //thickness=0.18 //x=15.885 //y=0.9 //x2=15.77 //y2=0.9
r344 (  104 125 ) resistor r=5.52526 //w=0.168 //l=0.115 //layer=ply \
 //thickness=0.18 //x=16.105 //y=0.9 //x2=16.22 //y2=0.9
r345 (  104 105 ) resistor r=112.809 //w=0.094 //l=0.22 //layer=ply \
 //thickness=0.18 //x=16.105 //y=0.9 //x2=15.885 //y2=0.9
r346 (  103 122 ) resistor r=58.7805 //w=0.246 //l=0.373497 //layer=ply \
 //thickness=0.18 //x=15.73 //y=2.095 //x2=16.03 //y2=2.26
r347 (  102 120 ) resistor r=39.5823 //w=0.21 //l=0.173853 //layer=ply \
 //thickness=0.18 //x=15.73 //y=1.71 //x2=15.77 //y2=1.555
r348 (  102 103 ) resistor r=197.415 //w=0.094 //l=0.385 //layer=ply \
 //thickness=0.18 //x=15.73 //y=1.71 //x2=15.73 //y2=2.095
r349 (  101 120 ) resistor r=39.5823 //w=0.21 //l=0.173853 //layer=ply \
 //thickness=0.18 //x=15.73 //y=1.4 //x2=15.77 //y2=1.555
r350 (  100 119 ) resistor r=45.1352 //w=0.168 //l=0.173853 //layer=ply \
 //thickness=0.18 //x=15.73 //y=1.055 //x2=15.77 //y2=0.9
r351 (  100 101 ) resistor r=176.904 //w=0.094 //l=0.345 //layer=ply \
 //thickness=0.18 //x=15.73 //y=1.055 //x2=15.73 //y2=1.4
r352 (  99 116 ) resistor r=592.245 //w=0.094 //l=1.155 //layer=ply \
 //thickness=0.18 //x=16.67 //y=6.2 //x2=16.67 //y2=5.045
r353 (  98 109 ) resistor r=592.245 //w=0.094 //l=1.155 //layer=ply \
 //thickness=0.18 //x=16.23 //y=6.2 //x2=16.23 //y2=5.045
r354 (  97 106 ) resistor r=56.4043 //w=0.094 //l=0.11 //layer=ply \
 //thickness=0.18 //x=15.995 //y=1.555 //x2=16.105 //y2=1.555
r355 (  97 107 ) resistor r=56.4043 //w=0.094 //l=0.11 //layer=ply \
 //thickness=0.18 //x=15.995 //y=1.555 //x2=15.885 //y2=1.555
r356 (  93 124 ) resistor r=152 //w=0.17 //l=0.17 //layer=licon //count=1 \
 //x=16.03 //y=4.88 //x2=16.03 //y2=4.88
r357 (  84 122 ) resistor r=152 //w=0.17 //l=0.17 //layer=licon //count=1 \
 //x=16.03 //y=2.26 //x2=16.03 //y2=2.26
r358 (  67 131 ) resistor r=23.615 //w=0.187 //l=0.345 //layer=li \
 //thickness=0.1 //x=13.4 //y=5.56 //x2=13.4 //y2=5.905
r359 (  59 130 ) resistor r=23.615 //w=0.187 //l=0.345 //layer=li \
 //thickness=0.1 //x=12.52 //y=5.56 //x2=12.52 //y2=5.905
r360 (  51 129 ) resistor r=23.615 //w=0.187 //l=0.345 //layer=li \
 //thickness=0.1 //x=11.64 //y=5.56 //x2=11.64 //y2=5.905
r361 (  43 45 ) resistor r=0.10734 //w=0.281 //l=0.16 //layer=m2 \
 //thickness=0.36 //x=14.34 //y=2.77 //x2=14.18 //y2=2.77
r362 (  42 48 ) resistor r=0.10734 //w=0.281 //l=0.16 //layer=m2 \
 //thickness=0.36 //x=15.88 //y=2.77 //x2=16.04 //y2=2.77
r363 (  42 43 ) resistor r=1.46947 //w=0.131 //l=1.54 //layer=m2 \
 //thickness=0.36 //x=15.88 //y=2.77 //x2=14.34 //y2=2.77
r364 (  41 93 ) resistor r=9.3 //w=0.17 //l=0.17 //layer=mcon //count=1 \
 //x=16.03 //y=4.88 //x2=16.03 //y2=4.88
r365 (  39 84 ) resistor r=9.3 //w=0.17 //l=0.17 //layer=mcon //count=1 \
 //x=16.03 //y=2.26 //x2=16.03 //y2=2.26
r366 (  36 48 ) resistor r=4.5 //w=0.15 //l=0.15 //layer=via1 //count=1 \
 //x=16.04 //y=2.77 //x2=16.04 //y2=2.77
r367 (  33 45 ) resistor r=4.5 //w=0.15 //l=0.15 //layer=via1 //count=1 \
 //x=14.18 //y=2.77 //x2=14.18 //y2=2.77
r368 (  31 127 ) resistor r=9.3 //w=0.17 //l=0.17 //layer=mcon //count=1 \
 //x=13.695 //y=1.19 //x2=13.695 //y2=1.19
r369 (  29 67 ) resistor r=9.3 //w=0.17 //l=0.17 //layer=mcon //count=1 \
 //x=13.4 //y=5.56 //x2=13.4 //y2=5.56
r370 (  26 59 ) resistor r=9.3 //w=0.17 //l=0.17 //layer=mcon //count=1 \
 //x=12.52 //y=5.56 //x2=12.52 //y2=5.56
r371 (  24 26 ) resistor r=0.121228 //w=0.232 //l=0.225 //layer=m1 \
 //thickness=0.36 //x=12.52 //y=5.335 //x2=12.52 //y2=5.56
r372 (  23 51 ) resistor r=9.3 //w=0.17 //l=0.17 //layer=mcon //count=1 \
 //x=11.64 //y=5.56 //x2=11.64 //y2=5.56
r373 (  21 23 ) resistor r=0.129608 //w=0.217 //l=0.225 //layer=m1 \
 //thickness=0.36 //x=11.642 //y=5.335 //x2=11.642 //y2=5.56
r374 (  20 41 ) resistor r=0.0760407 //w=0.238 //l=0.125 //layer=m1 \
 //thickness=0.36 //x=16.03 //y=4.755 //x2=16.03 //y2=4.88
r375 (  19 36 ) resistor r=0.0914072 //w=0.382 //l=0.182428 //layer=m1 \
 //thickness=0.36 //x=16.03 //y=2.93 //x2=15.982 //y2=2.77
r376 (  19 20 ) resistor r=1.74141 //w=0.131 //l=1.825 //layer=m1 \
 //thickness=0.36 //x=16.03 //y=2.93 //x2=16.03 //y2=4.755
r377 (  18 36 ) resistor r=0.0914072 //w=0.382 //l=0.182428 //layer=m1 \
 //thickness=0.36 //x=16.03 //y=2.61 //x2=15.982 //y2=2.77
r378 (  17 39 ) resistor r=0.0719237 //w=0.222 //l=0.115 //layer=m1 \
 //thickness=0.36 //x=16.03 //y=2.375 //x2=16.03 //y2=2.26
r379 (  17 18 ) resistor r=0.224237 //w=0.131 //l=0.235 //layer=m1 \
 //thickness=0.36 //x=16.03 //y=2.375 //x2=16.03 //y2=2.61
r380 (  15 33 ) resistor r=0.0911593 //w=0.376 //l=0.184174 //layer=m1 \
 //thickness=0.36 //x=14.18 //y=2.93 //x2=14.232 //y2=2.77
r381 (  15 16 ) resistor r=2.21374 //w=0.131 //l=2.32 //layer=m1 \
 //thickness=0.36 //x=14.18 //y=2.93 //x2=14.18 //y2=5.25
r382 (  14 33 ) resistor r=0.0911593 //w=0.376 //l=0.184174 //layer=m1 \
 //thickness=0.36 //x=14.18 //y=2.61 //x2=14.232 //y2=2.77
r383 (  13 14 ) resistor r=0.648855 //w=0.131 //l=0.68 //layer=m1 \
 //thickness=0.36 //x=14.18 //y=1.93 //x2=14.18 //y2=2.61
r384 (  11 13 ) resistor r=0.0698411 //w=0.17 //l=0.120208 //layer=m1 \
 //thickness=0.36 //x=14.095 //y=1.845 //x2=14.18 //y2=1.93
r385 (  11 12 ) resistor r=0.300573 //w=0.131 //l=0.315 //layer=m1 \
 //thickness=0.36 //x=14.095 //y=1.845 //x2=13.78 //y2=1.845
r386 (  10 12 ) resistor r=0.0698411 //w=0.17 //l=0.120208 //layer=m1 \
 //thickness=0.36 //x=13.695 //y=1.76 //x2=13.78 //y2=1.845
r387 (  9 31 ) resistor r=0.0717383 //w=0.224 //l=0.115 //layer=m1 \
 //thickness=0.36 //x=13.695 //y=1.305 //x2=13.695 //y2=1.19
r388 (  9 10 ) resistor r=0.43416 //w=0.131 //l=0.455 //layer=m1 \
 //thickness=0.36 //x=13.695 //y=1.305 //x2=13.695 //y2=1.76
r389 (  8 27 ) resistor r=0.0675342 //w=0.23 //l=0.115 //layer=m1 \
 //thickness=0.36 //x=13.515 //y=5.335 //x2=13.4 //y2=5.335
r390 (  7 16 ) resistor r=0.0698411 //w=0.17 //l=0.120208 //layer=m1 \
 //thickness=0.36 //x=14.095 //y=5.335 //x2=14.18 //y2=5.25
r391 (  7 8 ) resistor r=0.553435 //w=0.131 //l=0.58 //layer=m1 \
 //thickness=0.36 //x=14.095 //y=5.335 //x2=13.515 //y2=5.335
r392 (  6 29 ) resistor r=0.00118313 //w=0.23 //layer=m1 //thickness=0.36 \
 //x=13.4 //y=5.56 //x2=13.4 //y2=5.56
r393 (  5 27 ) resistor r=0.002872 //w=0.34 //l=0.085 //layer=m1 \
 //thickness=0.36 //x=13.4 //y=5.42 //x2=13.4 //y2=5.335
r394 (  5 6 ) resistor r=0.091623 //w=0.191 //l=0.14 //layer=m1 \
 //thickness=0.36 //x=13.4 //y=5.42 //x2=13.4 //y2=5.56
r395 (  4 24 ) resistor r=0.0262263 //w=0.232 //l=0.12 //layer=m1 \
 //thickness=0.36 //x=12.64 //y=5.335 //x2=12.52 //y2=5.335
r396 (  3 27 ) resistor r=0.0675342 //w=0.23 //l=0.115 //layer=m1 \
 //thickness=0.36 //x=13.285 //y=5.335 //x2=13.4 //y2=5.335
r397 (  3 4 ) resistor r=0.615458 //w=0.131 //l=0.645 //layer=m1 \
 //thickness=0.36 //x=13.285 //y=5.335 //x2=12.64 //y2=5.335
r398 (  2 21 ) resistor r=0.0222262 //w=0.217 //l=0.118 //layer=m1 \
 //thickness=0.36 //x=11.76 //y=5.335 //x2=11.642 //y2=5.335
r399 (  1 24 ) resistor r=0.0262263 //w=0.232 //l=0.12 //layer=m1 \
 //thickness=0.36 //x=12.4 //y=5.335 //x2=12.52 //y2=5.335
r400 (  1 2 ) resistor r=0.610687 //w=0.131 //l=0.64 //layer=m1 \
 //thickness=0.36 //x=12.4 //y=5.335 //x2=11.76 //y2=5.335
ends PM_TMRDFFSNRNQNX1\%noxref_2

subckt PM_TMRDFFSNRNQNX1\%noxref_3 ( 1 2 3 4 5 7 10 11 13 14 15 16 18 19 20 21 \
 22 23 24 30 33 36 39 47 49 57 62 65 66 68 71 80 85 93 101 118 127 131 132 133 \
 134 135 136 140 141 142 147 149 152 153 154 155 156 157 158 160 166 167 168 \
 169 174 175 180 191 193 194 195 )
c470 ( 191 0 ) capacitor c=0.00885916f //x=8.695 //y=1.095
c471 ( 180 0 ) capacitor c=0.0710579f //x=3.82 //y=4.88
c472 ( 175 0 ) capacitor c=0.0278202f //x=3.82 //y=2.095
c473 ( 174 0 ) capacitor c=0.0479349f //x=3.82 //y=2.26
c474 ( 169 0 ) capacitor c=0.0612936f //x=21.115 //y=4.97
c475 ( 168 0 ) capacitor c=0.0376642f //x=21.405 //y=4.97
c476 ( 167 0 ) capacitor c=0.0346489f //x=21.07 //y=1.4
c477 ( 166 0 ) capacitor c=0.018692f //x=21.07 //y=1.055
c478 ( 160 0 ) capacitor c=0.0137077f //x=20.915 //y=1.555
c479 ( 158 0 ) capacitor c=0.0158585f //x=20.915 //y=0.9
c480 ( 157 0 ) capacitor c=0.10101f //x=20.54 //y=2.095
c481 ( 156 0 ) capacitor c=0.0229444f //x=20.54 //y=1.71
c482 ( 155 0 ) capacitor c=0.0234359f //x=20.54 //y=1.4
c483 ( 154 0 ) capacitor c=0.019815f //x=20.54 //y=1.055
c484 ( 153 0 ) capacitor c=0.0443175f //x=4.34 //y=1.44
c485 ( 152 0 ) capacitor c=0.0199703f //x=4.34 //y=1.095
c486 ( 149 0 ) capacitor c=0.0162526f //x=4.185 //y=1.595
c487 ( 147 0 ) capacitor c=0.0157807f //x=4.185 //y=0.94
c488 ( 142 0 ) capacitor c=0.0220935f //x=3.81 //y=1.75
c489 ( 141 0 ) capacitor c=0.0207489f //x=3.81 //y=1.44
c490 ( 140 0 ) capacitor c=0.0194091f //x=3.81 //y=1.095
c491 ( 136 0 ) capacitor c=0.110208f //x=21.48 //y=6.2
c492 ( 135 0 ) capacitor c=0.158957f //x=21.04 //y=6.2
c493 ( 134 0 ) capacitor c=0.159671f //x=4 //y=6.2
c494 ( 133 0 ) capacitor c=0.110208f //x=3.56 //y=6.2
c495 ( 127 0 ) capacitor c=0.0014751f //x=20.84 //y=4.88
c496 ( 118 0 ) capacitor c=0.0012618f //x=20.84 //y=2.26
c497 ( 101 0 ) capacitor c=0.0293723f //x=8.59 //y=5.56
c498 ( 93 0 ) capacitor c=0.029137f //x=7.71 //y=5.56
c499 ( 85 0 ) capacitor c=0.0278099f //x=6.83 //y=5.56
c500 ( 80 0 ) capacitor c=7.7417e-19 //x=3.82 //y=4.88
c501 ( 71 0 ) capacitor c=0.00101179f //x=3.82 //y=2.26
c502 ( 68 0 ) capacitor c=4.92288e-19 //x=20.835 //y=3.51
c503 ( 66 0 ) capacitor c=8.37596e-19 //x=9.53 //y=3.495
c504 ( 65 0 ) capacitor c=0.071237f //x=9.21 //y=3.495
c505 ( 62 0 ) capacitor c=9.84133e-19 //x=3.99 //y=3.515
c506 ( 57 0 ) capacitor c=0.121226f //x=20.675 //y=3.51
c507 ( 49 0 ) capacitor c=0.0169562f //x=20.835 //y=3.51
c508 ( 47 0 ) capacitor c=0.0158593f //x=9.37 //y=3.51
c509 ( 39 0 ) capacitor c=8.8245e-19 //x=8.59 //y=5.335
c510 ( 36 0 ) capacitor c=0.00740623f //x=7.71 //y=5.335
c511 ( 33 0 ) capacitor c=0.0113499f //x=6.832 //y=5.335
c512 ( 30 0 ) capacitor c=0.0150828f //x=3.82 //y=3.51
c513 ( 24 0 ) capacitor c=0.037614f //x=20.84 //y=4.755
c514 ( 23 0 ) capacitor c=0.0144231f //x=20.84 //y=3.67
c515 ( 22 0 ) capacitor c=0.0280962f //x=20.84 //y=3.35
c516 ( 21 0 ) capacitor c=0.00493552f //x=20.84 //y=2.375
c517 ( 20 0 ) capacitor c=0.0426794f //x=9.37 //y=5.25
c518 ( 19 0 ) capacitor c=0.0133594f //x=9.37 //y=3.655
c519 ( 18 0 ) capacitor c=0.0401079f //x=9.37 //y=3.335
c520 ( 16 0 ) capacitor c=0.0048771f //x=8.97 //y=1.845
c521 ( 15 0 ) capacitor c=0.0132685f //x=9.285 //y=1.845
c522 ( 14 0 ) capacitor c=0.0167992f //x=8.885 //y=1.76
c523 ( 13 0 ) capacitor c=0.0113147f //x=8.885 //y=1.305
c524 ( 11 0 ) capacitor c=0.0228465f //x=9.285 //y=5.335
c525 ( 10 0 ) capacitor c=0.00933983f //x=8.59 //y=5.56
c526 ( 7 0 ) capacitor c=0.019444f //x=8.475 //y=5.335
c527 ( 5 0 ) capacitor c=0.0149475f //x=7.59 //y=5.335
c528 ( 4 0 ) capacitor c=0.0329827f //x=3.82 //y=4.75
c529 ( 3 0 ) capacitor c=0.0122381f //x=3.82 //y=3.675
c530 ( 2 0 ) capacitor c=0.0243464f //x=3.82 //y=3.355
c531 ( 1 0 ) capacitor c=0.005545f //x=3.82 //y=2.375
r532 (  174 175 ) resistor r=52.7279 //w=0.214 //l=0.165 //layer=ply \
 //thickness=0.18 //x=3.82 //y=2.26 //x2=3.82 //y2=2.095
r533 (  168 170 ) resistor r=26.9307 //w=0.15 //l=0.106066 //layer=ply \
 //thickness=0.18 //x=21.405 //y=4.97 //x2=21.48 //y2=5.045
r534 (  168 169 ) resistor r=148.702 //w=0.094 //l=0.29 //layer=ply \
 //thickness=0.18 //x=21.405 //y=4.97 //x2=21.115 //y2=4.97
r535 (  167 190 ) resistor r=45.1352 //w=0.168 //l=0.173853 //layer=ply \
 //thickness=0.18 //x=21.07 //y=1.4 //x2=21.03 //y2=1.555
r536 (  166 189 ) resistor r=45.1352 //w=0.168 //l=0.173853 //layer=ply \
 //thickness=0.18 //x=21.07 //y=1.055 //x2=21.03 //y2=0.9
r537 (  166 167 ) resistor r=176.904 //w=0.094 //l=0.345 //layer=ply \
 //thickness=0.18 //x=21.07 //y=1.055 //x2=21.07 //y2=1.4
r538 (  163 169 ) resistor r=22.7971 //w=0.269 //l=0.106066 //layer=ply \
 //thickness=0.18 //x=21.04 //y=5.045 //x2=21.115 //y2=4.97
r539 (  163 188 ) resistor r=35.8364 //w=0.269 //l=0.270185 //layer=ply \
 //thickness=0.18 //x=21.04 //y=5.045 //x2=20.84 //y2=4.88
r540 (  161 184 ) resistor r=10.701 //w=0.21 //l=0.115 //layer=ply \
 //thickness=0.18 //x=20.695 //y=1.555 //x2=20.58 //y2=1.555
r541 (  160 190 ) resistor r=5.52526 //w=0.168 //l=0.115 //layer=ply \
 //thickness=0.18 //x=20.915 //y=1.555 //x2=21.03 //y2=1.555
r542 (  159 183 ) resistor r=5.52526 //w=0.168 //l=0.115 //layer=ply \
 //thickness=0.18 //x=20.695 //y=0.9 //x2=20.58 //y2=0.9
r543 (  158 189 ) resistor r=5.52526 //w=0.168 //l=0.115 //layer=ply \
 //thickness=0.18 //x=20.915 //y=0.9 //x2=21.03 //y2=0.9
r544 (  158 159 ) resistor r=112.809 //w=0.094 //l=0.22 //layer=ply \
 //thickness=0.18 //x=20.915 //y=0.9 //x2=20.695 //y2=0.9
r545 (  157 186 ) resistor r=58.7805 //w=0.246 //l=0.373497 //layer=ply \
 //thickness=0.18 //x=20.54 //y=2.095 //x2=20.84 //y2=2.26
r546 (  156 184 ) resistor r=39.5823 //w=0.21 //l=0.173853 //layer=ply \
 //thickness=0.18 //x=20.54 //y=1.71 //x2=20.58 //y2=1.555
r547 (  156 157 ) resistor r=197.415 //w=0.094 //l=0.385 //layer=ply \
 //thickness=0.18 //x=20.54 //y=1.71 //x2=20.54 //y2=2.095
r548 (  155 184 ) resistor r=39.5823 //w=0.21 //l=0.173853 //layer=ply \
 //thickness=0.18 //x=20.54 //y=1.4 //x2=20.58 //y2=1.555
r549 (  154 183 ) resistor r=45.1352 //w=0.168 //l=0.173853 //layer=ply \
 //thickness=0.18 //x=20.54 //y=1.055 //x2=20.58 //y2=0.9
r550 (  154 155 ) resistor r=176.904 //w=0.094 //l=0.345 //layer=ply \
 //thickness=0.18 //x=20.54 //y=1.055 //x2=20.54 //y2=1.4
r551 (  153 182 ) resistor r=45.1352 //w=0.168 //l=0.173853 //layer=ply \
 //thickness=0.18 //x=4.34 //y=1.44 //x2=4.3 //y2=1.595
r552 (  152 181 ) resistor r=45.1352 //w=0.168 //l=0.173853 //layer=ply \
 //thickness=0.18 //x=4.34 //y=1.095 //x2=4.3 //y2=0.94
r553 (  152 153 ) resistor r=176.904 //w=0.094 //l=0.345 //layer=ply \
 //thickness=0.18 //x=4.34 //y=1.095 //x2=4.34 //y2=1.44
r554 (  150 178 ) resistor r=10.701 //w=0.21 //l=0.115 //layer=ply \
 //thickness=0.18 //x=3.965 //y=1.595 //x2=3.85 //y2=1.595
r555 (  149 182 ) resistor r=5.52526 //w=0.168 //l=0.115 //layer=ply \
 //thickness=0.18 //x=4.185 //y=1.595 //x2=4.3 //y2=1.595
r556 (  148 177 ) resistor r=5.52526 //w=0.168 //l=0.115 //layer=ply \
 //thickness=0.18 //x=3.965 //y=0.94 //x2=3.85 //y2=0.94
r557 (  147 181 ) resistor r=5.52526 //w=0.168 //l=0.115 //layer=ply \
 //thickness=0.18 //x=4.185 //y=0.94 //x2=4.3 //y2=0.94
r558 (  147 148 ) resistor r=112.809 //w=0.094 //l=0.22 //layer=ply \
 //thickness=0.18 //x=4.185 //y=0.94 //x2=3.965 //y2=0.94
r559 (  144 180 ) resistor r=37.236 //w=0.233 //l=0.249199 //layer=ply \
 //thickness=0.18 //x=4 //y=5.045 //x2=3.82 //y2=4.88
r560 (  142 178 ) resistor r=39.5823 //w=0.21 //l=0.173853 //layer=ply \
 //thickness=0.18 //x=3.81 //y=1.75 //x2=3.85 //y2=1.595
r561 (  142 175 ) resistor r=176.904 //w=0.094 //l=0.345 //layer=ply \
 //thickness=0.18 //x=3.81 //y=1.75 //x2=3.81 //y2=2.095
r562 (  141 178 ) resistor r=39.5823 //w=0.21 //l=0.173853 //layer=ply \
 //thickness=0.18 //x=3.81 //y=1.44 //x2=3.85 //y2=1.595
r563 (  140 177 ) resistor r=45.1352 //w=0.168 //l=0.173853 //layer=ply \
 //thickness=0.18 //x=3.81 //y=1.095 //x2=3.85 //y2=0.94
r564 (  140 141 ) resistor r=176.904 //w=0.094 //l=0.345 //layer=ply \
 //thickness=0.18 //x=3.81 //y=1.095 //x2=3.81 //y2=1.44
r565 (  137 180 ) resistor r=53.7854 //w=0.233 //l=0.332415 //layer=ply \
 //thickness=0.18 //x=3.56 //y=5.045 //x2=3.82 //y2=4.88
r566 (  136 170 ) resistor r=592.245 //w=0.094 //l=1.155 //layer=ply \
 //thickness=0.18 //x=21.48 //y=6.2 //x2=21.48 //y2=5.045
r567 (  135 163 ) resistor r=592.245 //w=0.094 //l=1.155 //layer=ply \
 //thickness=0.18 //x=21.04 //y=6.2 //x2=21.04 //y2=5.045
r568 (  134 144 ) resistor r=592.245 //w=0.094 //l=1.155 //layer=ply \
 //thickness=0.18 //x=4 //y=6.2 //x2=4 //y2=5.045
r569 (  133 137 ) resistor r=592.245 //w=0.094 //l=1.155 //layer=ply \
 //thickness=0.18 //x=3.56 //y=6.2 //x2=3.56 //y2=5.045
r570 (  132 160 ) resistor r=56.4043 //w=0.094 //l=0.11 //layer=ply \
 //thickness=0.18 //x=20.805 //y=1.555 //x2=20.915 //y2=1.555
r571 (  132 161 ) resistor r=56.4043 //w=0.094 //l=0.11 //layer=ply \
 //thickness=0.18 //x=20.805 //y=1.555 //x2=20.695 //y2=1.555
r572 (  131 149 ) resistor r=56.4043 //w=0.094 //l=0.11 //layer=ply \
 //thickness=0.18 //x=4.075 //y=1.595 //x2=4.185 //y2=1.595
r573 (  131 150 ) resistor r=56.4043 //w=0.094 //l=0.11 //layer=ply \
 //thickness=0.18 //x=4.075 //y=1.595 //x2=3.965 //y2=1.595
r574 (  127 188 ) resistor r=152 //w=0.17 //l=0.17 //layer=licon //count=1 \
 //x=20.84 //y=4.88 //x2=20.84 //y2=4.88
r575 (  118 186 ) resistor r=152 //w=0.17 //l=0.17 //layer=licon //count=1 \
 //x=20.84 //y=2.26 //x2=20.84 //y2=2.26
r576 (  101 195 ) resistor r=23.615 //w=0.187 //l=0.345 //layer=li \
 //thickness=0.1 //x=8.59 //y=5.56 //x2=8.59 //y2=5.905
r577 (  93 194 ) resistor r=23.615 //w=0.187 //l=0.345 //layer=li \
 //thickness=0.1 //x=7.71 //y=5.56 //x2=7.71 //y2=5.905
r578 (  85 193 ) resistor r=23.615 //w=0.187 //l=0.345 //layer=li \
 //thickness=0.1 //x=6.83 //y=5.56 //x2=6.83 //y2=5.905
r579 (  80 180 ) resistor r=152 //w=0.17 //l=0.17 //layer=licon //count=1 \
 //x=3.82 //y=4.88 //x2=3.82 //y2=4.88
r580 (  71 174 ) resistor r=152 //w=0.17 //l=0.17 //layer=licon //count=1 \
 //x=3.82 //y=2.26 //x2=3.82 //y2=2.26
r581 (  64 66 ) resistor r=0.10734 //w=0.281 //l=0.16 //layer=m2 \
 //thickness=0.36 //x=9.37 //y=3.495 //x2=9.53 //y2=3.495
r582 (  64 65 ) resistor r=0.10734 //w=0.281 //l=0.16 //layer=m2 \
 //thickness=0.36 //x=9.37 //y=3.495 //x2=9.21 //y2=3.495
r583 (  62 65 ) resistor r=4.98092 //w=0.131 //l=5.22 //layer=m2 \
 //thickness=0.36 //x=3.99 //y=3.51 //x2=9.21 //y2=3.51
r584 (  60 62 ) resistor r=0.10734 //w=0.281 //l=0.16 //layer=m2 \
 //thickness=0.36 //x=3.83 //y=3.515 //x2=3.99 //y2=3.515
r585 (  57 68 ) resistor r=0.10734 //w=0.281 //l=0.16 //layer=m2 \
 //thickness=0.36 //x=20.675 //y=3.51 //x2=20.835 //y2=3.51
r586 (  57 66 ) resistor r=10.6345 //w=0.131 //l=11.145 //layer=m2 \
 //thickness=0.36 //x=20.675 //y=3.51 //x2=9.53 //y2=3.51
r587 (  54 127 ) resistor r=9.3 //w=0.17 //l=0.17 //layer=mcon //count=1 \
 //x=20.84 //y=4.88 //x2=20.84 //y2=4.88
r588 (  52 118 ) resistor r=9.3 //w=0.17 //l=0.17 //layer=mcon //count=1 \
 //x=20.84 //y=2.26 //x2=20.84 //y2=2.26
r589 (  49 68 ) resistor r=4.5 //w=0.15 //l=0.15 //layer=via1 //count=1 \
 //x=20.835 //y=3.51 //x2=20.835 //y2=3.51
r590 (  45 64 ) resistor r=4.5 //w=0.15 //l=0.15 //layer=via1 //count=1 \
 //x=9.37 //y=3.495 //x2=9.37 //y2=3.495
r591 (  45 47 ) resistor r=0.0049867 //w=0.376 //l=0.015 //layer=m1 \
 //thickness=0.36 //x=9.422 //y=3.495 //x2=9.422 //y2=3.51
r592 (  43 191 ) resistor r=9.3 //w=0.17 //l=0.17 //layer=mcon //count=1 \
 //x=8.885 //y=1.19 //x2=8.885 //y2=1.19
r593 (  41 101 ) resistor r=9.3 //w=0.17 //l=0.17 //layer=mcon //count=1 \
 //x=8.59 //y=5.56 //x2=8.59 //y2=5.56
r594 (  38 93 ) resistor r=9.3 //w=0.17 //l=0.17 //layer=mcon //count=1 \
 //x=7.71 //y=5.56 //x2=7.71 //y2=5.56
r595 (  36 38 ) resistor r=0.121228 //w=0.232 //l=0.225 //layer=m1 \
 //thickness=0.36 //x=7.71 //y=5.335 //x2=7.71 //y2=5.56
r596 (  35 85 ) resistor r=9.3 //w=0.17 //l=0.17 //layer=mcon //count=1 \
 //x=6.83 //y=5.56 //x2=6.83 //y2=5.56
r597 (  33 35 ) resistor r=0.129608 //w=0.217 //l=0.225 //layer=m1 \
 //thickness=0.36 //x=6.832 //y=5.335 //x2=6.832 //y2=5.56
r598 (  32 60 ) resistor r=4.5 //w=0.15 //l=0.15 //layer=via1 //count=1 \
 //x=3.83 //y=3.515 //x2=3.83 //y2=3.515
r599 (  30 32 ) resistor r=0.00168464 //w=0.371 //l=0.005 //layer=m1 \
 //thickness=0.36 //x=3.877 //y=3.51 //x2=3.877 //y2=3.515
r600 (  28 80 ) resistor r=9.3 //w=0.17 //l=0.17 //layer=mcon //count=1 \
 //x=3.82 //y=4.88 //x2=3.82 //y2=4.88
r601 (  26 71 ) resistor r=9.3 //w=0.17 //l=0.17 //layer=mcon //count=1 \
 //x=3.82 //y=2.26 //x2=3.82 //y2=2.26
r602 (  24 54 ) resistor r=0.0760407 //w=0.238 //l=0.125 //layer=m1 \
 //thickness=0.36 //x=20.84 //y=4.755 //x2=20.84 //y2=4.88
r603 (  23 49 ) resistor r=0.0910802 //w=0.374 //l=0.185472 //layer=m1 \
 //thickness=0.36 //x=20.84 //y=3.67 //x2=20.785 //y2=3.51
r604 (  23 24 ) resistor r=1.03531 //w=0.131 //l=1.085 //layer=m1 \
 //thickness=0.36 //x=20.84 //y=3.67 //x2=20.84 //y2=4.755
r605 (  22 49 ) resistor r=0.0910802 //w=0.374 //l=0.185472 //layer=m1 \
 //thickness=0.36 //x=20.84 //y=3.35 //x2=20.785 //y2=3.51
r606 (  21 52 ) resistor r=0.0719237 //w=0.222 //l=0.115 //layer=m1 \
 //thickness=0.36 //x=20.84 //y=2.375 //x2=20.84 //y2=2.26
r607 (  21 22 ) resistor r=0.930344 //w=0.131 //l=0.975 //layer=m1 \
 //thickness=0.36 //x=20.84 //y=2.375 //x2=20.84 //y2=3.35
r608 (  19 47 ) resistor r=0.0861726 //w=0.376 //l=0.169012 //layer=m1 \
 //thickness=0.36 //x=9.37 //y=3.655 //x2=9.422 //y2=3.51
r609 (  19 20 ) resistor r=1.52195 //w=0.131 //l=1.595 //layer=m1 \
 //thickness=0.36 //x=9.37 //y=3.655 //x2=9.37 //y2=5.25
r610 (  18 45 ) resistor r=0.0911593 //w=0.376 //l=0.184174 //layer=m1 \
 //thickness=0.36 //x=9.37 //y=3.335 //x2=9.422 //y2=3.495
r611 (  17 18 ) resistor r=1.34065 //w=0.131 //l=1.405 //layer=m1 \
 //thickness=0.36 //x=9.37 //y=1.93 //x2=9.37 //y2=3.335
r612 (  15 17 ) resistor r=0.0698411 //w=0.17 //l=0.120208 //layer=m1 \
 //thickness=0.36 //x=9.285 //y=1.845 //x2=9.37 //y2=1.93
r613 (  15 16 ) resistor r=0.300573 //w=0.131 //l=0.315 //layer=m1 \
 //thickness=0.36 //x=9.285 //y=1.845 //x2=8.97 //y2=1.845
r614 (  14 16 ) resistor r=0.0698411 //w=0.17 //l=0.120208 //layer=m1 \
 //thickness=0.36 //x=8.885 //y=1.76 //x2=8.97 //y2=1.845
r615 (  13 43 ) resistor r=0.0717383 //w=0.224 //l=0.115 //layer=m1 \
 //thickness=0.36 //x=8.885 //y=1.305 //x2=8.885 //y2=1.19
r616 (  13 14 ) resistor r=0.43416 //w=0.131 //l=0.455 //layer=m1 \
 //thickness=0.36 //x=8.885 //y=1.305 //x2=8.885 //y2=1.76
r617 (  12 39 ) resistor r=0.0675342 //w=0.23 //l=0.115 //layer=m1 \
 //thickness=0.36 //x=8.705 //y=5.335 //x2=8.59 //y2=5.335
r618 (  11 20 ) resistor r=0.0698411 //w=0.17 //l=0.120208 //layer=m1 \
 //thickness=0.36 //x=9.285 //y=5.335 //x2=9.37 //y2=5.25
r619 (  11 12 ) resistor r=0.553435 //w=0.131 //l=0.58 //layer=m1 \
 //thickness=0.36 //x=9.285 //y=5.335 //x2=8.705 //y2=5.335
r620 (  10 41 ) resistor r=0.00118313 //w=0.23 //layer=m1 //thickness=0.36 \
 //x=8.59 //y=5.56 //x2=8.59 //y2=5.56
r621 (  9 39 ) resistor r=0.002872 //w=0.34 //l=0.085 //layer=m1 \
 //thickness=0.36 //x=8.59 //y=5.42 //x2=8.59 //y2=5.335
r622 (  9 10 ) resistor r=0.091623 //w=0.191 //l=0.14 //layer=m1 \
 //thickness=0.36 //x=8.59 //y=5.42 //x2=8.59 //y2=5.56
r623 (  8 36 ) resistor r=0.0262263 //w=0.232 //l=0.12 //layer=m1 \
 //thickness=0.36 //x=7.83 //y=5.335 //x2=7.71 //y2=5.335
r624 (  7 39 ) resistor r=0.0675342 //w=0.23 //l=0.115 //layer=m1 \
 //thickness=0.36 //x=8.475 //y=5.335 //x2=8.59 //y2=5.335
r625 (  7 8 ) resistor r=0.615458 //w=0.131 //l=0.645 //layer=m1 \
 //thickness=0.36 //x=8.475 //y=5.335 //x2=7.83 //y2=5.335
r626 (  6 33 ) resistor r=0.0222262 //w=0.217 //l=0.118 //layer=m1 \
 //thickness=0.36 //x=6.95 //y=5.335 //x2=6.832 //y2=5.335
r627 (  5 36 ) resistor r=0.0262263 //w=0.232 //l=0.12 //layer=m1 \
 //thickness=0.36 //x=7.59 //y=5.335 //x2=7.71 //y2=5.335
r628 (  5 6 ) resistor r=0.610687 //w=0.131 //l=0.64 //layer=m1 \
 //thickness=0.36 //x=7.59 //y=5.335 //x2=6.95 //y2=5.335
r629 (  4 28 ) resistor r=0.0801089 //w=0.224 //l=0.13 //layer=m1 \
 //thickness=0.36 //x=3.82 //y=4.75 //x2=3.82 //y2=4.88
r630 (  3 32 ) resistor r=0.0909648 //w=0.371 //l=0.186333 //layer=m1 \
 //thickness=0.36 //x=3.82 //y=3.675 //x2=3.877 //y2=3.515
r631 (  3 4 ) resistor r=1.02576 //w=0.131 //l=1.075 //layer=m1 \
 //thickness=0.36 //x=3.82 //y=3.675 //x2=3.82 //y2=4.75
r632 (  2 30 ) resistor r=0.0892801 //w=0.371 //l=0.181273 //layer=m1 \
 //thickness=0.36 //x=3.82 //y=3.355 //x2=3.877 //y2=3.51
r633 (  1 26 ) resistor r=0.0719237 //w=0.222 //l=0.115 //layer=m1 \
 //thickness=0.36 //x=3.82 //y=2.375 //x2=3.82 //y2=2.26
r634 (  1 2 ) resistor r=0.935115 //w=0.131 //l=0.98 //layer=m1 \
 //thickness=0.36 //x=3.82 //y=2.375 //x2=3.82 //y2=3.355
ends PM_TMRDFFSNRNQNX1\%noxref_3

subckt PM_TMRDFFSNRNQNX1\%noxref_4 ( 1 3 6 7 9 10 11 12 14 15 16 17 18 19 20 \
 21 22 23 24 25 28 31 37 39 44 52 56 59 67 68 69 71 72 73 75 76 77 79 80 81 83 \
 84 85 87 88 89 91 92 93 95 97 98 99 101 105 107 110 111 115 120 121 124 132 \
 140 161 170 175 180 186 191 196 197 198 199 200 201 202 203 204 205 206 207 \
 208 209 211 217 218 219 220 224 225 226 227 231 233 236 237 238 239 243 244 \
 245 246 250 252 258 259 269 282 285 287 288 289 )
c904 ( 285 0 ) capacitor c=0.00885916f //x=23.125 //y=1.095
c905 ( 282 0 ) capacitor c=0.0692896f //x=91.51 //y=4.885
c906 ( 269 0 ) capacitor c=0.0603371f //x=87.81 //y=2.26
c907 ( 259 0 ) capacitor c=0.0344584f //x=91.845 //y=1.39
c908 ( 258 0 ) capacitor c=0.0188421f //x=91.845 //y=1.045
c909 ( 252 0 ) capacitor c=0.0141798f //x=91.69 //y=1.545
c910 ( 250 0 ) capacitor c=0.0160622f //x=91.69 //y=0.89
c911 ( 246 0 ) capacitor c=0.104052f //x=91.315 //y=2.095
c912 ( 245 0 ) capacitor c=0.0227978f //x=91.315 //y=1.7
c913 ( 244 0 ) capacitor c=0.0234352f //x=91.315 //y=1.39
c914 ( 243 0 ) capacitor c=0.0200371f //x=91.315 //y=1.045
c915 ( 239 0 ) capacitor c=0.0318956f //x=88.515 //y=1.39
c916 ( 238 0 ) capacitor c=0.0186809f //x=88.515 //y=1.045
c917 ( 237 0 ) capacitor c=0.0624333f //x=88.155 //y=4.975
c918 ( 236 0 ) capacitor c=0.0375163f //x=88.445 //y=4.975
c919 ( 233 0 ) capacitor c=0.0157936f //x=88.36 //y=1.545
c920 ( 231 0 ) capacitor c=0.0158553f //x=88.36 //y=0.89
c921 ( 227 0 ) capacitor c=0.0302441f //x=87.985 //y=2.095
c922 ( 226 0 ) capacitor c=0.0238107f //x=87.985 //y=1.7
c923 ( 225 0 ) capacitor c=0.0234359f //x=87.985 //y=1.39
c924 ( 224 0 ) capacitor c=0.0199332f //x=87.985 //y=1.045
c925 ( 220 0 ) capacitor c=0.0612936f //x=25.925 //y=4.97
c926 ( 219 0 ) capacitor c=0.0376642f //x=26.215 //y=4.97
c927 ( 218 0 ) capacitor c=0.0346489f //x=25.88 //y=1.4
c928 ( 217 0 ) capacitor c=0.018692f //x=25.88 //y=1.055
c929 ( 211 0 ) capacitor c=0.0137077f //x=25.725 //y=1.555
c930 ( 209 0 ) capacitor c=0.0158585f //x=25.725 //y=0.9
c931 ( 208 0 ) capacitor c=0.097937f //x=25.35 //y=2.095
c932 ( 207 0 ) capacitor c=0.0229364f //x=25.35 //y=1.71
c933 ( 206 0 ) capacitor c=0.0234359f //x=25.35 //y=1.4
c934 ( 205 0 ) capacitor c=0.019815f //x=25.35 //y=1.055
c935 ( 204 0 ) capacitor c=0.111167f //x=91.84 //y=6.205
c936 ( 203 0 ) capacitor c=0.154978f //x=91.4 //y=6.205
c937 ( 202 0 ) capacitor c=0.110282f //x=88.52 //y=6.205
c938 ( 201 0 ) capacitor c=0.155219f //x=88.08 //y=6.205
c939 ( 200 0 ) capacitor c=0.110208f //x=26.29 //y=6.2
c940 ( 199 0 ) capacitor c=0.158957f //x=25.85 //y=6.2
c941 ( 191 0 ) capacitor c=0.0156727f //x=91.51 //y=4.62
c942 ( 186 0 ) capacitor c=0.00133484f //x=91.51 //y=2.26
c943 ( 180 0 ) capacitor c=0.0130807f //x=87.81 //y=4.62
c944 ( 175 0 ) capacitor c=8.37642e-19 //x=87.81 //y=2.26
c945 ( 170 0 ) capacitor c=0.0014751f //x=25.65 //y=4.88
c946 ( 161 0 ) capacitor c=9.93222e-19 //x=25.65 //y=2.26
c947 ( 140 0 ) capacitor c=0.0293555f //x=23.02 //y=5.56
c948 ( 132 0 ) capacitor c=0.029137f //x=22.14 //y=5.56
c949 ( 124 0 ) capacitor c=0.0278099f //x=21.26 //y=5.56
c950 ( 121 0 ) capacitor c=0.0683501f //x=91.355 //y=4.64
c951 ( 120 0 ) capacitor c=0.00642399f //x=91.515 //y=4.64
c952 ( 115 0 ) capacitor c=0.0113244f //x=75.6 //y=4.99
c953 ( 111 0 ) capacitor c=0.0150338f //x=25.445 //y=2.755
c954 ( 110 0 ) capacitor c=0.00484623f //x=25.605 //y=2.755
c955 ( 107 0 ) capacitor c=0.27608f //x=23.785 //y=5.095
c956 ( 105 0 ) capacitor c=0.00514732f //x=24.005 //y=2.755
c957 ( 101 0 ) capacitor c=0.00568391f //x=87.975 //y=4.62
c958 ( 99 0 ) capacitor c=0.002039f //x=75.685 //y=4.62
c959 ( 98 0 ) capacitor c=0.295984f //x=87.655 //y=4.62
c960 ( 97 0 ) capacitor c=0.00346713f //x=75.6 //y=4.905
c961 ( 95 0 ) capacitor c=0.00345952f //x=75.3 //y=5.215
c962 ( 93 0 ) capacitor c=0.00689396f //x=74.415 //y=5.3
c963 ( 92 0 ) capacitor c=0.0265837f //x=75.215 //y=5.3
c964 ( 91 0 ) capacitor c=0.00371196f //x=74.33 //y=5.215
c965 ( 89 0 ) capacitor c=0.00185164f //x=65.895 //y=4.99
c966 ( 88 0 ) capacitor c=0.186833f //x=74.245 //y=4.99
c967 ( 87 0 ) capacitor c=0.00353307f //x=65.81 //y=5.22
c968 ( 85 0 ) capacitor c=0.0068632f //x=64.765 //y=5.305
c969 ( 84 0 ) capacitor c=0.0299178f //x=65.725 //y=5.305
c970 ( 83 0 ) capacitor c=0.00390795f //x=64.68 //y=5.22
c971 ( 81 0 ) capacitor c=0.00182741f //x=46.645 //y=4.99
c972 ( 80 0 ) capacitor c=0.395864f //x=64.595 //y=4.99
c973 ( 79 0 ) capacitor c=0.00353587f //x=46.56 //y=5.22
c974 ( 77 0 ) capacitor c=0.00687528f //x=45.53 //y=5.305
c975 ( 76 0 ) capacitor c=0.0296352f //x=46.475 //y=5.305
c976 ( 75 0 ) capacitor c=0.00390429f //x=45.445 //y=5.22
c977 ( 73 0 ) capacitor c=0.00218889f //x=37.09 //y=4.99
c978 ( 72 0 ) capacitor c=0.185204f //x=45.36 //y=4.99
c979 ( 71 0 ) capacitor c=0.00517365f //x=37.005 //y=5.265
c980 ( 69 0 ) capacitor c=0.00633296f //x=35.975 //y=5.35
c981 ( 68 0 ) capacitor c=0.0314834f //x=36.92 //y=5.35
c982 ( 67 0 ) capacitor c=0.00514912f //x=35.89 //y=5.265
c983 ( 59 0 ) capacitor c=0.0127073f //x=91.51 //y=4.62
c984 ( 56 0 ) capacitor c=0.0137635f //x=87.81 //y=4.62
c985 ( 52 0 ) capacitor c=0.0148553f //x=25.65 //y=2.77
c986 ( 44 0 ) capacitor c=0.0144001f //x=23.8 //y=2.77
c987 ( 39 0 ) capacitor c=0.024777f //x=23.785 //y=5.095
c988 ( 37 0 ) capacitor c=0.014148f //x=23.8 //y=4.99
c989 ( 31 0 ) capacitor c=9.58516e-19 //x=23.02 //y=5.335
c990 ( 28 0 ) capacitor c=0.00778188f //x=22.14 //y=5.335
c991 ( 25 0 ) capacitor c=0.0111234f //x=21.262 //y=5.335
c992 ( 24 0 ) capacitor c=0.0838237f //x=91.51 //y=4.475
c993 ( 23 0 ) capacitor c=0.00613489f //x=91.51 //y=2.385
c994 ( 22 0 ) capacitor c=0.0626977f //x=87.81 //y=4.46
c995 ( 21 0 ) capacitor c=0.00377765f //x=87.81 //y=2.375
c996 ( 20 0 ) capacitor c=0.0579716f //x=25.65 //y=4.755
c997 ( 19 0 ) capacitor c=0.0139549f //x=25.65 //y=2.915
c998 ( 18 0 ) capacitor c=0.00427649f //x=25.65 //y=2.595
c999 ( 17 0 ) capacitor c=0.00437465f //x=25.65 //y=2.375
c1000 ( 16 0 ) capacitor c=0.0515446f //x=23.8 //y=4.875
c1001 ( 15 0 ) capacitor c=0.0140858f //x=23.8 //y=2.915
c1002 ( 14 0 ) capacitor c=0.017505f //x=23.8 //y=2.595
c1003 ( 12 0 ) capacitor c=0.0047266f //x=23.4 //y=1.845
c1004 ( 11 0 ) capacitor c=0.0129783f //x=23.715 //y=1.845
c1005 ( 10 0 ) capacitor c=0.0167992f //x=23.315 //y=1.76
c1006 ( 9 0 ) capacitor c=0.0110975f //x=23.315 //y=1.305
c1007 ( 7 0 ) capacitor c=0.0130988f //x=23.625 //y=5.335
c1008 ( 6 0 ) capacitor c=0.00933983f //x=23.02 //y=5.56
c1009 ( 3 0 ) capacitor c=0.019444f //x=22.905 //y=5.335
c1010 ( 1 0 ) capacitor c=0.0151997f //x=22.02 //y=5.335
r1011 (  280 282 ) resistor r=22.7554 //w=0.233 //l=0.11 //layer=ply \
 //thickness=0.18 //x=91.4 //y=4.885 //x2=91.51 //y2=4.885
r1012 (  259 284 ) resistor r=45.1352 //w=0.168 //l=0.173853 //layer=ply \
 //thickness=0.18 //x=91.845 //y=1.39 //x2=91.805 //y2=1.545
r1013 (  258 283 ) resistor r=45.1352 //w=0.168 //l=0.173853 //layer=ply \
 //thickness=0.18 //x=91.845 //y=1.045 //x2=91.805 //y2=0.89
r1014 (  258 259 ) resistor r=176.904 //w=0.094 //l=0.345 //layer=ply \
 //thickness=0.18 //x=91.845 //y=1.045 //x2=91.845 //y2=1.39
r1015 (  255 282 ) resistor r=68.2661 //w=0.233 //l=0.404166 //layer=ply \
 //thickness=0.18 //x=91.84 //y=5.05 //x2=91.51 //y2=4.885
r1016 (  253 279 ) resistor r=10.701 //w=0.21 //l=0.115 //layer=ply \
 //thickness=0.18 //x=91.47 //y=1.545 //x2=91.355 //y2=1.545
r1017 (  252 284 ) resistor r=5.52526 //w=0.168 //l=0.115 //layer=ply \
 //thickness=0.18 //x=91.69 //y=1.545 //x2=91.805 //y2=1.545
r1018 (  251 278 ) resistor r=5.52526 //w=0.168 //l=0.115 //layer=ply \
 //thickness=0.18 //x=91.47 //y=0.89 //x2=91.355 //y2=0.89
r1019 (  250 283 ) resistor r=5.52526 //w=0.168 //l=0.115 //layer=ply \
 //thickness=0.18 //x=91.69 //y=0.89 //x2=91.805 //y2=0.89
r1020 (  250 251 ) resistor r=112.809 //w=0.094 //l=0.22 //layer=ply \
 //thickness=0.18 //x=91.69 //y=0.89 //x2=91.47 //y2=0.89
r1021 (  247 280 ) resistor r=13.0941 //w=0.233 //l=0.165 //layer=ply \
 //thickness=0.18 //x=91.4 //y=5.05 //x2=91.4 //y2=4.885
r1022 (  246 277 ) resistor r=34.8111 //w=0.27 //l=0.264953 //layer=ply \
 //thickness=0.18 //x=91.315 //y=2.095 //x2=91.51 //y2=2.26
r1023 (  245 279 ) resistor r=39.5823 //w=0.21 //l=0.173853 //layer=ply \
 //thickness=0.18 //x=91.315 //y=1.7 //x2=91.355 //y2=1.545
r1024 (  245 246 ) resistor r=202.543 //w=0.094 //l=0.395 //layer=ply \
 //thickness=0.18 //x=91.315 //y=1.7 //x2=91.315 //y2=2.095
r1025 (  244 279 ) resistor r=39.5823 //w=0.21 //l=0.173853 //layer=ply \
 //thickness=0.18 //x=91.315 //y=1.39 //x2=91.355 //y2=1.545
r1026 (  243 278 ) resistor r=45.1352 //w=0.168 //l=0.173853 //layer=ply \
 //thickness=0.18 //x=91.315 //y=1.045 //x2=91.355 //y2=0.89
r1027 (  243 244 ) resistor r=176.904 //w=0.094 //l=0.345 //layer=ply \
 //thickness=0.18 //x=91.315 //y=1.045 //x2=91.315 //y2=1.39
r1028 (  239 275 ) resistor r=45.1352 //w=0.168 //l=0.173853 //layer=ply \
 //thickness=0.18 //x=88.515 //y=1.39 //x2=88.475 //y2=1.545
r1029 (  238 274 ) resistor r=45.1352 //w=0.168 //l=0.173853 //layer=ply \
 //thickness=0.18 //x=88.515 //y=1.045 //x2=88.475 //y2=0.89
r1030 (  238 239 ) resistor r=176.904 //w=0.094 //l=0.345 //layer=ply \
 //thickness=0.18 //x=88.515 //y=1.045 //x2=88.515 //y2=1.39
r1031 (  236 240 ) resistor r=26.9307 //w=0.15 //l=0.106066 //layer=ply \
 //thickness=0.18 //x=88.445 //y=4.975 //x2=88.52 //y2=5.05
r1032 (  236 237 ) resistor r=148.702 //w=0.094 //l=0.29 //layer=ply \
 //thickness=0.18 //x=88.445 //y=4.975 //x2=88.155 //y2=4.975
r1033 (  234 273 ) resistor r=10.701 //w=0.21 //l=0.115 //layer=ply \
 //thickness=0.18 //x=88.14 //y=1.545 //x2=88.025 //y2=1.545
r1034 (  233 275 ) resistor r=5.52526 //w=0.168 //l=0.115 //layer=ply \
 //thickness=0.18 //x=88.36 //y=1.545 //x2=88.475 //y2=1.545
r1035 (  232 272 ) resistor r=5.52526 //w=0.168 //l=0.115 //layer=ply \
 //thickness=0.18 //x=88.14 //y=0.89 //x2=88.025 //y2=0.89
r1036 (  231 274 ) resistor r=5.52526 //w=0.168 //l=0.115 //layer=ply \
 //thickness=0.18 //x=88.36 //y=0.89 //x2=88.475 //y2=0.89
r1037 (  231 232 ) resistor r=112.809 //w=0.094 //l=0.22 //layer=ply \
 //thickness=0.18 //x=88.36 //y=0.89 //x2=88.14 //y2=0.89
r1038 (  228 237 ) resistor r=22.1787 //w=0.252 //l=0.106066 //layer=ply \
 //thickness=0.18 //x=88.08 //y=5.05 //x2=88.155 //y2=4.975
r1039 (  228 271 ) resistor r=51.6429 //w=0.252 //l=0.34271 //layer=ply \
 //thickness=0.18 //x=88.08 //y=5.05 //x2=87.81 //y2=4.885
r1040 (  227 269 ) resistor r=30.4513 //w=0.277 //l=0.243926 //layer=ply \
 //thickness=0.18 //x=87.985 //y=2.095 //x2=87.81 //y2=2.26
r1041 (  226 273 ) resistor r=39.5823 //w=0.21 //l=0.173853 //layer=ply \
 //thickness=0.18 //x=87.985 //y=1.7 //x2=88.025 //y2=1.545
r1042 (  226 227 ) resistor r=202.543 //w=0.094 //l=0.395 //layer=ply \
 //thickness=0.18 //x=87.985 //y=1.7 //x2=87.985 //y2=2.095
r1043 (  225 273 ) resistor r=39.5823 //w=0.21 //l=0.173853 //layer=ply \
 //thickness=0.18 //x=87.985 //y=1.39 //x2=88.025 //y2=1.545
r1044 (  224 272 ) resistor r=45.1352 //w=0.168 //l=0.173853 //layer=ply \
 //thickness=0.18 //x=87.985 //y=1.045 //x2=88.025 //y2=0.89
r1045 (  224 225 ) resistor r=176.904 //w=0.094 //l=0.345 //layer=ply \
 //thickness=0.18 //x=87.985 //y=1.045 //x2=87.985 //y2=1.39
r1046 (  219 221 ) resistor r=26.9307 //w=0.15 //l=0.106066 //layer=ply \
 //thickness=0.18 //x=26.215 //y=4.97 //x2=26.29 //y2=5.045
r1047 (  219 220 ) resistor r=148.702 //w=0.094 //l=0.29 //layer=ply \
 //thickness=0.18 //x=26.215 //y=4.97 //x2=25.925 //y2=4.97
r1048 (  218 267 ) resistor r=45.1352 //w=0.168 //l=0.173853 //layer=ply \
 //thickness=0.18 //x=25.88 //y=1.4 //x2=25.84 //y2=1.555
r1049 (  217 266 ) resistor r=45.1352 //w=0.168 //l=0.173853 //layer=ply \
 //thickness=0.18 //x=25.88 //y=1.055 //x2=25.84 //y2=0.9
r1050 (  217 218 ) resistor r=176.904 //w=0.094 //l=0.345 //layer=ply \
 //thickness=0.18 //x=25.88 //y=1.055 //x2=25.88 //y2=1.4
r1051 (  214 220 ) resistor r=22.7971 //w=0.269 //l=0.106066 //layer=ply \
 //thickness=0.18 //x=25.85 //y=5.045 //x2=25.925 //y2=4.97
r1052 (  214 265 ) resistor r=35.8364 //w=0.269 //l=0.270185 //layer=ply \
 //thickness=0.18 //x=25.85 //y=5.045 //x2=25.65 //y2=4.88
r1053 (  212 261 ) resistor r=10.701 //w=0.21 //l=0.115 //layer=ply \
 //thickness=0.18 //x=25.505 //y=1.555 //x2=25.39 //y2=1.555
r1054 (  211 267 ) resistor r=5.52526 //w=0.168 //l=0.115 //layer=ply \
 //thickness=0.18 //x=25.725 //y=1.555 //x2=25.84 //y2=1.555
r1055 (  210 260 ) resistor r=5.52526 //w=0.168 //l=0.115 //layer=ply \
 //thickness=0.18 //x=25.505 //y=0.9 //x2=25.39 //y2=0.9
r1056 (  209 266 ) resistor r=5.52526 //w=0.168 //l=0.115 //layer=ply \
 //thickness=0.18 //x=25.725 //y=0.9 //x2=25.84 //y2=0.9
r1057 (  209 210 ) resistor r=112.809 //w=0.094 //l=0.22 //layer=ply \
 //thickness=0.18 //x=25.725 //y=0.9 //x2=25.505 //y2=0.9
r1058 (  208 263 ) resistor r=58.7805 //w=0.246 //l=0.373497 //layer=ply \
 //thickness=0.18 //x=25.35 //y=2.095 //x2=25.65 //y2=2.26
r1059 (  207 261 ) resistor r=39.5823 //w=0.21 //l=0.173853 //layer=ply \
 //thickness=0.18 //x=25.35 //y=1.71 //x2=25.39 //y2=1.555
r1060 (  207 208 ) resistor r=197.415 //w=0.094 //l=0.385 //layer=ply \
 //thickness=0.18 //x=25.35 //y=1.71 //x2=25.35 //y2=2.095
r1061 (  206 261 ) resistor r=39.5823 //w=0.21 //l=0.173853 //layer=ply \
 //thickness=0.18 //x=25.35 //y=1.4 //x2=25.39 //y2=1.555
r1062 (  205 260 ) resistor r=45.1352 //w=0.168 //l=0.173853 //layer=ply \
 //thickness=0.18 //x=25.35 //y=1.055 //x2=25.39 //y2=0.9
r1063 (  205 206 ) resistor r=176.904 //w=0.094 //l=0.345 //layer=ply \
 //thickness=0.18 //x=25.35 //y=1.055 //x2=25.35 //y2=1.4
r1064 (  204 255 ) resistor r=592.245 //w=0.094 //l=1.155 //layer=ply \
 //thickness=0.18 //x=91.84 //y=6.205 //x2=91.84 //y2=5.05
r1065 (  203 247 ) resistor r=592.245 //w=0.094 //l=1.155 //layer=ply \
 //thickness=0.18 //x=91.4 //y=6.205 //x2=91.4 //y2=5.05
r1066 (  202 240 ) resistor r=592.245 //w=0.094 //l=1.155 //layer=ply \
 //thickness=0.18 //x=88.52 //y=6.205 //x2=88.52 //y2=5.05
r1067 (  201 228 ) resistor r=592.245 //w=0.094 //l=1.155 //layer=ply \
 //thickness=0.18 //x=88.08 //y=6.205 //x2=88.08 //y2=5.05
r1068 (  200 221 ) resistor r=592.245 //w=0.094 //l=1.155 //layer=ply \
 //thickness=0.18 //x=26.29 //y=6.2 //x2=26.29 //y2=5.045
r1069 (  199 214 ) resistor r=592.245 //w=0.094 //l=1.155 //layer=ply \
 //thickness=0.18 //x=25.85 //y=6.2 //x2=25.85 //y2=5.045
r1070 (  198 252 ) resistor r=56.4043 //w=0.094 //l=0.11 //layer=ply \
 //thickness=0.18 //x=91.58 //y=1.545 //x2=91.69 //y2=1.545
r1071 (  198 253 ) resistor r=56.4043 //w=0.094 //l=0.11 //layer=ply \
 //thickness=0.18 //x=91.58 //y=1.545 //x2=91.47 //y2=1.545
r1072 (  197 233 ) resistor r=56.4043 //w=0.094 //l=0.11 //layer=ply \
 //thickness=0.18 //x=88.25 //y=1.545 //x2=88.36 //y2=1.545
r1073 (  197 234 ) resistor r=56.4043 //w=0.094 //l=0.11 //layer=ply \
 //thickness=0.18 //x=88.25 //y=1.545 //x2=88.14 //y2=1.545
r1074 (  196 211 ) resistor r=56.4043 //w=0.094 //l=0.11 //layer=ply \
 //thickness=0.18 //x=25.615 //y=1.555 //x2=25.725 //y2=1.555
r1075 (  196 212 ) resistor r=56.4043 //w=0.094 //l=0.11 //layer=ply \
 //thickness=0.18 //x=25.615 //y=1.555 //x2=25.505 //y2=1.555
r1076 (  194 282 ) resistor r=152 //w=0.17 //l=0.17 //layer=licon //count=1 \
 //x=91.51 //y=4.885 //x2=91.51 //y2=4.885
r1077 (  191 194 ) resistor r=18.139 //w=0.187 //l=0.265 //layer=li \
 //thickness=0.1 //x=91.51 //y=4.62 //x2=91.51 //y2=4.885
r1078 (  186 277 ) resistor r=152 //w=0.17 //l=0.17 //layer=licon //count=1 \
 //x=91.51 //y=2.26 //x2=91.51 //y2=2.26
r1079 (  183 271 ) resistor r=152 //w=0.17 //l=0.17 //layer=licon //count=1 \
 //x=87.81 //y=4.885 //x2=87.81 //y2=4.885
r1080 (  180 183 ) resistor r=18.139 //w=0.187 //l=0.265 //layer=li \
 //thickness=0.1 //x=87.81 //y=4.62 //x2=87.81 //y2=4.885
r1081 (  175 269 ) resistor r=152 //w=0.17 //l=0.17 //layer=licon //count=1 \
 //x=87.81 //y=2.26 //x2=87.81 //y2=2.26
r1082 (  170 265 ) resistor r=152 //w=0.17 //l=0.17 //layer=licon //count=1 \
 //x=25.65 //y=4.88 //x2=25.65 //y2=4.88
r1083 (  161 263 ) resistor r=152 //w=0.17 //l=0.17 //layer=licon //count=1 \
 //x=25.65 //y=2.26 //x2=25.65 //y2=2.26
r1084 (  140 289 ) resistor r=23.615 //w=0.187 //l=0.345 //layer=li \
 //thickness=0.1 //x=23.02 //y=5.56 //x2=23.02 //y2=5.905
r1085 (  132 288 ) resistor r=23.615 //w=0.187 //l=0.345 //layer=li \
 //thickness=0.1 //x=22.14 //y=5.56 //x2=22.14 //y2=5.905
r1086 (  124 287 ) resistor r=23.615 //w=0.187 //l=0.345 //layer=li \
 //thickness=0.1 //x=21.26 //y=5.56 //x2=21.26 //y2=5.905
r1087 (  120 121 ) resistor r=0.10734 //w=0.281 //l=0.16 //layer=m2 \
 //thickness=0.36 //x=91.515 //y=4.64 //x2=91.355 //y2=4.64
r1088 (  113 115 ) resistor r=0.28626 //w=0.131 //l=0.3 //layer=m2 \
 //thickness=0.36 //x=75.3 //y=4.99 //x2=75.6 //y2=4.99
r1089 (  110 111 ) resistor r=0.10734 //w=0.281 //l=0.16 //layer=m2 \
 //thickness=0.36 //x=25.605 //y=2.755 //x2=25.445 //y2=2.755
r1090 (  105 111 ) resistor r=1.37405 //w=0.131 //l=1.44 //layer=m2 \
 //thickness=0.36 //x=24.005 //y=2.77 //x2=25.445 //y2=2.77
r1091 (  103 105 ) resistor r=0.10734 //w=0.281 //l=0.16 //layer=m2 \
 //thickness=0.36 //x=23.845 //y=2.755 //x2=24.005 //y2=2.755
r1092 (  101 118 ) resistor r=0.10734 //w=0.281 //l=0.16 //layer=m2 \
 //thickness=0.36 //x=87.975 //y=4.62 //x2=87.815 //y2=4.62
r1093 (  101 121 ) resistor r=3.22519 //w=0.131 //l=3.38 //layer=m2 \
 //thickness=0.36 //x=87.975 //y=4.62 //x2=91.355 //y2=4.62
r1094 (  98 118 ) resistor r=0.10734 //w=0.281 //l=0.16 //layer=m2 \
 //thickness=0.36 //x=87.655 //y=4.62 //x2=87.815 //y2=4.62
r1095 (  98 99 ) resistor r=11.4218 //w=0.131 //l=11.97 //layer=m2 \
 //thickness=0.36 //x=87.655 //y=4.62 //x2=75.685 //y2=4.62
r1096 (  97 115 ) resistor r=0.0073411 //w=0.17 //l=0.085 //layer=m2 \
 //thickness=0.36 //x=75.6 //y=4.905 //x2=75.6 //y2=4.99
r1097 (  96 99 ) resistor r=0.0718295 //w=0.17 //l=0.120208 //layer=m2 \
 //thickness=0.36 //x=75.6 //y=4.705 //x2=75.685 //y2=4.62
r1098 (  96 97 ) resistor r=0.19084 //w=0.131 //l=0.2 //layer=m2 \
 //thickness=0.36 //x=75.6 //y=4.705 //x2=75.6 //y2=4.905
r1099 (  94 113 ) resistor r=0.0073411 //w=0.17 //l=0.085 //layer=m2 \
 //thickness=0.36 //x=75.3 //y=5.075 //x2=75.3 //y2=4.99
r1100 (  94 95 ) resistor r=0.133588 //w=0.131 //l=0.14 //layer=m2 \
 //thickness=0.36 //x=75.3 //y=5.075 //x2=75.3 //y2=5.215
r1101 (  92 95 ) resistor r=0.0698411 //w=0.17 //l=0.120208 //layer=m2 \
 //thickness=0.36 //x=75.215 //y=5.3 //x2=75.3 //y2=5.215
r1102 (  92 93 ) resistor r=0.763359 //w=0.131 //l=0.8 //layer=m2 \
 //thickness=0.36 //x=75.215 //y=5.3 //x2=74.415 //y2=5.3
r1103 (  91 93 ) resistor r=0.0698411 //w=0.17 //l=0.120208 //layer=m2 \
 //thickness=0.36 //x=74.33 //y=5.215 //x2=74.415 //y2=5.3
r1104 (  90 91 ) resistor r=0.133588 //w=0.131 //l=0.14 //layer=m2 \
 //thickness=0.36 //x=74.33 //y=5.075 //x2=74.33 //y2=5.215
r1105 (  88 90 ) resistor r=0.0698411 //w=0.17 //l=0.120208 //layer=m2 \
 //thickness=0.36 //x=74.245 //y=4.99 //x2=74.33 //y2=5.075
r1106 (  88 89 ) resistor r=7.96756 //w=0.131 //l=8.35 //layer=m2 \
 //thickness=0.36 //x=74.245 //y=4.99 //x2=65.895 //y2=4.99
r1107 (  86 89 ) resistor r=0.0698411 //w=0.17 //l=0.120208 //layer=m2 \
 //thickness=0.36 //x=65.81 //y=5.075 //x2=65.895 //y2=4.99
r1108 (  86 87 ) resistor r=0.138359 //w=0.131 //l=0.145 //layer=m2 \
 //thickness=0.36 //x=65.81 //y=5.075 //x2=65.81 //y2=5.22
r1109 (  84 87 ) resistor r=0.0698411 //w=0.17 //l=0.120208 //layer=m2 \
 //thickness=0.36 //x=65.725 //y=5.305 //x2=65.81 //y2=5.22
r1110 (  84 85 ) resistor r=0.916031 //w=0.131 //l=0.96 //layer=m2 \
 //thickness=0.36 //x=65.725 //y=5.305 //x2=64.765 //y2=5.305
r1111 (  83 85 ) resistor r=0.0698411 //w=0.17 //l=0.120208 //layer=m2 \
 //thickness=0.36 //x=64.68 //y=5.22 //x2=64.765 //y2=5.305
r1112 (  82 83 ) resistor r=0.138359 //w=0.131 //l=0.145 //layer=m2 \
 //thickness=0.36 //x=64.68 //y=5.075 //x2=64.68 //y2=5.22
r1113 (  80 82 ) resistor r=0.0698411 //w=0.17 //l=0.120208 //layer=m2 \
 //thickness=0.36 //x=64.595 //y=4.99 //x2=64.68 //y2=5.075
r1114 (  80 81 ) resistor r=17.1279 //w=0.131 //l=17.95 //layer=m2 \
 //thickness=0.36 //x=64.595 //y=4.99 //x2=46.645 //y2=4.99
r1115 (  78 81 ) resistor r=0.0698411 //w=0.17 //l=0.120208 //layer=m2 \
 //thickness=0.36 //x=46.56 //y=5.075 //x2=46.645 //y2=4.99
r1116 (  78 79 ) resistor r=0.138359 //w=0.131 //l=0.145 //layer=m2 \
 //thickness=0.36 //x=46.56 //y=5.075 //x2=46.56 //y2=5.22
r1117 (  76 79 ) resistor r=0.0698411 //w=0.17 //l=0.120208 //layer=m2 \
 //thickness=0.36 //x=46.475 //y=5.305 //x2=46.56 //y2=5.22
r1118 (  76 77 ) resistor r=0.901718 //w=0.131 //l=0.945 //layer=m2 \
 //thickness=0.36 //x=46.475 //y=5.305 //x2=45.53 //y2=5.305
r1119 (  75 77 ) resistor r=0.0698411 //w=0.17 //l=0.120208 //layer=m2 \
 //thickness=0.36 //x=45.445 //y=5.22 //x2=45.53 //y2=5.305
r1120 (  74 75 ) resistor r=0.138359 //w=0.131 //l=0.145 //layer=m2 \
 //thickness=0.36 //x=45.445 //y=5.075 //x2=45.445 //y2=5.22
r1121 (  72 74 ) resistor r=0.0698411 //w=0.17 //l=0.120208 //layer=m2 \
 //thickness=0.36 //x=45.36 //y=4.99 //x2=45.445 //y2=5.075
r1122 (  72 73 ) resistor r=7.89122 //w=0.131 //l=8.27 //layer=m2 \
 //thickness=0.36 //x=45.36 //y=4.99 //x2=37.09 //y2=4.99
r1123 (  70 73 ) resistor r=0.0698411 //w=0.17 //l=0.120208 //layer=m2 \
 //thickness=0.36 //x=37.005 //y=5.075 //x2=37.09 //y2=4.99
r1124 (  70 71 ) resistor r=0.181298 //w=0.131 //l=0.19 //layer=m2 \
 //thickness=0.36 //x=37.005 //y=5.075 //x2=37.005 //y2=5.265
r1125 (  68 71 ) resistor r=0.0698411 //w=0.17 //l=0.120208 //layer=m2 \
 //thickness=0.36 //x=36.92 //y=5.35 //x2=37.005 //y2=5.265
r1126 (  68 69 ) resistor r=0.901718 //w=0.131 //l=0.945 //layer=m2 \
 //thickness=0.36 //x=36.92 //y=5.35 //x2=35.975 //y2=5.35
r1127 (  67 69 ) resistor r=0.0698411 //w=0.17 //l=0.120208 //layer=m2 \
 //thickness=0.36 //x=35.89 //y=5.265 //x2=35.975 //y2=5.35
r1128 (  66 107 ) resistor r=8.69612 //w=0.174 //l=12.105 //layer=m2 \
 //thickness=0.36 //x=35.89 //y=5.075 //x2=23.785 //y2=5.075
r1129 (  66 67 ) resistor r=0.181298 //w=0.131 //l=0.19 //layer=m2 \
 //thickness=0.36 //x=35.89 //y=5.075 //x2=35.89 //y2=5.265
r1130 (  63 186 ) resistor r=9.3 //w=0.17 //l=0.17 //layer=mcon //count=1 \
 //x=91.51 //y=2.26 //x2=91.51 //y2=2.26
r1131 (  61 120 ) resistor r=4.5 //w=0.15 //l=0.15 //layer=via1 //count=1 \
 //x=91.515 //y=4.64 //x2=91.515 //y2=4.64
r1132 (  59 191 ) resistor r=9.3 //w=0.17 //l=0.17 //layer=mcon //count=1 \
 //x=91.51 //y=4.62 //x2=91.51 //y2=4.62
r1133 (  59 61 ) resistor r=0.00659631 //w=0.379 //l=0.02 //layer=m1 \
 //thickness=0.36 //x=91.46 //y=4.62 //x2=91.46 //y2=4.64
r1134 (  56 180 ) resistor r=9.3 //w=0.17 //l=0.17 //layer=mcon //count=1 \
 //x=87.81 //y=4.62 //x2=87.81 //y2=4.62
r1135 (  56 118 ) resistor r=4.5 //w=0.15 //l=0.15 //layer=via1 //count=1 \
 //x=87.815 //y=4.62 //x2=87.815 //y2=4.62
r1136 (  54 175 ) resistor r=9.3 //w=0.17 //l=0.17 //layer=mcon //count=1 \
 //x=87.81 //y=2.26 //x2=87.81 //y2=2.26
r1137 (  50 110 ) resistor r=4.5 //w=0.15 //l=0.15 //layer=via1 //count=1 \
 //x=25.605 //y=2.755 //x2=25.605 //y2=2.755
r1138 (  50 52 ) resistor r=0.00509511 //w=0.368 //l=0.015 //layer=m1 \
 //thickness=0.36 //x=25.59 //y=2.755 //x2=25.59 //y2=2.77
r1139 (  48 170 ) resistor r=9.3 //w=0.17 //l=0.17 //layer=mcon //count=1 \
 //x=25.65 //y=4.88 //x2=25.65 //y2=4.88
r1140 (  46 161 ) resistor r=9.3 //w=0.17 //l=0.17 //layer=mcon //count=1 \
 //x=25.65 //y=2.26 //x2=25.65 //y2=2.26
r1141 (  42 103 ) resistor r=4.5 //w=0.15 //l=0.15 //layer=via1 //count=1 \
 //x=23.845 //y=2.755 //x2=23.845 //y2=2.755
r1142 (  42 44 ) resistor r=0.00509511 //w=0.368 //l=0.015 //layer=m1 \
 //thickness=0.36 //x=23.86 //y=2.755 //x2=23.86 //y2=2.77
r1143 (  39 107 ) resistor r=4.5 //w=0.15 //l=0.15 //layer=via1 //count=1 \
 //x=23.785 //y=5.095 //x2=23.785 //y2=5.095
r1144 (  39 40 ) resistor r=0.0900901 //w=0.333 //l=0.24 //layer=m1 \
 //thickness=0.36 //x=23.845 //y=5.095 //x2=23.845 //y2=5.335
r1145 (  37 39 ) resistor r=0.0394144 //w=0.333 //l=0.105 //layer=m1 \
 //thickness=0.36 //x=23.845 //y=4.99 //x2=23.845 //y2=5.095
r1146 (  35 285 ) resistor r=9.3 //w=0.17 //l=0.17 //layer=mcon //count=1 \
 //x=23.315 //y=1.19 //x2=23.315 //y2=1.19
r1147 (  33 140 ) resistor r=9.3 //w=0.17 //l=0.17 //layer=mcon //count=1 \
 //x=23.02 //y=5.56 //x2=23.02 //y2=5.56
r1148 (  30 132 ) resistor r=9.3 //w=0.17 //l=0.17 //layer=mcon //count=1 \
 //x=22.14 //y=5.56 //x2=22.14 //y2=5.56
r1149 (  28 30 ) resistor r=0.121228 //w=0.232 //l=0.225 //layer=m1 \
 //thickness=0.36 //x=22.14 //y=5.335 //x2=22.14 //y2=5.56
r1150 (  27 124 ) resistor r=9.3 //w=0.17 //l=0.17 //layer=mcon //count=1 \
 //x=21.26 //y=5.56 //x2=21.26 //y2=5.56
r1151 (  25 27 ) resistor r=0.129608 //w=0.217 //l=0.225 //layer=m1 \
 //thickness=0.36 //x=21.262 //y=5.335 //x2=21.262 //y2=5.56
r1152 (  24 59 ) resistor r=0.0863342 //w=0.379 //l=0.168152 //layer=m1 \
 //thickness=0.36 //x=91.51 //y=4.475 //x2=91.46 //y2=4.62
r1153 (  23 63 ) resistor r=0.0761125 //w=0.237 //l=0.126491 //layer=m1 \
 //thickness=0.36 //x=91.51 //y=2.385 //x2=91.507 //y2=2.26
r1154 (  23 24 ) resistor r=1.99427 //w=0.131 //l=2.09 //layer=m1 \
 //thickness=0.36 //x=91.51 //y=2.385 //x2=91.51 //y2=4.475
r1155 (  22 56 ) resistor r=0.0898201 //w=0.322 //l=0.185472 //layer=m1 \
 //thickness=0.36 //x=87.81 //y=4.46 //x2=87.865 //y2=4.62
r1156 (  21 54 ) resistor r=0.0717383 //w=0.224 //l=0.115 //layer=m1 \
 //thickness=0.36 //x=87.81 //y=2.375 //x2=87.81 //y2=2.26
r1157 (  21 22 ) resistor r=1.9895 //w=0.131 //l=2.085 //layer=m1 \
 //thickness=0.36 //x=87.81 //y=2.375 //x2=87.81 //y2=4.46
r1158 (  20 48 ) resistor r=0.0760407 //w=0.238 //l=0.125 //layer=m1 \
 //thickness=0.36 //x=25.65 //y=4.755 //x2=25.65 //y2=4.88
r1159 (  19 52 ) resistor r=0.0857585 //w=0.368 //l=0.172409 //layer=m1 \
 //thickness=0.36 //x=25.65 //y=2.915 //x2=25.59 //y2=2.77
r1160 (  19 20 ) resistor r=1.75573 //w=0.131 //l=1.84 //layer=m1 \
 //thickness=0.36 //x=25.65 //y=2.915 //x2=25.65 //y2=4.755
r1161 (  18 50 ) resistor r=0.0908536 //w=0.368 //l=0.187617 //layer=m1 \
 //thickness=0.36 //x=25.65 //y=2.595 //x2=25.59 //y2=2.755
r1162 (  17 46 ) resistor r=0.0719237 //w=0.222 //l=0.115 //layer=m1 \
 //thickness=0.36 //x=25.65 //y=2.375 //x2=25.65 //y2=2.26
r1163 (  17 18 ) resistor r=0.209924 //w=0.131 //l=0.22 //layer=m1 \
 //thickness=0.36 //x=25.65 //y=2.375 //x2=25.65 //y2=2.595
r1164 (  16 37 ) resistor r=0.0730397 //w=0.333 //l=0.135647 //layer=m1 \
 //thickness=0.36 //x=23.8 //y=4.875 //x2=23.845 //y2=4.99
r1165 (  15 44 ) resistor r=0.0857585 //w=0.368 //l=0.172409 //layer=m1 \
 //thickness=0.36 //x=23.8 //y=2.915 //x2=23.86 //y2=2.77
r1166 (  15 16 ) resistor r=1.87023 //w=0.131 //l=1.96 //layer=m1 \
 //thickness=0.36 //x=23.8 //y=2.915 //x2=23.8 //y2=4.875
r1167 (  14 42 ) resistor r=0.0908536 //w=0.368 //l=0.187617 //layer=m1 \
 //thickness=0.36 //x=23.8 //y=2.595 //x2=23.86 //y2=2.755
r1168 (  13 14 ) resistor r=0.634542 //w=0.131 //l=0.665 //layer=m1 \
 //thickness=0.36 //x=23.8 //y=1.93 //x2=23.8 //y2=2.595
r1169 (  11 13 ) resistor r=0.0698411 //w=0.17 //l=0.120208 //layer=m1 \
 //thickness=0.36 //x=23.715 //y=1.845 //x2=23.8 //y2=1.93
r1170 (  11 12 ) resistor r=0.300573 //w=0.131 //l=0.315 //layer=m1 \
 //thickness=0.36 //x=23.715 //y=1.845 //x2=23.4 //y2=1.845
r1171 (  10 12 ) resistor r=0.0698411 //w=0.17 //l=0.120208 //layer=m1 \
 //thickness=0.36 //x=23.315 //y=1.76 //x2=23.4 //y2=1.845
r1172 (  9 35 ) resistor r=0.0717383 //w=0.224 //l=0.115 //layer=m1 \
 //thickness=0.36 //x=23.315 //y=1.305 //x2=23.315 //y2=1.19
r1173 (  9 10 ) resistor r=0.43416 //w=0.131 //l=0.455 //layer=m1 \
 //thickness=0.36 //x=23.315 //y=1.305 //x2=23.315 //y2=1.76
r1174 (  8 31 ) resistor r=0.0675342 //w=0.23 //l=0.115 //layer=m1 \
 //thickness=0.36 //x=23.135 //y=5.335 //x2=23.02 //y2=5.335
r1175 (  7 40 ) resistor r=0.0479249 //w=0.333 //l=0.22 //layer=m1 \
 //thickness=0.36 //x=23.625 //y=5.335 //x2=23.845 //y2=5.335
r1176 (  7 8 ) resistor r=0.467557 //w=0.131 //l=0.49 //layer=m1 \
 //thickness=0.36 //x=23.625 //y=5.335 //x2=23.135 //y2=5.335
r1177 (  6 33 ) resistor r=0.00118313 //w=0.23 //layer=m1 //thickness=0.36 \
 //x=23.02 //y=5.56 //x2=23.02 //y2=5.56
r1178 (  5 31 ) resistor r=0.002872 //w=0.34 //l=0.085 //layer=m1 \
 //thickness=0.36 //x=23.02 //y=5.42 //x2=23.02 //y2=5.335
r1179 (  5 6 ) resistor r=0.091623 //w=0.191 //l=0.14 //layer=m1 \
 //thickness=0.36 //x=23.02 //y=5.42 //x2=23.02 //y2=5.56
r1180 (  4 28 ) resistor r=0.0262263 //w=0.232 //l=0.12 //layer=m1 \
 //thickness=0.36 //x=22.26 //y=5.335 //x2=22.14 //y2=5.335
r1181 (  3 31 ) resistor r=0.0675342 //w=0.23 //l=0.115 //layer=m1 \
 //thickness=0.36 //x=22.905 //y=5.335 //x2=23.02 //y2=5.335
r1182 (  3 4 ) resistor r=0.615458 //w=0.131 //l=0.645 //layer=m1 \
 //thickness=0.36 //x=22.905 //y=5.335 //x2=22.26 //y2=5.335
r1183 (  2 25 ) resistor r=0.0222262 //w=0.217 //l=0.118 //layer=m1 \
 //thickness=0.36 //x=21.38 //y=5.335 //x2=21.262 //y2=5.335
r1184 (  1 28 ) resistor r=0.0262263 //w=0.232 //l=0.12 //layer=m1 \
 //thickness=0.36 //x=22.02 //y=5.335 //x2=22.14 //y2=5.335
r1185 (  1 2 ) resistor r=0.610687 //w=0.131 //l=0.64 //layer=m1 \
 //thickness=0.36 //x=22.02 //y=5.335 //x2=21.38 //y2=5.335
ends PM_TMRDFFSNRNQNX1\%noxref_4

subckt PM_TMRDFFSNRNQNX1\%noxref_5 ( 1 2 3 4 5 6 7 8 9 11 14 15 17 18 19 20 22 \
 23 24 25 26 27 28 34 38 45 48 51 57 61 70 72 73 77 80 81 87 96 101 110 115 \
 123 131 148 157 161 162 163 164 165 166 167 168 169 173 174 175 180 182 185 \
 186 190 191 192 197 199 202 203 207 208 209 214 216 219 220 222 223 228 232 \
 233 238 242 243 248 251 253 254 255 )
c598 ( 251 0 ) capacitor c=0.00885916f //x=18.315 //y=1.095
c599 ( 248 0 ) capacitor c=0.0651477f //x=27.87 //y=4.88
c600 ( 243 0 ) capacitor c=0.0278202f //x=27.87 //y=2.095
c601 ( 242 0 ) capacitor c=0.0503043f //x=27.87 //y=2.26
c602 ( 238 0 ) capacitor c=0.0651406f //x=13.44 //y=4.88
c603 ( 233 0 ) capacitor c=0.0278202f //x=13.44 //y=2.095
c604 ( 232 0 ) capacitor c=0.0503043f //x=13.44 //y=2.26
c605 ( 228 0 ) capacitor c=0.0653609f //x=8.63 //y=4.88
c606 ( 223 0 ) capacitor c=0.0278202f //x=8.63 //y=2.095
c607 ( 222 0 ) capacitor c=0.0503043f //x=8.63 //y=2.26
c608 ( 220 0 ) capacitor c=0.0443175f //x=28.39 //y=1.44
c609 ( 219 0 ) capacitor c=0.0199703f //x=28.39 //y=1.095
c610 ( 216 0 ) capacitor c=0.0162526f //x=28.235 //y=1.595
c611 ( 214 0 ) capacitor c=0.0157807f //x=28.235 //y=0.94
c612 ( 209 0 ) capacitor c=0.0220935f //x=27.86 //y=1.75
c613 ( 208 0 ) capacitor c=0.0207489f //x=27.86 //y=1.44
c614 ( 207 0 ) capacitor c=0.0194091f //x=27.86 //y=1.095
c615 ( 203 0 ) capacitor c=0.0443175f //x=13.96 //y=1.44
c616 ( 202 0 ) capacitor c=0.0199703f //x=13.96 //y=1.095
c617 ( 199 0 ) capacitor c=0.0162526f //x=13.805 //y=1.595
c618 ( 197 0 ) capacitor c=0.0157807f //x=13.805 //y=0.94
c619 ( 192 0 ) capacitor c=0.0220935f //x=13.43 //y=1.75
c620 ( 191 0 ) capacitor c=0.0207489f //x=13.43 //y=1.44
c621 ( 190 0 ) capacitor c=0.0194091f //x=13.43 //y=1.095
c622 ( 186 0 ) capacitor c=0.0443175f //x=9.15 //y=1.44
c623 ( 185 0 ) capacitor c=0.0199703f //x=9.15 //y=1.095
c624 ( 182 0 ) capacitor c=0.0162526f //x=8.995 //y=1.595
c625 ( 180 0 ) capacitor c=0.0157807f //x=8.995 //y=0.94
c626 ( 175 0 ) capacitor c=0.0220935f //x=8.62 //y=1.75
c627 ( 174 0 ) capacitor c=0.0207489f //x=8.62 //y=1.44
c628 ( 173 0 ) capacitor c=0.0194091f //x=8.62 //y=1.095
c629 ( 169 0 ) capacitor c=0.159671f //x=28.05 //y=6.2
c630 ( 168 0 ) capacitor c=0.110208f //x=27.61 //y=6.2
c631 ( 167 0 ) capacitor c=0.159671f //x=13.62 //y=6.2
c632 ( 166 0 ) capacitor c=0.110208f //x=13.18 //y=6.2
c633 ( 165 0 ) capacitor c=0.159671f //x=8.81 //y=6.2
c634 ( 164 0 ) capacitor c=0.110208f //x=8.37 //y=6.2
c635 ( 157 0 ) capacitor c=9.5006e-19 //x=27.87 //y=4.88
c636 ( 148 0 ) capacitor c=0.00101179f //x=27.87 //y=2.26
c637 ( 131 0 ) capacitor c=0.0293124f //x=18.21 //y=5.56
c638 ( 123 0 ) capacitor c=0.029137f //x=17.33 //y=5.56
c639 ( 115 0 ) capacitor c=0.0278099f //x=16.45 //y=5.56
c640 ( 110 0 ) capacitor c=7.7417e-19 //x=13.44 //y=4.88
c641 ( 101 0 ) capacitor c=0.00101179f //x=13.44 //y=2.26
c642 ( 96 0 ) capacitor c=7.7417e-19 //x=8.63 //y=4.88
c643 ( 87 0 ) capacitor c=0.00101179f //x=8.63 //y=2.26
c644 ( 81 0 ) capacitor c=6.2466e-19 //x=13.6 //y=3.895
c645 ( 80 0 ) capacitor c=0.0446269f //x=13.28 //y=3.895
c646 ( 77 0 ) capacitor c=6.16295e-19 //x=8.79 //y=3.895
c647 ( 73 0 ) capacitor c=0.0212158f //x=20.705 //y=3.895
c648 ( 72 0 ) capacitor c=0.0710808f //x=21.05 //y=3.895
c649 ( 70 0 ) capacitor c=0.0535679f //x=18.82 //y=3.88
c650 ( 61 0 ) capacitor c=0.0149589f //x=27.87 //y=3.88
c651 ( 57 0 ) capacitor c=0.0158949f //x=18.99 //y=3.88
c652 ( 51 0 ) capacitor c=0.00111241f //x=18.21 //y=5.335
c653 ( 48 0 ) capacitor c=0.00731246f //x=17.33 //y=5.335
c654 ( 45 0 ) capacitor c=0.0111234f //x=16.452 //y=5.335
c655 ( 38 0 ) capacitor c=0.0149589f //x=13.44 //y=3.88
c656 ( 34 0 ) capacitor c=0.0149589f //x=8.63 //y=3.88
c657 ( 28 0 ) capacitor c=0.0180445f //x=27.87 //y=4.75
c658 ( 27 0 ) capacitor c=0.011467f //x=27.87 //y=4.045
c659 ( 26 0 ) capacitor c=0.0291048f //x=27.87 //y=3.725
c660 ( 25 0 ) capacitor c=0.00556102f //x=27.87 //y=2.375
c661 ( 24 0 ) capacitor c=0.0323149f //x=18.99 //y=5.25
c662 ( 23 0 ) capacitor c=0.0138897f //x=18.99 //y=4.055
c663 ( 22 0 ) capacitor c=0.0490588f //x=18.99 //y=3.735
c664 ( 20 0 ) capacitor c=0.00493487f //x=18.59 //y=1.845
c665 ( 19 0 ) capacitor c=0.0133342f //x=18.905 //y=1.845
c666 ( 18 0 ) capacitor c=0.0167992f //x=18.505 //y=1.76
c667 ( 17 0 ) capacitor c=0.0111491f //x=18.505 //y=1.305
c668 ( 15 0 ) capacitor c=0.0238276f //x=18.905 //y=5.335
c669 ( 14 0 ) capacitor c=0.00933983f //x=18.21 //y=5.56
c670 ( 11 0 ) capacitor c=0.019596f //x=18.095 //y=5.335
c671 ( 9 0 ) capacitor c=0.0148057f //x=17.21 //y=5.335
c672 ( 8 0 ) capacitor c=0.0195876f //x=13.44 //y=4.75
c673 ( 7 0 ) capacitor c=0.011494f //x=13.44 //y=4.055
c674 ( 6 0 ) capacitor c=0.029293f //x=13.44 //y=3.735
c675 ( 5 0 ) capacitor c=0.00556102f //x=13.44 //y=2.375
c676 ( 4 0 ) capacitor c=0.019633f //x=8.63 //y=4.75
c677 ( 3 0 ) capacitor c=0.0115187f //x=8.63 //y=4.055
c678 ( 2 0 ) capacitor c=0.0329467f //x=8.63 //y=3.735
c679 ( 1 0 ) capacitor c=0.00556102f //x=8.63 //y=2.375
r680 (  242 243 ) resistor r=52.7279 //w=0.214 //l=0.165 //layer=ply \
 //thickness=0.18 //x=27.87 //y=2.26 //x2=27.87 //y2=2.095
r681 (  232 233 ) resistor r=52.7279 //w=0.214 //l=0.165 //layer=ply \
 //thickness=0.18 //x=13.44 //y=2.26 //x2=13.44 //y2=2.095
r682 (  222 223 ) resistor r=52.7279 //w=0.214 //l=0.165 //layer=ply \
 //thickness=0.18 //x=8.63 //y=2.26 //x2=8.63 //y2=2.095
r683 (  220 250 ) resistor r=45.1352 //w=0.168 //l=0.173853 //layer=ply \
 //thickness=0.18 //x=28.39 //y=1.44 //x2=28.35 //y2=1.595
r684 (  219 249 ) resistor r=45.1352 //w=0.168 //l=0.173853 //layer=ply \
 //thickness=0.18 //x=28.39 //y=1.095 //x2=28.35 //y2=0.94
r685 (  219 220 ) resistor r=176.904 //w=0.094 //l=0.345 //layer=ply \
 //thickness=0.18 //x=28.39 //y=1.095 //x2=28.39 //y2=1.44
r686 (  217 246 ) resistor r=10.701 //w=0.21 //l=0.115 //layer=ply \
 //thickness=0.18 //x=28.015 //y=1.595 //x2=27.9 //y2=1.595
r687 (  216 250 ) resistor r=5.52526 //w=0.168 //l=0.115 //layer=ply \
 //thickness=0.18 //x=28.235 //y=1.595 //x2=28.35 //y2=1.595
r688 (  215 245 ) resistor r=5.52526 //w=0.168 //l=0.115 //layer=ply \
 //thickness=0.18 //x=28.015 //y=0.94 //x2=27.9 //y2=0.94
r689 (  214 249 ) resistor r=5.52526 //w=0.168 //l=0.115 //layer=ply \
 //thickness=0.18 //x=28.235 //y=0.94 //x2=28.35 //y2=0.94
r690 (  214 215 ) resistor r=112.809 //w=0.094 //l=0.22 //layer=ply \
 //thickness=0.18 //x=28.235 //y=0.94 //x2=28.015 //y2=0.94
r691 (  211 248 ) resistor r=37.236 //w=0.233 //l=0.249199 //layer=ply \
 //thickness=0.18 //x=28.05 //y=5.045 //x2=27.87 //y2=4.88
r692 (  209 246 ) resistor r=39.5823 //w=0.21 //l=0.173853 //layer=ply \
 //thickness=0.18 //x=27.86 //y=1.75 //x2=27.9 //y2=1.595
r693 (  209 243 ) resistor r=176.904 //w=0.094 //l=0.345 //layer=ply \
 //thickness=0.18 //x=27.86 //y=1.75 //x2=27.86 //y2=2.095
r694 (  208 246 ) resistor r=39.5823 //w=0.21 //l=0.173853 //layer=ply \
 //thickness=0.18 //x=27.86 //y=1.44 //x2=27.9 //y2=1.595
r695 (  207 245 ) resistor r=45.1352 //w=0.168 //l=0.173853 //layer=ply \
 //thickness=0.18 //x=27.86 //y=1.095 //x2=27.9 //y2=0.94
r696 (  207 208 ) resistor r=176.904 //w=0.094 //l=0.345 //layer=ply \
 //thickness=0.18 //x=27.86 //y=1.095 //x2=27.86 //y2=1.44
r697 (  204 248 ) resistor r=53.7854 //w=0.233 //l=0.332415 //layer=ply \
 //thickness=0.18 //x=27.61 //y=5.045 //x2=27.87 //y2=4.88
r698 (  203 240 ) resistor r=45.1352 //w=0.168 //l=0.173853 //layer=ply \
 //thickness=0.18 //x=13.96 //y=1.44 //x2=13.92 //y2=1.595
r699 (  202 239 ) resistor r=45.1352 //w=0.168 //l=0.173853 //layer=ply \
 //thickness=0.18 //x=13.96 //y=1.095 //x2=13.92 //y2=0.94
r700 (  202 203 ) resistor r=176.904 //w=0.094 //l=0.345 //layer=ply \
 //thickness=0.18 //x=13.96 //y=1.095 //x2=13.96 //y2=1.44
r701 (  200 236 ) resistor r=10.701 //w=0.21 //l=0.115 //layer=ply \
 //thickness=0.18 //x=13.585 //y=1.595 //x2=13.47 //y2=1.595
r702 (  199 240 ) resistor r=5.52526 //w=0.168 //l=0.115 //layer=ply \
 //thickness=0.18 //x=13.805 //y=1.595 //x2=13.92 //y2=1.595
r703 (  198 235 ) resistor r=5.52526 //w=0.168 //l=0.115 //layer=ply \
 //thickness=0.18 //x=13.585 //y=0.94 //x2=13.47 //y2=0.94
r704 (  197 239 ) resistor r=5.52526 //w=0.168 //l=0.115 //layer=ply \
 //thickness=0.18 //x=13.805 //y=0.94 //x2=13.92 //y2=0.94
r705 (  197 198 ) resistor r=112.809 //w=0.094 //l=0.22 //layer=ply \
 //thickness=0.18 //x=13.805 //y=0.94 //x2=13.585 //y2=0.94
r706 (  194 238 ) resistor r=37.236 //w=0.233 //l=0.249199 //layer=ply \
 //thickness=0.18 //x=13.62 //y=5.045 //x2=13.44 //y2=4.88
r707 (  192 236 ) resistor r=39.5823 //w=0.21 //l=0.173853 //layer=ply \
 //thickness=0.18 //x=13.43 //y=1.75 //x2=13.47 //y2=1.595
r708 (  192 233 ) resistor r=176.904 //w=0.094 //l=0.345 //layer=ply \
 //thickness=0.18 //x=13.43 //y=1.75 //x2=13.43 //y2=2.095
r709 (  191 236 ) resistor r=39.5823 //w=0.21 //l=0.173853 //layer=ply \
 //thickness=0.18 //x=13.43 //y=1.44 //x2=13.47 //y2=1.595
r710 (  190 235 ) resistor r=45.1352 //w=0.168 //l=0.173853 //layer=ply \
 //thickness=0.18 //x=13.43 //y=1.095 //x2=13.47 //y2=0.94
r711 (  190 191 ) resistor r=176.904 //w=0.094 //l=0.345 //layer=ply \
 //thickness=0.18 //x=13.43 //y=1.095 //x2=13.43 //y2=1.44
r712 (  187 238 ) resistor r=53.7854 //w=0.233 //l=0.332415 //layer=ply \
 //thickness=0.18 //x=13.18 //y=5.045 //x2=13.44 //y2=4.88
r713 (  186 230 ) resistor r=45.1352 //w=0.168 //l=0.173853 //layer=ply \
 //thickness=0.18 //x=9.15 //y=1.44 //x2=9.11 //y2=1.595
r714 (  185 229 ) resistor r=45.1352 //w=0.168 //l=0.173853 //layer=ply \
 //thickness=0.18 //x=9.15 //y=1.095 //x2=9.11 //y2=0.94
r715 (  185 186 ) resistor r=176.904 //w=0.094 //l=0.345 //layer=ply \
 //thickness=0.18 //x=9.15 //y=1.095 //x2=9.15 //y2=1.44
r716 (  183 226 ) resistor r=10.701 //w=0.21 //l=0.115 //layer=ply \
 //thickness=0.18 //x=8.775 //y=1.595 //x2=8.66 //y2=1.595
r717 (  182 230 ) resistor r=5.52526 //w=0.168 //l=0.115 //layer=ply \
 //thickness=0.18 //x=8.995 //y=1.595 //x2=9.11 //y2=1.595
r718 (  181 225 ) resistor r=5.52526 //w=0.168 //l=0.115 //layer=ply \
 //thickness=0.18 //x=8.775 //y=0.94 //x2=8.66 //y2=0.94
r719 (  180 229 ) resistor r=5.52526 //w=0.168 //l=0.115 //layer=ply \
 //thickness=0.18 //x=8.995 //y=0.94 //x2=9.11 //y2=0.94
r720 (  180 181 ) resistor r=112.809 //w=0.094 //l=0.22 //layer=ply \
 //thickness=0.18 //x=8.995 //y=0.94 //x2=8.775 //y2=0.94
r721 (  177 228 ) resistor r=37.236 //w=0.233 //l=0.249199 //layer=ply \
 //thickness=0.18 //x=8.81 //y=5.045 //x2=8.63 //y2=4.88
r722 (  175 226 ) resistor r=39.5823 //w=0.21 //l=0.173853 //layer=ply \
 //thickness=0.18 //x=8.62 //y=1.75 //x2=8.66 //y2=1.595
r723 (  175 223 ) resistor r=176.904 //w=0.094 //l=0.345 //layer=ply \
 //thickness=0.18 //x=8.62 //y=1.75 //x2=8.62 //y2=2.095
r724 (  174 226 ) resistor r=39.5823 //w=0.21 //l=0.173853 //layer=ply \
 //thickness=0.18 //x=8.62 //y=1.44 //x2=8.66 //y2=1.595
r725 (  173 225 ) resistor r=45.1352 //w=0.168 //l=0.173853 //layer=ply \
 //thickness=0.18 //x=8.62 //y=1.095 //x2=8.66 //y2=0.94
r726 (  173 174 ) resistor r=176.904 //w=0.094 //l=0.345 //layer=ply \
 //thickness=0.18 //x=8.62 //y=1.095 //x2=8.62 //y2=1.44
r727 (  170 228 ) resistor r=53.7854 //w=0.233 //l=0.332415 //layer=ply \
 //thickness=0.18 //x=8.37 //y=5.045 //x2=8.63 //y2=4.88
r728 (  169 211 ) resistor r=592.245 //w=0.094 //l=1.155 //layer=ply \
 //thickness=0.18 //x=28.05 //y=6.2 //x2=28.05 //y2=5.045
r729 (  168 204 ) resistor r=592.245 //w=0.094 //l=1.155 //layer=ply \
 //thickness=0.18 //x=27.61 //y=6.2 //x2=27.61 //y2=5.045
r730 (  167 194 ) resistor r=592.245 //w=0.094 //l=1.155 //layer=ply \
 //thickness=0.18 //x=13.62 //y=6.2 //x2=13.62 //y2=5.045
r731 (  166 187 ) resistor r=592.245 //w=0.094 //l=1.155 //layer=ply \
 //thickness=0.18 //x=13.18 //y=6.2 //x2=13.18 //y2=5.045
r732 (  165 177 ) resistor r=592.245 //w=0.094 //l=1.155 //layer=ply \
 //thickness=0.18 //x=8.81 //y=6.2 //x2=8.81 //y2=5.045
r733 (  164 170 ) resistor r=592.245 //w=0.094 //l=1.155 //layer=ply \
 //thickness=0.18 //x=8.37 //y=6.2 //x2=8.37 //y2=5.045
r734 (  163 216 ) resistor r=56.4043 //w=0.094 //l=0.11 //layer=ply \
 //thickness=0.18 //x=28.125 //y=1.595 //x2=28.235 //y2=1.595
r735 (  163 217 ) resistor r=56.4043 //w=0.094 //l=0.11 //layer=ply \
 //thickness=0.18 //x=28.125 //y=1.595 //x2=28.015 //y2=1.595
r736 (  162 199 ) resistor r=56.4043 //w=0.094 //l=0.11 //layer=ply \
 //thickness=0.18 //x=13.695 //y=1.595 //x2=13.805 //y2=1.595
r737 (  162 200 ) resistor r=56.4043 //w=0.094 //l=0.11 //layer=ply \
 //thickness=0.18 //x=13.695 //y=1.595 //x2=13.585 //y2=1.595
r738 (  161 182 ) resistor r=56.4043 //w=0.094 //l=0.11 //layer=ply \
 //thickness=0.18 //x=8.885 //y=1.595 //x2=8.995 //y2=1.595
r739 (  161 183 ) resistor r=56.4043 //w=0.094 //l=0.11 //layer=ply \
 //thickness=0.18 //x=8.885 //y=1.595 //x2=8.775 //y2=1.595
r740 (  157 248 ) resistor r=152 //w=0.17 //l=0.17 //layer=licon //count=1 \
 //x=27.87 //y=4.88 //x2=27.87 //y2=4.88
r741 (  148 242 ) resistor r=152 //w=0.17 //l=0.17 //layer=licon //count=1 \
 //x=27.87 //y=2.26 //x2=27.87 //y2=2.26
r742 (  131 255 ) resistor r=23.615 //w=0.187 //l=0.345 //layer=li \
 //thickness=0.1 //x=18.21 //y=5.56 //x2=18.21 //y2=5.905
r743 (  123 254 ) resistor r=23.615 //w=0.187 //l=0.345 //layer=li \
 //thickness=0.1 //x=17.33 //y=5.56 //x2=17.33 //y2=5.905
r744 (  115 253 ) resistor r=23.615 //w=0.187 //l=0.345 //layer=li \
 //thickness=0.1 //x=16.45 //y=5.56 //x2=16.45 //y2=5.905
r745 (  110 238 ) resistor r=152 //w=0.17 //l=0.17 //layer=licon //count=1 \
 //x=13.44 //y=4.88 //x2=13.44 //y2=4.88
r746 (  101 232 ) resistor r=152 //w=0.17 //l=0.17 //layer=licon //count=1 \
 //x=13.44 //y=2.26 //x2=13.44 //y2=2.26
r747 (  96 228 ) resistor r=152 //w=0.17 //l=0.17 //layer=licon //count=1 \
 //x=8.63 //y=4.88 //x2=8.63 //y2=4.88
r748 (  87 222 ) resistor r=152 //w=0.17 //l=0.17 //layer=licon //count=1 \
 //x=8.63 //y=2.26 //x2=8.63 //y2=2.26
r749 (  79 81 ) resistor r=0.10734 //w=0.281 //l=0.16 //layer=m2 \
 //thickness=0.36 //x=13.44 //y=3.895 //x2=13.6 //y2=3.895
r750 (  79 80 ) resistor r=0.10734 //w=0.281 //l=0.16 //layer=m2 \
 //thickness=0.36 //x=13.44 //y=3.895 //x2=13.28 //y2=3.895
r751 (  77 80 ) resistor r=4.28435 //w=0.131 //l=4.49 //layer=m2 \
 //thickness=0.36 //x=8.79 //y=3.88 //x2=13.28 //y2=3.88
r752 (  75 77 ) resistor r=0.10734 //w=0.281 //l=0.16 //layer=m2 \
 //thickness=0.36 //x=8.63 //y=3.895 //x2=8.79 //y2=3.895
r753 (  73 83 ) resistor r=1.10266 //w=0.196 //l=1.725 //layer=m2 \
 //thickness=0.36 //x=20.705 //y=3.895 //x2=18.98 //y2=3.895
r754 (  72 85 ) resistor r=4.81638 //w=0.177 //l=6.825 //layer=m2 \
 //thickness=0.36 //x=21.05 //y=3.895 //x2=27.87 //y2=3.885
r755 (  72 73 ) resistor r=0.329198 //w=0.131 //l=0.345 //layer=m2 \
 //thickness=0.36 //x=21.05 //y=3.895 //x2=20.705 //y2=3.895
r756 (  70 83 ) resistor r=0.104578 //w=0.196 //l=0.167332 //layer=m2 \
 //thickness=0.36 //x=18.82 //y=3.88 //x2=18.98 //y2=3.895
r757 (  70 81 ) resistor r=4.98092 //w=0.131 //l=5.22 //layer=m2 \
 //thickness=0.36 //x=18.82 //y=3.88 //x2=13.6 //y2=3.88
r758 (  67 157 ) resistor r=9.3 //w=0.17 //l=0.17 //layer=mcon //count=1 \
 //x=27.87 //y=4.88 //x2=27.87 //y2=4.88
r759 (  65 148 ) resistor r=9.3 //w=0.17 //l=0.17 //layer=mcon //count=1 \
 //x=27.87 //y=2.26 //x2=27.87 //y2=2.26
r760 (  63 85 ) resistor r=4.5 //w=0.15 //l=0.15 //layer=via1 //count=1 \
 //x=27.87 //y=3.885 //x2=27.87 //y2=3.885
r761 (  61 63 ) resistor r=0.00166223 //w=0.376 //l=0.005 //layer=m1 \
 //thickness=0.36 //x=27.817 //y=3.88 //x2=27.817 //y2=3.885
r762 (  59 83 ) resistor r=4.5 //w=0.15 //l=0.15 //layer=via1 //count=1 \
 //x=18.98 //y=3.895 //x2=18.98 //y2=3.895
r763 (  57 59 ) resistor r=0.00490838 //w=0.382 //l=0.015 //layer=m1 \
 //thickness=0.36 //x=19.037 //y=3.88 //x2=19.037 //y2=3.895
r764 (  55 251 ) resistor r=9.3 //w=0.17 //l=0.17 //layer=mcon //count=1 \
 //x=18.505 //y=1.19 //x2=18.505 //y2=1.19
r765 (  53 131 ) resistor r=9.3 //w=0.17 //l=0.17 //layer=mcon //count=1 \
 //x=18.21 //y=5.56 //x2=18.21 //y2=5.56
r766 (  50 123 ) resistor r=9.3 //w=0.17 //l=0.17 //layer=mcon //count=1 \
 //x=17.33 //y=5.56 //x2=17.33 //y2=5.56
r767 (  48 50 ) resistor r=0.121228 //w=0.232 //l=0.225 //layer=m1 \
 //thickness=0.36 //x=17.33 //y=5.335 //x2=17.33 //y2=5.56
r768 (  47 115 ) resistor r=9.3 //w=0.17 //l=0.17 //layer=mcon //count=1 \
 //x=16.45 //y=5.56 //x2=16.45 //y2=5.56
r769 (  45 47 ) resistor r=0.129608 //w=0.217 //l=0.225 //layer=m1 \
 //thickness=0.36 //x=16.452 //y=5.335 //x2=16.452 //y2=5.56
r770 (  44 110 ) resistor r=9.3 //w=0.17 //l=0.17 //layer=mcon //count=1 \
 //x=13.44 //y=4.88 //x2=13.44 //y2=4.88
r771 (  42 101 ) resistor r=9.3 //w=0.17 //l=0.17 //layer=mcon //count=1 \
 //x=13.44 //y=2.26 //x2=13.44 //y2=2.26
r772 (  40 79 ) resistor r=4.5 //w=0.15 //l=0.15 //layer=via1 //count=1 \
 //x=13.44 //y=3.895 //x2=13.44 //y2=3.895
r773 (  38 40 ) resistor r=0.0049867 //w=0.376 //l=0.015 //layer=m1 \
 //thickness=0.36 //x=13.387 //y=3.88 //x2=13.387 //y2=3.895
r774 (  36 75 ) resistor r=4.5 //w=0.15 //l=0.15 //layer=via1 //count=1 \
 //x=8.63 //y=3.895 //x2=8.63 //y2=3.895
r775 (  34 36 ) resistor r=0.0049867 //w=0.376 //l=0.015 //layer=m1 \
 //thickness=0.36 //x=8.682 //y=3.88 //x2=8.682 //y2=3.895
r776 (  32 96 ) resistor r=9.3 //w=0.17 //l=0.17 //layer=mcon //count=1 \
 //x=8.63 //y=4.88 //x2=8.63 //y2=4.88
r777 (  30 87 ) resistor r=9.3 //w=0.17 //l=0.17 //layer=mcon //count=1 \
 //x=8.63 //y=2.26 //x2=8.63 //y2=2.26
r778 (  28 67 ) resistor r=0.0801089 //w=0.224 //l=0.13 //layer=m1 \
 //thickness=0.36 //x=27.87 //y=4.75 //x2=27.87 //y2=4.88
r779 (  27 63 ) resistor r=0.0911593 //w=0.376 //l=0.184608 //layer=m1 \
 //thickness=0.36 //x=27.87 //y=4.045 //x2=27.817 //y2=3.885
r780 (  27 28 ) resistor r=0.67271 //w=0.131 //l=0.705 //layer=m1 \
 //thickness=0.36 //x=27.87 //y=4.045 //x2=27.87 //y2=4.75
r781 (  26 61 ) resistor r=0.0894971 //w=0.376 //l=0.179555 //layer=m1 \
 //thickness=0.36 //x=27.87 //y=3.725 //x2=27.817 //y2=3.88
r782 (  25 65 ) resistor r=0.0719237 //w=0.222 //l=0.115 //layer=m1 \
 //thickness=0.36 //x=27.87 //y=2.375 //x2=27.87 //y2=2.26
r783 (  25 26 ) resistor r=1.28817 //w=0.131 //l=1.35 //layer=m1 \
 //thickness=0.36 //x=27.87 //y=2.375 //x2=27.87 //y2=3.725
r784 (  23 59 ) resistor r=0.0914072 //w=0.382 //l=0.181989 //layer=m1 \
 //thickness=0.36 //x=18.99 //y=4.055 //x2=19.037 //y2=3.895
r785 (  23 24 ) resistor r=1.14027 //w=0.131 //l=1.195 //layer=m1 \
 //thickness=0.36 //x=18.99 //y=4.055 //x2=18.99 //y2=5.25
r786 (  22 57 ) resistor r=0.0864989 //w=0.382 //l=0.166853 //layer=m1 \
 //thickness=0.36 //x=18.99 //y=3.735 //x2=19.037 //y2=3.88
r787 (  21 22 ) resistor r=1.72233 //w=0.131 //l=1.805 //layer=m1 \
 //thickness=0.36 //x=18.99 //y=1.93 //x2=18.99 //y2=3.735
r788 (  19 21 ) resistor r=0.0698411 //w=0.17 //l=0.120208 //layer=m1 \
 //thickness=0.36 //x=18.905 //y=1.845 //x2=18.99 //y2=1.93
r789 (  19 20 ) resistor r=0.300573 //w=0.131 //l=0.315 //layer=m1 \
 //thickness=0.36 //x=18.905 //y=1.845 //x2=18.59 //y2=1.845
r790 (  18 20 ) resistor r=0.0698411 //w=0.17 //l=0.120208 //layer=m1 \
 //thickness=0.36 //x=18.505 //y=1.76 //x2=18.59 //y2=1.845
r791 (  17 55 ) resistor r=0.0717383 //w=0.224 //l=0.115 //layer=m1 \
 //thickness=0.36 //x=18.505 //y=1.305 //x2=18.505 //y2=1.19
r792 (  17 18 ) resistor r=0.43416 //w=0.131 //l=0.455 //layer=m1 \
 //thickness=0.36 //x=18.505 //y=1.305 //x2=18.505 //y2=1.76
r793 (  16 51 ) resistor r=0.0675342 //w=0.23 //l=0.115 //layer=m1 \
 //thickness=0.36 //x=18.325 //y=5.335 //x2=18.21 //y2=5.335
r794 (  15 24 ) resistor r=0.0698411 //w=0.17 //l=0.120208 //layer=m1 \
 //thickness=0.36 //x=18.905 //y=5.335 //x2=18.99 //y2=5.25
r795 (  15 16 ) resistor r=0.553435 //w=0.131 //l=0.58 //layer=m1 \
 //thickness=0.36 //x=18.905 //y=5.335 //x2=18.325 //y2=5.335
r796 (  14 53 ) resistor r=0.00118313 //w=0.23 //layer=m1 //thickness=0.36 \
 //x=18.21 //y=5.56 //x2=18.21 //y2=5.56
r797 (  13 51 ) resistor r=0.002872 //w=0.34 //l=0.085 //layer=m1 \
 //thickness=0.36 //x=18.21 //y=5.42 //x2=18.21 //y2=5.335
r798 (  13 14 ) resistor r=0.091623 //w=0.191 //l=0.14 //layer=m1 \
 //thickness=0.36 //x=18.21 //y=5.42 //x2=18.21 //y2=5.56
r799 (  12 48 ) resistor r=0.0262263 //w=0.232 //l=0.12 //layer=m1 \
 //thickness=0.36 //x=17.45 //y=5.335 //x2=17.33 //y2=5.335
r800 (  11 51 ) resistor r=0.0675342 //w=0.23 //l=0.115 //layer=m1 \
 //thickness=0.36 //x=18.095 //y=5.335 //x2=18.21 //y2=5.335
r801 (  11 12 ) resistor r=0.615458 //w=0.131 //l=0.645 //layer=m1 \
 //thickness=0.36 //x=18.095 //y=5.335 //x2=17.45 //y2=5.335
r802 (  10 45 ) resistor r=0.0222262 //w=0.217 //l=0.118 //layer=m1 \
 //thickness=0.36 //x=16.57 //y=5.335 //x2=16.452 //y2=5.335
r803 (  9 48 ) resistor r=0.0262263 //w=0.232 //l=0.12 //layer=m1 \
 //thickness=0.36 //x=17.21 //y=5.335 //x2=17.33 //y2=5.335
r804 (  9 10 ) resistor r=0.610687 //w=0.131 //l=0.64 //layer=m1 \
 //thickness=0.36 //x=17.21 //y=5.335 //x2=16.57 //y2=5.335
r805 (  8 44 ) resistor r=0.0801089 //w=0.224 //l=0.13 //layer=m1 \
 //thickness=0.36 //x=13.44 //y=4.75 //x2=13.44 //y2=4.88
r806 (  7 40 ) resistor r=0.0911593 //w=0.376 //l=0.184608 //layer=m1 \
 //thickness=0.36 //x=13.44 //y=4.055 //x2=13.387 //y2=3.895
r807 (  7 8 ) resistor r=0.663168 //w=0.131 //l=0.695 //layer=m1 \
 //thickness=0.36 //x=13.44 //y=4.055 //x2=13.44 //y2=4.75
r808 (  6 38 ) resistor r=0.0861726 //w=0.376 //l=0.16944 //layer=m1 \
 //thickness=0.36 //x=13.44 //y=3.735 //x2=13.387 //y2=3.88
r809 (  5 42 ) resistor r=0.0719237 //w=0.222 //l=0.115 //layer=m1 \
 //thickness=0.36 //x=13.44 //y=2.375 //x2=13.44 //y2=2.26
r810 (  5 6 ) resistor r=1.29771 //w=0.131 //l=1.36 //layer=m1 \
 //thickness=0.36 //x=13.44 //y=2.375 //x2=13.44 //y2=3.735
r811 (  4 32 ) resistor r=0.0801089 //w=0.224 //l=0.13 //layer=m1 \
 //thickness=0.36 //x=8.63 //y=4.75 //x2=8.63 //y2=4.88
r812 (  3 36 ) resistor r=0.0911593 //w=0.376 //l=0.184174 //layer=m1 \
 //thickness=0.36 //x=8.63 //y=4.055 //x2=8.682 //y2=3.895
r813 (  3 4 ) resistor r=0.663168 //w=0.131 //l=0.695 //layer=m1 \
 //thickness=0.36 //x=8.63 //y=4.055 //x2=8.63 //y2=4.75
r814 (  2 34 ) resistor r=0.0861726 //w=0.376 //l=0.169012 //layer=m1 \
 //thickness=0.36 //x=8.63 //y=3.735 //x2=8.682 //y2=3.88
r815 (  1 30 ) resistor r=0.0719237 //w=0.222 //l=0.115 //layer=m1 \
 //thickness=0.36 //x=8.63 //y=2.375 //x2=8.63 //y2=2.26
r816 (  1 2 ) resistor r=1.29771 //w=0.131 //l=1.36 //layer=m1 \
 //thickness=0.36 //x=8.63 //y=2.375 //x2=8.63 //y2=3.735
ends PM_TMRDFFSNRNQNX1\%noxref_5

subckt PM_TMRDFFSNRNQNX1\%noxref_6 ( 1 2 3 4 5 7 10 11 13 14 15 16 18 19 20 26 \
 28 31 34 40 43 44 45 47 49 57 66 71 79 87 103 104 105 109 110 111 116 118 121 \
 122 124 125 130 133 135 136 137 )
c324 ( 133 0 ) capacitor c=0.00885916f //x=27.935 //y=1.095
c325 ( 130 0 ) capacitor c=0.0693379f //x=23.06 //y=4.88
c326 ( 125 0 ) capacitor c=0.0278202f //x=23.06 //y=2.095
c327 ( 124 0 ) capacitor c=0.0479397f //x=23.06 //y=2.26
c328 ( 122 0 ) capacitor c=0.0443175f //x=23.58 //y=1.44
c329 ( 121 0 ) capacitor c=0.0199703f //x=23.58 //y=1.095
c330 ( 118 0 ) capacitor c=0.0162526f //x=23.425 //y=1.595
c331 ( 116 0 ) capacitor c=0.0157807f //x=23.425 //y=0.94
c332 ( 111 0 ) capacitor c=0.0220935f //x=23.05 //y=1.75
c333 ( 110 0 ) capacitor c=0.0207489f //x=23.05 //y=1.44
c334 ( 109 0 ) capacitor c=0.0194091f //x=23.05 //y=1.095
c335 ( 105 0 ) capacitor c=0.159306f //x=23.24 //y=6.2
c336 ( 104 0 ) capacitor c=0.110208f //x=22.8 //y=6.2
c337 ( 87 0 ) capacitor c=0.0293719f //x=27.83 //y=5.56
c338 ( 79 0 ) capacitor c=0.0292879f //x=26.95 //y=5.56
c339 ( 71 0 ) capacitor c=0.0278099f //x=26.07 //y=5.56
c340 ( 66 0 ) capacitor c=7.7417e-19 //x=23.06 //y=4.88
c341 ( 57 0 ) capacitor c=0.00101179f //x=23.06 //y=2.26
c342 ( 49 0 ) capacitor c=0.00614581f //x=28.09 //y=3.5
c343 ( 47 0 ) capacitor c=0.00512138f //x=27.485 //y=3.51
c344 ( 45 0 ) capacitor c=0.00323896f //x=26.98 //y=3.53
c345 ( 44 0 ) capacitor c=5.50259e-19 //x=23.22 //y=3.51
c346 ( 43 0 ) capacitor c=0.0352681f //x=26.375 //y=3.51
c347 ( 40 0 ) capacitor c=0.0158263f //x=28.61 //y=3.51
c348 ( 34 0 ) capacitor c=8.42472e-19 //x=27.83 //y=5.335
c349 ( 31 0 ) capacitor c=0.00753514f //x=26.95 //y=5.335
c350 ( 28 0 ) capacitor c=0.0109203f //x=26.072 //y=5.335
c351 ( 26 0 ) capacitor c=0.0166445f //x=23.06 //y=3.51
c352 ( 20 0 ) capacitor c=0.0425176f //x=28.61 //y=5.25
c353 ( 19 0 ) capacitor c=0.014234f //x=28.61 //y=3.685
c354 ( 18 0 ) capacitor c=0.0389407f //x=28.61 //y=3.365
c355 ( 16 0 ) capacitor c=0.00493487f //x=28.21 //y=1.845
c356 ( 15 0 ) capacitor c=0.0132922f //x=28.525 //y=1.845
c357 ( 14 0 ) capacitor c=0.0167992f //x=28.125 //y=1.76
c358 ( 13 0 ) capacitor c=0.0112869f //x=28.125 //y=1.305
c359 ( 11 0 ) capacitor c=0.0213481f //x=28.525 //y=5.335
c360 ( 10 0 ) capacitor c=0.00933983f //x=27.83 //y=5.56
c361 ( 7 0 ) capacitor c=0.0177111f //x=27.715 //y=5.335
c362 ( 5 0 ) capacitor c=0.0143796f //x=26.83 //y=5.335
c363 ( 4 0 ) capacitor c=0.0305793f //x=23.06 //y=4.75
c364 ( 3 0 ) capacitor c=0.0121604f //x=23.06 //y=3.655
c365 ( 2 0 ) capacitor c=0.0220277f //x=23.06 //y=3.365
c366 ( 1 0 ) capacitor c=0.00554887f //x=23.06 //y=2.375
r367 (  124 125 ) resistor r=52.7279 //w=0.214 //l=0.165 //layer=ply \
 //thickness=0.18 //x=23.06 //y=2.26 //x2=23.06 //y2=2.095
r368 (  122 132 ) resistor r=45.1352 //w=0.168 //l=0.173853 //layer=ply \
 //thickness=0.18 //x=23.58 //y=1.44 //x2=23.54 //y2=1.595
r369 (  121 131 ) resistor r=45.1352 //w=0.168 //l=0.173853 //layer=ply \
 //thickness=0.18 //x=23.58 //y=1.095 //x2=23.54 //y2=0.94
r370 (  121 122 ) resistor r=176.904 //w=0.094 //l=0.345 //layer=ply \
 //thickness=0.18 //x=23.58 //y=1.095 //x2=23.58 //y2=1.44
r371 (  119 128 ) resistor r=10.701 //w=0.21 //l=0.115 //layer=ply \
 //thickness=0.18 //x=23.205 //y=1.595 //x2=23.09 //y2=1.595
r372 (  118 132 ) resistor r=5.52526 //w=0.168 //l=0.115 //layer=ply \
 //thickness=0.18 //x=23.425 //y=1.595 //x2=23.54 //y2=1.595
r373 (  117 127 ) resistor r=5.52526 //w=0.168 //l=0.115 //layer=ply \
 //thickness=0.18 //x=23.205 //y=0.94 //x2=23.09 //y2=0.94
r374 (  116 131 ) resistor r=5.52526 //w=0.168 //l=0.115 //layer=ply \
 //thickness=0.18 //x=23.425 //y=0.94 //x2=23.54 //y2=0.94
r375 (  116 117 ) resistor r=112.809 //w=0.094 //l=0.22 //layer=ply \
 //thickness=0.18 //x=23.425 //y=0.94 //x2=23.205 //y2=0.94
r376 (  113 130 ) resistor r=37.236 //w=0.233 //l=0.249199 //layer=ply \
 //thickness=0.18 //x=23.24 //y=5.045 //x2=23.06 //y2=4.88
r377 (  111 128 ) resistor r=39.5823 //w=0.21 //l=0.173853 //layer=ply \
 //thickness=0.18 //x=23.05 //y=1.75 //x2=23.09 //y2=1.595
r378 (  111 125 ) resistor r=176.904 //w=0.094 //l=0.345 //layer=ply \
 //thickness=0.18 //x=23.05 //y=1.75 //x2=23.05 //y2=2.095
r379 (  110 128 ) resistor r=39.5823 //w=0.21 //l=0.173853 //layer=ply \
 //thickness=0.18 //x=23.05 //y=1.44 //x2=23.09 //y2=1.595
r380 (  109 127 ) resistor r=45.1352 //w=0.168 //l=0.173853 //layer=ply \
 //thickness=0.18 //x=23.05 //y=1.095 //x2=23.09 //y2=0.94
r381 (  109 110 ) resistor r=176.904 //w=0.094 //l=0.345 //layer=ply \
 //thickness=0.18 //x=23.05 //y=1.095 //x2=23.05 //y2=1.44
r382 (  106 130 ) resistor r=53.7854 //w=0.233 //l=0.332415 //layer=ply \
 //thickness=0.18 //x=22.8 //y=5.045 //x2=23.06 //y2=4.88
r383 (  105 113 ) resistor r=592.245 //w=0.094 //l=1.155 //layer=ply \
 //thickness=0.18 //x=23.24 //y=6.2 //x2=23.24 //y2=5.045
r384 (  104 106 ) resistor r=592.245 //w=0.094 //l=1.155 //layer=ply \
 //thickness=0.18 //x=22.8 //y=6.2 //x2=22.8 //y2=5.045
r385 (  103 118 ) resistor r=56.4043 //w=0.094 //l=0.11 //layer=ply \
 //thickness=0.18 //x=23.315 //y=1.595 //x2=23.425 //y2=1.595
r386 (  103 119 ) resistor r=56.4043 //w=0.094 //l=0.11 //layer=ply \
 //thickness=0.18 //x=23.315 //y=1.595 //x2=23.205 //y2=1.595
r387 (  87 137 ) resistor r=23.615 //w=0.187 //l=0.345 //layer=li \
 //thickness=0.1 //x=27.83 //y=5.56 //x2=27.83 //y2=5.905
r388 (  79 136 ) resistor r=23.615 //w=0.187 //l=0.345 //layer=li \
 //thickness=0.1 //x=26.95 //y=5.56 //x2=26.95 //y2=5.905
r389 (  71 135 ) resistor r=23.615 //w=0.187 //l=0.345 //layer=li \
 //thickness=0.1 //x=26.07 //y=5.56 //x2=26.07 //y2=5.905
r390 (  66 130 ) resistor r=152 //w=0.17 //l=0.17 //layer=licon //count=1 \
 //x=23.06 //y=4.88 //x2=23.06 //y2=4.88
r391 (  57 124 ) resistor r=152 //w=0.17 //l=0.17 //layer=licon //count=1 \
 //x=23.06 //y=2.26 //x2=23.06 //y2=2.26
r392 (  49 55 ) resistor r=0.293022 //w=0.239 //l=0.552359 //layer=m2 \
 //thickness=0.36 //x=28.09 //y=3.5 //x2=28.63 //y2=3.525
r393 (  49 50 ) resistor r=0.415076 //w=0.131 //l=0.435 //layer=m2 \
 //thickness=0.36 //x=28.09 //y=3.5 //x2=27.655 //y2=3.5
r394 (  47 50 ) resistor r=0.125 //w=0.17 //l=0.174929 //layer=m2 \
 //thickness=0.36 //x=27.485 //y=3.51 //x2=27.655 //y2=3.5
r395 (  47 48 ) resistor r=0.319656 //w=0.131 //l=0.335 //layer=m2 \
 //thickness=0.36 //x=27.485 //y=3.51 //x2=27.15 //y2=3.51
r396 (  45 48 ) resistor r=0.125 //w=0.17 //l=0.179722 //layer=m2 \
 //thickness=0.36 //x=26.98 //y=3.53 //x2=27.15 //y2=3.51
r397 (  45 46 ) resistor r=0.333969 //w=0.131 //l=0.35 //layer=m2 \
 //thickness=0.36 //x=26.98 //y=3.53 //x2=26.63 //y2=3.53
r398 (  44 52 ) resistor r=0.108362 //w=0.251 //l=0.16 //layer=m2 \
 //thickness=0.36 //x=23.22 //y=3.51 //x2=23.06 //y2=3.51
r399 (  43 46 ) resistor r=0.1875 //w=0.17 //l=0.264811 //layer=m2 \
 //thickness=0.36 //x=26.375 //y=3.51 //x2=26.63 //y2=3.53
r400 (  43 44 ) resistor r=3.0105 //w=0.131 //l=3.155 //layer=m2 \
 //thickness=0.36 //x=26.375 //y=3.51 //x2=23.22 //y2=3.51
r401 (  42 55 ) resistor r=4.5 //w=0.15 //l=0.15 //layer=via1 //count=1 \
 //x=28.63 //y=3.525 //x2=28.63 //y2=3.525
r402 (  40 42 ) resistor r=0.00484496 //w=0.387 //l=0.015 //layer=m1 \
 //thickness=0.36 //x=28.567 //y=3.51 //x2=28.567 //y2=3.525
r403 (  38 133 ) resistor r=9.3 //w=0.17 //l=0.17 //layer=mcon //count=1 \
 //x=28.125 //y=1.19 //x2=28.125 //y2=1.19
r404 (  36 87 ) resistor r=9.3 //w=0.17 //l=0.17 //layer=mcon //count=1 \
 //x=27.83 //y=5.56 //x2=27.83 //y2=5.56
r405 (  33 79 ) resistor r=9.3 //w=0.17 //l=0.17 //layer=mcon //count=1 \
 //x=26.95 //y=5.56 //x2=26.95 //y2=5.56
r406 (  31 33 ) resistor r=0.121228 //w=0.232 //l=0.225 //layer=m1 \
 //thickness=0.36 //x=26.95 //y=5.335 //x2=26.95 //y2=5.56
r407 (  30 71 ) resistor r=9.3 //w=0.17 //l=0.17 //layer=mcon //count=1 \
 //x=26.07 //y=5.56 //x2=26.07 //y2=5.56
r408 (  28 30 ) resistor r=0.129608 //w=0.217 //l=0.225 //layer=m1 \
 //thickness=0.36 //x=26.072 //y=5.335 //x2=26.072 //y2=5.56
r409 (  26 52 ) resistor r=4.5 //w=0.15 //l=0.15 //layer=via1 //count=1 \
 //x=23.06 //y=3.51 //x2=23.06 //y2=3.51
r410 (  24 66 ) resistor r=9.3 //w=0.17 //l=0.17 //layer=mcon //count=1 \
 //x=23.06 //y=4.88 //x2=23.06 //y2=4.88
r411 (  22 57 ) resistor r=9.3 //w=0.17 //l=0.17 //layer=mcon //count=1 \
 //x=23.06 //y=2.26 //x2=23.06 //y2=2.26
r412 (  19 42 ) resistor r=0.091625 //w=0.387 //l=0.180222 //layer=m1 \
 //thickness=0.36 //x=28.61 //y=3.685 //x2=28.567 //y2=3.525
r413 (  19 20 ) resistor r=1.49332 //w=0.131 //l=1.565 //layer=m1 \
 //thickness=0.36 //x=28.61 //y=3.685 //x2=28.61 //y2=5.25
r414 (  18 40 ) resistor r=0.08678 //w=0.387 //l=0.165106 //layer=m1 \
 //thickness=0.36 //x=28.61 //y=3.365 //x2=28.567 //y2=3.51
r415 (  17 18 ) resistor r=1.36927 //w=0.131 //l=1.435 //layer=m1 \
 //thickness=0.36 //x=28.61 //y=1.93 //x2=28.61 //y2=3.365
r416 (  15 17 ) resistor r=0.0698411 //w=0.17 //l=0.120208 //layer=m1 \
 //thickness=0.36 //x=28.525 //y=1.845 //x2=28.61 //y2=1.93
r417 (  15 16 ) resistor r=0.300573 //w=0.131 //l=0.315 //layer=m1 \
 //thickness=0.36 //x=28.525 //y=1.845 //x2=28.21 //y2=1.845
r418 (  14 16 ) resistor r=0.0698411 //w=0.17 //l=0.120208 //layer=m1 \
 //thickness=0.36 //x=28.125 //y=1.76 //x2=28.21 //y2=1.845
r419 (  13 38 ) resistor r=0.0717383 //w=0.224 //l=0.115 //layer=m1 \
 //thickness=0.36 //x=28.125 //y=1.305 //x2=28.125 //y2=1.19
r420 (  13 14 ) resistor r=0.43416 //w=0.131 //l=0.455 //layer=m1 \
 //thickness=0.36 //x=28.125 //y=1.305 //x2=28.125 //y2=1.76
r421 (  12 34 ) resistor r=0.0675342 //w=0.23 //l=0.115 //layer=m1 \
 //thickness=0.36 //x=27.945 //y=5.335 //x2=27.83 //y2=5.335
r422 (  11 20 ) resistor r=0.0698411 //w=0.17 //l=0.120208 //layer=m1 \
 //thickness=0.36 //x=28.525 //y=5.335 //x2=28.61 //y2=5.25
r423 (  11 12 ) resistor r=0.553435 //w=0.131 //l=0.58 //layer=m1 \
 //thickness=0.36 //x=28.525 //y=5.335 //x2=27.945 //y2=5.335
r424 (  10 36 ) resistor r=0.00118313 //w=0.23 //layer=m1 //thickness=0.36 \
 //x=27.83 //y=5.56 //x2=27.83 //y2=5.56
r425 (  9 34 ) resistor r=0.002872 //w=0.34 //l=0.085 //layer=m1 \
 //thickness=0.36 //x=27.83 //y=5.42 //x2=27.83 //y2=5.335
r426 (  9 10 ) resistor r=0.091623 //w=0.191 //l=0.14 //layer=m1 \
 //thickness=0.36 //x=27.83 //y=5.42 //x2=27.83 //y2=5.56
r427 (  8 31 ) resistor r=0.0262263 //w=0.232 //l=0.12 //layer=m1 \
 //thickness=0.36 //x=27.07 //y=5.335 //x2=26.95 //y2=5.335
r428 (  7 34 ) resistor r=0.0675342 //w=0.23 //l=0.115 //layer=m1 \
 //thickness=0.36 //x=27.715 //y=5.335 //x2=27.83 //y2=5.335
r429 (  7 8 ) resistor r=0.615458 //w=0.131 //l=0.645 //layer=m1 \
 //thickness=0.36 //x=27.715 //y=5.335 //x2=27.07 //y2=5.335
r430 (  6 28 ) resistor r=0.0222262 //w=0.217 //l=0.118 //layer=m1 \
 //thickness=0.36 //x=26.19 //y=5.335 //x2=26.072 //y2=5.335
r431 (  5 31 ) resistor r=0.0262263 //w=0.232 //l=0.12 //layer=m1 \
 //thickness=0.36 //x=26.83 //y=5.335 //x2=26.95 //y2=5.335
r432 (  5 6 ) resistor r=0.610687 //w=0.131 //l=0.64 //layer=m1 \
 //thickness=0.36 //x=26.83 //y=5.335 //x2=26.19 //y2=5.335
r433 (  4 24 ) resistor r=0.0801089 //w=0.224 //l=0.13 //layer=m1 \
 //thickness=0.36 //x=23.06 //y=4.75 //x2=23.06 //y2=4.88
r434 (  3 26 ) resistor r=0.0864989 //w=0.382 //l=0.169012 //layer=m1 \
 //thickness=0.36 //x=23.06 //y=3.655 //x2=23.112 //y2=3.51
r435 (  3 4 ) resistor r=1.04485 //w=0.131 //l=1.095 //layer=m1 \
 //thickness=0.36 //x=23.06 //y=3.655 //x2=23.06 //y2=4.75
r436 (  2 26 ) resistor r=0.0864989 //w=0.382 //l=0.169012 //layer=m1 \
 //thickness=0.36 //x=23.06 //y=3.365 //x2=23.112 //y2=3.51
r437 (  1 22 ) resistor r=0.0719237 //w=0.222 //l=0.115 //layer=m1 \
 //thickness=0.36 //x=23.06 //y=2.375 //x2=23.06 //y2=2.26
r438 (  1 2 ) resistor r=0.944656 //w=0.131 //l=0.99 //layer=m1 \
 //thickness=0.36 //x=23.06 //y=2.375 //x2=23.06 //y2=3.365
ends PM_TMRDFFSNRNQNX1\%noxref_6

subckt PM_TMRDFFSNRNQNX1\%noxref_7 ( 1 3 6 7 9 10 11 12 14 15 16 17 18 19 20 \
 21 22 23 24 25 28 31 37 45 49 63 66 67 69 70 73 81 89 106 115 120 129 133 134 \
 135 136 137 138 139 140 141 142 143 145 151 152 153 154 158 159 160 161 162 \
 164 170 171 172 173 193 195 196 197 )
c442 ( 193 0 ) capacitor c=0.00885916f //x=32.745 //y=1.095
c443 ( 173 0 ) capacitor c=0.0612936f //x=40.355 //y=4.97
c444 ( 172 0 ) capacitor c=0.0376642f //x=40.645 //y=4.97
c445 ( 171 0 ) capacitor c=0.0346489f //x=40.31 //y=1.4
c446 ( 170 0 ) capacitor c=0.018692f //x=40.31 //y=1.055
c447 ( 164 0 ) capacitor c=0.0137077f //x=40.155 //y=1.555
c448 ( 162 0 ) capacitor c=0.0158585f //x=40.155 //y=0.9
c449 ( 161 0 ) capacitor c=0.0979536f //x=39.78 //y=2.095
c450 ( 160 0 ) capacitor c=0.0229444f //x=39.78 //y=1.71
c451 ( 159 0 ) capacitor c=0.0234359f //x=39.78 //y=1.4
c452 ( 158 0 ) capacitor c=0.019815f //x=39.78 //y=1.055
c453 ( 154 0 ) capacitor c=0.0614625f //x=35.545 //y=4.97
c454 ( 153 0 ) capacitor c=0.0376642f //x=35.835 //y=4.97
c455 ( 152 0 ) capacitor c=0.0346489f //x=35.5 //y=1.4
c456 ( 151 0 ) capacitor c=0.018692f //x=35.5 //y=1.055
c457 ( 145 0 ) capacitor c=0.0137077f //x=35.345 //y=1.555
c458 ( 143 0 ) capacitor c=0.0158585f //x=35.345 //y=0.9
c459 ( 142 0 ) capacitor c=0.0996161f //x=34.97 //y=2.095
c460 ( 141 0 ) capacitor c=0.0229444f //x=34.97 //y=1.71
c461 ( 140 0 ) capacitor c=0.0234359f //x=34.97 //y=1.4
c462 ( 139 0 ) capacitor c=0.019815f //x=34.97 //y=1.055
c463 ( 138 0 ) capacitor c=0.110208f //x=40.72 //y=6.2
c464 ( 137 0 ) capacitor c=0.158957f //x=40.28 //y=6.2
c465 ( 136 0 ) capacitor c=0.110285f //x=35.91 //y=6.2
c466 ( 135 0 ) capacitor c=0.158957f //x=35.47 //y=6.2
c467 ( 129 0 ) capacitor c=0.00159026f //x=40.08 //y=4.88
c468 ( 120 0 ) capacitor c=9.93222e-19 //x=40.08 //y=2.26
c469 ( 115 0 ) capacitor c=0.00157967f //x=35.27 //y=4.88
c470 ( 106 0 ) capacitor c=9.93222e-19 //x=35.27 //y=2.26
c471 ( 89 0 ) capacitor c=0.0293562f //x=32.64 //y=5.56
c472 ( 81 0 ) capacitor c=0.029137f //x=31.76 //y=5.56
c473 ( 73 0 ) capacitor c=0.0278099f //x=30.88 //y=5.56
c474 ( 70 0 ) capacitor c=0.0392891f //x=39.92 //y=2.785
c475 ( 69 0 ) capacitor c=5.7546e-19 //x=40.08 //y=2.785
c476 ( 67 0 ) capacitor c=5.7546e-19 //x=35.435 //y=2.785
c477 ( 66 0 ) capacitor c=0.0167579f //x=35.115 //y=2.785
c478 ( 63 0 ) capacitor c=9.56892e-19 //x=33.585 //y=2.785
c479 ( 49 0 ) capacitor c=0.0154699f //x=40.08 //y=2.77
c480 ( 45 0 ) capacitor c=0.0148628f //x=35.27 //y=2.77
c481 ( 37 0 ) capacitor c=0.0144706f //x=33.42 //y=2.77
c482 ( 31 0 ) capacitor c=9.37498e-19 //x=32.64 //y=5.335
c483 ( 28 0 ) capacitor c=0.0076134f //x=31.76 //y=5.335
c484 ( 25 0 ) capacitor c=0.0109203f //x=30.882 //y=5.335
c485 ( 24 0 ) capacitor c=0.0552258f //x=40.08 //y=4.755
c486 ( 23 0 ) capacitor c=0.0130763f //x=40.08 //y=2.945
c487 ( 22 0 ) capacitor c=0.00473602f //x=40.08 //y=2.625
c488 ( 21 0 ) capacitor c=0.00495287f //x=40.08 //y=2.375
c489 ( 20 0 ) capacitor c=0.060164f //x=35.27 //y=4.755
c490 ( 19 0 ) capacitor c=0.0129478f //x=35.27 //y=2.945
c491 ( 18 0 ) capacitor c=0.00482124f //x=35.27 //y=2.625
c492 ( 17 0 ) capacitor c=0.00495287f //x=35.27 //y=2.375
c493 ( 16 0 ) capacitor c=0.0657499f //x=33.42 //y=5.25
c494 ( 15 0 ) capacitor c=0.0123004f //x=33.42 //y=2.945
c495 ( 14 0 ) capacitor c=0.0179579f //x=33.42 //y=2.625
c496 ( 12 0 ) capacitor c=0.0047266f //x=33.02 //y=1.845
c497 ( 11 0 ) capacitor c=0.0129788f //x=33.335 //y=1.845
c498 ( 10 0 ) capacitor c=0.0167992f //x=32.935 //y=1.76
c499 ( 9 0 ) capacitor c=0.0110957f //x=32.935 //y=1.305
c500 ( 7 0 ) capacitor c=0.0202877f //x=33.335 //y=5.335
c501 ( 6 0 ) capacitor c=0.00933983f //x=32.64 //y=5.56
c502 ( 3 0 ) capacitor c=0.0192055f //x=32.525 //y=5.335
c503 ( 1 0 ) capacitor c=0.0149267f //x=31.64 //y=5.335
r504 (  172 174 ) resistor r=26.9307 //w=0.15 //l=0.106066 //layer=ply \
 //thickness=0.18 //x=40.645 //y=4.97 //x2=40.72 //y2=5.045
r505 (  172 173 ) resistor r=148.702 //w=0.094 //l=0.29 //layer=ply \
 //thickness=0.18 //x=40.645 //y=4.97 //x2=40.355 //y2=4.97
r506 (  171 192 ) resistor r=45.1352 //w=0.168 //l=0.173853 //layer=ply \
 //thickness=0.18 //x=40.31 //y=1.4 //x2=40.27 //y2=1.555
r507 (  170 191 ) resistor r=45.1352 //w=0.168 //l=0.173853 //layer=ply \
 //thickness=0.18 //x=40.31 //y=1.055 //x2=40.27 //y2=0.9
r508 (  170 171 ) resistor r=176.904 //w=0.094 //l=0.345 //layer=ply \
 //thickness=0.18 //x=40.31 //y=1.055 //x2=40.31 //y2=1.4
r509 (  167 173 ) resistor r=22.7971 //w=0.269 //l=0.106066 //layer=ply \
 //thickness=0.18 //x=40.28 //y=5.045 //x2=40.355 //y2=4.97
r510 (  167 190 ) resistor r=35.8364 //w=0.269 //l=0.270185 //layer=ply \
 //thickness=0.18 //x=40.28 //y=5.045 //x2=40.08 //y2=4.88
r511 (  165 186 ) resistor r=10.701 //w=0.21 //l=0.115 //layer=ply \
 //thickness=0.18 //x=39.935 //y=1.555 //x2=39.82 //y2=1.555
r512 (  164 192 ) resistor r=5.52526 //w=0.168 //l=0.115 //layer=ply \
 //thickness=0.18 //x=40.155 //y=1.555 //x2=40.27 //y2=1.555
r513 (  163 185 ) resistor r=5.52526 //w=0.168 //l=0.115 //layer=ply \
 //thickness=0.18 //x=39.935 //y=0.9 //x2=39.82 //y2=0.9
r514 (  162 191 ) resistor r=5.52526 //w=0.168 //l=0.115 //layer=ply \
 //thickness=0.18 //x=40.155 //y=0.9 //x2=40.27 //y2=0.9
r515 (  162 163 ) resistor r=112.809 //w=0.094 //l=0.22 //layer=ply \
 //thickness=0.18 //x=40.155 //y=0.9 //x2=39.935 //y2=0.9
r516 (  161 188 ) resistor r=58.7805 //w=0.246 //l=0.373497 //layer=ply \
 //thickness=0.18 //x=39.78 //y=2.095 //x2=40.08 //y2=2.26
r517 (  160 186 ) resistor r=39.5823 //w=0.21 //l=0.173853 //layer=ply \
 //thickness=0.18 //x=39.78 //y=1.71 //x2=39.82 //y2=1.555
r518 (  160 161 ) resistor r=197.415 //w=0.094 //l=0.385 //layer=ply \
 //thickness=0.18 //x=39.78 //y=1.71 //x2=39.78 //y2=2.095
r519 (  159 186 ) resistor r=39.5823 //w=0.21 //l=0.173853 //layer=ply \
 //thickness=0.18 //x=39.78 //y=1.4 //x2=39.82 //y2=1.555
r520 (  158 185 ) resistor r=45.1352 //w=0.168 //l=0.173853 //layer=ply \
 //thickness=0.18 //x=39.78 //y=1.055 //x2=39.82 //y2=0.9
r521 (  158 159 ) resistor r=176.904 //w=0.094 //l=0.345 //layer=ply \
 //thickness=0.18 //x=39.78 //y=1.055 //x2=39.78 //y2=1.4
r522 (  153 155 ) resistor r=26.9307 //w=0.15 //l=0.106066 //layer=ply \
 //thickness=0.18 //x=35.835 //y=4.97 //x2=35.91 //y2=5.045
r523 (  153 154 ) resistor r=148.702 //w=0.094 //l=0.29 //layer=ply \
 //thickness=0.18 //x=35.835 //y=4.97 //x2=35.545 //y2=4.97
r524 (  152 184 ) resistor r=45.1352 //w=0.168 //l=0.173853 //layer=ply \
 //thickness=0.18 //x=35.5 //y=1.4 //x2=35.46 //y2=1.555
r525 (  151 183 ) resistor r=45.1352 //w=0.168 //l=0.173853 //layer=ply \
 //thickness=0.18 //x=35.5 //y=1.055 //x2=35.46 //y2=0.9
r526 (  151 152 ) resistor r=176.904 //w=0.094 //l=0.345 //layer=ply \
 //thickness=0.18 //x=35.5 //y=1.055 //x2=35.5 //y2=1.4
r527 (  148 154 ) resistor r=22.7971 //w=0.269 //l=0.106066 //layer=ply \
 //thickness=0.18 //x=35.47 //y=5.045 //x2=35.545 //y2=4.97
r528 (  148 182 ) resistor r=35.8364 //w=0.269 //l=0.270185 //layer=ply \
 //thickness=0.18 //x=35.47 //y=5.045 //x2=35.27 //y2=4.88
r529 (  146 178 ) resistor r=10.701 //w=0.21 //l=0.115 //layer=ply \
 //thickness=0.18 //x=35.125 //y=1.555 //x2=35.01 //y2=1.555
r530 (  145 184 ) resistor r=5.52526 //w=0.168 //l=0.115 //layer=ply \
 //thickness=0.18 //x=35.345 //y=1.555 //x2=35.46 //y2=1.555
r531 (  144 177 ) resistor r=5.52526 //w=0.168 //l=0.115 //layer=ply \
 //thickness=0.18 //x=35.125 //y=0.9 //x2=35.01 //y2=0.9
r532 (  143 183 ) resistor r=5.52526 //w=0.168 //l=0.115 //layer=ply \
 //thickness=0.18 //x=35.345 //y=0.9 //x2=35.46 //y2=0.9
r533 (  143 144 ) resistor r=112.809 //w=0.094 //l=0.22 //layer=ply \
 //thickness=0.18 //x=35.345 //y=0.9 //x2=35.125 //y2=0.9
r534 (  142 180 ) resistor r=58.7805 //w=0.246 //l=0.373497 //layer=ply \
 //thickness=0.18 //x=34.97 //y=2.095 //x2=35.27 //y2=2.26
r535 (  141 178 ) resistor r=39.5823 //w=0.21 //l=0.173853 //layer=ply \
 //thickness=0.18 //x=34.97 //y=1.71 //x2=35.01 //y2=1.555
r536 (  141 142 ) resistor r=197.415 //w=0.094 //l=0.385 //layer=ply \
 //thickness=0.18 //x=34.97 //y=1.71 //x2=34.97 //y2=2.095
r537 (  140 178 ) resistor r=39.5823 //w=0.21 //l=0.173853 //layer=ply \
 //thickness=0.18 //x=34.97 //y=1.4 //x2=35.01 //y2=1.555
r538 (  139 177 ) resistor r=45.1352 //w=0.168 //l=0.173853 //layer=ply \
 //thickness=0.18 //x=34.97 //y=1.055 //x2=35.01 //y2=0.9
r539 (  139 140 ) resistor r=176.904 //w=0.094 //l=0.345 //layer=ply \
 //thickness=0.18 //x=34.97 //y=1.055 //x2=34.97 //y2=1.4
r540 (  138 174 ) resistor r=592.245 //w=0.094 //l=1.155 //layer=ply \
 //thickness=0.18 //x=40.72 //y=6.2 //x2=40.72 //y2=5.045
r541 (  137 167 ) resistor r=592.245 //w=0.094 //l=1.155 //layer=ply \
 //thickness=0.18 //x=40.28 //y=6.2 //x2=40.28 //y2=5.045
r542 (  136 155 ) resistor r=592.245 //w=0.094 //l=1.155 //layer=ply \
 //thickness=0.18 //x=35.91 //y=6.2 //x2=35.91 //y2=5.045
r543 (  135 148 ) resistor r=592.245 //w=0.094 //l=1.155 //layer=ply \
 //thickness=0.18 //x=35.47 //y=6.2 //x2=35.47 //y2=5.045
r544 (  134 164 ) resistor r=56.4043 //w=0.094 //l=0.11 //layer=ply \
 //thickness=0.18 //x=40.045 //y=1.555 //x2=40.155 //y2=1.555
r545 (  134 165 ) resistor r=56.4043 //w=0.094 //l=0.11 //layer=ply \
 //thickness=0.18 //x=40.045 //y=1.555 //x2=39.935 //y2=1.555
r546 (  133 145 ) resistor r=56.4043 //w=0.094 //l=0.11 //layer=ply \
 //thickness=0.18 //x=35.235 //y=1.555 //x2=35.345 //y2=1.555
r547 (  133 146 ) resistor r=56.4043 //w=0.094 //l=0.11 //layer=ply \
 //thickness=0.18 //x=35.235 //y=1.555 //x2=35.125 //y2=1.555
r548 (  129 190 ) resistor r=152 //w=0.17 //l=0.17 //layer=licon //count=1 \
 //x=40.08 //y=4.88 //x2=40.08 //y2=4.88
r549 (  120 188 ) resistor r=152 //w=0.17 //l=0.17 //layer=licon //count=1 \
 //x=40.08 //y=2.26 //x2=40.08 //y2=2.26
r550 (  115 182 ) resistor r=152 //w=0.17 //l=0.17 //layer=licon //count=1 \
 //x=35.27 //y=4.88 //x2=35.27 //y2=4.88
r551 (  106 180 ) resistor r=152 //w=0.17 //l=0.17 //layer=licon //count=1 \
 //x=35.27 //y=2.26 //x2=35.27 //y2=2.26
r552 (  89 197 ) resistor r=23.615 //w=0.187 //l=0.345 //layer=li \
 //thickness=0.1 //x=32.64 //y=5.56 //x2=32.64 //y2=5.905
r553 (  81 196 ) resistor r=23.615 //w=0.187 //l=0.345 //layer=li \
 //thickness=0.1 //x=31.76 //y=5.56 //x2=31.76 //y2=5.905
r554 (  73 195 ) resistor r=23.615 //w=0.187 //l=0.345 //layer=li \
 //thickness=0.1 //x=30.88 //y=5.56 //x2=30.88 //y2=5.905
r555 (  69 70 ) resistor r=0.10734 //w=0.281 //l=0.16 //layer=m2 \
 //thickness=0.36 //x=40.08 //y=2.785 //x2=39.92 //y2=2.785
r556 (  67 70 ) resistor r=4.27958 //w=0.131 //l=4.485 //layer=m2 \
 //thickness=0.36 //x=35.435 //y=2.77 //x2=39.92 //y2=2.77
r557 (  65 67 ) resistor r=0.10734 //w=0.281 //l=0.16 //layer=m2 \
 //thickness=0.36 //x=35.275 //y=2.785 //x2=35.435 //y2=2.785
r558 (  65 66 ) resistor r=0.10734 //w=0.281 //l=0.16 //layer=m2 \
 //thickness=0.36 //x=35.275 //y=2.785 //x2=35.115 //y2=2.785
r559 (  63 66 ) resistor r=1.45992 //w=0.131 //l=1.53 //layer=m2 \
 //thickness=0.36 //x=33.585 //y=2.77 //x2=35.115 //y2=2.77
r560 (  61 63 ) resistor r=0.10734 //w=0.281 //l=0.16 //layer=m2 \
 //thickness=0.36 //x=33.425 //y=2.785 //x2=33.585 //y2=2.785
r561 (  55 129 ) resistor r=9.3 //w=0.17 //l=0.17 //layer=mcon //count=1 \
 //x=40.08 //y=4.88 //x2=40.08 //y2=4.88
r562 (  53 120 ) resistor r=9.3 //w=0.17 //l=0.17 //layer=mcon //count=1 \
 //x=40.08 //y=2.26 //x2=40.08 //y2=2.26
r563 (  51 69 ) resistor r=4.5 //w=0.15 //l=0.15 //layer=via1 //count=1 \
 //x=40.08 //y=2.785 //x2=40.08 //y2=2.785
r564 (  49 51 ) resistor r=0.0049867 //w=0.376 //l=0.015 //layer=m1 \
 //thickness=0.36 //x=40.027 //y=2.77 //x2=40.027 //y2=2.785
r565 (  47 65 ) resistor r=4.5 //w=0.15 //l=0.15 //layer=via1 //count=1 \
 //x=35.275 //y=2.785 //x2=35.275 //y2=2.785
r566 (  45 47 ) resistor r=0.00501337 //w=0.374 //l=0.015 //layer=m1 \
 //thickness=0.36 //x=35.325 //y=2.77 //x2=35.325 //y2=2.785
r567 (  43 115 ) resistor r=9.3 //w=0.17 //l=0.17 //layer=mcon //count=1 \
 //x=35.27 //y=4.88 //x2=35.27 //y2=4.88
r568 (  41 106 ) resistor r=9.3 //w=0.17 //l=0.17 //layer=mcon //count=1 \
 //x=35.27 //y=2.26 //x2=35.27 //y2=2.26
r569 (  39 61 ) resistor r=4.5 //w=0.15 //l=0.15 //layer=via1 //count=1 \
 //x=33.425 //y=2.785 //x2=33.425 //y2=2.785
r570 (  37 39 ) resistor r=0.00501337 //w=0.374 //l=0.015 //layer=m1 \
 //thickness=0.36 //x=33.475 //y=2.77 //x2=33.475 //y2=2.785
r571 (  35 193 ) resistor r=9.3 //w=0.17 //l=0.17 //layer=mcon //count=1 \
 //x=32.935 //y=1.19 //x2=32.935 //y2=1.19
r572 (  33 89 ) resistor r=9.3 //w=0.17 //l=0.17 //layer=mcon //count=1 \
 //x=32.64 //y=5.56 //x2=32.64 //y2=5.56
r573 (  30 81 ) resistor r=9.3 //w=0.17 //l=0.17 //layer=mcon //count=1 \
 //x=31.76 //y=5.56 //x2=31.76 //y2=5.56
r574 (  28 30 ) resistor r=0.121228 //w=0.232 //l=0.225 //layer=m1 \
 //thickness=0.36 //x=31.76 //y=5.335 //x2=31.76 //y2=5.56
r575 (  27 73 ) resistor r=9.3 //w=0.17 //l=0.17 //layer=mcon //count=1 \
 //x=30.88 //y=5.56 //x2=30.88 //y2=5.56
r576 (  25 27 ) resistor r=0.129608 //w=0.217 //l=0.225 //layer=m1 \
 //thickness=0.36 //x=30.882 //y=5.335 //x2=30.882 //y2=5.56
r577 (  24 55 ) resistor r=0.0760407 //w=0.238 //l=0.125 //layer=m1 \
 //thickness=0.36 //x=40.08 //y=4.755 //x2=40.08 //y2=4.88
r578 (  23 51 ) resistor r=0.0911593 //w=0.376 //l=0.184608 //layer=m1 \
 //thickness=0.36 //x=40.08 //y=2.945 //x2=40.027 //y2=2.785
r579 (  23 24 ) resistor r=1.7271 //w=0.131 //l=1.81 //layer=m1 \
 //thickness=0.36 //x=40.08 //y=2.945 //x2=40.08 //y2=4.755
r580 (  22 49 ) resistor r=0.0861726 //w=0.376 //l=0.16944 //layer=m1 \
 //thickness=0.36 //x=40.08 //y=2.625 //x2=40.027 //y2=2.77
r581 (  21 53 ) resistor r=0.0719237 //w=0.222 //l=0.115 //layer=m1 \
 //thickness=0.36 //x=40.08 //y=2.375 //x2=40.08 //y2=2.26
r582 (  21 22 ) resistor r=0.23855 //w=0.131 //l=0.25 //layer=m1 \
 //thickness=0.36 //x=40.08 //y=2.375 //x2=40.08 //y2=2.625
r583 (  20 43 ) resistor r=0.0760407 //w=0.238 //l=0.125 //layer=m1 \
 //thickness=0.36 //x=35.27 //y=4.755 //x2=35.27 //y2=4.88
r584 (  19 47 ) resistor r=0.0910802 //w=0.374 //l=0.185472 //layer=m1 \
 //thickness=0.36 //x=35.27 //y=2.945 //x2=35.325 //y2=2.785
r585 (  19 20 ) resistor r=1.7271 //w=0.131 //l=1.81 //layer=m1 \
 //thickness=0.36 //x=35.27 //y=2.945 //x2=35.27 //y2=4.755
r586 (  18 45 ) resistor r=0.0860668 //w=0.374 //l=0.170294 //layer=m1 \
 //thickness=0.36 //x=35.27 //y=2.625 //x2=35.325 //y2=2.77
r587 (  17 41 ) resistor r=0.0719237 //w=0.222 //l=0.115 //layer=m1 \
 //thickness=0.36 //x=35.27 //y=2.375 //x2=35.27 //y2=2.26
r588 (  17 18 ) resistor r=0.23855 //w=0.131 //l=0.25 //layer=m1 \
 //thickness=0.36 //x=35.27 //y=2.375 //x2=35.27 //y2=2.625
r589 (  15 39 ) resistor r=0.0910802 //w=0.374 //l=0.185472 //layer=m1 \
 //thickness=0.36 //x=33.42 //y=2.945 //x2=33.475 //y2=2.785
r590 (  15 16 ) resistor r=2.19943 //w=0.131 //l=2.305 //layer=m1 \
 //thickness=0.36 //x=33.42 //y=2.945 //x2=33.42 //y2=5.25
r591 (  14 37 ) resistor r=0.0860668 //w=0.374 //l=0.170294 //layer=m1 \
 //thickness=0.36 //x=33.42 //y=2.625 //x2=33.475 //y2=2.77
r592 (  13 14 ) resistor r=0.663168 //w=0.131 //l=0.695 //layer=m1 \
 //thickness=0.36 //x=33.42 //y=1.93 //x2=33.42 //y2=2.625
r593 (  11 13 ) resistor r=0.0698411 //w=0.17 //l=0.120208 //layer=m1 \
 //thickness=0.36 //x=33.335 //y=1.845 //x2=33.42 //y2=1.93
r594 (  11 12 ) resistor r=0.300573 //w=0.131 //l=0.315 //layer=m1 \
 //thickness=0.36 //x=33.335 //y=1.845 //x2=33.02 //y2=1.845
r595 (  10 12 ) resistor r=0.0698411 //w=0.17 //l=0.120208 //layer=m1 \
 //thickness=0.36 //x=32.935 //y=1.76 //x2=33.02 //y2=1.845
r596 (  9 35 ) resistor r=0.0717383 //w=0.224 //l=0.115 //layer=m1 \
 //thickness=0.36 //x=32.935 //y=1.305 //x2=32.935 //y2=1.19
r597 (  9 10 ) resistor r=0.43416 //w=0.131 //l=0.455 //layer=m1 \
 //thickness=0.36 //x=32.935 //y=1.305 //x2=32.935 //y2=1.76
r598 (  8 31 ) resistor r=0.0675342 //w=0.23 //l=0.115 //layer=m1 \
 //thickness=0.36 //x=32.755 //y=5.335 //x2=32.64 //y2=5.335
r599 (  7 16 ) resistor r=0.0698411 //w=0.17 //l=0.120208 //layer=m1 \
 //thickness=0.36 //x=33.335 //y=5.335 //x2=33.42 //y2=5.25
r600 (  7 8 ) resistor r=0.553435 //w=0.131 //l=0.58 //layer=m1 \
 //thickness=0.36 //x=33.335 //y=5.335 //x2=32.755 //y2=5.335
r601 (  6 33 ) resistor r=0.00118313 //w=0.23 //layer=m1 //thickness=0.36 \
 //x=32.64 //y=5.56 //x2=32.64 //y2=5.56
r602 (  5 31 ) resistor r=0.002872 //w=0.34 //l=0.085 //layer=m1 \
 //thickness=0.36 //x=32.64 //y=5.42 //x2=32.64 //y2=5.335
r603 (  5 6 ) resistor r=0.091623 //w=0.191 //l=0.14 //layer=m1 \
 //thickness=0.36 //x=32.64 //y=5.42 //x2=32.64 //y2=5.56
r604 (  4 28 ) resistor r=0.0262263 //w=0.232 //l=0.12 //layer=m1 \
 //thickness=0.36 //x=31.88 //y=5.335 //x2=31.76 //y2=5.335
r605 (  3 31 ) resistor r=0.0675342 //w=0.23 //l=0.115 //layer=m1 \
 //thickness=0.36 //x=32.525 //y=5.335 //x2=32.64 //y2=5.335
r606 (  3 4 ) resistor r=0.615458 //w=0.131 //l=0.645 //layer=m1 \
 //thickness=0.36 //x=32.525 //y=5.335 //x2=31.88 //y2=5.335
r607 (  2 25 ) resistor r=0.0222262 //w=0.217 //l=0.118 //layer=m1 \
 //thickness=0.36 //x=31 //y=5.335 //x2=30.882 //y2=5.335
r608 (  1 28 ) resistor r=0.0262263 //w=0.232 //l=0.12 //layer=m1 \
 //thickness=0.36 //x=31.64 //y=5.335 //x2=31.76 //y2=5.335
r609 (  1 2 ) resistor r=0.610687 //w=0.131 //l=0.64 //layer=m1 \
 //thickness=0.36 //x=31.64 //y=5.335 //x2=31 //y2=5.335
ends PM_TMRDFFSNRNQNX1\%noxref_7

subckt PM_TMRDFFSNRNQNX1\%noxref_8 ( 1 3 6 7 9 10 11 12 14 15 16 17 18 19 20 \
 21 24 27 33 36 42 43 48 51 59 67 84 93 97 98 99 100 101 102 103 104 106 112 \
 113 114 115 127 129 130 131 )
c300 ( 127 0 ) capacitor c=0.00885916f //x=42.365 //y=1.095
c301 ( 115 0 ) capacitor c=0.0612936f //x=45.165 //y=4.97
c302 ( 114 0 ) capacitor c=0.0376642f //x=45.455 //y=4.97
c303 ( 113 0 ) capacitor c=0.0346489f //x=45.12 //y=1.4
c304 ( 112 0 ) capacitor c=0.018692f //x=45.12 //y=1.055
c305 ( 106 0 ) capacitor c=0.0137077f //x=44.965 //y=1.555
c306 ( 104 0 ) capacitor c=0.0158585f //x=44.965 //y=0.9
c307 ( 103 0 ) capacitor c=0.0979523f //x=44.59 //y=2.095
c308 ( 102 0 ) capacitor c=0.0229444f //x=44.59 //y=1.71
c309 ( 101 0 ) capacitor c=0.0234359f //x=44.59 //y=1.4
c310 ( 100 0 ) capacitor c=0.019815f //x=44.59 //y=1.055
c311 ( 99 0 ) capacitor c=0.110288f //x=45.53 //y=6.2
c312 ( 98 0 ) capacitor c=0.158957f //x=45.09 //y=6.2
c313 ( 93 0 ) capacitor c=0.00157785f //x=44.89 //y=4.88
c314 ( 84 0 ) capacitor c=9.93222e-19 //x=44.89 //y=2.26
c315 ( 67 0 ) capacitor c=0.0293723f //x=42.26 //y=5.56
c316 ( 59 0 ) capacitor c=0.029137f //x=41.38 //y=5.56
c317 ( 51 0 ) capacitor c=0.0278099f //x=40.5 //y=5.56
c318 ( 48 0 ) capacitor c=5.79974e-19 //x=44.9 //y=2.77
c319 ( 43 0 ) capacitor c=9.44624e-19 //x=43.2 //y=2.77
c320 ( 42 0 ) capacitor c=0.0155215f //x=44.74 //y=2.77
c321 ( 36 0 ) capacitor c=0.0146045f //x=44.89 //y=2.77
c322 ( 33 0 ) capacitor c=0.0146969f //x=43.04 //y=2.77
c323 ( 27 0 ) capacitor c=8.40513e-19 //x=42.26 //y=5.335
c324 ( 24 0 ) capacitor c=0.00712803f //x=41.38 //y=5.335
c325 ( 21 0 ) capacitor c=0.0109203f //x=40.502 //y=5.335
c326 ( 20 0 ) capacitor c=0.0604532f //x=44.89 //y=4.755
c327 ( 19 0 ) capacitor c=0.0131932f //x=44.89 //y=2.93
c328 ( 18 0 ) capacitor c=0.00432188f //x=44.89 //y=2.61
c329 ( 17 0 ) capacitor c=0.00485584f //x=44.89 //y=2.375
c330 ( 16 0 ) capacitor c=0.0631261f //x=43.04 //y=5.25
c331 ( 15 0 ) capacitor c=0.0122936f //x=43.04 //y=2.93
c332 ( 14 0 ) capacitor c=0.0181662f //x=43.04 //y=2.61
c333 ( 12 0 ) capacitor c=0.00493487f //x=42.64 //y=1.845
c334 ( 11 0 ) capacitor c=0.0129068f //x=42.955 //y=1.845
c335 ( 10 0 ) capacitor c=0.0167992f //x=42.555 //y=1.76
c336 ( 9 0 ) capacitor c=0.0112867f //x=42.555 //y=1.305
c337 ( 7 0 ) capacitor c=0.0208064f //x=42.955 //y=5.335
c338 ( 6 0 ) capacitor c=0.00933983f //x=42.26 //y=5.56
c339 ( 3 0 ) capacitor c=0.0177111f //x=42.145 //y=5.335
c340 ( 1 0 ) capacitor c=0.0148498f //x=41.26 //y=5.335
r341 (  114 116 ) resistor r=26.9307 //w=0.15 //l=0.106066 //layer=ply \
 //thickness=0.18 //x=45.455 //y=4.97 //x2=45.53 //y2=5.045
r342 (  114 115 ) resistor r=148.702 //w=0.094 //l=0.29 //layer=ply \
 //thickness=0.18 //x=45.455 //y=4.97 //x2=45.165 //y2=4.97
r343 (  113 126 ) resistor r=45.1352 //w=0.168 //l=0.173853 //layer=ply \
 //thickness=0.18 //x=45.12 //y=1.4 //x2=45.08 //y2=1.555
r344 (  112 125 ) resistor r=45.1352 //w=0.168 //l=0.173853 //layer=ply \
 //thickness=0.18 //x=45.12 //y=1.055 //x2=45.08 //y2=0.9
r345 (  112 113 ) resistor r=176.904 //w=0.094 //l=0.345 //layer=ply \
 //thickness=0.18 //x=45.12 //y=1.055 //x2=45.12 //y2=1.4
r346 (  109 115 ) resistor r=22.7971 //w=0.269 //l=0.106066 //layer=ply \
 //thickness=0.18 //x=45.09 //y=5.045 //x2=45.165 //y2=4.97
r347 (  109 124 ) resistor r=35.8364 //w=0.269 //l=0.270185 //layer=ply \
 //thickness=0.18 //x=45.09 //y=5.045 //x2=44.89 //y2=4.88
r348 (  107 120 ) resistor r=10.701 //w=0.21 //l=0.115 //layer=ply \
 //thickness=0.18 //x=44.745 //y=1.555 //x2=44.63 //y2=1.555
r349 (  106 126 ) resistor r=5.52526 //w=0.168 //l=0.115 //layer=ply \
 //thickness=0.18 //x=44.965 //y=1.555 //x2=45.08 //y2=1.555
r350 (  105 119 ) resistor r=5.52526 //w=0.168 //l=0.115 //layer=ply \
 //thickness=0.18 //x=44.745 //y=0.9 //x2=44.63 //y2=0.9
r351 (  104 125 ) resistor r=5.52526 //w=0.168 //l=0.115 //layer=ply \
 //thickness=0.18 //x=44.965 //y=0.9 //x2=45.08 //y2=0.9
r352 (  104 105 ) resistor r=112.809 //w=0.094 //l=0.22 //layer=ply \
 //thickness=0.18 //x=44.965 //y=0.9 //x2=44.745 //y2=0.9
r353 (  103 122 ) resistor r=58.7805 //w=0.246 //l=0.373497 //layer=ply \
 //thickness=0.18 //x=44.59 //y=2.095 //x2=44.89 //y2=2.26
r354 (  102 120 ) resistor r=39.5823 //w=0.21 //l=0.173853 //layer=ply \
 //thickness=0.18 //x=44.59 //y=1.71 //x2=44.63 //y2=1.555
r355 (  102 103 ) resistor r=197.415 //w=0.094 //l=0.385 //layer=ply \
 //thickness=0.18 //x=44.59 //y=1.71 //x2=44.59 //y2=2.095
r356 (  101 120 ) resistor r=39.5823 //w=0.21 //l=0.173853 //layer=ply \
 //thickness=0.18 //x=44.59 //y=1.4 //x2=44.63 //y2=1.555
r357 (  100 119 ) resistor r=45.1352 //w=0.168 //l=0.173853 //layer=ply \
 //thickness=0.18 //x=44.59 //y=1.055 //x2=44.63 //y2=0.9
r358 (  100 101 ) resistor r=176.904 //w=0.094 //l=0.345 //layer=ply \
 //thickness=0.18 //x=44.59 //y=1.055 //x2=44.59 //y2=1.4
r359 (  99 116 ) resistor r=592.245 //w=0.094 //l=1.155 //layer=ply \
 //thickness=0.18 //x=45.53 //y=6.2 //x2=45.53 //y2=5.045
r360 (  98 109 ) resistor r=592.245 //w=0.094 //l=1.155 //layer=ply \
 //thickness=0.18 //x=45.09 //y=6.2 //x2=45.09 //y2=5.045
r361 (  97 106 ) resistor r=56.4043 //w=0.094 //l=0.11 //layer=ply \
 //thickness=0.18 //x=44.855 //y=1.555 //x2=44.965 //y2=1.555
r362 (  97 107 ) resistor r=56.4043 //w=0.094 //l=0.11 //layer=ply \
 //thickness=0.18 //x=44.855 //y=1.555 //x2=44.745 //y2=1.555
r363 (  93 124 ) resistor r=152 //w=0.17 //l=0.17 //layer=licon //count=1 \
 //x=44.89 //y=4.88 //x2=44.89 //y2=4.88
r364 (  84 122 ) resistor r=152 //w=0.17 //l=0.17 //layer=licon //count=1 \
 //x=44.89 //y=2.26 //x2=44.89 //y2=2.26
r365 (  67 131 ) resistor r=23.615 //w=0.187 //l=0.345 //layer=li \
 //thickness=0.1 //x=42.26 //y=5.56 //x2=42.26 //y2=5.905
r366 (  59 130 ) resistor r=23.615 //w=0.187 //l=0.345 //layer=li \
 //thickness=0.1 //x=41.38 //y=5.56 //x2=41.38 //y2=5.905
r367 (  51 129 ) resistor r=23.615 //w=0.187 //l=0.345 //layer=li \
 //thickness=0.1 //x=40.5 //y=5.56 //x2=40.5 //y2=5.905
r368 (  43 45 ) resistor r=0.10734 //w=0.281 //l=0.16 //layer=m2 \
 //thickness=0.36 //x=43.2 //y=2.77 //x2=43.04 //y2=2.77
r369 (  42 48 ) resistor r=0.10734 //w=0.281 //l=0.16 //layer=m2 \
 //thickness=0.36 //x=44.74 //y=2.77 //x2=44.9 //y2=2.77
r370 (  42 43 ) resistor r=1.46947 //w=0.131 //l=1.54 //layer=m2 \
 //thickness=0.36 //x=44.74 //y=2.77 //x2=43.2 //y2=2.77
r371 (  41 93 ) resistor r=9.3 //w=0.17 //l=0.17 //layer=mcon //count=1 \
 //x=44.89 //y=4.88 //x2=44.89 //y2=4.88
r372 (  39 84 ) resistor r=9.3 //w=0.17 //l=0.17 //layer=mcon //count=1 \
 //x=44.89 //y=2.26 //x2=44.89 //y2=2.26
r373 (  36 48 ) resistor r=4.5 //w=0.15 //l=0.15 //layer=via1 //count=1 \
 //x=44.9 //y=2.77 //x2=44.9 //y2=2.77
r374 (  33 45 ) resistor r=4.5 //w=0.15 //l=0.15 //layer=via1 //count=1 \
 //x=43.04 //y=2.77 //x2=43.04 //y2=2.77
r375 (  31 127 ) resistor r=9.3 //w=0.17 //l=0.17 //layer=mcon //count=1 \
 //x=42.555 //y=1.19 //x2=42.555 //y2=1.19
r376 (  29 67 ) resistor r=9.3 //w=0.17 //l=0.17 //layer=mcon //count=1 \
 //x=42.26 //y=5.56 //x2=42.26 //y2=5.56
r377 (  26 59 ) resistor r=9.3 //w=0.17 //l=0.17 //layer=mcon //count=1 \
 //x=41.38 //y=5.56 //x2=41.38 //y2=5.56
r378 (  24 26 ) resistor r=0.121228 //w=0.232 //l=0.225 //layer=m1 \
 //thickness=0.36 //x=41.38 //y=5.335 //x2=41.38 //y2=5.56
r379 (  23 51 ) resistor r=9.3 //w=0.17 //l=0.17 //layer=mcon //count=1 \
 //x=40.5 //y=5.56 //x2=40.5 //y2=5.56
r380 (  21 23 ) resistor r=0.129608 //w=0.217 //l=0.225 //layer=m1 \
 //thickness=0.36 //x=40.502 //y=5.335 //x2=40.502 //y2=5.56
r381 (  20 41 ) resistor r=0.0760407 //w=0.238 //l=0.125 //layer=m1 \
 //thickness=0.36 //x=44.89 //y=4.755 //x2=44.89 //y2=4.88
r382 (  19 36 ) resistor r=0.0914072 //w=0.382 //l=0.182428 //layer=m1 \
 //thickness=0.36 //x=44.89 //y=2.93 //x2=44.842 //y2=2.77
r383 (  19 20 ) resistor r=1.74141 //w=0.131 //l=1.825 //layer=m1 \
 //thickness=0.36 //x=44.89 //y=2.93 //x2=44.89 //y2=4.755
r384 (  18 36 ) resistor r=0.0914072 //w=0.382 //l=0.182428 //layer=m1 \
 //thickness=0.36 //x=44.89 //y=2.61 //x2=44.842 //y2=2.77
r385 (  17 39 ) resistor r=0.0719237 //w=0.222 //l=0.115 //layer=m1 \
 //thickness=0.36 //x=44.89 //y=2.375 //x2=44.89 //y2=2.26
r386 (  17 18 ) resistor r=0.224237 //w=0.131 //l=0.235 //layer=m1 \
 //thickness=0.36 //x=44.89 //y=2.375 //x2=44.89 //y2=2.61
r387 (  15 33 ) resistor r=0.0911593 //w=0.376 //l=0.184174 //layer=m1 \
 //thickness=0.36 //x=43.04 //y=2.93 //x2=43.092 //y2=2.77
r388 (  15 16 ) resistor r=2.21374 //w=0.131 //l=2.32 //layer=m1 \
 //thickness=0.36 //x=43.04 //y=2.93 //x2=43.04 //y2=5.25
r389 (  14 33 ) resistor r=0.0911593 //w=0.376 //l=0.184174 //layer=m1 \
 //thickness=0.36 //x=43.04 //y=2.61 //x2=43.092 //y2=2.77
r390 (  13 14 ) resistor r=0.648855 //w=0.131 //l=0.68 //layer=m1 \
 //thickness=0.36 //x=43.04 //y=1.93 //x2=43.04 //y2=2.61
r391 (  11 13 ) resistor r=0.0698411 //w=0.17 //l=0.120208 //layer=m1 \
 //thickness=0.36 //x=42.955 //y=1.845 //x2=43.04 //y2=1.93
r392 (  11 12 ) resistor r=0.300573 //w=0.131 //l=0.315 //layer=m1 \
 //thickness=0.36 //x=42.955 //y=1.845 //x2=42.64 //y2=1.845
r393 (  10 12 ) resistor r=0.0698411 //w=0.17 //l=0.120208 //layer=m1 \
 //thickness=0.36 //x=42.555 //y=1.76 //x2=42.64 //y2=1.845
r394 (  9 31 ) resistor r=0.0717383 //w=0.224 //l=0.115 //layer=m1 \
 //thickness=0.36 //x=42.555 //y=1.305 //x2=42.555 //y2=1.19
r395 (  9 10 ) resistor r=0.43416 //w=0.131 //l=0.455 //layer=m1 \
 //thickness=0.36 //x=42.555 //y=1.305 //x2=42.555 //y2=1.76
r396 (  8 27 ) resistor r=0.0675342 //w=0.23 //l=0.115 //layer=m1 \
 //thickness=0.36 //x=42.375 //y=5.335 //x2=42.26 //y2=5.335
r397 (  7 16 ) resistor r=0.0698411 //w=0.17 //l=0.120208 //layer=m1 \
 //thickness=0.36 //x=42.955 //y=5.335 //x2=43.04 //y2=5.25
r398 (  7 8 ) resistor r=0.553435 //w=0.131 //l=0.58 //layer=m1 \
 //thickness=0.36 //x=42.955 //y=5.335 //x2=42.375 //y2=5.335
r399 (  6 29 ) resistor r=0.00118313 //w=0.23 //layer=m1 //thickness=0.36 \
 //x=42.26 //y=5.56 //x2=42.26 //y2=5.56
r400 (  5 27 ) resistor r=0.002872 //w=0.34 //l=0.085 //layer=m1 \
 //thickness=0.36 //x=42.26 //y=5.42 //x2=42.26 //y2=5.335
r401 (  5 6 ) resistor r=0.091623 //w=0.191 //l=0.14 //layer=m1 \
 //thickness=0.36 //x=42.26 //y=5.42 //x2=42.26 //y2=5.56
r402 (  4 24 ) resistor r=0.0262263 //w=0.232 //l=0.12 //layer=m1 \
 //thickness=0.36 //x=41.5 //y=5.335 //x2=41.38 //y2=5.335
r403 (  3 27 ) resistor r=0.0675342 //w=0.23 //l=0.115 //layer=m1 \
 //thickness=0.36 //x=42.145 //y=5.335 //x2=42.26 //y2=5.335
r404 (  3 4 ) resistor r=0.615458 //w=0.131 //l=0.645 //layer=m1 \
 //thickness=0.36 //x=42.145 //y=5.335 //x2=41.5 //y2=5.335
r405 (  2 21 ) resistor r=0.0222262 //w=0.217 //l=0.118 //layer=m1 \
 //thickness=0.36 //x=40.62 //y=5.335 //x2=40.502 //y2=5.335
r406 (  1 24 ) resistor r=0.0262263 //w=0.232 //l=0.12 //layer=m1 \
 //thickness=0.36 //x=41.26 //y=5.335 //x2=41.38 //y2=5.335
r407 (  1 2 ) resistor r=0.610687 //w=0.131 //l=0.64 //layer=m1 \
 //thickness=0.36 //x=41.26 //y=5.335 //x2=40.62 //y2=5.335
ends PM_TMRDFFSNRNQNX1\%noxref_8

subckt PM_TMRDFFSNRNQNX1\%noxref_9 ( 1 2 3 4 5 7 10 11 13 14 15 16 18 19 20 21 \
 22 23 24 30 33 36 39 47 49 57 62 65 66 68 71 80 85 93 101 118 127 131 132 133 \
 134 135 136 140 141 142 147 149 152 153 154 155 156 157 158 160 166 167 168 \
 169 174 175 180 191 193 194 195 )
c494 ( 191 0 ) capacitor c=0.00885916f //x=37.555 //y=1.095
c495 ( 180 0 ) capacitor c=0.0710579f //x=32.68 //y=4.88
c496 ( 175 0 ) capacitor c=0.0278202f //x=32.68 //y=2.095
c497 ( 174 0 ) capacitor c=0.0479349f //x=32.68 //y=2.26
c498 ( 169 0 ) capacitor c=0.0612936f //x=49.975 //y=4.97
c499 ( 168 0 ) capacitor c=0.0376642f //x=50.265 //y=4.97
c500 ( 167 0 ) capacitor c=0.0346489f //x=49.93 //y=1.4
c501 ( 166 0 ) capacitor c=0.018692f //x=49.93 //y=1.055
c502 ( 160 0 ) capacitor c=0.0137077f //x=49.775 //y=1.555
c503 ( 158 0 ) capacitor c=0.0158585f //x=49.775 //y=0.9
c504 ( 157 0 ) capacitor c=0.10101f //x=49.4 //y=2.095
c505 ( 156 0 ) capacitor c=0.0229444f //x=49.4 //y=1.71
c506 ( 155 0 ) capacitor c=0.0234359f //x=49.4 //y=1.4
c507 ( 154 0 ) capacitor c=0.019815f //x=49.4 //y=1.055
c508 ( 153 0 ) capacitor c=0.0443175f //x=33.2 //y=1.44
c509 ( 152 0 ) capacitor c=0.0199703f //x=33.2 //y=1.095
c510 ( 149 0 ) capacitor c=0.0162526f //x=33.045 //y=1.595
c511 ( 147 0 ) capacitor c=0.0157807f //x=33.045 //y=0.94
c512 ( 142 0 ) capacitor c=0.0220935f //x=32.67 //y=1.75
c513 ( 141 0 ) capacitor c=0.0207489f //x=32.67 //y=1.44
c514 ( 140 0 ) capacitor c=0.0194091f //x=32.67 //y=1.095
c515 ( 136 0 ) capacitor c=0.110208f //x=50.34 //y=6.2
c516 ( 135 0 ) capacitor c=0.158957f //x=49.9 //y=6.2
c517 ( 134 0 ) capacitor c=0.159671f //x=32.86 //y=6.2
c518 ( 133 0 ) capacitor c=0.110208f //x=32.42 //y=6.2
c519 ( 127 0 ) capacitor c=0.00159026f //x=49.7 //y=4.88
c520 ( 118 0 ) capacitor c=0.0012618f //x=49.7 //y=2.26
c521 ( 101 0 ) capacitor c=0.0293723f //x=37.45 //y=5.56
c522 ( 93 0 ) capacitor c=0.029137f //x=36.57 //y=5.56
c523 ( 85 0 ) capacitor c=0.0278099f //x=35.69 //y=5.56
c524 ( 80 0 ) capacitor c=9.5006e-19 //x=32.68 //y=4.88
c525 ( 71 0 ) capacitor c=0.00101179f //x=32.68 //y=2.26
c526 ( 68 0 ) capacitor c=3.39224e-19 //x=49.695 //y=3.51
c527 ( 66 0 ) capacitor c=6.97864e-19 //x=38.39 //y=3.495
c528 ( 65 0 ) capacitor c=0.0608267f //x=38.07 //y=3.495
c529 ( 62 0 ) capacitor c=4.31985e-19 //x=32.85 //y=3.515
c530 ( 57 0 ) capacitor c=0.113478f //x=49.535 //y=3.51
c531 ( 49 0 ) capacitor c=0.0170797f //x=49.695 //y=3.51
c532 ( 47 0 ) capacitor c=0.0158593f //x=38.23 //y=3.51
c533 ( 39 0 ) capacitor c=8.40513e-19 //x=37.45 //y=5.335
c534 ( 36 0 ) capacitor c=0.00784956f //x=36.57 //y=5.335
c535 ( 33 0 ) capacitor c=0.0123748f //x=35.692 //y=5.335
c536 ( 30 0 ) capacitor c=0.0150828f //x=32.68 //y=3.51
c537 ( 24 0 ) capacitor c=0.0346814f //x=49.7 //y=4.755
c538 ( 23 0 ) capacitor c=0.0144231f //x=49.7 //y=3.67
c539 ( 22 0 ) capacitor c=0.026634f //x=49.7 //y=3.35
c540 ( 21 0 ) capacitor c=0.00493552f //x=49.7 //y=2.375
c541 ( 20 0 ) capacitor c=0.0410307f //x=38.23 //y=5.25
c542 ( 19 0 ) capacitor c=0.0133594f //x=38.23 //y=3.655
c543 ( 18 0 ) capacitor c=0.0372097f //x=38.23 //y=3.335
c544 ( 16 0 ) capacitor c=0.0048771f //x=37.83 //y=1.845
c545 ( 15 0 ) capacitor c=0.0132685f //x=38.145 //y=1.845
c546 ( 14 0 ) capacitor c=0.0167992f //x=37.745 //y=1.76
c547 ( 13 0 ) capacitor c=0.0113147f //x=37.745 //y=1.305
c548 ( 11 0 ) capacitor c=0.0205222f //x=38.145 //y=5.335
c549 ( 10 0 ) capacitor c=0.00933583f //x=37.45 //y=5.56
c550 ( 7 0 ) capacitor c=0.0155123f //x=37.335 //y=5.335
c551 ( 5 0 ) capacitor c=0.00958589f //x=36.45 //y=5.335
c552 ( 4 0 ) capacitor c=0.0303415f //x=32.68 //y=4.75
c553 ( 3 0 ) capacitor c=0.0122376f //x=32.68 //y=3.675
c554 ( 2 0 ) capacitor c=0.0217875f //x=32.68 //y=3.355
c555 ( 1 0 ) capacitor c=0.005545f //x=32.68 //y=2.375
r556 (  174 175 ) resistor r=52.7279 //w=0.214 //l=0.165 //layer=ply \
 //thickness=0.18 //x=32.68 //y=2.26 //x2=32.68 //y2=2.095
r557 (  168 170 ) resistor r=26.9307 //w=0.15 //l=0.106066 //layer=ply \
 //thickness=0.18 //x=50.265 //y=4.97 //x2=50.34 //y2=5.045
r558 (  168 169 ) resistor r=148.702 //w=0.094 //l=0.29 //layer=ply \
 //thickness=0.18 //x=50.265 //y=4.97 //x2=49.975 //y2=4.97
r559 (  167 190 ) resistor r=45.1352 //w=0.168 //l=0.173853 //layer=ply \
 //thickness=0.18 //x=49.93 //y=1.4 //x2=49.89 //y2=1.555
r560 (  166 189 ) resistor r=45.1352 //w=0.168 //l=0.173853 //layer=ply \
 //thickness=0.18 //x=49.93 //y=1.055 //x2=49.89 //y2=0.9
r561 (  166 167 ) resistor r=176.904 //w=0.094 //l=0.345 //layer=ply \
 //thickness=0.18 //x=49.93 //y=1.055 //x2=49.93 //y2=1.4
r562 (  163 169 ) resistor r=22.7971 //w=0.269 //l=0.106066 //layer=ply \
 //thickness=0.18 //x=49.9 //y=5.045 //x2=49.975 //y2=4.97
r563 (  163 188 ) resistor r=35.8364 //w=0.269 //l=0.270185 //layer=ply \
 //thickness=0.18 //x=49.9 //y=5.045 //x2=49.7 //y2=4.88
r564 (  161 184 ) resistor r=10.701 //w=0.21 //l=0.115 //layer=ply \
 //thickness=0.18 //x=49.555 //y=1.555 //x2=49.44 //y2=1.555
r565 (  160 190 ) resistor r=5.52526 //w=0.168 //l=0.115 //layer=ply \
 //thickness=0.18 //x=49.775 //y=1.555 //x2=49.89 //y2=1.555
r566 (  159 183 ) resistor r=5.52526 //w=0.168 //l=0.115 //layer=ply \
 //thickness=0.18 //x=49.555 //y=0.9 //x2=49.44 //y2=0.9
r567 (  158 189 ) resistor r=5.52526 //w=0.168 //l=0.115 //layer=ply \
 //thickness=0.18 //x=49.775 //y=0.9 //x2=49.89 //y2=0.9
r568 (  158 159 ) resistor r=112.809 //w=0.094 //l=0.22 //layer=ply \
 //thickness=0.18 //x=49.775 //y=0.9 //x2=49.555 //y2=0.9
r569 (  157 186 ) resistor r=58.7805 //w=0.246 //l=0.373497 //layer=ply \
 //thickness=0.18 //x=49.4 //y=2.095 //x2=49.7 //y2=2.26
r570 (  156 184 ) resistor r=39.5823 //w=0.21 //l=0.173853 //layer=ply \
 //thickness=0.18 //x=49.4 //y=1.71 //x2=49.44 //y2=1.555
r571 (  156 157 ) resistor r=197.415 //w=0.094 //l=0.385 //layer=ply \
 //thickness=0.18 //x=49.4 //y=1.71 //x2=49.4 //y2=2.095
r572 (  155 184 ) resistor r=39.5823 //w=0.21 //l=0.173853 //layer=ply \
 //thickness=0.18 //x=49.4 //y=1.4 //x2=49.44 //y2=1.555
r573 (  154 183 ) resistor r=45.1352 //w=0.168 //l=0.173853 //layer=ply \
 //thickness=0.18 //x=49.4 //y=1.055 //x2=49.44 //y2=0.9
r574 (  154 155 ) resistor r=176.904 //w=0.094 //l=0.345 //layer=ply \
 //thickness=0.18 //x=49.4 //y=1.055 //x2=49.4 //y2=1.4
r575 (  153 182 ) resistor r=45.1352 //w=0.168 //l=0.173853 //layer=ply \
 //thickness=0.18 //x=33.2 //y=1.44 //x2=33.16 //y2=1.595
r576 (  152 181 ) resistor r=45.1352 //w=0.168 //l=0.173853 //layer=ply \
 //thickness=0.18 //x=33.2 //y=1.095 //x2=33.16 //y2=0.94
r577 (  152 153 ) resistor r=176.904 //w=0.094 //l=0.345 //layer=ply \
 //thickness=0.18 //x=33.2 //y=1.095 //x2=33.2 //y2=1.44
r578 (  150 178 ) resistor r=10.701 //w=0.21 //l=0.115 //layer=ply \
 //thickness=0.18 //x=32.825 //y=1.595 //x2=32.71 //y2=1.595
r579 (  149 182 ) resistor r=5.52526 //w=0.168 //l=0.115 //layer=ply \
 //thickness=0.18 //x=33.045 //y=1.595 //x2=33.16 //y2=1.595
r580 (  148 177 ) resistor r=5.52526 //w=0.168 //l=0.115 //layer=ply \
 //thickness=0.18 //x=32.825 //y=0.94 //x2=32.71 //y2=0.94
r581 (  147 181 ) resistor r=5.52526 //w=0.168 //l=0.115 //layer=ply \
 //thickness=0.18 //x=33.045 //y=0.94 //x2=33.16 //y2=0.94
r582 (  147 148 ) resistor r=112.809 //w=0.094 //l=0.22 //layer=ply \
 //thickness=0.18 //x=33.045 //y=0.94 //x2=32.825 //y2=0.94
r583 (  144 180 ) resistor r=37.236 //w=0.233 //l=0.249199 //layer=ply \
 //thickness=0.18 //x=32.86 //y=5.045 //x2=32.68 //y2=4.88
r584 (  142 178 ) resistor r=39.5823 //w=0.21 //l=0.173853 //layer=ply \
 //thickness=0.18 //x=32.67 //y=1.75 //x2=32.71 //y2=1.595
r585 (  142 175 ) resistor r=176.904 //w=0.094 //l=0.345 //layer=ply \
 //thickness=0.18 //x=32.67 //y=1.75 //x2=32.67 //y2=2.095
r586 (  141 178 ) resistor r=39.5823 //w=0.21 //l=0.173853 //layer=ply \
 //thickness=0.18 //x=32.67 //y=1.44 //x2=32.71 //y2=1.595
r587 (  140 177 ) resistor r=45.1352 //w=0.168 //l=0.173853 //layer=ply \
 //thickness=0.18 //x=32.67 //y=1.095 //x2=32.71 //y2=0.94
r588 (  140 141 ) resistor r=176.904 //w=0.094 //l=0.345 //layer=ply \
 //thickness=0.18 //x=32.67 //y=1.095 //x2=32.67 //y2=1.44
r589 (  137 180 ) resistor r=53.7854 //w=0.233 //l=0.332415 //layer=ply \
 //thickness=0.18 //x=32.42 //y=5.045 //x2=32.68 //y2=4.88
r590 (  136 170 ) resistor r=592.245 //w=0.094 //l=1.155 //layer=ply \
 //thickness=0.18 //x=50.34 //y=6.2 //x2=50.34 //y2=5.045
r591 (  135 163 ) resistor r=592.245 //w=0.094 //l=1.155 //layer=ply \
 //thickness=0.18 //x=49.9 //y=6.2 //x2=49.9 //y2=5.045
r592 (  134 144 ) resistor r=592.245 //w=0.094 //l=1.155 //layer=ply \
 //thickness=0.18 //x=32.86 //y=6.2 //x2=32.86 //y2=5.045
r593 (  133 137 ) resistor r=592.245 //w=0.094 //l=1.155 //layer=ply \
 //thickness=0.18 //x=32.42 //y=6.2 //x2=32.42 //y2=5.045
r594 (  132 160 ) resistor r=56.4043 //w=0.094 //l=0.11 //layer=ply \
 //thickness=0.18 //x=49.665 //y=1.555 //x2=49.775 //y2=1.555
r595 (  132 161 ) resistor r=56.4043 //w=0.094 //l=0.11 //layer=ply \
 //thickness=0.18 //x=49.665 //y=1.555 //x2=49.555 //y2=1.555
r596 (  131 149 ) resistor r=56.4043 //w=0.094 //l=0.11 //layer=ply \
 //thickness=0.18 //x=32.935 //y=1.595 //x2=33.045 //y2=1.595
r597 (  131 150 ) resistor r=56.4043 //w=0.094 //l=0.11 //layer=ply \
 //thickness=0.18 //x=32.935 //y=1.595 //x2=32.825 //y2=1.595
r598 (  127 188 ) resistor r=152 //w=0.17 //l=0.17 //layer=licon //count=1 \
 //x=49.7 //y=4.88 //x2=49.7 //y2=4.88
r599 (  118 186 ) resistor r=152 //w=0.17 //l=0.17 //layer=licon //count=1 \
 //x=49.7 //y=2.26 //x2=49.7 //y2=2.26
r600 (  101 195 ) resistor r=23.615 //w=0.187 //l=0.345 //layer=li \
 //thickness=0.1 //x=37.45 //y=5.56 //x2=37.45 //y2=5.905
r601 (  93 194 ) resistor r=23.615 //w=0.187 //l=0.345 //layer=li \
 //thickness=0.1 //x=36.57 //y=5.56 //x2=36.57 //y2=5.905
r602 (  85 193 ) resistor r=23.615 //w=0.187 //l=0.345 //layer=li \
 //thickness=0.1 //x=35.69 //y=5.56 //x2=35.69 //y2=5.905
r603 (  80 180 ) resistor r=152 //w=0.17 //l=0.17 //layer=licon //count=1 \
 //x=32.68 //y=4.88 //x2=32.68 //y2=4.88
r604 (  71 174 ) resistor r=152 //w=0.17 //l=0.17 //layer=licon //count=1 \
 //x=32.68 //y=2.26 //x2=32.68 //y2=2.26
r605 (  64 66 ) resistor r=0.10734 //w=0.281 //l=0.16 //layer=m2 \
 //thickness=0.36 //x=38.23 //y=3.495 //x2=38.39 //y2=3.495
r606 (  64 65 ) resistor r=0.10734 //w=0.281 //l=0.16 //layer=m2 \
 //thickness=0.36 //x=38.23 //y=3.495 //x2=38.07 //y2=3.495
r607 (  62 65 ) resistor r=4.98092 //w=0.131 //l=5.22 //layer=m2 \
 //thickness=0.36 //x=32.85 //y=3.51 //x2=38.07 //y2=3.51
r608 (  60 62 ) resistor r=0.10734 //w=0.281 //l=0.16 //layer=m2 \
 //thickness=0.36 //x=32.69 //y=3.515 //x2=32.85 //y2=3.515
r609 (  57 68 ) resistor r=0.10734 //w=0.281 //l=0.16 //layer=m2 \
 //thickness=0.36 //x=49.535 //y=3.51 //x2=49.695 //y2=3.51
r610 (  57 66 ) resistor r=10.6345 //w=0.131 //l=11.145 //layer=m2 \
 //thickness=0.36 //x=49.535 //y=3.51 //x2=38.39 //y2=3.51
r611 (  54 127 ) resistor r=9.3 //w=0.17 //l=0.17 //layer=mcon //count=1 \
 //x=49.7 //y=4.88 //x2=49.7 //y2=4.88
r612 (  52 118 ) resistor r=9.3 //w=0.17 //l=0.17 //layer=mcon //count=1 \
 //x=49.7 //y=2.26 //x2=49.7 //y2=2.26
r613 (  49 68 ) resistor r=4.5 //w=0.15 //l=0.15 //layer=via1 //count=1 \
 //x=49.695 //y=3.51 //x2=49.695 //y2=3.51
r614 (  45 64 ) resistor r=4.5 //w=0.15 //l=0.15 //layer=via1 //count=1 \
 //x=38.23 //y=3.495 //x2=38.23 //y2=3.495
r615 (  45 47 ) resistor r=0.0049867 //w=0.376 //l=0.015 //layer=m1 \
 //thickness=0.36 //x=38.282 //y=3.495 //x2=38.282 //y2=3.51
r616 (  43 191 ) resistor r=9.3 //w=0.17 //l=0.17 //layer=mcon //count=1 \
 //x=37.745 //y=1.19 //x2=37.745 //y2=1.19
r617 (  41 101 ) resistor r=9.3 //w=0.17 //l=0.17 //layer=mcon //count=1 \
 //x=37.45 //y=5.56 //x2=37.45 //y2=5.56
r618 (  38 93 ) resistor r=9.3 //w=0.17 //l=0.17 //layer=mcon //count=1 \
 //x=36.57 //y=5.56 //x2=36.57 //y2=5.56
r619 (  36 38 ) resistor r=0.121228 //w=0.232 //l=0.225 //layer=m1 \
 //thickness=0.36 //x=36.57 //y=5.335 //x2=36.57 //y2=5.56
r620 (  35 85 ) resistor r=9.3 //w=0.17 //l=0.17 //layer=mcon //count=1 \
 //x=35.69 //y=5.56 //x2=35.69 //y2=5.56
r621 (  33 35 ) resistor r=0.129608 //w=0.217 //l=0.225 //layer=m1 \
 //thickness=0.36 //x=35.692 //y=5.335 //x2=35.692 //y2=5.56
r622 (  32 60 ) resistor r=4.5 //w=0.15 //l=0.15 //layer=via1 //count=1 \
 //x=32.69 //y=3.515 //x2=32.69 //y2=3.515
r623 (  30 32 ) resistor r=0.00168464 //w=0.371 //l=0.005 //layer=m1 \
 //thickness=0.36 //x=32.737 //y=3.51 //x2=32.737 //y2=3.515
r624 (  28 80 ) resistor r=9.3 //w=0.17 //l=0.17 //layer=mcon //count=1 \
 //x=32.68 //y=4.88 //x2=32.68 //y2=4.88
r625 (  26 71 ) resistor r=9.3 //w=0.17 //l=0.17 //layer=mcon //count=1 \
 //x=32.68 //y=2.26 //x2=32.68 //y2=2.26
r626 (  24 54 ) resistor r=0.0760407 //w=0.238 //l=0.125 //layer=m1 \
 //thickness=0.36 //x=49.7 //y=4.755 //x2=49.7 //y2=4.88
r627 (  23 49 ) resistor r=0.0910802 //w=0.374 //l=0.185472 //layer=m1 \
 //thickness=0.36 //x=49.7 //y=3.67 //x2=49.645 //y2=3.51
r628 (  23 24 ) resistor r=1.03531 //w=0.131 //l=1.085 //layer=m1 \
 //thickness=0.36 //x=49.7 //y=3.67 //x2=49.7 //y2=4.755
r629 (  22 49 ) resistor r=0.0910802 //w=0.374 //l=0.185472 //layer=m1 \
 //thickness=0.36 //x=49.7 //y=3.35 //x2=49.645 //y2=3.51
r630 (  21 52 ) resistor r=0.0719237 //w=0.222 //l=0.115 //layer=m1 \
 //thickness=0.36 //x=49.7 //y=2.375 //x2=49.7 //y2=2.26
r631 (  21 22 ) resistor r=0.930344 //w=0.131 //l=0.975 //layer=m1 \
 //thickness=0.36 //x=49.7 //y=2.375 //x2=49.7 //y2=3.35
r632 (  19 47 ) resistor r=0.0861726 //w=0.376 //l=0.169012 //layer=m1 \
 //thickness=0.36 //x=38.23 //y=3.655 //x2=38.282 //y2=3.51
r633 (  19 20 ) resistor r=1.52195 //w=0.131 //l=1.595 //layer=m1 \
 //thickness=0.36 //x=38.23 //y=3.655 //x2=38.23 //y2=5.25
r634 (  18 45 ) resistor r=0.0911593 //w=0.376 //l=0.184174 //layer=m1 \
 //thickness=0.36 //x=38.23 //y=3.335 //x2=38.282 //y2=3.495
r635 (  17 18 ) resistor r=1.34065 //w=0.131 //l=1.405 //layer=m1 \
 //thickness=0.36 //x=38.23 //y=1.93 //x2=38.23 //y2=3.335
r636 (  15 17 ) resistor r=0.0698411 //w=0.17 //l=0.120208 //layer=m1 \
 //thickness=0.36 //x=38.145 //y=1.845 //x2=38.23 //y2=1.93
r637 (  15 16 ) resistor r=0.300573 //w=0.131 //l=0.315 //layer=m1 \
 //thickness=0.36 //x=38.145 //y=1.845 //x2=37.83 //y2=1.845
r638 (  14 16 ) resistor r=0.0698411 //w=0.17 //l=0.120208 //layer=m1 \
 //thickness=0.36 //x=37.745 //y=1.76 //x2=37.83 //y2=1.845
r639 (  13 43 ) resistor r=0.0717383 //w=0.224 //l=0.115 //layer=m1 \
 //thickness=0.36 //x=37.745 //y=1.305 //x2=37.745 //y2=1.19
r640 (  13 14 ) resistor r=0.43416 //w=0.131 //l=0.455 //layer=m1 \
 //thickness=0.36 //x=37.745 //y=1.305 //x2=37.745 //y2=1.76
r641 (  12 39 ) resistor r=0.0675342 //w=0.23 //l=0.115 //layer=m1 \
 //thickness=0.36 //x=37.565 //y=5.335 //x2=37.45 //y2=5.335
r642 (  11 20 ) resistor r=0.0698411 //w=0.17 //l=0.120208 //layer=m1 \
 //thickness=0.36 //x=38.145 //y=5.335 //x2=38.23 //y2=5.25
r643 (  11 12 ) resistor r=0.553435 //w=0.131 //l=0.58 //layer=m1 \
 //thickness=0.36 //x=38.145 //y=5.335 //x2=37.565 //y2=5.335
r644 (  10 41 ) resistor r=0.00118313 //w=0.23 //layer=m1 //thickness=0.36 \
 //x=37.45 //y=5.56 //x2=37.45 //y2=5.56
r645 (  9 39 ) resistor r=0.002872 //w=0.34 //l=0.085 //layer=m1 \
 //thickness=0.36 //x=37.45 //y=5.42 //x2=37.45 //y2=5.335
r646 (  9 10 ) resistor r=0.091623 //w=0.191 //l=0.14 //layer=m1 \
 //thickness=0.36 //x=37.45 //y=5.42 //x2=37.45 //y2=5.56
r647 (  8 36 ) resistor r=0.0262263 //w=0.232 //l=0.12 //layer=m1 \
 //thickness=0.36 //x=36.69 //y=5.335 //x2=36.57 //y2=5.335
r648 (  7 39 ) resistor r=0.0675342 //w=0.23 //l=0.115 //layer=m1 \
 //thickness=0.36 //x=37.335 //y=5.335 //x2=37.45 //y2=5.335
r649 (  7 8 ) resistor r=0.615458 //w=0.131 //l=0.645 //layer=m1 \
 //thickness=0.36 //x=37.335 //y=5.335 //x2=36.69 //y2=5.335
r650 (  6 33 ) resistor r=0.0222262 //w=0.217 //l=0.118 //layer=m1 \
 //thickness=0.36 //x=35.81 //y=5.335 //x2=35.692 //y2=5.335
r651 (  5 36 ) resistor r=0.0262263 //w=0.232 //l=0.12 //layer=m1 \
 //thickness=0.36 //x=36.45 //y=5.335 //x2=36.57 //y2=5.335
r652 (  5 6 ) resistor r=0.610687 //w=0.131 //l=0.64 //layer=m1 \
 //thickness=0.36 //x=36.45 //y=5.335 //x2=35.81 //y2=5.335
r653 (  4 28 ) resistor r=0.0801089 //w=0.224 //l=0.13 //layer=m1 \
 //thickness=0.36 //x=32.68 //y=4.75 //x2=32.68 //y2=4.88
r654 (  3 32 ) resistor r=0.0909648 //w=0.371 //l=0.186333 //layer=m1 \
 //thickness=0.36 //x=32.68 //y=3.675 //x2=32.737 //y2=3.515
r655 (  3 4 ) resistor r=1.02576 //w=0.131 //l=1.075 //layer=m1 \
 //thickness=0.36 //x=32.68 //y=3.675 //x2=32.68 //y2=4.75
r656 (  2 30 ) resistor r=0.0892801 //w=0.371 //l=0.181273 //layer=m1 \
 //thickness=0.36 //x=32.68 //y=3.355 //x2=32.737 //y2=3.51
r657 (  1 26 ) resistor r=0.0719237 //w=0.222 //l=0.115 //layer=m1 \
 //thickness=0.36 //x=32.68 //y=2.375 //x2=32.68 //y2=2.26
r658 (  1 2 ) resistor r=0.935115 //w=0.131 //l=0.98 //layer=m1 \
 //thickness=0.36 //x=32.68 //y=2.375 //x2=32.68 //y2=3.355
ends PM_TMRDFFSNRNQNX1\%noxref_9

subckt PM_TMRDFFSNRNQNX1\%noxref_10 ( 1 2 3 4 5 6 7 8 9 11 14 15 17 18 19 20 \
 22 23 24 25 26 27 28 34 38 45 48 51 57 61 70 72 73 77 80 81 87 96 101 110 115 \
 123 131 148 157 161 162 163 164 165 166 167 168 169 173 174 175 180 182 185 \
 186 190 191 192 197 199 202 203 207 208 209 214 216 219 220 222 223 228 232 \
 233 238 242 243 248 251 253 254 255 )
c614 ( 251 0 ) capacitor c=0.00885916f //x=47.175 //y=1.095
c615 ( 248 0 ) capacitor c=0.0651477f //x=56.73 //y=4.88
c616 ( 243 0 ) capacitor c=0.0278202f //x=56.73 //y=2.095
c617 ( 242 0 ) capacitor c=0.0503043f //x=56.73 //y=2.26
c618 ( 238 0 ) capacitor c=0.0651406f //x=42.3 //y=4.88
c619 ( 233 0 ) capacitor c=0.0278202f //x=42.3 //y=2.095
c620 ( 232 0 ) capacitor c=0.0503043f //x=42.3 //y=2.26
c621 ( 228 0 ) capacitor c=0.0653609f //x=37.49 //y=4.88
c622 ( 223 0 ) capacitor c=0.0278202f //x=37.49 //y=2.095
c623 ( 222 0 ) capacitor c=0.0503043f //x=37.49 //y=2.26
c624 ( 220 0 ) capacitor c=0.0443175f //x=57.25 //y=1.44
c625 ( 219 0 ) capacitor c=0.0199703f //x=57.25 //y=1.095
c626 ( 216 0 ) capacitor c=0.0162526f //x=57.095 //y=1.595
c627 ( 214 0 ) capacitor c=0.0157807f //x=57.095 //y=0.94
c628 ( 209 0 ) capacitor c=0.0220935f //x=56.72 //y=1.75
c629 ( 208 0 ) capacitor c=0.0207489f //x=56.72 //y=1.44
c630 ( 207 0 ) capacitor c=0.0194091f //x=56.72 //y=1.095
c631 ( 203 0 ) capacitor c=0.0443175f //x=42.82 //y=1.44
c632 ( 202 0 ) capacitor c=0.0199703f //x=42.82 //y=1.095
c633 ( 199 0 ) capacitor c=0.0162526f //x=42.665 //y=1.595
c634 ( 197 0 ) capacitor c=0.0157807f //x=42.665 //y=0.94
c635 ( 192 0 ) capacitor c=0.0220935f //x=42.29 //y=1.75
c636 ( 191 0 ) capacitor c=0.0207489f //x=42.29 //y=1.44
c637 ( 190 0 ) capacitor c=0.0194091f //x=42.29 //y=1.095
c638 ( 186 0 ) capacitor c=0.0443175f //x=38.01 //y=1.44
c639 ( 185 0 ) capacitor c=0.0199703f //x=38.01 //y=1.095
c640 ( 182 0 ) capacitor c=0.0162526f //x=37.855 //y=1.595
c641 ( 180 0 ) capacitor c=0.0157807f //x=37.855 //y=0.94
c642 ( 175 0 ) capacitor c=0.0220935f //x=37.48 //y=1.75
c643 ( 174 0 ) capacitor c=0.0207489f //x=37.48 //y=1.44
c644 ( 173 0 ) capacitor c=0.0194091f //x=37.48 //y=1.095
c645 ( 169 0 ) capacitor c=0.159671f //x=56.91 //y=6.2
c646 ( 168 0 ) capacitor c=0.110208f //x=56.47 //y=6.2
c647 ( 167 0 ) capacitor c=0.159671f //x=42.48 //y=6.2
c648 ( 166 0 ) capacitor c=0.110208f //x=42.04 //y=6.2
c649 ( 165 0 ) capacitor c=0.159671f //x=37.67 //y=6.2
c650 ( 164 0 ) capacitor c=0.110208f //x=37.23 //y=6.2
c651 ( 157 0 ) capacitor c=9.5006e-19 //x=56.73 //y=4.88
c652 ( 148 0 ) capacitor c=0.00101179f //x=56.73 //y=2.26
c653 ( 131 0 ) capacitor c=0.0293124f //x=47.07 //y=5.56
c654 ( 123 0 ) capacitor c=0.029137f //x=46.19 //y=5.56
c655 ( 115 0 ) capacitor c=0.0278099f //x=45.31 //y=5.56
c656 ( 110 0 ) capacitor c=9.5006e-19 //x=42.3 //y=4.88
c657 ( 101 0 ) capacitor c=0.00101179f //x=42.3 //y=2.26
c658 ( 96 0 ) capacitor c=9.06359e-19 //x=37.49 //y=4.88
c659 ( 87 0 ) capacitor c=0.00101179f //x=37.49 //y=2.26
c660 ( 81 0 ) capacitor c=3.98458e-19 //x=42.46 //y=3.895
c661 ( 80 0 ) capacitor c=0.0441961f //x=42.14 //y=3.895
c662 ( 77 0 ) capacitor c=3.98458e-19 //x=37.65 //y=3.895
c663 ( 73 0 ) capacitor c=0.0212158f //x=49.565 //y=3.895
c664 ( 72 0 ) capacitor c=0.0706645f //x=49.91 //y=3.895
c665 ( 70 0 ) capacitor c=0.0531379f //x=47.68 //y=3.88
c666 ( 61 0 ) capacitor c=0.0149589f //x=56.73 //y=3.88
c667 ( 57 0 ) capacitor c=0.0158949f //x=47.85 //y=3.88
c668 ( 51 0 ) capacitor c=0.00105955f //x=47.07 //y=5.335
c669 ( 48 0 ) capacitor c=0.00737416f //x=46.19 //y=5.335
c670 ( 45 0 ) capacitor c=0.0119563f //x=45.312 //y=5.335
c671 ( 38 0 ) capacitor c=0.0149589f //x=42.3 //y=3.88
c672 ( 34 0 ) capacitor c=0.0149589f //x=37.49 //y=3.88
c673 ( 28 0 ) capacitor c=0.0180433f //x=56.73 //y=4.75
c674 ( 27 0 ) capacitor c=0.013506f //x=56.73 //y=4.045
c675 ( 26 0 ) capacitor c=0.0288083f //x=56.73 //y=3.725
c676 ( 25 0 ) capacitor c=0.00556102f //x=56.73 //y=2.375
c677 ( 24 0 ) capacitor c=0.0306844f //x=47.85 //y=5.25
c678 ( 23 0 ) capacitor c=0.0138897f //x=47.85 //y=4.055
c679 ( 22 0 ) capacitor c=0.0490588f //x=47.85 //y=3.735
c680 ( 20 0 ) capacitor c=0.00493487f //x=47.45 //y=1.845
c681 ( 19 0 ) capacitor c=0.0133342f //x=47.765 //y=1.845
c682 ( 18 0 ) capacitor c=0.0167992f //x=47.365 //y=1.76
c683 ( 17 0 ) capacitor c=0.0111491f //x=47.365 //y=1.305
c684 ( 15 0 ) capacitor c=0.0215649f //x=47.765 //y=5.335
c685 ( 14 0 ) capacitor c=0.00933983f //x=47.07 //y=5.56
c686 ( 11 0 ) capacitor c=0.0182817f //x=46.955 //y=5.335
c687 ( 9 0 ) capacitor c=0.0152347f //x=46.07 //y=5.335
c688 ( 8 0 ) capacitor c=0.0180104f //x=42.3 //y=4.75
c689 ( 7 0 ) capacitor c=0.011494f //x=42.3 //y=4.055
c690 ( 6 0 ) capacitor c=0.029293f //x=42.3 //y=3.735
c691 ( 5 0 ) capacitor c=0.00556102f //x=42.3 //y=2.375
c692 ( 4 0 ) capacitor c=0.0180726f //x=37.49 //y=4.75
c693 ( 3 0 ) capacitor c=0.0115187f //x=37.49 //y=4.055
c694 ( 2 0 ) capacitor c=0.0302471f //x=37.49 //y=3.735
c695 ( 1 0 ) capacitor c=0.00556102f //x=37.49 //y=2.375
r696 (  242 243 ) resistor r=52.7279 //w=0.214 //l=0.165 //layer=ply \
 //thickness=0.18 //x=56.73 //y=2.26 //x2=56.73 //y2=2.095
r697 (  232 233 ) resistor r=52.7279 //w=0.214 //l=0.165 //layer=ply \
 //thickness=0.18 //x=42.3 //y=2.26 //x2=42.3 //y2=2.095
r698 (  222 223 ) resistor r=52.7279 //w=0.214 //l=0.165 //layer=ply \
 //thickness=0.18 //x=37.49 //y=2.26 //x2=37.49 //y2=2.095
r699 (  220 250 ) resistor r=45.1352 //w=0.168 //l=0.173853 //layer=ply \
 //thickness=0.18 //x=57.25 //y=1.44 //x2=57.21 //y2=1.595
r700 (  219 249 ) resistor r=45.1352 //w=0.168 //l=0.173853 //layer=ply \
 //thickness=0.18 //x=57.25 //y=1.095 //x2=57.21 //y2=0.94
r701 (  219 220 ) resistor r=176.904 //w=0.094 //l=0.345 //layer=ply \
 //thickness=0.18 //x=57.25 //y=1.095 //x2=57.25 //y2=1.44
r702 (  217 246 ) resistor r=10.701 //w=0.21 //l=0.115 //layer=ply \
 //thickness=0.18 //x=56.875 //y=1.595 //x2=56.76 //y2=1.595
r703 (  216 250 ) resistor r=5.52526 //w=0.168 //l=0.115 //layer=ply \
 //thickness=0.18 //x=57.095 //y=1.595 //x2=57.21 //y2=1.595
r704 (  215 245 ) resistor r=5.52526 //w=0.168 //l=0.115 //layer=ply \
 //thickness=0.18 //x=56.875 //y=0.94 //x2=56.76 //y2=0.94
r705 (  214 249 ) resistor r=5.52526 //w=0.168 //l=0.115 //layer=ply \
 //thickness=0.18 //x=57.095 //y=0.94 //x2=57.21 //y2=0.94
r706 (  214 215 ) resistor r=112.809 //w=0.094 //l=0.22 //layer=ply \
 //thickness=0.18 //x=57.095 //y=0.94 //x2=56.875 //y2=0.94
r707 (  211 248 ) resistor r=37.236 //w=0.233 //l=0.249199 //layer=ply \
 //thickness=0.18 //x=56.91 //y=5.045 //x2=56.73 //y2=4.88
r708 (  209 246 ) resistor r=39.5823 //w=0.21 //l=0.173853 //layer=ply \
 //thickness=0.18 //x=56.72 //y=1.75 //x2=56.76 //y2=1.595
r709 (  209 243 ) resistor r=176.904 //w=0.094 //l=0.345 //layer=ply \
 //thickness=0.18 //x=56.72 //y=1.75 //x2=56.72 //y2=2.095
r710 (  208 246 ) resistor r=39.5823 //w=0.21 //l=0.173853 //layer=ply \
 //thickness=0.18 //x=56.72 //y=1.44 //x2=56.76 //y2=1.595
r711 (  207 245 ) resistor r=45.1352 //w=0.168 //l=0.173853 //layer=ply \
 //thickness=0.18 //x=56.72 //y=1.095 //x2=56.76 //y2=0.94
r712 (  207 208 ) resistor r=176.904 //w=0.094 //l=0.345 //layer=ply \
 //thickness=0.18 //x=56.72 //y=1.095 //x2=56.72 //y2=1.44
r713 (  204 248 ) resistor r=53.7854 //w=0.233 //l=0.332415 //layer=ply \
 //thickness=0.18 //x=56.47 //y=5.045 //x2=56.73 //y2=4.88
r714 (  203 240 ) resistor r=45.1352 //w=0.168 //l=0.173853 //layer=ply \
 //thickness=0.18 //x=42.82 //y=1.44 //x2=42.78 //y2=1.595
r715 (  202 239 ) resistor r=45.1352 //w=0.168 //l=0.173853 //layer=ply \
 //thickness=0.18 //x=42.82 //y=1.095 //x2=42.78 //y2=0.94
r716 (  202 203 ) resistor r=176.904 //w=0.094 //l=0.345 //layer=ply \
 //thickness=0.18 //x=42.82 //y=1.095 //x2=42.82 //y2=1.44
r717 (  200 236 ) resistor r=10.701 //w=0.21 //l=0.115 //layer=ply \
 //thickness=0.18 //x=42.445 //y=1.595 //x2=42.33 //y2=1.595
r718 (  199 240 ) resistor r=5.52526 //w=0.168 //l=0.115 //layer=ply \
 //thickness=0.18 //x=42.665 //y=1.595 //x2=42.78 //y2=1.595
r719 (  198 235 ) resistor r=5.52526 //w=0.168 //l=0.115 //layer=ply \
 //thickness=0.18 //x=42.445 //y=0.94 //x2=42.33 //y2=0.94
r720 (  197 239 ) resistor r=5.52526 //w=0.168 //l=0.115 //layer=ply \
 //thickness=0.18 //x=42.665 //y=0.94 //x2=42.78 //y2=0.94
r721 (  197 198 ) resistor r=112.809 //w=0.094 //l=0.22 //layer=ply \
 //thickness=0.18 //x=42.665 //y=0.94 //x2=42.445 //y2=0.94
r722 (  194 238 ) resistor r=37.236 //w=0.233 //l=0.249199 //layer=ply \
 //thickness=0.18 //x=42.48 //y=5.045 //x2=42.3 //y2=4.88
r723 (  192 236 ) resistor r=39.5823 //w=0.21 //l=0.173853 //layer=ply \
 //thickness=0.18 //x=42.29 //y=1.75 //x2=42.33 //y2=1.595
r724 (  192 233 ) resistor r=176.904 //w=0.094 //l=0.345 //layer=ply \
 //thickness=0.18 //x=42.29 //y=1.75 //x2=42.29 //y2=2.095
r725 (  191 236 ) resistor r=39.5823 //w=0.21 //l=0.173853 //layer=ply \
 //thickness=0.18 //x=42.29 //y=1.44 //x2=42.33 //y2=1.595
r726 (  190 235 ) resistor r=45.1352 //w=0.168 //l=0.173853 //layer=ply \
 //thickness=0.18 //x=42.29 //y=1.095 //x2=42.33 //y2=0.94
r727 (  190 191 ) resistor r=176.904 //w=0.094 //l=0.345 //layer=ply \
 //thickness=0.18 //x=42.29 //y=1.095 //x2=42.29 //y2=1.44
r728 (  187 238 ) resistor r=53.7854 //w=0.233 //l=0.332415 //layer=ply \
 //thickness=0.18 //x=42.04 //y=5.045 //x2=42.3 //y2=4.88
r729 (  186 230 ) resistor r=45.1352 //w=0.168 //l=0.173853 //layer=ply \
 //thickness=0.18 //x=38.01 //y=1.44 //x2=37.97 //y2=1.595
r730 (  185 229 ) resistor r=45.1352 //w=0.168 //l=0.173853 //layer=ply \
 //thickness=0.18 //x=38.01 //y=1.095 //x2=37.97 //y2=0.94
r731 (  185 186 ) resistor r=176.904 //w=0.094 //l=0.345 //layer=ply \
 //thickness=0.18 //x=38.01 //y=1.095 //x2=38.01 //y2=1.44
r732 (  183 226 ) resistor r=10.701 //w=0.21 //l=0.115 //layer=ply \
 //thickness=0.18 //x=37.635 //y=1.595 //x2=37.52 //y2=1.595
r733 (  182 230 ) resistor r=5.52526 //w=0.168 //l=0.115 //layer=ply \
 //thickness=0.18 //x=37.855 //y=1.595 //x2=37.97 //y2=1.595
r734 (  181 225 ) resistor r=5.52526 //w=0.168 //l=0.115 //layer=ply \
 //thickness=0.18 //x=37.635 //y=0.94 //x2=37.52 //y2=0.94
r735 (  180 229 ) resistor r=5.52526 //w=0.168 //l=0.115 //layer=ply \
 //thickness=0.18 //x=37.855 //y=0.94 //x2=37.97 //y2=0.94
r736 (  180 181 ) resistor r=112.809 //w=0.094 //l=0.22 //layer=ply \
 //thickness=0.18 //x=37.855 //y=0.94 //x2=37.635 //y2=0.94
r737 (  177 228 ) resistor r=37.236 //w=0.233 //l=0.249199 //layer=ply \
 //thickness=0.18 //x=37.67 //y=5.045 //x2=37.49 //y2=4.88
r738 (  175 226 ) resistor r=39.5823 //w=0.21 //l=0.173853 //layer=ply \
 //thickness=0.18 //x=37.48 //y=1.75 //x2=37.52 //y2=1.595
r739 (  175 223 ) resistor r=176.904 //w=0.094 //l=0.345 //layer=ply \
 //thickness=0.18 //x=37.48 //y=1.75 //x2=37.48 //y2=2.095
r740 (  174 226 ) resistor r=39.5823 //w=0.21 //l=0.173853 //layer=ply \
 //thickness=0.18 //x=37.48 //y=1.44 //x2=37.52 //y2=1.595
r741 (  173 225 ) resistor r=45.1352 //w=0.168 //l=0.173853 //layer=ply \
 //thickness=0.18 //x=37.48 //y=1.095 //x2=37.52 //y2=0.94
r742 (  173 174 ) resistor r=176.904 //w=0.094 //l=0.345 //layer=ply \
 //thickness=0.18 //x=37.48 //y=1.095 //x2=37.48 //y2=1.44
r743 (  170 228 ) resistor r=53.7854 //w=0.233 //l=0.332415 //layer=ply \
 //thickness=0.18 //x=37.23 //y=5.045 //x2=37.49 //y2=4.88
r744 (  169 211 ) resistor r=592.245 //w=0.094 //l=1.155 //layer=ply \
 //thickness=0.18 //x=56.91 //y=6.2 //x2=56.91 //y2=5.045
r745 (  168 204 ) resistor r=592.245 //w=0.094 //l=1.155 //layer=ply \
 //thickness=0.18 //x=56.47 //y=6.2 //x2=56.47 //y2=5.045
r746 (  167 194 ) resistor r=592.245 //w=0.094 //l=1.155 //layer=ply \
 //thickness=0.18 //x=42.48 //y=6.2 //x2=42.48 //y2=5.045
r747 (  166 187 ) resistor r=592.245 //w=0.094 //l=1.155 //layer=ply \
 //thickness=0.18 //x=42.04 //y=6.2 //x2=42.04 //y2=5.045
r748 (  165 177 ) resistor r=592.245 //w=0.094 //l=1.155 //layer=ply \
 //thickness=0.18 //x=37.67 //y=6.2 //x2=37.67 //y2=5.045
r749 (  164 170 ) resistor r=592.245 //w=0.094 //l=1.155 //layer=ply \
 //thickness=0.18 //x=37.23 //y=6.2 //x2=37.23 //y2=5.045
r750 (  163 216 ) resistor r=56.4043 //w=0.094 //l=0.11 //layer=ply \
 //thickness=0.18 //x=56.985 //y=1.595 //x2=57.095 //y2=1.595
r751 (  163 217 ) resistor r=56.4043 //w=0.094 //l=0.11 //layer=ply \
 //thickness=0.18 //x=56.985 //y=1.595 //x2=56.875 //y2=1.595
r752 (  162 199 ) resistor r=56.4043 //w=0.094 //l=0.11 //layer=ply \
 //thickness=0.18 //x=42.555 //y=1.595 //x2=42.665 //y2=1.595
r753 (  162 200 ) resistor r=56.4043 //w=0.094 //l=0.11 //layer=ply \
 //thickness=0.18 //x=42.555 //y=1.595 //x2=42.445 //y2=1.595
r754 (  161 182 ) resistor r=56.4043 //w=0.094 //l=0.11 //layer=ply \
 //thickness=0.18 //x=37.745 //y=1.595 //x2=37.855 //y2=1.595
r755 (  161 183 ) resistor r=56.4043 //w=0.094 //l=0.11 //layer=ply \
 //thickness=0.18 //x=37.745 //y=1.595 //x2=37.635 //y2=1.595
r756 (  157 248 ) resistor r=152 //w=0.17 //l=0.17 //layer=licon //count=1 \
 //x=56.73 //y=4.88 //x2=56.73 //y2=4.88
r757 (  148 242 ) resistor r=152 //w=0.17 //l=0.17 //layer=licon //count=1 \
 //x=56.73 //y=2.26 //x2=56.73 //y2=2.26
r758 (  131 255 ) resistor r=23.615 //w=0.187 //l=0.345 //layer=li \
 //thickness=0.1 //x=47.07 //y=5.56 //x2=47.07 //y2=5.905
r759 (  123 254 ) resistor r=23.615 //w=0.187 //l=0.345 //layer=li \
 //thickness=0.1 //x=46.19 //y=5.56 //x2=46.19 //y2=5.905
r760 (  115 253 ) resistor r=23.615 //w=0.187 //l=0.345 //layer=li \
 //thickness=0.1 //x=45.31 //y=5.56 //x2=45.31 //y2=5.905
r761 (  110 238 ) resistor r=152 //w=0.17 //l=0.17 //layer=licon //count=1 \
 //x=42.3 //y=4.88 //x2=42.3 //y2=4.88
r762 (  101 232 ) resistor r=152 //w=0.17 //l=0.17 //layer=licon //count=1 \
 //x=42.3 //y=2.26 //x2=42.3 //y2=2.26
r763 (  96 228 ) resistor r=152 //w=0.17 //l=0.17 //layer=licon //count=1 \
 //x=37.49 //y=4.88 //x2=37.49 //y2=4.88
r764 (  87 222 ) resistor r=152 //w=0.17 //l=0.17 //layer=licon //count=1 \
 //x=37.49 //y=2.26 //x2=37.49 //y2=2.26
r765 (  79 81 ) resistor r=0.10734 //w=0.281 //l=0.16 //layer=m2 \
 //thickness=0.36 //x=42.3 //y=3.895 //x2=42.46 //y2=3.895
r766 (  79 80 ) resistor r=0.10734 //w=0.281 //l=0.16 //layer=m2 \
 //thickness=0.36 //x=42.3 //y=3.895 //x2=42.14 //y2=3.895
r767 (  77 80 ) resistor r=4.28435 //w=0.131 //l=4.49 //layer=m2 \
 //thickness=0.36 //x=37.65 //y=3.88 //x2=42.14 //y2=3.88
r768 (  75 77 ) resistor r=0.10734 //w=0.281 //l=0.16 //layer=m2 \
 //thickness=0.36 //x=37.49 //y=3.895 //x2=37.65 //y2=3.895
r769 (  73 83 ) resistor r=1.10266 //w=0.196 //l=1.725 //layer=m2 \
 //thickness=0.36 //x=49.565 //y=3.895 //x2=47.84 //y2=3.895
r770 (  72 85 ) resistor r=4.81638 //w=0.177 //l=6.825 //layer=m2 \
 //thickness=0.36 //x=49.91 //y=3.895 //x2=56.73 //y2=3.885
r771 (  72 73 ) resistor r=0.329198 //w=0.131 //l=0.345 //layer=m2 \
 //thickness=0.36 //x=49.91 //y=3.895 //x2=49.565 //y2=3.895
r772 (  70 83 ) resistor r=0.104578 //w=0.196 //l=0.167332 //layer=m2 \
 //thickness=0.36 //x=47.68 //y=3.88 //x2=47.84 //y2=3.895
r773 (  70 81 ) resistor r=4.98092 //w=0.131 //l=5.22 //layer=m2 \
 //thickness=0.36 //x=47.68 //y=3.88 //x2=42.46 //y2=3.88
r774 (  67 157 ) resistor r=9.3 //w=0.17 //l=0.17 //layer=mcon //count=1 \
 //x=56.73 //y=4.88 //x2=56.73 //y2=4.88
r775 (  65 148 ) resistor r=9.3 //w=0.17 //l=0.17 //layer=mcon //count=1 \
 //x=56.73 //y=2.26 //x2=56.73 //y2=2.26
r776 (  63 85 ) resistor r=4.5 //w=0.15 //l=0.15 //layer=via1 //count=1 \
 //x=56.73 //y=3.885 //x2=56.73 //y2=3.885
r777 (  61 63 ) resistor r=0.00166223 //w=0.376 //l=0.005 //layer=m1 \
 //thickness=0.36 //x=56.677 //y=3.88 //x2=56.677 //y2=3.885
r778 (  59 83 ) resistor r=4.5 //w=0.15 //l=0.15 //layer=via1 //count=1 \
 //x=47.84 //y=3.895 //x2=47.84 //y2=3.895
r779 (  57 59 ) resistor r=0.00490838 //w=0.382 //l=0.015 //layer=m1 \
 //thickness=0.36 //x=47.897 //y=3.88 //x2=47.897 //y2=3.895
r780 (  55 251 ) resistor r=9.3 //w=0.17 //l=0.17 //layer=mcon //count=1 \
 //x=47.365 //y=1.19 //x2=47.365 //y2=1.19
r781 (  53 131 ) resistor r=9.3 //w=0.17 //l=0.17 //layer=mcon //count=1 \
 //x=47.07 //y=5.56 //x2=47.07 //y2=5.56
r782 (  50 123 ) resistor r=9.3 //w=0.17 //l=0.17 //layer=mcon //count=1 \
 //x=46.19 //y=5.56 //x2=46.19 //y2=5.56
r783 (  48 50 ) resistor r=0.121228 //w=0.232 //l=0.225 //layer=m1 \
 //thickness=0.36 //x=46.19 //y=5.335 //x2=46.19 //y2=5.56
r784 (  47 115 ) resistor r=9.3 //w=0.17 //l=0.17 //layer=mcon //count=1 \
 //x=45.31 //y=5.56 //x2=45.31 //y2=5.56
r785 (  45 47 ) resistor r=0.129608 //w=0.217 //l=0.225 //layer=m1 \
 //thickness=0.36 //x=45.312 //y=5.335 //x2=45.312 //y2=5.56
r786 (  44 110 ) resistor r=9.3 //w=0.17 //l=0.17 //layer=mcon //count=1 \
 //x=42.3 //y=4.88 //x2=42.3 //y2=4.88
r787 (  42 101 ) resistor r=9.3 //w=0.17 //l=0.17 //layer=mcon //count=1 \
 //x=42.3 //y=2.26 //x2=42.3 //y2=2.26
r788 (  40 79 ) resistor r=4.5 //w=0.15 //l=0.15 //layer=via1 //count=1 \
 //x=42.3 //y=3.895 //x2=42.3 //y2=3.895
r789 (  38 40 ) resistor r=0.0049867 //w=0.376 //l=0.015 //layer=m1 \
 //thickness=0.36 //x=42.247 //y=3.88 //x2=42.247 //y2=3.895
r790 (  36 75 ) resistor r=4.5 //w=0.15 //l=0.15 //layer=via1 //count=1 \
 //x=37.49 //y=3.895 //x2=37.49 //y2=3.895
r791 (  34 36 ) resistor r=0.0049867 //w=0.376 //l=0.015 //layer=m1 \
 //thickness=0.36 //x=37.542 //y=3.88 //x2=37.542 //y2=3.895
r792 (  32 96 ) resistor r=9.3 //w=0.17 //l=0.17 //layer=mcon //count=1 \
 //x=37.49 //y=4.88 //x2=37.49 //y2=4.88
r793 (  30 87 ) resistor r=9.3 //w=0.17 //l=0.17 //layer=mcon //count=1 \
 //x=37.49 //y=2.26 //x2=37.49 //y2=2.26
r794 (  28 67 ) resistor r=0.0801089 //w=0.224 //l=0.13 //layer=m1 \
 //thickness=0.36 //x=56.73 //y=4.75 //x2=56.73 //y2=4.88
r795 (  27 63 ) resistor r=0.0911593 //w=0.376 //l=0.184608 //layer=m1 \
 //thickness=0.36 //x=56.73 //y=4.045 //x2=56.677 //y2=3.885
r796 (  27 28 ) resistor r=0.67271 //w=0.131 //l=0.705 //layer=m1 \
 //thickness=0.36 //x=56.73 //y=4.045 //x2=56.73 //y2=4.75
r797 (  26 61 ) resistor r=0.0894971 //w=0.376 //l=0.179555 //layer=m1 \
 //thickness=0.36 //x=56.73 //y=3.725 //x2=56.677 //y2=3.88
r798 (  25 65 ) resistor r=0.0719237 //w=0.222 //l=0.115 //layer=m1 \
 //thickness=0.36 //x=56.73 //y=2.375 //x2=56.73 //y2=2.26
r799 (  25 26 ) resistor r=1.28817 //w=0.131 //l=1.35 //layer=m1 \
 //thickness=0.36 //x=56.73 //y=2.375 //x2=56.73 //y2=3.725
r800 (  23 59 ) resistor r=0.0914072 //w=0.382 //l=0.181989 //layer=m1 \
 //thickness=0.36 //x=47.85 //y=4.055 //x2=47.897 //y2=3.895
r801 (  23 24 ) resistor r=1.14027 //w=0.131 //l=1.195 //layer=m1 \
 //thickness=0.36 //x=47.85 //y=4.055 //x2=47.85 //y2=5.25
r802 (  22 57 ) resistor r=0.0864989 //w=0.382 //l=0.166853 //layer=m1 \
 //thickness=0.36 //x=47.85 //y=3.735 //x2=47.897 //y2=3.88
r803 (  21 22 ) resistor r=1.72233 //w=0.131 //l=1.805 //layer=m1 \
 //thickness=0.36 //x=47.85 //y=1.93 //x2=47.85 //y2=3.735
r804 (  19 21 ) resistor r=0.0698411 //w=0.17 //l=0.120208 //layer=m1 \
 //thickness=0.36 //x=47.765 //y=1.845 //x2=47.85 //y2=1.93
r805 (  19 20 ) resistor r=0.300573 //w=0.131 //l=0.315 //layer=m1 \
 //thickness=0.36 //x=47.765 //y=1.845 //x2=47.45 //y2=1.845
r806 (  18 20 ) resistor r=0.0698411 //w=0.17 //l=0.120208 //layer=m1 \
 //thickness=0.36 //x=47.365 //y=1.76 //x2=47.45 //y2=1.845
r807 (  17 55 ) resistor r=0.0717383 //w=0.224 //l=0.115 //layer=m1 \
 //thickness=0.36 //x=47.365 //y=1.305 //x2=47.365 //y2=1.19
r808 (  17 18 ) resistor r=0.43416 //w=0.131 //l=0.455 //layer=m1 \
 //thickness=0.36 //x=47.365 //y=1.305 //x2=47.365 //y2=1.76
r809 (  16 51 ) resistor r=0.0675342 //w=0.23 //l=0.115 //layer=m1 \
 //thickness=0.36 //x=47.185 //y=5.335 //x2=47.07 //y2=5.335
r810 (  15 24 ) resistor r=0.0698411 //w=0.17 //l=0.120208 //layer=m1 \
 //thickness=0.36 //x=47.765 //y=5.335 //x2=47.85 //y2=5.25
r811 (  15 16 ) resistor r=0.553435 //w=0.131 //l=0.58 //layer=m1 \
 //thickness=0.36 //x=47.765 //y=5.335 //x2=47.185 //y2=5.335
r812 (  14 53 ) resistor r=0.00118313 //w=0.23 //layer=m1 //thickness=0.36 \
 //x=47.07 //y=5.56 //x2=47.07 //y2=5.56
r813 (  13 51 ) resistor r=0.002872 //w=0.34 //l=0.085 //layer=m1 \
 //thickness=0.36 //x=47.07 //y=5.42 //x2=47.07 //y2=5.335
r814 (  13 14 ) resistor r=0.091623 //w=0.191 //l=0.14 //layer=m1 \
 //thickness=0.36 //x=47.07 //y=5.42 //x2=47.07 //y2=5.56
r815 (  12 48 ) resistor r=0.0262263 //w=0.232 //l=0.12 //layer=m1 \
 //thickness=0.36 //x=46.31 //y=5.335 //x2=46.19 //y2=5.335
r816 (  11 51 ) resistor r=0.0675342 //w=0.23 //l=0.115 //layer=m1 \
 //thickness=0.36 //x=46.955 //y=5.335 //x2=47.07 //y2=5.335
r817 (  11 12 ) resistor r=0.615458 //w=0.131 //l=0.645 //layer=m1 \
 //thickness=0.36 //x=46.955 //y=5.335 //x2=46.31 //y2=5.335
r818 (  10 45 ) resistor r=0.0222262 //w=0.217 //l=0.118 //layer=m1 \
 //thickness=0.36 //x=45.43 //y=5.335 //x2=45.312 //y2=5.335
r819 (  9 48 ) resistor r=0.0262263 //w=0.232 //l=0.12 //layer=m1 \
 //thickness=0.36 //x=46.07 //y=5.335 //x2=46.19 //y2=5.335
r820 (  9 10 ) resistor r=0.610687 //w=0.131 //l=0.64 //layer=m1 \
 //thickness=0.36 //x=46.07 //y=5.335 //x2=45.43 //y2=5.335
r821 (  8 44 ) resistor r=0.0801089 //w=0.224 //l=0.13 //layer=m1 \
 //thickness=0.36 //x=42.3 //y=4.75 //x2=42.3 //y2=4.88
r822 (  7 40 ) resistor r=0.0911593 //w=0.376 //l=0.184608 //layer=m1 \
 //thickness=0.36 //x=42.3 //y=4.055 //x2=42.247 //y2=3.895
r823 (  7 8 ) resistor r=0.663168 //w=0.131 //l=0.695 //layer=m1 \
 //thickness=0.36 //x=42.3 //y=4.055 //x2=42.3 //y2=4.75
r824 (  6 38 ) resistor r=0.0861726 //w=0.376 //l=0.16944 //layer=m1 \
 //thickness=0.36 //x=42.3 //y=3.735 //x2=42.247 //y2=3.88
r825 (  5 42 ) resistor r=0.0719237 //w=0.222 //l=0.115 //layer=m1 \
 //thickness=0.36 //x=42.3 //y=2.375 //x2=42.3 //y2=2.26
r826 (  5 6 ) resistor r=1.29771 //w=0.131 //l=1.36 //layer=m1 \
 //thickness=0.36 //x=42.3 //y=2.375 //x2=42.3 //y2=3.735
r827 (  4 32 ) resistor r=0.0801089 //w=0.224 //l=0.13 //layer=m1 \
 //thickness=0.36 //x=37.49 //y=4.75 //x2=37.49 //y2=4.88
r828 (  3 36 ) resistor r=0.0911593 //w=0.376 //l=0.184174 //layer=m1 \
 //thickness=0.36 //x=37.49 //y=4.055 //x2=37.542 //y2=3.895
r829 (  3 4 ) resistor r=0.663168 //w=0.131 //l=0.695 //layer=m1 \
 //thickness=0.36 //x=37.49 //y=4.055 //x2=37.49 //y2=4.75
r830 (  2 34 ) resistor r=0.0861726 //w=0.376 //l=0.169012 //layer=m1 \
 //thickness=0.36 //x=37.49 //y=3.735 //x2=37.542 //y2=3.88
r831 (  1 30 ) resistor r=0.0719237 //w=0.222 //l=0.115 //layer=m1 \
 //thickness=0.36 //x=37.49 //y=2.375 //x2=37.49 //y2=2.26
r832 (  1 2 ) resistor r=1.29771 //w=0.131 //l=1.36 //layer=m1 \
 //thickness=0.36 //x=37.49 //y=2.375 //x2=37.49 //y2=3.735
ends PM_TMRDFFSNRNQNX1\%noxref_10

subckt PM_TMRDFFSNRNQNX1\%noxref_11 ( 1 2 3 4 5 7 10 11 13 14 15 16 18 19 20 \
 28 29 32 35 43 44 46 51 55 64 69 77 85 101 102 103 107 108 109 114 116 119 \
 120 122 123 128 131 133 134 135 )
c322 ( 131 0 ) capacitor c=0.00885916f //x=56.795 //y=1.095
c323 ( 128 0 ) capacitor c=0.0710579f //x=51.92 //y=4.88
c324 ( 123 0 ) capacitor c=0.0278202f //x=51.92 //y=2.095
c325 ( 122 0 ) capacitor c=0.0467713f //x=51.92 //y=2.26
c326 ( 120 0 ) capacitor c=0.0443175f //x=52.44 //y=1.44
c327 ( 119 0 ) capacitor c=0.0199703f //x=52.44 //y=1.095
c328 ( 116 0 ) capacitor c=0.0161662f //x=52.285 //y=1.595
c329 ( 114 0 ) capacitor c=0.0157807f //x=52.285 //y=0.94
c330 ( 109 0 ) capacitor c=0.0220935f //x=51.91 //y=1.75
c331 ( 108 0 ) capacitor c=0.0207489f //x=51.91 //y=1.44
c332 ( 107 0 ) capacitor c=0.0194091f //x=51.91 //y=1.095
c333 ( 103 0 ) capacitor c=0.159671f //x=52.1 //y=6.2
c334 ( 102 0 ) capacitor c=0.110208f //x=51.66 //y=6.2
c335 ( 85 0 ) capacitor c=0.0293719f //x=56.69 //y=5.56
c336 ( 77 0 ) capacitor c=0.0292879f //x=55.81 //y=5.56
c337 ( 69 0 ) capacitor c=0.0278099f //x=54.93 //y=5.56
c338 ( 64 0 ) capacitor c=9.5006e-19 //x=51.92 //y=4.88
c339 ( 55 0 ) capacitor c=7.43216e-19 //x=51.92 //y=2.26
c340 ( 51 0 ) capacitor c=7.87194e-19 //x=52.075 //y=2.755
c341 ( 46 0 ) capacitor c=0.0151289f //x=55.835 //y=2.76
c342 ( 44 0 ) capacitor c=0.0297896f //x=55.235 //y=2.77
c343 ( 43 0 ) capacitor c=0.0144376f //x=57.47 //y=2.77
c344 ( 35 0 ) capacitor c=8.42472e-19 //x=56.69 //y=5.335
c345 ( 32 0 ) capacitor c=0.00753514f //x=55.81 //y=5.335
c346 ( 29 0 ) capacitor c=0.0109203f //x=54.932 //y=5.335
c347 ( 28 0 ) capacitor c=0.0151653f //x=51.92 //y=2.77
c348 ( 20 0 ) capacitor c=0.0617628f //x=57.47 //y=5.25
c349 ( 19 0 ) capacitor c=0.0128917f //x=57.47 //y=2.915
c350 ( 18 0 ) capacitor c=0.0177867f //x=57.47 //y=2.595
c351 ( 16 0 ) capacitor c=0.00493487f //x=57.07 //y=1.845
c352 ( 15 0 ) capacitor c=0.0125086f //x=57.385 //y=1.845
c353 ( 14 0 ) capacitor c=0.0167992f //x=56.985 //y=1.76
c354 ( 13 0 ) capacitor c=0.0112869f //x=56.985 //y=1.305
c355 ( 11 0 ) capacitor c=0.0212955f //x=57.385 //y=5.335
c356 ( 10 0 ) capacitor c=0.00933983f //x=56.69 //y=5.56
c357 ( 7 0 ) capacitor c=0.0177111f //x=56.575 //y=5.335
c358 ( 5 0 ) capacitor c=0.0143796f //x=55.69 //y=5.335
c359 ( 4 0 ) capacitor c=0.0465159f //x=51.92 //y=4.75
c360 ( 3 0 ) capacitor c=0.0124253f //x=51.92 //y=2.915
c361 ( 2 0 ) capacitor c=0.00283249f //x=51.92 //y=2.595
c362 ( 1 0 ) capacitor c=0.00514953f //x=51.92 //y=2.375
r363 (  122 123 ) resistor r=52.7279 //w=0.214 //l=0.165 //layer=ply \
 //thickness=0.18 //x=51.92 //y=2.26 //x2=51.92 //y2=2.095
r364 (  120 130 ) resistor r=45.1352 //w=0.168 //l=0.173853 //layer=ply \
 //thickness=0.18 //x=52.44 //y=1.44 //x2=52.4 //y2=1.595
r365 (  119 129 ) resistor r=45.1352 //w=0.168 //l=0.173853 //layer=ply \
 //thickness=0.18 //x=52.44 //y=1.095 //x2=52.4 //y2=0.94
r366 (  119 120 ) resistor r=176.904 //w=0.094 //l=0.345 //layer=ply \
 //thickness=0.18 //x=52.44 //y=1.095 //x2=52.44 //y2=1.44
r367 (  117 126 ) resistor r=10.701 //w=0.21 //l=0.115 //layer=ply \
 //thickness=0.18 //x=52.065 //y=1.595 //x2=51.95 //y2=1.595
r368 (  116 130 ) resistor r=5.52526 //w=0.168 //l=0.115 //layer=ply \
 //thickness=0.18 //x=52.285 //y=1.595 //x2=52.4 //y2=1.595
r369 (  115 125 ) resistor r=5.52526 //w=0.168 //l=0.115 //layer=ply \
 //thickness=0.18 //x=52.065 //y=0.94 //x2=51.95 //y2=0.94
r370 (  114 129 ) resistor r=5.52526 //w=0.168 //l=0.115 //layer=ply \
 //thickness=0.18 //x=52.285 //y=0.94 //x2=52.4 //y2=0.94
r371 (  114 115 ) resistor r=112.809 //w=0.094 //l=0.22 //layer=ply \
 //thickness=0.18 //x=52.285 //y=0.94 //x2=52.065 //y2=0.94
r372 (  111 128 ) resistor r=37.236 //w=0.233 //l=0.249199 //layer=ply \
 //thickness=0.18 //x=52.1 //y=5.045 //x2=51.92 //y2=4.88
r373 (  109 126 ) resistor r=39.5823 //w=0.21 //l=0.173853 //layer=ply \
 //thickness=0.18 //x=51.91 //y=1.75 //x2=51.95 //y2=1.595
r374 (  109 123 ) resistor r=176.904 //w=0.094 //l=0.345 //layer=ply \
 //thickness=0.18 //x=51.91 //y=1.75 //x2=51.91 //y2=2.095
r375 (  108 126 ) resistor r=39.5823 //w=0.21 //l=0.173853 //layer=ply \
 //thickness=0.18 //x=51.91 //y=1.44 //x2=51.95 //y2=1.595
r376 (  107 125 ) resistor r=45.1352 //w=0.168 //l=0.173853 //layer=ply \
 //thickness=0.18 //x=51.91 //y=1.095 //x2=51.95 //y2=0.94
r377 (  107 108 ) resistor r=176.904 //w=0.094 //l=0.345 //layer=ply \
 //thickness=0.18 //x=51.91 //y=1.095 //x2=51.91 //y2=1.44
r378 (  104 128 ) resistor r=53.7854 //w=0.233 //l=0.332415 //layer=ply \
 //thickness=0.18 //x=51.66 //y=5.045 //x2=51.92 //y2=4.88
r379 (  103 111 ) resistor r=592.245 //w=0.094 //l=1.155 //layer=ply \
 //thickness=0.18 //x=52.1 //y=6.2 //x2=52.1 //y2=5.045
r380 (  102 104 ) resistor r=592.245 //w=0.094 //l=1.155 //layer=ply \
 //thickness=0.18 //x=51.66 //y=6.2 //x2=51.66 //y2=5.045
r381 (  101 116 ) resistor r=56.4043 //w=0.094 //l=0.11 //layer=ply \
 //thickness=0.18 //x=52.175 //y=1.595 //x2=52.285 //y2=1.595
r382 (  101 117 ) resistor r=56.4043 //w=0.094 //l=0.11 //layer=ply \
 //thickness=0.18 //x=52.175 //y=1.595 //x2=52.065 //y2=1.595
r383 (  85 135 ) resistor r=23.615 //w=0.187 //l=0.345 //layer=li \
 //thickness=0.1 //x=56.69 //y=5.56 //x2=56.69 //y2=5.905
r384 (  77 134 ) resistor r=23.615 //w=0.187 //l=0.345 //layer=li \
 //thickness=0.1 //x=55.81 //y=5.56 //x2=55.81 //y2=5.905
r385 (  69 133 ) resistor r=23.615 //w=0.187 //l=0.345 //layer=li \
 //thickness=0.1 //x=54.93 //y=5.56 //x2=54.93 //y2=5.905
r386 (  64 128 ) resistor r=152 //w=0.17 //l=0.17 //layer=licon //count=1 \
 //x=51.92 //y=4.88 //x2=51.92 //y2=4.88
r387 (  55 122 ) resistor r=152 //w=0.17 //l=0.17 //layer=licon //count=1 \
 //x=51.92 //y=2.26 //x2=51.92 //y2=2.26
r388 (  49 51 ) resistor r=0.10734 //w=0.281 //l=0.16 //layer=m2 \
 //thickness=0.36 //x=51.915 //y=2.755 //x2=52.075 //y2=2.755
r389 (  46 53 ) resistor r=1.04013 //w=0.197 //l=1.6375 //layer=m2 \
 //thickness=0.36 //x=55.835 //y=2.76 //x2=57.47 //y2=2.755
r390 (  46 47 ) resistor r=0.410305 //w=0.131 //l=0.43 //layer=m2 \
 //thickness=0.36 //x=55.835 //y=2.76 //x2=55.405 //y2=2.76
r391 (  44 47 ) resistor r=0.125 //w=0.17 //l=0.174929 //layer=m2 \
 //thickness=0.36 //x=55.235 //y=2.77 //x2=55.405 //y2=2.76
r392 (  44 51 ) resistor r=3.01527 //w=0.131 //l=3.16 //layer=m2 \
 //thickness=0.36 //x=55.235 //y=2.77 //x2=52.075 //y2=2.77
r393 (  41 53 ) resistor r=4.5 //w=0.15 //l=0.15 //layer=via1 //count=1 \
 //x=57.47 //y=2.755 //x2=57.47 //y2=2.755
r394 (  41 43 ) resistor r=0.0049867 //w=0.376 //l=0.015 //layer=m1 \
 //thickness=0.36 //x=57.417 //y=2.755 //x2=57.417 //y2=2.77
r395 (  39 131 ) resistor r=9.3 //w=0.17 //l=0.17 //layer=mcon //count=1 \
 //x=56.985 //y=1.19 //x2=56.985 //y2=1.19
r396 (  37 85 ) resistor r=9.3 //w=0.17 //l=0.17 //layer=mcon //count=1 \
 //x=56.69 //y=5.56 //x2=56.69 //y2=5.56
r397 (  34 77 ) resistor r=9.3 //w=0.17 //l=0.17 //layer=mcon //count=1 \
 //x=55.81 //y=5.56 //x2=55.81 //y2=5.56
r398 (  32 34 ) resistor r=0.121228 //w=0.232 //l=0.225 //layer=m1 \
 //thickness=0.36 //x=55.81 //y=5.335 //x2=55.81 //y2=5.56
r399 (  31 69 ) resistor r=9.3 //w=0.17 //l=0.17 //layer=mcon //count=1 \
 //x=54.93 //y=5.56 //x2=54.93 //y2=5.56
r400 (  29 31 ) resistor r=0.129608 //w=0.217 //l=0.225 //layer=m1 \
 //thickness=0.36 //x=54.932 //y=5.335 //x2=54.932 //y2=5.56
r401 (  26 49 ) resistor r=4.5 //w=0.15 //l=0.15 //layer=via1 //count=1 \
 //x=51.915 //y=2.755 //x2=51.915 //y2=2.755
r402 (  26 28 ) resistor r=0.00494723 //w=0.379 //l=0.015 //layer=m1 \
 //thickness=0.36 //x=51.97 //y=2.755 //x2=51.97 //y2=2.77
r403 (  24 64 ) resistor r=9.3 //w=0.17 //l=0.17 //layer=mcon //count=1 \
 //x=51.92 //y=4.88 //x2=51.92 //y2=4.88
r404 (  22 55 ) resistor r=9.3 //w=0.17 //l=0.17 //layer=mcon //count=1 \
 //x=51.92 //y=2.26 //x2=51.92 //y2=2.26
r405 (  19 43 ) resistor r=0.0861726 //w=0.376 //l=0.16944 //layer=m1 \
 //thickness=0.36 //x=57.47 //y=2.915 //x2=57.417 //y2=2.77
r406 (  19 20 ) resistor r=2.22805 //w=0.131 //l=2.335 //layer=m1 \
 //thickness=0.36 //x=57.47 //y=2.915 //x2=57.47 //y2=5.25
r407 (  18 41 ) resistor r=0.0911593 //w=0.376 //l=0.184608 //layer=m1 \
 //thickness=0.36 //x=57.47 //y=2.595 //x2=57.417 //y2=2.755
r408 (  17 18 ) resistor r=0.634542 //w=0.131 //l=0.665 //layer=m1 \
 //thickness=0.36 //x=57.47 //y=1.93 //x2=57.47 //y2=2.595
r409 (  15 17 ) resistor r=0.0698411 //w=0.17 //l=0.120208 //layer=m1 \
 //thickness=0.36 //x=57.385 //y=1.845 //x2=57.47 //y2=1.93
r410 (  15 16 ) resistor r=0.300573 //w=0.131 //l=0.315 //layer=m1 \
 //thickness=0.36 //x=57.385 //y=1.845 //x2=57.07 //y2=1.845
r411 (  14 16 ) resistor r=0.0698411 //w=0.17 //l=0.120208 //layer=m1 \
 //thickness=0.36 //x=56.985 //y=1.76 //x2=57.07 //y2=1.845
r412 (  13 39 ) resistor r=0.0717383 //w=0.224 //l=0.115 //layer=m1 \
 //thickness=0.36 //x=56.985 //y=1.305 //x2=56.985 //y2=1.19
r413 (  13 14 ) resistor r=0.43416 //w=0.131 //l=0.455 //layer=m1 \
 //thickness=0.36 //x=56.985 //y=1.305 //x2=56.985 //y2=1.76
r414 (  12 35 ) resistor r=0.0675342 //w=0.23 //l=0.115 //layer=m1 \
 //thickness=0.36 //x=56.805 //y=5.335 //x2=56.69 //y2=5.335
r415 (  11 20 ) resistor r=0.0698411 //w=0.17 //l=0.120208 //layer=m1 \
 //thickness=0.36 //x=57.385 //y=5.335 //x2=57.47 //y2=5.25
r416 (  11 12 ) resistor r=0.553435 //w=0.131 //l=0.58 //layer=m1 \
 //thickness=0.36 //x=57.385 //y=5.335 //x2=56.805 //y2=5.335
r417 (  10 37 ) resistor r=0.00118313 //w=0.23 //layer=m1 //thickness=0.36 \
 //x=56.69 //y=5.56 //x2=56.69 //y2=5.56
r418 (  9 35 ) resistor r=0.002872 //w=0.34 //l=0.085 //layer=m1 \
 //thickness=0.36 //x=56.69 //y=5.42 //x2=56.69 //y2=5.335
r419 (  9 10 ) resistor r=0.091623 //w=0.191 //l=0.14 //layer=m1 \
 //thickness=0.36 //x=56.69 //y=5.42 //x2=56.69 //y2=5.56
r420 (  8 32 ) resistor r=0.0262263 //w=0.232 //l=0.12 //layer=m1 \
 //thickness=0.36 //x=55.93 //y=5.335 //x2=55.81 //y2=5.335
r421 (  7 35 ) resistor r=0.0675342 //w=0.23 //l=0.115 //layer=m1 \
 //thickness=0.36 //x=56.575 //y=5.335 //x2=56.69 //y2=5.335
r422 (  7 8 ) resistor r=0.615458 //w=0.131 //l=0.645 //layer=m1 \
 //thickness=0.36 //x=56.575 //y=5.335 //x2=55.93 //y2=5.335
r423 (  6 29 ) resistor r=0.0222262 //w=0.217 //l=0.118 //layer=m1 \
 //thickness=0.36 //x=55.05 //y=5.335 //x2=54.932 //y2=5.335
r424 (  5 32 ) resistor r=0.0262263 //w=0.232 //l=0.12 //layer=m1 \
 //thickness=0.36 //x=55.69 //y=5.335 //x2=55.81 //y2=5.335
r425 (  5 6 ) resistor r=0.610687 //w=0.131 //l=0.64 //layer=m1 \
 //thickness=0.36 //x=55.69 //y=5.335 //x2=55.05 //y2=5.335
r426 (  4 24 ) resistor r=0.0801089 //w=0.224 //l=0.13 //layer=m1 \
 //thickness=0.36 //x=51.92 //y=4.75 //x2=51.92 //y2=4.88
r427 (  3 28 ) resistor r=0.0863342 //w=0.379 //l=0.168152 //layer=m1 \
 //thickness=0.36 //x=51.92 //y=2.915 //x2=51.97 //y2=2.77
r428 (  3 4 ) resistor r=1.75095 //w=0.131 //l=1.835 //layer=m1 \
 //thickness=0.36 //x=51.92 //y=2.915 //x2=51.92 //y2=4.75
r429 (  2 26 ) resistor r=0.0912814 //w=0.379 //l=0.183303 //layer=m1 \
 //thickness=0.36 //x=51.92 //y=2.595 //x2=51.97 //y2=2.755
r430 (  1 22 ) resistor r=0.0719237 //w=0.222 //l=0.115 //layer=m1 \
 //thickness=0.36 //x=51.92 //y=2.375 //x2=51.92 //y2=2.26
r431 (  1 2 ) resistor r=0.209924 //w=0.131 //l=0.22 //layer=m1 \
 //thickness=0.36 //x=51.92 //y=2.375 //x2=51.92 //y2=2.595
ends PM_TMRDFFSNRNQNX1\%noxref_11

subckt PM_TMRDFFSNRNQNX1\%D ( 1 2 3 4 5 6 7 8 9 10 11 12 13 14 15 22 23 25 30 \
 31 32 36 37 62 64 66 68 70 72 74 76 77 78 80 82 84 86 91 97 106 111 120 125 \
 134 138 139 140 141 142 143 144 145 146 147 148 149 150 151 153 159 160 161 \
 162 166 167 168 169 170 172 178 179 180 181 185 186 187 188 189 191 197 198 \
 199 200 )
c556 ( 200 0 ) capacitor c=0.0573033f //x=59.595 //y=4.97
c557 ( 199 0 ) capacitor c=0.0376642f //x=59.885 //y=4.97
c558 ( 198 0 ) capacitor c=0.0346489f //x=59.55 //y=1.4
c559 ( 197 0 ) capacitor c=0.018692f //x=59.55 //y=1.055
c560 ( 191 0 ) capacitor c=0.0137077f //x=59.395 //y=1.555
c561 ( 189 0 ) capacitor c=0.0158585f //x=59.395 //y=0.9
c562 ( 188 0 ) capacitor c=0.103534f //x=59.02 //y=2.095
c563 ( 187 0 ) capacitor c=0.0229444f //x=59.02 //y=1.71
c564 ( 186 0 ) capacitor c=0.0234359f //x=59.02 //y=1.4
c565 ( 185 0 ) capacitor c=0.019815f //x=59.02 //y=1.055
c566 ( 181 0 ) capacitor c=0.0553409f //x=30.735 //y=4.97
c567 ( 180 0 ) capacitor c=0.0376642f //x=31.025 //y=4.97
c568 ( 179 0 ) capacitor c=0.0346489f //x=30.69 //y=1.4
c569 ( 178 0 ) capacitor c=0.018692f //x=30.69 //y=1.055
c570 ( 172 0 ) capacitor c=0.0137077f //x=30.535 //y=1.555
c571 ( 170 0 ) capacitor c=0.0158585f //x=30.535 //y=0.9
c572 ( 169 0 ) capacitor c=0.103534f //x=30.16 //y=2.095
c573 ( 168 0 ) capacitor c=0.0229444f //x=30.16 //y=1.71
c574 ( 167 0 ) capacitor c=0.0234359f //x=30.16 //y=1.4
c575 ( 166 0 ) capacitor c=0.019815f //x=30.16 //y=1.055
c576 ( 162 0 ) capacitor c=0.0571086f //x=1.875 //y=4.97
c577 ( 161 0 ) capacitor c=0.0376642f //x=2.165 //y=4.97
c578 ( 160 0 ) capacitor c=0.0346489f //x=1.83 //y=1.4
c579 ( 159 0 ) capacitor c=0.018692f //x=1.83 //y=1.055
c580 ( 153 0 ) capacitor c=0.0137077f //x=1.675 //y=1.555
c581 ( 151 0 ) capacitor c=0.0158585f //x=1.675 //y=0.9
c582 ( 150 0 ) capacitor c=0.103534f //x=1.3 //y=2.095
c583 ( 149 0 ) capacitor c=0.0229444f //x=1.3 //y=1.71
c584 ( 148 0 ) capacitor c=0.0234359f //x=1.3 //y=1.4
c585 ( 147 0 ) capacitor c=0.019815f //x=1.3 //y=1.055
c586 ( 146 0 ) capacitor c=0.110208f //x=59.96 //y=6.2
c587 ( 145 0 ) capacitor c=0.158957f //x=59.52 //y=6.2
c588 ( 144 0 ) capacitor c=0.110208f //x=31.1 //y=6.2
c589 ( 143 0 ) capacitor c=0.158957f //x=30.66 //y=6.2
c590 ( 142 0 ) capacitor c=0.110208f //x=2.24 //y=6.2
c591 ( 141 0 ) capacitor c=0.158957f //x=1.8 //y=6.2
c592 ( 134 0 ) capacitor c=0.00132168f //x=59.32 //y=4.88
c593 ( 125 0 ) capacitor c=0.0012618f //x=59.32 //y=2.26
c594 ( 120 0 ) capacitor c=0.00132168f //x=30.46 //y=4.88
c595 ( 111 0 ) capacitor c=0.0012618f //x=30.46 //y=2.26
c596 ( 106 0 ) capacitor c=0.00120653f //x=1.6 //y=4.88
c597 ( 97 0 ) capacitor c=0.0012618f //x=1.6 //y=2.26
c598 ( 91 0 ) capacitor c=0.0118755f //x=1.76 //y=4.255
c599 ( 86 0 ) capacitor c=0.0264356f //x=56.945 //y=4.27
c600 ( 84 0 ) capacitor c=0.0802451f //x=56.345 //y=4.25
c601 ( 82 0 ) capacitor c=0.00430603f //x=48.055 //y=4.28
c602 ( 80 0 ) capacitor c=0.048042f //x=47.455 //y=4.25
c603 ( 78 0 ) capacitor c=0.00409034f //x=42.52 //y=4.31
c604 ( 77 0 ) capacitor c=0.115399f //x=37.36 //y=4.28
c605 ( 76 0 ) capacitor c=0.0450017f //x=37.71 //y=4.28
c606 ( 74 0 ) capacitor c=0.00130957f //x=28.09 //y=4.27
c607 ( 72 0 ) capacitor c=0.0806645f //x=27.485 //y=4.25
c608 ( 70 0 ) capacitor c=0.00430603f //x=19.195 //y=4.28
c609 ( 68 0 ) capacitor c=0.0486924f //x=18.595 //y=4.25
c610 ( 66 0 ) capacitor c=0.00434239f //x=13.655 //y=4.31
c611 ( 64 0 ) capacitor c=0.045907f //x=8.845 //y=4.28
c612 ( 62 0 ) capacitor c=0.182353f //x=8.245 //y=4.25
c613 ( 37 0 ) capacitor c=0.0116931f //x=59.32 //y=4.755
c614 ( 36 0 ) capacitor c=0.0126596f //x=59.32 //y=4.395
c615 ( 32 0 ) capacitor c=0.00493485f //x=59.32 //y=2.375
c616 ( 31 0 ) capacitor c=0.0116931f //x=30.46 //y=4.755
c617 ( 30 0 ) capacitor c=0.0126796f //x=30.46 //y=4.395
c618 ( 25 0 ) capacitor c=0.00493485f //x=30.46 //y=2.375
c619 ( 23 0 ) capacitor c=0.010934f //x=1.6 //y=4.755
c620 ( 22 0 ) capacitor c=0.0204514f //x=1.6 //y=4.415
c621 ( 15 0 ) capacitor c=0.0113082f //x=1.6 //y=2.375
c622 ( 14 0 ) capacitor c=0.0148084f //x=59.32 //y=4.25
c623 ( 13 0 ) capacitor c=0.0148084f //x=30.46 //y=4.25
c624 ( 12 0 ) capacitor c=0.0158298f //x=1.6 //y=4.25
c625 ( 10 0 ) capacitor c=0.0495713f //x=59.32 //y=2.77
c626 ( 7 0 ) capacitor c=0.0516076f //x=30.46 //y=2.77
c627 ( 6 0 ) capacitor c=0.0130702f //x=1.6 //y=4.62
c628 ( 1 0 ) capacitor c=0.0853296f //x=1.6 //y=2.4
r629 (  199 201 ) resistor r=26.9307 //w=0.15 //l=0.106066 //layer=ply \
 //thickness=0.18 //x=59.885 //y=4.97 //x2=59.96 //y2=5.045
r630 (  199 200 ) resistor r=148.702 //w=0.094 //l=0.29 //layer=ply \
 //thickness=0.18 //x=59.885 //y=4.97 //x2=59.595 //y2=4.97
r631 (  198 227 ) resistor r=45.1352 //w=0.168 //l=0.173853 //layer=ply \
 //thickness=0.18 //x=59.55 //y=1.4 //x2=59.51 //y2=1.555
r632 (  197 226 ) resistor r=45.1352 //w=0.168 //l=0.173853 //layer=ply \
 //thickness=0.18 //x=59.55 //y=1.055 //x2=59.51 //y2=0.9
r633 (  197 198 ) resistor r=176.904 //w=0.094 //l=0.345 //layer=ply \
 //thickness=0.18 //x=59.55 //y=1.055 //x2=59.55 //y2=1.4
r634 (  194 200 ) resistor r=22.7971 //w=0.269 //l=0.106066 //layer=ply \
 //thickness=0.18 //x=59.52 //y=5.045 //x2=59.595 //y2=4.97
r635 (  194 225 ) resistor r=35.8364 //w=0.269 //l=0.270185 //layer=ply \
 //thickness=0.18 //x=59.52 //y=5.045 //x2=59.32 //y2=4.88
r636 (  192 221 ) resistor r=10.701 //w=0.21 //l=0.115 //layer=ply \
 //thickness=0.18 //x=59.175 //y=1.555 //x2=59.06 //y2=1.555
r637 (  191 227 ) resistor r=5.52526 //w=0.168 //l=0.115 //layer=ply \
 //thickness=0.18 //x=59.395 //y=1.555 //x2=59.51 //y2=1.555
r638 (  190 220 ) resistor r=5.52526 //w=0.168 //l=0.115 //layer=ply \
 //thickness=0.18 //x=59.175 //y=0.9 //x2=59.06 //y2=0.9
r639 (  189 226 ) resistor r=5.52526 //w=0.168 //l=0.115 //layer=ply \
 //thickness=0.18 //x=59.395 //y=0.9 //x2=59.51 //y2=0.9
r640 (  189 190 ) resistor r=112.809 //w=0.094 //l=0.22 //layer=ply \
 //thickness=0.18 //x=59.395 //y=0.9 //x2=59.175 //y2=0.9
r641 (  188 223 ) resistor r=58.7805 //w=0.246 //l=0.373497 //layer=ply \
 //thickness=0.18 //x=59.02 //y=2.095 //x2=59.32 //y2=2.26
r642 (  187 221 ) resistor r=39.5823 //w=0.21 //l=0.173853 //layer=ply \
 //thickness=0.18 //x=59.02 //y=1.71 //x2=59.06 //y2=1.555
r643 (  187 188 ) resistor r=197.415 //w=0.094 //l=0.385 //layer=ply \
 //thickness=0.18 //x=59.02 //y=1.71 //x2=59.02 //y2=2.095
r644 (  186 221 ) resistor r=39.5823 //w=0.21 //l=0.173853 //layer=ply \
 //thickness=0.18 //x=59.02 //y=1.4 //x2=59.06 //y2=1.555
r645 (  185 220 ) resistor r=45.1352 //w=0.168 //l=0.173853 //layer=ply \
 //thickness=0.18 //x=59.02 //y=1.055 //x2=59.06 //y2=0.9
r646 (  185 186 ) resistor r=176.904 //w=0.094 //l=0.345 //layer=ply \
 //thickness=0.18 //x=59.02 //y=1.055 //x2=59.02 //y2=1.4
r647 (  180 182 ) resistor r=26.9307 //w=0.15 //l=0.106066 //layer=ply \
 //thickness=0.18 //x=31.025 //y=4.97 //x2=31.1 //y2=5.045
r648 (  180 181 ) resistor r=148.702 //w=0.094 //l=0.29 //layer=ply \
 //thickness=0.18 //x=31.025 //y=4.97 //x2=30.735 //y2=4.97
r649 (  179 219 ) resistor r=45.1352 //w=0.168 //l=0.173853 //layer=ply \
 //thickness=0.18 //x=30.69 //y=1.4 //x2=30.65 //y2=1.555
r650 (  178 218 ) resistor r=45.1352 //w=0.168 //l=0.173853 //layer=ply \
 //thickness=0.18 //x=30.69 //y=1.055 //x2=30.65 //y2=0.9
r651 (  178 179 ) resistor r=176.904 //w=0.094 //l=0.345 //layer=ply \
 //thickness=0.18 //x=30.69 //y=1.055 //x2=30.69 //y2=1.4
r652 (  175 181 ) resistor r=22.7971 //w=0.269 //l=0.106066 //layer=ply \
 //thickness=0.18 //x=30.66 //y=5.045 //x2=30.735 //y2=4.97
r653 (  175 217 ) resistor r=35.8364 //w=0.269 //l=0.270185 //layer=ply \
 //thickness=0.18 //x=30.66 //y=5.045 //x2=30.46 //y2=4.88
r654 (  173 213 ) resistor r=10.701 //w=0.21 //l=0.115 //layer=ply \
 //thickness=0.18 //x=30.315 //y=1.555 //x2=30.2 //y2=1.555
r655 (  172 219 ) resistor r=5.52526 //w=0.168 //l=0.115 //layer=ply \
 //thickness=0.18 //x=30.535 //y=1.555 //x2=30.65 //y2=1.555
r656 (  171 212 ) resistor r=5.52526 //w=0.168 //l=0.115 //layer=ply \
 //thickness=0.18 //x=30.315 //y=0.9 //x2=30.2 //y2=0.9
r657 (  170 218 ) resistor r=5.52526 //w=0.168 //l=0.115 //layer=ply \
 //thickness=0.18 //x=30.535 //y=0.9 //x2=30.65 //y2=0.9
r658 (  170 171 ) resistor r=112.809 //w=0.094 //l=0.22 //layer=ply \
 //thickness=0.18 //x=30.535 //y=0.9 //x2=30.315 //y2=0.9
r659 (  169 215 ) resistor r=58.7805 //w=0.246 //l=0.373497 //layer=ply \
 //thickness=0.18 //x=30.16 //y=2.095 //x2=30.46 //y2=2.26
r660 (  168 213 ) resistor r=39.5823 //w=0.21 //l=0.173853 //layer=ply \
 //thickness=0.18 //x=30.16 //y=1.71 //x2=30.2 //y2=1.555
r661 (  168 169 ) resistor r=197.415 //w=0.094 //l=0.385 //layer=ply \
 //thickness=0.18 //x=30.16 //y=1.71 //x2=30.16 //y2=2.095
r662 (  167 213 ) resistor r=39.5823 //w=0.21 //l=0.173853 //layer=ply \
 //thickness=0.18 //x=30.16 //y=1.4 //x2=30.2 //y2=1.555
r663 (  166 212 ) resistor r=45.1352 //w=0.168 //l=0.173853 //layer=ply \
 //thickness=0.18 //x=30.16 //y=1.055 //x2=30.2 //y2=0.9
r664 (  166 167 ) resistor r=176.904 //w=0.094 //l=0.345 //layer=ply \
 //thickness=0.18 //x=30.16 //y=1.055 //x2=30.16 //y2=1.4
r665 (  161 163 ) resistor r=26.9307 //w=0.15 //l=0.106066 //layer=ply \
 //thickness=0.18 //x=2.165 //y=4.97 //x2=2.24 //y2=5.045
r666 (  161 162 ) resistor r=148.702 //w=0.094 //l=0.29 //layer=ply \
 //thickness=0.18 //x=2.165 //y=4.97 //x2=1.875 //y2=4.97
r667 (  160 211 ) resistor r=45.1352 //w=0.168 //l=0.173853 //layer=ply \
 //thickness=0.18 //x=1.83 //y=1.4 //x2=1.79 //y2=1.555
r668 (  159 210 ) resistor r=45.1352 //w=0.168 //l=0.173853 //layer=ply \
 //thickness=0.18 //x=1.83 //y=1.055 //x2=1.79 //y2=0.9
r669 (  159 160 ) resistor r=176.904 //w=0.094 //l=0.345 //layer=ply \
 //thickness=0.18 //x=1.83 //y=1.055 //x2=1.83 //y2=1.4
r670 (  156 162 ) resistor r=22.7971 //w=0.269 //l=0.106066 //layer=ply \
 //thickness=0.18 //x=1.8 //y=5.045 //x2=1.875 //y2=4.97
r671 (  156 209 ) resistor r=35.8364 //w=0.269 //l=0.270185 //layer=ply \
 //thickness=0.18 //x=1.8 //y=5.045 //x2=1.6 //y2=4.88
r672 (  154 205 ) resistor r=10.701 //w=0.21 //l=0.115 //layer=ply \
 //thickness=0.18 //x=1.455 //y=1.555 //x2=1.34 //y2=1.555
r673 (  153 211 ) resistor r=5.52526 //w=0.168 //l=0.115 //layer=ply \
 //thickness=0.18 //x=1.675 //y=1.555 //x2=1.79 //y2=1.555
r674 (  152 204 ) resistor r=5.52526 //w=0.168 //l=0.115 //layer=ply \
 //thickness=0.18 //x=1.455 //y=0.9 //x2=1.34 //y2=0.9
r675 (  151 210 ) resistor r=5.52526 //w=0.168 //l=0.115 //layer=ply \
 //thickness=0.18 //x=1.675 //y=0.9 //x2=1.79 //y2=0.9
r676 (  151 152 ) resistor r=112.809 //w=0.094 //l=0.22 //layer=ply \
 //thickness=0.18 //x=1.675 //y=0.9 //x2=1.455 //y2=0.9
r677 (  150 207 ) resistor r=58.7805 //w=0.246 //l=0.373497 //layer=ply \
 //thickness=0.18 //x=1.3 //y=2.095 //x2=1.6 //y2=2.26
r678 (  149 205 ) resistor r=39.5823 //w=0.21 //l=0.173853 //layer=ply \
 //thickness=0.18 //x=1.3 //y=1.71 //x2=1.34 //y2=1.555
r679 (  149 150 ) resistor r=197.415 //w=0.094 //l=0.385 //layer=ply \
 //thickness=0.18 //x=1.3 //y=1.71 //x2=1.3 //y2=2.095
r680 (  148 205 ) resistor r=39.5823 //w=0.21 //l=0.173853 //layer=ply \
 //thickness=0.18 //x=1.3 //y=1.4 //x2=1.34 //y2=1.555
r681 (  147 204 ) resistor r=45.1352 //w=0.168 //l=0.173853 //layer=ply \
 //thickness=0.18 //x=1.3 //y=1.055 //x2=1.34 //y2=0.9
r682 (  147 148 ) resistor r=176.904 //w=0.094 //l=0.345 //layer=ply \
 //thickness=0.18 //x=1.3 //y=1.055 //x2=1.3 //y2=1.4
r683 (  146 201 ) resistor r=592.245 //w=0.094 //l=1.155 //layer=ply \
 //thickness=0.18 //x=59.96 //y=6.2 //x2=59.96 //y2=5.045
r684 (  145 194 ) resistor r=592.245 //w=0.094 //l=1.155 //layer=ply \
 //thickness=0.18 //x=59.52 //y=6.2 //x2=59.52 //y2=5.045
r685 (  144 182 ) resistor r=592.245 //w=0.094 //l=1.155 //layer=ply \
 //thickness=0.18 //x=31.1 //y=6.2 //x2=31.1 //y2=5.045
r686 (  143 175 ) resistor r=592.245 //w=0.094 //l=1.155 //layer=ply \
 //thickness=0.18 //x=30.66 //y=6.2 //x2=30.66 //y2=5.045
r687 (  142 163 ) resistor r=592.245 //w=0.094 //l=1.155 //layer=ply \
 //thickness=0.18 //x=2.24 //y=6.2 //x2=2.24 //y2=5.045
r688 (  141 156 ) resistor r=592.245 //w=0.094 //l=1.155 //layer=ply \
 //thickness=0.18 //x=1.8 //y=6.2 //x2=1.8 //y2=5.045
r689 (  140 191 ) resistor r=56.4043 //w=0.094 //l=0.11 //layer=ply \
 //thickness=0.18 //x=59.285 //y=1.555 //x2=59.395 //y2=1.555
r690 (  140 192 ) resistor r=56.4043 //w=0.094 //l=0.11 //layer=ply \
 //thickness=0.18 //x=59.285 //y=1.555 //x2=59.175 //y2=1.555
r691 (  139 172 ) resistor r=56.4043 //w=0.094 //l=0.11 //layer=ply \
 //thickness=0.18 //x=30.425 //y=1.555 //x2=30.535 //y2=1.555
r692 (  139 173 ) resistor r=56.4043 //w=0.094 //l=0.11 //layer=ply \
 //thickness=0.18 //x=30.425 //y=1.555 //x2=30.315 //y2=1.555
r693 (  138 153 ) resistor r=56.4043 //w=0.094 //l=0.11 //layer=ply \
 //thickness=0.18 //x=1.565 //y=1.555 //x2=1.675 //y2=1.555
r694 (  138 154 ) resistor r=56.4043 //w=0.094 //l=0.11 //layer=ply \
 //thickness=0.18 //x=1.565 //y=1.555 //x2=1.455 //y2=1.555
r695 (  134 225 ) resistor r=152 //w=0.17 //l=0.17 //layer=licon //count=1 \
 //x=59.32 //y=4.88 //x2=59.32 //y2=4.88
r696 (  125 223 ) resistor r=152 //w=0.17 //l=0.17 //layer=licon //count=1 \
 //x=59.32 //y=2.26 //x2=59.32 //y2=2.26
r697 (  120 217 ) resistor r=152 //w=0.17 //l=0.17 //layer=licon //count=1 \
 //x=30.46 //y=4.88 //x2=30.46 //y2=4.88
r698 (  111 215 ) resistor r=152 //w=0.17 //l=0.17 //layer=licon //count=1 \
 //x=30.46 //y=2.26 //x2=30.46 //y2=2.26
r699 (  106 209 ) resistor r=152 //w=0.17 //l=0.17 //layer=licon //count=1 \
 //x=1.6 //y=4.88 //x2=1.6 //y2=4.88
r700 (  97 207 ) resistor r=152 //w=0.17 //l=0.17 //layer=licon //count=1 \
 //x=1.6 //y=2.26 //x2=1.6 //y2=2.26
r701 (  89 91 ) resistor r=0.10734 //w=0.281 //l=0.16 //layer=m2 \
 //thickness=0.36 //x=1.6 //y=4.255 //x2=1.76 //y2=4.255
r702 (  86 95 ) resistor r=1.55759 //w=0.19 //l=2.38244 //layer=m2 \
 //thickness=0.36 //x=56.945 //y=4.27 //x2=59.31 //y2=4.235
r703 (  86 87 ) resistor r=0.329198 //w=0.131 //l=0.345 //layer=m2 \
 //thickness=0.36 //x=56.945 //y=4.27 //x2=56.6 //y2=4.27
r704 (  84 87 ) resistor r=0.1875 //w=0.17 //l=0.264811 //layer=m2 \
 //thickness=0.36 //x=56.345 //y=4.25 //x2=56.6 //y2=4.27
r705 (  84 85 ) resistor r=7.74809 //w=0.131 //l=8.12 //layer=m2 \
 //thickness=0.36 //x=56.345 //y=4.25 //x2=48.225 //y2=4.25
r706 (  82 85 ) resistor r=0.125 //w=0.17 //l=0.184391 //layer=m2 \
 //thickness=0.36 //x=48.055 //y=4.28 //x2=48.225 //y2=4.25
r707 (  82 83 ) resistor r=0.329198 //w=0.131 //l=0.345 //layer=m2 \
 //thickness=0.36 //x=48.055 //y=4.28 //x2=47.71 //y2=4.28
r708 (  80 83 ) resistor r=0.1875 //w=0.17 //l=0.269583 //layer=m2 \
 //thickness=0.36 //x=47.455 //y=4.25 //x2=47.71 //y2=4.28
r709 (  80 81 ) resistor r=4.49427 //w=0.131 //l=4.71 //layer=m2 \
 //thickness=0.36 //x=47.455 //y=4.25 //x2=42.745 //y2=4.25
r710 (  78 81 ) resistor r=0.14881 //w=0.189 //l=0.253229 //layer=m2 \
 //thickness=0.36 //x=42.52 //y=4.31 //x2=42.745 //y2=4.25
r711 (  78 79 ) resistor r=0.333969 //w=0.131 //l=0.35 //layer=m2 \
 //thickness=0.36 //x=42.52 //y=4.31 //x2=42.17 //y2=4.31
r712 (  77 93 ) resistor r=4.89702 //w=0.176 //l=6.91746 //layer=m2 \
 //thickness=0.36 //x=37.36 //y=4.28 //x2=30.465 //y2=4.235
r713 (  76 79 ) resistor r=3.26023 //w=0.171 //l=4.47498 //layer=m2 \
 //thickness=0.36 //x=37.71 //y=4.28 //x2=42.17 //y2=4.31
r714 (  76 77 ) resistor r=0.333969 //w=0.131 //l=0.35 //layer=m2 \
 //thickness=0.36 //x=37.71 //y=4.28 //x2=37.36 //y2=4.28
r715 (  74 93 ) resistor r=1.68679 //w=0.176 //l=2.39244 //layer=m2 \
 //thickness=0.36 //x=28.09 //y=4.27 //x2=30.465 //y2=4.235
r716 (  74 75 ) resistor r=0.333969 //w=0.131 //l=0.35 //layer=m2 \
 //thickness=0.36 //x=28.09 //y=4.27 //x2=27.74 //y2=4.27
r717 (  72 75 ) resistor r=0.1875 //w=0.17 //l=0.264811 //layer=m2 \
 //thickness=0.36 //x=27.485 //y=4.25 //x2=27.74 //y2=4.27
r718 (  72 73 ) resistor r=7.74809 //w=0.131 //l=8.12 //layer=m2 \
 //thickness=0.36 //x=27.485 //y=4.25 //x2=19.365 //y2=4.25
r719 (  70 73 ) resistor r=0.125 //w=0.17 //l=0.184391 //layer=m2 \
 //thickness=0.36 //x=19.195 //y=4.28 //x2=19.365 //y2=4.25
r720 (  70 71 ) resistor r=0.329198 //w=0.131 //l=0.345 //layer=m2 \
 //thickness=0.36 //x=19.195 //y=4.28 //x2=18.85 //y2=4.28
r721 (  68 71 ) resistor r=0.1875 //w=0.17 //l=0.269583 //layer=m2 \
 //thickness=0.36 //x=18.595 //y=4.25 //x2=18.85 //y2=4.28
r722 (  68 69 ) resistor r=4.49905 //w=0.131 //l=4.715 //layer=m2 \
 //thickness=0.36 //x=18.595 //y=4.25 //x2=13.88 //y2=4.25
r723 (  66 69 ) resistor r=0.14881 //w=0.189 //l=0.253229 //layer=m2 \
 //thickness=0.36 //x=13.655 //y=4.31 //x2=13.88 //y2=4.25
r724 (  66 67 ) resistor r=0.329198 //w=0.131 //l=0.345 //layer=m2 \
 //thickness=0.36 //x=13.655 //y=4.31 //x2=13.31 //y2=4.31
r725 (  64 67 ) resistor r=3.26389 //w=0.171 //l=4.47998 //layer=m2 \
 //thickness=0.36 //x=8.845 //y=4.28 //x2=13.31 //y2=4.31
r726 (  64 65 ) resistor r=0.329198 //w=0.131 //l=0.345 //layer=m2 \
 //thickness=0.36 //x=8.845 //y=4.28 //x2=8.5 //y2=4.28
r727 (  62 65 ) resistor r=0.1875 //w=0.17 //l=0.269583 //layer=m2 \
 //thickness=0.36 //x=8.245 //y=4.25 //x2=8.5 //y2=4.28
r728 (  62 91 ) resistor r=6.18798 //w=0.131 //l=6.485 //layer=m2 \
 //thickness=0.36 //x=8.245 //y=4.25 //x2=1.76 //y2=4.25
r729 (  61 134 ) resistor r=9.3 //w=0.17 //l=0.17 //layer=mcon //count=1 \
 //x=59.32 //y=4.88 //x2=59.32 //y2=4.88
r730 (  59 125 ) resistor r=9.3 //w=0.17 //l=0.17 //layer=mcon //count=1 \
 //x=59.32 //y=2.26 //x2=59.32 //y2=2.26
r731 (  55 95 ) resistor r=4.5 //w=0.15 //l=0.15 //layer=via1 //count=1 \
 //x=59.31 //y=4.235 //x2=59.31 //y2=4.235
r732 (  51 93 ) resistor r=4.5 //w=0.15 //l=0.15 //layer=via1 //count=1 \
 //x=30.465 //y=4.235 //x2=30.465 //y2=4.235
r733 (  49 120 ) resistor r=9.3 //w=0.17 //l=0.17 //layer=mcon //count=1 \
 //x=30.46 //y=4.88 //x2=30.46 //y2=4.88
r734 (  47 111 ) resistor r=9.3 //w=0.17 //l=0.17 //layer=mcon //count=1 \
 //x=30.46 //y=2.26 //x2=30.46 //y2=2.26
r735 (  45 106 ) resistor r=9.3 //w=0.17 //l=0.17 //layer=mcon //count=1 \
 //x=1.6 //y=4.88 //x2=1.6 //y2=4.88
r736 (  43 97 ) resistor r=9.3 //w=0.17 //l=0.17 //layer=mcon //count=1 \
 //x=1.6 //y=2.26 //x2=1.6 //y2=2.26
r737 (  41 89 ) resistor r=4.5 //w=0.15 //l=0.15 //layer=via1 //count=1 \
 //x=1.6 //y=4.255 //x2=1.6 //y2=4.255
r738 (  37 61 ) resistor r=0.0760407 //w=0.238 //l=0.125 //layer=m1 \
 //thickness=0.36 //x=59.32 //y=4.755 //x2=59.32 //y2=4.88
r739 (  36 37 ) resistor r=0.343511 //w=0.131 //l=0.36 //layer=m1 \
 //thickness=0.36 //x=59.32 //y=4.395 //x2=59.32 //y2=4.755
r740 (  33 55 ) resistor r=0.0909648 //w=0.371 //l=0.186762 //layer=m1 \
 //thickness=0.36 //x=59.32 //y=4.075 //x2=59.262 //y2=4.235
r741 (  32 59 ) resistor r=0.0719237 //w=0.222 //l=0.115 //layer=m1 \
 //thickness=0.36 //x=59.32 //y=2.375 //x2=59.32 //y2=2.26
r742 (  31 49 ) resistor r=0.0760407 //w=0.238 //l=0.125 //layer=m1 \
 //thickness=0.36 //x=30.46 //y=4.755 //x2=30.46 //y2=4.88
r743 (  30 31 ) resistor r=0.343511 //w=0.131 //l=0.36 //layer=m1 \
 //thickness=0.36 //x=30.46 //y=4.395 //x2=30.46 //y2=4.755
r744 (  26 51 ) resistor r=0.0910802 //w=0.374 //l=0.185472 //layer=m1 \
 //thickness=0.36 //x=30.46 //y=4.075 //x2=30.515 //y2=4.235
r745 (  25 47 ) resistor r=0.0719237 //w=0.222 //l=0.115 //layer=m1 \
 //thickness=0.36 //x=30.46 //y=2.375 //x2=30.46 //y2=2.26
r746 (  23 45 ) resistor r=0.0760407 //w=0.238 //l=0.125 //layer=m1 \
 //thickness=0.36 //x=1.6 //y=4.755 //x2=1.6 //y2=4.88
r747 (  22 41 ) resistor r=0.0911593 //w=0.376 //l=0.184608 //layer=m1 \
 //thickness=0.36 //x=1.6 //y=4.415 //x2=1.547 //y2=4.255
r748 (  15 43 ) resistor r=0.0719237 //w=0.222 //l=0.115 //layer=m1 \
 //thickness=0.36 //x=1.6 //y=2.375 //x2=1.6 //y2=2.26
r749 (  14 36 ) resistor r=0.0859108 //w=0.371 //l=0.171566 //layer=m1 \
 //thickness=0.36 //x=59.262 //y=4.25 //x2=59.32 //y2=4.395
r750 (  14 55 ) resistor r=0.00505391 //w=0.371 //l=0.015 //layer=m1 \
 //thickness=0.36 //x=59.262 //y=4.25 //x2=59.262 //y2=4.235
r751 (  13 30 ) resistor r=0.0860668 //w=0.374 //l=0.170294 //layer=m1 \
 //thickness=0.36 //x=30.515 //y=4.25 //x2=30.46 //y2=4.395
r752 (  13 51 ) resistor r=0.00501337 //w=0.374 //l=0.015 //layer=m1 \
 //thickness=0.36 //x=30.515 //y=4.25 //x2=30.515 //y2=4.235
r753 (  12 41 ) resistor r=0.00166223 //w=0.376 //l=0.005 //layer=m1 \
 //thickness=0.36 //x=1.547 //y=4.25 //x2=1.547 //y2=4.255
r754 (  12 16 ) resistor r=0.0894971 //w=0.376 //l=0.179555 //layer=m1 \
 //thickness=0.36 //x=1.547 //y=4.25 //x2=1.6 //y2=4.095
r755 (  11 33 ) resistor r=0.539122 //w=0.131 //l=0.565 //layer=m1 \
 //thickness=0.36 //x=59.32 //y=3.51 //x2=59.32 //y2=4.075
r756 (  10 11 ) resistor r=0.706107 //w=0.131 //l=0.74 //layer=m1 \
 //thickness=0.36 //x=59.32 //y=2.77 //x2=59.32 //y2=3.51
r757 (  10 32 ) resistor r=0.376908 //w=0.131 //l=0.395 //layer=m1 \
 //thickness=0.36 //x=59.32 //y=2.77 //x2=59.32 //y2=2.375
r758 (  9 26 ) resistor r=0.186069 //w=0.131 //l=0.195 //layer=m1 \
 //thickness=0.36 //x=30.46 //y=3.88 //x2=30.46 //y2=4.075
r759 (  8 9 ) resistor r=0.353053 //w=0.131 //l=0.37 //layer=m1 \
 //thickness=0.36 //x=30.46 //y=3.51 //x2=30.46 //y2=3.88
r760 (  7 8 ) resistor r=0.706107 //w=0.131 //l=0.74 //layer=m1 \
 //thickness=0.36 //x=30.46 //y=2.77 //x2=30.46 //y2=3.51
r761 (  7 25 ) resistor r=0.376908 //w=0.131 //l=0.395 //layer=m1 \
 //thickness=0.36 //x=30.46 //y=2.77 //x2=30.46 //y2=2.375
r762 (  6 23 ) resistor r=0.128817 //w=0.131 //l=0.135 //layer=m1 \
 //thickness=0.36 //x=1.6 //y=4.62 //x2=1.6 //y2=4.755
r763 (  6 22 ) resistor r=0.195611 //w=0.131 //l=0.205 //layer=m1 \
 //thickness=0.36 //x=1.6 //y=4.62 //x2=1.6 //y2=4.415
r764 (  5 16 ) resistor r=0.205153 //w=0.131 //l=0.215 //layer=m1 \
 //thickness=0.36 //x=1.6 //y=3.88 //x2=1.6 //y2=4.095
r765 (  4 5 ) resistor r=0.353053 //w=0.131 //l=0.37 //layer=m1 \
 //thickness=0.36 //x=1.6 //y=3.51 //x2=1.6 //y2=3.88
r766 (  3 4 ) resistor r=0.353053 //w=0.131 //l=0.37 //layer=m1 \
 //thickness=0.36 //x=1.6 //y=3.14 //x2=1.6 //y2=3.51
r767 (  2 3 ) resistor r=0.353053 //w=0.131 //l=0.37 //layer=m1 \
 //thickness=0.36 //x=1.6 //y=2.77 //x2=1.6 //y2=3.14
r768 (  1 2 ) resistor r=0.353053 //w=0.131 //l=0.37 //layer=m1 \
 //thickness=0.36 //x=1.6 //y=2.4 //x2=1.6 //y2=2.77
r769 (  1 15 ) resistor r=0.023855 //w=0.131 //l=0.025 //layer=m1 \
 //thickness=0.36 //x=1.6 //y=2.4 //x2=1.6 //y2=2.375
ends PM_TMRDFFSNRNQNX1\%D

subckt PM_TMRDFFSNRNQNX1\%noxref_13 ( 1 3 6 7 9 10 11 12 14 15 16 17 18 19 20 \
 21 22 23 24 25 28 31 37 45 49 63 66 67 69 70 73 81 89 106 115 120 129 133 134 \
 135 136 137 138 139 140 141 142 143 145 151 152 153 154 158 159 160 161 162 \
 164 170 171 172 173 193 195 196 197 )
c441 ( 193 0 ) capacitor c=0.00885916f //x=61.605 //y=1.095
c442 ( 173 0 ) capacitor c=0.0612936f //x=69.215 //y=4.97
c443 ( 172 0 ) capacitor c=0.0376642f //x=69.505 //y=4.97
c444 ( 171 0 ) capacitor c=0.0346489f //x=69.17 //y=1.4
c445 ( 170 0 ) capacitor c=0.018692f //x=69.17 //y=1.055
c446 ( 164 0 ) capacitor c=0.0137077f //x=69.015 //y=1.555
c447 ( 162 0 ) capacitor c=0.0158585f //x=69.015 //y=0.9
c448 ( 161 0 ) capacitor c=0.0979536f //x=68.64 //y=2.095
c449 ( 160 0 ) capacitor c=0.0229444f //x=68.64 //y=1.71
c450 ( 159 0 ) capacitor c=0.0234359f //x=68.64 //y=1.4
c451 ( 158 0 ) capacitor c=0.019815f //x=68.64 //y=1.055
c452 ( 154 0 ) capacitor c=0.0614625f //x=64.405 //y=4.97
c453 ( 153 0 ) capacitor c=0.0376642f //x=64.695 //y=4.97
c454 ( 152 0 ) capacitor c=0.0346489f //x=64.36 //y=1.4
c455 ( 151 0 ) capacitor c=0.018692f //x=64.36 //y=1.055
c456 ( 145 0 ) capacitor c=0.0137077f //x=64.205 //y=1.555
c457 ( 143 0 ) capacitor c=0.0158585f //x=64.205 //y=0.9
c458 ( 142 0 ) capacitor c=0.0996161f //x=63.83 //y=2.095
c459 ( 141 0 ) capacitor c=0.0229444f //x=63.83 //y=1.71
c460 ( 140 0 ) capacitor c=0.0234359f //x=63.83 //y=1.4
c461 ( 139 0 ) capacitor c=0.019815f //x=63.83 //y=1.055
c462 ( 138 0 ) capacitor c=0.110208f //x=69.58 //y=6.2
c463 ( 137 0 ) capacitor c=0.158957f //x=69.14 //y=6.2
c464 ( 136 0 ) capacitor c=0.110299f //x=64.77 //y=6.2
c465 ( 135 0 ) capacitor c=0.158957f //x=64.33 //y=6.2
c466 ( 129 0 ) capacitor c=0.00159026f //x=68.94 //y=4.88
c467 ( 120 0 ) capacitor c=9.93222e-19 //x=68.94 //y=2.26
c468 ( 115 0 ) capacitor c=0.00157785f //x=64.13 //y=4.88
c469 ( 106 0 ) capacitor c=9.93222e-19 //x=64.13 //y=2.26
c470 ( 89 0 ) capacitor c=0.0293562f //x=61.5 //y=5.56
c471 ( 81 0 ) capacitor c=0.029137f //x=60.62 //y=5.56
c472 ( 73 0 ) capacitor c=0.0278099f //x=59.74 //y=5.56
c473 ( 70 0 ) capacitor c=0.0392804f //x=68.78 //y=2.785
c474 ( 69 0 ) capacitor c=5.7546e-19 //x=68.94 //y=2.785
c475 ( 67 0 ) capacitor c=5.7546e-19 //x=64.295 //y=2.785
c476 ( 66 0 ) capacitor c=0.016756f //x=63.975 //y=2.785
c477 ( 63 0 ) capacitor c=9.56892e-19 //x=62.445 //y=2.785
c478 ( 49 0 ) capacitor c=0.0154699f //x=68.94 //y=2.77
c479 ( 45 0 ) capacitor c=0.0148628f //x=64.13 //y=2.77
c480 ( 37 0 ) capacitor c=0.0144706f //x=62.28 //y=2.77
c481 ( 31 0 ) capacitor c=9.37498e-19 //x=61.5 //y=5.335
c482 ( 28 0 ) capacitor c=0.0076134f //x=60.62 //y=5.335
c483 ( 25 0 ) capacitor c=0.0109203f //x=59.742 //y=5.335
c484 ( 24 0 ) capacitor c=0.0552261f //x=68.94 //y=4.755
c485 ( 23 0 ) capacitor c=0.0130763f //x=68.94 //y=2.945
c486 ( 22 0 ) capacitor c=0.00473602f //x=68.94 //y=2.625
c487 ( 21 0 ) capacitor c=0.00495287f //x=68.94 //y=2.375
c488 ( 20 0 ) capacitor c=0.0593148f //x=64.13 //y=4.755
c489 ( 19 0 ) capacitor c=0.0129478f //x=64.13 //y=2.945
c490 ( 18 0 ) capacitor c=0.00482124f //x=64.13 //y=2.625
c491 ( 17 0 ) capacitor c=0.00495287f //x=64.13 //y=2.375
c492 ( 16 0 ) capacitor c=0.0647558f //x=62.28 //y=5.25
c493 ( 15 0 ) capacitor c=0.0123004f //x=62.28 //y=2.945
c494 ( 14 0 ) capacitor c=0.0179579f //x=62.28 //y=2.625
c495 ( 12 0 ) capacitor c=0.0047266f //x=61.88 //y=1.845
c496 ( 11 0 ) capacitor c=0.0129788f //x=62.195 //y=1.845
c497 ( 10 0 ) capacitor c=0.0167992f //x=61.795 //y=1.76
c498 ( 9 0 ) capacitor c=0.0110957f //x=61.795 //y=1.305
c499 ( 7 0 ) capacitor c=0.0203517f //x=62.195 //y=5.335
c500 ( 6 0 ) capacitor c=0.00933983f //x=61.5 //y=5.56
c501 ( 3 0 ) capacitor c=0.0192055f //x=61.385 //y=5.335
c502 ( 1 0 ) capacitor c=0.0149267f //x=60.5 //y=5.335
r503 (  172 174 ) resistor r=26.9307 //w=0.15 //l=0.106066 //layer=ply \
 //thickness=0.18 //x=69.505 //y=4.97 //x2=69.58 //y2=5.045
r504 (  172 173 ) resistor r=148.702 //w=0.094 //l=0.29 //layer=ply \
 //thickness=0.18 //x=69.505 //y=4.97 //x2=69.215 //y2=4.97
r505 (  171 192 ) resistor r=45.1352 //w=0.168 //l=0.173853 //layer=ply \
 //thickness=0.18 //x=69.17 //y=1.4 //x2=69.13 //y2=1.555
r506 (  170 191 ) resistor r=45.1352 //w=0.168 //l=0.173853 //layer=ply \
 //thickness=0.18 //x=69.17 //y=1.055 //x2=69.13 //y2=0.9
r507 (  170 171 ) resistor r=176.904 //w=0.094 //l=0.345 //layer=ply \
 //thickness=0.18 //x=69.17 //y=1.055 //x2=69.17 //y2=1.4
r508 (  167 173 ) resistor r=22.7971 //w=0.269 //l=0.106066 //layer=ply \
 //thickness=0.18 //x=69.14 //y=5.045 //x2=69.215 //y2=4.97
r509 (  167 190 ) resistor r=35.8364 //w=0.269 //l=0.270185 //layer=ply \
 //thickness=0.18 //x=69.14 //y=5.045 //x2=68.94 //y2=4.88
r510 (  165 186 ) resistor r=10.701 //w=0.21 //l=0.115 //layer=ply \
 //thickness=0.18 //x=68.795 //y=1.555 //x2=68.68 //y2=1.555
r511 (  164 192 ) resistor r=5.52526 //w=0.168 //l=0.115 //layer=ply \
 //thickness=0.18 //x=69.015 //y=1.555 //x2=69.13 //y2=1.555
r512 (  163 185 ) resistor r=5.52526 //w=0.168 //l=0.115 //layer=ply \
 //thickness=0.18 //x=68.795 //y=0.9 //x2=68.68 //y2=0.9
r513 (  162 191 ) resistor r=5.52526 //w=0.168 //l=0.115 //layer=ply \
 //thickness=0.18 //x=69.015 //y=0.9 //x2=69.13 //y2=0.9
r514 (  162 163 ) resistor r=112.809 //w=0.094 //l=0.22 //layer=ply \
 //thickness=0.18 //x=69.015 //y=0.9 //x2=68.795 //y2=0.9
r515 (  161 188 ) resistor r=58.7805 //w=0.246 //l=0.373497 //layer=ply \
 //thickness=0.18 //x=68.64 //y=2.095 //x2=68.94 //y2=2.26
r516 (  160 186 ) resistor r=39.5823 //w=0.21 //l=0.173853 //layer=ply \
 //thickness=0.18 //x=68.64 //y=1.71 //x2=68.68 //y2=1.555
r517 (  160 161 ) resistor r=197.415 //w=0.094 //l=0.385 //layer=ply \
 //thickness=0.18 //x=68.64 //y=1.71 //x2=68.64 //y2=2.095
r518 (  159 186 ) resistor r=39.5823 //w=0.21 //l=0.173853 //layer=ply \
 //thickness=0.18 //x=68.64 //y=1.4 //x2=68.68 //y2=1.555
r519 (  158 185 ) resistor r=45.1352 //w=0.168 //l=0.173853 //layer=ply \
 //thickness=0.18 //x=68.64 //y=1.055 //x2=68.68 //y2=0.9
r520 (  158 159 ) resistor r=176.904 //w=0.094 //l=0.345 //layer=ply \
 //thickness=0.18 //x=68.64 //y=1.055 //x2=68.64 //y2=1.4
r521 (  153 155 ) resistor r=26.9307 //w=0.15 //l=0.106066 //layer=ply \
 //thickness=0.18 //x=64.695 //y=4.97 //x2=64.77 //y2=5.045
r522 (  153 154 ) resistor r=148.702 //w=0.094 //l=0.29 //layer=ply \
 //thickness=0.18 //x=64.695 //y=4.97 //x2=64.405 //y2=4.97
r523 (  152 184 ) resistor r=45.1352 //w=0.168 //l=0.173853 //layer=ply \
 //thickness=0.18 //x=64.36 //y=1.4 //x2=64.32 //y2=1.555
r524 (  151 183 ) resistor r=45.1352 //w=0.168 //l=0.173853 //layer=ply \
 //thickness=0.18 //x=64.36 //y=1.055 //x2=64.32 //y2=0.9
r525 (  151 152 ) resistor r=176.904 //w=0.094 //l=0.345 //layer=ply \
 //thickness=0.18 //x=64.36 //y=1.055 //x2=64.36 //y2=1.4
r526 (  148 154 ) resistor r=22.7971 //w=0.269 //l=0.106066 //layer=ply \
 //thickness=0.18 //x=64.33 //y=5.045 //x2=64.405 //y2=4.97
r527 (  148 182 ) resistor r=35.8364 //w=0.269 //l=0.270185 //layer=ply \
 //thickness=0.18 //x=64.33 //y=5.045 //x2=64.13 //y2=4.88
r528 (  146 178 ) resistor r=10.701 //w=0.21 //l=0.115 //layer=ply \
 //thickness=0.18 //x=63.985 //y=1.555 //x2=63.87 //y2=1.555
r529 (  145 184 ) resistor r=5.52526 //w=0.168 //l=0.115 //layer=ply \
 //thickness=0.18 //x=64.205 //y=1.555 //x2=64.32 //y2=1.555
r530 (  144 177 ) resistor r=5.52526 //w=0.168 //l=0.115 //layer=ply \
 //thickness=0.18 //x=63.985 //y=0.9 //x2=63.87 //y2=0.9
r531 (  143 183 ) resistor r=5.52526 //w=0.168 //l=0.115 //layer=ply \
 //thickness=0.18 //x=64.205 //y=0.9 //x2=64.32 //y2=0.9
r532 (  143 144 ) resistor r=112.809 //w=0.094 //l=0.22 //layer=ply \
 //thickness=0.18 //x=64.205 //y=0.9 //x2=63.985 //y2=0.9
r533 (  142 180 ) resistor r=58.7805 //w=0.246 //l=0.373497 //layer=ply \
 //thickness=0.18 //x=63.83 //y=2.095 //x2=64.13 //y2=2.26
r534 (  141 178 ) resistor r=39.5823 //w=0.21 //l=0.173853 //layer=ply \
 //thickness=0.18 //x=63.83 //y=1.71 //x2=63.87 //y2=1.555
r535 (  141 142 ) resistor r=197.415 //w=0.094 //l=0.385 //layer=ply \
 //thickness=0.18 //x=63.83 //y=1.71 //x2=63.83 //y2=2.095
r536 (  140 178 ) resistor r=39.5823 //w=0.21 //l=0.173853 //layer=ply \
 //thickness=0.18 //x=63.83 //y=1.4 //x2=63.87 //y2=1.555
r537 (  139 177 ) resistor r=45.1352 //w=0.168 //l=0.173853 //layer=ply \
 //thickness=0.18 //x=63.83 //y=1.055 //x2=63.87 //y2=0.9
r538 (  139 140 ) resistor r=176.904 //w=0.094 //l=0.345 //layer=ply \
 //thickness=0.18 //x=63.83 //y=1.055 //x2=63.83 //y2=1.4
r539 (  138 174 ) resistor r=592.245 //w=0.094 //l=1.155 //layer=ply \
 //thickness=0.18 //x=69.58 //y=6.2 //x2=69.58 //y2=5.045
r540 (  137 167 ) resistor r=592.245 //w=0.094 //l=1.155 //layer=ply \
 //thickness=0.18 //x=69.14 //y=6.2 //x2=69.14 //y2=5.045
r541 (  136 155 ) resistor r=592.245 //w=0.094 //l=1.155 //layer=ply \
 //thickness=0.18 //x=64.77 //y=6.2 //x2=64.77 //y2=5.045
r542 (  135 148 ) resistor r=592.245 //w=0.094 //l=1.155 //layer=ply \
 //thickness=0.18 //x=64.33 //y=6.2 //x2=64.33 //y2=5.045
r543 (  134 164 ) resistor r=56.4043 //w=0.094 //l=0.11 //layer=ply \
 //thickness=0.18 //x=68.905 //y=1.555 //x2=69.015 //y2=1.555
r544 (  134 165 ) resistor r=56.4043 //w=0.094 //l=0.11 //layer=ply \
 //thickness=0.18 //x=68.905 //y=1.555 //x2=68.795 //y2=1.555
r545 (  133 145 ) resistor r=56.4043 //w=0.094 //l=0.11 //layer=ply \
 //thickness=0.18 //x=64.095 //y=1.555 //x2=64.205 //y2=1.555
r546 (  133 146 ) resistor r=56.4043 //w=0.094 //l=0.11 //layer=ply \
 //thickness=0.18 //x=64.095 //y=1.555 //x2=63.985 //y2=1.555
r547 (  129 190 ) resistor r=152 //w=0.17 //l=0.17 //layer=licon //count=1 \
 //x=68.94 //y=4.88 //x2=68.94 //y2=4.88
r548 (  120 188 ) resistor r=152 //w=0.17 //l=0.17 //layer=licon //count=1 \
 //x=68.94 //y=2.26 //x2=68.94 //y2=2.26
r549 (  115 182 ) resistor r=152 //w=0.17 //l=0.17 //layer=licon //count=1 \
 //x=64.13 //y=4.88 //x2=64.13 //y2=4.88
r550 (  106 180 ) resistor r=152 //w=0.17 //l=0.17 //layer=licon //count=1 \
 //x=64.13 //y=2.26 //x2=64.13 //y2=2.26
r551 (  89 197 ) resistor r=23.615 //w=0.187 //l=0.345 //layer=li \
 //thickness=0.1 //x=61.5 //y=5.56 //x2=61.5 //y2=5.905
r552 (  81 196 ) resistor r=23.615 //w=0.187 //l=0.345 //layer=li \
 //thickness=0.1 //x=60.62 //y=5.56 //x2=60.62 //y2=5.905
r553 (  73 195 ) resistor r=23.615 //w=0.187 //l=0.345 //layer=li \
 //thickness=0.1 //x=59.74 //y=5.56 //x2=59.74 //y2=5.905
r554 (  69 70 ) resistor r=0.10734 //w=0.281 //l=0.16 //layer=m2 \
 //thickness=0.36 //x=68.94 //y=2.785 //x2=68.78 //y2=2.785
r555 (  67 70 ) resistor r=4.27958 //w=0.131 //l=4.485 //layer=m2 \
 //thickness=0.36 //x=64.295 //y=2.77 //x2=68.78 //y2=2.77
r556 (  65 67 ) resistor r=0.10734 //w=0.281 //l=0.16 //layer=m2 \
 //thickness=0.36 //x=64.135 //y=2.785 //x2=64.295 //y2=2.785
r557 (  65 66 ) resistor r=0.10734 //w=0.281 //l=0.16 //layer=m2 \
 //thickness=0.36 //x=64.135 //y=2.785 //x2=63.975 //y2=2.785
r558 (  63 66 ) resistor r=1.45992 //w=0.131 //l=1.53 //layer=m2 \
 //thickness=0.36 //x=62.445 //y=2.77 //x2=63.975 //y2=2.77
r559 (  61 63 ) resistor r=0.10734 //w=0.281 //l=0.16 //layer=m2 \
 //thickness=0.36 //x=62.285 //y=2.785 //x2=62.445 //y2=2.785
r560 (  55 129 ) resistor r=9.3 //w=0.17 //l=0.17 //layer=mcon //count=1 \
 //x=68.94 //y=4.88 //x2=68.94 //y2=4.88
r561 (  53 120 ) resistor r=9.3 //w=0.17 //l=0.17 //layer=mcon //count=1 \
 //x=68.94 //y=2.26 //x2=68.94 //y2=2.26
r562 (  51 69 ) resistor r=4.5 //w=0.15 //l=0.15 //layer=via1 //count=1 \
 //x=68.94 //y=2.785 //x2=68.94 //y2=2.785
r563 (  49 51 ) resistor r=0.0049867 //w=0.376 //l=0.015 //layer=m1 \
 //thickness=0.36 //x=68.887 //y=2.77 //x2=68.887 //y2=2.785
r564 (  47 65 ) resistor r=4.5 //w=0.15 //l=0.15 //layer=via1 //count=1 \
 //x=64.135 //y=2.785 //x2=64.135 //y2=2.785
r565 (  45 47 ) resistor r=0.00501337 //w=0.374 //l=0.015 //layer=m1 \
 //thickness=0.36 //x=64.185 //y=2.77 //x2=64.185 //y2=2.785
r566 (  43 115 ) resistor r=9.3 //w=0.17 //l=0.17 //layer=mcon //count=1 \
 //x=64.13 //y=4.88 //x2=64.13 //y2=4.88
r567 (  41 106 ) resistor r=9.3 //w=0.17 //l=0.17 //layer=mcon //count=1 \
 //x=64.13 //y=2.26 //x2=64.13 //y2=2.26
r568 (  39 61 ) resistor r=4.5 //w=0.15 //l=0.15 //layer=via1 //count=1 \
 //x=62.285 //y=2.785 //x2=62.285 //y2=2.785
r569 (  37 39 ) resistor r=0.00501337 //w=0.374 //l=0.015 //layer=m1 \
 //thickness=0.36 //x=62.335 //y=2.77 //x2=62.335 //y2=2.785
r570 (  35 193 ) resistor r=9.3 //w=0.17 //l=0.17 //layer=mcon //count=1 \
 //x=61.795 //y=1.19 //x2=61.795 //y2=1.19
r571 (  33 89 ) resistor r=9.3 //w=0.17 //l=0.17 //layer=mcon //count=1 \
 //x=61.5 //y=5.56 //x2=61.5 //y2=5.56
r572 (  30 81 ) resistor r=9.3 //w=0.17 //l=0.17 //layer=mcon //count=1 \
 //x=60.62 //y=5.56 //x2=60.62 //y2=5.56
r573 (  28 30 ) resistor r=0.121228 //w=0.232 //l=0.225 //layer=m1 \
 //thickness=0.36 //x=60.62 //y=5.335 //x2=60.62 //y2=5.56
r574 (  27 73 ) resistor r=9.3 //w=0.17 //l=0.17 //layer=mcon //count=1 \
 //x=59.74 //y=5.56 //x2=59.74 //y2=5.56
r575 (  25 27 ) resistor r=0.129608 //w=0.217 //l=0.225 //layer=m1 \
 //thickness=0.36 //x=59.742 //y=5.335 //x2=59.742 //y2=5.56
r576 (  24 55 ) resistor r=0.0760407 //w=0.238 //l=0.125 //layer=m1 \
 //thickness=0.36 //x=68.94 //y=4.755 //x2=68.94 //y2=4.88
r577 (  23 51 ) resistor r=0.0911593 //w=0.376 //l=0.184608 //layer=m1 \
 //thickness=0.36 //x=68.94 //y=2.945 //x2=68.887 //y2=2.785
r578 (  23 24 ) resistor r=1.7271 //w=0.131 //l=1.81 //layer=m1 \
 //thickness=0.36 //x=68.94 //y=2.945 //x2=68.94 //y2=4.755
r579 (  22 49 ) resistor r=0.0861726 //w=0.376 //l=0.16944 //layer=m1 \
 //thickness=0.36 //x=68.94 //y=2.625 //x2=68.887 //y2=2.77
r580 (  21 53 ) resistor r=0.0719237 //w=0.222 //l=0.115 //layer=m1 \
 //thickness=0.36 //x=68.94 //y=2.375 //x2=68.94 //y2=2.26
r581 (  21 22 ) resistor r=0.23855 //w=0.131 //l=0.25 //layer=m1 \
 //thickness=0.36 //x=68.94 //y=2.375 //x2=68.94 //y2=2.625
r582 (  20 43 ) resistor r=0.0760407 //w=0.238 //l=0.125 //layer=m1 \
 //thickness=0.36 //x=64.13 //y=4.755 //x2=64.13 //y2=4.88
r583 (  19 47 ) resistor r=0.0910802 //w=0.374 //l=0.185472 //layer=m1 \
 //thickness=0.36 //x=64.13 //y=2.945 //x2=64.185 //y2=2.785
r584 (  19 20 ) resistor r=1.7271 //w=0.131 //l=1.81 //layer=m1 \
 //thickness=0.36 //x=64.13 //y=2.945 //x2=64.13 //y2=4.755
r585 (  18 45 ) resistor r=0.0860668 //w=0.374 //l=0.170294 //layer=m1 \
 //thickness=0.36 //x=64.13 //y=2.625 //x2=64.185 //y2=2.77
r586 (  17 41 ) resistor r=0.0719237 //w=0.222 //l=0.115 //layer=m1 \
 //thickness=0.36 //x=64.13 //y=2.375 //x2=64.13 //y2=2.26
r587 (  17 18 ) resistor r=0.23855 //w=0.131 //l=0.25 //layer=m1 \
 //thickness=0.36 //x=64.13 //y=2.375 //x2=64.13 //y2=2.625
r588 (  15 39 ) resistor r=0.0910802 //w=0.374 //l=0.185472 //layer=m1 \
 //thickness=0.36 //x=62.28 //y=2.945 //x2=62.335 //y2=2.785
r589 (  15 16 ) resistor r=2.19943 //w=0.131 //l=2.305 //layer=m1 \
 //thickness=0.36 //x=62.28 //y=2.945 //x2=62.28 //y2=5.25
r590 (  14 37 ) resistor r=0.0860668 //w=0.374 //l=0.170294 //layer=m1 \
 //thickness=0.36 //x=62.28 //y=2.625 //x2=62.335 //y2=2.77
r591 (  13 14 ) resistor r=0.663168 //w=0.131 //l=0.695 //layer=m1 \
 //thickness=0.36 //x=62.28 //y=1.93 //x2=62.28 //y2=2.625
r592 (  11 13 ) resistor r=0.0698411 //w=0.17 //l=0.120208 //layer=m1 \
 //thickness=0.36 //x=62.195 //y=1.845 //x2=62.28 //y2=1.93
r593 (  11 12 ) resistor r=0.300573 //w=0.131 //l=0.315 //layer=m1 \
 //thickness=0.36 //x=62.195 //y=1.845 //x2=61.88 //y2=1.845
r594 (  10 12 ) resistor r=0.0698411 //w=0.17 //l=0.120208 //layer=m1 \
 //thickness=0.36 //x=61.795 //y=1.76 //x2=61.88 //y2=1.845
r595 (  9 35 ) resistor r=0.0717383 //w=0.224 //l=0.115 //layer=m1 \
 //thickness=0.36 //x=61.795 //y=1.305 //x2=61.795 //y2=1.19
r596 (  9 10 ) resistor r=0.43416 //w=0.131 //l=0.455 //layer=m1 \
 //thickness=0.36 //x=61.795 //y=1.305 //x2=61.795 //y2=1.76
r597 (  8 31 ) resistor r=0.0675342 //w=0.23 //l=0.115 //layer=m1 \
 //thickness=0.36 //x=61.615 //y=5.335 //x2=61.5 //y2=5.335
r598 (  7 16 ) resistor r=0.0698411 //w=0.17 //l=0.120208 //layer=m1 \
 //thickness=0.36 //x=62.195 //y=5.335 //x2=62.28 //y2=5.25
r599 (  7 8 ) resistor r=0.553435 //w=0.131 //l=0.58 //layer=m1 \
 //thickness=0.36 //x=62.195 //y=5.335 //x2=61.615 //y2=5.335
r600 (  6 33 ) resistor r=0.00118313 //w=0.23 //layer=m1 //thickness=0.36 \
 //x=61.5 //y=5.56 //x2=61.5 //y2=5.56
r601 (  5 31 ) resistor r=0.002872 //w=0.34 //l=0.085 //layer=m1 \
 //thickness=0.36 //x=61.5 //y=5.42 //x2=61.5 //y2=5.335
r602 (  5 6 ) resistor r=0.091623 //w=0.191 //l=0.14 //layer=m1 \
 //thickness=0.36 //x=61.5 //y=5.42 //x2=61.5 //y2=5.56
r603 (  4 28 ) resistor r=0.0262263 //w=0.232 //l=0.12 //layer=m1 \
 //thickness=0.36 //x=60.74 //y=5.335 //x2=60.62 //y2=5.335
r604 (  3 31 ) resistor r=0.0675342 //w=0.23 //l=0.115 //layer=m1 \
 //thickness=0.36 //x=61.385 //y=5.335 //x2=61.5 //y2=5.335
r605 (  3 4 ) resistor r=0.615458 //w=0.131 //l=0.645 //layer=m1 \
 //thickness=0.36 //x=61.385 //y=5.335 //x2=60.74 //y2=5.335
r606 (  2 25 ) resistor r=0.0222262 //w=0.217 //l=0.118 //layer=m1 \
 //thickness=0.36 //x=59.86 //y=5.335 //x2=59.742 //y2=5.335
r607 (  1 28 ) resistor r=0.0262263 //w=0.232 //l=0.12 //layer=m1 \
 //thickness=0.36 //x=60.5 //y=5.335 //x2=60.62 //y2=5.335
r608 (  1 2 ) resistor r=0.610687 //w=0.131 //l=0.64 //layer=m1 \
 //thickness=0.36 //x=60.5 //y=5.335 //x2=59.86 //y2=5.335
ends PM_TMRDFFSNRNQNX1\%noxref_13

subckt PM_TMRDFFSNRNQNX1\%noxref_14 ( 1 3 6 7 9 10 11 12 14 15 16 17 18 19 20 \
 21 24 27 33 36 42 43 48 51 59 67 84 93 97 98 99 100 101 102 103 104 106 112 \
 113 114 115 127 129 130 131 )
c299 ( 127 0 ) capacitor c=0.00885916f //x=71.225 //y=1.095
c300 ( 115 0 ) capacitor c=0.0612936f //x=74.025 //y=4.97
c301 ( 114 0 ) capacitor c=0.0376642f //x=74.315 //y=4.97
c302 ( 113 0 ) capacitor c=0.0346489f //x=73.98 //y=1.4
c303 ( 112 0 ) capacitor c=0.018692f //x=73.98 //y=1.055
c304 ( 106 0 ) capacitor c=0.0137077f //x=73.825 //y=1.555
c305 ( 104 0 ) capacitor c=0.0158585f //x=73.825 //y=0.9
c306 ( 103 0 ) capacitor c=0.0979523f //x=73.45 //y=2.095
c307 ( 102 0 ) capacitor c=0.0229444f //x=73.45 //y=1.71
c308 ( 101 0 ) capacitor c=0.0234359f //x=73.45 //y=1.4
c309 ( 100 0 ) capacitor c=0.019815f //x=73.45 //y=1.055
c310 ( 99 0 ) capacitor c=0.110419f //x=74.39 //y=6.2
c311 ( 98 0 ) capacitor c=0.158957f //x=73.95 //y=6.2
c312 ( 93 0 ) capacitor c=0.00157857f //x=73.75 //y=4.88
c313 ( 84 0 ) capacitor c=9.93222e-19 //x=73.75 //y=2.26
c314 ( 67 0 ) capacitor c=0.0293723f //x=71.12 //y=5.56
c315 ( 59 0 ) capacitor c=0.029137f //x=70.24 //y=5.56
c316 ( 51 0 ) capacitor c=0.0278099f //x=69.36 //y=5.56
c317 ( 48 0 ) capacitor c=5.79974e-19 //x=73.76 //y=2.77
c318 ( 43 0 ) capacitor c=9.44624e-19 //x=72.06 //y=2.77
c319 ( 42 0 ) capacitor c=0.0155215f //x=73.6 //y=2.77
c320 ( 36 0 ) capacitor c=0.0146045f //x=73.75 //y=2.77
c321 ( 33 0 ) capacitor c=0.0146969f //x=71.9 //y=2.77
c322 ( 27 0 ) capacitor c=8.40513e-19 //x=71.12 //y=5.335
c323 ( 24 0 ) capacitor c=0.00712803f //x=70.24 //y=5.335
c324 ( 21 0 ) capacitor c=0.0109203f //x=69.362 //y=5.335
c325 ( 20 0 ) capacitor c=0.0604532f //x=73.75 //y=4.755
c326 ( 19 0 ) capacitor c=0.0131932f //x=73.75 //y=2.93
c327 ( 18 0 ) capacitor c=0.00432188f //x=73.75 //y=2.61
c328 ( 17 0 ) capacitor c=0.00485584f //x=73.75 //y=2.375
c329 ( 16 0 ) capacitor c=0.0631313f //x=71.9 //y=5.25
c330 ( 15 0 ) capacitor c=0.0122936f //x=71.9 //y=2.93
c331 ( 14 0 ) capacitor c=0.0181662f //x=71.9 //y=2.61
c332 ( 12 0 ) capacitor c=0.00493487f //x=71.5 //y=1.845
c333 ( 11 0 ) capacitor c=0.0129068f //x=71.815 //y=1.845
c334 ( 10 0 ) capacitor c=0.0167992f //x=71.415 //y=1.76
c335 ( 9 0 ) capacitor c=0.0112867f //x=71.415 //y=1.305
c336 ( 7 0 ) capacitor c=0.0208222f //x=71.815 //y=5.335
c337 ( 6 0 ) capacitor c=0.00933983f //x=71.12 //y=5.56
c338 ( 3 0 ) capacitor c=0.0177111f //x=71.005 //y=5.335
c339 ( 1 0 ) capacitor c=0.0148498f //x=70.12 //y=5.335
r340 (  114 116 ) resistor r=26.9307 //w=0.15 //l=0.106066 //layer=ply \
 //thickness=0.18 //x=74.315 //y=4.97 //x2=74.39 //y2=5.045
r341 (  114 115 ) resistor r=148.702 //w=0.094 //l=0.29 //layer=ply \
 //thickness=0.18 //x=74.315 //y=4.97 //x2=74.025 //y2=4.97
r342 (  113 126 ) resistor r=45.1352 //w=0.168 //l=0.173853 //layer=ply \
 //thickness=0.18 //x=73.98 //y=1.4 //x2=73.94 //y2=1.555
r343 (  112 125 ) resistor r=45.1352 //w=0.168 //l=0.173853 //layer=ply \
 //thickness=0.18 //x=73.98 //y=1.055 //x2=73.94 //y2=0.9
r344 (  112 113 ) resistor r=176.904 //w=0.094 //l=0.345 //layer=ply \
 //thickness=0.18 //x=73.98 //y=1.055 //x2=73.98 //y2=1.4
r345 (  109 115 ) resistor r=22.7971 //w=0.269 //l=0.106066 //layer=ply \
 //thickness=0.18 //x=73.95 //y=5.045 //x2=74.025 //y2=4.97
r346 (  109 124 ) resistor r=35.8364 //w=0.269 //l=0.270185 //layer=ply \
 //thickness=0.18 //x=73.95 //y=5.045 //x2=73.75 //y2=4.88
r347 (  107 120 ) resistor r=10.701 //w=0.21 //l=0.115 //layer=ply \
 //thickness=0.18 //x=73.605 //y=1.555 //x2=73.49 //y2=1.555
r348 (  106 126 ) resistor r=5.52526 //w=0.168 //l=0.115 //layer=ply \
 //thickness=0.18 //x=73.825 //y=1.555 //x2=73.94 //y2=1.555
r349 (  105 119 ) resistor r=5.52526 //w=0.168 //l=0.115 //layer=ply \
 //thickness=0.18 //x=73.605 //y=0.9 //x2=73.49 //y2=0.9
r350 (  104 125 ) resistor r=5.52526 //w=0.168 //l=0.115 //layer=ply \
 //thickness=0.18 //x=73.825 //y=0.9 //x2=73.94 //y2=0.9
r351 (  104 105 ) resistor r=112.809 //w=0.094 //l=0.22 //layer=ply \
 //thickness=0.18 //x=73.825 //y=0.9 //x2=73.605 //y2=0.9
r352 (  103 122 ) resistor r=58.7805 //w=0.246 //l=0.373497 //layer=ply \
 //thickness=0.18 //x=73.45 //y=2.095 //x2=73.75 //y2=2.26
r353 (  102 120 ) resistor r=39.5823 //w=0.21 //l=0.173853 //layer=ply \
 //thickness=0.18 //x=73.45 //y=1.71 //x2=73.49 //y2=1.555
r354 (  102 103 ) resistor r=197.415 //w=0.094 //l=0.385 //layer=ply \
 //thickness=0.18 //x=73.45 //y=1.71 //x2=73.45 //y2=2.095
r355 (  101 120 ) resistor r=39.5823 //w=0.21 //l=0.173853 //layer=ply \
 //thickness=0.18 //x=73.45 //y=1.4 //x2=73.49 //y2=1.555
r356 (  100 119 ) resistor r=45.1352 //w=0.168 //l=0.173853 //layer=ply \
 //thickness=0.18 //x=73.45 //y=1.055 //x2=73.49 //y2=0.9
r357 (  100 101 ) resistor r=176.904 //w=0.094 //l=0.345 //layer=ply \
 //thickness=0.18 //x=73.45 //y=1.055 //x2=73.45 //y2=1.4
r358 (  99 116 ) resistor r=592.245 //w=0.094 //l=1.155 //layer=ply \
 //thickness=0.18 //x=74.39 //y=6.2 //x2=74.39 //y2=5.045
r359 (  98 109 ) resistor r=592.245 //w=0.094 //l=1.155 //layer=ply \
 //thickness=0.18 //x=73.95 //y=6.2 //x2=73.95 //y2=5.045
r360 (  97 106 ) resistor r=56.4043 //w=0.094 //l=0.11 //layer=ply \
 //thickness=0.18 //x=73.715 //y=1.555 //x2=73.825 //y2=1.555
r361 (  97 107 ) resistor r=56.4043 //w=0.094 //l=0.11 //layer=ply \
 //thickness=0.18 //x=73.715 //y=1.555 //x2=73.605 //y2=1.555
r362 (  93 124 ) resistor r=152 //w=0.17 //l=0.17 //layer=licon //count=1 \
 //x=73.75 //y=4.88 //x2=73.75 //y2=4.88
r363 (  84 122 ) resistor r=152 //w=0.17 //l=0.17 //layer=licon //count=1 \
 //x=73.75 //y=2.26 //x2=73.75 //y2=2.26
r364 (  67 131 ) resistor r=23.615 //w=0.187 //l=0.345 //layer=li \
 //thickness=0.1 //x=71.12 //y=5.56 //x2=71.12 //y2=5.905
r365 (  59 130 ) resistor r=23.615 //w=0.187 //l=0.345 //layer=li \
 //thickness=0.1 //x=70.24 //y=5.56 //x2=70.24 //y2=5.905
r366 (  51 129 ) resistor r=23.615 //w=0.187 //l=0.345 //layer=li \
 //thickness=0.1 //x=69.36 //y=5.56 //x2=69.36 //y2=5.905
r367 (  43 45 ) resistor r=0.10734 //w=0.281 //l=0.16 //layer=m2 \
 //thickness=0.36 //x=72.06 //y=2.77 //x2=71.9 //y2=2.77
r368 (  42 48 ) resistor r=0.10734 //w=0.281 //l=0.16 //layer=m2 \
 //thickness=0.36 //x=73.6 //y=2.77 //x2=73.76 //y2=2.77
r369 (  42 43 ) resistor r=1.46947 //w=0.131 //l=1.54 //layer=m2 \
 //thickness=0.36 //x=73.6 //y=2.77 //x2=72.06 //y2=2.77
r370 (  41 93 ) resistor r=9.3 //w=0.17 //l=0.17 //layer=mcon //count=1 \
 //x=73.75 //y=4.88 //x2=73.75 //y2=4.88
r371 (  39 84 ) resistor r=9.3 //w=0.17 //l=0.17 //layer=mcon //count=1 \
 //x=73.75 //y=2.26 //x2=73.75 //y2=2.26
r372 (  36 48 ) resistor r=4.5 //w=0.15 //l=0.15 //layer=via1 //count=1 \
 //x=73.76 //y=2.77 //x2=73.76 //y2=2.77
r373 (  33 45 ) resistor r=4.5 //w=0.15 //l=0.15 //layer=via1 //count=1 \
 //x=71.9 //y=2.77 //x2=71.9 //y2=2.77
r374 (  31 127 ) resistor r=9.3 //w=0.17 //l=0.17 //layer=mcon //count=1 \
 //x=71.415 //y=1.19 //x2=71.415 //y2=1.19
r375 (  29 67 ) resistor r=9.3 //w=0.17 //l=0.17 //layer=mcon //count=1 \
 //x=71.12 //y=5.56 //x2=71.12 //y2=5.56
r376 (  26 59 ) resistor r=9.3 //w=0.17 //l=0.17 //layer=mcon //count=1 \
 //x=70.24 //y=5.56 //x2=70.24 //y2=5.56
r377 (  24 26 ) resistor r=0.121228 //w=0.232 //l=0.225 //layer=m1 \
 //thickness=0.36 //x=70.24 //y=5.335 //x2=70.24 //y2=5.56
r378 (  23 51 ) resistor r=9.3 //w=0.17 //l=0.17 //layer=mcon //count=1 \
 //x=69.36 //y=5.56 //x2=69.36 //y2=5.56
r379 (  21 23 ) resistor r=0.129608 //w=0.217 //l=0.225 //layer=m1 \
 //thickness=0.36 //x=69.362 //y=5.335 //x2=69.362 //y2=5.56
r380 (  20 41 ) resistor r=0.0760407 //w=0.238 //l=0.125 //layer=m1 \
 //thickness=0.36 //x=73.75 //y=4.755 //x2=73.75 //y2=4.88
r381 (  19 36 ) resistor r=0.0914072 //w=0.382 //l=0.182428 //layer=m1 \
 //thickness=0.36 //x=73.75 //y=2.93 //x2=73.702 //y2=2.77
r382 (  19 20 ) resistor r=1.74141 //w=0.131 //l=1.825 //layer=m1 \
 //thickness=0.36 //x=73.75 //y=2.93 //x2=73.75 //y2=4.755
r383 (  18 36 ) resistor r=0.0914072 //w=0.382 //l=0.182428 //layer=m1 \
 //thickness=0.36 //x=73.75 //y=2.61 //x2=73.702 //y2=2.77
r384 (  17 39 ) resistor r=0.0719237 //w=0.222 //l=0.115 //layer=m1 \
 //thickness=0.36 //x=73.75 //y=2.375 //x2=73.75 //y2=2.26
r385 (  17 18 ) resistor r=0.224237 //w=0.131 //l=0.235 //layer=m1 \
 //thickness=0.36 //x=73.75 //y=2.375 //x2=73.75 //y2=2.61
r386 (  15 33 ) resistor r=0.0911593 //w=0.376 //l=0.184174 //layer=m1 \
 //thickness=0.36 //x=71.9 //y=2.93 //x2=71.952 //y2=2.77
r387 (  15 16 ) resistor r=2.21374 //w=0.131 //l=2.32 //layer=m1 \
 //thickness=0.36 //x=71.9 //y=2.93 //x2=71.9 //y2=5.25
r388 (  14 33 ) resistor r=0.0911593 //w=0.376 //l=0.184174 //layer=m1 \
 //thickness=0.36 //x=71.9 //y=2.61 //x2=71.952 //y2=2.77
r389 (  13 14 ) resistor r=0.648855 //w=0.131 //l=0.68 //layer=m1 \
 //thickness=0.36 //x=71.9 //y=1.93 //x2=71.9 //y2=2.61
r390 (  11 13 ) resistor r=0.0698411 //w=0.17 //l=0.120208 //layer=m1 \
 //thickness=0.36 //x=71.815 //y=1.845 //x2=71.9 //y2=1.93
r391 (  11 12 ) resistor r=0.300573 //w=0.131 //l=0.315 //layer=m1 \
 //thickness=0.36 //x=71.815 //y=1.845 //x2=71.5 //y2=1.845
r392 (  10 12 ) resistor r=0.0698411 //w=0.17 //l=0.120208 //layer=m1 \
 //thickness=0.36 //x=71.415 //y=1.76 //x2=71.5 //y2=1.845
r393 (  9 31 ) resistor r=0.0717383 //w=0.224 //l=0.115 //layer=m1 \
 //thickness=0.36 //x=71.415 //y=1.305 //x2=71.415 //y2=1.19
r394 (  9 10 ) resistor r=0.43416 //w=0.131 //l=0.455 //layer=m1 \
 //thickness=0.36 //x=71.415 //y=1.305 //x2=71.415 //y2=1.76
r395 (  8 27 ) resistor r=0.0675342 //w=0.23 //l=0.115 //layer=m1 \
 //thickness=0.36 //x=71.235 //y=5.335 //x2=71.12 //y2=5.335
r396 (  7 16 ) resistor r=0.0698411 //w=0.17 //l=0.120208 //layer=m1 \
 //thickness=0.36 //x=71.815 //y=5.335 //x2=71.9 //y2=5.25
r397 (  7 8 ) resistor r=0.553435 //w=0.131 //l=0.58 //layer=m1 \
 //thickness=0.36 //x=71.815 //y=5.335 //x2=71.235 //y2=5.335
r398 (  6 29 ) resistor r=0.00118313 //w=0.23 //layer=m1 //thickness=0.36 \
 //x=71.12 //y=5.56 //x2=71.12 //y2=5.56
r399 (  5 27 ) resistor r=0.002872 //w=0.34 //l=0.085 //layer=m1 \
 //thickness=0.36 //x=71.12 //y=5.42 //x2=71.12 //y2=5.335
r400 (  5 6 ) resistor r=0.091623 //w=0.191 //l=0.14 //layer=m1 \
 //thickness=0.36 //x=71.12 //y=5.42 //x2=71.12 //y2=5.56
r401 (  4 24 ) resistor r=0.0262263 //w=0.232 //l=0.12 //layer=m1 \
 //thickness=0.36 //x=70.36 //y=5.335 //x2=70.24 //y2=5.335
r402 (  3 27 ) resistor r=0.0675342 //w=0.23 //l=0.115 //layer=m1 \
 //thickness=0.36 //x=71.005 //y=5.335 //x2=71.12 //y2=5.335
r403 (  3 4 ) resistor r=0.615458 //w=0.131 //l=0.645 //layer=m1 \
 //thickness=0.36 //x=71.005 //y=5.335 //x2=70.36 //y2=5.335
r404 (  2 21 ) resistor r=0.0222262 //w=0.217 //l=0.118 //layer=m1 \
 //thickness=0.36 //x=69.48 //y=5.335 //x2=69.362 //y2=5.335
r405 (  1 24 ) resistor r=0.0262263 //w=0.232 //l=0.12 //layer=m1 \
 //thickness=0.36 //x=70.12 //y=5.335 //x2=70.24 //y2=5.335
r406 (  1 2 ) resistor r=0.610687 //w=0.131 //l=0.64 //layer=m1 \
 //thickness=0.36 //x=70.12 //y=5.335 //x2=69.48 //y2=5.335
ends PM_TMRDFFSNRNQNX1\%noxref_14

subckt PM_TMRDFFSNRNQNX1\%CLK ( 1 2 3 4 5 6 7 8 9 10 11 12 13 18 22 26 30 33 \
 40 46 52 58 64 70 73 75 77 79 81 83 86 91 96 101 106 110 115 120 125 130 135 \
 140 145 150 155 160 165 169 170 171 172 173 174 175 176 177 178 179 180 181 \
 182 183 184 185 186 187 188 189 191 197 198 199 200 201 206 207 208 210 216 \
 217 218 219 220 225 226 227 229 235 236 237 238 239 244 245 246 248 254 255 \
 256 257 258 263 264 265 267 273 274 275 276 277 282 283 284 286 292 293 294 \
 295 296 304 315 326 337 348 359 )
c961 ( 359 0 ) capacitor c=0.0357436f //x=74.86 //y=4.88
c962 ( 348 0 ) capacitor c=0.0357436f //x=65.24 //y=4.88
c963 ( 337 0 ) capacitor c=0.0357436f //x=46 //y=4.88
c964 ( 326 0 ) capacitor c=0.0357445f //x=36.38 //y=4.88
c965 ( 315 0 ) capacitor c=0.0357436f //x=17.14 //y=4.88
c966 ( 304 0 ) capacitor c=0.0357436f //x=7.52 //y=4.88
c967 ( 296 0 ) capacitor c=0.0305218f //x=75.195 //y=4.97
c968 ( 295 0 ) capacitor c=0.0863671f //x=74.95 //y=2.095
c969 ( 294 0 ) capacitor c=0.0170266f //x=74.95 //y=1.63
c970 ( 293 0 ) capacitor c=0.018609f //x=74.95 //y=1.4
c971 ( 292 0 ) capacitor c=0.0186599f //x=74.95 //y=1.09
c972 ( 286 0 ) capacitor c=0.0146988f //x=74.795 //y=1.555
c973 ( 284 0 ) capacitor c=0.0148531f //x=74.795 //y=0.935
c974 ( 283 0 ) capacitor c=0.0334406f //x=74.425 //y=1.4
c975 ( 282 0 ) capacitor c=0.0173191f //x=74.425 //y=1.09
c976 ( 277 0 ) capacitor c=0.0306608f //x=65.575 //y=4.97
c977 ( 276 0 ) capacitor c=0.0863671f //x=65.33 //y=2.095
c978 ( 275 0 ) capacitor c=0.0170266f //x=65.33 //y=1.63
c979 ( 274 0 ) capacitor c=0.018609f //x=65.33 //y=1.4
c980 ( 273 0 ) capacitor c=0.0186599f //x=65.33 //y=1.09
c981 ( 267 0 ) capacitor c=0.0146988f //x=65.175 //y=1.555
c982 ( 265 0 ) capacitor c=0.0148531f //x=65.175 //y=0.935
c983 ( 264 0 ) capacitor c=0.0334406f //x=64.805 //y=1.4
c984 ( 263 0 ) capacitor c=0.0173191f //x=64.805 //y=1.09
c985 ( 258 0 ) capacitor c=0.0305218f //x=46.335 //y=4.97
c986 ( 257 0 ) capacitor c=0.0863671f //x=46.09 //y=2.095
c987 ( 256 0 ) capacitor c=0.0170266f //x=46.09 //y=1.63
c988 ( 255 0 ) capacitor c=0.018609f //x=46.09 //y=1.4
c989 ( 254 0 ) capacitor c=0.0186599f //x=46.09 //y=1.09
c990 ( 248 0 ) capacitor c=0.0146988f //x=45.935 //y=1.555
c991 ( 246 0 ) capacitor c=0.0148531f //x=45.935 //y=0.935
c992 ( 245 0 ) capacitor c=0.0334406f //x=45.565 //y=1.4
c993 ( 244 0 ) capacitor c=0.0173191f //x=45.565 //y=1.09
c994 ( 239 0 ) capacitor c=0.0306608f //x=36.715 //y=4.97
c995 ( 238 0 ) capacitor c=0.0863671f //x=36.47 //y=2.095
c996 ( 237 0 ) capacitor c=0.0170266f //x=36.47 //y=1.63
c997 ( 236 0 ) capacitor c=0.018609f //x=36.47 //y=1.4
c998 ( 235 0 ) capacitor c=0.0186599f //x=36.47 //y=1.09
c999 ( 229 0 ) capacitor c=0.0146988f //x=36.315 //y=1.555
c1000 ( 227 0 ) capacitor c=0.0148531f //x=36.315 //y=0.935
c1001 ( 226 0 ) capacitor c=0.0334406f //x=35.945 //y=1.4
c1002 ( 225 0 ) capacitor c=0.0173191f //x=35.945 //y=1.09
c1003 ( 220 0 ) capacitor c=0.0305218f //x=17.475 //y=4.97
c1004 ( 219 0 ) capacitor c=0.0863671f //x=17.23 //y=2.095
c1005 ( 218 0 ) capacitor c=0.0170266f //x=17.23 //y=1.63
c1006 ( 217 0 ) capacitor c=0.018609f //x=17.23 //y=1.4
c1007 ( 216 0 ) capacitor c=0.0186599f //x=17.23 //y=1.09
c1008 ( 210 0 ) capacitor c=0.0146988f //x=17.075 //y=1.555
c1009 ( 208 0 ) capacitor c=0.0148531f //x=17.075 //y=0.935
c1010 ( 207 0 ) capacitor c=0.0334406f //x=16.705 //y=1.4
c1011 ( 206 0 ) capacitor c=0.0173191f //x=16.705 //y=1.09
c1012 ( 201 0 ) capacitor c=0.0306608f //x=7.855 //y=4.97
c1013 ( 200 0 ) capacitor c=0.0863671f //x=7.61 //y=2.095
c1014 ( 199 0 ) capacitor c=0.0170266f //x=7.61 //y=1.63
c1015 ( 198 0 ) capacitor c=0.018609f //x=7.61 //y=1.4
c1016 ( 197 0 ) capacitor c=0.0186599f //x=7.61 //y=1.09
c1017 ( 191 0 ) capacitor c=0.0146988f //x=7.455 //y=1.555
c1018 ( 189 0 ) capacitor c=0.0148531f //x=7.455 //y=0.935
c1019 ( 188 0 ) capacitor c=0.0334406f //x=7.085 //y=1.4
c1020 ( 187 0 ) capacitor c=0.0173191f //x=7.085 //y=1.09
c1021 ( 186 0 ) capacitor c=0.110348f //x=75.27 //y=6.2
c1022 ( 185 0 ) capacitor c=0.110214f //x=74.83 //y=6.2
c1023 ( 184 0 ) capacitor c=0.110321f //x=65.65 //y=6.2
c1024 ( 183 0 ) capacitor c=0.110214f //x=65.21 //y=6.2
c1025 ( 182 0 ) capacitor c=0.110317f //x=46.41 //y=6.2
c1026 ( 181 0 ) capacitor c=0.110214f //x=45.97 //y=6.2
c1027 ( 180 0 ) capacitor c=0.110247f //x=36.79 //y=6.2
c1028 ( 179 0 ) capacitor c=0.110255f //x=36.35 //y=6.2
c1029 ( 178 0 ) capacitor c=0.110208f //x=17.55 //y=6.2
c1030 ( 177 0 ) capacitor c=0.110214f //x=17.11 //y=6.2
c1031 ( 176 0 ) capacitor c=0.110208f //x=7.93 //y=6.2
c1032 ( 175 0 ) capacitor c=0.110214f //x=7.49 //y=6.2
c1033 ( 165 0 ) capacitor c=0.00129935f //x=74.86 //y=4.88
c1034 ( 160 0 ) capacitor c=0.00121786f //x=74.86 //y=2.26
c1035 ( 155 0 ) capacitor c=0.00129935f //x=65.24 //y=4.88
c1036 ( 150 0 ) capacitor c=0.00121786f //x=65.24 //y=2.26
c1037 ( 145 0 ) capacitor c=0.00129935f //x=46 //y=4.88
c1038 ( 140 0 ) capacitor c=0.00121786f //x=46 //y=2.26
c1039 ( 135 0 ) capacitor c=0.00129935f //x=36.38 //y=4.88
c1040 ( 130 0 ) capacitor c=0.00121786f //x=36.38 //y=2.26
c1041 ( 125 0 ) capacitor c=0.00129935f //x=17.14 //y=4.88
c1042 ( 120 0 ) capacitor c=0.00121786f //x=17.14 //y=2.26
c1043 ( 115 0 ) capacitor c=0.00129935f //x=7.52 //y=4.88
c1044 ( 110 0 ) capacitor c=0.00121786f //x=7.52 //y=2.26
c1045 ( 106 0 ) capacitor c=0.00133493f //x=74.865 //y=4.62
c1046 ( 101 0 ) capacitor c=0.00199937f //x=65.235 //y=4.62
c1047 ( 96 0 ) capacitor c=0.00155307f //x=46.005 //y=4.62
c1048 ( 91 0 ) capacitor c=0.00158028f //x=36.375 //y=4.62
c1049 ( 86 0 ) capacitor c=0.00466776f //x=17.145 //y=4.62
c1050 ( 83 0 ) capacitor c=0.0105362f //x=7.515 //y=4.62
c1051 ( 81 0 ) capacitor c=0.0883858f //x=74.705 //y=4.62
c1052 ( 79 0 ) capacitor c=0.194139f //x=65.075 //y=4.62
c1053 ( 77 0 ) capacitor c=0.0880393f //x=45.845 //y=4.62
c1054 ( 75 0 ) capacitor c=0.269087f //x=36.215 //y=4.62
c1055 ( 73 0 ) capacitor c=0.232869f //x=16.985 //y=4.62
c1056 ( 70 0 ) capacitor c=0.00773203f //x=74.865 //y=4.835
c1057 ( 64 0 ) capacitor c=0.00797644f //x=65.235 //y=4.835
c1058 ( 58 0 ) capacitor c=0.0077321f //x=46.005 //y=4.835
c1059 ( 52 0 ) capacitor c=0.00786592f //x=36.375 //y=4.835
c1060 ( 46 0 ) capacitor c=0.0077588f //x=17.145 //y=4.835
c1061 ( 40 0 ) capacitor c=0.00779217f //x=7.515 //y=4.835
c1062 ( 33 0 ) capacitor c=0.00378707f //x=74.86 //y=2.375
c1063 ( 30 0 ) capacitor c=0.00380207f //x=65.24 //y=2.375
c1064 ( 26 0 ) capacitor c=0.00378707f //x=46 //y=2.375
c1065 ( 22 0 ) capacitor c=0.00380207f //x=36.38 //y=2.375
c1066 ( 18 0 ) capacitor c=0.00378707f //x=17.14 //y=2.375
c1067 ( 13 0 ) capacitor c=0.00380207f //x=7.52 //y=2.375
c1068 ( 11 0 ) capacitor c=0.0617495f //x=74.86 //y=2.77
c1069 ( 10 0 ) capacitor c=0.0599742f //x=65.24 //y=4.62
c1070 ( 8 0 ) capacitor c=0.0617495f //x=46 //y=2.77
c1071 ( 6 0 ) capacitor c=0.0604929f //x=36.38 //y=3.88
c1072 ( 4 0 ) capacitor c=0.0617495f //x=17.14 //y=2.77
c1073 ( 1 0 ) capacitor c=0.0633306f //x=7.52 //y=3.14
r1074 (  361 362 ) resistor r=32.4568 //w=0.214 //l=0.075 //layer=ply \
 //thickness=0.18 //x=74.86 //y=4.97 //x2=74.86 //y2=5.045
r1075 (  359 361 ) resistor r=20.271 //w=0.214 //l=0.09 //layer=ply \
 //thickness=0.18 //x=74.86 //y=4.88 //x2=74.86 //y2=4.97
r1076 (  350 351 ) resistor r=32.4568 //w=0.214 //l=0.075 //layer=ply \
 //thickness=0.18 //x=65.24 //y=4.97 //x2=65.24 //y2=5.045
r1077 (  348 350 ) resistor r=20.271 //w=0.214 //l=0.09 //layer=ply \
 //thickness=0.18 //x=65.24 //y=4.88 //x2=65.24 //y2=4.97
r1078 (  339 340 ) resistor r=32.4568 //w=0.214 //l=0.075 //layer=ply \
 //thickness=0.18 //x=46 //y=4.97 //x2=46 //y2=5.045
r1079 (  337 339 ) resistor r=20.271 //w=0.214 //l=0.09 //layer=ply \
 //thickness=0.18 //x=46 //y=4.88 //x2=46 //y2=4.97
r1080 (  328 329 ) resistor r=32.4568 //w=0.214 //l=0.075 //layer=ply \
 //thickness=0.18 //x=36.38 //y=4.97 //x2=36.38 //y2=5.045
r1081 (  326 328 ) resistor r=20.271 //w=0.214 //l=0.09 //layer=ply \
 //thickness=0.18 //x=36.38 //y=4.88 //x2=36.38 //y2=4.97
r1082 (  317 318 ) resistor r=32.4568 //w=0.214 //l=0.075 //layer=ply \
 //thickness=0.18 //x=17.14 //y=4.97 //x2=17.14 //y2=5.045
r1083 (  315 317 ) resistor r=20.271 //w=0.214 //l=0.09 //layer=ply \
 //thickness=0.18 //x=17.14 //y=4.88 //x2=17.14 //y2=4.97
r1084 (  306 307 ) resistor r=32.4568 //w=0.214 //l=0.075 //layer=ply \
 //thickness=0.18 //x=7.52 //y=4.97 //x2=7.52 //y2=5.045
r1085 (  304 306 ) resistor r=20.271 //w=0.214 //l=0.09 //layer=ply \
 //thickness=0.18 //x=7.52 //y=4.88 //x2=7.52 //y2=4.97
r1086 (  297 361 ) resistor r=16.5046 //w=0.27 //l=0.135 //layer=ply \
 //thickness=0.18 //x=74.995 //y=4.97 //x2=74.86 //y2=4.97
r1087 (  296 298 ) resistor r=26.9307 //w=0.15 //l=0.106066 //layer=ply \
 //thickness=0.18 //x=75.195 //y=4.97 //x2=75.27 //y2=5.045
r1088 (  296 297 ) resistor r=102.553 //w=0.094 //l=0.2 //layer=ply \
 //thickness=0.18 //x=75.195 //y=4.97 //x2=74.995 //y2=4.97
r1089 (  295 366 ) resistor r=38.6777 //w=0.284 //l=0.198997 //layer=ply \
 //thickness=0.18 //x=74.95 //y=2.095 //x2=74.875 //y2=2.26
r1090 (  294 364 ) resistor r=21.2976 //w=0.217 //l=0.0928709 //layer=ply \
 //thickness=0.18 //x=74.95 //y=1.63 //x2=74.91 //y2=1.555
r1091 (  294 295 ) resistor r=238.436 //w=0.094 //l=0.465 //layer=ply \
 //thickness=0.18 //x=74.95 //y=1.63 //x2=74.95 //y2=2.095
r1092 (  293 364 ) resistor r=39.0671 //w=0.217 //l=0.173853 //layer=ply \
 //thickness=0.18 //x=74.95 //y=1.4 //x2=74.91 //y2=1.555
r1093 (  292 363 ) resistor r=45.1352 //w=0.168 //l=0.173853 //layer=ply \
 //thickness=0.18 //x=74.95 //y=1.09 //x2=74.91 //y2=0.935
r1094 (  292 293 ) resistor r=158.957 //w=0.094 //l=0.31 //layer=ply \
 //thickness=0.18 //x=74.95 //y=1.09 //x2=74.95 //y2=1.4
r1095 (  287 357 ) resistor r=5.52526 //w=0.168 //l=0.115 //layer=ply \
 //thickness=0.18 //x=74.58 //y=1.555 //x2=74.465 //y2=1.555
r1096 (  286 364 ) resistor r=11.4558 //w=0.217 //l=0.115 //layer=ply \
 //thickness=0.18 //x=74.795 //y=1.555 //x2=74.91 //y2=1.555
r1097 (  285 356 ) resistor r=5.52526 //w=0.168 //l=0.115 //layer=ply \
 //thickness=0.18 //x=74.58 //y=0.935 //x2=74.465 //y2=0.935
r1098 (  284 363 ) resistor r=5.52526 //w=0.168 //l=0.115 //layer=ply \
 //thickness=0.18 //x=74.795 //y=0.935 //x2=74.91 //y2=0.935
r1099 (  284 285 ) resistor r=110.245 //w=0.094 //l=0.215 //layer=ply \
 //thickness=0.18 //x=74.795 //y=0.935 //x2=74.58 //y2=0.935
r1100 (  283 357 ) resistor r=45.1352 //w=0.168 //l=0.173853 //layer=ply \
 //thickness=0.18 //x=74.425 //y=1.4 //x2=74.465 //y2=1.555
r1101 (  282 356 ) resistor r=45.1352 //w=0.168 //l=0.173853 //layer=ply \
 //thickness=0.18 //x=74.425 //y=1.09 //x2=74.465 //y2=0.935
r1102 (  282 283 ) resistor r=158.957 //w=0.094 //l=0.31 //layer=ply \
 //thickness=0.18 //x=74.425 //y=1.09 //x2=74.425 //y2=1.4
r1103 (  278 350 ) resistor r=16.5046 //w=0.27 //l=0.135 //layer=ply \
 //thickness=0.18 //x=65.375 //y=4.97 //x2=65.24 //y2=4.97
r1104 (  277 279 ) resistor r=26.9307 //w=0.15 //l=0.106066 //layer=ply \
 //thickness=0.18 //x=65.575 //y=4.97 //x2=65.65 //y2=5.045
r1105 (  277 278 ) resistor r=102.553 //w=0.094 //l=0.2 //layer=ply \
 //thickness=0.18 //x=65.575 //y=4.97 //x2=65.375 //y2=4.97
r1106 (  276 355 ) resistor r=38.6777 //w=0.284 //l=0.198997 //layer=ply \
 //thickness=0.18 //x=65.33 //y=2.095 //x2=65.255 //y2=2.26
r1107 (  275 353 ) resistor r=21.2976 //w=0.217 //l=0.0928709 //layer=ply \
 //thickness=0.18 //x=65.33 //y=1.63 //x2=65.29 //y2=1.555
r1108 (  275 276 ) resistor r=238.436 //w=0.094 //l=0.465 //layer=ply \
 //thickness=0.18 //x=65.33 //y=1.63 //x2=65.33 //y2=2.095
r1109 (  274 353 ) resistor r=39.0671 //w=0.217 //l=0.173853 //layer=ply \
 //thickness=0.18 //x=65.33 //y=1.4 //x2=65.29 //y2=1.555
r1110 (  273 352 ) resistor r=45.1352 //w=0.168 //l=0.173853 //layer=ply \
 //thickness=0.18 //x=65.33 //y=1.09 //x2=65.29 //y2=0.935
r1111 (  273 274 ) resistor r=158.957 //w=0.094 //l=0.31 //layer=ply \
 //thickness=0.18 //x=65.33 //y=1.09 //x2=65.33 //y2=1.4
r1112 (  268 346 ) resistor r=5.52526 //w=0.168 //l=0.115 //layer=ply \
 //thickness=0.18 //x=64.96 //y=1.555 //x2=64.845 //y2=1.555
r1113 (  267 353 ) resistor r=11.4558 //w=0.217 //l=0.115 //layer=ply \
 //thickness=0.18 //x=65.175 //y=1.555 //x2=65.29 //y2=1.555
r1114 (  266 345 ) resistor r=5.52526 //w=0.168 //l=0.115 //layer=ply \
 //thickness=0.18 //x=64.96 //y=0.935 //x2=64.845 //y2=0.935
r1115 (  265 352 ) resistor r=5.52526 //w=0.168 //l=0.115 //layer=ply \
 //thickness=0.18 //x=65.175 //y=0.935 //x2=65.29 //y2=0.935
r1116 (  265 266 ) resistor r=110.245 //w=0.094 //l=0.215 //layer=ply \
 //thickness=0.18 //x=65.175 //y=0.935 //x2=64.96 //y2=0.935
r1117 (  264 346 ) resistor r=45.1352 //w=0.168 //l=0.173853 //layer=ply \
 //thickness=0.18 //x=64.805 //y=1.4 //x2=64.845 //y2=1.555
r1118 (  263 345 ) resistor r=45.1352 //w=0.168 //l=0.173853 //layer=ply \
 //thickness=0.18 //x=64.805 //y=1.09 //x2=64.845 //y2=0.935
r1119 (  263 264 ) resistor r=158.957 //w=0.094 //l=0.31 //layer=ply \
 //thickness=0.18 //x=64.805 //y=1.09 //x2=64.805 //y2=1.4
r1120 (  259 339 ) resistor r=16.5046 //w=0.27 //l=0.135 //layer=ply \
 //thickness=0.18 //x=46.135 //y=4.97 //x2=46 //y2=4.97
r1121 (  258 260 ) resistor r=26.9307 //w=0.15 //l=0.106066 //layer=ply \
 //thickness=0.18 //x=46.335 //y=4.97 //x2=46.41 //y2=5.045
r1122 (  258 259 ) resistor r=102.553 //w=0.094 //l=0.2 //layer=ply \
 //thickness=0.18 //x=46.335 //y=4.97 //x2=46.135 //y2=4.97
r1123 (  257 344 ) resistor r=38.6777 //w=0.284 //l=0.198997 //layer=ply \
 //thickness=0.18 //x=46.09 //y=2.095 //x2=46.015 //y2=2.26
r1124 (  256 342 ) resistor r=21.2976 //w=0.217 //l=0.0928709 //layer=ply \
 //thickness=0.18 //x=46.09 //y=1.63 //x2=46.05 //y2=1.555
r1125 (  256 257 ) resistor r=238.436 //w=0.094 //l=0.465 //layer=ply \
 //thickness=0.18 //x=46.09 //y=1.63 //x2=46.09 //y2=2.095
r1126 (  255 342 ) resistor r=39.0671 //w=0.217 //l=0.173853 //layer=ply \
 //thickness=0.18 //x=46.09 //y=1.4 //x2=46.05 //y2=1.555
r1127 (  254 341 ) resistor r=45.1352 //w=0.168 //l=0.173853 //layer=ply \
 //thickness=0.18 //x=46.09 //y=1.09 //x2=46.05 //y2=0.935
r1128 (  254 255 ) resistor r=158.957 //w=0.094 //l=0.31 //layer=ply \
 //thickness=0.18 //x=46.09 //y=1.09 //x2=46.09 //y2=1.4
r1129 (  249 335 ) resistor r=5.52526 //w=0.168 //l=0.115 //layer=ply \
 //thickness=0.18 //x=45.72 //y=1.555 //x2=45.605 //y2=1.555
r1130 (  248 342 ) resistor r=11.4558 //w=0.217 //l=0.115 //layer=ply \
 //thickness=0.18 //x=45.935 //y=1.555 //x2=46.05 //y2=1.555
r1131 (  247 334 ) resistor r=5.52526 //w=0.168 //l=0.115 //layer=ply \
 //thickness=0.18 //x=45.72 //y=0.935 //x2=45.605 //y2=0.935
r1132 (  246 341 ) resistor r=5.52526 //w=0.168 //l=0.115 //layer=ply \
 //thickness=0.18 //x=45.935 //y=0.935 //x2=46.05 //y2=0.935
r1133 (  246 247 ) resistor r=110.245 //w=0.094 //l=0.215 //layer=ply \
 //thickness=0.18 //x=45.935 //y=0.935 //x2=45.72 //y2=0.935
r1134 (  245 335 ) resistor r=45.1352 //w=0.168 //l=0.173853 //layer=ply \
 //thickness=0.18 //x=45.565 //y=1.4 //x2=45.605 //y2=1.555
r1135 (  244 334 ) resistor r=45.1352 //w=0.168 //l=0.173853 //layer=ply \
 //thickness=0.18 //x=45.565 //y=1.09 //x2=45.605 //y2=0.935
r1136 (  244 245 ) resistor r=158.957 //w=0.094 //l=0.31 //layer=ply \
 //thickness=0.18 //x=45.565 //y=1.09 //x2=45.565 //y2=1.4
r1137 (  240 328 ) resistor r=16.5046 //w=0.27 //l=0.135 //layer=ply \
 //thickness=0.18 //x=36.515 //y=4.97 //x2=36.38 //y2=4.97
r1138 (  239 241 ) resistor r=26.9307 //w=0.15 //l=0.106066 //layer=ply \
 //thickness=0.18 //x=36.715 //y=4.97 //x2=36.79 //y2=5.045
r1139 (  239 240 ) resistor r=102.553 //w=0.094 //l=0.2 //layer=ply \
 //thickness=0.18 //x=36.715 //y=4.97 //x2=36.515 //y2=4.97
r1140 (  238 333 ) resistor r=38.6777 //w=0.284 //l=0.198997 //layer=ply \
 //thickness=0.18 //x=36.47 //y=2.095 //x2=36.395 //y2=2.26
r1141 (  237 331 ) resistor r=21.2976 //w=0.217 //l=0.0928709 //layer=ply \
 //thickness=0.18 //x=36.47 //y=1.63 //x2=36.43 //y2=1.555
r1142 (  237 238 ) resistor r=238.436 //w=0.094 //l=0.465 //layer=ply \
 //thickness=0.18 //x=36.47 //y=1.63 //x2=36.47 //y2=2.095
r1143 (  236 331 ) resistor r=39.0671 //w=0.217 //l=0.173853 //layer=ply \
 //thickness=0.18 //x=36.47 //y=1.4 //x2=36.43 //y2=1.555
r1144 (  235 330 ) resistor r=45.1352 //w=0.168 //l=0.173853 //layer=ply \
 //thickness=0.18 //x=36.47 //y=1.09 //x2=36.43 //y2=0.935
r1145 (  235 236 ) resistor r=158.957 //w=0.094 //l=0.31 //layer=ply \
 //thickness=0.18 //x=36.47 //y=1.09 //x2=36.47 //y2=1.4
r1146 (  230 324 ) resistor r=5.52526 //w=0.168 //l=0.115 //layer=ply \
 //thickness=0.18 //x=36.1 //y=1.555 //x2=35.985 //y2=1.555
r1147 (  229 331 ) resistor r=11.4558 //w=0.217 //l=0.115 //layer=ply \
 //thickness=0.18 //x=36.315 //y=1.555 //x2=36.43 //y2=1.555
r1148 (  228 323 ) resistor r=5.52526 //w=0.168 //l=0.115 //layer=ply \
 //thickness=0.18 //x=36.1 //y=0.935 //x2=35.985 //y2=0.935
r1149 (  227 330 ) resistor r=5.52526 //w=0.168 //l=0.115 //layer=ply \
 //thickness=0.18 //x=36.315 //y=0.935 //x2=36.43 //y2=0.935
r1150 (  227 228 ) resistor r=110.245 //w=0.094 //l=0.215 //layer=ply \
 //thickness=0.18 //x=36.315 //y=0.935 //x2=36.1 //y2=0.935
r1151 (  226 324 ) resistor r=45.1352 //w=0.168 //l=0.173853 //layer=ply \
 //thickness=0.18 //x=35.945 //y=1.4 //x2=35.985 //y2=1.555
r1152 (  225 323 ) resistor r=45.1352 //w=0.168 //l=0.173853 //layer=ply \
 //thickness=0.18 //x=35.945 //y=1.09 //x2=35.985 //y2=0.935
r1153 (  225 226 ) resistor r=158.957 //w=0.094 //l=0.31 //layer=ply \
 //thickness=0.18 //x=35.945 //y=1.09 //x2=35.945 //y2=1.4
r1154 (  221 317 ) resistor r=16.5046 //w=0.27 //l=0.135 //layer=ply \
 //thickness=0.18 //x=17.275 //y=4.97 //x2=17.14 //y2=4.97
r1155 (  220 222 ) resistor r=26.9307 //w=0.15 //l=0.106066 //layer=ply \
 //thickness=0.18 //x=17.475 //y=4.97 //x2=17.55 //y2=5.045
r1156 (  220 221 ) resistor r=102.553 //w=0.094 //l=0.2 //layer=ply \
 //thickness=0.18 //x=17.475 //y=4.97 //x2=17.275 //y2=4.97
r1157 (  219 322 ) resistor r=38.6777 //w=0.284 //l=0.198997 //layer=ply \
 //thickness=0.18 //x=17.23 //y=2.095 //x2=17.155 //y2=2.26
r1158 (  218 320 ) resistor r=21.2976 //w=0.217 //l=0.0928709 //layer=ply \
 //thickness=0.18 //x=17.23 //y=1.63 //x2=17.19 //y2=1.555
r1159 (  218 219 ) resistor r=238.436 //w=0.094 //l=0.465 //layer=ply \
 //thickness=0.18 //x=17.23 //y=1.63 //x2=17.23 //y2=2.095
r1160 (  217 320 ) resistor r=39.0671 //w=0.217 //l=0.173853 //layer=ply \
 //thickness=0.18 //x=17.23 //y=1.4 //x2=17.19 //y2=1.555
r1161 (  216 319 ) resistor r=45.1352 //w=0.168 //l=0.173853 //layer=ply \
 //thickness=0.18 //x=17.23 //y=1.09 //x2=17.19 //y2=0.935
r1162 (  216 217 ) resistor r=158.957 //w=0.094 //l=0.31 //layer=ply \
 //thickness=0.18 //x=17.23 //y=1.09 //x2=17.23 //y2=1.4
r1163 (  211 313 ) resistor r=5.52526 //w=0.168 //l=0.115 //layer=ply \
 //thickness=0.18 //x=16.86 //y=1.555 //x2=16.745 //y2=1.555
r1164 (  210 320 ) resistor r=11.4558 //w=0.217 //l=0.115 //layer=ply \
 //thickness=0.18 //x=17.075 //y=1.555 //x2=17.19 //y2=1.555
r1165 (  209 312 ) resistor r=5.52526 //w=0.168 //l=0.115 //layer=ply \
 //thickness=0.18 //x=16.86 //y=0.935 //x2=16.745 //y2=0.935
r1166 (  208 319 ) resistor r=5.52526 //w=0.168 //l=0.115 //layer=ply \
 //thickness=0.18 //x=17.075 //y=0.935 //x2=17.19 //y2=0.935
r1167 (  208 209 ) resistor r=110.245 //w=0.094 //l=0.215 //layer=ply \
 //thickness=0.18 //x=17.075 //y=0.935 //x2=16.86 //y2=0.935
r1168 (  207 313 ) resistor r=45.1352 //w=0.168 //l=0.173853 //layer=ply \
 //thickness=0.18 //x=16.705 //y=1.4 //x2=16.745 //y2=1.555
r1169 (  206 312 ) resistor r=45.1352 //w=0.168 //l=0.173853 //layer=ply \
 //thickness=0.18 //x=16.705 //y=1.09 //x2=16.745 //y2=0.935
r1170 (  206 207 ) resistor r=158.957 //w=0.094 //l=0.31 //layer=ply \
 //thickness=0.18 //x=16.705 //y=1.09 //x2=16.705 //y2=1.4
r1171 (  202 306 ) resistor r=16.5046 //w=0.27 //l=0.135 //layer=ply \
 //thickness=0.18 //x=7.655 //y=4.97 //x2=7.52 //y2=4.97
r1172 (  201 203 ) resistor r=26.9307 //w=0.15 //l=0.106066 //layer=ply \
 //thickness=0.18 //x=7.855 //y=4.97 //x2=7.93 //y2=5.045
r1173 (  201 202 ) resistor r=102.553 //w=0.094 //l=0.2 //layer=ply \
 //thickness=0.18 //x=7.855 //y=4.97 //x2=7.655 //y2=4.97
r1174 (  200 311 ) resistor r=38.6777 //w=0.284 //l=0.198997 //layer=ply \
 //thickness=0.18 //x=7.61 //y=2.095 //x2=7.535 //y2=2.26
r1175 (  199 309 ) resistor r=21.2976 //w=0.217 //l=0.0928709 //layer=ply \
 //thickness=0.18 //x=7.61 //y=1.63 //x2=7.57 //y2=1.555
r1176 (  199 200 ) resistor r=238.436 //w=0.094 //l=0.465 //layer=ply \
 //thickness=0.18 //x=7.61 //y=1.63 //x2=7.61 //y2=2.095
r1177 (  198 309 ) resistor r=39.0671 //w=0.217 //l=0.173853 //layer=ply \
 //thickness=0.18 //x=7.61 //y=1.4 //x2=7.57 //y2=1.555
r1178 (  197 308 ) resistor r=45.1352 //w=0.168 //l=0.173853 //layer=ply \
 //thickness=0.18 //x=7.61 //y=1.09 //x2=7.57 //y2=0.935
r1179 (  197 198 ) resistor r=158.957 //w=0.094 //l=0.31 //layer=ply \
 //thickness=0.18 //x=7.61 //y=1.09 //x2=7.61 //y2=1.4
r1180 (  192 302 ) resistor r=5.52526 //w=0.168 //l=0.115 //layer=ply \
 //thickness=0.18 //x=7.24 //y=1.555 //x2=7.125 //y2=1.555
r1181 (  191 309 ) resistor r=11.4558 //w=0.217 //l=0.115 //layer=ply \
 //thickness=0.18 //x=7.455 //y=1.555 //x2=7.57 //y2=1.555
r1182 (  190 301 ) resistor r=5.52526 //w=0.168 //l=0.115 //layer=ply \
 //thickness=0.18 //x=7.24 //y=0.935 //x2=7.125 //y2=0.935
r1183 (  189 308 ) resistor r=5.52526 //w=0.168 //l=0.115 //layer=ply \
 //thickness=0.18 //x=7.455 //y=0.935 //x2=7.57 //y2=0.935
r1184 (  189 190 ) resistor r=110.245 //w=0.094 //l=0.215 //layer=ply \
 //thickness=0.18 //x=7.455 //y=0.935 //x2=7.24 //y2=0.935
r1185 (  188 302 ) resistor r=45.1352 //w=0.168 //l=0.173853 //layer=ply \
 //thickness=0.18 //x=7.085 //y=1.4 //x2=7.125 //y2=1.555
r1186 (  187 301 ) resistor r=45.1352 //w=0.168 //l=0.173853 //layer=ply \
 //thickness=0.18 //x=7.085 //y=1.09 //x2=7.125 //y2=0.935
r1187 (  187 188 ) resistor r=158.957 //w=0.094 //l=0.31 //layer=ply \
 //thickness=0.18 //x=7.085 //y=1.09 //x2=7.085 //y2=1.4
r1188 (  186 298 ) resistor r=592.245 //w=0.094 //l=1.155 //layer=ply \
 //thickness=0.18 //x=75.27 //y=6.2 //x2=75.27 //y2=5.045
r1189 (  185 362 ) resistor r=592.245 //w=0.094 //l=1.155 //layer=ply \
 //thickness=0.18 //x=74.83 //y=6.2 //x2=74.83 //y2=5.045
r1190 (  184 279 ) resistor r=592.245 //w=0.094 //l=1.155 //layer=ply \
 //thickness=0.18 //x=65.65 //y=6.2 //x2=65.65 //y2=5.045
r1191 (  183 351 ) resistor r=592.245 //w=0.094 //l=1.155 //layer=ply \
 //thickness=0.18 //x=65.21 //y=6.2 //x2=65.21 //y2=5.045
r1192 (  182 260 ) resistor r=592.245 //w=0.094 //l=1.155 //layer=ply \
 //thickness=0.18 //x=46.41 //y=6.2 //x2=46.41 //y2=5.045
r1193 (  181 340 ) resistor r=592.245 //w=0.094 //l=1.155 //layer=ply \
 //thickness=0.18 //x=45.97 //y=6.2 //x2=45.97 //y2=5.045
r1194 (  180 241 ) resistor r=592.245 //w=0.094 //l=1.155 //layer=ply \
 //thickness=0.18 //x=36.79 //y=6.2 //x2=36.79 //y2=5.045
r1195 (  179 329 ) resistor r=592.245 //w=0.094 //l=1.155 //layer=ply \
 //thickness=0.18 //x=36.35 //y=6.2 //x2=36.35 //y2=5.045
r1196 (  178 222 ) resistor r=592.245 //w=0.094 //l=1.155 //layer=ply \
 //thickness=0.18 //x=17.55 //y=6.2 //x2=17.55 //y2=5.045
r1197 (  177 318 ) resistor r=592.245 //w=0.094 //l=1.155 //layer=ply \
 //thickness=0.18 //x=17.11 //y=6.2 //x2=17.11 //y2=5.045
r1198 (  176 203 ) resistor r=592.245 //w=0.094 //l=1.155 //layer=ply \
 //thickness=0.18 //x=7.93 //y=6.2 //x2=7.93 //y2=5.045
r1199 (  175 307 ) resistor r=592.245 //w=0.094 //l=1.155 //layer=ply \
 //thickness=0.18 //x=7.49 //y=6.2 //x2=7.49 //y2=5.045
r1200 (  174 286 ) resistor r=55.3787 //w=0.094 //l=0.108 //layer=ply \
 //thickness=0.18 //x=74.687 //y=1.555 //x2=74.795 //y2=1.555
r1201 (  174 287 ) resistor r=54.866 //w=0.094 //l=0.107 //layer=ply \
 //thickness=0.18 //x=74.687 //y=1.555 //x2=74.58 //y2=1.555
r1202 (  173 267 ) resistor r=55.3787 //w=0.094 //l=0.108 //layer=ply \
 //thickness=0.18 //x=65.067 //y=1.555 //x2=65.175 //y2=1.555
r1203 (  173 268 ) resistor r=54.866 //w=0.094 //l=0.107 //layer=ply \
 //thickness=0.18 //x=65.067 //y=1.555 //x2=64.96 //y2=1.555
r1204 (  172 248 ) resistor r=55.3787 //w=0.094 //l=0.108 //layer=ply \
 //thickness=0.18 //x=45.827 //y=1.555 //x2=45.935 //y2=1.555
r1205 (  172 249 ) resistor r=54.866 //w=0.094 //l=0.107 //layer=ply \
 //thickness=0.18 //x=45.827 //y=1.555 //x2=45.72 //y2=1.555
r1206 (  171 229 ) resistor r=55.3787 //w=0.094 //l=0.108 //layer=ply \
 //thickness=0.18 //x=36.207 //y=1.555 //x2=36.315 //y2=1.555
r1207 (  171 230 ) resistor r=54.866 //w=0.094 //l=0.107 //layer=ply \
 //thickness=0.18 //x=36.207 //y=1.555 //x2=36.1 //y2=1.555
r1208 (  170 210 ) resistor r=55.3787 //w=0.094 //l=0.108 //layer=ply \
 //thickness=0.18 //x=16.967 //y=1.555 //x2=17.075 //y2=1.555
r1209 (  170 211 ) resistor r=54.866 //w=0.094 //l=0.107 //layer=ply \
 //thickness=0.18 //x=16.967 //y=1.555 //x2=16.86 //y2=1.555
r1210 (  169 191 ) resistor r=55.3787 //w=0.094 //l=0.108 //layer=ply \
 //thickness=0.18 //x=7.347 //y=1.555 //x2=7.455 //y2=1.555
r1211 (  169 192 ) resistor r=54.866 //w=0.094 //l=0.107 //layer=ply \
 //thickness=0.18 //x=7.347 //y=1.555 //x2=7.24 //y2=1.555
r1212 (  165 359 ) resistor r=152 //w=0.17 //l=0.17 //layer=licon //count=1 \
 //x=74.86 //y=4.88 //x2=74.86 //y2=4.88
r1213 (  160 366 ) resistor r=152 //w=0.17 //l=0.17 //layer=licon //count=1 \
 //x=74.86 //y=2.26 //x2=74.86 //y2=2.26
r1214 (  155 348 ) resistor r=152 //w=0.17 //l=0.17 //layer=licon //count=1 \
 //x=65.24 //y=4.88 //x2=65.24 //y2=4.88
r1215 (  150 355 ) resistor r=152 //w=0.17 //l=0.17 //layer=licon //count=1 \
 //x=65.24 //y=2.26 //x2=65.24 //y2=2.26
r1216 (  145 337 ) resistor r=152 //w=0.17 //l=0.17 //layer=licon //count=1 \
 //x=46 //y=4.88 //x2=46 //y2=4.88
r1217 (  140 344 ) resistor r=152 //w=0.17 //l=0.17 //layer=licon //count=1 \
 //x=46 //y=2.26 //x2=46 //y2=2.26
r1218 (  135 326 ) resistor r=152 //w=0.17 //l=0.17 //layer=licon //count=1 \
 //x=36.38 //y=4.88 //x2=36.38 //y2=4.88
r1219 (  130 333 ) resistor r=152 //w=0.17 //l=0.17 //layer=licon //count=1 \
 //x=36.38 //y=2.26 //x2=36.38 //y2=2.26
r1220 (  125 315 ) resistor r=152 //w=0.17 //l=0.17 //layer=licon //count=1 \
 //x=17.14 //y=4.88 //x2=17.14 //y2=4.88
r1221 (  120 322 ) resistor r=152 //w=0.17 //l=0.17 //layer=licon //count=1 \
 //x=17.14 //y=2.26 //x2=17.14 //y2=2.26
r1222 (  115 304 ) resistor r=152 //w=0.17 //l=0.17 //layer=licon //count=1 \
 //x=7.52 //y=4.88 //x2=7.52 //y2=4.88
r1223 (  110 311 ) resistor r=152 //w=0.17 //l=0.17 //layer=licon //count=1 \
 //x=7.52 //y=2.26 //x2=7.52 //y2=2.26
r1224 (  106 108 ) resistor r=0.0907939 //w=0.296 //l=0.215 //layer=m2 \
 //thickness=0.36 //x=74.865 //y=4.62 //x2=74.865 //y2=4.835
r1225 (  101 104 ) resistor r=0.0956406 //w=0.281 //l=0.215 //layer=m2 \
 //thickness=0.36 //x=65.235 //y=4.62 //x2=65.235 //y2=4.835
r1226 (  96 99 ) resistor r=0.0956406 //w=0.281 //l=0.215 //layer=m2 \
 //thickness=0.36 //x=46.005 //y=4.62 //x2=46.005 //y2=4.835
r1227 (  91 94 ) resistor r=0.0956406 //w=0.281 //l=0.215 //layer=m2 \
 //thickness=0.36 //x=36.375 //y=4.62 //x2=36.375 //y2=4.835
r1228 (  86 89 ) resistor r=0.0956406 //w=0.281 //l=0.215 //layer=m2 \
 //thickness=0.36 //x=17.145 //y=4.62 //x2=17.145 //y2=4.835
r1229 (  83 85 ) resistor r=0.0875407 //w=0.307 //l=0.215 //layer=m2 \
 //thickness=0.36 //x=7.515 //y=4.62 //x2=7.515 //y2=4.835
r1230 (  82 101 ) resistor r=0.0455071 //w=0.32 //l=0.16 //layer=m2 \
 //thickness=0.36 //x=65.395 //y=4.62 //x2=65.235 //y2=4.62
r1231 (  81 106 ) resistor r=0.0408006 //w=0.296 //l=0.16 //layer=m2 \
 //thickness=0.36 //x=74.705 //y=4.62 //x2=74.865 //y2=4.62
r1232 (  81 82 ) resistor r=8.88359 //w=0.131 //l=9.31 //layer=m2 \
 //thickness=0.36 //x=74.705 //y=4.62 //x2=65.395 //y2=4.62
r1233 (  80 96 ) resistor r=0.0455071 //w=0.32 //l=0.16 //layer=m2 \
 //thickness=0.36 //x=46.165 //y=4.62 //x2=46.005 //y2=4.62
r1234 (  79 101 ) resistor r=0.0455071 //w=0.32 //l=0.16 //layer=m2 \
 //thickness=0.36 //x=65.075 //y=4.62 //x2=65.235 //y2=4.62
r1235 (  79 80 ) resistor r=18.0439 //w=0.131 //l=18.91 //layer=m2 \
 //thickness=0.36 //x=65.075 //y=4.62 //x2=46.165 //y2=4.62
r1236 (  78 91 ) resistor r=0.0455071 //w=0.32 //l=0.16 //layer=m2 \
 //thickness=0.36 //x=36.535 //y=4.62 //x2=36.375 //y2=4.62
r1237 (  77 96 ) resistor r=0.0455071 //w=0.32 //l=0.16 //layer=m2 \
 //thickness=0.36 //x=45.845 //y=4.62 //x2=46.005 //y2=4.62
r1238 (  77 78 ) resistor r=8.88359 //w=0.131 //l=9.31 //layer=m2 \
 //thickness=0.36 //x=45.845 //y=4.62 //x2=36.535 //y2=4.62
r1239 (  76 86 ) resistor r=0.0455071 //w=0.32 //l=0.16 //layer=m2 \
 //thickness=0.36 //x=17.305 //y=4.62 //x2=17.145 //y2=4.62
r1240 (  75 91 ) resistor r=0.0455071 //w=0.32 //l=0.16 //layer=m2 \
 //thickness=0.36 //x=36.215 //y=4.62 //x2=36.375 //y2=4.62
r1241 (  75 76 ) resistor r=18.0439 //w=0.131 //l=18.91 //layer=m2 \
 //thickness=0.36 //x=36.215 //y=4.62 //x2=17.305 //y2=4.62
r1242 (  74 83 ) resistor r=0.0429992 //w=0.307 //l=0.16 //layer=m2 \
 //thickness=0.36 //x=7.675 //y=4.62 //x2=7.515 //y2=4.62
r1243 (  73 86 ) resistor r=0.0455071 //w=0.32 //l=0.16 //layer=m2 \
 //thickness=0.36 //x=16.985 //y=4.62 //x2=17.145 //y2=4.62
r1244 (  73 74 ) resistor r=8.88359 //w=0.131 //l=9.31 //layer=m2 \
 //thickness=0.36 //x=16.985 //y=4.62 //x2=7.675 //y2=4.62
r1245 (  72 165 ) resistor r=9.3 //w=0.17 //l=0.17 //layer=mcon //count=1 \
 //x=74.86 //y=4.88 //x2=74.86 //y2=4.88
r1246 (  70 108 ) resistor r=4.5 //w=0.15 //l=0.15 //layer=via1 //count=1 \
 //x=74.865 //y=4.835 //x2=74.865 //y2=4.835
r1247 (  70 72 ) resistor r=0.018263 //w=0.308 //l=0.045 //layer=m1 \
 //thickness=0.36 //x=74.865 //y=4.835 //x2=74.865 //y2=4.88
r1248 (  68 160 ) resistor r=9.3 //w=0.17 //l=0.17 //layer=mcon //count=1 \
 //x=74.86 //y=2.26 //x2=74.86 //y2=2.26
r1249 (  66 155 ) resistor r=9.3 //w=0.17 //l=0.17 //layer=mcon //count=1 \
 //x=65.24 //y=4.88 //x2=65.24 //y2=4.88
r1250 (  64 104 ) resistor r=4.5 //w=0.15 //l=0.15 //layer=via1 //count=1 \
 //x=65.235 //y=4.835 //x2=65.235 //y2=4.835
r1251 (  64 66 ) resistor r=0.018263 //w=0.308 //l=0.045 //layer=m1 \
 //thickness=0.36 //x=65.235 //y=4.835 //x2=65.235 //y2=4.88
r1252 (  62 150 ) resistor r=9.3 //w=0.17 //l=0.17 //layer=mcon //count=1 \
 //x=65.24 //y=2.26 //x2=65.24 //y2=2.26
r1253 (  60 145 ) resistor r=9.3 //w=0.17 //l=0.17 //layer=mcon //count=1 \
 //x=46 //y=4.88 //x2=46 //y2=4.88
r1254 (  58 99 ) resistor r=4.5 //w=0.15 //l=0.15 //layer=via1 //count=1 \
 //x=46.005 //y=4.835 //x2=46.005 //y2=4.835
r1255 (  58 60 ) resistor r=0.018263 //w=0.308 //l=0.045 //layer=m1 \
 //thickness=0.36 //x=46.005 //y=4.835 //x2=46.005 //y2=4.88
r1256 (  56 140 ) resistor r=9.3 //w=0.17 //l=0.17 //layer=mcon //count=1 \
 //x=46 //y=2.26 //x2=46 //y2=2.26
r1257 (  54 135 ) resistor r=9.3 //w=0.17 //l=0.17 //layer=mcon //count=1 \
 //x=36.38 //y=4.88 //x2=36.38 //y2=4.88
r1258 (  52 94 ) resistor r=4.5 //w=0.15 //l=0.15 //layer=via1 //count=1 \
 //x=36.375 //y=4.835 //x2=36.375 //y2=4.835
r1259 (  52 54 ) resistor r=0.018263 //w=0.308 //l=0.045 //layer=m1 \
 //thickness=0.36 //x=36.375 //y=4.835 //x2=36.375 //y2=4.88
r1260 (  50 130 ) resistor r=9.3 //w=0.17 //l=0.17 //layer=mcon //count=1 \
 //x=36.38 //y=2.26 //x2=36.38 //y2=2.26
r1261 (  48 125 ) resistor r=9.3 //w=0.17 //l=0.17 //layer=mcon //count=1 \
 //x=17.14 //y=4.88 //x2=17.14 //y2=4.88
r1262 (  46 89 ) resistor r=4.5 //w=0.15 //l=0.15 //layer=via1 //count=1 \
 //x=17.145 //y=4.835 //x2=17.145 //y2=4.835
r1263 (  46 48 ) resistor r=0.018263 //w=0.308 //l=0.045 //layer=m1 \
 //thickness=0.36 //x=17.145 //y=4.835 //x2=17.145 //y2=4.88
r1264 (  44 120 ) resistor r=9.3 //w=0.17 //l=0.17 //layer=mcon //count=1 \
 //x=17.14 //y=2.26 //x2=17.14 //y2=2.26
r1265 (  42 115 ) resistor r=9.3 //w=0.17 //l=0.17 //layer=mcon //count=1 \
 //x=7.52 //y=4.88 //x2=7.52 //y2=4.88
r1266 (  40 85 ) resistor r=4.5 //w=0.15 //l=0.15 //layer=via1 //count=1 \
 //x=7.515 //y=4.835 //x2=7.515 //y2=4.835
r1267 (  40 42 ) resistor r=0.018263 //w=0.308 //l=0.045 //layer=m1 \
 //thickness=0.36 //x=7.515 //y=4.835 //x2=7.515 //y2=4.88
r1268 (  38 110 ) resistor r=9.3 //w=0.17 //l=0.17 //layer=mcon //count=1 \
 //x=7.52 //y=2.26 //x2=7.52 //y2=2.26
r1269 (  34 70 ) resistor r=0.0898396 //w=0.308 //l=0.162481 //layer=m1 \
 //thickness=0.36 //x=74.86 //y=4.675 //x2=74.865 //y2=4.835
r1270 (  33 68 ) resistor r=0.0715665 //w=0.226 //l=0.115996 //layer=m1 \
 //thickness=0.36 //x=74.86 //y=2.375 //x2=74.862 //y2=2.26
r1271 (  31 64 ) resistor r=0.0898396 //w=0.308 //l=0.162481 //layer=m1 \
 //thickness=0.36 //x=65.24 //y=4.675 //x2=65.235 //y2=4.835
r1272 (  30 62 ) resistor r=0.0715665 //w=0.226 //l=0.115996 //layer=m1 \
 //thickness=0.36 //x=65.24 //y=2.375 //x2=65.242 //y2=2.26
r1273 (  27 58 ) resistor r=0.0898396 //w=0.308 //l=0.162481 //layer=m1 \
 //thickness=0.36 //x=46 //y=4.675 //x2=46.005 //y2=4.835
r1274 (  26 56 ) resistor r=0.0715665 //w=0.226 //l=0.115996 //layer=m1 \
 //thickness=0.36 //x=46 //y=2.375 //x2=46.002 //y2=2.26
r1275 (  23 52 ) resistor r=0.0898396 //w=0.308 //l=0.162481 //layer=m1 \
 //thickness=0.36 //x=36.38 //y=4.675 //x2=36.375 //y2=4.835
r1276 (  22 50 ) resistor r=0.0715665 //w=0.226 //l=0.115996 //layer=m1 \
 //thickness=0.36 //x=36.38 //y=2.375 //x2=36.382 //y2=2.26
r1277 (  19 46 ) resistor r=0.0898396 //w=0.308 //l=0.162481 //layer=m1 \
 //thickness=0.36 //x=17.14 //y=4.675 //x2=17.145 //y2=4.835
r1278 (  18 44 ) resistor r=0.0715665 //w=0.226 //l=0.115996 //layer=m1 \
 //thickness=0.36 //x=17.14 //y=2.375 //x2=17.142 //y2=2.26
r1279 (  14 40 ) resistor r=0.0898396 //w=0.308 //l=0.162481 //layer=m1 \
 //thickness=0.36 //x=7.52 //y=4.675 //x2=7.515 //y2=4.835
r1280 (  13 38 ) resistor r=0.0715665 //w=0.226 //l=0.115996 //layer=m1 \
 //thickness=0.36 //x=7.52 //y=2.375 //x2=7.522 //y2=2.26
r1281 (  12 34 ) resistor r=0.0524809 //w=0.131 //l=0.055 //layer=m1 \
 //thickness=0.36 //x=74.86 //y=4.62 //x2=74.86 //y2=4.675
r1282 (  11 12 ) resistor r=1.76527 //w=0.131 //l=1.85 //layer=m1 \
 //thickness=0.36 //x=74.86 //y=2.77 //x2=74.86 //y2=4.62
r1283 (  11 33 ) resistor r=0.376908 //w=0.131 //l=0.395 //layer=m1 \
 //thickness=0.36 //x=74.86 //y=2.77 //x2=74.86 //y2=2.375
r1284 (  10 31 ) resistor r=0.0524809 //w=0.131 //l=0.055 //layer=m1 \
 //thickness=0.36 //x=65.24 //y=4.62 //x2=65.24 //y2=4.675
r1285 (  10 30 ) resistor r=2.14218 //w=0.131 //l=2.245 //layer=m1 \
 //thickness=0.36 //x=65.24 //y=4.62 //x2=65.24 //y2=2.375
r1286 (  9 27 ) resistor r=0.0524809 //w=0.131 //l=0.055 //layer=m1 \
 //thickness=0.36 //x=46 //y=4.62 //x2=46 //y2=4.675
r1287 (  8 9 ) resistor r=1.76527 //w=0.131 //l=1.85 //layer=m1 \
 //thickness=0.36 //x=46 //y=2.77 //x2=46 //y2=4.62
r1288 (  8 26 ) resistor r=0.376908 //w=0.131 //l=0.395 //layer=m1 \
 //thickness=0.36 //x=46 //y=2.77 //x2=46 //y2=2.375
r1289 (  7 23 ) resistor r=0.0524809 //w=0.131 //l=0.055 //layer=m1 \
 //thickness=0.36 //x=36.38 //y=4.62 //x2=36.38 //y2=4.675
r1290 (  6 7 ) resistor r=0.706107 //w=0.131 //l=0.74 //layer=m1 \
 //thickness=0.36 //x=36.38 //y=3.88 //x2=36.38 //y2=4.62
r1291 (  6 22 ) resistor r=1.43607 //w=0.131 //l=1.505 //layer=m1 \
 //thickness=0.36 //x=36.38 //y=3.88 //x2=36.38 //y2=2.375
r1292 (  5 19 ) resistor r=0.0524809 //w=0.131 //l=0.055 //layer=m1 \
 //thickness=0.36 //x=17.14 //y=4.62 //x2=17.14 //y2=4.675
r1293 (  4 5 ) resistor r=1.76527 //w=0.131 //l=1.85 //layer=m1 \
 //thickness=0.36 //x=17.14 //y=2.77 //x2=17.14 //y2=4.62
r1294 (  4 18 ) resistor r=0.376908 //w=0.131 //l=0.395 //layer=m1 \
 //thickness=0.36 //x=17.14 //y=2.77 //x2=17.14 //y2=2.375
r1295 (  3 14 ) resistor r=0.0524809 //w=0.131 //l=0.055 //layer=m1 \
 //thickness=0.36 //x=7.52 //y=4.62 //x2=7.52 //y2=4.675
r1296 (  2 3 ) resistor r=0.706107 //w=0.131 //l=0.74 //layer=m1 \
 //thickness=0.36 //x=7.52 //y=3.88 //x2=7.52 //y2=4.62
r1297 (  1 2 ) resistor r=0.706107 //w=0.131 //l=0.74 //layer=m1 \
 //thickness=0.36 //x=7.52 //y=3.14 //x2=7.52 //y2=3.88
r1298 (  1 13 ) resistor r=0.729962 //w=0.131 //l=0.765 //layer=m1 \
 //thickness=0.36 //x=7.52 //y=3.14 //x2=7.52 //y2=2.375
ends PM_TMRDFFSNRNQNX1\%CLK

subckt PM_TMRDFFSNRNQNX1\%noxref_16 ( 1 2 3 4 5 7 10 11 13 14 15 16 18 19 20 \
 21 22 23 24 30 33 36 39 47 49 57 62 65 66 68 71 80 85 93 101 118 127 131 132 \
 133 134 135 136 140 141 142 147 149 152 153 154 155 156 157 158 160 166 167 \
 168 169 174 175 180 191 193 194 195 )
c482 ( 191 0 ) capacitor c=0.00885916f //x=66.415 //y=1.095
c483 ( 180 0 ) capacitor c=0.0710579f //x=61.54 //y=4.88
c484 ( 175 0 ) capacitor c=0.0278202f //x=61.54 //y=2.095
c485 ( 174 0 ) capacitor c=0.0479349f //x=61.54 //y=2.26
c486 ( 169 0 ) capacitor c=0.0612936f //x=78.835 //y=4.97
c487 ( 168 0 ) capacitor c=0.0376642f //x=79.125 //y=4.97
c488 ( 167 0 ) capacitor c=0.0346489f //x=78.79 //y=1.4
c489 ( 166 0 ) capacitor c=0.018692f //x=78.79 //y=1.055
c490 ( 160 0 ) capacitor c=0.0137077f //x=78.635 //y=1.555
c491 ( 158 0 ) capacitor c=0.0158585f //x=78.635 //y=0.9
c492 ( 157 0 ) capacitor c=0.10101f //x=78.26 //y=2.095
c493 ( 156 0 ) capacitor c=0.0229444f //x=78.26 //y=1.71
c494 ( 155 0 ) capacitor c=0.0234359f //x=78.26 //y=1.4
c495 ( 154 0 ) capacitor c=0.019815f //x=78.26 //y=1.055
c496 ( 153 0 ) capacitor c=0.0443175f //x=62.06 //y=1.44
c497 ( 152 0 ) capacitor c=0.0199703f //x=62.06 //y=1.095
c498 ( 149 0 ) capacitor c=0.0162526f //x=61.905 //y=1.595
c499 ( 147 0 ) capacitor c=0.0157807f //x=61.905 //y=0.94
c500 ( 142 0 ) capacitor c=0.0220935f //x=61.53 //y=1.75
c501 ( 141 0 ) capacitor c=0.0207489f //x=61.53 //y=1.44
c502 ( 140 0 ) capacitor c=0.0194091f //x=61.53 //y=1.095
c503 ( 136 0 ) capacitor c=0.110208f //x=79.2 //y=6.2
c504 ( 135 0 ) capacitor c=0.158957f //x=78.76 //y=6.2
c505 ( 134 0 ) capacitor c=0.159671f //x=61.72 //y=6.2
c506 ( 133 0 ) capacitor c=0.110208f //x=61.28 //y=6.2
c507 ( 127 0 ) capacitor c=0.0014751f //x=78.56 //y=4.88
c508 ( 118 0 ) capacitor c=0.0012618f //x=78.56 //y=2.26
c509 ( 101 0 ) capacitor c=0.0293723f //x=66.31 //y=5.56
c510 ( 93 0 ) capacitor c=0.029137f //x=65.43 //y=5.56
c511 ( 85 0 ) capacitor c=0.0278099f //x=64.55 //y=5.56
c512 ( 80 0 ) capacitor c=9.5006e-19 //x=61.54 //y=4.88
c513 ( 71 0 ) capacitor c=0.00101179f //x=61.54 //y=2.26
c514 ( 68 0 ) capacitor c=4.92288e-19 //x=78.555 //y=3.51
c515 ( 66 0 ) capacitor c=6.97864e-19 //x=67.25 //y=3.495
c516 ( 65 0 ) capacitor c=0.0517493f //x=66.93 //y=3.495
c517 ( 62 0 ) capacitor c=4.31985e-19 //x=61.71 //y=3.515
c518 ( 57 0 ) capacitor c=0.113631f //x=78.395 //y=3.51
c519 ( 49 0 ) capacitor c=0.015408f //x=78.555 //y=3.51
c520 ( 47 0 ) capacitor c=0.0158593f //x=67.09 //y=3.51
c521 ( 39 0 ) capacitor c=8.40513e-19 //x=66.31 //y=5.335
c522 ( 36 0 ) capacitor c=0.00746333f //x=65.43 //y=5.335
c523 ( 33 0 ) capacitor c=0.0119613f //x=64.552 //y=5.335
c524 ( 30 0 ) capacitor c=0.0150828f //x=61.54 //y=3.51
c525 ( 24 0 ) capacitor c=0.037614f //x=78.56 //y=4.755
c526 ( 23 0 ) capacitor c=0.0144231f //x=78.56 //y=3.67
c527 ( 22 0 ) capacitor c=0.0265596f //x=78.56 //y=3.35
c528 ( 21 0 ) capacitor c=0.00493552f //x=78.56 //y=2.375
c529 ( 20 0 ) capacitor c=0.0405366f //x=67.09 //y=5.25
c530 ( 19 0 ) capacitor c=0.0133594f //x=67.09 //y=3.655
c531 ( 18 0 ) capacitor c=0.0372096f //x=67.09 //y=3.335
c532 ( 16 0 ) capacitor c=0.0048771f //x=66.69 //y=1.845
c533 ( 15 0 ) capacitor c=0.0132685f //x=67.005 //y=1.845
c534 ( 14 0 ) capacitor c=0.0167992f //x=66.605 //y=1.76
c535 ( 13 0 ) capacitor c=0.0113147f //x=66.605 //y=1.305
c536 ( 11 0 ) capacitor c=0.0205277f //x=67.005 //y=5.335
c537 ( 10 0 ) capacitor c=0.00933983f //x=66.31 //y=5.56
c538 ( 7 0 ) capacitor c=0.0183181f //x=66.195 //y=5.335
c539 ( 5 0 ) capacitor c=0.0151206f //x=65.31 //y=5.335
c540 ( 4 0 ) capacitor c=0.0285275f //x=61.54 //y=4.75
c541 ( 3 0 ) capacitor c=0.0121725f //x=61.54 //y=3.675
c542 ( 2 0 ) capacitor c=0.0217874f //x=61.54 //y=3.355
c543 ( 1 0 ) capacitor c=0.005545f //x=61.54 //y=2.375
r544 (  174 175 ) resistor r=52.7279 //w=0.214 //l=0.165 //layer=ply \
 //thickness=0.18 //x=61.54 //y=2.26 //x2=61.54 //y2=2.095
r545 (  168 170 ) resistor r=26.9307 //w=0.15 //l=0.106066 //layer=ply \
 //thickness=0.18 //x=79.125 //y=4.97 //x2=79.2 //y2=5.045
r546 (  168 169 ) resistor r=148.702 //w=0.094 //l=0.29 //layer=ply \
 //thickness=0.18 //x=79.125 //y=4.97 //x2=78.835 //y2=4.97
r547 (  167 190 ) resistor r=45.1352 //w=0.168 //l=0.173853 //layer=ply \
 //thickness=0.18 //x=78.79 //y=1.4 //x2=78.75 //y2=1.555
r548 (  166 189 ) resistor r=45.1352 //w=0.168 //l=0.173853 //layer=ply \
 //thickness=0.18 //x=78.79 //y=1.055 //x2=78.75 //y2=0.9
r549 (  166 167 ) resistor r=176.904 //w=0.094 //l=0.345 //layer=ply \
 //thickness=0.18 //x=78.79 //y=1.055 //x2=78.79 //y2=1.4
r550 (  163 169 ) resistor r=22.7971 //w=0.269 //l=0.106066 //layer=ply \
 //thickness=0.18 //x=78.76 //y=5.045 //x2=78.835 //y2=4.97
r551 (  163 188 ) resistor r=35.8364 //w=0.269 //l=0.270185 //layer=ply \
 //thickness=0.18 //x=78.76 //y=5.045 //x2=78.56 //y2=4.88
r552 (  161 184 ) resistor r=10.701 //w=0.21 //l=0.115 //layer=ply \
 //thickness=0.18 //x=78.415 //y=1.555 //x2=78.3 //y2=1.555
r553 (  160 190 ) resistor r=5.52526 //w=0.168 //l=0.115 //layer=ply \
 //thickness=0.18 //x=78.635 //y=1.555 //x2=78.75 //y2=1.555
r554 (  159 183 ) resistor r=5.52526 //w=0.168 //l=0.115 //layer=ply \
 //thickness=0.18 //x=78.415 //y=0.9 //x2=78.3 //y2=0.9
r555 (  158 189 ) resistor r=5.52526 //w=0.168 //l=0.115 //layer=ply \
 //thickness=0.18 //x=78.635 //y=0.9 //x2=78.75 //y2=0.9
r556 (  158 159 ) resistor r=112.809 //w=0.094 //l=0.22 //layer=ply \
 //thickness=0.18 //x=78.635 //y=0.9 //x2=78.415 //y2=0.9
r557 (  157 186 ) resistor r=58.7805 //w=0.246 //l=0.373497 //layer=ply \
 //thickness=0.18 //x=78.26 //y=2.095 //x2=78.56 //y2=2.26
r558 (  156 184 ) resistor r=39.5823 //w=0.21 //l=0.173853 //layer=ply \
 //thickness=0.18 //x=78.26 //y=1.71 //x2=78.3 //y2=1.555
r559 (  156 157 ) resistor r=197.415 //w=0.094 //l=0.385 //layer=ply \
 //thickness=0.18 //x=78.26 //y=1.71 //x2=78.26 //y2=2.095
r560 (  155 184 ) resistor r=39.5823 //w=0.21 //l=0.173853 //layer=ply \
 //thickness=0.18 //x=78.26 //y=1.4 //x2=78.3 //y2=1.555
r561 (  154 183 ) resistor r=45.1352 //w=0.168 //l=0.173853 //layer=ply \
 //thickness=0.18 //x=78.26 //y=1.055 //x2=78.3 //y2=0.9
r562 (  154 155 ) resistor r=176.904 //w=0.094 //l=0.345 //layer=ply \
 //thickness=0.18 //x=78.26 //y=1.055 //x2=78.26 //y2=1.4
r563 (  153 182 ) resistor r=45.1352 //w=0.168 //l=0.173853 //layer=ply \
 //thickness=0.18 //x=62.06 //y=1.44 //x2=62.02 //y2=1.595
r564 (  152 181 ) resistor r=45.1352 //w=0.168 //l=0.173853 //layer=ply \
 //thickness=0.18 //x=62.06 //y=1.095 //x2=62.02 //y2=0.94
r565 (  152 153 ) resistor r=176.904 //w=0.094 //l=0.345 //layer=ply \
 //thickness=0.18 //x=62.06 //y=1.095 //x2=62.06 //y2=1.44
r566 (  150 178 ) resistor r=10.701 //w=0.21 //l=0.115 //layer=ply \
 //thickness=0.18 //x=61.685 //y=1.595 //x2=61.57 //y2=1.595
r567 (  149 182 ) resistor r=5.52526 //w=0.168 //l=0.115 //layer=ply \
 //thickness=0.18 //x=61.905 //y=1.595 //x2=62.02 //y2=1.595
r568 (  148 177 ) resistor r=5.52526 //w=0.168 //l=0.115 //layer=ply \
 //thickness=0.18 //x=61.685 //y=0.94 //x2=61.57 //y2=0.94
r569 (  147 181 ) resistor r=5.52526 //w=0.168 //l=0.115 //layer=ply \
 //thickness=0.18 //x=61.905 //y=0.94 //x2=62.02 //y2=0.94
r570 (  147 148 ) resistor r=112.809 //w=0.094 //l=0.22 //layer=ply \
 //thickness=0.18 //x=61.905 //y=0.94 //x2=61.685 //y2=0.94
r571 (  144 180 ) resistor r=37.236 //w=0.233 //l=0.249199 //layer=ply \
 //thickness=0.18 //x=61.72 //y=5.045 //x2=61.54 //y2=4.88
r572 (  142 178 ) resistor r=39.5823 //w=0.21 //l=0.173853 //layer=ply \
 //thickness=0.18 //x=61.53 //y=1.75 //x2=61.57 //y2=1.595
r573 (  142 175 ) resistor r=176.904 //w=0.094 //l=0.345 //layer=ply \
 //thickness=0.18 //x=61.53 //y=1.75 //x2=61.53 //y2=2.095
r574 (  141 178 ) resistor r=39.5823 //w=0.21 //l=0.173853 //layer=ply \
 //thickness=0.18 //x=61.53 //y=1.44 //x2=61.57 //y2=1.595
r575 (  140 177 ) resistor r=45.1352 //w=0.168 //l=0.173853 //layer=ply \
 //thickness=0.18 //x=61.53 //y=1.095 //x2=61.57 //y2=0.94
r576 (  140 141 ) resistor r=176.904 //w=0.094 //l=0.345 //layer=ply \
 //thickness=0.18 //x=61.53 //y=1.095 //x2=61.53 //y2=1.44
r577 (  137 180 ) resistor r=53.7854 //w=0.233 //l=0.332415 //layer=ply \
 //thickness=0.18 //x=61.28 //y=5.045 //x2=61.54 //y2=4.88
r578 (  136 170 ) resistor r=592.245 //w=0.094 //l=1.155 //layer=ply \
 //thickness=0.18 //x=79.2 //y=6.2 //x2=79.2 //y2=5.045
r579 (  135 163 ) resistor r=592.245 //w=0.094 //l=1.155 //layer=ply \
 //thickness=0.18 //x=78.76 //y=6.2 //x2=78.76 //y2=5.045
r580 (  134 144 ) resistor r=592.245 //w=0.094 //l=1.155 //layer=ply \
 //thickness=0.18 //x=61.72 //y=6.2 //x2=61.72 //y2=5.045
r581 (  133 137 ) resistor r=592.245 //w=0.094 //l=1.155 //layer=ply \
 //thickness=0.18 //x=61.28 //y=6.2 //x2=61.28 //y2=5.045
r582 (  132 160 ) resistor r=56.4043 //w=0.094 //l=0.11 //layer=ply \
 //thickness=0.18 //x=78.525 //y=1.555 //x2=78.635 //y2=1.555
r583 (  132 161 ) resistor r=56.4043 //w=0.094 //l=0.11 //layer=ply \
 //thickness=0.18 //x=78.525 //y=1.555 //x2=78.415 //y2=1.555
r584 (  131 149 ) resistor r=56.4043 //w=0.094 //l=0.11 //layer=ply \
 //thickness=0.18 //x=61.795 //y=1.595 //x2=61.905 //y2=1.595
r585 (  131 150 ) resistor r=56.4043 //w=0.094 //l=0.11 //layer=ply \
 //thickness=0.18 //x=61.795 //y=1.595 //x2=61.685 //y2=1.595
r586 (  127 188 ) resistor r=152 //w=0.17 //l=0.17 //layer=licon //count=1 \
 //x=78.56 //y=4.88 //x2=78.56 //y2=4.88
r587 (  118 186 ) resistor r=152 //w=0.17 //l=0.17 //layer=licon //count=1 \
 //x=78.56 //y=2.26 //x2=78.56 //y2=2.26
r588 (  101 195 ) resistor r=23.615 //w=0.187 //l=0.345 //layer=li \
 //thickness=0.1 //x=66.31 //y=5.56 //x2=66.31 //y2=5.905
r589 (  93 194 ) resistor r=23.615 //w=0.187 //l=0.345 //layer=li \
 //thickness=0.1 //x=65.43 //y=5.56 //x2=65.43 //y2=5.905
r590 (  85 193 ) resistor r=23.615 //w=0.187 //l=0.345 //layer=li \
 //thickness=0.1 //x=64.55 //y=5.56 //x2=64.55 //y2=5.905
r591 (  80 180 ) resistor r=152 //w=0.17 //l=0.17 //layer=licon //count=1 \
 //x=61.54 //y=4.88 //x2=61.54 //y2=4.88
r592 (  71 174 ) resistor r=152 //w=0.17 //l=0.17 //layer=licon //count=1 \
 //x=61.54 //y=2.26 //x2=61.54 //y2=2.26
r593 (  64 66 ) resistor r=0.10734 //w=0.281 //l=0.16 //layer=m2 \
 //thickness=0.36 //x=67.09 //y=3.495 //x2=67.25 //y2=3.495
r594 (  64 65 ) resistor r=0.10734 //w=0.281 //l=0.16 //layer=m2 \
 //thickness=0.36 //x=67.09 //y=3.495 //x2=66.93 //y2=3.495
r595 (  62 65 ) resistor r=4.98092 //w=0.131 //l=5.22 //layer=m2 \
 //thickness=0.36 //x=61.71 //y=3.51 //x2=66.93 //y2=3.51
r596 (  60 62 ) resistor r=0.10734 //w=0.281 //l=0.16 //layer=m2 \
 //thickness=0.36 //x=61.55 //y=3.515 //x2=61.71 //y2=3.515
r597 (  57 68 ) resistor r=0.10734 //w=0.281 //l=0.16 //layer=m2 \
 //thickness=0.36 //x=78.395 //y=3.51 //x2=78.555 //y2=3.51
r598 (  57 66 ) resistor r=10.6345 //w=0.131 //l=11.145 //layer=m2 \
 //thickness=0.36 //x=78.395 //y=3.51 //x2=67.25 //y2=3.51
r599 (  54 127 ) resistor r=9.3 //w=0.17 //l=0.17 //layer=mcon //count=1 \
 //x=78.56 //y=4.88 //x2=78.56 //y2=4.88
r600 (  52 118 ) resistor r=9.3 //w=0.17 //l=0.17 //layer=mcon //count=1 \
 //x=78.56 //y=2.26 //x2=78.56 //y2=2.26
r601 (  49 68 ) resistor r=4.5 //w=0.15 //l=0.15 //layer=via1 //count=1 \
 //x=78.555 //y=3.51 //x2=78.555 //y2=3.51
r602 (  45 64 ) resistor r=4.5 //w=0.15 //l=0.15 //layer=via1 //count=1 \
 //x=67.09 //y=3.495 //x2=67.09 //y2=3.495
r603 (  45 47 ) resistor r=0.0049867 //w=0.376 //l=0.015 //layer=m1 \
 //thickness=0.36 //x=67.142 //y=3.495 //x2=67.142 //y2=3.51
r604 (  43 191 ) resistor r=9.3 //w=0.17 //l=0.17 //layer=mcon //count=1 \
 //x=66.605 //y=1.19 //x2=66.605 //y2=1.19
r605 (  41 101 ) resistor r=9.3 //w=0.17 //l=0.17 //layer=mcon //count=1 \
 //x=66.31 //y=5.56 //x2=66.31 //y2=5.56
r606 (  38 93 ) resistor r=9.3 //w=0.17 //l=0.17 //layer=mcon //count=1 \
 //x=65.43 //y=5.56 //x2=65.43 //y2=5.56
r607 (  36 38 ) resistor r=0.121228 //w=0.232 //l=0.225 //layer=m1 \
 //thickness=0.36 //x=65.43 //y=5.335 //x2=65.43 //y2=5.56
r608 (  35 85 ) resistor r=9.3 //w=0.17 //l=0.17 //layer=mcon //count=1 \
 //x=64.55 //y=5.56 //x2=64.55 //y2=5.56
r609 (  33 35 ) resistor r=0.129608 //w=0.217 //l=0.225 //layer=m1 \
 //thickness=0.36 //x=64.552 //y=5.335 //x2=64.552 //y2=5.56
r610 (  32 60 ) resistor r=4.5 //w=0.15 //l=0.15 //layer=via1 //count=1 \
 //x=61.55 //y=3.515 //x2=61.55 //y2=3.515
r611 (  30 32 ) resistor r=0.00168464 //w=0.371 //l=0.005 //layer=m1 \
 //thickness=0.36 //x=61.597 //y=3.51 //x2=61.597 //y2=3.515
r612 (  28 80 ) resistor r=9.3 //w=0.17 //l=0.17 //layer=mcon //count=1 \
 //x=61.54 //y=4.88 //x2=61.54 //y2=4.88
r613 (  26 71 ) resistor r=9.3 //w=0.17 //l=0.17 //layer=mcon //count=1 \
 //x=61.54 //y=2.26 //x2=61.54 //y2=2.26
r614 (  24 54 ) resistor r=0.0760407 //w=0.238 //l=0.125 //layer=m1 \
 //thickness=0.36 //x=78.56 //y=4.755 //x2=78.56 //y2=4.88
r615 (  23 49 ) resistor r=0.0910802 //w=0.374 //l=0.185472 //layer=m1 \
 //thickness=0.36 //x=78.56 //y=3.67 //x2=78.505 //y2=3.51
r616 (  23 24 ) resistor r=1.03531 //w=0.131 //l=1.085 //layer=m1 \
 //thickness=0.36 //x=78.56 //y=3.67 //x2=78.56 //y2=4.755
r617 (  22 49 ) resistor r=0.0910802 //w=0.374 //l=0.185472 //layer=m1 \
 //thickness=0.36 //x=78.56 //y=3.35 //x2=78.505 //y2=3.51
r618 (  21 52 ) resistor r=0.0719237 //w=0.222 //l=0.115 //layer=m1 \
 //thickness=0.36 //x=78.56 //y=2.375 //x2=78.56 //y2=2.26
r619 (  21 22 ) resistor r=0.930344 //w=0.131 //l=0.975 //layer=m1 \
 //thickness=0.36 //x=78.56 //y=2.375 //x2=78.56 //y2=3.35
r620 (  19 47 ) resistor r=0.0861726 //w=0.376 //l=0.169012 //layer=m1 \
 //thickness=0.36 //x=67.09 //y=3.655 //x2=67.142 //y2=3.51
r621 (  19 20 ) resistor r=1.52195 //w=0.131 //l=1.595 //layer=m1 \
 //thickness=0.36 //x=67.09 //y=3.655 //x2=67.09 //y2=5.25
r622 (  18 45 ) resistor r=0.0911593 //w=0.376 //l=0.184174 //layer=m1 \
 //thickness=0.36 //x=67.09 //y=3.335 //x2=67.142 //y2=3.495
r623 (  17 18 ) resistor r=1.34065 //w=0.131 //l=1.405 //layer=m1 \
 //thickness=0.36 //x=67.09 //y=1.93 //x2=67.09 //y2=3.335
r624 (  15 17 ) resistor r=0.0698411 //w=0.17 //l=0.120208 //layer=m1 \
 //thickness=0.36 //x=67.005 //y=1.845 //x2=67.09 //y2=1.93
r625 (  15 16 ) resistor r=0.300573 //w=0.131 //l=0.315 //layer=m1 \
 //thickness=0.36 //x=67.005 //y=1.845 //x2=66.69 //y2=1.845
r626 (  14 16 ) resistor r=0.0698411 //w=0.17 //l=0.120208 //layer=m1 \
 //thickness=0.36 //x=66.605 //y=1.76 //x2=66.69 //y2=1.845
r627 (  13 43 ) resistor r=0.0717383 //w=0.224 //l=0.115 //layer=m1 \
 //thickness=0.36 //x=66.605 //y=1.305 //x2=66.605 //y2=1.19
r628 (  13 14 ) resistor r=0.43416 //w=0.131 //l=0.455 //layer=m1 \
 //thickness=0.36 //x=66.605 //y=1.305 //x2=66.605 //y2=1.76
r629 (  12 39 ) resistor r=0.0675342 //w=0.23 //l=0.115 //layer=m1 \
 //thickness=0.36 //x=66.425 //y=5.335 //x2=66.31 //y2=5.335
r630 (  11 20 ) resistor r=0.0698411 //w=0.17 //l=0.120208 //layer=m1 \
 //thickness=0.36 //x=67.005 //y=5.335 //x2=67.09 //y2=5.25
r631 (  11 12 ) resistor r=0.553435 //w=0.131 //l=0.58 //layer=m1 \
 //thickness=0.36 //x=67.005 //y=5.335 //x2=66.425 //y2=5.335
r632 (  10 41 ) resistor r=0.00118313 //w=0.23 //layer=m1 //thickness=0.36 \
 //x=66.31 //y=5.56 //x2=66.31 //y2=5.56
r633 (  9 39 ) resistor r=0.002872 //w=0.34 //l=0.085 //layer=m1 \
 //thickness=0.36 //x=66.31 //y=5.42 //x2=66.31 //y2=5.335
r634 (  9 10 ) resistor r=0.091623 //w=0.191 //l=0.14 //layer=m1 \
 //thickness=0.36 //x=66.31 //y=5.42 //x2=66.31 //y2=5.56
r635 (  8 36 ) resistor r=0.0262263 //w=0.232 //l=0.12 //layer=m1 \
 //thickness=0.36 //x=65.55 //y=5.335 //x2=65.43 //y2=5.335
r636 (  7 39 ) resistor r=0.0675342 //w=0.23 //l=0.115 //layer=m1 \
 //thickness=0.36 //x=66.195 //y=5.335 //x2=66.31 //y2=5.335
r637 (  7 8 ) resistor r=0.615458 //w=0.131 //l=0.645 //layer=m1 \
 //thickness=0.36 //x=66.195 //y=5.335 //x2=65.55 //y2=5.335
r638 (  6 33 ) resistor r=0.0222262 //w=0.217 //l=0.118 //layer=m1 \
 //thickness=0.36 //x=64.67 //y=5.335 //x2=64.552 //y2=5.335
r639 (  5 36 ) resistor r=0.0262263 //w=0.232 //l=0.12 //layer=m1 \
 //thickness=0.36 //x=65.31 //y=5.335 //x2=65.43 //y2=5.335
r640 (  5 6 ) resistor r=0.610687 //w=0.131 //l=0.64 //layer=m1 \
 //thickness=0.36 //x=65.31 //y=5.335 //x2=64.67 //y2=5.335
r641 (  4 28 ) resistor r=0.0801089 //w=0.224 //l=0.13 //layer=m1 \
 //thickness=0.36 //x=61.54 //y=4.75 //x2=61.54 //y2=4.88
r642 (  3 32 ) resistor r=0.0909648 //w=0.371 //l=0.186333 //layer=m1 \
 //thickness=0.36 //x=61.54 //y=3.675 //x2=61.597 //y2=3.515
r643 (  3 4 ) resistor r=1.02576 //w=0.131 //l=1.075 //layer=m1 \
 //thickness=0.36 //x=61.54 //y=3.675 //x2=61.54 //y2=4.75
r644 (  2 30 ) resistor r=0.0892801 //w=0.371 //l=0.181273 //layer=m1 \
 //thickness=0.36 //x=61.54 //y=3.355 //x2=61.597 //y2=3.51
r645 (  1 26 ) resistor r=0.0719237 //w=0.222 //l=0.115 //layer=m1 \
 //thickness=0.36 //x=61.54 //y=2.375 //x2=61.54 //y2=2.26
r646 (  1 2 ) resistor r=0.935115 //w=0.131 //l=0.98 //layer=m1 \
 //thickness=0.36 //x=61.54 //y=2.375 //x2=61.54 //y2=3.355
ends PM_TMRDFFSNRNQNX1\%noxref_16

subckt PM_TMRDFFSNRNQNX1\%RN ( 1 2 3 4 5 6 7 8 9 10 11 12 13 14 15 16 17 18 19 \
 20 21 22 23 24 25 26 27 28 29 30 31 37 38 40 41 44 45 49 50 52 53 56 57 61 62 \
 64 65 128 129 130 132 134 136 137 138 139 140 142 144 145 146 148 150 151 152 \
 153 154 156 158 159 160 162 165 184 185 188 193 198 203 208 213 218 223 228 \
 233 238 243 248 253 258 263 268 273 277 278 279 280 281 282 283 284 285 286 \
 287 288 289 290 291 292 293 294 295 296 297 298 299 300 301 302 303 304 305 \
 306 308 314 315 316 317 318 326 327 328 333 335 338 339 340 341 342 344 350 \
 351 352 353 354 359 360 361 363 369 370 371 372 373 381 382 383 388 390 393 \
 394 395 396 397 399 405 406 407 408 409 414 415 416 418 424 425 426 427 428 \
 436 437 438 443 445 448 449 450 451 452 454 460 461 462 463 464 472 481 482 \
 487 493 504 513 514 519 525 536 545 546 551 557 )
c1709 ( 557 0 ) capacitor c=0.0369044f //x=79.67 //y=4.88
c1710 ( 551 0 ) capacitor c=0.0711095f //x=75.97 //y=4.88
c1711 ( 546 0 ) capacitor c=0.0278202f //x=75.97 //y=2.095
c1712 ( 545 0 ) capacitor c=0.0491433f //x=75.97 //y=2.26
c1713 ( 536 0 ) capacitor c=0.0369628f //x=60.43 //y=4.88
c1714 ( 525 0 ) capacitor c=0.0369628f //x=50.81 //y=4.88
c1715 ( 519 0 ) capacitor c=0.0710579f //x=47.11 //y=4.88
c1716 ( 514 0 ) capacitor c=0.0278202f //x=47.11 //y=2.095
c1717 ( 513 0 ) capacitor c=0.0491433f //x=47.11 //y=2.26
c1718 ( 504 0 ) capacitor c=0.0369628f //x=31.57 //y=4.88
c1719 ( 493 0 ) capacitor c=0.0369044f //x=21.95 //y=4.88
c1720 ( 487 0 ) capacitor c=0.0710579f //x=18.25 //y=4.88
c1721 ( 482 0 ) capacitor c=0.0278202f //x=18.25 //y=2.095
c1722 ( 481 0 ) capacitor c=0.0491433f //x=18.25 //y=2.26
c1723 ( 472 0 ) capacitor c=0.0369044f //x=2.71 //y=4.88
c1724 ( 464 0 ) capacitor c=0.0309248f //x=80.005 //y=4.97
c1725 ( 463 0 ) capacitor c=0.0846044f //x=79.76 //y=2.095
c1726 ( 462 0 ) capacitor c=0.0170266f //x=79.76 //y=1.63
c1727 ( 461 0 ) capacitor c=0.018609f //x=79.76 //y=1.4
c1728 ( 460 0 ) capacitor c=0.0186599f //x=79.76 //y=1.09
c1729 ( 454 0 ) capacitor c=0.0146988f //x=79.605 //y=1.555
c1730 ( 452 0 ) capacitor c=0.0148531f //x=79.605 //y=0.935
c1731 ( 451 0 ) capacitor c=0.0334406f //x=79.235 //y=1.4
c1732 ( 450 0 ) capacitor c=0.0173191f //x=79.235 //y=1.09
c1733 ( 449 0 ) capacitor c=0.0443175f //x=76.49 //y=1.44
c1734 ( 448 0 ) capacitor c=0.0199703f //x=76.49 //y=1.095
c1735 ( 445 0 ) capacitor c=0.0160404f //x=76.335 //y=1.595
c1736 ( 443 0 ) capacitor c=0.0157807f //x=76.335 //y=0.94
c1737 ( 438 0 ) capacitor c=0.0220935f //x=75.96 //y=1.75
c1738 ( 437 0 ) capacitor c=0.0207489f //x=75.96 //y=1.44
c1739 ( 436 0 ) capacitor c=0.0194091f //x=75.96 //y=1.095
c1740 ( 428 0 ) capacitor c=0.0309248f //x=60.765 //y=4.97
c1741 ( 427 0 ) capacitor c=0.0844916f //x=60.52 //y=2.095
c1742 ( 426 0 ) capacitor c=0.0170266f //x=60.52 //y=1.63
c1743 ( 425 0 ) capacitor c=0.018609f //x=60.52 //y=1.4
c1744 ( 424 0 ) capacitor c=0.0186599f //x=60.52 //y=1.09
c1745 ( 418 0 ) capacitor c=0.0146988f //x=60.365 //y=1.555
c1746 ( 416 0 ) capacitor c=0.0148531f //x=60.365 //y=0.935
c1747 ( 415 0 ) capacitor c=0.0334406f //x=59.995 //y=1.4
c1748 ( 414 0 ) capacitor c=0.0173191f //x=59.995 //y=1.09
c1749 ( 409 0 ) capacitor c=0.0309248f //x=51.145 //y=4.97
c1750 ( 408 0 ) capacitor c=0.0846044f //x=50.9 //y=2.095
c1751 ( 407 0 ) capacitor c=0.0170266f //x=50.9 //y=1.63
c1752 ( 406 0 ) capacitor c=0.018609f //x=50.9 //y=1.4
c1753 ( 405 0 ) capacitor c=0.0186599f //x=50.9 //y=1.09
c1754 ( 399 0 ) capacitor c=0.0146988f //x=50.745 //y=1.555
c1755 ( 397 0 ) capacitor c=0.0148531f //x=50.745 //y=0.935
c1756 ( 396 0 ) capacitor c=0.0334406f //x=50.375 //y=1.4
c1757 ( 395 0 ) capacitor c=0.0173191f //x=50.375 //y=1.09
c1758 ( 394 0 ) capacitor c=0.0443175f //x=47.63 //y=1.44
c1759 ( 393 0 ) capacitor c=0.0199703f //x=47.63 //y=1.095
c1760 ( 390 0 ) capacitor c=0.0160404f //x=47.475 //y=1.595
c1761 ( 388 0 ) capacitor c=0.0157807f //x=47.475 //y=0.94
c1762 ( 383 0 ) capacitor c=0.0220935f //x=47.1 //y=1.75
c1763 ( 382 0 ) capacitor c=0.0207489f //x=47.1 //y=1.44
c1764 ( 381 0 ) capacitor c=0.0194091f //x=47.1 //y=1.095
c1765 ( 373 0 ) capacitor c=0.0309248f //x=31.905 //y=4.97
c1766 ( 372 0 ) capacitor c=0.0844916f //x=31.66 //y=2.095
c1767 ( 371 0 ) capacitor c=0.0170266f //x=31.66 //y=1.63
c1768 ( 370 0 ) capacitor c=0.018609f //x=31.66 //y=1.4
c1769 ( 369 0 ) capacitor c=0.0186599f //x=31.66 //y=1.09
c1770 ( 363 0 ) capacitor c=0.0146988f //x=31.505 //y=1.555
c1771 ( 361 0 ) capacitor c=0.0148531f //x=31.505 //y=0.935
c1772 ( 360 0 ) capacitor c=0.0334406f //x=31.135 //y=1.4
c1773 ( 359 0 ) capacitor c=0.0173191f //x=31.135 //y=1.09
c1774 ( 354 0 ) capacitor c=0.0309248f //x=22.285 //y=4.97
c1775 ( 353 0 ) capacitor c=0.0846044f //x=22.04 //y=2.095
c1776 ( 352 0 ) capacitor c=0.0170266f //x=22.04 //y=1.63
c1777 ( 351 0 ) capacitor c=0.018609f //x=22.04 //y=1.4
c1778 ( 350 0 ) capacitor c=0.0186599f //x=22.04 //y=1.09
c1779 ( 344 0 ) capacitor c=0.0146988f //x=21.885 //y=1.555
c1780 ( 342 0 ) capacitor c=0.0148531f //x=21.885 //y=0.935
c1781 ( 341 0 ) capacitor c=0.0334406f //x=21.515 //y=1.4
c1782 ( 340 0 ) capacitor c=0.0173191f //x=21.515 //y=1.09
c1783 ( 339 0 ) capacitor c=0.0443175f //x=18.77 //y=1.44
c1784 ( 338 0 ) capacitor c=0.0199703f //x=18.77 //y=1.095
c1785 ( 335 0 ) capacitor c=0.0160404f //x=18.615 //y=1.595
c1786 ( 333 0 ) capacitor c=0.0157807f //x=18.615 //y=0.94
c1787 ( 328 0 ) capacitor c=0.0220935f //x=18.24 //y=1.75
c1788 ( 327 0 ) capacitor c=0.0207489f //x=18.24 //y=1.44
c1789 ( 326 0 ) capacitor c=0.0194091f //x=18.24 //y=1.095
c1790 ( 318 0 ) capacitor c=0.0309248f //x=3.045 //y=4.97
c1791 ( 317 0 ) capacitor c=0.0844916f //x=2.8 //y=2.095
c1792 ( 316 0 ) capacitor c=0.0170266f //x=2.8 //y=1.63
c1793 ( 315 0 ) capacitor c=0.018609f //x=2.8 //y=1.4
c1794 ( 314 0 ) capacitor c=0.0186599f //x=2.8 //y=1.09
c1795 ( 308 0 ) capacitor c=0.0146988f //x=2.645 //y=1.555
c1796 ( 306 0 ) capacitor c=0.0148531f //x=2.645 //y=0.935
c1797 ( 305 0 ) capacitor c=0.0334406f //x=2.275 //y=1.4
c1798 ( 304 0 ) capacitor c=0.0173191f //x=2.275 //y=1.09
c1799 ( 303 0 ) capacitor c=0.110208f //x=80.08 //y=6.2
c1800 ( 302 0 ) capacitor c=0.110214f //x=79.64 //y=6.2
c1801 ( 301 0 ) capacitor c=0.159671f //x=76.15 //y=6.2
c1802 ( 300 0 ) capacitor c=0.110208f //x=75.71 //y=6.2
c1803 ( 299 0 ) capacitor c=0.110208f //x=60.84 //y=6.2
c1804 ( 298 0 ) capacitor c=0.110214f //x=60.4 //y=6.2
c1805 ( 297 0 ) capacitor c=0.110208f //x=51.22 //y=6.2
c1806 ( 296 0 ) capacitor c=0.110214f //x=50.78 //y=6.2
c1807 ( 295 0 ) capacitor c=0.159671f //x=47.29 //y=6.2
c1808 ( 294 0 ) capacitor c=0.110208f //x=46.85 //y=6.2
c1809 ( 293 0 ) capacitor c=0.110208f //x=31.98 //y=6.2
c1810 ( 292 0 ) capacitor c=0.110214f //x=31.54 //y=6.2
c1811 ( 291 0 ) capacitor c=0.110208f //x=22.36 //y=6.2
c1812 ( 290 0 ) capacitor c=0.110214f //x=21.92 //y=6.2
c1813 ( 289 0 ) capacitor c=0.159671f //x=18.43 //y=6.2
c1814 ( 288 0 ) capacitor c=0.110208f //x=17.99 //y=6.2
c1815 ( 287 0 ) capacitor c=0.110208f //x=3.12 //y=6.2
c1816 ( 286 0 ) capacitor c=0.110214f //x=2.68 //y=6.2
c1817 ( 273 0 ) capacitor c=0.00129935f //x=79.67 //y=4.88
c1818 ( 268 0 ) capacitor c=0.00121786f //x=79.67 //y=2.26
c1819 ( 263 0 ) capacitor c=7.7417e-19 //x=75.97 //y=4.88
c1820 ( 258 0 ) capacitor c=0.00101179f //x=75.97 //y=2.26
c1821 ( 253 0 ) capacitor c=0.00129935f //x=60.43 //y=4.88
c1822 ( 248 0 ) capacitor c=0.00121786f //x=60.43 //y=2.26
c1823 ( 243 0 ) capacitor c=0.00129935f //x=50.81 //y=4.88
c1824 ( 238 0 ) capacitor c=0.00121786f //x=50.81 //y=2.26
c1825 ( 233 0 ) capacitor c=9.12403e-19 //x=47.11 //y=4.88
c1826 ( 228 0 ) capacitor c=0.00101179f //x=47.11 //y=2.26
c1827 ( 223 0 ) capacitor c=0.00129935f //x=31.57 //y=4.88
c1828 ( 218 0 ) capacitor c=0.00121786f //x=31.57 //y=2.26
c1829 ( 213 0 ) capacitor c=0.00129935f //x=21.95 //y=4.88
c1830 ( 208 0 ) capacitor c=0.00121786f //x=21.95 //y=2.26
c1831 ( 203 0 ) capacitor c=7.7417e-19 //x=18.25 //y=4.88
c1832 ( 198 0 ) capacitor c=0.00101179f //x=18.25 //y=2.26
c1833 ( 193 0 ) capacitor c=0.00129935f //x=2.71 //y=4.88
c1834 ( 188 0 ) capacitor c=0.00121786f //x=2.71 //y=2.26
c1835 ( 185 0 ) capacitor c=0.0856406f //x=79.505 //y=2.41
c1836 ( 184 0 ) capacitor c=0.00498615f //x=79.665 //y=2.41
c1837 ( 165 0 ) capacitor c=0.0572008f //x=76.135 //y=2.4
c1838 ( 162 0 ) capacitor c=0.00875699f //x=73.975 //y=2.385
c1839 ( 160 0 ) capacitor c=0.0264842f //x=73.375 //y=2.4
c1840 ( 159 0 ) capacitor c=0.337144f //x=71.685 //y=2.385
c1841 ( 158 0 ) capacitor c=0.0147324f //x=72.115 //y=2.385
c1842 ( 156 0 ) capacitor c=0.00748096f //x=57.685 //y=2.37
c1843 ( 154 0 ) capacitor c=0.11012f //x=57.085 //y=2.4
c1844 ( 153 0 ) capacitor c=0.0267673f //x=51.7 //y=2.37
c1845 ( 152 0 ) capacitor c=0.0144094f //x=52.13 //y=2.37
c1846 ( 151 0 ) capacitor c=0.0572008f //x=47.275 //y=2.4
c1847 ( 150 0 ) capacitor c=0.0856406f //x=50.645 //y=2.4
c1848 ( 148 0 ) capacitor c=0.00875699f //x=45.115 //y=2.385
c1849 ( 146 0 ) capacitor c=0.0264842f //x=44.515 //y=2.4
c1850 ( 145 0 ) capacitor c=0.411855f //x=42.825 //y=2.385
c1851 ( 144 0 ) capacitor c=0.0147324f //x=43.255 //y=2.385
c1852 ( 142 0 ) capacitor c=0.00856815f //x=25.82 //y=2.37
c1853 ( 140 0 ) capacitor c=0.0240914f //x=25.22 //y=2.4
c1854 ( 139 0 ) capacitor c=0.0450305f //x=23.63 //y=2.37
c1855 ( 138 0 ) capacitor c=0.0149878f //x=24.06 //y=2.37
c1856 ( 137 0 ) capacitor c=0.0572008f //x=18.415 //y=2.4
c1857 ( 136 0 ) capacitor c=0.0856406f //x=21.785 //y=2.4
c1858 ( 134 0 ) capacitor c=0.00875699f //x=16.255 //y=2.385
c1859 ( 132 0 ) capacitor c=0.0264842f //x=15.655 //y=2.4
c1860 ( 130 0 ) capacitor c=0.0147324f //x=14.395 //y=2.385
c1861 ( 129 0 ) capacitor c=0.00551787f //x=2.87 //y=2.4
c1862 ( 128 0 ) capacitor c=0.271118f //x=13.795 //y=2.4
c1863 ( 65 0 ) capacitor c=0.00504675f //x=79.67 //y=4.765
c1864 ( 64 0 ) capacitor c=0.0121708f //x=79.67 //y=2.57
c1865 ( 62 0 ) capacitor c=0.00443476f //x=75.97 //y=4.75
c1866 ( 61 0 ) capacitor c=0.0133066f //x=75.97 //y=2.565
c1867 ( 57 0 ) capacitor c=0.00295423f //x=60.43 //y=4.765
c1868 ( 56 0 ) capacitor c=0.0115735f //x=60.43 //y=2.56
c1869 ( 53 0 ) capacitor c=0.00295171f //x=50.81 //y=4.765
c1870 ( 52 0 ) capacitor c=0.0121708f //x=50.81 //y=2.57
c1871 ( 50 0 ) capacitor c=0.00287846f //x=47.11 //y=4.75
c1872 ( 49 0 ) capacitor c=0.0132863f //x=47.11 //y=2.565
c1873 ( 45 0 ) capacitor c=0.00295423f //x=31.57 //y=4.765
c1874 ( 44 0 ) capacitor c=0.0115735f //x=31.57 //y=2.56
c1875 ( 41 0 ) capacitor c=0.00504675f //x=21.95 //y=4.765
c1876 ( 40 0 ) capacitor c=0.0121708f //x=21.95 //y=2.57
c1877 ( 38 0 ) capacitor c=0.00443476f //x=18.25 //y=4.75
c1878 ( 37 0 ) capacitor c=0.0133066f //x=18.25 //y=2.565
c1879 ( 31 0 ) capacitor c=0.00504926f //x=2.71 //y=4.765
c1880 ( 30 0 ) capacitor c=0.0116271f //x=2.71 //y=2.56
c1881 ( 19 0 ) capacitor c=0.0598746f //x=79.67 //y=2.77
c1882 ( 18 0 ) capacitor c=0.053007f //x=75.97 //y=2.77
c1883 ( 15 0 ) capacitor c=0.0603862f //x=60.43 //y=2.77
c1884 ( 13 0 ) capacitor c=0.0572226f //x=50.81 //y=2.77
c1885 ( 12 0 ) capacitor c=0.0530147f //x=47.11 //y=2.77
c1886 ( 9 0 ) capacitor c=0.0616901f //x=31.57 //y=2.77
c1887 ( 7 0 ) capacitor c=0.0573842f //x=21.95 //y=2.77
c1888 ( 6 0 ) capacitor c=0.0530147f //x=18.25 //y=2.77
c1889 ( 1 0 ) capacitor c=0.0666365f //x=2.71 //y=2.77
r1890 (  559 560 ) resistor r=32.4568 //w=0.214 //l=0.075 //layer=ply \
 //thickness=0.18 //x=79.67 //y=4.97 //x2=79.67 //y2=5.045
r1891 (  557 559 ) resistor r=20.271 //w=0.214 //l=0.09 //layer=ply \
 //thickness=0.18 //x=79.67 //y=4.88 //x2=79.67 //y2=4.97
r1892 (  545 546 ) resistor r=52.7279 //w=0.214 //l=0.165 //layer=ply \
 //thickness=0.18 //x=75.97 //y=2.26 //x2=75.97 //y2=2.095
r1893 (  538 539 ) resistor r=32.4568 //w=0.214 //l=0.075 //layer=ply \
 //thickness=0.18 //x=60.43 //y=4.97 //x2=60.43 //y2=5.045
r1894 (  536 538 ) resistor r=20.271 //w=0.214 //l=0.09 //layer=ply \
 //thickness=0.18 //x=60.43 //y=4.88 //x2=60.43 //y2=4.97
r1895 (  527 528 ) resistor r=32.4568 //w=0.214 //l=0.075 //layer=ply \
 //thickness=0.18 //x=50.81 //y=4.97 //x2=50.81 //y2=5.045
r1896 (  525 527 ) resistor r=20.271 //w=0.214 //l=0.09 //layer=ply \
 //thickness=0.18 //x=50.81 //y=4.88 //x2=50.81 //y2=4.97
r1897 (  513 514 ) resistor r=52.7279 //w=0.214 //l=0.165 //layer=ply \
 //thickness=0.18 //x=47.11 //y=2.26 //x2=47.11 //y2=2.095
r1898 (  506 507 ) resistor r=32.4568 //w=0.214 //l=0.075 //layer=ply \
 //thickness=0.18 //x=31.57 //y=4.97 //x2=31.57 //y2=5.045
r1899 (  504 506 ) resistor r=20.271 //w=0.214 //l=0.09 //layer=ply \
 //thickness=0.18 //x=31.57 //y=4.88 //x2=31.57 //y2=4.97
r1900 (  495 496 ) resistor r=32.4568 //w=0.214 //l=0.075 //layer=ply \
 //thickness=0.18 //x=21.95 //y=4.97 //x2=21.95 //y2=5.045
r1901 (  493 495 ) resistor r=20.271 //w=0.214 //l=0.09 //layer=ply \
 //thickness=0.18 //x=21.95 //y=4.88 //x2=21.95 //y2=4.97
r1902 (  481 482 ) resistor r=52.7279 //w=0.214 //l=0.165 //layer=ply \
 //thickness=0.18 //x=18.25 //y=2.26 //x2=18.25 //y2=2.095
r1903 (  474 475 ) resistor r=32.4568 //w=0.214 //l=0.075 //layer=ply \
 //thickness=0.18 //x=2.71 //y=4.97 //x2=2.71 //y2=5.045
r1904 (  472 474 ) resistor r=20.271 //w=0.214 //l=0.09 //layer=ply \
 //thickness=0.18 //x=2.71 //y=4.88 //x2=2.71 //y2=4.97
r1905 (  465 559 ) resistor r=16.5046 //w=0.27 //l=0.135 //layer=ply \
 //thickness=0.18 //x=79.805 //y=4.97 //x2=79.67 //y2=4.97
r1906 (  464 466 ) resistor r=26.9307 //w=0.15 //l=0.106066 //layer=ply \
 //thickness=0.18 //x=80.005 //y=4.97 //x2=80.08 //y2=5.045
r1907 (  464 465 ) resistor r=102.553 //w=0.094 //l=0.2 //layer=ply \
 //thickness=0.18 //x=80.005 //y=4.97 //x2=79.805 //y2=4.97
r1908 (  463 564 ) resistor r=38.6777 //w=0.284 //l=0.198997 //layer=ply \
 //thickness=0.18 //x=79.76 //y=2.095 //x2=79.685 //y2=2.26
r1909 (  462 562 ) resistor r=21.2976 //w=0.217 //l=0.0928709 //layer=ply \
 //thickness=0.18 //x=79.76 //y=1.63 //x2=79.72 //y2=1.555
r1910 (  462 463 ) resistor r=238.436 //w=0.094 //l=0.465 //layer=ply \
 //thickness=0.18 //x=79.76 //y=1.63 //x2=79.76 //y2=2.095
r1911 (  461 562 ) resistor r=39.0671 //w=0.217 //l=0.173853 //layer=ply \
 //thickness=0.18 //x=79.76 //y=1.4 //x2=79.72 //y2=1.555
r1912 (  460 561 ) resistor r=45.1352 //w=0.168 //l=0.173853 //layer=ply \
 //thickness=0.18 //x=79.76 //y=1.09 //x2=79.72 //y2=0.935
r1913 (  460 461 ) resistor r=158.957 //w=0.094 //l=0.31 //layer=ply \
 //thickness=0.18 //x=79.76 //y=1.09 //x2=79.76 //y2=1.4
r1914 (  455 555 ) resistor r=5.52526 //w=0.168 //l=0.115 //layer=ply \
 //thickness=0.18 //x=79.39 //y=1.555 //x2=79.275 //y2=1.555
r1915 (  454 562 ) resistor r=11.4558 //w=0.217 //l=0.115 //layer=ply \
 //thickness=0.18 //x=79.605 //y=1.555 //x2=79.72 //y2=1.555
r1916 (  453 554 ) resistor r=5.52526 //w=0.168 //l=0.115 //layer=ply \
 //thickness=0.18 //x=79.39 //y=0.935 //x2=79.275 //y2=0.935
r1917 (  452 561 ) resistor r=5.52526 //w=0.168 //l=0.115 //layer=ply \
 //thickness=0.18 //x=79.605 //y=0.935 //x2=79.72 //y2=0.935
r1918 (  452 453 ) resistor r=110.245 //w=0.094 //l=0.215 //layer=ply \
 //thickness=0.18 //x=79.605 //y=0.935 //x2=79.39 //y2=0.935
r1919 (  451 555 ) resistor r=45.1352 //w=0.168 //l=0.173853 //layer=ply \
 //thickness=0.18 //x=79.235 //y=1.4 //x2=79.275 //y2=1.555
r1920 (  450 554 ) resistor r=45.1352 //w=0.168 //l=0.173853 //layer=ply \
 //thickness=0.18 //x=79.235 //y=1.09 //x2=79.275 //y2=0.935
r1921 (  450 451 ) resistor r=158.957 //w=0.094 //l=0.31 //layer=ply \
 //thickness=0.18 //x=79.235 //y=1.09 //x2=79.235 //y2=1.4
r1922 (  449 553 ) resistor r=45.1352 //w=0.168 //l=0.173853 //layer=ply \
 //thickness=0.18 //x=76.49 //y=1.44 //x2=76.45 //y2=1.595
r1923 (  448 552 ) resistor r=45.1352 //w=0.168 //l=0.173853 //layer=ply \
 //thickness=0.18 //x=76.49 //y=1.095 //x2=76.45 //y2=0.94
r1924 (  448 449 ) resistor r=176.904 //w=0.094 //l=0.345 //layer=ply \
 //thickness=0.18 //x=76.49 //y=1.095 //x2=76.49 //y2=1.44
r1925 (  446 549 ) resistor r=10.701 //w=0.21 //l=0.115 //layer=ply \
 //thickness=0.18 //x=76.115 //y=1.595 //x2=76 //y2=1.595
r1926 (  445 553 ) resistor r=5.52526 //w=0.168 //l=0.115 //layer=ply \
 //thickness=0.18 //x=76.335 //y=1.595 //x2=76.45 //y2=1.595
r1927 (  444 548 ) resistor r=5.52526 //w=0.168 //l=0.115 //layer=ply \
 //thickness=0.18 //x=76.115 //y=0.94 //x2=76 //y2=0.94
r1928 (  443 552 ) resistor r=5.52526 //w=0.168 //l=0.115 //layer=ply \
 //thickness=0.18 //x=76.335 //y=0.94 //x2=76.45 //y2=0.94
r1929 (  443 444 ) resistor r=112.809 //w=0.094 //l=0.22 //layer=ply \
 //thickness=0.18 //x=76.335 //y=0.94 //x2=76.115 //y2=0.94
r1930 (  440 551 ) resistor r=37.236 //w=0.233 //l=0.249199 //layer=ply \
 //thickness=0.18 //x=76.15 //y=5.045 //x2=75.97 //y2=4.88
r1931 (  438 549 ) resistor r=39.5823 //w=0.21 //l=0.173853 //layer=ply \
 //thickness=0.18 //x=75.96 //y=1.75 //x2=76 //y2=1.595
r1932 (  438 546 ) resistor r=176.904 //w=0.094 //l=0.345 //layer=ply \
 //thickness=0.18 //x=75.96 //y=1.75 //x2=75.96 //y2=2.095
r1933 (  437 549 ) resistor r=39.5823 //w=0.21 //l=0.173853 //layer=ply \
 //thickness=0.18 //x=75.96 //y=1.44 //x2=76 //y2=1.595
r1934 (  436 548 ) resistor r=45.1352 //w=0.168 //l=0.173853 //layer=ply \
 //thickness=0.18 //x=75.96 //y=1.095 //x2=76 //y2=0.94
r1935 (  436 437 ) resistor r=176.904 //w=0.094 //l=0.345 //layer=ply \
 //thickness=0.18 //x=75.96 //y=1.095 //x2=75.96 //y2=1.44
r1936 (  433 551 ) resistor r=53.7854 //w=0.233 //l=0.332415 //layer=ply \
 //thickness=0.18 //x=75.71 //y=5.045 //x2=75.97 //y2=4.88
r1937 (  429 538 ) resistor r=16.5046 //w=0.27 //l=0.135 //layer=ply \
 //thickness=0.18 //x=60.565 //y=4.97 //x2=60.43 //y2=4.97
r1938 (  428 430 ) resistor r=26.9307 //w=0.15 //l=0.106066 //layer=ply \
 //thickness=0.18 //x=60.765 //y=4.97 //x2=60.84 //y2=5.045
r1939 (  428 429 ) resistor r=102.553 //w=0.094 //l=0.2 //layer=ply \
 //thickness=0.18 //x=60.765 //y=4.97 //x2=60.565 //y2=4.97
r1940 (  427 543 ) resistor r=38.6777 //w=0.284 //l=0.198997 //layer=ply \
 //thickness=0.18 //x=60.52 //y=2.095 //x2=60.445 //y2=2.26
r1941 (  426 541 ) resistor r=21.2976 //w=0.217 //l=0.0928709 //layer=ply \
 //thickness=0.18 //x=60.52 //y=1.63 //x2=60.48 //y2=1.555
r1942 (  426 427 ) resistor r=238.436 //w=0.094 //l=0.465 //layer=ply \
 //thickness=0.18 //x=60.52 //y=1.63 //x2=60.52 //y2=2.095
r1943 (  425 541 ) resistor r=39.0671 //w=0.217 //l=0.173853 //layer=ply \
 //thickness=0.18 //x=60.52 //y=1.4 //x2=60.48 //y2=1.555
r1944 (  424 540 ) resistor r=45.1352 //w=0.168 //l=0.173853 //layer=ply \
 //thickness=0.18 //x=60.52 //y=1.09 //x2=60.48 //y2=0.935
r1945 (  424 425 ) resistor r=158.957 //w=0.094 //l=0.31 //layer=ply \
 //thickness=0.18 //x=60.52 //y=1.09 //x2=60.52 //y2=1.4
r1946 (  419 534 ) resistor r=5.52526 //w=0.168 //l=0.115 //layer=ply \
 //thickness=0.18 //x=60.15 //y=1.555 //x2=60.035 //y2=1.555
r1947 (  418 541 ) resistor r=11.4558 //w=0.217 //l=0.115 //layer=ply \
 //thickness=0.18 //x=60.365 //y=1.555 //x2=60.48 //y2=1.555
r1948 (  417 533 ) resistor r=5.52526 //w=0.168 //l=0.115 //layer=ply \
 //thickness=0.18 //x=60.15 //y=0.935 //x2=60.035 //y2=0.935
r1949 (  416 540 ) resistor r=5.52526 //w=0.168 //l=0.115 //layer=ply \
 //thickness=0.18 //x=60.365 //y=0.935 //x2=60.48 //y2=0.935
r1950 (  416 417 ) resistor r=110.245 //w=0.094 //l=0.215 //layer=ply \
 //thickness=0.18 //x=60.365 //y=0.935 //x2=60.15 //y2=0.935
r1951 (  415 534 ) resistor r=45.1352 //w=0.168 //l=0.173853 //layer=ply \
 //thickness=0.18 //x=59.995 //y=1.4 //x2=60.035 //y2=1.555
r1952 (  414 533 ) resistor r=45.1352 //w=0.168 //l=0.173853 //layer=ply \
 //thickness=0.18 //x=59.995 //y=1.09 //x2=60.035 //y2=0.935
r1953 (  414 415 ) resistor r=158.957 //w=0.094 //l=0.31 //layer=ply \
 //thickness=0.18 //x=59.995 //y=1.09 //x2=59.995 //y2=1.4
r1954 (  410 527 ) resistor r=16.5046 //w=0.27 //l=0.135 //layer=ply \
 //thickness=0.18 //x=50.945 //y=4.97 //x2=50.81 //y2=4.97
r1955 (  409 411 ) resistor r=26.9307 //w=0.15 //l=0.106066 //layer=ply \
 //thickness=0.18 //x=51.145 //y=4.97 //x2=51.22 //y2=5.045
r1956 (  409 410 ) resistor r=102.553 //w=0.094 //l=0.2 //layer=ply \
 //thickness=0.18 //x=51.145 //y=4.97 //x2=50.945 //y2=4.97
r1957 (  408 532 ) resistor r=38.6777 //w=0.284 //l=0.198997 //layer=ply \
 //thickness=0.18 //x=50.9 //y=2.095 //x2=50.825 //y2=2.26
r1958 (  407 530 ) resistor r=21.2976 //w=0.217 //l=0.0928709 //layer=ply \
 //thickness=0.18 //x=50.9 //y=1.63 //x2=50.86 //y2=1.555
r1959 (  407 408 ) resistor r=238.436 //w=0.094 //l=0.465 //layer=ply \
 //thickness=0.18 //x=50.9 //y=1.63 //x2=50.9 //y2=2.095
r1960 (  406 530 ) resistor r=39.0671 //w=0.217 //l=0.173853 //layer=ply \
 //thickness=0.18 //x=50.9 //y=1.4 //x2=50.86 //y2=1.555
r1961 (  405 529 ) resistor r=45.1352 //w=0.168 //l=0.173853 //layer=ply \
 //thickness=0.18 //x=50.9 //y=1.09 //x2=50.86 //y2=0.935
r1962 (  405 406 ) resistor r=158.957 //w=0.094 //l=0.31 //layer=ply \
 //thickness=0.18 //x=50.9 //y=1.09 //x2=50.9 //y2=1.4
r1963 (  400 523 ) resistor r=5.52526 //w=0.168 //l=0.115 //layer=ply \
 //thickness=0.18 //x=50.53 //y=1.555 //x2=50.415 //y2=1.555
r1964 (  399 530 ) resistor r=11.4558 //w=0.217 //l=0.115 //layer=ply \
 //thickness=0.18 //x=50.745 //y=1.555 //x2=50.86 //y2=1.555
r1965 (  398 522 ) resistor r=5.52526 //w=0.168 //l=0.115 //layer=ply \
 //thickness=0.18 //x=50.53 //y=0.935 //x2=50.415 //y2=0.935
r1966 (  397 529 ) resistor r=5.52526 //w=0.168 //l=0.115 //layer=ply \
 //thickness=0.18 //x=50.745 //y=0.935 //x2=50.86 //y2=0.935
r1967 (  397 398 ) resistor r=110.245 //w=0.094 //l=0.215 //layer=ply \
 //thickness=0.18 //x=50.745 //y=0.935 //x2=50.53 //y2=0.935
r1968 (  396 523 ) resistor r=45.1352 //w=0.168 //l=0.173853 //layer=ply \
 //thickness=0.18 //x=50.375 //y=1.4 //x2=50.415 //y2=1.555
r1969 (  395 522 ) resistor r=45.1352 //w=0.168 //l=0.173853 //layer=ply \
 //thickness=0.18 //x=50.375 //y=1.09 //x2=50.415 //y2=0.935
r1970 (  395 396 ) resistor r=158.957 //w=0.094 //l=0.31 //layer=ply \
 //thickness=0.18 //x=50.375 //y=1.09 //x2=50.375 //y2=1.4
r1971 (  394 521 ) resistor r=45.1352 //w=0.168 //l=0.173853 //layer=ply \
 //thickness=0.18 //x=47.63 //y=1.44 //x2=47.59 //y2=1.595
r1972 (  393 520 ) resistor r=45.1352 //w=0.168 //l=0.173853 //layer=ply \
 //thickness=0.18 //x=47.63 //y=1.095 //x2=47.59 //y2=0.94
r1973 (  393 394 ) resistor r=176.904 //w=0.094 //l=0.345 //layer=ply \
 //thickness=0.18 //x=47.63 //y=1.095 //x2=47.63 //y2=1.44
r1974 (  391 517 ) resistor r=10.701 //w=0.21 //l=0.115 //layer=ply \
 //thickness=0.18 //x=47.255 //y=1.595 //x2=47.14 //y2=1.595
r1975 (  390 521 ) resistor r=5.52526 //w=0.168 //l=0.115 //layer=ply \
 //thickness=0.18 //x=47.475 //y=1.595 //x2=47.59 //y2=1.595
r1976 (  389 516 ) resistor r=5.52526 //w=0.168 //l=0.115 //layer=ply \
 //thickness=0.18 //x=47.255 //y=0.94 //x2=47.14 //y2=0.94
r1977 (  388 520 ) resistor r=5.52526 //w=0.168 //l=0.115 //layer=ply \
 //thickness=0.18 //x=47.475 //y=0.94 //x2=47.59 //y2=0.94
r1978 (  388 389 ) resistor r=112.809 //w=0.094 //l=0.22 //layer=ply \
 //thickness=0.18 //x=47.475 //y=0.94 //x2=47.255 //y2=0.94
r1979 (  385 519 ) resistor r=37.236 //w=0.233 //l=0.249199 //layer=ply \
 //thickness=0.18 //x=47.29 //y=5.045 //x2=47.11 //y2=4.88
r1980 (  383 517 ) resistor r=39.5823 //w=0.21 //l=0.173853 //layer=ply \
 //thickness=0.18 //x=47.1 //y=1.75 //x2=47.14 //y2=1.595
r1981 (  383 514 ) resistor r=176.904 //w=0.094 //l=0.345 //layer=ply \
 //thickness=0.18 //x=47.1 //y=1.75 //x2=47.1 //y2=2.095
r1982 (  382 517 ) resistor r=39.5823 //w=0.21 //l=0.173853 //layer=ply \
 //thickness=0.18 //x=47.1 //y=1.44 //x2=47.14 //y2=1.595
r1983 (  381 516 ) resistor r=45.1352 //w=0.168 //l=0.173853 //layer=ply \
 //thickness=0.18 //x=47.1 //y=1.095 //x2=47.14 //y2=0.94
r1984 (  381 382 ) resistor r=176.904 //w=0.094 //l=0.345 //layer=ply \
 //thickness=0.18 //x=47.1 //y=1.095 //x2=47.1 //y2=1.44
r1985 (  378 519 ) resistor r=53.7854 //w=0.233 //l=0.332415 //layer=ply \
 //thickness=0.18 //x=46.85 //y=5.045 //x2=47.11 //y2=4.88
r1986 (  374 506 ) resistor r=16.5046 //w=0.27 //l=0.135 //layer=ply \
 //thickness=0.18 //x=31.705 //y=4.97 //x2=31.57 //y2=4.97
r1987 (  373 375 ) resistor r=26.9307 //w=0.15 //l=0.106066 //layer=ply \
 //thickness=0.18 //x=31.905 //y=4.97 //x2=31.98 //y2=5.045
r1988 (  373 374 ) resistor r=102.553 //w=0.094 //l=0.2 //layer=ply \
 //thickness=0.18 //x=31.905 //y=4.97 //x2=31.705 //y2=4.97
r1989 (  372 511 ) resistor r=38.6777 //w=0.284 //l=0.198997 //layer=ply \
 //thickness=0.18 //x=31.66 //y=2.095 //x2=31.585 //y2=2.26
r1990 (  371 509 ) resistor r=21.2976 //w=0.217 //l=0.0928709 //layer=ply \
 //thickness=0.18 //x=31.66 //y=1.63 //x2=31.62 //y2=1.555
r1991 (  371 372 ) resistor r=238.436 //w=0.094 //l=0.465 //layer=ply \
 //thickness=0.18 //x=31.66 //y=1.63 //x2=31.66 //y2=2.095
r1992 (  370 509 ) resistor r=39.0671 //w=0.217 //l=0.173853 //layer=ply \
 //thickness=0.18 //x=31.66 //y=1.4 //x2=31.62 //y2=1.555
r1993 (  369 508 ) resistor r=45.1352 //w=0.168 //l=0.173853 //layer=ply \
 //thickness=0.18 //x=31.66 //y=1.09 //x2=31.62 //y2=0.935
r1994 (  369 370 ) resistor r=158.957 //w=0.094 //l=0.31 //layer=ply \
 //thickness=0.18 //x=31.66 //y=1.09 //x2=31.66 //y2=1.4
r1995 (  364 502 ) resistor r=5.52526 //w=0.168 //l=0.115 //layer=ply \
 //thickness=0.18 //x=31.29 //y=1.555 //x2=31.175 //y2=1.555
r1996 (  363 509 ) resistor r=11.4558 //w=0.217 //l=0.115 //layer=ply \
 //thickness=0.18 //x=31.505 //y=1.555 //x2=31.62 //y2=1.555
r1997 (  362 501 ) resistor r=5.52526 //w=0.168 //l=0.115 //layer=ply \
 //thickness=0.18 //x=31.29 //y=0.935 //x2=31.175 //y2=0.935
r1998 (  361 508 ) resistor r=5.52526 //w=0.168 //l=0.115 //layer=ply \
 //thickness=0.18 //x=31.505 //y=0.935 //x2=31.62 //y2=0.935
r1999 (  361 362 ) resistor r=110.245 //w=0.094 //l=0.215 //layer=ply \
 //thickness=0.18 //x=31.505 //y=0.935 //x2=31.29 //y2=0.935
r2000 (  360 502 ) resistor r=45.1352 //w=0.168 //l=0.173853 //layer=ply \
 //thickness=0.18 //x=31.135 //y=1.4 //x2=31.175 //y2=1.555
r2001 (  359 501 ) resistor r=45.1352 //w=0.168 //l=0.173853 //layer=ply \
 //thickness=0.18 //x=31.135 //y=1.09 //x2=31.175 //y2=0.935
r2002 (  359 360 ) resistor r=158.957 //w=0.094 //l=0.31 //layer=ply \
 //thickness=0.18 //x=31.135 //y=1.09 //x2=31.135 //y2=1.4
r2003 (  355 495 ) resistor r=16.5046 //w=0.27 //l=0.135 //layer=ply \
 //thickness=0.18 //x=22.085 //y=4.97 //x2=21.95 //y2=4.97
r2004 (  354 356 ) resistor r=26.9307 //w=0.15 //l=0.106066 //layer=ply \
 //thickness=0.18 //x=22.285 //y=4.97 //x2=22.36 //y2=5.045
r2005 (  354 355 ) resistor r=102.553 //w=0.094 //l=0.2 //layer=ply \
 //thickness=0.18 //x=22.285 //y=4.97 //x2=22.085 //y2=4.97
r2006 (  353 500 ) resistor r=38.6777 //w=0.284 //l=0.198997 //layer=ply \
 //thickness=0.18 //x=22.04 //y=2.095 //x2=21.965 //y2=2.26
r2007 (  352 498 ) resistor r=21.2976 //w=0.217 //l=0.0928709 //layer=ply \
 //thickness=0.18 //x=22.04 //y=1.63 //x2=22 //y2=1.555
r2008 (  352 353 ) resistor r=238.436 //w=0.094 //l=0.465 //layer=ply \
 //thickness=0.18 //x=22.04 //y=1.63 //x2=22.04 //y2=2.095
r2009 (  351 498 ) resistor r=39.0671 //w=0.217 //l=0.173853 //layer=ply \
 //thickness=0.18 //x=22.04 //y=1.4 //x2=22 //y2=1.555
r2010 (  350 497 ) resistor r=45.1352 //w=0.168 //l=0.173853 //layer=ply \
 //thickness=0.18 //x=22.04 //y=1.09 //x2=22 //y2=0.935
r2011 (  350 351 ) resistor r=158.957 //w=0.094 //l=0.31 //layer=ply \
 //thickness=0.18 //x=22.04 //y=1.09 //x2=22.04 //y2=1.4
r2012 (  345 491 ) resistor r=5.52526 //w=0.168 //l=0.115 //layer=ply \
 //thickness=0.18 //x=21.67 //y=1.555 //x2=21.555 //y2=1.555
r2013 (  344 498 ) resistor r=11.4558 //w=0.217 //l=0.115 //layer=ply \
 //thickness=0.18 //x=21.885 //y=1.555 //x2=22 //y2=1.555
r2014 (  343 490 ) resistor r=5.52526 //w=0.168 //l=0.115 //layer=ply \
 //thickness=0.18 //x=21.67 //y=0.935 //x2=21.555 //y2=0.935
r2015 (  342 497 ) resistor r=5.52526 //w=0.168 //l=0.115 //layer=ply \
 //thickness=0.18 //x=21.885 //y=0.935 //x2=22 //y2=0.935
r2016 (  342 343 ) resistor r=110.245 //w=0.094 //l=0.215 //layer=ply \
 //thickness=0.18 //x=21.885 //y=0.935 //x2=21.67 //y2=0.935
r2017 (  341 491 ) resistor r=45.1352 //w=0.168 //l=0.173853 //layer=ply \
 //thickness=0.18 //x=21.515 //y=1.4 //x2=21.555 //y2=1.555
r2018 (  340 490 ) resistor r=45.1352 //w=0.168 //l=0.173853 //layer=ply \
 //thickness=0.18 //x=21.515 //y=1.09 //x2=21.555 //y2=0.935
r2019 (  340 341 ) resistor r=158.957 //w=0.094 //l=0.31 //layer=ply \
 //thickness=0.18 //x=21.515 //y=1.09 //x2=21.515 //y2=1.4
r2020 (  339 489 ) resistor r=45.1352 //w=0.168 //l=0.173853 //layer=ply \
 //thickness=0.18 //x=18.77 //y=1.44 //x2=18.73 //y2=1.595
r2021 (  338 488 ) resistor r=45.1352 //w=0.168 //l=0.173853 //layer=ply \
 //thickness=0.18 //x=18.77 //y=1.095 //x2=18.73 //y2=0.94
r2022 (  338 339 ) resistor r=176.904 //w=0.094 //l=0.345 //layer=ply \
 //thickness=0.18 //x=18.77 //y=1.095 //x2=18.77 //y2=1.44
r2023 (  336 485 ) resistor r=10.701 //w=0.21 //l=0.115 //layer=ply \
 //thickness=0.18 //x=18.395 //y=1.595 //x2=18.28 //y2=1.595
r2024 (  335 489 ) resistor r=5.52526 //w=0.168 //l=0.115 //layer=ply \
 //thickness=0.18 //x=18.615 //y=1.595 //x2=18.73 //y2=1.595
r2025 (  334 484 ) resistor r=5.52526 //w=0.168 //l=0.115 //layer=ply \
 //thickness=0.18 //x=18.395 //y=0.94 //x2=18.28 //y2=0.94
r2026 (  333 488 ) resistor r=5.52526 //w=0.168 //l=0.115 //layer=ply \
 //thickness=0.18 //x=18.615 //y=0.94 //x2=18.73 //y2=0.94
r2027 (  333 334 ) resistor r=112.809 //w=0.094 //l=0.22 //layer=ply \
 //thickness=0.18 //x=18.615 //y=0.94 //x2=18.395 //y2=0.94
r2028 (  330 487 ) resistor r=37.236 //w=0.233 //l=0.249199 //layer=ply \
 //thickness=0.18 //x=18.43 //y=5.045 //x2=18.25 //y2=4.88
r2029 (  328 485 ) resistor r=39.5823 //w=0.21 //l=0.173853 //layer=ply \
 //thickness=0.18 //x=18.24 //y=1.75 //x2=18.28 //y2=1.595
r2030 (  328 482 ) resistor r=176.904 //w=0.094 //l=0.345 //layer=ply \
 //thickness=0.18 //x=18.24 //y=1.75 //x2=18.24 //y2=2.095
r2031 (  327 485 ) resistor r=39.5823 //w=0.21 //l=0.173853 //layer=ply \
 //thickness=0.18 //x=18.24 //y=1.44 //x2=18.28 //y2=1.595
r2032 (  326 484 ) resistor r=45.1352 //w=0.168 //l=0.173853 //layer=ply \
 //thickness=0.18 //x=18.24 //y=1.095 //x2=18.28 //y2=0.94
r2033 (  326 327 ) resistor r=176.904 //w=0.094 //l=0.345 //layer=ply \
 //thickness=0.18 //x=18.24 //y=1.095 //x2=18.24 //y2=1.44
r2034 (  323 487 ) resistor r=53.7854 //w=0.233 //l=0.332415 //layer=ply \
 //thickness=0.18 //x=17.99 //y=5.045 //x2=18.25 //y2=4.88
r2035 (  319 474 ) resistor r=16.5046 //w=0.27 //l=0.135 //layer=ply \
 //thickness=0.18 //x=2.845 //y=4.97 //x2=2.71 //y2=4.97
r2036 (  318 320 ) resistor r=26.9307 //w=0.15 //l=0.106066 //layer=ply \
 //thickness=0.18 //x=3.045 //y=4.97 //x2=3.12 //y2=5.045
r2037 (  318 319 ) resistor r=102.553 //w=0.094 //l=0.2 //layer=ply \
 //thickness=0.18 //x=3.045 //y=4.97 //x2=2.845 //y2=4.97
r2038 (  317 479 ) resistor r=38.6777 //w=0.284 //l=0.198997 //layer=ply \
 //thickness=0.18 //x=2.8 //y=2.095 //x2=2.725 //y2=2.26
r2039 (  316 477 ) resistor r=21.2976 //w=0.217 //l=0.0928709 //layer=ply \
 //thickness=0.18 //x=2.8 //y=1.63 //x2=2.76 //y2=1.555
r2040 (  316 317 ) resistor r=238.436 //w=0.094 //l=0.465 //layer=ply \
 //thickness=0.18 //x=2.8 //y=1.63 //x2=2.8 //y2=2.095
r2041 (  315 477 ) resistor r=39.0671 //w=0.217 //l=0.173853 //layer=ply \
 //thickness=0.18 //x=2.8 //y=1.4 //x2=2.76 //y2=1.555
r2042 (  314 476 ) resistor r=45.1352 //w=0.168 //l=0.173853 //layer=ply \
 //thickness=0.18 //x=2.8 //y=1.09 //x2=2.76 //y2=0.935
r2043 (  314 315 ) resistor r=158.957 //w=0.094 //l=0.31 //layer=ply \
 //thickness=0.18 //x=2.8 //y=1.09 //x2=2.8 //y2=1.4
r2044 (  309 470 ) resistor r=5.52526 //w=0.168 //l=0.115 //layer=ply \
 //thickness=0.18 //x=2.43 //y=1.555 //x2=2.315 //y2=1.555
r2045 (  308 477 ) resistor r=11.4558 //w=0.217 //l=0.115 //layer=ply \
 //thickness=0.18 //x=2.645 //y=1.555 //x2=2.76 //y2=1.555
r2046 (  307 469 ) resistor r=5.52526 //w=0.168 //l=0.115 //layer=ply \
 //thickness=0.18 //x=2.43 //y=0.935 //x2=2.315 //y2=0.935
r2047 (  306 476 ) resistor r=5.52526 //w=0.168 //l=0.115 //layer=ply \
 //thickness=0.18 //x=2.645 //y=0.935 //x2=2.76 //y2=0.935
r2048 (  306 307 ) resistor r=110.245 //w=0.094 //l=0.215 //layer=ply \
 //thickness=0.18 //x=2.645 //y=0.935 //x2=2.43 //y2=0.935
r2049 (  305 470 ) resistor r=45.1352 //w=0.168 //l=0.173853 //layer=ply \
 //thickness=0.18 //x=2.275 //y=1.4 //x2=2.315 //y2=1.555
r2050 (  304 469 ) resistor r=45.1352 //w=0.168 //l=0.173853 //layer=ply \
 //thickness=0.18 //x=2.275 //y=1.09 //x2=2.315 //y2=0.935
r2051 (  304 305 ) resistor r=158.957 //w=0.094 //l=0.31 //layer=ply \
 //thickness=0.18 //x=2.275 //y=1.09 //x2=2.275 //y2=1.4
r2052 (  303 466 ) resistor r=592.245 //w=0.094 //l=1.155 //layer=ply \
 //thickness=0.18 //x=80.08 //y=6.2 //x2=80.08 //y2=5.045
r2053 (  302 560 ) resistor r=592.245 //w=0.094 //l=1.155 //layer=ply \
 //thickness=0.18 //x=79.64 //y=6.2 //x2=79.64 //y2=5.045
r2054 (  301 440 ) resistor r=592.245 //w=0.094 //l=1.155 //layer=ply \
 //thickness=0.18 //x=76.15 //y=6.2 //x2=76.15 //y2=5.045
r2055 (  300 433 ) resistor r=592.245 //w=0.094 //l=1.155 //layer=ply \
 //thickness=0.18 //x=75.71 //y=6.2 //x2=75.71 //y2=5.045
r2056 (  299 430 ) resistor r=592.245 //w=0.094 //l=1.155 //layer=ply \
 //thickness=0.18 //x=60.84 //y=6.2 //x2=60.84 //y2=5.045
r2057 (  298 539 ) resistor r=592.245 //w=0.094 //l=1.155 //layer=ply \
 //thickness=0.18 //x=60.4 //y=6.2 //x2=60.4 //y2=5.045
r2058 (  297 411 ) resistor r=592.245 //w=0.094 //l=1.155 //layer=ply \
 //thickness=0.18 //x=51.22 //y=6.2 //x2=51.22 //y2=5.045
r2059 (  296 528 ) resistor r=592.245 //w=0.094 //l=1.155 //layer=ply \
 //thickness=0.18 //x=50.78 //y=6.2 //x2=50.78 //y2=5.045
r2060 (  295 385 ) resistor r=592.245 //w=0.094 //l=1.155 //layer=ply \
 //thickness=0.18 //x=47.29 //y=6.2 //x2=47.29 //y2=5.045
r2061 (  294 378 ) resistor r=592.245 //w=0.094 //l=1.155 //layer=ply \
 //thickness=0.18 //x=46.85 //y=6.2 //x2=46.85 //y2=5.045
r2062 (  293 375 ) resistor r=592.245 //w=0.094 //l=1.155 //layer=ply \
 //thickness=0.18 //x=31.98 //y=6.2 //x2=31.98 //y2=5.045
r2063 (  292 507 ) resistor r=592.245 //w=0.094 //l=1.155 //layer=ply \
 //thickness=0.18 //x=31.54 //y=6.2 //x2=31.54 //y2=5.045
r2064 (  291 356 ) resistor r=592.245 //w=0.094 //l=1.155 //layer=ply \
 //thickness=0.18 //x=22.36 //y=6.2 //x2=22.36 //y2=5.045
r2065 (  290 496 ) resistor r=592.245 //w=0.094 //l=1.155 //layer=ply \
 //thickness=0.18 //x=21.92 //y=6.2 //x2=21.92 //y2=5.045
r2066 (  289 330 ) resistor r=592.245 //w=0.094 //l=1.155 //layer=ply \
 //thickness=0.18 //x=18.43 //y=6.2 //x2=18.43 //y2=5.045
r2067 (  288 323 ) resistor r=592.245 //w=0.094 //l=1.155 //layer=ply \
 //thickness=0.18 //x=17.99 //y=6.2 //x2=17.99 //y2=5.045
r2068 (  287 320 ) resistor r=592.245 //w=0.094 //l=1.155 //layer=ply \
 //thickness=0.18 //x=3.12 //y=6.2 //x2=3.12 //y2=5.045
r2069 (  286 475 ) resistor r=592.245 //w=0.094 //l=1.155 //layer=ply \
 //thickness=0.18 //x=2.68 //y=6.2 //x2=2.68 //y2=5.045
r2070 (  285 454 ) resistor r=55.3787 //w=0.094 //l=0.108 //layer=ply \
 //thickness=0.18 //x=79.497 //y=1.555 //x2=79.605 //y2=1.555
r2071 (  285 455 ) resistor r=54.866 //w=0.094 //l=0.107 //layer=ply \
 //thickness=0.18 //x=79.497 //y=1.555 //x2=79.39 //y2=1.555
r2072 (  284 445 ) resistor r=56.4043 //w=0.094 //l=0.11 //layer=ply \
 //thickness=0.18 //x=76.225 //y=1.595 //x2=76.335 //y2=1.595
r2073 (  284 446 ) resistor r=56.4043 //w=0.094 //l=0.11 //layer=ply \
 //thickness=0.18 //x=76.225 //y=1.595 //x2=76.115 //y2=1.595
r2074 (  283 418 ) resistor r=55.3787 //w=0.094 //l=0.108 //layer=ply \
 //thickness=0.18 //x=60.257 //y=1.555 //x2=60.365 //y2=1.555
r2075 (  283 419 ) resistor r=54.866 //w=0.094 //l=0.107 //layer=ply \
 //thickness=0.18 //x=60.257 //y=1.555 //x2=60.15 //y2=1.555
r2076 (  282 399 ) resistor r=55.3787 //w=0.094 //l=0.108 //layer=ply \
 //thickness=0.18 //x=50.637 //y=1.555 //x2=50.745 //y2=1.555
r2077 (  282 400 ) resistor r=54.866 //w=0.094 //l=0.107 //layer=ply \
 //thickness=0.18 //x=50.637 //y=1.555 //x2=50.53 //y2=1.555
r2078 (  281 390 ) resistor r=56.4043 //w=0.094 //l=0.11 //layer=ply \
 //thickness=0.18 //x=47.365 //y=1.595 //x2=47.475 //y2=1.595
r2079 (  281 391 ) resistor r=56.4043 //w=0.094 //l=0.11 //layer=ply \
 //thickness=0.18 //x=47.365 //y=1.595 //x2=47.255 //y2=1.595
r2080 (  280 363 ) resistor r=55.3787 //w=0.094 //l=0.108 //layer=ply \
 //thickness=0.18 //x=31.397 //y=1.555 //x2=31.505 //y2=1.555
r2081 (  280 364 ) resistor r=54.866 //w=0.094 //l=0.107 //layer=ply \
 //thickness=0.18 //x=31.397 //y=1.555 //x2=31.29 //y2=1.555
r2082 (  279 344 ) resistor r=55.3787 //w=0.094 //l=0.108 //layer=ply \
 //thickness=0.18 //x=21.777 //y=1.555 //x2=21.885 //y2=1.555
r2083 (  279 345 ) resistor r=54.866 //w=0.094 //l=0.107 //layer=ply \
 //thickness=0.18 //x=21.777 //y=1.555 //x2=21.67 //y2=1.555
r2084 (  278 335 ) resistor r=56.4043 //w=0.094 //l=0.11 //layer=ply \
 //thickness=0.18 //x=18.505 //y=1.595 //x2=18.615 //y2=1.595
r2085 (  278 336 ) resistor r=56.4043 //w=0.094 //l=0.11 //layer=ply \
 //thickness=0.18 //x=18.505 //y=1.595 //x2=18.395 //y2=1.595
r2086 (  277 308 ) resistor r=55.3787 //w=0.094 //l=0.108 //layer=ply \
 //thickness=0.18 //x=2.537 //y=1.555 //x2=2.645 //y2=1.555
r2087 (  277 309 ) resistor r=54.866 //w=0.094 //l=0.107 //layer=ply \
 //thickness=0.18 //x=2.537 //y=1.555 //x2=2.43 //y2=1.555
r2088 (  273 557 ) resistor r=152 //w=0.17 //l=0.17 //layer=licon //count=1 \
 //x=79.67 //y=4.88 //x2=79.67 //y2=4.88
r2089 (  268 564 ) resistor r=152 //w=0.17 //l=0.17 //layer=licon //count=1 \
 //x=79.67 //y=2.26 //x2=79.67 //y2=2.26
r2090 (  263 551 ) resistor r=152 //w=0.17 //l=0.17 //layer=licon //count=1 \
 //x=75.97 //y=4.88 //x2=75.97 //y2=4.88
r2091 (  258 545 ) resistor r=152 //w=0.17 //l=0.17 //layer=licon //count=1 \
 //x=75.97 //y=2.26 //x2=75.97 //y2=2.26
r2092 (  253 536 ) resistor r=152 //w=0.17 //l=0.17 //layer=licon //count=1 \
 //x=60.43 //y=4.88 //x2=60.43 //y2=4.88
r2093 (  248 543 ) resistor r=152 //w=0.17 //l=0.17 //layer=licon //count=1 \
 //x=60.43 //y=2.26 //x2=60.43 //y2=2.26
r2094 (  243 525 ) resistor r=152 //w=0.17 //l=0.17 //layer=licon //count=1 \
 //x=50.81 //y=4.88 //x2=50.81 //y2=4.88
r2095 (  238 532 ) resistor r=152 //w=0.17 //l=0.17 //layer=licon //count=1 \
 //x=50.81 //y=2.26 //x2=50.81 //y2=2.26
r2096 (  233 519 ) resistor r=152 //w=0.17 //l=0.17 //layer=licon //count=1 \
 //x=47.11 //y=4.88 //x2=47.11 //y2=4.88
r2097 (  228 513 ) resistor r=152 //w=0.17 //l=0.17 //layer=licon //count=1 \
 //x=47.11 //y=2.26 //x2=47.11 //y2=2.26
r2098 (  223 504 ) resistor r=152 //w=0.17 //l=0.17 //layer=licon //count=1 \
 //x=31.57 //y=4.88 //x2=31.57 //y2=4.88
r2099 (  218 511 ) resistor r=152 //w=0.17 //l=0.17 //layer=licon //count=1 \
 //x=31.57 //y=2.26 //x2=31.57 //y2=2.26
r2100 (  213 493 ) resistor r=152 //w=0.17 //l=0.17 //layer=licon //count=1 \
 //x=21.95 //y=4.88 //x2=21.95 //y2=4.88
r2101 (  208 500 ) resistor r=152 //w=0.17 //l=0.17 //layer=licon //count=1 \
 //x=21.95 //y=2.26 //x2=21.95 //y2=2.26
r2102 (  203 487 ) resistor r=152 //w=0.17 //l=0.17 //layer=licon //count=1 \
 //x=18.25 //y=4.88 //x2=18.25 //y2=4.88
r2103 (  198 481 ) resistor r=152 //w=0.17 //l=0.17 //layer=licon //count=1 \
 //x=18.25 //y=2.26 //x2=18.25 //y2=2.26
r2104 (  193 472 ) resistor r=152 //w=0.17 //l=0.17 //layer=licon //count=1 \
 //x=2.71 //y=4.88 //x2=2.71 //y2=4.88
r2105 (  188 479 ) resistor r=152 //w=0.17 //l=0.17 //layer=licon //count=1 \
 //x=2.71 //y=2.26 //x2=2.71 //y2=2.26
r2106 (  184 185 ) resistor r=0.10734 //w=0.281 //l=0.16 //layer=m2 \
 //thickness=0.36 //x=79.665 //y=2.41 //x2=79.505 //y2=2.41
r2107 (  165 182 ) resistor r=0.105717 //w=0.193 //l=0.162481 //layer=m2 \
 //thickness=0.36 //x=76.135 //y=2.4 //x2=75.975 //y2=2.405
r2108 (  165 185 ) resistor r=3.21565 //w=0.131 //l=3.37 //layer=m2 \
 //thickness=0.36 //x=76.135 //y=2.4 //x2=79.505 //y2=2.4
r2109 (  162 182 ) resistor r=1.29743 //w=0.193 //l=2.00998 //layer=m2 \
 //thickness=0.36 //x=73.975 //y=2.385 //x2=75.975 //y2=2.405
r2110 (  162 163 ) resistor r=0.410305 //w=0.131 //l=0.43 //layer=m2 \
 //thickness=0.36 //x=73.975 //y=2.385 //x2=73.545 //y2=2.385
r2111 (  160 163 ) resistor r=0.125 //w=0.17 //l=0.177341 //layer=m2 \
 //thickness=0.36 //x=73.375 //y=2.4 //x2=73.545 //y2=2.385
r2112 (  160 161 ) resistor r=0.958969 //w=0.131 //l=1.005 //layer=m2 \
 //thickness=0.36 //x=73.375 //y=2.4 //x2=72.37 //y2=2.4
r2113 (  159 180 ) resistor r=8.08549 //w=0.174 //l=11.2625 //layer=m2 \
 //thickness=0.36 //x=71.685 //y=2.385 //x2=60.43 //y2=2.4
r2114 (  158 161 ) resistor r=0.1875 //w=0.17 //l=0.262393 //layer=m2 \
 //thickness=0.36 //x=72.115 //y=2.385 //x2=72.37 //y2=2.4
r2115 (  158 159 ) resistor r=0.410305 //w=0.131 //l=0.43 //layer=m2 \
 //thickness=0.36 //x=72.115 //y=2.385 //x2=71.685 //y2=2.385
r2116 (  156 180 ) resistor r=1.97198 //w=0.174 //l=2.75996 //layer=m2 \
 //thickness=0.36 //x=57.685 //y=2.37 //x2=60.43 //y2=2.4
r2117 (  156 157 ) resistor r=0.410305 //w=0.131 //l=0.43 //layer=m2 \
 //thickness=0.36 //x=57.685 //y=2.37 //x2=57.255 //y2=2.37
r2118 (  154 157 ) resistor r=0.125 //w=0.17 //l=0.184391 //layer=m2 \
 //thickness=0.36 //x=57.085 //y=2.4 //x2=57.255 //y2=2.37
r2119 (  154 155 ) resistor r=4.48473 //w=0.131 //l=4.7 //layer=m2 \
 //thickness=0.36 //x=57.085 //y=2.4 //x2=52.385 //y2=2.4
r2120 (  153 178 ) resistor r=0.523955 //w=0.216 //l=0.914781 //layer=m2 \
 //thickness=0.36 //x=51.7 //y=2.37 //x2=50.805 //y2=2.41
r2121 (  152 155 ) resistor r=0.1875 //w=0.17 //l=0.269583 //layer=m2 \
 //thickness=0.36 //x=52.13 //y=2.37 //x2=52.385 //y2=2.4
r2122 (  152 153 ) resistor r=0.410305 //w=0.131 //l=0.43 //layer=m2 \
 //thickness=0.36 //x=52.13 //y=2.37 //x2=51.7 //y2=2.37
r2123 (  151 176 ) resistor r=0.105717 //w=0.193 //l=0.162481 //layer=m2 \
 //thickness=0.36 //x=47.275 //y=2.4 //x2=47.115 //y2=2.405
r2124 (  150 178 ) resistor r=0.0986081 //w=0.216 //l=0.164924 //layer=m2 \
 //thickness=0.36 //x=50.645 //y=2.4 //x2=50.805 //y2=2.41
r2125 (  150 151 ) resistor r=3.21565 //w=0.131 //l=3.37 //layer=m2 \
 //thickness=0.36 //x=50.645 //y=2.4 //x2=47.275 //y2=2.4
r2126 (  148 176 ) resistor r=1.29743 //w=0.193 //l=2.00998 //layer=m2 \
 //thickness=0.36 //x=45.115 //y=2.385 //x2=47.115 //y2=2.405
r2127 (  148 149 ) resistor r=0.410305 //w=0.131 //l=0.43 //layer=m2 \
 //thickness=0.36 //x=45.115 //y=2.385 //x2=44.685 //y2=2.385
r2128 (  146 149 ) resistor r=0.125 //w=0.17 //l=0.177341 //layer=m2 \
 //thickness=0.36 //x=44.515 //y=2.4 //x2=44.685 //y2=2.385
r2129 (  146 147 ) resistor r=0.958969 //w=0.131 //l=1.005 //layer=m2 \
 //thickness=0.36 //x=44.515 //y=2.4 //x2=43.51 //y2=2.4
r2130 (  145 174 ) resistor r=8.13223 //w=0.173 //l=11.2625 //layer=m2 \
 //thickness=0.36 //x=42.825 //y=2.385 //x2=31.57 //y2=2.4
r2131 (  144 147 ) resistor r=0.1875 //w=0.17 //l=0.262393 //layer=m2 \
 //thickness=0.36 //x=43.255 //y=2.385 //x2=43.51 //y2=2.4
r2132 (  144 145 ) resistor r=0.410305 //w=0.131 //l=0.43 //layer=m2 \
 //thickness=0.36 //x=43.255 //y=2.385 //x2=42.825 //y2=2.385
r2133 (  142 174 ) resistor r=4.15462 //w=0.173 //l=5.76498 //layer=m2 \
 //thickness=0.36 //x=25.82 //y=2.37 //x2=31.57 //y2=2.4
r2134 (  142 143 ) resistor r=0.410305 //w=0.131 //l=0.43 //layer=m2 \
 //thickness=0.36 //x=25.82 //y=2.37 //x2=25.39 //y2=2.37
r2135 (  140 143 ) resistor r=0.125 //w=0.17 //l=0.184391 //layer=m2 \
 //thickness=0.36 //x=25.22 //y=2.4 //x2=25.39 //y2=2.37
r2136 (  140 141 ) resistor r=0.86355 //w=0.131 //l=0.905 //layer=m2 \
 //thickness=0.36 //x=25.22 //y=2.4 //x2=24.315 //y2=2.4
r2137 (  139 172 ) resistor r=1.07185 //w=0.197 //l=1.70488 //layer=m2 \
 //thickness=0.36 //x=23.63 //y=2.37 //x2=21.945 //y2=2.41
r2138 (  138 141 ) resistor r=0.1875 //w=0.17 //l=0.269583 //layer=m2 \
 //thickness=0.36 //x=24.06 //y=2.37 //x2=24.315 //y2=2.4
r2139 (  138 139 ) resistor r=0.410305 //w=0.131 //l=0.43 //layer=m2 \
 //thickness=0.36 //x=24.06 //y=2.37 //x2=23.63 //y2=2.37
r2140 (  137 170 ) resistor r=0.105717 //w=0.193 //l=0.162481 //layer=m2 \
 //thickness=0.36 //x=18.415 //y=2.4 //x2=18.255 //y2=2.405
r2141 (  136 172 ) resistor r=0.104215 //w=0.197 //l=0.164924 //layer=m2 \
 //thickness=0.36 //x=21.785 //y=2.4 //x2=21.945 //y2=2.41
r2142 (  136 137 ) resistor r=3.21565 //w=0.131 //l=3.37 //layer=m2 \
 //thickness=0.36 //x=21.785 //y=2.4 //x2=18.415 //y2=2.4
r2143 (  134 170 ) resistor r=1.29743 //w=0.193 //l=2.00998 //layer=m2 \
 //thickness=0.36 //x=16.255 //y=2.385 //x2=18.255 //y2=2.405
r2144 (  134 135 ) resistor r=0.410305 //w=0.131 //l=0.43 //layer=m2 \
 //thickness=0.36 //x=16.255 //y=2.385 //x2=15.825 //y2=2.385
r2145 (  132 135 ) resistor r=0.125 //w=0.17 //l=0.177341 //layer=m2 \
 //thickness=0.36 //x=15.655 //y=2.4 //x2=15.825 //y2=2.385
r2146 (  132 133 ) resistor r=0.958969 //w=0.131 //l=1.005 //layer=m2 \
 //thickness=0.36 //x=15.655 //y=2.4 //x2=14.65 //y2=2.4
r2147 (  130 133 ) resistor r=0.1875 //w=0.17 //l=0.262393 //layer=m2 \
 //thickness=0.36 //x=14.395 //y=2.385 //x2=14.65 //y2=2.4
r2148 (  130 131 ) resistor r=0.410305 //w=0.131 //l=0.43 //layer=m2 \
 //thickness=0.36 //x=14.395 //y=2.385 //x2=13.965 //y2=2.385
r2149 (  129 167 ) resistor r=0.10734 //w=0.281 //l=0.16 //layer=m2 \
 //thickness=0.36 //x=2.87 //y=2.4 //x2=2.71 //y2=2.4
r2150 (  128 131 ) resistor r=0.125 //w=0.17 //l=0.177341 //layer=m2 \
 //thickness=0.36 //x=13.795 //y=2.4 //x2=13.965 //y2=2.385
r2151 (  128 129 ) resistor r=10.4246 //w=0.131 //l=10.925 //layer=m2 \
 //thickness=0.36 //x=13.795 //y=2.4 //x2=2.87 //y2=2.4
r2152 (  127 184 ) resistor r=4.5 //w=0.15 //l=0.15 //layer=via1 //count=1 \
 //x=79.665 //y=2.41 //x2=79.665 //y2=2.41
r2153 (  124 268 ) resistor r=9.3 //w=0.17 //l=0.17 //layer=mcon //count=1 \
 //x=79.67 //y=2.26 //x2=79.67 //y2=2.26
r2154 (  122 273 ) resistor r=9.3 //w=0.17 //l=0.17 //layer=mcon //count=1 \
 //x=79.67 //y=4.88 //x2=79.67 //y2=4.88
r2155 (  120 182 ) resistor r=4.5 //w=0.15 //l=0.15 //layer=via1 //count=1 \
 //x=75.975 //y=2.405 //x2=75.975 //y2=2.405
r2156 (  117 258 ) resistor r=9.3 //w=0.17 //l=0.17 //layer=mcon //count=1 \
 //x=75.97 //y=2.26 //x2=75.97 //y2=2.26
r2157 (  115 263 ) resistor r=9.3 //w=0.17 //l=0.17 //layer=mcon //count=1 \
 //x=75.97 //y=4.88 //x2=75.97 //y2=4.88
r2158 (  111 248 ) resistor r=9.3 //w=0.17 //l=0.17 //layer=mcon //count=1 \
 //x=60.43 //y=2.26 //x2=60.43 //y2=2.26
r2159 (  109 253 ) resistor r=9.3 //w=0.17 //l=0.17 //layer=mcon //count=1 \
 //x=60.43 //y=4.88 //x2=60.43 //y2=4.88
r2160 (  107 178 ) resistor r=4.5 //w=0.15 //l=0.15 //layer=via1 //count=1 \
 //x=50.805 //y=2.41 //x2=50.805 //y2=2.41
r2161 (  104 238 ) resistor r=9.3 //w=0.17 //l=0.17 //layer=mcon //count=1 \
 //x=50.81 //y=2.26 //x2=50.81 //y2=2.26
r2162 (  102 243 ) resistor r=9.3 //w=0.17 //l=0.17 //layer=mcon //count=1 \
 //x=50.81 //y=4.88 //x2=50.81 //y2=4.88
r2163 (  100 176 ) resistor r=4.5 //w=0.15 //l=0.15 //layer=via1 //count=1 \
 //x=47.115 //y=2.405 //x2=47.115 //y2=2.405
r2164 (  97 228 ) resistor r=9.3 //w=0.17 //l=0.17 //layer=mcon //count=1 \
 //x=47.11 //y=2.26 //x2=47.11 //y2=2.26
r2165 (  95 233 ) resistor r=9.3 //w=0.17 //l=0.17 //layer=mcon //count=1 \
 //x=47.11 //y=4.88 //x2=47.11 //y2=4.88
r2166 (  91 218 ) resistor r=9.3 //w=0.17 //l=0.17 //layer=mcon //count=1 \
 //x=31.57 //y=2.26 //x2=31.57 //y2=2.26
r2167 (  89 223 ) resistor r=9.3 //w=0.17 //l=0.17 //layer=mcon //count=1 \
 //x=31.57 //y=4.88 //x2=31.57 //y2=4.88
r2168 (  87 172 ) resistor r=4.5 //w=0.15 //l=0.15 //layer=via1 //count=1 \
 //x=21.945 //y=2.41 //x2=21.945 //y2=2.41
r2169 (  84 208 ) resistor r=9.3 //w=0.17 //l=0.17 //layer=mcon //count=1 \
 //x=21.95 //y=2.26 //x2=21.95 //y2=2.26
r2170 (  82 213 ) resistor r=9.3 //w=0.17 //l=0.17 //layer=mcon //count=1 \
 //x=21.95 //y=4.88 //x2=21.95 //y2=4.88
r2171 (  80 170 ) resistor r=4.5 //w=0.15 //l=0.15 //layer=via1 //count=1 \
 //x=18.255 //y=2.405 //x2=18.255 //y2=2.405
r2172 (  77 198 ) resistor r=9.3 //w=0.17 //l=0.17 //layer=mcon //count=1 \
 //x=18.25 //y=2.26 //x2=18.25 //y2=2.26
r2173 (  75 203 ) resistor r=9.3 //w=0.17 //l=0.17 //layer=mcon //count=1 \
 //x=18.25 //y=4.88 //x2=18.25 //y2=4.88
r2174 (  71 188 ) resistor r=9.3 //w=0.17 //l=0.17 //layer=mcon //count=1 \
 //x=2.71 //y=2.26 //x2=2.71 //y2=2.26
r2175 (  69 193 ) resistor r=9.3 //w=0.17 //l=0.17 //layer=mcon //count=1 \
 //x=2.71 //y=4.88 //x2=2.71 //y2=4.88
r2176 (  65 122 ) resistor r=0.0717383 //w=0.224 //l=0.115 //layer=m1 \
 //thickness=0.36 //x=79.67 //y=4.765 //x2=79.67 //y2=4.88
r2177 (  64 127 ) resistor r=0.0902915 //w=0.287 //l=0.162481 //layer=m1 \
 //thickness=0.36 //x=79.67 //y=2.57 //x2=79.665 //y2=2.41
r2178 (  62 115 ) resistor r=0.0801089 //w=0.224 //l=0.13 //layer=m1 \
 //thickness=0.36 //x=75.97 //y=4.75 //x2=75.97 //y2=4.88
r2179 (  61 120 ) resistor r=0.0902915 //w=0.287 //l=0.162481 //layer=m1 \
 //thickness=0.36 //x=75.97 //y=2.565 //x2=75.975 //y2=2.405
r2180 (  57 109 ) resistor r=0.0717383 //w=0.224 //l=0.115 //layer=m1 \
 //thickness=0.36 //x=60.43 //y=4.765 //x2=60.43 //y2=4.88
r2181 (  53 102 ) resistor r=0.0717383 //w=0.224 //l=0.115 //layer=m1 \
 //thickness=0.36 //x=50.81 //y=4.765 //x2=50.81 //y2=4.88
r2182 (  52 107 ) resistor r=0.0902915 //w=0.287 //l=0.162481 //layer=m1 \
 //thickness=0.36 //x=50.81 //y=2.57 //x2=50.805 //y2=2.41
r2183 (  50 95 ) resistor r=0.0801089 //w=0.224 //l=0.13 //layer=m1 \
 //thickness=0.36 //x=47.11 //y=4.75 //x2=47.11 //y2=4.88
r2184 (  49 100 ) resistor r=0.0902915 //w=0.287 //l=0.162481 //layer=m1 \
 //thickness=0.36 //x=47.11 //y=2.565 //x2=47.115 //y2=2.405
r2185 (  45 89 ) resistor r=0.0717383 //w=0.224 //l=0.115 //layer=m1 \
 //thickness=0.36 //x=31.57 //y=4.765 //x2=31.57 //y2=4.88
r2186 (  41 82 ) resistor r=0.0717383 //w=0.224 //l=0.115 //layer=m1 \
 //thickness=0.36 //x=21.95 //y=4.765 //x2=21.95 //y2=4.88
r2187 (  40 87 ) resistor r=0.0902915 //w=0.287 //l=0.162481 //layer=m1 \
 //thickness=0.36 //x=21.95 //y=2.57 //x2=21.945 //y2=2.41
r2188 (  38 75 ) resistor r=0.0801089 //w=0.224 //l=0.13 //layer=m1 \
 //thickness=0.36 //x=18.25 //y=4.75 //x2=18.25 //y2=4.88
r2189 (  37 80 ) resistor r=0.0902915 //w=0.287 //l=0.162481 //layer=m1 \
 //thickness=0.36 //x=18.25 //y=2.565 //x2=18.255 //y2=2.405
r2190 (  31 69 ) resistor r=0.0717383 //w=0.224 //l=0.115 //layer=m1 \
 //thickness=0.36 //x=2.71 //y=4.765 //x2=2.71 //y2=4.88
r2191 (  29 127 ) resistor r=0.0043554 //w=0.287 //l=0.01 //layer=m1 \
 //thickness=0.36 //x=79.665 //y=2.4 //x2=79.665 //y2=2.41
r2192 (  29 124 ) resistor r=0.0609756 //w=0.287 //l=0.14 //layer=m1 \
 //thickness=0.36 //x=79.665 //y=2.4 //x2=79.665 //y2=2.26
r2193 (  28 120 ) resistor r=0.0021777 //w=0.287 //l=0.005 //layer=m1 \
 //thickness=0.36 //x=75.975 //y=2.4 //x2=75.975 //y2=2.405
r2194 (  28 117 ) resistor r=0.0609756 //w=0.287 //l=0.14 //layer=m1 \
 //thickness=0.36 //x=75.975 //y=2.4 //x2=75.975 //y2=2.26
r2195 (  27 180 ) resistor r=4.5 //w=0.15 //l=0.15 //layer=via1 //count=1 \
 //x=60.43 //y=2.4 //x2=60.43 //y2=2.4
r2196 (  27 56 ) resistor r=0.0902565 //w=0.288 //l=0.16 //layer=m1 \
 //thickness=0.36 //x=60.43 //y=2.4 //x2=60.43 //y2=2.56
r2197 (  27 111 ) resistor r=0.0607639 //w=0.288 //l=0.14 //layer=m1 \
 //thickness=0.36 //x=60.43 //y=2.4 //x2=60.43 //y2=2.26
r2198 (  26 107 ) resistor r=0.0043554 //w=0.287 //l=0.01 //layer=m1 \
 //thickness=0.36 //x=50.805 //y=2.4 //x2=50.805 //y2=2.41
r2199 (  26 104 ) resistor r=0.0609756 //w=0.287 //l=0.14 //layer=m1 \
 //thickness=0.36 //x=50.805 //y=2.4 //x2=50.805 //y2=2.26
r2200 (  25 100 ) resistor r=0.0021777 //w=0.287 //l=0.005 //layer=m1 \
 //thickness=0.36 //x=47.115 //y=2.4 //x2=47.115 //y2=2.405
r2201 (  25 97 ) resistor r=0.0609756 //w=0.287 //l=0.14 //layer=m1 \
 //thickness=0.36 //x=47.115 //y=2.4 //x2=47.115 //y2=2.26
r2202 (  24 174 ) resistor r=4.5 //w=0.15 //l=0.15 //layer=via1 //count=1 \
 //x=31.57 //y=2.4 //x2=31.57 //y2=2.4
r2203 (  24 44 ) resistor r=0.0902565 //w=0.288 //l=0.16 //layer=m1 \
 //thickness=0.36 //x=31.57 //y=2.4 //x2=31.57 //y2=2.56
r2204 (  24 91 ) resistor r=0.0607639 //w=0.288 //l=0.14 //layer=m1 \
 //thickness=0.36 //x=31.57 //y=2.4 //x2=31.57 //y2=2.26
r2205 (  23 87 ) resistor r=0.0043554 //w=0.287 //l=0.01 //layer=m1 \
 //thickness=0.36 //x=21.945 //y=2.4 //x2=21.945 //y2=2.41
r2206 (  23 84 ) resistor r=0.0609756 //w=0.287 //l=0.14 //layer=m1 \
 //thickness=0.36 //x=21.945 //y=2.4 //x2=21.945 //y2=2.26
r2207 (  22 80 ) resistor r=0.0021777 //w=0.287 //l=0.005 //layer=m1 \
 //thickness=0.36 //x=18.255 //y=2.4 //x2=18.255 //y2=2.405
r2208 (  22 77 ) resistor r=0.0609756 //w=0.287 //l=0.14 //layer=m1 \
 //thickness=0.36 //x=18.255 //y=2.4 //x2=18.255 //y2=2.26
r2209 (  21 167 ) resistor r=4.5 //w=0.15 //l=0.15 //layer=via1 //count=1 \
 //x=2.71 //y=2.4 //x2=2.71 //y2=2.4
r2210 (  21 30 ) resistor r=0.0902565 //w=0.288 //l=0.16 //layer=m1 \
 //thickness=0.36 //x=2.71 //y=2.4 //x2=2.71 //y2=2.56
r2211 (  21 71 ) resistor r=0.0607639 //w=0.288 //l=0.14 //layer=m1 \
 //thickness=0.36 //x=2.71 //y=2.4 //x2=2.71 //y2=2.26
r2212 (  20 65 ) resistor r=1.19752 //w=0.131 //l=1.255 //layer=m1 \
 //thickness=0.36 //x=79.67 //y=3.51 //x2=79.67 //y2=4.765
r2213 (  19 20 ) resistor r=0.706107 //w=0.131 //l=0.74 //layer=m1 \
 //thickness=0.36 //x=79.67 //y=2.77 //x2=79.67 //y2=3.51
r2214 (  19 64 ) resistor r=0.19084 //w=0.131 //l=0.2 //layer=m1 \
 //thickness=0.36 //x=79.67 //y=2.77 //x2=79.67 //y2=2.57
r2215 (  18 62 ) resistor r=1.88931 //w=0.131 //l=1.98 //layer=m1 \
 //thickness=0.36 //x=75.97 //y=2.77 //x2=75.97 //y2=4.75
r2216 (  18 61 ) resistor r=0.195611 //w=0.131 //l=0.205 //layer=m1 \
 //thickness=0.36 //x=75.97 //y=2.77 //x2=75.97 //y2=2.565
r2217 (  17 57 ) resistor r=0.491412 //w=0.131 //l=0.515 //layer=m1 \
 //thickness=0.36 //x=60.43 //y=4.25 //x2=60.43 //y2=4.765
r2218 (  16 17 ) resistor r=0.706107 //w=0.131 //l=0.74 //layer=m1 \
 //thickness=0.36 //x=60.43 //y=3.51 //x2=60.43 //y2=4.25
r2219 (  15 16 ) resistor r=0.706107 //w=0.131 //l=0.74 //layer=m1 \
 //thickness=0.36 //x=60.43 //y=2.77 //x2=60.43 //y2=3.51
r2220 (  15 56 ) resistor r=0.200382 //w=0.131 //l=0.21 //layer=m1 \
 //thickness=0.36 //x=60.43 //y=2.77 //x2=60.43 //y2=2.56
r2221 (  14 53 ) resistor r=1.19752 //w=0.131 //l=1.255 //layer=m1 \
 //thickness=0.36 //x=50.81 //y=3.51 //x2=50.81 //y2=4.765
r2222 (  13 14 ) resistor r=0.706107 //w=0.131 //l=0.74 //layer=m1 \
 //thickness=0.36 //x=50.81 //y=2.77 //x2=50.81 //y2=3.51
r2223 (  13 52 ) resistor r=0.19084 //w=0.131 //l=0.2 //layer=m1 \
 //thickness=0.36 //x=50.81 //y=2.77 //x2=50.81 //y2=2.57
r2224 (  12 50 ) resistor r=1.88931 //w=0.131 //l=1.98 //layer=m1 \
 //thickness=0.36 //x=47.11 //y=2.77 //x2=47.11 //y2=4.75
r2225 (  12 49 ) resistor r=0.195611 //w=0.131 //l=0.205 //layer=m1 \
 //thickness=0.36 //x=47.11 //y=2.77 //x2=47.11 //y2=2.565
r2226 (  11 45 ) resistor r=0.844466 //w=0.131 //l=0.885 //layer=m1 \
 //thickness=0.36 //x=31.57 //y=3.88 //x2=31.57 //y2=4.765
r2227 (  10 11 ) resistor r=0.353053 //w=0.131 //l=0.37 //layer=m1 \
 //thickness=0.36 //x=31.57 //y=3.51 //x2=31.57 //y2=3.88
r2228 (  9 10 ) resistor r=0.706107 //w=0.131 //l=0.74 //layer=m1 \
 //thickness=0.36 //x=31.57 //y=2.77 //x2=31.57 //y2=3.51
r2229 (  9 44 ) resistor r=0.200382 //w=0.131 //l=0.21 //layer=m1 \
 //thickness=0.36 //x=31.57 //y=2.77 //x2=31.57 //y2=2.56
r2230 (  8 41 ) resistor r=1.19752 //w=0.131 //l=1.255 //layer=m1 \
 //thickness=0.36 //x=21.95 //y=3.51 //x2=21.95 //y2=4.765
r2231 (  7 8 ) resistor r=0.706107 //w=0.131 //l=0.74 //layer=m1 \
 //thickness=0.36 //x=21.95 //y=2.77 //x2=21.95 //y2=3.51
r2232 (  7 40 ) resistor r=0.19084 //w=0.131 //l=0.2 //layer=m1 \
 //thickness=0.36 //x=21.95 //y=2.77 //x2=21.95 //y2=2.57
r2233 (  6 38 ) resistor r=1.88931 //w=0.131 //l=1.98 //layer=m1 \
 //thickness=0.36 //x=18.25 //y=2.77 //x2=18.25 //y2=4.75
r2234 (  6 37 ) resistor r=0.195611 //w=0.131 //l=0.205 //layer=m1 \
 //thickness=0.36 //x=18.25 //y=2.77 //x2=18.25 //y2=2.565
r2235 (  5 31 ) resistor r=0.138359 //w=0.131 //l=0.145 //layer=m1 \
 //thickness=0.36 //x=2.71 //y=4.62 //x2=2.71 //y2=4.765
r2236 (  4 5 ) resistor r=0.706107 //w=0.131 //l=0.74 //layer=m1 \
 //thickness=0.36 //x=2.71 //y=3.88 //x2=2.71 //y2=4.62
r2237 (  3 4 ) resistor r=0.353053 //w=0.131 //l=0.37 //layer=m1 \
 //thickness=0.36 //x=2.71 //y=3.51 //x2=2.71 //y2=3.88
r2238 (  2 3 ) resistor r=0.353053 //w=0.131 //l=0.37 //layer=m1 \
 //thickness=0.36 //x=2.71 //y=3.14 //x2=2.71 //y2=3.51
r2239 (  1 2 ) resistor r=0.353053 //w=0.131 //l=0.37 //layer=m1 \
 //thickness=0.36 //x=2.71 //y=2.77 //x2=2.71 //y2=3.14
r2240 (  1 30 ) resistor r=0.200382 //w=0.131 //l=0.21 //layer=m1 \
 //thickness=0.36 //x=2.71 //y=2.77 //x2=2.71 //y2=2.56
ends PM_TMRDFFSNRNQNX1\%RN

subckt PM_TMRDFFSNRNQNX1\%SN ( 1 2 3 4 5 6 7 8 9 10 13 14 15 18 19 20 23 24 25 \
 26 27 28 29 32 33 34 35 36 37 79 86 88 90 92 94 96 98 100 102 103 104 106 108 \
 110 112 114 116 118 119 120 122 124 126 128 130 132 133 134 136 138 140 142 \
 144 146 148 149 150 152 154 156 161 162 167 175 184 189 198 203 212 217 226 \
 231 240 245 254 258 259 260 261 262 263 264 265 266 267 268 269 270 271 272 \
 273 274 275 276 277 278 280 286 287 288 289 290 295 296 297 299 305 306 307 \
 308 309 314 315 316 318 324 325 326 327 328 333 334 335 337 343 344 345 346 \
 347 352 353 354 356 362 363 364 365 366 371 372 373 375 381 382 383 384 385 \
 393 404 415 426 437 448 )
c1213 ( 448 0 ) capacitor c=0.0369044f //x=84.48 //y=4.88
c1214 ( 437 0 ) capacitor c=0.0369628f //x=70.05 //y=4.88
c1215 ( 426 0 ) capacitor c=0.0369628f //x=55.62 //y=4.88
c1216 ( 415 0 ) capacitor c=0.0369628f //x=41.19 //y=4.88
c1217 ( 404 0 ) capacitor c=0.0369628f //x=26.76 //y=4.88
c1218 ( 393 0 ) capacitor c=0.0369044f //x=12.33 //y=4.88
c1219 ( 385 0 ) capacitor c=0.0309248f //x=84.815 //y=4.97
c1220 ( 384 0 ) capacitor c=0.0819978f //x=84.57 //y=2.095
c1221 ( 383 0 ) capacitor c=0.0170266f //x=84.57 //y=1.63
c1222 ( 382 0 ) capacitor c=0.018609f //x=84.57 //y=1.4
c1223 ( 381 0 ) capacitor c=0.0186599f //x=84.57 //y=1.09
c1224 ( 375 0 ) capacitor c=0.0146988f //x=84.415 //y=1.555
c1225 ( 373 0 ) capacitor c=0.0148531f //x=84.415 //y=0.935
c1226 ( 372 0 ) capacitor c=0.0334406f //x=84.045 //y=1.4
c1227 ( 371 0 ) capacitor c=0.0173191f //x=84.045 //y=1.09
c1228 ( 366 0 ) capacitor c=0.0309248f //x=70.385 //y=4.97
c1229 ( 365 0 ) capacitor c=0.0818898f //x=70.14 //y=2.095
c1230 ( 364 0 ) capacitor c=0.0170266f //x=70.14 //y=1.63
c1231 ( 363 0 ) capacitor c=0.018609f //x=70.14 //y=1.4
c1232 ( 362 0 ) capacitor c=0.0186599f //x=70.14 //y=1.09
c1233 ( 356 0 ) capacitor c=0.0146988f //x=69.985 //y=1.555
c1234 ( 354 0 ) capacitor c=0.0148531f //x=69.985 //y=0.935
c1235 ( 353 0 ) capacitor c=0.0334406f //x=69.615 //y=1.4
c1236 ( 352 0 ) capacitor c=0.0173191f //x=69.615 //y=1.09
c1237 ( 347 0 ) capacitor c=0.0309248f //x=55.955 //y=4.97
c1238 ( 346 0 ) capacitor c=0.0819978f //x=55.71 //y=2.095
c1239 ( 345 0 ) capacitor c=0.0170266f //x=55.71 //y=1.63
c1240 ( 344 0 ) capacitor c=0.018609f //x=55.71 //y=1.4
c1241 ( 343 0 ) capacitor c=0.0186599f //x=55.71 //y=1.09
c1242 ( 337 0 ) capacitor c=0.0146988f //x=55.555 //y=1.555
c1243 ( 335 0 ) capacitor c=0.0148531f //x=55.555 //y=0.935
c1244 ( 334 0 ) capacitor c=0.0334406f //x=55.185 //y=1.4
c1245 ( 333 0 ) capacitor c=0.0173191f //x=55.185 //y=1.09
c1246 ( 328 0 ) capacitor c=0.0309248f //x=41.525 //y=4.97
c1247 ( 327 0 ) capacitor c=0.0818898f //x=41.28 //y=2.095
c1248 ( 326 0 ) capacitor c=0.0170266f //x=41.28 //y=1.63
c1249 ( 325 0 ) capacitor c=0.018609f //x=41.28 //y=1.4
c1250 ( 324 0 ) capacitor c=0.0186599f //x=41.28 //y=1.09
c1251 ( 318 0 ) capacitor c=0.0146988f //x=41.125 //y=1.555
c1252 ( 316 0 ) capacitor c=0.0148531f //x=41.125 //y=0.935
c1253 ( 315 0 ) capacitor c=0.0334406f //x=40.755 //y=1.4
c1254 ( 314 0 ) capacitor c=0.0173191f //x=40.755 //y=1.09
c1255 ( 309 0 ) capacitor c=0.0309248f //x=27.095 //y=4.97
c1256 ( 308 0 ) capacitor c=0.0819978f //x=26.85 //y=2.095
c1257 ( 307 0 ) capacitor c=0.0170266f //x=26.85 //y=1.63
c1258 ( 306 0 ) capacitor c=0.018609f //x=26.85 //y=1.4
c1259 ( 305 0 ) capacitor c=0.0186599f //x=26.85 //y=1.09
c1260 ( 299 0 ) capacitor c=0.0146988f //x=26.695 //y=1.555
c1261 ( 297 0 ) capacitor c=0.0148531f //x=26.695 //y=0.935
c1262 ( 296 0 ) capacitor c=0.0334406f //x=26.325 //y=1.4
c1263 ( 295 0 ) capacitor c=0.0173191f //x=26.325 //y=1.09
c1264 ( 290 0 ) capacitor c=0.0309248f //x=12.665 //y=4.97
c1265 ( 289 0 ) capacitor c=0.0818898f //x=12.42 //y=2.095
c1266 ( 288 0 ) capacitor c=0.0170266f //x=12.42 //y=1.63
c1267 ( 287 0 ) capacitor c=0.018609f //x=12.42 //y=1.4
c1268 ( 286 0 ) capacitor c=0.0186599f //x=12.42 //y=1.09
c1269 ( 280 0 ) capacitor c=0.0146988f //x=12.265 //y=1.555
c1270 ( 278 0 ) capacitor c=0.0148531f //x=12.265 //y=0.935
c1271 ( 277 0 ) capacitor c=0.0334406f //x=11.895 //y=1.4
c1272 ( 276 0 ) capacitor c=0.0173191f //x=11.895 //y=1.09
c1273 ( 275 0 ) capacitor c=0.110208f //x=84.89 //y=6.2
c1274 ( 274 0 ) capacitor c=0.110214f //x=84.45 //y=6.2
c1275 ( 273 0 ) capacitor c=0.110208f //x=70.46 //y=6.2
c1276 ( 272 0 ) capacitor c=0.110214f //x=70.02 //y=6.2
c1277 ( 271 0 ) capacitor c=0.110208f //x=56.03 //y=6.2
c1278 ( 270 0 ) capacitor c=0.110214f //x=55.59 //y=6.2
c1279 ( 269 0 ) capacitor c=0.110208f //x=41.6 //y=6.2
c1280 ( 268 0 ) capacitor c=0.110214f //x=41.16 //y=6.2
c1281 ( 267 0 ) capacitor c=0.110208f //x=27.17 //y=6.2
c1282 ( 266 0 ) capacitor c=0.110214f //x=26.73 //y=6.2
c1283 ( 265 0 ) capacitor c=0.110208f //x=12.74 //y=6.2
c1284 ( 264 0 ) capacitor c=0.110214f //x=12.3 //y=6.2
c1285 ( 254 0 ) capacitor c=0.00129935f //x=84.48 //y=4.88
c1286 ( 245 0 ) capacitor c=9.49278e-19 //x=84.48 //y=2.26
c1287 ( 240 0 ) capacitor c=0.00129935f //x=70.05 //y=4.88
c1288 ( 231 0 ) capacitor c=9.49278e-19 //x=70.05 //y=2.26
c1289 ( 226 0 ) capacitor c=0.00129935f //x=55.62 //y=4.88
c1290 ( 217 0 ) capacitor c=9.49278e-19 //x=55.62 //y=2.26
c1291 ( 212 0 ) capacitor c=0.00129935f //x=41.19 //y=4.88
c1292 ( 203 0 ) capacitor c=9.49278e-19 //x=41.19 //y=2.26
c1293 ( 198 0 ) capacitor c=0.00129935f //x=26.76 //y=4.88
c1294 ( 189 0 ) capacitor c=9.49278e-19 //x=26.76 //y=2.26
c1295 ( 184 0 ) capacitor c=0.00129935f //x=12.33 //y=4.88
c1296 ( 175 0 ) capacitor c=9.49278e-19 //x=12.33 //y=2.26
c1297 ( 167 0 ) capacitor c=0.00163887f //x=52.955 //y=3.125
c1298 ( 162 0 ) capacitor c=0.00100396f //x=23.36 //y=3.132
c1299 ( 161 0 ) capacitor c=4.39244e-19 //x=12.49 //y=3.125
c1300 ( 156 0 ) capacitor c=0.0846858f //x=78.77 //y=3.125
c1301 ( 154 0 ) capacitor c=0.0514333f //x=78.17 //y=3.14
c1302 ( 152 0 ) capacitor c=0.00422942f //x=73.975 //y=3.155
c1303 ( 150 0 ) capacitor c=0.0179685f //x=73.375 //y=3.14
c1304 ( 149 0 ) capacitor c=0.024406f //x=71.77 //y=3.155
c1305 ( 148 0 ) capacitor c=0.00413636f //x=72.115 //y=3.155
c1306 ( 146 0 ) capacitor c=0.00179684f //x=69.155 //y=3.17
c1307 ( 144 0 ) capacitor c=0.0169637f //x=68.555 //y=3.14
c1308 ( 142 0 ) capacitor c=0.0064451f //x=67.305 //y=3.11
c1309 ( 140 0 ) capacitor c=0.0207078f //x=66.705 //y=3.14
c1310 ( 138 0 ) capacitor c=0.00378224f //x=64.35 //y=3.17
c1311 ( 136 0 ) capacitor c=0.0184994f //x=63.75 //y=3.14
c1312 ( 134 0 ) capacitor c=0.00429578f //x=62.5 //y=3.17
c1313 ( 133 0 ) capacitor c=0.0724862f //x=61.335 //y=3.13
c1314 ( 132 0 ) capacitor c=0.00729482f //x=61.765 //y=3.13
c1315 ( 130 0 ) capacitor c=0.0269416f //x=55.46 //y=3.14
c1316 ( 128 0 ) capacitor c=0.00209667f //x=52.855 //y=3.125
c1317 ( 126 0 ) capacitor c=0.0331266f //x=49.91 //y=3.125
c1318 ( 124 0 ) capacitor c=0.0513238f //x=49.31 //y=3.14
c1319 ( 122 0 ) capacitor c=0.00422942f //x=45.115 //y=3.155
c1320 ( 120 0 ) capacitor c=0.0179685f //x=44.515 //y=3.14
c1321 ( 119 0 ) capacitor c=0.0243366f //x=42.91 //y=3.155
c1322 ( 118 0 ) capacitor c=0.00413636f //x=43.255 //y=3.155
c1323 ( 116 0 ) capacitor c=0.00186491f //x=40.3 //y=3.17
c1324 ( 114 0 ) capacitor c=0.0168895f //x=39.695 //y=3.14
c1325 ( 112 0 ) capacitor c=0.00651965f //x=38.45 //y=3.11
c1326 ( 110 0 ) capacitor c=0.0206704f //x=37.845 //y=3.14
c1327 ( 108 0 ) capacitor c=0.00383048f //x=35.495 //y=3.17
c1328 ( 106 0 ) capacitor c=0.0184245f //x=34.89 //y=3.14
c1329 ( 104 0 ) capacitor c=0.0043698f //x=33.645 //y=3.17
c1330 ( 103 0 ) capacitor c=0.0817674f //x=32.475 //y=3.13
c1331 ( 102 0 ) capacitor c=0.00738888f //x=32.91 //y=3.13
c1332 ( 100 0 ) capacitor c=0.0342925f //x=26.6 //y=3.14
c1333 ( 98 0 ) capacitor c=0.0026996f //x=23.268 //y=3.132
c1334 ( 96 0 ) capacitor c=0.0270168f //x=21.05 //y=3.125
c1335 ( 94 0 ) capacitor c=0.0514333f //x=20.45 //y=3.14
c1336 ( 92 0 ) capacitor c=0.00433851f //x=16.255 //y=3.155
c1337 ( 90 0 ) capacitor c=0.0179685f //x=15.655 //y=3.14
c1338 ( 88 0 ) capacitor c=0.00413636f //x=14.395 //y=3.155
c1339 ( 86 0 ) capacitor c=0.0151172f //x=13.795 //y=3.14
c1340 ( 79 0 ) capacitor c=0.015039f //x=84.48 //y=3.14
c1341 ( 37 0 ) capacitor c=0.0464356f //x=84.48 //y=4.765
c1342 ( 36 0 ) capacitor c=0.012684f //x=84.48 //y=3.305
c1343 ( 35 0 ) capacitor c=0.013527f //x=84.48 //y=2.985
c1344 ( 34 0 ) capacitor c=0.00378284f //x=84.48 //y=2.375
c1345 ( 33 0 ) capacitor c=0.0416113f //x=70.05 //y=4.765
c1346 ( 32 0 ) capacitor c=0.0130261f //x=70.05 //y=3.285
c1347 ( 29 0 ) capacitor c=0.00380207f //x=70.05 //y=2.375
c1348 ( 28 0 ) capacitor c=0.0396792f //x=55.62 //y=4.765
c1349 ( 27 0 ) capacitor c=0.0125032f //x=55.62 //y=3.305
c1350 ( 26 0 ) capacitor c=0.0138904f //x=55.62 //y=2.985
c1351 ( 25 0 ) capacitor c=0.00380207f //x=55.62 //y=2.375
c1352 ( 24 0 ) capacitor c=0.0416113f //x=41.19 //y=4.765
c1353 ( 23 0 ) capacitor c=0.013026f //x=41.19 //y=3.285
c1354 ( 20 0 ) capacitor c=0.00380207f //x=41.19 //y=2.375
c1355 ( 19 0 ) capacitor c=0.0405125f //x=26.76 //y=4.765
c1356 ( 18 0 ) capacitor c=0.0125032f //x=26.76 //y=3.305
c1357 ( 15 0 ) capacitor c=0.00380207f //x=26.76 //y=2.375
c1358 ( 14 0 ) capacitor c=0.0437064f //x=12.33 //y=4.765
c1359 ( 13 0 ) capacitor c=0.0127247f //x=12.33 //y=3.285
c1360 ( 10 0 ) capacitor c=0.00380207f //x=12.33 //y=2.375
c1361 ( 9 0 ) capacitor c=0.015039f //x=70.05 //y=3.14
c1362 ( 8 0 ) capacitor c=0.015039f //x=55.62 //y=3.14
c1363 ( 7 0 ) capacitor c=0.015039f //x=41.19 //y=3.14
c1364 ( 6 0 ) capacitor c=0.015039f //x=26.76 //y=3.14
c1365 ( 5 0 ) capacitor c=0.015039f //x=12.33 //y=3.14
c1366 ( 4 0 ) capacitor c=0.0114361f //x=70.05 //y=2.77
c1367 ( 3 0 ) capacitor c=0.0114361f //x=41.19 //y=2.77
c1368 ( 2 0 ) capacitor c=0.0136895f //x=26.76 //y=2.77
c1369 ( 1 0 ) capacitor c=0.0114361f //x=12.33 //y=2.77
r1370 (  450 451 ) resistor r=32.4568 //w=0.214 //l=0.075 //layer=ply \
 //thickness=0.18 //x=84.48 //y=4.97 //x2=84.48 //y2=5.045
r1371 (  448 450 ) resistor r=20.271 //w=0.214 //l=0.09 //layer=ply \
 //thickness=0.18 //x=84.48 //y=4.88 //x2=84.48 //y2=4.97
r1372 (  439 440 ) resistor r=32.4568 //w=0.214 //l=0.075 //layer=ply \
 //thickness=0.18 //x=70.05 //y=4.97 //x2=70.05 //y2=5.045
r1373 (  437 439 ) resistor r=20.271 //w=0.214 //l=0.09 //layer=ply \
 //thickness=0.18 //x=70.05 //y=4.88 //x2=70.05 //y2=4.97
r1374 (  428 429 ) resistor r=32.4568 //w=0.214 //l=0.075 //layer=ply \
 //thickness=0.18 //x=55.62 //y=4.97 //x2=55.62 //y2=5.045
r1375 (  426 428 ) resistor r=20.271 //w=0.214 //l=0.09 //layer=ply \
 //thickness=0.18 //x=55.62 //y=4.88 //x2=55.62 //y2=4.97
r1376 (  417 418 ) resistor r=32.4568 //w=0.214 //l=0.075 //layer=ply \
 //thickness=0.18 //x=41.19 //y=4.97 //x2=41.19 //y2=5.045
r1377 (  415 417 ) resistor r=20.271 //w=0.214 //l=0.09 //layer=ply \
 //thickness=0.18 //x=41.19 //y=4.88 //x2=41.19 //y2=4.97
r1378 (  406 407 ) resistor r=32.4568 //w=0.214 //l=0.075 //layer=ply \
 //thickness=0.18 //x=26.76 //y=4.97 //x2=26.76 //y2=5.045
r1379 (  404 406 ) resistor r=20.271 //w=0.214 //l=0.09 //layer=ply \
 //thickness=0.18 //x=26.76 //y=4.88 //x2=26.76 //y2=4.97
r1380 (  395 396 ) resistor r=32.4568 //w=0.214 //l=0.075 //layer=ply \
 //thickness=0.18 //x=12.33 //y=4.97 //x2=12.33 //y2=5.045
r1381 (  393 395 ) resistor r=20.271 //w=0.214 //l=0.09 //layer=ply \
 //thickness=0.18 //x=12.33 //y=4.88 //x2=12.33 //y2=4.97
r1382 (  386 450 ) resistor r=16.5046 //w=0.27 //l=0.135 //layer=ply \
 //thickness=0.18 //x=84.615 //y=4.97 //x2=84.48 //y2=4.97
r1383 (  385 387 ) resistor r=26.9307 //w=0.15 //l=0.106066 //layer=ply \
 //thickness=0.18 //x=84.815 //y=4.97 //x2=84.89 //y2=5.045
r1384 (  385 386 ) resistor r=102.553 //w=0.094 //l=0.2 //layer=ply \
 //thickness=0.18 //x=84.815 //y=4.97 //x2=84.615 //y2=4.97
r1385 (  384 455 ) resistor r=38.6777 //w=0.284 //l=0.198997 //layer=ply \
 //thickness=0.18 //x=84.57 //y=2.095 //x2=84.495 //y2=2.26
r1386 (  383 453 ) resistor r=21.2976 //w=0.217 //l=0.0928709 //layer=ply \
 //thickness=0.18 //x=84.57 //y=1.63 //x2=84.53 //y2=1.555
r1387 (  383 384 ) resistor r=238.436 //w=0.094 //l=0.465 //layer=ply \
 //thickness=0.18 //x=84.57 //y=1.63 //x2=84.57 //y2=2.095
r1388 (  382 453 ) resistor r=39.0671 //w=0.217 //l=0.173853 //layer=ply \
 //thickness=0.18 //x=84.57 //y=1.4 //x2=84.53 //y2=1.555
r1389 (  381 452 ) resistor r=45.1352 //w=0.168 //l=0.173853 //layer=ply \
 //thickness=0.18 //x=84.57 //y=1.09 //x2=84.53 //y2=0.935
r1390 (  381 382 ) resistor r=158.957 //w=0.094 //l=0.31 //layer=ply \
 //thickness=0.18 //x=84.57 //y=1.09 //x2=84.57 //y2=1.4
r1391 (  376 446 ) resistor r=5.52526 //w=0.168 //l=0.115 //layer=ply \
 //thickness=0.18 //x=84.2 //y=1.555 //x2=84.085 //y2=1.555
r1392 (  375 453 ) resistor r=11.4558 //w=0.217 //l=0.115 //layer=ply \
 //thickness=0.18 //x=84.415 //y=1.555 //x2=84.53 //y2=1.555
r1393 (  374 445 ) resistor r=5.52526 //w=0.168 //l=0.115 //layer=ply \
 //thickness=0.18 //x=84.2 //y=0.935 //x2=84.085 //y2=0.935
r1394 (  373 452 ) resistor r=5.52526 //w=0.168 //l=0.115 //layer=ply \
 //thickness=0.18 //x=84.415 //y=0.935 //x2=84.53 //y2=0.935
r1395 (  373 374 ) resistor r=110.245 //w=0.094 //l=0.215 //layer=ply \
 //thickness=0.18 //x=84.415 //y=0.935 //x2=84.2 //y2=0.935
r1396 (  372 446 ) resistor r=45.1352 //w=0.168 //l=0.173853 //layer=ply \
 //thickness=0.18 //x=84.045 //y=1.4 //x2=84.085 //y2=1.555
r1397 (  371 445 ) resistor r=45.1352 //w=0.168 //l=0.173853 //layer=ply \
 //thickness=0.18 //x=84.045 //y=1.09 //x2=84.085 //y2=0.935
r1398 (  371 372 ) resistor r=158.957 //w=0.094 //l=0.31 //layer=ply \
 //thickness=0.18 //x=84.045 //y=1.09 //x2=84.045 //y2=1.4
r1399 (  367 439 ) resistor r=16.5046 //w=0.27 //l=0.135 //layer=ply \
 //thickness=0.18 //x=70.185 //y=4.97 //x2=70.05 //y2=4.97
r1400 (  366 368 ) resistor r=26.9307 //w=0.15 //l=0.106066 //layer=ply \
 //thickness=0.18 //x=70.385 //y=4.97 //x2=70.46 //y2=5.045
r1401 (  366 367 ) resistor r=102.553 //w=0.094 //l=0.2 //layer=ply \
 //thickness=0.18 //x=70.385 //y=4.97 //x2=70.185 //y2=4.97
r1402 (  365 444 ) resistor r=38.6777 //w=0.284 //l=0.198997 //layer=ply \
 //thickness=0.18 //x=70.14 //y=2.095 //x2=70.065 //y2=2.26
r1403 (  364 442 ) resistor r=21.2976 //w=0.217 //l=0.0928709 //layer=ply \
 //thickness=0.18 //x=70.14 //y=1.63 //x2=70.1 //y2=1.555
r1404 (  364 365 ) resistor r=238.436 //w=0.094 //l=0.465 //layer=ply \
 //thickness=0.18 //x=70.14 //y=1.63 //x2=70.14 //y2=2.095
r1405 (  363 442 ) resistor r=39.0671 //w=0.217 //l=0.173853 //layer=ply \
 //thickness=0.18 //x=70.14 //y=1.4 //x2=70.1 //y2=1.555
r1406 (  362 441 ) resistor r=45.1352 //w=0.168 //l=0.173853 //layer=ply \
 //thickness=0.18 //x=70.14 //y=1.09 //x2=70.1 //y2=0.935
r1407 (  362 363 ) resistor r=158.957 //w=0.094 //l=0.31 //layer=ply \
 //thickness=0.18 //x=70.14 //y=1.09 //x2=70.14 //y2=1.4
r1408 (  357 435 ) resistor r=5.52526 //w=0.168 //l=0.115 //layer=ply \
 //thickness=0.18 //x=69.77 //y=1.555 //x2=69.655 //y2=1.555
r1409 (  356 442 ) resistor r=11.4558 //w=0.217 //l=0.115 //layer=ply \
 //thickness=0.18 //x=69.985 //y=1.555 //x2=70.1 //y2=1.555
r1410 (  355 434 ) resistor r=5.52526 //w=0.168 //l=0.115 //layer=ply \
 //thickness=0.18 //x=69.77 //y=0.935 //x2=69.655 //y2=0.935
r1411 (  354 441 ) resistor r=5.52526 //w=0.168 //l=0.115 //layer=ply \
 //thickness=0.18 //x=69.985 //y=0.935 //x2=70.1 //y2=0.935
r1412 (  354 355 ) resistor r=110.245 //w=0.094 //l=0.215 //layer=ply \
 //thickness=0.18 //x=69.985 //y=0.935 //x2=69.77 //y2=0.935
r1413 (  353 435 ) resistor r=45.1352 //w=0.168 //l=0.173853 //layer=ply \
 //thickness=0.18 //x=69.615 //y=1.4 //x2=69.655 //y2=1.555
r1414 (  352 434 ) resistor r=45.1352 //w=0.168 //l=0.173853 //layer=ply \
 //thickness=0.18 //x=69.615 //y=1.09 //x2=69.655 //y2=0.935
r1415 (  352 353 ) resistor r=158.957 //w=0.094 //l=0.31 //layer=ply \
 //thickness=0.18 //x=69.615 //y=1.09 //x2=69.615 //y2=1.4
r1416 (  348 428 ) resistor r=16.5046 //w=0.27 //l=0.135 //layer=ply \
 //thickness=0.18 //x=55.755 //y=4.97 //x2=55.62 //y2=4.97
r1417 (  347 349 ) resistor r=26.9307 //w=0.15 //l=0.106066 //layer=ply \
 //thickness=0.18 //x=55.955 //y=4.97 //x2=56.03 //y2=5.045
r1418 (  347 348 ) resistor r=102.553 //w=0.094 //l=0.2 //layer=ply \
 //thickness=0.18 //x=55.955 //y=4.97 //x2=55.755 //y2=4.97
r1419 (  346 433 ) resistor r=38.6777 //w=0.284 //l=0.198997 //layer=ply \
 //thickness=0.18 //x=55.71 //y=2.095 //x2=55.635 //y2=2.26
r1420 (  345 431 ) resistor r=21.2976 //w=0.217 //l=0.0928709 //layer=ply \
 //thickness=0.18 //x=55.71 //y=1.63 //x2=55.67 //y2=1.555
r1421 (  345 346 ) resistor r=238.436 //w=0.094 //l=0.465 //layer=ply \
 //thickness=0.18 //x=55.71 //y=1.63 //x2=55.71 //y2=2.095
r1422 (  344 431 ) resistor r=39.0671 //w=0.217 //l=0.173853 //layer=ply \
 //thickness=0.18 //x=55.71 //y=1.4 //x2=55.67 //y2=1.555
r1423 (  343 430 ) resistor r=45.1352 //w=0.168 //l=0.173853 //layer=ply \
 //thickness=0.18 //x=55.71 //y=1.09 //x2=55.67 //y2=0.935
r1424 (  343 344 ) resistor r=158.957 //w=0.094 //l=0.31 //layer=ply \
 //thickness=0.18 //x=55.71 //y=1.09 //x2=55.71 //y2=1.4
r1425 (  338 424 ) resistor r=5.52526 //w=0.168 //l=0.115 //layer=ply \
 //thickness=0.18 //x=55.34 //y=1.555 //x2=55.225 //y2=1.555
r1426 (  337 431 ) resistor r=11.4558 //w=0.217 //l=0.115 //layer=ply \
 //thickness=0.18 //x=55.555 //y=1.555 //x2=55.67 //y2=1.555
r1427 (  336 423 ) resistor r=5.52526 //w=0.168 //l=0.115 //layer=ply \
 //thickness=0.18 //x=55.34 //y=0.935 //x2=55.225 //y2=0.935
r1428 (  335 430 ) resistor r=5.52526 //w=0.168 //l=0.115 //layer=ply \
 //thickness=0.18 //x=55.555 //y=0.935 //x2=55.67 //y2=0.935
r1429 (  335 336 ) resistor r=110.245 //w=0.094 //l=0.215 //layer=ply \
 //thickness=0.18 //x=55.555 //y=0.935 //x2=55.34 //y2=0.935
r1430 (  334 424 ) resistor r=45.1352 //w=0.168 //l=0.173853 //layer=ply \
 //thickness=0.18 //x=55.185 //y=1.4 //x2=55.225 //y2=1.555
r1431 (  333 423 ) resistor r=45.1352 //w=0.168 //l=0.173853 //layer=ply \
 //thickness=0.18 //x=55.185 //y=1.09 //x2=55.225 //y2=0.935
r1432 (  333 334 ) resistor r=158.957 //w=0.094 //l=0.31 //layer=ply \
 //thickness=0.18 //x=55.185 //y=1.09 //x2=55.185 //y2=1.4
r1433 (  329 417 ) resistor r=16.5046 //w=0.27 //l=0.135 //layer=ply \
 //thickness=0.18 //x=41.325 //y=4.97 //x2=41.19 //y2=4.97
r1434 (  328 330 ) resistor r=26.9307 //w=0.15 //l=0.106066 //layer=ply \
 //thickness=0.18 //x=41.525 //y=4.97 //x2=41.6 //y2=5.045
r1435 (  328 329 ) resistor r=102.553 //w=0.094 //l=0.2 //layer=ply \
 //thickness=0.18 //x=41.525 //y=4.97 //x2=41.325 //y2=4.97
r1436 (  327 422 ) resistor r=38.6777 //w=0.284 //l=0.198997 //layer=ply \
 //thickness=0.18 //x=41.28 //y=2.095 //x2=41.205 //y2=2.26
r1437 (  326 420 ) resistor r=21.2976 //w=0.217 //l=0.0928709 //layer=ply \
 //thickness=0.18 //x=41.28 //y=1.63 //x2=41.24 //y2=1.555
r1438 (  326 327 ) resistor r=238.436 //w=0.094 //l=0.465 //layer=ply \
 //thickness=0.18 //x=41.28 //y=1.63 //x2=41.28 //y2=2.095
r1439 (  325 420 ) resistor r=39.0671 //w=0.217 //l=0.173853 //layer=ply \
 //thickness=0.18 //x=41.28 //y=1.4 //x2=41.24 //y2=1.555
r1440 (  324 419 ) resistor r=45.1352 //w=0.168 //l=0.173853 //layer=ply \
 //thickness=0.18 //x=41.28 //y=1.09 //x2=41.24 //y2=0.935
r1441 (  324 325 ) resistor r=158.957 //w=0.094 //l=0.31 //layer=ply \
 //thickness=0.18 //x=41.28 //y=1.09 //x2=41.28 //y2=1.4
r1442 (  319 413 ) resistor r=5.52526 //w=0.168 //l=0.115 //layer=ply \
 //thickness=0.18 //x=40.91 //y=1.555 //x2=40.795 //y2=1.555
r1443 (  318 420 ) resistor r=11.4558 //w=0.217 //l=0.115 //layer=ply \
 //thickness=0.18 //x=41.125 //y=1.555 //x2=41.24 //y2=1.555
r1444 (  317 412 ) resistor r=5.52526 //w=0.168 //l=0.115 //layer=ply \
 //thickness=0.18 //x=40.91 //y=0.935 //x2=40.795 //y2=0.935
r1445 (  316 419 ) resistor r=5.52526 //w=0.168 //l=0.115 //layer=ply \
 //thickness=0.18 //x=41.125 //y=0.935 //x2=41.24 //y2=0.935
r1446 (  316 317 ) resistor r=110.245 //w=0.094 //l=0.215 //layer=ply \
 //thickness=0.18 //x=41.125 //y=0.935 //x2=40.91 //y2=0.935
r1447 (  315 413 ) resistor r=45.1352 //w=0.168 //l=0.173853 //layer=ply \
 //thickness=0.18 //x=40.755 //y=1.4 //x2=40.795 //y2=1.555
r1448 (  314 412 ) resistor r=45.1352 //w=0.168 //l=0.173853 //layer=ply \
 //thickness=0.18 //x=40.755 //y=1.09 //x2=40.795 //y2=0.935
r1449 (  314 315 ) resistor r=158.957 //w=0.094 //l=0.31 //layer=ply \
 //thickness=0.18 //x=40.755 //y=1.09 //x2=40.755 //y2=1.4
r1450 (  310 406 ) resistor r=16.5046 //w=0.27 //l=0.135 //layer=ply \
 //thickness=0.18 //x=26.895 //y=4.97 //x2=26.76 //y2=4.97
r1451 (  309 311 ) resistor r=26.9307 //w=0.15 //l=0.106066 //layer=ply \
 //thickness=0.18 //x=27.095 //y=4.97 //x2=27.17 //y2=5.045
r1452 (  309 310 ) resistor r=102.553 //w=0.094 //l=0.2 //layer=ply \
 //thickness=0.18 //x=27.095 //y=4.97 //x2=26.895 //y2=4.97
r1453 (  308 411 ) resistor r=38.6777 //w=0.284 //l=0.198997 //layer=ply \
 //thickness=0.18 //x=26.85 //y=2.095 //x2=26.775 //y2=2.26
r1454 (  307 409 ) resistor r=21.2976 //w=0.217 //l=0.0928709 //layer=ply \
 //thickness=0.18 //x=26.85 //y=1.63 //x2=26.81 //y2=1.555
r1455 (  307 308 ) resistor r=238.436 //w=0.094 //l=0.465 //layer=ply \
 //thickness=0.18 //x=26.85 //y=1.63 //x2=26.85 //y2=2.095
r1456 (  306 409 ) resistor r=39.0671 //w=0.217 //l=0.173853 //layer=ply \
 //thickness=0.18 //x=26.85 //y=1.4 //x2=26.81 //y2=1.555
r1457 (  305 408 ) resistor r=45.1352 //w=0.168 //l=0.173853 //layer=ply \
 //thickness=0.18 //x=26.85 //y=1.09 //x2=26.81 //y2=0.935
r1458 (  305 306 ) resistor r=158.957 //w=0.094 //l=0.31 //layer=ply \
 //thickness=0.18 //x=26.85 //y=1.09 //x2=26.85 //y2=1.4
r1459 (  300 402 ) resistor r=5.52526 //w=0.168 //l=0.115 //layer=ply \
 //thickness=0.18 //x=26.48 //y=1.555 //x2=26.365 //y2=1.555
r1460 (  299 409 ) resistor r=11.4558 //w=0.217 //l=0.115 //layer=ply \
 //thickness=0.18 //x=26.695 //y=1.555 //x2=26.81 //y2=1.555
r1461 (  298 401 ) resistor r=5.52526 //w=0.168 //l=0.115 //layer=ply \
 //thickness=0.18 //x=26.48 //y=0.935 //x2=26.365 //y2=0.935
r1462 (  297 408 ) resistor r=5.52526 //w=0.168 //l=0.115 //layer=ply \
 //thickness=0.18 //x=26.695 //y=0.935 //x2=26.81 //y2=0.935
r1463 (  297 298 ) resistor r=110.245 //w=0.094 //l=0.215 //layer=ply \
 //thickness=0.18 //x=26.695 //y=0.935 //x2=26.48 //y2=0.935
r1464 (  296 402 ) resistor r=45.1352 //w=0.168 //l=0.173853 //layer=ply \
 //thickness=0.18 //x=26.325 //y=1.4 //x2=26.365 //y2=1.555
r1465 (  295 401 ) resistor r=45.1352 //w=0.168 //l=0.173853 //layer=ply \
 //thickness=0.18 //x=26.325 //y=1.09 //x2=26.365 //y2=0.935
r1466 (  295 296 ) resistor r=158.957 //w=0.094 //l=0.31 //layer=ply \
 //thickness=0.18 //x=26.325 //y=1.09 //x2=26.325 //y2=1.4
r1467 (  291 395 ) resistor r=16.5046 //w=0.27 //l=0.135 //layer=ply \
 //thickness=0.18 //x=12.465 //y=4.97 //x2=12.33 //y2=4.97
r1468 (  290 292 ) resistor r=26.9307 //w=0.15 //l=0.106066 //layer=ply \
 //thickness=0.18 //x=12.665 //y=4.97 //x2=12.74 //y2=5.045
r1469 (  290 291 ) resistor r=102.553 //w=0.094 //l=0.2 //layer=ply \
 //thickness=0.18 //x=12.665 //y=4.97 //x2=12.465 //y2=4.97
r1470 (  289 400 ) resistor r=38.6777 //w=0.284 //l=0.198997 //layer=ply \
 //thickness=0.18 //x=12.42 //y=2.095 //x2=12.345 //y2=2.26
r1471 (  288 398 ) resistor r=21.2976 //w=0.217 //l=0.0928709 //layer=ply \
 //thickness=0.18 //x=12.42 //y=1.63 //x2=12.38 //y2=1.555
r1472 (  288 289 ) resistor r=238.436 //w=0.094 //l=0.465 //layer=ply \
 //thickness=0.18 //x=12.42 //y=1.63 //x2=12.42 //y2=2.095
r1473 (  287 398 ) resistor r=39.0671 //w=0.217 //l=0.173853 //layer=ply \
 //thickness=0.18 //x=12.42 //y=1.4 //x2=12.38 //y2=1.555
r1474 (  286 397 ) resistor r=45.1352 //w=0.168 //l=0.173853 //layer=ply \
 //thickness=0.18 //x=12.42 //y=1.09 //x2=12.38 //y2=0.935
r1475 (  286 287 ) resistor r=158.957 //w=0.094 //l=0.31 //layer=ply \
 //thickness=0.18 //x=12.42 //y=1.09 //x2=12.42 //y2=1.4
r1476 (  281 391 ) resistor r=5.52526 //w=0.168 //l=0.115 //layer=ply \
 //thickness=0.18 //x=12.05 //y=1.555 //x2=11.935 //y2=1.555
r1477 (  280 398 ) resistor r=11.4558 //w=0.217 //l=0.115 //layer=ply \
 //thickness=0.18 //x=12.265 //y=1.555 //x2=12.38 //y2=1.555
r1478 (  279 390 ) resistor r=5.52526 //w=0.168 //l=0.115 //layer=ply \
 //thickness=0.18 //x=12.05 //y=0.935 //x2=11.935 //y2=0.935
r1479 (  278 397 ) resistor r=5.52526 //w=0.168 //l=0.115 //layer=ply \
 //thickness=0.18 //x=12.265 //y=0.935 //x2=12.38 //y2=0.935
r1480 (  278 279 ) resistor r=110.245 //w=0.094 //l=0.215 //layer=ply \
 //thickness=0.18 //x=12.265 //y=0.935 //x2=12.05 //y2=0.935
r1481 (  277 391 ) resistor r=45.1352 //w=0.168 //l=0.173853 //layer=ply \
 //thickness=0.18 //x=11.895 //y=1.4 //x2=11.935 //y2=1.555
r1482 (  276 390 ) resistor r=45.1352 //w=0.168 //l=0.173853 //layer=ply \
 //thickness=0.18 //x=11.895 //y=1.09 //x2=11.935 //y2=0.935
r1483 (  276 277 ) resistor r=158.957 //w=0.094 //l=0.31 //layer=ply \
 //thickness=0.18 //x=11.895 //y=1.09 //x2=11.895 //y2=1.4
r1484 (  275 387 ) resistor r=592.245 //w=0.094 //l=1.155 //layer=ply \
 //thickness=0.18 //x=84.89 //y=6.2 //x2=84.89 //y2=5.045
r1485 (  274 451 ) resistor r=592.245 //w=0.094 //l=1.155 //layer=ply \
 //thickness=0.18 //x=84.45 //y=6.2 //x2=84.45 //y2=5.045
r1486 (  273 368 ) resistor r=592.245 //w=0.094 //l=1.155 //layer=ply \
 //thickness=0.18 //x=70.46 //y=6.2 //x2=70.46 //y2=5.045
r1487 (  272 440 ) resistor r=592.245 //w=0.094 //l=1.155 //layer=ply \
 //thickness=0.18 //x=70.02 //y=6.2 //x2=70.02 //y2=5.045
r1488 (  271 349 ) resistor r=592.245 //w=0.094 //l=1.155 //layer=ply \
 //thickness=0.18 //x=56.03 //y=6.2 //x2=56.03 //y2=5.045
r1489 (  270 429 ) resistor r=592.245 //w=0.094 //l=1.155 //layer=ply \
 //thickness=0.18 //x=55.59 //y=6.2 //x2=55.59 //y2=5.045
r1490 (  269 330 ) resistor r=592.245 //w=0.094 //l=1.155 //layer=ply \
 //thickness=0.18 //x=41.6 //y=6.2 //x2=41.6 //y2=5.045
r1491 (  268 418 ) resistor r=592.245 //w=0.094 //l=1.155 //layer=ply \
 //thickness=0.18 //x=41.16 //y=6.2 //x2=41.16 //y2=5.045
r1492 (  267 311 ) resistor r=592.245 //w=0.094 //l=1.155 //layer=ply \
 //thickness=0.18 //x=27.17 //y=6.2 //x2=27.17 //y2=5.045
r1493 (  266 407 ) resistor r=592.245 //w=0.094 //l=1.155 //layer=ply \
 //thickness=0.18 //x=26.73 //y=6.2 //x2=26.73 //y2=5.045
r1494 (  265 292 ) resistor r=592.245 //w=0.094 //l=1.155 //layer=ply \
 //thickness=0.18 //x=12.74 //y=6.2 //x2=12.74 //y2=5.045
r1495 (  264 396 ) resistor r=592.245 //w=0.094 //l=1.155 //layer=ply \
 //thickness=0.18 //x=12.3 //y=6.2 //x2=12.3 //y2=5.045
r1496 (  263 375 ) resistor r=55.3787 //w=0.094 //l=0.108 //layer=ply \
 //thickness=0.18 //x=84.307 //y=1.555 //x2=84.415 //y2=1.555
r1497 (  263 376 ) resistor r=54.866 //w=0.094 //l=0.107 //layer=ply \
 //thickness=0.18 //x=84.307 //y=1.555 //x2=84.2 //y2=1.555
r1498 (  262 356 ) resistor r=55.3787 //w=0.094 //l=0.108 //layer=ply \
 //thickness=0.18 //x=69.877 //y=1.555 //x2=69.985 //y2=1.555
r1499 (  262 357 ) resistor r=54.866 //w=0.094 //l=0.107 //layer=ply \
 //thickness=0.18 //x=69.877 //y=1.555 //x2=69.77 //y2=1.555
r1500 (  261 337 ) resistor r=55.3787 //w=0.094 //l=0.108 //layer=ply \
 //thickness=0.18 //x=55.447 //y=1.555 //x2=55.555 //y2=1.555
r1501 (  261 338 ) resistor r=54.866 //w=0.094 //l=0.107 //layer=ply \
 //thickness=0.18 //x=55.447 //y=1.555 //x2=55.34 //y2=1.555
r1502 (  260 318 ) resistor r=55.3787 //w=0.094 //l=0.108 //layer=ply \
 //thickness=0.18 //x=41.017 //y=1.555 //x2=41.125 //y2=1.555
r1503 (  260 319 ) resistor r=54.866 //w=0.094 //l=0.107 //layer=ply \
 //thickness=0.18 //x=41.017 //y=1.555 //x2=40.91 //y2=1.555
r1504 (  259 299 ) resistor r=55.3787 //w=0.094 //l=0.108 //layer=ply \
 //thickness=0.18 //x=26.587 //y=1.555 //x2=26.695 //y2=1.555
r1505 (  259 300 ) resistor r=54.866 //w=0.094 //l=0.107 //layer=ply \
 //thickness=0.18 //x=26.587 //y=1.555 //x2=26.48 //y2=1.555
r1506 (  258 280 ) resistor r=55.3787 //w=0.094 //l=0.108 //layer=ply \
 //thickness=0.18 //x=12.157 //y=1.555 //x2=12.265 //y2=1.555
r1507 (  258 281 ) resistor r=54.866 //w=0.094 //l=0.107 //layer=ply \
 //thickness=0.18 //x=12.157 //y=1.555 //x2=12.05 //y2=1.555
r1508 (  254 448 ) resistor r=152 //w=0.17 //l=0.17 //layer=licon //count=1 \
 //x=84.48 //y=4.88 //x2=84.48 //y2=4.88
r1509 (  245 455 ) resistor r=152 //w=0.17 //l=0.17 //layer=licon //count=1 \
 //x=84.48 //y=2.26 //x2=84.48 //y2=2.26
r1510 (  240 437 ) resistor r=152 //w=0.17 //l=0.17 //layer=licon //count=1 \
 //x=70.05 //y=4.88 //x2=70.05 //y2=4.88
r1511 (  231 444 ) resistor r=152 //w=0.17 //l=0.17 //layer=licon //count=1 \
 //x=70.05 //y=2.26 //x2=70.05 //y2=2.26
r1512 (  226 426 ) resistor r=152 //w=0.17 //l=0.17 //layer=licon //count=1 \
 //x=55.62 //y=4.88 //x2=55.62 //y2=4.88
r1513 (  217 433 ) resistor r=152 //w=0.17 //l=0.17 //layer=licon //count=1 \
 //x=55.62 //y=2.26 //x2=55.62 //y2=2.26
r1514 (  212 415 ) resistor r=152 //w=0.17 //l=0.17 //layer=licon //count=1 \
 //x=41.19 //y=4.88 //x2=41.19 //y2=4.88
r1515 (  203 422 ) resistor r=152 //w=0.17 //l=0.17 //layer=licon //count=1 \
 //x=41.19 //y=2.26 //x2=41.19 //y2=2.26
r1516 (  198 404 ) resistor r=152 //w=0.17 //l=0.17 //layer=licon //count=1 \
 //x=26.76 //y=4.88 //x2=26.76 //y2=4.88
r1517 (  189 411 ) resistor r=152 //w=0.17 //l=0.17 //layer=licon //count=1 \
 //x=26.76 //y=2.26 //x2=26.76 //y2=2.26
r1518 (  184 393 ) resistor r=152 //w=0.17 //l=0.17 //layer=licon //count=1 \
 //x=12.33 //y=4.88 //x2=12.33 //y2=4.88
r1519 (  175 400 ) resistor r=152 //w=0.17 //l=0.17 //layer=licon //count=1 \
 //x=12.33 //y=2.26 //x2=12.33 //y2=2.26
r1520 (  159 161 ) resistor r=0.10734 //w=0.281 //l=0.16 //layer=m2 \
 //thickness=0.36 //x=12.33 //y=3.125 //x2=12.49 //y2=3.125
r1521 (  156 173 ) resistor r=3.98787 //w=0.179 //l=5.71999 //layer=m2 \
 //thickness=0.36 //x=78.77 //y=3.125 //x2=84.48 //y2=3.145
r1522 (  156 157 ) resistor r=0.410305 //w=0.131 //l=0.43 //layer=m2 \
 //thickness=0.36 //x=78.77 //y=3.125 //x2=78.34 //y2=3.125
r1523 (  154 157 ) resistor r=0.125 //w=0.17 //l=0.177341 //layer=m2 \
 //thickness=0.36 //x=78.17 //y=3.14 //x2=78.34 //y2=3.125
r1524 (  154 155 ) resistor r=3.84065 //w=0.131 //l=4.025 //layer=m2 \
 //thickness=0.36 //x=78.17 //y=3.14 //x2=74.145 //y2=3.14
r1525 (  152 155 ) resistor r=0.125 //w=0.17 //l=0.177341 //layer=m2 \
 //thickness=0.36 //x=73.975 //y=3.155 //x2=74.145 //y2=3.14
r1526 (  152 153 ) resistor r=0.329198 //w=0.131 //l=0.345 //layer=m2 \
 //thickness=0.36 //x=73.975 //y=3.155 //x2=73.63 //y2=3.155
r1527 (  150 153 ) resistor r=0.1875 //w=0.17 //l=0.262393 //layer=m2 \
 //thickness=0.36 //x=73.375 //y=3.14 //x2=73.63 //y2=3.155
r1528 (  150 151 ) resistor r=1.04008 //w=0.131 //l=1.09 //layer=m2 \
 //thickness=0.36 //x=73.375 //y=3.14 //x2=72.285 //y2=3.14
r1529 (  149 171 ) resistor r=1.1391 //w=0.189 //l=1.73494 //layer=m2 \
 //thickness=0.36 //x=71.77 //y=3.155 //x2=70.05 //y2=3.125
r1530 (  148 151 ) resistor r=0.125 //w=0.17 //l=0.177341 //layer=m2 \
 //thickness=0.36 //x=72.115 //y=3.155 //x2=72.285 //y2=3.14
r1531 (  148 149 ) resistor r=0.329198 //w=0.131 //l=0.345 //layer=m2 \
 //thickness=0.36 //x=72.115 //y=3.155 //x2=71.77 //y2=3.155
r1532 (  146 171 ) resistor r=0.593468 //w=0.189 //l=0.917224 //layer=m2 \
 //thickness=0.36 //x=69.155 //y=3.17 //x2=70.05 //y2=3.125
r1533 (  146 147 ) resistor r=0.329198 //w=0.131 //l=0.345 //layer=m2 \
 //thickness=0.36 //x=69.155 //y=3.17 //x2=68.81 //y2=3.17
r1534 (  144 147 ) resistor r=0.1875 //w=0.17 //l=0.269583 //layer=m2 \
 //thickness=0.36 //x=68.555 //y=3.14 //x2=68.81 //y2=3.17
r1535 (  144 145 ) resistor r=0.949427 //w=0.131 //l=0.995 //layer=m2 \
 //thickness=0.36 //x=68.555 //y=3.14 //x2=67.56 //y2=3.14
r1536 (  142 145 ) resistor r=0.1875 //w=0.17 //l=0.269583 //layer=m2 \
 //thickness=0.36 //x=67.305 //y=3.11 //x2=67.56 //y2=3.14
r1537 (  142 143 ) resistor r=0.410305 //w=0.131 //l=0.43 //layer=m2 \
 //thickness=0.36 //x=67.305 //y=3.11 //x2=66.875 //y2=3.11
r1538 (  140 143 ) resistor r=0.125 //w=0.17 //l=0.184391 //layer=m2 \
 //thickness=0.36 //x=66.705 //y=3.14 //x2=66.875 //y2=3.11
r1539 (  140 141 ) resistor r=2.08492 //w=0.131 //l=2.185 //layer=m2 \
 //thickness=0.36 //x=66.705 //y=3.14 //x2=64.52 //y2=3.14
r1540 (  138 141 ) resistor r=0.125 //w=0.17 //l=0.184391 //layer=m2 \
 //thickness=0.36 //x=64.35 //y=3.17 //x2=64.52 //y2=3.14
r1541 (  138 139 ) resistor r=0.329198 //w=0.131 //l=0.345 //layer=m2 \
 //thickness=0.36 //x=64.35 //y=3.17 //x2=64.005 //y2=3.17
r1542 (  136 139 ) resistor r=0.1875 //w=0.17 //l=0.269583 //layer=m2 \
 //thickness=0.36 //x=63.75 //y=3.14 //x2=64.005 //y2=3.17
r1543 (  136 137 ) resistor r=1.03053 //w=0.131 //l=1.08 //layer=m2 \
 //thickness=0.36 //x=63.75 //y=3.14 //x2=62.67 //y2=3.14
r1544 (  134 137 ) resistor r=0.125 //w=0.17 //l=0.184391 //layer=m2 \
 //thickness=0.36 //x=62.5 //y=3.17 //x2=62.67 //y2=3.14
r1545 (  134 135 ) resistor r=0.329198 //w=0.131 //l=0.345 //layer=m2 \
 //thickness=0.36 //x=62.5 //y=3.17 //x2=62.155 //y2=3.17
r1546 (  133 169 ) resistor r=3.99136 //w=0.179 //l=5.7225 //layer=m2 \
 //thickness=0.36 //x=61.335 //y=3.13 //x2=55.62 //y2=3.145
r1547 (  132 135 ) resistor r=0.286765 //w=0.17 //l=0.409512 //layer=m2 \
 //thickness=0.36 //x=61.765 //y=3.13 //x2=62.155 //y2=3.17
r1548 (  132 133 ) resistor r=0.410305 //w=0.131 //l=0.43 //layer=m2 \
 //thickness=0.36 //x=61.765 //y=3.13 //x2=61.335 //y2=3.13
r1549 (  130 169 ) resistor r=0.112172 //w=0.179 //l=0.162481 //layer=m2 \
 //thickness=0.36 //x=55.46 //y=3.14 //x2=55.62 //y2=3.145
r1550 (  130 167 ) resistor r=2.39027 //w=0.131 //l=2.505 //layer=m2 \
 //thickness=0.36 //x=55.46 //y=3.14 //x2=52.955 //y2=3.14
r1551 (  128 167 ) resistor r=0.0824018 //w=0.161 //l=0.1 //layer=m2 \
 //thickness=0.36 //x=52.855 //y=3.125 //x2=52.955 //y2=3.125
r1552 (  128 129 ) resistor r=0.310559 //w=0.161 //l=0.4 //layer=m2 \
 //thickness=0.36 //x=52.855 //y=3.125 //x2=52.455 //y2=3.125
r1553 (  126 129 ) resistor r=1.84956 //w=0.172 //l=2.545 //layer=m2 \
 //thickness=0.36 //x=49.91 //y=3.125 //x2=52.455 //y2=3.125
r1554 (  126 127 ) resistor r=0.410305 //w=0.131 //l=0.43 //layer=m2 \
 //thickness=0.36 //x=49.91 //y=3.125 //x2=49.48 //y2=3.125
r1555 (  124 127 ) resistor r=0.125 //w=0.17 //l=0.177341 //layer=m2 \
 //thickness=0.36 //x=49.31 //y=3.14 //x2=49.48 //y2=3.125
r1556 (  124 125 ) resistor r=3.84065 //w=0.131 //l=4.025 //layer=m2 \
 //thickness=0.36 //x=49.31 //y=3.14 //x2=45.285 //y2=3.14
r1557 (  122 125 ) resistor r=0.125 //w=0.17 //l=0.177341 //layer=m2 \
 //thickness=0.36 //x=45.115 //y=3.155 //x2=45.285 //y2=3.14
r1558 (  122 123 ) resistor r=0.329198 //w=0.131 //l=0.345 //layer=m2 \
 //thickness=0.36 //x=45.115 //y=3.155 //x2=44.77 //y2=3.155
r1559 (  120 123 ) resistor r=0.1875 //w=0.17 //l=0.262393 //layer=m2 \
 //thickness=0.36 //x=44.515 //y=3.14 //x2=44.77 //y2=3.155
r1560 (  120 121 ) resistor r=1.04008 //w=0.131 //l=1.09 //layer=m2 \
 //thickness=0.36 //x=44.515 //y=3.14 //x2=43.425 //y2=3.14
r1561 (  119 166 ) resistor r=1.1391 //w=0.189 //l=1.73494 //layer=m2 \
 //thickness=0.36 //x=42.91 //y=3.155 //x2=41.19 //y2=3.125
r1562 (  118 121 ) resistor r=0.125 //w=0.17 //l=0.177341 //layer=m2 \
 //thickness=0.36 //x=43.255 //y=3.155 //x2=43.425 //y2=3.14
r1563 (  118 119 ) resistor r=0.329198 //w=0.131 //l=0.345 //layer=m2 \
 //thickness=0.36 //x=43.255 //y=3.155 //x2=42.91 //y2=3.155
r1564 (  116 166 ) resistor r=0.590161 //w=0.189 //l=0.912223 //layer=m2 \
 //thickness=0.36 //x=40.3 //y=3.17 //x2=41.19 //y2=3.125
r1565 (  116 117 ) resistor r=0.333969 //w=0.131 //l=0.35 //layer=m2 \
 //thickness=0.36 //x=40.3 //y=3.17 //x2=39.95 //y2=3.17
r1566 (  114 117 ) resistor r=0.1875 //w=0.17 //l=0.269583 //layer=m2 \
 //thickness=0.36 //x=39.695 //y=3.14 //x2=39.95 //y2=3.17
r1567 (  114 115 ) resistor r=0.944656 //w=0.131 //l=0.99 //layer=m2 \
 //thickness=0.36 //x=39.695 //y=3.14 //x2=38.705 //y2=3.14
r1568 (  112 115 ) resistor r=0.1875 //w=0.17 //l=0.269583 //layer=m2 \
 //thickness=0.36 //x=38.45 //y=3.11 //x2=38.705 //y2=3.14
r1569 (  112 113 ) resistor r=0.415076 //w=0.131 //l=0.435 //layer=m2 \
 //thickness=0.36 //x=38.45 //y=3.11 //x2=38.015 //y2=3.11
r1570 (  110 113 ) resistor r=0.125 //w=0.17 //l=0.184391 //layer=m2 \
 //thickness=0.36 //x=37.845 //y=3.14 //x2=38.015 //y2=3.11
r1571 (  110 111 ) resistor r=2.08015 //w=0.131 //l=2.18 //layer=m2 \
 //thickness=0.36 //x=37.845 //y=3.14 //x2=35.665 //y2=3.14
r1572 (  108 111 ) resistor r=0.125 //w=0.17 //l=0.184391 //layer=m2 \
 //thickness=0.36 //x=35.495 //y=3.17 //x2=35.665 //y2=3.14
r1573 (  108 109 ) resistor r=0.333969 //w=0.131 //l=0.35 //layer=m2 \
 //thickness=0.36 //x=35.495 //y=3.17 //x2=35.145 //y2=3.17
r1574 (  106 109 ) resistor r=0.1875 //w=0.17 //l=0.269583 //layer=m2 \
 //thickness=0.36 //x=34.89 //y=3.14 //x2=35.145 //y2=3.17
r1575 (  106 107 ) resistor r=1.02576 //w=0.131 //l=1.075 //layer=m2 \
 //thickness=0.36 //x=34.89 //y=3.14 //x2=33.815 //y2=3.14
r1576 (  104 107 ) resistor r=0.125 //w=0.17 //l=0.184391 //layer=m2 \
 //thickness=0.36 //x=33.645 //y=3.17 //x2=33.815 //y2=3.14
r1577 (  104 105 ) resistor r=0.333969 //w=0.131 //l=0.35 //layer=m2 \
 //thickness=0.36 //x=33.645 //y=3.17 //x2=33.295 //y2=3.17
r1578 (  103 164 ) resistor r=3.99136 //w=0.179 //l=5.7225 //layer=m2 \
 //thickness=0.36 //x=32.475 //y=3.13 //x2=26.76 //y2=3.145
r1579 (  102 105 ) resistor r=0.283088 //w=0.17 //l=0.404506 //layer=m2 \
 //thickness=0.36 //x=32.91 //y=3.13 //x2=33.295 //y2=3.17
r1580 (  102 103 ) resistor r=0.415076 //w=0.131 //l=0.435 //layer=m2 \
 //thickness=0.36 //x=32.91 //y=3.13 //x2=32.475 //y2=3.13
r1581 (  100 164 ) resistor r=0.112172 //w=0.179 //l=0.162481 //layer=m2 \
 //thickness=0.36 //x=26.6 //y=3.14 //x2=26.76 //y2=3.145
r1582 (  100 162 ) resistor r=3.0916 //w=0.131 //l=3.24 //layer=m2 \
 //thickness=0.36 //x=26.6 //y=3.14 //x2=23.36 //y2=3.14
r1583 (  98 162 ) resistor r=0.0803857 //w=0.146 //l=0.092 //layer=m2 \
 //thickness=0.36 //x=23.268 //y=3.132 //x2=23.36 //y2=3.132
r1584 (  98 99 ) resistor r=0.356164 //w=0.146 //l=0.416 //layer=m2 \
 //thickness=0.36 //x=23.268 //y=3.132 //x2=22.852 //y2=3.132
r1585 (  96 99 ) resistor r=1.31725 //w=0.171 //l=1.8055 //layer=m2 \
 //thickness=0.36 //x=21.05 //y=3.125 //x2=22.852 //y2=3.132
r1586 (  96 97 ) resistor r=0.410305 //w=0.131 //l=0.43 //layer=m2 \
 //thickness=0.36 //x=21.05 //y=3.125 //x2=20.62 //y2=3.125
r1587 (  94 97 ) resistor r=0.125 //w=0.17 //l=0.177341 //layer=m2 \
 //thickness=0.36 //x=20.45 //y=3.14 //x2=20.62 //y2=3.125
r1588 (  94 95 ) resistor r=3.84065 //w=0.131 //l=4.025 //layer=m2 \
 //thickness=0.36 //x=20.45 //y=3.14 //x2=16.425 //y2=3.14
r1589 (  92 95 ) resistor r=0.125 //w=0.17 //l=0.177341 //layer=m2 \
 //thickness=0.36 //x=16.255 //y=3.155 //x2=16.425 //y2=3.14
r1590 (  92 93 ) resistor r=0.329198 //w=0.131 //l=0.345 //layer=m2 \
 //thickness=0.36 //x=16.255 //y=3.155 //x2=15.91 //y2=3.155
r1591 (  90 93 ) resistor r=0.1875 //w=0.17 //l=0.262393 //layer=m2 \
 //thickness=0.36 //x=15.655 //y=3.14 //x2=15.91 //y2=3.155
r1592 (  90 91 ) resistor r=1.04008 //w=0.131 //l=1.09 //layer=m2 \
 //thickness=0.36 //x=15.655 //y=3.14 //x2=14.565 //y2=3.14
r1593 (  88 91 ) resistor r=0.125 //w=0.17 //l=0.177341 //layer=m2 \
 //thickness=0.36 //x=14.395 //y=3.155 //x2=14.565 //y2=3.14
r1594 (  88 89 ) resistor r=0.329198 //w=0.131 //l=0.345 //layer=m2 \
 //thickness=0.36 //x=14.395 //y=3.155 //x2=14.05 //y2=3.155
r1595 (  86 89 ) resistor r=0.1875 //w=0.17 //l=0.262393 //layer=m2 \
 //thickness=0.36 //x=13.795 //y=3.14 //x2=14.05 //y2=3.155
r1596 (  86 161 ) resistor r=1.24523 //w=0.131 //l=1.305 //layer=m2 \
 //thickness=0.36 //x=13.795 //y=3.14 //x2=12.49 //y2=3.14
r1597 (  85 254 ) resistor r=9.3 //w=0.17 //l=0.17 //layer=mcon //count=1 \
 //x=84.48 //y=4.88 //x2=84.48 //y2=4.88
r1598 (  83 245 ) resistor r=9.3 //w=0.17 //l=0.17 //layer=mcon //count=1 \
 //x=84.48 //y=2.26 //x2=84.48 //y2=2.26
r1599 (  81 173 ) resistor r=4.5 //w=0.15 //l=0.15 //layer=via1 //count=1 \
 //x=84.48 //y=3.145 //x2=84.48 //y2=3.145
r1600 (  79 81 ) resistor r=0.00166223 //w=0.376 //l=0.005 //layer=m1 \
 //thickness=0.36 //x=84.427 //y=3.14 //x2=84.427 //y2=3.145
r1601 (  75 171 ) resistor r=4.5 //w=0.15 //l=0.15 //layer=via1 //count=1 \
 //x=70.05 //y=3.125 //x2=70.05 //y2=3.125
r1602 (  73 240 ) resistor r=9.3 //w=0.17 //l=0.17 //layer=mcon //count=1 \
 //x=70.05 //y=4.88 //x2=70.05 //y2=4.88
r1603 (  71 231 ) resistor r=9.3 //w=0.17 //l=0.17 //layer=mcon //count=1 \
 //x=70.05 //y=2.26 //x2=70.05 //y2=2.26
r1604 (  69 226 ) resistor r=9.3 //w=0.17 //l=0.17 //layer=mcon //count=1 \
 //x=55.62 //y=4.88 //x2=55.62 //y2=4.88
r1605 (  67 217 ) resistor r=9.3 //w=0.17 //l=0.17 //layer=mcon //count=1 \
 //x=55.62 //y=2.26 //x2=55.62 //y2=2.26
r1606 (  65 169 ) resistor r=4.5 //w=0.15 //l=0.15 //layer=via1 //count=1 \
 //x=55.62 //y=3.145 //x2=55.62 //y2=3.145
r1607 (  59 166 ) resistor r=4.5 //w=0.15 //l=0.15 //layer=via1 //count=1 \
 //x=41.19 //y=3.125 //x2=41.19 //y2=3.125
r1608 (  57 212 ) resistor r=9.3 //w=0.17 //l=0.17 //layer=mcon //count=1 \
 //x=41.19 //y=4.88 //x2=41.19 //y2=4.88
r1609 (  55 203 ) resistor r=9.3 //w=0.17 //l=0.17 //layer=mcon //count=1 \
 //x=41.19 //y=2.26 //x2=41.19 //y2=2.26
r1610 (  53 198 ) resistor r=9.3 //w=0.17 //l=0.17 //layer=mcon //count=1 \
 //x=26.76 //y=4.88 //x2=26.76 //y2=4.88
r1611 (  51 189 ) resistor r=9.3 //w=0.17 //l=0.17 //layer=mcon //count=1 \
 //x=26.76 //y=2.26 //x2=26.76 //y2=2.26
r1612 (  49 164 ) resistor r=4.5 //w=0.15 //l=0.15 //layer=via1 //count=1 \
 //x=26.76 //y=3.145 //x2=26.76 //y2=3.145
r1613 (  43 159 ) resistor r=4.5 //w=0.15 //l=0.15 //layer=via1 //count=1 \
 //x=12.33 //y=3.125 //x2=12.33 //y2=3.125
r1614 (  41 184 ) resistor r=9.3 //w=0.17 //l=0.17 //layer=mcon //count=1 \
 //x=12.33 //y=4.88 //x2=12.33 //y2=4.88
r1615 (  39 175 ) resistor r=9.3 //w=0.17 //l=0.17 //layer=mcon //count=1 \
 //x=12.33 //y=2.26 //x2=12.33 //y2=2.26
r1616 (  37 85 ) resistor r=0.0717383 //w=0.224 //l=0.115 //layer=m1 \
 //thickness=0.36 //x=84.48 //y=4.765 //x2=84.48 //y2=4.88
r1617 (  36 81 ) resistor r=0.0911593 //w=0.376 //l=0.184608 //layer=m1 \
 //thickness=0.36 //x=84.48 //y=3.305 //x2=84.427 //y2=3.145
r1618 (  36 37 ) resistor r=1.39313 //w=0.131 //l=1.46 //layer=m1 \
 //thickness=0.36 //x=84.48 //y=3.305 //x2=84.48 //y2=4.765
r1619 (  35 79 ) resistor r=0.0894971 //w=0.376 //l=0.179555 //layer=m1 \
 //thickness=0.36 //x=84.48 //y=2.985 //x2=84.427 //y2=3.14
r1620 (  34 83 ) resistor r=0.0715665 //w=0.226 //l=0.115996 //layer=m1 \
 //thickness=0.36 //x=84.48 //y=2.375 //x2=84.482 //y2=2.26
r1621 (  34 35 ) resistor r=0.582061 //w=0.131 //l=0.61 //layer=m1 \
 //thickness=0.36 //x=84.48 //y=2.375 //x2=84.48 //y2=2.985
r1622 (  33 73 ) resistor r=0.0717383 //w=0.224 //l=0.115 //layer=m1 \
 //thickness=0.36 //x=70.05 //y=4.765 //x2=70.05 //y2=4.88
r1623 (  32 33 ) resistor r=1.41221 //w=0.131 //l=1.48 //layer=m1 \
 //thickness=0.36 //x=70.05 //y=3.285 //x2=70.05 //y2=4.765
r1624 (  30 75 ) resistor r=0.0911593 //w=0.376 //l=0.184174 //layer=m1 \
 //thickness=0.36 //x=70.05 //y=2.965 //x2=70.102 //y2=3.125
r1625 (  29 71 ) resistor r=0.0715665 //w=0.226 //l=0.115996 //layer=m1 \
 //thickness=0.36 //x=70.05 //y=2.375 //x2=70.052 //y2=2.26
r1626 (  28 69 ) resistor r=0.0717383 //w=0.224 //l=0.115 //layer=m1 \
 //thickness=0.36 //x=55.62 //y=4.765 //x2=55.62 //y2=4.88
r1627 (  27 65 ) resistor r=0.0911593 //w=0.376 //l=0.184608 //layer=m1 \
 //thickness=0.36 //x=55.62 //y=3.305 //x2=55.567 //y2=3.145
r1628 (  27 28 ) resistor r=1.39313 //w=0.131 //l=1.46 //layer=m1 \
 //thickness=0.36 //x=55.62 //y=3.305 //x2=55.62 //y2=4.765
r1629 (  25 67 ) resistor r=0.0715665 //w=0.226 //l=0.115996 //layer=m1 \
 //thickness=0.36 //x=55.62 //y=2.375 //x2=55.622 //y2=2.26
r1630 (  25 26 ) resistor r=0.582061 //w=0.131 //l=0.61 //layer=m1 \
 //thickness=0.36 //x=55.62 //y=2.375 //x2=55.62 //y2=2.985
r1631 (  24 57 ) resistor r=0.0717383 //w=0.224 //l=0.115 //layer=m1 \
 //thickness=0.36 //x=41.19 //y=4.765 //x2=41.19 //y2=4.88
r1632 (  23 24 ) resistor r=1.41221 //w=0.131 //l=1.48 //layer=m1 \
 //thickness=0.36 //x=41.19 //y=3.285 //x2=41.19 //y2=4.765
r1633 (  21 59 ) resistor r=0.0911593 //w=0.376 //l=0.184174 //layer=m1 \
 //thickness=0.36 //x=41.19 //y=2.965 //x2=41.242 //y2=3.125
r1634 (  20 55 ) resistor r=0.0715665 //w=0.226 //l=0.115996 //layer=m1 \
 //thickness=0.36 //x=41.19 //y=2.375 //x2=41.192 //y2=2.26
r1635 (  19 53 ) resistor r=0.0717383 //w=0.224 //l=0.115 //layer=m1 \
 //thickness=0.36 //x=26.76 //y=4.765 //x2=26.76 //y2=4.88
r1636 (  18 49 ) resistor r=0.0911593 //w=0.376 //l=0.184608 //layer=m1 \
 //thickness=0.36 //x=26.76 //y=3.305 //x2=26.707 //y2=3.145
r1637 (  18 19 ) resistor r=1.39313 //w=0.131 //l=1.46 //layer=m1 \
 //thickness=0.36 //x=26.76 //y=3.305 //x2=26.76 //y2=4.765
r1638 (  15 51 ) resistor r=0.0715665 //w=0.226 //l=0.115996 //layer=m1 \
 //thickness=0.36 //x=26.76 //y=2.375 //x2=26.762 //y2=2.26
r1639 (  14 41 ) resistor r=0.0717383 //w=0.224 //l=0.115 //layer=m1 \
 //thickness=0.36 //x=12.33 //y=4.765 //x2=12.33 //y2=4.88
r1640 (  13 14 ) resistor r=1.41221 //w=0.131 //l=1.48 //layer=m1 \
 //thickness=0.36 //x=12.33 //y=3.285 //x2=12.33 //y2=4.765
r1641 (  11 43 ) resistor r=0.0911593 //w=0.376 //l=0.184174 //layer=m1 \
 //thickness=0.36 //x=12.33 //y=2.965 //x2=12.382 //y2=3.125
r1642 (  10 39 ) resistor r=0.0715665 //w=0.226 //l=0.115996 //layer=m1 \
 //thickness=0.36 //x=12.33 //y=2.375 //x2=12.332 //y2=2.26
r1643 (  9 32 ) resistor r=0.0861726 //w=0.376 //l=0.169012 //layer=m1 \
 //thickness=0.36 //x=70.102 //y=3.14 //x2=70.05 //y2=3.285
r1644 (  9 75 ) resistor r=0.0049867 //w=0.376 //l=0.015 //layer=m1 \
 //thickness=0.36 //x=70.102 //y=3.14 //x2=70.102 //y2=3.125
r1645 (  8 65 ) resistor r=0.00166223 //w=0.376 //l=0.005 //layer=m1 \
 //thickness=0.36 //x=55.567 //y=3.14 //x2=55.567 //y2=3.145
r1646 (  8 26 ) resistor r=0.0894971 //w=0.376 //l=0.179555 //layer=m1 \
 //thickness=0.36 //x=55.567 //y=3.14 //x2=55.62 //y2=2.985
r1647 (  7 23 ) resistor r=0.0861726 //w=0.376 //l=0.169012 //layer=m1 \
 //thickness=0.36 //x=41.242 //y=3.14 //x2=41.19 //y2=3.285
r1648 (  7 59 ) resistor r=0.0049867 //w=0.376 //l=0.015 //layer=m1 \
 //thickness=0.36 //x=41.242 //y=3.14 //x2=41.242 //y2=3.125
r1649 (  6 49 ) resistor r=0.00166223 //w=0.376 //l=0.005 //layer=m1 \
 //thickness=0.36 //x=26.707 //y=3.14 //x2=26.707 //y2=3.145
r1650 (  6 16 ) resistor r=0.0894971 //w=0.376 //l=0.179555 //layer=m1 \
 //thickness=0.36 //x=26.707 //y=3.14 //x2=26.76 //y2=2.985
r1651 (  5 13 ) resistor r=0.0861726 //w=0.376 //l=0.169012 //layer=m1 \
 //thickness=0.36 //x=12.382 //y=3.14 //x2=12.33 //y2=3.285
r1652 (  5 43 ) resistor r=0.0049867 //w=0.376 //l=0.015 //layer=m1 \
 //thickness=0.36 //x=12.382 //y=3.14 //x2=12.382 //y2=3.125
r1653 (  4 30 ) resistor r=0.186069 //w=0.131 //l=0.195 //layer=m1 \
 //thickness=0.36 //x=70.05 //y=2.77 //x2=70.05 //y2=2.965
r1654 (  4 29 ) resistor r=0.376908 //w=0.131 //l=0.395 //layer=m1 \
 //thickness=0.36 //x=70.05 //y=2.77 //x2=70.05 //y2=2.375
r1655 (  3 21 ) resistor r=0.186069 //w=0.131 //l=0.195 //layer=m1 \
 //thickness=0.36 //x=41.19 //y=2.77 //x2=41.19 //y2=2.965
r1656 (  3 20 ) resistor r=0.376908 //w=0.131 //l=0.395 //layer=m1 \
 //thickness=0.36 //x=41.19 //y=2.77 //x2=41.19 //y2=2.375
r1657 (  2 16 ) resistor r=0.205153 //w=0.131 //l=0.215 //layer=m1 \
 //thickness=0.36 //x=26.76 //y=2.77 //x2=26.76 //y2=2.985
r1658 (  2 15 ) resistor r=0.376908 //w=0.131 //l=0.395 //layer=m1 \
 //thickness=0.36 //x=26.76 //y=2.77 //x2=26.76 //y2=2.375
r1659 (  1 11 ) resistor r=0.186069 //w=0.131 //l=0.195 //layer=m1 \
 //thickness=0.36 //x=12.33 //y=2.77 //x2=12.33 //y2=2.965
r1660 (  1 10 ) resistor r=0.376908 //w=0.131 //l=0.395 //layer=m1 \
 //thickness=0.36 //x=12.33 //y=2.77 //x2=12.33 //y2=2.375
ends PM_TMRDFFSNRNQNX1\%SN

subckt PM_TMRDFFSNRNQNX1\%noxref_19 ( 1 2 3 4 5 6 7 8 9 11 14 15 17 18 19 20 \
 22 23 24 25 26 27 28 34 38 45 48 51 57 61 70 72 73 77 80 81 87 96 101 110 115 \
 123 131 148 157 161 162 163 164 165 166 167 168 169 173 174 175 180 182 185 \
 186 190 191 192 197 199 202 203 207 208 209 214 216 219 220 222 223 228 232 \
 233 238 242 243 248 251 253 254 255 )
c603 ( 251 0 ) capacitor c=0.00885916f //x=76.035 //y=1.095
c604 ( 248 0 ) capacitor c=0.0651477f //x=85.59 //y=4.88
c605 ( 243 0 ) capacitor c=0.0278202f //x=85.59 //y=2.095
c606 ( 242 0 ) capacitor c=0.0503043f //x=85.59 //y=2.26
c607 ( 238 0 ) capacitor c=0.0651406f //x=71.16 //y=4.88
c608 ( 233 0 ) capacitor c=0.0278202f //x=71.16 //y=2.095
c609 ( 232 0 ) capacitor c=0.0503043f //x=71.16 //y=2.26
c610 ( 228 0 ) capacitor c=0.0653609f //x=66.35 //y=4.88
c611 ( 223 0 ) capacitor c=0.0278202f //x=66.35 //y=2.095
c612 ( 222 0 ) capacitor c=0.0503043f //x=66.35 //y=2.26
c613 ( 220 0 ) capacitor c=0.0443175f //x=86.11 //y=1.44
c614 ( 219 0 ) capacitor c=0.0199703f //x=86.11 //y=1.095
c615 ( 216 0 ) capacitor c=0.0162526f //x=85.955 //y=1.595
c616 ( 214 0 ) capacitor c=0.0157807f //x=85.955 //y=0.94
c617 ( 209 0 ) capacitor c=0.0220935f //x=85.58 //y=1.75
c618 ( 208 0 ) capacitor c=0.0207489f //x=85.58 //y=1.44
c619 ( 207 0 ) capacitor c=0.0194091f //x=85.58 //y=1.095
c620 ( 203 0 ) capacitor c=0.0443175f //x=71.68 //y=1.44
c621 ( 202 0 ) capacitor c=0.0199703f //x=71.68 //y=1.095
c622 ( 199 0 ) capacitor c=0.0162526f //x=71.525 //y=1.595
c623 ( 197 0 ) capacitor c=0.0157807f //x=71.525 //y=0.94
c624 ( 192 0 ) capacitor c=0.0220935f //x=71.15 //y=1.75
c625 ( 191 0 ) capacitor c=0.0207489f //x=71.15 //y=1.44
c626 ( 190 0 ) capacitor c=0.0194091f //x=71.15 //y=1.095
c627 ( 186 0 ) capacitor c=0.0443175f //x=66.87 //y=1.44
c628 ( 185 0 ) capacitor c=0.0199703f //x=66.87 //y=1.095
c629 ( 182 0 ) capacitor c=0.0162526f //x=66.715 //y=1.595
c630 ( 180 0 ) capacitor c=0.0157807f //x=66.715 //y=0.94
c631 ( 175 0 ) capacitor c=0.0220935f //x=66.34 //y=1.75
c632 ( 174 0 ) capacitor c=0.0207489f //x=66.34 //y=1.44
c633 ( 173 0 ) capacitor c=0.0194091f //x=66.34 //y=1.095
c634 ( 169 0 ) capacitor c=0.159671f //x=85.77 //y=6.2
c635 ( 168 0 ) capacitor c=0.110208f //x=85.33 //y=6.2
c636 ( 167 0 ) capacitor c=0.159671f //x=71.34 //y=6.2
c637 ( 166 0 ) capacitor c=0.110208f //x=70.9 //y=6.2
c638 ( 165 0 ) capacitor c=0.159671f //x=66.53 //y=6.2
c639 ( 164 0 ) capacitor c=0.110208f //x=66.09 //y=6.2
c640 ( 157 0 ) capacitor c=7.7417e-19 //x=85.59 //y=4.88
c641 ( 148 0 ) capacitor c=0.00101179f //x=85.59 //y=2.26
c642 ( 131 0 ) capacitor c=0.0293124f //x=75.93 //y=5.56
c643 ( 123 0 ) capacitor c=0.029137f //x=75.05 //y=5.56
c644 ( 115 0 ) capacitor c=0.0278099f //x=74.17 //y=5.56
c645 ( 110 0 ) capacitor c=9.5006e-19 //x=71.16 //y=4.88
c646 ( 101 0 ) capacitor c=0.00101179f //x=71.16 //y=2.26
c647 ( 96 0 ) capacitor c=9.11512e-19 //x=66.35 //y=4.88
c648 ( 87 0 ) capacitor c=0.00101179f //x=66.35 //y=2.26
c649 ( 81 0 ) capacitor c=3.98458e-19 //x=71.32 //y=3.895
c650 ( 80 0 ) capacitor c=0.0441954f //x=71 //y=3.895
c651 ( 77 0 ) capacitor c=3.98458e-19 //x=66.51 //y=3.895
c652 ( 73 0 ) capacitor c=0.0212158f //x=78.425 //y=3.895
c653 ( 72 0 ) capacitor c=0.0852939f //x=78.77 //y=3.895
c654 ( 70 0 ) capacitor c=0.0533522f //x=76.54 //y=3.88
c655 ( 61 0 ) capacitor c=0.0149589f //x=85.59 //y=3.88
c656 ( 57 0 ) capacitor c=0.0158949f //x=76.71 //y=3.88
c657 ( 51 0 ) capacitor c=0.00111241f //x=75.93 //y=5.335
c658 ( 48 0 ) capacitor c=0.00737416f //x=75.05 //y=5.335
c659 ( 45 0 ) capacitor c=0.0120114f //x=74.172 //y=5.335
c660 ( 38 0 ) capacitor c=0.0149589f //x=71.16 //y=3.88
c661 ( 34 0 ) capacitor c=0.0149589f //x=66.35 //y=3.88
c662 ( 28 0 ) capacitor c=0.0197432f //x=85.59 //y=4.75
c663 ( 27 0 ) capacitor c=0.0115086f //x=85.59 //y=4.045
c664 ( 26 0 ) capacitor c=0.032949f //x=85.59 //y=3.725
c665 ( 25 0 ) capacitor c=0.00556102f //x=85.59 //y=2.375
c666 ( 24 0 ) capacitor c=0.0303433f //x=76.71 //y=5.25
c667 ( 23 0 ) capacitor c=0.0138897f //x=76.71 //y=4.055
c668 ( 22 0 ) capacitor c=0.0490588f //x=76.71 //y=3.735
c669 ( 20 0 ) capacitor c=0.00493487f //x=76.31 //y=1.845
c670 ( 19 0 ) capacitor c=0.0133342f //x=76.625 //y=1.845
c671 ( 18 0 ) capacitor c=0.0167992f //x=76.225 //y=1.76
c672 ( 17 0 ) capacitor c=0.0111491f //x=76.225 //y=1.305
c673 ( 15 0 ) capacitor c=0.0238276f //x=76.625 //y=5.335
c674 ( 14 0 ) capacitor c=0.00933983f //x=75.93 //y=5.56
c675 ( 11 0 ) capacitor c=0.016418f //x=75.815 //y=5.335
c676 ( 9 0 ) capacitor c=0.0150157f //x=74.93 //y=5.335
c677 ( 8 0 ) capacitor c=0.0180102f //x=71.16 //y=4.75
c678 ( 7 0 ) capacitor c=0.011494f //x=71.16 //y=4.055
c679 ( 6 0 ) capacitor c=0.029293f //x=71.16 //y=3.735
c680 ( 5 0 ) capacitor c=0.00556102f //x=71.16 //y=2.375
c681 ( 4 0 ) capacitor c=0.0173396f //x=66.35 //y=4.75
c682 ( 3 0 ) capacitor c=0.0132847f //x=66.35 //y=4.055
c683 ( 2 0 ) capacitor c=0.0302473f //x=66.35 //y=3.735
c684 ( 1 0 ) capacitor c=0.00556102f //x=66.35 //y=2.375
r685 (  242 243 ) resistor r=52.7279 //w=0.214 //l=0.165 //layer=ply \
 //thickness=0.18 //x=85.59 //y=2.26 //x2=85.59 //y2=2.095
r686 (  232 233 ) resistor r=52.7279 //w=0.214 //l=0.165 //layer=ply \
 //thickness=0.18 //x=71.16 //y=2.26 //x2=71.16 //y2=2.095
r687 (  222 223 ) resistor r=52.7279 //w=0.214 //l=0.165 //layer=ply \
 //thickness=0.18 //x=66.35 //y=2.26 //x2=66.35 //y2=2.095
r688 (  220 250 ) resistor r=45.1352 //w=0.168 //l=0.173853 //layer=ply \
 //thickness=0.18 //x=86.11 //y=1.44 //x2=86.07 //y2=1.595
r689 (  219 249 ) resistor r=45.1352 //w=0.168 //l=0.173853 //layer=ply \
 //thickness=0.18 //x=86.11 //y=1.095 //x2=86.07 //y2=0.94
r690 (  219 220 ) resistor r=176.904 //w=0.094 //l=0.345 //layer=ply \
 //thickness=0.18 //x=86.11 //y=1.095 //x2=86.11 //y2=1.44
r691 (  217 246 ) resistor r=10.701 //w=0.21 //l=0.115 //layer=ply \
 //thickness=0.18 //x=85.735 //y=1.595 //x2=85.62 //y2=1.595
r692 (  216 250 ) resistor r=5.52526 //w=0.168 //l=0.115 //layer=ply \
 //thickness=0.18 //x=85.955 //y=1.595 //x2=86.07 //y2=1.595
r693 (  215 245 ) resistor r=5.52526 //w=0.168 //l=0.115 //layer=ply \
 //thickness=0.18 //x=85.735 //y=0.94 //x2=85.62 //y2=0.94
r694 (  214 249 ) resistor r=5.52526 //w=0.168 //l=0.115 //layer=ply \
 //thickness=0.18 //x=85.955 //y=0.94 //x2=86.07 //y2=0.94
r695 (  214 215 ) resistor r=112.809 //w=0.094 //l=0.22 //layer=ply \
 //thickness=0.18 //x=85.955 //y=0.94 //x2=85.735 //y2=0.94
r696 (  211 248 ) resistor r=37.236 //w=0.233 //l=0.249199 //layer=ply \
 //thickness=0.18 //x=85.77 //y=5.045 //x2=85.59 //y2=4.88
r697 (  209 246 ) resistor r=39.5823 //w=0.21 //l=0.173853 //layer=ply \
 //thickness=0.18 //x=85.58 //y=1.75 //x2=85.62 //y2=1.595
r698 (  209 243 ) resistor r=176.904 //w=0.094 //l=0.345 //layer=ply \
 //thickness=0.18 //x=85.58 //y=1.75 //x2=85.58 //y2=2.095
r699 (  208 246 ) resistor r=39.5823 //w=0.21 //l=0.173853 //layer=ply \
 //thickness=0.18 //x=85.58 //y=1.44 //x2=85.62 //y2=1.595
r700 (  207 245 ) resistor r=45.1352 //w=0.168 //l=0.173853 //layer=ply \
 //thickness=0.18 //x=85.58 //y=1.095 //x2=85.62 //y2=0.94
r701 (  207 208 ) resistor r=176.904 //w=0.094 //l=0.345 //layer=ply \
 //thickness=0.18 //x=85.58 //y=1.095 //x2=85.58 //y2=1.44
r702 (  204 248 ) resistor r=53.7854 //w=0.233 //l=0.332415 //layer=ply \
 //thickness=0.18 //x=85.33 //y=5.045 //x2=85.59 //y2=4.88
r703 (  203 240 ) resistor r=45.1352 //w=0.168 //l=0.173853 //layer=ply \
 //thickness=0.18 //x=71.68 //y=1.44 //x2=71.64 //y2=1.595
r704 (  202 239 ) resistor r=45.1352 //w=0.168 //l=0.173853 //layer=ply \
 //thickness=0.18 //x=71.68 //y=1.095 //x2=71.64 //y2=0.94
r705 (  202 203 ) resistor r=176.904 //w=0.094 //l=0.345 //layer=ply \
 //thickness=0.18 //x=71.68 //y=1.095 //x2=71.68 //y2=1.44
r706 (  200 236 ) resistor r=10.701 //w=0.21 //l=0.115 //layer=ply \
 //thickness=0.18 //x=71.305 //y=1.595 //x2=71.19 //y2=1.595
r707 (  199 240 ) resistor r=5.52526 //w=0.168 //l=0.115 //layer=ply \
 //thickness=0.18 //x=71.525 //y=1.595 //x2=71.64 //y2=1.595
r708 (  198 235 ) resistor r=5.52526 //w=0.168 //l=0.115 //layer=ply \
 //thickness=0.18 //x=71.305 //y=0.94 //x2=71.19 //y2=0.94
r709 (  197 239 ) resistor r=5.52526 //w=0.168 //l=0.115 //layer=ply \
 //thickness=0.18 //x=71.525 //y=0.94 //x2=71.64 //y2=0.94
r710 (  197 198 ) resistor r=112.809 //w=0.094 //l=0.22 //layer=ply \
 //thickness=0.18 //x=71.525 //y=0.94 //x2=71.305 //y2=0.94
r711 (  194 238 ) resistor r=37.236 //w=0.233 //l=0.249199 //layer=ply \
 //thickness=0.18 //x=71.34 //y=5.045 //x2=71.16 //y2=4.88
r712 (  192 236 ) resistor r=39.5823 //w=0.21 //l=0.173853 //layer=ply \
 //thickness=0.18 //x=71.15 //y=1.75 //x2=71.19 //y2=1.595
r713 (  192 233 ) resistor r=176.904 //w=0.094 //l=0.345 //layer=ply \
 //thickness=0.18 //x=71.15 //y=1.75 //x2=71.15 //y2=2.095
r714 (  191 236 ) resistor r=39.5823 //w=0.21 //l=0.173853 //layer=ply \
 //thickness=0.18 //x=71.15 //y=1.44 //x2=71.19 //y2=1.595
r715 (  190 235 ) resistor r=45.1352 //w=0.168 //l=0.173853 //layer=ply \
 //thickness=0.18 //x=71.15 //y=1.095 //x2=71.19 //y2=0.94
r716 (  190 191 ) resistor r=176.904 //w=0.094 //l=0.345 //layer=ply \
 //thickness=0.18 //x=71.15 //y=1.095 //x2=71.15 //y2=1.44
r717 (  187 238 ) resistor r=53.7854 //w=0.233 //l=0.332415 //layer=ply \
 //thickness=0.18 //x=70.9 //y=5.045 //x2=71.16 //y2=4.88
r718 (  186 230 ) resistor r=45.1352 //w=0.168 //l=0.173853 //layer=ply \
 //thickness=0.18 //x=66.87 //y=1.44 //x2=66.83 //y2=1.595
r719 (  185 229 ) resistor r=45.1352 //w=0.168 //l=0.173853 //layer=ply \
 //thickness=0.18 //x=66.87 //y=1.095 //x2=66.83 //y2=0.94
r720 (  185 186 ) resistor r=176.904 //w=0.094 //l=0.345 //layer=ply \
 //thickness=0.18 //x=66.87 //y=1.095 //x2=66.87 //y2=1.44
r721 (  183 226 ) resistor r=10.701 //w=0.21 //l=0.115 //layer=ply \
 //thickness=0.18 //x=66.495 //y=1.595 //x2=66.38 //y2=1.595
r722 (  182 230 ) resistor r=5.52526 //w=0.168 //l=0.115 //layer=ply \
 //thickness=0.18 //x=66.715 //y=1.595 //x2=66.83 //y2=1.595
r723 (  181 225 ) resistor r=5.52526 //w=0.168 //l=0.115 //layer=ply \
 //thickness=0.18 //x=66.495 //y=0.94 //x2=66.38 //y2=0.94
r724 (  180 229 ) resistor r=5.52526 //w=0.168 //l=0.115 //layer=ply \
 //thickness=0.18 //x=66.715 //y=0.94 //x2=66.83 //y2=0.94
r725 (  180 181 ) resistor r=112.809 //w=0.094 //l=0.22 //layer=ply \
 //thickness=0.18 //x=66.715 //y=0.94 //x2=66.495 //y2=0.94
r726 (  177 228 ) resistor r=37.236 //w=0.233 //l=0.249199 //layer=ply \
 //thickness=0.18 //x=66.53 //y=5.045 //x2=66.35 //y2=4.88
r727 (  175 226 ) resistor r=39.5823 //w=0.21 //l=0.173853 //layer=ply \
 //thickness=0.18 //x=66.34 //y=1.75 //x2=66.38 //y2=1.595
r728 (  175 223 ) resistor r=176.904 //w=0.094 //l=0.345 //layer=ply \
 //thickness=0.18 //x=66.34 //y=1.75 //x2=66.34 //y2=2.095
r729 (  174 226 ) resistor r=39.5823 //w=0.21 //l=0.173853 //layer=ply \
 //thickness=0.18 //x=66.34 //y=1.44 //x2=66.38 //y2=1.595
r730 (  173 225 ) resistor r=45.1352 //w=0.168 //l=0.173853 //layer=ply \
 //thickness=0.18 //x=66.34 //y=1.095 //x2=66.38 //y2=0.94
r731 (  173 174 ) resistor r=176.904 //w=0.094 //l=0.345 //layer=ply \
 //thickness=0.18 //x=66.34 //y=1.095 //x2=66.34 //y2=1.44
r732 (  170 228 ) resistor r=53.7854 //w=0.233 //l=0.332415 //layer=ply \
 //thickness=0.18 //x=66.09 //y=5.045 //x2=66.35 //y2=4.88
r733 (  169 211 ) resistor r=592.245 //w=0.094 //l=1.155 //layer=ply \
 //thickness=0.18 //x=85.77 //y=6.2 //x2=85.77 //y2=5.045
r734 (  168 204 ) resistor r=592.245 //w=0.094 //l=1.155 //layer=ply \
 //thickness=0.18 //x=85.33 //y=6.2 //x2=85.33 //y2=5.045
r735 (  167 194 ) resistor r=592.245 //w=0.094 //l=1.155 //layer=ply \
 //thickness=0.18 //x=71.34 //y=6.2 //x2=71.34 //y2=5.045
r736 (  166 187 ) resistor r=592.245 //w=0.094 //l=1.155 //layer=ply \
 //thickness=0.18 //x=70.9 //y=6.2 //x2=70.9 //y2=5.045
r737 (  165 177 ) resistor r=592.245 //w=0.094 //l=1.155 //layer=ply \
 //thickness=0.18 //x=66.53 //y=6.2 //x2=66.53 //y2=5.045
r738 (  164 170 ) resistor r=592.245 //w=0.094 //l=1.155 //layer=ply \
 //thickness=0.18 //x=66.09 //y=6.2 //x2=66.09 //y2=5.045
r739 (  163 216 ) resistor r=56.4043 //w=0.094 //l=0.11 //layer=ply \
 //thickness=0.18 //x=85.845 //y=1.595 //x2=85.955 //y2=1.595
r740 (  163 217 ) resistor r=56.4043 //w=0.094 //l=0.11 //layer=ply \
 //thickness=0.18 //x=85.845 //y=1.595 //x2=85.735 //y2=1.595
r741 (  162 199 ) resistor r=56.4043 //w=0.094 //l=0.11 //layer=ply \
 //thickness=0.18 //x=71.415 //y=1.595 //x2=71.525 //y2=1.595
r742 (  162 200 ) resistor r=56.4043 //w=0.094 //l=0.11 //layer=ply \
 //thickness=0.18 //x=71.415 //y=1.595 //x2=71.305 //y2=1.595
r743 (  161 182 ) resistor r=56.4043 //w=0.094 //l=0.11 //layer=ply \
 //thickness=0.18 //x=66.605 //y=1.595 //x2=66.715 //y2=1.595
r744 (  161 183 ) resistor r=56.4043 //w=0.094 //l=0.11 //layer=ply \
 //thickness=0.18 //x=66.605 //y=1.595 //x2=66.495 //y2=1.595
r745 (  157 248 ) resistor r=152 //w=0.17 //l=0.17 //layer=licon //count=1 \
 //x=85.59 //y=4.88 //x2=85.59 //y2=4.88
r746 (  148 242 ) resistor r=152 //w=0.17 //l=0.17 //layer=licon //count=1 \
 //x=85.59 //y=2.26 //x2=85.59 //y2=2.26
r747 (  131 255 ) resistor r=23.615 //w=0.187 //l=0.345 //layer=li \
 //thickness=0.1 //x=75.93 //y=5.56 //x2=75.93 //y2=5.905
r748 (  123 254 ) resistor r=23.615 //w=0.187 //l=0.345 //layer=li \
 //thickness=0.1 //x=75.05 //y=5.56 //x2=75.05 //y2=5.905
r749 (  115 253 ) resistor r=23.615 //w=0.187 //l=0.345 //layer=li \
 //thickness=0.1 //x=74.17 //y=5.56 //x2=74.17 //y2=5.905
r750 (  110 238 ) resistor r=152 //w=0.17 //l=0.17 //layer=licon //count=1 \
 //x=71.16 //y=4.88 //x2=71.16 //y2=4.88
r751 (  101 232 ) resistor r=152 //w=0.17 //l=0.17 //layer=licon //count=1 \
 //x=71.16 //y=2.26 //x2=71.16 //y2=2.26
r752 (  96 228 ) resistor r=152 //w=0.17 //l=0.17 //layer=licon //count=1 \
 //x=66.35 //y=4.88 //x2=66.35 //y2=4.88
r753 (  87 222 ) resistor r=152 //w=0.17 //l=0.17 //layer=licon //count=1 \
 //x=66.35 //y=2.26 //x2=66.35 //y2=2.26
r754 (  79 81 ) resistor r=0.10734 //w=0.281 //l=0.16 //layer=m2 \
 //thickness=0.36 //x=71.16 //y=3.895 //x2=71.32 //y2=3.895
r755 (  79 80 ) resistor r=0.10734 //w=0.281 //l=0.16 //layer=m2 \
 //thickness=0.36 //x=71.16 //y=3.895 //x2=71 //y2=3.895
r756 (  77 80 ) resistor r=4.28435 //w=0.131 //l=4.49 //layer=m2 \
 //thickness=0.36 //x=66.51 //y=3.88 //x2=71 //y2=3.88
r757 (  75 77 ) resistor r=0.10734 //w=0.281 //l=0.16 //layer=m2 \
 //thickness=0.36 //x=66.35 //y=3.895 //x2=66.51 //y2=3.895
r758 (  73 83 ) resistor r=1.10266 //w=0.196 //l=1.725 //layer=m2 \
 //thickness=0.36 //x=78.425 //y=3.895 //x2=76.7 //y2=3.895
r759 (  72 85 ) resistor r=4.81638 //w=0.177 //l=6.825 //layer=m2 \
 //thickness=0.36 //x=78.77 //y=3.895 //x2=85.59 //y2=3.885
r760 (  72 73 ) resistor r=0.329198 //w=0.131 //l=0.345 //layer=m2 \
 //thickness=0.36 //x=78.77 //y=3.895 //x2=78.425 //y2=3.895
r761 (  70 83 ) resistor r=0.104578 //w=0.196 //l=0.167332 //layer=m2 \
 //thickness=0.36 //x=76.54 //y=3.88 //x2=76.7 //y2=3.895
r762 (  70 81 ) resistor r=4.98092 //w=0.131 //l=5.22 //layer=m2 \
 //thickness=0.36 //x=76.54 //y=3.88 //x2=71.32 //y2=3.88
r763 (  67 157 ) resistor r=9.3 //w=0.17 //l=0.17 //layer=mcon //count=1 \
 //x=85.59 //y=4.88 //x2=85.59 //y2=4.88
r764 (  65 148 ) resistor r=9.3 //w=0.17 //l=0.17 //layer=mcon //count=1 \
 //x=85.59 //y=2.26 //x2=85.59 //y2=2.26
r765 (  63 85 ) resistor r=4.5 //w=0.15 //l=0.15 //layer=via1 //count=1 \
 //x=85.59 //y=3.885 //x2=85.59 //y2=3.885
r766 (  61 63 ) resistor r=0.00166223 //w=0.376 //l=0.005 //layer=m1 \
 //thickness=0.36 //x=85.537 //y=3.88 //x2=85.537 //y2=3.885
r767 (  59 83 ) resistor r=4.5 //w=0.15 //l=0.15 //layer=via1 //count=1 \
 //x=76.7 //y=3.895 //x2=76.7 //y2=3.895
r768 (  57 59 ) resistor r=0.00490838 //w=0.382 //l=0.015 //layer=m1 \
 //thickness=0.36 //x=76.757 //y=3.88 //x2=76.757 //y2=3.895
r769 (  55 251 ) resistor r=9.3 //w=0.17 //l=0.17 //layer=mcon //count=1 \
 //x=76.225 //y=1.19 //x2=76.225 //y2=1.19
r770 (  53 131 ) resistor r=9.3 //w=0.17 //l=0.17 //layer=mcon //count=1 \
 //x=75.93 //y=5.56 //x2=75.93 //y2=5.56
r771 (  50 123 ) resistor r=9.3 //w=0.17 //l=0.17 //layer=mcon //count=1 \
 //x=75.05 //y=5.56 //x2=75.05 //y2=5.56
r772 (  48 50 ) resistor r=0.121228 //w=0.232 //l=0.225 //layer=m1 \
 //thickness=0.36 //x=75.05 //y=5.335 //x2=75.05 //y2=5.56
r773 (  47 115 ) resistor r=9.3 //w=0.17 //l=0.17 //layer=mcon //count=1 \
 //x=74.17 //y=5.56 //x2=74.17 //y2=5.56
r774 (  45 47 ) resistor r=0.129608 //w=0.217 //l=0.225 //layer=m1 \
 //thickness=0.36 //x=74.172 //y=5.335 //x2=74.172 //y2=5.56
r775 (  44 110 ) resistor r=9.3 //w=0.17 //l=0.17 //layer=mcon //count=1 \
 //x=71.16 //y=4.88 //x2=71.16 //y2=4.88
r776 (  42 101 ) resistor r=9.3 //w=0.17 //l=0.17 //layer=mcon //count=1 \
 //x=71.16 //y=2.26 //x2=71.16 //y2=2.26
r777 (  40 79 ) resistor r=4.5 //w=0.15 //l=0.15 //layer=via1 //count=1 \
 //x=71.16 //y=3.895 //x2=71.16 //y2=3.895
r778 (  38 40 ) resistor r=0.0049867 //w=0.376 //l=0.015 //layer=m1 \
 //thickness=0.36 //x=71.107 //y=3.88 //x2=71.107 //y2=3.895
r779 (  36 75 ) resistor r=4.5 //w=0.15 //l=0.15 //layer=via1 //count=1 \
 //x=66.35 //y=3.895 //x2=66.35 //y2=3.895
r780 (  34 36 ) resistor r=0.0049867 //w=0.376 //l=0.015 //layer=m1 \
 //thickness=0.36 //x=66.402 //y=3.88 //x2=66.402 //y2=3.895
r781 (  32 96 ) resistor r=9.3 //w=0.17 //l=0.17 //layer=mcon //count=1 \
 //x=66.35 //y=4.88 //x2=66.35 //y2=4.88
r782 (  30 87 ) resistor r=9.3 //w=0.17 //l=0.17 //layer=mcon //count=1 \
 //x=66.35 //y=2.26 //x2=66.35 //y2=2.26
r783 (  28 67 ) resistor r=0.0801089 //w=0.224 //l=0.13 //layer=m1 \
 //thickness=0.36 //x=85.59 //y=4.75 //x2=85.59 //y2=4.88
r784 (  27 63 ) resistor r=0.0911593 //w=0.376 //l=0.184608 //layer=m1 \
 //thickness=0.36 //x=85.59 //y=4.045 //x2=85.537 //y2=3.885
r785 (  27 28 ) resistor r=0.67271 //w=0.131 //l=0.705 //layer=m1 \
 //thickness=0.36 //x=85.59 //y=4.045 //x2=85.59 //y2=4.75
r786 (  26 61 ) resistor r=0.0894971 //w=0.376 //l=0.179555 //layer=m1 \
 //thickness=0.36 //x=85.59 //y=3.725 //x2=85.537 //y2=3.88
r787 (  25 65 ) resistor r=0.0719237 //w=0.222 //l=0.115 //layer=m1 \
 //thickness=0.36 //x=85.59 //y=2.375 //x2=85.59 //y2=2.26
r788 (  25 26 ) resistor r=1.28817 //w=0.131 //l=1.35 //layer=m1 \
 //thickness=0.36 //x=85.59 //y=2.375 //x2=85.59 //y2=3.725
r789 (  23 59 ) resistor r=0.0914072 //w=0.382 //l=0.181989 //layer=m1 \
 //thickness=0.36 //x=76.71 //y=4.055 //x2=76.757 //y2=3.895
r790 (  23 24 ) resistor r=1.14027 //w=0.131 //l=1.195 //layer=m1 \
 //thickness=0.36 //x=76.71 //y=4.055 //x2=76.71 //y2=5.25
r791 (  22 57 ) resistor r=0.0864989 //w=0.382 //l=0.166853 //layer=m1 \
 //thickness=0.36 //x=76.71 //y=3.735 //x2=76.757 //y2=3.88
r792 (  21 22 ) resistor r=1.72233 //w=0.131 //l=1.805 //layer=m1 \
 //thickness=0.36 //x=76.71 //y=1.93 //x2=76.71 //y2=3.735
r793 (  19 21 ) resistor r=0.0698411 //w=0.17 //l=0.120208 //layer=m1 \
 //thickness=0.36 //x=76.625 //y=1.845 //x2=76.71 //y2=1.93
r794 (  19 20 ) resistor r=0.300573 //w=0.131 //l=0.315 //layer=m1 \
 //thickness=0.36 //x=76.625 //y=1.845 //x2=76.31 //y2=1.845
r795 (  18 20 ) resistor r=0.0698411 //w=0.17 //l=0.120208 //layer=m1 \
 //thickness=0.36 //x=76.225 //y=1.76 //x2=76.31 //y2=1.845
r796 (  17 55 ) resistor r=0.0717383 //w=0.224 //l=0.115 //layer=m1 \
 //thickness=0.36 //x=76.225 //y=1.305 //x2=76.225 //y2=1.19
r797 (  17 18 ) resistor r=0.43416 //w=0.131 //l=0.455 //layer=m1 \
 //thickness=0.36 //x=76.225 //y=1.305 //x2=76.225 //y2=1.76
r798 (  16 51 ) resistor r=0.0675342 //w=0.23 //l=0.115 //layer=m1 \
 //thickness=0.36 //x=76.045 //y=5.335 //x2=75.93 //y2=5.335
r799 (  15 24 ) resistor r=0.0698411 //w=0.17 //l=0.120208 //layer=m1 \
 //thickness=0.36 //x=76.625 //y=5.335 //x2=76.71 //y2=5.25
r800 (  15 16 ) resistor r=0.553435 //w=0.131 //l=0.58 //layer=m1 \
 //thickness=0.36 //x=76.625 //y=5.335 //x2=76.045 //y2=5.335
r801 (  14 53 ) resistor r=0.00118313 //w=0.23 //layer=m1 //thickness=0.36 \
 //x=75.93 //y=5.56 //x2=75.93 //y2=5.56
r802 (  13 51 ) resistor r=0.002872 //w=0.34 //l=0.085 //layer=m1 \
 //thickness=0.36 //x=75.93 //y=5.42 //x2=75.93 //y2=5.335
r803 (  13 14 ) resistor r=0.091623 //w=0.191 //l=0.14 //layer=m1 \
 //thickness=0.36 //x=75.93 //y=5.42 //x2=75.93 //y2=5.56
r804 (  12 48 ) resistor r=0.0262263 //w=0.232 //l=0.12 //layer=m1 \
 //thickness=0.36 //x=75.17 //y=5.335 //x2=75.05 //y2=5.335
r805 (  11 51 ) resistor r=0.0675342 //w=0.23 //l=0.115 //layer=m1 \
 //thickness=0.36 //x=75.815 //y=5.335 //x2=75.93 //y2=5.335
r806 (  11 12 ) resistor r=0.615458 //w=0.131 //l=0.645 //layer=m1 \
 //thickness=0.36 //x=75.815 //y=5.335 //x2=75.17 //y2=5.335
r807 (  10 45 ) resistor r=0.0222262 //w=0.217 //l=0.118 //layer=m1 \
 //thickness=0.36 //x=74.29 //y=5.335 //x2=74.172 //y2=5.335
r808 (  9 48 ) resistor r=0.0262263 //w=0.232 //l=0.12 //layer=m1 \
 //thickness=0.36 //x=74.93 //y=5.335 //x2=75.05 //y2=5.335
r809 (  9 10 ) resistor r=0.610687 //w=0.131 //l=0.64 //layer=m1 \
 //thickness=0.36 //x=74.93 //y=5.335 //x2=74.29 //y2=5.335
r810 (  8 44 ) resistor r=0.0801089 //w=0.224 //l=0.13 //layer=m1 \
 //thickness=0.36 //x=71.16 //y=4.75 //x2=71.16 //y2=4.88
r811 (  7 40 ) resistor r=0.0911593 //w=0.376 //l=0.184608 //layer=m1 \
 //thickness=0.36 //x=71.16 //y=4.055 //x2=71.107 //y2=3.895
r812 (  7 8 ) resistor r=0.663168 //w=0.131 //l=0.695 //layer=m1 \
 //thickness=0.36 //x=71.16 //y=4.055 //x2=71.16 //y2=4.75
r813 (  6 38 ) resistor r=0.0861726 //w=0.376 //l=0.16944 //layer=m1 \
 //thickness=0.36 //x=71.16 //y=3.735 //x2=71.107 //y2=3.88
r814 (  5 42 ) resistor r=0.0719237 //w=0.222 //l=0.115 //layer=m1 \
 //thickness=0.36 //x=71.16 //y=2.375 //x2=71.16 //y2=2.26
r815 (  5 6 ) resistor r=1.29771 //w=0.131 //l=1.36 //layer=m1 \
 //thickness=0.36 //x=71.16 //y=2.375 //x2=71.16 //y2=3.735
r816 (  4 32 ) resistor r=0.0801089 //w=0.224 //l=0.13 //layer=m1 \
 //thickness=0.36 //x=66.35 //y=4.75 //x2=66.35 //y2=4.88
r817 (  3 36 ) resistor r=0.0911593 //w=0.376 //l=0.184174 //layer=m1 \
 //thickness=0.36 //x=66.35 //y=4.055 //x2=66.402 //y2=3.895
r818 (  3 4 ) resistor r=0.663168 //w=0.131 //l=0.695 //layer=m1 \
 //thickness=0.36 //x=66.35 //y=4.055 //x2=66.35 //y2=4.75
r819 (  2 34 ) resistor r=0.0861726 //w=0.376 //l=0.169012 //layer=m1 \
 //thickness=0.36 //x=66.35 //y=3.735 //x2=66.402 //y2=3.88
r820 (  1 30 ) resistor r=0.0719237 //w=0.222 //l=0.115 //layer=m1 \
 //thickness=0.36 //x=66.35 //y=2.375 //x2=66.35 //y2=2.26
r821 (  1 2 ) resistor r=1.29771 //w=0.131 //l=1.36 //layer=m1 \
 //thickness=0.36 //x=66.35 //y=2.375 //x2=66.35 //y2=3.735
ends PM_TMRDFFSNRNQNX1\%noxref_19

subckt PM_TMRDFFSNRNQNX1\%noxref_20 ( 1 2 3 4 5 7 10 11 13 14 15 16 18 19 20 \
 28 29 32 35 41 44 46 51 55 64 69 77 85 101 102 103 107 108 109 114 116 119 \
 120 122 123 128 131 133 134 135 )
c317 ( 131 0 ) capacitor c=0.00885916f //x=85.655 //y=1.095
c318 ( 128 0 ) capacitor c=0.0710579f //x=80.78 //y=4.88
c319 ( 123 0 ) capacitor c=0.0278202f //x=80.78 //y=2.095
c320 ( 122 0 ) capacitor c=0.0451939f //x=80.78 //y=2.26
c321 ( 120 0 ) capacitor c=0.0443175f //x=81.3 //y=1.44
c322 ( 119 0 ) capacitor c=0.0199703f //x=81.3 //y=1.095
c323 ( 116 0 ) capacitor c=0.0160573f //x=81.145 //y=1.595
c324 ( 114 0 ) capacitor c=0.0157807f //x=81.145 //y=0.94
c325 ( 109 0 ) capacitor c=0.0220935f //x=80.77 //y=1.75
c326 ( 108 0 ) capacitor c=0.0207489f //x=80.77 //y=1.44
c327 ( 107 0 ) capacitor c=0.0194091f //x=80.77 //y=1.095
c328 ( 103 0 ) capacitor c=0.159671f //x=80.96 //y=6.2
c329 ( 102 0 ) capacitor c=0.110208f //x=80.52 //y=6.2
c330 ( 85 0 ) capacitor c=0.0292914f //x=85.55 //y=5.56
c331 ( 77 0 ) capacitor c=0.0292489f //x=84.67 //y=5.56
c332 ( 69 0 ) capacitor c=0.0278099f //x=83.79 //y=5.56
c333 ( 64 0 ) capacitor c=7.7417e-19 //x=80.78 //y=4.88
c334 ( 55 0 ) capacitor c=7.43216e-19 //x=80.78 //y=2.26
c335 ( 51 0 ) capacitor c=0.00388754f //x=80.93 //y=2.755
c336 ( 46 0 ) capacitor c=0.0215005f //x=84.695 //y=2.76
c337 ( 44 0 ) capacitor c=0.0345684f //x=84.095 //y=2.77
c338 ( 41 0 ) capacitor c=0.0143395f //x=86.33 //y=2.77
c339 ( 35 0 ) capacitor c=8.84507e-19 //x=85.55 //y=5.335
c340 ( 32 0 ) capacitor c=0.00788343f //x=84.67 //y=5.335
c341 ( 29 0 ) capacitor c=0.0111234f //x=83.792 //y=5.335
c342 ( 28 0 ) capacitor c=0.0151653f //x=80.78 //y=2.77
c343 ( 20 0 ) capacitor c=0.0662191f //x=86.33 //y=5.25
c344 ( 19 0 ) capacitor c=0.0124572f //x=86.33 //y=2.945
c345 ( 18 0 ) capacitor c=0.0181143f //x=86.33 //y=2.625
c346 ( 16 0 ) capacitor c=0.00493487f //x=85.93 //y=1.845
c347 ( 15 0 ) capacitor c=0.0134751f //x=86.245 //y=1.845
c348 ( 14 0 ) capacitor c=0.0150416f //x=85.845 //y=1.76
c349 ( 13 0 ) capacitor c=0.0113205f //x=85.845 //y=1.305
c350 ( 11 0 ) capacitor c=0.0237318f //x=86.245 //y=5.335
c351 ( 10 0 ) capacitor c=0.00906283f //x=85.55 //y=5.56
c352 ( 7 0 ) capacitor c=0.0180822f //x=85.435 //y=5.335
c353 ( 5 0 ) capacitor c=0.0146396f //x=84.55 //y=5.335
c354 ( 4 0 ) capacitor c=0.0514093f //x=80.78 //y=4.75
c355 ( 3 0 ) capacitor c=0.0125996f //x=80.78 //y=2.915
c356 ( 2 0 ) capacitor c=0.00290193f //x=80.78 //y=2.595
c357 ( 1 0 ) capacitor c=0.00657405f //x=80.78 //y=2.375
r358 (  122 123 ) resistor r=52.7279 //w=0.214 //l=0.165 //layer=ply \
 //thickness=0.18 //x=80.78 //y=2.26 //x2=80.78 //y2=2.095
r359 (  120 130 ) resistor r=45.1352 //w=0.168 //l=0.173853 //layer=ply \
 //thickness=0.18 //x=81.3 //y=1.44 //x2=81.26 //y2=1.595
r360 (  119 129 ) resistor r=45.1352 //w=0.168 //l=0.173853 //layer=ply \
 //thickness=0.18 //x=81.3 //y=1.095 //x2=81.26 //y2=0.94
r361 (  119 120 ) resistor r=176.904 //w=0.094 //l=0.345 //layer=ply \
 //thickness=0.18 //x=81.3 //y=1.095 //x2=81.3 //y2=1.44
r362 (  117 126 ) resistor r=10.701 //w=0.21 //l=0.115 //layer=ply \
 //thickness=0.18 //x=80.925 //y=1.595 //x2=80.81 //y2=1.595
r363 (  116 130 ) resistor r=5.52526 //w=0.168 //l=0.115 //layer=ply \
 //thickness=0.18 //x=81.145 //y=1.595 //x2=81.26 //y2=1.595
r364 (  115 125 ) resistor r=5.52526 //w=0.168 //l=0.115 //layer=ply \
 //thickness=0.18 //x=80.925 //y=0.94 //x2=80.81 //y2=0.94
r365 (  114 129 ) resistor r=5.52526 //w=0.168 //l=0.115 //layer=ply \
 //thickness=0.18 //x=81.145 //y=0.94 //x2=81.26 //y2=0.94
r366 (  114 115 ) resistor r=112.809 //w=0.094 //l=0.22 //layer=ply \
 //thickness=0.18 //x=81.145 //y=0.94 //x2=80.925 //y2=0.94
r367 (  111 128 ) resistor r=37.236 //w=0.233 //l=0.249199 //layer=ply \
 //thickness=0.18 //x=80.96 //y=5.045 //x2=80.78 //y2=4.88
r368 (  109 126 ) resistor r=39.5823 //w=0.21 //l=0.173853 //layer=ply \
 //thickness=0.18 //x=80.77 //y=1.75 //x2=80.81 //y2=1.595
r369 (  109 123 ) resistor r=176.904 //w=0.094 //l=0.345 //layer=ply \
 //thickness=0.18 //x=80.77 //y=1.75 //x2=80.77 //y2=2.095
r370 (  108 126 ) resistor r=39.5823 //w=0.21 //l=0.173853 //layer=ply \
 //thickness=0.18 //x=80.77 //y=1.44 //x2=80.81 //y2=1.595
r371 (  107 125 ) resistor r=45.1352 //w=0.168 //l=0.173853 //layer=ply \
 //thickness=0.18 //x=80.77 //y=1.095 //x2=80.81 //y2=0.94
r372 (  107 108 ) resistor r=176.904 //w=0.094 //l=0.345 //layer=ply \
 //thickness=0.18 //x=80.77 //y=1.095 //x2=80.77 //y2=1.44
r373 (  104 128 ) resistor r=53.7854 //w=0.233 //l=0.332415 //layer=ply \
 //thickness=0.18 //x=80.52 //y=5.045 //x2=80.78 //y2=4.88
r374 (  103 111 ) resistor r=592.245 //w=0.094 //l=1.155 //layer=ply \
 //thickness=0.18 //x=80.96 //y=6.2 //x2=80.96 //y2=5.045
r375 (  102 104 ) resistor r=592.245 //w=0.094 //l=1.155 //layer=ply \
 //thickness=0.18 //x=80.52 //y=6.2 //x2=80.52 //y2=5.045
r376 (  101 116 ) resistor r=56.4043 //w=0.094 //l=0.11 //layer=ply \
 //thickness=0.18 //x=81.035 //y=1.595 //x2=81.145 //y2=1.595
r377 (  101 117 ) resistor r=56.4043 //w=0.094 //l=0.11 //layer=ply \
 //thickness=0.18 //x=81.035 //y=1.595 //x2=80.925 //y2=1.595
r378 (  85 135 ) resistor r=23.615 //w=0.187 //l=0.345 //layer=li \
 //thickness=0.1 //x=85.55 //y=5.56 //x2=85.55 //y2=5.905
r379 (  77 134 ) resistor r=23.615 //w=0.187 //l=0.345 //layer=li \
 //thickness=0.1 //x=84.67 //y=5.56 //x2=84.67 //y2=5.905
r380 (  69 133 ) resistor r=23.615 //w=0.187 //l=0.345 //layer=li \
 //thickness=0.1 //x=83.79 //y=5.56 //x2=83.79 //y2=5.905
r381 (  64 128 ) resistor r=152 //w=0.17 //l=0.17 //layer=licon //count=1 \
 //x=80.78 //y=4.88 //x2=80.78 //y2=4.88
r382 (  55 122 ) resistor r=152 //w=0.17 //l=0.17 //layer=licon //count=1 \
 //x=80.78 //y=2.26 //x2=80.78 //y2=2.26
r383 (  49 51 ) resistor r=0.10734 //w=0.281 //l=0.16 //layer=m2 \
 //thickness=0.36 //x=80.77 //y=2.755 //x2=80.93 //y2=2.755
r384 (  46 53 ) resistor r=1.03378 //w=0.197 //l=1.63745 //layer=m2 \
 //thickness=0.36 //x=84.695 //y=2.76 //x2=86.32 //y2=2.785
r385 (  46 47 ) resistor r=0.410305 //w=0.131 //l=0.43 //layer=m2 \
 //thickness=0.36 //x=84.695 //y=2.76 //x2=84.265 //y2=2.76
r386 (  44 47 ) resistor r=0.125 //w=0.17 //l=0.174929 //layer=m2 \
 //thickness=0.36 //x=84.095 //y=2.77 //x2=84.265 //y2=2.76
r387 (  44 51 ) resistor r=3.02004 //w=0.131 //l=3.165 //layer=m2 \
 //thickness=0.36 //x=84.095 //y=2.77 //x2=80.93 //y2=2.77
r388 (  43 53 ) resistor r=4.5 //w=0.15 //l=0.15 //layer=via1 //count=1 \
 //x=86.32 //y=2.785 //x2=86.32 //y2=2.785
r389 (  41 43 ) resistor r=0.00505391 //w=0.371 //l=0.015 //layer=m1 \
 //thickness=0.36 //x=86.272 //y=2.77 //x2=86.272 //y2=2.785
r390 (  39 131 ) resistor r=9.3 //w=0.17 //l=0.17 //layer=mcon //count=1 \
 //x=85.845 //y=1.19 //x2=85.845 //y2=1.19
r391 (  37 85 ) resistor r=9.3 //w=0.17 //l=0.17 //layer=mcon //count=1 \
 //x=85.55 //y=5.56 //x2=85.55 //y2=5.56
r392 (  34 77 ) resistor r=9.3 //w=0.17 //l=0.17 //layer=mcon //count=1 \
 //x=84.67 //y=5.56 //x2=84.67 //y2=5.56
r393 (  32 34 ) resistor r=0.121228 //w=0.232 //l=0.225 //layer=m1 \
 //thickness=0.36 //x=84.67 //y=5.335 //x2=84.67 //y2=5.56
r394 (  31 69 ) resistor r=9.3 //w=0.17 //l=0.17 //layer=mcon //count=1 \
 //x=83.79 //y=5.56 //x2=83.79 //y2=5.56
r395 (  29 31 ) resistor r=0.129608 //w=0.217 //l=0.225 //layer=m1 \
 //thickness=0.36 //x=83.792 //y=5.335 //x2=83.792 //y2=5.56
r396 (  26 49 ) resistor r=4.5 //w=0.15 //l=0.15 //layer=via1 //count=1 \
 //x=80.77 //y=2.755 //x2=80.77 //y2=2.755
r397 (  26 28 ) resistor r=0.00490838 //w=0.382 //l=0.015 //layer=m1 \
 //thickness=0.36 //x=80.827 //y=2.755 //x2=80.827 //y2=2.77
r398 (  24 64 ) resistor r=9.3 //w=0.17 //l=0.17 //layer=mcon //count=1 \
 //x=80.78 //y=4.88 //x2=80.78 //y2=4.88
r399 (  22 55 ) resistor r=9.3 //w=0.17 //l=0.17 //layer=mcon //count=1 \
 //x=80.78 //y=2.26 //x2=80.78 //y2=2.26
r400 (  19 43 ) resistor r=0.0909648 //w=0.371 //l=0.186762 //layer=m1 \
 //thickness=0.36 //x=86.33 //y=2.945 //x2=86.272 //y2=2.785
r401 (  19 20 ) resistor r=2.19943 //w=0.131 //l=2.305 //layer=m1 \
 //thickness=0.36 //x=86.33 //y=2.945 //x2=86.33 //y2=5.25
r402 (  18 41 ) resistor r=0.0859108 //w=0.371 //l=0.171566 //layer=m1 \
 //thickness=0.36 //x=86.33 //y=2.625 //x2=86.272 //y2=2.77
r403 (  17 18 ) resistor r=0.663168 //w=0.131 //l=0.695 //layer=m1 \
 //thickness=0.36 //x=86.33 //y=1.93 //x2=86.33 //y2=2.625
r404 (  15 17 ) resistor r=0.0698411 //w=0.17 //l=0.120208 //layer=m1 \
 //thickness=0.36 //x=86.245 //y=1.845 //x2=86.33 //y2=1.93
r405 (  15 16 ) resistor r=0.300573 //w=0.131 //l=0.315 //layer=m1 \
 //thickness=0.36 //x=86.245 //y=1.845 //x2=85.93 //y2=1.845
r406 (  14 16 ) resistor r=0.0698411 //w=0.17 //l=0.120208 //layer=m1 \
 //thickness=0.36 //x=85.845 //y=1.76 //x2=85.93 //y2=1.845
r407 (  13 39 ) resistor r=0.0717383 //w=0.224 //l=0.115 //layer=m1 \
 //thickness=0.36 //x=85.845 //y=1.305 //x2=85.845 //y2=1.19
r408 (  13 14 ) resistor r=0.43416 //w=0.131 //l=0.455 //layer=m1 \
 //thickness=0.36 //x=85.845 //y=1.305 //x2=85.845 //y2=1.76
r409 (  12 35 ) resistor r=0.0675342 //w=0.23 //l=0.115 //layer=m1 \
 //thickness=0.36 //x=85.665 //y=5.335 //x2=85.55 //y2=5.335
r410 (  11 20 ) resistor r=0.0698411 //w=0.17 //l=0.120208 //layer=m1 \
 //thickness=0.36 //x=86.245 //y=5.335 //x2=86.33 //y2=5.25
r411 (  11 12 ) resistor r=0.553435 //w=0.131 //l=0.58 //layer=m1 \
 //thickness=0.36 //x=86.245 //y=5.335 //x2=85.665 //y2=5.335
r412 (  10 37 ) resistor r=0.00118313 //w=0.23 //layer=m1 //thickness=0.36 \
 //x=85.55 //y=5.56 //x2=85.55 //y2=5.56
r413 (  9 35 ) resistor r=0.002872 //w=0.34 //l=0.085 //layer=m1 \
 //thickness=0.36 //x=85.55 //y=5.42 //x2=85.55 //y2=5.335
r414 (  9 10 ) resistor r=0.091623 //w=0.191 //l=0.14 //layer=m1 \
 //thickness=0.36 //x=85.55 //y=5.42 //x2=85.55 //y2=5.56
r415 (  8 32 ) resistor r=0.0262263 //w=0.232 //l=0.12 //layer=m1 \
 //thickness=0.36 //x=84.79 //y=5.335 //x2=84.67 //y2=5.335
r416 (  7 35 ) resistor r=0.0675342 //w=0.23 //l=0.115 //layer=m1 \
 //thickness=0.36 //x=85.435 //y=5.335 //x2=85.55 //y2=5.335
r417 (  7 8 ) resistor r=0.615458 //w=0.131 //l=0.645 //layer=m1 \
 //thickness=0.36 //x=85.435 //y=5.335 //x2=84.79 //y2=5.335
r418 (  6 29 ) resistor r=0.0222262 //w=0.217 //l=0.118 //layer=m1 \
 //thickness=0.36 //x=83.91 //y=5.335 //x2=83.792 //y2=5.335
r419 (  5 32 ) resistor r=0.0262263 //w=0.232 //l=0.12 //layer=m1 \
 //thickness=0.36 //x=84.55 //y=5.335 //x2=84.67 //y2=5.335
r420 (  5 6 ) resistor r=0.610687 //w=0.131 //l=0.64 //layer=m1 \
 //thickness=0.36 //x=84.55 //y=5.335 //x2=83.91 //y2=5.335
r421 (  4 24 ) resistor r=0.0801089 //w=0.224 //l=0.13 //layer=m1 \
 //thickness=0.36 //x=80.78 //y=4.75 //x2=80.78 //y2=4.88
r422 (  3 28 ) resistor r=0.0864989 //w=0.382 //l=0.166853 //layer=m1 \
 //thickness=0.36 //x=80.78 //y=2.915 //x2=80.827 //y2=2.77
r423 (  3 4 ) resistor r=1.75095 //w=0.131 //l=1.835 //layer=m1 \
 //thickness=0.36 //x=80.78 //y=2.915 //x2=80.78 //y2=4.75
r424 (  2 26 ) resistor r=0.0914072 //w=0.382 //l=0.181989 //layer=m1 \
 //thickness=0.36 //x=80.78 //y=2.595 //x2=80.827 //y2=2.755
r425 (  1 22 ) resistor r=0.0719237 //w=0.222 //l=0.115 //layer=m1 \
 //thickness=0.36 //x=80.78 //y=2.375 //x2=80.78 //y2=2.26
r426 (  1 2 ) resistor r=0.209924 //w=0.131 //l=0.22 //layer=m1 \
 //thickness=0.36 //x=80.78 //y=2.375 //x2=80.78 //y2=2.595
ends PM_TMRDFFSNRNQNX1\%noxref_20

subckt PM_TMRDFFSNRNQNX1\%noxref_21 ( 1 3 6 7 9 10 11 12 14 15 16 17 18 19 20 \
 21 22 23 26 29 37 58 61 65 68 69 73 74 77 85 93 110 115 120 125 130 135 139 \
 140 141 142 143 144 145 146 147 148 149 150 151 152 154 160 161 162 163 170 \
 171 172 173 174 176 179 182 183 184 185 186 187 188 189 193 195 198 199 200 \
 201 222 229 231 232 233 )
c567 ( 229 0 ) capacitor c=0.00885916f //x=80.845 //y=1.095
c568 ( 222 0 ) capacitor c=0.0586737f //x=94.47 //y=2.26
c569 ( 201 0 ) capacitor c=0.0318956f //x=95.175 //y=1.39
c570 ( 200 0 ) capacitor c=0.0186809f //x=95.175 //y=1.045
c571 ( 199 0 ) capacitor c=0.0659968f //x=94.815 //y=4.975
c572 ( 198 0 ) capacitor c=0.0373387f //x=95.105 //y=4.975
c573 ( 195 0 ) capacitor c=0.0157936f //x=95.02 //y=1.545
c574 ( 193 0 ) capacitor c=0.0158553f //x=95.02 //y=0.89
c575 ( 189 0 ) capacitor c=0.0302441f //x=94.645 //y=2.095
c576 ( 188 0 ) capacitor c=0.0238107f //x=94.645 //y=1.7
c577 ( 187 0 ) capacitor c=0.0234359f //x=94.645 //y=1.39
c578 ( 186 0 ) capacitor c=0.0199332f //x=94.645 //y=1.045
c579 ( 185 0 ) capacitor c=0.0972519f //x=92.815 //y=2.095
c580 ( 184 0 ) capacitor c=0.0251353f //x=92.815 //y=1.74
c581 ( 183 0 ) capacitor c=0.0234318f //x=92.815 //y=1.43
c582 ( 182 0 ) capacitor c=0.0192547f //x=92.815 //y=1.085
c583 ( 179 0 ) capacitor c=0.0714656f //x=92.72 //y=5.05
c584 ( 176 0 ) capacitor c=0.0186579f //x=92.66 //y=1.585
c585 ( 174 0 ) capacitor c=0.0157803f //x=92.66 //y=0.93
c586 ( 173 0 ) capacitor c=0.0134011f //x=92.355 //y=4.975
c587 ( 172 0 ) capacitor c=0.0243282f //x=92.645 //y=4.975
c588 ( 171 0 ) capacitor c=0.0364928f //x=92.285 //y=1.43
c589 ( 170 0 ) capacitor c=0.0174823f //x=92.285 //y=1.085
c590 ( 163 0 ) capacitor c=0.0612936f //x=83.645 //y=4.97
c591 ( 162 0 ) capacitor c=0.0376642f //x=83.935 //y=4.97
c592 ( 161 0 ) capacitor c=0.0346489f //x=83.6 //y=1.4
c593 ( 160 0 ) capacitor c=0.018692f //x=83.6 //y=1.055
c594 ( 154 0 ) capacitor c=0.0137077f //x=83.445 //y=1.555
c595 ( 152 0 ) capacitor c=0.0158585f //x=83.445 //y=0.9
c596 ( 151 0 ) capacitor c=0.101556f //x=83.07 //y=2.095
c597 ( 150 0 ) capacitor c=0.0229444f //x=83.07 //y=1.71
c598 ( 149 0 ) capacitor c=0.0234359f //x=83.07 //y=1.4
c599 ( 148 0 ) capacitor c=0.019815f //x=83.07 //y=1.055
c600 ( 147 0 ) capacitor c=0.11081f //x=95.18 //y=6.205
c601 ( 146 0 ) capacitor c=0.154997f //x=94.74 //y=6.205
c602 ( 145 0 ) capacitor c=0.155934f //x=92.72 //y=6.205
c603 ( 144 0 ) capacitor c=0.110594f //x=92.28 //y=6.205
c604 ( 143 0 ) capacitor c=0.110208f //x=84.01 //y=6.2
c605 ( 142 0 ) capacitor c=0.158957f //x=83.57 //y=6.2
c606 ( 135 0 ) capacitor c=7.7962e-19 //x=94.47 //y=4.885
c607 ( 130 0 ) capacitor c=7.89145e-19 //x=94.47 //y=2.26
c608 ( 125 0 ) capacitor c=7.79163e-19 //x=92.99 //y=4.885
c609 ( 120 0 ) capacitor c=7.43216e-19 //x=92.99 //y=2.26
c610 ( 115 0 ) capacitor c=0.0014751f //x=83.37 //y=4.88
c611 ( 110 0 ) capacitor c=0.0012618f //x=83.37 //y=2.26
c612 ( 93 0 ) capacitor c=0.0293393f //x=80.74 //y=5.56
c613 ( 85 0 ) capacitor c=0.029137f //x=79.86 //y=5.56
c614 ( 77 0 ) capacitor c=0.0278099f //x=78.98 //y=5.56
c615 ( 74 0 ) capacitor c=0.0208859f //x=94.305 //y=2.27
c616 ( 73 0 ) capacitor c=0.00241177f //x=94.465 //y=2.27
c617 ( 69 0 ) capacitor c=0.00482391f //x=83.525 //y=2.385
c618 ( 68 0 ) capacitor c=0.0341094f //x=83.205 //y=2.385
c619 ( 65 0 ) capacitor c=0.00274939f //x=81.68 //y=2.385
c620 ( 61 0 ) capacitor c=0.00572072f //x=93.155 //y=2.26
c621 ( 58 0 ) capacitor c=0.233627f //x=92.835 //y=2.4
c622 ( 37 0 ) capacitor c=0.0140311f //x=81.52 //y=2.4
c623 ( 29 0 ) capacitor c=0.00107025f //x=80.74 //y=5.335
c624 ( 26 0 ) capacitor c=0.00778188f //x=79.86 //y=5.335
c625 ( 23 0 ) capacitor c=0.0111234f //x=78.982 //y=5.335
c626 ( 22 0 ) capacitor c=0.0783117f //x=94.47 //y=4.755
c627 ( 21 0 ) capacitor c=0.00995077f //x=94.47 //y=2.43
c628 ( 20 0 ) capacitor c=0.0863594f //x=92.99 //y=4.76
c629 ( 19 0 ) capacitor c=0.0102822f //x=92.99 //y=2.43
c630 ( 18 0 ) capacitor c=0.0761354f //x=83.37 //y=4.755
c631 ( 17 0 ) capacitor c=0.0127514f //x=83.37 //y=2.545
c632 ( 16 0 ) capacitor c=0.0769697f //x=81.52 //y=5.25
c633 ( 15 0 ) capacitor c=0.0131133f //x=81.52 //y=2.545
c634 ( 14 0 ) capacitor c=0.00947661f //x=81.52 //y=2.225
c635 ( 12 0 ) capacitor c=0.00481389f //x=81.12 //y=1.845
c636 ( 11 0 ) capacitor c=0.0139445f //x=81.435 //y=1.845
c637 ( 10 0 ) capacitor c=0.0167992f //x=81.035 //y=1.76
c638 ( 9 0 ) capacitor c=0.0111799f //x=81.035 //y=1.305
c639 ( 7 0 ) capacitor c=0.0235661f //x=81.435 //y=5.335
c640 ( 6 0 ) capacitor c=0.00933983f //x=80.74 //y=5.56
c641 ( 3 0 ) capacitor c=0.0195424f //x=80.625 //y=5.335
c642 ( 1 0 ) capacitor c=0.0151997f //x=79.74 //y=5.335
r643 (  201 228 ) resistor r=45.1352 //w=0.168 //l=0.173853 //layer=ply \
 //thickness=0.18 //x=95.175 //y=1.39 //x2=95.135 //y2=1.545
r644 (  200 227 ) resistor r=45.1352 //w=0.168 //l=0.173853 //layer=ply \
 //thickness=0.18 //x=95.175 //y=1.045 //x2=95.135 //y2=0.89
r645 (  200 201 ) resistor r=176.904 //w=0.094 //l=0.345 //layer=ply \
 //thickness=0.18 //x=95.175 //y=1.045 //x2=95.175 //y2=1.39
r646 (  198 202 ) resistor r=26.9307 //w=0.15 //l=0.106066 //layer=ply \
 //thickness=0.18 //x=95.105 //y=4.975 //x2=95.18 //y2=5.05
r647 (  198 199 ) resistor r=148.702 //w=0.094 //l=0.29 //layer=ply \
 //thickness=0.18 //x=95.105 //y=4.975 //x2=94.815 //y2=4.975
r648 (  196 226 ) resistor r=10.701 //w=0.21 //l=0.115 //layer=ply \
 //thickness=0.18 //x=94.8 //y=1.545 //x2=94.685 //y2=1.545
r649 (  195 228 ) resistor r=5.52526 //w=0.168 //l=0.115 //layer=ply \
 //thickness=0.18 //x=95.02 //y=1.545 //x2=95.135 //y2=1.545
r650 (  194 225 ) resistor r=5.52526 //w=0.168 //l=0.115 //layer=ply \
 //thickness=0.18 //x=94.8 //y=0.89 //x2=94.685 //y2=0.89
r651 (  193 227 ) resistor r=5.52526 //w=0.168 //l=0.115 //layer=ply \
 //thickness=0.18 //x=95.02 //y=0.89 //x2=95.135 //y2=0.89
r652 (  193 194 ) resistor r=112.809 //w=0.094 //l=0.22 //layer=ply \
 //thickness=0.18 //x=95.02 //y=0.89 //x2=94.8 //y2=0.89
r653 (  190 199 ) resistor r=22.1787 //w=0.252 //l=0.106066 //layer=ply \
 //thickness=0.18 //x=94.74 //y=5.05 //x2=94.815 //y2=4.975
r654 (  190 224 ) resistor r=51.6429 //w=0.252 //l=0.34271 //layer=ply \
 //thickness=0.18 //x=94.74 //y=5.05 //x2=94.47 //y2=4.885
r655 (  189 222 ) resistor r=30.4513 //w=0.277 //l=0.243926 //layer=ply \
 //thickness=0.18 //x=94.645 //y=2.095 //x2=94.47 //y2=2.26
r656 (  188 226 ) resistor r=39.5823 //w=0.21 //l=0.173853 //layer=ply \
 //thickness=0.18 //x=94.645 //y=1.7 //x2=94.685 //y2=1.545
r657 (  188 189 ) resistor r=202.543 //w=0.094 //l=0.395 //layer=ply \
 //thickness=0.18 //x=94.645 //y=1.7 //x2=94.645 //y2=2.095
r658 (  187 226 ) resistor r=39.5823 //w=0.21 //l=0.173853 //layer=ply \
 //thickness=0.18 //x=94.645 //y=1.39 //x2=94.685 //y2=1.545
r659 (  186 225 ) resistor r=45.1352 //w=0.168 //l=0.173853 //layer=ply \
 //thickness=0.18 //x=94.645 //y=1.045 //x2=94.685 //y2=0.89
r660 (  186 187 ) resistor r=176.904 //w=0.094 //l=0.345 //layer=ply \
 //thickness=0.18 //x=94.645 //y=1.045 //x2=94.645 //y2=1.39
r661 (  185 218 ) resistor r=30.4513 //w=0.277 //l=0.243926 //layer=ply \
 //thickness=0.18 //x=92.815 //y=2.095 //x2=92.99 //y2=2.26
r662 (  184 216 ) resistor r=39.5823 //w=0.21 //l=0.173853 //layer=ply \
 //thickness=0.18 //x=92.815 //y=1.74 //x2=92.775 //y2=1.585
r663 (  184 185 ) resistor r=182.032 //w=0.094 //l=0.355 //layer=ply \
 //thickness=0.18 //x=92.815 //y=1.74 //x2=92.815 //y2=2.095
r664 (  183 216 ) resistor r=39.5823 //w=0.21 //l=0.173853 //layer=ply \
 //thickness=0.18 //x=92.815 //y=1.43 //x2=92.775 //y2=1.585
r665 (  182 215 ) resistor r=45.1352 //w=0.168 //l=0.173853 //layer=ply \
 //thickness=0.18 //x=92.815 //y=1.085 //x2=92.775 //y2=0.93
r666 (  182 183 ) resistor r=176.904 //w=0.094 //l=0.345 //layer=ply \
 //thickness=0.18 //x=92.815 //y=1.085 //x2=92.815 //y2=1.43
r667 (  179 220 ) resistor r=51.6429 //w=0.252 //l=0.34271 //layer=ply \
 //thickness=0.18 //x=92.72 //y=5.05 //x2=92.99 //y2=4.885
r668 (  177 214 ) resistor r=5.52526 //w=0.168 //l=0.115 //layer=ply \
 //thickness=0.18 //x=92.44 //y=1.585 //x2=92.325 //y2=1.585
r669 (  176 216 ) resistor r=10.701 //w=0.21 //l=0.115 //layer=ply \
 //thickness=0.18 //x=92.66 //y=1.585 //x2=92.775 //y2=1.585
r670 (  175 213 ) resistor r=5.52526 //w=0.168 //l=0.115 //layer=ply \
 //thickness=0.18 //x=92.44 //y=0.93 //x2=92.325 //y2=0.93
r671 (  174 215 ) resistor r=5.52526 //w=0.168 //l=0.115 //layer=ply \
 //thickness=0.18 //x=92.66 //y=0.93 //x2=92.775 //y2=0.93
r672 (  174 175 ) resistor r=112.809 //w=0.094 //l=0.22 //layer=ply \
 //thickness=0.18 //x=92.66 //y=0.93 //x2=92.44 //y2=0.93
r673 (  172 179 ) resistor r=22.1787 //w=0.252 //l=0.106066 //layer=ply \
 //thickness=0.18 //x=92.645 //y=4.975 //x2=92.72 //y2=5.05
r674 (  172 173 ) resistor r=148.702 //w=0.094 //l=0.29 //layer=ply \
 //thickness=0.18 //x=92.645 //y=4.975 //x2=92.355 //y2=4.975
r675 (  171 214 ) resistor r=45.1352 //w=0.168 //l=0.173853 //layer=ply \
 //thickness=0.18 //x=92.285 //y=1.43 //x2=92.325 //y2=1.585
r676 (  170 213 ) resistor r=45.1352 //w=0.168 //l=0.173853 //layer=ply \
 //thickness=0.18 //x=92.285 //y=1.085 //x2=92.325 //y2=0.93
r677 (  170 171 ) resistor r=176.904 //w=0.094 //l=0.345 //layer=ply \
 //thickness=0.18 //x=92.285 //y=1.085 //x2=92.285 //y2=1.43
r678 (  167 173 ) resistor r=26.9307 //w=0.15 //l=0.106066 //layer=ply \
 //thickness=0.18 //x=92.28 //y=5.05 //x2=92.355 //y2=4.975
r679 (  162 164 ) resistor r=26.9307 //w=0.15 //l=0.106066 //layer=ply \
 //thickness=0.18 //x=83.935 //y=4.97 //x2=84.01 //y2=5.045
r680 (  162 163 ) resistor r=148.702 //w=0.094 //l=0.29 //layer=ply \
 //thickness=0.18 //x=83.935 //y=4.97 //x2=83.645 //y2=4.97
r681 (  161 212 ) resistor r=45.1352 //w=0.168 //l=0.173853 //layer=ply \
 //thickness=0.18 //x=83.6 //y=1.4 //x2=83.56 //y2=1.555
r682 (  160 211 ) resistor r=45.1352 //w=0.168 //l=0.173853 //layer=ply \
 //thickness=0.18 //x=83.6 //y=1.055 //x2=83.56 //y2=0.9
r683 (  160 161 ) resistor r=176.904 //w=0.094 //l=0.345 //layer=ply \
 //thickness=0.18 //x=83.6 //y=1.055 //x2=83.6 //y2=1.4
r684 (  157 163 ) resistor r=22.7971 //w=0.269 //l=0.106066 //layer=ply \
 //thickness=0.18 //x=83.57 //y=5.045 //x2=83.645 //y2=4.97
r685 (  157 210 ) resistor r=35.8364 //w=0.269 //l=0.270185 //layer=ply \
 //thickness=0.18 //x=83.57 //y=5.045 //x2=83.37 //y2=4.88
r686 (  155 206 ) resistor r=10.701 //w=0.21 //l=0.115 //layer=ply \
 //thickness=0.18 //x=83.225 //y=1.555 //x2=83.11 //y2=1.555
r687 (  154 212 ) resistor r=5.52526 //w=0.168 //l=0.115 //layer=ply \
 //thickness=0.18 //x=83.445 //y=1.555 //x2=83.56 //y2=1.555
r688 (  153 205 ) resistor r=5.52526 //w=0.168 //l=0.115 //layer=ply \
 //thickness=0.18 //x=83.225 //y=0.9 //x2=83.11 //y2=0.9
r689 (  152 211 ) resistor r=5.52526 //w=0.168 //l=0.115 //layer=ply \
 //thickness=0.18 //x=83.445 //y=0.9 //x2=83.56 //y2=0.9
r690 (  152 153 ) resistor r=112.809 //w=0.094 //l=0.22 //layer=ply \
 //thickness=0.18 //x=83.445 //y=0.9 //x2=83.225 //y2=0.9
r691 (  151 208 ) resistor r=58.7805 //w=0.246 //l=0.373497 //layer=ply \
 //thickness=0.18 //x=83.07 //y=2.095 //x2=83.37 //y2=2.26
r692 (  150 206 ) resistor r=39.5823 //w=0.21 //l=0.173853 //layer=ply \
 //thickness=0.18 //x=83.07 //y=1.71 //x2=83.11 //y2=1.555
r693 (  150 151 ) resistor r=197.415 //w=0.094 //l=0.385 //layer=ply \
 //thickness=0.18 //x=83.07 //y=1.71 //x2=83.07 //y2=2.095
r694 (  149 206 ) resistor r=39.5823 //w=0.21 //l=0.173853 //layer=ply \
 //thickness=0.18 //x=83.07 //y=1.4 //x2=83.11 //y2=1.555
r695 (  148 205 ) resistor r=45.1352 //w=0.168 //l=0.173853 //layer=ply \
 //thickness=0.18 //x=83.07 //y=1.055 //x2=83.11 //y2=0.9
r696 (  148 149 ) resistor r=176.904 //w=0.094 //l=0.345 //layer=ply \
 //thickness=0.18 //x=83.07 //y=1.055 //x2=83.07 //y2=1.4
r697 (  147 202 ) resistor r=592.245 //w=0.094 //l=1.155 //layer=ply \
 //thickness=0.18 //x=95.18 //y=6.205 //x2=95.18 //y2=5.05
r698 (  146 190 ) resistor r=592.245 //w=0.094 //l=1.155 //layer=ply \
 //thickness=0.18 //x=94.74 //y=6.205 //x2=94.74 //y2=5.05
r699 (  145 179 ) resistor r=592.245 //w=0.094 //l=1.155 //layer=ply \
 //thickness=0.18 //x=92.72 //y=6.205 //x2=92.72 //y2=5.05
r700 (  144 167 ) resistor r=592.245 //w=0.094 //l=1.155 //layer=ply \
 //thickness=0.18 //x=92.28 //y=6.205 //x2=92.28 //y2=5.05
r701 (  143 164 ) resistor r=592.245 //w=0.094 //l=1.155 //layer=ply \
 //thickness=0.18 //x=84.01 //y=6.2 //x2=84.01 //y2=5.045
r702 (  142 157 ) resistor r=592.245 //w=0.094 //l=1.155 //layer=ply \
 //thickness=0.18 //x=83.57 //y=6.2 //x2=83.57 //y2=5.045
r703 (  141 195 ) resistor r=56.4043 //w=0.094 //l=0.11 //layer=ply \
 //thickness=0.18 //x=94.91 //y=1.545 //x2=95.02 //y2=1.545
r704 (  141 196 ) resistor r=56.4043 //w=0.094 //l=0.11 //layer=ply \
 //thickness=0.18 //x=94.91 //y=1.545 //x2=94.8 //y2=1.545
r705 (  140 176 ) resistor r=56.4043 //w=0.094 //l=0.11 //layer=ply \
 //thickness=0.18 //x=92.55 //y=1.585 //x2=92.66 //y2=1.585
r706 (  140 177 ) resistor r=56.4043 //w=0.094 //l=0.11 //layer=ply \
 //thickness=0.18 //x=92.55 //y=1.585 //x2=92.44 //y2=1.585
r707 (  139 154 ) resistor r=56.4043 //w=0.094 //l=0.11 //layer=ply \
 //thickness=0.18 //x=83.335 //y=1.555 //x2=83.445 //y2=1.555
r708 (  139 155 ) resistor r=56.4043 //w=0.094 //l=0.11 //layer=ply \
 //thickness=0.18 //x=83.335 //y=1.555 //x2=83.225 //y2=1.555
r709 (  135 224 ) resistor r=152 //w=0.17 //l=0.17 //layer=licon //count=1 \
 //x=94.47 //y=4.885 //x2=94.47 //y2=4.885
r710 (  130 222 ) resistor r=152 //w=0.17 //l=0.17 //layer=licon //count=1 \
 //x=94.47 //y=2.26 //x2=94.47 //y2=2.26
r711 (  125 220 ) resistor r=152 //w=0.17 //l=0.17 //layer=licon //count=1 \
 //x=92.99 //y=4.885 //x2=92.99 //y2=4.885
r712 (  120 218 ) resistor r=152 //w=0.17 //l=0.17 //layer=licon //count=1 \
 //x=92.99 //y=2.26 //x2=92.99 //y2=2.26
r713 (  115 210 ) resistor r=152 //w=0.17 //l=0.17 //layer=licon //count=1 \
 //x=83.37 //y=4.88 //x2=83.37 //y2=4.88
r714 (  110 208 ) resistor r=152 //w=0.17 //l=0.17 //layer=licon //count=1 \
 //x=83.37 //y=2.26 //x2=83.37 //y2=2.26
r715 (  93 233 ) resistor r=23.615 //w=0.187 //l=0.345 //layer=li \
 //thickness=0.1 //x=80.74 //y=5.56 //x2=80.74 //y2=5.905
r716 (  85 232 ) resistor r=23.615 //w=0.187 //l=0.345 //layer=li \
 //thickness=0.1 //x=79.86 //y=5.56 //x2=79.86 //y2=5.905
r717 (  77 231 ) resistor r=23.615 //w=0.187 //l=0.345 //layer=li \
 //thickness=0.1 //x=78.98 //y=5.56 //x2=78.98 //y2=5.905
r718 (  73 74 ) resistor r=0.10734 //w=0.281 //l=0.16 //layer=m2 \
 //thickness=0.36 //x=94.465 //y=2.27 //x2=94.305 //y2=2.27
r719 (  67 69 ) resistor r=0.10734 //w=0.281 //l=0.16 //layer=m2 \
 //thickness=0.36 //x=83.365 //y=2.385 //x2=83.525 //y2=2.385
r720 (  67 68 ) resistor r=0.10734 //w=0.281 //l=0.16 //layer=m2 \
 //thickness=0.36 //x=83.365 //y=2.385 //x2=83.205 //y2=2.385
r721 (  65 68 ) resistor r=1.45515 //w=0.131 //l=1.525 //layer=m2 \
 //thickness=0.36 //x=81.68 //y=2.4 //x2=83.205 //y2=2.4
r722 (  63 65 ) resistor r=0.10734 //w=0.281 //l=0.16 //layer=m2 \
 //thickness=0.36 //x=81.52 //y=2.385 //x2=81.68 //y2=2.385
r723 (  61 71 ) resistor r=0.0908175 //w=0.367 //l=0.177539 //layer=m2 \
 //thickness=0.36 //x=93.155 //y=2.26 //x2=92.995 //y2=2.297
r724 (  61 74 ) resistor r=1.09733 //w=0.131 //l=1.15 //layer=m2 \
 //thickness=0.36 //x=93.155 //y=2.26 //x2=94.305 //y2=2.26
r725 (  58 71 ) resistor r=0.0908175 //w=0.367 //l=0.205134 //layer=m2 \
 //thickness=0.36 //x=92.835 //y=2.4 //x2=92.995 //y2=2.297
r726 (  58 69 ) resistor r=8.88359 //w=0.131 //l=9.31 //layer=m2 \
 //thickness=0.36 //x=92.835 //y=2.4 //x2=83.525 //y2=2.4
r727 (  55 135 ) resistor r=9.3 //w=0.17 //l=0.17 //layer=mcon //count=1 \
 //x=94.47 //y=4.885 //x2=94.47 //y2=4.885
r728 (  53 73 ) resistor r=4.5 //w=0.15 //l=0.15 //layer=via1 //count=1 \
 //x=94.465 //y=2.27 //x2=94.465 //y2=2.27
r729 (  51 130 ) resistor r=9.3 //w=0.17 //l=0.17 //layer=mcon //count=1 \
 //x=94.47 //y=2.26 //x2=94.47 //y2=2.26
r730 (  51 53 ) resistor r=0.00334225 //w=0.374 //l=0.01 //layer=m1 \
 //thickness=0.36 //x=94.415 //y=2.26 //x2=94.415 //y2=2.27
r731 (  49 71 ) resistor r=4.5 //w=0.15 //l=0.15 //layer=via1 //count=1 \
 //x=92.995 //y=2.27 //x2=92.995 //y2=2.27
r732 (  47 120 ) resistor r=9.3 //w=0.17 //l=0.17 //layer=mcon //count=1 \
 //x=92.99 //y=2.26 //x2=92.99 //y2=2.26
r733 (  47 49 ) resistor r=0.00334225 //w=0.374 //l=0.01 //layer=m1 \
 //thickness=0.36 //x=93.045 //y=2.26 //x2=93.045 //y2=2.27
r734 (  45 125 ) resistor r=9.3 //w=0.17 //l=0.17 //layer=mcon //count=1 \
 //x=92.99 //y=4.885 //x2=92.99 //y2=4.885
r735 (  43 67 ) resistor r=4.5 //w=0.15 //l=0.15 //layer=via1 //count=1 \
 //x=83.365 //y=2.385 //x2=83.365 //y2=2.385
r736 (  41 110 ) resistor r=9.3 //w=0.17 //l=0.17 //layer=mcon //count=1 \
 //x=83.37 //y=2.26 //x2=83.37 //y2=2.26
r737 (  41 43 ) resistor r=0.0540657 //w=0.289 //l=0.125 //layer=m1 \
 //thickness=0.36 //x=83.365 //y=2.26 //x2=83.365 //y2=2.385
r738 (  39 115 ) resistor r=9.3 //w=0.17 //l=0.17 //layer=mcon //count=1 \
 //x=83.37 //y=4.88 //x2=83.37 //y2=4.88
r739 (  35 63 ) resistor r=4.5 //w=0.15 //l=0.15 //layer=via1 //count=1 \
 //x=81.52 //y=2.385 //x2=81.52 //y2=2.385
r740 (  35 37 ) resistor r=0.0049867 //w=0.376 //l=0.015 //layer=m1 \
 //thickness=0.36 //x=81.572 //y=2.385 //x2=81.572 //y2=2.4
r741 (  33 229 ) resistor r=9.3 //w=0.17 //l=0.17 //layer=mcon //count=1 \
 //x=81.035 //y=1.19 //x2=81.035 //y2=1.19
r742 (  31 93 ) resistor r=9.3 //w=0.17 //l=0.17 //layer=mcon //count=1 \
 //x=80.74 //y=5.56 //x2=80.74 //y2=5.56
r743 (  28 85 ) resistor r=9.3 //w=0.17 //l=0.17 //layer=mcon //count=1 \
 //x=79.86 //y=5.56 //x2=79.86 //y2=5.56
r744 (  26 28 ) resistor r=0.121228 //w=0.232 //l=0.225 //layer=m1 \
 //thickness=0.36 //x=79.86 //y=5.335 //x2=79.86 //y2=5.56
r745 (  25 77 ) resistor r=9.3 //w=0.17 //l=0.17 //layer=mcon //count=1 \
 //x=78.98 //y=5.56 //x2=78.98 //y2=5.56
r746 (  23 25 ) resistor r=0.129608 //w=0.217 //l=0.225 //layer=m1 \
 //thickness=0.36 //x=78.982 //y=5.335 //x2=78.982 //y2=5.56
r747 (  22 55 ) resistor r=0.0777782 //w=0.252 //l=0.131491 //layer=m1 \
 //thickness=0.36 //x=94.47 //y=4.755 //x2=94.467 //y2=4.885
r748 (  21 53 ) resistor r=0.0910802 //w=0.374 //l=0.185472 //layer=m1 \
 //thickness=0.36 //x=94.47 //y=2.43 //x2=94.415 //y2=2.27
r749 (  21 22 ) resistor r=2.21851 //w=0.131 //l=2.325 //layer=m1 \
 //thickness=0.36 //x=94.47 //y=2.43 //x2=94.47 //y2=4.755
r750 (  20 45 ) resistor r=0.075298 //w=0.252 //l=0.125 //layer=m1 \
 //thickness=0.36 //x=92.99 //y=4.76 //x2=92.99 //y2=4.885
r751 (  19 49 ) resistor r=0.0910802 //w=0.374 //l=0.185472 //layer=m1 \
 //thickness=0.36 //x=92.99 //y=2.43 //x2=93.045 //y2=2.27
r752 (  19 20 ) resistor r=2.22328 //w=0.131 //l=2.33 //layer=m1 \
 //thickness=0.36 //x=92.99 //y=2.43 //x2=92.99 //y2=4.76
r753 (  18 39 ) resistor r=0.0760407 //w=0.238 //l=0.125 //layer=m1 \
 //thickness=0.36 //x=83.37 //y=4.755 //x2=83.37 //y2=4.88
r754 (  17 43 ) resistor r=0.0902229 //w=0.289 //l=0.162481 //layer=m1 \
 //thickness=0.36 //x=83.37 //y=2.545 //x2=83.365 //y2=2.385
r755 (  17 18 ) resistor r=2.10878 //w=0.131 //l=2.21 //layer=m1 \
 //thickness=0.36 //x=83.37 //y=2.545 //x2=83.37 //y2=4.755
r756 (  15 37 ) resistor r=0.0861726 //w=0.376 //l=0.169012 //layer=m1 \
 //thickness=0.36 //x=81.52 //y=2.545 //x2=81.572 //y2=2.4
r757 (  15 16 ) resistor r=2.58111 //w=0.131 //l=2.705 //layer=m1 \
 //thickness=0.36 //x=81.52 //y=2.545 //x2=81.52 //y2=5.25
r758 (  14 35 ) resistor r=0.0911593 //w=0.376 //l=0.184174 //layer=m1 \
 //thickness=0.36 //x=81.52 //y=2.225 //x2=81.572 //y2=2.385
r759 (  13 14 ) resistor r=0.281489 //w=0.131 //l=0.295 //layer=m1 \
 //thickness=0.36 //x=81.52 //y=1.93 //x2=81.52 //y2=2.225
r760 (  11 13 ) resistor r=0.0698411 //w=0.17 //l=0.120208 //layer=m1 \
 //thickness=0.36 //x=81.435 //y=1.845 //x2=81.52 //y2=1.93
r761 (  11 12 ) resistor r=0.300573 //w=0.131 //l=0.315 //layer=m1 \
 //thickness=0.36 //x=81.435 //y=1.845 //x2=81.12 //y2=1.845
r762 (  10 12 ) resistor r=0.0698411 //w=0.17 //l=0.120208 //layer=m1 \
 //thickness=0.36 //x=81.035 //y=1.76 //x2=81.12 //y2=1.845
r763 (  9 33 ) resistor r=0.0717383 //w=0.224 //l=0.115 //layer=m1 \
 //thickness=0.36 //x=81.035 //y=1.305 //x2=81.035 //y2=1.19
r764 (  9 10 ) resistor r=0.43416 //w=0.131 //l=0.455 //layer=m1 \
 //thickness=0.36 //x=81.035 //y=1.305 //x2=81.035 //y2=1.76
r765 (  8 29 ) resistor r=0.0675342 //w=0.23 //l=0.115 //layer=m1 \
 //thickness=0.36 //x=80.855 //y=5.335 //x2=80.74 //y2=5.335
r766 (  7 16 ) resistor r=0.0698411 //w=0.17 //l=0.120208 //layer=m1 \
 //thickness=0.36 //x=81.435 //y=5.335 //x2=81.52 //y2=5.25
r767 (  7 8 ) resistor r=0.553435 //w=0.131 //l=0.58 //layer=m1 \
 //thickness=0.36 //x=81.435 //y=5.335 //x2=80.855 //y2=5.335
r768 (  6 31 ) resistor r=0.00118313 //w=0.23 //layer=m1 //thickness=0.36 \
 //x=80.74 //y=5.56 //x2=80.74 //y2=5.56
r769 (  5 29 ) resistor r=0.002872 //w=0.34 //l=0.085 //layer=m1 \
 //thickness=0.36 //x=80.74 //y=5.42 //x2=80.74 //y2=5.335
r770 (  5 6 ) resistor r=0.091623 //w=0.191 //l=0.14 //layer=m1 \
 //thickness=0.36 //x=80.74 //y=5.42 //x2=80.74 //y2=5.56
r771 (  4 26 ) resistor r=0.0262263 //w=0.232 //l=0.12 //layer=m1 \
 //thickness=0.36 //x=79.98 //y=5.335 //x2=79.86 //y2=5.335
r772 (  3 29 ) resistor r=0.0675342 //w=0.23 //l=0.115 //layer=m1 \
 //thickness=0.36 //x=80.625 //y=5.335 //x2=80.74 //y2=5.335
r773 (  3 4 ) resistor r=0.615458 //w=0.131 //l=0.645 //layer=m1 \
 //thickness=0.36 //x=80.625 //y=5.335 //x2=79.98 //y2=5.335
r774 (  2 23 ) resistor r=0.0222262 //w=0.217 //l=0.118 //layer=m1 \
 //thickness=0.36 //x=79.1 //y=5.335 //x2=78.982 //y2=5.335
r775 (  1 26 ) resistor r=0.0262263 //w=0.232 //l=0.12 //layer=m1 \
 //thickness=0.36 //x=79.74 //y=5.335 //x2=79.86 //y2=5.335
r776 (  1 2 ) resistor r=0.610687 //w=0.131 //l=0.64 //layer=m1 \
 //thickness=0.36 //x=79.74 //y=5.335 //x2=79.1 //y2=5.335
ends PM_TMRDFFSNRNQNX1\%noxref_21

subckt PM_TMRDFFSNRNQNX1\%noxref_22 ( 1 3 6 7 9 10 11 12 14 15 16 17 18 19 20 \
 21 22 23 24 25 26 27 28 29 32 35 43 47 59 63 68 69 70 71 72 74 77 78 79 80 82 \
 84 87 88 89 90 92 94 96 98 100 102 104 107 118 119 122 130 138 155 164 169 \
 178 183 192 196 197 198 199 200 201 202 203 204 205 206 207 208 209 211 217 \
 218 219 220 224 225 226 231 233 235 241 242 243 244 245 250 252 254 260 261 \
 271 272 275 283 284 287 295 297 298 299 )
c744 ( 295 0 ) capacitor c=0.00885916f //x=51.985 //y=1.095
c745 ( 287 0 ) capacitor c=0.0370698f //x=95.6 //y=4.885
c746 ( 284 0 ) capacitor c=0.028421f //x=95.58 //y=2.095
c747 ( 283 0 ) capacitor c=0.0512002f //x=95.58 //y=2.26
c748 ( 275 0 ) capacitor c=0.0387879f //x=88.96 //y=4.885
c749 ( 272 0 ) capacitor c=0.0300885f //x=88.92 //y=2.095
c750 ( 271 0 ) capacitor c=0.0554483f //x=88.92 //y=2.26
c751 ( 261 0 ) capacitor c=0.0237734f //x=96.145 //y=1.435
c752 ( 260 0 ) capacitor c=0.0191782f //x=96.145 //y=1.085
c753 ( 254 0 ) capacitor c=0.0361171f //x=95.99 //y=1.585
c754 ( 252 0 ) capacitor c=0.0157803f //x=95.99 //y=0.93
c755 ( 250 0 ) capacitor c=0.0376354f //x=95.985 //y=4.975
c756 ( 245 0 ) capacitor c=0.020493f //x=95.615 //y=1.74
c757 ( 244 0 ) capacitor c=0.0167049f //x=95.615 //y=1.435
c758 ( 243 0 ) capacitor c=0.0174993f //x=95.615 //y=1.085
c759 ( 242 0 ) capacitor c=0.0443648f //x=89.485 //y=1.43
c760 ( 241 0 ) capacitor c=0.0192211f //x=89.485 //y=1.085
c761 ( 235 0 ) capacitor c=0.0186579f //x=89.33 //y=1.585
c762 ( 233 0 ) capacitor c=0.0157795f //x=89.33 //y=0.93
c763 ( 231 0 ) capacitor c=0.0351351f //x=89.325 //y=4.975
c764 ( 226 0 ) capacitor c=0.0209124f //x=88.955 //y=1.74
c765 ( 225 0 ) capacitor c=0.016848f //x=88.955 //y=1.43
c766 ( 224 0 ) capacitor c=0.0174777f //x=88.955 //y=1.085
c767 ( 220 0 ) capacitor c=0.0612936f //x=54.785 //y=4.97
c768 ( 219 0 ) capacitor c=0.0376642f //x=55.075 //y=4.97
c769 ( 218 0 ) capacitor c=0.0346489f //x=54.74 //y=1.4
c770 ( 217 0 ) capacitor c=0.018692f //x=54.74 //y=1.055
c771 ( 211 0 ) capacitor c=0.0137077f //x=54.585 //y=1.555
c772 ( 209 0 ) capacitor c=0.0158585f //x=54.585 //y=0.9
c773 ( 208 0 ) capacitor c=0.101017f //x=54.21 //y=2.095
c774 ( 207 0 ) capacitor c=0.0229444f //x=54.21 //y=1.71
c775 ( 206 0 ) capacitor c=0.0234359f //x=54.21 //y=1.4
c776 ( 205 0 ) capacitor c=0.019815f //x=54.21 //y=1.055
c777 ( 204 0 ) capacitor c=0.155887f //x=96.06 //y=6.205
c778 ( 203 0 ) capacitor c=0.1106f //x=95.62 //y=6.205
c779 ( 202 0 ) capacitor c=0.154859f //x=89.4 //y=6.205
c780 ( 201 0 ) capacitor c=0.110573f //x=88.96 //y=6.205
c781 ( 200 0 ) capacitor c=0.110208f //x=55.15 //y=6.2
c782 ( 199 0 ) capacitor c=0.158957f //x=54.71 //y=6.2
c783 ( 192 0 ) capacitor c=8.10734e-19 //x=95.6 //y=4.885
c784 ( 183 0 ) capacitor c=0.00105273f //x=95.58 //y=2.26
c785 ( 178 0 ) capacitor c=0.00173056f //x=88.96 //y=4.885
c786 ( 169 0 ) capacitor c=0.00152737f //x=88.92 //y=2.26
c787 ( 164 0 ) capacitor c=0.00159026f //x=54.51 //y=4.88
c788 ( 155 0 ) capacitor c=0.0012618f //x=54.51 //y=2.26
c789 ( 138 0 ) capacitor c=0.0293393f //x=51.88 //y=5.56
c790 ( 130 0 ) capacitor c=0.029137f //x=51 //y=5.56
c791 ( 122 0 ) capacitor c=0.0278099f //x=50.12 //y=5.56
c792 ( 119 0 ) capacitor c=0.162165f //x=95.435 //y=4.21
c793 ( 118 0 ) capacitor c=0.00479868f //x=95.595 //y=4.21
c794 ( 107 0 ) capacitor c=0.0165817f //x=89.08 //y=4.252
c795 ( 104 0 ) capacitor c=0.00498823f //x=88.03 //y=4.235
c796 ( 102 0 ) capacitor c=0.0289344f //x=87.43 //y=4.25
c797 ( 100 0 ) capacitor c=0.00458125f //x=85.805 //y=4.27
c798 ( 98 0 ) capacitor c=0.0828724f //x=85.205 //y=4.25
c799 ( 96 0 ) capacitor c=0.00430603f //x=76.915 //y=4.28
c800 ( 94 0 ) capacitor c=0.0493089f //x=76.315 //y=4.25
c801 ( 92 0 ) capacitor c=0.00404489f //x=71.375 //y=4.31
c802 ( 90 0 ) capacitor c=0.0450008f //x=66.565 //y=4.28
c803 ( 89 0 ) capacitor c=0.00292689f //x=65.695 //y=4.25
c804 ( 88 0 ) capacitor c=0.00782061f //x=65.965 //y=4.25
c805 ( 87 0 ) capacitor c=0.00460873f //x=65.61 //y=4.165
c806 ( 84 0 ) capacitor c=0.0514445f //x=61.765 //y=3.9
c807 ( 82 0 ) capacitor c=0.0220058f //x=61.165 //y=3.88
c808 ( 80 0 ) capacitor c=0.00743812f //x=59.525 //y=3.85
c809 ( 79 0 ) capacitor c=1.50195e-19 //x=57.555 //y=3.88
c810 ( 78 0 ) capacitor c=0.0262859f //x=58.925 //y=3.88
c811 ( 74 0 ) capacitor c=0.00710318f //x=56.95 //y=3.5
c812 ( 72 0 ) capacitor c=0.00530231f //x=56.345 //y=3.51
c813 ( 71 0 ) capacitor c=0.00845301f //x=55.49 //y=3.53
c814 ( 70 0 ) capacitor c=0.00319409f //x=55.835 //y=3.53
c815 ( 69 0 ) capacitor c=6.63294e-19 //x=52.815 //y=3.51
c816 ( 68 0 ) capacitor c=0.0193329f //x=54.345 //y=3.51
c817 ( 63 0 ) capacitor c=0.0139164f //x=95.58 //y=4.25
c818 ( 59 0 ) capacitor c=0.0153807f //x=88.92 //y=4.25
c819 ( 47 0 ) capacitor c=0.0171627f //x=54.51 //y=3.51
c820 ( 43 0 ) capacitor c=0.0178187f //x=52.66 //y=3.51
c821 ( 35 0 ) capacitor c=0.00101939f //x=51.88 //y=5.335
c822 ( 32 0 ) capacitor c=0.00762667f //x=51 //y=5.335
c823 ( 29 0 ) capacitor c=0.0109203f //x=50.122 //y=5.335
c824 ( 28 0 ) capacitor c=0.0124358f //x=95.58 //y=4.74
c825 ( 27 0 ) capacitor c=0.0108569f //x=95.58 //y=4.37
c826 ( 26 0 ) capacitor c=0.0498276f //x=95.58 //y=4.05
c827 ( 25 0 ) capacitor c=0.00651439f //x=95.58 //y=2.38
c828 ( 24 0 ) capacitor c=0.0169891f //x=88.92 //y=4.71
c829 ( 23 0 ) capacitor c=0.0132636f //x=88.92 //y=4.365
c830 ( 22 0 ) capacitor c=0.0651938f //x=88.92 //y=4.045
c831 ( 21 0 ) capacitor c=0.00716889f //x=88.92 //y=2.375
c832 ( 20 0 ) capacitor c=0.0354965f //x=54.51 //y=4.755
c833 ( 19 0 ) capacitor c=0.0139769f //x=54.51 //y=3.655
c834 ( 18 0 ) capacitor c=0.0265366f //x=54.51 //y=3.365
c835 ( 17 0 ) capacitor c=0.00495287f //x=54.51 //y=2.375
c836 ( 16 0 ) capacitor c=0.0446664f //x=52.66 //y=5.25
c837 ( 15 0 ) capacitor c=0.0128677f //x=52.66 //y=3.655
c838 ( 14 0 ) capacitor c=0.0369704f //x=52.66 //y=3.365
c839 ( 12 0 ) capacitor c=0.00432784f //x=52.26 //y=1.845
c840 ( 11 0 ) capacitor c=0.0132749f //x=52.575 //y=1.845
c841 ( 10 0 ) capacitor c=0.0167992f //x=52.175 //y=1.76
c842 ( 9 0 ) capacitor c=0.011044f //x=52.175 //y=1.305
c843 ( 7 0 ) capacitor c=0.0211572f //x=52.575 //y=5.335
c844 ( 6 0 ) capacitor c=0.00933983f //x=51.88 //y=5.56
c845 ( 3 0 ) capacitor c=0.0191747f //x=51.765 //y=5.335
c846 ( 1 0 ) capacitor c=0.0149131f //x=50.88 //y=5.335
r847 (  289 290 ) resistor r=32.4568 //w=0.214 //l=0.075 //layer=ply \
 //thickness=0.18 //x=95.6 //y=4.975 //x2=95.6 //y2=5.05
r848 (  287 289 ) resistor r=20.271 //w=0.214 //l=0.09 //layer=ply \
 //thickness=0.18 //x=95.6 //y=4.885 //x2=95.6 //y2=4.975
r849 (  283 284 ) resistor r=52.7279 //w=0.214 //l=0.165 //layer=ply \
 //thickness=0.18 //x=95.58 //y=2.26 //x2=95.58 //y2=2.095
r850 (  275 277 ) resistor r=20.271 //w=0.214 //l=0.09 //layer=ply \
 //thickness=0.18 //x=88.96 //y=4.885 //x2=88.96 //y2=4.975
r851 (  271 272 ) resistor r=52.7279 //w=0.214 //l=0.165 //layer=ply \
 //thickness=0.18 //x=88.92 //y=2.26 //x2=88.92 //y2=2.095
r852 (  261 294 ) resistor r=4.95774 //w=0.164 //l=0.112 //layer=ply \
 //thickness=0.18 //x=96.145 //y=1.435 //x2=96.145 //y2=1.547
r853 (  260 293 ) resistor r=45.1352 //w=0.168 //l=0.173853 //layer=ply \
 //thickness=0.18 //x=96.145 //y=1.085 //x2=96.105 //y2=0.93
r854 (  260 261 ) resistor r=179.468 //w=0.094 //l=0.35 //layer=ply \
 //thickness=0.18 //x=96.145 //y=1.085 //x2=96.145 //y2=1.435
r855 (  255 292 ) resistor r=10.8103 //w=0.211 //l=0.115 //layer=ply \
 //thickness=0.18 //x=95.77 //y=1.585 //x2=95.655 //y2=1.585
r856 (  254 294 ) resistor r=45.9962 //w=0.164 //l=0.17296 //layer=ply \
 //thickness=0.18 //x=95.99 //y=1.585 //x2=96.145 //y2=1.547
r857 (  253 291 ) resistor r=5.52526 //w=0.168 //l=0.115 //layer=ply \
 //thickness=0.18 //x=95.77 //y=0.93 //x2=95.655 //y2=0.93
r858 (  252 293 ) resistor r=5.52526 //w=0.168 //l=0.115 //layer=ply \
 //thickness=0.18 //x=95.99 //y=0.93 //x2=96.105 //y2=0.93
r859 (  252 253 ) resistor r=112.809 //w=0.094 //l=0.22 //layer=ply \
 //thickness=0.18 //x=95.99 //y=0.93 //x2=95.77 //y2=0.93
r860 (  251 289 ) resistor r=16.5046 //w=0.27 //l=0.135 //layer=ply \
 //thickness=0.18 //x=95.735 //y=4.975 //x2=95.6 //y2=4.975
r861 (  250 257 ) resistor r=26.9307 //w=0.15 //l=0.106066 //layer=ply \
 //thickness=0.18 //x=95.985 //y=4.975 //x2=96.06 //y2=5.05
r862 (  250 251 ) resistor r=128.191 //w=0.094 //l=0.25 //layer=ply \
 //thickness=0.18 //x=95.985 //y=4.975 //x2=95.735 //y2=4.975
r863 (  245 292 ) resistor r=39.5036 //w=0.211 //l=0.173853 //layer=ply \
 //thickness=0.18 //x=95.615 //y=1.74 //x2=95.655 //y2=1.585
r864 (  245 284 ) resistor r=182.032 //w=0.094 //l=0.355 //layer=ply \
 //thickness=0.18 //x=95.615 //y=1.74 //x2=95.615 //y2=2.095
r865 (  244 292 ) resistor r=38.3614 //w=0.211 //l=0.168819 //layer=ply \
 //thickness=0.18 //x=95.615 //y=1.435 //x2=95.655 //y2=1.585
r866 (  243 291 ) resistor r=45.1352 //w=0.168 //l=0.173853 //layer=ply \
 //thickness=0.18 //x=95.615 //y=1.085 //x2=95.655 //y2=0.93
r867 (  243 244 ) resistor r=179.468 //w=0.094 //l=0.35 //layer=ply \
 //thickness=0.18 //x=95.615 //y=1.085 //x2=95.615 //y2=1.435
r868 (  242 281 ) resistor r=45.1352 //w=0.168 //l=0.173853 //layer=ply \
 //thickness=0.18 //x=89.485 //y=1.43 //x2=89.445 //y2=1.585
r869 (  241 280 ) resistor r=45.1352 //w=0.168 //l=0.173853 //layer=ply \
 //thickness=0.18 //x=89.485 //y=1.085 //x2=89.445 //y2=0.93
r870 (  241 242 ) resistor r=176.904 //w=0.094 //l=0.345 //layer=ply \
 //thickness=0.18 //x=89.485 //y=1.085 //x2=89.485 //y2=1.43
r871 (  236 279 ) resistor r=10.701 //w=0.21 //l=0.115 //layer=ply \
 //thickness=0.18 //x=89.11 //y=1.585 //x2=88.995 //y2=1.585
r872 (  235 281 ) resistor r=5.52526 //w=0.168 //l=0.115 //layer=ply \
 //thickness=0.18 //x=89.33 //y=1.585 //x2=89.445 //y2=1.585
r873 (  234 278 ) resistor r=5.52526 //w=0.168 //l=0.115 //layer=ply \
 //thickness=0.18 //x=89.11 //y=0.93 //x2=88.995 //y2=0.93
r874 (  233 280 ) resistor r=5.52526 //w=0.168 //l=0.115 //layer=ply \
 //thickness=0.18 //x=89.33 //y=0.93 //x2=89.445 //y2=0.93
r875 (  233 234 ) resistor r=112.809 //w=0.094 //l=0.22 //layer=ply \
 //thickness=0.18 //x=89.33 //y=0.93 //x2=89.11 //y2=0.93
r876 (  232 277 ) resistor r=16.5046 //w=0.27 //l=0.135 //layer=ply \
 //thickness=0.18 //x=89.095 //y=4.975 //x2=88.96 //y2=4.975
r877 (  231 238 ) resistor r=26.9307 //w=0.15 //l=0.106066 //layer=ply \
 //thickness=0.18 //x=89.325 //y=4.975 //x2=89.4 //y2=5.05
r878 (  231 232 ) resistor r=117.936 //w=0.094 //l=0.23 //layer=ply \
 //thickness=0.18 //x=89.325 //y=4.975 //x2=89.095 //y2=4.975
r879 (  228 277 ) resistor r=32.4568 //w=0.214 //l=0.075 //layer=ply \
 //thickness=0.18 //x=88.96 //y=5.05 //x2=88.96 //y2=4.975
r880 (  226 279 ) resistor r=39.5823 //w=0.21 //l=0.173853 //layer=ply \
 //thickness=0.18 //x=88.955 //y=1.74 //x2=88.995 //y2=1.585
r881 (  226 272 ) resistor r=182.032 //w=0.094 //l=0.355 //layer=ply \
 //thickness=0.18 //x=88.955 //y=1.74 //x2=88.955 //y2=2.095
r882 (  225 279 ) resistor r=39.5823 //w=0.21 //l=0.173853 //layer=ply \
 //thickness=0.18 //x=88.955 //y=1.43 //x2=88.995 //y2=1.585
r883 (  224 278 ) resistor r=45.1352 //w=0.168 //l=0.173853 //layer=ply \
 //thickness=0.18 //x=88.955 //y=1.085 //x2=88.995 //y2=0.93
r884 (  224 225 ) resistor r=176.904 //w=0.094 //l=0.345 //layer=ply \
 //thickness=0.18 //x=88.955 //y=1.085 //x2=88.955 //y2=1.43
r885 (  219 221 ) resistor r=26.9307 //w=0.15 //l=0.106066 //layer=ply \
 //thickness=0.18 //x=55.075 //y=4.97 //x2=55.15 //y2=5.045
r886 (  219 220 ) resistor r=148.702 //w=0.094 //l=0.29 //layer=ply \
 //thickness=0.18 //x=55.075 //y=4.97 //x2=54.785 //y2=4.97
r887 (  218 269 ) resistor r=45.1352 //w=0.168 //l=0.173853 //layer=ply \
 //thickness=0.18 //x=54.74 //y=1.4 //x2=54.7 //y2=1.555
r888 (  217 268 ) resistor r=45.1352 //w=0.168 //l=0.173853 //layer=ply \
 //thickness=0.18 //x=54.74 //y=1.055 //x2=54.7 //y2=0.9
r889 (  217 218 ) resistor r=176.904 //w=0.094 //l=0.345 //layer=ply \
 //thickness=0.18 //x=54.74 //y=1.055 //x2=54.74 //y2=1.4
r890 (  214 220 ) resistor r=22.7971 //w=0.269 //l=0.106066 //layer=ply \
 //thickness=0.18 //x=54.71 //y=5.045 //x2=54.785 //y2=4.97
r891 (  214 267 ) resistor r=35.8364 //w=0.269 //l=0.270185 //layer=ply \
 //thickness=0.18 //x=54.71 //y=5.045 //x2=54.51 //y2=4.88
r892 (  212 263 ) resistor r=10.701 //w=0.21 //l=0.115 //layer=ply \
 //thickness=0.18 //x=54.365 //y=1.555 //x2=54.25 //y2=1.555
r893 (  211 269 ) resistor r=5.52526 //w=0.168 //l=0.115 //layer=ply \
 //thickness=0.18 //x=54.585 //y=1.555 //x2=54.7 //y2=1.555
r894 (  210 262 ) resistor r=5.52526 //w=0.168 //l=0.115 //layer=ply \
 //thickness=0.18 //x=54.365 //y=0.9 //x2=54.25 //y2=0.9
r895 (  209 268 ) resistor r=5.52526 //w=0.168 //l=0.115 //layer=ply \
 //thickness=0.18 //x=54.585 //y=0.9 //x2=54.7 //y2=0.9
r896 (  209 210 ) resistor r=112.809 //w=0.094 //l=0.22 //layer=ply \
 //thickness=0.18 //x=54.585 //y=0.9 //x2=54.365 //y2=0.9
r897 (  208 265 ) resistor r=58.7805 //w=0.246 //l=0.373497 //layer=ply \
 //thickness=0.18 //x=54.21 //y=2.095 //x2=54.51 //y2=2.26
r898 (  207 263 ) resistor r=39.5823 //w=0.21 //l=0.173853 //layer=ply \
 //thickness=0.18 //x=54.21 //y=1.71 //x2=54.25 //y2=1.555
r899 (  207 208 ) resistor r=197.415 //w=0.094 //l=0.385 //layer=ply \
 //thickness=0.18 //x=54.21 //y=1.71 //x2=54.21 //y2=2.095
r900 (  206 263 ) resistor r=39.5823 //w=0.21 //l=0.173853 //layer=ply \
 //thickness=0.18 //x=54.21 //y=1.4 //x2=54.25 //y2=1.555
r901 (  205 262 ) resistor r=45.1352 //w=0.168 //l=0.173853 //layer=ply \
 //thickness=0.18 //x=54.21 //y=1.055 //x2=54.25 //y2=0.9
r902 (  205 206 ) resistor r=176.904 //w=0.094 //l=0.345 //layer=ply \
 //thickness=0.18 //x=54.21 //y=1.055 //x2=54.21 //y2=1.4
r903 (  204 257 ) resistor r=592.245 //w=0.094 //l=1.155 //layer=ply \
 //thickness=0.18 //x=96.06 //y=6.205 //x2=96.06 //y2=5.05
r904 (  203 290 ) resistor r=592.245 //w=0.094 //l=1.155 //layer=ply \
 //thickness=0.18 //x=95.62 //y=6.205 //x2=95.62 //y2=5.05
r905 (  202 238 ) resistor r=592.245 //w=0.094 //l=1.155 //layer=ply \
 //thickness=0.18 //x=89.4 //y=6.205 //x2=89.4 //y2=5.05
r906 (  201 228 ) resistor r=592.245 //w=0.094 //l=1.155 //layer=ply \
 //thickness=0.18 //x=88.96 //y=6.205 //x2=88.96 //y2=5.05
r907 (  200 221 ) resistor r=592.245 //w=0.094 //l=1.155 //layer=ply \
 //thickness=0.18 //x=55.15 //y=6.2 //x2=55.15 //y2=5.045
r908 (  199 214 ) resistor r=592.245 //w=0.094 //l=1.155 //layer=ply \
 //thickness=0.18 //x=54.71 //y=6.2 //x2=54.71 //y2=5.045
r909 (  198 254 ) resistor r=56.4043 //w=0.094 //l=0.11 //layer=ply \
 //thickness=0.18 //x=95.88 //y=1.585 //x2=95.99 //y2=1.585
r910 (  198 255 ) resistor r=56.4043 //w=0.094 //l=0.11 //layer=ply \
 //thickness=0.18 //x=95.88 //y=1.585 //x2=95.77 //y2=1.585
r911 (  197 235 ) resistor r=56.4043 //w=0.094 //l=0.11 //layer=ply \
 //thickness=0.18 //x=89.22 //y=1.585 //x2=89.33 //y2=1.585
r912 (  197 236 ) resistor r=56.4043 //w=0.094 //l=0.11 //layer=ply \
 //thickness=0.18 //x=89.22 //y=1.585 //x2=89.11 //y2=1.585
r913 (  196 211 ) resistor r=56.4043 //w=0.094 //l=0.11 //layer=ply \
 //thickness=0.18 //x=54.475 //y=1.555 //x2=54.585 //y2=1.555
r914 (  196 212 ) resistor r=56.4043 //w=0.094 //l=0.11 //layer=ply \
 //thickness=0.18 //x=54.475 //y=1.555 //x2=54.365 //y2=1.555
r915 (  192 287 ) resistor r=152 //w=0.17 //l=0.17 //layer=licon //count=1 \
 //x=95.6 //y=4.885 //x2=95.6 //y2=4.885
r916 (  183 283 ) resistor r=152 //w=0.17 //l=0.17 //layer=licon //count=1 \
 //x=95.58 //y=2.26 //x2=95.58 //y2=2.26
r917 (  178 275 ) resistor r=152 //w=0.17 //l=0.17 //layer=licon //count=1 \
 //x=88.96 //y=4.885 //x2=88.96 //y2=4.885
r918 (  169 271 ) resistor r=152 //w=0.17 //l=0.17 //layer=licon //count=1 \
 //x=88.92 //y=2.26 //x2=88.92 //y2=2.26
r919 (  164 267 ) resistor r=152 //w=0.17 //l=0.17 //layer=licon //count=1 \
 //x=54.51 //y=4.88 //x2=54.51 //y2=4.88
r920 (  155 265 ) resistor r=152 //w=0.17 //l=0.17 //layer=licon //count=1 \
 //x=54.51 //y=2.26 //x2=54.51 //y2=2.26
r921 (  138 299 ) resistor r=23.615 //w=0.187 //l=0.345 //layer=li \
 //thickness=0.1 //x=51.88 //y=5.56 //x2=51.88 //y2=5.905
r922 (  130 298 ) resistor r=23.615 //w=0.187 //l=0.345 //layer=li \
 //thickness=0.1 //x=51 //y=5.56 //x2=51 //y2=5.905
r923 (  122 297 ) resistor r=23.615 //w=0.187 //l=0.345 //layer=li \
 //thickness=0.1 //x=50.12 //y=5.56 //x2=50.12 //y2=5.905
r924 (  118 119 ) resistor r=0.104807 //w=0.281 //l=0.16 //layer=m2 \
 //thickness=0.36 //x=95.595 //y=4.21 //x2=95.435 //y2=4.21
r925 (  107 116 ) resistor r=0.0974628 //w=0.216 //l=0.181989 //layer=m2 \
 //thickness=0.36 //x=89.08 //y=4.252 //x2=88.92 //y2=4.205
r926 (  107 119 ) resistor r=5.84099 //w=0.136 //l=6.355 //layer=m2 \
 //thickness=0.36 //x=89.08 //y=4.252 //x2=95.435 //y2=4.252
r927 (  104 116 ) resistor r=0.521062 //w=0.216 //l=0.904876 //layer=m2 \
 //thickness=0.36 //x=88.03 //y=4.235 //x2=88.92 //y2=4.205
r928 (  104 105 ) resistor r=0.410305 //w=0.131 //l=0.43 //layer=m2 \
 //thickness=0.36 //x=88.03 //y=4.235 //x2=87.6 //y2=4.235
r929 (  102 105 ) resistor r=0.125 //w=0.17 //l=0.177341 //layer=m2 \
 //thickness=0.36 //x=87.43 //y=4.25 //x2=87.6 //y2=4.235
r930 (  102 103 ) resistor r=1.38836 //w=0.131 //l=1.455 //layer=m2 \
 //thickness=0.36 //x=87.43 //y=4.25 //x2=85.975 //y2=4.25
r931 (  100 103 ) resistor r=0.125 //w=0.17 //l=0.179722 //layer=m2 \
 //thickness=0.36 //x=85.805 //y=4.27 //x2=85.975 //y2=4.25
r932 (  100 101 ) resistor r=0.329198 //w=0.131 //l=0.345 //layer=m2 \
 //thickness=0.36 //x=85.805 //y=4.27 //x2=85.46 //y2=4.27
r933 (  98 101 ) resistor r=0.1875 //w=0.17 //l=0.264811 //layer=m2 \
 //thickness=0.36 //x=85.205 //y=4.25 //x2=85.46 //y2=4.27
r934 (  98 99 ) resistor r=7.74809 //w=0.131 //l=8.12 //layer=m2 \
 //thickness=0.36 //x=85.205 //y=4.25 //x2=77.085 //y2=4.25
r935 (  96 99 ) resistor r=0.125 //w=0.17 //l=0.184391 //layer=m2 \
 //thickness=0.36 //x=76.915 //y=4.28 //x2=77.085 //y2=4.25
r936 (  96 97 ) resistor r=0.329198 //w=0.131 //l=0.345 //layer=m2 \
 //thickness=0.36 //x=76.915 //y=4.28 //x2=76.57 //y2=4.28
r937 (  94 97 ) resistor r=0.1875 //w=0.17 //l=0.269583 //layer=m2 \
 //thickness=0.36 //x=76.315 //y=4.25 //x2=76.57 //y2=4.28
r938 (  94 95 ) resistor r=4.49905 //w=0.131 //l=4.715 //layer=m2 \
 //thickness=0.36 //x=76.315 //y=4.25 //x2=71.6 //y2=4.25
r939 (  92 95 ) resistor r=0.14881 //w=0.189 //l=0.253229 //layer=m2 \
 //thickness=0.36 //x=71.375 //y=4.31 //x2=71.6 //y2=4.25
r940 (  92 93 ) resistor r=0.329198 //w=0.131 //l=0.345 //layer=m2 \
 //thickness=0.36 //x=71.375 //y=4.31 //x2=71.03 //y2=4.31
r941 (  90 93 ) resistor r=3.26389 //w=0.171 //l=4.47998 //layer=m2 \
 //thickness=0.36 //x=66.565 //y=4.28 //x2=71.03 //y2=4.31
r942 (  90 91 ) resistor r=0.329198 //w=0.131 //l=0.345 //layer=m2 \
 //thickness=0.36 //x=66.565 //y=4.28 //x2=66.22 //y2=4.28
r943 (  88 91 ) resistor r=0.1875 //w=0.17 //l=0.269583 //layer=m2 \
 //thickness=0.36 //x=65.965 //y=4.25 //x2=66.22 //y2=4.28
r944 (  88 89 ) resistor r=0.257634 //w=0.131 //l=0.27 //layer=m2 \
 //thickness=0.36 //x=65.965 //y=4.25 //x2=65.695 //y2=4.25
r945 (  87 89 ) resistor r=0.0698411 //w=0.17 //l=0.120208 //layer=m2 \
 //thickness=0.36 //x=65.61 //y=4.165 //x2=65.695 //y2=4.25
r946 (  86 87 ) resistor r=0.19084 //w=0.131 //l=0.2 //layer=m2 \
 //thickness=0.36 //x=65.61 //y=3.965 //x2=65.61 //y2=4.165
r947 (  84 86 ) resistor r=2.82721 //w=0.17 //l=3.85 //layer=m2 \
 //thickness=0.36 //x=61.765 //y=3.9 //x2=65.61 //y2=3.89
r948 (  84 85 ) resistor r=0.329198 //w=0.131 //l=0.345 //layer=m2 \
 //thickness=0.36 //x=61.765 //y=3.9 //x2=61.42 //y2=3.9
r949 (  82 85 ) resistor r=0.1875 //w=0.17 //l=0.264811 //layer=m2 \
 //thickness=0.36 //x=61.165 //y=3.88 //x2=61.42 //y2=3.9
r950 (  82 83 ) resistor r=1.32156 //w=0.131 //l=1.385 //layer=m2 \
 //thickness=0.36 //x=61.165 //y=3.88 //x2=59.78 //y2=3.88
r951 (  80 83 ) resistor r=0.1875 //w=0.17 //l=0.269583 //layer=m2 \
 //thickness=0.36 //x=59.525 //y=3.85 //x2=59.78 //y2=3.88
r952 (  80 81 ) resistor r=0.410305 //w=0.131 //l=0.43 //layer=m2 \
 //thickness=0.36 //x=59.525 //y=3.85 //x2=59.095 //y2=3.85
r953 (  78 81 ) resistor r=0.125 //w=0.17 //l=0.184391 //layer=m2 \
 //thickness=0.36 //x=58.925 //y=3.88 //x2=59.095 //y2=3.85
r954 (  78 79 ) resistor r=1.30725 //w=0.131 //l=1.37 //layer=m2 \
 //thickness=0.36 //x=58.925 //y=3.88 //x2=57.555 //y2=3.88
r955 (  77 79 ) resistor r=0.0698411 //w=0.17 //l=0.120208 //layer=m2 \
 //thickness=0.36 //x=57.47 //y=3.795 //x2=57.555 //y2=3.88
r956 (  76 113 ) resistor r=0.0073411 //w=0.17 //l=0.09 //layer=m2 \
 //thickness=0.36 //x=57.47 //y=3.595 //x2=57.47 //y2=3.505
r957 (  76 77 ) resistor r=0.19084 //w=0.131 //l=0.2 //layer=m2 \
 //thickness=0.36 //x=57.47 //y=3.595 //x2=57.47 //y2=3.795
r958 (  74 113 ) resistor r=0.382353 //w=0.17 //l=0.522494 //layer=m2 \
 //thickness=0.36 //x=56.95 //y=3.5 //x2=57.47 //y2=3.505
r959 (  74 75 ) resistor r=0.415076 //w=0.131 //l=0.435 //layer=m2 \
 //thickness=0.36 //x=56.95 //y=3.5 //x2=56.515 //y2=3.5
r960 (  72 75 ) resistor r=0.125 //w=0.17 //l=0.174929 //layer=m2 \
 //thickness=0.36 //x=56.345 //y=3.51 //x2=56.515 //y2=3.5
r961 (  72 73 ) resistor r=0.324427 //w=0.131 //l=0.34 //layer=m2 \
 //thickness=0.36 //x=56.345 //y=3.51 //x2=56.005 //y2=3.51
r962 (  71 112 ) resistor r=0.607395 //w=0.204 //l=0.99495 //layer=m2 \
 //thickness=0.36 //x=55.49 //y=3.53 //x2=54.505 //y2=3.51
r963 (  70 73 ) resistor r=0.125 //w=0.17 //l=0.179722 //layer=m2 \
 //thickness=0.36 //x=55.835 //y=3.53 //x2=56.005 //y2=3.51
r964 (  70 71 ) resistor r=0.329198 //w=0.131 //l=0.345 //layer=m2 \
 //thickness=0.36 //x=55.835 //y=3.53 //x2=55.49 //y2=3.53
r965 (  69 109 ) resistor r=0.108362 //w=0.251 //l=0.16 //layer=m2 \
 //thickness=0.36 //x=52.815 //y=3.51 //x2=52.655 //y2=3.51
r966 (  68 112 ) resistor r=0.10188 //w=0.204 //l=0.16 //layer=m2 \
 //thickness=0.36 //x=54.345 //y=3.51 //x2=54.505 //y2=3.51
r967 (  68 69 ) resistor r=1.45992 //w=0.131 //l=1.53 //layer=m2 \
 //thickness=0.36 //x=54.345 //y=3.51 //x2=52.815 //y2=3.51
r968 (  67 192 ) resistor r=9.3 //w=0.17 //l=0.17 //layer=mcon //count=1 \
 //x=95.6 //y=4.885 //x2=95.6 //y2=4.885
r969 (  65 183 ) resistor r=9.3 //w=0.17 //l=0.17 //layer=mcon //count=1 \
 //x=95.58 //y=2.26 //x2=95.58 //y2=2.26
r970 (  61 118 ) resistor r=4.5 //w=0.15 //l=0.15 //layer=via1 //count=1 \
 //x=95.595 //y=4.21 //x2=95.595 //y2=4.21
r971 (  61 63 ) resistor r=0.0130208 //w=0.384 //l=0.04 //layer=m1 \
 //thickness=0.36 //x=95.535 //y=4.21 //x2=95.535 //y2=4.25
r972 (  57 116 ) resistor r=4.5 //w=0.15 //l=0.15 //layer=via1 //count=1 \
 //x=88.92 //y=4.205 //x2=88.92 //y2=4.205
r973 (  57 59 ) resistor r=0.0149601 //w=0.376 //l=0.045 //layer=m1 \
 //thickness=0.36 //x=88.972 //y=4.205 //x2=88.972 //y2=4.25
r974 (  55 178 ) resistor r=9.3 //w=0.17 //l=0.17 //layer=mcon //count=1 \
 //x=88.96 //y=4.885 //x2=88.96 //y2=4.885
r975 (  53 169 ) resistor r=9.3 //w=0.17 //l=0.17 //layer=mcon //count=1 \
 //x=88.92 //y=2.26 //x2=88.92 //y2=2.26
r976 (  51 164 ) resistor r=9.3 //w=0.17 //l=0.17 //layer=mcon //count=1 \
 //x=54.51 //y=4.88 //x2=54.51 //y2=4.88
r977 (  49 155 ) resistor r=9.3 //w=0.17 //l=0.17 //layer=mcon //count=1 \
 //x=54.51 //y=2.26 //x2=54.51 //y2=2.26
r978 (  45 112 ) resistor r=4.5 //w=0.15 //l=0.15 //layer=via1 //count=1 \
 //x=54.505 //y=3.495 //x2=54.505 //y2=3.495
r979 (  45 47 ) resistor r=0.00494723 //w=0.379 //l=0.015 //layer=m1 \
 //thickness=0.36 //x=54.455 //y=3.495 //x2=54.455 //y2=3.51
r980 (  41 109 ) resistor r=4.5 //w=0.15 //l=0.15 //layer=via1 //count=1 \
 //x=52.655 //y=3.495 //x2=52.655 //y2=3.495
r981 (  41 43 ) resistor r=0.00487013 //w=0.385 //l=0.015 //layer=m1 \
 //thickness=0.36 //x=52.71 //y=3.495 //x2=52.71 //y2=3.51
r982 (  39 295 ) resistor r=9.3 //w=0.17 //l=0.17 //layer=mcon //count=1 \
 //x=52.175 //y=1.19 //x2=52.175 //y2=1.19
r983 (  37 138 ) resistor r=9.3 //w=0.17 //l=0.17 //layer=mcon //count=1 \
 //x=51.88 //y=5.56 //x2=51.88 //y2=5.56
r984 (  34 130 ) resistor r=9.3 //w=0.17 //l=0.17 //layer=mcon //count=1 \
 //x=51 //y=5.56 //x2=51 //y2=5.56
r985 (  32 34 ) resistor r=0.121228 //w=0.232 //l=0.225 //layer=m1 \
 //thickness=0.36 //x=51 //y=5.335 //x2=51 //y2=5.56
r986 (  31 122 ) resistor r=9.3 //w=0.17 //l=0.17 //layer=mcon //count=1 \
 //x=50.12 //y=5.56 //x2=50.12 //y2=5.56
r987 (  29 31 ) resistor r=0.129608 //w=0.217 //l=0.225 //layer=m1 \
 //thickness=0.36 //x=50.122 //y=5.335 //x2=50.122 //y2=5.56
r988 (  28 67 ) resistor r=0.0893515 //w=0.219 //l=0.154677 //layer=m1 \
 //thickness=0.36 //x=95.58 //y=4.74 //x2=95.6 //y2=4.885
r989 (  27 63 ) resistor r=0.0784723 //w=0.384 //l=0.140712 //layer=m1 \
 //thickness=0.36 //x=95.58 //y=4.37 //x2=95.535 //y2=4.25
r990 (  27 28 ) resistor r=0.353053 //w=0.131 //l=0.37 //layer=m1 \
 //thickness=0.36 //x=95.58 //y=4.37 //x2=95.58 //y2=4.74
r991 (  26 61 ) resistor r=0.0914932 //w=0.384 //l=0.181108 //layer=m1 \
 //thickness=0.36 //x=95.58 //y=4.05 //x2=95.535 //y2=4.21
r992 (  25 65 ) resistor r=0.0744285 //w=0.225 //l=0.12 //layer=m1 \
 //thickness=0.36 //x=95.58 //y=2.38 //x2=95.58 //y2=2.26
r993 (  25 26 ) resistor r=1.59351 //w=0.131 //l=1.67 //layer=m1 \
 //thickness=0.36 //x=95.58 //y=2.38 //x2=95.58 //y2=4.05
r994 (  24 55 ) resistor r=0.100665 //w=0.248 //l=0.193972 //layer=m1 \
 //thickness=0.36 //x=88.92 //y=4.71 //x2=88.96 //y2=4.885
r995 (  23 59 ) resistor r=0.0761992 //w=0.376 //l=0.138582 //layer=m1 \
 //thickness=0.36 //x=88.92 //y=4.365 //x2=88.972 //y2=4.25
r996 (  23 24 ) resistor r=0.329198 //w=0.131 //l=0.345 //layer=m1 \
 //thickness=0.36 //x=88.92 //y=4.365 //x2=88.92 //y2=4.71
r997 (  22 57 ) resistor r=0.0911593 //w=0.376 //l=0.184174 //layer=m1 \
 //thickness=0.36 //x=88.92 //y=4.045 //x2=88.972 //y2=4.205
r998 (  21 53 ) resistor r=0.0717383 //w=0.224 //l=0.115 //layer=m1 \
 //thickness=0.36 //x=88.92 //y=2.375 //x2=88.92 //y2=2.26
r999 (  21 22 ) resistor r=1.59351 //w=0.131 //l=1.67 //layer=m1 \
 //thickness=0.36 //x=88.92 //y=2.375 //x2=88.92 //y2=4.045
r1000 (  20 51 ) resistor r=0.0760407 //w=0.238 //l=0.125 //layer=m1 \
 //thickness=0.36 //x=54.51 //y=4.755 //x2=54.51 //y2=4.88
r1001 (  19 47 ) resistor r=0.0863342 //w=0.379 //l=0.170294 //layer=m1 \
 //thickness=0.36 //x=54.51 //y=3.655 //x2=54.455 //y2=3.51
r1002 (  19 20 ) resistor r=1.04962 //w=0.131 //l=1.1 //layer=m1 \
 //thickness=0.36 //x=54.51 //y=3.655 //x2=54.51 //y2=4.755
r1003 (  18 45 ) resistor r=0.0813869 //w=0.379 //l=0.155081 //layer=m1 \
 //thickness=0.36 //x=54.51 //y=3.365 //x2=54.455 //y2=3.495
r1004 (  17 49 ) resistor r=0.0719237 //w=0.222 //l=0.115 //layer=m1 \
 //thickness=0.36 //x=54.51 //y=2.375 //x2=54.51 //y2=2.26
r1005 (  17 18 ) resistor r=0.944656 //w=0.131 //l=0.99 //layer=m1 \
 //thickness=0.36 //x=54.51 //y=2.375 //x2=54.51 //y2=3.365
r1006 (  15 43 ) resistor r=0.0866666 //w=0.385 //l=0.168152 //layer=m1 \
 //thickness=0.36 //x=52.66 //y=3.655 //x2=52.71 //y2=3.51
r1007 (  15 16 ) resistor r=1.52195 //w=0.131 //l=1.595 //layer=m1 \
 //thickness=0.36 //x=52.66 //y=3.655 //x2=52.66 //y2=5.25
r1008 (  14 41 ) resistor r=0.0817965 //w=0.385 //l=0.152971 //layer=m1 \
 //thickness=0.36 //x=52.66 //y=3.365 //x2=52.71 //y2=3.495
r1009 (  13 14 ) resistor r=1.36927 //w=0.131 //l=1.435 //layer=m1 \
 //thickness=0.36 //x=52.66 //y=1.93 //x2=52.66 //y2=3.365
r1010 (  11 13 ) resistor r=0.0698411 //w=0.17 //l=0.120208 //layer=m1 \
 //thickness=0.36 //x=52.575 //y=1.845 //x2=52.66 //y2=1.93
r1011 (  11 12 ) resistor r=0.300573 //w=0.131 //l=0.315 //layer=m1 \
 //thickness=0.36 //x=52.575 //y=1.845 //x2=52.26 //y2=1.845
r1012 (  10 12 ) resistor r=0.0698411 //w=0.17 //l=0.120208 //layer=m1 \
 //thickness=0.36 //x=52.175 //y=1.76 //x2=52.26 //y2=1.845
r1013 (  9 39 ) resistor r=0.0717383 //w=0.224 //l=0.115 //layer=m1 \
 //thickness=0.36 //x=52.175 //y=1.305 //x2=52.175 //y2=1.19
r1014 (  9 10 ) resistor r=0.43416 //w=0.131 //l=0.455 //layer=m1 \
 //thickness=0.36 //x=52.175 //y=1.305 //x2=52.175 //y2=1.76
r1015 (  8 35 ) resistor r=0.0675342 //w=0.23 //l=0.115 //layer=m1 \
 //thickness=0.36 //x=51.995 //y=5.335 //x2=51.88 //y2=5.335
r1016 (  7 16 ) resistor r=0.0698411 //w=0.17 //l=0.120208 //layer=m1 \
 //thickness=0.36 //x=52.575 //y=5.335 //x2=52.66 //y2=5.25
r1017 (  7 8 ) resistor r=0.553435 //w=0.131 //l=0.58 //layer=m1 \
 //thickness=0.36 //x=52.575 //y=5.335 //x2=51.995 //y2=5.335
r1018 (  6 37 ) resistor r=0.00118313 //w=0.23 //layer=m1 //thickness=0.36 \
 //x=51.88 //y=5.56 //x2=51.88 //y2=5.56
r1019 (  5 35 ) resistor r=0.002872 //w=0.34 //l=0.085 //layer=m1 \
 //thickness=0.36 //x=51.88 //y=5.42 //x2=51.88 //y2=5.335
r1020 (  5 6 ) resistor r=0.091623 //w=0.191 //l=0.14 //layer=m1 \
 //thickness=0.36 //x=51.88 //y=5.42 //x2=51.88 //y2=5.56
r1021 (  4 32 ) resistor r=0.0262263 //w=0.232 //l=0.12 //layer=m1 \
 //thickness=0.36 //x=51.12 //y=5.335 //x2=51 //y2=5.335
r1022 (  3 35 ) resistor r=0.0675342 //w=0.23 //l=0.115 //layer=m1 \
 //thickness=0.36 //x=51.765 //y=5.335 //x2=51.88 //y2=5.335
r1023 (  3 4 ) resistor r=0.615458 //w=0.131 //l=0.645 //layer=m1 \
 //thickness=0.36 //x=51.765 //y=5.335 //x2=51.12 //y2=5.335
r1024 (  2 29 ) resistor r=0.0222262 //w=0.217 //l=0.118 //layer=m1 \
 //thickness=0.36 //x=50.24 //y=5.335 //x2=50.122 //y2=5.335
r1025 (  1 32 ) resistor r=0.0262263 //w=0.232 //l=0.12 //layer=m1 \
 //thickness=0.36 //x=50.88 //y=5.335 //x2=51 //y2=5.335
r1026 (  1 2 ) resistor r=0.610687 //w=0.131 //l=0.64 //layer=m1 \
 //thickness=0.36 //x=50.88 //y=5.335 //x2=50.24 //y2=5.335
ends PM_TMRDFFSNRNQNX1\%noxref_22

subckt PM_TMRDFFSNRNQNX1\%Q ( 1 3 4 5 7 8 10 11 12 14 18 21 24 32 35 48 51 52 \
 54 55 64 72 93 94 95 99 100 )
c229 ( 95 0 ) capacitor c=0.009897f //x=95.69 //y=1.085
c230 ( 94 0 ) capacitor c=0.0110388f //x=92.36 //y=1.085
c231 ( 93 0 ) capacitor c=0.0110842f //x=89.03 //y=1.085
c232 ( 72 0 ) capacitor c=0.0265472f //x=95.84 //y=5.56
c233 ( 64 0 ) capacitor c=0.0232072f //x=94.96 //y=5.56
c234 ( 55 0 ) capacitor c=0.0842754f //x=95.715 //y=1.405
c235 ( 54 0 ) capacitor c=0.0257508f //x=95.875 //y=1.405
c236 ( 52 0 ) capacitor c=0.00655817f //x=92.68 //y=1.405
c237 ( 51 0 ) capacitor c=0.0759669f //x=92.42 //y=1.405
c238 ( 48 0 ) capacitor c=0.00222181f //x=89.385 //y=1.405
c239 ( 35 0 ) capacitor c=0.011927f //x=96.32 //y=4.25
c240 ( 32 0 ) capacitor c=0.0151866f //x=96.32 //y=4.25
c241 ( 24 0 ) capacitor c=0.01557f //x=95.837 //y=5.39
c242 ( 21 0 ) capacitor c=0.0155006f //x=94.96 //y=5.39
c243 ( 18 0 ) capacitor c=0.00888844f //x=92.55 //y=1.36
c244 ( 14 0 ) capacitor c=0.00591263f //x=89.22 //y=1.36
c245 ( 12 0 ) capacitor c=0.030072f //x=96.32 //y=5.305
c246 ( 11 0 ) capacitor c=0.0201673f //x=96.32 //y=4.415
c247 ( 10 0 ) capacitor c=0.0973385f //x=96.32 //y=4.095
c248 ( 8 0 ) capacitor c=0.00834076f //x=95.965 //y=1.825
c249 ( 7 0 ) capacitor c=0.0158331f //x=96.235 //y=1.825
c250 ( 5 0 ) capacitor c=0.0117302f //x=96.235 //y=5.39
c251 ( 4 0 ) capacitor c=0.00871794f //x=95.88 //y=1.74
c252 ( 3 0 ) capacitor c=0.00698506f //x=95.88 //y=1.535
c253 ( 1 0 ) capacitor c=0.0116295f //x=95.715 //y=5.39
r254 (  92 93 ) resistor r=13.3953 //w=0.172 //l=0.18 //layer=li \
 //thickness=0.1 //x=89.217 //y=1.36 //x2=89.217 //y2=1.18
r255 (  83 95 ) resistor r=12.3209 //w=0.187 //l=0.18 //layer=li \
 //thickness=0.1 //x=95.88 //y=1.36 //x2=95.88 //y2=1.18
r256 (  72 100 ) resistor r=23.2727 //w=0.187 //l=0.34 //layer=li \
 //thickness=0.1 //x=95.84 //y=5.56 //x2=95.84 //y2=5.9
r257 (  64 99 ) resistor r=23.2727 //w=0.187 //l=0.34 //layer=li \
 //thickness=0.1 //x=94.96 //y=5.56 //x2=94.96 //y2=5.9
r258 (  61 94 ) resistor r=12.3209 //w=0.187 //l=0.18 //layer=li \
 //thickness=0.1 //x=92.55 //y=1.36 //x2=92.55 //y2=1.18
r259 (  54 55 ) resistor r=0.10734 //w=0.281 //l=0.16 //layer=m2 \
 //thickness=0.36 //x=95.875 //y=1.405 //x2=95.715 //y2=1.405
r260 (  52 55 ) resistor r=2.89599 //w=0.131 //l=3.035 //layer=m2 \
 //thickness=0.36 //x=92.68 //y=1.36 //x2=95.715 //y2=1.36
r261 (  50 52 ) resistor r=0.0942778 //w=0.221 //l=0.13 //layer=m2 \
 //thickness=0.36 //x=92.55 //y=1.405 //x2=92.68 //y2=1.405
r262 (  50 51 ) resistor r=0.0942778 //w=0.221 //l=0.13 //layer=m2 \
 //thickness=0.36 //x=92.55 //y=1.405 //x2=92.42 //y2=1.405
r263 (  48 51 ) resistor r=2.89599 //w=0.131 //l=3.035 //layer=m2 \
 //thickness=0.36 //x=89.385 //y=1.36 //x2=92.42 //y2=1.36
r264 (  46 48 ) resistor r=0.10734 //w=0.281 //l=0.16 //layer=m2 \
 //thickness=0.36 //x=89.225 //y=1.405 //x2=89.385 //y2=1.405
r265 (  35 43 ) resistor r=0.0022242 //w=0.281 //l=0.005 //layer=m2 \
 //thickness=0.36 //x=96.32 //y=4.25 //x2=96.32 //y2=4.255
r266 (  34 43 ) resistor r=4.5 //w=0.15 //l=0.15 //layer=via1 //count=1 \
 //x=96.32 //y=4.255 //x2=96.32 //y2=4.255
r267 (  32 34 ) resistor r=0.00166223 //w=0.376 //l=0.005 //layer=m1 \
 //thickness=0.36 //x=96.372 //y=4.25 //x2=96.372 //y2=4.255
r268 (  30 54 ) resistor r=4.5 //w=0.15 //l=0.15 //layer=via1 //count=1 \
 //x=95.875 //y=1.405 //x2=95.875 //y2=1.405
r269 (  28 83 ) resistor r=9.3 //w=0.17 //l=0.17 //layer=mcon //count=1 \
 //x=95.88 //y=1.36 //x2=95.88 //y2=1.36
r270 (  28 30 ) resistor r=0.0163043 //w=0.345 //l=0.045 //layer=m1 \
 //thickness=0.36 //x=95.82 //y=1.36 //x2=95.82 //y2=1.405
r271 (  26 72 ) resistor r=9.3 //w=0.17 //l=0.17 //layer=mcon //count=1 \
 //x=95.84 //y=5.56 //x2=95.84 //y2=5.56
r272 (  24 26 ) resistor r=0.0944444 //w=0.225 //l=0.17 //layer=m1 \
 //thickness=0.36 //x=95.837 //y=5.39 //x2=95.837 //y2=5.56
r273 (  23 64 ) resistor r=9.3 //w=0.17 //l=0.17 //layer=mcon //count=1 \
 //x=94.96 //y=5.56 //x2=94.96 //y2=5.56
r274 (  21 23 ) resistor r=0.0936123 //w=0.227 //l=0.17 //layer=m1 \
 //thickness=0.36 //x=94.96 //y=5.39 //x2=94.96 //y2=5.56
r275 (  20 50 ) resistor r=4.5 //w=0.15 //l=0.15 //layer=via1 //count=1 \
 //x=92.55 //y=1.405 //x2=92.55 //y2=1.405
r276 (  18 61 ) resistor r=9.3 //w=0.17 //l=0.17 //layer=mcon //count=1 \
 //x=92.55 //y=1.36 //x2=92.55 //y2=1.36
r277 (  18 20 ) resistor r=0.0163043 //w=0.345 //l=0.045 //layer=m1 \
 //thickness=0.36 //x=92.49 //y=1.36 //x2=92.49 //y2=1.405
r278 (  16 46 ) resistor r=4.5 //w=0.15 //l=0.15 //layer=via1 //count=1 \
 //x=89.225 //y=1.405 //x2=89.225 //y2=1.405
r279 (  14 92 ) resistor r=9.3 //w=0.17 //l=0.17 //layer=mcon //count=1 \
 //x=89.22 //y=1.36 //x2=89.22 //y2=1.36
r280 (  14 16 ) resistor r=0.0150401 //w=0.374 //l=0.045 //layer=m1 \
 //thickness=0.36 //x=89.275 //y=1.36 //x2=89.275 //y2=1.405
r281 (  11 34 ) resistor r=0.0911593 //w=0.376 //l=0.184174 //layer=m1 \
 //thickness=0.36 //x=96.32 //y=4.415 //x2=96.372 //y2=4.255
r282 (  11 12 ) resistor r=0.849237 //w=0.131 //l=0.89 //layer=m1 \
 //thickness=0.36 //x=96.32 //y=4.415 //x2=96.32 //y2=5.305
r283 (  10 32 ) resistor r=0.0894971 //w=0.376 //l=0.179123 //layer=m1 \
 //thickness=0.36 //x=96.32 //y=4.095 //x2=96.372 //y2=4.25
r284 (  9 10 ) resistor r=2.08492 //w=0.131 //l=2.185 //layer=m1 \
 //thickness=0.36 //x=96.32 //y=1.91 //x2=96.32 //y2=4.095
r285 (  7 9 ) resistor r=0.0698411 //w=0.17 //l=0.120208 //layer=m1 \
 //thickness=0.36 //x=96.235 //y=1.825 //x2=96.32 //y2=1.91
r286 (  7 8 ) resistor r=0.257634 //w=0.131 //l=0.27 //layer=m1 \
 //thickness=0.36 //x=96.235 //y=1.825 //x2=95.965 //y2=1.825
r287 (  6 24 ) resistor r=0.0243946 //w=0.225 //l=0.123 //layer=m1 \
 //thickness=0.36 //x=95.96 //y=5.39 //x2=95.837 //y2=5.39
r288 (  5 12 ) resistor r=0.0698411 //w=0.17 //l=0.120208 //layer=m1 \
 //thickness=0.36 //x=96.235 //y=5.39 //x2=96.32 //y2=5.305
r289 (  5 6 ) resistor r=0.262405 //w=0.131 //l=0.275 //layer=m1 \
 //thickness=0.36 //x=96.235 //y=5.39 //x2=95.96 //y2=5.39
r290 (  4 8 ) resistor r=0.0698411 //w=0.17 //l=0.120208 //layer=m1 \
 //thickness=0.36 //x=95.88 //y=1.74 //x2=95.965 //y2=1.825
r291 (  3 30 ) resistor r=0.0792909 //w=0.345 //l=0.157162 //layer=m1 \
 //thickness=0.36 //x=95.88 //y=1.535 //x2=95.82 //y2=1.405
r292 (  3 4 ) resistor r=0.195611 //w=0.131 //l=0.205 //layer=m1 \
 //thickness=0.36 //x=95.88 //y=1.535 //x2=95.88 //y2=1.74
r293 (  2 21 ) resistor r=0.0249239 //w=0.227 //l=0.125 //layer=m1 \
 //thickness=0.36 //x=95.085 //y=5.39 //x2=94.96 //y2=5.39
r294 (  1 24 ) resistor r=0.0243946 //w=0.225 //l=0.122 //layer=m1 \
 //thickness=0.36 //x=95.715 //y=5.39 //x2=95.837 //y2=5.39
r295 (  1 2 ) resistor r=0.601145 //w=0.131 //l=0.63 //layer=m1 \
 //thickness=0.36 //x=95.715 //y=5.39 //x2=95.085 //y2=5.39
ends PM_TMRDFFSNRNQNX1\%Q

subckt PM_TMRDFFSNRNQNX1\%VDD ( 1 2 149 150 151 153 154 155 159 160 173 225 \
 228 237 247 255 265 283 293 301 311 329 339 347 357 375 385 393 403 421 431 \
 439 449 467 477 485 495 513 523 531 541 559 569 577 587 605 615 623 633 651 \
 661 669 679 697 707 715 725 743 753 761 771 777 789 799 807 817 835 845 853 \
 863 881 891 899 909 927 937 945 955 973 983 991 1001 1019 1029 1037 1047 1053 \
 1088 1103 1110 1115 1120 1125 1130 1135 1140 1145 1150 1155 1160 1165 1170 \
 1175 1180 1185 1190 1195 1196 1197 1198 1199 1200 1201 1202 1203 1204 1205 \
 1206 1207 1208 1209 1210 1211 1212 1213 1214 1215 1216 1217 1218 1219 1220 \
 1221 1222 1223 1224 1225 1226 1227 1228 1229 1230 1231 1232 1233 1234 1235 \
 1236 1237 1238 1239 1240 1241 1242 1243 1244 1245 1246 1247 1248 1249 1250 \
 1251 1252 1253 1254 1255 1256 1257 1258 1259 1260 1261 1262 1263 1264 1265 \
 1266 1267 1268 1269 1270 1271 1272 )
c1402 ( 1272 0 ) capacitor c=0.0424825f //x=89.475 //y=5.205
c1403 ( 1271 0 ) capacitor c=0.0224071f //x=88.595 //y=5.205
c1404 ( 1270 0 ) capacitor c=0.051473f //x=87.725 //y=5.205
c1405 ( 1269 0 ) capacitor c=0.046689f //x=85.845 //y=5.2
c1406 ( 1268 0 ) capacitor c=0.0255621f //x=84.965 //y=5.2
c1407 ( 1267 0 ) capacitor c=0.0256114f //x=84.085 //y=5.2
c1408 ( 1266 0 ) capacitor c=0.0676809f //x=83.215 //y=5.2
c1409 ( 1265 0 ) capacitor c=0.0466891f //x=81.035 //y=5.2
c1410 ( 1264 0 ) capacitor c=0.025617f //x=80.155 //y=5.2
c1411 ( 1263 0 ) capacitor c=0.0256114f //x=79.275 //y=5.2
c1412 ( 1262 0 ) capacitor c=0.0676623f //x=78.405 //y=5.2
c1413 ( 1261 0 ) capacitor c=0.0466891f //x=76.225 //y=5.2
c1414 ( 1260 0 ) capacitor c=0.025617f //x=75.345 //y=5.2
c1415 ( 1259 0 ) capacitor c=0.0256114f //x=74.465 //y=5.2
c1416 ( 1258 0 ) capacitor c=0.0676871f //x=73.595 //y=5.2
c1417 ( 1257 0 ) capacitor c=0.0466891f //x=71.415 //y=5.2
c1418 ( 1256 0 ) capacitor c=0.025617f //x=70.535 //y=5.2
c1419 ( 1255 0 ) capacitor c=0.0256114f //x=69.655 //y=5.2
c1420 ( 1254 0 ) capacitor c=0.0676862f //x=68.785 //y=5.2
c1421 ( 1253 0 ) capacitor c=0.0466891f //x=66.605 //y=5.2
c1422 ( 1252 0 ) capacitor c=0.025617f //x=65.725 //y=5.2
c1423 ( 1251 0 ) capacitor c=0.0256114f //x=64.845 //y=5.2
c1424 ( 1250 0 ) capacitor c=0.0676862f //x=63.975 //y=5.2
c1425 ( 1249 0 ) capacitor c=0.0466891f //x=61.795 //y=5.2
c1426 ( 1248 0 ) capacitor c=0.025617f //x=60.915 //y=5.2
c1427 ( 1247 0 ) capacitor c=0.0256114f //x=60.035 //y=5.2
c1428 ( 1246 0 ) capacitor c=0.0675526f //x=59.165 //y=5.2
c1429 ( 1245 0 ) capacitor c=0.0466891f //x=56.985 //y=5.2
c1430 ( 1244 0 ) capacitor c=0.025617f //x=56.105 //y=5.2
c1431 ( 1243 0 ) capacitor c=0.0256114f //x=55.225 //y=5.2
c1432 ( 1242 0 ) capacitor c=0.0676386f //x=54.355 //y=5.2
c1433 ( 1241 0 ) capacitor c=0.0466891f //x=52.175 //y=5.2
c1434 ( 1240 0 ) capacitor c=0.025617f //x=51.295 //y=5.2
c1435 ( 1239 0 ) capacitor c=0.0256114f //x=50.415 //y=5.2
c1436 ( 1238 0 ) capacitor c=0.0676378f //x=49.545 //y=5.2
c1437 ( 1237 0 ) capacitor c=0.0466891f //x=47.365 //y=5.2
c1438 ( 1236 0 ) capacitor c=0.025617f //x=46.485 //y=5.2
c1439 ( 1235 0 ) capacitor c=0.0256114f //x=45.605 //y=5.2
c1440 ( 1234 0 ) capacitor c=0.0676871f //x=44.735 //y=5.2
c1441 ( 1233 0 ) capacitor c=0.0466891f //x=42.555 //y=5.2
c1442 ( 1232 0 ) capacitor c=0.025617f //x=41.675 //y=5.2
c1443 ( 1231 0 ) capacitor c=0.0256114f //x=40.795 //y=5.2
c1444 ( 1230 0 ) capacitor c=0.0676862f //x=39.925 //y=5.2
c1445 ( 1229 0 ) capacitor c=0.0466891f //x=37.745 //y=5.2
c1446 ( 1228 0 ) capacitor c=0.025617f //x=36.865 //y=5.2
c1447 ( 1227 0 ) capacitor c=0.0256114f //x=35.985 //y=5.2
c1448 ( 1226 0 ) capacitor c=0.0676862f //x=35.115 //y=5.2
c1449 ( 1225 0 ) capacitor c=0.0466891f //x=32.935 //y=5.2
c1450 ( 1224 0 ) capacitor c=0.025617f //x=32.055 //y=5.2
c1451 ( 1223 0 ) capacitor c=0.0256114f //x=31.175 //y=5.2
c1452 ( 1222 0 ) capacitor c=0.0675526f //x=30.305 //y=5.2
c1453 ( 1221 0 ) capacitor c=0.0466891f //x=28.125 //y=5.2
c1454 ( 1220 0 ) capacitor c=0.025617f //x=27.245 //y=5.2
c1455 ( 1219 0 ) capacitor c=0.0256114f //x=26.365 //y=5.2
c1456 ( 1218 0 ) capacitor c=0.0676881f //x=25.495 //y=5.2
c1457 ( 1217 0 ) capacitor c=0.0466891f //x=23.315 //y=5.2
c1458 ( 1216 0 ) capacitor c=0.025617f //x=22.435 //y=5.2
c1459 ( 1215 0 ) capacitor c=0.0256114f //x=21.555 //y=5.2
c1460 ( 1214 0 ) capacitor c=0.0676623f //x=20.685 //y=5.2
c1461 ( 1213 0 ) capacitor c=0.0466891f //x=18.505 //y=5.2
c1462 ( 1212 0 ) capacitor c=0.025617f //x=17.625 //y=5.2
c1463 ( 1211 0 ) capacitor c=0.0256114f //x=16.745 //y=5.2
c1464 ( 1210 0 ) capacitor c=0.0677138f //x=15.875 //y=5.2
c1465 ( 1209 0 ) capacitor c=0.0466891f //x=13.695 //y=5.2
c1466 ( 1208 0 ) capacitor c=0.025617f //x=12.815 //y=5.2
c1467 ( 1207 0 ) capacitor c=0.0256114f //x=11.935 //y=5.2
c1468 ( 1206 0 ) capacitor c=0.0676529f //x=11.065 //y=5.2
c1469 ( 1205 0 ) capacitor c=0.0466891f //x=8.885 //y=5.2
c1470 ( 1204 0 ) capacitor c=0.025617f //x=8.005 //y=5.2
c1471 ( 1203 0 ) capacitor c=0.0256114f //x=7.125 //y=5.2
c1472 ( 1202 0 ) capacitor c=0.0677384f //x=6.255 //y=5.2
c1473 ( 1201 0 ) capacitor c=0.0466891f //x=4.075 //y=5.2
c1474 ( 1200 0 ) capacitor c=0.025617f //x=3.195 //y=5.2
c1475 ( 1199 0 ) capacitor c=0.0256114f //x=2.315 //y=5.2
c1476 ( 1198 0 ) capacitor c=0.0693239f //x=1.445 //y=5.2
c1477 ( 1197 0 ) capacitor c=0.121201f //x=93.73 //y=7.585
c1478 ( 1196 0 ) capacitor c=0.125977f //x=90.4 //y=7.585
c1479 ( 1195 0 ) capacitor c=0.140972f //x=87.07 //y=7.585
c1480 ( 1194 0 ) capacitor c=0.00597439f //x=85.99 //y=7.585
c1481 ( 1193 0 ) capacitor c=0.00597439f //x=85.11 //y=7.585
c1482 ( 1192 0 ) capacitor c=0.00597439f //x=84.23 //y=7.585
c1483 ( 1191 0 ) capacitor c=0.00597439f //x=83.35 //y=7.585
c1484 ( 1190 0 ) capacitor c=0.163341f //x=82.26 //y=7.585
c1485 ( 1189 0 ) capacitor c=0.00597439f //x=81.18 //y=7.585
c1486 ( 1188 0 ) capacitor c=0.00597439f //x=80.3 //y=7.585
c1487 ( 1187 0 ) capacitor c=0.00597439f //x=79.42 //y=7.585
c1488 ( 1186 0 ) capacitor c=0.00597439f //x=78.54 //y=7.585
c1489 ( 1185 0 ) capacitor c=0.163341f //x=77.45 //y=7.585
c1490 ( 1184 0 ) capacitor c=0.00597439f //x=76.37 //y=7.585
c1491 ( 1183 0 ) capacitor c=0.00597439f //x=75.49 //y=7.585
c1492 ( 1182 0 ) capacitor c=0.00597439f //x=74.61 //y=7.585
c1493 ( 1181 0 ) capacitor c=0.00597439f //x=73.73 //y=7.585
c1494 ( 1180 0 ) capacitor c=0.161213f //x=72.64 //y=7.585
c1495 ( 1179 0 ) capacitor c=0.00597439f //x=71.56 //y=7.585
c1496 ( 1178 0 ) capacitor c=0.00597439f //x=70.68 //y=7.585
c1497 ( 1177 0 ) capacitor c=0.00597439f //x=69.8 //y=7.585
c1498 ( 1176 0 ) capacitor c=0.00597439f //x=68.92 //y=7.585
c1499 ( 1175 0 ) capacitor c=0.163472f //x=67.83 //y=7.585
c1500 ( 1174 0 ) capacitor c=0.00597439f //x=66.75 //y=7.585
c1501 ( 1173 0 ) capacitor c=0.00597439f //x=65.87 //y=7.585
c1502 ( 1172 0 ) capacitor c=0.00597439f //x=64.99 //y=7.585
c1503 ( 1171 0 ) capacitor c=0.00597439f //x=64.11 //y=7.585
c1504 ( 1170 0 ) capacitor c=0.162707f //x=63.02 //y=7.585
c1505 ( 1169 0 ) capacitor c=0.00597439f //x=61.94 //y=7.585
c1506 ( 1168 0 ) capacitor c=0.00597439f //x=61.06 //y=7.585
c1507 ( 1167 0 ) capacitor c=0.00597439f //x=60.18 //y=7.585
c1508 ( 1166 0 ) capacitor c=0.00597439f //x=59.3 //y=7.585
c1509 ( 1165 0 ) capacitor c=0.162704f //x=58.21 //y=7.585
c1510 ( 1164 0 ) capacitor c=0.00597439f //x=57.13 //y=7.585
c1511 ( 1163 0 ) capacitor c=0.00597439f //x=56.25 //y=7.585
c1512 ( 1162 0 ) capacitor c=0.00597439f //x=55.37 //y=7.585
c1513 ( 1161 0 ) capacitor c=0.00597439f //x=54.49 //y=7.585
c1514 ( 1160 0 ) capacitor c=0.163472f //x=53.4 //y=7.585
c1515 ( 1159 0 ) capacitor c=0.00597439f //x=52.32 //y=7.585
c1516 ( 1158 0 ) capacitor c=0.00597439f //x=51.44 //y=7.585
c1517 ( 1157 0 ) capacitor c=0.00597439f //x=50.56 //y=7.585
c1518 ( 1156 0 ) capacitor c=0.00597439f //x=49.68 //y=7.585
c1519 ( 1155 0 ) capacitor c=0.163472f //x=48.59 //y=7.585
c1520 ( 1154 0 ) capacitor c=0.00597439f //x=47.51 //y=7.585
c1521 ( 1153 0 ) capacitor c=0.00597439f //x=46.63 //y=7.585
c1522 ( 1152 0 ) capacitor c=0.00597439f //x=45.75 //y=7.585
c1523 ( 1151 0 ) capacitor c=0.00597439f //x=44.87 //y=7.585
c1524 ( 1150 0 ) capacitor c=0.161197f //x=43.78 //y=7.585
c1525 ( 1149 0 ) capacitor c=0.00597439f //x=42.7 //y=7.585
c1526 ( 1148 0 ) capacitor c=0.00597439f //x=41.82 //y=7.585
c1527 ( 1147 0 ) capacitor c=0.00597439f //x=40.94 //y=7.585
c1528 ( 1146 0 ) capacitor c=0.00597439f //x=40.06 //y=7.585
c1529 ( 1145 0 ) capacitor c=0.163472f //x=38.97 //y=7.585
c1530 ( 1144 0 ) capacitor c=0.00597439f //x=37.89 //y=7.585
c1531 ( 1143 0 ) capacitor c=0.00597439f //x=37.01 //y=7.585
c1532 ( 1142 0 ) capacitor c=0.00597439f //x=36.13 //y=7.585
c1533 ( 1141 0 ) capacitor c=0.00597439f //x=35.25 //y=7.585
c1534 ( 1140 0 ) capacitor c=0.161286f //x=34.16 //y=7.585
c1535 ( 1139 0 ) capacitor c=0.00597439f //x=33.08 //y=7.585
c1536 ( 1138 0 ) capacitor c=0.00597439f //x=32.2 //y=7.585
c1537 ( 1137 0 ) capacitor c=0.00597439f //x=31.32 //y=7.585
c1538 ( 1136 0 ) capacitor c=0.00597439f //x=30.44 //y=7.585
c1539 ( 1135 0 ) capacitor c=0.162814f //x=29.35 //y=7.585
c1540 ( 1134 0 ) capacitor c=0.00597439f //x=28.27 //y=7.585
c1541 ( 1133 0 ) capacitor c=0.00597439f //x=27.39 //y=7.585
c1542 ( 1132 0 ) capacitor c=0.00597439f //x=26.51 //y=7.585
c1543 ( 1131 0 ) capacitor c=0.00597439f //x=25.63 //y=7.585
c1544 ( 1130 0 ) capacitor c=0.160993f //x=24.54 //y=7.585
c1545 ( 1129 0 ) capacitor c=0.00597439f //x=23.46 //y=7.585
c1546 ( 1128 0 ) capacitor c=0.00597439f //x=22.58 //y=7.585
c1547 ( 1127 0 ) capacitor c=0.00597439f //x=21.7 //y=7.585
c1548 ( 1126 0 ) capacitor c=0.00597439f //x=20.82 //y=7.585
c1549 ( 1125 0 ) capacitor c=0.163341f //x=19.73 //y=7.585
c1550 ( 1124 0 ) capacitor c=0.00597439f //x=18.65 //y=7.585
c1551 ( 1123 0 ) capacitor c=0.00597439f //x=17.77 //y=7.585
c1552 ( 1122 0 ) capacitor c=0.00597439f //x=16.89 //y=7.585
c1553 ( 1121 0 ) capacitor c=0.00597439f //x=16.01 //y=7.585
c1554 ( 1120 0 ) capacitor c=0.163341f //x=14.92 //y=7.585
c1555 ( 1119 0 ) capacitor c=0.00597439f //x=13.84 //y=7.585
c1556 ( 1118 0 ) capacitor c=0.00597439f //x=12.96 //y=7.585
c1557 ( 1117 0 ) capacitor c=0.00597439f //x=12.08 //y=7.585
c1558 ( 1116 0 ) capacitor c=0.00597439f //x=11.2 //y=7.585
c1559 ( 1115 0 ) capacitor c=0.163341f //x=10.11 //y=7.585
c1560 ( 1114 0 ) capacitor c=0.00597439f //x=9.03 //y=7.585
c1561 ( 1113 0 ) capacitor c=0.00597439f //x=8.15 //y=7.585
c1562 ( 1112 0 ) capacitor c=0.00597439f //x=7.27 //y=7.585
c1563 ( 1111 0 ) capacitor c=0.00597439f //x=6.39 //y=7.585
c1564 ( 1110 0 ) capacitor c=0.163259f //x=5.3 //y=7.585
c1565 ( 1109 0 ) capacitor c=0.00597439f //x=4.22 //y=7.585
c1566 ( 1108 0 ) capacitor c=0.00597439f //x=3.34 //y=7.585
c1567 ( 1107 0 ) capacitor c=0.00597439f //x=2.46 //y=7.585
c1568 ( 1106 0 ) capacitor c=0.00597439f //x=1.58 //y=7.585
c1569 ( 1103 0 ) capacitor c=0.366847f //x=96.32 //y=7.58
c1570 ( 1088 0 ) capacitor c=0.131873f //x=93.56 //y=7.585
c1571 ( 1053 0 ) capacitor c=0.133054f //x=90.23 //y=7.585
c1572 ( 1047 0 ) capacitor c=0.042257f //x=86.9 //y=7.585
c1573 ( 1037 0 ) capacitor c=0.0288858f //x=85.905 //y=7.585
c1574 ( 1029 0 ) capacitor c=0.0289326f //x=85.025 //y=7.585
c1575 ( 1019 0 ) capacitor c=0.0290299f //x=84.145 //y=7.585
c1576 ( 1007 0 ) capacitor c=0.0455283f //x=83.265 //y=7.585
c1577 ( 1001 0 ) capacitor c=0.042257f //x=82.09 //y=7.585
c1578 ( 991 0 ) capacitor c=0.0288858f //x=81.095 //y=7.585
c1579 ( 983 0 ) capacitor c=0.0289326f //x=80.215 //y=7.585
c1580 ( 973 0 ) capacitor c=0.0290299f //x=79.335 //y=7.585
c1581 ( 961 0 ) capacitor c=0.0455283f //x=78.455 //y=7.585
c1582 ( 955 0 ) capacitor c=0.042257f //x=77.28 //y=7.585
c1583 ( 945 0 ) capacitor c=0.0288858f //x=76.285 //y=7.585
c1584 ( 937 0 ) capacitor c=0.0289326f //x=75.405 //y=7.585
c1585 ( 927 0 ) capacitor c=0.0286631f //x=74.525 //y=7.585
c1586 ( 915 0 ) capacitor c=0.0386886f //x=73.645 //y=7.585
c1587 ( 909 0 ) capacitor c=0.038209f //x=72.47 //y=7.585
c1588 ( 899 0 ) capacitor c=0.0288858f //x=71.475 //y=7.585
c1589 ( 891 0 ) capacitor c=0.0289326f //x=70.595 //y=7.585
c1590 ( 881 0 ) capacitor c=0.0286631f //x=69.715 //y=7.585
c1591 ( 869 0 ) capacitor c=0.0386886f //x=68.835 //y=7.585
c1592 ( 863 0 ) capacitor c=0.038209f //x=67.66 //y=7.585
c1593 ( 853 0 ) capacitor c=0.0288858f //x=66.665 //y=7.585
c1594 ( 845 0 ) capacitor c=0.0289326f //x=65.785 //y=7.585
c1595 ( 835 0 ) capacitor c=0.0286631f //x=64.905 //y=7.585
c1596 ( 823 0 ) capacitor c=0.0386886f //x=64.025 //y=7.585
c1597 ( 817 0 ) capacitor c=0.038209f //x=62.85 //y=7.585
c1598 ( 807 0 ) capacitor c=0.0288858f //x=61.855 //y=7.585
c1599 ( 799 0 ) capacitor c=0.0289326f //x=60.975 //y=7.585
c1600 ( 789 0 ) capacitor c=0.0287304f //x=60.095 //y=7.585
c1601 ( 777 0 ) capacitor c=0.0386886f //x=59.215 //y=7.585
c1602 ( 771 0 ) capacitor c=0.038209f //x=58.04 //y=7.585
c1603 ( 761 0 ) capacitor c=0.0288858f //x=57.045 //y=7.585
c1604 ( 753 0 ) capacitor c=0.0289326f //x=56.165 //y=7.585
c1605 ( 743 0 ) capacitor c=0.0286631f //x=55.285 //y=7.585
c1606 ( 731 0 ) capacitor c=0.0386886f //x=54.405 //y=7.585
c1607 ( 725 0 ) capacitor c=0.038209f //x=53.23 //y=7.585
c1608 ( 715 0 ) capacitor c=0.0288858f //x=52.235 //y=7.585
c1609 ( 707 0 ) capacitor c=0.0289326f //x=51.355 //y=7.585
c1610 ( 697 0 ) capacitor c=0.0286631f //x=50.475 //y=7.585
c1611 ( 685 0 ) capacitor c=0.0386886f //x=49.595 //y=7.585
c1612 ( 679 0 ) capacitor c=0.038209f //x=48.42 //y=7.585
c1613 ( 669 0 ) capacitor c=0.0288858f //x=47.425 //y=7.585
c1614 ( 661 0 ) capacitor c=0.0289326f //x=46.545 //y=7.585
c1615 ( 651 0 ) capacitor c=0.0286631f //x=45.665 //y=7.585
c1616 ( 639 0 ) capacitor c=0.0386886f //x=44.785 //y=7.585
c1617 ( 633 0 ) capacitor c=0.038209f //x=43.61 //y=7.585
c1618 ( 623 0 ) capacitor c=0.0288858f //x=42.615 //y=7.585
c1619 ( 615 0 ) capacitor c=0.0289326f //x=41.735 //y=7.585
c1620 ( 605 0 ) capacitor c=0.0286631f //x=40.855 //y=7.585
c1621 ( 593 0 ) capacitor c=0.0386886f //x=39.975 //y=7.585
c1622 ( 587 0 ) capacitor c=0.038209f //x=38.8 //y=7.585
c1623 ( 577 0 ) capacitor c=0.0288858f //x=37.805 //y=7.585
c1624 ( 569 0 ) capacitor c=0.0289326f //x=36.925 //y=7.585
c1625 ( 559 0 ) capacitor c=0.0286631f //x=36.045 //y=7.585
c1626 ( 547 0 ) capacitor c=0.0386886f //x=35.165 //y=7.585
c1627 ( 541 0 ) capacitor c=0.038209f //x=33.99 //y=7.585
c1628 ( 531 0 ) capacitor c=0.0288858f //x=32.995 //y=7.585
c1629 ( 523 0 ) capacitor c=0.0289326f //x=32.115 //y=7.585
c1630 ( 513 0 ) capacitor c=0.0286631f //x=31.235 //y=7.585
c1631 ( 501 0 ) capacitor c=0.0386886f //x=30.355 //y=7.585
c1632 ( 495 0 ) capacitor c=0.038209f //x=29.18 //y=7.585
c1633 ( 485 0 ) capacitor c=0.0288858f //x=28.185 //y=7.585
c1634 ( 477 0 ) capacitor c=0.0289326f //x=27.305 //y=7.585
c1635 ( 467 0 ) capacitor c=0.0286631f //x=26.425 //y=7.585
c1636 ( 455 0 ) capacitor c=0.0386886f //x=25.545 //y=7.585
c1637 ( 449 0 ) capacitor c=0.0390964f //x=24.37 //y=7.585
c1638 ( 439 0 ) capacitor c=0.0288858f //x=23.375 //y=7.585
c1639 ( 431 0 ) capacitor c=0.0289326f //x=22.495 //y=7.585
c1640 ( 421 0 ) capacitor c=0.0290299f //x=21.615 //y=7.585
c1641 ( 409 0 ) capacitor c=0.0455283f //x=20.735 //y=7.585
c1642 ( 403 0 ) capacitor c=0.042257f //x=19.56 //y=7.585
c1643 ( 393 0 ) capacitor c=0.0288858f //x=18.565 //y=7.585
c1644 ( 385 0 ) capacitor c=0.0289326f //x=17.685 //y=7.585
c1645 ( 375 0 ) capacitor c=0.0290299f //x=16.805 //y=7.585
c1646 ( 363 0 ) capacitor c=0.0455283f //x=15.925 //y=7.585
c1647 ( 357 0 ) capacitor c=0.042257f //x=14.75 //y=7.585
c1648 ( 347 0 ) capacitor c=0.0288858f //x=13.755 //y=7.585
c1649 ( 339 0 ) capacitor c=0.0289326f //x=12.875 //y=7.585
c1650 ( 329 0 ) capacitor c=0.0290299f //x=11.995 //y=7.585
c1651 ( 317 0 ) capacitor c=0.0455283f //x=11.115 //y=7.585
c1652 ( 311 0 ) capacitor c=0.042257f //x=9.94 //y=7.585
c1653 ( 301 0 ) capacitor c=0.0288858f //x=8.945 //y=7.585
c1654 ( 293 0 ) capacitor c=0.0289326f //x=8.065 //y=7.585
c1655 ( 283 0 ) capacitor c=0.0290299f //x=7.185 //y=7.585
c1656 ( 271 0 ) capacitor c=0.0455283f //x=6.305 //y=7.585
c1657 ( 265 0 ) capacitor c=0.042257f //x=5.13 //y=7.585
c1658 ( 255 0 ) capacitor c=0.0288858f //x=4.135 //y=7.585
c1659 ( 247 0 ) capacitor c=0.0289326f //x=3.255 //y=7.585
c1660 ( 237 0 ) capacitor c=0.029074f //x=2.375 //y=7.585
c1661 ( 228 0 ) capacitor c=0.25352f //x=1.23 //y=7.58
c1662 ( 225 0 ) capacitor c=0.0445047f //x=1.495 //y=7.585
c1663 ( 220 0 ) capacitor c=0.00499323f //x=89.62 //y=7.585
c1664 ( 217 0 ) capacitor c=0.00499323f //x=88.74 //y=7.585
c1665 ( 212 0 ) capacitor c=0.00499323f //x=87.81 //y=7.58
c1666 ( 173 0 ) capacitor c=0.268865f //x=96.32 //y=7.58
c1667 ( 160 0 ) capacitor c=0.00657976f //x=89.62 //y=7.41
c1668 ( 159 0 ) capacitor c=0.00827249f //x=89.62 //y=7.035
c1669 ( 155 0 ) capacitor c=0.0220779f //x=89.535 //y=7.585
c1670 ( 154 0 ) capacitor c=0.00369726f //x=88.74 //y=7.41
c1671 ( 153 0 ) capacitor c=0.00650208f //x=88.74 //y=7.035
c1672 ( 151 0 ) capacitor c=0.02242f //x=88.655 //y=7.585
c1673 ( 150 0 ) capacitor c=0.0090067f //x=87.86 //y=7.41
c1674 ( 149 0 ) capacitor c=0.0125184f //x=87.86 //y=7.035
c1675 ( 2 0 ) capacitor c=3.14246f //x=87.775 //y=7.585
r1676 (  1101 1103 ) resistor r=38.7139 //w=0.367 //l=1.11 //layer=li \
 //thickness=0.1 //x=95.21 //y=7.585 //x2=96.32 //y2=7.585
r1677 (  1099 1101 ) resistor r=38.7139 //w=0.367 //l=1.11 //layer=li \
 //thickness=0.1 //x=94.1 //y=7.585 //x2=95.21 //y2=7.585
r1678 (  1097 1197 ) resistor r=5.29055 //w=0.35 //l=0.17 //layer=li \
 //thickness=0.1 //x=93.9 //y=7.585 //x2=93.73 //y2=7.585
r1679 (  1097 1099 ) resistor r=6.97548 //w=0.367 //l=0.2 //layer=li \
 //thickness=0.1 //x=93.9 //y=7.585 //x2=94.1 //y2=7.585
r1680 (  1091 1093 ) resistor r=38.7139 //w=0.367 //l=1.11 //layer=li \
 //thickness=0.1 //x=91.51 //y=7.585 //x2=92.62 //y2=7.585
r1681 (  1089 1196 ) resistor r=5.29055 //w=0.35 //l=0.17 //layer=li \
 //thickness=0.1 //x=90.57 //y=7.585 //x2=90.4 //y2=7.585
r1682 (  1089 1091 ) resistor r=32.7847 //w=0.367 //l=0.94 //layer=li \
 //thickness=0.1 //x=90.57 //y=7.585 //x2=91.51 //y2=7.585
r1683 (  1088 1197 ) resistor r=5.29055 //w=0.35 //l=0.17 //layer=li \
 //thickness=0.1 //x=93.56 //y=7.585 //x2=93.73 //y2=7.585
r1684 (  1088 1093 ) resistor r=32.7847 //w=0.367 //l=0.94 //layer=li \
 //thickness=0.1 //x=93.56 //y=7.585 //x2=92.62 //y2=7.585
r1685 (  1084 1272 ) resistor r=23.2727 //w=0.187 //l=0.34 //layer=li \
 //thickness=0.1 //x=89.62 //y=6.92 //x2=89.62 //y2=6.58
r1686 (  1069 1270 ) resistor r=23.2727 //w=0.187 //l=0.34 //layer=li \
 //thickness=0.1 //x=87.86 //y=6.92 //x2=87.86 //y2=6.58
r1687 (  1058 1060 ) resistor r=38.7139 //w=0.367 //l=1.11 //layer=li \
 //thickness=0.1 //x=88.92 //y=7.585 //x2=90.03 //y2=7.585
r1688 (  1056 1058 ) resistor r=38.7139 //w=0.367 //l=1.11 //layer=li \
 //thickness=0.1 //x=87.81 //y=7.585 //x2=88.92 //y2=7.585
r1689 (  1054 1195 ) resistor r=5.29055 //w=0.35 //l=0.17 //layer=li \
 //thickness=0.1 //x=87.24 //y=7.585 //x2=87.07 //y2=7.585
r1690 (  1054 1056 ) resistor r=19.8801 //w=0.367 //l=0.57 //layer=li \
 //thickness=0.1 //x=87.24 //y=7.585 //x2=87.81 //y2=7.585
r1691 (  1053 1196 ) resistor r=5.29055 //w=0.35 //l=0.17 //layer=li \
 //thickness=0.1 //x=90.23 //y=7.585 //x2=90.4 //y2=7.585
r1692 (  1053 1060 ) resistor r=6.97548 //w=0.367 //l=0.2 //layer=li \
 //thickness=0.1 //x=90.23 //y=7.585 //x2=90.03 //y2=7.585
r1693 (  1048 1194 ) resistor r=2.87058 //w=0.35 //l=0.085 //layer=li \
 //thickness=0.1 //x=86.075 //y=7.585 //x2=85.99 //y2=7.585
r1694 (  1048 1050 ) resistor r=8.89373 //w=0.367 //l=0.255 //layer=li \
 //thickness=0.1 //x=86.075 //y=7.585 //x2=86.33 //y2=7.585
r1695 (  1047 1195 ) resistor r=5.29055 //w=0.35 //l=0.17 //layer=li \
 //thickness=0.1 //x=86.9 //y=7.585 //x2=87.07 //y2=7.585
r1696 (  1047 1050 ) resistor r=19.8801 //w=0.367 //l=0.57 //layer=li \
 //thickness=0.1 //x=86.9 //y=7.585 //x2=86.33 //y2=7.585
r1697 (  1041 1194 ) resistor r=4.23183 //w=0.7 //l=0.175 //layer=li \
 //thickness=0.1 //x=85.99 //y=7.41 //x2=85.99 //y2=7.585
r1698 (  1041 1269 ) resistor r=33.1979 //w=0.187 //l=0.485 //layer=li \
 //thickness=0.1 //x=85.99 //y=7.41 //x2=85.99 //y2=6.925
r1699 (  1038 1193 ) resistor r=2.87058 //w=0.35 //l=0.085 //layer=li \
 //thickness=0.1 //x=85.195 //y=7.585 //x2=85.11 //y2=7.585
r1700 (  1038 1040 ) resistor r=0.871935 //w=0.367 //l=0.025 //layer=li \
 //thickness=0.1 //x=85.195 //y=7.585 //x2=85.22 //y2=7.585
r1701 (  1037 1194 ) resistor r=2.87058 //w=0.35 //l=0.085 //layer=li \
 //thickness=0.1 //x=85.905 //y=7.585 //x2=85.99 //y2=7.585
r1702 (  1037 1040 ) resistor r=23.891 //w=0.367 //l=0.685 //layer=li \
 //thickness=0.1 //x=85.905 //y=7.585 //x2=85.22 //y2=7.585
r1703 (  1031 1193 ) resistor r=4.23183 //w=0.7 //l=0.175 //layer=li \
 //thickness=0.1 //x=85.11 //y=7.41 //x2=85.11 //y2=7.585
r1704 (  1031 1268 ) resistor r=33.1979 //w=0.187 //l=0.485 //layer=li \
 //thickness=0.1 //x=85.11 //y=7.41 //x2=85.11 //y2=6.925
r1705 (  1030 1192 ) resistor r=2.87058 //w=0.35 //l=0.085 //layer=li \
 //thickness=0.1 //x=84.315 //y=7.585 //x2=84.23 //y2=7.585
r1706 (  1029 1193 ) resistor r=2.87058 //w=0.35 //l=0.085 //layer=li \
 //thickness=0.1 //x=85.025 //y=7.585 //x2=85.11 //y2=7.585
r1707 (  1029 1030 ) resistor r=24.7629 //w=0.367 //l=0.71 //layer=li \
 //thickness=0.1 //x=85.025 //y=7.585 //x2=84.315 //y2=7.585
r1708 (  1023 1192 ) resistor r=4.23183 //w=0.7 //l=0.175 //layer=li \
 //thickness=0.1 //x=84.23 //y=7.41 //x2=84.23 //y2=7.585
r1709 (  1023 1267 ) resistor r=33.1979 //w=0.187 //l=0.485 //layer=li \
 //thickness=0.1 //x=84.23 //y=7.41 //x2=84.23 //y2=6.925
r1710 (  1020 1191 ) resistor r=2.87058 //w=0.35 //l=0.085 //layer=li \
 //thickness=0.1 //x=83.435 //y=7.585 //x2=83.35 //y2=7.585
r1711 (  1020 1022 ) resistor r=23.5422 //w=0.367 //l=0.675 //layer=li \
 //thickness=0.1 //x=83.435 //y=7.585 //x2=84.11 //y2=7.585
r1712 (  1019 1192 ) resistor r=2.87058 //w=0.35 //l=0.085 //layer=li \
 //thickness=0.1 //x=84.145 //y=7.585 //x2=84.23 //y2=7.585
r1713 (  1019 1022 ) resistor r=1.22071 //w=0.367 //l=0.035 //layer=li \
 //thickness=0.1 //x=84.145 //y=7.585 //x2=84.11 //y2=7.585
r1714 (  1011 1191 ) resistor r=4.23183 //w=0.7 //l=0.175 //layer=li \
 //thickness=0.1 //x=83.35 //y=7.41 //x2=83.35 //y2=7.585
r1715 (  1011 1266 ) resistor r=56.4706 //w=0.187 //l=0.825 //layer=li \
 //thickness=0.1 //x=83.35 //y=7.41 //x2=83.35 //y2=6.585
r1716 (  1008 1190 ) resistor r=5.29055 //w=0.35 //l=0.17 //layer=li \
 //thickness=0.1 //x=82.43 //y=7.585 //x2=82.26 //y2=7.585
r1717 (  1008 1010 ) resistor r=19.8801 //w=0.367 //l=0.57 //layer=li \
 //thickness=0.1 //x=82.43 //y=7.585 //x2=83 //y2=7.585
r1718 (  1007 1191 ) resistor r=2.87058 //w=0.35 //l=0.085 //layer=li \
 //thickness=0.1 //x=83.265 //y=7.585 //x2=83.35 //y2=7.585
r1719 (  1007 1010 ) resistor r=9.24251 //w=0.367 //l=0.265 //layer=li \
 //thickness=0.1 //x=83.265 //y=7.585 //x2=83 //y2=7.585
r1720 (  1002 1189 ) resistor r=2.87058 //w=0.35 //l=0.085 //layer=li \
 //thickness=0.1 //x=81.265 //y=7.585 //x2=81.18 //y2=7.585
r1721 (  1002 1004 ) resistor r=8.89373 //w=0.367 //l=0.255 //layer=li \
 //thickness=0.1 //x=81.265 //y=7.585 //x2=81.52 //y2=7.585
r1722 (  1001 1190 ) resistor r=5.29055 //w=0.35 //l=0.17 //layer=li \
 //thickness=0.1 //x=82.09 //y=7.585 //x2=82.26 //y2=7.585
r1723 (  1001 1004 ) resistor r=19.8801 //w=0.367 //l=0.57 //layer=li \
 //thickness=0.1 //x=82.09 //y=7.585 //x2=81.52 //y2=7.585
r1724 (  995 1189 ) resistor r=4.23183 //w=0.7 //l=0.175 //layer=li \
 //thickness=0.1 //x=81.18 //y=7.41 //x2=81.18 //y2=7.585
r1725 (  995 1265 ) resistor r=33.1979 //w=0.187 //l=0.485 //layer=li \
 //thickness=0.1 //x=81.18 //y=7.41 //x2=81.18 //y2=6.925
r1726 (  992 1188 ) resistor r=2.87058 //w=0.35 //l=0.085 //layer=li \
 //thickness=0.1 //x=80.385 //y=7.585 //x2=80.3 //y2=7.585
r1727 (  992 994 ) resistor r=0.871935 //w=0.367 //l=0.025 //layer=li \
 //thickness=0.1 //x=80.385 //y=7.585 //x2=80.41 //y2=7.585
r1728 (  991 1189 ) resistor r=2.87058 //w=0.35 //l=0.085 //layer=li \
 //thickness=0.1 //x=81.095 //y=7.585 //x2=81.18 //y2=7.585
r1729 (  991 994 ) resistor r=23.891 //w=0.367 //l=0.685 //layer=li \
 //thickness=0.1 //x=81.095 //y=7.585 //x2=80.41 //y2=7.585
r1730 (  985 1188 ) resistor r=4.23183 //w=0.7 //l=0.175 //layer=li \
 //thickness=0.1 //x=80.3 //y=7.41 //x2=80.3 //y2=7.585
r1731 (  985 1264 ) resistor r=33.1979 //w=0.187 //l=0.485 //layer=li \
 //thickness=0.1 //x=80.3 //y=7.41 //x2=80.3 //y2=6.925
r1732 (  984 1187 ) resistor r=2.87058 //w=0.35 //l=0.085 //layer=li \
 //thickness=0.1 //x=79.505 //y=7.585 //x2=79.42 //y2=7.585
r1733 (  983 1188 ) resistor r=2.87058 //w=0.35 //l=0.085 //layer=li \
 //thickness=0.1 //x=80.215 //y=7.585 //x2=80.3 //y2=7.585
r1734 (  983 984 ) resistor r=24.7629 //w=0.367 //l=0.71 //layer=li \
 //thickness=0.1 //x=80.215 //y=7.585 //x2=79.505 //y2=7.585
r1735 (  977 1187 ) resistor r=4.23183 //w=0.7 //l=0.175 //layer=li \
 //thickness=0.1 //x=79.42 //y=7.41 //x2=79.42 //y2=7.585
r1736 (  977 1263 ) resistor r=33.1979 //w=0.187 //l=0.485 //layer=li \
 //thickness=0.1 //x=79.42 //y=7.41 //x2=79.42 //y2=6.925
r1737 (  974 1186 ) resistor r=2.87058 //w=0.35 //l=0.085 //layer=li \
 //thickness=0.1 //x=78.625 //y=7.585 //x2=78.54 //y2=7.585
r1738 (  974 976 ) resistor r=23.5422 //w=0.367 //l=0.675 //layer=li \
 //thickness=0.1 //x=78.625 //y=7.585 //x2=79.3 //y2=7.585
r1739 (  973 1187 ) resistor r=2.87058 //w=0.35 //l=0.085 //layer=li \
 //thickness=0.1 //x=79.335 //y=7.585 //x2=79.42 //y2=7.585
r1740 (  973 976 ) resistor r=1.22071 //w=0.367 //l=0.035 //layer=li \
 //thickness=0.1 //x=79.335 //y=7.585 //x2=79.3 //y2=7.585
r1741 (  965 1186 ) resistor r=4.23183 //w=0.7 //l=0.175 //layer=li \
 //thickness=0.1 //x=78.54 //y=7.41 //x2=78.54 //y2=7.585
r1742 (  965 1262 ) resistor r=56.4706 //w=0.187 //l=0.825 //layer=li \
 //thickness=0.1 //x=78.54 //y=7.41 //x2=78.54 //y2=6.585
r1743 (  962 1185 ) resistor r=5.29055 //w=0.35 //l=0.17 //layer=li \
 //thickness=0.1 //x=77.62 //y=7.585 //x2=77.45 //y2=7.585
r1744 (  962 964 ) resistor r=19.8801 //w=0.367 //l=0.57 //layer=li \
 //thickness=0.1 //x=77.62 //y=7.585 //x2=78.19 //y2=7.585
r1745 (  961 1186 ) resistor r=2.87058 //w=0.35 //l=0.085 //layer=li \
 //thickness=0.1 //x=78.455 //y=7.585 //x2=78.54 //y2=7.585
r1746 (  961 964 ) resistor r=9.24251 //w=0.367 //l=0.265 //layer=li \
 //thickness=0.1 //x=78.455 //y=7.585 //x2=78.19 //y2=7.585
r1747 (  956 1184 ) resistor r=2.87058 //w=0.35 //l=0.085 //layer=li \
 //thickness=0.1 //x=76.455 //y=7.585 //x2=76.37 //y2=7.585
r1748 (  956 958 ) resistor r=8.89373 //w=0.367 //l=0.255 //layer=li \
 //thickness=0.1 //x=76.455 //y=7.585 //x2=76.71 //y2=7.585
r1749 (  955 1185 ) resistor r=5.29055 //w=0.35 //l=0.17 //layer=li \
 //thickness=0.1 //x=77.28 //y=7.585 //x2=77.45 //y2=7.585
r1750 (  955 958 ) resistor r=19.8801 //w=0.367 //l=0.57 //layer=li \
 //thickness=0.1 //x=77.28 //y=7.585 //x2=76.71 //y2=7.585
r1751 (  949 1184 ) resistor r=4.23183 //w=0.7 //l=0.175 //layer=li \
 //thickness=0.1 //x=76.37 //y=7.41 //x2=76.37 //y2=7.585
r1752 (  949 1261 ) resistor r=33.1979 //w=0.187 //l=0.485 //layer=li \
 //thickness=0.1 //x=76.37 //y=7.41 //x2=76.37 //y2=6.925
r1753 (  946 1183 ) resistor r=2.87058 //w=0.35 //l=0.085 //layer=li \
 //thickness=0.1 //x=75.575 //y=7.585 //x2=75.49 //y2=7.585
r1754 (  946 948 ) resistor r=0.871935 //w=0.367 //l=0.025 //layer=li \
 //thickness=0.1 //x=75.575 //y=7.585 //x2=75.6 //y2=7.585
r1755 (  945 1184 ) resistor r=2.87058 //w=0.35 //l=0.085 //layer=li \
 //thickness=0.1 //x=76.285 //y=7.585 //x2=76.37 //y2=7.585
r1756 (  945 948 ) resistor r=23.891 //w=0.367 //l=0.685 //layer=li \
 //thickness=0.1 //x=76.285 //y=7.585 //x2=75.6 //y2=7.585
r1757 (  939 1183 ) resistor r=4.23183 //w=0.7 //l=0.175 //layer=li \
 //thickness=0.1 //x=75.49 //y=7.41 //x2=75.49 //y2=7.585
r1758 (  939 1260 ) resistor r=33.1979 //w=0.187 //l=0.485 //layer=li \
 //thickness=0.1 //x=75.49 //y=7.41 //x2=75.49 //y2=6.925
r1759 (  938 1182 ) resistor r=2.87058 //w=0.35 //l=0.085 //layer=li \
 //thickness=0.1 //x=74.695 //y=7.585 //x2=74.61 //y2=7.585
r1760 (  937 1183 ) resistor r=2.87058 //w=0.35 //l=0.085 //layer=li \
 //thickness=0.1 //x=75.405 //y=7.585 //x2=75.49 //y2=7.585
r1761 (  937 938 ) resistor r=24.7629 //w=0.367 //l=0.71 //layer=li \
 //thickness=0.1 //x=75.405 //y=7.585 //x2=74.695 //y2=7.585
r1762 (  931 1182 ) resistor r=4.23183 //w=0.7 //l=0.175 //layer=li \
 //thickness=0.1 //x=74.61 //y=7.41 //x2=74.61 //y2=7.585
r1763 (  931 1259 ) resistor r=33.1979 //w=0.187 //l=0.485 //layer=li \
 //thickness=0.1 //x=74.61 //y=7.41 //x2=74.61 //y2=6.925
r1764 (  928 1181 ) resistor r=2.87058 //w=0.35 //l=0.085 //layer=li \
 //thickness=0.1 //x=73.815 //y=7.585 //x2=73.73 //y2=7.585
r1765 (  928 930 ) resistor r=23.5422 //w=0.367 //l=0.675 //layer=li \
 //thickness=0.1 //x=73.815 //y=7.585 //x2=74.49 //y2=7.585
r1766 (  927 1182 ) resistor r=2.87058 //w=0.35 //l=0.085 //layer=li \
 //thickness=0.1 //x=74.525 //y=7.585 //x2=74.61 //y2=7.585
r1767 (  927 930 ) resistor r=1.22071 //w=0.367 //l=0.035 //layer=li \
 //thickness=0.1 //x=74.525 //y=7.585 //x2=74.49 //y2=7.585
r1768 (  919 1181 ) resistor r=4.23183 //w=0.7 //l=0.175 //layer=li \
 //thickness=0.1 //x=73.73 //y=7.41 //x2=73.73 //y2=7.585
r1769 (  919 1258 ) resistor r=56.4706 //w=0.187 //l=0.825 //layer=li \
 //thickness=0.1 //x=73.73 //y=7.41 //x2=73.73 //y2=6.585
r1770 (  916 1180 ) resistor r=5.29055 //w=0.35 //l=0.17 //layer=li \
 //thickness=0.1 //x=72.81 //y=7.585 //x2=72.64 //y2=7.585
r1771 (  916 918 ) resistor r=19.8801 //w=0.367 //l=0.57 //layer=li \
 //thickness=0.1 //x=72.81 //y=7.585 //x2=73.38 //y2=7.585
r1772 (  915 1181 ) resistor r=2.87058 //w=0.35 //l=0.085 //layer=li \
 //thickness=0.1 //x=73.645 //y=7.585 //x2=73.73 //y2=7.585
r1773 (  915 918 ) resistor r=9.24251 //w=0.367 //l=0.265 //layer=li \
 //thickness=0.1 //x=73.645 //y=7.585 //x2=73.38 //y2=7.585
r1774 (  910 1179 ) resistor r=2.87058 //w=0.35 //l=0.085 //layer=li \
 //thickness=0.1 //x=71.645 //y=7.585 //x2=71.56 //y2=7.585
r1775 (  910 912 ) resistor r=8.89373 //w=0.367 //l=0.255 //layer=li \
 //thickness=0.1 //x=71.645 //y=7.585 //x2=71.9 //y2=7.585
r1776 (  909 1180 ) resistor r=5.29055 //w=0.35 //l=0.17 //layer=li \
 //thickness=0.1 //x=72.47 //y=7.585 //x2=72.64 //y2=7.585
r1777 (  909 912 ) resistor r=19.8801 //w=0.367 //l=0.57 //layer=li \
 //thickness=0.1 //x=72.47 //y=7.585 //x2=71.9 //y2=7.585
r1778 (  903 1179 ) resistor r=4.23183 //w=0.7 //l=0.175 //layer=li \
 //thickness=0.1 //x=71.56 //y=7.41 //x2=71.56 //y2=7.585
r1779 (  903 1257 ) resistor r=33.1979 //w=0.187 //l=0.485 //layer=li \
 //thickness=0.1 //x=71.56 //y=7.41 //x2=71.56 //y2=6.925
r1780 (  900 1178 ) resistor r=2.87058 //w=0.35 //l=0.085 //layer=li \
 //thickness=0.1 //x=70.765 //y=7.585 //x2=70.68 //y2=7.585
r1781 (  900 902 ) resistor r=0.871935 //w=0.367 //l=0.025 //layer=li \
 //thickness=0.1 //x=70.765 //y=7.585 //x2=70.79 //y2=7.585
r1782 (  899 1179 ) resistor r=2.87058 //w=0.35 //l=0.085 //layer=li \
 //thickness=0.1 //x=71.475 //y=7.585 //x2=71.56 //y2=7.585
r1783 (  899 902 ) resistor r=23.891 //w=0.367 //l=0.685 //layer=li \
 //thickness=0.1 //x=71.475 //y=7.585 //x2=70.79 //y2=7.585
r1784 (  893 1178 ) resistor r=4.23183 //w=0.7 //l=0.175 //layer=li \
 //thickness=0.1 //x=70.68 //y=7.41 //x2=70.68 //y2=7.585
r1785 (  893 1256 ) resistor r=33.1979 //w=0.187 //l=0.485 //layer=li \
 //thickness=0.1 //x=70.68 //y=7.41 //x2=70.68 //y2=6.925
r1786 (  892 1177 ) resistor r=2.87058 //w=0.35 //l=0.085 //layer=li \
 //thickness=0.1 //x=69.885 //y=7.585 //x2=69.8 //y2=7.585
r1787 (  891 1178 ) resistor r=2.87058 //w=0.35 //l=0.085 //layer=li \
 //thickness=0.1 //x=70.595 //y=7.585 //x2=70.68 //y2=7.585
r1788 (  891 892 ) resistor r=24.7629 //w=0.367 //l=0.71 //layer=li \
 //thickness=0.1 //x=70.595 //y=7.585 //x2=69.885 //y2=7.585
r1789 (  885 1177 ) resistor r=4.23183 //w=0.7 //l=0.175 //layer=li \
 //thickness=0.1 //x=69.8 //y=7.41 //x2=69.8 //y2=7.585
r1790 (  885 1255 ) resistor r=33.1979 //w=0.187 //l=0.485 //layer=li \
 //thickness=0.1 //x=69.8 //y=7.41 //x2=69.8 //y2=6.925
r1791 (  882 1176 ) resistor r=2.87058 //w=0.35 //l=0.085 //layer=li \
 //thickness=0.1 //x=69.005 //y=7.585 //x2=68.92 //y2=7.585
r1792 (  882 884 ) resistor r=23.5422 //w=0.367 //l=0.675 //layer=li \
 //thickness=0.1 //x=69.005 //y=7.585 //x2=69.68 //y2=7.585
r1793 (  881 1177 ) resistor r=2.87058 //w=0.35 //l=0.085 //layer=li \
 //thickness=0.1 //x=69.715 //y=7.585 //x2=69.8 //y2=7.585
r1794 (  881 884 ) resistor r=1.22071 //w=0.367 //l=0.035 //layer=li \
 //thickness=0.1 //x=69.715 //y=7.585 //x2=69.68 //y2=7.585
r1795 (  873 1176 ) resistor r=4.23183 //w=0.7 //l=0.175 //layer=li \
 //thickness=0.1 //x=68.92 //y=7.41 //x2=68.92 //y2=7.585
r1796 (  873 1254 ) resistor r=56.4706 //w=0.187 //l=0.825 //layer=li \
 //thickness=0.1 //x=68.92 //y=7.41 //x2=68.92 //y2=6.585
r1797 (  870 1175 ) resistor r=5.29055 //w=0.35 //l=0.17 //layer=li \
 //thickness=0.1 //x=68 //y=7.585 //x2=67.83 //y2=7.585
r1798 (  870 872 ) resistor r=19.8801 //w=0.367 //l=0.57 //layer=li \
 //thickness=0.1 //x=68 //y=7.585 //x2=68.57 //y2=7.585
r1799 (  869 1176 ) resistor r=2.87058 //w=0.35 //l=0.085 //layer=li \
 //thickness=0.1 //x=68.835 //y=7.585 //x2=68.92 //y2=7.585
r1800 (  869 872 ) resistor r=9.24251 //w=0.367 //l=0.265 //layer=li \
 //thickness=0.1 //x=68.835 //y=7.585 //x2=68.57 //y2=7.585
r1801 (  864 1174 ) resistor r=2.87058 //w=0.35 //l=0.085 //layer=li \
 //thickness=0.1 //x=66.835 //y=7.585 //x2=66.75 //y2=7.585
r1802 (  864 866 ) resistor r=8.89373 //w=0.367 //l=0.255 //layer=li \
 //thickness=0.1 //x=66.835 //y=7.585 //x2=67.09 //y2=7.585
r1803 (  863 1175 ) resistor r=5.29055 //w=0.35 //l=0.17 //layer=li \
 //thickness=0.1 //x=67.66 //y=7.585 //x2=67.83 //y2=7.585
r1804 (  863 866 ) resistor r=19.8801 //w=0.367 //l=0.57 //layer=li \
 //thickness=0.1 //x=67.66 //y=7.585 //x2=67.09 //y2=7.585
r1805 (  857 1174 ) resistor r=4.23183 //w=0.7 //l=0.175 //layer=li \
 //thickness=0.1 //x=66.75 //y=7.41 //x2=66.75 //y2=7.585
r1806 (  857 1253 ) resistor r=33.1979 //w=0.187 //l=0.485 //layer=li \
 //thickness=0.1 //x=66.75 //y=7.41 //x2=66.75 //y2=6.925
r1807 (  854 1173 ) resistor r=2.87058 //w=0.35 //l=0.085 //layer=li \
 //thickness=0.1 //x=65.955 //y=7.585 //x2=65.87 //y2=7.585
r1808 (  854 856 ) resistor r=0.871935 //w=0.367 //l=0.025 //layer=li \
 //thickness=0.1 //x=65.955 //y=7.585 //x2=65.98 //y2=7.585
r1809 (  853 1174 ) resistor r=2.87058 //w=0.35 //l=0.085 //layer=li \
 //thickness=0.1 //x=66.665 //y=7.585 //x2=66.75 //y2=7.585
r1810 (  853 856 ) resistor r=23.891 //w=0.367 //l=0.685 //layer=li \
 //thickness=0.1 //x=66.665 //y=7.585 //x2=65.98 //y2=7.585
r1811 (  847 1173 ) resistor r=4.23183 //w=0.7 //l=0.175 //layer=li \
 //thickness=0.1 //x=65.87 //y=7.41 //x2=65.87 //y2=7.585
r1812 (  847 1252 ) resistor r=33.1979 //w=0.187 //l=0.485 //layer=li \
 //thickness=0.1 //x=65.87 //y=7.41 //x2=65.87 //y2=6.925
r1813 (  846 1172 ) resistor r=2.87058 //w=0.35 //l=0.085 //layer=li \
 //thickness=0.1 //x=65.075 //y=7.585 //x2=64.99 //y2=7.585
r1814 (  845 1173 ) resistor r=2.87058 //w=0.35 //l=0.085 //layer=li \
 //thickness=0.1 //x=65.785 //y=7.585 //x2=65.87 //y2=7.585
r1815 (  845 846 ) resistor r=24.7629 //w=0.367 //l=0.71 //layer=li \
 //thickness=0.1 //x=65.785 //y=7.585 //x2=65.075 //y2=7.585
r1816 (  839 1172 ) resistor r=4.23183 //w=0.7 //l=0.175 //layer=li \
 //thickness=0.1 //x=64.99 //y=7.41 //x2=64.99 //y2=7.585
r1817 (  839 1251 ) resistor r=33.1979 //w=0.187 //l=0.485 //layer=li \
 //thickness=0.1 //x=64.99 //y=7.41 //x2=64.99 //y2=6.925
r1818 (  836 1171 ) resistor r=2.87058 //w=0.35 //l=0.085 //layer=li \
 //thickness=0.1 //x=64.195 //y=7.585 //x2=64.11 //y2=7.585
r1819 (  836 838 ) resistor r=23.5422 //w=0.367 //l=0.675 //layer=li \
 //thickness=0.1 //x=64.195 //y=7.585 //x2=64.87 //y2=7.585
r1820 (  835 1172 ) resistor r=2.87058 //w=0.35 //l=0.085 //layer=li \
 //thickness=0.1 //x=64.905 //y=7.585 //x2=64.99 //y2=7.585
r1821 (  835 838 ) resistor r=1.22071 //w=0.367 //l=0.035 //layer=li \
 //thickness=0.1 //x=64.905 //y=7.585 //x2=64.87 //y2=7.585
r1822 (  827 1171 ) resistor r=4.23183 //w=0.7 //l=0.175 //layer=li \
 //thickness=0.1 //x=64.11 //y=7.41 //x2=64.11 //y2=7.585
r1823 (  827 1250 ) resistor r=56.4706 //w=0.187 //l=0.825 //layer=li \
 //thickness=0.1 //x=64.11 //y=7.41 //x2=64.11 //y2=6.585
r1824 (  824 1170 ) resistor r=5.29055 //w=0.35 //l=0.17 //layer=li \
 //thickness=0.1 //x=63.19 //y=7.585 //x2=63.02 //y2=7.585
r1825 (  824 826 ) resistor r=19.8801 //w=0.367 //l=0.57 //layer=li \
 //thickness=0.1 //x=63.19 //y=7.585 //x2=63.76 //y2=7.585
r1826 (  823 1171 ) resistor r=2.87058 //w=0.35 //l=0.085 //layer=li \
 //thickness=0.1 //x=64.025 //y=7.585 //x2=64.11 //y2=7.585
r1827 (  823 826 ) resistor r=9.24251 //w=0.367 //l=0.265 //layer=li \
 //thickness=0.1 //x=64.025 //y=7.585 //x2=63.76 //y2=7.585
r1828 (  818 1169 ) resistor r=2.87058 //w=0.35 //l=0.085 //layer=li \
 //thickness=0.1 //x=62.025 //y=7.585 //x2=61.94 //y2=7.585
r1829 (  818 820 ) resistor r=8.89373 //w=0.367 //l=0.255 //layer=li \
 //thickness=0.1 //x=62.025 //y=7.585 //x2=62.28 //y2=7.585
r1830 (  817 1170 ) resistor r=5.29055 //w=0.35 //l=0.17 //layer=li \
 //thickness=0.1 //x=62.85 //y=7.585 //x2=63.02 //y2=7.585
r1831 (  817 820 ) resistor r=19.8801 //w=0.367 //l=0.57 //layer=li \
 //thickness=0.1 //x=62.85 //y=7.585 //x2=62.28 //y2=7.585
r1832 (  811 1169 ) resistor r=4.23183 //w=0.7 //l=0.175 //layer=li \
 //thickness=0.1 //x=61.94 //y=7.41 //x2=61.94 //y2=7.585
r1833 (  811 1249 ) resistor r=33.1979 //w=0.187 //l=0.485 //layer=li \
 //thickness=0.1 //x=61.94 //y=7.41 //x2=61.94 //y2=6.925
r1834 (  808 1168 ) resistor r=2.87058 //w=0.35 //l=0.085 //layer=li \
 //thickness=0.1 //x=61.145 //y=7.585 //x2=61.06 //y2=7.585
r1835 (  808 810 ) resistor r=0.871935 //w=0.367 //l=0.025 //layer=li \
 //thickness=0.1 //x=61.145 //y=7.585 //x2=61.17 //y2=7.585
r1836 (  807 1169 ) resistor r=2.87058 //w=0.35 //l=0.085 //layer=li \
 //thickness=0.1 //x=61.855 //y=7.585 //x2=61.94 //y2=7.585
r1837 (  807 810 ) resistor r=23.891 //w=0.367 //l=0.685 //layer=li \
 //thickness=0.1 //x=61.855 //y=7.585 //x2=61.17 //y2=7.585
r1838 (  801 1168 ) resistor r=4.23183 //w=0.7 //l=0.175 //layer=li \
 //thickness=0.1 //x=61.06 //y=7.41 //x2=61.06 //y2=7.585
r1839 (  801 1248 ) resistor r=33.1979 //w=0.187 //l=0.485 //layer=li \
 //thickness=0.1 //x=61.06 //y=7.41 //x2=61.06 //y2=6.925
r1840 (  800 1167 ) resistor r=2.87058 //w=0.35 //l=0.085 //layer=li \
 //thickness=0.1 //x=60.265 //y=7.585 //x2=60.18 //y2=7.585
r1841 (  799 1168 ) resistor r=2.87058 //w=0.35 //l=0.085 //layer=li \
 //thickness=0.1 //x=60.975 //y=7.585 //x2=61.06 //y2=7.585
r1842 (  799 800 ) resistor r=24.7629 //w=0.367 //l=0.71 //layer=li \
 //thickness=0.1 //x=60.975 //y=7.585 //x2=60.265 //y2=7.585
r1843 (  793 1167 ) resistor r=4.23183 //w=0.7 //l=0.175 //layer=li \
 //thickness=0.1 //x=60.18 //y=7.41 //x2=60.18 //y2=7.585
r1844 (  793 1247 ) resistor r=33.1979 //w=0.187 //l=0.485 //layer=li \
 //thickness=0.1 //x=60.18 //y=7.41 //x2=60.18 //y2=6.925
r1845 (  790 1166 ) resistor r=2.87058 //w=0.35 //l=0.085 //layer=li \
 //thickness=0.1 //x=59.385 //y=7.585 //x2=59.3 //y2=7.585
r1846 (  790 792 ) resistor r=23.5422 //w=0.367 //l=0.675 //layer=li \
 //thickness=0.1 //x=59.385 //y=7.585 //x2=60.06 //y2=7.585
r1847 (  789 1167 ) resistor r=2.87058 //w=0.35 //l=0.085 //layer=li \
 //thickness=0.1 //x=60.095 //y=7.585 //x2=60.18 //y2=7.585
r1848 (  789 792 ) resistor r=1.22071 //w=0.367 //l=0.035 //layer=li \
 //thickness=0.1 //x=60.095 //y=7.585 //x2=60.06 //y2=7.585
r1849 (  781 1166 ) resistor r=4.23183 //w=0.7 //l=0.175 //layer=li \
 //thickness=0.1 //x=59.3 //y=7.41 //x2=59.3 //y2=7.585
r1850 (  781 1246 ) resistor r=56.4706 //w=0.187 //l=0.825 //layer=li \
 //thickness=0.1 //x=59.3 //y=7.41 //x2=59.3 //y2=6.585
r1851 (  778 1165 ) resistor r=5.29055 //w=0.35 //l=0.17 //layer=li \
 //thickness=0.1 //x=58.38 //y=7.585 //x2=58.21 //y2=7.585
r1852 (  778 780 ) resistor r=19.8801 //w=0.367 //l=0.57 //layer=li \
 //thickness=0.1 //x=58.38 //y=7.585 //x2=58.95 //y2=7.585
r1853 (  777 1166 ) resistor r=2.87058 //w=0.35 //l=0.085 //layer=li \
 //thickness=0.1 //x=59.215 //y=7.585 //x2=59.3 //y2=7.585
r1854 (  777 780 ) resistor r=9.24251 //w=0.367 //l=0.265 //layer=li \
 //thickness=0.1 //x=59.215 //y=7.585 //x2=58.95 //y2=7.585
r1855 (  772 1164 ) resistor r=2.87058 //w=0.35 //l=0.085 //layer=li \
 //thickness=0.1 //x=57.215 //y=7.585 //x2=57.13 //y2=7.585
r1856 (  772 774 ) resistor r=8.89373 //w=0.367 //l=0.255 //layer=li \
 //thickness=0.1 //x=57.215 //y=7.585 //x2=57.47 //y2=7.585
r1857 (  771 1165 ) resistor r=5.29055 //w=0.35 //l=0.17 //layer=li \
 //thickness=0.1 //x=58.04 //y=7.585 //x2=58.21 //y2=7.585
r1858 (  771 774 ) resistor r=19.8801 //w=0.367 //l=0.57 //layer=li \
 //thickness=0.1 //x=58.04 //y=7.585 //x2=57.47 //y2=7.585
r1859 (  765 1164 ) resistor r=4.23183 //w=0.7 //l=0.175 //layer=li \
 //thickness=0.1 //x=57.13 //y=7.41 //x2=57.13 //y2=7.585
r1860 (  765 1245 ) resistor r=33.1979 //w=0.187 //l=0.485 //layer=li \
 //thickness=0.1 //x=57.13 //y=7.41 //x2=57.13 //y2=6.925
r1861 (  762 1163 ) resistor r=2.87058 //w=0.35 //l=0.085 //layer=li \
 //thickness=0.1 //x=56.335 //y=7.585 //x2=56.25 //y2=7.585
r1862 (  762 764 ) resistor r=0.871935 //w=0.367 //l=0.025 //layer=li \
 //thickness=0.1 //x=56.335 //y=7.585 //x2=56.36 //y2=7.585
r1863 (  761 1164 ) resistor r=2.87058 //w=0.35 //l=0.085 //layer=li \
 //thickness=0.1 //x=57.045 //y=7.585 //x2=57.13 //y2=7.585
r1864 (  761 764 ) resistor r=23.891 //w=0.367 //l=0.685 //layer=li \
 //thickness=0.1 //x=57.045 //y=7.585 //x2=56.36 //y2=7.585
r1865 (  755 1163 ) resistor r=4.23183 //w=0.7 //l=0.175 //layer=li \
 //thickness=0.1 //x=56.25 //y=7.41 //x2=56.25 //y2=7.585
r1866 (  755 1244 ) resistor r=33.1979 //w=0.187 //l=0.485 //layer=li \
 //thickness=0.1 //x=56.25 //y=7.41 //x2=56.25 //y2=6.925
r1867 (  754 1162 ) resistor r=2.87058 //w=0.35 //l=0.085 //layer=li \
 //thickness=0.1 //x=55.455 //y=7.585 //x2=55.37 //y2=7.585
r1868 (  753 1163 ) resistor r=2.87058 //w=0.35 //l=0.085 //layer=li \
 //thickness=0.1 //x=56.165 //y=7.585 //x2=56.25 //y2=7.585
r1869 (  753 754 ) resistor r=24.7629 //w=0.367 //l=0.71 //layer=li \
 //thickness=0.1 //x=56.165 //y=7.585 //x2=55.455 //y2=7.585
r1870 (  747 1162 ) resistor r=4.23183 //w=0.7 //l=0.175 //layer=li \
 //thickness=0.1 //x=55.37 //y=7.41 //x2=55.37 //y2=7.585
r1871 (  747 1243 ) resistor r=33.1979 //w=0.187 //l=0.485 //layer=li \
 //thickness=0.1 //x=55.37 //y=7.41 //x2=55.37 //y2=6.925
r1872 (  744 1161 ) resistor r=2.87058 //w=0.35 //l=0.085 //layer=li \
 //thickness=0.1 //x=54.575 //y=7.585 //x2=54.49 //y2=7.585
r1873 (  744 746 ) resistor r=23.5422 //w=0.367 //l=0.675 //layer=li \
 //thickness=0.1 //x=54.575 //y=7.585 //x2=55.25 //y2=7.585
r1874 (  743 1162 ) resistor r=2.87058 //w=0.35 //l=0.085 //layer=li \
 //thickness=0.1 //x=55.285 //y=7.585 //x2=55.37 //y2=7.585
r1875 (  743 746 ) resistor r=1.22071 //w=0.367 //l=0.035 //layer=li \
 //thickness=0.1 //x=55.285 //y=7.585 //x2=55.25 //y2=7.585
r1876 (  735 1161 ) resistor r=4.23183 //w=0.7 //l=0.175 //layer=li \
 //thickness=0.1 //x=54.49 //y=7.41 //x2=54.49 //y2=7.585
r1877 (  735 1242 ) resistor r=56.4706 //w=0.187 //l=0.825 //layer=li \
 //thickness=0.1 //x=54.49 //y=7.41 //x2=54.49 //y2=6.585
r1878 (  732 1160 ) resistor r=5.29055 //w=0.35 //l=0.17 //layer=li \
 //thickness=0.1 //x=53.57 //y=7.585 //x2=53.4 //y2=7.585
r1879 (  732 734 ) resistor r=19.8801 //w=0.367 //l=0.57 //layer=li \
 //thickness=0.1 //x=53.57 //y=7.585 //x2=54.14 //y2=7.585
r1880 (  731 1161 ) resistor r=2.87058 //w=0.35 //l=0.085 //layer=li \
 //thickness=0.1 //x=54.405 //y=7.585 //x2=54.49 //y2=7.585
r1881 (  731 734 ) resistor r=9.24251 //w=0.367 //l=0.265 //layer=li \
 //thickness=0.1 //x=54.405 //y=7.585 //x2=54.14 //y2=7.585
r1882 (  726 1159 ) resistor r=2.87058 //w=0.35 //l=0.085 //layer=li \
 //thickness=0.1 //x=52.405 //y=7.585 //x2=52.32 //y2=7.585
r1883 (  726 728 ) resistor r=8.89373 //w=0.367 //l=0.255 //layer=li \
 //thickness=0.1 //x=52.405 //y=7.585 //x2=52.66 //y2=7.585
r1884 (  725 1160 ) resistor r=5.29055 //w=0.35 //l=0.17 //layer=li \
 //thickness=0.1 //x=53.23 //y=7.585 //x2=53.4 //y2=7.585
r1885 (  725 728 ) resistor r=19.8801 //w=0.367 //l=0.57 //layer=li \
 //thickness=0.1 //x=53.23 //y=7.585 //x2=52.66 //y2=7.585
r1886 (  719 1159 ) resistor r=4.23183 //w=0.7 //l=0.175 //layer=li \
 //thickness=0.1 //x=52.32 //y=7.41 //x2=52.32 //y2=7.585
r1887 (  719 1241 ) resistor r=33.1979 //w=0.187 //l=0.485 //layer=li \
 //thickness=0.1 //x=52.32 //y=7.41 //x2=52.32 //y2=6.925
r1888 (  716 1158 ) resistor r=2.87058 //w=0.35 //l=0.085 //layer=li \
 //thickness=0.1 //x=51.525 //y=7.585 //x2=51.44 //y2=7.585
r1889 (  716 718 ) resistor r=0.871935 //w=0.367 //l=0.025 //layer=li \
 //thickness=0.1 //x=51.525 //y=7.585 //x2=51.55 //y2=7.585
r1890 (  715 1159 ) resistor r=2.87058 //w=0.35 //l=0.085 //layer=li \
 //thickness=0.1 //x=52.235 //y=7.585 //x2=52.32 //y2=7.585
r1891 (  715 718 ) resistor r=23.891 //w=0.367 //l=0.685 //layer=li \
 //thickness=0.1 //x=52.235 //y=7.585 //x2=51.55 //y2=7.585
r1892 (  709 1158 ) resistor r=4.23183 //w=0.7 //l=0.175 //layer=li \
 //thickness=0.1 //x=51.44 //y=7.41 //x2=51.44 //y2=7.585
r1893 (  709 1240 ) resistor r=33.1979 //w=0.187 //l=0.485 //layer=li \
 //thickness=0.1 //x=51.44 //y=7.41 //x2=51.44 //y2=6.925
r1894 (  708 1157 ) resistor r=2.87058 //w=0.35 //l=0.085 //layer=li \
 //thickness=0.1 //x=50.645 //y=7.585 //x2=50.56 //y2=7.585
r1895 (  707 1158 ) resistor r=2.87058 //w=0.35 //l=0.085 //layer=li \
 //thickness=0.1 //x=51.355 //y=7.585 //x2=51.44 //y2=7.585
r1896 (  707 708 ) resistor r=24.7629 //w=0.367 //l=0.71 //layer=li \
 //thickness=0.1 //x=51.355 //y=7.585 //x2=50.645 //y2=7.585
r1897 (  701 1157 ) resistor r=4.23183 //w=0.7 //l=0.175 //layer=li \
 //thickness=0.1 //x=50.56 //y=7.41 //x2=50.56 //y2=7.585
r1898 (  701 1239 ) resistor r=33.1979 //w=0.187 //l=0.485 //layer=li \
 //thickness=0.1 //x=50.56 //y=7.41 //x2=50.56 //y2=6.925
r1899 (  698 1156 ) resistor r=2.87058 //w=0.35 //l=0.085 //layer=li \
 //thickness=0.1 //x=49.765 //y=7.585 //x2=49.68 //y2=7.585
r1900 (  698 700 ) resistor r=23.5422 //w=0.367 //l=0.675 //layer=li \
 //thickness=0.1 //x=49.765 //y=7.585 //x2=50.44 //y2=7.585
r1901 (  697 1157 ) resistor r=2.87058 //w=0.35 //l=0.085 //layer=li \
 //thickness=0.1 //x=50.475 //y=7.585 //x2=50.56 //y2=7.585
r1902 (  697 700 ) resistor r=1.22071 //w=0.367 //l=0.035 //layer=li \
 //thickness=0.1 //x=50.475 //y=7.585 //x2=50.44 //y2=7.585
r1903 (  689 1156 ) resistor r=4.23183 //w=0.7 //l=0.175 //layer=li \
 //thickness=0.1 //x=49.68 //y=7.41 //x2=49.68 //y2=7.585
r1904 (  689 1238 ) resistor r=56.4706 //w=0.187 //l=0.825 //layer=li \
 //thickness=0.1 //x=49.68 //y=7.41 //x2=49.68 //y2=6.585
r1905 (  686 1155 ) resistor r=5.29055 //w=0.35 //l=0.17 //layer=li \
 //thickness=0.1 //x=48.76 //y=7.585 //x2=48.59 //y2=7.585
r1906 (  686 688 ) resistor r=19.8801 //w=0.367 //l=0.57 //layer=li \
 //thickness=0.1 //x=48.76 //y=7.585 //x2=49.33 //y2=7.585
r1907 (  685 1156 ) resistor r=2.87058 //w=0.35 //l=0.085 //layer=li \
 //thickness=0.1 //x=49.595 //y=7.585 //x2=49.68 //y2=7.585
r1908 (  685 688 ) resistor r=9.24251 //w=0.367 //l=0.265 //layer=li \
 //thickness=0.1 //x=49.595 //y=7.585 //x2=49.33 //y2=7.585
r1909 (  680 1154 ) resistor r=2.87058 //w=0.35 //l=0.085 //layer=li \
 //thickness=0.1 //x=47.595 //y=7.585 //x2=47.51 //y2=7.585
r1910 (  680 682 ) resistor r=8.89373 //w=0.367 //l=0.255 //layer=li \
 //thickness=0.1 //x=47.595 //y=7.585 //x2=47.85 //y2=7.585
r1911 (  679 1155 ) resistor r=5.29055 //w=0.35 //l=0.17 //layer=li \
 //thickness=0.1 //x=48.42 //y=7.585 //x2=48.59 //y2=7.585
r1912 (  679 682 ) resistor r=19.8801 //w=0.367 //l=0.57 //layer=li \
 //thickness=0.1 //x=48.42 //y=7.585 //x2=47.85 //y2=7.585
r1913 (  673 1154 ) resistor r=4.23183 //w=0.7 //l=0.175 //layer=li \
 //thickness=0.1 //x=47.51 //y=7.41 //x2=47.51 //y2=7.585
r1914 (  673 1237 ) resistor r=33.1979 //w=0.187 //l=0.485 //layer=li \
 //thickness=0.1 //x=47.51 //y=7.41 //x2=47.51 //y2=6.925
r1915 (  670 1153 ) resistor r=2.87058 //w=0.35 //l=0.085 //layer=li \
 //thickness=0.1 //x=46.715 //y=7.585 //x2=46.63 //y2=7.585
r1916 (  670 672 ) resistor r=0.871935 //w=0.367 //l=0.025 //layer=li \
 //thickness=0.1 //x=46.715 //y=7.585 //x2=46.74 //y2=7.585
r1917 (  669 1154 ) resistor r=2.87058 //w=0.35 //l=0.085 //layer=li \
 //thickness=0.1 //x=47.425 //y=7.585 //x2=47.51 //y2=7.585
r1918 (  669 672 ) resistor r=23.891 //w=0.367 //l=0.685 //layer=li \
 //thickness=0.1 //x=47.425 //y=7.585 //x2=46.74 //y2=7.585
r1919 (  663 1153 ) resistor r=4.23183 //w=0.7 //l=0.175 //layer=li \
 //thickness=0.1 //x=46.63 //y=7.41 //x2=46.63 //y2=7.585
r1920 (  663 1236 ) resistor r=33.1979 //w=0.187 //l=0.485 //layer=li \
 //thickness=0.1 //x=46.63 //y=7.41 //x2=46.63 //y2=6.925
r1921 (  662 1152 ) resistor r=2.87058 //w=0.35 //l=0.085 //layer=li \
 //thickness=0.1 //x=45.835 //y=7.585 //x2=45.75 //y2=7.585
r1922 (  661 1153 ) resistor r=2.87058 //w=0.35 //l=0.085 //layer=li \
 //thickness=0.1 //x=46.545 //y=7.585 //x2=46.63 //y2=7.585
r1923 (  661 662 ) resistor r=24.7629 //w=0.367 //l=0.71 //layer=li \
 //thickness=0.1 //x=46.545 //y=7.585 //x2=45.835 //y2=7.585
r1924 (  655 1152 ) resistor r=4.23183 //w=0.7 //l=0.175 //layer=li \
 //thickness=0.1 //x=45.75 //y=7.41 //x2=45.75 //y2=7.585
r1925 (  655 1235 ) resistor r=33.1979 //w=0.187 //l=0.485 //layer=li \
 //thickness=0.1 //x=45.75 //y=7.41 //x2=45.75 //y2=6.925
r1926 (  652 1151 ) resistor r=2.87058 //w=0.35 //l=0.085 //layer=li \
 //thickness=0.1 //x=44.955 //y=7.585 //x2=44.87 //y2=7.585
r1927 (  652 654 ) resistor r=23.5422 //w=0.367 //l=0.675 //layer=li \
 //thickness=0.1 //x=44.955 //y=7.585 //x2=45.63 //y2=7.585
r1928 (  651 1152 ) resistor r=2.87058 //w=0.35 //l=0.085 //layer=li \
 //thickness=0.1 //x=45.665 //y=7.585 //x2=45.75 //y2=7.585
r1929 (  651 654 ) resistor r=1.22071 //w=0.367 //l=0.035 //layer=li \
 //thickness=0.1 //x=45.665 //y=7.585 //x2=45.63 //y2=7.585
r1930 (  643 1151 ) resistor r=4.23183 //w=0.7 //l=0.175 //layer=li \
 //thickness=0.1 //x=44.87 //y=7.41 //x2=44.87 //y2=7.585
r1931 (  643 1234 ) resistor r=56.4706 //w=0.187 //l=0.825 //layer=li \
 //thickness=0.1 //x=44.87 //y=7.41 //x2=44.87 //y2=6.585
r1932 (  640 1150 ) resistor r=5.29055 //w=0.35 //l=0.17 //layer=li \
 //thickness=0.1 //x=43.95 //y=7.585 //x2=43.78 //y2=7.585
r1933 (  640 642 ) resistor r=19.8801 //w=0.367 //l=0.57 //layer=li \
 //thickness=0.1 //x=43.95 //y=7.585 //x2=44.52 //y2=7.585
r1934 (  639 1151 ) resistor r=2.87058 //w=0.35 //l=0.085 //layer=li \
 //thickness=0.1 //x=44.785 //y=7.585 //x2=44.87 //y2=7.585
r1935 (  639 642 ) resistor r=9.24251 //w=0.367 //l=0.265 //layer=li \
 //thickness=0.1 //x=44.785 //y=7.585 //x2=44.52 //y2=7.585
r1936 (  634 1149 ) resistor r=2.87058 //w=0.35 //l=0.085 //layer=li \
 //thickness=0.1 //x=42.785 //y=7.585 //x2=42.7 //y2=7.585
r1937 (  634 636 ) resistor r=8.89373 //w=0.367 //l=0.255 //layer=li \
 //thickness=0.1 //x=42.785 //y=7.585 //x2=43.04 //y2=7.585
r1938 (  633 1150 ) resistor r=5.29055 //w=0.35 //l=0.17 //layer=li \
 //thickness=0.1 //x=43.61 //y=7.585 //x2=43.78 //y2=7.585
r1939 (  633 636 ) resistor r=19.8801 //w=0.367 //l=0.57 //layer=li \
 //thickness=0.1 //x=43.61 //y=7.585 //x2=43.04 //y2=7.585
r1940 (  627 1149 ) resistor r=4.23183 //w=0.7 //l=0.175 //layer=li \
 //thickness=0.1 //x=42.7 //y=7.41 //x2=42.7 //y2=7.585
r1941 (  627 1233 ) resistor r=33.1979 //w=0.187 //l=0.485 //layer=li \
 //thickness=0.1 //x=42.7 //y=7.41 //x2=42.7 //y2=6.925
r1942 (  624 1148 ) resistor r=2.87058 //w=0.35 //l=0.085 //layer=li \
 //thickness=0.1 //x=41.905 //y=7.585 //x2=41.82 //y2=7.585
r1943 (  624 626 ) resistor r=0.871935 //w=0.367 //l=0.025 //layer=li \
 //thickness=0.1 //x=41.905 //y=7.585 //x2=41.93 //y2=7.585
r1944 (  623 1149 ) resistor r=2.87058 //w=0.35 //l=0.085 //layer=li \
 //thickness=0.1 //x=42.615 //y=7.585 //x2=42.7 //y2=7.585
r1945 (  623 626 ) resistor r=23.891 //w=0.367 //l=0.685 //layer=li \
 //thickness=0.1 //x=42.615 //y=7.585 //x2=41.93 //y2=7.585
r1946 (  617 1148 ) resistor r=4.23183 //w=0.7 //l=0.175 //layer=li \
 //thickness=0.1 //x=41.82 //y=7.41 //x2=41.82 //y2=7.585
r1947 (  617 1232 ) resistor r=33.1979 //w=0.187 //l=0.485 //layer=li \
 //thickness=0.1 //x=41.82 //y=7.41 //x2=41.82 //y2=6.925
r1948 (  616 1147 ) resistor r=2.87058 //w=0.35 //l=0.085 //layer=li \
 //thickness=0.1 //x=41.025 //y=7.585 //x2=40.94 //y2=7.585
r1949 (  615 1148 ) resistor r=2.87058 //w=0.35 //l=0.085 //layer=li \
 //thickness=0.1 //x=41.735 //y=7.585 //x2=41.82 //y2=7.585
r1950 (  615 616 ) resistor r=24.7629 //w=0.367 //l=0.71 //layer=li \
 //thickness=0.1 //x=41.735 //y=7.585 //x2=41.025 //y2=7.585
r1951 (  609 1147 ) resistor r=4.23183 //w=0.7 //l=0.175 //layer=li \
 //thickness=0.1 //x=40.94 //y=7.41 //x2=40.94 //y2=7.585
r1952 (  609 1231 ) resistor r=33.1979 //w=0.187 //l=0.485 //layer=li \
 //thickness=0.1 //x=40.94 //y=7.41 //x2=40.94 //y2=6.925
r1953 (  606 1146 ) resistor r=2.87058 //w=0.35 //l=0.085 //layer=li \
 //thickness=0.1 //x=40.145 //y=7.585 //x2=40.06 //y2=7.585
r1954 (  606 608 ) resistor r=23.5422 //w=0.367 //l=0.675 //layer=li \
 //thickness=0.1 //x=40.145 //y=7.585 //x2=40.82 //y2=7.585
r1955 (  605 1147 ) resistor r=2.87058 //w=0.35 //l=0.085 //layer=li \
 //thickness=0.1 //x=40.855 //y=7.585 //x2=40.94 //y2=7.585
r1956 (  605 608 ) resistor r=1.22071 //w=0.367 //l=0.035 //layer=li \
 //thickness=0.1 //x=40.855 //y=7.585 //x2=40.82 //y2=7.585
r1957 (  597 1146 ) resistor r=4.23183 //w=0.7 //l=0.175 //layer=li \
 //thickness=0.1 //x=40.06 //y=7.41 //x2=40.06 //y2=7.585
r1958 (  597 1230 ) resistor r=56.4706 //w=0.187 //l=0.825 //layer=li \
 //thickness=0.1 //x=40.06 //y=7.41 //x2=40.06 //y2=6.585
r1959 (  594 1145 ) resistor r=5.29055 //w=0.35 //l=0.17 //layer=li \
 //thickness=0.1 //x=39.14 //y=7.585 //x2=38.97 //y2=7.585
r1960 (  594 596 ) resistor r=19.8801 //w=0.367 //l=0.57 //layer=li \
 //thickness=0.1 //x=39.14 //y=7.585 //x2=39.71 //y2=7.585
r1961 (  593 1146 ) resistor r=2.87058 //w=0.35 //l=0.085 //layer=li \
 //thickness=0.1 //x=39.975 //y=7.585 //x2=40.06 //y2=7.585
r1962 (  593 596 ) resistor r=9.24251 //w=0.367 //l=0.265 //layer=li \
 //thickness=0.1 //x=39.975 //y=7.585 //x2=39.71 //y2=7.585
r1963 (  588 1144 ) resistor r=2.87058 //w=0.35 //l=0.085 //layer=li \
 //thickness=0.1 //x=37.975 //y=7.585 //x2=37.89 //y2=7.585
r1964 (  588 590 ) resistor r=8.89373 //w=0.367 //l=0.255 //layer=li \
 //thickness=0.1 //x=37.975 //y=7.585 //x2=38.23 //y2=7.585
r1965 (  587 1145 ) resistor r=5.29055 //w=0.35 //l=0.17 //layer=li \
 //thickness=0.1 //x=38.8 //y=7.585 //x2=38.97 //y2=7.585
r1966 (  587 590 ) resistor r=19.8801 //w=0.367 //l=0.57 //layer=li \
 //thickness=0.1 //x=38.8 //y=7.585 //x2=38.23 //y2=7.585
r1967 (  581 1144 ) resistor r=4.23183 //w=0.7 //l=0.175 //layer=li \
 //thickness=0.1 //x=37.89 //y=7.41 //x2=37.89 //y2=7.585
r1968 (  581 1229 ) resistor r=33.1979 //w=0.187 //l=0.485 //layer=li \
 //thickness=0.1 //x=37.89 //y=7.41 //x2=37.89 //y2=6.925
r1969 (  578 1143 ) resistor r=2.87058 //w=0.35 //l=0.085 //layer=li \
 //thickness=0.1 //x=37.095 //y=7.585 //x2=37.01 //y2=7.585
r1970 (  578 580 ) resistor r=0.871935 //w=0.367 //l=0.025 //layer=li \
 //thickness=0.1 //x=37.095 //y=7.585 //x2=37.12 //y2=7.585
r1971 (  577 1144 ) resistor r=2.87058 //w=0.35 //l=0.085 //layer=li \
 //thickness=0.1 //x=37.805 //y=7.585 //x2=37.89 //y2=7.585
r1972 (  577 580 ) resistor r=23.891 //w=0.367 //l=0.685 //layer=li \
 //thickness=0.1 //x=37.805 //y=7.585 //x2=37.12 //y2=7.585
r1973 (  571 1143 ) resistor r=4.23183 //w=0.7 //l=0.175 //layer=li \
 //thickness=0.1 //x=37.01 //y=7.41 //x2=37.01 //y2=7.585
r1974 (  571 1228 ) resistor r=33.1979 //w=0.187 //l=0.485 //layer=li \
 //thickness=0.1 //x=37.01 //y=7.41 //x2=37.01 //y2=6.925
r1975 (  570 1142 ) resistor r=2.87058 //w=0.35 //l=0.085 //layer=li \
 //thickness=0.1 //x=36.215 //y=7.585 //x2=36.13 //y2=7.585
r1976 (  569 1143 ) resistor r=2.87058 //w=0.35 //l=0.085 //layer=li \
 //thickness=0.1 //x=36.925 //y=7.585 //x2=37.01 //y2=7.585
r1977 (  569 570 ) resistor r=24.7629 //w=0.367 //l=0.71 //layer=li \
 //thickness=0.1 //x=36.925 //y=7.585 //x2=36.215 //y2=7.585
r1978 (  563 1142 ) resistor r=4.23183 //w=0.7 //l=0.175 //layer=li \
 //thickness=0.1 //x=36.13 //y=7.41 //x2=36.13 //y2=7.585
r1979 (  563 1227 ) resistor r=33.1979 //w=0.187 //l=0.485 //layer=li \
 //thickness=0.1 //x=36.13 //y=7.41 //x2=36.13 //y2=6.925
r1980 (  560 1141 ) resistor r=2.87058 //w=0.35 //l=0.085 //layer=li \
 //thickness=0.1 //x=35.335 //y=7.585 //x2=35.25 //y2=7.585
r1981 (  560 562 ) resistor r=23.5422 //w=0.367 //l=0.675 //layer=li \
 //thickness=0.1 //x=35.335 //y=7.585 //x2=36.01 //y2=7.585
r1982 (  559 1142 ) resistor r=2.87058 //w=0.35 //l=0.085 //layer=li \
 //thickness=0.1 //x=36.045 //y=7.585 //x2=36.13 //y2=7.585
r1983 (  559 562 ) resistor r=1.22071 //w=0.367 //l=0.035 //layer=li \
 //thickness=0.1 //x=36.045 //y=7.585 //x2=36.01 //y2=7.585
r1984 (  551 1141 ) resistor r=4.23183 //w=0.7 //l=0.175 //layer=li \
 //thickness=0.1 //x=35.25 //y=7.41 //x2=35.25 //y2=7.585
r1985 (  551 1226 ) resistor r=56.4706 //w=0.187 //l=0.825 //layer=li \
 //thickness=0.1 //x=35.25 //y=7.41 //x2=35.25 //y2=6.585
r1986 (  548 1140 ) resistor r=5.29055 //w=0.35 //l=0.17 //layer=li \
 //thickness=0.1 //x=34.33 //y=7.585 //x2=34.16 //y2=7.585
r1987 (  548 550 ) resistor r=19.8801 //w=0.367 //l=0.57 //layer=li \
 //thickness=0.1 //x=34.33 //y=7.585 //x2=34.9 //y2=7.585
r1988 (  547 1141 ) resistor r=2.87058 //w=0.35 //l=0.085 //layer=li \
 //thickness=0.1 //x=35.165 //y=7.585 //x2=35.25 //y2=7.585
r1989 (  547 550 ) resistor r=9.24251 //w=0.367 //l=0.265 //layer=li \
 //thickness=0.1 //x=35.165 //y=7.585 //x2=34.9 //y2=7.585
r1990 (  542 1139 ) resistor r=2.87058 //w=0.35 //l=0.085 //layer=li \
 //thickness=0.1 //x=33.165 //y=7.585 //x2=33.08 //y2=7.585
r1991 (  542 544 ) resistor r=8.89373 //w=0.367 //l=0.255 //layer=li \
 //thickness=0.1 //x=33.165 //y=7.585 //x2=33.42 //y2=7.585
r1992 (  541 1140 ) resistor r=5.29055 //w=0.35 //l=0.17 //layer=li \
 //thickness=0.1 //x=33.99 //y=7.585 //x2=34.16 //y2=7.585
r1993 (  541 544 ) resistor r=19.8801 //w=0.367 //l=0.57 //layer=li \
 //thickness=0.1 //x=33.99 //y=7.585 //x2=33.42 //y2=7.585
r1994 (  535 1139 ) resistor r=4.23183 //w=0.7 //l=0.175 //layer=li \
 //thickness=0.1 //x=33.08 //y=7.41 //x2=33.08 //y2=7.585
r1995 (  535 1225 ) resistor r=33.1979 //w=0.187 //l=0.485 //layer=li \
 //thickness=0.1 //x=33.08 //y=7.41 //x2=33.08 //y2=6.925
r1996 (  532 1138 ) resistor r=2.87058 //w=0.35 //l=0.085 //layer=li \
 //thickness=0.1 //x=32.285 //y=7.585 //x2=32.2 //y2=7.585
r1997 (  532 534 ) resistor r=0.871935 //w=0.367 //l=0.025 //layer=li \
 //thickness=0.1 //x=32.285 //y=7.585 //x2=32.31 //y2=7.585
r1998 (  531 1139 ) resistor r=2.87058 //w=0.35 //l=0.085 //layer=li \
 //thickness=0.1 //x=32.995 //y=7.585 //x2=33.08 //y2=7.585
r1999 (  531 534 ) resistor r=23.891 //w=0.367 //l=0.685 //layer=li \
 //thickness=0.1 //x=32.995 //y=7.585 //x2=32.31 //y2=7.585
r2000 (  525 1138 ) resistor r=4.23183 //w=0.7 //l=0.175 //layer=li \
 //thickness=0.1 //x=32.2 //y=7.41 //x2=32.2 //y2=7.585
r2001 (  525 1224 ) resistor r=33.1979 //w=0.187 //l=0.485 //layer=li \
 //thickness=0.1 //x=32.2 //y=7.41 //x2=32.2 //y2=6.925
r2002 (  524 1137 ) resistor r=2.87058 //w=0.35 //l=0.085 //layer=li \
 //thickness=0.1 //x=31.405 //y=7.585 //x2=31.32 //y2=7.585
r2003 (  523 1138 ) resistor r=2.87058 //w=0.35 //l=0.085 //layer=li \
 //thickness=0.1 //x=32.115 //y=7.585 //x2=32.2 //y2=7.585
r2004 (  523 524 ) resistor r=24.7629 //w=0.367 //l=0.71 //layer=li \
 //thickness=0.1 //x=32.115 //y=7.585 //x2=31.405 //y2=7.585
r2005 (  517 1137 ) resistor r=4.23183 //w=0.7 //l=0.175 //layer=li \
 //thickness=0.1 //x=31.32 //y=7.41 //x2=31.32 //y2=7.585
r2006 (  517 1223 ) resistor r=33.1979 //w=0.187 //l=0.485 //layer=li \
 //thickness=0.1 //x=31.32 //y=7.41 //x2=31.32 //y2=6.925
r2007 (  514 1136 ) resistor r=2.87058 //w=0.35 //l=0.085 //layer=li \
 //thickness=0.1 //x=30.525 //y=7.585 //x2=30.44 //y2=7.585
r2008 (  514 516 ) resistor r=23.5422 //w=0.367 //l=0.675 //layer=li \
 //thickness=0.1 //x=30.525 //y=7.585 //x2=31.2 //y2=7.585
r2009 (  513 1137 ) resistor r=2.87058 //w=0.35 //l=0.085 //layer=li \
 //thickness=0.1 //x=31.235 //y=7.585 //x2=31.32 //y2=7.585
r2010 (  513 516 ) resistor r=1.22071 //w=0.367 //l=0.035 //layer=li \
 //thickness=0.1 //x=31.235 //y=7.585 //x2=31.2 //y2=7.585
r2011 (  505 1136 ) resistor r=4.23183 //w=0.7 //l=0.175 //layer=li \
 //thickness=0.1 //x=30.44 //y=7.41 //x2=30.44 //y2=7.585
r2012 (  505 1222 ) resistor r=56.4706 //w=0.187 //l=0.825 //layer=li \
 //thickness=0.1 //x=30.44 //y=7.41 //x2=30.44 //y2=6.585
r2013 (  502 1135 ) resistor r=5.29055 //w=0.35 //l=0.17 //layer=li \
 //thickness=0.1 //x=29.52 //y=7.585 //x2=29.35 //y2=7.585
r2014 (  502 504 ) resistor r=19.8801 //w=0.367 //l=0.57 //layer=li \
 //thickness=0.1 //x=29.52 //y=7.585 //x2=30.09 //y2=7.585
r2015 (  501 1136 ) resistor r=2.87058 //w=0.35 //l=0.085 //layer=li \
 //thickness=0.1 //x=30.355 //y=7.585 //x2=30.44 //y2=7.585
r2016 (  501 504 ) resistor r=9.24251 //w=0.367 //l=0.265 //layer=li \
 //thickness=0.1 //x=30.355 //y=7.585 //x2=30.09 //y2=7.585
r2017 (  496 1134 ) resistor r=2.87058 //w=0.35 //l=0.085 //layer=li \
 //thickness=0.1 //x=28.355 //y=7.585 //x2=28.27 //y2=7.585
r2018 (  496 498 ) resistor r=8.89373 //w=0.367 //l=0.255 //layer=li \
 //thickness=0.1 //x=28.355 //y=7.585 //x2=28.61 //y2=7.585
r2019 (  495 1135 ) resistor r=5.29055 //w=0.35 //l=0.17 //layer=li \
 //thickness=0.1 //x=29.18 //y=7.585 //x2=29.35 //y2=7.585
r2020 (  495 498 ) resistor r=19.8801 //w=0.367 //l=0.57 //layer=li \
 //thickness=0.1 //x=29.18 //y=7.585 //x2=28.61 //y2=7.585
r2021 (  489 1134 ) resistor r=4.23183 //w=0.7 //l=0.175 //layer=li \
 //thickness=0.1 //x=28.27 //y=7.41 //x2=28.27 //y2=7.585
r2022 (  489 1221 ) resistor r=33.1979 //w=0.187 //l=0.485 //layer=li \
 //thickness=0.1 //x=28.27 //y=7.41 //x2=28.27 //y2=6.925
r2023 (  486 1133 ) resistor r=2.87058 //w=0.35 //l=0.085 //layer=li \
 //thickness=0.1 //x=27.475 //y=7.585 //x2=27.39 //y2=7.585
r2024 (  486 488 ) resistor r=0.871935 //w=0.367 //l=0.025 //layer=li \
 //thickness=0.1 //x=27.475 //y=7.585 //x2=27.5 //y2=7.585
r2025 (  485 1134 ) resistor r=2.87058 //w=0.35 //l=0.085 //layer=li \
 //thickness=0.1 //x=28.185 //y=7.585 //x2=28.27 //y2=7.585
r2026 (  485 488 ) resistor r=23.891 //w=0.367 //l=0.685 //layer=li \
 //thickness=0.1 //x=28.185 //y=7.585 //x2=27.5 //y2=7.585
r2027 (  479 1133 ) resistor r=4.23183 //w=0.7 //l=0.175 //layer=li \
 //thickness=0.1 //x=27.39 //y=7.41 //x2=27.39 //y2=7.585
r2028 (  479 1220 ) resistor r=33.1979 //w=0.187 //l=0.485 //layer=li \
 //thickness=0.1 //x=27.39 //y=7.41 //x2=27.39 //y2=6.925
r2029 (  478 1132 ) resistor r=2.87058 //w=0.35 //l=0.085 //layer=li \
 //thickness=0.1 //x=26.595 //y=7.585 //x2=26.51 //y2=7.585
r2030 (  477 1133 ) resistor r=2.87058 //w=0.35 //l=0.085 //layer=li \
 //thickness=0.1 //x=27.305 //y=7.585 //x2=27.39 //y2=7.585
r2031 (  477 478 ) resistor r=24.7629 //w=0.367 //l=0.71 //layer=li \
 //thickness=0.1 //x=27.305 //y=7.585 //x2=26.595 //y2=7.585
r2032 (  471 1132 ) resistor r=4.23183 //w=0.7 //l=0.175 //layer=li \
 //thickness=0.1 //x=26.51 //y=7.41 //x2=26.51 //y2=7.585
r2033 (  471 1219 ) resistor r=33.1979 //w=0.187 //l=0.485 //layer=li \
 //thickness=0.1 //x=26.51 //y=7.41 //x2=26.51 //y2=6.925
r2034 (  468 1131 ) resistor r=2.87058 //w=0.35 //l=0.085 //layer=li \
 //thickness=0.1 //x=25.715 //y=7.585 //x2=25.63 //y2=7.585
r2035 (  468 470 ) resistor r=23.5422 //w=0.367 //l=0.675 //layer=li \
 //thickness=0.1 //x=25.715 //y=7.585 //x2=26.39 //y2=7.585
r2036 (  467 1132 ) resistor r=2.87058 //w=0.35 //l=0.085 //layer=li \
 //thickness=0.1 //x=26.425 //y=7.585 //x2=26.51 //y2=7.585
r2037 (  467 470 ) resistor r=1.22071 //w=0.367 //l=0.035 //layer=li \
 //thickness=0.1 //x=26.425 //y=7.585 //x2=26.39 //y2=7.585
r2038 (  459 1131 ) resistor r=4.23183 //w=0.7 //l=0.175 //layer=li \
 //thickness=0.1 //x=25.63 //y=7.41 //x2=25.63 //y2=7.585
r2039 (  459 1218 ) resistor r=56.4706 //w=0.187 //l=0.825 //layer=li \
 //thickness=0.1 //x=25.63 //y=7.41 //x2=25.63 //y2=6.585
r2040 (  456 1130 ) resistor r=5.29055 //w=0.35 //l=0.17 //layer=li \
 //thickness=0.1 //x=24.71 //y=7.585 //x2=24.54 //y2=7.585
r2041 (  456 458 ) resistor r=19.8801 //w=0.367 //l=0.57 //layer=li \
 //thickness=0.1 //x=24.71 //y=7.585 //x2=25.28 //y2=7.585
r2042 (  455 1131 ) resistor r=2.87058 //w=0.35 //l=0.085 //layer=li \
 //thickness=0.1 //x=25.545 //y=7.585 //x2=25.63 //y2=7.585
r2043 (  455 458 ) resistor r=9.24251 //w=0.367 //l=0.265 //layer=li \
 //thickness=0.1 //x=25.545 //y=7.585 //x2=25.28 //y2=7.585
r2044 (  450 1129 ) resistor r=2.87058 //w=0.35 //l=0.085 //layer=li \
 //thickness=0.1 //x=23.545 //y=7.585 //x2=23.46 //y2=7.585
r2045 (  450 452 ) resistor r=8.89373 //w=0.367 //l=0.255 //layer=li \
 //thickness=0.1 //x=23.545 //y=7.585 //x2=23.8 //y2=7.585
r2046 (  449 1130 ) resistor r=5.29055 //w=0.35 //l=0.17 //layer=li \
 //thickness=0.1 //x=24.37 //y=7.585 //x2=24.54 //y2=7.585
r2047 (  449 452 ) resistor r=19.8801 //w=0.367 //l=0.57 //layer=li \
 //thickness=0.1 //x=24.37 //y=7.585 //x2=23.8 //y2=7.585
r2048 (  443 1129 ) resistor r=4.23183 //w=0.7 //l=0.175 //layer=li \
 //thickness=0.1 //x=23.46 //y=7.41 //x2=23.46 //y2=7.585
r2049 (  443 1217 ) resistor r=33.1979 //w=0.187 //l=0.485 //layer=li \
 //thickness=0.1 //x=23.46 //y=7.41 //x2=23.46 //y2=6.925
r2050 (  440 1128 ) resistor r=2.87058 //w=0.35 //l=0.085 //layer=li \
 //thickness=0.1 //x=22.665 //y=7.585 //x2=22.58 //y2=7.585
r2051 (  440 442 ) resistor r=0.871935 //w=0.367 //l=0.025 //layer=li \
 //thickness=0.1 //x=22.665 //y=7.585 //x2=22.69 //y2=7.585
r2052 (  439 1129 ) resistor r=2.87058 //w=0.35 //l=0.085 //layer=li \
 //thickness=0.1 //x=23.375 //y=7.585 //x2=23.46 //y2=7.585
r2053 (  439 442 ) resistor r=23.891 //w=0.367 //l=0.685 //layer=li \
 //thickness=0.1 //x=23.375 //y=7.585 //x2=22.69 //y2=7.585
r2054 (  433 1128 ) resistor r=4.23183 //w=0.7 //l=0.175 //layer=li \
 //thickness=0.1 //x=22.58 //y=7.41 //x2=22.58 //y2=7.585
r2055 (  433 1216 ) resistor r=33.1979 //w=0.187 //l=0.485 //layer=li \
 //thickness=0.1 //x=22.58 //y=7.41 //x2=22.58 //y2=6.925
r2056 (  432 1127 ) resistor r=2.87058 //w=0.35 //l=0.085 //layer=li \
 //thickness=0.1 //x=21.785 //y=7.585 //x2=21.7 //y2=7.585
r2057 (  431 1128 ) resistor r=2.87058 //w=0.35 //l=0.085 //layer=li \
 //thickness=0.1 //x=22.495 //y=7.585 //x2=22.58 //y2=7.585
r2058 (  431 432 ) resistor r=24.7629 //w=0.367 //l=0.71 //layer=li \
 //thickness=0.1 //x=22.495 //y=7.585 //x2=21.785 //y2=7.585
r2059 (  425 1127 ) resistor r=4.23183 //w=0.7 //l=0.175 //layer=li \
 //thickness=0.1 //x=21.7 //y=7.41 //x2=21.7 //y2=7.585
r2060 (  425 1215 ) resistor r=33.1979 //w=0.187 //l=0.485 //layer=li \
 //thickness=0.1 //x=21.7 //y=7.41 //x2=21.7 //y2=6.925
r2061 (  422 1126 ) resistor r=2.87058 //w=0.35 //l=0.085 //layer=li \
 //thickness=0.1 //x=20.905 //y=7.585 //x2=20.82 //y2=7.585
r2062 (  422 424 ) resistor r=23.5422 //w=0.367 //l=0.675 //layer=li \
 //thickness=0.1 //x=20.905 //y=7.585 //x2=21.58 //y2=7.585
r2063 (  421 1127 ) resistor r=2.87058 //w=0.35 //l=0.085 //layer=li \
 //thickness=0.1 //x=21.615 //y=7.585 //x2=21.7 //y2=7.585
r2064 (  421 424 ) resistor r=1.22071 //w=0.367 //l=0.035 //layer=li \
 //thickness=0.1 //x=21.615 //y=7.585 //x2=21.58 //y2=7.585
r2065 (  413 1126 ) resistor r=4.23183 //w=0.7 //l=0.175 //layer=li \
 //thickness=0.1 //x=20.82 //y=7.41 //x2=20.82 //y2=7.585
r2066 (  413 1214 ) resistor r=56.4706 //w=0.187 //l=0.825 //layer=li \
 //thickness=0.1 //x=20.82 //y=7.41 //x2=20.82 //y2=6.585
r2067 (  410 1125 ) resistor r=5.29055 //w=0.35 //l=0.17 //layer=li \
 //thickness=0.1 //x=19.9 //y=7.585 //x2=19.73 //y2=7.585
r2068 (  410 412 ) resistor r=19.8801 //w=0.367 //l=0.57 //layer=li \
 //thickness=0.1 //x=19.9 //y=7.585 //x2=20.47 //y2=7.585
r2069 (  409 1126 ) resistor r=2.87058 //w=0.35 //l=0.085 //layer=li \
 //thickness=0.1 //x=20.735 //y=7.585 //x2=20.82 //y2=7.585
r2070 (  409 412 ) resistor r=9.24251 //w=0.367 //l=0.265 //layer=li \
 //thickness=0.1 //x=20.735 //y=7.585 //x2=20.47 //y2=7.585
r2071 (  404 1124 ) resistor r=2.87058 //w=0.35 //l=0.085 //layer=li \
 //thickness=0.1 //x=18.735 //y=7.585 //x2=18.65 //y2=7.585
r2072 (  404 406 ) resistor r=8.89373 //w=0.367 //l=0.255 //layer=li \
 //thickness=0.1 //x=18.735 //y=7.585 //x2=18.99 //y2=7.585
r2073 (  403 1125 ) resistor r=5.29055 //w=0.35 //l=0.17 //layer=li \
 //thickness=0.1 //x=19.56 //y=7.585 //x2=19.73 //y2=7.585
r2074 (  403 406 ) resistor r=19.8801 //w=0.367 //l=0.57 //layer=li \
 //thickness=0.1 //x=19.56 //y=7.585 //x2=18.99 //y2=7.585
r2075 (  397 1124 ) resistor r=4.23183 //w=0.7 //l=0.175 //layer=li \
 //thickness=0.1 //x=18.65 //y=7.41 //x2=18.65 //y2=7.585
r2076 (  397 1213 ) resistor r=33.1979 //w=0.187 //l=0.485 //layer=li \
 //thickness=0.1 //x=18.65 //y=7.41 //x2=18.65 //y2=6.925
r2077 (  394 1123 ) resistor r=2.87058 //w=0.35 //l=0.085 //layer=li \
 //thickness=0.1 //x=17.855 //y=7.585 //x2=17.77 //y2=7.585
r2078 (  394 396 ) resistor r=0.871935 //w=0.367 //l=0.025 //layer=li \
 //thickness=0.1 //x=17.855 //y=7.585 //x2=17.88 //y2=7.585
r2079 (  393 1124 ) resistor r=2.87058 //w=0.35 //l=0.085 //layer=li \
 //thickness=0.1 //x=18.565 //y=7.585 //x2=18.65 //y2=7.585
r2080 (  393 396 ) resistor r=23.891 //w=0.367 //l=0.685 //layer=li \
 //thickness=0.1 //x=18.565 //y=7.585 //x2=17.88 //y2=7.585
r2081 (  387 1123 ) resistor r=4.23183 //w=0.7 //l=0.175 //layer=li \
 //thickness=0.1 //x=17.77 //y=7.41 //x2=17.77 //y2=7.585
r2082 (  387 1212 ) resistor r=33.1979 //w=0.187 //l=0.485 //layer=li \
 //thickness=0.1 //x=17.77 //y=7.41 //x2=17.77 //y2=6.925
r2083 (  386 1122 ) resistor r=2.87058 //w=0.35 //l=0.085 //layer=li \
 //thickness=0.1 //x=16.975 //y=7.585 //x2=16.89 //y2=7.585
r2084 (  385 1123 ) resistor r=2.87058 //w=0.35 //l=0.085 //layer=li \
 //thickness=0.1 //x=17.685 //y=7.585 //x2=17.77 //y2=7.585
r2085 (  385 386 ) resistor r=24.7629 //w=0.367 //l=0.71 //layer=li \
 //thickness=0.1 //x=17.685 //y=7.585 //x2=16.975 //y2=7.585
r2086 (  379 1122 ) resistor r=4.23183 //w=0.7 //l=0.175 //layer=li \
 //thickness=0.1 //x=16.89 //y=7.41 //x2=16.89 //y2=7.585
r2087 (  379 1211 ) resistor r=33.1979 //w=0.187 //l=0.485 //layer=li \
 //thickness=0.1 //x=16.89 //y=7.41 //x2=16.89 //y2=6.925
r2088 (  376 1121 ) resistor r=2.87058 //w=0.35 //l=0.085 //layer=li \
 //thickness=0.1 //x=16.095 //y=7.585 //x2=16.01 //y2=7.585
r2089 (  376 378 ) resistor r=23.5422 //w=0.367 //l=0.675 //layer=li \
 //thickness=0.1 //x=16.095 //y=7.585 //x2=16.77 //y2=7.585
r2090 (  375 1122 ) resistor r=2.87058 //w=0.35 //l=0.085 //layer=li \
 //thickness=0.1 //x=16.805 //y=7.585 //x2=16.89 //y2=7.585
r2091 (  375 378 ) resistor r=1.22071 //w=0.367 //l=0.035 //layer=li \
 //thickness=0.1 //x=16.805 //y=7.585 //x2=16.77 //y2=7.585
r2092 (  367 1121 ) resistor r=4.23183 //w=0.7 //l=0.175 //layer=li \
 //thickness=0.1 //x=16.01 //y=7.41 //x2=16.01 //y2=7.585
r2093 (  367 1210 ) resistor r=56.4706 //w=0.187 //l=0.825 //layer=li \
 //thickness=0.1 //x=16.01 //y=7.41 //x2=16.01 //y2=6.585
r2094 (  364 1120 ) resistor r=5.29055 //w=0.35 //l=0.17 //layer=li \
 //thickness=0.1 //x=15.09 //y=7.585 //x2=14.92 //y2=7.585
r2095 (  364 366 ) resistor r=19.8801 //w=0.367 //l=0.57 //layer=li \
 //thickness=0.1 //x=15.09 //y=7.585 //x2=15.66 //y2=7.585
r2096 (  363 1121 ) resistor r=2.87058 //w=0.35 //l=0.085 //layer=li \
 //thickness=0.1 //x=15.925 //y=7.585 //x2=16.01 //y2=7.585
r2097 (  363 366 ) resistor r=9.24251 //w=0.367 //l=0.265 //layer=li \
 //thickness=0.1 //x=15.925 //y=7.585 //x2=15.66 //y2=7.585
r2098 (  358 1119 ) resistor r=2.87058 //w=0.35 //l=0.085 //layer=li \
 //thickness=0.1 //x=13.925 //y=7.585 //x2=13.84 //y2=7.585
r2099 (  358 360 ) resistor r=8.89373 //w=0.367 //l=0.255 //layer=li \
 //thickness=0.1 //x=13.925 //y=7.585 //x2=14.18 //y2=7.585
r2100 (  357 1120 ) resistor r=5.29055 //w=0.35 //l=0.17 //layer=li \
 //thickness=0.1 //x=14.75 //y=7.585 //x2=14.92 //y2=7.585
r2101 (  357 360 ) resistor r=19.8801 //w=0.367 //l=0.57 //layer=li \
 //thickness=0.1 //x=14.75 //y=7.585 //x2=14.18 //y2=7.585
r2102 (  351 1119 ) resistor r=4.23183 //w=0.7 //l=0.175 //layer=li \
 //thickness=0.1 //x=13.84 //y=7.41 //x2=13.84 //y2=7.585
r2103 (  351 1209 ) resistor r=33.1979 //w=0.187 //l=0.485 //layer=li \
 //thickness=0.1 //x=13.84 //y=7.41 //x2=13.84 //y2=6.925
r2104 (  348 1118 ) resistor r=2.87058 //w=0.35 //l=0.085 //layer=li \
 //thickness=0.1 //x=13.045 //y=7.585 //x2=12.96 //y2=7.585
r2105 (  348 350 ) resistor r=0.871935 //w=0.367 //l=0.025 //layer=li \
 //thickness=0.1 //x=13.045 //y=7.585 //x2=13.07 //y2=7.585
r2106 (  347 1119 ) resistor r=2.87058 //w=0.35 //l=0.085 //layer=li \
 //thickness=0.1 //x=13.755 //y=7.585 //x2=13.84 //y2=7.585
r2107 (  347 350 ) resistor r=23.891 //w=0.367 //l=0.685 //layer=li \
 //thickness=0.1 //x=13.755 //y=7.585 //x2=13.07 //y2=7.585
r2108 (  341 1118 ) resistor r=4.23183 //w=0.7 //l=0.175 //layer=li \
 //thickness=0.1 //x=12.96 //y=7.41 //x2=12.96 //y2=7.585
r2109 (  341 1208 ) resistor r=33.1979 //w=0.187 //l=0.485 //layer=li \
 //thickness=0.1 //x=12.96 //y=7.41 //x2=12.96 //y2=6.925
r2110 (  340 1117 ) resistor r=2.87058 //w=0.35 //l=0.085 //layer=li \
 //thickness=0.1 //x=12.165 //y=7.585 //x2=12.08 //y2=7.585
r2111 (  339 1118 ) resistor r=2.87058 //w=0.35 //l=0.085 //layer=li \
 //thickness=0.1 //x=12.875 //y=7.585 //x2=12.96 //y2=7.585
r2112 (  339 340 ) resistor r=24.7629 //w=0.367 //l=0.71 //layer=li \
 //thickness=0.1 //x=12.875 //y=7.585 //x2=12.165 //y2=7.585
r2113 (  333 1117 ) resistor r=4.23183 //w=0.7 //l=0.175 //layer=li \
 //thickness=0.1 //x=12.08 //y=7.41 //x2=12.08 //y2=7.585
r2114 (  333 1207 ) resistor r=33.1979 //w=0.187 //l=0.485 //layer=li \
 //thickness=0.1 //x=12.08 //y=7.41 //x2=12.08 //y2=6.925
r2115 (  330 1116 ) resistor r=2.87058 //w=0.35 //l=0.085 //layer=li \
 //thickness=0.1 //x=11.285 //y=7.585 //x2=11.2 //y2=7.585
r2116 (  330 332 ) resistor r=23.5422 //w=0.367 //l=0.675 //layer=li \
 //thickness=0.1 //x=11.285 //y=7.585 //x2=11.96 //y2=7.585
r2117 (  329 1117 ) resistor r=2.87058 //w=0.35 //l=0.085 //layer=li \
 //thickness=0.1 //x=11.995 //y=7.585 //x2=12.08 //y2=7.585
r2118 (  329 332 ) resistor r=1.22071 //w=0.367 //l=0.035 //layer=li \
 //thickness=0.1 //x=11.995 //y=7.585 //x2=11.96 //y2=7.585
r2119 (  321 1116 ) resistor r=4.23183 //w=0.7 //l=0.175 //layer=li \
 //thickness=0.1 //x=11.2 //y=7.41 //x2=11.2 //y2=7.585
r2120 (  321 1206 ) resistor r=56.4706 //w=0.187 //l=0.825 //layer=li \
 //thickness=0.1 //x=11.2 //y=7.41 //x2=11.2 //y2=6.585
r2121 (  318 1115 ) resistor r=5.29055 //w=0.35 //l=0.17 //layer=li \
 //thickness=0.1 //x=10.28 //y=7.585 //x2=10.11 //y2=7.585
r2122 (  318 320 ) resistor r=19.8801 //w=0.367 //l=0.57 //layer=li \
 //thickness=0.1 //x=10.28 //y=7.585 //x2=10.85 //y2=7.585
r2123 (  317 1116 ) resistor r=2.87058 //w=0.35 //l=0.085 //layer=li \
 //thickness=0.1 //x=11.115 //y=7.585 //x2=11.2 //y2=7.585
r2124 (  317 320 ) resistor r=9.24251 //w=0.367 //l=0.265 //layer=li \
 //thickness=0.1 //x=11.115 //y=7.585 //x2=10.85 //y2=7.585
r2125 (  312 1114 ) resistor r=2.87058 //w=0.35 //l=0.085 //layer=li \
 //thickness=0.1 //x=9.115 //y=7.585 //x2=9.03 //y2=7.585
r2126 (  312 314 ) resistor r=8.89373 //w=0.367 //l=0.255 //layer=li \
 //thickness=0.1 //x=9.115 //y=7.585 //x2=9.37 //y2=7.585
r2127 (  311 1115 ) resistor r=5.29055 //w=0.35 //l=0.17 //layer=li \
 //thickness=0.1 //x=9.94 //y=7.585 //x2=10.11 //y2=7.585
r2128 (  311 314 ) resistor r=19.8801 //w=0.367 //l=0.57 //layer=li \
 //thickness=0.1 //x=9.94 //y=7.585 //x2=9.37 //y2=7.585
r2129 (  305 1114 ) resistor r=4.23183 //w=0.7 //l=0.175 //layer=li \
 //thickness=0.1 //x=9.03 //y=7.41 //x2=9.03 //y2=7.585
r2130 (  305 1205 ) resistor r=33.1979 //w=0.187 //l=0.485 //layer=li \
 //thickness=0.1 //x=9.03 //y=7.41 //x2=9.03 //y2=6.925
r2131 (  302 1113 ) resistor r=2.87058 //w=0.35 //l=0.085 //layer=li \
 //thickness=0.1 //x=8.235 //y=7.585 //x2=8.15 //y2=7.585
r2132 (  302 304 ) resistor r=0.871935 //w=0.367 //l=0.025 //layer=li \
 //thickness=0.1 //x=8.235 //y=7.585 //x2=8.26 //y2=7.585
r2133 (  301 1114 ) resistor r=2.87058 //w=0.35 //l=0.085 //layer=li \
 //thickness=0.1 //x=8.945 //y=7.585 //x2=9.03 //y2=7.585
r2134 (  301 304 ) resistor r=23.891 //w=0.367 //l=0.685 //layer=li \
 //thickness=0.1 //x=8.945 //y=7.585 //x2=8.26 //y2=7.585
r2135 (  295 1113 ) resistor r=4.23183 //w=0.7 //l=0.175 //layer=li \
 //thickness=0.1 //x=8.15 //y=7.41 //x2=8.15 //y2=7.585
r2136 (  295 1204 ) resistor r=33.1979 //w=0.187 //l=0.485 //layer=li \
 //thickness=0.1 //x=8.15 //y=7.41 //x2=8.15 //y2=6.925
r2137 (  294 1112 ) resistor r=2.87058 //w=0.35 //l=0.085 //layer=li \
 //thickness=0.1 //x=7.355 //y=7.585 //x2=7.27 //y2=7.585
r2138 (  293 1113 ) resistor r=2.87058 //w=0.35 //l=0.085 //layer=li \
 //thickness=0.1 //x=8.065 //y=7.585 //x2=8.15 //y2=7.585
r2139 (  293 294 ) resistor r=24.7629 //w=0.367 //l=0.71 //layer=li \
 //thickness=0.1 //x=8.065 //y=7.585 //x2=7.355 //y2=7.585
r2140 (  287 1112 ) resistor r=4.23183 //w=0.7 //l=0.175 //layer=li \
 //thickness=0.1 //x=7.27 //y=7.41 //x2=7.27 //y2=7.585
r2141 (  287 1203 ) resistor r=33.1979 //w=0.187 //l=0.485 //layer=li \
 //thickness=0.1 //x=7.27 //y=7.41 //x2=7.27 //y2=6.925
r2142 (  284 1111 ) resistor r=2.87058 //w=0.35 //l=0.085 //layer=li \
 //thickness=0.1 //x=6.475 //y=7.585 //x2=6.39 //y2=7.585
r2143 (  284 286 ) resistor r=23.5422 //w=0.367 //l=0.675 //layer=li \
 //thickness=0.1 //x=6.475 //y=7.585 //x2=7.15 //y2=7.585
r2144 (  283 1112 ) resistor r=2.87058 //w=0.35 //l=0.085 //layer=li \
 //thickness=0.1 //x=7.185 //y=7.585 //x2=7.27 //y2=7.585
r2145 (  283 286 ) resistor r=1.22071 //w=0.367 //l=0.035 //layer=li \
 //thickness=0.1 //x=7.185 //y=7.585 //x2=7.15 //y2=7.585
r2146 (  275 1111 ) resistor r=4.23183 //w=0.7 //l=0.175 //layer=li \
 //thickness=0.1 //x=6.39 //y=7.41 //x2=6.39 //y2=7.585
r2147 (  275 1202 ) resistor r=56.4706 //w=0.187 //l=0.825 //layer=li \
 //thickness=0.1 //x=6.39 //y=7.41 //x2=6.39 //y2=6.585
r2148 (  272 1110 ) resistor r=5.29055 //w=0.35 //l=0.17 //layer=li \
 //thickness=0.1 //x=5.47 //y=7.585 //x2=5.3 //y2=7.585
r2149 (  272 274 ) resistor r=19.8801 //w=0.367 //l=0.57 //layer=li \
 //thickness=0.1 //x=5.47 //y=7.585 //x2=6.04 //y2=7.585
r2150 (  271 1111 ) resistor r=2.87058 //w=0.35 //l=0.085 //layer=li \
 //thickness=0.1 //x=6.305 //y=7.585 //x2=6.39 //y2=7.585
r2151 (  271 274 ) resistor r=9.24251 //w=0.367 //l=0.265 //layer=li \
 //thickness=0.1 //x=6.305 //y=7.585 //x2=6.04 //y2=7.585
r2152 (  266 1109 ) resistor r=2.87058 //w=0.35 //l=0.085 //layer=li \
 //thickness=0.1 //x=4.305 //y=7.585 //x2=4.22 //y2=7.585
r2153 (  266 268 ) resistor r=8.89373 //w=0.367 //l=0.255 //layer=li \
 //thickness=0.1 //x=4.305 //y=7.585 //x2=4.56 //y2=7.585
r2154 (  265 1110 ) resistor r=5.29055 //w=0.35 //l=0.17 //layer=li \
 //thickness=0.1 //x=5.13 //y=7.585 //x2=5.3 //y2=7.585
r2155 (  265 268 ) resistor r=19.8801 //w=0.367 //l=0.57 //layer=li \
 //thickness=0.1 //x=5.13 //y=7.585 //x2=4.56 //y2=7.585
r2156 (  259 1109 ) resistor r=4.23183 //w=0.7 //l=0.175 //layer=li \
 //thickness=0.1 //x=4.22 //y=7.41 //x2=4.22 //y2=7.585
r2157 (  259 1201 ) resistor r=33.1979 //w=0.187 //l=0.485 //layer=li \
 //thickness=0.1 //x=4.22 //y=7.41 //x2=4.22 //y2=6.925
r2158 (  256 1108 ) resistor r=2.87058 //w=0.35 //l=0.085 //layer=li \
 //thickness=0.1 //x=3.425 //y=7.585 //x2=3.34 //y2=7.585
r2159 (  256 258 ) resistor r=0.871935 //w=0.367 //l=0.025 //layer=li \
 //thickness=0.1 //x=3.425 //y=7.585 //x2=3.45 //y2=7.585
r2160 (  255 1109 ) resistor r=2.87058 //w=0.35 //l=0.085 //layer=li \
 //thickness=0.1 //x=4.135 //y=7.585 //x2=4.22 //y2=7.585
r2161 (  255 258 ) resistor r=23.891 //w=0.367 //l=0.685 //layer=li \
 //thickness=0.1 //x=4.135 //y=7.585 //x2=3.45 //y2=7.585
r2162 (  249 1108 ) resistor r=4.23183 //w=0.7 //l=0.175 //layer=li \
 //thickness=0.1 //x=3.34 //y=7.41 //x2=3.34 //y2=7.585
r2163 (  249 1200 ) resistor r=33.1979 //w=0.187 //l=0.485 //layer=li \
 //thickness=0.1 //x=3.34 //y=7.41 //x2=3.34 //y2=6.925
r2164 (  248 1107 ) resistor r=2.87058 //w=0.35 //l=0.085 //layer=li \
 //thickness=0.1 //x=2.545 //y=7.585 //x2=2.46 //y2=7.585
r2165 (  247 1108 ) resistor r=2.87058 //w=0.35 //l=0.085 //layer=li \
 //thickness=0.1 //x=3.255 //y=7.585 //x2=3.34 //y2=7.585
r2166 (  247 248 ) resistor r=24.7629 //w=0.367 //l=0.71 //layer=li \
 //thickness=0.1 //x=3.255 //y=7.585 //x2=2.545 //y2=7.585
r2167 (  241 1107 ) resistor r=4.23183 //w=0.7 //l=0.175 //layer=li \
 //thickness=0.1 //x=2.46 //y=7.41 //x2=2.46 //y2=7.585
r2168 (  241 1199 ) resistor r=33.1979 //w=0.187 //l=0.485 //layer=li \
 //thickness=0.1 //x=2.46 //y=7.41 //x2=2.46 //y2=6.925
r2169 (  238 1106 ) resistor r=2.87058 //w=0.35 //l=0.085 //layer=li \
 //thickness=0.1 //x=1.665 //y=7.585 //x2=1.58 //y2=7.585
r2170 (  238 240 ) resistor r=23.5422 //w=0.367 //l=0.675 //layer=li \
 //thickness=0.1 //x=1.665 //y=7.585 //x2=2.34 //y2=7.585
r2171 (  237 1107 ) resistor r=2.87058 //w=0.35 //l=0.085 //layer=li \
 //thickness=0.1 //x=2.375 //y=7.585 //x2=2.46 //y2=7.585
r2172 (  237 240 ) resistor r=1.22071 //w=0.367 //l=0.035 //layer=li \
 //thickness=0.1 //x=2.375 //y=7.585 //x2=2.34 //y2=7.585
r2173 (  229 1106 ) resistor r=4.23183 //w=0.7 //l=0.175 //layer=li \
 //thickness=0.1 //x=1.58 //y=7.41 //x2=1.58 //y2=7.585
r2174 (  229 1198 ) resistor r=56.4706 //w=0.187 //l=0.825 //layer=li \
 //thickness=0.1 //x=1.58 //y=7.41 //x2=1.58 //y2=6.585
r2175 (  225 1106 ) resistor r=2.87058 //w=0.35 //l=0.085 //layer=li \
 //thickness=0.1 //x=1.495 //y=7.585 //x2=1.58 //y2=7.585
r2176 (  225 228 ) resistor r=9.24251 //w=0.367 //l=0.265 //layer=li \
 //thickness=0.1 //x=1.495 //y=7.585 //x2=1.23 //y2=7.585
r2177 (  222 1084 ) resistor r=9.3 //w=0.17 //l=0.17 //layer=mcon //count=1 \
 //x=89.62 //y=6.92 //x2=89.62 //y2=6.92
r2178 (  219 1271 ) resistor r=9.3 //w=0.17 //l=0.17 //layer=mcon //count=1 \
 //x=88.74 //y=6.92 //x2=88.74 //y2=6.92
r2179 (  216 1069 ) resistor r=9.3 //w=0.17 //l=0.17 //layer=mcon //count=1 \
 //x=87.86 //y=6.92 //x2=87.86 //y2=6.92
r2180 (  212 1056 ) resistor r=3.1 //w=0.17 //l=0.51 //layer=mcon //count=3 \
 //x=87.81 //y=7.58 //x2=87.81 //y2=7.58
r2181 (  173 1103 ) resistor r=3.1 //w=0.17 //l=0.51 //layer=mcon //count=3 \
 //x=96.32 //y=7.58 //x2=96.32 //y2=7.58
r2182 (  171 1101 ) resistor r=3.1 //w=0.17 //l=0.51 //layer=mcon //count=3 \
 //x=95.21 //y=7.58 //x2=95.21 //y2=7.58
r2183 (  171 173 ) resistor r=0.446141 //w=0.311 //l=1.11 //layer=m1 \
 //thickness=0.36 //x=95.21 //y=7.585 //x2=96.32 //y2=7.585
r2184 (  169 1099 ) resistor r=3.1 //w=0.17 //l=0.51 //layer=mcon //count=3 \
 //x=94.1 //y=7.58 //x2=94.1 //y2=7.58
r2185 (  169 171 ) resistor r=0.446141 //w=0.311 //l=1.11 //layer=m1 \
 //thickness=0.36 //x=94.1 //y=7.585 //x2=95.21 //y2=7.585
r2186 (  167 1093 ) resistor r=3.1 //w=0.17 //l=0.51 //layer=mcon //count=3 \
 //x=92.62 //y=7.58 //x2=92.62 //y2=7.58
r2187 (  167 169 ) resistor r=0.594855 //w=0.311 //l=1.48 //layer=m1 \
 //thickness=0.36 //x=92.62 //y=7.585 //x2=94.1 //y2=7.585
r2188 (  165 1091 ) resistor r=3.1 //w=0.17 //l=0.51 //layer=mcon //count=3 \
 //x=91.51 //y=7.58 //x2=91.51 //y2=7.58
r2189 (  165 167 ) resistor r=0.446141 //w=0.311 //l=1.11 //layer=m1 \
 //thickness=0.36 //x=91.51 //y=7.585 //x2=92.62 //y2=7.585
r2190 (  163 1060 ) resistor r=3.1 //w=0.17 //l=0.51 //layer=mcon //count=3 \
 //x=90.03 //y=7.58 //x2=90.03 //y2=7.58
r2191 (  163 165 ) resistor r=0.594855 //w=0.311 //l=1.48 //layer=m1 \
 //thickness=0.36 //x=90.03 //y=7.585 //x2=91.51 //y2=7.585
r2192 (  161 220 ) resistor r=0.028033 //w=0.35 //l=0.085 //layer=m1 \
 //thickness=0.36 //x=89.705 //y=7.585 //x2=89.62 //y2=7.585
r2193 (  161 163 ) resistor r=0.130627 //w=0.311 //l=0.325 //layer=m1 \
 //thickness=0.36 //x=89.705 //y=7.585 //x2=90.03 //y2=7.585
r2194 (  160 220 ) resistor r=0.0413265 //w=0.7 //l=0.175 //layer=m1 \
 //thickness=0.36 //x=89.62 //y=7.41 //x2=89.62 //y2=7.585
r2195 (  159 222 ) resistor r=0.0715665 //w=0.226 //l=0.115 //layer=m1 \
 //thickness=0.36 //x=89.62 //y=7.035 //x2=89.62 //y2=6.92
r2196 (  159 160 ) resistor r=0.357824 //w=0.131 //l=0.375 //layer=m1 \
 //thickness=0.36 //x=89.62 //y=7.035 //x2=89.62 //y2=7.41
r2197 (  158 1058 ) resistor r=3.1 //w=0.17 //l=0.51 //layer=mcon //count=3 \
 //x=88.92 //y=7.58 //x2=88.92 //y2=7.58
r2198 (  156 217 ) resistor r=0.028033 //w=0.35 //l=0.085 //layer=m1 \
 //thickness=0.36 //x=88.825 //y=7.585 //x2=88.74 //y2=7.585
r2199 (  156 158 ) resistor r=0.0381833 //w=0.311 //l=0.095 //layer=m1 \
 //thickness=0.36 //x=88.825 //y=7.585 //x2=88.92 //y2=7.585
r2200 (  155 220 ) resistor r=0.028033 //w=0.35 //l=0.085 //layer=m1 \
 //thickness=0.36 //x=89.535 //y=7.585 //x2=89.62 //y2=7.585
r2201 (  155 158 ) resistor r=0.247186 //w=0.311 //l=0.615 //layer=m1 \
 //thickness=0.36 //x=89.535 //y=7.585 //x2=88.92 //y2=7.585
r2202 (  154 217 ) resistor r=0.0413265 //w=0.7 //l=0.175 //layer=m1 \
 //thickness=0.36 //x=88.74 //y=7.41 //x2=88.74 //y2=7.585
r2203 (  153 219 ) resistor r=0.0715665 //w=0.226 //l=0.117473 //layer=m1 \
 //thickness=0.36 //x=88.74 //y=7.035 //x2=88.745 //y2=6.92
r2204 (  153 154 ) resistor r=0.357824 //w=0.131 //l=0.375 //layer=m1 \
 //thickness=0.36 //x=88.74 //y=7.035 //x2=88.74 //y2=7.41
r2205 (  152 212 ) resistor r=0.028033 //w=0.35 //l=0.085 //layer=m1 \
 //thickness=0.36 //x=87.945 //y=7.585 //x2=87.86 //y2=7.585
r2206 (  151 217 ) resistor r=0.028033 //w=0.35 //l=0.085 //layer=m1 \
 //thickness=0.36 //x=88.655 //y=7.585 //x2=88.74 //y2=7.585
r2207 (  151 152 ) resistor r=0.28537 //w=0.311 //l=0.71 //layer=m1 \
 //thickness=0.36 //x=88.655 //y=7.585 //x2=87.945 //y2=7.585
r2208 (  150 212 ) resistor r=0.0413265 //w=0.7 //l=0.175 //layer=m1 \
 //thickness=0.36 //x=87.86 //y=7.41 //x2=87.86 //y2=7.585
r2209 (  149 216 ) resistor r=0.0712609 //w=0.23 //l=0.11649 //layer=m1 \
 //thickness=0.36 //x=87.86 //y=7.035 //x2=87.857 //y2=6.92
r2210 (  149 150 ) resistor r=0.357824 //w=0.131 //l=0.375 //layer=m1 \
 //thickness=0.36 //x=87.86 //y=7.035 //x2=87.86 //y2=7.41
r2211 (  148 1050 ) resistor r=3.1 //w=0.17 //l=0.51 //layer=mcon //count=3 \
 //x=86.33 //y=7.58 //x2=86.33 //y2=7.58
r2212 (  146 1040 ) resistor r=3.1 //w=0.17 //l=0.51 //layer=mcon //count=3 \
 //x=85.22 //y=7.58 //x2=85.22 //y2=7.58
r2213 (  146 148 ) resistor r=0.446141 //w=0.311 //l=1.11 //layer=m1 \
 //thickness=0.36 //x=85.22 //y=7.585 //x2=86.33 //y2=7.585
r2214 (  144 1022 ) resistor r=3.1 //w=0.17 //l=0.51 //layer=mcon //count=3 \
 //x=84.11 //y=7.58 //x2=84.11 //y2=7.58
r2215 (  144 146 ) resistor r=0.446141 //w=0.311 //l=1.11 //layer=m1 \
 //thickness=0.36 //x=84.11 //y=7.585 //x2=85.22 //y2=7.585
r2216 (  142 1010 ) resistor r=3.1 //w=0.17 //l=0.51 //layer=mcon //count=3 \
 //x=83 //y=7.58 //x2=83 //y2=7.58
r2217 (  142 144 ) resistor r=0.446141 //w=0.311 //l=1.11 //layer=m1 \
 //thickness=0.36 //x=83 //y=7.585 //x2=84.11 //y2=7.585
r2218 (  140 1004 ) resistor r=3.1 //w=0.17 //l=0.51 //layer=mcon //count=3 \
 //x=81.52 //y=7.58 //x2=81.52 //y2=7.58
r2219 (  140 142 ) resistor r=0.594855 //w=0.311 //l=1.48 //layer=m1 \
 //thickness=0.36 //x=81.52 //y=7.585 //x2=83 //y2=7.585
r2220 (  138 994 ) resistor r=3.1 //w=0.17 //l=0.51 //layer=mcon //count=3 \
 //x=80.41 //y=7.58 //x2=80.41 //y2=7.58
r2221 (  138 140 ) resistor r=0.446141 //w=0.311 //l=1.11 //layer=m1 \
 //thickness=0.36 //x=80.41 //y=7.585 //x2=81.52 //y2=7.585
r2222 (  136 976 ) resistor r=3.1 //w=0.17 //l=0.51 //layer=mcon //count=3 \
 //x=79.3 //y=7.58 //x2=79.3 //y2=7.58
r2223 (  136 138 ) resistor r=0.446141 //w=0.311 //l=1.11 //layer=m1 \
 //thickness=0.36 //x=79.3 //y=7.585 //x2=80.41 //y2=7.585
r2224 (  134 964 ) resistor r=3.1 //w=0.17 //l=0.51 //layer=mcon //count=3 \
 //x=78.19 //y=7.58 //x2=78.19 //y2=7.58
r2225 (  134 136 ) resistor r=0.446141 //w=0.311 //l=1.11 //layer=m1 \
 //thickness=0.36 //x=78.19 //y=7.585 //x2=79.3 //y2=7.585
r2226 (  132 958 ) resistor r=3.1 //w=0.17 //l=0.51 //layer=mcon //count=3 \
 //x=76.71 //y=7.58 //x2=76.71 //y2=7.58
r2227 (  132 134 ) resistor r=0.594855 //w=0.311 //l=1.48 //layer=m1 \
 //thickness=0.36 //x=76.71 //y=7.585 //x2=78.19 //y2=7.585
r2228 (  130 948 ) resistor r=3.1 //w=0.17 //l=0.51 //layer=mcon //count=3 \
 //x=75.6 //y=7.58 //x2=75.6 //y2=7.58
r2229 (  130 132 ) resistor r=0.446141 //w=0.311 //l=1.11 //layer=m1 \
 //thickness=0.36 //x=75.6 //y=7.585 //x2=76.71 //y2=7.585
r2230 (  128 930 ) resistor r=3.1 //w=0.17 //l=0.51 //layer=mcon //count=3 \
 //x=74.49 //y=7.58 //x2=74.49 //y2=7.58
r2231 (  128 130 ) resistor r=0.446141 //w=0.311 //l=1.11 //layer=m1 \
 //thickness=0.36 //x=74.49 //y=7.585 //x2=75.6 //y2=7.585
r2232 (  126 918 ) resistor r=3.1 //w=0.17 //l=0.51 //layer=mcon //count=3 \
 //x=73.38 //y=7.58 //x2=73.38 //y2=7.58
r2233 (  126 128 ) resistor r=0.446141 //w=0.311 //l=1.11 //layer=m1 \
 //thickness=0.36 //x=73.38 //y=7.585 //x2=74.49 //y2=7.585
r2234 (  124 912 ) resistor r=3.1 //w=0.17 //l=0.51 //layer=mcon //count=3 \
 //x=71.9 //y=7.58 //x2=71.9 //y2=7.58
r2235 (  124 126 ) resistor r=0.594855 //w=0.311 //l=1.48 //layer=m1 \
 //thickness=0.36 //x=71.9 //y=7.585 //x2=73.38 //y2=7.585
r2236 (  122 902 ) resistor r=3.1 //w=0.17 //l=0.51 //layer=mcon //count=3 \
 //x=70.79 //y=7.58 //x2=70.79 //y2=7.58
r2237 (  122 124 ) resistor r=0.446141 //w=0.311 //l=1.11 //layer=m1 \
 //thickness=0.36 //x=70.79 //y=7.585 //x2=71.9 //y2=7.585
r2238 (  120 884 ) resistor r=3.1 //w=0.17 //l=0.51 //layer=mcon //count=3 \
 //x=69.68 //y=7.58 //x2=69.68 //y2=7.58
r2239 (  120 122 ) resistor r=0.446141 //w=0.311 //l=1.11 //layer=m1 \
 //thickness=0.36 //x=69.68 //y=7.585 //x2=70.79 //y2=7.585
r2240 (  118 872 ) resistor r=3.1 //w=0.17 //l=0.51 //layer=mcon //count=3 \
 //x=68.57 //y=7.58 //x2=68.57 //y2=7.58
r2241 (  118 120 ) resistor r=0.446141 //w=0.311 //l=1.11 //layer=m1 \
 //thickness=0.36 //x=68.57 //y=7.585 //x2=69.68 //y2=7.585
r2242 (  116 866 ) resistor r=3.1 //w=0.17 //l=0.51 //layer=mcon //count=3 \
 //x=67.09 //y=7.58 //x2=67.09 //y2=7.58
r2243 (  116 118 ) resistor r=0.594855 //w=0.311 //l=1.48 //layer=m1 \
 //thickness=0.36 //x=67.09 //y=7.585 //x2=68.57 //y2=7.585
r2244 (  114 856 ) resistor r=3.1 //w=0.17 //l=0.51 //layer=mcon //count=3 \
 //x=65.98 //y=7.58 //x2=65.98 //y2=7.58
r2245 (  114 116 ) resistor r=0.446141 //w=0.311 //l=1.11 //layer=m1 \
 //thickness=0.36 //x=65.98 //y=7.585 //x2=67.09 //y2=7.585
r2246 (  112 838 ) resistor r=3.1 //w=0.17 //l=0.51 //layer=mcon //count=3 \
 //x=64.87 //y=7.58 //x2=64.87 //y2=7.58
r2247 (  112 114 ) resistor r=0.446141 //w=0.311 //l=1.11 //layer=m1 \
 //thickness=0.36 //x=64.87 //y=7.585 //x2=65.98 //y2=7.585
r2248 (  110 826 ) resistor r=3.1 //w=0.17 //l=0.51 //layer=mcon //count=3 \
 //x=63.76 //y=7.58 //x2=63.76 //y2=7.58
r2249 (  110 112 ) resistor r=0.446141 //w=0.311 //l=1.11 //layer=m1 \
 //thickness=0.36 //x=63.76 //y=7.585 //x2=64.87 //y2=7.585
r2250 (  108 820 ) resistor r=3.1 //w=0.17 //l=0.51 //layer=mcon //count=3 \
 //x=62.28 //y=7.58 //x2=62.28 //y2=7.58
r2251 (  108 110 ) resistor r=0.594855 //w=0.311 //l=1.48 //layer=m1 \
 //thickness=0.36 //x=62.28 //y=7.585 //x2=63.76 //y2=7.585
r2252 (  106 810 ) resistor r=3.1 //w=0.17 //l=0.51 //layer=mcon //count=3 \
 //x=61.17 //y=7.58 //x2=61.17 //y2=7.58
r2253 (  106 108 ) resistor r=0.446141 //w=0.311 //l=1.11 //layer=m1 \
 //thickness=0.36 //x=61.17 //y=7.585 //x2=62.28 //y2=7.585
r2254 (  104 792 ) resistor r=3.1 //w=0.17 //l=0.51 //layer=mcon //count=3 \
 //x=60.06 //y=7.58 //x2=60.06 //y2=7.58
r2255 (  104 106 ) resistor r=0.446141 //w=0.311 //l=1.11 //layer=m1 \
 //thickness=0.36 //x=60.06 //y=7.585 //x2=61.17 //y2=7.585
r2256 (  102 780 ) resistor r=3.1 //w=0.17 //l=0.51 //layer=mcon //count=3 \
 //x=58.95 //y=7.58 //x2=58.95 //y2=7.58
r2257 (  102 104 ) resistor r=0.446141 //w=0.311 //l=1.11 //layer=m1 \
 //thickness=0.36 //x=58.95 //y=7.585 //x2=60.06 //y2=7.585
r2258 (  100 774 ) resistor r=3.1 //w=0.17 //l=0.51 //layer=mcon //count=3 \
 //x=57.47 //y=7.58 //x2=57.47 //y2=7.58
r2259 (  100 102 ) resistor r=0.594855 //w=0.311 //l=1.48 //layer=m1 \
 //thickness=0.36 //x=57.47 //y=7.585 //x2=58.95 //y2=7.585
r2260 (  98 764 ) resistor r=3.1 //w=0.17 //l=0.51 //layer=mcon //count=3 \
 //x=56.36 //y=7.58 //x2=56.36 //y2=7.58
r2261 (  98 100 ) resistor r=0.446141 //w=0.311 //l=1.11 //layer=m1 \
 //thickness=0.36 //x=56.36 //y=7.585 //x2=57.47 //y2=7.585
r2262 (  96 746 ) resistor r=3.1 //w=0.17 //l=0.51 //layer=mcon //count=3 \
 //x=55.25 //y=7.58 //x2=55.25 //y2=7.58
r2263 (  96 98 ) resistor r=0.446141 //w=0.311 //l=1.11 //layer=m1 \
 //thickness=0.36 //x=55.25 //y=7.585 //x2=56.36 //y2=7.585
r2264 (  94 734 ) resistor r=3.1 //w=0.17 //l=0.51 //layer=mcon //count=3 \
 //x=54.14 //y=7.58 //x2=54.14 //y2=7.58
r2265 (  94 96 ) resistor r=0.446141 //w=0.311 //l=1.11 //layer=m1 \
 //thickness=0.36 //x=54.14 //y=7.585 //x2=55.25 //y2=7.585
r2266 (  92 728 ) resistor r=3.1 //w=0.17 //l=0.51 //layer=mcon //count=3 \
 //x=52.66 //y=7.58 //x2=52.66 //y2=7.58
r2267 (  92 94 ) resistor r=0.594855 //w=0.311 //l=1.48 //layer=m1 \
 //thickness=0.36 //x=52.66 //y=7.585 //x2=54.14 //y2=7.585
r2268 (  90 718 ) resistor r=3.1 //w=0.17 //l=0.51 //layer=mcon //count=3 \
 //x=51.55 //y=7.58 //x2=51.55 //y2=7.58
r2269 (  90 92 ) resistor r=0.446141 //w=0.311 //l=1.11 //layer=m1 \
 //thickness=0.36 //x=51.55 //y=7.585 //x2=52.66 //y2=7.585
r2270 (  88 700 ) resistor r=3.1 //w=0.17 //l=0.51 //layer=mcon //count=3 \
 //x=50.44 //y=7.58 //x2=50.44 //y2=7.58
r2271 (  88 90 ) resistor r=0.446141 //w=0.311 //l=1.11 //layer=m1 \
 //thickness=0.36 //x=50.44 //y=7.585 //x2=51.55 //y2=7.585
r2272 (  86 688 ) resistor r=3.1 //w=0.17 //l=0.51 //layer=mcon //count=3 \
 //x=49.33 //y=7.58 //x2=49.33 //y2=7.58
r2273 (  86 88 ) resistor r=0.446141 //w=0.311 //l=1.11 //layer=m1 \
 //thickness=0.36 //x=49.33 //y=7.585 //x2=50.44 //y2=7.585
r2274 (  83 682 ) resistor r=3.1 //w=0.17 //l=0.51 //layer=mcon //count=3 \
 //x=47.85 //y=7.58 //x2=47.85 //y2=7.58
r2275 (  81 672 ) resistor r=3.1 //w=0.17 //l=0.51 //layer=mcon //count=3 \
 //x=46.74 //y=7.58 //x2=46.74 //y2=7.58
r2276 (  81 83 ) resistor r=0.446141 //w=0.311 //l=1.11 //layer=m1 \
 //thickness=0.36 //x=46.74 //y=7.585 //x2=47.85 //y2=7.585
r2277 (  79 654 ) resistor r=3.1 //w=0.17 //l=0.51 //layer=mcon //count=3 \
 //x=45.63 //y=7.58 //x2=45.63 //y2=7.58
r2278 (  79 81 ) resistor r=0.446141 //w=0.311 //l=1.11 //layer=m1 \
 //thickness=0.36 //x=45.63 //y=7.585 //x2=46.74 //y2=7.585
r2279 (  77 642 ) resistor r=3.1 //w=0.17 //l=0.51 //layer=mcon //count=3 \
 //x=44.52 //y=7.58 //x2=44.52 //y2=7.58
r2280 (  77 79 ) resistor r=0.446141 //w=0.311 //l=1.11 //layer=m1 \
 //thickness=0.36 //x=44.52 //y=7.585 //x2=45.63 //y2=7.585
r2281 (  75 636 ) resistor r=3.1 //w=0.17 //l=0.51 //layer=mcon //count=3 \
 //x=43.04 //y=7.58 //x2=43.04 //y2=7.58
r2282 (  75 77 ) resistor r=0.594855 //w=0.311 //l=1.48 //layer=m1 \
 //thickness=0.36 //x=43.04 //y=7.585 //x2=44.52 //y2=7.585
r2283 (  73 626 ) resistor r=3.1 //w=0.17 //l=0.51 //layer=mcon //count=3 \
 //x=41.93 //y=7.58 //x2=41.93 //y2=7.58
r2284 (  73 75 ) resistor r=0.446141 //w=0.311 //l=1.11 //layer=m1 \
 //thickness=0.36 //x=41.93 //y=7.585 //x2=43.04 //y2=7.585
r2285 (  71 608 ) resistor r=3.1 //w=0.17 //l=0.51 //layer=mcon //count=3 \
 //x=40.82 //y=7.58 //x2=40.82 //y2=7.58
r2286 (  71 73 ) resistor r=0.446141 //w=0.311 //l=1.11 //layer=m1 \
 //thickness=0.36 //x=40.82 //y=7.585 //x2=41.93 //y2=7.585
r2287 (  69 596 ) resistor r=3.1 //w=0.17 //l=0.51 //layer=mcon //count=3 \
 //x=39.71 //y=7.58 //x2=39.71 //y2=7.58
r2288 (  69 71 ) resistor r=0.446141 //w=0.311 //l=1.11 //layer=m1 \
 //thickness=0.36 //x=39.71 //y=7.585 //x2=40.82 //y2=7.585
r2289 (  67 590 ) resistor r=3.1 //w=0.17 //l=0.51 //layer=mcon //count=3 \
 //x=38.23 //y=7.58 //x2=38.23 //y2=7.58
r2290 (  67 69 ) resistor r=0.594855 //w=0.311 //l=1.48 //layer=m1 \
 //thickness=0.36 //x=38.23 //y=7.585 //x2=39.71 //y2=7.585
r2291 (  65 580 ) resistor r=3.1 //w=0.17 //l=0.51 //layer=mcon //count=3 \
 //x=37.12 //y=7.58 //x2=37.12 //y2=7.58
r2292 (  65 67 ) resistor r=0.446141 //w=0.311 //l=1.11 //layer=m1 \
 //thickness=0.36 //x=37.12 //y=7.585 //x2=38.23 //y2=7.585
r2293 (  63 562 ) resistor r=3.1 //w=0.17 //l=0.51 //layer=mcon //count=3 \
 //x=36.01 //y=7.58 //x2=36.01 //y2=7.58
r2294 (  63 65 ) resistor r=0.446141 //w=0.311 //l=1.11 //layer=m1 \
 //thickness=0.36 //x=36.01 //y=7.585 //x2=37.12 //y2=7.585
r2295 (  61 550 ) resistor r=3.1 //w=0.17 //l=0.51 //layer=mcon //count=3 \
 //x=34.9 //y=7.58 //x2=34.9 //y2=7.58
r2296 (  61 63 ) resistor r=0.446141 //w=0.311 //l=1.11 //layer=m1 \
 //thickness=0.36 //x=34.9 //y=7.585 //x2=36.01 //y2=7.585
r2297 (  59 544 ) resistor r=3.1 //w=0.17 //l=0.51 //layer=mcon //count=3 \
 //x=33.42 //y=7.58 //x2=33.42 //y2=7.58
r2298 (  59 61 ) resistor r=0.594855 //w=0.311 //l=1.48 //layer=m1 \
 //thickness=0.36 //x=33.42 //y=7.585 //x2=34.9 //y2=7.585
r2299 (  57 534 ) resistor r=3.1 //w=0.17 //l=0.51 //layer=mcon //count=3 \
 //x=32.31 //y=7.58 //x2=32.31 //y2=7.58
r2300 (  57 59 ) resistor r=0.446141 //w=0.311 //l=1.11 //layer=m1 \
 //thickness=0.36 //x=32.31 //y=7.585 //x2=33.42 //y2=7.585
r2301 (  55 516 ) resistor r=3.1 //w=0.17 //l=0.51 //layer=mcon //count=3 \
 //x=31.2 //y=7.58 //x2=31.2 //y2=7.58
r2302 (  55 57 ) resistor r=0.446141 //w=0.311 //l=1.11 //layer=m1 \
 //thickness=0.36 //x=31.2 //y=7.585 //x2=32.31 //y2=7.585
r2303 (  53 504 ) resistor r=3.1 //w=0.17 //l=0.51 //layer=mcon //count=3 \
 //x=30.09 //y=7.58 //x2=30.09 //y2=7.58
r2304 (  53 55 ) resistor r=0.446141 //w=0.311 //l=1.11 //layer=m1 \
 //thickness=0.36 //x=30.09 //y=7.585 //x2=31.2 //y2=7.585
r2305 (  51 498 ) resistor r=3.1 //w=0.17 //l=0.51 //layer=mcon //count=3 \
 //x=28.61 //y=7.58 //x2=28.61 //y2=7.58
r2306 (  51 53 ) resistor r=0.594855 //w=0.311 //l=1.48 //layer=m1 \
 //thickness=0.36 //x=28.61 //y=7.585 //x2=30.09 //y2=7.585
r2307 (  49 488 ) resistor r=3.1 //w=0.17 //l=0.51 //layer=mcon //count=3 \
 //x=27.5 //y=7.58 //x2=27.5 //y2=7.58
r2308 (  49 51 ) resistor r=0.446141 //w=0.311 //l=1.11 //layer=m1 \
 //thickness=0.36 //x=27.5 //y=7.585 //x2=28.61 //y2=7.585
r2309 (  47 470 ) resistor r=3.1 //w=0.17 //l=0.51 //layer=mcon //count=3 \
 //x=26.39 //y=7.58 //x2=26.39 //y2=7.58
r2310 (  47 49 ) resistor r=0.446141 //w=0.311 //l=1.11 //layer=m1 \
 //thickness=0.36 //x=26.39 //y=7.585 //x2=27.5 //y2=7.585
r2311 (  45 458 ) resistor r=3.1 //w=0.17 //l=0.51 //layer=mcon //count=3 \
 //x=25.28 //y=7.58 //x2=25.28 //y2=7.58
r2312 (  45 47 ) resistor r=0.446141 //w=0.311 //l=1.11 //layer=m1 \
 //thickness=0.36 //x=25.28 //y=7.585 //x2=26.39 //y2=7.585
r2313 (  43 452 ) resistor r=3.1 //w=0.17 //l=0.51 //layer=mcon //count=3 \
 //x=23.8 //y=7.58 //x2=23.8 //y2=7.58
r2314 (  43 45 ) resistor r=0.594855 //w=0.311 //l=1.48 //layer=m1 \
 //thickness=0.36 //x=23.8 //y=7.585 //x2=25.28 //y2=7.585
r2315 (  41 442 ) resistor r=3.1 //w=0.17 //l=0.51 //layer=mcon //count=3 \
 //x=22.69 //y=7.58 //x2=22.69 //y2=7.58
r2316 (  41 43 ) resistor r=0.446141 //w=0.311 //l=1.11 //layer=m1 \
 //thickness=0.36 //x=22.69 //y=7.585 //x2=23.8 //y2=7.585
r2317 (  39 424 ) resistor r=3.1 //w=0.17 //l=0.51 //layer=mcon //count=3 \
 //x=21.58 //y=7.58 //x2=21.58 //y2=7.58
r2318 (  39 41 ) resistor r=0.446141 //w=0.311 //l=1.11 //layer=m1 \
 //thickness=0.36 //x=21.58 //y=7.585 //x2=22.69 //y2=7.585
r2319 (  37 412 ) resistor r=3.1 //w=0.17 //l=0.51 //layer=mcon //count=3 \
 //x=20.47 //y=7.58 //x2=20.47 //y2=7.58
r2320 (  37 39 ) resistor r=0.446141 //w=0.311 //l=1.11 //layer=m1 \
 //thickness=0.36 //x=20.47 //y=7.585 //x2=21.58 //y2=7.585
r2321 (  35 406 ) resistor r=3.1 //w=0.17 //l=0.51 //layer=mcon //count=3 \
 //x=18.99 //y=7.58 //x2=18.99 //y2=7.58
r2322 (  35 37 ) resistor r=0.594855 //w=0.311 //l=1.48 //layer=m1 \
 //thickness=0.36 //x=18.99 //y=7.585 //x2=20.47 //y2=7.585
r2323 (  33 396 ) resistor r=3.1 //w=0.17 //l=0.51 //layer=mcon //count=3 \
 //x=17.88 //y=7.58 //x2=17.88 //y2=7.58
r2324 (  33 35 ) resistor r=0.446141 //w=0.311 //l=1.11 //layer=m1 \
 //thickness=0.36 //x=17.88 //y=7.585 //x2=18.99 //y2=7.585
r2325 (  31 378 ) resistor r=3.1 //w=0.17 //l=0.51 //layer=mcon //count=3 \
 //x=16.77 //y=7.58 //x2=16.77 //y2=7.58
r2326 (  31 33 ) resistor r=0.446141 //w=0.311 //l=1.11 //layer=m1 \
 //thickness=0.36 //x=16.77 //y=7.585 //x2=17.88 //y2=7.585
r2327 (  29 366 ) resistor r=3.1 //w=0.17 //l=0.51 //layer=mcon //count=3 \
 //x=15.66 //y=7.58 //x2=15.66 //y2=7.58
r2328 (  29 31 ) resistor r=0.446141 //w=0.311 //l=1.11 //layer=m1 \
 //thickness=0.36 //x=15.66 //y=7.585 //x2=16.77 //y2=7.585
r2329 (  27 360 ) resistor r=3.1 //w=0.17 //l=0.51 //layer=mcon //count=3 \
 //x=14.18 //y=7.58 //x2=14.18 //y2=7.58
r2330 (  27 29 ) resistor r=0.594855 //w=0.311 //l=1.48 //layer=m1 \
 //thickness=0.36 //x=14.18 //y=7.585 //x2=15.66 //y2=7.585
r2331 (  25 350 ) resistor r=3.1 //w=0.17 //l=0.51 //layer=mcon //count=3 \
 //x=13.07 //y=7.58 //x2=13.07 //y2=7.58
r2332 (  25 27 ) resistor r=0.446141 //w=0.311 //l=1.11 //layer=m1 \
 //thickness=0.36 //x=13.07 //y=7.585 //x2=14.18 //y2=7.585
r2333 (  23 332 ) resistor r=3.1 //w=0.17 //l=0.51 //layer=mcon //count=3 \
 //x=11.96 //y=7.58 //x2=11.96 //y2=7.58
r2334 (  23 25 ) resistor r=0.446141 //w=0.311 //l=1.11 //layer=m1 \
 //thickness=0.36 //x=11.96 //y=7.585 //x2=13.07 //y2=7.585
r2335 (  21 320 ) resistor r=3.1 //w=0.17 //l=0.51 //layer=mcon //count=3 \
 //x=10.85 //y=7.58 //x2=10.85 //y2=7.58
r2336 (  21 23 ) resistor r=0.446141 //w=0.311 //l=1.11 //layer=m1 \
 //thickness=0.36 //x=10.85 //y=7.585 //x2=11.96 //y2=7.585
r2337 (  19 314 ) resistor r=3.1 //w=0.17 //l=0.51 //layer=mcon //count=3 \
 //x=9.37 //y=7.58 //x2=9.37 //y2=7.58
r2338 (  19 21 ) resistor r=0.594855 //w=0.311 //l=1.48 //layer=m1 \
 //thickness=0.36 //x=9.37 //y=7.585 //x2=10.85 //y2=7.585
r2339 (  17 304 ) resistor r=3.1 //w=0.17 //l=0.51 //layer=mcon //count=3 \
 //x=8.26 //y=7.58 //x2=8.26 //y2=7.58
r2340 (  17 19 ) resistor r=0.446141 //w=0.311 //l=1.11 //layer=m1 \
 //thickness=0.36 //x=8.26 //y=7.585 //x2=9.37 //y2=7.585
r2341 (  15 286 ) resistor r=3.1 //w=0.17 //l=0.51 //layer=mcon //count=3 \
 //x=7.15 //y=7.58 //x2=7.15 //y2=7.58
r2342 (  15 17 ) resistor r=0.446141 //w=0.311 //l=1.11 //layer=m1 \
 //thickness=0.36 //x=7.15 //y=7.585 //x2=8.26 //y2=7.585
r2343 (  13 274 ) resistor r=3.1 //w=0.17 //l=0.51 //layer=mcon //count=3 \
 //x=6.04 //y=7.58 //x2=6.04 //y2=7.58
r2344 (  13 15 ) resistor r=0.446141 //w=0.311 //l=1.11 //layer=m1 \
 //thickness=0.36 //x=6.04 //y=7.585 //x2=7.15 //y2=7.585
r2345 (  11 268 ) resistor r=3.1 //w=0.17 //l=0.51 //layer=mcon //count=3 \
 //x=4.56 //y=7.58 //x2=4.56 //y2=7.58
r2346 (  11 13 ) resistor r=0.594855 //w=0.311 //l=1.48 //layer=m1 \
 //thickness=0.36 //x=4.56 //y=7.585 //x2=6.04 //y2=7.585
r2347 (  9 258 ) resistor r=3.1 //w=0.17 //l=0.51 //layer=mcon //count=3 \
 //x=3.45 //y=7.58 //x2=3.45 //y2=7.58
r2348 (  9 11 ) resistor r=0.446141 //w=0.311 //l=1.11 //layer=m1 \
 //thickness=0.36 //x=3.45 //y=7.585 //x2=4.56 //y2=7.585
r2349 (  7 240 ) resistor r=3.1 //w=0.17 //l=0.51 //layer=mcon //count=3 \
 //x=2.34 //y=7.58 //x2=2.34 //y2=7.58
r2350 (  7 9 ) resistor r=0.446141 //w=0.311 //l=1.11 //layer=m1 \
 //thickness=0.36 //x=2.34 //y=7.585 //x2=3.45 //y2=7.585
r2351 (  4 228 ) resistor r=3.1 //w=0.17 //l=0.51 //layer=mcon //count=3 \
 //x=1.23 //y=7.58 //x2=1.23 //y2=7.58
r2352 (  4 7 ) resistor r=0.446141 //w=0.311 //l=1.11 //layer=m1 \
 //thickness=0.36 //x=1.23 //y=7.585 //x2=2.34 //y2=7.585
r2353 (  2 212 ) resistor r=0.028033 //w=0.35 //l=0.085 //layer=m1 \
 //thickness=0.36 //x=87.775 //y=7.585 //x2=87.86 //y2=7.585
r2354 (  2 148 ) resistor r=0.580788 //w=0.311 //l=1.445 //layer=m1 \
 //thickness=0.36 //x=87.775 //y=7.585 //x2=86.33 //y2=7.585
r2355 (  1 86 ) resistor r=0.223071 //w=0.311 //l=0.555 //layer=m1 \
 //thickness=0.36 //x=48.775 //y=7.585 //x2=49.33 //y2=7.585
r2356 (  1 83 ) resistor r=0.371785 //w=0.311 //l=0.925 //layer=m1 \
 //thickness=0.36 //x=48.775 //y=7.585 //x2=47.85 //y2=7.585
ends PM_TMRDFFSNRNQNX1\%VDD

subckt PM_TMRDFFSNRNQNX1\%noxref_25 ( 5 7 15 19 30 33 34 )
c66 ( 34 0 ) capacitor c=0.0443556f //x=3.455 //y=0.555
c67 ( 33 0 ) capacitor c=0.0194217f //x=2.35 //y=1.09
c68 ( 30 0 ) capacitor c=0.00141302f //x=3.59 //y=1.175
c69 ( 19 0 ) capacitor c=0.00692795f //x=4.56 //y=0.805
c70 ( 15 0 ) capacitor c=0.0155078f //x=4.475 //y=0.72
c71 ( 7 0 ) capacitor c=0.00689459f //x=3.59 //y=0.805
c72 ( 5 0 ) capacitor c=0.0235962f //x=3.505 //y=1.175
r73 (  19 34 ) resistor r=3.57586 //w=0.17 //l=0.125 //layer=li \
 //thickness=0.1 //x=4.56 //y=0.805 //x2=4.56 //y2=0.68
r74 (  19 34 ) resistor r=18.139 //w=0.187 //l=0.265 //layer=li \
 //thickness=0.1 //x=4.56 //y=0.805 //x2=4.56 //y2=1.07
r75 (  16 34 ) resistor r=3.57586 //w=0.17 //l=0.103078 //layer=li \
 //thickness=0.1 //x=3.675 //y=0.72 //x2=3.59 //y2=0.68
r76 (  16 34 ) resistor r=27.3797 //w=0.187 //l=0.4 //layer=li //thickness=0.1 \
 //x=3.675 //y=0.72 //x2=4.075 //y2=0.72
r77 (  15 34 ) resistor r=3.57586 //w=0.17 //l=0.103078 //layer=li \
 //thickness=0.1 //x=4.475 //y=0.72 //x2=4.56 //y2=0.68
r78 (  15 34 ) resistor r=27.3797 //w=0.187 //l=0.4 //layer=li //thickness=0.1 \
 //x=4.475 //y=0.72 //x2=4.075 //y2=0.72
r79 (  11 30 ) resistor r=5.4201 //w=0.17 //l=0.085 //layer=li //thickness=0.1 \
 //x=3.59 //y=1.26 //x2=3.59 //y2=1.175
r80 (  11 34 ) resistor r=10.2674 //w=0.187 //l=0.15 //layer=li \
 //thickness=0.1 //x=3.59 //y=1.26 //x2=3.59 //y2=1.41
r81 (  8 30 ) resistor r=5.4201 //w=0.17 //l=0.085 //layer=li //thickness=0.1 \
 //x=3.59 //y=1.09 //x2=3.59 //y2=1.175
r82 (  8 34 ) resistor r=1.36898 //w=0.187 //l=0.02 //layer=li //thickness=0.1 \
 //x=3.59 //y=1.09 //x2=3.59 //y2=1.07
r83 (  7 34 ) resistor r=3.57586 //w=0.17 //l=0.125 //layer=li //thickness=0.1 \
 //x=3.59 //y=0.805 //x2=3.59 //y2=0.68
r84 (  7 34 ) resistor r=18.139 //w=0.187 //l=0.265 //layer=li //thickness=0.1 \
 //x=3.59 //y=0.805 //x2=3.59 //y2=1.07
r85 (  6 33 ) resistor r=0.751729 //w=0.17 //l=0.085 //layer=li \
 //thickness=0.1 //x=2.625 //y=1.175 //x2=2.54 //y2=1.175
r86 (  5 30 ) resistor r=1.40859 //w=0.34 //l=0.085 //layer=li //thickness=0.1 \
 //x=3.505 //y=1.175 //x2=3.59 //y2=1.175
r87 (  5 6 ) resistor r=60.2353 //w=0.187 //l=0.88 //layer=li //thickness=0.1 \
 //x=3.505 //y=1.175 //x2=2.625 //y2=1.175
ends PM_TMRDFFSNRNQNX1\%noxref_25

subckt PM_TMRDFFSNRNQNX1\%noxref_26 ( 5 7 15 19 30 33 34 )
c67 ( 34 0 ) capacitor c=0.0451719f //x=8.265 //y=0.555
c68 ( 33 0 ) capacitor c=0.0194945f //x=7.16 //y=1.09
c69 ( 30 0 ) capacitor c=0.00141302f //x=8.4 //y=1.175
c70 ( 19 0 ) capacitor c=0.00692795f //x=9.37 //y=0.805
c71 ( 15 0 ) capacitor c=0.0154868f //x=9.285 //y=0.72
c72 ( 7 0 ) capacitor c=0.00689459f //x=8.4 //y=0.805
c73 ( 5 0 ) capacitor c=0.0235962f //x=8.315 //y=1.175
r74 (  19 34 ) resistor r=3.57586 //w=0.17 //l=0.125 //layer=li \
 //thickness=0.1 //x=9.37 //y=0.805 //x2=9.37 //y2=0.68
r75 (  19 34 ) resistor r=18.139 //w=0.187 //l=0.265 //layer=li \
 //thickness=0.1 //x=9.37 //y=0.805 //x2=9.37 //y2=1.07
r76 (  16 34 ) resistor r=3.57586 //w=0.17 //l=0.103078 //layer=li \
 //thickness=0.1 //x=8.485 //y=0.72 //x2=8.4 //y2=0.68
r77 (  16 34 ) resistor r=27.3797 //w=0.187 //l=0.4 //layer=li //thickness=0.1 \
 //x=8.485 //y=0.72 //x2=8.885 //y2=0.72
r78 (  15 34 ) resistor r=3.57586 //w=0.17 //l=0.103078 //layer=li \
 //thickness=0.1 //x=9.285 //y=0.72 //x2=9.37 //y2=0.68
r79 (  15 34 ) resistor r=27.3797 //w=0.187 //l=0.4 //layer=li //thickness=0.1 \
 //x=9.285 //y=0.72 //x2=8.885 //y2=0.72
r80 (  11 30 ) resistor r=5.4201 //w=0.17 //l=0.085 //layer=li //thickness=0.1 \
 //x=8.4 //y=1.26 //x2=8.4 //y2=1.175
r81 (  11 34 ) resistor r=10.2674 //w=0.187 //l=0.15 //layer=li \
 //thickness=0.1 //x=8.4 //y=1.26 //x2=8.4 //y2=1.41
r82 (  8 30 ) resistor r=5.4201 //w=0.17 //l=0.085 //layer=li //thickness=0.1 \
 //x=8.4 //y=1.09 //x2=8.4 //y2=1.175
r83 (  8 34 ) resistor r=1.36898 //w=0.187 //l=0.02 //layer=li //thickness=0.1 \
 //x=8.4 //y=1.09 //x2=8.4 //y2=1.07
r84 (  7 34 ) resistor r=3.57586 //w=0.17 //l=0.125 //layer=li //thickness=0.1 \
 //x=8.4 //y=0.805 //x2=8.4 //y2=0.68
r85 (  7 34 ) resistor r=18.139 //w=0.187 //l=0.265 //layer=li //thickness=0.1 \
 //x=8.4 //y=0.805 //x2=8.4 //y2=1.07
r86 (  6 33 ) resistor r=0.751729 //w=0.17 //l=0.085 //layer=li \
 //thickness=0.1 //x=7.435 //y=1.175 //x2=7.35 //y2=1.175
r87 (  5 30 ) resistor r=1.40859 //w=0.34 //l=0.085 //layer=li //thickness=0.1 \
 //x=8.315 //y=1.175 //x2=8.4 //y2=1.175
r88 (  5 6 ) resistor r=60.2353 //w=0.187 //l=0.88 //layer=li //thickness=0.1 \
 //x=8.315 //y=1.175 //x2=7.435 //y2=1.175
ends PM_TMRDFFSNRNQNX1\%noxref_26

subckt PM_TMRDFFSNRNQNX1\%noxref_27 ( 5 7 15 19 30 33 34 )
c68 ( 34 0 ) capacitor c=0.0442917f //x=13.075 //y=0.555
c69 ( 33 0 ) capacitor c=0.0193551f //x=11.97 //y=1.09
c70 ( 30 0 ) capacitor c=0.00141302f //x=13.21 //y=1.175
c71 ( 19 0 ) capacitor c=0.00692795f //x=14.18 //y=0.805
c72 ( 15 0 ) capacitor c=0.0154868f //x=14.095 //y=0.72
c73 ( 7 0 ) capacitor c=0.00689459f //x=13.21 //y=0.805
c74 ( 5 0 ) capacitor c=0.0235962f //x=13.125 //y=1.175
r75 (  19 34 ) resistor r=3.57586 //w=0.17 //l=0.125 //layer=li \
 //thickness=0.1 //x=14.18 //y=0.805 //x2=14.18 //y2=0.68
r76 (  19 34 ) resistor r=18.139 //w=0.187 //l=0.265 //layer=li \
 //thickness=0.1 //x=14.18 //y=0.805 //x2=14.18 //y2=1.07
r77 (  16 34 ) resistor r=3.57586 //w=0.17 //l=0.103078 //layer=li \
 //thickness=0.1 //x=13.295 //y=0.72 //x2=13.21 //y2=0.68
r78 (  16 34 ) resistor r=27.3797 //w=0.187 //l=0.4 //layer=li //thickness=0.1 \
 //x=13.295 //y=0.72 //x2=13.695 //y2=0.72
r79 (  15 34 ) resistor r=3.57586 //w=0.17 //l=0.103078 //layer=li \
 //thickness=0.1 //x=14.095 //y=0.72 //x2=14.18 //y2=0.68
r80 (  15 34 ) resistor r=27.3797 //w=0.187 //l=0.4 //layer=li //thickness=0.1 \
 //x=14.095 //y=0.72 //x2=13.695 //y2=0.72
r81 (  11 30 ) resistor r=5.4201 //w=0.17 //l=0.085 //layer=li //thickness=0.1 \
 //x=13.21 //y=1.26 //x2=13.21 //y2=1.175
r82 (  11 34 ) resistor r=10.2674 //w=0.187 //l=0.15 //layer=li \
 //thickness=0.1 //x=13.21 //y=1.26 //x2=13.21 //y2=1.41
r83 (  8 30 ) resistor r=5.4201 //w=0.17 //l=0.085 //layer=li //thickness=0.1 \
 //x=13.21 //y=1.09 //x2=13.21 //y2=1.175
r84 (  8 34 ) resistor r=1.36898 //w=0.187 //l=0.02 //layer=li //thickness=0.1 \
 //x=13.21 //y=1.09 //x2=13.21 //y2=1.07
r85 (  7 34 ) resistor r=3.57586 //w=0.17 //l=0.125 //layer=li //thickness=0.1 \
 //x=13.21 //y=0.805 //x2=13.21 //y2=0.68
r86 (  7 34 ) resistor r=18.139 //w=0.187 //l=0.265 //layer=li //thickness=0.1 \
 //x=13.21 //y=0.805 //x2=13.21 //y2=1.07
r87 (  6 33 ) resistor r=0.751729 //w=0.17 //l=0.085 //layer=li \
 //thickness=0.1 //x=12.245 //y=1.175 //x2=12.16 //y2=1.175
r88 (  5 30 ) resistor r=1.40859 //w=0.34 //l=0.085 //layer=li //thickness=0.1 \
 //x=13.125 //y=1.175 //x2=13.21 //y2=1.175
r89 (  5 6 ) resistor r=60.2353 //w=0.187 //l=0.88 //layer=li //thickness=0.1 \
 //x=13.125 //y=1.175 //x2=12.245 //y2=1.175
ends PM_TMRDFFSNRNQNX1\%noxref_27

subckt PM_TMRDFFSNRNQNX1\%noxref_28 ( 5 7 15 19 30 33 34 )
c67 ( 34 0 ) capacitor c=0.0452753f //x=17.885 //y=0.555
c68 ( 33 0 ) capacitor c=0.0194988f //x=16.78 //y=1.09
c69 ( 30 0 ) capacitor c=0.00141302f //x=18.02 //y=1.175
c70 ( 19 0 ) capacitor c=0.00692795f //x=18.99 //y=0.805
c71 ( 15 0 ) capacitor c=0.0153812f //x=18.905 //y=0.72
c72 ( 7 0 ) capacitor c=0.00689459f //x=18.02 //y=0.805
c73 ( 5 0 ) capacitor c=0.0235962f //x=17.935 //y=1.175
r74 (  19 34 ) resistor r=3.57586 //w=0.17 //l=0.125 //layer=li \
 //thickness=0.1 //x=18.99 //y=0.805 //x2=18.99 //y2=0.68
r75 (  19 34 ) resistor r=18.139 //w=0.187 //l=0.265 //layer=li \
 //thickness=0.1 //x=18.99 //y=0.805 //x2=18.99 //y2=1.07
r76 (  16 34 ) resistor r=3.57586 //w=0.17 //l=0.103078 //layer=li \
 //thickness=0.1 //x=18.105 //y=0.72 //x2=18.02 //y2=0.68
r77 (  16 34 ) resistor r=27.3797 //w=0.187 //l=0.4 //layer=li //thickness=0.1 \
 //x=18.105 //y=0.72 //x2=18.505 //y2=0.72
r78 (  15 34 ) resistor r=3.57586 //w=0.17 //l=0.103078 //layer=li \
 //thickness=0.1 //x=18.905 //y=0.72 //x2=18.99 //y2=0.68
r79 (  15 34 ) resistor r=27.3797 //w=0.187 //l=0.4 //layer=li //thickness=0.1 \
 //x=18.905 //y=0.72 //x2=18.505 //y2=0.72
r80 (  11 30 ) resistor r=5.4201 //w=0.17 //l=0.085 //layer=li //thickness=0.1 \
 //x=18.02 //y=1.26 //x2=18.02 //y2=1.175
r81 (  11 34 ) resistor r=10.2674 //w=0.187 //l=0.15 //layer=li \
 //thickness=0.1 //x=18.02 //y=1.26 //x2=18.02 //y2=1.41
r82 (  8 30 ) resistor r=5.4201 //w=0.17 //l=0.085 //layer=li //thickness=0.1 \
 //x=18.02 //y=1.09 //x2=18.02 //y2=1.175
r83 (  8 34 ) resistor r=1.36898 //w=0.187 //l=0.02 //layer=li //thickness=0.1 \
 //x=18.02 //y=1.09 //x2=18.02 //y2=1.07
r84 (  7 34 ) resistor r=3.57586 //w=0.17 //l=0.125 //layer=li //thickness=0.1 \
 //x=18.02 //y=0.805 //x2=18.02 //y2=0.68
r85 (  7 34 ) resistor r=18.139 //w=0.187 //l=0.265 //layer=li //thickness=0.1 \
 //x=18.02 //y=0.805 //x2=18.02 //y2=1.07
r86 (  6 33 ) resistor r=0.751729 //w=0.17 //l=0.085 //layer=li \
 //thickness=0.1 //x=17.055 //y=1.175 //x2=16.97 //y2=1.175
r87 (  5 30 ) resistor r=1.40859 //w=0.34 //l=0.085 //layer=li //thickness=0.1 \
 //x=17.935 //y=1.175 //x2=18.02 //y2=1.175
r88 (  5 6 ) resistor r=60.2353 //w=0.187 //l=0.88 //layer=li //thickness=0.1 \
 //x=17.935 //y=1.175 //x2=17.055 //y2=1.175
ends PM_TMRDFFSNRNQNX1\%noxref_28

subckt PM_TMRDFFSNRNQNX1\%noxref_29 ( 5 7 15 19 30 33 34 )
c68 ( 34 0 ) capacitor c=0.0444783f //x=22.695 //y=0.555
c69 ( 33 0 ) capacitor c=0.0190261f //x=21.59 //y=1.09
c70 ( 30 0 ) capacitor c=0.00141302f //x=22.83 //y=1.175
c71 ( 19 0 ) capacitor c=0.00692795f //x=23.8 //y=0.805
c72 ( 15 0 ) capacitor c=0.0155062f //x=23.715 //y=0.72
c73 ( 7 0 ) capacitor c=0.00689459f //x=22.83 //y=0.805
c74 ( 5 0 ) capacitor c=0.0235962f //x=22.745 //y=1.175
r75 (  19 34 ) resistor r=3.57586 //w=0.17 //l=0.125 //layer=li \
 //thickness=0.1 //x=23.8 //y=0.805 //x2=23.8 //y2=0.68
r76 (  19 34 ) resistor r=18.139 //w=0.187 //l=0.265 //layer=li \
 //thickness=0.1 //x=23.8 //y=0.805 //x2=23.8 //y2=1.07
r77 (  16 34 ) resistor r=3.57586 //w=0.17 //l=0.103078 //layer=li \
 //thickness=0.1 //x=22.915 //y=0.72 //x2=22.83 //y2=0.68
r78 (  16 34 ) resistor r=27.3797 //w=0.187 //l=0.4 //layer=li //thickness=0.1 \
 //x=22.915 //y=0.72 //x2=23.315 //y2=0.72
r79 (  15 34 ) resistor r=3.57586 //w=0.17 //l=0.103078 //layer=li \
 //thickness=0.1 //x=23.715 //y=0.72 //x2=23.8 //y2=0.68
r80 (  15 34 ) resistor r=27.3797 //w=0.187 //l=0.4 //layer=li //thickness=0.1 \
 //x=23.715 //y=0.72 //x2=23.315 //y2=0.72
r81 (  11 30 ) resistor r=5.4201 //w=0.17 //l=0.085 //layer=li //thickness=0.1 \
 //x=22.83 //y=1.26 //x2=22.83 //y2=1.175
r82 (  11 34 ) resistor r=10.2674 //w=0.187 //l=0.15 //layer=li \
 //thickness=0.1 //x=22.83 //y=1.26 //x2=22.83 //y2=1.41
r83 (  8 30 ) resistor r=5.4201 //w=0.17 //l=0.085 //layer=li //thickness=0.1 \
 //x=22.83 //y=1.09 //x2=22.83 //y2=1.175
r84 (  8 34 ) resistor r=1.36898 //w=0.187 //l=0.02 //layer=li //thickness=0.1 \
 //x=22.83 //y=1.09 //x2=22.83 //y2=1.07
r85 (  7 34 ) resistor r=3.57586 //w=0.17 //l=0.125 //layer=li //thickness=0.1 \
 //x=22.83 //y=0.805 //x2=22.83 //y2=0.68
r86 (  7 34 ) resistor r=18.139 //w=0.187 //l=0.265 //layer=li //thickness=0.1 \
 //x=22.83 //y=0.805 //x2=22.83 //y2=1.07
r87 (  6 33 ) resistor r=0.751729 //w=0.17 //l=0.085 //layer=li \
 //thickness=0.1 //x=21.865 //y=1.175 //x2=21.78 //y2=1.175
r88 (  5 30 ) resistor r=1.40859 //w=0.34 //l=0.085 //layer=li //thickness=0.1 \
 //x=22.745 //y=1.175 //x2=22.83 //y2=1.175
r89 (  5 6 ) resistor r=60.2353 //w=0.187 //l=0.88 //layer=li //thickness=0.1 \
 //x=22.745 //y=1.175 //x2=21.865 //y2=1.175
ends PM_TMRDFFSNRNQNX1\%noxref_29

subckt PM_TMRDFFSNRNQNX1\%noxref_30 ( 5 7 15 19 30 33 34 )
c69 ( 34 0 ) capacitor c=0.0450311f //x=27.505 //y=0.555
c70 ( 33 0 ) capacitor c=0.018587f //x=26.4 //y=1.09
c71 ( 30 0 ) capacitor c=0.00141302f //x=27.64 //y=1.175
c72 ( 19 0 ) capacitor c=0.00692795f //x=28.61 //y=0.805
c73 ( 15 0 ) capacitor c=0.0154873f //x=28.525 //y=0.72
c74 ( 7 0 ) capacitor c=0.00689459f //x=27.64 //y=0.805
c75 ( 5 0 ) capacitor c=0.0235962f //x=27.555 //y=1.175
r76 (  19 34 ) resistor r=3.57586 //w=0.17 //l=0.125 //layer=li \
 //thickness=0.1 //x=28.61 //y=0.805 //x2=28.61 //y2=0.68
r77 (  19 34 ) resistor r=18.139 //w=0.187 //l=0.265 //layer=li \
 //thickness=0.1 //x=28.61 //y=0.805 //x2=28.61 //y2=1.07
r78 (  16 34 ) resistor r=3.57586 //w=0.17 //l=0.103078 //layer=li \
 //thickness=0.1 //x=27.725 //y=0.72 //x2=27.64 //y2=0.68
r79 (  16 34 ) resistor r=27.3797 //w=0.187 //l=0.4 //layer=li //thickness=0.1 \
 //x=27.725 //y=0.72 //x2=28.125 //y2=0.72
r80 (  15 34 ) resistor r=3.57586 //w=0.17 //l=0.103078 //layer=li \
 //thickness=0.1 //x=28.525 //y=0.72 //x2=28.61 //y2=0.68
r81 (  15 34 ) resistor r=27.3797 //w=0.187 //l=0.4 //layer=li //thickness=0.1 \
 //x=28.525 //y=0.72 //x2=28.125 //y2=0.72
r82 (  11 30 ) resistor r=5.4201 //w=0.17 //l=0.085 //layer=li //thickness=0.1 \
 //x=27.64 //y=1.26 //x2=27.64 //y2=1.175
r83 (  11 34 ) resistor r=10.2674 //w=0.187 //l=0.15 //layer=li \
 //thickness=0.1 //x=27.64 //y=1.26 //x2=27.64 //y2=1.41
r84 (  8 30 ) resistor r=5.4201 //w=0.17 //l=0.085 //layer=li //thickness=0.1 \
 //x=27.64 //y=1.09 //x2=27.64 //y2=1.175
r85 (  8 34 ) resistor r=1.36898 //w=0.187 //l=0.02 //layer=li //thickness=0.1 \
 //x=27.64 //y=1.09 //x2=27.64 //y2=1.07
r86 (  7 34 ) resistor r=3.57586 //w=0.17 //l=0.125 //layer=li //thickness=0.1 \
 //x=27.64 //y=0.805 //x2=27.64 //y2=0.68
r87 (  7 34 ) resistor r=18.139 //w=0.187 //l=0.265 //layer=li //thickness=0.1 \
 //x=27.64 //y=0.805 //x2=27.64 //y2=1.07
r88 (  6 33 ) resistor r=0.751729 //w=0.17 //l=0.085 //layer=li \
 //thickness=0.1 //x=26.675 //y=1.175 //x2=26.59 //y2=1.175
r89 (  5 30 ) resistor r=1.40859 //w=0.34 //l=0.085 //layer=li //thickness=0.1 \
 //x=27.555 //y=1.175 //x2=27.64 //y2=1.175
r90 (  5 6 ) resistor r=60.2353 //w=0.187 //l=0.88 //layer=li //thickness=0.1 \
 //x=27.555 //y=1.175 //x2=26.675 //y2=1.175
ends PM_TMRDFFSNRNQNX1\%noxref_30

subckt PM_TMRDFFSNRNQNX1\%noxref_31 ( 5 7 15 19 30 33 34 )
c67 ( 34 0 ) capacitor c=0.0443556f //x=32.315 //y=0.555
c68 ( 33 0 ) capacitor c=0.019073f //x=31.21 //y=1.09
c69 ( 30 0 ) capacitor c=0.00141302f //x=32.45 //y=1.175
c70 ( 19 0 ) capacitor c=0.00692795f //x=33.42 //y=0.805
c71 ( 15 0 ) capacitor c=0.0155078f //x=33.335 //y=0.72
c72 ( 7 0 ) capacitor c=0.00689459f //x=32.45 //y=0.805
c73 ( 5 0 ) capacitor c=0.0235962f //x=32.365 //y=1.175
r74 (  19 34 ) resistor r=3.57586 //w=0.17 //l=0.125 //layer=li \
 //thickness=0.1 //x=33.42 //y=0.805 //x2=33.42 //y2=0.68
r75 (  19 34 ) resistor r=18.139 //w=0.187 //l=0.265 //layer=li \
 //thickness=0.1 //x=33.42 //y=0.805 //x2=33.42 //y2=1.07
r76 (  16 34 ) resistor r=3.57586 //w=0.17 //l=0.103078 //layer=li \
 //thickness=0.1 //x=32.535 //y=0.72 //x2=32.45 //y2=0.68
r77 (  16 34 ) resistor r=27.3797 //w=0.187 //l=0.4 //layer=li //thickness=0.1 \
 //x=32.535 //y=0.72 //x2=32.935 //y2=0.72
r78 (  15 34 ) resistor r=3.57586 //w=0.17 //l=0.103078 //layer=li \
 //thickness=0.1 //x=33.335 //y=0.72 //x2=33.42 //y2=0.68
r79 (  15 34 ) resistor r=27.3797 //w=0.187 //l=0.4 //layer=li //thickness=0.1 \
 //x=33.335 //y=0.72 //x2=32.935 //y2=0.72
r80 (  11 30 ) resistor r=5.4201 //w=0.17 //l=0.085 //layer=li //thickness=0.1 \
 //x=32.45 //y=1.26 //x2=32.45 //y2=1.175
r81 (  11 34 ) resistor r=10.2674 //w=0.187 //l=0.15 //layer=li \
 //thickness=0.1 //x=32.45 //y=1.26 //x2=32.45 //y2=1.41
r82 (  8 30 ) resistor r=5.4201 //w=0.17 //l=0.085 //layer=li //thickness=0.1 \
 //x=32.45 //y=1.09 //x2=32.45 //y2=1.175
r83 (  8 34 ) resistor r=1.36898 //w=0.187 //l=0.02 //layer=li //thickness=0.1 \
 //x=32.45 //y=1.09 //x2=32.45 //y2=1.07
r84 (  7 34 ) resistor r=3.57586 //w=0.17 //l=0.125 //layer=li //thickness=0.1 \
 //x=32.45 //y=0.805 //x2=32.45 //y2=0.68
r85 (  7 34 ) resistor r=18.139 //w=0.187 //l=0.265 //layer=li //thickness=0.1 \
 //x=32.45 //y=0.805 //x2=32.45 //y2=1.07
r86 (  6 33 ) resistor r=0.751729 //w=0.17 //l=0.085 //layer=li \
 //thickness=0.1 //x=31.485 //y=1.175 //x2=31.4 //y2=1.175
r87 (  5 30 ) resistor r=1.40859 //w=0.34 //l=0.085 //layer=li //thickness=0.1 \
 //x=32.365 //y=1.175 //x2=32.45 //y2=1.175
r88 (  5 6 ) resistor r=60.2353 //w=0.187 //l=0.88 //layer=li //thickness=0.1 \
 //x=32.365 //y=1.175 //x2=31.485 //y2=1.175
ends PM_TMRDFFSNRNQNX1\%noxref_31

subckt PM_TMRDFFSNRNQNX1\%noxref_32 ( 5 7 15 19 30 33 34 )
c67 ( 34 0 ) capacitor c=0.0451719f //x=37.125 //y=0.555
c68 ( 33 0 ) capacitor c=0.0194981f //x=36.02 //y=1.09
c69 ( 30 0 ) capacitor c=0.00141302f //x=37.26 //y=1.175
c70 ( 19 0 ) capacitor c=0.00692795f //x=38.23 //y=0.805
c71 ( 15 0 ) capacitor c=0.0154868f //x=38.145 //y=0.72
c72 ( 7 0 ) capacitor c=0.00689459f //x=37.26 //y=0.805
c73 ( 5 0 ) capacitor c=0.0235962f //x=37.175 //y=1.175
r74 (  19 34 ) resistor r=3.57586 //w=0.17 //l=0.125 //layer=li \
 //thickness=0.1 //x=38.23 //y=0.805 //x2=38.23 //y2=0.68
r75 (  19 34 ) resistor r=18.139 //w=0.187 //l=0.265 //layer=li \
 //thickness=0.1 //x=38.23 //y=0.805 //x2=38.23 //y2=1.07
r76 (  16 34 ) resistor r=3.57586 //w=0.17 //l=0.103078 //layer=li \
 //thickness=0.1 //x=37.345 //y=0.72 //x2=37.26 //y2=0.68
r77 (  16 34 ) resistor r=27.3797 //w=0.187 //l=0.4 //layer=li //thickness=0.1 \
 //x=37.345 //y=0.72 //x2=37.745 //y2=0.72
r78 (  15 34 ) resistor r=3.57586 //w=0.17 //l=0.103078 //layer=li \
 //thickness=0.1 //x=38.145 //y=0.72 //x2=38.23 //y2=0.68
r79 (  15 34 ) resistor r=27.3797 //w=0.187 //l=0.4 //layer=li //thickness=0.1 \
 //x=38.145 //y=0.72 //x2=37.745 //y2=0.72
r80 (  11 30 ) resistor r=5.4201 //w=0.17 //l=0.085 //layer=li //thickness=0.1 \
 //x=37.26 //y=1.26 //x2=37.26 //y2=1.175
r81 (  11 34 ) resistor r=10.2674 //w=0.187 //l=0.15 //layer=li \
 //thickness=0.1 //x=37.26 //y=1.26 //x2=37.26 //y2=1.41
r82 (  8 30 ) resistor r=5.4201 //w=0.17 //l=0.085 //layer=li //thickness=0.1 \
 //x=37.26 //y=1.09 //x2=37.26 //y2=1.175
r83 (  8 34 ) resistor r=1.36898 //w=0.187 //l=0.02 //layer=li //thickness=0.1 \
 //x=37.26 //y=1.09 //x2=37.26 //y2=1.07
r84 (  7 34 ) resistor r=3.57586 //w=0.17 //l=0.125 //layer=li //thickness=0.1 \
 //x=37.26 //y=0.805 //x2=37.26 //y2=0.68
r85 (  7 34 ) resistor r=18.139 //w=0.187 //l=0.265 //layer=li //thickness=0.1 \
 //x=37.26 //y=0.805 //x2=37.26 //y2=1.07
r86 (  6 33 ) resistor r=0.751729 //w=0.17 //l=0.085 //layer=li \
 //thickness=0.1 //x=36.295 //y=1.175 //x2=36.21 //y2=1.175
r87 (  5 30 ) resistor r=1.40859 //w=0.34 //l=0.085 //layer=li //thickness=0.1 \
 //x=37.175 //y=1.175 //x2=37.26 //y2=1.175
r88 (  5 6 ) resistor r=60.2353 //w=0.187 //l=0.88 //layer=li //thickness=0.1 \
 //x=37.175 //y=1.175 //x2=36.295 //y2=1.175
ends PM_TMRDFFSNRNQNX1\%noxref_32

subckt PM_TMRDFFSNRNQNX1\%noxref_33 ( 5 7 15 19 30 33 34 )
c68 ( 34 0 ) capacitor c=0.0442917f //x=41.935 //y=0.555
c69 ( 33 0 ) capacitor c=0.0193551f //x=40.83 //y=1.09
c70 ( 30 0 ) capacitor c=0.00141302f //x=42.07 //y=1.175
c71 ( 19 0 ) capacitor c=0.00692795f //x=43.04 //y=0.805
c72 ( 15 0 ) capacitor c=0.0154868f //x=42.955 //y=0.72
c73 ( 7 0 ) capacitor c=0.00689459f //x=42.07 //y=0.805
c74 ( 5 0 ) capacitor c=0.0235962f //x=41.985 //y=1.175
r75 (  19 34 ) resistor r=3.57586 //w=0.17 //l=0.125 //layer=li \
 //thickness=0.1 //x=43.04 //y=0.805 //x2=43.04 //y2=0.68
r76 (  19 34 ) resistor r=18.139 //w=0.187 //l=0.265 //layer=li \
 //thickness=0.1 //x=43.04 //y=0.805 //x2=43.04 //y2=1.07
r77 (  16 34 ) resistor r=3.57586 //w=0.17 //l=0.103078 //layer=li \
 //thickness=0.1 //x=42.155 //y=0.72 //x2=42.07 //y2=0.68
r78 (  16 34 ) resistor r=27.3797 //w=0.187 //l=0.4 //layer=li //thickness=0.1 \
 //x=42.155 //y=0.72 //x2=42.555 //y2=0.72
r79 (  15 34 ) resistor r=3.57586 //w=0.17 //l=0.103078 //layer=li \
 //thickness=0.1 //x=42.955 //y=0.72 //x2=43.04 //y2=0.68
r80 (  15 34 ) resistor r=27.3797 //w=0.187 //l=0.4 //layer=li //thickness=0.1 \
 //x=42.955 //y=0.72 //x2=42.555 //y2=0.72
r81 (  11 30 ) resistor r=5.4201 //w=0.17 //l=0.085 //layer=li //thickness=0.1 \
 //x=42.07 //y=1.26 //x2=42.07 //y2=1.175
r82 (  11 34 ) resistor r=10.2674 //w=0.187 //l=0.15 //layer=li \
 //thickness=0.1 //x=42.07 //y=1.26 //x2=42.07 //y2=1.41
r83 (  8 30 ) resistor r=5.4201 //w=0.17 //l=0.085 //layer=li //thickness=0.1 \
 //x=42.07 //y=1.09 //x2=42.07 //y2=1.175
r84 (  8 34 ) resistor r=1.36898 //w=0.187 //l=0.02 //layer=li //thickness=0.1 \
 //x=42.07 //y=1.09 //x2=42.07 //y2=1.07
r85 (  7 34 ) resistor r=3.57586 //w=0.17 //l=0.125 //layer=li //thickness=0.1 \
 //x=42.07 //y=0.805 //x2=42.07 //y2=0.68
r86 (  7 34 ) resistor r=18.139 //w=0.187 //l=0.265 //layer=li //thickness=0.1 \
 //x=42.07 //y=0.805 //x2=42.07 //y2=1.07
r87 (  6 33 ) resistor r=0.751729 //w=0.17 //l=0.085 //layer=li \
 //thickness=0.1 //x=41.105 //y=1.175 //x2=41.02 //y2=1.175
r88 (  5 30 ) resistor r=1.40859 //w=0.34 //l=0.085 //layer=li //thickness=0.1 \
 //x=41.985 //y=1.175 //x2=42.07 //y2=1.175
r89 (  5 6 ) resistor r=60.2353 //w=0.187 //l=0.88 //layer=li //thickness=0.1 \
 //x=41.985 //y=1.175 //x2=41.105 //y2=1.175
ends PM_TMRDFFSNRNQNX1\%noxref_33

subckt PM_TMRDFFSNRNQNX1\%noxref_34 ( 5 7 15 19 30 33 34 )
c67 ( 34 0 ) capacitor c=0.0452753f //x=46.745 //y=0.555
c68 ( 33 0 ) capacitor c=0.0194988f //x=45.64 //y=1.09
c69 ( 30 0 ) capacitor c=0.00141302f //x=46.88 //y=1.175
c70 ( 19 0 ) capacitor c=0.00692795f //x=47.85 //y=0.805
c71 ( 15 0 ) capacitor c=0.0153812f //x=47.765 //y=0.72
c72 ( 7 0 ) capacitor c=0.00689459f //x=46.88 //y=0.805
c73 ( 5 0 ) capacitor c=0.0235962f //x=46.795 //y=1.175
r74 (  19 34 ) resistor r=3.57586 //w=0.17 //l=0.125 //layer=li \
 //thickness=0.1 //x=47.85 //y=0.805 //x2=47.85 //y2=0.68
r75 (  19 34 ) resistor r=18.139 //w=0.187 //l=0.265 //layer=li \
 //thickness=0.1 //x=47.85 //y=0.805 //x2=47.85 //y2=1.07
r76 (  16 34 ) resistor r=3.57586 //w=0.17 //l=0.103078 //layer=li \
 //thickness=0.1 //x=46.965 //y=0.72 //x2=46.88 //y2=0.68
r77 (  16 34 ) resistor r=27.3797 //w=0.187 //l=0.4 //layer=li //thickness=0.1 \
 //x=46.965 //y=0.72 //x2=47.365 //y2=0.72
r78 (  15 34 ) resistor r=3.57586 //w=0.17 //l=0.103078 //layer=li \
 //thickness=0.1 //x=47.765 //y=0.72 //x2=47.85 //y2=0.68
r79 (  15 34 ) resistor r=27.3797 //w=0.187 //l=0.4 //layer=li //thickness=0.1 \
 //x=47.765 //y=0.72 //x2=47.365 //y2=0.72
r80 (  11 30 ) resistor r=5.4201 //w=0.17 //l=0.085 //layer=li //thickness=0.1 \
 //x=46.88 //y=1.26 //x2=46.88 //y2=1.175
r81 (  11 34 ) resistor r=10.2674 //w=0.187 //l=0.15 //layer=li \
 //thickness=0.1 //x=46.88 //y=1.26 //x2=46.88 //y2=1.41
r82 (  8 30 ) resistor r=5.4201 //w=0.17 //l=0.085 //layer=li //thickness=0.1 \
 //x=46.88 //y=1.09 //x2=46.88 //y2=1.175
r83 (  8 34 ) resistor r=1.36898 //w=0.187 //l=0.02 //layer=li //thickness=0.1 \
 //x=46.88 //y=1.09 //x2=46.88 //y2=1.07
r84 (  7 34 ) resistor r=3.57586 //w=0.17 //l=0.125 //layer=li //thickness=0.1 \
 //x=46.88 //y=0.805 //x2=46.88 //y2=0.68
r85 (  7 34 ) resistor r=18.139 //w=0.187 //l=0.265 //layer=li //thickness=0.1 \
 //x=46.88 //y=0.805 //x2=46.88 //y2=1.07
r86 (  6 33 ) resistor r=0.751729 //w=0.17 //l=0.085 //layer=li \
 //thickness=0.1 //x=45.915 //y=1.175 //x2=45.83 //y2=1.175
r87 (  5 30 ) resistor r=1.40859 //w=0.34 //l=0.085 //layer=li //thickness=0.1 \
 //x=46.795 //y=1.175 //x2=46.88 //y2=1.175
r88 (  5 6 ) resistor r=60.2353 //w=0.187 //l=0.88 //layer=li //thickness=0.1 \
 //x=46.795 //y=1.175 //x2=45.915 //y2=1.175
ends PM_TMRDFFSNRNQNX1\%noxref_34

subckt PM_TMRDFFSNRNQNX1\%noxref_35 ( 5 7 15 19 30 33 34 )
c69 ( 34 0 ) capacitor c=0.0449889f //x=51.555 //y=0.555
c70 ( 33 0 ) capacitor c=0.0190261f //x=50.45 //y=1.09
c71 ( 30 0 ) capacitor c=0.00141302f //x=51.69 //y=1.175
c72 ( 19 0 ) capacitor c=0.00692795f //x=52.66 //y=0.805
c73 ( 15 0 ) capacitor c=0.0155872f //x=52.575 //y=0.72
c74 ( 7 0 ) capacitor c=0.00689459f //x=51.69 //y=0.805
c75 ( 5 0 ) capacitor c=0.0235962f //x=51.605 //y=1.175
r76 (  19 34 ) resistor r=3.57586 //w=0.17 //l=0.125 //layer=li \
 //thickness=0.1 //x=52.66 //y=0.805 //x2=52.66 //y2=0.68
r77 (  19 34 ) resistor r=18.139 //w=0.187 //l=0.265 //layer=li \
 //thickness=0.1 //x=52.66 //y=0.805 //x2=52.66 //y2=1.07
r78 (  16 34 ) resistor r=3.57586 //w=0.17 //l=0.103078 //layer=li \
 //thickness=0.1 //x=51.775 //y=0.72 //x2=51.69 //y2=0.68
r79 (  16 34 ) resistor r=27.3797 //w=0.187 //l=0.4 //layer=li //thickness=0.1 \
 //x=51.775 //y=0.72 //x2=52.175 //y2=0.72
r80 (  15 34 ) resistor r=3.57586 //w=0.17 //l=0.103078 //layer=li \
 //thickness=0.1 //x=52.575 //y=0.72 //x2=52.66 //y2=0.68
r81 (  15 34 ) resistor r=27.3797 //w=0.187 //l=0.4 //layer=li //thickness=0.1 \
 //x=52.575 //y=0.72 //x2=52.175 //y2=0.72
r82 (  11 30 ) resistor r=5.4201 //w=0.17 //l=0.085 //layer=li //thickness=0.1 \
 //x=51.69 //y=1.26 //x2=51.69 //y2=1.175
r83 (  11 34 ) resistor r=10.2674 //w=0.187 //l=0.15 //layer=li \
 //thickness=0.1 //x=51.69 //y=1.26 //x2=51.69 //y2=1.41
r84 (  8 30 ) resistor r=5.4201 //w=0.17 //l=0.085 //layer=li //thickness=0.1 \
 //x=51.69 //y=1.09 //x2=51.69 //y2=1.175
r85 (  8 34 ) resistor r=1.36898 //w=0.187 //l=0.02 //layer=li //thickness=0.1 \
 //x=51.69 //y=1.09 //x2=51.69 //y2=1.07
r86 (  7 34 ) resistor r=3.57586 //w=0.17 //l=0.125 //layer=li //thickness=0.1 \
 //x=51.69 //y=0.805 //x2=51.69 //y2=0.68
r87 (  7 34 ) resistor r=18.139 //w=0.187 //l=0.265 //layer=li //thickness=0.1 \
 //x=51.69 //y=0.805 //x2=51.69 //y2=1.07
r88 (  6 33 ) resistor r=0.751729 //w=0.17 //l=0.085 //layer=li \
 //thickness=0.1 //x=50.725 //y=1.175 //x2=50.64 //y2=1.175
r89 (  5 30 ) resistor r=1.40859 //w=0.34 //l=0.085 //layer=li //thickness=0.1 \
 //x=51.605 //y=1.175 //x2=51.69 //y2=1.175
r90 (  5 6 ) resistor r=60.2353 //w=0.187 //l=0.88 //layer=li //thickness=0.1 \
 //x=51.605 //y=1.175 //x2=50.725 //y2=1.175
ends PM_TMRDFFSNRNQNX1\%noxref_35

subckt PM_TMRDFFSNRNQNX1\%noxref_36 ( 5 7 15 19 30 33 34 )
c69 ( 34 0 ) capacitor c=0.0442917f //x=56.365 //y=0.555
c70 ( 33 0 ) capacitor c=0.018587f //x=55.26 //y=1.09
c71 ( 30 0 ) capacitor c=0.00141302f //x=56.5 //y=1.175
c72 ( 19 0 ) capacitor c=0.00692795f //x=57.47 //y=0.805
c73 ( 15 0 ) capacitor c=0.0154873f //x=57.385 //y=0.72
c74 ( 7 0 ) capacitor c=0.00689459f //x=56.5 //y=0.805
c75 ( 5 0 ) capacitor c=0.0235962f //x=56.415 //y=1.175
r76 (  19 34 ) resistor r=3.57586 //w=0.17 //l=0.125 //layer=li \
 //thickness=0.1 //x=57.47 //y=0.805 //x2=57.47 //y2=0.68
r77 (  19 34 ) resistor r=18.139 //w=0.187 //l=0.265 //layer=li \
 //thickness=0.1 //x=57.47 //y=0.805 //x2=57.47 //y2=1.07
r78 (  16 34 ) resistor r=3.57586 //w=0.17 //l=0.103078 //layer=li \
 //thickness=0.1 //x=56.585 //y=0.72 //x2=56.5 //y2=0.68
r79 (  16 34 ) resistor r=27.3797 //w=0.187 //l=0.4 //layer=li //thickness=0.1 \
 //x=56.585 //y=0.72 //x2=56.985 //y2=0.72
r80 (  15 34 ) resistor r=3.57586 //w=0.17 //l=0.103078 //layer=li \
 //thickness=0.1 //x=57.385 //y=0.72 //x2=57.47 //y2=0.68
r81 (  15 34 ) resistor r=27.3797 //w=0.187 //l=0.4 //layer=li //thickness=0.1 \
 //x=57.385 //y=0.72 //x2=56.985 //y2=0.72
r82 (  11 30 ) resistor r=5.4201 //w=0.17 //l=0.085 //layer=li //thickness=0.1 \
 //x=56.5 //y=1.26 //x2=56.5 //y2=1.175
r83 (  11 34 ) resistor r=10.2674 //w=0.187 //l=0.15 //layer=li \
 //thickness=0.1 //x=56.5 //y=1.26 //x2=56.5 //y2=1.41
r84 (  8 30 ) resistor r=5.4201 //w=0.17 //l=0.085 //layer=li //thickness=0.1 \
 //x=56.5 //y=1.09 //x2=56.5 //y2=1.175
r85 (  8 34 ) resistor r=1.36898 //w=0.187 //l=0.02 //layer=li //thickness=0.1 \
 //x=56.5 //y=1.09 //x2=56.5 //y2=1.07
r86 (  7 34 ) resistor r=3.57586 //w=0.17 //l=0.125 //layer=li //thickness=0.1 \
 //x=56.5 //y=0.805 //x2=56.5 //y2=0.68
r87 (  7 34 ) resistor r=18.139 //w=0.187 //l=0.265 //layer=li //thickness=0.1 \
 //x=56.5 //y=0.805 //x2=56.5 //y2=1.07
r88 (  6 33 ) resistor r=0.751729 //w=0.17 //l=0.085 //layer=li \
 //thickness=0.1 //x=55.535 //y=1.175 //x2=55.45 //y2=1.175
r89 (  5 30 ) resistor r=1.40859 //w=0.34 //l=0.085 //layer=li //thickness=0.1 \
 //x=56.415 //y=1.175 //x2=56.5 //y2=1.175
r90 (  5 6 ) resistor r=60.2353 //w=0.187 //l=0.88 //layer=li //thickness=0.1 \
 //x=56.415 //y=1.175 //x2=55.535 //y2=1.175
ends PM_TMRDFFSNRNQNX1\%noxref_36

subckt PM_TMRDFFSNRNQNX1\%noxref_37 ( 5 7 15 19 30 33 34 )
c67 ( 34 0 ) capacitor c=0.0443556f //x=61.175 //y=0.555
c68 ( 33 0 ) capacitor c=0.019073f //x=60.07 //y=1.09
c69 ( 30 0 ) capacitor c=0.00141302f //x=61.31 //y=1.175
c70 ( 19 0 ) capacitor c=0.00692795f //x=62.28 //y=0.805
c71 ( 15 0 ) capacitor c=0.0155078f //x=62.195 //y=0.72
c72 ( 7 0 ) capacitor c=0.00689459f //x=61.31 //y=0.805
c73 ( 5 0 ) capacitor c=0.0235962f //x=61.225 //y=1.175
r74 (  19 34 ) resistor r=3.57586 //w=0.17 //l=0.125 //layer=li \
 //thickness=0.1 //x=62.28 //y=0.805 //x2=62.28 //y2=0.68
r75 (  19 34 ) resistor r=18.139 //w=0.187 //l=0.265 //layer=li \
 //thickness=0.1 //x=62.28 //y=0.805 //x2=62.28 //y2=1.07
r76 (  16 34 ) resistor r=3.57586 //w=0.17 //l=0.103078 //layer=li \
 //thickness=0.1 //x=61.395 //y=0.72 //x2=61.31 //y2=0.68
r77 (  16 34 ) resistor r=27.3797 //w=0.187 //l=0.4 //layer=li //thickness=0.1 \
 //x=61.395 //y=0.72 //x2=61.795 //y2=0.72
r78 (  15 34 ) resistor r=3.57586 //w=0.17 //l=0.103078 //layer=li \
 //thickness=0.1 //x=62.195 //y=0.72 //x2=62.28 //y2=0.68
r79 (  15 34 ) resistor r=27.3797 //w=0.187 //l=0.4 //layer=li //thickness=0.1 \
 //x=62.195 //y=0.72 //x2=61.795 //y2=0.72
r80 (  11 30 ) resistor r=5.4201 //w=0.17 //l=0.085 //layer=li //thickness=0.1 \
 //x=61.31 //y=1.26 //x2=61.31 //y2=1.175
r81 (  11 34 ) resistor r=10.2674 //w=0.187 //l=0.15 //layer=li \
 //thickness=0.1 //x=61.31 //y=1.26 //x2=61.31 //y2=1.41
r82 (  8 30 ) resistor r=5.4201 //w=0.17 //l=0.085 //layer=li //thickness=0.1 \
 //x=61.31 //y=1.09 //x2=61.31 //y2=1.175
r83 (  8 34 ) resistor r=1.36898 //w=0.187 //l=0.02 //layer=li //thickness=0.1 \
 //x=61.31 //y=1.09 //x2=61.31 //y2=1.07
r84 (  7 34 ) resistor r=3.57586 //w=0.17 //l=0.125 //layer=li //thickness=0.1 \
 //x=61.31 //y=0.805 //x2=61.31 //y2=0.68
r85 (  7 34 ) resistor r=18.139 //w=0.187 //l=0.265 //layer=li //thickness=0.1 \
 //x=61.31 //y=0.805 //x2=61.31 //y2=1.07
r86 (  6 33 ) resistor r=0.751729 //w=0.17 //l=0.085 //layer=li \
 //thickness=0.1 //x=60.345 //y=1.175 //x2=60.26 //y2=1.175
r87 (  5 30 ) resistor r=1.40859 //w=0.34 //l=0.085 //layer=li //thickness=0.1 \
 //x=61.225 //y=1.175 //x2=61.31 //y2=1.175
r88 (  5 6 ) resistor r=60.2353 //w=0.187 //l=0.88 //layer=li //thickness=0.1 \
 //x=61.225 //y=1.175 //x2=60.345 //y2=1.175
ends PM_TMRDFFSNRNQNX1\%noxref_37

subckt PM_TMRDFFSNRNQNX1\%noxref_38 ( 5 7 15 19 30 33 34 )
c67 ( 34 0 ) capacitor c=0.0451719f //x=65.985 //y=0.555
c68 ( 33 0 ) capacitor c=0.0194945f //x=64.88 //y=1.09
c69 ( 30 0 ) capacitor c=0.00141302f //x=66.12 //y=1.175
c70 ( 19 0 ) capacitor c=0.00692795f //x=67.09 //y=0.805
c71 ( 15 0 ) capacitor c=0.0154868f //x=67.005 //y=0.72
c72 ( 7 0 ) capacitor c=0.00689459f //x=66.12 //y=0.805
c73 ( 5 0 ) capacitor c=0.0235962f //x=66.035 //y=1.175
r74 (  19 34 ) resistor r=3.57586 //w=0.17 //l=0.125 //layer=li \
 //thickness=0.1 //x=67.09 //y=0.805 //x2=67.09 //y2=0.68
r75 (  19 34 ) resistor r=18.139 //w=0.187 //l=0.265 //layer=li \
 //thickness=0.1 //x=67.09 //y=0.805 //x2=67.09 //y2=1.07
r76 (  16 34 ) resistor r=3.57586 //w=0.17 //l=0.103078 //layer=li \
 //thickness=0.1 //x=66.205 //y=0.72 //x2=66.12 //y2=0.68
r77 (  16 34 ) resistor r=27.3797 //w=0.187 //l=0.4 //layer=li //thickness=0.1 \
 //x=66.205 //y=0.72 //x2=66.605 //y2=0.72
r78 (  15 34 ) resistor r=3.57586 //w=0.17 //l=0.103078 //layer=li \
 //thickness=0.1 //x=67.005 //y=0.72 //x2=67.09 //y2=0.68
r79 (  15 34 ) resistor r=27.3797 //w=0.187 //l=0.4 //layer=li //thickness=0.1 \
 //x=67.005 //y=0.72 //x2=66.605 //y2=0.72
r80 (  11 30 ) resistor r=5.4201 //w=0.17 //l=0.085 //layer=li //thickness=0.1 \
 //x=66.12 //y=1.26 //x2=66.12 //y2=1.175
r81 (  11 34 ) resistor r=10.2674 //w=0.187 //l=0.15 //layer=li \
 //thickness=0.1 //x=66.12 //y=1.26 //x2=66.12 //y2=1.41
r82 (  8 30 ) resistor r=5.4201 //w=0.17 //l=0.085 //layer=li //thickness=0.1 \
 //x=66.12 //y=1.09 //x2=66.12 //y2=1.175
r83 (  8 34 ) resistor r=1.36898 //w=0.187 //l=0.02 //layer=li //thickness=0.1 \
 //x=66.12 //y=1.09 //x2=66.12 //y2=1.07
r84 (  7 34 ) resistor r=3.57586 //w=0.17 //l=0.125 //layer=li //thickness=0.1 \
 //x=66.12 //y=0.805 //x2=66.12 //y2=0.68
r85 (  7 34 ) resistor r=18.139 //w=0.187 //l=0.265 //layer=li //thickness=0.1 \
 //x=66.12 //y=0.805 //x2=66.12 //y2=1.07
r86 (  6 33 ) resistor r=0.751729 //w=0.17 //l=0.085 //layer=li \
 //thickness=0.1 //x=65.155 //y=1.175 //x2=65.07 //y2=1.175
r87 (  5 30 ) resistor r=1.40859 //w=0.34 //l=0.085 //layer=li //thickness=0.1 \
 //x=66.035 //y=1.175 //x2=66.12 //y2=1.175
r88 (  5 6 ) resistor r=60.2353 //w=0.187 //l=0.88 //layer=li //thickness=0.1 \
 //x=66.035 //y=1.175 //x2=65.155 //y2=1.175
ends PM_TMRDFFSNRNQNX1\%noxref_38

subckt PM_TMRDFFSNRNQNX1\%noxref_39 ( 5 7 15 19 30 33 34 )
c68 ( 34 0 ) capacitor c=0.0442917f //x=70.795 //y=0.555
c69 ( 33 0 ) capacitor c=0.0193551f //x=69.69 //y=1.09
c70 ( 30 0 ) capacitor c=0.00141302f //x=70.93 //y=1.175
c71 ( 19 0 ) capacitor c=0.00692795f //x=71.9 //y=0.805
c72 ( 15 0 ) capacitor c=0.0154868f //x=71.815 //y=0.72
c73 ( 7 0 ) capacitor c=0.00689459f //x=70.93 //y=0.805
c74 ( 5 0 ) capacitor c=0.0235962f //x=70.845 //y=1.175
r75 (  19 34 ) resistor r=3.57586 //w=0.17 //l=0.125 //layer=li \
 //thickness=0.1 //x=71.9 //y=0.805 //x2=71.9 //y2=0.68
r76 (  19 34 ) resistor r=18.139 //w=0.187 //l=0.265 //layer=li \
 //thickness=0.1 //x=71.9 //y=0.805 //x2=71.9 //y2=1.07
r77 (  16 34 ) resistor r=3.57586 //w=0.17 //l=0.103078 //layer=li \
 //thickness=0.1 //x=71.015 //y=0.72 //x2=70.93 //y2=0.68
r78 (  16 34 ) resistor r=27.3797 //w=0.187 //l=0.4 //layer=li //thickness=0.1 \
 //x=71.015 //y=0.72 //x2=71.415 //y2=0.72
r79 (  15 34 ) resistor r=3.57586 //w=0.17 //l=0.103078 //layer=li \
 //thickness=0.1 //x=71.815 //y=0.72 //x2=71.9 //y2=0.68
r80 (  15 34 ) resistor r=27.3797 //w=0.187 //l=0.4 //layer=li //thickness=0.1 \
 //x=71.815 //y=0.72 //x2=71.415 //y2=0.72
r81 (  11 30 ) resistor r=5.4201 //w=0.17 //l=0.085 //layer=li //thickness=0.1 \
 //x=70.93 //y=1.26 //x2=70.93 //y2=1.175
r82 (  11 34 ) resistor r=10.2674 //w=0.187 //l=0.15 //layer=li \
 //thickness=0.1 //x=70.93 //y=1.26 //x2=70.93 //y2=1.41
r83 (  8 30 ) resistor r=5.4201 //w=0.17 //l=0.085 //layer=li //thickness=0.1 \
 //x=70.93 //y=1.09 //x2=70.93 //y2=1.175
r84 (  8 34 ) resistor r=1.36898 //w=0.187 //l=0.02 //layer=li //thickness=0.1 \
 //x=70.93 //y=1.09 //x2=70.93 //y2=1.07
r85 (  7 34 ) resistor r=3.57586 //w=0.17 //l=0.125 //layer=li //thickness=0.1 \
 //x=70.93 //y=0.805 //x2=70.93 //y2=0.68
r86 (  7 34 ) resistor r=18.139 //w=0.187 //l=0.265 //layer=li //thickness=0.1 \
 //x=70.93 //y=0.805 //x2=70.93 //y2=1.07
r87 (  6 33 ) resistor r=0.751729 //w=0.17 //l=0.085 //layer=li \
 //thickness=0.1 //x=69.965 //y=1.175 //x2=69.88 //y2=1.175
r88 (  5 30 ) resistor r=1.40859 //w=0.34 //l=0.085 //layer=li //thickness=0.1 \
 //x=70.845 //y=1.175 //x2=70.93 //y2=1.175
r89 (  5 6 ) resistor r=60.2353 //w=0.187 //l=0.88 //layer=li //thickness=0.1 \
 //x=70.845 //y=1.175 //x2=69.965 //y2=1.175
ends PM_TMRDFFSNRNQNX1\%noxref_39

subckt PM_TMRDFFSNRNQNX1\%noxref_40 ( 5 7 15 19 30 33 34 )
c67 ( 34 0 ) capacitor c=0.0452753f //x=75.605 //y=0.555
c68 ( 33 0 ) capacitor c=0.0194988f //x=74.5 //y=1.09
c69 ( 30 0 ) capacitor c=0.00141302f //x=75.74 //y=1.175
c70 ( 19 0 ) capacitor c=0.00692795f //x=76.71 //y=0.805
c71 ( 15 0 ) capacitor c=0.0153812f //x=76.625 //y=0.72
c72 ( 7 0 ) capacitor c=0.00689459f //x=75.74 //y=0.805
c73 ( 5 0 ) capacitor c=0.0235962f //x=75.655 //y=1.175
r74 (  19 34 ) resistor r=3.57586 //w=0.17 //l=0.125 //layer=li \
 //thickness=0.1 //x=76.71 //y=0.805 //x2=76.71 //y2=0.68
r75 (  19 34 ) resistor r=18.139 //w=0.187 //l=0.265 //layer=li \
 //thickness=0.1 //x=76.71 //y=0.805 //x2=76.71 //y2=1.07
r76 (  16 34 ) resistor r=3.57586 //w=0.17 //l=0.103078 //layer=li \
 //thickness=0.1 //x=75.825 //y=0.72 //x2=75.74 //y2=0.68
r77 (  16 34 ) resistor r=27.3797 //w=0.187 //l=0.4 //layer=li //thickness=0.1 \
 //x=75.825 //y=0.72 //x2=76.225 //y2=0.72
r78 (  15 34 ) resistor r=3.57586 //w=0.17 //l=0.103078 //layer=li \
 //thickness=0.1 //x=76.625 //y=0.72 //x2=76.71 //y2=0.68
r79 (  15 34 ) resistor r=27.3797 //w=0.187 //l=0.4 //layer=li //thickness=0.1 \
 //x=76.625 //y=0.72 //x2=76.225 //y2=0.72
r80 (  11 30 ) resistor r=5.4201 //w=0.17 //l=0.085 //layer=li //thickness=0.1 \
 //x=75.74 //y=1.26 //x2=75.74 //y2=1.175
r81 (  11 34 ) resistor r=10.2674 //w=0.187 //l=0.15 //layer=li \
 //thickness=0.1 //x=75.74 //y=1.26 //x2=75.74 //y2=1.41
r82 (  8 30 ) resistor r=5.4201 //w=0.17 //l=0.085 //layer=li //thickness=0.1 \
 //x=75.74 //y=1.09 //x2=75.74 //y2=1.175
r83 (  8 34 ) resistor r=1.36898 //w=0.187 //l=0.02 //layer=li //thickness=0.1 \
 //x=75.74 //y=1.09 //x2=75.74 //y2=1.07
r84 (  7 34 ) resistor r=3.57586 //w=0.17 //l=0.125 //layer=li //thickness=0.1 \
 //x=75.74 //y=0.805 //x2=75.74 //y2=0.68
r85 (  7 34 ) resistor r=18.139 //w=0.187 //l=0.265 //layer=li //thickness=0.1 \
 //x=75.74 //y=0.805 //x2=75.74 //y2=1.07
r86 (  6 33 ) resistor r=0.751729 //w=0.17 //l=0.085 //layer=li \
 //thickness=0.1 //x=74.775 //y=1.175 //x2=74.69 //y2=1.175
r87 (  5 30 ) resistor r=1.40859 //w=0.34 //l=0.085 //layer=li //thickness=0.1 \
 //x=75.655 //y=1.175 //x2=75.74 //y2=1.175
r88 (  5 6 ) resistor r=60.2353 //w=0.187 //l=0.88 //layer=li //thickness=0.1 \
 //x=75.655 //y=1.175 //x2=74.775 //y2=1.175
ends PM_TMRDFFSNRNQNX1\%noxref_40

subckt PM_TMRDFFSNRNQNX1\%noxref_41 ( 5 7 15 19 30 33 34 )
c68 ( 34 0 ) capacitor c=0.0440892f //x=80.415 //y=0.555
c69 ( 33 0 ) capacitor c=0.0190261f //x=79.31 //y=1.09
c70 ( 30 0 ) capacitor c=0.00141302f //x=80.55 //y=1.175
c71 ( 19 0 ) capacitor c=0.00692795f //x=81.52 //y=0.805
c72 ( 15 0 ) capacitor c=0.0155864f //x=81.435 //y=0.72
c73 ( 7 0 ) capacitor c=0.00689459f //x=80.55 //y=0.805
c74 ( 5 0 ) capacitor c=0.0247635f //x=80.465 //y=1.175
r75 (  19 34 ) resistor r=3.57586 //w=0.17 //l=0.125 //layer=li \
 //thickness=0.1 //x=81.52 //y=0.805 //x2=81.52 //y2=0.68
r76 (  19 34 ) resistor r=18.139 //w=0.187 //l=0.265 //layer=li \
 //thickness=0.1 //x=81.52 //y=0.805 //x2=81.52 //y2=1.07
r77 (  16 34 ) resistor r=3.57586 //w=0.17 //l=0.103078 //layer=li \
 //thickness=0.1 //x=80.635 //y=0.72 //x2=80.55 //y2=0.68
r78 (  16 34 ) resistor r=27.3797 //w=0.187 //l=0.4 //layer=li //thickness=0.1 \
 //x=80.635 //y=0.72 //x2=81.035 //y2=0.72
r79 (  15 34 ) resistor r=3.57586 //w=0.17 //l=0.103078 //layer=li \
 //thickness=0.1 //x=81.435 //y=0.72 //x2=81.52 //y2=0.68
r80 (  15 34 ) resistor r=27.3797 //w=0.187 //l=0.4 //layer=li //thickness=0.1 \
 //x=81.435 //y=0.72 //x2=81.035 //y2=0.72
r81 (  11 30 ) resistor r=5.4201 //w=0.17 //l=0.085 //layer=li //thickness=0.1 \
 //x=80.55 //y=1.26 //x2=80.55 //y2=1.175
r82 (  11 34 ) resistor r=10.2674 //w=0.187 //l=0.15 //layer=li \
 //thickness=0.1 //x=80.55 //y=1.26 //x2=80.55 //y2=1.41
r83 (  8 30 ) resistor r=5.4201 //w=0.17 //l=0.085 //layer=li //thickness=0.1 \
 //x=80.55 //y=1.09 //x2=80.55 //y2=1.175
r84 (  8 34 ) resistor r=1.36898 //w=0.187 //l=0.02 //layer=li //thickness=0.1 \
 //x=80.55 //y=1.09 //x2=80.55 //y2=1.07
r85 (  7 34 ) resistor r=3.57586 //w=0.17 //l=0.125 //layer=li //thickness=0.1 \
 //x=80.55 //y=0.805 //x2=80.55 //y2=0.68
r86 (  7 34 ) resistor r=18.139 //w=0.187 //l=0.265 //layer=li //thickness=0.1 \
 //x=80.55 //y=0.805 //x2=80.55 //y2=1.07
r87 (  6 33 ) resistor r=0.751729 //w=0.17 //l=0.085 //layer=li \
 //thickness=0.1 //x=79.585 //y=1.175 //x2=79.5 //y2=1.175
r88 (  5 30 ) resistor r=1.40859 //w=0.34 //l=0.085 //layer=li //thickness=0.1 \
 //x=80.465 //y=1.175 //x2=80.55 //y2=1.175
r89 (  5 6 ) resistor r=60.2353 //w=0.187 //l=0.88 //layer=li //thickness=0.1 \
 //x=80.465 //y=1.175 //x2=79.585 //y2=1.175
ends PM_TMRDFFSNRNQNX1\%noxref_41

subckt PM_TMRDFFSNRNQNX1\%noxref_42 ( 5 7 15 19 30 33 34 )
c69 ( 34 0 ) capacitor c=0.0442064f //x=85.225 //y=0.555
c70 ( 33 0 ) capacitor c=0.0185765f //x=84.12 //y=1.09
c71 ( 30 0 ) capacitor c=0.00141302f //x=85.36 //y=1.175
c72 ( 19 0 ) capacitor c=0.00695768f //x=86.33 //y=0.805
c73 ( 15 0 ) capacitor c=0.0154873f //x=86.245 //y=0.72
c74 ( 7 0 ) capacitor c=0.00689476f //x=85.36 //y=0.805
c75 ( 5 0 ) capacitor c=0.0235962f //x=85.275 //y=1.175
r76 (  19 34 ) resistor r=3.57586 //w=0.17 //l=0.125 //layer=li \
 //thickness=0.1 //x=86.33 //y=0.805 //x2=86.33 //y2=0.68
r77 (  19 34 ) resistor r=18.139 //w=0.187 //l=0.265 //layer=li \
 //thickness=0.1 //x=86.33 //y=0.805 //x2=86.33 //y2=1.07
r78 (  16 34 ) resistor r=3.57586 //w=0.17 //l=0.103078 //layer=li \
 //thickness=0.1 //x=85.445 //y=0.72 //x2=85.36 //y2=0.68
r79 (  16 34 ) resistor r=27.3797 //w=0.187 //l=0.4 //layer=li //thickness=0.1 \
 //x=85.445 //y=0.72 //x2=85.845 //y2=0.72
r80 (  15 34 ) resistor r=3.57586 //w=0.17 //l=0.103078 //layer=li \
 //thickness=0.1 //x=86.245 //y=0.72 //x2=86.33 //y2=0.68
r81 (  15 34 ) resistor r=27.3797 //w=0.187 //l=0.4 //layer=li //thickness=0.1 \
 //x=86.245 //y=0.72 //x2=85.845 //y2=0.72
r82 (  11 30 ) resistor r=5.4201 //w=0.17 //l=0.085 //layer=li //thickness=0.1 \
 //x=85.36 //y=1.26 //x2=85.36 //y2=1.175
r83 (  11 34 ) resistor r=10.2674 //w=0.187 //l=0.15 //layer=li \
 //thickness=0.1 //x=85.36 //y=1.26 //x2=85.36 //y2=1.41
r84 (  8 30 ) resistor r=5.4201 //w=0.17 //l=0.085 //layer=li //thickness=0.1 \
 //x=85.36 //y=1.09 //x2=85.36 //y2=1.175
r85 (  8 34 ) resistor r=1.36898 //w=0.187 //l=0.02 //layer=li //thickness=0.1 \
 //x=85.36 //y=1.09 //x2=85.36 //y2=1.07
r86 (  7 34 ) resistor r=3.57586 //w=0.17 //l=0.125 //layer=li //thickness=0.1 \
 //x=85.36 //y=0.805 //x2=85.36 //y2=0.68
r87 (  7 34 ) resistor r=18.139 //w=0.187 //l=0.265 //layer=li //thickness=0.1 \
 //x=85.36 //y=0.805 //x2=85.36 //y2=1.07
r88 (  6 33 ) resistor r=0.751729 //w=0.17 //l=0.085 //layer=li \
 //thickness=0.1 //x=84.395 //y=1.175 //x2=84.31 //y2=1.175
r89 (  5 30 ) resistor r=1.40859 //w=0.34 //l=0.085 //layer=li //thickness=0.1 \
 //x=85.275 //y=1.175 //x2=85.36 //y2=1.175
r90 (  5 6 ) resistor r=60.2353 //w=0.187 //l=0.88 //layer=li //thickness=0.1 \
 //x=85.275 //y=1.175 //x2=84.395 //y2=1.175
ends PM_TMRDFFSNRNQNX1\%noxref_42

subckt PM_TMRDFFSNRNQNX1\%noxref_43 ( 1 3 4 5 7 9 19 25 27 30 40 49 71 72 73 \
 74 75 )
c161 ( 75 0 ) capacitor c=0.0354016f //x=92.795 //y=5.205
c162 ( 74 0 ) capacitor c=0.0241107f //x=91.915 //y=5.205
c163 ( 72 0 ) capacitor c=0.00544792f //x=89.035 //y=5.205
c164 ( 71 0 ) capacitor c=0.00516996f //x=88.155 //y=5.205
c165 ( 49 0 ) capacitor c=0.0508454f //x=91.18 //y=5.39
c166 ( 40 0 ) capacitor c=0.0363228f //x=89.18 //y=5.39
c167 ( 30 0 ) capacitor c=0.0294643f //x=88.3 //y=5.56
c168 ( 27 0 ) capacitor c=0.00984489f //x=92.94 //y=6.92
c169 ( 25 0 ) capacitor c=0.0059844f //x=92.057 //y=7.09
c170 ( 19 0 ) capacitor c=0.00975753f //x=91.18 //y=6.92
c171 ( 9 0 ) capacitor c=0.014892f //x=88.302 //y=5.39
c172 ( 7 0 ) capacitor c=0.00787288f //x=92.825 //y=7.09
c173 ( 5 0 ) capacitor c=0.00659042f //x=91.94 //y=7.09
c174 ( 4 0 ) capacitor c=0.00558326f //x=89.295 //y=5.39
c175 ( 3 0 ) capacitor c=0.0636102f //x=91.065 //y=5.39
c176 ( 1 0 ) capacitor c=0.0145996f //x=89.065 //y=5.39
r177 (  49 73 ) resistor r=58.1818 //w=0.187 //l=0.85 //layer=li \
 //thickness=0.1 //x=91.18 //y=5.39 //x2=91.18 //y2=6.24
r178 (  40 72 ) resistor r=58.1818 //w=0.187 //l=0.85 //layer=li \
 //thickness=0.1 //x=89.18 //y=5.39 //x2=89.18 //y2=6.24
r179 (  30 71 ) resistor r=23.2727 //w=0.187 //l=0.34 //layer=li \
 //thickness=0.1 //x=88.3 //y=5.56 //x2=88.3 //y2=5.9
r180 (  27 75 ) resistor r=9.3 //w=0.17 //l=0.17 //layer=mcon //count=1 \
 //x=92.94 //y=6.92 //x2=92.94 //y2=6.92
r181 (  27 28 ) resistor r=0.0988372 //w=0.215 //l=0.17 //layer=m1 \
 //thickness=0.36 //x=92.942 //y=6.92 //x2=92.942 //y2=7.09
r182 (  24 74 ) resistor r=9.3 //w=0.17 //l=0.17 //layer=mcon //count=1 \
 //x=92.06 //y=6.92 //x2=92.06 //y2=6.92
r183 (  24 25 ) resistor r=0.0940266 //w=0.226 //l=0.17 //layer=m1 \
 //thickness=0.36 //x=92.057 //y=6.92 //x2=92.057 //y2=7.09
r184 (  22 49 ) resistor r=9.3 //w=0.17 //l=0.17 //layer=mcon //count=1 \
 //x=91.18 //y=5.39 //x2=91.18 //y2=5.39
r185 (  19 73 ) resistor r=9.3 //w=0.17 //l=0.17 //layer=mcon //count=1 \
 //x=91.18 //y=6.92 //x2=91.18 //y2=6.92
r186 (  19 20 ) resistor r=0.0979263 //w=0.217 //l=0.17 //layer=m1 \
 //thickness=0.36 //x=91.182 //y=6.92 //x2=91.182 //y2=7.09
r187 (  15 40 ) resistor r=9.3 //w=0.17 //l=0.17 //layer=mcon //count=1 \
 //x=89.18 //y=5.39 //x2=89.18 //y2=5.39
r188 (  11 30 ) resistor r=9.3 //w=0.17 //l=0.17 //layer=mcon //count=1 \
 //x=88.3 //y=5.56 //x2=88.3 //y2=5.56
r189 (  9 11 ) resistor r=0.0944444 //w=0.225 //l=0.17 //layer=m1 \
 //thickness=0.36 //x=88.302 //y=5.39 //x2=88.302 //y2=5.56
r190 (  8 25 ) resistor r=0.0246599 //w=0.226 //l=0.118 //layer=m1 \
 //thickness=0.36 //x=92.175 //y=7.09 //x2=92.057 //y2=7.09
r191 (  7 28 ) resistor r=0.0216707 //w=0.215 //l=0.117 //layer=m1 \
 //thickness=0.36 //x=92.825 //y=7.09 //x2=92.942 //y2=7.09
r192 (  7 8 ) resistor r=0.620229 //w=0.131 //l=0.65 //layer=m1 \
 //thickness=0.36 //x=92.825 //y=7.09 //x2=92.175 //y2=7.09
r193 (  6 20 ) resistor r=0.0222262 //w=0.217 //l=0.118 //layer=m1 \
 //thickness=0.36 //x=91.3 //y=7.09 //x2=91.182 //y2=7.09
r194 (  5 25 ) resistor r=0.0246599 //w=0.226 //l=0.117 //layer=m1 \
 //thickness=0.36 //x=91.94 //y=7.09 //x2=92.057 //y2=7.09
r195 (  5 6 ) resistor r=0.610687 //w=0.131 //l=0.64 //layer=m1 \
 //thickness=0.36 //x=91.94 //y=7.09 //x2=91.3 //y2=7.09
r196 (  4 15 ) resistor r=0.0880901 //w=0.191 //l=0.115 //layer=m1 \
 //thickness=0.36 //x=89.295 //y=5.39 //x2=89.18 //y2=5.39
r197 (  3 22 ) resistor r=0.0717383 //w=0.224 //l=0.115 //layer=m1 \
 //thickness=0.36 //x=91.065 //y=5.39 //x2=91.18 //y2=5.39
r198 (  3 4 ) resistor r=1.68893 //w=0.131 //l=1.77 //layer=m1 \
 //thickness=0.36 //x=91.065 //y=5.39 //x2=89.295 //y2=5.39
r199 (  2 9 ) resistor r=0.0243946 //w=0.225 //l=0.123 //layer=m1 \
 //thickness=0.36 //x=88.425 //y=5.39 //x2=88.302 //y2=5.39
r200 (  1 15 ) resistor r=0.0880901 //w=0.191 //l=0.115 //layer=m1 \
 //thickness=0.36 //x=89.065 //y=5.39 //x2=89.18 //y2=5.39
r201 (  1 2 ) resistor r=0.610687 //w=0.131 //l=0.64 //layer=m1 \
 //thickness=0.36 //x=89.065 //y=5.39 //x2=88.425 //y2=5.39
ends PM_TMRDFFSNRNQNX1\%noxref_43

subckt PM_TMRDFFSNRNQNX1\%noxref_44 ( 1 3 4 5 7 9 13 15 21 23 26 38 60 61 62 \
 63 )
c124 ( 63 0 ) capacitor c=0.034392f //x=96.135 //y=5.205
c125 ( 62 0 ) capacitor c=0.0239063f //x=95.255 //y=5.205
c126 ( 38 0 ) capacitor c=0.0496553f //x=94.52 //y=5.39
c127 ( 26 0 ) capacitor c=0.0229521f //x=91.62 //y=5.56
c128 ( 23 0 ) capacitor c=0.0155899f //x=96.28 //y=6.92
c129 ( 21 0 ) capacitor c=0.00566376f //x=95.4 //y=7.09
c130 ( 15 0 ) capacitor c=0.00945187f //x=94.52 //y=6.92
c131 ( 13 0 ) capacitor c=0.0163615f //x=92.5 //y=5.39
c132 ( 9 0 ) capacitor c=0.0150333f //x=91.62 //y=5.39
c133 ( 7 0 ) capacitor c=0.0068287f //x=96.15 //y=7.09
c134 ( 5 0 ) capacitor c=0.00878908f //x=95.285 //y=7.09
c135 ( 4 0 ) capacitor c=0.00826388f //x=92.615 //y=5.39
c136 ( 3 0 ) capacitor c=0.0570379f //x=94.405 //y=5.39
c137 ( 1 0 ) capacitor c=0.0183133f //x=92.385 //y=5.39
r138 (  38 61 ) resistor r=58.1818 //w=0.187 //l=0.85 //layer=li \
 //thickness=0.1 //x=94.52 //y=5.39 //x2=94.52 //y2=6.24
r139 (  26 60 ) resistor r=23.2727 //w=0.187 //l=0.34 //layer=li \
 //thickness=0.1 //x=91.62 //y=5.56 //x2=91.62 //y2=5.9
r140 (  23 63 ) resistor r=9.3 //w=0.17 //l=0.17 //layer=mcon //count=1 \
 //x=96.28 //y=6.92 //x2=96.28 //y2=6.92
r141 (  23 24 ) resistor r=0.0923913 //w=0.23 //l=0.17 //layer=m1 \
 //thickness=0.36 //x=96.275 //y=6.92 //x2=96.275 //y2=7.09
r142 (  20 62 ) resistor r=9.3 //w=0.17 //l=0.17 //layer=mcon //count=1 \
 //x=95.4 //y=6.92 //x2=95.4 //y2=6.92
r143 (  20 21 ) resistor r=0.0957207 //w=0.222 //l=0.17 //layer=m1 \
 //thickness=0.36 //x=95.4 //y=6.92 //x2=95.4 //y2=7.09
r144 (  18 38 ) resistor r=9.3 //w=0.17 //l=0.17 //layer=mcon //count=1 \
 //x=94.52 //y=5.39 //x2=94.52 //y2=5.39
r145 (  15 61 ) resistor r=9.3 //w=0.17 //l=0.17 //layer=mcon //count=1 \
 //x=94.52 //y=6.92 //x2=94.52 //y2=6.92
r146 (  15 16 ) resistor r=0.100236 //w=0.212 //l=0.17 //layer=m1 \
 //thickness=0.36 //x=94.52 //y=6.92 //x2=94.52 //y2=7.09
r147 (  11 26 ) resistor r=9.3 //w=0.17 //l=0.17 //layer=mcon //count=1 \
 //x=91.62 //y=5.56 //x2=91.62 //y2=5.56
r148 (  9 11 ) resistor r=0.100236 //w=0.212 //l=0.17 //layer=m1 \
 //thickness=0.36 //x=91.62 //y=5.39 //x2=91.62 //y2=5.56
r149 (  8 21 ) resistor r=0.0235912 //w=0.222 //l=0.115 //layer=m1 \
 //thickness=0.36 //x=95.515 //y=7.09 //x2=95.4 //y2=7.09
r150 (  7 24 ) resistor r=0.0257089 //w=0.23 //l=0.125 //layer=m1 \
 //thickness=0.36 //x=96.15 //y=7.09 //x2=96.275 //y2=7.09
r151 (  7 8 ) resistor r=0.605916 //w=0.131 //l=0.635 //layer=m1 \
 //thickness=0.36 //x=96.15 //y=7.09 //x2=95.515 //y2=7.09
r152 (  6 16 ) resistor r=0.0208269 //w=0.212 //l=0.115 //layer=m1 \
 //thickness=0.36 //x=94.635 //y=7.09 //x2=94.52 //y2=7.09
r153 (  5 21 ) resistor r=0.0235912 //w=0.222 //l=0.115 //layer=m1 \
 //thickness=0.36 //x=95.285 //y=7.09 //x2=95.4 //y2=7.09
r154 (  5 6 ) resistor r=0.620229 //w=0.131 //l=0.65 //layer=m1 \
 //thickness=0.36 //x=95.285 //y=7.09 //x2=94.635 //y2=7.09
r155 (  4 13 ) resistor r=0.0880901 //w=0.191 //l=0.115 //layer=m1 \
 //thickness=0.36 //x=92.615 //y=5.39 //x2=92.5 //y2=5.39
r156 (  3 18 ) resistor r=0.0717383 //w=0.224 //l=0.115 //layer=m1 \
 //thickness=0.36 //x=94.405 //y=5.39 //x2=94.52 //y2=5.39
r157 (  3 4 ) resistor r=1.70802 //w=0.131 //l=1.79 //layer=m1 \
 //thickness=0.36 //x=94.405 //y=5.39 //x2=92.615 //y2=5.39
r158 (  2 9 ) resistor r=0.0208269 //w=0.212 //l=0.115 //layer=m1 \
 //thickness=0.36 //x=91.735 //y=5.39 //x2=91.62 //y2=5.39
r159 (  1 13 ) resistor r=0.0880901 //w=0.191 //l=0.115 //layer=m1 \
 //thickness=0.36 //x=92.385 //y=5.39 //x2=92.5 //y2=5.39
r160 (  1 2 ) resistor r=0.620229 //w=0.131 //l=0.65 //layer=m1 \
 //thickness=0.36 //x=92.385 //y=5.39 //x2=91.735 //y2=5.39
ends PM_TMRDFFSNRNQNX1\%noxref_44

subckt PM_TMRDFFSNRNQNX1\%GND ( 1 2 6 7 18 19 30 31 42 43 54 55 66 67 78 79 90 \
 91 102 103 114 115 127 128 139 140 151 152 163 164 175 176 187 188 199 200 \
 211 212 223 224 232 239 244 247 251 255 259 263 267 271 275 279 283 287 291 \
 295 299 303 307 311 315 322 328 331 345 362 379 396 413 430 447 464 481 498 \
 515 532 549 566 583 600 617 634 649 664 672 673 674 675 676 677 678 679 680 \
 681 682 683 684 685 686 687 688 689 690 691 692 693 694 695 696 697 698 699 \
 700 701 702 703 704 705 706 707 708 709 710 711 )
c1674 ( 711 0 ) capacitor c=0.00828027f //x=94.72 //y=1.045
c1675 ( 710 0 ) capacitor c=0.0083251f //x=88.06 //y=1.045
c1676 ( 709 0 ) capacitor c=0.00840423f //x=83.145 //y=1.055
c1677 ( 708 0 ) capacitor c=0.00840423f //x=78.335 //y=1.055
c1678 ( 707 0 ) capacitor c=0.00840423f //x=73.525 //y=1.055
c1679 ( 706 0 ) capacitor c=0.00840423f //x=68.715 //y=1.055
c1680 ( 705 0 ) capacitor c=0.00840423f //x=63.905 //y=1.055
c1681 ( 704 0 ) capacitor c=0.00840423f //x=59.095 //y=1.055
c1682 ( 703 0 ) capacitor c=0.00840423f //x=54.285 //y=1.055
c1683 ( 702 0 ) capacitor c=0.00840423f //x=49.475 //y=1.055
c1684 ( 701 0 ) capacitor c=0.00840423f //x=44.665 //y=1.055
c1685 ( 700 0 ) capacitor c=0.00840423f //x=39.855 //y=1.055
c1686 ( 699 0 ) capacitor c=0.00840423f //x=35.045 //y=1.055
c1687 ( 698 0 ) capacitor c=0.00840423f //x=30.235 //y=1.055
c1688 ( 697 0 ) capacitor c=0.00840423f //x=25.425 //y=1.055
c1689 ( 696 0 ) capacitor c=0.00840423f //x=20.615 //y=1.055
c1690 ( 695 0 ) capacitor c=0.00840423f //x=15.805 //y=1.055
c1691 ( 694 0 ) capacitor c=0.00840423f //x=10.995 //y=1.055
c1692 ( 693 0 ) capacitor c=0.00840423f //x=6.185 //y=1.055
c1693 ( 692 0 ) capacitor c=0.00840423f //x=1.375 //y=1.055
c1694 ( 691 0 ) capacitor c=0.110371f //x=93.73 //y=0.175
c1695 ( 690 0 ) capacitor c=0.124012f //x=90.4 //y=0.175
c1696 ( 689 0 ) capacitor c=0.114547f //x=87.07 //y=0.175
c1697 ( 688 0 ) capacitor c=0.110773f //x=82.26 //y=0.175
c1698 ( 687 0 ) capacitor c=0.115871f //x=77.45 //y=0.175
c1699 ( 686 0 ) capacitor c=0.109628f //x=72.64 //y=0.175
c1700 ( 685 0 ) capacitor c=0.112438f //x=67.83 //y=0.175
c1701 ( 684 0 ) capacitor c=0.109586f //x=63.02 //y=0.175
c1702 ( 683 0 ) capacitor c=0.111695f //x=58.21 //y=0.175
c1703 ( 682 0 ) capacitor c=0.113313f //x=53.4 //y=0.175
c1704 ( 681 0 ) capacitor c=0.115871f //x=48.59 //y=0.175
c1705 ( 680 0 ) capacitor c=0.109628f //x=43.78 //y=0.175
c1706 ( 679 0 ) capacitor c=0.112438f //x=38.97 //y=0.175
c1707 ( 678 0 ) capacitor c=0.109586f //x=34.16 //y=0.175
c1708 ( 677 0 ) capacitor c=0.114177f //x=29.35 //y=0.175
c1709 ( 676 0 ) capacitor c=0.109534f //x=24.54 //y=0.175
c1710 ( 675 0 ) capacitor c=0.114177f //x=19.73 //y=0.175
c1711 ( 674 0 ) capacitor c=0.109628f //x=14.92 //y=0.175
c1712 ( 673 0 ) capacitor c=0.112592f //x=10.11 //y=0.175
c1713 ( 672 0 ) capacitor c=0.10974f //x=5.3 //y=0.175
c1714 ( 664 0 ) capacitor c=0.333412f //x=96.32 //y=0.18
c1715 ( 649 0 ) capacitor c=0.118825f //x=93.56 //y=0.175
c1716 ( 634 0 ) capacitor c=0.119089f //x=90.23 //y=0.175
c1717 ( 617 0 ) capacitor c=0.176388f //x=86.9 //y=0.175
c1718 ( 600 0 ) capacitor c=0.174611f //x=82.09 //y=0.175
c1719 ( 583 0 ) capacitor c=0.176385f //x=77.28 //y=0.175
c1720 ( 566 0 ) capacitor c=0.176388f //x=72.47 //y=0.175
c1721 ( 549 0 ) capacitor c=0.176388f //x=67.66 //y=0.175
c1722 ( 532 0 ) capacitor c=0.17641f //x=62.85 //y=0.175
c1723 ( 515 0 ) capacitor c=0.176388f //x=58.04 //y=0.175
c1724 ( 498 0 ) capacitor c=0.176434f //x=53.23 //y=0.175
c1725 ( 481 0 ) capacitor c=0.176385f //x=48.42 //y=0.175
c1726 ( 464 0 ) capacitor c=0.176388f //x=43.61 //y=0.175
c1727 ( 447 0 ) capacitor c=0.176388f //x=38.8 //y=0.175
c1728 ( 430 0 ) capacitor c=0.17641f //x=33.99 //y=0.175
c1729 ( 413 0 ) capacitor c=0.176388f //x=29.18 //y=0.175
c1730 ( 396 0 ) capacitor c=0.176414f //x=24.37 //y=0.175
c1731 ( 379 0 ) capacitor c=0.176385f //x=19.56 //y=0.175
c1732 ( 362 0 ) capacitor c=0.176388f //x=14.75 //y=0.175
c1733 ( 345 0 ) capacitor c=0.176388f //x=9.94 //y=0.175
c1734 ( 331 0 ) capacitor c=0.197064f //x=1.23 //y=0.18
c1735 ( 328 0 ) capacitor c=0.17924f //x=5.13 //y=0.175
c1736 ( 323 0 ) capacitor c=0.00509083f //x=94.91 //y=0.175
c1737 ( 322 0 ) capacitor c=0.0256262f //x=91.51 //y=0.18
c1738 ( 318 0 ) capacitor c=0.00509083f //x=88.25 //y=0.175
c1739 ( 317 0 ) capacitor c=0.00509414f //x=83.335 //y=0.175
c1740 ( 315 0 ) capacitor c=0.0139218f //x=83.335 //y=1.145
c1741 ( 313 0 ) capacitor c=0.00509414f //x=78.525 //y=0.175
c1742 ( 311 0 ) capacitor c=0.0140686f //x=78.525 //y=1.145
c1743 ( 309 0 ) capacitor c=0.00509414f //x=73.715 //y=0.175
c1744 ( 307 0 ) capacitor c=0.0140128f //x=73.715 //y=1.145
c1745 ( 305 0 ) capacitor c=0.00509414f //x=68.905 //y=0.175
c1746 ( 303 0 ) capacitor c=0.0140132f //x=68.905 //y=1.145
c1747 ( 301 0 ) capacitor c=0.00509414f //x=64.095 //y=0.175
c1748 ( 299 0 ) capacitor c=0.0140783f //x=64.095 //y=1.145
c1749 ( 297 0 ) capacitor c=0.00509414f //x=59.285 //y=0.175
c1750 ( 295 0 ) capacitor c=0.0140562f //x=59.285 //y=1.145
c1751 ( 293 0 ) capacitor c=0.00509414f //x=54.475 //y=0.175
c1752 ( 291 0 ) capacitor c=0.0140651f //x=54.475 //y=1.145
c1753 ( 289 0 ) capacitor c=0.00509414f //x=49.665 //y=0.175
c1754 ( 287 0 ) capacitor c=0.0140644f //x=49.665 //y=1.145
c1755 ( 285 0 ) capacitor c=0.00509414f //x=44.855 //y=0.175
c1756 ( 283 0 ) capacitor c=0.0140128f //x=44.855 //y=1.145
c1757 ( 281 0 ) capacitor c=0.00509414f //x=40.045 //y=0.175
c1758 ( 279 0 ) capacitor c=0.0140132f //x=40.045 //y=1.145
c1759 ( 277 0 ) capacitor c=0.00509414f //x=35.235 //y=0.175
c1760 ( 275 0 ) capacitor c=0.0140783f //x=35.235 //y=1.145
c1761 ( 273 0 ) capacitor c=0.00509414f //x=30.425 //y=0.175
c1762 ( 271 0 ) capacitor c=0.0141008f //x=30.425 //y=1.145
c1763 ( 269 0 ) capacitor c=0.00509414f //x=25.615 //y=0.175
c1764 ( 267 0 ) capacitor c=0.0140088f //x=25.615 //y=1.145
c1765 ( 265 0 ) capacitor c=0.00509414f //x=20.805 //y=0.175
c1766 ( 263 0 ) capacitor c=0.0140686f //x=20.805 //y=1.145
c1767 ( 261 0 ) capacitor c=0.00509414f //x=15.995 //y=0.175
c1768 ( 259 0 ) capacitor c=0.0140168f //x=15.995 //y=1.145
c1769 ( 257 0 ) capacitor c=0.00509414f //x=11.185 //y=0.175
c1770 ( 255 0 ) capacitor c=0.0139572f //x=11.185 //y=1.145
c1771 ( 253 0 ) capacitor c=0.00509414f //x=6.375 //y=0.175
c1772 ( 251 0 ) capacitor c=0.0140851f //x=6.375 //y=1.145
c1773 ( 249 0 ) capacitor c=0.00509414f //x=1.565 //y=0.175
c1774 ( 247 0 ) capacitor c=0.0169996f //x=1.565 //y=1.145
c1775 ( 244 0 ) capacitor c=0.10135f //x=96.32 //y=0.18
c1776 ( 239 0 ) capacitor c=0.0435289f //x=94.91 //y=1.02
c1777 ( 232 0 ) capacitor c=0.10749f //x=94.825 //y=0.175
c1778 ( 224 0 ) capacitor c=0.112526f //x=91.495 //y=0.175
c1779 ( 223 0 ) capacitor c=0.0413076f //x=88.25 //y=1.015
c1780 ( 212 0 ) capacitor c=0.154984f //x=88.165 //y=0.175
c1781 ( 211 0 ) capacitor c=0.0302305f //x=83.335 //y=1.015
c1782 ( 200 0 ) capacitor c=0.14844f //x=83.25 //y=0.175
c1783 ( 199 0 ) capacitor c=0.0302305f //x=78.525 //y=1.015
c1784 ( 188 0 ) capacitor c=0.14916f //x=78.44 //y=0.175
c1785 ( 187 0 ) capacitor c=0.0302305f //x=73.715 //y=1.015
c1786 ( 176 0 ) capacitor c=0.148704f //x=73.63 //y=0.175
c1787 ( 175 0 ) capacitor c=0.0302305f //x=68.905 //y=1.015
c1788 ( 164 0 ) capacitor c=0.149124f //x=68.82 //y=0.175
c1789 ( 163 0 ) capacitor c=0.0302305f //x=64.095 //y=1.015
c1790 ( 152 0 ) capacitor c=0.148598f //x=64.01 //y=0.175
c1791 ( 151 0 ) capacitor c=0.0302305f //x=59.285 //y=1.015
c1792 ( 140 0 ) capacitor c=0.150358f //x=59.2 //y=0.175
c1793 ( 139 0 ) capacitor c=0.0302305f //x=54.475 //y=1.015
c1794 ( 128 0 ) capacitor c=0.149093f //x=54.39 //y=0.175
c1795 ( 127 0 ) capacitor c=0.0302305f //x=49.665 //y=1.015
c1796 ( 115 0 ) capacitor c=0.14916f //x=49.58 //y=0.175
c1797 ( 114 0 ) capacitor c=0.0302305f //x=44.855 //y=1.015
c1798 ( 103 0 ) capacitor c=0.148704f //x=44.77 //y=0.175
c1799 ( 102 0 ) capacitor c=0.0302305f //x=40.045 //y=1.015
c1800 ( 91 0 ) capacitor c=0.149124f //x=39.96 //y=0.175
c1801 ( 90 0 ) capacitor c=0.0302305f //x=35.235 //y=1.015
c1802 ( 79 0 ) capacitor c=0.148636f //x=35.15 //y=0.175
c1803 ( 78 0 ) capacitor c=0.0302305f //x=30.425 //y=1.015
c1804 ( 67 0 ) capacitor c=0.150287f //x=30.34 //y=0.175
c1805 ( 66 0 ) capacitor c=0.0302305f //x=25.615 //y=1.015
c1806 ( 55 0 ) capacitor c=0.148588f //x=25.53 //y=0.175
c1807 ( 54 0 ) capacitor c=0.0302305f //x=20.805 //y=1.015
c1808 ( 43 0 ) capacitor c=0.14916f //x=20.72 //y=0.175
c1809 ( 42 0 ) capacitor c=0.0302305f //x=15.995 //y=1.015
c1810 ( 31 0 ) capacitor c=0.148704f //x=15.91 //y=0.175
c1811 ( 30 0 ) capacitor c=0.0302305f //x=11.185 //y=1.015
c1812 ( 19 0 ) capacitor c=0.149124f //x=11.1 //y=0.175
c1813 ( 18 0 ) capacitor c=0.0302305f //x=6.375 //y=1.015
c1814 ( 7 0 ) capacitor c=0.148598f //x=6.29 //y=0.175
c1815 ( 6 0 ) capacitor c=0.0302305f //x=1.565 //y=1.015
c1816 ( 2 0 ) capacitor c=0.0710427f //x=1.48 //y=0.175
r1817 (  662 664 ) resistor r=38.7139 //w=0.367 //l=1.11 //layer=li \
 //thickness=0.1 //x=95.21 //y=0.175 //x2=96.32 //y2=0.175
r1818 (  660 662 ) resistor r=38.7139 //w=0.367 //l=1.11 //layer=li \
 //thickness=0.1 //x=94.1 //y=0.175 //x2=95.21 //y2=0.175
r1819 (  658 691 ) resistor r=5.29055 //w=0.35 //l=0.17 //layer=li \
 //thickness=0.1 //x=93.9 //y=0.175 //x2=93.73 //y2=0.175
r1820 (  658 660 ) resistor r=6.97548 //w=0.367 //l=0.2 //layer=li \
 //thickness=0.1 //x=93.9 //y=0.175 //x2=94.1 //y2=0.175
r1821 (  652 654 ) resistor r=38.7139 //w=0.367 //l=1.11 //layer=li \
 //thickness=0.1 //x=91.51 //y=0.175 //x2=92.62 //y2=0.175
r1822 (  650 690 ) resistor r=5.29055 //w=0.35 //l=0.17 //layer=li \
 //thickness=0.1 //x=90.57 //y=0.175 //x2=90.4 //y2=0.175
r1823 (  650 652 ) resistor r=32.7847 //w=0.367 //l=0.94 //layer=li \
 //thickness=0.1 //x=90.57 //y=0.175 //x2=91.51 //y2=0.175
r1824 (  649 691 ) resistor r=5.29055 //w=0.35 //l=0.17 //layer=li \
 //thickness=0.1 //x=93.56 //y=0.175 //x2=93.73 //y2=0.175
r1825 (  649 654 ) resistor r=32.7847 //w=0.367 //l=0.94 //layer=li \
 //thickness=0.1 //x=93.56 //y=0.175 //x2=92.62 //y2=0.175
r1826 (  639 641 ) resistor r=38.7139 //w=0.367 //l=1.11 //layer=li \
 //thickness=0.1 //x=88.92 //y=0.175 //x2=90.03 //y2=0.175
r1827 (  637 639 ) resistor r=38.7139 //w=0.367 //l=1.11 //layer=li \
 //thickness=0.1 //x=87.81 //y=0.175 //x2=88.92 //y2=0.175
r1828 (  635 689 ) resistor r=5.29055 //w=0.35 //l=0.17 //layer=li \
 //thickness=0.1 //x=87.24 //y=0.175 //x2=87.07 //y2=0.175
r1829 (  635 637 ) resistor r=19.8801 //w=0.367 //l=0.57 //layer=li \
 //thickness=0.1 //x=87.24 //y=0.175 //x2=87.81 //y2=0.175
r1830 (  634 690 ) resistor r=5.29055 //w=0.35 //l=0.17 //layer=li \
 //thickness=0.1 //x=90.23 //y=0.175 //x2=90.4 //y2=0.175
r1831 (  634 641 ) resistor r=6.97548 //w=0.367 //l=0.2 //layer=li \
 //thickness=0.1 //x=90.23 //y=0.175 //x2=90.03 //y2=0.175
r1832 (  624 626 ) resistor r=38.7139 //w=0.367 //l=1.11 //layer=li \
 //thickness=0.1 //x=85.22 //y=0.175 //x2=86.33 //y2=0.175
r1833 (  622 624 ) resistor r=38.7139 //w=0.367 //l=1.11 //layer=li \
 //thickness=0.1 //x=84.11 //y=0.175 //x2=85.22 //y2=0.175
r1834 (  620 622 ) resistor r=38.7139 //w=0.367 //l=1.11 //layer=li \
 //thickness=0.1 //x=83 //y=0.175 //x2=84.11 //y2=0.175
r1835 (  618 688 ) resistor r=5.29055 //w=0.35 //l=0.17 //layer=li \
 //thickness=0.1 //x=82.43 //y=0.175 //x2=82.26 //y2=0.175
r1836 (  618 620 ) resistor r=19.8801 //w=0.367 //l=0.57 //layer=li \
 //thickness=0.1 //x=82.43 //y=0.175 //x2=83 //y2=0.175
r1837 (  617 689 ) resistor r=5.29055 //w=0.35 //l=0.17 //layer=li \
 //thickness=0.1 //x=86.9 //y=0.175 //x2=87.07 //y2=0.175
r1838 (  617 626 ) resistor r=19.8801 //w=0.367 //l=0.57 //layer=li \
 //thickness=0.1 //x=86.9 //y=0.175 //x2=86.33 //y2=0.175
r1839 (  607 609 ) resistor r=38.7139 //w=0.367 //l=1.11 //layer=li \
 //thickness=0.1 //x=80.41 //y=0.175 //x2=81.52 //y2=0.175
r1840 (  605 607 ) resistor r=38.7139 //w=0.367 //l=1.11 //layer=li \
 //thickness=0.1 //x=79.3 //y=0.175 //x2=80.41 //y2=0.175
r1841 (  603 605 ) resistor r=38.7139 //w=0.367 //l=1.11 //layer=li \
 //thickness=0.1 //x=78.19 //y=0.175 //x2=79.3 //y2=0.175
r1842 (  601 687 ) resistor r=5.29055 //w=0.35 //l=0.17 //layer=li \
 //thickness=0.1 //x=77.62 //y=0.175 //x2=77.45 //y2=0.175
r1843 (  601 603 ) resistor r=19.8801 //w=0.367 //l=0.57 //layer=li \
 //thickness=0.1 //x=77.62 //y=0.175 //x2=78.19 //y2=0.175
r1844 (  600 688 ) resistor r=5.29055 //w=0.35 //l=0.17 //layer=li \
 //thickness=0.1 //x=82.09 //y=0.175 //x2=82.26 //y2=0.175
r1845 (  600 609 ) resistor r=19.8801 //w=0.367 //l=0.57 //layer=li \
 //thickness=0.1 //x=82.09 //y=0.175 //x2=81.52 //y2=0.175
r1846 (  590 592 ) resistor r=38.7139 //w=0.367 //l=1.11 //layer=li \
 //thickness=0.1 //x=75.6 //y=0.175 //x2=76.71 //y2=0.175
r1847 (  588 590 ) resistor r=38.7139 //w=0.367 //l=1.11 //layer=li \
 //thickness=0.1 //x=74.49 //y=0.175 //x2=75.6 //y2=0.175
r1848 (  586 588 ) resistor r=38.7139 //w=0.367 //l=1.11 //layer=li \
 //thickness=0.1 //x=73.38 //y=0.175 //x2=74.49 //y2=0.175
r1849 (  584 686 ) resistor r=5.29055 //w=0.35 //l=0.17 //layer=li \
 //thickness=0.1 //x=72.81 //y=0.175 //x2=72.64 //y2=0.175
r1850 (  584 586 ) resistor r=19.8801 //w=0.367 //l=0.57 //layer=li \
 //thickness=0.1 //x=72.81 //y=0.175 //x2=73.38 //y2=0.175
r1851 (  583 687 ) resistor r=5.29055 //w=0.35 //l=0.17 //layer=li \
 //thickness=0.1 //x=77.28 //y=0.175 //x2=77.45 //y2=0.175
r1852 (  583 592 ) resistor r=19.8801 //w=0.367 //l=0.57 //layer=li \
 //thickness=0.1 //x=77.28 //y=0.175 //x2=76.71 //y2=0.175
r1853 (  573 575 ) resistor r=38.7139 //w=0.367 //l=1.11 //layer=li \
 //thickness=0.1 //x=70.79 //y=0.175 //x2=71.9 //y2=0.175
r1854 (  571 573 ) resistor r=38.7139 //w=0.367 //l=1.11 //layer=li \
 //thickness=0.1 //x=69.68 //y=0.175 //x2=70.79 //y2=0.175
r1855 (  569 571 ) resistor r=38.7139 //w=0.367 //l=1.11 //layer=li \
 //thickness=0.1 //x=68.57 //y=0.175 //x2=69.68 //y2=0.175
r1856 (  567 685 ) resistor r=5.29055 //w=0.35 //l=0.17 //layer=li \
 //thickness=0.1 //x=68 //y=0.175 //x2=67.83 //y2=0.175
r1857 (  567 569 ) resistor r=19.8801 //w=0.367 //l=0.57 //layer=li \
 //thickness=0.1 //x=68 //y=0.175 //x2=68.57 //y2=0.175
r1858 (  566 686 ) resistor r=5.29055 //w=0.35 //l=0.17 //layer=li \
 //thickness=0.1 //x=72.47 //y=0.175 //x2=72.64 //y2=0.175
r1859 (  566 575 ) resistor r=19.8801 //w=0.367 //l=0.57 //layer=li \
 //thickness=0.1 //x=72.47 //y=0.175 //x2=71.9 //y2=0.175
r1860 (  556 558 ) resistor r=38.7139 //w=0.367 //l=1.11 //layer=li \
 //thickness=0.1 //x=65.98 //y=0.175 //x2=67.09 //y2=0.175
r1861 (  554 556 ) resistor r=38.7139 //w=0.367 //l=1.11 //layer=li \
 //thickness=0.1 //x=64.87 //y=0.175 //x2=65.98 //y2=0.175
r1862 (  552 554 ) resistor r=38.7139 //w=0.367 //l=1.11 //layer=li \
 //thickness=0.1 //x=63.76 //y=0.175 //x2=64.87 //y2=0.175
r1863 (  550 684 ) resistor r=5.29055 //w=0.35 //l=0.17 //layer=li \
 //thickness=0.1 //x=63.19 //y=0.175 //x2=63.02 //y2=0.175
r1864 (  550 552 ) resistor r=19.8801 //w=0.367 //l=0.57 //layer=li \
 //thickness=0.1 //x=63.19 //y=0.175 //x2=63.76 //y2=0.175
r1865 (  549 685 ) resistor r=5.29055 //w=0.35 //l=0.17 //layer=li \
 //thickness=0.1 //x=67.66 //y=0.175 //x2=67.83 //y2=0.175
r1866 (  549 558 ) resistor r=19.8801 //w=0.367 //l=0.57 //layer=li \
 //thickness=0.1 //x=67.66 //y=0.175 //x2=67.09 //y2=0.175
r1867 (  539 541 ) resistor r=38.7139 //w=0.367 //l=1.11 //layer=li \
 //thickness=0.1 //x=61.17 //y=0.175 //x2=62.28 //y2=0.175
r1868 (  537 539 ) resistor r=38.7139 //w=0.367 //l=1.11 //layer=li \
 //thickness=0.1 //x=60.06 //y=0.175 //x2=61.17 //y2=0.175
r1869 (  535 537 ) resistor r=38.7139 //w=0.367 //l=1.11 //layer=li \
 //thickness=0.1 //x=58.95 //y=0.175 //x2=60.06 //y2=0.175
r1870 (  533 683 ) resistor r=5.29055 //w=0.35 //l=0.17 //layer=li \
 //thickness=0.1 //x=58.38 //y=0.175 //x2=58.21 //y2=0.175
r1871 (  533 535 ) resistor r=19.8801 //w=0.367 //l=0.57 //layer=li \
 //thickness=0.1 //x=58.38 //y=0.175 //x2=58.95 //y2=0.175
r1872 (  532 684 ) resistor r=5.29055 //w=0.35 //l=0.17 //layer=li \
 //thickness=0.1 //x=62.85 //y=0.175 //x2=63.02 //y2=0.175
r1873 (  532 541 ) resistor r=19.8801 //w=0.367 //l=0.57 //layer=li \
 //thickness=0.1 //x=62.85 //y=0.175 //x2=62.28 //y2=0.175
r1874 (  522 524 ) resistor r=38.7139 //w=0.367 //l=1.11 //layer=li \
 //thickness=0.1 //x=56.36 //y=0.175 //x2=57.47 //y2=0.175
r1875 (  520 522 ) resistor r=38.7139 //w=0.367 //l=1.11 //layer=li \
 //thickness=0.1 //x=55.25 //y=0.175 //x2=56.36 //y2=0.175
r1876 (  518 520 ) resistor r=38.7139 //w=0.367 //l=1.11 //layer=li \
 //thickness=0.1 //x=54.14 //y=0.175 //x2=55.25 //y2=0.175
r1877 (  516 682 ) resistor r=5.29055 //w=0.35 //l=0.17 //layer=li \
 //thickness=0.1 //x=53.57 //y=0.175 //x2=53.4 //y2=0.175
r1878 (  516 518 ) resistor r=19.8801 //w=0.367 //l=0.57 //layer=li \
 //thickness=0.1 //x=53.57 //y=0.175 //x2=54.14 //y2=0.175
r1879 (  515 683 ) resistor r=5.29055 //w=0.35 //l=0.17 //layer=li \
 //thickness=0.1 //x=58.04 //y=0.175 //x2=58.21 //y2=0.175
r1880 (  515 524 ) resistor r=19.8801 //w=0.367 //l=0.57 //layer=li \
 //thickness=0.1 //x=58.04 //y=0.175 //x2=57.47 //y2=0.175
r1881 (  505 507 ) resistor r=38.7139 //w=0.367 //l=1.11 //layer=li \
 //thickness=0.1 //x=51.55 //y=0.175 //x2=52.66 //y2=0.175
r1882 (  503 505 ) resistor r=38.7139 //w=0.367 //l=1.11 //layer=li \
 //thickness=0.1 //x=50.44 //y=0.175 //x2=51.55 //y2=0.175
r1883 (  501 503 ) resistor r=38.7139 //w=0.367 //l=1.11 //layer=li \
 //thickness=0.1 //x=49.33 //y=0.175 //x2=50.44 //y2=0.175
r1884 (  499 681 ) resistor r=5.29055 //w=0.35 //l=0.17 //layer=li \
 //thickness=0.1 //x=48.76 //y=0.175 //x2=48.59 //y2=0.175
r1885 (  499 501 ) resistor r=19.8801 //w=0.367 //l=0.57 //layer=li \
 //thickness=0.1 //x=48.76 //y=0.175 //x2=49.33 //y2=0.175
r1886 (  498 682 ) resistor r=5.29055 //w=0.35 //l=0.17 //layer=li \
 //thickness=0.1 //x=53.23 //y=0.175 //x2=53.4 //y2=0.175
r1887 (  498 507 ) resistor r=19.8801 //w=0.367 //l=0.57 //layer=li \
 //thickness=0.1 //x=53.23 //y=0.175 //x2=52.66 //y2=0.175
r1888 (  488 490 ) resistor r=38.7139 //w=0.367 //l=1.11 //layer=li \
 //thickness=0.1 //x=46.74 //y=0.175 //x2=47.85 //y2=0.175
r1889 (  486 488 ) resistor r=38.7139 //w=0.367 //l=1.11 //layer=li \
 //thickness=0.1 //x=45.63 //y=0.175 //x2=46.74 //y2=0.175
r1890 (  484 486 ) resistor r=38.7139 //w=0.367 //l=1.11 //layer=li \
 //thickness=0.1 //x=44.52 //y=0.175 //x2=45.63 //y2=0.175
r1891 (  482 680 ) resistor r=5.29055 //w=0.35 //l=0.17 //layer=li \
 //thickness=0.1 //x=43.95 //y=0.175 //x2=43.78 //y2=0.175
r1892 (  482 484 ) resistor r=19.8801 //w=0.367 //l=0.57 //layer=li \
 //thickness=0.1 //x=43.95 //y=0.175 //x2=44.52 //y2=0.175
r1893 (  481 681 ) resistor r=5.29055 //w=0.35 //l=0.17 //layer=li \
 //thickness=0.1 //x=48.42 //y=0.175 //x2=48.59 //y2=0.175
r1894 (  481 490 ) resistor r=19.8801 //w=0.367 //l=0.57 //layer=li \
 //thickness=0.1 //x=48.42 //y=0.175 //x2=47.85 //y2=0.175
r1895 (  471 473 ) resistor r=38.7139 //w=0.367 //l=1.11 //layer=li \
 //thickness=0.1 //x=41.93 //y=0.175 //x2=43.04 //y2=0.175
r1896 (  469 471 ) resistor r=38.7139 //w=0.367 //l=1.11 //layer=li \
 //thickness=0.1 //x=40.82 //y=0.175 //x2=41.93 //y2=0.175
r1897 (  467 469 ) resistor r=38.7139 //w=0.367 //l=1.11 //layer=li \
 //thickness=0.1 //x=39.71 //y=0.175 //x2=40.82 //y2=0.175
r1898 (  465 679 ) resistor r=5.29055 //w=0.35 //l=0.17 //layer=li \
 //thickness=0.1 //x=39.14 //y=0.175 //x2=38.97 //y2=0.175
r1899 (  465 467 ) resistor r=19.8801 //w=0.367 //l=0.57 //layer=li \
 //thickness=0.1 //x=39.14 //y=0.175 //x2=39.71 //y2=0.175
r1900 (  464 680 ) resistor r=5.29055 //w=0.35 //l=0.17 //layer=li \
 //thickness=0.1 //x=43.61 //y=0.175 //x2=43.78 //y2=0.175
r1901 (  464 473 ) resistor r=19.8801 //w=0.367 //l=0.57 //layer=li \
 //thickness=0.1 //x=43.61 //y=0.175 //x2=43.04 //y2=0.175
r1902 (  454 456 ) resistor r=38.7139 //w=0.367 //l=1.11 //layer=li \
 //thickness=0.1 //x=37.12 //y=0.175 //x2=38.23 //y2=0.175
r1903 (  452 454 ) resistor r=38.7139 //w=0.367 //l=1.11 //layer=li \
 //thickness=0.1 //x=36.01 //y=0.175 //x2=37.12 //y2=0.175
r1904 (  450 452 ) resistor r=38.7139 //w=0.367 //l=1.11 //layer=li \
 //thickness=0.1 //x=34.9 //y=0.175 //x2=36.01 //y2=0.175
r1905 (  448 678 ) resistor r=5.29055 //w=0.35 //l=0.17 //layer=li \
 //thickness=0.1 //x=34.33 //y=0.175 //x2=34.16 //y2=0.175
r1906 (  448 450 ) resistor r=19.8801 //w=0.367 //l=0.57 //layer=li \
 //thickness=0.1 //x=34.33 //y=0.175 //x2=34.9 //y2=0.175
r1907 (  447 679 ) resistor r=5.29055 //w=0.35 //l=0.17 //layer=li \
 //thickness=0.1 //x=38.8 //y=0.175 //x2=38.97 //y2=0.175
r1908 (  447 456 ) resistor r=19.8801 //w=0.367 //l=0.57 //layer=li \
 //thickness=0.1 //x=38.8 //y=0.175 //x2=38.23 //y2=0.175
r1909 (  437 439 ) resistor r=38.7139 //w=0.367 //l=1.11 //layer=li \
 //thickness=0.1 //x=32.31 //y=0.175 //x2=33.42 //y2=0.175
r1910 (  435 437 ) resistor r=38.7139 //w=0.367 //l=1.11 //layer=li \
 //thickness=0.1 //x=31.2 //y=0.175 //x2=32.31 //y2=0.175
r1911 (  433 435 ) resistor r=38.7139 //w=0.367 //l=1.11 //layer=li \
 //thickness=0.1 //x=30.09 //y=0.175 //x2=31.2 //y2=0.175
r1912 (  431 677 ) resistor r=5.29055 //w=0.35 //l=0.17 //layer=li \
 //thickness=0.1 //x=29.52 //y=0.175 //x2=29.35 //y2=0.175
r1913 (  431 433 ) resistor r=19.8801 //w=0.367 //l=0.57 //layer=li \
 //thickness=0.1 //x=29.52 //y=0.175 //x2=30.09 //y2=0.175
r1914 (  430 678 ) resistor r=5.29055 //w=0.35 //l=0.17 //layer=li \
 //thickness=0.1 //x=33.99 //y=0.175 //x2=34.16 //y2=0.175
r1915 (  430 439 ) resistor r=19.8801 //w=0.367 //l=0.57 //layer=li \
 //thickness=0.1 //x=33.99 //y=0.175 //x2=33.42 //y2=0.175
r1916 (  420 422 ) resistor r=38.7139 //w=0.367 //l=1.11 //layer=li \
 //thickness=0.1 //x=27.5 //y=0.175 //x2=28.61 //y2=0.175
r1917 (  418 420 ) resistor r=38.7139 //w=0.367 //l=1.11 //layer=li \
 //thickness=0.1 //x=26.39 //y=0.175 //x2=27.5 //y2=0.175
r1918 (  416 418 ) resistor r=38.7139 //w=0.367 //l=1.11 //layer=li \
 //thickness=0.1 //x=25.28 //y=0.175 //x2=26.39 //y2=0.175
r1919 (  414 676 ) resistor r=5.29055 //w=0.35 //l=0.17 //layer=li \
 //thickness=0.1 //x=24.71 //y=0.175 //x2=24.54 //y2=0.175
r1920 (  414 416 ) resistor r=19.8801 //w=0.367 //l=0.57 //layer=li \
 //thickness=0.1 //x=24.71 //y=0.175 //x2=25.28 //y2=0.175
r1921 (  413 677 ) resistor r=5.29055 //w=0.35 //l=0.17 //layer=li \
 //thickness=0.1 //x=29.18 //y=0.175 //x2=29.35 //y2=0.175
r1922 (  413 422 ) resistor r=19.8801 //w=0.367 //l=0.57 //layer=li \
 //thickness=0.1 //x=29.18 //y=0.175 //x2=28.61 //y2=0.175
r1923 (  403 405 ) resistor r=38.7139 //w=0.367 //l=1.11 //layer=li \
 //thickness=0.1 //x=22.69 //y=0.175 //x2=23.8 //y2=0.175
r1924 (  401 403 ) resistor r=38.7139 //w=0.367 //l=1.11 //layer=li \
 //thickness=0.1 //x=21.58 //y=0.175 //x2=22.69 //y2=0.175
r1925 (  399 401 ) resistor r=38.7139 //w=0.367 //l=1.11 //layer=li \
 //thickness=0.1 //x=20.47 //y=0.175 //x2=21.58 //y2=0.175
r1926 (  397 675 ) resistor r=5.29055 //w=0.35 //l=0.17 //layer=li \
 //thickness=0.1 //x=19.9 //y=0.175 //x2=19.73 //y2=0.175
r1927 (  397 399 ) resistor r=19.8801 //w=0.367 //l=0.57 //layer=li \
 //thickness=0.1 //x=19.9 //y=0.175 //x2=20.47 //y2=0.175
r1928 (  396 676 ) resistor r=5.29055 //w=0.35 //l=0.17 //layer=li \
 //thickness=0.1 //x=24.37 //y=0.175 //x2=24.54 //y2=0.175
r1929 (  396 405 ) resistor r=19.8801 //w=0.367 //l=0.57 //layer=li \
 //thickness=0.1 //x=24.37 //y=0.175 //x2=23.8 //y2=0.175
r1930 (  386 388 ) resistor r=38.7139 //w=0.367 //l=1.11 //layer=li \
 //thickness=0.1 //x=17.88 //y=0.175 //x2=18.99 //y2=0.175
r1931 (  384 386 ) resistor r=38.7139 //w=0.367 //l=1.11 //layer=li \
 //thickness=0.1 //x=16.77 //y=0.175 //x2=17.88 //y2=0.175
r1932 (  382 384 ) resistor r=38.7139 //w=0.367 //l=1.11 //layer=li \
 //thickness=0.1 //x=15.66 //y=0.175 //x2=16.77 //y2=0.175
r1933 (  380 674 ) resistor r=5.29055 //w=0.35 //l=0.17 //layer=li \
 //thickness=0.1 //x=15.09 //y=0.175 //x2=14.92 //y2=0.175
r1934 (  380 382 ) resistor r=19.8801 //w=0.367 //l=0.57 //layer=li \
 //thickness=0.1 //x=15.09 //y=0.175 //x2=15.66 //y2=0.175
r1935 (  379 675 ) resistor r=5.29055 //w=0.35 //l=0.17 //layer=li \
 //thickness=0.1 //x=19.56 //y=0.175 //x2=19.73 //y2=0.175
r1936 (  379 388 ) resistor r=19.8801 //w=0.367 //l=0.57 //layer=li \
 //thickness=0.1 //x=19.56 //y=0.175 //x2=18.99 //y2=0.175
r1937 (  369 371 ) resistor r=38.7139 //w=0.367 //l=1.11 //layer=li \
 //thickness=0.1 //x=13.07 //y=0.175 //x2=14.18 //y2=0.175
r1938 (  367 369 ) resistor r=38.7139 //w=0.367 //l=1.11 //layer=li \
 //thickness=0.1 //x=11.96 //y=0.175 //x2=13.07 //y2=0.175
r1939 (  365 367 ) resistor r=38.7139 //w=0.367 //l=1.11 //layer=li \
 //thickness=0.1 //x=10.85 //y=0.175 //x2=11.96 //y2=0.175
r1940 (  363 673 ) resistor r=5.29055 //w=0.35 //l=0.17 //layer=li \
 //thickness=0.1 //x=10.28 //y=0.175 //x2=10.11 //y2=0.175
r1941 (  363 365 ) resistor r=19.8801 //w=0.367 //l=0.57 //layer=li \
 //thickness=0.1 //x=10.28 //y=0.175 //x2=10.85 //y2=0.175
r1942 (  362 674 ) resistor r=5.29055 //w=0.35 //l=0.17 //layer=li \
 //thickness=0.1 //x=14.75 //y=0.175 //x2=14.92 //y2=0.175
r1943 (  362 371 ) resistor r=19.8801 //w=0.367 //l=0.57 //layer=li \
 //thickness=0.1 //x=14.75 //y=0.175 //x2=14.18 //y2=0.175
r1944 (  352 354 ) resistor r=38.7139 //w=0.367 //l=1.11 //layer=li \
 //thickness=0.1 //x=8.26 //y=0.175 //x2=9.37 //y2=0.175
r1945 (  350 352 ) resistor r=38.7139 //w=0.367 //l=1.11 //layer=li \
 //thickness=0.1 //x=7.15 //y=0.175 //x2=8.26 //y2=0.175
r1946 (  348 350 ) resistor r=38.7139 //w=0.367 //l=1.11 //layer=li \
 //thickness=0.1 //x=6.04 //y=0.175 //x2=7.15 //y2=0.175
r1947 (  346 672 ) resistor r=5.29055 //w=0.35 //l=0.17 //layer=li \
 //thickness=0.1 //x=5.47 //y=0.175 //x2=5.3 //y2=0.175
r1948 (  346 348 ) resistor r=19.8801 //w=0.367 //l=0.57 //layer=li \
 //thickness=0.1 //x=5.47 //y=0.175 //x2=6.04 //y2=0.175
r1949 (  345 673 ) resistor r=5.29055 //w=0.35 //l=0.17 //layer=li \
 //thickness=0.1 //x=9.94 //y=0.175 //x2=10.11 //y2=0.175
r1950 (  345 354 ) resistor r=19.8801 //w=0.367 //l=0.57 //layer=li \
 //thickness=0.1 //x=9.94 //y=0.175 //x2=9.37 //y2=0.175
r1951 (  335 337 ) resistor r=38.7139 //w=0.367 //l=1.11 //layer=li \
 //thickness=0.1 //x=3.45 //y=0.175 //x2=4.56 //y2=0.175
r1952 (  333 335 ) resistor r=38.7139 //w=0.367 //l=1.11 //layer=li \
 //thickness=0.1 //x=2.34 //y=0.175 //x2=3.45 //y2=0.175
r1953 (  331 333 ) resistor r=38.7139 //w=0.367 //l=1.11 //layer=li \
 //thickness=0.1 //x=1.23 //y=0.175 //x2=2.34 //y2=0.175
r1954 (  328 672 ) resistor r=5.29055 //w=0.35 //l=0.17 //layer=li \
 //thickness=0.1 //x=5.13 //y=0.175 //x2=5.3 //y2=0.175
r1955 (  328 337 ) resistor r=19.8801 //w=0.367 //l=0.57 //layer=li \
 //thickness=0.1 //x=5.13 //y=0.175 //x2=4.56 //y2=0.175
r1956 (  325 711 ) resistor r=9.3 //w=0.17 //l=0.17 //layer=mcon //count=1 \
 //x=94.91 //y=1.135 //x2=94.91 //y2=1.135
r1957 (  322 652 ) resistor r=3.1 //w=0.17 //l=0.51 //layer=mcon //count=3 \
 //x=91.51 //y=0.18 //x2=91.51 //y2=0.18
r1958 (  320 710 ) resistor r=9.3 //w=0.17 //l=0.17 //layer=mcon //count=1 \
 //x=88.25 //y=1.135 //x2=88.25 //y2=1.135
r1959 (  315 709 ) resistor r=9.3 //w=0.17 //l=0.17 //layer=mcon //count=1 \
 //x=83.335 //y=1.145 //x2=83.335 //y2=1.145
r1960 (  311 708 ) resistor r=9.3 //w=0.17 //l=0.17 //layer=mcon //count=1 \
 //x=78.525 //y=1.145 //x2=78.525 //y2=1.145
r1961 (  307 707 ) resistor r=9.3 //w=0.17 //l=0.17 //layer=mcon //count=1 \
 //x=73.715 //y=1.145 //x2=73.715 //y2=1.145
r1962 (  303 706 ) resistor r=9.3 //w=0.17 //l=0.17 //layer=mcon //count=1 \
 //x=68.905 //y=1.145 //x2=68.905 //y2=1.145
r1963 (  299 705 ) resistor r=9.3 //w=0.17 //l=0.17 //layer=mcon //count=1 \
 //x=64.095 //y=1.145 //x2=64.095 //y2=1.145
r1964 (  295 704 ) resistor r=9.3 //w=0.17 //l=0.17 //layer=mcon //count=1 \
 //x=59.285 //y=1.145 //x2=59.285 //y2=1.145
r1965 (  291 703 ) resistor r=9.3 //w=0.17 //l=0.17 //layer=mcon //count=1 \
 //x=54.475 //y=1.145 //x2=54.475 //y2=1.145
r1966 (  287 702 ) resistor r=9.3 //w=0.17 //l=0.17 //layer=mcon //count=1 \
 //x=49.665 //y=1.145 //x2=49.665 //y2=1.145
r1967 (  283 701 ) resistor r=9.3 //w=0.17 //l=0.17 //layer=mcon //count=1 \
 //x=44.855 //y=1.145 //x2=44.855 //y2=1.145
r1968 (  279 700 ) resistor r=9.3 //w=0.17 //l=0.17 //layer=mcon //count=1 \
 //x=40.045 //y=1.145 //x2=40.045 //y2=1.145
r1969 (  275 699 ) resistor r=9.3 //w=0.17 //l=0.17 //layer=mcon //count=1 \
 //x=35.235 //y=1.145 //x2=35.235 //y2=1.145
r1970 (  271 698 ) resistor r=9.3 //w=0.17 //l=0.17 //layer=mcon //count=1 \
 //x=30.425 //y=1.145 //x2=30.425 //y2=1.145
r1971 (  267 697 ) resistor r=9.3 //w=0.17 //l=0.17 //layer=mcon //count=1 \
 //x=25.615 //y=1.145 //x2=25.615 //y2=1.145
r1972 (  263 696 ) resistor r=9.3 //w=0.17 //l=0.17 //layer=mcon //count=1 \
 //x=20.805 //y=1.145 //x2=20.805 //y2=1.145
r1973 (  259 695 ) resistor r=9.3 //w=0.17 //l=0.17 //layer=mcon //count=1 \
 //x=15.995 //y=1.145 //x2=15.995 //y2=1.145
r1974 (  255 694 ) resistor r=9.3 //w=0.17 //l=0.17 //layer=mcon //count=1 \
 //x=11.185 //y=1.145 //x2=11.185 //y2=1.145
r1975 (  251 693 ) resistor r=9.3 //w=0.17 //l=0.17 //layer=mcon //count=1 \
 //x=6.375 //y=1.145 //x2=6.375 //y2=1.145
r1976 (  247 692 ) resistor r=9.3 //w=0.17 //l=0.17 //layer=mcon //count=1 \
 //x=1.565 //y=1.145 //x2=1.565 //y2=1.145
r1977 (  244 664 ) resistor r=3.1 //w=0.17 //l=0.51 //layer=mcon //count=3 \
 //x=96.32 //y=0.18 //x2=96.32 //y2=0.18
r1978 (  242 662 ) resistor r=3.1 //w=0.17 //l=0.51 //layer=mcon //count=3 \
 //x=95.21 //y=0.18 //x2=95.21 //y2=0.18
r1979 (  242 244 ) resistor r=0.446141 //w=0.311 //l=1.11 //layer=m1 \
 //thickness=0.36 //x=95.21 //y=0.175 //x2=96.32 //y2=0.175
r1980 (  240 323 ) resistor r=0.028033 //w=0.35 //l=0.085 //layer=m1 \
 //thickness=0.36 //x=94.995 //y=0.175 //x2=94.91 //y2=0.175
r1981 (  240 242 ) resistor r=0.0864148 //w=0.311 //l=0.215 //layer=m1 \
 //thickness=0.36 //x=94.995 //y=0.175 //x2=95.21 //y2=0.175
r1982 (  239 325 ) resistor r=0.0703067 //w=0.254 //l=0.11649 //layer=m1 \
 //thickness=0.36 //x=94.91 //y=1.02 //x2=94.907 //y2=1.135
r1983 (  238 323 ) resistor r=0.0413265 //w=0.7 //l=0.175 //layer=m1 \
 //thickness=0.36 //x=94.91 //y=0.35 //x2=94.91 //y2=0.175
r1984 (  238 239 ) resistor r=0.639313 //w=0.131 //l=0.67 //layer=m1 \
 //thickness=0.36 //x=94.91 //y=0.35 //x2=94.91 //y2=1.02
r1985 (  237 660 ) resistor r=3.1 //w=0.17 //l=0.51 //layer=mcon //count=3 \
 //x=94.1 //y=0.18 //x2=94.1 //y2=0.18
r1986 (  235 654 ) resistor r=3.1 //w=0.17 //l=0.51 //layer=mcon //count=3 \
 //x=92.62 //y=0.18 //x2=92.62 //y2=0.18
r1987 (  235 237 ) resistor r=0.594855 //w=0.311 //l=1.48 //layer=m1 \
 //thickness=0.36 //x=92.62 //y=0.175 //x2=94.1 //y2=0.175
r1988 (  233 322 ) resistor r=0.028033 //w=0.35 //l=0.085 //layer=m1 \
 //thickness=0.36 //x=91.665 //y=0.175 //x2=91.58 //y2=0.175
r1989 (  233 235 ) resistor r=0.383842 //w=0.311 //l=0.955 //layer=m1 \
 //thickness=0.36 //x=91.665 //y=0.175 //x2=92.62 //y2=0.175
r1990 (  232 323 ) resistor r=0.028033 //w=0.35 //l=0.085 //layer=m1 \
 //thickness=0.36 //x=94.825 //y=0.175 //x2=94.91 //y2=0.175
r1991 (  232 237 ) resistor r=0.291399 //w=0.311 //l=0.725 //layer=m1 \
 //thickness=0.36 //x=94.825 //y=0.175 //x2=94.1 //y2=0.175
r1992 (  229 641 ) resistor r=3.1 //w=0.17 //l=0.51 //layer=mcon //count=3 \
 //x=90.03 //y=0.18 //x2=90.03 //y2=0.18
r1993 (  227 639 ) resistor r=3.1 //w=0.17 //l=0.51 //layer=mcon //count=3 \
 //x=88.92 //y=0.18 //x2=88.92 //y2=0.18
r1994 (  227 229 ) resistor r=0.446141 //w=0.311 //l=1.11 //layer=m1 \
 //thickness=0.36 //x=88.92 //y=0.175 //x2=90.03 //y2=0.175
r1995 (  225 318 ) resistor r=0.028033 //w=0.35 //l=0.085 //layer=m1 \
 //thickness=0.36 //x=88.335 //y=0.175 //x2=88.25 //y2=0.175
r1996 (  225 227 ) resistor r=0.235129 //w=0.311 //l=0.585 //layer=m1 \
 //thickness=0.36 //x=88.335 //y=0.175 //x2=88.92 //y2=0.175
r1997 (  224 322 ) resistor r=0.028033 //w=0.35 //l=0.085 //layer=m1 \
 //thickness=0.36 //x=91.495 //y=0.175 //x2=91.58 //y2=0.175
r1998 (  224 229 ) resistor r=0.588826 //w=0.311 //l=1.465 //layer=m1 \
 //thickness=0.36 //x=91.495 //y=0.175 //x2=90.03 //y2=0.175
r1999 (  223 320 ) resistor r=0.0729089 //w=0.249 //l=0.120996 //layer=m1 \
 //thickness=0.36 //x=88.25 //y=1.015 //x2=88.252 //y2=1.135
r2000 (  222 318 ) resistor r=0.0413265 //w=0.7 //l=0.175 //layer=m1 \
 //thickness=0.36 //x=88.25 //y=0.35 //x2=88.25 //y2=0.175
r2001 (  222 223 ) resistor r=0.634542 //w=0.131 //l=0.665 //layer=m1 \
 //thickness=0.36 //x=88.25 //y=0.35 //x2=88.25 //y2=1.015
r2002 (  221 637 ) resistor r=3.1 //w=0.17 //l=0.51 //layer=mcon //count=3 \
 //x=87.81 //y=0.18 //x2=87.81 //y2=0.18
r2003 (  219 626 ) resistor r=3.1 //w=0.17 //l=0.51 //layer=mcon //count=3 \
 //x=86.33 //y=0.18 //x2=86.33 //y2=0.18
r2004 (  219 221 ) resistor r=0.594855 //w=0.311 //l=1.48 //layer=m1 \
 //thickness=0.36 //x=86.33 //y=0.175 //x2=87.81 //y2=0.175
r2005 (  217 624 ) resistor r=3.1 //w=0.17 //l=0.51 //layer=mcon //count=3 \
 //x=85.22 //y=0.18 //x2=85.22 //y2=0.18
r2006 (  217 219 ) resistor r=0.446141 //w=0.311 //l=1.11 //layer=m1 \
 //thickness=0.36 //x=85.22 //y=0.175 //x2=86.33 //y2=0.175
r2007 (  215 622 ) resistor r=3.1 //w=0.17 //l=0.51 //layer=mcon //count=3 \
 //x=84.11 //y=0.18 //x2=84.11 //y2=0.18
r2008 (  215 217 ) resistor r=0.446141 //w=0.311 //l=1.11 //layer=m1 \
 //thickness=0.36 //x=84.11 //y=0.175 //x2=85.22 //y2=0.175
r2009 (  213 317 ) resistor r=0.028033 //w=0.35 //l=0.085 //layer=m1 \
 //thickness=0.36 //x=83.42 //y=0.175 //x2=83.335 //y2=0.175
r2010 (  213 215 ) resistor r=0.277331 //w=0.311 //l=0.69 //layer=m1 \
 //thickness=0.36 //x=83.42 //y=0.175 //x2=84.11 //y2=0.175
r2011 (  212 318 ) resistor r=0.028033 //w=0.35 //l=0.085 //layer=m1 \
 //thickness=0.36 //x=88.165 //y=0.175 //x2=88.25 //y2=0.175
r2012 (  212 221 ) resistor r=0.142685 //w=0.311 //l=0.355 //layer=m1 \
 //thickness=0.36 //x=88.165 //y=0.175 //x2=87.81 //y2=0.175
r2013 (  211 315 ) resistor r=0.0942778 //w=0.221 //l=0.13 //layer=m1 \
 //thickness=0.36 //x=83.335 //y=1.015 //x2=83.335 //y2=1.145
r2014 (  210 317 ) resistor r=0.0413265 //w=0.7 //l=0.175 //layer=m1 \
 //thickness=0.36 //x=83.335 //y=0.35 //x2=83.335 //y2=0.175
r2015 (  210 211 ) resistor r=0.634542 //w=0.131 //l=0.665 //layer=m1 \
 //thickness=0.36 //x=83.335 //y=0.35 //x2=83.335 //y2=1.015
r2016 (  209 620 ) resistor r=3.1 //w=0.17 //l=0.51 //layer=mcon //count=3 \
 //x=83 //y=0.18 //x2=83 //y2=0.18
r2017 (  207 609 ) resistor r=3.1 //w=0.17 //l=0.51 //layer=mcon //count=3 \
 //x=81.52 //y=0.18 //x2=81.52 //y2=0.18
r2018 (  207 209 ) resistor r=0.594855 //w=0.311 //l=1.48 //layer=m1 \
 //thickness=0.36 //x=81.52 //y=0.175 //x2=83 //y2=0.175
r2019 (  205 607 ) resistor r=3.1 //w=0.17 //l=0.51 //layer=mcon //count=3 \
 //x=80.41 //y=0.18 //x2=80.41 //y2=0.18
r2020 (  205 207 ) resistor r=0.446141 //w=0.311 //l=1.11 //layer=m1 \
 //thickness=0.36 //x=80.41 //y=0.175 //x2=81.52 //y2=0.175
r2021 (  203 605 ) resistor r=3.1 //w=0.17 //l=0.51 //layer=mcon //count=3 \
 //x=79.3 //y=0.18 //x2=79.3 //y2=0.18
r2022 (  203 205 ) resistor r=0.446141 //w=0.311 //l=1.11 //layer=m1 \
 //thickness=0.36 //x=79.3 //y=0.175 //x2=80.41 //y2=0.175
r2023 (  201 313 ) resistor r=0.028033 //w=0.35 //l=0.085 //layer=m1 \
 //thickness=0.36 //x=78.61 //y=0.175 //x2=78.525 //y2=0.175
r2024 (  201 203 ) resistor r=0.277331 //w=0.311 //l=0.69 //layer=m1 \
 //thickness=0.36 //x=78.61 //y=0.175 //x2=79.3 //y2=0.175
r2025 (  200 317 ) resistor r=0.028033 //w=0.35 //l=0.085 //layer=m1 \
 //thickness=0.36 //x=83.25 //y=0.175 //x2=83.335 //y2=0.175
r2026 (  200 209 ) resistor r=0.100482 //w=0.311 //l=0.25 //layer=m1 \
 //thickness=0.36 //x=83.25 //y=0.175 //x2=83 //y2=0.175
r2027 (  199 311 ) resistor r=0.0942778 //w=0.221 //l=0.13 //layer=m1 \
 //thickness=0.36 //x=78.525 //y=1.015 //x2=78.525 //y2=1.145
r2028 (  198 313 ) resistor r=0.0413265 //w=0.7 //l=0.175 //layer=m1 \
 //thickness=0.36 //x=78.525 //y=0.35 //x2=78.525 //y2=0.175
r2029 (  198 199 ) resistor r=0.634542 //w=0.131 //l=0.665 //layer=m1 \
 //thickness=0.36 //x=78.525 //y=0.35 //x2=78.525 //y2=1.015
r2030 (  197 603 ) resistor r=3.1 //w=0.17 //l=0.51 //layer=mcon //count=3 \
 //x=78.19 //y=0.18 //x2=78.19 //y2=0.18
r2031 (  195 592 ) resistor r=3.1 //w=0.17 //l=0.51 //layer=mcon //count=3 \
 //x=76.71 //y=0.18 //x2=76.71 //y2=0.18
r2032 (  195 197 ) resistor r=0.594855 //w=0.311 //l=1.48 //layer=m1 \
 //thickness=0.36 //x=76.71 //y=0.175 //x2=78.19 //y2=0.175
r2033 (  193 590 ) resistor r=3.1 //w=0.17 //l=0.51 //layer=mcon //count=3 \
 //x=75.6 //y=0.18 //x2=75.6 //y2=0.18
r2034 (  193 195 ) resistor r=0.446141 //w=0.311 //l=1.11 //layer=m1 \
 //thickness=0.36 //x=75.6 //y=0.175 //x2=76.71 //y2=0.175
r2035 (  191 588 ) resistor r=3.1 //w=0.17 //l=0.51 //layer=mcon //count=3 \
 //x=74.49 //y=0.18 //x2=74.49 //y2=0.18
r2036 (  191 193 ) resistor r=0.446141 //w=0.311 //l=1.11 //layer=m1 \
 //thickness=0.36 //x=74.49 //y=0.175 //x2=75.6 //y2=0.175
r2037 (  189 309 ) resistor r=0.028033 //w=0.35 //l=0.085 //layer=m1 \
 //thickness=0.36 //x=73.8 //y=0.175 //x2=73.715 //y2=0.175
r2038 (  189 191 ) resistor r=0.277331 //w=0.311 //l=0.69 //layer=m1 \
 //thickness=0.36 //x=73.8 //y=0.175 //x2=74.49 //y2=0.175
r2039 (  188 313 ) resistor r=0.028033 //w=0.35 //l=0.085 //layer=m1 \
 //thickness=0.36 //x=78.44 //y=0.175 //x2=78.525 //y2=0.175
r2040 (  188 197 ) resistor r=0.100482 //w=0.311 //l=0.25 //layer=m1 \
 //thickness=0.36 //x=78.44 //y=0.175 //x2=78.19 //y2=0.175
r2041 (  187 307 ) resistor r=0.0942778 //w=0.221 //l=0.13 //layer=m1 \
 //thickness=0.36 //x=73.715 //y=1.015 //x2=73.715 //y2=1.145
r2042 (  186 309 ) resistor r=0.0413265 //w=0.7 //l=0.175 //layer=m1 \
 //thickness=0.36 //x=73.715 //y=0.35 //x2=73.715 //y2=0.175
r2043 (  186 187 ) resistor r=0.634542 //w=0.131 //l=0.665 //layer=m1 \
 //thickness=0.36 //x=73.715 //y=0.35 //x2=73.715 //y2=1.015
r2044 (  185 586 ) resistor r=3.1 //w=0.17 //l=0.51 //layer=mcon //count=3 \
 //x=73.38 //y=0.18 //x2=73.38 //y2=0.18
r2045 (  183 575 ) resistor r=3.1 //w=0.17 //l=0.51 //layer=mcon //count=3 \
 //x=71.9 //y=0.18 //x2=71.9 //y2=0.18
r2046 (  183 185 ) resistor r=0.594855 //w=0.311 //l=1.48 //layer=m1 \
 //thickness=0.36 //x=71.9 //y=0.175 //x2=73.38 //y2=0.175
r2047 (  181 573 ) resistor r=3.1 //w=0.17 //l=0.51 //layer=mcon //count=3 \
 //x=70.79 //y=0.18 //x2=70.79 //y2=0.18
r2048 (  181 183 ) resistor r=0.446141 //w=0.311 //l=1.11 //layer=m1 \
 //thickness=0.36 //x=70.79 //y=0.175 //x2=71.9 //y2=0.175
r2049 (  179 571 ) resistor r=3.1 //w=0.17 //l=0.51 //layer=mcon //count=3 \
 //x=69.68 //y=0.18 //x2=69.68 //y2=0.18
r2050 (  179 181 ) resistor r=0.446141 //w=0.311 //l=1.11 //layer=m1 \
 //thickness=0.36 //x=69.68 //y=0.175 //x2=70.79 //y2=0.175
r2051 (  177 305 ) resistor r=0.028033 //w=0.35 //l=0.085 //layer=m1 \
 //thickness=0.36 //x=68.99 //y=0.175 //x2=68.905 //y2=0.175
r2052 (  177 179 ) resistor r=0.277331 //w=0.311 //l=0.69 //layer=m1 \
 //thickness=0.36 //x=68.99 //y=0.175 //x2=69.68 //y2=0.175
r2053 (  176 309 ) resistor r=0.028033 //w=0.35 //l=0.085 //layer=m1 \
 //thickness=0.36 //x=73.63 //y=0.175 //x2=73.715 //y2=0.175
r2054 (  176 185 ) resistor r=0.100482 //w=0.311 //l=0.25 //layer=m1 \
 //thickness=0.36 //x=73.63 //y=0.175 //x2=73.38 //y2=0.175
r2055 (  175 303 ) resistor r=0.0942778 //w=0.221 //l=0.13 //layer=m1 \
 //thickness=0.36 //x=68.905 //y=1.015 //x2=68.905 //y2=1.145
r2056 (  174 305 ) resistor r=0.0413265 //w=0.7 //l=0.175 //layer=m1 \
 //thickness=0.36 //x=68.905 //y=0.35 //x2=68.905 //y2=0.175
r2057 (  174 175 ) resistor r=0.634542 //w=0.131 //l=0.665 //layer=m1 \
 //thickness=0.36 //x=68.905 //y=0.35 //x2=68.905 //y2=1.015
r2058 (  173 569 ) resistor r=3.1 //w=0.17 //l=0.51 //layer=mcon //count=3 \
 //x=68.57 //y=0.18 //x2=68.57 //y2=0.18
r2059 (  171 558 ) resistor r=3.1 //w=0.17 //l=0.51 //layer=mcon //count=3 \
 //x=67.09 //y=0.18 //x2=67.09 //y2=0.18
r2060 (  171 173 ) resistor r=0.594855 //w=0.311 //l=1.48 //layer=m1 \
 //thickness=0.36 //x=67.09 //y=0.175 //x2=68.57 //y2=0.175
r2061 (  169 556 ) resistor r=3.1 //w=0.17 //l=0.51 //layer=mcon //count=3 \
 //x=65.98 //y=0.18 //x2=65.98 //y2=0.18
r2062 (  169 171 ) resistor r=0.446141 //w=0.311 //l=1.11 //layer=m1 \
 //thickness=0.36 //x=65.98 //y=0.175 //x2=67.09 //y2=0.175
r2063 (  167 554 ) resistor r=3.1 //w=0.17 //l=0.51 //layer=mcon //count=3 \
 //x=64.87 //y=0.18 //x2=64.87 //y2=0.18
r2064 (  167 169 ) resistor r=0.446141 //w=0.311 //l=1.11 //layer=m1 \
 //thickness=0.36 //x=64.87 //y=0.175 //x2=65.98 //y2=0.175
r2065 (  165 301 ) resistor r=0.028033 //w=0.35 //l=0.085 //layer=m1 \
 //thickness=0.36 //x=64.18 //y=0.175 //x2=64.095 //y2=0.175
r2066 (  165 167 ) resistor r=0.277331 //w=0.311 //l=0.69 //layer=m1 \
 //thickness=0.36 //x=64.18 //y=0.175 //x2=64.87 //y2=0.175
r2067 (  164 305 ) resistor r=0.028033 //w=0.35 //l=0.085 //layer=m1 \
 //thickness=0.36 //x=68.82 //y=0.175 //x2=68.905 //y2=0.175
r2068 (  164 173 ) resistor r=0.100482 //w=0.311 //l=0.25 //layer=m1 \
 //thickness=0.36 //x=68.82 //y=0.175 //x2=68.57 //y2=0.175
r2069 (  163 299 ) resistor r=0.0942778 //w=0.221 //l=0.13 //layer=m1 \
 //thickness=0.36 //x=64.095 //y=1.015 //x2=64.095 //y2=1.145
r2070 (  162 301 ) resistor r=0.0413265 //w=0.7 //l=0.175 //layer=m1 \
 //thickness=0.36 //x=64.095 //y=0.35 //x2=64.095 //y2=0.175
r2071 (  162 163 ) resistor r=0.634542 //w=0.131 //l=0.665 //layer=m1 \
 //thickness=0.36 //x=64.095 //y=0.35 //x2=64.095 //y2=1.015
r2072 (  161 552 ) resistor r=3.1 //w=0.17 //l=0.51 //layer=mcon //count=3 \
 //x=63.76 //y=0.18 //x2=63.76 //y2=0.18
r2073 (  159 541 ) resistor r=3.1 //w=0.17 //l=0.51 //layer=mcon //count=3 \
 //x=62.28 //y=0.18 //x2=62.28 //y2=0.18
r2074 (  159 161 ) resistor r=0.594855 //w=0.311 //l=1.48 //layer=m1 \
 //thickness=0.36 //x=62.28 //y=0.175 //x2=63.76 //y2=0.175
r2075 (  157 539 ) resistor r=3.1 //w=0.17 //l=0.51 //layer=mcon //count=3 \
 //x=61.17 //y=0.18 //x2=61.17 //y2=0.18
r2076 (  157 159 ) resistor r=0.446141 //w=0.311 //l=1.11 //layer=m1 \
 //thickness=0.36 //x=61.17 //y=0.175 //x2=62.28 //y2=0.175
r2077 (  155 537 ) resistor r=3.1 //w=0.17 //l=0.51 //layer=mcon //count=3 \
 //x=60.06 //y=0.18 //x2=60.06 //y2=0.18
r2078 (  155 157 ) resistor r=0.446141 //w=0.311 //l=1.11 //layer=m1 \
 //thickness=0.36 //x=60.06 //y=0.175 //x2=61.17 //y2=0.175
r2079 (  153 297 ) resistor r=0.028033 //w=0.35 //l=0.085 //layer=m1 \
 //thickness=0.36 //x=59.37 //y=0.175 //x2=59.285 //y2=0.175
r2080 (  153 155 ) resistor r=0.277331 //w=0.311 //l=0.69 //layer=m1 \
 //thickness=0.36 //x=59.37 //y=0.175 //x2=60.06 //y2=0.175
r2081 (  152 301 ) resistor r=0.028033 //w=0.35 //l=0.085 //layer=m1 \
 //thickness=0.36 //x=64.01 //y=0.175 //x2=64.095 //y2=0.175
r2082 (  152 161 ) resistor r=0.100482 //w=0.311 //l=0.25 //layer=m1 \
 //thickness=0.36 //x=64.01 //y=0.175 //x2=63.76 //y2=0.175
r2083 (  151 295 ) resistor r=0.0942778 //w=0.221 //l=0.13 //layer=m1 \
 //thickness=0.36 //x=59.285 //y=1.015 //x2=59.285 //y2=1.145
r2084 (  150 297 ) resistor r=0.0413265 //w=0.7 //l=0.175 //layer=m1 \
 //thickness=0.36 //x=59.285 //y=0.35 //x2=59.285 //y2=0.175
r2085 (  150 151 ) resistor r=0.634542 //w=0.131 //l=0.665 //layer=m1 \
 //thickness=0.36 //x=59.285 //y=0.35 //x2=59.285 //y2=1.015
r2086 (  149 535 ) resistor r=3.1 //w=0.17 //l=0.51 //layer=mcon //count=3 \
 //x=58.95 //y=0.18 //x2=58.95 //y2=0.18
r2087 (  147 524 ) resistor r=3.1 //w=0.17 //l=0.51 //layer=mcon //count=3 \
 //x=57.47 //y=0.18 //x2=57.47 //y2=0.18
r2088 (  147 149 ) resistor r=0.594855 //w=0.311 //l=1.48 //layer=m1 \
 //thickness=0.36 //x=57.47 //y=0.175 //x2=58.95 //y2=0.175
r2089 (  145 522 ) resistor r=3.1 //w=0.17 //l=0.51 //layer=mcon //count=3 \
 //x=56.36 //y=0.18 //x2=56.36 //y2=0.18
r2090 (  145 147 ) resistor r=0.446141 //w=0.311 //l=1.11 //layer=m1 \
 //thickness=0.36 //x=56.36 //y=0.175 //x2=57.47 //y2=0.175
r2091 (  143 520 ) resistor r=3.1 //w=0.17 //l=0.51 //layer=mcon //count=3 \
 //x=55.25 //y=0.18 //x2=55.25 //y2=0.18
r2092 (  143 145 ) resistor r=0.446141 //w=0.311 //l=1.11 //layer=m1 \
 //thickness=0.36 //x=55.25 //y=0.175 //x2=56.36 //y2=0.175
r2093 (  141 293 ) resistor r=0.028033 //w=0.35 //l=0.085 //layer=m1 \
 //thickness=0.36 //x=54.56 //y=0.175 //x2=54.475 //y2=0.175
r2094 (  141 143 ) resistor r=0.277331 //w=0.311 //l=0.69 //layer=m1 \
 //thickness=0.36 //x=54.56 //y=0.175 //x2=55.25 //y2=0.175
r2095 (  140 297 ) resistor r=0.028033 //w=0.35 //l=0.085 //layer=m1 \
 //thickness=0.36 //x=59.2 //y=0.175 //x2=59.285 //y2=0.175
r2096 (  140 149 ) resistor r=0.100482 //w=0.311 //l=0.25 //layer=m1 \
 //thickness=0.36 //x=59.2 //y=0.175 //x2=58.95 //y2=0.175
r2097 (  139 291 ) resistor r=0.0942778 //w=0.221 //l=0.13 //layer=m1 \
 //thickness=0.36 //x=54.475 //y=1.015 //x2=54.475 //y2=1.145
r2098 (  138 293 ) resistor r=0.0413265 //w=0.7 //l=0.175 //layer=m1 \
 //thickness=0.36 //x=54.475 //y=0.35 //x2=54.475 //y2=0.175
r2099 (  138 139 ) resistor r=0.634542 //w=0.131 //l=0.665 //layer=m1 \
 //thickness=0.36 //x=54.475 //y=0.35 //x2=54.475 //y2=1.015
r2100 (  137 518 ) resistor r=3.1 //w=0.17 //l=0.51 //layer=mcon //count=3 \
 //x=54.14 //y=0.18 //x2=54.14 //y2=0.18
r2101 (  135 507 ) resistor r=3.1 //w=0.17 //l=0.51 //layer=mcon //count=3 \
 //x=52.66 //y=0.18 //x2=52.66 //y2=0.18
r2102 (  135 137 ) resistor r=0.594855 //w=0.311 //l=1.48 //layer=m1 \
 //thickness=0.36 //x=52.66 //y=0.175 //x2=54.14 //y2=0.175
r2103 (  133 505 ) resistor r=3.1 //w=0.17 //l=0.51 //layer=mcon //count=3 \
 //x=51.55 //y=0.18 //x2=51.55 //y2=0.18
r2104 (  133 135 ) resistor r=0.446141 //w=0.311 //l=1.11 //layer=m1 \
 //thickness=0.36 //x=51.55 //y=0.175 //x2=52.66 //y2=0.175
r2105 (  131 503 ) resistor r=3.1 //w=0.17 //l=0.51 //layer=mcon //count=3 \
 //x=50.44 //y=0.18 //x2=50.44 //y2=0.18
r2106 (  131 133 ) resistor r=0.446141 //w=0.311 //l=1.11 //layer=m1 \
 //thickness=0.36 //x=50.44 //y=0.175 //x2=51.55 //y2=0.175
r2107 (  129 289 ) resistor r=0.028033 //w=0.35 //l=0.085 //layer=m1 \
 //thickness=0.36 //x=49.75 //y=0.175 //x2=49.665 //y2=0.175
r2108 (  129 131 ) resistor r=0.277331 //w=0.311 //l=0.69 //layer=m1 \
 //thickness=0.36 //x=49.75 //y=0.175 //x2=50.44 //y2=0.175
r2109 (  128 293 ) resistor r=0.028033 //w=0.35 //l=0.085 //layer=m1 \
 //thickness=0.36 //x=54.39 //y=0.175 //x2=54.475 //y2=0.175
r2110 (  128 137 ) resistor r=0.100482 //w=0.311 //l=0.25 //layer=m1 \
 //thickness=0.36 //x=54.39 //y=0.175 //x2=54.14 //y2=0.175
r2111 (  127 287 ) resistor r=0.0942778 //w=0.221 //l=0.13 //layer=m1 \
 //thickness=0.36 //x=49.665 //y=1.015 //x2=49.665 //y2=1.145
r2112 (  126 289 ) resistor r=0.0413265 //w=0.7 //l=0.175 //layer=m1 \
 //thickness=0.36 //x=49.665 //y=0.35 //x2=49.665 //y2=0.175
r2113 (  126 127 ) resistor r=0.634542 //w=0.131 //l=0.665 //layer=m1 \
 //thickness=0.36 //x=49.665 //y=0.35 //x2=49.665 //y2=1.015
r2114 (  125 501 ) resistor r=3.1 //w=0.17 //l=0.51 //layer=mcon //count=3 \
 //x=49.33 //y=0.18 //x2=49.33 //y2=0.18
r2115 (  122 490 ) resistor r=3.1 //w=0.17 //l=0.51 //layer=mcon //count=3 \
 //x=47.85 //y=0.18 //x2=47.85 //y2=0.18
r2116 (  120 488 ) resistor r=3.1 //w=0.17 //l=0.51 //layer=mcon //count=3 \
 //x=46.74 //y=0.18 //x2=46.74 //y2=0.18
r2117 (  120 122 ) resistor r=0.446141 //w=0.311 //l=1.11 //layer=m1 \
 //thickness=0.36 //x=46.74 //y=0.175 //x2=47.85 //y2=0.175
r2118 (  118 486 ) resistor r=3.1 //w=0.17 //l=0.51 //layer=mcon //count=3 \
 //x=45.63 //y=0.18 //x2=45.63 //y2=0.18
r2119 (  118 120 ) resistor r=0.446141 //w=0.311 //l=1.11 //layer=m1 \
 //thickness=0.36 //x=45.63 //y=0.175 //x2=46.74 //y2=0.175
r2120 (  116 285 ) resistor r=0.028033 //w=0.35 //l=0.085 //layer=m1 \
 //thickness=0.36 //x=44.94 //y=0.175 //x2=44.855 //y2=0.175
r2121 (  116 118 ) resistor r=0.277331 //w=0.311 //l=0.69 //layer=m1 \
 //thickness=0.36 //x=44.94 //y=0.175 //x2=45.63 //y2=0.175
r2122 (  115 289 ) resistor r=0.028033 //w=0.35 //l=0.085 //layer=m1 \
 //thickness=0.36 //x=49.58 //y=0.175 //x2=49.665 //y2=0.175
r2123 (  115 125 ) resistor r=0.100482 //w=0.311 //l=0.25 //layer=m1 \
 //thickness=0.36 //x=49.58 //y=0.175 //x2=49.33 //y2=0.175
r2124 (  114 283 ) resistor r=0.0942778 //w=0.221 //l=0.13 //layer=m1 \
 //thickness=0.36 //x=44.855 //y=1.015 //x2=44.855 //y2=1.145
r2125 (  113 285 ) resistor r=0.0413265 //w=0.7 //l=0.175 //layer=m1 \
 //thickness=0.36 //x=44.855 //y=0.35 //x2=44.855 //y2=0.175
r2126 (  113 114 ) resistor r=0.634542 //w=0.131 //l=0.665 //layer=m1 \
 //thickness=0.36 //x=44.855 //y=0.35 //x2=44.855 //y2=1.015
r2127 (  112 484 ) resistor r=3.1 //w=0.17 //l=0.51 //layer=mcon //count=3 \
 //x=44.52 //y=0.18 //x2=44.52 //y2=0.18
r2128 (  110 473 ) resistor r=3.1 //w=0.17 //l=0.51 //layer=mcon //count=3 \
 //x=43.04 //y=0.18 //x2=43.04 //y2=0.18
r2129 (  110 112 ) resistor r=0.594855 //w=0.311 //l=1.48 //layer=m1 \
 //thickness=0.36 //x=43.04 //y=0.175 //x2=44.52 //y2=0.175
r2130 (  108 471 ) resistor r=3.1 //w=0.17 //l=0.51 //layer=mcon //count=3 \
 //x=41.93 //y=0.18 //x2=41.93 //y2=0.18
r2131 (  108 110 ) resistor r=0.446141 //w=0.311 //l=1.11 //layer=m1 \
 //thickness=0.36 //x=41.93 //y=0.175 //x2=43.04 //y2=0.175
r2132 (  106 469 ) resistor r=3.1 //w=0.17 //l=0.51 //layer=mcon //count=3 \
 //x=40.82 //y=0.18 //x2=40.82 //y2=0.18
r2133 (  106 108 ) resistor r=0.446141 //w=0.311 //l=1.11 //layer=m1 \
 //thickness=0.36 //x=40.82 //y=0.175 //x2=41.93 //y2=0.175
r2134 (  104 281 ) resistor r=0.028033 //w=0.35 //l=0.085 //layer=m1 \
 //thickness=0.36 //x=40.13 //y=0.175 //x2=40.045 //y2=0.175
r2135 (  104 106 ) resistor r=0.277331 //w=0.311 //l=0.69 //layer=m1 \
 //thickness=0.36 //x=40.13 //y=0.175 //x2=40.82 //y2=0.175
r2136 (  103 285 ) resistor r=0.028033 //w=0.35 //l=0.085 //layer=m1 \
 //thickness=0.36 //x=44.77 //y=0.175 //x2=44.855 //y2=0.175
r2137 (  103 112 ) resistor r=0.100482 //w=0.311 //l=0.25 //layer=m1 \
 //thickness=0.36 //x=44.77 //y=0.175 //x2=44.52 //y2=0.175
r2138 (  102 279 ) resistor r=0.0942778 //w=0.221 //l=0.13 //layer=m1 \
 //thickness=0.36 //x=40.045 //y=1.015 //x2=40.045 //y2=1.145
r2139 (  101 281 ) resistor r=0.0413265 //w=0.7 //l=0.175 //layer=m1 \
 //thickness=0.36 //x=40.045 //y=0.35 //x2=40.045 //y2=0.175
r2140 (  101 102 ) resistor r=0.634542 //w=0.131 //l=0.665 //layer=m1 \
 //thickness=0.36 //x=40.045 //y=0.35 //x2=40.045 //y2=1.015
r2141 (  100 467 ) resistor r=3.1 //w=0.17 //l=0.51 //layer=mcon //count=3 \
 //x=39.71 //y=0.18 //x2=39.71 //y2=0.18
r2142 (  98 456 ) resistor r=3.1 //w=0.17 //l=0.51 //layer=mcon //count=3 \
 //x=38.23 //y=0.18 //x2=38.23 //y2=0.18
r2143 (  98 100 ) resistor r=0.594855 //w=0.311 //l=1.48 //layer=m1 \
 //thickness=0.36 //x=38.23 //y=0.175 //x2=39.71 //y2=0.175
r2144 (  96 454 ) resistor r=3.1 //w=0.17 //l=0.51 //layer=mcon //count=3 \
 //x=37.12 //y=0.18 //x2=37.12 //y2=0.18
r2145 (  96 98 ) resistor r=0.446141 //w=0.311 //l=1.11 //layer=m1 \
 //thickness=0.36 //x=37.12 //y=0.175 //x2=38.23 //y2=0.175
r2146 (  94 452 ) resistor r=3.1 //w=0.17 //l=0.51 //layer=mcon //count=3 \
 //x=36.01 //y=0.18 //x2=36.01 //y2=0.18
r2147 (  94 96 ) resistor r=0.446141 //w=0.311 //l=1.11 //layer=m1 \
 //thickness=0.36 //x=36.01 //y=0.175 //x2=37.12 //y2=0.175
r2148 (  92 277 ) resistor r=0.028033 //w=0.35 //l=0.085 //layer=m1 \
 //thickness=0.36 //x=35.32 //y=0.175 //x2=35.235 //y2=0.175
r2149 (  92 94 ) resistor r=0.277331 //w=0.311 //l=0.69 //layer=m1 \
 //thickness=0.36 //x=35.32 //y=0.175 //x2=36.01 //y2=0.175
r2150 (  91 281 ) resistor r=0.028033 //w=0.35 //l=0.085 //layer=m1 \
 //thickness=0.36 //x=39.96 //y=0.175 //x2=40.045 //y2=0.175
r2151 (  91 100 ) resistor r=0.100482 //w=0.311 //l=0.25 //layer=m1 \
 //thickness=0.36 //x=39.96 //y=0.175 //x2=39.71 //y2=0.175
r2152 (  90 275 ) resistor r=0.0942778 //w=0.221 //l=0.13 //layer=m1 \
 //thickness=0.36 //x=35.235 //y=1.015 //x2=35.235 //y2=1.145
r2153 (  89 277 ) resistor r=0.0413265 //w=0.7 //l=0.175 //layer=m1 \
 //thickness=0.36 //x=35.235 //y=0.35 //x2=35.235 //y2=0.175
r2154 (  89 90 ) resistor r=0.634542 //w=0.131 //l=0.665 //layer=m1 \
 //thickness=0.36 //x=35.235 //y=0.35 //x2=35.235 //y2=1.015
r2155 (  88 450 ) resistor r=3.1 //w=0.17 //l=0.51 //layer=mcon //count=3 \
 //x=34.9 //y=0.18 //x2=34.9 //y2=0.18
r2156 (  86 439 ) resistor r=3.1 //w=0.17 //l=0.51 //layer=mcon //count=3 \
 //x=33.42 //y=0.18 //x2=33.42 //y2=0.18
r2157 (  86 88 ) resistor r=0.594855 //w=0.311 //l=1.48 //layer=m1 \
 //thickness=0.36 //x=33.42 //y=0.175 //x2=34.9 //y2=0.175
r2158 (  84 437 ) resistor r=3.1 //w=0.17 //l=0.51 //layer=mcon //count=3 \
 //x=32.31 //y=0.18 //x2=32.31 //y2=0.18
r2159 (  84 86 ) resistor r=0.446141 //w=0.311 //l=1.11 //layer=m1 \
 //thickness=0.36 //x=32.31 //y=0.175 //x2=33.42 //y2=0.175
r2160 (  82 435 ) resistor r=3.1 //w=0.17 //l=0.51 //layer=mcon //count=3 \
 //x=31.2 //y=0.18 //x2=31.2 //y2=0.18
r2161 (  82 84 ) resistor r=0.446141 //w=0.311 //l=1.11 //layer=m1 \
 //thickness=0.36 //x=31.2 //y=0.175 //x2=32.31 //y2=0.175
r2162 (  80 273 ) resistor r=0.028033 //w=0.35 //l=0.085 //layer=m1 \
 //thickness=0.36 //x=30.51 //y=0.175 //x2=30.425 //y2=0.175
r2163 (  80 82 ) resistor r=0.277331 //w=0.311 //l=0.69 //layer=m1 \
 //thickness=0.36 //x=30.51 //y=0.175 //x2=31.2 //y2=0.175
r2164 (  79 277 ) resistor r=0.028033 //w=0.35 //l=0.085 //layer=m1 \
 //thickness=0.36 //x=35.15 //y=0.175 //x2=35.235 //y2=0.175
r2165 (  79 88 ) resistor r=0.100482 //w=0.311 //l=0.25 //layer=m1 \
 //thickness=0.36 //x=35.15 //y=0.175 //x2=34.9 //y2=0.175
r2166 (  78 271 ) resistor r=0.0942778 //w=0.221 //l=0.13 //layer=m1 \
 //thickness=0.36 //x=30.425 //y=1.015 //x2=30.425 //y2=1.145
r2167 (  77 273 ) resistor r=0.0413265 //w=0.7 //l=0.175 //layer=m1 \
 //thickness=0.36 //x=30.425 //y=0.35 //x2=30.425 //y2=0.175
r2168 (  77 78 ) resistor r=0.634542 //w=0.131 //l=0.665 //layer=m1 \
 //thickness=0.36 //x=30.425 //y=0.35 //x2=30.425 //y2=1.015
r2169 (  76 433 ) resistor r=3.1 //w=0.17 //l=0.51 //layer=mcon //count=3 \
 //x=30.09 //y=0.18 //x2=30.09 //y2=0.18
r2170 (  74 422 ) resistor r=3.1 //w=0.17 //l=0.51 //layer=mcon //count=3 \
 //x=28.61 //y=0.18 //x2=28.61 //y2=0.18
r2171 (  74 76 ) resistor r=0.594855 //w=0.311 //l=1.48 //layer=m1 \
 //thickness=0.36 //x=28.61 //y=0.175 //x2=30.09 //y2=0.175
r2172 (  72 420 ) resistor r=3.1 //w=0.17 //l=0.51 //layer=mcon //count=3 \
 //x=27.5 //y=0.18 //x2=27.5 //y2=0.18
r2173 (  72 74 ) resistor r=0.446141 //w=0.311 //l=1.11 //layer=m1 \
 //thickness=0.36 //x=27.5 //y=0.175 //x2=28.61 //y2=0.175
r2174 (  70 418 ) resistor r=3.1 //w=0.17 //l=0.51 //layer=mcon //count=3 \
 //x=26.39 //y=0.18 //x2=26.39 //y2=0.18
r2175 (  70 72 ) resistor r=0.446141 //w=0.311 //l=1.11 //layer=m1 \
 //thickness=0.36 //x=26.39 //y=0.175 //x2=27.5 //y2=0.175
r2176 (  68 269 ) resistor r=0.028033 //w=0.35 //l=0.085 //layer=m1 \
 //thickness=0.36 //x=25.7 //y=0.175 //x2=25.615 //y2=0.175
r2177 (  68 70 ) resistor r=0.277331 //w=0.311 //l=0.69 //layer=m1 \
 //thickness=0.36 //x=25.7 //y=0.175 //x2=26.39 //y2=0.175
r2178 (  67 273 ) resistor r=0.028033 //w=0.35 //l=0.085 //layer=m1 \
 //thickness=0.36 //x=30.34 //y=0.175 //x2=30.425 //y2=0.175
r2179 (  67 76 ) resistor r=0.100482 //w=0.311 //l=0.25 //layer=m1 \
 //thickness=0.36 //x=30.34 //y=0.175 //x2=30.09 //y2=0.175
r2180 (  66 267 ) resistor r=0.0942778 //w=0.221 //l=0.13 //layer=m1 \
 //thickness=0.36 //x=25.615 //y=1.015 //x2=25.615 //y2=1.145
r2181 (  65 269 ) resistor r=0.0413265 //w=0.7 //l=0.175 //layer=m1 \
 //thickness=0.36 //x=25.615 //y=0.35 //x2=25.615 //y2=0.175
r2182 (  65 66 ) resistor r=0.634542 //w=0.131 //l=0.665 //layer=m1 \
 //thickness=0.36 //x=25.615 //y=0.35 //x2=25.615 //y2=1.015
r2183 (  64 416 ) resistor r=3.1 //w=0.17 //l=0.51 //layer=mcon //count=3 \
 //x=25.28 //y=0.18 //x2=25.28 //y2=0.18
r2184 (  62 405 ) resistor r=3.1 //w=0.17 //l=0.51 //layer=mcon //count=3 \
 //x=23.8 //y=0.18 //x2=23.8 //y2=0.18
r2185 (  62 64 ) resistor r=0.594855 //w=0.311 //l=1.48 //layer=m1 \
 //thickness=0.36 //x=23.8 //y=0.175 //x2=25.28 //y2=0.175
r2186 (  60 403 ) resistor r=3.1 //w=0.17 //l=0.51 //layer=mcon //count=3 \
 //x=22.69 //y=0.18 //x2=22.69 //y2=0.18
r2187 (  60 62 ) resistor r=0.446141 //w=0.311 //l=1.11 //layer=m1 \
 //thickness=0.36 //x=22.69 //y=0.175 //x2=23.8 //y2=0.175
r2188 (  58 401 ) resistor r=3.1 //w=0.17 //l=0.51 //layer=mcon //count=3 \
 //x=21.58 //y=0.18 //x2=21.58 //y2=0.18
r2189 (  58 60 ) resistor r=0.446141 //w=0.311 //l=1.11 //layer=m1 \
 //thickness=0.36 //x=21.58 //y=0.175 //x2=22.69 //y2=0.175
r2190 (  56 265 ) resistor r=0.028033 //w=0.35 //l=0.085 //layer=m1 \
 //thickness=0.36 //x=20.89 //y=0.175 //x2=20.805 //y2=0.175
r2191 (  56 58 ) resistor r=0.277331 //w=0.311 //l=0.69 //layer=m1 \
 //thickness=0.36 //x=20.89 //y=0.175 //x2=21.58 //y2=0.175
r2192 (  55 269 ) resistor r=0.028033 //w=0.35 //l=0.085 //layer=m1 \
 //thickness=0.36 //x=25.53 //y=0.175 //x2=25.615 //y2=0.175
r2193 (  55 64 ) resistor r=0.100482 //w=0.311 //l=0.25 //layer=m1 \
 //thickness=0.36 //x=25.53 //y=0.175 //x2=25.28 //y2=0.175
r2194 (  54 263 ) resistor r=0.0942778 //w=0.221 //l=0.13 //layer=m1 \
 //thickness=0.36 //x=20.805 //y=1.015 //x2=20.805 //y2=1.145
r2195 (  53 265 ) resistor r=0.0413265 //w=0.7 //l=0.175 //layer=m1 \
 //thickness=0.36 //x=20.805 //y=0.35 //x2=20.805 //y2=0.175
r2196 (  53 54 ) resistor r=0.634542 //w=0.131 //l=0.665 //layer=m1 \
 //thickness=0.36 //x=20.805 //y=0.35 //x2=20.805 //y2=1.015
r2197 (  52 399 ) resistor r=3.1 //w=0.17 //l=0.51 //layer=mcon //count=3 \
 //x=20.47 //y=0.18 //x2=20.47 //y2=0.18
r2198 (  50 388 ) resistor r=3.1 //w=0.17 //l=0.51 //layer=mcon //count=3 \
 //x=18.99 //y=0.18 //x2=18.99 //y2=0.18
r2199 (  50 52 ) resistor r=0.594855 //w=0.311 //l=1.48 //layer=m1 \
 //thickness=0.36 //x=18.99 //y=0.175 //x2=20.47 //y2=0.175
r2200 (  48 386 ) resistor r=3.1 //w=0.17 //l=0.51 //layer=mcon //count=3 \
 //x=17.88 //y=0.18 //x2=17.88 //y2=0.18
r2201 (  48 50 ) resistor r=0.446141 //w=0.311 //l=1.11 //layer=m1 \
 //thickness=0.36 //x=17.88 //y=0.175 //x2=18.99 //y2=0.175
r2202 (  46 384 ) resistor r=3.1 //w=0.17 //l=0.51 //layer=mcon //count=3 \
 //x=16.77 //y=0.18 //x2=16.77 //y2=0.18
r2203 (  46 48 ) resistor r=0.446141 //w=0.311 //l=1.11 //layer=m1 \
 //thickness=0.36 //x=16.77 //y=0.175 //x2=17.88 //y2=0.175
r2204 (  44 261 ) resistor r=0.028033 //w=0.35 //l=0.085 //layer=m1 \
 //thickness=0.36 //x=16.08 //y=0.175 //x2=15.995 //y2=0.175
r2205 (  44 46 ) resistor r=0.277331 //w=0.311 //l=0.69 //layer=m1 \
 //thickness=0.36 //x=16.08 //y=0.175 //x2=16.77 //y2=0.175
r2206 (  43 265 ) resistor r=0.028033 //w=0.35 //l=0.085 //layer=m1 \
 //thickness=0.36 //x=20.72 //y=0.175 //x2=20.805 //y2=0.175
r2207 (  43 52 ) resistor r=0.100482 //w=0.311 //l=0.25 //layer=m1 \
 //thickness=0.36 //x=20.72 //y=0.175 //x2=20.47 //y2=0.175
r2208 (  42 259 ) resistor r=0.0942778 //w=0.221 //l=0.13 //layer=m1 \
 //thickness=0.36 //x=15.995 //y=1.015 //x2=15.995 //y2=1.145
r2209 (  41 261 ) resistor r=0.0413265 //w=0.7 //l=0.175 //layer=m1 \
 //thickness=0.36 //x=15.995 //y=0.35 //x2=15.995 //y2=0.175
r2210 (  41 42 ) resistor r=0.634542 //w=0.131 //l=0.665 //layer=m1 \
 //thickness=0.36 //x=15.995 //y=0.35 //x2=15.995 //y2=1.015
r2211 (  40 382 ) resistor r=3.1 //w=0.17 //l=0.51 //layer=mcon //count=3 \
 //x=15.66 //y=0.18 //x2=15.66 //y2=0.18
r2212 (  38 371 ) resistor r=3.1 //w=0.17 //l=0.51 //layer=mcon //count=3 \
 //x=14.18 //y=0.18 //x2=14.18 //y2=0.18
r2213 (  38 40 ) resistor r=0.594855 //w=0.311 //l=1.48 //layer=m1 \
 //thickness=0.36 //x=14.18 //y=0.175 //x2=15.66 //y2=0.175
r2214 (  36 369 ) resistor r=3.1 //w=0.17 //l=0.51 //layer=mcon //count=3 \
 //x=13.07 //y=0.18 //x2=13.07 //y2=0.18
r2215 (  36 38 ) resistor r=0.446141 //w=0.311 //l=1.11 //layer=m1 \
 //thickness=0.36 //x=13.07 //y=0.175 //x2=14.18 //y2=0.175
r2216 (  34 367 ) resistor r=3.1 //w=0.17 //l=0.51 //layer=mcon //count=3 \
 //x=11.96 //y=0.18 //x2=11.96 //y2=0.18
r2217 (  34 36 ) resistor r=0.446141 //w=0.311 //l=1.11 //layer=m1 \
 //thickness=0.36 //x=11.96 //y=0.175 //x2=13.07 //y2=0.175
r2218 (  32 257 ) resistor r=0.028033 //w=0.35 //l=0.085 //layer=m1 \
 //thickness=0.36 //x=11.27 //y=0.175 //x2=11.185 //y2=0.175
r2219 (  32 34 ) resistor r=0.277331 //w=0.311 //l=0.69 //layer=m1 \
 //thickness=0.36 //x=11.27 //y=0.175 //x2=11.96 //y2=0.175
r2220 (  31 261 ) resistor r=0.028033 //w=0.35 //l=0.085 //layer=m1 \
 //thickness=0.36 //x=15.91 //y=0.175 //x2=15.995 //y2=0.175
r2221 (  31 40 ) resistor r=0.100482 //w=0.311 //l=0.25 //layer=m1 \
 //thickness=0.36 //x=15.91 //y=0.175 //x2=15.66 //y2=0.175
r2222 (  30 255 ) resistor r=0.0942778 //w=0.221 //l=0.13 //layer=m1 \
 //thickness=0.36 //x=11.185 //y=1.015 //x2=11.185 //y2=1.145
r2223 (  29 257 ) resistor r=0.0413265 //w=0.7 //l=0.175 //layer=m1 \
 //thickness=0.36 //x=11.185 //y=0.35 //x2=11.185 //y2=0.175
r2224 (  29 30 ) resistor r=0.634542 //w=0.131 //l=0.665 //layer=m1 \
 //thickness=0.36 //x=11.185 //y=0.35 //x2=11.185 //y2=1.015
r2225 (  28 365 ) resistor r=3.1 //w=0.17 //l=0.51 //layer=mcon //count=3 \
 //x=10.85 //y=0.18 //x2=10.85 //y2=0.18
r2226 (  26 354 ) resistor r=3.1 //w=0.17 //l=0.51 //layer=mcon //count=3 \
 //x=9.37 //y=0.18 //x2=9.37 //y2=0.18
r2227 (  26 28 ) resistor r=0.594855 //w=0.311 //l=1.48 //layer=m1 \
 //thickness=0.36 //x=9.37 //y=0.175 //x2=10.85 //y2=0.175
r2228 (  24 352 ) resistor r=3.1 //w=0.17 //l=0.51 //layer=mcon //count=3 \
 //x=8.26 //y=0.18 //x2=8.26 //y2=0.18
r2229 (  24 26 ) resistor r=0.446141 //w=0.311 //l=1.11 //layer=m1 \
 //thickness=0.36 //x=8.26 //y=0.175 //x2=9.37 //y2=0.175
r2230 (  22 350 ) resistor r=3.1 //w=0.17 //l=0.51 //layer=mcon //count=3 \
 //x=7.15 //y=0.18 //x2=7.15 //y2=0.18
r2231 (  22 24 ) resistor r=0.446141 //w=0.311 //l=1.11 //layer=m1 \
 //thickness=0.36 //x=7.15 //y=0.175 //x2=8.26 //y2=0.175
r2232 (  20 253 ) resistor r=0.028033 //w=0.35 //l=0.085 //layer=m1 \
 //thickness=0.36 //x=6.46 //y=0.175 //x2=6.375 //y2=0.175
r2233 (  20 22 ) resistor r=0.277331 //w=0.311 //l=0.69 //layer=m1 \
 //thickness=0.36 //x=6.46 //y=0.175 //x2=7.15 //y2=0.175
r2234 (  19 257 ) resistor r=0.028033 //w=0.35 //l=0.085 //layer=m1 \
 //thickness=0.36 //x=11.1 //y=0.175 //x2=11.185 //y2=0.175
r2235 (  19 28 ) resistor r=0.100482 //w=0.311 //l=0.25 //layer=m1 \
 //thickness=0.36 //x=11.1 //y=0.175 //x2=10.85 //y2=0.175
r2236 (  18 251 ) resistor r=0.0942778 //w=0.221 //l=0.13 //layer=m1 \
 //thickness=0.36 //x=6.375 //y=1.015 //x2=6.375 //y2=1.145
r2237 (  17 253 ) resistor r=0.0413265 //w=0.7 //l=0.175 //layer=m1 \
 //thickness=0.36 //x=6.375 //y=0.35 //x2=6.375 //y2=0.175
r2238 (  17 18 ) resistor r=0.634542 //w=0.131 //l=0.665 //layer=m1 \
 //thickness=0.36 //x=6.375 //y=0.35 //x2=6.375 //y2=1.015
r2239 (  16 348 ) resistor r=3.1 //w=0.17 //l=0.51 //layer=mcon //count=3 \
 //x=6.04 //y=0.18 //x2=6.04 //y2=0.18
r2240 (  14 337 ) resistor r=3.1 //w=0.17 //l=0.51 //layer=mcon //count=3 \
 //x=4.56 //y=0.18 //x2=4.56 //y2=0.18
r2241 (  14 16 ) resistor r=0.594855 //w=0.311 //l=1.48 //layer=m1 \
 //thickness=0.36 //x=4.56 //y=0.175 //x2=6.04 //y2=0.175
r2242 (  12 335 ) resistor r=3.1 //w=0.17 //l=0.51 //layer=mcon //count=3 \
 //x=3.45 //y=0.18 //x2=3.45 //y2=0.18
r2243 (  12 14 ) resistor r=0.446141 //w=0.311 //l=1.11 //layer=m1 \
 //thickness=0.36 //x=3.45 //y=0.175 //x2=4.56 //y2=0.175
r2244 (  10 333 ) resistor r=3.1 //w=0.17 //l=0.51 //layer=mcon //count=3 \
 //x=2.34 //y=0.18 //x2=2.34 //y2=0.18
r2245 (  10 12 ) resistor r=0.446141 //w=0.311 //l=1.11 //layer=m1 \
 //thickness=0.36 //x=2.34 //y=0.175 //x2=3.45 //y2=0.175
r2246 (  8 249 ) resistor r=0.028033 //w=0.35 //l=0.085 //layer=m1 \
 //thickness=0.36 //x=1.65 //y=0.175 //x2=1.565 //y2=0.175
r2247 (  8 10 ) resistor r=0.277331 //w=0.311 //l=0.69 //layer=m1 \
 //thickness=0.36 //x=1.65 //y=0.175 //x2=2.34 //y2=0.175
r2248 (  7 253 ) resistor r=0.028033 //w=0.35 //l=0.085 //layer=m1 \
 //thickness=0.36 //x=6.29 //y=0.175 //x2=6.375 //y2=0.175
r2249 (  7 16 ) resistor r=0.100482 //w=0.311 //l=0.25 //layer=m1 \
 //thickness=0.36 //x=6.29 //y=0.175 //x2=6.04 //y2=0.175
r2250 (  6 247 ) resistor r=0.0942778 //w=0.221 //l=0.13 //layer=m1 \
 //thickness=0.36 //x=1.565 //y=1.015 //x2=1.565 //y2=1.145
r2251 (  5 249 ) resistor r=0.0413265 //w=0.7 //l=0.175 //layer=m1 \
 //thickness=0.36 //x=1.565 //y=0.35 //x2=1.565 //y2=0.175
r2252 (  5 6 ) resistor r=0.634542 //w=0.131 //l=0.665 //layer=m1 \
 //thickness=0.36 //x=1.565 //y=0.35 //x2=1.565 //y2=1.015
r2253 (  4 331 ) resistor r=3.1 //w=0.17 //l=0.51 //layer=mcon //count=3 \
 //x=1.23 //y=0.18 //x2=1.23 //y2=0.18
r2254 (  2 249 ) resistor r=0.028033 //w=0.35 //l=0.085 //layer=m1 \
 //thickness=0.36 //x=1.48 //y=0.175 //x2=1.565 //y2=0.175
r2255 (  2 4 ) resistor r=0.0892857 //w=0.35 //l=0.25 //layer=m1 \
 //thickness=0.36 //x=1.48 //y=0.175 //x2=1.23 //y2=0.175
r2256 (  1 125 ) resistor r=0.223071 //w=0.311 //l=0.555 //layer=m1 \
 //thickness=0.36 //x=48.775 //y=0.175 //x2=49.33 //y2=0.175
r2257 (  1 122 ) resistor r=0.371785 //w=0.311 //l=0.925 //layer=m1 \
 //thickness=0.36 //x=48.775 //y=0.175 //x2=47.85 //y2=0.175
ends PM_TMRDFFSNRNQNX1\%GND

subckt PM_TMRDFFSNRNQNX1\%noxref_46 ( 1 5 9 13 17 35 )
c55 ( 35 0 ) capacitor c=0.0709164f //x=0.945 //y=0.555
c56 ( 17 0 ) capacitor c=0.0214613f //x=2.935 //y=1.77
c57 ( 13 0 ) capacitor c=0.0153216f //x=2.935 //y=0.72
c58 ( 9 0 ) capacitor c=0.00772076f //x=2.05 //y=0.805
c59 ( 5 0 ) capacitor c=0.0197372f //x=1.965 //y=1.77
c60 ( 1 0 ) capacitor c=0.0109947f //x=1.08 //y=1.685
r61 (  18 35 ) resistor r=5.4201 //w=0.17 //l=0.103078 //layer=li \
 //thickness=0.1 //x=2.135 //y=1.77 //x2=2.05 //y2=1.81
r62 (  18 35 ) resistor r=27.3797 //w=0.187 //l=0.4 //layer=li //thickness=0.1 \
 //x=2.135 //y=1.77 //x2=2.535 //y2=1.77
r63 (  17 35 ) resistor r=0.751729 //w=0.17 //l=0.085 //layer=li \
 //thickness=0.1 //x=2.935 //y=1.77 //x2=3.02 //y2=1.77
r64 (  17 35 ) resistor r=27.3797 //w=0.187 //l=0.4 //layer=li //thickness=0.1 \
 //x=2.935 //y=1.77 //x2=2.535 //y2=1.77
r65 (  14 35 ) resistor r=3.57586 //w=0.17 //l=0.103078 //layer=li \
 //thickness=0.1 //x=2.135 //y=0.72 //x2=2.05 //y2=0.68
r66 (  14 35 ) resistor r=27.3797 //w=0.187 //l=0.4 //layer=li //thickness=0.1 \
 //x=2.135 //y=0.72 //x2=2.535 //y2=0.72
r67 (  13 35 ) resistor r=0.751729 //w=0.17 //l=0.085 //layer=li \
 //thickness=0.1 //x=2.935 //y=0.72 //x2=3.02 //y2=0.72
r68 (  13 35 ) resistor r=27.3797 //w=0.187 //l=0.4 //layer=li //thickness=0.1 \
 //x=2.935 //y=0.72 //x2=2.535 //y2=0.72
r69 (  10 35 ) resistor r=1.40859 //w=0.34 //l=0.125 //layer=li \
 //thickness=0.1 //x=2.05 //y=1.685 //x2=2.05 //y2=1.81
r70 (  10 35 ) resistor r=42.0963 //w=0.187 //l=0.615 //layer=li \
 //thickness=0.1 //x=2.05 //y=1.685 //x2=2.05 //y2=1.07
r71 (  9 35 ) resistor r=3.57586 //w=0.17 //l=0.125 //layer=li //thickness=0.1 \
 //x=2.05 //y=0.805 //x2=2.05 //y2=0.68
r72 (  9 35 ) resistor r=18.139 //w=0.187 //l=0.265 //layer=li //thickness=0.1 \
 //x=2.05 //y=0.805 //x2=2.05 //y2=1.07
r73 (  6 35 ) resistor r=3.57586 //w=0.17 //l=0.103078 //layer=li \
 //thickness=0.1 //x=1.165 //y=1.77 //x2=1.08 //y2=1.81
r74 (  6 35 ) resistor r=27.3797 //w=0.187 //l=0.4 //layer=li //thickness=0.1 \
 //x=1.165 //y=1.77 //x2=1.565 //y2=1.77
r75 (  5 35 ) resistor r=5.4201 //w=0.17 //l=0.103078 //layer=li \
 //thickness=0.1 //x=1.965 //y=1.77 //x2=2.05 //y2=1.81
r76 (  5 35 ) resistor r=27.3797 //w=0.187 //l=0.4 //layer=li //thickness=0.1 \
 //x=1.965 //y=1.77 //x2=1.565 //y2=1.77
r77 (  1 35 ) resistor r=3.57586 //w=0.17 //l=0.125 //layer=li //thickness=0.1 \
 //x=1.08 //y=1.685 //x2=1.08 //y2=1.81
r78 (  1 35 ) resistor r=42.0963 //w=0.187 //l=0.615 //layer=li \
 //thickness=0.1 //x=1.08 //y=1.685 //x2=1.08 //y2=1.07
ends PM_TMRDFFSNRNQNX1\%noxref_46

subckt PM_TMRDFFSNRNQNX1\%noxref_47 ( 1 5 9 13 17 35 )
c57 ( 35 0 ) capacitor c=0.0691212f //x=5.755 //y=0.555
c58 ( 17 0 ) capacitor c=0.0190725f //x=7.745 //y=1.77
c59 ( 13 0 ) capacitor c=0.015325f //x=7.745 //y=0.72
c60 ( 9 0 ) capacitor c=0.00772076f //x=6.86 //y=0.805
c61 ( 5 0 ) capacitor c=0.0166941f //x=6.775 //y=1.77
c62 ( 1 0 ) capacitor c=0.00710458f //x=5.89 //y=1.685
r63 (  18 35 ) resistor r=5.4201 //w=0.17 //l=0.103078 //layer=li \
 //thickness=0.1 //x=6.945 //y=1.77 //x2=6.86 //y2=1.81
r64 (  18 35 ) resistor r=27.3797 //w=0.187 //l=0.4 //layer=li //thickness=0.1 \
 //x=6.945 //y=1.77 //x2=7.345 //y2=1.77
r65 (  17 35 ) resistor r=0.751729 //w=0.17 //l=0.085 //layer=li \
 //thickness=0.1 //x=7.745 //y=1.77 //x2=7.83 //y2=1.77
r66 (  17 35 ) resistor r=27.3797 //w=0.187 //l=0.4 //layer=li //thickness=0.1 \
 //x=7.745 //y=1.77 //x2=7.345 //y2=1.77
r67 (  14 35 ) resistor r=3.57586 //w=0.17 //l=0.103078 //layer=li \
 //thickness=0.1 //x=6.945 //y=0.72 //x2=6.86 //y2=0.68
r68 (  14 35 ) resistor r=27.3797 //w=0.187 //l=0.4 //layer=li //thickness=0.1 \
 //x=6.945 //y=0.72 //x2=7.345 //y2=0.72
r69 (  13 35 ) resistor r=0.751729 //w=0.17 //l=0.085 //layer=li \
 //thickness=0.1 //x=7.745 //y=0.72 //x2=7.83 //y2=0.72
r70 (  13 35 ) resistor r=27.3797 //w=0.187 //l=0.4 //layer=li //thickness=0.1 \
 //x=7.745 //y=0.72 //x2=7.345 //y2=0.72
r71 (  10 35 ) resistor r=1.40859 //w=0.34 //l=0.125 //layer=li \
 //thickness=0.1 //x=6.86 //y=1.685 //x2=6.86 //y2=1.81
r72 (  10 35 ) resistor r=42.0963 //w=0.187 //l=0.615 //layer=li \
 //thickness=0.1 //x=6.86 //y=1.685 //x2=6.86 //y2=1.07
r73 (  9 35 ) resistor r=3.57586 //w=0.17 //l=0.125 //layer=li //thickness=0.1 \
 //x=6.86 //y=0.805 //x2=6.86 //y2=0.68
r74 (  9 35 ) resistor r=18.139 //w=0.187 //l=0.265 //layer=li //thickness=0.1 \
 //x=6.86 //y=0.805 //x2=6.86 //y2=1.07
r75 (  6 35 ) resistor r=3.57586 //w=0.17 //l=0.103078 //layer=li \
 //thickness=0.1 //x=5.975 //y=1.77 //x2=5.89 //y2=1.81
r76 (  6 35 ) resistor r=27.3797 //w=0.187 //l=0.4 //layer=li //thickness=0.1 \
 //x=5.975 //y=1.77 //x2=6.375 //y2=1.77
r77 (  5 35 ) resistor r=5.4201 //w=0.17 //l=0.103078 //layer=li \
 //thickness=0.1 //x=6.775 //y=1.77 //x2=6.86 //y2=1.81
r78 (  5 35 ) resistor r=27.3797 //w=0.187 //l=0.4 //layer=li //thickness=0.1 \
 //x=6.775 //y=1.77 //x2=6.375 //y2=1.77
r79 (  1 35 ) resistor r=3.57586 //w=0.17 //l=0.125 //layer=li //thickness=0.1 \
 //x=5.89 //y=1.685 //x2=5.89 //y2=1.81
r80 (  1 35 ) resistor r=42.0963 //w=0.187 //l=0.615 //layer=li \
 //thickness=0.1 //x=5.89 //y=1.685 //x2=5.89 //y2=1.07
ends PM_TMRDFFSNRNQNX1\%noxref_47

subckt PM_TMRDFFSNRNQNX1\%noxref_48 ( 1 5 9 13 17 35 )
c58 ( 35 0 ) capacitor c=0.0691212f //x=10.565 //y=0.555
c59 ( 17 0 ) capacitor c=0.0190725f //x=12.555 //y=1.77
c60 ( 13 0 ) capacitor c=0.015325f //x=12.555 //y=0.72
c61 ( 9 0 ) capacitor c=0.00772076f //x=11.67 //y=0.805
c62 ( 5 0 ) capacitor c=0.0167789f //x=11.585 //y=1.77
c63 ( 1 0 ) capacitor c=0.00710458f //x=10.7 //y=1.685
r64 (  18 35 ) resistor r=5.4201 //w=0.17 //l=0.103078 //layer=li \
 //thickness=0.1 //x=11.755 //y=1.77 //x2=11.67 //y2=1.81
r65 (  18 35 ) resistor r=27.3797 //w=0.187 //l=0.4 //layer=li //thickness=0.1 \
 //x=11.755 //y=1.77 //x2=12.155 //y2=1.77
r66 (  17 35 ) resistor r=0.751729 //w=0.17 //l=0.085 //layer=li \
 //thickness=0.1 //x=12.555 //y=1.77 //x2=12.64 //y2=1.77
r67 (  17 35 ) resistor r=27.3797 //w=0.187 //l=0.4 //layer=li //thickness=0.1 \
 //x=12.555 //y=1.77 //x2=12.155 //y2=1.77
r68 (  14 35 ) resistor r=3.57586 //w=0.17 //l=0.103078 //layer=li \
 //thickness=0.1 //x=11.755 //y=0.72 //x2=11.67 //y2=0.68
r69 (  14 35 ) resistor r=27.3797 //w=0.187 //l=0.4 //layer=li //thickness=0.1 \
 //x=11.755 //y=0.72 //x2=12.155 //y2=0.72
r70 (  13 35 ) resistor r=0.751729 //w=0.17 //l=0.085 //layer=li \
 //thickness=0.1 //x=12.555 //y=0.72 //x2=12.64 //y2=0.72
r71 (  13 35 ) resistor r=27.3797 //w=0.187 //l=0.4 //layer=li //thickness=0.1 \
 //x=12.555 //y=0.72 //x2=12.155 //y2=0.72
r72 (  10 35 ) resistor r=1.40859 //w=0.34 //l=0.125 //layer=li \
 //thickness=0.1 //x=11.67 //y=1.685 //x2=11.67 //y2=1.81
r73 (  10 35 ) resistor r=42.0963 //w=0.187 //l=0.615 //layer=li \
 //thickness=0.1 //x=11.67 //y=1.685 //x2=11.67 //y2=1.07
r74 (  9 35 ) resistor r=3.57586 //w=0.17 //l=0.125 //layer=li //thickness=0.1 \
 //x=11.67 //y=0.805 //x2=11.67 //y2=0.68
r75 (  9 35 ) resistor r=18.139 //w=0.187 //l=0.265 //layer=li //thickness=0.1 \
 //x=11.67 //y=0.805 //x2=11.67 //y2=1.07
r76 (  6 35 ) resistor r=3.57586 //w=0.17 //l=0.103078 //layer=li \
 //thickness=0.1 //x=10.785 //y=1.77 //x2=10.7 //y2=1.81
r77 (  6 35 ) resistor r=27.3797 //w=0.187 //l=0.4 //layer=li //thickness=0.1 \
 //x=10.785 //y=1.77 //x2=11.185 //y2=1.77
r78 (  5 35 ) resistor r=5.4201 //w=0.17 //l=0.103078 //layer=li \
 //thickness=0.1 //x=11.585 //y=1.77 //x2=11.67 //y2=1.81
r79 (  5 35 ) resistor r=27.3797 //w=0.187 //l=0.4 //layer=li //thickness=0.1 \
 //x=11.585 //y=1.77 //x2=11.185 //y2=1.77
r80 (  1 35 ) resistor r=3.57586 //w=0.17 //l=0.125 //layer=li //thickness=0.1 \
 //x=10.7 //y=1.685 //x2=10.7 //y2=1.81
r81 (  1 35 ) resistor r=42.0963 //w=0.187 //l=0.615 //layer=li \
 //thickness=0.1 //x=10.7 //y=1.685 //x2=10.7 //y2=1.07
ends PM_TMRDFFSNRNQNX1\%noxref_48

subckt PM_TMRDFFSNRNQNX1\%noxref_49 ( 1 5 9 13 17 35 )
c59 ( 35 0 ) capacitor c=0.0691212f //x=15.375 //y=0.555
c60 ( 17 0 ) capacitor c=0.0190725f //x=17.365 //y=1.77
c61 ( 13 0 ) capacitor c=0.015325f //x=17.365 //y=0.72
c62 ( 9 0 ) capacitor c=0.00772076f //x=16.48 //y=0.805
c63 ( 5 0 ) capacitor c=0.0167589f //x=16.395 //y=1.77
c64 ( 1 0 ) capacitor c=0.00710458f //x=15.51 //y=1.685
r65 (  18 35 ) resistor r=5.4201 //w=0.17 //l=0.103078 //layer=li \
 //thickness=0.1 //x=16.565 //y=1.77 //x2=16.48 //y2=1.81
r66 (  18 35 ) resistor r=27.3797 //w=0.187 //l=0.4 //layer=li //thickness=0.1 \
 //x=16.565 //y=1.77 //x2=16.965 //y2=1.77
r67 (  17 35 ) resistor r=0.751729 //w=0.17 //l=0.085 //layer=li \
 //thickness=0.1 //x=17.365 //y=1.77 //x2=17.45 //y2=1.77
r68 (  17 35 ) resistor r=27.3797 //w=0.187 //l=0.4 //layer=li //thickness=0.1 \
 //x=17.365 //y=1.77 //x2=16.965 //y2=1.77
r69 (  14 35 ) resistor r=3.57586 //w=0.17 //l=0.103078 //layer=li \
 //thickness=0.1 //x=16.565 //y=0.72 //x2=16.48 //y2=0.68
r70 (  14 35 ) resistor r=27.3797 //w=0.187 //l=0.4 //layer=li //thickness=0.1 \
 //x=16.565 //y=0.72 //x2=16.965 //y2=0.72
r71 (  13 35 ) resistor r=0.751729 //w=0.17 //l=0.085 //layer=li \
 //thickness=0.1 //x=17.365 //y=0.72 //x2=17.45 //y2=0.72
r72 (  13 35 ) resistor r=27.3797 //w=0.187 //l=0.4 //layer=li //thickness=0.1 \
 //x=17.365 //y=0.72 //x2=16.965 //y2=0.72
r73 (  10 35 ) resistor r=1.40859 //w=0.34 //l=0.125 //layer=li \
 //thickness=0.1 //x=16.48 //y=1.685 //x2=16.48 //y2=1.81
r74 (  10 35 ) resistor r=42.0963 //w=0.187 //l=0.615 //layer=li \
 //thickness=0.1 //x=16.48 //y=1.685 //x2=16.48 //y2=1.07
r75 (  9 35 ) resistor r=3.57586 //w=0.17 //l=0.125 //layer=li //thickness=0.1 \
 //x=16.48 //y=0.805 //x2=16.48 //y2=0.68
r76 (  9 35 ) resistor r=18.139 //w=0.187 //l=0.265 //layer=li //thickness=0.1 \
 //x=16.48 //y=0.805 //x2=16.48 //y2=1.07
r77 (  6 35 ) resistor r=3.57586 //w=0.17 //l=0.103078 //layer=li \
 //thickness=0.1 //x=15.595 //y=1.77 //x2=15.51 //y2=1.81
r78 (  6 35 ) resistor r=27.3797 //w=0.187 //l=0.4 //layer=li //thickness=0.1 \
 //x=15.595 //y=1.77 //x2=15.995 //y2=1.77
r79 (  5 35 ) resistor r=5.4201 //w=0.17 //l=0.103078 //layer=li \
 //thickness=0.1 //x=16.395 //y=1.77 //x2=16.48 //y2=1.81
r80 (  5 35 ) resistor r=27.3797 //w=0.187 //l=0.4 //layer=li //thickness=0.1 \
 //x=16.395 //y=1.77 //x2=15.995 //y2=1.77
r81 (  1 35 ) resistor r=3.57586 //w=0.17 //l=0.125 //layer=li //thickness=0.1 \
 //x=15.51 //y=1.685 //x2=15.51 //y2=1.81
r82 (  1 35 ) resistor r=42.0963 //w=0.187 //l=0.615 //layer=li \
 //thickness=0.1 //x=15.51 //y=1.685 //x2=15.51 //y2=1.07
ends PM_TMRDFFSNRNQNX1\%noxref_49

subckt PM_TMRDFFSNRNQNX1\%noxref_50 ( 1 5 9 13 17 35 )
c58 ( 35 0 ) capacitor c=0.0691212f //x=20.185 //y=0.555
c59 ( 17 0 ) capacitor c=0.0189585f //x=22.175 //y=1.77
c60 ( 13 0 ) capacitor c=0.0153221f //x=22.175 //y=0.72
c61 ( 9 0 ) capacitor c=0.00772076f //x=21.29 //y=0.805
c62 ( 5 0 ) capacitor c=0.0168501f //x=21.205 //y=1.77
c63 ( 1 0 ) capacitor c=0.00710458f //x=20.32 //y=1.685
r64 (  18 35 ) resistor r=5.4201 //w=0.17 //l=0.103078 //layer=li \
 //thickness=0.1 //x=21.375 //y=1.77 //x2=21.29 //y2=1.81
r65 (  18 35 ) resistor r=27.3797 //w=0.187 //l=0.4 //layer=li //thickness=0.1 \
 //x=21.375 //y=1.77 //x2=21.775 //y2=1.77
r66 (  17 35 ) resistor r=0.751729 //w=0.17 //l=0.085 //layer=li \
 //thickness=0.1 //x=22.175 //y=1.77 //x2=22.26 //y2=1.77
r67 (  17 35 ) resistor r=27.3797 //w=0.187 //l=0.4 //layer=li //thickness=0.1 \
 //x=22.175 //y=1.77 //x2=21.775 //y2=1.77
r68 (  14 35 ) resistor r=3.57586 //w=0.17 //l=0.103078 //layer=li \
 //thickness=0.1 //x=21.375 //y=0.72 //x2=21.29 //y2=0.68
r69 (  14 35 ) resistor r=27.3797 //w=0.187 //l=0.4 //layer=li //thickness=0.1 \
 //x=21.375 //y=0.72 //x2=21.775 //y2=0.72
r70 (  13 35 ) resistor r=0.751729 //w=0.17 //l=0.085 //layer=li \
 //thickness=0.1 //x=22.175 //y=0.72 //x2=22.26 //y2=0.72
r71 (  13 35 ) resistor r=27.3797 //w=0.187 //l=0.4 //layer=li //thickness=0.1 \
 //x=22.175 //y=0.72 //x2=21.775 //y2=0.72
r72 (  10 35 ) resistor r=1.40859 //w=0.34 //l=0.125 //layer=li \
 //thickness=0.1 //x=21.29 //y=1.685 //x2=21.29 //y2=1.81
r73 (  10 35 ) resistor r=42.0963 //w=0.187 //l=0.615 //layer=li \
 //thickness=0.1 //x=21.29 //y=1.685 //x2=21.29 //y2=1.07
r74 (  9 35 ) resistor r=3.57586 //w=0.17 //l=0.125 //layer=li //thickness=0.1 \
 //x=21.29 //y=0.805 //x2=21.29 //y2=0.68
r75 (  9 35 ) resistor r=18.139 //w=0.187 //l=0.265 //layer=li //thickness=0.1 \
 //x=21.29 //y=0.805 //x2=21.29 //y2=1.07
r76 (  6 35 ) resistor r=3.57586 //w=0.17 //l=0.103078 //layer=li \
 //thickness=0.1 //x=20.405 //y=1.77 //x2=20.32 //y2=1.81
r77 (  6 35 ) resistor r=27.3797 //w=0.187 //l=0.4 //layer=li //thickness=0.1 \
 //x=20.405 //y=1.77 //x2=20.805 //y2=1.77
r78 (  5 35 ) resistor r=5.4201 //w=0.17 //l=0.103078 //layer=li \
 //thickness=0.1 //x=21.205 //y=1.77 //x2=21.29 //y2=1.81
r79 (  5 35 ) resistor r=27.3797 //w=0.187 //l=0.4 //layer=li //thickness=0.1 \
 //x=21.205 //y=1.77 //x2=20.805 //y2=1.77
r80 (  1 35 ) resistor r=3.57586 //w=0.17 //l=0.125 //layer=li //thickness=0.1 \
 //x=20.32 //y=1.685 //x2=20.32 //y2=1.81
r81 (  1 35 ) resistor r=42.0963 //w=0.187 //l=0.615 //layer=li \
 //thickness=0.1 //x=20.32 //y=1.685 //x2=20.32 //y2=1.07
ends PM_TMRDFFSNRNQNX1\%noxref_50

subckt PM_TMRDFFSNRNQNX1\%noxref_51 ( 1 5 9 13 17 35 )
c59 ( 35 0 ) capacitor c=0.0691212f //x=24.995 //y=0.555
c60 ( 17 0 ) capacitor c=0.0190725f //x=26.985 //y=1.77
c61 ( 13 0 ) capacitor c=0.015325f //x=26.985 //y=0.72
c62 ( 9 0 ) capacitor c=0.00772076f //x=26.1 //y=0.805
c63 ( 5 0 ) capacitor c=0.0167869f //x=26.015 //y=1.77
c64 ( 1 0 ) capacitor c=0.00710458f //x=25.13 //y=1.685
r65 (  18 35 ) resistor r=5.4201 //w=0.17 //l=0.103078 //layer=li \
 //thickness=0.1 //x=26.185 //y=1.77 //x2=26.1 //y2=1.81
r66 (  18 35 ) resistor r=27.3797 //w=0.187 //l=0.4 //layer=li //thickness=0.1 \
 //x=26.185 //y=1.77 //x2=26.585 //y2=1.77
r67 (  17 35 ) resistor r=0.751729 //w=0.17 //l=0.085 //layer=li \
 //thickness=0.1 //x=26.985 //y=1.77 //x2=27.07 //y2=1.77
r68 (  17 35 ) resistor r=27.3797 //w=0.187 //l=0.4 //layer=li //thickness=0.1 \
 //x=26.985 //y=1.77 //x2=26.585 //y2=1.77
r69 (  14 35 ) resistor r=3.57586 //w=0.17 //l=0.103078 //layer=li \
 //thickness=0.1 //x=26.185 //y=0.72 //x2=26.1 //y2=0.68
r70 (  14 35 ) resistor r=27.3797 //w=0.187 //l=0.4 //layer=li //thickness=0.1 \
 //x=26.185 //y=0.72 //x2=26.585 //y2=0.72
r71 (  13 35 ) resistor r=0.751729 //w=0.17 //l=0.085 //layer=li \
 //thickness=0.1 //x=26.985 //y=0.72 //x2=27.07 //y2=0.72
r72 (  13 35 ) resistor r=27.3797 //w=0.187 //l=0.4 //layer=li //thickness=0.1 \
 //x=26.985 //y=0.72 //x2=26.585 //y2=0.72
r73 (  10 35 ) resistor r=1.40859 //w=0.34 //l=0.125 //layer=li \
 //thickness=0.1 //x=26.1 //y=1.685 //x2=26.1 //y2=1.81
r74 (  10 35 ) resistor r=42.0963 //w=0.187 //l=0.615 //layer=li \
 //thickness=0.1 //x=26.1 //y=1.685 //x2=26.1 //y2=1.07
r75 (  9 35 ) resistor r=3.57586 //w=0.17 //l=0.125 //layer=li //thickness=0.1 \
 //x=26.1 //y=0.805 //x2=26.1 //y2=0.68
r76 (  9 35 ) resistor r=18.139 //w=0.187 //l=0.265 //layer=li //thickness=0.1 \
 //x=26.1 //y=0.805 //x2=26.1 //y2=1.07
r77 (  6 35 ) resistor r=3.57586 //w=0.17 //l=0.103078 //layer=li \
 //thickness=0.1 //x=25.215 //y=1.77 //x2=25.13 //y2=1.81
r78 (  6 35 ) resistor r=27.3797 //w=0.187 //l=0.4 //layer=li //thickness=0.1 \
 //x=25.215 //y=1.77 //x2=25.615 //y2=1.77
r79 (  5 35 ) resistor r=5.4201 //w=0.17 //l=0.103078 //layer=li \
 //thickness=0.1 //x=26.015 //y=1.77 //x2=26.1 //y2=1.81
r80 (  5 35 ) resistor r=27.3797 //w=0.187 //l=0.4 //layer=li //thickness=0.1 \
 //x=26.015 //y=1.77 //x2=25.615 //y2=1.77
r81 (  1 35 ) resistor r=3.57586 //w=0.17 //l=0.125 //layer=li //thickness=0.1 \
 //x=25.13 //y=1.685 //x2=25.13 //y2=1.81
r82 (  1 35 ) resistor r=42.0963 //w=0.187 //l=0.615 //layer=li \
 //thickness=0.1 //x=25.13 //y=1.685 //x2=25.13 //y2=1.07
ends PM_TMRDFFSNRNQNX1\%noxref_51

subckt PM_TMRDFFSNRNQNX1\%noxref_52 ( 1 5 9 13 17 35 )
c56 ( 35 0 ) capacitor c=0.0691212f //x=29.805 //y=0.555
c57 ( 17 0 ) capacitor c=0.0189725f //x=31.795 //y=1.77
c58 ( 13 0 ) capacitor c=0.0153216f //x=31.795 //y=0.72
c59 ( 9 0 ) capacitor c=0.00772076f //x=30.91 //y=0.805
c60 ( 5 0 ) capacitor c=0.0168501f //x=30.825 //y=1.77
c61 ( 1 0 ) capacitor c=0.00710458f //x=29.94 //y=1.685
r62 (  18 35 ) resistor r=5.4201 //w=0.17 //l=0.103078 //layer=li \
 //thickness=0.1 //x=30.995 //y=1.77 //x2=30.91 //y2=1.81
r63 (  18 35 ) resistor r=27.3797 //w=0.187 //l=0.4 //layer=li //thickness=0.1 \
 //x=30.995 //y=1.77 //x2=31.395 //y2=1.77
r64 (  17 35 ) resistor r=0.751729 //w=0.17 //l=0.085 //layer=li \
 //thickness=0.1 //x=31.795 //y=1.77 //x2=31.88 //y2=1.77
r65 (  17 35 ) resistor r=27.3797 //w=0.187 //l=0.4 //layer=li //thickness=0.1 \
 //x=31.795 //y=1.77 //x2=31.395 //y2=1.77
r66 (  14 35 ) resistor r=3.57586 //w=0.17 //l=0.103078 //layer=li \
 //thickness=0.1 //x=30.995 //y=0.72 //x2=30.91 //y2=0.68
r67 (  14 35 ) resistor r=27.3797 //w=0.187 //l=0.4 //layer=li //thickness=0.1 \
 //x=30.995 //y=0.72 //x2=31.395 //y2=0.72
r68 (  13 35 ) resistor r=0.751729 //w=0.17 //l=0.085 //layer=li \
 //thickness=0.1 //x=31.795 //y=0.72 //x2=31.88 //y2=0.72
r69 (  13 35 ) resistor r=27.3797 //w=0.187 //l=0.4 //layer=li //thickness=0.1 \
 //x=31.795 //y=0.72 //x2=31.395 //y2=0.72
r70 (  10 35 ) resistor r=1.40859 //w=0.34 //l=0.125 //layer=li \
 //thickness=0.1 //x=30.91 //y=1.685 //x2=30.91 //y2=1.81
r71 (  10 35 ) resistor r=42.0963 //w=0.187 //l=0.615 //layer=li \
 //thickness=0.1 //x=30.91 //y=1.685 //x2=30.91 //y2=1.07
r72 (  9 35 ) resistor r=3.57586 //w=0.17 //l=0.125 //layer=li //thickness=0.1 \
 //x=30.91 //y=0.805 //x2=30.91 //y2=0.68
r73 (  9 35 ) resistor r=18.139 //w=0.187 //l=0.265 //layer=li //thickness=0.1 \
 //x=30.91 //y=0.805 //x2=30.91 //y2=1.07
r74 (  6 35 ) resistor r=3.57586 //w=0.17 //l=0.103078 //layer=li \
 //thickness=0.1 //x=30.025 //y=1.77 //x2=29.94 //y2=1.81
r75 (  6 35 ) resistor r=27.3797 //w=0.187 //l=0.4 //layer=li //thickness=0.1 \
 //x=30.025 //y=1.77 //x2=30.425 //y2=1.77
r76 (  5 35 ) resistor r=5.4201 //w=0.17 //l=0.103078 //layer=li \
 //thickness=0.1 //x=30.825 //y=1.77 //x2=30.91 //y2=1.81
r77 (  5 35 ) resistor r=27.3797 //w=0.187 //l=0.4 //layer=li //thickness=0.1 \
 //x=30.825 //y=1.77 //x2=30.425 //y2=1.77
r78 (  1 35 ) resistor r=3.57586 //w=0.17 //l=0.125 //layer=li //thickness=0.1 \
 //x=29.94 //y=1.685 //x2=29.94 //y2=1.81
r79 (  1 35 ) resistor r=42.0963 //w=0.187 //l=0.615 //layer=li \
 //thickness=0.1 //x=29.94 //y=1.685 //x2=29.94 //y2=1.07
ends PM_TMRDFFSNRNQNX1\%noxref_52

subckt PM_TMRDFFSNRNQNX1\%noxref_53 ( 1 5 9 13 17 35 )
c57 ( 35 0 ) capacitor c=0.0691212f //x=34.615 //y=0.555
c58 ( 17 0 ) capacitor c=0.0190725f //x=36.605 //y=1.77
c59 ( 13 0 ) capacitor c=0.015325f //x=36.605 //y=0.72
c60 ( 9 0 ) capacitor c=0.00772076f //x=35.72 //y=0.805
c61 ( 5 0 ) capacitor c=0.0166941f //x=35.635 //y=1.77
c62 ( 1 0 ) capacitor c=0.00710458f //x=34.75 //y=1.685
r63 (  18 35 ) resistor r=5.4201 //w=0.17 //l=0.103078 //layer=li \
 //thickness=0.1 //x=35.805 //y=1.77 //x2=35.72 //y2=1.81
r64 (  18 35 ) resistor r=27.3797 //w=0.187 //l=0.4 //layer=li //thickness=0.1 \
 //x=35.805 //y=1.77 //x2=36.205 //y2=1.77
r65 (  17 35 ) resistor r=0.751729 //w=0.17 //l=0.085 //layer=li \
 //thickness=0.1 //x=36.605 //y=1.77 //x2=36.69 //y2=1.77
r66 (  17 35 ) resistor r=27.3797 //w=0.187 //l=0.4 //layer=li //thickness=0.1 \
 //x=36.605 //y=1.77 //x2=36.205 //y2=1.77
r67 (  14 35 ) resistor r=3.57586 //w=0.17 //l=0.103078 //layer=li \
 //thickness=0.1 //x=35.805 //y=0.72 //x2=35.72 //y2=0.68
r68 (  14 35 ) resistor r=27.3797 //w=0.187 //l=0.4 //layer=li //thickness=0.1 \
 //x=35.805 //y=0.72 //x2=36.205 //y2=0.72
r69 (  13 35 ) resistor r=0.751729 //w=0.17 //l=0.085 //layer=li \
 //thickness=0.1 //x=36.605 //y=0.72 //x2=36.69 //y2=0.72
r70 (  13 35 ) resistor r=27.3797 //w=0.187 //l=0.4 //layer=li //thickness=0.1 \
 //x=36.605 //y=0.72 //x2=36.205 //y2=0.72
r71 (  10 35 ) resistor r=1.40859 //w=0.34 //l=0.125 //layer=li \
 //thickness=0.1 //x=35.72 //y=1.685 //x2=35.72 //y2=1.81
r72 (  10 35 ) resistor r=42.0963 //w=0.187 //l=0.615 //layer=li \
 //thickness=0.1 //x=35.72 //y=1.685 //x2=35.72 //y2=1.07
r73 (  9 35 ) resistor r=3.57586 //w=0.17 //l=0.125 //layer=li //thickness=0.1 \
 //x=35.72 //y=0.805 //x2=35.72 //y2=0.68
r74 (  9 35 ) resistor r=18.139 //w=0.187 //l=0.265 //layer=li //thickness=0.1 \
 //x=35.72 //y=0.805 //x2=35.72 //y2=1.07
r75 (  6 35 ) resistor r=3.57586 //w=0.17 //l=0.103078 //layer=li \
 //thickness=0.1 //x=34.835 //y=1.77 //x2=34.75 //y2=1.81
r76 (  6 35 ) resistor r=27.3797 //w=0.187 //l=0.4 //layer=li //thickness=0.1 \
 //x=34.835 //y=1.77 //x2=35.235 //y2=1.77
r77 (  5 35 ) resistor r=5.4201 //w=0.17 //l=0.103078 //layer=li \
 //thickness=0.1 //x=35.635 //y=1.77 //x2=35.72 //y2=1.81
r78 (  5 35 ) resistor r=27.3797 //w=0.187 //l=0.4 //layer=li //thickness=0.1 \
 //x=35.635 //y=1.77 //x2=35.235 //y2=1.77
r79 (  1 35 ) resistor r=3.57586 //w=0.17 //l=0.125 //layer=li //thickness=0.1 \
 //x=34.75 //y=1.685 //x2=34.75 //y2=1.81
r80 (  1 35 ) resistor r=42.0963 //w=0.187 //l=0.615 //layer=li \
 //thickness=0.1 //x=34.75 //y=1.685 //x2=34.75 //y2=1.07
ends PM_TMRDFFSNRNQNX1\%noxref_53

subckt PM_TMRDFFSNRNQNX1\%noxref_54 ( 1 5 9 13 17 35 )
c58 ( 35 0 ) capacitor c=0.0691212f //x=39.425 //y=0.555
c59 ( 17 0 ) capacitor c=0.0190725f //x=41.415 //y=1.77
c60 ( 13 0 ) capacitor c=0.015325f //x=41.415 //y=0.72
c61 ( 9 0 ) capacitor c=0.00772076f //x=40.53 //y=0.805
c62 ( 5 0 ) capacitor c=0.0167789f //x=40.445 //y=1.77
c63 ( 1 0 ) capacitor c=0.00710458f //x=39.56 //y=1.685
r64 (  18 35 ) resistor r=5.4201 //w=0.17 //l=0.103078 //layer=li \
 //thickness=0.1 //x=40.615 //y=1.77 //x2=40.53 //y2=1.81
r65 (  18 35 ) resistor r=27.3797 //w=0.187 //l=0.4 //layer=li //thickness=0.1 \
 //x=40.615 //y=1.77 //x2=41.015 //y2=1.77
r66 (  17 35 ) resistor r=0.751729 //w=0.17 //l=0.085 //layer=li \
 //thickness=0.1 //x=41.415 //y=1.77 //x2=41.5 //y2=1.77
r67 (  17 35 ) resistor r=27.3797 //w=0.187 //l=0.4 //layer=li //thickness=0.1 \
 //x=41.415 //y=1.77 //x2=41.015 //y2=1.77
r68 (  14 35 ) resistor r=3.57586 //w=0.17 //l=0.103078 //layer=li \
 //thickness=0.1 //x=40.615 //y=0.72 //x2=40.53 //y2=0.68
r69 (  14 35 ) resistor r=27.3797 //w=0.187 //l=0.4 //layer=li //thickness=0.1 \
 //x=40.615 //y=0.72 //x2=41.015 //y2=0.72
r70 (  13 35 ) resistor r=0.751729 //w=0.17 //l=0.085 //layer=li \
 //thickness=0.1 //x=41.415 //y=0.72 //x2=41.5 //y2=0.72
r71 (  13 35 ) resistor r=27.3797 //w=0.187 //l=0.4 //layer=li //thickness=0.1 \
 //x=41.415 //y=0.72 //x2=41.015 //y2=0.72
r72 (  10 35 ) resistor r=1.40859 //w=0.34 //l=0.125 //layer=li \
 //thickness=0.1 //x=40.53 //y=1.685 //x2=40.53 //y2=1.81
r73 (  10 35 ) resistor r=42.0963 //w=0.187 //l=0.615 //layer=li \
 //thickness=0.1 //x=40.53 //y=1.685 //x2=40.53 //y2=1.07
r74 (  9 35 ) resistor r=3.57586 //w=0.17 //l=0.125 //layer=li //thickness=0.1 \
 //x=40.53 //y=0.805 //x2=40.53 //y2=0.68
r75 (  9 35 ) resistor r=18.139 //w=0.187 //l=0.265 //layer=li //thickness=0.1 \
 //x=40.53 //y=0.805 //x2=40.53 //y2=1.07
r76 (  6 35 ) resistor r=3.57586 //w=0.17 //l=0.103078 //layer=li \
 //thickness=0.1 //x=39.645 //y=1.77 //x2=39.56 //y2=1.81
r77 (  6 35 ) resistor r=27.3797 //w=0.187 //l=0.4 //layer=li //thickness=0.1 \
 //x=39.645 //y=1.77 //x2=40.045 //y2=1.77
r78 (  5 35 ) resistor r=5.4201 //w=0.17 //l=0.103078 //layer=li \
 //thickness=0.1 //x=40.445 //y=1.77 //x2=40.53 //y2=1.81
r79 (  5 35 ) resistor r=27.3797 //w=0.187 //l=0.4 //layer=li //thickness=0.1 \
 //x=40.445 //y=1.77 //x2=40.045 //y2=1.77
r80 (  1 35 ) resistor r=3.57586 //w=0.17 //l=0.125 //layer=li //thickness=0.1 \
 //x=39.56 //y=1.685 //x2=39.56 //y2=1.81
r81 (  1 35 ) resistor r=42.0963 //w=0.187 //l=0.615 //layer=li \
 //thickness=0.1 //x=39.56 //y=1.685 //x2=39.56 //y2=1.07
ends PM_TMRDFFSNRNQNX1\%noxref_54

subckt PM_TMRDFFSNRNQNX1\%noxref_55 ( 1 5 9 13 17 35 )
c59 ( 35 0 ) capacitor c=0.0691212f //x=44.235 //y=0.555
c60 ( 17 0 ) capacitor c=0.0190725f //x=46.225 //y=1.77
c61 ( 13 0 ) capacitor c=0.015325f //x=46.225 //y=0.72
c62 ( 9 0 ) capacitor c=0.00772076f //x=45.34 //y=0.805
c63 ( 5 0 ) capacitor c=0.0167589f //x=45.255 //y=1.77
c64 ( 1 0 ) capacitor c=0.00710458f //x=44.37 //y=1.685
r65 (  18 35 ) resistor r=5.4201 //w=0.17 //l=0.103078 //layer=li \
 //thickness=0.1 //x=45.425 //y=1.77 //x2=45.34 //y2=1.81
r66 (  18 35 ) resistor r=27.3797 //w=0.187 //l=0.4 //layer=li //thickness=0.1 \
 //x=45.425 //y=1.77 //x2=45.825 //y2=1.77
r67 (  17 35 ) resistor r=0.751729 //w=0.17 //l=0.085 //layer=li \
 //thickness=0.1 //x=46.225 //y=1.77 //x2=46.31 //y2=1.77
r68 (  17 35 ) resistor r=27.3797 //w=0.187 //l=0.4 //layer=li //thickness=0.1 \
 //x=46.225 //y=1.77 //x2=45.825 //y2=1.77
r69 (  14 35 ) resistor r=3.57586 //w=0.17 //l=0.103078 //layer=li \
 //thickness=0.1 //x=45.425 //y=0.72 //x2=45.34 //y2=0.68
r70 (  14 35 ) resistor r=27.3797 //w=0.187 //l=0.4 //layer=li //thickness=0.1 \
 //x=45.425 //y=0.72 //x2=45.825 //y2=0.72
r71 (  13 35 ) resistor r=0.751729 //w=0.17 //l=0.085 //layer=li \
 //thickness=0.1 //x=46.225 //y=0.72 //x2=46.31 //y2=0.72
r72 (  13 35 ) resistor r=27.3797 //w=0.187 //l=0.4 //layer=li //thickness=0.1 \
 //x=46.225 //y=0.72 //x2=45.825 //y2=0.72
r73 (  10 35 ) resistor r=1.40859 //w=0.34 //l=0.125 //layer=li \
 //thickness=0.1 //x=45.34 //y=1.685 //x2=45.34 //y2=1.81
r74 (  10 35 ) resistor r=42.0963 //w=0.187 //l=0.615 //layer=li \
 //thickness=0.1 //x=45.34 //y=1.685 //x2=45.34 //y2=1.07
r75 (  9 35 ) resistor r=3.57586 //w=0.17 //l=0.125 //layer=li //thickness=0.1 \
 //x=45.34 //y=0.805 //x2=45.34 //y2=0.68
r76 (  9 35 ) resistor r=18.139 //w=0.187 //l=0.265 //layer=li //thickness=0.1 \
 //x=45.34 //y=0.805 //x2=45.34 //y2=1.07
r77 (  6 35 ) resistor r=3.57586 //w=0.17 //l=0.103078 //layer=li \
 //thickness=0.1 //x=44.455 //y=1.77 //x2=44.37 //y2=1.81
r78 (  6 35 ) resistor r=27.3797 //w=0.187 //l=0.4 //layer=li //thickness=0.1 \
 //x=44.455 //y=1.77 //x2=44.855 //y2=1.77
r79 (  5 35 ) resistor r=5.4201 //w=0.17 //l=0.103078 //layer=li \
 //thickness=0.1 //x=45.255 //y=1.77 //x2=45.34 //y2=1.81
r80 (  5 35 ) resistor r=27.3797 //w=0.187 //l=0.4 //layer=li //thickness=0.1 \
 //x=45.255 //y=1.77 //x2=44.855 //y2=1.77
r81 (  1 35 ) resistor r=3.57586 //w=0.17 //l=0.125 //layer=li //thickness=0.1 \
 //x=44.37 //y=1.685 //x2=44.37 //y2=1.81
r82 (  1 35 ) resistor r=42.0963 //w=0.187 //l=0.615 //layer=li \
 //thickness=0.1 //x=44.37 //y=1.685 //x2=44.37 //y2=1.07
ends PM_TMRDFFSNRNQNX1\%noxref_55

subckt PM_TMRDFFSNRNQNX1\%noxref_56 ( 1 5 9 13 17 35 )
c58 ( 35 0 ) capacitor c=0.0691212f //x=49.045 //y=0.555
c59 ( 17 0 ) capacitor c=0.0189585f //x=51.035 //y=1.77
c60 ( 13 0 ) capacitor c=0.0153221f //x=51.035 //y=0.72
c61 ( 9 0 ) capacitor c=0.00772076f //x=50.15 //y=0.805
c62 ( 5 0 ) capacitor c=0.0168501f //x=50.065 //y=1.77
c63 ( 1 0 ) capacitor c=0.00710458f //x=49.18 //y=1.685
r64 (  18 35 ) resistor r=5.4201 //w=0.17 //l=0.103078 //layer=li \
 //thickness=0.1 //x=50.235 //y=1.77 //x2=50.15 //y2=1.81
r65 (  18 35 ) resistor r=27.3797 //w=0.187 //l=0.4 //layer=li //thickness=0.1 \
 //x=50.235 //y=1.77 //x2=50.635 //y2=1.77
r66 (  17 35 ) resistor r=0.751729 //w=0.17 //l=0.085 //layer=li \
 //thickness=0.1 //x=51.035 //y=1.77 //x2=51.12 //y2=1.77
r67 (  17 35 ) resistor r=27.3797 //w=0.187 //l=0.4 //layer=li //thickness=0.1 \
 //x=51.035 //y=1.77 //x2=50.635 //y2=1.77
r68 (  14 35 ) resistor r=3.57586 //w=0.17 //l=0.103078 //layer=li \
 //thickness=0.1 //x=50.235 //y=0.72 //x2=50.15 //y2=0.68
r69 (  14 35 ) resistor r=27.3797 //w=0.187 //l=0.4 //layer=li //thickness=0.1 \
 //x=50.235 //y=0.72 //x2=50.635 //y2=0.72
r70 (  13 35 ) resistor r=0.751729 //w=0.17 //l=0.085 //layer=li \
 //thickness=0.1 //x=51.035 //y=0.72 //x2=51.12 //y2=0.72
r71 (  13 35 ) resistor r=27.3797 //w=0.187 //l=0.4 //layer=li //thickness=0.1 \
 //x=51.035 //y=0.72 //x2=50.635 //y2=0.72
r72 (  10 35 ) resistor r=1.40859 //w=0.34 //l=0.125 //layer=li \
 //thickness=0.1 //x=50.15 //y=1.685 //x2=50.15 //y2=1.81
r73 (  10 35 ) resistor r=42.0963 //w=0.187 //l=0.615 //layer=li \
 //thickness=0.1 //x=50.15 //y=1.685 //x2=50.15 //y2=1.07
r74 (  9 35 ) resistor r=3.57586 //w=0.17 //l=0.125 //layer=li //thickness=0.1 \
 //x=50.15 //y=0.805 //x2=50.15 //y2=0.68
r75 (  9 35 ) resistor r=18.139 //w=0.187 //l=0.265 //layer=li //thickness=0.1 \
 //x=50.15 //y=0.805 //x2=50.15 //y2=1.07
r76 (  6 35 ) resistor r=3.57586 //w=0.17 //l=0.103078 //layer=li \
 //thickness=0.1 //x=49.265 //y=1.77 //x2=49.18 //y2=1.81
r77 (  6 35 ) resistor r=27.3797 //w=0.187 //l=0.4 //layer=li //thickness=0.1 \
 //x=49.265 //y=1.77 //x2=49.665 //y2=1.77
r78 (  5 35 ) resistor r=5.4201 //w=0.17 //l=0.103078 //layer=li \
 //thickness=0.1 //x=50.065 //y=1.77 //x2=50.15 //y2=1.81
r79 (  5 35 ) resistor r=27.3797 //w=0.187 //l=0.4 //layer=li //thickness=0.1 \
 //x=50.065 //y=1.77 //x2=49.665 //y2=1.77
r80 (  1 35 ) resistor r=3.57586 //w=0.17 //l=0.125 //layer=li //thickness=0.1 \
 //x=49.18 //y=1.685 //x2=49.18 //y2=1.81
r81 (  1 35 ) resistor r=42.0963 //w=0.187 //l=0.615 //layer=li \
 //thickness=0.1 //x=49.18 //y=1.685 //x2=49.18 //y2=1.07
ends PM_TMRDFFSNRNQNX1\%noxref_56

subckt PM_TMRDFFSNRNQNX1\%noxref_57 ( 1 5 9 13 17 35 )
c57 ( 35 0 ) capacitor c=0.0691212f //x=53.855 //y=0.555
c58 ( 17 0 ) capacitor c=0.0190725f //x=55.845 //y=1.77
c59 ( 13 0 ) capacitor c=0.015325f //x=55.845 //y=0.72
c60 ( 9 0 ) capacitor c=0.00772076f //x=54.96 //y=0.805
c61 ( 5 0 ) capacitor c=0.0168501f //x=54.875 //y=1.77
c62 ( 1 0 ) capacitor c=0.00710458f //x=53.99 //y=1.685
r63 (  18 35 ) resistor r=5.4201 //w=0.17 //l=0.103078 //layer=li \
 //thickness=0.1 //x=55.045 //y=1.77 //x2=54.96 //y2=1.81
r64 (  18 35 ) resistor r=27.3797 //w=0.187 //l=0.4 //layer=li //thickness=0.1 \
 //x=55.045 //y=1.77 //x2=55.445 //y2=1.77
r65 (  17 35 ) resistor r=0.751729 //w=0.17 //l=0.085 //layer=li \
 //thickness=0.1 //x=55.845 //y=1.77 //x2=55.93 //y2=1.77
r66 (  17 35 ) resistor r=27.3797 //w=0.187 //l=0.4 //layer=li //thickness=0.1 \
 //x=55.845 //y=1.77 //x2=55.445 //y2=1.77
r67 (  14 35 ) resistor r=3.57586 //w=0.17 //l=0.103078 //layer=li \
 //thickness=0.1 //x=55.045 //y=0.72 //x2=54.96 //y2=0.68
r68 (  14 35 ) resistor r=27.3797 //w=0.187 //l=0.4 //layer=li //thickness=0.1 \
 //x=55.045 //y=0.72 //x2=55.445 //y2=0.72
r69 (  13 35 ) resistor r=0.751729 //w=0.17 //l=0.085 //layer=li \
 //thickness=0.1 //x=55.845 //y=0.72 //x2=55.93 //y2=0.72
r70 (  13 35 ) resistor r=27.3797 //w=0.187 //l=0.4 //layer=li //thickness=0.1 \
 //x=55.845 //y=0.72 //x2=55.445 //y2=0.72
r71 (  10 35 ) resistor r=1.40859 //w=0.34 //l=0.125 //layer=li \
 //thickness=0.1 //x=54.96 //y=1.685 //x2=54.96 //y2=1.81
r72 (  10 35 ) resistor r=42.0963 //w=0.187 //l=0.615 //layer=li \
 //thickness=0.1 //x=54.96 //y=1.685 //x2=54.96 //y2=1.07
r73 (  9 35 ) resistor r=3.57586 //w=0.17 //l=0.125 //layer=li //thickness=0.1 \
 //x=54.96 //y=0.805 //x2=54.96 //y2=0.68
r74 (  9 35 ) resistor r=18.139 //w=0.187 //l=0.265 //layer=li //thickness=0.1 \
 //x=54.96 //y=0.805 //x2=54.96 //y2=1.07
r75 (  6 35 ) resistor r=3.57586 //w=0.17 //l=0.103078 //layer=li \
 //thickness=0.1 //x=54.075 //y=1.77 //x2=53.99 //y2=1.81
r76 (  6 35 ) resistor r=27.3797 //w=0.187 //l=0.4 //layer=li //thickness=0.1 \
 //x=54.075 //y=1.77 //x2=54.475 //y2=1.77
r77 (  5 35 ) resistor r=5.4201 //w=0.17 //l=0.103078 //layer=li \
 //thickness=0.1 //x=54.875 //y=1.77 //x2=54.96 //y2=1.81
r78 (  5 35 ) resistor r=27.3797 //w=0.187 //l=0.4 //layer=li //thickness=0.1 \
 //x=54.875 //y=1.77 //x2=54.475 //y2=1.77
r79 (  1 35 ) resistor r=3.57586 //w=0.17 //l=0.125 //layer=li //thickness=0.1 \
 //x=53.99 //y=1.685 //x2=53.99 //y2=1.81
r80 (  1 35 ) resistor r=42.0963 //w=0.187 //l=0.615 //layer=li \
 //thickness=0.1 //x=53.99 //y=1.685 //x2=53.99 //y2=1.07
ends PM_TMRDFFSNRNQNX1\%noxref_57

subckt PM_TMRDFFSNRNQNX1\%noxref_58 ( 1 5 9 13 17 35 )
c56 ( 35 0 ) capacitor c=0.0691212f //x=58.665 //y=0.555
c57 ( 17 0 ) capacitor c=0.0189725f //x=60.655 //y=1.77
c58 ( 13 0 ) capacitor c=0.0153216f //x=60.655 //y=0.72
c59 ( 9 0 ) capacitor c=0.00772076f //x=59.77 //y=0.805
c60 ( 5 0 ) capacitor c=0.0168501f //x=59.685 //y=1.77
c61 ( 1 0 ) capacitor c=0.00710458f //x=58.8 //y=1.685
r62 (  18 35 ) resistor r=5.4201 //w=0.17 //l=0.103078 //layer=li \
 //thickness=0.1 //x=59.855 //y=1.77 //x2=59.77 //y2=1.81
r63 (  18 35 ) resistor r=27.3797 //w=0.187 //l=0.4 //layer=li //thickness=0.1 \
 //x=59.855 //y=1.77 //x2=60.255 //y2=1.77
r64 (  17 35 ) resistor r=0.751729 //w=0.17 //l=0.085 //layer=li \
 //thickness=0.1 //x=60.655 //y=1.77 //x2=60.74 //y2=1.77
r65 (  17 35 ) resistor r=27.3797 //w=0.187 //l=0.4 //layer=li //thickness=0.1 \
 //x=60.655 //y=1.77 //x2=60.255 //y2=1.77
r66 (  14 35 ) resistor r=3.57586 //w=0.17 //l=0.103078 //layer=li \
 //thickness=0.1 //x=59.855 //y=0.72 //x2=59.77 //y2=0.68
r67 (  14 35 ) resistor r=27.3797 //w=0.187 //l=0.4 //layer=li //thickness=0.1 \
 //x=59.855 //y=0.72 //x2=60.255 //y2=0.72
r68 (  13 35 ) resistor r=0.751729 //w=0.17 //l=0.085 //layer=li \
 //thickness=0.1 //x=60.655 //y=0.72 //x2=60.74 //y2=0.72
r69 (  13 35 ) resistor r=27.3797 //w=0.187 //l=0.4 //layer=li //thickness=0.1 \
 //x=60.655 //y=0.72 //x2=60.255 //y2=0.72
r70 (  10 35 ) resistor r=1.40859 //w=0.34 //l=0.125 //layer=li \
 //thickness=0.1 //x=59.77 //y=1.685 //x2=59.77 //y2=1.81
r71 (  10 35 ) resistor r=42.0963 //w=0.187 //l=0.615 //layer=li \
 //thickness=0.1 //x=59.77 //y=1.685 //x2=59.77 //y2=1.07
r72 (  9 35 ) resistor r=3.57586 //w=0.17 //l=0.125 //layer=li //thickness=0.1 \
 //x=59.77 //y=0.805 //x2=59.77 //y2=0.68
r73 (  9 35 ) resistor r=18.139 //w=0.187 //l=0.265 //layer=li //thickness=0.1 \
 //x=59.77 //y=0.805 //x2=59.77 //y2=1.07
r74 (  6 35 ) resistor r=3.57586 //w=0.17 //l=0.103078 //layer=li \
 //thickness=0.1 //x=58.885 //y=1.77 //x2=58.8 //y2=1.81
r75 (  6 35 ) resistor r=27.3797 //w=0.187 //l=0.4 //layer=li //thickness=0.1 \
 //x=58.885 //y=1.77 //x2=59.285 //y2=1.77
r76 (  5 35 ) resistor r=5.4201 //w=0.17 //l=0.103078 //layer=li \
 //thickness=0.1 //x=59.685 //y=1.77 //x2=59.77 //y2=1.81
r77 (  5 35 ) resistor r=27.3797 //w=0.187 //l=0.4 //layer=li //thickness=0.1 \
 //x=59.685 //y=1.77 //x2=59.285 //y2=1.77
r78 (  1 35 ) resistor r=3.57586 //w=0.17 //l=0.125 //layer=li //thickness=0.1 \
 //x=58.8 //y=1.685 //x2=58.8 //y2=1.81
r79 (  1 35 ) resistor r=42.0963 //w=0.187 //l=0.615 //layer=li \
 //thickness=0.1 //x=58.8 //y=1.685 //x2=58.8 //y2=1.07
ends PM_TMRDFFSNRNQNX1\%noxref_58

subckt PM_TMRDFFSNRNQNX1\%noxref_59 ( 1 5 9 13 17 35 )
c57 ( 35 0 ) capacitor c=0.0691212f //x=63.475 //y=0.555
c58 ( 17 0 ) capacitor c=0.0190725f //x=65.465 //y=1.77
c59 ( 13 0 ) capacitor c=0.015325f //x=65.465 //y=0.72
c60 ( 9 0 ) capacitor c=0.00772076f //x=64.58 //y=0.805
c61 ( 5 0 ) capacitor c=0.0166941f //x=64.495 //y=1.77
c62 ( 1 0 ) capacitor c=0.00710458f //x=63.61 //y=1.685
r63 (  18 35 ) resistor r=5.4201 //w=0.17 //l=0.103078 //layer=li \
 //thickness=0.1 //x=64.665 //y=1.77 //x2=64.58 //y2=1.81
r64 (  18 35 ) resistor r=27.3797 //w=0.187 //l=0.4 //layer=li //thickness=0.1 \
 //x=64.665 //y=1.77 //x2=65.065 //y2=1.77
r65 (  17 35 ) resistor r=0.751729 //w=0.17 //l=0.085 //layer=li \
 //thickness=0.1 //x=65.465 //y=1.77 //x2=65.55 //y2=1.77
r66 (  17 35 ) resistor r=27.3797 //w=0.187 //l=0.4 //layer=li //thickness=0.1 \
 //x=65.465 //y=1.77 //x2=65.065 //y2=1.77
r67 (  14 35 ) resistor r=3.57586 //w=0.17 //l=0.103078 //layer=li \
 //thickness=0.1 //x=64.665 //y=0.72 //x2=64.58 //y2=0.68
r68 (  14 35 ) resistor r=27.3797 //w=0.187 //l=0.4 //layer=li //thickness=0.1 \
 //x=64.665 //y=0.72 //x2=65.065 //y2=0.72
r69 (  13 35 ) resistor r=0.751729 //w=0.17 //l=0.085 //layer=li \
 //thickness=0.1 //x=65.465 //y=0.72 //x2=65.55 //y2=0.72
r70 (  13 35 ) resistor r=27.3797 //w=0.187 //l=0.4 //layer=li //thickness=0.1 \
 //x=65.465 //y=0.72 //x2=65.065 //y2=0.72
r71 (  10 35 ) resistor r=1.40859 //w=0.34 //l=0.125 //layer=li \
 //thickness=0.1 //x=64.58 //y=1.685 //x2=64.58 //y2=1.81
r72 (  10 35 ) resistor r=42.0963 //w=0.187 //l=0.615 //layer=li \
 //thickness=0.1 //x=64.58 //y=1.685 //x2=64.58 //y2=1.07
r73 (  9 35 ) resistor r=3.57586 //w=0.17 //l=0.125 //layer=li //thickness=0.1 \
 //x=64.58 //y=0.805 //x2=64.58 //y2=0.68
r74 (  9 35 ) resistor r=18.139 //w=0.187 //l=0.265 //layer=li //thickness=0.1 \
 //x=64.58 //y=0.805 //x2=64.58 //y2=1.07
r75 (  6 35 ) resistor r=3.57586 //w=0.17 //l=0.103078 //layer=li \
 //thickness=0.1 //x=63.695 //y=1.77 //x2=63.61 //y2=1.81
r76 (  6 35 ) resistor r=27.3797 //w=0.187 //l=0.4 //layer=li //thickness=0.1 \
 //x=63.695 //y=1.77 //x2=64.095 //y2=1.77
r77 (  5 35 ) resistor r=5.4201 //w=0.17 //l=0.103078 //layer=li \
 //thickness=0.1 //x=64.495 //y=1.77 //x2=64.58 //y2=1.81
r78 (  5 35 ) resistor r=27.3797 //w=0.187 //l=0.4 //layer=li //thickness=0.1 \
 //x=64.495 //y=1.77 //x2=64.095 //y2=1.77
r79 (  1 35 ) resistor r=3.57586 //w=0.17 //l=0.125 //layer=li //thickness=0.1 \
 //x=63.61 //y=1.685 //x2=63.61 //y2=1.81
r80 (  1 35 ) resistor r=42.0963 //w=0.187 //l=0.615 //layer=li \
 //thickness=0.1 //x=63.61 //y=1.685 //x2=63.61 //y2=1.07
ends PM_TMRDFFSNRNQNX1\%noxref_59

subckt PM_TMRDFFSNRNQNX1\%noxref_60 ( 1 5 9 13 17 35 )
c58 ( 35 0 ) capacitor c=0.0691212f //x=68.285 //y=0.555
c59 ( 17 0 ) capacitor c=0.0190725f //x=70.275 //y=1.77
c60 ( 13 0 ) capacitor c=0.015325f //x=70.275 //y=0.72
c61 ( 9 0 ) capacitor c=0.00772076f //x=69.39 //y=0.805
c62 ( 5 0 ) capacitor c=0.0167789f //x=69.305 //y=1.77
c63 ( 1 0 ) capacitor c=0.00710458f //x=68.42 //y=1.685
r64 (  18 35 ) resistor r=5.4201 //w=0.17 //l=0.103078 //layer=li \
 //thickness=0.1 //x=69.475 //y=1.77 //x2=69.39 //y2=1.81
r65 (  18 35 ) resistor r=27.3797 //w=0.187 //l=0.4 //layer=li //thickness=0.1 \
 //x=69.475 //y=1.77 //x2=69.875 //y2=1.77
r66 (  17 35 ) resistor r=0.751729 //w=0.17 //l=0.085 //layer=li \
 //thickness=0.1 //x=70.275 //y=1.77 //x2=70.36 //y2=1.77
r67 (  17 35 ) resistor r=27.3797 //w=0.187 //l=0.4 //layer=li //thickness=0.1 \
 //x=70.275 //y=1.77 //x2=69.875 //y2=1.77
r68 (  14 35 ) resistor r=3.57586 //w=0.17 //l=0.103078 //layer=li \
 //thickness=0.1 //x=69.475 //y=0.72 //x2=69.39 //y2=0.68
r69 (  14 35 ) resistor r=27.3797 //w=0.187 //l=0.4 //layer=li //thickness=0.1 \
 //x=69.475 //y=0.72 //x2=69.875 //y2=0.72
r70 (  13 35 ) resistor r=0.751729 //w=0.17 //l=0.085 //layer=li \
 //thickness=0.1 //x=70.275 //y=0.72 //x2=70.36 //y2=0.72
r71 (  13 35 ) resistor r=27.3797 //w=0.187 //l=0.4 //layer=li //thickness=0.1 \
 //x=70.275 //y=0.72 //x2=69.875 //y2=0.72
r72 (  10 35 ) resistor r=1.40859 //w=0.34 //l=0.125 //layer=li \
 //thickness=0.1 //x=69.39 //y=1.685 //x2=69.39 //y2=1.81
r73 (  10 35 ) resistor r=42.0963 //w=0.187 //l=0.615 //layer=li \
 //thickness=0.1 //x=69.39 //y=1.685 //x2=69.39 //y2=1.07
r74 (  9 35 ) resistor r=3.57586 //w=0.17 //l=0.125 //layer=li //thickness=0.1 \
 //x=69.39 //y=0.805 //x2=69.39 //y2=0.68
r75 (  9 35 ) resistor r=18.139 //w=0.187 //l=0.265 //layer=li //thickness=0.1 \
 //x=69.39 //y=0.805 //x2=69.39 //y2=1.07
r76 (  6 35 ) resistor r=3.57586 //w=0.17 //l=0.103078 //layer=li \
 //thickness=0.1 //x=68.505 //y=1.77 //x2=68.42 //y2=1.81
r77 (  6 35 ) resistor r=27.3797 //w=0.187 //l=0.4 //layer=li //thickness=0.1 \
 //x=68.505 //y=1.77 //x2=68.905 //y2=1.77
r78 (  5 35 ) resistor r=5.4201 //w=0.17 //l=0.103078 //layer=li \
 //thickness=0.1 //x=69.305 //y=1.77 //x2=69.39 //y2=1.81
r79 (  5 35 ) resistor r=27.3797 //w=0.187 //l=0.4 //layer=li //thickness=0.1 \
 //x=69.305 //y=1.77 //x2=68.905 //y2=1.77
r80 (  1 35 ) resistor r=3.57586 //w=0.17 //l=0.125 //layer=li //thickness=0.1 \
 //x=68.42 //y=1.685 //x2=68.42 //y2=1.81
r81 (  1 35 ) resistor r=42.0963 //w=0.187 //l=0.615 //layer=li \
 //thickness=0.1 //x=68.42 //y=1.685 //x2=68.42 //y2=1.07
ends PM_TMRDFFSNRNQNX1\%noxref_60

subckt PM_TMRDFFSNRNQNX1\%noxref_61 ( 1 5 9 13 17 35 )
c59 ( 35 0 ) capacitor c=0.0691212f //x=73.095 //y=0.555
c60 ( 17 0 ) capacitor c=0.0190725f //x=75.085 //y=1.77
c61 ( 13 0 ) capacitor c=0.015325f //x=75.085 //y=0.72
c62 ( 9 0 ) capacitor c=0.00772076f //x=74.2 //y=0.805
c63 ( 5 0 ) capacitor c=0.0167589f //x=74.115 //y=1.77
c64 ( 1 0 ) capacitor c=0.00710458f //x=73.23 //y=1.685
r65 (  18 35 ) resistor r=5.4201 //w=0.17 //l=0.103078 //layer=li \
 //thickness=0.1 //x=74.285 //y=1.77 //x2=74.2 //y2=1.81
r66 (  18 35 ) resistor r=27.3797 //w=0.187 //l=0.4 //layer=li //thickness=0.1 \
 //x=74.285 //y=1.77 //x2=74.685 //y2=1.77
r67 (  17 35 ) resistor r=0.751729 //w=0.17 //l=0.085 //layer=li \
 //thickness=0.1 //x=75.085 //y=1.77 //x2=75.17 //y2=1.77
r68 (  17 35 ) resistor r=27.3797 //w=0.187 //l=0.4 //layer=li //thickness=0.1 \
 //x=75.085 //y=1.77 //x2=74.685 //y2=1.77
r69 (  14 35 ) resistor r=3.57586 //w=0.17 //l=0.103078 //layer=li \
 //thickness=0.1 //x=74.285 //y=0.72 //x2=74.2 //y2=0.68
r70 (  14 35 ) resistor r=27.3797 //w=0.187 //l=0.4 //layer=li //thickness=0.1 \
 //x=74.285 //y=0.72 //x2=74.685 //y2=0.72
r71 (  13 35 ) resistor r=0.751729 //w=0.17 //l=0.085 //layer=li \
 //thickness=0.1 //x=75.085 //y=0.72 //x2=75.17 //y2=0.72
r72 (  13 35 ) resistor r=27.3797 //w=0.187 //l=0.4 //layer=li //thickness=0.1 \
 //x=75.085 //y=0.72 //x2=74.685 //y2=0.72
r73 (  10 35 ) resistor r=1.40859 //w=0.34 //l=0.125 //layer=li \
 //thickness=0.1 //x=74.2 //y=1.685 //x2=74.2 //y2=1.81
r74 (  10 35 ) resistor r=42.0963 //w=0.187 //l=0.615 //layer=li \
 //thickness=0.1 //x=74.2 //y=1.685 //x2=74.2 //y2=1.07
r75 (  9 35 ) resistor r=3.57586 //w=0.17 //l=0.125 //layer=li //thickness=0.1 \
 //x=74.2 //y=0.805 //x2=74.2 //y2=0.68
r76 (  9 35 ) resistor r=18.139 //w=0.187 //l=0.265 //layer=li //thickness=0.1 \
 //x=74.2 //y=0.805 //x2=74.2 //y2=1.07
r77 (  6 35 ) resistor r=3.57586 //w=0.17 //l=0.103078 //layer=li \
 //thickness=0.1 //x=73.315 //y=1.77 //x2=73.23 //y2=1.81
r78 (  6 35 ) resistor r=27.3797 //w=0.187 //l=0.4 //layer=li //thickness=0.1 \
 //x=73.315 //y=1.77 //x2=73.715 //y2=1.77
r79 (  5 35 ) resistor r=5.4201 //w=0.17 //l=0.103078 //layer=li \
 //thickness=0.1 //x=74.115 //y=1.77 //x2=74.2 //y2=1.81
r80 (  5 35 ) resistor r=27.3797 //w=0.187 //l=0.4 //layer=li //thickness=0.1 \
 //x=74.115 //y=1.77 //x2=73.715 //y2=1.77
r81 (  1 35 ) resistor r=3.57586 //w=0.17 //l=0.125 //layer=li //thickness=0.1 \
 //x=73.23 //y=1.685 //x2=73.23 //y2=1.81
r82 (  1 35 ) resistor r=42.0963 //w=0.187 //l=0.615 //layer=li \
 //thickness=0.1 //x=73.23 //y=1.685 //x2=73.23 //y2=1.07
ends PM_TMRDFFSNRNQNX1\%noxref_61

subckt PM_TMRDFFSNRNQNX1\%noxref_62 ( 1 5 9 13 17 35 )
c58 ( 35 0 ) capacitor c=0.069559f //x=77.905 //y=0.555
c59 ( 17 0 ) capacitor c=0.0190918f //x=79.895 //y=1.77
c60 ( 13 0 ) capacitor c=0.0153483f //x=79.895 //y=0.72
c61 ( 9 0 ) capacitor c=0.00772076f //x=79.01 //y=0.805
c62 ( 5 0 ) capacitor c=0.0168501f //x=78.925 //y=1.77
c63 ( 1 0 ) capacitor c=0.00710458f //x=78.04 //y=1.685
r64 (  18 35 ) resistor r=5.4201 //w=0.17 //l=0.103078 //layer=li \
 //thickness=0.1 //x=79.095 //y=1.77 //x2=79.01 //y2=1.81
r65 (  18 35 ) resistor r=27.3797 //w=0.187 //l=0.4 //layer=li //thickness=0.1 \
 //x=79.095 //y=1.77 //x2=79.495 //y2=1.77
r66 (  17 35 ) resistor r=0.751729 //w=0.17 //l=0.085 //layer=li \
 //thickness=0.1 //x=79.895 //y=1.77 //x2=79.98 //y2=1.77
r67 (  17 35 ) resistor r=27.3797 //w=0.187 //l=0.4 //layer=li //thickness=0.1 \
 //x=79.895 //y=1.77 //x2=79.495 //y2=1.77
r68 (  14 35 ) resistor r=3.57586 //w=0.17 //l=0.103078 //layer=li \
 //thickness=0.1 //x=79.095 //y=0.72 //x2=79.01 //y2=0.68
r69 (  14 35 ) resistor r=27.3797 //w=0.187 //l=0.4 //layer=li //thickness=0.1 \
 //x=79.095 //y=0.72 //x2=79.495 //y2=0.72
r70 (  13 35 ) resistor r=0.751729 //w=0.17 //l=0.085 //layer=li \
 //thickness=0.1 //x=79.895 //y=0.72 //x2=79.98 //y2=0.72
r71 (  13 35 ) resistor r=27.3797 //w=0.187 //l=0.4 //layer=li //thickness=0.1 \
 //x=79.895 //y=0.72 //x2=79.495 //y2=0.72
r72 (  10 35 ) resistor r=1.40859 //w=0.34 //l=0.125 //layer=li \
 //thickness=0.1 //x=79.01 //y=1.685 //x2=79.01 //y2=1.81
r73 (  10 35 ) resistor r=42.0963 //w=0.187 //l=0.615 //layer=li \
 //thickness=0.1 //x=79.01 //y=1.685 //x2=79.01 //y2=1.07
r74 (  9 35 ) resistor r=3.57586 //w=0.17 //l=0.125 //layer=li //thickness=0.1 \
 //x=79.01 //y=0.805 //x2=79.01 //y2=0.68
r75 (  9 35 ) resistor r=18.139 //w=0.187 //l=0.265 //layer=li //thickness=0.1 \
 //x=79.01 //y=0.805 //x2=79.01 //y2=1.07
r76 (  6 35 ) resistor r=3.57586 //w=0.17 //l=0.103078 //layer=li \
 //thickness=0.1 //x=78.125 //y=1.77 //x2=78.04 //y2=1.81
r77 (  6 35 ) resistor r=27.3797 //w=0.187 //l=0.4 //layer=li //thickness=0.1 \
 //x=78.125 //y=1.77 //x2=78.525 //y2=1.77
r78 (  5 35 ) resistor r=5.4201 //w=0.17 //l=0.103078 //layer=li \
 //thickness=0.1 //x=78.925 //y=1.77 //x2=79.01 //y2=1.81
r79 (  5 35 ) resistor r=27.3797 //w=0.187 //l=0.4 //layer=li //thickness=0.1 \
 //x=78.925 //y=1.77 //x2=78.525 //y2=1.77
r80 (  1 35 ) resistor r=3.57586 //w=0.17 //l=0.125 //layer=li //thickness=0.1 \
 //x=78.04 //y=1.685 //x2=78.04 //y2=1.81
r81 (  1 35 ) resistor r=42.0963 //w=0.187 //l=0.615 //layer=li \
 //thickness=0.1 //x=78.04 //y=1.685 //x2=78.04 //y2=1.07
ends PM_TMRDFFSNRNQNX1\%noxref_62

subckt PM_TMRDFFSNRNQNX1\%noxref_63 ( 1 5 9 13 17 35 )
c57 ( 35 0 ) capacitor c=0.0691304f //x=82.715 //y=0.555
c58 ( 17 0 ) capacitor c=0.0190725f //x=84.705 //y=1.77
c59 ( 13 0 ) capacitor c=0.015325f //x=84.705 //y=0.72
c60 ( 9 0 ) capacitor c=0.00772076f //x=83.82 //y=0.805
c61 ( 5 0 ) capacitor c=0.0167091f //x=83.735 //y=1.77
c62 ( 1 0 ) capacitor c=0.00710458f //x=82.85 //y=1.685
r63 (  18 35 ) resistor r=5.4201 //w=0.17 //l=0.103078 //layer=li \
 //thickness=0.1 //x=83.905 //y=1.77 //x2=83.82 //y2=1.81
r64 (  18 35 ) resistor r=27.3797 //w=0.187 //l=0.4 //layer=li //thickness=0.1 \
 //x=83.905 //y=1.77 //x2=84.305 //y2=1.77
r65 (  17 35 ) resistor r=0.751729 //w=0.17 //l=0.085 //layer=li \
 //thickness=0.1 //x=84.705 //y=1.77 //x2=84.79 //y2=1.77
r66 (  17 35 ) resistor r=27.3797 //w=0.187 //l=0.4 //layer=li //thickness=0.1 \
 //x=84.705 //y=1.77 //x2=84.305 //y2=1.77
r67 (  14 35 ) resistor r=3.57586 //w=0.17 //l=0.103078 //layer=li \
 //thickness=0.1 //x=83.905 //y=0.72 //x2=83.82 //y2=0.68
r68 (  14 35 ) resistor r=27.3797 //w=0.187 //l=0.4 //layer=li //thickness=0.1 \
 //x=83.905 //y=0.72 //x2=84.305 //y2=0.72
r69 (  13 35 ) resistor r=0.751729 //w=0.17 //l=0.085 //layer=li \
 //thickness=0.1 //x=84.705 //y=0.72 //x2=84.79 //y2=0.72
r70 (  13 35 ) resistor r=27.3797 //w=0.187 //l=0.4 //layer=li //thickness=0.1 \
 //x=84.705 //y=0.72 //x2=84.305 //y2=0.72
r71 (  10 35 ) resistor r=1.40859 //w=0.34 //l=0.125 //layer=li \
 //thickness=0.1 //x=83.82 //y=1.685 //x2=83.82 //y2=1.81
r72 (  10 35 ) resistor r=42.0963 //w=0.187 //l=0.615 //layer=li \
 //thickness=0.1 //x=83.82 //y=1.685 //x2=83.82 //y2=1.07
r73 (  9 35 ) resistor r=3.57586 //w=0.17 //l=0.125 //layer=li //thickness=0.1 \
 //x=83.82 //y=0.805 //x2=83.82 //y2=0.68
r74 (  9 35 ) resistor r=18.139 //w=0.187 //l=0.265 //layer=li //thickness=0.1 \
 //x=83.82 //y=0.805 //x2=83.82 //y2=1.07
r75 (  6 35 ) resistor r=3.57586 //w=0.17 //l=0.103078 //layer=li \
 //thickness=0.1 //x=82.935 //y=1.77 //x2=82.85 //y2=1.81
r76 (  6 35 ) resistor r=27.3797 //w=0.187 //l=0.4 //layer=li //thickness=0.1 \
 //x=82.935 //y=1.77 //x2=83.335 //y2=1.77
r77 (  5 35 ) resistor r=5.4201 //w=0.17 //l=0.103078 //layer=li \
 //thickness=0.1 //x=83.735 //y=1.77 //x2=83.82 //y2=1.81
r78 (  5 35 ) resistor r=27.3797 //w=0.187 //l=0.4 //layer=li //thickness=0.1 \
 //x=83.735 //y=1.77 //x2=83.335 //y2=1.77
r79 (  1 35 ) resistor r=3.57586 //w=0.17 //l=0.125 //layer=li //thickness=0.1 \
 //x=82.85 //y=1.685 //x2=82.85 //y2=1.81
r80 (  1 35 ) resistor r=42.0963 //w=0.187 //l=0.615 //layer=li \
 //thickness=0.1 //x=82.85 //y=1.685 //x2=82.85 //y2=1.07
ends PM_TMRDFFSNRNQNX1\%noxref_63

subckt PM_TMRDFFSNRNQNX1\%noxref_64 ( 1 5 9 10 13 17 29 )
c67 ( 29 0 ) capacitor c=0.0768209f //x=87.63 //y=0.545
c68 ( 17 0 ) capacitor c=0.00678917f //x=89.705 //y=0.795
c69 ( 13 0 ) capacitor c=0.0154047f //x=89.62 //y=0.71
c70 ( 10 0 ) capacitor c=0.00748068f //x=88.735 //y=1.675
c71 ( 9 0 ) capacitor c=0.00770028f //x=88.735 //y=0.795
c72 ( 5 0 ) capacitor c=0.0203276f //x=88.65 //y=1.76
c73 ( 1 0 ) capacitor c=0.00454619f //x=87.765 //y=1.675
r74 (  17 29 ) resistor r=3.57586 //w=0.17 //l=0.125 //layer=li \
 //thickness=0.1 //x=89.705 //y=0.795 //x2=89.705 //y2=0.67
r75 (  17 29 ) resistor r=41.4118 //w=0.187 //l=0.605 //layer=li \
 //thickness=0.1 //x=89.705 //y=0.795 //x2=89.705 //y2=1.4
r76 (  14 29 ) resistor r=3.57586 //w=0.17 //l=0.103078 //layer=li \
 //thickness=0.1 //x=88.82 //y=0.71 //x2=88.735 //y2=0.67
r77 (  14 29 ) resistor r=27.0374 //w=0.187 //l=0.395 //layer=li \
 //thickness=0.1 //x=88.82 //y=0.71 //x2=89.215 //y2=0.71
r78 (  13 29 ) resistor r=3.57586 //w=0.17 //l=0.103078 //layer=li \
 //thickness=0.1 //x=89.62 //y=0.71 //x2=89.705 //y2=0.67
r79 (  13 29 ) resistor r=27.7219 //w=0.187 //l=0.405 //layer=li \
 //thickness=0.1 //x=89.62 //y=0.71 //x2=89.215 //y2=0.71
r80 (  10 29 ) resistor r=3.57586 //w=0.17 //l=0.125 //layer=li \
 //thickness=0.1 //x=88.735 //y=1.675 //x2=88.735 //y2=1.8
r81 (  10 29 ) resistor r=42.0963 //w=0.187 //l=0.615 //layer=li \
 //thickness=0.1 //x=88.735 //y=1.675 //x2=88.735 //y2=1.06
r82 (  9 29 ) resistor r=3.57586 //w=0.17 //l=0.125 //layer=li //thickness=0.1 \
 //x=88.735 //y=0.795 //x2=88.735 //y2=0.67
r83 (  9 29 ) resistor r=18.139 //w=0.187 //l=0.265 //layer=li //thickness=0.1 \
 //x=88.735 //y=0.795 //x2=88.735 //y2=1.06
r84 (  6 29 ) resistor r=3.57586 //w=0.17 //l=0.103078 //layer=li \
 //thickness=0.1 //x=87.85 //y=1.76 //x2=87.765 //y2=1.8
r85 (  6 29 ) resistor r=27.3797 //w=0.187 //l=0.4 //layer=li //thickness=0.1 \
 //x=87.85 //y=1.76 //x2=88.25 //y2=1.76
r86 (  5 29 ) resistor r=3.57586 //w=0.17 //l=0.103078 //layer=li \
 //thickness=0.1 //x=88.65 //y=1.76 //x2=88.735 //y2=1.8
r87 (  5 29 ) resistor r=27.3797 //w=0.187 //l=0.4 //layer=li //thickness=0.1 \
 //x=88.65 //y=1.76 //x2=88.25 //y2=1.76
r88 (  1 29 ) resistor r=3.57586 //w=0.17 //l=0.125 //layer=li //thickness=0.1 \
 //x=87.765 //y=1.675 //x2=87.765 //y2=1.8
r89 (  1 29 ) resistor r=42.0963 //w=0.187 //l=0.615 //layer=li \
 //thickness=0.1 //x=87.765 //y=1.675 //x2=87.765 //y2=1.06
ends PM_TMRDFFSNRNQNX1\%noxref_64

subckt PM_TMRDFFSNRNQNX1\%noxref_67 ( 1 5 9 10 13 17 29 )
c62 ( 29 0 ) capacitor c=0.0746046f //x=90.96 //y=0.545
c63 ( 17 0 ) capacitor c=0.00678917f //x=93.035 //y=0.795
c64 ( 13 0 ) capacitor c=0.0158009f //x=92.95 //y=0.71
c65 ( 10 0 ) capacitor c=0.00864691f //x=92.065 //y=1.675
c66 ( 9 0 ) capacitor c=0.00770028f //x=92.065 //y=0.795
c67 ( 5 0 ) capacitor c=0.0177875f //x=91.98 //y=1.76
c68 ( 1 0 ) capacitor c=0.00845775f //x=91.095 //y=1.675
r69 (  17 29 ) resistor r=3.57586 //w=0.17 //l=0.125 //layer=li \
 //thickness=0.1 //x=93.035 //y=0.795 //x2=93.035 //y2=0.67
r70 (  17 29 ) resistor r=41.4118 //w=0.187 //l=0.605 //layer=li \
 //thickness=0.1 //x=93.035 //y=0.795 //x2=93.035 //y2=1.4
r71 (  14 29 ) resistor r=3.57586 //w=0.17 //l=0.103078 //layer=li \
 //thickness=0.1 //x=92.15 //y=0.71 //x2=92.065 //y2=0.67
r72 (  14 29 ) resistor r=27.3797 //w=0.187 //l=0.4 //layer=li //thickness=0.1 \
 //x=92.15 //y=0.71 //x2=92.55 //y2=0.71
r73 (  13 29 ) resistor r=3.57586 //w=0.17 //l=0.103078 //layer=li \
 //thickness=0.1 //x=92.95 //y=0.71 //x2=93.035 //y2=0.67
r74 (  13 29 ) resistor r=27.3797 //w=0.187 //l=0.4 //layer=li //thickness=0.1 \
 //x=92.95 //y=0.71 //x2=92.55 //y2=0.71
r75 (  10 29 ) resistor r=3.57586 //w=0.17 //l=0.125 //layer=li \
 //thickness=0.1 //x=92.065 //y=1.675 //x2=92.065 //y2=1.8
r76 (  10 29 ) resistor r=42.0963 //w=0.187 //l=0.615 //layer=li \
 //thickness=0.1 //x=92.065 //y=1.675 //x2=92.065 //y2=1.06
r77 (  9 29 ) resistor r=3.57586 //w=0.17 //l=0.125 //layer=li //thickness=0.1 \
 //x=92.065 //y=0.795 //x2=92.065 //y2=0.67
r78 (  9 29 ) resistor r=18.139 //w=0.187 //l=0.265 //layer=li //thickness=0.1 \
 //x=92.065 //y=0.795 //x2=92.065 //y2=1.06
r79 (  6 29 ) resistor r=3.57586 //w=0.17 //l=0.103078 //layer=li \
 //thickness=0.1 //x=91.18 //y=1.76 //x2=91.095 //y2=1.8
r80 (  6 29 ) resistor r=27.3797 //w=0.187 //l=0.4 //layer=li //thickness=0.1 \
 //x=91.18 //y=1.76 //x2=91.58 //y2=1.76
r81 (  5 29 ) resistor r=3.57586 //w=0.17 //l=0.103078 //layer=li \
 //thickness=0.1 //x=91.98 //y=1.76 //x2=92.065 //y2=1.8
r82 (  5 29 ) resistor r=27.3797 //w=0.187 //l=0.4 //layer=li //thickness=0.1 \
 //x=91.98 //y=1.76 //x2=91.58 //y2=1.76
r83 (  1 29 ) resistor r=3.57586 //w=0.17 //l=0.125 //layer=li //thickness=0.1 \
 //x=91.095 //y=1.675 //x2=91.095 //y2=1.8
r84 (  1 29 ) resistor r=42.0963 //w=0.187 //l=0.615 //layer=li \
 //thickness=0.1 //x=91.095 //y=1.675 //x2=91.095 //y2=1.06
ends PM_TMRDFFSNRNQNX1\%noxref_67

subckt PM_TMRDFFSNRNQNX1\%noxref_68 ( 1 5 9 10 13 17 29 )
c64 ( 29 0 ) capacitor c=0.0688366f //x=94.29 //y=0.545
c65 ( 17 0 ) capacitor c=0.00709795f //x=96.365 //y=0.795
c66 ( 13 0 ) capacitor c=0.0152565f //x=96.28 //y=0.71
c67 ( 10 0 ) capacitor c=0.00749806f //x=95.395 //y=1.675
c68 ( 9 0 ) capacitor c=0.00770028f //x=95.395 //y=0.795
c69 ( 5 0 ) capacitor c=0.0236235f //x=95.31 //y=1.76
c70 ( 1 0 ) capacitor c=0.00498238f //x=94.425 //y=1.675
r71 (  17 29 ) resistor r=3.57586 //w=0.17 //l=0.125 //layer=li \
 //thickness=0.1 //x=96.365 //y=0.795 //x2=96.365 //y2=0.67
r72 (  17 29 ) resistor r=18.139 //w=0.187 //l=0.265 //layer=li \
 //thickness=0.1 //x=96.365 //y=0.795 //x2=96.365 //y2=1.06
r73 (  14 29 ) resistor r=3.57586 //w=0.17 //l=0.103078 //layer=li \
 //thickness=0.1 //x=95.48 //y=0.71 //x2=95.395 //y2=0.67
r74 (  14 29 ) resistor r=27.3797 //w=0.187 //l=0.4 //layer=li //thickness=0.1 \
 //x=95.48 //y=0.71 //x2=95.88 //y2=0.71
r75 (  13 29 ) resistor r=3.57586 //w=0.17 //l=0.103078 //layer=li \
 //thickness=0.1 //x=96.28 //y=0.71 //x2=96.365 //y2=0.67
r76 (  13 29 ) resistor r=27.3797 //w=0.187 //l=0.4 //layer=li //thickness=0.1 \
 //x=96.28 //y=0.71 //x2=95.88 //y2=0.71
r77 (  10 29 ) resistor r=3.57586 //w=0.17 //l=0.125 //layer=li \
 //thickness=0.1 //x=95.395 //y=1.675 //x2=95.395 //y2=1.8
r78 (  10 29 ) resistor r=42.0963 //w=0.187 //l=0.615 //layer=li \
 //thickness=0.1 //x=95.395 //y=1.675 //x2=95.395 //y2=1.06
r79 (  9 29 ) resistor r=3.57586 //w=0.17 //l=0.125 //layer=li //thickness=0.1 \
 //x=95.395 //y=0.795 //x2=95.395 //y2=0.67
r80 (  9 29 ) resistor r=18.139 //w=0.187 //l=0.265 //layer=li //thickness=0.1 \
 //x=95.395 //y=0.795 //x2=95.395 //y2=1.06
r81 (  6 29 ) resistor r=3.57586 //w=0.17 //l=0.103078 //layer=li \
 //thickness=0.1 //x=94.51 //y=1.76 //x2=94.425 //y2=1.8
r82 (  6 29 ) resistor r=27.3797 //w=0.187 //l=0.4 //layer=li //thickness=0.1 \
 //x=94.51 //y=1.76 //x2=94.91 //y2=1.76
r83 (  5 29 ) resistor r=3.57586 //w=0.17 //l=0.103078 //layer=li \
 //thickness=0.1 //x=95.31 //y=1.76 //x2=95.395 //y2=1.8
r84 (  5 29 ) resistor r=27.3797 //w=0.187 //l=0.4 //layer=li //thickness=0.1 \
 //x=95.31 //y=1.76 //x2=94.91 //y2=1.76
r85 (  1 29 ) resistor r=3.57586 //w=0.17 //l=0.125 //layer=li //thickness=0.1 \
 //x=94.425 //y=1.675 //x2=94.425 //y2=1.8
r86 (  1 29 ) resistor r=42.0963 //w=0.187 //l=0.615 //layer=li \
 //thickness=0.1 //x=94.425 //y=1.675 //x2=94.425 //y2=1.06
ends PM_TMRDFFSNRNQNX1\%noxref_68
