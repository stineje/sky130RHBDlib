// File: TMRDFFSNRNQNX1.spi.pex
// Created: Tue Apr 29 10:46:13 2025
// Program "Calibre xRC"
// Version "v2023.2_27.15"
// Nominal Temperature: 30C
// Circuit Temperature: 30C
//
simulator lang=spectre
subckt PM_TMRDFFSNRNQNX1\%GND ( 1 163 167 170 175 185 193 203 211 221 229 239 \
 247 257 265 275 283 293 301 311 319 329 337 347 355 365 373 383 391 401 409 \
 419 427 437 445 455 463 473 481 491 499 507 513 519 532 536 538 540 542 544 \
 546 548 550 552 554 556 558 560 562 564 566 568 570 572 575 577 578 579 580 \
 581 582 583 584 585 586 587 588 589 590 591 592 593 594 595 596 597 )
c1062 ( 597 0 ) capacitor c=0.0215013f //x=94.72 //y=1.045
c1063 ( 596 0 ) capacitor c=0.0215013f //x=91.39 //y=1.045
c1064 ( 595 0 ) capacitor c=0.0207058f //x=88.06 //y=1.045
c1065 ( 594 0 ) capacitor c=0.022593f //x=83.145 //y=1.055
c1066 ( 593 0 ) capacitor c=0.0225954f //x=78.335 //y=1.055
c1067 ( 592 0 ) capacitor c=0.0225954f //x=73.525 //y=1.055
c1068 ( 591 0 ) capacitor c=0.0225954f //x=68.715 //y=1.055
c1069 ( 590 0 ) capacitor c=0.0225954f //x=63.905 //y=1.055
c1070 ( 589 0 ) capacitor c=0.0225954f //x=59.095 //y=1.055
c1071 ( 588 0 ) capacitor c=0.0225954f //x=54.285 //y=1.055
c1072 ( 587 0 ) capacitor c=0.0225954f //x=49.475 //y=1.055
c1073 ( 586 0 ) capacitor c=0.0225954f //x=44.665 //y=1.055
c1074 ( 585 0 ) capacitor c=0.0225954f //x=39.855 //y=1.055
c1075 ( 584 0 ) capacitor c=0.0225954f //x=35.045 //y=1.055
c1076 ( 583 0 ) capacitor c=0.0225954f //x=30.235 //y=1.055
c1077 ( 582 0 ) capacitor c=0.0225954f //x=25.425 //y=1.055
c1078 ( 581 0 ) capacitor c=0.0225954f //x=20.615 //y=1.055
c1079 ( 580 0 ) capacitor c=0.0225954f //x=15.805 //y=1.055
c1080 ( 579 0 ) capacitor c=0.0225954f //x=10.995 //y=1.055
c1081 ( 578 0 ) capacitor c=0.0225954f //x=6.185 //y=1.055
c1082 ( 577 0 ) capacitor c=0.022675f //x=1.375 //y=1.055
c1083 ( 576 0 ) capacitor c=0.00446416f //x=94.91 //y=0.175
c1084 ( 575 0 ) capacitor c=0.101321f //x=93.73 //y=0.175
c1085 ( 574 0 ) capacitor c=0.00446416f //x=91.51 //y=0.18
c1086 ( 572 0 ) capacitor c=0.116223f //x=90.4 //y=0.175
c1087 ( 571 0 ) capacitor c=0.00446416f //x=88.25 //y=0.175
c1088 ( 570 0 ) capacitor c=0.10681f //x=87.07 //y=0.175
c1089 ( 569 0 ) capacitor c=0.00446464f //x=83.335 //y=0.175
c1090 ( 568 0 ) capacitor c=0.107139f //x=82.26 //y=0.175
c1091 ( 567 0 ) capacitor c=0.00446464f //x=78.525 //y=0.175
c1092 ( 566 0 ) capacitor c=0.106902f //x=77.45 //y=0.175
c1093 ( 565 0 ) capacitor c=0.00446464f //x=73.715 //y=0.175
c1094 ( 564 0 ) capacitor c=0.107178f //x=72.64 //y=0.175
c1095 ( 563 0 ) capacitor c=0.00446464f //x=68.905 //y=0.175
c1096 ( 562 0 ) capacitor c=0.107419f //x=67.83 //y=0.175
c1097 ( 561 0 ) capacitor c=0.00446464f //x=64.095 //y=0.175
c1098 ( 560 0 ) capacitor c=0.107156f //x=63.02 //y=0.175
c1099 ( 559 0 ) capacitor c=0.00446464f //x=59.285 //y=0.175
c1100 ( 558 0 ) capacitor c=0.106302f //x=58.21 //y=0.175
c1101 ( 557 0 ) capacitor c=0.00446464f //x=54.475 //y=0.175
c1102 ( 556 0 ) capacitor c=0.107472f //x=53.4 //y=0.175
c1103 ( 555 0 ) capacitor c=0.00446464f //x=49.665 //y=0.175
c1104 ( 554 0 ) capacitor c=0.106902f //x=48.59 //y=0.175
c1105 ( 553 0 ) capacitor c=0.00446464f //x=44.855 //y=0.175
c1106 ( 552 0 ) capacitor c=0.107178f //x=43.78 //y=0.175
c1107 ( 551 0 ) capacitor c=0.00446464f //x=40.045 //y=0.175
c1108 ( 550 0 ) capacitor c=0.107419f //x=38.97 //y=0.175
c1109 ( 549 0 ) capacitor c=0.00446464f //x=35.235 //y=0.175
c1110 ( 548 0 ) capacitor c=0.107156f //x=34.16 //y=0.175
c1111 ( 547 0 ) capacitor c=0.00446464f //x=30.425 //y=0.175
c1112 ( 546 0 ) capacitor c=0.107149f //x=29.35 //y=0.175
c1113 ( 545 0 ) capacitor c=0.00446464f //x=25.615 //y=0.175
c1114 ( 544 0 ) capacitor c=0.107156f //x=24.54 //y=0.175
c1115 ( 543 0 ) capacitor c=0.00446464f //x=20.805 //y=0.175
c1116 ( 542 0 ) capacitor c=0.107029f //x=19.73 //y=0.175
c1117 ( 541 0 ) capacitor c=0.00446464f //x=15.995 //y=0.175
c1118 ( 540 0 ) capacitor c=0.107178f //x=14.92 //y=0.175
c1119 ( 539 0 ) capacitor c=0.00446464f //x=11.185 //y=0.175
c1120 ( 538 0 ) capacitor c=0.107419f //x=10.11 //y=0.175
c1121 ( 537 0 ) capacitor c=0.00446464f //x=6.375 //y=0.175
c1122 ( 536 0 ) capacitor c=0.107156f //x=5.3 //y=0.175
c1123 ( 535 0 ) capacitor c=0.00446464f //x=1.565 //y=0.175
c1124 ( 532 0 ) capacitor c=0.278196f //x=96.32 //y=0.18
c1125 ( 519 0 ) capacitor c=0.0393378f //x=94.825 //y=0.175
c1126 ( 513 0 ) capacitor c=0.0725462f //x=93.56 //y=0.175
c1127 ( 507 0 ) capacitor c=0.0391794f //x=91.495 //y=0.175
c1128 ( 499 0 ) capacitor c=0.0726307f //x=90.23 //y=0.175
c1129 ( 491 0 ) capacitor c=0.039444f //x=88.165 //y=0.175
c1130 ( 481 0 ) capacitor c=0.135066f //x=86.9 //y=0.175
c1131 ( 473 0 ) capacitor c=0.0342713f //x=83.25 //y=0.175
c1132 ( 463 0 ) capacitor c=0.135409f //x=82.09 //y=0.175
c1133 ( 455 0 ) capacitor c=0.0342713f //x=78.44 //y=0.175
c1134 ( 445 0 ) capacitor c=0.135264f //x=77.28 //y=0.175
c1135 ( 437 0 ) capacitor c=0.0342713f //x=73.63 //y=0.175
c1136 ( 427 0 ) capacitor c=0.135066f //x=72.47 //y=0.175
c1137 ( 419 0 ) capacitor c=0.0342713f //x=68.82 //y=0.175
c1138 ( 409 0 ) capacitor c=0.135066f //x=67.66 //y=0.175
c1139 ( 401 0 ) capacitor c=0.0342713f //x=64.01 //y=0.175
c1140 ( 391 0 ) capacitor c=0.135066f //x=62.85 //y=0.175
c1141 ( 383 0 ) capacitor c=0.0342713f //x=59.2 //y=0.175
c1142 ( 373 0 ) capacitor c=0.135066f //x=58.04 //y=0.175
c1143 ( 365 0 ) capacitor c=0.0342713f //x=54.39 //y=0.175
c1144 ( 355 0 ) capacitor c=0.135066f //x=53.23 //y=0.175
c1145 ( 347 0 ) capacitor c=0.0342713f //x=49.58 //y=0.175
c1146 ( 337 0 ) capacitor c=0.135264f //x=48.42 //y=0.175
c1147 ( 329 0 ) capacitor c=0.0342713f //x=44.77 //y=0.175
c1148 ( 319 0 ) capacitor c=0.135066f //x=43.61 //y=0.175
c1149 ( 311 0 ) capacitor c=0.0342713f //x=39.96 //y=0.175
c1150 ( 301 0 ) capacitor c=0.135066f //x=38.8 //y=0.175
c1151 ( 293 0 ) capacitor c=0.0342713f //x=35.15 //y=0.175
c1152 ( 283 0 ) capacitor c=0.135066f //x=33.99 //y=0.175
c1153 ( 275 0 ) capacitor c=0.0342713f //x=30.34 //y=0.175
c1154 ( 265 0 ) capacitor c=0.135066f //x=29.18 //y=0.175
c1155 ( 257 0 ) capacitor c=0.0342713f //x=25.53 //y=0.175
c1156 ( 247 0 ) capacitor c=0.135066f //x=24.37 //y=0.175
c1157 ( 239 0 ) capacitor c=0.0342713f //x=20.72 //y=0.175
c1158 ( 229 0 ) capacitor c=0.135264f //x=19.56 //y=0.175
c1159 ( 221 0 ) capacitor c=0.0342713f //x=15.91 //y=0.175
c1160 ( 211 0 ) capacitor c=0.135066f //x=14.75 //y=0.175
c1161 ( 203 0 ) capacitor c=0.0342713f //x=11.1 //y=0.175
c1162 ( 193 0 ) capacitor c=0.135066f //x=9.94 //y=0.175
c1163 ( 185 0 ) capacitor c=0.0342713f //x=6.29 //y=0.175
c1164 ( 175 0 ) capacitor c=0.13511f //x=5.13 //y=0.175
c1165 ( 170 0 ) capacitor c=0.196729f //x=1.23 //y=0.18
c1166 ( 167 0 ) capacitor c=0.0370791f //x=1.48 //y=0.175
c1167 ( 163 0 ) capacitor c=2.90439f //x=96.32 //y=0.18
r1168 (  530 532 ) resistor r=38.7139 //w=0.367 //l=1.11 //layer=li \
 //thickness=0.1 //x=95.21 //y=0.175 //x2=96.32 //y2=0.175
r1169 (  528 576 ) resistor r=2.87058 //w=0.35 //l=0.085 //layer=li \
 //thickness=0.1 //x=94.995 //y=0.175 //x2=94.91 //y2=0.175
r1170 (  528 530 ) resistor r=7.49864 //w=0.367 //l=0.215 //layer=li \
 //thickness=0.1 //x=94.995 //y=0.175 //x2=95.21 //y2=0.175
r1171 (  523 576 ) resistor r=4.23183 //w=0.7 //l=0.175 //layer=li \
 //thickness=0.1 //x=94.91 //y=0.35 //x2=94.91 //y2=0.175
r1172 (  523 597 ) resistor r=53.7326 //w=0.187 //l=0.785 //layer=li \
 //thickness=0.1 //x=94.91 //y=0.35 //x2=94.91 //y2=1.135
r1173 (  520 575 ) resistor r=5.29055 //w=0.35 //l=0.17 //layer=li \
 //thickness=0.1 //x=93.9 //y=0.175 //x2=93.73 //y2=0.175
r1174 (  520 522 ) resistor r=6.97548 //w=0.367 //l=0.2 //layer=li \
 //thickness=0.1 //x=93.9 //y=0.175 //x2=94.1 //y2=0.175
r1175 (  519 576 ) resistor r=2.87058 //w=0.35 //l=0.085 //layer=li \
 //thickness=0.1 //x=94.825 //y=0.175 //x2=94.91 //y2=0.175
r1176 (  519 522 ) resistor r=25.2861 //w=0.367 //l=0.725 //layer=li \
 //thickness=0.1 //x=94.825 //y=0.175 //x2=94.1 //y2=0.175
r1177 (  514 574 ) resistor r=2.87058 //w=0.35 //l=0.085 //layer=li \
 //thickness=0.1 //x=91.665 //y=0.175 //x2=91.58 //y2=0.175
r1178 (  514 516 ) resistor r=33.3079 //w=0.367 //l=0.955 //layer=li \
 //thickness=0.1 //x=91.665 //y=0.175 //x2=92.62 //y2=0.175
r1179 (  513 575 ) resistor r=5.29055 //w=0.35 //l=0.17 //layer=li \
 //thickness=0.1 //x=93.56 //y=0.175 //x2=93.73 //y2=0.175
r1180 (  513 516 ) resistor r=32.7847 //w=0.367 //l=0.94 //layer=li \
 //thickness=0.1 //x=93.56 //y=0.175 //x2=92.62 //y2=0.175
r1181 (  509 574 ) resistor r=4.23183 //w=0.7 //l=0.175 //layer=li \
 //thickness=0.1 //x=91.58 //y=0.35 //x2=91.58 //y2=0.175
r1182 (  509 596 ) resistor r=53.7326 //w=0.187 //l=0.785 //layer=li \
 //thickness=0.1 //x=91.58 //y=0.35 //x2=91.58 //y2=1.135
r1183 (  508 572 ) resistor r=5.29055 //w=0.35 //l=0.17 //layer=li \
 //thickness=0.1 //x=90.57 //y=0.175 //x2=90.4 //y2=0.175
r1184 (  507 574 ) resistor r=2.87058 //w=0.35 //l=0.085 //layer=li \
 //thickness=0.1 //x=91.495 //y=0.175 //x2=91.58 //y2=0.175
r1185 (  507 508 ) resistor r=32.2616 //w=0.367 //l=0.925 //layer=li \
 //thickness=0.1 //x=91.495 //y=0.175 //x2=90.57 //y2=0.175
r1186 (  502 504 ) resistor r=38.7139 //w=0.367 //l=1.11 //layer=li \
 //thickness=0.1 //x=88.92 //y=0.175 //x2=90.03 //y2=0.175
r1187 (  500 571 ) resistor r=2.87058 //w=0.35 //l=0.085 //layer=li \
 //thickness=0.1 //x=88.335 //y=0.175 //x2=88.25 //y2=0.175
r1188 (  500 502 ) resistor r=20.4033 //w=0.367 //l=0.585 //layer=li \
 //thickness=0.1 //x=88.335 //y=0.175 //x2=88.92 //y2=0.175
r1189 (  499 572 ) resistor r=5.29055 //w=0.35 //l=0.17 //layer=li \
 //thickness=0.1 //x=90.23 //y=0.175 //x2=90.4 //y2=0.175
r1190 (  499 504 ) resistor r=6.97548 //w=0.367 //l=0.2 //layer=li \
 //thickness=0.1 //x=90.23 //y=0.175 //x2=90.03 //y2=0.175
r1191 (  495 571 ) resistor r=4.23183 //w=0.7 //l=0.175 //layer=li \
 //thickness=0.1 //x=88.25 //y=0.35 //x2=88.25 //y2=0.175
r1192 (  495 595 ) resistor r=53.7326 //w=0.187 //l=0.785 //layer=li \
 //thickness=0.1 //x=88.25 //y=0.35 //x2=88.25 //y2=1.135
r1193 (  492 570 ) resistor r=5.29055 //w=0.35 //l=0.17 //layer=li \
 //thickness=0.1 //x=87.24 //y=0.175 //x2=87.07 //y2=0.175
r1194 (  492 494 ) resistor r=19.8801 //w=0.367 //l=0.57 //layer=li \
 //thickness=0.1 //x=87.24 //y=0.175 //x2=87.81 //y2=0.175
r1195 (  491 571 ) resistor r=2.87058 //w=0.35 //l=0.085 //layer=li \
 //thickness=0.1 //x=88.165 //y=0.175 //x2=88.25 //y2=0.175
r1196 (  491 494 ) resistor r=12.3815 //w=0.367 //l=0.355 //layer=li \
 //thickness=0.1 //x=88.165 //y=0.175 //x2=87.81 //y2=0.175
r1197 (  486 488 ) resistor r=38.7139 //w=0.367 //l=1.11 //layer=li \
 //thickness=0.1 //x=85.22 //y=0.175 //x2=86.33 //y2=0.175
r1198 (  484 486 ) resistor r=38.7139 //w=0.367 //l=1.11 //layer=li \
 //thickness=0.1 //x=84.11 //y=0.175 //x2=85.22 //y2=0.175
r1199 (  482 569 ) resistor r=2.87058 //w=0.35 //l=0.085 //layer=li \
 //thickness=0.1 //x=83.42 //y=0.175 //x2=83.335 //y2=0.175
r1200 (  482 484 ) resistor r=24.0654 //w=0.367 //l=0.69 //layer=li \
 //thickness=0.1 //x=83.42 //y=0.175 //x2=84.11 //y2=0.175
r1201 (  481 570 ) resistor r=5.29055 //w=0.35 //l=0.17 //layer=li \
 //thickness=0.1 //x=86.9 //y=0.175 //x2=87.07 //y2=0.175
r1202 (  481 488 ) resistor r=19.8801 //w=0.367 //l=0.57 //layer=li \
 //thickness=0.1 //x=86.9 //y=0.175 //x2=86.33 //y2=0.175
r1203 (  477 569 ) resistor r=4.23183 //w=0.7 //l=0.175 //layer=li \
 //thickness=0.1 //x=83.335 //y=0.35 //x2=83.335 //y2=0.175
r1204 (  477 594 ) resistor r=54.4171 //w=0.187 //l=0.795 //layer=li \
 //thickness=0.1 //x=83.335 //y=0.35 //x2=83.335 //y2=1.145
r1205 (  474 568 ) resistor r=5.29055 //w=0.35 //l=0.17 //layer=li \
 //thickness=0.1 //x=82.43 //y=0.175 //x2=82.26 //y2=0.175
r1206 (  474 476 ) resistor r=19.8801 //w=0.367 //l=0.57 //layer=li \
 //thickness=0.1 //x=82.43 //y=0.175 //x2=83 //y2=0.175
r1207 (  473 569 ) resistor r=2.87058 //w=0.35 //l=0.085 //layer=li \
 //thickness=0.1 //x=83.25 //y=0.175 //x2=83.335 //y2=0.175
r1208 (  473 476 ) resistor r=8.71935 //w=0.367 //l=0.25 //layer=li \
 //thickness=0.1 //x=83.25 //y=0.175 //x2=83 //y2=0.175
r1209 (  468 470 ) resistor r=38.7139 //w=0.367 //l=1.11 //layer=li \
 //thickness=0.1 //x=80.41 //y=0.175 //x2=81.52 //y2=0.175
r1210 (  466 468 ) resistor r=38.7139 //w=0.367 //l=1.11 //layer=li \
 //thickness=0.1 //x=79.3 //y=0.175 //x2=80.41 //y2=0.175
r1211 (  464 567 ) resistor r=2.87058 //w=0.35 //l=0.085 //layer=li \
 //thickness=0.1 //x=78.61 //y=0.175 //x2=78.525 //y2=0.175
r1212 (  464 466 ) resistor r=24.0654 //w=0.367 //l=0.69 //layer=li \
 //thickness=0.1 //x=78.61 //y=0.175 //x2=79.3 //y2=0.175
r1213 (  463 568 ) resistor r=5.29055 //w=0.35 //l=0.17 //layer=li \
 //thickness=0.1 //x=82.09 //y=0.175 //x2=82.26 //y2=0.175
r1214 (  463 470 ) resistor r=19.8801 //w=0.367 //l=0.57 //layer=li \
 //thickness=0.1 //x=82.09 //y=0.175 //x2=81.52 //y2=0.175
r1215 (  459 567 ) resistor r=4.23183 //w=0.7 //l=0.175 //layer=li \
 //thickness=0.1 //x=78.525 //y=0.35 //x2=78.525 //y2=0.175
r1216 (  459 593 ) resistor r=54.4171 //w=0.187 //l=0.795 //layer=li \
 //thickness=0.1 //x=78.525 //y=0.35 //x2=78.525 //y2=1.145
r1217 (  456 566 ) resistor r=5.29055 //w=0.35 //l=0.17 //layer=li \
 //thickness=0.1 //x=77.62 //y=0.175 //x2=77.45 //y2=0.175
r1218 (  456 458 ) resistor r=19.8801 //w=0.367 //l=0.57 //layer=li \
 //thickness=0.1 //x=77.62 //y=0.175 //x2=78.19 //y2=0.175
r1219 (  455 567 ) resistor r=2.87058 //w=0.35 //l=0.085 //layer=li \
 //thickness=0.1 //x=78.44 //y=0.175 //x2=78.525 //y2=0.175
r1220 (  455 458 ) resistor r=8.71935 //w=0.367 //l=0.25 //layer=li \
 //thickness=0.1 //x=78.44 //y=0.175 //x2=78.19 //y2=0.175
r1221 (  450 452 ) resistor r=38.7139 //w=0.367 //l=1.11 //layer=li \
 //thickness=0.1 //x=75.6 //y=0.175 //x2=76.71 //y2=0.175
r1222 (  448 450 ) resistor r=38.7139 //w=0.367 //l=1.11 //layer=li \
 //thickness=0.1 //x=74.49 //y=0.175 //x2=75.6 //y2=0.175
r1223 (  446 565 ) resistor r=2.87058 //w=0.35 //l=0.085 //layer=li \
 //thickness=0.1 //x=73.8 //y=0.175 //x2=73.715 //y2=0.175
r1224 (  446 448 ) resistor r=24.0654 //w=0.367 //l=0.69 //layer=li \
 //thickness=0.1 //x=73.8 //y=0.175 //x2=74.49 //y2=0.175
r1225 (  445 566 ) resistor r=5.29055 //w=0.35 //l=0.17 //layer=li \
 //thickness=0.1 //x=77.28 //y=0.175 //x2=77.45 //y2=0.175
r1226 (  445 452 ) resistor r=19.8801 //w=0.367 //l=0.57 //layer=li \
 //thickness=0.1 //x=77.28 //y=0.175 //x2=76.71 //y2=0.175
r1227 (  441 565 ) resistor r=4.23183 //w=0.7 //l=0.175 //layer=li \
 //thickness=0.1 //x=73.715 //y=0.35 //x2=73.715 //y2=0.175
r1228 (  441 592 ) resistor r=54.4171 //w=0.187 //l=0.795 //layer=li \
 //thickness=0.1 //x=73.715 //y=0.35 //x2=73.715 //y2=1.145
r1229 (  438 564 ) resistor r=5.29055 //w=0.35 //l=0.17 //layer=li \
 //thickness=0.1 //x=72.81 //y=0.175 //x2=72.64 //y2=0.175
r1230 (  438 440 ) resistor r=19.8801 //w=0.367 //l=0.57 //layer=li \
 //thickness=0.1 //x=72.81 //y=0.175 //x2=73.38 //y2=0.175
r1231 (  437 565 ) resistor r=2.87058 //w=0.35 //l=0.085 //layer=li \
 //thickness=0.1 //x=73.63 //y=0.175 //x2=73.715 //y2=0.175
r1232 (  437 440 ) resistor r=8.71935 //w=0.367 //l=0.25 //layer=li \
 //thickness=0.1 //x=73.63 //y=0.175 //x2=73.38 //y2=0.175
r1233 (  432 434 ) resistor r=38.7139 //w=0.367 //l=1.11 //layer=li \
 //thickness=0.1 //x=70.79 //y=0.175 //x2=71.9 //y2=0.175
r1234 (  430 432 ) resistor r=38.7139 //w=0.367 //l=1.11 //layer=li \
 //thickness=0.1 //x=69.68 //y=0.175 //x2=70.79 //y2=0.175
r1235 (  428 563 ) resistor r=2.87058 //w=0.35 //l=0.085 //layer=li \
 //thickness=0.1 //x=68.99 //y=0.175 //x2=68.905 //y2=0.175
r1236 (  428 430 ) resistor r=24.0654 //w=0.367 //l=0.69 //layer=li \
 //thickness=0.1 //x=68.99 //y=0.175 //x2=69.68 //y2=0.175
r1237 (  427 564 ) resistor r=5.29055 //w=0.35 //l=0.17 //layer=li \
 //thickness=0.1 //x=72.47 //y=0.175 //x2=72.64 //y2=0.175
r1238 (  427 434 ) resistor r=19.8801 //w=0.367 //l=0.57 //layer=li \
 //thickness=0.1 //x=72.47 //y=0.175 //x2=71.9 //y2=0.175
r1239 (  423 563 ) resistor r=4.23183 //w=0.7 //l=0.175 //layer=li \
 //thickness=0.1 //x=68.905 //y=0.35 //x2=68.905 //y2=0.175
r1240 (  423 591 ) resistor r=54.4171 //w=0.187 //l=0.795 //layer=li \
 //thickness=0.1 //x=68.905 //y=0.35 //x2=68.905 //y2=1.145
r1241 (  420 562 ) resistor r=5.29055 //w=0.35 //l=0.17 //layer=li \
 //thickness=0.1 //x=68 //y=0.175 //x2=67.83 //y2=0.175
r1242 (  420 422 ) resistor r=19.8801 //w=0.367 //l=0.57 //layer=li \
 //thickness=0.1 //x=68 //y=0.175 //x2=68.57 //y2=0.175
r1243 (  419 563 ) resistor r=2.87058 //w=0.35 //l=0.085 //layer=li \
 //thickness=0.1 //x=68.82 //y=0.175 //x2=68.905 //y2=0.175
r1244 (  419 422 ) resistor r=8.71935 //w=0.367 //l=0.25 //layer=li \
 //thickness=0.1 //x=68.82 //y=0.175 //x2=68.57 //y2=0.175
r1245 (  414 416 ) resistor r=38.7139 //w=0.367 //l=1.11 //layer=li \
 //thickness=0.1 //x=65.98 //y=0.175 //x2=67.09 //y2=0.175
r1246 (  412 414 ) resistor r=38.7139 //w=0.367 //l=1.11 //layer=li \
 //thickness=0.1 //x=64.87 //y=0.175 //x2=65.98 //y2=0.175
r1247 (  410 561 ) resistor r=2.87058 //w=0.35 //l=0.085 //layer=li \
 //thickness=0.1 //x=64.18 //y=0.175 //x2=64.095 //y2=0.175
r1248 (  410 412 ) resistor r=24.0654 //w=0.367 //l=0.69 //layer=li \
 //thickness=0.1 //x=64.18 //y=0.175 //x2=64.87 //y2=0.175
r1249 (  409 562 ) resistor r=5.29055 //w=0.35 //l=0.17 //layer=li \
 //thickness=0.1 //x=67.66 //y=0.175 //x2=67.83 //y2=0.175
r1250 (  409 416 ) resistor r=19.8801 //w=0.367 //l=0.57 //layer=li \
 //thickness=0.1 //x=67.66 //y=0.175 //x2=67.09 //y2=0.175
r1251 (  405 561 ) resistor r=4.23183 //w=0.7 //l=0.175 //layer=li \
 //thickness=0.1 //x=64.095 //y=0.35 //x2=64.095 //y2=0.175
r1252 (  405 590 ) resistor r=54.4171 //w=0.187 //l=0.795 //layer=li \
 //thickness=0.1 //x=64.095 //y=0.35 //x2=64.095 //y2=1.145
r1253 (  402 560 ) resistor r=5.29055 //w=0.35 //l=0.17 //layer=li \
 //thickness=0.1 //x=63.19 //y=0.175 //x2=63.02 //y2=0.175
r1254 (  402 404 ) resistor r=19.8801 //w=0.367 //l=0.57 //layer=li \
 //thickness=0.1 //x=63.19 //y=0.175 //x2=63.76 //y2=0.175
r1255 (  401 561 ) resistor r=2.87058 //w=0.35 //l=0.085 //layer=li \
 //thickness=0.1 //x=64.01 //y=0.175 //x2=64.095 //y2=0.175
r1256 (  401 404 ) resistor r=8.71935 //w=0.367 //l=0.25 //layer=li \
 //thickness=0.1 //x=64.01 //y=0.175 //x2=63.76 //y2=0.175
r1257 (  396 398 ) resistor r=38.7139 //w=0.367 //l=1.11 //layer=li \
 //thickness=0.1 //x=61.17 //y=0.175 //x2=62.28 //y2=0.175
r1258 (  394 396 ) resistor r=38.7139 //w=0.367 //l=1.11 //layer=li \
 //thickness=0.1 //x=60.06 //y=0.175 //x2=61.17 //y2=0.175
r1259 (  392 559 ) resistor r=2.87058 //w=0.35 //l=0.085 //layer=li \
 //thickness=0.1 //x=59.37 //y=0.175 //x2=59.285 //y2=0.175
r1260 (  392 394 ) resistor r=24.0654 //w=0.367 //l=0.69 //layer=li \
 //thickness=0.1 //x=59.37 //y=0.175 //x2=60.06 //y2=0.175
r1261 (  391 560 ) resistor r=5.29055 //w=0.35 //l=0.17 //layer=li \
 //thickness=0.1 //x=62.85 //y=0.175 //x2=63.02 //y2=0.175
r1262 (  391 398 ) resistor r=19.8801 //w=0.367 //l=0.57 //layer=li \
 //thickness=0.1 //x=62.85 //y=0.175 //x2=62.28 //y2=0.175
r1263 (  387 559 ) resistor r=4.23183 //w=0.7 //l=0.175 //layer=li \
 //thickness=0.1 //x=59.285 //y=0.35 //x2=59.285 //y2=0.175
r1264 (  387 589 ) resistor r=54.4171 //w=0.187 //l=0.795 //layer=li \
 //thickness=0.1 //x=59.285 //y=0.35 //x2=59.285 //y2=1.145
r1265 (  384 558 ) resistor r=5.29055 //w=0.35 //l=0.17 //layer=li \
 //thickness=0.1 //x=58.38 //y=0.175 //x2=58.21 //y2=0.175
r1266 (  384 386 ) resistor r=19.8801 //w=0.367 //l=0.57 //layer=li \
 //thickness=0.1 //x=58.38 //y=0.175 //x2=58.95 //y2=0.175
r1267 (  383 559 ) resistor r=2.87058 //w=0.35 //l=0.085 //layer=li \
 //thickness=0.1 //x=59.2 //y=0.175 //x2=59.285 //y2=0.175
r1268 (  383 386 ) resistor r=8.71935 //w=0.367 //l=0.25 //layer=li \
 //thickness=0.1 //x=59.2 //y=0.175 //x2=58.95 //y2=0.175
r1269 (  378 380 ) resistor r=38.7139 //w=0.367 //l=1.11 //layer=li \
 //thickness=0.1 //x=56.36 //y=0.175 //x2=57.47 //y2=0.175
r1270 (  376 378 ) resistor r=38.7139 //w=0.367 //l=1.11 //layer=li \
 //thickness=0.1 //x=55.25 //y=0.175 //x2=56.36 //y2=0.175
r1271 (  374 557 ) resistor r=2.87058 //w=0.35 //l=0.085 //layer=li \
 //thickness=0.1 //x=54.56 //y=0.175 //x2=54.475 //y2=0.175
r1272 (  374 376 ) resistor r=24.0654 //w=0.367 //l=0.69 //layer=li \
 //thickness=0.1 //x=54.56 //y=0.175 //x2=55.25 //y2=0.175
r1273 (  373 558 ) resistor r=5.29055 //w=0.35 //l=0.17 //layer=li \
 //thickness=0.1 //x=58.04 //y=0.175 //x2=58.21 //y2=0.175
r1274 (  373 380 ) resistor r=19.8801 //w=0.367 //l=0.57 //layer=li \
 //thickness=0.1 //x=58.04 //y=0.175 //x2=57.47 //y2=0.175
r1275 (  369 557 ) resistor r=4.23183 //w=0.7 //l=0.175 //layer=li \
 //thickness=0.1 //x=54.475 //y=0.35 //x2=54.475 //y2=0.175
r1276 (  369 588 ) resistor r=54.4171 //w=0.187 //l=0.795 //layer=li \
 //thickness=0.1 //x=54.475 //y=0.35 //x2=54.475 //y2=1.145
r1277 (  366 556 ) resistor r=5.29055 //w=0.35 //l=0.17 //layer=li \
 //thickness=0.1 //x=53.57 //y=0.175 //x2=53.4 //y2=0.175
r1278 (  366 368 ) resistor r=19.8801 //w=0.367 //l=0.57 //layer=li \
 //thickness=0.1 //x=53.57 //y=0.175 //x2=54.14 //y2=0.175
r1279 (  365 557 ) resistor r=2.87058 //w=0.35 //l=0.085 //layer=li \
 //thickness=0.1 //x=54.39 //y=0.175 //x2=54.475 //y2=0.175
r1280 (  365 368 ) resistor r=8.71935 //w=0.367 //l=0.25 //layer=li \
 //thickness=0.1 //x=54.39 //y=0.175 //x2=54.14 //y2=0.175
r1281 (  360 362 ) resistor r=38.7139 //w=0.367 //l=1.11 //layer=li \
 //thickness=0.1 //x=51.55 //y=0.175 //x2=52.66 //y2=0.175
r1282 (  358 360 ) resistor r=38.7139 //w=0.367 //l=1.11 //layer=li \
 //thickness=0.1 //x=50.44 //y=0.175 //x2=51.55 //y2=0.175
r1283 (  356 555 ) resistor r=2.87058 //w=0.35 //l=0.085 //layer=li \
 //thickness=0.1 //x=49.75 //y=0.175 //x2=49.665 //y2=0.175
r1284 (  356 358 ) resistor r=24.0654 //w=0.367 //l=0.69 //layer=li \
 //thickness=0.1 //x=49.75 //y=0.175 //x2=50.44 //y2=0.175
r1285 (  355 556 ) resistor r=5.29055 //w=0.35 //l=0.17 //layer=li \
 //thickness=0.1 //x=53.23 //y=0.175 //x2=53.4 //y2=0.175
r1286 (  355 362 ) resistor r=19.8801 //w=0.367 //l=0.57 //layer=li \
 //thickness=0.1 //x=53.23 //y=0.175 //x2=52.66 //y2=0.175
r1287 (  351 555 ) resistor r=4.23183 //w=0.7 //l=0.175 //layer=li \
 //thickness=0.1 //x=49.665 //y=0.35 //x2=49.665 //y2=0.175
r1288 (  351 587 ) resistor r=54.4171 //w=0.187 //l=0.795 //layer=li \
 //thickness=0.1 //x=49.665 //y=0.35 //x2=49.665 //y2=1.145
r1289 (  348 554 ) resistor r=5.29055 //w=0.35 //l=0.17 //layer=li \
 //thickness=0.1 //x=48.76 //y=0.175 //x2=48.59 //y2=0.175
r1290 (  348 350 ) resistor r=19.8801 //w=0.367 //l=0.57 //layer=li \
 //thickness=0.1 //x=48.76 //y=0.175 //x2=49.33 //y2=0.175
r1291 (  347 555 ) resistor r=2.87058 //w=0.35 //l=0.085 //layer=li \
 //thickness=0.1 //x=49.58 //y=0.175 //x2=49.665 //y2=0.175
r1292 (  347 350 ) resistor r=8.71935 //w=0.367 //l=0.25 //layer=li \
 //thickness=0.1 //x=49.58 //y=0.175 //x2=49.33 //y2=0.175
r1293 (  342 344 ) resistor r=38.7139 //w=0.367 //l=1.11 //layer=li \
 //thickness=0.1 //x=46.74 //y=0.175 //x2=47.85 //y2=0.175
r1294 (  340 342 ) resistor r=38.7139 //w=0.367 //l=1.11 //layer=li \
 //thickness=0.1 //x=45.63 //y=0.175 //x2=46.74 //y2=0.175
r1295 (  338 553 ) resistor r=2.87058 //w=0.35 //l=0.085 //layer=li \
 //thickness=0.1 //x=44.94 //y=0.175 //x2=44.855 //y2=0.175
r1296 (  338 340 ) resistor r=24.0654 //w=0.367 //l=0.69 //layer=li \
 //thickness=0.1 //x=44.94 //y=0.175 //x2=45.63 //y2=0.175
r1297 (  337 554 ) resistor r=5.29055 //w=0.35 //l=0.17 //layer=li \
 //thickness=0.1 //x=48.42 //y=0.175 //x2=48.59 //y2=0.175
r1298 (  337 344 ) resistor r=19.8801 //w=0.367 //l=0.57 //layer=li \
 //thickness=0.1 //x=48.42 //y=0.175 //x2=47.85 //y2=0.175
r1299 (  333 553 ) resistor r=4.23183 //w=0.7 //l=0.175 //layer=li \
 //thickness=0.1 //x=44.855 //y=0.35 //x2=44.855 //y2=0.175
r1300 (  333 586 ) resistor r=54.4171 //w=0.187 //l=0.795 //layer=li \
 //thickness=0.1 //x=44.855 //y=0.35 //x2=44.855 //y2=1.145
r1301 (  330 552 ) resistor r=5.29055 //w=0.35 //l=0.17 //layer=li \
 //thickness=0.1 //x=43.95 //y=0.175 //x2=43.78 //y2=0.175
r1302 (  330 332 ) resistor r=19.8801 //w=0.367 //l=0.57 //layer=li \
 //thickness=0.1 //x=43.95 //y=0.175 //x2=44.52 //y2=0.175
r1303 (  329 553 ) resistor r=2.87058 //w=0.35 //l=0.085 //layer=li \
 //thickness=0.1 //x=44.77 //y=0.175 //x2=44.855 //y2=0.175
r1304 (  329 332 ) resistor r=8.71935 //w=0.367 //l=0.25 //layer=li \
 //thickness=0.1 //x=44.77 //y=0.175 //x2=44.52 //y2=0.175
r1305 (  324 326 ) resistor r=38.7139 //w=0.367 //l=1.11 //layer=li \
 //thickness=0.1 //x=41.93 //y=0.175 //x2=43.04 //y2=0.175
r1306 (  322 324 ) resistor r=38.7139 //w=0.367 //l=1.11 //layer=li \
 //thickness=0.1 //x=40.82 //y=0.175 //x2=41.93 //y2=0.175
r1307 (  320 551 ) resistor r=2.87058 //w=0.35 //l=0.085 //layer=li \
 //thickness=0.1 //x=40.13 //y=0.175 //x2=40.045 //y2=0.175
r1308 (  320 322 ) resistor r=24.0654 //w=0.367 //l=0.69 //layer=li \
 //thickness=0.1 //x=40.13 //y=0.175 //x2=40.82 //y2=0.175
r1309 (  319 552 ) resistor r=5.29055 //w=0.35 //l=0.17 //layer=li \
 //thickness=0.1 //x=43.61 //y=0.175 //x2=43.78 //y2=0.175
r1310 (  319 326 ) resistor r=19.8801 //w=0.367 //l=0.57 //layer=li \
 //thickness=0.1 //x=43.61 //y=0.175 //x2=43.04 //y2=0.175
r1311 (  315 551 ) resistor r=4.23183 //w=0.7 //l=0.175 //layer=li \
 //thickness=0.1 //x=40.045 //y=0.35 //x2=40.045 //y2=0.175
r1312 (  315 585 ) resistor r=54.4171 //w=0.187 //l=0.795 //layer=li \
 //thickness=0.1 //x=40.045 //y=0.35 //x2=40.045 //y2=1.145
r1313 (  312 550 ) resistor r=5.29055 //w=0.35 //l=0.17 //layer=li \
 //thickness=0.1 //x=39.14 //y=0.175 //x2=38.97 //y2=0.175
r1314 (  312 314 ) resistor r=19.8801 //w=0.367 //l=0.57 //layer=li \
 //thickness=0.1 //x=39.14 //y=0.175 //x2=39.71 //y2=0.175
r1315 (  311 551 ) resistor r=2.87058 //w=0.35 //l=0.085 //layer=li \
 //thickness=0.1 //x=39.96 //y=0.175 //x2=40.045 //y2=0.175
r1316 (  311 314 ) resistor r=8.71935 //w=0.367 //l=0.25 //layer=li \
 //thickness=0.1 //x=39.96 //y=0.175 //x2=39.71 //y2=0.175
r1317 (  306 308 ) resistor r=38.7139 //w=0.367 //l=1.11 //layer=li \
 //thickness=0.1 //x=37.12 //y=0.175 //x2=38.23 //y2=0.175
r1318 (  304 306 ) resistor r=38.7139 //w=0.367 //l=1.11 //layer=li \
 //thickness=0.1 //x=36.01 //y=0.175 //x2=37.12 //y2=0.175
r1319 (  302 549 ) resistor r=2.87058 //w=0.35 //l=0.085 //layer=li \
 //thickness=0.1 //x=35.32 //y=0.175 //x2=35.235 //y2=0.175
r1320 (  302 304 ) resistor r=24.0654 //w=0.367 //l=0.69 //layer=li \
 //thickness=0.1 //x=35.32 //y=0.175 //x2=36.01 //y2=0.175
r1321 (  301 550 ) resistor r=5.29055 //w=0.35 //l=0.17 //layer=li \
 //thickness=0.1 //x=38.8 //y=0.175 //x2=38.97 //y2=0.175
r1322 (  301 308 ) resistor r=19.8801 //w=0.367 //l=0.57 //layer=li \
 //thickness=0.1 //x=38.8 //y=0.175 //x2=38.23 //y2=0.175
r1323 (  297 549 ) resistor r=4.23183 //w=0.7 //l=0.175 //layer=li \
 //thickness=0.1 //x=35.235 //y=0.35 //x2=35.235 //y2=0.175
r1324 (  297 584 ) resistor r=54.4171 //w=0.187 //l=0.795 //layer=li \
 //thickness=0.1 //x=35.235 //y=0.35 //x2=35.235 //y2=1.145
r1325 (  294 548 ) resistor r=5.29055 //w=0.35 //l=0.17 //layer=li \
 //thickness=0.1 //x=34.33 //y=0.175 //x2=34.16 //y2=0.175
r1326 (  294 296 ) resistor r=19.8801 //w=0.367 //l=0.57 //layer=li \
 //thickness=0.1 //x=34.33 //y=0.175 //x2=34.9 //y2=0.175
r1327 (  293 549 ) resistor r=2.87058 //w=0.35 //l=0.085 //layer=li \
 //thickness=0.1 //x=35.15 //y=0.175 //x2=35.235 //y2=0.175
r1328 (  293 296 ) resistor r=8.71935 //w=0.367 //l=0.25 //layer=li \
 //thickness=0.1 //x=35.15 //y=0.175 //x2=34.9 //y2=0.175
r1329 (  288 290 ) resistor r=38.7139 //w=0.367 //l=1.11 //layer=li \
 //thickness=0.1 //x=32.31 //y=0.175 //x2=33.42 //y2=0.175
r1330 (  286 288 ) resistor r=38.7139 //w=0.367 //l=1.11 //layer=li \
 //thickness=0.1 //x=31.2 //y=0.175 //x2=32.31 //y2=0.175
r1331 (  284 547 ) resistor r=2.87058 //w=0.35 //l=0.085 //layer=li \
 //thickness=0.1 //x=30.51 //y=0.175 //x2=30.425 //y2=0.175
r1332 (  284 286 ) resistor r=24.0654 //w=0.367 //l=0.69 //layer=li \
 //thickness=0.1 //x=30.51 //y=0.175 //x2=31.2 //y2=0.175
r1333 (  283 548 ) resistor r=5.29055 //w=0.35 //l=0.17 //layer=li \
 //thickness=0.1 //x=33.99 //y=0.175 //x2=34.16 //y2=0.175
r1334 (  283 290 ) resistor r=19.8801 //w=0.367 //l=0.57 //layer=li \
 //thickness=0.1 //x=33.99 //y=0.175 //x2=33.42 //y2=0.175
r1335 (  279 547 ) resistor r=4.23183 //w=0.7 //l=0.175 //layer=li \
 //thickness=0.1 //x=30.425 //y=0.35 //x2=30.425 //y2=0.175
r1336 (  279 583 ) resistor r=54.4171 //w=0.187 //l=0.795 //layer=li \
 //thickness=0.1 //x=30.425 //y=0.35 //x2=30.425 //y2=1.145
r1337 (  276 546 ) resistor r=5.29055 //w=0.35 //l=0.17 //layer=li \
 //thickness=0.1 //x=29.52 //y=0.175 //x2=29.35 //y2=0.175
r1338 (  276 278 ) resistor r=19.8801 //w=0.367 //l=0.57 //layer=li \
 //thickness=0.1 //x=29.52 //y=0.175 //x2=30.09 //y2=0.175
r1339 (  275 547 ) resistor r=2.87058 //w=0.35 //l=0.085 //layer=li \
 //thickness=0.1 //x=30.34 //y=0.175 //x2=30.425 //y2=0.175
r1340 (  275 278 ) resistor r=8.71935 //w=0.367 //l=0.25 //layer=li \
 //thickness=0.1 //x=30.34 //y=0.175 //x2=30.09 //y2=0.175
r1341 (  270 272 ) resistor r=38.7139 //w=0.367 //l=1.11 //layer=li \
 //thickness=0.1 //x=27.5 //y=0.175 //x2=28.61 //y2=0.175
r1342 (  268 270 ) resistor r=38.7139 //w=0.367 //l=1.11 //layer=li \
 //thickness=0.1 //x=26.39 //y=0.175 //x2=27.5 //y2=0.175
r1343 (  266 545 ) resistor r=2.87058 //w=0.35 //l=0.085 //layer=li \
 //thickness=0.1 //x=25.7 //y=0.175 //x2=25.615 //y2=0.175
r1344 (  266 268 ) resistor r=24.0654 //w=0.367 //l=0.69 //layer=li \
 //thickness=0.1 //x=25.7 //y=0.175 //x2=26.39 //y2=0.175
r1345 (  265 546 ) resistor r=5.29055 //w=0.35 //l=0.17 //layer=li \
 //thickness=0.1 //x=29.18 //y=0.175 //x2=29.35 //y2=0.175
r1346 (  265 272 ) resistor r=19.8801 //w=0.367 //l=0.57 //layer=li \
 //thickness=0.1 //x=29.18 //y=0.175 //x2=28.61 //y2=0.175
r1347 (  261 545 ) resistor r=4.23183 //w=0.7 //l=0.175 //layer=li \
 //thickness=0.1 //x=25.615 //y=0.35 //x2=25.615 //y2=0.175
r1348 (  261 582 ) resistor r=54.4171 //w=0.187 //l=0.795 //layer=li \
 //thickness=0.1 //x=25.615 //y=0.35 //x2=25.615 //y2=1.145
r1349 (  258 544 ) resistor r=5.29055 //w=0.35 //l=0.17 //layer=li \
 //thickness=0.1 //x=24.71 //y=0.175 //x2=24.54 //y2=0.175
r1350 (  258 260 ) resistor r=19.8801 //w=0.367 //l=0.57 //layer=li \
 //thickness=0.1 //x=24.71 //y=0.175 //x2=25.28 //y2=0.175
r1351 (  257 545 ) resistor r=2.87058 //w=0.35 //l=0.085 //layer=li \
 //thickness=0.1 //x=25.53 //y=0.175 //x2=25.615 //y2=0.175
r1352 (  257 260 ) resistor r=8.71935 //w=0.367 //l=0.25 //layer=li \
 //thickness=0.1 //x=25.53 //y=0.175 //x2=25.28 //y2=0.175
r1353 (  252 254 ) resistor r=38.7139 //w=0.367 //l=1.11 //layer=li \
 //thickness=0.1 //x=22.69 //y=0.175 //x2=23.8 //y2=0.175
r1354 (  250 252 ) resistor r=38.7139 //w=0.367 //l=1.11 //layer=li \
 //thickness=0.1 //x=21.58 //y=0.175 //x2=22.69 //y2=0.175
r1355 (  248 543 ) resistor r=2.87058 //w=0.35 //l=0.085 //layer=li \
 //thickness=0.1 //x=20.89 //y=0.175 //x2=20.805 //y2=0.175
r1356 (  248 250 ) resistor r=24.0654 //w=0.367 //l=0.69 //layer=li \
 //thickness=0.1 //x=20.89 //y=0.175 //x2=21.58 //y2=0.175
r1357 (  247 544 ) resistor r=5.29055 //w=0.35 //l=0.17 //layer=li \
 //thickness=0.1 //x=24.37 //y=0.175 //x2=24.54 //y2=0.175
r1358 (  247 254 ) resistor r=19.8801 //w=0.367 //l=0.57 //layer=li \
 //thickness=0.1 //x=24.37 //y=0.175 //x2=23.8 //y2=0.175
r1359 (  243 543 ) resistor r=4.23183 //w=0.7 //l=0.175 //layer=li \
 //thickness=0.1 //x=20.805 //y=0.35 //x2=20.805 //y2=0.175
r1360 (  243 581 ) resistor r=54.4171 //w=0.187 //l=0.795 //layer=li \
 //thickness=0.1 //x=20.805 //y=0.35 //x2=20.805 //y2=1.145
r1361 (  240 542 ) resistor r=5.29055 //w=0.35 //l=0.17 //layer=li \
 //thickness=0.1 //x=19.9 //y=0.175 //x2=19.73 //y2=0.175
r1362 (  240 242 ) resistor r=19.8801 //w=0.367 //l=0.57 //layer=li \
 //thickness=0.1 //x=19.9 //y=0.175 //x2=20.47 //y2=0.175
r1363 (  239 543 ) resistor r=2.87058 //w=0.35 //l=0.085 //layer=li \
 //thickness=0.1 //x=20.72 //y=0.175 //x2=20.805 //y2=0.175
r1364 (  239 242 ) resistor r=8.71935 //w=0.367 //l=0.25 //layer=li \
 //thickness=0.1 //x=20.72 //y=0.175 //x2=20.47 //y2=0.175
r1365 (  234 236 ) resistor r=38.7139 //w=0.367 //l=1.11 //layer=li \
 //thickness=0.1 //x=17.88 //y=0.175 //x2=18.99 //y2=0.175
r1366 (  232 234 ) resistor r=38.7139 //w=0.367 //l=1.11 //layer=li \
 //thickness=0.1 //x=16.77 //y=0.175 //x2=17.88 //y2=0.175
r1367 (  230 541 ) resistor r=2.87058 //w=0.35 //l=0.085 //layer=li \
 //thickness=0.1 //x=16.08 //y=0.175 //x2=15.995 //y2=0.175
r1368 (  230 232 ) resistor r=24.0654 //w=0.367 //l=0.69 //layer=li \
 //thickness=0.1 //x=16.08 //y=0.175 //x2=16.77 //y2=0.175
r1369 (  229 542 ) resistor r=5.29055 //w=0.35 //l=0.17 //layer=li \
 //thickness=0.1 //x=19.56 //y=0.175 //x2=19.73 //y2=0.175
r1370 (  229 236 ) resistor r=19.8801 //w=0.367 //l=0.57 //layer=li \
 //thickness=0.1 //x=19.56 //y=0.175 //x2=18.99 //y2=0.175
r1371 (  225 541 ) resistor r=4.23183 //w=0.7 //l=0.175 //layer=li \
 //thickness=0.1 //x=15.995 //y=0.35 //x2=15.995 //y2=0.175
r1372 (  225 580 ) resistor r=54.4171 //w=0.187 //l=0.795 //layer=li \
 //thickness=0.1 //x=15.995 //y=0.35 //x2=15.995 //y2=1.145
r1373 (  222 540 ) resistor r=5.29055 //w=0.35 //l=0.17 //layer=li \
 //thickness=0.1 //x=15.09 //y=0.175 //x2=14.92 //y2=0.175
r1374 (  222 224 ) resistor r=19.8801 //w=0.367 //l=0.57 //layer=li \
 //thickness=0.1 //x=15.09 //y=0.175 //x2=15.66 //y2=0.175
r1375 (  221 541 ) resistor r=2.87058 //w=0.35 //l=0.085 //layer=li \
 //thickness=0.1 //x=15.91 //y=0.175 //x2=15.995 //y2=0.175
r1376 (  221 224 ) resistor r=8.71935 //w=0.367 //l=0.25 //layer=li \
 //thickness=0.1 //x=15.91 //y=0.175 //x2=15.66 //y2=0.175
r1377 (  216 218 ) resistor r=38.7139 //w=0.367 //l=1.11 //layer=li \
 //thickness=0.1 //x=13.07 //y=0.175 //x2=14.18 //y2=0.175
r1378 (  214 216 ) resistor r=38.7139 //w=0.367 //l=1.11 //layer=li \
 //thickness=0.1 //x=11.96 //y=0.175 //x2=13.07 //y2=0.175
r1379 (  212 539 ) resistor r=2.87058 //w=0.35 //l=0.085 //layer=li \
 //thickness=0.1 //x=11.27 //y=0.175 //x2=11.185 //y2=0.175
r1380 (  212 214 ) resistor r=24.0654 //w=0.367 //l=0.69 //layer=li \
 //thickness=0.1 //x=11.27 //y=0.175 //x2=11.96 //y2=0.175
r1381 (  211 540 ) resistor r=5.29055 //w=0.35 //l=0.17 //layer=li \
 //thickness=0.1 //x=14.75 //y=0.175 //x2=14.92 //y2=0.175
r1382 (  211 218 ) resistor r=19.8801 //w=0.367 //l=0.57 //layer=li \
 //thickness=0.1 //x=14.75 //y=0.175 //x2=14.18 //y2=0.175
r1383 (  207 539 ) resistor r=4.23183 //w=0.7 //l=0.175 //layer=li \
 //thickness=0.1 //x=11.185 //y=0.35 //x2=11.185 //y2=0.175
r1384 (  207 579 ) resistor r=54.4171 //w=0.187 //l=0.795 //layer=li \
 //thickness=0.1 //x=11.185 //y=0.35 //x2=11.185 //y2=1.145
r1385 (  204 538 ) resistor r=5.29055 //w=0.35 //l=0.17 //layer=li \
 //thickness=0.1 //x=10.28 //y=0.175 //x2=10.11 //y2=0.175
r1386 (  204 206 ) resistor r=19.8801 //w=0.367 //l=0.57 //layer=li \
 //thickness=0.1 //x=10.28 //y=0.175 //x2=10.85 //y2=0.175
r1387 (  203 539 ) resistor r=2.87058 //w=0.35 //l=0.085 //layer=li \
 //thickness=0.1 //x=11.1 //y=0.175 //x2=11.185 //y2=0.175
r1388 (  203 206 ) resistor r=8.71935 //w=0.367 //l=0.25 //layer=li \
 //thickness=0.1 //x=11.1 //y=0.175 //x2=10.85 //y2=0.175
r1389 (  198 200 ) resistor r=38.7139 //w=0.367 //l=1.11 //layer=li \
 //thickness=0.1 //x=8.26 //y=0.175 //x2=9.37 //y2=0.175
r1390 (  196 198 ) resistor r=38.7139 //w=0.367 //l=1.11 //layer=li \
 //thickness=0.1 //x=7.15 //y=0.175 //x2=8.26 //y2=0.175
r1391 (  194 537 ) resistor r=2.87058 //w=0.35 //l=0.085 //layer=li \
 //thickness=0.1 //x=6.46 //y=0.175 //x2=6.375 //y2=0.175
r1392 (  194 196 ) resistor r=24.0654 //w=0.367 //l=0.69 //layer=li \
 //thickness=0.1 //x=6.46 //y=0.175 //x2=7.15 //y2=0.175
r1393 (  193 538 ) resistor r=5.29055 //w=0.35 //l=0.17 //layer=li \
 //thickness=0.1 //x=9.94 //y=0.175 //x2=10.11 //y2=0.175
r1394 (  193 200 ) resistor r=19.8801 //w=0.367 //l=0.57 //layer=li \
 //thickness=0.1 //x=9.94 //y=0.175 //x2=9.37 //y2=0.175
r1395 (  189 537 ) resistor r=4.23183 //w=0.7 //l=0.175 //layer=li \
 //thickness=0.1 //x=6.375 //y=0.35 //x2=6.375 //y2=0.175
r1396 (  189 578 ) resistor r=54.4171 //w=0.187 //l=0.795 //layer=li \
 //thickness=0.1 //x=6.375 //y=0.35 //x2=6.375 //y2=1.145
r1397 (  186 536 ) resistor r=5.29055 //w=0.35 //l=0.17 //layer=li \
 //thickness=0.1 //x=5.47 //y=0.175 //x2=5.3 //y2=0.175
r1398 (  186 188 ) resistor r=19.8801 //w=0.367 //l=0.57 //layer=li \
 //thickness=0.1 //x=5.47 //y=0.175 //x2=6.04 //y2=0.175
r1399 (  185 537 ) resistor r=2.87058 //w=0.35 //l=0.085 //layer=li \
 //thickness=0.1 //x=6.29 //y=0.175 //x2=6.375 //y2=0.175
r1400 (  185 188 ) resistor r=8.71935 //w=0.367 //l=0.25 //layer=li \
 //thickness=0.1 //x=6.29 //y=0.175 //x2=6.04 //y2=0.175
r1401 (  180 182 ) resistor r=38.7139 //w=0.367 //l=1.11 //layer=li \
 //thickness=0.1 //x=3.45 //y=0.175 //x2=4.56 //y2=0.175
r1402 (  178 180 ) resistor r=38.7139 //w=0.367 //l=1.11 //layer=li \
 //thickness=0.1 //x=2.34 //y=0.175 //x2=3.45 //y2=0.175
r1403 (  176 535 ) resistor r=2.87058 //w=0.35 //l=0.085 //layer=li \
 //thickness=0.1 //x=1.65 //y=0.175 //x2=1.565 //y2=0.175
r1404 (  176 178 ) resistor r=24.0654 //w=0.367 //l=0.69 //layer=li \
 //thickness=0.1 //x=1.65 //y=0.175 //x2=2.34 //y2=0.175
r1405 (  175 536 ) resistor r=5.29055 //w=0.35 //l=0.17 //layer=li \
 //thickness=0.1 //x=5.13 //y=0.175 //x2=5.3 //y2=0.175
r1406 (  175 182 ) resistor r=19.8801 //w=0.367 //l=0.57 //layer=li \
 //thickness=0.1 //x=5.13 //y=0.175 //x2=4.56 //y2=0.175
r1407 (  171 535 ) resistor r=4.23183 //w=0.7 //l=0.175 //layer=li \
 //thickness=0.1 //x=1.565 //y=0.35 //x2=1.565 //y2=0.175
r1408 (  171 577 ) resistor r=54.4171 //w=0.187 //l=0.795 //layer=li \
 //thickness=0.1 //x=1.565 //y=0.35 //x2=1.565 //y2=1.145
r1409 (  167 535 ) resistor r=2.87058 //w=0.35 //l=0.085 //layer=li \
 //thickness=0.1 //x=1.48 //y=0.175 //x2=1.565 //y2=0.175
r1410 (  167 170 ) resistor r=8.71935 //w=0.367 //l=0.25 //layer=li \
 //thickness=0.1 //x=1.48 //y=0.175 //x2=1.23 //y2=0.175
r1411 (  163 532 ) resistor r=3.1 //w=0.17 //l=0.51 //layer=mcon //count=3 \
 //x=96.32 //y=0.18 //x2=96.32 //y2=0.18
r1412 (  161 530 ) resistor r=3.1 //w=0.17 //l=0.51 //layer=mcon //count=3 \
 //x=95.21 //y=0.18 //x2=95.21 //y2=0.18
r1413 (  161 163 ) resistor r=0.446141 //w=0.311 //l=1.11 //layer=m1 \
 //thickness=0.36 //x=95.21 //y=0.175 //x2=96.32 //y2=0.175
r1414 (  159 522 ) resistor r=3.1 //w=0.17 //l=0.51 //layer=mcon //count=3 \
 //x=94.1 //y=0.18 //x2=94.1 //y2=0.18
r1415 (  159 161 ) resistor r=0.446141 //w=0.311 //l=1.11 //layer=m1 \
 //thickness=0.36 //x=94.1 //y=0.175 //x2=95.21 //y2=0.175
r1416 (  157 516 ) resistor r=3.1 //w=0.17 //l=0.51 //layer=mcon //count=3 \
 //x=92.62 //y=0.18 //x2=92.62 //y2=0.18
r1417 (  157 159 ) resistor r=0.594855 //w=0.311 //l=1.48 //layer=m1 \
 //thickness=0.36 //x=92.62 //y=0.175 //x2=94.1 //y2=0.175
r1418 (  155 574 ) resistor r=3.1 //w=0.17 //l=0.51 //layer=mcon //count=3 \
 //x=91.51 //y=0.18 //x2=91.51 //y2=0.18
r1419 (  155 157 ) resistor r=0.446141 //w=0.311 //l=1.11 //layer=m1 \
 //thickness=0.36 //x=91.51 //y=0.175 //x2=92.62 //y2=0.175
r1420 (  153 504 ) resistor r=3.1 //w=0.17 //l=0.51 //layer=mcon //count=3 \
 //x=90.03 //y=0.18 //x2=90.03 //y2=0.18
r1421 (  153 155 ) resistor r=0.594855 //w=0.311 //l=1.48 //layer=m1 \
 //thickness=0.36 //x=90.03 //y=0.175 //x2=91.51 //y2=0.175
r1422 (  151 502 ) resistor r=3.1 //w=0.17 //l=0.51 //layer=mcon //count=3 \
 //x=88.92 //y=0.18 //x2=88.92 //y2=0.18
r1423 (  151 153 ) resistor r=0.446141 //w=0.311 //l=1.11 //layer=m1 \
 //thickness=0.36 //x=88.92 //y=0.175 //x2=90.03 //y2=0.175
r1424 (  149 494 ) resistor r=3.1 //w=0.17 //l=0.51 //layer=mcon //count=3 \
 //x=87.81 //y=0.18 //x2=87.81 //y2=0.18
r1425 (  149 151 ) resistor r=0.446141 //w=0.311 //l=1.11 //layer=m1 \
 //thickness=0.36 //x=87.81 //y=0.175 //x2=88.92 //y2=0.175
r1426 (  147 488 ) resistor r=3.1 //w=0.17 //l=0.51 //layer=mcon //count=3 \
 //x=86.33 //y=0.18 //x2=86.33 //y2=0.18
r1427 (  147 149 ) resistor r=0.594855 //w=0.311 //l=1.48 //layer=m1 \
 //thickness=0.36 //x=86.33 //y=0.175 //x2=87.81 //y2=0.175
r1428 (  145 486 ) resistor r=3.1 //w=0.17 //l=0.51 //layer=mcon //count=3 \
 //x=85.22 //y=0.18 //x2=85.22 //y2=0.18
r1429 (  145 147 ) resistor r=0.446141 //w=0.311 //l=1.11 //layer=m1 \
 //thickness=0.36 //x=85.22 //y=0.175 //x2=86.33 //y2=0.175
r1430 (  143 484 ) resistor r=3.1 //w=0.17 //l=0.51 //layer=mcon //count=3 \
 //x=84.11 //y=0.18 //x2=84.11 //y2=0.18
r1431 (  143 145 ) resistor r=0.446141 //w=0.311 //l=1.11 //layer=m1 \
 //thickness=0.36 //x=84.11 //y=0.175 //x2=85.22 //y2=0.175
r1432 (  141 476 ) resistor r=3.1 //w=0.17 //l=0.51 //layer=mcon //count=3 \
 //x=83 //y=0.18 //x2=83 //y2=0.18
r1433 (  141 143 ) resistor r=0.446141 //w=0.311 //l=1.11 //layer=m1 \
 //thickness=0.36 //x=83 //y=0.175 //x2=84.11 //y2=0.175
r1434 (  139 470 ) resistor r=3.1 //w=0.17 //l=0.51 //layer=mcon //count=3 \
 //x=81.52 //y=0.18 //x2=81.52 //y2=0.18
r1435 (  139 141 ) resistor r=0.594855 //w=0.311 //l=1.48 //layer=m1 \
 //thickness=0.36 //x=81.52 //y=0.175 //x2=83 //y2=0.175
r1436 (  137 468 ) resistor r=3.1 //w=0.17 //l=0.51 //layer=mcon //count=3 \
 //x=80.41 //y=0.18 //x2=80.41 //y2=0.18
r1437 (  137 139 ) resistor r=0.446141 //w=0.311 //l=1.11 //layer=m1 \
 //thickness=0.36 //x=80.41 //y=0.175 //x2=81.52 //y2=0.175
r1438 (  135 466 ) resistor r=3.1 //w=0.17 //l=0.51 //layer=mcon //count=3 \
 //x=79.3 //y=0.18 //x2=79.3 //y2=0.18
r1439 (  135 137 ) resistor r=0.446141 //w=0.311 //l=1.11 //layer=m1 \
 //thickness=0.36 //x=79.3 //y=0.175 //x2=80.41 //y2=0.175
r1440 (  133 458 ) resistor r=3.1 //w=0.17 //l=0.51 //layer=mcon //count=3 \
 //x=78.19 //y=0.18 //x2=78.19 //y2=0.18
r1441 (  133 135 ) resistor r=0.446141 //w=0.311 //l=1.11 //layer=m1 \
 //thickness=0.36 //x=78.19 //y=0.175 //x2=79.3 //y2=0.175
r1442 (  131 452 ) resistor r=3.1 //w=0.17 //l=0.51 //layer=mcon //count=3 \
 //x=76.71 //y=0.18 //x2=76.71 //y2=0.18
r1443 (  131 133 ) resistor r=0.594855 //w=0.311 //l=1.48 //layer=m1 \
 //thickness=0.36 //x=76.71 //y=0.175 //x2=78.19 //y2=0.175
r1444 (  129 450 ) resistor r=3.1 //w=0.17 //l=0.51 //layer=mcon //count=3 \
 //x=75.6 //y=0.18 //x2=75.6 //y2=0.18
r1445 (  129 131 ) resistor r=0.446141 //w=0.311 //l=1.11 //layer=m1 \
 //thickness=0.36 //x=75.6 //y=0.175 //x2=76.71 //y2=0.175
r1446 (  127 448 ) resistor r=3.1 //w=0.17 //l=0.51 //layer=mcon //count=3 \
 //x=74.49 //y=0.18 //x2=74.49 //y2=0.18
r1447 (  127 129 ) resistor r=0.446141 //w=0.311 //l=1.11 //layer=m1 \
 //thickness=0.36 //x=74.49 //y=0.175 //x2=75.6 //y2=0.175
r1448 (  125 440 ) resistor r=3.1 //w=0.17 //l=0.51 //layer=mcon //count=3 \
 //x=73.38 //y=0.18 //x2=73.38 //y2=0.18
r1449 (  125 127 ) resistor r=0.446141 //w=0.311 //l=1.11 //layer=m1 \
 //thickness=0.36 //x=73.38 //y=0.175 //x2=74.49 //y2=0.175
r1450 (  123 434 ) resistor r=3.1 //w=0.17 //l=0.51 //layer=mcon //count=3 \
 //x=71.9 //y=0.18 //x2=71.9 //y2=0.18
r1451 (  123 125 ) resistor r=0.594855 //w=0.311 //l=1.48 //layer=m1 \
 //thickness=0.36 //x=71.9 //y=0.175 //x2=73.38 //y2=0.175
r1452 (  121 432 ) resistor r=3.1 //w=0.17 //l=0.51 //layer=mcon //count=3 \
 //x=70.79 //y=0.18 //x2=70.79 //y2=0.18
r1453 (  121 123 ) resistor r=0.446141 //w=0.311 //l=1.11 //layer=m1 \
 //thickness=0.36 //x=70.79 //y=0.175 //x2=71.9 //y2=0.175
r1454 (  119 430 ) resistor r=3.1 //w=0.17 //l=0.51 //layer=mcon //count=3 \
 //x=69.68 //y=0.18 //x2=69.68 //y2=0.18
r1455 (  119 121 ) resistor r=0.446141 //w=0.311 //l=1.11 //layer=m1 \
 //thickness=0.36 //x=69.68 //y=0.175 //x2=70.79 //y2=0.175
r1456 (  117 422 ) resistor r=3.1 //w=0.17 //l=0.51 //layer=mcon //count=3 \
 //x=68.57 //y=0.18 //x2=68.57 //y2=0.18
r1457 (  117 119 ) resistor r=0.446141 //w=0.311 //l=1.11 //layer=m1 \
 //thickness=0.36 //x=68.57 //y=0.175 //x2=69.68 //y2=0.175
r1458 (  115 416 ) resistor r=3.1 //w=0.17 //l=0.51 //layer=mcon //count=3 \
 //x=67.09 //y=0.18 //x2=67.09 //y2=0.18
r1459 (  115 117 ) resistor r=0.594855 //w=0.311 //l=1.48 //layer=m1 \
 //thickness=0.36 //x=67.09 //y=0.175 //x2=68.57 //y2=0.175
r1460 (  113 414 ) resistor r=3.1 //w=0.17 //l=0.51 //layer=mcon //count=3 \
 //x=65.98 //y=0.18 //x2=65.98 //y2=0.18
r1461 (  113 115 ) resistor r=0.446141 //w=0.311 //l=1.11 //layer=m1 \
 //thickness=0.36 //x=65.98 //y=0.175 //x2=67.09 //y2=0.175
r1462 (  111 412 ) resistor r=3.1 //w=0.17 //l=0.51 //layer=mcon //count=3 \
 //x=64.87 //y=0.18 //x2=64.87 //y2=0.18
r1463 (  111 113 ) resistor r=0.446141 //w=0.311 //l=1.11 //layer=m1 \
 //thickness=0.36 //x=64.87 //y=0.175 //x2=65.98 //y2=0.175
r1464 (  109 404 ) resistor r=3.1 //w=0.17 //l=0.51 //layer=mcon //count=3 \
 //x=63.76 //y=0.18 //x2=63.76 //y2=0.18
r1465 (  109 111 ) resistor r=0.446141 //w=0.311 //l=1.11 //layer=m1 \
 //thickness=0.36 //x=63.76 //y=0.175 //x2=64.87 //y2=0.175
r1466 (  107 398 ) resistor r=3.1 //w=0.17 //l=0.51 //layer=mcon //count=3 \
 //x=62.28 //y=0.18 //x2=62.28 //y2=0.18
r1467 (  107 109 ) resistor r=0.594855 //w=0.311 //l=1.48 //layer=m1 \
 //thickness=0.36 //x=62.28 //y=0.175 //x2=63.76 //y2=0.175
r1468 (  105 396 ) resistor r=3.1 //w=0.17 //l=0.51 //layer=mcon //count=3 \
 //x=61.17 //y=0.18 //x2=61.17 //y2=0.18
r1469 (  105 107 ) resistor r=0.446141 //w=0.311 //l=1.11 //layer=m1 \
 //thickness=0.36 //x=61.17 //y=0.175 //x2=62.28 //y2=0.175
r1470 (  103 394 ) resistor r=3.1 //w=0.17 //l=0.51 //layer=mcon //count=3 \
 //x=60.06 //y=0.18 //x2=60.06 //y2=0.18
r1471 (  103 105 ) resistor r=0.446141 //w=0.311 //l=1.11 //layer=m1 \
 //thickness=0.36 //x=60.06 //y=0.175 //x2=61.17 //y2=0.175
r1472 (  101 386 ) resistor r=3.1 //w=0.17 //l=0.51 //layer=mcon //count=3 \
 //x=58.95 //y=0.18 //x2=58.95 //y2=0.18
r1473 (  101 103 ) resistor r=0.446141 //w=0.311 //l=1.11 //layer=m1 \
 //thickness=0.36 //x=58.95 //y=0.175 //x2=60.06 //y2=0.175
r1474 (  99 380 ) resistor r=3.1 //w=0.17 //l=0.51 //layer=mcon //count=3 \
 //x=57.47 //y=0.18 //x2=57.47 //y2=0.18
r1475 (  99 101 ) resistor r=0.594855 //w=0.311 //l=1.48 //layer=m1 \
 //thickness=0.36 //x=57.47 //y=0.175 //x2=58.95 //y2=0.175
r1476 (  97 378 ) resistor r=3.1 //w=0.17 //l=0.51 //layer=mcon //count=3 \
 //x=56.36 //y=0.18 //x2=56.36 //y2=0.18
r1477 (  97 99 ) resistor r=0.446141 //w=0.311 //l=1.11 //layer=m1 \
 //thickness=0.36 //x=56.36 //y=0.175 //x2=57.47 //y2=0.175
r1478 (  95 376 ) resistor r=3.1 //w=0.17 //l=0.51 //layer=mcon //count=3 \
 //x=55.25 //y=0.18 //x2=55.25 //y2=0.18
r1479 (  95 97 ) resistor r=0.446141 //w=0.311 //l=1.11 //layer=m1 \
 //thickness=0.36 //x=55.25 //y=0.175 //x2=56.36 //y2=0.175
r1480 (  93 368 ) resistor r=3.1 //w=0.17 //l=0.51 //layer=mcon //count=3 \
 //x=54.14 //y=0.18 //x2=54.14 //y2=0.18
r1481 (  93 95 ) resistor r=0.446141 //w=0.311 //l=1.11 //layer=m1 \
 //thickness=0.36 //x=54.14 //y=0.175 //x2=55.25 //y2=0.175
r1482 (  91 362 ) resistor r=3.1 //w=0.17 //l=0.51 //layer=mcon //count=3 \
 //x=52.66 //y=0.18 //x2=52.66 //y2=0.18
r1483 (  91 93 ) resistor r=0.594855 //w=0.311 //l=1.48 //layer=m1 \
 //thickness=0.36 //x=52.66 //y=0.175 //x2=54.14 //y2=0.175
r1484 (  89 360 ) resistor r=3.1 //w=0.17 //l=0.51 //layer=mcon //count=3 \
 //x=51.55 //y=0.18 //x2=51.55 //y2=0.18
r1485 (  89 91 ) resistor r=0.446141 //w=0.311 //l=1.11 //layer=m1 \
 //thickness=0.36 //x=51.55 //y=0.175 //x2=52.66 //y2=0.175
r1486 (  87 358 ) resistor r=3.1 //w=0.17 //l=0.51 //layer=mcon //count=3 \
 //x=50.44 //y=0.18 //x2=50.44 //y2=0.18
r1487 (  87 89 ) resistor r=0.446141 //w=0.311 //l=1.11 //layer=m1 \
 //thickness=0.36 //x=50.44 //y=0.175 //x2=51.55 //y2=0.175
r1488 (  85 350 ) resistor r=3.1 //w=0.17 //l=0.51 //layer=mcon //count=3 \
 //x=49.33 //y=0.18 //x2=49.33 //y2=0.18
r1489 (  85 87 ) resistor r=0.446141 //w=0.311 //l=1.11 //layer=m1 \
 //thickness=0.36 //x=49.33 //y=0.175 //x2=50.44 //y2=0.175
r1490 (  82 344 ) resistor r=3.1 //w=0.17 //l=0.51 //layer=mcon //count=3 \
 //x=47.85 //y=0.18 //x2=47.85 //y2=0.18
r1491 (  80 342 ) resistor r=3.1 //w=0.17 //l=0.51 //layer=mcon //count=3 \
 //x=46.74 //y=0.18 //x2=46.74 //y2=0.18
r1492 (  80 82 ) resistor r=0.446141 //w=0.311 //l=1.11 //layer=m1 \
 //thickness=0.36 //x=46.74 //y=0.175 //x2=47.85 //y2=0.175
r1493 (  78 340 ) resistor r=3.1 //w=0.17 //l=0.51 //layer=mcon //count=3 \
 //x=45.63 //y=0.18 //x2=45.63 //y2=0.18
r1494 (  78 80 ) resistor r=0.446141 //w=0.311 //l=1.11 //layer=m1 \
 //thickness=0.36 //x=45.63 //y=0.175 //x2=46.74 //y2=0.175
r1495 (  76 332 ) resistor r=3.1 //w=0.17 //l=0.51 //layer=mcon //count=3 \
 //x=44.52 //y=0.18 //x2=44.52 //y2=0.18
r1496 (  76 78 ) resistor r=0.446141 //w=0.311 //l=1.11 //layer=m1 \
 //thickness=0.36 //x=44.52 //y=0.175 //x2=45.63 //y2=0.175
r1497 (  74 326 ) resistor r=3.1 //w=0.17 //l=0.51 //layer=mcon //count=3 \
 //x=43.04 //y=0.18 //x2=43.04 //y2=0.18
r1498 (  74 76 ) resistor r=0.594855 //w=0.311 //l=1.48 //layer=m1 \
 //thickness=0.36 //x=43.04 //y=0.175 //x2=44.52 //y2=0.175
r1499 (  72 324 ) resistor r=3.1 //w=0.17 //l=0.51 //layer=mcon //count=3 \
 //x=41.93 //y=0.18 //x2=41.93 //y2=0.18
r1500 (  72 74 ) resistor r=0.446141 //w=0.311 //l=1.11 //layer=m1 \
 //thickness=0.36 //x=41.93 //y=0.175 //x2=43.04 //y2=0.175
r1501 (  70 322 ) resistor r=3.1 //w=0.17 //l=0.51 //layer=mcon //count=3 \
 //x=40.82 //y=0.18 //x2=40.82 //y2=0.18
r1502 (  70 72 ) resistor r=0.446141 //w=0.311 //l=1.11 //layer=m1 \
 //thickness=0.36 //x=40.82 //y=0.175 //x2=41.93 //y2=0.175
r1503 (  68 314 ) resistor r=3.1 //w=0.17 //l=0.51 //layer=mcon //count=3 \
 //x=39.71 //y=0.18 //x2=39.71 //y2=0.18
r1504 (  68 70 ) resistor r=0.446141 //w=0.311 //l=1.11 //layer=m1 \
 //thickness=0.36 //x=39.71 //y=0.175 //x2=40.82 //y2=0.175
r1505 (  66 308 ) resistor r=3.1 //w=0.17 //l=0.51 //layer=mcon //count=3 \
 //x=38.23 //y=0.18 //x2=38.23 //y2=0.18
r1506 (  66 68 ) resistor r=0.594855 //w=0.311 //l=1.48 //layer=m1 \
 //thickness=0.36 //x=38.23 //y=0.175 //x2=39.71 //y2=0.175
r1507 (  64 306 ) resistor r=3.1 //w=0.17 //l=0.51 //layer=mcon //count=3 \
 //x=37.12 //y=0.18 //x2=37.12 //y2=0.18
r1508 (  64 66 ) resistor r=0.446141 //w=0.311 //l=1.11 //layer=m1 \
 //thickness=0.36 //x=37.12 //y=0.175 //x2=38.23 //y2=0.175
r1509 (  62 304 ) resistor r=3.1 //w=0.17 //l=0.51 //layer=mcon //count=3 \
 //x=36.01 //y=0.18 //x2=36.01 //y2=0.18
r1510 (  62 64 ) resistor r=0.446141 //w=0.311 //l=1.11 //layer=m1 \
 //thickness=0.36 //x=36.01 //y=0.175 //x2=37.12 //y2=0.175
r1511 (  60 296 ) resistor r=3.1 //w=0.17 //l=0.51 //layer=mcon //count=3 \
 //x=34.9 //y=0.18 //x2=34.9 //y2=0.18
r1512 (  60 62 ) resistor r=0.446141 //w=0.311 //l=1.11 //layer=m1 \
 //thickness=0.36 //x=34.9 //y=0.175 //x2=36.01 //y2=0.175
r1513 (  58 290 ) resistor r=3.1 //w=0.17 //l=0.51 //layer=mcon //count=3 \
 //x=33.42 //y=0.18 //x2=33.42 //y2=0.18
r1514 (  58 60 ) resistor r=0.594855 //w=0.311 //l=1.48 //layer=m1 \
 //thickness=0.36 //x=33.42 //y=0.175 //x2=34.9 //y2=0.175
r1515 (  56 288 ) resistor r=3.1 //w=0.17 //l=0.51 //layer=mcon //count=3 \
 //x=32.31 //y=0.18 //x2=32.31 //y2=0.18
r1516 (  56 58 ) resistor r=0.446141 //w=0.311 //l=1.11 //layer=m1 \
 //thickness=0.36 //x=32.31 //y=0.175 //x2=33.42 //y2=0.175
r1517 (  54 286 ) resistor r=3.1 //w=0.17 //l=0.51 //layer=mcon //count=3 \
 //x=31.2 //y=0.18 //x2=31.2 //y2=0.18
r1518 (  54 56 ) resistor r=0.446141 //w=0.311 //l=1.11 //layer=m1 \
 //thickness=0.36 //x=31.2 //y=0.175 //x2=32.31 //y2=0.175
r1519 (  52 278 ) resistor r=3.1 //w=0.17 //l=0.51 //layer=mcon //count=3 \
 //x=30.09 //y=0.18 //x2=30.09 //y2=0.18
r1520 (  52 54 ) resistor r=0.446141 //w=0.311 //l=1.11 //layer=m1 \
 //thickness=0.36 //x=30.09 //y=0.175 //x2=31.2 //y2=0.175
r1521 (  50 272 ) resistor r=3.1 //w=0.17 //l=0.51 //layer=mcon //count=3 \
 //x=28.61 //y=0.18 //x2=28.61 //y2=0.18
r1522 (  50 52 ) resistor r=0.594855 //w=0.311 //l=1.48 //layer=m1 \
 //thickness=0.36 //x=28.61 //y=0.175 //x2=30.09 //y2=0.175
r1523 (  48 270 ) resistor r=3.1 //w=0.17 //l=0.51 //layer=mcon //count=3 \
 //x=27.5 //y=0.18 //x2=27.5 //y2=0.18
r1524 (  48 50 ) resistor r=0.446141 //w=0.311 //l=1.11 //layer=m1 \
 //thickness=0.36 //x=27.5 //y=0.175 //x2=28.61 //y2=0.175
r1525 (  46 268 ) resistor r=3.1 //w=0.17 //l=0.51 //layer=mcon //count=3 \
 //x=26.39 //y=0.18 //x2=26.39 //y2=0.18
r1526 (  46 48 ) resistor r=0.446141 //w=0.311 //l=1.11 //layer=m1 \
 //thickness=0.36 //x=26.39 //y=0.175 //x2=27.5 //y2=0.175
r1527 (  44 260 ) resistor r=3.1 //w=0.17 //l=0.51 //layer=mcon //count=3 \
 //x=25.28 //y=0.18 //x2=25.28 //y2=0.18
r1528 (  44 46 ) resistor r=0.446141 //w=0.311 //l=1.11 //layer=m1 \
 //thickness=0.36 //x=25.28 //y=0.175 //x2=26.39 //y2=0.175
r1529 (  42 254 ) resistor r=3.1 //w=0.17 //l=0.51 //layer=mcon //count=3 \
 //x=23.8 //y=0.18 //x2=23.8 //y2=0.18
r1530 (  42 44 ) resistor r=0.594855 //w=0.311 //l=1.48 //layer=m1 \
 //thickness=0.36 //x=23.8 //y=0.175 //x2=25.28 //y2=0.175
r1531 (  40 252 ) resistor r=3.1 //w=0.17 //l=0.51 //layer=mcon //count=3 \
 //x=22.69 //y=0.18 //x2=22.69 //y2=0.18
r1532 (  40 42 ) resistor r=0.446141 //w=0.311 //l=1.11 //layer=m1 \
 //thickness=0.36 //x=22.69 //y=0.175 //x2=23.8 //y2=0.175
r1533 (  38 250 ) resistor r=3.1 //w=0.17 //l=0.51 //layer=mcon //count=3 \
 //x=21.58 //y=0.18 //x2=21.58 //y2=0.18
r1534 (  38 40 ) resistor r=0.446141 //w=0.311 //l=1.11 //layer=m1 \
 //thickness=0.36 //x=21.58 //y=0.175 //x2=22.69 //y2=0.175
r1535 (  36 242 ) resistor r=3.1 //w=0.17 //l=0.51 //layer=mcon //count=3 \
 //x=20.47 //y=0.18 //x2=20.47 //y2=0.18
r1536 (  36 38 ) resistor r=0.446141 //w=0.311 //l=1.11 //layer=m1 \
 //thickness=0.36 //x=20.47 //y=0.175 //x2=21.58 //y2=0.175
r1537 (  34 236 ) resistor r=3.1 //w=0.17 //l=0.51 //layer=mcon //count=3 \
 //x=18.99 //y=0.18 //x2=18.99 //y2=0.18
r1538 (  34 36 ) resistor r=0.594855 //w=0.311 //l=1.48 //layer=m1 \
 //thickness=0.36 //x=18.99 //y=0.175 //x2=20.47 //y2=0.175
r1539 (  32 234 ) resistor r=3.1 //w=0.17 //l=0.51 //layer=mcon //count=3 \
 //x=17.88 //y=0.18 //x2=17.88 //y2=0.18
r1540 (  32 34 ) resistor r=0.446141 //w=0.311 //l=1.11 //layer=m1 \
 //thickness=0.36 //x=17.88 //y=0.175 //x2=18.99 //y2=0.175
r1541 (  30 232 ) resistor r=3.1 //w=0.17 //l=0.51 //layer=mcon //count=3 \
 //x=16.77 //y=0.18 //x2=16.77 //y2=0.18
r1542 (  30 32 ) resistor r=0.446141 //w=0.311 //l=1.11 //layer=m1 \
 //thickness=0.36 //x=16.77 //y=0.175 //x2=17.88 //y2=0.175
r1543 (  28 224 ) resistor r=3.1 //w=0.17 //l=0.51 //layer=mcon //count=3 \
 //x=15.66 //y=0.18 //x2=15.66 //y2=0.18
r1544 (  28 30 ) resistor r=0.446141 //w=0.311 //l=1.11 //layer=m1 \
 //thickness=0.36 //x=15.66 //y=0.175 //x2=16.77 //y2=0.175
r1545 (  26 218 ) resistor r=3.1 //w=0.17 //l=0.51 //layer=mcon //count=3 \
 //x=14.18 //y=0.18 //x2=14.18 //y2=0.18
r1546 (  26 28 ) resistor r=0.594855 //w=0.311 //l=1.48 //layer=m1 \
 //thickness=0.36 //x=14.18 //y=0.175 //x2=15.66 //y2=0.175
r1547 (  24 216 ) resistor r=3.1 //w=0.17 //l=0.51 //layer=mcon //count=3 \
 //x=13.07 //y=0.18 //x2=13.07 //y2=0.18
r1548 (  24 26 ) resistor r=0.446141 //w=0.311 //l=1.11 //layer=m1 \
 //thickness=0.36 //x=13.07 //y=0.175 //x2=14.18 //y2=0.175
r1549 (  22 214 ) resistor r=3.1 //w=0.17 //l=0.51 //layer=mcon //count=3 \
 //x=11.96 //y=0.18 //x2=11.96 //y2=0.18
r1550 (  22 24 ) resistor r=0.446141 //w=0.311 //l=1.11 //layer=m1 \
 //thickness=0.36 //x=11.96 //y=0.175 //x2=13.07 //y2=0.175
r1551 (  20 206 ) resistor r=3.1 //w=0.17 //l=0.51 //layer=mcon //count=3 \
 //x=10.85 //y=0.18 //x2=10.85 //y2=0.18
r1552 (  20 22 ) resistor r=0.446141 //w=0.311 //l=1.11 //layer=m1 \
 //thickness=0.36 //x=10.85 //y=0.175 //x2=11.96 //y2=0.175
r1553 (  18 200 ) resistor r=3.1 //w=0.17 //l=0.51 //layer=mcon //count=3 \
 //x=9.37 //y=0.18 //x2=9.37 //y2=0.18
r1554 (  18 20 ) resistor r=0.594855 //w=0.311 //l=1.48 //layer=m1 \
 //thickness=0.36 //x=9.37 //y=0.175 //x2=10.85 //y2=0.175
r1555 (  16 198 ) resistor r=3.1 //w=0.17 //l=0.51 //layer=mcon //count=3 \
 //x=8.26 //y=0.18 //x2=8.26 //y2=0.18
r1556 (  16 18 ) resistor r=0.446141 //w=0.311 //l=1.11 //layer=m1 \
 //thickness=0.36 //x=8.26 //y=0.175 //x2=9.37 //y2=0.175
r1557 (  14 196 ) resistor r=3.1 //w=0.17 //l=0.51 //layer=mcon //count=3 \
 //x=7.15 //y=0.18 //x2=7.15 //y2=0.18
r1558 (  14 16 ) resistor r=0.446141 //w=0.311 //l=1.11 //layer=m1 \
 //thickness=0.36 //x=7.15 //y=0.175 //x2=8.26 //y2=0.175
r1559 (  12 188 ) resistor r=3.1 //w=0.17 //l=0.51 //layer=mcon //count=3 \
 //x=6.04 //y=0.18 //x2=6.04 //y2=0.18
r1560 (  12 14 ) resistor r=0.446141 //w=0.311 //l=1.11 //layer=m1 \
 //thickness=0.36 //x=6.04 //y=0.175 //x2=7.15 //y2=0.175
r1561 (  10 182 ) resistor r=3.1 //w=0.17 //l=0.51 //layer=mcon //count=3 \
 //x=4.56 //y=0.18 //x2=4.56 //y2=0.18
r1562 (  10 12 ) resistor r=0.594855 //w=0.311 //l=1.48 //layer=m1 \
 //thickness=0.36 //x=4.56 //y=0.175 //x2=6.04 //y2=0.175
r1563 (  8 180 ) resistor r=3.1 //w=0.17 //l=0.51 //layer=mcon //count=3 \
 //x=3.45 //y=0.18 //x2=3.45 //y2=0.18
r1564 (  8 10 ) resistor r=0.446141 //w=0.311 //l=1.11 //layer=m1 \
 //thickness=0.36 //x=3.45 //y=0.175 //x2=4.56 //y2=0.175
r1565 (  6 178 ) resistor r=3.1 //w=0.17 //l=0.51 //layer=mcon //count=3 \
 //x=2.34 //y=0.18 //x2=2.34 //y2=0.18
r1566 (  6 8 ) resistor r=0.446141 //w=0.311 //l=1.11 //layer=m1 \
 //thickness=0.36 //x=2.34 //y=0.175 //x2=3.45 //y2=0.175
r1567 (  3 170 ) resistor r=3.1 //w=0.17 //l=0.51 //layer=mcon //count=3 \
 //x=1.23 //y=0.18 //x2=1.23 //y2=0.18
r1568 (  3 6 ) resistor r=0.446141 //w=0.311 //l=1.11 //layer=m1 \
 //thickness=0.36 //x=1.23 //y=0.175 //x2=2.34 //y2=0.175
r1569 (  1 85 ) resistor r=0.223071 //w=0.311 //l=0.555 //layer=m1 \
 //thickness=0.36 //x=48.775 //y=0.175 //x2=49.33 //y2=0.175
r1570 (  1 82 ) resistor r=0.371785 //w=0.311 //l=0.925 //layer=m1 \
 //thickness=0.36 //x=48.775 //y=0.175 //x2=47.85 //y2=0.175
ends PM_TMRDFFSNRNQNX1\%GND

subckt PM_TMRDFFSNRNQNX1\%VDD ( 1 163 167 170 177 187 195 205 211 221 231 239 \
 249 255 265 275 283 293 299 309 319 327 337 343 353 363 371 381 387 397 407 \
 415 425 431 441 451 459 469 475 485 495 503 513 519 529 539 547 557 563 573 \
 583 591 601 607 617 627 635 645 651 661 671 679 689 695 705 715 723 733 739 \
 749 759 767 777 783 793 803 811 821 827 837 847 855 865 871 881 891 899 909 \
 915 925 935 943 953 959 967 975 985 991 1006 1013 1018 1023 1028 1033 1038 \
 1043 1048 1053 1058 1063 1068 1073 1078 1083 1088 1093 1098 1103 1104 1105 \
 1106 1107 1108 1109 1110 1111 1112 1113 1114 1115 1116 1117 1118 1119 1120 \
 1121 1122 1123 1124 1125 1126 1127 1128 1129 1130 1131 1132 1133 1134 1135 \
 1136 1137 1138 1139 1140 1141 1142 1143 1144 1145 1146 1147 1148 1149 1150 \
 1151 1152 1153 1154 1155 1156 1157 1158 1159 1160 1161 1162 1163 1164 1165 \
 1166 1167 1168 1169 1170 1171 1172 1173 1174 1175 1176 1177 1178 1179 )
c1158 ( 1179 0 ) capacitor c=0.0476809f //x=89.475 //y=5.205
c1159 ( 1178 0 ) capacitor c=0.0241715f //x=88.595 //y=5.205
c1160 ( 1177 0 ) capacitor c=0.0467094f //x=87.725 //y=5.205
c1161 ( 1176 0 ) capacitor c=0.045218f //x=85.845 //y=5.2
c1162 ( 1175 0 ) capacitor c=0.0241521f //x=84.965 //y=5.2
c1163 ( 1174 0 ) capacitor c=0.0241521f //x=84.085 //y=5.2
c1164 ( 1173 0 ) capacitor c=0.053132f //x=83.215 //y=5.2
c1165 ( 1172 0 ) capacitor c=0.045218f //x=81.035 //y=5.2
c1166 ( 1171 0 ) capacitor c=0.0241521f //x=80.155 //y=5.2
c1167 ( 1170 0 ) capacitor c=0.0241521f //x=79.275 //y=5.2
c1168 ( 1169 0 ) capacitor c=0.053132f //x=78.405 //y=5.2
c1169 ( 1168 0 ) capacitor c=0.045218f //x=76.225 //y=5.2
c1170 ( 1167 0 ) capacitor c=0.0240372f //x=75.345 //y=5.2
c1171 ( 1166 0 ) capacitor c=0.0240372f //x=74.465 //y=5.2
c1172 ( 1165 0 ) capacitor c=0.0530795f //x=73.595 //y=5.2
c1173 ( 1164 0 ) capacitor c=0.0451031f //x=71.415 //y=5.2
c1174 ( 1163 0 ) capacitor c=0.0240372f //x=70.535 //y=5.2
c1175 ( 1162 0 ) capacitor c=0.0240372f //x=69.655 //y=5.2
c1176 ( 1161 0 ) capacitor c=0.0530795f //x=68.785 //y=5.2
c1177 ( 1160 0 ) capacitor c=0.0451031f //x=66.605 //y=5.2
c1178 ( 1159 0 ) capacitor c=0.0240372f //x=65.725 //y=5.2
c1179 ( 1158 0 ) capacitor c=0.0240372f //x=64.845 //y=5.2
c1180 ( 1157 0 ) capacitor c=0.0530795f //x=63.975 //y=5.2
c1181 ( 1156 0 ) capacitor c=0.0451031f //x=61.795 //y=5.2
c1182 ( 1155 0 ) capacitor c=0.0240372f //x=60.915 //y=5.2
c1183 ( 1154 0 ) capacitor c=0.0240372f //x=60.035 //y=5.2
c1184 ( 1153 0 ) capacitor c=0.0530795f //x=59.165 //y=5.2
c1185 ( 1152 0 ) capacitor c=0.0451031f //x=56.985 //y=5.2
c1186 ( 1151 0 ) capacitor c=0.0240372f //x=56.105 //y=5.2
c1187 ( 1150 0 ) capacitor c=0.0240372f //x=55.225 //y=5.2
c1188 ( 1149 0 ) capacitor c=0.0530795f //x=54.355 //y=5.2
c1189 ( 1148 0 ) capacitor c=0.0451031f //x=52.175 //y=5.2
c1190 ( 1147 0 ) capacitor c=0.0240372f //x=51.295 //y=5.2
c1191 ( 1146 0 ) capacitor c=0.0240372f //x=50.415 //y=5.2
c1192 ( 1145 0 ) capacitor c=0.0530795f //x=49.545 //y=5.2
c1193 ( 1144 0 ) capacitor c=0.0451031f //x=47.365 //y=5.2
c1194 ( 1143 0 ) capacitor c=0.0240372f //x=46.485 //y=5.2
c1195 ( 1142 0 ) capacitor c=0.0240372f //x=45.605 //y=5.2
c1196 ( 1141 0 ) capacitor c=0.0530795f //x=44.735 //y=5.2
c1197 ( 1140 0 ) capacitor c=0.0451031f //x=42.555 //y=5.2
c1198 ( 1139 0 ) capacitor c=0.0240372f //x=41.675 //y=5.2
c1199 ( 1138 0 ) capacitor c=0.0240372f //x=40.795 //y=5.2
c1200 ( 1137 0 ) capacitor c=0.0530795f //x=39.925 //y=5.2
c1201 ( 1136 0 ) capacitor c=0.0451031f //x=37.745 //y=5.2
c1202 ( 1135 0 ) capacitor c=0.0240372f //x=36.865 //y=5.2
c1203 ( 1134 0 ) capacitor c=0.0240372f //x=35.985 //y=5.2
c1204 ( 1133 0 ) capacitor c=0.0530795f //x=35.115 //y=5.2
c1205 ( 1132 0 ) capacitor c=0.0451031f //x=32.935 //y=5.2
c1206 ( 1131 0 ) capacitor c=0.0240372f //x=32.055 //y=5.2
c1207 ( 1130 0 ) capacitor c=0.0240372f //x=31.175 //y=5.2
c1208 ( 1129 0 ) capacitor c=0.0530795f //x=30.305 //y=5.2
c1209 ( 1128 0 ) capacitor c=0.0451031f //x=28.125 //y=5.2
c1210 ( 1127 0 ) capacitor c=0.0240372f //x=27.245 //y=5.2
c1211 ( 1126 0 ) capacitor c=0.0240372f //x=26.365 //y=5.2
c1212 ( 1125 0 ) capacitor c=0.0530795f //x=25.495 //y=5.2
c1213 ( 1124 0 ) capacitor c=0.045218f //x=23.315 //y=5.2
c1214 ( 1123 0 ) capacitor c=0.0241521f //x=22.435 //y=5.2
c1215 ( 1122 0 ) capacitor c=0.0241521f //x=21.555 //y=5.2
c1216 ( 1121 0 ) capacitor c=0.053132f //x=20.685 //y=5.2
c1217 ( 1120 0 ) capacitor c=0.045218f //x=18.505 //y=5.2
c1218 ( 1119 0 ) capacitor c=0.0241521f //x=17.625 //y=5.2
c1219 ( 1118 0 ) capacitor c=0.0241521f //x=16.745 //y=5.2
c1220 ( 1117 0 ) capacitor c=0.053132f //x=15.875 //y=5.2
c1221 ( 1116 0 ) capacitor c=0.045218f //x=13.695 //y=5.2
c1222 ( 1115 0 ) capacitor c=0.0241521f //x=12.815 //y=5.2
c1223 ( 1114 0 ) capacitor c=0.0241521f //x=11.935 //y=5.2
c1224 ( 1113 0 ) capacitor c=0.053132f //x=11.065 //y=5.2
c1225 ( 1112 0 ) capacitor c=0.045218f //x=8.885 //y=5.2
c1226 ( 1111 0 ) capacitor c=0.0241521f //x=8.005 //y=5.2
c1227 ( 1110 0 ) capacitor c=0.0242401f //x=7.125 //y=5.2
c1228 ( 1109 0 ) capacitor c=0.0531794f //x=6.255 //y=5.2
c1229 ( 1108 0 ) capacitor c=0.045306f //x=4.075 //y=5.2
c1230 ( 1107 0 ) capacitor c=0.0242401f //x=3.195 //y=5.2
c1231 ( 1106 0 ) capacitor c=0.0242401f //x=2.315 //y=5.2
c1232 ( 1105 0 ) capacitor c=0.0531407f //x=1.445 //y=5.2
c1233 ( 1104 0 ) capacitor c=0.113453f //x=93.73 //y=7.585
c1234 ( 1103 0 ) capacitor c=0.121512f //x=90.4 //y=7.585
c1235 ( 1102 0 ) capacitor c=0.00597439f //x=89.62 //y=7.585
c1236 ( 1101 0 ) capacitor c=0.00597439f //x=88.74 //y=7.585
c1237 ( 1100 0 ) capacitor c=0.00597439f //x=87.81 //y=7.58
c1238 ( 1098 0 ) capacitor c=0.133098f //x=87.07 //y=7.585
c1239 ( 1097 0 ) capacitor c=0.00597439f //x=85.99 //y=7.585
c1240 ( 1096 0 ) capacitor c=0.00597439f //x=85.11 //y=7.585
c1241 ( 1095 0 ) capacitor c=0.00597439f //x=84.23 //y=7.585
c1242 ( 1094 0 ) capacitor c=0.00597439f //x=83.35 //y=7.585
c1243 ( 1093 0 ) capacitor c=0.15536f //x=82.26 //y=7.585
c1244 ( 1092 0 ) capacitor c=0.00597439f //x=81.18 //y=7.585
c1245 ( 1091 0 ) capacitor c=0.00597439f //x=80.3 //y=7.585
c1246 ( 1090 0 ) capacitor c=0.00597439f //x=79.42 //y=7.585
c1247 ( 1089 0 ) capacitor c=0.00597439f //x=78.54 //y=7.585
c1248 ( 1088 0 ) capacitor c=0.15481f //x=77.45 //y=7.585
c1249 ( 1087 0 ) capacitor c=0.00597439f //x=76.37 //y=7.585
c1250 ( 1086 0 ) capacitor c=0.00597439f //x=75.49 //y=7.585
c1251 ( 1085 0 ) capacitor c=0.00597439f //x=74.61 //y=7.585
c1252 ( 1084 0 ) capacitor c=0.00597439f //x=73.73 //y=7.585
c1253 ( 1083 0 ) capacitor c=0.153845f //x=72.64 //y=7.585
c1254 ( 1082 0 ) capacitor c=0.00597439f //x=71.56 //y=7.585
c1255 ( 1081 0 ) capacitor c=0.00597439f //x=70.68 //y=7.585
c1256 ( 1080 0 ) capacitor c=0.00597439f //x=69.8 //y=7.585
c1257 ( 1079 0 ) capacitor c=0.00597439f //x=68.92 //y=7.585
c1258 ( 1078 0 ) capacitor c=0.153927f //x=67.83 //y=7.585
c1259 ( 1077 0 ) capacitor c=0.00597439f //x=66.75 //y=7.585
c1260 ( 1076 0 ) capacitor c=0.00597439f //x=65.87 //y=7.585
c1261 ( 1075 0 ) capacitor c=0.00597439f //x=64.99 //y=7.585
c1262 ( 1074 0 ) capacitor c=0.00597439f //x=64.11 //y=7.585
c1263 ( 1073 0 ) capacitor c=0.158415f //x=63.02 //y=7.585
c1264 ( 1072 0 ) capacitor c=0.00597439f //x=61.94 //y=7.585
c1265 ( 1071 0 ) capacitor c=0.00597439f //x=61.06 //y=7.585
c1266 ( 1070 0 ) capacitor c=0.00597439f //x=60.18 //y=7.585
c1267 ( 1069 0 ) capacitor c=0.00597439f //x=59.3 //y=7.585
c1268 ( 1068 0 ) capacitor c=0.153864f //x=58.21 //y=7.585
c1269 ( 1067 0 ) capacitor c=0.00597439f //x=57.13 //y=7.585
c1270 ( 1066 0 ) capacitor c=0.00597439f //x=56.25 //y=7.585
c1271 ( 1065 0 ) capacitor c=0.00597439f //x=55.37 //y=7.585
c1272 ( 1064 0 ) capacitor c=0.00597439f //x=54.49 //y=7.585
c1273 ( 1063 0 ) capacitor c=0.153973f //x=53.4 //y=7.585
c1274 ( 1062 0 ) capacitor c=0.00597439f //x=52.32 //y=7.585
c1275 ( 1061 0 ) capacitor c=0.00597439f //x=51.44 //y=7.585
c1276 ( 1060 0 ) capacitor c=0.00597439f //x=50.56 //y=7.585
c1277 ( 1059 0 ) capacitor c=0.00597439f //x=49.68 //y=7.585
c1278 ( 1058 0 ) capacitor c=0.153927f //x=48.59 //y=7.585
c1279 ( 1057 0 ) capacitor c=0.00597439f //x=47.51 //y=7.585
c1280 ( 1056 0 ) capacitor c=0.00597439f //x=46.63 //y=7.585
c1281 ( 1055 0 ) capacitor c=0.00597439f //x=45.75 //y=7.585
c1282 ( 1054 0 ) capacitor c=0.00597439f //x=44.87 //y=7.585
c1283 ( 1053 0 ) capacitor c=0.153903f //x=43.78 //y=7.585
c1284 ( 1052 0 ) capacitor c=0.00597439f //x=42.7 //y=7.585
c1285 ( 1051 0 ) capacitor c=0.00597439f //x=41.82 //y=7.585
c1286 ( 1050 0 ) capacitor c=0.00597439f //x=40.94 //y=7.585
c1287 ( 1049 0 ) capacitor c=0.00597439f //x=40.06 //y=7.585
c1288 ( 1048 0 ) capacitor c=0.153927f //x=38.97 //y=7.585
c1289 ( 1047 0 ) capacitor c=0.00597439f //x=37.89 //y=7.585
c1290 ( 1046 0 ) capacitor c=0.00597439f //x=37.01 //y=7.585
c1291 ( 1045 0 ) capacitor c=0.00597439f //x=36.13 //y=7.585
c1292 ( 1044 0 ) capacitor c=0.00597439f //x=35.25 //y=7.585
c1293 ( 1043 0 ) capacitor c=0.15408f //x=34.16 //y=7.585
c1294 ( 1042 0 ) capacitor c=0.00597439f //x=33.08 //y=7.585
c1295 ( 1041 0 ) capacitor c=0.00597439f //x=32.2 //y=7.585
c1296 ( 1040 0 ) capacitor c=0.00597439f //x=31.32 //y=7.585
c1297 ( 1039 0 ) capacitor c=0.00597439f //x=30.44 //y=7.585
c1298 ( 1038 0 ) capacitor c=0.154178f //x=29.35 //y=7.585
c1299 ( 1037 0 ) capacitor c=0.00597439f //x=28.27 //y=7.585
c1300 ( 1036 0 ) capacitor c=0.00597439f //x=27.39 //y=7.585
c1301 ( 1035 0 ) capacitor c=0.00597439f //x=26.51 //y=7.585
c1302 ( 1034 0 ) capacitor c=0.00597439f //x=25.63 //y=7.585
c1303 ( 1033 0 ) capacitor c=0.153756f //x=24.54 //y=7.585
c1304 ( 1032 0 ) capacitor c=0.00597439f //x=23.46 //y=7.585
c1305 ( 1031 0 ) capacitor c=0.00597439f //x=22.58 //y=7.585
c1306 ( 1030 0 ) capacitor c=0.00597439f //x=21.7 //y=7.585
c1307 ( 1029 0 ) capacitor c=0.00597439f //x=20.82 //y=7.585
c1308 ( 1028 0 ) capacitor c=0.155314f //x=19.73 //y=7.585
c1309 ( 1027 0 ) capacitor c=0.00597439f //x=18.65 //y=7.585
c1310 ( 1026 0 ) capacitor c=0.00597439f //x=17.77 //y=7.585
c1311 ( 1025 0 ) capacitor c=0.00597439f //x=16.89 //y=7.585
c1312 ( 1024 0 ) capacitor c=0.00597439f //x=16.01 //y=7.585
c1313 ( 1023 0 ) capacitor c=0.15529f //x=14.92 //y=7.585
c1314 ( 1022 0 ) capacitor c=0.00597439f //x=13.84 //y=7.585
c1315 ( 1021 0 ) capacitor c=0.00597439f //x=12.96 //y=7.585
c1316 ( 1020 0 ) capacitor c=0.00597439f //x=12.08 //y=7.585
c1317 ( 1019 0 ) capacitor c=0.00597439f //x=11.2 //y=7.585
c1318 ( 1018 0 ) capacitor c=0.155314f //x=10.11 //y=7.585
c1319 ( 1017 0 ) capacitor c=0.00597439f //x=9.03 //y=7.585
c1320 ( 1016 0 ) capacitor c=0.00597439f //x=8.15 //y=7.585
c1321 ( 1015 0 ) capacitor c=0.00597439f //x=7.27 //y=7.585
c1322 ( 1014 0 ) capacitor c=0.00597439f //x=6.39 //y=7.585
c1323 ( 1013 0 ) capacitor c=0.157412f //x=5.3 //y=7.585
c1324 ( 1012 0 ) capacitor c=0.00597439f //x=4.22 //y=7.585
c1325 ( 1011 0 ) capacitor c=0.00597439f //x=3.34 //y=7.585
c1326 ( 1010 0 ) capacitor c=0.00597439f //x=2.46 //y=7.585
c1327 ( 1009 0 ) capacitor c=0.00597439f //x=1.58 //y=7.585
c1328 ( 1006 0 ) capacitor c=0.35302f //x=96.32 //y=7.58
c1329 ( 991 0 ) capacitor c=0.122102f //x=93.56 //y=7.585
c1330 ( 985 0 ) capacitor c=0.0238235f //x=90.23 //y=7.585
c1331 ( 975 0 ) capacitor c=0.0288071f //x=89.535 //y=7.585
c1332 ( 967 0 ) capacitor c=0.0287754f //x=88.655 //y=7.585
c1333 ( 959 0 ) capacitor c=0.024303f //x=87.775 //y=7.585
c1334 ( 953 0 ) capacitor c=0.0397734f //x=86.9 //y=7.585
c1335 ( 943 0 ) capacitor c=0.0291138f //x=85.905 //y=7.585
c1336 ( 935 0 ) capacitor c=0.0290172f //x=85.025 //y=7.585
c1337 ( 925 0 ) capacitor c=0.0287649f //x=84.145 //y=7.585
c1338 ( 915 0 ) capacitor c=0.0386886f //x=83.265 //y=7.585
c1339 ( 909 0 ) capacitor c=0.0397734f //x=82.09 //y=7.585
c1340 ( 899 0 ) capacitor c=0.0291138f //x=81.095 //y=7.585
c1341 ( 891 0 ) capacitor c=0.0290172f //x=80.215 //y=7.585
c1342 ( 881 0 ) capacitor c=0.0287649f //x=79.335 //y=7.585
c1343 ( 871 0 ) capacitor c=0.0386886f //x=78.455 //y=7.585
c1344 ( 865 0 ) capacitor c=0.0397734f //x=77.28 //y=7.585
c1345 ( 855 0 ) capacitor c=0.0291116f //x=76.285 //y=7.585
c1346 ( 847 0 ) capacitor c=0.0289898f //x=75.405 //y=7.585
c1347 ( 837 0 ) capacitor c=0.0287487f //x=74.525 //y=7.585
c1348 ( 827 0 ) capacitor c=0.0386886f //x=73.645 //y=7.585
c1349 ( 821 0 ) capacitor c=0.0397093f //x=72.47 //y=7.585
c1350 ( 811 0 ) capacitor c=0.0290822f //x=71.475 //y=7.585
c1351 ( 803 0 ) capacitor c=0.0289898f //x=70.595 //y=7.585
c1352 ( 793 0 ) capacitor c=0.0287487f //x=69.715 //y=7.585
c1353 ( 783 0 ) capacitor c=0.0386886f //x=68.835 //y=7.585
c1354 ( 777 0 ) capacitor c=0.0397093f //x=67.66 //y=7.585
c1355 ( 767 0 ) capacitor c=0.0290822f //x=66.665 //y=7.585
c1356 ( 759 0 ) capacitor c=0.0289898f //x=65.785 //y=7.585
c1357 ( 749 0 ) capacitor c=0.0287487f //x=64.905 //y=7.585
c1358 ( 739 0 ) capacitor c=0.0386886f //x=64.025 //y=7.585
c1359 ( 733 0 ) capacitor c=0.0397093f //x=62.85 //y=7.585
c1360 ( 723 0 ) capacitor c=0.0290822f //x=61.855 //y=7.585
c1361 ( 715 0 ) capacitor c=0.0289898f //x=60.975 //y=7.585
c1362 ( 705 0 ) capacitor c=0.0287487f //x=60.095 //y=7.585
c1363 ( 695 0 ) capacitor c=0.0386886f //x=59.215 //y=7.585
c1364 ( 689 0 ) capacitor c=0.0397093f //x=58.04 //y=7.585
c1365 ( 679 0 ) capacitor c=0.0290822f //x=57.045 //y=7.585
c1366 ( 671 0 ) capacitor c=0.0289898f //x=56.165 //y=7.585
c1367 ( 661 0 ) capacitor c=0.0287487f //x=55.285 //y=7.585
c1368 ( 651 0 ) capacitor c=0.0386886f //x=54.405 //y=7.585
c1369 ( 645 0 ) capacitor c=0.0397093f //x=53.23 //y=7.585
c1370 ( 635 0 ) capacitor c=0.0290822f //x=52.235 //y=7.585
c1371 ( 627 0 ) capacitor c=0.0289898f //x=51.355 //y=7.585
c1372 ( 617 0 ) capacitor c=0.0287487f //x=50.475 //y=7.585
c1373 ( 607 0 ) capacitor c=0.0386886f //x=49.595 //y=7.585
c1374 ( 601 0 ) capacitor c=0.0397093f //x=48.42 //y=7.585
c1375 ( 591 0 ) capacitor c=0.0290822f //x=47.425 //y=7.585
c1376 ( 583 0 ) capacitor c=0.0289898f //x=46.545 //y=7.585
c1377 ( 573 0 ) capacitor c=0.0287487f //x=45.665 //y=7.585
c1378 ( 563 0 ) capacitor c=0.0386886f //x=44.785 //y=7.585
c1379 ( 557 0 ) capacitor c=0.0397093f //x=43.61 //y=7.585
c1380 ( 547 0 ) capacitor c=0.0290822f //x=42.615 //y=7.585
c1381 ( 539 0 ) capacitor c=0.0289898f //x=41.735 //y=7.585
c1382 ( 529 0 ) capacitor c=0.0287487f //x=40.855 //y=7.585
c1383 ( 519 0 ) capacitor c=0.0386886f //x=39.975 //y=7.585
c1384 ( 513 0 ) capacitor c=0.0397093f //x=38.8 //y=7.585
c1385 ( 503 0 ) capacitor c=0.0290822f //x=37.805 //y=7.585
c1386 ( 495 0 ) capacitor c=0.0289898f //x=36.925 //y=7.585
c1387 ( 485 0 ) capacitor c=0.0287487f //x=36.045 //y=7.585
c1388 ( 475 0 ) capacitor c=0.0386886f //x=35.165 //y=7.585
c1389 ( 469 0 ) capacitor c=0.0397093f //x=33.99 //y=7.585
c1390 ( 459 0 ) capacitor c=0.0290822f //x=32.995 //y=7.585
c1391 ( 451 0 ) capacitor c=0.0289898f //x=32.115 //y=7.585
c1392 ( 441 0 ) capacitor c=0.0287487f //x=31.235 //y=7.585
c1393 ( 431 0 ) capacitor c=0.0386886f //x=30.355 //y=7.585
c1394 ( 425 0 ) capacitor c=0.0397093f //x=29.18 //y=7.585
c1395 ( 415 0 ) capacitor c=0.0290822f //x=28.185 //y=7.585
c1396 ( 407 0 ) capacitor c=0.0289898f //x=27.305 //y=7.585
c1397 ( 397 0 ) capacitor c=0.0287487f //x=26.425 //y=7.585
c1398 ( 387 0 ) capacitor c=0.0386886f //x=25.545 //y=7.585
c1399 ( 381 0 ) capacitor c=0.0397187f //x=24.37 //y=7.585
c1400 ( 371 0 ) capacitor c=0.0291138f //x=23.375 //y=7.585
c1401 ( 363 0 ) capacitor c=0.0290172f //x=22.495 //y=7.585
c1402 ( 353 0 ) capacitor c=0.0287649f //x=21.615 //y=7.585
c1403 ( 343 0 ) capacitor c=0.0386886f //x=20.735 //y=7.585
c1404 ( 337 0 ) capacitor c=0.0397734f //x=19.56 //y=7.585
c1405 ( 327 0 ) capacitor c=0.0291138f //x=18.565 //y=7.585
c1406 ( 319 0 ) capacitor c=0.0290163f //x=17.685 //y=7.585
c1407 ( 309 0 ) capacitor c=0.0287649f //x=16.805 //y=7.585
c1408 ( 299 0 ) capacitor c=0.0386886f //x=15.925 //y=7.585
c1409 ( 293 0 ) capacitor c=0.0397734f //x=14.75 //y=7.585
c1410 ( 283 0 ) capacitor c=0.0291138f //x=13.755 //y=7.585
c1411 ( 275 0 ) capacitor c=0.0290172f //x=12.875 //y=7.585
c1412 ( 265 0 ) capacitor c=0.0287649f //x=11.995 //y=7.585
c1413 ( 255 0 ) capacitor c=0.0386886f //x=11.115 //y=7.585
c1414 ( 249 0 ) capacitor c=0.0397734f //x=9.94 //y=7.585
c1415 ( 239 0 ) capacitor c=0.0291138f //x=8.945 //y=7.585
c1416 ( 231 0 ) capacitor c=0.0290163f //x=8.065 //y=7.585
c1417 ( 221 0 ) capacitor c=0.0287792f //x=7.185 //y=7.585
c1418 ( 211 0 ) capacitor c=0.0386886f //x=6.305 //y=7.585
c1419 ( 205 0 ) capacitor c=0.0398302f //x=5.13 //y=7.585
c1420 ( 195 0 ) capacitor c=0.0291418f //x=4.135 //y=7.585
c1421 ( 187 0 ) capacitor c=0.0290414f //x=3.255 //y=7.585
c1422 ( 177 0 ) capacitor c=0.0287792f //x=2.375 //y=7.585
c1423 ( 170 0 ) capacitor c=0.253398f //x=1.23 //y=7.58
c1424 ( 167 0 ) capacitor c=0.0445047f //x=1.495 //y=7.585
c1425 ( 163 0 ) capacitor c=3.2208f //x=96.32 //y=7.58
r1426 (  1004 1006 ) resistor r=38.7139 //w=0.367 //l=1.11 //layer=li \
 //thickness=0.1 //x=95.21 //y=7.585 //x2=96.32 //y2=7.585
r1427 (  1002 1004 ) resistor r=38.7139 //w=0.367 //l=1.11 //layer=li \
 //thickness=0.1 //x=94.1 //y=7.585 //x2=95.21 //y2=7.585
r1428 (  1000 1104 ) resistor r=5.29055 //w=0.35 //l=0.17 //layer=li \
 //thickness=0.1 //x=93.9 //y=7.585 //x2=93.73 //y2=7.585
r1429 (  1000 1002 ) resistor r=6.97548 //w=0.367 //l=0.2 //layer=li \
 //thickness=0.1 //x=93.9 //y=7.585 //x2=94.1 //y2=7.585
r1430 (  994 996 ) resistor r=38.7139 //w=0.367 //l=1.11 //layer=li \
 //thickness=0.1 //x=91.51 //y=7.585 //x2=92.62 //y2=7.585
r1431 (  992 1103 ) resistor r=5.29055 //w=0.35 //l=0.17 //layer=li \
 //thickness=0.1 //x=90.57 //y=7.585 //x2=90.4 //y2=7.585
r1432 (  992 994 ) resistor r=32.7847 //w=0.367 //l=0.94 //layer=li \
 //thickness=0.1 //x=90.57 //y=7.585 //x2=91.51 //y2=7.585
r1433 (  991 1104 ) resistor r=5.29055 //w=0.35 //l=0.17 //layer=li \
 //thickness=0.1 //x=93.56 //y=7.585 //x2=93.73 //y2=7.585
r1434 (  991 996 ) resistor r=32.7847 //w=0.367 //l=0.94 //layer=li \
 //thickness=0.1 //x=93.56 //y=7.585 //x2=92.62 //y2=7.585
r1435 (  986 1102 ) resistor r=2.87058 //w=0.35 //l=0.085 //layer=li \
 //thickness=0.1 //x=89.705 //y=7.585 //x2=89.62 //y2=7.585
r1436 (  986 988 ) resistor r=11.3351 //w=0.367 //l=0.325 //layer=li \
 //thickness=0.1 //x=89.705 //y=7.585 //x2=90.03 //y2=7.585
r1437 (  985 1103 ) resistor r=5.29055 //w=0.35 //l=0.17 //layer=li \
 //thickness=0.1 //x=90.23 //y=7.585 //x2=90.4 //y2=7.585
r1438 (  985 988 ) resistor r=6.97548 //w=0.367 //l=0.2 //layer=li \
 //thickness=0.1 //x=90.23 //y=7.585 //x2=90.03 //y2=7.585
r1439 (  979 1102 ) resistor r=4.23183 //w=0.7 //l=0.175 //layer=li \
 //thickness=0.1 //x=89.62 //y=7.41 //x2=89.62 //y2=7.585
r1440 (  979 1179 ) resistor r=56.8128 //w=0.187 //l=0.83 //layer=li \
 //thickness=0.1 //x=89.62 //y=7.41 //x2=89.62 //y2=6.58
r1441 (  976 1101 ) resistor r=2.87058 //w=0.35 //l=0.085 //layer=li \
 //thickness=0.1 //x=88.825 //y=7.585 //x2=88.74 //y2=7.585
r1442 (  976 978 ) resistor r=3.31335 //w=0.367 //l=0.095 //layer=li \
 //thickness=0.1 //x=88.825 //y=7.585 //x2=88.92 //y2=7.585
r1443 (  975 1102 ) resistor r=2.87058 //w=0.35 //l=0.085 //layer=li \
 //thickness=0.1 //x=89.535 //y=7.585 //x2=89.62 //y2=7.585
r1444 (  975 978 ) resistor r=21.4496 //w=0.367 //l=0.615 //layer=li \
 //thickness=0.1 //x=89.535 //y=7.585 //x2=88.92 //y2=7.585
r1445 (  969 1101 ) resistor r=4.23183 //w=0.7 //l=0.175 //layer=li \
 //thickness=0.1 //x=88.74 //y=7.41 //x2=88.74 //y2=7.585
r1446 (  969 1178 ) resistor r=33.5401 //w=0.187 //l=0.49 //layer=li \
 //thickness=0.1 //x=88.74 //y=7.41 //x2=88.74 //y2=6.92
r1447 (  968 1100 ) resistor r=2.87058 //w=0.35 //l=0.085 //layer=li \
 //thickness=0.1 //x=87.945 //y=7.585 //x2=87.86 //y2=7.585
r1448 (  967 1101 ) resistor r=2.87058 //w=0.35 //l=0.085 //layer=li \
 //thickness=0.1 //x=88.655 //y=7.585 //x2=88.74 //y2=7.585
r1449 (  967 968 ) resistor r=24.7629 //w=0.367 //l=0.71 //layer=li \
 //thickness=0.1 //x=88.655 //y=7.585 //x2=87.945 //y2=7.585
r1450 (  961 1100 ) resistor r=4.23183 //w=0.7 //l=0.175 //layer=li \
 //thickness=0.1 //x=87.86 //y=7.41 //x2=87.86 //y2=7.585
r1451 (  961 1177 ) resistor r=56.8128 //w=0.187 //l=0.83 //layer=li \
 //thickness=0.1 //x=87.86 //y=7.41 //x2=87.86 //y2=6.58
r1452 (  960 1098 ) resistor r=5.29055 //w=0.35 //l=0.17 //layer=li \
 //thickness=0.1 //x=87.24 //y=7.585 //x2=87.07 //y2=7.585
r1453 (  959 1100 ) resistor r=2.87058 //w=0.35 //l=0.085 //layer=li \
 //thickness=0.1 //x=87.775 //y=7.585 //x2=87.86 //y2=7.585
r1454 (  959 960 ) resistor r=18.6594 //w=0.367 //l=0.535 //layer=li \
 //thickness=0.1 //x=87.775 //y=7.585 //x2=87.24 //y2=7.585
r1455 (  954 1097 ) resistor r=2.87058 //w=0.35 //l=0.085 //layer=li \
 //thickness=0.1 //x=86.075 //y=7.585 //x2=85.99 //y2=7.585
r1456 (  954 956 ) resistor r=8.89373 //w=0.367 //l=0.255 //layer=li \
 //thickness=0.1 //x=86.075 //y=7.585 //x2=86.33 //y2=7.585
r1457 (  953 1098 ) resistor r=5.29055 //w=0.35 //l=0.17 //layer=li \
 //thickness=0.1 //x=86.9 //y=7.585 //x2=87.07 //y2=7.585
r1458 (  953 956 ) resistor r=19.8801 //w=0.367 //l=0.57 //layer=li \
 //thickness=0.1 //x=86.9 //y=7.585 //x2=86.33 //y2=7.585
r1459 (  947 1097 ) resistor r=4.23183 //w=0.7 //l=0.175 //layer=li \
 //thickness=0.1 //x=85.99 //y=7.41 //x2=85.99 //y2=7.585
r1460 (  947 1176 ) resistor r=33.1979 //w=0.187 //l=0.485 //layer=li \
 //thickness=0.1 //x=85.99 //y=7.41 //x2=85.99 //y2=6.925
r1461 (  944 1096 ) resistor r=2.87058 //w=0.35 //l=0.085 //layer=li \
 //thickness=0.1 //x=85.195 //y=7.585 //x2=85.11 //y2=7.585
r1462 (  944 946 ) resistor r=0.871935 //w=0.367 //l=0.025 //layer=li \
 //thickness=0.1 //x=85.195 //y=7.585 //x2=85.22 //y2=7.585
r1463 (  943 1097 ) resistor r=2.87058 //w=0.35 //l=0.085 //layer=li \
 //thickness=0.1 //x=85.905 //y=7.585 //x2=85.99 //y2=7.585
r1464 (  943 946 ) resistor r=23.891 //w=0.367 //l=0.685 //layer=li \
 //thickness=0.1 //x=85.905 //y=7.585 //x2=85.22 //y2=7.585
r1465 (  937 1096 ) resistor r=4.23183 //w=0.7 //l=0.175 //layer=li \
 //thickness=0.1 //x=85.11 //y=7.41 //x2=85.11 //y2=7.585
r1466 (  937 1175 ) resistor r=33.1979 //w=0.187 //l=0.485 //layer=li \
 //thickness=0.1 //x=85.11 //y=7.41 //x2=85.11 //y2=6.925
r1467 (  936 1095 ) resistor r=2.87058 //w=0.35 //l=0.085 //layer=li \
 //thickness=0.1 //x=84.315 //y=7.585 //x2=84.23 //y2=7.585
r1468 (  935 1096 ) resistor r=2.87058 //w=0.35 //l=0.085 //layer=li \
 //thickness=0.1 //x=85.025 //y=7.585 //x2=85.11 //y2=7.585
r1469 (  935 936 ) resistor r=24.7629 //w=0.367 //l=0.71 //layer=li \
 //thickness=0.1 //x=85.025 //y=7.585 //x2=84.315 //y2=7.585
r1470 (  929 1095 ) resistor r=4.23183 //w=0.7 //l=0.175 //layer=li \
 //thickness=0.1 //x=84.23 //y=7.41 //x2=84.23 //y2=7.585
r1471 (  929 1174 ) resistor r=33.1979 //w=0.187 //l=0.485 //layer=li \
 //thickness=0.1 //x=84.23 //y=7.41 //x2=84.23 //y2=6.925
r1472 (  926 1094 ) resistor r=2.87058 //w=0.35 //l=0.085 //layer=li \
 //thickness=0.1 //x=83.435 //y=7.585 //x2=83.35 //y2=7.585
r1473 (  926 928 ) resistor r=23.5422 //w=0.367 //l=0.675 //layer=li \
 //thickness=0.1 //x=83.435 //y=7.585 //x2=84.11 //y2=7.585
r1474 (  925 1095 ) resistor r=2.87058 //w=0.35 //l=0.085 //layer=li \
 //thickness=0.1 //x=84.145 //y=7.585 //x2=84.23 //y2=7.585
r1475 (  925 928 ) resistor r=1.22071 //w=0.367 //l=0.035 //layer=li \
 //thickness=0.1 //x=84.145 //y=7.585 //x2=84.11 //y2=7.585
r1476 (  919 1094 ) resistor r=4.23183 //w=0.7 //l=0.175 //layer=li \
 //thickness=0.1 //x=83.35 //y=7.41 //x2=83.35 //y2=7.585
r1477 (  919 1173 ) resistor r=56.4706 //w=0.187 //l=0.825 //layer=li \
 //thickness=0.1 //x=83.35 //y=7.41 //x2=83.35 //y2=6.585
r1478 (  916 1093 ) resistor r=5.29055 //w=0.35 //l=0.17 //layer=li \
 //thickness=0.1 //x=82.43 //y=7.585 //x2=82.26 //y2=7.585
r1479 (  916 918 ) resistor r=19.8801 //w=0.367 //l=0.57 //layer=li \
 //thickness=0.1 //x=82.43 //y=7.585 //x2=83 //y2=7.585
r1480 (  915 1094 ) resistor r=2.87058 //w=0.35 //l=0.085 //layer=li \
 //thickness=0.1 //x=83.265 //y=7.585 //x2=83.35 //y2=7.585
r1481 (  915 918 ) resistor r=9.24251 //w=0.367 //l=0.265 //layer=li \
 //thickness=0.1 //x=83.265 //y=7.585 //x2=83 //y2=7.585
r1482 (  910 1092 ) resistor r=2.87058 //w=0.35 //l=0.085 //layer=li \
 //thickness=0.1 //x=81.265 //y=7.585 //x2=81.18 //y2=7.585
r1483 (  910 912 ) resistor r=8.89373 //w=0.367 //l=0.255 //layer=li \
 //thickness=0.1 //x=81.265 //y=7.585 //x2=81.52 //y2=7.585
r1484 (  909 1093 ) resistor r=5.29055 //w=0.35 //l=0.17 //layer=li \
 //thickness=0.1 //x=82.09 //y=7.585 //x2=82.26 //y2=7.585
r1485 (  909 912 ) resistor r=19.8801 //w=0.367 //l=0.57 //layer=li \
 //thickness=0.1 //x=82.09 //y=7.585 //x2=81.52 //y2=7.585
r1486 (  903 1092 ) resistor r=4.23183 //w=0.7 //l=0.175 //layer=li \
 //thickness=0.1 //x=81.18 //y=7.41 //x2=81.18 //y2=7.585
r1487 (  903 1172 ) resistor r=33.1979 //w=0.187 //l=0.485 //layer=li \
 //thickness=0.1 //x=81.18 //y=7.41 //x2=81.18 //y2=6.925
r1488 (  900 1091 ) resistor r=2.87058 //w=0.35 //l=0.085 //layer=li \
 //thickness=0.1 //x=80.385 //y=7.585 //x2=80.3 //y2=7.585
r1489 (  900 902 ) resistor r=0.871935 //w=0.367 //l=0.025 //layer=li \
 //thickness=0.1 //x=80.385 //y=7.585 //x2=80.41 //y2=7.585
r1490 (  899 1092 ) resistor r=2.87058 //w=0.35 //l=0.085 //layer=li \
 //thickness=0.1 //x=81.095 //y=7.585 //x2=81.18 //y2=7.585
r1491 (  899 902 ) resistor r=23.891 //w=0.367 //l=0.685 //layer=li \
 //thickness=0.1 //x=81.095 //y=7.585 //x2=80.41 //y2=7.585
r1492 (  893 1091 ) resistor r=4.23183 //w=0.7 //l=0.175 //layer=li \
 //thickness=0.1 //x=80.3 //y=7.41 //x2=80.3 //y2=7.585
r1493 (  893 1171 ) resistor r=33.1979 //w=0.187 //l=0.485 //layer=li \
 //thickness=0.1 //x=80.3 //y=7.41 //x2=80.3 //y2=6.925
r1494 (  892 1090 ) resistor r=2.87058 //w=0.35 //l=0.085 //layer=li \
 //thickness=0.1 //x=79.505 //y=7.585 //x2=79.42 //y2=7.585
r1495 (  891 1091 ) resistor r=2.87058 //w=0.35 //l=0.085 //layer=li \
 //thickness=0.1 //x=80.215 //y=7.585 //x2=80.3 //y2=7.585
r1496 (  891 892 ) resistor r=24.7629 //w=0.367 //l=0.71 //layer=li \
 //thickness=0.1 //x=80.215 //y=7.585 //x2=79.505 //y2=7.585
r1497 (  885 1090 ) resistor r=4.23183 //w=0.7 //l=0.175 //layer=li \
 //thickness=0.1 //x=79.42 //y=7.41 //x2=79.42 //y2=7.585
r1498 (  885 1170 ) resistor r=33.1979 //w=0.187 //l=0.485 //layer=li \
 //thickness=0.1 //x=79.42 //y=7.41 //x2=79.42 //y2=6.925
r1499 (  882 1089 ) resistor r=2.87058 //w=0.35 //l=0.085 //layer=li \
 //thickness=0.1 //x=78.625 //y=7.585 //x2=78.54 //y2=7.585
r1500 (  882 884 ) resistor r=23.5422 //w=0.367 //l=0.675 //layer=li \
 //thickness=0.1 //x=78.625 //y=7.585 //x2=79.3 //y2=7.585
r1501 (  881 1090 ) resistor r=2.87058 //w=0.35 //l=0.085 //layer=li \
 //thickness=0.1 //x=79.335 //y=7.585 //x2=79.42 //y2=7.585
r1502 (  881 884 ) resistor r=1.22071 //w=0.367 //l=0.035 //layer=li \
 //thickness=0.1 //x=79.335 //y=7.585 //x2=79.3 //y2=7.585
r1503 (  875 1089 ) resistor r=4.23183 //w=0.7 //l=0.175 //layer=li \
 //thickness=0.1 //x=78.54 //y=7.41 //x2=78.54 //y2=7.585
r1504 (  875 1169 ) resistor r=56.4706 //w=0.187 //l=0.825 //layer=li \
 //thickness=0.1 //x=78.54 //y=7.41 //x2=78.54 //y2=6.585
r1505 (  872 1088 ) resistor r=5.29055 //w=0.35 //l=0.17 //layer=li \
 //thickness=0.1 //x=77.62 //y=7.585 //x2=77.45 //y2=7.585
r1506 (  872 874 ) resistor r=19.8801 //w=0.367 //l=0.57 //layer=li \
 //thickness=0.1 //x=77.62 //y=7.585 //x2=78.19 //y2=7.585
r1507 (  871 1089 ) resistor r=2.87058 //w=0.35 //l=0.085 //layer=li \
 //thickness=0.1 //x=78.455 //y=7.585 //x2=78.54 //y2=7.585
r1508 (  871 874 ) resistor r=9.24251 //w=0.367 //l=0.265 //layer=li \
 //thickness=0.1 //x=78.455 //y=7.585 //x2=78.19 //y2=7.585
r1509 (  866 1087 ) resistor r=2.87058 //w=0.35 //l=0.085 //layer=li \
 //thickness=0.1 //x=76.455 //y=7.585 //x2=76.37 //y2=7.585
r1510 (  866 868 ) resistor r=8.89373 //w=0.367 //l=0.255 //layer=li \
 //thickness=0.1 //x=76.455 //y=7.585 //x2=76.71 //y2=7.585
r1511 (  865 1088 ) resistor r=5.29055 //w=0.35 //l=0.17 //layer=li \
 //thickness=0.1 //x=77.28 //y=7.585 //x2=77.45 //y2=7.585
r1512 (  865 868 ) resistor r=19.8801 //w=0.367 //l=0.57 //layer=li \
 //thickness=0.1 //x=77.28 //y=7.585 //x2=76.71 //y2=7.585
r1513 (  859 1087 ) resistor r=4.23183 //w=0.7 //l=0.175 //layer=li \
 //thickness=0.1 //x=76.37 //y=7.41 //x2=76.37 //y2=7.585
r1514 (  859 1168 ) resistor r=33.1979 //w=0.187 //l=0.485 //layer=li \
 //thickness=0.1 //x=76.37 //y=7.41 //x2=76.37 //y2=6.925
r1515 (  856 1086 ) resistor r=2.87058 //w=0.35 //l=0.085 //layer=li \
 //thickness=0.1 //x=75.575 //y=7.585 //x2=75.49 //y2=7.585
r1516 (  856 858 ) resistor r=0.871935 //w=0.367 //l=0.025 //layer=li \
 //thickness=0.1 //x=75.575 //y=7.585 //x2=75.6 //y2=7.585
r1517 (  855 1087 ) resistor r=2.87058 //w=0.35 //l=0.085 //layer=li \
 //thickness=0.1 //x=76.285 //y=7.585 //x2=76.37 //y2=7.585
r1518 (  855 858 ) resistor r=23.891 //w=0.367 //l=0.685 //layer=li \
 //thickness=0.1 //x=76.285 //y=7.585 //x2=75.6 //y2=7.585
r1519 (  849 1086 ) resistor r=4.23183 //w=0.7 //l=0.175 //layer=li \
 //thickness=0.1 //x=75.49 //y=7.41 //x2=75.49 //y2=7.585
r1520 (  849 1167 ) resistor r=33.1979 //w=0.187 //l=0.485 //layer=li \
 //thickness=0.1 //x=75.49 //y=7.41 //x2=75.49 //y2=6.925
r1521 (  848 1085 ) resistor r=2.87058 //w=0.35 //l=0.085 //layer=li \
 //thickness=0.1 //x=74.695 //y=7.585 //x2=74.61 //y2=7.585
r1522 (  847 1086 ) resistor r=2.87058 //w=0.35 //l=0.085 //layer=li \
 //thickness=0.1 //x=75.405 //y=7.585 //x2=75.49 //y2=7.585
r1523 (  847 848 ) resistor r=24.7629 //w=0.367 //l=0.71 //layer=li \
 //thickness=0.1 //x=75.405 //y=7.585 //x2=74.695 //y2=7.585
r1524 (  841 1085 ) resistor r=4.23183 //w=0.7 //l=0.175 //layer=li \
 //thickness=0.1 //x=74.61 //y=7.41 //x2=74.61 //y2=7.585
r1525 (  841 1166 ) resistor r=33.1979 //w=0.187 //l=0.485 //layer=li \
 //thickness=0.1 //x=74.61 //y=7.41 //x2=74.61 //y2=6.925
r1526 (  838 1084 ) resistor r=2.87058 //w=0.35 //l=0.085 //layer=li \
 //thickness=0.1 //x=73.815 //y=7.585 //x2=73.73 //y2=7.585
r1527 (  838 840 ) resistor r=23.5422 //w=0.367 //l=0.675 //layer=li \
 //thickness=0.1 //x=73.815 //y=7.585 //x2=74.49 //y2=7.585
r1528 (  837 1085 ) resistor r=2.87058 //w=0.35 //l=0.085 //layer=li \
 //thickness=0.1 //x=74.525 //y=7.585 //x2=74.61 //y2=7.585
r1529 (  837 840 ) resistor r=1.22071 //w=0.367 //l=0.035 //layer=li \
 //thickness=0.1 //x=74.525 //y=7.585 //x2=74.49 //y2=7.585
r1530 (  831 1084 ) resistor r=4.23183 //w=0.7 //l=0.175 //layer=li \
 //thickness=0.1 //x=73.73 //y=7.41 //x2=73.73 //y2=7.585
r1531 (  831 1165 ) resistor r=56.4706 //w=0.187 //l=0.825 //layer=li \
 //thickness=0.1 //x=73.73 //y=7.41 //x2=73.73 //y2=6.585
r1532 (  828 1083 ) resistor r=5.29055 //w=0.35 //l=0.17 //layer=li \
 //thickness=0.1 //x=72.81 //y=7.585 //x2=72.64 //y2=7.585
r1533 (  828 830 ) resistor r=19.8801 //w=0.367 //l=0.57 //layer=li \
 //thickness=0.1 //x=72.81 //y=7.585 //x2=73.38 //y2=7.585
r1534 (  827 1084 ) resistor r=2.87058 //w=0.35 //l=0.085 //layer=li \
 //thickness=0.1 //x=73.645 //y=7.585 //x2=73.73 //y2=7.585
r1535 (  827 830 ) resistor r=9.24251 //w=0.367 //l=0.265 //layer=li \
 //thickness=0.1 //x=73.645 //y=7.585 //x2=73.38 //y2=7.585
r1536 (  822 1082 ) resistor r=2.87058 //w=0.35 //l=0.085 //layer=li \
 //thickness=0.1 //x=71.645 //y=7.585 //x2=71.56 //y2=7.585
r1537 (  822 824 ) resistor r=8.89373 //w=0.367 //l=0.255 //layer=li \
 //thickness=0.1 //x=71.645 //y=7.585 //x2=71.9 //y2=7.585
r1538 (  821 1083 ) resistor r=5.29055 //w=0.35 //l=0.17 //layer=li \
 //thickness=0.1 //x=72.47 //y=7.585 //x2=72.64 //y2=7.585
r1539 (  821 824 ) resistor r=19.8801 //w=0.367 //l=0.57 //layer=li \
 //thickness=0.1 //x=72.47 //y=7.585 //x2=71.9 //y2=7.585
r1540 (  815 1082 ) resistor r=4.23183 //w=0.7 //l=0.175 //layer=li \
 //thickness=0.1 //x=71.56 //y=7.41 //x2=71.56 //y2=7.585
r1541 (  815 1164 ) resistor r=33.1979 //w=0.187 //l=0.485 //layer=li \
 //thickness=0.1 //x=71.56 //y=7.41 //x2=71.56 //y2=6.925
r1542 (  812 1081 ) resistor r=2.87058 //w=0.35 //l=0.085 //layer=li \
 //thickness=0.1 //x=70.765 //y=7.585 //x2=70.68 //y2=7.585
r1543 (  812 814 ) resistor r=0.871935 //w=0.367 //l=0.025 //layer=li \
 //thickness=0.1 //x=70.765 //y=7.585 //x2=70.79 //y2=7.585
r1544 (  811 1082 ) resistor r=2.87058 //w=0.35 //l=0.085 //layer=li \
 //thickness=0.1 //x=71.475 //y=7.585 //x2=71.56 //y2=7.585
r1545 (  811 814 ) resistor r=23.891 //w=0.367 //l=0.685 //layer=li \
 //thickness=0.1 //x=71.475 //y=7.585 //x2=70.79 //y2=7.585
r1546 (  805 1081 ) resistor r=4.23183 //w=0.7 //l=0.175 //layer=li \
 //thickness=0.1 //x=70.68 //y=7.41 //x2=70.68 //y2=7.585
r1547 (  805 1163 ) resistor r=33.1979 //w=0.187 //l=0.485 //layer=li \
 //thickness=0.1 //x=70.68 //y=7.41 //x2=70.68 //y2=6.925
r1548 (  804 1080 ) resistor r=2.87058 //w=0.35 //l=0.085 //layer=li \
 //thickness=0.1 //x=69.885 //y=7.585 //x2=69.8 //y2=7.585
r1549 (  803 1081 ) resistor r=2.87058 //w=0.35 //l=0.085 //layer=li \
 //thickness=0.1 //x=70.595 //y=7.585 //x2=70.68 //y2=7.585
r1550 (  803 804 ) resistor r=24.7629 //w=0.367 //l=0.71 //layer=li \
 //thickness=0.1 //x=70.595 //y=7.585 //x2=69.885 //y2=7.585
r1551 (  797 1080 ) resistor r=4.23183 //w=0.7 //l=0.175 //layer=li \
 //thickness=0.1 //x=69.8 //y=7.41 //x2=69.8 //y2=7.585
r1552 (  797 1162 ) resistor r=33.1979 //w=0.187 //l=0.485 //layer=li \
 //thickness=0.1 //x=69.8 //y=7.41 //x2=69.8 //y2=6.925
r1553 (  794 1079 ) resistor r=2.87058 //w=0.35 //l=0.085 //layer=li \
 //thickness=0.1 //x=69.005 //y=7.585 //x2=68.92 //y2=7.585
r1554 (  794 796 ) resistor r=23.5422 //w=0.367 //l=0.675 //layer=li \
 //thickness=0.1 //x=69.005 //y=7.585 //x2=69.68 //y2=7.585
r1555 (  793 1080 ) resistor r=2.87058 //w=0.35 //l=0.085 //layer=li \
 //thickness=0.1 //x=69.715 //y=7.585 //x2=69.8 //y2=7.585
r1556 (  793 796 ) resistor r=1.22071 //w=0.367 //l=0.035 //layer=li \
 //thickness=0.1 //x=69.715 //y=7.585 //x2=69.68 //y2=7.585
r1557 (  787 1079 ) resistor r=4.23183 //w=0.7 //l=0.175 //layer=li \
 //thickness=0.1 //x=68.92 //y=7.41 //x2=68.92 //y2=7.585
r1558 (  787 1161 ) resistor r=56.4706 //w=0.187 //l=0.825 //layer=li \
 //thickness=0.1 //x=68.92 //y=7.41 //x2=68.92 //y2=6.585
r1559 (  784 1078 ) resistor r=5.29055 //w=0.35 //l=0.17 //layer=li \
 //thickness=0.1 //x=68 //y=7.585 //x2=67.83 //y2=7.585
r1560 (  784 786 ) resistor r=19.8801 //w=0.367 //l=0.57 //layer=li \
 //thickness=0.1 //x=68 //y=7.585 //x2=68.57 //y2=7.585
r1561 (  783 1079 ) resistor r=2.87058 //w=0.35 //l=0.085 //layer=li \
 //thickness=0.1 //x=68.835 //y=7.585 //x2=68.92 //y2=7.585
r1562 (  783 786 ) resistor r=9.24251 //w=0.367 //l=0.265 //layer=li \
 //thickness=0.1 //x=68.835 //y=7.585 //x2=68.57 //y2=7.585
r1563 (  778 1077 ) resistor r=2.87058 //w=0.35 //l=0.085 //layer=li \
 //thickness=0.1 //x=66.835 //y=7.585 //x2=66.75 //y2=7.585
r1564 (  778 780 ) resistor r=8.89373 //w=0.367 //l=0.255 //layer=li \
 //thickness=0.1 //x=66.835 //y=7.585 //x2=67.09 //y2=7.585
r1565 (  777 1078 ) resistor r=5.29055 //w=0.35 //l=0.17 //layer=li \
 //thickness=0.1 //x=67.66 //y=7.585 //x2=67.83 //y2=7.585
r1566 (  777 780 ) resistor r=19.8801 //w=0.367 //l=0.57 //layer=li \
 //thickness=0.1 //x=67.66 //y=7.585 //x2=67.09 //y2=7.585
r1567 (  771 1077 ) resistor r=4.23183 //w=0.7 //l=0.175 //layer=li \
 //thickness=0.1 //x=66.75 //y=7.41 //x2=66.75 //y2=7.585
r1568 (  771 1160 ) resistor r=33.1979 //w=0.187 //l=0.485 //layer=li \
 //thickness=0.1 //x=66.75 //y=7.41 //x2=66.75 //y2=6.925
r1569 (  768 1076 ) resistor r=2.87058 //w=0.35 //l=0.085 //layer=li \
 //thickness=0.1 //x=65.955 //y=7.585 //x2=65.87 //y2=7.585
r1570 (  768 770 ) resistor r=0.871935 //w=0.367 //l=0.025 //layer=li \
 //thickness=0.1 //x=65.955 //y=7.585 //x2=65.98 //y2=7.585
r1571 (  767 1077 ) resistor r=2.87058 //w=0.35 //l=0.085 //layer=li \
 //thickness=0.1 //x=66.665 //y=7.585 //x2=66.75 //y2=7.585
r1572 (  767 770 ) resistor r=23.891 //w=0.367 //l=0.685 //layer=li \
 //thickness=0.1 //x=66.665 //y=7.585 //x2=65.98 //y2=7.585
r1573 (  761 1076 ) resistor r=4.23183 //w=0.7 //l=0.175 //layer=li \
 //thickness=0.1 //x=65.87 //y=7.41 //x2=65.87 //y2=7.585
r1574 (  761 1159 ) resistor r=33.1979 //w=0.187 //l=0.485 //layer=li \
 //thickness=0.1 //x=65.87 //y=7.41 //x2=65.87 //y2=6.925
r1575 (  760 1075 ) resistor r=2.87058 //w=0.35 //l=0.085 //layer=li \
 //thickness=0.1 //x=65.075 //y=7.585 //x2=64.99 //y2=7.585
r1576 (  759 1076 ) resistor r=2.87058 //w=0.35 //l=0.085 //layer=li \
 //thickness=0.1 //x=65.785 //y=7.585 //x2=65.87 //y2=7.585
r1577 (  759 760 ) resistor r=24.7629 //w=0.367 //l=0.71 //layer=li \
 //thickness=0.1 //x=65.785 //y=7.585 //x2=65.075 //y2=7.585
r1578 (  753 1075 ) resistor r=4.23183 //w=0.7 //l=0.175 //layer=li \
 //thickness=0.1 //x=64.99 //y=7.41 //x2=64.99 //y2=7.585
r1579 (  753 1158 ) resistor r=33.1979 //w=0.187 //l=0.485 //layer=li \
 //thickness=0.1 //x=64.99 //y=7.41 //x2=64.99 //y2=6.925
r1580 (  750 1074 ) resistor r=2.87058 //w=0.35 //l=0.085 //layer=li \
 //thickness=0.1 //x=64.195 //y=7.585 //x2=64.11 //y2=7.585
r1581 (  750 752 ) resistor r=23.5422 //w=0.367 //l=0.675 //layer=li \
 //thickness=0.1 //x=64.195 //y=7.585 //x2=64.87 //y2=7.585
r1582 (  749 1075 ) resistor r=2.87058 //w=0.35 //l=0.085 //layer=li \
 //thickness=0.1 //x=64.905 //y=7.585 //x2=64.99 //y2=7.585
r1583 (  749 752 ) resistor r=1.22071 //w=0.367 //l=0.035 //layer=li \
 //thickness=0.1 //x=64.905 //y=7.585 //x2=64.87 //y2=7.585
r1584 (  743 1074 ) resistor r=4.23183 //w=0.7 //l=0.175 //layer=li \
 //thickness=0.1 //x=64.11 //y=7.41 //x2=64.11 //y2=7.585
r1585 (  743 1157 ) resistor r=56.4706 //w=0.187 //l=0.825 //layer=li \
 //thickness=0.1 //x=64.11 //y=7.41 //x2=64.11 //y2=6.585
r1586 (  740 1073 ) resistor r=5.29055 //w=0.35 //l=0.17 //layer=li \
 //thickness=0.1 //x=63.19 //y=7.585 //x2=63.02 //y2=7.585
r1587 (  740 742 ) resistor r=19.8801 //w=0.367 //l=0.57 //layer=li \
 //thickness=0.1 //x=63.19 //y=7.585 //x2=63.76 //y2=7.585
r1588 (  739 1074 ) resistor r=2.87058 //w=0.35 //l=0.085 //layer=li \
 //thickness=0.1 //x=64.025 //y=7.585 //x2=64.11 //y2=7.585
r1589 (  739 742 ) resistor r=9.24251 //w=0.367 //l=0.265 //layer=li \
 //thickness=0.1 //x=64.025 //y=7.585 //x2=63.76 //y2=7.585
r1590 (  734 1072 ) resistor r=2.87058 //w=0.35 //l=0.085 //layer=li \
 //thickness=0.1 //x=62.025 //y=7.585 //x2=61.94 //y2=7.585
r1591 (  734 736 ) resistor r=8.89373 //w=0.367 //l=0.255 //layer=li \
 //thickness=0.1 //x=62.025 //y=7.585 //x2=62.28 //y2=7.585
r1592 (  733 1073 ) resistor r=5.29055 //w=0.35 //l=0.17 //layer=li \
 //thickness=0.1 //x=62.85 //y=7.585 //x2=63.02 //y2=7.585
r1593 (  733 736 ) resistor r=19.8801 //w=0.367 //l=0.57 //layer=li \
 //thickness=0.1 //x=62.85 //y=7.585 //x2=62.28 //y2=7.585
r1594 (  727 1072 ) resistor r=4.23183 //w=0.7 //l=0.175 //layer=li \
 //thickness=0.1 //x=61.94 //y=7.41 //x2=61.94 //y2=7.585
r1595 (  727 1156 ) resistor r=33.1979 //w=0.187 //l=0.485 //layer=li \
 //thickness=0.1 //x=61.94 //y=7.41 //x2=61.94 //y2=6.925
r1596 (  724 1071 ) resistor r=2.87058 //w=0.35 //l=0.085 //layer=li \
 //thickness=0.1 //x=61.145 //y=7.585 //x2=61.06 //y2=7.585
r1597 (  724 726 ) resistor r=0.871935 //w=0.367 //l=0.025 //layer=li \
 //thickness=0.1 //x=61.145 //y=7.585 //x2=61.17 //y2=7.585
r1598 (  723 1072 ) resistor r=2.87058 //w=0.35 //l=0.085 //layer=li \
 //thickness=0.1 //x=61.855 //y=7.585 //x2=61.94 //y2=7.585
r1599 (  723 726 ) resistor r=23.891 //w=0.367 //l=0.685 //layer=li \
 //thickness=0.1 //x=61.855 //y=7.585 //x2=61.17 //y2=7.585
r1600 (  717 1071 ) resistor r=4.23183 //w=0.7 //l=0.175 //layer=li \
 //thickness=0.1 //x=61.06 //y=7.41 //x2=61.06 //y2=7.585
r1601 (  717 1155 ) resistor r=33.1979 //w=0.187 //l=0.485 //layer=li \
 //thickness=0.1 //x=61.06 //y=7.41 //x2=61.06 //y2=6.925
r1602 (  716 1070 ) resistor r=2.87058 //w=0.35 //l=0.085 //layer=li \
 //thickness=0.1 //x=60.265 //y=7.585 //x2=60.18 //y2=7.585
r1603 (  715 1071 ) resistor r=2.87058 //w=0.35 //l=0.085 //layer=li \
 //thickness=0.1 //x=60.975 //y=7.585 //x2=61.06 //y2=7.585
r1604 (  715 716 ) resistor r=24.7629 //w=0.367 //l=0.71 //layer=li \
 //thickness=0.1 //x=60.975 //y=7.585 //x2=60.265 //y2=7.585
r1605 (  709 1070 ) resistor r=4.23183 //w=0.7 //l=0.175 //layer=li \
 //thickness=0.1 //x=60.18 //y=7.41 //x2=60.18 //y2=7.585
r1606 (  709 1154 ) resistor r=33.1979 //w=0.187 //l=0.485 //layer=li \
 //thickness=0.1 //x=60.18 //y=7.41 //x2=60.18 //y2=6.925
r1607 (  706 1069 ) resistor r=2.87058 //w=0.35 //l=0.085 //layer=li \
 //thickness=0.1 //x=59.385 //y=7.585 //x2=59.3 //y2=7.585
r1608 (  706 708 ) resistor r=23.5422 //w=0.367 //l=0.675 //layer=li \
 //thickness=0.1 //x=59.385 //y=7.585 //x2=60.06 //y2=7.585
r1609 (  705 1070 ) resistor r=2.87058 //w=0.35 //l=0.085 //layer=li \
 //thickness=0.1 //x=60.095 //y=7.585 //x2=60.18 //y2=7.585
r1610 (  705 708 ) resistor r=1.22071 //w=0.367 //l=0.035 //layer=li \
 //thickness=0.1 //x=60.095 //y=7.585 //x2=60.06 //y2=7.585
r1611 (  699 1069 ) resistor r=4.23183 //w=0.7 //l=0.175 //layer=li \
 //thickness=0.1 //x=59.3 //y=7.41 //x2=59.3 //y2=7.585
r1612 (  699 1153 ) resistor r=56.4706 //w=0.187 //l=0.825 //layer=li \
 //thickness=0.1 //x=59.3 //y=7.41 //x2=59.3 //y2=6.585
r1613 (  696 1068 ) resistor r=5.29055 //w=0.35 //l=0.17 //layer=li \
 //thickness=0.1 //x=58.38 //y=7.585 //x2=58.21 //y2=7.585
r1614 (  696 698 ) resistor r=19.8801 //w=0.367 //l=0.57 //layer=li \
 //thickness=0.1 //x=58.38 //y=7.585 //x2=58.95 //y2=7.585
r1615 (  695 1069 ) resistor r=2.87058 //w=0.35 //l=0.085 //layer=li \
 //thickness=0.1 //x=59.215 //y=7.585 //x2=59.3 //y2=7.585
r1616 (  695 698 ) resistor r=9.24251 //w=0.367 //l=0.265 //layer=li \
 //thickness=0.1 //x=59.215 //y=7.585 //x2=58.95 //y2=7.585
r1617 (  690 1067 ) resistor r=2.87058 //w=0.35 //l=0.085 //layer=li \
 //thickness=0.1 //x=57.215 //y=7.585 //x2=57.13 //y2=7.585
r1618 (  690 692 ) resistor r=8.89373 //w=0.367 //l=0.255 //layer=li \
 //thickness=0.1 //x=57.215 //y=7.585 //x2=57.47 //y2=7.585
r1619 (  689 1068 ) resistor r=5.29055 //w=0.35 //l=0.17 //layer=li \
 //thickness=0.1 //x=58.04 //y=7.585 //x2=58.21 //y2=7.585
r1620 (  689 692 ) resistor r=19.8801 //w=0.367 //l=0.57 //layer=li \
 //thickness=0.1 //x=58.04 //y=7.585 //x2=57.47 //y2=7.585
r1621 (  683 1067 ) resistor r=4.23183 //w=0.7 //l=0.175 //layer=li \
 //thickness=0.1 //x=57.13 //y=7.41 //x2=57.13 //y2=7.585
r1622 (  683 1152 ) resistor r=33.1979 //w=0.187 //l=0.485 //layer=li \
 //thickness=0.1 //x=57.13 //y=7.41 //x2=57.13 //y2=6.925
r1623 (  680 1066 ) resistor r=2.87058 //w=0.35 //l=0.085 //layer=li \
 //thickness=0.1 //x=56.335 //y=7.585 //x2=56.25 //y2=7.585
r1624 (  680 682 ) resistor r=0.871935 //w=0.367 //l=0.025 //layer=li \
 //thickness=0.1 //x=56.335 //y=7.585 //x2=56.36 //y2=7.585
r1625 (  679 1067 ) resistor r=2.87058 //w=0.35 //l=0.085 //layer=li \
 //thickness=0.1 //x=57.045 //y=7.585 //x2=57.13 //y2=7.585
r1626 (  679 682 ) resistor r=23.891 //w=0.367 //l=0.685 //layer=li \
 //thickness=0.1 //x=57.045 //y=7.585 //x2=56.36 //y2=7.585
r1627 (  673 1066 ) resistor r=4.23183 //w=0.7 //l=0.175 //layer=li \
 //thickness=0.1 //x=56.25 //y=7.41 //x2=56.25 //y2=7.585
r1628 (  673 1151 ) resistor r=33.1979 //w=0.187 //l=0.485 //layer=li \
 //thickness=0.1 //x=56.25 //y=7.41 //x2=56.25 //y2=6.925
r1629 (  672 1065 ) resistor r=2.87058 //w=0.35 //l=0.085 //layer=li \
 //thickness=0.1 //x=55.455 //y=7.585 //x2=55.37 //y2=7.585
r1630 (  671 1066 ) resistor r=2.87058 //w=0.35 //l=0.085 //layer=li \
 //thickness=0.1 //x=56.165 //y=7.585 //x2=56.25 //y2=7.585
r1631 (  671 672 ) resistor r=24.7629 //w=0.367 //l=0.71 //layer=li \
 //thickness=0.1 //x=56.165 //y=7.585 //x2=55.455 //y2=7.585
r1632 (  665 1065 ) resistor r=4.23183 //w=0.7 //l=0.175 //layer=li \
 //thickness=0.1 //x=55.37 //y=7.41 //x2=55.37 //y2=7.585
r1633 (  665 1150 ) resistor r=33.1979 //w=0.187 //l=0.485 //layer=li \
 //thickness=0.1 //x=55.37 //y=7.41 //x2=55.37 //y2=6.925
r1634 (  662 1064 ) resistor r=2.87058 //w=0.35 //l=0.085 //layer=li \
 //thickness=0.1 //x=54.575 //y=7.585 //x2=54.49 //y2=7.585
r1635 (  662 664 ) resistor r=23.5422 //w=0.367 //l=0.675 //layer=li \
 //thickness=0.1 //x=54.575 //y=7.585 //x2=55.25 //y2=7.585
r1636 (  661 1065 ) resistor r=2.87058 //w=0.35 //l=0.085 //layer=li \
 //thickness=0.1 //x=55.285 //y=7.585 //x2=55.37 //y2=7.585
r1637 (  661 664 ) resistor r=1.22071 //w=0.367 //l=0.035 //layer=li \
 //thickness=0.1 //x=55.285 //y=7.585 //x2=55.25 //y2=7.585
r1638 (  655 1064 ) resistor r=4.23183 //w=0.7 //l=0.175 //layer=li \
 //thickness=0.1 //x=54.49 //y=7.41 //x2=54.49 //y2=7.585
r1639 (  655 1149 ) resistor r=56.4706 //w=0.187 //l=0.825 //layer=li \
 //thickness=0.1 //x=54.49 //y=7.41 //x2=54.49 //y2=6.585
r1640 (  652 1063 ) resistor r=5.29055 //w=0.35 //l=0.17 //layer=li \
 //thickness=0.1 //x=53.57 //y=7.585 //x2=53.4 //y2=7.585
r1641 (  652 654 ) resistor r=19.8801 //w=0.367 //l=0.57 //layer=li \
 //thickness=0.1 //x=53.57 //y=7.585 //x2=54.14 //y2=7.585
r1642 (  651 1064 ) resistor r=2.87058 //w=0.35 //l=0.085 //layer=li \
 //thickness=0.1 //x=54.405 //y=7.585 //x2=54.49 //y2=7.585
r1643 (  651 654 ) resistor r=9.24251 //w=0.367 //l=0.265 //layer=li \
 //thickness=0.1 //x=54.405 //y=7.585 //x2=54.14 //y2=7.585
r1644 (  646 1062 ) resistor r=2.87058 //w=0.35 //l=0.085 //layer=li \
 //thickness=0.1 //x=52.405 //y=7.585 //x2=52.32 //y2=7.585
r1645 (  646 648 ) resistor r=8.89373 //w=0.367 //l=0.255 //layer=li \
 //thickness=0.1 //x=52.405 //y=7.585 //x2=52.66 //y2=7.585
r1646 (  645 1063 ) resistor r=5.29055 //w=0.35 //l=0.17 //layer=li \
 //thickness=0.1 //x=53.23 //y=7.585 //x2=53.4 //y2=7.585
r1647 (  645 648 ) resistor r=19.8801 //w=0.367 //l=0.57 //layer=li \
 //thickness=0.1 //x=53.23 //y=7.585 //x2=52.66 //y2=7.585
r1648 (  639 1062 ) resistor r=4.23183 //w=0.7 //l=0.175 //layer=li \
 //thickness=0.1 //x=52.32 //y=7.41 //x2=52.32 //y2=7.585
r1649 (  639 1148 ) resistor r=33.1979 //w=0.187 //l=0.485 //layer=li \
 //thickness=0.1 //x=52.32 //y=7.41 //x2=52.32 //y2=6.925
r1650 (  636 1061 ) resistor r=2.87058 //w=0.35 //l=0.085 //layer=li \
 //thickness=0.1 //x=51.525 //y=7.585 //x2=51.44 //y2=7.585
r1651 (  636 638 ) resistor r=0.871935 //w=0.367 //l=0.025 //layer=li \
 //thickness=0.1 //x=51.525 //y=7.585 //x2=51.55 //y2=7.585
r1652 (  635 1062 ) resistor r=2.87058 //w=0.35 //l=0.085 //layer=li \
 //thickness=0.1 //x=52.235 //y=7.585 //x2=52.32 //y2=7.585
r1653 (  635 638 ) resistor r=23.891 //w=0.367 //l=0.685 //layer=li \
 //thickness=0.1 //x=52.235 //y=7.585 //x2=51.55 //y2=7.585
r1654 (  629 1061 ) resistor r=4.23183 //w=0.7 //l=0.175 //layer=li \
 //thickness=0.1 //x=51.44 //y=7.41 //x2=51.44 //y2=7.585
r1655 (  629 1147 ) resistor r=33.1979 //w=0.187 //l=0.485 //layer=li \
 //thickness=0.1 //x=51.44 //y=7.41 //x2=51.44 //y2=6.925
r1656 (  628 1060 ) resistor r=2.87058 //w=0.35 //l=0.085 //layer=li \
 //thickness=0.1 //x=50.645 //y=7.585 //x2=50.56 //y2=7.585
r1657 (  627 1061 ) resistor r=2.87058 //w=0.35 //l=0.085 //layer=li \
 //thickness=0.1 //x=51.355 //y=7.585 //x2=51.44 //y2=7.585
r1658 (  627 628 ) resistor r=24.7629 //w=0.367 //l=0.71 //layer=li \
 //thickness=0.1 //x=51.355 //y=7.585 //x2=50.645 //y2=7.585
r1659 (  621 1060 ) resistor r=4.23183 //w=0.7 //l=0.175 //layer=li \
 //thickness=0.1 //x=50.56 //y=7.41 //x2=50.56 //y2=7.585
r1660 (  621 1146 ) resistor r=33.1979 //w=0.187 //l=0.485 //layer=li \
 //thickness=0.1 //x=50.56 //y=7.41 //x2=50.56 //y2=6.925
r1661 (  618 1059 ) resistor r=2.87058 //w=0.35 //l=0.085 //layer=li \
 //thickness=0.1 //x=49.765 //y=7.585 //x2=49.68 //y2=7.585
r1662 (  618 620 ) resistor r=23.5422 //w=0.367 //l=0.675 //layer=li \
 //thickness=0.1 //x=49.765 //y=7.585 //x2=50.44 //y2=7.585
r1663 (  617 1060 ) resistor r=2.87058 //w=0.35 //l=0.085 //layer=li \
 //thickness=0.1 //x=50.475 //y=7.585 //x2=50.56 //y2=7.585
r1664 (  617 620 ) resistor r=1.22071 //w=0.367 //l=0.035 //layer=li \
 //thickness=0.1 //x=50.475 //y=7.585 //x2=50.44 //y2=7.585
r1665 (  611 1059 ) resistor r=4.23183 //w=0.7 //l=0.175 //layer=li \
 //thickness=0.1 //x=49.68 //y=7.41 //x2=49.68 //y2=7.585
r1666 (  611 1145 ) resistor r=56.4706 //w=0.187 //l=0.825 //layer=li \
 //thickness=0.1 //x=49.68 //y=7.41 //x2=49.68 //y2=6.585
r1667 (  608 1058 ) resistor r=5.29055 //w=0.35 //l=0.17 //layer=li \
 //thickness=0.1 //x=48.76 //y=7.585 //x2=48.59 //y2=7.585
r1668 (  608 610 ) resistor r=19.8801 //w=0.367 //l=0.57 //layer=li \
 //thickness=0.1 //x=48.76 //y=7.585 //x2=49.33 //y2=7.585
r1669 (  607 1059 ) resistor r=2.87058 //w=0.35 //l=0.085 //layer=li \
 //thickness=0.1 //x=49.595 //y=7.585 //x2=49.68 //y2=7.585
r1670 (  607 610 ) resistor r=9.24251 //w=0.367 //l=0.265 //layer=li \
 //thickness=0.1 //x=49.595 //y=7.585 //x2=49.33 //y2=7.585
r1671 (  602 1057 ) resistor r=2.87058 //w=0.35 //l=0.085 //layer=li \
 //thickness=0.1 //x=47.595 //y=7.585 //x2=47.51 //y2=7.585
r1672 (  602 604 ) resistor r=8.89373 //w=0.367 //l=0.255 //layer=li \
 //thickness=0.1 //x=47.595 //y=7.585 //x2=47.85 //y2=7.585
r1673 (  601 1058 ) resistor r=5.29055 //w=0.35 //l=0.17 //layer=li \
 //thickness=0.1 //x=48.42 //y=7.585 //x2=48.59 //y2=7.585
r1674 (  601 604 ) resistor r=19.8801 //w=0.367 //l=0.57 //layer=li \
 //thickness=0.1 //x=48.42 //y=7.585 //x2=47.85 //y2=7.585
r1675 (  595 1057 ) resistor r=4.23183 //w=0.7 //l=0.175 //layer=li \
 //thickness=0.1 //x=47.51 //y=7.41 //x2=47.51 //y2=7.585
r1676 (  595 1144 ) resistor r=33.1979 //w=0.187 //l=0.485 //layer=li \
 //thickness=0.1 //x=47.51 //y=7.41 //x2=47.51 //y2=6.925
r1677 (  592 1056 ) resistor r=2.87058 //w=0.35 //l=0.085 //layer=li \
 //thickness=0.1 //x=46.715 //y=7.585 //x2=46.63 //y2=7.585
r1678 (  592 594 ) resistor r=0.871935 //w=0.367 //l=0.025 //layer=li \
 //thickness=0.1 //x=46.715 //y=7.585 //x2=46.74 //y2=7.585
r1679 (  591 1057 ) resistor r=2.87058 //w=0.35 //l=0.085 //layer=li \
 //thickness=0.1 //x=47.425 //y=7.585 //x2=47.51 //y2=7.585
r1680 (  591 594 ) resistor r=23.891 //w=0.367 //l=0.685 //layer=li \
 //thickness=0.1 //x=47.425 //y=7.585 //x2=46.74 //y2=7.585
r1681 (  585 1056 ) resistor r=4.23183 //w=0.7 //l=0.175 //layer=li \
 //thickness=0.1 //x=46.63 //y=7.41 //x2=46.63 //y2=7.585
r1682 (  585 1143 ) resistor r=33.1979 //w=0.187 //l=0.485 //layer=li \
 //thickness=0.1 //x=46.63 //y=7.41 //x2=46.63 //y2=6.925
r1683 (  584 1055 ) resistor r=2.87058 //w=0.35 //l=0.085 //layer=li \
 //thickness=0.1 //x=45.835 //y=7.585 //x2=45.75 //y2=7.585
r1684 (  583 1056 ) resistor r=2.87058 //w=0.35 //l=0.085 //layer=li \
 //thickness=0.1 //x=46.545 //y=7.585 //x2=46.63 //y2=7.585
r1685 (  583 584 ) resistor r=24.7629 //w=0.367 //l=0.71 //layer=li \
 //thickness=0.1 //x=46.545 //y=7.585 //x2=45.835 //y2=7.585
r1686 (  577 1055 ) resistor r=4.23183 //w=0.7 //l=0.175 //layer=li \
 //thickness=0.1 //x=45.75 //y=7.41 //x2=45.75 //y2=7.585
r1687 (  577 1142 ) resistor r=33.1979 //w=0.187 //l=0.485 //layer=li \
 //thickness=0.1 //x=45.75 //y=7.41 //x2=45.75 //y2=6.925
r1688 (  574 1054 ) resistor r=2.87058 //w=0.35 //l=0.085 //layer=li \
 //thickness=0.1 //x=44.955 //y=7.585 //x2=44.87 //y2=7.585
r1689 (  574 576 ) resistor r=23.5422 //w=0.367 //l=0.675 //layer=li \
 //thickness=0.1 //x=44.955 //y=7.585 //x2=45.63 //y2=7.585
r1690 (  573 1055 ) resistor r=2.87058 //w=0.35 //l=0.085 //layer=li \
 //thickness=0.1 //x=45.665 //y=7.585 //x2=45.75 //y2=7.585
r1691 (  573 576 ) resistor r=1.22071 //w=0.367 //l=0.035 //layer=li \
 //thickness=0.1 //x=45.665 //y=7.585 //x2=45.63 //y2=7.585
r1692 (  567 1054 ) resistor r=4.23183 //w=0.7 //l=0.175 //layer=li \
 //thickness=0.1 //x=44.87 //y=7.41 //x2=44.87 //y2=7.585
r1693 (  567 1141 ) resistor r=56.4706 //w=0.187 //l=0.825 //layer=li \
 //thickness=0.1 //x=44.87 //y=7.41 //x2=44.87 //y2=6.585
r1694 (  564 1053 ) resistor r=5.29055 //w=0.35 //l=0.17 //layer=li \
 //thickness=0.1 //x=43.95 //y=7.585 //x2=43.78 //y2=7.585
r1695 (  564 566 ) resistor r=19.8801 //w=0.367 //l=0.57 //layer=li \
 //thickness=0.1 //x=43.95 //y=7.585 //x2=44.52 //y2=7.585
r1696 (  563 1054 ) resistor r=2.87058 //w=0.35 //l=0.085 //layer=li \
 //thickness=0.1 //x=44.785 //y=7.585 //x2=44.87 //y2=7.585
r1697 (  563 566 ) resistor r=9.24251 //w=0.367 //l=0.265 //layer=li \
 //thickness=0.1 //x=44.785 //y=7.585 //x2=44.52 //y2=7.585
r1698 (  558 1052 ) resistor r=2.87058 //w=0.35 //l=0.085 //layer=li \
 //thickness=0.1 //x=42.785 //y=7.585 //x2=42.7 //y2=7.585
r1699 (  558 560 ) resistor r=8.89373 //w=0.367 //l=0.255 //layer=li \
 //thickness=0.1 //x=42.785 //y=7.585 //x2=43.04 //y2=7.585
r1700 (  557 1053 ) resistor r=5.29055 //w=0.35 //l=0.17 //layer=li \
 //thickness=0.1 //x=43.61 //y=7.585 //x2=43.78 //y2=7.585
r1701 (  557 560 ) resistor r=19.8801 //w=0.367 //l=0.57 //layer=li \
 //thickness=0.1 //x=43.61 //y=7.585 //x2=43.04 //y2=7.585
r1702 (  551 1052 ) resistor r=4.23183 //w=0.7 //l=0.175 //layer=li \
 //thickness=0.1 //x=42.7 //y=7.41 //x2=42.7 //y2=7.585
r1703 (  551 1140 ) resistor r=33.1979 //w=0.187 //l=0.485 //layer=li \
 //thickness=0.1 //x=42.7 //y=7.41 //x2=42.7 //y2=6.925
r1704 (  548 1051 ) resistor r=2.87058 //w=0.35 //l=0.085 //layer=li \
 //thickness=0.1 //x=41.905 //y=7.585 //x2=41.82 //y2=7.585
r1705 (  548 550 ) resistor r=0.871935 //w=0.367 //l=0.025 //layer=li \
 //thickness=0.1 //x=41.905 //y=7.585 //x2=41.93 //y2=7.585
r1706 (  547 1052 ) resistor r=2.87058 //w=0.35 //l=0.085 //layer=li \
 //thickness=0.1 //x=42.615 //y=7.585 //x2=42.7 //y2=7.585
r1707 (  547 550 ) resistor r=23.891 //w=0.367 //l=0.685 //layer=li \
 //thickness=0.1 //x=42.615 //y=7.585 //x2=41.93 //y2=7.585
r1708 (  541 1051 ) resistor r=4.23183 //w=0.7 //l=0.175 //layer=li \
 //thickness=0.1 //x=41.82 //y=7.41 //x2=41.82 //y2=7.585
r1709 (  541 1139 ) resistor r=33.1979 //w=0.187 //l=0.485 //layer=li \
 //thickness=0.1 //x=41.82 //y=7.41 //x2=41.82 //y2=6.925
r1710 (  540 1050 ) resistor r=2.87058 //w=0.35 //l=0.085 //layer=li \
 //thickness=0.1 //x=41.025 //y=7.585 //x2=40.94 //y2=7.585
r1711 (  539 1051 ) resistor r=2.87058 //w=0.35 //l=0.085 //layer=li \
 //thickness=0.1 //x=41.735 //y=7.585 //x2=41.82 //y2=7.585
r1712 (  539 540 ) resistor r=24.7629 //w=0.367 //l=0.71 //layer=li \
 //thickness=0.1 //x=41.735 //y=7.585 //x2=41.025 //y2=7.585
r1713 (  533 1050 ) resistor r=4.23183 //w=0.7 //l=0.175 //layer=li \
 //thickness=0.1 //x=40.94 //y=7.41 //x2=40.94 //y2=7.585
r1714 (  533 1138 ) resistor r=33.1979 //w=0.187 //l=0.485 //layer=li \
 //thickness=0.1 //x=40.94 //y=7.41 //x2=40.94 //y2=6.925
r1715 (  530 1049 ) resistor r=2.87058 //w=0.35 //l=0.085 //layer=li \
 //thickness=0.1 //x=40.145 //y=7.585 //x2=40.06 //y2=7.585
r1716 (  530 532 ) resistor r=23.5422 //w=0.367 //l=0.675 //layer=li \
 //thickness=0.1 //x=40.145 //y=7.585 //x2=40.82 //y2=7.585
r1717 (  529 1050 ) resistor r=2.87058 //w=0.35 //l=0.085 //layer=li \
 //thickness=0.1 //x=40.855 //y=7.585 //x2=40.94 //y2=7.585
r1718 (  529 532 ) resistor r=1.22071 //w=0.367 //l=0.035 //layer=li \
 //thickness=0.1 //x=40.855 //y=7.585 //x2=40.82 //y2=7.585
r1719 (  523 1049 ) resistor r=4.23183 //w=0.7 //l=0.175 //layer=li \
 //thickness=0.1 //x=40.06 //y=7.41 //x2=40.06 //y2=7.585
r1720 (  523 1137 ) resistor r=56.4706 //w=0.187 //l=0.825 //layer=li \
 //thickness=0.1 //x=40.06 //y=7.41 //x2=40.06 //y2=6.585
r1721 (  520 1048 ) resistor r=5.29055 //w=0.35 //l=0.17 //layer=li \
 //thickness=0.1 //x=39.14 //y=7.585 //x2=38.97 //y2=7.585
r1722 (  520 522 ) resistor r=19.8801 //w=0.367 //l=0.57 //layer=li \
 //thickness=0.1 //x=39.14 //y=7.585 //x2=39.71 //y2=7.585
r1723 (  519 1049 ) resistor r=2.87058 //w=0.35 //l=0.085 //layer=li \
 //thickness=0.1 //x=39.975 //y=7.585 //x2=40.06 //y2=7.585
r1724 (  519 522 ) resistor r=9.24251 //w=0.367 //l=0.265 //layer=li \
 //thickness=0.1 //x=39.975 //y=7.585 //x2=39.71 //y2=7.585
r1725 (  514 1047 ) resistor r=2.87058 //w=0.35 //l=0.085 //layer=li \
 //thickness=0.1 //x=37.975 //y=7.585 //x2=37.89 //y2=7.585
r1726 (  514 516 ) resistor r=8.89373 //w=0.367 //l=0.255 //layer=li \
 //thickness=0.1 //x=37.975 //y=7.585 //x2=38.23 //y2=7.585
r1727 (  513 1048 ) resistor r=5.29055 //w=0.35 //l=0.17 //layer=li \
 //thickness=0.1 //x=38.8 //y=7.585 //x2=38.97 //y2=7.585
r1728 (  513 516 ) resistor r=19.8801 //w=0.367 //l=0.57 //layer=li \
 //thickness=0.1 //x=38.8 //y=7.585 //x2=38.23 //y2=7.585
r1729 (  507 1047 ) resistor r=4.23183 //w=0.7 //l=0.175 //layer=li \
 //thickness=0.1 //x=37.89 //y=7.41 //x2=37.89 //y2=7.585
r1730 (  507 1136 ) resistor r=33.1979 //w=0.187 //l=0.485 //layer=li \
 //thickness=0.1 //x=37.89 //y=7.41 //x2=37.89 //y2=6.925
r1731 (  504 1046 ) resistor r=2.87058 //w=0.35 //l=0.085 //layer=li \
 //thickness=0.1 //x=37.095 //y=7.585 //x2=37.01 //y2=7.585
r1732 (  504 506 ) resistor r=0.871935 //w=0.367 //l=0.025 //layer=li \
 //thickness=0.1 //x=37.095 //y=7.585 //x2=37.12 //y2=7.585
r1733 (  503 1047 ) resistor r=2.87058 //w=0.35 //l=0.085 //layer=li \
 //thickness=0.1 //x=37.805 //y=7.585 //x2=37.89 //y2=7.585
r1734 (  503 506 ) resistor r=23.891 //w=0.367 //l=0.685 //layer=li \
 //thickness=0.1 //x=37.805 //y=7.585 //x2=37.12 //y2=7.585
r1735 (  497 1046 ) resistor r=4.23183 //w=0.7 //l=0.175 //layer=li \
 //thickness=0.1 //x=37.01 //y=7.41 //x2=37.01 //y2=7.585
r1736 (  497 1135 ) resistor r=33.1979 //w=0.187 //l=0.485 //layer=li \
 //thickness=0.1 //x=37.01 //y=7.41 //x2=37.01 //y2=6.925
r1737 (  496 1045 ) resistor r=2.87058 //w=0.35 //l=0.085 //layer=li \
 //thickness=0.1 //x=36.215 //y=7.585 //x2=36.13 //y2=7.585
r1738 (  495 1046 ) resistor r=2.87058 //w=0.35 //l=0.085 //layer=li \
 //thickness=0.1 //x=36.925 //y=7.585 //x2=37.01 //y2=7.585
r1739 (  495 496 ) resistor r=24.7629 //w=0.367 //l=0.71 //layer=li \
 //thickness=0.1 //x=36.925 //y=7.585 //x2=36.215 //y2=7.585
r1740 (  489 1045 ) resistor r=4.23183 //w=0.7 //l=0.175 //layer=li \
 //thickness=0.1 //x=36.13 //y=7.41 //x2=36.13 //y2=7.585
r1741 (  489 1134 ) resistor r=33.1979 //w=0.187 //l=0.485 //layer=li \
 //thickness=0.1 //x=36.13 //y=7.41 //x2=36.13 //y2=6.925
r1742 (  486 1044 ) resistor r=2.87058 //w=0.35 //l=0.085 //layer=li \
 //thickness=0.1 //x=35.335 //y=7.585 //x2=35.25 //y2=7.585
r1743 (  486 488 ) resistor r=23.5422 //w=0.367 //l=0.675 //layer=li \
 //thickness=0.1 //x=35.335 //y=7.585 //x2=36.01 //y2=7.585
r1744 (  485 1045 ) resistor r=2.87058 //w=0.35 //l=0.085 //layer=li \
 //thickness=0.1 //x=36.045 //y=7.585 //x2=36.13 //y2=7.585
r1745 (  485 488 ) resistor r=1.22071 //w=0.367 //l=0.035 //layer=li \
 //thickness=0.1 //x=36.045 //y=7.585 //x2=36.01 //y2=7.585
r1746 (  479 1044 ) resistor r=4.23183 //w=0.7 //l=0.175 //layer=li \
 //thickness=0.1 //x=35.25 //y=7.41 //x2=35.25 //y2=7.585
r1747 (  479 1133 ) resistor r=56.4706 //w=0.187 //l=0.825 //layer=li \
 //thickness=0.1 //x=35.25 //y=7.41 //x2=35.25 //y2=6.585
r1748 (  476 1043 ) resistor r=5.29055 //w=0.35 //l=0.17 //layer=li \
 //thickness=0.1 //x=34.33 //y=7.585 //x2=34.16 //y2=7.585
r1749 (  476 478 ) resistor r=19.8801 //w=0.367 //l=0.57 //layer=li \
 //thickness=0.1 //x=34.33 //y=7.585 //x2=34.9 //y2=7.585
r1750 (  475 1044 ) resistor r=2.87058 //w=0.35 //l=0.085 //layer=li \
 //thickness=0.1 //x=35.165 //y=7.585 //x2=35.25 //y2=7.585
r1751 (  475 478 ) resistor r=9.24251 //w=0.367 //l=0.265 //layer=li \
 //thickness=0.1 //x=35.165 //y=7.585 //x2=34.9 //y2=7.585
r1752 (  470 1042 ) resistor r=2.87058 //w=0.35 //l=0.085 //layer=li \
 //thickness=0.1 //x=33.165 //y=7.585 //x2=33.08 //y2=7.585
r1753 (  470 472 ) resistor r=8.89373 //w=0.367 //l=0.255 //layer=li \
 //thickness=0.1 //x=33.165 //y=7.585 //x2=33.42 //y2=7.585
r1754 (  469 1043 ) resistor r=5.29055 //w=0.35 //l=0.17 //layer=li \
 //thickness=0.1 //x=33.99 //y=7.585 //x2=34.16 //y2=7.585
r1755 (  469 472 ) resistor r=19.8801 //w=0.367 //l=0.57 //layer=li \
 //thickness=0.1 //x=33.99 //y=7.585 //x2=33.42 //y2=7.585
r1756 (  463 1042 ) resistor r=4.23183 //w=0.7 //l=0.175 //layer=li \
 //thickness=0.1 //x=33.08 //y=7.41 //x2=33.08 //y2=7.585
r1757 (  463 1132 ) resistor r=33.1979 //w=0.187 //l=0.485 //layer=li \
 //thickness=0.1 //x=33.08 //y=7.41 //x2=33.08 //y2=6.925
r1758 (  460 1041 ) resistor r=2.87058 //w=0.35 //l=0.085 //layer=li \
 //thickness=0.1 //x=32.285 //y=7.585 //x2=32.2 //y2=7.585
r1759 (  460 462 ) resistor r=0.871935 //w=0.367 //l=0.025 //layer=li \
 //thickness=0.1 //x=32.285 //y=7.585 //x2=32.31 //y2=7.585
r1760 (  459 1042 ) resistor r=2.87058 //w=0.35 //l=0.085 //layer=li \
 //thickness=0.1 //x=32.995 //y=7.585 //x2=33.08 //y2=7.585
r1761 (  459 462 ) resistor r=23.891 //w=0.367 //l=0.685 //layer=li \
 //thickness=0.1 //x=32.995 //y=7.585 //x2=32.31 //y2=7.585
r1762 (  453 1041 ) resistor r=4.23183 //w=0.7 //l=0.175 //layer=li \
 //thickness=0.1 //x=32.2 //y=7.41 //x2=32.2 //y2=7.585
r1763 (  453 1131 ) resistor r=33.1979 //w=0.187 //l=0.485 //layer=li \
 //thickness=0.1 //x=32.2 //y=7.41 //x2=32.2 //y2=6.925
r1764 (  452 1040 ) resistor r=2.87058 //w=0.35 //l=0.085 //layer=li \
 //thickness=0.1 //x=31.405 //y=7.585 //x2=31.32 //y2=7.585
r1765 (  451 1041 ) resistor r=2.87058 //w=0.35 //l=0.085 //layer=li \
 //thickness=0.1 //x=32.115 //y=7.585 //x2=32.2 //y2=7.585
r1766 (  451 452 ) resistor r=24.7629 //w=0.367 //l=0.71 //layer=li \
 //thickness=0.1 //x=32.115 //y=7.585 //x2=31.405 //y2=7.585
r1767 (  445 1040 ) resistor r=4.23183 //w=0.7 //l=0.175 //layer=li \
 //thickness=0.1 //x=31.32 //y=7.41 //x2=31.32 //y2=7.585
r1768 (  445 1130 ) resistor r=33.1979 //w=0.187 //l=0.485 //layer=li \
 //thickness=0.1 //x=31.32 //y=7.41 //x2=31.32 //y2=6.925
r1769 (  442 1039 ) resistor r=2.87058 //w=0.35 //l=0.085 //layer=li \
 //thickness=0.1 //x=30.525 //y=7.585 //x2=30.44 //y2=7.585
r1770 (  442 444 ) resistor r=23.5422 //w=0.367 //l=0.675 //layer=li \
 //thickness=0.1 //x=30.525 //y=7.585 //x2=31.2 //y2=7.585
r1771 (  441 1040 ) resistor r=2.87058 //w=0.35 //l=0.085 //layer=li \
 //thickness=0.1 //x=31.235 //y=7.585 //x2=31.32 //y2=7.585
r1772 (  441 444 ) resistor r=1.22071 //w=0.367 //l=0.035 //layer=li \
 //thickness=0.1 //x=31.235 //y=7.585 //x2=31.2 //y2=7.585
r1773 (  435 1039 ) resistor r=4.23183 //w=0.7 //l=0.175 //layer=li \
 //thickness=0.1 //x=30.44 //y=7.41 //x2=30.44 //y2=7.585
r1774 (  435 1129 ) resistor r=56.4706 //w=0.187 //l=0.825 //layer=li \
 //thickness=0.1 //x=30.44 //y=7.41 //x2=30.44 //y2=6.585
r1775 (  432 1038 ) resistor r=5.29055 //w=0.35 //l=0.17 //layer=li \
 //thickness=0.1 //x=29.52 //y=7.585 //x2=29.35 //y2=7.585
r1776 (  432 434 ) resistor r=19.8801 //w=0.367 //l=0.57 //layer=li \
 //thickness=0.1 //x=29.52 //y=7.585 //x2=30.09 //y2=7.585
r1777 (  431 1039 ) resistor r=2.87058 //w=0.35 //l=0.085 //layer=li \
 //thickness=0.1 //x=30.355 //y=7.585 //x2=30.44 //y2=7.585
r1778 (  431 434 ) resistor r=9.24251 //w=0.367 //l=0.265 //layer=li \
 //thickness=0.1 //x=30.355 //y=7.585 //x2=30.09 //y2=7.585
r1779 (  426 1037 ) resistor r=2.87058 //w=0.35 //l=0.085 //layer=li \
 //thickness=0.1 //x=28.355 //y=7.585 //x2=28.27 //y2=7.585
r1780 (  426 428 ) resistor r=8.89373 //w=0.367 //l=0.255 //layer=li \
 //thickness=0.1 //x=28.355 //y=7.585 //x2=28.61 //y2=7.585
r1781 (  425 1038 ) resistor r=5.29055 //w=0.35 //l=0.17 //layer=li \
 //thickness=0.1 //x=29.18 //y=7.585 //x2=29.35 //y2=7.585
r1782 (  425 428 ) resistor r=19.8801 //w=0.367 //l=0.57 //layer=li \
 //thickness=0.1 //x=29.18 //y=7.585 //x2=28.61 //y2=7.585
r1783 (  419 1037 ) resistor r=4.23183 //w=0.7 //l=0.175 //layer=li \
 //thickness=0.1 //x=28.27 //y=7.41 //x2=28.27 //y2=7.585
r1784 (  419 1128 ) resistor r=33.1979 //w=0.187 //l=0.485 //layer=li \
 //thickness=0.1 //x=28.27 //y=7.41 //x2=28.27 //y2=6.925
r1785 (  416 1036 ) resistor r=2.87058 //w=0.35 //l=0.085 //layer=li \
 //thickness=0.1 //x=27.475 //y=7.585 //x2=27.39 //y2=7.585
r1786 (  416 418 ) resistor r=0.871935 //w=0.367 //l=0.025 //layer=li \
 //thickness=0.1 //x=27.475 //y=7.585 //x2=27.5 //y2=7.585
r1787 (  415 1037 ) resistor r=2.87058 //w=0.35 //l=0.085 //layer=li \
 //thickness=0.1 //x=28.185 //y=7.585 //x2=28.27 //y2=7.585
r1788 (  415 418 ) resistor r=23.891 //w=0.367 //l=0.685 //layer=li \
 //thickness=0.1 //x=28.185 //y=7.585 //x2=27.5 //y2=7.585
r1789 (  409 1036 ) resistor r=4.23183 //w=0.7 //l=0.175 //layer=li \
 //thickness=0.1 //x=27.39 //y=7.41 //x2=27.39 //y2=7.585
r1790 (  409 1127 ) resistor r=33.1979 //w=0.187 //l=0.485 //layer=li \
 //thickness=0.1 //x=27.39 //y=7.41 //x2=27.39 //y2=6.925
r1791 (  408 1035 ) resistor r=2.87058 //w=0.35 //l=0.085 //layer=li \
 //thickness=0.1 //x=26.595 //y=7.585 //x2=26.51 //y2=7.585
r1792 (  407 1036 ) resistor r=2.87058 //w=0.35 //l=0.085 //layer=li \
 //thickness=0.1 //x=27.305 //y=7.585 //x2=27.39 //y2=7.585
r1793 (  407 408 ) resistor r=24.7629 //w=0.367 //l=0.71 //layer=li \
 //thickness=0.1 //x=27.305 //y=7.585 //x2=26.595 //y2=7.585
r1794 (  401 1035 ) resistor r=4.23183 //w=0.7 //l=0.175 //layer=li \
 //thickness=0.1 //x=26.51 //y=7.41 //x2=26.51 //y2=7.585
r1795 (  401 1126 ) resistor r=33.1979 //w=0.187 //l=0.485 //layer=li \
 //thickness=0.1 //x=26.51 //y=7.41 //x2=26.51 //y2=6.925
r1796 (  398 1034 ) resistor r=2.87058 //w=0.35 //l=0.085 //layer=li \
 //thickness=0.1 //x=25.715 //y=7.585 //x2=25.63 //y2=7.585
r1797 (  398 400 ) resistor r=23.5422 //w=0.367 //l=0.675 //layer=li \
 //thickness=0.1 //x=25.715 //y=7.585 //x2=26.39 //y2=7.585
r1798 (  397 1035 ) resistor r=2.87058 //w=0.35 //l=0.085 //layer=li \
 //thickness=0.1 //x=26.425 //y=7.585 //x2=26.51 //y2=7.585
r1799 (  397 400 ) resistor r=1.22071 //w=0.367 //l=0.035 //layer=li \
 //thickness=0.1 //x=26.425 //y=7.585 //x2=26.39 //y2=7.585
r1800 (  391 1034 ) resistor r=4.23183 //w=0.7 //l=0.175 //layer=li \
 //thickness=0.1 //x=25.63 //y=7.41 //x2=25.63 //y2=7.585
r1801 (  391 1125 ) resistor r=56.4706 //w=0.187 //l=0.825 //layer=li \
 //thickness=0.1 //x=25.63 //y=7.41 //x2=25.63 //y2=6.585
r1802 (  388 1033 ) resistor r=5.29055 //w=0.35 //l=0.17 //layer=li \
 //thickness=0.1 //x=24.71 //y=7.585 //x2=24.54 //y2=7.585
r1803 (  388 390 ) resistor r=19.8801 //w=0.367 //l=0.57 //layer=li \
 //thickness=0.1 //x=24.71 //y=7.585 //x2=25.28 //y2=7.585
r1804 (  387 1034 ) resistor r=2.87058 //w=0.35 //l=0.085 //layer=li \
 //thickness=0.1 //x=25.545 //y=7.585 //x2=25.63 //y2=7.585
r1805 (  387 390 ) resistor r=9.24251 //w=0.367 //l=0.265 //layer=li \
 //thickness=0.1 //x=25.545 //y=7.585 //x2=25.28 //y2=7.585
r1806 (  382 1032 ) resistor r=2.87058 //w=0.35 //l=0.085 //layer=li \
 //thickness=0.1 //x=23.545 //y=7.585 //x2=23.46 //y2=7.585
r1807 (  382 384 ) resistor r=8.89373 //w=0.367 //l=0.255 //layer=li \
 //thickness=0.1 //x=23.545 //y=7.585 //x2=23.8 //y2=7.585
r1808 (  381 1033 ) resistor r=5.29055 //w=0.35 //l=0.17 //layer=li \
 //thickness=0.1 //x=24.37 //y=7.585 //x2=24.54 //y2=7.585
r1809 (  381 384 ) resistor r=19.8801 //w=0.367 //l=0.57 //layer=li \
 //thickness=0.1 //x=24.37 //y=7.585 //x2=23.8 //y2=7.585
r1810 (  375 1032 ) resistor r=4.23183 //w=0.7 //l=0.175 //layer=li \
 //thickness=0.1 //x=23.46 //y=7.41 //x2=23.46 //y2=7.585
r1811 (  375 1124 ) resistor r=33.1979 //w=0.187 //l=0.485 //layer=li \
 //thickness=0.1 //x=23.46 //y=7.41 //x2=23.46 //y2=6.925
r1812 (  372 1031 ) resistor r=2.87058 //w=0.35 //l=0.085 //layer=li \
 //thickness=0.1 //x=22.665 //y=7.585 //x2=22.58 //y2=7.585
r1813 (  372 374 ) resistor r=0.871935 //w=0.367 //l=0.025 //layer=li \
 //thickness=0.1 //x=22.665 //y=7.585 //x2=22.69 //y2=7.585
r1814 (  371 1032 ) resistor r=2.87058 //w=0.35 //l=0.085 //layer=li \
 //thickness=0.1 //x=23.375 //y=7.585 //x2=23.46 //y2=7.585
r1815 (  371 374 ) resistor r=23.891 //w=0.367 //l=0.685 //layer=li \
 //thickness=0.1 //x=23.375 //y=7.585 //x2=22.69 //y2=7.585
r1816 (  365 1031 ) resistor r=4.23183 //w=0.7 //l=0.175 //layer=li \
 //thickness=0.1 //x=22.58 //y=7.41 //x2=22.58 //y2=7.585
r1817 (  365 1123 ) resistor r=33.1979 //w=0.187 //l=0.485 //layer=li \
 //thickness=0.1 //x=22.58 //y=7.41 //x2=22.58 //y2=6.925
r1818 (  364 1030 ) resistor r=2.87058 //w=0.35 //l=0.085 //layer=li \
 //thickness=0.1 //x=21.785 //y=7.585 //x2=21.7 //y2=7.585
r1819 (  363 1031 ) resistor r=2.87058 //w=0.35 //l=0.085 //layer=li \
 //thickness=0.1 //x=22.495 //y=7.585 //x2=22.58 //y2=7.585
r1820 (  363 364 ) resistor r=24.7629 //w=0.367 //l=0.71 //layer=li \
 //thickness=0.1 //x=22.495 //y=7.585 //x2=21.785 //y2=7.585
r1821 (  357 1030 ) resistor r=4.23183 //w=0.7 //l=0.175 //layer=li \
 //thickness=0.1 //x=21.7 //y=7.41 //x2=21.7 //y2=7.585
r1822 (  357 1122 ) resistor r=33.1979 //w=0.187 //l=0.485 //layer=li \
 //thickness=0.1 //x=21.7 //y=7.41 //x2=21.7 //y2=6.925
r1823 (  354 1029 ) resistor r=2.87058 //w=0.35 //l=0.085 //layer=li \
 //thickness=0.1 //x=20.905 //y=7.585 //x2=20.82 //y2=7.585
r1824 (  354 356 ) resistor r=23.5422 //w=0.367 //l=0.675 //layer=li \
 //thickness=0.1 //x=20.905 //y=7.585 //x2=21.58 //y2=7.585
r1825 (  353 1030 ) resistor r=2.87058 //w=0.35 //l=0.085 //layer=li \
 //thickness=0.1 //x=21.615 //y=7.585 //x2=21.7 //y2=7.585
r1826 (  353 356 ) resistor r=1.22071 //w=0.367 //l=0.035 //layer=li \
 //thickness=0.1 //x=21.615 //y=7.585 //x2=21.58 //y2=7.585
r1827 (  347 1029 ) resistor r=4.23183 //w=0.7 //l=0.175 //layer=li \
 //thickness=0.1 //x=20.82 //y=7.41 //x2=20.82 //y2=7.585
r1828 (  347 1121 ) resistor r=56.4706 //w=0.187 //l=0.825 //layer=li \
 //thickness=0.1 //x=20.82 //y=7.41 //x2=20.82 //y2=6.585
r1829 (  344 1028 ) resistor r=5.29055 //w=0.35 //l=0.17 //layer=li \
 //thickness=0.1 //x=19.9 //y=7.585 //x2=19.73 //y2=7.585
r1830 (  344 346 ) resistor r=19.8801 //w=0.367 //l=0.57 //layer=li \
 //thickness=0.1 //x=19.9 //y=7.585 //x2=20.47 //y2=7.585
r1831 (  343 1029 ) resistor r=2.87058 //w=0.35 //l=0.085 //layer=li \
 //thickness=0.1 //x=20.735 //y=7.585 //x2=20.82 //y2=7.585
r1832 (  343 346 ) resistor r=9.24251 //w=0.367 //l=0.265 //layer=li \
 //thickness=0.1 //x=20.735 //y=7.585 //x2=20.47 //y2=7.585
r1833 (  338 1027 ) resistor r=2.87058 //w=0.35 //l=0.085 //layer=li \
 //thickness=0.1 //x=18.735 //y=7.585 //x2=18.65 //y2=7.585
r1834 (  338 340 ) resistor r=8.89373 //w=0.367 //l=0.255 //layer=li \
 //thickness=0.1 //x=18.735 //y=7.585 //x2=18.99 //y2=7.585
r1835 (  337 1028 ) resistor r=5.29055 //w=0.35 //l=0.17 //layer=li \
 //thickness=0.1 //x=19.56 //y=7.585 //x2=19.73 //y2=7.585
r1836 (  337 340 ) resistor r=19.8801 //w=0.367 //l=0.57 //layer=li \
 //thickness=0.1 //x=19.56 //y=7.585 //x2=18.99 //y2=7.585
r1837 (  331 1027 ) resistor r=4.23183 //w=0.7 //l=0.175 //layer=li \
 //thickness=0.1 //x=18.65 //y=7.41 //x2=18.65 //y2=7.585
r1838 (  331 1120 ) resistor r=33.1979 //w=0.187 //l=0.485 //layer=li \
 //thickness=0.1 //x=18.65 //y=7.41 //x2=18.65 //y2=6.925
r1839 (  328 1026 ) resistor r=2.87058 //w=0.35 //l=0.085 //layer=li \
 //thickness=0.1 //x=17.855 //y=7.585 //x2=17.77 //y2=7.585
r1840 (  328 330 ) resistor r=0.871935 //w=0.367 //l=0.025 //layer=li \
 //thickness=0.1 //x=17.855 //y=7.585 //x2=17.88 //y2=7.585
r1841 (  327 1027 ) resistor r=2.87058 //w=0.35 //l=0.085 //layer=li \
 //thickness=0.1 //x=18.565 //y=7.585 //x2=18.65 //y2=7.585
r1842 (  327 330 ) resistor r=23.891 //w=0.367 //l=0.685 //layer=li \
 //thickness=0.1 //x=18.565 //y=7.585 //x2=17.88 //y2=7.585
r1843 (  321 1026 ) resistor r=4.23183 //w=0.7 //l=0.175 //layer=li \
 //thickness=0.1 //x=17.77 //y=7.41 //x2=17.77 //y2=7.585
r1844 (  321 1119 ) resistor r=33.1979 //w=0.187 //l=0.485 //layer=li \
 //thickness=0.1 //x=17.77 //y=7.41 //x2=17.77 //y2=6.925
r1845 (  320 1025 ) resistor r=2.87058 //w=0.35 //l=0.085 //layer=li \
 //thickness=0.1 //x=16.975 //y=7.585 //x2=16.89 //y2=7.585
r1846 (  319 1026 ) resistor r=2.87058 //w=0.35 //l=0.085 //layer=li \
 //thickness=0.1 //x=17.685 //y=7.585 //x2=17.77 //y2=7.585
r1847 (  319 320 ) resistor r=24.7629 //w=0.367 //l=0.71 //layer=li \
 //thickness=0.1 //x=17.685 //y=7.585 //x2=16.975 //y2=7.585
r1848 (  313 1025 ) resistor r=4.23183 //w=0.7 //l=0.175 //layer=li \
 //thickness=0.1 //x=16.89 //y=7.41 //x2=16.89 //y2=7.585
r1849 (  313 1118 ) resistor r=33.1979 //w=0.187 //l=0.485 //layer=li \
 //thickness=0.1 //x=16.89 //y=7.41 //x2=16.89 //y2=6.925
r1850 (  310 1024 ) resistor r=2.87058 //w=0.35 //l=0.085 //layer=li \
 //thickness=0.1 //x=16.095 //y=7.585 //x2=16.01 //y2=7.585
r1851 (  310 312 ) resistor r=23.5422 //w=0.367 //l=0.675 //layer=li \
 //thickness=0.1 //x=16.095 //y=7.585 //x2=16.77 //y2=7.585
r1852 (  309 1025 ) resistor r=2.87058 //w=0.35 //l=0.085 //layer=li \
 //thickness=0.1 //x=16.805 //y=7.585 //x2=16.89 //y2=7.585
r1853 (  309 312 ) resistor r=1.22071 //w=0.367 //l=0.035 //layer=li \
 //thickness=0.1 //x=16.805 //y=7.585 //x2=16.77 //y2=7.585
r1854 (  303 1024 ) resistor r=4.23183 //w=0.7 //l=0.175 //layer=li \
 //thickness=0.1 //x=16.01 //y=7.41 //x2=16.01 //y2=7.585
r1855 (  303 1117 ) resistor r=56.4706 //w=0.187 //l=0.825 //layer=li \
 //thickness=0.1 //x=16.01 //y=7.41 //x2=16.01 //y2=6.585
r1856 (  300 1023 ) resistor r=5.29055 //w=0.35 //l=0.17 //layer=li \
 //thickness=0.1 //x=15.09 //y=7.585 //x2=14.92 //y2=7.585
r1857 (  300 302 ) resistor r=19.8801 //w=0.367 //l=0.57 //layer=li \
 //thickness=0.1 //x=15.09 //y=7.585 //x2=15.66 //y2=7.585
r1858 (  299 1024 ) resistor r=2.87058 //w=0.35 //l=0.085 //layer=li \
 //thickness=0.1 //x=15.925 //y=7.585 //x2=16.01 //y2=7.585
r1859 (  299 302 ) resistor r=9.24251 //w=0.367 //l=0.265 //layer=li \
 //thickness=0.1 //x=15.925 //y=7.585 //x2=15.66 //y2=7.585
r1860 (  294 1022 ) resistor r=2.87058 //w=0.35 //l=0.085 //layer=li \
 //thickness=0.1 //x=13.925 //y=7.585 //x2=13.84 //y2=7.585
r1861 (  294 296 ) resistor r=8.89373 //w=0.367 //l=0.255 //layer=li \
 //thickness=0.1 //x=13.925 //y=7.585 //x2=14.18 //y2=7.585
r1862 (  293 1023 ) resistor r=5.29055 //w=0.35 //l=0.17 //layer=li \
 //thickness=0.1 //x=14.75 //y=7.585 //x2=14.92 //y2=7.585
r1863 (  293 296 ) resistor r=19.8801 //w=0.367 //l=0.57 //layer=li \
 //thickness=0.1 //x=14.75 //y=7.585 //x2=14.18 //y2=7.585
r1864 (  287 1022 ) resistor r=4.23183 //w=0.7 //l=0.175 //layer=li \
 //thickness=0.1 //x=13.84 //y=7.41 //x2=13.84 //y2=7.585
r1865 (  287 1116 ) resistor r=33.1979 //w=0.187 //l=0.485 //layer=li \
 //thickness=0.1 //x=13.84 //y=7.41 //x2=13.84 //y2=6.925
r1866 (  284 1021 ) resistor r=2.87058 //w=0.35 //l=0.085 //layer=li \
 //thickness=0.1 //x=13.045 //y=7.585 //x2=12.96 //y2=7.585
r1867 (  284 286 ) resistor r=0.871935 //w=0.367 //l=0.025 //layer=li \
 //thickness=0.1 //x=13.045 //y=7.585 //x2=13.07 //y2=7.585
r1868 (  283 1022 ) resistor r=2.87058 //w=0.35 //l=0.085 //layer=li \
 //thickness=0.1 //x=13.755 //y=7.585 //x2=13.84 //y2=7.585
r1869 (  283 286 ) resistor r=23.891 //w=0.367 //l=0.685 //layer=li \
 //thickness=0.1 //x=13.755 //y=7.585 //x2=13.07 //y2=7.585
r1870 (  277 1021 ) resistor r=4.23183 //w=0.7 //l=0.175 //layer=li \
 //thickness=0.1 //x=12.96 //y=7.41 //x2=12.96 //y2=7.585
r1871 (  277 1115 ) resistor r=33.1979 //w=0.187 //l=0.485 //layer=li \
 //thickness=0.1 //x=12.96 //y=7.41 //x2=12.96 //y2=6.925
r1872 (  276 1020 ) resistor r=2.87058 //w=0.35 //l=0.085 //layer=li \
 //thickness=0.1 //x=12.165 //y=7.585 //x2=12.08 //y2=7.585
r1873 (  275 1021 ) resistor r=2.87058 //w=0.35 //l=0.085 //layer=li \
 //thickness=0.1 //x=12.875 //y=7.585 //x2=12.96 //y2=7.585
r1874 (  275 276 ) resistor r=24.7629 //w=0.367 //l=0.71 //layer=li \
 //thickness=0.1 //x=12.875 //y=7.585 //x2=12.165 //y2=7.585
r1875 (  269 1020 ) resistor r=4.23183 //w=0.7 //l=0.175 //layer=li \
 //thickness=0.1 //x=12.08 //y=7.41 //x2=12.08 //y2=7.585
r1876 (  269 1114 ) resistor r=33.1979 //w=0.187 //l=0.485 //layer=li \
 //thickness=0.1 //x=12.08 //y=7.41 //x2=12.08 //y2=6.925
r1877 (  266 1019 ) resistor r=2.87058 //w=0.35 //l=0.085 //layer=li \
 //thickness=0.1 //x=11.285 //y=7.585 //x2=11.2 //y2=7.585
r1878 (  266 268 ) resistor r=23.5422 //w=0.367 //l=0.675 //layer=li \
 //thickness=0.1 //x=11.285 //y=7.585 //x2=11.96 //y2=7.585
r1879 (  265 1020 ) resistor r=2.87058 //w=0.35 //l=0.085 //layer=li \
 //thickness=0.1 //x=11.995 //y=7.585 //x2=12.08 //y2=7.585
r1880 (  265 268 ) resistor r=1.22071 //w=0.367 //l=0.035 //layer=li \
 //thickness=0.1 //x=11.995 //y=7.585 //x2=11.96 //y2=7.585
r1881 (  259 1019 ) resistor r=4.23183 //w=0.7 //l=0.175 //layer=li \
 //thickness=0.1 //x=11.2 //y=7.41 //x2=11.2 //y2=7.585
r1882 (  259 1113 ) resistor r=56.4706 //w=0.187 //l=0.825 //layer=li \
 //thickness=0.1 //x=11.2 //y=7.41 //x2=11.2 //y2=6.585
r1883 (  256 1018 ) resistor r=5.29055 //w=0.35 //l=0.17 //layer=li \
 //thickness=0.1 //x=10.28 //y=7.585 //x2=10.11 //y2=7.585
r1884 (  256 258 ) resistor r=19.8801 //w=0.367 //l=0.57 //layer=li \
 //thickness=0.1 //x=10.28 //y=7.585 //x2=10.85 //y2=7.585
r1885 (  255 1019 ) resistor r=2.87058 //w=0.35 //l=0.085 //layer=li \
 //thickness=0.1 //x=11.115 //y=7.585 //x2=11.2 //y2=7.585
r1886 (  255 258 ) resistor r=9.24251 //w=0.367 //l=0.265 //layer=li \
 //thickness=0.1 //x=11.115 //y=7.585 //x2=10.85 //y2=7.585
r1887 (  250 1017 ) resistor r=2.87058 //w=0.35 //l=0.085 //layer=li \
 //thickness=0.1 //x=9.115 //y=7.585 //x2=9.03 //y2=7.585
r1888 (  250 252 ) resistor r=8.89373 //w=0.367 //l=0.255 //layer=li \
 //thickness=0.1 //x=9.115 //y=7.585 //x2=9.37 //y2=7.585
r1889 (  249 1018 ) resistor r=5.29055 //w=0.35 //l=0.17 //layer=li \
 //thickness=0.1 //x=9.94 //y=7.585 //x2=10.11 //y2=7.585
r1890 (  249 252 ) resistor r=19.8801 //w=0.367 //l=0.57 //layer=li \
 //thickness=0.1 //x=9.94 //y=7.585 //x2=9.37 //y2=7.585
r1891 (  243 1017 ) resistor r=4.23183 //w=0.7 //l=0.175 //layer=li \
 //thickness=0.1 //x=9.03 //y=7.41 //x2=9.03 //y2=7.585
r1892 (  243 1112 ) resistor r=33.1979 //w=0.187 //l=0.485 //layer=li \
 //thickness=0.1 //x=9.03 //y=7.41 //x2=9.03 //y2=6.925
r1893 (  240 1016 ) resistor r=2.87058 //w=0.35 //l=0.085 //layer=li \
 //thickness=0.1 //x=8.235 //y=7.585 //x2=8.15 //y2=7.585
r1894 (  240 242 ) resistor r=0.871935 //w=0.367 //l=0.025 //layer=li \
 //thickness=0.1 //x=8.235 //y=7.585 //x2=8.26 //y2=7.585
r1895 (  239 1017 ) resistor r=2.87058 //w=0.35 //l=0.085 //layer=li \
 //thickness=0.1 //x=8.945 //y=7.585 //x2=9.03 //y2=7.585
r1896 (  239 242 ) resistor r=23.891 //w=0.367 //l=0.685 //layer=li \
 //thickness=0.1 //x=8.945 //y=7.585 //x2=8.26 //y2=7.585
r1897 (  233 1016 ) resistor r=4.23183 //w=0.7 //l=0.175 //layer=li \
 //thickness=0.1 //x=8.15 //y=7.41 //x2=8.15 //y2=7.585
r1898 (  233 1111 ) resistor r=33.1979 //w=0.187 //l=0.485 //layer=li \
 //thickness=0.1 //x=8.15 //y=7.41 //x2=8.15 //y2=6.925
r1899 (  232 1015 ) resistor r=2.87058 //w=0.35 //l=0.085 //layer=li \
 //thickness=0.1 //x=7.355 //y=7.585 //x2=7.27 //y2=7.585
r1900 (  231 1016 ) resistor r=2.87058 //w=0.35 //l=0.085 //layer=li \
 //thickness=0.1 //x=8.065 //y=7.585 //x2=8.15 //y2=7.585
r1901 (  231 232 ) resistor r=24.7629 //w=0.367 //l=0.71 //layer=li \
 //thickness=0.1 //x=8.065 //y=7.585 //x2=7.355 //y2=7.585
r1902 (  225 1015 ) resistor r=4.23183 //w=0.7 //l=0.175 //layer=li \
 //thickness=0.1 //x=7.27 //y=7.41 //x2=7.27 //y2=7.585
r1903 (  225 1110 ) resistor r=33.1979 //w=0.187 //l=0.485 //layer=li \
 //thickness=0.1 //x=7.27 //y=7.41 //x2=7.27 //y2=6.925
r1904 (  222 1014 ) resistor r=2.87058 //w=0.35 //l=0.085 //layer=li \
 //thickness=0.1 //x=6.475 //y=7.585 //x2=6.39 //y2=7.585
r1905 (  222 224 ) resistor r=23.5422 //w=0.367 //l=0.675 //layer=li \
 //thickness=0.1 //x=6.475 //y=7.585 //x2=7.15 //y2=7.585
r1906 (  221 1015 ) resistor r=2.87058 //w=0.35 //l=0.085 //layer=li \
 //thickness=0.1 //x=7.185 //y=7.585 //x2=7.27 //y2=7.585
r1907 (  221 224 ) resistor r=1.22071 //w=0.367 //l=0.035 //layer=li \
 //thickness=0.1 //x=7.185 //y=7.585 //x2=7.15 //y2=7.585
r1908 (  215 1014 ) resistor r=4.23183 //w=0.7 //l=0.175 //layer=li \
 //thickness=0.1 //x=6.39 //y=7.41 //x2=6.39 //y2=7.585
r1909 (  215 1109 ) resistor r=56.4706 //w=0.187 //l=0.825 //layer=li \
 //thickness=0.1 //x=6.39 //y=7.41 //x2=6.39 //y2=6.585
r1910 (  212 1013 ) resistor r=5.29055 //w=0.35 //l=0.17 //layer=li \
 //thickness=0.1 //x=5.47 //y=7.585 //x2=5.3 //y2=7.585
r1911 (  212 214 ) resistor r=19.8801 //w=0.367 //l=0.57 //layer=li \
 //thickness=0.1 //x=5.47 //y=7.585 //x2=6.04 //y2=7.585
r1912 (  211 1014 ) resistor r=2.87058 //w=0.35 //l=0.085 //layer=li \
 //thickness=0.1 //x=6.305 //y=7.585 //x2=6.39 //y2=7.585
r1913 (  211 214 ) resistor r=9.24251 //w=0.367 //l=0.265 //layer=li \
 //thickness=0.1 //x=6.305 //y=7.585 //x2=6.04 //y2=7.585
r1914 (  206 1012 ) resistor r=2.87058 //w=0.35 //l=0.085 //layer=li \
 //thickness=0.1 //x=4.305 //y=7.585 //x2=4.22 //y2=7.585
r1915 (  206 208 ) resistor r=8.89373 //w=0.367 //l=0.255 //layer=li \
 //thickness=0.1 //x=4.305 //y=7.585 //x2=4.56 //y2=7.585
r1916 (  205 1013 ) resistor r=5.29055 //w=0.35 //l=0.17 //layer=li \
 //thickness=0.1 //x=5.13 //y=7.585 //x2=5.3 //y2=7.585
r1917 (  205 208 ) resistor r=19.8801 //w=0.367 //l=0.57 //layer=li \
 //thickness=0.1 //x=5.13 //y=7.585 //x2=4.56 //y2=7.585
r1918 (  199 1012 ) resistor r=4.23183 //w=0.7 //l=0.175 //layer=li \
 //thickness=0.1 //x=4.22 //y=7.41 //x2=4.22 //y2=7.585
r1919 (  199 1108 ) resistor r=33.1979 //w=0.187 //l=0.485 //layer=li \
 //thickness=0.1 //x=4.22 //y=7.41 //x2=4.22 //y2=6.925
r1920 (  196 1011 ) resistor r=2.87058 //w=0.35 //l=0.085 //layer=li \
 //thickness=0.1 //x=3.425 //y=7.585 //x2=3.34 //y2=7.585
r1921 (  196 198 ) resistor r=0.871935 //w=0.367 //l=0.025 //layer=li \
 //thickness=0.1 //x=3.425 //y=7.585 //x2=3.45 //y2=7.585
r1922 (  195 1012 ) resistor r=2.87058 //w=0.35 //l=0.085 //layer=li \
 //thickness=0.1 //x=4.135 //y=7.585 //x2=4.22 //y2=7.585
r1923 (  195 198 ) resistor r=23.891 //w=0.367 //l=0.685 //layer=li \
 //thickness=0.1 //x=4.135 //y=7.585 //x2=3.45 //y2=7.585
r1924 (  189 1011 ) resistor r=4.23183 //w=0.7 //l=0.175 //layer=li \
 //thickness=0.1 //x=3.34 //y=7.41 //x2=3.34 //y2=7.585
r1925 (  189 1107 ) resistor r=33.1979 //w=0.187 //l=0.485 //layer=li \
 //thickness=0.1 //x=3.34 //y=7.41 //x2=3.34 //y2=6.925
r1926 (  188 1010 ) resistor r=2.87058 //w=0.35 //l=0.085 //layer=li \
 //thickness=0.1 //x=2.545 //y=7.585 //x2=2.46 //y2=7.585
r1927 (  187 1011 ) resistor r=2.87058 //w=0.35 //l=0.085 //layer=li \
 //thickness=0.1 //x=3.255 //y=7.585 //x2=3.34 //y2=7.585
r1928 (  187 188 ) resistor r=24.7629 //w=0.367 //l=0.71 //layer=li \
 //thickness=0.1 //x=3.255 //y=7.585 //x2=2.545 //y2=7.585
r1929 (  181 1010 ) resistor r=4.23183 //w=0.7 //l=0.175 //layer=li \
 //thickness=0.1 //x=2.46 //y=7.41 //x2=2.46 //y2=7.585
r1930 (  181 1106 ) resistor r=33.1979 //w=0.187 //l=0.485 //layer=li \
 //thickness=0.1 //x=2.46 //y=7.41 //x2=2.46 //y2=6.925
r1931 (  178 1009 ) resistor r=2.87058 //w=0.35 //l=0.085 //layer=li \
 //thickness=0.1 //x=1.665 //y=7.585 //x2=1.58 //y2=7.585
r1932 (  178 180 ) resistor r=23.5422 //w=0.367 //l=0.675 //layer=li \
 //thickness=0.1 //x=1.665 //y=7.585 //x2=2.34 //y2=7.585
r1933 (  177 1010 ) resistor r=2.87058 //w=0.35 //l=0.085 //layer=li \
 //thickness=0.1 //x=2.375 //y=7.585 //x2=2.46 //y2=7.585
r1934 (  177 180 ) resistor r=1.22071 //w=0.367 //l=0.035 //layer=li \
 //thickness=0.1 //x=2.375 //y=7.585 //x2=2.34 //y2=7.585
r1935 (  171 1009 ) resistor r=4.23183 //w=0.7 //l=0.175 //layer=li \
 //thickness=0.1 //x=1.58 //y=7.41 //x2=1.58 //y2=7.585
r1936 (  171 1105 ) resistor r=56.4706 //w=0.187 //l=0.825 //layer=li \
 //thickness=0.1 //x=1.58 //y=7.41 //x2=1.58 //y2=6.585
r1937 (  167 1009 ) resistor r=2.87058 //w=0.35 //l=0.085 //layer=li \
 //thickness=0.1 //x=1.495 //y=7.585 //x2=1.58 //y2=7.585
r1938 (  167 170 ) resistor r=9.24251 //w=0.367 //l=0.265 //layer=li \
 //thickness=0.1 //x=1.495 //y=7.585 //x2=1.23 //y2=7.585
r1939 (  163 1006 ) resistor r=3.1 //w=0.17 //l=0.51 //layer=mcon //count=3 \
 //x=96.32 //y=7.58 //x2=96.32 //y2=7.58
r1940 (  161 1004 ) resistor r=3.1 //w=0.17 //l=0.51 //layer=mcon //count=3 \
 //x=95.21 //y=7.58 //x2=95.21 //y2=7.58
r1941 (  161 163 ) resistor r=0.446141 //w=0.311 //l=1.11 //layer=m1 \
 //thickness=0.36 //x=95.21 //y=7.585 //x2=96.32 //y2=7.585
r1942 (  159 1002 ) resistor r=3.1 //w=0.17 //l=0.51 //layer=mcon //count=3 \
 //x=94.1 //y=7.58 //x2=94.1 //y2=7.58
r1943 (  159 161 ) resistor r=0.446141 //w=0.311 //l=1.11 //layer=m1 \
 //thickness=0.36 //x=94.1 //y=7.585 //x2=95.21 //y2=7.585
r1944 (  157 996 ) resistor r=3.1 //w=0.17 //l=0.51 //layer=mcon //count=3 \
 //x=92.62 //y=7.58 //x2=92.62 //y2=7.58
r1945 (  157 159 ) resistor r=0.594855 //w=0.311 //l=1.48 //layer=m1 \
 //thickness=0.36 //x=92.62 //y=7.585 //x2=94.1 //y2=7.585
r1946 (  155 994 ) resistor r=3.1 //w=0.17 //l=0.51 //layer=mcon //count=3 \
 //x=91.51 //y=7.58 //x2=91.51 //y2=7.58
r1947 (  155 157 ) resistor r=0.446141 //w=0.311 //l=1.11 //layer=m1 \
 //thickness=0.36 //x=91.51 //y=7.585 //x2=92.62 //y2=7.585
r1948 (  153 988 ) resistor r=3.1 //w=0.17 //l=0.51 //layer=mcon //count=3 \
 //x=90.03 //y=7.58 //x2=90.03 //y2=7.58
r1949 (  153 155 ) resistor r=0.594855 //w=0.311 //l=1.48 //layer=m1 \
 //thickness=0.36 //x=90.03 //y=7.585 //x2=91.51 //y2=7.585
r1950 (  151 978 ) resistor r=3.1 //w=0.17 //l=0.51 //layer=mcon //count=3 \
 //x=88.92 //y=7.58 //x2=88.92 //y2=7.58
r1951 (  151 153 ) resistor r=0.446141 //w=0.311 //l=1.11 //layer=m1 \
 //thickness=0.36 //x=88.92 //y=7.585 //x2=90.03 //y2=7.585
r1952 (  149 1100 ) resistor r=3.1 //w=0.17 //l=0.51 //layer=mcon //count=3 \
 //x=87.81 //y=7.58 //x2=87.81 //y2=7.58
r1953 (  149 151 ) resistor r=0.446141 //w=0.311 //l=1.11 //layer=m1 \
 //thickness=0.36 //x=87.81 //y=7.585 //x2=88.92 //y2=7.585
r1954 (  147 956 ) resistor r=3.1 //w=0.17 //l=0.51 //layer=mcon //count=3 \
 //x=86.33 //y=7.58 //x2=86.33 //y2=7.58
r1955 (  147 149 ) resistor r=0.594855 //w=0.311 //l=1.48 //layer=m1 \
 //thickness=0.36 //x=86.33 //y=7.585 //x2=87.81 //y2=7.585
r1956 (  145 946 ) resistor r=3.1 //w=0.17 //l=0.51 //layer=mcon //count=3 \
 //x=85.22 //y=7.58 //x2=85.22 //y2=7.58
r1957 (  145 147 ) resistor r=0.446141 //w=0.311 //l=1.11 //layer=m1 \
 //thickness=0.36 //x=85.22 //y=7.585 //x2=86.33 //y2=7.585
r1958 (  143 928 ) resistor r=3.1 //w=0.17 //l=0.51 //layer=mcon //count=3 \
 //x=84.11 //y=7.58 //x2=84.11 //y2=7.58
r1959 (  143 145 ) resistor r=0.446141 //w=0.311 //l=1.11 //layer=m1 \
 //thickness=0.36 //x=84.11 //y=7.585 //x2=85.22 //y2=7.585
r1960 (  141 918 ) resistor r=3.1 //w=0.17 //l=0.51 //layer=mcon //count=3 \
 //x=83 //y=7.58 //x2=83 //y2=7.58
r1961 (  141 143 ) resistor r=0.446141 //w=0.311 //l=1.11 //layer=m1 \
 //thickness=0.36 //x=83 //y=7.585 //x2=84.11 //y2=7.585
r1962 (  139 912 ) resistor r=3.1 //w=0.17 //l=0.51 //layer=mcon //count=3 \
 //x=81.52 //y=7.58 //x2=81.52 //y2=7.58
r1963 (  139 141 ) resistor r=0.594855 //w=0.311 //l=1.48 //layer=m1 \
 //thickness=0.36 //x=81.52 //y=7.585 //x2=83 //y2=7.585
r1964 (  137 902 ) resistor r=3.1 //w=0.17 //l=0.51 //layer=mcon //count=3 \
 //x=80.41 //y=7.58 //x2=80.41 //y2=7.58
r1965 (  137 139 ) resistor r=0.446141 //w=0.311 //l=1.11 //layer=m1 \
 //thickness=0.36 //x=80.41 //y=7.585 //x2=81.52 //y2=7.585
r1966 (  135 884 ) resistor r=3.1 //w=0.17 //l=0.51 //layer=mcon //count=3 \
 //x=79.3 //y=7.58 //x2=79.3 //y2=7.58
r1967 (  135 137 ) resistor r=0.446141 //w=0.311 //l=1.11 //layer=m1 \
 //thickness=0.36 //x=79.3 //y=7.585 //x2=80.41 //y2=7.585
r1968 (  133 874 ) resistor r=3.1 //w=0.17 //l=0.51 //layer=mcon //count=3 \
 //x=78.19 //y=7.58 //x2=78.19 //y2=7.58
r1969 (  133 135 ) resistor r=0.446141 //w=0.311 //l=1.11 //layer=m1 \
 //thickness=0.36 //x=78.19 //y=7.585 //x2=79.3 //y2=7.585
r1970 (  131 868 ) resistor r=3.1 //w=0.17 //l=0.51 //layer=mcon //count=3 \
 //x=76.71 //y=7.58 //x2=76.71 //y2=7.58
r1971 (  131 133 ) resistor r=0.594855 //w=0.311 //l=1.48 //layer=m1 \
 //thickness=0.36 //x=76.71 //y=7.585 //x2=78.19 //y2=7.585
r1972 (  129 858 ) resistor r=3.1 //w=0.17 //l=0.51 //layer=mcon //count=3 \
 //x=75.6 //y=7.58 //x2=75.6 //y2=7.58
r1973 (  129 131 ) resistor r=0.446141 //w=0.311 //l=1.11 //layer=m1 \
 //thickness=0.36 //x=75.6 //y=7.585 //x2=76.71 //y2=7.585
r1974 (  127 840 ) resistor r=3.1 //w=0.17 //l=0.51 //layer=mcon //count=3 \
 //x=74.49 //y=7.58 //x2=74.49 //y2=7.58
r1975 (  127 129 ) resistor r=0.446141 //w=0.311 //l=1.11 //layer=m1 \
 //thickness=0.36 //x=74.49 //y=7.585 //x2=75.6 //y2=7.585
r1976 (  125 830 ) resistor r=3.1 //w=0.17 //l=0.51 //layer=mcon //count=3 \
 //x=73.38 //y=7.58 //x2=73.38 //y2=7.58
r1977 (  125 127 ) resistor r=0.446141 //w=0.311 //l=1.11 //layer=m1 \
 //thickness=0.36 //x=73.38 //y=7.585 //x2=74.49 //y2=7.585
r1978 (  123 824 ) resistor r=3.1 //w=0.17 //l=0.51 //layer=mcon //count=3 \
 //x=71.9 //y=7.58 //x2=71.9 //y2=7.58
r1979 (  123 125 ) resistor r=0.594855 //w=0.311 //l=1.48 //layer=m1 \
 //thickness=0.36 //x=71.9 //y=7.585 //x2=73.38 //y2=7.585
r1980 (  121 814 ) resistor r=3.1 //w=0.17 //l=0.51 //layer=mcon //count=3 \
 //x=70.79 //y=7.58 //x2=70.79 //y2=7.58
r1981 (  121 123 ) resistor r=0.446141 //w=0.311 //l=1.11 //layer=m1 \
 //thickness=0.36 //x=70.79 //y=7.585 //x2=71.9 //y2=7.585
r1982 (  119 796 ) resistor r=3.1 //w=0.17 //l=0.51 //layer=mcon //count=3 \
 //x=69.68 //y=7.58 //x2=69.68 //y2=7.58
r1983 (  119 121 ) resistor r=0.446141 //w=0.311 //l=1.11 //layer=m1 \
 //thickness=0.36 //x=69.68 //y=7.585 //x2=70.79 //y2=7.585
r1984 (  117 786 ) resistor r=3.1 //w=0.17 //l=0.51 //layer=mcon //count=3 \
 //x=68.57 //y=7.58 //x2=68.57 //y2=7.58
r1985 (  117 119 ) resistor r=0.446141 //w=0.311 //l=1.11 //layer=m1 \
 //thickness=0.36 //x=68.57 //y=7.585 //x2=69.68 //y2=7.585
r1986 (  115 780 ) resistor r=3.1 //w=0.17 //l=0.51 //layer=mcon //count=3 \
 //x=67.09 //y=7.58 //x2=67.09 //y2=7.58
r1987 (  115 117 ) resistor r=0.594855 //w=0.311 //l=1.48 //layer=m1 \
 //thickness=0.36 //x=67.09 //y=7.585 //x2=68.57 //y2=7.585
r1988 (  113 770 ) resistor r=3.1 //w=0.17 //l=0.51 //layer=mcon //count=3 \
 //x=65.98 //y=7.58 //x2=65.98 //y2=7.58
r1989 (  113 115 ) resistor r=0.446141 //w=0.311 //l=1.11 //layer=m1 \
 //thickness=0.36 //x=65.98 //y=7.585 //x2=67.09 //y2=7.585
r1990 (  111 752 ) resistor r=3.1 //w=0.17 //l=0.51 //layer=mcon //count=3 \
 //x=64.87 //y=7.58 //x2=64.87 //y2=7.58
r1991 (  111 113 ) resistor r=0.446141 //w=0.311 //l=1.11 //layer=m1 \
 //thickness=0.36 //x=64.87 //y=7.585 //x2=65.98 //y2=7.585
r1992 (  109 742 ) resistor r=3.1 //w=0.17 //l=0.51 //layer=mcon //count=3 \
 //x=63.76 //y=7.58 //x2=63.76 //y2=7.58
r1993 (  109 111 ) resistor r=0.446141 //w=0.311 //l=1.11 //layer=m1 \
 //thickness=0.36 //x=63.76 //y=7.585 //x2=64.87 //y2=7.585
r1994 (  107 736 ) resistor r=3.1 //w=0.17 //l=0.51 //layer=mcon //count=3 \
 //x=62.28 //y=7.58 //x2=62.28 //y2=7.58
r1995 (  107 109 ) resistor r=0.594855 //w=0.311 //l=1.48 //layer=m1 \
 //thickness=0.36 //x=62.28 //y=7.585 //x2=63.76 //y2=7.585
r1996 (  105 726 ) resistor r=3.1 //w=0.17 //l=0.51 //layer=mcon //count=3 \
 //x=61.17 //y=7.58 //x2=61.17 //y2=7.58
r1997 (  105 107 ) resistor r=0.446141 //w=0.311 //l=1.11 //layer=m1 \
 //thickness=0.36 //x=61.17 //y=7.585 //x2=62.28 //y2=7.585
r1998 (  103 708 ) resistor r=3.1 //w=0.17 //l=0.51 //layer=mcon //count=3 \
 //x=60.06 //y=7.58 //x2=60.06 //y2=7.58
r1999 (  103 105 ) resistor r=0.446141 //w=0.311 //l=1.11 //layer=m1 \
 //thickness=0.36 //x=60.06 //y=7.585 //x2=61.17 //y2=7.585
r2000 (  101 698 ) resistor r=3.1 //w=0.17 //l=0.51 //layer=mcon //count=3 \
 //x=58.95 //y=7.58 //x2=58.95 //y2=7.58
r2001 (  101 103 ) resistor r=0.446141 //w=0.311 //l=1.11 //layer=m1 \
 //thickness=0.36 //x=58.95 //y=7.585 //x2=60.06 //y2=7.585
r2002 (  99 692 ) resistor r=3.1 //w=0.17 //l=0.51 //layer=mcon //count=3 \
 //x=57.47 //y=7.58 //x2=57.47 //y2=7.58
r2003 (  99 101 ) resistor r=0.594855 //w=0.311 //l=1.48 //layer=m1 \
 //thickness=0.36 //x=57.47 //y=7.585 //x2=58.95 //y2=7.585
r2004 (  97 682 ) resistor r=3.1 //w=0.17 //l=0.51 //layer=mcon //count=3 \
 //x=56.36 //y=7.58 //x2=56.36 //y2=7.58
r2005 (  97 99 ) resistor r=0.446141 //w=0.311 //l=1.11 //layer=m1 \
 //thickness=0.36 //x=56.36 //y=7.585 //x2=57.47 //y2=7.585
r2006 (  95 664 ) resistor r=3.1 //w=0.17 //l=0.51 //layer=mcon //count=3 \
 //x=55.25 //y=7.58 //x2=55.25 //y2=7.58
r2007 (  95 97 ) resistor r=0.446141 //w=0.311 //l=1.11 //layer=m1 \
 //thickness=0.36 //x=55.25 //y=7.585 //x2=56.36 //y2=7.585
r2008 (  93 654 ) resistor r=3.1 //w=0.17 //l=0.51 //layer=mcon //count=3 \
 //x=54.14 //y=7.58 //x2=54.14 //y2=7.58
r2009 (  93 95 ) resistor r=0.446141 //w=0.311 //l=1.11 //layer=m1 \
 //thickness=0.36 //x=54.14 //y=7.585 //x2=55.25 //y2=7.585
r2010 (  91 648 ) resistor r=3.1 //w=0.17 //l=0.51 //layer=mcon //count=3 \
 //x=52.66 //y=7.58 //x2=52.66 //y2=7.58
r2011 (  91 93 ) resistor r=0.594855 //w=0.311 //l=1.48 //layer=m1 \
 //thickness=0.36 //x=52.66 //y=7.585 //x2=54.14 //y2=7.585
r2012 (  89 638 ) resistor r=3.1 //w=0.17 //l=0.51 //layer=mcon //count=3 \
 //x=51.55 //y=7.58 //x2=51.55 //y2=7.58
r2013 (  89 91 ) resistor r=0.446141 //w=0.311 //l=1.11 //layer=m1 \
 //thickness=0.36 //x=51.55 //y=7.585 //x2=52.66 //y2=7.585
r2014 (  87 620 ) resistor r=3.1 //w=0.17 //l=0.51 //layer=mcon //count=3 \
 //x=50.44 //y=7.58 //x2=50.44 //y2=7.58
r2015 (  87 89 ) resistor r=0.446141 //w=0.311 //l=1.11 //layer=m1 \
 //thickness=0.36 //x=50.44 //y=7.585 //x2=51.55 //y2=7.585
r2016 (  85 610 ) resistor r=3.1 //w=0.17 //l=0.51 //layer=mcon //count=3 \
 //x=49.33 //y=7.58 //x2=49.33 //y2=7.58
r2017 (  85 87 ) resistor r=0.446141 //w=0.311 //l=1.11 //layer=m1 \
 //thickness=0.36 //x=49.33 //y=7.585 //x2=50.44 //y2=7.585
r2018 (  82 604 ) resistor r=3.1 //w=0.17 //l=0.51 //layer=mcon //count=3 \
 //x=47.85 //y=7.58 //x2=47.85 //y2=7.58
r2019 (  80 594 ) resistor r=3.1 //w=0.17 //l=0.51 //layer=mcon //count=3 \
 //x=46.74 //y=7.58 //x2=46.74 //y2=7.58
r2020 (  80 82 ) resistor r=0.446141 //w=0.311 //l=1.11 //layer=m1 \
 //thickness=0.36 //x=46.74 //y=7.585 //x2=47.85 //y2=7.585
r2021 (  78 576 ) resistor r=3.1 //w=0.17 //l=0.51 //layer=mcon //count=3 \
 //x=45.63 //y=7.58 //x2=45.63 //y2=7.58
r2022 (  78 80 ) resistor r=0.446141 //w=0.311 //l=1.11 //layer=m1 \
 //thickness=0.36 //x=45.63 //y=7.585 //x2=46.74 //y2=7.585
r2023 (  76 566 ) resistor r=3.1 //w=0.17 //l=0.51 //layer=mcon //count=3 \
 //x=44.52 //y=7.58 //x2=44.52 //y2=7.58
r2024 (  76 78 ) resistor r=0.446141 //w=0.311 //l=1.11 //layer=m1 \
 //thickness=0.36 //x=44.52 //y=7.585 //x2=45.63 //y2=7.585
r2025 (  74 560 ) resistor r=3.1 //w=0.17 //l=0.51 //layer=mcon //count=3 \
 //x=43.04 //y=7.58 //x2=43.04 //y2=7.58
r2026 (  74 76 ) resistor r=0.594855 //w=0.311 //l=1.48 //layer=m1 \
 //thickness=0.36 //x=43.04 //y=7.585 //x2=44.52 //y2=7.585
r2027 (  72 550 ) resistor r=3.1 //w=0.17 //l=0.51 //layer=mcon //count=3 \
 //x=41.93 //y=7.58 //x2=41.93 //y2=7.58
r2028 (  72 74 ) resistor r=0.446141 //w=0.311 //l=1.11 //layer=m1 \
 //thickness=0.36 //x=41.93 //y=7.585 //x2=43.04 //y2=7.585
r2029 (  70 532 ) resistor r=3.1 //w=0.17 //l=0.51 //layer=mcon //count=3 \
 //x=40.82 //y=7.58 //x2=40.82 //y2=7.58
r2030 (  70 72 ) resistor r=0.446141 //w=0.311 //l=1.11 //layer=m1 \
 //thickness=0.36 //x=40.82 //y=7.585 //x2=41.93 //y2=7.585
r2031 (  68 522 ) resistor r=3.1 //w=0.17 //l=0.51 //layer=mcon //count=3 \
 //x=39.71 //y=7.58 //x2=39.71 //y2=7.58
r2032 (  68 70 ) resistor r=0.446141 //w=0.311 //l=1.11 //layer=m1 \
 //thickness=0.36 //x=39.71 //y=7.585 //x2=40.82 //y2=7.585
r2033 (  66 516 ) resistor r=3.1 //w=0.17 //l=0.51 //layer=mcon //count=3 \
 //x=38.23 //y=7.58 //x2=38.23 //y2=7.58
r2034 (  66 68 ) resistor r=0.594855 //w=0.311 //l=1.48 //layer=m1 \
 //thickness=0.36 //x=38.23 //y=7.585 //x2=39.71 //y2=7.585
r2035 (  64 506 ) resistor r=3.1 //w=0.17 //l=0.51 //layer=mcon //count=3 \
 //x=37.12 //y=7.58 //x2=37.12 //y2=7.58
r2036 (  64 66 ) resistor r=0.446141 //w=0.311 //l=1.11 //layer=m1 \
 //thickness=0.36 //x=37.12 //y=7.585 //x2=38.23 //y2=7.585
r2037 (  62 488 ) resistor r=3.1 //w=0.17 //l=0.51 //layer=mcon //count=3 \
 //x=36.01 //y=7.58 //x2=36.01 //y2=7.58
r2038 (  62 64 ) resistor r=0.446141 //w=0.311 //l=1.11 //layer=m1 \
 //thickness=0.36 //x=36.01 //y=7.585 //x2=37.12 //y2=7.585
r2039 (  60 478 ) resistor r=3.1 //w=0.17 //l=0.51 //layer=mcon //count=3 \
 //x=34.9 //y=7.58 //x2=34.9 //y2=7.58
r2040 (  60 62 ) resistor r=0.446141 //w=0.311 //l=1.11 //layer=m1 \
 //thickness=0.36 //x=34.9 //y=7.585 //x2=36.01 //y2=7.585
r2041 (  58 472 ) resistor r=3.1 //w=0.17 //l=0.51 //layer=mcon //count=3 \
 //x=33.42 //y=7.58 //x2=33.42 //y2=7.58
r2042 (  58 60 ) resistor r=0.594855 //w=0.311 //l=1.48 //layer=m1 \
 //thickness=0.36 //x=33.42 //y=7.585 //x2=34.9 //y2=7.585
r2043 (  56 462 ) resistor r=3.1 //w=0.17 //l=0.51 //layer=mcon //count=3 \
 //x=32.31 //y=7.58 //x2=32.31 //y2=7.58
r2044 (  56 58 ) resistor r=0.446141 //w=0.311 //l=1.11 //layer=m1 \
 //thickness=0.36 //x=32.31 //y=7.585 //x2=33.42 //y2=7.585
r2045 (  54 444 ) resistor r=3.1 //w=0.17 //l=0.51 //layer=mcon //count=3 \
 //x=31.2 //y=7.58 //x2=31.2 //y2=7.58
r2046 (  54 56 ) resistor r=0.446141 //w=0.311 //l=1.11 //layer=m1 \
 //thickness=0.36 //x=31.2 //y=7.585 //x2=32.31 //y2=7.585
r2047 (  52 434 ) resistor r=3.1 //w=0.17 //l=0.51 //layer=mcon //count=3 \
 //x=30.09 //y=7.58 //x2=30.09 //y2=7.58
r2048 (  52 54 ) resistor r=0.446141 //w=0.311 //l=1.11 //layer=m1 \
 //thickness=0.36 //x=30.09 //y=7.585 //x2=31.2 //y2=7.585
r2049 (  50 428 ) resistor r=3.1 //w=0.17 //l=0.51 //layer=mcon //count=3 \
 //x=28.61 //y=7.58 //x2=28.61 //y2=7.58
r2050 (  50 52 ) resistor r=0.594855 //w=0.311 //l=1.48 //layer=m1 \
 //thickness=0.36 //x=28.61 //y=7.585 //x2=30.09 //y2=7.585
r2051 (  48 418 ) resistor r=3.1 //w=0.17 //l=0.51 //layer=mcon //count=3 \
 //x=27.5 //y=7.58 //x2=27.5 //y2=7.58
r2052 (  48 50 ) resistor r=0.446141 //w=0.311 //l=1.11 //layer=m1 \
 //thickness=0.36 //x=27.5 //y=7.585 //x2=28.61 //y2=7.585
r2053 (  46 400 ) resistor r=3.1 //w=0.17 //l=0.51 //layer=mcon //count=3 \
 //x=26.39 //y=7.58 //x2=26.39 //y2=7.58
r2054 (  46 48 ) resistor r=0.446141 //w=0.311 //l=1.11 //layer=m1 \
 //thickness=0.36 //x=26.39 //y=7.585 //x2=27.5 //y2=7.585
r2055 (  44 390 ) resistor r=3.1 //w=0.17 //l=0.51 //layer=mcon //count=3 \
 //x=25.28 //y=7.58 //x2=25.28 //y2=7.58
r2056 (  44 46 ) resistor r=0.446141 //w=0.311 //l=1.11 //layer=m1 \
 //thickness=0.36 //x=25.28 //y=7.585 //x2=26.39 //y2=7.585
r2057 (  42 384 ) resistor r=3.1 //w=0.17 //l=0.51 //layer=mcon //count=3 \
 //x=23.8 //y=7.58 //x2=23.8 //y2=7.58
r2058 (  42 44 ) resistor r=0.594855 //w=0.311 //l=1.48 //layer=m1 \
 //thickness=0.36 //x=23.8 //y=7.585 //x2=25.28 //y2=7.585
r2059 (  40 374 ) resistor r=3.1 //w=0.17 //l=0.51 //layer=mcon //count=3 \
 //x=22.69 //y=7.58 //x2=22.69 //y2=7.58
r2060 (  40 42 ) resistor r=0.446141 //w=0.311 //l=1.11 //layer=m1 \
 //thickness=0.36 //x=22.69 //y=7.585 //x2=23.8 //y2=7.585
r2061 (  38 356 ) resistor r=3.1 //w=0.17 //l=0.51 //layer=mcon //count=3 \
 //x=21.58 //y=7.58 //x2=21.58 //y2=7.58
r2062 (  38 40 ) resistor r=0.446141 //w=0.311 //l=1.11 //layer=m1 \
 //thickness=0.36 //x=21.58 //y=7.585 //x2=22.69 //y2=7.585
r2063 (  36 346 ) resistor r=3.1 //w=0.17 //l=0.51 //layer=mcon //count=3 \
 //x=20.47 //y=7.58 //x2=20.47 //y2=7.58
r2064 (  36 38 ) resistor r=0.446141 //w=0.311 //l=1.11 //layer=m1 \
 //thickness=0.36 //x=20.47 //y=7.585 //x2=21.58 //y2=7.585
r2065 (  34 340 ) resistor r=3.1 //w=0.17 //l=0.51 //layer=mcon //count=3 \
 //x=18.99 //y=7.58 //x2=18.99 //y2=7.58
r2066 (  34 36 ) resistor r=0.594855 //w=0.311 //l=1.48 //layer=m1 \
 //thickness=0.36 //x=18.99 //y=7.585 //x2=20.47 //y2=7.585
r2067 (  32 330 ) resistor r=3.1 //w=0.17 //l=0.51 //layer=mcon //count=3 \
 //x=17.88 //y=7.58 //x2=17.88 //y2=7.58
r2068 (  32 34 ) resistor r=0.446141 //w=0.311 //l=1.11 //layer=m1 \
 //thickness=0.36 //x=17.88 //y=7.585 //x2=18.99 //y2=7.585
r2069 (  30 312 ) resistor r=3.1 //w=0.17 //l=0.51 //layer=mcon //count=3 \
 //x=16.77 //y=7.58 //x2=16.77 //y2=7.58
r2070 (  30 32 ) resistor r=0.446141 //w=0.311 //l=1.11 //layer=m1 \
 //thickness=0.36 //x=16.77 //y=7.585 //x2=17.88 //y2=7.585
r2071 (  28 302 ) resistor r=3.1 //w=0.17 //l=0.51 //layer=mcon //count=3 \
 //x=15.66 //y=7.58 //x2=15.66 //y2=7.58
r2072 (  28 30 ) resistor r=0.446141 //w=0.311 //l=1.11 //layer=m1 \
 //thickness=0.36 //x=15.66 //y=7.585 //x2=16.77 //y2=7.585
r2073 (  26 296 ) resistor r=3.1 //w=0.17 //l=0.51 //layer=mcon //count=3 \
 //x=14.18 //y=7.58 //x2=14.18 //y2=7.58
r2074 (  26 28 ) resistor r=0.594855 //w=0.311 //l=1.48 //layer=m1 \
 //thickness=0.36 //x=14.18 //y=7.585 //x2=15.66 //y2=7.585
r2075 (  24 286 ) resistor r=3.1 //w=0.17 //l=0.51 //layer=mcon //count=3 \
 //x=13.07 //y=7.58 //x2=13.07 //y2=7.58
r2076 (  24 26 ) resistor r=0.446141 //w=0.311 //l=1.11 //layer=m1 \
 //thickness=0.36 //x=13.07 //y=7.585 //x2=14.18 //y2=7.585
r2077 (  22 268 ) resistor r=3.1 //w=0.17 //l=0.51 //layer=mcon //count=3 \
 //x=11.96 //y=7.58 //x2=11.96 //y2=7.58
r2078 (  22 24 ) resistor r=0.446141 //w=0.311 //l=1.11 //layer=m1 \
 //thickness=0.36 //x=11.96 //y=7.585 //x2=13.07 //y2=7.585
r2079 (  20 258 ) resistor r=3.1 //w=0.17 //l=0.51 //layer=mcon //count=3 \
 //x=10.85 //y=7.58 //x2=10.85 //y2=7.58
r2080 (  20 22 ) resistor r=0.446141 //w=0.311 //l=1.11 //layer=m1 \
 //thickness=0.36 //x=10.85 //y=7.585 //x2=11.96 //y2=7.585
r2081 (  18 252 ) resistor r=3.1 //w=0.17 //l=0.51 //layer=mcon //count=3 \
 //x=9.37 //y=7.58 //x2=9.37 //y2=7.58
r2082 (  18 20 ) resistor r=0.594855 //w=0.311 //l=1.48 //layer=m1 \
 //thickness=0.36 //x=9.37 //y=7.585 //x2=10.85 //y2=7.585
r2083 (  16 242 ) resistor r=3.1 //w=0.17 //l=0.51 //layer=mcon //count=3 \
 //x=8.26 //y=7.58 //x2=8.26 //y2=7.58
r2084 (  16 18 ) resistor r=0.446141 //w=0.311 //l=1.11 //layer=m1 \
 //thickness=0.36 //x=8.26 //y=7.585 //x2=9.37 //y2=7.585
r2085 (  14 224 ) resistor r=3.1 //w=0.17 //l=0.51 //layer=mcon //count=3 \
 //x=7.15 //y=7.58 //x2=7.15 //y2=7.58
r2086 (  14 16 ) resistor r=0.446141 //w=0.311 //l=1.11 //layer=m1 \
 //thickness=0.36 //x=7.15 //y=7.585 //x2=8.26 //y2=7.585
r2087 (  12 214 ) resistor r=3.1 //w=0.17 //l=0.51 //layer=mcon //count=3 \
 //x=6.04 //y=7.58 //x2=6.04 //y2=7.58
r2088 (  12 14 ) resistor r=0.446141 //w=0.311 //l=1.11 //layer=m1 \
 //thickness=0.36 //x=6.04 //y=7.585 //x2=7.15 //y2=7.585
r2089 (  10 208 ) resistor r=3.1 //w=0.17 //l=0.51 //layer=mcon //count=3 \
 //x=4.56 //y=7.58 //x2=4.56 //y2=7.58
r2090 (  10 12 ) resistor r=0.594855 //w=0.311 //l=1.48 //layer=m1 \
 //thickness=0.36 //x=4.56 //y=7.585 //x2=6.04 //y2=7.585
r2091 (  8 198 ) resistor r=3.1 //w=0.17 //l=0.51 //layer=mcon //count=3 \
 //x=3.45 //y=7.58 //x2=3.45 //y2=7.58
r2092 (  8 10 ) resistor r=0.446141 //w=0.311 //l=1.11 //layer=m1 \
 //thickness=0.36 //x=3.45 //y=7.585 //x2=4.56 //y2=7.585
r2093 (  6 180 ) resistor r=3.1 //w=0.17 //l=0.51 //layer=mcon //count=3 \
 //x=2.34 //y=7.58 //x2=2.34 //y2=7.58
r2094 (  6 8 ) resistor r=0.446141 //w=0.311 //l=1.11 //layer=m1 \
 //thickness=0.36 //x=2.34 //y=7.585 //x2=3.45 //y2=7.585
r2095 (  3 170 ) resistor r=3.1 //w=0.17 //l=0.51 //layer=mcon //count=3 \
 //x=1.23 //y=7.58 //x2=1.23 //y2=7.58
r2096 (  3 6 ) resistor r=0.446141 //w=0.311 //l=1.11 //layer=m1 \
 //thickness=0.36 //x=1.23 //y=7.585 //x2=2.34 //y2=7.585
r2097 (  1 85 ) resistor r=0.223071 //w=0.311 //l=0.555 //layer=m1 \
 //thickness=0.36 //x=48.775 //y=7.585 //x2=49.33 //y2=7.585
r2098 (  1 82 ) resistor r=0.371785 //w=0.311 //l=0.925 //layer=m1 \
 //thickness=0.36 //x=48.775 //y=7.585 //x2=47.85 //y2=7.585
ends PM_TMRDFFSNRNQNX1\%VDD

subckt PM_TMRDFFSNRNQNX1\%noxref_3 ( 1 2 3 4 17 18 25 33 39 40 44 46 54 61 62 \
 63 64 65 66 67 68 69 70 71 72 73 75 81 82 83 84 88 89 90 91 92 94 100 101 102 \
 103 123 125 126 127 )
c240 ( 127 0 ) capacitor c=0.023087f //x=3.635 //y=5.2
c241 ( 126 0 ) capacitor c=0.023519f //x=2.755 //y=5.2
c242 ( 125 0 ) capacitor c=0.0224735f //x=1.875 //y=5.2
c243 ( 123 0 ) capacitor c=0.00853354f //x=3.885 //y=1.095
c244 ( 103 0 ) capacitor c=0.0556143f //x=11.495 //y=4.97
c245 ( 102 0 ) capacitor c=0.0293157f //x=11.785 //y=4.97
c246 ( 101 0 ) capacitor c=0.0347816f //x=11.45 //y=1.4
c247 ( 100 0 ) capacitor c=0.0187487f //x=11.45 //y=1.055
c248 ( 94 0 ) capacitor c=0.0137055f //x=11.295 //y=1.555
c249 ( 92 0 ) capacitor c=0.0149861f //x=11.295 //y=0.9
c250 ( 91 0 ) capacitor c=0.096037f //x=10.92 //y=2.095
c251 ( 90 0 ) capacitor c=0.0228993f //x=10.92 //y=1.71
c252 ( 89 0 ) capacitor c=0.0234352f //x=10.92 //y=1.4
c253 ( 88 0 ) capacitor c=0.0198724f //x=10.92 //y=1.055
c254 ( 84 0 ) capacitor c=0.055995f //x=6.685 //y=4.97
c255 ( 83 0 ) capacitor c=0.0298189f //x=6.975 //y=4.97
c256 ( 82 0 ) capacitor c=0.0347816f //x=6.64 //y=1.4
c257 ( 81 0 ) capacitor c=0.0187487f //x=6.64 //y=1.055
c258 ( 75 0 ) capacitor c=0.0137055f //x=6.485 //y=1.555
c259 ( 73 0 ) capacitor c=0.0149861f //x=6.485 //y=0.9
c260 ( 72 0 ) capacitor c=0.096037f //x=6.11 //y=2.095
c261 ( 71 0 ) capacitor c=0.0228993f //x=6.11 //y=1.71
c262 ( 70 0 ) capacitor c=0.0234352f //x=6.11 //y=1.4
c263 ( 69 0 ) capacitor c=0.0198724f //x=6.11 //y=1.055
c264 ( 68 0 ) capacitor c=0.110114f //x=11.86 //y=6.2
c265 ( 67 0 ) capacitor c=0.158956f //x=11.42 //y=6.2
c266 ( 66 0 ) capacitor c=0.110114f //x=7.05 //y=6.2
c267 ( 65 0 ) capacitor c=0.158956f //x=6.61 //y=6.2
c268 ( 62 0 ) capacitor c=0.00116729f //x=3.78 //y=5.335
c269 ( 61 0 ) capacitor c=0.00226015f //x=2.9 //y=5.335
c270 ( 54 0 ) capacitor c=0.0970684f //x=11.22 //y=2.26
c271 ( 46 0 ) capacitor c=0.102314f //x=6.41 //y=2.26
c272 ( 44 0 ) capacitor c=0.111586f //x=4.56 //y=2.77
c273 ( 40 0 ) capacitor c=0.00398962f //x=4.16 //y=1.845
c274 ( 39 0 ) capacitor c=0.0137288f //x=4.475 //y=1.845
c275 ( 33 0 ) capacitor c=0.0291119f //x=4.475 //y=5.335
c276 ( 25 0 ) capacitor c=0.0184197f //x=3.695 //y=5.335
c277 ( 18 0 ) capacitor c=0.00351598f //x=2.105 //y=5.335
c278 ( 17 0 ) capacitor c=0.0155255f //x=2.815 //y=5.335
c279 ( 4 0 ) capacitor c=0.00440131f //x=6.525 //y=2.77
c280 ( 3 0 ) capacitor c=0.0870935f //x=11.105 //y=2.77
c281 ( 2 0 ) capacitor c=0.0124623f //x=4.675 //y=2.77
c282 ( 1 0 ) capacitor c=0.0300768f //x=6.295 //y=2.77
r283 (  102 104 ) resistor r=26.9307 //w=0.15 //l=0.106066 //layer=ply \
 //thickness=0.18 //x=11.785 //y=4.97 //x2=11.86 //y2=5.045
r284 (  102 103 ) resistor r=148.702 //w=0.094 //l=0.29 //layer=ply \
 //thickness=0.18 //x=11.785 //y=4.97 //x2=11.495 //y2=4.97
r285 (  101 122 ) resistor r=45.1352 //w=0.168 //l=0.173853 //layer=ply \
 //thickness=0.18 //x=11.45 //y=1.4 //x2=11.41 //y2=1.555
r286 (  100 121 ) resistor r=45.1352 //w=0.168 //l=0.173853 //layer=ply \
 //thickness=0.18 //x=11.45 //y=1.055 //x2=11.41 //y2=0.9
r287 (  100 101 ) resistor r=176.904 //w=0.094 //l=0.345 //layer=ply \
 //thickness=0.18 //x=11.45 //y=1.055 //x2=11.45 //y2=1.4
r288 (  97 103 ) resistor r=22.7971 //w=0.269 //l=0.106066 //layer=ply \
 //thickness=0.18 //x=11.42 //y=5.045 //x2=11.495 //y2=4.97
r289 (  97 120 ) resistor r=35.8364 //w=0.269 //l=0.270185 //layer=ply \
 //thickness=0.18 //x=11.42 //y=5.045 //x2=11.22 //y2=4.88
r290 (  95 116 ) resistor r=10.701 //w=0.21 //l=0.115 //layer=ply \
 //thickness=0.18 //x=11.075 //y=1.555 //x2=10.96 //y2=1.555
r291 (  94 122 ) resistor r=5.52526 //w=0.168 //l=0.115 //layer=ply \
 //thickness=0.18 //x=11.295 //y=1.555 //x2=11.41 //y2=1.555
r292 (  93 115 ) resistor r=5.52526 //w=0.168 //l=0.115 //layer=ply \
 //thickness=0.18 //x=11.075 //y=0.9 //x2=10.96 //y2=0.9
r293 (  92 121 ) resistor r=5.52526 //w=0.168 //l=0.115 //layer=ply \
 //thickness=0.18 //x=11.295 //y=0.9 //x2=11.41 //y2=0.9
r294 (  92 93 ) resistor r=112.809 //w=0.094 //l=0.22 //layer=ply \
 //thickness=0.18 //x=11.295 //y=0.9 //x2=11.075 //y2=0.9
r295 (  91 118 ) resistor r=58.7805 //w=0.246 //l=0.373497 //layer=ply \
 //thickness=0.18 //x=10.92 //y=2.095 //x2=11.22 //y2=2.26
r296 (  90 116 ) resistor r=39.5823 //w=0.21 //l=0.173853 //layer=ply \
 //thickness=0.18 //x=10.92 //y=1.71 //x2=10.96 //y2=1.555
r297 (  90 91 ) resistor r=197.415 //w=0.094 //l=0.385 //layer=ply \
 //thickness=0.18 //x=10.92 //y=1.71 //x2=10.92 //y2=2.095
r298 (  89 116 ) resistor r=39.5823 //w=0.21 //l=0.173853 //layer=ply \
 //thickness=0.18 //x=10.92 //y=1.4 //x2=10.96 //y2=1.555
r299 (  88 115 ) resistor r=45.1352 //w=0.168 //l=0.173853 //layer=ply \
 //thickness=0.18 //x=10.92 //y=1.055 //x2=10.96 //y2=0.9
r300 (  88 89 ) resistor r=176.904 //w=0.094 //l=0.345 //layer=ply \
 //thickness=0.18 //x=10.92 //y=1.055 //x2=10.92 //y2=1.4
r301 (  83 85 ) resistor r=26.9307 //w=0.15 //l=0.106066 //layer=ply \
 //thickness=0.18 //x=6.975 //y=4.97 //x2=7.05 //y2=5.045
r302 (  83 84 ) resistor r=148.702 //w=0.094 //l=0.29 //layer=ply \
 //thickness=0.18 //x=6.975 //y=4.97 //x2=6.685 //y2=4.97
r303 (  82 114 ) resistor r=45.1352 //w=0.168 //l=0.173853 //layer=ply \
 //thickness=0.18 //x=6.64 //y=1.4 //x2=6.6 //y2=1.555
r304 (  81 113 ) resistor r=45.1352 //w=0.168 //l=0.173853 //layer=ply \
 //thickness=0.18 //x=6.64 //y=1.055 //x2=6.6 //y2=0.9
r305 (  81 82 ) resistor r=176.904 //w=0.094 //l=0.345 //layer=ply \
 //thickness=0.18 //x=6.64 //y=1.055 //x2=6.64 //y2=1.4
r306 (  78 84 ) resistor r=22.7971 //w=0.269 //l=0.106066 //layer=ply \
 //thickness=0.18 //x=6.61 //y=5.045 //x2=6.685 //y2=4.97
r307 (  78 112 ) resistor r=35.8364 //w=0.269 //l=0.270185 //layer=ply \
 //thickness=0.18 //x=6.61 //y=5.045 //x2=6.41 //y2=4.88
r308 (  76 108 ) resistor r=10.701 //w=0.21 //l=0.115 //layer=ply \
 //thickness=0.18 //x=6.265 //y=1.555 //x2=6.15 //y2=1.555
r309 (  75 114 ) resistor r=5.52526 //w=0.168 //l=0.115 //layer=ply \
 //thickness=0.18 //x=6.485 //y=1.555 //x2=6.6 //y2=1.555
r310 (  74 107 ) resistor r=5.52526 //w=0.168 //l=0.115 //layer=ply \
 //thickness=0.18 //x=6.265 //y=0.9 //x2=6.15 //y2=0.9
r311 (  73 113 ) resistor r=5.52526 //w=0.168 //l=0.115 //layer=ply \
 //thickness=0.18 //x=6.485 //y=0.9 //x2=6.6 //y2=0.9
r312 (  73 74 ) resistor r=112.809 //w=0.094 //l=0.22 //layer=ply \
 //thickness=0.18 //x=6.485 //y=0.9 //x2=6.265 //y2=0.9
r313 (  72 110 ) resistor r=58.7805 //w=0.246 //l=0.373497 //layer=ply \
 //thickness=0.18 //x=6.11 //y=2.095 //x2=6.41 //y2=2.26
r314 (  71 108 ) resistor r=39.5823 //w=0.21 //l=0.173853 //layer=ply \
 //thickness=0.18 //x=6.11 //y=1.71 //x2=6.15 //y2=1.555
r315 (  71 72 ) resistor r=197.415 //w=0.094 //l=0.385 //layer=ply \
 //thickness=0.18 //x=6.11 //y=1.71 //x2=6.11 //y2=2.095
r316 (  70 108 ) resistor r=39.5823 //w=0.21 //l=0.173853 //layer=ply \
 //thickness=0.18 //x=6.11 //y=1.4 //x2=6.15 //y2=1.555
r317 (  69 107 ) resistor r=45.1352 //w=0.168 //l=0.173853 //layer=ply \
 //thickness=0.18 //x=6.11 //y=1.055 //x2=6.15 //y2=0.9
r318 (  69 70 ) resistor r=176.904 //w=0.094 //l=0.345 //layer=ply \
 //thickness=0.18 //x=6.11 //y=1.055 //x2=6.11 //y2=1.4
r319 (  68 104 ) resistor r=592.245 //w=0.094 //l=1.155 //layer=ply \
 //thickness=0.18 //x=11.86 //y=6.2 //x2=11.86 //y2=5.045
r320 (  67 97 ) resistor r=592.245 //w=0.094 //l=1.155 //layer=ply \
 //thickness=0.18 //x=11.42 //y=6.2 //x2=11.42 //y2=5.045
r321 (  66 85 ) resistor r=592.245 //w=0.094 //l=1.155 //layer=ply \
 //thickness=0.18 //x=7.05 //y=6.2 //x2=7.05 //y2=5.045
r322 (  65 78 ) resistor r=592.245 //w=0.094 //l=1.155 //layer=ply \
 //thickness=0.18 //x=6.61 //y=6.2 //x2=6.61 //y2=5.045
r323 (  64 94 ) resistor r=56.4043 //w=0.094 //l=0.11 //layer=ply \
 //thickness=0.18 //x=11.185 //y=1.555 //x2=11.295 //y2=1.555
r324 (  64 95 ) resistor r=56.4043 //w=0.094 //l=0.11 //layer=ply \
 //thickness=0.18 //x=11.185 //y=1.555 //x2=11.075 //y2=1.555
r325 (  63 75 ) resistor r=56.4043 //w=0.094 //l=0.11 //layer=ply \
 //thickness=0.18 //x=6.375 //y=1.555 //x2=6.485 //y2=1.555
r326 (  63 76 ) resistor r=56.4043 //w=0.094 //l=0.11 //layer=ply \
 //thickness=0.18 //x=6.375 //y=1.555 //x2=6.265 //y2=1.555
r327 (  59 120 ) resistor r=152 //w=0.17 //l=0.17 //layer=licon //count=1 \
 //x=11.22 //y=4.88 //x2=11.22 //y2=4.88
r328 (  57 59 ) resistor r=144.428 //w=0.187 //l=2.11 //layer=li \
 //thickness=0.1 //x=11.22 //y=2.77 //x2=11.22 //y2=4.88
r329 (  54 118 ) resistor r=152 //w=0.17 //l=0.17 //layer=licon //count=1 \
 //x=11.22 //y=2.26 //x2=11.22 //y2=2.26
r330 (  54 57 ) resistor r=34.9091 //w=0.187 //l=0.51 //layer=li \
 //thickness=0.1 //x=11.22 //y=2.26 //x2=11.22 //y2=2.77
r331 (  51 112 ) resistor r=152 //w=0.17 //l=0.17 //layer=licon //count=1 \
 //x=6.41 //y=4.88 //x2=6.41 //y2=4.88
r332 (  49 51 ) resistor r=144.428 //w=0.187 //l=2.11 //layer=li \
 //thickness=0.1 //x=6.41 //y=2.77 //x2=6.41 //y2=4.88
r333 (  46 110 ) resistor r=152 //w=0.17 //l=0.17 //layer=licon //count=1 \
 //x=6.41 //y=2.26 //x2=6.41 //y2=2.26
r334 (  46 49 ) resistor r=34.9091 //w=0.187 //l=0.51 //layer=li \
 //thickness=0.1 //x=6.41 //y=2.26 //x2=6.41 //y2=2.77
r335 (  42 44 ) resistor r=169.754 //w=0.187 //l=2.48 //layer=li \
 //thickness=0.1 //x=4.56 //y=5.25 //x2=4.56 //y2=2.77
r336 (  41 44 ) resistor r=57.4973 //w=0.187 //l=0.84 //layer=li \
 //thickness=0.1 //x=4.56 //y=1.93 //x2=4.56 //y2=2.77
r337 (  39 41 ) resistor r=7.15173 //w=0.17 //l=0.120208 //layer=li \
 //thickness=0.1 //x=4.475 //y=1.845 //x2=4.56 //y2=1.93
r338 (  39 40 ) resistor r=21.5615 //w=0.187 //l=0.315 //layer=li \
 //thickness=0.1 //x=4.475 //y=1.845 //x2=4.16 //y2=1.845
r339 (  35 40 ) resistor r=7.15173 //w=0.17 //l=0.120208 //layer=li \
 //thickness=0.1 //x=4.075 //y=1.76 //x2=4.16 //y2=1.845
r340 (  35 123 ) resistor r=39.016 //w=0.187 //l=0.57 //layer=li \
 //thickness=0.1 //x=4.075 //y=1.76 //x2=4.075 //y2=1.19
r341 (  34 62 ) resistor r=5.4201 //w=0.17 //l=0.085 //layer=li \
 //thickness=0.1 //x=3.865 //y=5.335 //x2=3.78 //y2=5.335
r342 (  33 42 ) resistor r=7.15173 //w=0.17 //l=0.120208 //layer=li \
 //thickness=0.1 //x=4.475 //y=5.335 //x2=4.56 //y2=5.25
r343 (  33 34 ) resistor r=41.754 //w=0.187 //l=0.61 //layer=li \
 //thickness=0.1 //x=4.475 //y=5.335 //x2=3.865 //y2=5.335
r344 (  27 62 ) resistor r=1.40859 //w=0.34 //l=0.085 //layer=li \
 //thickness=0.1 //x=3.78 //y=5.42 //x2=3.78 //y2=5.335
r345 (  27 127 ) resistor r=33.1979 //w=0.187 //l=0.485 //layer=li \
 //thickness=0.1 //x=3.78 //y=5.42 //x2=3.78 //y2=5.905
r346 (  26 61 ) resistor r=5.4201 //w=0.17 //l=0.085 //layer=li \
 //thickness=0.1 //x=2.985 //y=5.335 //x2=2.9 //y2=5.335
r347 (  25 62 ) resistor r=5.4201 //w=0.17 //l=0.085 //layer=li \
 //thickness=0.1 //x=3.695 //y=5.335 //x2=3.78 //y2=5.335
r348 (  25 26 ) resistor r=48.5989 //w=0.187 //l=0.71 //layer=li \
 //thickness=0.1 //x=3.695 //y=5.335 //x2=2.985 //y2=5.335
r349 (  19 61 ) resistor r=1.40859 //w=0.34 //l=0.085 //layer=li \
 //thickness=0.1 //x=2.9 //y=5.42 //x2=2.9 //y2=5.335
r350 (  19 126 ) resistor r=33.1979 //w=0.187 //l=0.485 //layer=li \
 //thickness=0.1 //x=2.9 //y=5.42 //x2=2.9 //y2=5.905
r351 (  17 61 ) resistor r=5.4201 //w=0.17 //l=0.085 //layer=li \
 //thickness=0.1 //x=2.815 //y=5.335 //x2=2.9 //y2=5.335
r352 (  17 18 ) resistor r=48.5989 //w=0.187 //l=0.71 //layer=li \
 //thickness=0.1 //x=2.815 //y=5.335 //x2=2.105 //y2=5.335
r353 (  11 18 ) resistor r=7.15173 //w=0.17 //l=0.120208 //layer=li \
 //thickness=0.1 //x=2.02 //y=5.42 //x2=2.105 //y2=5.335
r354 (  11 125 ) resistor r=33.1979 //w=0.187 //l=0.485 //layer=li \
 //thickness=0.1 //x=2.02 //y=5.42 //x2=2.02 //y2=5.905
r355 (  10 57 ) resistor r=9.3 //w=0.17 //l=0.17 //layer=mcon //count=1 \
 //x=11.22 //y=2.77 //x2=11.22 //y2=2.77
r356 (  8 49 ) resistor r=9.3 //w=0.17 //l=0.17 //layer=mcon //count=1 \
 //x=6.41 //y=2.77 //x2=6.41 //y2=2.77
r357 (  6 44 ) resistor r=9.3 //w=0.17 //l=0.17 //layer=mcon //count=1 \
 //x=4.56 //y=2.77 //x2=4.56 //y2=2.77
r358 (  4 8 ) resistor r=0.0880901 //w=0.191 //l=0.115 //layer=m1 \
 //thickness=0.36 //x=6.525 //y=2.77 //x2=6.41 //y2=2.77
r359 (  3 10 ) resistor r=0.0717383 //w=0.224 //l=0.115 //layer=m1 \
 //thickness=0.36 //x=11.105 //y=2.77 //x2=11.22 //y2=2.77
r360 (  3 4 ) resistor r=4.37023 //w=0.131 //l=4.58 //layer=m1 \
 //thickness=0.36 //x=11.105 //y=2.77 //x2=6.525 //y2=2.77
r361 (  2 6 ) resistor r=0.0717383 //w=0.224 //l=0.115 //layer=m1 \
 //thickness=0.36 //x=4.675 //y=2.77 //x2=4.56 //y2=2.77
r362 (  1 8 ) resistor r=0.0880901 //w=0.191 //l=0.115 //layer=m1 \
 //thickness=0.36 //x=6.295 //y=2.77 //x2=6.41 //y2=2.77
r363 (  1 2 ) resistor r=1.5458 //w=0.131 //l=1.62 //layer=m1 //thickness=0.36 \
 //x=6.295 //y=2.77 //x2=4.675 //y2=2.77
ends PM_TMRDFFSNRNQNX1\%noxref_3

subckt PM_TMRDFFSNRNQNX1\%noxref_4 ( 1 2 13 14 21 29 35 36 40 42 49 50 51 52 \
 53 54 55 56 57 58 60 66 67 68 69 81 83 84 85 )
c165 ( 85 0 ) capacitor c=0.023087f //x=13.255 //y=5.2
c166 ( 84 0 ) capacitor c=0.023519f //x=12.375 //y=5.2
c167 ( 83 0 ) capacitor c=0.0224735f //x=11.495 //y=5.2
c168 ( 81 0 ) capacitor c=0.00853354f //x=13.505 //y=1.095
c169 ( 69 0 ) capacitor c=0.0557698f //x=16.305 //y=4.97
c170 ( 68 0 ) capacitor c=0.0293157f //x=16.595 //y=4.97
c171 ( 67 0 ) capacitor c=0.0347816f //x=16.26 //y=1.4
c172 ( 66 0 ) capacitor c=0.0187487f //x=16.26 //y=1.055
c173 ( 60 0 ) capacitor c=0.0137055f //x=16.105 //y=1.555
c174 ( 58 0 ) capacitor c=0.0149861f //x=16.105 //y=0.9
c175 ( 57 0 ) capacitor c=0.096037f //x=15.73 //y=2.095
c176 ( 56 0 ) capacitor c=0.0228993f //x=15.73 //y=1.71
c177 ( 55 0 ) capacitor c=0.0234352f //x=15.73 //y=1.4
c178 ( 54 0 ) capacitor c=0.0198724f //x=15.73 //y=1.055
c179 ( 53 0 ) capacitor c=0.110114f //x=16.67 //y=6.2
c180 ( 52 0 ) capacitor c=0.158956f //x=16.23 //y=6.2
c181 ( 50 0 ) capacitor c=0.00106608f //x=13.4 //y=5.335
c182 ( 49 0 ) capacitor c=0.00207319f //x=12.52 //y=5.335
c183 ( 42 0 ) capacitor c=0.0939064f //x=16.03 //y=2.26
c184 ( 40 0 ) capacitor c=0.10406f //x=14.18 //y=2.77
c185 ( 36 0 ) capacitor c=0.00398962f //x=13.78 //y=1.845
c186 ( 35 0 ) capacitor c=0.0137288f //x=14.095 //y=1.845
c187 ( 29 0 ) capacitor c=0.0283082f //x=14.095 //y=5.335
c188 ( 21 0 ) capacitor c=0.0176454f //x=13.315 //y=5.335
c189 ( 14 0 ) capacitor c=0.00332903f //x=11.725 //y=5.335
c190 ( 13 0 ) capacitor c=0.0148427f //x=12.435 //y=5.335
c191 ( 2 0 ) capacitor c=0.00808366f //x=14.295 //y=2.77
c192 ( 1 0 ) capacitor c=0.0352679f //x=15.915 //y=2.77
r193 (  68 70 ) resistor r=26.9307 //w=0.15 //l=0.106066 //layer=ply \
 //thickness=0.18 //x=16.595 //y=4.97 //x2=16.67 //y2=5.045
r194 (  68 69 ) resistor r=148.702 //w=0.094 //l=0.29 //layer=ply \
 //thickness=0.18 //x=16.595 //y=4.97 //x2=16.305 //y2=4.97
r195 (  67 80 ) resistor r=45.1352 //w=0.168 //l=0.173853 //layer=ply \
 //thickness=0.18 //x=16.26 //y=1.4 //x2=16.22 //y2=1.555
r196 (  66 79 ) resistor r=45.1352 //w=0.168 //l=0.173853 //layer=ply \
 //thickness=0.18 //x=16.26 //y=1.055 //x2=16.22 //y2=0.9
r197 (  66 67 ) resistor r=176.904 //w=0.094 //l=0.345 //layer=ply \
 //thickness=0.18 //x=16.26 //y=1.055 //x2=16.26 //y2=1.4
r198 (  63 69 ) resistor r=22.7971 //w=0.269 //l=0.106066 //layer=ply \
 //thickness=0.18 //x=16.23 //y=5.045 //x2=16.305 //y2=4.97
r199 (  63 78 ) resistor r=35.8364 //w=0.269 //l=0.270185 //layer=ply \
 //thickness=0.18 //x=16.23 //y=5.045 //x2=16.03 //y2=4.88
r200 (  61 74 ) resistor r=10.701 //w=0.21 //l=0.115 //layer=ply \
 //thickness=0.18 //x=15.885 //y=1.555 //x2=15.77 //y2=1.555
r201 (  60 80 ) resistor r=5.52526 //w=0.168 //l=0.115 //layer=ply \
 //thickness=0.18 //x=16.105 //y=1.555 //x2=16.22 //y2=1.555
r202 (  59 73 ) resistor r=5.52526 //w=0.168 //l=0.115 //layer=ply \
 //thickness=0.18 //x=15.885 //y=0.9 //x2=15.77 //y2=0.9
r203 (  58 79 ) resistor r=5.52526 //w=0.168 //l=0.115 //layer=ply \
 //thickness=0.18 //x=16.105 //y=0.9 //x2=16.22 //y2=0.9
r204 (  58 59 ) resistor r=112.809 //w=0.094 //l=0.22 //layer=ply \
 //thickness=0.18 //x=16.105 //y=0.9 //x2=15.885 //y2=0.9
r205 (  57 76 ) resistor r=58.7805 //w=0.246 //l=0.373497 //layer=ply \
 //thickness=0.18 //x=15.73 //y=2.095 //x2=16.03 //y2=2.26
r206 (  56 74 ) resistor r=39.5823 //w=0.21 //l=0.173853 //layer=ply \
 //thickness=0.18 //x=15.73 //y=1.71 //x2=15.77 //y2=1.555
r207 (  56 57 ) resistor r=197.415 //w=0.094 //l=0.385 //layer=ply \
 //thickness=0.18 //x=15.73 //y=1.71 //x2=15.73 //y2=2.095
r208 (  55 74 ) resistor r=39.5823 //w=0.21 //l=0.173853 //layer=ply \
 //thickness=0.18 //x=15.73 //y=1.4 //x2=15.77 //y2=1.555
r209 (  54 73 ) resistor r=45.1352 //w=0.168 //l=0.173853 //layer=ply \
 //thickness=0.18 //x=15.73 //y=1.055 //x2=15.77 //y2=0.9
r210 (  54 55 ) resistor r=176.904 //w=0.094 //l=0.345 //layer=ply \
 //thickness=0.18 //x=15.73 //y=1.055 //x2=15.73 //y2=1.4
r211 (  53 70 ) resistor r=592.245 //w=0.094 //l=1.155 //layer=ply \
 //thickness=0.18 //x=16.67 //y=6.2 //x2=16.67 //y2=5.045
r212 (  52 63 ) resistor r=592.245 //w=0.094 //l=1.155 //layer=ply \
 //thickness=0.18 //x=16.23 //y=6.2 //x2=16.23 //y2=5.045
r213 (  51 60 ) resistor r=56.4043 //w=0.094 //l=0.11 //layer=ply \
 //thickness=0.18 //x=15.995 //y=1.555 //x2=16.105 //y2=1.555
r214 (  51 61 ) resistor r=56.4043 //w=0.094 //l=0.11 //layer=ply \
 //thickness=0.18 //x=15.995 //y=1.555 //x2=15.885 //y2=1.555
r215 (  47 78 ) resistor r=152 //w=0.17 //l=0.17 //layer=licon //count=1 \
 //x=16.03 //y=4.88 //x2=16.03 //y2=4.88
r216 (  45 47 ) resistor r=144.428 //w=0.187 //l=2.11 //layer=li \
 //thickness=0.1 //x=16.03 //y=2.77 //x2=16.03 //y2=4.88
r217 (  42 76 ) resistor r=152 //w=0.17 //l=0.17 //layer=licon //count=1 \
 //x=16.03 //y=2.26 //x2=16.03 //y2=2.26
r218 (  42 45 ) resistor r=34.9091 //w=0.187 //l=0.51 //layer=li \
 //thickness=0.1 //x=16.03 //y=2.26 //x2=16.03 //y2=2.77
r219 (  38 40 ) resistor r=169.754 //w=0.187 //l=2.48 //layer=li \
 //thickness=0.1 //x=14.18 //y=5.25 //x2=14.18 //y2=2.77
r220 (  37 40 ) resistor r=57.4973 //w=0.187 //l=0.84 //layer=li \
 //thickness=0.1 //x=14.18 //y=1.93 //x2=14.18 //y2=2.77
r221 (  35 37 ) resistor r=7.15173 //w=0.17 //l=0.120208 //layer=li \
 //thickness=0.1 //x=14.095 //y=1.845 //x2=14.18 //y2=1.93
r222 (  35 36 ) resistor r=21.5615 //w=0.187 //l=0.315 //layer=li \
 //thickness=0.1 //x=14.095 //y=1.845 //x2=13.78 //y2=1.845
r223 (  31 36 ) resistor r=7.15173 //w=0.17 //l=0.120208 //layer=li \
 //thickness=0.1 //x=13.695 //y=1.76 //x2=13.78 //y2=1.845
r224 (  31 81 ) resistor r=39.016 //w=0.187 //l=0.57 //layer=li \
 //thickness=0.1 //x=13.695 //y=1.76 //x2=13.695 //y2=1.19
r225 (  30 50 ) resistor r=5.4201 //w=0.17 //l=0.085 //layer=li \
 //thickness=0.1 //x=13.485 //y=5.335 //x2=13.4 //y2=5.335
r226 (  29 38 ) resistor r=7.15173 //w=0.17 //l=0.120208 //layer=li \
 //thickness=0.1 //x=14.095 //y=5.335 //x2=14.18 //y2=5.25
r227 (  29 30 ) resistor r=41.754 //w=0.187 //l=0.61 //layer=li \
 //thickness=0.1 //x=14.095 //y=5.335 //x2=13.485 //y2=5.335
r228 (  23 50 ) resistor r=1.40859 //w=0.34 //l=0.085 //layer=li \
 //thickness=0.1 //x=13.4 //y=5.42 //x2=13.4 //y2=5.335
r229 (  23 85 ) resistor r=33.1979 //w=0.187 //l=0.485 //layer=li \
 //thickness=0.1 //x=13.4 //y=5.42 //x2=13.4 //y2=5.905
r230 (  22 49 ) resistor r=5.4201 //w=0.17 //l=0.085 //layer=li \
 //thickness=0.1 //x=12.605 //y=5.335 //x2=12.52 //y2=5.335
r231 (  21 50 ) resistor r=5.4201 //w=0.17 //l=0.085 //layer=li \
 //thickness=0.1 //x=13.315 //y=5.335 //x2=13.4 //y2=5.335
r232 (  21 22 ) resistor r=48.5989 //w=0.187 //l=0.71 //layer=li \
 //thickness=0.1 //x=13.315 //y=5.335 //x2=12.605 //y2=5.335
r233 (  15 49 ) resistor r=1.40859 //w=0.34 //l=0.085 //layer=li \
 //thickness=0.1 //x=12.52 //y=5.42 //x2=12.52 //y2=5.335
r234 (  15 84 ) resistor r=33.1979 //w=0.187 //l=0.485 //layer=li \
 //thickness=0.1 //x=12.52 //y=5.42 //x2=12.52 //y2=5.905
r235 (  13 49 ) resistor r=5.4201 //w=0.17 //l=0.085 //layer=li \
 //thickness=0.1 //x=12.435 //y=5.335 //x2=12.52 //y2=5.335
r236 (  13 14 ) resistor r=48.5989 //w=0.187 //l=0.71 //layer=li \
 //thickness=0.1 //x=12.435 //y=5.335 //x2=11.725 //y2=5.335
r237 (  7 14 ) resistor r=7.15173 //w=0.17 //l=0.120208 //layer=li \
 //thickness=0.1 //x=11.64 //y=5.42 //x2=11.725 //y2=5.335
r238 (  7 83 ) resistor r=33.1979 //w=0.187 //l=0.485 //layer=li \
 //thickness=0.1 //x=11.64 //y=5.42 //x2=11.64 //y2=5.905
r239 (  6 45 ) resistor r=9.3 //w=0.17 //l=0.17 //layer=mcon //count=1 \
 //x=16.03 //y=2.77 //x2=16.03 //y2=2.77
r240 (  4 40 ) resistor r=9.3 //w=0.17 //l=0.17 //layer=mcon //count=1 \
 //x=14.18 //y=2.77 //x2=14.18 //y2=2.77
r241 (  2 4 ) resistor r=0.0717383 //w=0.224 //l=0.115 //layer=m1 \
 //thickness=0.36 //x=14.295 //y=2.77 //x2=14.18 //y2=2.77
r242 (  1 6 ) resistor r=0.0717383 //w=0.224 //l=0.115 //layer=m1 \
 //thickness=0.36 //x=15.915 //y=2.77 //x2=16.03 //y2=2.77
r243 (  1 2 ) resistor r=1.5458 //w=0.131 //l=1.62 //layer=m1 //thickness=0.36 \
 //x=15.915 //y=2.77 //x2=14.295 //y2=2.77
ends PM_TMRDFFSNRNQNX1\%noxref_4

subckt PM_TMRDFFSNRNQNX1\%noxref_5 ( 1 2 3 4 12 25 26 33 41 47 48 52 54 61 62 \
 63 64 65 66 67 68 72 73 74 79 81 84 85 86 87 88 89 90 92 98 99 100 101 106 \
 107 112 123 125 126 127 )
c267 ( 127 0 ) capacitor c=0.023087f //x=8.445 //y=5.2
c268 ( 126 0 ) capacitor c=0.023519f //x=7.565 //y=5.2
c269 ( 125 0 ) capacitor c=0.0224735f //x=6.685 //y=5.2
c270 ( 123 0 ) capacitor c=0.00853354f //x=8.695 //y=1.095
c271 ( 112 0 ) capacitor c=0.059212f //x=3.82 //y=4.88
c272 ( 107 0 ) capacitor c=0.0273931f //x=3.82 //y=2.095
c273 ( 106 0 ) capacitor c=0.045877f //x=3.82 //y=2.26
c274 ( 101 0 ) capacitor c=0.0556143f //x=21.115 //y=4.97
c275 ( 100 0 ) capacitor c=0.0293157f //x=21.405 //y=4.97
c276 ( 99 0 ) capacitor c=0.0347816f //x=21.07 //y=1.4
c277 ( 98 0 ) capacitor c=0.0187487f //x=21.07 //y=1.055
c278 ( 92 0 ) capacitor c=0.0137055f //x=20.915 //y=1.555
c279 ( 90 0 ) capacitor c=0.0149861f //x=20.915 //y=0.9
c280 ( 89 0 ) capacitor c=0.096037f //x=20.54 //y=2.095
c281 ( 88 0 ) capacitor c=0.0228993f //x=20.54 //y=1.71
c282 ( 87 0 ) capacitor c=0.0234352f //x=20.54 //y=1.4
c283 ( 86 0 ) capacitor c=0.0198724f //x=20.54 //y=1.055
c284 ( 85 0 ) capacitor c=0.0432517f //x=4.34 //y=1.44
c285 ( 84 0 ) capacitor c=0.0200379f //x=4.34 //y=1.095
c286 ( 81 0 ) capacitor c=0.0148873f //x=4.185 //y=1.595
c287 ( 79 0 ) capacitor c=0.0157803f //x=4.185 //y=0.94
c288 ( 74 0 ) capacitor c=0.0218028f //x=3.81 //y=1.75
c289 ( 73 0 ) capacitor c=0.0207459f //x=3.81 //y=1.44
c290 ( 72 0 ) capacitor c=0.0194308f //x=3.81 //y=1.095
c291 ( 68 0 ) capacitor c=0.110114f //x=21.48 //y=6.2
c292 ( 67 0 ) capacitor c=0.158956f //x=21.04 //y=6.2
c293 ( 66 0 ) capacitor c=0.158794f //x=4 //y=6.2
c294 ( 65 0 ) capacitor c=0.110114f //x=3.56 //y=6.2
c295 ( 62 0 ) capacitor c=0.00106608f //x=8.59 //y=5.335
c296 ( 61 0 ) capacitor c=0.00207162f //x=7.71 //y=5.335
c297 ( 54 0 ) capacitor c=0.0965808f //x=20.84 //y=2.26
c298 ( 52 0 ) capacitor c=0.10653f //x=9.37 //y=3.51
c299 ( 48 0 ) capacitor c=0.00398962f //x=8.97 //y=1.845
c300 ( 47 0 ) capacitor c=0.0137288f //x=9.285 //y=1.845
c301 ( 41 0 ) capacitor c=0.0283082f //x=9.285 //y=5.335
c302 ( 33 0 ) capacitor c=0.0176454f //x=8.505 //y=5.335
c303 ( 26 0 ) capacitor c=0.00351598f //x=6.915 //y=5.335
c304 ( 25 0 ) capacitor c=0.0154196f //x=7.625 //y=5.335
c305 ( 12 0 ) capacitor c=0.0883624f //x=3.82 //y=2.26
c306 ( 4 0 ) capacitor c=0.00578611f //x=9.485 //y=3.51
c307 ( 3 0 ) capacitor c=0.184375f //x=20.725 //y=3.51
c308 ( 2 0 ) capacitor c=0.0148738f //x=3.935 //y=3.51
c309 ( 1 0 ) capacitor c=0.107193f //x=9.255 //y=3.51
r310 (  106 107 ) resistor r=52.7279 //w=0.214 //l=0.165 //layer=ply \
 //thickness=0.18 //x=3.82 //y=2.26 //x2=3.82 //y2=2.095
r311 (  100 102 ) resistor r=26.9307 //w=0.15 //l=0.106066 //layer=ply \
 //thickness=0.18 //x=21.405 //y=4.97 //x2=21.48 //y2=5.045
r312 (  100 101 ) resistor r=148.702 //w=0.094 //l=0.29 //layer=ply \
 //thickness=0.18 //x=21.405 //y=4.97 //x2=21.115 //y2=4.97
r313 (  99 122 ) resistor r=45.1352 //w=0.168 //l=0.173853 //layer=ply \
 //thickness=0.18 //x=21.07 //y=1.4 //x2=21.03 //y2=1.555
r314 (  98 121 ) resistor r=45.1352 //w=0.168 //l=0.173853 //layer=ply \
 //thickness=0.18 //x=21.07 //y=1.055 //x2=21.03 //y2=0.9
r315 (  98 99 ) resistor r=176.904 //w=0.094 //l=0.345 //layer=ply \
 //thickness=0.18 //x=21.07 //y=1.055 //x2=21.07 //y2=1.4
r316 (  95 101 ) resistor r=22.7971 //w=0.269 //l=0.106066 //layer=ply \
 //thickness=0.18 //x=21.04 //y=5.045 //x2=21.115 //y2=4.97
r317 (  95 120 ) resistor r=35.8364 //w=0.269 //l=0.270185 //layer=ply \
 //thickness=0.18 //x=21.04 //y=5.045 //x2=20.84 //y2=4.88
r318 (  93 116 ) resistor r=10.701 //w=0.21 //l=0.115 //layer=ply \
 //thickness=0.18 //x=20.695 //y=1.555 //x2=20.58 //y2=1.555
r319 (  92 122 ) resistor r=5.52526 //w=0.168 //l=0.115 //layer=ply \
 //thickness=0.18 //x=20.915 //y=1.555 //x2=21.03 //y2=1.555
r320 (  91 115 ) resistor r=5.52526 //w=0.168 //l=0.115 //layer=ply \
 //thickness=0.18 //x=20.695 //y=0.9 //x2=20.58 //y2=0.9
r321 (  90 121 ) resistor r=5.52526 //w=0.168 //l=0.115 //layer=ply \
 //thickness=0.18 //x=20.915 //y=0.9 //x2=21.03 //y2=0.9
r322 (  90 91 ) resistor r=112.809 //w=0.094 //l=0.22 //layer=ply \
 //thickness=0.18 //x=20.915 //y=0.9 //x2=20.695 //y2=0.9
r323 (  89 118 ) resistor r=58.7805 //w=0.246 //l=0.373497 //layer=ply \
 //thickness=0.18 //x=20.54 //y=2.095 //x2=20.84 //y2=2.26
r324 (  88 116 ) resistor r=39.5823 //w=0.21 //l=0.173853 //layer=ply \
 //thickness=0.18 //x=20.54 //y=1.71 //x2=20.58 //y2=1.555
r325 (  88 89 ) resistor r=197.415 //w=0.094 //l=0.385 //layer=ply \
 //thickness=0.18 //x=20.54 //y=1.71 //x2=20.54 //y2=2.095
r326 (  87 116 ) resistor r=39.5823 //w=0.21 //l=0.173853 //layer=ply \
 //thickness=0.18 //x=20.54 //y=1.4 //x2=20.58 //y2=1.555
r327 (  86 115 ) resistor r=45.1352 //w=0.168 //l=0.173853 //layer=ply \
 //thickness=0.18 //x=20.54 //y=1.055 //x2=20.58 //y2=0.9
r328 (  86 87 ) resistor r=176.904 //w=0.094 //l=0.345 //layer=ply \
 //thickness=0.18 //x=20.54 //y=1.055 //x2=20.54 //y2=1.4
r329 (  85 114 ) resistor r=45.1352 //w=0.168 //l=0.173853 //layer=ply \
 //thickness=0.18 //x=4.34 //y=1.44 //x2=4.3 //y2=1.595
r330 (  84 113 ) resistor r=45.1352 //w=0.168 //l=0.173853 //layer=ply \
 //thickness=0.18 //x=4.34 //y=1.095 //x2=4.3 //y2=0.94
r331 (  84 85 ) resistor r=176.904 //w=0.094 //l=0.345 //layer=ply \
 //thickness=0.18 //x=4.34 //y=1.095 //x2=4.34 //y2=1.44
r332 (  82 110 ) resistor r=10.701 //w=0.21 //l=0.115 //layer=ply \
 //thickness=0.18 //x=3.965 //y=1.595 //x2=3.85 //y2=1.595
r333 (  81 114 ) resistor r=5.52526 //w=0.168 //l=0.115 //layer=ply \
 //thickness=0.18 //x=4.185 //y=1.595 //x2=4.3 //y2=1.595
r334 (  80 109 ) resistor r=5.52526 //w=0.168 //l=0.115 //layer=ply \
 //thickness=0.18 //x=3.965 //y=0.94 //x2=3.85 //y2=0.94
r335 (  79 113 ) resistor r=5.52526 //w=0.168 //l=0.115 //layer=ply \
 //thickness=0.18 //x=4.185 //y=0.94 //x2=4.3 //y2=0.94
r336 (  79 80 ) resistor r=112.809 //w=0.094 //l=0.22 //layer=ply \
 //thickness=0.18 //x=4.185 //y=0.94 //x2=3.965 //y2=0.94
r337 (  76 112 ) resistor r=37.236 //w=0.233 //l=0.249199 //layer=ply \
 //thickness=0.18 //x=4 //y=5.045 //x2=3.82 //y2=4.88
r338 (  74 110 ) resistor r=39.5823 //w=0.21 //l=0.173853 //layer=ply \
 //thickness=0.18 //x=3.81 //y=1.75 //x2=3.85 //y2=1.595
r339 (  74 107 ) resistor r=176.904 //w=0.094 //l=0.345 //layer=ply \
 //thickness=0.18 //x=3.81 //y=1.75 //x2=3.81 //y2=2.095
r340 (  73 110 ) resistor r=39.5823 //w=0.21 //l=0.173853 //layer=ply \
 //thickness=0.18 //x=3.81 //y=1.44 //x2=3.85 //y2=1.595
r341 (  72 109 ) resistor r=45.1352 //w=0.168 //l=0.173853 //layer=ply \
 //thickness=0.18 //x=3.81 //y=1.095 //x2=3.85 //y2=0.94
r342 (  72 73 ) resistor r=176.904 //w=0.094 //l=0.345 //layer=ply \
 //thickness=0.18 //x=3.81 //y=1.095 //x2=3.81 //y2=1.44
r343 (  69 112 ) resistor r=53.7854 //w=0.233 //l=0.332415 //layer=ply \
 //thickness=0.18 //x=3.56 //y=5.045 //x2=3.82 //y2=4.88
r344 (  68 102 ) resistor r=592.245 //w=0.094 //l=1.155 //layer=ply \
 //thickness=0.18 //x=21.48 //y=6.2 //x2=21.48 //y2=5.045
r345 (  67 95 ) resistor r=592.245 //w=0.094 //l=1.155 //layer=ply \
 //thickness=0.18 //x=21.04 //y=6.2 //x2=21.04 //y2=5.045
r346 (  66 76 ) resistor r=592.245 //w=0.094 //l=1.155 //layer=ply \
 //thickness=0.18 //x=4 //y=6.2 //x2=4 //y2=5.045
r347 (  65 69 ) resistor r=592.245 //w=0.094 //l=1.155 //layer=ply \
 //thickness=0.18 //x=3.56 //y=6.2 //x2=3.56 //y2=5.045
r348 (  64 92 ) resistor r=56.4043 //w=0.094 //l=0.11 //layer=ply \
 //thickness=0.18 //x=20.805 //y=1.555 //x2=20.915 //y2=1.555
r349 (  64 93 ) resistor r=56.4043 //w=0.094 //l=0.11 //layer=ply \
 //thickness=0.18 //x=20.805 //y=1.555 //x2=20.695 //y2=1.555
r350 (  63 81 ) resistor r=56.4043 //w=0.094 //l=0.11 //layer=ply \
 //thickness=0.18 //x=4.075 //y=1.595 //x2=4.185 //y2=1.595
r351 (  63 82 ) resistor r=56.4043 //w=0.094 //l=0.11 //layer=ply \
 //thickness=0.18 //x=4.075 //y=1.595 //x2=3.965 //y2=1.595
r352 (  59 120 ) resistor r=152 //w=0.17 //l=0.17 //layer=licon //count=1 \
 //x=20.84 //y=4.88 //x2=20.84 //y2=4.88
r353 (  57 59 ) resistor r=93.7754 //w=0.187 //l=1.37 //layer=li \
 //thickness=0.1 //x=20.84 //y=3.51 //x2=20.84 //y2=4.88
r354 (  54 118 ) resistor r=152 //w=0.17 //l=0.17 //layer=licon //count=1 \
 //x=20.84 //y=2.26 //x2=20.84 //y2=2.26
r355 (  54 57 ) resistor r=85.5615 //w=0.187 //l=1.25 //layer=li \
 //thickness=0.1 //x=20.84 //y=2.26 //x2=20.84 //y2=3.51
r356 (  50 52 ) resistor r=119.102 //w=0.187 //l=1.74 //layer=li \
 //thickness=0.1 //x=9.37 //y=5.25 //x2=9.37 //y2=3.51
r357 (  49 52 ) resistor r=108.15 //w=0.187 //l=1.58 //layer=li \
 //thickness=0.1 //x=9.37 //y=1.93 //x2=9.37 //y2=3.51
r358 (  47 49 ) resistor r=7.15173 //w=0.17 //l=0.120208 //layer=li \
 //thickness=0.1 //x=9.285 //y=1.845 //x2=9.37 //y2=1.93
r359 (  47 48 ) resistor r=21.5615 //w=0.187 //l=0.315 //layer=li \
 //thickness=0.1 //x=9.285 //y=1.845 //x2=8.97 //y2=1.845
r360 (  43 48 ) resistor r=7.15173 //w=0.17 //l=0.120208 //layer=li \
 //thickness=0.1 //x=8.885 //y=1.76 //x2=8.97 //y2=1.845
r361 (  43 123 ) resistor r=39.016 //w=0.187 //l=0.57 //layer=li \
 //thickness=0.1 //x=8.885 //y=1.76 //x2=8.885 //y2=1.19
r362 (  42 62 ) resistor r=5.4201 //w=0.17 //l=0.085 //layer=li \
 //thickness=0.1 //x=8.675 //y=5.335 //x2=8.59 //y2=5.335
r363 (  41 50 ) resistor r=7.15173 //w=0.17 //l=0.120208 //layer=li \
 //thickness=0.1 //x=9.285 //y=5.335 //x2=9.37 //y2=5.25
r364 (  41 42 ) resistor r=41.754 //w=0.187 //l=0.61 //layer=li \
 //thickness=0.1 //x=9.285 //y=5.335 //x2=8.675 //y2=5.335
r365 (  35 62 ) resistor r=1.40859 //w=0.34 //l=0.085 //layer=li \
 //thickness=0.1 //x=8.59 //y=5.42 //x2=8.59 //y2=5.335
r366 (  35 127 ) resistor r=33.1979 //w=0.187 //l=0.485 //layer=li \
 //thickness=0.1 //x=8.59 //y=5.42 //x2=8.59 //y2=5.905
r367 (  34 61 ) resistor r=5.4201 //w=0.17 //l=0.085 //layer=li \
 //thickness=0.1 //x=7.795 //y=5.335 //x2=7.71 //y2=5.335
r368 (  33 62 ) resistor r=5.4201 //w=0.17 //l=0.085 //layer=li \
 //thickness=0.1 //x=8.505 //y=5.335 //x2=8.59 //y2=5.335
r369 (  33 34 ) resistor r=48.5989 //w=0.187 //l=0.71 //layer=li \
 //thickness=0.1 //x=8.505 //y=5.335 //x2=7.795 //y2=5.335
r370 (  27 61 ) resistor r=1.40859 //w=0.34 //l=0.085 //layer=li \
 //thickness=0.1 //x=7.71 //y=5.42 //x2=7.71 //y2=5.335
r371 (  27 126 ) resistor r=33.1979 //w=0.187 //l=0.485 //layer=li \
 //thickness=0.1 //x=7.71 //y=5.42 //x2=7.71 //y2=5.905
r372 (  25 61 ) resistor r=5.4201 //w=0.17 //l=0.085 //layer=li \
 //thickness=0.1 //x=7.625 //y=5.335 //x2=7.71 //y2=5.335
r373 (  25 26 ) resistor r=48.5989 //w=0.187 //l=0.71 //layer=li \
 //thickness=0.1 //x=7.625 //y=5.335 //x2=6.915 //y2=5.335
r374 (  19 26 ) resistor r=7.15173 //w=0.17 //l=0.120208 //layer=li \
 //thickness=0.1 //x=6.83 //y=5.42 //x2=6.915 //y2=5.335
r375 (  19 125 ) resistor r=33.1979 //w=0.187 //l=0.485 //layer=li \
 //thickness=0.1 //x=6.83 //y=5.42 //x2=6.83 //y2=5.905
r376 (  17 112 ) resistor r=152 //w=0.17 //l=0.17 //layer=licon //count=1 \
 //x=3.82 //y=4.88 //x2=3.82 //y2=4.88
r377 (  15 17 ) resistor r=93.7754 //w=0.187 //l=1.37 //layer=li \
 //thickness=0.1 //x=3.82 //y=3.51 //x2=3.82 //y2=4.88
r378 (  12 106 ) resistor r=152 //w=0.17 //l=0.17 //layer=licon //count=1 \
 //x=3.82 //y=2.26 //x2=3.82 //y2=2.26
r379 (  12 15 ) resistor r=85.5615 //w=0.187 //l=1.25 //layer=li \
 //thickness=0.1 //x=3.82 //y=2.26 //x2=3.82 //y2=3.51
r380 (  10 57 ) resistor r=9.3 //w=0.17 //l=0.17 //layer=mcon //count=1 \
 //x=20.84 //y=3.51 //x2=20.84 //y2=3.51
r381 (  8 52 ) resistor r=9.3 //w=0.17 //l=0.17 //layer=mcon //count=1 \
 //x=9.37 //y=3.51 //x2=9.37 //y2=3.51
r382 (  6 15 ) resistor r=9.3 //w=0.17 //l=0.17 //layer=mcon //count=1 \
 //x=3.82 //y=3.51 //x2=3.82 //y2=3.51
r383 (  4 8 ) resistor r=0.0880901 //w=0.191 //l=0.115 //layer=m1 \
 //thickness=0.36 //x=9.485 //y=3.51 //x2=9.37 //y2=3.51
r384 (  3 10 ) resistor r=0.0717383 //w=0.224 //l=0.115 //layer=m1 \
 //thickness=0.36 //x=20.725 //y=3.51 //x2=20.84 //y2=3.51
r385 (  3 4 ) resistor r=10.7252 //w=0.131 //l=11.24 //layer=m1 \
 //thickness=0.36 //x=20.725 //y=3.51 //x2=9.485 //y2=3.51
r386 (  2 6 ) resistor r=0.0717383 //w=0.224 //l=0.115 //layer=m1 \
 //thickness=0.36 //x=3.935 //y=3.51 //x2=3.82 //y2=3.51
r387 (  1 8 ) resistor r=0.0880901 //w=0.191 //l=0.115 //layer=m1 \
 //thickness=0.36 //x=9.255 //y=3.51 //x2=9.37 //y2=3.51
r388 (  1 2 ) resistor r=5.07634 //w=0.131 //l=5.32 //layer=m1 \
 //thickness=0.36 //x=9.255 //y=3.51 //x2=3.935 //y2=3.51
ends PM_TMRDFFSNRNQNX1\%noxref_5

subckt PM_TMRDFFSNRNQNX1\%noxref_6 ( 1 2 3 4 6 7 8 9 10 27 28 35 43 49 50 54 \
 58 66 74 81 82 83 84 85 86 87 88 89 90 91 92 93 94 95 96 98 104 105 106 107 \
 111 112 113 114 118 120 123 124 125 126 130 131 132 133 137 139 145 146 156 \
 169 172 174 175 176 )
c634 ( 176 0 ) capacitor c=0.023087f //x=22.875 //y=5.2
c635 ( 175 0 ) capacitor c=0.023519f //x=21.995 //y=5.2
c636 ( 174 0 ) capacitor c=0.0224735f //x=21.115 //y=5.2
c637 ( 172 0 ) capacitor c=0.00853354f //x=23.125 //y=1.095
c638 ( 169 0 ) capacitor c=0.0655948f //x=91.51 //y=4.885
c639 ( 156 0 ) capacitor c=0.054113f //x=87.81 //y=2.26
c640 ( 146 0 ) capacitor c=0.0342409f //x=91.845 //y=1.39
c641 ( 145 0 ) capacitor c=0.0187384f //x=91.845 //y=1.045
c642 ( 139 0 ) capacitor c=0.0141797f //x=91.69 //y=1.545
c643 ( 137 0 ) capacitor c=0.0149844f //x=91.69 //y=0.89
c644 ( 133 0 ) capacitor c=0.0954119f //x=91.315 //y=2.095
c645 ( 132 0 ) capacitor c=0.022465f //x=91.315 //y=1.7
c646 ( 131 0 ) capacitor c=0.0234376f //x=91.315 //y=1.39
c647 ( 130 0 ) capacitor c=0.0199343f //x=91.315 //y=1.045
c648 ( 126 0 ) capacitor c=0.0318948f //x=88.515 //y=1.39
c649 ( 125 0 ) capacitor c=0.0187384f //x=88.515 //y=1.045
c650 ( 124 0 ) capacitor c=0.0605713f //x=88.155 //y=4.975
c651 ( 123 0 ) capacitor c=0.0292043f //x=88.445 //y=4.975
c652 ( 120 0 ) capacitor c=0.0157913f //x=88.36 //y=1.545
c653 ( 118 0 ) capacitor c=0.0149844f //x=88.36 //y=0.89
c654 ( 114 0 ) capacitor c=0.0302441f //x=87.985 //y=2.095
c655 ( 113 0 ) capacitor c=0.0237559f //x=87.985 //y=1.7
c656 ( 112 0 ) capacitor c=0.0234352f //x=87.985 //y=1.39
c657 ( 111 0 ) capacitor c=0.0199931f //x=87.985 //y=1.045
c658 ( 107 0 ) capacitor c=0.0547611f //x=25.925 //y=4.97
c659 ( 106 0 ) capacitor c=0.0294456f //x=26.215 //y=4.97
c660 ( 105 0 ) capacitor c=0.0347816f //x=25.88 //y=1.4
c661 ( 104 0 ) capacitor c=0.0187487f //x=25.88 //y=1.055
c662 ( 98 0 ) capacitor c=0.0137055f //x=25.725 //y=1.555
c663 ( 96 0 ) capacitor c=0.0149861f //x=25.725 //y=0.9
c664 ( 95 0 ) capacitor c=0.096037f //x=25.35 //y=2.095
c665 ( 94 0 ) capacitor c=0.0228993f //x=25.35 //y=1.71
c666 ( 93 0 ) capacitor c=0.0234352f //x=25.35 //y=1.4
c667 ( 92 0 ) capacitor c=0.0198724f //x=25.35 //y=1.055
c668 ( 91 0 ) capacitor c=0.110336f //x=91.84 //y=6.205
c669 ( 90 0 ) capacitor c=0.154049f //x=91.4 //y=6.205
c670 ( 89 0 ) capacitor c=0.110003f //x=88.52 //y=6.205
c671 ( 88 0 ) capacitor c=0.15424f //x=88.08 //y=6.205
c672 ( 87 0 ) capacitor c=0.109949f //x=26.29 //y=6.2
c673 ( 86 0 ) capacitor c=0.158483f //x=25.85 //y=6.2
c674 ( 82 0 ) capacitor c=0.00106608f //x=23.02 //y=5.335
c675 ( 81 0 ) capacitor c=0.00207319f //x=22.14 //y=5.335
c676 ( 74 0 ) capacitor c=0.119551f //x=91.51 //y=2.26
c677 ( 66 0 ) capacitor c=0.0991032f //x=87.81 //y=2.26
c678 ( 58 0 ) capacitor c=0.0910382f //x=25.65 //y=2.26
c679 ( 54 0 ) capacitor c=0.102793f //x=23.8 //y=2.77
c680 ( 50 0 ) capacitor c=0.00398962f //x=23.4 //y=1.845
c681 ( 49 0 ) capacitor c=0.0137288f //x=23.715 //y=1.845
c682 ( 43 0 ) capacitor c=0.0282124f //x=23.715 //y=5.335
c683 ( 35 0 ) capacitor c=0.0176454f //x=22.935 //y=5.335
c684 ( 28 0 ) capacitor c=0.00332903f //x=21.345 //y=5.335
c685 ( 27 0 ) capacitor c=0.0148427f //x=22.055 //y=5.335
c686 ( 10 0 ) capacitor c=0.00638553f //x=87.925 //y=4.62
c687 ( 9 0 ) capacitor c=0.0799095f //x=91.395 //y=4.62
c688 ( 8 0 ) capacitor c=0.00309768f //x=75.685 //y=4.62
c689 ( 7 0 ) capacitor c=0.267484f //x=87.695 //y=4.62
c690 ( 6 0 ) capacitor c=0.00718365f //x=75.6 //y=4.905
c691 ( 4 0 ) capacitor c=0.0158574f //x=23.915 //y=4.99
c692 ( 3 0 ) capacitor c=0.939239f //x=75.515 //y=4.99
c693 ( 2 0 ) capacitor c=0.0116088f //x=23.915 //y=2.77
c694 ( 1 0 ) capacitor c=0.0351856f //x=25.535 //y=2.77
r695 (  167 169 ) resistor r=22.7554 //w=0.233 //l=0.11 //layer=ply \
 //thickness=0.18 //x=91.4 //y=4.885 //x2=91.51 //y2=4.885
r696 (  146 171 ) resistor r=45.1352 //w=0.168 //l=0.173853 //layer=ply \
 //thickness=0.18 //x=91.845 //y=1.39 //x2=91.805 //y2=1.545
r697 (  145 170 ) resistor r=45.1352 //w=0.168 //l=0.173853 //layer=ply \
 //thickness=0.18 //x=91.845 //y=1.045 //x2=91.805 //y2=0.89
r698 (  145 146 ) resistor r=176.904 //w=0.094 //l=0.345 //layer=ply \
 //thickness=0.18 //x=91.845 //y=1.045 //x2=91.845 //y2=1.39
r699 (  142 169 ) resistor r=68.2661 //w=0.233 //l=0.404166 //layer=ply \
 //thickness=0.18 //x=91.84 //y=5.05 //x2=91.51 //y2=4.885
r700 (  140 166 ) resistor r=10.701 //w=0.21 //l=0.115 //layer=ply \
 //thickness=0.18 //x=91.47 //y=1.545 //x2=91.355 //y2=1.545
r701 (  139 171 ) resistor r=5.52526 //w=0.168 //l=0.115 //layer=ply \
 //thickness=0.18 //x=91.69 //y=1.545 //x2=91.805 //y2=1.545
r702 (  138 165 ) resistor r=5.52526 //w=0.168 //l=0.115 //layer=ply \
 //thickness=0.18 //x=91.47 //y=0.89 //x2=91.355 //y2=0.89
r703 (  137 170 ) resistor r=5.52526 //w=0.168 //l=0.115 //layer=ply \
 //thickness=0.18 //x=91.69 //y=0.89 //x2=91.805 //y2=0.89
r704 (  137 138 ) resistor r=112.809 //w=0.094 //l=0.22 //layer=ply \
 //thickness=0.18 //x=91.69 //y=0.89 //x2=91.47 //y2=0.89
r705 (  134 167 ) resistor r=13.0941 //w=0.233 //l=0.165 //layer=ply \
 //thickness=0.18 //x=91.4 //y=5.05 //x2=91.4 //y2=4.885
r706 (  133 164 ) resistor r=34.8111 //w=0.27 //l=0.264953 //layer=ply \
 //thickness=0.18 //x=91.315 //y=2.095 //x2=91.51 //y2=2.26
r707 (  132 166 ) resistor r=39.5823 //w=0.21 //l=0.173853 //layer=ply \
 //thickness=0.18 //x=91.315 //y=1.7 //x2=91.355 //y2=1.545
r708 (  132 133 ) resistor r=202.543 //w=0.094 //l=0.395 //layer=ply \
 //thickness=0.18 //x=91.315 //y=1.7 //x2=91.315 //y2=2.095
r709 (  131 166 ) resistor r=39.5823 //w=0.21 //l=0.173853 //layer=ply \
 //thickness=0.18 //x=91.315 //y=1.39 //x2=91.355 //y2=1.545
r710 (  130 165 ) resistor r=45.1352 //w=0.168 //l=0.173853 //layer=ply \
 //thickness=0.18 //x=91.315 //y=1.045 //x2=91.355 //y2=0.89
r711 (  130 131 ) resistor r=176.904 //w=0.094 //l=0.345 //layer=ply \
 //thickness=0.18 //x=91.315 //y=1.045 //x2=91.315 //y2=1.39
r712 (  126 162 ) resistor r=45.1352 //w=0.168 //l=0.173853 //layer=ply \
 //thickness=0.18 //x=88.515 //y=1.39 //x2=88.475 //y2=1.545
r713 (  125 161 ) resistor r=45.1352 //w=0.168 //l=0.173853 //layer=ply \
 //thickness=0.18 //x=88.515 //y=1.045 //x2=88.475 //y2=0.89
r714 (  125 126 ) resistor r=176.904 //w=0.094 //l=0.345 //layer=ply \
 //thickness=0.18 //x=88.515 //y=1.045 //x2=88.515 //y2=1.39
r715 (  123 127 ) resistor r=26.9307 //w=0.15 //l=0.106066 //layer=ply \
 //thickness=0.18 //x=88.445 //y=4.975 //x2=88.52 //y2=5.05
r716 (  123 124 ) resistor r=148.702 //w=0.094 //l=0.29 //layer=ply \
 //thickness=0.18 //x=88.445 //y=4.975 //x2=88.155 //y2=4.975
r717 (  121 160 ) resistor r=10.701 //w=0.21 //l=0.115 //layer=ply \
 //thickness=0.18 //x=88.14 //y=1.545 //x2=88.025 //y2=1.545
r718 (  120 162 ) resistor r=5.52526 //w=0.168 //l=0.115 //layer=ply \
 //thickness=0.18 //x=88.36 //y=1.545 //x2=88.475 //y2=1.545
r719 (  119 159 ) resistor r=5.52526 //w=0.168 //l=0.115 //layer=ply \
 //thickness=0.18 //x=88.14 //y=0.89 //x2=88.025 //y2=0.89
r720 (  118 161 ) resistor r=5.52526 //w=0.168 //l=0.115 //layer=ply \
 //thickness=0.18 //x=88.36 //y=0.89 //x2=88.475 //y2=0.89
r721 (  118 119 ) resistor r=112.809 //w=0.094 //l=0.22 //layer=ply \
 //thickness=0.18 //x=88.36 //y=0.89 //x2=88.14 //y2=0.89
r722 (  115 124 ) resistor r=22.1787 //w=0.252 //l=0.106066 //layer=ply \
 //thickness=0.18 //x=88.08 //y=5.05 //x2=88.155 //y2=4.975
r723 (  115 158 ) resistor r=51.6429 //w=0.252 //l=0.34271 //layer=ply \
 //thickness=0.18 //x=88.08 //y=5.05 //x2=87.81 //y2=4.885
r724 (  114 156 ) resistor r=30.4513 //w=0.277 //l=0.243926 //layer=ply \
 //thickness=0.18 //x=87.985 //y=2.095 //x2=87.81 //y2=2.26
r725 (  113 160 ) resistor r=39.5823 //w=0.21 //l=0.173853 //layer=ply \
 //thickness=0.18 //x=87.985 //y=1.7 //x2=88.025 //y2=1.545
r726 (  113 114 ) resistor r=202.543 //w=0.094 //l=0.395 //layer=ply \
 //thickness=0.18 //x=87.985 //y=1.7 //x2=87.985 //y2=2.095
r727 (  112 160 ) resistor r=39.5823 //w=0.21 //l=0.173853 //layer=ply \
 //thickness=0.18 //x=87.985 //y=1.39 //x2=88.025 //y2=1.545
r728 (  111 159 ) resistor r=45.1352 //w=0.168 //l=0.173853 //layer=ply \
 //thickness=0.18 //x=87.985 //y=1.045 //x2=88.025 //y2=0.89
r729 (  111 112 ) resistor r=176.904 //w=0.094 //l=0.345 //layer=ply \
 //thickness=0.18 //x=87.985 //y=1.045 //x2=87.985 //y2=1.39
r730 (  106 108 ) resistor r=26.9307 //w=0.15 //l=0.106066 //layer=ply \
 //thickness=0.18 //x=26.215 //y=4.97 //x2=26.29 //y2=5.045
r731 (  106 107 ) resistor r=148.702 //w=0.094 //l=0.29 //layer=ply \
 //thickness=0.18 //x=26.215 //y=4.97 //x2=25.925 //y2=4.97
r732 (  105 154 ) resistor r=45.1352 //w=0.168 //l=0.173853 //layer=ply \
 //thickness=0.18 //x=25.88 //y=1.4 //x2=25.84 //y2=1.555
r733 (  104 153 ) resistor r=45.1352 //w=0.168 //l=0.173853 //layer=ply \
 //thickness=0.18 //x=25.88 //y=1.055 //x2=25.84 //y2=0.9
r734 (  104 105 ) resistor r=176.904 //w=0.094 //l=0.345 //layer=ply \
 //thickness=0.18 //x=25.88 //y=1.055 //x2=25.88 //y2=1.4
r735 (  101 107 ) resistor r=22.7971 //w=0.269 //l=0.106066 //layer=ply \
 //thickness=0.18 //x=25.85 //y=5.045 //x2=25.925 //y2=4.97
r736 (  101 152 ) resistor r=35.8364 //w=0.269 //l=0.270185 //layer=ply \
 //thickness=0.18 //x=25.85 //y=5.045 //x2=25.65 //y2=4.88
r737 (  99 148 ) resistor r=10.701 //w=0.21 //l=0.115 //layer=ply \
 //thickness=0.18 //x=25.505 //y=1.555 //x2=25.39 //y2=1.555
r738 (  98 154 ) resistor r=5.52526 //w=0.168 //l=0.115 //layer=ply \
 //thickness=0.18 //x=25.725 //y=1.555 //x2=25.84 //y2=1.555
r739 (  97 147 ) resistor r=5.52526 //w=0.168 //l=0.115 //layer=ply \
 //thickness=0.18 //x=25.505 //y=0.9 //x2=25.39 //y2=0.9
r740 (  96 153 ) resistor r=5.52526 //w=0.168 //l=0.115 //layer=ply \
 //thickness=0.18 //x=25.725 //y=0.9 //x2=25.84 //y2=0.9
r741 (  96 97 ) resistor r=112.809 //w=0.094 //l=0.22 //layer=ply \
 //thickness=0.18 //x=25.725 //y=0.9 //x2=25.505 //y2=0.9
r742 (  95 150 ) resistor r=58.7805 //w=0.246 //l=0.373497 //layer=ply \
 //thickness=0.18 //x=25.35 //y=2.095 //x2=25.65 //y2=2.26
r743 (  94 148 ) resistor r=39.5823 //w=0.21 //l=0.173853 //layer=ply \
 //thickness=0.18 //x=25.35 //y=1.71 //x2=25.39 //y2=1.555
r744 (  94 95 ) resistor r=197.415 //w=0.094 //l=0.385 //layer=ply \
 //thickness=0.18 //x=25.35 //y=1.71 //x2=25.35 //y2=2.095
r745 (  93 148 ) resistor r=39.5823 //w=0.21 //l=0.173853 //layer=ply \
 //thickness=0.18 //x=25.35 //y=1.4 //x2=25.39 //y2=1.555
r746 (  92 147 ) resistor r=45.1352 //w=0.168 //l=0.173853 //layer=ply \
 //thickness=0.18 //x=25.35 //y=1.055 //x2=25.39 //y2=0.9
r747 (  92 93 ) resistor r=176.904 //w=0.094 //l=0.345 //layer=ply \
 //thickness=0.18 //x=25.35 //y=1.055 //x2=25.35 //y2=1.4
r748 (  91 142 ) resistor r=592.245 //w=0.094 //l=1.155 //layer=ply \
 //thickness=0.18 //x=91.84 //y=6.205 //x2=91.84 //y2=5.05
r749 (  90 134 ) resistor r=592.245 //w=0.094 //l=1.155 //layer=ply \
 //thickness=0.18 //x=91.4 //y=6.205 //x2=91.4 //y2=5.05
r750 (  89 127 ) resistor r=592.245 //w=0.094 //l=1.155 //layer=ply \
 //thickness=0.18 //x=88.52 //y=6.205 //x2=88.52 //y2=5.05
r751 (  88 115 ) resistor r=592.245 //w=0.094 //l=1.155 //layer=ply \
 //thickness=0.18 //x=88.08 //y=6.205 //x2=88.08 //y2=5.05
r752 (  87 108 ) resistor r=592.245 //w=0.094 //l=1.155 //layer=ply \
 //thickness=0.18 //x=26.29 //y=6.2 //x2=26.29 //y2=5.045
r753 (  86 101 ) resistor r=592.245 //w=0.094 //l=1.155 //layer=ply \
 //thickness=0.18 //x=25.85 //y=6.2 //x2=25.85 //y2=5.045
r754 (  85 139 ) resistor r=56.4043 //w=0.094 //l=0.11 //layer=ply \
 //thickness=0.18 //x=91.58 //y=1.545 //x2=91.69 //y2=1.545
r755 (  85 140 ) resistor r=56.4043 //w=0.094 //l=0.11 //layer=ply \
 //thickness=0.18 //x=91.58 //y=1.545 //x2=91.47 //y2=1.545
r756 (  84 120 ) resistor r=56.4043 //w=0.094 //l=0.11 //layer=ply \
 //thickness=0.18 //x=88.25 //y=1.545 //x2=88.36 //y2=1.545
r757 (  84 121 ) resistor r=56.4043 //w=0.094 //l=0.11 //layer=ply \
 //thickness=0.18 //x=88.25 //y=1.545 //x2=88.14 //y2=1.545
r758 (  83 98 ) resistor r=56.4043 //w=0.094 //l=0.11 //layer=ply \
 //thickness=0.18 //x=25.615 //y=1.555 //x2=25.725 //y2=1.555
r759 (  83 99 ) resistor r=56.4043 //w=0.094 //l=0.11 //layer=ply \
 //thickness=0.18 //x=25.615 //y=1.555 //x2=25.505 //y2=1.555
r760 (  79 169 ) resistor r=152 //w=0.17 //l=0.17 //layer=licon //count=1 \
 //x=91.51 //y=4.885 //x2=91.51 //y2=4.885
r761 (  77 79 ) resistor r=18.139 //w=0.187 //l=0.265 //layer=li \
 //thickness=0.1 //x=91.51 //y=4.62 //x2=91.51 //y2=4.885
r762 (  74 164 ) resistor r=152 //w=0.17 //l=0.17 //layer=licon //count=1 \
 //x=91.51 //y=2.26 //x2=91.51 //y2=2.26
r763 (  74 77 ) resistor r=161.54 //w=0.187 //l=2.36 //layer=li \
 //thickness=0.1 //x=91.51 //y=2.26 //x2=91.51 //y2=4.62
r764 (  71 158 ) resistor r=152 //w=0.17 //l=0.17 //layer=licon //count=1 \
 //x=87.81 //y=4.885 //x2=87.81 //y2=4.885
r765 (  69 71 ) resistor r=18.139 //w=0.187 //l=0.265 //layer=li \
 //thickness=0.1 //x=87.81 //y=4.62 //x2=87.81 //y2=4.885
r766 (  66 156 ) resistor r=152 //w=0.17 //l=0.17 //layer=licon //count=1 \
 //x=87.81 //y=2.26 //x2=87.81 //y2=2.26
r767 (  66 69 ) resistor r=161.54 //w=0.187 //l=2.36 //layer=li \
 //thickness=0.1 //x=87.81 //y=2.26 //x2=87.81 //y2=4.62
r768 (  63 152 ) resistor r=152 //w=0.17 //l=0.17 //layer=licon //count=1 \
 //x=25.65 //y=4.88 //x2=25.65 //y2=4.88
r769 (  61 63 ) resistor r=144.428 //w=0.187 //l=2.11 //layer=li \
 //thickness=0.1 //x=25.65 //y=2.77 //x2=25.65 //y2=4.88
r770 (  58 150 ) resistor r=152 //w=0.17 //l=0.17 //layer=licon //count=1 \
 //x=25.65 //y=2.26 //x2=25.65 //y2=2.26
r771 (  58 61 ) resistor r=34.9091 //w=0.187 //l=0.51 //layer=li \
 //thickness=0.1 //x=25.65 //y=2.26 //x2=25.65 //y2=2.77
r772 (  54 56 ) resistor r=151.957 //w=0.187 //l=2.22 //layer=li \
 //thickness=0.1 //x=23.8 //y=2.77 //x2=23.8 //y2=4.99
r773 (  52 56 ) resistor r=17.7968 //w=0.187 //l=0.26 //layer=li \
 //thickness=0.1 //x=23.8 //y=5.25 //x2=23.8 //y2=4.99
r774 (  51 54 ) resistor r=57.4973 //w=0.187 //l=0.84 //layer=li \
 //thickness=0.1 //x=23.8 //y=1.93 //x2=23.8 //y2=2.77
r775 (  49 51 ) resistor r=7.15173 //w=0.17 //l=0.120208 //layer=li \
 //thickness=0.1 //x=23.715 //y=1.845 //x2=23.8 //y2=1.93
r776 (  49 50 ) resistor r=21.5615 //w=0.187 //l=0.315 //layer=li \
 //thickness=0.1 //x=23.715 //y=1.845 //x2=23.4 //y2=1.845
r777 (  45 50 ) resistor r=7.15173 //w=0.17 //l=0.120208 //layer=li \
 //thickness=0.1 //x=23.315 //y=1.76 //x2=23.4 //y2=1.845
r778 (  45 172 ) resistor r=39.016 //w=0.187 //l=0.57 //layer=li \
 //thickness=0.1 //x=23.315 //y=1.76 //x2=23.315 //y2=1.19
r779 (  44 82 ) resistor r=5.4201 //w=0.17 //l=0.085 //layer=li \
 //thickness=0.1 //x=23.105 //y=5.335 //x2=23.02 //y2=5.335
r780 (  43 52 ) resistor r=7.15173 //w=0.17 //l=0.120208 //layer=li \
 //thickness=0.1 //x=23.715 //y=5.335 //x2=23.8 //y2=5.25
r781 (  43 44 ) resistor r=41.754 //w=0.187 //l=0.61 //layer=li \
 //thickness=0.1 //x=23.715 //y=5.335 //x2=23.105 //y2=5.335
r782 (  37 82 ) resistor r=1.40859 //w=0.34 //l=0.085 //layer=li \
 //thickness=0.1 //x=23.02 //y=5.42 //x2=23.02 //y2=5.335
r783 (  37 176 ) resistor r=33.1979 //w=0.187 //l=0.485 //layer=li \
 //thickness=0.1 //x=23.02 //y=5.42 //x2=23.02 //y2=5.905
r784 (  36 81 ) resistor r=5.4201 //w=0.17 //l=0.085 //layer=li \
 //thickness=0.1 //x=22.225 //y=5.335 //x2=22.14 //y2=5.335
r785 (  35 82 ) resistor r=5.4201 //w=0.17 //l=0.085 //layer=li \
 //thickness=0.1 //x=22.935 //y=5.335 //x2=23.02 //y2=5.335
r786 (  35 36 ) resistor r=48.5989 //w=0.187 //l=0.71 //layer=li \
 //thickness=0.1 //x=22.935 //y=5.335 //x2=22.225 //y2=5.335
r787 (  29 81 ) resistor r=1.40859 //w=0.34 //l=0.085 //layer=li \
 //thickness=0.1 //x=22.14 //y=5.42 //x2=22.14 //y2=5.335
r788 (  29 175 ) resistor r=33.1979 //w=0.187 //l=0.485 //layer=li \
 //thickness=0.1 //x=22.14 //y=5.42 //x2=22.14 //y2=5.905
r789 (  27 81 ) resistor r=5.4201 //w=0.17 //l=0.085 //layer=li \
 //thickness=0.1 //x=22.055 //y=5.335 //x2=22.14 //y2=5.335
r790 (  27 28 ) resistor r=48.5989 //w=0.187 //l=0.71 //layer=li \
 //thickness=0.1 //x=22.055 //y=5.335 //x2=21.345 //y2=5.335
r791 (  21 28 ) resistor r=7.15173 //w=0.17 //l=0.120208 //layer=li \
 //thickness=0.1 //x=21.26 //y=5.42 //x2=21.345 //y2=5.335
r792 (  21 174 ) resistor r=33.1979 //w=0.187 //l=0.485 //layer=li \
 //thickness=0.1 //x=21.26 //y=5.42 //x2=21.26 //y2=5.905
r793 (  20 77 ) resistor r=9.3 //w=0.17 //l=0.17 //layer=mcon //count=1 \
 //x=91.51 //y=4.62 //x2=91.51 //y2=4.62
r794 (  18 69 ) resistor r=9.3 //w=0.17 //l=0.17 //layer=mcon //count=1 \
 //x=87.81 //y=4.62 //x2=87.81 //y2=4.62
r795 (  16 61 ) resistor r=9.3 //w=0.17 //l=0.17 //layer=mcon //count=1 \
 //x=25.65 //y=2.77 //x2=25.65 //y2=2.77
r796 (  14 56 ) resistor r=9.3 //w=0.17 //l=0.17 //layer=mcon //count=1 \
 //x=23.8 //y=4.99 //x2=23.8 //y2=4.99
r797 (  12 54 ) resistor r=9.3 //w=0.17 //l=0.17 //layer=mcon //count=1 \
 //x=23.8 //y=2.77 //x2=23.8 //y2=2.77
r798 (  10 18 ) resistor r=0.0880901 //w=0.191 //l=0.115 //layer=m1 \
 //thickness=0.36 //x=87.925 //y=4.62 //x2=87.81 //y2=4.62
r799 (  9 20 ) resistor r=0.0717383 //w=0.224 //l=0.115 //layer=m1 \
 //thickness=0.36 //x=91.395 //y=4.62 //x2=91.51 //y2=4.62
r800 (  9 10 ) resistor r=3.31107 //w=0.131 //l=3.47 //layer=m1 \
 //thickness=0.36 //x=91.395 //y=4.62 //x2=87.925 //y2=4.62
r801 (  7 18 ) resistor r=0.0880901 //w=0.191 //l=0.115 //layer=m1 \
 //thickness=0.36 //x=87.695 //y=4.62 //x2=87.81 //y2=4.62
r802 (  7 8 ) resistor r=11.4599 //w=0.131 //l=12.01 //layer=m1 \
 //thickness=0.36 //x=87.695 //y=4.62 //x2=75.685 //y2=4.62
r803 (  5 8 ) resistor r=0.0718295 //w=0.17 //l=0.120208 //layer=m1 \
 //thickness=0.36 //x=75.6 //y=4.705 //x2=75.685 //y2=4.62
r804 (  5 6 ) resistor r=0.19084 //w=0.131 //l=0.2 //layer=m1 //thickness=0.36 \
 //x=75.6 //y=4.705 //x2=75.6 //y2=4.905
r805 (  4 14 ) resistor r=0.0717383 //w=0.224 //l=0.115 //layer=m1 \
 //thickness=0.36 //x=23.915 //y=4.99 //x2=23.8 //y2=4.99
r806 (  3 6 ) resistor r=0.0698411 //w=0.17 //l=0.120208 //layer=m1 \
 //thickness=0.36 //x=75.515 //y=4.99 //x2=75.6 //y2=4.905
r807 (  3 4 ) resistor r=49.2366 //w=0.131 //l=51.6 //layer=m1 \
 //thickness=0.36 //x=75.515 //y=4.99 //x2=23.915 //y2=4.99
r808 (  2 12 ) resistor r=0.0717383 //w=0.224 //l=0.115 //layer=m1 \
 //thickness=0.36 //x=23.915 //y=2.77 //x2=23.8 //y2=2.77
r809 (  1 16 ) resistor r=0.0717383 //w=0.224 //l=0.115 //layer=m1 \
 //thickness=0.36 //x=25.535 //y=2.77 //x2=25.65 //y2=2.77
r810 (  1 2 ) resistor r=1.5458 //w=0.131 //l=1.62 //layer=m1 //thickness=0.36 \
 //x=25.535 //y=2.77 //x2=23.915 //y2=2.77
ends PM_TMRDFFSNRNQNX1\%noxref_6

subckt PM_TMRDFFSNRNQNX1\%noxref_7 ( 1 2 3 4 5 6 16 24 37 38 45 53 59 60 64 66 \
 73 74 75 76 77 78 79 80 81 82 83 87 88 89 94 96 99 100 104 105 106 111 113 \
 116 117 121 122 123 128 130 133 134 136 137 142 146 147 152 156 157 162 165 \
 167 168 169 )
c339 ( 169 0 ) capacitor c=0.023087f //x=18.065 //y=5.2
c340 ( 168 0 ) capacitor c=0.023519f //x=17.185 //y=5.2
c341 ( 167 0 ) capacitor c=0.0224735f //x=16.305 //y=5.2
c342 ( 165 0 ) capacitor c=0.00853354f //x=18.315 //y=1.095
c343 ( 162 0 ) capacitor c=0.0588394f //x=27.87 //y=4.88
c344 ( 157 0 ) capacitor c=0.0273931f //x=27.87 //y=2.095
c345 ( 156 0 ) capacitor c=0.0456313f //x=27.87 //y=2.26
c346 ( 152 0 ) capacitor c=0.0587755f //x=13.44 //y=4.88
c347 ( 147 0 ) capacitor c=0.0273931f //x=13.44 //y=2.095
c348 ( 146 0 ) capacitor c=0.0456313f //x=13.44 //y=2.26
c349 ( 142 0 ) capacitor c=0.058931f //x=8.63 //y=4.88
c350 ( 137 0 ) capacitor c=0.0273931f //x=8.63 //y=2.095
c351 ( 136 0 ) capacitor c=0.0456313f //x=8.63 //y=2.26
c352 ( 134 0 ) capacitor c=0.0432517f //x=28.39 //y=1.44
c353 ( 133 0 ) capacitor c=0.0200379f //x=28.39 //y=1.095
c354 ( 130 0 ) capacitor c=0.0148873f //x=28.235 //y=1.595
c355 ( 128 0 ) capacitor c=0.0157803f //x=28.235 //y=0.94
c356 ( 123 0 ) capacitor c=0.0218028f //x=27.86 //y=1.75
c357 ( 122 0 ) capacitor c=0.0207459f //x=27.86 //y=1.44
c358 ( 121 0 ) capacitor c=0.0194308f //x=27.86 //y=1.095
c359 ( 117 0 ) capacitor c=0.0432517f //x=13.96 //y=1.44
c360 ( 116 0 ) capacitor c=0.0200379f //x=13.96 //y=1.095
c361 ( 113 0 ) capacitor c=0.0148873f //x=13.805 //y=1.595
c362 ( 111 0 ) capacitor c=0.0157803f //x=13.805 //y=0.94
c363 ( 106 0 ) capacitor c=0.0218028f //x=13.43 //y=1.75
c364 ( 105 0 ) capacitor c=0.0207459f //x=13.43 //y=1.44
c365 ( 104 0 ) capacitor c=0.0194308f //x=13.43 //y=1.095
c366 ( 100 0 ) capacitor c=0.0432517f //x=9.15 //y=1.44
c367 ( 99 0 ) capacitor c=0.0200379f //x=9.15 //y=1.095
c368 ( 96 0 ) capacitor c=0.0148873f //x=8.995 //y=1.595
c369 ( 94 0 ) capacitor c=0.0157803f //x=8.995 //y=0.94
c370 ( 89 0 ) capacitor c=0.0218028f //x=8.62 //y=1.75
c371 ( 88 0 ) capacitor c=0.0207459f //x=8.62 //y=1.44
c372 ( 87 0 ) capacitor c=0.0194308f //x=8.62 //y=1.095
c373 ( 83 0 ) capacitor c=0.158754f //x=28.05 //y=6.2
c374 ( 82 0 ) capacitor c=0.109949f //x=27.61 //y=6.2
c375 ( 81 0 ) capacitor c=0.158794f //x=13.62 //y=6.2
c376 ( 80 0 ) capacitor c=0.110114f //x=13.18 //y=6.2
c377 ( 79 0 ) capacitor c=0.158794f //x=8.81 //y=6.2
c378 ( 78 0 ) capacitor c=0.110114f //x=8.37 //y=6.2
c379 ( 74 0 ) capacitor c=0.00106608f //x=18.21 //y=5.335
c380 ( 73 0 ) capacitor c=0.00207162f //x=17.33 //y=5.335
c381 ( 66 0 ) capacitor c=0.0796271f //x=27.87 //y=2.26
c382 ( 64 0 ) capacitor c=0.105458f //x=18.99 //y=3.88
c383 ( 60 0 ) capacitor c=0.00398962f //x=18.59 //y=1.845
c384 ( 59 0 ) capacitor c=0.0137288f //x=18.905 //y=1.845
c385 ( 53 0 ) capacitor c=0.0283082f //x=18.905 //y=5.335
c386 ( 45 0 ) capacitor c=0.0176454f //x=18.125 //y=5.335
c387 ( 38 0 ) capacitor c=0.00332903f //x=16.535 //y=5.335
c388 ( 37 0 ) capacitor c=0.014837f //x=17.245 //y=5.335
c389 ( 24 0 ) capacitor c=0.0810736f //x=13.44 //y=2.26
c390 ( 16 0 ) capacitor c=0.0819749f //x=8.63 //y=2.26
c391 ( 6 0 ) capacitor c=0.0055354f //x=19.105 //y=3.88
c392 ( 5 0 ) capacitor c=0.145577f //x=27.755 //y=3.88
c393 ( 4 0 ) capacitor c=0.00556898f //x=13.555 //y=3.88
c394 ( 3 0 ) capacitor c=0.0758356f //x=18.875 //y=3.88
c395 ( 2 0 ) capacitor c=0.0138772f //x=8.745 //y=3.88
c396 ( 1 0 ) capacitor c=0.067053f //x=13.325 //y=3.88
r397 (  156 157 ) resistor r=52.7279 //w=0.214 //l=0.165 //layer=ply \
 //thickness=0.18 //x=27.87 //y=2.26 //x2=27.87 //y2=2.095
r398 (  146 147 ) resistor r=52.7279 //w=0.214 //l=0.165 //layer=ply \
 //thickness=0.18 //x=13.44 //y=2.26 //x2=13.44 //y2=2.095
r399 (  136 137 ) resistor r=52.7279 //w=0.214 //l=0.165 //layer=ply \
 //thickness=0.18 //x=8.63 //y=2.26 //x2=8.63 //y2=2.095
r400 (  134 164 ) resistor r=45.1352 //w=0.168 //l=0.173853 //layer=ply \
 //thickness=0.18 //x=28.39 //y=1.44 //x2=28.35 //y2=1.595
r401 (  133 163 ) resistor r=45.1352 //w=0.168 //l=0.173853 //layer=ply \
 //thickness=0.18 //x=28.39 //y=1.095 //x2=28.35 //y2=0.94
r402 (  133 134 ) resistor r=176.904 //w=0.094 //l=0.345 //layer=ply \
 //thickness=0.18 //x=28.39 //y=1.095 //x2=28.39 //y2=1.44
r403 (  131 160 ) resistor r=10.701 //w=0.21 //l=0.115 //layer=ply \
 //thickness=0.18 //x=28.015 //y=1.595 //x2=27.9 //y2=1.595
r404 (  130 164 ) resistor r=5.52526 //w=0.168 //l=0.115 //layer=ply \
 //thickness=0.18 //x=28.235 //y=1.595 //x2=28.35 //y2=1.595
r405 (  129 159 ) resistor r=5.52526 //w=0.168 //l=0.115 //layer=ply \
 //thickness=0.18 //x=28.015 //y=0.94 //x2=27.9 //y2=0.94
r406 (  128 163 ) resistor r=5.52526 //w=0.168 //l=0.115 //layer=ply \
 //thickness=0.18 //x=28.235 //y=0.94 //x2=28.35 //y2=0.94
r407 (  128 129 ) resistor r=112.809 //w=0.094 //l=0.22 //layer=ply \
 //thickness=0.18 //x=28.235 //y=0.94 //x2=28.015 //y2=0.94
r408 (  125 162 ) resistor r=37.236 //w=0.233 //l=0.249199 //layer=ply \
 //thickness=0.18 //x=28.05 //y=5.045 //x2=27.87 //y2=4.88
r409 (  123 160 ) resistor r=39.5823 //w=0.21 //l=0.173853 //layer=ply \
 //thickness=0.18 //x=27.86 //y=1.75 //x2=27.9 //y2=1.595
r410 (  123 157 ) resistor r=176.904 //w=0.094 //l=0.345 //layer=ply \
 //thickness=0.18 //x=27.86 //y=1.75 //x2=27.86 //y2=2.095
r411 (  122 160 ) resistor r=39.5823 //w=0.21 //l=0.173853 //layer=ply \
 //thickness=0.18 //x=27.86 //y=1.44 //x2=27.9 //y2=1.595
r412 (  121 159 ) resistor r=45.1352 //w=0.168 //l=0.173853 //layer=ply \
 //thickness=0.18 //x=27.86 //y=1.095 //x2=27.9 //y2=0.94
r413 (  121 122 ) resistor r=176.904 //w=0.094 //l=0.345 //layer=ply \
 //thickness=0.18 //x=27.86 //y=1.095 //x2=27.86 //y2=1.44
r414 (  118 162 ) resistor r=53.7854 //w=0.233 //l=0.332415 //layer=ply \
 //thickness=0.18 //x=27.61 //y=5.045 //x2=27.87 //y2=4.88
r415 (  117 154 ) resistor r=45.1352 //w=0.168 //l=0.173853 //layer=ply \
 //thickness=0.18 //x=13.96 //y=1.44 //x2=13.92 //y2=1.595
r416 (  116 153 ) resistor r=45.1352 //w=0.168 //l=0.173853 //layer=ply \
 //thickness=0.18 //x=13.96 //y=1.095 //x2=13.92 //y2=0.94
r417 (  116 117 ) resistor r=176.904 //w=0.094 //l=0.345 //layer=ply \
 //thickness=0.18 //x=13.96 //y=1.095 //x2=13.96 //y2=1.44
r418 (  114 150 ) resistor r=10.701 //w=0.21 //l=0.115 //layer=ply \
 //thickness=0.18 //x=13.585 //y=1.595 //x2=13.47 //y2=1.595
r419 (  113 154 ) resistor r=5.52526 //w=0.168 //l=0.115 //layer=ply \
 //thickness=0.18 //x=13.805 //y=1.595 //x2=13.92 //y2=1.595
r420 (  112 149 ) resistor r=5.52526 //w=0.168 //l=0.115 //layer=ply \
 //thickness=0.18 //x=13.585 //y=0.94 //x2=13.47 //y2=0.94
r421 (  111 153 ) resistor r=5.52526 //w=0.168 //l=0.115 //layer=ply \
 //thickness=0.18 //x=13.805 //y=0.94 //x2=13.92 //y2=0.94
r422 (  111 112 ) resistor r=112.809 //w=0.094 //l=0.22 //layer=ply \
 //thickness=0.18 //x=13.805 //y=0.94 //x2=13.585 //y2=0.94
r423 (  108 152 ) resistor r=37.236 //w=0.233 //l=0.249199 //layer=ply \
 //thickness=0.18 //x=13.62 //y=5.045 //x2=13.44 //y2=4.88
r424 (  106 150 ) resistor r=39.5823 //w=0.21 //l=0.173853 //layer=ply \
 //thickness=0.18 //x=13.43 //y=1.75 //x2=13.47 //y2=1.595
r425 (  106 147 ) resistor r=176.904 //w=0.094 //l=0.345 //layer=ply \
 //thickness=0.18 //x=13.43 //y=1.75 //x2=13.43 //y2=2.095
r426 (  105 150 ) resistor r=39.5823 //w=0.21 //l=0.173853 //layer=ply \
 //thickness=0.18 //x=13.43 //y=1.44 //x2=13.47 //y2=1.595
r427 (  104 149 ) resistor r=45.1352 //w=0.168 //l=0.173853 //layer=ply \
 //thickness=0.18 //x=13.43 //y=1.095 //x2=13.47 //y2=0.94
r428 (  104 105 ) resistor r=176.904 //w=0.094 //l=0.345 //layer=ply \
 //thickness=0.18 //x=13.43 //y=1.095 //x2=13.43 //y2=1.44
r429 (  101 152 ) resistor r=53.7854 //w=0.233 //l=0.332415 //layer=ply \
 //thickness=0.18 //x=13.18 //y=5.045 //x2=13.44 //y2=4.88
r430 (  100 144 ) resistor r=45.1352 //w=0.168 //l=0.173853 //layer=ply \
 //thickness=0.18 //x=9.15 //y=1.44 //x2=9.11 //y2=1.595
r431 (  99 143 ) resistor r=45.1352 //w=0.168 //l=0.173853 //layer=ply \
 //thickness=0.18 //x=9.15 //y=1.095 //x2=9.11 //y2=0.94
r432 (  99 100 ) resistor r=176.904 //w=0.094 //l=0.345 //layer=ply \
 //thickness=0.18 //x=9.15 //y=1.095 //x2=9.15 //y2=1.44
r433 (  97 140 ) resistor r=10.701 //w=0.21 //l=0.115 //layer=ply \
 //thickness=0.18 //x=8.775 //y=1.595 //x2=8.66 //y2=1.595
r434 (  96 144 ) resistor r=5.52526 //w=0.168 //l=0.115 //layer=ply \
 //thickness=0.18 //x=8.995 //y=1.595 //x2=9.11 //y2=1.595
r435 (  95 139 ) resistor r=5.52526 //w=0.168 //l=0.115 //layer=ply \
 //thickness=0.18 //x=8.775 //y=0.94 //x2=8.66 //y2=0.94
r436 (  94 143 ) resistor r=5.52526 //w=0.168 //l=0.115 //layer=ply \
 //thickness=0.18 //x=8.995 //y=0.94 //x2=9.11 //y2=0.94
r437 (  94 95 ) resistor r=112.809 //w=0.094 //l=0.22 //layer=ply \
 //thickness=0.18 //x=8.995 //y=0.94 //x2=8.775 //y2=0.94
r438 (  91 142 ) resistor r=37.236 //w=0.233 //l=0.249199 //layer=ply \
 //thickness=0.18 //x=8.81 //y=5.045 //x2=8.63 //y2=4.88
r439 (  89 140 ) resistor r=39.5823 //w=0.21 //l=0.173853 //layer=ply \
 //thickness=0.18 //x=8.62 //y=1.75 //x2=8.66 //y2=1.595
r440 (  89 137 ) resistor r=176.904 //w=0.094 //l=0.345 //layer=ply \
 //thickness=0.18 //x=8.62 //y=1.75 //x2=8.62 //y2=2.095
r441 (  88 140 ) resistor r=39.5823 //w=0.21 //l=0.173853 //layer=ply \
 //thickness=0.18 //x=8.62 //y=1.44 //x2=8.66 //y2=1.595
r442 (  87 139 ) resistor r=45.1352 //w=0.168 //l=0.173853 //layer=ply \
 //thickness=0.18 //x=8.62 //y=1.095 //x2=8.66 //y2=0.94
r443 (  87 88 ) resistor r=176.904 //w=0.094 //l=0.345 //layer=ply \
 //thickness=0.18 //x=8.62 //y=1.095 //x2=8.62 //y2=1.44
r444 (  84 142 ) resistor r=53.7854 //w=0.233 //l=0.332415 //layer=ply \
 //thickness=0.18 //x=8.37 //y=5.045 //x2=8.63 //y2=4.88
r445 (  83 125 ) resistor r=592.245 //w=0.094 //l=1.155 //layer=ply \
 //thickness=0.18 //x=28.05 //y=6.2 //x2=28.05 //y2=5.045
r446 (  82 118 ) resistor r=592.245 //w=0.094 //l=1.155 //layer=ply \
 //thickness=0.18 //x=27.61 //y=6.2 //x2=27.61 //y2=5.045
r447 (  81 108 ) resistor r=592.245 //w=0.094 //l=1.155 //layer=ply \
 //thickness=0.18 //x=13.62 //y=6.2 //x2=13.62 //y2=5.045
r448 (  80 101 ) resistor r=592.245 //w=0.094 //l=1.155 //layer=ply \
 //thickness=0.18 //x=13.18 //y=6.2 //x2=13.18 //y2=5.045
r449 (  79 91 ) resistor r=592.245 //w=0.094 //l=1.155 //layer=ply \
 //thickness=0.18 //x=8.81 //y=6.2 //x2=8.81 //y2=5.045
r450 (  78 84 ) resistor r=592.245 //w=0.094 //l=1.155 //layer=ply \
 //thickness=0.18 //x=8.37 //y=6.2 //x2=8.37 //y2=5.045
r451 (  77 130 ) resistor r=56.4043 //w=0.094 //l=0.11 //layer=ply \
 //thickness=0.18 //x=28.125 //y=1.595 //x2=28.235 //y2=1.595
r452 (  77 131 ) resistor r=56.4043 //w=0.094 //l=0.11 //layer=ply \
 //thickness=0.18 //x=28.125 //y=1.595 //x2=28.015 //y2=1.595
r453 (  76 113 ) resistor r=56.4043 //w=0.094 //l=0.11 //layer=ply \
 //thickness=0.18 //x=13.695 //y=1.595 //x2=13.805 //y2=1.595
r454 (  76 114 ) resistor r=56.4043 //w=0.094 //l=0.11 //layer=ply \
 //thickness=0.18 //x=13.695 //y=1.595 //x2=13.585 //y2=1.595
r455 (  75 96 ) resistor r=56.4043 //w=0.094 //l=0.11 //layer=ply \
 //thickness=0.18 //x=8.885 //y=1.595 //x2=8.995 //y2=1.595
r456 (  75 97 ) resistor r=56.4043 //w=0.094 //l=0.11 //layer=ply \
 //thickness=0.18 //x=8.885 //y=1.595 //x2=8.775 //y2=1.595
r457 (  71 162 ) resistor r=152 //w=0.17 //l=0.17 //layer=licon //count=1 \
 //x=27.87 //y=4.88 //x2=27.87 //y2=4.88
r458 (  69 71 ) resistor r=68.4492 //w=0.187 //l=1 //layer=li //thickness=0.1 \
 //x=27.87 //y=3.88 //x2=27.87 //y2=4.88
r459 (  66 156 ) resistor r=152 //w=0.17 //l=0.17 //layer=licon //count=1 \
 //x=27.87 //y=2.26 //x2=27.87 //y2=2.26
r460 (  66 69 ) resistor r=110.888 //w=0.187 //l=1.62 //layer=li \
 //thickness=0.1 //x=27.87 //y=2.26 //x2=27.87 //y2=3.88
r461 (  62 64 ) resistor r=93.7754 //w=0.187 //l=1.37 //layer=li \
 //thickness=0.1 //x=18.99 //y=5.25 //x2=18.99 //y2=3.88
r462 (  61 64 ) resistor r=133.476 //w=0.187 //l=1.95 //layer=li \
 //thickness=0.1 //x=18.99 //y=1.93 //x2=18.99 //y2=3.88
r463 (  59 61 ) resistor r=7.15173 //w=0.17 //l=0.120208 //layer=li \
 //thickness=0.1 //x=18.905 //y=1.845 //x2=18.99 //y2=1.93
r464 (  59 60 ) resistor r=21.5615 //w=0.187 //l=0.315 //layer=li \
 //thickness=0.1 //x=18.905 //y=1.845 //x2=18.59 //y2=1.845
r465 (  55 60 ) resistor r=7.15173 //w=0.17 //l=0.120208 //layer=li \
 //thickness=0.1 //x=18.505 //y=1.76 //x2=18.59 //y2=1.845
r466 (  55 165 ) resistor r=39.016 //w=0.187 //l=0.57 //layer=li \
 //thickness=0.1 //x=18.505 //y=1.76 //x2=18.505 //y2=1.19
r467 (  54 74 ) resistor r=5.4201 //w=0.17 //l=0.085 //layer=li \
 //thickness=0.1 //x=18.295 //y=5.335 //x2=18.21 //y2=5.335
r468 (  53 62 ) resistor r=7.15173 //w=0.17 //l=0.120208 //layer=li \
 //thickness=0.1 //x=18.905 //y=5.335 //x2=18.99 //y2=5.25
r469 (  53 54 ) resistor r=41.754 //w=0.187 //l=0.61 //layer=li \
 //thickness=0.1 //x=18.905 //y=5.335 //x2=18.295 //y2=5.335
r470 (  47 74 ) resistor r=1.40859 //w=0.34 //l=0.085 //layer=li \
 //thickness=0.1 //x=18.21 //y=5.42 //x2=18.21 //y2=5.335
r471 (  47 169 ) resistor r=33.1979 //w=0.187 //l=0.485 //layer=li \
 //thickness=0.1 //x=18.21 //y=5.42 //x2=18.21 //y2=5.905
r472 (  46 73 ) resistor r=5.4201 //w=0.17 //l=0.085 //layer=li \
 //thickness=0.1 //x=17.415 //y=5.335 //x2=17.33 //y2=5.335
r473 (  45 74 ) resistor r=5.4201 //w=0.17 //l=0.085 //layer=li \
 //thickness=0.1 //x=18.125 //y=5.335 //x2=18.21 //y2=5.335
r474 (  45 46 ) resistor r=48.5989 //w=0.187 //l=0.71 //layer=li \
 //thickness=0.1 //x=18.125 //y=5.335 //x2=17.415 //y2=5.335
r475 (  39 73 ) resistor r=1.40859 //w=0.34 //l=0.085 //layer=li \
 //thickness=0.1 //x=17.33 //y=5.42 //x2=17.33 //y2=5.335
r476 (  39 168 ) resistor r=33.1979 //w=0.187 //l=0.485 //layer=li \
 //thickness=0.1 //x=17.33 //y=5.42 //x2=17.33 //y2=5.905
r477 (  37 73 ) resistor r=5.4201 //w=0.17 //l=0.085 //layer=li \
 //thickness=0.1 //x=17.245 //y=5.335 //x2=17.33 //y2=5.335
r478 (  37 38 ) resistor r=48.5989 //w=0.187 //l=0.71 //layer=li \
 //thickness=0.1 //x=17.245 //y=5.335 //x2=16.535 //y2=5.335
r479 (  31 38 ) resistor r=7.15173 //w=0.17 //l=0.120208 //layer=li \
 //thickness=0.1 //x=16.45 //y=5.42 //x2=16.535 //y2=5.335
r480 (  31 167 ) resistor r=33.1979 //w=0.187 //l=0.485 //layer=li \
 //thickness=0.1 //x=16.45 //y=5.42 //x2=16.45 //y2=5.905
r481 (  29 152 ) resistor r=152 //w=0.17 //l=0.17 //layer=licon //count=1 \
 //x=13.44 //y=4.88 //x2=13.44 //y2=4.88
r482 (  27 29 ) resistor r=68.4492 //w=0.187 //l=1 //layer=li //thickness=0.1 \
 //x=13.44 //y=3.88 //x2=13.44 //y2=4.88
r483 (  24 146 ) resistor r=152 //w=0.17 //l=0.17 //layer=licon //count=1 \
 //x=13.44 //y=2.26 //x2=13.44 //y2=2.26
r484 (  24 27 ) resistor r=110.888 //w=0.187 //l=1.62 //layer=li \
 //thickness=0.1 //x=13.44 //y=2.26 //x2=13.44 //y2=3.88
r485 (  21 142 ) resistor r=152 //w=0.17 //l=0.17 //layer=licon //count=1 \
 //x=8.63 //y=4.88 //x2=8.63 //y2=4.88
r486 (  19 21 ) resistor r=68.4492 //w=0.187 //l=1 //layer=li //thickness=0.1 \
 //x=8.63 //y=3.88 //x2=8.63 //y2=4.88
r487 (  16 136 ) resistor r=152 //w=0.17 //l=0.17 //layer=licon //count=1 \
 //x=8.63 //y=2.26 //x2=8.63 //y2=2.26
r488 (  16 19 ) resistor r=110.888 //w=0.187 //l=1.62 //layer=li \
 //thickness=0.1 //x=8.63 //y=2.26 //x2=8.63 //y2=3.88
r489 (  14 69 ) resistor r=9.3 //w=0.17 //l=0.17 //layer=mcon //count=1 \
 //x=27.87 //y=3.88 //x2=27.87 //y2=3.88
r490 (  12 64 ) resistor r=9.3 //w=0.17 //l=0.17 //layer=mcon //count=1 \
 //x=18.99 //y=3.88 //x2=18.99 //y2=3.88
r491 (  10 27 ) resistor r=9.3 //w=0.17 //l=0.17 //layer=mcon //count=1 \
 //x=13.44 //y=3.88 //x2=13.44 //y2=3.88
r492 (  8 19 ) resistor r=9.3 //w=0.17 //l=0.17 //layer=mcon //count=1 \
 //x=8.63 //y=3.88 //x2=8.63 //y2=3.88
r493 (  6 12 ) resistor r=0.0880901 //w=0.191 //l=0.115 //layer=m1 \
 //thickness=0.36 //x=19.105 //y=3.88 //x2=18.99 //y2=3.88
r494 (  5 14 ) resistor r=0.0717383 //w=0.224 //l=0.115 //layer=m1 \
 //thickness=0.36 //x=27.755 //y=3.88 //x2=27.87 //y2=3.88
r495 (  5 6 ) resistor r=8.25382 //w=0.131 //l=8.65 //layer=m1 \
 //thickness=0.36 //x=27.755 //y=3.88 //x2=19.105 //y2=3.88
r496 (  4 10 ) resistor r=0.0880901 //w=0.191 //l=0.115 //layer=m1 \
 //thickness=0.36 //x=13.555 //y=3.88 //x2=13.44 //y2=3.88
r497 (  3 12 ) resistor r=0.0880901 //w=0.191 //l=0.115 //layer=m1 \
 //thickness=0.36 //x=18.875 //y=3.88 //x2=18.99 //y2=3.88
r498 (  3 4 ) resistor r=5.07634 //w=0.131 //l=5.32 //layer=m1 \
 //thickness=0.36 //x=18.875 //y=3.88 //x2=13.555 //y2=3.88
r499 (  2 8 ) resistor r=0.0717383 //w=0.224 //l=0.115 //layer=m1 \
 //thickness=0.36 //x=8.745 //y=3.88 //x2=8.63 //y2=3.88
r500 (  1 10 ) resistor r=0.0880901 //w=0.191 //l=0.115 //layer=m1 \
 //thickness=0.36 //x=13.325 //y=3.88 //x2=13.44 //y2=3.88
r501 (  1 2 ) resistor r=4.37023 //w=0.131 //l=4.58 //layer=m1 \
 //thickness=0.36 //x=13.325 //y=3.88 //x2=8.745 //y2=3.88
ends PM_TMRDFFSNRNQNX1\%noxref_7

subckt PM_TMRDFFSNRNQNX1\%noxref_8 ( 1 2 8 21 22 29 37 43 44 48 49 50 51 52 53 \
 57 58 59 64 66 69 70 72 73 78 81 83 84 85 )
c176 ( 85 0 ) capacitor c=0.023087f //x=27.685 //y=5.2
c177 ( 84 0 ) capacitor c=0.023519f //x=26.805 //y=5.2
c178 ( 83 0 ) capacitor c=0.0224735f //x=25.925 //y=5.2
c179 ( 81 0 ) capacitor c=0.00853354f //x=27.935 //y=1.095
c180 ( 78 0 ) capacitor c=0.0587755f //x=23.06 //y=4.88
c181 ( 73 0 ) capacitor c=0.0273931f //x=23.06 //y=2.095
c182 ( 72 0 ) capacitor c=0.0456313f //x=23.06 //y=2.26
c183 ( 70 0 ) capacitor c=0.0432517f //x=23.58 //y=1.44
c184 ( 69 0 ) capacitor c=0.0200379f //x=23.58 //y=1.095
c185 ( 66 0 ) capacitor c=0.0148873f //x=23.425 //y=1.595
c186 ( 64 0 ) capacitor c=0.0157803f //x=23.425 //y=0.94
c187 ( 59 0 ) capacitor c=0.0218028f //x=23.05 //y=1.75
c188 ( 58 0 ) capacitor c=0.0207459f //x=23.05 //y=1.44
c189 ( 57 0 ) capacitor c=0.0194308f //x=23.05 //y=1.095
c190 ( 53 0 ) capacitor c=0.158794f //x=23.24 //y=6.2
c191 ( 52 0 ) capacitor c=0.110114f //x=22.8 //y=6.2
c192 ( 50 0 ) capacitor c=9.74268e-19 //x=27.83 //y=5.335
c193 ( 49 0 ) capacitor c=0.00191414f //x=26.95 //y=5.335
c194 ( 48 0 ) capacitor c=0.107305f //x=28.61 //y=3.51
c195 ( 44 0 ) capacitor c=0.00398962f //x=28.21 //y=1.845
c196 ( 43 0 ) capacitor c=0.0137288f //x=28.525 //y=1.845
c197 ( 37 0 ) capacitor c=0.0276208f //x=28.525 //y=5.335
c198 ( 29 0 ) capacitor c=0.0169868f //x=27.745 //y=5.335
c199 ( 22 0 ) capacitor c=0.00316998f //x=26.155 //y=5.335
c200 ( 21 0 ) capacitor c=0.014258f //x=26.865 //y=5.335
c201 ( 8 0 ) capacitor c=0.0820026f //x=23.06 //y=2.26
c202 ( 2 0 ) capacitor c=0.00906635f //x=23.175 //y=3.51
c203 ( 1 0 ) capacitor c=0.0884963f //x=28.495 //y=3.51
r204 (  72 73 ) resistor r=52.7279 //w=0.214 //l=0.165 //layer=ply \
 //thickness=0.18 //x=23.06 //y=2.26 //x2=23.06 //y2=2.095
r205 (  70 80 ) resistor r=45.1352 //w=0.168 //l=0.173853 //layer=ply \
 //thickness=0.18 //x=23.58 //y=1.44 //x2=23.54 //y2=1.595
r206 (  69 79 ) resistor r=45.1352 //w=0.168 //l=0.173853 //layer=ply \
 //thickness=0.18 //x=23.58 //y=1.095 //x2=23.54 //y2=0.94
r207 (  69 70 ) resistor r=176.904 //w=0.094 //l=0.345 //layer=ply \
 //thickness=0.18 //x=23.58 //y=1.095 //x2=23.58 //y2=1.44
r208 (  67 76 ) resistor r=10.701 //w=0.21 //l=0.115 //layer=ply \
 //thickness=0.18 //x=23.205 //y=1.595 //x2=23.09 //y2=1.595
r209 (  66 80 ) resistor r=5.52526 //w=0.168 //l=0.115 //layer=ply \
 //thickness=0.18 //x=23.425 //y=1.595 //x2=23.54 //y2=1.595
r210 (  65 75 ) resistor r=5.52526 //w=0.168 //l=0.115 //layer=ply \
 //thickness=0.18 //x=23.205 //y=0.94 //x2=23.09 //y2=0.94
r211 (  64 79 ) resistor r=5.52526 //w=0.168 //l=0.115 //layer=ply \
 //thickness=0.18 //x=23.425 //y=0.94 //x2=23.54 //y2=0.94
r212 (  64 65 ) resistor r=112.809 //w=0.094 //l=0.22 //layer=ply \
 //thickness=0.18 //x=23.425 //y=0.94 //x2=23.205 //y2=0.94
r213 (  61 78 ) resistor r=37.236 //w=0.233 //l=0.249199 //layer=ply \
 //thickness=0.18 //x=23.24 //y=5.045 //x2=23.06 //y2=4.88
r214 (  59 76 ) resistor r=39.5823 //w=0.21 //l=0.173853 //layer=ply \
 //thickness=0.18 //x=23.05 //y=1.75 //x2=23.09 //y2=1.595
r215 (  59 73 ) resistor r=176.904 //w=0.094 //l=0.345 //layer=ply \
 //thickness=0.18 //x=23.05 //y=1.75 //x2=23.05 //y2=2.095
r216 (  58 76 ) resistor r=39.5823 //w=0.21 //l=0.173853 //layer=ply \
 //thickness=0.18 //x=23.05 //y=1.44 //x2=23.09 //y2=1.595
r217 (  57 75 ) resistor r=45.1352 //w=0.168 //l=0.173853 //layer=ply \
 //thickness=0.18 //x=23.05 //y=1.095 //x2=23.09 //y2=0.94
r218 (  57 58 ) resistor r=176.904 //w=0.094 //l=0.345 //layer=ply \
 //thickness=0.18 //x=23.05 //y=1.095 //x2=23.05 //y2=1.44
r219 (  54 78 ) resistor r=53.7854 //w=0.233 //l=0.332415 //layer=ply \
 //thickness=0.18 //x=22.8 //y=5.045 //x2=23.06 //y2=4.88
r220 (  53 61 ) resistor r=592.245 //w=0.094 //l=1.155 //layer=ply \
 //thickness=0.18 //x=23.24 //y=6.2 //x2=23.24 //y2=5.045
r221 (  52 54 ) resistor r=592.245 //w=0.094 //l=1.155 //layer=ply \
 //thickness=0.18 //x=22.8 //y=6.2 //x2=22.8 //y2=5.045
r222 (  51 66 ) resistor r=56.4043 //w=0.094 //l=0.11 //layer=ply \
 //thickness=0.18 //x=23.315 //y=1.595 //x2=23.425 //y2=1.595
r223 (  51 67 ) resistor r=56.4043 //w=0.094 //l=0.11 //layer=ply \
 //thickness=0.18 //x=23.315 //y=1.595 //x2=23.205 //y2=1.595
r224 (  46 48 ) resistor r=119.102 //w=0.187 //l=1.74 //layer=li \
 //thickness=0.1 //x=28.61 //y=5.25 //x2=28.61 //y2=3.51
r225 (  45 48 ) resistor r=108.15 //w=0.187 //l=1.58 //layer=li \
 //thickness=0.1 //x=28.61 //y=1.93 //x2=28.61 //y2=3.51
r226 (  43 45 ) resistor r=7.15173 //w=0.17 //l=0.120208 //layer=li \
 //thickness=0.1 //x=28.525 //y=1.845 //x2=28.61 //y2=1.93
r227 (  43 44 ) resistor r=21.5615 //w=0.187 //l=0.315 //layer=li \
 //thickness=0.1 //x=28.525 //y=1.845 //x2=28.21 //y2=1.845
r228 (  39 44 ) resistor r=7.15173 //w=0.17 //l=0.120208 //layer=li \
 //thickness=0.1 //x=28.125 //y=1.76 //x2=28.21 //y2=1.845
r229 (  39 81 ) resistor r=39.016 //w=0.187 //l=0.57 //layer=li \
 //thickness=0.1 //x=28.125 //y=1.76 //x2=28.125 //y2=1.19
r230 (  38 50 ) resistor r=5.4201 //w=0.17 //l=0.085 //layer=li \
 //thickness=0.1 //x=27.915 //y=5.335 //x2=27.83 //y2=5.335
r231 (  37 46 ) resistor r=7.15173 //w=0.17 //l=0.120208 //layer=li \
 //thickness=0.1 //x=28.525 //y=5.335 //x2=28.61 //y2=5.25
r232 (  37 38 ) resistor r=41.754 //w=0.187 //l=0.61 //layer=li \
 //thickness=0.1 //x=28.525 //y=5.335 //x2=27.915 //y2=5.335
r233 (  31 50 ) resistor r=1.40859 //w=0.34 //l=0.085 //layer=li \
 //thickness=0.1 //x=27.83 //y=5.42 //x2=27.83 //y2=5.335
r234 (  31 85 ) resistor r=33.1979 //w=0.187 //l=0.485 //layer=li \
 //thickness=0.1 //x=27.83 //y=5.42 //x2=27.83 //y2=5.905
r235 (  30 49 ) resistor r=5.4201 //w=0.17 //l=0.085 //layer=li \
 //thickness=0.1 //x=27.035 //y=5.335 //x2=26.95 //y2=5.335
r236 (  29 50 ) resistor r=5.4201 //w=0.17 //l=0.085 //layer=li \
 //thickness=0.1 //x=27.745 //y=5.335 //x2=27.83 //y2=5.335
r237 (  29 30 ) resistor r=48.5989 //w=0.187 //l=0.71 //layer=li \
 //thickness=0.1 //x=27.745 //y=5.335 //x2=27.035 //y2=5.335
r238 (  23 49 ) resistor r=1.40859 //w=0.34 //l=0.085 //layer=li \
 //thickness=0.1 //x=26.95 //y=5.42 //x2=26.95 //y2=5.335
r239 (  23 84 ) resistor r=33.1979 //w=0.187 //l=0.485 //layer=li \
 //thickness=0.1 //x=26.95 //y=5.42 //x2=26.95 //y2=5.905
r240 (  21 49 ) resistor r=5.4201 //w=0.17 //l=0.085 //layer=li \
 //thickness=0.1 //x=26.865 //y=5.335 //x2=26.95 //y2=5.335
r241 (  21 22 ) resistor r=48.5989 //w=0.187 //l=0.71 //layer=li \
 //thickness=0.1 //x=26.865 //y=5.335 //x2=26.155 //y2=5.335
r242 (  15 22 ) resistor r=7.15173 //w=0.17 //l=0.120208 //layer=li \
 //thickness=0.1 //x=26.07 //y=5.42 //x2=26.155 //y2=5.335
r243 (  15 83 ) resistor r=33.1979 //w=0.187 //l=0.485 //layer=li \
 //thickness=0.1 //x=26.07 //y=5.42 //x2=26.07 //y2=5.905
r244 (  13 78 ) resistor r=152 //w=0.17 //l=0.17 //layer=licon //count=1 \
 //x=23.06 //y=4.88 //x2=23.06 //y2=4.88
r245 (  11 13 ) resistor r=93.7754 //w=0.187 //l=1.37 //layer=li \
 //thickness=0.1 //x=23.06 //y=3.51 //x2=23.06 //y2=4.88
r246 (  8 72 ) resistor r=152 //w=0.17 //l=0.17 //layer=licon //count=1 \
 //x=23.06 //y=2.26 //x2=23.06 //y2=2.26
r247 (  8 11 ) resistor r=85.5615 //w=0.187 //l=1.25 //layer=li \
 //thickness=0.1 //x=23.06 //y=2.26 //x2=23.06 //y2=3.51
r248 (  6 48 ) resistor r=9.3 //w=0.17 //l=0.17 //layer=mcon //count=1 \
 //x=28.61 //y=3.51 //x2=28.61 //y2=3.51
r249 (  4 11 ) resistor r=9.3 //w=0.17 //l=0.17 //layer=mcon //count=1 \
 //x=23.06 //y=3.51 //x2=23.06 //y2=3.51
r250 (  2 4 ) resistor r=0.0717383 //w=0.224 //l=0.115 //layer=m1 \
 //thickness=0.36 //x=23.175 //y=3.51 //x2=23.06 //y2=3.51
r251 (  1 6 ) resistor r=0.0717383 //w=0.224 //l=0.115 //layer=m1 \
 //thickness=0.36 //x=28.495 //y=3.51 //x2=28.61 //y2=3.51
r252 (  1 2 ) resistor r=5.07634 //w=0.131 //l=5.32 //layer=m1 \
 //thickness=0.36 //x=28.495 //y=3.51 //x2=23.175 //y2=3.51
ends PM_TMRDFFSNRNQNX1\%noxref_8

subckt PM_TMRDFFSNRNQNX1\%noxref_9 ( 1 2 3 4 17 18 25 33 39 40 44 46 54 61 62 \
 63 64 65 66 67 68 69 70 71 72 73 75 81 82 83 84 88 89 90 91 92 94 100 101 102 \
 103 123 125 126 127 )
c253 ( 127 0 ) capacitor c=0.023087f //x=32.495 //y=5.2
c254 ( 126 0 ) capacitor c=0.023519f //x=31.615 //y=5.2
c255 ( 125 0 ) capacitor c=0.0224735f //x=30.735 //y=5.2
c256 ( 123 0 ) capacitor c=0.00853354f //x=32.745 //y=1.095
c257 ( 103 0 ) capacitor c=0.0547611f //x=40.355 //y=4.97
c258 ( 102 0 ) capacitor c=0.0294456f //x=40.645 //y=4.97
c259 ( 101 0 ) capacitor c=0.0347816f //x=40.31 //y=1.4
c260 ( 100 0 ) capacitor c=0.0187487f //x=40.31 //y=1.055
c261 ( 94 0 ) capacitor c=0.0137055f //x=40.155 //y=1.555
c262 ( 92 0 ) capacitor c=0.0149861f //x=40.155 //y=0.9
c263 ( 91 0 ) capacitor c=0.096037f //x=39.78 //y=2.095
c264 ( 90 0 ) capacitor c=0.0228993f //x=39.78 //y=1.71
c265 ( 89 0 ) capacitor c=0.0234352f //x=39.78 //y=1.4
c266 ( 88 0 ) capacitor c=0.0198724f //x=39.78 //y=1.055
c267 ( 84 0 ) capacitor c=0.0549166f //x=35.545 //y=4.97
c268 ( 83 0 ) capacitor c=0.0294456f //x=35.835 //y=4.97
c269 ( 82 0 ) capacitor c=0.0347816f //x=35.5 //y=1.4
c270 ( 81 0 ) capacitor c=0.0187487f //x=35.5 //y=1.055
c271 ( 75 0 ) capacitor c=0.0137055f //x=35.345 //y=1.555
c272 ( 73 0 ) capacitor c=0.0149861f //x=35.345 //y=0.9
c273 ( 72 0 ) capacitor c=0.096037f //x=34.97 //y=2.095
c274 ( 71 0 ) capacitor c=0.0228993f //x=34.97 //y=1.71
c275 ( 70 0 ) capacitor c=0.0234352f //x=34.97 //y=1.4
c276 ( 69 0 ) capacitor c=0.0198724f //x=34.97 //y=1.055
c277 ( 68 0 ) capacitor c=0.109949f //x=40.72 //y=6.2
c278 ( 67 0 ) capacitor c=0.158483f //x=40.28 //y=6.2
c279 ( 66 0 ) capacitor c=0.109949f //x=35.91 //y=6.2
c280 ( 65 0 ) capacitor c=0.158483f //x=35.47 //y=6.2
c281 ( 62 0 ) capacitor c=9.74268e-19 //x=32.64 //y=5.335
c282 ( 61 0 ) capacitor c=0.00191414f //x=31.76 //y=5.335
c283 ( 54 0 ) capacitor c=0.0914984f //x=40.08 //y=2.26
c284 ( 46 0 ) capacitor c=0.0942434f //x=35.27 //y=2.26
c285 ( 44 0 ) capacitor c=0.106133f //x=33.42 //y=2.77
c286 ( 40 0 ) capacitor c=0.00398962f //x=33.02 //y=1.845
c287 ( 39 0 ) capacitor c=0.0137288f //x=33.335 //y=1.845
c288 ( 33 0 ) capacitor c=0.0276208f //x=33.335 //y=5.335
c289 ( 25 0 ) capacitor c=0.0169868f //x=32.555 //y=5.335
c290 ( 18 0 ) capacitor c=0.00316998f //x=30.965 //y=5.335
c291 ( 17 0 ) capacitor c=0.014258f //x=31.675 //y=5.335
c292 ( 4 0 ) capacitor c=0.00401138f //x=35.385 //y=2.77
c293 ( 3 0 ) capacitor c=0.0706637f //x=39.965 //y=2.77
c294 ( 2 0 ) capacitor c=0.0120752f //x=33.535 //y=2.77
c295 ( 1 0 ) capacitor c=0.0233554f //x=35.155 //y=2.77
r296 (  102 104 ) resistor r=26.9307 //w=0.15 //l=0.106066 //layer=ply \
 //thickness=0.18 //x=40.645 //y=4.97 //x2=40.72 //y2=5.045
r297 (  102 103 ) resistor r=148.702 //w=0.094 //l=0.29 //layer=ply \
 //thickness=0.18 //x=40.645 //y=4.97 //x2=40.355 //y2=4.97
r298 (  101 122 ) resistor r=45.1352 //w=0.168 //l=0.173853 //layer=ply \
 //thickness=0.18 //x=40.31 //y=1.4 //x2=40.27 //y2=1.555
r299 (  100 121 ) resistor r=45.1352 //w=0.168 //l=0.173853 //layer=ply \
 //thickness=0.18 //x=40.31 //y=1.055 //x2=40.27 //y2=0.9
r300 (  100 101 ) resistor r=176.904 //w=0.094 //l=0.345 //layer=ply \
 //thickness=0.18 //x=40.31 //y=1.055 //x2=40.31 //y2=1.4
r301 (  97 103 ) resistor r=22.7971 //w=0.269 //l=0.106066 //layer=ply \
 //thickness=0.18 //x=40.28 //y=5.045 //x2=40.355 //y2=4.97
r302 (  97 120 ) resistor r=35.8364 //w=0.269 //l=0.270185 //layer=ply \
 //thickness=0.18 //x=40.28 //y=5.045 //x2=40.08 //y2=4.88
r303 (  95 116 ) resistor r=10.701 //w=0.21 //l=0.115 //layer=ply \
 //thickness=0.18 //x=39.935 //y=1.555 //x2=39.82 //y2=1.555
r304 (  94 122 ) resistor r=5.52526 //w=0.168 //l=0.115 //layer=ply \
 //thickness=0.18 //x=40.155 //y=1.555 //x2=40.27 //y2=1.555
r305 (  93 115 ) resistor r=5.52526 //w=0.168 //l=0.115 //layer=ply \
 //thickness=0.18 //x=39.935 //y=0.9 //x2=39.82 //y2=0.9
r306 (  92 121 ) resistor r=5.52526 //w=0.168 //l=0.115 //layer=ply \
 //thickness=0.18 //x=40.155 //y=0.9 //x2=40.27 //y2=0.9
r307 (  92 93 ) resistor r=112.809 //w=0.094 //l=0.22 //layer=ply \
 //thickness=0.18 //x=40.155 //y=0.9 //x2=39.935 //y2=0.9
r308 (  91 118 ) resistor r=58.7805 //w=0.246 //l=0.373497 //layer=ply \
 //thickness=0.18 //x=39.78 //y=2.095 //x2=40.08 //y2=2.26
r309 (  90 116 ) resistor r=39.5823 //w=0.21 //l=0.173853 //layer=ply \
 //thickness=0.18 //x=39.78 //y=1.71 //x2=39.82 //y2=1.555
r310 (  90 91 ) resistor r=197.415 //w=0.094 //l=0.385 //layer=ply \
 //thickness=0.18 //x=39.78 //y=1.71 //x2=39.78 //y2=2.095
r311 (  89 116 ) resistor r=39.5823 //w=0.21 //l=0.173853 //layer=ply \
 //thickness=0.18 //x=39.78 //y=1.4 //x2=39.82 //y2=1.555
r312 (  88 115 ) resistor r=45.1352 //w=0.168 //l=0.173853 //layer=ply \
 //thickness=0.18 //x=39.78 //y=1.055 //x2=39.82 //y2=0.9
r313 (  88 89 ) resistor r=176.904 //w=0.094 //l=0.345 //layer=ply \
 //thickness=0.18 //x=39.78 //y=1.055 //x2=39.78 //y2=1.4
r314 (  83 85 ) resistor r=26.9307 //w=0.15 //l=0.106066 //layer=ply \
 //thickness=0.18 //x=35.835 //y=4.97 //x2=35.91 //y2=5.045
r315 (  83 84 ) resistor r=148.702 //w=0.094 //l=0.29 //layer=ply \
 //thickness=0.18 //x=35.835 //y=4.97 //x2=35.545 //y2=4.97
r316 (  82 114 ) resistor r=45.1352 //w=0.168 //l=0.173853 //layer=ply \
 //thickness=0.18 //x=35.5 //y=1.4 //x2=35.46 //y2=1.555
r317 (  81 113 ) resistor r=45.1352 //w=0.168 //l=0.173853 //layer=ply \
 //thickness=0.18 //x=35.5 //y=1.055 //x2=35.46 //y2=0.9
r318 (  81 82 ) resistor r=176.904 //w=0.094 //l=0.345 //layer=ply \
 //thickness=0.18 //x=35.5 //y=1.055 //x2=35.5 //y2=1.4
r319 (  78 84 ) resistor r=22.7971 //w=0.269 //l=0.106066 //layer=ply \
 //thickness=0.18 //x=35.47 //y=5.045 //x2=35.545 //y2=4.97
r320 (  78 112 ) resistor r=35.8364 //w=0.269 //l=0.270185 //layer=ply \
 //thickness=0.18 //x=35.47 //y=5.045 //x2=35.27 //y2=4.88
r321 (  76 108 ) resistor r=10.701 //w=0.21 //l=0.115 //layer=ply \
 //thickness=0.18 //x=35.125 //y=1.555 //x2=35.01 //y2=1.555
r322 (  75 114 ) resistor r=5.52526 //w=0.168 //l=0.115 //layer=ply \
 //thickness=0.18 //x=35.345 //y=1.555 //x2=35.46 //y2=1.555
r323 (  74 107 ) resistor r=5.52526 //w=0.168 //l=0.115 //layer=ply \
 //thickness=0.18 //x=35.125 //y=0.9 //x2=35.01 //y2=0.9
r324 (  73 113 ) resistor r=5.52526 //w=0.168 //l=0.115 //layer=ply \
 //thickness=0.18 //x=35.345 //y=0.9 //x2=35.46 //y2=0.9
r325 (  73 74 ) resistor r=112.809 //w=0.094 //l=0.22 //layer=ply \
 //thickness=0.18 //x=35.345 //y=0.9 //x2=35.125 //y2=0.9
r326 (  72 110 ) resistor r=58.7805 //w=0.246 //l=0.373497 //layer=ply \
 //thickness=0.18 //x=34.97 //y=2.095 //x2=35.27 //y2=2.26
r327 (  71 108 ) resistor r=39.5823 //w=0.21 //l=0.173853 //layer=ply \
 //thickness=0.18 //x=34.97 //y=1.71 //x2=35.01 //y2=1.555
r328 (  71 72 ) resistor r=197.415 //w=0.094 //l=0.385 //layer=ply \
 //thickness=0.18 //x=34.97 //y=1.71 //x2=34.97 //y2=2.095
r329 (  70 108 ) resistor r=39.5823 //w=0.21 //l=0.173853 //layer=ply \
 //thickness=0.18 //x=34.97 //y=1.4 //x2=35.01 //y2=1.555
r330 (  69 107 ) resistor r=45.1352 //w=0.168 //l=0.173853 //layer=ply \
 //thickness=0.18 //x=34.97 //y=1.055 //x2=35.01 //y2=0.9
r331 (  69 70 ) resistor r=176.904 //w=0.094 //l=0.345 //layer=ply \
 //thickness=0.18 //x=34.97 //y=1.055 //x2=34.97 //y2=1.4
r332 (  68 104 ) resistor r=592.245 //w=0.094 //l=1.155 //layer=ply \
 //thickness=0.18 //x=40.72 //y=6.2 //x2=40.72 //y2=5.045
r333 (  67 97 ) resistor r=592.245 //w=0.094 //l=1.155 //layer=ply \
 //thickness=0.18 //x=40.28 //y=6.2 //x2=40.28 //y2=5.045
r334 (  66 85 ) resistor r=592.245 //w=0.094 //l=1.155 //layer=ply \
 //thickness=0.18 //x=35.91 //y=6.2 //x2=35.91 //y2=5.045
r335 (  65 78 ) resistor r=592.245 //w=0.094 //l=1.155 //layer=ply \
 //thickness=0.18 //x=35.47 //y=6.2 //x2=35.47 //y2=5.045
r336 (  64 94 ) resistor r=56.4043 //w=0.094 //l=0.11 //layer=ply \
 //thickness=0.18 //x=40.045 //y=1.555 //x2=40.155 //y2=1.555
r337 (  64 95 ) resistor r=56.4043 //w=0.094 //l=0.11 //layer=ply \
 //thickness=0.18 //x=40.045 //y=1.555 //x2=39.935 //y2=1.555
r338 (  63 75 ) resistor r=56.4043 //w=0.094 //l=0.11 //layer=ply \
 //thickness=0.18 //x=35.235 //y=1.555 //x2=35.345 //y2=1.555
r339 (  63 76 ) resistor r=56.4043 //w=0.094 //l=0.11 //layer=ply \
 //thickness=0.18 //x=35.235 //y=1.555 //x2=35.125 //y2=1.555
r340 (  59 120 ) resistor r=152 //w=0.17 //l=0.17 //layer=licon //count=1 \
 //x=40.08 //y=4.88 //x2=40.08 //y2=4.88
r341 (  57 59 ) resistor r=144.428 //w=0.187 //l=2.11 //layer=li \
 //thickness=0.1 //x=40.08 //y=2.77 //x2=40.08 //y2=4.88
r342 (  54 118 ) resistor r=152 //w=0.17 //l=0.17 //layer=licon //count=1 \
 //x=40.08 //y=2.26 //x2=40.08 //y2=2.26
r343 (  54 57 ) resistor r=34.9091 //w=0.187 //l=0.51 //layer=li \
 //thickness=0.1 //x=40.08 //y=2.26 //x2=40.08 //y2=2.77
r344 (  51 112 ) resistor r=152 //w=0.17 //l=0.17 //layer=licon //count=1 \
 //x=35.27 //y=4.88 //x2=35.27 //y2=4.88
r345 (  49 51 ) resistor r=144.428 //w=0.187 //l=2.11 //layer=li \
 //thickness=0.1 //x=35.27 //y=2.77 //x2=35.27 //y2=4.88
r346 (  46 110 ) resistor r=152 //w=0.17 //l=0.17 //layer=licon //count=1 \
 //x=35.27 //y=2.26 //x2=35.27 //y2=2.26
r347 (  46 49 ) resistor r=34.9091 //w=0.187 //l=0.51 //layer=li \
 //thickness=0.1 //x=35.27 //y=2.26 //x2=35.27 //y2=2.77
r348 (  42 44 ) resistor r=169.754 //w=0.187 //l=2.48 //layer=li \
 //thickness=0.1 //x=33.42 //y=5.25 //x2=33.42 //y2=2.77
r349 (  41 44 ) resistor r=57.4973 //w=0.187 //l=0.84 //layer=li \
 //thickness=0.1 //x=33.42 //y=1.93 //x2=33.42 //y2=2.77
r350 (  39 41 ) resistor r=7.15173 //w=0.17 //l=0.120208 //layer=li \
 //thickness=0.1 //x=33.335 //y=1.845 //x2=33.42 //y2=1.93
r351 (  39 40 ) resistor r=21.5615 //w=0.187 //l=0.315 //layer=li \
 //thickness=0.1 //x=33.335 //y=1.845 //x2=33.02 //y2=1.845
r352 (  35 40 ) resistor r=7.15173 //w=0.17 //l=0.120208 //layer=li \
 //thickness=0.1 //x=32.935 //y=1.76 //x2=33.02 //y2=1.845
r353 (  35 123 ) resistor r=39.016 //w=0.187 //l=0.57 //layer=li \
 //thickness=0.1 //x=32.935 //y=1.76 //x2=32.935 //y2=1.19
r354 (  34 62 ) resistor r=5.4201 //w=0.17 //l=0.085 //layer=li \
 //thickness=0.1 //x=32.725 //y=5.335 //x2=32.64 //y2=5.335
r355 (  33 42 ) resistor r=7.15173 //w=0.17 //l=0.120208 //layer=li \
 //thickness=0.1 //x=33.335 //y=5.335 //x2=33.42 //y2=5.25
r356 (  33 34 ) resistor r=41.754 //w=0.187 //l=0.61 //layer=li \
 //thickness=0.1 //x=33.335 //y=5.335 //x2=32.725 //y2=5.335
r357 (  27 62 ) resistor r=1.40859 //w=0.34 //l=0.085 //layer=li \
 //thickness=0.1 //x=32.64 //y=5.42 //x2=32.64 //y2=5.335
r358 (  27 127 ) resistor r=33.1979 //w=0.187 //l=0.485 //layer=li \
 //thickness=0.1 //x=32.64 //y=5.42 //x2=32.64 //y2=5.905
r359 (  26 61 ) resistor r=5.4201 //w=0.17 //l=0.085 //layer=li \
 //thickness=0.1 //x=31.845 //y=5.335 //x2=31.76 //y2=5.335
r360 (  25 62 ) resistor r=5.4201 //w=0.17 //l=0.085 //layer=li \
 //thickness=0.1 //x=32.555 //y=5.335 //x2=32.64 //y2=5.335
r361 (  25 26 ) resistor r=48.5989 //w=0.187 //l=0.71 //layer=li \
 //thickness=0.1 //x=32.555 //y=5.335 //x2=31.845 //y2=5.335
r362 (  19 61 ) resistor r=1.40859 //w=0.34 //l=0.085 //layer=li \
 //thickness=0.1 //x=31.76 //y=5.42 //x2=31.76 //y2=5.335
r363 (  19 126 ) resistor r=33.1979 //w=0.187 //l=0.485 //layer=li \
 //thickness=0.1 //x=31.76 //y=5.42 //x2=31.76 //y2=5.905
r364 (  17 61 ) resistor r=5.4201 //w=0.17 //l=0.085 //layer=li \
 //thickness=0.1 //x=31.675 //y=5.335 //x2=31.76 //y2=5.335
r365 (  17 18 ) resistor r=48.5989 //w=0.187 //l=0.71 //layer=li \
 //thickness=0.1 //x=31.675 //y=5.335 //x2=30.965 //y2=5.335
r366 (  11 18 ) resistor r=7.15173 //w=0.17 //l=0.120208 //layer=li \
 //thickness=0.1 //x=30.88 //y=5.42 //x2=30.965 //y2=5.335
r367 (  11 125 ) resistor r=33.1979 //w=0.187 //l=0.485 //layer=li \
 //thickness=0.1 //x=30.88 //y=5.42 //x2=30.88 //y2=5.905
r368 (  10 57 ) resistor r=9.3 //w=0.17 //l=0.17 //layer=mcon //count=1 \
 //x=40.08 //y=2.77 //x2=40.08 //y2=2.77
r369 (  8 49 ) resistor r=9.3 //w=0.17 //l=0.17 //layer=mcon //count=1 \
 //x=35.27 //y=2.77 //x2=35.27 //y2=2.77
r370 (  6 44 ) resistor r=9.3 //w=0.17 //l=0.17 //layer=mcon //count=1 \
 //x=33.42 //y=2.77 //x2=33.42 //y2=2.77
r371 (  4 8 ) resistor r=0.0880901 //w=0.191 //l=0.115 //layer=m1 \
 //thickness=0.36 //x=35.385 //y=2.77 //x2=35.27 //y2=2.77
r372 (  3 10 ) resistor r=0.0717383 //w=0.224 //l=0.115 //layer=m1 \
 //thickness=0.36 //x=39.965 //y=2.77 //x2=40.08 //y2=2.77
r373 (  3 4 ) resistor r=4.37023 //w=0.131 //l=4.58 //layer=m1 \
 //thickness=0.36 //x=39.965 //y=2.77 //x2=35.385 //y2=2.77
r374 (  2 6 ) resistor r=0.0717383 //w=0.224 //l=0.115 //layer=m1 \
 //thickness=0.36 //x=33.535 //y=2.77 //x2=33.42 //y2=2.77
r375 (  1 8 ) resistor r=0.0880901 //w=0.191 //l=0.115 //layer=m1 \
 //thickness=0.36 //x=35.155 //y=2.77 //x2=35.27 //y2=2.77
r376 (  1 2 ) resistor r=1.5458 //w=0.131 //l=1.62 //layer=m1 //thickness=0.36 \
 //x=35.155 //y=2.77 //x2=33.535 //y2=2.77
ends PM_TMRDFFSNRNQNX1\%noxref_9

subckt PM_TMRDFFSNRNQNX1\%noxref_10 ( 1 2 13 14 21 29 35 36 40 42 49 50 51 52 \
 53 54 55 56 57 58 60 66 67 68 69 81 83 84 85 )
c169 ( 85 0 ) capacitor c=0.023087f //x=42.115 //y=5.2
c170 ( 84 0 ) capacitor c=0.023519f //x=41.235 //y=5.2
c171 ( 83 0 ) capacitor c=0.0224735f //x=40.355 //y=5.2
c172 ( 81 0 ) capacitor c=0.00853354f //x=42.365 //y=1.095
c173 ( 69 0 ) capacitor c=0.0549166f //x=45.165 //y=4.97
c174 ( 68 0 ) capacitor c=0.0294456f //x=45.455 //y=4.97
c175 ( 67 0 ) capacitor c=0.0347816f //x=45.12 //y=1.4
c176 ( 66 0 ) capacitor c=0.0187487f //x=45.12 //y=1.055
c177 ( 60 0 ) capacitor c=0.0137055f //x=44.965 //y=1.555
c178 ( 58 0 ) capacitor c=0.0149861f //x=44.965 //y=0.9
c179 ( 57 0 ) capacitor c=0.096037f //x=44.59 //y=2.095
c180 ( 56 0 ) capacitor c=0.0228993f //x=44.59 //y=1.71
c181 ( 55 0 ) capacitor c=0.0234352f //x=44.59 //y=1.4
c182 ( 54 0 ) capacitor c=0.0198724f //x=44.59 //y=1.055
c183 ( 53 0 ) capacitor c=0.109949f //x=45.53 //y=6.2
c184 ( 52 0 ) capacitor c=0.158483f //x=45.09 //y=6.2
c185 ( 50 0 ) capacitor c=9.74268e-19 //x=42.26 //y=5.335
c186 ( 49 0 ) capacitor c=0.00191414f //x=41.38 //y=5.335
c187 ( 42 0 ) capacitor c=0.0911502f //x=44.89 //y=2.26
c188 ( 40 0 ) capacitor c=0.103494f //x=43.04 //y=2.77
c189 ( 36 0 ) capacitor c=0.00398962f //x=42.64 //y=1.845
c190 ( 35 0 ) capacitor c=0.0137288f //x=42.955 //y=1.845
c191 ( 29 0 ) capacitor c=0.0276208f //x=42.955 //y=5.335
c192 ( 21 0 ) capacitor c=0.0169868f //x=42.175 //y=5.335
c193 ( 14 0 ) capacitor c=0.00316998f //x=40.585 //y=5.335
c194 ( 13 0 ) capacitor c=0.014258f //x=41.295 //y=5.335
c195 ( 2 0 ) capacitor c=0.00808366f //x=43.155 //y=2.77
c196 ( 1 0 ) capacitor c=0.0351856f //x=44.775 //y=2.77
r197 (  68 70 ) resistor r=26.9307 //w=0.15 //l=0.106066 //layer=ply \
 //thickness=0.18 //x=45.455 //y=4.97 //x2=45.53 //y2=5.045
r198 (  68 69 ) resistor r=148.702 //w=0.094 //l=0.29 //layer=ply \
 //thickness=0.18 //x=45.455 //y=4.97 //x2=45.165 //y2=4.97
r199 (  67 80 ) resistor r=45.1352 //w=0.168 //l=0.173853 //layer=ply \
 //thickness=0.18 //x=45.12 //y=1.4 //x2=45.08 //y2=1.555
r200 (  66 79 ) resistor r=45.1352 //w=0.168 //l=0.173853 //layer=ply \
 //thickness=0.18 //x=45.12 //y=1.055 //x2=45.08 //y2=0.9
r201 (  66 67 ) resistor r=176.904 //w=0.094 //l=0.345 //layer=ply \
 //thickness=0.18 //x=45.12 //y=1.055 //x2=45.12 //y2=1.4
r202 (  63 69 ) resistor r=22.7971 //w=0.269 //l=0.106066 //layer=ply \
 //thickness=0.18 //x=45.09 //y=5.045 //x2=45.165 //y2=4.97
r203 (  63 78 ) resistor r=35.8364 //w=0.269 //l=0.270185 //layer=ply \
 //thickness=0.18 //x=45.09 //y=5.045 //x2=44.89 //y2=4.88
r204 (  61 74 ) resistor r=10.701 //w=0.21 //l=0.115 //layer=ply \
 //thickness=0.18 //x=44.745 //y=1.555 //x2=44.63 //y2=1.555
r205 (  60 80 ) resistor r=5.52526 //w=0.168 //l=0.115 //layer=ply \
 //thickness=0.18 //x=44.965 //y=1.555 //x2=45.08 //y2=1.555
r206 (  59 73 ) resistor r=5.52526 //w=0.168 //l=0.115 //layer=ply \
 //thickness=0.18 //x=44.745 //y=0.9 //x2=44.63 //y2=0.9
r207 (  58 79 ) resistor r=5.52526 //w=0.168 //l=0.115 //layer=ply \
 //thickness=0.18 //x=44.965 //y=0.9 //x2=45.08 //y2=0.9
r208 (  58 59 ) resistor r=112.809 //w=0.094 //l=0.22 //layer=ply \
 //thickness=0.18 //x=44.965 //y=0.9 //x2=44.745 //y2=0.9
r209 (  57 76 ) resistor r=58.7805 //w=0.246 //l=0.373497 //layer=ply \
 //thickness=0.18 //x=44.59 //y=2.095 //x2=44.89 //y2=2.26
r210 (  56 74 ) resistor r=39.5823 //w=0.21 //l=0.173853 //layer=ply \
 //thickness=0.18 //x=44.59 //y=1.71 //x2=44.63 //y2=1.555
r211 (  56 57 ) resistor r=197.415 //w=0.094 //l=0.385 //layer=ply \
 //thickness=0.18 //x=44.59 //y=1.71 //x2=44.59 //y2=2.095
r212 (  55 74 ) resistor r=39.5823 //w=0.21 //l=0.173853 //layer=ply \
 //thickness=0.18 //x=44.59 //y=1.4 //x2=44.63 //y2=1.555
r213 (  54 73 ) resistor r=45.1352 //w=0.168 //l=0.173853 //layer=ply \
 //thickness=0.18 //x=44.59 //y=1.055 //x2=44.63 //y2=0.9
r214 (  54 55 ) resistor r=176.904 //w=0.094 //l=0.345 //layer=ply \
 //thickness=0.18 //x=44.59 //y=1.055 //x2=44.59 //y2=1.4
r215 (  53 70 ) resistor r=592.245 //w=0.094 //l=1.155 //layer=ply \
 //thickness=0.18 //x=45.53 //y=6.2 //x2=45.53 //y2=5.045
r216 (  52 63 ) resistor r=592.245 //w=0.094 //l=1.155 //layer=ply \
 //thickness=0.18 //x=45.09 //y=6.2 //x2=45.09 //y2=5.045
r217 (  51 60 ) resistor r=56.4043 //w=0.094 //l=0.11 //layer=ply \
 //thickness=0.18 //x=44.855 //y=1.555 //x2=44.965 //y2=1.555
r218 (  51 61 ) resistor r=56.4043 //w=0.094 //l=0.11 //layer=ply \
 //thickness=0.18 //x=44.855 //y=1.555 //x2=44.745 //y2=1.555
r219 (  47 78 ) resistor r=152 //w=0.17 //l=0.17 //layer=licon //count=1 \
 //x=44.89 //y=4.88 //x2=44.89 //y2=4.88
r220 (  45 47 ) resistor r=144.428 //w=0.187 //l=2.11 //layer=li \
 //thickness=0.1 //x=44.89 //y=2.77 //x2=44.89 //y2=4.88
r221 (  42 76 ) resistor r=152 //w=0.17 //l=0.17 //layer=licon //count=1 \
 //x=44.89 //y=2.26 //x2=44.89 //y2=2.26
r222 (  42 45 ) resistor r=34.9091 //w=0.187 //l=0.51 //layer=li \
 //thickness=0.1 //x=44.89 //y=2.26 //x2=44.89 //y2=2.77
r223 (  38 40 ) resistor r=169.754 //w=0.187 //l=2.48 //layer=li \
 //thickness=0.1 //x=43.04 //y=5.25 //x2=43.04 //y2=2.77
r224 (  37 40 ) resistor r=57.4973 //w=0.187 //l=0.84 //layer=li \
 //thickness=0.1 //x=43.04 //y=1.93 //x2=43.04 //y2=2.77
r225 (  35 37 ) resistor r=7.15173 //w=0.17 //l=0.120208 //layer=li \
 //thickness=0.1 //x=42.955 //y=1.845 //x2=43.04 //y2=1.93
r226 (  35 36 ) resistor r=21.5615 //w=0.187 //l=0.315 //layer=li \
 //thickness=0.1 //x=42.955 //y=1.845 //x2=42.64 //y2=1.845
r227 (  31 36 ) resistor r=7.15173 //w=0.17 //l=0.120208 //layer=li \
 //thickness=0.1 //x=42.555 //y=1.76 //x2=42.64 //y2=1.845
r228 (  31 81 ) resistor r=39.016 //w=0.187 //l=0.57 //layer=li \
 //thickness=0.1 //x=42.555 //y=1.76 //x2=42.555 //y2=1.19
r229 (  30 50 ) resistor r=5.4201 //w=0.17 //l=0.085 //layer=li \
 //thickness=0.1 //x=42.345 //y=5.335 //x2=42.26 //y2=5.335
r230 (  29 38 ) resistor r=7.15173 //w=0.17 //l=0.120208 //layer=li \
 //thickness=0.1 //x=42.955 //y=5.335 //x2=43.04 //y2=5.25
r231 (  29 30 ) resistor r=41.754 //w=0.187 //l=0.61 //layer=li \
 //thickness=0.1 //x=42.955 //y=5.335 //x2=42.345 //y2=5.335
r232 (  23 50 ) resistor r=1.40859 //w=0.34 //l=0.085 //layer=li \
 //thickness=0.1 //x=42.26 //y=5.42 //x2=42.26 //y2=5.335
r233 (  23 85 ) resistor r=33.1979 //w=0.187 //l=0.485 //layer=li \
 //thickness=0.1 //x=42.26 //y=5.42 //x2=42.26 //y2=5.905
r234 (  22 49 ) resistor r=5.4201 //w=0.17 //l=0.085 //layer=li \
 //thickness=0.1 //x=41.465 //y=5.335 //x2=41.38 //y2=5.335
r235 (  21 50 ) resistor r=5.4201 //w=0.17 //l=0.085 //layer=li \
 //thickness=0.1 //x=42.175 //y=5.335 //x2=42.26 //y2=5.335
r236 (  21 22 ) resistor r=48.5989 //w=0.187 //l=0.71 //layer=li \
 //thickness=0.1 //x=42.175 //y=5.335 //x2=41.465 //y2=5.335
r237 (  15 49 ) resistor r=1.40859 //w=0.34 //l=0.085 //layer=li \
 //thickness=0.1 //x=41.38 //y=5.42 //x2=41.38 //y2=5.335
r238 (  15 84 ) resistor r=33.1979 //w=0.187 //l=0.485 //layer=li \
 //thickness=0.1 //x=41.38 //y=5.42 //x2=41.38 //y2=5.905
r239 (  13 49 ) resistor r=5.4201 //w=0.17 //l=0.085 //layer=li \
 //thickness=0.1 //x=41.295 //y=5.335 //x2=41.38 //y2=5.335
r240 (  13 14 ) resistor r=48.5989 //w=0.187 //l=0.71 //layer=li \
 //thickness=0.1 //x=41.295 //y=5.335 //x2=40.585 //y2=5.335
r241 (  7 14 ) resistor r=7.15173 //w=0.17 //l=0.120208 //layer=li \
 //thickness=0.1 //x=40.5 //y=5.42 //x2=40.585 //y2=5.335
r242 (  7 83 ) resistor r=33.1979 //w=0.187 //l=0.485 //layer=li \
 //thickness=0.1 //x=40.5 //y=5.42 //x2=40.5 //y2=5.905
r243 (  6 45 ) resistor r=9.3 //w=0.17 //l=0.17 //layer=mcon //count=1 \
 //x=44.89 //y=2.77 //x2=44.89 //y2=2.77
r244 (  4 40 ) resistor r=9.3 //w=0.17 //l=0.17 //layer=mcon //count=1 \
 //x=43.04 //y=2.77 //x2=43.04 //y2=2.77
r245 (  2 4 ) resistor r=0.0717383 //w=0.224 //l=0.115 //layer=m1 \
 //thickness=0.36 //x=43.155 //y=2.77 //x2=43.04 //y2=2.77
r246 (  1 6 ) resistor r=0.0717383 //w=0.224 //l=0.115 //layer=m1 \
 //thickness=0.36 //x=44.775 //y=2.77 //x2=44.89 //y2=2.77
r247 (  1 2 ) resistor r=1.5458 //w=0.131 //l=1.62 //layer=m1 //thickness=0.36 \
 //x=44.775 //y=2.77 //x2=43.155 //y2=2.77
ends PM_TMRDFFSNRNQNX1\%noxref_10

subckt PM_TMRDFFSNRNQNX1\%noxref_11 ( 1 2 3 4 12 25 26 33 41 47 48 52 54 61 62 \
 63 64 65 66 67 68 72 73 74 79 81 84 85 86 87 88 89 90 92 98 99 100 101 106 \
 107 112 123 125 126 127 )
c281 ( 127 0 ) capacitor c=0.023087f //x=37.305 //y=5.2
c282 ( 126 0 ) capacitor c=0.023519f //x=36.425 //y=5.2
c283 ( 125 0 ) capacitor c=0.0224735f //x=35.545 //y=5.2
c284 ( 123 0 ) capacitor c=0.00853354f //x=37.555 //y=1.095
c285 ( 112 0 ) capacitor c=0.0588394f //x=32.68 //y=4.88
c286 ( 107 0 ) capacitor c=0.0273931f //x=32.68 //y=2.095
c287 ( 106 0 ) capacitor c=0.0456313f //x=32.68 //y=2.26
c288 ( 101 0 ) capacitor c=0.0547611f //x=49.975 //y=4.97
c289 ( 100 0 ) capacitor c=0.0294456f //x=50.265 //y=4.97
c290 ( 99 0 ) capacitor c=0.0347816f //x=49.93 //y=1.4
c291 ( 98 0 ) capacitor c=0.0187487f //x=49.93 //y=1.055
c292 ( 92 0 ) capacitor c=0.0137055f //x=49.775 //y=1.555
c293 ( 90 0 ) capacitor c=0.0149861f //x=49.775 //y=0.9
c294 ( 89 0 ) capacitor c=0.096037f //x=49.4 //y=2.095
c295 ( 88 0 ) capacitor c=0.0228993f //x=49.4 //y=1.71
c296 ( 87 0 ) capacitor c=0.0234352f //x=49.4 //y=1.4
c297 ( 86 0 ) capacitor c=0.0198724f //x=49.4 //y=1.055
c298 ( 85 0 ) capacitor c=0.0432517f //x=33.2 //y=1.44
c299 ( 84 0 ) capacitor c=0.0200379f //x=33.2 //y=1.095
c300 ( 81 0 ) capacitor c=0.0148873f //x=33.045 //y=1.595
c301 ( 79 0 ) capacitor c=0.0157803f //x=33.045 //y=0.94
c302 ( 74 0 ) capacitor c=0.0218028f //x=32.67 //y=1.75
c303 ( 73 0 ) capacitor c=0.0207459f //x=32.67 //y=1.44
c304 ( 72 0 ) capacitor c=0.0194308f //x=32.67 //y=1.095
c305 ( 68 0 ) capacitor c=0.109949f //x=50.34 //y=6.2
c306 ( 67 0 ) capacitor c=0.158483f //x=49.9 //y=6.2
c307 ( 66 0 ) capacitor c=0.158754f //x=32.86 //y=6.2
c308 ( 65 0 ) capacitor c=0.109949f //x=32.42 //y=6.2
c309 ( 62 0 ) capacitor c=9.74268e-19 //x=37.45 //y=5.335
c310 ( 61 0 ) capacitor c=0.00191414f //x=36.57 //y=5.335
c311 ( 54 0 ) capacitor c=0.0937531f //x=49.7 //y=2.26
c312 ( 52 0 ) capacitor c=0.103032f //x=38.23 //y=3.51
c313 ( 48 0 ) capacitor c=0.00398962f //x=37.83 //y=1.845
c314 ( 47 0 ) capacitor c=0.0137288f //x=38.145 //y=1.845
c315 ( 41 0 ) capacitor c=0.0276208f //x=38.145 //y=5.335
c316 ( 33 0 ) capacitor c=0.0169868f //x=37.365 //y=5.335
c317 ( 26 0 ) capacitor c=0.00316998f //x=35.775 //y=5.335
c318 ( 25 0 ) capacitor c=0.014258f //x=36.485 //y=5.335
c319 ( 12 0 ) capacitor c=0.0816952f //x=32.68 //y=2.26
c320 ( 4 0 ) capacitor c=0.00551333f //x=38.345 //y=3.51
c321 ( 3 0 ) capacitor c=0.173933f //x=49.585 //y=3.51
c322 ( 2 0 ) capacitor c=0.0108616f //x=32.795 //y=3.51
c323 ( 1 0 ) capacitor c=0.0905825f //x=38.115 //y=3.51
r324 (  106 107 ) resistor r=52.7279 //w=0.214 //l=0.165 //layer=ply \
 //thickness=0.18 //x=32.68 //y=2.26 //x2=32.68 //y2=2.095
r325 (  100 102 ) resistor r=26.9307 //w=0.15 //l=0.106066 //layer=ply \
 //thickness=0.18 //x=50.265 //y=4.97 //x2=50.34 //y2=5.045
r326 (  100 101 ) resistor r=148.702 //w=0.094 //l=0.29 //layer=ply \
 //thickness=0.18 //x=50.265 //y=4.97 //x2=49.975 //y2=4.97
r327 (  99 122 ) resistor r=45.1352 //w=0.168 //l=0.173853 //layer=ply \
 //thickness=0.18 //x=49.93 //y=1.4 //x2=49.89 //y2=1.555
r328 (  98 121 ) resistor r=45.1352 //w=0.168 //l=0.173853 //layer=ply \
 //thickness=0.18 //x=49.93 //y=1.055 //x2=49.89 //y2=0.9
r329 (  98 99 ) resistor r=176.904 //w=0.094 //l=0.345 //layer=ply \
 //thickness=0.18 //x=49.93 //y=1.055 //x2=49.93 //y2=1.4
r330 (  95 101 ) resistor r=22.7971 //w=0.269 //l=0.106066 //layer=ply \
 //thickness=0.18 //x=49.9 //y=5.045 //x2=49.975 //y2=4.97
r331 (  95 120 ) resistor r=35.8364 //w=0.269 //l=0.270185 //layer=ply \
 //thickness=0.18 //x=49.9 //y=5.045 //x2=49.7 //y2=4.88
r332 (  93 116 ) resistor r=10.701 //w=0.21 //l=0.115 //layer=ply \
 //thickness=0.18 //x=49.555 //y=1.555 //x2=49.44 //y2=1.555
r333 (  92 122 ) resistor r=5.52526 //w=0.168 //l=0.115 //layer=ply \
 //thickness=0.18 //x=49.775 //y=1.555 //x2=49.89 //y2=1.555
r334 (  91 115 ) resistor r=5.52526 //w=0.168 //l=0.115 //layer=ply \
 //thickness=0.18 //x=49.555 //y=0.9 //x2=49.44 //y2=0.9
r335 (  90 121 ) resistor r=5.52526 //w=0.168 //l=0.115 //layer=ply \
 //thickness=0.18 //x=49.775 //y=0.9 //x2=49.89 //y2=0.9
r336 (  90 91 ) resistor r=112.809 //w=0.094 //l=0.22 //layer=ply \
 //thickness=0.18 //x=49.775 //y=0.9 //x2=49.555 //y2=0.9
r337 (  89 118 ) resistor r=58.7805 //w=0.246 //l=0.373497 //layer=ply \
 //thickness=0.18 //x=49.4 //y=2.095 //x2=49.7 //y2=2.26
r338 (  88 116 ) resistor r=39.5823 //w=0.21 //l=0.173853 //layer=ply \
 //thickness=0.18 //x=49.4 //y=1.71 //x2=49.44 //y2=1.555
r339 (  88 89 ) resistor r=197.415 //w=0.094 //l=0.385 //layer=ply \
 //thickness=0.18 //x=49.4 //y=1.71 //x2=49.4 //y2=2.095
r340 (  87 116 ) resistor r=39.5823 //w=0.21 //l=0.173853 //layer=ply \
 //thickness=0.18 //x=49.4 //y=1.4 //x2=49.44 //y2=1.555
r341 (  86 115 ) resistor r=45.1352 //w=0.168 //l=0.173853 //layer=ply \
 //thickness=0.18 //x=49.4 //y=1.055 //x2=49.44 //y2=0.9
r342 (  86 87 ) resistor r=176.904 //w=0.094 //l=0.345 //layer=ply \
 //thickness=0.18 //x=49.4 //y=1.055 //x2=49.4 //y2=1.4
r343 (  85 114 ) resistor r=45.1352 //w=0.168 //l=0.173853 //layer=ply \
 //thickness=0.18 //x=33.2 //y=1.44 //x2=33.16 //y2=1.595
r344 (  84 113 ) resistor r=45.1352 //w=0.168 //l=0.173853 //layer=ply \
 //thickness=0.18 //x=33.2 //y=1.095 //x2=33.16 //y2=0.94
r345 (  84 85 ) resistor r=176.904 //w=0.094 //l=0.345 //layer=ply \
 //thickness=0.18 //x=33.2 //y=1.095 //x2=33.2 //y2=1.44
r346 (  82 110 ) resistor r=10.701 //w=0.21 //l=0.115 //layer=ply \
 //thickness=0.18 //x=32.825 //y=1.595 //x2=32.71 //y2=1.595
r347 (  81 114 ) resistor r=5.52526 //w=0.168 //l=0.115 //layer=ply \
 //thickness=0.18 //x=33.045 //y=1.595 //x2=33.16 //y2=1.595
r348 (  80 109 ) resistor r=5.52526 //w=0.168 //l=0.115 //layer=ply \
 //thickness=0.18 //x=32.825 //y=0.94 //x2=32.71 //y2=0.94
r349 (  79 113 ) resistor r=5.52526 //w=0.168 //l=0.115 //layer=ply \
 //thickness=0.18 //x=33.045 //y=0.94 //x2=33.16 //y2=0.94
r350 (  79 80 ) resistor r=112.809 //w=0.094 //l=0.22 //layer=ply \
 //thickness=0.18 //x=33.045 //y=0.94 //x2=32.825 //y2=0.94
r351 (  76 112 ) resistor r=37.236 //w=0.233 //l=0.249199 //layer=ply \
 //thickness=0.18 //x=32.86 //y=5.045 //x2=32.68 //y2=4.88
r352 (  74 110 ) resistor r=39.5823 //w=0.21 //l=0.173853 //layer=ply \
 //thickness=0.18 //x=32.67 //y=1.75 //x2=32.71 //y2=1.595
r353 (  74 107 ) resistor r=176.904 //w=0.094 //l=0.345 //layer=ply \
 //thickness=0.18 //x=32.67 //y=1.75 //x2=32.67 //y2=2.095
r354 (  73 110 ) resistor r=39.5823 //w=0.21 //l=0.173853 //layer=ply \
 //thickness=0.18 //x=32.67 //y=1.44 //x2=32.71 //y2=1.595
r355 (  72 109 ) resistor r=45.1352 //w=0.168 //l=0.173853 //layer=ply \
 //thickness=0.18 //x=32.67 //y=1.095 //x2=32.71 //y2=0.94
r356 (  72 73 ) resistor r=176.904 //w=0.094 //l=0.345 //layer=ply \
 //thickness=0.18 //x=32.67 //y=1.095 //x2=32.67 //y2=1.44
r357 (  69 112 ) resistor r=53.7854 //w=0.233 //l=0.332415 //layer=ply \
 //thickness=0.18 //x=32.42 //y=5.045 //x2=32.68 //y2=4.88
r358 (  68 102 ) resistor r=592.245 //w=0.094 //l=1.155 //layer=ply \
 //thickness=0.18 //x=50.34 //y=6.2 //x2=50.34 //y2=5.045
r359 (  67 95 ) resistor r=592.245 //w=0.094 //l=1.155 //layer=ply \
 //thickness=0.18 //x=49.9 //y=6.2 //x2=49.9 //y2=5.045
r360 (  66 76 ) resistor r=592.245 //w=0.094 //l=1.155 //layer=ply \
 //thickness=0.18 //x=32.86 //y=6.2 //x2=32.86 //y2=5.045
r361 (  65 69 ) resistor r=592.245 //w=0.094 //l=1.155 //layer=ply \
 //thickness=0.18 //x=32.42 //y=6.2 //x2=32.42 //y2=5.045
r362 (  64 92 ) resistor r=56.4043 //w=0.094 //l=0.11 //layer=ply \
 //thickness=0.18 //x=49.665 //y=1.555 //x2=49.775 //y2=1.555
r363 (  64 93 ) resistor r=56.4043 //w=0.094 //l=0.11 //layer=ply \
 //thickness=0.18 //x=49.665 //y=1.555 //x2=49.555 //y2=1.555
r364 (  63 81 ) resistor r=56.4043 //w=0.094 //l=0.11 //layer=ply \
 //thickness=0.18 //x=32.935 //y=1.595 //x2=33.045 //y2=1.595
r365 (  63 82 ) resistor r=56.4043 //w=0.094 //l=0.11 //layer=ply \
 //thickness=0.18 //x=32.935 //y=1.595 //x2=32.825 //y2=1.595
r366 (  59 120 ) resistor r=152 //w=0.17 //l=0.17 //layer=licon //count=1 \
 //x=49.7 //y=4.88 //x2=49.7 //y2=4.88
r367 (  57 59 ) resistor r=93.7754 //w=0.187 //l=1.37 //layer=li \
 //thickness=0.1 //x=49.7 //y=3.51 //x2=49.7 //y2=4.88
r368 (  54 118 ) resistor r=152 //w=0.17 //l=0.17 //layer=licon //count=1 \
 //x=49.7 //y=2.26 //x2=49.7 //y2=2.26
r369 (  54 57 ) resistor r=85.5615 //w=0.187 //l=1.25 //layer=li \
 //thickness=0.1 //x=49.7 //y=2.26 //x2=49.7 //y2=3.51
r370 (  50 52 ) resistor r=119.102 //w=0.187 //l=1.74 //layer=li \
 //thickness=0.1 //x=38.23 //y=5.25 //x2=38.23 //y2=3.51
r371 (  49 52 ) resistor r=108.15 //w=0.187 //l=1.58 //layer=li \
 //thickness=0.1 //x=38.23 //y=1.93 //x2=38.23 //y2=3.51
r372 (  47 49 ) resistor r=7.15173 //w=0.17 //l=0.120208 //layer=li \
 //thickness=0.1 //x=38.145 //y=1.845 //x2=38.23 //y2=1.93
r373 (  47 48 ) resistor r=21.5615 //w=0.187 //l=0.315 //layer=li \
 //thickness=0.1 //x=38.145 //y=1.845 //x2=37.83 //y2=1.845
r374 (  43 48 ) resistor r=7.15173 //w=0.17 //l=0.120208 //layer=li \
 //thickness=0.1 //x=37.745 //y=1.76 //x2=37.83 //y2=1.845
r375 (  43 123 ) resistor r=39.016 //w=0.187 //l=0.57 //layer=li \
 //thickness=0.1 //x=37.745 //y=1.76 //x2=37.745 //y2=1.19
r376 (  42 62 ) resistor r=5.4201 //w=0.17 //l=0.085 //layer=li \
 //thickness=0.1 //x=37.535 //y=5.335 //x2=37.45 //y2=5.335
r377 (  41 50 ) resistor r=7.15173 //w=0.17 //l=0.120208 //layer=li \
 //thickness=0.1 //x=38.145 //y=5.335 //x2=38.23 //y2=5.25
r378 (  41 42 ) resistor r=41.754 //w=0.187 //l=0.61 //layer=li \
 //thickness=0.1 //x=38.145 //y=5.335 //x2=37.535 //y2=5.335
r379 (  35 62 ) resistor r=1.40859 //w=0.34 //l=0.085 //layer=li \
 //thickness=0.1 //x=37.45 //y=5.42 //x2=37.45 //y2=5.335
r380 (  35 127 ) resistor r=33.1979 //w=0.187 //l=0.485 //layer=li \
 //thickness=0.1 //x=37.45 //y=5.42 //x2=37.45 //y2=5.905
r381 (  34 61 ) resistor r=5.4201 //w=0.17 //l=0.085 //layer=li \
 //thickness=0.1 //x=36.655 //y=5.335 //x2=36.57 //y2=5.335
r382 (  33 62 ) resistor r=5.4201 //w=0.17 //l=0.085 //layer=li \
 //thickness=0.1 //x=37.365 //y=5.335 //x2=37.45 //y2=5.335
r383 (  33 34 ) resistor r=48.5989 //w=0.187 //l=0.71 //layer=li \
 //thickness=0.1 //x=37.365 //y=5.335 //x2=36.655 //y2=5.335
r384 (  27 61 ) resistor r=1.40859 //w=0.34 //l=0.085 //layer=li \
 //thickness=0.1 //x=36.57 //y=5.42 //x2=36.57 //y2=5.335
r385 (  27 126 ) resistor r=33.1979 //w=0.187 //l=0.485 //layer=li \
 //thickness=0.1 //x=36.57 //y=5.42 //x2=36.57 //y2=5.905
r386 (  25 61 ) resistor r=5.4201 //w=0.17 //l=0.085 //layer=li \
 //thickness=0.1 //x=36.485 //y=5.335 //x2=36.57 //y2=5.335
r387 (  25 26 ) resistor r=48.5989 //w=0.187 //l=0.71 //layer=li \
 //thickness=0.1 //x=36.485 //y=5.335 //x2=35.775 //y2=5.335
r388 (  19 26 ) resistor r=7.15173 //w=0.17 //l=0.120208 //layer=li \
 //thickness=0.1 //x=35.69 //y=5.42 //x2=35.775 //y2=5.335
r389 (  19 125 ) resistor r=33.1979 //w=0.187 //l=0.485 //layer=li \
 //thickness=0.1 //x=35.69 //y=5.42 //x2=35.69 //y2=5.905
r390 (  17 112 ) resistor r=152 //w=0.17 //l=0.17 //layer=licon //count=1 \
 //x=32.68 //y=4.88 //x2=32.68 //y2=4.88
r391 (  15 17 ) resistor r=93.7754 //w=0.187 //l=1.37 //layer=li \
 //thickness=0.1 //x=32.68 //y=3.51 //x2=32.68 //y2=4.88
r392 (  12 106 ) resistor r=152 //w=0.17 //l=0.17 //layer=licon //count=1 \
 //x=32.68 //y=2.26 //x2=32.68 //y2=2.26
r393 (  12 15 ) resistor r=85.5615 //w=0.187 //l=1.25 //layer=li \
 //thickness=0.1 //x=32.68 //y=2.26 //x2=32.68 //y2=3.51
r394 (  10 57 ) resistor r=9.3 //w=0.17 //l=0.17 //layer=mcon //count=1 \
 //x=49.7 //y=3.51 //x2=49.7 //y2=3.51
r395 (  8 52 ) resistor r=9.3 //w=0.17 //l=0.17 //layer=mcon //count=1 \
 //x=38.23 //y=3.51 //x2=38.23 //y2=3.51
r396 (  6 15 ) resistor r=9.3 //w=0.17 //l=0.17 //layer=mcon //count=1 \
 //x=32.68 //y=3.51 //x2=32.68 //y2=3.51
r397 (  4 8 ) resistor r=0.0880901 //w=0.191 //l=0.115 //layer=m1 \
 //thickness=0.36 //x=38.345 //y=3.51 //x2=38.23 //y2=3.51
r398 (  3 10 ) resistor r=0.0717383 //w=0.224 //l=0.115 //layer=m1 \
 //thickness=0.36 //x=49.585 //y=3.51 //x2=49.7 //y2=3.51
r399 (  3 4 ) resistor r=10.7252 //w=0.131 //l=11.24 //layer=m1 \
 //thickness=0.36 //x=49.585 //y=3.51 //x2=38.345 //y2=3.51
r400 (  2 6 ) resistor r=0.0717383 //w=0.224 //l=0.115 //layer=m1 \
 //thickness=0.36 //x=32.795 //y=3.51 //x2=32.68 //y2=3.51
r401 (  1 8 ) resistor r=0.0880901 //w=0.191 //l=0.115 //layer=m1 \
 //thickness=0.36 //x=38.115 //y=3.51 //x2=38.23 //y2=3.51
r402 (  1 2 ) resistor r=5.07634 //w=0.131 //l=5.32 //layer=m1 \
 //thickness=0.36 //x=38.115 //y=3.51 //x2=32.795 //y2=3.51
ends PM_TMRDFFSNRNQNX1\%noxref_11

subckt PM_TMRDFFSNRNQNX1\%noxref_12 ( 1 2 3 4 5 6 16 24 37 38 45 53 59 60 64 \
 66 73 74 75 76 77 78 79 80 81 82 83 87 88 89 94 96 99 100 104 105 106 111 113 \
 116 117 121 122 123 128 130 133 134 136 137 142 146 147 152 156 157 162 165 \
 167 168 169 )
c354 ( 169 0 ) capacitor c=0.023087f //x=46.925 //y=5.2
c355 ( 168 0 ) capacitor c=0.023519f //x=46.045 //y=5.2
c356 ( 167 0 ) capacitor c=0.0224735f //x=45.165 //y=5.2
c357 ( 165 0 ) capacitor c=0.00853354f //x=47.175 //y=1.095
c358 ( 162 0 ) capacitor c=0.0588394f //x=56.73 //y=4.88
c359 ( 157 0 ) capacitor c=0.0273931f //x=56.73 //y=2.095
c360 ( 156 0 ) capacitor c=0.0456313f //x=56.73 //y=2.26
c361 ( 152 0 ) capacitor c=0.0588394f //x=42.3 //y=4.88
c362 ( 147 0 ) capacitor c=0.0273931f //x=42.3 //y=2.095
c363 ( 146 0 ) capacitor c=0.0456313f //x=42.3 //y=2.26
c364 ( 142 0 ) capacitor c=0.0589949f //x=37.49 //y=4.88
c365 ( 137 0 ) capacitor c=0.0273931f //x=37.49 //y=2.095
c366 ( 136 0 ) capacitor c=0.0456313f //x=37.49 //y=2.26
c367 ( 134 0 ) capacitor c=0.0432517f //x=57.25 //y=1.44
c368 ( 133 0 ) capacitor c=0.0200379f //x=57.25 //y=1.095
c369 ( 130 0 ) capacitor c=0.0148873f //x=57.095 //y=1.595
c370 ( 128 0 ) capacitor c=0.0157803f //x=57.095 //y=0.94
c371 ( 123 0 ) capacitor c=0.0218028f //x=56.72 //y=1.75
c372 ( 122 0 ) capacitor c=0.0207459f //x=56.72 //y=1.44
c373 ( 121 0 ) capacitor c=0.0194308f //x=56.72 //y=1.095
c374 ( 117 0 ) capacitor c=0.0432517f //x=42.82 //y=1.44
c375 ( 116 0 ) capacitor c=0.0200379f //x=42.82 //y=1.095
c376 ( 113 0 ) capacitor c=0.0148873f //x=42.665 //y=1.595
c377 ( 111 0 ) capacitor c=0.0157803f //x=42.665 //y=0.94
c378 ( 106 0 ) capacitor c=0.0218028f //x=42.29 //y=1.75
c379 ( 105 0 ) capacitor c=0.0207459f //x=42.29 //y=1.44
c380 ( 104 0 ) capacitor c=0.0194308f //x=42.29 //y=1.095
c381 ( 100 0 ) capacitor c=0.0432517f //x=38.01 //y=1.44
c382 ( 99 0 ) capacitor c=0.0200379f //x=38.01 //y=1.095
c383 ( 96 0 ) capacitor c=0.0148873f //x=37.855 //y=1.595
c384 ( 94 0 ) capacitor c=0.0157803f //x=37.855 //y=0.94
c385 ( 89 0 ) capacitor c=0.0218028f //x=37.48 //y=1.75
c386 ( 88 0 ) capacitor c=0.0207459f //x=37.48 //y=1.44
c387 ( 87 0 ) capacitor c=0.0194308f //x=37.48 //y=1.095
c388 ( 83 0 ) capacitor c=0.158754f //x=56.91 //y=6.2
c389 ( 82 0 ) capacitor c=0.109949f //x=56.47 //y=6.2
c390 ( 81 0 ) capacitor c=0.158754f //x=42.48 //y=6.2
c391 ( 80 0 ) capacitor c=0.109949f //x=42.04 //y=6.2
c392 ( 79 0 ) capacitor c=0.158754f //x=37.67 //y=6.2
c393 ( 78 0 ) capacitor c=0.109949f //x=37.23 //y=6.2
c394 ( 74 0 ) capacitor c=9.74268e-19 //x=47.07 //y=5.335
c395 ( 73 0 ) capacitor c=0.00191414f //x=46.19 //y=5.335
c396 ( 66 0 ) capacitor c=0.0770908f //x=56.73 //y=2.26
c397 ( 64 0 ) capacitor c=0.104892f //x=47.85 //y=3.88
c398 ( 60 0 ) capacitor c=0.00398962f //x=47.45 //y=1.845
c399 ( 59 0 ) capacitor c=0.0137288f //x=47.765 //y=1.845
c400 ( 53 0 ) capacitor c=0.0276208f //x=47.765 //y=5.335
c401 ( 45 0 ) capacitor c=0.0169868f //x=46.985 //y=5.335
c402 ( 38 0 ) capacitor c=0.00316998f //x=45.395 //y=5.335
c403 ( 37 0 ) capacitor c=0.014258f //x=46.105 //y=5.335
c404 ( 24 0 ) capacitor c=0.0790362f //x=42.3 //y=2.26
c405 ( 16 0 ) capacitor c=0.0776243f //x=37.49 //y=2.26
c406 ( 6 0 ) capacitor c=0.0055354f //x=47.965 //y=3.88
c407 ( 5 0 ) capacitor c=0.140148f //x=56.615 //y=3.88
c408 ( 4 0 ) capacitor c=0.00533183f //x=42.415 //y=3.88
c409 ( 3 0 ) capacitor c=0.0751185f //x=47.735 //y=3.88
c410 ( 2 0 ) capacitor c=0.01364f //x=37.605 //y=3.88
c411 ( 1 0 ) capacitor c=0.0665749f //x=42.185 //y=3.88
r412 (  156 157 ) resistor r=52.7279 //w=0.214 //l=0.165 //layer=ply \
 //thickness=0.18 //x=56.73 //y=2.26 //x2=56.73 //y2=2.095
r413 (  146 147 ) resistor r=52.7279 //w=0.214 //l=0.165 //layer=ply \
 //thickness=0.18 //x=42.3 //y=2.26 //x2=42.3 //y2=2.095
r414 (  136 137 ) resistor r=52.7279 //w=0.214 //l=0.165 //layer=ply \
 //thickness=0.18 //x=37.49 //y=2.26 //x2=37.49 //y2=2.095
r415 (  134 164 ) resistor r=45.1352 //w=0.168 //l=0.173853 //layer=ply \
 //thickness=0.18 //x=57.25 //y=1.44 //x2=57.21 //y2=1.595
r416 (  133 163 ) resistor r=45.1352 //w=0.168 //l=0.173853 //layer=ply \
 //thickness=0.18 //x=57.25 //y=1.095 //x2=57.21 //y2=0.94
r417 (  133 134 ) resistor r=176.904 //w=0.094 //l=0.345 //layer=ply \
 //thickness=0.18 //x=57.25 //y=1.095 //x2=57.25 //y2=1.44
r418 (  131 160 ) resistor r=10.701 //w=0.21 //l=0.115 //layer=ply \
 //thickness=0.18 //x=56.875 //y=1.595 //x2=56.76 //y2=1.595
r419 (  130 164 ) resistor r=5.52526 //w=0.168 //l=0.115 //layer=ply \
 //thickness=0.18 //x=57.095 //y=1.595 //x2=57.21 //y2=1.595
r420 (  129 159 ) resistor r=5.52526 //w=0.168 //l=0.115 //layer=ply \
 //thickness=0.18 //x=56.875 //y=0.94 //x2=56.76 //y2=0.94
r421 (  128 163 ) resistor r=5.52526 //w=0.168 //l=0.115 //layer=ply \
 //thickness=0.18 //x=57.095 //y=0.94 //x2=57.21 //y2=0.94
r422 (  128 129 ) resistor r=112.809 //w=0.094 //l=0.22 //layer=ply \
 //thickness=0.18 //x=57.095 //y=0.94 //x2=56.875 //y2=0.94
r423 (  125 162 ) resistor r=37.236 //w=0.233 //l=0.249199 //layer=ply \
 //thickness=0.18 //x=56.91 //y=5.045 //x2=56.73 //y2=4.88
r424 (  123 160 ) resistor r=39.5823 //w=0.21 //l=0.173853 //layer=ply \
 //thickness=0.18 //x=56.72 //y=1.75 //x2=56.76 //y2=1.595
r425 (  123 157 ) resistor r=176.904 //w=0.094 //l=0.345 //layer=ply \
 //thickness=0.18 //x=56.72 //y=1.75 //x2=56.72 //y2=2.095
r426 (  122 160 ) resistor r=39.5823 //w=0.21 //l=0.173853 //layer=ply \
 //thickness=0.18 //x=56.72 //y=1.44 //x2=56.76 //y2=1.595
r427 (  121 159 ) resistor r=45.1352 //w=0.168 //l=0.173853 //layer=ply \
 //thickness=0.18 //x=56.72 //y=1.095 //x2=56.76 //y2=0.94
r428 (  121 122 ) resistor r=176.904 //w=0.094 //l=0.345 //layer=ply \
 //thickness=0.18 //x=56.72 //y=1.095 //x2=56.72 //y2=1.44
r429 (  118 162 ) resistor r=53.7854 //w=0.233 //l=0.332415 //layer=ply \
 //thickness=0.18 //x=56.47 //y=5.045 //x2=56.73 //y2=4.88
r430 (  117 154 ) resistor r=45.1352 //w=0.168 //l=0.173853 //layer=ply \
 //thickness=0.18 //x=42.82 //y=1.44 //x2=42.78 //y2=1.595
r431 (  116 153 ) resistor r=45.1352 //w=0.168 //l=0.173853 //layer=ply \
 //thickness=0.18 //x=42.82 //y=1.095 //x2=42.78 //y2=0.94
r432 (  116 117 ) resistor r=176.904 //w=0.094 //l=0.345 //layer=ply \
 //thickness=0.18 //x=42.82 //y=1.095 //x2=42.82 //y2=1.44
r433 (  114 150 ) resistor r=10.701 //w=0.21 //l=0.115 //layer=ply \
 //thickness=0.18 //x=42.445 //y=1.595 //x2=42.33 //y2=1.595
r434 (  113 154 ) resistor r=5.52526 //w=0.168 //l=0.115 //layer=ply \
 //thickness=0.18 //x=42.665 //y=1.595 //x2=42.78 //y2=1.595
r435 (  112 149 ) resistor r=5.52526 //w=0.168 //l=0.115 //layer=ply \
 //thickness=0.18 //x=42.445 //y=0.94 //x2=42.33 //y2=0.94
r436 (  111 153 ) resistor r=5.52526 //w=0.168 //l=0.115 //layer=ply \
 //thickness=0.18 //x=42.665 //y=0.94 //x2=42.78 //y2=0.94
r437 (  111 112 ) resistor r=112.809 //w=0.094 //l=0.22 //layer=ply \
 //thickness=0.18 //x=42.665 //y=0.94 //x2=42.445 //y2=0.94
r438 (  108 152 ) resistor r=37.236 //w=0.233 //l=0.249199 //layer=ply \
 //thickness=0.18 //x=42.48 //y=5.045 //x2=42.3 //y2=4.88
r439 (  106 150 ) resistor r=39.5823 //w=0.21 //l=0.173853 //layer=ply \
 //thickness=0.18 //x=42.29 //y=1.75 //x2=42.33 //y2=1.595
r440 (  106 147 ) resistor r=176.904 //w=0.094 //l=0.345 //layer=ply \
 //thickness=0.18 //x=42.29 //y=1.75 //x2=42.29 //y2=2.095
r441 (  105 150 ) resistor r=39.5823 //w=0.21 //l=0.173853 //layer=ply \
 //thickness=0.18 //x=42.29 //y=1.44 //x2=42.33 //y2=1.595
r442 (  104 149 ) resistor r=45.1352 //w=0.168 //l=0.173853 //layer=ply \
 //thickness=0.18 //x=42.29 //y=1.095 //x2=42.33 //y2=0.94
r443 (  104 105 ) resistor r=176.904 //w=0.094 //l=0.345 //layer=ply \
 //thickness=0.18 //x=42.29 //y=1.095 //x2=42.29 //y2=1.44
r444 (  101 152 ) resistor r=53.7854 //w=0.233 //l=0.332415 //layer=ply \
 //thickness=0.18 //x=42.04 //y=5.045 //x2=42.3 //y2=4.88
r445 (  100 144 ) resistor r=45.1352 //w=0.168 //l=0.173853 //layer=ply \
 //thickness=0.18 //x=38.01 //y=1.44 //x2=37.97 //y2=1.595
r446 (  99 143 ) resistor r=45.1352 //w=0.168 //l=0.173853 //layer=ply \
 //thickness=0.18 //x=38.01 //y=1.095 //x2=37.97 //y2=0.94
r447 (  99 100 ) resistor r=176.904 //w=0.094 //l=0.345 //layer=ply \
 //thickness=0.18 //x=38.01 //y=1.095 //x2=38.01 //y2=1.44
r448 (  97 140 ) resistor r=10.701 //w=0.21 //l=0.115 //layer=ply \
 //thickness=0.18 //x=37.635 //y=1.595 //x2=37.52 //y2=1.595
r449 (  96 144 ) resistor r=5.52526 //w=0.168 //l=0.115 //layer=ply \
 //thickness=0.18 //x=37.855 //y=1.595 //x2=37.97 //y2=1.595
r450 (  95 139 ) resistor r=5.52526 //w=0.168 //l=0.115 //layer=ply \
 //thickness=0.18 //x=37.635 //y=0.94 //x2=37.52 //y2=0.94
r451 (  94 143 ) resistor r=5.52526 //w=0.168 //l=0.115 //layer=ply \
 //thickness=0.18 //x=37.855 //y=0.94 //x2=37.97 //y2=0.94
r452 (  94 95 ) resistor r=112.809 //w=0.094 //l=0.22 //layer=ply \
 //thickness=0.18 //x=37.855 //y=0.94 //x2=37.635 //y2=0.94
r453 (  91 142 ) resistor r=37.236 //w=0.233 //l=0.249199 //layer=ply \
 //thickness=0.18 //x=37.67 //y=5.045 //x2=37.49 //y2=4.88
r454 (  89 140 ) resistor r=39.5823 //w=0.21 //l=0.173853 //layer=ply \
 //thickness=0.18 //x=37.48 //y=1.75 //x2=37.52 //y2=1.595
r455 (  89 137 ) resistor r=176.904 //w=0.094 //l=0.345 //layer=ply \
 //thickness=0.18 //x=37.48 //y=1.75 //x2=37.48 //y2=2.095
r456 (  88 140 ) resistor r=39.5823 //w=0.21 //l=0.173853 //layer=ply \
 //thickness=0.18 //x=37.48 //y=1.44 //x2=37.52 //y2=1.595
r457 (  87 139 ) resistor r=45.1352 //w=0.168 //l=0.173853 //layer=ply \
 //thickness=0.18 //x=37.48 //y=1.095 //x2=37.52 //y2=0.94
r458 (  87 88 ) resistor r=176.904 //w=0.094 //l=0.345 //layer=ply \
 //thickness=0.18 //x=37.48 //y=1.095 //x2=37.48 //y2=1.44
r459 (  84 142 ) resistor r=53.7854 //w=0.233 //l=0.332415 //layer=ply \
 //thickness=0.18 //x=37.23 //y=5.045 //x2=37.49 //y2=4.88
r460 (  83 125 ) resistor r=592.245 //w=0.094 //l=1.155 //layer=ply \
 //thickness=0.18 //x=56.91 //y=6.2 //x2=56.91 //y2=5.045
r461 (  82 118 ) resistor r=592.245 //w=0.094 //l=1.155 //layer=ply \
 //thickness=0.18 //x=56.47 //y=6.2 //x2=56.47 //y2=5.045
r462 (  81 108 ) resistor r=592.245 //w=0.094 //l=1.155 //layer=ply \
 //thickness=0.18 //x=42.48 //y=6.2 //x2=42.48 //y2=5.045
r463 (  80 101 ) resistor r=592.245 //w=0.094 //l=1.155 //layer=ply \
 //thickness=0.18 //x=42.04 //y=6.2 //x2=42.04 //y2=5.045
r464 (  79 91 ) resistor r=592.245 //w=0.094 //l=1.155 //layer=ply \
 //thickness=0.18 //x=37.67 //y=6.2 //x2=37.67 //y2=5.045
r465 (  78 84 ) resistor r=592.245 //w=0.094 //l=1.155 //layer=ply \
 //thickness=0.18 //x=37.23 //y=6.2 //x2=37.23 //y2=5.045
r466 (  77 130 ) resistor r=56.4043 //w=0.094 //l=0.11 //layer=ply \
 //thickness=0.18 //x=56.985 //y=1.595 //x2=57.095 //y2=1.595
r467 (  77 131 ) resistor r=56.4043 //w=0.094 //l=0.11 //layer=ply \
 //thickness=0.18 //x=56.985 //y=1.595 //x2=56.875 //y2=1.595
r468 (  76 113 ) resistor r=56.4043 //w=0.094 //l=0.11 //layer=ply \
 //thickness=0.18 //x=42.555 //y=1.595 //x2=42.665 //y2=1.595
r469 (  76 114 ) resistor r=56.4043 //w=0.094 //l=0.11 //layer=ply \
 //thickness=0.18 //x=42.555 //y=1.595 //x2=42.445 //y2=1.595
r470 (  75 96 ) resistor r=56.4043 //w=0.094 //l=0.11 //layer=ply \
 //thickness=0.18 //x=37.745 //y=1.595 //x2=37.855 //y2=1.595
r471 (  75 97 ) resistor r=56.4043 //w=0.094 //l=0.11 //layer=ply \
 //thickness=0.18 //x=37.745 //y=1.595 //x2=37.635 //y2=1.595
r472 (  71 162 ) resistor r=152 //w=0.17 //l=0.17 //layer=licon //count=1 \
 //x=56.73 //y=4.88 //x2=56.73 //y2=4.88
r473 (  69 71 ) resistor r=68.4492 //w=0.187 //l=1 //layer=li //thickness=0.1 \
 //x=56.73 //y=3.88 //x2=56.73 //y2=4.88
r474 (  66 156 ) resistor r=152 //w=0.17 //l=0.17 //layer=licon //count=1 \
 //x=56.73 //y=2.26 //x2=56.73 //y2=2.26
r475 (  66 69 ) resistor r=110.888 //w=0.187 //l=1.62 //layer=li \
 //thickness=0.1 //x=56.73 //y=2.26 //x2=56.73 //y2=3.88
r476 (  62 64 ) resistor r=93.7754 //w=0.187 //l=1.37 //layer=li \
 //thickness=0.1 //x=47.85 //y=5.25 //x2=47.85 //y2=3.88
r477 (  61 64 ) resistor r=133.476 //w=0.187 //l=1.95 //layer=li \
 //thickness=0.1 //x=47.85 //y=1.93 //x2=47.85 //y2=3.88
r478 (  59 61 ) resistor r=7.15173 //w=0.17 //l=0.120208 //layer=li \
 //thickness=0.1 //x=47.765 //y=1.845 //x2=47.85 //y2=1.93
r479 (  59 60 ) resistor r=21.5615 //w=0.187 //l=0.315 //layer=li \
 //thickness=0.1 //x=47.765 //y=1.845 //x2=47.45 //y2=1.845
r480 (  55 60 ) resistor r=7.15173 //w=0.17 //l=0.120208 //layer=li \
 //thickness=0.1 //x=47.365 //y=1.76 //x2=47.45 //y2=1.845
r481 (  55 165 ) resistor r=39.016 //w=0.187 //l=0.57 //layer=li \
 //thickness=0.1 //x=47.365 //y=1.76 //x2=47.365 //y2=1.19
r482 (  54 74 ) resistor r=5.4201 //w=0.17 //l=0.085 //layer=li \
 //thickness=0.1 //x=47.155 //y=5.335 //x2=47.07 //y2=5.335
r483 (  53 62 ) resistor r=7.15173 //w=0.17 //l=0.120208 //layer=li \
 //thickness=0.1 //x=47.765 //y=5.335 //x2=47.85 //y2=5.25
r484 (  53 54 ) resistor r=41.754 //w=0.187 //l=0.61 //layer=li \
 //thickness=0.1 //x=47.765 //y=5.335 //x2=47.155 //y2=5.335
r485 (  47 74 ) resistor r=1.40859 //w=0.34 //l=0.085 //layer=li \
 //thickness=0.1 //x=47.07 //y=5.42 //x2=47.07 //y2=5.335
r486 (  47 169 ) resistor r=33.1979 //w=0.187 //l=0.485 //layer=li \
 //thickness=0.1 //x=47.07 //y=5.42 //x2=47.07 //y2=5.905
r487 (  46 73 ) resistor r=5.4201 //w=0.17 //l=0.085 //layer=li \
 //thickness=0.1 //x=46.275 //y=5.335 //x2=46.19 //y2=5.335
r488 (  45 74 ) resistor r=5.4201 //w=0.17 //l=0.085 //layer=li \
 //thickness=0.1 //x=46.985 //y=5.335 //x2=47.07 //y2=5.335
r489 (  45 46 ) resistor r=48.5989 //w=0.187 //l=0.71 //layer=li \
 //thickness=0.1 //x=46.985 //y=5.335 //x2=46.275 //y2=5.335
r490 (  39 73 ) resistor r=1.40859 //w=0.34 //l=0.085 //layer=li \
 //thickness=0.1 //x=46.19 //y=5.42 //x2=46.19 //y2=5.335
r491 (  39 168 ) resistor r=33.1979 //w=0.187 //l=0.485 //layer=li \
 //thickness=0.1 //x=46.19 //y=5.42 //x2=46.19 //y2=5.905
r492 (  37 73 ) resistor r=5.4201 //w=0.17 //l=0.085 //layer=li \
 //thickness=0.1 //x=46.105 //y=5.335 //x2=46.19 //y2=5.335
r493 (  37 38 ) resistor r=48.5989 //w=0.187 //l=0.71 //layer=li \
 //thickness=0.1 //x=46.105 //y=5.335 //x2=45.395 //y2=5.335
r494 (  31 38 ) resistor r=7.15173 //w=0.17 //l=0.120208 //layer=li \
 //thickness=0.1 //x=45.31 //y=5.42 //x2=45.395 //y2=5.335
r495 (  31 167 ) resistor r=33.1979 //w=0.187 //l=0.485 //layer=li \
 //thickness=0.1 //x=45.31 //y=5.42 //x2=45.31 //y2=5.905
r496 (  29 152 ) resistor r=152 //w=0.17 //l=0.17 //layer=licon //count=1 \
 //x=42.3 //y=4.88 //x2=42.3 //y2=4.88
r497 (  27 29 ) resistor r=68.4492 //w=0.187 //l=1 //layer=li //thickness=0.1 \
 //x=42.3 //y=3.88 //x2=42.3 //y2=4.88
r498 (  24 146 ) resistor r=152 //w=0.17 //l=0.17 //layer=licon //count=1 \
 //x=42.3 //y=2.26 //x2=42.3 //y2=2.26
r499 (  24 27 ) resistor r=110.888 //w=0.187 //l=1.62 //layer=li \
 //thickness=0.1 //x=42.3 //y=2.26 //x2=42.3 //y2=3.88
r500 (  21 142 ) resistor r=152 //w=0.17 //l=0.17 //layer=licon //count=1 \
 //x=37.49 //y=4.88 //x2=37.49 //y2=4.88
r501 (  19 21 ) resistor r=68.4492 //w=0.187 //l=1 //layer=li //thickness=0.1 \
 //x=37.49 //y=3.88 //x2=37.49 //y2=4.88
r502 (  16 136 ) resistor r=152 //w=0.17 //l=0.17 //layer=licon //count=1 \
 //x=37.49 //y=2.26 //x2=37.49 //y2=2.26
r503 (  16 19 ) resistor r=110.888 //w=0.187 //l=1.62 //layer=li \
 //thickness=0.1 //x=37.49 //y=2.26 //x2=37.49 //y2=3.88
r504 (  14 69 ) resistor r=9.3 //w=0.17 //l=0.17 //layer=mcon //count=1 \
 //x=56.73 //y=3.88 //x2=56.73 //y2=3.88
r505 (  12 64 ) resistor r=9.3 //w=0.17 //l=0.17 //layer=mcon //count=1 \
 //x=47.85 //y=3.88 //x2=47.85 //y2=3.88
r506 (  10 27 ) resistor r=9.3 //w=0.17 //l=0.17 //layer=mcon //count=1 \
 //x=42.3 //y=3.88 //x2=42.3 //y2=3.88
r507 (  8 19 ) resistor r=9.3 //w=0.17 //l=0.17 //layer=mcon //count=1 \
 //x=37.49 //y=3.88 //x2=37.49 //y2=3.88
r508 (  6 12 ) resistor r=0.0880901 //w=0.191 //l=0.115 //layer=m1 \
 //thickness=0.36 //x=47.965 //y=3.88 //x2=47.85 //y2=3.88
r509 (  5 14 ) resistor r=0.0717383 //w=0.224 //l=0.115 //layer=m1 \
 //thickness=0.36 //x=56.615 //y=3.88 //x2=56.73 //y2=3.88
r510 (  5 6 ) resistor r=8.25382 //w=0.131 //l=8.65 //layer=m1 \
 //thickness=0.36 //x=56.615 //y=3.88 //x2=47.965 //y2=3.88
r511 (  4 10 ) resistor r=0.0880901 //w=0.191 //l=0.115 //layer=m1 \
 //thickness=0.36 //x=42.415 //y=3.88 //x2=42.3 //y2=3.88
r512 (  3 12 ) resistor r=0.0880901 //w=0.191 //l=0.115 //layer=m1 \
 //thickness=0.36 //x=47.735 //y=3.88 //x2=47.85 //y2=3.88
r513 (  3 4 ) resistor r=5.07634 //w=0.131 //l=5.32 //layer=m1 \
 //thickness=0.36 //x=47.735 //y=3.88 //x2=42.415 //y2=3.88
r514 (  2 8 ) resistor r=0.0717383 //w=0.224 //l=0.115 //layer=m1 \
 //thickness=0.36 //x=37.605 //y=3.88 //x2=37.49 //y2=3.88
r515 (  1 10 ) resistor r=0.0880901 //w=0.191 //l=0.115 //layer=m1 \
 //thickness=0.36 //x=42.185 //y=3.88 //x2=42.3 //y2=3.88
r516 (  1 2 ) resistor r=4.37023 //w=0.131 //l=4.58 //layer=m1 \
 //thickness=0.36 //x=42.185 //y=3.88 //x2=37.605 //y2=3.88
ends PM_TMRDFFSNRNQNX1\%noxref_12

subckt PM_TMRDFFSNRNQNX1\%noxref_13 ( 1 2 8 21 22 29 37 43 44 48 49 50 51 52 \
 53 57 58 59 64 66 69 70 72 73 78 81 83 84 85 )
c178 ( 85 0 ) capacitor c=0.023087f //x=56.545 //y=5.2
c179 ( 84 0 ) capacitor c=0.023519f //x=55.665 //y=5.2
c180 ( 83 0 ) capacitor c=0.0224735f //x=54.785 //y=5.2
c181 ( 81 0 ) capacitor c=0.00853354f //x=56.795 //y=1.095
c182 ( 78 0 ) capacitor c=0.0588394f //x=51.92 //y=4.88
c183 ( 73 0 ) capacitor c=0.0273931f //x=51.92 //y=2.095
c184 ( 72 0 ) capacitor c=0.0456313f //x=51.92 //y=2.26
c185 ( 70 0 ) capacitor c=0.0432517f //x=52.44 //y=1.44
c186 ( 69 0 ) capacitor c=0.0200379f //x=52.44 //y=1.095
c187 ( 66 0 ) capacitor c=0.0148873f //x=52.285 //y=1.595
c188 ( 64 0 ) capacitor c=0.0157803f //x=52.285 //y=0.94
c189 ( 59 0 ) capacitor c=0.0218028f //x=51.91 //y=1.75
c190 ( 58 0 ) capacitor c=0.0207459f //x=51.91 //y=1.44
c191 ( 57 0 ) capacitor c=0.0194308f //x=51.91 //y=1.095
c192 ( 53 0 ) capacitor c=0.158754f //x=52.1 //y=6.2
c193 ( 52 0 ) capacitor c=0.109949f //x=51.66 //y=6.2
c194 ( 50 0 ) capacitor c=9.74268e-19 //x=56.69 //y=5.335
c195 ( 49 0 ) capacitor c=0.00191414f //x=55.81 //y=5.335
c196 ( 48 0 ) capacitor c=0.0997105f //x=57.47 //y=2.77
c197 ( 44 0 ) capacitor c=0.00398962f //x=57.07 //y=1.845
c198 ( 43 0 ) capacitor c=0.0137288f //x=57.385 //y=1.845
c199 ( 37 0 ) capacitor c=0.0276208f //x=57.385 //y=5.335
c200 ( 29 0 ) capacitor c=0.0169868f //x=56.605 //y=5.335
c201 ( 22 0 ) capacitor c=0.00316998f //x=55.015 //y=5.335
c202 ( 21 0 ) capacitor c=0.014258f //x=55.725 //y=5.335
c203 ( 8 0 ) capacitor c=0.0791424f //x=51.92 //y=2.26
c204 ( 2 0 ) capacitor c=0.0137813f //x=52.035 //y=2.77
c205 ( 1 0 ) capacitor c=0.0833895f //x=57.355 //y=2.77
r206 (  72 73 ) resistor r=52.7279 //w=0.214 //l=0.165 //layer=ply \
 //thickness=0.18 //x=51.92 //y=2.26 //x2=51.92 //y2=2.095
r207 (  70 80 ) resistor r=45.1352 //w=0.168 //l=0.173853 //layer=ply \
 //thickness=0.18 //x=52.44 //y=1.44 //x2=52.4 //y2=1.595
r208 (  69 79 ) resistor r=45.1352 //w=0.168 //l=0.173853 //layer=ply \
 //thickness=0.18 //x=52.44 //y=1.095 //x2=52.4 //y2=0.94
r209 (  69 70 ) resistor r=176.904 //w=0.094 //l=0.345 //layer=ply \
 //thickness=0.18 //x=52.44 //y=1.095 //x2=52.44 //y2=1.44
r210 (  67 76 ) resistor r=10.701 //w=0.21 //l=0.115 //layer=ply \
 //thickness=0.18 //x=52.065 //y=1.595 //x2=51.95 //y2=1.595
r211 (  66 80 ) resistor r=5.52526 //w=0.168 //l=0.115 //layer=ply \
 //thickness=0.18 //x=52.285 //y=1.595 //x2=52.4 //y2=1.595
r212 (  65 75 ) resistor r=5.52526 //w=0.168 //l=0.115 //layer=ply \
 //thickness=0.18 //x=52.065 //y=0.94 //x2=51.95 //y2=0.94
r213 (  64 79 ) resistor r=5.52526 //w=0.168 //l=0.115 //layer=ply \
 //thickness=0.18 //x=52.285 //y=0.94 //x2=52.4 //y2=0.94
r214 (  64 65 ) resistor r=112.809 //w=0.094 //l=0.22 //layer=ply \
 //thickness=0.18 //x=52.285 //y=0.94 //x2=52.065 //y2=0.94
r215 (  61 78 ) resistor r=37.236 //w=0.233 //l=0.249199 //layer=ply \
 //thickness=0.18 //x=52.1 //y=5.045 //x2=51.92 //y2=4.88
r216 (  59 76 ) resistor r=39.5823 //w=0.21 //l=0.173853 //layer=ply \
 //thickness=0.18 //x=51.91 //y=1.75 //x2=51.95 //y2=1.595
r217 (  59 73 ) resistor r=176.904 //w=0.094 //l=0.345 //layer=ply \
 //thickness=0.18 //x=51.91 //y=1.75 //x2=51.91 //y2=2.095
r218 (  58 76 ) resistor r=39.5823 //w=0.21 //l=0.173853 //layer=ply \
 //thickness=0.18 //x=51.91 //y=1.44 //x2=51.95 //y2=1.595
r219 (  57 75 ) resistor r=45.1352 //w=0.168 //l=0.173853 //layer=ply \
 //thickness=0.18 //x=51.91 //y=1.095 //x2=51.95 //y2=0.94
r220 (  57 58 ) resistor r=176.904 //w=0.094 //l=0.345 //layer=ply \
 //thickness=0.18 //x=51.91 //y=1.095 //x2=51.91 //y2=1.44
r221 (  54 78 ) resistor r=53.7854 //w=0.233 //l=0.332415 //layer=ply \
 //thickness=0.18 //x=51.66 //y=5.045 //x2=51.92 //y2=4.88
r222 (  53 61 ) resistor r=592.245 //w=0.094 //l=1.155 //layer=ply \
 //thickness=0.18 //x=52.1 //y=6.2 //x2=52.1 //y2=5.045
r223 (  52 54 ) resistor r=592.245 //w=0.094 //l=1.155 //layer=ply \
 //thickness=0.18 //x=51.66 //y=6.2 //x2=51.66 //y2=5.045
r224 (  51 66 ) resistor r=56.4043 //w=0.094 //l=0.11 //layer=ply \
 //thickness=0.18 //x=52.175 //y=1.595 //x2=52.285 //y2=1.595
r225 (  51 67 ) resistor r=56.4043 //w=0.094 //l=0.11 //layer=ply \
 //thickness=0.18 //x=52.175 //y=1.595 //x2=52.065 //y2=1.595
r226 (  46 48 ) resistor r=169.754 //w=0.187 //l=2.48 //layer=li \
 //thickness=0.1 //x=57.47 //y=5.25 //x2=57.47 //y2=2.77
r227 (  45 48 ) resistor r=57.4973 //w=0.187 //l=0.84 //layer=li \
 //thickness=0.1 //x=57.47 //y=1.93 //x2=57.47 //y2=2.77
r228 (  43 45 ) resistor r=7.15173 //w=0.17 //l=0.120208 //layer=li \
 //thickness=0.1 //x=57.385 //y=1.845 //x2=57.47 //y2=1.93
r229 (  43 44 ) resistor r=21.5615 //w=0.187 //l=0.315 //layer=li \
 //thickness=0.1 //x=57.385 //y=1.845 //x2=57.07 //y2=1.845
r230 (  39 44 ) resistor r=7.15173 //w=0.17 //l=0.120208 //layer=li \
 //thickness=0.1 //x=56.985 //y=1.76 //x2=57.07 //y2=1.845
r231 (  39 81 ) resistor r=39.016 //w=0.187 //l=0.57 //layer=li \
 //thickness=0.1 //x=56.985 //y=1.76 //x2=56.985 //y2=1.19
r232 (  38 50 ) resistor r=5.4201 //w=0.17 //l=0.085 //layer=li \
 //thickness=0.1 //x=56.775 //y=5.335 //x2=56.69 //y2=5.335
r233 (  37 46 ) resistor r=7.15173 //w=0.17 //l=0.120208 //layer=li \
 //thickness=0.1 //x=57.385 //y=5.335 //x2=57.47 //y2=5.25
r234 (  37 38 ) resistor r=41.754 //w=0.187 //l=0.61 //layer=li \
 //thickness=0.1 //x=57.385 //y=5.335 //x2=56.775 //y2=5.335
r235 (  31 50 ) resistor r=1.40859 //w=0.34 //l=0.085 //layer=li \
 //thickness=0.1 //x=56.69 //y=5.42 //x2=56.69 //y2=5.335
r236 (  31 85 ) resistor r=33.1979 //w=0.187 //l=0.485 //layer=li \
 //thickness=0.1 //x=56.69 //y=5.42 //x2=56.69 //y2=5.905
r237 (  30 49 ) resistor r=5.4201 //w=0.17 //l=0.085 //layer=li \
 //thickness=0.1 //x=55.895 //y=5.335 //x2=55.81 //y2=5.335
r238 (  29 50 ) resistor r=5.4201 //w=0.17 //l=0.085 //layer=li \
 //thickness=0.1 //x=56.605 //y=5.335 //x2=56.69 //y2=5.335
r239 (  29 30 ) resistor r=48.5989 //w=0.187 //l=0.71 //layer=li \
 //thickness=0.1 //x=56.605 //y=5.335 //x2=55.895 //y2=5.335
r240 (  23 49 ) resistor r=1.40859 //w=0.34 //l=0.085 //layer=li \
 //thickness=0.1 //x=55.81 //y=5.42 //x2=55.81 //y2=5.335
r241 (  23 84 ) resistor r=33.1979 //w=0.187 //l=0.485 //layer=li \
 //thickness=0.1 //x=55.81 //y=5.42 //x2=55.81 //y2=5.905
r242 (  21 49 ) resistor r=5.4201 //w=0.17 //l=0.085 //layer=li \
 //thickness=0.1 //x=55.725 //y=5.335 //x2=55.81 //y2=5.335
r243 (  21 22 ) resistor r=48.5989 //w=0.187 //l=0.71 //layer=li \
 //thickness=0.1 //x=55.725 //y=5.335 //x2=55.015 //y2=5.335
r244 (  15 22 ) resistor r=7.15173 //w=0.17 //l=0.120208 //layer=li \
 //thickness=0.1 //x=54.93 //y=5.42 //x2=55.015 //y2=5.335
r245 (  15 83 ) resistor r=33.1979 //w=0.187 //l=0.485 //layer=li \
 //thickness=0.1 //x=54.93 //y=5.42 //x2=54.93 //y2=5.905
r246 (  13 78 ) resistor r=152 //w=0.17 //l=0.17 //layer=licon //count=1 \
 //x=51.92 //y=4.88 //x2=51.92 //y2=4.88
r247 (  11 13 ) resistor r=144.428 //w=0.187 //l=2.11 //layer=li \
 //thickness=0.1 //x=51.92 //y=2.77 //x2=51.92 //y2=4.88
r248 (  8 72 ) resistor r=152 //w=0.17 //l=0.17 //layer=licon //count=1 \
 //x=51.92 //y=2.26 //x2=51.92 //y2=2.26
r249 (  8 11 ) resistor r=34.9091 //w=0.187 //l=0.51 //layer=li \
 //thickness=0.1 //x=51.92 //y=2.26 //x2=51.92 //y2=2.77
r250 (  6 48 ) resistor r=9.3 //w=0.17 //l=0.17 //layer=mcon //count=1 \
 //x=57.47 //y=2.77 //x2=57.47 //y2=2.77
r251 (  4 11 ) resistor r=9.3 //w=0.17 //l=0.17 //layer=mcon //count=1 \
 //x=51.92 //y=2.77 //x2=51.92 //y2=2.77
r252 (  2 4 ) resistor r=0.0717383 //w=0.224 //l=0.115 //layer=m1 \
 //thickness=0.36 //x=52.035 //y=2.77 //x2=51.92 //y2=2.77
r253 (  1 6 ) resistor r=0.0717383 //w=0.224 //l=0.115 //layer=m1 \
 //thickness=0.36 //x=57.355 //y=2.77 //x2=57.47 //y2=2.77
r254 (  1 2 ) resistor r=5.07634 //w=0.131 //l=5.32 //layer=m1 \
 //thickness=0.36 //x=57.355 //y=2.77 //x2=52.035 //y2=2.77
ends PM_TMRDFFSNRNQNX1\%noxref_13

subckt PM_TMRDFFSNRNQNX1\%D ( 1 2 3 4 11 12 13 14 15 16 17 18 19 20 21 22 23 \
 24 26 40 51 60 61 62 63 64 65 66 67 68 69 70 71 72 73 75 81 82 83 84 88 89 90 \
 91 92 94 100 101 102 103 107 108 109 110 111 113 119 120 121 122 )
c342 ( 122 0 ) capacitor c=0.0547611f //x=59.595 //y=4.97
c343 ( 121 0 ) capacitor c=0.0294456f //x=59.885 //y=4.97
c344 ( 120 0 ) capacitor c=0.0347816f //x=59.55 //y=1.4
c345 ( 119 0 ) capacitor c=0.0187487f //x=59.55 //y=1.055
c346 ( 113 0 ) capacitor c=0.0137055f //x=59.395 //y=1.555
c347 ( 111 0 ) capacitor c=0.0149861f //x=59.395 //y=0.9
c348 ( 110 0 ) capacitor c=0.096037f //x=59.02 //y=2.095
c349 ( 109 0 ) capacitor c=0.0228993f //x=59.02 //y=1.71
c350 ( 108 0 ) capacitor c=0.0234352f //x=59.02 //y=1.4
c351 ( 107 0 ) capacitor c=0.0198724f //x=59.02 //y=1.055
c352 ( 103 0 ) capacitor c=0.0547611f //x=30.735 //y=4.97
c353 ( 102 0 ) capacitor c=0.0294456f //x=31.025 //y=4.97
c354 ( 101 0 ) capacitor c=0.0347816f //x=30.69 //y=1.4
c355 ( 100 0 ) capacitor c=0.0187487f //x=30.69 //y=1.055
c356 ( 94 0 ) capacitor c=0.0137055f //x=30.535 //y=1.555
c357 ( 92 0 ) capacitor c=0.0149861f //x=30.535 //y=0.9
c358 ( 91 0 ) capacitor c=0.096037f //x=30.16 //y=2.095
c359 ( 90 0 ) capacitor c=0.0228993f //x=30.16 //y=1.71
c360 ( 89 0 ) capacitor c=0.0234352f //x=30.16 //y=1.4
c361 ( 88 0 ) capacitor c=0.0198724f //x=30.16 //y=1.055
c362 ( 84 0 ) capacitor c=0.0558341f //x=1.875 //y=4.97
c363 ( 83 0 ) capacitor c=0.0298189f //x=2.165 //y=4.97
c364 ( 82 0 ) capacitor c=0.0347816f //x=1.83 //y=1.4
c365 ( 81 0 ) capacitor c=0.0187487f //x=1.83 //y=1.055
c366 ( 75 0 ) capacitor c=0.0137055f //x=1.675 //y=1.555
c367 ( 73 0 ) capacitor c=0.0149861f //x=1.675 //y=0.9
c368 ( 72 0 ) capacitor c=0.102158f //x=1.3 //y=2.095
c369 ( 71 0 ) capacitor c=0.0229444f //x=1.3 //y=1.71
c370 ( 70 0 ) capacitor c=0.0234352f //x=1.3 //y=1.4
c371 ( 69 0 ) capacitor c=0.0198724f //x=1.3 //y=1.055
c372 ( 68 0 ) capacitor c=0.109949f //x=59.96 //y=6.2
c373 ( 67 0 ) capacitor c=0.158483f //x=59.52 //y=6.2
c374 ( 66 0 ) capacitor c=0.109949f //x=31.1 //y=6.2
c375 ( 65 0 ) capacitor c=0.158483f //x=30.66 //y=6.2
c376 ( 64 0 ) capacitor c=0.110114f //x=2.24 //y=6.2
c377 ( 63 0 ) capacitor c=0.158956f //x=1.8 //y=6.2
c378 ( 51 0 ) capacitor c=0.0952756f //x=59.32 //y=2.26
c379 ( 40 0 ) capacitor c=0.0991769f //x=30.46 //y=2.26
c380 ( 26 0 ) capacitor c=0.124371f //x=1.6 //y=2.26
c381 ( 4 0 ) capacitor c=0.00590384f //x=30.575 //y=4.25
c382 ( 3 0 ) capacitor c=0.426491f //x=59.205 //y=4.25
c383 ( 2 0 ) capacitor c=0.0231516f //x=1.715 //y=4.25
c384 ( 1 0 ) capacitor c=0.511583f //x=30.345 //y=4.25
r385 (  121 123 ) resistor r=26.9307 //w=0.15 //l=0.106066 //layer=ply \
 //thickness=0.18 //x=59.885 //y=4.97 //x2=59.96 //y2=5.045
r386 (  121 122 ) resistor r=148.702 //w=0.094 //l=0.29 //layer=ply \
 //thickness=0.18 //x=59.885 //y=4.97 //x2=59.595 //y2=4.97
r387 (  120 149 ) resistor r=45.1352 //w=0.168 //l=0.173853 //layer=ply \
 //thickness=0.18 //x=59.55 //y=1.4 //x2=59.51 //y2=1.555
r388 (  119 148 ) resistor r=45.1352 //w=0.168 //l=0.173853 //layer=ply \
 //thickness=0.18 //x=59.55 //y=1.055 //x2=59.51 //y2=0.9
r389 (  119 120 ) resistor r=176.904 //w=0.094 //l=0.345 //layer=ply \
 //thickness=0.18 //x=59.55 //y=1.055 //x2=59.55 //y2=1.4
r390 (  116 122 ) resistor r=22.7971 //w=0.269 //l=0.106066 //layer=ply \
 //thickness=0.18 //x=59.52 //y=5.045 //x2=59.595 //y2=4.97
r391 (  116 147 ) resistor r=35.8364 //w=0.269 //l=0.270185 //layer=ply \
 //thickness=0.18 //x=59.52 //y=5.045 //x2=59.32 //y2=4.88
r392 (  114 143 ) resistor r=10.701 //w=0.21 //l=0.115 //layer=ply \
 //thickness=0.18 //x=59.175 //y=1.555 //x2=59.06 //y2=1.555
r393 (  113 149 ) resistor r=5.52526 //w=0.168 //l=0.115 //layer=ply \
 //thickness=0.18 //x=59.395 //y=1.555 //x2=59.51 //y2=1.555
r394 (  112 142 ) resistor r=5.52526 //w=0.168 //l=0.115 //layer=ply \
 //thickness=0.18 //x=59.175 //y=0.9 //x2=59.06 //y2=0.9
r395 (  111 148 ) resistor r=5.52526 //w=0.168 //l=0.115 //layer=ply \
 //thickness=0.18 //x=59.395 //y=0.9 //x2=59.51 //y2=0.9
r396 (  111 112 ) resistor r=112.809 //w=0.094 //l=0.22 //layer=ply \
 //thickness=0.18 //x=59.395 //y=0.9 //x2=59.175 //y2=0.9
r397 (  110 145 ) resistor r=58.7805 //w=0.246 //l=0.373497 //layer=ply \
 //thickness=0.18 //x=59.02 //y=2.095 //x2=59.32 //y2=2.26
r398 (  109 143 ) resistor r=39.5823 //w=0.21 //l=0.173853 //layer=ply \
 //thickness=0.18 //x=59.02 //y=1.71 //x2=59.06 //y2=1.555
r399 (  109 110 ) resistor r=197.415 //w=0.094 //l=0.385 //layer=ply \
 //thickness=0.18 //x=59.02 //y=1.71 //x2=59.02 //y2=2.095
r400 (  108 143 ) resistor r=39.5823 //w=0.21 //l=0.173853 //layer=ply \
 //thickness=0.18 //x=59.02 //y=1.4 //x2=59.06 //y2=1.555
r401 (  107 142 ) resistor r=45.1352 //w=0.168 //l=0.173853 //layer=ply \
 //thickness=0.18 //x=59.02 //y=1.055 //x2=59.06 //y2=0.9
r402 (  107 108 ) resistor r=176.904 //w=0.094 //l=0.345 //layer=ply \
 //thickness=0.18 //x=59.02 //y=1.055 //x2=59.02 //y2=1.4
r403 (  102 104 ) resistor r=26.9307 //w=0.15 //l=0.106066 //layer=ply \
 //thickness=0.18 //x=31.025 //y=4.97 //x2=31.1 //y2=5.045
r404 (  102 103 ) resistor r=148.702 //w=0.094 //l=0.29 //layer=ply \
 //thickness=0.18 //x=31.025 //y=4.97 //x2=30.735 //y2=4.97
r405 (  101 141 ) resistor r=45.1352 //w=0.168 //l=0.173853 //layer=ply \
 //thickness=0.18 //x=30.69 //y=1.4 //x2=30.65 //y2=1.555
r406 (  100 140 ) resistor r=45.1352 //w=0.168 //l=0.173853 //layer=ply \
 //thickness=0.18 //x=30.69 //y=1.055 //x2=30.65 //y2=0.9
r407 (  100 101 ) resistor r=176.904 //w=0.094 //l=0.345 //layer=ply \
 //thickness=0.18 //x=30.69 //y=1.055 //x2=30.69 //y2=1.4
r408 (  97 103 ) resistor r=22.7971 //w=0.269 //l=0.106066 //layer=ply \
 //thickness=0.18 //x=30.66 //y=5.045 //x2=30.735 //y2=4.97
r409 (  97 139 ) resistor r=35.8364 //w=0.269 //l=0.270185 //layer=ply \
 //thickness=0.18 //x=30.66 //y=5.045 //x2=30.46 //y2=4.88
r410 (  95 135 ) resistor r=10.701 //w=0.21 //l=0.115 //layer=ply \
 //thickness=0.18 //x=30.315 //y=1.555 //x2=30.2 //y2=1.555
r411 (  94 141 ) resistor r=5.52526 //w=0.168 //l=0.115 //layer=ply \
 //thickness=0.18 //x=30.535 //y=1.555 //x2=30.65 //y2=1.555
r412 (  93 134 ) resistor r=5.52526 //w=0.168 //l=0.115 //layer=ply \
 //thickness=0.18 //x=30.315 //y=0.9 //x2=30.2 //y2=0.9
r413 (  92 140 ) resistor r=5.52526 //w=0.168 //l=0.115 //layer=ply \
 //thickness=0.18 //x=30.535 //y=0.9 //x2=30.65 //y2=0.9
r414 (  92 93 ) resistor r=112.809 //w=0.094 //l=0.22 //layer=ply \
 //thickness=0.18 //x=30.535 //y=0.9 //x2=30.315 //y2=0.9
r415 (  91 137 ) resistor r=58.7805 //w=0.246 //l=0.373497 //layer=ply \
 //thickness=0.18 //x=30.16 //y=2.095 //x2=30.46 //y2=2.26
r416 (  90 135 ) resistor r=39.5823 //w=0.21 //l=0.173853 //layer=ply \
 //thickness=0.18 //x=30.16 //y=1.71 //x2=30.2 //y2=1.555
r417 (  90 91 ) resistor r=197.415 //w=0.094 //l=0.385 //layer=ply \
 //thickness=0.18 //x=30.16 //y=1.71 //x2=30.16 //y2=2.095
r418 (  89 135 ) resistor r=39.5823 //w=0.21 //l=0.173853 //layer=ply \
 //thickness=0.18 //x=30.16 //y=1.4 //x2=30.2 //y2=1.555
r419 (  88 134 ) resistor r=45.1352 //w=0.168 //l=0.173853 //layer=ply \
 //thickness=0.18 //x=30.16 //y=1.055 //x2=30.2 //y2=0.9
r420 (  88 89 ) resistor r=176.904 //w=0.094 //l=0.345 //layer=ply \
 //thickness=0.18 //x=30.16 //y=1.055 //x2=30.16 //y2=1.4
r421 (  83 85 ) resistor r=26.9307 //w=0.15 //l=0.106066 //layer=ply \
 //thickness=0.18 //x=2.165 //y=4.97 //x2=2.24 //y2=5.045
r422 (  83 84 ) resistor r=148.702 //w=0.094 //l=0.29 //layer=ply \
 //thickness=0.18 //x=2.165 //y=4.97 //x2=1.875 //y2=4.97
r423 (  82 133 ) resistor r=45.1352 //w=0.168 //l=0.173853 //layer=ply \
 //thickness=0.18 //x=1.83 //y=1.4 //x2=1.79 //y2=1.555
r424 (  81 132 ) resistor r=45.1352 //w=0.168 //l=0.173853 //layer=ply \
 //thickness=0.18 //x=1.83 //y=1.055 //x2=1.79 //y2=0.9
r425 (  81 82 ) resistor r=176.904 //w=0.094 //l=0.345 //layer=ply \
 //thickness=0.18 //x=1.83 //y=1.055 //x2=1.83 //y2=1.4
r426 (  78 84 ) resistor r=22.7971 //w=0.269 //l=0.106066 //layer=ply \
 //thickness=0.18 //x=1.8 //y=5.045 //x2=1.875 //y2=4.97
r427 (  78 131 ) resistor r=35.8364 //w=0.269 //l=0.270185 //layer=ply \
 //thickness=0.18 //x=1.8 //y=5.045 //x2=1.6 //y2=4.88
r428 (  76 127 ) resistor r=10.701 //w=0.21 //l=0.115 //layer=ply \
 //thickness=0.18 //x=1.455 //y=1.555 //x2=1.34 //y2=1.555
r429 (  75 133 ) resistor r=5.52526 //w=0.168 //l=0.115 //layer=ply \
 //thickness=0.18 //x=1.675 //y=1.555 //x2=1.79 //y2=1.555
r430 (  74 126 ) resistor r=5.52526 //w=0.168 //l=0.115 //layer=ply \
 //thickness=0.18 //x=1.455 //y=0.9 //x2=1.34 //y2=0.9
r431 (  73 132 ) resistor r=5.52526 //w=0.168 //l=0.115 //layer=ply \
 //thickness=0.18 //x=1.675 //y=0.9 //x2=1.79 //y2=0.9
r432 (  73 74 ) resistor r=112.809 //w=0.094 //l=0.22 //layer=ply \
 //thickness=0.18 //x=1.675 //y=0.9 //x2=1.455 //y2=0.9
r433 (  72 129 ) resistor r=58.7805 //w=0.246 //l=0.373497 //layer=ply \
 //thickness=0.18 //x=1.3 //y=2.095 //x2=1.6 //y2=2.26
r434 (  71 127 ) resistor r=39.5823 //w=0.21 //l=0.173853 //layer=ply \
 //thickness=0.18 //x=1.3 //y=1.71 //x2=1.34 //y2=1.555
r435 (  71 72 ) resistor r=197.415 //w=0.094 //l=0.385 //layer=ply \
 //thickness=0.18 //x=1.3 //y=1.71 //x2=1.3 //y2=2.095
r436 (  70 127 ) resistor r=39.5823 //w=0.21 //l=0.173853 //layer=ply \
 //thickness=0.18 //x=1.3 //y=1.4 //x2=1.34 //y2=1.555
r437 (  69 126 ) resistor r=45.1352 //w=0.168 //l=0.173853 //layer=ply \
 //thickness=0.18 //x=1.3 //y=1.055 //x2=1.34 //y2=0.9
r438 (  69 70 ) resistor r=176.904 //w=0.094 //l=0.345 //layer=ply \
 //thickness=0.18 //x=1.3 //y=1.055 //x2=1.3 //y2=1.4
r439 (  68 123 ) resistor r=592.245 //w=0.094 //l=1.155 //layer=ply \
 //thickness=0.18 //x=59.96 //y=6.2 //x2=59.96 //y2=5.045
r440 (  67 116 ) resistor r=592.245 //w=0.094 //l=1.155 //layer=ply \
 //thickness=0.18 //x=59.52 //y=6.2 //x2=59.52 //y2=5.045
r441 (  66 104 ) resistor r=592.245 //w=0.094 //l=1.155 //layer=ply \
 //thickness=0.18 //x=31.1 //y=6.2 //x2=31.1 //y2=5.045
r442 (  65 97 ) resistor r=592.245 //w=0.094 //l=1.155 //layer=ply \
 //thickness=0.18 //x=30.66 //y=6.2 //x2=30.66 //y2=5.045
r443 (  64 85 ) resistor r=592.245 //w=0.094 //l=1.155 //layer=ply \
 //thickness=0.18 //x=2.24 //y=6.2 //x2=2.24 //y2=5.045
r444 (  63 78 ) resistor r=592.245 //w=0.094 //l=1.155 //layer=ply \
 //thickness=0.18 //x=1.8 //y=6.2 //x2=1.8 //y2=5.045
r445 (  62 113 ) resistor r=56.4043 //w=0.094 //l=0.11 //layer=ply \
 //thickness=0.18 //x=59.285 //y=1.555 //x2=59.395 //y2=1.555
r446 (  62 114 ) resistor r=56.4043 //w=0.094 //l=0.11 //layer=ply \
 //thickness=0.18 //x=59.285 //y=1.555 //x2=59.175 //y2=1.555
r447 (  61 94 ) resistor r=56.4043 //w=0.094 //l=0.11 //layer=ply \
 //thickness=0.18 //x=30.425 //y=1.555 //x2=30.535 //y2=1.555
r448 (  61 95 ) resistor r=56.4043 //w=0.094 //l=0.11 //layer=ply \
 //thickness=0.18 //x=30.425 //y=1.555 //x2=30.315 //y2=1.555
r449 (  60 75 ) resistor r=56.4043 //w=0.094 //l=0.11 //layer=ply \
 //thickness=0.18 //x=1.565 //y=1.555 //x2=1.675 //y2=1.555
r450 (  60 76 ) resistor r=56.4043 //w=0.094 //l=0.11 //layer=ply \
 //thickness=0.18 //x=1.565 //y=1.555 //x2=1.455 //y2=1.555
r451 (  58 147 ) resistor r=152 //w=0.17 //l=0.17 //layer=licon //count=1 \
 //x=59.32 //y=4.88 //x2=59.32 //y2=4.88
r452 (  51 145 ) resistor r=152 //w=0.17 //l=0.17 //layer=licon //count=1 \
 //x=59.32 //y=2.26 //x2=59.32 //y2=2.26
r453 (  48 139 ) resistor r=152 //w=0.17 //l=0.17 //layer=licon //count=1 \
 //x=30.46 //y=4.88 //x2=30.46 //y2=4.88
r454 (  40 137 ) resistor r=152 //w=0.17 //l=0.17 //layer=licon //count=1 \
 //x=30.46 //y=2.26 //x2=30.46 //y2=2.26
r455 (  37 131 ) resistor r=152 //w=0.17 //l=0.17 //layer=licon //count=1 \
 //x=1.6 //y=4.88 //x2=1.6 //y2=4.88
r456 (  26 129 ) resistor r=152 //w=0.17 //l=0.17 //layer=licon //count=1 \
 //x=1.6 //y=2.26 //x2=1.6 //y2=2.26
r457 (  24 58 ) resistor r=43.123 //w=0.187 //l=0.63 //layer=li \
 //thickness=0.1 //x=59.32 //y=4.25 //x2=59.32 //y2=4.88
r458 (  23 24 ) resistor r=50.6524 //w=0.187 //l=0.74 //layer=li \
 //thickness=0.1 //x=59.32 //y=3.51 //x2=59.32 //y2=4.25
r459 (  22 23 ) resistor r=50.6524 //w=0.187 //l=0.74 //layer=li \
 //thickness=0.1 //x=59.32 //y=2.77 //x2=59.32 //y2=3.51
r460 (  22 51 ) resistor r=34.9091 //w=0.187 //l=0.51 //layer=li \
 //thickness=0.1 //x=59.32 //y=2.77 //x2=59.32 //y2=2.26
r461 (  21 48 ) resistor r=43.123 //w=0.187 //l=0.63 //layer=li \
 //thickness=0.1 //x=30.46 //y=4.25 //x2=30.46 //y2=4.88
r462 (  20 21 ) resistor r=25.3262 //w=0.187 //l=0.37 //layer=li \
 //thickness=0.1 //x=30.46 //y=3.88 //x2=30.46 //y2=4.25
r463 (  19 20 ) resistor r=25.3262 //w=0.187 //l=0.37 //layer=li \
 //thickness=0.1 //x=30.46 //y=3.51 //x2=30.46 //y2=3.88
r464 (  18 19 ) resistor r=50.6524 //w=0.187 //l=0.74 //layer=li \
 //thickness=0.1 //x=30.46 //y=2.77 //x2=30.46 //y2=3.51
r465 (  18 40 ) resistor r=34.9091 //w=0.187 //l=0.51 //layer=li \
 //thickness=0.1 //x=30.46 //y=2.77 //x2=30.46 //y2=2.26
r466 (  17 37 ) resistor r=17.7968 //w=0.187 //l=0.26 //layer=li \
 //thickness=0.1 //x=1.6 //y=4.62 //x2=1.6 //y2=4.88
r467 (  16 17 ) resistor r=25.3262 //w=0.187 //l=0.37 //layer=li \
 //thickness=0.1 //x=1.6 //y=4.25 //x2=1.6 //y2=4.62
r468 (  15 16 ) resistor r=25.3262 //w=0.187 //l=0.37 //layer=li \
 //thickness=0.1 //x=1.6 //y=3.88 //x2=1.6 //y2=4.25
r469 (  14 15 ) resistor r=25.3262 //w=0.187 //l=0.37 //layer=li \
 //thickness=0.1 //x=1.6 //y=3.51 //x2=1.6 //y2=3.88
r470 (  13 14 ) resistor r=25.3262 //w=0.187 //l=0.37 //layer=li \
 //thickness=0.1 //x=1.6 //y=3.14 //x2=1.6 //y2=3.51
r471 (  12 13 ) resistor r=25.3262 //w=0.187 //l=0.37 //layer=li \
 //thickness=0.1 //x=1.6 //y=2.77 //x2=1.6 //y2=3.14
r472 (  11 12 ) resistor r=25.3262 //w=0.187 //l=0.37 //layer=li \
 //thickness=0.1 //x=1.6 //y=2.4 //x2=1.6 //y2=2.77
r473 (  11 26 ) resistor r=9.58289 //w=0.187 //l=0.14 //layer=li \
 //thickness=0.1 //x=1.6 //y=2.4 //x2=1.6 //y2=2.26
r474 (  10 24 ) resistor r=9.3 //w=0.17 //l=0.17 //layer=mcon //count=1 \
 //x=59.32 //y=4.25 //x2=59.32 //y2=4.25
r475 (  8 21 ) resistor r=9.3 //w=0.17 //l=0.17 //layer=mcon //count=1 \
 //x=30.46 //y=4.25 //x2=30.46 //y2=4.25
r476 (  6 16 ) resistor r=9.3 //w=0.17 //l=0.17 //layer=mcon //count=1 //x=1.6 \
 //y=4.25 //x2=1.6 //y2=4.25
r477 (  4 8 ) resistor r=0.0880901 //w=0.191 //l=0.115 //layer=m1 \
 //thickness=0.36 //x=30.575 //y=4.25 //x2=30.46 //y2=4.25
r478 (  3 10 ) resistor r=0.0717383 //w=0.224 //l=0.115 //layer=m1 \
 //thickness=0.36 //x=59.205 //y=4.25 //x2=59.32 //y2=4.25
r479 (  3 4 ) resistor r=27.3187 //w=0.131 //l=28.63 //layer=m1 \
 //thickness=0.36 //x=59.205 //y=4.25 //x2=30.575 //y2=4.25
r480 (  2 6 ) resistor r=0.0738079 //w=0.207 //l=0.115 //layer=m1 \
 //thickness=0.36 //x=1.715 //y=4.25 //x2=1.6 //y2=4.25
r481 (  1 8 ) resistor r=0.0880901 //w=0.191 //l=0.115 //layer=m1 \
 //thickness=0.36 //x=30.345 //y=4.25 //x2=30.46 //y2=4.25
r482 (  1 2 ) resistor r=27.3187 //w=0.131 //l=28.63 //layer=m1 \
 //thickness=0.36 //x=30.345 //y=4.25 //x2=1.715 //y2=4.25
ends PM_TMRDFFSNRNQNX1\%D

subckt PM_TMRDFFSNRNQNX1\%noxref_15 ( 1 2 3 4 17 18 25 33 39 40 44 46 54 61 62 \
 63 64 65 66 67 68 69 70 71 72 73 75 81 82 83 84 88 89 90 91 92 94 100 101 102 \
 103 123 125 126 127 )
c253 ( 127 0 ) capacitor c=0.023087f //x=61.355 //y=5.2
c254 ( 126 0 ) capacitor c=0.023519f //x=60.475 //y=5.2
c255 ( 125 0 ) capacitor c=0.0224735f //x=59.595 //y=5.2
c256 ( 123 0 ) capacitor c=0.00853354f //x=61.605 //y=1.095
c257 ( 103 0 ) capacitor c=0.0547611f //x=69.215 //y=4.97
c258 ( 102 0 ) capacitor c=0.0294456f //x=69.505 //y=4.97
c259 ( 101 0 ) capacitor c=0.0347816f //x=69.17 //y=1.4
c260 ( 100 0 ) capacitor c=0.0187487f //x=69.17 //y=1.055
c261 ( 94 0 ) capacitor c=0.0137055f //x=69.015 //y=1.555
c262 ( 92 0 ) capacitor c=0.0149861f //x=69.015 //y=0.9
c263 ( 91 0 ) capacitor c=0.096037f //x=68.64 //y=2.095
c264 ( 90 0 ) capacitor c=0.0228993f //x=68.64 //y=1.71
c265 ( 89 0 ) capacitor c=0.0234352f //x=68.64 //y=1.4
c266 ( 88 0 ) capacitor c=0.0198724f //x=68.64 //y=1.055
c267 ( 84 0 ) capacitor c=0.0549166f //x=64.405 //y=4.97
c268 ( 83 0 ) capacitor c=0.0294456f //x=64.695 //y=4.97
c269 ( 82 0 ) capacitor c=0.0347816f //x=64.36 //y=1.4
c270 ( 81 0 ) capacitor c=0.0187487f //x=64.36 //y=1.055
c271 ( 75 0 ) capacitor c=0.0137055f //x=64.205 //y=1.555
c272 ( 73 0 ) capacitor c=0.0149861f //x=64.205 //y=0.9
c273 ( 72 0 ) capacitor c=0.096037f //x=63.83 //y=2.095
c274 ( 71 0 ) capacitor c=0.0228993f //x=63.83 //y=1.71
c275 ( 70 0 ) capacitor c=0.0234352f //x=63.83 //y=1.4
c276 ( 69 0 ) capacitor c=0.0198724f //x=63.83 //y=1.055
c277 ( 68 0 ) capacitor c=0.109949f //x=69.58 //y=6.2
c278 ( 67 0 ) capacitor c=0.158483f //x=69.14 //y=6.2
c279 ( 66 0 ) capacitor c=0.109949f //x=64.77 //y=6.2
c280 ( 65 0 ) capacitor c=0.158483f //x=64.33 //y=6.2
c281 ( 62 0 ) capacitor c=9.74268e-19 //x=61.5 //y=5.335
c282 ( 61 0 ) capacitor c=0.00191414f //x=60.62 //y=5.335
c283 ( 54 0 ) capacitor c=0.0913827f //x=68.94 //y=2.26
c284 ( 46 0 ) capacitor c=0.093372f //x=64.13 //y=2.26
c285 ( 44 0 ) capacitor c=0.105725f //x=62.28 //y=2.77
c286 ( 40 0 ) capacitor c=0.00398962f //x=61.88 //y=1.845
c287 ( 39 0 ) capacitor c=0.0137288f //x=62.195 //y=1.845
c288 ( 33 0 ) capacitor c=0.0276208f //x=62.195 //y=5.335
c289 ( 25 0 ) capacitor c=0.0169868f //x=61.415 //y=5.335
c290 ( 18 0 ) capacitor c=0.00316998f //x=59.825 //y=5.335
c291 ( 17 0 ) capacitor c=0.014258f //x=60.535 //y=5.335
c292 ( 4 0 ) capacitor c=0.00401138f //x=64.245 //y=2.77
c293 ( 3 0 ) capacitor c=0.0706637f //x=68.825 //y=2.77
c294 ( 2 0 ) capacitor c=0.0120752f //x=62.395 //y=2.77
c295 ( 1 0 ) capacitor c=0.0233554f //x=64.015 //y=2.77
r296 (  102 104 ) resistor r=26.9307 //w=0.15 //l=0.106066 //layer=ply \
 //thickness=0.18 //x=69.505 //y=4.97 //x2=69.58 //y2=5.045
r297 (  102 103 ) resistor r=148.702 //w=0.094 //l=0.29 //layer=ply \
 //thickness=0.18 //x=69.505 //y=4.97 //x2=69.215 //y2=4.97
r298 (  101 122 ) resistor r=45.1352 //w=0.168 //l=0.173853 //layer=ply \
 //thickness=0.18 //x=69.17 //y=1.4 //x2=69.13 //y2=1.555
r299 (  100 121 ) resistor r=45.1352 //w=0.168 //l=0.173853 //layer=ply \
 //thickness=0.18 //x=69.17 //y=1.055 //x2=69.13 //y2=0.9
r300 (  100 101 ) resistor r=176.904 //w=0.094 //l=0.345 //layer=ply \
 //thickness=0.18 //x=69.17 //y=1.055 //x2=69.17 //y2=1.4
r301 (  97 103 ) resistor r=22.7971 //w=0.269 //l=0.106066 //layer=ply \
 //thickness=0.18 //x=69.14 //y=5.045 //x2=69.215 //y2=4.97
r302 (  97 120 ) resistor r=35.8364 //w=0.269 //l=0.270185 //layer=ply \
 //thickness=0.18 //x=69.14 //y=5.045 //x2=68.94 //y2=4.88
r303 (  95 116 ) resistor r=10.701 //w=0.21 //l=0.115 //layer=ply \
 //thickness=0.18 //x=68.795 //y=1.555 //x2=68.68 //y2=1.555
r304 (  94 122 ) resistor r=5.52526 //w=0.168 //l=0.115 //layer=ply \
 //thickness=0.18 //x=69.015 //y=1.555 //x2=69.13 //y2=1.555
r305 (  93 115 ) resistor r=5.52526 //w=0.168 //l=0.115 //layer=ply \
 //thickness=0.18 //x=68.795 //y=0.9 //x2=68.68 //y2=0.9
r306 (  92 121 ) resistor r=5.52526 //w=0.168 //l=0.115 //layer=ply \
 //thickness=0.18 //x=69.015 //y=0.9 //x2=69.13 //y2=0.9
r307 (  92 93 ) resistor r=112.809 //w=0.094 //l=0.22 //layer=ply \
 //thickness=0.18 //x=69.015 //y=0.9 //x2=68.795 //y2=0.9
r308 (  91 118 ) resistor r=58.7805 //w=0.246 //l=0.373497 //layer=ply \
 //thickness=0.18 //x=68.64 //y=2.095 //x2=68.94 //y2=2.26
r309 (  90 116 ) resistor r=39.5823 //w=0.21 //l=0.173853 //layer=ply \
 //thickness=0.18 //x=68.64 //y=1.71 //x2=68.68 //y2=1.555
r310 (  90 91 ) resistor r=197.415 //w=0.094 //l=0.385 //layer=ply \
 //thickness=0.18 //x=68.64 //y=1.71 //x2=68.64 //y2=2.095
r311 (  89 116 ) resistor r=39.5823 //w=0.21 //l=0.173853 //layer=ply \
 //thickness=0.18 //x=68.64 //y=1.4 //x2=68.68 //y2=1.555
r312 (  88 115 ) resistor r=45.1352 //w=0.168 //l=0.173853 //layer=ply \
 //thickness=0.18 //x=68.64 //y=1.055 //x2=68.68 //y2=0.9
r313 (  88 89 ) resistor r=176.904 //w=0.094 //l=0.345 //layer=ply \
 //thickness=0.18 //x=68.64 //y=1.055 //x2=68.64 //y2=1.4
r314 (  83 85 ) resistor r=26.9307 //w=0.15 //l=0.106066 //layer=ply \
 //thickness=0.18 //x=64.695 //y=4.97 //x2=64.77 //y2=5.045
r315 (  83 84 ) resistor r=148.702 //w=0.094 //l=0.29 //layer=ply \
 //thickness=0.18 //x=64.695 //y=4.97 //x2=64.405 //y2=4.97
r316 (  82 114 ) resistor r=45.1352 //w=0.168 //l=0.173853 //layer=ply \
 //thickness=0.18 //x=64.36 //y=1.4 //x2=64.32 //y2=1.555
r317 (  81 113 ) resistor r=45.1352 //w=0.168 //l=0.173853 //layer=ply \
 //thickness=0.18 //x=64.36 //y=1.055 //x2=64.32 //y2=0.9
r318 (  81 82 ) resistor r=176.904 //w=0.094 //l=0.345 //layer=ply \
 //thickness=0.18 //x=64.36 //y=1.055 //x2=64.36 //y2=1.4
r319 (  78 84 ) resistor r=22.7971 //w=0.269 //l=0.106066 //layer=ply \
 //thickness=0.18 //x=64.33 //y=5.045 //x2=64.405 //y2=4.97
r320 (  78 112 ) resistor r=35.8364 //w=0.269 //l=0.270185 //layer=ply \
 //thickness=0.18 //x=64.33 //y=5.045 //x2=64.13 //y2=4.88
r321 (  76 108 ) resistor r=10.701 //w=0.21 //l=0.115 //layer=ply \
 //thickness=0.18 //x=63.985 //y=1.555 //x2=63.87 //y2=1.555
r322 (  75 114 ) resistor r=5.52526 //w=0.168 //l=0.115 //layer=ply \
 //thickness=0.18 //x=64.205 //y=1.555 //x2=64.32 //y2=1.555
r323 (  74 107 ) resistor r=5.52526 //w=0.168 //l=0.115 //layer=ply \
 //thickness=0.18 //x=63.985 //y=0.9 //x2=63.87 //y2=0.9
r324 (  73 113 ) resistor r=5.52526 //w=0.168 //l=0.115 //layer=ply \
 //thickness=0.18 //x=64.205 //y=0.9 //x2=64.32 //y2=0.9
r325 (  73 74 ) resistor r=112.809 //w=0.094 //l=0.22 //layer=ply \
 //thickness=0.18 //x=64.205 //y=0.9 //x2=63.985 //y2=0.9
r326 (  72 110 ) resistor r=58.7805 //w=0.246 //l=0.373497 //layer=ply \
 //thickness=0.18 //x=63.83 //y=2.095 //x2=64.13 //y2=2.26
r327 (  71 108 ) resistor r=39.5823 //w=0.21 //l=0.173853 //layer=ply \
 //thickness=0.18 //x=63.83 //y=1.71 //x2=63.87 //y2=1.555
r328 (  71 72 ) resistor r=197.415 //w=0.094 //l=0.385 //layer=ply \
 //thickness=0.18 //x=63.83 //y=1.71 //x2=63.83 //y2=2.095
r329 (  70 108 ) resistor r=39.5823 //w=0.21 //l=0.173853 //layer=ply \
 //thickness=0.18 //x=63.83 //y=1.4 //x2=63.87 //y2=1.555
r330 (  69 107 ) resistor r=45.1352 //w=0.168 //l=0.173853 //layer=ply \
 //thickness=0.18 //x=63.83 //y=1.055 //x2=63.87 //y2=0.9
r331 (  69 70 ) resistor r=176.904 //w=0.094 //l=0.345 //layer=ply \
 //thickness=0.18 //x=63.83 //y=1.055 //x2=63.83 //y2=1.4
r332 (  68 104 ) resistor r=592.245 //w=0.094 //l=1.155 //layer=ply \
 //thickness=0.18 //x=69.58 //y=6.2 //x2=69.58 //y2=5.045
r333 (  67 97 ) resistor r=592.245 //w=0.094 //l=1.155 //layer=ply \
 //thickness=0.18 //x=69.14 //y=6.2 //x2=69.14 //y2=5.045
r334 (  66 85 ) resistor r=592.245 //w=0.094 //l=1.155 //layer=ply \
 //thickness=0.18 //x=64.77 //y=6.2 //x2=64.77 //y2=5.045
r335 (  65 78 ) resistor r=592.245 //w=0.094 //l=1.155 //layer=ply \
 //thickness=0.18 //x=64.33 //y=6.2 //x2=64.33 //y2=5.045
r336 (  64 94 ) resistor r=56.4043 //w=0.094 //l=0.11 //layer=ply \
 //thickness=0.18 //x=68.905 //y=1.555 //x2=69.015 //y2=1.555
r337 (  64 95 ) resistor r=56.4043 //w=0.094 //l=0.11 //layer=ply \
 //thickness=0.18 //x=68.905 //y=1.555 //x2=68.795 //y2=1.555
r338 (  63 75 ) resistor r=56.4043 //w=0.094 //l=0.11 //layer=ply \
 //thickness=0.18 //x=64.095 //y=1.555 //x2=64.205 //y2=1.555
r339 (  63 76 ) resistor r=56.4043 //w=0.094 //l=0.11 //layer=ply \
 //thickness=0.18 //x=64.095 //y=1.555 //x2=63.985 //y2=1.555
r340 (  59 120 ) resistor r=152 //w=0.17 //l=0.17 //layer=licon //count=1 \
 //x=68.94 //y=4.88 //x2=68.94 //y2=4.88
r341 (  57 59 ) resistor r=144.428 //w=0.187 //l=2.11 //layer=li \
 //thickness=0.1 //x=68.94 //y=2.77 //x2=68.94 //y2=4.88
r342 (  54 118 ) resistor r=152 //w=0.17 //l=0.17 //layer=licon //count=1 \
 //x=68.94 //y=2.26 //x2=68.94 //y2=2.26
r343 (  54 57 ) resistor r=34.9091 //w=0.187 //l=0.51 //layer=li \
 //thickness=0.1 //x=68.94 //y=2.26 //x2=68.94 //y2=2.77
r344 (  51 112 ) resistor r=152 //w=0.17 //l=0.17 //layer=licon //count=1 \
 //x=64.13 //y=4.88 //x2=64.13 //y2=4.88
r345 (  49 51 ) resistor r=144.428 //w=0.187 //l=2.11 //layer=li \
 //thickness=0.1 //x=64.13 //y=2.77 //x2=64.13 //y2=4.88
r346 (  46 110 ) resistor r=152 //w=0.17 //l=0.17 //layer=licon //count=1 \
 //x=64.13 //y=2.26 //x2=64.13 //y2=2.26
r347 (  46 49 ) resistor r=34.9091 //w=0.187 //l=0.51 //layer=li \
 //thickness=0.1 //x=64.13 //y=2.26 //x2=64.13 //y2=2.77
r348 (  42 44 ) resistor r=169.754 //w=0.187 //l=2.48 //layer=li \
 //thickness=0.1 //x=62.28 //y=5.25 //x2=62.28 //y2=2.77
r349 (  41 44 ) resistor r=57.4973 //w=0.187 //l=0.84 //layer=li \
 //thickness=0.1 //x=62.28 //y=1.93 //x2=62.28 //y2=2.77
r350 (  39 41 ) resistor r=7.15173 //w=0.17 //l=0.120208 //layer=li \
 //thickness=0.1 //x=62.195 //y=1.845 //x2=62.28 //y2=1.93
r351 (  39 40 ) resistor r=21.5615 //w=0.187 //l=0.315 //layer=li \
 //thickness=0.1 //x=62.195 //y=1.845 //x2=61.88 //y2=1.845
r352 (  35 40 ) resistor r=7.15173 //w=0.17 //l=0.120208 //layer=li \
 //thickness=0.1 //x=61.795 //y=1.76 //x2=61.88 //y2=1.845
r353 (  35 123 ) resistor r=39.016 //w=0.187 //l=0.57 //layer=li \
 //thickness=0.1 //x=61.795 //y=1.76 //x2=61.795 //y2=1.19
r354 (  34 62 ) resistor r=5.4201 //w=0.17 //l=0.085 //layer=li \
 //thickness=0.1 //x=61.585 //y=5.335 //x2=61.5 //y2=5.335
r355 (  33 42 ) resistor r=7.15173 //w=0.17 //l=0.120208 //layer=li \
 //thickness=0.1 //x=62.195 //y=5.335 //x2=62.28 //y2=5.25
r356 (  33 34 ) resistor r=41.754 //w=0.187 //l=0.61 //layer=li \
 //thickness=0.1 //x=62.195 //y=5.335 //x2=61.585 //y2=5.335
r357 (  27 62 ) resistor r=1.40859 //w=0.34 //l=0.085 //layer=li \
 //thickness=0.1 //x=61.5 //y=5.42 //x2=61.5 //y2=5.335
r358 (  27 127 ) resistor r=33.1979 //w=0.187 //l=0.485 //layer=li \
 //thickness=0.1 //x=61.5 //y=5.42 //x2=61.5 //y2=5.905
r359 (  26 61 ) resistor r=5.4201 //w=0.17 //l=0.085 //layer=li \
 //thickness=0.1 //x=60.705 //y=5.335 //x2=60.62 //y2=5.335
r360 (  25 62 ) resistor r=5.4201 //w=0.17 //l=0.085 //layer=li \
 //thickness=0.1 //x=61.415 //y=5.335 //x2=61.5 //y2=5.335
r361 (  25 26 ) resistor r=48.5989 //w=0.187 //l=0.71 //layer=li \
 //thickness=0.1 //x=61.415 //y=5.335 //x2=60.705 //y2=5.335
r362 (  19 61 ) resistor r=1.40859 //w=0.34 //l=0.085 //layer=li \
 //thickness=0.1 //x=60.62 //y=5.42 //x2=60.62 //y2=5.335
r363 (  19 126 ) resistor r=33.1979 //w=0.187 //l=0.485 //layer=li \
 //thickness=0.1 //x=60.62 //y=5.42 //x2=60.62 //y2=5.905
r364 (  17 61 ) resistor r=5.4201 //w=0.17 //l=0.085 //layer=li \
 //thickness=0.1 //x=60.535 //y=5.335 //x2=60.62 //y2=5.335
r365 (  17 18 ) resistor r=48.5989 //w=0.187 //l=0.71 //layer=li \
 //thickness=0.1 //x=60.535 //y=5.335 //x2=59.825 //y2=5.335
r366 (  11 18 ) resistor r=7.15173 //w=0.17 //l=0.120208 //layer=li \
 //thickness=0.1 //x=59.74 //y=5.42 //x2=59.825 //y2=5.335
r367 (  11 125 ) resistor r=33.1979 //w=0.187 //l=0.485 //layer=li \
 //thickness=0.1 //x=59.74 //y=5.42 //x2=59.74 //y2=5.905
r368 (  10 57 ) resistor r=9.3 //w=0.17 //l=0.17 //layer=mcon //count=1 \
 //x=68.94 //y=2.77 //x2=68.94 //y2=2.77
r369 (  8 49 ) resistor r=9.3 //w=0.17 //l=0.17 //layer=mcon //count=1 \
 //x=64.13 //y=2.77 //x2=64.13 //y2=2.77
r370 (  6 44 ) resistor r=9.3 //w=0.17 //l=0.17 //layer=mcon //count=1 \
 //x=62.28 //y=2.77 //x2=62.28 //y2=2.77
r371 (  4 8 ) resistor r=0.0880901 //w=0.191 //l=0.115 //layer=m1 \
 //thickness=0.36 //x=64.245 //y=2.77 //x2=64.13 //y2=2.77
r372 (  3 10 ) resistor r=0.0717383 //w=0.224 //l=0.115 //layer=m1 \
 //thickness=0.36 //x=68.825 //y=2.77 //x2=68.94 //y2=2.77
r373 (  3 4 ) resistor r=4.37023 //w=0.131 //l=4.58 //layer=m1 \
 //thickness=0.36 //x=68.825 //y=2.77 //x2=64.245 //y2=2.77
r374 (  2 6 ) resistor r=0.0717383 //w=0.224 //l=0.115 //layer=m1 \
 //thickness=0.36 //x=62.395 //y=2.77 //x2=62.28 //y2=2.77
r375 (  1 8 ) resistor r=0.0880901 //w=0.191 //l=0.115 //layer=m1 \
 //thickness=0.36 //x=64.015 //y=2.77 //x2=64.13 //y2=2.77
r376 (  1 2 ) resistor r=1.5458 //w=0.131 //l=1.62 //layer=m1 //thickness=0.36 \
 //x=64.015 //y=2.77 //x2=62.395 //y2=2.77
ends PM_TMRDFFSNRNQNX1\%noxref_15

subckt PM_TMRDFFSNRNQNX1\%noxref_16 ( 1 2 13 14 21 29 35 36 40 42 49 50 51 52 \
 53 54 55 56 57 58 60 66 67 68 69 81 83 84 85 )
c168 ( 85 0 ) capacitor c=0.023087f //x=70.975 //y=5.2
c169 ( 84 0 ) capacitor c=0.023519f //x=70.095 //y=5.2
c170 ( 83 0 ) capacitor c=0.0224735f //x=69.215 //y=5.2
c171 ( 81 0 ) capacitor c=0.00853354f //x=71.225 //y=1.095
c172 ( 69 0 ) capacitor c=0.0547611f //x=74.025 //y=4.97
c173 ( 68 0 ) capacitor c=0.0294456f //x=74.315 //y=4.97
c174 ( 67 0 ) capacitor c=0.0347816f //x=73.98 //y=1.4
c175 ( 66 0 ) capacitor c=0.0187487f //x=73.98 //y=1.055
c176 ( 60 0 ) capacitor c=0.0137055f //x=73.825 //y=1.555
c177 ( 58 0 ) capacitor c=0.0149861f //x=73.825 //y=0.9
c178 ( 57 0 ) capacitor c=0.096037f //x=73.45 //y=2.095
c179 ( 56 0 ) capacitor c=0.0228993f //x=73.45 //y=1.71
c180 ( 55 0 ) capacitor c=0.0234352f //x=73.45 //y=1.4
c181 ( 54 0 ) capacitor c=0.0198724f //x=73.45 //y=1.055
c182 ( 53 0 ) capacitor c=0.109949f //x=74.39 //y=6.2
c183 ( 52 0 ) capacitor c=0.158483f //x=73.95 //y=6.2
c184 ( 50 0 ) capacitor c=9.74268e-19 //x=71.12 //y=5.335
c185 ( 49 0 ) capacitor c=0.00191414f //x=70.24 //y=5.335
c186 ( 42 0 ) capacitor c=0.0911502f //x=73.75 //y=2.26
c187 ( 40 0 ) capacitor c=0.103494f //x=71.9 //y=2.77
c188 ( 36 0 ) capacitor c=0.00398962f //x=71.5 //y=1.845
c189 ( 35 0 ) capacitor c=0.0137288f //x=71.815 //y=1.845
c190 ( 29 0 ) capacitor c=0.0276208f //x=71.815 //y=5.335
c191 ( 21 0 ) capacitor c=0.0169868f //x=71.035 //y=5.335
c192 ( 14 0 ) capacitor c=0.00316998f //x=69.445 //y=5.335
c193 ( 13 0 ) capacitor c=0.014258f //x=70.155 //y=5.335
c194 ( 2 0 ) capacitor c=0.00808366f //x=72.015 //y=2.77
c195 ( 1 0 ) capacitor c=0.0351856f //x=73.635 //y=2.77
r196 (  68 70 ) resistor r=26.9307 //w=0.15 //l=0.106066 //layer=ply \
 //thickness=0.18 //x=74.315 //y=4.97 //x2=74.39 //y2=5.045
r197 (  68 69 ) resistor r=148.702 //w=0.094 //l=0.29 //layer=ply \
 //thickness=0.18 //x=74.315 //y=4.97 //x2=74.025 //y2=4.97
r198 (  67 80 ) resistor r=45.1352 //w=0.168 //l=0.173853 //layer=ply \
 //thickness=0.18 //x=73.98 //y=1.4 //x2=73.94 //y2=1.555
r199 (  66 79 ) resistor r=45.1352 //w=0.168 //l=0.173853 //layer=ply \
 //thickness=0.18 //x=73.98 //y=1.055 //x2=73.94 //y2=0.9
r200 (  66 67 ) resistor r=176.904 //w=0.094 //l=0.345 //layer=ply \
 //thickness=0.18 //x=73.98 //y=1.055 //x2=73.98 //y2=1.4
r201 (  63 69 ) resistor r=22.7971 //w=0.269 //l=0.106066 //layer=ply \
 //thickness=0.18 //x=73.95 //y=5.045 //x2=74.025 //y2=4.97
r202 (  63 78 ) resistor r=35.8364 //w=0.269 //l=0.270185 //layer=ply \
 //thickness=0.18 //x=73.95 //y=5.045 //x2=73.75 //y2=4.88
r203 (  61 74 ) resistor r=10.701 //w=0.21 //l=0.115 //layer=ply \
 //thickness=0.18 //x=73.605 //y=1.555 //x2=73.49 //y2=1.555
r204 (  60 80 ) resistor r=5.52526 //w=0.168 //l=0.115 //layer=ply \
 //thickness=0.18 //x=73.825 //y=1.555 //x2=73.94 //y2=1.555
r205 (  59 73 ) resistor r=5.52526 //w=0.168 //l=0.115 //layer=ply \
 //thickness=0.18 //x=73.605 //y=0.9 //x2=73.49 //y2=0.9
r206 (  58 79 ) resistor r=5.52526 //w=0.168 //l=0.115 //layer=ply \
 //thickness=0.18 //x=73.825 //y=0.9 //x2=73.94 //y2=0.9
r207 (  58 59 ) resistor r=112.809 //w=0.094 //l=0.22 //layer=ply \
 //thickness=0.18 //x=73.825 //y=0.9 //x2=73.605 //y2=0.9
r208 (  57 76 ) resistor r=58.7805 //w=0.246 //l=0.373497 //layer=ply \
 //thickness=0.18 //x=73.45 //y=2.095 //x2=73.75 //y2=2.26
r209 (  56 74 ) resistor r=39.5823 //w=0.21 //l=0.173853 //layer=ply \
 //thickness=0.18 //x=73.45 //y=1.71 //x2=73.49 //y2=1.555
r210 (  56 57 ) resistor r=197.415 //w=0.094 //l=0.385 //layer=ply \
 //thickness=0.18 //x=73.45 //y=1.71 //x2=73.45 //y2=2.095
r211 (  55 74 ) resistor r=39.5823 //w=0.21 //l=0.173853 //layer=ply \
 //thickness=0.18 //x=73.45 //y=1.4 //x2=73.49 //y2=1.555
r212 (  54 73 ) resistor r=45.1352 //w=0.168 //l=0.173853 //layer=ply \
 //thickness=0.18 //x=73.45 //y=1.055 //x2=73.49 //y2=0.9
r213 (  54 55 ) resistor r=176.904 //w=0.094 //l=0.345 //layer=ply \
 //thickness=0.18 //x=73.45 //y=1.055 //x2=73.45 //y2=1.4
r214 (  53 70 ) resistor r=592.245 //w=0.094 //l=1.155 //layer=ply \
 //thickness=0.18 //x=74.39 //y=6.2 //x2=74.39 //y2=5.045
r215 (  52 63 ) resistor r=592.245 //w=0.094 //l=1.155 //layer=ply \
 //thickness=0.18 //x=73.95 //y=6.2 //x2=73.95 //y2=5.045
r216 (  51 60 ) resistor r=56.4043 //w=0.094 //l=0.11 //layer=ply \
 //thickness=0.18 //x=73.715 //y=1.555 //x2=73.825 //y2=1.555
r217 (  51 61 ) resistor r=56.4043 //w=0.094 //l=0.11 //layer=ply \
 //thickness=0.18 //x=73.715 //y=1.555 //x2=73.605 //y2=1.555
r218 (  47 78 ) resistor r=152 //w=0.17 //l=0.17 //layer=licon //count=1 \
 //x=73.75 //y=4.88 //x2=73.75 //y2=4.88
r219 (  45 47 ) resistor r=144.428 //w=0.187 //l=2.11 //layer=li \
 //thickness=0.1 //x=73.75 //y=2.77 //x2=73.75 //y2=4.88
r220 (  42 76 ) resistor r=152 //w=0.17 //l=0.17 //layer=licon //count=1 \
 //x=73.75 //y=2.26 //x2=73.75 //y2=2.26
r221 (  42 45 ) resistor r=34.9091 //w=0.187 //l=0.51 //layer=li \
 //thickness=0.1 //x=73.75 //y=2.26 //x2=73.75 //y2=2.77
r222 (  38 40 ) resistor r=169.754 //w=0.187 //l=2.48 //layer=li \
 //thickness=0.1 //x=71.9 //y=5.25 //x2=71.9 //y2=2.77
r223 (  37 40 ) resistor r=57.4973 //w=0.187 //l=0.84 //layer=li \
 //thickness=0.1 //x=71.9 //y=1.93 //x2=71.9 //y2=2.77
r224 (  35 37 ) resistor r=7.15173 //w=0.17 //l=0.120208 //layer=li \
 //thickness=0.1 //x=71.815 //y=1.845 //x2=71.9 //y2=1.93
r225 (  35 36 ) resistor r=21.5615 //w=0.187 //l=0.315 //layer=li \
 //thickness=0.1 //x=71.815 //y=1.845 //x2=71.5 //y2=1.845
r226 (  31 36 ) resistor r=7.15173 //w=0.17 //l=0.120208 //layer=li \
 //thickness=0.1 //x=71.415 //y=1.76 //x2=71.5 //y2=1.845
r227 (  31 81 ) resistor r=39.016 //w=0.187 //l=0.57 //layer=li \
 //thickness=0.1 //x=71.415 //y=1.76 //x2=71.415 //y2=1.19
r228 (  30 50 ) resistor r=5.4201 //w=0.17 //l=0.085 //layer=li \
 //thickness=0.1 //x=71.205 //y=5.335 //x2=71.12 //y2=5.335
r229 (  29 38 ) resistor r=7.15173 //w=0.17 //l=0.120208 //layer=li \
 //thickness=0.1 //x=71.815 //y=5.335 //x2=71.9 //y2=5.25
r230 (  29 30 ) resistor r=41.754 //w=0.187 //l=0.61 //layer=li \
 //thickness=0.1 //x=71.815 //y=5.335 //x2=71.205 //y2=5.335
r231 (  23 50 ) resistor r=1.40859 //w=0.34 //l=0.085 //layer=li \
 //thickness=0.1 //x=71.12 //y=5.42 //x2=71.12 //y2=5.335
r232 (  23 85 ) resistor r=33.1979 //w=0.187 //l=0.485 //layer=li \
 //thickness=0.1 //x=71.12 //y=5.42 //x2=71.12 //y2=5.905
r233 (  22 49 ) resistor r=5.4201 //w=0.17 //l=0.085 //layer=li \
 //thickness=0.1 //x=70.325 //y=5.335 //x2=70.24 //y2=5.335
r234 (  21 50 ) resistor r=5.4201 //w=0.17 //l=0.085 //layer=li \
 //thickness=0.1 //x=71.035 //y=5.335 //x2=71.12 //y2=5.335
r235 (  21 22 ) resistor r=48.5989 //w=0.187 //l=0.71 //layer=li \
 //thickness=0.1 //x=71.035 //y=5.335 //x2=70.325 //y2=5.335
r236 (  15 49 ) resistor r=1.40859 //w=0.34 //l=0.085 //layer=li \
 //thickness=0.1 //x=70.24 //y=5.42 //x2=70.24 //y2=5.335
r237 (  15 84 ) resistor r=33.1979 //w=0.187 //l=0.485 //layer=li \
 //thickness=0.1 //x=70.24 //y=5.42 //x2=70.24 //y2=5.905
r238 (  13 49 ) resistor r=5.4201 //w=0.17 //l=0.085 //layer=li \
 //thickness=0.1 //x=70.155 //y=5.335 //x2=70.24 //y2=5.335
r239 (  13 14 ) resistor r=48.5989 //w=0.187 //l=0.71 //layer=li \
 //thickness=0.1 //x=70.155 //y=5.335 //x2=69.445 //y2=5.335
r240 (  7 14 ) resistor r=7.15173 //w=0.17 //l=0.120208 //layer=li \
 //thickness=0.1 //x=69.36 //y=5.42 //x2=69.445 //y2=5.335
r241 (  7 83 ) resistor r=33.1979 //w=0.187 //l=0.485 //layer=li \
 //thickness=0.1 //x=69.36 //y=5.42 //x2=69.36 //y2=5.905
r242 (  6 45 ) resistor r=9.3 //w=0.17 //l=0.17 //layer=mcon //count=1 \
 //x=73.75 //y=2.77 //x2=73.75 //y2=2.77
r243 (  4 40 ) resistor r=9.3 //w=0.17 //l=0.17 //layer=mcon //count=1 \
 //x=71.9 //y=2.77 //x2=71.9 //y2=2.77
r244 (  2 4 ) resistor r=0.0717383 //w=0.224 //l=0.115 //layer=m1 \
 //thickness=0.36 //x=72.015 //y=2.77 //x2=71.9 //y2=2.77
r245 (  1 6 ) resistor r=0.0717383 //w=0.224 //l=0.115 //layer=m1 \
 //thickness=0.36 //x=73.635 //y=2.77 //x2=73.75 //y2=2.77
r246 (  1 2 ) resistor r=1.5458 //w=0.131 //l=1.62 //layer=m1 //thickness=0.36 \
 //x=73.635 //y=2.77 //x2=72.015 //y2=2.77
ends PM_TMRDFFSNRNQNX1\%noxref_16

subckt PM_TMRDFFSNRNQNX1\%CLK ( 1 2 3 4 5 6 7 8 9 10 23 24 25 26 27 28 29 30 \
 31 32 33 34 36 46 55 64 73 81 89 90 91 92 93 94 95 96 97 98 99 100 101 102 \
 103 104 105 106 107 108 109 111 117 118 119 120 121 126 127 128 130 136 137 \
 138 139 140 145 146 147 149 155 156 157 158 159 164 165 166 168 174 175 176 \
 177 178 183 184 185 187 193 194 195 196 197 202 203 204 206 212 213 214 215 \
 216 224 235 246 257 268 279 )
c707 ( 279 0 ) capacitor c=0.0333177f //x=74.86 //y=4.88
c708 ( 268 0 ) capacitor c=0.0333177f //x=65.24 //y=4.88
c709 ( 257 0 ) capacitor c=0.0333177f //x=46 //y=4.88
c710 ( 246 0 ) capacitor c=0.0333177f //x=36.38 //y=4.88
c711 ( 235 0 ) capacitor c=0.0334842f //x=17.14 //y=4.88
c712 ( 224 0 ) capacitor c=0.0334842f //x=7.52 //y=4.88
c713 ( 216 0 ) capacitor c=0.0252241f //x=75.195 //y=4.97
c714 ( 215 0 ) capacitor c=0.0825763f //x=74.95 //y=2.095
c715 ( 214 0 ) capacitor c=0.0170266f //x=74.95 //y=1.63
c716 ( 213 0 ) capacitor c=0.018609f //x=74.95 //y=1.4
c717 ( 212 0 ) capacitor c=0.0187309f //x=74.95 //y=1.09
c718 ( 206 0 ) capacitor c=0.014725f //x=74.795 //y=1.555
c719 ( 204 0 ) capacitor c=0.0146567f //x=74.795 //y=0.935
c720 ( 203 0 ) capacitor c=0.0335408f //x=74.425 //y=1.4
c721 ( 202 0 ) capacitor c=0.0173761f //x=74.425 //y=1.09
c722 ( 197 0 ) capacitor c=0.0246783f //x=65.575 //y=4.97
c723 ( 196 0 ) capacitor c=0.0825763f //x=65.33 //y=2.095
c724 ( 195 0 ) capacitor c=0.0170266f //x=65.33 //y=1.63
c725 ( 194 0 ) capacitor c=0.018609f //x=65.33 //y=1.4
c726 ( 193 0 ) capacitor c=0.0187309f //x=65.33 //y=1.09
c727 ( 187 0 ) capacitor c=0.014725f //x=65.175 //y=1.555
c728 ( 185 0 ) capacitor c=0.0146567f //x=65.175 //y=0.935
c729 ( 184 0 ) capacitor c=0.0335408f //x=64.805 //y=1.4
c730 ( 183 0 ) capacitor c=0.0173761f //x=64.805 //y=1.09
c731 ( 178 0 ) capacitor c=0.0246783f //x=46.335 //y=4.97
c732 ( 177 0 ) capacitor c=0.0825763f //x=46.09 //y=2.095
c733 ( 176 0 ) capacitor c=0.0170266f //x=46.09 //y=1.63
c734 ( 175 0 ) capacitor c=0.018609f //x=46.09 //y=1.4
c735 ( 174 0 ) capacitor c=0.0187309f //x=46.09 //y=1.09
c736 ( 168 0 ) capacitor c=0.014725f //x=45.935 //y=1.555
c737 ( 166 0 ) capacitor c=0.0146567f //x=45.935 //y=0.935
c738 ( 165 0 ) capacitor c=0.0335408f //x=45.565 //y=1.4
c739 ( 164 0 ) capacitor c=0.0173761f //x=45.565 //y=1.09
c740 ( 159 0 ) capacitor c=0.0246783f //x=36.715 //y=4.97
c741 ( 158 0 ) capacitor c=0.0825763f //x=36.47 //y=2.095
c742 ( 157 0 ) capacitor c=0.0170266f //x=36.47 //y=1.63
c743 ( 156 0 ) capacitor c=0.018609f //x=36.47 //y=1.4
c744 ( 155 0 ) capacitor c=0.0187309f //x=36.47 //y=1.09
c745 ( 149 0 ) capacitor c=0.014725f //x=36.315 //y=1.555
c746 ( 147 0 ) capacitor c=0.0146567f //x=36.315 //y=0.935
c747 ( 146 0 ) capacitor c=0.0335408f //x=35.945 //y=1.4
c748 ( 145 0 ) capacitor c=0.0173761f //x=35.945 //y=1.09
c749 ( 140 0 ) capacitor c=0.0245352f //x=17.475 //y=4.97
c750 ( 139 0 ) capacitor c=0.0825763f //x=17.23 //y=2.095
c751 ( 138 0 ) capacitor c=0.0170266f //x=17.23 //y=1.63
c752 ( 137 0 ) capacitor c=0.018609f //x=17.23 //y=1.4
c753 ( 136 0 ) capacitor c=0.0187309f //x=17.23 //y=1.09
c754 ( 130 0 ) capacitor c=0.014725f //x=17.075 //y=1.555
c755 ( 128 0 ) capacitor c=0.0146567f //x=17.075 //y=0.935
c756 ( 127 0 ) capacitor c=0.0335408f //x=16.705 //y=1.4
c757 ( 126 0 ) capacitor c=0.0173761f //x=16.705 //y=1.09
c758 ( 121 0 ) capacitor c=0.0245352f //x=7.855 //y=4.97
c759 ( 120 0 ) capacitor c=0.0825763f //x=7.61 //y=2.095
c760 ( 119 0 ) capacitor c=0.0170266f //x=7.61 //y=1.63
c761 ( 118 0 ) capacitor c=0.018609f //x=7.61 //y=1.4
c762 ( 117 0 ) capacitor c=0.0187309f //x=7.61 //y=1.09
c763 ( 111 0 ) capacitor c=0.014725f //x=7.455 //y=1.555
c764 ( 109 0 ) capacitor c=0.0146567f //x=7.455 //y=0.935
c765 ( 108 0 ) capacitor c=0.0335408f //x=7.085 //y=1.4
c766 ( 107 0 ) capacitor c=0.0173761f //x=7.085 //y=1.09
c767 ( 106 0 ) capacitor c=0.109949f //x=75.27 //y=6.2
c768 ( 105 0 ) capacitor c=0.109956f //x=74.83 //y=6.2
c769 ( 104 0 ) capacitor c=0.109949f //x=65.65 //y=6.2
c770 ( 103 0 ) capacitor c=0.109956f //x=65.21 //y=6.2
c771 ( 102 0 ) capacitor c=0.109949f //x=46.41 //y=6.2
c772 ( 101 0 ) capacitor c=0.109956f //x=45.97 //y=6.2
c773 ( 100 0 ) capacitor c=0.109949f //x=36.79 //y=6.2
c774 ( 99 0 ) capacitor c=0.109956f //x=36.35 //y=6.2
c775 ( 98 0 ) capacitor c=0.110114f //x=17.55 //y=6.2
c776 ( 97 0 ) capacitor c=0.11012f //x=17.11 //y=6.2
c777 ( 96 0 ) capacitor c=0.110114f //x=7.93 //y=6.2
c778 ( 95 0 ) capacitor c=0.11012f //x=7.49 //y=6.2
c779 ( 81 0 ) capacitor c=0.0880091f //x=74.86 //y=2.26
c780 ( 73 0 ) capacitor c=0.0867126f //x=65.24 //y=2.26
c781 ( 64 0 ) capacitor c=0.0882701f //x=46 //y=2.26
c782 ( 55 0 ) capacitor c=0.0881639f //x=36.38 //y=2.26
c783 ( 46 0 ) capacitor c=0.0899873f //x=17.14 //y=2.26
c784 ( 36 0 ) capacitor c=0.0925246f //x=7.52 //y=2.26
c785 ( 10 0 ) capacitor c=0.0052048f //x=65.355 //y=4.62
c786 ( 9 0 ) capacitor c=0.124137f //x=74.745 //y=4.62
c787 ( 8 0 ) capacitor c=0.00494979f //x=46.115 //y=4.62
c788 ( 7 0 ) capacitor c=0.255004f //x=65.125 //y=4.62
c789 ( 6 0 ) capacitor c=0.00494979f //x=36.495 //y=4.62
c790 ( 5 0 ) capacitor c=0.117333f //x=45.885 //y=4.62
c791 ( 4 0 ) capacitor c=0.00697397f //x=17.255 //y=4.62
c792 ( 3 0 ) capacitor c=0.297275f //x=36.265 //y=4.62
c793 ( 2 0 ) capacitor c=0.0154455f //x=7.635 //y=4.62
c794 ( 1 0 ) capacitor c=0.212324f //x=17.025 //y=4.62
r795 (  281 282 ) resistor r=32.4568 //w=0.214 //l=0.075 //layer=ply \
 //thickness=0.18 //x=74.86 //y=4.97 //x2=74.86 //y2=5.045
r796 (  279 281 ) resistor r=20.271 //w=0.214 //l=0.09 //layer=ply \
 //thickness=0.18 //x=74.86 //y=4.88 //x2=74.86 //y2=4.97
r797 (  270 271 ) resistor r=32.4568 //w=0.214 //l=0.075 //layer=ply \
 //thickness=0.18 //x=65.24 //y=4.97 //x2=65.24 //y2=5.045
r798 (  268 270 ) resistor r=20.271 //w=0.214 //l=0.09 //layer=ply \
 //thickness=0.18 //x=65.24 //y=4.88 //x2=65.24 //y2=4.97
r799 (  259 260 ) resistor r=32.4568 //w=0.214 //l=0.075 //layer=ply \
 //thickness=0.18 //x=46 //y=4.97 //x2=46 //y2=5.045
r800 (  257 259 ) resistor r=20.271 //w=0.214 //l=0.09 //layer=ply \
 //thickness=0.18 //x=46 //y=4.88 //x2=46 //y2=4.97
r801 (  248 249 ) resistor r=32.4568 //w=0.214 //l=0.075 //layer=ply \
 //thickness=0.18 //x=36.38 //y=4.97 //x2=36.38 //y2=5.045
r802 (  246 248 ) resistor r=20.271 //w=0.214 //l=0.09 //layer=ply \
 //thickness=0.18 //x=36.38 //y=4.88 //x2=36.38 //y2=4.97
r803 (  237 238 ) resistor r=32.4568 //w=0.214 //l=0.075 //layer=ply \
 //thickness=0.18 //x=17.14 //y=4.97 //x2=17.14 //y2=5.045
r804 (  235 237 ) resistor r=20.271 //w=0.214 //l=0.09 //layer=ply \
 //thickness=0.18 //x=17.14 //y=4.88 //x2=17.14 //y2=4.97
r805 (  226 227 ) resistor r=32.4568 //w=0.214 //l=0.075 //layer=ply \
 //thickness=0.18 //x=7.52 //y=4.97 //x2=7.52 //y2=5.045
r806 (  224 226 ) resistor r=20.271 //w=0.214 //l=0.09 //layer=ply \
 //thickness=0.18 //x=7.52 //y=4.88 //x2=7.52 //y2=4.97
r807 (  217 281 ) resistor r=16.5046 //w=0.27 //l=0.135 //layer=ply \
 //thickness=0.18 //x=74.995 //y=4.97 //x2=74.86 //y2=4.97
r808 (  216 218 ) resistor r=26.9307 //w=0.15 //l=0.106066 //layer=ply \
 //thickness=0.18 //x=75.195 //y=4.97 //x2=75.27 //y2=5.045
r809 (  216 217 ) resistor r=102.553 //w=0.094 //l=0.2 //layer=ply \
 //thickness=0.18 //x=75.195 //y=4.97 //x2=74.995 //y2=4.97
r810 (  215 286 ) resistor r=38.6777 //w=0.284 //l=0.198997 //layer=ply \
 //thickness=0.18 //x=74.95 //y=2.095 //x2=74.875 //y2=2.26
r811 (  214 284 ) resistor r=21.2976 //w=0.217 //l=0.0928709 //layer=ply \
 //thickness=0.18 //x=74.95 //y=1.63 //x2=74.91 //y2=1.555
r812 (  214 215 ) resistor r=238.436 //w=0.094 //l=0.465 //layer=ply \
 //thickness=0.18 //x=74.95 //y=1.63 //x2=74.95 //y2=2.095
r813 (  213 284 ) resistor r=39.0671 //w=0.217 //l=0.173853 //layer=ply \
 //thickness=0.18 //x=74.95 //y=1.4 //x2=74.91 //y2=1.555
r814 (  212 283 ) resistor r=45.1352 //w=0.168 //l=0.173853 //layer=ply \
 //thickness=0.18 //x=74.95 //y=1.09 //x2=74.91 //y2=0.935
r815 (  212 213 ) resistor r=158.957 //w=0.094 //l=0.31 //layer=ply \
 //thickness=0.18 //x=74.95 //y=1.09 //x2=74.95 //y2=1.4
r816 (  207 277 ) resistor r=5.52526 //w=0.168 //l=0.115 //layer=ply \
 //thickness=0.18 //x=74.58 //y=1.555 //x2=74.465 //y2=1.555
r817 (  206 284 ) resistor r=11.4558 //w=0.217 //l=0.115 //layer=ply \
 //thickness=0.18 //x=74.795 //y=1.555 //x2=74.91 //y2=1.555
r818 (  205 276 ) resistor r=5.52526 //w=0.168 //l=0.115 //layer=ply \
 //thickness=0.18 //x=74.58 //y=0.935 //x2=74.465 //y2=0.935
r819 (  204 283 ) resistor r=5.52526 //w=0.168 //l=0.115 //layer=ply \
 //thickness=0.18 //x=74.795 //y=0.935 //x2=74.91 //y2=0.935
r820 (  204 205 ) resistor r=110.245 //w=0.094 //l=0.215 //layer=ply \
 //thickness=0.18 //x=74.795 //y=0.935 //x2=74.58 //y2=0.935
r821 (  203 277 ) resistor r=45.1352 //w=0.168 //l=0.173853 //layer=ply \
 //thickness=0.18 //x=74.425 //y=1.4 //x2=74.465 //y2=1.555
r822 (  202 276 ) resistor r=45.1352 //w=0.168 //l=0.173853 //layer=ply \
 //thickness=0.18 //x=74.425 //y=1.09 //x2=74.465 //y2=0.935
r823 (  202 203 ) resistor r=158.957 //w=0.094 //l=0.31 //layer=ply \
 //thickness=0.18 //x=74.425 //y=1.09 //x2=74.425 //y2=1.4
r824 (  198 270 ) resistor r=16.5046 //w=0.27 //l=0.135 //layer=ply \
 //thickness=0.18 //x=65.375 //y=4.97 //x2=65.24 //y2=4.97
r825 (  197 199 ) resistor r=26.9307 //w=0.15 //l=0.106066 //layer=ply \
 //thickness=0.18 //x=65.575 //y=4.97 //x2=65.65 //y2=5.045
r826 (  197 198 ) resistor r=102.553 //w=0.094 //l=0.2 //layer=ply \
 //thickness=0.18 //x=65.575 //y=4.97 //x2=65.375 //y2=4.97
r827 (  196 275 ) resistor r=38.6777 //w=0.284 //l=0.198997 //layer=ply \
 //thickness=0.18 //x=65.33 //y=2.095 //x2=65.255 //y2=2.26
r828 (  195 273 ) resistor r=21.2976 //w=0.217 //l=0.0928709 //layer=ply \
 //thickness=0.18 //x=65.33 //y=1.63 //x2=65.29 //y2=1.555
r829 (  195 196 ) resistor r=238.436 //w=0.094 //l=0.465 //layer=ply \
 //thickness=0.18 //x=65.33 //y=1.63 //x2=65.33 //y2=2.095
r830 (  194 273 ) resistor r=39.0671 //w=0.217 //l=0.173853 //layer=ply \
 //thickness=0.18 //x=65.33 //y=1.4 //x2=65.29 //y2=1.555
r831 (  193 272 ) resistor r=45.1352 //w=0.168 //l=0.173853 //layer=ply \
 //thickness=0.18 //x=65.33 //y=1.09 //x2=65.29 //y2=0.935
r832 (  193 194 ) resistor r=158.957 //w=0.094 //l=0.31 //layer=ply \
 //thickness=0.18 //x=65.33 //y=1.09 //x2=65.33 //y2=1.4
r833 (  188 266 ) resistor r=5.52526 //w=0.168 //l=0.115 //layer=ply \
 //thickness=0.18 //x=64.96 //y=1.555 //x2=64.845 //y2=1.555
r834 (  187 273 ) resistor r=11.4558 //w=0.217 //l=0.115 //layer=ply \
 //thickness=0.18 //x=65.175 //y=1.555 //x2=65.29 //y2=1.555
r835 (  186 265 ) resistor r=5.52526 //w=0.168 //l=0.115 //layer=ply \
 //thickness=0.18 //x=64.96 //y=0.935 //x2=64.845 //y2=0.935
r836 (  185 272 ) resistor r=5.52526 //w=0.168 //l=0.115 //layer=ply \
 //thickness=0.18 //x=65.175 //y=0.935 //x2=65.29 //y2=0.935
r837 (  185 186 ) resistor r=110.245 //w=0.094 //l=0.215 //layer=ply \
 //thickness=0.18 //x=65.175 //y=0.935 //x2=64.96 //y2=0.935
r838 (  184 266 ) resistor r=45.1352 //w=0.168 //l=0.173853 //layer=ply \
 //thickness=0.18 //x=64.805 //y=1.4 //x2=64.845 //y2=1.555
r839 (  183 265 ) resistor r=45.1352 //w=0.168 //l=0.173853 //layer=ply \
 //thickness=0.18 //x=64.805 //y=1.09 //x2=64.845 //y2=0.935
r840 (  183 184 ) resistor r=158.957 //w=0.094 //l=0.31 //layer=ply \
 //thickness=0.18 //x=64.805 //y=1.09 //x2=64.805 //y2=1.4
r841 (  179 259 ) resistor r=16.5046 //w=0.27 //l=0.135 //layer=ply \
 //thickness=0.18 //x=46.135 //y=4.97 //x2=46 //y2=4.97
r842 (  178 180 ) resistor r=26.9307 //w=0.15 //l=0.106066 //layer=ply \
 //thickness=0.18 //x=46.335 //y=4.97 //x2=46.41 //y2=5.045
r843 (  178 179 ) resistor r=102.553 //w=0.094 //l=0.2 //layer=ply \
 //thickness=0.18 //x=46.335 //y=4.97 //x2=46.135 //y2=4.97
r844 (  177 264 ) resistor r=38.6777 //w=0.284 //l=0.198997 //layer=ply \
 //thickness=0.18 //x=46.09 //y=2.095 //x2=46.015 //y2=2.26
r845 (  176 262 ) resistor r=21.2976 //w=0.217 //l=0.0928709 //layer=ply \
 //thickness=0.18 //x=46.09 //y=1.63 //x2=46.05 //y2=1.555
r846 (  176 177 ) resistor r=238.436 //w=0.094 //l=0.465 //layer=ply \
 //thickness=0.18 //x=46.09 //y=1.63 //x2=46.09 //y2=2.095
r847 (  175 262 ) resistor r=39.0671 //w=0.217 //l=0.173853 //layer=ply \
 //thickness=0.18 //x=46.09 //y=1.4 //x2=46.05 //y2=1.555
r848 (  174 261 ) resistor r=45.1352 //w=0.168 //l=0.173853 //layer=ply \
 //thickness=0.18 //x=46.09 //y=1.09 //x2=46.05 //y2=0.935
r849 (  174 175 ) resistor r=158.957 //w=0.094 //l=0.31 //layer=ply \
 //thickness=0.18 //x=46.09 //y=1.09 //x2=46.09 //y2=1.4
r850 (  169 255 ) resistor r=5.52526 //w=0.168 //l=0.115 //layer=ply \
 //thickness=0.18 //x=45.72 //y=1.555 //x2=45.605 //y2=1.555
r851 (  168 262 ) resistor r=11.4558 //w=0.217 //l=0.115 //layer=ply \
 //thickness=0.18 //x=45.935 //y=1.555 //x2=46.05 //y2=1.555
r852 (  167 254 ) resistor r=5.52526 //w=0.168 //l=0.115 //layer=ply \
 //thickness=0.18 //x=45.72 //y=0.935 //x2=45.605 //y2=0.935
r853 (  166 261 ) resistor r=5.52526 //w=0.168 //l=0.115 //layer=ply \
 //thickness=0.18 //x=45.935 //y=0.935 //x2=46.05 //y2=0.935
r854 (  166 167 ) resistor r=110.245 //w=0.094 //l=0.215 //layer=ply \
 //thickness=0.18 //x=45.935 //y=0.935 //x2=45.72 //y2=0.935
r855 (  165 255 ) resistor r=45.1352 //w=0.168 //l=0.173853 //layer=ply \
 //thickness=0.18 //x=45.565 //y=1.4 //x2=45.605 //y2=1.555
r856 (  164 254 ) resistor r=45.1352 //w=0.168 //l=0.173853 //layer=ply \
 //thickness=0.18 //x=45.565 //y=1.09 //x2=45.605 //y2=0.935
r857 (  164 165 ) resistor r=158.957 //w=0.094 //l=0.31 //layer=ply \
 //thickness=0.18 //x=45.565 //y=1.09 //x2=45.565 //y2=1.4
r858 (  160 248 ) resistor r=16.5046 //w=0.27 //l=0.135 //layer=ply \
 //thickness=0.18 //x=36.515 //y=4.97 //x2=36.38 //y2=4.97
r859 (  159 161 ) resistor r=26.9307 //w=0.15 //l=0.106066 //layer=ply \
 //thickness=0.18 //x=36.715 //y=4.97 //x2=36.79 //y2=5.045
r860 (  159 160 ) resistor r=102.553 //w=0.094 //l=0.2 //layer=ply \
 //thickness=0.18 //x=36.715 //y=4.97 //x2=36.515 //y2=4.97
r861 (  158 253 ) resistor r=38.6777 //w=0.284 //l=0.198997 //layer=ply \
 //thickness=0.18 //x=36.47 //y=2.095 //x2=36.395 //y2=2.26
r862 (  157 251 ) resistor r=21.2976 //w=0.217 //l=0.0928709 //layer=ply \
 //thickness=0.18 //x=36.47 //y=1.63 //x2=36.43 //y2=1.555
r863 (  157 158 ) resistor r=238.436 //w=0.094 //l=0.465 //layer=ply \
 //thickness=0.18 //x=36.47 //y=1.63 //x2=36.47 //y2=2.095
r864 (  156 251 ) resistor r=39.0671 //w=0.217 //l=0.173853 //layer=ply \
 //thickness=0.18 //x=36.47 //y=1.4 //x2=36.43 //y2=1.555
r865 (  155 250 ) resistor r=45.1352 //w=0.168 //l=0.173853 //layer=ply \
 //thickness=0.18 //x=36.47 //y=1.09 //x2=36.43 //y2=0.935
r866 (  155 156 ) resistor r=158.957 //w=0.094 //l=0.31 //layer=ply \
 //thickness=0.18 //x=36.47 //y=1.09 //x2=36.47 //y2=1.4
r867 (  150 244 ) resistor r=5.52526 //w=0.168 //l=0.115 //layer=ply \
 //thickness=0.18 //x=36.1 //y=1.555 //x2=35.985 //y2=1.555
r868 (  149 251 ) resistor r=11.4558 //w=0.217 //l=0.115 //layer=ply \
 //thickness=0.18 //x=36.315 //y=1.555 //x2=36.43 //y2=1.555
r869 (  148 243 ) resistor r=5.52526 //w=0.168 //l=0.115 //layer=ply \
 //thickness=0.18 //x=36.1 //y=0.935 //x2=35.985 //y2=0.935
r870 (  147 250 ) resistor r=5.52526 //w=0.168 //l=0.115 //layer=ply \
 //thickness=0.18 //x=36.315 //y=0.935 //x2=36.43 //y2=0.935
r871 (  147 148 ) resistor r=110.245 //w=0.094 //l=0.215 //layer=ply \
 //thickness=0.18 //x=36.315 //y=0.935 //x2=36.1 //y2=0.935
r872 (  146 244 ) resistor r=45.1352 //w=0.168 //l=0.173853 //layer=ply \
 //thickness=0.18 //x=35.945 //y=1.4 //x2=35.985 //y2=1.555
r873 (  145 243 ) resistor r=45.1352 //w=0.168 //l=0.173853 //layer=ply \
 //thickness=0.18 //x=35.945 //y=1.09 //x2=35.985 //y2=0.935
r874 (  145 146 ) resistor r=158.957 //w=0.094 //l=0.31 //layer=ply \
 //thickness=0.18 //x=35.945 //y=1.09 //x2=35.945 //y2=1.4
r875 (  141 237 ) resistor r=16.5046 //w=0.27 //l=0.135 //layer=ply \
 //thickness=0.18 //x=17.275 //y=4.97 //x2=17.14 //y2=4.97
r876 (  140 142 ) resistor r=26.9307 //w=0.15 //l=0.106066 //layer=ply \
 //thickness=0.18 //x=17.475 //y=4.97 //x2=17.55 //y2=5.045
r877 (  140 141 ) resistor r=102.553 //w=0.094 //l=0.2 //layer=ply \
 //thickness=0.18 //x=17.475 //y=4.97 //x2=17.275 //y2=4.97
r878 (  139 242 ) resistor r=38.6777 //w=0.284 //l=0.198997 //layer=ply \
 //thickness=0.18 //x=17.23 //y=2.095 //x2=17.155 //y2=2.26
r879 (  138 240 ) resistor r=21.2976 //w=0.217 //l=0.0928709 //layer=ply \
 //thickness=0.18 //x=17.23 //y=1.63 //x2=17.19 //y2=1.555
r880 (  138 139 ) resistor r=238.436 //w=0.094 //l=0.465 //layer=ply \
 //thickness=0.18 //x=17.23 //y=1.63 //x2=17.23 //y2=2.095
r881 (  137 240 ) resistor r=39.0671 //w=0.217 //l=0.173853 //layer=ply \
 //thickness=0.18 //x=17.23 //y=1.4 //x2=17.19 //y2=1.555
r882 (  136 239 ) resistor r=45.1352 //w=0.168 //l=0.173853 //layer=ply \
 //thickness=0.18 //x=17.23 //y=1.09 //x2=17.19 //y2=0.935
r883 (  136 137 ) resistor r=158.957 //w=0.094 //l=0.31 //layer=ply \
 //thickness=0.18 //x=17.23 //y=1.09 //x2=17.23 //y2=1.4
r884 (  131 233 ) resistor r=5.52526 //w=0.168 //l=0.115 //layer=ply \
 //thickness=0.18 //x=16.86 //y=1.555 //x2=16.745 //y2=1.555
r885 (  130 240 ) resistor r=11.4558 //w=0.217 //l=0.115 //layer=ply \
 //thickness=0.18 //x=17.075 //y=1.555 //x2=17.19 //y2=1.555
r886 (  129 232 ) resistor r=5.52526 //w=0.168 //l=0.115 //layer=ply \
 //thickness=0.18 //x=16.86 //y=0.935 //x2=16.745 //y2=0.935
r887 (  128 239 ) resistor r=5.52526 //w=0.168 //l=0.115 //layer=ply \
 //thickness=0.18 //x=17.075 //y=0.935 //x2=17.19 //y2=0.935
r888 (  128 129 ) resistor r=110.245 //w=0.094 //l=0.215 //layer=ply \
 //thickness=0.18 //x=17.075 //y=0.935 //x2=16.86 //y2=0.935
r889 (  127 233 ) resistor r=45.1352 //w=0.168 //l=0.173853 //layer=ply \
 //thickness=0.18 //x=16.705 //y=1.4 //x2=16.745 //y2=1.555
r890 (  126 232 ) resistor r=45.1352 //w=0.168 //l=0.173853 //layer=ply \
 //thickness=0.18 //x=16.705 //y=1.09 //x2=16.745 //y2=0.935
r891 (  126 127 ) resistor r=158.957 //w=0.094 //l=0.31 //layer=ply \
 //thickness=0.18 //x=16.705 //y=1.09 //x2=16.705 //y2=1.4
r892 (  122 226 ) resistor r=16.5046 //w=0.27 //l=0.135 //layer=ply \
 //thickness=0.18 //x=7.655 //y=4.97 //x2=7.52 //y2=4.97
r893 (  121 123 ) resistor r=26.9307 //w=0.15 //l=0.106066 //layer=ply \
 //thickness=0.18 //x=7.855 //y=4.97 //x2=7.93 //y2=5.045
r894 (  121 122 ) resistor r=102.553 //w=0.094 //l=0.2 //layer=ply \
 //thickness=0.18 //x=7.855 //y=4.97 //x2=7.655 //y2=4.97
r895 (  120 231 ) resistor r=38.6777 //w=0.284 //l=0.198997 //layer=ply \
 //thickness=0.18 //x=7.61 //y=2.095 //x2=7.535 //y2=2.26
r896 (  119 229 ) resistor r=21.2976 //w=0.217 //l=0.0928709 //layer=ply \
 //thickness=0.18 //x=7.61 //y=1.63 //x2=7.57 //y2=1.555
r897 (  119 120 ) resistor r=238.436 //w=0.094 //l=0.465 //layer=ply \
 //thickness=0.18 //x=7.61 //y=1.63 //x2=7.61 //y2=2.095
r898 (  118 229 ) resistor r=39.0671 //w=0.217 //l=0.173853 //layer=ply \
 //thickness=0.18 //x=7.61 //y=1.4 //x2=7.57 //y2=1.555
r899 (  117 228 ) resistor r=45.1352 //w=0.168 //l=0.173853 //layer=ply \
 //thickness=0.18 //x=7.61 //y=1.09 //x2=7.57 //y2=0.935
r900 (  117 118 ) resistor r=158.957 //w=0.094 //l=0.31 //layer=ply \
 //thickness=0.18 //x=7.61 //y=1.09 //x2=7.61 //y2=1.4
r901 (  112 222 ) resistor r=5.52526 //w=0.168 //l=0.115 //layer=ply \
 //thickness=0.18 //x=7.24 //y=1.555 //x2=7.125 //y2=1.555
r902 (  111 229 ) resistor r=11.4558 //w=0.217 //l=0.115 //layer=ply \
 //thickness=0.18 //x=7.455 //y=1.555 //x2=7.57 //y2=1.555
r903 (  110 221 ) resistor r=5.52526 //w=0.168 //l=0.115 //layer=ply \
 //thickness=0.18 //x=7.24 //y=0.935 //x2=7.125 //y2=0.935
r904 (  109 228 ) resistor r=5.52526 //w=0.168 //l=0.115 //layer=ply \
 //thickness=0.18 //x=7.455 //y=0.935 //x2=7.57 //y2=0.935
r905 (  109 110 ) resistor r=110.245 //w=0.094 //l=0.215 //layer=ply \
 //thickness=0.18 //x=7.455 //y=0.935 //x2=7.24 //y2=0.935
r906 (  108 222 ) resistor r=45.1352 //w=0.168 //l=0.173853 //layer=ply \
 //thickness=0.18 //x=7.085 //y=1.4 //x2=7.125 //y2=1.555
r907 (  107 221 ) resistor r=45.1352 //w=0.168 //l=0.173853 //layer=ply \
 //thickness=0.18 //x=7.085 //y=1.09 //x2=7.125 //y2=0.935
r908 (  107 108 ) resistor r=158.957 //w=0.094 //l=0.31 //layer=ply \
 //thickness=0.18 //x=7.085 //y=1.09 //x2=7.085 //y2=1.4
r909 (  106 218 ) resistor r=592.245 //w=0.094 //l=1.155 //layer=ply \
 //thickness=0.18 //x=75.27 //y=6.2 //x2=75.27 //y2=5.045
r910 (  105 282 ) resistor r=592.245 //w=0.094 //l=1.155 //layer=ply \
 //thickness=0.18 //x=74.83 //y=6.2 //x2=74.83 //y2=5.045
r911 (  104 199 ) resistor r=592.245 //w=0.094 //l=1.155 //layer=ply \
 //thickness=0.18 //x=65.65 //y=6.2 //x2=65.65 //y2=5.045
r912 (  103 271 ) resistor r=592.245 //w=0.094 //l=1.155 //layer=ply \
 //thickness=0.18 //x=65.21 //y=6.2 //x2=65.21 //y2=5.045
r913 (  102 180 ) resistor r=592.245 //w=0.094 //l=1.155 //layer=ply \
 //thickness=0.18 //x=46.41 //y=6.2 //x2=46.41 //y2=5.045
r914 (  101 260 ) resistor r=592.245 //w=0.094 //l=1.155 //layer=ply \
 //thickness=0.18 //x=45.97 //y=6.2 //x2=45.97 //y2=5.045
r915 (  100 161 ) resistor r=592.245 //w=0.094 //l=1.155 //layer=ply \
 //thickness=0.18 //x=36.79 //y=6.2 //x2=36.79 //y2=5.045
r916 (  99 249 ) resistor r=592.245 //w=0.094 //l=1.155 //layer=ply \
 //thickness=0.18 //x=36.35 //y=6.2 //x2=36.35 //y2=5.045
r917 (  98 142 ) resistor r=592.245 //w=0.094 //l=1.155 //layer=ply \
 //thickness=0.18 //x=17.55 //y=6.2 //x2=17.55 //y2=5.045
r918 (  97 238 ) resistor r=592.245 //w=0.094 //l=1.155 //layer=ply \
 //thickness=0.18 //x=17.11 //y=6.2 //x2=17.11 //y2=5.045
r919 (  96 123 ) resistor r=592.245 //w=0.094 //l=1.155 //layer=ply \
 //thickness=0.18 //x=7.93 //y=6.2 //x2=7.93 //y2=5.045
r920 (  95 227 ) resistor r=592.245 //w=0.094 //l=1.155 //layer=ply \
 //thickness=0.18 //x=7.49 //y=6.2 //x2=7.49 //y2=5.045
r921 (  94 206 ) resistor r=55.3787 //w=0.094 //l=0.108 //layer=ply \
 //thickness=0.18 //x=74.687 //y=1.555 //x2=74.795 //y2=1.555
r922 (  94 207 ) resistor r=54.866 //w=0.094 //l=0.107 //layer=ply \
 //thickness=0.18 //x=74.687 //y=1.555 //x2=74.58 //y2=1.555
r923 (  93 187 ) resistor r=55.3787 //w=0.094 //l=0.108 //layer=ply \
 //thickness=0.18 //x=65.067 //y=1.555 //x2=65.175 //y2=1.555
r924 (  93 188 ) resistor r=54.866 //w=0.094 //l=0.107 //layer=ply \
 //thickness=0.18 //x=65.067 //y=1.555 //x2=64.96 //y2=1.555
r925 (  92 168 ) resistor r=55.3787 //w=0.094 //l=0.108 //layer=ply \
 //thickness=0.18 //x=45.827 //y=1.555 //x2=45.935 //y2=1.555
r926 (  92 169 ) resistor r=54.866 //w=0.094 //l=0.107 //layer=ply \
 //thickness=0.18 //x=45.827 //y=1.555 //x2=45.72 //y2=1.555
r927 (  91 149 ) resistor r=55.3787 //w=0.094 //l=0.108 //layer=ply \
 //thickness=0.18 //x=36.207 //y=1.555 //x2=36.315 //y2=1.555
r928 (  91 150 ) resistor r=54.866 //w=0.094 //l=0.107 //layer=ply \
 //thickness=0.18 //x=36.207 //y=1.555 //x2=36.1 //y2=1.555
r929 (  90 130 ) resistor r=55.3787 //w=0.094 //l=0.108 //layer=ply \
 //thickness=0.18 //x=16.967 //y=1.555 //x2=17.075 //y2=1.555
r930 (  90 131 ) resistor r=54.866 //w=0.094 //l=0.107 //layer=ply \
 //thickness=0.18 //x=16.967 //y=1.555 //x2=16.86 //y2=1.555
r931 (  89 111 ) resistor r=55.3787 //w=0.094 //l=0.108 //layer=ply \
 //thickness=0.18 //x=7.347 //y=1.555 //x2=7.455 //y2=1.555
r932 (  89 112 ) resistor r=54.866 //w=0.094 //l=0.107 //layer=ply \
 //thickness=0.18 //x=7.347 //y=1.555 //x2=7.24 //y2=1.555
r933 (  87 279 ) resistor r=152 //w=0.17 //l=0.17 //layer=licon //count=1 \
 //x=74.86 //y=4.88 //x2=74.86 //y2=4.88
r934 (  81 286 ) resistor r=152 //w=0.17 //l=0.17 //layer=licon //count=1 \
 //x=74.86 //y=2.26 //x2=74.86 //y2=2.26
r935 (  78 268 ) resistor r=152 //w=0.17 //l=0.17 //layer=licon //count=1 \
 //x=65.24 //y=4.88 //x2=65.24 //y2=4.88
r936 (  73 275 ) resistor r=152 //w=0.17 //l=0.17 //layer=licon //count=1 \
 //x=65.24 //y=2.26 //x2=65.24 //y2=2.26
r937 (  70 257 ) resistor r=152 //w=0.17 //l=0.17 //layer=licon //count=1 \
 //x=46 //y=4.88 //x2=46 //y2=4.88
r938 (  64 264 ) resistor r=152 //w=0.17 //l=0.17 //layer=licon //count=1 \
 //x=46 //y=2.26 //x2=46 //y2=2.26
r939 (  61 246 ) resistor r=152 //w=0.17 //l=0.17 //layer=licon //count=1 \
 //x=36.38 //y=4.88 //x2=36.38 //y2=4.88
r940 (  55 253 ) resistor r=152 //w=0.17 //l=0.17 //layer=licon //count=1 \
 //x=36.38 //y=2.26 //x2=36.38 //y2=2.26
r941 (  52 235 ) resistor r=152 //w=0.17 //l=0.17 //layer=licon //count=1 \
 //x=17.14 //y=4.88 //x2=17.14 //y2=4.88
r942 (  46 242 ) resistor r=152 //w=0.17 //l=0.17 //layer=licon //count=1 \
 //x=17.14 //y=2.26 //x2=17.14 //y2=2.26
r943 (  43 224 ) resistor r=152 //w=0.17 //l=0.17 //layer=licon //count=1 \
 //x=7.52 //y=4.88 //x2=7.52 //y2=4.88
r944 (  36 231 ) resistor r=152 //w=0.17 //l=0.17 //layer=licon //count=1 \
 //x=7.52 //y=2.26 //x2=7.52 //y2=2.26
r945 (  34 87 ) resistor r=17.7968 //w=0.187 //l=0.26 //layer=li \
 //thickness=0.1 //x=74.86 //y=4.62 //x2=74.86 //y2=4.88
r946 (  33 34 ) resistor r=126.631 //w=0.187 //l=1.85 //layer=li \
 //thickness=0.1 //x=74.86 //y=2.77 //x2=74.86 //y2=4.62
r947 (  33 81 ) resistor r=34.9091 //w=0.187 //l=0.51 //layer=li \
 //thickness=0.1 //x=74.86 //y=2.77 //x2=74.86 //y2=2.26
r948 (  32 78 ) resistor r=17.7968 //w=0.187 //l=0.26 //layer=li \
 //thickness=0.1 //x=65.24 //y=4.62 //x2=65.24 //y2=4.88
r949 (  32 73 ) resistor r=161.54 //w=0.187 //l=2.36 //layer=li \
 //thickness=0.1 //x=65.24 //y=4.62 //x2=65.24 //y2=2.26
r950 (  31 70 ) resistor r=17.7968 //w=0.187 //l=0.26 //layer=li \
 //thickness=0.1 //x=46 //y=4.62 //x2=46 //y2=4.88
r951 (  30 31 ) resistor r=126.631 //w=0.187 //l=1.85 //layer=li \
 //thickness=0.1 //x=46 //y=2.77 //x2=46 //y2=4.62
r952 (  30 64 ) resistor r=34.9091 //w=0.187 //l=0.51 //layer=li \
 //thickness=0.1 //x=46 //y=2.77 //x2=46 //y2=2.26
r953 (  29 61 ) resistor r=17.7968 //w=0.187 //l=0.26 //layer=li \
 //thickness=0.1 //x=36.38 //y=4.62 //x2=36.38 //y2=4.88
r954 (  28 29 ) resistor r=50.6524 //w=0.187 //l=0.74 //layer=li \
 //thickness=0.1 //x=36.38 //y=3.88 //x2=36.38 //y2=4.62
r955 (  28 55 ) resistor r=110.888 //w=0.187 //l=1.62 //layer=li \
 //thickness=0.1 //x=36.38 //y=3.88 //x2=36.38 //y2=2.26
r956 (  27 52 ) resistor r=17.7968 //w=0.187 //l=0.26 //layer=li \
 //thickness=0.1 //x=17.14 //y=4.62 //x2=17.14 //y2=4.88
r957 (  26 27 ) resistor r=126.631 //w=0.187 //l=1.85 //layer=li \
 //thickness=0.1 //x=17.14 //y=2.77 //x2=17.14 //y2=4.62
r958 (  26 46 ) resistor r=34.9091 //w=0.187 //l=0.51 //layer=li \
 //thickness=0.1 //x=17.14 //y=2.77 //x2=17.14 //y2=2.26
r959 (  25 43 ) resistor r=17.7968 //w=0.187 //l=0.26 //layer=li \
 //thickness=0.1 //x=7.52 //y=4.62 //x2=7.52 //y2=4.88
r960 (  24 25 ) resistor r=50.6524 //w=0.187 //l=0.74 //layer=li \
 //thickness=0.1 //x=7.52 //y=3.88 //x2=7.52 //y2=4.62
r961 (  23 24 ) resistor r=50.6524 //w=0.187 //l=0.74 //layer=li \
 //thickness=0.1 //x=7.52 //y=3.14 //x2=7.52 //y2=3.88
r962 (  23 36 ) resistor r=60.2353 //w=0.187 //l=0.88 //layer=li \
 //thickness=0.1 //x=7.52 //y=3.14 //x2=7.52 //y2=2.26
r963 (  22 34 ) resistor r=9.3 //w=0.17 //l=0.17 //layer=mcon //count=1 \
 //x=74.86 //y=4.62 //x2=74.86 //y2=4.62
r964 (  20 32 ) resistor r=9.3 //w=0.17 //l=0.17 //layer=mcon //count=1 \
 //x=65.24 //y=4.62 //x2=65.24 //y2=4.62
r965 (  18 31 ) resistor r=9.3 //w=0.17 //l=0.17 //layer=mcon //count=1 //x=46 \
 //y=4.62 //x2=46 //y2=4.62
r966 (  16 29 ) resistor r=9.3 //w=0.17 //l=0.17 //layer=mcon //count=1 \
 //x=36.38 //y=4.62 //x2=36.38 //y2=4.62
r967 (  14 27 ) resistor r=9.3 //w=0.17 //l=0.17 //layer=mcon //count=1 \
 //x=17.14 //y=4.62 //x2=17.14 //y2=4.62
r968 (  12 25 ) resistor r=9.3 //w=0.17 //l=0.17 //layer=mcon //count=1 \
 //x=7.52 //y=4.62 //x2=7.52 //y2=4.62
r969 (  10 20 ) resistor r=0.0880901 //w=0.191 //l=0.115 //layer=m1 \
 //thickness=0.36 //x=65.355 //y=4.62 //x2=65.24 //y2=4.62
r970 (  9 22 ) resistor r=0.0717383 //w=0.224 //l=0.115 //layer=m1 \
 //thickness=0.36 //x=74.745 //y=4.62 //x2=74.86 //y2=4.62
r971 (  9 10 ) resistor r=8.95992 //w=0.131 //l=9.39 //layer=m1 \
 //thickness=0.36 //x=74.745 //y=4.62 //x2=65.355 //y2=4.62
r972 (  8 18 ) resistor r=0.0880901 //w=0.191 //l=0.115 //layer=m1 \
 //thickness=0.36 //x=46.115 //y=4.62 //x2=46 //y2=4.62
r973 (  7 20 ) resistor r=0.0880901 //w=0.191 //l=0.115 //layer=m1 \
 //thickness=0.36 //x=65.125 //y=4.62 //x2=65.24 //y2=4.62
r974 (  7 8 ) resistor r=18.1393 //w=0.131 //l=19.01 //layer=m1 \
 //thickness=0.36 //x=65.125 //y=4.62 //x2=46.115 //y2=4.62
r975 (  6 16 ) resistor r=0.0880901 //w=0.191 //l=0.115 //layer=m1 \
 //thickness=0.36 //x=36.495 //y=4.62 //x2=36.38 //y2=4.62
r976 (  5 18 ) resistor r=0.0880901 //w=0.191 //l=0.115 //layer=m1 \
 //thickness=0.36 //x=45.885 //y=4.62 //x2=46 //y2=4.62
r977 (  5 6 ) resistor r=8.95992 //w=0.131 //l=9.39 //layer=m1 \
 //thickness=0.36 //x=45.885 //y=4.62 //x2=36.495 //y2=4.62
r978 (  4 14 ) resistor r=0.0880901 //w=0.191 //l=0.115 //layer=m1 \
 //thickness=0.36 //x=17.255 //y=4.62 //x2=17.14 //y2=4.62
r979 (  3 16 ) resistor r=0.0880901 //w=0.191 //l=0.115 //layer=m1 \
 //thickness=0.36 //x=36.265 //y=4.62 //x2=36.38 //y2=4.62
r980 (  3 4 ) resistor r=18.1393 //w=0.131 //l=19.01 //layer=m1 \
 //thickness=0.36 //x=36.265 //y=4.62 //x2=17.255 //y2=4.62
r981 (  2 12 ) resistor r=0.0717383 //w=0.224 //l=0.115 //layer=m1 \
 //thickness=0.36 //x=7.635 //y=4.62 //x2=7.52 //y2=4.62
r982 (  1 14 ) resistor r=0.0880901 //w=0.191 //l=0.115 //layer=m1 \
 //thickness=0.36 //x=17.025 //y=4.62 //x2=17.14 //y2=4.62
r983 (  1 2 ) resistor r=8.95992 //w=0.131 //l=9.39 //layer=m1 \
 //thickness=0.36 //x=17.025 //y=4.62 //x2=7.635 //y2=4.62
ends PM_TMRDFFSNRNQNX1\%CLK

subckt PM_TMRDFFSNRNQNX1\%noxref_18 ( 1 2 3 4 12 25 26 33 41 47 48 52 54 61 62 \
 63 64 65 66 67 68 72 73 74 79 81 84 85 86 87 88 89 90 92 98 99 100 101 106 \
 107 112 123 125 126 127 )
c274 ( 127 0 ) capacitor c=0.023087f //x=66.165 //y=5.2
c275 ( 126 0 ) capacitor c=0.023519f //x=65.285 //y=5.2
c276 ( 125 0 ) capacitor c=0.0224735f //x=64.405 //y=5.2
c277 ( 123 0 ) capacitor c=0.00853354f //x=66.415 //y=1.095
c278 ( 112 0 ) capacitor c=0.0588394f //x=61.54 //y=4.88
c279 ( 107 0 ) capacitor c=0.0273931f //x=61.54 //y=2.095
c280 ( 106 0 ) capacitor c=0.0456313f //x=61.54 //y=2.26
c281 ( 101 0 ) capacitor c=0.0556143f //x=78.835 //y=4.97
c282 ( 100 0 ) capacitor c=0.0293157f //x=79.125 //y=4.97
c283 ( 99 0 ) capacitor c=0.0347816f //x=78.79 //y=1.4
c284 ( 98 0 ) capacitor c=0.0187487f //x=78.79 //y=1.055
c285 ( 92 0 ) capacitor c=0.0137055f //x=78.635 //y=1.555
c286 ( 90 0 ) capacitor c=0.0149861f //x=78.635 //y=0.9
c287 ( 89 0 ) capacitor c=0.096037f //x=78.26 //y=2.095
c288 ( 88 0 ) capacitor c=0.0228993f //x=78.26 //y=1.71
c289 ( 87 0 ) capacitor c=0.0234352f //x=78.26 //y=1.4
c290 ( 86 0 ) capacitor c=0.0198724f //x=78.26 //y=1.055
c291 ( 85 0 ) capacitor c=0.0432517f //x=62.06 //y=1.44
c292 ( 84 0 ) capacitor c=0.0200379f //x=62.06 //y=1.095
c293 ( 81 0 ) capacitor c=0.0148873f //x=61.905 //y=1.595
c294 ( 79 0 ) capacitor c=0.0157803f //x=61.905 //y=0.94
c295 ( 74 0 ) capacitor c=0.0218028f //x=61.53 //y=1.75
c296 ( 73 0 ) capacitor c=0.0207459f //x=61.53 //y=1.44
c297 ( 72 0 ) capacitor c=0.0194308f //x=61.53 //y=1.095
c298 ( 68 0 ) capacitor c=0.110114f //x=79.2 //y=6.2
c299 ( 67 0 ) capacitor c=0.158956f //x=78.76 //y=6.2
c300 ( 66 0 ) capacitor c=0.158754f //x=61.72 //y=6.2
c301 ( 65 0 ) capacitor c=0.109949f //x=61.28 //y=6.2
c302 ( 62 0 ) capacitor c=9.74268e-19 //x=66.31 //y=5.335
c303 ( 61 0 ) capacitor c=0.00191414f //x=65.43 //y=5.335
c304 ( 54 0 ) capacitor c=0.0958029f //x=78.56 //y=2.26
c305 ( 52 0 ) capacitor c=0.1027f //x=67.09 //y=3.51
c306 ( 48 0 ) capacitor c=0.00398962f //x=66.69 //y=1.845
c307 ( 47 0 ) capacitor c=0.0137288f //x=67.005 //y=1.845
c308 ( 41 0 ) capacitor c=0.0276208f //x=67.005 //y=5.335
c309 ( 33 0 ) capacitor c=0.0169868f //x=66.225 //y=5.335
c310 ( 26 0 ) capacitor c=0.00316998f //x=64.635 //y=5.335
c311 ( 25 0 ) capacitor c=0.014258f //x=65.345 //y=5.335
c312 ( 12 0 ) capacitor c=0.0814556f //x=61.54 //y=2.26
c313 ( 4 0 ) capacitor c=0.00551333f //x=67.205 //y=3.51
c314 ( 3 0 ) capacitor c=0.17826f //x=78.445 //y=3.51
c315 ( 2 0 ) capacitor c=0.0109971f //x=61.655 //y=3.51
c316 ( 1 0 ) capacitor c=0.077341f //x=66.975 //y=3.51
r317 (  106 107 ) resistor r=52.7279 //w=0.214 //l=0.165 //layer=ply \
 //thickness=0.18 //x=61.54 //y=2.26 //x2=61.54 //y2=2.095
r318 (  100 102 ) resistor r=26.9307 //w=0.15 //l=0.106066 //layer=ply \
 //thickness=0.18 //x=79.125 //y=4.97 //x2=79.2 //y2=5.045
r319 (  100 101 ) resistor r=148.702 //w=0.094 //l=0.29 //layer=ply \
 //thickness=0.18 //x=79.125 //y=4.97 //x2=78.835 //y2=4.97
r320 (  99 122 ) resistor r=45.1352 //w=0.168 //l=0.173853 //layer=ply \
 //thickness=0.18 //x=78.79 //y=1.4 //x2=78.75 //y2=1.555
r321 (  98 121 ) resistor r=45.1352 //w=0.168 //l=0.173853 //layer=ply \
 //thickness=0.18 //x=78.79 //y=1.055 //x2=78.75 //y2=0.9
r322 (  98 99 ) resistor r=176.904 //w=0.094 //l=0.345 //layer=ply \
 //thickness=0.18 //x=78.79 //y=1.055 //x2=78.79 //y2=1.4
r323 (  95 101 ) resistor r=22.7971 //w=0.269 //l=0.106066 //layer=ply \
 //thickness=0.18 //x=78.76 //y=5.045 //x2=78.835 //y2=4.97
r324 (  95 120 ) resistor r=35.8364 //w=0.269 //l=0.270185 //layer=ply \
 //thickness=0.18 //x=78.76 //y=5.045 //x2=78.56 //y2=4.88
r325 (  93 116 ) resistor r=10.701 //w=0.21 //l=0.115 //layer=ply \
 //thickness=0.18 //x=78.415 //y=1.555 //x2=78.3 //y2=1.555
r326 (  92 122 ) resistor r=5.52526 //w=0.168 //l=0.115 //layer=ply \
 //thickness=0.18 //x=78.635 //y=1.555 //x2=78.75 //y2=1.555
r327 (  91 115 ) resistor r=5.52526 //w=0.168 //l=0.115 //layer=ply \
 //thickness=0.18 //x=78.415 //y=0.9 //x2=78.3 //y2=0.9
r328 (  90 121 ) resistor r=5.52526 //w=0.168 //l=0.115 //layer=ply \
 //thickness=0.18 //x=78.635 //y=0.9 //x2=78.75 //y2=0.9
r329 (  90 91 ) resistor r=112.809 //w=0.094 //l=0.22 //layer=ply \
 //thickness=0.18 //x=78.635 //y=0.9 //x2=78.415 //y2=0.9
r330 (  89 118 ) resistor r=58.7805 //w=0.246 //l=0.373497 //layer=ply \
 //thickness=0.18 //x=78.26 //y=2.095 //x2=78.56 //y2=2.26
r331 (  88 116 ) resistor r=39.5823 //w=0.21 //l=0.173853 //layer=ply \
 //thickness=0.18 //x=78.26 //y=1.71 //x2=78.3 //y2=1.555
r332 (  88 89 ) resistor r=197.415 //w=0.094 //l=0.385 //layer=ply \
 //thickness=0.18 //x=78.26 //y=1.71 //x2=78.26 //y2=2.095
r333 (  87 116 ) resistor r=39.5823 //w=0.21 //l=0.173853 //layer=ply \
 //thickness=0.18 //x=78.26 //y=1.4 //x2=78.3 //y2=1.555
r334 (  86 115 ) resistor r=45.1352 //w=0.168 //l=0.173853 //layer=ply \
 //thickness=0.18 //x=78.26 //y=1.055 //x2=78.3 //y2=0.9
r335 (  86 87 ) resistor r=176.904 //w=0.094 //l=0.345 //layer=ply \
 //thickness=0.18 //x=78.26 //y=1.055 //x2=78.26 //y2=1.4
r336 (  85 114 ) resistor r=45.1352 //w=0.168 //l=0.173853 //layer=ply \
 //thickness=0.18 //x=62.06 //y=1.44 //x2=62.02 //y2=1.595
r337 (  84 113 ) resistor r=45.1352 //w=0.168 //l=0.173853 //layer=ply \
 //thickness=0.18 //x=62.06 //y=1.095 //x2=62.02 //y2=0.94
r338 (  84 85 ) resistor r=176.904 //w=0.094 //l=0.345 //layer=ply \
 //thickness=0.18 //x=62.06 //y=1.095 //x2=62.06 //y2=1.44
r339 (  82 110 ) resistor r=10.701 //w=0.21 //l=0.115 //layer=ply \
 //thickness=0.18 //x=61.685 //y=1.595 //x2=61.57 //y2=1.595
r340 (  81 114 ) resistor r=5.52526 //w=0.168 //l=0.115 //layer=ply \
 //thickness=0.18 //x=61.905 //y=1.595 //x2=62.02 //y2=1.595
r341 (  80 109 ) resistor r=5.52526 //w=0.168 //l=0.115 //layer=ply \
 //thickness=0.18 //x=61.685 //y=0.94 //x2=61.57 //y2=0.94
r342 (  79 113 ) resistor r=5.52526 //w=0.168 //l=0.115 //layer=ply \
 //thickness=0.18 //x=61.905 //y=0.94 //x2=62.02 //y2=0.94
r343 (  79 80 ) resistor r=112.809 //w=0.094 //l=0.22 //layer=ply \
 //thickness=0.18 //x=61.905 //y=0.94 //x2=61.685 //y2=0.94
r344 (  76 112 ) resistor r=37.236 //w=0.233 //l=0.249199 //layer=ply \
 //thickness=0.18 //x=61.72 //y=5.045 //x2=61.54 //y2=4.88
r345 (  74 110 ) resistor r=39.5823 //w=0.21 //l=0.173853 //layer=ply \
 //thickness=0.18 //x=61.53 //y=1.75 //x2=61.57 //y2=1.595
r346 (  74 107 ) resistor r=176.904 //w=0.094 //l=0.345 //layer=ply \
 //thickness=0.18 //x=61.53 //y=1.75 //x2=61.53 //y2=2.095
r347 (  73 110 ) resistor r=39.5823 //w=0.21 //l=0.173853 //layer=ply \
 //thickness=0.18 //x=61.53 //y=1.44 //x2=61.57 //y2=1.595
r348 (  72 109 ) resistor r=45.1352 //w=0.168 //l=0.173853 //layer=ply \
 //thickness=0.18 //x=61.53 //y=1.095 //x2=61.57 //y2=0.94
r349 (  72 73 ) resistor r=176.904 //w=0.094 //l=0.345 //layer=ply \
 //thickness=0.18 //x=61.53 //y=1.095 //x2=61.53 //y2=1.44
r350 (  69 112 ) resistor r=53.7854 //w=0.233 //l=0.332415 //layer=ply \
 //thickness=0.18 //x=61.28 //y=5.045 //x2=61.54 //y2=4.88
r351 (  68 102 ) resistor r=592.245 //w=0.094 //l=1.155 //layer=ply \
 //thickness=0.18 //x=79.2 //y=6.2 //x2=79.2 //y2=5.045
r352 (  67 95 ) resistor r=592.245 //w=0.094 //l=1.155 //layer=ply \
 //thickness=0.18 //x=78.76 //y=6.2 //x2=78.76 //y2=5.045
r353 (  66 76 ) resistor r=592.245 //w=0.094 //l=1.155 //layer=ply \
 //thickness=0.18 //x=61.72 //y=6.2 //x2=61.72 //y2=5.045
r354 (  65 69 ) resistor r=592.245 //w=0.094 //l=1.155 //layer=ply \
 //thickness=0.18 //x=61.28 //y=6.2 //x2=61.28 //y2=5.045
r355 (  64 92 ) resistor r=56.4043 //w=0.094 //l=0.11 //layer=ply \
 //thickness=0.18 //x=78.525 //y=1.555 //x2=78.635 //y2=1.555
r356 (  64 93 ) resistor r=56.4043 //w=0.094 //l=0.11 //layer=ply \
 //thickness=0.18 //x=78.525 //y=1.555 //x2=78.415 //y2=1.555
r357 (  63 81 ) resistor r=56.4043 //w=0.094 //l=0.11 //layer=ply \
 //thickness=0.18 //x=61.795 //y=1.595 //x2=61.905 //y2=1.595
r358 (  63 82 ) resistor r=56.4043 //w=0.094 //l=0.11 //layer=ply \
 //thickness=0.18 //x=61.795 //y=1.595 //x2=61.685 //y2=1.595
r359 (  59 120 ) resistor r=152 //w=0.17 //l=0.17 //layer=licon //count=1 \
 //x=78.56 //y=4.88 //x2=78.56 //y2=4.88
r360 (  57 59 ) resistor r=93.7754 //w=0.187 //l=1.37 //layer=li \
 //thickness=0.1 //x=78.56 //y=3.51 //x2=78.56 //y2=4.88
r361 (  54 118 ) resistor r=152 //w=0.17 //l=0.17 //layer=licon //count=1 \
 //x=78.56 //y=2.26 //x2=78.56 //y2=2.26
r362 (  54 57 ) resistor r=85.5615 //w=0.187 //l=1.25 //layer=li \
 //thickness=0.1 //x=78.56 //y=2.26 //x2=78.56 //y2=3.51
r363 (  50 52 ) resistor r=119.102 //w=0.187 //l=1.74 //layer=li \
 //thickness=0.1 //x=67.09 //y=5.25 //x2=67.09 //y2=3.51
r364 (  49 52 ) resistor r=108.15 //w=0.187 //l=1.58 //layer=li \
 //thickness=0.1 //x=67.09 //y=1.93 //x2=67.09 //y2=3.51
r365 (  47 49 ) resistor r=7.15173 //w=0.17 //l=0.120208 //layer=li \
 //thickness=0.1 //x=67.005 //y=1.845 //x2=67.09 //y2=1.93
r366 (  47 48 ) resistor r=21.5615 //w=0.187 //l=0.315 //layer=li \
 //thickness=0.1 //x=67.005 //y=1.845 //x2=66.69 //y2=1.845
r367 (  43 48 ) resistor r=7.15173 //w=0.17 //l=0.120208 //layer=li \
 //thickness=0.1 //x=66.605 //y=1.76 //x2=66.69 //y2=1.845
r368 (  43 123 ) resistor r=39.016 //w=0.187 //l=0.57 //layer=li \
 //thickness=0.1 //x=66.605 //y=1.76 //x2=66.605 //y2=1.19
r369 (  42 62 ) resistor r=5.4201 //w=0.17 //l=0.085 //layer=li \
 //thickness=0.1 //x=66.395 //y=5.335 //x2=66.31 //y2=5.335
r370 (  41 50 ) resistor r=7.15173 //w=0.17 //l=0.120208 //layer=li \
 //thickness=0.1 //x=67.005 //y=5.335 //x2=67.09 //y2=5.25
r371 (  41 42 ) resistor r=41.754 //w=0.187 //l=0.61 //layer=li \
 //thickness=0.1 //x=67.005 //y=5.335 //x2=66.395 //y2=5.335
r372 (  35 62 ) resistor r=1.40859 //w=0.34 //l=0.085 //layer=li \
 //thickness=0.1 //x=66.31 //y=5.42 //x2=66.31 //y2=5.335
r373 (  35 127 ) resistor r=33.1979 //w=0.187 //l=0.485 //layer=li \
 //thickness=0.1 //x=66.31 //y=5.42 //x2=66.31 //y2=5.905
r374 (  34 61 ) resistor r=5.4201 //w=0.17 //l=0.085 //layer=li \
 //thickness=0.1 //x=65.515 //y=5.335 //x2=65.43 //y2=5.335
r375 (  33 62 ) resistor r=5.4201 //w=0.17 //l=0.085 //layer=li \
 //thickness=0.1 //x=66.225 //y=5.335 //x2=66.31 //y2=5.335
r376 (  33 34 ) resistor r=48.5989 //w=0.187 //l=0.71 //layer=li \
 //thickness=0.1 //x=66.225 //y=5.335 //x2=65.515 //y2=5.335
r377 (  27 61 ) resistor r=1.40859 //w=0.34 //l=0.085 //layer=li \
 //thickness=0.1 //x=65.43 //y=5.42 //x2=65.43 //y2=5.335
r378 (  27 126 ) resistor r=33.1979 //w=0.187 //l=0.485 //layer=li \
 //thickness=0.1 //x=65.43 //y=5.42 //x2=65.43 //y2=5.905
r379 (  25 61 ) resistor r=5.4201 //w=0.17 //l=0.085 //layer=li \
 //thickness=0.1 //x=65.345 //y=5.335 //x2=65.43 //y2=5.335
r380 (  25 26 ) resistor r=48.5989 //w=0.187 //l=0.71 //layer=li \
 //thickness=0.1 //x=65.345 //y=5.335 //x2=64.635 //y2=5.335
r381 (  19 26 ) resistor r=7.15173 //w=0.17 //l=0.120208 //layer=li \
 //thickness=0.1 //x=64.55 //y=5.42 //x2=64.635 //y2=5.335
r382 (  19 125 ) resistor r=33.1979 //w=0.187 //l=0.485 //layer=li \
 //thickness=0.1 //x=64.55 //y=5.42 //x2=64.55 //y2=5.905
r383 (  17 112 ) resistor r=152 //w=0.17 //l=0.17 //layer=licon //count=1 \
 //x=61.54 //y=4.88 //x2=61.54 //y2=4.88
r384 (  15 17 ) resistor r=93.7754 //w=0.187 //l=1.37 //layer=li \
 //thickness=0.1 //x=61.54 //y=3.51 //x2=61.54 //y2=4.88
r385 (  12 106 ) resistor r=152 //w=0.17 //l=0.17 //layer=licon //count=1 \
 //x=61.54 //y=2.26 //x2=61.54 //y2=2.26
r386 (  12 15 ) resistor r=85.5615 //w=0.187 //l=1.25 //layer=li \
 //thickness=0.1 //x=61.54 //y=2.26 //x2=61.54 //y2=3.51
r387 (  10 57 ) resistor r=9.3 //w=0.17 //l=0.17 //layer=mcon //count=1 \
 //x=78.56 //y=3.51 //x2=78.56 //y2=3.51
r388 (  8 52 ) resistor r=9.3 //w=0.17 //l=0.17 //layer=mcon //count=1 \
 //x=67.09 //y=3.51 //x2=67.09 //y2=3.51
r389 (  6 15 ) resistor r=9.3 //w=0.17 //l=0.17 //layer=mcon //count=1 \
 //x=61.54 //y=3.51 //x2=61.54 //y2=3.51
r390 (  4 8 ) resistor r=0.0880901 //w=0.191 //l=0.115 //layer=m1 \
 //thickness=0.36 //x=67.205 //y=3.51 //x2=67.09 //y2=3.51
r391 (  3 10 ) resistor r=0.0717383 //w=0.224 //l=0.115 //layer=m1 \
 //thickness=0.36 //x=78.445 //y=3.51 //x2=78.56 //y2=3.51
r392 (  3 4 ) resistor r=10.7252 //w=0.131 //l=11.24 //layer=m1 \
 //thickness=0.36 //x=78.445 //y=3.51 //x2=67.205 //y2=3.51
r393 (  2 6 ) resistor r=0.0717383 //w=0.224 //l=0.115 //layer=m1 \
 //thickness=0.36 //x=61.655 //y=3.51 //x2=61.54 //y2=3.51
r394 (  1 8 ) resistor r=0.0880901 //w=0.191 //l=0.115 //layer=m1 \
 //thickness=0.36 //x=66.975 //y=3.51 //x2=67.09 //y2=3.51
r395 (  1 2 ) resistor r=5.07634 //w=0.131 //l=5.32 //layer=m1 \
 //thickness=0.36 //x=66.975 //y=3.51 //x2=61.655 //y2=3.51
ends PM_TMRDFFSNRNQNX1\%noxref_18

subckt PM_TMRDFFSNRNQNX1\%RN ( 1 2 3 4 5 6 7 8 9 10 11 12 13 14 15 16 35 36 37 \
 38 39 40 41 42 43 44 45 46 47 48 49 50 51 52 53 54 55 56 57 58 59 60 61 62 63 \
 65 78 87 97 108 117 127 138 147 156 157 158 159 160 161 162 163 164 165 166 \
 167 168 169 170 171 172 173 174 175 176 177 178 179 180 181 182 183 184 185 \
 187 193 194 195 196 197 205 206 207 212 214 217 218 219 220 221 223 229 230 \
 231 232 233 238 239 240 242 248 249 250 251 252 260 261 262 267 269 272 273 \
 274 275 276 278 284 285 286 287 288 293 294 295 297 303 304 305 306 307 315 \
 316 317 322 324 327 328 329 330 331 333 339 340 341 342 343 351 360 361 366 \
 372 383 392 393 398 404 415 424 425 430 436 )
c1108 ( 436 0 ) capacitor c=0.0335551f //x=79.67 //y=4.88
c1109 ( 430 0 ) capacitor c=0.0584472f //x=75.97 //y=4.88
c1110 ( 425 0 ) capacitor c=0.0273931f //x=75.97 //y=2.095
c1111 ( 424 0 ) capacitor c=0.0455604f //x=75.97 //y=2.26
c1112 ( 415 0 ) capacitor c=0.0333886f //x=60.43 //y=4.88
c1113 ( 404 0 ) capacitor c=0.0333886f //x=50.81 //y=4.88
c1114 ( 398 0 ) capacitor c=0.0589949f //x=47.11 //y=4.88
c1115 ( 393 0 ) capacitor c=0.0273931f //x=47.11 //y=2.095
c1116 ( 392 0 ) capacitor c=0.0455604f //x=47.11 //y=2.26
c1117 ( 383 0 ) capacitor c=0.0333886f //x=31.57 //y=4.88
c1118 ( 372 0 ) capacitor c=0.0335551f //x=21.95 //y=4.88
c1119 ( 366 0 ) capacitor c=0.058931f //x=18.25 //y=4.88
c1120 ( 361 0 ) capacitor c=0.0273931f //x=18.25 //y=2.095
c1121 ( 360 0 ) capacitor c=0.0455604f //x=18.25 //y=2.26
c1122 ( 351 0 ) capacitor c=0.0336203f //x=2.71 //y=4.88
c1123 ( 343 0 ) capacitor c=0.0245352f //x=80.005 //y=4.97
c1124 ( 342 0 ) capacitor c=0.0827272f //x=79.76 //y=2.095
c1125 ( 341 0 ) capacitor c=0.0170266f //x=79.76 //y=1.63
c1126 ( 340 0 ) capacitor c=0.018609f //x=79.76 //y=1.4
c1127 ( 339 0 ) capacitor c=0.0187309f //x=79.76 //y=1.09
c1128 ( 333 0 ) capacitor c=0.014725f //x=79.605 //y=1.555
c1129 ( 331 0 ) capacitor c=0.0146567f //x=79.605 //y=0.935
c1130 ( 330 0 ) capacitor c=0.0335408f //x=79.235 //y=1.4
c1131 ( 329 0 ) capacitor c=0.0173761f //x=79.235 //y=1.09
c1132 ( 328 0 ) capacitor c=0.0432517f //x=76.49 //y=1.44
c1133 ( 327 0 ) capacitor c=0.0200379f //x=76.49 //y=1.095
c1134 ( 324 0 ) capacitor c=0.0148873f //x=76.335 //y=1.595
c1135 ( 322 0 ) capacitor c=0.0157803f //x=76.335 //y=0.94
c1136 ( 317 0 ) capacitor c=0.0218028f //x=75.96 //y=1.75
c1137 ( 316 0 ) capacitor c=0.0207459f //x=75.96 //y=1.44
c1138 ( 315 0 ) capacitor c=0.0194308f //x=75.96 //y=1.095
c1139 ( 307 0 ) capacitor c=0.0246783f //x=60.765 //y=4.97
c1140 ( 306 0 ) capacitor c=0.0825033f //x=60.52 //y=2.095
c1141 ( 305 0 ) capacitor c=0.0170266f //x=60.52 //y=1.63
c1142 ( 304 0 ) capacitor c=0.018609f //x=60.52 //y=1.4
c1143 ( 303 0 ) capacitor c=0.0187309f //x=60.52 //y=1.09
c1144 ( 297 0 ) capacitor c=0.014725f //x=60.365 //y=1.555
c1145 ( 295 0 ) capacitor c=0.0146567f //x=60.365 //y=0.935
c1146 ( 294 0 ) capacitor c=0.0335408f //x=59.995 //y=1.4
c1147 ( 293 0 ) capacitor c=0.0173761f //x=59.995 //y=1.09
c1148 ( 288 0 ) capacitor c=0.0246783f //x=51.145 //y=4.97
c1149 ( 287 0 ) capacitor c=0.0825033f //x=50.9 //y=2.095
c1150 ( 286 0 ) capacitor c=0.0170266f //x=50.9 //y=1.63
c1151 ( 285 0 ) capacitor c=0.018609f //x=50.9 //y=1.4
c1152 ( 284 0 ) capacitor c=0.0187309f //x=50.9 //y=1.09
c1153 ( 278 0 ) capacitor c=0.014725f //x=50.745 //y=1.555
c1154 ( 276 0 ) capacitor c=0.0146567f //x=50.745 //y=0.935
c1155 ( 275 0 ) capacitor c=0.0335408f //x=50.375 //y=1.4
c1156 ( 274 0 ) capacitor c=0.0173761f //x=50.375 //y=1.09
c1157 ( 273 0 ) capacitor c=0.0432517f //x=47.63 //y=1.44
c1158 ( 272 0 ) capacitor c=0.0200379f //x=47.63 //y=1.095
c1159 ( 269 0 ) capacitor c=0.0148873f //x=47.475 //y=1.595
c1160 ( 267 0 ) capacitor c=0.0157803f //x=47.475 //y=0.94
c1161 ( 262 0 ) capacitor c=0.0218028f //x=47.1 //y=1.75
c1162 ( 261 0 ) capacitor c=0.0207459f //x=47.1 //y=1.44
c1163 ( 260 0 ) capacitor c=0.0194308f //x=47.1 //y=1.095
c1164 ( 252 0 ) capacitor c=0.0246783f //x=31.905 //y=4.97
c1165 ( 251 0 ) capacitor c=0.0825033f //x=31.66 //y=2.095
c1166 ( 250 0 ) capacitor c=0.0170266f //x=31.66 //y=1.63
c1167 ( 249 0 ) capacitor c=0.018609f //x=31.66 //y=1.4
c1168 ( 248 0 ) capacitor c=0.0187309f //x=31.66 //y=1.09
c1169 ( 242 0 ) capacitor c=0.014725f //x=31.505 //y=1.555
c1170 ( 240 0 ) capacitor c=0.0146567f //x=31.505 //y=0.935
c1171 ( 239 0 ) capacitor c=0.0335408f //x=31.135 //y=1.4
c1172 ( 238 0 ) capacitor c=0.0173761f //x=31.135 //y=1.09
c1173 ( 233 0 ) capacitor c=0.0245352f //x=22.285 //y=4.97
c1174 ( 232 0 ) capacitor c=0.0825033f //x=22.04 //y=2.095
c1175 ( 231 0 ) capacitor c=0.0170266f //x=22.04 //y=1.63
c1176 ( 230 0 ) capacitor c=0.018609f //x=22.04 //y=1.4
c1177 ( 229 0 ) capacitor c=0.0187309f //x=22.04 //y=1.09
c1178 ( 223 0 ) capacitor c=0.014725f //x=21.885 //y=1.555
c1179 ( 221 0 ) capacitor c=0.0146567f //x=21.885 //y=0.935
c1180 ( 220 0 ) capacitor c=0.0335408f //x=21.515 //y=1.4
c1181 ( 219 0 ) capacitor c=0.0173761f //x=21.515 //y=1.09
c1182 ( 218 0 ) capacitor c=0.0432517f //x=18.77 //y=1.44
c1183 ( 217 0 ) capacitor c=0.0200379f //x=18.77 //y=1.095
c1184 ( 214 0 ) capacitor c=0.0148873f //x=18.615 //y=1.595
c1185 ( 212 0 ) capacitor c=0.0157803f //x=18.615 //y=0.94
c1186 ( 207 0 ) capacitor c=0.0218028f //x=18.24 //y=1.75
c1187 ( 206 0 ) capacitor c=0.0207459f //x=18.24 //y=1.44
c1188 ( 205 0 ) capacitor c=0.0194308f //x=18.24 //y=1.095
c1189 ( 197 0 ) capacitor c=0.024933f //x=3.045 //y=4.97
c1190 ( 196 0 ) capacitor c=0.0826756f //x=2.8 //y=2.095
c1191 ( 195 0 ) capacitor c=0.0170266f //x=2.8 //y=1.63
c1192 ( 194 0 ) capacitor c=0.018609f //x=2.8 //y=1.4
c1193 ( 193 0 ) capacitor c=0.0187309f //x=2.8 //y=1.09
c1194 ( 187 0 ) capacitor c=0.014725f //x=2.645 //y=1.555
c1195 ( 185 0 ) capacitor c=0.0146567f //x=2.645 //y=0.935
c1196 ( 184 0 ) capacitor c=0.0335408f //x=2.275 //y=1.4
c1197 ( 183 0 ) capacitor c=0.0173761f //x=2.275 //y=1.09
c1198 ( 182 0 ) capacitor c=0.110114f //x=80.08 //y=6.2
c1199 ( 181 0 ) capacitor c=0.11012f //x=79.64 //y=6.2
c1200 ( 180 0 ) capacitor c=0.158794f //x=76.15 //y=6.2
c1201 ( 179 0 ) capacitor c=0.11002f //x=75.71 //y=6.2
c1202 ( 178 0 ) capacitor c=0.109949f //x=60.84 //y=6.2
c1203 ( 177 0 ) capacitor c=0.109956f //x=60.4 //y=6.2
c1204 ( 176 0 ) capacitor c=0.109949f //x=51.22 //y=6.2
c1205 ( 175 0 ) capacitor c=0.109956f //x=50.78 //y=6.2
c1206 ( 174 0 ) capacitor c=0.158754f //x=47.29 //y=6.2
c1207 ( 173 0 ) capacitor c=0.109949f //x=46.85 //y=6.2
c1208 ( 172 0 ) capacitor c=0.109949f //x=31.98 //y=6.2
c1209 ( 171 0 ) capacitor c=0.109956f //x=31.54 //y=6.2
c1210 ( 170 0 ) capacitor c=0.110114f //x=22.36 //y=6.2
c1211 ( 169 0 ) capacitor c=0.11012f //x=21.92 //y=6.2
c1212 ( 168 0 ) capacitor c=0.158794f //x=18.43 //y=6.2
c1213 ( 167 0 ) capacitor c=0.110114f //x=17.99 //y=6.2
c1214 ( 166 0 ) capacitor c=0.110114f //x=3.12 //y=6.2
c1215 ( 165 0 ) capacitor c=0.11012f //x=2.68 //y=6.2
c1216 ( 147 0 ) capacitor c=0.0921679f //x=79.67 //y=2.26
c1217 ( 138 0 ) capacitor c=0.0818106f //x=75.97 //y=2.26
c1218 ( 127 0 ) capacitor c=0.0920722f //x=60.43 //y=2.26
c1219 ( 117 0 ) capacitor c=0.0898147f //x=50.81 //y=2.26
c1220 ( 108 0 ) capacitor c=0.0797966f //x=47.11 //y=2.26
c1221 ( 97 0 ) capacitor c=0.0929489f //x=31.57 //y=2.26
c1222 ( 87 0 ) capacitor c=0.0915318f //x=21.95 //y=2.26
c1223 ( 78 0 ) capacitor c=0.081834f //x=18.25 //y=2.26
c1224 ( 65 0 ) capacitor c=0.100124f //x=2.71 //y=2.26
c1225 ( 16 0 ) capacitor c=0.00626811f //x=76.085 //y=2.4
c1226 ( 15 0 ) capacitor c=0.0896247f //x=79.555 //y=2.4
c1227 ( 14 0 ) capacitor c=0.00683472f //x=60.545 //y=2.4
c1228 ( 13 0 ) capacitor c=0.318477f //x=75.855 //y=2.4
c1229 ( 12 0 ) capacitor c=0.0059254f //x=50.925 //y=2.4
c1230 ( 11 0 ) capacitor c=0.196303f //x=60.315 //y=2.4
c1231 ( 10 0 ) capacitor c=0.00618146f //x=47.225 //y=2.4
c1232 ( 9 0 ) capacitor c=0.0804516f //x=50.695 //y=2.4
c1233 ( 8 0 ) capacitor c=0.00683472f //x=31.685 //y=2.4
c1234 ( 7 0 ) capacitor c=0.318477f //x=46.995 //y=2.4
c1235 ( 6 0 ) capacitor c=0.00601205f //x=22.065 //y=2.4
c1236 ( 5 0 ) capacitor c=0.20788f //x=31.455 //y=2.4
c1237 ( 4 0 ) capacitor c=0.00626811f //x=18.365 //y=2.4
c1238 ( 3 0 ) capacitor c=0.0805381f //x=21.835 //y=2.4
c1239 ( 2 0 ) capacitor c=0.0163048f //x=2.825 //y=2.4
c1240 ( 1 0 ) capacitor c=0.330466f //x=18.135 //y=2.4
r1241 (  438 439 ) resistor r=32.4568 //w=0.214 //l=0.075 //layer=ply \
 //thickness=0.18 //x=79.67 //y=4.97 //x2=79.67 //y2=5.045
r1242 (  436 438 ) resistor r=20.271 //w=0.214 //l=0.09 //layer=ply \
 //thickness=0.18 //x=79.67 //y=4.88 //x2=79.67 //y2=4.97
r1243 (  424 425 ) resistor r=52.7279 //w=0.214 //l=0.165 //layer=ply \
 //thickness=0.18 //x=75.97 //y=2.26 //x2=75.97 //y2=2.095
r1244 (  417 418 ) resistor r=32.4568 //w=0.214 //l=0.075 //layer=ply \
 //thickness=0.18 //x=60.43 //y=4.97 //x2=60.43 //y2=5.045
r1245 (  415 417 ) resistor r=20.271 //w=0.214 //l=0.09 //layer=ply \
 //thickness=0.18 //x=60.43 //y=4.88 //x2=60.43 //y2=4.97
r1246 (  406 407 ) resistor r=32.4568 //w=0.214 //l=0.075 //layer=ply \
 //thickness=0.18 //x=50.81 //y=4.97 //x2=50.81 //y2=5.045
r1247 (  404 406 ) resistor r=20.271 //w=0.214 //l=0.09 //layer=ply \
 //thickness=0.18 //x=50.81 //y=4.88 //x2=50.81 //y2=4.97
r1248 (  392 393 ) resistor r=52.7279 //w=0.214 //l=0.165 //layer=ply \
 //thickness=0.18 //x=47.11 //y=2.26 //x2=47.11 //y2=2.095
r1249 (  385 386 ) resistor r=32.4568 //w=0.214 //l=0.075 //layer=ply \
 //thickness=0.18 //x=31.57 //y=4.97 //x2=31.57 //y2=5.045
r1250 (  383 385 ) resistor r=20.271 //w=0.214 //l=0.09 //layer=ply \
 //thickness=0.18 //x=31.57 //y=4.88 //x2=31.57 //y2=4.97
r1251 (  374 375 ) resistor r=32.4568 //w=0.214 //l=0.075 //layer=ply \
 //thickness=0.18 //x=21.95 //y=4.97 //x2=21.95 //y2=5.045
r1252 (  372 374 ) resistor r=20.271 //w=0.214 //l=0.09 //layer=ply \
 //thickness=0.18 //x=21.95 //y=4.88 //x2=21.95 //y2=4.97
r1253 (  360 361 ) resistor r=52.7279 //w=0.214 //l=0.165 //layer=ply \
 //thickness=0.18 //x=18.25 //y=2.26 //x2=18.25 //y2=2.095
r1254 (  353 354 ) resistor r=32.4568 //w=0.214 //l=0.075 //layer=ply \
 //thickness=0.18 //x=2.71 //y=4.97 //x2=2.71 //y2=5.045
r1255 (  351 353 ) resistor r=20.271 //w=0.214 //l=0.09 //layer=ply \
 //thickness=0.18 //x=2.71 //y=4.88 //x2=2.71 //y2=4.97
r1256 (  344 438 ) resistor r=16.5046 //w=0.27 //l=0.135 //layer=ply \
 //thickness=0.18 //x=79.805 //y=4.97 //x2=79.67 //y2=4.97
r1257 (  343 345 ) resistor r=26.9307 //w=0.15 //l=0.106066 //layer=ply \
 //thickness=0.18 //x=80.005 //y=4.97 //x2=80.08 //y2=5.045
r1258 (  343 344 ) resistor r=102.553 //w=0.094 //l=0.2 //layer=ply \
 //thickness=0.18 //x=80.005 //y=4.97 //x2=79.805 //y2=4.97
r1259 (  342 443 ) resistor r=38.6777 //w=0.284 //l=0.198997 //layer=ply \
 //thickness=0.18 //x=79.76 //y=2.095 //x2=79.685 //y2=2.26
r1260 (  341 441 ) resistor r=21.2976 //w=0.217 //l=0.0928709 //layer=ply \
 //thickness=0.18 //x=79.76 //y=1.63 //x2=79.72 //y2=1.555
r1261 (  341 342 ) resistor r=238.436 //w=0.094 //l=0.465 //layer=ply \
 //thickness=0.18 //x=79.76 //y=1.63 //x2=79.76 //y2=2.095
r1262 (  340 441 ) resistor r=39.0671 //w=0.217 //l=0.173853 //layer=ply \
 //thickness=0.18 //x=79.76 //y=1.4 //x2=79.72 //y2=1.555
r1263 (  339 440 ) resistor r=45.1352 //w=0.168 //l=0.173853 //layer=ply \
 //thickness=0.18 //x=79.76 //y=1.09 //x2=79.72 //y2=0.935
r1264 (  339 340 ) resistor r=158.957 //w=0.094 //l=0.31 //layer=ply \
 //thickness=0.18 //x=79.76 //y=1.09 //x2=79.76 //y2=1.4
r1265 (  334 434 ) resistor r=5.52526 //w=0.168 //l=0.115 //layer=ply \
 //thickness=0.18 //x=79.39 //y=1.555 //x2=79.275 //y2=1.555
r1266 (  333 441 ) resistor r=11.4558 //w=0.217 //l=0.115 //layer=ply \
 //thickness=0.18 //x=79.605 //y=1.555 //x2=79.72 //y2=1.555
r1267 (  332 433 ) resistor r=5.52526 //w=0.168 //l=0.115 //layer=ply \
 //thickness=0.18 //x=79.39 //y=0.935 //x2=79.275 //y2=0.935
r1268 (  331 440 ) resistor r=5.52526 //w=0.168 //l=0.115 //layer=ply \
 //thickness=0.18 //x=79.605 //y=0.935 //x2=79.72 //y2=0.935
r1269 (  331 332 ) resistor r=110.245 //w=0.094 //l=0.215 //layer=ply \
 //thickness=0.18 //x=79.605 //y=0.935 //x2=79.39 //y2=0.935
r1270 (  330 434 ) resistor r=45.1352 //w=0.168 //l=0.173853 //layer=ply \
 //thickness=0.18 //x=79.235 //y=1.4 //x2=79.275 //y2=1.555
r1271 (  329 433 ) resistor r=45.1352 //w=0.168 //l=0.173853 //layer=ply \
 //thickness=0.18 //x=79.235 //y=1.09 //x2=79.275 //y2=0.935
r1272 (  329 330 ) resistor r=158.957 //w=0.094 //l=0.31 //layer=ply \
 //thickness=0.18 //x=79.235 //y=1.09 //x2=79.235 //y2=1.4
r1273 (  328 432 ) resistor r=45.1352 //w=0.168 //l=0.173853 //layer=ply \
 //thickness=0.18 //x=76.49 //y=1.44 //x2=76.45 //y2=1.595
r1274 (  327 431 ) resistor r=45.1352 //w=0.168 //l=0.173853 //layer=ply \
 //thickness=0.18 //x=76.49 //y=1.095 //x2=76.45 //y2=0.94
r1275 (  327 328 ) resistor r=176.904 //w=0.094 //l=0.345 //layer=ply \
 //thickness=0.18 //x=76.49 //y=1.095 //x2=76.49 //y2=1.44
r1276 (  325 428 ) resistor r=10.701 //w=0.21 //l=0.115 //layer=ply \
 //thickness=0.18 //x=76.115 //y=1.595 //x2=76 //y2=1.595
r1277 (  324 432 ) resistor r=5.52526 //w=0.168 //l=0.115 //layer=ply \
 //thickness=0.18 //x=76.335 //y=1.595 //x2=76.45 //y2=1.595
r1278 (  323 427 ) resistor r=5.52526 //w=0.168 //l=0.115 //layer=ply \
 //thickness=0.18 //x=76.115 //y=0.94 //x2=76 //y2=0.94
r1279 (  322 431 ) resistor r=5.52526 //w=0.168 //l=0.115 //layer=ply \
 //thickness=0.18 //x=76.335 //y=0.94 //x2=76.45 //y2=0.94
r1280 (  322 323 ) resistor r=112.809 //w=0.094 //l=0.22 //layer=ply \
 //thickness=0.18 //x=76.335 //y=0.94 //x2=76.115 //y2=0.94
r1281 (  319 430 ) resistor r=37.236 //w=0.233 //l=0.249199 //layer=ply \
 //thickness=0.18 //x=76.15 //y=5.045 //x2=75.97 //y2=4.88
r1282 (  317 428 ) resistor r=39.5823 //w=0.21 //l=0.173853 //layer=ply \
 //thickness=0.18 //x=75.96 //y=1.75 //x2=76 //y2=1.595
r1283 (  317 425 ) resistor r=176.904 //w=0.094 //l=0.345 //layer=ply \
 //thickness=0.18 //x=75.96 //y=1.75 //x2=75.96 //y2=2.095
r1284 (  316 428 ) resistor r=39.5823 //w=0.21 //l=0.173853 //layer=ply \
 //thickness=0.18 //x=75.96 //y=1.44 //x2=76 //y2=1.595
r1285 (  315 427 ) resistor r=45.1352 //w=0.168 //l=0.173853 //layer=ply \
 //thickness=0.18 //x=75.96 //y=1.095 //x2=76 //y2=0.94
r1286 (  315 316 ) resistor r=176.904 //w=0.094 //l=0.345 //layer=ply \
 //thickness=0.18 //x=75.96 //y=1.095 //x2=75.96 //y2=1.44
r1287 (  312 430 ) resistor r=53.7854 //w=0.233 //l=0.332415 //layer=ply \
 //thickness=0.18 //x=75.71 //y=5.045 //x2=75.97 //y2=4.88
r1288 (  308 417 ) resistor r=16.5046 //w=0.27 //l=0.135 //layer=ply \
 //thickness=0.18 //x=60.565 //y=4.97 //x2=60.43 //y2=4.97
r1289 (  307 309 ) resistor r=26.9307 //w=0.15 //l=0.106066 //layer=ply \
 //thickness=0.18 //x=60.765 //y=4.97 //x2=60.84 //y2=5.045
r1290 (  307 308 ) resistor r=102.553 //w=0.094 //l=0.2 //layer=ply \
 //thickness=0.18 //x=60.765 //y=4.97 //x2=60.565 //y2=4.97
r1291 (  306 422 ) resistor r=38.6777 //w=0.284 //l=0.198997 //layer=ply \
 //thickness=0.18 //x=60.52 //y=2.095 //x2=60.445 //y2=2.26
r1292 (  305 420 ) resistor r=21.2976 //w=0.217 //l=0.0928709 //layer=ply \
 //thickness=0.18 //x=60.52 //y=1.63 //x2=60.48 //y2=1.555
r1293 (  305 306 ) resistor r=238.436 //w=0.094 //l=0.465 //layer=ply \
 //thickness=0.18 //x=60.52 //y=1.63 //x2=60.52 //y2=2.095
r1294 (  304 420 ) resistor r=39.0671 //w=0.217 //l=0.173853 //layer=ply \
 //thickness=0.18 //x=60.52 //y=1.4 //x2=60.48 //y2=1.555
r1295 (  303 419 ) resistor r=45.1352 //w=0.168 //l=0.173853 //layer=ply \
 //thickness=0.18 //x=60.52 //y=1.09 //x2=60.48 //y2=0.935
r1296 (  303 304 ) resistor r=158.957 //w=0.094 //l=0.31 //layer=ply \
 //thickness=0.18 //x=60.52 //y=1.09 //x2=60.52 //y2=1.4
r1297 (  298 413 ) resistor r=5.52526 //w=0.168 //l=0.115 //layer=ply \
 //thickness=0.18 //x=60.15 //y=1.555 //x2=60.035 //y2=1.555
r1298 (  297 420 ) resistor r=11.4558 //w=0.217 //l=0.115 //layer=ply \
 //thickness=0.18 //x=60.365 //y=1.555 //x2=60.48 //y2=1.555
r1299 (  296 412 ) resistor r=5.52526 //w=0.168 //l=0.115 //layer=ply \
 //thickness=0.18 //x=60.15 //y=0.935 //x2=60.035 //y2=0.935
r1300 (  295 419 ) resistor r=5.52526 //w=0.168 //l=0.115 //layer=ply \
 //thickness=0.18 //x=60.365 //y=0.935 //x2=60.48 //y2=0.935
r1301 (  295 296 ) resistor r=110.245 //w=0.094 //l=0.215 //layer=ply \
 //thickness=0.18 //x=60.365 //y=0.935 //x2=60.15 //y2=0.935
r1302 (  294 413 ) resistor r=45.1352 //w=0.168 //l=0.173853 //layer=ply \
 //thickness=0.18 //x=59.995 //y=1.4 //x2=60.035 //y2=1.555
r1303 (  293 412 ) resistor r=45.1352 //w=0.168 //l=0.173853 //layer=ply \
 //thickness=0.18 //x=59.995 //y=1.09 //x2=60.035 //y2=0.935
r1304 (  293 294 ) resistor r=158.957 //w=0.094 //l=0.31 //layer=ply \
 //thickness=0.18 //x=59.995 //y=1.09 //x2=59.995 //y2=1.4
r1305 (  289 406 ) resistor r=16.5046 //w=0.27 //l=0.135 //layer=ply \
 //thickness=0.18 //x=50.945 //y=4.97 //x2=50.81 //y2=4.97
r1306 (  288 290 ) resistor r=26.9307 //w=0.15 //l=0.106066 //layer=ply \
 //thickness=0.18 //x=51.145 //y=4.97 //x2=51.22 //y2=5.045
r1307 (  288 289 ) resistor r=102.553 //w=0.094 //l=0.2 //layer=ply \
 //thickness=0.18 //x=51.145 //y=4.97 //x2=50.945 //y2=4.97
r1308 (  287 411 ) resistor r=38.6777 //w=0.284 //l=0.198997 //layer=ply \
 //thickness=0.18 //x=50.9 //y=2.095 //x2=50.825 //y2=2.26
r1309 (  286 409 ) resistor r=21.2976 //w=0.217 //l=0.0928709 //layer=ply \
 //thickness=0.18 //x=50.9 //y=1.63 //x2=50.86 //y2=1.555
r1310 (  286 287 ) resistor r=238.436 //w=0.094 //l=0.465 //layer=ply \
 //thickness=0.18 //x=50.9 //y=1.63 //x2=50.9 //y2=2.095
r1311 (  285 409 ) resistor r=39.0671 //w=0.217 //l=0.173853 //layer=ply \
 //thickness=0.18 //x=50.9 //y=1.4 //x2=50.86 //y2=1.555
r1312 (  284 408 ) resistor r=45.1352 //w=0.168 //l=0.173853 //layer=ply \
 //thickness=0.18 //x=50.9 //y=1.09 //x2=50.86 //y2=0.935
r1313 (  284 285 ) resistor r=158.957 //w=0.094 //l=0.31 //layer=ply \
 //thickness=0.18 //x=50.9 //y=1.09 //x2=50.9 //y2=1.4
r1314 (  279 402 ) resistor r=5.52526 //w=0.168 //l=0.115 //layer=ply \
 //thickness=0.18 //x=50.53 //y=1.555 //x2=50.415 //y2=1.555
r1315 (  278 409 ) resistor r=11.4558 //w=0.217 //l=0.115 //layer=ply \
 //thickness=0.18 //x=50.745 //y=1.555 //x2=50.86 //y2=1.555
r1316 (  277 401 ) resistor r=5.52526 //w=0.168 //l=0.115 //layer=ply \
 //thickness=0.18 //x=50.53 //y=0.935 //x2=50.415 //y2=0.935
r1317 (  276 408 ) resistor r=5.52526 //w=0.168 //l=0.115 //layer=ply \
 //thickness=0.18 //x=50.745 //y=0.935 //x2=50.86 //y2=0.935
r1318 (  276 277 ) resistor r=110.245 //w=0.094 //l=0.215 //layer=ply \
 //thickness=0.18 //x=50.745 //y=0.935 //x2=50.53 //y2=0.935
r1319 (  275 402 ) resistor r=45.1352 //w=0.168 //l=0.173853 //layer=ply \
 //thickness=0.18 //x=50.375 //y=1.4 //x2=50.415 //y2=1.555
r1320 (  274 401 ) resistor r=45.1352 //w=0.168 //l=0.173853 //layer=ply \
 //thickness=0.18 //x=50.375 //y=1.09 //x2=50.415 //y2=0.935
r1321 (  274 275 ) resistor r=158.957 //w=0.094 //l=0.31 //layer=ply \
 //thickness=0.18 //x=50.375 //y=1.09 //x2=50.375 //y2=1.4
r1322 (  273 400 ) resistor r=45.1352 //w=0.168 //l=0.173853 //layer=ply \
 //thickness=0.18 //x=47.63 //y=1.44 //x2=47.59 //y2=1.595
r1323 (  272 399 ) resistor r=45.1352 //w=0.168 //l=0.173853 //layer=ply \
 //thickness=0.18 //x=47.63 //y=1.095 //x2=47.59 //y2=0.94
r1324 (  272 273 ) resistor r=176.904 //w=0.094 //l=0.345 //layer=ply \
 //thickness=0.18 //x=47.63 //y=1.095 //x2=47.63 //y2=1.44
r1325 (  270 396 ) resistor r=10.701 //w=0.21 //l=0.115 //layer=ply \
 //thickness=0.18 //x=47.255 //y=1.595 //x2=47.14 //y2=1.595
r1326 (  269 400 ) resistor r=5.52526 //w=0.168 //l=0.115 //layer=ply \
 //thickness=0.18 //x=47.475 //y=1.595 //x2=47.59 //y2=1.595
r1327 (  268 395 ) resistor r=5.52526 //w=0.168 //l=0.115 //layer=ply \
 //thickness=0.18 //x=47.255 //y=0.94 //x2=47.14 //y2=0.94
r1328 (  267 399 ) resistor r=5.52526 //w=0.168 //l=0.115 //layer=ply \
 //thickness=0.18 //x=47.475 //y=0.94 //x2=47.59 //y2=0.94
r1329 (  267 268 ) resistor r=112.809 //w=0.094 //l=0.22 //layer=ply \
 //thickness=0.18 //x=47.475 //y=0.94 //x2=47.255 //y2=0.94
r1330 (  264 398 ) resistor r=37.236 //w=0.233 //l=0.249199 //layer=ply \
 //thickness=0.18 //x=47.29 //y=5.045 //x2=47.11 //y2=4.88
r1331 (  262 396 ) resistor r=39.5823 //w=0.21 //l=0.173853 //layer=ply \
 //thickness=0.18 //x=47.1 //y=1.75 //x2=47.14 //y2=1.595
r1332 (  262 393 ) resistor r=176.904 //w=0.094 //l=0.345 //layer=ply \
 //thickness=0.18 //x=47.1 //y=1.75 //x2=47.1 //y2=2.095
r1333 (  261 396 ) resistor r=39.5823 //w=0.21 //l=0.173853 //layer=ply \
 //thickness=0.18 //x=47.1 //y=1.44 //x2=47.14 //y2=1.595
r1334 (  260 395 ) resistor r=45.1352 //w=0.168 //l=0.173853 //layer=ply \
 //thickness=0.18 //x=47.1 //y=1.095 //x2=47.14 //y2=0.94
r1335 (  260 261 ) resistor r=176.904 //w=0.094 //l=0.345 //layer=ply \
 //thickness=0.18 //x=47.1 //y=1.095 //x2=47.1 //y2=1.44
r1336 (  257 398 ) resistor r=53.7854 //w=0.233 //l=0.332415 //layer=ply \
 //thickness=0.18 //x=46.85 //y=5.045 //x2=47.11 //y2=4.88
r1337 (  253 385 ) resistor r=16.5046 //w=0.27 //l=0.135 //layer=ply \
 //thickness=0.18 //x=31.705 //y=4.97 //x2=31.57 //y2=4.97
r1338 (  252 254 ) resistor r=26.9307 //w=0.15 //l=0.106066 //layer=ply \
 //thickness=0.18 //x=31.905 //y=4.97 //x2=31.98 //y2=5.045
r1339 (  252 253 ) resistor r=102.553 //w=0.094 //l=0.2 //layer=ply \
 //thickness=0.18 //x=31.905 //y=4.97 //x2=31.705 //y2=4.97
r1340 (  251 390 ) resistor r=38.6777 //w=0.284 //l=0.198997 //layer=ply \
 //thickness=0.18 //x=31.66 //y=2.095 //x2=31.585 //y2=2.26
r1341 (  250 388 ) resistor r=21.2976 //w=0.217 //l=0.0928709 //layer=ply \
 //thickness=0.18 //x=31.66 //y=1.63 //x2=31.62 //y2=1.555
r1342 (  250 251 ) resistor r=238.436 //w=0.094 //l=0.465 //layer=ply \
 //thickness=0.18 //x=31.66 //y=1.63 //x2=31.66 //y2=2.095
r1343 (  249 388 ) resistor r=39.0671 //w=0.217 //l=0.173853 //layer=ply \
 //thickness=0.18 //x=31.66 //y=1.4 //x2=31.62 //y2=1.555
r1344 (  248 387 ) resistor r=45.1352 //w=0.168 //l=0.173853 //layer=ply \
 //thickness=0.18 //x=31.66 //y=1.09 //x2=31.62 //y2=0.935
r1345 (  248 249 ) resistor r=158.957 //w=0.094 //l=0.31 //layer=ply \
 //thickness=0.18 //x=31.66 //y=1.09 //x2=31.66 //y2=1.4
r1346 (  243 381 ) resistor r=5.52526 //w=0.168 //l=0.115 //layer=ply \
 //thickness=0.18 //x=31.29 //y=1.555 //x2=31.175 //y2=1.555
r1347 (  242 388 ) resistor r=11.4558 //w=0.217 //l=0.115 //layer=ply \
 //thickness=0.18 //x=31.505 //y=1.555 //x2=31.62 //y2=1.555
r1348 (  241 380 ) resistor r=5.52526 //w=0.168 //l=0.115 //layer=ply \
 //thickness=0.18 //x=31.29 //y=0.935 //x2=31.175 //y2=0.935
r1349 (  240 387 ) resistor r=5.52526 //w=0.168 //l=0.115 //layer=ply \
 //thickness=0.18 //x=31.505 //y=0.935 //x2=31.62 //y2=0.935
r1350 (  240 241 ) resistor r=110.245 //w=0.094 //l=0.215 //layer=ply \
 //thickness=0.18 //x=31.505 //y=0.935 //x2=31.29 //y2=0.935
r1351 (  239 381 ) resistor r=45.1352 //w=0.168 //l=0.173853 //layer=ply \
 //thickness=0.18 //x=31.135 //y=1.4 //x2=31.175 //y2=1.555
r1352 (  238 380 ) resistor r=45.1352 //w=0.168 //l=0.173853 //layer=ply \
 //thickness=0.18 //x=31.135 //y=1.09 //x2=31.175 //y2=0.935
r1353 (  238 239 ) resistor r=158.957 //w=0.094 //l=0.31 //layer=ply \
 //thickness=0.18 //x=31.135 //y=1.09 //x2=31.135 //y2=1.4
r1354 (  234 374 ) resistor r=16.5046 //w=0.27 //l=0.135 //layer=ply \
 //thickness=0.18 //x=22.085 //y=4.97 //x2=21.95 //y2=4.97
r1355 (  233 235 ) resistor r=26.9307 //w=0.15 //l=0.106066 //layer=ply \
 //thickness=0.18 //x=22.285 //y=4.97 //x2=22.36 //y2=5.045
r1356 (  233 234 ) resistor r=102.553 //w=0.094 //l=0.2 //layer=ply \
 //thickness=0.18 //x=22.285 //y=4.97 //x2=22.085 //y2=4.97
r1357 (  232 379 ) resistor r=38.6777 //w=0.284 //l=0.198997 //layer=ply \
 //thickness=0.18 //x=22.04 //y=2.095 //x2=21.965 //y2=2.26
r1358 (  231 377 ) resistor r=21.2976 //w=0.217 //l=0.0928709 //layer=ply \
 //thickness=0.18 //x=22.04 //y=1.63 //x2=22 //y2=1.555
r1359 (  231 232 ) resistor r=238.436 //w=0.094 //l=0.465 //layer=ply \
 //thickness=0.18 //x=22.04 //y=1.63 //x2=22.04 //y2=2.095
r1360 (  230 377 ) resistor r=39.0671 //w=0.217 //l=0.173853 //layer=ply \
 //thickness=0.18 //x=22.04 //y=1.4 //x2=22 //y2=1.555
r1361 (  229 376 ) resistor r=45.1352 //w=0.168 //l=0.173853 //layer=ply \
 //thickness=0.18 //x=22.04 //y=1.09 //x2=22 //y2=0.935
r1362 (  229 230 ) resistor r=158.957 //w=0.094 //l=0.31 //layer=ply \
 //thickness=0.18 //x=22.04 //y=1.09 //x2=22.04 //y2=1.4
r1363 (  224 370 ) resistor r=5.52526 //w=0.168 //l=0.115 //layer=ply \
 //thickness=0.18 //x=21.67 //y=1.555 //x2=21.555 //y2=1.555
r1364 (  223 377 ) resistor r=11.4558 //w=0.217 //l=0.115 //layer=ply \
 //thickness=0.18 //x=21.885 //y=1.555 //x2=22 //y2=1.555
r1365 (  222 369 ) resistor r=5.52526 //w=0.168 //l=0.115 //layer=ply \
 //thickness=0.18 //x=21.67 //y=0.935 //x2=21.555 //y2=0.935
r1366 (  221 376 ) resistor r=5.52526 //w=0.168 //l=0.115 //layer=ply \
 //thickness=0.18 //x=21.885 //y=0.935 //x2=22 //y2=0.935
r1367 (  221 222 ) resistor r=110.245 //w=0.094 //l=0.215 //layer=ply \
 //thickness=0.18 //x=21.885 //y=0.935 //x2=21.67 //y2=0.935
r1368 (  220 370 ) resistor r=45.1352 //w=0.168 //l=0.173853 //layer=ply \
 //thickness=0.18 //x=21.515 //y=1.4 //x2=21.555 //y2=1.555
r1369 (  219 369 ) resistor r=45.1352 //w=0.168 //l=0.173853 //layer=ply \
 //thickness=0.18 //x=21.515 //y=1.09 //x2=21.555 //y2=0.935
r1370 (  219 220 ) resistor r=158.957 //w=0.094 //l=0.31 //layer=ply \
 //thickness=0.18 //x=21.515 //y=1.09 //x2=21.515 //y2=1.4
r1371 (  218 368 ) resistor r=45.1352 //w=0.168 //l=0.173853 //layer=ply \
 //thickness=0.18 //x=18.77 //y=1.44 //x2=18.73 //y2=1.595
r1372 (  217 367 ) resistor r=45.1352 //w=0.168 //l=0.173853 //layer=ply \
 //thickness=0.18 //x=18.77 //y=1.095 //x2=18.73 //y2=0.94
r1373 (  217 218 ) resistor r=176.904 //w=0.094 //l=0.345 //layer=ply \
 //thickness=0.18 //x=18.77 //y=1.095 //x2=18.77 //y2=1.44
r1374 (  215 364 ) resistor r=10.701 //w=0.21 //l=0.115 //layer=ply \
 //thickness=0.18 //x=18.395 //y=1.595 //x2=18.28 //y2=1.595
r1375 (  214 368 ) resistor r=5.52526 //w=0.168 //l=0.115 //layer=ply \
 //thickness=0.18 //x=18.615 //y=1.595 //x2=18.73 //y2=1.595
r1376 (  213 363 ) resistor r=5.52526 //w=0.168 //l=0.115 //layer=ply \
 //thickness=0.18 //x=18.395 //y=0.94 //x2=18.28 //y2=0.94
r1377 (  212 367 ) resistor r=5.52526 //w=0.168 //l=0.115 //layer=ply \
 //thickness=0.18 //x=18.615 //y=0.94 //x2=18.73 //y2=0.94
r1378 (  212 213 ) resistor r=112.809 //w=0.094 //l=0.22 //layer=ply \
 //thickness=0.18 //x=18.615 //y=0.94 //x2=18.395 //y2=0.94
r1379 (  209 366 ) resistor r=37.236 //w=0.233 //l=0.249199 //layer=ply \
 //thickness=0.18 //x=18.43 //y=5.045 //x2=18.25 //y2=4.88
r1380 (  207 364 ) resistor r=39.5823 //w=0.21 //l=0.173853 //layer=ply \
 //thickness=0.18 //x=18.24 //y=1.75 //x2=18.28 //y2=1.595
r1381 (  207 361 ) resistor r=176.904 //w=0.094 //l=0.345 //layer=ply \
 //thickness=0.18 //x=18.24 //y=1.75 //x2=18.24 //y2=2.095
r1382 (  206 364 ) resistor r=39.5823 //w=0.21 //l=0.173853 //layer=ply \
 //thickness=0.18 //x=18.24 //y=1.44 //x2=18.28 //y2=1.595
r1383 (  205 363 ) resistor r=45.1352 //w=0.168 //l=0.173853 //layer=ply \
 //thickness=0.18 //x=18.24 //y=1.095 //x2=18.28 //y2=0.94
r1384 (  205 206 ) resistor r=176.904 //w=0.094 //l=0.345 //layer=ply \
 //thickness=0.18 //x=18.24 //y=1.095 //x2=18.24 //y2=1.44
r1385 (  202 366 ) resistor r=53.7854 //w=0.233 //l=0.332415 //layer=ply \
 //thickness=0.18 //x=17.99 //y=5.045 //x2=18.25 //y2=4.88
r1386 (  198 353 ) resistor r=16.5046 //w=0.27 //l=0.135 //layer=ply \
 //thickness=0.18 //x=2.845 //y=4.97 //x2=2.71 //y2=4.97
r1387 (  197 199 ) resistor r=26.9307 //w=0.15 //l=0.106066 //layer=ply \
 //thickness=0.18 //x=3.045 //y=4.97 //x2=3.12 //y2=5.045
r1388 (  197 198 ) resistor r=102.553 //w=0.094 //l=0.2 //layer=ply \
 //thickness=0.18 //x=3.045 //y=4.97 //x2=2.845 //y2=4.97
r1389 (  196 358 ) resistor r=38.6777 //w=0.284 //l=0.198997 //layer=ply \
 //thickness=0.18 //x=2.8 //y=2.095 //x2=2.725 //y2=2.26
r1390 (  195 356 ) resistor r=21.2976 //w=0.217 //l=0.0928709 //layer=ply \
 //thickness=0.18 //x=2.8 //y=1.63 //x2=2.76 //y2=1.555
r1391 (  195 196 ) resistor r=238.436 //w=0.094 //l=0.465 //layer=ply \
 //thickness=0.18 //x=2.8 //y=1.63 //x2=2.8 //y2=2.095
r1392 (  194 356 ) resistor r=39.0671 //w=0.217 //l=0.173853 //layer=ply \
 //thickness=0.18 //x=2.8 //y=1.4 //x2=2.76 //y2=1.555
r1393 (  193 355 ) resistor r=45.1352 //w=0.168 //l=0.173853 //layer=ply \
 //thickness=0.18 //x=2.8 //y=1.09 //x2=2.76 //y2=0.935
r1394 (  193 194 ) resistor r=158.957 //w=0.094 //l=0.31 //layer=ply \
 //thickness=0.18 //x=2.8 //y=1.09 //x2=2.8 //y2=1.4
r1395 (  188 349 ) resistor r=5.52526 //w=0.168 //l=0.115 //layer=ply \
 //thickness=0.18 //x=2.43 //y=1.555 //x2=2.315 //y2=1.555
r1396 (  187 356 ) resistor r=11.4558 //w=0.217 //l=0.115 //layer=ply \
 //thickness=0.18 //x=2.645 //y=1.555 //x2=2.76 //y2=1.555
r1397 (  186 348 ) resistor r=5.52526 //w=0.168 //l=0.115 //layer=ply \
 //thickness=0.18 //x=2.43 //y=0.935 //x2=2.315 //y2=0.935
r1398 (  185 355 ) resistor r=5.52526 //w=0.168 //l=0.115 //layer=ply \
 //thickness=0.18 //x=2.645 //y=0.935 //x2=2.76 //y2=0.935
r1399 (  185 186 ) resistor r=110.245 //w=0.094 //l=0.215 //layer=ply \
 //thickness=0.18 //x=2.645 //y=0.935 //x2=2.43 //y2=0.935
r1400 (  184 349 ) resistor r=45.1352 //w=0.168 //l=0.173853 //layer=ply \
 //thickness=0.18 //x=2.275 //y=1.4 //x2=2.315 //y2=1.555
r1401 (  183 348 ) resistor r=45.1352 //w=0.168 //l=0.173853 //layer=ply \
 //thickness=0.18 //x=2.275 //y=1.09 //x2=2.315 //y2=0.935
r1402 (  183 184 ) resistor r=158.957 //w=0.094 //l=0.31 //layer=ply \
 //thickness=0.18 //x=2.275 //y=1.09 //x2=2.275 //y2=1.4
r1403 (  182 345 ) resistor r=592.245 //w=0.094 //l=1.155 //layer=ply \
 //thickness=0.18 //x=80.08 //y=6.2 //x2=80.08 //y2=5.045
r1404 (  181 439 ) resistor r=592.245 //w=0.094 //l=1.155 //layer=ply \
 //thickness=0.18 //x=79.64 //y=6.2 //x2=79.64 //y2=5.045
r1405 (  180 319 ) resistor r=592.245 //w=0.094 //l=1.155 //layer=ply \
 //thickness=0.18 //x=76.15 //y=6.2 //x2=76.15 //y2=5.045
r1406 (  179 312 ) resistor r=592.245 //w=0.094 //l=1.155 //layer=ply \
 //thickness=0.18 //x=75.71 //y=6.2 //x2=75.71 //y2=5.045
r1407 (  178 309 ) resistor r=592.245 //w=0.094 //l=1.155 //layer=ply \
 //thickness=0.18 //x=60.84 //y=6.2 //x2=60.84 //y2=5.045
r1408 (  177 418 ) resistor r=592.245 //w=0.094 //l=1.155 //layer=ply \
 //thickness=0.18 //x=60.4 //y=6.2 //x2=60.4 //y2=5.045
r1409 (  176 290 ) resistor r=592.245 //w=0.094 //l=1.155 //layer=ply \
 //thickness=0.18 //x=51.22 //y=6.2 //x2=51.22 //y2=5.045
r1410 (  175 407 ) resistor r=592.245 //w=0.094 //l=1.155 //layer=ply \
 //thickness=0.18 //x=50.78 //y=6.2 //x2=50.78 //y2=5.045
r1411 (  174 264 ) resistor r=592.245 //w=0.094 //l=1.155 //layer=ply \
 //thickness=0.18 //x=47.29 //y=6.2 //x2=47.29 //y2=5.045
r1412 (  173 257 ) resistor r=592.245 //w=0.094 //l=1.155 //layer=ply \
 //thickness=0.18 //x=46.85 //y=6.2 //x2=46.85 //y2=5.045
r1413 (  172 254 ) resistor r=592.245 //w=0.094 //l=1.155 //layer=ply \
 //thickness=0.18 //x=31.98 //y=6.2 //x2=31.98 //y2=5.045
r1414 (  171 386 ) resistor r=592.245 //w=0.094 //l=1.155 //layer=ply \
 //thickness=0.18 //x=31.54 //y=6.2 //x2=31.54 //y2=5.045
r1415 (  170 235 ) resistor r=592.245 //w=0.094 //l=1.155 //layer=ply \
 //thickness=0.18 //x=22.36 //y=6.2 //x2=22.36 //y2=5.045
r1416 (  169 375 ) resistor r=592.245 //w=0.094 //l=1.155 //layer=ply \
 //thickness=0.18 //x=21.92 //y=6.2 //x2=21.92 //y2=5.045
r1417 (  168 209 ) resistor r=592.245 //w=0.094 //l=1.155 //layer=ply \
 //thickness=0.18 //x=18.43 //y=6.2 //x2=18.43 //y2=5.045
r1418 (  167 202 ) resistor r=592.245 //w=0.094 //l=1.155 //layer=ply \
 //thickness=0.18 //x=17.99 //y=6.2 //x2=17.99 //y2=5.045
r1419 (  166 199 ) resistor r=592.245 //w=0.094 //l=1.155 //layer=ply \
 //thickness=0.18 //x=3.12 //y=6.2 //x2=3.12 //y2=5.045
r1420 (  165 354 ) resistor r=592.245 //w=0.094 //l=1.155 //layer=ply \
 //thickness=0.18 //x=2.68 //y=6.2 //x2=2.68 //y2=5.045
r1421 (  164 333 ) resistor r=55.3787 //w=0.094 //l=0.108 //layer=ply \
 //thickness=0.18 //x=79.497 //y=1.555 //x2=79.605 //y2=1.555
r1422 (  164 334 ) resistor r=54.866 //w=0.094 //l=0.107 //layer=ply \
 //thickness=0.18 //x=79.497 //y=1.555 //x2=79.39 //y2=1.555
r1423 (  163 324 ) resistor r=56.4043 //w=0.094 //l=0.11 //layer=ply \
 //thickness=0.18 //x=76.225 //y=1.595 //x2=76.335 //y2=1.595
r1424 (  163 325 ) resistor r=56.4043 //w=0.094 //l=0.11 //layer=ply \
 //thickness=0.18 //x=76.225 //y=1.595 //x2=76.115 //y2=1.595
r1425 (  162 297 ) resistor r=55.3787 //w=0.094 //l=0.108 //layer=ply \
 //thickness=0.18 //x=60.257 //y=1.555 //x2=60.365 //y2=1.555
r1426 (  162 298 ) resistor r=54.866 //w=0.094 //l=0.107 //layer=ply \
 //thickness=0.18 //x=60.257 //y=1.555 //x2=60.15 //y2=1.555
r1427 (  161 278 ) resistor r=55.3787 //w=0.094 //l=0.108 //layer=ply \
 //thickness=0.18 //x=50.637 //y=1.555 //x2=50.745 //y2=1.555
r1428 (  161 279 ) resistor r=54.866 //w=0.094 //l=0.107 //layer=ply \
 //thickness=0.18 //x=50.637 //y=1.555 //x2=50.53 //y2=1.555
r1429 (  160 269 ) resistor r=56.4043 //w=0.094 //l=0.11 //layer=ply \
 //thickness=0.18 //x=47.365 //y=1.595 //x2=47.475 //y2=1.595
r1430 (  160 270 ) resistor r=56.4043 //w=0.094 //l=0.11 //layer=ply \
 //thickness=0.18 //x=47.365 //y=1.595 //x2=47.255 //y2=1.595
r1431 (  159 242 ) resistor r=55.3787 //w=0.094 //l=0.108 //layer=ply \
 //thickness=0.18 //x=31.397 //y=1.555 //x2=31.505 //y2=1.555
r1432 (  159 243 ) resistor r=54.866 //w=0.094 //l=0.107 //layer=ply \
 //thickness=0.18 //x=31.397 //y=1.555 //x2=31.29 //y2=1.555
r1433 (  158 223 ) resistor r=55.3787 //w=0.094 //l=0.108 //layer=ply \
 //thickness=0.18 //x=21.777 //y=1.555 //x2=21.885 //y2=1.555
r1434 (  158 224 ) resistor r=54.866 //w=0.094 //l=0.107 //layer=ply \
 //thickness=0.18 //x=21.777 //y=1.555 //x2=21.67 //y2=1.555
r1435 (  157 214 ) resistor r=56.4043 //w=0.094 //l=0.11 //layer=ply \
 //thickness=0.18 //x=18.505 //y=1.595 //x2=18.615 //y2=1.595
r1436 (  157 215 ) resistor r=56.4043 //w=0.094 //l=0.11 //layer=ply \
 //thickness=0.18 //x=18.505 //y=1.595 //x2=18.395 //y2=1.595
r1437 (  156 187 ) resistor r=55.3787 //w=0.094 //l=0.108 //layer=ply \
 //thickness=0.18 //x=2.537 //y=1.555 //x2=2.645 //y2=1.555
r1438 (  156 188 ) resistor r=54.866 //w=0.094 //l=0.107 //layer=ply \
 //thickness=0.18 //x=2.537 //y=1.555 //x2=2.43 //y2=1.555
r1439 (  154 436 ) resistor r=152 //w=0.17 //l=0.17 //layer=licon //count=1 \
 //x=79.67 //y=4.88 //x2=79.67 //y2=4.88
r1440 (  147 443 ) resistor r=152 //w=0.17 //l=0.17 //layer=licon //count=1 \
 //x=79.67 //y=2.26 //x2=79.67 //y2=2.26
r1441 (  144 430 ) resistor r=152 //w=0.17 //l=0.17 //layer=licon //count=1 \
 //x=75.97 //y=4.88 //x2=75.97 //y2=4.88
r1442 (  138 424 ) resistor r=152 //w=0.17 //l=0.17 //layer=licon //count=1 \
 //x=75.97 //y=2.26 //x2=75.97 //y2=2.26
r1443 (  135 415 ) resistor r=152 //w=0.17 //l=0.17 //layer=licon //count=1 \
 //x=60.43 //y=4.88 //x2=60.43 //y2=4.88
r1444 (  127 422 ) resistor r=152 //w=0.17 //l=0.17 //layer=licon //count=1 \
 //x=60.43 //y=2.26 //x2=60.43 //y2=2.26
r1445 (  124 404 ) resistor r=152 //w=0.17 //l=0.17 //layer=licon //count=1 \
 //x=50.81 //y=4.88 //x2=50.81 //y2=4.88
r1446 (  117 411 ) resistor r=152 //w=0.17 //l=0.17 //layer=licon //count=1 \
 //x=50.81 //y=2.26 //x2=50.81 //y2=2.26
r1447 (  114 398 ) resistor r=152 //w=0.17 //l=0.17 //layer=licon //count=1 \
 //x=47.11 //y=4.88 //x2=47.11 //y2=4.88
r1448 (  108 392 ) resistor r=152 //w=0.17 //l=0.17 //layer=licon //count=1 \
 //x=47.11 //y=2.26 //x2=47.11 //y2=2.26
r1449 (  105 383 ) resistor r=152 //w=0.17 //l=0.17 //layer=licon //count=1 \
 //x=31.57 //y=4.88 //x2=31.57 //y2=4.88
r1450 (  97 390 ) resistor r=152 //w=0.17 //l=0.17 //layer=licon //count=1 \
 //x=31.57 //y=2.26 //x2=31.57 //y2=2.26
r1451 (  94 372 ) resistor r=152 //w=0.17 //l=0.17 //layer=licon //count=1 \
 //x=21.95 //y=4.88 //x2=21.95 //y2=4.88
r1452 (  87 379 ) resistor r=152 //w=0.17 //l=0.17 //layer=licon //count=1 \
 //x=21.95 //y=2.26 //x2=21.95 //y2=2.26
r1453 (  84 366 ) resistor r=152 //w=0.17 //l=0.17 //layer=licon //count=1 \
 //x=18.25 //y=4.88 //x2=18.25 //y2=4.88
r1454 (  78 360 ) resistor r=152 //w=0.17 //l=0.17 //layer=licon //count=1 \
 //x=18.25 //y=2.26 //x2=18.25 //y2=2.26
r1455 (  75 351 ) resistor r=152 //w=0.17 //l=0.17 //layer=licon //count=1 \
 //x=2.71 //y=4.88 //x2=2.71 //y2=4.88
r1456 (  65 358 ) resistor r=152 //w=0.17 //l=0.17 //layer=licon //count=1 \
 //x=2.71 //y=2.26 //x2=2.71 //y2=2.26
r1457 (  63 154 ) resistor r=93.7754 //w=0.187 //l=1.37 //layer=li \
 //thickness=0.1 //x=79.67 //y=3.51 //x2=79.67 //y2=4.88
r1458 (  62 63 ) resistor r=50.6524 //w=0.187 //l=0.74 //layer=li \
 //thickness=0.1 //x=79.67 //y=2.77 //x2=79.67 //y2=3.51
r1459 (  61 62 ) resistor r=25.3262 //w=0.187 //l=0.37 //layer=li \
 //thickness=0.1 //x=79.67 //y=2.4 //x2=79.67 //y2=2.77
r1460 (  61 147 ) resistor r=9.58289 //w=0.187 //l=0.14 //layer=li \
 //thickness=0.1 //x=79.67 //y=2.4 //x2=79.67 //y2=2.26
r1461 (  60 144 ) resistor r=144.428 //w=0.187 //l=2.11 //layer=li \
 //thickness=0.1 //x=75.97 //y=2.77 //x2=75.97 //y2=4.88
r1462 (  59 60 ) resistor r=25.3262 //w=0.187 //l=0.37 //layer=li \
 //thickness=0.1 //x=75.97 //y=2.4 //x2=75.97 //y2=2.77
r1463 (  59 138 ) resistor r=9.58289 //w=0.187 //l=0.14 //layer=li \
 //thickness=0.1 //x=75.97 //y=2.4 //x2=75.97 //y2=2.26
r1464 (  58 135 ) resistor r=43.123 //w=0.187 //l=0.63 //layer=li \
 //thickness=0.1 //x=60.43 //y=4.25 //x2=60.43 //y2=4.88
r1465 (  57 58 ) resistor r=50.6524 //w=0.187 //l=0.74 //layer=li \
 //thickness=0.1 //x=60.43 //y=3.51 //x2=60.43 //y2=4.25
r1466 (  56 57 ) resistor r=50.6524 //w=0.187 //l=0.74 //layer=li \
 //thickness=0.1 //x=60.43 //y=2.77 //x2=60.43 //y2=3.51
r1467 (  55 56 ) resistor r=25.3262 //w=0.187 //l=0.37 //layer=li \
 //thickness=0.1 //x=60.43 //y=2.4 //x2=60.43 //y2=2.77
r1468 (  55 127 ) resistor r=9.58289 //w=0.187 //l=0.14 //layer=li \
 //thickness=0.1 //x=60.43 //y=2.4 //x2=60.43 //y2=2.26
r1469 (  54 124 ) resistor r=93.7754 //w=0.187 //l=1.37 //layer=li \
 //thickness=0.1 //x=50.81 //y=3.51 //x2=50.81 //y2=4.88
r1470 (  53 54 ) resistor r=50.6524 //w=0.187 //l=0.74 //layer=li \
 //thickness=0.1 //x=50.81 //y=2.77 //x2=50.81 //y2=3.51
r1471 (  52 53 ) resistor r=25.3262 //w=0.187 //l=0.37 //layer=li \
 //thickness=0.1 //x=50.81 //y=2.4 //x2=50.81 //y2=2.77
r1472 (  52 117 ) resistor r=9.58289 //w=0.187 //l=0.14 //layer=li \
 //thickness=0.1 //x=50.81 //y=2.4 //x2=50.81 //y2=2.26
r1473 (  51 114 ) resistor r=144.428 //w=0.187 //l=2.11 //layer=li \
 //thickness=0.1 //x=47.11 //y=2.77 //x2=47.11 //y2=4.88
r1474 (  50 51 ) resistor r=25.3262 //w=0.187 //l=0.37 //layer=li \
 //thickness=0.1 //x=47.11 //y=2.4 //x2=47.11 //y2=2.77
r1475 (  50 108 ) resistor r=9.58289 //w=0.187 //l=0.14 //layer=li \
 //thickness=0.1 //x=47.11 //y=2.4 //x2=47.11 //y2=2.26
r1476 (  49 105 ) resistor r=68.4492 //w=0.187 //l=1 //layer=li \
 //thickness=0.1 //x=31.57 //y=3.88 //x2=31.57 //y2=4.88
r1477 (  48 49 ) resistor r=25.3262 //w=0.187 //l=0.37 //layer=li \
 //thickness=0.1 //x=31.57 //y=3.51 //x2=31.57 //y2=3.88
r1478 (  47 48 ) resistor r=50.6524 //w=0.187 //l=0.74 //layer=li \
 //thickness=0.1 //x=31.57 //y=2.77 //x2=31.57 //y2=3.51
r1479 (  46 47 ) resistor r=25.3262 //w=0.187 //l=0.37 //layer=li \
 //thickness=0.1 //x=31.57 //y=2.4 //x2=31.57 //y2=2.77
r1480 (  46 97 ) resistor r=9.58289 //w=0.187 //l=0.14 //layer=li \
 //thickness=0.1 //x=31.57 //y=2.4 //x2=31.57 //y2=2.26
r1481 (  45 94 ) resistor r=93.7754 //w=0.187 //l=1.37 //layer=li \
 //thickness=0.1 //x=21.95 //y=3.51 //x2=21.95 //y2=4.88
r1482 (  44 45 ) resistor r=50.6524 //w=0.187 //l=0.74 //layer=li \
 //thickness=0.1 //x=21.95 //y=2.77 //x2=21.95 //y2=3.51
r1483 (  43 44 ) resistor r=25.3262 //w=0.187 //l=0.37 //layer=li \
 //thickness=0.1 //x=21.95 //y=2.4 //x2=21.95 //y2=2.77
r1484 (  43 87 ) resistor r=9.58289 //w=0.187 //l=0.14 //layer=li \
 //thickness=0.1 //x=21.95 //y=2.4 //x2=21.95 //y2=2.26
r1485 (  42 84 ) resistor r=144.428 //w=0.187 //l=2.11 //layer=li \
 //thickness=0.1 //x=18.25 //y=2.77 //x2=18.25 //y2=4.88
r1486 (  41 42 ) resistor r=25.3262 //w=0.187 //l=0.37 //layer=li \
 //thickness=0.1 //x=18.25 //y=2.4 //x2=18.25 //y2=2.77
r1487 (  41 78 ) resistor r=9.58289 //w=0.187 //l=0.14 //layer=li \
 //thickness=0.1 //x=18.25 //y=2.4 //x2=18.25 //y2=2.26
r1488 (  40 75 ) resistor r=17.7968 //w=0.187 //l=0.26 //layer=li \
 //thickness=0.1 //x=2.71 //y=4.62 //x2=2.71 //y2=4.88
r1489 (  39 40 ) resistor r=50.6524 //w=0.187 //l=0.74 //layer=li \
 //thickness=0.1 //x=2.71 //y=3.88 //x2=2.71 //y2=4.62
r1490 (  38 39 ) resistor r=25.3262 //w=0.187 //l=0.37 //layer=li \
 //thickness=0.1 //x=2.71 //y=3.51 //x2=2.71 //y2=3.88
r1491 (  37 38 ) resistor r=25.3262 //w=0.187 //l=0.37 //layer=li \
 //thickness=0.1 //x=2.71 //y=3.14 //x2=2.71 //y2=3.51
r1492 (  36 37 ) resistor r=25.3262 //w=0.187 //l=0.37 //layer=li \
 //thickness=0.1 //x=2.71 //y=2.77 //x2=2.71 //y2=3.14
r1493 (  35 36 ) resistor r=25.3262 //w=0.187 //l=0.37 //layer=li \
 //thickness=0.1 //x=2.71 //y=2.4 //x2=2.71 //y2=2.77
r1494 (  35 65 ) resistor r=9.58289 //w=0.187 //l=0.14 //layer=li \
 //thickness=0.1 //x=2.71 //y=2.4 //x2=2.71 //y2=2.26
r1495 (  34 61 ) resistor r=9.3 //w=0.17 //l=0.17 //layer=mcon //count=1 \
 //x=79.67 //y=2.4 //x2=79.67 //y2=2.4
r1496 (  32 59 ) resistor r=9.3 //w=0.17 //l=0.17 //layer=mcon //count=1 \
 //x=75.97 //y=2.4 //x2=75.97 //y2=2.4
r1497 (  30 55 ) resistor r=9.3 //w=0.17 //l=0.17 //layer=mcon //count=1 \
 //x=60.43 //y=2.4 //x2=60.43 //y2=2.4
r1498 (  28 52 ) resistor r=9.3 //w=0.17 //l=0.17 //layer=mcon //count=1 \
 //x=50.81 //y=2.4 //x2=50.81 //y2=2.4
r1499 (  26 50 ) resistor r=9.3 //w=0.17 //l=0.17 //layer=mcon //count=1 \
 //x=47.11 //y=2.4 //x2=47.11 //y2=2.4
r1500 (  24 46 ) resistor r=9.3 //w=0.17 //l=0.17 //layer=mcon //count=1 \
 //x=31.57 //y=2.4 //x2=31.57 //y2=2.4
r1501 (  22 43 ) resistor r=9.3 //w=0.17 //l=0.17 //layer=mcon //count=1 \
 //x=21.95 //y=2.4 //x2=21.95 //y2=2.4
r1502 (  20 41 ) resistor r=9.3 //w=0.17 //l=0.17 //layer=mcon //count=1 \
 //x=18.25 //y=2.4 //x2=18.25 //y2=2.4
r1503 (  18 35 ) resistor r=9.3 //w=0.17 //l=0.17 //layer=mcon //count=1 \
 //x=2.71 //y=2.4 //x2=2.71 //y2=2.4
r1504 (  16 32 ) resistor r=0.0880901 //w=0.191 //l=0.115 //layer=m1 \
 //thickness=0.36 //x=76.085 //y=2.4 //x2=75.97 //y2=2.4
r1505 (  15 34 ) resistor r=0.0717383 //w=0.224 //l=0.115 //layer=m1 \
 //thickness=0.36 //x=79.555 //y=2.4 //x2=79.67 //y2=2.4
r1506 (  15 16 ) resistor r=3.31107 //w=0.131 //l=3.47 //layer=m1 \
 //thickness=0.36 //x=79.555 //y=2.4 //x2=76.085 //y2=2.4
r1507 (  14 30 ) resistor r=0.0880901 //w=0.191 //l=0.115 //layer=m1 \
 //thickness=0.36 //x=60.545 //y=2.4 //x2=60.43 //y2=2.4
r1508 (  13 32 ) resistor r=0.0880901 //w=0.191 //l=0.115 //layer=m1 \
 //thickness=0.36 //x=75.855 //y=2.4 //x2=75.97 //y2=2.4
r1509 (  13 14 ) resistor r=14.6088 //w=0.131 //l=15.31 //layer=m1 \
 //thickness=0.36 //x=75.855 //y=2.4 //x2=60.545 //y2=2.4
r1510 (  12 28 ) resistor r=0.0880901 //w=0.191 //l=0.115 //layer=m1 \
 //thickness=0.36 //x=50.925 //y=2.4 //x2=50.81 //y2=2.4
r1511 (  11 30 ) resistor r=0.0880901 //w=0.191 //l=0.115 //layer=m1 \
 //thickness=0.36 //x=60.315 //y=2.4 //x2=60.43 //y2=2.4
r1512 (  11 12 ) resistor r=8.95992 //w=0.131 //l=9.39 //layer=m1 \
 //thickness=0.36 //x=60.315 //y=2.4 //x2=50.925 //y2=2.4
r1513 (  10 26 ) resistor r=0.0880901 //w=0.191 //l=0.115 //layer=m1 \
 //thickness=0.36 //x=47.225 //y=2.4 //x2=47.11 //y2=2.4
r1514 (  9 28 ) resistor r=0.0880901 //w=0.191 //l=0.115 //layer=m1 \
 //thickness=0.36 //x=50.695 //y=2.4 //x2=50.81 //y2=2.4
r1515 (  9 10 ) resistor r=3.31107 //w=0.131 //l=3.47 //layer=m1 \
 //thickness=0.36 //x=50.695 //y=2.4 //x2=47.225 //y2=2.4
r1516 (  8 24 ) resistor r=0.0880901 //w=0.191 //l=0.115 //layer=m1 \
 //thickness=0.36 //x=31.685 //y=2.4 //x2=31.57 //y2=2.4
r1517 (  7 26 ) resistor r=0.0880901 //w=0.191 //l=0.115 //layer=m1 \
 //thickness=0.36 //x=46.995 //y=2.4 //x2=47.11 //y2=2.4
r1518 (  7 8 ) resistor r=14.6088 //w=0.131 //l=15.31 //layer=m1 \
 //thickness=0.36 //x=46.995 //y=2.4 //x2=31.685 //y2=2.4
r1519 (  6 22 ) resistor r=0.0880901 //w=0.191 //l=0.115 //layer=m1 \
 //thickness=0.36 //x=22.065 //y=2.4 //x2=21.95 //y2=2.4
r1520 (  5 24 ) resistor r=0.0880901 //w=0.191 //l=0.115 //layer=m1 \
 //thickness=0.36 //x=31.455 //y=2.4 //x2=31.57 //y2=2.4
r1521 (  5 6 ) resistor r=8.95992 //w=0.131 //l=9.39 //layer=m1 \
 //thickness=0.36 //x=31.455 //y=2.4 //x2=22.065 //y2=2.4
r1522 (  4 20 ) resistor r=0.0880901 //w=0.191 //l=0.115 //layer=m1 \
 //thickness=0.36 //x=18.365 //y=2.4 //x2=18.25 //y2=2.4
r1523 (  3 22 ) resistor r=0.0880901 //w=0.191 //l=0.115 //layer=m1 \
 //thickness=0.36 //x=21.835 //y=2.4 //x2=21.95 //y2=2.4
r1524 (  3 4 ) resistor r=3.31107 //w=0.131 //l=3.47 //layer=m1 \
 //thickness=0.36 //x=21.835 //y=2.4 //x2=18.365 //y2=2.4
r1525 (  2 18 ) resistor r=0.0717383 //w=0.224 //l=0.115 //layer=m1 \
 //thickness=0.36 //x=2.825 //y=2.4 //x2=2.71 //y2=2.4
r1526 (  1 20 ) resistor r=0.0880901 //w=0.191 //l=0.115 //layer=m1 \
 //thickness=0.36 //x=18.135 //y=2.4 //x2=18.25 //y2=2.4
r1527 (  1 2 ) resistor r=14.6088 //w=0.131 //l=15.31 //layer=m1 \
 //thickness=0.36 //x=18.135 //y=2.4 //x2=2.825 //y2=2.4
ends PM_TMRDFFSNRNQNX1\%RN

subckt PM_TMRDFFSNRNQNX1\%SN ( 1 2 3 4 5 6 7 8 9 10 23 24 25 26 27 28 29 30 31 \
 33 42 51 60 68 77 84 85 86 87 88 89 90 91 92 93 94 95 96 97 98 99 100 101 102 \
 103 104 106 112 113 114 115 116 121 122 123 125 131 132 133 134 135 140 141 \
 142 144 150 151 152 153 154 159 160 161 163 169 170 171 172 173 178 179 180 \
 182 188 189 190 191 192 197 198 199 201 207 208 209 210 211 219 230 241 252 \
 263 274 )
c699 ( 274 0 ) capacitor c=0.0335551f //x=84.48 //y=4.88
c700 ( 263 0 ) capacitor c=0.0333886f //x=70.05 //y=4.88
c701 ( 252 0 ) capacitor c=0.0333886f //x=55.62 //y=4.88
c702 ( 241 0 ) capacitor c=0.0333886f //x=41.19 //y=4.88
c703 ( 230 0 ) capacitor c=0.0333886f //x=26.76 //y=4.88
c704 ( 219 0 ) capacitor c=0.0335551f //x=12.33 //y=4.88
c705 ( 211 0 ) capacitor c=0.0245352f //x=84.815 //y=4.97
c706 ( 210 0 ) capacitor c=0.0825763f //x=84.57 //y=2.095
c707 ( 209 0 ) capacitor c=0.0170266f //x=84.57 //y=1.63
c708 ( 208 0 ) capacitor c=0.018609f //x=84.57 //y=1.4
c709 ( 207 0 ) capacitor c=0.0187309f //x=84.57 //y=1.09
c710 ( 201 0 ) capacitor c=0.014725f //x=84.415 //y=1.555
c711 ( 199 0 ) capacitor c=0.0146567f //x=84.415 //y=0.935
c712 ( 198 0 ) capacitor c=0.0335408f //x=84.045 //y=1.4
c713 ( 197 0 ) capacitor c=0.0173761f //x=84.045 //y=1.09
c714 ( 192 0 ) capacitor c=0.0246783f //x=70.385 //y=4.97
c715 ( 191 0 ) capacitor c=0.0825763f //x=70.14 //y=2.095
c716 ( 190 0 ) capacitor c=0.0170266f //x=70.14 //y=1.63
c717 ( 189 0 ) capacitor c=0.018609f //x=70.14 //y=1.4
c718 ( 188 0 ) capacitor c=0.0187309f //x=70.14 //y=1.09
c719 ( 182 0 ) capacitor c=0.014725f //x=69.985 //y=1.555
c720 ( 180 0 ) capacitor c=0.0146567f //x=69.985 //y=0.935
c721 ( 179 0 ) capacitor c=0.0335408f //x=69.615 //y=1.4
c722 ( 178 0 ) capacitor c=0.0173761f //x=69.615 //y=1.09
c723 ( 173 0 ) capacitor c=0.0246783f //x=55.955 //y=4.97
c724 ( 172 0 ) capacitor c=0.0825763f //x=55.71 //y=2.095
c725 ( 171 0 ) capacitor c=0.0170266f //x=55.71 //y=1.63
c726 ( 170 0 ) capacitor c=0.018609f //x=55.71 //y=1.4
c727 ( 169 0 ) capacitor c=0.0187309f //x=55.71 //y=1.09
c728 ( 163 0 ) capacitor c=0.014725f //x=55.555 //y=1.555
c729 ( 161 0 ) capacitor c=0.0146567f //x=55.555 //y=0.935
c730 ( 160 0 ) capacitor c=0.0335408f //x=55.185 //y=1.4
c731 ( 159 0 ) capacitor c=0.0173761f //x=55.185 //y=1.09
c732 ( 154 0 ) capacitor c=0.0246783f //x=41.525 //y=4.97
c733 ( 153 0 ) capacitor c=0.0825763f //x=41.28 //y=2.095
c734 ( 152 0 ) capacitor c=0.0170266f //x=41.28 //y=1.63
c735 ( 151 0 ) capacitor c=0.018609f //x=41.28 //y=1.4
c736 ( 150 0 ) capacitor c=0.0187309f //x=41.28 //y=1.09
c737 ( 144 0 ) capacitor c=0.014725f //x=41.125 //y=1.555
c738 ( 142 0 ) capacitor c=0.0146567f //x=41.125 //y=0.935
c739 ( 141 0 ) capacitor c=0.0335408f //x=40.755 //y=1.4
c740 ( 140 0 ) capacitor c=0.0173761f //x=40.755 //y=1.09
c741 ( 135 0 ) capacitor c=0.0246783f //x=27.095 //y=4.97
c742 ( 134 0 ) capacitor c=0.0825763f //x=26.85 //y=2.095
c743 ( 133 0 ) capacitor c=0.0170266f //x=26.85 //y=1.63
c744 ( 132 0 ) capacitor c=0.018609f //x=26.85 //y=1.4
c745 ( 131 0 ) capacitor c=0.0187309f //x=26.85 //y=1.09
c746 ( 125 0 ) capacitor c=0.014725f //x=26.695 //y=1.555
c747 ( 123 0 ) capacitor c=0.0146567f //x=26.695 //y=0.935
c748 ( 122 0 ) capacitor c=0.0335408f //x=26.325 //y=1.4
c749 ( 121 0 ) capacitor c=0.0173761f //x=26.325 //y=1.09
c750 ( 116 0 ) capacitor c=0.0245352f //x=12.665 //y=4.97
c751 ( 115 0 ) capacitor c=0.0825763f //x=12.42 //y=2.095
c752 ( 114 0 ) capacitor c=0.0170266f //x=12.42 //y=1.63
c753 ( 113 0 ) capacitor c=0.018609f //x=12.42 //y=1.4
c754 ( 112 0 ) capacitor c=0.0187309f //x=12.42 //y=1.09
c755 ( 106 0 ) capacitor c=0.014725f //x=12.265 //y=1.555
c756 ( 104 0 ) capacitor c=0.0146567f //x=12.265 //y=0.935
c757 ( 103 0 ) capacitor c=0.0335408f //x=11.895 //y=1.4
c758 ( 102 0 ) capacitor c=0.0173761f //x=11.895 //y=1.09
c759 ( 101 0 ) capacitor c=0.110114f //x=84.89 //y=6.2
c760 ( 100 0 ) capacitor c=0.11012f //x=84.45 //y=6.2
c761 ( 99 0 ) capacitor c=0.109949f //x=70.46 //y=6.2
c762 ( 98 0 ) capacitor c=0.109956f //x=70.02 //y=6.2
c763 ( 97 0 ) capacitor c=0.109949f //x=56.03 //y=6.2
c764 ( 96 0 ) capacitor c=0.109956f //x=55.59 //y=6.2
c765 ( 95 0 ) capacitor c=0.109949f //x=41.6 //y=6.2
c766 ( 94 0 ) capacitor c=0.109956f //x=41.16 //y=6.2
c767 ( 93 0 ) capacitor c=0.109949f //x=27.17 //y=6.2
c768 ( 92 0 ) capacitor c=0.109956f //x=26.73 //y=6.2
c769 ( 91 0 ) capacitor c=0.110114f //x=12.74 //y=6.2
c770 ( 90 0 ) capacitor c=0.11012f //x=12.3 //y=6.2
c771 ( 77 0 ) capacitor c=0.0905889f //x=84.48 //y=2.26
c772 ( 68 0 ) capacitor c=0.0877967f //x=70.05 //y=2.26
c773 ( 60 0 ) capacitor c=0.0858297f //x=55.62 //y=2.26
c774 ( 51 0 ) capacitor c=0.0877967f //x=41.19 //y=2.26
c775 ( 42 0 ) capacitor c=0.0881699f //x=26.76 //y=2.26
c776 ( 33 0 ) capacitor c=0.0895139f //x=12.33 //y=2.26
c777 ( 10 0 ) capacitor c=0.00568147f //x=70.165 //y=3.14
c778 ( 9 0 ) capacitor c=0.263037f //x=84.365 //y=3.14
c779 ( 8 0 ) capacitor c=0.00539919f //x=55.735 //y=3.14
c780 ( 7 0 ) capacitor c=0.22725f //x=69.935 //y=3.14
c781 ( 6 0 ) capacitor c=0.00568147f //x=41.305 //y=3.14
c782 ( 5 0 ) capacitor c=0.228822f //x=55.505 //y=3.14
c783 ( 4 0 ) capacitor c=0.00568147f //x=26.875 //y=3.14
c784 ( 3 0 ) capacitor c=0.242055f //x=41.075 //y=3.14
c785 ( 2 0 ) capacitor c=0.0141295f //x=12.445 //y=3.14
c786 ( 1 0 ) capacitor c=0.231676f //x=26.645 //y=3.14
r787 (  276 277 ) resistor r=32.4568 //w=0.214 //l=0.075 //layer=ply \
 //thickness=0.18 //x=84.48 //y=4.97 //x2=84.48 //y2=5.045
r788 (  274 276 ) resistor r=20.271 //w=0.214 //l=0.09 //layer=ply \
 //thickness=0.18 //x=84.48 //y=4.88 //x2=84.48 //y2=4.97
r789 (  265 266 ) resistor r=32.4568 //w=0.214 //l=0.075 //layer=ply \
 //thickness=0.18 //x=70.05 //y=4.97 //x2=70.05 //y2=5.045
r790 (  263 265 ) resistor r=20.271 //w=0.214 //l=0.09 //layer=ply \
 //thickness=0.18 //x=70.05 //y=4.88 //x2=70.05 //y2=4.97
r791 (  254 255 ) resistor r=32.4568 //w=0.214 //l=0.075 //layer=ply \
 //thickness=0.18 //x=55.62 //y=4.97 //x2=55.62 //y2=5.045
r792 (  252 254 ) resistor r=20.271 //w=0.214 //l=0.09 //layer=ply \
 //thickness=0.18 //x=55.62 //y=4.88 //x2=55.62 //y2=4.97
r793 (  243 244 ) resistor r=32.4568 //w=0.214 //l=0.075 //layer=ply \
 //thickness=0.18 //x=41.19 //y=4.97 //x2=41.19 //y2=5.045
r794 (  241 243 ) resistor r=20.271 //w=0.214 //l=0.09 //layer=ply \
 //thickness=0.18 //x=41.19 //y=4.88 //x2=41.19 //y2=4.97
r795 (  232 233 ) resistor r=32.4568 //w=0.214 //l=0.075 //layer=ply \
 //thickness=0.18 //x=26.76 //y=4.97 //x2=26.76 //y2=5.045
r796 (  230 232 ) resistor r=20.271 //w=0.214 //l=0.09 //layer=ply \
 //thickness=0.18 //x=26.76 //y=4.88 //x2=26.76 //y2=4.97
r797 (  221 222 ) resistor r=32.4568 //w=0.214 //l=0.075 //layer=ply \
 //thickness=0.18 //x=12.33 //y=4.97 //x2=12.33 //y2=5.045
r798 (  219 221 ) resistor r=20.271 //w=0.214 //l=0.09 //layer=ply \
 //thickness=0.18 //x=12.33 //y=4.88 //x2=12.33 //y2=4.97
r799 (  212 276 ) resistor r=16.5046 //w=0.27 //l=0.135 //layer=ply \
 //thickness=0.18 //x=84.615 //y=4.97 //x2=84.48 //y2=4.97
r800 (  211 213 ) resistor r=26.9307 //w=0.15 //l=0.106066 //layer=ply \
 //thickness=0.18 //x=84.815 //y=4.97 //x2=84.89 //y2=5.045
r801 (  211 212 ) resistor r=102.553 //w=0.094 //l=0.2 //layer=ply \
 //thickness=0.18 //x=84.815 //y=4.97 //x2=84.615 //y2=4.97
r802 (  210 281 ) resistor r=38.6777 //w=0.284 //l=0.198997 //layer=ply \
 //thickness=0.18 //x=84.57 //y=2.095 //x2=84.495 //y2=2.26
r803 (  209 279 ) resistor r=21.2976 //w=0.217 //l=0.0928709 //layer=ply \
 //thickness=0.18 //x=84.57 //y=1.63 //x2=84.53 //y2=1.555
r804 (  209 210 ) resistor r=238.436 //w=0.094 //l=0.465 //layer=ply \
 //thickness=0.18 //x=84.57 //y=1.63 //x2=84.57 //y2=2.095
r805 (  208 279 ) resistor r=39.0671 //w=0.217 //l=0.173853 //layer=ply \
 //thickness=0.18 //x=84.57 //y=1.4 //x2=84.53 //y2=1.555
r806 (  207 278 ) resistor r=45.1352 //w=0.168 //l=0.173853 //layer=ply \
 //thickness=0.18 //x=84.57 //y=1.09 //x2=84.53 //y2=0.935
r807 (  207 208 ) resistor r=158.957 //w=0.094 //l=0.31 //layer=ply \
 //thickness=0.18 //x=84.57 //y=1.09 //x2=84.57 //y2=1.4
r808 (  202 272 ) resistor r=5.52526 //w=0.168 //l=0.115 //layer=ply \
 //thickness=0.18 //x=84.2 //y=1.555 //x2=84.085 //y2=1.555
r809 (  201 279 ) resistor r=11.4558 //w=0.217 //l=0.115 //layer=ply \
 //thickness=0.18 //x=84.415 //y=1.555 //x2=84.53 //y2=1.555
r810 (  200 271 ) resistor r=5.52526 //w=0.168 //l=0.115 //layer=ply \
 //thickness=0.18 //x=84.2 //y=0.935 //x2=84.085 //y2=0.935
r811 (  199 278 ) resistor r=5.52526 //w=0.168 //l=0.115 //layer=ply \
 //thickness=0.18 //x=84.415 //y=0.935 //x2=84.53 //y2=0.935
r812 (  199 200 ) resistor r=110.245 //w=0.094 //l=0.215 //layer=ply \
 //thickness=0.18 //x=84.415 //y=0.935 //x2=84.2 //y2=0.935
r813 (  198 272 ) resistor r=45.1352 //w=0.168 //l=0.173853 //layer=ply \
 //thickness=0.18 //x=84.045 //y=1.4 //x2=84.085 //y2=1.555
r814 (  197 271 ) resistor r=45.1352 //w=0.168 //l=0.173853 //layer=ply \
 //thickness=0.18 //x=84.045 //y=1.09 //x2=84.085 //y2=0.935
r815 (  197 198 ) resistor r=158.957 //w=0.094 //l=0.31 //layer=ply \
 //thickness=0.18 //x=84.045 //y=1.09 //x2=84.045 //y2=1.4
r816 (  193 265 ) resistor r=16.5046 //w=0.27 //l=0.135 //layer=ply \
 //thickness=0.18 //x=70.185 //y=4.97 //x2=70.05 //y2=4.97
r817 (  192 194 ) resistor r=26.9307 //w=0.15 //l=0.106066 //layer=ply \
 //thickness=0.18 //x=70.385 //y=4.97 //x2=70.46 //y2=5.045
r818 (  192 193 ) resistor r=102.553 //w=0.094 //l=0.2 //layer=ply \
 //thickness=0.18 //x=70.385 //y=4.97 //x2=70.185 //y2=4.97
r819 (  191 270 ) resistor r=38.6777 //w=0.284 //l=0.198997 //layer=ply \
 //thickness=0.18 //x=70.14 //y=2.095 //x2=70.065 //y2=2.26
r820 (  190 268 ) resistor r=21.2976 //w=0.217 //l=0.0928709 //layer=ply \
 //thickness=0.18 //x=70.14 //y=1.63 //x2=70.1 //y2=1.555
r821 (  190 191 ) resistor r=238.436 //w=0.094 //l=0.465 //layer=ply \
 //thickness=0.18 //x=70.14 //y=1.63 //x2=70.14 //y2=2.095
r822 (  189 268 ) resistor r=39.0671 //w=0.217 //l=0.173853 //layer=ply \
 //thickness=0.18 //x=70.14 //y=1.4 //x2=70.1 //y2=1.555
r823 (  188 267 ) resistor r=45.1352 //w=0.168 //l=0.173853 //layer=ply \
 //thickness=0.18 //x=70.14 //y=1.09 //x2=70.1 //y2=0.935
r824 (  188 189 ) resistor r=158.957 //w=0.094 //l=0.31 //layer=ply \
 //thickness=0.18 //x=70.14 //y=1.09 //x2=70.14 //y2=1.4
r825 (  183 261 ) resistor r=5.52526 //w=0.168 //l=0.115 //layer=ply \
 //thickness=0.18 //x=69.77 //y=1.555 //x2=69.655 //y2=1.555
r826 (  182 268 ) resistor r=11.4558 //w=0.217 //l=0.115 //layer=ply \
 //thickness=0.18 //x=69.985 //y=1.555 //x2=70.1 //y2=1.555
r827 (  181 260 ) resistor r=5.52526 //w=0.168 //l=0.115 //layer=ply \
 //thickness=0.18 //x=69.77 //y=0.935 //x2=69.655 //y2=0.935
r828 (  180 267 ) resistor r=5.52526 //w=0.168 //l=0.115 //layer=ply \
 //thickness=0.18 //x=69.985 //y=0.935 //x2=70.1 //y2=0.935
r829 (  180 181 ) resistor r=110.245 //w=0.094 //l=0.215 //layer=ply \
 //thickness=0.18 //x=69.985 //y=0.935 //x2=69.77 //y2=0.935
r830 (  179 261 ) resistor r=45.1352 //w=0.168 //l=0.173853 //layer=ply \
 //thickness=0.18 //x=69.615 //y=1.4 //x2=69.655 //y2=1.555
r831 (  178 260 ) resistor r=45.1352 //w=0.168 //l=0.173853 //layer=ply \
 //thickness=0.18 //x=69.615 //y=1.09 //x2=69.655 //y2=0.935
r832 (  178 179 ) resistor r=158.957 //w=0.094 //l=0.31 //layer=ply \
 //thickness=0.18 //x=69.615 //y=1.09 //x2=69.615 //y2=1.4
r833 (  174 254 ) resistor r=16.5046 //w=0.27 //l=0.135 //layer=ply \
 //thickness=0.18 //x=55.755 //y=4.97 //x2=55.62 //y2=4.97
r834 (  173 175 ) resistor r=26.9307 //w=0.15 //l=0.106066 //layer=ply \
 //thickness=0.18 //x=55.955 //y=4.97 //x2=56.03 //y2=5.045
r835 (  173 174 ) resistor r=102.553 //w=0.094 //l=0.2 //layer=ply \
 //thickness=0.18 //x=55.955 //y=4.97 //x2=55.755 //y2=4.97
r836 (  172 259 ) resistor r=38.6777 //w=0.284 //l=0.198997 //layer=ply \
 //thickness=0.18 //x=55.71 //y=2.095 //x2=55.635 //y2=2.26
r837 (  171 257 ) resistor r=21.2976 //w=0.217 //l=0.0928709 //layer=ply \
 //thickness=0.18 //x=55.71 //y=1.63 //x2=55.67 //y2=1.555
r838 (  171 172 ) resistor r=238.436 //w=0.094 //l=0.465 //layer=ply \
 //thickness=0.18 //x=55.71 //y=1.63 //x2=55.71 //y2=2.095
r839 (  170 257 ) resistor r=39.0671 //w=0.217 //l=0.173853 //layer=ply \
 //thickness=0.18 //x=55.71 //y=1.4 //x2=55.67 //y2=1.555
r840 (  169 256 ) resistor r=45.1352 //w=0.168 //l=0.173853 //layer=ply \
 //thickness=0.18 //x=55.71 //y=1.09 //x2=55.67 //y2=0.935
r841 (  169 170 ) resistor r=158.957 //w=0.094 //l=0.31 //layer=ply \
 //thickness=0.18 //x=55.71 //y=1.09 //x2=55.71 //y2=1.4
r842 (  164 250 ) resistor r=5.52526 //w=0.168 //l=0.115 //layer=ply \
 //thickness=0.18 //x=55.34 //y=1.555 //x2=55.225 //y2=1.555
r843 (  163 257 ) resistor r=11.4558 //w=0.217 //l=0.115 //layer=ply \
 //thickness=0.18 //x=55.555 //y=1.555 //x2=55.67 //y2=1.555
r844 (  162 249 ) resistor r=5.52526 //w=0.168 //l=0.115 //layer=ply \
 //thickness=0.18 //x=55.34 //y=0.935 //x2=55.225 //y2=0.935
r845 (  161 256 ) resistor r=5.52526 //w=0.168 //l=0.115 //layer=ply \
 //thickness=0.18 //x=55.555 //y=0.935 //x2=55.67 //y2=0.935
r846 (  161 162 ) resistor r=110.245 //w=0.094 //l=0.215 //layer=ply \
 //thickness=0.18 //x=55.555 //y=0.935 //x2=55.34 //y2=0.935
r847 (  160 250 ) resistor r=45.1352 //w=0.168 //l=0.173853 //layer=ply \
 //thickness=0.18 //x=55.185 //y=1.4 //x2=55.225 //y2=1.555
r848 (  159 249 ) resistor r=45.1352 //w=0.168 //l=0.173853 //layer=ply \
 //thickness=0.18 //x=55.185 //y=1.09 //x2=55.225 //y2=0.935
r849 (  159 160 ) resistor r=158.957 //w=0.094 //l=0.31 //layer=ply \
 //thickness=0.18 //x=55.185 //y=1.09 //x2=55.185 //y2=1.4
r850 (  155 243 ) resistor r=16.5046 //w=0.27 //l=0.135 //layer=ply \
 //thickness=0.18 //x=41.325 //y=4.97 //x2=41.19 //y2=4.97
r851 (  154 156 ) resistor r=26.9307 //w=0.15 //l=0.106066 //layer=ply \
 //thickness=0.18 //x=41.525 //y=4.97 //x2=41.6 //y2=5.045
r852 (  154 155 ) resistor r=102.553 //w=0.094 //l=0.2 //layer=ply \
 //thickness=0.18 //x=41.525 //y=4.97 //x2=41.325 //y2=4.97
r853 (  153 248 ) resistor r=38.6777 //w=0.284 //l=0.198997 //layer=ply \
 //thickness=0.18 //x=41.28 //y=2.095 //x2=41.205 //y2=2.26
r854 (  152 246 ) resistor r=21.2976 //w=0.217 //l=0.0928709 //layer=ply \
 //thickness=0.18 //x=41.28 //y=1.63 //x2=41.24 //y2=1.555
r855 (  152 153 ) resistor r=238.436 //w=0.094 //l=0.465 //layer=ply \
 //thickness=0.18 //x=41.28 //y=1.63 //x2=41.28 //y2=2.095
r856 (  151 246 ) resistor r=39.0671 //w=0.217 //l=0.173853 //layer=ply \
 //thickness=0.18 //x=41.28 //y=1.4 //x2=41.24 //y2=1.555
r857 (  150 245 ) resistor r=45.1352 //w=0.168 //l=0.173853 //layer=ply \
 //thickness=0.18 //x=41.28 //y=1.09 //x2=41.24 //y2=0.935
r858 (  150 151 ) resistor r=158.957 //w=0.094 //l=0.31 //layer=ply \
 //thickness=0.18 //x=41.28 //y=1.09 //x2=41.28 //y2=1.4
r859 (  145 239 ) resistor r=5.52526 //w=0.168 //l=0.115 //layer=ply \
 //thickness=0.18 //x=40.91 //y=1.555 //x2=40.795 //y2=1.555
r860 (  144 246 ) resistor r=11.4558 //w=0.217 //l=0.115 //layer=ply \
 //thickness=0.18 //x=41.125 //y=1.555 //x2=41.24 //y2=1.555
r861 (  143 238 ) resistor r=5.52526 //w=0.168 //l=0.115 //layer=ply \
 //thickness=0.18 //x=40.91 //y=0.935 //x2=40.795 //y2=0.935
r862 (  142 245 ) resistor r=5.52526 //w=0.168 //l=0.115 //layer=ply \
 //thickness=0.18 //x=41.125 //y=0.935 //x2=41.24 //y2=0.935
r863 (  142 143 ) resistor r=110.245 //w=0.094 //l=0.215 //layer=ply \
 //thickness=0.18 //x=41.125 //y=0.935 //x2=40.91 //y2=0.935
r864 (  141 239 ) resistor r=45.1352 //w=0.168 //l=0.173853 //layer=ply \
 //thickness=0.18 //x=40.755 //y=1.4 //x2=40.795 //y2=1.555
r865 (  140 238 ) resistor r=45.1352 //w=0.168 //l=0.173853 //layer=ply \
 //thickness=0.18 //x=40.755 //y=1.09 //x2=40.795 //y2=0.935
r866 (  140 141 ) resistor r=158.957 //w=0.094 //l=0.31 //layer=ply \
 //thickness=0.18 //x=40.755 //y=1.09 //x2=40.755 //y2=1.4
r867 (  136 232 ) resistor r=16.5046 //w=0.27 //l=0.135 //layer=ply \
 //thickness=0.18 //x=26.895 //y=4.97 //x2=26.76 //y2=4.97
r868 (  135 137 ) resistor r=26.9307 //w=0.15 //l=0.106066 //layer=ply \
 //thickness=0.18 //x=27.095 //y=4.97 //x2=27.17 //y2=5.045
r869 (  135 136 ) resistor r=102.553 //w=0.094 //l=0.2 //layer=ply \
 //thickness=0.18 //x=27.095 //y=4.97 //x2=26.895 //y2=4.97
r870 (  134 237 ) resistor r=38.6777 //w=0.284 //l=0.198997 //layer=ply \
 //thickness=0.18 //x=26.85 //y=2.095 //x2=26.775 //y2=2.26
r871 (  133 235 ) resistor r=21.2976 //w=0.217 //l=0.0928709 //layer=ply \
 //thickness=0.18 //x=26.85 //y=1.63 //x2=26.81 //y2=1.555
r872 (  133 134 ) resistor r=238.436 //w=0.094 //l=0.465 //layer=ply \
 //thickness=0.18 //x=26.85 //y=1.63 //x2=26.85 //y2=2.095
r873 (  132 235 ) resistor r=39.0671 //w=0.217 //l=0.173853 //layer=ply \
 //thickness=0.18 //x=26.85 //y=1.4 //x2=26.81 //y2=1.555
r874 (  131 234 ) resistor r=45.1352 //w=0.168 //l=0.173853 //layer=ply \
 //thickness=0.18 //x=26.85 //y=1.09 //x2=26.81 //y2=0.935
r875 (  131 132 ) resistor r=158.957 //w=0.094 //l=0.31 //layer=ply \
 //thickness=0.18 //x=26.85 //y=1.09 //x2=26.85 //y2=1.4
r876 (  126 228 ) resistor r=5.52526 //w=0.168 //l=0.115 //layer=ply \
 //thickness=0.18 //x=26.48 //y=1.555 //x2=26.365 //y2=1.555
r877 (  125 235 ) resistor r=11.4558 //w=0.217 //l=0.115 //layer=ply \
 //thickness=0.18 //x=26.695 //y=1.555 //x2=26.81 //y2=1.555
r878 (  124 227 ) resistor r=5.52526 //w=0.168 //l=0.115 //layer=ply \
 //thickness=0.18 //x=26.48 //y=0.935 //x2=26.365 //y2=0.935
r879 (  123 234 ) resistor r=5.52526 //w=0.168 //l=0.115 //layer=ply \
 //thickness=0.18 //x=26.695 //y=0.935 //x2=26.81 //y2=0.935
r880 (  123 124 ) resistor r=110.245 //w=0.094 //l=0.215 //layer=ply \
 //thickness=0.18 //x=26.695 //y=0.935 //x2=26.48 //y2=0.935
r881 (  122 228 ) resistor r=45.1352 //w=0.168 //l=0.173853 //layer=ply \
 //thickness=0.18 //x=26.325 //y=1.4 //x2=26.365 //y2=1.555
r882 (  121 227 ) resistor r=45.1352 //w=0.168 //l=0.173853 //layer=ply \
 //thickness=0.18 //x=26.325 //y=1.09 //x2=26.365 //y2=0.935
r883 (  121 122 ) resistor r=158.957 //w=0.094 //l=0.31 //layer=ply \
 //thickness=0.18 //x=26.325 //y=1.09 //x2=26.325 //y2=1.4
r884 (  117 221 ) resistor r=16.5046 //w=0.27 //l=0.135 //layer=ply \
 //thickness=0.18 //x=12.465 //y=4.97 //x2=12.33 //y2=4.97
r885 (  116 118 ) resistor r=26.9307 //w=0.15 //l=0.106066 //layer=ply \
 //thickness=0.18 //x=12.665 //y=4.97 //x2=12.74 //y2=5.045
r886 (  116 117 ) resistor r=102.553 //w=0.094 //l=0.2 //layer=ply \
 //thickness=0.18 //x=12.665 //y=4.97 //x2=12.465 //y2=4.97
r887 (  115 226 ) resistor r=38.6777 //w=0.284 //l=0.198997 //layer=ply \
 //thickness=0.18 //x=12.42 //y=2.095 //x2=12.345 //y2=2.26
r888 (  114 224 ) resistor r=21.2976 //w=0.217 //l=0.0928709 //layer=ply \
 //thickness=0.18 //x=12.42 //y=1.63 //x2=12.38 //y2=1.555
r889 (  114 115 ) resistor r=238.436 //w=0.094 //l=0.465 //layer=ply \
 //thickness=0.18 //x=12.42 //y=1.63 //x2=12.42 //y2=2.095
r890 (  113 224 ) resistor r=39.0671 //w=0.217 //l=0.173853 //layer=ply \
 //thickness=0.18 //x=12.42 //y=1.4 //x2=12.38 //y2=1.555
r891 (  112 223 ) resistor r=45.1352 //w=0.168 //l=0.173853 //layer=ply \
 //thickness=0.18 //x=12.42 //y=1.09 //x2=12.38 //y2=0.935
r892 (  112 113 ) resistor r=158.957 //w=0.094 //l=0.31 //layer=ply \
 //thickness=0.18 //x=12.42 //y=1.09 //x2=12.42 //y2=1.4
r893 (  107 217 ) resistor r=5.52526 //w=0.168 //l=0.115 //layer=ply \
 //thickness=0.18 //x=12.05 //y=1.555 //x2=11.935 //y2=1.555
r894 (  106 224 ) resistor r=11.4558 //w=0.217 //l=0.115 //layer=ply \
 //thickness=0.18 //x=12.265 //y=1.555 //x2=12.38 //y2=1.555
r895 (  105 216 ) resistor r=5.52526 //w=0.168 //l=0.115 //layer=ply \
 //thickness=0.18 //x=12.05 //y=0.935 //x2=11.935 //y2=0.935
r896 (  104 223 ) resistor r=5.52526 //w=0.168 //l=0.115 //layer=ply \
 //thickness=0.18 //x=12.265 //y=0.935 //x2=12.38 //y2=0.935
r897 (  104 105 ) resistor r=110.245 //w=0.094 //l=0.215 //layer=ply \
 //thickness=0.18 //x=12.265 //y=0.935 //x2=12.05 //y2=0.935
r898 (  103 217 ) resistor r=45.1352 //w=0.168 //l=0.173853 //layer=ply \
 //thickness=0.18 //x=11.895 //y=1.4 //x2=11.935 //y2=1.555
r899 (  102 216 ) resistor r=45.1352 //w=0.168 //l=0.173853 //layer=ply \
 //thickness=0.18 //x=11.895 //y=1.09 //x2=11.935 //y2=0.935
r900 (  102 103 ) resistor r=158.957 //w=0.094 //l=0.31 //layer=ply \
 //thickness=0.18 //x=11.895 //y=1.09 //x2=11.895 //y2=1.4
r901 (  101 213 ) resistor r=592.245 //w=0.094 //l=1.155 //layer=ply \
 //thickness=0.18 //x=84.89 //y=6.2 //x2=84.89 //y2=5.045
r902 (  100 277 ) resistor r=592.245 //w=0.094 //l=1.155 //layer=ply \
 //thickness=0.18 //x=84.45 //y=6.2 //x2=84.45 //y2=5.045
r903 (  99 194 ) resistor r=592.245 //w=0.094 //l=1.155 //layer=ply \
 //thickness=0.18 //x=70.46 //y=6.2 //x2=70.46 //y2=5.045
r904 (  98 266 ) resistor r=592.245 //w=0.094 //l=1.155 //layer=ply \
 //thickness=0.18 //x=70.02 //y=6.2 //x2=70.02 //y2=5.045
r905 (  97 175 ) resistor r=592.245 //w=0.094 //l=1.155 //layer=ply \
 //thickness=0.18 //x=56.03 //y=6.2 //x2=56.03 //y2=5.045
r906 (  96 255 ) resistor r=592.245 //w=0.094 //l=1.155 //layer=ply \
 //thickness=0.18 //x=55.59 //y=6.2 //x2=55.59 //y2=5.045
r907 (  95 156 ) resistor r=592.245 //w=0.094 //l=1.155 //layer=ply \
 //thickness=0.18 //x=41.6 //y=6.2 //x2=41.6 //y2=5.045
r908 (  94 244 ) resistor r=592.245 //w=0.094 //l=1.155 //layer=ply \
 //thickness=0.18 //x=41.16 //y=6.2 //x2=41.16 //y2=5.045
r909 (  93 137 ) resistor r=592.245 //w=0.094 //l=1.155 //layer=ply \
 //thickness=0.18 //x=27.17 //y=6.2 //x2=27.17 //y2=5.045
r910 (  92 233 ) resistor r=592.245 //w=0.094 //l=1.155 //layer=ply \
 //thickness=0.18 //x=26.73 //y=6.2 //x2=26.73 //y2=5.045
r911 (  91 118 ) resistor r=592.245 //w=0.094 //l=1.155 //layer=ply \
 //thickness=0.18 //x=12.74 //y=6.2 //x2=12.74 //y2=5.045
r912 (  90 222 ) resistor r=592.245 //w=0.094 //l=1.155 //layer=ply \
 //thickness=0.18 //x=12.3 //y=6.2 //x2=12.3 //y2=5.045
r913 (  89 201 ) resistor r=55.3787 //w=0.094 //l=0.108 //layer=ply \
 //thickness=0.18 //x=84.307 //y=1.555 //x2=84.415 //y2=1.555
r914 (  89 202 ) resistor r=54.866 //w=0.094 //l=0.107 //layer=ply \
 //thickness=0.18 //x=84.307 //y=1.555 //x2=84.2 //y2=1.555
r915 (  88 182 ) resistor r=55.3787 //w=0.094 //l=0.108 //layer=ply \
 //thickness=0.18 //x=69.877 //y=1.555 //x2=69.985 //y2=1.555
r916 (  88 183 ) resistor r=54.866 //w=0.094 //l=0.107 //layer=ply \
 //thickness=0.18 //x=69.877 //y=1.555 //x2=69.77 //y2=1.555
r917 (  87 163 ) resistor r=55.3787 //w=0.094 //l=0.108 //layer=ply \
 //thickness=0.18 //x=55.447 //y=1.555 //x2=55.555 //y2=1.555
r918 (  87 164 ) resistor r=54.866 //w=0.094 //l=0.107 //layer=ply \
 //thickness=0.18 //x=55.447 //y=1.555 //x2=55.34 //y2=1.555
r919 (  86 144 ) resistor r=55.3787 //w=0.094 //l=0.108 //layer=ply \
 //thickness=0.18 //x=41.017 //y=1.555 //x2=41.125 //y2=1.555
r920 (  86 145 ) resistor r=54.866 //w=0.094 //l=0.107 //layer=ply \
 //thickness=0.18 //x=41.017 //y=1.555 //x2=40.91 //y2=1.555
r921 (  85 125 ) resistor r=55.3787 //w=0.094 //l=0.108 //layer=ply \
 //thickness=0.18 //x=26.587 //y=1.555 //x2=26.695 //y2=1.555
r922 (  85 126 ) resistor r=54.866 //w=0.094 //l=0.107 //layer=ply \
 //thickness=0.18 //x=26.587 //y=1.555 //x2=26.48 //y2=1.555
r923 (  84 106 ) resistor r=55.3787 //w=0.094 //l=0.108 //layer=ply \
 //thickness=0.18 //x=12.157 //y=1.555 //x2=12.265 //y2=1.555
r924 (  84 107 ) resistor r=54.866 //w=0.094 //l=0.107 //layer=ply \
 //thickness=0.18 //x=12.157 //y=1.555 //x2=12.05 //y2=1.555
r925 (  82 274 ) resistor r=152 //w=0.17 //l=0.17 //layer=licon //count=1 \
 //x=84.48 //y=4.88 //x2=84.48 //y2=4.88
r926 (  80 82 ) resistor r=119.102 //w=0.187 //l=1.74 //layer=li \
 //thickness=0.1 //x=84.48 //y=3.14 //x2=84.48 //y2=4.88
r927 (  77 281 ) resistor r=152 //w=0.17 //l=0.17 //layer=licon //count=1 \
 //x=84.48 //y=2.26 //x2=84.48 //y2=2.26
r928 (  77 80 ) resistor r=60.2353 //w=0.187 //l=0.88 //layer=li \
 //thickness=0.1 //x=84.48 //y=2.26 //x2=84.48 //y2=3.14
r929 (  74 263 ) resistor r=152 //w=0.17 //l=0.17 //layer=licon //count=1 \
 //x=70.05 //y=4.88 //x2=70.05 //y2=4.88
r930 (  68 270 ) resistor r=152 //w=0.17 //l=0.17 //layer=licon //count=1 \
 //x=70.05 //y=2.26 //x2=70.05 //y2=2.26
r931 (  65 252 ) resistor r=152 //w=0.17 //l=0.17 //layer=licon //count=1 \
 //x=55.62 //y=4.88 //x2=55.62 //y2=4.88
r932 (  60 259 ) resistor r=152 //w=0.17 //l=0.17 //layer=licon //count=1 \
 //x=55.62 //y=2.26 //x2=55.62 //y2=2.26
r933 (  57 241 ) resistor r=152 //w=0.17 //l=0.17 //layer=licon //count=1 \
 //x=41.19 //y=4.88 //x2=41.19 //y2=4.88
r934 (  51 248 ) resistor r=152 //w=0.17 //l=0.17 //layer=licon //count=1 \
 //x=41.19 //y=2.26 //x2=41.19 //y2=2.26
r935 (  48 230 ) resistor r=152 //w=0.17 //l=0.17 //layer=licon //count=1 \
 //x=26.76 //y=4.88 //x2=26.76 //y2=4.88
r936 (  42 237 ) resistor r=152 //w=0.17 //l=0.17 //layer=licon //count=1 \
 //x=26.76 //y=2.26 //x2=26.76 //y2=2.26
r937 (  39 219 ) resistor r=152 //w=0.17 //l=0.17 //layer=licon //count=1 \
 //x=12.33 //y=4.88 //x2=12.33 //y2=4.88
r938 (  33 226 ) resistor r=152 //w=0.17 //l=0.17 //layer=licon //count=1 \
 //x=12.33 //y=2.26 //x2=12.33 //y2=2.26
r939 (  31 74 ) resistor r=119.102 //w=0.187 //l=1.74 //layer=li \
 //thickness=0.1 //x=70.05 //y=3.14 //x2=70.05 //y2=4.88
r940 (  30 31 ) resistor r=25.3262 //w=0.187 //l=0.37 //layer=li \
 //thickness=0.1 //x=70.05 //y=2.77 //x2=70.05 //y2=3.14
r941 (  30 68 ) resistor r=34.9091 //w=0.187 //l=0.51 //layer=li \
 //thickness=0.1 //x=70.05 //y=2.77 //x2=70.05 //y2=2.26
r942 (  29 65 ) resistor r=119.102 //w=0.187 //l=1.74 //layer=li \
 //thickness=0.1 //x=55.62 //y=3.14 //x2=55.62 //y2=4.88
r943 (  29 60 ) resistor r=60.2353 //w=0.187 //l=0.88 //layer=li \
 //thickness=0.1 //x=55.62 //y=3.14 //x2=55.62 //y2=2.26
r944 (  28 57 ) resistor r=119.102 //w=0.187 //l=1.74 //layer=li \
 //thickness=0.1 //x=41.19 //y=3.14 //x2=41.19 //y2=4.88
r945 (  27 28 ) resistor r=25.3262 //w=0.187 //l=0.37 //layer=li \
 //thickness=0.1 //x=41.19 //y=2.77 //x2=41.19 //y2=3.14
r946 (  27 51 ) resistor r=34.9091 //w=0.187 //l=0.51 //layer=li \
 //thickness=0.1 //x=41.19 //y=2.77 //x2=41.19 //y2=2.26
r947 (  26 48 ) resistor r=119.102 //w=0.187 //l=1.74 //layer=li \
 //thickness=0.1 //x=26.76 //y=3.14 //x2=26.76 //y2=4.88
r948 (  25 26 ) resistor r=25.3262 //w=0.187 //l=0.37 //layer=li \
 //thickness=0.1 //x=26.76 //y=2.77 //x2=26.76 //y2=3.14
r949 (  25 42 ) resistor r=34.9091 //w=0.187 //l=0.51 //layer=li \
 //thickness=0.1 //x=26.76 //y=2.77 //x2=26.76 //y2=2.26
r950 (  24 39 ) resistor r=119.102 //w=0.187 //l=1.74 //layer=li \
 //thickness=0.1 //x=12.33 //y=3.14 //x2=12.33 //y2=4.88
r951 (  23 24 ) resistor r=25.3262 //w=0.187 //l=0.37 //layer=li \
 //thickness=0.1 //x=12.33 //y=2.77 //x2=12.33 //y2=3.14
r952 (  23 33 ) resistor r=34.9091 //w=0.187 //l=0.51 //layer=li \
 //thickness=0.1 //x=12.33 //y=2.77 //x2=12.33 //y2=2.26
r953 (  22 80 ) resistor r=9.3 //w=0.17 //l=0.17 //layer=mcon //count=1 \
 //x=84.48 //y=3.14 //x2=84.48 //y2=3.14
r954 (  20 31 ) resistor r=9.3 //w=0.17 //l=0.17 //layer=mcon //count=1 \
 //x=70.05 //y=3.14 //x2=70.05 //y2=3.14
r955 (  18 29 ) resistor r=9.3 //w=0.17 //l=0.17 //layer=mcon //count=1 \
 //x=55.62 //y=3.14 //x2=55.62 //y2=3.14
r956 (  16 28 ) resistor r=9.3 //w=0.17 //l=0.17 //layer=mcon //count=1 \
 //x=41.19 //y=3.14 //x2=41.19 //y2=3.14
r957 (  14 26 ) resistor r=9.3 //w=0.17 //l=0.17 //layer=mcon //count=1 \
 //x=26.76 //y=3.14 //x2=26.76 //y2=3.14
r958 (  12 24 ) resistor r=9.3 //w=0.17 //l=0.17 //layer=mcon //count=1 \
 //x=12.33 //y=3.14 //x2=12.33 //y2=3.14
r959 (  10 20 ) resistor r=0.0880901 //w=0.191 //l=0.115 //layer=m1 \
 //thickness=0.36 //x=70.165 //y=3.14 //x2=70.05 //y2=3.14
r960 (  9 22 ) resistor r=0.0717383 //w=0.224 //l=0.115 //layer=m1 \
 //thickness=0.36 //x=84.365 //y=3.14 //x2=84.48 //y2=3.14
r961 (  9 10 ) resistor r=13.5496 //w=0.131 //l=14.2 //layer=m1 \
 //thickness=0.36 //x=84.365 //y=3.14 //x2=70.165 //y2=3.14
r962 (  8 18 ) resistor r=0.0880901 //w=0.191 //l=0.115 //layer=m1 \
 //thickness=0.36 //x=55.735 //y=3.14 //x2=55.62 //y2=3.14
r963 (  7 20 ) resistor r=0.0880901 //w=0.191 //l=0.115 //layer=m1 \
 //thickness=0.36 //x=69.935 //y=3.14 //x2=70.05 //y2=3.14
r964 (  7 8 ) resistor r=13.5496 //w=0.131 //l=14.2 //layer=m1 \
 //thickness=0.36 //x=69.935 //y=3.14 //x2=55.735 //y2=3.14
r965 (  6 16 ) resistor r=0.0880901 //w=0.191 //l=0.115 //layer=m1 \
 //thickness=0.36 //x=41.305 //y=3.14 //x2=41.19 //y2=3.14
r966 (  5 18 ) resistor r=0.0880901 //w=0.191 //l=0.115 //layer=m1 \
 //thickness=0.36 //x=55.505 //y=3.14 //x2=55.62 //y2=3.14
r967 (  5 6 ) resistor r=13.5496 //w=0.131 //l=14.2 //layer=m1 \
 //thickness=0.36 //x=55.505 //y=3.14 //x2=41.305 //y2=3.14
r968 (  4 14 ) resistor r=0.0880901 //w=0.191 //l=0.115 //layer=m1 \
 //thickness=0.36 //x=26.875 //y=3.14 //x2=26.76 //y2=3.14
r969 (  3 16 ) resistor r=0.0880901 //w=0.191 //l=0.115 //layer=m1 \
 //thickness=0.36 //x=41.075 //y=3.14 //x2=41.19 //y2=3.14
r970 (  3 4 ) resistor r=13.5496 //w=0.131 //l=14.2 //layer=m1 \
 //thickness=0.36 //x=41.075 //y=3.14 //x2=26.875 //y2=3.14
r971 (  2 12 ) resistor r=0.0717383 //w=0.224 //l=0.115 //layer=m1 \
 //thickness=0.36 //x=12.445 //y=3.14 //x2=12.33 //y2=3.14
r972 (  1 14 ) resistor r=0.0880901 //w=0.191 //l=0.115 //layer=m1 \
 //thickness=0.36 //x=26.645 //y=3.14 //x2=26.76 //y2=3.14
r973 (  1 2 ) resistor r=13.5496 //w=0.131 //l=14.2 //layer=m1 \
 //thickness=0.36 //x=26.645 //y=3.14 //x2=12.445 //y2=3.14
ends PM_TMRDFFSNRNQNX1\%SN

subckt PM_TMRDFFSNRNQNX1\%noxref_21 ( 1 2 3 4 5 6 16 24 37 38 45 53 59 60 64 \
 66 73 74 75 76 77 78 79 80 81 82 83 87 88 89 94 96 99 100 104 105 106 111 113 \
 116 117 121 122 123 128 130 133 134 136 137 142 146 147 152 156 157 162 165 \
 167 168 169 )
c343 ( 169 0 ) capacitor c=0.023087f //x=75.785 //y=5.2
c344 ( 168 0 ) capacitor c=0.023519f //x=74.905 //y=5.2
c345 ( 167 0 ) capacitor c=0.0224735f //x=74.025 //y=5.2
c346 ( 165 0 ) capacitor c=0.00853354f //x=76.035 //y=1.095
c347 ( 162 0 ) capacitor c=0.0587755f //x=85.59 //y=4.88
c348 ( 157 0 ) capacitor c=0.0273931f //x=85.59 //y=2.095
c349 ( 156 0 ) capacitor c=0.0456313f //x=85.59 //y=2.26
c350 ( 152 0 ) capacitor c=0.0588394f //x=71.16 //y=4.88
c351 ( 147 0 ) capacitor c=0.0273931f //x=71.16 //y=2.095
c352 ( 146 0 ) capacitor c=0.0456313f //x=71.16 //y=2.26
c353 ( 142 0 ) capacitor c=0.0589949f //x=66.35 //y=4.88
c354 ( 137 0 ) capacitor c=0.0273931f //x=66.35 //y=2.095
c355 ( 136 0 ) capacitor c=0.0456313f //x=66.35 //y=2.26
c356 ( 134 0 ) capacitor c=0.0432517f //x=86.11 //y=1.44
c357 ( 133 0 ) capacitor c=0.0200379f //x=86.11 //y=1.095
c358 ( 130 0 ) capacitor c=0.0148873f //x=85.955 //y=1.595
c359 ( 128 0 ) capacitor c=0.0157803f //x=85.955 //y=0.94
c360 ( 123 0 ) capacitor c=0.0218028f //x=85.58 //y=1.75
c361 ( 122 0 ) capacitor c=0.0207459f //x=85.58 //y=1.44
c362 ( 121 0 ) capacitor c=0.0194308f //x=85.58 //y=1.095
c363 ( 117 0 ) capacitor c=0.0432517f //x=71.68 //y=1.44
c364 ( 116 0 ) capacitor c=0.0200379f //x=71.68 //y=1.095
c365 ( 113 0 ) capacitor c=0.0148873f //x=71.525 //y=1.595
c366 ( 111 0 ) capacitor c=0.0157803f //x=71.525 //y=0.94
c367 ( 106 0 ) capacitor c=0.0218028f //x=71.15 //y=1.75
c368 ( 105 0 ) capacitor c=0.0207459f //x=71.15 //y=1.44
c369 ( 104 0 ) capacitor c=0.0194308f //x=71.15 //y=1.095
c370 ( 100 0 ) capacitor c=0.0432517f //x=66.87 //y=1.44
c371 ( 99 0 ) capacitor c=0.0200379f //x=66.87 //y=1.095
c372 ( 96 0 ) capacitor c=0.0148873f //x=66.715 //y=1.595
c373 ( 94 0 ) capacitor c=0.0157803f //x=66.715 //y=0.94
c374 ( 89 0 ) capacitor c=0.0218028f //x=66.34 //y=1.75
c375 ( 88 0 ) capacitor c=0.0207459f //x=66.34 //y=1.44
c376 ( 87 0 ) capacitor c=0.0194308f //x=66.34 //y=1.095
c377 ( 83 0 ) capacitor c=0.158794f //x=85.77 //y=6.2
c378 ( 82 0 ) capacitor c=0.110114f //x=85.33 //y=6.2
c379 ( 81 0 ) capacitor c=0.158754f //x=71.34 //y=6.2
c380 ( 80 0 ) capacitor c=0.109949f //x=70.9 //y=6.2
c381 ( 79 0 ) capacitor c=0.158754f //x=66.53 //y=6.2
c382 ( 78 0 ) capacitor c=0.109949f //x=66.09 //y=6.2
c383 ( 74 0 ) capacitor c=0.00106608f //x=75.93 //y=5.335
c384 ( 73 0 ) capacitor c=0.00191414f //x=75.05 //y=5.335
c385 ( 66 0 ) capacitor c=0.0836242f //x=85.59 //y=2.26
c386 ( 64 0 ) capacitor c=0.10494f //x=76.71 //y=3.88
c387 ( 60 0 ) capacitor c=0.00398962f //x=76.31 //y=1.845
c388 ( 59 0 ) capacitor c=0.0137288f //x=76.625 //y=1.845
c389 ( 53 0 ) capacitor c=0.0283082f //x=76.625 //y=5.335
c390 ( 45 0 ) capacitor c=0.0170864f //x=75.845 //y=5.335
c391 ( 38 0 ) capacitor c=0.00316998f //x=74.255 //y=5.335
c392 ( 37 0 ) capacitor c=0.014258f //x=74.965 //y=5.335
c393 ( 24 0 ) capacitor c=0.0790362f //x=71.16 //y=2.26
c394 ( 16 0 ) capacitor c=0.076565f //x=66.35 //y=2.26
c395 ( 6 0 ) capacitor c=0.0055354f //x=76.825 //y=3.88
c396 ( 5 0 ) capacitor c=0.164574f //x=85.475 //y=3.88
c397 ( 4 0 ) capacitor c=0.00533183f //x=71.275 //y=3.88
c398 ( 3 0 ) capacitor c=0.0753575f //x=76.595 //y=3.88
c399 ( 2 0 ) capacitor c=0.00692093f //x=66.465 //y=3.88
c400 ( 1 0 ) capacitor c=0.0665749f //x=71.045 //y=3.88
r401 (  156 157 ) resistor r=52.7279 //w=0.214 //l=0.165 //layer=ply \
 //thickness=0.18 //x=85.59 //y=2.26 //x2=85.59 //y2=2.095
r402 (  146 147 ) resistor r=52.7279 //w=0.214 //l=0.165 //layer=ply \
 //thickness=0.18 //x=71.16 //y=2.26 //x2=71.16 //y2=2.095
r403 (  136 137 ) resistor r=52.7279 //w=0.214 //l=0.165 //layer=ply \
 //thickness=0.18 //x=66.35 //y=2.26 //x2=66.35 //y2=2.095
r404 (  134 164 ) resistor r=45.1352 //w=0.168 //l=0.173853 //layer=ply \
 //thickness=0.18 //x=86.11 //y=1.44 //x2=86.07 //y2=1.595
r405 (  133 163 ) resistor r=45.1352 //w=0.168 //l=0.173853 //layer=ply \
 //thickness=0.18 //x=86.11 //y=1.095 //x2=86.07 //y2=0.94
r406 (  133 134 ) resistor r=176.904 //w=0.094 //l=0.345 //layer=ply \
 //thickness=0.18 //x=86.11 //y=1.095 //x2=86.11 //y2=1.44
r407 (  131 160 ) resistor r=10.701 //w=0.21 //l=0.115 //layer=ply \
 //thickness=0.18 //x=85.735 //y=1.595 //x2=85.62 //y2=1.595
r408 (  130 164 ) resistor r=5.52526 //w=0.168 //l=0.115 //layer=ply \
 //thickness=0.18 //x=85.955 //y=1.595 //x2=86.07 //y2=1.595
r409 (  129 159 ) resistor r=5.52526 //w=0.168 //l=0.115 //layer=ply \
 //thickness=0.18 //x=85.735 //y=0.94 //x2=85.62 //y2=0.94
r410 (  128 163 ) resistor r=5.52526 //w=0.168 //l=0.115 //layer=ply \
 //thickness=0.18 //x=85.955 //y=0.94 //x2=86.07 //y2=0.94
r411 (  128 129 ) resistor r=112.809 //w=0.094 //l=0.22 //layer=ply \
 //thickness=0.18 //x=85.955 //y=0.94 //x2=85.735 //y2=0.94
r412 (  125 162 ) resistor r=37.236 //w=0.233 //l=0.249199 //layer=ply \
 //thickness=0.18 //x=85.77 //y=5.045 //x2=85.59 //y2=4.88
r413 (  123 160 ) resistor r=39.5823 //w=0.21 //l=0.173853 //layer=ply \
 //thickness=0.18 //x=85.58 //y=1.75 //x2=85.62 //y2=1.595
r414 (  123 157 ) resistor r=176.904 //w=0.094 //l=0.345 //layer=ply \
 //thickness=0.18 //x=85.58 //y=1.75 //x2=85.58 //y2=2.095
r415 (  122 160 ) resistor r=39.5823 //w=0.21 //l=0.173853 //layer=ply \
 //thickness=0.18 //x=85.58 //y=1.44 //x2=85.62 //y2=1.595
r416 (  121 159 ) resistor r=45.1352 //w=0.168 //l=0.173853 //layer=ply \
 //thickness=0.18 //x=85.58 //y=1.095 //x2=85.62 //y2=0.94
r417 (  121 122 ) resistor r=176.904 //w=0.094 //l=0.345 //layer=ply \
 //thickness=0.18 //x=85.58 //y=1.095 //x2=85.58 //y2=1.44
r418 (  118 162 ) resistor r=53.7854 //w=0.233 //l=0.332415 //layer=ply \
 //thickness=0.18 //x=85.33 //y=5.045 //x2=85.59 //y2=4.88
r419 (  117 154 ) resistor r=45.1352 //w=0.168 //l=0.173853 //layer=ply \
 //thickness=0.18 //x=71.68 //y=1.44 //x2=71.64 //y2=1.595
r420 (  116 153 ) resistor r=45.1352 //w=0.168 //l=0.173853 //layer=ply \
 //thickness=0.18 //x=71.68 //y=1.095 //x2=71.64 //y2=0.94
r421 (  116 117 ) resistor r=176.904 //w=0.094 //l=0.345 //layer=ply \
 //thickness=0.18 //x=71.68 //y=1.095 //x2=71.68 //y2=1.44
r422 (  114 150 ) resistor r=10.701 //w=0.21 //l=0.115 //layer=ply \
 //thickness=0.18 //x=71.305 //y=1.595 //x2=71.19 //y2=1.595
r423 (  113 154 ) resistor r=5.52526 //w=0.168 //l=0.115 //layer=ply \
 //thickness=0.18 //x=71.525 //y=1.595 //x2=71.64 //y2=1.595
r424 (  112 149 ) resistor r=5.52526 //w=0.168 //l=0.115 //layer=ply \
 //thickness=0.18 //x=71.305 //y=0.94 //x2=71.19 //y2=0.94
r425 (  111 153 ) resistor r=5.52526 //w=0.168 //l=0.115 //layer=ply \
 //thickness=0.18 //x=71.525 //y=0.94 //x2=71.64 //y2=0.94
r426 (  111 112 ) resistor r=112.809 //w=0.094 //l=0.22 //layer=ply \
 //thickness=0.18 //x=71.525 //y=0.94 //x2=71.305 //y2=0.94
r427 (  108 152 ) resistor r=37.236 //w=0.233 //l=0.249199 //layer=ply \
 //thickness=0.18 //x=71.34 //y=5.045 //x2=71.16 //y2=4.88
r428 (  106 150 ) resistor r=39.5823 //w=0.21 //l=0.173853 //layer=ply \
 //thickness=0.18 //x=71.15 //y=1.75 //x2=71.19 //y2=1.595
r429 (  106 147 ) resistor r=176.904 //w=0.094 //l=0.345 //layer=ply \
 //thickness=0.18 //x=71.15 //y=1.75 //x2=71.15 //y2=2.095
r430 (  105 150 ) resistor r=39.5823 //w=0.21 //l=0.173853 //layer=ply \
 //thickness=0.18 //x=71.15 //y=1.44 //x2=71.19 //y2=1.595
r431 (  104 149 ) resistor r=45.1352 //w=0.168 //l=0.173853 //layer=ply \
 //thickness=0.18 //x=71.15 //y=1.095 //x2=71.19 //y2=0.94
r432 (  104 105 ) resistor r=176.904 //w=0.094 //l=0.345 //layer=ply \
 //thickness=0.18 //x=71.15 //y=1.095 //x2=71.15 //y2=1.44
r433 (  101 152 ) resistor r=53.7854 //w=0.233 //l=0.332415 //layer=ply \
 //thickness=0.18 //x=70.9 //y=5.045 //x2=71.16 //y2=4.88
r434 (  100 144 ) resistor r=45.1352 //w=0.168 //l=0.173853 //layer=ply \
 //thickness=0.18 //x=66.87 //y=1.44 //x2=66.83 //y2=1.595
r435 (  99 143 ) resistor r=45.1352 //w=0.168 //l=0.173853 //layer=ply \
 //thickness=0.18 //x=66.87 //y=1.095 //x2=66.83 //y2=0.94
r436 (  99 100 ) resistor r=176.904 //w=0.094 //l=0.345 //layer=ply \
 //thickness=0.18 //x=66.87 //y=1.095 //x2=66.87 //y2=1.44
r437 (  97 140 ) resistor r=10.701 //w=0.21 //l=0.115 //layer=ply \
 //thickness=0.18 //x=66.495 //y=1.595 //x2=66.38 //y2=1.595
r438 (  96 144 ) resistor r=5.52526 //w=0.168 //l=0.115 //layer=ply \
 //thickness=0.18 //x=66.715 //y=1.595 //x2=66.83 //y2=1.595
r439 (  95 139 ) resistor r=5.52526 //w=0.168 //l=0.115 //layer=ply \
 //thickness=0.18 //x=66.495 //y=0.94 //x2=66.38 //y2=0.94
r440 (  94 143 ) resistor r=5.52526 //w=0.168 //l=0.115 //layer=ply \
 //thickness=0.18 //x=66.715 //y=0.94 //x2=66.83 //y2=0.94
r441 (  94 95 ) resistor r=112.809 //w=0.094 //l=0.22 //layer=ply \
 //thickness=0.18 //x=66.715 //y=0.94 //x2=66.495 //y2=0.94
r442 (  91 142 ) resistor r=37.236 //w=0.233 //l=0.249199 //layer=ply \
 //thickness=0.18 //x=66.53 //y=5.045 //x2=66.35 //y2=4.88
r443 (  89 140 ) resistor r=39.5823 //w=0.21 //l=0.173853 //layer=ply \
 //thickness=0.18 //x=66.34 //y=1.75 //x2=66.38 //y2=1.595
r444 (  89 137 ) resistor r=176.904 //w=0.094 //l=0.345 //layer=ply \
 //thickness=0.18 //x=66.34 //y=1.75 //x2=66.34 //y2=2.095
r445 (  88 140 ) resistor r=39.5823 //w=0.21 //l=0.173853 //layer=ply \
 //thickness=0.18 //x=66.34 //y=1.44 //x2=66.38 //y2=1.595
r446 (  87 139 ) resistor r=45.1352 //w=0.168 //l=0.173853 //layer=ply \
 //thickness=0.18 //x=66.34 //y=1.095 //x2=66.38 //y2=0.94
r447 (  87 88 ) resistor r=176.904 //w=0.094 //l=0.345 //layer=ply \
 //thickness=0.18 //x=66.34 //y=1.095 //x2=66.34 //y2=1.44
r448 (  84 142 ) resistor r=53.7854 //w=0.233 //l=0.332415 //layer=ply \
 //thickness=0.18 //x=66.09 //y=5.045 //x2=66.35 //y2=4.88
r449 (  83 125 ) resistor r=592.245 //w=0.094 //l=1.155 //layer=ply \
 //thickness=0.18 //x=85.77 //y=6.2 //x2=85.77 //y2=5.045
r450 (  82 118 ) resistor r=592.245 //w=0.094 //l=1.155 //layer=ply \
 //thickness=0.18 //x=85.33 //y=6.2 //x2=85.33 //y2=5.045
r451 (  81 108 ) resistor r=592.245 //w=0.094 //l=1.155 //layer=ply \
 //thickness=0.18 //x=71.34 //y=6.2 //x2=71.34 //y2=5.045
r452 (  80 101 ) resistor r=592.245 //w=0.094 //l=1.155 //layer=ply \
 //thickness=0.18 //x=70.9 //y=6.2 //x2=70.9 //y2=5.045
r453 (  79 91 ) resistor r=592.245 //w=0.094 //l=1.155 //layer=ply \
 //thickness=0.18 //x=66.53 //y=6.2 //x2=66.53 //y2=5.045
r454 (  78 84 ) resistor r=592.245 //w=0.094 //l=1.155 //layer=ply \
 //thickness=0.18 //x=66.09 //y=6.2 //x2=66.09 //y2=5.045
r455 (  77 130 ) resistor r=56.4043 //w=0.094 //l=0.11 //layer=ply \
 //thickness=0.18 //x=85.845 //y=1.595 //x2=85.955 //y2=1.595
r456 (  77 131 ) resistor r=56.4043 //w=0.094 //l=0.11 //layer=ply \
 //thickness=0.18 //x=85.845 //y=1.595 //x2=85.735 //y2=1.595
r457 (  76 113 ) resistor r=56.4043 //w=0.094 //l=0.11 //layer=ply \
 //thickness=0.18 //x=71.415 //y=1.595 //x2=71.525 //y2=1.595
r458 (  76 114 ) resistor r=56.4043 //w=0.094 //l=0.11 //layer=ply \
 //thickness=0.18 //x=71.415 //y=1.595 //x2=71.305 //y2=1.595
r459 (  75 96 ) resistor r=56.4043 //w=0.094 //l=0.11 //layer=ply \
 //thickness=0.18 //x=66.605 //y=1.595 //x2=66.715 //y2=1.595
r460 (  75 97 ) resistor r=56.4043 //w=0.094 //l=0.11 //layer=ply \
 //thickness=0.18 //x=66.605 //y=1.595 //x2=66.495 //y2=1.595
r461 (  71 162 ) resistor r=152 //w=0.17 //l=0.17 //layer=licon //count=1 \
 //x=85.59 //y=4.88 //x2=85.59 //y2=4.88
r462 (  69 71 ) resistor r=68.4492 //w=0.187 //l=1 //layer=li //thickness=0.1 \
 //x=85.59 //y=3.88 //x2=85.59 //y2=4.88
r463 (  66 156 ) resistor r=152 //w=0.17 //l=0.17 //layer=licon //count=1 \
 //x=85.59 //y=2.26 //x2=85.59 //y2=2.26
r464 (  66 69 ) resistor r=110.888 //w=0.187 //l=1.62 //layer=li \
 //thickness=0.1 //x=85.59 //y=2.26 //x2=85.59 //y2=3.88
r465 (  62 64 ) resistor r=93.7754 //w=0.187 //l=1.37 //layer=li \
 //thickness=0.1 //x=76.71 //y=5.25 //x2=76.71 //y2=3.88
r466 (  61 64 ) resistor r=133.476 //w=0.187 //l=1.95 //layer=li \
 //thickness=0.1 //x=76.71 //y=1.93 //x2=76.71 //y2=3.88
r467 (  59 61 ) resistor r=7.15173 //w=0.17 //l=0.120208 //layer=li \
 //thickness=0.1 //x=76.625 //y=1.845 //x2=76.71 //y2=1.93
r468 (  59 60 ) resistor r=21.5615 //w=0.187 //l=0.315 //layer=li \
 //thickness=0.1 //x=76.625 //y=1.845 //x2=76.31 //y2=1.845
r469 (  55 60 ) resistor r=7.15173 //w=0.17 //l=0.120208 //layer=li \
 //thickness=0.1 //x=76.225 //y=1.76 //x2=76.31 //y2=1.845
r470 (  55 165 ) resistor r=39.016 //w=0.187 //l=0.57 //layer=li \
 //thickness=0.1 //x=76.225 //y=1.76 //x2=76.225 //y2=1.19
r471 (  54 74 ) resistor r=5.4201 //w=0.17 //l=0.085 //layer=li \
 //thickness=0.1 //x=76.015 //y=5.335 //x2=75.93 //y2=5.335
r472 (  53 62 ) resistor r=7.15173 //w=0.17 //l=0.120208 //layer=li \
 //thickness=0.1 //x=76.625 //y=5.335 //x2=76.71 //y2=5.25
r473 (  53 54 ) resistor r=41.754 //w=0.187 //l=0.61 //layer=li \
 //thickness=0.1 //x=76.625 //y=5.335 //x2=76.015 //y2=5.335
r474 (  47 74 ) resistor r=1.40859 //w=0.34 //l=0.085 //layer=li \
 //thickness=0.1 //x=75.93 //y=5.42 //x2=75.93 //y2=5.335
r475 (  47 169 ) resistor r=33.1979 //w=0.187 //l=0.485 //layer=li \
 //thickness=0.1 //x=75.93 //y=5.42 //x2=75.93 //y2=5.905
r476 (  46 73 ) resistor r=5.4201 //w=0.17 //l=0.085 //layer=li \
 //thickness=0.1 //x=75.135 //y=5.335 //x2=75.05 //y2=5.335
r477 (  45 74 ) resistor r=5.4201 //w=0.17 //l=0.085 //layer=li \
 //thickness=0.1 //x=75.845 //y=5.335 //x2=75.93 //y2=5.335
r478 (  45 46 ) resistor r=48.5989 //w=0.187 //l=0.71 //layer=li \
 //thickness=0.1 //x=75.845 //y=5.335 //x2=75.135 //y2=5.335
r479 (  39 73 ) resistor r=1.40859 //w=0.34 //l=0.085 //layer=li \
 //thickness=0.1 //x=75.05 //y=5.42 //x2=75.05 //y2=5.335
r480 (  39 168 ) resistor r=33.1979 //w=0.187 //l=0.485 //layer=li \
 //thickness=0.1 //x=75.05 //y=5.42 //x2=75.05 //y2=5.905
r481 (  37 73 ) resistor r=5.4201 //w=0.17 //l=0.085 //layer=li \
 //thickness=0.1 //x=74.965 //y=5.335 //x2=75.05 //y2=5.335
r482 (  37 38 ) resistor r=48.5989 //w=0.187 //l=0.71 //layer=li \
 //thickness=0.1 //x=74.965 //y=5.335 //x2=74.255 //y2=5.335
r483 (  31 38 ) resistor r=7.15173 //w=0.17 //l=0.120208 //layer=li \
 //thickness=0.1 //x=74.17 //y=5.42 //x2=74.255 //y2=5.335
r484 (  31 167 ) resistor r=33.1979 //w=0.187 //l=0.485 //layer=li \
 //thickness=0.1 //x=74.17 //y=5.42 //x2=74.17 //y2=5.905
r485 (  29 152 ) resistor r=152 //w=0.17 //l=0.17 //layer=licon //count=1 \
 //x=71.16 //y=4.88 //x2=71.16 //y2=4.88
r486 (  27 29 ) resistor r=68.4492 //w=0.187 //l=1 //layer=li //thickness=0.1 \
 //x=71.16 //y=3.88 //x2=71.16 //y2=4.88
r487 (  24 146 ) resistor r=152 //w=0.17 //l=0.17 //layer=licon //count=1 \
 //x=71.16 //y=2.26 //x2=71.16 //y2=2.26
r488 (  24 27 ) resistor r=110.888 //w=0.187 //l=1.62 //layer=li \
 //thickness=0.1 //x=71.16 //y=2.26 //x2=71.16 //y2=3.88
r489 (  21 142 ) resistor r=152 //w=0.17 //l=0.17 //layer=licon //count=1 \
 //x=66.35 //y=4.88 //x2=66.35 //y2=4.88
r490 (  19 21 ) resistor r=68.4492 //w=0.187 //l=1 //layer=li //thickness=0.1 \
 //x=66.35 //y=3.88 //x2=66.35 //y2=4.88
r491 (  16 136 ) resistor r=152 //w=0.17 //l=0.17 //layer=licon //count=1 \
 //x=66.35 //y=2.26 //x2=66.35 //y2=2.26
r492 (  16 19 ) resistor r=110.888 //w=0.187 //l=1.62 //layer=li \
 //thickness=0.1 //x=66.35 //y=2.26 //x2=66.35 //y2=3.88
r493 (  14 69 ) resistor r=9.3 //w=0.17 //l=0.17 //layer=mcon //count=1 \
 //x=85.59 //y=3.88 //x2=85.59 //y2=3.88
r494 (  12 64 ) resistor r=9.3 //w=0.17 //l=0.17 //layer=mcon //count=1 \
 //x=76.71 //y=3.88 //x2=76.71 //y2=3.88
r495 (  10 27 ) resistor r=9.3 //w=0.17 //l=0.17 //layer=mcon //count=1 \
 //x=71.16 //y=3.88 //x2=71.16 //y2=3.88
r496 (  8 19 ) resistor r=9.3 //w=0.17 //l=0.17 //layer=mcon //count=1 \
 //x=66.35 //y=3.88 //x2=66.35 //y2=3.88
r497 (  6 12 ) resistor r=0.0880901 //w=0.191 //l=0.115 //layer=m1 \
 //thickness=0.36 //x=76.825 //y=3.88 //x2=76.71 //y2=3.88
r498 (  5 14 ) resistor r=0.0717383 //w=0.224 //l=0.115 //layer=m1 \
 //thickness=0.36 //x=85.475 //y=3.88 //x2=85.59 //y2=3.88
r499 (  5 6 ) resistor r=8.25382 //w=0.131 //l=8.65 //layer=m1 \
 //thickness=0.36 //x=85.475 //y=3.88 //x2=76.825 //y2=3.88
r500 (  4 10 ) resistor r=0.0880901 //w=0.191 //l=0.115 //layer=m1 \
 //thickness=0.36 //x=71.275 //y=3.88 //x2=71.16 //y2=3.88
r501 (  3 12 ) resistor r=0.0880901 //w=0.191 //l=0.115 //layer=m1 \
 //thickness=0.36 //x=76.595 //y=3.88 //x2=76.71 //y2=3.88
r502 (  3 4 ) resistor r=5.07634 //w=0.131 //l=5.32 //layer=m1 \
 //thickness=0.36 //x=76.595 //y=3.88 //x2=71.275 //y2=3.88
r503 (  2 8 ) resistor r=0.0717383 //w=0.224 //l=0.115 //layer=m1 \
 //thickness=0.36 //x=66.465 //y=3.88 //x2=66.35 //y2=3.88
r504 (  1 10 ) resistor r=0.0880901 //w=0.191 //l=0.115 //layer=m1 \
 //thickness=0.36 //x=71.045 //y=3.88 //x2=71.16 //y2=3.88
r505 (  1 2 ) resistor r=4.37023 //w=0.131 //l=4.58 //layer=m1 \
 //thickness=0.36 //x=71.045 //y=3.88 //x2=66.465 //y2=3.88
ends PM_TMRDFFSNRNQNX1\%noxref_21

subckt PM_TMRDFFSNRNQNX1\%noxref_22 ( 1 2 8 21 22 29 37 43 44 48 49 50 51 52 \
 53 57 58 59 64 66 69 70 72 73 78 81 83 84 85 )
c171 ( 85 0 ) capacitor c=0.023087f //x=85.405 //y=5.2
c172 ( 84 0 ) capacitor c=0.023519f //x=84.525 //y=5.2
c173 ( 83 0 ) capacitor c=0.0224735f //x=83.645 //y=5.2
c174 ( 81 0 ) capacitor c=0.0087111f //x=85.655 //y=1.095
c175 ( 78 0 ) capacitor c=0.0587755f //x=80.78 //y=4.88
c176 ( 73 0 ) capacitor c=0.0273931f //x=80.78 //y=2.095
c177 ( 72 0 ) capacitor c=0.0457015f //x=80.78 //y=2.26
c178 ( 70 0 ) capacitor c=0.0432517f //x=81.3 //y=1.44
c179 ( 69 0 ) capacitor c=0.0200379f //x=81.3 //y=1.095
c180 ( 66 0 ) capacitor c=0.0158629f //x=81.145 //y=1.595
c181 ( 64 0 ) capacitor c=0.0157803f //x=81.145 //y=0.94
c182 ( 59 0 ) capacitor c=0.0218028f //x=80.77 //y=1.75
c183 ( 58 0 ) capacitor c=0.0207459f //x=80.77 //y=1.44
c184 ( 57 0 ) capacitor c=0.0194308f //x=80.77 //y=1.095
c185 ( 53 0 ) capacitor c=0.158794f //x=80.96 //y=6.2
c186 ( 52 0 ) capacitor c=0.110114f //x=80.52 //y=6.2
c187 ( 50 0 ) capacitor c=0.00106608f //x=85.55 //y=5.335
c188 ( 49 0 ) capacitor c=0.00207319f //x=84.67 //y=5.335
c189 ( 48 0 ) capacitor c=0.108549f //x=86.33 //y=2.77
c190 ( 44 0 ) capacitor c=0.00398962f //x=85.93 //y=1.845
c191 ( 43 0 ) capacitor c=0.0137288f //x=86.245 //y=1.845
c192 ( 37 0 ) capacitor c=0.0281866f //x=86.245 //y=5.335
c193 ( 29 0 ) capacitor c=0.0176454f //x=85.465 //y=5.335
c194 ( 22 0 ) capacitor c=0.00332903f //x=83.875 //y=5.335
c195 ( 21 0 ) capacitor c=0.0148427f //x=84.585 //y=5.335
c196 ( 8 0 ) capacitor c=0.0838166f //x=80.78 //y=2.26
c197 ( 2 0 ) capacitor c=0.0158526f //x=80.895 //y=2.77
c198 ( 1 0 ) capacitor c=0.0993317f //x=86.215 //y=2.77
r199 (  72 73 ) resistor r=52.7279 //w=0.214 //l=0.165 //layer=ply \
 //thickness=0.18 //x=80.78 //y=2.26 //x2=80.78 //y2=2.095
r200 (  70 80 ) resistor r=45.1352 //w=0.168 //l=0.173853 //layer=ply \
 //thickness=0.18 //x=81.3 //y=1.44 //x2=81.26 //y2=1.595
r201 (  69 79 ) resistor r=45.1352 //w=0.168 //l=0.173853 //layer=ply \
 //thickness=0.18 //x=81.3 //y=1.095 //x2=81.26 //y2=0.94
r202 (  69 70 ) resistor r=176.904 //w=0.094 //l=0.345 //layer=ply \
 //thickness=0.18 //x=81.3 //y=1.095 //x2=81.3 //y2=1.44
r203 (  67 76 ) resistor r=10.701 //w=0.21 //l=0.115 //layer=ply \
 //thickness=0.18 //x=80.925 //y=1.595 //x2=80.81 //y2=1.595
r204 (  66 80 ) resistor r=5.52526 //w=0.168 //l=0.115 //layer=ply \
 //thickness=0.18 //x=81.145 //y=1.595 //x2=81.26 //y2=1.595
r205 (  65 75 ) resistor r=5.52526 //w=0.168 //l=0.115 //layer=ply \
 //thickness=0.18 //x=80.925 //y=0.94 //x2=80.81 //y2=0.94
r206 (  64 79 ) resistor r=5.52526 //w=0.168 //l=0.115 //layer=ply \
 //thickness=0.18 //x=81.145 //y=0.94 //x2=81.26 //y2=0.94
r207 (  64 65 ) resistor r=112.809 //w=0.094 //l=0.22 //layer=ply \
 //thickness=0.18 //x=81.145 //y=0.94 //x2=80.925 //y2=0.94
r208 (  61 78 ) resistor r=37.236 //w=0.233 //l=0.249199 //layer=ply \
 //thickness=0.18 //x=80.96 //y=5.045 //x2=80.78 //y2=4.88
r209 (  59 76 ) resistor r=39.5823 //w=0.21 //l=0.173853 //layer=ply \
 //thickness=0.18 //x=80.77 //y=1.75 //x2=80.81 //y2=1.595
r210 (  59 73 ) resistor r=176.904 //w=0.094 //l=0.345 //layer=ply \
 //thickness=0.18 //x=80.77 //y=1.75 //x2=80.77 //y2=2.095
r211 (  58 76 ) resistor r=39.5823 //w=0.21 //l=0.173853 //layer=ply \
 //thickness=0.18 //x=80.77 //y=1.44 //x2=80.81 //y2=1.595
r212 (  57 75 ) resistor r=45.1352 //w=0.168 //l=0.173853 //layer=ply \
 //thickness=0.18 //x=80.77 //y=1.095 //x2=80.81 //y2=0.94
r213 (  57 58 ) resistor r=176.904 //w=0.094 //l=0.345 //layer=ply \
 //thickness=0.18 //x=80.77 //y=1.095 //x2=80.77 //y2=1.44
r214 (  54 78 ) resistor r=53.7854 //w=0.233 //l=0.332415 //layer=ply \
 //thickness=0.18 //x=80.52 //y=5.045 //x2=80.78 //y2=4.88
r215 (  53 61 ) resistor r=592.245 //w=0.094 //l=1.155 //layer=ply \
 //thickness=0.18 //x=80.96 //y=6.2 //x2=80.96 //y2=5.045
r216 (  52 54 ) resistor r=592.245 //w=0.094 //l=1.155 //layer=ply \
 //thickness=0.18 //x=80.52 //y=6.2 //x2=80.52 //y2=5.045
r217 (  51 66 ) resistor r=56.4043 //w=0.094 //l=0.11 //layer=ply \
 //thickness=0.18 //x=81.035 //y=1.595 //x2=81.145 //y2=1.595
r218 (  51 67 ) resistor r=56.4043 //w=0.094 //l=0.11 //layer=ply \
 //thickness=0.18 //x=81.035 //y=1.595 //x2=80.925 //y2=1.595
r219 (  46 48 ) resistor r=169.754 //w=0.187 //l=2.48 //layer=li \
 //thickness=0.1 //x=86.33 //y=5.25 //x2=86.33 //y2=2.77
r220 (  45 48 ) resistor r=57.4973 //w=0.187 //l=0.84 //layer=li \
 //thickness=0.1 //x=86.33 //y=1.93 //x2=86.33 //y2=2.77
r221 (  43 45 ) resistor r=7.15173 //w=0.17 //l=0.120208 //layer=li \
 //thickness=0.1 //x=86.245 //y=1.845 //x2=86.33 //y2=1.93
r222 (  43 44 ) resistor r=21.5615 //w=0.187 //l=0.315 //layer=li \
 //thickness=0.1 //x=86.245 //y=1.845 //x2=85.93 //y2=1.845
r223 (  39 44 ) resistor r=7.15173 //w=0.17 //l=0.120208 //layer=li \
 //thickness=0.1 //x=85.845 //y=1.76 //x2=85.93 //y2=1.845
r224 (  39 81 ) resistor r=39.016 //w=0.187 //l=0.57 //layer=li \
 //thickness=0.1 //x=85.845 //y=1.76 //x2=85.845 //y2=1.19
r225 (  38 50 ) resistor r=5.4201 //w=0.17 //l=0.085 //layer=li \
 //thickness=0.1 //x=85.635 //y=5.335 //x2=85.55 //y2=5.335
r226 (  37 46 ) resistor r=7.15173 //w=0.17 //l=0.120208 //layer=li \
 //thickness=0.1 //x=86.245 //y=5.335 //x2=86.33 //y2=5.25
r227 (  37 38 ) resistor r=41.754 //w=0.187 //l=0.61 //layer=li \
 //thickness=0.1 //x=86.245 //y=5.335 //x2=85.635 //y2=5.335
r228 (  31 50 ) resistor r=1.40859 //w=0.34 //l=0.085 //layer=li \
 //thickness=0.1 //x=85.55 //y=5.42 //x2=85.55 //y2=5.335
r229 (  31 85 ) resistor r=33.1979 //w=0.187 //l=0.485 //layer=li \
 //thickness=0.1 //x=85.55 //y=5.42 //x2=85.55 //y2=5.905
r230 (  30 49 ) resistor r=5.4201 //w=0.17 //l=0.085 //layer=li \
 //thickness=0.1 //x=84.755 //y=5.335 //x2=84.67 //y2=5.335
r231 (  29 50 ) resistor r=5.4201 //w=0.17 //l=0.085 //layer=li \
 //thickness=0.1 //x=85.465 //y=5.335 //x2=85.55 //y2=5.335
r232 (  29 30 ) resistor r=48.5989 //w=0.187 //l=0.71 //layer=li \
 //thickness=0.1 //x=85.465 //y=5.335 //x2=84.755 //y2=5.335
r233 (  23 49 ) resistor r=1.40859 //w=0.34 //l=0.085 //layer=li \
 //thickness=0.1 //x=84.67 //y=5.42 //x2=84.67 //y2=5.335
r234 (  23 84 ) resistor r=33.1979 //w=0.187 //l=0.485 //layer=li \
 //thickness=0.1 //x=84.67 //y=5.42 //x2=84.67 //y2=5.905
r235 (  21 49 ) resistor r=5.4201 //w=0.17 //l=0.085 //layer=li \
 //thickness=0.1 //x=84.585 //y=5.335 //x2=84.67 //y2=5.335
r236 (  21 22 ) resistor r=48.5989 //w=0.187 //l=0.71 //layer=li \
 //thickness=0.1 //x=84.585 //y=5.335 //x2=83.875 //y2=5.335
r237 (  15 22 ) resistor r=7.15173 //w=0.17 //l=0.120208 //layer=li \
 //thickness=0.1 //x=83.79 //y=5.42 //x2=83.875 //y2=5.335
r238 (  15 83 ) resistor r=33.1979 //w=0.187 //l=0.485 //layer=li \
 //thickness=0.1 //x=83.79 //y=5.42 //x2=83.79 //y2=5.905
r239 (  13 78 ) resistor r=152 //w=0.17 //l=0.17 //layer=licon //count=1 \
 //x=80.78 //y=4.88 //x2=80.78 //y2=4.88
r240 (  11 13 ) resistor r=144.428 //w=0.187 //l=2.11 //layer=li \
 //thickness=0.1 //x=80.78 //y=2.77 //x2=80.78 //y2=4.88
r241 (  8 72 ) resistor r=152 //w=0.17 //l=0.17 //layer=licon //count=1 \
 //x=80.78 //y=2.26 //x2=80.78 //y2=2.26
r242 (  8 11 ) resistor r=34.9091 //w=0.187 //l=0.51 //layer=li \
 //thickness=0.1 //x=80.78 //y=2.26 //x2=80.78 //y2=2.77
r243 (  6 48 ) resistor r=9.3 //w=0.17 //l=0.17 //layer=mcon //count=1 \
 //x=86.33 //y=2.77 //x2=86.33 //y2=2.77
r244 (  4 11 ) resistor r=9.3 //w=0.17 //l=0.17 //layer=mcon //count=1 \
 //x=80.78 //y=2.77 //x2=80.78 //y2=2.77
r245 (  2 4 ) resistor r=0.0717383 //w=0.224 //l=0.115 //layer=m1 \
 //thickness=0.36 //x=80.895 //y=2.77 //x2=80.78 //y2=2.77
r246 (  1 6 ) resistor r=0.0717383 //w=0.224 //l=0.115 //layer=m1 \
 //thickness=0.36 //x=86.215 //y=2.77 //x2=86.33 //y2=2.77
r247 (  1 2 ) resistor r=5.07634 //w=0.131 //l=5.32 //layer=m1 \
 //thickness=0.36 //x=86.215 //y=2.77 //x2=80.895 //y2=2.77
ends PM_TMRDFFSNRNQNX1\%noxref_22

subckt PM_TMRDFFSNRNQNX1\%noxref_23 ( 1 2 13 14 15 23 29 30 37 50 51 52 53 54 )
c91 ( 54 0 ) capacitor c=0.034295f //x=92.795 //y=5.205
c92 ( 53 0 ) capacitor c=0.0174957f //x=91.915 //y=5.205
c93 ( 51 0 ) capacitor c=0.0214849f //x=89.035 //y=5.205
c94 ( 50 0 ) capacitor c=0.0217161f //x=88.155 //y=5.205
c95 ( 49 0 ) capacitor c=0.00115294f //x=92.06 //y=7.09
c96 ( 37 0 ) capacitor c=0.0131238f //x=92.855 //y=7.09
c97 ( 30 0 ) capacitor c=0.00386507f //x=91.265 //y=7.09
c98 ( 29 0 ) capacitor c=0.00951687f //x=91.975 //y=7.09
c99 ( 23 0 ) capacitor c=0.0455351f //x=91.18 //y=5.39
c100 ( 15 0 ) capacitor c=0.00871244f //x=89.18 //y=5.475
c101 ( 14 0 ) capacitor c=0.00290434f //x=88.385 //y=5.39
c102 ( 13 0 ) capacitor c=0.0139202f //x=89.095 //y=5.39
c103 ( 2 0 ) capacitor c=0.0091252f //x=89.295 //y=5.39
c104 ( 1 0 ) capacitor c=0.0484159f //x=91.065 //y=5.39
r105 (  39 54 ) resistor r=5.81818 //w=0.187 //l=0.085 //layer=li \
 //thickness=0.1 //x=92.94 //y=7.005 //x2=92.94 //y2=6.92
r106 (  38 49 ) resistor r=5.4201 //w=0.17 //l=0.085 //layer=li \
 //thickness=0.1 //x=92.145 //y=7.09 //x2=92.06 //y2=7.09
r107 (  37 39 ) resistor r=7.15173 //w=0.17 //l=0.120208 //layer=li \
 //thickness=0.1 //x=92.855 //y=7.09 //x2=92.94 //y2=7.005
r108 (  37 38 ) resistor r=48.5989 //w=0.187 //l=0.71 //layer=li \
 //thickness=0.1 //x=92.855 //y=7.09 //x2=92.145 //y2=7.09
r109 (  31 49 ) resistor r=1.40859 //w=0.34 //l=0.085 //layer=li \
 //thickness=0.1 //x=92.06 //y=7.005 //x2=92.06 //y2=7.09
r110 (  31 53 ) resistor r=5.81818 //w=0.187 //l=0.085 //layer=li \
 //thickness=0.1 //x=92.06 //y=7.005 //x2=92.06 //y2=6.92
r111 (  29 49 ) resistor r=5.4201 //w=0.17 //l=0.085 //layer=li \
 //thickness=0.1 //x=91.975 //y=7.09 //x2=92.06 //y2=7.09
r112 (  29 30 ) resistor r=48.5989 //w=0.187 //l=0.71 //layer=li \
 //thickness=0.1 //x=91.975 //y=7.09 //x2=91.265 //y2=7.09
r113 (  23 52 ) resistor r=58.1818 //w=0.187 //l=0.85 //layer=li \
 //thickness=0.1 //x=91.18 //y=5.39 //x2=91.18 //y2=6.24
r114 (  21 30 ) resistor r=7.15173 //w=0.17 //l=0.120208 //layer=li \
 //thickness=0.1 //x=91.18 //y=7.005 //x2=91.265 //y2=7.09
r115 (  21 52 ) resistor r=5.81818 //w=0.187 //l=0.085 //layer=li \
 //thickness=0.1 //x=91.18 //y=7.005 //x2=91.18 //y2=6.92
r116 (  15 48 ) resistor r=3.57586 //w=0.17 //l=0.125 //layer=li \
 //thickness=0.1 //x=89.18 //y=5.475 //x2=89.18 //y2=5.35
r117 (  15 51 ) resistor r=52.3636 //w=0.187 //l=0.765 //layer=li \
 //thickness=0.1 //x=89.18 //y=5.475 //x2=89.18 //y2=6.24
r118 (  13 48 ) resistor r=3.57586 //w=0.17 //l=0.103078 //layer=li \
 //thickness=0.1 //x=89.095 //y=5.39 //x2=89.18 //y2=5.35
r119 (  13 14 ) resistor r=48.5989 //w=0.187 //l=0.71 //layer=li \
 //thickness=0.1 //x=89.095 //y=5.39 //x2=88.385 //y2=5.39
r120 (  7 14 ) resistor r=7.15173 //w=0.17 //l=0.120208 //layer=li \
 //thickness=0.1 //x=88.3 //y=5.475 //x2=88.385 //y2=5.39
r121 (  7 50 ) resistor r=29.0909 //w=0.187 //l=0.425 //layer=li \
 //thickness=0.1 //x=88.3 //y=5.475 //x2=88.3 //y2=5.9
r122 (  6 23 ) resistor r=9.3 //w=0.17 //l=0.17 //layer=mcon //count=1 \
 //x=91.18 //y=5.39 //x2=91.18 //y2=5.39
r123 (  4 48 ) resistor r=9.3 //w=0.17 //l=0.17 //layer=mcon //count=1 \
 //x=89.18 //y=5.39 //x2=89.18 //y2=5.39
r124 (  2 4 ) resistor r=0.0717383 //w=0.224 //l=0.115 //layer=m1 \
 //thickness=0.36 //x=89.295 //y=5.39 //x2=89.18 //y2=5.39
r125 (  1 6 ) resistor r=0.0717383 //w=0.224 //l=0.115 //layer=m1 \
 //thickness=0.36 //x=91.065 //y=5.39 //x2=91.18 //y2=5.39
r126 (  1 2 ) resistor r=1.68893 //w=0.131 //l=1.77 //layer=m1 \
 //thickness=0.36 //x=91.065 //y=5.39 //x2=89.295 //y2=5.39
ends PM_TMRDFFSNRNQNX1\%noxref_23

subckt PM_TMRDFFSNRNQNX1\%noxref_24 ( 1 2 3 4 5 12 22 23 30 38 44 45 49 51 59 \
 66 72 73 74 75 76 77 78 79 80 81 82 83 84 85 86 87 89 95 96 97 98 105 106 107 \
 108 109 111 114 117 118 119 120 121 122 123 124 128 130 133 134 135 136 157 \
 164 166 167 168 )
c390 ( 168 0 ) capacitor c=0.023087f //x=80.595 //y=5.2
c391 ( 167 0 ) capacitor c=0.023519f //x=79.715 //y=5.2
c392 ( 166 0 ) capacitor c=0.0224735f //x=78.835 //y=5.2
c393 ( 164 0 ) capacitor c=0.00853354f //x=80.845 //y=1.095
c394 ( 157 0 ) capacitor c=0.0583848f //x=94.47 //y=2.26
c395 ( 136 0 ) capacitor c=0.0316774f //x=95.175 //y=1.39
c396 ( 135 0 ) capacitor c=0.0187384f //x=95.175 //y=1.045
c397 ( 134 0 ) capacitor c=0.0590362f //x=94.815 //y=4.975
c398 ( 133 0 ) capacitor c=0.0296075f //x=95.105 //y=4.975
c399 ( 130 0 ) capacitor c=0.0157912f //x=95.02 //y=1.545
c400 ( 128 0 ) capacitor c=0.0149844f //x=95.02 //y=0.89
c401 ( 124 0 ) capacitor c=0.0302441f //x=94.645 //y=2.095
c402 ( 123 0 ) capacitor c=0.0234157f //x=94.645 //y=1.7
c403 ( 122 0 ) capacitor c=0.0234376f //x=94.645 //y=1.39
c404 ( 121 0 ) capacitor c=0.0199931f //x=94.645 //y=1.045
c405 ( 120 0 ) capacitor c=0.092271f //x=92.815 //y=2.095
c406 ( 119 0 ) capacitor c=0.0249466f //x=92.815 //y=1.74
c407 ( 118 0 ) capacitor c=0.0234397f //x=92.815 //y=1.43
c408 ( 117 0 ) capacitor c=0.0193195f //x=92.815 //y=1.085
c409 ( 114 0 ) capacitor c=0.0631944f //x=92.72 //y=5.05
c410 ( 111 0 ) capacitor c=0.0164325f //x=92.66 //y=1.585
c411 ( 109 0 ) capacitor c=0.0157803f //x=92.66 //y=0.93
c412 ( 108 0 ) capacitor c=0.010629f //x=92.355 //y=4.975
c413 ( 107 0 ) capacitor c=0.0194269f //x=92.645 //y=4.975
c414 ( 106 0 ) capacitor c=0.0353695f //x=92.285 //y=1.43
c415 ( 105 0 ) capacitor c=0.0175988f //x=92.285 //y=1.085
c416 ( 98 0 ) capacitor c=0.0556143f //x=83.645 //y=4.97
c417 ( 97 0 ) capacitor c=0.0293157f //x=83.935 //y=4.97
c418 ( 96 0 ) capacitor c=0.0347816f //x=83.6 //y=1.4
c419 ( 95 0 ) capacitor c=0.0187487f //x=83.6 //y=1.055
c420 ( 89 0 ) capacitor c=0.0137055f //x=83.445 //y=1.555
c421 ( 87 0 ) capacitor c=0.0149861f //x=83.445 //y=0.9
c422 ( 86 0 ) capacitor c=0.095966f //x=83.07 //y=2.095
c423 ( 85 0 ) capacitor c=0.0228993f //x=83.07 //y=1.71
c424 ( 84 0 ) capacitor c=0.0234352f //x=83.07 //y=1.4
c425 ( 83 0 ) capacitor c=0.0198724f //x=83.07 //y=1.055
c426 ( 82 0 ) capacitor c=0.110622f //x=95.18 //y=6.205
c427 ( 81 0 ) capacitor c=0.154068f //x=94.74 //y=6.205
c428 ( 80 0 ) capacitor c=0.154291f //x=92.72 //y=6.205
c429 ( 79 0 ) capacitor c=0.110404f //x=92.28 //y=6.205
c430 ( 78 0 ) capacitor c=0.110114f //x=84.01 //y=6.2
c431 ( 77 0 ) capacitor c=0.158956f //x=83.57 //y=6.2
c432 ( 73 0 ) capacitor c=0.00106608f //x=80.74 //y=5.335
c433 ( 72 0 ) capacitor c=0.00207319f //x=79.86 //y=5.335
c434 ( 66 0 ) capacitor c=0.100793f //x=94.47 //y=2.26
c435 ( 59 0 ) capacitor c=0.107544f //x=92.99 //y=2.26
c436 ( 51 0 ) capacitor c=0.0970431f //x=83.37 //y=2.26
c437 ( 49 0 ) capacitor c=0.107181f //x=81.52 //y=2.4
c438 ( 45 0 ) capacitor c=0.00431225f //x=81.12 //y=1.845
c439 ( 44 0 ) capacitor c=0.0141892f //x=81.435 //y=1.845
c440 ( 38 0 ) capacitor c=0.0283082f //x=81.435 //y=5.335
c441 ( 30 0 ) capacitor c=0.0176454f //x=80.655 //y=5.335
c442 ( 23 0 ) capacitor c=0.00332903f //x=79.065 //y=5.335
c443 ( 22 0 ) capacitor c=0.0148427f //x=79.775 //y=5.335
c444 ( 12 0 ) capacitor c=0.0148272f //x=92.99 //y=2.26
c445 ( 5 0 ) capacitor c=0.0465668f //x=94.355 //y=2.26
c446 ( 4 0 ) capacitor c=0.00560639f //x=83.485 //y=2.4
c447 ( 3 0 ) capacitor c=0.244868f //x=92.845 //y=2.4
c448 ( 2 0 ) capacitor c=0.00833032f //x=81.635 //y=2.4
c449 ( 1 0 ) capacitor c=0.0348685f //x=83.255 //y=2.4
r450 (  136 163 ) resistor r=45.1352 //w=0.168 //l=0.173853 //layer=ply \
 //thickness=0.18 //x=95.175 //y=1.39 //x2=95.135 //y2=1.545
r451 (  135 162 ) resistor r=45.1352 //w=0.168 //l=0.173853 //layer=ply \
 //thickness=0.18 //x=95.175 //y=1.045 //x2=95.135 //y2=0.89
r452 (  135 136 ) resistor r=176.904 //w=0.094 //l=0.345 //layer=ply \
 //thickness=0.18 //x=95.175 //y=1.045 //x2=95.175 //y2=1.39
r453 (  133 137 ) resistor r=26.9307 //w=0.15 //l=0.106066 //layer=ply \
 //thickness=0.18 //x=95.105 //y=4.975 //x2=95.18 //y2=5.05
r454 (  133 134 ) resistor r=148.702 //w=0.094 //l=0.29 //layer=ply \
 //thickness=0.18 //x=95.105 //y=4.975 //x2=94.815 //y2=4.975
r455 (  131 161 ) resistor r=10.701 //w=0.21 //l=0.115 //layer=ply \
 //thickness=0.18 //x=94.8 //y=1.545 //x2=94.685 //y2=1.545
r456 (  130 163 ) resistor r=5.52526 //w=0.168 //l=0.115 //layer=ply \
 //thickness=0.18 //x=95.02 //y=1.545 //x2=95.135 //y2=1.545
r457 (  129 160 ) resistor r=5.52526 //w=0.168 //l=0.115 //layer=ply \
 //thickness=0.18 //x=94.8 //y=0.89 //x2=94.685 //y2=0.89
r458 (  128 162 ) resistor r=5.52526 //w=0.168 //l=0.115 //layer=ply \
 //thickness=0.18 //x=95.02 //y=0.89 //x2=95.135 //y2=0.89
r459 (  128 129 ) resistor r=112.809 //w=0.094 //l=0.22 //layer=ply \
 //thickness=0.18 //x=95.02 //y=0.89 //x2=94.8 //y2=0.89
r460 (  125 134 ) resistor r=22.1787 //w=0.252 //l=0.106066 //layer=ply \
 //thickness=0.18 //x=94.74 //y=5.05 //x2=94.815 //y2=4.975
r461 (  125 159 ) resistor r=51.6429 //w=0.252 //l=0.34271 //layer=ply \
 //thickness=0.18 //x=94.74 //y=5.05 //x2=94.47 //y2=4.885
r462 (  124 157 ) resistor r=30.4513 //w=0.277 //l=0.243926 //layer=ply \
 //thickness=0.18 //x=94.645 //y=2.095 //x2=94.47 //y2=2.26
r463 (  123 161 ) resistor r=39.5823 //w=0.21 //l=0.173853 //layer=ply \
 //thickness=0.18 //x=94.645 //y=1.7 //x2=94.685 //y2=1.545
r464 (  123 124 ) resistor r=202.543 //w=0.094 //l=0.395 //layer=ply \
 //thickness=0.18 //x=94.645 //y=1.7 //x2=94.645 //y2=2.095
r465 (  122 161 ) resistor r=39.5823 //w=0.21 //l=0.173853 //layer=ply \
 //thickness=0.18 //x=94.645 //y=1.39 //x2=94.685 //y2=1.545
r466 (  121 160 ) resistor r=45.1352 //w=0.168 //l=0.173853 //layer=ply \
 //thickness=0.18 //x=94.645 //y=1.045 //x2=94.685 //y2=0.89
r467 (  121 122 ) resistor r=176.904 //w=0.094 //l=0.345 //layer=ply \
 //thickness=0.18 //x=94.645 //y=1.045 //x2=94.645 //y2=1.39
r468 (  120 153 ) resistor r=30.4513 //w=0.277 //l=0.243926 //layer=ply \
 //thickness=0.18 //x=92.815 //y=2.095 //x2=92.99 //y2=2.26
r469 (  119 151 ) resistor r=39.5823 //w=0.21 //l=0.173853 //layer=ply \
 //thickness=0.18 //x=92.815 //y=1.74 //x2=92.775 //y2=1.585
r470 (  119 120 ) resistor r=182.032 //w=0.094 //l=0.355 //layer=ply \
 //thickness=0.18 //x=92.815 //y=1.74 //x2=92.815 //y2=2.095
r471 (  118 151 ) resistor r=39.5823 //w=0.21 //l=0.173853 //layer=ply \
 //thickness=0.18 //x=92.815 //y=1.43 //x2=92.775 //y2=1.585
r472 (  117 150 ) resistor r=45.1352 //w=0.168 //l=0.173853 //layer=ply \
 //thickness=0.18 //x=92.815 //y=1.085 //x2=92.775 //y2=0.93
r473 (  117 118 ) resistor r=176.904 //w=0.094 //l=0.345 //layer=ply \
 //thickness=0.18 //x=92.815 //y=1.085 //x2=92.815 //y2=1.43
r474 (  114 155 ) resistor r=51.6429 //w=0.252 //l=0.34271 //layer=ply \
 //thickness=0.18 //x=92.72 //y=5.05 //x2=92.99 //y2=4.885
r475 (  112 149 ) resistor r=5.52526 //w=0.168 //l=0.115 //layer=ply \
 //thickness=0.18 //x=92.44 //y=1.585 //x2=92.325 //y2=1.585
r476 (  111 151 ) resistor r=10.701 //w=0.21 //l=0.115 //layer=ply \
 //thickness=0.18 //x=92.66 //y=1.585 //x2=92.775 //y2=1.585
r477 (  110 148 ) resistor r=5.52526 //w=0.168 //l=0.115 //layer=ply \
 //thickness=0.18 //x=92.44 //y=0.93 //x2=92.325 //y2=0.93
r478 (  109 150 ) resistor r=5.52526 //w=0.168 //l=0.115 //layer=ply \
 //thickness=0.18 //x=92.66 //y=0.93 //x2=92.775 //y2=0.93
r479 (  109 110 ) resistor r=112.809 //w=0.094 //l=0.22 //layer=ply \
 //thickness=0.18 //x=92.66 //y=0.93 //x2=92.44 //y2=0.93
r480 (  107 114 ) resistor r=22.1787 //w=0.252 //l=0.106066 //layer=ply \
 //thickness=0.18 //x=92.645 //y=4.975 //x2=92.72 //y2=5.05
r481 (  107 108 ) resistor r=148.702 //w=0.094 //l=0.29 //layer=ply \
 //thickness=0.18 //x=92.645 //y=4.975 //x2=92.355 //y2=4.975
r482 (  106 149 ) resistor r=45.1352 //w=0.168 //l=0.173853 //layer=ply \
 //thickness=0.18 //x=92.285 //y=1.43 //x2=92.325 //y2=1.585
r483 (  105 148 ) resistor r=45.1352 //w=0.168 //l=0.173853 //layer=ply \
 //thickness=0.18 //x=92.285 //y=1.085 //x2=92.325 //y2=0.93
r484 (  105 106 ) resistor r=176.904 //w=0.094 //l=0.345 //layer=ply \
 //thickness=0.18 //x=92.285 //y=1.085 //x2=92.285 //y2=1.43
r485 (  102 108 ) resistor r=26.9307 //w=0.15 //l=0.106066 //layer=ply \
 //thickness=0.18 //x=92.28 //y=5.05 //x2=92.355 //y2=4.975
r486 (  97 99 ) resistor r=26.9307 //w=0.15 //l=0.106066 //layer=ply \
 //thickness=0.18 //x=83.935 //y=4.97 //x2=84.01 //y2=5.045
r487 (  97 98 ) resistor r=148.702 //w=0.094 //l=0.29 //layer=ply \
 //thickness=0.18 //x=83.935 //y=4.97 //x2=83.645 //y2=4.97
r488 (  96 147 ) resistor r=45.1352 //w=0.168 //l=0.173853 //layer=ply \
 //thickness=0.18 //x=83.6 //y=1.4 //x2=83.56 //y2=1.555
r489 (  95 146 ) resistor r=45.1352 //w=0.168 //l=0.173853 //layer=ply \
 //thickness=0.18 //x=83.6 //y=1.055 //x2=83.56 //y2=0.9
r490 (  95 96 ) resistor r=176.904 //w=0.094 //l=0.345 //layer=ply \
 //thickness=0.18 //x=83.6 //y=1.055 //x2=83.6 //y2=1.4
r491 (  92 98 ) resistor r=22.7971 //w=0.269 //l=0.106066 //layer=ply \
 //thickness=0.18 //x=83.57 //y=5.045 //x2=83.645 //y2=4.97
r492 (  92 145 ) resistor r=35.8364 //w=0.269 //l=0.270185 //layer=ply \
 //thickness=0.18 //x=83.57 //y=5.045 //x2=83.37 //y2=4.88
r493 (  90 141 ) resistor r=10.701 //w=0.21 //l=0.115 //layer=ply \
 //thickness=0.18 //x=83.225 //y=1.555 //x2=83.11 //y2=1.555
r494 (  89 147 ) resistor r=5.52526 //w=0.168 //l=0.115 //layer=ply \
 //thickness=0.18 //x=83.445 //y=1.555 //x2=83.56 //y2=1.555
r495 (  88 140 ) resistor r=5.52526 //w=0.168 //l=0.115 //layer=ply \
 //thickness=0.18 //x=83.225 //y=0.9 //x2=83.11 //y2=0.9
r496 (  87 146 ) resistor r=5.52526 //w=0.168 //l=0.115 //layer=ply \
 //thickness=0.18 //x=83.445 //y=0.9 //x2=83.56 //y2=0.9
r497 (  87 88 ) resistor r=112.809 //w=0.094 //l=0.22 //layer=ply \
 //thickness=0.18 //x=83.445 //y=0.9 //x2=83.225 //y2=0.9
r498 (  86 143 ) resistor r=58.7805 //w=0.246 //l=0.373497 //layer=ply \
 //thickness=0.18 //x=83.07 //y=2.095 //x2=83.37 //y2=2.26
r499 (  85 141 ) resistor r=39.5823 //w=0.21 //l=0.173853 //layer=ply \
 //thickness=0.18 //x=83.07 //y=1.71 //x2=83.11 //y2=1.555
r500 (  85 86 ) resistor r=197.415 //w=0.094 //l=0.385 //layer=ply \
 //thickness=0.18 //x=83.07 //y=1.71 //x2=83.07 //y2=2.095
r501 (  84 141 ) resistor r=39.5823 //w=0.21 //l=0.173853 //layer=ply \
 //thickness=0.18 //x=83.07 //y=1.4 //x2=83.11 //y2=1.555
r502 (  83 140 ) resistor r=45.1352 //w=0.168 //l=0.173853 //layer=ply \
 //thickness=0.18 //x=83.07 //y=1.055 //x2=83.11 //y2=0.9
r503 (  83 84 ) resistor r=176.904 //w=0.094 //l=0.345 //layer=ply \
 //thickness=0.18 //x=83.07 //y=1.055 //x2=83.07 //y2=1.4
r504 (  82 137 ) resistor r=592.245 //w=0.094 //l=1.155 //layer=ply \
 //thickness=0.18 //x=95.18 //y=6.205 //x2=95.18 //y2=5.05
r505 (  81 125 ) resistor r=592.245 //w=0.094 //l=1.155 //layer=ply \
 //thickness=0.18 //x=94.74 //y=6.205 //x2=94.74 //y2=5.05
r506 (  80 114 ) resistor r=592.245 //w=0.094 //l=1.155 //layer=ply \
 //thickness=0.18 //x=92.72 //y=6.205 //x2=92.72 //y2=5.05
r507 (  79 102 ) resistor r=592.245 //w=0.094 //l=1.155 //layer=ply \
 //thickness=0.18 //x=92.28 //y=6.205 //x2=92.28 //y2=5.05
r508 (  78 99 ) resistor r=592.245 //w=0.094 //l=1.155 //layer=ply \
 //thickness=0.18 //x=84.01 //y=6.2 //x2=84.01 //y2=5.045
r509 (  77 92 ) resistor r=592.245 //w=0.094 //l=1.155 //layer=ply \
 //thickness=0.18 //x=83.57 //y=6.2 //x2=83.57 //y2=5.045
r510 (  76 130 ) resistor r=56.4043 //w=0.094 //l=0.11 //layer=ply \
 //thickness=0.18 //x=94.91 //y=1.545 //x2=95.02 //y2=1.545
r511 (  76 131 ) resistor r=56.4043 //w=0.094 //l=0.11 //layer=ply \
 //thickness=0.18 //x=94.91 //y=1.545 //x2=94.8 //y2=1.545
r512 (  75 111 ) resistor r=56.4043 //w=0.094 //l=0.11 //layer=ply \
 //thickness=0.18 //x=92.55 //y=1.585 //x2=92.66 //y2=1.585
r513 (  75 112 ) resistor r=56.4043 //w=0.094 //l=0.11 //layer=ply \
 //thickness=0.18 //x=92.55 //y=1.585 //x2=92.44 //y2=1.585
r514 (  74 89 ) resistor r=56.4043 //w=0.094 //l=0.11 //layer=ply \
 //thickness=0.18 //x=83.335 //y=1.555 //x2=83.445 //y2=1.555
r515 (  74 90 ) resistor r=56.4043 //w=0.094 //l=0.11 //layer=ply \
 //thickness=0.18 //x=83.335 //y=1.555 //x2=83.225 //y2=1.555
r516 (  70 159 ) resistor r=152 //w=0.17 //l=0.17 //layer=licon //count=1 \
 //x=94.47 //y=4.885 //x2=94.47 //y2=4.885
r517 (  66 157 ) resistor r=152 //w=0.17 //l=0.17 //layer=licon //count=1 \
 //x=94.47 //y=2.26 //x2=94.47 //y2=2.26
r518 (  66 70 ) resistor r=179.679 //w=0.187 //l=2.625 //layer=li \
 //thickness=0.1 //x=94.47 //y=2.26 //x2=94.47 //y2=4.885
r519 (  63 155 ) resistor r=152 //w=0.17 //l=0.17 //layer=licon //count=1 \
 //x=92.99 //y=4.885 //x2=92.99 //y2=4.885
r520 (  59 153 ) resistor r=152 //w=0.17 //l=0.17 //layer=licon //count=1 \
 //x=92.99 //y=2.26 //x2=92.99 //y2=2.26
r521 (  59 63 ) resistor r=179.679 //w=0.187 //l=2.625 //layer=li \
 //thickness=0.1 //x=92.99 //y=2.26 //x2=92.99 //y2=4.885
r522 (  56 145 ) resistor r=152 //w=0.17 //l=0.17 //layer=licon //count=1 \
 //x=83.37 //y=4.88 //x2=83.37 //y2=4.88
r523 (  54 56 ) resistor r=169.754 //w=0.187 //l=2.48 //layer=li \
 //thickness=0.1 //x=83.37 //y=2.4 //x2=83.37 //y2=4.88
r524 (  51 143 ) resistor r=152 //w=0.17 //l=0.17 //layer=licon //count=1 \
 //x=83.37 //y=2.26 //x2=83.37 //y2=2.26
r525 (  51 54 ) resistor r=9.58289 //w=0.187 //l=0.14 //layer=li \
 //thickness=0.1 //x=83.37 //y=2.26 //x2=83.37 //y2=2.4
r526 (  47 49 ) resistor r=195.08 //w=0.187 //l=2.85 //layer=li \
 //thickness=0.1 //x=81.52 //y=5.25 //x2=81.52 //y2=2.4
r527 (  46 49 ) resistor r=32.1711 //w=0.187 //l=0.47 //layer=li \
 //thickness=0.1 //x=81.52 //y=1.93 //x2=81.52 //y2=2.4
r528 (  44 46 ) resistor r=7.15173 //w=0.17 //l=0.120208 //layer=li \
 //thickness=0.1 //x=81.435 //y=1.845 //x2=81.52 //y2=1.93
r529 (  44 45 ) resistor r=21.5615 //w=0.187 //l=0.315 //layer=li \
 //thickness=0.1 //x=81.435 //y=1.845 //x2=81.12 //y2=1.845
r530 (  40 45 ) resistor r=7.15173 //w=0.17 //l=0.120208 //layer=li \
 //thickness=0.1 //x=81.035 //y=1.76 //x2=81.12 //y2=1.845
r531 (  40 164 ) resistor r=39.016 //w=0.187 //l=0.57 //layer=li \
 //thickness=0.1 //x=81.035 //y=1.76 //x2=81.035 //y2=1.19
r532 (  39 73 ) resistor r=5.4201 //w=0.17 //l=0.085 //layer=li \
 //thickness=0.1 //x=80.825 //y=5.335 //x2=80.74 //y2=5.335
r533 (  38 47 ) resistor r=7.15173 //w=0.17 //l=0.120208 //layer=li \
 //thickness=0.1 //x=81.435 //y=5.335 //x2=81.52 //y2=5.25
r534 (  38 39 ) resistor r=41.754 //w=0.187 //l=0.61 //layer=li \
 //thickness=0.1 //x=81.435 //y=5.335 //x2=80.825 //y2=5.335
r535 (  32 73 ) resistor r=1.40859 //w=0.34 //l=0.085 //layer=li \
 //thickness=0.1 //x=80.74 //y=5.42 //x2=80.74 //y2=5.335
r536 (  32 168 ) resistor r=33.1979 //w=0.187 //l=0.485 //layer=li \
 //thickness=0.1 //x=80.74 //y=5.42 //x2=80.74 //y2=5.905
r537 (  31 72 ) resistor r=5.4201 //w=0.17 //l=0.085 //layer=li \
 //thickness=0.1 //x=79.945 //y=5.335 //x2=79.86 //y2=5.335
r538 (  30 73 ) resistor r=5.4201 //w=0.17 //l=0.085 //layer=li \
 //thickness=0.1 //x=80.655 //y=5.335 //x2=80.74 //y2=5.335
r539 (  30 31 ) resistor r=48.5989 //w=0.187 //l=0.71 //layer=li \
 //thickness=0.1 //x=80.655 //y=5.335 //x2=79.945 //y2=5.335
r540 (  24 72 ) resistor r=1.40859 //w=0.34 //l=0.085 //layer=li \
 //thickness=0.1 //x=79.86 //y=5.42 //x2=79.86 //y2=5.335
r541 (  24 167 ) resistor r=33.1979 //w=0.187 //l=0.485 //layer=li \
 //thickness=0.1 //x=79.86 //y=5.42 //x2=79.86 //y2=5.905
r542 (  22 72 ) resistor r=5.4201 //w=0.17 //l=0.085 //layer=li \
 //thickness=0.1 //x=79.775 //y=5.335 //x2=79.86 //y2=5.335
r543 (  22 23 ) resistor r=48.5989 //w=0.187 //l=0.71 //layer=li \
 //thickness=0.1 //x=79.775 //y=5.335 //x2=79.065 //y2=5.335
r544 (  16 23 ) resistor r=7.15173 //w=0.17 //l=0.120208 //layer=li \
 //thickness=0.1 //x=78.98 //y=5.42 //x2=79.065 //y2=5.335
r545 (  16 166 ) resistor r=33.1979 //w=0.187 //l=0.485 //layer=li \
 //thickness=0.1 //x=78.98 //y=5.42 //x2=78.98 //y2=5.905
r546 (  15 66 ) resistor r=9.3 //w=0.17 //l=0.17 //layer=mcon //count=1 \
 //x=94.47 //y=2.26 //x2=94.47 //y2=2.26
r547 (  12 59 ) resistor r=9.3 //w=0.17 //l=0.17 //layer=mcon //count=1 \
 //x=92.99 //y=2.26 //x2=92.99 //y2=2.26
r548 (  12 13 ) resistor r=0.0678295 //w=0.258 //l=0.14 //layer=m1 \
 //thickness=0.36 //x=92.975 //y=2.26 //x2=92.975 //y2=2.4
r549 (  10 54 ) resistor r=9.3 //w=0.17 //l=0.17 //layer=mcon //count=1 \
 //x=83.37 //y=2.4 //x2=83.37 //y2=2.4
r550 (  8 49 ) resistor r=9.3 //w=0.17 //l=0.17 //layer=mcon //count=1 \
 //x=81.52 //y=2.4 //x2=81.52 //y2=2.4
r551 (  6 12 ) resistor r=0.032569 //w=0.258 //l=0.13 //layer=m1 \
 //thickness=0.36 //x=93.105 //y=2.26 //x2=92.975 //y2=2.26
r552 (  5 15 ) resistor r=0.0717383 //w=0.224 //l=0.115 //layer=m1 \
 //thickness=0.36 //x=94.355 //y=2.26 //x2=94.47 //y2=2.26
r553 (  5 6 ) resistor r=1.19275 //w=0.131 //l=1.25 //layer=m1 \
 //thickness=0.36 //x=94.355 //y=2.26 //x2=93.105 //y2=2.26
r554 (  4 10 ) resistor r=0.0880901 //w=0.191 //l=0.115 //layer=m1 \
 //thickness=0.36 //x=83.485 //y=2.4 //x2=83.37 //y2=2.4
r555 (  3 13 ) resistor r=0.032569 //w=0.258 //l=0.13 //layer=m1 \
 //thickness=0.36 //x=92.845 //y=2.4 //x2=92.975 //y2=2.4
r556 (  3 4 ) resistor r=8.9313 //w=0.131 //l=9.36 //layer=m1 //thickness=0.36 \
 //x=92.845 //y=2.4 //x2=83.485 //y2=2.4
r557 (  2 8 ) resistor r=0.0717383 //w=0.224 //l=0.115 //layer=m1 \
 //thickness=0.36 //x=81.635 //y=2.4 //x2=81.52 //y2=2.4
r558 (  1 10 ) resistor r=0.0880901 //w=0.191 //l=0.115 //layer=m1 \
 //thickness=0.36 //x=83.255 //y=2.4 //x2=83.37 //y2=2.4
r559 (  1 2 ) resistor r=1.5458 //w=0.131 //l=1.62 //layer=m1 //thickness=0.36 \
 //x=83.255 //y=2.4 //x2=81.635 //y2=2.4
ends PM_TMRDFFSNRNQNX1\%noxref_24

subckt PM_TMRDFFSNRNQNX1\%noxref_25 ( 1 2 13 14 15 21 27 28 35 46 47 48 49 50 )
c89 ( 50 0 ) capacitor c=0.0306574f //x=96.135 //y=5.205
c90 ( 49 0 ) capacitor c=0.0173945f //x=95.255 //y=5.205
c91 ( 47 0 ) capacitor c=0.0169278f //x=92.355 //y=5.205
c92 ( 46 0 ) capacitor c=0.0166762f //x=91.475 //y=5.205
c93 ( 45 0 ) capacitor c=0.00115294f //x=95.4 //y=7.09
c94 ( 35 0 ) capacitor c=0.0132983f //x=96.195 //y=7.09
c95 ( 28 0 ) capacitor c=0.00388794f //x=94.605 //y=7.09
c96 ( 27 0 ) capacitor c=0.00985708f //x=95.315 //y=7.09
c97 ( 21 0 ) capacitor c=0.0442221f //x=94.52 //y=5.39
c98 ( 15 0 ) capacitor c=0.0105083f //x=92.5 //y=5.475
c99 ( 14 0 ) capacitor c=0.00227812f //x=91.705 //y=5.39
c100 ( 13 0 ) capacitor c=0.0174384f //x=92.415 //y=5.39
c101 ( 2 0 ) capacitor c=0.00682032f //x=92.615 //y=5.39
c102 ( 1 0 ) capacitor c=0.0574911f //x=94.405 //y=5.39
r103 (  37 50 ) resistor r=5.81818 //w=0.187 //l=0.085 //layer=li \
 //thickness=0.1 //x=96.28 //y=7.005 //x2=96.28 //y2=6.92
r104 (  36 45 ) resistor r=5.4201 //w=0.17 //l=0.085 //layer=li \
 //thickness=0.1 //x=95.485 //y=7.09 //x2=95.4 //y2=7.09
r105 (  35 37 ) resistor r=7.15173 //w=0.17 //l=0.120208 //layer=li \
 //thickness=0.1 //x=96.195 //y=7.09 //x2=96.28 //y2=7.005
r106 (  35 36 ) resistor r=48.5989 //w=0.187 //l=0.71 //layer=li \
 //thickness=0.1 //x=96.195 //y=7.09 //x2=95.485 //y2=7.09
r107 (  29 45 ) resistor r=1.40859 //w=0.34 //l=0.085 //layer=li \
 //thickness=0.1 //x=95.4 //y=7.005 //x2=95.4 //y2=7.09
r108 (  29 49 ) resistor r=5.81818 //w=0.187 //l=0.085 //layer=li \
 //thickness=0.1 //x=95.4 //y=7.005 //x2=95.4 //y2=6.92
r109 (  27 45 ) resistor r=5.4201 //w=0.17 //l=0.085 //layer=li \
 //thickness=0.1 //x=95.315 //y=7.09 //x2=95.4 //y2=7.09
r110 (  27 28 ) resistor r=48.5989 //w=0.187 //l=0.71 //layer=li \
 //thickness=0.1 //x=95.315 //y=7.09 //x2=94.605 //y2=7.09
r111 (  21 48 ) resistor r=58.1818 //w=0.187 //l=0.85 //layer=li \
 //thickness=0.1 //x=94.52 //y=5.39 //x2=94.52 //y2=6.24
r112 (  19 28 ) resistor r=7.15173 //w=0.17 //l=0.120208 //layer=li \
 //thickness=0.1 //x=94.52 //y=7.005 //x2=94.605 //y2=7.09
r113 (  19 48 ) resistor r=5.81818 //w=0.187 //l=0.085 //layer=li \
 //thickness=0.1 //x=94.52 //y=7.005 //x2=94.52 //y2=6.92
r114 (  15 44 ) resistor r=3.57586 //w=0.17 //l=0.125 //layer=li \
 //thickness=0.1 //x=92.5 //y=5.475 //x2=92.5 //y2=5.35
r115 (  15 47 ) resistor r=52.3636 //w=0.187 //l=0.765 //layer=li \
 //thickness=0.1 //x=92.5 //y=5.475 //x2=92.5 //y2=6.24
r116 (  13 44 ) resistor r=3.57586 //w=0.17 //l=0.103078 //layer=li \
 //thickness=0.1 //x=92.415 //y=5.39 //x2=92.5 //y2=5.35
r117 (  13 14 ) resistor r=48.5989 //w=0.187 //l=0.71 //layer=li \
 //thickness=0.1 //x=92.415 //y=5.39 //x2=91.705 //y2=5.39
r118 (  7 14 ) resistor r=7.15173 //w=0.17 //l=0.120208 //layer=li \
 //thickness=0.1 //x=91.62 //y=5.475 //x2=91.705 //y2=5.39
r119 (  7 46 ) resistor r=29.0909 //w=0.187 //l=0.425 //layer=li \
 //thickness=0.1 //x=91.62 //y=5.475 //x2=91.62 //y2=5.9
r120 (  6 21 ) resistor r=9.3 //w=0.17 //l=0.17 //layer=mcon //count=1 \
 //x=94.52 //y=5.39 //x2=94.52 //y2=5.39
r121 (  4 44 ) resistor r=9.3 //w=0.17 //l=0.17 //layer=mcon //count=1 \
 //x=92.5 //y=5.39 //x2=92.5 //y2=5.39
r122 (  2 4 ) resistor r=0.0717383 //w=0.224 //l=0.115 //layer=m1 \
 //thickness=0.36 //x=92.615 //y=5.39 //x2=92.5 //y2=5.39
r123 (  1 6 ) resistor r=0.0717383 //w=0.224 //l=0.115 //layer=m1 \
 //thickness=0.36 //x=94.405 //y=5.39 //x2=94.52 //y2=5.39
r124 (  1 2 ) resistor r=1.70802 //w=0.131 //l=1.79 //layer=m1 \
 //thickness=0.36 //x=94.405 //y=5.39 //x2=92.615 //y2=5.39
ends PM_TMRDFFSNRNQNX1\%noxref_25

subckt PM_TMRDFFSNRNQNX1\%noxref_26 ( 1 2 3 4 6 7 8 10 11 12 13 14 29 30 37 45 \
 51 52 56 58 65 67 73 77 78 82 85 86 87 88 89 90 91 92 93 94 95 96 97 98 100 \
 106 107 108 109 113 114 115 120 122 124 130 131 132 133 134 139 141 143 149 \
 150 160 161 164 172 173 176 184 186 187 188 )
c455 ( 188 0 ) capacitor c=0.023087f //x=51.735 //y=5.2
c456 ( 187 0 ) capacitor c=0.023519f //x=50.855 //y=5.2
c457 ( 186 0 ) capacitor c=0.0224735f //x=49.975 //y=5.2
c458 ( 184 0 ) capacitor c=0.00853354f //x=51.985 //y=1.095
c459 ( 176 0 ) capacitor c=0.0352016f //x=95.6 //y=4.885
c460 ( 173 0 ) capacitor c=0.0279733f //x=95.58 //y=2.095
c461 ( 172 0 ) capacitor c=0.0467621f //x=95.58 //y=2.26
c462 ( 164 0 ) capacitor c=0.03845f //x=88.96 //y=4.885
c463 ( 161 0 ) capacitor c=0.0300885f //x=88.92 //y=2.095
c464 ( 160 0 ) capacitor c=0.0504818f //x=88.92 //y=2.26
c465 ( 150 0 ) capacitor c=0.0237734f //x=96.145 //y=1.435
c466 ( 149 0 ) capacitor c=0.0191782f //x=96.145 //y=1.085
c467 ( 143 0 ) capacitor c=0.0351663f //x=95.99 //y=1.585
c468 ( 141 0 ) capacitor c=0.0157803f //x=95.99 //y=0.93
c469 ( 139 0 ) capacitor c=0.0373879f //x=95.985 //y=4.975
c470 ( 134 0 ) capacitor c=0.0200628f //x=95.615 //y=1.74
c471 ( 133 0 ) capacitor c=0.0168575f //x=95.615 //y=1.435
c472 ( 132 0 ) capacitor c=0.0174993f //x=95.615 //y=1.085
c473 ( 131 0 ) capacitor c=0.0435065f //x=89.485 //y=1.43
c474 ( 130 0 ) capacitor c=0.019286f //x=89.485 //y=1.085
c475 ( 124 0 ) capacitor c=0.0164316f //x=89.33 //y=1.585
c476 ( 122 0 ) capacitor c=0.0157795f //x=89.33 //y=0.93
c477 ( 120 0 ) capacitor c=0.029531f //x=89.325 //y=4.975
c478 ( 115 0 ) capacitor c=0.0206178f //x=88.955 //y=1.74
c479 ( 114 0 ) capacitor c=0.016848f //x=88.955 //y=1.43
c480 ( 113 0 ) capacitor c=0.0174777f //x=88.955 //y=1.085
c481 ( 109 0 ) capacitor c=0.0547611f //x=54.785 //y=4.97
c482 ( 108 0 ) capacitor c=0.0294456f //x=55.075 //y=4.97
c483 ( 107 0 ) capacitor c=0.0347816f //x=54.74 //y=1.4
c484 ( 106 0 ) capacitor c=0.0187487f //x=54.74 //y=1.055
c485 ( 100 0 ) capacitor c=0.0137055f //x=54.585 //y=1.555
c486 ( 98 0 ) capacitor c=0.0149861f //x=54.585 //y=0.9
c487 ( 97 0 ) capacitor c=0.096037f //x=54.21 //y=2.095
c488 ( 96 0 ) capacitor c=0.0228993f //x=54.21 //y=1.71
c489 ( 95 0 ) capacitor c=0.0234352f //x=54.21 //y=1.4
c490 ( 94 0 ) capacitor c=0.0198724f //x=54.21 //y=1.055
c491 ( 93 0 ) capacitor c=0.15325f //x=96.06 //y=6.205
c492 ( 92 0 ) capacitor c=0.110411f //x=95.62 //y=6.205
c493 ( 91 0 ) capacitor c=0.154236f //x=89.4 //y=6.205
c494 ( 90 0 ) capacitor c=0.110294f //x=88.96 //y=6.205
c495 ( 89 0 ) capacitor c=0.109949f //x=55.15 //y=6.2
c496 ( 88 0 ) capacitor c=0.158483f //x=54.71 //y=6.2
c497 ( 82 0 ) capacitor c=0.00501304f //x=95.6 //y=4.885
c498 ( 78 0 ) capacitor c=9.74268e-19 //x=51.88 //y=5.335
c499 ( 77 0 ) capacitor c=0.00191414f //x=51 //y=5.335
c500 ( 73 0 ) capacitor c=0.0903046f //x=95.58 //y=2.26
c501 ( 67 0 ) capacitor c=0.11005f //x=88.92 //y=2.26
c502 ( 65 0 ) capacitor c=0.00669947f //x=88.92 //y=4.72
c503 ( 58 0 ) capacitor c=0.0907522f //x=54.51 //y=2.26
c504 ( 56 0 ) capacitor c=0.103749f //x=52.66 //y=3.51
c505 ( 52 0 ) capacitor c=0.00398962f //x=52.26 //y=1.845
c506 ( 51 0 ) capacitor c=0.0137288f //x=52.575 //y=1.845
c507 ( 45 0 ) capacitor c=0.0276208f //x=52.575 //y=5.335
c508 ( 37 0 ) capacitor c=0.0169868f //x=51.795 //y=5.335
c509 ( 30 0 ) capacitor c=0.00316998f //x=50.205 //y=5.335
c510 ( 29 0 ) capacitor c=0.014258f //x=50.915 //y=5.335
c511 ( 14 0 ) capacitor c=0.00672327f //x=89.035 //y=4.25
c512 ( 13 0 ) capacitor c=0.212984f //x=95.465 //y=4.25
c513 ( 12 0 ) capacitor c=0.004561f //x=65.695 //y=4.25
c514 ( 11 0 ) capacitor c=0.345736f //x=88.805 //y=4.25
c515 ( 10 0 ) capacitor c=0.00784097f //x=65.61 //y=4.165
c516 ( 8 0 ) capacitor c=1.67157e-19 //x=57.555 //y=3.88
c517 ( 7 0 ) capacitor c=0.146519f //x=65.525 //y=3.88
c518 ( 6 0 ) capacitor c=0.0049602f //x=57.47 //y=3.795
c519 ( 4 0 ) capacitor c=0.00349717f //x=54.625 //y=3.51
c520 ( 3 0 ) capacitor c=0.0428789f //x=57.385 //y=3.51
c521 ( 2 0 ) capacitor c=0.00852385f //x=52.775 //y=3.51
c522 ( 1 0 ) capacitor c=0.0280751f //x=54.395 //y=3.51
r523 (  178 179 ) resistor r=32.4568 //w=0.214 //l=0.075 //layer=ply \
 //thickness=0.18 //x=95.6 //y=4.975 //x2=95.6 //y2=5.05
r524 (  176 178 ) resistor r=20.271 //w=0.214 //l=0.09 //layer=ply \
 //thickness=0.18 //x=95.6 //y=4.885 //x2=95.6 //y2=4.975
r525 (  172 173 ) resistor r=52.7279 //w=0.214 //l=0.165 //layer=ply \
 //thickness=0.18 //x=95.58 //y=2.26 //x2=95.58 //y2=2.095
r526 (  164 166 ) resistor r=20.271 //w=0.214 //l=0.09 //layer=ply \
 //thickness=0.18 //x=88.96 //y=4.885 //x2=88.96 //y2=4.975
r527 (  160 161 ) resistor r=52.7279 //w=0.214 //l=0.165 //layer=ply \
 //thickness=0.18 //x=88.92 //y=2.26 //x2=88.92 //y2=2.095
r528 (  150 183 ) resistor r=4.95774 //w=0.164 //l=0.112 //layer=ply \
 //thickness=0.18 //x=96.145 //y=1.435 //x2=96.145 //y2=1.547
r529 (  149 182 ) resistor r=45.1352 //w=0.168 //l=0.173853 //layer=ply \
 //thickness=0.18 //x=96.145 //y=1.085 //x2=96.105 //y2=0.93
r530 (  149 150 ) resistor r=179.468 //w=0.094 //l=0.35 //layer=ply \
 //thickness=0.18 //x=96.145 //y=1.085 //x2=96.145 //y2=1.435
r531 (  144 181 ) resistor r=10.8103 //w=0.211 //l=0.115 //layer=ply \
 //thickness=0.18 //x=95.77 //y=1.585 //x2=95.655 //y2=1.585
r532 (  143 183 ) resistor r=45.9962 //w=0.164 //l=0.17296 //layer=ply \
 //thickness=0.18 //x=95.99 //y=1.585 //x2=96.145 //y2=1.547
r533 (  142 180 ) resistor r=5.52526 //w=0.168 //l=0.115 //layer=ply \
 //thickness=0.18 //x=95.77 //y=0.93 //x2=95.655 //y2=0.93
r534 (  141 182 ) resistor r=5.52526 //w=0.168 //l=0.115 //layer=ply \
 //thickness=0.18 //x=95.99 //y=0.93 //x2=96.105 //y2=0.93
r535 (  141 142 ) resistor r=112.809 //w=0.094 //l=0.22 //layer=ply \
 //thickness=0.18 //x=95.99 //y=0.93 //x2=95.77 //y2=0.93
r536 (  140 178 ) resistor r=16.5046 //w=0.27 //l=0.135 //layer=ply \
 //thickness=0.18 //x=95.735 //y=4.975 //x2=95.6 //y2=4.975
r537 (  139 146 ) resistor r=26.9307 //w=0.15 //l=0.106066 //layer=ply \
 //thickness=0.18 //x=95.985 //y=4.975 //x2=96.06 //y2=5.05
r538 (  139 140 ) resistor r=128.191 //w=0.094 //l=0.25 //layer=ply \
 //thickness=0.18 //x=95.985 //y=4.975 //x2=95.735 //y2=4.975
r539 (  134 181 ) resistor r=39.5036 //w=0.211 //l=0.173853 //layer=ply \
 //thickness=0.18 //x=95.615 //y=1.74 //x2=95.655 //y2=1.585
r540 (  134 173 ) resistor r=182.032 //w=0.094 //l=0.355 //layer=ply \
 //thickness=0.18 //x=95.615 //y=1.74 //x2=95.615 //y2=2.095
r541 (  133 181 ) resistor r=38.3614 //w=0.211 //l=0.168819 //layer=ply \
 //thickness=0.18 //x=95.615 //y=1.435 //x2=95.655 //y2=1.585
r542 (  132 180 ) resistor r=45.1352 //w=0.168 //l=0.173853 //layer=ply \
 //thickness=0.18 //x=95.615 //y=1.085 //x2=95.655 //y2=0.93
r543 (  132 133 ) resistor r=179.468 //w=0.094 //l=0.35 //layer=ply \
 //thickness=0.18 //x=95.615 //y=1.085 //x2=95.615 //y2=1.435
r544 (  131 170 ) resistor r=45.1352 //w=0.168 //l=0.173853 //layer=ply \
 //thickness=0.18 //x=89.485 //y=1.43 //x2=89.445 //y2=1.585
r545 (  130 169 ) resistor r=45.1352 //w=0.168 //l=0.173853 //layer=ply \
 //thickness=0.18 //x=89.485 //y=1.085 //x2=89.445 //y2=0.93
r546 (  130 131 ) resistor r=176.904 //w=0.094 //l=0.345 //layer=ply \
 //thickness=0.18 //x=89.485 //y=1.085 //x2=89.485 //y2=1.43
r547 (  125 168 ) resistor r=10.701 //w=0.21 //l=0.115 //layer=ply \
 //thickness=0.18 //x=89.11 //y=1.585 //x2=88.995 //y2=1.585
r548 (  124 170 ) resistor r=5.52526 //w=0.168 //l=0.115 //layer=ply \
 //thickness=0.18 //x=89.33 //y=1.585 //x2=89.445 //y2=1.585
r549 (  123 167 ) resistor r=5.52526 //w=0.168 //l=0.115 //layer=ply \
 //thickness=0.18 //x=89.11 //y=0.93 //x2=88.995 //y2=0.93
r550 (  122 169 ) resistor r=5.52526 //w=0.168 //l=0.115 //layer=ply \
 //thickness=0.18 //x=89.33 //y=0.93 //x2=89.445 //y2=0.93
r551 (  122 123 ) resistor r=112.809 //w=0.094 //l=0.22 //layer=ply \
 //thickness=0.18 //x=89.33 //y=0.93 //x2=89.11 //y2=0.93
r552 (  121 166 ) resistor r=16.5046 //w=0.27 //l=0.135 //layer=ply \
 //thickness=0.18 //x=89.095 //y=4.975 //x2=88.96 //y2=4.975
r553 (  120 127 ) resistor r=26.9307 //w=0.15 //l=0.106066 //layer=ply \
 //thickness=0.18 //x=89.325 //y=4.975 //x2=89.4 //y2=5.05
r554 (  120 121 ) resistor r=117.936 //w=0.094 //l=0.23 //layer=ply \
 //thickness=0.18 //x=89.325 //y=4.975 //x2=89.095 //y2=4.975
r555 (  117 166 ) resistor r=32.4568 //w=0.214 //l=0.075 //layer=ply \
 //thickness=0.18 //x=88.96 //y=5.05 //x2=88.96 //y2=4.975
r556 (  115 168 ) resistor r=39.5823 //w=0.21 //l=0.173853 //layer=ply \
 //thickness=0.18 //x=88.955 //y=1.74 //x2=88.995 //y2=1.585
r557 (  115 161 ) resistor r=182.032 //w=0.094 //l=0.355 //layer=ply \
 //thickness=0.18 //x=88.955 //y=1.74 //x2=88.955 //y2=2.095
r558 (  114 168 ) resistor r=39.5823 //w=0.21 //l=0.173853 //layer=ply \
 //thickness=0.18 //x=88.955 //y=1.43 //x2=88.995 //y2=1.585
r559 (  113 167 ) resistor r=45.1352 //w=0.168 //l=0.173853 //layer=ply \
 //thickness=0.18 //x=88.955 //y=1.085 //x2=88.995 //y2=0.93
r560 (  113 114 ) resistor r=176.904 //w=0.094 //l=0.345 //layer=ply \
 //thickness=0.18 //x=88.955 //y=1.085 //x2=88.955 //y2=1.43
r561 (  108 110 ) resistor r=26.9307 //w=0.15 //l=0.106066 //layer=ply \
 //thickness=0.18 //x=55.075 //y=4.97 //x2=55.15 //y2=5.045
r562 (  108 109 ) resistor r=148.702 //w=0.094 //l=0.29 //layer=ply \
 //thickness=0.18 //x=55.075 //y=4.97 //x2=54.785 //y2=4.97
r563 (  107 158 ) resistor r=45.1352 //w=0.168 //l=0.173853 //layer=ply \
 //thickness=0.18 //x=54.74 //y=1.4 //x2=54.7 //y2=1.555
r564 (  106 157 ) resistor r=45.1352 //w=0.168 //l=0.173853 //layer=ply \
 //thickness=0.18 //x=54.74 //y=1.055 //x2=54.7 //y2=0.9
r565 (  106 107 ) resistor r=176.904 //w=0.094 //l=0.345 //layer=ply \
 //thickness=0.18 //x=54.74 //y=1.055 //x2=54.74 //y2=1.4
r566 (  103 109 ) resistor r=22.7971 //w=0.269 //l=0.106066 //layer=ply \
 //thickness=0.18 //x=54.71 //y=5.045 //x2=54.785 //y2=4.97
r567 (  103 156 ) resistor r=35.8364 //w=0.269 //l=0.270185 //layer=ply \
 //thickness=0.18 //x=54.71 //y=5.045 //x2=54.51 //y2=4.88
r568 (  101 152 ) resistor r=10.701 //w=0.21 //l=0.115 //layer=ply \
 //thickness=0.18 //x=54.365 //y=1.555 //x2=54.25 //y2=1.555
r569 (  100 158 ) resistor r=5.52526 //w=0.168 //l=0.115 //layer=ply \
 //thickness=0.18 //x=54.585 //y=1.555 //x2=54.7 //y2=1.555
r570 (  99 151 ) resistor r=5.52526 //w=0.168 //l=0.115 //layer=ply \
 //thickness=0.18 //x=54.365 //y=0.9 //x2=54.25 //y2=0.9
r571 (  98 157 ) resistor r=5.52526 //w=0.168 //l=0.115 //layer=ply \
 //thickness=0.18 //x=54.585 //y=0.9 //x2=54.7 //y2=0.9
r572 (  98 99 ) resistor r=112.809 //w=0.094 //l=0.22 //layer=ply \
 //thickness=0.18 //x=54.585 //y=0.9 //x2=54.365 //y2=0.9
r573 (  97 154 ) resistor r=58.7805 //w=0.246 //l=0.373497 //layer=ply \
 //thickness=0.18 //x=54.21 //y=2.095 //x2=54.51 //y2=2.26
r574 (  96 152 ) resistor r=39.5823 //w=0.21 //l=0.173853 //layer=ply \
 //thickness=0.18 //x=54.21 //y=1.71 //x2=54.25 //y2=1.555
r575 (  96 97 ) resistor r=197.415 //w=0.094 //l=0.385 //layer=ply \
 //thickness=0.18 //x=54.21 //y=1.71 //x2=54.21 //y2=2.095
r576 (  95 152 ) resistor r=39.5823 //w=0.21 //l=0.173853 //layer=ply \
 //thickness=0.18 //x=54.21 //y=1.4 //x2=54.25 //y2=1.555
r577 (  94 151 ) resistor r=45.1352 //w=0.168 //l=0.173853 //layer=ply \
 //thickness=0.18 //x=54.21 //y=1.055 //x2=54.25 //y2=0.9
r578 (  94 95 ) resistor r=176.904 //w=0.094 //l=0.345 //layer=ply \
 //thickness=0.18 //x=54.21 //y=1.055 //x2=54.21 //y2=1.4
r579 (  93 146 ) resistor r=592.245 //w=0.094 //l=1.155 //layer=ply \
 //thickness=0.18 //x=96.06 //y=6.205 //x2=96.06 //y2=5.05
r580 (  92 179 ) resistor r=592.245 //w=0.094 //l=1.155 //layer=ply \
 //thickness=0.18 //x=95.62 //y=6.205 //x2=95.62 //y2=5.05
r581 (  91 127 ) resistor r=592.245 //w=0.094 //l=1.155 //layer=ply \
 //thickness=0.18 //x=89.4 //y=6.205 //x2=89.4 //y2=5.05
r582 (  90 117 ) resistor r=592.245 //w=0.094 //l=1.155 //layer=ply \
 //thickness=0.18 //x=88.96 //y=6.205 //x2=88.96 //y2=5.05
r583 (  89 110 ) resistor r=592.245 //w=0.094 //l=1.155 //layer=ply \
 //thickness=0.18 //x=55.15 //y=6.2 //x2=55.15 //y2=5.045
r584 (  88 103 ) resistor r=592.245 //w=0.094 //l=1.155 //layer=ply \
 //thickness=0.18 //x=54.71 //y=6.2 //x2=54.71 //y2=5.045
r585 (  87 143 ) resistor r=56.4043 //w=0.094 //l=0.11 //layer=ply \
 //thickness=0.18 //x=95.88 //y=1.585 //x2=95.99 //y2=1.585
r586 (  87 144 ) resistor r=56.4043 //w=0.094 //l=0.11 //layer=ply \
 //thickness=0.18 //x=95.88 //y=1.585 //x2=95.77 //y2=1.585
r587 (  86 124 ) resistor r=56.4043 //w=0.094 //l=0.11 //layer=ply \
 //thickness=0.18 //x=89.22 //y=1.585 //x2=89.33 //y2=1.585
r588 (  86 125 ) resistor r=56.4043 //w=0.094 //l=0.11 //layer=ply \
 //thickness=0.18 //x=89.22 //y=1.585 //x2=89.11 //y2=1.585
r589 (  85 100 ) resistor r=56.4043 //w=0.094 //l=0.11 //layer=ply \
 //thickness=0.18 //x=54.475 //y=1.555 //x2=54.585 //y2=1.555
r590 (  85 101 ) resistor r=56.4043 //w=0.094 //l=0.11 //layer=ply \
 //thickness=0.18 //x=54.475 //y=1.555 //x2=54.365 //y2=1.555
r591 (  82 176 ) resistor r=152 //w=0.17 //l=0.17 //layer=licon //count=1 \
 //x=95.6 //y=4.885 //x2=95.6 //y2=4.885
r592 (  82 83 ) resistor r=10.3507 //w=0.207 //l=0.165 //layer=li \
 //thickness=0.1 //x=95.59 //y=4.885 //x2=95.59 //y2=4.72
r593 (  80 164 ) resistor r=152 //w=0.17 //l=0.17 //layer=licon //count=1 \
 //x=88.96 //y=4.885 //x2=88.96 //y2=4.885
r594 (  76 83 ) resistor r=32.1711 //w=0.187 //l=0.47 //layer=li \
 //thickness=0.1 //x=95.58 //y=4.25 //x2=95.58 //y2=4.72
r595 (  73 172 ) resistor r=152 //w=0.17 //l=0.17 //layer=licon //count=1 \
 //x=95.58 //y=2.26 //x2=95.58 //y2=2.26
r596 (  73 76 ) resistor r=136.214 //w=0.187 //l=1.99 //layer=li \
 //thickness=0.1 //x=95.58 //y=2.26 //x2=95.58 //y2=4.25
r597 (  67 160 ) resistor r=152 //w=0.17 //l=0.17 //layer=licon //count=1 \
 //x=88.92 //y=2.26 //x2=88.92 //y2=2.26
r598 (  67 70 ) resistor r=136.214 //w=0.187 //l=1.99 //layer=li \
 //thickness=0.1 //x=88.92 //y=2.26 //x2=88.92 //y2=4.25
r599 (  65 80 ) resistor r=11.2426 //w=0.191 //l=0.174714 //layer=li \
 //thickness=0.1 //x=88.92 //y=4.72 //x2=88.94 //y2=4.885
r600 (  65 70 ) resistor r=32.1711 //w=0.187 //l=0.47 //layer=li \
 //thickness=0.1 //x=88.92 //y=4.72 //x2=88.92 //y2=4.25
r601 (  63 156 ) resistor r=152 //w=0.17 //l=0.17 //layer=licon //count=1 \
 //x=54.51 //y=4.88 //x2=54.51 //y2=4.88
r602 (  61 63 ) resistor r=93.7754 //w=0.187 //l=1.37 //layer=li \
 //thickness=0.1 //x=54.51 //y=3.51 //x2=54.51 //y2=4.88
r603 (  58 154 ) resistor r=152 //w=0.17 //l=0.17 //layer=licon //count=1 \
 //x=54.51 //y=2.26 //x2=54.51 //y2=2.26
r604 (  58 61 ) resistor r=85.5615 //w=0.187 //l=1.25 //layer=li \
 //thickness=0.1 //x=54.51 //y=2.26 //x2=54.51 //y2=3.51
r605 (  54 56 ) resistor r=119.102 //w=0.187 //l=1.74 //layer=li \
 //thickness=0.1 //x=52.66 //y=5.25 //x2=52.66 //y2=3.51
r606 (  53 56 ) resistor r=108.15 //w=0.187 //l=1.58 //layer=li \
 //thickness=0.1 //x=52.66 //y=1.93 //x2=52.66 //y2=3.51
r607 (  51 53 ) resistor r=7.15173 //w=0.17 //l=0.120208 //layer=li \
 //thickness=0.1 //x=52.575 //y=1.845 //x2=52.66 //y2=1.93
r608 (  51 52 ) resistor r=21.5615 //w=0.187 //l=0.315 //layer=li \
 //thickness=0.1 //x=52.575 //y=1.845 //x2=52.26 //y2=1.845
r609 (  47 52 ) resistor r=7.15173 //w=0.17 //l=0.120208 //layer=li \
 //thickness=0.1 //x=52.175 //y=1.76 //x2=52.26 //y2=1.845
r610 (  47 184 ) resistor r=39.016 //w=0.187 //l=0.57 //layer=li \
 //thickness=0.1 //x=52.175 //y=1.76 //x2=52.175 //y2=1.19
r611 (  46 78 ) resistor r=5.4201 //w=0.17 //l=0.085 //layer=li \
 //thickness=0.1 //x=51.965 //y=5.335 //x2=51.88 //y2=5.335
r612 (  45 54 ) resistor r=7.15173 //w=0.17 //l=0.120208 //layer=li \
 //thickness=0.1 //x=52.575 //y=5.335 //x2=52.66 //y2=5.25
r613 (  45 46 ) resistor r=41.754 //w=0.187 //l=0.61 //layer=li \
 //thickness=0.1 //x=52.575 //y=5.335 //x2=51.965 //y2=5.335
r614 (  39 78 ) resistor r=1.40859 //w=0.34 //l=0.085 //layer=li \
 //thickness=0.1 //x=51.88 //y=5.42 //x2=51.88 //y2=5.335
r615 (  39 188 ) resistor r=33.1979 //w=0.187 //l=0.485 //layer=li \
 //thickness=0.1 //x=51.88 //y=5.42 //x2=51.88 //y2=5.905
r616 (  38 77 ) resistor r=5.4201 //w=0.17 //l=0.085 //layer=li \
 //thickness=0.1 //x=51.085 //y=5.335 //x2=51 //y2=5.335
r617 (  37 78 ) resistor r=5.4201 //w=0.17 //l=0.085 //layer=li \
 //thickness=0.1 //x=51.795 //y=5.335 //x2=51.88 //y2=5.335
r618 (  37 38 ) resistor r=48.5989 //w=0.187 //l=0.71 //layer=li \
 //thickness=0.1 //x=51.795 //y=5.335 //x2=51.085 //y2=5.335
r619 (  31 77 ) resistor r=1.40859 //w=0.34 //l=0.085 //layer=li \
 //thickness=0.1 //x=51 //y=5.42 //x2=51 //y2=5.335
r620 (  31 187 ) resistor r=33.1979 //w=0.187 //l=0.485 //layer=li \
 //thickness=0.1 //x=51 //y=5.42 //x2=51 //y2=5.905
r621 (  29 77 ) resistor r=5.4201 //w=0.17 //l=0.085 //layer=li \
 //thickness=0.1 //x=50.915 //y=5.335 //x2=51 //y2=5.335
r622 (  29 30 ) resistor r=48.5989 //w=0.187 //l=0.71 //layer=li \
 //thickness=0.1 //x=50.915 //y=5.335 //x2=50.205 //y2=5.335
r623 (  23 30 ) resistor r=7.15173 //w=0.17 //l=0.120208 //layer=li \
 //thickness=0.1 //x=50.12 //y=5.42 //x2=50.205 //y2=5.335
r624 (  23 186 ) resistor r=33.1979 //w=0.187 //l=0.485 //layer=li \
 //thickness=0.1 //x=50.12 //y=5.42 //x2=50.12 //y2=5.905
r625 (  22 76 ) resistor r=9.3 //w=0.17 //l=0.17 //layer=mcon //count=1 \
 //x=95.58 //y=4.25 //x2=95.58 //y2=4.25
r626 (  20 70 ) resistor r=9.3 //w=0.17 //l=0.17 //layer=mcon //count=1 \
 //x=88.92 //y=4.25 //x2=88.92 //y2=4.25
r627 (  18 61 ) resistor r=9.3 //w=0.17 //l=0.17 //layer=mcon //count=1 \
 //x=54.51 //y=3.51 //x2=54.51 //y2=3.51
r628 (  16 56 ) resistor r=9.3 //w=0.17 //l=0.17 //layer=mcon //count=1 \
 //x=52.66 //y=3.51 //x2=52.66 //y2=3.51
r629 (  14 20 ) resistor r=0.0880901 //w=0.191 //l=0.115 //layer=m1 \
 //thickness=0.36 //x=89.035 //y=4.25 //x2=88.92 //y2=4.25
r630 (  13 22 ) resistor r=0.0717383 //w=0.224 //l=0.115 //layer=m1 \
 //thickness=0.36 //x=95.465 //y=4.25 //x2=95.58 //y2=4.25
r631 (  13 14 ) resistor r=6.1355 //w=0.131 //l=6.43 //layer=m1 \
 //thickness=0.36 //x=95.465 //y=4.25 //x2=89.035 //y2=4.25
r632 (  11 20 ) resistor r=0.0880901 //w=0.191 //l=0.115 //layer=m1 \
 //thickness=0.36 //x=88.805 //y=4.25 //x2=88.92 //y2=4.25
r633 (  11 12 ) resistor r=22.0515 //w=0.131 //l=23.11 //layer=m1 \
 //thickness=0.36 //x=88.805 //y=4.25 //x2=65.695 //y2=4.25
r634 (  10 12 ) resistor r=0.0698411 //w=0.17 //l=0.120208 //layer=m1 \
 //thickness=0.36 //x=65.61 //y=4.165 //x2=65.695 //y2=4.25
r635 (  9 10 ) resistor r=0.19084 //w=0.131 //l=0.2 //layer=m1 \
 //thickness=0.36 //x=65.61 //y=3.965 //x2=65.61 //y2=4.165
r636 (  7 9 ) resistor r=0.0698411 //w=0.17 //l=0.120208 //layer=m1 \
 //thickness=0.36 //x=65.525 //y=3.88 //x2=65.61 //y2=3.965
r637 (  7 8 ) resistor r=7.60496 //w=0.131 //l=7.97 //layer=m1 \
 //thickness=0.36 //x=65.525 //y=3.88 //x2=57.555 //y2=3.88
r638 (  6 8 ) resistor r=0.0698411 //w=0.17 //l=0.120208 //layer=m1 \
 //thickness=0.36 //x=57.47 //y=3.795 //x2=57.555 //y2=3.88
r639 (  5 6 ) resistor r=0.19084 //w=0.131 //l=0.2 //layer=m1 //thickness=0.36 \
 //x=57.47 //y=3.595 //x2=57.47 //y2=3.795
r640 (  4 18 ) resistor r=0.0880901 //w=0.191 //l=0.115 //layer=m1 \
 //thickness=0.36 //x=54.625 //y=3.51 //x2=54.51 //y2=3.51
r641 (  3 5 ) resistor r=0.0698411 //w=0.17 //l=0.120208 //layer=m1 \
 //thickness=0.36 //x=57.385 //y=3.51 //x2=57.47 //y2=3.595
r642 (  3 4 ) resistor r=2.63359 //w=0.131 //l=2.76 //layer=m1 \
 //thickness=0.36 //x=57.385 //y=3.51 //x2=54.625 //y2=3.51
r643 (  2 16 ) resistor r=0.0717383 //w=0.224 //l=0.115 //layer=m1 \
 //thickness=0.36 //x=52.775 //y=3.51 //x2=52.66 //y2=3.51
r644 (  1 18 ) resistor r=0.0880901 //w=0.191 //l=0.115 //layer=m1 \
 //thickness=0.36 //x=54.395 //y=3.51 //x2=54.51 //y2=3.51
r645 (  1 2 ) resistor r=1.5458 //w=0.131 //l=1.62 //layer=m1 //thickness=0.36 \
 //x=54.395 //y=3.51 //x2=52.775 //y2=3.51
ends PM_TMRDFFSNRNQNX1\%noxref_26

subckt PM_TMRDFFSNRNQNX1\%Q ( 1 2 3 4 5 26 27 40 42 43 47 52 53 54 55 59 60 )
c175 ( 60 0 ) capacitor c=0.0167617f //x=95.695 //y=5.205
c176 ( 59 0 ) capacitor c=0.0164812f //x=94.815 //y=5.205
c177 ( 55 0 ) capacitor c=0.0108176f //x=95.69 //y=1.085
c178 ( 54 0 ) capacitor c=0.0131637f //x=92.36 //y=1.085
c179 ( 53 0 ) capacitor c=0.0131367f //x=89.03 //y=1.085
c180 ( 52 0 ) capacitor c=0.00421476f //x=95.84 //y=5.39
c181 ( 47 0 ) capacitor c=0.13039f //x=96.32 //y=4.25
c182 ( 43 0 ) capacitor c=0.00775877f //x=95.965 //y=1.825
c183 ( 42 0 ) capacitor c=0.0161066f //x=96.235 //y=1.825
c184 ( 40 0 ) capacitor c=0.0151634f //x=96.235 //y=5.39
c185 ( 27 0 ) capacitor c=0.0029383f //x=95.045 //y=5.39
c186 ( 26 0 ) capacitor c=0.0155464f //x=95.755 //y=5.39
c187 ( 5 0 ) capacitor c=0.00436966f //x=92.665 //y=1.36
c188 ( 4 0 ) capacitor c=0.069473f //x=95.765 //y=1.36
c189 ( 3 0 ) capacitor c=0.0141674f //x=89.335 //y=1.36
c190 ( 2 0 ) capacitor c=0.0494873f //x=92.435 //y=1.36
c191 ( 1 0 ) capacitor c=0.0241378f //x=96.32 //y=4.25
r192 (  51 53 ) resistor r=13.3953 //w=0.172 //l=0.18 //layer=li \
 //thickness=0.1 //x=89.217 //y=1.36 //x2=89.217 //y2=1.18
r193 (  45 47 ) resistor r=72.2139 //w=0.187 //l=1.055 //layer=li \
 //thickness=0.1 //x=96.32 //y=5.305 //x2=96.32 //y2=4.25
r194 (  44 47 ) resistor r=160.171 //w=0.187 //l=2.34 //layer=li \
 //thickness=0.1 //x=96.32 //y=1.91 //x2=96.32 //y2=4.25
r195 (  42 44 ) resistor r=7.15173 //w=0.17 //l=0.120208 //layer=li \
 //thickness=0.1 //x=96.235 //y=1.825 //x2=96.32 //y2=1.91
r196 (  42 43 ) resistor r=18.4813 //w=0.187 //l=0.27 //layer=li \
 //thickness=0.1 //x=96.235 //y=1.825 //x2=95.965 //y2=1.825
r197 (  41 52 ) resistor r=5.4201 //w=0.17 //l=0.085 //layer=li \
 //thickness=0.1 //x=95.925 //y=5.39 //x2=95.84 //y2=5.39
r198 (  40 45 ) resistor r=7.15173 //w=0.17 //l=0.120208 //layer=li \
 //thickness=0.1 //x=96.235 //y=5.39 //x2=96.32 //y2=5.305
r199 (  40 41 ) resistor r=21.2193 //w=0.187 //l=0.31 //layer=li \
 //thickness=0.1 //x=96.235 //y=5.39 //x2=95.925 //y2=5.39
r200 (  39 55 ) resistor r=12.3209 //w=0.187 //l=0.18 //layer=li \
 //thickness=0.1 //x=95.88 //y=1.36 //x2=95.88 //y2=1.18
r201 (  34 43 ) resistor r=7.15173 //w=0.17 //l=0.120208 //layer=li \
 //thickness=0.1 //x=95.88 //y=1.74 //x2=95.965 //y2=1.825
r202 (  34 39 ) resistor r=26.0107 //w=0.187 //l=0.38 //layer=li \
 //thickness=0.1 //x=95.88 //y=1.74 //x2=95.88 //y2=1.36
r203 (  28 52 ) resistor r=1.40859 //w=0.34 //l=0.085 //layer=li \
 //thickness=0.1 //x=95.84 //y=5.475 //x2=95.84 //y2=5.39
r204 (  28 60 ) resistor r=29.0909 //w=0.187 //l=0.425 //layer=li \
 //thickness=0.1 //x=95.84 //y=5.475 //x2=95.84 //y2=5.9
r205 (  26 52 ) resistor r=5.4201 //w=0.17 //l=0.085 //layer=li \
 //thickness=0.1 //x=95.755 //y=5.39 //x2=95.84 //y2=5.39
r206 (  26 27 ) resistor r=48.5989 //w=0.187 //l=0.71 //layer=li \
 //thickness=0.1 //x=95.755 //y=5.39 //x2=95.045 //y2=5.39
r207 (  20 27 ) resistor r=7.15173 //w=0.17 //l=0.120208 //layer=li \
 //thickness=0.1 //x=94.96 //y=5.475 //x2=95.045 //y2=5.39
r208 (  20 59 ) resistor r=29.0909 //w=0.187 //l=0.425 //layer=li \
 //thickness=0.1 //x=94.96 //y=5.475 //x2=94.96 //y2=5.9
r209 (  18 54 ) resistor r=12.3209 //w=0.187 //l=0.18 //layer=li \
 //thickness=0.1 //x=92.55 //y=1.36 //x2=92.55 //y2=1.18
r210 (  11 39 ) resistor r=9.3 //w=0.17 //l=0.17 //layer=mcon //count=1 \
 //x=95.88 //y=1.36 //x2=95.88 //y2=1.36
r211 (  9 18 ) resistor r=9.3 //w=0.17 //l=0.17 //layer=mcon //count=1 \
 //x=92.55 //y=1.36 //x2=92.55 //y2=1.36
r212 (  7 51 ) resistor r=9.3 //w=0.17 //l=0.17 //layer=mcon //count=1 \
 //x=89.22 //y=1.36 //x2=89.22 //y2=1.36
r213 (  5 9 ) resistor r=0.0880901 //w=0.191 //l=0.115 //layer=m1 \
 //thickness=0.36 //x=92.665 //y=1.36 //x2=92.55 //y2=1.36
r214 (  4 11 ) resistor r=0.0717383 //w=0.224 //l=0.115 //layer=m1 \
 //thickness=0.36 //x=95.765 //y=1.36 //x2=95.88 //y2=1.36
r215 (  4 5 ) resistor r=2.95802 //w=0.131 //l=3.1 //layer=m1 //thickness=0.36 \
 //x=95.765 //y=1.36 //x2=92.665 //y2=1.36
r216 (  3 7 ) resistor r=0.0717383 //w=0.224 //l=0.115 //layer=m1 \
 //thickness=0.36 //x=89.335 //y=1.36 //x2=89.22 //y2=1.36
r217 (  2 9 ) resistor r=0.0880901 //w=0.191 //l=0.115 //layer=m1 \
 //thickness=0.36 //x=92.435 //y=1.36 //x2=92.55 //y2=1.36
r218 (  2 3 ) resistor r=2.95802 //w=0.131 //l=3.1 //layer=m1 //thickness=0.36 \
 //x=92.435 //y=1.36 //x2=89.335 //y2=1.36
r219 (  1 47 ) resistor r=9.3 //w=0.17 //l=0.17 //layer=mcon //count=1 \
 //x=96.32 //y=4.25 //x2=96.32 //y2=4.25
ends PM_TMRDFFSNRNQNX1\%Q

subckt PM_TMRDFFSNRNQNX1\%noxref_28 ( 1 5 9 13 17 35 )
c49 ( 35 0 ) capacitor c=0.0687824f //x=0.945 //y=0.555
c50 ( 17 0 ) capacitor c=0.0213512f //x=2.935 //y=1.77
c51 ( 13 0 ) capacitor c=0.015523f //x=2.935 //y=0.72
c52 ( 9 0 ) capacitor c=0.00678203f //x=2.05 //y=0.805
c53 ( 5 0 ) capacitor c=0.0204181f //x=1.965 //y=1.77
c54 ( 1 0 ) capacitor c=0.0109947f //x=1.08 //y=1.685
r55 (  18 35 ) resistor r=5.4201 //w=0.17 //l=0.103078 //layer=li \
 //thickness=0.1 //x=2.135 //y=1.77 //x2=2.05 //y2=1.81
r56 (  18 35 ) resistor r=27.3797 //w=0.187 //l=0.4 //layer=li //thickness=0.1 \
 //x=2.135 //y=1.77 //x2=2.535 //y2=1.77
r57 (  17 35 ) resistor r=0.751729 //w=0.17 //l=0.085 //layer=li \
 //thickness=0.1 //x=2.935 //y=1.77 //x2=3.02 //y2=1.77
r58 (  17 35 ) resistor r=27.3797 //w=0.187 //l=0.4 //layer=li //thickness=0.1 \
 //x=2.935 //y=1.77 //x2=2.535 //y2=1.77
r59 (  14 35 ) resistor r=3.57586 //w=0.17 //l=0.103078 //layer=li \
 //thickness=0.1 //x=2.135 //y=0.72 //x2=2.05 //y2=0.68
r60 (  14 35 ) resistor r=27.3797 //w=0.187 //l=0.4 //layer=li //thickness=0.1 \
 //x=2.135 //y=0.72 //x2=2.535 //y2=0.72
r61 (  13 35 ) resistor r=0.751729 //w=0.17 //l=0.085 //layer=li \
 //thickness=0.1 //x=2.935 //y=0.72 //x2=3.02 //y2=0.72
r62 (  13 35 ) resistor r=27.3797 //w=0.187 //l=0.4 //layer=li //thickness=0.1 \
 //x=2.935 //y=0.72 //x2=2.535 //y2=0.72
r63 (  10 35 ) resistor r=1.40859 //w=0.34 //l=0.125 //layer=li \
 //thickness=0.1 //x=2.05 //y=1.685 //x2=2.05 //y2=1.81
r64 (  10 35 ) resistor r=42.0963 //w=0.187 //l=0.615 //layer=li \
 //thickness=0.1 //x=2.05 //y=1.685 //x2=2.05 //y2=1.07
r65 (  9 35 ) resistor r=3.57586 //w=0.17 //l=0.125 //layer=li //thickness=0.1 \
 //x=2.05 //y=0.805 //x2=2.05 //y2=0.68
r66 (  9 35 ) resistor r=18.139 //w=0.187 //l=0.265 //layer=li //thickness=0.1 \
 //x=2.05 //y=0.805 //x2=2.05 //y2=1.07
r67 (  6 35 ) resistor r=3.57586 //w=0.17 //l=0.103078 //layer=li \
 //thickness=0.1 //x=1.165 //y=1.77 //x2=1.08 //y2=1.81
r68 (  6 35 ) resistor r=27.3797 //w=0.187 //l=0.4 //layer=li //thickness=0.1 \
 //x=1.165 //y=1.77 //x2=1.565 //y2=1.77
r69 (  5 35 ) resistor r=5.4201 //w=0.17 //l=0.103078 //layer=li \
 //thickness=0.1 //x=1.965 //y=1.77 //x2=2.05 //y2=1.81
r70 (  5 35 ) resistor r=27.3797 //w=0.187 //l=0.4 //layer=li //thickness=0.1 \
 //x=1.965 //y=1.77 //x2=1.565 //y2=1.77
r71 (  1 35 ) resistor r=3.57586 //w=0.17 //l=0.125 //layer=li //thickness=0.1 \
 //x=1.08 //y=1.685 //x2=1.08 //y2=1.81
r72 (  1 35 ) resistor r=42.0963 //w=0.187 //l=0.615 //layer=li \
 //thickness=0.1 //x=1.08 //y=1.685 //x2=1.08 //y2=1.07
ends PM_TMRDFFSNRNQNX1\%noxref_28

subckt PM_TMRDFFSNRNQNX1\%noxref_29 ( 1 3 11 15 25 28 29 )
c52 ( 29 0 ) capacitor c=0.0414744f //x=3.455 //y=0.555
c53 ( 28 0 ) capacitor c=0.00462395f //x=2.35 //y=1.09
c54 ( 25 0 ) capacitor c=0.00156479f //x=3.59 //y=1.175
c55 ( 15 0 ) capacitor c=0.00737666f //x=4.56 //y=0.805
c56 ( 11 0 ) capacitor c=0.0144274f //x=4.475 //y=0.72
c57 ( 3 0 ) capacitor c=0.00718386f //x=3.59 //y=0.805
c58 ( 1 0 ) capacitor c=0.0218873f //x=3.505 //y=1.175
r59 (  15 29 ) resistor r=3.57586 //w=0.17 //l=0.125 //layer=li \
 //thickness=0.1 //x=4.56 //y=0.805 //x2=4.56 //y2=0.68
r60 (  15 29 ) resistor r=18.139 //w=0.187 //l=0.265 //layer=li \
 //thickness=0.1 //x=4.56 //y=0.805 //x2=4.56 //y2=1.07
r61 (  12 29 ) resistor r=3.57586 //w=0.17 //l=0.103078 //layer=li \
 //thickness=0.1 //x=3.675 //y=0.72 //x2=3.59 //y2=0.68
r62 (  12 29 ) resistor r=27.3797 //w=0.187 //l=0.4 //layer=li //thickness=0.1 \
 //x=3.675 //y=0.72 //x2=4.075 //y2=0.72
r63 (  11 29 ) resistor r=3.57586 //w=0.17 //l=0.103078 //layer=li \
 //thickness=0.1 //x=4.475 //y=0.72 //x2=4.56 //y2=0.68
r64 (  11 29 ) resistor r=27.3797 //w=0.187 //l=0.4 //layer=li //thickness=0.1 \
 //x=4.475 //y=0.72 //x2=4.075 //y2=0.72
r65 (  7 25 ) resistor r=5.4201 //w=0.17 //l=0.085 //layer=li //thickness=0.1 \
 //x=3.59 //y=1.26 //x2=3.59 //y2=1.175
r66 (  7 29 ) resistor r=10.2674 //w=0.187 //l=0.15 //layer=li //thickness=0.1 \
 //x=3.59 //y=1.26 //x2=3.59 //y2=1.41
r67 (  4 25 ) resistor r=5.4201 //w=0.17 //l=0.085 //layer=li //thickness=0.1 \
 //x=3.59 //y=1.09 //x2=3.59 //y2=1.175
r68 (  4 29 ) resistor r=1.36898 //w=0.187 //l=0.02 //layer=li //thickness=0.1 \
 //x=3.59 //y=1.09 //x2=3.59 //y2=1.07
r69 (  3 29 ) resistor r=3.57586 //w=0.17 //l=0.125 //layer=li //thickness=0.1 \
 //x=3.59 //y=0.805 //x2=3.59 //y2=0.68
r70 (  3 29 ) resistor r=18.139 //w=0.187 //l=0.265 //layer=li //thickness=0.1 \
 //x=3.59 //y=0.805 //x2=3.59 //y2=1.07
r71 (  2 28 ) resistor r=0.751729 //w=0.17 //l=0.085 //layer=li \
 //thickness=0.1 //x=2.625 //y=1.175 //x2=2.54 //y2=1.175
r72 (  1 25 ) resistor r=1.40859 //w=0.34 //l=0.085 //layer=li //thickness=0.1 \
 //x=3.505 //y=1.175 //x2=3.59 //y2=1.175
r73 (  1 2 ) resistor r=60.2353 //w=0.187 //l=0.88 //layer=li //thickness=0.1 \
 //x=3.505 //y=1.175 //x2=2.625 //y2=1.175
ends PM_TMRDFFSNRNQNX1\%noxref_29

subckt PM_TMRDFFSNRNQNX1\%noxref_30 ( 1 5 9 13 17 35 )
c49 ( 35 0 ) capacitor c=0.0673029f //x=5.755 //y=0.555
c50 ( 17 0 ) capacitor c=0.0178317f //x=7.745 //y=1.77
c51 ( 13 0 ) capacitor c=0.0154936f //x=7.745 //y=0.72
c52 ( 9 0 ) capacitor c=0.00678203f //x=6.86 //y=0.805
c53 ( 5 0 ) capacitor c=0.0164013f //x=6.775 //y=1.77
c54 ( 1 0 ) capacitor c=0.00696517f //x=5.89 //y=1.685
r55 (  18 35 ) resistor r=5.4201 //w=0.17 //l=0.103078 //layer=li \
 //thickness=0.1 //x=6.945 //y=1.77 //x2=6.86 //y2=1.81
r56 (  18 35 ) resistor r=27.3797 //w=0.187 //l=0.4 //layer=li //thickness=0.1 \
 //x=6.945 //y=1.77 //x2=7.345 //y2=1.77
r57 (  17 35 ) resistor r=0.751729 //w=0.17 //l=0.085 //layer=li \
 //thickness=0.1 //x=7.745 //y=1.77 //x2=7.83 //y2=1.77
r58 (  17 35 ) resistor r=27.3797 //w=0.187 //l=0.4 //layer=li //thickness=0.1 \
 //x=7.745 //y=1.77 //x2=7.345 //y2=1.77
r59 (  14 35 ) resistor r=3.57586 //w=0.17 //l=0.103078 //layer=li \
 //thickness=0.1 //x=6.945 //y=0.72 //x2=6.86 //y2=0.68
r60 (  14 35 ) resistor r=27.3797 //w=0.187 //l=0.4 //layer=li //thickness=0.1 \
 //x=6.945 //y=0.72 //x2=7.345 //y2=0.72
r61 (  13 35 ) resistor r=0.751729 //w=0.17 //l=0.085 //layer=li \
 //thickness=0.1 //x=7.745 //y=0.72 //x2=7.83 //y2=0.72
r62 (  13 35 ) resistor r=27.3797 //w=0.187 //l=0.4 //layer=li //thickness=0.1 \
 //x=7.745 //y=0.72 //x2=7.345 //y2=0.72
r63 (  10 35 ) resistor r=1.40859 //w=0.34 //l=0.125 //layer=li \
 //thickness=0.1 //x=6.86 //y=1.685 //x2=6.86 //y2=1.81
r64 (  10 35 ) resistor r=42.0963 //w=0.187 //l=0.615 //layer=li \
 //thickness=0.1 //x=6.86 //y=1.685 //x2=6.86 //y2=1.07
r65 (  9 35 ) resistor r=3.57586 //w=0.17 //l=0.125 //layer=li //thickness=0.1 \
 //x=6.86 //y=0.805 //x2=6.86 //y2=0.68
r66 (  9 35 ) resistor r=18.139 //w=0.187 //l=0.265 //layer=li //thickness=0.1 \
 //x=6.86 //y=0.805 //x2=6.86 //y2=1.07
r67 (  6 35 ) resistor r=3.57586 //w=0.17 //l=0.103078 //layer=li \
 //thickness=0.1 //x=5.975 //y=1.77 //x2=5.89 //y2=1.81
r68 (  6 35 ) resistor r=27.3797 //w=0.187 //l=0.4 //layer=li //thickness=0.1 \
 //x=5.975 //y=1.77 //x2=6.375 //y2=1.77
r69 (  5 35 ) resistor r=5.4201 //w=0.17 //l=0.103078 //layer=li \
 //thickness=0.1 //x=6.775 //y=1.77 //x2=6.86 //y2=1.81
r70 (  5 35 ) resistor r=27.3797 //w=0.187 //l=0.4 //layer=li //thickness=0.1 \
 //x=6.775 //y=1.77 //x2=6.375 //y2=1.77
r71 (  1 35 ) resistor r=3.57586 //w=0.17 //l=0.125 //layer=li //thickness=0.1 \
 //x=5.89 //y=1.685 //x2=5.89 //y2=1.81
r72 (  1 35 ) resistor r=42.0963 //w=0.187 //l=0.615 //layer=li \
 //thickness=0.1 //x=5.89 //y=1.685 //x2=5.89 //y2=1.07
ends PM_TMRDFFSNRNQNX1\%noxref_30

subckt PM_TMRDFFSNRNQNX1\%noxref_31 ( 1 3 11 15 25 28 29 )
c52 ( 29 0 ) capacitor c=0.0413887f //x=8.265 //y=0.555
c53 ( 28 0 ) capacitor c=0.0045748f //x=7.16 //y=1.09
c54 ( 25 0 ) capacitor c=0.00156479f //x=8.4 //y=1.175
c55 ( 15 0 ) capacitor c=0.00737666f //x=9.37 //y=0.805
c56 ( 11 0 ) capacitor c=0.0144274f //x=9.285 //y=0.72
c57 ( 3 0 ) capacitor c=0.00718386f //x=8.4 //y=0.805
c58 ( 1 0 ) capacitor c=0.0218888f //x=8.315 //y=1.175
r59 (  15 29 ) resistor r=3.57586 //w=0.17 //l=0.125 //layer=li \
 //thickness=0.1 //x=9.37 //y=0.805 //x2=9.37 //y2=0.68
r60 (  15 29 ) resistor r=18.139 //w=0.187 //l=0.265 //layer=li \
 //thickness=0.1 //x=9.37 //y=0.805 //x2=9.37 //y2=1.07
r61 (  12 29 ) resistor r=3.57586 //w=0.17 //l=0.103078 //layer=li \
 //thickness=0.1 //x=8.485 //y=0.72 //x2=8.4 //y2=0.68
r62 (  12 29 ) resistor r=27.3797 //w=0.187 //l=0.4 //layer=li //thickness=0.1 \
 //x=8.485 //y=0.72 //x2=8.885 //y2=0.72
r63 (  11 29 ) resistor r=3.57586 //w=0.17 //l=0.103078 //layer=li \
 //thickness=0.1 //x=9.285 //y=0.72 //x2=9.37 //y2=0.68
r64 (  11 29 ) resistor r=27.3797 //w=0.187 //l=0.4 //layer=li //thickness=0.1 \
 //x=9.285 //y=0.72 //x2=8.885 //y2=0.72
r65 (  7 25 ) resistor r=5.4201 //w=0.17 //l=0.085 //layer=li //thickness=0.1 \
 //x=8.4 //y=1.26 //x2=8.4 //y2=1.175
r66 (  7 29 ) resistor r=10.2674 //w=0.187 //l=0.15 //layer=li //thickness=0.1 \
 //x=8.4 //y=1.26 //x2=8.4 //y2=1.41
r67 (  4 25 ) resistor r=5.4201 //w=0.17 //l=0.085 //layer=li //thickness=0.1 \
 //x=8.4 //y=1.09 //x2=8.4 //y2=1.175
r68 (  4 29 ) resistor r=1.36898 //w=0.187 //l=0.02 //layer=li //thickness=0.1 \
 //x=8.4 //y=1.09 //x2=8.4 //y2=1.07
r69 (  3 29 ) resistor r=3.57586 //w=0.17 //l=0.125 //layer=li //thickness=0.1 \
 //x=8.4 //y=0.805 //x2=8.4 //y2=0.68
r70 (  3 29 ) resistor r=18.139 //w=0.187 //l=0.265 //layer=li //thickness=0.1 \
 //x=8.4 //y=0.805 //x2=8.4 //y2=1.07
r71 (  2 28 ) resistor r=0.751729 //w=0.17 //l=0.085 //layer=li \
 //thickness=0.1 //x=7.435 //y=1.175 //x2=7.35 //y2=1.175
r72 (  1 25 ) resistor r=1.40859 //w=0.34 //l=0.085 //layer=li //thickness=0.1 \
 //x=8.315 //y=1.175 //x2=8.4 //y2=1.175
r73 (  1 2 ) resistor r=60.2353 //w=0.187 //l=0.88 //layer=li //thickness=0.1 \
 //x=8.315 //y=1.175 //x2=7.435 //y2=1.175
ends PM_TMRDFFSNRNQNX1\%noxref_31

subckt PM_TMRDFFSNRNQNX1\%noxref_32 ( 1 5 9 13 17 35 )
c49 ( 35 0 ) capacitor c=0.0673029f //x=10.565 //y=0.555
c50 ( 17 0 ) capacitor c=0.0178317f //x=12.555 //y=1.77
c51 ( 13 0 ) capacitor c=0.0154936f //x=12.555 //y=0.72
c52 ( 9 0 ) capacitor c=0.00678203f //x=11.67 //y=0.805
c53 ( 5 0 ) capacitor c=0.0164013f //x=11.585 //y=1.77
c54 ( 1 0 ) capacitor c=0.00696517f //x=10.7 //y=1.685
r55 (  18 35 ) resistor r=5.4201 //w=0.17 //l=0.103078 //layer=li \
 //thickness=0.1 //x=11.755 //y=1.77 //x2=11.67 //y2=1.81
r56 (  18 35 ) resistor r=27.3797 //w=0.187 //l=0.4 //layer=li //thickness=0.1 \
 //x=11.755 //y=1.77 //x2=12.155 //y2=1.77
r57 (  17 35 ) resistor r=0.751729 //w=0.17 //l=0.085 //layer=li \
 //thickness=0.1 //x=12.555 //y=1.77 //x2=12.64 //y2=1.77
r58 (  17 35 ) resistor r=27.3797 //w=0.187 //l=0.4 //layer=li //thickness=0.1 \
 //x=12.555 //y=1.77 //x2=12.155 //y2=1.77
r59 (  14 35 ) resistor r=3.57586 //w=0.17 //l=0.103078 //layer=li \
 //thickness=0.1 //x=11.755 //y=0.72 //x2=11.67 //y2=0.68
r60 (  14 35 ) resistor r=27.3797 //w=0.187 //l=0.4 //layer=li //thickness=0.1 \
 //x=11.755 //y=0.72 //x2=12.155 //y2=0.72
r61 (  13 35 ) resistor r=0.751729 //w=0.17 //l=0.085 //layer=li \
 //thickness=0.1 //x=12.555 //y=0.72 //x2=12.64 //y2=0.72
r62 (  13 35 ) resistor r=27.3797 //w=0.187 //l=0.4 //layer=li //thickness=0.1 \
 //x=12.555 //y=0.72 //x2=12.155 //y2=0.72
r63 (  10 35 ) resistor r=1.40859 //w=0.34 //l=0.125 //layer=li \
 //thickness=0.1 //x=11.67 //y=1.685 //x2=11.67 //y2=1.81
r64 (  10 35 ) resistor r=42.0963 //w=0.187 //l=0.615 //layer=li \
 //thickness=0.1 //x=11.67 //y=1.685 //x2=11.67 //y2=1.07
r65 (  9 35 ) resistor r=3.57586 //w=0.17 //l=0.125 //layer=li //thickness=0.1 \
 //x=11.67 //y=0.805 //x2=11.67 //y2=0.68
r66 (  9 35 ) resistor r=18.139 //w=0.187 //l=0.265 //layer=li //thickness=0.1 \
 //x=11.67 //y=0.805 //x2=11.67 //y2=1.07
r67 (  6 35 ) resistor r=3.57586 //w=0.17 //l=0.103078 //layer=li \
 //thickness=0.1 //x=10.785 //y=1.77 //x2=10.7 //y2=1.81
r68 (  6 35 ) resistor r=27.3797 //w=0.187 //l=0.4 //layer=li //thickness=0.1 \
 //x=10.785 //y=1.77 //x2=11.185 //y2=1.77
r69 (  5 35 ) resistor r=5.4201 //w=0.17 //l=0.103078 //layer=li \
 //thickness=0.1 //x=11.585 //y=1.77 //x2=11.67 //y2=1.81
r70 (  5 35 ) resistor r=27.3797 //w=0.187 //l=0.4 //layer=li //thickness=0.1 \
 //x=11.585 //y=1.77 //x2=11.185 //y2=1.77
r71 (  1 35 ) resistor r=3.57586 //w=0.17 //l=0.125 //layer=li //thickness=0.1 \
 //x=10.7 //y=1.685 //x2=10.7 //y2=1.81
r72 (  1 35 ) resistor r=42.0963 //w=0.187 //l=0.615 //layer=li \
 //thickness=0.1 //x=10.7 //y=1.685 //x2=10.7 //y2=1.07
ends PM_TMRDFFSNRNQNX1\%noxref_32

subckt PM_TMRDFFSNRNQNX1\%noxref_33 ( 1 3 11 15 25 28 29 )
c52 ( 29 0 ) capacitor c=0.0414744f //x=13.075 //y=0.555
c53 ( 28 0 ) capacitor c=0.0045748f //x=11.97 //y=1.09
c54 ( 25 0 ) capacitor c=0.00156479f //x=13.21 //y=1.175
c55 ( 15 0 ) capacitor c=0.00737666f //x=14.18 //y=0.805
c56 ( 11 0 ) capacitor c=0.0144274f //x=14.095 //y=0.72
c57 ( 3 0 ) capacitor c=0.00718386f //x=13.21 //y=0.805
c58 ( 1 0 ) capacitor c=0.0218888f //x=13.125 //y=1.175
r59 (  15 29 ) resistor r=3.57586 //w=0.17 //l=0.125 //layer=li \
 //thickness=0.1 //x=14.18 //y=0.805 //x2=14.18 //y2=0.68
r60 (  15 29 ) resistor r=18.139 //w=0.187 //l=0.265 //layer=li \
 //thickness=0.1 //x=14.18 //y=0.805 //x2=14.18 //y2=1.07
r61 (  12 29 ) resistor r=3.57586 //w=0.17 //l=0.103078 //layer=li \
 //thickness=0.1 //x=13.295 //y=0.72 //x2=13.21 //y2=0.68
r62 (  12 29 ) resistor r=27.3797 //w=0.187 //l=0.4 //layer=li //thickness=0.1 \
 //x=13.295 //y=0.72 //x2=13.695 //y2=0.72
r63 (  11 29 ) resistor r=3.57586 //w=0.17 //l=0.103078 //layer=li \
 //thickness=0.1 //x=14.095 //y=0.72 //x2=14.18 //y2=0.68
r64 (  11 29 ) resistor r=27.3797 //w=0.187 //l=0.4 //layer=li //thickness=0.1 \
 //x=14.095 //y=0.72 //x2=13.695 //y2=0.72
r65 (  7 25 ) resistor r=5.4201 //w=0.17 //l=0.085 //layer=li //thickness=0.1 \
 //x=13.21 //y=1.26 //x2=13.21 //y2=1.175
r66 (  7 29 ) resistor r=10.2674 //w=0.187 //l=0.15 //layer=li //thickness=0.1 \
 //x=13.21 //y=1.26 //x2=13.21 //y2=1.41
r67 (  4 25 ) resistor r=5.4201 //w=0.17 //l=0.085 //layer=li //thickness=0.1 \
 //x=13.21 //y=1.09 //x2=13.21 //y2=1.175
r68 (  4 29 ) resistor r=1.36898 //w=0.187 //l=0.02 //layer=li //thickness=0.1 \
 //x=13.21 //y=1.09 //x2=13.21 //y2=1.07
r69 (  3 29 ) resistor r=3.57586 //w=0.17 //l=0.125 //layer=li //thickness=0.1 \
 //x=13.21 //y=0.805 //x2=13.21 //y2=0.68
r70 (  3 29 ) resistor r=18.139 //w=0.187 //l=0.265 //layer=li //thickness=0.1 \
 //x=13.21 //y=0.805 //x2=13.21 //y2=1.07
r71 (  2 28 ) resistor r=0.751729 //w=0.17 //l=0.085 //layer=li \
 //thickness=0.1 //x=12.245 //y=1.175 //x2=12.16 //y2=1.175
r72 (  1 25 ) resistor r=1.40859 //w=0.34 //l=0.085 //layer=li //thickness=0.1 \
 //x=13.125 //y=1.175 //x2=13.21 //y2=1.175
r73 (  1 2 ) resistor r=60.2353 //w=0.187 //l=0.88 //layer=li //thickness=0.1 \
 //x=13.125 //y=1.175 //x2=12.245 //y2=1.175
ends PM_TMRDFFSNRNQNX1\%noxref_33

subckt PM_TMRDFFSNRNQNX1\%noxref_34 ( 1 5 9 13 17 35 )
c49 ( 35 0 ) capacitor c=0.0673029f //x=15.375 //y=0.555
c50 ( 17 0 ) capacitor c=0.0178317f //x=17.365 //y=1.77
c51 ( 13 0 ) capacitor c=0.0154936f //x=17.365 //y=0.72
c52 ( 9 0 ) capacitor c=0.00678203f //x=16.48 //y=0.805
c53 ( 5 0 ) capacitor c=0.0164013f //x=16.395 //y=1.77
c54 ( 1 0 ) capacitor c=0.00696517f //x=15.51 //y=1.685
r55 (  18 35 ) resistor r=5.4201 //w=0.17 //l=0.103078 //layer=li \
 //thickness=0.1 //x=16.565 //y=1.77 //x2=16.48 //y2=1.81
r56 (  18 35 ) resistor r=27.3797 //w=0.187 //l=0.4 //layer=li //thickness=0.1 \
 //x=16.565 //y=1.77 //x2=16.965 //y2=1.77
r57 (  17 35 ) resistor r=0.751729 //w=0.17 //l=0.085 //layer=li \
 //thickness=0.1 //x=17.365 //y=1.77 //x2=17.45 //y2=1.77
r58 (  17 35 ) resistor r=27.3797 //w=0.187 //l=0.4 //layer=li //thickness=0.1 \
 //x=17.365 //y=1.77 //x2=16.965 //y2=1.77
r59 (  14 35 ) resistor r=3.57586 //w=0.17 //l=0.103078 //layer=li \
 //thickness=0.1 //x=16.565 //y=0.72 //x2=16.48 //y2=0.68
r60 (  14 35 ) resistor r=27.3797 //w=0.187 //l=0.4 //layer=li //thickness=0.1 \
 //x=16.565 //y=0.72 //x2=16.965 //y2=0.72
r61 (  13 35 ) resistor r=0.751729 //w=0.17 //l=0.085 //layer=li \
 //thickness=0.1 //x=17.365 //y=0.72 //x2=17.45 //y2=0.72
r62 (  13 35 ) resistor r=27.3797 //w=0.187 //l=0.4 //layer=li //thickness=0.1 \
 //x=17.365 //y=0.72 //x2=16.965 //y2=0.72
r63 (  10 35 ) resistor r=1.40859 //w=0.34 //l=0.125 //layer=li \
 //thickness=0.1 //x=16.48 //y=1.685 //x2=16.48 //y2=1.81
r64 (  10 35 ) resistor r=42.0963 //w=0.187 //l=0.615 //layer=li \
 //thickness=0.1 //x=16.48 //y=1.685 //x2=16.48 //y2=1.07
r65 (  9 35 ) resistor r=3.57586 //w=0.17 //l=0.125 //layer=li //thickness=0.1 \
 //x=16.48 //y=0.805 //x2=16.48 //y2=0.68
r66 (  9 35 ) resistor r=18.139 //w=0.187 //l=0.265 //layer=li //thickness=0.1 \
 //x=16.48 //y=0.805 //x2=16.48 //y2=1.07
r67 (  6 35 ) resistor r=3.57586 //w=0.17 //l=0.103078 //layer=li \
 //thickness=0.1 //x=15.595 //y=1.77 //x2=15.51 //y2=1.81
r68 (  6 35 ) resistor r=27.3797 //w=0.187 //l=0.4 //layer=li //thickness=0.1 \
 //x=15.595 //y=1.77 //x2=15.995 //y2=1.77
r69 (  5 35 ) resistor r=5.4201 //w=0.17 //l=0.103078 //layer=li \
 //thickness=0.1 //x=16.395 //y=1.77 //x2=16.48 //y2=1.81
r70 (  5 35 ) resistor r=27.3797 //w=0.187 //l=0.4 //layer=li //thickness=0.1 \
 //x=16.395 //y=1.77 //x2=15.995 //y2=1.77
r71 (  1 35 ) resistor r=3.57586 //w=0.17 //l=0.125 //layer=li //thickness=0.1 \
 //x=15.51 //y=1.685 //x2=15.51 //y2=1.81
r72 (  1 35 ) resistor r=42.0963 //w=0.187 //l=0.615 //layer=li \
 //thickness=0.1 //x=15.51 //y=1.685 //x2=15.51 //y2=1.07
ends PM_TMRDFFSNRNQNX1\%noxref_34

subckt PM_TMRDFFSNRNQNX1\%noxref_35 ( 1 3 11 15 25 28 29 )
c53 ( 29 0 ) capacitor c=0.0413887f //x=17.885 //y=0.555
c54 ( 28 0 ) capacitor c=0.0045748f //x=16.78 //y=1.09
c55 ( 25 0 ) capacitor c=0.00156479f //x=18.02 //y=1.175
c56 ( 15 0 ) capacitor c=0.00737666f //x=18.99 //y=0.805
c57 ( 11 0 ) capacitor c=0.0144218f //x=18.905 //y=0.72
c58 ( 3 0 ) capacitor c=0.00718386f //x=18.02 //y=0.805
c59 ( 1 0 ) capacitor c=0.0218888f //x=17.935 //y=1.175
r60 (  15 29 ) resistor r=3.57586 //w=0.17 //l=0.125 //layer=li \
 //thickness=0.1 //x=18.99 //y=0.805 //x2=18.99 //y2=0.68
r61 (  15 29 ) resistor r=18.139 //w=0.187 //l=0.265 //layer=li \
 //thickness=0.1 //x=18.99 //y=0.805 //x2=18.99 //y2=1.07
r62 (  12 29 ) resistor r=3.57586 //w=0.17 //l=0.103078 //layer=li \
 //thickness=0.1 //x=18.105 //y=0.72 //x2=18.02 //y2=0.68
r63 (  12 29 ) resistor r=27.3797 //w=0.187 //l=0.4 //layer=li //thickness=0.1 \
 //x=18.105 //y=0.72 //x2=18.505 //y2=0.72
r64 (  11 29 ) resistor r=3.57586 //w=0.17 //l=0.103078 //layer=li \
 //thickness=0.1 //x=18.905 //y=0.72 //x2=18.99 //y2=0.68
r65 (  11 29 ) resistor r=27.3797 //w=0.187 //l=0.4 //layer=li //thickness=0.1 \
 //x=18.905 //y=0.72 //x2=18.505 //y2=0.72
r66 (  7 25 ) resistor r=5.4201 //w=0.17 //l=0.085 //layer=li //thickness=0.1 \
 //x=18.02 //y=1.26 //x2=18.02 //y2=1.175
r67 (  7 29 ) resistor r=10.2674 //w=0.187 //l=0.15 //layer=li //thickness=0.1 \
 //x=18.02 //y=1.26 //x2=18.02 //y2=1.41
r68 (  4 25 ) resistor r=5.4201 //w=0.17 //l=0.085 //layer=li //thickness=0.1 \
 //x=18.02 //y=1.09 //x2=18.02 //y2=1.175
r69 (  4 29 ) resistor r=1.36898 //w=0.187 //l=0.02 //layer=li //thickness=0.1 \
 //x=18.02 //y=1.09 //x2=18.02 //y2=1.07
r70 (  3 29 ) resistor r=3.57586 //w=0.17 //l=0.125 //layer=li //thickness=0.1 \
 //x=18.02 //y=0.805 //x2=18.02 //y2=0.68
r71 (  3 29 ) resistor r=18.139 //w=0.187 //l=0.265 //layer=li //thickness=0.1 \
 //x=18.02 //y=0.805 //x2=18.02 //y2=1.07
r72 (  2 28 ) resistor r=0.751729 //w=0.17 //l=0.085 //layer=li \
 //thickness=0.1 //x=17.055 //y=1.175 //x2=16.97 //y2=1.175
r73 (  1 25 ) resistor r=1.40859 //w=0.34 //l=0.085 //layer=li //thickness=0.1 \
 //x=17.935 //y=1.175 //x2=18.02 //y2=1.175
r74 (  1 2 ) resistor r=60.2353 //w=0.187 //l=0.88 //layer=li //thickness=0.1 \
 //x=17.935 //y=1.175 //x2=17.055 //y2=1.175
ends PM_TMRDFFSNRNQNX1\%noxref_35

subckt PM_TMRDFFSNRNQNX1\%noxref_36 ( 1 5 9 13 17 35 )
c52 ( 35 0 ) capacitor c=0.0673029f //x=20.185 //y=0.555
c53 ( 17 0 ) capacitor c=0.0178286f //x=22.175 //y=1.77
c54 ( 13 0 ) capacitor c=0.0154917f //x=22.175 //y=0.72
c55 ( 9 0 ) capacitor c=0.00678203f //x=21.29 //y=0.805
c56 ( 5 0 ) capacitor c=0.0164013f //x=21.205 //y=1.77
c57 ( 1 0 ) capacitor c=0.00696517f //x=20.32 //y=1.685
r58 (  18 35 ) resistor r=5.4201 //w=0.17 //l=0.103078 //layer=li \
 //thickness=0.1 //x=21.375 //y=1.77 //x2=21.29 //y2=1.81
r59 (  18 35 ) resistor r=27.3797 //w=0.187 //l=0.4 //layer=li //thickness=0.1 \
 //x=21.375 //y=1.77 //x2=21.775 //y2=1.77
r60 (  17 35 ) resistor r=0.751729 //w=0.17 //l=0.085 //layer=li \
 //thickness=0.1 //x=22.175 //y=1.77 //x2=22.26 //y2=1.77
r61 (  17 35 ) resistor r=27.3797 //w=0.187 //l=0.4 //layer=li //thickness=0.1 \
 //x=22.175 //y=1.77 //x2=21.775 //y2=1.77
r62 (  14 35 ) resistor r=3.57586 //w=0.17 //l=0.103078 //layer=li \
 //thickness=0.1 //x=21.375 //y=0.72 //x2=21.29 //y2=0.68
r63 (  14 35 ) resistor r=27.3797 //w=0.187 //l=0.4 //layer=li //thickness=0.1 \
 //x=21.375 //y=0.72 //x2=21.775 //y2=0.72
r64 (  13 35 ) resistor r=0.751729 //w=0.17 //l=0.085 //layer=li \
 //thickness=0.1 //x=22.175 //y=0.72 //x2=22.26 //y2=0.72
r65 (  13 35 ) resistor r=27.3797 //w=0.187 //l=0.4 //layer=li //thickness=0.1 \
 //x=22.175 //y=0.72 //x2=21.775 //y2=0.72
r66 (  10 35 ) resistor r=1.40859 //w=0.34 //l=0.125 //layer=li \
 //thickness=0.1 //x=21.29 //y=1.685 //x2=21.29 //y2=1.81
r67 (  10 35 ) resistor r=42.0963 //w=0.187 //l=0.615 //layer=li \
 //thickness=0.1 //x=21.29 //y=1.685 //x2=21.29 //y2=1.07
r68 (  9 35 ) resistor r=3.57586 //w=0.17 //l=0.125 //layer=li //thickness=0.1 \
 //x=21.29 //y=0.805 //x2=21.29 //y2=0.68
r69 (  9 35 ) resistor r=18.139 //w=0.187 //l=0.265 //layer=li //thickness=0.1 \
 //x=21.29 //y=0.805 //x2=21.29 //y2=1.07
r70 (  6 35 ) resistor r=3.57586 //w=0.17 //l=0.103078 //layer=li \
 //thickness=0.1 //x=20.405 //y=1.77 //x2=20.32 //y2=1.81
r71 (  6 35 ) resistor r=27.3797 //w=0.187 //l=0.4 //layer=li //thickness=0.1 \
 //x=20.405 //y=1.77 //x2=20.805 //y2=1.77
r72 (  5 35 ) resistor r=5.4201 //w=0.17 //l=0.103078 //layer=li \
 //thickness=0.1 //x=21.205 //y=1.77 //x2=21.29 //y2=1.81
r73 (  5 35 ) resistor r=27.3797 //w=0.187 //l=0.4 //layer=li //thickness=0.1 \
 //x=21.205 //y=1.77 //x2=20.805 //y2=1.77
r74 (  1 35 ) resistor r=3.57586 //w=0.17 //l=0.125 //layer=li //thickness=0.1 \
 //x=20.32 //y=1.685 //x2=20.32 //y2=1.81
r75 (  1 35 ) resistor r=42.0963 //w=0.187 //l=0.615 //layer=li \
 //thickness=0.1 //x=20.32 //y=1.685 //x2=20.32 //y2=1.07
ends PM_TMRDFFSNRNQNX1\%noxref_36

subckt PM_TMRDFFSNRNQNX1\%noxref_37 ( 1 3 11 15 25 28 29 )
c52 ( 29 0 ) capacitor c=0.0414744f //x=22.695 //y=0.555
c53 ( 28 0 ) capacitor c=0.00457437f //x=21.59 //y=1.09
c54 ( 25 0 ) capacitor c=0.00156479f //x=22.83 //y=1.175
c55 ( 15 0 ) capacitor c=0.00737666f //x=23.8 //y=0.805
c56 ( 11 0 ) capacitor c=0.0144274f //x=23.715 //y=0.72
c57 ( 3 0 ) capacitor c=0.00718386f //x=22.83 //y=0.805
c58 ( 1 0 ) capacitor c=0.0218873f //x=22.745 //y=1.175
r59 (  15 29 ) resistor r=3.57586 //w=0.17 //l=0.125 //layer=li \
 //thickness=0.1 //x=23.8 //y=0.805 //x2=23.8 //y2=0.68
r60 (  15 29 ) resistor r=18.139 //w=0.187 //l=0.265 //layer=li \
 //thickness=0.1 //x=23.8 //y=0.805 //x2=23.8 //y2=1.07
r61 (  12 29 ) resistor r=3.57586 //w=0.17 //l=0.103078 //layer=li \
 //thickness=0.1 //x=22.915 //y=0.72 //x2=22.83 //y2=0.68
r62 (  12 29 ) resistor r=27.3797 //w=0.187 //l=0.4 //layer=li //thickness=0.1 \
 //x=22.915 //y=0.72 //x2=23.315 //y2=0.72
r63 (  11 29 ) resistor r=3.57586 //w=0.17 //l=0.103078 //layer=li \
 //thickness=0.1 //x=23.715 //y=0.72 //x2=23.8 //y2=0.68
r64 (  11 29 ) resistor r=27.3797 //w=0.187 //l=0.4 //layer=li //thickness=0.1 \
 //x=23.715 //y=0.72 //x2=23.315 //y2=0.72
r65 (  7 25 ) resistor r=5.4201 //w=0.17 //l=0.085 //layer=li //thickness=0.1 \
 //x=22.83 //y=1.26 //x2=22.83 //y2=1.175
r66 (  7 29 ) resistor r=10.2674 //w=0.187 //l=0.15 //layer=li //thickness=0.1 \
 //x=22.83 //y=1.26 //x2=22.83 //y2=1.41
r67 (  4 25 ) resistor r=5.4201 //w=0.17 //l=0.085 //layer=li //thickness=0.1 \
 //x=22.83 //y=1.09 //x2=22.83 //y2=1.175
r68 (  4 29 ) resistor r=1.36898 //w=0.187 //l=0.02 //layer=li //thickness=0.1 \
 //x=22.83 //y=1.09 //x2=22.83 //y2=1.07
r69 (  3 29 ) resistor r=3.57586 //w=0.17 //l=0.125 //layer=li //thickness=0.1 \
 //x=22.83 //y=0.805 //x2=22.83 //y2=0.68
r70 (  3 29 ) resistor r=18.139 //w=0.187 //l=0.265 //layer=li //thickness=0.1 \
 //x=22.83 //y=0.805 //x2=22.83 //y2=1.07
r71 (  2 28 ) resistor r=0.751729 //w=0.17 //l=0.085 //layer=li \
 //thickness=0.1 //x=21.865 //y=1.175 //x2=21.78 //y2=1.175
r72 (  1 25 ) resistor r=1.40859 //w=0.34 //l=0.085 //layer=li //thickness=0.1 \
 //x=22.745 //y=1.175 //x2=22.83 //y2=1.175
r73 (  1 2 ) resistor r=60.2353 //w=0.187 //l=0.88 //layer=li //thickness=0.1 \
 //x=22.745 //y=1.175 //x2=21.865 //y2=1.175
ends PM_TMRDFFSNRNQNX1\%noxref_37

subckt PM_TMRDFFSNRNQNX1\%noxref_38 ( 1 5 9 13 17 35 )
c49 ( 35 0 ) capacitor c=0.0673029f //x=24.995 //y=0.555
c50 ( 17 0 ) capacitor c=0.0178317f //x=26.985 //y=1.77
c51 ( 13 0 ) capacitor c=0.0154936f //x=26.985 //y=0.72
c52 ( 9 0 ) capacitor c=0.00678203f //x=26.1 //y=0.805
c53 ( 5 0 ) capacitor c=0.0164013f //x=26.015 //y=1.77
c54 ( 1 0 ) capacitor c=0.00696517f //x=25.13 //y=1.685
r55 (  18 35 ) resistor r=5.4201 //w=0.17 //l=0.103078 //layer=li \
 //thickness=0.1 //x=26.185 //y=1.77 //x2=26.1 //y2=1.81
r56 (  18 35 ) resistor r=27.3797 //w=0.187 //l=0.4 //layer=li //thickness=0.1 \
 //x=26.185 //y=1.77 //x2=26.585 //y2=1.77
r57 (  17 35 ) resistor r=0.751729 //w=0.17 //l=0.085 //layer=li \
 //thickness=0.1 //x=26.985 //y=1.77 //x2=27.07 //y2=1.77
r58 (  17 35 ) resistor r=27.3797 //w=0.187 //l=0.4 //layer=li //thickness=0.1 \
 //x=26.985 //y=1.77 //x2=26.585 //y2=1.77
r59 (  14 35 ) resistor r=3.57586 //w=0.17 //l=0.103078 //layer=li \
 //thickness=0.1 //x=26.185 //y=0.72 //x2=26.1 //y2=0.68
r60 (  14 35 ) resistor r=27.3797 //w=0.187 //l=0.4 //layer=li //thickness=0.1 \
 //x=26.185 //y=0.72 //x2=26.585 //y2=0.72
r61 (  13 35 ) resistor r=0.751729 //w=0.17 //l=0.085 //layer=li \
 //thickness=0.1 //x=26.985 //y=0.72 //x2=27.07 //y2=0.72
r62 (  13 35 ) resistor r=27.3797 //w=0.187 //l=0.4 //layer=li //thickness=0.1 \
 //x=26.985 //y=0.72 //x2=26.585 //y2=0.72
r63 (  10 35 ) resistor r=1.40859 //w=0.34 //l=0.125 //layer=li \
 //thickness=0.1 //x=26.1 //y=1.685 //x2=26.1 //y2=1.81
r64 (  10 35 ) resistor r=42.0963 //w=0.187 //l=0.615 //layer=li \
 //thickness=0.1 //x=26.1 //y=1.685 //x2=26.1 //y2=1.07
r65 (  9 35 ) resistor r=3.57586 //w=0.17 //l=0.125 //layer=li //thickness=0.1 \
 //x=26.1 //y=0.805 //x2=26.1 //y2=0.68
r66 (  9 35 ) resistor r=18.139 //w=0.187 //l=0.265 //layer=li //thickness=0.1 \
 //x=26.1 //y=0.805 //x2=26.1 //y2=1.07
r67 (  6 35 ) resistor r=3.57586 //w=0.17 //l=0.103078 //layer=li \
 //thickness=0.1 //x=25.215 //y=1.77 //x2=25.13 //y2=1.81
r68 (  6 35 ) resistor r=27.3797 //w=0.187 //l=0.4 //layer=li //thickness=0.1 \
 //x=25.215 //y=1.77 //x2=25.615 //y2=1.77
r69 (  5 35 ) resistor r=5.4201 //w=0.17 //l=0.103078 //layer=li \
 //thickness=0.1 //x=26.015 //y=1.77 //x2=26.1 //y2=1.81
r70 (  5 35 ) resistor r=27.3797 //w=0.187 //l=0.4 //layer=li //thickness=0.1 \
 //x=26.015 //y=1.77 //x2=25.615 //y2=1.77
r71 (  1 35 ) resistor r=3.57586 //w=0.17 //l=0.125 //layer=li //thickness=0.1 \
 //x=25.13 //y=1.685 //x2=25.13 //y2=1.81
r72 (  1 35 ) resistor r=42.0963 //w=0.187 //l=0.615 //layer=li \
 //thickness=0.1 //x=25.13 //y=1.685 //x2=25.13 //y2=1.07
ends PM_TMRDFFSNRNQNX1\%noxref_38

subckt PM_TMRDFFSNRNQNX1\%noxref_39 ( 1 3 11 15 25 28 29 )
c52 ( 29 0 ) capacitor c=0.0413887f //x=27.505 //y=0.555
c53 ( 28 0 ) capacitor c=0.0045748f //x=26.4 //y=1.09
c54 ( 25 0 ) capacitor c=0.00156479f //x=27.64 //y=1.175
c55 ( 15 0 ) capacitor c=0.00737666f //x=28.61 //y=0.805
c56 ( 11 0 ) capacitor c=0.0144274f //x=28.525 //y=0.72
c57 ( 3 0 ) capacitor c=0.00718386f //x=27.64 //y=0.805
c58 ( 1 0 ) capacitor c=0.0218888f //x=27.555 //y=1.175
r59 (  15 29 ) resistor r=3.57586 //w=0.17 //l=0.125 //layer=li \
 //thickness=0.1 //x=28.61 //y=0.805 //x2=28.61 //y2=0.68
r60 (  15 29 ) resistor r=18.139 //w=0.187 //l=0.265 //layer=li \
 //thickness=0.1 //x=28.61 //y=0.805 //x2=28.61 //y2=1.07
r61 (  12 29 ) resistor r=3.57586 //w=0.17 //l=0.103078 //layer=li \
 //thickness=0.1 //x=27.725 //y=0.72 //x2=27.64 //y2=0.68
r62 (  12 29 ) resistor r=27.3797 //w=0.187 //l=0.4 //layer=li //thickness=0.1 \
 //x=27.725 //y=0.72 //x2=28.125 //y2=0.72
r63 (  11 29 ) resistor r=3.57586 //w=0.17 //l=0.103078 //layer=li \
 //thickness=0.1 //x=28.525 //y=0.72 //x2=28.61 //y2=0.68
r64 (  11 29 ) resistor r=27.3797 //w=0.187 //l=0.4 //layer=li //thickness=0.1 \
 //x=28.525 //y=0.72 //x2=28.125 //y2=0.72
r65 (  7 25 ) resistor r=5.4201 //w=0.17 //l=0.085 //layer=li //thickness=0.1 \
 //x=27.64 //y=1.26 //x2=27.64 //y2=1.175
r66 (  7 29 ) resistor r=10.2674 //w=0.187 //l=0.15 //layer=li //thickness=0.1 \
 //x=27.64 //y=1.26 //x2=27.64 //y2=1.41
r67 (  4 25 ) resistor r=5.4201 //w=0.17 //l=0.085 //layer=li //thickness=0.1 \
 //x=27.64 //y=1.09 //x2=27.64 //y2=1.175
r68 (  4 29 ) resistor r=1.36898 //w=0.187 //l=0.02 //layer=li //thickness=0.1 \
 //x=27.64 //y=1.09 //x2=27.64 //y2=1.07
r69 (  3 29 ) resistor r=3.57586 //w=0.17 //l=0.125 //layer=li //thickness=0.1 \
 //x=27.64 //y=0.805 //x2=27.64 //y2=0.68
r70 (  3 29 ) resistor r=18.139 //w=0.187 //l=0.265 //layer=li //thickness=0.1 \
 //x=27.64 //y=0.805 //x2=27.64 //y2=1.07
r71 (  2 28 ) resistor r=0.751729 //w=0.17 //l=0.085 //layer=li \
 //thickness=0.1 //x=26.675 //y=1.175 //x2=26.59 //y2=1.175
r72 (  1 25 ) resistor r=1.40859 //w=0.34 //l=0.085 //layer=li //thickness=0.1 \
 //x=27.555 //y=1.175 //x2=27.64 //y2=1.175
r73 (  1 2 ) resistor r=60.2353 //w=0.187 //l=0.88 //layer=li //thickness=0.1 \
 //x=27.555 //y=1.175 //x2=26.675 //y2=1.175
ends PM_TMRDFFSNRNQNX1\%noxref_39

subckt PM_TMRDFFSNRNQNX1\%noxref_40 ( 1 5 9 13 17 35 )
c52 ( 35 0 ) capacitor c=0.0673029f //x=29.805 //y=0.555
c53 ( 17 0 ) capacitor c=0.0178286f //x=31.795 //y=1.77
c54 ( 13 0 ) capacitor c=0.0154917f //x=31.795 //y=0.72
c55 ( 9 0 ) capacitor c=0.00678203f //x=30.91 //y=0.805
c56 ( 5 0 ) capacitor c=0.0164013f //x=30.825 //y=1.77
c57 ( 1 0 ) capacitor c=0.00696517f //x=29.94 //y=1.685
r58 (  18 35 ) resistor r=5.4201 //w=0.17 //l=0.103078 //layer=li \
 //thickness=0.1 //x=30.995 //y=1.77 //x2=30.91 //y2=1.81
r59 (  18 35 ) resistor r=27.3797 //w=0.187 //l=0.4 //layer=li //thickness=0.1 \
 //x=30.995 //y=1.77 //x2=31.395 //y2=1.77
r60 (  17 35 ) resistor r=0.751729 //w=0.17 //l=0.085 //layer=li \
 //thickness=0.1 //x=31.795 //y=1.77 //x2=31.88 //y2=1.77
r61 (  17 35 ) resistor r=27.3797 //w=0.187 //l=0.4 //layer=li //thickness=0.1 \
 //x=31.795 //y=1.77 //x2=31.395 //y2=1.77
r62 (  14 35 ) resistor r=3.57586 //w=0.17 //l=0.103078 //layer=li \
 //thickness=0.1 //x=30.995 //y=0.72 //x2=30.91 //y2=0.68
r63 (  14 35 ) resistor r=27.3797 //w=0.187 //l=0.4 //layer=li //thickness=0.1 \
 //x=30.995 //y=0.72 //x2=31.395 //y2=0.72
r64 (  13 35 ) resistor r=0.751729 //w=0.17 //l=0.085 //layer=li \
 //thickness=0.1 //x=31.795 //y=0.72 //x2=31.88 //y2=0.72
r65 (  13 35 ) resistor r=27.3797 //w=0.187 //l=0.4 //layer=li //thickness=0.1 \
 //x=31.795 //y=0.72 //x2=31.395 //y2=0.72
r66 (  10 35 ) resistor r=1.40859 //w=0.34 //l=0.125 //layer=li \
 //thickness=0.1 //x=30.91 //y=1.685 //x2=30.91 //y2=1.81
r67 (  10 35 ) resistor r=42.0963 //w=0.187 //l=0.615 //layer=li \
 //thickness=0.1 //x=30.91 //y=1.685 //x2=30.91 //y2=1.07
r68 (  9 35 ) resistor r=3.57586 //w=0.17 //l=0.125 //layer=li //thickness=0.1 \
 //x=30.91 //y=0.805 //x2=30.91 //y2=0.68
r69 (  9 35 ) resistor r=18.139 //w=0.187 //l=0.265 //layer=li //thickness=0.1 \
 //x=30.91 //y=0.805 //x2=30.91 //y2=1.07
r70 (  6 35 ) resistor r=3.57586 //w=0.17 //l=0.103078 //layer=li \
 //thickness=0.1 //x=30.025 //y=1.77 //x2=29.94 //y2=1.81
r71 (  6 35 ) resistor r=27.3797 //w=0.187 //l=0.4 //layer=li //thickness=0.1 \
 //x=30.025 //y=1.77 //x2=30.425 //y2=1.77
r72 (  5 35 ) resistor r=5.4201 //w=0.17 //l=0.103078 //layer=li \
 //thickness=0.1 //x=30.825 //y=1.77 //x2=30.91 //y2=1.81
r73 (  5 35 ) resistor r=27.3797 //w=0.187 //l=0.4 //layer=li //thickness=0.1 \
 //x=30.825 //y=1.77 //x2=30.425 //y2=1.77
r74 (  1 35 ) resistor r=3.57586 //w=0.17 //l=0.125 //layer=li //thickness=0.1 \
 //x=29.94 //y=1.685 //x2=29.94 //y2=1.81
r75 (  1 35 ) resistor r=42.0963 //w=0.187 //l=0.615 //layer=li \
 //thickness=0.1 //x=29.94 //y=1.685 //x2=29.94 //y2=1.07
ends PM_TMRDFFSNRNQNX1\%noxref_40

subckt PM_TMRDFFSNRNQNX1\%noxref_41 ( 1 3 11 15 25 28 29 )
c52 ( 29 0 ) capacitor c=0.0414744f //x=32.315 //y=0.555
c53 ( 28 0 ) capacitor c=0.00457437f //x=31.21 //y=1.09
c54 ( 25 0 ) capacitor c=0.00156479f //x=32.45 //y=1.175
c55 ( 15 0 ) capacitor c=0.00737666f //x=33.42 //y=0.805
c56 ( 11 0 ) capacitor c=0.0144274f //x=33.335 //y=0.72
c57 ( 3 0 ) capacitor c=0.00718386f //x=32.45 //y=0.805
c58 ( 1 0 ) capacitor c=0.0218873f //x=32.365 //y=1.175
r59 (  15 29 ) resistor r=3.57586 //w=0.17 //l=0.125 //layer=li \
 //thickness=0.1 //x=33.42 //y=0.805 //x2=33.42 //y2=0.68
r60 (  15 29 ) resistor r=18.139 //w=0.187 //l=0.265 //layer=li \
 //thickness=0.1 //x=33.42 //y=0.805 //x2=33.42 //y2=1.07
r61 (  12 29 ) resistor r=3.57586 //w=0.17 //l=0.103078 //layer=li \
 //thickness=0.1 //x=32.535 //y=0.72 //x2=32.45 //y2=0.68
r62 (  12 29 ) resistor r=27.3797 //w=0.187 //l=0.4 //layer=li //thickness=0.1 \
 //x=32.535 //y=0.72 //x2=32.935 //y2=0.72
r63 (  11 29 ) resistor r=3.57586 //w=0.17 //l=0.103078 //layer=li \
 //thickness=0.1 //x=33.335 //y=0.72 //x2=33.42 //y2=0.68
r64 (  11 29 ) resistor r=27.3797 //w=0.187 //l=0.4 //layer=li //thickness=0.1 \
 //x=33.335 //y=0.72 //x2=32.935 //y2=0.72
r65 (  7 25 ) resistor r=5.4201 //w=0.17 //l=0.085 //layer=li //thickness=0.1 \
 //x=32.45 //y=1.26 //x2=32.45 //y2=1.175
r66 (  7 29 ) resistor r=10.2674 //w=0.187 //l=0.15 //layer=li //thickness=0.1 \
 //x=32.45 //y=1.26 //x2=32.45 //y2=1.41
r67 (  4 25 ) resistor r=5.4201 //w=0.17 //l=0.085 //layer=li //thickness=0.1 \
 //x=32.45 //y=1.09 //x2=32.45 //y2=1.175
r68 (  4 29 ) resistor r=1.36898 //w=0.187 //l=0.02 //layer=li //thickness=0.1 \
 //x=32.45 //y=1.09 //x2=32.45 //y2=1.07
r69 (  3 29 ) resistor r=3.57586 //w=0.17 //l=0.125 //layer=li //thickness=0.1 \
 //x=32.45 //y=0.805 //x2=32.45 //y2=0.68
r70 (  3 29 ) resistor r=18.139 //w=0.187 //l=0.265 //layer=li //thickness=0.1 \
 //x=32.45 //y=0.805 //x2=32.45 //y2=1.07
r71 (  2 28 ) resistor r=0.751729 //w=0.17 //l=0.085 //layer=li \
 //thickness=0.1 //x=31.485 //y=1.175 //x2=31.4 //y2=1.175
r72 (  1 25 ) resistor r=1.40859 //w=0.34 //l=0.085 //layer=li //thickness=0.1 \
 //x=32.365 //y=1.175 //x2=32.45 //y2=1.175
r73 (  1 2 ) resistor r=60.2353 //w=0.187 //l=0.88 //layer=li //thickness=0.1 \
 //x=32.365 //y=1.175 //x2=31.485 //y2=1.175
ends PM_TMRDFFSNRNQNX1\%noxref_41

subckt PM_TMRDFFSNRNQNX1\%noxref_42 ( 1 5 9 13 17 35 )
c49 ( 35 0 ) capacitor c=0.0673029f //x=34.615 //y=0.555
c50 ( 17 0 ) capacitor c=0.0178317f //x=36.605 //y=1.77
c51 ( 13 0 ) capacitor c=0.0154936f //x=36.605 //y=0.72
c52 ( 9 0 ) capacitor c=0.00678203f //x=35.72 //y=0.805
c53 ( 5 0 ) capacitor c=0.0164013f //x=35.635 //y=1.77
c54 ( 1 0 ) capacitor c=0.00696517f //x=34.75 //y=1.685
r55 (  18 35 ) resistor r=5.4201 //w=0.17 //l=0.103078 //layer=li \
 //thickness=0.1 //x=35.805 //y=1.77 //x2=35.72 //y2=1.81
r56 (  18 35 ) resistor r=27.3797 //w=0.187 //l=0.4 //layer=li //thickness=0.1 \
 //x=35.805 //y=1.77 //x2=36.205 //y2=1.77
r57 (  17 35 ) resistor r=0.751729 //w=0.17 //l=0.085 //layer=li \
 //thickness=0.1 //x=36.605 //y=1.77 //x2=36.69 //y2=1.77
r58 (  17 35 ) resistor r=27.3797 //w=0.187 //l=0.4 //layer=li //thickness=0.1 \
 //x=36.605 //y=1.77 //x2=36.205 //y2=1.77
r59 (  14 35 ) resistor r=3.57586 //w=0.17 //l=0.103078 //layer=li \
 //thickness=0.1 //x=35.805 //y=0.72 //x2=35.72 //y2=0.68
r60 (  14 35 ) resistor r=27.3797 //w=0.187 //l=0.4 //layer=li //thickness=0.1 \
 //x=35.805 //y=0.72 //x2=36.205 //y2=0.72
r61 (  13 35 ) resistor r=0.751729 //w=0.17 //l=0.085 //layer=li \
 //thickness=0.1 //x=36.605 //y=0.72 //x2=36.69 //y2=0.72
r62 (  13 35 ) resistor r=27.3797 //w=0.187 //l=0.4 //layer=li //thickness=0.1 \
 //x=36.605 //y=0.72 //x2=36.205 //y2=0.72
r63 (  10 35 ) resistor r=1.40859 //w=0.34 //l=0.125 //layer=li \
 //thickness=0.1 //x=35.72 //y=1.685 //x2=35.72 //y2=1.81
r64 (  10 35 ) resistor r=42.0963 //w=0.187 //l=0.615 //layer=li \
 //thickness=0.1 //x=35.72 //y=1.685 //x2=35.72 //y2=1.07
r65 (  9 35 ) resistor r=3.57586 //w=0.17 //l=0.125 //layer=li //thickness=0.1 \
 //x=35.72 //y=0.805 //x2=35.72 //y2=0.68
r66 (  9 35 ) resistor r=18.139 //w=0.187 //l=0.265 //layer=li //thickness=0.1 \
 //x=35.72 //y=0.805 //x2=35.72 //y2=1.07
r67 (  6 35 ) resistor r=3.57586 //w=0.17 //l=0.103078 //layer=li \
 //thickness=0.1 //x=34.835 //y=1.77 //x2=34.75 //y2=1.81
r68 (  6 35 ) resistor r=27.3797 //w=0.187 //l=0.4 //layer=li //thickness=0.1 \
 //x=34.835 //y=1.77 //x2=35.235 //y2=1.77
r69 (  5 35 ) resistor r=5.4201 //w=0.17 //l=0.103078 //layer=li \
 //thickness=0.1 //x=35.635 //y=1.77 //x2=35.72 //y2=1.81
r70 (  5 35 ) resistor r=27.3797 //w=0.187 //l=0.4 //layer=li //thickness=0.1 \
 //x=35.635 //y=1.77 //x2=35.235 //y2=1.77
r71 (  1 35 ) resistor r=3.57586 //w=0.17 //l=0.125 //layer=li //thickness=0.1 \
 //x=34.75 //y=1.685 //x2=34.75 //y2=1.81
r72 (  1 35 ) resistor r=42.0963 //w=0.187 //l=0.615 //layer=li \
 //thickness=0.1 //x=34.75 //y=1.685 //x2=34.75 //y2=1.07
ends PM_TMRDFFSNRNQNX1\%noxref_42

subckt PM_TMRDFFSNRNQNX1\%noxref_43 ( 1 3 11 15 25 28 29 )
c52 ( 29 0 ) capacitor c=0.0413887f //x=37.125 //y=0.555
c53 ( 28 0 ) capacitor c=0.0045748f //x=36.02 //y=1.09
c54 ( 25 0 ) capacitor c=0.00156479f //x=37.26 //y=1.175
c55 ( 15 0 ) capacitor c=0.00737666f //x=38.23 //y=0.805
c56 ( 11 0 ) capacitor c=0.0144274f //x=38.145 //y=0.72
c57 ( 3 0 ) capacitor c=0.00718386f //x=37.26 //y=0.805
c58 ( 1 0 ) capacitor c=0.0218888f //x=37.175 //y=1.175
r59 (  15 29 ) resistor r=3.57586 //w=0.17 //l=0.125 //layer=li \
 //thickness=0.1 //x=38.23 //y=0.805 //x2=38.23 //y2=0.68
r60 (  15 29 ) resistor r=18.139 //w=0.187 //l=0.265 //layer=li \
 //thickness=0.1 //x=38.23 //y=0.805 //x2=38.23 //y2=1.07
r61 (  12 29 ) resistor r=3.57586 //w=0.17 //l=0.103078 //layer=li \
 //thickness=0.1 //x=37.345 //y=0.72 //x2=37.26 //y2=0.68
r62 (  12 29 ) resistor r=27.3797 //w=0.187 //l=0.4 //layer=li //thickness=0.1 \
 //x=37.345 //y=0.72 //x2=37.745 //y2=0.72
r63 (  11 29 ) resistor r=3.57586 //w=0.17 //l=0.103078 //layer=li \
 //thickness=0.1 //x=38.145 //y=0.72 //x2=38.23 //y2=0.68
r64 (  11 29 ) resistor r=27.3797 //w=0.187 //l=0.4 //layer=li //thickness=0.1 \
 //x=38.145 //y=0.72 //x2=37.745 //y2=0.72
r65 (  7 25 ) resistor r=5.4201 //w=0.17 //l=0.085 //layer=li //thickness=0.1 \
 //x=37.26 //y=1.26 //x2=37.26 //y2=1.175
r66 (  7 29 ) resistor r=10.2674 //w=0.187 //l=0.15 //layer=li //thickness=0.1 \
 //x=37.26 //y=1.26 //x2=37.26 //y2=1.41
r67 (  4 25 ) resistor r=5.4201 //w=0.17 //l=0.085 //layer=li //thickness=0.1 \
 //x=37.26 //y=1.09 //x2=37.26 //y2=1.175
r68 (  4 29 ) resistor r=1.36898 //w=0.187 //l=0.02 //layer=li //thickness=0.1 \
 //x=37.26 //y=1.09 //x2=37.26 //y2=1.07
r69 (  3 29 ) resistor r=3.57586 //w=0.17 //l=0.125 //layer=li //thickness=0.1 \
 //x=37.26 //y=0.805 //x2=37.26 //y2=0.68
r70 (  3 29 ) resistor r=18.139 //w=0.187 //l=0.265 //layer=li //thickness=0.1 \
 //x=37.26 //y=0.805 //x2=37.26 //y2=1.07
r71 (  2 28 ) resistor r=0.751729 //w=0.17 //l=0.085 //layer=li \
 //thickness=0.1 //x=36.295 //y=1.175 //x2=36.21 //y2=1.175
r72 (  1 25 ) resistor r=1.40859 //w=0.34 //l=0.085 //layer=li //thickness=0.1 \
 //x=37.175 //y=1.175 //x2=37.26 //y2=1.175
r73 (  1 2 ) resistor r=60.2353 //w=0.187 //l=0.88 //layer=li //thickness=0.1 \
 //x=37.175 //y=1.175 //x2=36.295 //y2=1.175
ends PM_TMRDFFSNRNQNX1\%noxref_43

subckt PM_TMRDFFSNRNQNX1\%noxref_44 ( 1 5 9 13 17 35 )
c49 ( 35 0 ) capacitor c=0.0673029f //x=39.425 //y=0.555
c50 ( 17 0 ) capacitor c=0.0178317f //x=41.415 //y=1.77
c51 ( 13 0 ) capacitor c=0.0154936f //x=41.415 //y=0.72
c52 ( 9 0 ) capacitor c=0.00678203f //x=40.53 //y=0.805
c53 ( 5 0 ) capacitor c=0.0164013f //x=40.445 //y=1.77
c54 ( 1 0 ) capacitor c=0.00696517f //x=39.56 //y=1.685
r55 (  18 35 ) resistor r=5.4201 //w=0.17 //l=0.103078 //layer=li \
 //thickness=0.1 //x=40.615 //y=1.77 //x2=40.53 //y2=1.81
r56 (  18 35 ) resistor r=27.3797 //w=0.187 //l=0.4 //layer=li //thickness=0.1 \
 //x=40.615 //y=1.77 //x2=41.015 //y2=1.77
r57 (  17 35 ) resistor r=0.751729 //w=0.17 //l=0.085 //layer=li \
 //thickness=0.1 //x=41.415 //y=1.77 //x2=41.5 //y2=1.77
r58 (  17 35 ) resistor r=27.3797 //w=0.187 //l=0.4 //layer=li //thickness=0.1 \
 //x=41.415 //y=1.77 //x2=41.015 //y2=1.77
r59 (  14 35 ) resistor r=3.57586 //w=0.17 //l=0.103078 //layer=li \
 //thickness=0.1 //x=40.615 //y=0.72 //x2=40.53 //y2=0.68
r60 (  14 35 ) resistor r=27.3797 //w=0.187 //l=0.4 //layer=li //thickness=0.1 \
 //x=40.615 //y=0.72 //x2=41.015 //y2=0.72
r61 (  13 35 ) resistor r=0.751729 //w=0.17 //l=0.085 //layer=li \
 //thickness=0.1 //x=41.415 //y=0.72 //x2=41.5 //y2=0.72
r62 (  13 35 ) resistor r=27.3797 //w=0.187 //l=0.4 //layer=li //thickness=0.1 \
 //x=41.415 //y=0.72 //x2=41.015 //y2=0.72
r63 (  10 35 ) resistor r=1.40859 //w=0.34 //l=0.125 //layer=li \
 //thickness=0.1 //x=40.53 //y=1.685 //x2=40.53 //y2=1.81
r64 (  10 35 ) resistor r=42.0963 //w=0.187 //l=0.615 //layer=li \
 //thickness=0.1 //x=40.53 //y=1.685 //x2=40.53 //y2=1.07
r65 (  9 35 ) resistor r=3.57586 //w=0.17 //l=0.125 //layer=li //thickness=0.1 \
 //x=40.53 //y=0.805 //x2=40.53 //y2=0.68
r66 (  9 35 ) resistor r=18.139 //w=0.187 //l=0.265 //layer=li //thickness=0.1 \
 //x=40.53 //y=0.805 //x2=40.53 //y2=1.07
r67 (  6 35 ) resistor r=3.57586 //w=0.17 //l=0.103078 //layer=li \
 //thickness=0.1 //x=39.645 //y=1.77 //x2=39.56 //y2=1.81
r68 (  6 35 ) resistor r=27.3797 //w=0.187 //l=0.4 //layer=li //thickness=0.1 \
 //x=39.645 //y=1.77 //x2=40.045 //y2=1.77
r69 (  5 35 ) resistor r=5.4201 //w=0.17 //l=0.103078 //layer=li \
 //thickness=0.1 //x=40.445 //y=1.77 //x2=40.53 //y2=1.81
r70 (  5 35 ) resistor r=27.3797 //w=0.187 //l=0.4 //layer=li //thickness=0.1 \
 //x=40.445 //y=1.77 //x2=40.045 //y2=1.77
r71 (  1 35 ) resistor r=3.57586 //w=0.17 //l=0.125 //layer=li //thickness=0.1 \
 //x=39.56 //y=1.685 //x2=39.56 //y2=1.81
r72 (  1 35 ) resistor r=42.0963 //w=0.187 //l=0.615 //layer=li \
 //thickness=0.1 //x=39.56 //y=1.685 //x2=39.56 //y2=1.07
ends PM_TMRDFFSNRNQNX1\%noxref_44

subckt PM_TMRDFFSNRNQNX1\%noxref_45 ( 1 3 11 15 25 28 29 )
c52 ( 29 0 ) capacitor c=0.0414744f //x=41.935 //y=0.555
c53 ( 28 0 ) capacitor c=0.0045748f //x=40.83 //y=1.09
c54 ( 25 0 ) capacitor c=0.00156479f //x=42.07 //y=1.175
c55 ( 15 0 ) capacitor c=0.00737666f //x=43.04 //y=0.805
c56 ( 11 0 ) capacitor c=0.0144274f //x=42.955 //y=0.72
c57 ( 3 0 ) capacitor c=0.00718386f //x=42.07 //y=0.805
c58 ( 1 0 ) capacitor c=0.0218888f //x=41.985 //y=1.175
r59 (  15 29 ) resistor r=3.57586 //w=0.17 //l=0.125 //layer=li \
 //thickness=0.1 //x=43.04 //y=0.805 //x2=43.04 //y2=0.68
r60 (  15 29 ) resistor r=18.139 //w=0.187 //l=0.265 //layer=li \
 //thickness=0.1 //x=43.04 //y=0.805 //x2=43.04 //y2=1.07
r61 (  12 29 ) resistor r=3.57586 //w=0.17 //l=0.103078 //layer=li \
 //thickness=0.1 //x=42.155 //y=0.72 //x2=42.07 //y2=0.68
r62 (  12 29 ) resistor r=27.3797 //w=0.187 //l=0.4 //layer=li //thickness=0.1 \
 //x=42.155 //y=0.72 //x2=42.555 //y2=0.72
r63 (  11 29 ) resistor r=3.57586 //w=0.17 //l=0.103078 //layer=li \
 //thickness=0.1 //x=42.955 //y=0.72 //x2=43.04 //y2=0.68
r64 (  11 29 ) resistor r=27.3797 //w=0.187 //l=0.4 //layer=li //thickness=0.1 \
 //x=42.955 //y=0.72 //x2=42.555 //y2=0.72
r65 (  7 25 ) resistor r=5.4201 //w=0.17 //l=0.085 //layer=li //thickness=0.1 \
 //x=42.07 //y=1.26 //x2=42.07 //y2=1.175
r66 (  7 29 ) resistor r=10.2674 //w=0.187 //l=0.15 //layer=li //thickness=0.1 \
 //x=42.07 //y=1.26 //x2=42.07 //y2=1.41
r67 (  4 25 ) resistor r=5.4201 //w=0.17 //l=0.085 //layer=li //thickness=0.1 \
 //x=42.07 //y=1.09 //x2=42.07 //y2=1.175
r68 (  4 29 ) resistor r=1.36898 //w=0.187 //l=0.02 //layer=li //thickness=0.1 \
 //x=42.07 //y=1.09 //x2=42.07 //y2=1.07
r69 (  3 29 ) resistor r=3.57586 //w=0.17 //l=0.125 //layer=li //thickness=0.1 \
 //x=42.07 //y=0.805 //x2=42.07 //y2=0.68
r70 (  3 29 ) resistor r=18.139 //w=0.187 //l=0.265 //layer=li //thickness=0.1 \
 //x=42.07 //y=0.805 //x2=42.07 //y2=1.07
r71 (  2 28 ) resistor r=0.751729 //w=0.17 //l=0.085 //layer=li \
 //thickness=0.1 //x=41.105 //y=1.175 //x2=41.02 //y2=1.175
r72 (  1 25 ) resistor r=1.40859 //w=0.34 //l=0.085 //layer=li //thickness=0.1 \
 //x=41.985 //y=1.175 //x2=42.07 //y2=1.175
r73 (  1 2 ) resistor r=60.2353 //w=0.187 //l=0.88 //layer=li //thickness=0.1 \
 //x=41.985 //y=1.175 //x2=41.105 //y2=1.175
ends PM_TMRDFFSNRNQNX1\%noxref_45

subckt PM_TMRDFFSNRNQNX1\%noxref_46 ( 1 5 9 13 17 35 )
c49 ( 35 0 ) capacitor c=0.0673029f //x=44.235 //y=0.555
c50 ( 17 0 ) capacitor c=0.0178317f //x=46.225 //y=1.77
c51 ( 13 0 ) capacitor c=0.0154936f //x=46.225 //y=0.72
c52 ( 9 0 ) capacitor c=0.00678203f //x=45.34 //y=0.805
c53 ( 5 0 ) capacitor c=0.0164013f //x=45.255 //y=1.77
c54 ( 1 0 ) capacitor c=0.00696517f //x=44.37 //y=1.685
r55 (  18 35 ) resistor r=5.4201 //w=0.17 //l=0.103078 //layer=li \
 //thickness=0.1 //x=45.425 //y=1.77 //x2=45.34 //y2=1.81
r56 (  18 35 ) resistor r=27.3797 //w=0.187 //l=0.4 //layer=li //thickness=0.1 \
 //x=45.425 //y=1.77 //x2=45.825 //y2=1.77
r57 (  17 35 ) resistor r=0.751729 //w=0.17 //l=0.085 //layer=li \
 //thickness=0.1 //x=46.225 //y=1.77 //x2=46.31 //y2=1.77
r58 (  17 35 ) resistor r=27.3797 //w=0.187 //l=0.4 //layer=li //thickness=0.1 \
 //x=46.225 //y=1.77 //x2=45.825 //y2=1.77
r59 (  14 35 ) resistor r=3.57586 //w=0.17 //l=0.103078 //layer=li \
 //thickness=0.1 //x=45.425 //y=0.72 //x2=45.34 //y2=0.68
r60 (  14 35 ) resistor r=27.3797 //w=0.187 //l=0.4 //layer=li //thickness=0.1 \
 //x=45.425 //y=0.72 //x2=45.825 //y2=0.72
r61 (  13 35 ) resistor r=0.751729 //w=0.17 //l=0.085 //layer=li \
 //thickness=0.1 //x=46.225 //y=0.72 //x2=46.31 //y2=0.72
r62 (  13 35 ) resistor r=27.3797 //w=0.187 //l=0.4 //layer=li //thickness=0.1 \
 //x=46.225 //y=0.72 //x2=45.825 //y2=0.72
r63 (  10 35 ) resistor r=1.40859 //w=0.34 //l=0.125 //layer=li \
 //thickness=0.1 //x=45.34 //y=1.685 //x2=45.34 //y2=1.81
r64 (  10 35 ) resistor r=42.0963 //w=0.187 //l=0.615 //layer=li \
 //thickness=0.1 //x=45.34 //y=1.685 //x2=45.34 //y2=1.07
r65 (  9 35 ) resistor r=3.57586 //w=0.17 //l=0.125 //layer=li //thickness=0.1 \
 //x=45.34 //y=0.805 //x2=45.34 //y2=0.68
r66 (  9 35 ) resistor r=18.139 //w=0.187 //l=0.265 //layer=li //thickness=0.1 \
 //x=45.34 //y=0.805 //x2=45.34 //y2=1.07
r67 (  6 35 ) resistor r=3.57586 //w=0.17 //l=0.103078 //layer=li \
 //thickness=0.1 //x=44.455 //y=1.77 //x2=44.37 //y2=1.81
r68 (  6 35 ) resistor r=27.3797 //w=0.187 //l=0.4 //layer=li //thickness=0.1 \
 //x=44.455 //y=1.77 //x2=44.855 //y2=1.77
r69 (  5 35 ) resistor r=5.4201 //w=0.17 //l=0.103078 //layer=li \
 //thickness=0.1 //x=45.255 //y=1.77 //x2=45.34 //y2=1.81
r70 (  5 35 ) resistor r=27.3797 //w=0.187 //l=0.4 //layer=li //thickness=0.1 \
 //x=45.255 //y=1.77 //x2=44.855 //y2=1.77
r71 (  1 35 ) resistor r=3.57586 //w=0.17 //l=0.125 //layer=li //thickness=0.1 \
 //x=44.37 //y=1.685 //x2=44.37 //y2=1.81
r72 (  1 35 ) resistor r=42.0963 //w=0.187 //l=0.615 //layer=li \
 //thickness=0.1 //x=44.37 //y=1.685 //x2=44.37 //y2=1.07
ends PM_TMRDFFSNRNQNX1\%noxref_46

subckt PM_TMRDFFSNRNQNX1\%noxref_47 ( 1 3 11 15 25 28 29 )
c53 ( 29 0 ) capacitor c=0.0413887f //x=46.745 //y=0.555
c54 ( 28 0 ) capacitor c=0.0045748f //x=45.64 //y=1.09
c55 ( 25 0 ) capacitor c=0.00156479f //x=46.88 //y=1.175
c56 ( 15 0 ) capacitor c=0.00737666f //x=47.85 //y=0.805
c57 ( 11 0 ) capacitor c=0.0144218f //x=47.765 //y=0.72
c58 ( 3 0 ) capacitor c=0.00718386f //x=46.88 //y=0.805
c59 ( 1 0 ) capacitor c=0.0218888f //x=46.795 //y=1.175
r60 (  15 29 ) resistor r=3.57586 //w=0.17 //l=0.125 //layer=li \
 //thickness=0.1 //x=47.85 //y=0.805 //x2=47.85 //y2=0.68
r61 (  15 29 ) resistor r=18.139 //w=0.187 //l=0.265 //layer=li \
 //thickness=0.1 //x=47.85 //y=0.805 //x2=47.85 //y2=1.07
r62 (  12 29 ) resistor r=3.57586 //w=0.17 //l=0.103078 //layer=li \
 //thickness=0.1 //x=46.965 //y=0.72 //x2=46.88 //y2=0.68
r63 (  12 29 ) resistor r=27.3797 //w=0.187 //l=0.4 //layer=li //thickness=0.1 \
 //x=46.965 //y=0.72 //x2=47.365 //y2=0.72
r64 (  11 29 ) resistor r=3.57586 //w=0.17 //l=0.103078 //layer=li \
 //thickness=0.1 //x=47.765 //y=0.72 //x2=47.85 //y2=0.68
r65 (  11 29 ) resistor r=27.3797 //w=0.187 //l=0.4 //layer=li //thickness=0.1 \
 //x=47.765 //y=0.72 //x2=47.365 //y2=0.72
r66 (  7 25 ) resistor r=5.4201 //w=0.17 //l=0.085 //layer=li //thickness=0.1 \
 //x=46.88 //y=1.26 //x2=46.88 //y2=1.175
r67 (  7 29 ) resistor r=10.2674 //w=0.187 //l=0.15 //layer=li //thickness=0.1 \
 //x=46.88 //y=1.26 //x2=46.88 //y2=1.41
r68 (  4 25 ) resistor r=5.4201 //w=0.17 //l=0.085 //layer=li //thickness=0.1 \
 //x=46.88 //y=1.09 //x2=46.88 //y2=1.175
r69 (  4 29 ) resistor r=1.36898 //w=0.187 //l=0.02 //layer=li //thickness=0.1 \
 //x=46.88 //y=1.09 //x2=46.88 //y2=1.07
r70 (  3 29 ) resistor r=3.57586 //w=0.17 //l=0.125 //layer=li //thickness=0.1 \
 //x=46.88 //y=0.805 //x2=46.88 //y2=0.68
r71 (  3 29 ) resistor r=18.139 //w=0.187 //l=0.265 //layer=li //thickness=0.1 \
 //x=46.88 //y=0.805 //x2=46.88 //y2=1.07
r72 (  2 28 ) resistor r=0.751729 //w=0.17 //l=0.085 //layer=li \
 //thickness=0.1 //x=45.915 //y=1.175 //x2=45.83 //y2=1.175
r73 (  1 25 ) resistor r=1.40859 //w=0.34 //l=0.085 //layer=li //thickness=0.1 \
 //x=46.795 //y=1.175 //x2=46.88 //y2=1.175
r74 (  1 2 ) resistor r=60.2353 //w=0.187 //l=0.88 //layer=li //thickness=0.1 \
 //x=46.795 //y=1.175 //x2=45.915 //y2=1.175
ends PM_TMRDFFSNRNQNX1\%noxref_47

subckt PM_TMRDFFSNRNQNX1\%noxref_48 ( 1 5 9 13 17 35 )
c52 ( 35 0 ) capacitor c=0.0673029f //x=49.045 //y=0.555
c53 ( 17 0 ) capacitor c=0.0178286f //x=51.035 //y=1.77
c54 ( 13 0 ) capacitor c=0.0154917f //x=51.035 //y=0.72
c55 ( 9 0 ) capacitor c=0.00678203f //x=50.15 //y=0.805
c56 ( 5 0 ) capacitor c=0.0164013f //x=50.065 //y=1.77
c57 ( 1 0 ) capacitor c=0.00696517f //x=49.18 //y=1.685
r58 (  18 35 ) resistor r=5.4201 //w=0.17 //l=0.103078 //layer=li \
 //thickness=0.1 //x=50.235 //y=1.77 //x2=50.15 //y2=1.81
r59 (  18 35 ) resistor r=27.3797 //w=0.187 //l=0.4 //layer=li //thickness=0.1 \
 //x=50.235 //y=1.77 //x2=50.635 //y2=1.77
r60 (  17 35 ) resistor r=0.751729 //w=0.17 //l=0.085 //layer=li \
 //thickness=0.1 //x=51.035 //y=1.77 //x2=51.12 //y2=1.77
r61 (  17 35 ) resistor r=27.3797 //w=0.187 //l=0.4 //layer=li //thickness=0.1 \
 //x=51.035 //y=1.77 //x2=50.635 //y2=1.77
r62 (  14 35 ) resistor r=3.57586 //w=0.17 //l=0.103078 //layer=li \
 //thickness=0.1 //x=50.235 //y=0.72 //x2=50.15 //y2=0.68
r63 (  14 35 ) resistor r=27.3797 //w=0.187 //l=0.4 //layer=li //thickness=0.1 \
 //x=50.235 //y=0.72 //x2=50.635 //y2=0.72
r64 (  13 35 ) resistor r=0.751729 //w=0.17 //l=0.085 //layer=li \
 //thickness=0.1 //x=51.035 //y=0.72 //x2=51.12 //y2=0.72
r65 (  13 35 ) resistor r=27.3797 //w=0.187 //l=0.4 //layer=li //thickness=0.1 \
 //x=51.035 //y=0.72 //x2=50.635 //y2=0.72
r66 (  10 35 ) resistor r=1.40859 //w=0.34 //l=0.125 //layer=li \
 //thickness=0.1 //x=50.15 //y=1.685 //x2=50.15 //y2=1.81
r67 (  10 35 ) resistor r=42.0963 //w=0.187 //l=0.615 //layer=li \
 //thickness=0.1 //x=50.15 //y=1.685 //x2=50.15 //y2=1.07
r68 (  9 35 ) resistor r=3.57586 //w=0.17 //l=0.125 //layer=li //thickness=0.1 \
 //x=50.15 //y=0.805 //x2=50.15 //y2=0.68
r69 (  9 35 ) resistor r=18.139 //w=0.187 //l=0.265 //layer=li //thickness=0.1 \
 //x=50.15 //y=0.805 //x2=50.15 //y2=1.07
r70 (  6 35 ) resistor r=3.57586 //w=0.17 //l=0.103078 //layer=li \
 //thickness=0.1 //x=49.265 //y=1.77 //x2=49.18 //y2=1.81
r71 (  6 35 ) resistor r=27.3797 //w=0.187 //l=0.4 //layer=li //thickness=0.1 \
 //x=49.265 //y=1.77 //x2=49.665 //y2=1.77
r72 (  5 35 ) resistor r=5.4201 //w=0.17 //l=0.103078 //layer=li \
 //thickness=0.1 //x=50.065 //y=1.77 //x2=50.15 //y2=1.81
r73 (  5 35 ) resistor r=27.3797 //w=0.187 //l=0.4 //layer=li //thickness=0.1 \
 //x=50.065 //y=1.77 //x2=49.665 //y2=1.77
r74 (  1 35 ) resistor r=3.57586 //w=0.17 //l=0.125 //layer=li //thickness=0.1 \
 //x=49.18 //y=1.685 //x2=49.18 //y2=1.81
r75 (  1 35 ) resistor r=42.0963 //w=0.187 //l=0.615 //layer=li \
 //thickness=0.1 //x=49.18 //y=1.685 //x2=49.18 //y2=1.07
ends PM_TMRDFFSNRNQNX1\%noxref_48

subckt PM_TMRDFFSNRNQNX1\%noxref_49 ( 1 3 11 15 25 28 29 )
c52 ( 29 0 ) capacitor c=0.0413887f //x=51.555 //y=0.555
c53 ( 28 0 ) capacitor c=0.00457437f //x=50.45 //y=1.09
c54 ( 25 0 ) capacitor c=0.00156479f //x=51.69 //y=1.175
c55 ( 15 0 ) capacitor c=0.00737666f //x=52.66 //y=0.805
c56 ( 11 0 ) capacitor c=0.0144274f //x=52.575 //y=0.72
c57 ( 3 0 ) capacitor c=0.00718386f //x=51.69 //y=0.805
c58 ( 1 0 ) capacitor c=0.0218873f //x=51.605 //y=1.175
r59 (  15 29 ) resistor r=3.57586 //w=0.17 //l=0.125 //layer=li \
 //thickness=0.1 //x=52.66 //y=0.805 //x2=52.66 //y2=0.68
r60 (  15 29 ) resistor r=18.139 //w=0.187 //l=0.265 //layer=li \
 //thickness=0.1 //x=52.66 //y=0.805 //x2=52.66 //y2=1.07
r61 (  12 29 ) resistor r=3.57586 //w=0.17 //l=0.103078 //layer=li \
 //thickness=0.1 //x=51.775 //y=0.72 //x2=51.69 //y2=0.68
r62 (  12 29 ) resistor r=27.3797 //w=0.187 //l=0.4 //layer=li //thickness=0.1 \
 //x=51.775 //y=0.72 //x2=52.175 //y2=0.72
r63 (  11 29 ) resistor r=3.57586 //w=0.17 //l=0.103078 //layer=li \
 //thickness=0.1 //x=52.575 //y=0.72 //x2=52.66 //y2=0.68
r64 (  11 29 ) resistor r=27.3797 //w=0.187 //l=0.4 //layer=li //thickness=0.1 \
 //x=52.575 //y=0.72 //x2=52.175 //y2=0.72
r65 (  7 25 ) resistor r=5.4201 //w=0.17 //l=0.085 //layer=li //thickness=0.1 \
 //x=51.69 //y=1.26 //x2=51.69 //y2=1.175
r66 (  7 29 ) resistor r=10.2674 //w=0.187 //l=0.15 //layer=li //thickness=0.1 \
 //x=51.69 //y=1.26 //x2=51.69 //y2=1.41
r67 (  4 25 ) resistor r=5.4201 //w=0.17 //l=0.085 //layer=li //thickness=0.1 \
 //x=51.69 //y=1.09 //x2=51.69 //y2=1.175
r68 (  4 29 ) resistor r=1.36898 //w=0.187 //l=0.02 //layer=li //thickness=0.1 \
 //x=51.69 //y=1.09 //x2=51.69 //y2=1.07
r69 (  3 29 ) resistor r=3.57586 //w=0.17 //l=0.125 //layer=li //thickness=0.1 \
 //x=51.69 //y=0.805 //x2=51.69 //y2=0.68
r70 (  3 29 ) resistor r=18.139 //w=0.187 //l=0.265 //layer=li //thickness=0.1 \
 //x=51.69 //y=0.805 //x2=51.69 //y2=1.07
r71 (  2 28 ) resistor r=0.751729 //w=0.17 //l=0.085 //layer=li \
 //thickness=0.1 //x=50.725 //y=1.175 //x2=50.64 //y2=1.175
r72 (  1 25 ) resistor r=1.40859 //w=0.34 //l=0.085 //layer=li //thickness=0.1 \
 //x=51.605 //y=1.175 //x2=51.69 //y2=1.175
r73 (  1 2 ) resistor r=60.2353 //w=0.187 //l=0.88 //layer=li //thickness=0.1 \
 //x=51.605 //y=1.175 //x2=50.725 //y2=1.175
ends PM_TMRDFFSNRNQNX1\%noxref_49

subckt PM_TMRDFFSNRNQNX1\%noxref_50 ( 1 5 9 13 17 35 )
c49 ( 35 0 ) capacitor c=0.0673029f //x=53.855 //y=0.555
c50 ( 17 0 ) capacitor c=0.0178317f //x=55.845 //y=1.77
c51 ( 13 0 ) capacitor c=0.0154936f //x=55.845 //y=0.72
c52 ( 9 0 ) capacitor c=0.00678203f //x=54.96 //y=0.805
c53 ( 5 0 ) capacitor c=0.0164013f //x=54.875 //y=1.77
c54 ( 1 0 ) capacitor c=0.00696517f //x=53.99 //y=1.685
r55 (  18 35 ) resistor r=5.4201 //w=0.17 //l=0.103078 //layer=li \
 //thickness=0.1 //x=55.045 //y=1.77 //x2=54.96 //y2=1.81
r56 (  18 35 ) resistor r=27.3797 //w=0.187 //l=0.4 //layer=li //thickness=0.1 \
 //x=55.045 //y=1.77 //x2=55.445 //y2=1.77
r57 (  17 35 ) resistor r=0.751729 //w=0.17 //l=0.085 //layer=li \
 //thickness=0.1 //x=55.845 //y=1.77 //x2=55.93 //y2=1.77
r58 (  17 35 ) resistor r=27.3797 //w=0.187 //l=0.4 //layer=li //thickness=0.1 \
 //x=55.845 //y=1.77 //x2=55.445 //y2=1.77
r59 (  14 35 ) resistor r=3.57586 //w=0.17 //l=0.103078 //layer=li \
 //thickness=0.1 //x=55.045 //y=0.72 //x2=54.96 //y2=0.68
r60 (  14 35 ) resistor r=27.3797 //w=0.187 //l=0.4 //layer=li //thickness=0.1 \
 //x=55.045 //y=0.72 //x2=55.445 //y2=0.72
r61 (  13 35 ) resistor r=0.751729 //w=0.17 //l=0.085 //layer=li \
 //thickness=0.1 //x=55.845 //y=0.72 //x2=55.93 //y2=0.72
r62 (  13 35 ) resistor r=27.3797 //w=0.187 //l=0.4 //layer=li //thickness=0.1 \
 //x=55.845 //y=0.72 //x2=55.445 //y2=0.72
r63 (  10 35 ) resistor r=1.40859 //w=0.34 //l=0.125 //layer=li \
 //thickness=0.1 //x=54.96 //y=1.685 //x2=54.96 //y2=1.81
r64 (  10 35 ) resistor r=42.0963 //w=0.187 //l=0.615 //layer=li \
 //thickness=0.1 //x=54.96 //y=1.685 //x2=54.96 //y2=1.07
r65 (  9 35 ) resistor r=3.57586 //w=0.17 //l=0.125 //layer=li //thickness=0.1 \
 //x=54.96 //y=0.805 //x2=54.96 //y2=0.68
r66 (  9 35 ) resistor r=18.139 //w=0.187 //l=0.265 //layer=li //thickness=0.1 \
 //x=54.96 //y=0.805 //x2=54.96 //y2=1.07
r67 (  6 35 ) resistor r=3.57586 //w=0.17 //l=0.103078 //layer=li \
 //thickness=0.1 //x=54.075 //y=1.77 //x2=53.99 //y2=1.81
r68 (  6 35 ) resistor r=27.3797 //w=0.187 //l=0.4 //layer=li //thickness=0.1 \
 //x=54.075 //y=1.77 //x2=54.475 //y2=1.77
r69 (  5 35 ) resistor r=5.4201 //w=0.17 //l=0.103078 //layer=li \
 //thickness=0.1 //x=54.875 //y=1.77 //x2=54.96 //y2=1.81
r70 (  5 35 ) resistor r=27.3797 //w=0.187 //l=0.4 //layer=li //thickness=0.1 \
 //x=54.875 //y=1.77 //x2=54.475 //y2=1.77
r71 (  1 35 ) resistor r=3.57586 //w=0.17 //l=0.125 //layer=li //thickness=0.1 \
 //x=53.99 //y=1.685 //x2=53.99 //y2=1.81
r72 (  1 35 ) resistor r=42.0963 //w=0.187 //l=0.615 //layer=li \
 //thickness=0.1 //x=53.99 //y=1.685 //x2=53.99 //y2=1.07
ends PM_TMRDFFSNRNQNX1\%noxref_50

subckt PM_TMRDFFSNRNQNX1\%noxref_51 ( 1 3 11 15 25 28 29 )
c52 ( 29 0 ) capacitor c=0.0414744f //x=56.365 //y=0.555
c53 ( 28 0 ) capacitor c=0.0045748f //x=55.26 //y=1.09
c54 ( 25 0 ) capacitor c=0.00156479f //x=56.5 //y=1.175
c55 ( 15 0 ) capacitor c=0.00737666f //x=57.47 //y=0.805
c56 ( 11 0 ) capacitor c=0.0144274f //x=57.385 //y=0.72
c57 ( 3 0 ) capacitor c=0.00718386f //x=56.5 //y=0.805
c58 ( 1 0 ) capacitor c=0.0218888f //x=56.415 //y=1.175
r59 (  15 29 ) resistor r=3.57586 //w=0.17 //l=0.125 //layer=li \
 //thickness=0.1 //x=57.47 //y=0.805 //x2=57.47 //y2=0.68
r60 (  15 29 ) resistor r=18.139 //w=0.187 //l=0.265 //layer=li \
 //thickness=0.1 //x=57.47 //y=0.805 //x2=57.47 //y2=1.07
r61 (  12 29 ) resistor r=3.57586 //w=0.17 //l=0.103078 //layer=li \
 //thickness=0.1 //x=56.585 //y=0.72 //x2=56.5 //y2=0.68
r62 (  12 29 ) resistor r=27.3797 //w=0.187 //l=0.4 //layer=li //thickness=0.1 \
 //x=56.585 //y=0.72 //x2=56.985 //y2=0.72
r63 (  11 29 ) resistor r=3.57586 //w=0.17 //l=0.103078 //layer=li \
 //thickness=0.1 //x=57.385 //y=0.72 //x2=57.47 //y2=0.68
r64 (  11 29 ) resistor r=27.3797 //w=0.187 //l=0.4 //layer=li //thickness=0.1 \
 //x=57.385 //y=0.72 //x2=56.985 //y2=0.72
r65 (  7 25 ) resistor r=5.4201 //w=0.17 //l=0.085 //layer=li //thickness=0.1 \
 //x=56.5 //y=1.26 //x2=56.5 //y2=1.175
r66 (  7 29 ) resistor r=10.2674 //w=0.187 //l=0.15 //layer=li //thickness=0.1 \
 //x=56.5 //y=1.26 //x2=56.5 //y2=1.41
r67 (  4 25 ) resistor r=5.4201 //w=0.17 //l=0.085 //layer=li //thickness=0.1 \
 //x=56.5 //y=1.09 //x2=56.5 //y2=1.175
r68 (  4 29 ) resistor r=1.36898 //w=0.187 //l=0.02 //layer=li //thickness=0.1 \
 //x=56.5 //y=1.09 //x2=56.5 //y2=1.07
r69 (  3 29 ) resistor r=3.57586 //w=0.17 //l=0.125 //layer=li //thickness=0.1 \
 //x=56.5 //y=0.805 //x2=56.5 //y2=0.68
r70 (  3 29 ) resistor r=18.139 //w=0.187 //l=0.265 //layer=li //thickness=0.1 \
 //x=56.5 //y=0.805 //x2=56.5 //y2=1.07
r71 (  2 28 ) resistor r=0.751729 //w=0.17 //l=0.085 //layer=li \
 //thickness=0.1 //x=55.535 //y=1.175 //x2=55.45 //y2=1.175
r72 (  1 25 ) resistor r=1.40859 //w=0.34 //l=0.085 //layer=li //thickness=0.1 \
 //x=56.415 //y=1.175 //x2=56.5 //y2=1.175
r73 (  1 2 ) resistor r=60.2353 //w=0.187 //l=0.88 //layer=li //thickness=0.1 \
 //x=56.415 //y=1.175 //x2=55.535 //y2=1.175
ends PM_TMRDFFSNRNQNX1\%noxref_51

subckt PM_TMRDFFSNRNQNX1\%noxref_52 ( 1 5 9 13 17 35 )
c52 ( 35 0 ) capacitor c=0.0673029f //x=58.665 //y=0.555
c53 ( 17 0 ) capacitor c=0.0178286f //x=60.655 //y=1.77
c54 ( 13 0 ) capacitor c=0.0154917f //x=60.655 //y=0.72
c55 ( 9 0 ) capacitor c=0.00678203f //x=59.77 //y=0.805
c56 ( 5 0 ) capacitor c=0.0164013f //x=59.685 //y=1.77
c57 ( 1 0 ) capacitor c=0.00696517f //x=58.8 //y=1.685
r58 (  18 35 ) resistor r=5.4201 //w=0.17 //l=0.103078 //layer=li \
 //thickness=0.1 //x=59.855 //y=1.77 //x2=59.77 //y2=1.81
r59 (  18 35 ) resistor r=27.3797 //w=0.187 //l=0.4 //layer=li //thickness=0.1 \
 //x=59.855 //y=1.77 //x2=60.255 //y2=1.77
r60 (  17 35 ) resistor r=0.751729 //w=0.17 //l=0.085 //layer=li \
 //thickness=0.1 //x=60.655 //y=1.77 //x2=60.74 //y2=1.77
r61 (  17 35 ) resistor r=27.3797 //w=0.187 //l=0.4 //layer=li //thickness=0.1 \
 //x=60.655 //y=1.77 //x2=60.255 //y2=1.77
r62 (  14 35 ) resistor r=3.57586 //w=0.17 //l=0.103078 //layer=li \
 //thickness=0.1 //x=59.855 //y=0.72 //x2=59.77 //y2=0.68
r63 (  14 35 ) resistor r=27.3797 //w=0.187 //l=0.4 //layer=li //thickness=0.1 \
 //x=59.855 //y=0.72 //x2=60.255 //y2=0.72
r64 (  13 35 ) resistor r=0.751729 //w=0.17 //l=0.085 //layer=li \
 //thickness=0.1 //x=60.655 //y=0.72 //x2=60.74 //y2=0.72
r65 (  13 35 ) resistor r=27.3797 //w=0.187 //l=0.4 //layer=li //thickness=0.1 \
 //x=60.655 //y=0.72 //x2=60.255 //y2=0.72
r66 (  10 35 ) resistor r=1.40859 //w=0.34 //l=0.125 //layer=li \
 //thickness=0.1 //x=59.77 //y=1.685 //x2=59.77 //y2=1.81
r67 (  10 35 ) resistor r=42.0963 //w=0.187 //l=0.615 //layer=li \
 //thickness=0.1 //x=59.77 //y=1.685 //x2=59.77 //y2=1.07
r68 (  9 35 ) resistor r=3.57586 //w=0.17 //l=0.125 //layer=li //thickness=0.1 \
 //x=59.77 //y=0.805 //x2=59.77 //y2=0.68
r69 (  9 35 ) resistor r=18.139 //w=0.187 //l=0.265 //layer=li //thickness=0.1 \
 //x=59.77 //y=0.805 //x2=59.77 //y2=1.07
r70 (  6 35 ) resistor r=3.57586 //w=0.17 //l=0.103078 //layer=li \
 //thickness=0.1 //x=58.885 //y=1.77 //x2=58.8 //y2=1.81
r71 (  6 35 ) resistor r=27.3797 //w=0.187 //l=0.4 //layer=li //thickness=0.1 \
 //x=58.885 //y=1.77 //x2=59.285 //y2=1.77
r72 (  5 35 ) resistor r=5.4201 //w=0.17 //l=0.103078 //layer=li \
 //thickness=0.1 //x=59.685 //y=1.77 //x2=59.77 //y2=1.81
r73 (  5 35 ) resistor r=27.3797 //w=0.187 //l=0.4 //layer=li //thickness=0.1 \
 //x=59.685 //y=1.77 //x2=59.285 //y2=1.77
r74 (  1 35 ) resistor r=3.57586 //w=0.17 //l=0.125 //layer=li //thickness=0.1 \
 //x=58.8 //y=1.685 //x2=58.8 //y2=1.81
r75 (  1 35 ) resistor r=42.0963 //w=0.187 //l=0.615 //layer=li \
 //thickness=0.1 //x=58.8 //y=1.685 //x2=58.8 //y2=1.07
ends PM_TMRDFFSNRNQNX1\%noxref_52

subckt PM_TMRDFFSNRNQNX1\%noxref_53 ( 1 3 11 15 25 28 29 )
c52 ( 29 0 ) capacitor c=0.0414744f //x=61.175 //y=0.555
c53 ( 28 0 ) capacitor c=0.00457437f //x=60.07 //y=1.09
c54 ( 25 0 ) capacitor c=0.00156479f //x=61.31 //y=1.175
c55 ( 15 0 ) capacitor c=0.00737666f //x=62.28 //y=0.805
c56 ( 11 0 ) capacitor c=0.0144274f //x=62.195 //y=0.72
c57 ( 3 0 ) capacitor c=0.00718386f //x=61.31 //y=0.805
c58 ( 1 0 ) capacitor c=0.0218873f //x=61.225 //y=1.175
r59 (  15 29 ) resistor r=3.57586 //w=0.17 //l=0.125 //layer=li \
 //thickness=0.1 //x=62.28 //y=0.805 //x2=62.28 //y2=0.68
r60 (  15 29 ) resistor r=18.139 //w=0.187 //l=0.265 //layer=li \
 //thickness=0.1 //x=62.28 //y=0.805 //x2=62.28 //y2=1.07
r61 (  12 29 ) resistor r=3.57586 //w=0.17 //l=0.103078 //layer=li \
 //thickness=0.1 //x=61.395 //y=0.72 //x2=61.31 //y2=0.68
r62 (  12 29 ) resistor r=27.3797 //w=0.187 //l=0.4 //layer=li //thickness=0.1 \
 //x=61.395 //y=0.72 //x2=61.795 //y2=0.72
r63 (  11 29 ) resistor r=3.57586 //w=0.17 //l=0.103078 //layer=li \
 //thickness=0.1 //x=62.195 //y=0.72 //x2=62.28 //y2=0.68
r64 (  11 29 ) resistor r=27.3797 //w=0.187 //l=0.4 //layer=li //thickness=0.1 \
 //x=62.195 //y=0.72 //x2=61.795 //y2=0.72
r65 (  7 25 ) resistor r=5.4201 //w=0.17 //l=0.085 //layer=li //thickness=0.1 \
 //x=61.31 //y=1.26 //x2=61.31 //y2=1.175
r66 (  7 29 ) resistor r=10.2674 //w=0.187 //l=0.15 //layer=li //thickness=0.1 \
 //x=61.31 //y=1.26 //x2=61.31 //y2=1.41
r67 (  4 25 ) resistor r=5.4201 //w=0.17 //l=0.085 //layer=li //thickness=0.1 \
 //x=61.31 //y=1.09 //x2=61.31 //y2=1.175
r68 (  4 29 ) resistor r=1.36898 //w=0.187 //l=0.02 //layer=li //thickness=0.1 \
 //x=61.31 //y=1.09 //x2=61.31 //y2=1.07
r69 (  3 29 ) resistor r=3.57586 //w=0.17 //l=0.125 //layer=li //thickness=0.1 \
 //x=61.31 //y=0.805 //x2=61.31 //y2=0.68
r70 (  3 29 ) resistor r=18.139 //w=0.187 //l=0.265 //layer=li //thickness=0.1 \
 //x=61.31 //y=0.805 //x2=61.31 //y2=1.07
r71 (  2 28 ) resistor r=0.751729 //w=0.17 //l=0.085 //layer=li \
 //thickness=0.1 //x=60.345 //y=1.175 //x2=60.26 //y2=1.175
r72 (  1 25 ) resistor r=1.40859 //w=0.34 //l=0.085 //layer=li //thickness=0.1 \
 //x=61.225 //y=1.175 //x2=61.31 //y2=1.175
r73 (  1 2 ) resistor r=60.2353 //w=0.187 //l=0.88 //layer=li //thickness=0.1 \
 //x=61.225 //y=1.175 //x2=60.345 //y2=1.175
ends PM_TMRDFFSNRNQNX1\%noxref_53

subckt PM_TMRDFFSNRNQNX1\%noxref_54 ( 1 5 9 13 17 35 )
c49 ( 35 0 ) capacitor c=0.0673029f //x=63.475 //y=0.555
c50 ( 17 0 ) capacitor c=0.0178317f //x=65.465 //y=1.77
c51 ( 13 0 ) capacitor c=0.0154936f //x=65.465 //y=0.72
c52 ( 9 0 ) capacitor c=0.00678203f //x=64.58 //y=0.805
c53 ( 5 0 ) capacitor c=0.0164013f //x=64.495 //y=1.77
c54 ( 1 0 ) capacitor c=0.00696517f //x=63.61 //y=1.685
r55 (  18 35 ) resistor r=5.4201 //w=0.17 //l=0.103078 //layer=li \
 //thickness=0.1 //x=64.665 //y=1.77 //x2=64.58 //y2=1.81
r56 (  18 35 ) resistor r=27.3797 //w=0.187 //l=0.4 //layer=li //thickness=0.1 \
 //x=64.665 //y=1.77 //x2=65.065 //y2=1.77
r57 (  17 35 ) resistor r=0.751729 //w=0.17 //l=0.085 //layer=li \
 //thickness=0.1 //x=65.465 //y=1.77 //x2=65.55 //y2=1.77
r58 (  17 35 ) resistor r=27.3797 //w=0.187 //l=0.4 //layer=li //thickness=0.1 \
 //x=65.465 //y=1.77 //x2=65.065 //y2=1.77
r59 (  14 35 ) resistor r=3.57586 //w=0.17 //l=0.103078 //layer=li \
 //thickness=0.1 //x=64.665 //y=0.72 //x2=64.58 //y2=0.68
r60 (  14 35 ) resistor r=27.3797 //w=0.187 //l=0.4 //layer=li //thickness=0.1 \
 //x=64.665 //y=0.72 //x2=65.065 //y2=0.72
r61 (  13 35 ) resistor r=0.751729 //w=0.17 //l=0.085 //layer=li \
 //thickness=0.1 //x=65.465 //y=0.72 //x2=65.55 //y2=0.72
r62 (  13 35 ) resistor r=27.3797 //w=0.187 //l=0.4 //layer=li //thickness=0.1 \
 //x=65.465 //y=0.72 //x2=65.065 //y2=0.72
r63 (  10 35 ) resistor r=1.40859 //w=0.34 //l=0.125 //layer=li \
 //thickness=0.1 //x=64.58 //y=1.685 //x2=64.58 //y2=1.81
r64 (  10 35 ) resistor r=42.0963 //w=0.187 //l=0.615 //layer=li \
 //thickness=0.1 //x=64.58 //y=1.685 //x2=64.58 //y2=1.07
r65 (  9 35 ) resistor r=3.57586 //w=0.17 //l=0.125 //layer=li //thickness=0.1 \
 //x=64.58 //y=0.805 //x2=64.58 //y2=0.68
r66 (  9 35 ) resistor r=18.139 //w=0.187 //l=0.265 //layer=li //thickness=0.1 \
 //x=64.58 //y=0.805 //x2=64.58 //y2=1.07
r67 (  6 35 ) resistor r=3.57586 //w=0.17 //l=0.103078 //layer=li \
 //thickness=0.1 //x=63.695 //y=1.77 //x2=63.61 //y2=1.81
r68 (  6 35 ) resistor r=27.3797 //w=0.187 //l=0.4 //layer=li //thickness=0.1 \
 //x=63.695 //y=1.77 //x2=64.095 //y2=1.77
r69 (  5 35 ) resistor r=5.4201 //w=0.17 //l=0.103078 //layer=li \
 //thickness=0.1 //x=64.495 //y=1.77 //x2=64.58 //y2=1.81
r70 (  5 35 ) resistor r=27.3797 //w=0.187 //l=0.4 //layer=li //thickness=0.1 \
 //x=64.495 //y=1.77 //x2=64.095 //y2=1.77
r71 (  1 35 ) resistor r=3.57586 //w=0.17 //l=0.125 //layer=li //thickness=0.1 \
 //x=63.61 //y=1.685 //x2=63.61 //y2=1.81
r72 (  1 35 ) resistor r=42.0963 //w=0.187 //l=0.615 //layer=li \
 //thickness=0.1 //x=63.61 //y=1.685 //x2=63.61 //y2=1.07
ends PM_TMRDFFSNRNQNX1\%noxref_54

subckt PM_TMRDFFSNRNQNX1\%noxref_55 ( 1 3 11 15 25 28 29 )
c52 ( 29 0 ) capacitor c=0.0413887f //x=65.985 //y=0.555
c53 ( 28 0 ) capacitor c=0.0045748f //x=64.88 //y=1.09
c54 ( 25 0 ) capacitor c=0.00156479f //x=66.12 //y=1.175
c55 ( 15 0 ) capacitor c=0.00737666f //x=67.09 //y=0.805
c56 ( 11 0 ) capacitor c=0.0144274f //x=67.005 //y=0.72
c57 ( 3 0 ) capacitor c=0.00718386f //x=66.12 //y=0.805
c58 ( 1 0 ) capacitor c=0.0218888f //x=66.035 //y=1.175
r59 (  15 29 ) resistor r=3.57586 //w=0.17 //l=0.125 //layer=li \
 //thickness=0.1 //x=67.09 //y=0.805 //x2=67.09 //y2=0.68
r60 (  15 29 ) resistor r=18.139 //w=0.187 //l=0.265 //layer=li \
 //thickness=0.1 //x=67.09 //y=0.805 //x2=67.09 //y2=1.07
r61 (  12 29 ) resistor r=3.57586 //w=0.17 //l=0.103078 //layer=li \
 //thickness=0.1 //x=66.205 //y=0.72 //x2=66.12 //y2=0.68
r62 (  12 29 ) resistor r=27.3797 //w=0.187 //l=0.4 //layer=li //thickness=0.1 \
 //x=66.205 //y=0.72 //x2=66.605 //y2=0.72
r63 (  11 29 ) resistor r=3.57586 //w=0.17 //l=0.103078 //layer=li \
 //thickness=0.1 //x=67.005 //y=0.72 //x2=67.09 //y2=0.68
r64 (  11 29 ) resistor r=27.3797 //w=0.187 //l=0.4 //layer=li //thickness=0.1 \
 //x=67.005 //y=0.72 //x2=66.605 //y2=0.72
r65 (  7 25 ) resistor r=5.4201 //w=0.17 //l=0.085 //layer=li //thickness=0.1 \
 //x=66.12 //y=1.26 //x2=66.12 //y2=1.175
r66 (  7 29 ) resistor r=10.2674 //w=0.187 //l=0.15 //layer=li //thickness=0.1 \
 //x=66.12 //y=1.26 //x2=66.12 //y2=1.41
r67 (  4 25 ) resistor r=5.4201 //w=0.17 //l=0.085 //layer=li //thickness=0.1 \
 //x=66.12 //y=1.09 //x2=66.12 //y2=1.175
r68 (  4 29 ) resistor r=1.36898 //w=0.187 //l=0.02 //layer=li //thickness=0.1 \
 //x=66.12 //y=1.09 //x2=66.12 //y2=1.07
r69 (  3 29 ) resistor r=3.57586 //w=0.17 //l=0.125 //layer=li //thickness=0.1 \
 //x=66.12 //y=0.805 //x2=66.12 //y2=0.68
r70 (  3 29 ) resistor r=18.139 //w=0.187 //l=0.265 //layer=li //thickness=0.1 \
 //x=66.12 //y=0.805 //x2=66.12 //y2=1.07
r71 (  2 28 ) resistor r=0.751729 //w=0.17 //l=0.085 //layer=li \
 //thickness=0.1 //x=65.155 //y=1.175 //x2=65.07 //y2=1.175
r72 (  1 25 ) resistor r=1.40859 //w=0.34 //l=0.085 //layer=li //thickness=0.1 \
 //x=66.035 //y=1.175 //x2=66.12 //y2=1.175
r73 (  1 2 ) resistor r=60.2353 //w=0.187 //l=0.88 //layer=li //thickness=0.1 \
 //x=66.035 //y=1.175 //x2=65.155 //y2=1.175
ends PM_TMRDFFSNRNQNX1\%noxref_55

subckt PM_TMRDFFSNRNQNX1\%noxref_56 ( 1 5 9 13 17 35 )
c49 ( 35 0 ) capacitor c=0.0673029f //x=68.285 //y=0.555
c50 ( 17 0 ) capacitor c=0.0178317f //x=70.275 //y=1.77
c51 ( 13 0 ) capacitor c=0.0154936f //x=70.275 //y=0.72
c52 ( 9 0 ) capacitor c=0.00678203f //x=69.39 //y=0.805
c53 ( 5 0 ) capacitor c=0.0164013f //x=69.305 //y=1.77
c54 ( 1 0 ) capacitor c=0.00696517f //x=68.42 //y=1.685
r55 (  18 35 ) resistor r=5.4201 //w=0.17 //l=0.103078 //layer=li \
 //thickness=0.1 //x=69.475 //y=1.77 //x2=69.39 //y2=1.81
r56 (  18 35 ) resistor r=27.3797 //w=0.187 //l=0.4 //layer=li //thickness=0.1 \
 //x=69.475 //y=1.77 //x2=69.875 //y2=1.77
r57 (  17 35 ) resistor r=0.751729 //w=0.17 //l=0.085 //layer=li \
 //thickness=0.1 //x=70.275 //y=1.77 //x2=70.36 //y2=1.77
r58 (  17 35 ) resistor r=27.3797 //w=0.187 //l=0.4 //layer=li //thickness=0.1 \
 //x=70.275 //y=1.77 //x2=69.875 //y2=1.77
r59 (  14 35 ) resistor r=3.57586 //w=0.17 //l=0.103078 //layer=li \
 //thickness=0.1 //x=69.475 //y=0.72 //x2=69.39 //y2=0.68
r60 (  14 35 ) resistor r=27.3797 //w=0.187 //l=0.4 //layer=li //thickness=0.1 \
 //x=69.475 //y=0.72 //x2=69.875 //y2=0.72
r61 (  13 35 ) resistor r=0.751729 //w=0.17 //l=0.085 //layer=li \
 //thickness=0.1 //x=70.275 //y=0.72 //x2=70.36 //y2=0.72
r62 (  13 35 ) resistor r=27.3797 //w=0.187 //l=0.4 //layer=li //thickness=0.1 \
 //x=70.275 //y=0.72 //x2=69.875 //y2=0.72
r63 (  10 35 ) resistor r=1.40859 //w=0.34 //l=0.125 //layer=li \
 //thickness=0.1 //x=69.39 //y=1.685 //x2=69.39 //y2=1.81
r64 (  10 35 ) resistor r=42.0963 //w=0.187 //l=0.615 //layer=li \
 //thickness=0.1 //x=69.39 //y=1.685 //x2=69.39 //y2=1.07
r65 (  9 35 ) resistor r=3.57586 //w=0.17 //l=0.125 //layer=li //thickness=0.1 \
 //x=69.39 //y=0.805 //x2=69.39 //y2=0.68
r66 (  9 35 ) resistor r=18.139 //w=0.187 //l=0.265 //layer=li //thickness=0.1 \
 //x=69.39 //y=0.805 //x2=69.39 //y2=1.07
r67 (  6 35 ) resistor r=3.57586 //w=0.17 //l=0.103078 //layer=li \
 //thickness=0.1 //x=68.505 //y=1.77 //x2=68.42 //y2=1.81
r68 (  6 35 ) resistor r=27.3797 //w=0.187 //l=0.4 //layer=li //thickness=0.1 \
 //x=68.505 //y=1.77 //x2=68.905 //y2=1.77
r69 (  5 35 ) resistor r=5.4201 //w=0.17 //l=0.103078 //layer=li \
 //thickness=0.1 //x=69.305 //y=1.77 //x2=69.39 //y2=1.81
r70 (  5 35 ) resistor r=27.3797 //w=0.187 //l=0.4 //layer=li //thickness=0.1 \
 //x=69.305 //y=1.77 //x2=68.905 //y2=1.77
r71 (  1 35 ) resistor r=3.57586 //w=0.17 //l=0.125 //layer=li //thickness=0.1 \
 //x=68.42 //y=1.685 //x2=68.42 //y2=1.81
r72 (  1 35 ) resistor r=42.0963 //w=0.187 //l=0.615 //layer=li \
 //thickness=0.1 //x=68.42 //y=1.685 //x2=68.42 //y2=1.07
ends PM_TMRDFFSNRNQNX1\%noxref_56

subckt PM_TMRDFFSNRNQNX1\%noxref_57 ( 1 3 11 15 25 28 29 )
c52 ( 29 0 ) capacitor c=0.0414744f //x=70.795 //y=0.555
c53 ( 28 0 ) capacitor c=0.0045748f //x=69.69 //y=1.09
c54 ( 25 0 ) capacitor c=0.00156479f //x=70.93 //y=1.175
c55 ( 15 0 ) capacitor c=0.00737666f //x=71.9 //y=0.805
c56 ( 11 0 ) capacitor c=0.0144274f //x=71.815 //y=0.72
c57 ( 3 0 ) capacitor c=0.00718386f //x=70.93 //y=0.805
c58 ( 1 0 ) capacitor c=0.0218888f //x=70.845 //y=1.175
r59 (  15 29 ) resistor r=3.57586 //w=0.17 //l=0.125 //layer=li \
 //thickness=0.1 //x=71.9 //y=0.805 //x2=71.9 //y2=0.68
r60 (  15 29 ) resistor r=18.139 //w=0.187 //l=0.265 //layer=li \
 //thickness=0.1 //x=71.9 //y=0.805 //x2=71.9 //y2=1.07
r61 (  12 29 ) resistor r=3.57586 //w=0.17 //l=0.103078 //layer=li \
 //thickness=0.1 //x=71.015 //y=0.72 //x2=70.93 //y2=0.68
r62 (  12 29 ) resistor r=27.3797 //w=0.187 //l=0.4 //layer=li //thickness=0.1 \
 //x=71.015 //y=0.72 //x2=71.415 //y2=0.72
r63 (  11 29 ) resistor r=3.57586 //w=0.17 //l=0.103078 //layer=li \
 //thickness=0.1 //x=71.815 //y=0.72 //x2=71.9 //y2=0.68
r64 (  11 29 ) resistor r=27.3797 //w=0.187 //l=0.4 //layer=li //thickness=0.1 \
 //x=71.815 //y=0.72 //x2=71.415 //y2=0.72
r65 (  7 25 ) resistor r=5.4201 //w=0.17 //l=0.085 //layer=li //thickness=0.1 \
 //x=70.93 //y=1.26 //x2=70.93 //y2=1.175
r66 (  7 29 ) resistor r=10.2674 //w=0.187 //l=0.15 //layer=li //thickness=0.1 \
 //x=70.93 //y=1.26 //x2=70.93 //y2=1.41
r67 (  4 25 ) resistor r=5.4201 //w=0.17 //l=0.085 //layer=li //thickness=0.1 \
 //x=70.93 //y=1.09 //x2=70.93 //y2=1.175
r68 (  4 29 ) resistor r=1.36898 //w=0.187 //l=0.02 //layer=li //thickness=0.1 \
 //x=70.93 //y=1.09 //x2=70.93 //y2=1.07
r69 (  3 29 ) resistor r=3.57586 //w=0.17 //l=0.125 //layer=li //thickness=0.1 \
 //x=70.93 //y=0.805 //x2=70.93 //y2=0.68
r70 (  3 29 ) resistor r=18.139 //w=0.187 //l=0.265 //layer=li //thickness=0.1 \
 //x=70.93 //y=0.805 //x2=70.93 //y2=1.07
r71 (  2 28 ) resistor r=0.751729 //w=0.17 //l=0.085 //layer=li \
 //thickness=0.1 //x=69.965 //y=1.175 //x2=69.88 //y2=1.175
r72 (  1 25 ) resistor r=1.40859 //w=0.34 //l=0.085 //layer=li //thickness=0.1 \
 //x=70.845 //y=1.175 //x2=70.93 //y2=1.175
r73 (  1 2 ) resistor r=60.2353 //w=0.187 //l=0.88 //layer=li //thickness=0.1 \
 //x=70.845 //y=1.175 //x2=69.965 //y2=1.175
ends PM_TMRDFFSNRNQNX1\%noxref_57

subckt PM_TMRDFFSNRNQNX1\%noxref_58 ( 1 5 9 13 17 35 )
c49 ( 35 0 ) capacitor c=0.0673029f //x=73.095 //y=0.555
c50 ( 17 0 ) capacitor c=0.0178317f //x=75.085 //y=1.77
c51 ( 13 0 ) capacitor c=0.0154936f //x=75.085 //y=0.72
c52 ( 9 0 ) capacitor c=0.00678203f //x=74.2 //y=0.805
c53 ( 5 0 ) capacitor c=0.0164013f //x=74.115 //y=1.77
c54 ( 1 0 ) capacitor c=0.00696517f //x=73.23 //y=1.685
r55 (  18 35 ) resistor r=5.4201 //w=0.17 //l=0.103078 //layer=li \
 //thickness=0.1 //x=74.285 //y=1.77 //x2=74.2 //y2=1.81
r56 (  18 35 ) resistor r=27.3797 //w=0.187 //l=0.4 //layer=li //thickness=0.1 \
 //x=74.285 //y=1.77 //x2=74.685 //y2=1.77
r57 (  17 35 ) resistor r=0.751729 //w=0.17 //l=0.085 //layer=li \
 //thickness=0.1 //x=75.085 //y=1.77 //x2=75.17 //y2=1.77
r58 (  17 35 ) resistor r=27.3797 //w=0.187 //l=0.4 //layer=li //thickness=0.1 \
 //x=75.085 //y=1.77 //x2=74.685 //y2=1.77
r59 (  14 35 ) resistor r=3.57586 //w=0.17 //l=0.103078 //layer=li \
 //thickness=0.1 //x=74.285 //y=0.72 //x2=74.2 //y2=0.68
r60 (  14 35 ) resistor r=27.3797 //w=0.187 //l=0.4 //layer=li //thickness=0.1 \
 //x=74.285 //y=0.72 //x2=74.685 //y2=0.72
r61 (  13 35 ) resistor r=0.751729 //w=0.17 //l=0.085 //layer=li \
 //thickness=0.1 //x=75.085 //y=0.72 //x2=75.17 //y2=0.72
r62 (  13 35 ) resistor r=27.3797 //w=0.187 //l=0.4 //layer=li //thickness=0.1 \
 //x=75.085 //y=0.72 //x2=74.685 //y2=0.72
r63 (  10 35 ) resistor r=1.40859 //w=0.34 //l=0.125 //layer=li \
 //thickness=0.1 //x=74.2 //y=1.685 //x2=74.2 //y2=1.81
r64 (  10 35 ) resistor r=42.0963 //w=0.187 //l=0.615 //layer=li \
 //thickness=0.1 //x=74.2 //y=1.685 //x2=74.2 //y2=1.07
r65 (  9 35 ) resistor r=3.57586 //w=0.17 //l=0.125 //layer=li //thickness=0.1 \
 //x=74.2 //y=0.805 //x2=74.2 //y2=0.68
r66 (  9 35 ) resistor r=18.139 //w=0.187 //l=0.265 //layer=li //thickness=0.1 \
 //x=74.2 //y=0.805 //x2=74.2 //y2=1.07
r67 (  6 35 ) resistor r=3.57586 //w=0.17 //l=0.103078 //layer=li \
 //thickness=0.1 //x=73.315 //y=1.77 //x2=73.23 //y2=1.81
r68 (  6 35 ) resistor r=27.3797 //w=0.187 //l=0.4 //layer=li //thickness=0.1 \
 //x=73.315 //y=1.77 //x2=73.715 //y2=1.77
r69 (  5 35 ) resistor r=5.4201 //w=0.17 //l=0.103078 //layer=li \
 //thickness=0.1 //x=74.115 //y=1.77 //x2=74.2 //y2=1.81
r70 (  5 35 ) resistor r=27.3797 //w=0.187 //l=0.4 //layer=li //thickness=0.1 \
 //x=74.115 //y=1.77 //x2=73.715 //y2=1.77
r71 (  1 35 ) resistor r=3.57586 //w=0.17 //l=0.125 //layer=li //thickness=0.1 \
 //x=73.23 //y=1.685 //x2=73.23 //y2=1.81
r72 (  1 35 ) resistor r=42.0963 //w=0.187 //l=0.615 //layer=li \
 //thickness=0.1 //x=73.23 //y=1.685 //x2=73.23 //y2=1.07
ends PM_TMRDFFSNRNQNX1\%noxref_58

subckt PM_TMRDFFSNRNQNX1\%noxref_59 ( 1 3 11 15 25 28 29 )
c53 ( 29 0 ) capacitor c=0.0413887f //x=75.605 //y=0.555
c54 ( 28 0 ) capacitor c=0.0045748f //x=74.5 //y=1.09
c55 ( 25 0 ) capacitor c=0.00156479f //x=75.74 //y=1.175
c56 ( 15 0 ) capacitor c=0.00737666f //x=76.71 //y=0.805
c57 ( 11 0 ) capacitor c=0.0144218f //x=76.625 //y=0.72
c58 ( 3 0 ) capacitor c=0.00718386f //x=75.74 //y=0.805
c59 ( 1 0 ) capacitor c=0.0218888f //x=75.655 //y=1.175
r60 (  15 29 ) resistor r=3.57586 //w=0.17 //l=0.125 //layer=li \
 //thickness=0.1 //x=76.71 //y=0.805 //x2=76.71 //y2=0.68
r61 (  15 29 ) resistor r=18.139 //w=0.187 //l=0.265 //layer=li \
 //thickness=0.1 //x=76.71 //y=0.805 //x2=76.71 //y2=1.07
r62 (  12 29 ) resistor r=3.57586 //w=0.17 //l=0.103078 //layer=li \
 //thickness=0.1 //x=75.825 //y=0.72 //x2=75.74 //y2=0.68
r63 (  12 29 ) resistor r=27.3797 //w=0.187 //l=0.4 //layer=li //thickness=0.1 \
 //x=75.825 //y=0.72 //x2=76.225 //y2=0.72
r64 (  11 29 ) resistor r=3.57586 //w=0.17 //l=0.103078 //layer=li \
 //thickness=0.1 //x=76.625 //y=0.72 //x2=76.71 //y2=0.68
r65 (  11 29 ) resistor r=27.3797 //w=0.187 //l=0.4 //layer=li //thickness=0.1 \
 //x=76.625 //y=0.72 //x2=76.225 //y2=0.72
r66 (  7 25 ) resistor r=5.4201 //w=0.17 //l=0.085 //layer=li //thickness=0.1 \
 //x=75.74 //y=1.26 //x2=75.74 //y2=1.175
r67 (  7 29 ) resistor r=10.2674 //w=0.187 //l=0.15 //layer=li //thickness=0.1 \
 //x=75.74 //y=1.26 //x2=75.74 //y2=1.41
r68 (  4 25 ) resistor r=5.4201 //w=0.17 //l=0.085 //layer=li //thickness=0.1 \
 //x=75.74 //y=1.09 //x2=75.74 //y2=1.175
r69 (  4 29 ) resistor r=1.36898 //w=0.187 //l=0.02 //layer=li //thickness=0.1 \
 //x=75.74 //y=1.09 //x2=75.74 //y2=1.07
r70 (  3 29 ) resistor r=3.57586 //w=0.17 //l=0.125 //layer=li //thickness=0.1 \
 //x=75.74 //y=0.805 //x2=75.74 //y2=0.68
r71 (  3 29 ) resistor r=18.139 //w=0.187 //l=0.265 //layer=li //thickness=0.1 \
 //x=75.74 //y=0.805 //x2=75.74 //y2=1.07
r72 (  2 28 ) resistor r=0.751729 //w=0.17 //l=0.085 //layer=li \
 //thickness=0.1 //x=74.775 //y=1.175 //x2=74.69 //y2=1.175
r73 (  1 25 ) resistor r=1.40859 //w=0.34 //l=0.085 //layer=li //thickness=0.1 \
 //x=75.655 //y=1.175 //x2=75.74 //y2=1.175
r74 (  1 2 ) resistor r=60.2353 //w=0.187 //l=0.88 //layer=li //thickness=0.1 \
 //x=75.655 //y=1.175 //x2=74.775 //y2=1.175
ends PM_TMRDFFSNRNQNX1\%noxref_59

subckt PM_TMRDFFSNRNQNX1\%noxref_60 ( 1 5 9 13 17 35 )
c51 ( 35 0 ) capacitor c=0.0680259f //x=77.905 //y=0.555
c52 ( 17 0 ) capacitor c=0.0180446f //x=79.895 //y=1.77
c53 ( 13 0 ) capacitor c=0.0155283f //x=79.895 //y=0.72
c54 ( 9 0 ) capacitor c=0.00678203f //x=79.01 //y=0.805
c55 ( 5 0 ) capacitor c=0.0164013f //x=78.925 //y=1.77
c56 ( 1 0 ) capacitor c=0.00696517f //x=78.04 //y=1.685
r57 (  18 35 ) resistor r=5.4201 //w=0.17 //l=0.103078 //layer=li \
 //thickness=0.1 //x=79.095 //y=1.77 //x2=79.01 //y2=1.81
r58 (  18 35 ) resistor r=27.3797 //w=0.187 //l=0.4 //layer=li //thickness=0.1 \
 //x=79.095 //y=1.77 //x2=79.495 //y2=1.77
r59 (  17 35 ) resistor r=0.751729 //w=0.17 //l=0.085 //layer=li \
 //thickness=0.1 //x=79.895 //y=1.77 //x2=79.98 //y2=1.77
r60 (  17 35 ) resistor r=27.3797 //w=0.187 //l=0.4 //layer=li //thickness=0.1 \
 //x=79.895 //y=1.77 //x2=79.495 //y2=1.77
r61 (  14 35 ) resistor r=3.57586 //w=0.17 //l=0.103078 //layer=li \
 //thickness=0.1 //x=79.095 //y=0.72 //x2=79.01 //y2=0.68
r62 (  14 35 ) resistor r=27.3797 //w=0.187 //l=0.4 //layer=li //thickness=0.1 \
 //x=79.095 //y=0.72 //x2=79.495 //y2=0.72
r63 (  13 35 ) resistor r=0.751729 //w=0.17 //l=0.085 //layer=li \
 //thickness=0.1 //x=79.895 //y=0.72 //x2=79.98 //y2=0.72
r64 (  13 35 ) resistor r=27.3797 //w=0.187 //l=0.4 //layer=li //thickness=0.1 \
 //x=79.895 //y=0.72 //x2=79.495 //y2=0.72
r65 (  10 35 ) resistor r=1.40859 //w=0.34 //l=0.125 //layer=li \
 //thickness=0.1 //x=79.01 //y=1.685 //x2=79.01 //y2=1.81
r66 (  10 35 ) resistor r=42.0963 //w=0.187 //l=0.615 //layer=li \
 //thickness=0.1 //x=79.01 //y=1.685 //x2=79.01 //y2=1.07
r67 (  9 35 ) resistor r=3.57586 //w=0.17 //l=0.125 //layer=li //thickness=0.1 \
 //x=79.01 //y=0.805 //x2=79.01 //y2=0.68
r68 (  9 35 ) resistor r=18.139 //w=0.187 //l=0.265 //layer=li //thickness=0.1 \
 //x=79.01 //y=0.805 //x2=79.01 //y2=1.07
r69 (  6 35 ) resistor r=3.57586 //w=0.17 //l=0.103078 //layer=li \
 //thickness=0.1 //x=78.125 //y=1.77 //x2=78.04 //y2=1.81
r70 (  6 35 ) resistor r=27.3797 //w=0.187 //l=0.4 //layer=li //thickness=0.1 \
 //x=78.125 //y=1.77 //x2=78.525 //y2=1.77
r71 (  5 35 ) resistor r=5.4201 //w=0.17 //l=0.103078 //layer=li \
 //thickness=0.1 //x=78.925 //y=1.77 //x2=79.01 //y2=1.81
r72 (  5 35 ) resistor r=27.3797 //w=0.187 //l=0.4 //layer=li //thickness=0.1 \
 //x=78.925 //y=1.77 //x2=78.525 //y2=1.77
r73 (  1 35 ) resistor r=3.57586 //w=0.17 //l=0.125 //layer=li //thickness=0.1 \
 //x=78.04 //y=1.685 //x2=78.04 //y2=1.81
r74 (  1 35 ) resistor r=42.0963 //w=0.187 //l=0.615 //layer=li \
 //thickness=0.1 //x=78.04 //y=1.685 //x2=78.04 //y2=1.07
ends PM_TMRDFFSNRNQNX1\%noxref_60

subckt PM_TMRDFFSNRNQNX1\%noxref_61 ( 1 3 11 15 25 28 29 )
c54 ( 29 0 ) capacitor c=0.0420321f //x=80.415 //y=0.555
c55 ( 28 0 ) capacitor c=0.00457437f //x=79.31 //y=1.09
c56 ( 25 0 ) capacitor c=0.00156479f //x=80.55 //y=1.175
c57 ( 15 0 ) capacitor c=0.00737666f //x=81.52 //y=0.805
c58 ( 11 0 ) capacitor c=0.0145658f //x=81.435 //y=0.72
c59 ( 3 0 ) capacitor c=0.00718386f //x=80.55 //y=0.805
c60 ( 1 0 ) capacitor c=0.0234159f //x=80.465 //y=1.175
r61 (  15 29 ) resistor r=3.57586 //w=0.17 //l=0.125 //layer=li \
 //thickness=0.1 //x=81.52 //y=0.805 //x2=81.52 //y2=0.68
r62 (  15 29 ) resistor r=18.139 //w=0.187 //l=0.265 //layer=li \
 //thickness=0.1 //x=81.52 //y=0.805 //x2=81.52 //y2=1.07
r63 (  12 29 ) resistor r=3.57586 //w=0.17 //l=0.103078 //layer=li \
 //thickness=0.1 //x=80.635 //y=0.72 //x2=80.55 //y2=0.68
r64 (  12 29 ) resistor r=27.3797 //w=0.187 //l=0.4 //layer=li //thickness=0.1 \
 //x=80.635 //y=0.72 //x2=81.035 //y2=0.72
r65 (  11 29 ) resistor r=3.57586 //w=0.17 //l=0.103078 //layer=li \
 //thickness=0.1 //x=81.435 //y=0.72 //x2=81.52 //y2=0.68
r66 (  11 29 ) resistor r=27.3797 //w=0.187 //l=0.4 //layer=li //thickness=0.1 \
 //x=81.435 //y=0.72 //x2=81.035 //y2=0.72
r67 (  7 25 ) resistor r=5.4201 //w=0.17 //l=0.085 //layer=li //thickness=0.1 \
 //x=80.55 //y=1.26 //x2=80.55 //y2=1.175
r68 (  7 29 ) resistor r=10.2674 //w=0.187 //l=0.15 //layer=li //thickness=0.1 \
 //x=80.55 //y=1.26 //x2=80.55 //y2=1.41
r69 (  4 25 ) resistor r=5.4201 //w=0.17 //l=0.085 //layer=li //thickness=0.1 \
 //x=80.55 //y=1.09 //x2=80.55 //y2=1.175
r70 (  4 29 ) resistor r=1.36898 //w=0.187 //l=0.02 //layer=li //thickness=0.1 \
 //x=80.55 //y=1.09 //x2=80.55 //y2=1.07
r71 (  3 29 ) resistor r=3.57586 //w=0.17 //l=0.125 //layer=li //thickness=0.1 \
 //x=80.55 //y=0.805 //x2=80.55 //y2=0.68
r72 (  3 29 ) resistor r=18.139 //w=0.187 //l=0.265 //layer=li //thickness=0.1 \
 //x=80.55 //y=0.805 //x2=80.55 //y2=1.07
r73 (  2 28 ) resistor r=0.751729 //w=0.17 //l=0.085 //layer=li \
 //thickness=0.1 //x=79.585 //y=1.175 //x2=79.5 //y2=1.175
r74 (  1 25 ) resistor r=1.40859 //w=0.34 //l=0.085 //layer=li //thickness=0.1 \
 //x=80.465 //y=1.175 //x2=80.55 //y2=1.175
r75 (  1 2 ) resistor r=60.2353 //w=0.187 //l=0.88 //layer=li //thickness=0.1 \
 //x=80.465 //y=1.175 //x2=79.585 //y2=1.175
ends PM_TMRDFFSNRNQNX1\%noxref_61

subckt PM_TMRDFFSNRNQNX1\%noxref_62 ( 1 5 9 13 17 35 )
c51 ( 35 0 ) capacitor c=0.0673029f //x=82.715 //y=0.555
c52 ( 17 0 ) capacitor c=0.0178317f //x=84.705 //y=1.77
c53 ( 13 0 ) capacitor c=0.0154936f //x=84.705 //y=0.72
c54 ( 9 0 ) capacitor c=0.00678203f //x=83.82 //y=0.805
c55 ( 5 0 ) capacitor c=0.0163955f //x=83.735 //y=1.77
c56 ( 1 0 ) capacitor c=0.00696517f //x=82.85 //y=1.685
r57 (  18 35 ) resistor r=5.4201 //w=0.17 //l=0.103078 //layer=li \
 //thickness=0.1 //x=83.905 //y=1.77 //x2=83.82 //y2=1.81
r58 (  18 35 ) resistor r=27.3797 //w=0.187 //l=0.4 //layer=li //thickness=0.1 \
 //x=83.905 //y=1.77 //x2=84.305 //y2=1.77
r59 (  17 35 ) resistor r=0.751729 //w=0.17 //l=0.085 //layer=li \
 //thickness=0.1 //x=84.705 //y=1.77 //x2=84.79 //y2=1.77
r60 (  17 35 ) resistor r=27.3797 //w=0.187 //l=0.4 //layer=li //thickness=0.1 \
 //x=84.705 //y=1.77 //x2=84.305 //y2=1.77
r61 (  14 35 ) resistor r=3.57586 //w=0.17 //l=0.103078 //layer=li \
 //thickness=0.1 //x=83.905 //y=0.72 //x2=83.82 //y2=0.68
r62 (  14 35 ) resistor r=27.3797 //w=0.187 //l=0.4 //layer=li //thickness=0.1 \
 //x=83.905 //y=0.72 //x2=84.305 //y2=0.72
r63 (  13 35 ) resistor r=0.751729 //w=0.17 //l=0.085 //layer=li \
 //thickness=0.1 //x=84.705 //y=0.72 //x2=84.79 //y2=0.72
r64 (  13 35 ) resistor r=27.3797 //w=0.187 //l=0.4 //layer=li //thickness=0.1 \
 //x=84.705 //y=0.72 //x2=84.305 //y2=0.72
r65 (  10 35 ) resistor r=1.40859 //w=0.34 //l=0.125 //layer=li \
 //thickness=0.1 //x=83.82 //y=1.685 //x2=83.82 //y2=1.81
r66 (  10 35 ) resistor r=42.0963 //w=0.187 //l=0.615 //layer=li \
 //thickness=0.1 //x=83.82 //y=1.685 //x2=83.82 //y2=1.07
r67 (  9 35 ) resistor r=3.57586 //w=0.17 //l=0.125 //layer=li //thickness=0.1 \
 //x=83.82 //y=0.805 //x2=83.82 //y2=0.68
r68 (  9 35 ) resistor r=18.139 //w=0.187 //l=0.265 //layer=li //thickness=0.1 \
 //x=83.82 //y=0.805 //x2=83.82 //y2=1.07
r69 (  6 35 ) resistor r=3.57586 //w=0.17 //l=0.103078 //layer=li \
 //thickness=0.1 //x=82.935 //y=1.77 //x2=82.85 //y2=1.81
r70 (  6 35 ) resistor r=27.3797 //w=0.187 //l=0.4 //layer=li //thickness=0.1 \
 //x=82.935 //y=1.77 //x2=83.335 //y2=1.77
r71 (  5 35 ) resistor r=5.4201 //w=0.17 //l=0.103078 //layer=li \
 //thickness=0.1 //x=83.735 //y=1.77 //x2=83.82 //y2=1.81
r72 (  5 35 ) resistor r=27.3797 //w=0.187 //l=0.4 //layer=li //thickness=0.1 \
 //x=83.735 //y=1.77 //x2=83.335 //y2=1.77
r73 (  1 35 ) resistor r=3.57586 //w=0.17 //l=0.125 //layer=li //thickness=0.1 \
 //x=82.85 //y=1.685 //x2=82.85 //y2=1.81
r74 (  1 35 ) resistor r=42.0963 //w=0.187 //l=0.615 //layer=li \
 //thickness=0.1 //x=82.85 //y=1.685 //x2=82.85 //y2=1.07
ends PM_TMRDFFSNRNQNX1\%noxref_62

subckt PM_TMRDFFSNRNQNX1\%noxref_63 ( 1 3 11 15 25 28 29 )
c52 ( 29 0 ) capacitor c=0.041346f //x=85.225 //y=0.555
c53 ( 28 0 ) capacitor c=0.0045748f //x=84.12 //y=1.09
c54 ( 25 0 ) capacitor c=0.00156479f //x=85.36 //y=1.175
c55 ( 15 0 ) capacitor c=0.00737666f //x=86.33 //y=0.805
c56 ( 11 0 ) capacitor c=0.0144274f //x=86.245 //y=0.72
c57 ( 3 0 ) capacitor c=0.00718386f //x=85.36 //y=0.805
c58 ( 1 0 ) capacitor c=0.0218888f //x=85.275 //y=1.175
r59 (  15 29 ) resistor r=3.57586 //w=0.17 //l=0.125 //layer=li \
 //thickness=0.1 //x=86.33 //y=0.805 //x2=86.33 //y2=0.68
r60 (  15 29 ) resistor r=18.139 //w=0.187 //l=0.265 //layer=li \
 //thickness=0.1 //x=86.33 //y=0.805 //x2=86.33 //y2=1.07
r61 (  12 29 ) resistor r=3.57586 //w=0.17 //l=0.103078 //layer=li \
 //thickness=0.1 //x=85.445 //y=0.72 //x2=85.36 //y2=0.68
r62 (  12 29 ) resistor r=27.3797 //w=0.187 //l=0.4 //layer=li //thickness=0.1 \
 //x=85.445 //y=0.72 //x2=85.845 //y2=0.72
r63 (  11 29 ) resistor r=3.57586 //w=0.17 //l=0.103078 //layer=li \
 //thickness=0.1 //x=86.245 //y=0.72 //x2=86.33 //y2=0.68
r64 (  11 29 ) resistor r=27.3797 //w=0.187 //l=0.4 //layer=li //thickness=0.1 \
 //x=86.245 //y=0.72 //x2=85.845 //y2=0.72
r65 (  7 25 ) resistor r=5.4201 //w=0.17 //l=0.085 //layer=li //thickness=0.1 \
 //x=85.36 //y=1.26 //x2=85.36 //y2=1.175
r66 (  7 29 ) resistor r=10.2674 //w=0.187 //l=0.15 //layer=li //thickness=0.1 \
 //x=85.36 //y=1.26 //x2=85.36 //y2=1.41
r67 (  4 25 ) resistor r=5.4201 //w=0.17 //l=0.085 //layer=li //thickness=0.1 \
 //x=85.36 //y=1.09 //x2=85.36 //y2=1.175
r68 (  4 29 ) resistor r=1.36898 //w=0.187 //l=0.02 //layer=li //thickness=0.1 \
 //x=85.36 //y=1.09 //x2=85.36 //y2=1.07
r69 (  3 29 ) resistor r=3.57586 //w=0.17 //l=0.125 //layer=li //thickness=0.1 \
 //x=85.36 //y=0.805 //x2=85.36 //y2=0.68
r70 (  3 29 ) resistor r=18.139 //w=0.187 //l=0.265 //layer=li //thickness=0.1 \
 //x=85.36 //y=0.805 //x2=85.36 //y2=1.07
r71 (  2 28 ) resistor r=0.751729 //w=0.17 //l=0.085 //layer=li \
 //thickness=0.1 //x=84.395 //y=1.175 //x2=84.31 //y2=1.175
r72 (  1 25 ) resistor r=1.40859 //w=0.34 //l=0.085 //layer=li //thickness=0.1 \
 //x=85.275 //y=1.175 //x2=85.36 //y2=1.175
r73 (  1 2 ) resistor r=60.2353 //w=0.187 //l=0.88 //layer=li //thickness=0.1 \
 //x=85.275 //y=1.175 //x2=84.395 //y2=1.175
ends PM_TMRDFFSNRNQNX1\%noxref_63

subckt PM_TMRDFFSNRNQNX1\%noxref_64 ( 1 5 9 10 13 17 29 )
c57 ( 29 0 ) capacitor c=0.0751624f //x=87.63 //y=0.545
c58 ( 17 0 ) capacitor c=0.0072249f //x=89.705 //y=0.795
c59 ( 13 0 ) capacitor c=0.0152499f //x=89.62 //y=0.71
c60 ( 10 0 ) capacitor c=0.00698291f //x=88.735 //y=1.675
c61 ( 9 0 ) capacitor c=0.006761f //x=88.735 //y=0.795
c62 ( 5 0 ) capacitor c=0.0191191f //x=88.65 //y=1.76
c63 ( 1 0 ) capacitor c=0.00483164f //x=87.765 //y=1.675
r64 (  17 29 ) resistor r=3.57586 //w=0.17 //l=0.125 //layer=li \
 //thickness=0.1 //x=89.705 //y=0.795 //x2=89.705 //y2=0.67
r65 (  17 29 ) resistor r=41.4118 //w=0.187 //l=0.605 //layer=li \
 //thickness=0.1 //x=89.705 //y=0.795 //x2=89.705 //y2=1.4
r66 (  14 29 ) resistor r=3.57586 //w=0.17 //l=0.103078 //layer=li \
 //thickness=0.1 //x=88.82 //y=0.71 //x2=88.735 //y2=0.67
r67 (  14 29 ) resistor r=27.0374 //w=0.187 //l=0.395 //layer=li \
 //thickness=0.1 //x=88.82 //y=0.71 //x2=89.215 //y2=0.71
r68 (  13 29 ) resistor r=3.57586 //w=0.17 //l=0.103078 //layer=li \
 //thickness=0.1 //x=89.62 //y=0.71 //x2=89.705 //y2=0.67
r69 (  13 29 ) resistor r=27.7219 //w=0.187 //l=0.405 //layer=li \
 //thickness=0.1 //x=89.62 //y=0.71 //x2=89.215 //y2=0.71
r70 (  10 29 ) resistor r=3.57586 //w=0.17 //l=0.125 //layer=li \
 //thickness=0.1 //x=88.735 //y=1.675 //x2=88.735 //y2=1.8
r71 (  10 29 ) resistor r=42.0963 //w=0.187 //l=0.615 //layer=li \
 //thickness=0.1 //x=88.735 //y=1.675 //x2=88.735 //y2=1.06
r72 (  9 29 ) resistor r=3.57586 //w=0.17 //l=0.125 //layer=li //thickness=0.1 \
 //x=88.735 //y=0.795 //x2=88.735 //y2=0.67
r73 (  9 29 ) resistor r=18.139 //w=0.187 //l=0.265 //layer=li //thickness=0.1 \
 //x=88.735 //y=0.795 //x2=88.735 //y2=1.06
r74 (  6 29 ) resistor r=3.57586 //w=0.17 //l=0.103078 //layer=li \
 //thickness=0.1 //x=87.85 //y=1.76 //x2=87.765 //y2=1.8
r75 (  6 29 ) resistor r=27.3797 //w=0.187 //l=0.4 //layer=li //thickness=0.1 \
 //x=87.85 //y=1.76 //x2=88.25 //y2=1.76
r76 (  5 29 ) resistor r=3.57586 //w=0.17 //l=0.103078 //layer=li \
 //thickness=0.1 //x=88.65 //y=1.76 //x2=88.735 //y2=1.8
r77 (  5 29 ) resistor r=27.3797 //w=0.187 //l=0.4 //layer=li //thickness=0.1 \
 //x=88.65 //y=1.76 //x2=88.25 //y2=1.76
r78 (  1 29 ) resistor r=3.57586 //w=0.17 //l=0.125 //layer=li //thickness=0.1 \
 //x=87.765 //y=1.675 //x2=87.765 //y2=1.8
r79 (  1 29 ) resistor r=42.0963 //w=0.187 //l=0.615 //layer=li \
 //thickness=0.1 //x=87.765 //y=1.675 //x2=87.765 //y2=1.06
ends PM_TMRDFFSNRNQNX1\%noxref_64

subckt PM_TMRDFFSNRNQNX1\%noxref_65 ( 1 5 9 10 13 17 29 )
c55 ( 29 0 ) capacitor c=0.0723103f //x=90.96 //y=0.545
c56 ( 17 0 ) capacitor c=0.0072249f //x=93.035 //y=0.795
c57 ( 13 0 ) capacitor c=0.0155051f //x=92.95 //y=0.71
c58 ( 10 0 ) capacitor c=0.00811719f //x=92.065 //y=1.675
c59 ( 9 0 ) capacitor c=0.006761f //x=92.065 //y=0.795
c60 ( 5 0 ) capacitor c=0.0166789f //x=91.98 //y=1.76
c61 ( 1 0 ) capacitor c=0.00788388f //x=91.095 //y=1.675
r62 (  17 29 ) resistor r=3.57586 //w=0.17 //l=0.125 //layer=li \
 //thickness=0.1 //x=93.035 //y=0.795 //x2=93.035 //y2=0.67
r63 (  17 29 ) resistor r=41.4118 //w=0.187 //l=0.605 //layer=li \
 //thickness=0.1 //x=93.035 //y=0.795 //x2=93.035 //y2=1.4
r64 (  14 29 ) resistor r=3.57586 //w=0.17 //l=0.103078 //layer=li \
 //thickness=0.1 //x=92.15 //y=0.71 //x2=92.065 //y2=0.67
r65 (  14 29 ) resistor r=27.3797 //w=0.187 //l=0.4 //layer=li //thickness=0.1 \
 //x=92.15 //y=0.71 //x2=92.55 //y2=0.71
r66 (  13 29 ) resistor r=3.57586 //w=0.17 //l=0.103078 //layer=li \
 //thickness=0.1 //x=92.95 //y=0.71 //x2=93.035 //y2=0.67
r67 (  13 29 ) resistor r=27.3797 //w=0.187 //l=0.4 //layer=li //thickness=0.1 \
 //x=92.95 //y=0.71 //x2=92.55 //y2=0.71
r68 (  10 29 ) resistor r=3.57586 //w=0.17 //l=0.125 //layer=li \
 //thickness=0.1 //x=92.065 //y=1.675 //x2=92.065 //y2=1.8
r69 (  10 29 ) resistor r=42.0963 //w=0.187 //l=0.615 //layer=li \
 //thickness=0.1 //x=92.065 //y=1.675 //x2=92.065 //y2=1.06
r70 (  9 29 ) resistor r=3.57586 //w=0.17 //l=0.125 //layer=li //thickness=0.1 \
 //x=92.065 //y=0.795 //x2=92.065 //y2=0.67
r71 (  9 29 ) resistor r=18.139 //w=0.187 //l=0.265 //layer=li //thickness=0.1 \
 //x=92.065 //y=0.795 //x2=92.065 //y2=1.06
r72 (  6 29 ) resistor r=3.57586 //w=0.17 //l=0.103078 //layer=li \
 //thickness=0.1 //x=91.18 //y=1.76 //x2=91.095 //y2=1.8
r73 (  6 29 ) resistor r=27.3797 //w=0.187 //l=0.4 //layer=li //thickness=0.1 \
 //x=91.18 //y=1.76 //x2=91.58 //y2=1.76
r74 (  5 29 ) resistor r=3.57586 //w=0.17 //l=0.103078 //layer=li \
 //thickness=0.1 //x=91.98 //y=1.76 //x2=92.065 //y2=1.8
r75 (  5 29 ) resistor r=27.3797 //w=0.187 //l=0.4 //layer=li //thickness=0.1 \
 //x=91.98 //y=1.76 //x2=91.58 //y2=1.76
r76 (  1 29 ) resistor r=3.57586 //w=0.17 //l=0.125 //layer=li //thickness=0.1 \
 //x=91.095 //y=1.675 //x2=91.095 //y2=1.8
r77 (  1 29 ) resistor r=42.0963 //w=0.187 //l=0.615 //layer=li \
 //thickness=0.1 //x=91.095 //y=1.675 //x2=91.095 //y2=1.06
ends PM_TMRDFFSNRNQNX1\%noxref_65

subckt PM_TMRDFFSNRNQNX1\%noxref_66 ( 1 5 9 10 13 17 29 )
c54 ( 29 0 ) capacitor c=0.0637439f //x=94.29 //y=0.545
c55 ( 17 0 ) capacitor c=0.00722228f //x=96.365 //y=0.795
c56 ( 13 0 ) capacitor c=0.0141607f //x=96.28 //y=0.71
c57 ( 10 0 ) capacitor c=0.00712138f //x=95.395 //y=1.675
c58 ( 9 0 ) capacitor c=0.006761f //x=95.395 //y=0.795
c59 ( 5 0 ) capacitor c=0.0233454f //x=95.31 //y=1.76
c60 ( 1 0 ) capacitor c=0.00481264f //x=94.425 //y=1.675
r61 (  17 29 ) resistor r=3.57586 //w=0.17 //l=0.125 //layer=li \
 //thickness=0.1 //x=96.365 //y=0.795 //x2=96.365 //y2=0.67
r62 (  17 29 ) resistor r=18.139 //w=0.187 //l=0.265 //layer=li \
 //thickness=0.1 //x=96.365 //y=0.795 //x2=96.365 //y2=1.06
r63 (  14 29 ) resistor r=3.57586 //w=0.17 //l=0.103078 //layer=li \
 //thickness=0.1 //x=95.48 //y=0.71 //x2=95.395 //y2=0.67
r64 (  14 29 ) resistor r=27.3797 //w=0.187 //l=0.4 //layer=li //thickness=0.1 \
 //x=95.48 //y=0.71 //x2=95.88 //y2=0.71
r65 (  13 29 ) resistor r=3.57586 //w=0.17 //l=0.103078 //layer=li \
 //thickness=0.1 //x=96.28 //y=0.71 //x2=96.365 //y2=0.67
r66 (  13 29 ) resistor r=27.3797 //w=0.187 //l=0.4 //layer=li //thickness=0.1 \
 //x=96.28 //y=0.71 //x2=95.88 //y2=0.71
r67 (  10 29 ) resistor r=3.57586 //w=0.17 //l=0.125 //layer=li \
 //thickness=0.1 //x=95.395 //y=1.675 //x2=95.395 //y2=1.8
r68 (  10 29 ) resistor r=42.0963 //w=0.187 //l=0.615 //layer=li \
 //thickness=0.1 //x=95.395 //y=1.675 //x2=95.395 //y2=1.06
r69 (  9 29 ) resistor r=3.57586 //w=0.17 //l=0.125 //layer=li //thickness=0.1 \
 //x=95.395 //y=0.795 //x2=95.395 //y2=0.67
r70 (  9 29 ) resistor r=18.139 //w=0.187 //l=0.265 //layer=li //thickness=0.1 \
 //x=95.395 //y=0.795 //x2=95.395 //y2=1.06
r71 (  6 29 ) resistor r=3.57586 //w=0.17 //l=0.103078 //layer=li \
 //thickness=0.1 //x=94.51 //y=1.76 //x2=94.425 //y2=1.8
r72 (  6 29 ) resistor r=27.3797 //w=0.187 //l=0.4 //layer=li //thickness=0.1 \
 //x=94.51 //y=1.76 //x2=94.91 //y2=1.76
r73 (  5 29 ) resistor r=3.57586 //w=0.17 //l=0.103078 //layer=li \
 //thickness=0.1 //x=95.31 //y=1.76 //x2=95.395 //y2=1.8
r74 (  5 29 ) resistor r=27.3797 //w=0.187 //l=0.4 //layer=li //thickness=0.1 \
 //x=95.31 //y=1.76 //x2=94.91 //y2=1.76
r75 (  1 29 ) resistor r=3.57586 //w=0.17 //l=0.125 //layer=li //thickness=0.1 \
 //x=94.425 //y=1.675 //x2=94.425 //y2=1.8
r76 (  1 29 ) resistor r=42.0963 //w=0.187 //l=0.615 //layer=li \
 //thickness=0.1 //x=94.425 //y=1.675 //x2=94.425 //y2=1.06
ends PM_TMRDFFSNRNQNX1\%noxref_66
