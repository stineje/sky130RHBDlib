// File: nmos_top_trim1.spi.pex
// Created: Tue Apr 29 10:51:44 2025
// Program "Calibre xRC"
// Version "v2023.2_27.15"
// Nominal Temperature: 30C
// Circuit Temperature: 30C
//
simulator lang=spectre
