// File: AOI3X1.spi
// Created: Sun Apr 12 08:30:26 2026
// Program "Calibre xRC"
// Version "v2023.2_27.15"
//
simulator lang=spectre
include "/import/yukari1/lrburle/sky130RHBDlib/calibre/sky130_rhbd_output/spice/AOI3X1.pex.spice"
subckt AOI3X1 (  VDD A GND B C YN )
//
// YN	YN
// C	C
// B	B
// GND	GND
// A	A
// VDD	VDD
M0_noxref ( N_GND_M0_noxref_d N_A_M0_noxref_g N_noxref_9_M0_noxref_s noxref_86 \
 ) NMOS l=0.163119 w=2.35104 m=1
M1_noxref ( N_noxref_1_M1_noxref_d N_B_M1_noxref_g N_noxref_9_M0_noxref_s \
 noxref_86 ) NMOS l=0.163346 w=2.31104 m=1
M2_noxref ( N_YN_M2_noxref_d N_noxref_1_M2_noxref_g N_GND_M2_noxref_s \
 noxref_86 ) NMOS l=0.163346 w=2.31104 m=1
M3_noxref ( N_YN_M3_noxref_d N_C_M3_noxref_g N_GND_M2_noxref_s noxref_86 ) \
 NMOS l=0.163129 w=2.31397 m=1
M4_noxref ( N_noxref_1_M4_noxref_d N_A_M4_noxref_g N_VDD_M4_noxref_s noxref_84 \
 ) PMOS l=0.15 w=2 ad=0.57 as=0.57 pd=2.57 ps=2.57 nrd=0 nrs=0 m=1
M5_noxref ( N_VDD_M5_noxref_d N_A_M5_noxref_g N_noxref_1_M4_noxref_d noxref_84 \
 ) PMOS l=0.15 w=2 ad=0.58 as=0.58 pd=2.58 ps=2.58 nrd=0 nrs=0 m=1
M6_noxref ( N_noxref_1_M6_noxref_d N_B_M6_noxref_g N_VDD_M5_noxref_d noxref_84 \
 ) PMOS l=0.15 w=2 ad=0.58 as=0.58 pd=2.58 ps=2.58 nrd=0 nrs=0 m=1
M7_noxref ( N_VDD_M7_noxref_d N_B_M7_noxref_g N_noxref_1_M6_noxref_d noxref_84 \
 ) PMOS l=0.15 w=2 ad=0.56 as=0.56 pd=2.56 ps=2.56 nrd=0 nrs=0 m=1
M8_noxref ( N_VDD_M8_noxref_d N_noxref_1_M8_noxref_g N_noxref_6_M8_noxref_s \
 noxref_84 ) PMOS l=0.15 w=2 ad=0.57 as=0.57 pd=2.57 ps=2.57 nrd=0 nrs=0 m=1
M9_noxref ( N_noxref_6_M9_noxref_d N_noxref_1_M9_noxref_g N_VDD_M8_noxref_d \
 noxref_84 ) PMOS l=0.15 w=2 ad=0.58 as=0.58 pd=2.58 ps=2.58 nrd=0 nrs=0 m=1
M10_noxref ( N_YN_M10_noxref_d N_C_M10_noxref_g N_noxref_6_M9_noxref_d \
 noxref_84 ) PMOS l=0.15 w=2 ad=0.58 as=0.58 pd=2.58 ps=2.58 nrd=0 nrs=0 m=1
M11_noxref ( N_noxref_6_M11_noxref_d N_C_M11_noxref_g N_YN_M10_noxref_d \
 noxref_84 ) PMOS l=0.15 w=2 ad=0.56 as=0.56 pd=2.56 ps=2.56 nrd=0 nrs=0 m=1
//
include "/import/yukari1/lrburle/sky130RHBDlib/calibre/sky130_rhbd_output/spice/AOI3X1.pxi.spice"
//
ends AOI3X1
//
//
