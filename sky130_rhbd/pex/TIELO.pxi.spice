// File: TIELO.spi.TIELO.pxi
// Created: Thu Jan 22 07:08:24 2026
//
simulator lang=spectre
x_PM_TIELO\%VDD ( VDD N_VDD_c_16_p N_VDD_c_17_p N_VDD_c_3_p N_VDD_c_19_p \
 N_VDD_c_20_p N_VDD_c_1_p N_VDD_c_5_p N_VDD_c_2_p N_VDD_M1_noxref_s \
 N_VDD_M2_noxref_d )  PM_TIELO\%VDD
x_PM_TIELO\%YN ( YN YN YN N_YN_c_43_p N_YN_M0_noxref_d )  PM_TIELO\%YN
x_PM_TIELO\%noxref_3 ( N_noxref_3_c_111_n N_noxref_3_c_75_n N_noxref_3_c_77_n \
 N_noxref_3_c_82_n N_noxref_3_c_116_n N_noxref_3_c_87_n N_noxref_3_c_90_n \
 N_noxref_3_M0_noxref_g N_noxref_3_M1_noxref_g N_noxref_3_M2_noxref_g \
 N_noxref_3_c_118_n N_noxref_3_c_120_n N_noxref_3_c_123_n N_noxref_3_c_124_n \
 N_noxref_3_c_107_n N_noxref_3_c_108_n N_noxref_3_c_125_n N_noxref_3_c_127_n \
 N_noxref_3_c_130_n N_noxref_3_c_132_n N_noxref_3_c_135_n \
 N_noxref_3_M1_noxref_d )  PM_TIELO\%noxref_3
x_PM_TIELO\%GND ( GND N_GND_c_160_n N_GND_c_175_n N_GND_c_161_n N_GND_c_164_n \
 N_GND_c_162_n N_GND_c_163_n N_GND_c_168_n N_GND_M0_noxref_s )  PM_TIELO\%GND
cc_1 ( N_VDD_c_1_p N_noxref_3_c_75_n ) capacitor c=0.0159268f //x=0.86 \
 //y=7.58 //x2=1.23 //y2=4.765
cc_2 ( N_VDD_c_2_p N_noxref_3_c_75_n ) capacitor c=0.00767892f //x=2.34 \
 //y=7.58 //x2=1.23 //y2=4.765
cc_3 ( N_VDD_c_3_p N_noxref_3_c_77_n ) capacitor c=0.0027246f //x=1.955 \
 //y=7.585 //x2=1.6 //y2=5.45
cc_4 ( N_VDD_c_1_p N_noxref_3_c_77_n ) capacitor c=0.0052091f //x=0.86 \
 //y=7.58 //x2=1.6 //y2=5.45
cc_5 ( N_VDD_c_5_p N_noxref_3_c_77_n ) capacitor c=0.00100578f //x=1.955 \
 //y=7.585 //x2=1.6 //y2=5.45
cc_6 ( N_VDD_M1_noxref_s N_noxref_3_c_77_n ) capacitor c=0.0576604f //x=1.025 \
 //y=5.2 //x2=1.6 //y2=5.45
cc_7 ( N_VDD_M2_noxref_d N_noxref_3_c_77_n ) capacitor c=0.0575881f //x=1.895 \
 //y=5.2 //x2=1.6 //y2=5.45
cc_8 ( N_VDD_c_3_p N_noxref_3_c_82_n ) capacitor c=3.7805e-19 //x=1.955 \
 //y=7.585 //x2=1.23 //y2=4.88
cc_9 ( N_VDD_c_1_p N_noxref_3_c_82_n ) capacitor c=0.00802658f //x=0.86 \
 //y=7.58 //x2=1.23 //y2=4.88
cc_10 ( N_VDD_c_5_p N_noxref_3_c_82_n ) capacitor c=0.00333678f //x=1.955 \
 //y=7.585 //x2=1.23 //y2=4.88
cc_11 ( N_VDD_c_2_p N_noxref_3_c_82_n ) capacitor c=0.0127951f //x=2.34 \
 //y=7.58 //x2=1.23 //y2=4.88
cc_12 ( N_VDD_M1_noxref_s N_noxref_3_c_82_n ) capacitor c=0.021773f //x=1.025 \
 //y=5.2 //x2=1.23 //y2=4.88
cc_13 ( N_VDD_c_1_p N_noxref_3_c_87_n ) capacitor c=0.00735633f //x=0.86 \
 //y=7.58 //x2=1.23 //y2=4.88
cc_14 ( N_VDD_c_2_p N_noxref_3_c_87_n ) capacitor c=0.00234816f //x=2.34 \
 //y=7.58 //x2=1.23 //y2=4.88
cc_15 ( N_VDD_M1_noxref_s N_noxref_3_c_87_n ) capacitor c=0.00940593f \
 //x=1.025 //y=5.2 //x2=1.23 //y2=4.88
cc_16 ( N_VDD_c_16_p N_noxref_3_c_90_n ) capacitor c=0.00310744f //x=1.16 \
 //y=7.04 //x2=1.6 //y2=5.565
cc_17 ( N_VDD_c_17_p N_noxref_3_c_90_n ) capacitor c=0.00163202f //x=1.16 \
 //y=7.41 //x2=1.6 //y2=5.565
cc_18 ( N_VDD_c_3_p N_noxref_3_c_90_n ) capacitor c=0.00239075f //x=1.955 \
 //y=7.585 //x2=1.6 //y2=5.565
cc_19 ( N_VDD_c_19_p N_noxref_3_c_90_n ) capacitor c=0.00310744f //x=2.04 \
 //y=7.04 //x2=1.6 //y2=5.565
cc_20 ( N_VDD_c_20_p N_noxref_3_c_90_n ) capacitor c=0.00163202f //x=2.04 \
 //y=7.41 //x2=1.6 //y2=5.565
cc_21 ( N_VDD_c_1_p N_noxref_3_c_90_n ) capacitor c=0.00768607f //x=0.86 \
 //y=7.58 //x2=1.6 //y2=5.565
cc_22 ( N_VDD_c_5_p N_noxref_3_c_90_n ) capacitor c=0.0151329f //x=1.955 \
 //y=7.585 //x2=1.6 //y2=5.565
cc_23 ( N_VDD_c_2_p N_noxref_3_c_90_n ) capacitor c=0.00768607f //x=2.34 \
 //y=7.58 //x2=1.6 //y2=5.565
cc_24 ( N_VDD_M1_noxref_s N_noxref_3_c_90_n ) capacitor c=0.0912825f //x=1.025 \
 //y=5.2 //x2=1.6 //y2=5.565
cc_25 ( N_VDD_M2_noxref_d N_noxref_3_c_90_n ) capacitor c=0.0912833f //x=1.895 \
 //y=5.2 //x2=1.6 //y2=5.565
cc_26 ( N_VDD_c_16_p N_noxref_3_M1_noxref_g ) capacitor c=0.00453775f //x=1.16 \
 //y=7.04 //x2=1.38 //y2=6.2
cc_27 ( N_VDD_c_1_p N_noxref_3_M1_noxref_g ) capacitor c=0.0151146f //x=0.86 \
 //y=7.58 //x2=1.38 //y2=6.2
cc_28 ( N_VDD_c_5_p N_noxref_3_M1_noxref_g ) capacitor c=0.00769938f //x=1.955 \
 //y=7.585 //x2=1.38 //y2=6.2
cc_29 ( N_VDD_M1_noxref_s N_noxref_3_M1_noxref_g ) capacitor c=0.0588707f \
 //x=1.025 //y=5.2 //x2=1.38 //y2=6.2
cc_30 ( N_VDD_c_19_p N_noxref_3_M2_noxref_g ) capacitor c=0.00453775f //x=2.04 \
 //y=7.04 //x2=1.82 //y2=6.2
cc_31 ( N_VDD_c_5_p N_noxref_3_M2_noxref_g ) capacitor c=0.00773472f //x=1.955 \
 //y=7.585 //x2=1.82 //y2=6.2
cc_32 ( N_VDD_M2_noxref_d N_noxref_3_M2_noxref_g ) capacitor c=0.0588721f \
 //x=1.895 //y=5.2 //x2=1.82 //y2=6.2
cc_33 ( N_VDD_c_2_p N_noxref_3_c_107_n ) capacitor c=0.0187722f //x=2.34 \
 //y=7.58 //x2=1.745 //y2=4.97
cc_34 ( N_VDD_c_1_p N_noxref_3_c_108_n ) capacitor c=0.00816327f //x=0.86 \
 //y=7.58 //x2=1.455 //y2=4.97
cc_35 ( N_VDD_c_2_p N_noxref_3_c_108_n ) capacitor c=2.63786e-19 //x=2.34 \
 //y=7.58 //x2=1.455 //y2=4.97
cc_36 ( N_VDD_M1_noxref_s N_noxref_3_c_108_n ) capacitor c=0.00682661f \
 //x=1.025 //y=5.2 //x2=1.455 //y2=4.97
cc_37 ( N_VDD_M1_noxref_s N_GND_c_160_n ) capacitor c=2.26053e-19 //x=1.025 \
 //y=5.2 //x2=1.12 //y2=0.595
cc_38 ( N_VDD_M2_noxref_d N_GND_c_161_n ) capacitor c=6.53128e-19 //x=1.895 \
 //y=5.2 //x2=2.09 //y2=0.595
cc_39 ( N_VDD_c_1_p N_GND_c_162_n ) capacitor c=0.00989514f //x=0.86 //y=7.58 \
 //x2=1.23 //y2=0.18
cc_40 ( N_VDD_c_2_p N_GND_c_163_n ) capacitor c=0.00989514f //x=2.34 //y=7.58 \
 //x2=1.97 //y2=0.18
cc_41 ( YN N_noxref_3_c_111_n ) capacitor c=0.0310076f //x=1.6 //y=2.4 \
 //x2=1.23 //y2=2.375
cc_42 ( YN N_noxref_3_c_75_n ) capacitor c=0.0815684f //x=1.6 //y=2.4 \
 //x2=1.23 //y2=4.765
cc_43 ( N_YN_c_43_p N_noxref_3_c_77_n ) capacitor c=2.92103e-19 //x=1.6 \
 //y=1.295 //x2=1.6 //y2=5.45
cc_44 ( YN N_noxref_3_c_82_n ) capacitor c=0.00575049f //x=1.6 //y=2.4 \
 //x2=1.23 //y2=4.88
cc_45 ( N_YN_c_43_p N_noxref_3_c_82_n ) capacitor c=2.6483e-19 //x=1.6 \
 //y=1.295 //x2=1.23 //y2=4.88
cc_46 ( YN N_noxref_3_c_116_n ) capacitor c=0.00706146f //x=1.6 //y=2.4 \
 //x2=1.23 //y2=2.26
cc_47 ( YN N_noxref_3_c_90_n ) capacitor c=9.63387e-19 //x=1.6 //y=2.4 \
 //x2=1.6 //y2=5.565
cc_48 ( N_YN_c_43_p N_noxref_3_c_118_n ) capacitor c=6.55883e-19 //x=1.6 \
 //y=1.295 //x2=1.34 //y2=1.085
cc_49 ( N_YN_M0_noxref_d N_noxref_3_c_118_n ) capacitor c=0.00137914f \
 //x=1.415 //y=1.085 //x2=1.34 //y2=1.085
cc_50 ( YN N_noxref_3_c_120_n ) capacitor c=0.0012792f //x=1.6 //y=2.4 \
 //x2=1.34 //y2=1.43
cc_51 ( N_YN_c_43_p N_noxref_3_c_120_n ) capacitor c=0.00359145f //x=1.6 \
 //y=1.295 //x2=1.34 //y2=1.43
cc_52 ( N_YN_M0_noxref_d N_noxref_3_c_120_n ) capacitor c=0.0023891f //x=1.415 \
 //y=1.085 //x2=1.34 //y2=1.43
cc_53 ( YN N_noxref_3_c_123_n ) capacitor c=0.00561986f //x=1.6 //y=2.4 \
 //x2=1.34 //y2=1.74
cc_54 ( YN N_noxref_3_c_124_n ) capacitor c=0.0100048f //x=1.6 //y=2.4 \
 //x2=1.34 //y2=2.095
cc_55 ( N_YN_c_43_p N_noxref_3_c_125_n ) capacitor c=3.45657e-19 //x=1.6 \
 //y=1.295 //x2=1.715 //y2=0.93
cc_56 ( N_YN_M0_noxref_d N_noxref_3_c_125_n ) capacitor c=0.0020782f //x=1.415 \
 //y=1.085 //x2=1.715 //y2=0.93
cc_57 ( YN N_noxref_3_c_127_n ) capacitor c=0.00999774f //x=1.6 //y=2.4 \
 //x2=1.715 //y2=1.585
cc_58 ( N_YN_c_43_p N_noxref_3_c_127_n ) capacitor c=7.58372e-19 //x=1.6 \
 //y=1.295 //x2=1.715 //y2=1.585
cc_59 ( N_YN_M0_noxref_d N_noxref_3_c_127_n ) capacitor c=0.00356097f \
 //x=1.415 //y=1.085 //x2=1.715 //y2=1.585
cc_60 ( N_YN_c_43_p N_noxref_3_c_130_n ) capacitor c=4.44634e-19 //x=1.6 \
 //y=1.295 //x2=1.87 //y2=1.085
cc_61 ( N_YN_M0_noxref_d N_noxref_3_c_130_n ) capacitor c=0.00138452f \
 //x=1.415 //y=1.085 //x2=1.87 //y2=1.085
cc_62 ( YN N_noxref_3_c_132_n ) capacitor c=0.00362207f //x=1.6 //y=2.4 \
 //x2=1.87 //y2=1.43
cc_63 ( N_YN_c_43_p N_noxref_3_c_132_n ) capacitor c=0.00356375f //x=1.6 \
 //y=1.295 //x2=1.87 //y2=1.43
cc_64 ( N_YN_M0_noxref_d N_noxref_3_c_132_n ) capacitor c=0.00235934f \
 //x=1.415 //y=1.085 //x2=1.87 //y2=1.43
cc_65 ( YN N_noxref_3_c_135_n ) capacitor c=0.00147568f //x=1.6 //y=2.4 \
 //x2=1.23 //y2=2.26
cc_66 ( N_YN_c_43_p N_GND_c_164_n ) capacitor c=0.0342199f //x=1.6 //y=1.295 \
 //x2=1.6 //y2=0.71
cc_67 ( N_YN_M0_noxref_d N_GND_c_164_n ) capacitor c=0.00295844f //x=1.415 \
 //y=1.085 //x2=1.6 //y2=0.71
cc_68 ( YN N_GND_c_162_n ) capacitor c=0.00570664f //x=1.6 //y=2.4 //x2=1.23 \
 //y2=0.18
cc_69 ( YN N_GND_c_163_n ) capacitor c=0.0225786f //x=1.6 //y=2.4 //x2=1.97 \
 //y2=0.18
cc_70 ( N_YN_c_43_p N_GND_c_168_n ) capacitor c=0.00464371f //x=1.6 //y=1.295 \
 //x2=2.005 //y2=0.71
cc_71 ( N_YN_M0_noxref_d N_GND_c_168_n ) capacitor c=0.0127526f //x=1.415 \
 //y=1.085 //x2=2.005 //y2=0.71
cc_72 ( YN N_GND_M0_noxref_s ) capacitor c=0.0378977f //x=1.6 //y=2.4 \
 //x2=0.985 //y2=0.545
cc_73 ( N_YN_c_43_p N_GND_M0_noxref_s ) capacitor c=0.013328f //x=1.6 \
 //y=1.295 //x2=0.985 //y2=0.545
cc_74 ( N_YN_M0_noxref_d N_GND_M0_noxref_s ) capacitor c=0.0275672f //x=1.415 \
 //y=1.085 //x2=0.985 //y2=0.545
cc_75 ( N_noxref_3_c_111_n N_GND_c_160_n ) capacitor c=0.0027312f //x=1.23 \
 //y=2.375 //x2=1.12 //y2=0.595
cc_76 ( N_noxref_3_c_116_n N_GND_c_160_n ) capacitor c=7.23627e-19 //x=1.23 \
 //y=2.26 //x2=1.12 //y2=0.595
cc_77 ( N_noxref_3_c_111_n N_GND_c_175_n ) capacitor c=0.00168244f //x=1.23 \
 //y=2.375 //x2=1.485 //y2=0.71
cc_78 ( N_noxref_3_c_82_n N_GND_c_175_n ) capacitor c=6.7495e-19 //x=1.23 \
 //y=4.88 //x2=1.485 //y2=0.71
cc_79 ( N_noxref_3_c_116_n N_GND_c_175_n ) capacitor c=6.45828e-19 //x=1.23 \
 //y=2.26 //x2=1.485 //y2=0.71
cc_80 ( N_noxref_3_c_118_n N_GND_c_164_n ) capacitor c=0.00405442f //x=1.34 \
 //y=1.085 //x2=1.6 //y2=0.71
cc_81 ( N_noxref_3_c_111_n N_GND_c_162_n ) capacitor c=0.00793669f //x=1.23 \
 //y=2.375 //x2=1.23 //y2=0.18
cc_82 ( N_noxref_3_c_75_n N_GND_c_162_n ) capacitor c=0.0156728f //x=1.23 \
 //y=4.765 //x2=1.23 //y2=0.18
cc_83 ( N_noxref_3_c_116_n N_GND_c_162_n ) capacitor c=0.00791319f //x=1.23 \
 //y=2.26 //x2=1.23 //y2=0.18
cc_84 ( N_noxref_3_c_124_n N_GND_c_162_n ) capacitor c=0.00574455f //x=1.34 \
 //y=2.095 //x2=1.23 //y2=0.18
cc_85 ( N_noxref_3_c_135_n N_GND_c_162_n ) capacitor c=0.00687599f //x=1.23 \
 //y=2.26 //x2=1.23 //y2=0.18
cc_86 ( N_noxref_3_c_116_n N_GND_c_163_n ) capacitor c=0.00243018f //x=1.23 \
 //y=2.26 //x2=1.97 //y2=0.18
cc_87 ( N_noxref_3_c_111_n N_GND_c_168_n ) capacitor c=6.99805e-19 //x=1.23 \
 //y=2.375 //x2=2.005 //y2=0.71
cc_88 ( N_noxref_3_c_118_n N_GND_c_168_n ) capacitor c=0.019649f //x=1.34 \
 //y=1.085 //x2=2.005 //y2=0.71
cc_89 ( N_noxref_3_c_130_n N_GND_c_168_n ) capacitor c=0.00747944f //x=1.87 \
 //y=1.085 //x2=2.005 //y2=0.71
cc_90 ( N_noxref_3_c_135_n N_GND_c_168_n ) capacitor c=2.1838e-19 //x=1.23 \
 //y=2.26 //x2=2.005 //y2=0.71
cc_91 ( N_noxref_3_c_111_n N_GND_M0_noxref_s ) capacitor c=0.00216033f \
 //x=1.23 //y=2.375 //x2=0.985 //y2=0.545
cc_92 ( N_noxref_3_c_116_n N_GND_M0_noxref_s ) capacitor c=0.00646196f \
 //x=1.23 //y=2.26 //x2=0.985 //y2=0.545
cc_93 ( N_noxref_3_c_118_n N_GND_M0_noxref_s ) capacitor c=0.0299684f //x=1.34 \
 //y=1.085 //x2=0.985 //y2=0.545
cc_94 ( N_noxref_3_c_123_n N_GND_M0_noxref_s ) capacitor c=0.002132f //x=1.34 \
 //y=1.74 //x2=0.985 //y2=0.545
cc_95 ( N_noxref_3_c_124_n N_GND_M0_noxref_s ) capacitor c=0.00304786f \
 //x=1.34 //y=2.095 //x2=0.985 //y2=0.545
cc_96 ( N_noxref_3_c_130_n N_GND_M0_noxref_s ) capacitor c=0.0153553f //x=1.87 \
 //y=1.085 //x2=0.985 //y2=0.545
cc_97 ( N_noxref_3_c_132_n N_GND_M0_noxref_s ) capacitor c=0.00629878f \
 //x=1.87 //y=1.43 //x2=0.985 //y2=0.545
cc_98 ( N_noxref_3_c_135_n N_GND_M0_noxref_s ) capacitor c=0.00653626f \
 //x=1.23 //y=2.26 //x2=0.985 //y2=0.545
