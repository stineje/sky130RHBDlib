// File: TIELO.spi.TIELO.pxi
// Created: Tue Apr 29 10:44:39 2025
//
simulator lang=spectre
x_PM_TIELO\%GND ( GND N_GND_c_3_p N_GND_c_8_p N_GND_c_16_p N_GND_c_1_p \
 N_GND_c_2_p N_GND_M0_noxref_s )  PM_TIELO\%GND
x_PM_TIELO\%VDD ( VDD N_VDD_c_38_p N_VDD_c_27_p N_VDD_c_22_n N_VDD_c_23_n \
 N_VDD_M1_noxref_s N_VDD_M2_noxref_d )  PM_TIELO\%VDD
x_PM_TIELO\%YN ( YN YN YN N_YN_M0_noxref_d )  PM_TIELO\%YN
x_PM_TIELO\%noxref_4 ( N_noxref_4_c_74_n N_noxref_4_c_59_n N_noxref_4_c_77_n \
 N_noxref_4_M0_noxref_g N_noxref_4_M1_noxref_g N_noxref_4_M2_noxref_g \
 N_noxref_4_c_64_n N_noxref_4_c_97_n N_noxref_4_c_98_n N_noxref_4_c_66_n \
 N_noxref_4_c_84_n N_noxref_4_c_85_n N_noxref_4_c_67_n N_noxref_4_c_101_n \
 N_noxref_4_c_68_n N_noxref_4_c_70_n N_noxref_4_c_71_n N_noxref_4_M1_noxref_d ) \
 PM_TIELO\%noxref_4
cc_1 ( N_GND_c_1_p N_VDD_c_22_n ) capacitor c=0.00989514f //x=1.12 //y=0.175 \
 //x2=1.23 //y2=7.58
cc_2 ( N_GND_c_2_p N_VDD_c_23_n ) capacitor c=0.00989514f //x=2.09 //y=0.175 \
 //x2=1.97 //y2=7.58
cc_3 ( N_GND_c_3_p N_YN_M0_noxref_d ) capacitor c=0.00196667f //x=1.97 \
 //y=0.18 //x2=1.415 //y2=1.085
cc_4 ( N_GND_c_1_p N_YN_M0_noxref_d ) capacitor c=0.0110709f //x=1.12 \
 //y=0.175 //x2=1.415 //y2=1.085
cc_5 ( N_GND_c_2_p N_YN_M0_noxref_d ) capacitor c=0.0275544f //x=2.09 \
 //y=0.175 //x2=1.415 //y2=1.085
cc_6 ( N_GND_M0_noxref_s N_YN_M0_noxref_d ) capacitor c=0.0935304f //x=0.985 \
 //y=0.545 //x2=1.415 //y2=1.085
cc_7 ( N_GND_c_3_p N_noxref_4_c_59_n ) capacitor c=0.0020346f //x=1.97 \
 //y=0.18 //x2=1.23 //y2=2.26
cc_8 ( N_GND_c_8_p N_noxref_4_c_59_n ) capacitor c=8.00608e-19 //x=1.515 \
 //y=0.71 //x2=1.23 //y2=2.26
cc_9 ( N_GND_c_1_p N_noxref_4_c_59_n ) capacitor c=0.0295726f //x=1.12 \
 //y=0.175 //x2=1.23 //y2=2.26
cc_10 ( N_GND_c_2_p N_noxref_4_c_59_n ) capacitor c=0.00117065f //x=2.09 \
 //y=0.175 //x2=1.23 //y2=2.26
cc_11 ( N_GND_M0_noxref_s N_noxref_4_c_59_n ) capacitor c=0.0107275f //x=0.985 \
 //y=0.545 //x2=1.23 //y2=2.26
cc_12 ( N_GND_c_8_p N_noxref_4_c_64_n ) capacitor c=0.0122675f //x=1.515 \
 //y=0.71 //x2=1.34 //y2=1.085
cc_13 ( N_GND_M0_noxref_s N_noxref_4_c_64_n ) capacitor c=0.0315727f //x=0.985 \
 //y=0.545 //x2=1.34 //y2=1.085
cc_14 ( N_GND_c_1_p N_noxref_4_c_66_n ) capacitor c=0.0124051f //x=1.12 \
 //y=0.175 //x2=1.34 //y2=2.095
cc_15 ( N_GND_M0_noxref_s N_noxref_4_c_67_n ) capacitor c=0.00505255f \
 //x=0.985 //y=0.545 //x2=1.715 //y2=0.93
cc_16 ( N_GND_c_16_p N_noxref_4_c_68_n ) capacitor c=0.0129102f //x=2.005 \
 //y=0.71 //x2=1.87 //y2=1.085
cc_17 ( N_GND_M0_noxref_s N_noxref_4_c_68_n ) capacitor c=0.0143355f //x=0.985 \
 //y=0.545 //x2=1.87 //y2=1.085
cc_18 ( N_GND_M0_noxref_s N_noxref_4_c_70_n ) capacitor c=0.0074042f //x=0.985 \
 //y=0.545 //x2=1.87 //y2=1.43
cc_19 ( N_GND_c_8_p N_noxref_4_c_71_n ) capacitor c=2.1838e-19 //x=1.515 \
 //y=0.71 //x2=1.23 //y2=2.26
cc_20 ( N_GND_c_1_p N_noxref_4_c_71_n ) capacitor c=0.0108202f //x=1.12 \
 //y=0.175 //x2=1.23 //y2=2.26
cc_21 ( N_GND_M0_noxref_s N_noxref_4_c_71_n ) capacitor c=0.00650255f \
 //x=0.985 //y=0.545 //x2=1.23 //y2=2.26
cc_22 ( N_VDD_M1_noxref_s N_noxref_4_c_74_n ) capacitor c=0.0123296f //x=1.025 \
 //y=5.2 //x2=1.23 //y2=4.795
cc_23 ( N_VDD_c_22_n N_noxref_4_c_59_n ) capacitor c=0.0281058f //x=1.23 \
 //y=7.58 //x2=1.23 //y2=2.26
cc_24 ( N_VDD_c_23_n N_noxref_4_c_59_n ) capacitor c=0.0083883f //x=1.97 \
 //y=7.58 //x2=1.23 //y2=2.26
cc_25 ( N_VDD_c_27_p N_noxref_4_c_77_n ) capacitor c=4.13453e-19 //x=1.955 \
 //y=7.585 //x2=1.515 //y2=4.88
cc_26 ( N_VDD_c_23_n N_noxref_4_c_77_n ) capacitor c=0.0209484f //x=1.97 \
 //y=7.58 //x2=1.515 //y2=4.88
cc_27 ( N_VDD_c_27_p N_noxref_4_M1_noxref_g ) capacitor c=0.00698611f \
 //x=1.955 //y=7.585 //x2=1.38 //y2=6.2
cc_28 ( N_VDD_c_22_n N_noxref_4_M1_noxref_g ) capacitor c=0.0230612f //x=1.23 \
 //y=7.58 //x2=1.38 //y2=6.2
cc_29 ( N_VDD_M1_noxref_s N_noxref_4_M1_noxref_g ) capacitor c=0.0556551f \
 //x=1.025 //y=5.2 //x2=1.38 //y2=6.2
cc_30 ( N_VDD_c_27_p N_noxref_4_M2_noxref_g ) capacitor c=0.00755544f \
 //x=1.955 //y=7.585 //x2=1.82 //y2=6.2
cc_31 ( N_VDD_M2_noxref_d N_noxref_4_M2_noxref_g ) capacitor c=0.0556551f \
 //x=1.895 //y=5.2 //x2=1.82 //y2=6.2
cc_32 ( N_VDD_c_23_n N_noxref_4_c_84_n ) capacitor c=0.0274323f //x=1.97 \
 //y=7.58 //x2=1.745 //y2=4.97
cc_33 ( N_VDD_c_22_n N_noxref_4_c_85_n ) capacitor c=0.0111304f //x=1.23 \
 //y=7.58 //x2=1.455 //y2=4.97
cc_34 ( N_VDD_c_23_n N_noxref_4_c_85_n ) capacitor c=2.63786e-19 //x=1.97 \
 //y=7.58 //x2=1.455 //y2=4.97
cc_35 ( N_VDD_M1_noxref_s N_noxref_4_c_85_n ) capacitor c=0.00804139f \
 //x=1.025 //y=5.2 //x2=1.455 //y2=4.97
cc_36 ( N_VDD_c_38_p N_noxref_4_M1_noxref_d ) capacitor c=0.00723776f //x=1.97 \
 //y=7.58 //x2=1.455 //y2=5.2
cc_37 ( N_VDD_c_27_p N_noxref_4_M1_noxref_d ) capacitor c=0.0139325f //x=1.955 \
 //y=7.585 //x2=1.455 //y2=5.2
cc_38 ( N_VDD_c_22_n N_noxref_4_M1_noxref_d ) capacitor c=0.0149428f //x=1.23 \
 //y=7.58 //x2=1.455 //y2=5.2
cc_39 ( N_VDD_c_23_n N_noxref_4_M1_noxref_d ) capacitor c=0.00135847f //x=1.97 \
 //y=7.58 //x2=1.455 //y2=5.2
cc_40 ( N_VDD_M1_noxref_s N_noxref_4_M1_noxref_d ) capacitor c=0.0880286f \
 //x=1.025 //y=5.2 //x2=1.455 //y2=5.2
cc_41 ( N_VDD_M2_noxref_d N_noxref_4_M1_noxref_d ) capacitor c=0.089071f \
 //x=1.895 //y=5.2 //x2=1.455 //y2=5.2
cc_42 ( N_YN_M0_noxref_d N_noxref_4_c_59_n ) capacitor c=0.0746766f //x=1.415 \
 //y=1.085 //x2=1.23 //y2=2.26
cc_43 ( N_YN_M0_noxref_d N_noxref_4_c_77_n ) capacitor c=0.00416169f //x=1.415 \
 //y=1.085 //x2=1.515 //y2=4.88
cc_44 ( N_YN_M0_noxref_d N_noxref_4_c_64_n ) capacitor c=0.00218556f //x=1.415 \
 //y=1.085 //x2=1.34 //y2=1.085
cc_45 ( N_YN_M0_noxref_d N_noxref_4_c_97_n ) capacitor c=0.00347355f //x=1.415 \
 //y=1.085 //x2=1.34 //y2=1.43
cc_46 ( N_YN_M0_noxref_d N_noxref_4_c_98_n ) capacitor c=0.00742431f //x=1.415 \
 //y=1.085 //x2=1.34 //y2=1.74
cc_47 ( N_YN_M0_noxref_d N_noxref_4_c_66_n ) capacitor c=0.0191483f //x=1.415 \
 //y=1.085 //x2=1.34 //y2=2.095
cc_48 ( N_YN_M0_noxref_d N_noxref_4_c_67_n ) capacitor c=0.00221752f //x=1.415 \
 //y=1.085 //x2=1.715 //y2=0.93
cc_49 ( N_YN_M0_noxref_d N_noxref_4_c_101_n ) capacitor c=0.0140259f //x=1.415 \
 //y=1.085 //x2=1.715 //y2=1.585
cc_50 ( N_YN_M0_noxref_d N_noxref_4_c_68_n ) capacitor c=0.00218624f //x=1.415 \
 //y=1.085 //x2=1.87 //y2=1.085
cc_51 ( N_YN_M0_noxref_d N_noxref_4_c_70_n ) capacitor c=0.00601286f //x=1.415 \
 //y=1.085 //x2=1.87 //y2=1.43
cc_52 ( N_YN_M0_noxref_d N_noxref_4_c_71_n ) capacitor c=0.00927197f //x=1.415 \
 //y=1.085 //x2=1.23 //y2=2.26
