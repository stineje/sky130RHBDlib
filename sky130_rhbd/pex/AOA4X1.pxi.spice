// File: AOA4X1.spi.AOA4X1.pxi
// Created: Tue Apr 29 10:38:34 2025
//
simulator lang=spectre
x_PM_AOA4X1\%GND ( GND N_GND_c_14_p N_GND_c_90_p N_GND_c_1_p N_GND_c_97_p \
 N_GND_c_116_p N_GND_c_6_p N_GND_c_22_p N_GND_c_34_p N_GND_c_37_p \
 N_GND_c_154_p N_GND_c_43_p N_GND_c_50_p N_GND_c_150_p N_GND_c_62_p \
 N_GND_c_79_p N_GND_c_2_p N_GND_c_3_p N_GND_c_4_p N_GND_c_5_p \
 N_GND_M0_noxref_d N_GND_M2_noxref_s N_GND_M4_noxref_d N_GND_M6_noxref_s )  \
 PM_AOA4X1\%GND
x_PM_AOA4X1\%VDD ( VDD N_VDD_c_194_p N_VDD_c_176_p N_VDD_c_177_p N_VDD_c_188_p \
 N_VDD_c_191_p N_VDD_c_212_p N_VDD_c_224_p N_VDD_c_235_p N_VDD_c_170_n \
 N_VDD_c_171_n N_VDD_c_172_n N_VDD_c_173_n N_VDD_c_174_n N_VDD_M7_noxref_s \
 N_VDD_M8_noxref_d N_VDD_M10_noxref_d N_VDD_M11_noxref_d N_VDD_M15_noxref_s \
 N_VDD_M16_noxref_d N_VDD_M18_noxref_d N_VDD_M19_noxref_s N_VDD_M20_noxref_d ) \
 PM_AOA4X1\%VDD
x_PM_AOA4X1\%noxref_3 ( N_noxref_3_c_311_n N_noxref_3_c_314_n \
 N_noxref_3_c_334_n N_noxref_3_c_337_n N_noxref_3_c_339_n N_noxref_3_c_315_n \
 N_noxref_3_c_410_p N_noxref_3_c_317_n N_noxref_3_c_319_n N_noxref_3_c_398_p \
 N_noxref_3_c_344_n N_noxref_3_M2_noxref_g N_noxref_3_M11_noxref_g \
 N_noxref_3_M12_noxref_g N_noxref_3_c_322_n N_noxref_3_c_372_p \
 N_noxref_3_c_373_p N_noxref_3_c_324_n N_noxref_3_c_326_n N_noxref_3_c_376_p \
 N_noxref_3_c_419_p N_noxref_3_c_327_n N_noxref_3_c_329_n N_noxref_3_c_351_n \
 N_noxref_3_M1_noxref_d N_noxref_3_M7_noxref_d N_noxref_3_M9_noxref_d )  \
 PM_AOA4X1\%noxref_3
x_PM_AOA4X1\%noxref_4 ( N_noxref_4_c_455_n N_noxref_4_c_457_n \
 N_noxref_4_c_459_n N_noxref_4_c_507_n N_noxref_4_c_490_n N_noxref_4_c_492_n \
 N_noxref_4_c_463_n N_noxref_4_c_467_n N_noxref_4_c_469_n \
 N_noxref_4_M4_noxref_g N_noxref_4_M15_noxref_g N_noxref_4_M16_noxref_g \
 N_noxref_4_c_470_n N_noxref_4_c_472_n N_noxref_4_c_473_n N_noxref_4_c_474_n \
 N_noxref_4_c_475_n N_noxref_4_c_476_n N_noxref_4_c_477_n N_noxref_4_c_479_n \
 N_noxref_4_c_501_n N_noxref_4_M2_noxref_d N_noxref_4_M3_noxref_d \
 N_noxref_4_M13_noxref_d )  PM_AOA4X1\%noxref_4
x_PM_AOA4X1\%noxref_5 ( N_noxref_5_c_597_n N_noxref_5_c_600_n \
 N_noxref_5_c_625_n N_noxref_5_c_628_n N_noxref_5_c_630_n N_noxref_5_c_601_n \
 N_noxref_5_c_691_p N_noxref_5_c_603_n N_noxref_5_c_605_n N_noxref_5_c_679_p \
 N_noxref_5_M6_noxref_g N_noxref_5_M19_noxref_g N_noxref_5_M20_noxref_g \
 N_noxref_5_c_610_n N_noxref_5_c_711_p N_noxref_5_c_712_p N_noxref_5_c_612_n \
 N_noxref_5_c_642_n N_noxref_5_c_643_n N_noxref_5_c_613_n N_noxref_5_c_703_p \
 N_noxref_5_c_614_n N_noxref_5_c_616_n N_noxref_5_c_617_n \
 N_noxref_5_M5_noxref_d N_noxref_5_M15_noxref_d N_noxref_5_M17_noxref_d )  \
 PM_AOA4X1\%noxref_5
x_PM_AOA4X1\%A ( A A A A A A A N_A_c_723_n N_A_M0_noxref_g N_A_M7_noxref_g \
 N_A_M8_noxref_g N_A_c_724_n N_A_c_726_n N_A_c_727_n N_A_c_728_n N_A_c_729_n \
 N_A_c_730_n N_A_c_731_n N_A_c_733_n N_A_c_740_n )  PM_AOA4X1\%A
x_PM_AOA4X1\%B ( B B B B B B B N_B_c_787_n N_B_c_778_n N_B_M1_noxref_g \
 N_B_M9_noxref_g N_B_M10_noxref_g N_B_c_796_n N_B_c_797_n N_B_c_798_n \
 N_B_c_799_n N_B_c_801_n N_B_c_802_n N_B_c_804_n N_B_c_805_n N_B_c_807_n \
 N_B_c_808_n N_B_c_810_n )  PM_AOA4X1\%B
x_PM_AOA4X1\%noxref_8 ( N_noxref_8_c_866_n N_noxref_8_c_842_n \
 N_noxref_8_c_846_n N_noxref_8_c_850_n N_noxref_8_c_851_n N_noxref_8_c_854_n \
 N_noxref_8_M0_noxref_s )  PM_AOA4X1\%noxref_8
x_PM_AOA4X1\%C ( C C C C C C C N_C_c_906_n N_C_c_893_n N_C_M3_noxref_g \
 N_C_M13_noxref_g N_C_M14_noxref_g N_C_c_895_n N_C_c_918_n N_C_c_921_n \
 N_C_c_945_n N_C_c_897_n N_C_c_898_n N_C_c_899_n N_C_c_925_n N_C_c_926_n \
 N_C_c_928_n N_C_c_929_n )  PM_AOA4X1\%C
x_PM_AOA4X1\%noxref_10 ( N_noxref_10_c_964_n N_noxref_10_c_968_n \
 N_noxref_10_c_969_n N_noxref_10_c_970_n N_noxref_10_M11_noxref_s \
 N_noxref_10_M12_noxref_d N_noxref_10_M14_noxref_d )  PM_AOA4X1\%noxref_10
x_PM_AOA4X1\%D ( D D D D D D D N_D_c_1016_n N_D_c_1007_n N_D_M5_noxref_g \
 N_D_M17_noxref_g N_D_M18_noxref_g N_D_c_1025_n N_D_c_1028_n N_D_c_1030_n \
 N_D_c_1051_n N_D_c_1053_n N_D_c_1054_n N_D_c_1033_n N_D_c_1034_n N_D_c_1035_n \
 N_D_c_1060_n N_D_c_1037_n )  PM_AOA4X1\%D
x_PM_AOA4X1\%noxref_12 ( N_noxref_12_c_1098_n N_noxref_12_c_1073_n \
 N_noxref_12_c_1077_n N_noxref_12_c_1081_n N_noxref_12_c_1082_n \
 N_noxref_12_c_1085_n N_noxref_12_M4_noxref_s )  PM_AOA4X1\%noxref_12
x_PM_AOA4X1\%Y ( Y Y Y Y Y Y Y N_Y_c_1129_n N_Y_c_1152_n N_Y_c_1139_n \
 N_Y_c_1141_n N_Y_M6_noxref_d N_Y_M19_noxref_d )  PM_AOA4X1\%Y
cc_1 ( N_GND_c_1_p N_VDD_c_170_n ) capacitor c=0.00989514f //x=1.23 //y=0.18 \
 //x2=1.23 //y2=7.58
cc_2 ( N_GND_c_2_p N_VDD_c_171_n ) capacitor c=0.00963367f //x=3.82 //y=0.175 \
 //x2=3.82 //y2=7.585
cc_3 ( N_GND_c_3_p N_VDD_c_172_n ) capacitor c=0.00963367f //x=7.15 //y=0.175 \
 //x2=7.15 //y2=7.585
cc_4 ( N_GND_c_4_p N_VDD_c_173_n ) capacitor c=0.00963367f //x=10.48 //y=0.175 \
 //x2=10.48 //y2=7.585
cc_5 ( N_GND_c_5_p N_VDD_c_174_n ) capacitor c=0.00989514f //x=12.08 //y=0.175 \
 //x2=11.96 //y2=7.58
cc_6 ( N_GND_c_6_p N_noxref_3_c_311_n ) capacitor c=7.233e-19 //x=4.915 \
 //y=0.71 //x2=4.815 //y2=2.77
cc_7 ( N_GND_c_2_p N_noxref_3_c_311_n ) capacitor c=0.0435449f //x=3.82 \
 //y=0.175 //x2=4.815 //y2=2.77
cc_8 ( N_GND_M2_noxref_s N_noxref_3_c_311_n ) capacitor c=0.00494377f //x=4.38 \
 //y=0.545 //x2=4.815 //y2=2.77
cc_9 ( N_GND_c_2_p N_noxref_3_c_314_n ) capacitor c=0.00102529f //x=3.82 \
 //y=0.175 //x2=3.195 //y2=2.77
cc_10 ( N_GND_c_2_p N_noxref_3_c_315_n ) capacitor c=0.0431271f //x=3.82 \
 //y=0.175 //x2=2.995 //y2=1.835
cc_11 ( N_GND_M2_noxref_s N_noxref_3_c_315_n ) capacitor c=3.00901e-19 \
 //x=4.38 //y=0.545 //x2=2.995 //y2=1.835
cc_12 ( N_GND_c_1_p N_noxref_3_c_317_n ) capacitor c=0.00101801f //x=1.23 \
 //y=0.18 //x2=3.08 //y2=2.77
cc_13 ( N_GND_c_2_p N_noxref_3_c_317_n ) capacitor c=5.56859e-19 //x=3.82 \
 //y=0.175 //x2=3.08 //y2=2.77
cc_14 ( N_GND_c_14_p N_noxref_3_c_319_n ) capacitor c=6.77224e-19 //x=11.96 \
 //y=0.18 //x2=4.93 //y2=2.26
cc_15 ( N_GND_c_6_p N_noxref_3_c_319_n ) capacitor c=0.00133267f //x=4.915 \
 //y=0.71 //x2=4.93 //y2=2.26
cc_16 ( N_GND_c_2_p N_noxref_3_c_319_n ) capacitor c=0.0147015f //x=3.82 \
 //y=0.175 //x2=4.93 //y2=2.26
cc_17 ( N_GND_c_6_p N_noxref_3_c_322_n ) capacitor c=0.0122588f //x=4.915 \
 //y=0.71 //x2=4.735 //y2=1.085
cc_18 ( N_GND_M2_noxref_s N_noxref_3_c_322_n ) capacitor c=0.0318086f //x=4.38 \
 //y=0.545 //x2=4.735 //y2=1.085
cc_19 ( N_GND_c_6_p N_noxref_3_c_324_n ) capacitor c=2.1838e-19 //x=4.915 \
 //y=0.71 //x2=4.735 //y2=2.095
cc_20 ( N_GND_c_2_p N_noxref_3_c_324_n ) capacitor c=0.0131707f //x=3.82 \
 //y=0.175 //x2=4.735 //y2=2.095
cc_21 ( N_GND_M2_noxref_s N_noxref_3_c_326_n ) capacitor c=0.00476604f \
 //x=4.38 //y=0.545 //x2=5.11 //y2=0.93
cc_22 ( N_GND_c_22_p N_noxref_3_c_327_n ) capacitor c=0.0113306f //x=5.4 \
 //y=0.71 //x2=5.265 //y2=1.085
cc_23 ( N_GND_M2_noxref_s N_noxref_3_c_327_n ) capacitor c=0.00514143f \
 //x=4.38 //y=0.545 //x2=5.265 //y2=1.085
cc_24 ( N_GND_M2_noxref_s N_noxref_3_c_329_n ) capacitor c=8.33128e-19 \
 //x=4.38 //y=0.545 //x2=5.265 //y2=1.43
cc_25 ( N_GND_c_1_p N_noxref_3_M1_noxref_d ) capacitor c=8.58106e-19 //x=1.23 \
 //y=0.18 //x2=2.45 //y2=1.085
cc_26 ( N_GND_c_2_p N_noxref_3_M1_noxref_d ) capacitor c=0.00616547f //x=3.82 \
 //y=0.175 //x2=2.45 //y2=1.085
cc_27 ( N_GND_M0_noxref_d N_noxref_3_M1_noxref_d ) capacitor c=0.00143464f \
 //x=1.48 //y=1.045 //x2=2.45 //y2=1.085
cc_28 ( N_GND_c_3_p N_noxref_4_c_455_n ) capacitor c=0.0435449f //x=7.15 \
 //y=0.175 //x2=8.145 //y2=2.77
cc_29 ( N_GND_M2_noxref_s N_noxref_4_c_455_n ) capacitor c=3.07352e-19 \
 //x=4.38 //y=0.545 //x2=8.145 //y2=2.77
cc_30 ( N_GND_c_3_p N_noxref_4_c_457_n ) capacitor c=0.00102529f //x=7.15 \
 //y=0.175 //x2=6.525 //y2=2.77
cc_31 ( N_GND_M2_noxref_s N_noxref_4_c_457_n ) capacitor c=0.00162167f \
 //x=4.38 //y=0.545 //x2=6.525 //y2=2.77
cc_32 ( N_GND_c_14_p N_noxref_4_c_459_n ) capacitor c=0.00359332f //x=11.96 \
 //y=0.18 //x2=5.885 //y2=1.835
cc_33 ( N_GND_c_22_p N_noxref_4_c_459_n ) capacitor c=0.00381844f //x=5.4 \
 //y=0.71 //x2=5.885 //y2=1.835
cc_34 ( N_GND_c_34_p N_noxref_4_c_459_n ) capacitor c=0.00323369f //x=5.885 \
 //y=0.71 //x2=5.885 //y2=1.835
cc_35 ( N_GND_M2_noxref_s N_noxref_4_c_459_n ) capacitor c=0.0173696f //x=4.38 \
 //y=0.545 //x2=5.885 //y2=1.835
cc_36 ( N_GND_c_14_p N_noxref_4_c_463_n ) capacitor c=0.00233035f //x=11.96 \
 //y=0.18 //x2=6.325 //y2=1.835
cc_37 ( N_GND_c_37_p N_noxref_4_c_463_n ) capacitor c=0.00479063f //x=6.37 \
 //y=0.71 //x2=6.325 //y2=1.835
cc_38 ( N_GND_c_3_p N_noxref_4_c_463_n ) capacitor c=0.04345f //x=7.15 \
 //y=0.175 //x2=6.325 //y2=1.835
cc_39 ( N_GND_M2_noxref_s N_noxref_4_c_463_n ) capacitor c=0.0145664f //x=4.38 \
 //y=0.545 //x2=6.325 //y2=1.835
cc_40 ( N_GND_c_2_p N_noxref_4_c_467_n ) capacitor c=9.64732e-19 //x=3.82 \
 //y=0.175 //x2=6.41 //y2=2.77
cc_41 ( N_GND_c_3_p N_noxref_4_c_467_n ) capacitor c=5.56859e-19 //x=7.15 \
 //y=0.175 //x2=6.41 //y2=2.77
cc_42 ( N_GND_c_3_p N_noxref_4_c_469_n ) capacitor c=0.0150626f //x=7.15 \
 //y=0.175 //x2=8.26 //y2=2.26
cc_43 ( N_GND_c_43_p N_noxref_4_c_470_n ) capacitor c=0.00135783f //x=8.245 \
 //y=0.175 //x2=8.065 //y2=1.045
cc_44 ( N_GND_M4_noxref_d N_noxref_4_c_470_n ) capacitor c=0.00220047f \
 //x=8.14 //y=1.045 //x2=8.065 //y2=1.045
cc_45 ( N_GND_M4_noxref_d N_noxref_4_c_472_n ) capacitor c=0.00255985f \
 //x=8.14 //y=1.045 //x2=8.065 //y2=1.39
cc_46 ( N_GND_c_3_p N_noxref_4_c_473_n ) capacitor c=0.0018059f //x=7.15 \
 //y=0.175 //x2=8.065 //y2=1.7
cc_47 ( N_GND_c_3_p N_noxref_4_c_474_n ) capacitor c=0.0114883f //x=7.15 \
 //y=0.175 //x2=8.065 //y2=2.095
cc_48 ( N_GND_M4_noxref_d N_noxref_4_c_475_n ) capacitor c=0.0131374f //x=8.14 \
 //y=1.045 //x2=8.44 //y2=0.89
cc_49 ( N_GND_M4_noxref_d N_noxref_4_c_476_n ) capacitor c=0.00193146f \
 //x=8.14 //y=1.045 //x2=8.44 //y2=1.545
cc_50 ( N_GND_c_50_p N_noxref_4_c_477_n ) capacitor c=0.00131234f //x=10.31 \
 //y=0.175 //x2=8.595 //y2=1.045
cc_51 ( N_GND_M4_noxref_d N_noxref_4_c_477_n ) capacitor c=0.00257848f \
 //x=8.14 //y=1.045 //x2=8.595 //y2=1.045
cc_52 ( N_GND_M4_noxref_d N_noxref_4_c_479_n ) capacitor c=0.00255985f \
 //x=8.14 //y=1.045 //x2=8.595 //y2=1.39
cc_53 ( N_GND_c_14_p N_noxref_4_M2_noxref_d ) capacitor c=0.00175671f \
 //x=11.96 //y=0.18 //x2=4.81 //y2=1.085
cc_54 ( N_GND_c_2_p N_noxref_4_M2_noxref_d ) capacitor c=0.00416273f //x=3.82 \
 //y=0.175 //x2=4.81 //y2=1.085
cc_55 ( N_GND_c_3_p N_noxref_4_M2_noxref_d ) capacitor c=2.57516e-19 //x=7.15 \
 //y=0.175 //x2=4.81 //y2=1.085
cc_56 ( N_GND_c_5_p N_noxref_4_M2_noxref_d ) capacitor c=2.31043e-19 //x=12.08 \
 //y=0.175 //x2=4.81 //y2=1.085
cc_57 ( N_GND_M2_noxref_s N_noxref_4_M2_noxref_d ) capacitor c=0.0769615f \
 //x=4.38 //y=0.545 //x2=4.81 //y2=1.085
cc_58 ( N_GND_c_14_p N_noxref_4_M3_noxref_d ) capacitor c=0.00195238f \
 //x=11.96 //y=0.18 //x2=5.78 //y2=1.085
cc_59 ( N_GND_c_3_p N_noxref_4_M3_noxref_d ) capacitor c=0.00609243f //x=7.15 \
 //y=0.175 //x2=5.78 //y2=1.085
cc_60 ( N_GND_c_5_p N_noxref_4_M3_noxref_d ) capacitor c=2.31043e-19 //x=12.08 \
 //y=0.175 //x2=5.78 //y2=1.085
cc_61 ( N_GND_M2_noxref_s N_noxref_4_M3_noxref_d ) capacitor c=0.061033f \
 //x=4.38 //y=0.545 //x2=5.78 //y2=1.085
cc_62 ( N_GND_c_62_p N_noxref_5_c_597_n ) capacitor c=2.8021e-19 //x=11.51 \
 //y=0.715 //x2=11.105 //y2=2.77
cc_63 ( N_GND_c_4_p N_noxref_5_c_597_n ) capacitor c=0.0424932f //x=10.48 \
 //y=0.175 //x2=11.105 //y2=2.77
cc_64 ( N_GND_M6_noxref_s N_noxref_5_c_597_n ) capacitor c=0.00380507f \
 //x=10.975 //y=0.55 //x2=11.105 //y2=2.77
cc_65 ( N_GND_c_4_p N_noxref_5_c_600_n ) capacitor c=9.11674e-19 //x=10.48 \
 //y=0.175 //x2=9.855 //y2=2.77
cc_66 ( N_GND_c_4_p N_noxref_5_c_601_n ) capacitor c=0.0429465f //x=10.48 \
 //y=0.175 //x2=9.655 //y2=1.835
cc_67 ( N_GND_M6_noxref_s N_noxref_5_c_601_n ) capacitor c=3.37896e-19 \
 //x=10.975 //y=0.55 //x2=9.655 //y2=1.835
cc_68 ( N_GND_c_3_p N_noxref_5_c_603_n ) capacitor c=9.64732e-19 //x=7.15 \
 //y=0.175 //x2=9.74 //y2=2.77
cc_69 ( N_GND_c_4_p N_noxref_5_c_603_n ) capacitor c=5.56859e-19 //x=10.48 \
 //y=0.175 //x2=9.74 //y2=2.77
cc_70 ( N_GND_c_14_p N_noxref_5_c_605_n ) capacitor c=0.00203126f //x=11.96 \
 //y=0.18 //x2=11.22 //y2=2.265
cc_71 ( N_GND_c_62_p N_noxref_5_c_605_n ) capacitor c=7.79915e-19 //x=11.51 \
 //y=0.715 //x2=11.22 //y2=2.265
cc_72 ( N_GND_c_4_p N_noxref_5_c_605_n ) capacitor c=0.0264037f //x=10.48 \
 //y=0.175 //x2=11.22 //y2=2.265
cc_73 ( N_GND_c_5_p N_noxref_5_c_605_n ) capacitor c=0.00135052f //x=12.08 \
 //y=0.175 //x2=11.22 //y2=2.265
cc_74 ( N_GND_M6_noxref_s N_noxref_5_c_605_n ) capacitor c=0.0105404f \
 //x=10.975 //y=0.55 //x2=11.22 //y2=2.265
cc_75 ( N_GND_c_62_p N_noxref_5_c_610_n ) capacitor c=0.0121156f //x=11.51 \
 //y=0.715 //x2=11.33 //y2=1.09
cc_76 ( N_GND_M6_noxref_s N_noxref_5_c_610_n ) capacitor c=0.0317792f \
 //x=10.975 //y=0.55 //x2=11.33 //y2=1.09
cc_77 ( N_GND_c_4_p N_noxref_5_c_612_n ) capacitor c=0.0056248f //x=10.48 \
 //y=0.175 //x2=11.33 //y2=2.1
cc_78 ( N_GND_M6_noxref_s N_noxref_5_c_613_n ) capacitor c=0.00483567f \
 //x=10.975 //y=0.55 //x2=11.705 //y2=0.935
cc_79 ( N_GND_c_79_p N_noxref_5_c_614_n ) capacitor c=0.0118631f //x=11.995 \
 //y=0.715 //x2=11.86 //y2=1.09
cc_80 ( N_GND_M6_noxref_s N_noxref_5_c_614_n ) capacitor c=0.0143355f \
 //x=10.975 //y=0.55 //x2=11.86 //y2=1.09
cc_81 ( N_GND_M6_noxref_s N_noxref_5_c_616_n ) capacitor c=0.0074042f \
 //x=10.975 //y=0.55 //x2=11.86 //y2=1.435
cc_82 ( N_GND_c_62_p N_noxref_5_c_617_n ) capacitor c=2.1838e-19 //x=11.51 \
 //y=0.715 //x2=11.22 //y2=2.265
cc_83 ( N_GND_c_4_p N_noxref_5_c_617_n ) capacitor c=0.0108179f //x=10.48 \
 //y=0.175 //x2=11.22 //y2=2.265
cc_84 ( N_GND_M6_noxref_s N_noxref_5_c_617_n ) capacitor c=0.006523f \
 //x=10.975 //y=0.55 //x2=11.22 //y2=2.265
cc_85 ( N_GND_c_3_p N_noxref_5_M5_noxref_d ) capacitor c=8.58106e-19 //x=7.15 \
 //y=0.175 //x2=9.11 //y2=1.085
cc_86 ( N_GND_c_4_p N_noxref_5_M5_noxref_d ) capacitor c=0.00616547f //x=10.48 \
 //y=0.175 //x2=9.11 //y2=1.085
cc_87 ( N_GND_M4_noxref_d N_noxref_5_M5_noxref_d ) capacitor c=0.00143464f \
 //x=8.14 //y=1.045 //x2=9.11 //y2=1.085
cc_88 ( N_GND_M6_noxref_s N_noxref_5_M5_noxref_d ) capacitor c=2.09402e-19 \
 //x=10.975 //y=0.55 //x2=9.11 //y2=1.085
cc_89 ( N_GND_c_1_p N_A_c_723_n ) capacitor c=0.0180518f //x=1.23 //y=0.18 \
 //x2=1.6 //y2=2.26
cc_90 ( N_GND_c_90_p N_A_c_724_n ) capacitor c=0.00135783f //x=1.585 //y=0.175 \
 //x2=1.405 //y2=1.045
cc_91 ( N_GND_M0_noxref_d N_A_c_724_n ) capacitor c=0.00220047f //x=1.48 \
 //y=1.045 //x2=1.405 //y2=1.045
cc_92 ( N_GND_M0_noxref_d N_A_c_726_n ) capacitor c=0.00255985f //x=1.48 \
 //y=1.045 //x2=1.405 //y2=1.39
cc_93 ( N_GND_c_1_p N_A_c_727_n ) capacitor c=0.00264481f //x=1.23 //y=0.18 \
 //x2=1.405 //y2=1.7
cc_94 ( N_GND_c_1_p N_A_c_728_n ) capacitor c=0.0121947f //x=1.23 //y=0.18 \
 //x2=1.405 //y2=2.095
cc_95 ( N_GND_M0_noxref_d N_A_c_729_n ) capacitor c=0.0131374f //x=1.48 \
 //y=1.045 //x2=1.78 //y2=0.89
cc_96 ( N_GND_M0_noxref_d N_A_c_730_n ) capacitor c=0.00193146f //x=1.48 \
 //y=1.045 //x2=1.78 //y2=1.545
cc_97 ( N_GND_c_97_p N_A_c_731_n ) capacitor c=0.00131234f //x=3.65 //y=0.175 \
 //x2=1.935 //y2=1.045
cc_98 ( N_GND_M0_noxref_d N_A_c_731_n ) capacitor c=0.00257848f //x=1.48 \
 //y=1.045 //x2=1.935 //y2=1.045
cc_99 ( N_GND_M0_noxref_d N_A_c_733_n ) capacitor c=0.00255985f //x=1.48 \
 //y=1.045 //x2=1.935 //y2=1.39
cc_100 ( N_GND_c_1_p N_B_c_778_n ) capacitor c=9.2064e-19 //x=1.23 //y=0.18 \
 //x2=2.34 //y2=2.26
cc_101 ( N_GND_c_2_p N_B_c_778_n ) capacitor c=0.00110071f //x=3.82 //y=0.175 \
 //x2=2.34 //y2=2.26
cc_102 ( N_GND_c_14_p N_noxref_8_c_842_n ) capacitor c=0.00711001f //x=11.96 \
 //y=0.18 //x2=2.07 //y2=1.76
cc_103 ( N_GND_c_90_p N_noxref_8_c_842_n ) capacitor c=0.00111556f //x=1.585 \
 //y=0.175 //x2=2.07 //y2=1.76
cc_104 ( N_GND_c_97_p N_noxref_8_c_842_n ) capacitor c=0.00181083f //x=3.65 \
 //y=0.175 //x2=2.07 //y2=1.76
cc_105 ( N_GND_M0_noxref_d N_noxref_8_c_842_n ) capacitor c=0.00909955f \
 //x=1.48 //y=1.045 //x2=2.07 //y2=1.76
cc_106 ( N_GND_c_14_p N_noxref_8_c_846_n ) capacitor c=0.00724992f //x=11.96 \
 //y=0.18 //x2=2.155 //y2=0.795
cc_107 ( N_GND_c_97_p N_noxref_8_c_846_n ) capacitor c=0.014661f //x=3.65 \
 //y=0.175 //x2=2.155 //y2=0.795
cc_108 ( N_GND_c_5_p N_noxref_8_c_846_n ) capacitor c=0.00145873f //x=12.08 \
 //y=0.175 //x2=2.155 //y2=0.795
cc_109 ( N_GND_M0_noxref_d N_noxref_8_c_846_n ) capacitor c=0.033812f //x=1.48 \
 //y=1.045 //x2=2.155 //y2=0.795
cc_110 ( N_GND_c_1_p N_noxref_8_c_850_n ) capacitor c=2.91423e-19 //x=1.23 \
 //y=0.18 //x2=2.155 //y2=1.675
cc_111 ( N_GND_c_14_p N_noxref_8_c_851_n ) capacitor c=0.0199827f //x=11.96 \
 //y=0.18 //x2=3.04 //y2=0.71
cc_112 ( N_GND_c_97_p N_noxref_8_c_851_n ) capacitor c=0.0371502f //x=3.65 \
 //y=0.175 //x2=3.04 //y2=0.71
cc_113 ( N_GND_c_5_p N_noxref_8_c_851_n ) capacitor c=0.00199095f //x=12.08 \
 //y=0.175 //x2=3.04 //y2=0.71
cc_114 ( N_GND_c_14_p N_noxref_8_c_854_n ) capacitor c=0.00720883f //x=11.96 \
 //y=0.18 //x2=3.125 //y2=0.795
cc_115 ( N_GND_c_97_p N_noxref_8_c_854_n ) capacitor c=0.0144635f //x=3.65 \
 //y=0.175 //x2=3.125 //y2=0.795
cc_116 ( N_GND_c_116_p N_noxref_8_c_854_n ) capacitor c=9.02073e-19 //x=4.515 \
 //y=0.625 //x2=3.125 //y2=0.795
cc_117 ( N_GND_c_2_p N_noxref_8_c_854_n ) capacitor c=0.0431718f //x=3.82 \
 //y=0.175 //x2=3.125 //y2=0.795
cc_118 ( N_GND_c_5_p N_noxref_8_c_854_n ) capacitor c=0.00145015f //x=12.08 \
 //y=0.175 //x2=3.125 //y2=0.795
cc_119 ( N_GND_c_14_p N_noxref_8_M0_noxref_s ) capacitor c=0.00724992f \
 //x=11.96 //y=0.18 //x2=1.05 //y2=0.545
cc_120 ( N_GND_c_90_p N_noxref_8_M0_noxref_s ) capacitor c=0.014661f //x=1.585 \
 //y=0.175 //x2=1.05 //y2=0.545
cc_121 ( N_GND_c_1_p N_noxref_8_M0_noxref_s ) capacitor c=0.0594057f //x=1.23 \
 //y=0.18 //x2=1.05 //y2=0.545
cc_122 ( N_GND_c_2_p N_noxref_8_M0_noxref_s ) capacitor c=0.00198043f //x=3.82 \
 //y=0.175 //x2=1.05 //y2=0.545
cc_123 ( N_GND_c_5_p N_noxref_8_M0_noxref_s ) capacitor c=0.00145873f \
 //x=12.08 //y=0.175 //x2=1.05 //y2=0.545
cc_124 ( N_GND_M0_noxref_d N_noxref_8_M0_noxref_s ) capacitor c=0.0334197f \
 //x=1.48 //y=1.045 //x2=1.05 //y2=0.545
cc_125 ( N_GND_M2_noxref_s N_noxref_8_M0_noxref_s ) capacitor c=9.02073e-19 \
 //x=4.38 //y=0.545 //x2=1.05 //y2=0.545
cc_126 ( N_GND_c_2_p N_C_c_893_n ) capacitor c=0.00112835f //x=3.82 //y=0.175 \
 //x2=5.67 //y2=2.26
cc_127 ( N_GND_c_3_p N_C_c_893_n ) capacitor c=0.00110071f //x=7.15 //y=0.175 \
 //x2=5.67 //y2=2.26
cc_128 ( N_GND_c_34_p N_C_c_895_n ) capacitor c=0.0109831f //x=5.885 //y=0.71 \
 //x2=5.705 //y2=1.085
cc_129 ( N_GND_M2_noxref_s N_C_c_895_n ) capacitor c=0.00590563f //x=4.38 \
 //y=0.545 //x2=5.705 //y2=1.085
cc_130 ( N_GND_M2_noxref_s N_C_c_897_n ) capacitor c=0.00467042f //x=4.38 \
 //y=0.545 //x2=6.08 //y2=0.93
cc_131 ( N_GND_M2_noxref_s N_C_c_898_n ) capacitor c=0.00316186f //x=4.38 \
 //y=0.545 //x2=6.08 //y2=1.585
cc_132 ( N_GND_c_37_p N_C_c_899_n ) capacitor c=0.011235f //x=6.37 //y=0.71 \
 //x2=6.235 //y2=1.085
cc_133 ( N_GND_M2_noxref_s N_C_c_899_n ) capacitor c=0.0142835f //x=4.38 \
 //y=0.545 //x2=6.235 //y2=1.085
cc_134 ( N_GND_c_3_p N_D_c_1007_n ) capacitor c=0.00112835f //x=7.15 //y=0.175 \
 //x2=9 //y2=2.26
cc_135 ( N_GND_c_4_p N_D_c_1007_n ) capacitor c=0.00110071f //x=10.48 \
 //y=0.175 //x2=9 //y2=2.26
cc_136 ( N_GND_c_14_p N_noxref_12_c_1073_n ) capacitor c=0.00708133f //x=11.96 \
 //y=0.18 //x2=8.73 //y2=1.76
cc_137 ( N_GND_c_43_p N_noxref_12_c_1073_n ) capacitor c=0.00111556f //x=8.245 \
 //y=0.175 //x2=8.73 //y2=1.76
cc_138 ( N_GND_c_50_p N_noxref_12_c_1073_n ) capacitor c=0.00181083f //x=10.31 \
 //y=0.175 //x2=8.73 //y2=1.76
cc_139 ( N_GND_M4_noxref_d N_noxref_12_c_1073_n ) capacitor c=0.00881064f \
 //x=8.14 //y=1.045 //x2=8.73 //y2=1.76
cc_140 ( N_GND_c_14_p N_noxref_12_c_1077_n ) capacitor c=0.00724992f //x=11.96 \
 //y=0.18 //x2=8.815 //y2=0.795
cc_141 ( N_GND_c_50_p N_noxref_12_c_1077_n ) capacitor c=0.014661f //x=10.31 \
 //y=0.175 //x2=8.815 //y2=0.795
cc_142 ( N_GND_c_5_p N_noxref_12_c_1077_n ) capacitor c=0.00145873f //x=12.08 \
 //y=0.175 //x2=8.815 //y2=0.795
cc_143 ( N_GND_M4_noxref_d N_noxref_12_c_1077_n ) capacitor c=0.033812f \
 //x=8.14 //y=1.045 //x2=8.815 //y2=0.795
cc_144 ( N_GND_c_3_p N_noxref_12_c_1081_n ) capacitor c=2.91423e-19 //x=7.15 \
 //y=0.175 //x2=8.815 //y2=1.675
cc_145 ( N_GND_c_14_p N_noxref_12_c_1082_n ) capacitor c=0.0199827f //x=11.96 \
 //y=0.18 //x2=9.7 //y2=0.71
cc_146 ( N_GND_c_50_p N_noxref_12_c_1082_n ) capacitor c=0.0371502f //x=10.31 \
 //y=0.175 //x2=9.7 //y2=0.71
cc_147 ( N_GND_c_5_p N_noxref_12_c_1082_n ) capacitor c=0.00199095f //x=12.08 \
 //y=0.175 //x2=9.7 //y2=0.71
cc_148 ( N_GND_c_14_p N_noxref_12_c_1085_n ) capacitor c=0.00720883f //x=11.96 \
 //y=0.18 //x2=9.785 //y2=0.795
cc_149 ( N_GND_c_50_p N_noxref_12_c_1085_n ) capacitor c=0.0144635f //x=10.31 \
 //y=0.175 //x2=9.785 //y2=0.795
cc_150 ( N_GND_c_150_p N_noxref_12_c_1085_n ) capacitor c=9.77746e-19 \
 //x=11.11 //y=0.63 //x2=9.785 //y2=0.795
cc_151 ( N_GND_c_4_p N_noxref_12_c_1085_n ) capacitor c=0.0431718f //x=10.48 \
 //y=0.175 //x2=9.785 //y2=0.795
cc_152 ( N_GND_c_5_p N_noxref_12_c_1085_n ) capacitor c=0.00145015f //x=12.08 \
 //y=0.175 //x2=9.785 //y2=0.795
cc_153 ( N_GND_c_14_p N_noxref_12_M4_noxref_s ) capacitor c=0.00724992f \
 //x=11.96 //y=0.18 //x2=7.71 //y2=0.545
cc_154 ( N_GND_c_154_p N_noxref_12_M4_noxref_s ) capacitor c=0.00177507f \
 //x=6.455 //y=0.625 //x2=7.71 //y2=0.545
cc_155 ( N_GND_c_43_p N_noxref_12_M4_noxref_s ) capacitor c=0.014661f \
 //x=8.245 //y=0.175 //x2=7.71 //y2=0.545
cc_156 ( N_GND_c_3_p N_noxref_12_M4_noxref_s ) capacitor c=0.058339f //x=7.15 \
 //y=0.175 //x2=7.71 //y2=0.545
cc_157 ( N_GND_c_4_p N_noxref_12_M4_noxref_s ) capacitor c=0.00198098f \
 //x=10.48 //y=0.175 //x2=7.71 //y2=0.545
cc_158 ( N_GND_c_5_p N_noxref_12_M4_noxref_s ) capacitor c=0.00145873f \
 //x=12.08 //y=0.175 //x2=7.71 //y2=0.545
cc_159 ( N_GND_M4_noxref_d N_noxref_12_M4_noxref_s ) capacitor c=0.0334197f \
 //x=8.14 //y=1.045 //x2=7.71 //y2=0.545
cc_160 ( N_GND_M6_noxref_s N_noxref_12_M4_noxref_s ) capacitor c=9.77746e-19 \
 //x=10.975 //y=0.55 //x2=7.71 //y2=0.545
cc_161 ( N_GND_c_4_p Y ) capacitor c=9.57726e-19 //x=10.48 //y=0.175 \
 //x2=11.96 //y2=2.4
cc_162 ( N_GND_c_14_p N_Y_c_1129_n ) capacitor c=0.00212303f //x=11.96 \
 //y=0.18 //x2=11.875 //y2=2.26
cc_163 ( N_GND_c_5_p N_Y_c_1129_n ) capacitor c=0.029556f //x=12.08 //y=0.175 \
 //x2=11.875 //y2=2.26
cc_164 ( N_GND_M6_noxref_s N_Y_c_1129_n ) capacitor c=0.0099963f //x=10.975 \
 //y=0.55 //x2=11.875 //y2=2.26
cc_165 ( N_GND_c_14_p N_Y_M6_noxref_d ) capacitor c=0.00194747f //x=11.96 \
 //y=0.18 //x2=11.405 //y2=1.09
cc_166 ( N_GND_c_62_p N_Y_M6_noxref_d ) capacitor c=0.014622f //x=11.51 \
 //y=0.715 //x2=11.405 //y2=1.09
cc_167 ( N_GND_c_4_p N_Y_M6_noxref_d ) capacitor c=0.00924905f //x=10.48 \
 //y=0.175 //x2=11.405 //y2=1.09
cc_168 ( N_GND_c_5_p N_Y_M6_noxref_d ) capacitor c=0.00973758f //x=12.08 \
 //y=0.175 //x2=11.405 //y2=1.09
cc_169 ( N_GND_M6_noxref_s N_Y_M6_noxref_d ) capacitor c=0.076995f //x=10.975 \
 //y=0.55 //x2=11.405 //y2=1.09
cc_170 ( N_VDD_c_171_n N_noxref_3_c_311_n ) capacitor c=0.00382819f //x=3.82 \
 //y=7.585 //x2=4.815 //y2=2.77
cc_171 ( N_VDD_c_176_p N_noxref_3_c_334_n ) capacitor c=5.7743e-19 //x=2.075 \
 //y=7.585 //x2=2.515 //y2=5.38
cc_172 ( N_VDD_c_177_p N_noxref_3_c_334_n ) capacitor c=5.7743e-19 //x=2.955 \
 //y=7.585 //x2=2.515 //y2=5.38
cc_173 ( N_VDD_M8_noxref_d N_noxref_3_c_334_n ) capacitor c=0.0132783f \
 //x=2.015 //y=5.2 //x2=2.515 //y2=5.38
cc_174 ( N_VDD_c_170_n N_noxref_3_c_337_n ) capacitor c=0.00989999f //x=1.23 \
 //y=7.58 //x2=1.805 //y2=5.38
cc_175 ( N_VDD_M7_noxref_s N_noxref_3_c_337_n ) capacitor c=0.087833f \
 //x=1.145 //y=5.2 //x2=1.805 //y2=5.38
cc_176 ( N_VDD_c_177_p N_noxref_3_c_339_n ) capacitor c=8.72934e-19 //x=2.955 \
 //y=7.585 //x2=2.995 //y2=5.38
cc_177 ( N_VDD_M10_noxref_d N_noxref_3_c_339_n ) capacitor c=0.0167847f \
 //x=2.895 //y=5.2 //x2=2.995 //y2=5.38
cc_178 ( N_VDD_c_170_n N_noxref_3_c_317_n ) capacitor c=0.00159771f //x=1.23 \
 //y=7.58 //x2=3.08 //y2=2.77
cc_179 ( N_VDD_c_171_n N_noxref_3_c_317_n ) capacitor c=0.0462672f //x=3.82 \
 //y=7.585 //x2=3.08 //y2=2.77
cc_180 ( N_VDD_c_171_n N_noxref_3_c_319_n ) capacitor c=0.0103855f //x=3.82 \
 //y=7.585 //x2=4.93 //y2=2.26
cc_181 ( N_VDD_c_171_n N_noxref_3_c_344_n ) capacitor c=0.00860173f //x=3.82 \
 //y=7.585 //x2=4.775 //y2=4.885
cc_182 ( N_VDD_M11_noxref_d N_noxref_3_c_344_n ) capacitor c=2.85066e-19 \
 //x=4.905 //y=5.205 //x2=4.775 //y2=4.885
cc_183 ( N_VDD_c_188_p N_noxref_3_M11_noxref_g ) capacitor c=0.00683851f \
 //x=4.965 //y=7.585 //x2=4.83 //y2=6.205
cc_184 ( N_VDD_c_171_n N_noxref_3_M11_noxref_g ) capacitor c=0.0105272f \
 //x=3.82 //y=7.585 //x2=4.83 //y2=6.205
cc_185 ( N_VDD_M11_noxref_d N_noxref_3_M11_noxref_g ) capacitor c=0.0156786f \
 //x=4.905 //y=5.205 //x2=4.83 //y2=6.205
cc_186 ( N_VDD_c_191_p N_noxref_3_M12_noxref_g ) capacitor c=0.0068279f \
 //x=6.98 //y=7.585 //x2=5.27 //y2=6.205
cc_187 ( N_VDD_M11_noxref_d N_noxref_3_M12_noxref_g ) capacitor c=0.0183011f \
 //x=4.905 //y=5.205 //x2=5.27 //y2=6.205
cc_188 ( N_VDD_c_171_n N_noxref_3_c_351_n ) capacitor c=0.00890932f //x=3.82 \
 //y=7.585 //x2=4.775 //y2=4.885
cc_189 ( N_VDD_c_194_p N_noxref_3_M7_noxref_d ) capacitor c=0.00720906f \
 //x=11.96 //y=7.58 //x2=1.575 //y2=5.2
cc_190 ( N_VDD_c_176_p N_noxref_3_M7_noxref_d ) capacitor c=0.0138506f \
 //x=2.075 //y=7.585 //x2=1.575 //y2=5.2
cc_191 ( N_VDD_c_171_n N_noxref_3_M7_noxref_d ) capacitor c=6.94454e-19 \
 //x=3.82 //y=7.585 //x2=1.575 //y2=5.2
cc_192 ( N_VDD_c_174_n N_noxref_3_M7_noxref_d ) capacitor c=0.00135231f \
 //x=11.96 //y=7.58 //x2=1.575 //y2=5.2
cc_193 ( N_VDD_M8_noxref_d N_noxref_3_M7_noxref_d ) capacitor c=0.0664752f \
 //x=2.015 //y=5.2 //x2=1.575 //y2=5.2
cc_194 ( N_VDD_c_194_p N_noxref_3_M9_noxref_d ) capacitor c=0.00720906f \
 //x=11.96 //y=7.58 //x2=2.455 //y2=5.2
cc_195 ( N_VDD_c_177_p N_noxref_3_M9_noxref_d ) capacitor c=0.0138783f \
 //x=2.955 //y=7.585 //x2=2.455 //y2=5.2
cc_196 ( N_VDD_c_171_n N_noxref_3_M9_noxref_d ) capacitor c=0.0120541f \
 //x=3.82 //y=7.585 //x2=2.455 //y2=5.2
cc_197 ( N_VDD_c_174_n N_noxref_3_M9_noxref_d ) capacitor c=0.00135231f \
 //x=11.96 //y=7.58 //x2=2.455 //y2=5.2
cc_198 ( N_VDD_M7_noxref_s N_noxref_3_M9_noxref_d ) capacitor c=0.00111971f \
 //x=1.145 //y=5.2 //x2=2.455 //y2=5.2
cc_199 ( N_VDD_M8_noxref_d N_noxref_3_M9_noxref_d ) capacitor c=0.0664752f \
 //x=2.015 //y=5.2 //x2=2.455 //y2=5.2
cc_200 ( N_VDD_M10_noxref_d N_noxref_3_M9_noxref_d ) capacitor c=0.0664752f \
 //x=2.895 //y=5.2 //x2=2.455 //y2=5.2
cc_201 ( N_VDD_c_172_n N_noxref_4_c_455_n ) capacitor c=0.00382819f //x=7.15 \
 //y=7.585 //x2=8.145 //y2=2.77
cc_202 ( N_VDD_c_191_p N_noxref_4_c_490_n ) capacitor c=9.662e-19 //x=6.98 \
 //y=7.585 //x2=6.325 //y2=5.39
cc_203 ( N_VDD_M15_noxref_s N_noxref_4_c_490_n ) capacitor c=2.47894e-19 \
 //x=7.805 //y=5.2 //x2=6.325 //y2=5.39
cc_204 ( N_VDD_c_171_n N_noxref_4_c_492_n ) capacitor c=8.9933e-19 //x=3.82 \
 //y=7.585 //x2=6.015 //y2=5.39
cc_205 ( N_VDD_c_171_n N_noxref_4_c_467_n ) capacitor c=0.00155409f //x=3.82 \
 //y=7.585 //x2=6.41 //y2=2.77
cc_206 ( N_VDD_c_172_n N_noxref_4_c_467_n ) capacitor c=0.0462858f //x=7.15 \
 //y=7.585 //x2=6.41 //y2=2.77
cc_207 ( N_VDD_c_212_p N_noxref_4_c_469_n ) capacitor c=3.98531e-19 //x=8.735 \
 //y=7.585 //x2=8.26 //y2=2.26
cc_208 ( N_VDD_c_172_n N_noxref_4_c_469_n ) capacitor c=0.0167437f //x=7.15 \
 //y=7.585 //x2=8.26 //y2=2.26
cc_209 ( N_VDD_c_212_p N_noxref_4_M15_noxref_g ) capacitor c=0.00732332f \
 //x=8.735 //y=7.585 //x2=8.16 //y2=6.2
cc_210 ( N_VDD_M15_noxref_s N_noxref_4_M15_noxref_g ) capacitor c=0.054195f \
 //x=7.805 //y=5.2 //x2=8.16 //y2=6.2
cc_211 ( N_VDD_c_212_p N_noxref_4_M16_noxref_g ) capacitor c=0.00677553f \
 //x=8.735 //y=7.585 //x2=8.6 //y2=6.2
cc_212 ( N_VDD_M16_noxref_d N_noxref_4_M16_noxref_g ) capacitor c=0.015318f \
 //x=8.675 //y=5.2 //x2=8.6 //y2=6.2
cc_213 ( N_VDD_c_172_n N_noxref_4_c_501_n ) capacitor c=0.0162221f //x=7.15 \
 //y=7.585 //x2=8.26 //y2=4.88
cc_214 ( N_VDD_c_172_n N_noxref_4_M13_noxref_d ) capacitor c=0.00966019f \
 //x=7.15 //y=7.585 //x2=5.785 //y2=5.205
cc_215 ( N_VDD_M11_noxref_d N_noxref_4_M13_noxref_d ) capacitor c=0.00561178f \
 //x=4.905 //y=5.205 //x2=5.785 //y2=5.205
cc_216 ( N_VDD_M15_noxref_s N_noxref_4_M13_noxref_d ) capacitor c=4.37644e-19 \
 //x=7.805 //y=5.2 //x2=5.785 //y2=5.205
cc_217 ( N_VDD_c_173_n N_noxref_5_c_597_n ) capacitor c=0.00382819f //x=10.48 \
 //y=7.585 //x2=11.105 //y2=2.77
cc_218 ( N_VDD_c_212_p N_noxref_5_c_625_n ) capacitor c=5.7743e-19 //x=8.735 \
 //y=7.585 //x2=9.175 //y2=5.38
cc_219 ( N_VDD_c_224_p N_noxref_5_c_625_n ) capacitor c=5.7743e-19 //x=9.615 \
 //y=7.585 //x2=9.175 //y2=5.38
cc_220 ( N_VDD_M16_noxref_d N_noxref_5_c_625_n ) capacitor c=0.0132783f \
 //x=8.675 //y=5.2 //x2=9.175 //y2=5.38
cc_221 ( N_VDD_c_172_n N_noxref_5_c_628_n ) capacitor c=0.00985474f //x=7.15 \
 //y=7.585 //x2=8.465 //y2=5.38
cc_222 ( N_VDD_M15_noxref_s N_noxref_5_c_628_n ) capacitor c=0.087833f \
 //x=7.805 //y=5.2 //x2=8.465 //y2=5.38
cc_223 ( N_VDD_c_224_p N_noxref_5_c_630_n ) capacitor c=8.72934e-19 //x=9.615 \
 //y=7.585 //x2=9.655 //y2=5.38
cc_224 ( N_VDD_M18_noxref_d N_noxref_5_c_630_n ) capacitor c=0.0167847f \
 //x=9.555 //y=5.2 //x2=9.655 //y2=5.38
cc_225 ( N_VDD_c_172_n N_noxref_5_c_603_n ) capacitor c=0.00151618f //x=7.15 \
 //y=7.585 //x2=9.74 //y2=2.77
cc_226 ( N_VDD_c_173_n N_noxref_5_c_603_n ) capacitor c=0.0461201f //x=10.48 \
 //y=7.585 //x2=9.74 //y2=2.77
cc_227 ( N_VDD_c_173_n N_noxref_5_c_605_n ) capacitor c=0.0272885f //x=10.48 \
 //y=7.585 //x2=11.22 //y2=2.265
cc_228 ( N_VDD_c_174_n N_noxref_5_c_605_n ) capacitor c=0.00144809f //x=11.96 \
 //y=7.58 //x2=11.22 //y2=2.265
cc_229 ( N_VDD_M19_noxref_s N_noxref_5_c_605_n ) capacitor c=0.00938354f \
 //x=11.02 //y=5.2 //x2=11.22 //y2=2.265
cc_230 ( N_VDD_c_235_p N_noxref_5_M19_noxref_g ) capacitor c=0.00753931f \
 //x=11.95 //y=7.585 //x2=11.375 //y2=6.2
cc_231 ( N_VDD_c_173_n N_noxref_5_M19_noxref_g ) capacitor c=0.00895557f \
 //x=10.48 //y=7.585 //x2=11.375 //y2=6.2
cc_232 ( N_VDD_M19_noxref_s N_noxref_5_M19_noxref_g ) capacitor c=0.0528676f \
 //x=11.02 //y=5.2 //x2=11.375 //y2=6.2
cc_233 ( N_VDD_c_235_p N_noxref_5_M20_noxref_g ) capacitor c=0.00702238f \
 //x=11.95 //y=7.585 //x2=11.815 //y2=6.2
cc_234 ( N_VDD_M20_noxref_d N_noxref_5_M20_noxref_g ) capacitor c=0.0528676f \
 //x=11.89 //y=5.2 //x2=11.815 //y2=6.2
cc_235 ( N_VDD_c_174_n N_noxref_5_c_642_n ) capacitor c=0.0287802f //x=11.96 \
 //y=7.58 //x2=11.74 //y2=4.97
cc_236 ( N_VDD_c_173_n N_noxref_5_c_643_n ) capacitor c=0.011132f //x=10.48 \
 //y=7.585 //x2=11.45 //y2=4.97
cc_237 ( N_VDD_M19_noxref_s N_noxref_5_c_643_n ) capacitor c=0.00665885f \
 //x=11.02 //y=5.2 //x2=11.45 //y2=4.97
cc_238 ( N_VDD_c_194_p N_noxref_5_M15_noxref_d ) capacitor c=0.00720906f \
 //x=11.96 //y=7.58 //x2=8.235 //y2=5.2
cc_239 ( N_VDD_c_212_p N_noxref_5_M15_noxref_d ) capacitor c=0.0138506f \
 //x=8.735 //y=7.585 //x2=8.235 //y2=5.2
cc_240 ( N_VDD_c_173_n N_noxref_5_M15_noxref_d ) capacitor c=6.94454e-19 \
 //x=10.48 //y=7.585 //x2=8.235 //y2=5.2
cc_241 ( N_VDD_c_174_n N_noxref_5_M15_noxref_d ) capacitor c=0.00135231f \
 //x=11.96 //y=7.58 //x2=8.235 //y2=5.2
cc_242 ( N_VDD_M16_noxref_d N_noxref_5_M15_noxref_d ) capacitor c=0.0664752f \
 //x=8.675 //y=5.2 //x2=8.235 //y2=5.2
cc_243 ( N_VDD_c_194_p N_noxref_5_M17_noxref_d ) capacitor c=0.00720906f \
 //x=11.96 //y=7.58 //x2=9.115 //y2=5.2
cc_244 ( N_VDD_c_224_p N_noxref_5_M17_noxref_d ) capacitor c=0.0138783f \
 //x=9.615 //y=7.585 //x2=9.115 //y2=5.2
cc_245 ( N_VDD_c_173_n N_noxref_5_M17_noxref_d ) capacitor c=0.0120541f \
 //x=10.48 //y=7.585 //x2=9.115 //y2=5.2
cc_246 ( N_VDD_c_174_n N_noxref_5_M17_noxref_d ) capacitor c=0.00135231f \
 //x=11.96 //y=7.58 //x2=9.115 //y2=5.2
cc_247 ( N_VDD_M15_noxref_s N_noxref_5_M17_noxref_d ) capacitor c=0.00111971f \
 //x=7.805 //y=5.2 //x2=9.115 //y2=5.2
cc_248 ( N_VDD_M16_noxref_d N_noxref_5_M17_noxref_d ) capacitor c=0.0664752f \
 //x=8.675 //y=5.2 //x2=9.115 //y2=5.2
cc_249 ( N_VDD_M18_noxref_d N_noxref_5_M17_noxref_d ) capacitor c=0.0664752f \
 //x=9.555 //y=5.2 //x2=9.115 //y2=5.2
cc_250 ( N_VDD_M19_noxref_s N_noxref_5_M17_noxref_d ) capacitor c=5.1407e-19 \
 //x=11.02 //y=5.2 //x2=9.115 //y2=5.2
cc_251 ( N_VDD_c_176_p N_A_c_723_n ) capacitor c=3.98531e-19 //x=2.075 \
 //y=7.585 //x2=1.6 //y2=2.26
cc_252 ( N_VDD_c_170_n N_A_c_723_n ) capacitor c=0.016845f //x=1.23 //y=7.58 \
 //x2=1.6 //y2=2.26
cc_253 ( N_VDD_c_176_p N_A_M7_noxref_g ) capacitor c=0.00732332f //x=2.075 \
 //y=7.585 //x2=1.5 //y2=6.2
cc_254 ( N_VDD_M7_noxref_s N_A_M7_noxref_g ) capacitor c=0.054195f //x=1.145 \
 //y=5.2 //x2=1.5 //y2=6.2
cc_255 ( N_VDD_c_176_p N_A_M8_noxref_g ) capacitor c=0.00677553f //x=2.075 \
 //y=7.585 //x2=1.94 //y2=6.2
cc_256 ( N_VDD_M8_noxref_d N_A_M8_noxref_g ) capacitor c=0.015318f //x=2.015 \
 //y=5.2 //x2=1.94 //y2=6.2
cc_257 ( N_VDD_c_170_n N_A_c_740_n ) capacitor c=0.0292267f //x=1.23 //y=7.58 \
 //x2=1.6 //y2=4.88
cc_258 ( N_VDD_c_170_n N_B_c_778_n ) capacitor c=6.61004e-19 //x=1.23 //y=7.58 \
 //x2=2.34 //y2=2.26
cc_259 ( N_VDD_c_171_n N_B_c_778_n ) capacitor c=6.09526e-19 //x=3.82 \
 //y=7.585 //x2=2.34 //y2=2.26
cc_260 ( N_VDD_c_177_p N_B_M9_noxref_g ) capacitor c=0.00678607f //x=2.955 \
 //y=7.585 //x2=2.38 //y2=6.2
cc_261 ( N_VDD_M8_noxref_d N_B_M9_noxref_g ) capacitor c=0.015318f //x=2.015 \
 //y=5.2 //x2=2.38 //y2=6.2
cc_262 ( N_VDD_c_177_p N_B_M10_noxref_g ) capacitor c=0.00677553f //x=2.955 \
 //y=7.585 //x2=2.82 //y2=6.2
cc_263 ( N_VDD_c_171_n N_B_M10_noxref_g ) capacitor c=0.00954586f //x=3.82 \
 //y=7.585 //x2=2.82 //y2=6.2
cc_264 ( N_VDD_M10_noxref_d N_B_M10_noxref_g ) capacitor c=0.0430452f \
 //x=2.895 //y=5.2 //x2=2.82 //y2=6.2
cc_265 ( N_VDD_c_171_n N_C_c_893_n ) capacitor c=7.02327e-19 //x=3.82 \
 //y=7.585 //x2=5.67 //y2=2.26
cc_266 ( N_VDD_c_172_n N_C_c_893_n ) capacitor c=6.16704e-19 //x=7.15 \
 //y=7.585 //x2=5.67 //y2=2.26
cc_267 ( N_VDD_c_191_p N_C_M13_noxref_g ) capacitor c=0.00516984f //x=6.98 \
 //y=7.585 //x2=5.71 //y2=6.205
cc_268 ( N_VDD_c_191_p N_C_M14_noxref_g ) capacitor c=0.00515938f //x=6.98 \
 //y=7.585 //x2=6.15 //y2=6.205
cc_269 ( N_VDD_c_172_n N_C_M14_noxref_g ) capacitor c=0.0116195f //x=7.15 \
 //y=7.585 //x2=6.15 //y2=6.205
cc_270 ( N_VDD_c_188_p N_noxref_10_c_964_n ) capacitor c=5.82208e-19 //x=4.965 \
 //y=7.585 //x2=5.405 //y2=5.39
cc_271 ( N_VDD_c_191_p N_noxref_10_c_964_n ) capacitor c=5.82208e-19 //x=6.98 \
 //y=7.585 //x2=5.405 //y2=5.39
cc_272 ( N_VDD_c_172_n N_noxref_10_c_964_n ) capacitor c=0.00289291f //x=7.15 \
 //y=7.585 //x2=5.405 //y2=5.39
cc_273 ( N_VDD_M11_noxref_d N_noxref_10_c_964_n ) capacitor c=0.013244f \
 //x=4.905 //y=5.205 //x2=5.405 //y2=5.39
cc_274 ( N_VDD_c_171_n N_noxref_10_c_968_n ) capacitor c=0.0669114f //x=3.82 \
 //y=7.585 //x2=4.695 //y2=5.39
cc_275 ( N_VDD_c_174_n N_noxref_10_c_969_n ) capacitor c=0.00360102f //x=11.96 \
 //y=7.58 //x2=6.285 //y2=7.09
cc_276 ( N_VDD_c_194_p N_noxref_10_c_970_n ) capacitor c=0.0370795f //x=11.96 \
 //y=7.58 //x2=5.575 //y2=7.09
cc_277 ( N_VDD_c_191_p N_noxref_10_c_970_n ) capacitor c=0.0587731f //x=6.98 \
 //y=7.585 //x2=5.575 //y2=7.09
cc_278 ( N_VDD_c_174_n N_noxref_10_c_970_n ) capacitor c=0.00118659f //x=11.96 \
 //y=7.58 //x2=5.575 //y2=7.09
cc_279 ( N_VDD_c_194_p N_noxref_10_M11_noxref_s ) capacitor c=0.00727771f \
 //x=11.96 //y=7.58 //x2=4.475 //y2=5.205
cc_280 ( N_VDD_c_188_p N_noxref_10_M11_noxref_s ) capacitor c=0.0141529f \
 //x=4.965 //y=7.585 //x2=4.475 //y2=5.205
cc_281 ( N_VDD_c_174_n N_noxref_10_M11_noxref_s ) capacitor c=0.00138926f \
 //x=11.96 //y=7.58 //x2=4.475 //y2=5.205
cc_282 ( N_VDD_M10_noxref_d N_noxref_10_M11_noxref_s ) capacitor c=0.00196306f \
 //x=2.895 //y=5.2 //x2=4.475 //y2=5.205
cc_283 ( N_VDD_M11_noxref_d N_noxref_10_M11_noxref_s ) capacitor c=0.0667021f \
 //x=4.905 //y=5.205 //x2=4.475 //y2=5.205
cc_284 ( N_VDD_c_171_n N_noxref_10_M12_noxref_d ) capacitor c=8.88629e-19 \
 //x=3.82 //y=7.585 //x2=5.345 //y2=5.205
cc_285 ( N_VDD_M11_noxref_d N_noxref_10_M12_noxref_d ) capacitor c=0.0659925f \
 //x=4.905 //y=5.205 //x2=5.345 //y2=5.205
cc_286 ( N_VDD_c_172_n N_noxref_10_M14_noxref_d ) capacitor c=0.0520312f \
 //x=7.15 //y=7.585 //x2=6.225 //y2=5.205
cc_287 ( N_VDD_M11_noxref_d N_noxref_10_M14_noxref_d ) capacitor c=0.00107819f \
 //x=4.905 //y=5.205 //x2=6.225 //y2=5.205
cc_288 ( N_VDD_M15_noxref_s N_noxref_10_M14_noxref_d ) capacitor c=0.00195151f \
 //x=7.805 //y=5.2 //x2=6.225 //y2=5.205
cc_289 ( N_VDD_c_172_n N_D_c_1007_n ) capacitor c=6.61004e-19 //x=7.15 \
 //y=7.585 //x2=9 //y2=2.26
cc_290 ( N_VDD_c_173_n N_D_c_1007_n ) capacitor c=6.09526e-19 //x=10.48 \
 //y=7.585 //x2=9 //y2=2.26
cc_291 ( N_VDD_c_224_p N_D_M17_noxref_g ) capacitor c=0.00678607f //x=9.615 \
 //y=7.585 //x2=9.04 //y2=6.2
cc_292 ( N_VDD_M16_noxref_d N_D_M17_noxref_g ) capacitor c=0.015318f //x=8.675 \
 //y=5.2 //x2=9.04 //y2=6.2
cc_293 ( N_VDD_c_224_p N_D_M18_noxref_g ) capacitor c=0.00677553f //x=9.615 \
 //y=7.585 //x2=9.48 //y2=6.2
cc_294 ( N_VDD_c_173_n N_D_M18_noxref_g ) capacitor c=0.00904525f //x=10.48 \
 //y=7.585 //x2=9.48 //y2=6.2
cc_295 ( N_VDD_M18_noxref_d N_D_M18_noxref_g ) capacitor c=0.0430452f \
 //x=9.555 //y=5.2 //x2=9.48 //y2=6.2
cc_296 ( N_VDD_c_173_n Y ) capacitor c=4.80934e-19 //x=10.48 //y=7.585 \
 //x2=11.96 //y2=2.4
cc_297 ( N_VDD_c_174_n Y ) capacitor c=0.0232778f //x=11.96 //y=7.58 \
 //x2=11.96 //y2=2.4
cc_298 ( N_VDD_c_235_p N_Y_c_1139_n ) capacitor c=8.94397e-19 //x=11.95 \
 //y=7.585 //x2=11.875 //y2=4.76
cc_299 ( N_VDD_M20_noxref_d N_Y_c_1139_n ) capacitor c=0.00645128f //x=11.89 \
 //y=5.2 //x2=11.875 //y2=4.76
cc_300 ( N_VDD_c_173_n N_Y_c_1141_n ) capacitor c=0.017572f //x=10.48 \
 //y=7.585 //x2=11.68 //y2=4.76
cc_301 ( N_VDD_c_194_p N_Y_M19_noxref_d ) capacitor c=0.00724309f //x=11.96 \
 //y=7.58 //x2=11.45 //y2=5.2
cc_302 ( N_VDD_c_235_p N_Y_M19_noxref_d ) capacitor c=0.0139426f //x=11.95 \
 //y=7.585 //x2=11.45 //y2=5.2
cc_303 ( N_VDD_c_174_n N_Y_M19_noxref_d ) capacitor c=0.0219131f //x=11.96 \
 //y=7.58 //x2=11.45 //y2=5.2
cc_304 ( N_VDD_M19_noxref_s N_Y_M19_noxref_d ) capacitor c=0.0843065f \
 //x=11.02 //y=5.2 //x2=11.45 //y2=5.2
cc_305 ( N_VDD_M20_noxref_d N_Y_M19_noxref_d ) capacitor c=0.0832641f \
 //x=11.89 //y=5.2 //x2=11.45 //y2=5.2
cc_306 ( N_noxref_3_c_311_n N_noxref_4_c_457_n ) capacitor c=0.0114841f \
 //x=4.815 //y=2.77 //x2=6.525 //y2=2.77
cc_307 ( N_noxref_3_c_329_n N_noxref_4_c_459_n ) capacitor c=0.00431513f \
 //x=5.265 //y=1.43 //x2=5.885 //y2=1.835
cc_308 ( N_noxref_3_c_311_n N_noxref_4_c_507_n ) capacitor c=0.0018301f \
 //x=4.815 //y=2.77 //x2=5.085 //y2=1.835
cc_309 ( N_noxref_3_c_319_n N_noxref_4_c_507_n ) capacitor c=0.0107041f \
 //x=4.93 //y=2.26 //x2=5.085 //y2=1.835
cc_310 ( N_noxref_3_c_324_n N_noxref_4_c_507_n ) capacitor c=0.00524371f \
 //x=4.735 //y=2.095 //x2=5.085 //y2=1.835
cc_311 ( N_noxref_3_c_317_n N_noxref_4_c_467_n ) capacitor c=3.55699e-19 \
 //x=3.08 //y=2.77 //x2=6.41 //y2=2.77
cc_312 ( N_noxref_3_c_319_n N_noxref_4_c_467_n ) capacitor c=0.00354085f \
 //x=4.93 //y=2.26 //x2=6.41 //y2=2.77
cc_313 ( N_noxref_3_c_322_n N_noxref_4_M2_noxref_d ) capacitor c=0.0013184f \
 //x=4.735 //y=1.085 //x2=4.81 //y2=1.085
cc_314 ( N_noxref_3_c_372_p N_noxref_4_M2_noxref_d ) capacitor c=0.0034598f \
 //x=4.735 //y=1.43 //x2=4.81 //y2=1.085
cc_315 ( N_noxref_3_c_373_p N_noxref_4_M2_noxref_d ) capacitor c=0.00300148f \
 //x=4.735 //y=1.74 //x2=4.81 //y2=1.085
cc_316 ( N_noxref_3_c_324_n N_noxref_4_M2_noxref_d ) capacitor c=0.00273686f \
 //x=4.735 //y=2.095 //x2=4.81 //y2=1.085
cc_317 ( N_noxref_3_c_326_n N_noxref_4_M2_noxref_d ) capacitor c=0.00241102f \
 //x=5.11 //y=0.93 //x2=4.81 //y2=1.085
cc_318 ( N_noxref_3_c_376_p N_noxref_4_M2_noxref_d ) capacitor c=0.0123304f \
 //x=5.11 //y=1.585 //x2=4.81 //y2=1.085
cc_319 ( N_noxref_3_c_327_n N_noxref_4_M2_noxref_d ) capacitor c=0.00219619f \
 //x=5.265 //y=1.085 //x2=4.81 //y2=1.085
cc_320 ( N_noxref_3_c_329_n N_noxref_4_M2_noxref_d ) capacitor c=0.00603828f \
 //x=5.265 //y=1.43 //x2=4.81 //y2=1.085
cc_321 ( N_noxref_3_c_337_n N_A_c_723_n ) capacitor c=0.0055959f //x=1.805 \
 //y=5.38 //x2=1.6 //y2=2.26
cc_322 ( N_noxref_3_c_317_n N_A_c_723_n ) capacitor c=0.00407922f //x=3.08 \
 //y=2.77 //x2=1.6 //y2=2.26
cc_323 ( N_noxref_3_c_337_n N_A_M7_noxref_g ) capacitor c=0.0177326f //x=1.805 \
 //y=5.38 //x2=1.5 //y2=6.2
cc_324 ( N_noxref_3_c_334_n N_A_M8_noxref_g ) capacitor c=0.0204115f //x=2.515 \
 //y=5.38 //x2=1.94 //y2=6.2
cc_325 ( N_noxref_3_M7_noxref_d N_A_M8_noxref_g ) capacitor c=0.0173476f \
 //x=1.575 //y=5.2 //x2=1.94 //y2=6.2
cc_326 ( N_noxref_3_c_337_n N_A_c_740_n ) capacitor c=0.00605692f //x=1.805 \
 //y=5.38 //x2=1.6 //y2=4.88
cc_327 ( N_noxref_3_c_334_n N_B_c_787_n ) capacitor c=0.0127867f //x=2.515 \
 //y=5.38 //x2=2.34 //y2=4.715
cc_328 ( N_noxref_3_c_317_n N_B_c_787_n ) capacitor c=0.0101284f //x=3.08 \
 //y=2.77 //x2=2.34 //y2=4.715
cc_329 ( N_noxref_3_c_314_n N_B_c_778_n ) capacitor c=0.00732168f //x=3.195 \
 //y=2.77 //x2=2.34 //y2=2.26
cc_330 ( N_noxref_3_c_317_n N_B_c_778_n ) capacitor c=0.0813981f //x=3.08 \
 //y=2.77 //x2=2.34 //y2=2.26
cc_331 ( N_noxref_3_c_319_n N_B_c_778_n ) capacitor c=9.8819e-19 //x=4.93 \
 //y=2.26 //x2=2.34 //y2=2.26
cc_332 ( N_noxref_3_c_334_n N_B_M9_noxref_g ) capacitor c=0.0166699f //x=2.515 \
 //y=5.38 //x2=2.38 //y2=6.2
cc_333 ( N_noxref_3_M9_noxref_d N_B_M9_noxref_g ) capacitor c=0.0173477f \
 //x=2.455 //y=5.2 //x2=2.38 //y2=6.2
cc_334 ( N_noxref_3_c_339_n N_B_M10_noxref_g ) capacitor c=0.0223814f \
 //x=2.995 //y=5.38 //x2=2.82 //y2=6.2
cc_335 ( N_noxref_3_M9_noxref_d N_B_M10_noxref_g ) capacitor c=0.0179769f \
 //x=2.455 //y=5.2 //x2=2.82 //y2=6.2
cc_336 ( N_noxref_3_M1_noxref_d N_B_c_796_n ) capacitor c=0.00217566f //x=2.45 \
 //y=1.085 //x2=2.375 //y2=1.085
cc_337 ( N_noxref_3_M1_noxref_d N_B_c_797_n ) capacitor c=0.0034598f //x=2.45 \
 //y=1.085 //x2=2.375 //y2=1.43
cc_338 ( N_noxref_3_M1_noxref_d N_B_c_798_n ) capacitor c=0.0065582f //x=2.45 \
 //y=1.085 //x2=2.375 //y2=1.74
cc_339 ( N_noxref_3_c_317_n N_B_c_799_n ) capacitor c=0.0142673f //x=3.08 \
 //y=2.77 //x2=2.745 //y2=4.97
cc_340 ( N_noxref_3_c_398_p N_B_c_799_n ) capacitor c=0.00421574f //x=2.6 \
 //y=5.38 //x2=2.745 //y2=4.97
cc_341 ( N_noxref_3_M1_noxref_d N_B_c_801_n ) capacitor c=0.00241102f //x=2.45 \
 //y=1.085 //x2=2.75 //y2=0.93
cc_342 ( N_noxref_3_c_315_n N_B_c_802_n ) capacitor c=0.00359704f //x=2.995 \
 //y=1.835 //x2=2.75 //y2=1.585
cc_343 ( N_noxref_3_M1_noxref_d N_B_c_802_n ) capacitor c=0.0138845f //x=2.45 \
 //y=1.085 //x2=2.75 //y2=1.585
cc_344 ( N_noxref_3_M1_noxref_d N_B_c_804_n ) capacitor c=0.00132245f //x=2.45 \
 //y=1.085 //x2=2.905 //y2=1.085
cc_345 ( N_noxref_3_c_315_n N_B_c_805_n ) capacitor c=0.00457401f //x=2.995 \
 //y=1.835 //x2=2.905 //y2=1.43
cc_346 ( N_noxref_3_M1_noxref_d N_B_c_805_n ) capacitor c=0.00566463f //x=2.45 \
 //y=1.085 //x2=2.905 //y2=1.43
cc_347 ( N_noxref_3_c_317_n N_B_c_807_n ) capacitor c=0.00877984f //x=3.08 \
 //y=2.77 //x2=2.34 //y2=2.26
cc_348 ( N_noxref_3_c_317_n N_B_c_808_n ) capacitor c=0.00306024f //x=3.08 \
 //y=2.77 //x2=2.34 //y2=2.095
cc_349 ( N_noxref_3_M1_noxref_d N_B_c_808_n ) capacitor c=0.00660593f //x=2.45 \
 //y=1.085 //x2=2.34 //y2=2.095
cc_350 ( N_noxref_3_c_334_n N_B_c_810_n ) capacitor c=0.00399417f //x=2.515 \
 //y=5.38 //x2=2.37 //y2=4.88
cc_351 ( N_noxref_3_c_317_n N_B_c_810_n ) capacitor c=0.00533692f //x=3.08 \
 //y=2.77 //x2=2.37 //y2=4.88
cc_352 ( N_noxref_3_c_410_p N_noxref_8_c_866_n ) capacitor c=3.15806e-19 \
 //x=2.725 //y=1.835 //x2=1.185 //y2=1.675
cc_353 ( N_noxref_3_c_410_p N_noxref_8_c_850_n ) capacitor c=0.0201674f \
 //x=2.725 //y=1.835 //x2=2.155 //y2=1.675
cc_354 ( N_noxref_3_c_315_n N_noxref_8_c_851_n ) capacitor c=0.00468333f \
 //x=2.995 //y=1.835 //x2=3.04 //y2=0.71
cc_355 ( N_noxref_3_M1_noxref_d N_noxref_8_c_851_n ) capacitor c=0.0118355f \
 //x=2.45 //y=1.085 //x2=3.04 //y2=0.71
cc_356 ( N_noxref_3_c_311_n N_noxref_8_M0_noxref_s ) capacitor c=3.03583e-19 \
 //x=4.815 //y=2.77 //x2=1.05 //y2=0.545
cc_357 ( N_noxref_3_c_314_n N_noxref_8_M0_noxref_s ) capacitor c=6.92363e-19 \
 //x=3.195 //y=2.77 //x2=1.05 //y2=0.545
cc_358 ( N_noxref_3_c_315_n N_noxref_8_M0_noxref_s ) capacitor c=0.0129465f \
 //x=2.995 //y=1.835 //x2=1.05 //y2=0.545
cc_359 ( N_noxref_3_M1_noxref_d N_noxref_8_M0_noxref_s ) capacitor \
 c=0.0437911f //x=2.45 //y=1.085 //x2=1.05 //y2=0.545
cc_360 ( N_noxref_3_c_344_n N_C_c_906_n ) capacitor c=0.0470738f //x=4.775 \
 //y=4.885 //x2=5.67 //y2=4.72
cc_361 ( N_noxref_3_c_419_p N_C_c_906_n ) capacitor c=0.00146509f //x=5.195 \
 //y=4.975 //x2=5.67 //y2=4.72
cc_362 ( N_noxref_3_c_351_n N_C_c_906_n ) capacitor c=0.00112871f //x=4.775 \
 //y=4.885 //x2=5.67 //y2=4.72
cc_363 ( N_noxref_3_c_311_n N_C_c_893_n ) capacitor c=0.00316948f //x=4.815 \
 //y=2.77 //x2=5.67 //y2=2.26
cc_364 ( N_noxref_3_c_317_n N_C_c_893_n ) capacitor c=9.8819e-19 //x=3.08 \
 //y=2.77 //x2=5.67 //y2=2.26
cc_365 ( N_noxref_3_c_319_n N_C_c_893_n ) capacitor c=0.0447305f //x=4.93 \
 //y=2.26 //x2=5.67 //y2=2.26
cc_366 ( N_noxref_3_c_324_n N_C_c_893_n ) capacitor c=0.00308814f //x=4.735 \
 //y=2.095 //x2=5.67 //y2=2.26
cc_367 ( N_noxref_3_M11_noxref_g N_C_M13_noxref_g ) capacitor c=0.0100243f \
 //x=4.83 //y=6.205 //x2=5.71 //y2=6.205
cc_368 ( N_noxref_3_M12_noxref_g N_C_M13_noxref_g ) capacitor c=0.107798f \
 //x=5.27 //y=6.205 //x2=5.71 //y2=6.205
cc_369 ( N_noxref_3_M12_noxref_g N_C_M14_noxref_g ) capacitor c=0.0094155f \
 //x=5.27 //y=6.205 //x2=6.15 //y2=6.205
cc_370 ( N_noxref_3_c_322_n N_C_c_895_n ) capacitor c=0.00125788f //x=4.735 \
 //y=1.085 //x2=5.705 //y2=1.085
cc_371 ( N_noxref_3_c_327_n N_C_c_895_n ) capacitor c=0.0126654f //x=5.265 \
 //y=1.085 //x2=5.705 //y2=1.085
cc_372 ( N_noxref_3_c_372_p N_C_c_918_n ) capacitor c=0.00148539f //x=4.735 \
 //y=1.43 //x2=5.705 //y2=1.435
cc_373 ( N_noxref_3_c_373_p N_C_c_918_n ) capacitor c=0.00105591f //x=4.735 \
 //y=1.74 //x2=5.705 //y2=1.435
cc_374 ( N_noxref_3_c_329_n N_C_c_918_n ) capacitor c=0.0126654f //x=5.265 \
 //y=1.43 //x2=5.705 //y2=1.435
cc_375 ( N_noxref_3_c_373_p N_C_c_921_n ) capacitor c=0.00109549f //x=4.735 \
 //y=1.74 //x2=5.705 //y2=1.74
cc_376 ( N_noxref_3_c_329_n N_C_c_921_n ) capacitor c=0.00886999f //x=5.265 \
 //y=1.43 //x2=5.705 //y2=1.74
cc_377 ( N_noxref_3_c_329_n N_C_c_898_n ) capacitor c=0.00123863f //x=5.265 \
 //y=1.43 //x2=6.08 //y2=1.585
cc_378 ( N_noxref_3_c_327_n N_C_c_899_n ) capacitor c=0.00132934f //x=5.265 \
 //y=1.085 //x2=6.235 //y2=1.085
cc_379 ( N_noxref_3_c_329_n N_C_c_925_n ) capacitor c=0.00150734f //x=5.265 \
 //y=1.43 //x2=6.235 //y2=1.435
cc_380 ( N_noxref_3_c_319_n N_C_c_926_n ) capacitor c=0.00307062f //x=4.93 \
 //y=2.26 //x2=5.67 //y2=2.26
cc_381 ( N_noxref_3_c_324_n N_C_c_926_n ) capacitor c=0.0179092f //x=4.735 \
 //y=2.095 //x2=5.67 //y2=2.26
cc_382 ( N_noxref_3_c_324_n N_C_c_928_n ) capacitor c=0.00577193f //x=4.735 \
 //y=2.095 //x2=5.67 //y2=2.095
cc_383 ( N_noxref_3_c_344_n N_C_c_929_n ) capacitor c=0.00336963f //x=4.775 \
 //y=4.885 //x2=5.705 //y2=4.885
cc_384 ( N_noxref_3_c_419_p N_C_c_929_n ) capacitor c=0.020271f //x=5.195 \
 //y=4.975 //x2=5.705 //y2=4.885
cc_385 ( N_noxref_3_c_351_n N_C_c_929_n ) capacitor c=0.00546725f //x=4.775 \
 //y=4.885 //x2=5.705 //y2=4.885
cc_386 ( N_noxref_3_c_344_n N_noxref_10_c_964_n ) capacitor c=0.00630079f \
 //x=4.775 //y=4.885 //x2=5.405 //y2=5.39
cc_387 ( N_noxref_3_M11_noxref_g N_noxref_10_c_964_n ) capacitor c=0.0182669f \
 //x=4.83 //y=6.205 //x2=5.405 //y2=5.39
cc_388 ( N_noxref_3_M12_noxref_g N_noxref_10_c_964_n ) capacitor c=0.0204082f \
 //x=5.27 //y=6.205 //x2=5.405 //y2=5.39
cc_389 ( N_noxref_3_c_419_p N_noxref_10_c_964_n ) capacitor c=0.00365818f \
 //x=5.195 //y=4.975 //x2=5.405 //y2=5.39
cc_390 ( N_noxref_3_c_351_n N_noxref_10_c_964_n ) capacitor c=0.0017421f \
 //x=4.775 //y=4.885 //x2=5.405 //y2=5.39
cc_391 ( N_noxref_3_c_339_n N_noxref_10_c_968_n ) capacitor c=2.87761e-19 \
 //x=2.995 //y=5.38 //x2=4.695 //y2=5.39
cc_392 ( N_noxref_3_c_344_n N_noxref_10_c_968_n ) capacitor c=0.0118415f \
 //x=4.775 //y=4.885 //x2=4.695 //y2=5.39
cc_393 ( N_noxref_3_c_351_n N_noxref_10_c_968_n ) capacitor c=0.00613395f \
 //x=4.775 //y=4.885 //x2=4.695 //y2=5.39
cc_394 ( N_noxref_3_M9_noxref_d N_noxref_10_c_968_n ) capacitor c=4.5543e-19 \
 //x=2.455 //y=5.2 //x2=4.695 //y2=5.39
cc_395 ( N_noxref_3_M11_noxref_g N_noxref_10_M11_noxref_s ) capacitor \
 c=0.0473218f //x=4.83 //y=6.205 //x2=4.475 //y2=5.205
cc_396 ( N_noxref_3_M12_noxref_g N_noxref_10_M12_noxref_d ) capacitor \
 c=0.0170604f //x=5.27 //y=6.205 //x2=5.345 //y2=5.205
cc_397 ( N_noxref_4_c_455_n N_noxref_5_c_600_n ) capacitor c=0.0114841f \
 //x=8.145 //y=2.77 //x2=9.855 //y2=2.77
cc_398 ( N_noxref_4_M16_noxref_g N_noxref_5_c_625_n ) capacitor c=0.0204115f \
 //x=8.6 //y=6.2 //x2=9.175 //y2=5.38
cc_399 ( N_noxref_4_c_469_n N_noxref_5_c_628_n ) capacitor c=0.0055959f \
 //x=8.26 //y=2.26 //x2=8.465 //y2=5.38
cc_400 ( N_noxref_4_M15_noxref_g N_noxref_5_c_628_n ) capacitor c=0.0177326f \
 //x=8.16 //y=6.2 //x2=8.465 //y2=5.38
cc_401 ( N_noxref_4_c_501_n N_noxref_5_c_628_n ) capacitor c=0.00605692f \
 //x=8.26 //y=4.88 //x2=8.465 //y2=5.38
cc_402 ( N_noxref_4_c_467_n N_noxref_5_c_603_n ) capacitor c=3.49822e-19 \
 //x=6.41 //y=2.77 //x2=9.74 //y2=2.77
cc_403 ( N_noxref_4_c_469_n N_noxref_5_c_603_n ) capacitor c=0.00369745f \
 //x=8.26 //y=2.26 //x2=9.74 //y2=2.77
cc_404 ( N_noxref_4_M16_noxref_g N_noxref_5_M15_noxref_d ) capacitor \
 c=0.0173476f //x=8.6 //y=6.2 //x2=8.235 //y2=5.2
cc_405 ( N_noxref_4_c_467_n N_C_c_906_n ) capacitor c=0.0102183f //x=6.41 \
 //y=2.77 //x2=5.67 //y2=4.72
cc_406 ( N_noxref_4_c_457_n N_C_c_893_n ) capacitor c=0.00316948f //x=6.525 \
 //y=2.77 //x2=5.67 //y2=2.26
cc_407 ( N_noxref_4_c_459_n N_C_c_893_n ) capacitor c=0.0162392f //x=5.885 \
 //y=1.835 //x2=5.67 //y2=2.26
cc_408 ( N_noxref_4_c_467_n N_C_c_893_n ) capacitor c=0.0822198f //x=6.41 \
 //y=2.77 //x2=5.67 //y2=2.26
cc_409 ( N_noxref_4_c_469_n N_C_c_893_n ) capacitor c=9.8819e-19 //x=8.26 \
 //y=2.26 //x2=5.67 //y2=2.26
cc_410 ( N_noxref_4_c_492_n N_C_M13_noxref_g ) capacitor c=0.0132788f \
 //x=6.015 //y=5.39 //x2=5.71 //y2=6.205
cc_411 ( N_noxref_4_c_490_n N_C_M14_noxref_g ) capacitor c=0.0217751f \
 //x=6.325 //y=5.39 //x2=6.15 //y2=6.205
cc_412 ( N_noxref_4_M13_noxref_d N_C_M14_noxref_g ) capacitor c=0.0136385f \
 //x=5.785 //y=5.205 //x2=6.15 //y2=6.205
cc_413 ( N_noxref_4_M3_noxref_d N_C_c_895_n ) capacitor c=0.00226395f //x=5.78 \
 //y=1.085 //x2=5.705 //y2=1.085
cc_414 ( N_noxref_4_M3_noxref_d N_C_c_918_n ) capacitor c=0.0035101f //x=5.78 \
 //y=1.085 //x2=5.705 //y2=1.435
cc_415 ( N_noxref_4_c_459_n N_C_c_921_n ) capacitor c=0.00218915f //x=5.885 \
 //y=1.835 //x2=5.705 //y2=1.74
cc_416 ( N_noxref_4_M2_noxref_d N_C_c_921_n ) capacitor c=0.00148728f //x=4.81 \
 //y=1.085 //x2=5.705 //y2=1.74
cc_417 ( N_noxref_4_M3_noxref_d N_C_c_921_n ) capacitor c=0.00546704f //x=5.78 \
 //y=1.085 //x2=5.705 //y2=1.74
cc_418 ( N_noxref_4_c_492_n N_C_c_945_n ) capacitor c=0.00417892f //x=6.015 \
 //y=5.39 //x2=6.075 //y2=4.975
cc_419 ( N_noxref_4_c_467_n N_C_c_945_n ) capacitor c=0.0144455f //x=6.41 \
 //y=2.77 //x2=6.075 //y2=4.975
cc_420 ( N_noxref_4_M3_noxref_d N_C_c_897_n ) capacitor c=0.00241102f //x=5.78 \
 //y=1.085 //x2=6.08 //y2=0.93
cc_421 ( N_noxref_4_c_463_n N_C_c_898_n ) capacitor c=0.00801563f //x=6.325 \
 //y=1.835 //x2=6.08 //y2=1.585
cc_422 ( N_noxref_4_M3_noxref_d N_C_c_898_n ) capacitor c=0.0158021f //x=5.78 \
 //y=1.085 //x2=6.08 //y2=1.585
cc_423 ( N_noxref_4_M3_noxref_d N_C_c_899_n ) capacitor c=0.00132831f //x=5.78 \
 //y=1.085 //x2=6.235 //y2=1.085
cc_424 ( N_noxref_4_M3_noxref_d N_C_c_925_n ) capacitor c=0.0035101f //x=5.78 \
 //y=1.085 //x2=6.235 //y2=1.435
cc_425 ( N_noxref_4_c_459_n N_C_c_926_n ) capacitor c=0.00633758f //x=5.885 \
 //y=1.835 //x2=5.67 //y2=2.26
cc_426 ( N_noxref_4_c_467_n N_C_c_926_n ) capacitor c=0.00877984f //x=6.41 \
 //y=2.77 //x2=5.67 //y2=2.26
cc_427 ( N_noxref_4_c_459_n N_C_c_928_n ) capacitor c=0.0189958f //x=5.885 \
 //y=1.835 //x2=5.67 //y2=2.095
cc_428 ( N_noxref_4_c_467_n N_C_c_928_n ) capacitor c=0.00306024f //x=6.41 \
 //y=2.77 //x2=5.67 //y2=2.095
cc_429 ( N_noxref_4_M3_noxref_d N_C_c_928_n ) capacitor c=3.4952e-19 //x=5.78 \
 //y=1.085 //x2=5.67 //y2=2.095
cc_430 ( N_noxref_4_c_467_n N_C_c_929_n ) capacitor c=0.00537091f //x=6.41 \
 //y=2.77 //x2=5.705 //y2=4.885
cc_431 ( N_noxref_4_c_492_n N_noxref_10_c_964_n ) capacitor c=0.0348754f \
 //x=6.015 //y=5.39 //x2=5.405 //y2=5.39
cc_432 ( N_noxref_4_c_490_n N_noxref_10_c_969_n ) capacitor c=0.00194034f \
 //x=6.325 //y=5.39 //x2=6.285 //y2=7.09
cc_433 ( N_noxref_4_M13_noxref_d N_noxref_10_c_969_n ) capacitor c=0.0118172f \
 //x=5.785 //y=5.205 //x2=6.285 //y2=7.09
cc_434 ( N_noxref_4_M13_noxref_d N_noxref_10_M11_noxref_s ) capacitor \
 c=0.00107541f //x=5.785 //y=5.205 //x2=4.475 //y2=5.205
cc_435 ( N_noxref_4_M13_noxref_d N_noxref_10_M12_noxref_d ) capacitor \
 c=0.0348754f //x=5.785 //y=5.205 //x2=5.345 //y2=5.205
cc_436 ( N_noxref_4_c_490_n N_noxref_10_M14_noxref_d ) capacitor c=0.0164221f \
 //x=6.325 //y=5.39 //x2=6.225 //y2=5.205
cc_437 ( N_noxref_4_M13_noxref_d N_noxref_10_M14_noxref_d ) capacitor \
 c=0.0458293f //x=5.785 //y=5.205 //x2=6.225 //y2=5.205
cc_438 ( N_noxref_4_c_469_n N_D_c_1016_n ) capacitor c=0.00400249f //x=8.26 \
 //y=2.26 //x2=9 //y2=4.715
cc_439 ( N_noxref_4_c_501_n N_D_c_1016_n ) capacitor c=0.00417994f //x=8.26 \
 //y=4.88 //x2=9 //y2=4.715
cc_440 ( N_noxref_4_c_455_n N_D_c_1007_n ) capacitor c=0.00316948f //x=8.145 \
 //y=2.77 //x2=9 //y2=2.26
cc_441 ( N_noxref_4_c_467_n N_D_c_1007_n ) capacitor c=9.8819e-19 //x=6.41 \
 //y=2.77 //x2=9 //y2=2.26
cc_442 ( N_noxref_4_c_469_n N_D_c_1007_n ) capacitor c=0.0872088f //x=8.26 \
 //y=2.26 //x2=9 //y2=2.26
cc_443 ( N_noxref_4_c_474_n N_D_c_1007_n ) capacitor c=0.00308814f //x=8.065 \
 //y=2.095 //x2=9 //y2=2.26
cc_444 ( N_noxref_4_M15_noxref_g N_D_M17_noxref_g ) capacitor c=0.0104611f \
 //x=8.16 //y=6.2 //x2=9.04 //y2=6.2
cc_445 ( N_noxref_4_M16_noxref_g N_D_M17_noxref_g ) capacitor c=0.106811f \
 //x=8.6 //y=6.2 //x2=9.04 //y2=6.2
cc_446 ( N_noxref_4_M16_noxref_g N_D_M18_noxref_g ) capacitor c=0.0100341f \
 //x=8.6 //y=6.2 //x2=9.48 //y2=6.2
cc_447 ( N_noxref_4_c_470_n N_D_c_1025_n ) capacitor c=4.86506e-19 //x=8.065 \
 //y=1.045 //x2=9.035 //y2=1.085
cc_448 ( N_noxref_4_c_472_n N_D_c_1025_n ) capacitor c=0.00152104f //x=8.065 \
 //y=1.39 //x2=9.035 //y2=1.085
cc_449 ( N_noxref_4_c_477_n N_D_c_1025_n ) capacitor c=0.0151475f //x=8.595 \
 //y=1.045 //x2=9.035 //y2=1.085
cc_450 ( N_noxref_4_c_473_n N_D_c_1028_n ) capacitor c=0.00109982f //x=8.065 \
 //y=1.7 //x2=9.035 //y2=1.43
cc_451 ( N_noxref_4_c_479_n N_D_c_1028_n ) capacitor c=0.0111064f //x=8.595 \
 //y=1.39 //x2=9.035 //y2=1.43
cc_452 ( N_noxref_4_c_473_n N_D_c_1030_n ) capacitor c=9.57794e-19 //x=8.065 \
 //y=1.7 //x2=9.035 //y2=1.74
cc_453 ( N_noxref_4_c_474_n N_D_c_1030_n ) capacitor c=0.00662747f //x=8.065 \
 //y=2.095 //x2=9.035 //y2=1.74
cc_454 ( N_noxref_4_c_479_n N_D_c_1030_n ) capacitor c=0.00862358f //x=8.595 \
 //y=1.39 //x2=9.035 //y2=1.74
cc_455 ( N_noxref_4_c_477_n N_D_c_1033_n ) capacitor c=0.00124821f //x=8.595 \
 //y=1.045 //x2=9.565 //y2=1.085
cc_456 ( N_noxref_4_c_479_n N_D_c_1034_n ) capacitor c=0.00200715f //x=8.595 \
 //y=1.39 //x2=9.565 //y2=1.43
cc_457 ( N_noxref_4_c_469_n N_D_c_1035_n ) capacitor c=0.00307062f //x=8.26 \
 //y=2.26 //x2=9 //y2=2.26
cc_458 ( N_noxref_4_c_474_n N_D_c_1035_n ) capacitor c=0.0179092f //x=8.065 \
 //y=2.095 //x2=9 //y2=2.26
cc_459 ( N_noxref_4_c_469_n N_D_c_1037_n ) capacitor c=0.00344981f //x=8.26 \
 //y=2.26 //x2=9.03 //y2=4.88
cc_460 ( N_noxref_4_c_501_n N_D_c_1037_n ) capacitor c=0.0293367f //x=8.26 \
 //y=4.88 //x2=9.03 //y2=4.88
cc_461 ( N_noxref_4_c_455_n N_noxref_12_c_1098_n ) capacitor c=0.00491973f \
 //x=8.145 //y=2.77 //x2=7.845 //y2=1.675
cc_462 ( N_noxref_4_c_463_n N_noxref_12_c_1098_n ) capacitor c=3.37788e-19 \
 //x=6.325 //y=1.835 //x2=7.845 //y2=1.675
cc_463 ( N_noxref_4_c_474_n N_noxref_12_c_1098_n ) capacitor c=0.0034165f \
 //x=8.065 //y=2.095 //x2=7.845 //y2=1.675
cc_464 ( N_noxref_4_c_455_n N_noxref_12_c_1073_n ) capacitor c=0.0108509f \
 //x=8.145 //y=2.77 //x2=8.73 //y2=1.76
cc_465 ( N_noxref_4_c_469_n N_noxref_12_c_1073_n ) capacitor c=0.0114076f \
 //x=8.26 //y=2.26 //x2=8.73 //y2=1.76
cc_466 ( N_noxref_4_c_473_n N_noxref_12_c_1073_n ) capacitor c=0.00700575f \
 //x=8.065 //y=1.7 //x2=8.73 //y2=1.76
cc_467 ( N_noxref_4_c_474_n N_noxref_12_c_1073_n ) capacitor c=0.018562f \
 //x=8.065 //y=2.095 //x2=8.73 //y2=1.76
cc_468 ( N_noxref_4_c_476_n N_noxref_12_c_1073_n ) capacitor c=0.00780629f \
 //x=8.44 //y=1.545 //x2=8.73 //y2=1.76
cc_469 ( N_noxref_4_c_479_n N_noxref_12_c_1073_n ) capacitor c=0.00339872f \
 //x=8.595 //y=1.39 //x2=8.73 //y2=1.76
cc_470 ( N_noxref_4_c_474_n N_noxref_12_c_1081_n ) capacitor c=6.71402e-19 \
 //x=8.065 //y=2.095 //x2=8.815 //y2=1.675
cc_471 ( N_noxref_4_c_470_n N_noxref_12_M4_noxref_s ) capacitor c=0.0326693f \
 //x=8.065 //y=1.045 //x2=7.71 //y2=0.545
cc_472 ( N_noxref_4_c_473_n N_noxref_12_M4_noxref_s ) capacitor c=3.48408e-19 \
 //x=8.065 //y=1.7 //x2=7.71 //y2=0.545
cc_473 ( N_noxref_4_c_477_n N_noxref_12_M4_noxref_s ) capacitor c=0.0120759f \
 //x=8.595 //y=1.045 //x2=7.71 //y2=0.545
cc_474 ( N_noxref_5_c_625_n N_D_c_1016_n ) capacitor c=0.0127867f //x=9.175 \
 //y=5.38 //x2=9 //y2=4.715
cc_475 ( N_noxref_5_c_603_n N_D_c_1016_n ) capacitor c=0.0101115f //x=9.74 \
 //y=2.77 //x2=9 //y2=4.715
cc_476 ( N_noxref_5_c_600_n N_D_c_1007_n ) capacitor c=0.00316373f //x=9.855 \
 //y=2.77 //x2=9 //y2=2.26
cc_477 ( N_noxref_5_c_603_n N_D_c_1007_n ) capacitor c=0.0820562f //x=9.74 \
 //y=2.77 //x2=9 //y2=2.26
cc_478 ( N_noxref_5_c_605_n N_D_c_1007_n ) capacitor c=0.00108914f //x=11.22 \
 //y=2.265 //x2=9 //y2=2.26
cc_479 ( N_noxref_5_c_625_n N_D_M17_noxref_g ) capacitor c=0.0166699f \
 //x=9.175 //y=5.38 //x2=9.04 //y2=6.2
cc_480 ( N_noxref_5_M17_noxref_d N_D_M17_noxref_g ) capacitor c=0.0173476f \
 //x=9.115 //y=5.2 //x2=9.04 //y2=6.2
cc_481 ( N_noxref_5_c_630_n N_D_M18_noxref_g ) capacitor c=0.0223814f \
 //x=9.655 //y=5.38 //x2=9.48 //y2=6.2
cc_482 ( N_noxref_5_M17_noxref_d N_D_M18_noxref_g ) capacitor c=0.0179769f \
 //x=9.115 //y=5.2 //x2=9.48 //y2=6.2
cc_483 ( N_noxref_5_M5_noxref_d N_D_c_1025_n ) capacitor c=0.00217566f \
 //x=9.11 //y=1.085 //x2=9.035 //y2=1.085
cc_484 ( N_noxref_5_M5_noxref_d N_D_c_1028_n ) capacitor c=0.0034598f //x=9.11 \
 //y=1.085 //x2=9.035 //y2=1.43
cc_485 ( N_noxref_5_M5_noxref_d N_D_c_1030_n ) capacitor c=0.0065582f //x=9.11 \
 //y=1.085 //x2=9.035 //y2=1.74
cc_486 ( N_noxref_5_c_603_n N_D_c_1051_n ) capacitor c=0.0142673f //x=9.74 \
 //y=2.77 //x2=9.405 //y2=4.97
cc_487 ( N_noxref_5_c_679_p N_D_c_1051_n ) capacitor c=0.00421574f //x=9.26 \
 //y=5.38 //x2=9.405 //y2=4.97
cc_488 ( N_noxref_5_M5_noxref_d N_D_c_1053_n ) capacitor c=0.00241102f \
 //x=9.11 //y=1.085 //x2=9.41 //y2=0.93
cc_489 ( N_noxref_5_c_601_n N_D_c_1054_n ) capacitor c=0.00359704f //x=9.655 \
 //y=1.835 //x2=9.41 //y2=1.585
cc_490 ( N_noxref_5_M5_noxref_d N_D_c_1054_n ) capacitor c=0.0138845f //x=9.11 \
 //y=1.085 //x2=9.41 //y2=1.585
cc_491 ( N_noxref_5_M5_noxref_d N_D_c_1033_n ) capacitor c=0.00132245f \
 //x=9.11 //y=1.085 //x2=9.565 //y2=1.085
cc_492 ( N_noxref_5_c_601_n N_D_c_1034_n ) capacitor c=0.00457401f //x=9.655 \
 //y=1.835 //x2=9.565 //y2=1.43
cc_493 ( N_noxref_5_M5_noxref_d N_D_c_1034_n ) capacitor c=0.00566463f \
 //x=9.11 //y=1.085 //x2=9.565 //y2=1.43
cc_494 ( N_noxref_5_c_603_n N_D_c_1035_n ) capacitor c=0.00877984f //x=9.74 \
 //y=2.77 //x2=9 //y2=2.26
cc_495 ( N_noxref_5_c_603_n N_D_c_1060_n ) capacitor c=0.00306024f //x=9.74 \
 //y=2.77 //x2=9 //y2=2.095
cc_496 ( N_noxref_5_M5_noxref_d N_D_c_1060_n ) capacitor c=0.00660593f \
 //x=9.11 //y=1.085 //x2=9 //y2=2.095
cc_497 ( N_noxref_5_c_625_n N_D_c_1037_n ) capacitor c=0.00399417f //x=9.175 \
 //y=5.38 //x2=9.03 //y2=4.88
cc_498 ( N_noxref_5_c_603_n N_D_c_1037_n ) capacitor c=0.00533692f //x=9.74 \
 //y=2.77 //x2=9.03 //y2=4.88
cc_499 ( N_noxref_5_c_691_p N_noxref_12_c_1098_n ) capacitor c=3.15806e-19 \
 //x=9.385 //y=1.835 //x2=7.845 //y2=1.675
cc_500 ( N_noxref_5_c_691_p N_noxref_12_c_1081_n ) capacitor c=0.0203424f \
 //x=9.385 //y=1.835 //x2=8.815 //y2=1.675
cc_501 ( N_noxref_5_c_601_n N_noxref_12_c_1082_n ) capacitor c=0.00468333f \
 //x=9.655 //y=1.835 //x2=9.7 //y2=0.71
cc_502 ( N_noxref_5_M5_noxref_d N_noxref_12_c_1082_n ) capacitor c=0.0118355f \
 //x=9.11 //y=1.085 //x2=9.7 //y2=0.71
cc_503 ( N_noxref_5_c_597_n N_noxref_12_M4_noxref_s ) capacitor c=3.03583e-19 \
 //x=11.105 //y=2.77 //x2=7.71 //y2=0.545
cc_504 ( N_noxref_5_c_600_n N_noxref_12_M4_noxref_s ) capacitor c=6.92363e-19 \
 //x=9.855 //y=2.77 //x2=7.71 //y2=0.545
cc_505 ( N_noxref_5_c_601_n N_noxref_12_M4_noxref_s ) capacitor c=0.0129465f \
 //x=9.655 //y=1.835 //x2=7.71 //y2=0.545
cc_506 ( N_noxref_5_M5_noxref_d N_noxref_12_M4_noxref_s ) capacitor \
 c=0.043966f //x=9.11 //y=1.085 //x2=7.71 //y2=0.545
cc_507 ( N_noxref_5_c_597_n Y ) capacitor c=0.00730959f //x=11.105 //y=2.77 \
 //x2=11.96 //y2=2.4
cc_508 ( N_noxref_5_c_603_n Y ) capacitor c=0.00108914f //x=9.74 //y=2.77 \
 //x2=11.96 //y2=2.4
cc_509 ( N_noxref_5_c_605_n Y ) capacitor c=0.0712221f //x=11.22 //y=2.265 \
 //x2=11.96 //y2=2.4
cc_510 ( N_noxref_5_c_617_n Y ) capacitor c=8.49451e-19 //x=11.22 //y=2.265 \
 //x2=11.96 //y2=2.4
cc_511 ( N_noxref_5_c_703_p N_Y_c_1129_n ) capacitor c=0.0023507f //x=11.705 \
 //y=1.59 //x2=11.875 //y2=2.26
cc_512 ( N_noxref_5_c_617_n N_Y_c_1152_n ) capacitor c=0.0167852f //x=11.22 \
 //y=2.265 //x2=11.675 //y2=2.26
cc_513 ( N_noxref_5_c_642_n N_Y_c_1139_n ) capacitor c=0.0107726f //x=11.74 \
 //y=4.97 //x2=11.875 //y2=4.76
cc_514 ( N_noxref_5_c_605_n N_Y_c_1141_n ) capacitor c=0.0250789f //x=11.22 \
 //y=2.265 //x2=11.68 //y2=4.76
cc_515 ( N_noxref_5_c_643_n N_Y_c_1141_n ) capacitor c=0.00962086f //x=11.45 \
 //y=4.97 //x2=11.68 //y2=4.76
cc_516 ( N_noxref_5_c_603_n N_Y_M6_noxref_d ) capacitor c=3.35192e-19 //x=9.74 \
 //y=2.77 //x2=11.405 //y2=1.09
cc_517 ( N_noxref_5_c_605_n N_Y_M6_noxref_d ) capacitor c=0.0175773f //x=11.22 \
 //y=2.265 //x2=11.405 //y2=1.09
cc_518 ( N_noxref_5_c_610_n N_Y_M6_noxref_d ) capacitor c=0.00218556f \
 //x=11.33 //y=1.09 //x2=11.405 //y2=1.09
cc_519 ( N_noxref_5_c_711_p N_Y_M6_noxref_d ) capacitor c=0.00347355f \
 //x=11.33 //y=1.435 //x2=11.405 //y2=1.09
cc_520 ( N_noxref_5_c_712_p N_Y_M6_noxref_d ) capacitor c=0.00742431f \
 //x=11.33 //y=1.745 //x2=11.405 //y2=1.09
cc_521 ( N_noxref_5_c_612_n N_Y_M6_noxref_d ) capacitor c=0.00957707f \
 //x=11.33 //y=2.1 //x2=11.405 //y2=1.09
cc_522 ( N_noxref_5_c_613_n N_Y_M6_noxref_d ) capacitor c=0.00220879f \
 //x=11.705 //y=0.935 //x2=11.405 //y2=1.09
cc_523 ( N_noxref_5_c_703_p N_Y_M6_noxref_d ) capacitor c=0.0138447f \
 //x=11.705 //y=1.59 //x2=11.405 //y2=1.09
cc_524 ( N_noxref_5_c_614_n N_Y_M6_noxref_d ) capacitor c=0.00218624f \
 //x=11.86 //y=1.09 //x2=11.405 //y2=1.09
cc_525 ( N_noxref_5_c_616_n N_Y_M6_noxref_d ) capacitor c=0.00601286f \
 //x=11.86 //y=1.435 //x2=11.405 //y2=1.09
cc_526 ( N_noxref_5_c_603_n N_Y_M19_noxref_d ) capacitor c=6.3502e-19 //x=9.74 \
 //y=2.77 //x2=11.45 //y2=5.2
cc_527 ( N_noxref_5_M19_noxref_g N_Y_M19_noxref_d ) capacitor c=0.0219309f \
 //x=11.375 //y=6.2 //x2=11.45 //y2=5.2
cc_528 ( N_noxref_5_M20_noxref_g N_Y_M19_noxref_d ) capacitor c=0.021902f \
 //x=11.815 //y=6.2 //x2=11.45 //y2=5.2
cc_529 ( N_noxref_5_c_642_n N_Y_M19_noxref_d ) capacitor c=0.0148755f \
 //x=11.74 //y=4.97 //x2=11.45 //y2=5.2
cc_530 ( N_noxref_5_c_643_n N_Y_M19_noxref_d ) capacitor c=0.00307344f \
 //x=11.45 //y=4.97 //x2=11.45 //y2=5.2
cc_531 ( N_A_c_723_n N_B_c_787_n ) capacitor c=0.00400249f //x=1.6 //y=2.26 \
 //x2=2.34 //y2=4.715
cc_532 ( N_A_c_740_n N_B_c_787_n ) capacitor c=0.00417994f //x=1.6 //y=4.88 \
 //x2=2.34 //y2=4.715
cc_533 ( N_A_c_723_n N_B_c_778_n ) capacitor c=0.0887263f //x=1.6 //y=2.26 \
 //x2=2.34 //y2=2.26
cc_534 ( N_A_c_728_n N_B_c_778_n ) capacitor c=0.00308814f //x=1.405 //y=2.095 \
 //x2=2.34 //y2=2.26
cc_535 ( N_A_M7_noxref_g N_B_M9_noxref_g ) capacitor c=0.0104611f //x=1.5 \
 //y=6.2 //x2=2.38 //y2=6.2
cc_536 ( N_A_M8_noxref_g N_B_M9_noxref_g ) capacitor c=0.106811f //x=1.94 \
 //y=6.2 //x2=2.38 //y2=6.2
cc_537 ( N_A_M8_noxref_g N_B_M10_noxref_g ) capacitor c=0.0100341f //x=1.94 \
 //y=6.2 //x2=2.82 //y2=6.2
cc_538 ( N_A_c_724_n N_B_c_796_n ) capacitor c=4.86506e-19 //x=1.405 //y=1.045 \
 //x2=2.375 //y2=1.085
cc_539 ( N_A_c_726_n N_B_c_796_n ) capacitor c=0.00152104f //x=1.405 //y=1.39 \
 //x2=2.375 //y2=1.085
cc_540 ( N_A_c_731_n N_B_c_796_n ) capacitor c=0.0151475f //x=1.935 //y=1.045 \
 //x2=2.375 //y2=1.085
cc_541 ( N_A_c_727_n N_B_c_797_n ) capacitor c=0.00109982f //x=1.405 //y=1.7 \
 //x2=2.375 //y2=1.43
cc_542 ( N_A_c_733_n N_B_c_797_n ) capacitor c=0.0111064f //x=1.935 //y=1.39 \
 //x2=2.375 //y2=1.43
cc_543 ( N_A_c_727_n N_B_c_798_n ) capacitor c=9.57794e-19 //x=1.405 //y=1.7 \
 //x2=2.375 //y2=1.74
cc_544 ( N_A_c_728_n N_B_c_798_n ) capacitor c=0.00662747f //x=1.405 //y=2.095 \
 //x2=2.375 //y2=1.74
cc_545 ( N_A_c_733_n N_B_c_798_n ) capacitor c=0.00862358f //x=1.935 //y=1.39 \
 //x2=2.375 //y2=1.74
cc_546 ( N_A_c_731_n N_B_c_804_n ) capacitor c=0.00124821f //x=1.935 //y=1.045 \
 //x2=2.905 //y2=1.085
cc_547 ( N_A_c_733_n N_B_c_805_n ) capacitor c=0.00200715f //x=1.935 //y=1.39 \
 //x2=2.905 //y2=1.43
cc_548 ( N_A_c_723_n N_B_c_807_n ) capacitor c=0.00307062f //x=1.6 //y=2.26 \
 //x2=2.34 //y2=2.26
cc_549 ( N_A_c_728_n N_B_c_807_n ) capacitor c=0.0179092f //x=1.405 //y=2.095 \
 //x2=2.34 //y2=2.26
cc_550 ( N_A_c_723_n N_B_c_810_n ) capacitor c=0.00344981f //x=1.6 //y=2.26 \
 //x2=2.37 //y2=4.88
cc_551 ( N_A_c_740_n N_B_c_810_n ) capacitor c=0.0293367f //x=1.6 //y=4.88 \
 //x2=2.37 //y2=4.88
cc_552 ( N_A_c_728_n N_noxref_8_c_866_n ) capacitor c=0.0034165f //x=1.405 \
 //y=2.095 //x2=1.185 //y2=1.675
cc_553 ( N_A_c_723_n N_noxref_8_c_842_n ) capacitor c=0.0118986f //x=1.6 \
 //y=2.26 //x2=2.07 //y2=1.76
cc_554 ( N_A_c_727_n N_noxref_8_c_842_n ) capacitor c=0.00703567f //x=1.405 \
 //y=1.7 //x2=2.07 //y2=1.76
cc_555 ( N_A_c_728_n N_noxref_8_c_842_n ) capacitor c=0.0216532f //x=1.405 \
 //y=2.095 //x2=2.07 //y2=1.76
cc_556 ( N_A_c_730_n N_noxref_8_c_842_n ) capacitor c=0.00780629f //x=1.78 \
 //y=1.545 //x2=2.07 //y2=1.76
cc_557 ( N_A_c_733_n N_noxref_8_c_842_n ) capacitor c=0.00339872f //x=1.935 \
 //y=1.39 //x2=2.07 //y2=1.76
cc_558 ( N_A_c_728_n N_noxref_8_c_850_n ) capacitor c=6.71402e-19 //x=1.405 \
 //y=2.095 //x2=2.155 //y2=1.675
cc_559 ( N_A_c_724_n N_noxref_8_M0_noxref_s ) capacitor c=0.0326577f //x=1.405 \
 //y=1.045 //x2=1.05 //y2=0.545
cc_560 ( N_A_c_727_n N_noxref_8_M0_noxref_s ) capacitor c=3.48408e-19 \
 //x=1.405 //y=1.7 //x2=1.05 //y2=0.545
cc_561 ( N_A_c_731_n N_noxref_8_M0_noxref_s ) capacitor c=0.0120759f //x=1.935 \
 //y=1.045 //x2=1.05 //y2=0.545
cc_562 ( N_B_c_798_n N_noxref_8_c_850_n ) capacitor c=0.00623646f //x=2.375 \
 //y=1.74 //x2=2.155 //y2=1.675
cc_563 ( N_B_c_807_n N_noxref_8_c_850_n ) capacitor c=0.00172768f //x=2.34 \
 //y=2.26 //x2=2.155 //y2=1.675
cc_564 ( N_B_c_778_n N_noxref_8_c_851_n ) capacitor c=0.00161845f //x=2.34 \
 //y=2.26 //x2=3.04 //y2=0.71
cc_565 ( N_B_c_796_n N_noxref_8_c_851_n ) capacitor c=0.0186143f //x=2.375 \
 //y=1.085 //x2=3.04 //y2=0.71
cc_566 ( N_B_c_804_n N_noxref_8_c_851_n ) capacitor c=0.00656458f //x=2.905 \
 //y=1.085 //x2=3.04 //y2=0.71
cc_567 ( N_B_c_807_n N_noxref_8_c_851_n ) capacitor c=2.1838e-19 //x=2.34 \
 //y=2.26 //x2=3.04 //y2=0.71
cc_568 ( N_B_c_796_n N_noxref_8_M0_noxref_s ) capacitor c=0.00623646f \
 //x=2.375 //y=1.085 //x2=1.05 //y2=0.545
cc_569 ( N_B_c_804_n N_noxref_8_M0_noxref_s ) capacitor c=0.0143002f //x=2.905 \
 //y=1.085 //x2=1.05 //y2=0.545
cc_570 ( N_B_c_805_n N_noxref_8_M0_noxref_s ) capacitor c=0.00290153f \
 //x=2.905 //y=1.43 //x2=1.05 //y2=0.545
cc_571 ( N_C_M13_noxref_g N_noxref_10_c_964_n ) capacitor c=0.0170604f \
 //x=5.71 //y=6.205 //x2=5.405 //y2=5.39
cc_572 ( N_C_c_929_n N_noxref_10_c_964_n ) capacitor c=2.3112e-19 //x=5.705 \
 //y=4.885 //x2=5.405 //y2=5.39
cc_573 ( N_C_c_906_n N_noxref_10_c_969_n ) capacitor c=0.00109004f //x=5.67 \
 //y=4.72 //x2=6.285 //y2=7.09
cc_574 ( N_C_M13_noxref_g N_noxref_10_c_969_n ) capacitor c=0.0148484f \
 //x=5.71 //y=6.205 //x2=6.285 //y2=7.09
cc_575 ( N_C_M14_noxref_g N_noxref_10_c_969_n ) capacitor c=0.0163196f \
 //x=6.15 //y=6.205 //x2=6.285 //y2=7.09
cc_576 ( N_C_M14_noxref_g N_noxref_10_M14_noxref_d ) capacitor c=0.0351101f \
 //x=6.15 //y=6.205 //x2=6.225 //y2=5.205
cc_577 ( N_D_c_1030_n N_noxref_12_c_1081_n ) capacitor c=0.00623646f //x=9.035 \
 //y=1.74 //x2=8.815 //y2=1.675
cc_578 ( N_D_c_1035_n N_noxref_12_c_1081_n ) capacitor c=0.00172768f //x=9 \
 //y=2.26 //x2=8.815 //y2=1.675
cc_579 ( N_D_c_1007_n N_noxref_12_c_1082_n ) capacitor c=0.00161845f //x=9 \
 //y=2.26 //x2=9.7 //y2=0.71
cc_580 ( N_D_c_1025_n N_noxref_12_c_1082_n ) capacitor c=0.0186143f //x=9.035 \
 //y=1.085 //x2=9.7 //y2=0.71
cc_581 ( N_D_c_1033_n N_noxref_12_c_1082_n ) capacitor c=0.00656458f //x=9.565 \
 //y=1.085 //x2=9.7 //y2=0.71
cc_582 ( N_D_c_1035_n N_noxref_12_c_1082_n ) capacitor c=2.1838e-19 //x=9 \
 //y=2.26 //x2=9.7 //y2=0.71
cc_583 ( N_D_c_1025_n N_noxref_12_M4_noxref_s ) capacitor c=0.00623646f \
 //x=9.035 //y=1.085 //x2=7.71 //y2=0.545
cc_584 ( N_D_c_1033_n N_noxref_12_M4_noxref_s ) capacitor c=0.0143002f \
 //x=9.565 //y=1.085 //x2=7.71 //y2=0.545
cc_585 ( N_D_c_1034_n N_noxref_12_M4_noxref_s ) capacitor c=0.00290153f \
 //x=9.565 //y=1.43 //x2=7.71 //y2=0.545
