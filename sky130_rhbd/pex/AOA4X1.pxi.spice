// File: AOA4X1.spi.AOA4X1.pxi
// Created: Sun Mar 15 12:39:00 2026
//
simulator lang=spectre
x_PM_AOA4X1\%noxref_1 ( N_noxref_1_c_43_p N_noxref_1_c_10_p N_noxref_1_c_30_p \
 N_noxref_1_c_17_p N_noxref_1_c_256_p N_noxref_1_c_25_p N_noxref_1_c_110_p \
 N_noxref_1_c_27_p N_noxref_1_c_26_p N_noxref_1_c_18_p N_noxref_1_c_28_p \
 N_noxref_1_c_45_p N_noxref_1_c_46_p N_noxref_1_c_47_p N_noxref_1_c_1_p \
 N_noxref_1_c_90_p N_noxref_1_c_31_p N_noxref_1_c_2_p N_noxref_1_c_71_p \
 N_noxref_1_c_115_p N_noxref_1_c_20_p N_noxref_1_c_72_p N_noxref_1_c_48_p \
 N_noxref_1_c_49_p N_noxref_1_c_29_p N_noxref_1_c_3_p N_noxref_1_M2_noxref_g \
 N_noxref_1_M11_noxref_g N_noxref_1_M12_noxref_g N_noxref_1_c_4_p \
 N_noxref_1_c_5_p N_noxref_1_c_12_p N_noxref_1_c_13_p N_noxref_1_c_6_p \
 N_noxref_1_c_7_p N_noxref_1_c_95_p N_noxref_1_c_8_p N_noxref_1_c_9_p \
 N_noxref_1_c_76_p N_noxref_1_M1_noxref_d N_noxref_1_M7_noxref_d \
 N_noxref_1_M9_noxref_d )  PM_AOA4X1\%noxref_1
x_PM_AOA4X1\%noxref_2 ( N_noxref_2_c_266_n N_noxref_2_c_275_n \
 N_noxref_2_c_281_n N_noxref_2_c_282_n N_noxref_2_c_324_p N_noxref_2_c_288_n \
 N_noxref_2_c_332_p N_noxref_2_c_311_p N_noxref_2_c_290_n N_noxref_2_c_372_p \
 N_noxref_2_c_292_n N_noxref_2_c_313_p N_noxref_2_c_317_p N_noxref_2_c_295_n \
 N_noxref_2_c_296_n N_noxref_2_c_325_p N_noxref_2_c_428_p N_noxref_2_c_319_p \
 N_noxref_2_c_315_p N_noxref_2_c_297_n N_noxref_2_c_326_p N_noxref_2_c_345_p \
 N_noxref_2_c_336_p N_noxref_2_c_430_p N_noxref_2_c_320_p \
 N_noxref_2_M4_noxref_g N_noxref_2_M15_noxref_g N_noxref_2_M16_noxref_g \
 N_noxref_2_c_431_p N_noxref_2_c_432_p N_noxref_2_c_433_p N_noxref_2_c_462_p \
 N_noxref_2_c_434_p N_noxref_2_c_435_p N_noxref_2_c_436_p N_noxref_2_c_437_p \
 N_noxref_2_c_323_p N_noxref_2_M2_noxref_d N_noxref_2_M3_noxref_d \
 N_noxref_2_M13_noxref_d )  PM_AOA4X1\%noxref_2
x_PM_AOA4X1\%noxref_3 ( N_noxref_3_c_538_n N_noxref_3_c_539_n \
 N_noxref_3_c_563_p N_noxref_3_c_619_p N_noxref_3_c_541_n N_noxref_3_c_542_n \
 N_noxref_3_c_620_p N_noxref_3_c_544_n N_noxref_3_c_641_p N_noxref_3_c_611_p \
 N_noxref_3_c_564_p N_noxref_3_c_546_n N_noxref_3_c_566_p N_noxref_3_c_567_p \
 N_noxref_3_c_554_n N_noxref_3_c_555_n N_noxref_3_c_644_p N_noxref_3_c_623_p \
 N_noxref_3_c_556_n N_noxref_3_c_718_p N_noxref_3_c_589_p N_noxref_3_c_557_n \
 N_noxref_3_c_569_p N_noxref_3_c_624_p N_noxref_3_c_570_p \
 N_noxref_3_M6_noxref_g N_noxref_3_M19_noxref_g N_noxref_3_M20_noxref_g \
 N_noxref_3_c_634_p N_noxref_3_c_726_p N_noxref_3_c_659_p N_noxref_3_c_648_p \
 N_noxref_3_c_597_p N_noxref_3_c_593_p N_noxref_3_c_661_p N_noxref_3_c_729_p \
 N_noxref_3_c_636_p N_noxref_3_c_663_p N_noxref_3_c_635_p \
 N_noxref_3_M5_noxref_d N_noxref_3_M15_noxref_d N_noxref_3_M17_noxref_d )  \
 PM_AOA4X1\%noxref_3
x_PM_AOA4X1\%VDD ( VDD N_VDD_c_769_n N_VDD_c_776_n N_VDD_c_778_n N_VDD_c_822_n \
 N_VDD_c_780_n N_VDD_c_783_n N_VDD_c_788_n N_VDD_c_827_n N_VDD_c_858_n \
 N_VDD_c_863_n N_VDD_c_790_n N_VDD_c_793_n N_VDD_c_803_n N_VDD_c_869_n \
 N_VDD_c_804_n N_VDD_M7_noxref_s N_VDD_M8_noxref_d N_VDD_M10_noxref_d \
 N_VDD_M11_noxref_d N_VDD_M15_noxref_s N_VDD_M16_noxref_d N_VDD_M18_noxref_d \
 N_VDD_M19_noxref_s N_VDD_M20_noxref_d )  PM_AOA4X1\%VDD
x_PM_AOA4X1\%A ( A A A A A A A N_A_c_1034_p N_A_c_1005_n N_A_c_1028_p \
 N_A_c_1007_n N_A_M0_noxref_g N_A_M7_noxref_g N_A_M8_noxref_g N_A_c_1048_p \
 N_A_c_1049_p N_A_c_1051_p N_A_c_1036_p N_A_c_1070_p N_A_c_1071_p N_A_c_1050_p \
 N_A_c_1052_p N_A_c_1014_n )  PM_AOA4X1\%A
x_PM_AOA4X1\%B ( B B B B B B B N_B_c_1108_n N_B_c_1110_n N_B_c_1112_n \
 N_B_c_1113_n N_B_M1_noxref_g N_B_M9_noxref_g N_B_M10_noxref_g N_B_c_1121_n \
 N_B_c_1123_n N_B_c_1126_n N_B_c_1127_n N_B_c_1130_n N_B_c_1132_n N_B_c_1136_n \
 N_B_c_1138_n N_B_c_1142_n N_B_c_1143_n N_B_c_1145_n )  PM_AOA4X1\%B
x_PM_AOA4X1\%noxref_7 ( N_noxref_7_c_1208_n N_noxref_7_c_1231_n \
 N_noxref_7_c_1214_n N_noxref_7_c_1221_n N_noxref_7_c_1222_n \
 N_noxref_7_c_1238_n N_noxref_7_c_1223_n N_noxref_7_c_1227_n \
 N_noxref_7_M11_noxref_s N_noxref_7_M12_noxref_d N_noxref_7_M14_noxref_d )  \
 PM_AOA4X1\%noxref_7
x_PM_AOA4X1\%C ( C C C C C C C N_C_c_1310_n N_C_c_1313_n N_C_c_1316_n \
 N_C_c_1320_n N_C_M3_noxref_g N_C_M13_noxref_g N_C_M14_noxref_g N_C_c_1327_n \
 N_C_c_1329_n N_C_c_1332_n N_C_c_1373_n N_C_c_1376_n N_C_c_1334_n N_C_c_1335_n \
 N_C_c_1336_n N_C_c_1337_n N_C_c_1340_n N_C_c_1341_n )  PM_AOA4X1\%C
x_PM_AOA4X1\%GND ( GND N_GND_c_1573_n N_GND_c_1421_n N_GND_c_1522_n \
 N_GND_c_1427_n N_GND_c_1583_n N_GND_c_1467_n N_GND_c_1478_n N_GND_c_1430_n \
 N_GND_c_1432_n N_GND_c_1653_p N_GND_c_1434_n N_GND_c_1484_n N_GND_c_1688_p \
 N_GND_c_1488_n N_GND_c_1489_n N_GND_c_1682_p N_GND_c_1534_n N_GND_c_1539_n \
 N_GND_c_1440_n N_GND_c_1491_n N_GND_c_1541_n N_GND_c_1451_n N_GND_M0_noxref_d \
 N_GND_M2_noxref_s N_GND_M4_noxref_d N_GND_M6_noxref_s )  PM_AOA4X1\%GND
x_PM_AOA4X1\%D ( D D D D D D D N_D_c_1706_n N_D_c_1709_n N_D_c_1712_n \
 N_D_c_1716_n N_D_M5_noxref_g N_D_M17_noxref_g N_D_M18_noxref_g N_D_c_1722_n \
 N_D_c_1725_n N_D_c_1727_n N_D_c_1764_n N_D_c_1767_n N_D_c_1769_n N_D_c_1730_n \
 N_D_c_1731_n N_D_c_1732_n N_D_c_1780_n N_D_c_1735_n )  PM_AOA4X1\%D
x_PM_AOA4X1\%Y ( Y Y Y Y Y Y Y N_Y_c_1821_n N_Y_c_1828_n N_Y_c_1832_n \
 N_Y_c_1833_n N_Y_c_1835_n N_Y_c_1836_n N_Y_c_1839_n N_Y_c_1847_n \
 N_Y_M6_noxref_d N_Y_M19_noxref_d )  PM_AOA4X1\%Y
x_PM_AOA4X1\%noxref_12 ( N_noxref_12_c_1898_n N_noxref_12_c_1899_n \
 N_noxref_12_c_1925_n N_noxref_12_c_1888_n N_noxref_12_c_1889_n \
 N_noxref_12_c_1935_n N_noxref_12_M0_noxref_s )  PM_AOA4X1\%noxref_12
x_PM_AOA4X1\%noxref_13 ( N_noxref_13_c_1949_n N_noxref_13_c_1951_n \
 N_noxref_13_c_1978_n N_noxref_13_c_1959_n N_noxref_13_c_1964_n \
 N_noxref_13_c_1988_n N_noxref_13_M4_noxref_s )  PM_AOA4X1\%noxref_13
cc_1 ( N_noxref_1_c_1_p N_noxref_2_c_266_n ) capacitor c=0.00604284f //x=2.64 \
 //y=1.18 //x2=5 //y2=1.305
cc_2 ( N_noxref_1_c_2_p N_noxref_2_c_266_n ) capacitor c=0.00116613f //x=4.93 \
 //y=2.26 //x2=5 //y2=1.305
cc_3 ( N_noxref_1_c_3_p N_noxref_2_c_266_n ) capacitor c=7.02188e-19 //x=4.93 \
 //y=2.26 //x2=5 //y2=1.305
cc_4 ( N_noxref_1_c_4_p N_noxref_2_c_266_n ) capacitor c=6.06305e-19 //x=4.735 \
 //y=1.085 //x2=5 //y2=1.305
cc_5 ( N_noxref_1_c_5_p N_noxref_2_c_266_n ) capacitor c=0.00328491f //x=4.735 \
 //y=1.43 //x2=5 //y2=1.305
cc_6 ( N_noxref_1_c_6_p N_noxref_2_c_266_n ) capacitor c=5.29726e-19 //x=5.11 \
 //y=0.93 //x2=5 //y2=1.305
cc_7 ( N_noxref_1_c_7_p N_noxref_2_c_266_n ) capacitor c=6.14781e-19 //x=5.11 \
 //y=1.585 //x2=5 //y2=1.305
cc_8 ( N_noxref_1_c_8_p N_noxref_2_c_266_n ) capacitor c=5.57259e-19 //x=5.265 \
 //y=1.085 //x2=5 //y2=1.305
cc_9 ( N_noxref_1_c_9_p N_noxref_2_c_266_n ) capacitor c=0.00212774f //x=5.265 \
 //y=1.43 //x2=5 //y2=1.305
cc_10 ( N_noxref_1_c_10_p N_noxref_2_c_275_n ) capacitor c=0.00445584f \
 //x=2.64 //y=1.75 //x2=5 //y2=1.75
cc_11 ( N_noxref_1_c_5_p N_noxref_2_c_275_n ) capacitor c=0.00109347f \
 //x=4.735 //y=1.43 //x2=5 //y2=1.75
cc_12 ( N_noxref_1_c_12_p N_noxref_2_c_275_n ) capacitor c=0.00314841f \
 //x=4.735 //y=1.74 //x2=5 //y2=1.75
cc_13 ( N_noxref_1_c_13_p N_noxref_2_c_275_n ) capacitor c=0.00309965f \
 //x=4.735 //y=2.095 //x2=5 //y2=1.75
cc_14 ( N_noxref_1_c_7_p N_noxref_2_c_275_n ) capacitor c=0.00674367f //x=5.11 \
 //y=1.585 //x2=5 //y2=1.75
cc_15 ( N_noxref_1_c_9_p N_noxref_2_c_275_n ) capacitor c=0.00253555f \
 //x=5.265 //y=1.43 //x2=5 //y2=1.75
cc_16 ( N_noxref_1_c_9_p N_noxref_2_c_281_n ) capacitor c=7.25274e-19 \
 //x=5.265 //y=1.43 //x2=5.885 //y2=1.835
cc_17 ( N_noxref_1_c_17_p N_noxref_2_c_282_n ) capacitor c=0.00351497f \
 //x=2.995 //y=1.835 //x2=5.085 //y2=1.835
cc_18 ( N_noxref_1_c_18_p N_noxref_2_c_282_n ) capacitor c=0.00127002f \
 //x=4.93 //y=2.925 //x2=5.085 //y2=1.835
cc_19 ( N_noxref_1_c_2_p N_noxref_2_c_282_n ) capacitor c=0.0161272f //x=4.93 \
 //y=2.26 //x2=5.085 //y2=1.835
cc_20 ( N_noxref_1_c_20_p N_noxref_2_c_282_n ) capacitor c=6.59793e-19 \
 //x=4.925 //y=2.765 //x2=5.085 //y2=1.835
cc_21 ( N_noxref_1_c_3_p N_noxref_2_c_282_n ) capacitor c=0.00293572f //x=4.93 \
 //y=2.26 //x2=5.085 //y2=1.835
cc_22 ( N_noxref_1_c_13_p N_noxref_2_c_282_n ) capacitor c=0.00107086f \
 //x=4.735 //y=2.095 //x2=5.085 //y2=1.835
cc_23 ( N_noxref_1_c_10_p N_noxref_2_c_288_n ) capacitor c=6.26628e-19 \
 //x=2.64 //y=1.75 //x2=5.97 //y2=1.75
cc_24 ( N_noxref_1_c_9_p N_noxref_2_c_288_n ) capacitor c=6.29838e-19 \
 //x=5.265 //y=1.43 //x2=5.97 //y2=1.75
cc_25 ( N_noxref_1_c_25_p N_noxref_2_c_290_n ) capacitor c=0.00204276f \
 //x=3.08 //y=2.605 //x2=6.41 //y2=2.605
cc_26 ( N_noxref_1_c_26_p N_noxref_2_c_290_n ) capacitor c=9.83329e-19 \
 //x=4.93 //y=2.605 //x2=6.41 //y2=2.605
cc_27 ( N_noxref_1_c_27_p N_noxref_2_c_292_n ) capacitor c=0.00294086f \
 //x=3.08 //y=5.295 //x2=6.41 //y2=5.305
cc_28 ( N_noxref_1_c_28_p N_noxref_2_c_292_n ) capacitor c=0.00558958f \
 //x=4.93 //y=4.765 //x2=6.41 //y2=5.305
cc_29 ( N_noxref_1_c_29_p N_noxref_2_c_292_n ) capacitor c=2.44646e-19 \
 //x=4.775 //y=4.885 //x2=6.41 //y2=5.305
cc_30 ( N_noxref_1_c_30_p N_noxref_2_c_295_n ) capacitor c=7.34073e-19 \
 //x=2.995 //y=5.38 //x2=5.925 //y2=5.39
cc_31 ( N_noxref_1_c_31_p N_noxref_2_c_296_n ) capacitor c=0.00251935f \
 //x=4.93 //y=2.77 //x2=6.41 //y2=2.77
cc_32 ( N_noxref_1_c_20_p N_noxref_2_c_297_n ) capacitor c=0.00542346f \
 //x=4.925 //y=2.765 //x2=6.565 //y2=2.765
cc_33 ( N_noxref_1_c_18_p N_noxref_2_M2_noxref_d ) capacitor c=3.25483e-19 \
 //x=4.93 //y=2.925 //x2=4.81 //y2=1.085
cc_34 ( N_noxref_1_c_2_p N_noxref_2_M2_noxref_d ) capacitor c=7.18966e-19 \
 //x=4.93 //y=2.26 //x2=4.81 //y2=1.085
cc_35 ( N_noxref_1_c_3_p N_noxref_2_M2_noxref_d ) capacitor c=0.00150225f \
 //x=4.93 //y=2.26 //x2=4.81 //y2=1.085
cc_36 ( N_noxref_1_c_4_p N_noxref_2_M2_noxref_d ) capacitor c=0.00124139f \
 //x=4.735 //y=1.085 //x2=4.81 //y2=1.085
cc_37 ( N_noxref_1_c_5_p N_noxref_2_M2_noxref_d ) capacitor c=0.00237422f \
 //x=4.735 //y=1.43 //x2=4.81 //y2=1.085
cc_38 ( N_noxref_1_c_13_p N_noxref_2_M2_noxref_d ) capacitor c=4.64713e-19 \
 //x=4.735 //y=2.095 //x2=4.81 //y2=1.085
cc_39 ( N_noxref_1_c_6_p N_noxref_2_M2_noxref_d ) capacitor c=0.00213893f \
 //x=5.11 //y=0.93 //x2=4.81 //y2=1.085
cc_40 ( N_noxref_1_c_7_p N_noxref_2_M2_noxref_d ) capacitor c=0.00345753f \
 //x=5.11 //y=1.585 //x2=4.81 //y2=1.085
cc_41 ( N_noxref_1_c_8_p N_noxref_2_M2_noxref_d ) capacitor c=0.00211919f \
 //x=5.265 //y=1.085 //x2=4.81 //y2=1.085
cc_42 ( N_noxref_1_c_9_p N_noxref_2_M2_noxref_d ) capacitor c=0.00237422f \
 //x=5.265 //y=1.43 //x2=4.81 //y2=1.085
cc_43 ( N_noxref_1_c_43_p N_VDD_c_769_n ) capacitor c=0.00648307f //x=2.485 \
 //y=5.38 //x2=4.965 //y2=7.585
cc_44 ( N_noxref_1_c_30_p N_VDD_c_769_n ) capacitor c=0.00488503f //x=2.995 \
 //y=5.38 //x2=4.965 //y2=7.585
cc_45 ( N_noxref_1_c_45_p N_VDD_c_769_n ) capacitor c=0.00368834f //x=1.72 \
 //y=5.56 //x2=4.965 //y2=7.585
cc_46 ( N_noxref_1_c_46_p N_VDD_c_769_n ) capacitor c=8.42709e-19 //x=2.6 \
 //y=5.38 //x2=4.965 //y2=7.585
cc_47 ( N_noxref_1_c_47_p N_VDD_c_769_n ) capacitor c=0.00285853f //x=2.6 \
 //y=5.56 //x2=4.965 //y2=7.585
cc_48 ( N_noxref_1_c_48_p N_VDD_c_769_n ) capacitor c=0.00224881f //x=1.72 \
 //y=5.56 //x2=4.965 //y2=7.585
cc_49 ( N_noxref_1_c_49_p N_VDD_c_769_n ) capacitor c=0.00224881f //x=2.6 \
 //y=5.56 //x2=4.965 //y2=7.585
cc_50 ( N_noxref_1_M11_noxref_g N_VDD_c_776_n ) capacitor c=0.00122608f \
 //x=4.83 //y=6.205 //x2=5.05 //y2=7.035
cc_51 ( N_noxref_1_M12_noxref_g N_VDD_c_776_n ) capacitor c=0.00122608f \
 //x=5.27 //y=6.205 //x2=5.05 //y2=7.035
cc_52 ( N_noxref_1_M11_noxref_g N_VDD_c_778_n ) capacitor c=0.00205385f \
 //x=4.83 //y=6.205 //x2=5.05 //y2=7.41
cc_53 ( N_noxref_1_M12_noxref_g N_VDD_c_778_n ) capacitor c=0.00294739f \
 //x=5.27 //y=6.205 //x2=5.05 //y2=7.41
cc_54 ( N_noxref_1_c_43_p N_VDD_c_780_n ) capacitor c=0.00213203f //x=2.485 \
 //y=5.38 //x2=2.075 //y2=7.585
cc_55 ( N_noxref_1_c_45_p N_VDD_c_780_n ) capacitor c=9.99055e-19 //x=1.72 \
 //y=5.56 //x2=2.075 //y2=7.585
cc_56 ( N_noxref_1_c_48_p N_VDD_c_780_n ) capacitor c=0.0136705f //x=1.72 \
 //y=5.56 //x2=2.075 //y2=7.585
cc_57 ( N_noxref_1_c_43_p N_VDD_c_783_n ) capacitor c=0.00184541f //x=2.485 \
 //y=5.38 //x2=2.955 //y2=7.585
cc_58 ( N_noxref_1_c_30_p N_VDD_c_783_n ) capacitor c=0.00213203f //x=2.995 \
 //y=5.38 //x2=2.955 //y2=7.585
cc_59 ( N_noxref_1_c_46_p N_VDD_c_783_n ) capacitor c=5.39459e-19 //x=2.6 \
 //y=5.38 //x2=2.955 //y2=7.585
cc_60 ( N_noxref_1_c_47_p N_VDD_c_783_n ) capacitor c=5.77976e-19 //x=2.6 \
 //y=5.56 //x2=2.955 //y2=7.585
cc_61 ( N_noxref_1_c_49_p N_VDD_c_783_n ) capacitor c=0.0136705f //x=2.6 \
 //y=5.56 //x2=2.955 //y2=7.585
cc_62 ( N_noxref_1_M11_noxref_g N_VDD_c_788_n ) capacitor c=0.00720181f \
 //x=4.83 //y=6.205 //x2=6.98 //y2=7.585
cc_63 ( N_noxref_1_M12_noxref_g N_VDD_c_788_n ) capacitor c=0.00760847f \
 //x=5.27 //y=6.205 //x2=6.98 //y2=7.585
cc_64 ( N_noxref_1_c_27_p N_VDD_c_790_n ) capacitor c=0.00197052f //x=3.08 \
 //y=5.295 //x2=1.23 //y2=7.58
cc_65 ( N_noxref_1_c_45_p N_VDD_c_790_n ) capacitor c=6.39392e-19 //x=1.72 \
 //y=5.56 //x2=1.23 //y2=7.58
cc_66 ( N_noxref_1_c_48_p N_VDD_c_790_n ) capacitor c=0.0064135f //x=1.72 \
 //y=5.56 //x2=1.23 //y2=7.58
cc_67 ( N_noxref_1_c_27_p N_VDD_c_793_n ) capacitor c=0.0305833f //x=3.08 \
 //y=5.295 //x2=3.82 //y2=7.585
cc_68 ( N_noxref_1_c_28_p N_VDD_c_793_n ) capacitor c=0.00722719f //x=4.93 \
 //y=4.765 //x2=3.82 //y2=7.585
cc_69 ( N_noxref_1_c_46_p N_VDD_c_793_n ) capacitor c=0.00240948f //x=2.6 \
 //y=5.38 //x2=3.82 //y2=7.585
cc_70 ( N_noxref_1_c_47_p N_VDD_c_793_n ) capacitor c=4.09141e-19 //x=2.6 \
 //y=5.56 //x2=3.82 //y2=7.585
cc_71 ( N_noxref_1_c_71_p N_VDD_c_793_n ) capacitor c=0.00344941f //x=4.775 \
 //y=4.885 //x2=3.82 //y2=7.585
cc_72 ( N_noxref_1_c_72_p N_VDD_c_793_n ) capacitor c=0.00259242f //x=4.765 \
 //y=2.765 //x2=3.82 //y2=7.585
cc_73 ( N_noxref_1_c_49_p N_VDD_c_793_n ) capacitor c=0.0101448f //x=2.6 \
 //y=5.56 //x2=3.82 //y2=7.585
cc_74 ( N_noxref_1_c_29_p N_VDD_c_793_n ) capacitor c=0.00643194f //x=4.775 \
 //y=4.885 //x2=3.82 //y2=7.585
cc_75 ( N_noxref_1_M11_noxref_g N_VDD_c_793_n ) capacitor c=0.00898416f \
 //x=4.83 //y=6.205 //x2=3.82 //y2=7.585
cc_76 ( N_noxref_1_c_76_p N_VDD_c_793_n ) capacitor c=0.00438848f //x=4.775 \
 //y=4.885 //x2=3.82 //y2=7.585
cc_77 ( N_noxref_1_c_29_p N_VDD_c_803_n ) capacitor c=3.49022e-19 //x=4.775 \
 //y=4.885 //x2=7.15 //y2=7.585
cc_78 ( N_noxref_1_c_48_p N_VDD_c_804_n ) capacitor c=0.00135089f //x=1.72 \
 //y=5.56 //x2=11.96 //y2=7.58
cc_79 ( N_noxref_1_c_49_p N_VDD_c_804_n ) capacitor c=0.00135089f //x=2.6 \
 //y=5.56 //x2=11.96 //y2=7.58
cc_80 ( N_noxref_1_c_45_p N_VDD_M7_noxref_s ) capacitor c=0.062494f //x=1.72 \
 //y=5.56 //x2=1.145 //y2=5.2
cc_81 ( N_noxref_1_c_46_p N_VDD_M7_noxref_s ) capacitor c=6.52457e-19 //x=2.6 \
 //y=5.38 //x2=1.145 //y2=5.2
cc_82 ( N_noxref_1_c_48_p N_VDD_M7_noxref_s ) capacitor c=0.0906034f //x=1.72 \
 //y=5.56 //x2=1.145 //y2=5.2
cc_83 ( N_noxref_1_c_43_p N_VDD_M8_noxref_d ) capacitor c=0.00810252f \
 //x=2.485 //y=5.38 //x2=2.015 //y2=5.2
cc_84 ( N_noxref_1_c_45_p N_VDD_M8_noxref_d ) capacitor c=0.0043528f //x=1.72 \
 //y=5.56 //x2=2.015 //y2=5.2
cc_85 ( N_noxref_1_c_47_p N_VDD_M8_noxref_d ) capacitor c=0.0043528f //x=2.6 \
 //y=5.56 //x2=2.015 //y2=5.2
cc_86 ( N_noxref_1_c_48_p N_VDD_M8_noxref_d ) capacitor c=0.0654258f //x=1.72 \
 //y=5.56 //x2=2.015 //y2=5.2
cc_87 ( N_noxref_1_c_49_p N_VDD_M8_noxref_d ) capacitor c=0.0653553f //x=2.6 \
 //y=5.56 //x2=2.015 //y2=5.2
cc_88 ( N_noxref_1_c_30_p N_VDD_M10_noxref_d ) capacitor c=0.0100502f \
 //x=2.995 //y=5.38 //x2=2.895 //y2=5.2
cc_89 ( N_noxref_1_c_47_p N_VDD_M10_noxref_d ) capacitor c=0.00979407f //x=2.6 \
 //y=5.56 //x2=2.895 //y2=5.2
cc_90 ( N_noxref_1_c_90_p N_VDD_M10_noxref_d ) capacitor c=6.87256e-19 \
 //x=3.08 //y=2.77 //x2=2.895 //y2=5.2
cc_91 ( N_noxref_1_c_49_p N_VDD_M10_noxref_d ) capacitor c=0.0651828f //x=2.6 \
 //y=5.56 //x2=2.895 //y2=5.2
cc_92 ( N_noxref_1_c_31_p N_VDD_M11_noxref_d ) capacitor c=3.55297e-19 \
 //x=4.93 //y=2.77 //x2=4.905 //y2=5.205
cc_93 ( N_noxref_1_M11_noxref_g N_VDD_M11_noxref_d ) capacitor c=0.0130453f \
 //x=4.83 //y=6.205 //x2=4.905 //y2=5.205
cc_94 ( N_noxref_1_M12_noxref_g N_VDD_M11_noxref_d ) capacitor c=0.0142727f \
 //x=5.27 //y=6.205 //x2=4.905 //y2=5.205
cc_95 ( N_noxref_1_c_95_p N_VDD_M11_noxref_d ) capacitor c=0.00241874f \
 //x=5.195 //y=4.975 //x2=4.905 //y2=5.205
cc_96 ( N_noxref_1_c_25_p A ) capacitor c=0.00100975f //x=3.08 //y=2.605 \
 //x2=1.6 //y2=2.4
cc_97 ( N_noxref_1_c_27_p A ) capacitor c=0.00453113f //x=3.08 //y=5.295 \
 //x2=1.6 //y2=2.4
cc_98 ( N_noxref_1_c_45_p N_A_c_1005_n ) capacitor c=0.0118546f //x=1.72 \
 //y=5.56 //x2=1.6 //y2=4.88
cc_99 ( N_noxref_1_c_48_p N_A_c_1005_n ) capacitor c=0.00165549f //x=1.72 \
 //y=5.56 //x2=1.6 //y2=4.88
cc_100 ( N_noxref_1_c_45_p N_A_c_1007_n ) capacitor c=0.00277154f //x=1.72 \
 //y=5.56 //x2=1.6 //y2=4.88
cc_101 ( N_noxref_1_c_48_p N_A_c_1007_n ) capacitor c=0.00377369f //x=1.72 \
 //y=5.56 //x2=1.6 //y2=4.88
cc_102 ( N_noxref_1_c_45_p N_A_M7_noxref_g ) capacitor c=0.0020878f //x=1.72 \
 //y=5.56 //x2=1.5 //y2=6.2
cc_103 ( N_noxref_1_c_48_p N_A_M7_noxref_g ) capacitor c=0.0158358f //x=1.72 \
 //y=5.56 //x2=1.5 //y2=6.2
cc_104 ( N_noxref_1_c_43_p N_A_M8_noxref_g ) capacitor c=0.0129249f //x=2.485 \
 //y=5.38 //x2=1.94 //y2=6.2
cc_105 ( N_noxref_1_c_45_p N_A_M8_noxref_g ) capacitor c=0.00192712f //x=1.72 \
 //y=5.56 //x2=1.94 //y2=6.2
cc_106 ( N_noxref_1_c_48_p N_A_M8_noxref_g ) capacitor c=0.0178987f //x=1.72 \
 //y=5.56 //x2=1.94 //y2=6.2
cc_107 ( N_noxref_1_c_45_p N_A_c_1014_n ) capacitor c=0.00207241f //x=1.72 \
 //y=5.56 //x2=1.6 //y2=4.88
cc_108 ( N_noxref_1_c_48_p N_A_c_1014_n ) capacitor c=0.0043218f //x=1.72 \
 //y=5.56 //x2=1.6 //y2=4.88
cc_109 ( N_noxref_1_c_25_p B ) capacitor c=0.009049f //x=3.08 //y=2.605 \
 //x2=2.34 //y2=2.4
cc_110 ( N_noxref_1_c_110_p B ) capacitor c=0.0148501f //x=3.08 //y=2.925 \
 //x2=2.34 //y2=2.4
cc_111 ( N_noxref_1_c_27_p B ) capacitor c=0.0837239f //x=3.08 //y=5.295 \
 //x2=2.34 //y2=2.4
cc_112 ( N_noxref_1_c_26_p B ) capacitor c=6.23212e-19 //x=4.93 //y=2.605 \
 //x2=2.34 //y2=2.4
cc_113 ( N_noxref_1_c_28_p B ) capacitor c=0.00288721f //x=4.93 //y=4.765 \
 //x2=2.34 //y2=2.4
cc_114 ( N_noxref_1_c_90_p B ) capacitor c=6.15181e-19 //x=3.08 //y=2.77 \
 //x2=2.34 //y2=2.4
cc_115 ( N_noxref_1_c_115_p B ) capacitor c=0.00687503f //x=3.24 //y=2.765 \
 //x2=2.34 //y2=2.4
cc_116 ( N_noxref_1_c_43_p N_B_c_1108_n ) capacitor c=0.0228479f //x=2.485 \
 //y=5.38 //x2=2.34 //y2=4.735
cc_117 ( N_noxref_1_c_27_p N_B_c_1108_n ) capacitor c=0.016905f //x=3.08 \
 //y=5.295 //x2=2.34 //y2=4.735
cc_118 ( N_noxref_1_c_43_p N_B_c_1110_n ) capacitor c=2.77624e-19 //x=2.485 \
 //y=5.38 //x2=2.34 //y2=2.26
cc_119 ( N_noxref_1_c_25_p N_B_c_1110_n ) capacitor c=0.015397f //x=3.08 \
 //y=2.605 //x2=2.34 //y2=2.26
cc_120 ( N_noxref_1_c_25_p N_B_c_1112_n ) capacitor c=9.90728e-19 //x=3.08 \
 //y=2.605 //x2=2.34 //y2=2.26
cc_121 ( N_noxref_1_c_43_p N_B_c_1113_n ) capacitor c=0.00469257f //x=2.485 \
 //y=5.38 //x2=2.37 //y2=4.88
cc_122 ( N_noxref_1_c_27_p N_B_c_1113_n ) capacitor c=0.00342433f //x=3.08 \
 //y=5.295 //x2=2.37 //y2=4.88
cc_123 ( N_noxref_1_c_43_p N_B_M9_noxref_g ) capacitor c=0.00842859f //x=2.485 \
 //y=5.38 //x2=2.38 //y2=6.2
cc_124 ( N_noxref_1_c_46_p N_B_M9_noxref_g ) capacitor c=0.00192712f //x=2.6 \
 //y=5.38 //x2=2.38 //y2=6.2
cc_125 ( N_noxref_1_c_49_p N_B_M9_noxref_g ) capacitor c=0.0178987f //x=2.6 \
 //y=5.56 //x2=2.38 //y2=6.2
cc_126 ( N_noxref_1_c_30_p N_B_M10_noxref_g ) capacitor c=0.0115937f //x=2.995 \
 //y=5.38 //x2=2.82 //y2=6.2
cc_127 ( N_noxref_1_c_46_p N_B_M10_noxref_g ) capacitor c=0.00298276f //x=2.6 \
 //y=5.38 //x2=2.82 //y2=6.2
cc_128 ( N_noxref_1_c_49_p N_B_M10_noxref_g ) capacitor c=0.0178506f //x=2.6 \
 //y=5.56 //x2=2.82 //y2=6.2
cc_129 ( N_noxref_1_c_1_p N_B_c_1121_n ) capacitor c=0.00120406f //x=2.64 \
 //y=1.18 //x2=2.375 //y2=1.085
cc_130 ( N_noxref_1_M1_noxref_d N_B_c_1121_n ) capacitor c=0.00137165f \
 //x=2.45 //y=1.085 //x2=2.375 //y2=1.085
cc_131 ( N_noxref_1_c_10_p N_B_c_1123_n ) capacitor c=0.00127432f //x=2.64 \
 //y=1.75 //x2=2.375 //y2=1.43
cc_132 ( N_noxref_1_c_1_p N_B_c_1123_n ) capacitor c=0.00220847f //x=2.64 \
 //y=1.18 //x2=2.375 //y2=1.43
cc_133 ( N_noxref_1_M1_noxref_d N_B_c_1123_n ) capacitor c=0.00237422f \
 //x=2.45 //y=1.085 //x2=2.375 //y2=1.43
cc_134 ( N_noxref_1_c_10_p N_B_c_1126_n ) capacitor c=0.00454577f //x=2.64 \
 //y=1.75 //x2=2.375 //y2=1.74
cc_135 ( N_noxref_1_c_27_p N_B_c_1127_n ) capacitor c=0.00874009f //x=3.08 \
 //y=5.295 //x2=2.745 //y2=4.97
cc_136 ( N_noxref_1_c_46_p N_B_c_1127_n ) capacitor c=0.0020909f //x=2.6 \
 //y=5.38 //x2=2.745 //y2=4.97
cc_137 ( N_noxref_1_c_49_p N_B_c_1127_n ) capacitor c=0.00291714f //x=2.6 \
 //y=5.56 //x2=2.745 //y2=4.97
cc_138 ( N_noxref_1_c_1_p N_B_c_1130_n ) capacitor c=5.50523e-19 //x=2.64 \
 //y=1.18 //x2=2.75 //y2=0.93
cc_139 ( N_noxref_1_M1_noxref_d N_B_c_1130_n ) capacitor c=0.0020782f //x=2.45 \
 //y=1.085 //x2=2.75 //y2=0.93
cc_140 ( N_noxref_1_c_10_p N_B_c_1132_n ) capacitor c=0.00912818f //x=2.64 \
 //y=1.75 //x2=2.75 //y2=1.585
cc_141 ( N_noxref_1_c_17_p N_B_c_1132_n ) capacitor c=0.00194324f //x=2.995 \
 //y=1.835 //x2=2.75 //y2=1.585
cc_142 ( N_noxref_1_c_1_p N_B_c_1132_n ) capacitor c=5.67071e-19 //x=2.64 \
 //y=1.18 //x2=2.75 //y2=1.585
cc_143 ( N_noxref_1_M1_noxref_d N_B_c_1132_n ) capacitor c=0.00356097f \
 //x=2.45 //y=1.085 //x2=2.75 //y2=1.585
cc_144 ( N_noxref_1_c_1_p N_B_c_1136_n ) capacitor c=0.0010954f //x=2.64 \
 //y=1.18 //x2=2.905 //y2=1.085
cc_145 ( N_noxref_1_M1_noxref_d N_B_c_1136_n ) capacitor c=8.50095e-19 \
 //x=2.45 //y=1.085 //x2=2.905 //y2=1.085
cc_146 ( N_noxref_1_c_10_p N_B_c_1138_n ) capacitor c=0.00305472f //x=2.64 \
 //y=1.75 //x2=2.905 //y2=1.43
cc_147 ( N_noxref_1_c_17_p N_B_c_1138_n ) capacitor c=0.00323005f //x=2.995 \
 //y=1.835 //x2=2.905 //y2=1.43
cc_148 ( N_noxref_1_c_1_p N_B_c_1138_n ) capacitor c=0.00314842f //x=2.64 \
 //y=1.18 //x2=2.905 //y2=1.43
cc_149 ( N_noxref_1_M1_noxref_d N_B_c_1138_n ) capacitor c=0.00237422f \
 //x=2.45 //y=1.085 //x2=2.905 //y2=1.43
cc_150 ( N_noxref_1_c_25_p N_B_c_1142_n ) capacitor c=0.00285392f //x=3.08 \
 //y=2.605 //x2=2.34 //y2=2.26
cc_151 ( N_noxref_1_c_10_p N_B_c_1143_n ) capacitor c=0.00371023f //x=2.64 \
 //y=1.75 //x2=2.34 //y2=2.095
cc_152 ( N_noxref_1_c_25_p N_B_c_1143_n ) capacitor c=0.00341496f //x=3.08 \
 //y=2.605 //x2=2.34 //y2=2.095
cc_153 ( N_noxref_1_c_43_p N_B_c_1145_n ) capacitor c=9.8107e-19 //x=2.485 \
 //y=5.38 //x2=2.37 //y2=4.88
cc_154 ( N_noxref_1_c_27_p N_B_c_1145_n ) capacitor c=0.00142201f //x=3.08 \
 //y=5.295 //x2=2.37 //y2=4.88
cc_155 ( N_noxref_1_c_18_p N_noxref_7_c_1208_n ) capacitor c=4.98604e-19 \
 //x=4.93 //y=2.925 //x2=5.37 //y2=5.39
cc_156 ( N_noxref_1_c_71_p N_noxref_7_c_1208_n ) capacitor c=0.0078395f \
 //x=4.775 //y=4.885 //x2=5.37 //y2=5.39
cc_157 ( N_noxref_1_c_29_p N_noxref_7_c_1208_n ) capacitor c=0.00104675f \
 //x=4.775 //y=4.885 //x2=5.37 //y2=5.39
cc_158 ( N_noxref_1_M11_noxref_g N_noxref_7_c_1208_n ) capacitor c=0.00996264f \
 //x=4.83 //y=6.205 //x2=5.37 //y2=5.39
cc_159 ( N_noxref_1_M12_noxref_g N_noxref_7_c_1208_n ) capacitor c=0.00967241f \
 //x=5.27 //y=6.205 //x2=5.37 //y2=5.39
cc_160 ( N_noxref_1_c_95_p N_noxref_7_c_1208_n ) capacitor c=0.00189947f \
 //x=5.195 //y=4.975 //x2=5.37 //y2=5.39
cc_161 ( N_noxref_1_c_30_p N_noxref_7_c_1214_n ) capacitor c=0.00408808f \
 //x=2.995 //y=5.38 //x2=4.61 //y2=5.39
cc_162 ( N_noxref_1_c_46_p N_noxref_7_c_1214_n ) capacitor c=0.00518363f \
 //x=2.6 //y=5.38 //x2=4.61 //y2=5.39
cc_163 ( N_noxref_1_c_47_p N_noxref_7_c_1214_n ) capacitor c=3.28075e-19 \
 //x=2.6 //y=5.56 //x2=4.61 //y2=5.39
cc_164 ( N_noxref_1_c_71_p N_noxref_7_c_1214_n ) capacitor c=0.0243045f \
 //x=4.775 //y=4.885 //x2=4.61 //y2=5.39
cc_165 ( N_noxref_1_c_29_p N_noxref_7_c_1214_n ) capacitor c=0.00565356f \
 //x=4.775 //y=4.885 //x2=4.61 //y2=5.39
cc_166 ( N_noxref_1_M11_noxref_g N_noxref_7_c_1214_n ) capacitor c=0.00403872f \
 //x=4.83 //y=6.205 //x2=4.61 //y2=5.39
cc_167 ( N_noxref_1_c_76_p N_noxref_7_c_1214_n ) capacitor c=9.12041e-19 \
 //x=4.775 //y=4.885 //x2=4.61 //y2=5.39
cc_168 ( N_noxref_1_M12_noxref_g N_noxref_7_c_1221_n ) capacitor c=0.0018094f \
 //x=5.27 //y=6.205 //x2=5.49 //y2=5.39
cc_169 ( N_noxref_1_M12_noxref_g N_noxref_7_c_1222_n ) capacitor c=0.00180782f \
 //x=5.27 //y=6.205 //x2=5.49 //y2=6.92
cc_170 ( N_noxref_1_c_71_p N_noxref_7_c_1223_n ) capacitor c=0.00154424f \
 //x=4.775 //y=4.885 //x2=4.61 //y2=5.56
cc_171 ( N_noxref_1_c_29_p N_noxref_7_c_1223_n ) capacitor c=0.00126834f \
 //x=4.775 //y=4.885 //x2=4.61 //y2=5.56
cc_172 ( N_noxref_1_M11_noxref_g N_noxref_7_c_1223_n ) capacitor c=0.0483843f \
 //x=4.83 //y=6.205 //x2=4.61 //y2=5.56
cc_173 ( N_noxref_1_c_76_p N_noxref_7_c_1223_n ) capacitor c=0.00297041f \
 //x=4.775 //y=4.885 //x2=4.61 //y2=5.56
cc_174 ( N_noxref_1_M12_noxref_g N_noxref_7_c_1227_n ) capacitor c=0.0170175f \
 //x=5.27 //y=6.205 //x2=5.49 //y2=5.56
cc_175 ( N_noxref_1_M11_noxref_g N_noxref_7_M11_noxref_s ) capacitor \
 c=0.00378422f //x=4.83 //y=6.205 //x2=4.475 //y2=5.205
cc_176 ( N_noxref_1_c_25_p C ) capacitor c=6.5122e-19 //x=3.08 //y=2.605 \
 //x2=5.67 //y2=2.4
cc_177 ( N_noxref_1_c_27_p C ) capacitor c=0.00351523f //x=3.08 //y=5.295 \
 //x2=5.67 //y2=2.4
cc_178 ( N_noxref_1_c_26_p C ) capacitor c=0.00863767f //x=4.93 //y=2.605 \
 //x2=5.67 //y2=2.4
cc_179 ( N_noxref_1_c_18_p C ) capacitor c=0.0146933f //x=4.93 //y=2.925 \
 //x2=5.67 //y2=2.4
cc_180 ( N_noxref_1_c_28_p C ) capacitor c=0.0473875f //x=4.93 //y=4.765 \
 //x2=5.67 //y2=2.4
cc_181 ( N_noxref_1_c_31_p C ) capacitor c=5.57251e-19 //x=4.93 //y=2.77 \
 //x2=5.67 //y2=2.4
cc_182 ( N_noxref_1_c_20_p C ) capacitor c=0.00359337f //x=4.925 //y=2.765 \
 //x2=5.67 //y2=2.4
cc_183 ( N_noxref_1_c_3_p C ) capacitor c=2.61947e-19 //x=4.93 //y=2.26 \
 //x2=5.67 //y2=2.4
cc_184 ( N_noxref_1_c_2_p N_C_c_1310_n ) capacitor c=0.0217252f //x=4.93 \
 //y=2.26 //x2=5.67 //y2=2.26
cc_185 ( N_noxref_1_c_3_p N_C_c_1310_n ) capacitor c=5.41079e-19 //x=4.93 \
 //y=2.26 //x2=5.67 //y2=2.26
cc_186 ( N_noxref_1_c_13_p N_C_c_1310_n ) capacitor c=0.00178181f //x=4.735 \
 //y=2.095 //x2=5.67 //y2=2.26
cc_187 ( N_noxref_1_c_71_p N_C_c_1313_n ) capacitor c=0.0486063f //x=4.775 \
 //y=4.885 //x2=5.705 //y2=4.885
cc_188 ( N_noxref_1_c_29_p N_C_c_1313_n ) capacitor c=0.00105182f //x=4.775 \
 //y=4.885 //x2=5.705 //y2=4.885
cc_189 ( N_noxref_1_c_95_p N_C_c_1313_n ) capacitor c=0.00107587f //x=5.195 \
 //y=4.975 //x2=5.705 //y2=4.885
cc_190 ( N_noxref_1_c_26_p N_C_c_1316_n ) capacitor c=2.61947e-19 //x=4.93 \
 //y=2.605 //x2=5.67 //y2=2.26
cc_191 ( N_noxref_1_c_2_p N_C_c_1316_n ) capacitor c=5.24865e-19 //x=4.93 \
 //y=2.26 //x2=5.67 //y2=2.26
cc_192 ( N_noxref_1_c_3_p N_C_c_1316_n ) capacitor c=0.00525888f //x=4.93 \
 //y=2.26 //x2=5.67 //y2=2.26
cc_193 ( N_noxref_1_c_13_p N_C_c_1316_n ) capacitor c=0.00190888f //x=4.735 \
 //y=2.095 //x2=5.67 //y2=2.26
cc_194 ( N_noxref_1_c_71_p N_C_c_1320_n ) capacitor c=4.32488e-19 //x=4.775 \
 //y=4.885 //x2=5.705 //y2=4.885
cc_195 ( N_noxref_1_c_29_p N_C_c_1320_n ) capacitor c=0.00242589f //x=4.775 \
 //y=4.885 //x2=5.705 //y2=4.885
cc_196 ( N_noxref_1_c_95_p N_C_c_1320_n ) capacitor c=0.00116837f //x=5.195 \
 //y=4.975 //x2=5.705 //y2=4.885
cc_197 ( N_noxref_1_c_76_p N_C_c_1320_n ) capacitor c=0.00121814f //x=4.775 \
 //y=4.885 //x2=5.705 //y2=4.885
cc_198 ( N_noxref_1_M11_noxref_g N_C_M13_noxref_g ) capacitor c=0.0101077f \
 //x=4.83 //y=6.205 //x2=5.71 //y2=6.205
cc_199 ( N_noxref_1_M12_noxref_g N_C_M13_noxref_g ) capacitor c=0.109254f \
 //x=5.27 //y=6.205 //x2=5.71 //y2=6.205
cc_200 ( N_noxref_1_M12_noxref_g N_C_M14_noxref_g ) capacitor c=0.00945018f \
 //x=5.27 //y=6.205 //x2=6.15 //y2=6.205
cc_201 ( N_noxref_1_c_4_p N_C_c_1327_n ) capacitor c=0.00125788f //x=4.735 \
 //y=1.085 //x2=5.705 //y2=1.085
cc_202 ( N_noxref_1_c_8_p N_C_c_1327_n ) capacitor c=0.0126654f //x=5.265 \
 //y=1.085 //x2=5.705 //y2=1.085
cc_203 ( N_noxref_1_c_5_p N_C_c_1329_n ) capacitor c=0.00149727f //x=4.735 \
 //y=1.43 //x2=5.705 //y2=1.435
cc_204 ( N_noxref_1_c_12_p N_C_c_1329_n ) capacitor c=0.00111802f //x=4.735 \
 //y=1.74 //x2=5.705 //y2=1.435
cc_205 ( N_noxref_1_c_9_p N_C_c_1329_n ) capacitor c=0.0126654f //x=5.265 \
 //y=1.43 //x2=5.705 //y2=1.435
cc_206 ( N_noxref_1_c_12_p N_C_c_1332_n ) capacitor c=0.00116305f //x=4.735 \
 //y=1.74 //x2=5.705 //y2=1.74
cc_207 ( N_noxref_1_c_9_p N_C_c_1332_n ) capacitor c=0.00938322f //x=5.265 \
 //y=1.43 //x2=5.705 //y2=1.74
cc_208 ( N_noxref_1_c_9_p N_C_c_1334_n ) capacitor c=0.00131492f //x=5.265 \
 //y=1.43 //x2=6.08 //y2=1.585
cc_209 ( N_noxref_1_c_8_p N_C_c_1335_n ) capacitor c=0.00132934f //x=5.265 \
 //y=1.085 //x2=6.235 //y2=1.085
cc_210 ( N_noxref_1_c_9_p N_C_c_1336_n ) capacitor c=0.00151998f //x=5.265 \
 //y=1.43 //x2=6.235 //y2=1.435
cc_211 ( N_noxref_1_c_2_p N_C_c_1337_n ) capacitor c=0.00173144f //x=4.93 \
 //y=2.26 //x2=5.67 //y2=2.26
cc_212 ( N_noxref_1_c_3_p N_C_c_1337_n ) capacitor c=0.0018937f //x=4.93 \
 //y=2.26 //x2=5.67 //y2=2.26
cc_213 ( N_noxref_1_c_13_p N_C_c_1337_n ) capacitor c=0.0181449f //x=4.735 \
 //y=2.095 //x2=5.67 //y2=2.26
cc_214 ( N_noxref_1_c_13_p N_C_c_1340_n ) capacitor c=0.00636965f //x=4.735 \
 //y=2.095 //x2=5.67 //y2=2.095
cc_215 ( N_noxref_1_c_28_p N_C_c_1341_n ) capacitor c=0.00117265f //x=4.93 \
 //y=4.765 //x2=5.705 //y2=4.885
cc_216 ( N_noxref_1_c_71_p N_C_c_1341_n ) capacitor c=4.8456e-19 //x=4.775 \
 //y=4.885 //x2=5.705 //y2=4.885
cc_217 ( N_noxref_1_c_29_p N_C_c_1341_n ) capacitor c=0.00211373f //x=4.775 \
 //y=4.885 //x2=5.705 //y2=4.885
cc_218 ( N_noxref_1_c_95_p N_C_c_1341_n ) capacitor c=0.0203928f //x=5.195 \
 //y=4.975 //x2=5.705 //y2=4.885
cc_219 ( N_noxref_1_c_76_p N_C_c_1341_n ) capacitor c=0.00590438f //x=4.775 \
 //y=4.885 //x2=5.705 //y2=4.885
cc_220 ( N_noxref_1_c_17_p N_GND_c_1421_n ) capacitor c=0.00654514f //x=2.995 \
 //y=1.835 //x2=8.245 //y2=0.175
cc_221 ( N_noxref_1_c_110_p N_GND_c_1421_n ) capacitor c=5.98934e-19 //x=3.08 \
 //y=2.925 //x2=8.245 //y2=0.175
cc_222 ( N_noxref_1_c_18_p N_GND_c_1421_n ) capacitor c=3.68809e-19 //x=4.93 \
 //y=2.925 //x2=8.245 //y2=0.175
cc_223 ( N_noxref_1_c_1_p N_GND_c_1421_n ) capacitor c=0.00964814f //x=2.64 \
 //y=1.18 //x2=8.245 //y2=0.175
cc_224 ( N_noxref_1_c_2_p N_GND_c_1421_n ) capacitor c=8.84449e-19 //x=4.93 \
 //y=2.26 //x2=8.245 //y2=0.175
cc_225 ( N_noxref_1_M1_noxref_d N_GND_c_1421_n ) capacitor c=3.01769e-19 \
 //x=2.45 //y=1.085 //x2=8.245 //y2=0.175
cc_226 ( N_noxref_1_c_45_p N_GND_c_1427_n ) capacitor c=9.64357e-19 //x=1.72 \
 //y=5.56 //x2=1.67 //y2=1.135
cc_227 ( N_noxref_1_c_1_p N_GND_c_1427_n ) capacitor c=0.0141894f //x=2.64 \
 //y=1.18 //x2=1.67 //y2=1.135
cc_228 ( N_noxref_1_M1_noxref_d N_GND_c_1427_n ) capacitor c=2.93544e-19 \
 //x=2.45 //y=1.085 //x2=1.67 //y2=1.135
cc_229 ( N_noxref_1_c_17_p N_GND_c_1430_n ) capacitor c=7.75992e-19 //x=2.995 \
 //y=1.835 //x2=3.65 //y2=0.175
cc_230 ( N_noxref_1_c_110_p N_GND_c_1430_n ) capacitor c=4.78725e-19 //x=3.08 \
 //y=2.925 //x2=3.65 //y2=0.175
cc_231 ( N_noxref_1_c_25_p N_GND_c_1432_n ) capacitor c=0.00139243f //x=3.08 \
 //y=2.605 //x2=1.23 //y2=0.18
cc_232 ( N_noxref_1_c_90_p N_GND_c_1432_n ) capacitor c=0.00133432f //x=3.08 \
 //y=2.77 //x2=1.23 //y2=0.18
cc_233 ( N_noxref_1_c_18_p N_GND_c_1434_n ) capacitor c=9.54331e-19 //x=4.93 \
 //y=2.925 //x2=5.4 //y2=0.71
cc_234 ( N_noxref_1_c_2_p N_GND_c_1434_n ) capacitor c=0.0010437f //x=4.93 \
 //y=2.26 //x2=5.4 //y2=0.71
cc_235 ( N_noxref_1_c_3_p N_GND_c_1434_n ) capacitor c=6.77674e-19 //x=4.93 \
 //y=2.26 //x2=5.4 //y2=0.71
cc_236 ( N_noxref_1_c_4_p N_GND_c_1434_n ) capacitor c=0.0211758f //x=4.735 \
 //y=1.085 //x2=5.4 //y2=0.71
cc_237 ( N_noxref_1_c_13_p N_GND_c_1434_n ) capacitor c=2.1838e-19 //x=4.735 \
 //y=2.095 //x2=5.4 //y2=0.71
cc_238 ( N_noxref_1_c_8_p N_GND_c_1434_n ) capacitor c=0.00805599f //x=5.265 \
 //y=1.085 //x2=5.4 //y2=0.71
cc_239 ( N_noxref_1_c_10_p N_GND_c_1440_n ) capacitor c=0.00271975f //x=2.64 \
 //y=1.75 //x2=3.82 //y2=0.175
cc_240 ( N_noxref_1_c_17_p N_GND_c_1440_n ) capacitor c=0.021518f //x=2.995 \
 //y=1.835 //x2=3.82 //y2=0.175
cc_241 ( N_noxref_1_c_110_p N_GND_c_1440_n ) capacitor c=0.00429364f //x=3.08 \
 //y=2.925 //x2=3.82 //y2=0.175
cc_242 ( N_noxref_1_c_26_p N_GND_c_1440_n ) capacitor c=0.00325281f //x=4.93 \
 //y=2.605 //x2=3.82 //y2=0.175
cc_243 ( N_noxref_1_c_18_p N_GND_c_1440_n ) capacitor c=0.00311747f //x=4.93 \
 //y=2.925 //x2=3.82 //y2=0.175
cc_244 ( N_noxref_1_c_90_p N_GND_c_1440_n ) capacitor c=0.0101726f //x=3.08 \
 //y=2.77 //x2=3.82 //y2=0.175
cc_245 ( N_noxref_1_c_31_p N_GND_c_1440_n ) capacitor c=0.00513832f //x=4.93 \
 //y=2.77 //x2=3.82 //y2=0.175
cc_246 ( N_noxref_1_c_2_p N_GND_c_1440_n ) capacitor c=0.00446799f //x=4.93 \
 //y=2.26 //x2=3.82 //y2=0.175
cc_247 ( N_noxref_1_c_72_p N_GND_c_1440_n ) capacitor c=0.0239533f //x=4.765 \
 //y=2.765 //x2=3.82 //y2=0.175
cc_248 ( N_noxref_1_c_3_p N_GND_c_1440_n ) capacitor c=0.00369203f //x=4.93 \
 //y=2.26 //x2=3.82 //y2=0.175
cc_249 ( N_noxref_1_c_13_p N_GND_c_1440_n ) capacitor c=0.0101725f //x=4.735 \
 //y=2.095 //x2=3.82 //y2=0.175
cc_250 ( N_noxref_1_c_1_p N_GND_c_1451_n ) capacitor c=2.83275e-19 //x=2.64 \
 //y=1.18 //x2=12.08 //y2=0.175
cc_251 ( N_noxref_1_c_1_p N_GND_M0_noxref_d ) capacitor c=2.82748e-19 //x=2.64 \
 //y=1.18 //x2=1.48 //y2=1.045
cc_252 ( N_noxref_1_c_72_p N_GND_M2_noxref_s ) capacitor c=0.00355168f \
 //x=4.765 //y=2.765 //x2=4.38 //y2=0.545
cc_253 ( N_noxref_1_c_4_p N_GND_M2_noxref_s ) capacitor c=0.0329097f //x=4.735 \
 //y=1.085 //x2=4.38 //y2=0.545
cc_254 ( N_noxref_1_c_8_p N_GND_M2_noxref_s ) capacitor c=0.00605785f \
 //x=5.265 //y=1.085 //x2=4.38 //y2=0.545
cc_255 ( N_noxref_1_c_9_p N_GND_M2_noxref_s ) capacitor c=0.00120103f \
 //x=5.265 //y=1.43 //x2=4.38 //y2=0.545
cc_256 ( N_noxref_1_c_256_p N_noxref_12_c_1888_n ) capacitor c=0.0103386f \
 //x=2.725 //y=1.835 //x2=2.155 //y2=1.675
cc_257 ( N_noxref_1_c_17_p N_noxref_12_c_1889_n ) capacitor c=0.00373013f \
 //x=2.995 //y=1.835 //x2=3.04 //y2=0.71
cc_258 ( N_noxref_1_c_1_p N_noxref_12_c_1889_n ) capacitor c=0.00367971f \
 //x=2.64 //y=1.18 //x2=3.04 //y2=0.71
cc_259 ( N_noxref_1_M1_noxref_d N_noxref_12_c_1889_n ) capacitor c=0.00910163f \
 //x=2.45 //y=1.085 //x2=3.04 //y2=0.71
cc_260 ( N_noxref_1_c_10_p N_noxref_12_M0_noxref_s ) capacitor c=0.0173667f \
 //x=2.64 //y=1.75 //x2=1.05 //y2=0.545
cc_261 ( N_noxref_1_c_17_p N_noxref_12_M0_noxref_s ) capacitor c=0.0055349f \
 //x=2.995 //y=1.835 //x2=1.05 //y2=0.545
cc_262 ( N_noxref_1_c_110_p N_noxref_12_M0_noxref_s ) capacitor c=7.90116e-19 \
 //x=3.08 //y=2.925 //x2=1.05 //y2=0.545
cc_263 ( N_noxref_1_c_1_p N_noxref_12_M0_noxref_s ) capacitor c=0.00907053f \
 //x=2.64 //y=1.18 //x2=1.05 //y2=0.545
cc_264 ( N_noxref_1_c_90_p N_noxref_12_M0_noxref_s ) capacitor c=0.00202552f \
 //x=3.08 //y=2.77 //x2=1.05 //y2=0.545
cc_265 ( N_noxref_1_M1_noxref_d N_noxref_12_M0_noxref_s ) capacitor \
 c=0.0275552f //x=2.45 //y=1.085 //x2=1.05 //y2=0.545
cc_266 ( N_noxref_2_M16_noxref_g N_noxref_3_c_538_n ) capacitor c=0.0129249f \
 //x=8.6 //y=6.2 //x2=9.145 //y2=5.38
cc_267 ( N_noxref_2_c_275_n N_noxref_3_c_539_n ) capacitor c=5.51079e-19 //x=5 \
 //y=1.75 //x2=9.3 //y2=1.75
cc_268 ( N_noxref_2_c_288_n N_noxref_3_c_539_n ) capacitor c=0.00311198f \
 //x=5.97 //y=1.75 //x2=9.3 //y2=1.75
cc_269 ( N_noxref_2_c_311_p N_noxref_3_c_541_n ) capacitor c=0.00242359f \
 //x=6.325 //y=1.835 //x2=9.385 //y2=1.835
cc_270 ( N_noxref_2_c_290_n N_noxref_3_c_542_n ) capacitor c=0.00204244f \
 //x=6.41 //y=2.605 //x2=9.74 //y2=2.605
cc_271 ( N_noxref_2_c_313_p N_noxref_3_c_542_n ) capacitor c=0.00100721f \
 //x=8.26 //y=2.605 //x2=9.74 //y2=2.605
cc_272 ( N_noxref_2_c_292_n N_noxref_3_c_544_n ) capacitor c=0.0028169f \
 //x=6.41 //y=5.305 //x2=9.74 //y2=5.295
cc_273 ( N_noxref_2_c_315_p N_noxref_3_c_544_n ) capacitor c=0.00450609f \
 //x=8.262 //y=4.74 //x2=9.74 //y2=5.295
cc_274 ( N_noxref_2_c_292_n N_noxref_3_c_546_n ) capacitor c=9.75602e-19 \
 //x=6.41 //y=5.305 //x2=8.38 //y2=5.56
cc_275 ( N_noxref_2_c_317_p N_noxref_3_c_546_n ) capacitor c=3.53224e-19 \
 //x=8.26 //y=2.925 //x2=8.38 //y2=5.56
cc_276 ( N_noxref_2_c_295_n N_noxref_3_c_546_n ) capacitor c=4.93096e-19 \
 //x=5.925 //y=5.39 //x2=8.38 //y2=5.56
cc_277 ( N_noxref_2_c_319_p N_noxref_3_c_546_n ) capacitor c=0.0118546f \
 //x=8.26 //y=4.88 //x2=8.38 //y2=5.56
cc_278 ( N_noxref_2_c_320_p N_noxref_3_c_546_n ) capacitor c=0.00277154f \
 //x=8.26 //y=4.88 //x2=8.38 //y2=5.56
cc_279 ( N_noxref_2_M15_noxref_g N_noxref_3_c_546_n ) capacitor c=0.00201806f \
 //x=8.16 //y=6.2 //x2=8.38 //y2=5.56
cc_280 ( N_noxref_2_M16_noxref_g N_noxref_3_c_546_n ) capacitor c=0.00192712f \
 //x=8.6 //y=6.2 //x2=8.38 //y2=5.56
cc_281 ( N_noxref_2_c_323_p N_noxref_3_c_546_n ) capacitor c=0.00201727f \
 //x=8.26 //y=4.88 //x2=8.38 //y2=5.56
cc_282 ( N_noxref_2_c_324_p N_noxref_3_c_554_n ) capacitor c=6.90042e-19 \
 //x=5.97 //y=1.3 //x2=9.3 //y2=1.18
cc_283 ( N_noxref_2_c_325_p N_noxref_3_c_555_n ) capacitor c=0.00251935f \
 //x=8.26 //y=2.77 //x2=9.74 //y2=2.77
cc_284 ( N_noxref_2_c_326_p N_noxref_3_c_556_n ) capacitor c=0.00532714f \
 //x=8.25 //y=2.765 //x2=9.9 //y2=2.765
cc_285 ( N_noxref_2_c_319_p N_noxref_3_c_557_n ) capacitor c=0.00104426f \
 //x=8.26 //y=4.88 //x2=8.38 //y2=5.56
cc_286 ( N_noxref_2_c_320_p N_noxref_3_c_557_n ) capacitor c=0.00377369f \
 //x=8.26 //y=4.88 //x2=8.38 //y2=5.56
cc_287 ( N_noxref_2_M15_noxref_g N_noxref_3_c_557_n ) capacitor c=0.0158358f \
 //x=8.16 //y=6.2 //x2=8.38 //y2=5.56
cc_288 ( N_noxref_2_M16_noxref_g N_noxref_3_c_557_n ) capacitor c=0.0178987f \
 //x=8.6 //y=6.2 //x2=8.38 //y2=5.56
cc_289 ( N_noxref_2_c_323_p N_noxref_3_c_557_n ) capacitor c=0.0043218f \
 //x=8.26 //y=4.88 //x2=8.38 //y2=5.56
cc_290 ( N_noxref_2_c_332_p N_VDD_c_822_n ) capacitor c=2.90144e-19 //x=6.325 \
 //y=5.39 //x2=11.96 //y2=7.58
cc_291 ( N_noxref_2_c_319_p N_VDD_c_822_n ) capacitor c=9.07241e-19 //x=8.26 \
 //y=4.88 //x2=11.96 //y2=7.58
cc_292 ( N_noxref_2_c_320_p N_VDD_c_822_n ) capacitor c=6.22888e-19 //x=8.26 \
 //y=4.88 //x2=11.96 //y2=7.58
cc_293 ( N_noxref_2_c_332_p N_VDD_c_788_n ) capacitor c=0.00153182f //x=6.325 \
 //y=5.39 //x2=6.98 //y2=7.585
cc_294 ( N_noxref_2_c_336_p N_VDD_c_788_n ) capacitor c=0.00513429f //x=5.93 \
 //y=5.56 //x2=6.98 //y2=7.585
cc_295 ( N_noxref_2_c_319_p N_VDD_c_827_n ) capacitor c=6.28113e-19 //x=8.26 \
 //y=4.88 //x2=8.735 //y2=7.585
cc_296 ( N_noxref_2_M15_noxref_g N_VDD_c_827_n ) capacitor c=0.00732618f \
 //x=8.16 //y=6.2 //x2=8.735 //y2=7.585
cc_297 ( N_noxref_2_M16_noxref_g N_VDD_c_827_n ) capacitor c=0.00755544f \
 //x=8.6 //y=6.2 //x2=8.735 //y2=7.585
cc_298 ( N_noxref_2_c_292_n N_VDD_c_793_n ) capacitor c=0.00125992f //x=6.41 \
 //y=5.305 //x2=3.82 //y2=7.585
cc_299 ( N_noxref_2_c_292_n N_VDD_c_803_n ) capacitor c=0.030593f //x=6.41 \
 //y=5.305 //x2=7.15 //y2=7.585
cc_300 ( N_noxref_2_c_295_n N_VDD_c_803_n ) capacitor c=0.00270468f //x=5.925 \
 //y=5.39 //x2=7.15 //y2=7.585
cc_301 ( N_noxref_2_c_319_p N_VDD_c_803_n ) capacitor c=0.00447349f //x=8.26 \
 //y=4.88 //x2=7.15 //y2=7.585
cc_302 ( N_noxref_2_c_315_p N_VDD_c_803_n ) capacitor c=0.00733791f //x=8.262 \
 //y=4.74 //x2=7.15 //y2=7.585
cc_303 ( N_noxref_2_c_345_p N_VDD_c_803_n ) capacitor c=0.00260419f //x=8.09 \
 //y=2.765 //x2=7.15 //y2=7.585
cc_304 ( N_noxref_2_c_336_p N_VDD_c_803_n ) capacitor c=0.0092106f //x=5.93 \
 //y=5.56 //x2=7.15 //y2=7.585
cc_305 ( N_noxref_2_c_320_p N_VDD_c_803_n ) capacitor c=0.00370495f //x=8.26 \
 //y=4.88 //x2=7.15 //y2=7.585
cc_306 ( N_noxref_2_c_323_p N_VDD_c_803_n ) capacitor c=0.01355f //x=8.26 \
 //y=4.88 //x2=7.15 //y2=7.585
cc_307 ( N_noxref_2_c_336_p N_VDD_c_804_n ) capacitor c=2.32853e-19 //x=5.93 \
 //y=5.56 //x2=11.96 //y2=7.58
cc_308 ( N_noxref_2_c_336_p N_VDD_M11_noxref_d ) capacitor c=0.00559643f \
 //x=5.93 //y=5.56 //x2=4.905 //y2=5.205
cc_309 ( N_noxref_2_c_332_p N_VDD_M15_noxref_s ) capacitor c=0.00364f \
 //x=6.325 //y=5.39 //x2=7.805 //y2=5.2
cc_310 ( N_noxref_2_c_317_p N_VDD_M15_noxref_s ) capacitor c=7.58516e-19 \
 //x=8.26 //y=2.925 //x2=7.805 //y2=5.2
cc_311 ( N_noxref_2_c_295_n N_VDD_M15_noxref_s ) capacitor c=0.00513745f \
 //x=5.925 //y=5.39 //x2=7.805 //y2=5.2
cc_312 ( N_noxref_2_M15_noxref_g N_VDD_M15_noxref_s ) capacitor c=0.0567929f \
 //x=8.16 //y=6.2 //x2=7.805 //y2=5.2
cc_313 ( N_noxref_2_M16_noxref_g N_VDD_M16_noxref_d ) capacitor c=0.015318f \
 //x=8.6 //y=6.2 //x2=8.675 //y2=5.2
cc_314 ( N_noxref_2_c_266_n N_noxref_7_c_1208_n ) capacitor c=2.9249e-19 //x=5 \
 //y=1.305 //x2=5.37 //y2=5.39
cc_315 ( N_noxref_2_c_282_n N_noxref_7_c_1208_n ) capacitor c=0.00265501f \
 //x=5.085 //y=1.835 //x2=5.37 //y2=5.39
cc_316 ( N_noxref_2_c_332_p N_noxref_7_c_1231_n ) capacitor c=0.00301289f \
 //x=6.325 //y=5.39 //x2=6.24 //y2=7.09
cc_317 ( N_noxref_2_c_295_n N_noxref_7_c_1231_n ) capacitor c=0.00513934f \
 //x=5.925 //y=5.39 //x2=6.24 //y2=7.09
cc_318 ( N_noxref_2_c_336_p N_noxref_7_c_1231_n ) capacitor c=0.00406191f \
 //x=5.93 //y=5.56 //x2=6.24 //y2=7.09
cc_319 ( N_noxref_2_c_295_n N_noxref_7_c_1214_n ) capacitor c=6.34305e-19 \
 //x=5.925 //y=5.39 //x2=4.61 //y2=5.39
cc_320 ( N_noxref_2_c_281_n N_noxref_7_c_1221_n ) capacitor c=0.00291215f \
 //x=5.885 //y=1.835 //x2=5.49 //y2=5.39
cc_321 ( N_noxref_2_c_295_n N_noxref_7_c_1221_n ) capacitor c=0.0514662f \
 //x=5.925 //y=5.39 //x2=5.49 //y2=5.39
cc_322 ( N_noxref_2_c_336_p N_noxref_7_c_1221_n ) capacitor c=0.00398527f \
 //x=5.93 //y=5.56 //x2=5.49 //y2=5.39
cc_323 ( N_noxref_2_c_332_p N_noxref_7_c_1238_n ) capacitor c=0.0056963f \
 //x=6.325 //y=5.39 //x2=6.37 //y2=6.92
cc_324 ( N_noxref_2_c_295_n N_noxref_7_c_1227_n ) capacitor c=0.00275395f \
 //x=5.925 //y=5.39 //x2=5.49 //y2=5.56
cc_325 ( N_noxref_2_c_336_p N_noxref_7_c_1227_n ) capacitor c=0.0683237f \
 //x=5.93 //y=5.56 //x2=5.49 //y2=5.56
cc_326 ( N_noxref_2_c_332_p N_noxref_7_M14_noxref_d ) capacitor c=0.00855426f \
 //x=6.325 //y=5.39 //x2=6.225 //y2=5.205
cc_327 ( N_noxref_2_c_296_n N_noxref_7_M14_noxref_d ) capacitor c=6.7951e-19 \
 //x=6.41 //y=2.77 //x2=6.225 //y2=5.205
cc_328 ( N_noxref_2_c_336_p N_noxref_7_M14_noxref_d ) capacitor c=0.047732f \
 //x=5.93 //y=5.56 //x2=6.225 //y2=5.205
cc_329 ( N_noxref_2_c_290_n C ) capacitor c=0.00866339f //x=6.41 //y=2.605 \
 //x2=5.67 //y2=2.4
cc_330 ( N_noxref_2_c_372_p C ) capacitor c=0.0150092f //x=6.41 //y=2.925 \
 //x2=5.67 //y2=2.4
cc_331 ( N_noxref_2_c_292_n C ) capacitor c=0.0839355f //x=6.41 //y=5.305 \
 //x2=5.67 //y2=2.4
cc_332 ( N_noxref_2_c_313_p C ) capacitor c=6.23212e-19 //x=8.26 //y=2.605 \
 //x2=5.67 //y2=2.4
cc_333 ( N_noxref_2_c_296_n C ) capacitor c=5.57251e-19 //x=6.41 //y=2.77 \
 //x2=5.67 //y2=2.4
cc_334 ( N_noxref_2_c_315_p C ) capacitor c=0.00289475f //x=8.262 //y=4.74 \
 //x2=5.67 //y2=2.4
cc_335 ( N_noxref_2_c_297_n C ) capacitor c=0.00361658f //x=6.565 //y=2.765 \
 //x2=5.67 //y2=2.4
cc_336 ( N_noxref_2_c_281_n N_C_c_1310_n ) capacitor c=0.0306211f //x=5.885 \
 //y=1.835 //x2=5.67 //y2=2.26
cc_337 ( N_noxref_2_c_290_n N_C_c_1310_n ) capacitor c=0.0160491f //x=6.41 \
 //y=2.605 //x2=5.67 //y2=2.26
cc_338 ( N_noxref_2_c_281_n N_C_c_1313_n ) capacitor c=4.30382e-19 //x=5.885 \
 //y=1.835 //x2=5.705 //y2=4.885
cc_339 ( N_noxref_2_c_292_n N_C_c_1313_n ) capacitor c=0.0175188f //x=6.41 \
 //y=5.305 //x2=5.705 //y2=4.885
cc_340 ( N_noxref_2_c_295_n N_C_c_1313_n ) capacitor c=0.00207961f //x=5.925 \
 //y=5.39 //x2=5.705 //y2=4.885
cc_341 ( N_noxref_2_c_281_n N_C_c_1316_n ) capacitor c=0.00491852f //x=5.885 \
 //y=1.835 //x2=5.67 //y2=2.26
cc_342 ( N_noxref_2_c_290_n N_C_c_1316_n ) capacitor c=8.61986e-19 //x=6.41 \
 //y=2.605 //x2=5.67 //y2=2.26
cc_343 ( N_noxref_2_c_292_n N_C_c_1320_n ) capacitor c=0.00342077f //x=6.41 \
 //y=5.305 //x2=5.705 //y2=4.885
cc_344 ( N_noxref_2_c_295_n N_C_M13_noxref_g ) capacitor c=0.00184899f \
 //x=5.925 //y=5.39 //x2=5.71 //y2=6.205
cc_345 ( N_noxref_2_c_336_p N_C_M13_noxref_g ) capacitor c=0.0120591f //x=5.93 \
 //y=5.56 //x2=5.71 //y2=6.205
cc_346 ( N_noxref_2_c_332_p N_C_M14_noxref_g ) capacitor c=0.0110031f \
 //x=6.325 //y=5.39 //x2=6.15 //y2=6.205
cc_347 ( N_noxref_2_c_295_n N_C_M14_noxref_g ) capacitor c=0.0027897f \
 //x=5.925 //y=5.39 //x2=6.15 //y2=6.205
cc_348 ( N_noxref_2_c_336_p N_C_M14_noxref_g ) capacitor c=0.0140704f //x=5.93 \
 //y=5.56 //x2=6.15 //y2=6.205
cc_349 ( N_noxref_2_c_324_p N_C_c_1327_n ) capacitor c=0.00112851f //x=5.97 \
 //y=1.3 //x2=5.705 //y2=1.085
cc_350 ( N_noxref_2_M3_noxref_d N_C_c_1327_n ) capacitor c=0.00218694f \
 //x=5.78 //y=1.085 //x2=5.705 //y2=1.085
cc_351 ( N_noxref_2_c_324_p N_C_c_1329_n ) capacitor c=0.0021447f //x=5.97 \
 //y=1.3 //x2=5.705 //y2=1.435
cc_352 ( N_noxref_2_c_288_n N_C_c_1329_n ) capacitor c=7.7986e-19 //x=5.97 \
 //y=1.75 //x2=5.705 //y2=1.435
cc_353 ( N_noxref_2_M3_noxref_d N_C_c_1329_n ) capacitor c=0.00237422f \
 //x=5.78 //y=1.085 //x2=5.705 //y2=1.435
cc_354 ( N_noxref_2_c_275_n N_C_c_1332_n ) capacitor c=0.00120307f //x=5 \
 //y=1.75 //x2=5.705 //y2=1.74
cc_355 ( N_noxref_2_c_288_n N_C_c_1332_n ) capacitor c=0.00364979f //x=5.97 \
 //y=1.75 //x2=5.705 //y2=1.74
cc_356 ( N_noxref_2_c_292_n N_C_c_1373_n ) capacitor c=0.00852293f //x=6.41 \
 //y=5.305 //x2=6.075 //y2=4.975
cc_357 ( N_noxref_2_c_295_n N_C_c_1373_n ) capacitor c=0.00213157f //x=5.925 \
 //y=5.39 //x2=6.075 //y2=4.975
cc_358 ( N_noxref_2_c_336_p N_C_c_1373_n ) capacitor c=0.00293135f //x=5.93 \
 //y=5.56 //x2=6.075 //y2=4.975
cc_359 ( N_noxref_2_c_324_p N_C_c_1376_n ) capacitor c=5.32053e-19 //x=5.97 \
 //y=1.3 //x2=6.08 //y2=0.93
cc_360 ( N_noxref_2_M3_noxref_d N_C_c_1376_n ) capacitor c=0.00213893f \
 //x=5.78 //y=1.085 //x2=6.08 //y2=0.93
cc_361 ( N_noxref_2_c_324_p N_C_c_1334_n ) capacitor c=5.60411e-19 //x=5.97 \
 //y=1.3 //x2=6.08 //y2=1.585
cc_362 ( N_noxref_2_c_288_n N_C_c_1334_n ) capacitor c=0.00983535f //x=5.97 \
 //y=1.75 //x2=6.08 //y2=1.585
cc_363 ( N_noxref_2_c_311_p N_C_c_1334_n ) capacitor c=0.00500113f //x=6.325 \
 //y=1.835 //x2=6.08 //y2=1.585
cc_364 ( N_noxref_2_M3_noxref_d N_C_c_1334_n ) capacitor c=0.00357974f \
 //x=5.78 //y=1.085 //x2=6.08 //y2=1.585
cc_365 ( N_noxref_2_c_324_p N_C_c_1335_n ) capacitor c=8.06279e-19 //x=5.97 \
 //y=1.3 //x2=6.235 //y2=1.085
cc_366 ( N_noxref_2_M3_noxref_d N_C_c_1335_n ) capacitor c=0.0012513f //x=5.78 \
 //y=1.085 //x2=6.235 //y2=1.085
cc_367 ( N_noxref_2_c_324_p N_C_c_1336_n ) capacitor c=0.00327546f //x=5.97 \
 //y=1.3 //x2=6.235 //y2=1.435
cc_368 ( N_noxref_2_c_288_n N_C_c_1336_n ) capacitor c=0.00126467f //x=5.97 \
 //y=1.75 //x2=6.235 //y2=1.435
cc_369 ( N_noxref_2_M3_noxref_d N_C_c_1336_n ) capacitor c=0.00237422f \
 //x=5.78 //y=1.085 //x2=6.235 //y2=1.435
cc_370 ( N_noxref_2_c_281_n N_C_c_1337_n ) capacitor c=0.00161541f //x=5.885 \
 //y=1.835 //x2=5.67 //y2=2.26
cc_371 ( N_noxref_2_c_290_n N_C_c_1337_n ) capacitor c=0.0028062f //x=6.41 \
 //y=2.605 //x2=5.67 //y2=2.26
cc_372 ( N_noxref_2_c_281_n N_C_c_1340_n ) capacitor c=0.00817459f //x=5.885 \
 //y=1.835 //x2=5.67 //y2=2.095
cc_373 ( N_noxref_2_c_290_n N_C_c_1340_n ) capacitor c=0.00311553f //x=6.41 \
 //y=2.605 //x2=5.67 //y2=2.095
cc_374 ( N_noxref_2_c_292_n N_C_c_1341_n ) capacitor c=0.00141757f //x=6.41 \
 //y=5.305 //x2=5.705 //y2=4.885
cc_375 ( N_noxref_2_c_266_n N_GND_c_1421_n ) capacitor c=0.00996669f //x=5 \
 //y=1.305 //x2=8.245 //y2=0.175
cc_376 ( N_noxref_2_c_281_n N_GND_c_1421_n ) capacitor c=0.00677962f //x=5.885 \
 //y=1.835 //x2=8.245 //y2=0.175
cc_377 ( N_noxref_2_c_324_p N_GND_c_1421_n ) capacitor c=0.0106318f //x=5.97 \
 //y=1.3 //x2=8.245 //y2=0.175
cc_378 ( N_noxref_2_c_311_p N_GND_c_1421_n ) capacitor c=0.00667105f //x=6.325 \
 //y=1.835 //x2=8.245 //y2=0.175
cc_379 ( N_noxref_2_c_372_p N_GND_c_1421_n ) capacitor c=6.42463e-19 //x=6.41 \
 //y=2.925 //x2=8.245 //y2=0.175
cc_380 ( N_noxref_2_c_317_p N_GND_c_1421_n ) capacitor c=2.2945e-19 //x=8.26 \
 //y=2.925 //x2=8.245 //y2=0.175
cc_381 ( N_noxref_2_c_296_n N_GND_c_1421_n ) capacitor c=5.1261e-19 //x=6.41 \
 //y=2.77 //x2=8.245 //y2=0.175
cc_382 ( N_noxref_2_M2_noxref_d N_GND_c_1421_n ) capacitor c=3.01769e-19 \
 //x=4.81 //y=1.085 //x2=8.245 //y2=0.175
cc_383 ( N_noxref_2_M3_noxref_d N_GND_c_1421_n ) capacitor c=3.01769e-19 \
 //x=5.78 //y=1.085 //x2=8.245 //y2=0.175
cc_384 ( N_noxref_2_c_266_n N_GND_c_1427_n ) capacitor c=4.59693e-19 //x=5 \
 //y=1.305 //x2=1.67 //y2=1.135
cc_385 ( N_noxref_2_c_324_p N_GND_c_1467_n ) capacitor c=0.00581397f //x=5.97 \
 //y=1.3 //x2=8.33 //y2=1.135
cc_386 ( N_noxref_2_c_428_p N_GND_c_1467_n ) capacitor c=0.00662465f //x=8.26 \
 //y=2.26 //x2=8.33 //y2=1.135
cc_387 ( N_noxref_2_c_326_p N_GND_c_1467_n ) capacitor c=0.00303385f //x=8.25 \
 //y=2.765 //x2=8.33 //y2=1.135
cc_388 ( N_noxref_2_c_430_p N_GND_c_1467_n ) capacitor c=2.13705e-19 //x=8.26 \
 //y=2.26 //x2=8.33 //y2=1.135
cc_389 ( N_noxref_2_c_431_p N_GND_c_1467_n ) capacitor c=0.00169607f //x=8.065 \
 //y=1.045 //x2=8.33 //y2=1.135
cc_390 ( N_noxref_2_c_432_p N_GND_c_1467_n ) capacitor c=0.00357243f //x=8.065 \
 //y=1.39 //x2=8.33 //y2=1.135
cc_391 ( N_noxref_2_c_433_p N_GND_c_1467_n ) capacitor c=4.2764e-19 //x=8.065 \
 //y=1.7 //x2=8.33 //y2=1.135
cc_392 ( N_noxref_2_c_434_p N_GND_c_1467_n ) capacitor c=7.35788e-19 //x=8.44 \
 //y=0.89 //x2=8.33 //y2=1.135
cc_393 ( N_noxref_2_c_435_p N_GND_c_1467_n ) capacitor c=6.38426e-19 //x=8.44 \
 //y=1.545 //x2=8.33 //y2=1.135
cc_394 ( N_noxref_2_c_436_p N_GND_c_1467_n ) capacitor c=0.00158609f //x=8.595 \
 //y=1.045 //x2=8.33 //y2=1.135
cc_395 ( N_noxref_2_c_437_p N_GND_c_1467_n ) capacitor c=0.00296337f //x=8.595 \
 //y=1.39 //x2=8.33 //y2=1.135
cc_396 ( N_noxref_2_c_431_p N_GND_c_1478_n ) capacitor c=3.51399e-19 //x=8.065 \
 //y=1.045 //x2=8.327 //y2=1.005
cc_397 ( N_noxref_2_c_434_p N_GND_c_1478_n ) capacitor c=0.00864609f //x=8.44 \
 //y=0.89 //x2=8.327 //y2=1.005
cc_398 ( N_noxref_2_c_436_p N_GND_c_1478_n ) capacitor c=4.45447e-19 //x=8.595 \
 //y=1.045 //x2=8.327 //y2=1.005
cc_399 ( N_noxref_2_c_266_n N_GND_c_1434_n ) capacitor c=0.00372564f //x=5 \
 //y=1.305 //x2=5.4 //y2=0.71
cc_400 ( N_noxref_2_c_281_n N_GND_c_1434_n ) capacitor c=0.00128856f //x=5.885 \
 //y=1.835 //x2=5.4 //y2=0.71
cc_401 ( N_noxref_2_M2_noxref_d N_GND_c_1434_n ) capacitor c=0.0124264f \
 //x=4.81 //y=1.085 //x2=5.4 //y2=0.71
cc_402 ( N_noxref_2_c_281_n N_GND_c_1484_n ) capacitor c=0.00105223f //x=5.885 \
 //y=1.835 //x2=6.37 //y2=0.71
cc_403 ( N_noxref_2_c_324_p N_GND_c_1484_n ) capacitor c=0.00469733f //x=5.97 \
 //y=1.3 //x2=6.37 //y2=0.71
cc_404 ( N_noxref_2_c_311_p N_GND_c_1484_n ) capacitor c=0.00353984f //x=6.325 \
 //y=1.835 //x2=6.37 //y2=0.71
cc_405 ( N_noxref_2_M3_noxref_d N_GND_c_1484_n ) capacitor c=0.0122548f \
 //x=5.78 //y=1.085 //x2=6.37 //y2=0.71
cc_406 ( N_noxref_2_c_372_p N_GND_c_1488_n ) capacitor c=2.81168e-19 //x=6.41 \
 //y=2.925 //x2=6.98 //y2=0.175
cc_407 ( N_noxref_2_c_431_p N_GND_c_1489_n ) capacitor c=0.00691994f //x=8.065 \
 //y=1.045 //x2=10.31 //y2=0.175
cc_408 ( N_noxref_2_c_290_n N_GND_c_1440_n ) capacitor c=9.32616e-19 //x=6.41 \
 //y=2.605 //x2=3.82 //y2=0.175
cc_409 ( N_noxref_2_c_288_n N_GND_c_1491_n ) capacitor c=0.00331216f //x=5.97 \
 //y=1.75 //x2=7.15 //y2=0.175
cc_410 ( N_noxref_2_c_311_p N_GND_c_1491_n ) capacitor c=0.0231857f //x=6.325 \
 //y=1.835 //x2=7.15 //y2=0.175
cc_411 ( N_noxref_2_c_372_p N_GND_c_1491_n ) capacitor c=0.00427064f //x=6.41 \
 //y=2.925 //x2=7.15 //y2=0.175
cc_412 ( N_noxref_2_c_313_p N_GND_c_1491_n ) capacitor c=0.00333222f //x=8.26 \
 //y=2.605 //x2=7.15 //y2=0.175
cc_413 ( N_noxref_2_c_317_p N_GND_c_1491_n ) capacitor c=0.00312614f //x=8.26 \
 //y=2.925 //x2=7.15 //y2=0.175
cc_414 ( N_noxref_2_c_296_n N_GND_c_1491_n ) capacitor c=0.0101754f //x=6.41 \
 //y=2.77 //x2=7.15 //y2=0.175
cc_415 ( N_noxref_2_c_325_p N_GND_c_1491_n ) capacitor c=0.00512799f //x=8.26 \
 //y=2.77 //x2=7.15 //y2=0.175
cc_416 ( N_noxref_2_c_428_p N_GND_c_1491_n ) capacitor c=0.00427323f //x=8.26 \
 //y=2.26 //x2=7.15 //y2=0.175
cc_417 ( N_noxref_2_c_345_p N_GND_c_1491_n ) capacitor c=0.0241255f //x=8.09 \
 //y=2.765 //x2=7.15 //y2=0.175
cc_418 ( N_noxref_2_c_430_p N_GND_c_1491_n ) capacitor c=0.00369427f //x=8.26 \
 //y=2.26 //x2=7.15 //y2=0.175
cc_419 ( N_noxref_2_c_433_p N_GND_c_1491_n ) capacitor c=0.0015404f //x=8.065 \
 //y=1.7 //x2=7.15 //y2=0.175
cc_420 ( N_noxref_2_c_462_p N_GND_c_1491_n ) capacitor c=0.00950704f //x=8.065 \
 //y=2.095 //x2=7.15 //y2=0.175
cc_421 ( N_noxref_2_c_266_n N_GND_c_1451_n ) capacitor c=3.01913e-19 //x=5 \
 //y=1.305 //x2=12.08 //y2=0.175
cc_422 ( N_noxref_2_c_324_p N_GND_c_1451_n ) capacitor c=3.01913e-19 //x=5.97 \
 //y=1.3 //x2=12.08 //y2=0.175
cc_423 ( N_noxref_2_c_266_n N_GND_M2_noxref_s ) capacitor c=0.00926082f //x=5 \
 //y=1.305 //x2=4.38 //y2=0.545
cc_424 ( N_noxref_2_c_275_n N_GND_M2_noxref_s ) capacitor c=0.0225586f //x=5 \
 //y=1.75 //x2=4.38 //y2=0.545
cc_425 ( N_noxref_2_c_281_n N_GND_M2_noxref_s ) capacitor c=0.00857623f \
 //x=5.885 //y=1.835 //x2=4.38 //y2=0.545
cc_426 ( N_noxref_2_c_324_p N_GND_M2_noxref_s ) capacitor c=0.00932895f \
 //x=5.97 //y=1.3 //x2=4.38 //y2=0.545
cc_427 ( N_noxref_2_c_288_n N_GND_M2_noxref_s ) capacitor c=0.0111835f \
 //x=5.97 //y=1.75 //x2=4.38 //y2=0.545
cc_428 ( N_noxref_2_c_311_p N_GND_M2_noxref_s ) capacitor c=0.00607462f \
 //x=6.325 //y=1.835 //x2=4.38 //y2=0.545
cc_429 ( N_noxref_2_c_372_p N_GND_M2_noxref_s ) capacitor c=8.10232e-19 \
 //x=6.41 //y=2.925 //x2=4.38 //y2=0.545
cc_430 ( N_noxref_2_c_296_n N_GND_M2_noxref_s ) capacitor c=0.00206188f \
 //x=6.41 //y=2.77 //x2=4.38 //y2=0.545
cc_431 ( N_noxref_2_M2_noxref_d N_GND_M2_noxref_s ) capacitor c=0.0297221f \
 //x=4.81 //y=1.085 //x2=4.38 //y2=0.545
cc_432 ( N_noxref_2_M3_noxref_d N_GND_M2_noxref_s ) capacitor c=0.029747f \
 //x=5.78 //y=1.085 //x2=4.38 //y2=0.545
cc_433 ( N_noxref_2_c_428_p N_GND_M4_noxref_d ) capacitor c=2.20438e-19 \
 //x=8.26 //y=2.26 //x2=8.14 //y2=1.045
cc_434 ( N_noxref_2_c_431_p N_GND_M4_noxref_d ) capacitor c=0.00192399f \
 //x=8.065 //y=1.045 //x2=8.14 //y2=1.045
cc_435 ( N_noxref_2_c_432_p N_GND_M4_noxref_d ) capacitor c=0.00210798f \
 //x=8.065 //y=1.39 //x2=8.14 //y2=1.045
cc_436 ( N_noxref_2_c_434_p N_GND_M4_noxref_d ) capacitor c=0.00472259f \
 //x=8.44 //y=0.89 //x2=8.14 //y2=1.045
cc_437 ( N_noxref_2_c_435_p N_GND_M4_noxref_d ) capacitor c=0.00166857f \
 //x=8.44 //y=1.545 //x2=8.14 //y2=1.045
cc_438 ( N_noxref_2_c_436_p N_GND_M4_noxref_d ) capacitor c=0.00230174f \
 //x=8.595 //y=1.045 //x2=8.14 //y2=1.045
cc_439 ( N_noxref_2_c_437_p N_GND_M4_noxref_d ) capacitor c=0.00210798f \
 //x=8.595 //y=1.39 //x2=8.14 //y2=1.045
cc_440 ( N_noxref_2_c_290_n D ) capacitor c=6.60708e-19 //x=6.41 //y=2.605 \
 //x2=9 //y2=2.4
cc_441 ( N_noxref_2_c_292_n D ) capacitor c=0.00317943f //x=6.41 //y=5.305 \
 //x2=9 //y2=2.4
cc_442 ( N_noxref_2_c_313_p D ) capacitor c=0.0090111f //x=8.26 //y=2.605 \
 //x2=9 //y2=2.4
cc_443 ( N_noxref_2_c_317_p D ) capacitor c=0.0145387f //x=8.26 //y=2.925 \
 //x2=9 //y2=2.4
cc_444 ( N_noxref_2_c_325_p D ) capacitor c=5.57251e-19 //x=8.26 //y=2.77 \
 //x2=9 //y2=2.4
cc_445 ( N_noxref_2_c_315_p D ) capacitor c=0.0840435f //x=8.262 //y=4.74 \
 //x2=9 //y2=2.4
cc_446 ( N_noxref_2_c_326_p D ) capacitor c=0.00358737f //x=8.25 //y=2.765 \
 //x2=9 //y2=2.4
cc_447 ( N_noxref_2_c_430_p D ) capacitor c=3.49899e-19 //x=8.26 //y=2.26 \
 //x2=9 //y2=2.4
cc_448 ( N_noxref_2_c_320_p D ) capacitor c=3.02466e-19 //x=8.26 //y=4.88 \
 //x2=9 //y2=2.4
cc_449 ( N_noxref_2_c_323_p D ) capacitor c=0.00108965f //x=8.26 //y=4.88 \
 //x2=9 //y2=2.4
cc_450 ( N_noxref_2_c_319_p N_D_c_1706_n ) capacitor c=0.0172958f //x=8.26 \
 //y=4.88 //x2=9 //y2=4.735
cc_451 ( N_noxref_2_c_320_p N_D_c_1706_n ) capacitor c=4.73677e-19 //x=8.26 \
 //y=4.88 //x2=9 //y2=4.735
cc_452 ( N_noxref_2_c_323_p N_D_c_1706_n ) capacitor c=9.22067e-19 //x=8.26 \
 //y=4.88 //x2=9 //y2=4.735
cc_453 ( N_noxref_2_c_428_p N_D_c_1709_n ) capacitor c=0.0205342f //x=8.26 \
 //y=2.26 //x2=9 //y2=2.26
cc_454 ( N_noxref_2_c_430_p N_D_c_1709_n ) capacitor c=5.16867e-19 //x=8.26 \
 //y=2.26 //x2=9 //y2=2.26
cc_455 ( N_noxref_2_c_462_p N_D_c_1709_n ) capacitor c=0.00167888f //x=8.065 \
 //y=2.095 //x2=9 //y2=2.26
cc_456 ( N_noxref_2_c_313_p N_D_c_1712_n ) capacitor c=3.49899e-19 //x=8.26 \
 //y=2.605 //x2=9 //y2=2.26
cc_457 ( N_noxref_2_c_428_p N_D_c_1712_n ) capacitor c=5.24723e-19 //x=8.26 \
 //y=2.26 //x2=9 //y2=2.26
cc_458 ( N_noxref_2_c_430_p N_D_c_1712_n ) capacitor c=0.00445529f //x=8.26 \
 //y=2.26 //x2=9 //y2=2.26
cc_459 ( N_noxref_2_c_462_p N_D_c_1712_n ) capacitor c=0.00267961f //x=8.065 \
 //y=2.095 //x2=9 //y2=2.26
cc_460 ( N_noxref_2_c_319_p N_D_c_1716_n ) capacitor c=4.80626e-19 //x=8.26 \
 //y=4.88 //x2=9.03 //y2=4.88
cc_461 ( N_noxref_2_c_320_p N_D_c_1716_n ) capacitor c=0.00397338f //x=8.26 \
 //y=4.88 //x2=9.03 //y2=4.88
cc_462 ( N_noxref_2_c_323_p N_D_c_1716_n ) capacitor c=0.00283894f //x=8.26 \
 //y=4.88 //x2=9.03 //y2=4.88
cc_463 ( N_noxref_2_M15_noxref_g N_D_M17_noxref_g ) capacitor c=0.0104892f \
 //x=8.16 //y=6.2 //x2=9.04 //y2=6.2
cc_464 ( N_noxref_2_M16_noxref_g N_D_M17_noxref_g ) capacitor c=0.107636f \
 //x=8.6 //y=6.2 //x2=9.04 //y2=6.2
cc_465 ( N_noxref_2_M16_noxref_g N_D_M18_noxref_g ) capacitor c=0.0100341f \
 //x=8.6 //y=6.2 //x2=9.48 //y2=6.2
cc_466 ( N_noxref_2_c_431_p N_D_c_1722_n ) capacitor c=4.86545e-19 //x=8.065 \
 //y=1.045 //x2=9.035 //y2=1.085
cc_467 ( N_noxref_2_c_432_p N_D_c_1722_n ) capacitor c=0.00152405f //x=8.065 \
 //y=1.39 //x2=9.035 //y2=1.085
cc_468 ( N_noxref_2_c_436_p N_D_c_1722_n ) capacitor c=0.0151475f //x=8.595 \
 //y=1.045 //x2=9.035 //y2=1.085
cc_469 ( N_noxref_2_c_433_p N_D_c_1725_n ) capacitor c=0.00109982f //x=8.065 \
 //y=1.7 //x2=9.035 //y2=1.43
cc_470 ( N_noxref_2_c_437_p N_D_c_1725_n ) capacitor c=0.0111064f //x=8.595 \
 //y=1.39 //x2=9.035 //y2=1.43
cc_471 ( N_noxref_2_c_433_p N_D_c_1727_n ) capacitor c=9.58243e-19 //x=8.065 \
 //y=1.7 //x2=9.035 //y2=1.74
cc_472 ( N_noxref_2_c_462_p N_D_c_1727_n ) capacitor c=0.00662747f //x=8.065 \
 //y=2.095 //x2=9.035 //y2=1.74
cc_473 ( N_noxref_2_c_437_p N_D_c_1727_n ) capacitor c=0.00862358f //x=8.595 \
 //y=1.39 //x2=9.035 //y2=1.74
cc_474 ( N_noxref_2_c_436_p N_D_c_1730_n ) capacitor c=0.00127211f //x=8.595 \
 //y=1.045 //x2=9.565 //y2=1.085
cc_475 ( N_noxref_2_c_437_p N_D_c_1731_n ) capacitor c=0.00204774f //x=8.595 \
 //y=1.39 //x2=9.565 //y2=1.43
cc_476 ( N_noxref_2_c_428_p N_D_c_1732_n ) capacitor c=0.00167305f //x=8.26 \
 //y=2.26 //x2=9 //y2=2.26
cc_477 ( N_noxref_2_c_430_p N_D_c_1732_n ) capacitor c=0.00266443f //x=8.26 \
 //y=2.26 //x2=9 //y2=2.26
cc_478 ( N_noxref_2_c_462_p N_D_c_1732_n ) capacitor c=0.0181449f //x=8.065 \
 //y=2.095 //x2=9 //y2=2.26
cc_479 ( N_noxref_2_c_319_p N_D_c_1735_n ) capacitor c=0.00158715f //x=8.26 \
 //y=4.88 //x2=9.03 //y2=4.88
cc_480 ( N_noxref_2_c_320_p N_D_c_1735_n ) capacitor c=0.00237977f //x=8.26 \
 //y=4.88 //x2=9.03 //y2=4.88
cc_481 ( N_noxref_2_c_323_p N_D_c_1735_n ) capacitor c=0.0297875f //x=8.26 \
 //y=4.88 //x2=9.03 //y2=4.88
cc_482 ( N_noxref_2_c_345_p N_noxref_13_c_1949_n ) capacitor c=0.00357165f \
 //x=8.09 //y=2.765 //x2=7.845 //y2=1.675
cc_483 ( N_noxref_2_c_462_p N_noxref_13_c_1949_n ) capacitor c=0.00262672f \
 //x=8.065 //y=2.095 //x2=7.845 //y2=1.675
cc_484 ( N_noxref_2_c_317_p N_noxref_13_c_1951_n ) capacitor c=0.00524385f \
 //x=8.26 //y=2.925 //x2=8.73 //y2=1.76
cc_485 ( N_noxref_2_c_428_p N_noxref_13_c_1951_n ) capacitor c=0.00509504f \
 //x=8.26 //y=2.26 //x2=8.73 //y2=1.76
cc_486 ( N_noxref_2_c_345_p N_noxref_13_c_1951_n ) capacitor c=0.00132102f \
 //x=8.09 //y=2.765 //x2=8.73 //y2=1.76
cc_487 ( N_noxref_2_c_430_p N_noxref_13_c_1951_n ) capacitor c=0.00763108f \
 //x=8.26 //y=2.26 //x2=8.73 //y2=1.76
cc_488 ( N_noxref_2_c_433_p N_noxref_13_c_1951_n ) capacitor c=0.00697076f \
 //x=8.065 //y=1.7 //x2=8.73 //y2=1.76
cc_489 ( N_noxref_2_c_462_p N_noxref_13_c_1951_n ) capacitor c=0.0165705f \
 //x=8.065 //y=2.095 //x2=8.73 //y2=1.76
cc_490 ( N_noxref_2_c_435_p N_noxref_13_c_1951_n ) capacitor c=0.00723574f \
 //x=8.44 //y=1.545 //x2=8.73 //y2=1.76
cc_491 ( N_noxref_2_c_437_p N_noxref_13_c_1951_n ) capacitor c=0.00339872f \
 //x=8.595 //y=1.39 //x2=8.73 //y2=1.76
cc_492 ( N_noxref_2_c_462_p N_noxref_13_c_1959_n ) capacitor c=6.71402e-19 \
 //x=8.065 //y=2.095 //x2=8.815 //y2=1.675
cc_493 ( N_noxref_2_c_431_p N_noxref_13_M4_noxref_s ) capacitor c=0.029498f \
 //x=8.065 //y=1.045 //x2=7.71 //y2=0.545
cc_494 ( N_noxref_2_c_433_p N_noxref_13_M4_noxref_s ) capacitor c=3.48408e-19 \
 //x=8.065 //y=1.7 //x2=7.71 //y2=0.545
cc_495 ( N_noxref_2_c_436_p N_noxref_13_M4_noxref_s ) capacitor c=0.0125442f \
 //x=8.595 //y=1.045 //x2=7.71 //y2=0.545
cc_496 ( N_noxref_3_c_538_n N_VDD_c_822_n ) capacitor c=0.00648307f //x=9.145 \
 //y=5.38 //x2=11.96 //y2=7.58
cc_497 ( N_noxref_3_c_563_p N_VDD_c_822_n ) capacitor c=0.00488503f //x=9.655 \
 //y=5.38 //x2=11.96 //y2=7.58
cc_498 ( N_noxref_3_c_564_p N_VDD_c_822_n ) capacitor c=5.73169e-19 //x=11.22 \
 //y=4.76 //x2=11.96 //y2=7.58
cc_499 ( N_noxref_3_c_546_n N_VDD_c_822_n ) capacitor c=0.00368834f //x=8.38 \
 //y=5.56 //x2=11.96 //y2=7.58
cc_500 ( N_noxref_3_c_566_p N_VDD_c_822_n ) capacitor c=8.42709e-19 //x=9.26 \
 //y=5.38 //x2=11.96 //y2=7.58
cc_501 ( N_noxref_3_c_567_p N_VDD_c_822_n ) capacitor c=0.00285853f //x=9.26 \
 //y=5.56 //x2=11.96 //y2=7.58
cc_502 ( N_noxref_3_c_557_n N_VDD_c_822_n ) capacitor c=0.00224881f //x=8.38 \
 //y=5.56 //x2=11.96 //y2=7.58
cc_503 ( N_noxref_3_c_569_p N_VDD_c_822_n ) capacitor c=0.00224881f //x=9.26 \
 //y=5.56 //x2=11.96 //y2=7.58
cc_504 ( N_noxref_3_c_570_p N_VDD_c_822_n ) capacitor c=3.40755e-19 //x=11.22 \
 //y=4.88 //x2=11.96 //y2=7.58
cc_505 ( N_noxref_3_c_538_n N_VDD_c_827_n ) capacitor c=0.00213203f //x=9.145 \
 //y=5.38 //x2=8.735 //y2=7.585
cc_506 ( N_noxref_3_c_546_n N_VDD_c_827_n ) capacitor c=9.99055e-19 //x=8.38 \
 //y=5.56 //x2=8.735 //y2=7.585
cc_507 ( N_noxref_3_c_557_n N_VDD_c_827_n ) capacitor c=0.0136705f //x=8.38 \
 //y=5.56 //x2=8.735 //y2=7.585
cc_508 ( N_noxref_3_c_538_n N_VDD_c_858_n ) capacitor c=0.00184541f //x=9.145 \
 //y=5.38 //x2=9.615 //y2=7.585
cc_509 ( N_noxref_3_c_563_p N_VDD_c_858_n ) capacitor c=0.00213203f //x=9.655 \
 //y=5.38 //x2=9.615 //y2=7.585
cc_510 ( N_noxref_3_c_566_p N_VDD_c_858_n ) capacitor c=5.39459e-19 //x=9.26 \
 //y=5.38 //x2=9.615 //y2=7.585
cc_511 ( N_noxref_3_c_567_p N_VDD_c_858_n ) capacitor c=5.77976e-19 //x=9.26 \
 //y=5.56 //x2=9.615 //y2=7.585
cc_512 ( N_noxref_3_c_569_p N_VDD_c_858_n ) capacitor c=0.0136705f //x=9.26 \
 //y=5.56 //x2=9.615 //y2=7.585
cc_513 ( N_noxref_3_c_564_p N_VDD_c_863_n ) capacitor c=5.48929e-19 //x=11.22 \
 //y=4.76 //x2=11.95 //y2=7.585
cc_514 ( N_noxref_3_M19_noxref_g N_VDD_c_863_n ) capacitor c=0.00753931f \
 //x=11.375 //y=6.2 //x2=11.95 //y2=7.585
cc_515 ( N_noxref_3_M20_noxref_g N_VDD_c_863_n ) capacitor c=0.00755544f \
 //x=11.815 //y=6.2 //x2=11.95 //y2=7.585
cc_516 ( N_noxref_3_c_544_n N_VDD_c_803_n ) capacitor c=0.0013228f //x=9.74 \
 //y=5.295 //x2=7.15 //y2=7.585
cc_517 ( N_noxref_3_c_546_n N_VDD_c_803_n ) capacitor c=4.91377e-19 //x=8.38 \
 //y=5.56 //x2=7.15 //y2=7.585
cc_518 ( N_noxref_3_c_557_n N_VDD_c_803_n ) capacitor c=0.00637389f //x=8.38 \
 //y=5.56 //x2=7.15 //y2=7.585
cc_519 ( N_noxref_3_c_544_n N_VDD_c_869_n ) capacitor c=0.0283322f //x=9.74 \
 //y=5.295 //x2=10.48 //y2=7.585
cc_520 ( N_noxref_3_c_564_p N_VDD_c_869_n ) capacitor c=0.0155837f //x=11.22 \
 //y=4.76 //x2=10.48 //y2=7.585
cc_521 ( N_noxref_3_c_566_p N_VDD_c_869_n ) capacitor c=0.002343f //x=9.26 \
 //y=5.38 //x2=10.48 //y2=7.585
cc_522 ( N_noxref_3_c_567_p N_VDD_c_869_n ) capacitor c=4.0348e-19 //x=9.26 \
 //y=5.56 //x2=10.48 //y2=7.585
cc_523 ( N_noxref_3_c_589_p N_VDD_c_869_n ) capacitor c=0.00259242f //x=11.06 \
 //y=2.765 //x2=10.48 //y2=7.585
cc_524 ( N_noxref_3_c_569_p N_VDD_c_869_n ) capacitor c=0.0101861f //x=9.26 \
 //y=5.56 //x2=10.48 //y2=7.585
cc_525 ( N_noxref_3_c_570_p N_VDD_c_869_n ) capacitor c=0.00795305f //x=11.22 \
 //y=4.88 //x2=10.48 //y2=7.585
cc_526 ( N_noxref_3_M19_noxref_g N_VDD_c_869_n ) capacitor c=0.00713874f \
 //x=11.375 //y=6.2 //x2=10.48 //y2=7.585
cc_527 ( N_noxref_3_c_593_p N_VDD_c_869_n ) capacitor c=0.00799922f //x=11.45 \
 //y=4.97 //x2=10.48 //y2=7.585
cc_528 ( N_noxref_3_c_557_n N_VDD_c_804_n ) capacitor c=0.00135089f //x=8.38 \
 //y=5.56 //x2=11.96 //y2=7.58
cc_529 ( N_noxref_3_c_569_p N_VDD_c_804_n ) capacitor c=0.00135089f //x=9.26 \
 //y=5.56 //x2=11.96 //y2=7.58
cc_530 ( N_noxref_3_c_570_p N_VDD_c_804_n ) capacitor c=0.00241457f //x=11.22 \
 //y=4.88 //x2=11.96 //y2=7.58
cc_531 ( N_noxref_3_c_597_p N_VDD_c_804_n ) capacitor c=0.0201557f //x=11.74 \
 //y=4.97 //x2=11.96 //y2=7.58
cc_532 ( N_noxref_3_c_546_n N_VDD_M15_noxref_s ) capacitor c=0.0611368f \
 //x=8.38 //y=5.56 //x2=7.805 //y2=5.2
cc_533 ( N_noxref_3_c_566_p N_VDD_M15_noxref_s ) capacitor c=6.52457e-19 \
 //x=9.26 //y=5.38 //x2=7.805 //y2=5.2
cc_534 ( N_noxref_3_c_557_n N_VDD_M15_noxref_s ) capacitor c=0.0884109f \
 //x=8.38 //y=5.56 //x2=7.805 //y2=5.2
cc_535 ( N_noxref_3_c_538_n N_VDD_M16_noxref_d ) capacitor c=0.00810252f \
 //x=9.145 //y=5.38 //x2=8.675 //y2=5.2
cc_536 ( N_noxref_3_c_546_n N_VDD_M16_noxref_d ) capacitor c=0.0043528f \
 //x=8.38 //y=5.56 //x2=8.675 //y2=5.2
cc_537 ( N_noxref_3_c_567_p N_VDD_M16_noxref_d ) capacitor c=0.0043528f \
 //x=9.26 //y=5.56 //x2=8.675 //y2=5.2
cc_538 ( N_noxref_3_c_557_n N_VDD_M16_noxref_d ) capacitor c=0.0653657f \
 //x=8.38 //y=5.56 //x2=8.675 //y2=5.2
cc_539 ( N_noxref_3_c_569_p N_VDD_M16_noxref_d ) capacitor c=0.0654383f \
 //x=9.26 //y=5.56 //x2=8.675 //y2=5.2
cc_540 ( N_noxref_3_c_563_p N_VDD_M18_noxref_d ) capacitor c=0.0100502f \
 //x=9.655 //y=5.38 //x2=9.555 //y2=5.2
cc_541 ( N_noxref_3_c_567_p N_VDD_M18_noxref_d ) capacitor c=0.00921458f \
 //x=9.26 //y=5.56 //x2=9.555 //y2=5.2
cc_542 ( N_noxref_3_c_555_n N_VDD_M18_noxref_d ) capacitor c=6.87256e-19 \
 //x=9.74 //y=2.77 //x2=9.555 //y2=5.2
cc_543 ( N_noxref_3_c_569_p N_VDD_M18_noxref_d ) capacitor c=0.0654892f \
 //x=9.26 //y=5.56 //x2=9.555 //y2=5.2
cc_544 ( N_noxref_3_c_563_p N_VDD_M19_noxref_s ) capacitor c=0.00316782f \
 //x=9.655 //y=5.38 //x2=11.02 //y2=5.2
cc_545 ( N_noxref_3_c_611_p N_VDD_M19_noxref_s ) capacitor c=8.61504e-19 \
 //x=11.22 //y=2.925 //x2=11.02 //y2=5.2
cc_546 ( N_noxref_3_c_564_p N_VDD_M19_noxref_s ) capacitor c=0.0211971f \
 //x=11.22 //y=4.76 //x2=11.02 //y2=5.2
cc_547 ( N_noxref_3_c_566_p N_VDD_M19_noxref_s ) capacitor c=0.00460957f \
 //x=9.26 //y=5.38 //x2=11.02 //y2=5.2
cc_548 ( N_noxref_3_c_567_p N_VDD_M19_noxref_s ) capacitor c=0.00135645f \
 //x=9.26 //y=5.56 //x2=11.02 //y2=5.2
cc_549 ( N_noxref_3_c_570_p N_VDD_M19_noxref_s ) capacitor c=0.00914073f \
 //x=11.22 //y=4.88 //x2=11.02 //y2=5.2
cc_550 ( N_noxref_3_M19_noxref_g N_VDD_M19_noxref_s ) capacitor c=0.0573441f \
 //x=11.375 //y=6.2 //x2=11.02 //y2=5.2
cc_551 ( N_noxref_3_c_593_p N_VDD_M19_noxref_s ) capacitor c=0.00527361f \
 //x=11.45 //y=4.97 //x2=11.02 //y2=5.2
cc_552 ( N_noxref_3_M20_noxref_g N_VDD_M20_noxref_d ) capacitor c=0.0572684f \
 //x=11.815 //y=6.2 //x2=11.89 //y2=5.2
cc_553 ( N_noxref_3_c_619_p N_GND_c_1522_n ) capacitor c=0.00654514f //x=9.655 \
 //y=1.835 //x2=11.96 //y2=0.18
cc_554 ( N_noxref_3_c_620_p N_GND_c_1522_n ) capacitor c=5.98934e-19 //x=9.74 \
 //y=2.925 //x2=11.96 //y2=0.18
cc_555 ( N_noxref_3_c_611_p N_GND_c_1522_n ) capacitor c=5.92387e-19 //x=11.22 \
 //y=2.925 //x2=11.96 //y2=0.18
cc_556 ( N_noxref_3_c_554_n N_GND_c_1522_n ) capacitor c=0.00964814f //x=9.3 \
 //y=1.18 //x2=11.96 //y2=0.18
cc_557 ( N_noxref_3_c_623_p N_GND_c_1522_n ) capacitor c=0.00249122f //x=11.22 \
 //y=2.265 //x2=11.96 //y2=0.18
cc_558 ( N_noxref_3_c_624_p N_GND_c_1522_n ) capacitor c=7.5371e-19 //x=11.22 \
 //y=2.265 //x2=11.96 //y2=0.18
cc_559 ( N_noxref_3_M5_noxref_d N_GND_c_1522_n ) capacitor c=3.01769e-19 \
 //x=9.11 //y=1.085 //x2=11.96 //y2=0.18
cc_560 ( N_noxref_3_c_546_n N_GND_c_1467_n ) capacitor c=7.0104e-19 //x=8.38 \
 //y=5.56 //x2=8.33 //y2=1.135
cc_561 ( N_noxref_3_c_554_n N_GND_c_1467_n ) capacitor c=0.0140149f //x=9.3 \
 //y=1.18 //x2=8.33 //y2=1.135
cc_562 ( N_noxref_3_M5_noxref_d N_GND_c_1467_n ) capacitor c=2.93544e-19 \
 //x=9.11 //y=1.085 //x2=8.33 //y2=1.135
cc_563 ( N_noxref_3_c_619_p N_GND_c_1489_n ) capacitor c=7.75992e-19 //x=9.655 \
 //y=1.835 //x2=10.31 //y2=0.175
cc_564 ( N_noxref_3_c_620_p N_GND_c_1489_n ) capacitor c=4.78725e-19 //x=9.74 \
 //y=2.925 //x2=10.31 //y2=0.175
cc_565 ( N_noxref_3_c_611_p N_GND_c_1534_n ) capacitor c=2.60522e-19 //x=11.22 \
 //y=2.925 //x2=11.505 //y2=0.715
cc_566 ( N_noxref_3_c_623_p N_GND_c_1534_n ) capacitor c=0.00114179f //x=11.22 \
 //y=2.265 //x2=11.505 //y2=0.715
cc_567 ( N_noxref_3_c_624_p N_GND_c_1534_n ) capacitor c=3.95714e-19 //x=11.22 \
 //y=2.265 //x2=11.505 //y2=0.715
cc_568 ( N_noxref_3_c_634_p N_GND_c_1534_n ) capacitor c=0.0125549f //x=11.33 \
 //y=1.09 //x2=11.505 //y2=0.715
cc_569 ( N_noxref_3_c_635_p N_GND_c_1534_n ) capacitor c=2.1838e-19 //x=11.22 \
 //y=2.265 //x2=11.505 //y2=0.715
cc_570 ( N_noxref_3_c_636_p N_GND_c_1539_n ) capacitor c=0.0134289f //x=11.86 \
 //y=1.09 //x2=11.995 //y2=0.715
cc_571 ( N_noxref_3_c_542_n N_GND_c_1491_n ) capacitor c=9.34934e-19 //x=9.74 \
 //y=2.605 //x2=7.15 //y2=0.175
cc_572 ( N_noxref_3_c_539_n N_GND_c_1541_n ) capacitor c=0.00269515f //x=9.3 \
 //y=1.75 //x2=10.48 //y2=0.175
cc_573 ( N_noxref_3_c_619_p N_GND_c_1541_n ) capacitor c=0.0197995f //x=9.655 \
 //y=1.835 //x2=10.48 //y2=0.175
cc_574 ( N_noxref_3_c_620_p N_GND_c_1541_n ) capacitor c=0.00494191f //x=9.74 \
 //y=2.925 //x2=10.48 //y2=0.175
cc_575 ( N_noxref_3_c_641_p N_GND_c_1541_n ) capacitor c=0.00382407f //x=11.22 \
 //y=2.605 //x2=10.48 //y2=0.175
cc_576 ( N_noxref_3_c_611_p N_GND_c_1541_n ) capacitor c=0.00494191f //x=11.22 \
 //y=2.925 //x2=10.48 //y2=0.175
cc_577 ( N_noxref_3_c_555_n N_GND_c_1541_n ) capacitor c=0.010052f //x=9.74 \
 //y=2.77 //x2=10.48 //y2=0.175
cc_578 ( N_noxref_3_c_644_p N_GND_c_1541_n ) capacitor c=0.010052f //x=11.22 \
 //y=2.77 //x2=10.48 //y2=0.175
cc_579 ( N_noxref_3_c_623_p N_GND_c_1541_n ) capacitor c=0.00682461f //x=11.22 \
 //y=2.265 //x2=10.48 //y2=0.175
cc_580 ( N_noxref_3_c_589_p N_GND_c_1541_n ) capacitor c=0.0228448f //x=11.06 \
 //y=2.765 //x2=10.48 //y2=0.175
cc_581 ( N_noxref_3_c_624_p N_GND_c_1541_n ) capacitor c=0.00733236f //x=11.22 \
 //y=2.265 //x2=10.48 //y2=0.175
cc_582 ( N_noxref_3_c_648_p N_GND_c_1541_n ) capacitor c=0.00427783f //x=11.33 \
 //y=2.1 //x2=10.48 //y2=0.175
cc_583 ( N_noxref_3_c_635_p N_GND_c_1541_n ) capacitor c=0.00786308f //x=11.22 \
 //y=2.265 //x2=10.48 //y2=0.175
cc_584 ( N_noxref_3_c_554_n N_GND_c_1451_n ) capacitor c=2.83275e-19 //x=9.3 \
 //y=1.18 //x2=12.08 //y2=0.175
cc_585 ( N_noxref_3_c_644_p N_GND_c_1451_n ) capacitor c=0.00313809f //x=11.22 \
 //y=2.77 //x2=12.08 //y2=0.175
cc_586 ( N_noxref_3_c_624_p N_GND_c_1451_n ) capacitor c=0.0022444f //x=11.22 \
 //y=2.265 //x2=12.08 //y2=0.175
cc_587 ( N_noxref_3_c_635_p N_GND_c_1451_n ) capacitor c=2.63786e-19 //x=11.22 \
 //y=2.265 //x2=12.08 //y2=0.175
cc_588 ( N_noxref_3_c_554_n N_GND_M4_noxref_d ) capacitor c=2.82748e-19 \
 //x=9.3 //y=1.18 //x2=8.14 //y2=1.045
cc_589 ( N_noxref_3_c_611_p N_GND_M6_noxref_s ) capacitor c=0.00169603f \
 //x=11.22 //y=2.925 //x2=10.975 //y2=0.55
cc_590 ( N_noxref_3_c_623_p N_GND_M6_noxref_s ) capacitor c=0.00297876f \
 //x=11.22 //y=2.265 //x2=10.975 //y2=0.55
cc_591 ( N_noxref_3_c_624_p N_GND_M6_noxref_s ) capacitor c=0.00651326f \
 //x=11.22 //y=2.265 //x2=10.975 //y2=0.55
cc_592 ( N_noxref_3_c_634_p N_GND_M6_noxref_s ) capacitor c=0.0300873f \
 //x=11.33 //y=1.09 //x2=10.975 //y2=0.55
cc_593 ( N_noxref_3_c_659_p N_GND_M6_noxref_s ) capacitor c=0.002132f \
 //x=11.33 //y=1.745 //x2=10.975 //y2=0.55
cc_594 ( N_noxref_3_c_648_p N_GND_M6_noxref_s ) capacitor c=0.00304786f \
 //x=11.33 //y=2.1 //x2=10.975 //y2=0.55
cc_595 ( N_noxref_3_c_661_p N_GND_M6_noxref_s ) capacitor c=0.00517463f \
 //x=11.705 //y=0.935 //x2=10.975 //y2=0.55
cc_596 ( N_noxref_3_c_636_p N_GND_M6_noxref_s ) capacitor c=0.0153553f \
 //x=11.86 //y=1.09 //x2=10.975 //y2=0.55
cc_597 ( N_noxref_3_c_663_p N_GND_M6_noxref_s ) capacitor c=0.00629878f \
 //x=11.86 //y=1.435 //x2=10.975 //y2=0.55
cc_598 ( N_noxref_3_c_635_p N_GND_M6_noxref_s ) capacitor c=0.00659832f \
 //x=11.22 //y=2.265 //x2=10.975 //y2=0.55
cc_599 ( N_noxref_3_c_542_n D ) capacitor c=0.009049f //x=9.74 //y=2.605 \
 //x2=9 //y2=2.4
cc_600 ( N_noxref_3_c_620_p D ) capacitor c=0.0148501f //x=9.74 //y=2.925 \
 //x2=9 //y2=2.4
cc_601 ( N_noxref_3_c_544_n D ) capacitor c=0.0837259f //x=9.74 //y=5.295 \
 //x2=9 //y2=2.4
cc_602 ( N_noxref_3_c_641_p D ) capacitor c=6.38703e-19 //x=11.22 //y=2.605 \
 //x2=9 //y2=2.4
cc_603 ( N_noxref_3_c_564_p D ) capacitor c=0.00309347f //x=11.22 //y=4.76 \
 //x2=9 //y2=2.4
cc_604 ( N_noxref_3_c_555_n D ) capacitor c=5.57251e-19 //x=9.74 //y=2.77 \
 //x2=9 //y2=2.4
cc_605 ( N_noxref_3_c_556_n D ) capacitor c=0.00361136f //x=9.9 //y=2.765 \
 //x2=9 //y2=2.4
cc_606 ( N_noxref_3_c_538_n N_D_c_1706_n ) capacitor c=0.0228479f //x=9.145 \
 //y=5.38 //x2=9 //y2=4.735
cc_607 ( N_noxref_3_c_544_n N_D_c_1706_n ) capacitor c=0.016905f //x=9.74 \
 //y=5.295 //x2=9 //y2=4.735
cc_608 ( N_noxref_3_c_538_n N_D_c_1709_n ) capacitor c=2.77624e-19 //x=9.145 \
 //y=5.38 //x2=9 //y2=2.26
cc_609 ( N_noxref_3_c_542_n N_D_c_1709_n ) capacitor c=0.015397f //x=9.74 \
 //y=2.605 //x2=9 //y2=2.26
cc_610 ( N_noxref_3_c_542_n N_D_c_1712_n ) capacitor c=0.00335761f //x=9.74 \
 //y=2.605 //x2=9 //y2=2.26
cc_611 ( N_noxref_3_c_538_n N_D_c_1716_n ) capacitor c=0.00469257f //x=9.145 \
 //y=5.38 //x2=9.03 //y2=4.88
cc_612 ( N_noxref_3_c_544_n N_D_c_1716_n ) capacitor c=7.76118e-19 //x=9.74 \
 //y=5.295 //x2=9.03 //y2=4.88
cc_613 ( N_noxref_3_c_538_n N_D_M17_noxref_g ) capacitor c=0.00842859f \
 //x=9.145 //y=5.38 //x2=9.04 //y2=6.2
cc_614 ( N_noxref_3_c_566_p N_D_M17_noxref_g ) capacitor c=0.00192712f \
 //x=9.26 //y=5.38 //x2=9.04 //y2=6.2
cc_615 ( N_noxref_3_c_569_p N_D_M17_noxref_g ) capacitor c=0.0178987f //x=9.26 \
 //y=5.56 //x2=9.04 //y2=6.2
cc_616 ( N_noxref_3_c_563_p N_D_M18_noxref_g ) capacitor c=0.0115937f \
 //x=9.655 //y=5.38 //x2=9.48 //y2=6.2
cc_617 ( N_noxref_3_c_566_p N_D_M18_noxref_g ) capacitor c=0.00291595f \
 //x=9.26 //y=5.38 //x2=9.48 //y2=6.2
cc_618 ( N_noxref_3_c_569_p N_D_M18_noxref_g ) capacitor c=0.0178506f //x=9.26 \
 //y=5.56 //x2=9.48 //y2=6.2
cc_619 ( N_noxref_3_c_554_n N_D_c_1722_n ) capacitor c=0.00120406f //x=9.3 \
 //y=1.18 //x2=9.035 //y2=1.085
cc_620 ( N_noxref_3_M5_noxref_d N_D_c_1722_n ) capacitor c=0.00137165f \
 //x=9.11 //y=1.085 //x2=9.035 //y2=1.085
cc_621 ( N_noxref_3_c_539_n N_D_c_1725_n ) capacitor c=0.00119008f //x=9.3 \
 //y=1.75 //x2=9.035 //y2=1.43
cc_622 ( N_noxref_3_c_554_n N_D_c_1725_n ) capacitor c=0.00218668f //x=9.3 \
 //y=1.18 //x2=9.035 //y2=1.43
cc_623 ( N_noxref_3_M5_noxref_d N_D_c_1725_n ) capacitor c=0.00237422f \
 //x=9.11 //y=1.085 //x2=9.035 //y2=1.43
cc_624 ( N_noxref_3_c_539_n N_D_c_1727_n ) capacitor c=0.00438634f //x=9.3 \
 //y=1.75 //x2=9.035 //y2=1.74
cc_625 ( N_noxref_3_c_544_n N_D_c_1764_n ) capacitor c=0.00845606f //x=9.74 \
 //y=5.295 //x2=9.405 //y2=4.97
cc_626 ( N_noxref_3_c_566_p N_D_c_1764_n ) capacitor c=0.0020909f //x=9.26 \
 //y=5.38 //x2=9.405 //y2=4.97
cc_627 ( N_noxref_3_c_569_p N_D_c_1764_n ) capacitor c=0.00291714f //x=9.26 \
 //y=5.56 //x2=9.405 //y2=4.97
cc_628 ( N_noxref_3_c_554_n N_D_c_1767_n ) capacitor c=5.50523e-19 //x=9.3 \
 //y=1.18 //x2=9.41 //y2=0.93
cc_629 ( N_noxref_3_M5_noxref_d N_D_c_1767_n ) capacitor c=0.0020782f //x=9.11 \
 //y=1.085 //x2=9.41 //y2=0.93
cc_630 ( N_noxref_3_c_539_n N_D_c_1769_n ) capacitor c=0.0089787f //x=9.3 \
 //y=1.75 //x2=9.41 //y2=1.585
cc_631 ( N_noxref_3_c_619_p N_D_c_1769_n ) capacitor c=0.00194324f //x=9.655 \
 //y=1.835 //x2=9.41 //y2=1.585
cc_632 ( N_noxref_3_c_554_n N_D_c_1769_n ) capacitor c=5.67071e-19 //x=9.3 \
 //y=1.18 //x2=9.41 //y2=1.585
cc_633 ( N_noxref_3_M5_noxref_d N_D_c_1769_n ) capacitor c=0.00356097f \
 //x=9.11 //y=1.085 //x2=9.41 //y2=1.585
cc_634 ( N_noxref_3_c_554_n N_D_c_1730_n ) capacitor c=0.00109893f //x=9.3 \
 //y=1.18 //x2=9.565 //y2=1.085
cc_635 ( N_noxref_3_M5_noxref_d N_D_c_1730_n ) capacitor c=8.50095e-19 \
 //x=9.11 //y=1.085 //x2=9.565 //y2=1.085
cc_636 ( N_noxref_3_c_539_n N_D_c_1731_n ) capacitor c=0.00303393f //x=9.3 \
 //y=1.75 //x2=9.565 //y2=1.43
cc_637 ( N_noxref_3_c_619_p N_D_c_1731_n ) capacitor c=0.00323005f //x=9.655 \
 //y=1.835 //x2=9.565 //y2=1.43
cc_638 ( N_noxref_3_c_554_n N_D_c_1731_n ) capacitor c=0.00312043f //x=9.3 \
 //y=1.18 //x2=9.565 //y2=1.43
cc_639 ( N_noxref_3_M5_noxref_d N_D_c_1731_n ) capacitor c=0.00237422f \
 //x=9.11 //y=1.085 //x2=9.565 //y2=1.43
cc_640 ( N_noxref_3_c_542_n N_D_c_1732_n ) capacitor c=0.00281392f //x=9.74 \
 //y=2.605 //x2=9 //y2=2.26
cc_641 ( N_noxref_3_c_539_n N_D_c_1780_n ) capacitor c=0.00341114f //x=9.3 \
 //y=1.75 //x2=9 //y2=2.095
cc_642 ( N_noxref_3_c_542_n N_D_c_1780_n ) capacitor c=0.00309058f //x=9.74 \
 //y=2.605 //x2=9 //y2=2.095
cc_643 ( N_noxref_3_c_538_n N_D_c_1735_n ) capacitor c=9.8107e-19 //x=9.145 \
 //y=5.38 //x2=9.03 //y2=4.88
cc_644 ( N_noxref_3_c_544_n N_D_c_1735_n ) capacitor c=0.00142201f //x=9.74 \
 //y=5.295 //x2=9.03 //y2=4.88
cc_645 ( N_noxref_3_c_542_n Y ) capacitor c=0.00110342f //x=9.74 //y=2.605 \
 //x2=11.96 //y2=2.4
cc_646 ( N_noxref_3_c_544_n Y ) capacitor c=0.00358906f //x=9.74 //y=5.295 \
 //x2=11.96 //y2=2.4
cc_647 ( N_noxref_3_c_641_p Y ) capacitor c=0.00761377f //x=11.22 //y=2.605 \
 //x2=11.96 //y2=2.4
cc_648 ( N_noxref_3_c_611_p Y ) capacitor c=0.0149195f //x=11.22 //y=2.925 \
 //x2=11.96 //y2=2.4
cc_649 ( N_noxref_3_c_564_p Y ) capacitor c=0.0933965f //x=11.22 //y=4.76 \
 //x2=11.96 //y2=2.4
cc_650 ( N_noxref_3_c_644_p Y ) capacitor c=0.00347652f //x=11.22 //y=2.77 \
 //x2=11.96 //y2=2.4
cc_651 ( N_noxref_3_c_623_p Y ) capacitor c=0.00825076f //x=11.22 //y=2.265 \
 //x2=11.96 //y2=2.4
cc_652 ( N_noxref_3_c_718_p Y ) capacitor c=0.00687738f //x=11.22 //y=2.765 \
 //x2=11.96 //y2=2.4
cc_653 ( N_noxref_3_c_624_p Y ) capacitor c=0.0023016f //x=11.22 //y=2.265 \
 //x2=11.96 //y2=2.4
cc_654 ( N_noxref_3_c_570_p Y ) capacitor c=0.00250262f //x=11.22 //y=4.88 \
 //x2=11.96 //y2=2.4
cc_655 ( N_noxref_3_c_597_p Y ) capacitor c=4.08297e-19 //x=11.74 //y=4.97 \
 //x2=11.96 //y2=2.4
cc_656 ( N_noxref_3_c_593_p Y ) capacitor c=0.00124564f //x=11.45 //y=4.97 \
 //x2=11.96 //y2=2.4
cc_657 ( N_noxref_3_c_635_p Y ) capacitor c=0.00112403f //x=11.22 //y=2.265 \
 //x2=11.96 //y2=2.4
cc_658 ( N_noxref_3_c_539_n N_Y_c_1821_n ) capacitor c=0.00466656f //x=9.3 \
 //y=1.75 //x2=11.59 //y2=1.935
cc_659 ( N_noxref_3_c_619_p N_Y_c_1821_n ) capacitor c=0.00320561f //x=9.655 \
 //y=1.835 //x2=11.59 //y2=1.935
cc_660 ( N_noxref_3_c_726_p N_Y_c_1821_n ) capacitor c=0.00108934f //x=11.33 \
 //y=1.435 //x2=11.59 //y2=1.935
cc_661 ( N_noxref_3_c_659_p N_Y_c_1821_n ) capacitor c=0.00524682f //x=11.33 \
 //y=1.745 //x2=11.59 //y2=1.935
cc_662 ( N_noxref_3_c_648_p N_Y_c_1821_n ) capacitor c=0.00376309f //x=11.33 \
 //y=2.1 //x2=11.59 //y2=1.935
cc_663 ( N_noxref_3_c_729_p N_Y_c_1821_n ) capacitor c=0.00934265f //x=11.705 \
 //y=1.59 //x2=11.59 //y2=1.935
cc_664 ( N_noxref_3_c_663_p N_Y_c_1821_n ) capacitor c=0.00362207f //x=11.86 \
 //y=1.435 //x2=11.59 //y2=1.935
cc_665 ( N_noxref_3_c_563_p N_Y_c_1828_n ) capacitor c=0.00308961f //x=9.655 \
 //y=5.38 //x2=11.595 //y2=5.42
cc_666 ( N_noxref_3_c_566_p N_Y_c_1828_n ) capacitor c=5.44332e-19 //x=9.26 \
 //y=5.38 //x2=11.595 //y2=5.42
cc_667 ( N_noxref_3_M19_noxref_g N_Y_c_1828_n ) capacitor c=0.00141266f \
 //x=11.375 //y=6.2 //x2=11.595 //y2=5.42
cc_668 ( N_noxref_3_M20_noxref_g N_Y_c_1828_n ) capacitor c=0.00377331f \
 //x=11.815 //y=6.2 //x2=11.595 //y2=5.42
cc_669 ( N_noxref_3_c_729_p N_Y_c_1832_n ) capacitor c=0.00180253f //x=11.705 \
 //y=1.59 //x2=11.875 //y2=2.02
cc_670 ( N_noxref_3_c_542_n N_Y_c_1833_n ) capacitor c=0.00320561f //x=9.74 \
 //y=2.605 //x2=11.675 //y2=2.02
cc_671 ( N_noxref_3_c_635_p N_Y_c_1833_n ) capacitor c=0.00376309f //x=11.22 \
 //y=2.265 //x2=11.675 //y2=2.02
cc_672 ( N_noxref_3_M20_noxref_g N_Y_c_1835_n ) capacitor c=0.00966342f \
 //x=11.815 //y=6.2 //x2=11.875 //y2=5.14
cc_673 ( N_noxref_3_c_544_n N_Y_c_1836_n ) capacitor c=0.00291366f //x=9.74 \
 //y=5.295 //x2=11.68 //y2=5.14
cc_674 ( N_noxref_3_M19_noxref_g N_Y_c_1836_n ) capacitor c=0.00427521f \
 //x=11.375 //y=6.2 //x2=11.68 //y2=5.14
cc_675 ( N_noxref_3_c_597_p N_Y_c_1836_n ) capacitor c=0.00262283f //x=11.74 \
 //y=4.97 //x2=11.68 //y2=5.14
cc_676 ( N_noxref_3_c_539_n N_Y_c_1839_n ) capacitor c=6.23317e-19 //x=9.3 \
 //y=1.75 //x2=11.59 //y2=1.185
cc_677 ( N_noxref_3_c_554_n N_Y_c_1839_n ) capacitor c=0.00598594f //x=9.3 \
 //y=1.18 //x2=11.59 //y2=1.185
cc_678 ( N_noxref_3_c_634_p N_Y_c_1839_n ) capacitor c=0.00175305f //x=11.33 \
 //y=1.09 //x2=11.59 //y2=1.185
cc_679 ( N_noxref_3_c_726_p N_Y_c_1839_n ) capacitor c=0.00354487f //x=11.33 \
 //y=1.435 //x2=11.59 //y2=1.185
cc_680 ( N_noxref_3_c_661_p N_Y_c_1839_n ) capacitor c=5.57924e-19 //x=11.705 \
 //y=0.935 //x2=11.59 //y2=1.185
cc_681 ( N_noxref_3_c_729_p N_Y_c_1839_n ) capacitor c=5.75878e-19 //x=11.705 \
 //y=1.59 //x2=11.59 //y2=1.185
cc_682 ( N_noxref_3_c_636_p N_Y_c_1839_n ) capacitor c=0.00160969f //x=11.86 \
 //y=1.09 //x2=11.59 //y2=1.185
cc_683 ( N_noxref_3_c_663_p N_Y_c_1839_n ) capacitor c=0.00411132f //x=11.86 \
 //y=1.435 //x2=11.59 //y2=1.185
cc_684 ( N_noxref_3_M19_noxref_g N_Y_c_1847_n ) capacitor c=0.0162066f \
 //x=11.375 //y=6.2 //x2=11.595 //y2=5.56
cc_685 ( N_noxref_3_M20_noxref_g N_Y_c_1847_n ) capacitor c=0.0162066f \
 //x=11.815 //y=6.2 //x2=11.595 //y2=5.56
cc_686 ( N_noxref_3_c_597_p N_Y_c_1847_n ) capacitor c=0.00290963f //x=11.74 \
 //y=4.97 //x2=11.595 //y2=5.56
cc_687 ( N_noxref_3_c_634_p N_Y_M6_noxref_d ) capacitor c=0.00137914f \
 //x=11.33 //y=1.09 //x2=11.405 //y2=1.09
cc_688 ( N_noxref_3_c_726_p N_Y_M6_noxref_d ) capacitor c=0.0023891f //x=11.33 \
 //y=1.435 //x2=11.405 //y2=1.09
cc_689 ( N_noxref_3_c_661_p N_Y_M6_noxref_d ) capacitor c=0.0020782f \
 //x=11.705 //y=0.935 //x2=11.405 //y2=1.09
cc_690 ( N_noxref_3_c_729_p N_Y_M6_noxref_d ) capacitor c=0.00356097f \
 //x=11.705 //y=1.59 //x2=11.405 //y2=1.09
cc_691 ( N_noxref_3_c_636_p N_Y_M6_noxref_d ) capacitor c=0.00138452f \
 //x=11.86 //y=1.09 //x2=11.405 //y2=1.09
cc_692 ( N_noxref_3_c_663_p N_Y_M6_noxref_d ) capacitor c=0.00235934f \
 //x=11.86 //y=1.435 //x2=11.405 //y2=1.09
cc_693 ( N_noxref_3_c_541_n N_noxref_13_c_1959_n ) capacitor c=0.00911498f \
 //x=9.385 //y=1.835 //x2=8.815 //y2=1.675
cc_694 ( N_noxref_3_c_619_p N_noxref_13_c_1964_n ) capacitor c=0.00373013f \
 //x=9.655 //y=1.835 //x2=9.7 //y2=0.71
cc_695 ( N_noxref_3_c_554_n N_noxref_13_c_1964_n ) capacitor c=0.00367971f \
 //x=9.3 //y=1.18 //x2=9.7 //y2=0.71
cc_696 ( N_noxref_3_M5_noxref_d N_noxref_13_c_1964_n ) capacitor c=0.00910163f \
 //x=9.11 //y=1.085 //x2=9.7 //y2=0.71
cc_697 ( N_noxref_3_c_539_n N_noxref_13_M4_noxref_s ) capacitor c=0.0157502f \
 //x=9.3 //y=1.75 //x2=7.71 //y2=0.545
cc_698 ( N_noxref_3_c_619_p N_noxref_13_M4_noxref_s ) capacitor c=0.0055349f \
 //x=9.655 //y=1.835 //x2=7.71 //y2=0.545
cc_699 ( N_noxref_3_c_620_p N_noxref_13_M4_noxref_s ) capacitor c=7.90116e-19 \
 //x=9.74 //y=2.925 //x2=7.71 //y2=0.545
cc_700 ( N_noxref_3_c_554_n N_noxref_13_M4_noxref_s ) capacitor c=0.00897308f \
 //x=9.3 //y=1.18 //x2=7.71 //y2=0.545
cc_701 ( N_noxref_3_c_555_n N_noxref_13_M4_noxref_s ) capacitor c=0.00202552f \
 //x=9.74 //y=2.77 //x2=7.71 //y2=0.545
cc_702 ( N_noxref_3_M5_noxref_d N_noxref_13_M4_noxref_s ) capacitor \
 c=0.0275552f //x=9.11 //y=1.085 //x2=7.71 //y2=0.545
cc_703 ( N_VDD_c_790_n A ) capacitor c=0.0104242f //x=1.23 //y=7.58 //x2=1.6 \
 //y2=2.4
cc_704 ( N_VDD_c_769_n N_A_c_1005_n ) capacitor c=9.07241e-19 //x=4.965 \
 //y=7.585 //x2=1.6 //y2=4.88
cc_705 ( N_VDD_c_780_n N_A_c_1005_n ) capacitor c=6.28113e-19 //x=2.075 \
 //y=7.585 //x2=1.6 //y2=4.88
cc_706 ( N_VDD_c_790_n N_A_c_1005_n ) capacitor c=0.00867681f //x=1.23 \
 //y=7.58 //x2=1.6 //y2=4.88
cc_707 ( N_VDD_c_769_n N_A_c_1007_n ) capacitor c=6.22888e-19 //x=4.965 \
 //y=7.585 //x2=1.6 //y2=4.88
cc_708 ( N_VDD_c_790_n N_A_c_1007_n ) capacitor c=0.00370735f //x=1.23 \
 //y=7.58 //x2=1.6 //y2=4.88
cc_709 ( N_VDD_c_780_n N_A_M7_noxref_g ) capacitor c=0.00732618f //x=2.075 \
 //y=7.585 //x2=1.5 //y2=6.2
cc_710 ( N_VDD_M7_noxref_s N_A_M7_noxref_g ) capacitor c=0.0567929f //x=1.145 \
 //y=5.2 //x2=1.5 //y2=6.2
cc_711 ( N_VDD_c_780_n N_A_M8_noxref_g ) capacitor c=0.00755544f //x=2.075 \
 //y=7.585 //x2=1.94 //y2=6.2
cc_712 ( N_VDD_M8_noxref_d N_A_M8_noxref_g ) capacitor c=0.015318f //x=2.015 \
 //y=5.2 //x2=1.94 //y2=6.2
cc_713 ( N_VDD_c_790_n N_A_c_1014_n ) capacitor c=0.0234764f //x=1.23 //y=7.58 \
 //x2=1.6 //y2=4.88
cc_714 ( N_VDD_c_793_n N_B_c_1113_n ) capacitor c=0.00226427f //x=3.82 \
 //y=7.585 //x2=2.37 //y2=4.88
cc_715 ( N_VDD_c_783_n N_B_M9_noxref_g ) capacitor c=0.00697352f //x=2.955 \
 //y=7.585 //x2=2.38 //y2=6.2
cc_716 ( N_VDD_M8_noxref_d N_B_M9_noxref_g ) capacitor c=0.015318f //x=2.015 \
 //y=5.2 //x2=2.38 //y2=6.2
cc_717 ( N_VDD_c_783_n N_B_M10_noxref_g ) capacitor c=0.00755544f //x=2.955 \
 //y=7.585 //x2=2.82 //y2=6.2
cc_718 ( N_VDD_M10_noxref_d N_B_M10_noxref_g ) capacitor c=0.0430452f \
 //x=2.895 //y=5.2 //x2=2.82 //y2=6.2
cc_719 ( N_VDD_c_793_n N_B_c_1127_n ) capacitor c=0.0132232f //x=3.82 \
 //y=7.585 //x2=2.745 //y2=4.97
cc_720 ( N_VDD_c_793_n N_B_c_1145_n ) capacitor c=2.73429e-19 //x=3.82 \
 //y=7.585 //x2=2.37 //y2=4.88
cc_721 ( N_VDD_M8_noxref_d N_B_c_1145_n ) capacitor c=3.32552e-19 //x=2.015 \
 //y=5.2 //x2=2.37 //y2=4.88
cc_722 ( N_VDD_c_769_n N_noxref_7_c_1208_n ) capacitor c=0.00198753f //x=4.965 \
 //y=7.585 //x2=5.37 //y2=5.39
cc_723 ( N_VDD_c_776_n N_noxref_7_c_1208_n ) capacitor c=0.00495393f //x=5.05 \
 //y=7.035 //x2=5.37 //y2=5.39
cc_724 ( N_VDD_c_822_n N_noxref_7_c_1208_n ) capacitor c=0.00192799f //x=11.96 \
 //y=7.58 //x2=5.37 //y2=5.39
cc_725 ( N_VDD_c_788_n N_noxref_7_c_1208_n ) capacitor c=0.00433505f //x=6.98 \
 //y=7.585 //x2=5.37 //y2=5.39
cc_726 ( N_VDD_M11_noxref_d N_noxref_7_c_1208_n ) capacitor c=0.00655495f \
 //x=4.905 //y=5.205 //x2=5.37 //y2=5.39
cc_727 ( N_VDD_c_804_n N_noxref_7_c_1231_n ) capacitor c=0.00223213f //x=11.96 \
 //y=7.58 //x2=6.24 //y2=7.09
cc_728 ( N_VDD_c_793_n N_noxref_7_c_1214_n ) capacitor c=0.00766391f //x=3.82 \
 //y=7.585 //x2=4.61 //y2=5.39
cc_729 ( N_VDD_M7_noxref_s N_noxref_7_c_1214_n ) capacitor c=5.03296e-19 \
 //x=1.145 //y=5.2 //x2=4.61 //y2=5.39
cc_730 ( N_VDD_M15_noxref_s N_noxref_7_c_1221_n ) capacitor c=0.00111428f \
 //x=7.805 //y=5.2 //x2=5.49 //y2=5.39
cc_731 ( N_VDD_c_776_n N_noxref_7_c_1222_n ) capacitor c=0.0377581f //x=5.05 \
 //y=7.035 //x2=5.49 //y2=6.92
cc_732 ( N_VDD_c_778_n N_noxref_7_c_1222_n ) capacitor c=0.0104317f //x=5.05 \
 //y=7.41 //x2=5.49 //y2=6.92
cc_733 ( N_VDD_c_822_n N_noxref_7_c_1222_n ) capacitor c=0.0975191f //x=11.96 \
 //y=7.58 //x2=5.49 //y2=6.92
cc_734 ( N_VDD_c_788_n N_noxref_7_c_1222_n ) capacitor c=0.0204966f //x=6.98 \
 //y=7.585 //x2=5.49 //y2=6.92
cc_735 ( N_VDD_c_804_n N_noxref_7_c_1222_n ) capacitor c=0.00112916f //x=11.96 \
 //y=7.58 //x2=5.49 //y2=6.92
cc_736 ( N_VDD_M11_noxref_d N_noxref_7_c_1222_n ) capacitor c=0.00510287f \
 //x=4.905 //y=5.205 //x2=5.49 //y2=6.92
cc_737 ( N_VDD_c_776_n N_noxref_7_c_1238_n ) capacitor c=6.1128e-19 //x=5.05 \
 //y=7.035 //x2=6.37 //y2=6.92
cc_738 ( N_VDD_c_822_n N_noxref_7_c_1238_n ) capacitor c=0.00193184f //x=11.96 \
 //y=7.58 //x2=6.37 //y2=6.92
cc_739 ( N_VDD_c_788_n N_noxref_7_c_1238_n ) capacitor c=9.3761e-19 //x=6.98 \
 //y=7.585 //x2=6.37 //y2=6.92
cc_740 ( N_VDD_c_803_n N_noxref_7_c_1238_n ) capacitor c=0.0111101f //x=7.15 \
 //y=7.585 //x2=6.37 //y2=6.92
cc_741 ( N_VDD_c_804_n N_noxref_7_c_1238_n ) capacitor c=0.00112713f //x=11.96 \
 //y=7.58 //x2=6.37 //y2=6.92
cc_742 ( N_VDD_c_769_n N_noxref_7_c_1223_n ) capacitor c=0.00240365f //x=4.965 \
 //y=7.585 //x2=4.61 //y2=5.56
cc_743 ( N_VDD_c_776_n N_noxref_7_c_1223_n ) capacitor c=0.00220777f //x=5.05 \
 //y=7.035 //x2=4.61 //y2=5.56
cc_744 ( N_VDD_c_778_n N_noxref_7_c_1223_n ) capacitor c=0.00154298f //x=5.05 \
 //y=7.41 //x2=4.61 //y2=5.56
cc_745 ( N_VDD_c_788_n N_noxref_7_c_1223_n ) capacitor c=0.0126473f //x=6.98 \
 //y=7.585 //x2=4.61 //y2=5.56
cc_746 ( N_VDD_c_793_n N_noxref_7_c_1223_n ) capacitor c=0.0552885f //x=3.82 \
 //y=7.585 //x2=4.61 //y2=5.56
cc_747 ( N_VDD_c_804_n N_noxref_7_c_1223_n ) capacitor c=0.00161681f //x=11.96 \
 //y=7.58 //x2=4.61 //y2=5.56
cc_748 ( N_VDD_M10_noxref_d N_noxref_7_c_1223_n ) capacitor c=0.00271974f \
 //x=2.895 //y=5.2 //x2=4.61 //y2=5.56
cc_749 ( N_VDD_M11_noxref_d N_noxref_7_c_1223_n ) capacitor c=0.0736177f \
 //x=4.905 //y=5.205 //x2=4.61 //y2=5.56
cc_750 ( N_VDD_c_776_n N_noxref_7_c_1227_n ) capacitor c=0.00211426f //x=5.05 \
 //y=7.035 //x2=5.49 //y2=5.56
cc_751 ( N_VDD_c_778_n N_noxref_7_c_1227_n ) capacitor c=4.62894e-19 //x=5.05 \
 //y=7.41 //x2=5.49 //y2=5.56
cc_752 ( N_VDD_c_822_n N_noxref_7_c_1227_n ) capacitor c=0.00205411f //x=11.96 \
 //y=7.58 //x2=5.49 //y2=5.56
cc_753 ( N_VDD_c_788_n N_noxref_7_c_1227_n ) capacitor c=0.0085453f //x=6.98 \
 //y=7.585 //x2=5.49 //y2=5.56
cc_754 ( N_VDD_c_804_n N_noxref_7_c_1227_n ) capacitor c=0.00100828f //x=11.96 \
 //y=7.58 //x2=5.49 //y2=5.56
cc_755 ( N_VDD_M11_noxref_d N_noxref_7_c_1227_n ) capacitor c=0.0672707f \
 //x=4.905 //y=5.205 //x2=5.49 //y2=5.56
cc_756 ( N_VDD_c_769_n N_noxref_7_M11_noxref_s ) capacitor c=0.0245962f \
 //x=4.965 //y=7.585 //x2=4.475 //y2=5.205
cc_757 ( N_VDD_c_776_n N_noxref_7_M11_noxref_s ) capacitor c=0.0378001f \
 //x=5.05 //y=7.035 //x2=4.475 //y2=5.205
cc_758 ( N_VDD_c_778_n N_noxref_7_M11_noxref_s ) capacitor c=0.0124823f \
 //x=5.05 //y=7.41 //x2=4.475 //y2=5.205
cc_759 ( N_VDD_c_788_n N_noxref_7_M11_noxref_s ) capacitor c=0.00293047f \
 //x=6.98 //y=7.585 //x2=4.475 //y2=5.205
cc_760 ( N_VDD_c_793_n N_noxref_7_M11_noxref_s ) capacitor c=0.00933367f \
 //x=3.82 //y=7.585 //x2=4.475 //y2=5.205
cc_761 ( N_VDD_c_804_n N_noxref_7_M11_noxref_s ) capacitor c=0.00129282f \
 //x=11.96 //y=7.58 //x2=4.475 //y2=5.205
cc_762 ( N_VDD_M11_noxref_d N_noxref_7_M11_noxref_s ) capacitor c=0.00566597f \
 //x=4.905 //y=5.205 //x2=4.475 //y2=5.205
cc_763 ( N_VDD_c_822_n N_noxref_7_M14_noxref_d ) capacitor c=0.00206569f \
 //x=11.96 //y=7.58 //x2=6.225 //y2=5.205
cc_764 ( N_VDD_c_788_n N_noxref_7_M14_noxref_d ) capacitor c=0.00856914f \
 //x=6.98 //y=7.585 //x2=6.225 //y2=5.205
cc_765 ( N_VDD_c_803_n N_noxref_7_M14_noxref_d ) capacitor c=0.0437918f \
 //x=7.15 //y=7.585 //x2=6.225 //y2=5.205
cc_766 ( N_VDD_c_804_n N_noxref_7_M14_noxref_d ) capacitor c=0.00100487f \
 //x=11.96 //y=7.58 //x2=6.225 //y2=5.205
cc_767 ( N_VDD_M15_noxref_s N_noxref_7_M14_noxref_d ) capacitor c=0.00249213f \
 //x=7.805 //y=5.2 //x2=6.225 //y2=5.205
cc_768 ( N_VDD_c_803_n N_C_c_1320_n ) capacitor c=0.00231379f //x=7.15 \
 //y=7.585 //x2=5.705 //y2=4.885
cc_769 ( N_VDD_c_788_n N_C_M13_noxref_g ) capacitor c=0.00724816f //x=6.98 \
 //y=7.585 //x2=5.71 //y2=6.205
cc_770 ( N_VDD_c_788_n N_C_M14_noxref_g ) capacitor c=0.00782837f //x=6.98 \
 //y=7.585 //x2=6.15 //y2=6.205
cc_771 ( N_VDD_c_803_n N_C_c_1373_n ) capacitor c=0.016784f //x=7.15 //y=7.585 \
 //x2=6.075 //y2=4.975
cc_772 ( N_VDD_c_803_n N_C_c_1341_n ) capacitor c=2.75092e-19 //x=7.15 \
 //y=7.585 //x2=5.705 //y2=4.885
cc_773 ( N_VDD_c_790_n N_GND_c_1432_n ) capacitor c=0.00989514f //x=1.23 \
 //y=7.58 //x2=1.23 //y2=0.18
cc_774 ( N_VDD_c_793_n N_GND_c_1440_n ) capacitor c=0.00970423f //x=3.82 \
 //y=7.585 //x2=3.82 //y2=0.175
cc_775 ( N_VDD_c_803_n N_GND_c_1491_n ) capacitor c=0.00970423f //x=7.15 \
 //y=7.585 //x2=7.15 //y2=0.175
cc_776 ( N_VDD_c_869_n N_GND_c_1541_n ) capacitor c=0.00970423f //x=10.48 \
 //y=7.585 //x2=10.48 //y2=0.175
cc_777 ( N_VDD_c_804_n N_GND_c_1451_n ) capacitor c=0.00989514f //x=11.96 \
 //y=7.58 //x2=12.08 //y2=0.175
cc_778 ( N_VDD_c_869_n N_D_c_1716_n ) capacitor c=0.00226427f //x=10.48 \
 //y=7.585 //x2=9.03 //y2=4.88
cc_779 ( N_VDD_c_858_n N_D_M17_noxref_g ) capacitor c=0.00697352f //x=9.615 \
 //y=7.585 //x2=9.04 //y2=6.2
cc_780 ( N_VDD_M16_noxref_d N_D_M17_noxref_g ) capacitor c=0.015318f //x=8.675 \
 //y=5.2 //x2=9.04 //y2=6.2
cc_781 ( N_VDD_c_858_n N_D_M18_noxref_g ) capacitor c=0.00755544f //x=9.615 \
 //y=7.585 //x2=9.48 //y2=6.2
cc_782 ( N_VDD_M18_noxref_d N_D_M18_noxref_g ) capacitor c=0.0430452f \
 //x=9.555 //y=5.2 //x2=9.48 //y2=6.2
cc_783 ( N_VDD_c_869_n N_D_c_1764_n ) capacitor c=0.0129375f //x=10.48 \
 //y=7.585 //x2=9.405 //y2=4.97
cc_784 ( N_VDD_c_869_n N_D_c_1735_n ) capacitor c=2.73429e-19 //x=10.48 \
 //y=7.585 //x2=9.03 //y2=4.88
cc_785 ( N_VDD_M16_noxref_d N_D_c_1735_n ) capacitor c=3.32552e-19 //x=8.675 \
 //y=5.2 //x2=9.03 //y2=4.88
cc_786 ( N_VDD_c_804_n Y ) capacitor c=0.0297606f //x=11.96 //y=7.58 \
 //x2=11.96 //y2=2.4
cc_787 ( N_VDD_c_822_n N_Y_c_1828_n ) capacitor c=0.00259721f //x=11.96 \
 //y=7.58 //x2=11.595 //y2=5.42
cc_788 ( N_VDD_c_863_n N_Y_c_1828_n ) capacitor c=0.00100699f //x=11.95 \
 //y=7.585 //x2=11.595 //y2=5.42
cc_789 ( N_VDD_c_804_n N_Y_c_1828_n ) capacitor c=0.00295945f //x=11.96 \
 //y=7.58 //x2=11.595 //y2=5.42
cc_790 ( N_VDD_M15_noxref_s N_Y_c_1828_n ) capacitor c=2.62188e-19 //x=7.805 \
 //y=5.2 //x2=11.595 //y2=5.42
cc_791 ( N_VDD_M19_noxref_s N_Y_c_1828_n ) capacitor c=0.0465774f //x=11.02 \
 //y=5.2 //x2=11.595 //y2=5.42
cc_792 ( N_VDD_M20_noxref_d N_Y_c_1828_n ) capacitor c=0.0486749f //x=11.89 \
 //y=5.2 //x2=11.595 //y2=5.42
cc_793 ( N_VDD_c_822_n N_Y_c_1835_n ) capacitor c=0.00199795f //x=11.96 \
 //y=7.58 //x2=11.875 //y2=5.14
cc_794 ( N_VDD_c_863_n N_Y_c_1835_n ) capacitor c=0.00207379f //x=11.95 \
 //y=7.585 //x2=11.875 //y2=5.14
cc_795 ( N_VDD_M20_noxref_d N_Y_c_1835_n ) capacitor c=0.0235609f //x=11.89 \
 //y=5.2 //x2=11.875 //y2=5.14
cc_796 ( N_VDD_c_869_n N_Y_c_1836_n ) capacitor c=0.00464635f //x=10.48 \
 //y=7.585 //x2=11.68 //y2=5.14
cc_797 ( N_VDD_c_822_n N_Y_c_1847_n ) capacitor c=0.00241566f //x=11.96 \
 //y=7.58 //x2=11.595 //y2=5.56
cc_798 ( N_VDD_c_863_n N_Y_c_1847_n ) capacitor c=0.0138017f //x=11.95 \
 //y=7.585 //x2=11.595 //y2=5.56
cc_799 ( N_VDD_c_869_n N_Y_c_1847_n ) capacitor c=0.00821941f //x=10.48 \
 //y=7.585 //x2=11.595 //y2=5.56
cc_800 ( N_VDD_c_804_n N_Y_c_1847_n ) capacitor c=0.00961566f //x=11.96 \
 //y=7.58 //x2=11.595 //y2=5.56
cc_801 ( N_VDD_M19_noxref_s N_Y_c_1847_n ) capacitor c=0.0900053f //x=11.02 \
 //y=5.2 //x2=11.595 //y2=5.56
cc_802 ( N_VDD_M20_noxref_d N_Y_c_1847_n ) capacitor c=0.0930425f //x=11.89 \
 //y=5.2 //x2=11.595 //y2=5.56
cc_803 ( A B ) capacitor c=0.109381f //x=1.6 //y=2.4 //x2=2.34 //y2=2.4
cc_804 ( N_A_c_1028_p B ) capacitor c=3.49899e-19 //x=1.6 //y=2.26 //x2=2.34 \
 //y2=2.4
cc_805 ( N_A_c_1007_n B ) capacitor c=3.02466e-19 //x=1.6 //y=4.88 //x2=2.34 \
 //y2=2.4
cc_806 ( N_A_c_1014_n B ) capacitor c=0.00108965f //x=1.6 //y=4.88 //x2=2.34 \
 //y2=2.4
cc_807 ( N_A_c_1005_n N_B_c_1108_n ) capacitor c=0.0172939f //x=1.6 //y=4.88 \
 //x2=2.34 //y2=4.735
cc_808 ( N_A_c_1007_n N_B_c_1108_n ) capacitor c=4.73677e-19 //x=1.6 //y=4.88 \
 //x2=2.34 //y2=4.735
cc_809 ( N_A_c_1014_n N_B_c_1108_n ) capacitor c=9.22067e-19 //x=1.6 //y=4.88 \
 //x2=2.34 //y2=4.735
cc_810 ( N_A_c_1034_p N_B_c_1110_n ) capacitor c=0.0205342f //x=1.6 //y=2.26 \
 //x2=2.34 //y2=2.26
cc_811 ( N_A_c_1028_p N_B_c_1110_n ) capacitor c=5.16867e-19 //x=1.6 //y=2.26 \
 //x2=2.34 //y2=2.26
cc_812 ( N_A_c_1036_p N_B_c_1110_n ) capacitor c=0.00167888f //x=1.405 \
 //y=2.095 //x2=2.34 //y2=2.26
cc_813 ( A N_B_c_1112_n ) capacitor c=3.49899e-19 //x=1.6 //y=2.4 //x2=2.34 \
 //y2=2.26
cc_814 ( N_A_c_1034_p N_B_c_1112_n ) capacitor c=0.00370824f //x=1.6 //y=2.26 \
 //x2=2.34 //y2=2.26
cc_815 ( N_A_c_1028_p N_B_c_1112_n ) capacitor c=0.00445529f //x=1.6 //y=2.26 \
 //x2=2.34 //y2=2.26
cc_816 ( N_A_c_1036_p N_B_c_1112_n ) capacitor c=0.00267961f //x=1.405 \
 //y=2.095 //x2=2.34 //y2=2.26
cc_817 ( A N_B_c_1113_n ) capacitor c=2.1563e-19 //x=1.6 //y=2.4 //x2=2.37 \
 //y2=4.88
cc_818 ( N_A_c_1005_n N_B_c_1113_n ) capacitor c=0.00389735f //x=1.6 //y=4.88 \
 //x2=2.37 //y2=4.88
cc_819 ( N_A_c_1007_n N_B_c_1113_n ) capacitor c=0.00397338f //x=1.6 //y=4.88 \
 //x2=2.37 //y2=4.88
cc_820 ( N_A_c_1014_n N_B_c_1113_n ) capacitor c=0.00283894f //x=1.6 //y=4.88 \
 //x2=2.37 //y2=4.88
cc_821 ( N_A_M7_noxref_g N_B_M9_noxref_g ) capacitor c=0.0104892f //x=1.5 \
 //y=6.2 //x2=2.38 //y2=6.2
cc_822 ( N_A_M8_noxref_g N_B_M9_noxref_g ) capacitor c=0.107636f //x=1.94 \
 //y=6.2 //x2=2.38 //y2=6.2
cc_823 ( N_A_M8_noxref_g N_B_M10_noxref_g ) capacitor c=0.0100341f //x=1.94 \
 //y=6.2 //x2=2.82 //y2=6.2
cc_824 ( N_A_c_1048_p N_B_c_1121_n ) capacitor c=4.86545e-19 //x=1.405 \
 //y=1.045 //x2=2.375 //y2=1.085
cc_825 ( N_A_c_1049_p N_B_c_1121_n ) capacitor c=0.00152405f //x=1.405 \
 //y=1.39 //x2=2.375 //y2=1.085
cc_826 ( N_A_c_1050_p N_B_c_1121_n ) capacitor c=0.0151475f //x=1.935 \
 //y=1.045 //x2=2.375 //y2=1.085
cc_827 ( N_A_c_1051_p N_B_c_1123_n ) capacitor c=0.00109982f //x=1.405 //y=1.7 \
 //x2=2.375 //y2=1.43
cc_828 ( N_A_c_1052_p N_B_c_1123_n ) capacitor c=0.0111064f //x=1.935 //y=1.39 \
 //x2=2.375 //y2=1.43
cc_829 ( N_A_c_1051_p N_B_c_1126_n ) capacitor c=9.58243e-19 //x=1.405 //y=1.7 \
 //x2=2.375 //y2=1.74
cc_830 ( N_A_c_1036_p N_B_c_1126_n ) capacitor c=0.00662747f //x=1.405 \
 //y=2.095 //x2=2.375 //y2=1.74
cc_831 ( N_A_c_1052_p N_B_c_1126_n ) capacitor c=0.00862358f //x=1.935 \
 //y=1.39 //x2=2.375 //y2=1.74
cc_832 ( N_A_c_1050_p N_B_c_1136_n ) capacitor c=0.00127211f //x=1.935 \
 //y=1.045 //x2=2.905 //y2=1.085
cc_833 ( N_A_c_1052_p N_B_c_1138_n ) capacitor c=0.00204774f //x=1.935 \
 //y=1.39 //x2=2.905 //y2=1.43
cc_834 ( N_A_c_1034_p N_B_c_1142_n ) capacitor c=0.00167305f //x=1.6 //y=2.26 \
 //x2=2.34 //y2=2.26
cc_835 ( N_A_c_1028_p N_B_c_1142_n ) capacitor c=0.00266443f //x=1.6 //y=2.26 \
 //x2=2.34 //y2=2.26
cc_836 ( N_A_c_1036_p N_B_c_1142_n ) capacitor c=0.0181449f //x=1.405 \
 //y=2.095 //x2=2.34 //y2=2.26
cc_837 ( N_A_c_1005_n N_B_c_1145_n ) capacitor c=0.00158715f //x=1.6 //y=4.88 \
 //x2=2.37 //y2=4.88
cc_838 ( N_A_c_1007_n N_B_c_1145_n ) capacitor c=0.00237977f //x=1.6 //y=4.88 \
 //x2=2.37 //y2=4.88
cc_839 ( N_A_c_1014_n N_B_c_1145_n ) capacitor c=0.0297875f //x=1.6 //y=4.88 \
 //x2=2.37 //y2=4.88
cc_840 ( N_A_c_1034_p N_GND_c_1573_n ) capacitor c=6.6172e-19 //x=1.6 //y=2.26 \
 //x2=1.585 //y2=0.175
cc_841 ( N_A_c_1034_p N_GND_c_1427_n ) capacitor c=0.00709624f //x=1.6 \
 //y=2.26 //x2=1.67 //y2=1.135
cc_842 ( N_A_c_1028_p N_GND_c_1427_n ) capacitor c=2.13705e-19 //x=1.6 \
 //y=2.26 //x2=1.67 //y2=1.135
cc_843 ( N_A_c_1048_p N_GND_c_1427_n ) capacitor c=0.00156094f //x=1.405 \
 //y=1.045 //x2=1.67 //y2=1.135
cc_844 ( N_A_c_1049_p N_GND_c_1427_n ) capacitor c=0.00413828f //x=1.405 \
 //y=1.39 //x2=1.67 //y2=1.135
cc_845 ( N_A_c_1051_p N_GND_c_1427_n ) capacitor c=4.2764e-19 //x=1.405 \
 //y=1.7 //x2=1.67 //y2=1.135
cc_846 ( N_A_c_1070_p N_GND_c_1427_n ) capacitor c=7.35788e-19 //x=1.78 \
 //y=0.89 //x2=1.67 //y2=1.135
cc_847 ( N_A_c_1071_p N_GND_c_1427_n ) capacitor c=6.38426e-19 //x=1.78 \
 //y=1.545 //x2=1.67 //y2=1.135
cc_848 ( N_A_c_1050_p N_GND_c_1427_n ) capacitor c=0.00172871f //x=1.935 \
 //y=1.045 //x2=1.67 //y2=1.135
cc_849 ( N_A_c_1052_p N_GND_c_1427_n ) capacitor c=0.00296337f //x=1.935 \
 //y=1.39 //x2=1.67 //y2=1.135
cc_850 ( N_A_c_1048_p N_GND_c_1583_n ) capacitor c=3.51399e-19 //x=1.405 \
 //y=1.045 //x2=1.667 //y2=1.005
cc_851 ( N_A_c_1070_p N_GND_c_1583_n ) capacitor c=0.00864609f //x=1.78 \
 //y=0.89 //x2=1.667 //y2=1.005
cc_852 ( N_A_c_1050_p N_GND_c_1583_n ) capacitor c=4.45447e-19 //x=1.935 \
 //y=1.045 //x2=1.667 //y2=1.005
cc_853 ( N_A_c_1048_p N_GND_c_1430_n ) capacitor c=0.00690758f //x=1.405 \
 //y=1.045 //x2=3.65 //y2=0.175
cc_854 ( A N_GND_c_1432_n ) capacitor c=0.0113199f //x=1.6 //y=2.4 //x2=1.23 \
 //y2=0.18
cc_855 ( N_A_c_1034_p N_GND_c_1432_n ) capacitor c=0.0082376f //x=1.6 //y=2.26 \
 //x2=1.23 //y2=0.18
cc_856 ( N_A_c_1028_p N_GND_c_1432_n ) capacitor c=0.00369668f //x=1.6 \
 //y=2.26 //x2=1.23 //y2=0.18
cc_857 ( N_A_c_1051_p N_GND_c_1432_n ) capacitor c=0.0015404f //x=1.405 \
 //y=1.7 //x2=1.23 //y2=0.18
cc_858 ( N_A_c_1036_p N_GND_c_1432_n ) capacitor c=0.00950704f //x=1.405 \
 //y=2.095 //x2=1.23 //y2=0.18
cc_859 ( N_A_c_1034_p N_GND_M0_noxref_d ) capacitor c=2.20438e-19 //x=1.6 \
 //y=2.26 //x2=1.48 //y2=1.045
cc_860 ( N_A_c_1048_p N_GND_M0_noxref_d ) capacitor c=0.00192399f //x=1.405 \
 //y=1.045 //x2=1.48 //y2=1.045
cc_861 ( N_A_c_1049_p N_GND_M0_noxref_d ) capacitor c=0.00210798f //x=1.405 \
 //y=1.39 //x2=1.48 //y2=1.045
cc_862 ( N_A_c_1070_p N_GND_M0_noxref_d ) capacitor c=0.00472259f //x=1.78 \
 //y=0.89 //x2=1.48 //y2=1.045
cc_863 ( N_A_c_1071_p N_GND_M0_noxref_d ) capacitor c=0.00166857f //x=1.78 \
 //y=1.545 //x2=1.48 //y2=1.045
cc_864 ( N_A_c_1050_p N_GND_M0_noxref_d ) capacitor c=0.00230174f //x=1.935 \
 //y=1.045 //x2=1.48 //y2=1.045
cc_865 ( N_A_c_1052_p N_GND_M0_noxref_d ) capacitor c=0.00210798f //x=1.935 \
 //y=1.39 //x2=1.48 //y2=1.045
cc_866 ( N_A_c_1036_p N_noxref_12_c_1898_n ) capacitor c=0.00262672f //x=1.405 \
 //y=2.095 //x2=1.185 //y2=1.675
cc_867 ( N_A_c_1034_p N_noxref_12_c_1899_n ) capacitor c=0.00459552f //x=1.6 \
 //y=2.26 //x2=2.07 //y2=1.76
cc_868 ( N_A_c_1028_p N_noxref_12_c_1899_n ) capacitor c=0.00763108f //x=1.6 \
 //y=2.26 //x2=2.07 //y2=1.76
cc_869 ( N_A_c_1051_p N_noxref_12_c_1899_n ) capacitor c=0.00695869f //x=1.405 \
 //y=1.7 //x2=2.07 //y2=1.76
cc_870 ( N_A_c_1036_p N_noxref_12_c_1899_n ) capacitor c=0.0194861f //x=1.405 \
 //y=2.095 //x2=2.07 //y2=1.76
cc_871 ( N_A_c_1071_p N_noxref_12_c_1899_n ) capacitor c=0.00723574f //x=1.78 \
 //y=1.545 //x2=2.07 //y2=1.76
cc_872 ( N_A_c_1052_p N_noxref_12_c_1899_n ) capacitor c=0.00399755f //x=1.935 \
 //y=1.39 //x2=2.07 //y2=1.76
cc_873 ( N_A_c_1036_p N_noxref_12_c_1888_n ) capacitor c=6.71402e-19 //x=1.405 \
 //y=2.095 //x2=2.155 //y2=1.675
cc_874 ( N_A_c_1048_p N_noxref_12_M0_noxref_s ) capacitor c=0.0294925f \
 //x=1.405 //y=1.045 //x2=1.05 //y2=0.545
cc_875 ( N_A_c_1051_p N_noxref_12_M0_noxref_s ) capacitor c=3.48408e-19 \
 //x=1.405 //y=1.7 //x2=1.05 //y2=0.545
cc_876 ( N_A_c_1050_p N_noxref_12_M0_noxref_s ) capacitor c=0.0125442f \
 //x=1.935 //y=1.045 //x2=1.05 //y2=0.545
cc_877 ( N_B_c_1110_n N_GND_c_1421_n ) capacitor c=0.00234561f //x=2.34 \
 //y=2.26 //x2=8.245 //y2=0.175
cc_878 ( N_B_c_1110_n N_GND_c_1430_n ) capacitor c=3.77328e-19 //x=2.34 \
 //y=2.26 //x2=3.65 //y2=0.175
cc_879 ( N_B_c_1112_n N_GND_c_1440_n ) capacitor c=0.00224736f //x=2.34 \
 //y=2.26 //x2=3.82 //y2=0.175
cc_880 ( N_B_c_1138_n N_GND_c_1440_n ) capacitor c=0.00275184f //x=2.905 \
 //y=1.43 //x2=3.82 //y2=0.175
cc_881 ( N_B_c_1142_n N_GND_c_1440_n ) capacitor c=2.63786e-19 //x=2.34 \
 //y=2.26 //x2=3.82 //y2=0.175
cc_882 ( N_B_c_1110_n N_noxref_12_c_1888_n ) capacitor c=7.471e-19 //x=2.34 \
 //y=2.26 //x2=2.155 //y2=1.675
cc_883 ( N_B_c_1126_n N_noxref_12_c_1888_n ) capacitor c=0.00888238f //x=2.375 \
 //y=1.74 //x2=2.155 //y2=1.675
cc_884 ( N_B_c_1142_n N_noxref_12_c_1888_n ) capacitor c=0.00173073f //x=2.34 \
 //y=2.26 //x2=2.155 //y2=1.675
cc_885 ( N_B_c_1110_n N_noxref_12_c_1889_n ) capacitor c=0.00141156f //x=2.34 \
 //y=2.26 //x2=3.04 //y2=0.71
cc_886 ( N_B_c_1112_n N_noxref_12_c_1889_n ) capacitor c=8.82141e-19 //x=2.34 \
 //y=2.26 //x2=3.04 //y2=0.71
cc_887 ( N_B_c_1121_n N_noxref_12_c_1889_n ) capacitor c=0.0199501f //x=2.375 \
 //y=1.085 //x2=3.04 //y2=0.71
cc_888 ( N_B_c_1136_n N_noxref_12_c_1889_n ) capacitor c=0.00825432f //x=2.905 \
 //y=1.085 //x2=3.04 //y2=0.71
cc_889 ( N_B_c_1142_n N_noxref_12_c_1889_n ) capacitor c=2.1838e-19 //x=2.34 \
 //y=2.26 //x2=3.04 //y2=0.71
cc_890 ( N_B_c_1121_n N_noxref_12_M0_noxref_s ) capacitor c=0.00888238f \
 //x=2.375 //y=1.085 //x2=1.05 //y2=0.545
cc_891 ( N_B_c_1136_n N_noxref_12_M0_noxref_s ) capacitor c=0.015333f \
 //x=2.905 //y=1.085 //x2=1.05 //y2=0.545
cc_892 ( N_B_c_1138_n N_noxref_12_M0_noxref_s ) capacitor c=0.00248746f \
 //x=2.905 //y=1.43 //x2=1.05 //y2=0.545
cc_893 ( N_noxref_7_c_1221_n N_C_c_1310_n ) capacitor c=7.31659e-19 //x=5.49 \
 //y=5.39 //x2=5.67 //y2=2.26
cc_894 ( N_noxref_7_c_1231_n N_C_c_1313_n ) capacitor c=0.00213985f //x=6.24 \
 //y=7.09 //x2=5.705 //y2=4.885
cc_895 ( N_noxref_7_c_1221_n N_C_c_1313_n ) capacitor c=0.00262304f //x=5.49 \
 //y=5.39 //x2=5.705 //y2=4.885
cc_896 ( N_noxref_7_c_1231_n N_C_c_1320_n ) capacitor c=0.00233585f //x=6.24 \
 //y=7.09 //x2=5.705 //y2=4.885
cc_897 ( N_noxref_7_c_1231_n N_C_M13_noxref_g ) capacitor c=0.00777443f \
 //x=6.24 //y=7.09 //x2=5.71 //y2=6.205
cc_898 ( N_noxref_7_c_1221_n N_C_M13_noxref_g ) capacitor c=0.00176767f \
 //x=5.49 //y=5.39 //x2=5.71 //y2=6.205
cc_899 ( N_noxref_7_c_1222_n N_C_M13_noxref_g ) capacitor c=0.00186228f \
 //x=5.49 //y=6.92 //x2=5.71 //y2=6.205
cc_900 ( N_noxref_7_c_1227_n N_C_M13_noxref_g ) capacitor c=0.0170175f \
 //x=5.49 //y=5.56 //x2=5.71 //y2=6.205
cc_901 ( N_noxref_7_c_1231_n N_C_M14_noxref_g ) capacitor c=0.0093887f \
 //x=6.24 //y=7.09 //x2=6.15 //y2=6.205
cc_902 ( N_noxref_7_c_1238_n N_C_M14_noxref_g ) capacitor c=0.00410728f \
 //x=6.37 //y=6.92 //x2=6.15 //y2=6.205
cc_903 ( N_noxref_7_M14_noxref_d N_C_M14_noxref_g ) capacitor c=0.0365939f \
 //x=6.225 //y=5.205 //x2=6.15 //y2=6.205
cc_904 ( N_noxref_7_c_1221_n N_C_c_1341_n ) capacitor c=6.45633e-19 //x=5.49 \
 //y=5.39 //x2=5.705 //y2=4.885
cc_905 ( N_C_c_1310_n N_GND_c_1484_n ) capacitor c=6.61292e-19 //x=5.67 \
 //y=2.26 //x2=6.37 //y2=0.71
cc_906 ( N_C_c_1316_n N_GND_c_1484_n ) capacitor c=8.64363e-19 //x=5.67 \
 //y=2.26 //x2=6.37 //y2=0.71
cc_907 ( N_C_c_1327_n N_GND_c_1484_n ) capacitor c=0.0210318f //x=5.705 \
 //y=1.085 //x2=6.37 //y2=0.71
cc_908 ( N_C_c_1335_n N_GND_c_1484_n ) capacitor c=0.00825432f //x=6.235 \
 //y=1.085 //x2=6.37 //y2=0.71
cc_909 ( N_C_c_1337_n N_GND_c_1484_n ) capacitor c=2.1838e-19 //x=5.67 \
 //y=2.26 //x2=6.37 //y2=0.71
cc_910 ( N_C_c_1316_n N_GND_c_1491_n ) capacitor c=0.00224736f //x=5.67 \
 //y=2.26 //x2=7.15 //y2=0.175
cc_911 ( N_C_c_1334_n N_GND_c_1491_n ) capacitor c=0.0028635f //x=6.08 \
 //y=1.585 //x2=7.15 //y2=0.175
cc_912 ( N_C_c_1337_n N_GND_c_1491_n ) capacitor c=2.63786e-19 //x=5.67 \
 //y=2.26 //x2=7.15 //y2=0.175
cc_913 ( N_C_c_1327_n N_GND_M2_noxref_s ) capacitor c=0.00720961f //x=5.705 \
 //y=1.085 //x2=4.38 //y2=0.545
cc_914 ( N_C_c_1334_n N_GND_M2_noxref_s ) capacitor c=0.00271091f //x=6.08 \
 //y=1.585 //x2=4.38 //y2=0.545
cc_915 ( N_C_c_1335_n N_GND_M2_noxref_s ) capacitor c=0.0151996f //x=6.235 \
 //y=1.085 //x2=4.38 //y2=0.545
cc_916 ( N_C_c_1337_n N_GND_M2_noxref_s ) capacitor c=0.00119136f //x=5.67 \
 //y=2.26 //x2=4.38 //y2=0.545
cc_917 ( N_GND_c_1522_n N_D_c_1709_n ) capacitor c=0.00234561f //x=11.96 \
 //y=0.18 //x2=9 //y2=2.26
cc_918 ( N_GND_c_1489_n N_D_c_1709_n ) capacitor c=3.77328e-19 //x=10.31 \
 //y=0.175 //x2=9 //y2=2.26
cc_919 ( N_GND_c_1541_n N_D_c_1712_n ) capacitor c=0.00224736f //x=10.48 \
 //y=0.175 //x2=9 //y2=2.26
cc_920 ( N_GND_c_1541_n N_D_c_1731_n ) capacitor c=0.00275184f //x=10.48 \
 //y=0.175 //x2=9.565 //y2=1.43
cc_921 ( N_GND_c_1541_n N_D_c_1732_n ) capacitor c=2.63786e-19 //x=10.48 \
 //y=0.175 //x2=9 //y2=2.26
cc_922 ( N_GND_c_1541_n N_Y_c_1821_n ) capacitor c=0.00272952f //x=10.48 \
 //y=0.175 //x2=11.59 //y2=1.935
cc_923 ( N_GND_c_1451_n N_Y_c_1821_n ) capacitor c=0.00122336f //x=12.08 \
 //y=0.175 //x2=11.59 //y2=1.935
cc_924 ( N_GND_M6_noxref_s N_Y_c_1821_n ) capacitor c=0.0325324f //x=10.975 \
 //y=0.55 //x2=11.59 //y2=1.935
cc_925 ( N_GND_c_1522_n N_Y_c_1832_n ) capacitor c=0.00497604f //x=11.96 \
 //y=0.18 //x2=11.875 //y2=2.02
cc_926 ( N_GND_c_1539_n N_Y_c_1832_n ) capacitor c=0.00321695f //x=11.995 \
 //y=0.715 //x2=11.875 //y2=2.02
cc_927 ( N_GND_c_1451_n N_Y_c_1832_n ) capacitor c=0.0298335f //x=12.08 \
 //y=0.175 //x2=11.875 //y2=2.02
cc_928 ( N_GND_M6_noxref_s N_Y_c_1832_n ) capacitor c=0.00565821f //x=10.975 \
 //y=0.55 //x2=11.875 //y2=2.02
cc_929 ( N_GND_c_1522_n N_Y_c_1839_n ) capacitor c=0.00998676f //x=11.96 \
 //y=0.18 //x2=11.59 //y2=1.185
cc_930 ( N_GND_c_1534_n N_Y_c_1839_n ) capacitor c=0.00124813f //x=11.505 \
 //y=0.715 //x2=11.59 //y2=1.185
cc_931 ( N_GND_c_1539_n N_Y_c_1839_n ) capacitor c=0.00130539f //x=11.995 \
 //y=0.715 //x2=11.59 //y2=1.185
cc_932 ( N_GND_c_1451_n N_Y_c_1839_n ) capacitor c=2.8029e-19 //x=12.08 \
 //y=0.175 //x2=11.59 //y2=1.185
cc_933 ( N_GND_M6_noxref_s N_Y_c_1839_n ) capacitor c=0.0156214f //x=10.975 \
 //y=0.55 //x2=11.59 //y2=1.185
cc_934 ( N_GND_c_1522_n N_Y_M6_noxref_d ) capacitor c=0.00119455f //x=11.96 \
 //y=0.18 //x2=11.405 //y2=1.09
cc_935 ( N_GND_c_1451_n N_Y_M6_noxref_d ) capacitor c=2.70835e-19 //x=12.08 \
 //y=0.175 //x2=11.405 //y2=1.09
cc_936 ( N_GND_M6_noxref_s N_Y_M6_noxref_d ) capacitor c=0.0377642f //x=10.975 \
 //y=0.55 //x2=11.405 //y2=1.09
cc_937 ( N_GND_c_1573_n N_noxref_12_c_1899_n ) capacitor c=0.00275848f \
 //x=1.585 //y=0.175 //x2=2.07 //y2=1.76
cc_938 ( N_GND_c_1421_n N_noxref_12_c_1899_n ) capacitor c=7.74325e-19 \
 //x=8.245 //y=0.175 //x2=2.07 //y2=1.76
cc_939 ( N_GND_c_1427_n N_noxref_12_c_1899_n ) capacitor c=0.00407714f \
 //x=1.67 //y=1.135 //x2=2.07 //y2=1.76
cc_940 ( N_GND_c_1430_n N_noxref_12_c_1899_n ) capacitor c=0.00375345f \
 //x=3.65 //y=0.175 //x2=2.07 //y2=1.76
cc_941 ( N_GND_M0_noxref_d N_noxref_12_c_1899_n ) capacitor c=0.00578453f \
 //x=1.48 //y=1.045 //x2=2.07 //y2=1.76
cc_942 ( N_GND_c_1421_n N_noxref_12_c_1925_n ) capacitor c=0.0068323f \
 //x=8.245 //y=0.175 //x2=2.155 //y2=0.795
cc_943 ( N_GND_c_1583_n N_noxref_12_c_1925_n ) capacitor c=0.0167642f \
 //x=1.667 //y=1.005 //x2=2.155 //y2=0.795
cc_944 ( N_GND_c_1430_n N_noxref_12_c_1925_n ) capacitor c=0.0146605f //x=3.65 \
 //y=0.175 //x2=2.155 //y2=0.795
cc_945 ( N_GND_c_1432_n N_noxref_12_c_1925_n ) capacitor c=0.00283128f \
 //x=1.23 //y=0.18 //x2=2.155 //y2=0.795
cc_946 ( N_GND_c_1440_n N_noxref_12_c_1925_n ) capacitor c=2.21767e-19 \
 //x=3.82 //y=0.175 //x2=2.155 //y2=0.795
cc_947 ( N_GND_c_1451_n N_noxref_12_c_1925_n ) capacitor c=0.00145873f \
 //x=12.08 //y=0.175 //x2=2.155 //y2=0.795
cc_948 ( N_GND_c_1432_n N_noxref_12_c_1888_n ) capacitor c=2.85935e-19 \
 //x=1.23 //y=0.18 //x2=2.155 //y2=1.675
cc_949 ( N_GND_c_1421_n N_noxref_12_c_1889_n ) capacitor c=0.0100399f \
 //x=8.245 //y=0.175 //x2=3.04 //y2=0.71
cc_950 ( N_GND_c_1430_n N_noxref_12_c_1889_n ) capacitor c=0.0374826f //x=3.65 \
 //y=0.175 //x2=3.04 //y2=0.71
cc_951 ( N_GND_c_1451_n N_noxref_12_c_1889_n ) capacitor c=0.00199095f \
 //x=12.08 //y=0.175 //x2=3.04 //y2=0.71
cc_952 ( N_GND_c_1421_n N_noxref_12_c_1935_n ) capacitor c=0.00244977f \
 //x=8.245 //y=0.175 //x2=3.125 //y2=0.795
cc_953 ( N_GND_c_1430_n N_noxref_12_c_1935_n ) capacitor c=0.0145365f //x=3.65 \
 //y=0.175 //x2=3.125 //y2=0.795
cc_954 ( N_GND_c_1653_p N_noxref_12_c_1935_n ) capacitor c=0.0019997f \
 //x=4.515 //y=0.625 //x2=3.125 //y2=0.795
cc_955 ( N_GND_c_1440_n N_noxref_12_c_1935_n ) capacitor c=0.0401922f //x=3.82 \
 //y=0.175 //x2=3.125 //y2=0.795
cc_956 ( N_GND_c_1451_n N_noxref_12_c_1935_n ) capacitor c=0.00145015f \
 //x=12.08 //y=0.175 //x2=3.125 //y2=0.795
cc_957 ( N_GND_c_1573_n N_noxref_12_M0_noxref_s ) capacitor c=0.00724992f \
 //x=1.585 //y=0.175 //x2=1.05 //y2=0.545
cc_958 ( N_GND_c_1427_n N_noxref_12_M0_noxref_s ) capacitor c=0.0113988f \
 //x=1.67 //y=1.135 //x2=1.05 //y2=0.545
cc_959 ( N_GND_c_1583_n N_noxref_12_M0_noxref_s ) capacitor c=0.0173062f \
 //x=1.667 //y=1.005 //x2=1.05 //y2=0.545
cc_960 ( N_GND_c_1430_n N_noxref_12_M0_noxref_s ) capacitor c=0.014661f \
 //x=3.65 //y=0.175 //x2=1.05 //y2=0.545
cc_961 ( N_GND_c_1432_n N_noxref_12_M0_noxref_s ) capacitor c=0.0559891f \
 //x=1.23 //y=0.18 //x2=1.05 //y2=0.545
cc_962 ( N_GND_c_1440_n N_noxref_12_M0_noxref_s ) capacitor c=0.00642623f \
 //x=3.82 //y=0.175 //x2=1.05 //y2=0.545
cc_963 ( N_GND_c_1451_n N_noxref_12_M0_noxref_s ) capacitor c=0.00145873f \
 //x=12.08 //y=0.175 //x2=1.05 //y2=0.545
cc_964 ( N_GND_M0_noxref_d N_noxref_12_M0_noxref_s ) capacitor c=0.0271276f \
 //x=1.48 //y=1.045 //x2=1.05 //y2=0.545
cc_965 ( N_GND_M2_noxref_s N_noxref_12_M0_noxref_s ) capacitor c=0.00298769f \
 //x=4.38 //y=0.545 //x2=1.05 //y2=0.545
cc_966 ( N_GND_c_1421_n N_noxref_13_c_1951_n ) capacitor c=9.58019e-19 \
 //x=8.245 //y=0.175 //x2=8.73 //y2=1.76
cc_967 ( N_GND_c_1522_n N_noxref_13_c_1951_n ) capacitor c=0.00203804f \
 //x=11.96 //y=0.18 //x2=8.73 //y2=1.76
cc_968 ( N_GND_c_1467_n N_noxref_13_c_1951_n ) capacitor c=0.00398377f \
 //x=8.33 //y=1.135 //x2=8.73 //y2=1.76
cc_969 ( N_GND_c_1489_n N_noxref_13_c_1951_n ) capacitor c=0.00387051f \
 //x=10.31 //y=0.175 //x2=8.73 //y2=1.76
cc_970 ( N_GND_M4_noxref_d N_noxref_13_c_1951_n ) capacitor c=0.00578453f \
 //x=8.14 //y=1.045 //x2=8.73 //y2=1.76
cc_971 ( N_GND_c_1522_n N_noxref_13_c_1978_n ) capacitor c=0.0068323f \
 //x=11.96 //y=0.18 //x2=8.815 //y2=0.795
cc_972 ( N_GND_c_1478_n N_noxref_13_c_1978_n ) capacitor c=0.0167642f \
 //x=8.327 //y=1.005 //x2=8.815 //y2=0.795
cc_973 ( N_GND_c_1489_n N_noxref_13_c_1978_n ) capacitor c=0.0146605f \
 //x=10.31 //y=0.175 //x2=8.815 //y2=0.795
cc_974 ( N_GND_c_1491_n N_noxref_13_c_1978_n ) capacitor c=0.00282552f \
 //x=7.15 //y=0.175 //x2=8.815 //y2=0.795
cc_975 ( N_GND_c_1541_n N_noxref_13_c_1978_n ) capacitor c=2.21767e-19 \
 //x=10.48 //y=0.175 //x2=8.815 //y2=0.795
cc_976 ( N_GND_c_1451_n N_noxref_13_c_1978_n ) capacitor c=0.00145873f \
 //x=12.08 //y=0.175 //x2=8.815 //y2=0.795
cc_977 ( N_GND_c_1491_n N_noxref_13_c_1959_n ) capacitor c=2.8386e-19 //x=7.15 \
 //y=0.175 //x2=8.815 //y2=1.675
cc_978 ( N_GND_c_1522_n N_noxref_13_c_1964_n ) capacitor c=0.0100399f \
 //x=11.96 //y=0.18 //x2=9.7 //y2=0.71
cc_979 ( N_GND_c_1489_n N_noxref_13_c_1964_n ) capacitor c=0.0374826f \
 //x=10.31 //y=0.175 //x2=9.7 //y2=0.71
cc_980 ( N_GND_c_1451_n N_noxref_13_c_1964_n ) capacitor c=0.00199095f \
 //x=12.08 //y=0.175 //x2=9.7 //y2=0.71
cc_981 ( N_GND_c_1522_n N_noxref_13_c_1988_n ) capacitor c=0.00244977f \
 //x=11.96 //y=0.18 //x2=9.785 //y2=0.795
cc_982 ( N_GND_c_1489_n N_noxref_13_c_1988_n ) capacitor c=0.0145365f \
 //x=10.31 //y=0.175 //x2=9.785 //y2=0.795
cc_983 ( N_GND_c_1682_p N_noxref_13_c_1988_n ) capacitor c=0.00209572f \
 //x=11.11 //y=0.63 //x2=9.785 //y2=0.795
cc_984 ( N_GND_c_1541_n N_noxref_13_c_1988_n ) capacitor c=0.0402083f \
 //x=10.48 //y=0.175 //x2=9.785 //y2=0.795
cc_985 ( N_GND_c_1451_n N_noxref_13_c_1988_n ) capacitor c=0.00145015f \
 //x=12.08 //y=0.175 //x2=9.785 //y2=0.795
cc_986 ( N_GND_c_1421_n N_noxref_13_M4_noxref_s ) capacitor c=0.00724992f \
 //x=8.245 //y=0.175 //x2=7.71 //y2=0.545
cc_987 ( N_GND_c_1467_n N_noxref_13_M4_noxref_s ) capacitor c=0.00997186f \
 //x=8.33 //y=1.135 //x2=7.71 //y2=0.545
cc_988 ( N_GND_c_1478_n N_noxref_13_M4_noxref_s ) capacitor c=0.0173062f \
 //x=8.327 //y=1.005 //x2=7.71 //y2=0.545
cc_989 ( N_GND_c_1688_p N_noxref_13_M4_noxref_s ) capacitor c=0.00396688f \
 //x=6.455 //y=0.625 //x2=7.71 //y2=0.545
cc_990 ( N_GND_c_1489_n N_noxref_13_M4_noxref_s ) capacitor c=0.014661f \
 //x=10.31 //y=0.175 //x2=7.71 //y2=0.545
cc_991 ( N_GND_c_1491_n N_noxref_13_M4_noxref_s ) capacitor c=0.052705f \
 //x=7.15 //y=0.175 //x2=7.71 //y2=0.545
cc_992 ( N_GND_c_1541_n N_noxref_13_M4_noxref_s ) capacitor c=0.00642652f \
 //x=10.48 //y=0.175 //x2=7.71 //y2=0.545
cc_993 ( N_GND_c_1451_n N_noxref_13_M4_noxref_s ) capacitor c=0.00145873f \
 //x=12.08 //y=0.175 //x2=7.71 //y2=0.545
cc_994 ( N_GND_M2_noxref_s N_noxref_13_M4_noxref_s ) capacitor c=9.07604e-19 \
 //x=4.38 //y=0.545 //x2=7.71 //y2=0.545
cc_995 ( N_GND_M4_noxref_d N_noxref_13_M4_noxref_s ) capacitor c=0.0271276f \
 //x=8.14 //y=1.045 //x2=7.71 //y2=0.545
cc_996 ( N_GND_M6_noxref_s N_noxref_13_M4_noxref_s ) capacitor c=0.0031675f \
 //x=10.975 //y=0.55 //x2=7.71 //y2=0.545
cc_997 ( N_D_c_1709_n N_noxref_13_c_1959_n ) capacitor c=7.471e-19 //x=9 \
 //y=2.26 //x2=8.815 //y2=1.675
cc_998 ( N_D_c_1727_n N_noxref_13_c_1959_n ) capacitor c=0.00888238f //x=9.035 \
 //y=1.74 //x2=8.815 //y2=1.675
cc_999 ( N_D_c_1732_n N_noxref_13_c_1959_n ) capacitor c=0.00173073f //x=9 \
 //y=2.26 //x2=8.815 //y2=1.675
cc_1000 ( N_D_c_1709_n N_noxref_13_c_1964_n ) capacitor c=0.00141156f //x=9 \
 //y=2.26 //x2=9.7 //y2=0.71
cc_1001 ( N_D_c_1712_n N_noxref_13_c_1964_n ) capacitor c=8.82141e-19 //x=9 \
 //y=2.26 //x2=9.7 //y2=0.71
cc_1002 ( N_D_c_1722_n N_noxref_13_c_1964_n ) capacitor c=0.0199501f //x=9.035 \
 //y=1.085 //x2=9.7 //y2=0.71
cc_1003 ( N_D_c_1730_n N_noxref_13_c_1964_n ) capacitor c=0.00825432f \
 //x=9.565 //y=1.085 //x2=9.7 //y2=0.71
cc_1004 ( N_D_c_1732_n N_noxref_13_c_1964_n ) capacitor c=2.1838e-19 //x=9 \
 //y=2.26 //x2=9.7 //y2=0.71
cc_1005 ( N_D_c_1722_n N_noxref_13_M4_noxref_s ) capacitor c=0.00888238f \
 //x=9.035 //y=1.085 //x2=7.71 //y2=0.545
cc_1006 ( N_D_c_1730_n N_noxref_13_M4_noxref_s ) capacitor c=0.015333f \
 //x=9.565 //y=1.085 //x2=7.71 //y2=0.545
cc_1007 ( N_D_c_1731_n N_noxref_13_M4_noxref_s ) capacitor c=0.00248746f \
 //x=9.565 //y=1.43 //x2=7.71 //y2=0.545
