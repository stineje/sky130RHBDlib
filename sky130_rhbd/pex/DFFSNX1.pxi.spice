// File: DFFSNX1.spi.DFFSNX1.pxi
// Created: Fri Feb 20 10:11:48 2026
//
simulator lang=spectre
x_PM_DFFSNX1\%noxref_1 ( N_noxref_1_c_61_p N_noxref_1_c_118_p \
 N_noxref_1_c_113_p N_noxref_1_c_71_p N_noxref_1_c_62_p N_noxref_1_c_9_p \
 N_noxref_1_c_55_p N_noxref_1_c_10_p N_noxref_1_c_18_p N_noxref_1_c_11_p \
 N_noxref_1_c_12_p N_noxref_1_c_13_p N_noxref_1_c_74_p N_noxref_1_c_75_p \
 N_noxref_1_c_76_p N_noxref_1_c_26_p N_noxref_1_c_203_p N_noxref_1_c_64_p \
 N_noxref_1_c_205_p N_noxref_1_c_116_p N_noxref_1_c_59_p N_noxref_1_c_14_p \
 N_noxref_1_c_5_p N_noxref_1_c_94_p N_noxref_1_c_60_p N_noxref_1_c_15_p \
 N_noxref_1_c_78_p N_noxref_1_c_16_p N_noxref_1_c_206_p N_noxref_1_c_65_p \
 N_noxref_1_c_17_p N_noxref_1_c_23_p N_noxref_1_c_150_p N_noxref_1_c_147_p \
 N_noxref_1_M2_noxref_g N_noxref_1_M5_noxref_g N_noxref_1_M19_noxref_g \
 N_noxref_1_M20_noxref_g N_noxref_1_M25_noxref_g N_noxref_1_M26_noxref_g \
 N_noxref_1_c_40_p N_noxref_1_c_41_p N_noxref_1_c_43_p N_noxref_1_c_21_p \
 N_noxref_1_c_284_p N_noxref_1_c_301_p N_noxref_1_c_42_p N_noxref_1_c_44_p \
 N_noxref_1_c_24_p N_noxref_1_c_25_p N_noxref_1_c_168_p N_noxref_1_c_169_p \
 N_noxref_1_c_171_p N_noxref_1_c_151_p N_noxref_1_c_287_p N_noxref_1_c_312_p \
 N_noxref_1_c_170_p N_noxref_1_c_172_p N_noxref_1_c_4_p N_noxref_1_c_155_p \
 N_noxref_1_M1_noxref_d N_noxref_1_M15_noxref_d N_noxref_1_M17_noxref_d )  \
 PM_DFFSNX1\%noxref_1
x_PM_DFFSNX1\%noxref_2 ( N_noxref_2_c_397_n N_noxref_2_c_480_p \
 N_noxref_2_c_511_p N_noxref_2_c_420_p N_noxref_2_c_464_p N_noxref_2_c_503_p \
 N_noxref_2_c_504_p N_noxref_2_c_454_p N_noxref_2_c_405_p N_noxref_2_c_467_p \
 N_noxref_2_c_406_p N_noxref_2_c_407_p N_noxref_2_c_408_p N_noxref_2_c_398_n \
 N_noxref_2_c_423_p N_noxref_2_c_499_p N_noxref_2_c_401_n N_noxref_2_c_409_p \
 N_noxref_2_c_413_p N_noxref_2_c_416_p N_noxref_2_c_410_p N_noxref_2_c_471_p \
 N_noxref_2_c_411_p N_noxref_2_c_457_p N_noxref_2_c_402_n N_noxref_2_c_463_p \
 N_noxref_2_c_501_p N_noxref_2_c_412_p N_noxref_2_c_418_p \
 N_noxref_2_M8_noxref_g N_noxref_2_M31_noxref_g N_noxref_2_M32_noxref_g \
 N_noxref_2_c_436_p N_noxref_2_c_437_p N_noxref_2_c_439_p N_noxref_2_c_415_p \
 N_noxref_2_c_641_p N_noxref_2_c_642_p N_noxref_2_c_438_p N_noxref_2_c_440_p \
 N_noxref_2_c_419_p N_noxref_2_M7_noxref_d N_noxref_2_M25_noxref_d \
 N_noxref_2_M27_noxref_d N_noxref_2_M29_noxref_d )  PM_DFFSNX1\%noxref_2
x_PM_DFFSNX1\%CLK ( CLK CLK CLK CLK CLK CLK CLK CLK N_CLK_c_693_n \
 N_CLK_c_697_n N_CLK_c_737_n N_CLK_c_740_n N_CLK_c_782_p N_CLK_c_701_n \
 N_CLK_c_702_n N_CLK_c_704_n N_CLK_c_708_n N_CLK_c_750_n N_CLK_c_754_n \
 N_CLK_M3_noxref_g N_CLK_M9_noxref_g N_CLK_M21_noxref_g N_CLK_M22_noxref_g \
 N_CLK_M33_noxref_g N_CLK_M34_noxref_g N_CLK_c_715_n N_CLK_c_718_n \
 N_CLK_c_926_p N_CLK_c_927_p N_CLK_c_720_n N_CLK_c_721_n N_CLK_c_722_n \
 N_CLK_c_723_n N_CLK_c_796_p N_CLK_c_760_n N_CLK_c_763_n N_CLK_c_765_n \
 N_CLK_c_845_p N_CLK_c_860_p N_CLK_c_833_p N_CLK_c_768_n N_CLK_c_769_n \
 N_CLK_c_726_n N_CLK_c_770_n N_CLK_c_835_p N_CLK_c_773_n )  PM_DFFSNX1\%CLK
x_PM_DFFSNX1\%noxref_4 ( N_noxref_4_c_961_n N_noxref_4_c_968_n \
 N_noxref_4_c_973_n N_noxref_4_c_976_n N_noxref_4_c_1060_n N_noxref_4_c_1049_n \
 N_noxref_4_c_1050_n N_noxref_4_c_977_n N_noxref_4_c_978_n N_noxref_4_c_1051_n \
 N_noxref_4_c_979_n N_noxref_4_c_981_n N_noxref_4_c_987_n N_noxref_4_c_988_n \
 N_noxref_4_c_1068_n N_noxref_4_c_1093_p N_noxref_4_c_989_n N_noxref_4_c_990_n \
 N_noxref_4_c_991_n N_noxref_4_c_1069_n N_noxref_4_c_1119_p \
 N_noxref_4_c_1126_p N_noxref_4_c_1202_p N_noxref_4_c_1110_p \
 N_noxref_4_c_1094_p N_noxref_4_c_1076_n N_noxref_4_c_996_n \
 N_noxref_4_c_1005_n N_noxref_4_c_1006_n N_noxref_4_c_1095_p \
 N_noxref_4_c_1009_n N_noxref_4_c_1011_n N_noxref_4_c_1012_n \
 N_noxref_4_c_1014_n N_noxref_4_c_1085_n N_noxref_4_c_1129_p \
 N_noxref_4_c_1112_p N_noxref_4_c_1096_p N_noxref_4_M1_noxref_g \
 N_noxref_4_M10_noxref_g N_noxref_4_M17_noxref_g N_noxref_4_M18_noxref_g \
 N_noxref_4_M35_noxref_g N_noxref_4_M36_noxref_g N_noxref_4_c_1023_n \
 N_noxref_4_c_1025_n N_noxref_4_c_1028_n N_noxref_4_c_1029_n \
 N_noxref_4_c_1032_n N_noxref_4_c_1034_n N_noxref_4_c_1038_n \
 N_noxref_4_c_1040_n N_noxref_4_c_1224_p N_noxref_4_c_1225_p \
 N_noxref_4_c_1227_p N_noxref_4_c_1211_p N_noxref_4_c_1379_p \
 N_noxref_4_c_1380_p N_noxref_4_c_1226_p N_noxref_4_c_1228_p \
 N_noxref_4_c_1044_n N_noxref_4_c_1045_n N_noxref_4_c_1047_n \
 N_noxref_4_c_1099_p N_noxref_4_M4_noxref_d N_noxref_4_M19_noxref_d \
 N_noxref_4_M21_noxref_d N_noxref_4_M23_noxref_d )  PM_DFFSNX1\%noxref_4
x_PM_DFFSNX1\%QN ( QN QN QN QN QN QN QN QN QN N_QN_c_1434_n N_QN_c_1504_p \
 N_QN_c_1566_p N_QN_c_1541_p N_QN_c_1469_p N_QN_c_1470_p N_QN_c_1458_p \
 N_QN_c_1453_p N_QN_c_1454_p N_QN_c_1435_n N_QN_c_1536_p N_QN_c_1601_p \
 N_QN_c_1473_p N_QN_c_1474_p N_QN_c_1455_p N_QN_c_1476_p N_QN_c_1442_n \
 N_QN_c_1537_p N_QN_c_1459_p N_QN_c_1456_p N_QN_M12_noxref_g N_QN_M39_noxref_g \
 N_QN_M40_noxref_g N_QN_c_1489_p N_QN_c_1490_p N_QN_c_1492_p N_QN_c_1460_p \
 N_QN_c_1651_p N_QN_c_1664_p N_QN_c_1491_p N_QN_c_1493_p N_QN_c_1463_p \
 N_QN_c_1464_p N_QN_M11_noxref_d N_QN_M35_noxref_d N_QN_M37_noxref_d )  \
 PM_DFFSNX1\%QN
x_PM_DFFSNX1\%SN ( SN SN SN SN SN SN SN SN N_SN_c_1716_n N_SN_c_1720_n \
 N_SN_c_1799_n N_SN_c_1803_n N_SN_c_1724_n N_SN_c_1807_n N_SN_c_1757_n \
 N_SN_c_1726_n N_SN_c_1729_n N_SN_c_1820_n N_SN_c_1823_n N_SN_M6_noxref_g \
 N_SN_M13_noxref_g N_SN_M27_noxref_g N_SN_M28_noxref_g N_SN_M41_noxref_g \
 N_SN_M42_noxref_g N_SN_c_1736_n N_SN_c_1739_n N_SN_c_1973_p N_SN_c_1974_p \
 N_SN_c_1741_n N_SN_c_1742_n N_SN_c_1743_n N_SN_c_1744_n N_SN_c_1776_n \
 N_SN_c_1831_n N_SN_c_1834_n N_SN_c_2005_p N_SN_c_2006_p N_SN_c_1836_n \
 N_SN_c_1837_n N_SN_c_1838_n N_SN_c_1839_n N_SN_c_1930_p N_SN_c_1747_n \
 N_SN_c_1842_n )  PM_DFFSNX1\%SN
x_PM_DFFSNX1\%noxref_7 ( N_noxref_7_c_2047_n N_noxref_7_c_2048_n \
 N_noxref_7_c_2053_n N_noxref_7_c_2054_n N_noxref_7_c_2065_n \
 N_noxref_7_c_2056_n N_noxref_7_c_2073_n N_noxref_7_c_2058_n \
 N_noxref_7_c_2081_n N_noxref_7_c_2082_n N_noxref_7_c_2169_n \
 N_noxref_7_c_2170_n N_noxref_7_c_2083_n N_noxref_7_c_2084_n \
 N_noxref_7_c_2177_n N_noxref_7_c_2087_n N_noxref_7_c_2356_n \
 N_noxref_7_c_2324_n N_noxref_7_c_2363_n N_noxref_7_c_2326_n \
 N_noxref_7_c_2184_n N_noxref_7_c_2089_n N_noxref_7_c_2090_n \
 N_noxref_7_c_2186_n N_noxref_7_c_2328_n N_noxref_7_c_2098_n \
 N_noxref_7_c_2197_n N_noxref_7_c_2370_n N_noxref_7_c_2059_n \
 N_noxref_7_c_2199_n N_noxref_7_c_2060_n N_noxref_7_c_2064_n \
 N_noxref_7_c_2100_n N_noxref_7_c_2204_n N_noxref_7_c_2377_n \
 N_noxref_7_c_2280_n N_noxref_7_c_2205_n N_noxref_7_c_2209_n \
 N_noxref_7_c_2107_n N_noxref_7_c_2108_n N_noxref_7_c_2112_n \
 N_noxref_7_c_2212_n N_noxref_7_c_2389_n N_noxref_7_c_2392_n \
 N_noxref_7_M4_noxref_g N_noxref_7_M7_noxref_g N_noxref_7_M14_noxref_g \
 N_noxref_7_M23_noxref_g N_noxref_7_M24_noxref_g N_noxref_7_M29_noxref_g \
 N_noxref_7_M30_noxref_g N_noxref_7_M43_noxref_g N_noxref_7_M44_noxref_g \
 N_noxref_7_c_2219_n N_noxref_7_c_2220_n N_noxref_7_c_2221_n \
 N_noxref_7_c_2301_n N_noxref_7_c_2303_n N_noxref_7_c_2307_n \
 N_noxref_7_c_2309_n N_noxref_7_c_2123_n N_noxref_7_c_2125_n \
 N_noxref_7_c_2128_n N_noxref_7_c_2129_n N_noxref_7_c_2131_n \
 N_noxref_7_c_2135_n N_noxref_7_c_2137_n N_noxref_7_c_2405_n \
 N_noxref_7_c_2406_n N_noxref_7_c_2407_n N_noxref_7_c_2451_p \
 N_noxref_7_c_2452_p N_noxref_7_c_2453_p N_noxref_7_c_2454_p \
 N_noxref_7_c_2222_n N_noxref_7_c_2225_n N_noxref_7_c_2226_n \
 N_noxref_7_c_2141_n N_noxref_7_c_2142_n N_noxref_7_c_2144_n \
 N_noxref_7_c_2416_n N_noxref_7_c_2419_n N_noxref_7_c_2420_n \
 N_noxref_7_M9_noxref_d N_noxref_7_M31_noxref_d N_noxref_7_M33_noxref_d )  \
 PM_DFFSNX1\%noxref_7
x_PM_DFFSNX1\%Q ( Q Q Q Q Q Q Q Q Q Q Q Q Q N_Q_c_2626_n N_Q_c_2629_n \
 N_Q_c_2680_n N_Q_c_2743_n N_Q_c_2777_n N_Q_c_2779_n N_Q_c_2783_n N_Q_c_2681_n \
 N_Q_c_2794_n N_Q_c_2682_n N_Q_c_2796_n N_Q_c_2632_n N_Q_c_2684_n N_Q_c_2745_n \
 N_Q_c_2797_n N_Q_c_2689_n N_Q_c_2804_n N_Q_c_2635_n N_Q_c_2637_n N_Q_c_2641_n \
 N_Q_c_2700_n N_Q_c_2754_n N_Q_c_2807_n N_Q_M11_noxref_g N_Q_M37_noxref_g \
 N_Q_M38_noxref_g N_Q_c_2647_n N_Q_c_2650_n N_Q_c_2652_n N_Q_c_2715_n \
 N_Q_c_2718_n N_Q_c_2720_n N_Q_c_2655_n N_Q_c_2656_n N_Q_c_2657_n N_Q_c_2731_n \
 N_Q_c_2660_n N_Q_M14_noxref_d N_Q_M39_noxref_d N_Q_M41_noxref_d \
 N_Q_M43_noxref_d )  PM_DFFSNX1\%Q
x_PM_DFFSNX1\%VDD ( VDD N_VDD_c_2903_n N_VDD_c_2910_n N_VDD_c_2913_n \
 N_VDD_c_2918_n N_VDD_c_3014_n N_VDD_c_3053_n N_VDD_c_3057_n N_VDD_c_2920_n \
 N_VDD_c_2977_n N_VDD_c_2981_n N_VDD_c_2985_n N_VDD_c_2986_n N_VDD_c_3016_n \
 N_VDD_c_3059_n N_VDD_c_3119_n N_VDD_c_3124_n N_VDD_c_3160_n N_VDD_c_3186_n \
 N_VDD_c_3188_n N_VDD_c_2922_n N_VDD_c_2925_n N_VDD_c_2933_n N_VDD_c_2991_n \
 N_VDD_c_3020_n N_VDD_c_3129_n N_VDD_M15_noxref_s N_VDD_M16_noxref_d \
 N_VDD_M18_noxref_d N_VDD_M19_noxref_s N_VDD_M20_noxref_d N_VDD_M22_noxref_d \
 N_VDD_M24_noxref_d N_VDD_M25_noxref_s N_VDD_M26_noxref_d N_VDD_M28_noxref_d \
 N_VDD_M30_noxref_d N_VDD_M31_noxref_s N_VDD_M32_noxref_d N_VDD_M34_noxref_d \
 N_VDD_M35_noxref_s N_VDD_M36_noxref_d N_VDD_M38_noxref_d N_VDD_M39_noxref_s \
 N_VDD_M40_noxref_d N_VDD_M42_noxref_d N_VDD_M44_noxref_d )  PM_DFFSNX1\%VDD
x_PM_DFFSNX1\%D ( D D D D D D N_D_c_3313_n N_D_c_3295_n N_D_c_3319_n \
 N_D_c_3297_n N_D_M0_noxref_g N_D_M15_noxref_g N_D_M16_noxref_g N_D_c_3329_n \
 N_D_c_3330_n N_D_c_3331_n N_D_c_3333_n N_D_c_3362_p N_D_c_3363_p N_D_c_3337_n \
 N_D_c_3339_n N_D_c_3304_n )  PM_DFFSNX1\%D
x_PM_DFFSNX1\%noxref_11 ( N_noxref_11_c_3393_n N_noxref_11_c_3435_p \
 N_noxref_11_c_3394_n N_noxref_11_c_3437_p N_noxref_11_c_3416_n \
 N_noxref_11_M3_noxref_d N_noxref_11_M4_noxref_s )  PM_DFFSNX1\%noxref_11
x_PM_DFFSNX1\%noxref_12 ( N_noxref_12_c_3474_n N_noxref_12_c_3505_p \
 N_noxref_12_c_3462_n N_noxref_12_c_3507_p N_noxref_12_c_3465_n \
 N_noxref_12_M6_noxref_d N_noxref_12_M7_noxref_s )  PM_DFFSNX1\%noxref_12
x_PM_DFFSNX1\%GND ( GND N_GND_c_3798_n N_GND_c_3532_n N_GND_c_3536_n \
 N_GND_c_3651_n N_GND_c_3539_n N_GND_c_3609_n N_GND_c_3652_n N_GND_c_3696_n \
 N_GND_c_3700_n N_GND_c_3742_n N_GND_c_3542_n N_GND_c_3808_n N_GND_c_3545_n \
 N_GND_c_3557_n N_GND_c_3613_n N_GND_c_3624_n N_GND_c_3663_n N_GND_c_3672_n \
 N_GND_c_3706_n N_GND_c_3568_n N_GND_c_3570_n N_GND_c_3572_n N_GND_c_3573_n \
 N_GND_c_3629_n N_GND_c_3677_n N_GND_c_3719_n N_GND_c_3574_n N_GND_c_3586_n \
 N_GND_c_3630_n N_GND_c_3643_n N_GND_c_3721_n N_GND_M0_noxref_d \
 N_GND_M2_noxref_d N_GND_M5_noxref_d N_GND_M8_noxref_d N_GND_M10_noxref_d \
 N_GND_M12_noxref_d )  PM_DFFSNX1\%GND
x_PM_DFFSNX1\%noxref_14 ( N_noxref_14_c_4001_n N_noxref_14_c_4043_n \
 N_noxref_14_c_4018_n N_noxref_14_c_4047_n N_noxref_14_c_4023_n \
 N_noxref_14_M13_noxref_d N_noxref_14_M14_noxref_s )  PM_DFFSNX1\%noxref_14
x_PM_DFFSNX1\%noxref_15 ( N_noxref_15_c_4086_n N_noxref_15_c_4087_n \
 N_noxref_15_c_4102_n N_noxref_15_c_4064_n N_noxref_15_c_4065_n \
 N_noxref_15_c_4111_n N_noxref_15_M0_noxref_s )  PM_DFFSNX1\%noxref_15
x_PM_DFFSNX1\%noxref_16 ( N_noxref_16_c_4124_n N_noxref_16_c_4126_n \
 N_noxref_16_c_4151_n N_noxref_16_c_4141_n N_noxref_16_c_4135_n \
 N_noxref_16_M2_noxref_s )  PM_DFFSNX1\%noxref_16
x_PM_DFFSNX1\%noxref_17 ( N_noxref_17_c_4184_n N_noxref_17_c_4186_n \
 N_noxref_17_c_4214_n N_noxref_17_c_4198_n N_noxref_17_c_4200_n \
 N_noxref_17_M5_noxref_s )  PM_DFFSNX1\%noxref_17
x_PM_DFFSNX1\%noxref_18 ( N_noxref_18_c_4244_n N_noxref_18_c_4245_n \
 N_noxref_18_c_4289_n N_noxref_18_c_4252_n N_noxref_18_c_4259_n \
 N_noxref_18_c_4298_n N_noxref_18_M8_noxref_s )  PM_DFFSNX1\%noxref_18
x_PM_DFFSNX1\%noxref_19 ( N_noxref_19_c_4311_n N_noxref_19_c_4312_n \
 N_noxref_19_c_4355_n N_noxref_19_c_4319_n N_noxref_19_c_4324_n \
 N_noxref_19_c_4364_n N_noxref_19_M10_noxref_s )  PM_DFFSNX1\%noxref_19
x_PM_DFFSNX1\%noxref_20 ( N_noxref_20_c_4380_n N_noxref_20_c_4381_n \
 N_noxref_20_c_4412_n N_noxref_20_c_4394_n N_noxref_20_c_4396_n \
 N_noxref_20_M12_noxref_s )  PM_DFFSNX1\%noxref_20
cc_1 ( N_noxref_1_M26_noxref_g N_noxref_2_c_397_n ) capacitor c=0.00893512f \
 //x=10.38 //y=6.2 //x2=10.92 //y2=5.335
cc_2 ( N_noxref_1_M25_noxref_g N_noxref_2_c_398_n ) capacitor c=0.00461408f \
 //x=9.94 //y=6.2 //x2=10.162 //y2=5.335
cc_3 ( N_noxref_1_M26_noxref_g N_noxref_2_c_398_n ) capacitor c=0.00229208f \
 //x=10.38 //y=6.2 //x2=10.162 //y2=5.335
cc_4 ( N_noxref_1_c_4_p N_noxref_2_c_398_n ) capacitor c=0.00171885f \
 //x=10.305 //y=4.97 //x2=10.162 //y2=5.335
cc_5 ( N_noxref_1_c_5_p N_noxref_2_c_401_n ) capacitor c=4.26537e-19 //x=9.74 \
 //y=2.77 //x2=12.7 //y2=2.77
cc_6 ( N_noxref_1_M25_noxref_g N_noxref_2_c_402_n ) capacitor c=0.0162284f \
 //x=9.94 //y=6.2 //x2=10.16 //y2=5.56
cc_7 ( N_noxref_1_M26_noxref_g N_noxref_2_c_402_n ) capacitor c=0.0179041f \
 //x=10.38 //y=6.2 //x2=10.16 //y2=5.56
cc_8 ( N_noxref_1_c_4_p N_noxref_2_c_402_n ) capacitor c=0.00291477f \
 //x=10.305 //y=4.97 //x2=10.16 //y2=5.56
cc_9 ( N_noxref_1_c_9_p CLK ) capacitor c=5.24004e-19 //x=3.08 //y=2.61 \
 //x2=6.04 //y2=3.14
cc_10 ( N_noxref_1_c_10_p CLK ) capacitor c=0.00136634f //x=3.08 //y=5.295 \
 //x2=6.04 //y2=3.14
cc_11 ( N_noxref_1_c_11_p CLK ) capacitor c=0.00648708f //x=4.93 //y=2.61 \
 //x2=6.04 //y2=3.14
cc_12 ( N_noxref_1_c_12_p CLK ) capacitor c=0.00765388f //x=4.93 //y=2.93 \
 //x2=6.04 //y2=3.14
cc_13 ( N_noxref_1_c_13_p CLK ) capacitor c=0.048986f //x=4.93 //y=4.755 \
 //x2=6.04 //y2=3.14
cc_14 ( N_noxref_1_c_14_p CLK ) capacitor c=2.98349e-19 //x=4.93 //y=2.765 \
 //x2=6.04 //y2=3.14
cc_15 ( N_noxref_1_c_15_p CLK ) capacitor c=0.00242466f //x=5.09 //y=2.77 \
 //x2=6.04 //y2=3.14
cc_16 ( N_noxref_1_c_16_p CLK ) capacitor c=0.0320922f //x=9.58 //y=2.775 \
 //x2=6.04 //y2=3.14
cc_17 ( N_noxref_1_c_17_p CLK ) capacitor c=4.16726e-19 //x=4.93 //y=2.26 \
 //x2=6.04 //y2=3.14
cc_18 ( N_noxref_1_c_18_p N_CLK_c_693_n ) capacitor c=0.0115546f //x=4.93 \
 //y=2.375 //x2=6.04 //y2=2.375
cc_19 ( N_noxref_1_c_16_p N_CLK_c_693_n ) capacitor c=0.00386237f //x=9.58 \
 //y=2.775 //x2=6.04 //y2=2.375
cc_20 ( N_noxref_1_c_17_p N_CLK_c_693_n ) capacitor c=5.40058e-19 //x=4.93 \
 //y=2.26 //x2=6.04 //y2=2.375
cc_21 ( N_noxref_1_c_21_p N_CLK_c_693_n ) capacitor c=0.00147006f //x=4.63 \
 //y=2.095 //x2=6.04 //y2=2.375
cc_22 ( N_noxref_1_c_13_p N_CLK_c_697_n ) capacitor c=0.0119263f //x=4.93 \
 //y=4.755 //x2=6.04 //y2=4.755
cc_23 ( N_noxref_1_c_23_p N_CLK_c_697_n ) capacitor c=8.35331e-19 //x=4.93 \
 //y=4.88 //x2=6.04 //y2=4.755
cc_24 ( N_noxref_1_c_24_p N_CLK_c_697_n ) capacitor c=7.55789e-19 //x=5.495 \
 //y=4.97 //x2=6.04 //y2=4.755
cc_25 ( N_noxref_1_c_25_p N_CLK_c_697_n ) capacitor c=8.63332e-19 //x=5.205 \
 //y=4.97 //x2=6.04 //y2=4.755
cc_26 ( N_noxref_1_c_26_p N_CLK_c_701_n ) capacitor c=0.0332142f //x=9.74 \
 //y=4.755 //x2=8.1 //y2=4.635
cc_27 ( N_noxref_1_c_13_p N_CLK_c_702_n ) capacitor c=0.00733425f //x=4.93 \
 //y=4.755 //x2=6.04 //y2=4.62
cc_28 ( N_noxref_1_c_16_p N_CLK_c_702_n ) capacitor c=0.00243053f //x=9.58 \
 //y=2.775 //x2=6.04 //y2=4.62
cc_29 ( N_noxref_1_c_18_p N_CLK_c_704_n ) capacitor c=5.39999e-19 //x=4.93 \
 //y=2.375 //x2=6.04 //y2=2.26
cc_30 ( N_noxref_1_c_11_p N_CLK_c_704_n ) capacitor c=4.16726e-19 //x=4.93 \
 //y=2.61 //x2=6.04 //y2=2.26
cc_31 ( N_noxref_1_c_17_p N_CLK_c_704_n ) capacitor c=0.00125213f //x=4.93 \
 //y=2.26 //x2=6.04 //y2=2.26
cc_32 ( N_noxref_1_c_21_p N_CLK_c_704_n ) capacitor c=0.00214573f //x=4.63 \
 //y=2.095 //x2=6.04 //y2=2.26
cc_33 ( N_noxref_1_c_13_p N_CLK_c_708_n ) capacitor c=5.64453e-19 //x=4.93 \
 //y=4.755 //x2=6.04 //y2=4.88
cc_34 ( N_noxref_1_c_23_p N_CLK_c_708_n ) capacitor c=0.00113668f //x=4.93 \
 //y=4.88 //x2=6.04 //y2=4.88
cc_35 ( N_noxref_1_c_24_p N_CLK_c_708_n ) capacitor c=0.00116563f //x=5.495 \
 //y=4.97 //x2=6.04 //y2=4.88
cc_36 ( N_noxref_1_c_25_p N_CLK_c_708_n ) capacitor c=0.0012974f //x=5.205 \
 //y=4.97 //x2=6.04 //y2=4.88
cc_37 ( N_noxref_1_M19_noxref_g N_CLK_M21_noxref_g ) capacitor c=0.0106276f \
 //x=5.13 //y=6.2 //x2=6.01 //y2=6.2
cc_38 ( N_noxref_1_M20_noxref_g N_CLK_M21_noxref_g ) capacitor c=0.107144f \
 //x=5.57 //y=6.2 //x2=6.01 //y2=6.2
cc_39 ( N_noxref_1_M20_noxref_g N_CLK_M22_noxref_g ) capacitor c=0.0101598f \
 //x=5.57 //y=6.2 //x2=6.45 //y2=6.2
cc_40 ( N_noxref_1_c_40_p N_CLK_c_715_n ) capacitor c=5.72528e-19 //x=4.63 \
 //y=1.055 //x2=5.605 //y2=1.09
cc_41 ( N_noxref_1_c_41_p N_CLK_c_715_n ) capacitor c=0.00150277f //x=4.63 \
 //y=1.4 //x2=5.605 //y2=1.09
cc_42 ( N_noxref_1_c_42_p N_CLK_c_715_n ) capacitor c=0.0160123f //x=5.16 \
 //y=1.055 //x2=5.605 //y2=1.09
cc_43 ( N_noxref_1_c_43_p N_CLK_c_718_n ) capacitor c=0.00111227f //x=4.63 \
 //y=1.71 //x2=5.605 //y2=1.4
cc_44 ( N_noxref_1_c_44_p N_CLK_c_718_n ) capacitor c=0.0124075f //x=5.16 \
 //y=1.4 //x2=5.605 //y2=1.4
cc_45 ( N_noxref_1_c_42_p N_CLK_c_720_n ) capacitor c=9.19165e-19 //x=5.16 \
 //y=1.055 //x2=6.13 //y2=1.09
cc_46 ( N_noxref_1_c_44_p N_CLK_c_721_n ) capacitor c=0.0010154f //x=5.16 \
 //y=1.4 //x2=6.13 //y2=1.4
cc_47 ( N_noxref_1_c_44_p N_CLK_c_722_n ) capacitor c=9.23422e-19 //x=5.16 \
 //y=1.4 //x2=6.13 //y2=1.63
cc_48 ( N_noxref_1_c_18_p N_CLK_c_723_n ) capacitor c=0.00140534f //x=4.93 \
 //y=2.375 //x2=6.13 //y2=2.095
cc_49 ( N_noxref_1_c_17_p N_CLK_c_723_n ) capacitor c=0.0020754f //x=4.93 \
 //y=2.26 //x2=6.13 //y2=2.095
cc_50 ( N_noxref_1_c_21_p N_CLK_c_723_n ) capacitor c=0.00964411f //x=4.63 \
 //y=2.095 //x2=6.13 //y2=2.095
cc_51 ( N_noxref_1_c_23_p N_CLK_c_726_n ) capacitor c=0.00123917f //x=4.93 \
 //y=4.88 //x2=6.04 //y2=4.88
cc_52 ( N_noxref_1_c_24_p N_CLK_c_726_n ) capacitor c=0.0171228f //x=5.495 \
 //y=4.97 //x2=6.04 //y2=4.88
cc_53 ( N_noxref_1_c_25_p N_CLK_c_726_n ) capacitor c=0.00406071f //x=5.205 \
 //y=4.97 //x2=6.04 //y2=4.88
cc_54 ( N_noxref_1_c_9_p N_noxref_4_c_961_n ) capacitor c=0.0092434f //x=3.08 \
 //y=2.61 //x2=2.34 //y2=4.085
cc_55 ( N_noxref_1_c_55_p N_noxref_4_c_961_n ) capacitor c=0.0148501f //x=3.08 \
 //y=2.93 //x2=2.34 //y2=4.085
cc_56 ( N_noxref_1_c_10_p N_noxref_4_c_961_n ) capacitor c=0.0551358f //x=3.08 \
 //y=5.295 //x2=2.34 //y2=4.085
cc_57 ( N_noxref_1_c_11_p N_noxref_4_c_961_n ) capacitor c=6.31188e-19 \
 //x=4.93 //y=2.61 //x2=2.34 //y2=4.085
cc_58 ( N_noxref_1_c_13_p N_noxref_4_c_961_n ) capacitor c=0.00119034f \
 //x=4.93 //y=4.755 //x2=2.34 //y2=4.085
cc_59 ( N_noxref_1_c_59_p N_noxref_4_c_961_n ) capacitor c=6.20144e-19 \
 //x=3.08 //y=2.77 //x2=2.34 //y2=4.085
cc_60 ( N_noxref_1_c_60_p N_noxref_4_c_961_n ) capacitor c=0.00686847f \
 //x=3.24 //y=2.77 //x2=2.34 //y2=4.085
cc_61 ( N_noxref_1_c_61_p N_noxref_4_c_968_n ) capacitor c=0.00212208f \
 //x=2.485 //y=5.38 //x2=2.34 //y2=4.405
cc_62 ( N_noxref_1_c_62_p N_noxref_4_c_968_n ) capacitor c=4.53917e-19 \
 //x=2.725 //y=1.835 //x2=2.34 //y2=4.405
cc_63 ( N_noxref_1_c_10_p N_noxref_4_c_968_n ) capacitor c=0.0173413f //x=3.08 \
 //y=5.295 //x2=2.34 //y2=4.405
cc_64 ( N_noxref_1_c_64_p N_noxref_4_c_968_n ) capacitor c=0.00245839f //x=2.6 \
 //y=5.38 //x2=2.34 //y2=4.405
cc_65 ( N_noxref_1_c_65_p N_noxref_4_c_968_n ) capacitor c=8.00244e-19 //x=2.6 \
 //y=5.56 //x2=2.34 //y2=4.405
cc_66 ( N_noxref_1_c_61_p N_noxref_4_c_973_n ) capacitor c=0.0220622f \
 //x=2.485 //y=5.38 //x2=2.34 //y2=4.735
cc_67 ( N_noxref_1_c_10_p N_noxref_4_c_973_n ) capacitor c=0.0306018f //x=3.08 \
 //y=5.295 //x2=2.34 //y2=4.735
cc_68 ( N_noxref_1_c_13_p N_noxref_4_c_973_n ) capacitor c=0.00105013f \
 //x=4.93 //y=4.755 //x2=2.34 //y2=4.735
cc_69 ( N_noxref_1_M20_noxref_g N_noxref_4_c_976_n ) capacitor c=0.00973141f \
 //x=5.57 //y=6.2 //x2=6.11 //y2=5.335
cc_70 ( N_noxref_1_c_16_p N_noxref_4_c_977_n ) capacitor c=5.30005e-19 \
 //x=9.58 //y=2.775 //x2=7.405 //y2=1.305
cc_71 ( N_noxref_1_c_71_p N_noxref_4_c_978_n ) capacitor c=8.09327e-19 \
 //x=2.995 //y=1.835 //x2=7.405 //y2=1.76
cc_72 ( N_noxref_1_c_9_p N_noxref_4_c_979_n ) capacitor c=8.09327e-19 //x=3.08 \
 //y=2.61 //x2=7.49 //y2=1.845
cc_73 ( N_noxref_1_c_16_p N_noxref_4_c_979_n ) capacitor c=0.0143628f //x=9.58 \
 //y=2.775 //x2=7.49 //y2=1.845
cc_74 ( N_noxref_1_c_74_p N_noxref_4_c_981_n ) capacitor c=0.00458539f \
 //x=9.74 //y=2.375 //x2=7.89 //y2=4.09
cc_75 ( N_noxref_1_c_75_p N_noxref_4_c_981_n ) capacitor c=0.0035808f //x=9.74 \
 //y=2.615 //x2=7.89 //y2=4.09
cc_76 ( N_noxref_1_c_76_p N_noxref_4_c_981_n ) capacitor c=0.00248106f \
 //x=9.74 //y=2.935 //x2=7.89 //y2=4.09
cc_77 ( N_noxref_1_c_26_p N_noxref_4_c_981_n ) capacitor c=0.0200791f //x=9.74 \
 //y=4.755 //x2=7.89 //y2=4.09
cc_78 ( N_noxref_1_c_78_p N_noxref_4_c_981_n ) capacitor c=0.0015808f //x=9.74 \
 //y=2.775 //x2=7.89 //y2=4.09
cc_79 ( N_noxref_1_c_16_p N_noxref_4_c_981_n ) capacitor c=0.0324761f //x=9.58 \
 //y=2.775 //x2=7.89 //y2=4.09
cc_80 ( N_noxref_1_c_26_p N_noxref_4_c_987_n ) capacitor c=0.00251118f \
 //x=9.74 //y=4.755 //x2=7.89 //y2=4.41
cc_81 ( N_noxref_1_c_26_p N_noxref_4_c_988_n ) capacitor c=0.00765202f \
 //x=9.74 //y=4.755 //x2=7.89 //y2=5.25
cc_82 ( N_noxref_1_c_9_p N_noxref_4_c_989_n ) capacitor c=0.015397f //x=3.08 \
 //y=2.61 //x2=2.34 //y2=2.26
cc_83 ( N_noxref_1_c_10_p N_noxref_4_c_990_n ) capacitor c=5.56185e-19 \
 //x=3.08 //y=5.295 //x2=2.34 //y2=4.25
cc_84 ( N_noxref_1_c_10_p N_noxref_4_c_991_n ) capacitor c=0.00261914f \
 //x=3.08 //y=5.295 //x2=5.352 //y2=5.335
cc_85 ( N_noxref_1_c_64_p N_noxref_4_c_991_n ) capacitor c=5.0812e-19 //x=2.6 \
 //y=5.38 //x2=5.352 //y2=5.335
cc_86 ( N_noxref_1_M19_noxref_g N_noxref_4_c_991_n ) capacitor c=0.00461408f \
 //x=5.13 //y=6.2 //x2=5.352 //y2=5.335
cc_87 ( N_noxref_1_M20_noxref_g N_noxref_4_c_991_n ) capacitor c=0.00229208f \
 //x=5.57 //y=6.2 //x2=5.352 //y2=5.335
cc_88 ( N_noxref_1_c_24_p N_noxref_4_c_991_n ) capacitor c=0.00171885f \
 //x=5.495 //y=4.97 //x2=5.352 //y2=5.335
cc_89 ( N_noxref_1_c_55_p N_noxref_4_c_996_n ) capacitor c=0.00334974f \
 //x=3.08 //y=2.93 //x2=7.725 //y2=4.25
cc_90 ( N_noxref_1_c_10_p N_noxref_4_c_996_n ) capacitor c=0.0331543f //x=3.08 \
 //y=5.295 //x2=7.725 //y2=4.25
cc_91 ( N_noxref_1_c_12_p N_noxref_4_c_996_n ) capacitor c=0.00317239f \
 //x=4.93 //y=2.93 //x2=7.725 //y2=4.25
cc_92 ( N_noxref_1_c_13_p N_noxref_4_c_996_n ) capacitor c=0.0375646f //x=4.93 \
 //y=4.755 //x2=7.725 //y2=4.25
cc_93 ( N_noxref_1_c_64_p N_noxref_4_c_996_n ) capacitor c=0.014239f //x=2.6 \
 //y=5.38 //x2=7.725 //y2=4.25
cc_94 ( N_noxref_1_c_94_p N_noxref_4_c_996_n ) capacitor c=0.0386101f //x=4.77 \
 //y=2.77 //x2=7.725 //y2=4.25
cc_95 ( N_noxref_1_c_60_p N_noxref_4_c_996_n ) capacitor c=0.00523905f \
 //x=3.24 //y=2.77 //x2=7.725 //y2=4.25
cc_96 ( N_noxref_1_c_15_p N_noxref_4_c_996_n ) capacitor c=0.00523885f \
 //x=5.09 //y=2.77 //x2=7.725 //y2=4.25
cc_97 ( N_noxref_1_c_16_p N_noxref_4_c_996_n ) capacitor c=0.0496542f //x=9.58 \
 //y=2.775 //x2=7.725 //y2=4.25
cc_98 ( N_noxref_1_c_26_p N_noxref_4_c_1005_n ) capacitor c=0.00157696f \
 //x=9.74 //y=4.755 //x2=8.045 //y2=4.25
cc_99 ( N_noxref_1_c_61_p N_noxref_4_c_1006_n ) capacitor c=0.00119162f \
 //x=2.485 //y=5.38 //x2=2.5 //y2=4.245
cc_100 ( N_noxref_1_c_10_p N_noxref_4_c_1006_n ) capacitor c=0.0032735f \
 //x=3.08 //y=5.295 //x2=2.5 //y2=4.245
cc_101 ( N_noxref_1_c_64_p N_noxref_4_c_1006_n ) capacitor c=2.41886e-19 \
 //x=2.6 //y=5.38 //x2=2.5 //y2=4.245
cc_102 ( N_noxref_1_c_26_p N_noxref_4_c_1009_n ) capacitor c=0.0245637f \
 //x=9.74 //y=4.755 //x2=17.72 //y2=4.265
cc_103 ( N_noxref_1_c_16_p N_noxref_4_c_1009_n ) capacitor c=0.00532725f \
 //x=9.58 //y=2.775 //x2=17.72 //y2=4.265
cc_104 ( N_noxref_1_c_9_p N_noxref_4_c_1011_n ) capacitor c=9.90728e-19 \
 //x=3.08 //y=2.61 //x2=2.34 //y2=2.26
cc_105 ( N_noxref_1_c_61_p N_noxref_4_c_1012_n ) capacitor c=0.00469257f \
 //x=2.485 //y=5.38 //x2=2.37 //y2=4.88
cc_106 ( N_noxref_1_c_10_p N_noxref_4_c_1012_n ) capacitor c=7.76118e-19 \
 //x=3.08 //y=5.295 //x2=2.37 //y2=4.88
cc_107 ( N_noxref_1_M19_noxref_g N_noxref_4_c_1014_n ) capacitor c=0.0162284f \
 //x=5.13 //y=6.2 //x2=5.35 //y2=5.56
cc_108 ( N_noxref_1_M20_noxref_g N_noxref_4_c_1014_n ) capacitor c=0.0179041f \
 //x=5.57 //y=6.2 //x2=5.35 //y2=5.56
cc_109 ( N_noxref_1_c_24_p N_noxref_4_c_1014_n ) capacitor c=0.00291477f \
 //x=5.495 //y=4.97 //x2=5.35 //y2=5.56
cc_110 ( N_noxref_1_c_61_p N_noxref_4_M17_noxref_g ) capacitor c=0.00842859f \
 //x=2.485 //y=5.38 //x2=2.38 //y2=6.2
cc_111 ( N_noxref_1_c_64_p N_noxref_4_M17_noxref_g ) capacitor c=0.00192712f \
 //x=2.6 //y=5.38 //x2=2.38 //y2=6.2
cc_112 ( N_noxref_1_c_65_p N_noxref_4_M17_noxref_g ) capacitor c=0.0178987f \
 //x=2.6 //y=5.56 //x2=2.38 //y2=6.2
cc_113 ( N_noxref_1_c_113_p N_noxref_4_M18_noxref_g ) capacitor c=0.0110279f \
 //x=2.995 //y=5.38 //x2=2.82 //y2=6.2
cc_114 ( N_noxref_1_c_64_p N_noxref_4_M18_noxref_g ) capacitor c=0.00312463f \
 //x=2.6 //y=5.38 //x2=2.82 //y2=6.2
cc_115 ( N_noxref_1_c_65_p N_noxref_4_M18_noxref_g ) capacitor c=0.0178506f \
 //x=2.6 //y=5.56 //x2=2.82 //y2=6.2
cc_116 ( N_noxref_1_c_116_p N_noxref_4_c_1023_n ) capacitor c=0.00120406f \
 //x=2.64 //y=1.18 //x2=2.375 //y2=1.085
cc_117 ( N_noxref_1_M1_noxref_d N_noxref_4_c_1023_n ) capacitor c=0.00137165f \
 //x=2.45 //y=1.085 //x2=2.375 //y2=1.085
cc_118 ( N_noxref_1_c_118_p N_noxref_4_c_1025_n ) capacitor c=0.00127432f \
 //x=2.64 //y=1.75 //x2=2.375 //y2=1.43
cc_119 ( N_noxref_1_c_116_p N_noxref_4_c_1025_n ) capacitor c=0.00220847f \
 //x=2.64 //y=1.18 //x2=2.375 //y2=1.43
cc_120 ( N_noxref_1_M1_noxref_d N_noxref_4_c_1025_n ) capacitor c=0.00237422f \
 //x=2.45 //y=1.085 //x2=2.375 //y2=1.43
cc_121 ( N_noxref_1_c_118_p N_noxref_4_c_1028_n ) capacitor c=0.00454577f \
 //x=2.64 //y=1.75 //x2=2.375 //y2=1.74
cc_122 ( N_noxref_1_c_10_p N_noxref_4_c_1029_n ) capacitor c=0.00874009f \
 //x=3.08 //y=5.295 //x2=2.745 //y2=4.97
cc_123 ( N_noxref_1_c_64_p N_noxref_4_c_1029_n ) capacitor c=0.0020269f \
 //x=2.6 //y=5.38 //x2=2.745 //y2=4.97
cc_124 ( N_noxref_1_c_65_p N_noxref_4_c_1029_n ) capacitor c=0.00302834f \
 //x=2.6 //y=5.56 //x2=2.745 //y2=4.97
cc_125 ( N_noxref_1_c_116_p N_noxref_4_c_1032_n ) capacitor c=5.50523e-19 \
 //x=2.64 //y=1.18 //x2=2.75 //y2=0.93
cc_126 ( N_noxref_1_M1_noxref_d N_noxref_4_c_1032_n ) capacitor c=0.0020782f \
 //x=2.45 //y=1.085 //x2=2.75 //y2=0.93
cc_127 ( N_noxref_1_c_118_p N_noxref_4_c_1034_n ) capacitor c=0.00942306f \
 //x=2.64 //y=1.75 //x2=2.75 //y2=1.585
cc_128 ( N_noxref_1_c_71_p N_noxref_4_c_1034_n ) capacitor c=0.00194324f \
 //x=2.995 //y=1.835 //x2=2.75 //y2=1.585
cc_129 ( N_noxref_1_c_116_p N_noxref_4_c_1034_n ) capacitor c=5.43945e-19 \
 //x=2.64 //y=1.18 //x2=2.75 //y2=1.585
cc_130 ( N_noxref_1_M1_noxref_d N_noxref_4_c_1034_n ) capacitor c=0.00356097f \
 //x=2.45 //y=1.085 //x2=2.75 //y2=1.585
cc_131 ( N_noxref_1_c_116_p N_noxref_4_c_1038_n ) capacitor c=0.00108157f \
 //x=2.64 //y=1.18 //x2=2.905 //y2=1.085
cc_132 ( N_noxref_1_M1_noxref_d N_noxref_4_c_1038_n ) capacitor c=8.50095e-19 \
 //x=2.45 //y=1.085 //x2=2.905 //y2=1.085
cc_133 ( N_noxref_1_c_118_p N_noxref_4_c_1040_n ) capacitor c=0.00341295f \
 //x=2.64 //y=1.75 //x2=2.905 //y2=1.43
cc_134 ( N_noxref_1_c_71_p N_noxref_4_c_1040_n ) capacitor c=0.00323005f \
 //x=2.995 //y=1.835 //x2=2.905 //y2=1.43
cc_135 ( N_noxref_1_c_116_p N_noxref_4_c_1040_n ) capacitor c=0.00312028f \
 //x=2.64 //y=1.18 //x2=2.905 //y2=1.43
cc_136 ( N_noxref_1_M1_noxref_d N_noxref_4_c_1040_n ) capacitor c=0.00237422f \
 //x=2.45 //y=1.085 //x2=2.905 //y2=1.43
cc_137 ( N_noxref_1_c_9_p N_noxref_4_c_1044_n ) capacitor c=0.00285392f \
 //x=3.08 //y=2.61 //x2=2.34 //y2=2.26
cc_138 ( N_noxref_1_c_118_p N_noxref_4_c_1045_n ) capacitor c=0.00371023f \
 //x=2.64 //y=1.75 //x2=2.34 //y2=2.095
cc_139 ( N_noxref_1_c_9_p N_noxref_4_c_1045_n ) capacitor c=0.00341496f \
 //x=3.08 //y=2.61 //x2=2.34 //y2=2.095
cc_140 ( N_noxref_1_c_61_p N_noxref_4_c_1047_n ) capacitor c=8.43115e-19 \
 //x=2.485 //y=5.38 //x2=2.37 //y2=4.88
cc_141 ( N_noxref_1_c_10_p N_noxref_4_c_1047_n ) capacitor c=0.00142201f \
 //x=3.08 //y=5.295 //x2=2.37 //y2=4.88
cc_142 ( N_noxref_1_c_75_p SN ) capacitor c=0.00188309f //x=9.74 //y=2.615 \
 //x2=10.85 //y2=2.77
cc_143 ( N_noxref_1_c_76_p SN ) capacitor c=0.00775314f //x=9.74 //y=2.935 \
 //x2=10.85 //y2=2.77
cc_144 ( N_noxref_1_c_26_p SN ) capacitor c=0.0485474f //x=9.74 //y=4.755 \
 //x2=10.85 //y2=2.77
cc_145 ( N_noxref_1_c_5_p SN ) capacitor c=2.69051e-19 //x=9.74 //y=2.77 \
 //x2=10.85 //y2=2.77
cc_146 ( N_noxref_1_c_78_p SN ) capacitor c=0.00508119f //x=9.74 //y=2.775 \
 //x2=10.85 //y2=2.77
cc_147 ( N_noxref_1_c_147_p SN ) capacitor c=3.36194e-19 //x=9.74 //y=4.88 \
 //x2=10.85 //y2=2.77
cc_148 ( N_noxref_1_c_74_p N_SN_c_1716_n ) capacitor c=0.00840403f //x=9.74 \
 //y=2.375 //x2=10.85 //y2=2.55
cc_149 ( N_noxref_1_c_75_p N_SN_c_1716_n ) capacitor c=0.00398079f //x=9.74 \
 //y=2.615 //x2=10.85 //y2=2.55
cc_150 ( N_noxref_1_c_150_p N_SN_c_1716_n ) capacitor c=0.00116411f //x=9.74 \
 //y=2.26 //x2=10.85 //y2=2.55
cc_151 ( N_noxref_1_c_151_p N_SN_c_1716_n ) capacitor c=0.0015646f //x=9.44 \
 //y=2.095 //x2=10.85 //y2=2.55
cc_152 ( N_noxref_1_c_26_p N_SN_c_1720_n ) capacitor c=0.0110307f //x=9.74 \
 //y=4.755 //x2=10.85 //y2=4.765
cc_153 ( N_noxref_1_c_147_p N_SN_c_1720_n ) capacitor c=2.89813e-19 //x=9.74 \
 //y=4.88 //x2=10.85 //y2=4.765
cc_154 ( N_noxref_1_c_4_p N_SN_c_1720_n ) capacitor c=7.66769e-19 //x=10.305 \
 //y=4.97 //x2=10.85 //y2=4.765
cc_155 ( N_noxref_1_c_155_p N_SN_c_1720_n ) capacitor c=7.54501e-19 //x=10.015 \
 //y=4.97 //x2=10.85 //y2=4.765
cc_156 ( N_noxref_1_c_74_p N_SN_c_1724_n ) capacitor c=0.00331546f //x=9.74 \
 //y=2.375 //x2=11.01 //y2=2.39
cc_157 ( N_noxref_1_c_75_p N_SN_c_1724_n ) capacitor c=0.00308827f //x=9.74 \
 //y=2.615 //x2=11.01 //y2=2.39
cc_158 ( N_noxref_1_c_74_p N_SN_c_1726_n ) capacitor c=5.39999e-19 //x=9.74 \
 //y=2.375 //x2=10.85 //y2=2.26
cc_159 ( N_noxref_1_c_150_p N_SN_c_1726_n ) capacitor c=0.00124907f //x=9.74 \
 //y=2.26 //x2=10.85 //y2=2.26
cc_160 ( N_noxref_1_c_151_p N_SN_c_1726_n ) capacitor c=0.00214501f //x=9.44 \
 //y=2.095 //x2=10.85 //y2=2.26
cc_161 ( N_noxref_1_c_26_p N_SN_c_1729_n ) capacitor c=0.00103399f //x=9.74 \
 //y=4.755 //x2=10.85 //y2=4.88
cc_162 ( N_noxref_1_c_147_p N_SN_c_1729_n ) capacitor c=0.00113984f //x=9.74 \
 //y=4.88 //x2=10.85 //y2=4.88
cc_163 ( N_noxref_1_c_4_p N_SN_c_1729_n ) capacitor c=0.00116563f //x=10.305 \
 //y=4.97 //x2=10.85 //y2=4.88
cc_164 ( N_noxref_1_c_155_p N_SN_c_1729_n ) capacitor c=0.00129812f //x=10.015 \
 //y=4.97 //x2=10.85 //y2=4.88
cc_165 ( N_noxref_1_M25_noxref_g N_SN_M27_noxref_g ) capacitor c=0.0106276f \
 //x=9.94 //y=6.2 //x2=10.82 //y2=6.2
cc_166 ( N_noxref_1_M26_noxref_g N_SN_M27_noxref_g ) capacitor c=0.107144f \
 //x=10.38 //y=6.2 //x2=10.82 //y2=6.2
cc_167 ( N_noxref_1_M26_noxref_g N_SN_M28_noxref_g ) capacitor c=0.0101598f \
 //x=10.38 //y=6.2 //x2=11.26 //y2=6.2
cc_168 ( N_noxref_1_c_168_p N_SN_c_1736_n ) capacitor c=5.72528e-19 //x=9.44 \
 //y=1.055 //x2=10.415 //y2=1.09
cc_169 ( N_noxref_1_c_169_p N_SN_c_1736_n ) capacitor c=0.00150277f //x=9.44 \
 //y=1.4 //x2=10.415 //y2=1.09
cc_170 ( N_noxref_1_c_170_p N_SN_c_1736_n ) capacitor c=0.0160123f //x=9.97 \
 //y=1.055 //x2=10.415 //y2=1.09
cc_171 ( N_noxref_1_c_171_p N_SN_c_1739_n ) capacitor c=0.00111227f //x=9.44 \
 //y=1.71 //x2=10.415 //y2=1.4
cc_172 ( N_noxref_1_c_172_p N_SN_c_1739_n ) capacitor c=0.0124075f //x=9.97 \
 //y=1.4 //x2=10.415 //y2=1.4
cc_173 ( N_noxref_1_c_170_p N_SN_c_1741_n ) capacitor c=9.19165e-19 //x=9.97 \
 //y=1.055 //x2=10.94 //y2=1.09
cc_174 ( N_noxref_1_c_172_p N_SN_c_1742_n ) capacitor c=0.0010154f //x=9.97 \
 //y=1.4 //x2=10.94 //y2=1.4
cc_175 ( N_noxref_1_c_172_p N_SN_c_1743_n ) capacitor c=9.23422e-19 //x=9.97 \
 //y=1.4 //x2=10.94 //y2=1.63
cc_176 ( N_noxref_1_c_74_p N_SN_c_1744_n ) capacitor c=5.616e-19 //x=9.74 \
 //y=2.375 //x2=10.94 //y2=2.095
cc_177 ( N_noxref_1_c_150_p N_SN_c_1744_n ) capacitor c=0.0017273f //x=9.74 \
 //y=2.26 //x2=10.94 //y2=2.095
cc_178 ( N_noxref_1_c_151_p N_SN_c_1744_n ) capacitor c=0.00880777f //x=9.44 \
 //y=2.095 //x2=10.94 //y2=2.095
cc_179 ( N_noxref_1_c_26_p N_SN_c_1747_n ) capacitor c=0.00116212f //x=9.74 \
 //y=4.755 //x2=10.85 //y2=4.88
cc_180 ( N_noxref_1_c_147_p N_SN_c_1747_n ) capacitor c=0.00155973f //x=9.74 \
 //y=4.88 //x2=10.85 //y2=4.88
cc_181 ( N_noxref_1_c_4_p N_SN_c_1747_n ) capacitor c=0.0171374f //x=10.305 \
 //y=4.97 //x2=10.85 //y2=4.88
cc_182 ( N_noxref_1_c_155_p N_SN_c_1747_n ) capacitor c=0.00484466f //x=10.015 \
 //y=4.97 //x2=10.85 //y2=4.88
cc_183 ( N_noxref_1_c_16_p N_noxref_7_c_2047_n ) capacitor c=0.00309026f \
 //x=9.58 //y=2.775 //x2=7.15 //y2=2.375
cc_184 ( N_noxref_1_c_11_p N_noxref_7_c_2048_n ) capacitor c=3.89313e-19 \
 //x=4.93 //y=2.61 //x2=7.15 //y2=3.705
cc_185 ( N_noxref_1_c_13_p N_noxref_7_c_2048_n ) capacitor c=7.01483e-19 \
 //x=4.93 //y=4.755 //x2=7.15 //y2=3.705
cc_186 ( N_noxref_1_c_75_p N_noxref_7_c_2048_n ) capacitor c=6.49065e-19 \
 //x=9.74 //y=2.615 //x2=7.15 //y2=3.705
cc_187 ( N_noxref_1_c_26_p N_noxref_7_c_2048_n ) capacitor c=7.8587e-19 \
 //x=9.74 //y=4.755 //x2=7.15 //y2=3.705
cc_188 ( N_noxref_1_c_16_p N_noxref_7_c_2048_n ) capacitor c=0.0299047f \
 //x=9.58 //y=2.775 //x2=7.15 //y2=3.705
cc_189 ( N_noxref_1_c_16_p N_noxref_7_c_2053_n ) capacitor c=0.00271462f \
 //x=9.58 //y=2.775 //x2=7.15 //y2=4.025
cc_190 ( N_noxref_1_c_13_p N_noxref_7_c_2054_n ) capacitor c=0.00107139f \
 //x=4.93 //y=4.755 //x2=7.15 //y2=4.75
cc_191 ( N_noxref_1_c_26_p N_noxref_7_c_2054_n ) capacitor c=0.00104627f \
 //x=9.74 //y=4.755 //x2=7.15 //y2=4.75
cc_192 ( N_noxref_1_c_75_p N_noxref_7_c_2056_n ) capacitor c=4.47631e-19 \
 //x=9.74 //y=2.615 //x2=11.96 //y2=3.705
cc_193 ( N_noxref_1_c_26_p N_noxref_7_c_2056_n ) capacitor c=6.96952e-19 \
 //x=9.74 //y=4.755 //x2=11.96 //y2=3.705
cc_194 ( N_noxref_1_c_26_p N_noxref_7_c_2058_n ) capacitor c=5.89264e-19 \
 //x=9.74 //y=4.755 //x2=11.96 //y2=4.75
cc_195 ( N_noxref_1_c_16_p N_noxref_7_c_2059_n ) capacitor c=0.0267006f \
 //x=9.58 //y=2.775 //x2=7.5 //y2=3.88
cc_196 ( N_noxref_1_c_76_p N_noxref_7_c_2060_n ) capacitor c=0.00350734f \
 //x=9.74 //y=2.935 //x2=12.12 //y2=3.88
cc_197 ( N_noxref_1_c_26_p N_noxref_7_c_2060_n ) capacitor c=0.0288892f \
 //x=9.74 //y=4.755 //x2=12.12 //y2=3.88
cc_198 ( N_noxref_1_c_78_p N_noxref_7_c_2060_n ) capacitor c=0.00843566f \
 //x=9.74 //y=2.775 //x2=12.12 //y2=3.88
cc_199 ( N_noxref_1_c_16_p N_noxref_7_c_2060_n ) capacitor c=0.0451914f \
 //x=9.58 //y=2.775 //x2=12.12 //y2=3.88
cc_200 ( N_noxref_1_c_16_p N_noxref_7_c_2064_n ) capacitor c=0.00831864f \
 //x=9.58 //y=2.775 //x2=7.315 //y2=3.865
cc_201 ( N_noxref_1_c_61_p N_VDD_c_2903_n ) capacitor c=0.00648294f //x=2.485 \
 //y=5.38 //x2=24.17 //y2=7.58
cc_202 ( N_noxref_1_c_113_p N_VDD_c_2903_n ) capacitor c=0.00488503f //x=2.995 \
 //y=5.38 //x2=24.17 //y2=7.58
cc_203 ( N_noxref_1_c_203_p N_VDD_c_2903_n ) capacitor c=0.00368834f //x=1.72 \
 //y=5.56 //x2=24.17 //y2=7.58
cc_204 ( N_noxref_1_c_64_p N_VDD_c_2903_n ) capacitor c=8.42537e-19 //x=2.6 \
 //y=5.38 //x2=24.17 //y2=7.58
cc_205 ( N_noxref_1_c_205_p N_VDD_c_2903_n ) capacitor c=0.00285853f //x=2.6 \
 //y=5.56 //x2=24.17 //y2=7.58
cc_206 ( N_noxref_1_c_206_p N_VDD_c_2903_n ) capacitor c=0.00224881f //x=1.72 \
 //y=5.56 //x2=24.17 //y2=7.58
cc_207 ( N_noxref_1_c_65_p N_VDD_c_2903_n ) capacitor c=0.00224881f //x=2.6 \
 //y=5.56 //x2=24.17 //y2=7.58
cc_208 ( N_noxref_1_c_61_p N_VDD_c_2910_n ) capacitor c=0.00213203f //x=2.485 \
 //y=5.38 //x2=2.075 //y2=7.585
cc_209 ( N_noxref_1_c_203_p N_VDD_c_2910_n ) capacitor c=9.99055e-19 //x=1.72 \
 //y=5.56 //x2=2.075 //y2=7.585
cc_210 ( N_noxref_1_c_206_p N_VDD_c_2910_n ) capacitor c=0.0136705f //x=1.72 \
 //y=5.56 //x2=2.075 //y2=7.585
cc_211 ( N_noxref_1_c_61_p N_VDD_c_2913_n ) capacitor c=0.00180737f //x=2.485 \
 //y=5.38 //x2=2.955 //y2=7.585
cc_212 ( N_noxref_1_c_113_p N_VDD_c_2913_n ) capacitor c=0.00208087f //x=2.995 \
 //y=5.38 //x2=2.955 //y2=7.585
cc_213 ( N_noxref_1_c_64_p N_VDD_c_2913_n ) capacitor c=4.23719e-19 //x=2.6 \
 //y=5.38 //x2=2.955 //y2=7.585
cc_214 ( N_noxref_1_c_205_p N_VDD_c_2913_n ) capacitor c=5.77976e-19 //x=2.6 \
 //y=5.56 //x2=2.955 //y2=7.585
cc_215 ( N_noxref_1_c_65_p N_VDD_c_2913_n ) capacitor c=0.0136705f //x=2.6 \
 //y=5.56 //x2=2.955 //y2=7.585
cc_216 ( N_noxref_1_M19_noxref_g N_VDD_c_2918_n ) capacitor c=0.00755614f \
 //x=5.13 //y=6.2 //x2=5.705 //y2=7.585
cc_217 ( N_noxref_1_M20_noxref_g N_VDD_c_2918_n ) capacitor c=0.00755544f \
 //x=5.57 //y=6.2 //x2=5.705 //y2=7.585
cc_218 ( N_noxref_1_M25_noxref_g N_VDD_c_2920_n ) capacitor c=0.00755614f \
 //x=9.94 //y=6.2 //x2=10.515 //y2=7.585
cc_219 ( N_noxref_1_M26_noxref_g N_VDD_c_2920_n ) capacitor c=0.00755544f \
 //x=10.38 //y=6.2 //x2=10.515 //y2=7.585
cc_220 ( N_noxref_1_c_10_p N_VDD_c_2922_n ) capacitor c=0.00197052f //x=3.08 \
 //y=5.295 //x2=1.23 //y2=7.58
cc_221 ( N_noxref_1_c_203_p N_VDD_c_2922_n ) capacitor c=6.39392e-19 //x=1.72 \
 //y=5.56 //x2=1.23 //y2=7.58
cc_222 ( N_noxref_1_c_206_p N_VDD_c_2922_n ) capacitor c=0.0064135f //x=1.72 \
 //y=5.56 //x2=1.23 //y2=7.58
cc_223 ( N_noxref_1_c_10_p N_VDD_c_2925_n ) capacitor c=0.0306839f //x=3.08 \
 //y=5.295 //x2=3.82 //y2=7.585
cc_224 ( N_noxref_1_c_13_p N_VDD_c_2925_n ) capacitor c=0.0135962f //x=4.93 \
 //y=4.755 //x2=3.82 //y2=7.585
cc_225 ( N_noxref_1_c_64_p N_VDD_c_2925_n ) capacitor c=0.0025639f //x=2.6 \
 //y=5.38 //x2=3.82 //y2=7.585
cc_226 ( N_noxref_1_c_205_p N_VDD_c_2925_n ) capacitor c=4.19141e-19 //x=2.6 \
 //y=5.56 //x2=3.82 //y2=7.585
cc_227 ( N_noxref_1_c_94_p N_VDD_c_2925_n ) capacitor c=0.00182463f //x=4.77 \
 //y=2.77 //x2=3.82 //y2=7.585
cc_228 ( N_noxref_1_c_65_p N_VDD_c_2925_n ) capacitor c=0.0101861f //x=2.6 \
 //y=5.56 //x2=3.82 //y2=7.585
cc_229 ( N_noxref_1_c_23_p N_VDD_c_2925_n ) capacitor c=0.00370784f //x=4.93 \
 //y=4.88 //x2=3.82 //y2=7.585
cc_230 ( N_noxref_1_c_25_p N_VDD_c_2925_n ) capacitor c=0.00590568f //x=5.205 \
 //y=4.97 //x2=3.82 //y2=7.585
cc_231 ( N_noxref_1_c_26_p N_VDD_c_2933_n ) capacitor c=0.0116769f //x=9.74 \
 //y=4.755 //x2=8.63 //y2=7.585
cc_232 ( N_noxref_1_c_147_p N_VDD_c_2933_n ) capacitor c=0.00370784f //x=9.74 \
 //y=4.88 //x2=8.63 //y2=7.585
cc_233 ( N_noxref_1_c_155_p N_VDD_c_2933_n ) capacitor c=0.00590568f \
 //x=10.015 //y=4.97 //x2=8.63 //y2=7.585
cc_234 ( N_noxref_1_c_203_p N_VDD_M15_noxref_s ) capacitor c=0.062494f \
 //x=1.72 //y=5.56 //x2=1.145 //y2=5.2
cc_235 ( N_noxref_1_c_64_p N_VDD_M15_noxref_s ) capacitor c=6.52457e-19 \
 //x=2.6 //y=5.38 //x2=1.145 //y2=5.2
cc_236 ( N_noxref_1_c_206_p N_VDD_M15_noxref_s ) capacitor c=0.0906717f \
 //x=1.72 //y=5.56 //x2=1.145 //y2=5.2
cc_237 ( N_noxref_1_c_61_p N_VDD_M16_noxref_d ) capacitor c=0.00784504f \
 //x=2.485 //y=5.38 //x2=2.015 //y2=5.2
cc_238 ( N_noxref_1_c_203_p N_VDD_M16_noxref_d ) capacitor c=0.0043528f \
 //x=1.72 //y=5.56 //x2=2.015 //y2=5.2
cc_239 ( N_noxref_1_c_205_p N_VDD_M16_noxref_d ) capacitor c=0.0043528f \
 //x=2.6 //y=5.56 //x2=2.015 //y2=5.2
cc_240 ( N_noxref_1_c_206_p N_VDD_M16_noxref_d ) capacitor c=0.065554f \
 //x=1.72 //y=5.56 //x2=2.015 //y2=5.2
cc_241 ( N_noxref_1_c_65_p N_VDD_M16_noxref_d ) capacitor c=0.065554f //x=2.6 \
 //y=5.56 //x2=2.015 //y2=5.2
cc_242 ( N_noxref_1_c_113_p N_VDD_M18_noxref_d ) capacitor c=0.00983727f \
 //x=2.995 //y=5.38 //x2=2.895 //y2=5.2
cc_243 ( N_noxref_1_c_205_p N_VDD_M18_noxref_d ) capacitor c=0.00955781f \
 //x=2.6 //y=5.56 //x2=2.895 //y2=5.2
cc_244 ( N_noxref_1_c_59_p N_VDD_M18_noxref_d ) capacitor c=6.87256e-19 \
 //x=3.08 //y=2.77 //x2=2.895 //y2=5.2
cc_245 ( N_noxref_1_c_65_p N_VDD_M18_noxref_d ) capacitor c=0.065554f //x=2.6 \
 //y=5.56 //x2=2.895 //y2=5.2
cc_246 ( N_noxref_1_c_113_p N_VDD_M19_noxref_s ) capacitor c=0.00220019f \
 //x=2.995 //y=5.38 //x2=4.775 //y2=5.2
cc_247 ( N_noxref_1_c_12_p N_VDD_M19_noxref_s ) capacitor c=4.52606e-19 \
 //x=4.93 //y=2.93 //x2=4.775 //y2=5.2
cc_248 ( N_noxref_1_c_13_p N_VDD_M19_noxref_s ) capacitor c=0.0224586f \
 //x=4.93 //y=4.755 //x2=4.775 //y2=5.2
cc_249 ( N_noxref_1_c_64_p N_VDD_M19_noxref_s ) capacitor c=0.00371125f \
 //x=2.6 //y=5.38 //x2=4.775 //y2=5.2
cc_250 ( N_noxref_1_c_205_p N_VDD_M19_noxref_s ) capacitor c=9.52042e-19 \
 //x=2.6 //y=5.56 //x2=4.775 //y2=5.2
cc_251 ( N_noxref_1_c_23_p N_VDD_M19_noxref_s ) capacitor c=0.00911317f \
 //x=4.93 //y=4.88 //x2=4.775 //y2=5.2
cc_252 ( N_noxref_1_M19_noxref_g N_VDD_M19_noxref_s ) capacitor c=0.053419f \
 //x=5.13 //y=6.2 //x2=4.775 //y2=5.2
cc_253 ( N_noxref_1_c_25_p N_VDD_M19_noxref_s ) capacitor c=0.00608913f \
 //x=5.205 //y=4.97 //x2=4.775 //y2=5.2
cc_254 ( N_noxref_1_M20_noxref_g N_VDD_M20_noxref_d ) capacitor c=0.015318f \
 //x=5.57 //y=6.2 //x2=5.645 //y2=5.2
cc_255 ( N_noxref_1_c_76_p N_VDD_M25_noxref_s ) capacitor c=4.37432e-19 \
 //x=9.74 //y=2.935 //x2=9.585 //y2=5.2
cc_256 ( N_noxref_1_c_26_p N_VDD_M25_noxref_s ) capacitor c=0.0217981f \
 //x=9.74 //y=4.755 //x2=9.585 //y2=5.2
cc_257 ( N_noxref_1_c_147_p N_VDD_M25_noxref_s ) capacitor c=0.00983413f \
 //x=9.74 //y=4.88 //x2=9.585 //y2=5.2
cc_258 ( N_noxref_1_M25_noxref_g N_VDD_M25_noxref_s ) capacitor c=0.053419f \
 //x=9.94 //y=6.2 //x2=9.585 //y2=5.2
cc_259 ( N_noxref_1_c_155_p N_VDD_M25_noxref_s ) capacitor c=0.00608899f \
 //x=10.015 //y=4.97 //x2=9.585 //y2=5.2
cc_260 ( N_noxref_1_M26_noxref_g N_VDD_M26_noxref_d ) capacitor c=0.015318f \
 //x=10.38 //y=6.2 //x2=10.455 //y2=5.2
cc_261 ( N_noxref_1_c_9_p D ) capacitor c=0.00102483f //x=3.08 //y=2.61 \
 //x2=1.6 //y2=2.77
cc_262 ( N_noxref_1_c_10_p D ) capacitor c=0.00469187f //x=3.08 //y=5.295 \
 //x2=1.6 //y2=2.77
cc_263 ( N_noxref_1_c_203_p N_D_c_3295_n ) capacitor c=0.0118546f //x=1.72 \
 //y=5.56 //x2=1.6 //y2=4.88
cc_264 ( N_noxref_1_c_206_p N_D_c_3295_n ) capacitor c=0.00165549f //x=1.72 \
 //y=5.56 //x2=1.6 //y2=4.88
cc_265 ( N_noxref_1_c_203_p N_D_c_3297_n ) capacitor c=0.00277154f //x=1.72 \
 //y=5.56 //x2=1.6 //y2=4.88
cc_266 ( N_noxref_1_c_206_p N_D_c_3297_n ) capacitor c=0.00377369f //x=1.72 \
 //y=5.56 //x2=1.6 //y2=4.88
cc_267 ( N_noxref_1_c_203_p N_D_M15_noxref_g ) capacitor c=0.0020878f //x=1.72 \
 //y=5.56 //x2=1.5 //y2=6.2
cc_268 ( N_noxref_1_c_206_p N_D_M15_noxref_g ) capacitor c=0.0158358f //x=1.72 \
 //y=5.56 //x2=1.5 //y2=6.2
cc_269 ( N_noxref_1_c_61_p N_D_M16_noxref_g ) capacitor c=0.0129249f //x=2.485 \
 //y=5.38 //x2=1.94 //y2=6.2
cc_270 ( N_noxref_1_c_203_p N_D_M16_noxref_g ) capacitor c=0.00192712f \
 //x=1.72 //y=5.56 //x2=1.94 //y2=6.2
cc_271 ( N_noxref_1_c_206_p N_D_M16_noxref_g ) capacitor c=0.0178987f //x=1.72 \
 //y=5.56 //x2=1.94 //y2=6.2
cc_272 ( N_noxref_1_c_203_p N_D_c_3304_n ) capacitor c=0.00207241f //x=1.72 \
 //y=5.56 //x2=1.6 //y2=4.88
cc_273 ( N_noxref_1_c_206_p N_D_c_3304_n ) capacitor c=0.0043218f //x=1.72 \
 //y=5.56 //x2=1.6 //y2=4.88
cc_274 ( N_noxref_1_c_16_p N_noxref_11_c_3393_n ) capacitor c=0.00528251f \
 //x=9.58 //y=2.775 //x2=6.835 //y2=1.175
cc_275 ( N_noxref_1_c_16_p N_noxref_11_c_3394_n ) capacitor c=2.88753e-19 \
 //x=9.58 //y=2.775 //x2=7.805 //y2=0.72
cc_276 ( N_noxref_1_c_116_p N_noxref_11_M3_noxref_d ) capacitor c=3.39394e-19 \
 //x=2.64 //y=1.18 //x2=5.68 //y2=1.09
cc_277 ( N_noxref_1_c_16_p N_noxref_11_M3_noxref_d ) capacitor c=0.00581656f \
 //x=9.58 //y=2.775 //x2=5.68 //y2=1.09
cc_278 ( N_noxref_1_c_16_p N_noxref_11_M4_noxref_s ) capacitor c=0.00354674f \
 //x=9.58 //y=2.775 //x2=6.785 //y2=0.555
cc_279 ( N_noxref_1_c_71_p N_GND_c_3532_n ) capacitor c=0.00654514f //x=2.995 \
 //y=1.835 //x2=4.81 //y2=0.175
cc_280 ( N_noxref_1_c_55_p N_GND_c_3532_n ) capacitor c=5.98224e-19 //x=3.08 \
 //y=2.93 //x2=4.81 //y2=0.175
cc_281 ( N_noxref_1_c_116_p N_GND_c_3532_n ) capacitor c=0.00964814f //x=2.64 \
 //y=1.18 //x2=4.81 //y2=0.175
cc_282 ( N_noxref_1_M1_noxref_d N_GND_c_3532_n ) capacitor c=3.01769e-19 \
 //x=2.45 //y=1.085 //x2=4.81 //y2=0.175
cc_283 ( N_noxref_1_c_40_p N_GND_c_3536_n ) capacitor c=3.92414e-19 //x=4.63 \
 //y=1.055 //x2=4.895 //y2=1.015
cc_284 ( N_noxref_1_c_284_p N_GND_c_3536_n ) capacitor c=0.0085115f //x=5.005 \
 //y=0.9 //x2=4.895 //y2=1.015
cc_285 ( N_noxref_1_c_42_p N_GND_c_3536_n ) capacitor c=4.45447e-19 //x=5.16 \
 //y=1.055 //x2=4.895 //y2=1.015
cc_286 ( N_noxref_1_c_168_p N_GND_c_3539_n ) capacitor c=3.97665e-19 //x=9.44 \
 //y=1.055 //x2=9.705 //y2=1.015
cc_287 ( N_noxref_1_c_287_p N_GND_c_3539_n ) capacitor c=0.00864776f //x=9.815 \
 //y=0.9 //x2=9.705 //y2=1.015
cc_288 ( N_noxref_1_c_170_p N_GND_c_3539_n ) capacitor c=4.45447e-19 //x=9.97 \
 //y=1.055 //x2=9.705 //y2=1.015
cc_289 ( N_noxref_1_c_203_p N_GND_c_3542_n ) capacitor c=8.63752e-19 //x=1.72 \
 //y=5.56 //x2=1.67 //y2=1.135
cc_290 ( N_noxref_1_c_116_p N_GND_c_3542_n ) capacitor c=0.0141894f //x=2.64 \
 //y=1.18 //x2=1.67 //y2=1.135
cc_291 ( N_noxref_1_M1_noxref_d N_GND_c_3542_n ) capacitor c=2.93544e-19 \
 //x=2.45 //y=1.085 //x2=1.67 //y2=1.135
cc_292 ( N_noxref_1_c_18_p N_GND_c_3545_n ) capacitor c=0.00794777f //x=4.93 \
 //y=2.375 //x2=4.895 //y2=1.145
cc_293 ( N_noxref_1_c_12_p N_GND_c_3545_n ) capacitor c=0.00108886f //x=4.93 \
 //y=2.93 //x2=4.895 //y2=1.145
cc_294 ( N_noxref_1_c_116_p N_GND_c_3545_n ) capacitor c=0.00606355f //x=2.64 \
 //y=1.18 //x2=4.895 //y2=1.145
cc_295 ( N_noxref_1_c_15_p N_GND_c_3545_n ) capacitor c=0.00335863f //x=5.09 \
 //y=2.77 //x2=4.895 //y2=1.145
cc_296 ( N_noxref_1_c_17_p N_GND_c_3545_n ) capacitor c=2.22883e-19 //x=4.93 \
 //y=2.26 //x2=4.895 //y2=1.145
cc_297 ( N_noxref_1_c_40_p N_GND_c_3545_n ) capacitor c=0.0015128f //x=4.63 \
 //y=1.055 //x2=4.895 //y2=1.145
cc_298 ( N_noxref_1_c_41_p N_GND_c_3545_n ) capacitor c=0.00350108f //x=4.63 \
 //y=1.4 //x2=4.895 //y2=1.145
cc_299 ( N_noxref_1_c_43_p N_GND_c_3545_n ) capacitor c=4.09667e-19 //x=4.63 \
 //y=1.71 //x2=4.895 //y2=1.145
cc_300 ( N_noxref_1_c_284_p N_GND_c_3545_n ) capacitor c=9.36995e-19 //x=5.005 \
 //y=0.9 //x2=4.895 //y2=1.145
cc_301 ( N_noxref_1_c_301_p N_GND_c_3545_n ) capacitor c=5.27793e-19 //x=5.005 \
 //y=1.555 //x2=4.895 //y2=1.145
cc_302 ( N_noxref_1_c_42_p N_GND_c_3545_n ) capacitor c=0.0017438f //x=5.16 \
 //y=1.055 //x2=4.895 //y2=1.145
cc_303 ( N_noxref_1_c_44_p N_GND_c_3545_n ) capacitor c=0.00276804f //x=5.16 \
 //y=1.4 //x2=4.895 //y2=1.145
cc_304 ( N_noxref_1_c_74_p N_GND_c_3557_n ) capacitor c=0.00795095f //x=9.74 \
 //y=2.375 //x2=9.705 //y2=1.145
cc_305 ( N_noxref_1_c_76_p N_GND_c_3557_n ) capacitor c=0.00120974f //x=9.74 \
 //y=2.935 //x2=9.705 //y2=1.145
cc_306 ( N_noxref_1_c_78_p N_GND_c_3557_n ) capacitor c=0.00334868f //x=9.74 \
 //y=2.775 //x2=9.705 //y2=1.145
cc_307 ( N_noxref_1_c_150_p N_GND_c_3557_n ) capacitor c=2.22883e-19 //x=9.74 \
 //y=2.26 //x2=9.705 //y2=1.145
cc_308 ( N_noxref_1_c_168_p N_GND_c_3557_n ) capacitor c=0.00156339f //x=9.44 \
 //y=1.055 //x2=9.705 //y2=1.145
cc_309 ( N_noxref_1_c_169_p N_GND_c_3557_n ) capacitor c=0.00352472f //x=9.44 \
 //y=1.4 //x2=9.705 //y2=1.145
cc_310 ( N_noxref_1_c_171_p N_GND_c_3557_n ) capacitor c=3.85805e-19 //x=9.44 \
 //y=1.71 //x2=9.705 //y2=1.145
cc_311 ( N_noxref_1_c_287_p N_GND_c_3557_n ) capacitor c=9.36995e-19 //x=9.815 \
 //y=0.9 //x2=9.705 //y2=1.145
cc_312 ( N_noxref_1_c_312_p N_GND_c_3557_n ) capacitor c=5.28241e-19 //x=9.815 \
 //y=1.555 //x2=9.705 //y2=1.145
cc_313 ( N_noxref_1_c_170_p N_GND_c_3557_n ) capacitor c=0.0017438f //x=9.97 \
 //y=1.055 //x2=9.705 //y2=1.145
cc_314 ( N_noxref_1_c_172_p N_GND_c_3557_n ) capacitor c=0.00276804f //x=9.97 \
 //y=1.4 //x2=9.705 //y2=1.145
cc_315 ( N_noxref_1_c_71_p N_GND_c_3568_n ) capacitor c=7.75992e-19 //x=2.995 \
 //y=1.835 //x2=3.65 //y2=0.175
cc_316 ( N_noxref_1_c_55_p N_GND_c_3568_n ) capacitor c=4.78337e-19 //x=3.08 \
 //y=2.93 //x2=3.65 //y2=0.175
cc_317 ( N_noxref_1_c_9_p N_GND_c_3570_n ) capacitor c=0.00139243f //x=3.08 \
 //y=2.61 //x2=1.23 //y2=0.18
cc_318 ( N_noxref_1_c_59_p N_GND_c_3570_n ) capacitor c=0.00133285f //x=3.08 \
 //y=2.77 //x2=1.23 //y2=0.18
cc_319 ( N_noxref_1_c_40_p N_GND_c_3572_n ) capacitor c=0.00677849f //x=4.63 \
 //y=1.055 //x2=8.46 //y2=0.175
cc_320 ( N_noxref_1_c_168_p N_GND_c_3573_n ) capacitor c=0.00677849f //x=9.44 \
 //y=1.055 //x2=13.27 //y2=0.175
cc_321 ( N_noxref_1_c_118_p N_GND_c_3574_n ) capacitor c=0.00460657f //x=2.64 \
 //y=1.75 //x2=3.82 //y2=0.175
cc_322 ( N_noxref_1_c_71_p N_GND_c_3574_n ) capacitor c=0.0229266f //x=2.995 \
 //y=1.835 //x2=3.82 //y2=0.175
cc_323 ( N_noxref_1_c_55_p N_GND_c_3574_n ) capacitor c=0.00430881f //x=3.08 \
 //y=2.93 //x2=3.82 //y2=0.175
cc_324 ( N_noxref_1_c_18_p N_GND_c_3574_n ) capacitor c=0.00407472f //x=4.93 \
 //y=2.375 //x2=3.82 //y2=0.175
cc_325 ( N_noxref_1_c_11_p N_GND_c_3574_n ) capacitor c=0.00468396f //x=4.93 \
 //y=2.61 //x2=3.82 //y2=0.175
cc_326 ( N_noxref_1_c_12_p N_GND_c_3574_n ) capacitor c=0.00272321f //x=4.93 \
 //y=2.93 //x2=3.82 //y2=0.175
cc_327 ( N_noxref_1_c_59_p N_GND_c_3574_n ) capacitor c=0.0101608f //x=3.08 \
 //y=2.77 //x2=3.82 //y2=0.175
cc_328 ( N_noxref_1_c_14_p N_GND_c_3574_n ) capacitor c=0.00539296f //x=4.93 \
 //y=2.765 //x2=3.82 //y2=0.175
cc_329 ( N_noxref_1_c_94_p N_GND_c_3574_n ) capacitor c=0.0217368f //x=4.77 \
 //y=2.77 //x2=3.82 //y2=0.175
cc_330 ( N_noxref_1_c_17_p N_GND_c_3574_n ) capacitor c=0.00394652f //x=4.93 \
 //y=2.26 //x2=3.82 //y2=0.175
cc_331 ( N_noxref_1_c_43_p N_GND_c_3574_n ) capacitor c=0.00170145f //x=4.63 \
 //y=1.71 //x2=3.82 //y2=0.175
cc_332 ( N_noxref_1_c_21_p N_GND_c_3574_n ) capacitor c=0.0103608f //x=4.63 \
 //y=2.095 //x2=3.82 //y2=0.175
cc_333 ( N_noxref_1_c_74_p N_GND_c_3586_n ) capacitor c=0.00439019f //x=9.74 \
 //y=2.375 //x2=8.63 //y2=0.175
cc_334 ( N_noxref_1_c_75_p N_GND_c_3586_n ) capacitor c=0.00436709f //x=9.74 \
 //y=2.615 //x2=8.63 //y2=0.175
cc_335 ( N_noxref_1_c_76_p N_GND_c_3586_n ) capacitor c=0.00311095f //x=9.74 \
 //y=2.935 //x2=8.63 //y2=0.175
cc_336 ( N_noxref_1_c_5_p N_GND_c_3586_n ) capacitor c=0.00528672f //x=9.74 \
 //y=2.77 //x2=8.63 //y2=0.175
cc_337 ( N_noxref_1_c_16_p N_GND_c_3586_n ) capacitor c=0.0235189f //x=9.58 \
 //y=2.775 //x2=8.63 //y2=0.175
cc_338 ( N_noxref_1_c_150_p N_GND_c_3586_n ) capacitor c=0.00394651f //x=9.74 \
 //y=2.26 //x2=8.63 //y2=0.175
cc_339 ( N_noxref_1_c_171_p N_GND_c_3586_n ) capacitor c=0.00170145f //x=9.44 \
 //y=1.71 //x2=8.63 //y2=0.175
cc_340 ( N_noxref_1_c_151_p N_GND_c_3586_n ) capacitor c=0.0103608f //x=9.44 \
 //y=2.095 //x2=8.63 //y2=0.175
cc_341 ( N_noxref_1_c_116_p N_GND_M0_noxref_d ) capacitor c=2.82748e-19 \
 //x=2.64 //y=1.18 //x2=1.48 //y2=1.045
cc_342 ( N_noxref_1_c_18_p N_GND_M2_noxref_d ) capacitor c=4.4417e-19 //x=4.93 \
 //y=2.375 //x2=4.705 //y2=1.055
cc_343 ( N_noxref_1_c_40_p N_GND_M2_noxref_d ) capacitor c=0.00184354f \
 //x=4.63 //y=1.055 //x2=4.705 //y2=1.055
cc_344 ( N_noxref_1_c_41_p N_GND_M2_noxref_d ) capacitor c=0.00210798f \
 //x=4.63 //y=1.4 //x2=4.705 //y2=1.055
cc_345 ( N_noxref_1_c_284_p N_GND_M2_noxref_d ) capacitor c=0.00474029f \
 //x=5.005 //y=0.9 //x2=4.705 //y2=1.055
cc_346 ( N_noxref_1_c_301_p N_GND_M2_noxref_d ) capacitor c=0.00166857f \
 //x=5.005 //y=1.555 //x2=4.705 //y2=1.055
cc_347 ( N_noxref_1_c_42_p N_GND_M2_noxref_d ) capacitor c=0.00230174f \
 //x=5.16 //y=1.055 //x2=4.705 //y2=1.055
cc_348 ( N_noxref_1_c_44_p N_GND_M2_noxref_d ) capacitor c=0.00210798f \
 //x=5.16 //y=1.4 //x2=4.705 //y2=1.055
cc_349 ( N_noxref_1_c_74_p N_GND_M5_noxref_d ) capacitor c=4.4417e-19 //x=9.74 \
 //y=2.375 //x2=9.515 //y2=1.055
cc_350 ( N_noxref_1_c_168_p N_GND_M5_noxref_d ) capacitor c=0.00184354f \
 //x=9.44 //y=1.055 //x2=9.515 //y2=1.055
cc_351 ( N_noxref_1_c_169_p N_GND_M5_noxref_d ) capacitor c=0.00210798f \
 //x=9.44 //y=1.4 //x2=9.515 //y2=1.055
cc_352 ( N_noxref_1_c_287_p N_GND_M5_noxref_d ) capacitor c=0.00474029f \
 //x=9.815 //y=0.9 //x2=9.515 //y2=1.055
cc_353 ( N_noxref_1_c_312_p N_GND_M5_noxref_d ) capacitor c=0.00166857f \
 //x=9.815 //y=1.555 //x2=9.515 //y2=1.055
cc_354 ( N_noxref_1_c_170_p N_GND_M5_noxref_d ) capacitor c=0.00230174f \
 //x=9.97 //y=1.055 //x2=9.515 //y2=1.055
cc_355 ( N_noxref_1_c_172_p N_GND_M5_noxref_d ) capacitor c=0.00210798f \
 //x=9.97 //y=1.4 //x2=9.515 //y2=1.055
cc_356 ( N_noxref_1_c_62_p N_noxref_15_c_4064_n ) capacitor c=0.0103386f \
 //x=2.725 //y=1.835 //x2=2.155 //y2=1.675
cc_357 ( N_noxref_1_c_71_p N_noxref_15_c_4065_n ) capacitor c=0.00373013f \
 //x=2.995 //y=1.835 //x2=3.04 //y2=0.71
cc_358 ( N_noxref_1_c_116_p N_noxref_15_c_4065_n ) capacitor c=0.00367971f \
 //x=2.64 //y=1.18 //x2=3.04 //y2=0.71
cc_359 ( N_noxref_1_M1_noxref_d N_noxref_15_c_4065_n ) capacitor c=0.00910163f \
 //x=2.45 //y=1.085 //x2=3.04 //y2=0.71
cc_360 ( N_noxref_1_c_118_p N_noxref_15_M0_noxref_s ) capacitor c=0.0190756f \
 //x=2.64 //y=1.75 //x2=1.05 //y2=0.545
cc_361 ( N_noxref_1_c_71_p N_noxref_15_M0_noxref_s ) capacitor c=0.0055349f \
 //x=2.995 //y=1.835 //x2=1.05 //y2=0.545
cc_362 ( N_noxref_1_c_55_p N_noxref_15_M0_noxref_s ) capacitor c=7.86324e-19 \
 //x=3.08 //y=2.93 //x2=1.05 //y2=0.545
cc_363 ( N_noxref_1_c_116_p N_noxref_15_M0_noxref_s ) capacitor c=0.00900047f \
 //x=2.64 //y=1.18 //x2=1.05 //y2=0.545
cc_364 ( N_noxref_1_c_59_p N_noxref_15_M0_noxref_s ) capacitor c=0.00202552f \
 //x=3.08 //y=2.77 //x2=1.05 //y2=0.545
cc_365 ( N_noxref_1_M1_noxref_d N_noxref_15_M0_noxref_s ) capacitor \
 c=0.0275552f //x=2.45 //y=1.085 //x2=1.05 //y2=0.545
cc_366 ( N_noxref_1_c_94_p N_noxref_16_c_4124_n ) capacitor c=0.00355253f \
 //x=4.77 //y=2.77 //x2=4.41 //y2=1.685
cc_367 ( N_noxref_1_c_21_p N_noxref_16_c_4124_n ) capacitor c=0.00262672f \
 //x=4.63 //y=2.095 //x2=4.41 //y2=1.685
cc_368 ( N_noxref_1_c_18_p N_noxref_16_c_4126_n ) capacitor c=0.00428451f \
 //x=4.93 //y=2.375 //x2=5.295 //y2=1.77
cc_369 ( N_noxref_1_c_12_p N_noxref_16_c_4126_n ) capacitor c=0.00374191f \
 //x=4.93 //y=2.93 //x2=5.295 //y2=1.77
cc_370 ( N_noxref_1_c_94_p N_noxref_16_c_4126_n ) capacitor c=0.00626727f \
 //x=4.77 //y=2.77 //x2=5.295 //y2=1.77
cc_371 ( N_noxref_1_c_16_p N_noxref_16_c_4126_n ) capacitor c=0.00196699f \
 //x=9.58 //y=2.775 //x2=5.295 //y2=1.77
cc_372 ( N_noxref_1_c_17_p N_noxref_16_c_4126_n ) capacitor c=0.0104666f \
 //x=4.93 //y=2.26 //x2=5.295 //y2=1.77
cc_373 ( N_noxref_1_c_43_p N_noxref_16_c_4126_n ) capacitor c=0.00705077f \
 //x=4.63 //y=1.71 //x2=5.295 //y2=1.77
cc_374 ( N_noxref_1_c_21_p N_noxref_16_c_4126_n ) capacitor c=0.0209271f \
 //x=4.63 //y=2.095 //x2=5.295 //y2=1.77
cc_375 ( N_noxref_1_c_301_p N_noxref_16_c_4126_n ) capacitor c=0.00588627f \
 //x=5.005 //y=1.555 //x2=5.295 //y2=1.77
cc_376 ( N_noxref_1_c_44_p N_noxref_16_c_4126_n ) capacitor c=0.00698822f \
 //x=5.16 //y=1.4 //x2=5.295 //y2=1.77
cc_377 ( N_noxref_1_c_16_p N_noxref_16_c_4135_n ) capacitor c=0.00982891f \
 //x=9.58 //y=2.775 //x2=6.265 //y2=1.77
cc_378 ( N_noxref_1_c_16_p N_noxref_16_M2_noxref_s ) capacitor c=0.00659617f \
 //x=9.58 //y=2.775 //x2=4.275 //y2=0.555
cc_379 ( N_noxref_1_c_40_p N_noxref_16_M2_noxref_s ) capacitor c=0.0295256f \
 //x=4.63 //y=1.055 //x2=4.275 //y2=0.555
cc_380 ( N_noxref_1_c_43_p N_noxref_16_M2_noxref_s ) capacitor c=7.99997e-19 \
 //x=4.63 //y=1.71 //x2=4.275 //y2=0.555
cc_381 ( N_noxref_1_c_21_p N_noxref_16_M2_noxref_s ) capacitor c=0.00122123f \
 //x=4.63 //y=2.095 //x2=4.275 //y2=0.555
cc_382 ( N_noxref_1_c_42_p N_noxref_16_M2_noxref_s ) capacitor c=0.0125924f \
 //x=5.16 //y=1.055 //x2=4.275 //y2=0.555
cc_383 ( N_noxref_1_c_16_p N_noxref_17_c_4184_n ) capacitor c=0.00375801f \
 //x=9.58 //y=2.775 //x2=9.22 //y2=1.685
cc_384 ( N_noxref_1_c_151_p N_noxref_17_c_4184_n ) capacitor c=0.00262672f \
 //x=9.44 //y=2.095 //x2=9.22 //y2=1.685
cc_385 ( N_noxref_1_c_74_p N_noxref_17_c_4186_n ) capacitor c=0.00428451f \
 //x=9.74 //y=2.375 //x2=10.105 //y2=1.77
cc_386 ( N_noxref_1_c_76_p N_noxref_17_c_4186_n ) capacitor c=0.00449871f \
 //x=9.74 //y=2.935 //x2=10.105 //y2=1.77
cc_387 ( N_noxref_1_c_16_p N_noxref_17_c_4186_n ) capacitor c=0.00407827f \
 //x=9.58 //y=2.775 //x2=10.105 //y2=1.77
cc_388 ( N_noxref_1_c_150_p N_noxref_17_c_4186_n ) capacitor c=0.0104666f \
 //x=9.74 //y=2.26 //x2=10.105 //y2=1.77
cc_389 ( N_noxref_1_c_171_p N_noxref_17_c_4186_n ) capacitor c=0.00705077f \
 //x=9.44 //y=1.71 //x2=10.105 //y2=1.77
cc_390 ( N_noxref_1_c_151_p N_noxref_17_c_4186_n ) capacitor c=0.0201014f \
 //x=9.44 //y=2.095 //x2=10.105 //y2=1.77
cc_391 ( N_noxref_1_c_312_p N_noxref_17_c_4186_n ) capacitor c=0.00588627f \
 //x=9.815 //y=1.555 //x2=10.105 //y2=1.77
cc_392 ( N_noxref_1_c_172_p N_noxref_17_c_4186_n ) capacitor c=0.00754339f \
 //x=9.97 //y=1.4 //x2=10.105 //y2=1.77
cc_393 ( N_noxref_1_c_168_p N_noxref_17_M5_noxref_s ) capacitor c=0.0295256f \
 //x=9.44 //y=1.055 //x2=9.085 //y2=0.555
cc_394 ( N_noxref_1_c_171_p N_noxref_17_M5_noxref_s ) capacitor c=7.99997e-19 \
 //x=9.44 //y=1.71 //x2=9.085 //y2=0.555
cc_395 ( N_noxref_1_c_151_p N_noxref_17_M5_noxref_s ) capacitor c=0.00122123f \
 //x=9.44 //y=2.095 //x2=9.085 //y2=0.555
cc_396 ( N_noxref_1_c_170_p N_noxref_17_M5_noxref_s ) capacitor c=0.0125924f \
 //x=9.97 //y=1.055 //x2=9.085 //y2=0.555
cc_397 ( N_noxref_2_c_405_p CLK ) capacitor c=4.63397e-19 //x=12.7 //y=2.625 \
 //x2=15.29 //y2=2.77
cc_398 ( N_noxref_2_c_406_p CLK ) capacitor c=0.00217465f //x=12.7 //y=5.25 \
 //x2=15.29 //y2=2.77
cc_399 ( N_noxref_2_c_407_p CLK ) capacitor c=0.00839909f //x=14.55 //y=2.625 \
 //x2=15.29 //y2=2.77
cc_400 ( N_noxref_2_c_408_p CLK ) capacitor c=0.014957f //x=14.55 //y=2.945 \
 //x2=15.29 //y2=2.77
cc_401 ( N_noxref_2_c_409_p CLK ) capacitor c=6.6241e-19 //x=14.55 //y=2.77 \
 //x2=15.29 //y2=2.77
cc_402 ( N_noxref_2_c_410_p CLK ) capacitor c=0.0694743f //x=14.552 //y=4.74 \
 //x2=15.29 //y2=2.77
cc_403 ( N_noxref_2_c_411_p CLK ) capacitor c=0.00693435f //x=14.545 //y=2.785 \
 //x2=15.29 //y2=2.77
cc_404 ( N_noxref_2_c_412_p CLK ) capacitor c=3.30333e-19 //x=14.55 //y=2.26 \
 //x2=15.29 //y2=2.77
cc_405 ( N_noxref_2_c_413_p N_CLK_c_737_n ) capacitor c=0.0179797f //x=14.55 \
 //y=2.26 //x2=15.29 //y2=2.26
cc_406 ( N_noxref_2_c_412_p N_CLK_c_737_n ) capacitor c=5.16867e-19 //x=14.55 \
 //y=2.26 //x2=15.29 //y2=2.26
cc_407 ( N_noxref_2_c_415_p N_CLK_c_737_n ) capacitor c=0.00161745f //x=14.355 \
 //y=2.095 //x2=15.29 //y2=2.26
cc_408 ( N_noxref_2_c_416_p N_CLK_c_740_n ) capacitor c=0.0160977f //x=14.55 \
 //y=4.88 //x2=15.325 //y2=4.75
cc_409 ( N_noxref_2_c_410_p N_CLK_c_740_n ) capacitor c=0.00638948f //x=14.552 \
 //y=4.74 //x2=15.325 //y2=4.75
cc_410 ( N_noxref_2_c_418_p N_CLK_c_740_n ) capacitor c=0.00121956f //x=14.55 \
 //y=4.88 //x2=15.325 //y2=4.75
cc_411 ( N_noxref_2_c_419_p N_CLK_c_740_n ) capacitor c=0.00177782f //x=14.55 \
 //y=4.88 //x2=15.325 //y2=4.75
cc_412 ( N_noxref_2_c_420_p N_CLK_c_701_n ) capacitor c=0.0218207f //x=12.615 \
 //y=5.335 //x2=8.1 //y2=4.635
cc_413 ( N_noxref_2_c_406_p N_CLK_c_701_n ) capacitor c=0.0300365f //x=12.7 \
 //y=5.25 //x2=8.1 //y2=4.635
cc_414 ( N_noxref_2_c_398_n N_CLK_c_701_n ) capacitor c=0.0297372f //x=10.162 \
 //y=5.335 //x2=8.1 //y2=4.635
cc_415 ( N_noxref_2_c_423_p N_CLK_c_701_n ) capacitor c=0.0378349f //x=11.04 \
 //y=5.335 //x2=8.1 //y2=4.635
cc_416 ( N_noxref_2_c_416_p N_CLK_c_701_n ) capacitor c=0.00901811f //x=14.55 \
 //y=4.88 //x2=8.1 //y2=4.635
cc_417 ( N_noxref_2_c_410_p N_CLK_c_701_n ) capacitor c=0.0273494f //x=14.552 \
 //y=4.74 //x2=8.1 //y2=4.635
cc_418 ( N_noxref_2_c_407_p N_CLK_c_750_n ) capacitor c=3.30333e-19 //x=14.55 \
 //y=2.625 //x2=15.29 //y2=2.26
cc_419 ( N_noxref_2_c_413_p N_CLK_c_750_n ) capacitor c=5.24723e-19 //x=14.55 \
 //y=2.26 //x2=15.29 //y2=2.26
cc_420 ( N_noxref_2_c_412_p N_CLK_c_750_n ) capacitor c=0.00485709f //x=14.55 \
 //y=2.26 //x2=15.29 //y2=2.26
cc_421 ( N_noxref_2_c_415_p N_CLK_c_750_n ) capacitor c=0.00190888f //x=14.355 \
 //y=2.095 //x2=15.29 //y2=2.26
cc_422 ( N_noxref_2_c_416_p N_CLK_c_754_n ) capacitor c=4.80626e-19 //x=14.55 \
 //y=4.88 //x2=15.32 //y2=4.88
cc_423 ( N_noxref_2_c_418_p N_CLK_c_754_n ) capacitor c=0.0039678f //x=14.55 \
 //y=4.88 //x2=15.32 //y2=4.88
cc_424 ( N_noxref_2_c_419_p N_CLK_c_754_n ) capacitor c=0.0028411f //x=14.55 \
 //y=4.88 //x2=15.32 //y2=4.88
cc_425 ( N_noxref_2_M31_noxref_g N_CLK_M33_noxref_g ) capacitor c=0.0104892f \
 //x=14.45 //y=6.2 //x2=15.33 //y2=6.2
cc_426 ( N_noxref_2_M32_noxref_g N_CLK_M33_noxref_g ) capacitor c=0.107636f \
 //x=14.89 //y=6.2 //x2=15.33 //y2=6.2
cc_427 ( N_noxref_2_M32_noxref_g N_CLK_M34_noxref_g ) capacitor c=0.0100341f \
 //x=14.89 //y=6.2 //x2=15.77 //y2=6.2
cc_428 ( N_noxref_2_c_436_p N_CLK_c_760_n ) capacitor c=4.86545e-19 //x=14.355 \
 //y=1.045 //x2=15.325 //y2=1.085
cc_429 ( N_noxref_2_c_437_p N_CLK_c_760_n ) capacitor c=0.00152405f //x=14.355 \
 //y=1.39 //x2=15.325 //y2=1.085
cc_430 ( N_noxref_2_c_438_p N_CLK_c_760_n ) capacitor c=0.0151475f //x=14.885 \
 //y=1.045 //x2=15.325 //y2=1.085
cc_431 ( N_noxref_2_c_439_p N_CLK_c_763_n ) capacitor c=0.00109982f //x=14.355 \
 //y=1.7 //x2=15.325 //y2=1.43
cc_432 ( N_noxref_2_c_440_p N_CLK_c_763_n ) capacitor c=0.0111064f //x=14.885 \
 //y=1.39 //x2=15.325 //y2=1.43
cc_433 ( N_noxref_2_c_439_p N_CLK_c_765_n ) capacitor c=9.58243e-19 //x=14.355 \
 //y=1.7 //x2=15.325 //y2=1.74
cc_434 ( N_noxref_2_c_415_p N_CLK_c_765_n ) capacitor c=0.00662747f //x=14.355 \
 //y=2.095 //x2=15.325 //y2=1.74
cc_435 ( N_noxref_2_c_440_p N_CLK_c_765_n ) capacitor c=0.00862358f //x=14.885 \
 //y=1.39 //x2=15.325 //y2=1.74
cc_436 ( N_noxref_2_c_438_p N_CLK_c_768_n ) capacitor c=0.00127211f //x=14.885 \
 //y=1.045 //x2=15.855 //y2=1.085
cc_437 ( N_noxref_2_c_440_p N_CLK_c_769_n ) capacitor c=0.00204774f //x=14.885 \
 //y=1.39 //x2=15.855 //y2=1.43
cc_438 ( N_noxref_2_c_413_p N_CLK_c_770_n ) capacitor c=0.00161167f //x=14.55 \
 //y=2.26 //x2=15.29 //y2=2.26
cc_439 ( N_noxref_2_c_412_p N_CLK_c_770_n ) capacitor c=0.00266443f //x=14.55 \
 //y=2.26 //x2=15.29 //y2=2.26
cc_440 ( N_noxref_2_c_415_p N_CLK_c_770_n ) capacitor c=0.0181449f //x=14.355 \
 //y=2.095 //x2=15.29 //y2=2.26
cc_441 ( N_noxref_2_c_416_p N_CLK_c_773_n ) capacitor c=5.5856e-19 //x=14.55 \
 //y=4.88 //x2=15.32 //y2=4.88
cc_442 ( N_noxref_2_c_418_p N_CLK_c_773_n ) capacitor c=0.00211091f //x=14.55 \
 //y=4.88 //x2=15.32 //y2=4.88
cc_443 ( N_noxref_2_c_419_p N_CLK_c_773_n ) capacitor c=0.0291521f //x=14.55 \
 //y=4.88 //x2=15.32 //y2=4.88
cc_444 ( N_noxref_2_c_398_n N_noxref_4_c_1049_n ) capacitor c=6.09703e-19 \
 //x=10.162 //y=5.335 //x2=7.11 //y2=5.56
cc_445 ( N_noxref_2_c_398_n N_noxref_4_c_1050_n ) capacitor c=0.00306432f \
 //x=10.162 //y=5.335 //x2=7.805 //y2=5.335
cc_446 ( N_noxref_2_c_454_p N_noxref_4_c_1051_n ) capacitor c=0.00163399f \
 //x=12.3 //y=1.845 //x2=7.805 //y2=1.845
cc_447 ( N_noxref_2_c_406_p N_noxref_4_c_1009_n ) capacitor c=0.0233658f \
 //x=12.7 //y=5.25 //x2=17.72 //y2=4.265
cc_448 ( N_noxref_2_c_410_p N_noxref_4_c_1009_n ) capacitor c=0.0233519f \
 //x=14.552 //y=4.74 //x2=17.72 //y2=4.265
cc_449 ( N_noxref_2_c_457_p N_noxref_4_c_1009_n ) capacitor c=0.00564023f \
 //x=14.385 //y=2.785 //x2=17.72 //y2=4.265
cc_450 ( N_noxref_2_c_406_p SN ) capacitor c=0.00246091f //x=12.7 //y=5.25 \
 //x2=10.85 //y2=2.77
cc_451 ( N_noxref_2_c_397_n N_SN_c_1716_n ) capacitor c=3.45015e-19 //x=10.92 \
 //y=5.335 //x2=10.85 //y2=2.55
cc_452 ( N_noxref_2_c_423_p N_SN_c_1716_n ) capacitor c=4.44961e-19 //x=11.04 \
 //y=5.335 //x2=10.85 //y2=2.55
cc_453 ( N_noxref_2_c_397_n N_SN_c_1720_n ) capacitor c=0.0213631f //x=10.92 \
 //y=5.335 //x2=10.85 //y2=4.765
cc_454 ( N_noxref_2_c_423_p N_SN_c_1720_n ) capacitor c=0.00239361f //x=11.04 \
 //y=5.335 //x2=10.85 //y2=4.765
cc_455 ( N_noxref_2_c_463_p N_SN_c_1720_n ) capacitor c=7.85344e-19 //x=11.04 \
 //y=5.56 //x2=10.85 //y2=4.765
cc_456 ( N_noxref_2_c_464_p N_SN_c_1757_n ) capacitor c=7.08559e-19 //x=12.215 \
 //y=1.305 //x2=22.15 //y2=2.39
cc_457 ( N_noxref_2_c_454_p N_SN_c_1757_n ) capacitor c=0.0210985f //x=12.3 \
 //y=1.845 //x2=22.15 //y2=2.39
cc_458 ( N_noxref_2_c_405_p N_SN_c_1757_n ) capacitor c=0.0272596f //x=12.7 \
 //y=2.625 //x2=22.15 //y2=2.39
cc_459 ( N_noxref_2_c_467_p N_SN_c_1757_n ) capacitor c=0.00838306f //x=12.7 \
 //y=2.945 //x2=22.15 //y2=2.39
cc_460 ( N_noxref_2_c_407_p N_SN_c_1757_n ) capacitor c=0.0121034f //x=14.55 \
 //y=2.625 //x2=22.15 //y2=2.39
cc_461 ( N_noxref_2_c_408_p N_SN_c_1757_n ) capacitor c=0.00673157f //x=14.55 \
 //y=2.945 //x2=22.15 //y2=2.39
cc_462 ( N_noxref_2_c_413_p N_SN_c_1757_n ) capacitor c=0.0165635f //x=14.55 \
 //y=2.26 //x2=22.15 //y2=2.39
cc_463 ( N_noxref_2_c_471_p N_SN_c_1757_n ) capacitor c=0.0365231f //x=12.86 \
 //y=2.785 //x2=22.15 //y2=2.39
cc_464 ( N_noxref_2_c_411_p N_SN_c_1757_n ) capacitor c=0.0371276f //x=14.545 \
 //y=2.785 //x2=22.15 //y2=2.39
cc_465 ( N_noxref_2_c_457_p N_SN_c_1757_n ) capacitor c=0.139504f //x=14.385 \
 //y=2.785 //x2=22.15 //y2=2.39
cc_466 ( N_noxref_2_c_412_p N_SN_c_1757_n ) capacitor c=2.20453e-19 //x=14.55 \
 //y=2.26 //x2=22.15 //y2=2.39
cc_467 ( N_noxref_2_c_397_n N_SN_c_1729_n ) capacitor c=0.00492634f //x=10.92 \
 //y=5.335 //x2=10.85 //y2=4.88
cc_468 ( N_noxref_2_c_423_p N_SN_c_1729_n ) capacitor c=0.00132214f //x=11.04 \
 //y=5.335 //x2=10.85 //y2=4.88
cc_469 ( N_noxref_2_c_397_n N_SN_M27_noxref_g ) capacitor c=0.00858241f \
 //x=10.92 //y=5.335 //x2=10.82 //y2=6.2
cc_470 ( N_noxref_2_c_423_p N_SN_M27_noxref_g ) capacitor c=0.00229818f \
 //x=11.04 //y=5.335 //x2=10.82 //y2=6.2
cc_471 ( N_noxref_2_c_463_p N_SN_M27_noxref_g ) capacitor c=0.0179041f \
 //x=11.04 //y=5.56 //x2=10.82 //y2=6.2
cc_472 ( N_noxref_2_c_480_p N_SN_M28_noxref_g ) capacitor c=0.00955829f \
 //x=11.805 //y=5.335 //x2=11.26 //y2=6.2
cc_473 ( N_noxref_2_c_423_p N_SN_M28_noxref_g ) capacitor c=0.00230699f \
 //x=11.04 //y=5.335 //x2=11.26 //y2=6.2
cc_474 ( N_noxref_2_c_463_p N_SN_M28_noxref_g ) capacitor c=0.0179041f \
 //x=11.04 //y=5.56 //x2=11.26 //y2=6.2
cc_475 ( N_noxref_2_c_423_p N_SN_c_1776_n ) capacitor c=0.00181015f //x=11.04 \
 //y=5.335 //x2=11.185 //y2=4.97
cc_476 ( N_noxref_2_c_463_p N_SN_c_1776_n ) capacitor c=0.00290085f //x=11.04 \
 //y=5.56 //x2=11.185 //y2=4.97
cc_477 ( N_noxref_2_c_397_n N_SN_c_1747_n ) capacitor c=6.14744e-19 //x=10.92 \
 //y=5.335 //x2=10.85 //y2=4.88
cc_478 ( N_noxref_2_c_405_p N_noxref_7_c_2065_n ) capacitor c=0.013943f \
 //x=12.7 //y=2.625 //x2=11.96 //y2=2.375
cc_479 ( N_noxref_2_c_405_p N_noxref_7_c_2056_n ) capacitor c=0.00898347f \
 //x=12.7 //y=2.625 //x2=11.96 //y2=3.705
cc_480 ( N_noxref_2_c_467_p N_noxref_7_c_2056_n ) capacitor c=0.0151188f \
 //x=12.7 //y=2.945 //x2=11.96 //y2=3.705
cc_481 ( N_noxref_2_c_406_p N_noxref_7_c_2056_n ) capacitor c=0.0362911f \
 //x=12.7 //y=5.25 //x2=11.96 //y2=3.705
cc_482 ( N_noxref_2_c_407_p N_noxref_7_c_2056_n ) capacitor c=4.63723e-19 \
 //x=14.55 //y=2.625 //x2=11.96 //y2=3.705
cc_483 ( N_noxref_2_c_401_n N_noxref_7_c_2056_n ) capacitor c=6.77171e-19 \
 //x=12.7 //y=2.77 //x2=11.96 //y2=3.705
cc_484 ( N_noxref_2_c_410_p N_noxref_7_c_2056_n ) capacitor c=7.7565e-19 \
 //x=14.552 //y=4.74 //x2=11.96 //y2=3.705
cc_485 ( N_noxref_2_c_471_p N_noxref_7_c_2056_n ) capacitor c=0.00696908f \
 //x=12.86 //y=2.785 //x2=11.96 //y2=3.705
cc_486 ( N_noxref_2_c_480_p N_noxref_7_c_2073_n ) capacitor c=0.00167286f \
 //x=11.805 //y=5.335 //x2=11.96 //y2=4.025
cc_487 ( N_noxref_2_c_420_p N_noxref_7_c_2073_n ) capacitor c=4.08809e-19 \
 //x=12.615 //y=5.335 //x2=11.96 //y2=4.025
cc_488 ( N_noxref_2_c_406_p N_noxref_7_c_2073_n ) capacitor c=0.0148932f \
 //x=12.7 //y=5.25 //x2=11.96 //y2=4.025
cc_489 ( N_noxref_2_c_420_p N_noxref_7_c_2058_n ) capacitor c=0.00228791f \
 //x=12.615 //y=5.335 //x2=11.96 //y2=4.75
cc_490 ( N_noxref_2_c_406_p N_noxref_7_c_2058_n ) capacitor c=0.042978f \
 //x=12.7 //y=5.25 //x2=11.96 //y2=4.75
cc_491 ( N_noxref_2_c_499_p N_noxref_7_c_2058_n ) capacitor c=0.0221235f \
 //x=11.92 //y=5.335 //x2=11.96 //y2=4.75
cc_492 ( N_noxref_2_c_410_p N_noxref_7_c_2058_n ) capacitor c=8.71319e-19 \
 //x=14.552 //y=4.74 //x2=11.96 //y2=4.75
cc_493 ( N_noxref_2_c_501_p N_noxref_7_c_2058_n ) capacitor c=0.00217653f \
 //x=11.92 //y=5.56 //x2=11.96 //y2=4.75
cc_494 ( N_noxref_2_M32_noxref_g N_noxref_7_c_2081_n ) capacitor c=0.00889217f \
 //x=14.89 //y=6.2 //x2=15.435 //y2=5.38
cc_495 ( N_noxref_2_c_503_p N_noxref_7_c_2082_n ) capacitor c=0.00326079f \
 //x=12.215 //y=1.76 //x2=15.59 //y2=1.75
cc_496 ( N_noxref_2_c_504_p N_noxref_7_c_2083_n ) capacitor c=0.00218808f \
 //x=12.615 //y=1.845 //x2=15.675 //y2=1.835
cc_497 ( N_noxref_2_c_504_p N_noxref_7_c_2084_n ) capacitor c=0.00203605f \
 //x=12.615 //y=1.845 //x2=16.03 //y2=3.705
cc_498 ( N_noxref_2_c_407_p N_noxref_7_c_2084_n ) capacitor c=6.61269e-19 \
 //x=14.55 //y=2.625 //x2=16.03 //y2=3.705
cc_499 ( N_noxref_2_c_410_p N_noxref_7_c_2084_n ) capacitor c=0.00127779f \
 //x=14.552 //y=4.74 //x2=16.03 //y2=3.705
cc_500 ( N_noxref_2_c_406_p N_noxref_7_c_2087_n ) capacitor c=0.00283621f \
 //x=12.7 //y=5.25 //x2=16.03 //y2=5.295
cc_501 ( N_noxref_2_c_410_p N_noxref_7_c_2087_n ) capacitor c=0.00195062f \
 //x=14.552 //y=4.74 //x2=16.03 //y2=5.295
cc_502 ( N_noxref_2_c_406_p N_noxref_7_c_2089_n ) capacitor c=9.19401e-19 \
 //x=12.7 //y=5.25 //x2=11.96 //y2=3.88
cc_503 ( N_noxref_2_c_511_p N_noxref_7_c_2090_n ) capacitor c=5.58535e-19 \
 //x=11.92 //y=5.56 //x2=14.67 //y2=5.56
cc_504 ( N_noxref_2_c_420_p N_noxref_7_c_2090_n ) capacitor c=0.00104762f \
 //x=12.615 //y=5.335 //x2=14.67 //y2=5.56
cc_505 ( N_noxref_2_c_408_p N_noxref_7_c_2090_n ) capacitor c=4.02865e-19 \
 //x=14.55 //y=2.945 //x2=14.67 //y2=5.56
cc_506 ( N_noxref_2_c_416_p N_noxref_7_c_2090_n ) capacitor c=0.0117744f \
 //x=14.55 //y=4.88 //x2=14.67 //y2=5.56
cc_507 ( N_noxref_2_c_418_p N_noxref_7_c_2090_n ) capacitor c=0.00277154f \
 //x=14.55 //y=4.88 //x2=14.67 //y2=5.56
cc_508 ( N_noxref_2_M31_noxref_g N_noxref_7_c_2090_n ) capacitor c=0.00201806f \
 //x=14.45 //y=6.2 //x2=14.67 //y2=5.56
cc_509 ( N_noxref_2_M32_noxref_g N_noxref_7_c_2090_n ) capacitor c=0.00192712f \
 //x=14.89 //y=6.2 //x2=14.67 //y2=5.56
cc_510 ( N_noxref_2_c_419_p N_noxref_7_c_2090_n ) capacitor c=0.00200677f \
 //x=14.55 //y=4.88 //x2=14.67 //y2=5.56
cc_511 ( N_noxref_2_c_464_p N_noxref_7_c_2098_n ) capacitor c=6.5615e-19 \
 //x=12.215 //y=1.305 //x2=15.59 //y2=1.18
cc_512 ( N_noxref_2_c_406_p N_noxref_7_c_2060_n ) capacitor c=0.00336755f \
 //x=12.7 //y=5.25 //x2=12.12 //y2=3.88
cc_513 ( N_noxref_2_c_467_p N_noxref_7_c_2100_n ) capacitor c=0.00454204f \
 //x=12.7 //y=2.945 //x2=15.865 //y2=3.865
cc_514 ( N_noxref_2_c_406_p N_noxref_7_c_2100_n ) capacitor c=0.0268865f \
 //x=12.7 //y=5.25 //x2=15.865 //y2=3.865
cc_515 ( N_noxref_2_c_408_p N_noxref_7_c_2100_n ) capacitor c=0.00308731f \
 //x=14.55 //y=2.945 //x2=15.865 //y2=3.865
cc_516 ( N_noxref_2_c_410_p N_noxref_7_c_2100_n ) capacitor c=0.0272967f \
 //x=14.552 //y=4.74 //x2=15.865 //y2=3.865
cc_517 ( N_noxref_2_c_471_p N_noxref_7_c_2100_n ) capacitor c=0.00829423f \
 //x=12.86 //y=2.785 //x2=15.865 //y2=3.865
cc_518 ( N_noxref_2_c_411_p N_noxref_7_c_2100_n ) capacitor c=0.00830817f \
 //x=14.545 //y=2.785 //x2=15.865 //y2=3.865
cc_519 ( N_noxref_2_c_457_p N_noxref_7_c_2100_n ) capacitor c=0.0472182f \
 //x=14.385 //y=2.785 //x2=15.865 //y2=3.865
cc_520 ( N_noxref_2_c_405_p N_noxref_7_c_2107_n ) capacitor c=0.0015536f \
 //x=12.7 //y=2.625 //x2=11.96 //y2=2.26
cc_521 ( N_noxref_2_c_420_p N_noxref_7_c_2108_n ) capacitor c=0.00130631f \
 //x=12.615 //y=5.335 //x2=11.96 //y2=4.88
cc_522 ( N_noxref_2_c_406_p N_noxref_7_c_2108_n ) capacitor c=0.00131258f \
 //x=12.7 //y=5.25 //x2=11.96 //y2=4.88
cc_523 ( N_noxref_2_c_499_p N_noxref_7_c_2108_n ) capacitor c=0.00346456f \
 //x=11.92 //y=5.335 //x2=11.96 //y2=4.88
cc_524 ( N_noxref_2_c_501_p N_noxref_7_c_2108_n ) capacitor c=0.00624059f \
 //x=11.92 //y=5.56 //x2=11.96 //y2=4.88
cc_525 ( N_noxref_2_c_416_p N_noxref_7_c_2112_n ) capacitor c=0.00104426f \
 //x=14.55 //y=4.88 //x2=14.67 //y2=5.56
cc_526 ( N_noxref_2_c_418_p N_noxref_7_c_2112_n ) capacitor c=0.00377369f \
 //x=14.55 //y=4.88 //x2=14.67 //y2=5.56
cc_527 ( N_noxref_2_M31_noxref_g N_noxref_7_c_2112_n ) capacitor c=0.0158358f \
 //x=14.45 //y=6.2 //x2=14.67 //y2=5.56
cc_528 ( N_noxref_2_M32_noxref_g N_noxref_7_c_2112_n ) capacitor c=0.0178987f \
 //x=14.89 //y=6.2 //x2=14.67 //y2=5.56
cc_529 ( N_noxref_2_c_419_p N_noxref_7_c_2112_n ) capacitor c=0.0043218f \
 //x=14.55 //y=4.88 //x2=14.67 //y2=5.56
cc_530 ( N_noxref_2_c_480_p N_noxref_7_M29_noxref_g ) capacitor c=0.00952006f \
 //x=11.805 //y=5.335 //x2=11.7 //y2=6.2
cc_531 ( N_noxref_2_c_511_p N_noxref_7_M29_noxref_g ) capacitor c=0.00226521f \
 //x=11.92 //y=5.56 //x2=11.7 //y2=6.2
cc_532 ( N_noxref_2_c_501_p N_noxref_7_M29_noxref_g ) capacitor c=0.0178885f \
 //x=11.92 //y=5.56 //x2=11.7 //y2=6.2
cc_533 ( N_noxref_2_c_511_p N_noxref_7_M30_noxref_g ) capacitor c=0.00368945f \
 //x=11.92 //y=5.56 //x2=12.14 //y2=6.2
cc_534 ( N_noxref_2_c_420_p N_noxref_7_M30_noxref_g ) capacitor c=0.010861f \
 //x=12.615 //y=5.335 //x2=12.14 //y2=6.2
cc_535 ( N_noxref_2_c_501_p N_noxref_7_M30_noxref_g ) capacitor c=0.0188608f \
 //x=11.92 //y=5.56 //x2=12.14 //y2=6.2
cc_536 ( N_noxref_2_c_464_p N_noxref_7_c_2123_n ) capacitor c=4.64015e-19 \
 //x=12.215 //y=1.305 //x2=11.95 //y2=1.095
cc_537 ( N_noxref_2_M7_noxref_d N_noxref_7_c_2123_n ) capacitor c=0.00137165f \
 //x=12.025 //y=1.095 //x2=11.95 //y2=1.095
cc_538 ( N_noxref_2_c_464_p N_noxref_7_c_2125_n ) capacitor c=0.0026012f \
 //x=12.215 //y=1.305 //x2=11.95 //y2=1.44
cc_539 ( N_noxref_2_c_503_p N_noxref_7_c_2125_n ) capacitor c=0.00127432f \
 //x=12.215 //y=1.76 //x2=11.95 //y2=1.44
cc_540 ( N_noxref_2_M7_noxref_d N_noxref_7_c_2125_n ) capacitor c=0.00237422f \
 //x=12.025 //y=1.095 //x2=11.95 //y2=1.44
cc_541 ( N_noxref_2_c_503_p N_noxref_7_c_2128_n ) capacitor c=0.00429966f \
 //x=12.215 //y=1.76 //x2=11.95 //y2=1.75
cc_542 ( N_noxref_2_c_464_p N_noxref_7_c_2129_n ) capacitor c=5.29969e-19 \
 //x=12.215 //y=1.305 //x2=12.325 //y2=0.94
cc_543 ( N_noxref_2_M7_noxref_d N_noxref_7_c_2129_n ) capacitor c=0.0020782f \
 //x=12.025 //y=1.095 //x2=12.325 //y2=0.94
cc_544 ( N_noxref_2_c_464_p N_noxref_7_c_2131_n ) capacitor c=5.31507e-19 \
 //x=12.215 //y=1.305 //x2=12.325 //y2=1.595
cc_545 ( N_noxref_2_c_503_p N_noxref_7_c_2131_n ) capacitor c=0.00930387f \
 //x=12.215 //y=1.76 //x2=12.325 //y2=1.595
cc_546 ( N_noxref_2_c_504_p N_noxref_7_c_2131_n ) capacitor c=0.00194716f \
 //x=12.615 //y=1.845 //x2=12.325 //y2=1.595
cc_547 ( N_noxref_2_M7_noxref_d N_noxref_7_c_2131_n ) capacitor c=0.00356097f \
 //x=12.025 //y=1.095 //x2=12.325 //y2=1.595
cc_548 ( N_noxref_2_c_464_p N_noxref_7_c_2135_n ) capacitor c=5.28622e-19 \
 //x=12.215 //y=1.305 //x2=12.48 //y2=1.095
cc_549 ( N_noxref_2_M7_noxref_d N_noxref_7_c_2135_n ) capacitor c=0.00139206f \
 //x=12.025 //y=1.095 //x2=12.48 //y2=1.095
cc_550 ( N_noxref_2_c_464_p N_noxref_7_c_2137_n ) capacitor c=0.00312156f \
 //x=12.215 //y=1.305 //x2=12.48 //y2=1.44
cc_551 ( N_noxref_2_c_503_p N_noxref_7_c_2137_n ) capacitor c=0.00347599f \
 //x=12.215 //y=1.76 //x2=12.48 //y2=1.44
cc_552 ( N_noxref_2_c_504_p N_noxref_7_c_2137_n ) capacitor c=0.00323576f \
 //x=12.615 //y=1.845 //x2=12.48 //y2=1.44
cc_553 ( N_noxref_2_M7_noxref_d N_noxref_7_c_2137_n ) capacitor c=0.00237422f \
 //x=12.025 //y=1.095 //x2=12.48 //y2=1.44
cc_554 ( N_noxref_2_c_405_p N_noxref_7_c_2141_n ) capacitor c=0.0024584f \
 //x=12.7 //y=2.625 //x2=11.96 //y2=2.26
cc_555 ( N_noxref_2_c_503_p N_noxref_7_c_2142_n ) capacitor c=0.0036273f \
 //x=12.215 //y=1.76 //x2=11.96 //y2=2.095
cc_556 ( N_noxref_2_c_405_p N_noxref_7_c_2142_n ) capacitor c=0.00282067f \
 //x=12.7 //y=2.625 //x2=11.96 //y2=2.095
cc_557 ( N_noxref_2_c_406_p N_noxref_7_c_2144_n ) capacitor c=0.00739875f \
 //x=12.7 //y=5.25 //x2=11.96 //y2=4.88
cc_558 ( N_noxref_2_c_499_p N_noxref_7_c_2144_n ) capacitor c=0.00203307f \
 //x=11.92 //y=5.335 //x2=11.96 //y2=4.88
cc_559 ( N_noxref_2_c_501_p N_noxref_7_c_2144_n ) capacitor c=0.00375636f \
 //x=11.92 //y=5.56 //x2=11.96 //y2=4.88
cc_560 ( N_noxref_2_c_397_n N_VDD_c_2903_n ) capacitor c=0.00621363f //x=10.92 \
 //y=5.335 //x2=24.17 //y2=7.58
cc_561 ( N_noxref_2_c_480_p N_VDD_c_2903_n ) capacitor c=0.00627186f \
 //x=11.805 //y=5.335 //x2=24.17 //y2=7.58
cc_562 ( N_noxref_2_c_511_p N_VDD_c_2903_n ) capacitor c=0.00256019f //x=11.92 \
 //y=5.56 //x2=24.17 //y2=7.58
cc_563 ( N_noxref_2_c_420_p N_VDD_c_2903_n ) capacitor c=0.00824067f \
 //x=12.615 //y=5.335 //x2=24.17 //y2=7.58
cc_564 ( N_noxref_2_c_398_n N_VDD_c_2903_n ) capacitor c=0.00261804f \
 //x=10.162 //y=5.335 //x2=24.17 //y2=7.58
cc_565 ( N_noxref_2_c_423_p N_VDD_c_2903_n ) capacitor c=0.00270108f //x=11.04 \
 //y=5.335 //x2=24.17 //y2=7.58
cc_566 ( N_noxref_2_c_416_p N_VDD_c_2903_n ) capacitor c=9.07241e-19 //x=14.55 \
 //y=4.88 //x2=24.17 //y2=7.58
cc_567 ( N_noxref_2_c_402_n N_VDD_c_2903_n ) capacitor c=0.0024232f //x=10.16 \
 //y=5.56 //x2=24.17 //y2=7.58
cc_568 ( N_noxref_2_c_463_p N_VDD_c_2903_n ) capacitor c=0.0024232f //x=11.04 \
 //y=5.56 //x2=24.17 //y2=7.58
cc_569 ( N_noxref_2_c_501_p N_VDD_c_2903_n ) capacitor c=0.0024232f //x=11.92 \
 //y=5.56 //x2=24.17 //y2=7.58
cc_570 ( N_noxref_2_c_418_p N_VDD_c_2903_n ) capacitor c=6.22888e-19 //x=14.55 \
 //y=4.88 //x2=24.17 //y2=7.58
cc_571 ( N_noxref_2_c_397_n N_VDD_c_2920_n ) capacitor c=0.00202922f //x=10.92 \
 //y=5.335 //x2=10.515 //y2=7.585
cc_572 ( N_noxref_2_c_398_n N_VDD_c_2920_n ) capacitor c=9.3757e-19 //x=10.162 \
 //y=5.335 //x2=10.515 //y2=7.585
cc_573 ( N_noxref_2_c_402_n N_VDD_c_2920_n ) capacitor c=0.0138074f //x=10.16 \
 //y=5.56 //x2=10.515 //y2=7.585
cc_574 ( N_noxref_2_c_397_n N_VDD_c_2977_n ) capacitor c=0.0017708f //x=10.92 \
 //y=5.335 //x2=11.395 //y2=7.585
cc_575 ( N_noxref_2_c_480_p N_VDD_c_2977_n ) capacitor c=0.00202922f \
 //x=11.805 //y=5.335 //x2=11.395 //y2=7.585
cc_576 ( N_noxref_2_c_423_p N_VDD_c_2977_n ) capacitor c=9.4822e-19 //x=11.04 \
 //y=5.335 //x2=11.395 //y2=7.585
cc_577 ( N_noxref_2_c_463_p N_VDD_c_2977_n ) capacitor c=0.0138074f //x=11.04 \
 //y=5.56 //x2=11.395 //y2=7.585
cc_578 ( N_noxref_2_c_480_p N_VDD_c_2981_n ) capacitor c=0.00205906f \
 //x=11.805 //y=5.335 //x2=12.275 //y2=7.585
cc_579 ( N_noxref_2_c_511_p N_VDD_c_2981_n ) capacitor c=8.49654e-19 //x=11.92 \
 //y=5.56 //x2=12.275 //y2=7.585
cc_580 ( N_noxref_2_c_420_p N_VDD_c_2981_n ) capacitor c=0.00204238f \
 //x=12.615 //y=5.335 //x2=12.275 //y2=7.585
cc_581 ( N_noxref_2_c_501_p N_VDD_c_2981_n ) capacitor c=0.0135103f //x=11.92 \
 //y=5.56 //x2=12.275 //y2=7.585
cc_582 ( N_noxref_2_c_420_p N_VDD_c_2985_n ) capacitor c=0.00183742f \
 //x=12.615 //y=5.335 //x2=13.27 //y2=7.585
cc_583 ( N_noxref_2_c_416_p N_VDD_c_2986_n ) capacitor c=6.28113e-19 //x=14.55 \
 //y=4.88 //x2=15.025 //y2=7.585
cc_584 ( N_noxref_2_M31_noxref_g N_VDD_c_2986_n ) capacitor c=0.00732618f \
 //x=14.45 //y=6.2 //x2=15.025 //y2=7.585
cc_585 ( N_noxref_2_M32_noxref_g N_VDD_c_2986_n ) capacitor c=0.00755544f \
 //x=14.89 //y=6.2 //x2=15.025 //y2=7.585
cc_586 ( N_noxref_2_c_398_n N_VDD_c_2933_n ) capacitor c=0.0022955f //x=10.162 \
 //y=5.335 //x2=8.63 //y2=7.585
cc_587 ( N_noxref_2_c_402_n N_VDD_c_2933_n ) capacitor c=0.00509469f //x=10.16 \
 //y=5.56 //x2=8.63 //y2=7.585
cc_588 ( N_noxref_2_c_511_p N_VDD_c_2991_n ) capacitor c=0.00269779f //x=11.92 \
 //y=5.56 //x2=13.44 //y2=7.585
cc_589 ( N_noxref_2_c_406_p N_VDD_c_2991_n ) capacitor c=0.0317189f //x=12.7 \
 //y=5.25 //x2=13.44 //y2=7.585
cc_590 ( N_noxref_2_c_416_p N_VDD_c_2991_n ) capacitor c=0.00483853f //x=14.55 \
 //y=4.88 //x2=13.44 //y2=7.585
cc_591 ( N_noxref_2_c_410_p N_VDD_c_2991_n ) capacitor c=0.00593318f \
 //x=14.552 //y=4.74 //x2=13.44 //y2=7.585
cc_592 ( N_noxref_2_c_501_p N_VDD_c_2991_n ) capacitor c=0.00776541f //x=11.92 \
 //y=5.56 //x2=13.44 //y2=7.585
cc_593 ( N_noxref_2_c_418_p N_VDD_c_2991_n ) capacitor c=0.00370494f //x=14.55 \
 //y=4.88 //x2=13.44 //y2=7.585
cc_594 ( N_noxref_2_c_419_p N_VDD_c_2991_n ) capacitor c=0.0129564f //x=14.55 \
 //y=4.88 //x2=13.44 //y2=7.585
cc_595 ( N_noxref_2_c_398_n N_VDD_M25_noxref_s ) capacitor c=0.0441176f \
 //x=10.162 //y=5.335 //x2=9.585 //y2=5.2
cc_596 ( N_noxref_2_c_423_p N_VDD_M25_noxref_s ) capacitor c=7.80122e-19 \
 //x=11.04 //y=5.335 //x2=9.585 //y2=5.2
cc_597 ( N_noxref_2_c_402_n N_VDD_M25_noxref_s ) capacitor c=0.09305f \
 //x=10.16 //y=5.56 //x2=9.585 //y2=5.2
cc_598 ( N_noxref_2_c_397_n N_VDD_M26_noxref_d ) capacitor c=0.00700141f \
 //x=10.92 //y=5.335 //x2=10.455 //y2=5.2
cc_599 ( N_noxref_2_c_402_n N_VDD_M26_noxref_d ) capacitor c=0.0674491f \
 //x=10.16 //y=5.56 //x2=10.455 //y2=5.2
cc_600 ( N_noxref_2_c_463_p N_VDD_M26_noxref_d ) capacitor c=0.0674762f \
 //x=11.04 //y=5.56 //x2=10.455 //y2=5.2
cc_601 ( N_noxref_2_c_480_p N_VDD_M28_noxref_d ) capacitor c=0.00700141f \
 //x=11.805 //y=5.335 //x2=11.335 //y2=5.2
cc_602 ( N_noxref_2_c_463_p N_VDD_M28_noxref_d ) capacitor c=0.067493f \
 //x=11.04 //y=5.56 //x2=11.335 //y2=5.2
cc_603 ( N_noxref_2_c_501_p N_VDD_M28_noxref_d ) capacitor c=0.0674288f \
 //x=11.92 //y=5.56 //x2=11.335 //y2=5.2
cc_604 ( N_noxref_2_c_420_p N_VDD_M30_noxref_d ) capacitor c=0.00700141f \
 //x=12.615 //y=5.335 //x2=12.215 //y2=5.2
cc_605 ( N_noxref_2_c_501_p N_VDD_M30_noxref_d ) capacitor c=0.0673824f \
 //x=11.92 //y=5.56 //x2=12.215 //y2=5.2
cc_606 ( N_noxref_2_c_511_p N_VDD_M31_noxref_s ) capacitor c=0.00536022f \
 //x=11.92 //y=5.56 //x2=14.095 //y2=5.2
cc_607 ( N_noxref_2_c_420_p N_VDD_M31_noxref_s ) capacitor c=0.00211796f \
 //x=12.615 //y=5.335 //x2=14.095 //y2=5.2
cc_608 ( N_noxref_2_c_408_p N_VDD_M31_noxref_s ) capacitor c=7.6965e-19 \
 //x=14.55 //y=2.945 //x2=14.095 //y2=5.2
cc_609 ( N_noxref_2_M31_noxref_g N_VDD_M31_noxref_s ) capacitor c=0.0567929f \
 //x=14.45 //y=6.2 //x2=14.095 //y2=5.2
cc_610 ( N_noxref_2_M32_noxref_g N_VDD_M32_noxref_d ) capacitor c=0.015318f \
 //x=14.89 //y=6.2 //x2=14.965 //y2=5.2
cc_611 ( N_noxref_2_c_464_p N_noxref_12_c_3462_n ) capacitor c=0.0036878f \
 //x=12.215 //y=1.305 //x2=12.615 //y2=0.72
cc_612 ( N_noxref_2_c_504_p N_noxref_12_c_3462_n ) capacitor c=0.00399931f \
 //x=12.615 //y=1.845 //x2=12.615 //y2=0.72
cc_613 ( N_noxref_2_M7_noxref_d N_noxref_12_c_3462_n ) capacitor c=0.00910163f \
 //x=12.025 //y=1.095 //x2=12.615 //y2=0.72
cc_614 ( N_noxref_2_M7_noxref_d N_noxref_12_c_3465_n ) capacitor c=0.00120711f \
 //x=12.025 //y=1.095 //x2=11.73 //y2=1.175
cc_615 ( N_noxref_2_c_397_n N_noxref_12_M6_noxref_d ) capacitor c=0.00140533f \
 //x=10.92 //y=5.335 //x2=10.49 //y2=1.09
cc_616 ( N_noxref_2_c_464_p N_noxref_12_M6_noxref_d ) capacitor c=0.00802836f \
 //x=12.215 //y=1.305 //x2=10.49 //y2=1.09
cc_617 ( N_noxref_2_c_464_p N_noxref_12_M7_noxref_s ) capacitor c=0.00993092f \
 //x=12.215 //y=1.305 //x2=11.595 //y2=0.555
cc_618 ( N_noxref_2_c_503_p N_noxref_12_M7_noxref_s ) capacitor c=0.0270624f \
 //x=12.215 //y=1.76 //x2=11.595 //y2=0.555
cc_619 ( N_noxref_2_c_504_p N_noxref_12_M7_noxref_s ) capacitor c=0.00752108f \
 //x=12.615 //y=1.845 //x2=11.595 //y2=0.555
cc_620 ( N_noxref_2_c_401_n N_noxref_12_M7_noxref_s ) capacitor c=0.00309975f \
 //x=12.7 //y=2.77 //x2=11.595 //y2=0.555
cc_621 ( N_noxref_2_M7_noxref_d N_noxref_12_M7_noxref_s ) capacitor \
 c=0.0279003f //x=12.025 //y=1.095 //x2=11.595 //y2=0.555
cc_622 ( N_noxref_2_c_464_p N_GND_c_3609_n ) capacitor c=0.00878689f \
 //x=12.215 //y=1.305 //x2=14.535 //y2=0.175
cc_623 ( N_noxref_2_c_504_p N_GND_c_3609_n ) capacitor c=0.00662992f \
 //x=12.615 //y=1.845 //x2=14.535 //y2=0.175
cc_624 ( N_noxref_2_c_467_p N_GND_c_3609_n ) capacitor c=4.30498e-19 //x=12.7 \
 //y=2.945 //x2=14.535 //y2=0.175
cc_625 ( N_noxref_2_M7_noxref_d N_GND_c_3609_n ) capacitor c=2.9462e-19 \
 //x=12.025 //y=1.095 //x2=14.535 //y2=0.175
cc_626 ( N_noxref_2_c_464_p N_GND_c_3613_n ) capacitor c=0.00488628f \
 //x=12.215 //y=1.305 //x2=14.62 //y2=1.135
cc_627 ( N_noxref_2_c_408_p N_GND_c_3613_n ) capacitor c=2.00375e-19 //x=14.55 \
 //y=2.945 //x2=14.62 //y2=1.135
cc_628 ( N_noxref_2_c_413_p N_GND_c_3613_n ) capacitor c=0.00645051f //x=14.55 \
 //y=2.26 //x2=14.62 //y2=1.135
cc_629 ( N_noxref_2_c_412_p N_GND_c_3613_n ) capacitor c=2.13705e-19 //x=14.55 \
 //y=2.26 //x2=14.62 //y2=1.135
cc_630 ( N_noxref_2_c_436_p N_GND_c_3613_n ) capacitor c=0.00176535f \
 //x=14.355 //y=1.045 //x2=14.62 //y2=1.135
cc_631 ( N_noxref_2_c_437_p N_GND_c_3613_n ) capacitor c=0.0036005f //x=14.355 \
 //y=1.39 //x2=14.62 //y2=1.135
cc_632 ( N_noxref_2_c_439_p N_GND_c_3613_n ) capacitor c=4.2764e-19 //x=14.355 \
 //y=1.7 //x2=14.62 //y2=1.135
cc_633 ( N_noxref_2_c_641_p N_GND_c_3613_n ) capacitor c=9.36995e-19 //x=14.73 \
 //y=0.89 //x2=14.62 //y2=1.135
cc_634 ( N_noxref_2_c_642_p N_GND_c_3613_n ) capacitor c=6.38426e-19 //x=14.73 \
 //y=1.545 //x2=14.62 //y2=1.135
cc_635 ( N_noxref_2_c_438_p N_GND_c_3613_n ) capacitor c=0.00171721f \
 //x=14.885 //y=1.045 //x2=14.62 //y2=1.135
cc_636 ( N_noxref_2_c_440_p N_GND_c_3613_n ) capacitor c=0.00296337f \
 //x=14.885 //y=1.39 //x2=14.62 //y2=1.135
cc_637 ( N_noxref_2_c_436_p N_GND_c_3624_n ) capacitor c=3.51399e-19 \
 //x=14.355 //y=1.045 //x2=14.617 //y2=1.005
cc_638 ( N_noxref_2_c_641_p N_GND_c_3624_n ) capacitor c=0.00852202f //x=14.73 \
 //y=0.89 //x2=14.617 //y2=1.005
cc_639 ( N_noxref_2_c_438_p N_GND_c_3624_n ) capacitor c=4.40641e-19 \
 //x=14.885 //y=1.045 //x2=14.617 //y2=1.005
cc_640 ( N_noxref_2_c_504_p N_GND_c_3573_n ) capacitor c=6.86343e-19 \
 //x=12.615 //y=1.845 //x2=13.27 //y2=0.175
cc_641 ( N_noxref_2_c_467_p N_GND_c_3573_n ) capacitor c=6.00344e-19 //x=12.7 \
 //y=2.945 //x2=13.27 //y2=0.175
cc_642 ( N_noxref_2_c_436_p N_GND_c_3629_n ) capacitor c=0.00688027f \
 //x=14.355 //y=1.045 //x2=16.6 //y2=0.175
cc_643 ( N_noxref_2_c_503_p N_GND_c_3630_n ) capacitor c=0.00285697f \
 //x=12.215 //y=1.76 //x2=13.44 //y2=0.175
cc_644 ( N_noxref_2_c_504_p N_GND_c_3630_n ) capacitor c=0.022222f //x=12.615 \
 //y=1.845 //x2=13.44 //y2=0.175
cc_645 ( N_noxref_2_c_405_p N_GND_c_3630_n ) capacitor c=2.00878e-19 //x=12.7 \
 //y=2.625 //x2=13.44 //y2=0.175
cc_646 ( N_noxref_2_c_467_p N_GND_c_3630_n ) capacitor c=0.00401039f //x=12.7 \
 //y=2.945 //x2=13.44 //y2=0.175
cc_647 ( N_noxref_2_c_407_p N_GND_c_3630_n ) capacitor c=0.00301679f //x=14.55 \
 //y=2.625 //x2=13.44 //y2=0.175
cc_648 ( N_noxref_2_c_408_p N_GND_c_3630_n ) capacitor c=0.00293146f //x=14.55 \
 //y=2.945 //x2=13.44 //y2=0.175
cc_649 ( N_noxref_2_c_401_n N_GND_c_3630_n ) capacitor c=0.0103966f //x=12.7 \
 //y=2.77 //x2=13.44 //y2=0.175
cc_650 ( N_noxref_2_c_409_p N_GND_c_3630_n ) capacitor c=0.00512795f //x=14.55 \
 //y=2.77 //x2=13.44 //y2=0.175
cc_651 ( N_noxref_2_c_413_p N_GND_c_3630_n ) capacitor c=0.00351582f //x=14.55 \
 //y=2.26 //x2=13.44 //y2=0.175
cc_652 ( N_noxref_2_c_457_p N_GND_c_3630_n ) capacitor c=0.0102999f //x=14.385 \
 //y=2.785 //x2=13.44 //y2=0.175
cc_653 ( N_noxref_2_c_412_p N_GND_c_3630_n ) capacitor c=0.00354425f //x=14.55 \
 //y=2.26 //x2=13.44 //y2=0.175
cc_654 ( N_noxref_2_c_439_p N_GND_c_3630_n ) capacitor c=0.0015404f //x=14.355 \
 //y=1.7 //x2=13.44 //y2=0.175
cc_655 ( N_noxref_2_c_415_p N_GND_c_3630_n ) capacitor c=0.0093907f //x=14.355 \
 //y=2.095 //x2=13.44 //y2=0.175
cc_656 ( N_noxref_2_c_409_p N_GND_c_3643_n ) capacitor c=0.00159554f //x=14.55 \
 //y=2.77 //x2=16.77 //y2=0.175
cc_657 ( N_noxref_2_c_413_p N_GND_M8_noxref_d ) capacitor c=2.20438e-19 \
 //x=14.55 //y=2.26 //x2=14.43 //y2=1.045
cc_658 ( N_noxref_2_c_436_p N_GND_M8_noxref_d ) capacitor c=0.00192399f \
 //x=14.355 //y=1.045 //x2=14.43 //y2=1.045
cc_659 ( N_noxref_2_c_437_p N_GND_M8_noxref_d ) capacitor c=0.00210798f \
 //x=14.355 //y=1.39 //x2=14.43 //y2=1.045
cc_660 ( N_noxref_2_c_641_p N_GND_M8_noxref_d ) capacitor c=0.00472259f \
 //x=14.73 //y=0.89 //x2=14.43 //y2=1.045
cc_661 ( N_noxref_2_c_642_p N_GND_M8_noxref_d ) capacitor c=0.00166857f \
 //x=14.73 //y=1.545 //x2=14.43 //y2=1.045
cc_662 ( N_noxref_2_c_438_p N_GND_M8_noxref_d ) capacitor c=0.00230174f \
 //x=14.885 //y=1.045 //x2=14.43 //y2=1.045
cc_663 ( N_noxref_2_c_440_p N_GND_M8_noxref_d ) capacitor c=0.00210798f \
 //x=14.885 //y=1.39 //x2=14.43 //y2=1.045
cc_664 ( N_noxref_2_c_415_p N_noxref_18_c_4244_n ) capacitor c=0.00262672f \
 //x=14.355 //y=2.095 //x2=14.135 //y2=1.675
cc_665 ( N_noxref_2_c_408_p N_noxref_18_c_4245_n ) capacitor c=0.00530082f \
 //x=14.55 //y=2.945 //x2=15.02 //y2=1.76
cc_666 ( N_noxref_2_c_413_p N_noxref_18_c_4245_n ) capacitor c=0.00509504f \
 //x=14.55 //y=2.26 //x2=15.02 //y2=1.76
cc_667 ( N_noxref_2_c_412_p N_noxref_18_c_4245_n ) capacitor c=0.00763108f \
 //x=14.55 //y=2.26 //x2=15.02 //y2=1.76
cc_668 ( N_noxref_2_c_439_p N_noxref_18_c_4245_n ) capacitor c=0.00697076f \
 //x=14.355 //y=1.7 //x2=15.02 //y2=1.76
cc_669 ( N_noxref_2_c_415_p N_noxref_18_c_4245_n ) capacitor c=0.0165799f \
 //x=14.355 //y=2.095 //x2=15.02 //y2=1.76
cc_670 ( N_noxref_2_c_642_p N_noxref_18_c_4245_n ) capacitor c=0.00723574f \
 //x=14.73 //y=1.545 //x2=15.02 //y2=1.76
cc_671 ( N_noxref_2_c_440_p N_noxref_18_c_4245_n ) capacitor c=0.00339872f \
 //x=14.885 //y=1.39 //x2=15.02 //y2=1.76
cc_672 ( N_noxref_2_c_415_p N_noxref_18_c_4252_n ) capacitor c=6.71402e-19 \
 //x=14.355 //y=2.095 //x2=15.105 //y2=1.675
cc_673 ( N_noxref_2_c_436_p N_noxref_18_M8_noxref_s ) capacitor c=0.0295366f \
 //x=14.355 //y=1.045 //x2=14 //y2=0.545
cc_674 ( N_noxref_2_c_439_p N_noxref_18_M8_noxref_s ) capacitor c=3.48408e-19 \
 //x=14.355 //y=1.7 //x2=14 //y2=0.545
cc_675 ( N_noxref_2_c_438_p N_noxref_18_M8_noxref_s ) capacitor c=0.0125442f \
 //x=14.885 //y=1.045 //x2=14 //y2=0.545
cc_676 ( N_CLK_c_697_n N_noxref_4_c_976_n ) capacitor c=0.023202f //x=6.04 \
 //y=4.755 //x2=6.11 //y2=5.335
cc_677 ( N_CLK_c_702_n N_noxref_4_c_976_n ) capacitor c=0.00118283f //x=6.04 \
 //y=4.62 //x2=6.11 //y2=5.335
cc_678 ( N_CLK_c_708_n N_noxref_4_c_976_n ) capacitor c=0.00492634f //x=6.04 \
 //y=4.88 //x2=6.11 //y2=5.335
cc_679 ( N_CLK_M21_noxref_g N_noxref_4_c_976_n ) capacitor c=0.00858236f \
 //x=6.01 //y=6.2 //x2=6.11 //y2=5.335
cc_680 ( N_CLK_c_726_n N_noxref_4_c_976_n ) capacitor c=3.67903e-19 //x=6.04 \
 //y=4.88 //x2=6.11 //y2=5.335
cc_681 ( N_CLK_M22_noxref_g N_noxref_4_c_1060_n ) capacitor c=0.00955829f \
 //x=6.45 //y=6.2 //x2=6.995 //y2=5.335
cc_682 ( N_CLK_c_782_p N_noxref_4_c_1050_n ) capacitor c=0.0194373f //x=7.5 \
 //y=4.62 //x2=7.805 //y2=5.335
cc_683 ( CLK N_noxref_4_c_981_n ) capacitor c=0.00321221f //x=6.04 //y=3.14 \
 //x2=7.89 //y2=4.09
cc_684 ( N_CLK_c_782_p N_noxref_4_c_987_n ) capacitor c=0.00124799f //x=7.5 \
 //y=4.62 //x2=7.89 //y2=4.41
cc_685 ( N_CLK_c_701_n N_noxref_4_c_987_n ) capacitor c=0.00726353f //x=8.1 \
 //y=4.635 //x2=7.89 //y2=4.41
cc_686 ( CLK N_noxref_4_c_988_n ) capacitor c=3.42225e-19 //x=6.04 //y=3.14 \
 //x2=7.89 //y2=5.25
cc_687 ( N_CLK_c_782_p N_noxref_4_c_988_n ) capacitor c=3.25767e-19 //x=7.5 \
 //y=4.62 //x2=7.89 //y2=5.25
cc_688 ( N_CLK_c_701_n N_noxref_4_c_988_n ) capacitor c=0.0293421f //x=8.1 \
 //y=4.635 //x2=7.89 //y2=5.25
cc_689 ( CLK N_noxref_4_c_1068_n ) capacitor c=0.00295973f //x=15.29 //y=2.77 \
 //x2=17.88 //y2=4.105
cc_690 ( N_CLK_c_697_n N_noxref_4_c_1069_n ) capacitor c=0.00519317f //x=6.04 \
 //y=4.755 //x2=6.23 //y2=5.335
cc_691 ( N_CLK_c_782_p N_noxref_4_c_1069_n ) capacitor c=0.0380295f //x=7.5 \
 //y=4.62 //x2=6.23 //y2=5.335
cc_692 ( N_CLK_c_702_n N_noxref_4_c_1069_n ) capacitor c=0.00118081f //x=6.04 \
 //y=4.62 //x2=6.23 //y2=5.335
cc_693 ( N_CLK_c_708_n N_noxref_4_c_1069_n ) capacitor c=0.00132214f //x=6.04 \
 //y=4.88 //x2=6.23 //y2=5.335
cc_694 ( N_CLK_M21_noxref_g N_noxref_4_c_1069_n ) capacitor c=0.00229818f \
 //x=6.01 //y=6.2 //x2=6.23 //y2=5.335
cc_695 ( N_CLK_M22_noxref_g N_noxref_4_c_1069_n ) capacitor c=0.00230699f \
 //x=6.45 //y=6.2 //x2=6.23 //y2=5.335
cc_696 ( N_CLK_c_796_p N_noxref_4_c_1069_n ) capacitor c=0.00172334f //x=6.375 \
 //y=4.97 //x2=6.23 //y2=5.335
cc_697 ( CLK N_noxref_4_c_1076_n ) capacitor c=4.34398e-19 //x=15.29 //y=2.77 \
 //x2=17.882 //y2=4.74
cc_698 ( CLK N_noxref_4_c_996_n ) capacitor c=0.0287619f //x=6.04 //y=3.14 \
 //x2=7.725 //y2=4.25
cc_699 ( N_CLK_c_697_n N_noxref_4_c_996_n ) capacitor c=0.00196208f //x=6.04 \
 //y=4.755 //x2=7.725 //y2=4.25
cc_700 ( N_CLK_c_782_p N_noxref_4_c_996_n ) capacitor c=0.0124008f //x=7.5 \
 //y=4.62 //x2=7.725 //y2=4.25
cc_701 ( N_CLK_c_702_n N_noxref_4_c_996_n ) capacitor c=0.155111f //x=6.04 \
 //y=4.62 //x2=7.725 //y2=4.25
cc_702 ( N_CLK_c_782_p N_noxref_4_c_1005_n ) capacitor c=0.0364871f //x=7.5 \
 //y=4.62 //x2=8.045 //y2=4.25
cc_703 ( CLK N_noxref_4_c_1009_n ) capacitor c=0.020623f //x=15.29 //y=2.77 \
 //x2=17.72 //y2=4.265
cc_704 ( N_CLK_c_740_n N_noxref_4_c_1009_n ) capacitor c=0.00235509f \
 //x=15.325 //y=4.75 //x2=17.72 //y2=4.265
cc_705 ( N_CLK_c_701_n N_noxref_4_c_1009_n ) capacitor c=0.676145f //x=8.1 \
 //y=4.635 //x2=17.72 //y2=4.265
cc_706 ( N_CLK_c_697_n N_noxref_4_c_1085_n ) capacitor c=0.00185675f //x=6.04 \
 //y=4.755 //x2=6.23 //y2=5.56
cc_707 ( N_CLK_M21_noxref_g N_noxref_4_c_1085_n ) capacitor c=0.0179041f \
 //x=6.01 //y=6.2 //x2=6.23 //y2=5.56
cc_708 ( N_CLK_M22_noxref_g N_noxref_4_c_1085_n ) capacitor c=0.0179041f \
 //x=6.45 //y=6.2 //x2=6.23 //y2=5.56
cc_709 ( N_CLK_c_796_p N_noxref_4_c_1085_n ) capacitor c=0.00294585f //x=6.375 \
 //y=4.97 //x2=6.23 //y2=5.56
cc_710 ( N_CLK_c_701_n SN ) capacitor c=0.0260794f //x=8.1 //y=4.635 \
 //x2=10.85 //y2=2.77
cc_711 ( N_CLK_c_701_n N_SN_c_1720_n ) capacitor c=0.00404632f //x=8.1 \
 //y=4.635 //x2=10.85 //y2=4.765
cc_712 ( CLK N_SN_c_1757_n ) capacitor c=0.0166179f //x=15.29 //y=2.77 \
 //x2=22.15 //y2=2.39
cc_713 ( N_CLK_c_737_n N_SN_c_1757_n ) capacitor c=0.0169481f //x=15.29 \
 //y=2.26 //x2=22.15 //y2=2.39
cc_714 ( N_CLK_c_693_n N_noxref_7_c_2047_n ) capacitor c=0.0116288f //x=6.04 \
 //y=2.375 //x2=7.15 //y2=2.375
cc_715 ( N_CLK_c_704_n N_noxref_7_c_2047_n ) capacitor c=5.39999e-19 //x=6.04 \
 //y=2.26 //x2=7.15 //y2=2.375
cc_716 ( N_CLK_c_723_n N_noxref_7_c_2047_n ) capacitor c=0.00141236f //x=6.13 \
 //y=2.095 //x2=7.15 //y2=2.375
cc_717 ( CLK N_noxref_7_c_2048_n ) capacitor c=0.038205f //x=6.04 //y=3.14 \
 //x2=7.15 //y2=3.705
cc_718 ( N_CLK_c_704_n N_noxref_7_c_2048_n ) capacitor c=4.16726e-19 //x=6.04 \
 //y=2.26 //x2=7.15 //y2=3.705
cc_719 ( CLK N_noxref_7_c_2053_n ) capacitor c=0.00776638f //x=6.04 //y=3.14 \
 //x2=7.15 //y2=4.025
cc_720 ( CLK N_noxref_7_c_2054_n ) capacitor c=0.0126059f //x=6.04 //y=3.14 \
 //x2=7.15 //y2=4.75
cc_721 ( N_CLK_c_697_n N_noxref_7_c_2054_n ) capacitor c=0.0109762f //x=6.04 \
 //y=4.755 //x2=7.15 //y2=4.75
cc_722 ( N_CLK_c_782_p N_noxref_7_c_2054_n ) capacitor c=0.0287277f //x=7.5 \
 //y=4.62 //x2=7.15 //y2=4.75
cc_723 ( N_CLK_c_702_n N_noxref_7_c_2054_n ) capacitor c=0.00462738f //x=6.04 \
 //y=4.62 //x2=7.15 //y2=4.75
cc_724 ( N_CLK_c_708_n N_noxref_7_c_2054_n ) capacitor c=4.56604e-19 //x=6.04 \
 //y=4.88 //x2=7.15 //y2=4.75
cc_725 ( N_CLK_c_701_n N_noxref_7_c_2058_n ) capacitor c=0.0287127f //x=8.1 \
 //y=4.635 //x2=11.96 //y2=4.75
cc_726 ( N_CLK_c_740_n N_noxref_7_c_2081_n ) capacitor c=0.0233476f //x=15.325 \
 //y=4.75 //x2=15.435 //y2=5.38
cc_727 ( N_CLK_c_701_n N_noxref_7_c_2081_n ) capacitor c=9.84751e-19 //x=8.1 \
 //y=4.635 //x2=15.435 //y2=5.38
cc_728 ( N_CLK_c_754_n N_noxref_7_c_2081_n ) capacitor c=0.00469232f //x=15.32 \
 //y=4.88 //x2=15.435 //y2=5.38
cc_729 ( N_CLK_M33_noxref_g N_noxref_7_c_2081_n ) capacitor c=0.00842852f \
 //x=15.33 //y=6.2 //x2=15.435 //y2=5.38
cc_730 ( N_CLK_c_773_n N_noxref_7_c_2081_n ) capacitor c=7.94507e-19 //x=15.32 \
 //y=4.88 //x2=15.435 //y2=5.38
cc_731 ( N_CLK_c_763_n N_noxref_7_c_2082_n ) capacitor c=0.00119302f \
 //x=15.325 //y=1.43 //x2=15.59 //y2=1.75
cc_732 ( N_CLK_c_765_n N_noxref_7_c_2082_n ) capacitor c=0.00439215f \
 //x=15.325 //y=1.74 //x2=15.59 //y2=1.75
cc_733 ( N_CLK_c_833_p N_noxref_7_c_2082_n ) capacitor c=0.00917366f //x=15.7 \
 //y=1.585 //x2=15.59 //y2=1.75
cc_734 ( N_CLK_c_769_n N_noxref_7_c_2082_n ) capacitor c=0.003249f //x=15.855 \
 //y=1.43 //x2=15.59 //y2=1.75
cc_735 ( N_CLK_c_835_p N_noxref_7_c_2082_n ) capacitor c=0.00341688f //x=15.29 \
 //y=2.095 //x2=15.59 //y2=1.75
cc_736 ( N_CLK_M34_noxref_g N_noxref_7_c_2169_n ) capacitor c=0.0109545f \
 //x=15.77 //y=6.2 //x2=15.945 //y2=5.38
cc_737 ( N_CLK_c_833_p N_noxref_7_c_2170_n ) capacitor c=0.00194324f //x=15.7 \
 //y=1.585 //x2=15.945 //y2=1.835
cc_738 ( N_CLK_c_769_n N_noxref_7_c_2170_n ) capacitor c=0.00323005f \
 //x=15.855 //y=1.43 //x2=15.945 //y2=1.835
cc_739 ( CLK N_noxref_7_c_2084_n ) capacitor c=0.0581058f //x=15.29 //y=2.77 \
 //x2=16.03 //y2=3.705
cc_740 ( N_CLK_c_737_n N_noxref_7_c_2084_n ) capacitor c=0.0138368f //x=15.29 \
 //y=2.26 //x2=16.03 //y2=3.705
cc_741 ( N_CLK_c_750_n N_noxref_7_c_2084_n ) capacitor c=9.26054e-19 //x=15.29 \
 //y=2.26 //x2=16.03 //y2=3.705
cc_742 ( N_CLK_c_770_n N_noxref_7_c_2084_n ) capacitor c=0.00268898f //x=15.29 \
 //y=2.26 //x2=16.03 //y2=3.705
cc_743 ( N_CLK_c_835_p N_noxref_7_c_2084_n ) capacitor c=0.00309058f //x=15.29 \
 //y=2.095 //x2=16.03 //y2=3.705
cc_744 ( CLK N_noxref_7_c_2177_n ) capacitor c=0.0176724f //x=15.29 //y=2.77 \
 //x2=16.03 //y2=4.025
cc_745 ( N_CLK_c_845_p N_noxref_7_c_2177_n ) capacitor c=0.00127572f \
 //x=15.695 //y=4.97 //x2=16.03 //y2=4.025
cc_746 ( CLK N_noxref_7_c_2087_n ) capacitor c=0.021778f //x=15.29 //y=2.77 \
 //x2=16.03 //y2=5.295
cc_747 ( N_CLK_c_740_n N_noxref_7_c_2087_n ) capacitor c=0.0218509f //x=15.325 \
 //y=4.75 //x2=16.03 //y2=5.295
cc_748 ( N_CLK_c_701_n N_noxref_7_c_2087_n ) capacitor c=0.00878819f //x=8.1 \
 //y=4.635 //x2=16.03 //y2=5.295
cc_749 ( N_CLK_c_754_n N_noxref_7_c_2087_n ) capacitor c=5.14671e-19 //x=15.32 \
 //y=4.88 //x2=16.03 //y2=5.295
cc_750 ( N_CLK_c_845_p N_noxref_7_c_2087_n ) capacitor c=0.00844995f \
 //x=15.695 //y=4.97 //x2=16.03 //y2=5.295
cc_751 ( CLK N_noxref_7_c_2184_n ) capacitor c=5.01652e-19 //x=6.04 //y=3.14 \
 //x2=7.15 //y2=3.88
cc_752 ( N_CLK_c_701_n N_noxref_7_c_2090_n ) capacitor c=0.0211459f //x=8.1 \
 //y=4.635 //x2=14.67 //y2=5.56
cc_753 ( N_CLK_c_740_n N_noxref_7_c_2186_n ) capacitor c=0.00285789f \
 //x=15.325 //y=4.75 //x2=15.55 //y2=5.38
cc_754 ( N_CLK_c_701_n N_noxref_7_c_2186_n ) capacitor c=0.00123315f //x=8.1 \
 //y=4.635 //x2=15.55 //y2=5.38
cc_755 ( N_CLK_M33_noxref_g N_noxref_7_c_2186_n ) capacitor c=0.00192712f \
 //x=15.33 //y=6.2 //x2=15.55 //y2=5.38
cc_756 ( N_CLK_M34_noxref_g N_noxref_7_c_2186_n ) capacitor c=0.00298276f \
 //x=15.77 //y=6.2 //x2=15.55 //y2=5.38
cc_757 ( N_CLK_c_845_p N_noxref_7_c_2186_n ) capacitor c=0.0020909f //x=15.695 \
 //y=4.97 //x2=15.55 //y2=5.38
cc_758 ( N_CLK_c_760_n N_noxref_7_c_2098_n ) capacitor c=0.00120406f \
 //x=15.325 //y=1.085 //x2=15.59 //y2=1.18
cc_759 ( N_CLK_c_763_n N_noxref_7_c_2098_n ) capacitor c=0.00218772f \
 //x=15.325 //y=1.43 //x2=15.59 //y2=1.18
cc_760 ( N_CLK_c_860_p N_noxref_7_c_2098_n ) capacitor c=5.50523e-19 //x=15.7 \
 //y=0.93 //x2=15.59 //y2=1.18
cc_761 ( N_CLK_c_833_p N_noxref_7_c_2098_n ) capacitor c=5.64626e-19 //x=15.7 \
 //y=1.585 //x2=15.59 //y2=1.18
cc_762 ( N_CLK_c_768_n N_noxref_7_c_2098_n ) capacitor c=0.00109205f \
 //x=15.855 //y=1.085 //x2=15.59 //y2=1.18
cc_763 ( N_CLK_c_769_n N_noxref_7_c_2098_n ) capacitor c=0.00317092f \
 //x=15.855 //y=1.43 //x2=15.59 //y2=1.18
cc_764 ( CLK N_noxref_7_c_2197_n ) capacitor c=9.19401e-19 //x=15.29 //y=2.77 \
 //x2=16.03 //y2=3.88
cc_765 ( N_CLK_c_782_p N_noxref_7_c_2059_n ) capacitor c=0.00355065f //x=7.5 \
 //y=4.62 //x2=7.5 //y2=3.88
cc_766 ( N_CLK_c_701_n N_noxref_7_c_2199_n ) capacitor c=0.00179696f //x=8.1 \
 //y=4.635 //x2=8.1 //y2=3.865
cc_767 ( N_CLK_c_701_n N_noxref_7_c_2060_n ) capacitor c=0.0213322f //x=8.1 \
 //y=4.635 //x2=12.12 //y2=3.88
cc_768 ( CLK N_noxref_7_c_2064_n ) capacitor c=0.00513046f //x=6.04 //y=3.14 \
 //x2=7.315 //y2=3.865
cc_769 ( CLK N_noxref_7_c_2100_n ) capacitor c=0.0247936f //x=15.29 //y=2.77 \
 //x2=15.865 //y2=3.865
cc_770 ( N_CLK_c_701_n N_noxref_7_c_2100_n ) capacitor c=0.0185064f //x=8.1 \
 //y=4.635 //x2=15.865 //y2=3.865
cc_771 ( CLK N_noxref_7_c_2204_n ) capacitor c=0.00338457f //x=15.29 //y=2.77 \
 //x2=16.185 //y2=3.865
cc_772 ( CLK N_noxref_7_c_2205_n ) capacitor c=4.16726e-19 //x=6.04 //y=3.14 \
 //x2=7.15 //y2=2.26
cc_773 ( N_CLK_c_693_n N_noxref_7_c_2205_n ) capacitor c=5.42289e-19 //x=6.04 \
 //y=2.375 //x2=7.15 //y2=2.26
cc_774 ( N_CLK_c_704_n N_noxref_7_c_2205_n ) capacitor c=0.00125213f //x=6.04 \
 //y=2.26 //x2=7.15 //y2=2.26
cc_775 ( N_CLK_c_723_n N_noxref_7_c_2205_n ) capacitor c=0.00209664f //x=6.13 \
 //y=2.095 //x2=7.15 //y2=2.26
cc_776 ( N_CLK_c_697_n N_noxref_7_c_2209_n ) capacitor c=9.62855e-19 //x=6.04 \
 //y=4.755 //x2=7.15 //y2=4.88
cc_777 ( N_CLK_c_708_n N_noxref_7_c_2209_n ) capacitor c=0.00113668f //x=6.04 \
 //y=4.88 //x2=7.15 //y2=4.88
cc_778 ( N_CLK_c_726_n N_noxref_7_c_2209_n ) capacitor c=9.77556e-19 //x=6.04 \
 //y=4.88 //x2=7.15 //y2=4.88
cc_779 ( N_CLK_c_740_n N_noxref_7_c_2212_n ) capacitor c=7.41644e-19 \
 //x=15.325 //y=4.75 //x2=15.55 //y2=5.56
cc_780 ( N_CLK_M33_noxref_g N_noxref_7_c_2212_n ) capacitor c=0.0178987f \
 //x=15.33 //y=6.2 //x2=15.55 //y2=5.56
cc_781 ( N_CLK_M34_noxref_g N_noxref_7_c_2212_n ) capacitor c=0.0178506f \
 //x=15.77 //y=6.2 //x2=15.55 //y2=5.56
cc_782 ( N_CLK_c_845_p N_noxref_7_c_2212_n ) capacitor c=0.00291714f \
 //x=15.695 //y=4.97 //x2=15.55 //y2=5.56
cc_783 ( N_CLK_M21_noxref_g N_noxref_7_M23_noxref_g ) capacitor c=0.0101598f \
 //x=6.01 //y=6.2 //x2=6.89 //y2=6.2
cc_784 ( N_CLK_M22_noxref_g N_noxref_7_M23_noxref_g ) capacitor c=0.0607518f \
 //x=6.45 //y=6.2 //x2=6.89 //y2=6.2
cc_785 ( N_CLK_M22_noxref_g N_noxref_7_M24_noxref_g ) capacitor c=0.0101598f \
 //x=6.45 //y=6.2 //x2=7.33 //y2=6.2
cc_786 ( N_CLK_c_720_n N_noxref_7_c_2219_n ) capacitor c=0.00456962f //x=6.13 \
 //y=1.09 //x2=7.14 //y2=1.095
cc_787 ( N_CLK_c_721_n N_noxref_7_c_2220_n ) capacitor c=0.00438372f //x=6.13 \
 //y=1.4 //x2=7.14 //y2=1.44
cc_788 ( N_CLK_c_722_n N_noxref_7_c_2221_n ) capacitor c=0.00438372f //x=6.13 \
 //y=1.63 //x2=7.14 //y2=1.75
cc_789 ( N_CLK_c_693_n N_noxref_7_c_2222_n ) capacitor c=0.00139071f //x=6.04 \
 //y=2.375 //x2=7.15 //y2=2.26
cc_790 ( N_CLK_c_704_n N_noxref_7_c_2222_n ) capacitor c=0.00204868f //x=6.04 \
 //y=2.26 //x2=7.15 //y2=2.26
cc_791 ( N_CLK_c_723_n N_noxref_7_c_2222_n ) capacitor c=0.00933826f //x=6.13 \
 //y=2.095 //x2=7.15 //y2=2.26
cc_792 ( N_CLK_c_723_n N_noxref_7_c_2225_n ) capacitor c=0.00438372f //x=6.13 \
 //y=2.095 //x2=7.15 //y2=2.095
cc_793 ( N_CLK_c_697_n N_noxref_7_c_2226_n ) capacitor c=0.00135081f //x=6.04 \
 //y=4.755 //x2=7.15 //y2=4.88
cc_794 ( N_CLK_c_708_n N_noxref_7_c_2226_n ) capacitor c=0.00186974f //x=6.04 \
 //y=4.88 //x2=7.15 //y2=4.88
cc_795 ( N_CLK_c_796_p N_noxref_7_c_2226_n ) capacitor c=0.0616777f //x=6.375 \
 //y=4.97 //x2=7.15 //y2=4.88
cc_796 ( N_CLK_c_726_n N_noxref_7_c_2226_n ) capacitor c=0.0042693f //x=6.04 \
 //y=4.88 //x2=7.15 //y2=4.88
cc_797 ( N_CLK_c_760_n N_noxref_7_M9_noxref_d ) capacitor c=0.00137165f \
 //x=15.325 //y=1.085 //x2=15.4 //y2=1.085
cc_798 ( N_CLK_c_763_n N_noxref_7_M9_noxref_d ) capacitor c=0.00237422f \
 //x=15.325 //y=1.43 //x2=15.4 //y2=1.085
cc_799 ( N_CLK_c_860_p N_noxref_7_M9_noxref_d ) capacitor c=0.0020782f \
 //x=15.7 //y=0.93 //x2=15.4 //y2=1.085
cc_800 ( N_CLK_c_833_p N_noxref_7_M9_noxref_d ) capacitor c=0.00356097f \
 //x=15.7 //y=1.585 //x2=15.4 //y2=1.085
cc_801 ( N_CLK_c_768_n N_noxref_7_M9_noxref_d ) capacitor c=8.50095e-19 \
 //x=15.855 //y=1.085 //x2=15.4 //y2=1.085
cc_802 ( N_CLK_c_769_n N_noxref_7_M9_noxref_d ) capacitor c=0.00237422f \
 //x=15.855 //y=1.43 //x2=15.4 //y2=1.085
cc_803 ( N_CLK_M21_noxref_g N_VDD_c_3014_n ) capacitor c=0.00705252f //x=6.01 \
 //y=6.2 //x2=6.585 //y2=7.585
cc_804 ( N_CLK_M22_noxref_g N_VDD_c_3014_n ) capacitor c=0.00755544f //x=6.45 \
 //y=6.2 //x2=6.585 //y2=7.585
cc_805 ( N_CLK_M33_noxref_g N_VDD_c_3016_n ) capacitor c=0.00697352f //x=15.33 \
 //y=6.2 //x2=15.905 //y2=7.585
cc_806 ( N_CLK_M34_noxref_g N_VDD_c_3016_n ) capacitor c=0.00755544f //x=15.77 \
 //y=6.2 //x2=15.905 //y2=7.585
cc_807 ( N_CLK_c_701_n N_VDD_c_2933_n ) capacitor c=0.0264761f //x=8.1 \
 //y=4.635 //x2=8.63 //y2=7.585
cc_808 ( N_CLK_c_701_n N_VDD_c_2991_n ) capacitor c=0.0263497f //x=8.1 \
 //y=4.635 //x2=13.44 //y2=7.585
cc_809 ( N_CLK_c_754_n N_VDD_c_3020_n ) capacitor c=0.00228191f //x=15.32 \
 //y=4.88 //x2=16.77 //y2=7.585
cc_810 ( N_CLK_c_845_p N_VDD_c_3020_n ) capacitor c=0.0129149f //x=15.695 \
 //y=4.97 //x2=16.77 //y2=7.585
cc_811 ( N_CLK_c_773_n N_VDD_c_3020_n ) capacitor c=2.73429e-19 //x=15.32 \
 //y=4.88 //x2=16.77 //y2=7.585
cc_812 ( N_CLK_M21_noxref_g N_VDD_M20_noxref_d ) capacitor c=0.015318f \
 //x=6.01 //y=6.2 //x2=5.645 //y2=5.2
cc_813 ( N_CLK_M22_noxref_g N_VDD_M22_noxref_d ) capacitor c=0.015318f \
 //x=6.45 //y=6.2 //x2=6.525 //y2=5.2
cc_814 ( N_CLK_c_701_n N_VDD_M25_noxref_s ) capacitor c=8.5753e-19 //x=8.1 \
 //y=4.635 //x2=9.585 //y2=5.2
cc_815 ( N_CLK_c_701_n N_VDD_M31_noxref_s ) capacitor c=0.00781443f //x=8.1 \
 //y=4.635 //x2=14.095 //y2=5.2
cc_816 ( N_CLK_M33_noxref_g N_VDD_M32_noxref_d ) capacitor c=0.015318f \
 //x=15.33 //y=6.2 //x2=14.965 //y2=5.2
cc_817 ( N_CLK_c_773_n N_VDD_M32_noxref_d ) capacitor c=3.50465e-19 //x=15.32 \
 //y=4.88 //x2=14.965 //y2=5.2
cc_818 ( N_CLK_M34_noxref_g N_VDD_M34_noxref_d ) capacitor c=0.0430452f \
 //x=15.77 //y=6.2 //x2=15.845 //y2=5.2
cc_819 ( N_CLK_c_720_n N_noxref_11_c_3393_n ) capacitor c=0.00123426f //x=6.13 \
 //y=1.09 //x2=6.835 //y2=1.175
cc_820 ( N_CLK_c_721_n N_noxref_11_c_3393_n ) capacitor c=0.0129288f //x=6.13 \
 //y=1.4 //x2=6.835 //y2=1.175
cc_821 ( N_CLK_c_722_n N_noxref_11_c_3393_n ) capacitor c=0.00132209f //x=6.13 \
 //y=1.63 //x2=6.835 //y2=1.175
cc_822 ( N_CLK_c_693_n N_noxref_11_M3_noxref_d ) capacitor c=0.00604066f \
 //x=6.04 //y=2.375 //x2=5.68 //y2=1.09
cc_823 ( N_CLK_c_704_n N_noxref_11_M3_noxref_d ) capacitor c=2.2052e-19 \
 //x=6.04 //y=2.26 //x2=5.68 //y2=1.09
cc_824 ( N_CLK_c_715_n N_noxref_11_M3_noxref_d ) capacitor c=0.00253592f \
 //x=5.605 //y=1.09 //x2=5.68 //y2=1.09
cc_825 ( N_CLK_c_718_n N_noxref_11_M3_noxref_d ) capacitor c=0.00604066f \
 //x=5.605 //y=1.4 //x2=5.68 //y2=1.09
cc_826 ( N_CLK_c_926_p N_noxref_11_M3_noxref_d ) capacitor c=0.002686f \
 //x=5.975 //y=0.935 //x2=5.68 //y2=1.09
cc_827 ( N_CLK_c_927_p N_noxref_11_M3_noxref_d ) capacitor c=0.00251995f \
 //x=5.975 //y=1.555 //x2=5.68 //y2=1.09
cc_828 ( N_CLK_c_720_n N_noxref_11_M3_noxref_d ) capacitor c=0.00314523f \
 //x=6.13 //y=1.09 //x2=5.68 //y2=1.09
cc_829 ( N_CLK_c_721_n N_noxref_11_M3_noxref_d ) capacitor c=0.00168289f \
 //x=6.13 //y=1.4 //x2=5.68 //y2=1.09
cc_830 ( N_CLK_c_722_n N_noxref_11_M3_noxref_d ) capacitor c=0.00111165f \
 //x=6.13 //y=1.63 //x2=5.68 //y2=1.09
cc_831 ( N_CLK_c_720_n N_noxref_11_M4_noxref_s ) capacitor c=7.21316e-19 \
 //x=6.13 //y=1.09 //x2=6.785 //y2=0.555
cc_832 ( N_CLK_c_721_n N_noxref_11_M4_noxref_s ) capacitor c=0.00365271f \
 //x=6.13 //y=1.4 //x2=6.785 //y2=0.555
cc_833 ( N_CLK_c_723_n N_noxref_11_M4_noxref_s ) capacitor c=9.86711e-19 \
 //x=6.13 //y=2.095 //x2=6.785 //y2=0.555
cc_834 ( N_CLK_c_693_n N_GND_c_3651_n ) capacitor c=9.16602e-19 //x=6.04 \
 //y=2.375 //x2=9.62 //y2=0.175
cc_835 ( N_CLK_c_737_n N_GND_c_3652_n ) capacitor c=0.00210951f //x=15.29 \
 //y=2.26 //x2=17.865 //y2=0.175
cc_836 ( N_CLK_c_737_n N_GND_c_3629_n ) capacitor c=3.77328e-19 //x=15.29 \
 //y=2.26 //x2=16.6 //y2=0.175
cc_837 ( N_CLK_c_750_n N_GND_c_3643_n ) capacitor c=0.00200922f //x=15.29 \
 //y=2.26 //x2=16.77 //y2=0.175
cc_838 ( N_CLK_c_769_n N_GND_c_3643_n ) capacitor c=0.00275184f //x=15.855 \
 //y=1.43 //x2=16.77 //y2=0.175
cc_839 ( N_CLK_c_770_n N_GND_c_3643_n ) capacitor c=2.63786e-19 //x=15.29 \
 //y=2.26 //x2=16.77 //y2=0.175
cc_840 ( N_CLK_c_715_n N_noxref_16_c_4141_n ) capacitor c=0.0167228f //x=5.605 \
 //y=1.09 //x2=6.265 //y2=0.72
cc_841 ( N_CLK_c_720_n N_noxref_16_c_4141_n ) capacitor c=0.00534519f //x=6.13 \
 //y=1.09 //x2=6.265 //y2=0.72
cc_842 ( N_CLK_c_693_n N_noxref_16_c_4135_n ) capacitor c=0.0048147f //x=6.04 \
 //y=2.375 //x2=6.265 //y2=1.77
cc_843 ( N_CLK_c_697_n N_noxref_16_c_4135_n ) capacitor c=9.66785e-19 //x=6.04 \
 //y=4.755 //x2=6.265 //y2=1.77
cc_844 ( N_CLK_c_704_n N_noxref_16_c_4135_n ) capacitor c=0.0105652f //x=6.04 \
 //y=2.26 //x2=6.265 //y2=1.77
cc_845 ( N_CLK_c_718_n N_noxref_16_c_4135_n ) capacitor c=0.0153476f //x=5.605 \
 //y=1.4 //x2=6.265 //y2=1.77
cc_846 ( N_CLK_c_723_n N_noxref_16_c_4135_n ) capacitor c=0.0200931f //x=6.13 \
 //y=2.095 //x2=6.265 //y2=1.77
cc_847 ( N_CLK_c_715_n N_noxref_16_M2_noxref_s ) capacitor c=0.00798959f \
 //x=5.605 //y=1.09 //x2=4.275 //y2=0.555
cc_848 ( N_CLK_c_722_n N_noxref_16_M2_noxref_s ) capacitor c=0.00212176f \
 //x=6.13 //y=1.63 //x2=4.275 //y2=0.555
cc_849 ( N_CLK_c_723_n N_noxref_16_M2_noxref_s ) capacitor c=0.00298115f \
 //x=6.13 //y=2.095 //x2=4.275 //y2=0.555
cc_850 ( N_CLK_c_737_n N_noxref_18_c_4252_n ) capacitor c=7.50092e-19 \
 //x=15.29 //y=2.26 //x2=15.105 //y2=1.675
cc_851 ( N_CLK_c_765_n N_noxref_18_c_4252_n ) capacitor c=0.00888238f \
 //x=15.325 //y=1.74 //x2=15.105 //y2=1.675
cc_852 ( N_CLK_c_770_n N_noxref_18_c_4252_n ) capacitor c=0.00175171f \
 //x=15.29 //y=2.26 //x2=15.105 //y2=1.675
cc_853 ( N_CLK_c_737_n N_noxref_18_c_4259_n ) capacitor c=0.001463f //x=15.29 \
 //y=2.26 //x2=15.99 //y2=0.71
cc_854 ( N_CLK_c_750_n N_noxref_18_c_4259_n ) capacitor c=8.82141e-19 \
 //x=15.29 //y=2.26 //x2=15.99 //y2=0.71
cc_855 ( N_CLK_c_760_n N_noxref_18_c_4259_n ) capacitor c=0.0200738f \
 //x=15.325 //y=1.085 //x2=15.99 //y2=0.71
cc_856 ( N_CLK_c_768_n N_noxref_18_c_4259_n ) capacitor c=0.00825432f \
 //x=15.855 //y=1.085 //x2=15.99 //y2=0.71
cc_857 ( N_CLK_c_770_n N_noxref_18_c_4259_n ) capacitor c=2.1838e-19 //x=15.29 \
 //y=2.26 //x2=15.99 //y2=0.71
cc_858 ( N_CLK_c_760_n N_noxref_18_M8_noxref_s ) capacitor c=0.00888238f \
 //x=15.325 //y=1.085 //x2=14 //y2=0.545
cc_859 ( N_CLK_c_768_n N_noxref_18_M8_noxref_s ) capacitor c=0.015333f \
 //x=15.855 //y=1.085 //x2=14 //y2=0.545
cc_860 ( N_CLK_c_769_n N_noxref_18_M8_noxref_s ) capacitor c=0.00248746f \
 //x=15.855 //y=1.43 //x2=14 //y2=0.545
cc_861 ( N_noxref_4_c_1068_n QN ) capacitor c=0.0022775f //x=17.88 //y=4.105 \
 //x2=19.36 //y2=2.77
cc_862 ( N_noxref_4_c_1068_n QN ) capacitor c=0.00134038f //x=17.88 //y=4.105 \
 //x2=19.36 //y2=3.51
cc_863 ( N_noxref_4_c_1076_n QN ) capacitor c=0.0015348f //x=17.882 //y=4.74 \
 //x2=19.36 //y2=3.51
cc_864 ( N_noxref_4_M36_noxref_g N_QN_c_1434_n ) capacitor c=0.0103227f \
 //x=18.22 //y=6.2 //x2=18.765 //y2=5.38
cc_865 ( N_noxref_4_c_1093_p N_QN_c_1435_n ) capacitor c=0.00121594f //x=17.88 \
 //y=4.425 //x2=18 //y2=5.56
cc_866 ( N_noxref_4_c_1094_p N_QN_c_1435_n ) capacitor c=0.0117962f //x=17.88 \
 //y=4.88 //x2=18 //y2=5.56
cc_867 ( N_noxref_4_c_1095_p N_QN_c_1435_n ) capacitor c=6.61088e-19 //x=17.88 \
 //y=4.265 //x2=18 //y2=5.56
cc_868 ( N_noxref_4_c_1096_p N_QN_c_1435_n ) capacitor c=0.00277154f //x=17.88 \
 //y=4.88 //x2=18 //y2=5.56
cc_869 ( N_noxref_4_M35_noxref_g N_QN_c_1435_n ) capacitor c=0.00201806f \
 //x=17.78 //y=6.2 //x2=18 //y2=5.56
cc_870 ( N_noxref_4_M36_noxref_g N_QN_c_1435_n ) capacitor c=0.00192712f \
 //x=18.22 //y=6.2 //x2=18 //y2=5.56
cc_871 ( N_noxref_4_c_1099_p N_QN_c_1435_n ) capacitor c=0.00201193f //x=17.88 \
 //y=4.88 //x2=18 //y2=5.56
cc_872 ( N_noxref_4_c_1093_p N_QN_c_1442_n ) capacitor c=4.87998e-19 //x=17.88 \
 //y=4.425 //x2=18 //y2=5.56
cc_873 ( N_noxref_4_c_1094_p N_QN_c_1442_n ) capacitor c=0.00104426f //x=17.88 \
 //y=4.88 //x2=18 //y2=5.56
cc_874 ( N_noxref_4_c_1096_p N_QN_c_1442_n ) capacitor c=0.00377369f //x=17.88 \
 //y=4.88 //x2=18 //y2=5.56
cc_875 ( N_noxref_4_M35_noxref_g N_QN_c_1442_n ) capacitor c=0.0158358f \
 //x=17.78 //y=6.2 //x2=18 //y2=5.56
cc_876 ( N_noxref_4_M36_noxref_g N_QN_c_1442_n ) capacitor c=0.0178987f \
 //x=18.22 //y=6.2 //x2=18 //y2=5.56
cc_877 ( N_noxref_4_c_1099_p N_QN_c_1442_n ) capacitor c=0.00319448f //x=17.88 \
 //y=4.88 //x2=18 //y2=5.56
cc_878 ( N_noxref_4_c_981_n SN ) capacitor c=0.00144926f //x=7.89 //y=4.09 \
 //x2=10.85 //y2=2.77
cc_879 ( N_noxref_4_c_988_n SN ) capacitor c=3.83887e-19 //x=7.89 //y=5.25 \
 //x2=10.85 //y2=2.77
cc_880 ( N_noxref_4_c_1009_n SN ) capacitor c=0.023508f //x=17.72 //y=4.265 \
 //x2=10.85 //y2=2.77
cc_881 ( N_noxref_4_c_1068_n N_SN_c_1757_n ) capacitor c=0.0179022f //x=17.88 \
 //y=4.105 //x2=22.15 //y2=2.39
cc_882 ( N_noxref_4_c_1110_p N_SN_c_1757_n ) capacitor c=0.0183918f //x=17.88 \
 //y=2.26 //x2=22.15 //y2=2.39
cc_883 ( N_noxref_4_c_1009_n N_SN_c_1757_n ) capacitor c=0.0132793f //x=17.72 \
 //y=4.265 //x2=22.15 //y2=2.39
cc_884 ( N_noxref_4_c_1112_p N_SN_c_1757_n ) capacitor c=2.20453e-19 //x=17.88 \
 //y=2.26 //x2=22.15 //y2=2.39
cc_885 ( N_noxref_4_c_981_n N_noxref_7_c_2047_n ) capacitor c=0.0154269f \
 //x=7.89 //y=4.09 //x2=7.15 //y2=2.375
cc_886 ( N_noxref_4_c_981_n N_noxref_7_c_2048_n ) capacitor c=0.0587286f \
 //x=7.89 //y=4.09 //x2=7.15 //y2=3.705
cc_887 ( N_noxref_4_c_1050_n N_noxref_7_c_2053_n ) capacitor c=0.00116878f \
 //x=7.805 //y=5.335 //x2=7.15 //y2=4.025
cc_888 ( N_noxref_4_c_977_n N_noxref_7_c_2053_n ) capacitor c=2.04829e-19 \
 //x=7.405 //y=1.305 //x2=7.15 //y2=4.025
cc_889 ( N_noxref_4_c_979_n N_noxref_7_c_2053_n ) capacitor c=8.43174e-19 \
 //x=7.49 //y=1.845 //x2=7.15 //y2=4.025
cc_890 ( N_noxref_4_c_981_n N_noxref_7_c_2053_n ) capacitor c=0.0176025f \
 //x=7.89 //y=4.09 //x2=7.15 //y2=4.025
cc_891 ( N_noxref_4_c_1119_p N_noxref_7_c_2053_n ) capacitor c=7.66594e-19 \
 //x=7.11 //y=5.335 //x2=7.15 //y2=4.025
cc_892 ( N_noxref_4_c_996_n N_noxref_7_c_2053_n ) capacitor c=0.00522697f \
 //x=7.725 //y=4.25 //x2=7.15 //y2=4.025
cc_893 ( N_noxref_4_c_1050_n N_noxref_7_c_2054_n ) capacitor c=0.00228791f \
 //x=7.805 //y=5.335 //x2=7.15 //y2=4.75
cc_894 ( N_noxref_4_c_981_n N_noxref_7_c_2054_n ) capacitor c=0.00283381f \
 //x=7.89 //y=4.09 //x2=7.15 //y2=4.75
cc_895 ( N_noxref_4_c_987_n N_noxref_7_c_2054_n ) capacitor c=0.0147947f \
 //x=7.89 //y=4.41 //x2=7.15 //y2=4.75
cc_896 ( N_noxref_4_c_988_n N_noxref_7_c_2054_n ) capacitor c=0.0275491f \
 //x=7.89 //y=5.25 //x2=7.15 //y2=4.75
cc_897 ( N_noxref_4_c_1119_p N_noxref_7_c_2054_n ) capacitor c=0.0221235f \
 //x=7.11 //y=5.335 //x2=7.15 //y2=4.75
cc_898 ( N_noxref_4_c_1126_p N_noxref_7_c_2054_n ) capacitor c=6.4807e-19 \
 //x=7.885 //y=4.25 //x2=7.15 //y2=4.75
cc_899 ( N_noxref_4_c_996_n N_noxref_7_c_2054_n ) capacitor c=0.0210332f \
 //x=7.725 //y=4.25 //x2=7.15 //y2=4.75
cc_900 ( N_noxref_4_c_1005_n N_noxref_7_c_2054_n ) capacitor c=0.00328982f \
 //x=8.045 //y=4.25 //x2=7.15 //y2=4.75
cc_901 ( N_noxref_4_c_1129_p N_noxref_7_c_2054_n ) capacitor c=0.00217653f \
 //x=7.11 //y=5.56 //x2=7.15 //y2=4.75
cc_902 ( N_noxref_4_c_1009_n N_noxref_7_c_2073_n ) capacitor c=0.00531452f \
 //x=17.72 //y=4.265 //x2=11.96 //y2=4.025
cc_903 ( N_noxref_4_c_1009_n N_noxref_7_c_2058_n ) capacitor c=0.0214777f \
 //x=17.72 //y=4.265 //x2=11.96 //y2=4.75
cc_904 ( N_noxref_4_c_1068_n N_noxref_7_c_2084_n ) capacitor c=0.0226195f \
 //x=17.88 //y=4.105 //x2=16.03 //y2=3.705
cc_905 ( N_noxref_4_c_1110_p N_noxref_7_c_2084_n ) capacitor c=0.00344372f \
 //x=17.88 //y=2.26 //x2=16.03 //y2=3.705
cc_906 ( N_noxref_4_c_1068_n N_noxref_7_c_2177_n ) capacitor c=0.00238733f \
 //x=17.88 //y=4.105 //x2=16.03 //y2=4.025
cc_907 ( N_noxref_4_c_1009_n N_noxref_7_c_2177_n ) capacitor c=0.00689641f \
 //x=17.72 //y=4.265 //x2=16.03 //y2=4.025
cc_908 ( N_noxref_4_c_1068_n N_noxref_7_c_2087_n ) capacitor c=0.00129137f \
 //x=17.88 //y=4.105 //x2=16.03 //y2=5.295
cc_909 ( N_noxref_4_c_1093_p N_noxref_7_c_2087_n ) capacitor c=0.00249513f \
 //x=17.88 //y=4.425 //x2=16.03 //y2=5.295
cc_910 ( N_noxref_4_c_1094_p N_noxref_7_c_2087_n ) capacitor c=0.00476843f \
 //x=17.88 //y=4.88 //x2=16.03 //y2=5.295
cc_911 ( N_noxref_4_c_1076_n N_noxref_7_c_2087_n ) capacitor c=0.00494097f \
 //x=17.882 //y=4.74 //x2=16.03 //y2=5.295
cc_912 ( N_noxref_4_c_1095_p N_noxref_7_c_2087_n ) capacitor c=0.0015808f \
 //x=17.88 //y=4.265 //x2=16.03 //y2=5.295
cc_913 ( N_noxref_4_c_1009_n N_noxref_7_c_2087_n ) capacitor c=0.028335f \
 //x=17.72 //y=4.265 //x2=16.03 //y2=5.295
cc_914 ( N_noxref_4_c_981_n N_noxref_7_c_2184_n ) capacitor c=9.19401e-19 \
 //x=7.89 //y=4.09 //x2=7.15 //y2=3.88
cc_915 ( N_noxref_4_c_1009_n N_noxref_7_c_2186_n ) capacitor c=0.012715f \
 //x=17.72 //y=4.265 //x2=15.55 //y2=5.38
cc_916 ( N_noxref_4_c_981_n N_noxref_7_c_2059_n ) capacitor c=2.73038e-19 \
 //x=7.89 //y=4.09 //x2=7.5 //y2=3.88
cc_917 ( N_noxref_4_c_996_n N_noxref_7_c_2059_n ) capacitor c=0.0345781f \
 //x=7.725 //y=4.25 //x2=7.5 //y2=3.88
cc_918 ( N_noxref_4_c_981_n N_noxref_7_c_2199_n ) capacitor c=0.0253905f \
 //x=7.89 //y=4.09 //x2=8.1 //y2=3.865
cc_919 ( N_noxref_4_c_987_n N_noxref_7_c_2199_n ) capacitor c=0.00912961f \
 //x=7.89 //y=4.41 //x2=8.1 //y2=3.865
cc_920 ( N_noxref_4_c_1005_n N_noxref_7_c_2199_n ) capacitor c=0.0358834f \
 //x=8.045 //y=4.25 //x2=8.1 //y2=3.865
cc_921 ( N_noxref_4_c_1009_n N_noxref_7_c_2199_n ) capacitor c=0.0109116f \
 //x=17.72 //y=4.265 //x2=8.1 //y2=3.865
cc_922 ( N_noxref_4_c_981_n N_noxref_7_c_2060_n ) capacitor c=4.72093e-19 \
 //x=7.89 //y=4.09 //x2=12.12 //y2=3.88
cc_923 ( N_noxref_4_c_1009_n N_noxref_7_c_2060_n ) capacitor c=0.355192f \
 //x=17.72 //y=4.265 //x2=12.12 //y2=3.88
cc_924 ( N_noxref_4_c_981_n N_noxref_7_c_2064_n ) capacitor c=0.00317812f \
 //x=7.89 //y=4.09 //x2=7.315 //y2=3.865
cc_925 ( N_noxref_4_c_996_n N_noxref_7_c_2064_n ) capacitor c=0.0358686f \
 //x=7.725 //y=4.25 //x2=7.315 //y2=3.865
cc_926 ( N_noxref_4_c_1009_n N_noxref_7_c_2100_n ) capacitor c=0.326716f \
 //x=17.72 //y=4.265 //x2=15.865 //y2=3.865
cc_927 ( N_noxref_4_c_1068_n N_noxref_7_c_2204_n ) capacitor c=0.00159442f \
 //x=17.88 //y=4.105 //x2=16.185 //y2=3.865
cc_928 ( N_noxref_4_c_1009_n N_noxref_7_c_2204_n ) capacitor c=0.0365231f \
 //x=17.72 //y=4.265 //x2=16.185 //y2=3.865
cc_929 ( N_noxref_4_c_1068_n N_noxref_7_c_2280_n ) capacitor c=0.027903f \
 //x=17.88 //y=4.105 //x2=23.27 //y2=3.885
cc_930 ( N_noxref_4_c_1093_p N_noxref_7_c_2280_n ) capacitor c=0.00890815f \
 //x=17.88 //y=4.425 //x2=23.27 //y2=3.885
cc_931 ( N_noxref_4_c_1095_p N_noxref_7_c_2280_n ) capacitor c=0.0368432f \
 //x=17.88 //y=4.265 //x2=23.27 //y2=3.885
cc_932 ( N_noxref_4_c_1009_n N_noxref_7_c_2280_n ) capacitor c=0.142205f \
 //x=17.72 //y=4.265 //x2=23.27 //y2=3.885
cc_933 ( N_noxref_4_c_981_n N_noxref_7_c_2205_n ) capacitor c=0.00163444f \
 //x=7.89 //y=4.09 //x2=7.15 //y2=2.26
cc_934 ( N_noxref_4_c_1050_n N_noxref_7_c_2209_n ) capacitor c=0.00130631f \
 //x=7.805 //y=5.335 //x2=7.15 //y2=4.88
cc_935 ( N_noxref_4_c_988_n N_noxref_7_c_2209_n ) capacitor c=0.0013045f \
 //x=7.89 //y=5.25 //x2=7.15 //y2=4.88
cc_936 ( N_noxref_4_c_1119_p N_noxref_7_c_2209_n ) capacitor c=0.00346456f \
 //x=7.11 //y=5.335 //x2=7.15 //y2=4.88
cc_937 ( N_noxref_4_c_1129_p N_noxref_7_c_2209_n ) capacitor c=0.00624059f \
 //x=7.11 //y=5.56 //x2=7.15 //y2=4.88
cc_938 ( N_noxref_4_c_1060_n N_noxref_7_M23_noxref_g ) capacitor c=0.00955829f \
 //x=6.995 //y=5.335 //x2=6.89 //y2=6.2
cc_939 ( N_noxref_4_c_1049_n N_noxref_7_M23_noxref_g ) capacitor c=0.00226521f \
 //x=7.11 //y=5.56 //x2=6.89 //y2=6.2
cc_940 ( N_noxref_4_c_1129_p N_noxref_7_M23_noxref_g ) capacitor c=0.0178885f \
 //x=7.11 //y=5.56 //x2=6.89 //y2=6.2
cc_941 ( N_noxref_4_c_1049_n N_noxref_7_M24_noxref_g ) capacitor c=0.00381703f \
 //x=7.11 //y=5.56 //x2=7.33 //y2=6.2
cc_942 ( N_noxref_4_c_1050_n N_noxref_7_M24_noxref_g ) capacitor c=0.0109667f \
 //x=7.805 //y=5.335 //x2=7.33 //y2=6.2
cc_943 ( N_noxref_4_c_1129_p N_noxref_7_M24_noxref_g ) capacitor c=0.0188608f \
 //x=7.11 //y=5.56 //x2=7.33 //y2=6.2
cc_944 ( N_noxref_4_c_977_n N_noxref_7_c_2219_n ) capacitor c=4.64015e-19 \
 //x=7.405 //y=1.305 //x2=7.14 //y2=1.095
cc_945 ( N_noxref_4_M4_noxref_d N_noxref_7_c_2219_n ) capacitor c=0.00137165f \
 //x=7.215 //y=1.095 //x2=7.14 //y2=1.095
cc_946 ( N_noxref_4_c_977_n N_noxref_7_c_2220_n ) capacitor c=0.0026012f \
 //x=7.405 //y=1.305 //x2=7.14 //y2=1.44
cc_947 ( N_noxref_4_c_978_n N_noxref_7_c_2220_n ) capacitor c=0.00127432f \
 //x=7.405 //y=1.76 //x2=7.14 //y2=1.44
cc_948 ( N_noxref_4_M4_noxref_d N_noxref_7_c_2220_n ) capacitor c=0.00237422f \
 //x=7.215 //y=1.095 //x2=7.14 //y2=1.44
cc_949 ( N_noxref_4_c_978_n N_noxref_7_c_2221_n ) capacitor c=0.00429966f \
 //x=7.405 //y=1.76 //x2=7.14 //y2=1.75
cc_950 ( N_noxref_4_c_977_n N_noxref_7_c_2301_n ) capacitor c=5.29969e-19 \
 //x=7.405 //y=1.305 //x2=7.515 //y2=0.94
cc_951 ( N_noxref_4_M4_noxref_d N_noxref_7_c_2301_n ) capacitor c=0.0020782f \
 //x=7.215 //y=1.095 //x2=7.515 //y2=0.94
cc_952 ( N_noxref_4_c_977_n N_noxref_7_c_2303_n ) capacitor c=5.16926e-19 \
 //x=7.405 //y=1.305 //x2=7.515 //y2=1.595
cc_953 ( N_noxref_4_c_978_n N_noxref_7_c_2303_n ) capacitor c=0.00942306f \
 //x=7.405 //y=1.76 //x2=7.515 //y2=1.595
cc_954 ( N_noxref_4_c_1051_n N_noxref_7_c_2303_n ) capacitor c=0.00194716f \
 //x=7.805 //y=1.845 //x2=7.515 //y2=1.595
cc_955 ( N_noxref_4_M4_noxref_d N_noxref_7_c_2303_n ) capacitor c=0.00356097f \
 //x=7.215 //y=1.095 //x2=7.515 //y2=1.595
cc_956 ( N_noxref_4_c_977_n N_noxref_7_c_2307_n ) capacitor c=5.24634e-19 \
 //x=7.405 //y=1.305 //x2=7.67 //y2=1.095
cc_957 ( N_noxref_4_M4_noxref_d N_noxref_7_c_2307_n ) capacitor c=0.00139206f \
 //x=7.215 //y=1.095 //x2=7.67 //y2=1.095
cc_958 ( N_noxref_4_c_977_n N_noxref_7_c_2309_n ) capacitor c=0.00307978f \
 //x=7.405 //y=1.305 //x2=7.67 //y2=1.44
cc_959 ( N_noxref_4_c_978_n N_noxref_7_c_2309_n ) capacitor c=0.00363411f \
 //x=7.405 //y=1.76 //x2=7.67 //y2=1.44
cc_960 ( N_noxref_4_c_1051_n N_noxref_7_c_2309_n ) capacitor c=0.00323576f \
 //x=7.805 //y=1.845 //x2=7.67 //y2=1.44
cc_961 ( N_noxref_4_M4_noxref_d N_noxref_7_c_2309_n ) capacitor c=0.00237422f \
 //x=7.215 //y=1.095 //x2=7.67 //y2=1.44
cc_962 ( N_noxref_4_c_981_n N_noxref_7_c_2222_n ) capacitor c=0.0025845f \
 //x=7.89 //y=4.09 //x2=7.15 //y2=2.26
cc_963 ( N_noxref_4_c_978_n N_noxref_7_c_2225_n ) capacitor c=0.00362297f \
 //x=7.405 //y=1.76 //x2=7.15 //y2=2.095
cc_964 ( N_noxref_4_c_981_n N_noxref_7_c_2225_n ) capacitor c=0.00282067f \
 //x=7.89 //y=4.09 //x2=7.15 //y2=2.095
cc_965 ( N_noxref_4_c_988_n N_noxref_7_c_2226_n ) capacitor c=0.00739287f \
 //x=7.89 //y=5.25 //x2=7.15 //y2=4.88
cc_966 ( N_noxref_4_c_1119_p N_noxref_7_c_2226_n ) capacitor c=0.00203307f \
 //x=7.11 //y=5.335 //x2=7.15 //y2=4.88
cc_967 ( N_noxref_4_c_1129_p N_noxref_7_c_2226_n ) capacitor c=0.00375636f \
 //x=7.11 //y=5.56 //x2=7.15 //y2=4.88
cc_968 ( N_noxref_4_c_1068_n Q ) capacitor c=0.0727372f //x=17.88 //y=4.105 \
 //x2=18.62 //y2=2.77
cc_969 ( N_noxref_4_c_1112_p Q ) capacitor c=3.30333e-19 //x=17.88 //y=2.26 \
 //x2=18.62 //y2=2.77
cc_970 ( N_noxref_4_c_1076_n Q ) capacitor c=0.0131641f //x=17.882 //y=4.74 \
 //x2=18.62 //y2=4.62
cc_971 ( N_noxref_4_c_1096_p Q ) capacitor c=3.02466e-19 //x=17.88 //y=4.88 \
 //x2=18.62 //y2=4.62
cc_972 ( N_noxref_4_c_1099_p Q ) capacitor c=0.00108965f //x=17.88 //y=4.88 \
 //x2=18.62 //y2=4.62
cc_973 ( N_noxref_4_c_1093_p Q ) capacitor c=5.9727e-19 //x=17.88 //y=4.425 \
 //x2=18.62 //y2=4.25
cc_974 ( N_noxref_4_c_1202_p Q ) capacitor c=0.0102254f //x=17.88 //y=4.25 \
 //x2=18.62 //y2=4.25
cc_975 ( N_noxref_4_c_1093_p N_Q_c_2626_n ) capacitor c=0.0215639f //x=17.88 \
 //y=4.425 //x2=18.62 //y2=4.425
cc_976 ( N_noxref_4_c_1202_p N_Q_c_2626_n ) capacitor c=5.9727e-19 //x=17.88 \
 //y=4.25 //x2=18.62 //y2=4.425
cc_977 ( N_noxref_4_c_1095_p N_Q_c_2626_n ) capacitor c=0.00324234f //x=17.88 \
 //y=4.265 //x2=18.62 //y2=4.425
cc_978 ( N_noxref_4_c_1094_p N_Q_c_2629_n ) capacitor c=0.0172939f //x=17.88 \
 //y=4.88 //x2=18.62 //y2=4.735
cc_979 ( N_noxref_4_c_1096_p N_Q_c_2629_n ) capacitor c=4.73677e-19 //x=17.88 \
 //y=4.88 //x2=18.62 //y2=4.735
cc_980 ( N_noxref_4_c_1099_p N_Q_c_2629_n ) capacitor c=9.22067e-19 //x=17.88 \
 //y=4.88 //x2=18.62 //y2=4.735
cc_981 ( N_noxref_4_c_1110_p N_Q_c_2632_n ) capacitor c=0.0179797f //x=17.88 \
 //y=2.26 //x2=18.62 //y2=2.26
cc_982 ( N_noxref_4_c_1112_p N_Q_c_2632_n ) capacitor c=5.16867e-19 //x=17.88 \
 //y=2.26 //x2=18.62 //y2=2.26
cc_983 ( N_noxref_4_c_1211_p N_Q_c_2632_n ) capacitor c=0.00161745f //x=17.685 \
 //y=2.095 //x2=18.62 //y2=2.26
cc_984 ( N_noxref_4_c_1093_p N_Q_c_2635_n ) capacitor c=0.00324237f //x=17.88 \
 //y=4.425 //x2=18.78 //y2=4.265
cc_985 ( N_noxref_4_c_1095_p N_Q_c_2635_n ) capacitor c=0.0235424f //x=17.88 \
 //y=4.265 //x2=18.78 //y2=4.265
cc_986 ( N_noxref_4_c_1068_n N_Q_c_2637_n ) capacitor c=3.30333e-19 //x=17.88 \
 //y=4.105 //x2=18.62 //y2=2.26
cc_987 ( N_noxref_4_c_1110_p N_Q_c_2637_n ) capacitor c=5.24723e-19 //x=17.88 \
 //y=2.26 //x2=18.62 //y2=2.26
cc_988 ( N_noxref_4_c_1112_p N_Q_c_2637_n ) capacitor c=0.00485709f //x=17.88 \
 //y=2.26 //x2=18.62 //y2=2.26
cc_989 ( N_noxref_4_c_1211_p N_Q_c_2637_n ) capacitor c=0.00267961f //x=17.685 \
 //y=2.095 //x2=18.62 //y2=2.26
cc_990 ( N_noxref_4_c_1094_p N_Q_c_2641_n ) capacitor c=4.80626e-19 //x=17.88 \
 //y=4.88 //x2=18.65 //y2=4.88
cc_991 ( N_noxref_4_c_1096_p N_Q_c_2641_n ) capacitor c=0.00397338f //x=17.88 \
 //y=4.88 //x2=18.65 //y2=4.88
cc_992 ( N_noxref_4_c_1099_p N_Q_c_2641_n ) capacitor c=0.00283894f //x=17.88 \
 //y=4.88 //x2=18.65 //y2=4.88
cc_993 ( N_noxref_4_M35_noxref_g N_Q_M37_noxref_g ) capacitor c=0.0104892f \
 //x=17.78 //y=6.2 //x2=18.66 //y2=6.2
cc_994 ( N_noxref_4_M36_noxref_g N_Q_M37_noxref_g ) capacitor c=0.107636f \
 //x=18.22 //y=6.2 //x2=18.66 //y2=6.2
cc_995 ( N_noxref_4_M36_noxref_g N_Q_M38_noxref_g ) capacitor c=0.0100341f \
 //x=18.22 //y=6.2 //x2=19.1 //y2=6.2
cc_996 ( N_noxref_4_c_1224_p N_Q_c_2647_n ) capacitor c=4.86545e-19 //x=17.685 \
 //y=1.045 //x2=18.655 //y2=1.085
cc_997 ( N_noxref_4_c_1225_p N_Q_c_2647_n ) capacitor c=0.00152405f //x=17.685 \
 //y=1.39 //x2=18.655 //y2=1.085
cc_998 ( N_noxref_4_c_1226_p N_Q_c_2647_n ) capacitor c=0.0151475f //x=18.215 \
 //y=1.045 //x2=18.655 //y2=1.085
cc_999 ( N_noxref_4_c_1227_p N_Q_c_2650_n ) capacitor c=0.00109982f //x=17.685 \
 //y=1.7 //x2=18.655 //y2=1.43
cc_1000 ( N_noxref_4_c_1228_p N_Q_c_2650_n ) capacitor c=0.0111064f //x=18.215 \
 //y=1.39 //x2=18.655 //y2=1.43
cc_1001 ( N_noxref_4_c_1227_p N_Q_c_2652_n ) capacitor c=9.58243e-19 \
 //x=17.685 //y=1.7 //x2=18.655 //y2=1.74
cc_1002 ( N_noxref_4_c_1211_p N_Q_c_2652_n ) capacitor c=0.00662747f \
 //x=17.685 //y=2.095 //x2=18.655 //y2=1.74
cc_1003 ( N_noxref_4_c_1228_p N_Q_c_2652_n ) capacitor c=0.00862358f \
 //x=18.215 //y=1.39 //x2=18.655 //y2=1.74
cc_1004 ( N_noxref_4_c_1226_p N_Q_c_2655_n ) capacitor c=0.00127211f \
 //x=18.215 //y=1.045 //x2=19.185 //y2=1.085
cc_1005 ( N_noxref_4_c_1228_p N_Q_c_2656_n ) capacitor c=0.00204774f \
 //x=18.215 //y=1.39 //x2=19.185 //y2=1.43
cc_1006 ( N_noxref_4_c_1110_p N_Q_c_2657_n ) capacitor c=0.00161167f //x=17.88 \
 //y=2.26 //x2=18.62 //y2=2.26
cc_1007 ( N_noxref_4_c_1112_p N_Q_c_2657_n ) capacitor c=0.0018937f //x=17.88 \
 //y=2.26 //x2=18.62 //y2=2.26
cc_1008 ( N_noxref_4_c_1211_p N_Q_c_2657_n ) capacitor c=0.0181449f //x=17.685 \
 //y=2.095 //x2=18.62 //y2=2.26
cc_1009 ( N_noxref_4_c_1094_p N_Q_c_2660_n ) capacitor c=0.00158715f //x=17.88 \
 //y=4.88 //x2=18.65 //y2=4.88
cc_1010 ( N_noxref_4_c_1096_p N_Q_c_2660_n ) capacitor c=0.00237977f //x=17.88 \
 //y=4.88 //x2=18.65 //y2=4.88
cc_1011 ( N_noxref_4_c_1099_p N_Q_c_2660_n ) capacitor c=0.0297875f //x=17.88 \
 //y=4.88 //x2=18.65 //y2=4.88
cc_1012 ( N_noxref_4_c_976_n N_VDD_c_2903_n ) capacitor c=0.00621353f //x=6.11 \
 //y=5.335 //x2=24.17 //y2=7.58
cc_1013 ( N_noxref_4_c_1060_n N_VDD_c_2903_n ) capacitor c=0.00627192f \
 //x=6.995 //y=5.335 //x2=24.17 //y2=7.58
cc_1014 ( N_noxref_4_c_1049_n N_VDD_c_2903_n ) capacitor c=0.00256019f \
 //x=7.11 //y=5.56 //x2=24.17 //y2=7.58
cc_1015 ( N_noxref_4_c_1050_n N_VDD_c_2903_n ) capacitor c=0.00829084f \
 //x=7.805 //y=5.335 //x2=24.17 //y2=7.58
cc_1016 ( N_noxref_4_c_987_n N_VDD_c_2903_n ) capacitor c=4.85202e-19 //x=7.89 \
 //y=4.41 //x2=24.17 //y2=7.58
cc_1017 ( N_noxref_4_c_1093_p N_VDD_c_2903_n ) capacitor c=2.26187e-19 \
 //x=17.88 //y=4.425 //x2=24.17 //y2=7.58
cc_1018 ( N_noxref_4_c_991_n N_VDD_c_2903_n ) capacitor c=0.00261804f \
 //x=5.352 //y=5.335 //x2=24.17 //y2=7.58
cc_1019 ( N_noxref_4_c_1069_n N_VDD_c_2903_n ) capacitor c=0.00270108f \
 //x=6.23 //y=5.335 //x2=24.17 //y2=7.58
cc_1020 ( N_noxref_4_c_1126_p N_VDD_c_2903_n ) capacitor c=3.82513e-19 \
 //x=7.885 //y=4.25 //x2=24.17 //y2=7.58
cc_1021 ( N_noxref_4_c_1094_p N_VDD_c_2903_n ) capacitor c=9.07241e-19 \
 //x=17.88 //y=4.88 //x2=24.17 //y2=7.58
cc_1022 ( N_noxref_4_c_1014_n N_VDD_c_2903_n ) capacitor c=0.0024232f //x=5.35 \
 //y=5.56 //x2=24.17 //y2=7.58
cc_1023 ( N_noxref_4_c_1085_n N_VDD_c_2903_n ) capacitor c=0.0024232f //x=6.23 \
 //y=5.56 //x2=24.17 //y2=7.58
cc_1024 ( N_noxref_4_c_1129_p N_VDD_c_2903_n ) capacitor c=0.0024232f //x=7.11 \
 //y=5.56 //x2=24.17 //y2=7.58
cc_1025 ( N_noxref_4_c_1096_p N_VDD_c_2903_n ) capacitor c=6.22888e-19 \
 //x=17.88 //y=4.88 //x2=24.17 //y2=7.58
cc_1026 ( N_noxref_4_M17_noxref_g N_VDD_c_2913_n ) capacitor c=0.00697352f \
 //x=2.38 //y=6.2 //x2=2.955 //y2=7.585
cc_1027 ( N_noxref_4_M18_noxref_g N_VDD_c_2913_n ) capacitor c=0.00755544f \
 //x=2.82 //y=6.2 //x2=2.955 //y2=7.585
cc_1028 ( N_noxref_4_c_976_n N_VDD_c_2918_n ) capacitor c=0.00202922f //x=6.11 \
 //y=5.335 //x2=5.705 //y2=7.585
cc_1029 ( N_noxref_4_c_991_n N_VDD_c_2918_n ) capacitor c=9.3757e-19 //x=5.352 \
 //y=5.335 //x2=5.705 //y2=7.585
cc_1030 ( N_noxref_4_c_1014_n N_VDD_c_2918_n ) capacitor c=0.0138074f //x=5.35 \
 //y=5.56 //x2=5.705 //y2=7.585
cc_1031 ( N_noxref_4_c_976_n N_VDD_c_3014_n ) capacitor c=0.0017708f //x=6.11 \
 //y=5.335 //x2=6.585 //y2=7.585
cc_1032 ( N_noxref_4_c_1060_n N_VDD_c_3014_n ) capacitor c=0.00202922f \
 //x=6.995 //y=5.335 //x2=6.585 //y2=7.585
cc_1033 ( N_noxref_4_c_1069_n N_VDD_c_3014_n ) capacitor c=9.4822e-19 //x=6.23 \
 //y=5.335 //x2=6.585 //y2=7.585
cc_1034 ( N_noxref_4_c_1085_n N_VDD_c_3014_n ) capacitor c=0.0138074f //x=6.23 \
 //y=5.56 //x2=6.585 //y2=7.585
cc_1035 ( N_noxref_4_c_1060_n N_VDD_c_3053_n ) capacitor c=0.00205906f \
 //x=6.995 //y=5.335 //x2=7.465 //y2=7.585
cc_1036 ( N_noxref_4_c_1049_n N_VDD_c_3053_n ) capacitor c=8.49654e-19 \
 //x=7.11 //y=5.56 //x2=7.465 //y2=7.585
cc_1037 ( N_noxref_4_c_1050_n N_VDD_c_3053_n ) capacitor c=0.00204238f \
 //x=7.805 //y=5.335 //x2=7.465 //y2=7.585
cc_1038 ( N_noxref_4_c_1129_p N_VDD_c_3053_n ) capacitor c=0.0135103f //x=7.11 \
 //y=5.56 //x2=7.465 //y2=7.585
cc_1039 ( N_noxref_4_c_1050_n N_VDD_c_3057_n ) capacitor c=0.00157114f \
 //x=7.805 //y=5.335 //x2=8.46 //y2=7.585
cc_1040 ( N_noxref_4_c_987_n N_VDD_c_3057_n ) capacitor c=3.91238e-19 //x=7.89 \
 //y=4.41 //x2=8.46 //y2=7.585
cc_1041 ( N_noxref_4_c_1094_p N_VDD_c_3059_n ) capacitor c=6.28113e-19 \
 //x=17.88 //y=4.88 //x2=18.355 //y2=7.585
cc_1042 ( N_noxref_4_M35_noxref_g N_VDD_c_3059_n ) capacitor c=0.00732618f \
 //x=17.78 //y=6.2 //x2=18.355 //y2=7.585
cc_1043 ( N_noxref_4_M36_noxref_g N_VDD_c_3059_n ) capacitor c=0.00755544f \
 //x=18.22 //y=6.2 //x2=18.355 //y2=7.585
cc_1044 ( N_noxref_4_c_990_n N_VDD_c_2922_n ) capacitor c=9.76453e-19 //x=2.34 \
 //y=4.25 //x2=1.23 //y2=7.58
cc_1045 ( N_noxref_4_c_990_n N_VDD_c_2925_n ) capacitor c=0.00133334f //x=2.34 \
 //y=4.25 //x2=3.82 //y2=7.585
cc_1046 ( N_noxref_4_c_991_n N_VDD_c_2925_n ) capacitor c=0.0022955f //x=5.352 \
 //y=5.335 //x2=3.82 //y2=7.585
cc_1047 ( N_noxref_4_c_996_n N_VDD_c_2925_n ) capacitor c=0.0195432f //x=7.725 \
 //y=4.25 //x2=3.82 //y2=7.585
cc_1048 ( N_noxref_4_c_1012_n N_VDD_c_2925_n ) capacitor c=0.00226427f \
 //x=2.37 //y=4.88 //x2=3.82 //y2=7.585
cc_1049 ( N_noxref_4_c_1014_n N_VDD_c_2925_n ) capacitor c=0.00508013f \
 //x=5.35 //y=5.56 //x2=3.82 //y2=7.585
cc_1050 ( N_noxref_4_c_1029_n N_VDD_c_2925_n ) capacitor c=0.0129149f \
 //x=2.745 //y=4.97 //x2=3.82 //y2=7.585
cc_1051 ( N_noxref_4_c_1047_n N_VDD_c_2925_n ) capacitor c=2.73429e-19 \
 //x=2.37 //y=4.88 //x2=3.82 //y2=7.585
cc_1052 ( N_noxref_4_c_1049_n N_VDD_c_2933_n ) capacitor c=0.00282782f \
 //x=7.11 //y=5.56 //x2=8.63 //y2=7.585
cc_1053 ( N_noxref_4_c_987_n N_VDD_c_2933_n ) capacitor c=0.00177813f //x=7.89 \
 //y=4.41 //x2=8.63 //y2=7.585
cc_1054 ( N_noxref_4_c_988_n N_VDD_c_2933_n ) capacitor c=0.0293445f //x=7.89 \
 //y=5.25 //x2=8.63 //y2=7.585
cc_1055 ( N_noxref_4_c_1126_p N_VDD_c_2933_n ) capacitor c=0.00499873f \
 //x=7.885 //y=4.25 //x2=8.63 //y2=7.585
cc_1056 ( N_noxref_4_c_1009_n N_VDD_c_2933_n ) capacitor c=0.00826669f \
 //x=17.72 //y=4.265 //x2=8.63 //y2=7.585
cc_1057 ( N_noxref_4_c_1129_p N_VDD_c_2933_n ) capacitor c=0.00777981f \
 //x=7.11 //y=5.56 //x2=8.63 //y2=7.585
cc_1058 ( N_noxref_4_c_1009_n N_VDD_c_2991_n ) capacitor c=0.00885867f \
 //x=17.72 //y=4.265 //x2=13.44 //y2=7.585
cc_1059 ( N_noxref_4_c_1093_p N_VDD_c_3020_n ) capacitor c=0.00144835f \
 //x=17.88 //y=4.425 //x2=16.77 //y2=7.585
cc_1060 ( N_noxref_4_c_1202_p N_VDD_c_3020_n ) capacitor c=0.00247508f \
 //x=17.88 //y=4.25 //x2=16.77 //y2=7.585
cc_1061 ( N_noxref_4_c_1094_p N_VDD_c_3020_n ) capacitor c=0.00447349f \
 //x=17.88 //y=4.88 //x2=16.77 //y2=7.585
cc_1062 ( N_noxref_4_c_1076_n N_VDD_c_3020_n ) capacitor c=0.00506192f \
 //x=17.882 //y=4.74 //x2=16.77 //y2=7.585
cc_1063 ( N_noxref_4_c_1009_n N_VDD_c_3020_n ) capacitor c=0.0193991f \
 //x=17.72 //y=4.265 //x2=16.77 //y2=7.585
cc_1064 ( N_noxref_4_c_1096_p N_VDD_c_3020_n ) capacitor c=0.00370494f \
 //x=17.88 //y=4.88 //x2=16.77 //y2=7.585
cc_1065 ( N_noxref_4_c_1099_p N_VDD_c_3020_n ) capacitor c=0.0129564f \
 //x=17.88 //y=4.88 //x2=16.77 //y2=7.585
cc_1066 ( N_noxref_4_c_991_n N_VDD_M15_noxref_s ) capacitor c=4.22189e-19 \
 //x=5.352 //y=5.335 //x2=1.145 //y2=5.2
cc_1067 ( N_noxref_4_M17_noxref_g N_VDD_M16_noxref_d ) capacitor c=0.015318f \
 //x=2.38 //y=6.2 //x2=2.015 //y2=5.2
cc_1068 ( N_noxref_4_c_1047_n N_VDD_M16_noxref_d ) capacitor c=3.50465e-19 \
 //x=2.37 //y=4.88 //x2=2.015 //y2=5.2
cc_1069 ( N_noxref_4_M18_noxref_g N_VDD_M18_noxref_d ) capacitor c=0.0430452f \
 //x=2.82 //y=6.2 //x2=2.895 //y2=5.2
cc_1070 ( N_noxref_4_c_991_n N_VDD_M19_noxref_s ) capacitor c=0.0442713f \
 //x=5.352 //y=5.335 //x2=4.775 //y2=5.2
cc_1071 ( N_noxref_4_c_1069_n N_VDD_M19_noxref_s ) capacitor c=7.80122e-19 \
 //x=6.23 //y=5.335 //x2=4.775 //y2=5.2
cc_1072 ( N_noxref_4_c_996_n N_VDD_M19_noxref_s ) capacitor c=6.18859e-19 \
 //x=7.725 //y=4.25 //x2=4.775 //y2=5.2
cc_1073 ( N_noxref_4_c_1014_n N_VDD_M19_noxref_s ) capacitor c=0.0908457f \
 //x=5.35 //y=5.56 //x2=4.775 //y2=5.2
cc_1074 ( N_noxref_4_c_976_n N_VDD_M20_noxref_d ) capacitor c=0.00700141f \
 //x=6.11 //y=5.335 //x2=5.645 //y2=5.2
cc_1075 ( N_noxref_4_c_1014_n N_VDD_M20_noxref_d ) capacitor c=0.0673792f \
 //x=5.35 //y=5.56 //x2=5.645 //y2=5.2
cc_1076 ( N_noxref_4_c_1085_n N_VDD_M20_noxref_d ) capacitor c=0.0674762f \
 //x=6.23 //y=5.56 //x2=5.645 //y2=5.2
cc_1077 ( N_noxref_4_c_1060_n N_VDD_M22_noxref_d ) capacitor c=0.00700141f \
 //x=6.995 //y=5.335 //x2=6.525 //y2=5.2
cc_1078 ( N_noxref_4_c_1085_n N_VDD_M22_noxref_d ) capacitor c=0.067493f \
 //x=6.23 //y=5.56 //x2=6.525 //y2=5.2
cc_1079 ( N_noxref_4_c_1129_p N_VDD_M22_noxref_d ) capacitor c=0.0674979f \
 //x=7.11 //y=5.56 //x2=6.525 //y2=5.2
cc_1080 ( N_noxref_4_c_1050_n N_VDD_M24_noxref_d ) capacitor c=0.00700141f \
 //x=7.805 //y=5.335 //x2=7.405 //y2=5.2
cc_1081 ( N_noxref_4_c_1129_p N_VDD_M24_noxref_d ) capacitor c=0.0675002f \
 //x=7.11 //y=5.56 //x2=7.405 //y2=5.2
cc_1082 ( N_noxref_4_c_1049_n N_VDD_M25_noxref_s ) capacitor c=0.00492616f \
 //x=7.11 //y=5.56 //x2=9.585 //y2=5.2
cc_1083 ( N_noxref_4_c_1050_n N_VDD_M25_noxref_s ) capacitor c=9.42705e-19 \
 //x=7.805 //y=5.335 //x2=9.585 //y2=5.2
cc_1084 ( N_noxref_4_c_1069_n N_VDD_M25_noxref_s ) capacitor c=2.11884e-19 \
 //x=6.23 //y=5.335 //x2=9.585 //y2=5.2
cc_1085 ( N_noxref_4_c_1093_p N_VDD_M35_noxref_s ) capacitor c=0.00222454f \
 //x=17.88 //y=4.425 //x2=17.425 //y2=5.2
cc_1086 ( N_noxref_4_c_1009_n N_VDD_M35_noxref_s ) capacitor c=0.00509704f \
 //x=17.72 //y=4.265 //x2=17.425 //y2=5.2
cc_1087 ( N_noxref_4_M35_noxref_g N_VDD_M35_noxref_s ) capacitor c=0.0567929f \
 //x=17.78 //y=6.2 //x2=17.425 //y2=5.2
cc_1088 ( N_noxref_4_M36_noxref_g N_VDD_M36_noxref_d ) capacitor c=0.015318f \
 //x=18.22 //y=6.2 //x2=18.295 //y2=5.2
cc_1089 ( N_noxref_4_c_961_n D ) capacitor c=0.0795217f //x=2.34 //y=4.085 \
 //x2=1.6 //y2=2.77
cc_1090 ( N_noxref_4_c_968_n D ) capacitor c=0.0149195f //x=2.34 //y=4.405 \
 //x2=1.6 //y2=2.77
cc_1091 ( N_noxref_4_c_973_n D ) capacitor c=0.0146931f //x=2.34 //y=4.735 \
 //x2=1.6 //y2=2.77
cc_1092 ( N_noxref_4_c_990_n D ) capacitor c=0.00465739f //x=2.34 //y=4.25 \
 //x2=1.6 //y2=2.77
cc_1093 ( N_noxref_4_c_1006_n D ) capacitor c=0.00686827f //x=2.5 //y=4.245 \
 //x2=1.6 //y2=2.77
cc_1094 ( N_noxref_4_c_1011_n D ) capacitor c=3.49899e-19 //x=2.34 //y=2.26 \
 //x2=1.6 //y2=2.77
cc_1095 ( N_noxref_4_c_1012_n D ) capacitor c=2.1563e-19 //x=2.37 //y=4.88 \
 //x2=1.6 //y2=2.77
cc_1096 ( N_noxref_4_c_989_n N_D_c_3313_n ) capacitor c=0.0205342f //x=2.34 \
 //y=2.26 //x2=1.6 //y2=2.26
cc_1097 ( N_noxref_4_c_1011_n N_D_c_3313_n ) capacitor c=0.00370824f //x=2.34 \
 //y=2.26 //x2=1.6 //y2=2.26
cc_1098 ( N_noxref_4_c_1044_n N_D_c_3313_n ) capacitor c=0.00167305f //x=2.34 \
 //y=2.26 //x2=1.6 //y2=2.26
cc_1099 ( N_noxref_4_c_973_n N_D_c_3295_n ) capacitor c=0.0172863f //x=2.34 \
 //y=4.735 //x2=1.6 //y2=4.88
cc_1100 ( N_noxref_4_c_1012_n N_D_c_3295_n ) capacitor c=0.00389736f //x=2.37 \
 //y=4.88 //x2=1.6 //y2=4.88
cc_1101 ( N_noxref_4_c_1047_n N_D_c_3295_n ) capacitor c=0.00158715f //x=2.37 \
 //y=4.88 //x2=1.6 //y2=4.88
cc_1102 ( N_noxref_4_c_961_n N_D_c_3319_n ) capacitor c=3.49899e-19 //x=2.34 \
 //y=4.085 //x2=1.6 //y2=2.26
cc_1103 ( N_noxref_4_c_989_n N_D_c_3319_n ) capacitor c=5.16867e-19 //x=2.34 \
 //y=2.26 //x2=1.6 //y2=2.26
cc_1104 ( N_noxref_4_c_1011_n N_D_c_3319_n ) capacitor c=0.00445529f //x=2.34 \
 //y=2.26 //x2=1.6 //y2=2.26
cc_1105 ( N_noxref_4_c_1044_n N_D_c_3319_n ) capacitor c=0.00266443f //x=2.34 \
 //y=2.26 //x2=1.6 //y2=2.26
cc_1106 ( N_noxref_4_c_973_n N_D_c_3297_n ) capacitor c=7.76143e-19 //x=2.34 \
 //y=4.735 //x2=1.6 //y2=4.88
cc_1107 ( N_noxref_4_c_1012_n N_D_c_3297_n ) capacitor c=0.00397338f //x=2.37 \
 //y=4.88 //x2=1.6 //y2=4.88
cc_1108 ( N_noxref_4_c_1047_n N_D_c_3297_n ) capacitor c=0.00237977f //x=2.37 \
 //y=4.88 //x2=1.6 //y2=4.88
cc_1109 ( N_noxref_4_M17_noxref_g N_D_M15_noxref_g ) capacitor c=0.0104892f \
 //x=2.38 //y=6.2 //x2=1.5 //y2=6.2
cc_1110 ( N_noxref_4_M17_noxref_g N_D_M16_noxref_g ) capacitor c=0.107636f \
 //x=2.38 //y=6.2 //x2=1.94 //y2=6.2
cc_1111 ( N_noxref_4_M18_noxref_g N_D_M16_noxref_g ) capacitor c=0.0100341f \
 //x=2.82 //y=6.2 //x2=1.94 //y2=6.2
cc_1112 ( N_noxref_4_c_1023_n N_D_c_3329_n ) capacitor c=4.86545e-19 //x=2.375 \
 //y=1.085 //x2=1.405 //y2=1.045
cc_1113 ( N_noxref_4_c_1023_n N_D_c_3330_n ) capacitor c=0.00152405f //x=2.375 \
 //y=1.085 //x2=1.405 //y2=1.39
cc_1114 ( N_noxref_4_c_1025_n N_D_c_3331_n ) capacitor c=0.00109982f //x=2.375 \
 //y=1.43 //x2=1.405 //y2=1.7
cc_1115 ( N_noxref_4_c_1028_n N_D_c_3331_n ) capacitor c=9.58243e-19 //x=2.375 \
 //y=1.74 //x2=1.405 //y2=1.7
cc_1116 ( N_noxref_4_c_989_n N_D_c_3333_n ) capacitor c=0.00167888f //x=2.34 \
 //y=2.26 //x2=1.405 //y2=2.095
cc_1117 ( N_noxref_4_c_1011_n N_D_c_3333_n ) capacitor c=0.00267961f //x=2.34 \
 //y=2.26 //x2=1.405 //y2=2.095
cc_1118 ( N_noxref_4_c_1028_n N_D_c_3333_n ) capacitor c=0.00662747f //x=2.375 \
 //y=1.74 //x2=1.405 //y2=2.095
cc_1119 ( N_noxref_4_c_1044_n N_D_c_3333_n ) capacitor c=0.0181449f //x=2.34 \
 //y=2.26 //x2=1.405 //y2=2.095
cc_1120 ( N_noxref_4_c_1023_n N_D_c_3337_n ) capacitor c=0.0151475f //x=2.375 \
 //y=1.085 //x2=1.935 //y2=1.045
cc_1121 ( N_noxref_4_c_1038_n N_D_c_3337_n ) capacitor c=0.00127211f //x=2.905 \
 //y=1.085 //x2=1.935 //y2=1.045
cc_1122 ( N_noxref_4_c_1025_n N_D_c_3339_n ) capacitor c=0.0111064f //x=2.375 \
 //y=1.43 //x2=1.935 //y2=1.39
cc_1123 ( N_noxref_4_c_1028_n N_D_c_3339_n ) capacitor c=0.00862358f //x=2.375 \
 //y=1.74 //x2=1.935 //y2=1.39
cc_1124 ( N_noxref_4_c_1040_n N_D_c_3339_n ) capacitor c=0.00204774f //x=2.905 \
 //y=1.43 //x2=1.935 //y2=1.39
cc_1125 ( N_noxref_4_c_973_n N_D_c_3304_n ) capacitor c=0.00201171f //x=2.34 \
 //y=4.735 //x2=1.6 //y2=4.88
cc_1126 ( N_noxref_4_c_1012_n N_D_c_3304_n ) capacitor c=0.00283894f //x=2.37 \
 //y=4.88 //x2=1.6 //y2=4.88
cc_1127 ( N_noxref_4_c_1047_n N_D_c_3304_n ) capacitor c=0.0297875f //x=2.37 \
 //y=4.88 //x2=1.6 //y2=4.88
cc_1128 ( N_noxref_4_c_977_n N_noxref_11_c_3394_n ) capacitor c=0.0036878f \
 //x=7.405 //y=1.305 //x2=7.805 //y2=0.72
cc_1129 ( N_noxref_4_c_1051_n N_noxref_11_c_3394_n ) capacitor c=0.00399931f \
 //x=7.805 //y=1.845 //x2=7.805 //y2=0.72
cc_1130 ( N_noxref_4_M4_noxref_d N_noxref_11_c_3394_n ) capacitor \
 c=0.00910163f //x=7.215 //y=1.095 //x2=7.805 //y2=0.72
cc_1131 ( N_noxref_4_M4_noxref_d N_noxref_11_c_3416_n ) capacitor \
 c=0.00120711f //x=7.215 //y=1.095 //x2=6.92 //y2=1.175
cc_1132 ( N_noxref_4_c_976_n N_noxref_11_M3_noxref_d ) capacitor c=0.00148661f \
 //x=6.11 //y=5.335 //x2=5.68 //y2=1.09
cc_1133 ( N_noxref_4_c_977_n N_noxref_11_M3_noxref_d ) capacitor c=0.00802417f \
 //x=7.405 //y=1.305 //x2=5.68 //y2=1.09
cc_1134 ( N_noxref_4_c_977_n N_noxref_11_M4_noxref_s ) capacitor c=0.0098487f \
 //x=7.405 //y=1.305 //x2=6.785 //y2=0.555
cc_1135 ( N_noxref_4_c_978_n N_noxref_11_M4_noxref_s ) capacitor c=0.0283111f \
 //x=7.405 //y=1.76 //x2=6.785 //y2=0.555
cc_1136 ( N_noxref_4_c_1051_n N_noxref_11_M4_noxref_s ) capacitor \
 c=0.00946155f //x=7.805 //y=1.845 //x2=6.785 //y2=0.555
cc_1137 ( N_noxref_4_c_1126_p N_noxref_11_M4_noxref_s ) capacitor \
 c=0.00104339f //x=7.885 //y=4.25 //x2=6.785 //y2=0.555
cc_1138 ( N_noxref_4_M4_noxref_d N_noxref_11_M4_noxref_s ) capacitor \
 c=0.0279003f //x=7.215 //y=1.095 //x2=6.785 //y2=0.555
cc_1139 ( N_noxref_4_c_977_n N_noxref_12_M6_noxref_d ) capacitor c=3.20746e-19 \
 //x=7.405 //y=1.305 //x2=10.49 //y2=1.09
cc_1140 ( N_noxref_4_c_989_n N_GND_c_3532_n ) capacitor c=0.00234561f //x=2.34 \
 //y=2.26 //x2=4.81 //y2=0.175
cc_1141 ( N_noxref_4_c_977_n N_GND_c_3651_n ) capacitor c=0.00901861f \
 //x=7.405 //y=1.305 //x2=9.62 //y2=0.175
cc_1142 ( N_noxref_4_c_1051_n N_GND_c_3651_n ) capacitor c=0.00713666f \
 //x=7.805 //y=1.845 //x2=9.62 //y2=0.175
cc_1143 ( N_noxref_4_c_987_n N_GND_c_3651_n ) capacitor c=4.45324e-19 //x=7.89 \
 //y=4.41 //x2=9.62 //y2=0.175
cc_1144 ( N_noxref_4_M4_noxref_d N_GND_c_3651_n ) capacitor c=2.9462e-19 \
 //x=7.215 //y=1.095 //x2=9.62 //y2=0.175
cc_1145 ( N_noxref_4_c_977_n N_GND_c_3557_n ) capacitor c=0.00543195f \
 //x=7.405 //y=1.305 //x2=9.705 //y2=1.145
cc_1146 ( N_noxref_4_c_1110_p N_GND_c_3663_n ) capacitor c=0.00644213f \
 //x=17.88 //y=2.26 //x2=17.95 //y2=1.135
cc_1147 ( N_noxref_4_c_1112_p N_GND_c_3663_n ) capacitor c=2.13705e-19 \
 //x=17.88 //y=2.26 //x2=17.95 //y2=1.135
cc_1148 ( N_noxref_4_c_1224_p N_GND_c_3663_n ) capacitor c=0.00171023f \
 //x=17.685 //y=1.045 //x2=17.95 //y2=1.135
cc_1149 ( N_noxref_4_c_1225_p N_GND_c_3663_n ) capacitor c=0.00357815f \
 //x=17.685 //y=1.39 //x2=17.95 //y2=1.135
cc_1150 ( N_noxref_4_c_1227_p N_GND_c_3663_n ) capacitor c=4.2764e-19 \
 //x=17.685 //y=1.7 //x2=17.95 //y2=1.135
cc_1151 ( N_noxref_4_c_1379_p N_GND_c_3663_n ) capacitor c=9.36995e-19 \
 //x=18.06 //y=0.89 //x2=17.95 //y2=1.135
cc_1152 ( N_noxref_4_c_1380_p N_GND_c_3663_n ) capacitor c=6.33567e-19 \
 //x=18.06 //y=1.545 //x2=17.95 //y2=1.135
cc_1153 ( N_noxref_4_c_1226_p N_GND_c_3663_n ) capacitor c=0.00171483f \
 //x=18.215 //y=1.045 //x2=17.95 //y2=1.135
cc_1154 ( N_noxref_4_c_1228_p N_GND_c_3663_n ) capacitor c=0.00296337f \
 //x=18.215 //y=1.39 //x2=17.95 //y2=1.135
cc_1155 ( N_noxref_4_c_1224_p N_GND_c_3672_n ) capacitor c=3.46594e-19 \
 //x=17.685 //y=1.045 //x2=17.947 //y2=1.005
cc_1156 ( N_noxref_4_c_1379_p N_GND_c_3672_n ) capacitor c=0.00838576f \
 //x=18.06 //y=0.89 //x2=17.947 //y2=1.005
cc_1157 ( N_noxref_4_c_1226_p N_GND_c_3672_n ) capacitor c=4.40196e-19 \
 //x=18.215 //y=1.045 //x2=17.947 //y2=1.005
cc_1158 ( N_noxref_4_c_989_n N_GND_c_3568_n ) capacitor c=3.77328e-19 //x=2.34 \
 //y=2.26 //x2=3.65 //y2=0.175
cc_1159 ( N_noxref_4_c_1051_n N_GND_c_3572_n ) capacitor c=6.86343e-19 \
 //x=7.805 //y=1.845 //x2=8.46 //y2=0.175
cc_1160 ( N_noxref_4_c_1224_p N_GND_c_3677_n ) capacitor c=0.00688027f \
 //x=17.685 //y=1.045 //x2=19.93 //y2=0.175
cc_1161 ( N_noxref_4_c_996_n N_GND_c_3574_n ) capacitor c=0.00224398f \
 //x=7.725 //y=4.25 //x2=3.82 //y2=0.175
cc_1162 ( N_noxref_4_c_1011_n N_GND_c_3574_n ) capacitor c=0.00224736f \
 //x=2.34 //y=2.26 //x2=3.82 //y2=0.175
cc_1163 ( N_noxref_4_c_1040_n N_GND_c_3574_n ) capacitor c=0.00275184f \
 //x=2.905 //y=1.43 //x2=3.82 //y2=0.175
cc_1164 ( N_noxref_4_c_1044_n N_GND_c_3574_n ) capacitor c=2.63786e-19 \
 //x=2.34 //y=2.26 //x2=3.82 //y2=0.175
cc_1165 ( N_noxref_4_c_978_n N_GND_c_3586_n ) capacitor c=0.0045138f //x=7.405 \
 //y=1.76 //x2=8.63 //y2=0.175
cc_1166 ( N_noxref_4_c_1051_n N_GND_c_3586_n ) capacitor c=0.0316807f \
 //x=7.805 //y=1.845 //x2=8.63 //y2=0.175
cc_1167 ( N_noxref_4_c_1068_n N_GND_c_3643_n ) capacitor c=0.00781993f \
 //x=17.88 //y=4.105 //x2=16.77 //y2=0.175
cc_1168 ( N_noxref_4_c_1110_p N_GND_c_3643_n ) capacitor c=0.00351582f \
 //x=17.88 //y=2.26 //x2=16.77 //y2=0.175
cc_1169 ( N_noxref_4_c_1112_p N_GND_c_3643_n ) capacitor c=0.00371068f \
 //x=17.88 //y=2.26 //x2=16.77 //y2=0.175
cc_1170 ( N_noxref_4_c_1227_p N_GND_c_3643_n ) capacitor c=0.0015404f \
 //x=17.685 //y=1.7 //x2=16.77 //y2=0.175
cc_1171 ( N_noxref_4_c_1211_p N_GND_c_3643_n ) capacitor c=0.00936534f \
 //x=17.685 //y=2.095 //x2=16.77 //y2=0.175
cc_1172 ( N_noxref_4_c_1110_p N_GND_M10_noxref_d ) capacitor c=2.20438e-19 \
 //x=17.88 //y=2.26 //x2=17.76 //y2=1.045
cc_1173 ( N_noxref_4_c_1224_p N_GND_M10_noxref_d ) capacitor c=0.00192399f \
 //x=17.685 //y=1.045 //x2=17.76 //y2=1.045
cc_1174 ( N_noxref_4_c_1225_p N_GND_M10_noxref_d ) capacitor c=0.00210798f \
 //x=17.685 //y=1.39 //x2=17.76 //y2=1.045
cc_1175 ( N_noxref_4_c_1379_p N_GND_M10_noxref_d ) capacitor c=0.00472259f \
 //x=18.06 //y=0.89 //x2=17.76 //y2=1.045
cc_1176 ( N_noxref_4_c_1380_p N_GND_M10_noxref_d ) capacitor c=0.00166857f \
 //x=18.06 //y=1.545 //x2=17.76 //y2=1.045
cc_1177 ( N_noxref_4_c_1226_p N_GND_M10_noxref_d ) capacitor c=0.00230174f \
 //x=18.215 //y=1.045 //x2=17.76 //y2=1.045
cc_1178 ( N_noxref_4_c_1228_p N_GND_M10_noxref_d ) capacitor c=0.00210798f \
 //x=18.215 //y=1.39 //x2=17.76 //y2=1.045
cc_1179 ( N_noxref_4_c_968_n N_noxref_15_c_4064_n ) capacitor c=2.69284e-19 \
 //x=2.34 //y=4.405 //x2=2.155 //y2=1.675
cc_1180 ( N_noxref_4_c_989_n N_noxref_15_c_4064_n ) capacitor c=7.50092e-19 \
 //x=2.34 //y=2.26 //x2=2.155 //y2=1.675
cc_1181 ( N_noxref_4_c_1028_n N_noxref_15_c_4064_n ) capacitor c=0.00888238f \
 //x=2.375 //y=1.74 //x2=2.155 //y2=1.675
cc_1182 ( N_noxref_4_c_1044_n N_noxref_15_c_4064_n ) capacitor c=0.00175171f \
 //x=2.34 //y=2.26 //x2=2.155 //y2=1.675
cc_1183 ( N_noxref_4_c_989_n N_noxref_15_c_4065_n ) capacitor c=0.001463f \
 //x=2.34 //y=2.26 //x2=3.04 //y2=0.71
cc_1184 ( N_noxref_4_c_1011_n N_noxref_15_c_4065_n ) capacitor c=8.82141e-19 \
 //x=2.34 //y=2.26 //x2=3.04 //y2=0.71
cc_1185 ( N_noxref_4_c_1023_n N_noxref_15_c_4065_n ) capacitor c=0.0200262f \
 //x=2.375 //y=1.085 //x2=3.04 //y2=0.71
cc_1186 ( N_noxref_4_c_1038_n N_noxref_15_c_4065_n ) capacitor c=0.00825432f \
 //x=2.905 //y=1.085 //x2=3.04 //y2=0.71
cc_1187 ( N_noxref_4_c_1044_n N_noxref_15_c_4065_n ) capacitor c=2.1838e-19 \
 //x=2.34 //y=2.26 //x2=3.04 //y2=0.71
cc_1188 ( N_noxref_4_c_1023_n N_noxref_15_M0_noxref_s ) capacitor \
 c=0.00888238f //x=2.375 //y=1.085 //x2=1.05 //y2=0.545
cc_1189 ( N_noxref_4_c_1038_n N_noxref_15_M0_noxref_s ) capacitor c=0.015333f \
 //x=2.905 //y=1.085 //x2=1.05 //y2=0.545
cc_1190 ( N_noxref_4_c_1040_n N_noxref_15_M0_noxref_s ) capacitor \
 c=0.00248746f //x=2.905 //y=1.43 //x2=1.05 //y2=0.545
cc_1191 ( N_noxref_4_c_1211_p N_noxref_19_c_4311_n ) capacitor c=0.00262672f \
 //x=17.685 //y=2.095 //x2=17.465 //y2=1.675
cc_1192 ( N_noxref_4_c_1093_p N_noxref_19_c_4312_n ) capacitor c=0.00330249f \
 //x=17.88 //y=4.425 //x2=18.35 //y2=1.76
cc_1193 ( N_noxref_4_c_1110_p N_noxref_19_c_4312_n ) capacitor c=0.00509504f \
 //x=17.88 //y=2.26 //x2=18.35 //y2=1.76
cc_1194 ( N_noxref_4_c_1112_p N_noxref_19_c_4312_n ) capacitor c=0.00763108f \
 //x=17.88 //y=2.26 //x2=18.35 //y2=1.76
cc_1195 ( N_noxref_4_c_1227_p N_noxref_19_c_4312_n ) capacitor c=0.00697076f \
 //x=17.685 //y=1.7 //x2=18.35 //y2=1.76
cc_1196 ( N_noxref_4_c_1211_p N_noxref_19_c_4312_n ) capacitor c=0.0170561f \
 //x=17.685 //y=2.095 //x2=18.35 //y2=1.76
cc_1197 ( N_noxref_4_c_1380_p N_noxref_19_c_4312_n ) capacitor c=0.00723574f \
 //x=18.06 //y=1.545 //x2=18.35 //y2=1.76
cc_1198 ( N_noxref_4_c_1228_p N_noxref_19_c_4312_n ) capacitor c=0.00339872f \
 //x=18.215 //y=1.39 //x2=18.35 //y2=1.76
cc_1199 ( N_noxref_4_c_1211_p N_noxref_19_c_4319_n ) capacitor c=6.71402e-19 \
 //x=17.685 //y=2.095 //x2=18.435 //y2=1.675
cc_1200 ( N_noxref_4_c_1224_p N_noxref_19_M10_noxref_s ) capacitor \
 c=0.0294925f //x=17.685 //y=1.045 //x2=17.33 //y2=0.545
cc_1201 ( N_noxref_4_c_1227_p N_noxref_19_M10_noxref_s ) capacitor \
 c=3.48408e-19 //x=17.685 //y=1.7 //x2=17.33 //y2=0.545
cc_1202 ( N_noxref_4_c_1226_p N_noxref_19_M10_noxref_s ) capacitor \
 c=0.0125442f //x=18.215 //y=1.045 //x2=17.33 //y2=0.545
cc_1203 ( QN SN ) capacitor c=9.81386e-19 //x=19.36 //y=2.77 //x2=22.32 \
 //y2=2.77
cc_1204 ( QN SN ) capacitor c=0.00147174f //x=19.36 //y=3.51 //x2=22.32 \
 //y2=2.77
cc_1205 ( QN SN ) capacitor c=0.0131366f //x=21.21 //y=2.77 //x2=22.32 //y2=2.77
cc_1206 ( QN SN ) capacitor c=0.0388869f //x=21.21 //y=3.51 //x2=22.32 //y2=2.77
cc_1207 ( QN SN ) capacitor c=2.98349e-19 //x=21.21 //y=3.14 //x2=22.32 \
 //y2=2.77
cc_1208 ( N_QN_c_1453_p SN ) capacitor c=0.00775314f //x=21.21 //y=3.295 \
 //x2=22.32 //y2=2.77
cc_1209 ( N_QN_c_1454_p SN ) capacitor c=4.22428e-19 //x=21.21 //y=4.755 \
 //x2=22.32 //y2=2.77
cc_1210 ( N_QN_c_1455_p SN ) capacitor c=0.00508571f //x=21.21 //y=3.135 \
 //x2=22.32 //y2=2.77
cc_1211 ( N_QN_c_1456_p SN ) capacitor c=3.36194e-19 //x=21.21 //y=4.88 \
 //x2=22.32 //y2=2.77
cc_1212 ( QN N_SN_c_1799_n ) capacitor c=0.00346868f //x=21.21 //y=2.77 \
 //x2=22.32 //y2=2.55
cc_1213 ( N_QN_c_1458_p N_SN_c_1799_n ) capacitor c=0.00802132f //x=21.21 \
 //y=2.375 //x2=22.32 //y2=2.55
cc_1214 ( N_QN_c_1459_p N_SN_c_1799_n ) capacitor c=0.00117245f //x=21.21 \
 //y=2.26 //x2=22.32 //y2=2.55
cc_1215 ( N_QN_c_1460_p N_SN_c_1799_n ) capacitor c=0.00157323f //x=20.91 \
 //y=2.095 //x2=22.32 //y2=2.55
cc_1216 ( N_QN_c_1454_p N_SN_c_1803_n ) capacitor c=0.0110307f //x=21.21 \
 //y=4.755 //x2=22.32 //y2=4.765
cc_1217 ( N_QN_c_1456_p N_SN_c_1803_n ) capacitor c=2.89813e-19 //x=21.21 \
 //y=4.88 //x2=22.32 //y2=4.765
cc_1218 ( N_QN_c_1463_p N_SN_c_1803_n ) capacitor c=7.66769e-19 //x=21.775 \
 //y=4.97 //x2=22.32 //y2=4.765
cc_1219 ( N_QN_c_1464_p N_SN_c_1803_n ) capacitor c=7.54501e-19 //x=21.485 \
 //y=4.97 //x2=22.32 //y2=4.765
cc_1220 ( QN N_SN_c_1807_n ) capacitor c=0.00105803f //x=21.21 //y=2.77 \
 //x2=22.31 //y2=2.39
cc_1221 ( N_QN_c_1458_p N_SN_c_1807_n ) capacitor c=0.00196004f //x=21.21 \
 //y=2.375 //x2=22.31 //y2=2.39
cc_1222 ( QN N_SN_c_1757_n ) capacitor c=0.030448f //x=19.36 //y=2.77 \
 //x2=22.15 //y2=2.39
cc_1223 ( QN N_SN_c_1757_n ) capacitor c=0.0164197f //x=21.21 //y=2.77 \
 //x2=22.15 //y2=2.39
cc_1224 ( N_QN_c_1469_p N_SN_c_1757_n ) capacitor c=0.0191268f //x=19.005 \
 //y=1.835 //x2=22.15 //y2=2.39
cc_1225 ( N_QN_c_1470_p N_SN_c_1757_n ) capacitor c=0.00451062f //x=19.36 \
 //y=3.31 //x2=22.15 //y2=2.39
cc_1226 ( N_QN_c_1458_p N_SN_c_1757_n ) capacitor c=0.0161111f //x=21.21 \
 //y=2.375 //x2=22.15 //y2=2.39
cc_1227 ( N_QN_c_1453_p N_SN_c_1757_n ) capacitor c=0.00411603f //x=21.21 \
 //y=3.295 //x2=22.15 //y2=2.39
cc_1228 ( N_QN_c_1473_p N_SN_c_1757_n ) capacitor c=7.47115e-19 //x=18.92 \
 //y=1.18 //x2=22.15 //y2=2.39
cc_1229 ( N_QN_c_1474_p N_SN_c_1757_n ) capacitor c=0.0154144f //x=19.52 \
 //y=3.15 //x2=22.15 //y2=2.39
cc_1230 ( N_QN_c_1455_p N_SN_c_1757_n ) capacitor c=0.0162267f //x=21.21 \
 //y=3.135 //x2=22.15 //y2=2.39
cc_1231 ( N_QN_c_1476_p N_SN_c_1757_n ) capacitor c=0.0708918f //x=21.05 \
 //y=3.135 //x2=22.15 //y2=2.39
cc_1232 ( N_QN_c_1459_p N_SN_c_1757_n ) capacitor c=2.54369e-19 //x=21.21 \
 //y=2.26 //x2=22.15 //y2=2.39
cc_1233 ( N_QN_c_1458_p N_SN_c_1820_n ) capacitor c=5.39999e-19 //x=21.21 \
 //y=2.375 //x2=22.32 //y2=2.26
cc_1234 ( N_QN_c_1459_p N_SN_c_1820_n ) capacitor c=0.00124905f //x=21.21 \
 //y=2.26 //x2=22.32 //y2=2.26
cc_1235 ( N_QN_c_1460_p N_SN_c_1820_n ) capacitor c=0.00214501f //x=20.91 \
 //y=2.095 //x2=22.32 //y2=2.26
cc_1236 ( QN N_SN_c_1823_n ) capacitor c=3.30718e-19 //x=21.21 //y=3.51 \
 //x2=22.32 //y2=4.88
cc_1237 ( N_QN_c_1454_p N_SN_c_1823_n ) capacitor c=7.03272e-19 //x=21.21 \
 //y=4.755 //x2=22.32 //y2=4.88
cc_1238 ( N_QN_c_1456_p N_SN_c_1823_n ) capacitor c=0.00113984f //x=21.21 \
 //y=4.88 //x2=22.32 //y2=4.88
cc_1239 ( N_QN_c_1463_p N_SN_c_1823_n ) capacitor c=0.00116563f //x=21.775 \
 //y=4.97 //x2=22.32 //y2=4.88
cc_1240 ( N_QN_c_1464_p N_SN_c_1823_n ) capacitor c=0.00129812f //x=21.485 \
 //y=4.97 //x2=22.32 //y2=4.88
cc_1241 ( N_QN_M39_noxref_g N_SN_M41_noxref_g ) capacitor c=0.0106276f \
 //x=21.41 //y=6.2 //x2=22.29 //y2=6.2
cc_1242 ( N_QN_M40_noxref_g N_SN_M41_noxref_g ) capacitor c=0.107144f \
 //x=21.85 //y=6.2 //x2=22.29 //y2=6.2
cc_1243 ( N_QN_M40_noxref_g N_SN_M42_noxref_g ) capacitor c=0.0101598f \
 //x=21.85 //y=6.2 //x2=22.73 //y2=6.2
cc_1244 ( N_QN_c_1489_p N_SN_c_1831_n ) capacitor c=5.72528e-19 //x=20.91 \
 //y=1.055 //x2=21.885 //y2=1.09
cc_1245 ( N_QN_c_1490_p N_SN_c_1831_n ) capacitor c=0.00150277f //x=20.91 \
 //y=1.4 //x2=21.885 //y2=1.09
cc_1246 ( N_QN_c_1491_p N_SN_c_1831_n ) capacitor c=0.0160123f //x=21.44 \
 //y=1.055 //x2=21.885 //y2=1.09
cc_1247 ( N_QN_c_1492_p N_SN_c_1834_n ) capacitor c=0.00111227f //x=20.91 \
 //y=1.71 //x2=21.885 //y2=1.4
cc_1248 ( N_QN_c_1493_p N_SN_c_1834_n ) capacitor c=0.0124075f //x=21.44 \
 //y=1.4 //x2=21.885 //y2=1.4
cc_1249 ( N_QN_c_1491_p N_SN_c_1836_n ) capacitor c=9.19165e-19 //x=21.44 \
 //y=1.055 //x2=22.41 //y2=1.09
cc_1250 ( N_QN_c_1493_p N_SN_c_1837_n ) capacitor c=0.0010154f //x=21.44 \
 //y=1.4 //x2=22.41 //y2=1.4
cc_1251 ( N_QN_c_1493_p N_SN_c_1838_n ) capacitor c=9.23422e-19 //x=21.44 \
 //y=1.4 //x2=22.41 //y2=1.63
cc_1252 ( N_QN_c_1458_p N_SN_c_1839_n ) capacitor c=5.616e-19 //x=21.21 \
 //y=2.375 //x2=22.41 //y2=2.095
cc_1253 ( N_QN_c_1459_p N_SN_c_1839_n ) capacitor c=0.0017273f //x=21.21 \
 //y=2.26 //x2=22.41 //y2=2.095
cc_1254 ( N_QN_c_1460_p N_SN_c_1839_n ) capacitor c=0.00880777f //x=20.91 \
 //y=2.095 //x2=22.41 //y2=2.095
cc_1255 ( N_QN_c_1454_p N_SN_c_1842_n ) capacitor c=0.00116212f //x=21.21 \
 //y=4.755 //x2=22.32 //y2=4.88
cc_1256 ( N_QN_c_1456_p N_SN_c_1842_n ) capacitor c=0.00155973f //x=21.21 \
 //y=4.88 //x2=22.32 //y2=4.88
cc_1257 ( N_QN_c_1463_p N_SN_c_1842_n ) capacitor c=0.0171374f //x=21.775 \
 //y=4.97 //x2=22.32 //y2=4.88
cc_1258 ( N_QN_c_1464_p N_SN_c_1842_n ) capacitor c=0.00484466f //x=21.485 \
 //y=4.97 //x2=22.32 //y2=4.88
cc_1259 ( N_QN_c_1504_p N_noxref_7_c_2082_n ) capacitor c=0.00324213f \
 //x=18.92 //y=1.75 //x2=15.59 //y2=1.75
cc_1260 ( N_QN_c_1435_n N_noxref_7_c_2169_n ) capacitor c=0.00114153f //x=18 \
 //y=5.56 //x2=15.945 //y2=5.38
cc_1261 ( N_QN_c_1469_p N_noxref_7_c_2170_n ) capacitor c=0.00231467f \
 //x=19.005 //y=1.835 //x2=15.945 //y2=1.835
cc_1262 ( QN N_noxref_7_c_2084_n ) capacitor c=0.00204244f //x=19.36 //y=2.77 \
 //x2=16.03 //y2=3.705
cc_1263 ( QN N_noxref_7_c_2087_n ) capacitor c=0.00281705f //x=19.36 //y=3.51 \
 //x2=16.03 //y2=5.295
cc_1264 ( QN N_noxref_7_c_2324_n ) capacitor c=0.00112568f //x=21.21 //y=2.77 \
 //x2=23.43 //y2=3.725
cc_1265 ( QN N_noxref_7_c_2324_n ) capacitor c=4.04915e-19 //x=21.21 //y=3.51 \
 //x2=23.43 //y2=3.725
cc_1266 ( QN N_noxref_7_c_2326_n ) capacitor c=0.00110675f //x=21.21 //y=3.51 \
 //x2=23.43 //y2=4.75
cc_1267 ( N_QN_c_1435_n N_noxref_7_c_2186_n ) capacitor c=5.29822e-19 //x=18 \
 //y=5.56 //x2=15.55 //y2=5.38
cc_1268 ( N_QN_c_1435_n N_noxref_7_c_2328_n ) capacitor c=0.00147119f //x=18 \
 //y=5.56 //x2=15.55 //y2=5.56
cc_1269 ( N_QN_c_1473_p N_noxref_7_c_2098_n ) capacitor c=6.99317e-19 \
 //x=18.92 //y=1.18 //x2=15.59 //y2=1.18
cc_1270 ( QN N_noxref_7_c_2280_n ) capacitor c=0.0255048f //x=19.36 //y=3.51 \
 //x2=23.27 //y2=3.885
cc_1271 ( QN N_noxref_7_c_2280_n ) capacitor c=0.027036f //x=21.21 //y=3.51 \
 //x2=23.27 //y2=3.885
cc_1272 ( N_QN_c_1470_p N_noxref_7_c_2280_n ) capacitor c=0.00531946f \
 //x=19.36 //y=3.31 //x2=23.27 //y2=3.885
cc_1273 ( N_QN_c_1453_p N_noxref_7_c_2280_n ) capacitor c=0.00364933f \
 //x=21.21 //y=3.295 //x2=23.27 //y2=3.885
cc_1274 ( N_QN_c_1435_n N_noxref_7_c_2280_n ) capacitor c=0.0129173f //x=18 \
 //y=5.56 //x2=23.27 //y2=3.885
cc_1275 ( N_QN_c_1474_p N_noxref_7_c_2280_n ) capacitor c=0.0159451f //x=19.52 \
 //y=3.15 //x2=23.27 //y2=3.885
cc_1276 ( N_QN_c_1455_p N_noxref_7_c_2280_n ) capacitor c=0.0154849f //x=21.21 \
 //y=3.135 //x2=23.27 //y2=3.885
cc_1277 ( N_QN_c_1476_p N_noxref_7_c_2280_n ) capacitor c=0.0682129f //x=21.05 \
 //y=3.135 //x2=23.27 //y2=3.885
cc_1278 ( QN Q ) capacitor c=0.0243881f //x=19.36 //y=2.77 //x2=18.62 //y2=2.77
cc_1279 ( QN Q ) capacitor c=0.0344874f //x=19.36 //y=3.51 //x2=18.62 //y2=2.77
cc_1280 ( QN Q ) capacitor c=0.00151557f //x=21.21 //y=2.77 //x2=18.62 //y2=2.77
cc_1281 ( QN Q ) capacitor c=6.79958e-19 //x=21.21 //y=3.51 //x2=18.62 //y2=2.77
cc_1282 ( QN Q ) capacitor c=6.92515e-19 //x=19.36 //y=3.14 //x2=18.62 //y2=2.77
cc_1283 ( N_QN_c_1470_p Q ) capacitor c=0.0148575f //x=19.36 //y=3.31 \
 //x2=18.62 //y2=2.77
cc_1284 ( N_QN_c_1474_p Q ) capacitor c=0.00692202f //x=19.52 //y=3.15 \
 //x2=18.62 //y2=2.77
cc_1285 ( QN Q ) capacitor c=0.01289f //x=19.36 //y=3.51 //x2=18.62 //y2=4.62
cc_1286 ( QN Q ) capacitor c=0.00100316f //x=21.21 //y=3.51 //x2=18.62 //y2=4.62
cc_1287 ( QN Q ) capacitor c=7.6985e-19 //x=19.36 //y=3.51 //x2=18.62 //y2=4.25
cc_1288 ( QN N_Q_c_2626_n ) capacitor c=0.0176089f //x=19.36 //y=3.51 \
 //x2=18.62 //y2=4.425
cc_1289 ( N_QN_c_1434_n N_Q_c_2626_n ) capacitor c=0.0022436f //x=18.765 \
 //y=5.38 //x2=18.62 //y2=4.425
cc_1290 ( N_QN_c_1469_p N_Q_c_2626_n ) capacitor c=3.54885e-19 //x=19.005 \
 //y=1.835 //x2=18.62 //y2=4.425
cc_1291 ( N_QN_c_1536_p N_Q_c_2626_n ) capacitor c=0.00245839f //x=18.88 \
 //y=5.38 //x2=18.62 //y2=4.425
cc_1292 ( N_QN_c_1537_p N_Q_c_2626_n ) capacitor c=8.00244e-19 //x=18.88 \
 //y=5.56 //x2=18.62 //y2=4.425
cc_1293 ( QN N_Q_c_2629_n ) capacitor c=0.016905f //x=19.36 //y=3.51 \
 //x2=18.62 //y2=4.735
cc_1294 ( N_QN_c_1434_n N_Q_c_2629_n ) capacitor c=0.0222361f //x=18.765 \
 //y=5.38 //x2=18.62 //y2=4.735
cc_1295 ( N_QN_M40_noxref_g N_Q_c_2680_n ) capacitor c=0.00973141f //x=21.85 \
 //y=6.2 //x2=22.39 //y2=5.335
cc_1296 ( N_QN_c_1541_p N_Q_c_2681_n ) capacitor c=8.09327e-19 //x=19.275 \
 //y=1.835 //x2=23.685 //y2=1.76
cc_1297 ( QN N_Q_c_2682_n ) capacitor c=8.09327e-19 //x=19.36 //y=2.77 \
 //x2=23.77 //y2=1.845
cc_1298 ( QN N_Q_c_2632_n ) capacitor c=0.0138368f //x=19.36 //y=2.77 \
 //x2=18.62 //y2=2.26
cc_1299 ( QN N_Q_c_2684_n ) capacitor c=0.00261914f //x=19.36 //y=3.51 \
 //x2=21.632 //y2=5.335
cc_1300 ( N_QN_c_1536_p N_Q_c_2684_n ) capacitor c=5.0812e-19 //x=18.88 \
 //y=5.38 //x2=21.632 //y2=5.335
cc_1301 ( N_QN_M39_noxref_g N_Q_c_2684_n ) capacitor c=0.00461408f //x=21.41 \
 //y=6.2 //x2=21.632 //y2=5.335
cc_1302 ( N_QN_M40_noxref_g N_Q_c_2684_n ) capacitor c=0.00229208f //x=21.85 \
 //y=6.2 //x2=21.632 //y2=5.335
cc_1303 ( N_QN_c_1463_p N_Q_c_2684_n ) capacitor c=0.00171885f //x=21.775 \
 //y=4.97 //x2=21.632 //y2=5.335
cc_1304 ( QN N_Q_c_2689_n ) capacitor c=0.0280613f //x=19.36 //y=3.51 \
 //x2=23.045 //y2=4.25
cc_1305 ( QN N_Q_c_2689_n ) capacitor c=0.028822f //x=21.21 //y=3.51 \
 //x2=23.045 //y2=4.25
cc_1306 ( N_QN_c_1454_p N_Q_c_2689_n ) capacitor c=0.00340515f //x=21.21 \
 //y=4.755 //x2=23.045 //y2=4.25
cc_1307 ( N_QN_c_1536_p N_Q_c_2689_n ) capacitor c=0.0141373f //x=18.88 \
 //y=5.38 //x2=23.045 //y2=4.25
cc_1308 ( N_QN_c_1476_p N_Q_c_2689_n ) capacitor c=0.00693875f //x=21.05 \
 //y=3.135 //x2=23.045 //y2=4.25
cc_1309 ( QN N_Q_c_2635_n ) capacitor c=0.0032735f //x=19.36 //y=3.51 \
 //x2=18.78 //y2=4.265
cc_1310 ( N_QN_c_1434_n N_Q_c_2635_n ) capacitor c=0.00120813f //x=18.765 \
 //y=5.38 //x2=18.78 //y2=4.265
cc_1311 ( N_QN_c_1536_p N_Q_c_2635_n ) capacitor c=2.45171e-19 //x=18.88 \
 //y=5.38 //x2=18.78 //y2=4.265
cc_1312 ( QN N_Q_c_2637_n ) capacitor c=9.26054e-19 //x=19.36 //y=2.77 \
 //x2=18.62 //y2=2.26
cc_1313 ( QN N_Q_c_2641_n ) capacitor c=7.76118e-19 //x=19.36 //y=3.51 \
 //x2=18.65 //y2=4.88
cc_1314 ( N_QN_c_1434_n N_Q_c_2641_n ) capacitor c=0.00469257f //x=18.765 \
 //y=5.38 //x2=18.65 //y2=4.88
cc_1315 ( N_QN_M39_noxref_g N_Q_c_2700_n ) capacitor c=0.0162284f //x=21.41 \
 //y=6.2 //x2=21.63 //y2=5.56
cc_1316 ( N_QN_M40_noxref_g N_Q_c_2700_n ) capacitor c=0.0179041f //x=21.85 \
 //y=6.2 //x2=21.63 //y2=5.56
cc_1317 ( N_QN_c_1463_p N_Q_c_2700_n ) capacitor c=0.00291477f //x=21.775 \
 //y=4.97 //x2=21.63 //y2=5.56
cc_1318 ( N_QN_c_1434_n N_Q_M37_noxref_g ) capacitor c=0.00842859f //x=18.765 \
 //y=5.38 //x2=18.66 //y2=6.2
cc_1319 ( N_QN_c_1536_p N_Q_M37_noxref_g ) capacitor c=0.00192712f //x=18.88 \
 //y=5.38 //x2=18.66 //y2=6.2
cc_1320 ( N_QN_c_1537_p N_Q_M37_noxref_g ) capacitor c=0.0178987f //x=18.88 \
 //y=5.56 //x2=18.66 //y2=6.2
cc_1321 ( N_QN_c_1566_p N_Q_M38_noxref_g ) capacitor c=0.0110279f //x=19.275 \
 //y=5.38 //x2=19.1 //y2=6.2
cc_1322 ( N_QN_c_1536_p N_Q_M38_noxref_g ) capacitor c=0.00312463f //x=18.88 \
 //y=5.38 //x2=19.1 //y2=6.2
cc_1323 ( N_QN_c_1537_p N_Q_M38_noxref_g ) capacitor c=0.0178506f //x=18.88 \
 //y=5.56 //x2=19.1 //y2=6.2
cc_1324 ( N_QN_c_1473_p N_Q_c_2647_n ) capacitor c=0.00120406f //x=18.92 \
 //y=1.18 //x2=18.655 //y2=1.085
cc_1325 ( N_QN_M11_noxref_d N_Q_c_2647_n ) capacitor c=0.00137165f //x=18.73 \
 //y=1.085 //x2=18.655 //y2=1.085
cc_1326 ( N_QN_c_1504_p N_Q_c_2650_n ) capacitor c=0.00119008f //x=18.92 \
 //y=1.75 //x2=18.655 //y2=1.43
cc_1327 ( N_QN_c_1473_p N_Q_c_2650_n ) capacitor c=0.00218694f //x=18.92 \
 //y=1.18 //x2=18.655 //y2=1.43
cc_1328 ( N_QN_M11_noxref_d N_Q_c_2650_n ) capacitor c=0.00237422f //x=18.73 \
 //y=1.085 //x2=18.655 //y2=1.43
cc_1329 ( N_QN_c_1504_p N_Q_c_2652_n ) capacitor c=0.00438634f //x=18.92 \
 //y=1.75 //x2=18.655 //y2=1.74
cc_1330 ( QN N_Q_c_2715_n ) capacitor c=0.00845606f //x=19.36 //y=3.51 \
 //x2=19.025 //y2=4.97
cc_1331 ( N_QN_c_1536_p N_Q_c_2715_n ) capacitor c=0.0020269f //x=18.88 \
 //y=5.38 //x2=19.025 //y2=4.97
cc_1332 ( N_QN_c_1537_p N_Q_c_2715_n ) capacitor c=0.00302834f //x=18.88 \
 //y=5.56 //x2=19.025 //y2=4.97
cc_1333 ( N_QN_c_1473_p N_Q_c_2718_n ) capacitor c=5.50523e-19 //x=18.92 \
 //y=1.18 //x2=19.03 //y2=0.93
cc_1334 ( N_QN_M11_noxref_d N_Q_c_2718_n ) capacitor c=0.0020782f //x=18.73 \
 //y=1.085 //x2=19.03 //y2=0.93
cc_1335 ( N_QN_c_1504_p N_Q_c_2720_n ) capacitor c=0.00929259f //x=18.92 \
 //y=1.75 //x2=19.03 //y2=1.585
cc_1336 ( N_QN_c_1541_p N_Q_c_2720_n ) capacitor c=0.00194324f //x=19.275 \
 //y=1.835 //x2=19.03 //y2=1.585
cc_1337 ( N_QN_c_1473_p N_Q_c_2720_n ) capacitor c=5.43945e-19 //x=18.92 \
 //y=1.18 //x2=19.03 //y2=1.585
cc_1338 ( N_QN_M11_noxref_d N_Q_c_2720_n ) capacitor c=0.00356097f //x=18.73 \
 //y=1.085 //x2=19.03 //y2=1.585
cc_1339 ( N_QN_c_1473_p N_Q_c_2655_n ) capacitor c=0.00108157f //x=18.92 \
 //y=1.18 //x2=19.185 //y2=1.085
cc_1340 ( N_QN_M11_noxref_d N_Q_c_2655_n ) capacitor c=8.50095e-19 //x=18.73 \
 //y=1.085 //x2=19.185 //y2=1.085
cc_1341 ( N_QN_c_1504_p N_Q_c_2656_n ) capacitor c=0.00341295f //x=18.92 \
 //y=1.75 //x2=19.185 //y2=1.43
cc_1342 ( N_QN_c_1541_p N_Q_c_2656_n ) capacitor c=0.00323005f //x=19.275 \
 //y=1.835 //x2=19.185 //y2=1.43
cc_1343 ( N_QN_c_1473_p N_Q_c_2656_n ) capacitor c=0.00312028f //x=18.92 \
 //y=1.18 //x2=19.185 //y2=1.43
cc_1344 ( N_QN_M11_noxref_d N_Q_c_2656_n ) capacitor c=0.00237422f //x=18.73 \
 //y=1.085 //x2=19.185 //y2=1.43
cc_1345 ( QN N_Q_c_2657_n ) capacitor c=0.00268898f //x=19.36 //y=2.77 \
 //x2=18.62 //y2=2.26
cc_1346 ( QN N_Q_c_2731_n ) capacitor c=0.00309058f //x=19.36 //y=2.77 \
 //x2=18.62 //y2=2.095
cc_1347 ( N_QN_c_1504_p N_Q_c_2731_n ) capacitor c=0.00341114f //x=18.92 \
 //y=1.75 //x2=18.62 //y2=2.095
cc_1348 ( QN N_Q_c_2660_n ) capacitor c=0.00142201f //x=19.36 //y=3.51 \
 //x2=18.65 //y2=4.88
cc_1349 ( N_QN_c_1434_n N_Q_c_2660_n ) capacitor c=8.40673e-19 //x=18.765 \
 //y=5.38 //x2=18.65 //y2=4.88
cc_1350 ( N_QN_c_1434_n N_VDD_c_2903_n ) capacitor c=0.00648294f //x=18.765 \
 //y=5.38 //x2=24.17 //y2=7.58
cc_1351 ( N_QN_c_1566_p N_VDD_c_2903_n ) capacitor c=0.00492584f //x=19.275 \
 //y=5.38 //x2=24.17 //y2=7.58
cc_1352 ( N_QN_c_1470_p N_VDD_c_2903_n ) capacitor c=4.23938e-19 //x=19.36 \
 //y=3.31 //x2=24.17 //y2=7.58
cc_1353 ( N_QN_c_1453_p N_VDD_c_2903_n ) capacitor c=3.56816e-19 //x=21.21 \
 //y=3.295 //x2=24.17 //y2=7.58
cc_1354 ( N_QN_c_1435_n N_VDD_c_2903_n ) capacitor c=0.00368834f //x=18 \
 //y=5.56 //x2=24.17 //y2=7.58
cc_1355 ( N_QN_c_1536_p N_VDD_c_2903_n ) capacitor c=8.42537e-19 //x=18.88 \
 //y=5.38 //x2=24.17 //y2=7.58
cc_1356 ( N_QN_c_1601_p N_VDD_c_2903_n ) capacitor c=0.00285853f //x=18.88 \
 //y=5.56 //x2=24.17 //y2=7.58
cc_1357 ( N_QN_c_1442_n N_VDD_c_2903_n ) capacitor c=0.00224881f //x=18 \
 //y=5.56 //x2=24.17 //y2=7.58
cc_1358 ( N_QN_c_1537_p N_VDD_c_2903_n ) capacitor c=0.00224881f //x=18.88 \
 //y=5.56 //x2=24.17 //y2=7.58
cc_1359 ( N_QN_c_1434_n N_VDD_c_3059_n ) capacitor c=0.00208087f //x=18.765 \
 //y=5.38 //x2=18.355 //y2=7.585
cc_1360 ( N_QN_c_1435_n N_VDD_c_3059_n ) capacitor c=9.41185e-19 //x=18 \
 //y=5.56 //x2=18.355 //y2=7.585
cc_1361 ( N_QN_c_1442_n N_VDD_c_3059_n ) capacitor c=0.0136705f //x=18 \
 //y=5.56 //x2=18.355 //y2=7.585
cc_1362 ( N_QN_c_1434_n N_VDD_c_3119_n ) capacitor c=0.00180737f //x=18.765 \
 //y=5.38 //x2=19.235 //y2=7.585
cc_1363 ( N_QN_c_1566_p N_VDD_c_3119_n ) capacitor c=0.00208087f //x=19.275 \
 //y=5.38 //x2=19.235 //y2=7.585
cc_1364 ( N_QN_c_1536_p N_VDD_c_3119_n ) capacitor c=4.23719e-19 //x=18.88 \
 //y=5.38 //x2=19.235 //y2=7.585
cc_1365 ( N_QN_c_1601_p N_VDD_c_3119_n ) capacitor c=5.77976e-19 //x=18.88 \
 //y=5.56 //x2=19.235 //y2=7.585
cc_1366 ( N_QN_c_1537_p N_VDD_c_3119_n ) capacitor c=0.0136705f //x=18.88 \
 //y=5.56 //x2=19.235 //y2=7.585
cc_1367 ( N_QN_M39_noxref_g N_VDD_c_3124_n ) capacitor c=0.00755614f //x=21.41 \
 //y=6.2 //x2=21.985 //y2=7.585
cc_1368 ( N_QN_M40_noxref_g N_VDD_c_3124_n ) capacitor c=0.00755544f //x=21.85 \
 //y=6.2 //x2=21.985 //y2=7.585
cc_1369 ( QN N_VDD_c_3020_n ) capacitor c=0.0013228f //x=19.36 //y=3.51 \
 //x2=16.77 //y2=7.585
cc_1370 ( N_QN_c_1435_n N_VDD_c_3020_n ) capacitor c=4.91377e-19 //x=18 \
 //y=5.56 //x2=16.77 //y2=7.585
cc_1371 ( N_QN_c_1442_n N_VDD_c_3020_n ) capacitor c=0.0064135f //x=18 \
 //y=5.56 //x2=16.77 //y2=7.585
cc_1372 ( QN N_VDD_c_3129_n ) capacitor c=0.0306839f //x=19.36 //y=3.51 \
 //x2=20.1 //y2=7.585
cc_1373 ( QN N_VDD_c_3129_n ) capacitor c=0.00969996f //x=21.21 //y=3.51 \
 //x2=20.1 //y2=7.585
cc_1374 ( N_QN_c_1454_p N_VDD_c_3129_n ) capacitor c=0.00419437f //x=21.21 \
 //y=4.755 //x2=20.1 //y2=7.585
cc_1375 ( N_QN_c_1536_p N_VDD_c_3129_n ) capacitor c=0.0025639f //x=18.88 \
 //y=5.38 //x2=20.1 //y2=7.585
cc_1376 ( N_QN_c_1601_p N_VDD_c_3129_n ) capacitor c=4.19141e-19 //x=18.88 \
 //y=5.56 //x2=20.1 //y2=7.585
cc_1377 ( N_QN_c_1537_p N_VDD_c_3129_n ) capacitor c=0.0101861f //x=18.88 \
 //y=5.56 //x2=20.1 //y2=7.585
cc_1378 ( N_QN_c_1456_p N_VDD_c_3129_n ) capacitor c=0.00370784f //x=21.21 \
 //y=4.88 //x2=20.1 //y2=7.585
cc_1379 ( N_QN_c_1464_p N_VDD_c_3129_n ) capacitor c=0.00590568f //x=21.485 \
 //y=4.97 //x2=20.1 //y2=7.585
cc_1380 ( N_QN_c_1435_n N_VDD_M35_noxref_s ) capacitor c=0.0572211f //x=18 \
 //y=5.56 //x2=17.425 //y2=5.2
cc_1381 ( N_QN_c_1536_p N_VDD_M35_noxref_s ) capacitor c=6.52457e-19 //x=18.88 \
 //y=5.38 //x2=17.425 //y2=5.2
cc_1382 ( N_QN_c_1442_n N_VDD_M35_noxref_s ) capacitor c=0.0887533f //x=18 \
 //y=5.56 //x2=17.425 //y2=5.2
cc_1383 ( N_QN_c_1434_n N_VDD_M36_noxref_d ) capacitor c=0.00734094f \
 //x=18.765 //y=5.38 //x2=18.295 //y2=5.2
cc_1384 ( N_QN_c_1435_n N_VDD_M36_noxref_d ) capacitor c=0.0043528f //x=18 \
 //y=5.56 //x2=18.295 //y2=5.2
cc_1385 ( N_QN_c_1601_p N_VDD_M36_noxref_d ) capacitor c=0.0043528f //x=18.88 \
 //y=5.56 //x2=18.295 //y2=5.2
cc_1386 ( N_QN_c_1442_n N_VDD_M36_noxref_d ) capacitor c=0.065554f //x=18 \
 //y=5.56 //x2=18.295 //y2=5.2
cc_1387 ( N_QN_c_1537_p N_VDD_M36_noxref_d ) capacitor c=0.065554f //x=18.88 \
 //y=5.56 //x2=18.295 //y2=5.2
cc_1388 ( QN N_VDD_M38_noxref_d ) capacitor c=8.01916e-19 //x=19.36 //y=3.14 \
 //x2=19.175 //y2=5.2
cc_1389 ( N_QN_c_1566_p N_VDD_M38_noxref_d ) capacitor c=0.00961919f \
 //x=19.275 //y=5.38 //x2=19.175 //y2=5.2
cc_1390 ( N_QN_c_1601_p N_VDD_M38_noxref_d ) capacitor c=0.00955781f //x=18.88 \
 //y=5.56 //x2=19.175 //y2=5.2
cc_1391 ( N_QN_c_1537_p N_VDD_M38_noxref_d ) capacitor c=0.065554f //x=18.88 \
 //y=5.56 //x2=19.175 //y2=5.2
cc_1392 ( N_QN_c_1566_p N_VDD_M39_noxref_s ) capacitor c=0.00220019f \
 //x=19.275 //y=5.38 //x2=21.055 //y2=5.2
cc_1393 ( N_QN_c_1453_p N_VDD_M39_noxref_s ) capacitor c=5.19935e-19 //x=21.21 \
 //y=3.295 //x2=21.055 //y2=5.2
cc_1394 ( N_QN_c_1454_p N_VDD_M39_noxref_s ) capacitor c=0.0224586f //x=21.21 \
 //y=4.755 //x2=21.055 //y2=5.2
cc_1395 ( N_QN_c_1536_p N_VDD_M39_noxref_s ) capacitor c=0.00371125f //x=18.88 \
 //y=5.38 //x2=21.055 //y2=5.2
cc_1396 ( N_QN_c_1601_p N_VDD_M39_noxref_s ) capacitor c=9.52042e-19 //x=18.88 \
 //y=5.56 //x2=21.055 //y2=5.2
cc_1397 ( N_QN_c_1456_p N_VDD_M39_noxref_s ) capacitor c=0.00983413f //x=21.21 \
 //y=4.88 //x2=21.055 //y2=5.2
cc_1398 ( N_QN_M39_noxref_g N_VDD_M39_noxref_s ) capacitor c=0.053419f \
 //x=21.41 //y=6.2 //x2=21.055 //y2=5.2
cc_1399 ( N_QN_c_1464_p N_VDD_M39_noxref_s ) capacitor c=0.00607761f \
 //x=21.485 //y=4.97 //x2=21.055 //y2=5.2
cc_1400 ( N_QN_M40_noxref_g N_VDD_M40_noxref_d ) capacitor c=0.015318f \
 //x=21.85 //y=6.2 //x2=21.925 //y2=5.2
cc_1401 ( N_QN_c_1541_p N_GND_c_3696_n ) capacitor c=0.00608539f //x=19.275 \
 //y=1.835 //x2=21.09 //y2=0.175
cc_1402 ( N_QN_c_1470_p N_GND_c_3696_n ) capacitor c=3.22569e-19 //x=19.36 \
 //y=3.31 //x2=21.09 //y2=0.175
cc_1403 ( N_QN_c_1473_p N_GND_c_3696_n ) capacitor c=0.00928865f //x=18.92 \
 //y=1.18 //x2=21.09 //y2=0.175
cc_1404 ( N_QN_M11_noxref_d N_GND_c_3696_n ) capacitor c=3.01769e-19 //x=18.73 \
 //y=1.085 //x2=21.09 //y2=0.175
cc_1405 ( N_QN_c_1489_p N_GND_c_3700_n ) capacitor c=3.92414e-19 //x=20.91 \
 //y=1.055 //x2=21.175 //y2=1.015
cc_1406 ( N_QN_c_1651_p N_GND_c_3700_n ) capacitor c=0.0085115f //x=21.285 \
 //y=0.9 //x2=21.175 //y2=1.015
cc_1407 ( N_QN_c_1491_p N_GND_c_3700_n ) capacitor c=4.45447e-19 //x=21.44 \
 //y=1.055 //x2=21.175 //y2=1.015
cc_1408 ( N_QN_c_1435_n N_GND_c_3663_n ) capacitor c=6.93965e-19 //x=18 \
 //y=5.56 //x2=17.95 //y2=1.135
cc_1409 ( N_QN_c_1473_p N_GND_c_3663_n ) capacitor c=0.0140087f //x=18.92 \
 //y=1.18 //x2=17.95 //y2=1.135
cc_1410 ( N_QN_M11_noxref_d N_GND_c_3663_n ) capacitor c=2.93544e-19 //x=18.73 \
 //y=1.085 //x2=17.95 //y2=1.135
cc_1411 ( N_QN_c_1458_p N_GND_c_3706_n ) capacitor c=0.00772482f //x=21.21 \
 //y=2.375 //x2=21.175 //y2=1.145
cc_1412 ( N_QN_c_1453_p N_GND_c_3706_n ) capacitor c=9.2673e-19 //x=21.21 \
 //y=3.295 //x2=21.175 //y2=1.145
cc_1413 ( N_QN_c_1473_p N_GND_c_3706_n ) capacitor c=0.00606355f //x=18.92 \
 //y=1.18 //x2=21.175 //y2=1.145
cc_1414 ( N_QN_c_1459_p N_GND_c_3706_n ) capacitor c=2.22883e-19 //x=21.21 \
 //y=2.26 //x2=21.175 //y2=1.145
cc_1415 ( N_QN_c_1489_p N_GND_c_3706_n ) capacitor c=0.0015128f //x=20.91 \
 //y=1.055 //x2=21.175 //y2=1.145
cc_1416 ( N_QN_c_1490_p N_GND_c_3706_n ) capacitor c=0.00350108f //x=20.91 \
 //y=1.4 //x2=21.175 //y2=1.145
cc_1417 ( N_QN_c_1492_p N_GND_c_3706_n ) capacitor c=4.09037e-19 //x=20.91 \
 //y=1.71 //x2=21.175 //y2=1.145
cc_1418 ( N_QN_c_1651_p N_GND_c_3706_n ) capacitor c=7.3749e-19 //x=21.285 \
 //y=0.9 //x2=21.175 //y2=1.145
cc_1419 ( N_QN_c_1664_p N_GND_c_3706_n ) capacitor c=5.56593e-19 //x=21.285 \
 //y=1.555 //x2=21.175 //y2=1.145
cc_1420 ( N_QN_c_1491_p N_GND_c_3706_n ) capacitor c=0.00158223f //x=21.44 \
 //y=1.055 //x2=21.175 //y2=1.145
cc_1421 ( N_QN_c_1493_p N_GND_c_3706_n ) capacitor c=0.00276804f //x=21.44 \
 //y=1.4 //x2=21.175 //y2=1.145
cc_1422 ( N_QN_c_1541_p N_GND_c_3677_n ) capacitor c=7.75992e-19 //x=19.275 \
 //y=1.835 //x2=19.93 //y2=0.175
cc_1423 ( N_QN_c_1470_p N_GND_c_3677_n ) capacitor c=3.88381e-19 //x=19.36 \
 //y=3.31 //x2=19.93 //y2=0.175
cc_1424 ( N_QN_c_1489_p N_GND_c_3719_n ) capacitor c=0.00681781f //x=20.91 \
 //y=1.055 //x2=24.17 //y2=0.18
cc_1425 ( QN N_GND_c_3643_n ) capacitor c=9.32616e-19 //x=19.36 //y=2.77 \
 //x2=16.77 //y2=0.175
cc_1426 ( QN N_GND_c_3721_n ) capacitor c=0.0107391f //x=21.21 //y=2.77 \
 //x2=20.1 //y2=0.175
cc_1427 ( N_QN_c_1504_p N_GND_c_3721_n ) capacitor c=0.00460657f //x=18.92 \
 //y=1.75 //x2=20.1 //y2=0.175
cc_1428 ( N_QN_c_1541_p N_GND_c_3721_n ) capacitor c=0.0300371f //x=19.275 \
 //y=1.835 //x2=20.1 //y2=0.175
cc_1429 ( N_QN_c_1458_p N_GND_c_3721_n ) capacitor c=0.00361632f //x=21.21 \
 //y=2.375 //x2=20.1 //y2=0.175
cc_1430 ( N_QN_c_1476_p N_GND_c_3721_n ) capacitor c=0.00504399f //x=21.05 \
 //y=3.135 //x2=20.1 //y2=0.175
cc_1431 ( N_QN_c_1459_p N_GND_c_3721_n ) capacitor c=0.00396211f //x=21.21 \
 //y=2.26 //x2=20.1 //y2=0.175
cc_1432 ( N_QN_c_1492_p N_GND_c_3721_n ) capacitor c=0.00170145f //x=20.91 \
 //y=1.71 //x2=20.1 //y2=0.175
cc_1433 ( N_QN_c_1460_p N_GND_c_3721_n ) capacitor c=0.0102191f //x=20.91 \
 //y=2.095 //x2=20.1 //y2=0.175
cc_1434 ( N_QN_c_1473_p N_GND_M10_noxref_d ) capacitor c=2.82748e-19 //x=18.92 \
 //y=1.18 //x2=17.76 //y2=1.045
cc_1435 ( N_QN_c_1458_p N_GND_M12_noxref_d ) capacitor c=4.4417e-19 //x=21.21 \
 //y=2.375 //x2=20.985 //y2=1.055
cc_1436 ( N_QN_c_1489_p N_GND_M12_noxref_d ) capacitor c=0.00184354f //x=20.91 \
 //y=1.055 //x2=20.985 //y2=1.055
cc_1437 ( N_QN_c_1490_p N_GND_M12_noxref_d ) capacitor c=0.00210798f //x=20.91 \
 //y=1.4 //x2=20.985 //y2=1.055
cc_1438 ( N_QN_c_1651_p N_GND_M12_noxref_d ) capacitor c=0.00474029f \
 //x=21.285 //y=0.9 //x2=20.985 //y2=1.055
cc_1439 ( N_QN_c_1664_p N_GND_M12_noxref_d ) capacitor c=0.00166857f \
 //x=21.285 //y=1.555 //x2=20.985 //y2=1.055
cc_1440 ( N_QN_c_1491_p N_GND_M12_noxref_d ) capacitor c=0.00230174f //x=21.44 \
 //y=1.055 //x2=20.985 //y2=1.055
cc_1441 ( N_QN_c_1493_p N_GND_M12_noxref_d ) capacitor c=0.00210798f //x=21.44 \
 //y=1.4 //x2=20.985 //y2=1.055
cc_1442 ( N_QN_c_1473_p N_noxref_14_M13_noxref_d ) capacitor c=3.39394e-19 \
 //x=18.92 //y=1.18 //x2=21.96 //y2=1.09
cc_1443 ( N_QN_c_1469_p N_noxref_19_c_4319_n ) capacitor c=0.00911498f \
 //x=19.005 //y=1.835 //x2=18.435 //y2=1.675
cc_1444 ( N_QN_c_1541_p N_noxref_19_c_4324_n ) capacitor c=0.00399245f \
 //x=19.275 //y=1.835 //x2=19.32 //y2=0.71
cc_1445 ( N_QN_c_1473_p N_noxref_19_c_4324_n ) capacitor c=0.003751f //x=18.92 \
 //y=1.18 //x2=19.32 //y2=0.71
cc_1446 ( N_QN_M11_noxref_d N_noxref_19_c_4324_n ) capacitor c=0.00910163f \
 //x=18.73 //y=1.085 //x2=19.32 //y2=0.71
cc_1447 ( QN N_noxref_19_M10_noxref_s ) capacitor c=0.00140776f //x=19.36 \
 //y=3.14 //x2=17.33 //y2=0.545
cc_1448 ( N_QN_c_1504_p N_noxref_19_M10_noxref_s ) capacitor c=0.0175047f \
 //x=18.92 //y=1.75 //x2=17.33 //y2=0.545
cc_1449 ( N_QN_c_1541_p N_noxref_19_M10_noxref_s ) capacitor c=0.00603051f \
 //x=19.275 //y=1.835 //x2=17.33 //y2=0.545
cc_1450 ( N_QN_c_1470_p N_noxref_19_M10_noxref_s ) capacitor c=5.56966e-19 \
 //x=19.36 //y=3.31 //x2=17.33 //y2=0.545
cc_1451 ( N_QN_c_1473_p N_noxref_19_M10_noxref_s ) capacitor c=0.00894261f \
 //x=18.92 //y=1.18 //x2=17.33 //y2=0.545
cc_1452 ( N_QN_M11_noxref_d N_noxref_19_M10_noxref_s ) capacitor c=0.0275552f \
 //x=18.73 //y=1.085 //x2=17.33 //y2=0.545
cc_1453 ( N_QN_c_1460_p N_noxref_20_c_4380_n ) capacitor c=0.00262672f \
 //x=20.91 //y=2.095 //x2=20.69 //y2=1.685
cc_1454 ( N_QN_c_1458_p N_noxref_20_c_4381_n ) capacitor c=0.00411069f \
 //x=21.21 //y=2.375 //x2=21.575 //y2=1.77
cc_1455 ( N_QN_c_1453_p N_noxref_20_c_4381_n ) capacitor c=0.00326303f \
 //x=21.21 //y=3.295 //x2=21.575 //y2=1.77
cc_1456 ( N_QN_c_1459_p N_noxref_20_c_4381_n ) capacitor c=0.0104666f \
 //x=21.21 //y=2.26 //x2=21.575 //y2=1.77
cc_1457 ( N_QN_c_1492_p N_noxref_20_c_4381_n ) capacitor c=0.00705077f \
 //x=20.91 //y=1.71 //x2=21.575 //y2=1.77
cc_1458 ( N_QN_c_1460_p N_noxref_20_c_4381_n ) capacitor c=0.0200737f \
 //x=20.91 //y=2.095 //x2=21.575 //y2=1.77
cc_1459 ( N_QN_c_1664_p N_noxref_20_c_4381_n ) capacitor c=0.00588627f \
 //x=21.285 //y=1.555 //x2=21.575 //y2=1.77
cc_1460 ( N_QN_c_1493_p N_noxref_20_c_4381_n ) capacitor c=0.00698822f \
 //x=21.44 //y=1.4 //x2=21.575 //y2=1.77
cc_1461 ( N_QN_c_1489_p N_noxref_20_M12_noxref_s ) capacitor c=0.0295256f \
 //x=20.91 //y=1.055 //x2=20.555 //y2=0.555
cc_1462 ( N_QN_c_1492_p N_noxref_20_M12_noxref_s ) capacitor c=7.99997e-19 \
 //x=20.91 //y=1.71 //x2=20.555 //y2=0.555
cc_1463 ( N_QN_c_1460_p N_noxref_20_M12_noxref_s ) capacitor c=0.00122123f \
 //x=20.91 //y=2.095 //x2=20.555 //y2=0.555
cc_1464 ( N_QN_c_1491_p N_noxref_20_M12_noxref_s ) capacitor c=0.0125924f \
 //x=21.44 //y=1.055 //x2=20.555 //y2=0.555
cc_1465 ( N_SN_c_1716_n N_noxref_7_c_2065_n ) capacitor c=0.00790562f \
 //x=10.85 //y=2.55 //x2=11.96 //y2=2.375
cc_1466 ( N_SN_c_1724_n N_noxref_7_c_2065_n ) capacitor c=0.00195485f \
 //x=11.01 //y=2.39 //x2=11.96 //y2=2.375
cc_1467 ( N_SN_c_1757_n N_noxref_7_c_2065_n ) capacitor c=0.0160193f //x=22.15 \
 //y=2.39 //x2=11.96 //y2=2.375
cc_1468 ( N_SN_c_1726_n N_noxref_7_c_2065_n ) capacitor c=5.39999e-19 \
 //x=10.85 //y=2.26 //x2=11.96 //y2=2.375
cc_1469 ( N_SN_c_1744_n N_noxref_7_c_2065_n ) capacitor c=6.5732e-19 //x=10.94 \
 //y=2.095 //x2=11.96 //y2=2.375
cc_1470 ( SN N_noxref_7_c_2056_n ) capacitor c=0.0359663f //x=10.85 //y=2.77 \
 //x2=11.96 //y2=3.705
cc_1471 ( N_SN_c_1716_n N_noxref_7_c_2056_n ) capacitor c=0.00339731f \
 //x=10.85 //y=2.55 //x2=11.96 //y2=3.705
cc_1472 ( N_SN_c_1724_n N_noxref_7_c_2056_n ) capacitor c=0.00105069f \
 //x=11.01 //y=2.39 //x2=11.96 //y2=3.705
cc_1473 ( N_SN_c_1757_n N_noxref_7_c_2056_n ) capacitor c=0.0178948f //x=22.15 \
 //y=2.39 //x2=11.96 //y2=3.705
cc_1474 ( SN N_noxref_7_c_2073_n ) capacitor c=0.0078001f //x=10.85 //y=2.77 \
 //x2=11.96 //y2=4.025
cc_1475 ( N_SN_c_1757_n N_noxref_7_c_2073_n ) capacitor c=0.00223608f \
 //x=22.15 //y=2.39 //x2=11.96 //y2=4.025
cc_1476 ( SN N_noxref_7_c_2058_n ) capacitor c=0.0158815f //x=10.85 //y=2.77 \
 //x2=11.96 //y2=4.75
cc_1477 ( N_SN_c_1720_n N_noxref_7_c_2058_n ) capacitor c=0.0107551f //x=10.85 \
 //y=4.765 //x2=11.96 //y2=4.75
cc_1478 ( N_SN_c_1729_n N_noxref_7_c_2058_n ) capacitor c=9.52396e-19 \
 //x=10.85 //y=4.88 //x2=11.96 //y2=4.75
cc_1479 ( N_SN_c_1747_n N_noxref_7_c_2058_n ) capacitor c=8.42568e-19 \
 //x=10.85 //y=4.88 //x2=11.96 //y2=4.75
cc_1480 ( N_SN_c_1757_n N_noxref_7_c_2083_n ) capacitor c=0.0192658f //x=22.15 \
 //y=2.39 //x2=15.675 //y2=1.835
cc_1481 ( N_SN_c_1757_n N_noxref_7_c_2084_n ) capacitor c=0.0331716f //x=22.15 \
 //y=2.39 //x2=16.03 //y2=3.705
cc_1482 ( N_SN_c_1757_n N_noxref_7_c_2177_n ) capacitor c=0.00210759f \
 //x=22.15 //y=2.39 //x2=16.03 //y2=4.025
cc_1483 ( N_SN_c_1799_n N_noxref_7_c_2356_n ) capacitor c=0.00829422f \
 //x=22.32 //y=2.55 //x2=23.43 //y2=2.375
cc_1484 ( N_SN_c_1807_n N_noxref_7_c_2356_n ) capacitor c=0.00330689f \
 //x=22.31 //y=2.39 //x2=23.43 //y2=2.375
cc_1485 ( N_SN_c_1820_n N_noxref_7_c_2356_n ) capacitor c=5.39999e-19 \
 //x=22.32 //y=2.26 //x2=23.43 //y2=2.375
cc_1486 ( N_SN_c_1839_n N_noxref_7_c_2356_n ) capacitor c=6.57457e-19 \
 //x=22.41 //y=2.095 //x2=23.43 //y2=2.375
cc_1487 ( SN N_noxref_7_c_2324_n ) capacitor c=0.0360584f //x=22.32 //y=2.77 \
 //x2=23.43 //y2=3.725
cc_1488 ( N_SN_c_1799_n N_noxref_7_c_2324_n ) capacitor c=0.00391297f \
 //x=22.32 //y=2.55 //x2=23.43 //y2=3.725
cc_1489 ( N_SN_c_1807_n N_noxref_7_c_2324_n ) capacitor c=0.00307154f \
 //x=22.31 //y=2.39 //x2=23.43 //y2=3.725
cc_1490 ( SN N_noxref_7_c_2363_n ) capacitor c=0.00772613f //x=22.32 //y=2.77 \
 //x2=23.43 //y2=4.045
cc_1491 ( SN N_noxref_7_c_2326_n ) capacitor c=0.0176311f //x=22.32 //y=2.77 \
 //x2=23.43 //y2=4.75
cc_1492 ( N_SN_c_1803_n N_noxref_7_c_2326_n ) capacitor c=0.0107551f //x=22.32 \
 //y=4.765 //x2=23.43 //y2=4.75
cc_1493 ( N_SN_c_1823_n N_noxref_7_c_2326_n ) capacitor c=9.52396e-19 \
 //x=22.32 //y=4.88 //x2=23.43 //y2=4.75
cc_1494 ( N_SN_c_1842_n N_noxref_7_c_2326_n ) capacitor c=8.42568e-19 \
 //x=22.32 //y=4.88 //x2=23.43 //y2=4.75
cc_1495 ( SN N_noxref_7_c_2089_n ) capacitor c=5.01652e-19 //x=10.85 //y=2.77 \
 //x2=11.96 //y2=3.88
cc_1496 ( N_SN_c_1757_n N_noxref_7_c_2098_n ) capacitor c=6.99179e-19 \
 //x=22.15 //y=2.39 //x2=15.59 //y2=1.18
cc_1497 ( SN N_noxref_7_c_2370_n ) capacitor c=3.43503e-19 //x=22.32 //y=2.77 \
 //x2=23.43 //y2=3.88
cc_1498 ( SN N_noxref_7_c_2060_n ) capacitor c=0.0305162f //x=10.85 //y=2.77 \
 //x2=12.12 //y2=3.88
cc_1499 ( N_SN_c_1716_n N_noxref_7_c_2060_n ) capacitor c=0.00126615f \
 //x=10.85 //y=2.55 //x2=12.12 //y2=3.88
cc_1500 ( N_SN_c_1724_n N_noxref_7_c_2060_n ) capacitor c=0.00517956f \
 //x=11.01 //y=2.39 //x2=12.12 //y2=3.88
cc_1501 ( N_SN_c_1757_n N_noxref_7_c_2060_n ) capacitor c=0.0250833f //x=22.15 \
 //y=2.39 //x2=12.12 //y2=3.88
cc_1502 ( N_SN_c_1757_n N_noxref_7_c_2100_n ) capacitor c=0.0439305f //x=22.15 \
 //y=2.39 //x2=15.865 //y2=3.865
cc_1503 ( N_SN_c_1757_n N_noxref_7_c_2204_n ) capacitor c=0.00512454f \
 //x=22.15 //y=2.39 //x2=16.185 //y2=3.865
cc_1504 ( SN N_noxref_7_c_2377_n ) capacitor c=0.00242466f //x=22.32 //y=2.77 \
 //x2=23.43 //y2=3.885
cc_1505 ( SN N_noxref_7_c_2280_n ) capacitor c=0.0280383f //x=22.32 //y=2.77 \
 //x2=23.27 //y2=3.885
cc_1506 ( N_SN_c_1799_n N_noxref_7_c_2280_n ) capacitor c=0.00126615f \
 //x=22.32 //y=2.55 //x2=23.27 //y2=3.885
cc_1507 ( N_SN_c_1807_n N_noxref_7_c_2280_n ) capacitor c=0.00517956f \
 //x=22.31 //y=2.39 //x2=23.27 //y2=3.885
cc_1508 ( N_SN_c_1757_n N_noxref_7_c_2280_n ) capacitor c=0.0968436f //x=22.15 \
 //y=2.39 //x2=23.27 //y2=3.885
cc_1509 ( N_SN_c_1716_n N_noxref_7_c_2107_n ) capacitor c=0.00116634f \
 //x=10.85 //y=2.55 //x2=11.96 //y2=2.26
cc_1510 ( N_SN_c_1726_n N_noxref_7_c_2107_n ) capacitor c=0.00124907f \
 //x=10.85 //y=2.26 //x2=11.96 //y2=2.26
cc_1511 ( N_SN_c_1744_n N_noxref_7_c_2107_n ) capacitor c=0.00177608f \
 //x=10.94 //y=2.095 //x2=11.96 //y2=2.26
cc_1512 ( SN N_noxref_7_c_2108_n ) capacitor c=2.94497e-19 //x=10.85 //y=2.77 \
 //x2=11.96 //y2=4.88
cc_1513 ( N_SN_c_1720_n N_noxref_7_c_2108_n ) capacitor c=4.56604e-19 \
 //x=10.85 //y=4.765 //x2=11.96 //y2=4.88
cc_1514 ( N_SN_c_1729_n N_noxref_7_c_2108_n ) capacitor c=0.00113985f \
 //x=10.85 //y=4.88 //x2=11.96 //y2=4.88
cc_1515 ( N_SN_c_1747_n N_noxref_7_c_2108_n ) capacitor c=0.00129812f \
 //x=10.85 //y=4.88 //x2=11.96 //y2=4.88
cc_1516 ( N_SN_c_1799_n N_noxref_7_c_2389_n ) capacitor c=0.00115817f \
 //x=22.32 //y=2.55 //x2=23.43 //y2=2.26
cc_1517 ( N_SN_c_1820_n N_noxref_7_c_2389_n ) capacitor c=0.0012491f //x=22.32 \
 //y=2.26 //x2=23.43 //y2=2.26
cc_1518 ( N_SN_c_1839_n N_noxref_7_c_2389_n ) capacitor c=0.00177608f \
 //x=22.41 //y=2.095 //x2=23.43 //y2=2.26
cc_1519 ( SN N_noxref_7_c_2392_n ) capacitor c=2.94497e-19 //x=22.32 //y=2.77 \
 //x2=23.43 //y2=4.88
cc_1520 ( N_SN_c_1803_n N_noxref_7_c_2392_n ) capacitor c=4.56604e-19 \
 //x=22.32 //y=4.765 //x2=23.43 //y2=4.88
cc_1521 ( N_SN_c_1823_n N_noxref_7_c_2392_n ) capacitor c=0.00113985f \
 //x=22.32 //y=4.88 //x2=23.43 //y2=4.88
cc_1522 ( N_SN_c_1842_n N_noxref_7_c_2392_n ) capacitor c=0.00129812f \
 //x=22.32 //y=4.88 //x2=23.43 //y2=4.88
cc_1523 ( N_SN_M27_noxref_g N_noxref_7_M29_noxref_g ) capacitor c=0.0101598f \
 //x=10.82 //y=6.2 //x2=11.7 //y2=6.2
cc_1524 ( N_SN_M28_noxref_g N_noxref_7_M29_noxref_g ) capacitor c=0.0607518f \
 //x=11.26 //y=6.2 //x2=11.7 //y2=6.2
cc_1525 ( N_SN_M28_noxref_g N_noxref_7_M30_noxref_g ) capacitor c=0.0101598f \
 //x=11.26 //y=6.2 //x2=12.14 //y2=6.2
cc_1526 ( N_SN_M41_noxref_g N_noxref_7_M43_noxref_g ) capacitor c=0.0101598f \
 //x=22.29 //y=6.2 //x2=23.17 //y2=6.2
cc_1527 ( N_SN_M42_noxref_g N_noxref_7_M43_noxref_g ) capacitor c=0.0607518f \
 //x=22.73 //y=6.2 //x2=23.17 //y2=6.2
cc_1528 ( N_SN_M42_noxref_g N_noxref_7_M44_noxref_g ) capacitor c=0.0101598f \
 //x=22.73 //y=6.2 //x2=23.61 //y2=6.2
cc_1529 ( N_SN_c_1741_n N_noxref_7_c_2123_n ) capacitor c=0.00456962f \
 //x=10.94 //y=1.09 //x2=11.95 //y2=1.095
cc_1530 ( N_SN_c_1742_n N_noxref_7_c_2125_n ) capacitor c=0.00438372f \
 //x=10.94 //y=1.4 //x2=11.95 //y2=1.44
cc_1531 ( N_SN_c_1743_n N_noxref_7_c_2128_n ) capacitor c=0.00438372f \
 //x=10.94 //y=1.63 //x2=11.95 //y2=1.75
cc_1532 ( N_SN_c_1836_n N_noxref_7_c_2405_n ) capacitor c=0.00456962f \
 //x=22.41 //y=1.09 //x2=23.42 //y2=1.095
cc_1533 ( N_SN_c_1837_n N_noxref_7_c_2406_n ) capacitor c=0.00438372f \
 //x=22.41 //y=1.4 //x2=23.42 //y2=1.44
cc_1534 ( N_SN_c_1838_n N_noxref_7_c_2407_n ) capacitor c=0.00438372f \
 //x=22.41 //y=1.63 //x2=23.42 //y2=1.75
cc_1535 ( N_SN_c_1716_n N_noxref_7_c_2141_n ) capacitor c=0.00149114f \
 //x=10.85 //y=2.55 //x2=11.96 //y2=2.26
cc_1536 ( N_SN_c_1726_n N_noxref_7_c_2141_n ) capacitor c=0.00204796f \
 //x=10.85 //y=2.26 //x2=11.96 //y2=2.26
cc_1537 ( N_SN_c_1744_n N_noxref_7_c_2141_n ) capacitor c=0.00873247f \
 //x=10.94 //y=2.095 //x2=11.96 //y2=2.26
cc_1538 ( N_SN_c_1744_n N_noxref_7_c_2142_n ) capacitor c=0.00438372f \
 //x=10.94 //y=2.095 //x2=11.96 //y2=2.095
cc_1539 ( N_SN_c_1720_n N_noxref_7_c_2144_n ) capacitor c=0.00124604f \
 //x=10.85 //y=4.765 //x2=11.96 //y2=4.88
cc_1540 ( N_SN_c_1729_n N_noxref_7_c_2144_n ) capacitor c=0.00187046f \
 //x=10.85 //y=4.88 //x2=11.96 //y2=4.88
cc_1541 ( N_SN_c_1776_n N_noxref_7_c_2144_n ) capacitor c=0.0616777f \
 //x=11.185 //y=4.97 //x2=11.96 //y2=4.88
cc_1542 ( N_SN_c_1747_n N_noxref_7_c_2144_n ) capacitor c=0.00487508f \
 //x=10.85 //y=4.88 //x2=11.96 //y2=4.88
cc_1543 ( N_SN_c_1799_n N_noxref_7_c_2416_n ) capacitor c=0.00148267f \
 //x=22.32 //y=2.55 //x2=23.43 //y2=2.26
cc_1544 ( N_SN_c_1820_n N_noxref_7_c_2416_n ) capacitor c=0.00204796f \
 //x=22.32 //y=2.26 //x2=23.43 //y2=2.26
cc_1545 ( N_SN_c_1839_n N_noxref_7_c_2416_n ) capacitor c=0.00873247f \
 //x=22.41 //y=2.095 //x2=23.43 //y2=2.26
cc_1546 ( N_SN_c_1839_n N_noxref_7_c_2419_n ) capacitor c=0.00438372f \
 //x=22.41 //y=2.095 //x2=23.43 //y2=2.095
cc_1547 ( N_SN_c_1803_n N_noxref_7_c_2420_n ) capacitor c=0.00124604f \
 //x=22.32 //y=4.765 //x2=23.43 //y2=4.88
cc_1548 ( N_SN_c_1823_n N_noxref_7_c_2420_n ) capacitor c=0.00187046f \
 //x=22.32 //y=4.88 //x2=23.43 //y2=4.88
cc_1549 ( N_SN_c_1930_p N_noxref_7_c_2420_n ) capacitor c=0.0616777f \
 //x=22.655 //y=4.97 //x2=23.43 //y2=4.88
cc_1550 ( N_SN_c_1842_n N_noxref_7_c_2420_n ) capacitor c=0.00487508f \
 //x=22.32 //y=4.88 //x2=23.43 //y2=4.88
cc_1551 ( N_SN_c_1757_n Q ) capacitor c=0.0166134f //x=22.15 //y=2.39 \
 //x2=18.62 //y2=2.77
cc_1552 ( SN Q ) capacitor c=0.00361534f //x=22.32 //y=2.77 //x2=24.17 //y2=2.4
cc_1553 ( SN Q ) capacitor c=8.49048e-19 //x=22.32 //y=2.77 //x2=24.17 //y2=4.62
cc_1554 ( N_SN_c_1799_n N_Q_c_2680_n ) capacitor c=4.23638e-19 //x=22.32 \
 //y=2.55 //x2=22.39 //y2=5.335
cc_1555 ( N_SN_c_1803_n N_Q_c_2680_n ) capacitor c=0.0217566f //x=22.32 \
 //y=4.765 //x2=22.39 //y2=5.335
cc_1556 ( N_SN_c_1823_n N_Q_c_2680_n ) capacitor c=0.00492634f //x=22.32 \
 //y=4.88 //x2=22.39 //y2=5.335
cc_1557 ( N_SN_M41_noxref_g N_Q_c_2680_n ) capacitor c=0.00858241f //x=22.29 \
 //y=6.2 //x2=22.39 //y2=5.335
cc_1558 ( N_SN_c_1842_n N_Q_c_2680_n ) capacitor c=6.14744e-19 //x=22.32 \
 //y=4.88 //x2=22.39 //y2=5.335
cc_1559 ( N_SN_M42_noxref_g N_Q_c_2743_n ) capacitor c=0.0103546f //x=22.73 \
 //y=6.2 //x2=23.275 //y2=5.335
cc_1560 ( N_SN_c_1757_n N_Q_c_2632_n ) capacitor c=0.0170109f //x=22.15 \
 //y=2.39 //x2=18.62 //y2=2.26
cc_1561 ( N_SN_c_1799_n N_Q_c_2745_n ) capacitor c=3.93778e-19 //x=22.32 \
 //y=2.55 //x2=22.51 //y2=5.335
cc_1562 ( N_SN_c_1803_n N_Q_c_2745_n ) capacitor c=0.00244335f //x=22.32 \
 //y=4.765 //x2=22.51 //y2=5.335
cc_1563 ( N_SN_c_1823_n N_Q_c_2745_n ) capacitor c=0.00132214f //x=22.32 \
 //y=4.88 //x2=22.51 //y2=5.335
cc_1564 ( N_SN_M41_noxref_g N_Q_c_2745_n ) capacitor c=0.00229818f //x=22.29 \
 //y=6.2 //x2=22.51 //y2=5.335
cc_1565 ( N_SN_M42_noxref_g N_Q_c_2745_n ) capacitor c=0.00230699f //x=22.73 \
 //y=6.2 //x2=22.51 //y2=5.335
cc_1566 ( N_SN_c_1930_p N_Q_c_2745_n ) capacitor c=0.00177039f //x=22.655 \
 //y=4.97 //x2=22.51 //y2=5.335
cc_1567 ( SN N_Q_c_2689_n ) capacitor c=0.0277861f //x=22.32 //y=2.77 \
 //x2=23.045 //y2=4.25
cc_1568 ( N_SN_c_1803_n N_Q_c_2689_n ) capacitor c=0.00325474f //x=22.32 \
 //y=4.765 //x2=23.045 //y2=4.25
cc_1569 ( N_SN_c_1757_n N_Q_c_2689_n ) capacitor c=0.00309203f //x=22.15 \
 //y=2.39 //x2=23.045 //y2=4.25
cc_1570 ( N_SN_c_1803_n N_Q_c_2754_n ) capacitor c=7.85344e-19 //x=22.32 \
 //y=4.765 //x2=22.51 //y2=5.56
cc_1571 ( N_SN_M41_noxref_g N_Q_c_2754_n ) capacitor c=0.0179041f //x=22.29 \
 //y=6.2 //x2=22.51 //y2=5.56
cc_1572 ( N_SN_M42_noxref_g N_Q_c_2754_n ) capacitor c=0.0179041f //x=22.73 \
 //y=6.2 //x2=22.51 //y2=5.56
cc_1573 ( N_SN_c_1930_p N_Q_c_2754_n ) capacitor c=0.00290085f //x=22.655 \
 //y=4.97 //x2=22.51 //y2=5.56
cc_1574 ( N_SN_M27_noxref_g N_VDD_c_2977_n ) capacitor c=0.00705252f //x=10.82 \
 //y=6.2 //x2=11.395 //y2=7.585
cc_1575 ( N_SN_M28_noxref_g N_VDD_c_2977_n ) capacitor c=0.00755544f //x=11.26 \
 //y=6.2 //x2=11.395 //y2=7.585
cc_1576 ( N_SN_M41_noxref_g N_VDD_c_3160_n ) capacitor c=0.00705252f //x=22.29 \
 //y=6.2 //x2=22.865 //y2=7.585
cc_1577 ( N_SN_M42_noxref_g N_VDD_c_3160_n ) capacitor c=0.00755544f //x=22.73 \
 //y=6.2 //x2=22.865 //y2=7.585
cc_1578 ( N_SN_M27_noxref_g N_VDD_M26_noxref_d ) capacitor c=0.015318f \
 //x=10.82 //y=6.2 //x2=10.455 //y2=5.2
cc_1579 ( N_SN_M28_noxref_g N_VDD_M28_noxref_d ) capacitor c=0.015318f \
 //x=11.26 //y=6.2 //x2=11.335 //y2=5.2
cc_1580 ( N_SN_M41_noxref_g N_VDD_M40_noxref_d ) capacitor c=0.015318f \
 //x=22.29 //y=6.2 //x2=21.925 //y2=5.2
cc_1581 ( N_SN_M42_noxref_g N_VDD_M42_noxref_d ) capacitor c=0.015318f \
 //x=22.73 //y=6.2 //x2=22.805 //y2=5.2
cc_1582 ( N_SN_c_1757_n N_noxref_12_c_3474_n ) capacitor c=0.00519491f \
 //x=22.15 //y=2.39 //x2=11.645 //y2=1.175
cc_1583 ( N_SN_c_1741_n N_noxref_12_c_3474_n ) capacitor c=0.00123426f \
 //x=10.94 //y=1.09 //x2=11.645 //y2=1.175
cc_1584 ( N_SN_c_1742_n N_noxref_12_c_3474_n ) capacitor c=0.0129287f \
 //x=10.94 //y=1.4 //x2=11.645 //y2=1.175
cc_1585 ( N_SN_c_1743_n N_noxref_12_c_3474_n ) capacitor c=0.00132209f \
 //x=10.94 //y=1.63 //x2=11.645 //y2=1.175
cc_1586 ( N_SN_c_1757_n N_noxref_12_c_3462_n ) capacitor c=3.59668e-19 \
 //x=22.15 //y=2.39 //x2=12.615 //y2=0.72
cc_1587 ( N_SN_c_1716_n N_noxref_12_M6_noxref_d ) capacitor c=0.0067342f \
 //x=10.85 //y=2.55 //x2=10.49 //y2=1.09
cc_1588 ( N_SN_c_1724_n N_noxref_12_M6_noxref_d ) capacitor c=9.81665e-19 \
 //x=11.01 //y=2.39 //x2=10.49 //y2=1.09
cc_1589 ( N_SN_c_1726_n N_noxref_12_M6_noxref_d ) capacitor c=2.2052e-19 \
 //x=10.85 //y=2.26 //x2=10.49 //y2=1.09
cc_1590 ( N_SN_c_1736_n N_noxref_12_M6_noxref_d ) capacitor c=0.00253592f \
 //x=10.415 //y=1.09 //x2=10.49 //y2=1.09
cc_1591 ( N_SN_c_1739_n N_noxref_12_M6_noxref_d ) capacitor c=0.00604087f \
 //x=10.415 //y=1.4 //x2=10.49 //y2=1.09
cc_1592 ( N_SN_c_1973_p N_noxref_12_M6_noxref_d ) capacitor c=0.002686f \
 //x=10.785 //y=0.935 //x2=10.49 //y2=1.09
cc_1593 ( N_SN_c_1974_p N_noxref_12_M6_noxref_d ) capacitor c=0.00251995f \
 //x=10.785 //y=1.555 //x2=10.49 //y2=1.09
cc_1594 ( N_SN_c_1741_n N_noxref_12_M6_noxref_d ) capacitor c=0.00314523f \
 //x=10.94 //y=1.09 //x2=10.49 //y2=1.09
cc_1595 ( N_SN_c_1742_n N_noxref_12_M6_noxref_d ) capacitor c=0.00168289f \
 //x=10.94 //y=1.4 //x2=10.49 //y2=1.09
cc_1596 ( N_SN_c_1743_n N_noxref_12_M6_noxref_d ) capacitor c=0.00111165f \
 //x=10.94 //y=1.63 //x2=10.49 //y2=1.09
cc_1597 ( N_SN_c_1757_n N_noxref_12_M7_noxref_s ) capacitor c=0.00471087f \
 //x=22.15 //y=2.39 //x2=11.595 //y2=0.555
cc_1598 ( N_SN_c_1741_n N_noxref_12_M7_noxref_s ) capacitor c=7.21316e-19 \
 //x=10.94 //y=1.09 //x2=11.595 //y2=0.555
cc_1599 ( N_SN_c_1742_n N_noxref_12_M7_noxref_s ) capacitor c=0.00365271f \
 //x=10.94 //y=1.4 //x2=11.595 //y2=0.555
cc_1600 ( N_SN_c_1744_n N_noxref_12_M7_noxref_s ) capacitor c=9.86711e-19 \
 //x=10.94 //y=2.095 //x2=11.595 //y2=0.555
cc_1601 ( N_SN_c_1716_n N_GND_c_3609_n ) capacitor c=8.88339e-19 //x=10.85 \
 //y=2.55 //x2=14.535 //y2=0.175
cc_1602 ( N_SN_c_1724_n N_GND_c_3609_n ) capacitor c=0.00334343f //x=11.01 \
 //y=2.39 //x2=14.535 //y2=0.175
cc_1603 ( N_SN_c_1757_n N_GND_c_3609_n ) capacitor c=0.100785f //x=22.15 \
 //y=2.39 //x2=14.535 //y2=0.175
cc_1604 ( N_SN_c_1757_n N_GND_c_3652_n ) capacitor c=0.0854967f //x=22.15 \
 //y=2.39 //x2=17.865 //y2=0.175
cc_1605 ( N_SN_c_1757_n N_GND_c_3696_n ) capacitor c=0.0807177f //x=22.15 \
 //y=2.39 //x2=21.09 //y2=0.175
cc_1606 ( N_SN_c_1799_n N_GND_c_3742_n ) capacitor c=8.66523e-19 //x=22.32 \
 //y=2.55 //x2=24.17 //y2=0.18
cc_1607 ( N_SN_c_1807_n N_GND_c_3742_n ) capacitor c=0.00316384f //x=22.31 \
 //y=2.39 //x2=24.17 //y2=0.18
cc_1608 ( N_SN_c_1757_n N_GND_c_3742_n ) capacitor c=0.0243267f //x=22.15 \
 //y=2.39 //x2=24.17 //y2=0.18
cc_1609 ( N_SN_c_1757_n N_GND_c_3613_n ) capacitor c=0.00537176f //x=22.15 \
 //y=2.39 //x2=14.62 //y2=1.135
cc_1610 ( N_SN_c_1757_n N_GND_c_3663_n ) capacitor c=0.00570671f //x=22.15 \
 //y=2.39 //x2=17.95 //y2=1.135
cc_1611 ( N_SN_c_1757_n N_GND_c_3706_n ) capacitor c=0.00480958f //x=22.15 \
 //y=2.39 //x2=21.175 //y2=1.145
cc_1612 ( N_SN_c_1757_n N_GND_c_3630_n ) capacitor c=0.0219223f //x=22.15 \
 //y=2.39 //x2=13.44 //y2=0.175
cc_1613 ( N_SN_c_1757_n N_GND_c_3643_n ) capacitor c=0.0228073f //x=22.15 \
 //y=2.39 //x2=16.77 //y2=0.175
cc_1614 ( N_SN_c_1757_n N_GND_c_3721_n ) capacitor c=0.0215281f //x=22.15 \
 //y=2.39 //x2=20.1 //y2=0.175
cc_1615 ( N_SN_c_1836_n N_noxref_14_c_4001_n ) capacitor c=0.00123426f \
 //x=22.41 //y=1.09 //x2=23.115 //y2=1.175
cc_1616 ( N_SN_c_1837_n N_noxref_14_c_4001_n ) capacitor c=0.0129287f \
 //x=22.41 //y=1.4 //x2=23.115 //y2=1.175
cc_1617 ( N_SN_c_1838_n N_noxref_14_c_4001_n ) capacitor c=0.00132209f \
 //x=22.41 //y=1.63 //x2=23.115 //y2=1.175
cc_1618 ( N_SN_c_1799_n N_noxref_14_M13_noxref_d ) capacitor c=0.00686082f \
 //x=22.32 //y=2.55 //x2=21.96 //y2=1.09
cc_1619 ( N_SN_c_1807_n N_noxref_14_M13_noxref_d ) capacitor c=0.00119981f \
 //x=22.31 //y=2.39 //x2=21.96 //y2=1.09
cc_1620 ( N_SN_c_1757_n N_noxref_14_M13_noxref_d ) capacitor c=0.00508822f \
 //x=22.15 //y=2.39 //x2=21.96 //y2=1.09
cc_1621 ( N_SN_c_1820_n N_noxref_14_M13_noxref_d ) capacitor c=2.2052e-19 \
 //x=22.32 //y=2.26 //x2=21.96 //y2=1.09
cc_1622 ( N_SN_c_1831_n N_noxref_14_M13_noxref_d ) capacitor c=0.00253592f \
 //x=21.885 //y=1.09 //x2=21.96 //y2=1.09
cc_1623 ( N_SN_c_1834_n N_noxref_14_M13_noxref_d ) capacitor c=0.00604066f \
 //x=21.885 //y=1.4 //x2=21.96 //y2=1.09
cc_1624 ( N_SN_c_2005_p N_noxref_14_M13_noxref_d ) capacitor c=0.002686f \
 //x=22.255 //y=0.935 //x2=21.96 //y2=1.09
cc_1625 ( N_SN_c_2006_p N_noxref_14_M13_noxref_d ) capacitor c=0.00251995f \
 //x=22.255 //y=1.555 //x2=21.96 //y2=1.09
cc_1626 ( N_SN_c_1836_n N_noxref_14_M13_noxref_d ) capacitor c=0.00314523f \
 //x=22.41 //y=1.09 //x2=21.96 //y2=1.09
cc_1627 ( N_SN_c_1837_n N_noxref_14_M13_noxref_d ) capacitor c=0.00168289f \
 //x=22.41 //y=1.4 //x2=21.96 //y2=1.09
cc_1628 ( N_SN_c_1838_n N_noxref_14_M13_noxref_d ) capacitor c=0.00111165f \
 //x=22.41 //y=1.63 //x2=21.96 //y2=1.09
cc_1629 ( N_SN_c_1836_n N_noxref_14_M14_noxref_s ) capacitor c=7.21316e-19 \
 //x=22.41 //y=1.09 //x2=23.065 //y2=0.555
cc_1630 ( N_SN_c_1837_n N_noxref_14_M14_noxref_s ) capacitor c=0.00365271f \
 //x=22.41 //y=1.4 //x2=23.065 //y2=0.555
cc_1631 ( N_SN_c_1839_n N_noxref_14_M14_noxref_s ) capacitor c=9.86711e-19 \
 //x=22.41 //y=2.095 //x2=23.065 //y2=0.555
cc_1632 ( N_SN_c_1736_n N_noxref_17_c_4198_n ) capacitor c=0.0167228f \
 //x=10.415 //y=1.09 //x2=11.075 //y2=0.72
cc_1633 ( N_SN_c_1741_n N_noxref_17_c_4198_n ) capacitor c=0.00534519f \
 //x=10.94 //y=1.09 //x2=11.075 //y2=0.72
cc_1634 ( N_SN_c_1716_n N_noxref_17_c_4200_n ) capacitor c=0.00751795f \
 //x=10.85 //y=2.55 //x2=11.075 //y2=1.77
cc_1635 ( N_SN_c_1757_n N_noxref_17_c_4200_n ) capacitor c=0.00129557f \
 //x=22.15 //y=2.39 //x2=11.075 //y2=1.77
cc_1636 ( N_SN_c_1726_n N_noxref_17_c_4200_n ) capacitor c=0.0105652f \
 //x=10.85 //y=2.26 //x2=11.075 //y2=1.77
cc_1637 ( N_SN_c_1739_n N_noxref_17_c_4200_n ) capacitor c=0.0154024f \
 //x=10.415 //y=1.4 //x2=11.075 //y2=1.77
cc_1638 ( N_SN_c_1744_n N_noxref_17_c_4200_n ) capacitor c=0.0211955f \
 //x=10.94 //y=2.095 //x2=11.075 //y2=1.77
cc_1639 ( N_SN_c_1757_n N_noxref_17_M5_noxref_s ) capacitor c=0.00383739f \
 //x=22.15 //y=2.39 //x2=9.085 //y2=0.555
cc_1640 ( N_SN_c_1736_n N_noxref_17_M5_noxref_s ) capacitor c=0.00798959f \
 //x=10.415 //y=1.09 //x2=9.085 //y2=0.555
cc_1641 ( N_SN_c_1743_n N_noxref_17_M5_noxref_s ) capacitor c=0.00212176f \
 //x=10.94 //y=1.63 //x2=9.085 //y2=0.555
cc_1642 ( N_SN_c_1744_n N_noxref_17_M5_noxref_s ) capacitor c=0.00298115f \
 //x=10.94 //y=2.095 //x2=9.085 //y2=0.555
cc_1643 ( N_SN_c_1757_n N_noxref_18_c_4244_n ) capacitor c=0.00442321f \
 //x=22.15 //y=2.39 //x2=14.135 //y2=1.675
cc_1644 ( N_SN_c_1757_n N_noxref_18_c_4245_n ) capacitor c=0.0127693f \
 //x=22.15 //y=2.39 //x2=15.02 //y2=1.76
cc_1645 ( N_SN_c_1757_n N_noxref_18_c_4252_n ) capacitor c=0.00403292f \
 //x=22.15 //y=2.39 //x2=15.105 //y2=1.675
cc_1646 ( N_SN_c_1757_n N_noxref_18_c_4259_n ) capacitor c=5.61937e-19 \
 //x=22.15 //y=2.39 //x2=15.99 //y2=0.71
cc_1647 ( N_SN_c_1757_n N_noxref_18_M8_noxref_s ) capacitor c=0.0010705f \
 //x=22.15 //y=2.39 //x2=14 //y2=0.545
cc_1648 ( N_SN_c_1757_n N_noxref_19_c_4311_n ) capacitor c=0.00442321f \
 //x=22.15 //y=2.39 //x2=17.465 //y2=1.675
cc_1649 ( N_SN_c_1757_n N_noxref_19_c_4312_n ) capacitor c=0.01279f //x=22.15 \
 //y=2.39 //x2=18.35 //y2=1.76
cc_1650 ( N_SN_c_1757_n N_noxref_19_c_4319_n ) capacitor c=0.00413238f \
 //x=22.15 //y=2.39 //x2=18.435 //y2=1.675
cc_1651 ( N_SN_c_1757_n N_noxref_19_c_4324_n ) capacitor c=7.32233e-19 \
 //x=22.15 //y=2.39 //x2=19.32 //y2=0.71
cc_1652 ( N_SN_c_1757_n N_noxref_19_M10_noxref_s ) capacitor c=0.0010705f \
 //x=22.15 //y=2.39 //x2=17.33 //y2=0.545
cc_1653 ( N_SN_c_1757_n N_noxref_20_c_4380_n ) capacitor c=0.00444844f \
 //x=22.15 //y=2.39 //x2=20.69 //y2=1.685
cc_1654 ( N_SN_c_1757_n N_noxref_20_c_4381_n ) capacitor c=0.0133549f \
 //x=22.15 //y=2.39 //x2=21.575 //y2=1.77
cc_1655 ( N_SN_c_1831_n N_noxref_20_c_4394_n ) capacitor c=0.0167228f \
 //x=21.885 //y=1.09 //x2=22.545 //y2=0.72
cc_1656 ( N_SN_c_1836_n N_noxref_20_c_4394_n ) capacitor c=0.00534519f \
 //x=22.41 //y=1.09 //x2=22.545 //y2=0.72
cc_1657 ( N_SN_c_1799_n N_noxref_20_c_4396_n ) capacitor c=0.00743214f \
 //x=22.32 //y=2.55 //x2=22.545 //y2=1.77
cc_1658 ( N_SN_c_1757_n N_noxref_20_c_4396_n ) capacitor c=0.00803439f \
 //x=22.15 //y=2.39 //x2=22.545 //y2=1.77
cc_1659 ( N_SN_c_1820_n N_noxref_20_c_4396_n ) capacitor c=0.0105652f \
 //x=22.32 //y=2.26 //x2=22.545 //y2=1.77
cc_1660 ( N_SN_c_1834_n N_noxref_20_c_4396_n ) capacitor c=0.0154243f \
 //x=21.885 //y=1.4 //x2=22.545 //y2=1.77
cc_1661 ( N_SN_c_1839_n N_noxref_20_c_4396_n ) capacitor c=0.0214725f \
 //x=22.41 //y=2.095 //x2=22.545 //y2=1.77
cc_1662 ( N_SN_c_1757_n N_noxref_20_M12_noxref_s ) capacitor c=0.00444844f \
 //x=22.15 //y=2.39 //x2=20.555 //y2=0.555
cc_1663 ( N_SN_c_1831_n N_noxref_20_M12_noxref_s ) capacitor c=0.00798959f \
 //x=21.885 //y=1.09 //x2=20.555 //y2=0.555
cc_1664 ( N_SN_c_1838_n N_noxref_20_M12_noxref_s ) capacitor c=0.00212176f \
 //x=22.41 //y=1.63 //x2=20.555 //y2=0.555
cc_1665 ( N_SN_c_1839_n N_noxref_20_M12_noxref_s ) capacitor c=0.00298115f \
 //x=22.41 //y=2.095 //x2=20.555 //y2=0.555
cc_1666 ( N_noxref_7_c_2084_n Q ) capacitor c=0.00253828f //x=16.03 //y=3.705 \
 //x2=18.62 //y2=2.77
cc_1667 ( N_noxref_7_c_2280_n Q ) capacitor c=0.0253005f //x=23.27 //y=3.885 \
 //x2=18.62 //y2=2.77
cc_1668 ( N_noxref_7_c_2087_n Q ) capacitor c=0.00130061f //x=16.03 //y=5.295 \
 //x2=18.62 //y2=4.62
cc_1669 ( N_noxref_7_c_2356_n Q ) capacitor c=0.0153209f //x=23.43 //y=2.375 \
 //x2=24.17 //y2=2.4
cc_1670 ( N_noxref_7_c_2324_n Q ) capacitor c=0.062823f //x=23.43 //y=3.725 \
 //x2=24.17 //y2=2.4
cc_1671 ( N_noxref_7_c_2363_n Q ) capacitor c=0.0149195f //x=23.43 //y=4.045 \
 //x2=24.17 //y2=2.4
cc_1672 ( N_noxref_7_c_2326_n Q ) capacitor c=0.00271037f //x=23.43 //y=4.75 \
 //x2=24.17 //y2=2.4
cc_1673 ( N_noxref_7_c_2370_n Q ) capacitor c=0.00548505f //x=23.43 //y=3.88 \
 //x2=24.17 //y2=2.4
cc_1674 ( N_noxref_7_c_2377_n Q ) capacitor c=0.00686827f //x=23.43 //y=3.885 \
 //x2=24.17 //y2=2.4
cc_1675 ( N_noxref_7_c_2389_n Q ) capacitor c=0.00467849f //x=23.43 //y=2.26 \
 //x2=24.17 //y2=2.4
cc_1676 ( N_noxref_7_c_2416_n Q ) capacitor c=0.0025845f //x=23.43 //y=2.26 \
 //x2=24.17 //y2=2.4
cc_1677 ( N_noxref_7_c_2419_n Q ) capacitor c=0.00282067f //x=23.43 //y=2.095 \
 //x2=24.17 //y2=2.4
cc_1678 ( N_noxref_7_c_2326_n Q ) capacitor c=0.0301911f //x=23.43 //y=4.75 \
 //x2=24.17 //y2=4.62
cc_1679 ( N_noxref_7_c_2392_n Q ) capacitor c=0.00442006f //x=23.43 //y=4.88 \
 //x2=24.17 //y2=4.62
cc_1680 ( N_noxref_7_c_2420_n Q ) capacitor c=0.00739875f //x=23.43 //y=4.88 \
 //x2=24.17 //y2=4.62
cc_1681 ( N_noxref_7_c_2326_n Q ) capacitor c=9.19401e-19 //x=23.43 //y=4.75 \
 //x2=24.17 //y2=4.25
cc_1682 ( N_noxref_7_c_2280_n N_Q_c_2626_n ) capacitor c=0.00645173f //x=23.27 \
 //y=3.885 //x2=18.62 //y2=4.425
cc_1683 ( N_noxref_7_c_2363_n N_Q_c_2743_n ) capacitor c=0.0018226f //x=23.43 \
 //y=4.045 //x2=23.275 //y2=5.335
cc_1684 ( N_noxref_7_M43_noxref_g N_Q_c_2743_n ) capacitor c=0.00994406f \
 //x=23.17 //y=6.2 //x2=23.275 //y2=5.335
cc_1685 ( N_noxref_7_M43_noxref_g N_Q_c_2777_n ) capacitor c=0.00226521f \
 //x=23.17 //y=6.2 //x2=23.39 //y2=5.56
cc_1686 ( N_noxref_7_M44_noxref_g N_Q_c_2777_n ) capacitor c=0.00427254f \
 //x=23.61 //y=6.2 //x2=23.39 //y2=5.56
cc_1687 ( N_noxref_7_c_2363_n N_Q_c_2779_n ) capacitor c=4.89109e-19 //x=23.43 \
 //y=4.045 //x2=24.085 //y2=5.335
cc_1688 ( N_noxref_7_c_2326_n N_Q_c_2779_n ) capacitor c=0.00234762f //x=23.43 \
 //y=4.75 //x2=24.085 //y2=5.335
cc_1689 ( N_noxref_7_c_2392_n N_Q_c_2779_n ) capacitor c=0.00130631f //x=23.43 \
 //y=4.88 //x2=24.085 //y2=5.335
cc_1690 ( N_noxref_7_M44_noxref_g N_Q_c_2779_n ) capacitor c=0.0111495f \
 //x=23.61 //y=6.2 //x2=24.085 //y2=5.335
cc_1691 ( N_noxref_7_c_2405_n N_Q_c_2783_n ) capacitor c=4.64015e-19 //x=23.42 \
 //y=1.095 //x2=23.685 //y2=1.305
cc_1692 ( N_noxref_7_c_2406_n N_Q_c_2783_n ) capacitor c=0.0026012f //x=23.42 \
 //y=1.44 //x2=23.685 //y2=1.305
cc_1693 ( N_noxref_7_c_2451_p N_Q_c_2783_n ) capacitor c=5.29969e-19 \
 //x=23.795 //y=0.94 //x2=23.685 //y2=1.305
cc_1694 ( N_noxref_7_c_2452_p N_Q_c_2783_n ) capacitor c=5.31989e-19 \
 //x=23.795 //y=1.595 //x2=23.685 //y2=1.305
cc_1695 ( N_noxref_7_c_2453_p N_Q_c_2783_n ) capacitor c=5.7502e-19 //x=23.95 \
 //y=1.095 //x2=23.685 //y2=1.305
cc_1696 ( N_noxref_7_c_2454_p N_Q_c_2783_n ) capacitor c=0.00357756f //x=23.95 \
 //y=1.44 //x2=23.685 //y2=1.305
cc_1697 ( N_noxref_7_c_2406_n N_Q_c_2681_n ) capacitor c=0.00127432f //x=23.42 \
 //y=1.44 //x2=23.685 //y2=1.76
cc_1698 ( N_noxref_7_c_2407_n N_Q_c_2681_n ) capacitor c=0.00429966f //x=23.42 \
 //y=1.75 //x2=23.685 //y2=1.76
cc_1699 ( N_noxref_7_c_2452_p N_Q_c_2681_n ) capacitor c=0.00942306f \
 //x=23.795 //y=1.595 //x2=23.685 //y2=1.76
cc_1700 ( N_noxref_7_c_2454_p N_Q_c_2681_n ) capacitor c=0.00363411f //x=23.95 \
 //y=1.44 //x2=23.685 //y2=1.76
cc_1701 ( N_noxref_7_c_2419_n N_Q_c_2681_n ) capacitor c=0.00362297f //x=23.43 \
 //y=2.095 //x2=23.685 //y2=1.76
cc_1702 ( N_noxref_7_c_2452_p N_Q_c_2794_n ) capacitor c=0.00194716f \
 //x=23.795 //y=1.595 //x2=24.085 //y2=1.845
cc_1703 ( N_noxref_7_c_2454_p N_Q_c_2794_n ) capacitor c=0.00323576f //x=23.95 \
 //y=1.44 //x2=24.085 //y2=1.845
cc_1704 ( N_noxref_7_c_2326_n N_Q_c_2796_n ) capacitor c=0.017807f //x=23.43 \
 //y=4.75 //x2=24.17 //y2=4.425
cc_1705 ( N_noxref_7_c_2326_n N_Q_c_2797_n ) capacitor c=0.0224599f //x=23.43 \
 //y=4.75 //x2=23.39 //y2=5.335
cc_1706 ( N_noxref_7_c_2392_n N_Q_c_2797_n ) capacitor c=0.00346456f //x=23.43 \
 //y=4.88 //x2=23.39 //y2=5.335
cc_1707 ( N_noxref_7_c_2420_n N_Q_c_2797_n ) capacitor c=0.00203307f //x=23.43 \
 //y=4.88 //x2=23.39 //y2=5.335
cc_1708 ( N_noxref_7_c_2363_n N_Q_c_2689_n ) capacitor c=0.00274241f //x=23.43 \
 //y=4.045 //x2=23.045 //y2=4.25
cc_1709 ( N_noxref_7_c_2326_n N_Q_c_2689_n ) capacitor c=5.04002e-19 //x=23.43 \
 //y=4.75 //x2=23.045 //y2=4.25
cc_1710 ( N_noxref_7_c_2377_n N_Q_c_2689_n ) capacitor c=0.0374497f //x=23.43 \
 //y=3.885 //x2=23.045 //y2=4.25
cc_1711 ( N_noxref_7_c_2280_n N_Q_c_2689_n ) capacitor c=0.409255f //x=23.27 \
 //y=3.885 //x2=23.045 //y2=4.25
cc_1712 ( N_noxref_7_c_2363_n N_Q_c_2804_n ) capacitor c=0.002495f //x=23.43 \
 //y=4.045 //x2=23.645 //y2=4.27
cc_1713 ( N_noxref_7_c_2326_n N_Q_c_2804_n ) capacitor c=0.0292186f //x=23.43 \
 //y=4.75 //x2=23.645 //y2=4.27
cc_1714 ( N_noxref_7_c_2280_n N_Q_c_2635_n ) capacitor c=0.0368432f //x=23.27 \
 //y=3.885 //x2=18.78 //y2=4.265
cc_1715 ( N_noxref_7_c_2326_n N_Q_c_2807_n ) capacitor c=0.00217653f //x=23.43 \
 //y=4.75 //x2=23.39 //y2=5.56
cc_1716 ( N_noxref_7_c_2392_n N_Q_c_2807_n ) capacitor c=0.00552343f //x=23.43 \
 //y=4.88 //x2=23.39 //y2=5.56
cc_1717 ( N_noxref_7_M43_noxref_g N_Q_c_2807_n ) capacitor c=0.0178885f \
 //x=23.17 //y=6.2 //x2=23.39 //y2=5.56
cc_1718 ( N_noxref_7_M44_noxref_g N_Q_c_2807_n ) capacitor c=0.0188608f \
 //x=23.61 //y=6.2 //x2=23.39 //y2=5.56
cc_1719 ( N_noxref_7_c_2420_n N_Q_c_2807_n ) capacitor c=0.00375636f //x=23.43 \
 //y=4.88 //x2=23.39 //y2=5.56
cc_1720 ( N_noxref_7_c_2405_n N_Q_M14_noxref_d ) capacitor c=0.00137165f \
 //x=23.42 //y=1.095 //x2=23.495 //y2=1.095
cc_1721 ( N_noxref_7_c_2406_n N_Q_M14_noxref_d ) capacitor c=0.00237422f \
 //x=23.42 //y=1.44 //x2=23.495 //y2=1.095
cc_1722 ( N_noxref_7_c_2451_p N_Q_M14_noxref_d ) capacitor c=0.0020782f \
 //x=23.795 //y=0.94 //x2=23.495 //y2=1.095
cc_1723 ( N_noxref_7_c_2452_p N_Q_M14_noxref_d ) capacitor c=0.00356097f \
 //x=23.795 //y=1.595 //x2=23.495 //y2=1.095
cc_1724 ( N_noxref_7_c_2453_p N_Q_M14_noxref_d ) capacitor c=0.00139206f \
 //x=23.95 //y=1.095 //x2=23.495 //y2=1.095
cc_1725 ( N_noxref_7_c_2454_p N_Q_M14_noxref_d ) capacitor c=0.00237422f \
 //x=23.95 //y=1.44 //x2=23.495 //y2=1.095
cc_1726 ( N_noxref_7_c_2081_n N_VDD_c_2903_n ) capacitor c=0.00648297f \
 //x=15.435 //y=5.38 //x2=24.17 //y2=7.58
cc_1727 ( N_noxref_7_c_2169_n N_VDD_c_2903_n ) capacitor c=0.00492578f \
 //x=15.945 //y=5.38 //x2=24.17 //y2=7.58
cc_1728 ( N_noxref_7_c_2177_n N_VDD_c_2903_n ) capacitor c=2.03815e-19 \
 //x=16.03 //y=4.025 //x2=24.17 //y2=7.58
cc_1729 ( N_noxref_7_c_2090_n N_VDD_c_2903_n ) capacitor c=0.00368834f \
 //x=14.67 //y=5.56 //x2=24.17 //y2=7.58
cc_1730 ( N_noxref_7_c_2186_n N_VDD_c_2903_n ) capacitor c=8.42537e-19 \
 //x=15.55 //y=5.38 //x2=24.17 //y2=7.58
cc_1731 ( N_noxref_7_c_2328_n N_VDD_c_2903_n ) capacitor c=0.00285853f \
 //x=15.55 //y=5.56 //x2=24.17 //y2=7.58
cc_1732 ( N_noxref_7_c_2112_n N_VDD_c_2903_n ) capacitor c=0.00224881f \
 //x=14.67 //y=5.56 //x2=24.17 //y2=7.58
cc_1733 ( N_noxref_7_c_2212_n N_VDD_c_2903_n ) capacitor c=0.00224881f \
 //x=15.55 //y=5.56 //x2=24.17 //y2=7.58
cc_1734 ( N_noxref_7_M23_noxref_g N_VDD_c_3053_n ) capacitor c=0.00755544f \
 //x=6.89 //y=6.2 //x2=7.465 //y2=7.585
cc_1735 ( N_noxref_7_M24_noxref_g N_VDD_c_3053_n ) capacitor c=0.00755754f \
 //x=7.33 //y=6.2 //x2=7.465 //y2=7.585
cc_1736 ( N_noxref_7_M29_noxref_g N_VDD_c_2981_n ) capacitor c=0.00755544f \
 //x=11.7 //y=6.2 //x2=12.275 //y2=7.585
cc_1737 ( N_noxref_7_M30_noxref_g N_VDD_c_2981_n ) capacitor c=0.00755754f \
 //x=12.14 //y=6.2 //x2=12.275 //y2=7.585
cc_1738 ( N_noxref_7_c_2081_n N_VDD_c_2986_n ) capacitor c=0.00208087f \
 //x=15.435 //y=5.38 //x2=15.025 //y2=7.585
cc_1739 ( N_noxref_7_c_2090_n N_VDD_c_2986_n ) capacitor c=9.41185e-19 \
 //x=14.67 //y=5.56 //x2=15.025 //y2=7.585
cc_1740 ( N_noxref_7_c_2112_n N_VDD_c_2986_n ) capacitor c=0.0136705f \
 //x=14.67 //y=5.56 //x2=15.025 //y2=7.585
cc_1741 ( N_noxref_7_c_2081_n N_VDD_c_3016_n ) capacitor c=0.00180737f \
 //x=15.435 //y=5.38 //x2=15.905 //y2=7.585
cc_1742 ( N_noxref_7_c_2169_n N_VDD_c_3016_n ) capacitor c=0.00208087f \
 //x=15.945 //y=5.38 //x2=15.905 //y2=7.585
cc_1743 ( N_noxref_7_c_2186_n N_VDD_c_3016_n ) capacitor c=4.23719e-19 \
 //x=15.55 //y=5.38 //x2=15.905 //y2=7.585
cc_1744 ( N_noxref_7_c_2328_n N_VDD_c_3016_n ) capacitor c=5.77976e-19 \
 //x=15.55 //y=5.56 //x2=15.905 //y2=7.585
cc_1745 ( N_noxref_7_c_2212_n N_VDD_c_3016_n ) capacitor c=0.0136705f \
 //x=15.55 //y=5.56 //x2=15.905 //y2=7.585
cc_1746 ( N_noxref_7_M43_noxref_g N_VDD_c_3186_n ) capacitor c=0.00755544f \
 //x=23.17 //y=6.2 //x2=23.745 //y2=7.585
cc_1747 ( N_noxref_7_M44_noxref_g N_VDD_c_3186_n ) capacitor c=0.00755754f \
 //x=23.61 //y=6.2 //x2=23.745 //y2=7.585
cc_1748 ( N_noxref_7_c_2392_n N_VDD_c_3188_n ) capacitor c=0.00224736f \
 //x=23.43 //y=4.88 //x2=24.17 //y2=7.58
cc_1749 ( N_noxref_7_c_2420_n N_VDD_c_3188_n ) capacitor c=2.63786e-19 \
 //x=23.43 //y=4.88 //x2=24.17 //y2=7.58
cc_1750 ( N_noxref_7_c_2209_n N_VDD_c_2933_n ) capacitor c=0.00224736f \
 //x=7.15 //y=4.88 //x2=8.63 //y2=7.585
cc_1751 ( N_noxref_7_c_2226_n N_VDD_c_2933_n ) capacitor c=2.63786e-19 \
 //x=7.15 //y=4.88 //x2=8.63 //y2=7.585
cc_1752 ( N_noxref_7_c_2087_n N_VDD_c_2991_n ) capacitor c=0.0013228f \
 //x=16.03 //y=5.295 //x2=13.44 //y2=7.585
cc_1753 ( N_noxref_7_c_2090_n N_VDD_c_2991_n ) capacitor c=4.91377e-19 \
 //x=14.67 //y=5.56 //x2=13.44 //y2=7.585
cc_1754 ( N_noxref_7_c_2108_n N_VDD_c_2991_n ) capacitor c=0.00224736f \
 //x=11.96 //y=4.88 //x2=13.44 //y2=7.585
cc_1755 ( N_noxref_7_c_2112_n N_VDD_c_2991_n ) capacitor c=0.0064135f \
 //x=14.67 //y=5.56 //x2=13.44 //y2=7.585
cc_1756 ( N_noxref_7_c_2144_n N_VDD_c_2991_n ) capacitor c=2.63786e-19 \
 //x=11.96 //y=4.88 //x2=13.44 //y2=7.585
cc_1757 ( N_noxref_7_c_2087_n N_VDD_c_3020_n ) capacitor c=0.0303435f \
 //x=16.03 //y=5.295 //x2=16.77 //y2=7.585
cc_1758 ( N_noxref_7_c_2186_n N_VDD_c_3020_n ) capacitor c=0.00240948f \
 //x=15.55 //y=5.38 //x2=16.77 //y2=7.585
cc_1759 ( N_noxref_7_c_2328_n N_VDD_c_3020_n ) capacitor c=4.09141e-19 \
 //x=15.55 //y=5.56 //x2=16.77 //y2=7.585
cc_1760 ( N_noxref_7_c_2212_n N_VDD_c_3020_n ) capacitor c=0.0101861f \
 //x=15.55 //y=5.56 //x2=16.77 //y2=7.585
cc_1761 ( N_noxref_7_M23_noxref_g N_VDD_M22_noxref_d ) capacitor c=0.015318f \
 //x=6.89 //y=6.2 //x2=6.525 //y2=5.2
cc_1762 ( N_noxref_7_M24_noxref_g N_VDD_M24_noxref_d ) capacitor c=0.0394719f \
 //x=7.33 //y=6.2 //x2=7.405 //y2=5.2
cc_1763 ( N_noxref_7_M29_noxref_g N_VDD_M28_noxref_d ) capacitor c=0.015318f \
 //x=11.7 //y=6.2 //x2=11.335 //y2=5.2
cc_1764 ( N_noxref_7_M30_noxref_g N_VDD_M30_noxref_d ) capacitor c=0.0394719f \
 //x=12.14 //y=6.2 //x2=12.215 //y2=5.2
cc_1765 ( N_noxref_7_c_2090_n N_VDD_M31_noxref_s ) capacitor c=0.0611368f \
 //x=14.67 //y=5.56 //x2=14.095 //y2=5.2
cc_1766 ( N_noxref_7_c_2186_n N_VDD_M31_noxref_s ) capacitor c=6.52457e-19 \
 //x=15.55 //y=5.38 //x2=14.095 //y2=5.2
cc_1767 ( N_noxref_7_c_2112_n N_VDD_M31_noxref_s ) capacitor c=0.0887533f \
 //x=14.67 //y=5.56 //x2=14.095 //y2=5.2
cc_1768 ( N_noxref_7_c_2081_n N_VDD_M32_noxref_d ) capacitor c=0.00734094f \
 //x=15.435 //y=5.38 //x2=14.965 //y2=5.2
cc_1769 ( N_noxref_7_c_2090_n N_VDD_M32_noxref_d ) capacitor c=0.0043528f \
 //x=14.67 //y=5.56 //x2=14.965 //y2=5.2
cc_1770 ( N_noxref_7_c_2328_n N_VDD_M32_noxref_d ) capacitor c=0.0043528f \
 //x=15.55 //y=5.56 //x2=14.965 //y2=5.2
cc_1771 ( N_noxref_7_c_2112_n N_VDD_M32_noxref_d ) capacitor c=0.065554f \
 //x=14.67 //y=5.56 //x2=14.965 //y2=5.2
cc_1772 ( N_noxref_7_c_2212_n N_VDD_M32_noxref_d ) capacitor c=0.065554f \
 //x=15.55 //y=5.56 //x2=14.965 //y2=5.2
cc_1773 ( N_noxref_7_c_2169_n N_VDD_M34_noxref_d ) capacitor c=0.00898356f \
 //x=15.945 //y=5.38 //x2=15.845 //y2=5.2
cc_1774 ( N_noxref_7_c_2328_n N_VDD_M34_noxref_d ) capacitor c=0.00587834f \
 //x=15.55 //y=5.56 //x2=15.845 //y2=5.2
cc_1775 ( N_noxref_7_c_2197_n N_VDD_M34_noxref_d ) capacitor c=0.00122238f \
 //x=16.03 //y=3.88 //x2=15.845 //y2=5.2
cc_1776 ( N_noxref_7_c_2212_n N_VDD_M34_noxref_d ) capacitor c=0.065554f \
 //x=15.55 //y=5.56 //x2=15.845 //y2=5.2
cc_1777 ( N_noxref_7_c_2169_n N_VDD_M35_noxref_s ) capacitor c=0.00326953f \
 //x=15.945 //y=5.38 //x2=17.425 //y2=5.2
cc_1778 ( N_noxref_7_c_2186_n N_VDD_M35_noxref_s ) capacitor c=0.00515461f \
 //x=15.55 //y=5.38 //x2=17.425 //y2=5.2
cc_1779 ( N_noxref_7_c_2328_n N_VDD_M35_noxref_s ) capacitor c=3.28075e-19 \
 //x=15.55 //y=5.56 //x2=17.425 //y2=5.2
cc_1780 ( N_noxref_7_M43_noxref_g N_VDD_M42_noxref_d ) capacitor c=0.015318f \
 //x=23.17 //y=6.2 //x2=22.805 //y2=5.2
cc_1781 ( N_noxref_7_M44_noxref_g N_VDD_M44_noxref_d ) capacitor c=0.0394719f \
 //x=23.61 //y=6.2 //x2=23.685 //y2=5.2
cc_1782 ( N_noxref_7_c_2047_n N_noxref_11_c_3394_n ) capacitor c=0.00177186f \
 //x=7.15 //y=2.375 //x2=7.805 //y2=0.72
cc_1783 ( N_noxref_7_c_2205_n N_noxref_11_c_3394_n ) capacitor c=0.00117306f \
 //x=7.15 //y=2.26 //x2=7.805 //y2=0.72
cc_1784 ( N_noxref_7_c_2219_n N_noxref_11_c_3394_n ) capacitor c=0.0206349f \
 //x=7.14 //y=1.095 //x2=7.805 //y2=0.72
cc_1785 ( N_noxref_7_c_2307_n N_noxref_11_c_3394_n ) capacitor c=0.00825432f \
 //x=7.67 //y=1.095 //x2=7.805 //y2=0.72
cc_1786 ( N_noxref_7_c_2222_n N_noxref_11_c_3394_n ) capacitor c=2.20712e-19 \
 //x=7.15 //y=2.26 //x2=7.805 //y2=0.72
cc_1787 ( N_noxref_7_c_2220_n N_noxref_11_c_3416_n ) capacitor c=0.0071177f \
 //x=7.14 //y=1.44 //x2=6.92 //y2=1.175
cc_1788 ( N_noxref_7_c_2219_n N_noxref_11_M4_noxref_s ) capacitor c=0.0071177f \
 //x=7.14 //y=1.095 //x2=6.785 //y2=0.555
cc_1789 ( N_noxref_7_c_2221_n N_noxref_11_M4_noxref_s ) capacitor c=0.0071177f \
 //x=7.14 //y=1.75 //x2=6.785 //y2=0.555
cc_1790 ( N_noxref_7_c_2307_n N_noxref_11_M4_noxref_s ) capacitor c=0.015333f \
 //x=7.67 //y=1.095 //x2=6.785 //y2=0.555
cc_1791 ( N_noxref_7_c_2309_n N_noxref_11_M4_noxref_s ) capacitor \
 c=0.00248746f //x=7.67 //y=1.44 //x2=6.785 //y2=0.555
cc_1792 ( N_noxref_7_c_2065_n N_noxref_12_c_3462_n ) capacitor c=0.00177186f \
 //x=11.96 //y=2.375 //x2=12.615 //y2=0.72
cc_1793 ( N_noxref_7_c_2107_n N_noxref_12_c_3462_n ) capacitor c=0.00117306f \
 //x=11.96 //y=2.26 //x2=12.615 //y2=0.72
cc_1794 ( N_noxref_7_c_2123_n N_noxref_12_c_3462_n ) capacitor c=0.0206349f \
 //x=11.95 //y=1.095 //x2=12.615 //y2=0.72
cc_1795 ( N_noxref_7_c_2135_n N_noxref_12_c_3462_n ) capacitor c=0.00825432f \
 //x=12.48 //y=1.095 //x2=12.615 //y2=0.72
cc_1796 ( N_noxref_7_c_2141_n N_noxref_12_c_3462_n ) capacitor c=2.20712e-19 \
 //x=11.96 //y=2.26 //x2=12.615 //y2=0.72
cc_1797 ( N_noxref_7_c_2125_n N_noxref_12_c_3465_n ) capacitor c=0.0071177f \
 //x=11.95 //y=1.44 //x2=11.73 //y2=1.175
cc_1798 ( N_noxref_7_c_2073_n N_noxref_12_M7_noxref_s ) capacitor \
 c=9.75621e-19 //x=11.96 //y=4.025 //x2=11.595 //y2=0.555
cc_1799 ( N_noxref_7_c_2123_n N_noxref_12_M7_noxref_s ) capacitor c=0.0071177f \
 //x=11.95 //y=1.095 //x2=11.595 //y2=0.555
cc_1800 ( N_noxref_7_c_2128_n N_noxref_12_M7_noxref_s ) capacitor c=0.0071177f \
 //x=11.95 //y=1.75 //x2=11.595 //y2=0.555
cc_1801 ( N_noxref_7_c_2135_n N_noxref_12_M7_noxref_s ) capacitor c=0.015333f \
 //x=12.48 //y=1.095 //x2=11.595 //y2=0.555
cc_1802 ( N_noxref_7_c_2137_n N_noxref_12_M7_noxref_s ) capacitor \
 c=0.00248746f //x=12.48 //y=1.44 //x2=11.595 //y2=0.555
cc_1803 ( N_noxref_7_c_2047_n N_GND_c_3651_n ) capacitor c=0.0021992f //x=7.15 \
 //y=2.375 //x2=9.62 //y2=0.175
cc_1804 ( N_noxref_7_c_2065_n N_GND_c_3609_n ) capacitor c=0.00196498f \
 //x=11.96 //y=2.375 //x2=14.535 //y2=0.175
cc_1805 ( N_noxref_7_c_2170_n N_GND_c_3652_n ) capacitor c=0.00608539f \
 //x=15.945 //y=1.835 //x2=17.865 //y2=0.175
cc_1806 ( N_noxref_7_c_2098_n N_GND_c_3652_n ) capacitor c=0.00915339f \
 //x=15.59 //y=1.18 //x2=17.865 //y2=0.175
cc_1807 ( N_noxref_7_M9_noxref_d N_GND_c_3652_n ) capacitor c=3.01769e-19 \
 //x=15.4 //y=1.085 //x2=17.865 //y2=0.175
cc_1808 ( N_noxref_7_c_2356_n N_GND_c_3742_n ) capacitor c=0.0021992f \
 //x=23.43 //y=2.375 //x2=24.17 //y2=0.18
cc_1809 ( N_noxref_7_c_2363_n N_GND_c_3742_n ) capacitor c=2.73939e-19 \
 //x=23.43 //y=4.045 //x2=24.17 //y2=0.18
cc_1810 ( N_noxref_7_c_2090_n N_GND_c_3613_n ) capacitor c=7.42819e-19 \
 //x=14.67 //y=5.56 //x2=14.62 //y2=1.135
cc_1811 ( N_noxref_7_c_2098_n N_GND_c_3613_n ) capacitor c=0.0140211f \
 //x=15.59 //y=1.18 //x2=14.62 //y2=1.135
cc_1812 ( N_noxref_7_M9_noxref_d N_GND_c_3613_n ) capacitor c=2.93544e-19 \
 //x=15.4 //y=1.085 //x2=14.62 //y2=1.135
cc_1813 ( N_noxref_7_c_2098_n N_GND_c_3663_n ) capacitor c=0.00549186f \
 //x=15.59 //y=1.18 //x2=17.95 //y2=1.135
cc_1814 ( N_noxref_7_c_2047_n N_GND_c_3572_n ) capacitor c=2.016e-19 //x=7.15 \
 //y=2.375 //x2=8.46 //y2=0.175
cc_1815 ( N_noxref_7_c_2065_n N_GND_c_3573_n ) capacitor c=2.016e-19 //x=11.96 \
 //y=2.375 //x2=13.27 //y2=0.175
cc_1816 ( N_noxref_7_c_2170_n N_GND_c_3629_n ) capacitor c=7.77585e-19 \
 //x=15.945 //y=1.835 //x2=16.6 //y2=0.175
cc_1817 ( N_noxref_7_c_2356_n N_GND_c_3719_n ) capacitor c=2.016e-19 //x=23.43 \
 //y=2.375 //x2=24.17 //y2=0.18
cc_1818 ( N_noxref_7_c_2389_n N_GND_c_3719_n ) capacitor c=0.00239899f \
 //x=23.43 //y=2.26 //x2=24.17 //y2=0.18
cc_1819 ( N_noxref_7_c_2454_p N_GND_c_3719_n ) capacitor c=0.00275764f \
 //x=23.95 //y=1.44 //x2=24.17 //y2=0.18
cc_1820 ( N_noxref_7_c_2416_n N_GND_c_3719_n ) capacitor c=2.63786e-19 \
 //x=23.43 //y=2.26 //x2=24.17 //y2=0.18
cc_1821 ( N_noxref_7_c_2060_n N_GND_c_3586_n ) capacitor c=0.00276652f \
 //x=12.12 //y=3.88 //x2=8.63 //y2=0.175
cc_1822 ( N_noxref_7_c_2205_n N_GND_c_3586_n ) capacitor c=0.00239899f \
 //x=7.15 //y=2.26 //x2=8.63 //y2=0.175
cc_1823 ( N_noxref_7_c_2309_n N_GND_c_3586_n ) capacitor c=0.00262688f \
 //x=7.67 //y=1.44 //x2=8.63 //y2=0.175
cc_1824 ( N_noxref_7_c_2222_n N_GND_c_3586_n ) capacitor c=2.63786e-19 \
 //x=7.15 //y=2.26 //x2=8.63 //y2=0.175
cc_1825 ( N_noxref_7_c_2084_n N_GND_c_3630_n ) capacitor c=9.32616e-19 \
 //x=16.03 //y=3.705 //x2=13.44 //y2=0.175
cc_1826 ( N_noxref_7_c_2100_n N_GND_c_3630_n ) capacitor c=0.00276652f \
 //x=15.865 //y=3.865 //x2=13.44 //y2=0.175
cc_1827 ( N_noxref_7_c_2107_n N_GND_c_3630_n ) capacitor c=0.00222376f \
 //x=11.96 //y=2.26 //x2=13.44 //y2=0.175
cc_1828 ( N_noxref_7_c_2137_n N_GND_c_3630_n ) capacitor c=0.00262688f \
 //x=12.48 //y=1.44 //x2=13.44 //y2=0.175
cc_1829 ( N_noxref_7_c_2141_n N_GND_c_3630_n ) capacitor c=2.63786e-19 \
 //x=11.96 //y=2.26 //x2=13.44 //y2=0.175
cc_1830 ( N_noxref_7_c_2082_n N_GND_c_3643_n ) capacitor c=0.002973f //x=15.59 \
 //y=1.75 //x2=16.77 //y2=0.175
cc_1831 ( N_noxref_7_c_2170_n N_GND_c_3643_n ) capacitor c=0.028425f \
 //x=15.945 //y=1.835 //x2=16.77 //y2=0.175
cc_1832 ( N_noxref_7_c_2280_n N_GND_c_3643_n ) capacitor c=0.00307724f \
 //x=23.27 //y=3.885 //x2=16.77 //y2=0.175
cc_1833 ( N_noxref_7_c_2098_n N_GND_M8_noxref_d ) capacitor c=2.82748e-19 \
 //x=15.59 //y=1.18 //x2=14.43 //y2=1.045
cc_1834 ( N_noxref_7_c_2356_n N_noxref_14_c_4018_n ) capacitor c=0.00177186f \
 //x=23.43 //y=2.375 //x2=24.085 //y2=0.72
cc_1835 ( N_noxref_7_c_2389_n N_noxref_14_c_4018_n ) capacitor c=0.00117306f \
 //x=23.43 //y=2.26 //x2=24.085 //y2=0.72
cc_1836 ( N_noxref_7_c_2405_n N_noxref_14_c_4018_n ) capacitor c=0.0206349f \
 //x=23.42 //y=1.095 //x2=24.085 //y2=0.72
cc_1837 ( N_noxref_7_c_2453_p N_noxref_14_c_4018_n ) capacitor c=0.00825432f \
 //x=23.95 //y=1.095 //x2=24.085 //y2=0.72
cc_1838 ( N_noxref_7_c_2416_n N_noxref_14_c_4018_n ) capacitor c=2.20712e-19 \
 //x=23.43 //y=2.26 //x2=24.085 //y2=0.72
cc_1839 ( N_noxref_7_c_2406_n N_noxref_14_c_4023_n ) capacitor c=0.0071177f \
 //x=23.42 //y=1.44 //x2=23.2 //y2=1.175
cc_1840 ( N_noxref_7_c_2363_n N_noxref_14_M14_noxref_s ) capacitor \
 c=9.72448e-19 //x=23.43 //y=4.045 //x2=23.065 //y2=0.555
cc_1841 ( N_noxref_7_c_2280_n N_noxref_14_M14_noxref_s ) capacitor \
 c=6.25077e-19 //x=23.27 //y=3.885 //x2=23.065 //y2=0.555
cc_1842 ( N_noxref_7_c_2405_n N_noxref_14_M14_noxref_s ) capacitor \
 c=0.0071177f //x=23.42 //y=1.095 //x2=23.065 //y2=0.555
cc_1843 ( N_noxref_7_c_2407_n N_noxref_14_M14_noxref_s ) capacitor \
 c=0.0071177f //x=23.42 //y=1.75 //x2=23.065 //y2=0.555
cc_1844 ( N_noxref_7_c_2453_p N_noxref_14_M14_noxref_s ) capacitor c=0.015333f \
 //x=23.95 //y=1.095 //x2=23.065 //y2=0.555
cc_1845 ( N_noxref_7_c_2454_p N_noxref_14_M14_noxref_s ) capacitor \
 c=0.00248746f //x=23.95 //y=1.44 //x2=23.065 //y2=0.555
cc_1846 ( N_noxref_7_c_2060_n N_noxref_17_c_4186_n ) capacitor c=0.00281558f \
 //x=12.12 //y=3.88 //x2=10.105 //y2=1.77
cc_1847 ( N_noxref_7_c_2060_n N_noxref_17_c_4200_n ) capacitor c=0.00475991f \
 //x=12.12 //y=3.88 //x2=11.075 //y2=1.77
cc_1848 ( N_noxref_7_c_2060_n N_noxref_17_M5_noxref_s ) capacitor \
 c=0.00212526f //x=12.12 //y=3.88 //x2=9.085 //y2=0.555
cc_1849 ( N_noxref_7_c_2083_n N_noxref_18_c_4252_n ) capacitor c=0.00911405f \
 //x=15.675 //y=1.835 //x2=15.105 //y2=1.675
cc_1850 ( N_noxref_7_c_2170_n N_noxref_18_c_4259_n ) capacitor c=0.00399245f \
 //x=15.945 //y=1.835 //x2=15.99 //y2=0.71
cc_1851 ( N_noxref_7_c_2098_n N_noxref_18_c_4259_n ) capacitor c=0.003751f \
 //x=15.59 //y=1.18 //x2=15.99 //y2=0.71
cc_1852 ( N_noxref_7_M9_noxref_d N_noxref_18_c_4259_n ) capacitor \
 c=0.00910163f //x=15.4 //y=1.085 //x2=15.99 //y2=0.71
cc_1853 ( N_noxref_7_c_2082_n N_noxref_18_M8_noxref_s ) capacitor c=0.01625f \
 //x=15.59 //y=1.75 //x2=14 //y2=0.545
cc_1854 ( N_noxref_7_c_2170_n N_noxref_18_M8_noxref_s ) capacitor \
 c=0.00670006f //x=15.945 //y=1.835 //x2=14 //y2=0.545
cc_1855 ( N_noxref_7_c_2177_n N_noxref_18_M8_noxref_s ) capacitor \
 c=3.24398e-19 //x=16.03 //y=4.025 //x2=14 //y2=0.545
cc_1856 ( N_noxref_7_c_2098_n N_noxref_18_M8_noxref_s ) capacitor \
 c=0.00905337f //x=15.59 //y=1.18 //x2=14 //y2=0.545
cc_1857 ( N_noxref_7_c_2197_n N_noxref_18_M8_noxref_s ) capacitor \
 c=8.42257e-19 //x=16.03 //y=3.88 //x2=14 //y2=0.545
cc_1858 ( N_noxref_7_M9_noxref_d N_noxref_18_M8_noxref_s ) capacitor \
 c=0.0275552f //x=15.4 //y=1.085 //x2=14 //y2=0.545
cc_1859 ( N_noxref_7_c_2280_n N_noxref_20_c_4396_n ) capacitor c=9.46934e-19 \
 //x=23.27 //y=3.885 //x2=22.545 //y2=1.77
cc_1860 ( N_noxref_7_c_2280_n N_noxref_20_M12_noxref_s ) capacitor \
 c=0.0020282f //x=23.27 //y=3.885 //x2=20.555 //y2=0.555
cc_1861 ( Q N_VDD_c_2903_n ) capacitor c=3.94104e-19 //x=24.17 //y=4.25 \
 //x2=24.17 //y2=7.58
cc_1862 ( N_Q_c_2680_n N_VDD_c_2903_n ) capacitor c=0.00621363f //x=22.39 \
 //y=5.335 //x2=24.17 //y2=7.58
cc_1863 ( N_Q_c_2743_n N_VDD_c_2903_n ) capacitor c=0.00627186f //x=23.275 \
 //y=5.335 //x2=24.17 //y2=7.58
cc_1864 ( N_Q_c_2777_n N_VDD_c_2903_n ) capacitor c=0.00256019f //x=23.39 \
 //y=5.56 //x2=24.17 //y2=7.58
cc_1865 ( N_Q_c_2779_n N_VDD_c_2903_n ) capacitor c=0.00829214f //x=24.085 \
 //y=5.335 //x2=24.17 //y2=7.58
cc_1866 ( N_Q_c_2796_n N_VDD_c_2903_n ) capacitor c=2.1563e-19 //x=24.17 \
 //y=4.425 //x2=24.17 //y2=7.58
cc_1867 ( N_Q_c_2684_n N_VDD_c_2903_n ) capacitor c=0.00261804f //x=21.632 \
 //y=5.335 //x2=24.17 //y2=7.58
cc_1868 ( N_Q_c_2745_n N_VDD_c_2903_n ) capacitor c=0.00270108f //x=22.51 \
 //y=5.335 //x2=24.17 //y2=7.58
cc_1869 ( N_Q_c_2700_n N_VDD_c_2903_n ) capacitor c=0.0024232f //x=21.63 \
 //y=5.56 //x2=24.17 //y2=7.58
cc_1870 ( N_Q_c_2754_n N_VDD_c_2903_n ) capacitor c=0.0024232f //x=22.51 \
 //y=5.56 //x2=24.17 //y2=7.58
cc_1871 ( N_Q_c_2807_n N_VDD_c_2903_n ) capacitor c=0.0024232f //x=23.39 \
 //y=5.56 //x2=24.17 //y2=7.58
cc_1872 ( N_Q_M37_noxref_g N_VDD_c_3119_n ) capacitor c=0.00697352f //x=18.66 \
 //y=6.2 //x2=19.235 //y2=7.585
cc_1873 ( N_Q_M38_noxref_g N_VDD_c_3119_n ) capacitor c=0.00755544f //x=19.1 \
 //y=6.2 //x2=19.235 //y2=7.585
cc_1874 ( N_Q_c_2680_n N_VDD_c_3124_n ) capacitor c=0.00202922f //x=22.39 \
 //y=5.335 //x2=21.985 //y2=7.585
cc_1875 ( N_Q_c_2684_n N_VDD_c_3124_n ) capacitor c=9.3757e-19 //x=21.632 \
 //y=5.335 //x2=21.985 //y2=7.585
cc_1876 ( N_Q_c_2700_n N_VDD_c_3124_n ) capacitor c=0.0138074f //x=21.63 \
 //y=5.56 //x2=21.985 //y2=7.585
cc_1877 ( N_Q_c_2680_n N_VDD_c_3160_n ) capacitor c=0.0017708f //x=22.39 \
 //y=5.335 //x2=22.865 //y2=7.585
cc_1878 ( N_Q_c_2743_n N_VDD_c_3160_n ) capacitor c=0.00202922f //x=23.275 \
 //y=5.335 //x2=22.865 //y2=7.585
cc_1879 ( N_Q_c_2745_n N_VDD_c_3160_n ) capacitor c=9.4822e-19 //x=22.51 \
 //y=5.335 //x2=22.865 //y2=7.585
cc_1880 ( N_Q_c_2754_n N_VDD_c_3160_n ) capacitor c=0.0138074f //x=22.51 \
 //y=5.56 //x2=22.865 //y2=7.585
cc_1881 ( N_Q_c_2743_n N_VDD_c_3186_n ) capacitor c=0.00205906f //x=23.275 \
 //y=5.335 //x2=23.745 //y2=7.585
cc_1882 ( N_Q_c_2777_n N_VDD_c_3186_n ) capacitor c=8.49654e-19 //x=23.39 \
 //y=5.56 //x2=23.745 //y2=7.585
cc_1883 ( N_Q_c_2779_n N_VDD_c_3186_n ) capacitor c=0.00204238f //x=24.085 \
 //y=5.335 //x2=23.745 //y2=7.585
cc_1884 ( N_Q_c_2807_n N_VDD_c_3186_n ) capacitor c=0.0135103f //x=23.39 \
 //y=5.56 //x2=23.745 //y2=7.585
cc_1885 ( Q N_VDD_c_3188_n ) capacitor c=0.0341648f //x=24.17 //y=4.62 \
 //x2=24.17 //y2=7.58
cc_1886 ( Q N_VDD_c_3188_n ) capacitor c=0.00461706f //x=24.17 //y=4.25 \
 //x2=24.17 //y2=7.58
cc_1887 ( N_Q_c_2777_n N_VDD_c_3188_n ) capacitor c=0.00414616f //x=23.39 \
 //y=5.56 //x2=24.17 //y2=7.58
cc_1888 ( N_Q_c_2779_n N_VDD_c_3188_n ) capacitor c=0.00157252f //x=24.085 \
 //y=5.335 //x2=24.17 //y2=7.58
cc_1889 ( N_Q_c_2796_n N_VDD_c_3188_n ) capacitor c=0.00306025f //x=24.17 \
 //y=4.425 //x2=24.17 //y2=7.58
cc_1890 ( N_Q_c_2807_n N_VDD_c_3188_n ) capacitor c=0.00778106f //x=23.39 \
 //y=5.56 //x2=24.17 //y2=7.58
cc_1891 ( Q N_VDD_c_3129_n ) capacitor c=0.00133985f //x=18.62 //y=4.25 \
 //x2=20.1 //y2=7.585
cc_1892 ( N_Q_c_2684_n N_VDD_c_3129_n ) capacitor c=0.0022955f //x=21.632 \
 //y=5.335 //x2=20.1 //y2=7.585
cc_1893 ( N_Q_c_2689_n N_VDD_c_3129_n ) capacitor c=0.0195415f //x=23.045 \
 //y=4.25 //x2=20.1 //y2=7.585
cc_1894 ( N_Q_c_2641_n N_VDD_c_3129_n ) capacitor c=0.00226427f //x=18.65 \
 //y=4.88 //x2=20.1 //y2=7.585
cc_1895 ( N_Q_c_2700_n N_VDD_c_3129_n ) capacitor c=0.00508013f //x=21.63 \
 //y=5.56 //x2=20.1 //y2=7.585
cc_1896 ( N_Q_c_2715_n N_VDD_c_3129_n ) capacitor c=0.0129149f //x=19.025 \
 //y=4.97 //x2=20.1 //y2=7.585
cc_1897 ( N_Q_c_2660_n N_VDD_c_3129_n ) capacitor c=2.73429e-19 //x=18.65 \
 //y=4.88 //x2=20.1 //y2=7.585
cc_1898 ( N_Q_c_2684_n N_VDD_M35_noxref_s ) capacitor c=4.22189e-19 //x=21.632 \
 //y=5.335 //x2=17.425 //y2=5.2
cc_1899 ( N_Q_M37_noxref_g N_VDD_M36_noxref_d ) capacitor c=0.015318f \
 //x=18.66 //y=6.2 //x2=18.295 //y2=5.2
cc_1900 ( N_Q_c_2660_n N_VDD_M36_noxref_d ) capacitor c=3.50465e-19 //x=18.65 \
 //y=4.88 //x2=18.295 //y2=5.2
cc_1901 ( N_Q_M38_noxref_g N_VDD_M38_noxref_d ) capacitor c=0.0430452f \
 //x=19.1 //y=6.2 //x2=19.175 //y2=5.2
cc_1902 ( N_Q_c_2684_n N_VDD_M39_noxref_s ) capacitor c=0.0442713f //x=21.632 \
 //y=5.335 //x2=21.055 //y2=5.2
cc_1903 ( N_Q_c_2745_n N_VDD_M39_noxref_s ) capacitor c=7.80122e-19 //x=22.51 \
 //y=5.335 //x2=21.055 //y2=5.2
cc_1904 ( N_Q_c_2689_n N_VDD_M39_noxref_s ) capacitor c=5.83367e-19 //x=23.045 \
 //y=4.25 //x2=21.055 //y2=5.2
cc_1905 ( N_Q_c_2700_n N_VDD_M39_noxref_s ) capacitor c=0.0908457f //x=21.63 \
 //y=5.56 //x2=21.055 //y2=5.2
cc_1906 ( N_Q_c_2680_n N_VDD_M40_noxref_d ) capacitor c=0.00700141f //x=22.39 \
 //y=5.335 //x2=21.925 //y2=5.2
cc_1907 ( N_Q_c_2700_n N_VDD_M40_noxref_d ) capacitor c=0.0673792f //x=21.63 \
 //y=5.56 //x2=21.925 //y2=5.2
cc_1908 ( N_Q_c_2754_n N_VDD_M40_noxref_d ) capacitor c=0.0674762f //x=22.51 \
 //y=5.56 //x2=21.925 //y2=5.2
cc_1909 ( N_Q_c_2743_n N_VDD_M42_noxref_d ) capacitor c=0.00700141f //x=23.275 \
 //y=5.335 //x2=22.805 //y2=5.2
cc_1910 ( N_Q_c_2754_n N_VDD_M42_noxref_d ) capacitor c=0.067493f //x=22.51 \
 //y=5.56 //x2=22.805 //y2=5.2
cc_1911 ( N_Q_c_2807_n N_VDD_M42_noxref_d ) capacitor c=0.0675031f //x=23.39 \
 //y=5.56 //x2=22.805 //y2=5.2
cc_1912 ( N_Q_c_2779_n N_VDD_M44_noxref_d ) capacitor c=0.00700141f //x=24.085 \
 //y=5.335 //x2=23.685 //y2=5.2
cc_1913 ( N_Q_c_2807_n N_VDD_M44_noxref_d ) capacitor c=0.0675091f //x=23.39 \
 //y=5.56 //x2=23.685 //y2=5.2
cc_1914 ( N_Q_c_2632_n N_GND_c_3696_n ) capacitor c=0.00210951f //x=18.62 \
 //y=2.26 //x2=21.09 //y2=0.175
cc_1915 ( N_Q_c_2783_n N_GND_c_3742_n ) capacitor c=0.00901861f //x=23.685 \
 //y=1.305 //x2=24.17 //y2=0.18
cc_1916 ( N_Q_c_2794_n N_GND_c_3742_n ) capacitor c=0.00713708f //x=24.085 \
 //y=1.845 //x2=24.17 //y2=0.18
cc_1917 ( N_Q_M14_noxref_d N_GND_c_3742_n ) capacitor c=2.9462e-19 //x=23.495 \
 //y=1.095 //x2=24.17 //y2=0.18
cc_1918 ( N_Q_c_2632_n N_GND_c_3677_n ) capacitor c=3.77328e-19 //x=18.62 \
 //y=2.26 //x2=19.93 //y2=0.175
cc_1919 ( N_Q_c_2681_n N_GND_c_3719_n ) capacitor c=0.00518727f //x=23.685 \
 //y=1.76 //x2=24.17 //y2=0.18
cc_1920 ( N_Q_c_2794_n N_GND_c_3719_n ) capacitor c=0.0393259f //x=24.085 \
 //y=1.845 //x2=24.17 //y2=0.18
cc_1921 ( N_Q_c_2637_n N_GND_c_3721_n ) capacitor c=0.00207214f //x=18.62 \
 //y=2.26 //x2=20.1 //y2=0.175
cc_1922 ( N_Q_c_2656_n N_GND_c_3721_n ) capacitor c=0.00275184f //x=19.185 \
 //y=1.43 //x2=20.1 //y2=0.175
cc_1923 ( N_Q_c_2783_n N_noxref_14_c_4018_n ) capacitor c=0.00366459f \
 //x=23.685 //y=1.305 //x2=24.085 //y2=0.72
cc_1924 ( N_Q_c_2794_n N_noxref_14_c_4018_n ) capacitor c=0.00366757f \
 //x=24.085 //y=1.845 //x2=24.085 //y2=0.72
cc_1925 ( N_Q_M14_noxref_d N_noxref_14_c_4018_n ) capacitor c=0.00910163f \
 //x=23.495 //y=1.095 //x2=24.085 //y2=0.72
cc_1926 ( N_Q_M14_noxref_d N_noxref_14_c_4023_n ) capacitor c=0.00120711f \
 //x=23.495 //y=1.095 //x2=23.2 //y2=1.175
cc_1927 ( N_Q_c_2680_n N_noxref_14_M13_noxref_d ) capacitor c=0.00128567f \
 //x=22.39 //y=5.335 //x2=21.96 //y2=1.09
cc_1928 ( N_Q_c_2783_n N_noxref_14_M13_noxref_d ) capacitor c=0.00803465f \
 //x=23.685 //y=1.305 //x2=21.96 //y2=1.09
cc_1929 ( Q N_noxref_14_M14_noxref_s ) capacitor c=0.00108527f //x=24.17 \
 //y=4.25 //x2=23.065 //y2=0.555
cc_1930 ( N_Q_c_2783_n N_noxref_14_M14_noxref_s ) capacitor c=0.011355f \
 //x=23.685 //y=1.305 //x2=23.065 //y2=0.555
cc_1931 ( N_Q_c_2681_n N_noxref_14_M14_noxref_s ) capacitor c=0.0283111f \
 //x=23.685 //y=1.76 //x2=23.065 //y2=0.555
cc_1932 ( N_Q_c_2794_n N_noxref_14_M14_noxref_s ) capacitor c=0.00942148f \
 //x=24.085 //y=1.845 //x2=23.065 //y2=0.555
cc_1933 ( N_Q_M14_noxref_d N_noxref_14_M14_noxref_s ) capacitor c=0.0279003f \
 //x=23.495 //y=1.095 //x2=23.065 //y2=0.555
cc_1934 ( N_Q_c_2626_n N_noxref_19_c_4319_n ) capacitor c=3.19639e-19 \
 //x=18.62 //y=4.425 //x2=18.435 //y2=1.675
cc_1935 ( N_Q_c_2632_n N_noxref_19_c_4319_n ) capacitor c=7.50092e-19 \
 //x=18.62 //y=2.26 //x2=18.435 //y2=1.675
cc_1936 ( N_Q_c_2652_n N_noxref_19_c_4319_n ) capacitor c=0.00888238f \
 //x=18.655 //y=1.74 //x2=18.435 //y2=1.675
cc_1937 ( N_Q_c_2657_n N_noxref_19_c_4319_n ) capacitor c=0.00175171f \
 //x=18.62 //y=2.26 //x2=18.435 //y2=1.675
cc_1938 ( N_Q_c_2632_n N_noxref_19_c_4324_n ) capacitor c=0.001463f //x=18.62 \
 //y=2.26 //x2=19.32 //y2=0.71
cc_1939 ( N_Q_c_2637_n N_noxref_19_c_4324_n ) capacitor c=8.82141e-19 \
 //x=18.62 //y=2.26 //x2=19.32 //y2=0.71
cc_1940 ( N_Q_c_2647_n N_noxref_19_c_4324_n ) capacitor c=0.0200738f \
 //x=18.655 //y=1.085 //x2=19.32 //y2=0.71
cc_1941 ( N_Q_c_2655_n N_noxref_19_c_4324_n ) capacitor c=0.00825432f \
 //x=19.185 //y=1.085 //x2=19.32 //y2=0.71
cc_1942 ( N_Q_c_2657_n N_noxref_19_c_4324_n ) capacitor c=2.1838e-19 //x=18.62 \
 //y=2.26 //x2=19.32 //y2=0.71
cc_1943 ( N_Q_c_2647_n N_noxref_19_M10_noxref_s ) capacitor c=0.00888238f \
 //x=18.655 //y=1.085 //x2=17.33 //y2=0.545
cc_1944 ( N_Q_c_2655_n N_noxref_19_M10_noxref_s ) capacitor c=0.015333f \
 //x=19.185 //y=1.085 //x2=17.33 //y2=0.545
cc_1945 ( N_Q_c_2656_n N_noxref_19_M10_noxref_s ) capacitor c=0.00248746f \
 //x=19.185 //y=1.43 //x2=17.33 //y2=0.545
cc_1946 ( N_VDD_c_2922_n D ) capacitor c=0.00998287f //x=1.23 //y=7.58 \
 //x2=1.6 //y2=2.77
cc_1947 ( N_VDD_c_2903_n N_D_c_3295_n ) capacitor c=9.07241e-19 //x=24.17 \
 //y=7.58 //x2=1.6 //y2=4.88
cc_1948 ( N_VDD_c_2910_n N_D_c_3295_n ) capacitor c=6.28113e-19 //x=2.075 \
 //y=7.585 //x2=1.6 //y2=4.88
cc_1949 ( N_VDD_c_2922_n N_D_c_3295_n ) capacitor c=0.00867681f //x=1.23 \
 //y=7.58 //x2=1.6 //y2=4.88
cc_1950 ( N_VDD_c_2903_n N_D_c_3297_n ) capacitor c=6.22888e-19 //x=24.17 \
 //y=7.58 //x2=1.6 //y2=4.88
cc_1951 ( N_VDD_c_2922_n N_D_c_3297_n ) capacitor c=0.00370735f //x=1.23 \
 //y=7.58 //x2=1.6 //y2=4.88
cc_1952 ( N_VDD_c_2910_n N_D_M15_noxref_g ) capacitor c=0.00732618f //x=2.075 \
 //y=7.585 //x2=1.5 //y2=6.2
cc_1953 ( N_VDD_M15_noxref_s N_D_M15_noxref_g ) capacitor c=0.0567929f \
 //x=1.145 //y=5.2 //x2=1.5 //y2=6.2
cc_1954 ( N_VDD_c_2910_n N_D_M16_noxref_g ) capacitor c=0.00755544f //x=2.075 \
 //y=7.585 //x2=1.94 //y2=6.2
cc_1955 ( N_VDD_M16_noxref_d N_D_M16_noxref_g ) capacitor c=0.015318f \
 //x=2.015 //y=5.2 //x2=1.94 //y2=6.2
cc_1956 ( N_VDD_c_2922_n N_D_c_3304_n ) capacitor c=0.0234764f //x=1.23 \
 //y=7.58 //x2=1.6 //y2=4.88
cc_1957 ( N_VDD_c_2922_n N_GND_c_3570_n ) capacitor c=0.00989514f //x=1.23 \
 //y=7.58 //x2=1.23 //y2=0.18
cc_1958 ( N_VDD_c_3188_n N_GND_c_3719_n ) capacitor c=0.00989514f //x=24.17 \
 //y=7.58 //x2=24.17 //y2=0.18
cc_1959 ( N_VDD_c_2925_n N_GND_c_3574_n ) capacitor c=0.00680738f //x=3.82 \
 //y=7.585 //x2=3.82 //y2=0.175
cc_1960 ( N_VDD_c_2933_n N_GND_c_3586_n ) capacitor c=0.00663779f //x=8.63 \
 //y=7.585 //x2=8.63 //y2=0.175
cc_1961 ( N_VDD_c_2991_n N_GND_c_3630_n ) capacitor c=0.00663779f //x=13.44 \
 //y=7.585 //x2=13.44 //y2=0.175
cc_1962 ( N_VDD_c_3020_n N_GND_c_3643_n ) capacitor c=0.00663779f //x=16.77 \
 //y=7.585 //x2=16.77 //y2=0.175
cc_1963 ( N_VDD_c_3129_n N_GND_c_3721_n ) capacitor c=0.00648088f //x=20.1 \
 //y=7.585 //x2=20.1 //y2=0.175
cc_1964 ( N_D_c_3313_n N_GND_c_3798_n ) capacitor c=6.6172e-19 //x=1.6 \
 //y=2.26 //x2=1.585 //y2=0.175
cc_1965 ( N_D_c_3313_n N_GND_c_3542_n ) capacitor c=0.00709624f //x=1.6 \
 //y=2.26 //x2=1.67 //y2=1.135
cc_1966 ( N_D_c_3319_n N_GND_c_3542_n ) capacitor c=2.13705e-19 //x=1.6 \
 //y=2.26 //x2=1.67 //y2=1.135
cc_1967 ( N_D_c_3329_n N_GND_c_3542_n ) capacitor c=0.00156094f //x=1.405 \
 //y=1.045 //x2=1.67 //y2=1.135
cc_1968 ( N_D_c_3330_n N_GND_c_3542_n ) capacitor c=0.00413828f //x=1.405 \
 //y=1.39 //x2=1.67 //y2=1.135
cc_1969 ( N_D_c_3331_n N_GND_c_3542_n ) capacitor c=4.2764e-19 //x=1.405 \
 //y=1.7 //x2=1.67 //y2=1.135
cc_1970 ( N_D_c_3362_p N_GND_c_3542_n ) capacitor c=7.35788e-19 //x=1.78 \
 //y=0.89 //x2=1.67 //y2=1.135
cc_1971 ( N_D_c_3363_p N_GND_c_3542_n ) capacitor c=6.38426e-19 //x=1.78 \
 //y=1.545 //x2=1.67 //y2=1.135
cc_1972 ( N_D_c_3337_n N_GND_c_3542_n ) capacitor c=0.00171483f //x=1.935 \
 //y=1.045 //x2=1.67 //y2=1.135
cc_1973 ( N_D_c_3339_n N_GND_c_3542_n ) capacitor c=0.00296337f //x=1.935 \
 //y=1.39 //x2=1.67 //y2=1.135
cc_1974 ( N_D_c_3329_n N_GND_c_3808_n ) capacitor c=3.51399e-19 //x=1.405 \
 //y=1.045 //x2=1.667 //y2=1.005
cc_1975 ( N_D_c_3362_p N_GND_c_3808_n ) capacitor c=0.00850983f //x=1.78 \
 //y=0.89 //x2=1.667 //y2=1.005
cc_1976 ( N_D_c_3337_n N_GND_c_3808_n ) capacitor c=4.40196e-19 //x=1.935 \
 //y=1.045 //x2=1.667 //y2=1.005
cc_1977 ( N_D_c_3329_n N_GND_c_3568_n ) capacitor c=0.00690758f //x=1.405 \
 //y=1.045 //x2=3.65 //y2=0.175
cc_1978 ( D N_GND_c_3570_n ) capacitor c=0.0113215f //x=1.6 //y=2.77 //x2=1.23 \
 //y2=0.18
cc_1979 ( N_D_c_3313_n N_GND_c_3570_n ) capacitor c=0.0082376f //x=1.6 \
 //y=2.26 //x2=1.23 //y2=0.18
cc_1980 ( N_D_c_3319_n N_GND_c_3570_n ) capacitor c=0.00369668f //x=1.6 \
 //y=2.26 //x2=1.23 //y2=0.18
cc_1981 ( N_D_c_3331_n N_GND_c_3570_n ) capacitor c=0.0015404f //x=1.405 \
 //y=1.7 //x2=1.23 //y2=0.18
cc_1982 ( N_D_c_3333_n N_GND_c_3570_n ) capacitor c=0.00950704f //x=1.405 \
 //y=2.095 //x2=1.23 //y2=0.18
cc_1983 ( N_D_c_3313_n N_GND_M0_noxref_d ) capacitor c=2.20438e-19 //x=1.6 \
 //y=2.26 //x2=1.48 //y2=1.045
cc_1984 ( N_D_c_3329_n N_GND_M0_noxref_d ) capacitor c=0.00192399f //x=1.405 \
 //y=1.045 //x2=1.48 //y2=1.045
cc_1985 ( N_D_c_3330_n N_GND_M0_noxref_d ) capacitor c=0.00210798f //x=1.405 \
 //y=1.39 //x2=1.48 //y2=1.045
cc_1986 ( N_D_c_3362_p N_GND_M0_noxref_d ) capacitor c=0.00472259f //x=1.78 \
 //y=0.89 //x2=1.48 //y2=1.045
cc_1987 ( N_D_c_3363_p N_GND_M0_noxref_d ) capacitor c=0.00166857f //x=1.78 \
 //y=1.545 //x2=1.48 //y2=1.045
cc_1988 ( N_D_c_3337_n N_GND_M0_noxref_d ) capacitor c=0.00230174f //x=1.935 \
 //y=1.045 //x2=1.48 //y2=1.045
cc_1989 ( N_D_c_3339_n N_GND_M0_noxref_d ) capacitor c=0.00210798f //x=1.935 \
 //y=1.39 //x2=1.48 //y2=1.045
cc_1990 ( N_D_c_3333_n N_noxref_15_c_4086_n ) capacitor c=0.00262672f \
 //x=1.405 //y=2.095 //x2=1.185 //y2=1.675
cc_1991 ( N_D_c_3313_n N_noxref_15_c_4087_n ) capacitor c=0.00459552f //x=1.6 \
 //y=2.26 //x2=2.07 //y2=1.76
cc_1992 ( N_D_c_3319_n N_noxref_15_c_4087_n ) capacitor c=0.00763108f //x=1.6 \
 //y=2.26 //x2=2.07 //y2=1.76
cc_1993 ( N_D_c_3331_n N_noxref_15_c_4087_n ) capacitor c=0.00695869f \
 //x=1.405 //y=1.7 //x2=2.07 //y2=1.76
cc_1994 ( N_D_c_3333_n N_noxref_15_c_4087_n ) capacitor c=0.0194861f //x=1.405 \
 //y=2.095 //x2=2.07 //y2=1.76
cc_1995 ( N_D_c_3363_p N_noxref_15_c_4087_n ) capacitor c=0.00723574f //x=1.78 \
 //y=1.545 //x2=2.07 //y2=1.76
cc_1996 ( N_D_c_3339_n N_noxref_15_c_4087_n ) capacitor c=0.00399755f \
 //x=1.935 //y=1.39 //x2=2.07 //y2=1.76
cc_1997 ( N_D_c_3333_n N_noxref_15_c_4064_n ) capacitor c=6.71402e-19 \
 //x=1.405 //y=2.095 //x2=2.155 //y2=1.675
cc_1998 ( N_D_c_3329_n N_noxref_15_M0_noxref_s ) capacitor c=0.0294925f \
 //x=1.405 //y=1.045 //x2=1.05 //y2=0.545
cc_1999 ( N_D_c_3331_n N_noxref_15_M0_noxref_s ) capacitor c=3.48408e-19 \
 //x=1.405 //y=1.7 //x2=1.05 //y2=0.545
cc_2000 ( N_D_c_3337_n N_noxref_15_M0_noxref_s ) capacitor c=0.0125442f \
 //x=1.935 //y=1.045 //x2=1.05 //y2=0.545
cc_2001 ( N_noxref_11_c_3393_n N_GND_c_3651_n ) capacitor c=0.00533679f \
 //x=6.835 //y=1.175 //x2=9.62 //y2=0.175
cc_2002 ( N_noxref_11_c_3435_p N_GND_c_3651_n ) capacitor c=0.00686435f \
 //x=6.92 //y=0.805 //x2=9.62 //y2=0.175
cc_2003 ( N_noxref_11_c_3394_n N_GND_c_3651_n ) capacitor c=0.0096072f \
 //x=7.805 //y=0.72 //x2=9.62 //y2=0.175
cc_2004 ( N_noxref_11_c_3437_p N_GND_c_3651_n ) capacitor c=0.00232964f \
 //x=7.89 //y=0.805 //x2=9.62 //y2=0.175
cc_2005 ( N_noxref_11_M3_noxref_d N_GND_c_3651_n ) capacitor c=0.0134285f \
 //x=5.68 //y=1.09 //x2=9.62 //y2=0.175
cc_2006 ( N_noxref_11_M3_noxref_d N_GND_c_3545_n ) capacitor c=0.0154456f \
 //x=5.68 //y=1.09 //x2=4.895 //y2=1.145
cc_2007 ( N_noxref_11_c_3393_n N_GND_c_3572_n ) capacitor c=0.0080792f \
 //x=6.835 //y=1.175 //x2=8.46 //y2=0.175
cc_2008 ( N_noxref_11_c_3435_p N_GND_c_3572_n ) capacitor c=0.0140604f \
 //x=6.92 //y=0.805 //x2=8.46 //y2=0.175
cc_2009 ( N_noxref_11_c_3394_n N_GND_c_3572_n ) capacitor c=0.0364637f \
 //x=7.805 //y=0.72 //x2=8.46 //y2=0.175
cc_2010 ( N_noxref_11_c_3437_p N_GND_c_3572_n ) capacitor c=0.013886f //x=7.89 \
 //y=0.805 //x2=8.46 //y2=0.175
cc_2011 ( N_noxref_11_c_3394_n N_GND_c_3719_n ) capacitor c=0.00189501f \
 //x=7.805 //y=0.72 //x2=24.17 //y2=0.18
cc_2012 ( N_noxref_11_M3_noxref_d N_GND_c_3719_n ) capacitor c=2.7648e-19 \
 //x=5.68 //y=1.09 //x2=24.17 //y2=0.18
cc_2013 ( N_noxref_11_M4_noxref_s N_GND_c_3574_n ) capacitor c=8.16352e-19 \
 //x=6.785 //y=0.555 //x2=3.82 //y2=0.175
cc_2014 ( N_noxref_11_c_3437_p N_GND_c_3586_n ) capacitor c=0.037873f //x=7.89 \
 //y=0.805 //x2=8.63 //y2=0.175
cc_2015 ( N_noxref_11_M4_noxref_s N_GND_c_3586_n ) capacitor c=0.0051897f \
 //x=6.785 //y=0.555 //x2=8.63 //y2=0.175
cc_2016 ( N_noxref_11_M3_noxref_d N_GND_M2_noxref_d ) capacitor c=3.12752e-19 \
 //x=5.68 //y=1.09 //x2=4.705 //y2=1.055
cc_2017 ( N_noxref_11_c_3435_p N_noxref_16_c_4151_n ) capacitor c=2.15937e-19 \
 //x=6.92 //y=0.805 //x2=5.38 //y2=0.805
cc_2018 ( N_noxref_11_c_3393_n N_noxref_16_c_4141_n ) capacitor c=0.0131134f \
 //x=6.835 //y=1.175 //x2=6.265 //y2=0.72
cc_2019 ( N_noxref_11_M3_noxref_d N_noxref_16_c_4141_n ) capacitor \
 c=0.0160925f //x=5.68 //y=1.09 //x2=6.265 //y2=0.72
cc_2020 ( N_noxref_11_c_3393_n N_noxref_16_c_4135_n ) capacitor c=0.00947943f \
 //x=6.835 //y=1.175 //x2=6.265 //y2=1.77
cc_2021 ( N_noxref_11_M3_noxref_d N_noxref_16_c_4135_n ) capacitor \
 c=0.0152665f //x=5.68 //y=1.09 //x2=6.265 //y2=1.77
cc_2022 ( N_noxref_11_c_3393_n N_noxref_16_M2_noxref_s ) capacitor \
 c=0.0225712f //x=6.835 //y=1.175 //x2=4.275 //y2=0.555
cc_2023 ( N_noxref_11_c_3435_p N_noxref_16_M2_noxref_s ) capacitor \
 c=0.0175461f //x=6.92 //y=0.805 //x2=4.275 //y2=0.555
cc_2024 ( N_noxref_11_c_3437_p N_noxref_16_M2_noxref_s ) capacitor \
 c=2.98576e-19 //x=7.89 //y=0.805 //x2=4.275 //y2=0.555
cc_2025 ( N_noxref_11_M3_noxref_d N_noxref_16_M2_noxref_s ) capacitor \
 c=0.0187674f //x=5.68 //y=1.09 //x2=4.275 //y2=0.555
cc_2026 ( N_noxref_11_M4_noxref_s N_noxref_16_M2_noxref_s ) capacitor \
 c=0.0210819f //x=6.785 //y=0.555 //x2=4.275 //y2=0.555
cc_2027 ( N_noxref_11_c_3437_p N_noxref_17_M5_noxref_s ) capacitor \
 c=0.00368328f //x=7.89 //y=0.805 //x2=9.085 //y2=0.555
cc_2028 ( N_noxref_11_M4_noxref_s N_noxref_17_M5_noxref_s ) capacitor \
 c=0.00125282f //x=6.785 //y=0.555 //x2=9.085 //y2=0.555
cc_2029 ( N_noxref_12_c_3474_n N_GND_c_3609_n ) capacitor c=0.00533679f \
 //x=11.645 //y=1.175 //x2=14.535 //y2=0.175
cc_2030 ( N_noxref_12_c_3505_p N_GND_c_3609_n ) capacitor c=0.0033879f \
 //x=11.73 //y=0.805 //x2=14.535 //y2=0.175
cc_2031 ( N_noxref_12_c_3462_n N_GND_c_3609_n ) capacitor c=0.0096072f \
 //x=12.615 //y=0.72 //x2=14.535 //y2=0.175
cc_2032 ( N_noxref_12_c_3507_p N_GND_c_3609_n ) capacitor c=0.00232964f \
 //x=12.7 //y=0.805 //x2=14.535 //y2=0.175
cc_2033 ( N_noxref_12_M6_noxref_d N_GND_c_3609_n ) capacitor c=0.0132509f \
 //x=10.49 //y=1.09 //x2=14.535 //y2=0.175
cc_2034 ( N_noxref_12_M6_noxref_d N_GND_c_3557_n ) capacitor c=0.0154456f \
 //x=10.49 //y=1.09 //x2=9.705 //y2=1.145
cc_2035 ( N_noxref_12_c_3474_n N_GND_c_3573_n ) capacitor c=0.0091517f \
 //x=11.645 //y=1.175 //x2=13.27 //y2=0.175
cc_2036 ( N_noxref_12_c_3505_p N_GND_c_3573_n ) capacitor c=0.0141638f \
 //x=11.73 //y=0.805 //x2=13.27 //y2=0.175
cc_2037 ( N_noxref_12_c_3462_n N_GND_c_3573_n ) capacitor c=0.0364778f \
 //x=12.615 //y=0.72 //x2=13.27 //y2=0.175
cc_2038 ( N_noxref_12_c_3507_p N_GND_c_3573_n ) capacitor c=0.013886f //x=12.7 \
 //y=0.805 //x2=13.27 //y2=0.175
cc_2039 ( N_noxref_12_c_3462_n N_GND_c_3719_n ) capacitor c=0.00189501f \
 //x=12.615 //y=0.72 //x2=24.17 //y2=0.18
cc_2040 ( N_noxref_12_M6_noxref_d N_GND_c_3719_n ) capacitor c=2.7648e-19 \
 //x=10.49 //y=1.09 //x2=24.17 //y2=0.18
cc_2041 ( N_noxref_12_M7_noxref_s N_GND_c_3586_n ) capacitor c=8.16352e-19 \
 //x=11.595 //y=0.555 //x2=8.63 //y2=0.175
cc_2042 ( N_noxref_12_c_3507_p N_GND_c_3630_n ) capacitor c=0.0374312f \
 //x=12.7 //y=0.805 //x2=13.44 //y2=0.175
cc_2043 ( N_noxref_12_M7_noxref_s N_GND_c_3630_n ) capacitor c=0.00519576f \
 //x=11.595 //y=0.555 //x2=13.44 //y2=0.175
cc_2044 ( N_noxref_12_M6_noxref_d N_GND_M5_noxref_d ) capacitor c=3.12752e-19 \
 //x=10.49 //y=1.09 //x2=9.515 //y2=1.055
cc_2045 ( N_noxref_12_c_3505_p N_noxref_17_c_4214_n ) capacitor c=2.15937e-19 \
 //x=11.73 //y=0.805 //x2=10.19 //y2=0.805
cc_2046 ( N_noxref_12_c_3474_n N_noxref_17_c_4198_n ) capacitor c=0.0130703f \
 //x=11.645 //y=1.175 //x2=11.075 //y2=0.72
cc_2047 ( N_noxref_12_M6_noxref_d N_noxref_17_c_4198_n ) capacitor \
 c=0.0162022f //x=10.49 //y=1.09 //x2=11.075 //y2=0.72
cc_2048 ( N_noxref_12_c_3474_n N_noxref_17_c_4200_n ) capacitor c=0.00940787f \
 //x=11.645 //y=1.175 //x2=11.075 //y2=1.77
cc_2049 ( N_noxref_12_M6_noxref_d N_noxref_17_c_4200_n ) capacitor \
 c=0.0151189f //x=10.49 //y=1.09 //x2=11.075 //y2=1.77
cc_2050 ( N_noxref_12_c_3474_n N_noxref_17_M5_noxref_s ) capacitor \
 c=0.0223986f //x=11.645 //y=1.175 //x2=9.085 //y2=0.555
cc_2051 ( N_noxref_12_c_3505_p N_noxref_17_M5_noxref_s ) capacitor \
 c=0.0175532f //x=11.73 //y=0.805 //x2=9.085 //y2=0.555
cc_2052 ( N_noxref_12_c_3507_p N_noxref_17_M5_noxref_s ) capacitor \
 c=2.98721e-19 //x=12.7 //y=0.805 //x2=9.085 //y2=0.555
cc_2053 ( N_noxref_12_M6_noxref_d N_noxref_17_M5_noxref_s ) capacitor \
 c=0.0187685f //x=10.49 //y=1.09 //x2=9.085 //y2=0.555
cc_2054 ( N_noxref_12_M7_noxref_s N_noxref_17_M5_noxref_s ) capacitor \
 c=0.021082f //x=11.595 //y=0.555 //x2=9.085 //y2=0.555
cc_2055 ( N_noxref_12_c_3507_p N_noxref_18_M8_noxref_s ) capacitor \
 c=0.00370912f //x=12.7 //y=0.805 //x2=14 //y2=0.545
cc_2056 ( N_noxref_12_M7_noxref_s N_noxref_18_M8_noxref_s ) capacitor \
 c=0.00101401f //x=11.595 //y=0.555 //x2=14 //y2=0.545
cc_2057 ( N_GND_c_3742_n N_noxref_14_c_4001_n ) capacitor c=0.0079063f \
 //x=24.17 //y=0.18 //x2=23.115 //y2=1.175
cc_2058 ( N_GND_c_3719_n N_noxref_14_c_4001_n ) capacitor c=0.0082582f \
 //x=24.17 //y=0.18 //x2=23.115 //y2=1.175
cc_2059 ( N_GND_c_3742_n N_noxref_14_c_4043_n ) capacitor c=0.00418576f \
 //x=24.17 //y=0.18 //x2=23.2 //y2=0.805
cc_2060 ( N_GND_c_3719_n N_noxref_14_c_4043_n ) capacitor c=0.0140604f \
 //x=24.17 //y=0.18 //x2=23.2 //y2=0.805
cc_2061 ( N_GND_c_3742_n N_noxref_14_c_4018_n ) capacitor c=0.00960852f \
 //x=24.17 //y=0.18 //x2=24.085 //y2=0.72
cc_2062 ( N_GND_c_3719_n N_noxref_14_c_4018_n ) capacitor c=0.0383587f \
 //x=24.17 //y=0.18 //x2=24.085 //y2=0.72
cc_2063 ( N_GND_c_3742_n N_noxref_14_c_4047_n ) capacitor c=0.00232964f \
 //x=24.17 //y=0.18 //x2=24.17 //y2=0.805
cc_2064 ( N_GND_c_3719_n N_noxref_14_c_4047_n ) capacitor c=0.0541549f \
 //x=24.17 //y=0.18 //x2=24.17 //y2=0.805
cc_2065 ( N_GND_c_3742_n N_noxref_14_M13_noxref_d ) capacitor c=0.0130869f \
 //x=24.17 //y=0.18 //x2=21.96 //y2=1.09
cc_2066 ( N_GND_c_3706_n N_noxref_14_M13_noxref_d ) capacitor c=0.0154456f \
 //x=21.175 //y=1.145 //x2=21.96 //y2=1.09
cc_2067 ( N_GND_c_3719_n N_noxref_14_M13_noxref_d ) capacitor c=2.7648e-19 \
 //x=24.17 //y=0.18 //x2=21.96 //y2=1.09
cc_2068 ( N_GND_M12_noxref_d N_noxref_14_M13_noxref_d ) capacitor \
 c=3.12752e-19 //x=20.985 //y=1.055 //x2=21.96 //y2=1.09
cc_2069 ( N_GND_c_3719_n N_noxref_14_M14_noxref_s ) capacitor c=0.00532909f \
 //x=24.17 //y=0.18 //x2=23.065 //y2=0.555
cc_2070 ( N_GND_c_3721_n N_noxref_14_M14_noxref_s ) capacitor c=8.16352e-19 \
 //x=20.1 //y=0.175 //x2=23.065 //y2=0.555
cc_2071 ( N_GND_c_3798_n N_noxref_15_c_4087_n ) capacitor c=0.00275848f \
 //x=1.585 //y=0.175 //x2=2.07 //y2=1.76
cc_2072 ( N_GND_c_3532_n N_noxref_15_c_4087_n ) capacitor c=7.74325e-19 \
 //x=4.81 //y=0.175 //x2=2.07 //y2=1.76
cc_2073 ( N_GND_c_3542_n N_noxref_15_c_4087_n ) capacitor c=0.00407714f \
 //x=1.67 //y=1.135 //x2=2.07 //y2=1.76
cc_2074 ( N_GND_c_3568_n N_noxref_15_c_4087_n ) capacitor c=0.00375345f \
 //x=3.65 //y=0.175 //x2=2.07 //y2=1.76
cc_2075 ( N_GND_M0_noxref_d N_noxref_15_c_4087_n ) capacitor c=0.00578453f \
 //x=1.48 //y=1.045 //x2=2.07 //y2=1.76
cc_2076 ( N_GND_c_3532_n N_noxref_15_c_4102_n ) capacitor c=0.00645992f \
 //x=4.81 //y=0.175 //x2=2.155 //y2=0.795
cc_2077 ( N_GND_c_3808_n N_noxref_15_c_4102_n ) capacitor c=0.0119573f \
 //x=1.667 //y=1.005 //x2=2.155 //y2=0.795
cc_2078 ( N_GND_c_3568_n N_noxref_15_c_4102_n ) capacitor c=0.0146605f \
 //x=3.65 //y=0.175 //x2=2.155 //y2=0.795
cc_2079 ( N_GND_c_3570_n N_noxref_15_c_4102_n ) capacitor c=0.00283128f \
 //x=1.23 //y=0.18 //x2=2.155 //y2=0.795
cc_2080 ( N_GND_c_3574_n N_noxref_15_c_4102_n ) capacitor c=2.99181e-19 \
 //x=3.82 //y=0.175 //x2=2.155 //y2=0.795
cc_2081 ( N_GND_c_3570_n N_noxref_15_c_4064_n ) capacitor c=2.85935e-19 \
 //x=1.23 //y=0.18 //x2=2.155 //y2=1.675
cc_2082 ( N_GND_c_3532_n N_noxref_15_c_4065_n ) capacitor c=0.00974619f \
 //x=4.81 //y=0.175 //x2=3.04 //y2=0.71
cc_2083 ( N_GND_c_3568_n N_noxref_15_c_4065_n ) capacitor c=0.0374826f \
 //x=3.65 //y=0.175 //x2=3.04 //y2=0.71
cc_2084 ( N_GND_c_3719_n N_noxref_15_c_4065_n ) capacitor c=0.00198522f \
 //x=24.17 //y=0.18 //x2=3.04 //y2=0.71
cc_2085 ( N_GND_c_3532_n N_noxref_15_c_4111_n ) capacitor c=0.00245021f \
 //x=4.81 //y=0.175 //x2=3.125 //y2=0.795
cc_2086 ( N_GND_c_3568_n N_noxref_15_c_4111_n ) capacitor c=0.0145368f \
 //x=3.65 //y=0.175 //x2=3.125 //y2=0.795
cc_2087 ( N_GND_c_3574_n N_noxref_15_c_4111_n ) capacitor c=0.0396774f \
 //x=3.82 //y=0.175 //x2=3.125 //y2=0.795
cc_2088 ( N_GND_c_3798_n N_noxref_15_M0_noxref_s ) capacitor c=0.00724992f \
 //x=1.585 //y=0.175 //x2=1.05 //y2=0.545
cc_2089 ( N_GND_c_3542_n N_noxref_15_M0_noxref_s ) capacitor c=0.0113621f \
 //x=1.67 //y=1.135 //x2=1.05 //y2=0.545
cc_2090 ( N_GND_c_3808_n N_noxref_15_M0_noxref_s ) capacitor c=0.0170608f \
 //x=1.667 //y=1.005 //x2=1.05 //y2=0.545
cc_2091 ( N_GND_c_3568_n N_noxref_15_M0_noxref_s ) capacitor c=0.014661f \
 //x=3.65 //y=0.175 //x2=1.05 //y2=0.545
cc_2092 ( N_GND_c_3570_n N_noxref_15_M0_noxref_s ) capacitor c=0.0559891f \
 //x=1.23 //y=0.18 //x2=1.05 //y2=0.545
cc_2093 ( N_GND_c_3574_n N_noxref_15_M0_noxref_s ) capacitor c=0.00648062f \
 //x=3.82 //y=0.175 //x2=1.05 //y2=0.545
cc_2094 ( N_GND_M0_noxref_d N_noxref_15_M0_noxref_s ) capacitor c=0.0271276f \
 //x=1.48 //y=1.045 //x2=1.05 //y2=0.545
cc_2095 ( N_GND_c_3532_n N_noxref_16_c_4126_n ) capacitor c=0.0011329f \
 //x=4.81 //y=0.175 //x2=5.295 //y2=1.77
cc_2096 ( N_GND_c_3651_n N_noxref_16_c_4126_n ) capacitor c=6.52594e-19 \
 //x=9.62 //y=0.175 //x2=5.295 //y2=1.77
cc_2097 ( N_GND_c_3545_n N_noxref_16_c_4126_n ) capacitor c=0.00354861f \
 //x=4.895 //y=1.145 //x2=5.295 //y2=1.77
cc_2098 ( N_GND_c_3572_n N_noxref_16_c_4126_n ) capacitor c=0.0038933f \
 //x=8.46 //y=0.175 //x2=5.295 //y2=1.77
cc_2099 ( N_GND_M2_noxref_d N_noxref_16_c_4126_n ) capacitor c=0.00578031f \
 //x=4.705 //y=1.055 //x2=5.295 //y2=1.77
cc_2100 ( N_GND_c_3536_n N_noxref_16_c_4151_n ) capacitor c=0.0169052f \
 //x=4.895 //y=1.015 //x2=5.38 //y2=0.805
cc_2101 ( N_GND_c_3651_n N_noxref_16_c_4151_n ) capacitor c=0.00710913f \
 //x=9.62 //y=0.175 //x2=5.38 //y2=0.805
cc_2102 ( N_GND_c_3572_n N_noxref_16_c_4151_n ) capacitor c=0.0140604f \
 //x=8.46 //y=0.175 //x2=5.38 //y2=0.805
cc_2103 ( N_GND_c_3574_n N_noxref_16_c_4151_n ) capacitor c=0.00322442f \
 //x=3.82 //y=0.175 //x2=5.38 //y2=0.805
cc_2104 ( N_GND_c_3651_n N_noxref_16_c_4141_n ) capacitor c=0.0124077f \
 //x=9.62 //y=0.175 //x2=6.265 //y2=0.72
cc_2105 ( N_GND_c_3572_n N_noxref_16_c_4141_n ) capacitor c=0.0356451f \
 //x=8.46 //y=0.175 //x2=6.265 //y2=0.72
cc_2106 ( N_GND_c_3719_n N_noxref_16_c_4141_n ) capacitor c=0.00177401f \
 //x=24.17 //y=0.18 //x2=6.265 //y2=0.72
cc_2107 ( N_GND_c_3532_n N_noxref_16_M2_noxref_s ) capacitor c=0.00710913f \
 //x=4.81 //y=0.175 //x2=4.275 //y2=0.555
cc_2108 ( N_GND_c_3536_n N_noxref_16_M2_noxref_s ) capacitor c=0.0125586f \
 //x=4.895 //y=1.015 //x2=4.275 //y2=0.555
cc_2109 ( N_GND_c_3651_n N_noxref_16_M2_noxref_s ) capacitor c=0.00683407f \
 //x=9.62 //y=0.175 //x2=4.275 //y2=0.555
cc_2110 ( N_GND_c_3545_n N_noxref_16_M2_noxref_s ) capacitor c=0.00972044f \
 //x=4.895 //y=1.145 //x2=4.275 //y2=0.555
cc_2111 ( N_GND_c_3572_n N_noxref_16_M2_noxref_s ) capacitor c=0.0272246f \
 //x=8.46 //y=0.175 //x2=4.275 //y2=0.555
cc_2112 ( N_GND_c_3574_n N_noxref_16_M2_noxref_s ) capacitor c=0.0624873f \
 //x=3.82 //y=0.175 //x2=4.275 //y2=0.555
cc_2113 ( N_GND_c_3586_n N_noxref_16_M2_noxref_s ) capacitor c=0.00166413f \
 //x=8.63 //y=0.175 //x2=4.275 //y2=0.555
cc_2114 ( N_GND_M2_noxref_d N_noxref_16_M2_noxref_s ) capacitor c=0.0271316f \
 //x=4.705 //y=1.055 //x2=4.275 //y2=0.555
cc_2115 ( N_GND_c_3651_n N_noxref_17_c_4186_n ) capacitor c=0.0011329f \
 //x=9.62 //y=0.175 //x2=10.105 //y2=1.77
cc_2116 ( N_GND_c_3609_n N_noxref_17_c_4186_n ) capacitor c=7.69197e-19 \
 //x=14.535 //y=0.175 //x2=10.105 //y2=1.77
cc_2117 ( N_GND_c_3557_n N_noxref_17_c_4186_n ) capacitor c=0.00350567f \
 //x=9.705 //y=1.145 //x2=10.105 //y2=1.77
cc_2118 ( N_GND_c_3573_n N_noxref_17_c_4186_n ) capacitor c=0.0038933f \
 //x=13.27 //y=0.175 //x2=10.105 //y2=1.77
cc_2119 ( N_GND_M5_noxref_d N_noxref_17_c_4186_n ) capacitor c=0.00578031f \
 //x=9.515 //y=1.055 //x2=10.105 //y2=1.77
cc_2120 ( N_GND_c_3539_n N_noxref_17_c_4214_n ) capacitor c=0.0169052f \
 //x=9.705 //y=1.015 //x2=10.19 //y2=0.805
cc_2121 ( N_GND_c_3609_n N_noxref_17_c_4214_n ) capacitor c=0.00710913f \
 //x=14.535 //y=0.175 //x2=10.19 //y2=0.805
cc_2122 ( N_GND_c_3573_n N_noxref_17_c_4214_n ) capacitor c=0.0140604f \
 //x=13.27 //y=0.175 //x2=10.19 //y2=0.805
cc_2123 ( N_GND_c_3586_n N_noxref_17_c_4214_n ) capacitor c=0.00322478f \
 //x=8.63 //y=0.175 //x2=10.19 //y2=0.805
cc_2124 ( N_GND_c_3609_n N_noxref_17_c_4198_n ) capacitor c=0.0130204f \
 //x=14.535 //y=0.175 //x2=11.075 //y2=0.72
cc_2125 ( N_GND_c_3573_n N_noxref_17_c_4198_n ) capacitor c=0.0358801f \
 //x=13.27 //y=0.175 //x2=11.075 //y2=0.72
cc_2126 ( N_GND_c_3719_n N_noxref_17_c_4198_n ) capacitor c=0.00177401f \
 //x=24.17 //y=0.18 //x2=11.075 //y2=0.72
cc_2127 ( N_GND_c_3651_n N_noxref_17_M5_noxref_s ) capacitor c=0.00710913f \
 //x=9.62 //y=0.175 //x2=9.085 //y2=0.555
cc_2128 ( N_GND_c_3539_n N_noxref_17_M5_noxref_s ) capacitor c=0.0173062f \
 //x=9.705 //y=1.015 //x2=9.085 //y2=0.555
cc_2129 ( N_GND_c_3609_n N_noxref_17_M5_noxref_s ) capacitor c=0.0044479f \
 //x=14.535 //y=0.175 //x2=9.085 //y2=0.555
cc_2130 ( N_GND_c_3557_n N_noxref_17_M5_noxref_s ) capacitor c=0.00988958f \
 //x=9.705 //y=1.145 //x2=9.085 //y2=0.555
cc_2131 ( N_GND_c_3573_n N_noxref_17_M5_noxref_s ) capacitor c=0.0272659f \
 //x=13.27 //y=0.175 //x2=9.085 //y2=0.555
cc_2132 ( N_GND_c_3586_n N_noxref_17_M5_noxref_s ) capacitor c=0.0634633f \
 //x=8.63 //y=0.175 //x2=9.085 //y2=0.555
cc_2133 ( N_GND_c_3630_n N_noxref_17_M5_noxref_s ) capacitor c=0.00166451f \
 //x=13.44 //y=0.175 //x2=9.085 //y2=0.555
cc_2134 ( N_GND_M5_noxref_d N_noxref_17_M5_noxref_s ) capacitor c=0.0271316f \
 //x=9.515 //y=1.055 //x2=9.085 //y2=0.555
cc_2135 ( N_GND_c_3609_n N_noxref_18_c_4245_n ) capacitor c=9.58019e-19 \
 //x=14.535 //y=0.175 //x2=15.02 //y2=1.76
cc_2136 ( N_GND_c_3652_n N_noxref_18_c_4245_n ) capacitor c=7.45647e-19 \
 //x=17.865 //y=0.175 //x2=15.02 //y2=1.76
cc_2137 ( N_GND_c_3613_n N_noxref_18_c_4245_n ) capacitor c=0.00396941f \
 //x=14.62 //y=1.135 //x2=15.02 //y2=1.76
cc_2138 ( N_GND_c_3629_n N_noxref_18_c_4245_n ) capacitor c=0.00395774f \
 //x=16.6 //y=0.175 //x2=15.02 //y2=1.76
cc_2139 ( N_GND_M8_noxref_d N_noxref_18_c_4245_n ) capacitor c=0.00578453f \
 //x=14.43 //y=1.045 //x2=15.02 //y2=1.76
cc_2140 ( N_GND_c_3652_n N_noxref_18_c_4289_n ) capacitor c=0.0042561f \
 //x=17.865 //y=0.175 //x2=15.105 //y2=0.795
cc_2141 ( N_GND_c_3624_n N_noxref_18_c_4289_n ) capacitor c=0.0120153f \
 //x=14.617 //y=1.005 //x2=15.105 //y2=0.795
cc_2142 ( N_GND_c_3629_n N_noxref_18_c_4289_n ) capacitor c=0.0147548f \
 //x=16.6 //y=0.175 //x2=15.105 //y2=0.795
cc_2143 ( N_GND_c_3630_n N_noxref_18_c_4289_n ) capacitor c=0.00282583f \
 //x=13.44 //y=0.175 //x2=15.105 //y2=0.795
cc_2144 ( N_GND_c_3643_n N_noxref_18_c_4289_n ) capacitor c=2.99356e-19 \
 //x=16.77 //y=0.175 //x2=15.105 //y2=0.795
cc_2145 ( N_GND_c_3630_n N_noxref_18_c_4252_n ) capacitor c=2.8386e-19 \
 //x=13.44 //y=0.175 //x2=15.105 //y2=1.675
cc_2146 ( N_GND_c_3652_n N_noxref_18_c_4259_n ) capacitor c=0.00979428f \
 //x=17.865 //y=0.175 //x2=15.99 //y2=0.71
cc_2147 ( N_GND_c_3629_n N_noxref_18_c_4259_n ) capacitor c=0.0375602f \
 //x=16.6 //y=0.175 //x2=15.99 //y2=0.71
cc_2148 ( N_GND_c_3719_n N_noxref_18_c_4259_n ) capacitor c=0.00198522f \
 //x=24.17 //y=0.18 //x2=15.99 //y2=0.71
cc_2149 ( N_GND_c_3652_n N_noxref_18_c_4298_n ) capacitor c=0.00253402f \
 //x=17.865 //y=0.175 //x2=16.075 //y2=0.795
cc_2150 ( N_GND_c_3629_n N_noxref_18_c_4298_n ) capacitor c=0.0145307f \
 //x=16.6 //y=0.175 //x2=16.075 //y2=0.795
cc_2151 ( N_GND_c_3643_n N_noxref_18_c_4298_n ) capacitor c=0.0392026f \
 //x=16.77 //y=0.175 //x2=16.075 //y2=0.795
cc_2152 ( N_GND_c_3609_n N_noxref_18_M8_noxref_s ) capacitor c=0.0045077f \
 //x=14.535 //y=0.175 //x2=14 //y2=0.545
cc_2153 ( N_GND_c_3613_n N_noxref_18_M8_noxref_s ) capacitor c=0.0100997f \
 //x=14.62 //y=1.135 //x2=14 //y2=0.545
cc_2154 ( N_GND_c_3624_n N_noxref_18_M8_noxref_s ) capacitor c=0.0170652f \
 //x=14.617 //y=1.005 //x2=14 //y2=0.545
cc_2155 ( N_GND_c_3629_n N_noxref_18_M8_noxref_s ) capacitor c=0.0147643f \
 //x=16.6 //y=0.175 //x2=14 //y2=0.545
cc_2156 ( N_GND_c_3630_n N_noxref_18_M8_noxref_s ) capacitor c=0.0528206f \
 //x=13.44 //y=0.175 //x2=14 //y2=0.545
cc_2157 ( N_GND_c_3643_n N_noxref_18_M8_noxref_s ) capacitor c=0.0064811f \
 //x=16.77 //y=0.175 //x2=14 //y2=0.545
cc_2158 ( N_GND_M8_noxref_d N_noxref_18_M8_noxref_s ) capacitor c=0.0271276f \
 //x=14.43 //y=1.045 //x2=14 //y2=0.545
cc_2159 ( N_GND_c_3652_n N_noxref_19_c_4312_n ) capacitor c=9.98096e-19 \
 //x=17.865 //y=0.175 //x2=18.35 //y2=1.76
cc_2160 ( N_GND_c_3696_n N_noxref_19_c_4312_n ) capacitor c=7.45647e-19 \
 //x=21.09 //y=0.175 //x2=18.35 //y2=1.76
cc_2161 ( N_GND_c_3663_n N_noxref_19_c_4312_n ) capacitor c=0.00402812f \
 //x=17.95 //y=1.135 //x2=18.35 //y2=1.76
cc_2162 ( N_GND_c_3677_n N_noxref_19_c_4312_n ) capacitor c=0.00395774f \
 //x=19.93 //y=0.175 //x2=18.35 //y2=1.76
cc_2163 ( N_GND_M10_noxref_d N_noxref_19_c_4312_n ) capacitor c=0.00578453f \
 //x=17.76 //y=1.045 //x2=18.35 //y2=1.76
cc_2164 ( N_GND_c_3696_n N_noxref_19_c_4355_n ) capacitor c=0.00396093f \
 //x=21.09 //y=0.175 //x2=18.435 //y2=0.795
cc_2165 ( N_GND_c_3672_n N_noxref_19_c_4355_n ) capacitor c=0.0119573f \
 //x=17.947 //y=1.005 //x2=18.435 //y2=0.795
cc_2166 ( N_GND_c_3677_n N_noxref_19_c_4355_n ) capacitor c=0.0147548f \
 //x=19.93 //y=0.175 //x2=18.435 //y2=0.795
cc_2167 ( N_GND_c_3643_n N_noxref_19_c_4355_n ) capacitor c=0.00282552f \
 //x=16.77 //y=0.175 //x2=18.435 //y2=0.795
cc_2168 ( N_GND_c_3721_n N_noxref_19_c_4355_n ) capacitor c=2.99181e-19 \
 //x=20.1 //y=0.175 //x2=18.435 //y2=0.795
cc_2169 ( N_GND_c_3643_n N_noxref_19_c_4319_n ) capacitor c=2.8386e-19 \
 //x=16.77 //y=0.175 //x2=18.435 //y2=1.675
cc_2170 ( N_GND_c_3696_n N_noxref_19_c_4324_n ) capacitor c=0.00974669f \
 //x=21.09 //y=0.175 //x2=19.32 //y2=0.71
cc_2171 ( N_GND_c_3677_n N_noxref_19_c_4324_n ) capacitor c=0.0374812f \
 //x=19.93 //y=0.175 //x2=19.32 //y2=0.71
cc_2172 ( N_GND_c_3719_n N_noxref_19_c_4324_n ) capacitor c=0.00198522f \
 //x=24.17 //y=0.18 //x2=19.32 //y2=0.71
cc_2173 ( N_GND_c_3696_n N_noxref_19_c_4364_n ) capacitor c=0.00248173f \
 //x=21.09 //y=0.175 //x2=19.405 //y2=0.795
cc_2174 ( N_GND_c_3677_n N_noxref_19_c_4364_n ) capacitor c=0.0145307f \
 //x=19.93 //y=0.175 //x2=19.405 //y2=0.795
cc_2175 ( N_GND_c_3721_n N_noxref_19_c_4364_n ) capacitor c=0.0396774f \
 //x=20.1 //y=0.175 //x2=19.405 //y2=0.795
cc_2176 ( N_GND_c_3652_n N_noxref_19_M10_noxref_s ) capacitor c=0.0045077f \
 //x=17.865 //y=0.175 //x2=17.33 //y2=0.545
cc_2177 ( N_GND_c_3663_n N_noxref_19_M10_noxref_s ) capacitor c=0.00990843f \
 //x=17.95 //y=1.135 //x2=17.33 //y2=0.545
cc_2178 ( N_GND_c_3672_n N_noxref_19_M10_noxref_s ) capacitor c=0.0123717f \
 //x=17.947 //y=1.005 //x2=17.33 //y2=0.545
cc_2179 ( N_GND_c_3677_n N_noxref_19_M10_noxref_s ) capacitor c=0.0147643f \
 //x=19.93 //y=0.175 //x2=17.33 //y2=0.545
cc_2180 ( N_GND_c_3643_n N_noxref_19_M10_noxref_s ) capacitor c=0.0518718f \
 //x=16.77 //y=0.175 //x2=17.33 //y2=0.545
cc_2181 ( N_GND_c_3721_n N_noxref_19_M10_noxref_s ) capacitor c=0.00648063f \
 //x=20.1 //y=0.175 //x2=17.33 //y2=0.545
cc_2182 ( N_GND_M10_noxref_d N_noxref_19_M10_noxref_s ) capacitor c=0.0271276f \
 //x=17.76 //y=1.045 //x2=17.33 //y2=0.545
cc_2183 ( N_GND_c_3696_n N_noxref_20_c_4381_n ) capacitor c=0.0011329f \
 //x=21.09 //y=0.175 //x2=21.575 //y2=1.77
cc_2184 ( N_GND_c_3742_n N_noxref_20_c_4381_n ) capacitor c=0.00183325f \
 //x=24.17 //y=0.18 //x2=21.575 //y2=1.77
cc_2185 ( N_GND_c_3706_n N_noxref_20_c_4381_n ) capacitor c=0.00358809f \
 //x=21.175 //y=1.145 //x2=21.575 //y2=1.77
cc_2186 ( N_GND_c_3719_n N_noxref_20_c_4381_n ) capacitor c=0.00386557f \
 //x=24.17 //y=0.18 //x2=21.575 //y2=1.77
cc_2187 ( N_GND_M12_noxref_d N_noxref_20_c_4381_n ) capacitor c=0.00578031f \
 //x=20.985 //y=1.055 //x2=21.575 //y2=1.77
cc_2188 ( N_GND_c_3700_n N_noxref_20_c_4412_n ) capacitor c=0.0169052f \
 //x=21.175 //y=1.015 //x2=21.66 //y2=0.805
cc_2189 ( N_GND_c_3742_n N_noxref_20_c_4412_n ) capacitor c=0.00439789f \
 //x=24.17 //y=0.18 //x2=21.66 //y2=0.805
cc_2190 ( N_GND_c_3719_n N_noxref_20_c_4412_n ) capacitor c=0.0141638f \
 //x=24.17 //y=0.18 //x2=21.66 //y2=0.805
cc_2191 ( N_GND_c_3721_n N_noxref_20_c_4412_n ) capacitor c=0.00322442f \
 //x=20.1 //y=0.175 //x2=21.66 //y2=0.805
cc_2192 ( N_GND_c_3742_n N_noxref_20_c_4394_n ) capacitor c=0.0130562f \
 //x=24.17 //y=0.18 //x2=22.545 //y2=0.72
cc_2193 ( N_GND_c_3719_n N_noxref_20_c_4394_n ) capacitor c=0.0376737f \
 //x=24.17 //y=0.18 //x2=22.545 //y2=0.72
cc_2194 ( N_GND_c_3696_n N_noxref_20_M12_noxref_s ) capacitor c=0.00439789f \
 //x=21.09 //y=0.175 //x2=20.555 //y2=0.555
cc_2195 ( N_GND_c_3700_n N_noxref_20_M12_noxref_s ) capacitor c=0.0125586f \
 //x=21.175 //y=1.015 //x2=20.555 //y2=0.555
cc_2196 ( N_GND_c_3742_n N_noxref_20_M12_noxref_s ) capacitor c=0.00683407f \
 //x=24.17 //y=0.18 //x2=20.555 //y2=0.555
cc_2197 ( N_GND_c_3706_n N_noxref_20_M12_noxref_s ) capacitor c=0.00972044f \
 //x=21.175 //y=1.145 //x2=20.555 //y2=0.555
cc_2198 ( N_GND_c_3719_n N_noxref_20_M12_noxref_s ) capacitor c=0.0286894f \
 //x=24.17 //y=0.18 //x2=20.555 //y2=0.555
cc_2199 ( N_GND_c_3721_n N_noxref_20_M12_noxref_s ) capacitor c=0.0624873f \
 //x=20.1 //y=0.175 //x2=20.555 //y2=0.555
cc_2200 ( N_GND_M12_noxref_d N_noxref_20_M12_noxref_s ) capacitor c=0.0271316f \
 //x=20.985 //y=1.055 //x2=20.555 //y2=0.555
cc_2201 ( N_noxref_14_c_4043_n N_noxref_20_c_4412_n ) capacitor c=2.15937e-19 \
 //x=23.2 //y=0.805 //x2=21.66 //y2=0.805
cc_2202 ( N_noxref_14_c_4001_n N_noxref_20_c_4394_n ) capacitor c=0.0132234f \
 //x=23.115 //y=1.175 //x2=22.545 //y2=0.72
cc_2203 ( N_noxref_14_M13_noxref_d N_noxref_20_c_4394_n ) capacitor \
 c=0.0160925f //x=21.96 //y=1.09 //x2=22.545 //y2=0.72
cc_2204 ( N_noxref_14_c_4001_n N_noxref_20_c_4396_n ) capacitor c=0.00949522f \
 //x=23.115 //y=1.175 //x2=22.545 //y2=1.77
cc_2205 ( N_noxref_14_M13_noxref_d N_noxref_20_c_4396_n ) capacitor c=0.01508f \
 //x=21.96 //y=1.09 //x2=22.545 //y2=1.77
cc_2206 ( N_noxref_14_c_4001_n N_noxref_20_M12_noxref_s ) capacitor \
 c=0.023368f //x=23.115 //y=1.175 //x2=20.555 //y2=0.555
cc_2207 ( N_noxref_14_c_4043_n N_noxref_20_M12_noxref_s ) capacitor \
 c=0.0182125f //x=23.2 //y=0.805 //x2=20.555 //y2=0.555
cc_2208 ( N_noxref_14_M13_noxref_d N_noxref_20_M12_noxref_s ) capacitor \
 c=0.0187674f //x=21.96 //y=1.09 //x2=20.555 //y2=0.555
cc_2209 ( N_noxref_14_M14_noxref_s N_noxref_20_M12_noxref_s ) capacitor \
 c=0.0209954f //x=23.065 //y=0.555 //x2=20.555 //y2=0.555
cc_2210 ( N_noxref_15_c_4064_n N_noxref_16_c_4124_n ) capacitor c=6.40432e-19 \
 //x=2.155 //y=1.675 //x2=4.41 //y2=1.685
cc_2211 ( N_noxref_15_c_4111_n N_noxref_16_M2_noxref_s ) capacitor \
 c=0.00453771f //x=3.125 //y=0.795 //x2=4.275 //y2=0.555
cc_2212 ( N_noxref_15_M0_noxref_s N_noxref_16_M2_noxref_s ) capacitor \
 c=6.40432e-19 //x=1.05 //y=0.545 //x2=4.275 //y2=0.555
cc_2213 ( N_noxref_18_c_4252_n N_noxref_19_c_4311_n ) capacitor c=5.34352e-19 \
 //x=15.105 //y=1.675 //x2=17.465 //y2=1.675
cc_2214 ( N_noxref_18_c_4298_n N_noxref_19_M10_noxref_s ) capacitor \
 c=0.0045327f //x=16.075 //y=0.795 //x2=17.33 //y2=0.545
cc_2215 ( N_noxref_18_M8_noxref_s N_noxref_19_M10_noxref_s ) capacitor \
 c=5.34352e-19 //x=14 //y=0.545 //x2=17.33 //y2=0.545
cc_2216 ( N_noxref_19_c_4319_n N_noxref_20_c_4380_n ) capacitor c=6.40432e-19 \
 //x=18.435 //y=1.675 //x2=20.69 //y2=1.685
cc_2217 ( N_noxref_19_c_4364_n N_noxref_20_M12_noxref_s ) capacitor \
 c=0.00453771f //x=19.405 //y=0.795 //x2=20.555 //y2=0.555
cc_2218 ( N_noxref_19_M10_noxref_s N_noxref_20_M12_noxref_s ) capacitor \
 c=6.40432e-19 //x=17.33 //y=0.545 //x2=20.555 //y2=0.555
