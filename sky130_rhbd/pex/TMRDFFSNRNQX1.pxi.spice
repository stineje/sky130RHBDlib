// File: TMRDFFSNRNQX1.spi.TMRDFFSNRNQX1.pxi
// Created: Sun Mar 15 12:46:31 2026
//
simulator lang=spectre
x_PM_TMRDFFSNRNQX1\%noxref_1 ( N_noxref_1_c_119_p N_noxref_1_c_67_p \
 N_noxref_1_c_39_p N_noxref_1_c_17_p N_noxref_1_c_18_p N_noxref_1_c_76_p \
 N_noxref_1_c_28_p N_noxref_1_c_19_p N_noxref_1_c_9_p N_noxref_1_c_11_p \
 N_noxref_1_c_12_p N_noxref_1_c_133_p N_noxref_1_c_13_p N_noxref_1_c_51_p \
 N_noxref_1_c_14_p N_noxref_1_c_29_p N_noxref_1_c_30_p N_noxref_1_c_31_p \
 N_noxref_1_c_32_p N_noxref_1_c_112_p N_noxref_1_c_113_p N_noxref_1_c_21_p \
 N_noxref_1_c_15_p N_noxref_1_c_129_p N_noxref_1_c_5_p N_noxref_1_c_16_p \
 N_noxref_1_c_54_p N_noxref_1_c_55_p N_noxref_1_c_33_p N_noxref_1_c_34_p \
 N_noxref_1_c_118_p N_noxref_1_c_172_p N_noxref_1_c_26_p N_noxref_1_c_132_p \
 N_noxref_1_c_137_p N_noxref_1_c_189_p N_noxref_1_c_215_p \
 N_noxref_1_M3_noxref_g N_noxref_1_M6_noxref_g N_noxref_1_M67_noxref_g \
 N_noxref_1_M68_noxref_g N_noxref_1_M73_noxref_g N_noxref_1_M74_noxref_g \
 N_noxref_1_c_153_p N_noxref_1_c_154_p N_noxref_1_c_156_p N_noxref_1_c_135_p \
 N_noxref_1_c_324_p N_noxref_1_c_337_p N_noxref_1_c_155_p N_noxref_1_c_157_p \
 N_noxref_1_c_43_p N_noxref_1_c_139_p N_noxref_1_c_230_p N_noxref_1_c_231_p \
 N_noxref_1_c_233_p N_noxref_1_c_191_p N_noxref_1_c_327_p N_noxref_1_c_347_p \
 N_noxref_1_c_232_p N_noxref_1_c_234_p N_noxref_1_c_4_p N_noxref_1_c_217_p \
 N_noxref_1_M2_noxref_d N_noxref_1_M61_noxref_d N_noxref_1_M63_noxref_d \
 N_noxref_1_M65_noxref_d )  PM_TMRDFFSNRNQX1\%noxref_1
x_PM_TMRDFFSNRNQX1\%noxref_2 ( N_noxref_2_c_413_n N_noxref_2_c_435_p \
 N_noxref_2_c_446_p N_noxref_2_c_436_p N_noxref_2_c_468_p N_noxref_2_c_471_p \
 N_noxref_2_c_444_p N_noxref_2_c_423_p N_noxref_2_c_427_p N_noxref_2_c_429_p \
 N_noxref_2_c_424_p N_noxref_2_c_503_p N_noxref_2_c_431_p N_noxref_2_c_498_p \
 N_noxref_2_c_425_p N_noxref_2_c_414_n N_noxref_2_c_514_p N_noxref_2_c_441_p \
 N_noxref_2_c_417_n N_noxref_2_c_500_p N_noxref_2_c_426_p N_noxref_2_c_434_p \
 N_noxref_2_c_501_p N_noxref_2_c_418_n N_noxref_2_c_563_p N_noxref_2_c_442_p \
 N_noxref_2_c_502_p N_noxref_2_c_507_p N_noxref_2_M9_noxref_g \
 N_noxref_2_M79_noxref_g N_noxref_2_M80_noxref_g N_noxref_2_c_527_p \
 N_noxref_2_c_528_p N_noxref_2_c_530_p N_noxref_2_c_505_p N_noxref_2_c_659_p \
 N_noxref_2_c_669_p N_noxref_2_c_529_p N_noxref_2_c_531_p N_noxref_2_c_450_p \
 N_noxref_2_c_509_p N_noxref_2_M8_noxref_d N_noxref_2_M73_noxref_d \
 N_noxref_2_M75_noxref_d N_noxref_2_M77_noxref_d )  PM_TMRDFFSNRNQX1\%noxref_2
x_PM_TMRDFFSNRNQX1\%noxref_3 ( N_noxref_3_c_706_n N_noxref_3_c_707_n \
 N_noxref_3_c_714_n N_noxref_3_c_719_n N_noxref_3_c_724_n N_noxref_3_c_814_p \
 N_noxref_3_c_794_n N_noxref_3_c_795_n N_noxref_3_c_861_p N_noxref_3_c_864_p \
 N_noxref_3_c_796_n N_noxref_3_c_725_n N_noxref_3_c_726_n N_noxref_3_c_732_n \
 N_noxref_3_c_734_n N_noxref_3_c_825_p N_noxref_3_c_826_p N_noxref_3_c_827_p \
 N_noxref_3_c_828_p N_noxref_3_c_735_n N_noxref_3_c_736_n N_noxref_3_c_910_p \
 N_noxref_3_c_821_p N_noxref_3_c_811_p N_noxref_3_c_887_p N_noxref_3_c_741_n \
 N_noxref_3_c_745_n N_noxref_3_c_746_n N_noxref_3_c_754_n N_noxref_3_c_830_p \
 N_noxref_3_c_756_n N_noxref_3_c_757_n N_noxref_3_c_761_n N_noxref_3_c_911_p \
 N_noxref_3_c_822_p N_noxref_3_c_954_p N_noxref_3_c_944_p \
 N_noxref_3_M2_noxref_g N_noxref_3_M12_noxref_g N_noxref_3_M65_noxref_g \
 N_noxref_3_M66_noxref_g N_noxref_3_M85_noxref_g N_noxref_3_M86_noxref_g \
 N_noxref_3_c_770_n N_noxref_3_c_772_n N_noxref_3_c_775_n N_noxref_3_c_776_n \
 N_noxref_3_c_778_n N_noxref_3_c_782_n N_noxref_3_c_784_n N_noxref_3_c_1008_p \
 N_noxref_3_c_1009_p N_noxref_3_c_1011_p N_noxref_3_c_955_p \
 N_noxref_3_c_1129_p N_noxref_3_c_1139_p N_noxref_3_c_1010_p \
 N_noxref_3_c_1012_p N_noxref_3_c_803_p N_noxref_3_c_959_p N_noxref_3_c_788_n \
 N_noxref_3_c_789_n N_noxref_3_c_791_n N_noxref_3_M5_noxref_d \
 N_noxref_3_M67_noxref_d N_noxref_3_M69_noxref_d N_noxref_3_M71_noxref_d )  \
 PM_TMRDFFSNRNQX1\%noxref_3
x_PM_TMRDFFSNRNQX1\%noxref_4 ( N_noxref_4_c_1177_n N_noxref_4_c_1200_p \
 N_noxref_4_c_1213_p N_noxref_4_c_1201_p N_noxref_4_c_1202_p \
 N_noxref_4_c_1239_p N_noxref_4_c_1211_p N_noxref_4_c_1186_p \
 N_noxref_4_c_1192_p N_noxref_4_c_1194_p N_noxref_4_c_1190_p \
 N_noxref_4_c_1285_p N_noxref_4_c_1187_p N_noxref_4_c_1283_p \
 N_noxref_4_c_1188_p N_noxref_4_c_1178_n N_noxref_4_c_1266_p \
 N_noxref_4_c_1208_p N_noxref_4_c_1198_p N_noxref_4_c_1307_p \
 N_noxref_4_c_1199_p N_noxref_4_c_1288_p N_noxref_4_c_1220_p \
 N_noxref_4_c_1181_n N_noxref_4_c_1272_p N_noxref_4_c_1209_p \
 N_noxref_4_c_1289_p N_noxref_4_c_1317_p N_noxref_4_M15_noxref_g \
 N_noxref_4_M91_noxref_g N_noxref_4_M92_noxref_g N_noxref_4_c_1338_p \
 N_noxref_4_c_1339_p N_noxref_4_c_1341_p N_noxref_4_c_1290_p \
 N_noxref_4_c_1421_p N_noxref_4_c_1431_p N_noxref_4_c_1340_p \
 N_noxref_4_c_1342_p N_noxref_4_c_1217_p N_noxref_4_c_1319_p \
 N_noxref_4_M14_noxref_d N_noxref_4_M85_noxref_d N_noxref_4_M87_noxref_d \
 N_noxref_4_M89_noxref_d )  PM_TMRDFFSNRNQX1\%noxref_4
x_PM_TMRDFFSNRNQX1\%noxref_5 ( N_noxref_5_c_1545_n N_noxref_5_c_1468_n \
 N_noxref_5_c_1552_n N_noxref_5_c_1473_n N_noxref_5_c_1480_n \
 N_noxref_5_c_1475_n N_noxref_5_c_1488_n N_noxref_5_c_1477_n \
 N_noxref_5_c_1496_n N_noxref_5_c_1773_p N_noxref_5_c_1623_n \
 N_noxref_5_c_1624_n N_noxref_5_c_1798_p N_noxref_5_c_1838_p \
 N_noxref_5_c_1625_n N_noxref_5_c_1497_n N_noxref_5_c_1563_n \
 N_noxref_5_c_1569_n N_noxref_5_c_1571_n N_noxref_5_c_1654_p \
 N_noxref_5_c_1626_n N_noxref_5_c_1633_p N_noxref_5_c_1628_n \
 N_noxref_5_c_1572_n N_noxref_5_c_1498_n N_noxref_5_c_1499_n \
 N_noxref_5_c_1743_p N_noxref_5_c_1800_p N_noxref_5_c_1792_p \
 N_noxref_5_c_1663_p N_noxref_5_c_1504_n N_noxref_5_c_1574_n \
 N_noxref_5_c_1576_n N_noxref_5_c_1580_n N_noxref_5_c_1478_n \
 N_noxref_5_c_1506_n N_noxref_5_c_1588_n N_noxref_5_c_1589_n \
 N_noxref_5_c_1507_n N_noxref_5_c_1508_n N_noxref_5_c_1512_n \
 N_noxref_5_c_1744_p N_noxref_5_c_1804_p N_noxref_5_c_1656_p \
 N_noxref_5_c_1639_p N_noxref_5_M5_noxref_g N_noxref_5_M8_noxref_g \
 N_noxref_5_M17_noxref_g N_noxref_5_M71_noxref_g N_noxref_5_M72_noxref_g \
 N_noxref_5_M77_noxref_g N_noxref_5_M78_noxref_g N_noxref_5_M95_noxref_g \
 N_noxref_5_M96_noxref_g N_noxref_5_c_1599_n N_noxref_5_c_1601_n \
 N_noxref_5_c_1604_n N_noxref_5_c_1605_n N_noxref_5_c_1607_n \
 N_noxref_5_c_1611_n N_noxref_5_c_1613_n N_noxref_5_c_1521_n \
 N_noxref_5_c_1523_n N_noxref_5_c_1526_n N_noxref_5_c_1527_n \
 N_noxref_5_c_1529_n N_noxref_5_c_1533_n N_noxref_5_c_1535_n \
 N_noxref_5_c_1641_p N_noxref_5_c_1642_p N_noxref_5_c_1648_p \
 N_noxref_5_c_1643_p N_noxref_5_c_1644_p N_noxref_5_c_1645_p \
 N_noxref_5_c_1646_p N_noxref_5_c_1617_n N_noxref_5_c_1618_n \
 N_noxref_5_c_1620_n N_noxref_5_c_1539_n N_noxref_5_c_1540_n \
 N_noxref_5_c_1542_n N_noxref_5_c_1657_p N_noxref_5_c_1651_p \
 N_noxref_5_c_1666_p N_noxref_5_M11_noxref_d N_noxref_5_M79_noxref_d \
 N_noxref_5_M81_noxref_d N_noxref_5_M83_noxref_d )  PM_TMRDFFSNRNQX1\%noxref_5
x_PM_TMRDFFSNRNQX1\%noxref_6 ( N_noxref_6_c_2069_n N_noxref_6_c_2065_n \
 N_noxref_6_c_2077_n N_noxref_6_c_2066_n N_noxref_6_c_2087_n \
 N_noxref_6_c_2139_n N_noxref_6_c_2141_n N_noxref_6_c_2143_n \
 N_noxref_6_c_2147_n N_noxref_6_c_2153_n N_noxref_6_c_2158_n \
 N_noxref_6_c_2088_n N_noxref_6_c_2160_n N_noxref_6_c_2165_n \
 N_noxref_6_c_2166_n N_noxref_6_c_2569_p N_noxref_6_c_2550_p \
 N_noxref_6_c_2576_p N_noxref_6_c_2577_p N_noxref_6_c_2067_n \
 N_noxref_6_c_2090_n N_noxref_6_c_2362_p N_noxref_6_c_2173_n \
 N_noxref_6_c_2176_n N_noxref_6_c_2177_n N_noxref_6_c_2180_n \
 N_noxref_6_c_2573_p N_noxref_6_c_2580_p N_noxref_6_c_2095_n \
 N_noxref_6_c_2068_n N_noxref_6_c_2185_n N_noxref_6_c_2187_n \
 N_noxref_6_c_2190_n N_noxref_6_c_2207_p N_noxref_6_c_2208_p \
 N_noxref_6_c_2231_p N_noxref_6_c_2205_p N_noxref_6_c_2236_p \
 N_noxref_6_c_2210_p N_noxref_6_c_2301_p N_noxref_6_c_2223_p \
 N_noxref_6_c_2227_p N_noxref_6_c_2221_p N_noxref_6_c_2263_p \
 N_noxref_6_c_2238_p N_noxref_6_c_2305_p N_noxref_6_c_2318_p \
 N_noxref_6_c_2323_p N_noxref_6_c_2316_p N_noxref_6_c_2402_p \
 N_noxref_6_c_2320_p N_noxref_6_c_2348_p N_noxref_6_c_2331_p \
 N_noxref_6_c_2336_p N_noxref_6_c_2329_p N_noxref_6_c_2394_p \
 N_noxref_6_c_2351_p N_noxref_6_c_2404_p N_noxref_6_c_2339_p \
 N_noxref_6_c_2575_p N_noxref_6_c_2193_n N_noxref_6_c_2353_p \
 N_noxref_6_c_2581_p N_noxref_6_c_2592_p N_noxref_6_c_2099_n \
 N_noxref_6_c_2100_n N_noxref_6_c_2104_n N_noxref_6_c_2502_p \
 N_noxref_6_c_2194_n N_noxref_6_c_2593_p N_noxref_6_c_2643_p \
 N_noxref_6_c_2578_p N_noxref_6_c_2582_p N_noxref_6_M14_noxref_g \
 N_noxref_6_M54_noxref_g N_noxref_6_M56_noxref_g N_noxref_6_M89_noxref_g \
 N_noxref_6_M90_noxref_g N_noxref_6_M169_noxref_g N_noxref_6_M170_noxref_g \
 N_noxref_6_M173_noxref_g N_noxref_6_M174_noxref_g N_noxref_6_c_2113_n \
 N_noxref_6_c_2115_n N_noxref_6_c_2118_n N_noxref_6_c_2119_n \
 N_noxref_6_c_2121_n N_noxref_6_c_2125_n N_noxref_6_c_2127_n \
 N_noxref_6_c_2690_p N_noxref_6_c_2691_p N_noxref_6_c_2693_p \
 N_noxref_6_c_2696_p N_noxref_6_c_2902_p N_noxref_6_c_2903_p \
 N_noxref_6_c_2644_p N_noxref_6_c_2645_p N_noxref_6_c_2692_p \
 N_noxref_6_c_2694_p N_noxref_6_c_2610_p N_noxref_6_c_2611_p \
 N_noxref_6_c_2613_p N_noxref_6_c_2603_p N_noxref_6_c_2911_p \
 N_noxref_6_c_2912_p N_noxref_6_c_2612_p N_noxref_6_c_2614_p \
 N_noxref_6_c_2131_n N_noxref_6_c_2132_n N_noxref_6_c_2134_n \
 N_noxref_6_c_2595_p N_noxref_6_c_2583_p N_noxref_6_M17_noxref_d \
 N_noxref_6_M91_noxref_d N_noxref_6_M93_noxref_d N_noxref_6_M95_noxref_d )  \
 PM_TMRDFFSNRNQX1\%noxref_6
x_PM_TMRDFFSNRNQX1\%noxref_7 ( N_noxref_7_c_3097_p N_noxref_7_c_3051_p \
 N_noxref_7_c_3030_p N_noxref_7_c_2977_n N_noxref_7_c_3010_p \
 N_noxref_7_c_3060_p N_noxref_7_c_3020_p N_noxref_7_c_2978_n \
 N_noxref_7_c_3001_p N_noxref_7_c_3003_p N_noxref_7_c_2979_n \
 N_noxref_7_c_3111_p N_noxref_7_c_3005_p N_noxref_7_c_3105_p \
 N_noxref_7_c_2981_n N_noxref_7_c_3021_p N_noxref_7_c_3022_p \
 N_noxref_7_c_3023_p N_noxref_7_c_2982_n N_noxref_7_c_2983_n \
 N_noxref_7_c_3148_p N_noxref_7_c_3013_p N_noxref_7_c_3007_p \
 N_noxref_7_c_3107_p N_noxref_7_c_2997_p N_noxref_7_c_3008_p \
 N_noxref_7_c_3040_p N_noxref_7_c_3108_p N_noxref_7_c_3025_p \
 N_noxref_7_c_3026_p N_noxref_7_c_3096_p N_noxref_7_c_3151_p \
 N_noxref_7_c_3018_p N_noxref_7_c_3110_p N_noxref_7_c_3115_p \
 N_noxref_7_c_3168_p N_noxref_7_c_3194_p N_noxref_7_M21_noxref_g \
 N_noxref_7_M24_noxref_g N_noxref_7_M103_noxref_g N_noxref_7_M104_noxref_g \
 N_noxref_7_M109_noxref_g N_noxref_7_M110_noxref_g N_noxref_7_c_3132_p \
 N_noxref_7_c_3133_p N_noxref_7_c_3135_p N_noxref_7_c_3113_p \
 N_noxref_7_c_3327_p N_noxref_7_c_3340_p N_noxref_7_c_3134_p \
 N_noxref_7_c_3136_p N_noxref_7_c_2990_n N_noxref_7_c_3117_p \
 N_noxref_7_c_3233_p N_noxref_7_c_3234_p N_noxref_7_c_3236_p \
 N_noxref_7_c_3170_p N_noxref_7_c_3330_p N_noxref_7_c_3350_p \
 N_noxref_7_c_3235_p N_noxref_7_c_3237_p N_noxref_7_c_2991_n \
 N_noxref_7_c_2992_n N_noxref_7_M20_noxref_d N_noxref_7_M97_noxref_d \
 N_noxref_7_M99_noxref_d N_noxref_7_M101_noxref_d )  PM_TMRDFFSNRNQX1\%noxref_7
x_PM_TMRDFFSNRNQX1\%noxref_8 ( N_noxref_8_c_3425_n N_noxref_8_c_3447_p \
 N_noxref_8_c_3458_p N_noxref_8_c_3416_n N_noxref_8_c_3480_p \
 N_noxref_8_c_3483_p N_noxref_8_c_3456_p N_noxref_8_c_3435_p \
 N_noxref_8_c_3439_p N_noxref_8_c_3441_p N_noxref_8_c_3417_n \
 N_noxref_8_c_3515_p N_noxref_8_c_3443_p N_noxref_8_c_3510_p \
 N_noxref_8_c_3419_n N_noxref_8_c_3420_n N_noxref_8_c_3571_p \
 N_noxref_8_c_3453_p N_noxref_8_c_3429_n N_noxref_8_c_3512_p \
 N_noxref_8_c_3438_p N_noxref_8_c_3446_p N_noxref_8_c_3513_p \
 N_noxref_8_c_3430_n N_noxref_8_c_3572_p N_noxref_8_c_3454_p \
 N_noxref_8_c_3514_p N_noxref_8_c_3519_p N_noxref_8_M27_noxref_g \
 N_noxref_8_M115_noxref_g N_noxref_8_M116_noxref_g N_noxref_8_c_3536_p \
 N_noxref_8_c_3537_p N_noxref_8_c_3539_p N_noxref_8_c_3517_p \
 N_noxref_8_c_3668_p N_noxref_8_c_3678_p N_noxref_8_c_3538_p \
 N_noxref_8_c_3540_p N_noxref_8_c_3423_n N_noxref_8_c_3424_n \
 N_noxref_8_M26_noxref_d N_noxref_8_M109_noxref_d N_noxref_8_M111_noxref_d \
 N_noxref_8_M113_noxref_d )  PM_TMRDFFSNRNQX1\%noxref_8
x_PM_TMRDFFSNRNQX1\%noxref_9 ( N_noxref_9_c_3734_n N_noxref_9_c_3735_n \
 N_noxref_9_c_3742_n N_noxref_9_c_3715_n N_noxref_9_c_3716_n \
 N_noxref_9_c_3718_n N_noxref_9_c_3814_n N_noxref_9_c_3815_n \
 N_noxref_9_c_3881_p N_noxref_9_c_3884_p N_noxref_9_c_3816_n \
 N_noxref_9_c_3753_n N_noxref_9_c_3754_n N_noxref_9_c_3760_n \
 N_noxref_9_c_3720_n N_noxref_9_c_3845_p N_noxref_9_c_3846_p \
 N_noxref_9_c_3847_p N_noxref_9_c_3723_n N_noxref_9_c_3762_n \
 N_noxref_9_c_3724_n N_noxref_9_c_3726_n N_noxref_9_c_3841_p \
 N_noxref_9_c_3831_p N_noxref_9_c_3954_p N_noxref_9_c_3768_n \
 N_noxref_9_c_3770_n N_noxref_9_c_3771_n N_noxref_9_c_3775_n \
 N_noxref_9_c_3850_p N_noxref_9_c_3776_n N_noxref_9_c_3777_n \
 N_noxref_9_c_3781_n N_noxref_9_c_3926_p N_noxref_9_c_3842_p \
 N_noxref_9_c_3966_p N_noxref_9_c_3956_p N_noxref_9_M20_noxref_g \
 N_noxref_9_M30_noxref_g N_noxref_9_M101_noxref_g N_noxref_9_M102_noxref_g \
 N_noxref_9_M121_noxref_g N_noxref_9_M122_noxref_g N_noxref_9_c_3790_n \
 N_noxref_9_c_3792_n N_noxref_9_c_3795_n N_noxref_9_c_3796_n \
 N_noxref_9_c_3798_n N_noxref_9_c_3802_n N_noxref_9_c_3804_n \
 N_noxref_9_c_4016_p N_noxref_9_c_4017_p N_noxref_9_c_4019_p \
 N_noxref_9_c_3967_p N_noxref_9_c_4154_p N_noxref_9_c_4164_p \
 N_noxref_9_c_4018_p N_noxref_9_c_4020_p N_noxref_9_c_3731_n \
 N_noxref_9_c_3732_n N_noxref_9_c_3808_n N_noxref_9_c_3809_n \
 N_noxref_9_c_3733_n N_noxref_9_M23_noxref_d N_noxref_9_M103_noxref_d \
 N_noxref_9_M105_noxref_d N_noxref_9_M107_noxref_d )  PM_TMRDFFSNRNQX1\%noxref_9
x_PM_TMRDFFSNRNQX1\%noxref_10 ( N_noxref_10_c_4207_n N_noxref_10_c_4258_p \
 N_noxref_10_c_4337_p N_noxref_10_c_4325_p N_noxref_10_c_4238_p \
 N_noxref_10_c_4363_p N_noxref_10_c_4239_p N_noxref_10_c_4216_p \
 N_noxref_10_c_4234_p N_noxref_10_c_4227_p N_noxref_10_c_4200_n \
 N_noxref_10_c_4246_p N_noxref_10_c_4217_p N_noxref_10_c_4218_p \
 N_noxref_10_c_4201_n N_noxref_10_c_4202_n N_noxref_10_c_4230_p \
 N_noxref_10_c_4332_p N_noxref_10_c_4322_p N_noxref_10_c_4268_p \
 N_noxref_10_c_4236_p N_noxref_10_c_4249_p N_noxref_10_c_4237_p \
 N_noxref_10_c_4211_n N_noxref_10_c_4233_p N_noxref_10_c_4333_p \
 N_noxref_10_c_4250_p N_noxref_10_c_4278_p N_noxref_10_M33_noxref_g \
 N_noxref_10_M127_noxref_g N_noxref_10_M128_noxref_g N_noxref_10_c_4301_p \
 N_noxref_10_c_4302_p N_noxref_10_c_4304_p N_noxref_10_c_4251_p \
 N_noxref_10_c_4452_p N_noxref_10_c_4462_p N_noxref_10_c_4303_p \
 N_noxref_10_c_4305_p N_noxref_10_c_4205_n N_noxref_10_c_4206_n \
 N_noxref_10_M32_noxref_d N_noxref_10_M121_noxref_d N_noxref_10_M123_noxref_d \
 N_noxref_10_M125_noxref_d )  PM_TMRDFFSNRNQX1\%noxref_10
x_PM_TMRDFFSNRNQX1\%noxref_11 ( N_noxref_11_c_4597_n N_noxref_11_c_4521_n \
 N_noxref_11_c_4604_n N_noxref_11_c_4499_n N_noxref_11_c_4532_n \
 N_noxref_11_c_4528_n N_noxref_11_c_4540_n N_noxref_11_c_4500_n \
 N_noxref_11_c_4501_n N_noxref_11_c_4503_n N_noxref_11_c_4675_n \
 N_noxref_11_c_4676_n N_noxref_11_c_4778_p N_noxref_11_c_4817_p \
 N_noxref_11_c_4677_n N_noxref_11_c_4549_n N_noxref_11_c_4615_n \
 N_noxref_11_c_4621_n N_noxref_11_c_4505_n N_noxref_11_c_4799_p \
 N_noxref_11_c_4678_n N_noxref_11_c_4705_p N_noxref_11_c_4508_n \
 N_noxref_11_c_4624_n N_noxref_11_c_4550_n N_noxref_11_c_4509_n \
 N_noxref_11_c_4511_n N_noxref_11_c_4780_p N_noxref_11_c_4772_p \
 N_noxref_11_c_4863_p N_noxref_11_c_4556_n N_noxref_11_c_4626_n \
 N_noxref_11_c_4628_n N_noxref_11_c_4632_n N_noxref_11_c_4531_n \
 N_noxref_11_c_4558_n N_noxref_11_c_4640_n N_noxref_11_c_4641_n \
 N_noxref_11_c_4559_n N_noxref_11_c_4560_n N_noxref_11_c_4564_n \
 N_noxref_11_c_4728_p N_noxref_11_c_4784_p N_noxref_11_c_4801_p \
 N_noxref_11_c_4865_p N_noxref_11_M23_noxref_g N_noxref_11_M26_noxref_g \
 N_noxref_11_M35_noxref_g N_noxref_11_M107_noxref_g N_noxref_11_M108_noxref_g \
 N_noxref_11_M113_noxref_g N_noxref_11_M114_noxref_g N_noxref_11_M131_noxref_g \
 N_noxref_11_M132_noxref_g N_noxref_11_c_4651_n N_noxref_11_c_4653_n \
 N_noxref_11_c_4656_n N_noxref_11_c_4657_n N_noxref_11_c_4659_n \
 N_noxref_11_c_4663_n N_noxref_11_c_4665_n N_noxref_11_c_4573_n \
 N_noxref_11_c_4575_n N_noxref_11_c_4578_n N_noxref_11_c_4579_n \
 N_noxref_11_c_4581_n N_noxref_11_c_4585_n N_noxref_11_c_4587_n \
 N_noxref_11_c_4910_p N_noxref_11_c_4911_p N_noxref_11_c_4912_p \
 N_noxref_11_c_4936_p N_noxref_11_c_4937_p N_noxref_11_c_4938_p \
 N_noxref_11_c_4939_p N_noxref_11_c_4669_n N_noxref_11_c_4670_n \
 N_noxref_11_c_4518_n N_noxref_11_c_4591_n N_noxref_11_c_4592_n \
 N_noxref_11_c_4519_n N_noxref_11_c_4802_p N_noxref_11_c_4916_p \
 N_noxref_11_c_4520_n N_noxref_11_M29_noxref_d N_noxref_11_M115_noxref_d \
 N_noxref_11_M117_noxref_d N_noxref_11_M119_noxref_d )  \
 PM_TMRDFFSNRNQX1\%noxref_11
x_PM_TMRDFFSNRNQX1\%D ( D D D D D D D D D D D D D D N_D_c_5337_p N_D_c_5315_p \
 N_D_c_5316_p N_D_c_5178_n N_D_c_5179_n N_D_c_5147_n N_D_c_5355_p N_D_c_5298_p \
 N_D_c_5184_n N_D_c_5110_n N_D_c_5117_n N_D_c_5125_n N_D_c_5126_n N_D_c_5141_n \
 N_D_c_5143_n N_D_c_5171_n N_D_c_5190_n N_D_c_5173_n N_D_c_5222_n N_D_c_5198_n \
 N_D_c_5202_n N_D_c_5203_n N_D_c_5204_n N_D_c_5318_p N_D_c_5339_p N_D_c_5319_p \
 N_D_c_5348_p N_D_c_5327_p N_D_c_5356_p N_D_c_5335_p N_D_M0_noxref_g \
 N_D_M18_noxref_g N_D_M36_noxref_g N_D_M61_noxref_g N_D_M62_noxref_g \
 N_D_M97_noxref_g N_D_M98_noxref_g N_D_M133_noxref_g N_D_M134_noxref_g \
 N_D_c_5407_p N_D_c_5408_p N_D_c_5410_p N_D_c_5340_p N_D_c_5555_p N_D_c_5570_p \
 N_D_c_5409_p N_D_c_5411_p N_D_c_5123_n N_D_c_5345_p N_D_c_5418_p N_D_c_5419_p \
 N_D_c_5421_p N_D_c_5349_p N_D_c_5558_p N_D_c_5580_p N_D_c_5420_p N_D_c_5422_p \
 N_D_c_5209_n N_D_c_5353_p N_D_c_5429_p N_D_c_5430_p N_D_c_5432_p N_D_c_5357_p \
 N_D_c_5561_p N_D_c_5590_p N_D_c_5431_p N_D_c_5433_p N_D_c_5210_n N_D_c_5211_n \
 )  PM_TMRDFFSNRNQX1\%D
x_PM_TMRDFFSNRNQX1\%noxref_13 ( N_noxref_13_c_5684_n N_noxref_13_c_5793_p \
 N_noxref_13_c_5772_p N_noxref_13_c_5671_n N_noxref_13_c_5752_p \
 N_noxref_13_c_5802_p N_noxref_13_c_5762_p N_noxref_13_c_5753_p \
 N_noxref_13_c_5699_p N_noxref_13_c_5745_p N_noxref_13_c_5672_n \
 N_noxref_13_c_5708_p N_noxref_13_c_5701_p N_noxref_13_c_5702_p \
 N_noxref_13_c_5674_n N_noxref_13_c_5763_p N_noxref_13_c_5764_p \
 N_noxref_13_c_5765_p N_noxref_13_c_5675_n N_noxref_13_c_5676_n \
 N_noxref_13_c_5825_p N_noxref_13_c_5755_p N_noxref_13_c_5749_p \
 N_noxref_13_c_5704_p N_noxref_13_c_5695_p N_noxref_13_c_5750_p \
 N_noxref_13_c_5782_p N_noxref_13_c_5705_p N_noxref_13_c_5767_p \
 N_noxref_13_c_5706_p N_noxref_13_c_5688_n N_noxref_13_c_5828_p \
 N_noxref_13_c_5760_p N_noxref_13_c_5707_p N_noxref_13_c_5712_p \
 N_noxref_13_c_5845_p N_noxref_13_c_5871_p N_noxref_13_M39_noxref_g \
 N_noxref_13_M42_noxref_g N_noxref_13_M139_noxref_g N_noxref_13_M140_noxref_g \
 N_noxref_13_M145_noxref_g N_noxref_13_M146_noxref_g N_noxref_13_c_5729_p \
 N_noxref_13_c_5730_p N_noxref_13_c_5732_p N_noxref_13_c_5710_p \
 N_noxref_13_c_6021_p N_noxref_13_c_6034_p N_noxref_13_c_5731_p \
 N_noxref_13_c_5733_p N_noxref_13_c_5681_n N_noxref_13_c_5714_p \
 N_noxref_13_c_5910_p N_noxref_13_c_5911_p N_noxref_13_c_5913_p \
 N_noxref_13_c_5847_p N_noxref_13_c_6024_p N_noxref_13_c_6044_p \
 N_noxref_13_c_5912_p N_noxref_13_c_5914_p N_noxref_13_c_5682_n \
 N_noxref_13_c_5683_n N_noxref_13_M38_noxref_d N_noxref_13_M133_noxref_d \
 N_noxref_13_M135_noxref_d N_noxref_13_M137_noxref_d )  \
 PM_TMRDFFSNRNQX1\%noxref_13
x_PM_TMRDFFSNRNQX1\%noxref_14 ( N_noxref_14_c_6120_n N_noxref_14_c_6221_p \
 N_noxref_14_c_6246_p N_noxref_14_c_6110_n N_noxref_14_c_6182_p \
 N_noxref_14_c_6271_p N_noxref_14_c_6183_p N_noxref_14_c_6173_p \
 N_noxref_14_c_6128_p N_noxref_14_c_6179_p N_noxref_14_c_6111_n \
 N_noxref_14_c_6136_p N_noxref_14_c_6130_p N_noxref_14_c_6131_p \
 N_noxref_14_c_6113_n N_noxref_14_c_6114_n N_noxref_14_c_6198_p \
 N_noxref_14_c_6241_p N_noxref_14_c_6124_n N_noxref_14_c_6133_p \
 N_noxref_14_c_6176_p N_noxref_14_c_6181_p N_noxref_14_c_6134_p \
 N_noxref_14_c_6125_n N_noxref_14_c_6199_p N_noxref_14_c_6242_p \
 N_noxref_14_c_6135_p N_noxref_14_c_6140_p N_noxref_14_M45_noxref_g \
 N_noxref_14_M151_noxref_g N_noxref_14_M152_noxref_g N_noxref_14_c_6157_p \
 N_noxref_14_c_6158_p N_noxref_14_c_6160_p N_noxref_14_c_6138_p \
 N_noxref_14_c_6363_p N_noxref_14_c_6373_p N_noxref_14_c_6159_p \
 N_noxref_14_c_6161_p N_noxref_14_c_6118_n N_noxref_14_c_6119_n \
 N_noxref_14_M44_noxref_d N_noxref_14_M145_noxref_d N_noxref_14_M147_noxref_d \
 N_noxref_14_M149_noxref_d )  PM_TMRDFFSNRNQX1\%noxref_14
x_PM_TMRDFFSNRNQX1\%CLK ( CLK CLK CLK CLK CLK CLK CLK CLK CLK CLK CLK CLK \
 N_CLK_c_6419_n N_CLK_c_6461_n N_CLK_c_6658_n N_CLK_c_6701_n N_CLK_c_6860_n \
 N_CLK_c_6903_n N_CLK_c_6422_n N_CLK_c_6464_n N_CLK_c_6592_n N_CLK_c_6595_n \
 N_CLK_c_6598_n N_CLK_c_6601_n N_CLK_c_6426_n N_CLK_c_6606_n N_CLK_c_6473_n \
 N_CLK_c_6616_n N_CLK_c_6619_n N_CLK_c_6840_n N_CLK_c_6623_n N_CLK_c_6627_n \
 N_CLK_c_6630_n N_CLK_c_6427_n N_CLK_c_6633_n N_CLK_c_6428_n N_CLK_c_6432_n \
 N_CLK_c_6474_n N_CLK_c_6478_n N_CLK_c_6668_n N_CLK_c_6672_n N_CLK_c_6711_n \
 N_CLK_c_6715_n N_CLK_c_6870_n N_CLK_c_6874_n N_CLK_c_6913_n N_CLK_c_6917_n \
 N_CLK_M4_noxref_g N_CLK_M10_noxref_g N_CLK_M22_noxref_g N_CLK_M28_noxref_g \
 N_CLK_M40_noxref_g N_CLK_M46_noxref_g N_CLK_M69_noxref_g N_CLK_M70_noxref_g \
 N_CLK_M81_noxref_g N_CLK_M82_noxref_g N_CLK_M105_noxref_g N_CLK_M106_noxref_g \
 N_CLK_M117_noxref_g N_CLK_M118_noxref_g N_CLK_M141_noxref_g \
 N_CLK_M142_noxref_g N_CLK_M153_noxref_g N_CLK_M154_noxref_g N_CLK_c_6439_n \
 N_CLK_c_6442_n N_CLK_c_7222_p N_CLK_c_7223_p N_CLK_c_6444_n N_CLK_c_6445_n \
 N_CLK_c_6446_n N_CLK_c_6447_n N_CLK_c_6521_n N_CLK_c_6485_n N_CLK_c_6488_n \
 N_CLK_c_7237_p N_CLK_c_7238_p N_CLK_c_6490_n N_CLK_c_6491_n N_CLK_c_6492_n \
 N_CLK_c_6493_n N_CLK_c_6586_n N_CLK_c_6679_n N_CLK_c_6682_n N_CLK_c_7252_p \
 N_CLK_c_7253_p N_CLK_c_6684_n N_CLK_c_6685_n N_CLK_c_6686_n N_CLK_c_6687_n \
 N_CLK_c_6647_n N_CLK_c_6722_n N_CLK_c_6725_n N_CLK_c_7267_p N_CLK_c_7268_p \
 N_CLK_c_6727_n N_CLK_c_6728_n N_CLK_c_6729_n N_CLK_c_6730_n N_CLK_c_6813_n \
 N_CLK_c_6881_n N_CLK_c_6884_n N_CLK_c_7282_p N_CLK_c_7283_p N_CLK_c_6886_n \
 N_CLK_c_6887_n N_CLK_c_6888_n N_CLK_c_6889_n N_CLK_c_6951_p N_CLK_c_6924_n \
 N_CLK_c_6927_n N_CLK_c_7297_p N_CLK_c_7298_p N_CLK_c_6929_n N_CLK_c_6930_n \
 N_CLK_c_6931_n N_CLK_c_6932_n N_CLK_c_6648_n N_CLK_c_6450_n N_CLK_c_6496_n \
 N_CLK_c_6690_n N_CLK_c_6733_n N_CLK_c_6892_n N_CLK_c_6935_n )  \
 PM_TMRDFFSNRNQX1\%CLK
x_PM_TMRDFFSNRNQX1\%noxref_16 ( N_noxref_16_c_7388_n N_noxref_16_c_7385_n \
 N_noxref_16_c_7396_n N_noxref_16_c_7371_n N_noxref_16_c_7372_n \
 N_noxref_16_c_7373_n N_noxref_16_c_7468_n N_noxref_16_c_7469_n \
 N_noxref_16_c_7527_p N_noxref_16_c_7681_p N_noxref_16_c_7470_n \
 N_noxref_16_c_7407_n N_noxref_16_c_7408_n N_noxref_16_c_7414_n \
 N_noxref_16_c_7375_n N_noxref_16_c_7517_p N_noxref_16_c_7501_p \
 N_noxref_16_c_7505_p N_noxref_16_c_7378_n N_noxref_16_c_7416_n \
 N_noxref_16_c_7379_n N_noxref_16_c_7381_n N_noxref_16_c_7638_p \
 N_noxref_16_c_7628_p N_noxref_16_c_7507_p N_noxref_16_c_7422_n \
 N_noxref_16_c_7424_n N_noxref_16_c_7425_n N_noxref_16_c_7429_n \
 N_noxref_16_c_7508_p N_noxref_16_c_7430_n N_noxref_16_c_7431_n \
 N_noxref_16_c_7435_n N_noxref_16_c_7491_n N_noxref_16_c_7639_p \
 N_noxref_16_c_7519_p N_noxref_16_c_7509_p N_noxref_16_M38_noxref_g \
 N_noxref_16_M48_noxref_g N_noxref_16_M137_noxref_g N_noxref_16_M138_noxref_g \
 N_noxref_16_M157_noxref_g N_noxref_16_M158_noxref_g N_noxref_16_c_7444_n \
 N_noxref_16_c_7446_n N_noxref_16_c_7449_n N_noxref_16_c_7450_n \
 N_noxref_16_c_7452_n N_noxref_16_c_7456_n N_noxref_16_c_7458_n \
 N_noxref_16_c_7569_p N_noxref_16_c_7570_p N_noxref_16_c_7572_p \
 N_noxref_16_c_7520_p N_noxref_16_c_7803_p N_noxref_16_c_7813_p \
 N_noxref_16_c_7571_p N_noxref_16_c_7573_p N_noxref_16_c_7523_p \
 N_noxref_16_c_7524_p N_noxref_16_c_7462_n N_noxref_16_c_7463_n \
 N_noxref_16_c_7384_n N_noxref_16_M41_noxref_d N_noxref_16_M139_noxref_d \
 N_noxref_16_M141_noxref_d N_noxref_16_M143_noxref_d )  \
 PM_TMRDFFSNRNQX1\%noxref_16
x_PM_TMRDFFSNRNQX1\%RN ( RN RN RN RN RN RN RN RN RN RN RN RN RN RN RN RN RN RN \
 RN RN RN RN RN RN RN RN RN RN RN N_RN_c_7850_n N_RN_c_7852_n N_RN_c_8045_n \
 N_RN_c_8048_n N_RN_c_7926_n N_RN_c_7930_n N_RN_c_8182_n N_RN_c_8124_n \
 N_RN_c_8374_n N_RN_c_8125_n N_RN_c_8258_n N_RN_c_8126_n N_RN_c_8476_n \
 N_RN_c_8127_n N_RN_c_8660_n N_RN_c_8128_n N_RN_c_8772_n N_RN_c_8131_n \
 N_RN_c_7855_n N_RN_c_7944_n N_RN_c_7890_n N_RN_c_7894_n N_RN_c_7897_n \
 N_RN_c_7947_n N_RN_c_7903_n N_RN_c_8006_n N_RN_c_7953_n N_RN_c_8014_n \
 N_RN_c_8018_n N_RN_c_8218_n N_RN_c_8024_n N_RN_c_8226_n N_RN_c_8229_n \
 N_RN_c_8275_n N_RN_c_8235_n N_RN_c_8335_n N_RN_c_8281_n N_RN_c_8343_n \
 N_RN_c_8347_n N_RN_c_8611_n N_RN_c_8353_n N_RN_c_8619_n N_RN_c_8622_n \
 N_RN_c_8628_n N_RN_c_8790_n N_RN_c_8792_n N_RN_c_7955_n N_RN_c_7874_n \
 N_RN_c_8071_n N_RN_c_8072_n N_RN_c_7961_n N_RN_c_7964_n N_RN_c_8283_n \
 N_RN_c_8150_n N_RN_c_8399_n N_RN_c_8400_n N_RN_c_8289_n N_RN_c_8151_n \
 N_RN_c_8513_n N_RN_c_8152_n N_RN_c_8702_n N_RN_c_8705_n N_RN_c_8803_n \
 N_RN_c_8806_n N_RN_M1_noxref_g N_RN_M11_noxref_g N_RN_M13_noxref_g \
 N_RN_M19_noxref_g N_RN_M29_noxref_g N_RN_M31_noxref_g N_RN_M37_noxref_g \
 N_RN_M47_noxref_g N_RN_M49_noxref_g N_RN_M63_noxref_g N_RN_M64_noxref_g \
 N_RN_M83_noxref_g N_RN_M84_noxref_g N_RN_M87_noxref_g N_RN_M88_noxref_g \
 N_RN_M99_noxref_g N_RN_M100_noxref_g N_RN_M119_noxref_g N_RN_M120_noxref_g \
 N_RN_M123_noxref_g N_RN_M124_noxref_g N_RN_M135_noxref_g N_RN_M136_noxref_g \
 N_RN_M155_noxref_g N_RN_M156_noxref_g N_RN_M159_noxref_g N_RN_M160_noxref_g \
 N_RN_c_8529_n N_RN_c_8532_n N_RN_c_9151_p N_RN_c_9152_p N_RN_c_7974_n \
 N_RN_c_7975_n N_RN_c_7976_n N_RN_c_7977_n N_RN_c_7882_n N_RN_c_8082_n \
 N_RN_c_8084_n N_RN_c_8087_n N_RN_c_8088_n N_RN_c_8090_n N_RN_c_8094_n \
 N_RN_c_8096_n N_RN_c_7982_n N_RN_c_7985_n N_RN_c_9193_p N_RN_c_9194_p \
 N_RN_c_7987_n N_RN_c_7988_n N_RN_c_7989_n N_RN_c_7990_n N_RN_c_8033_n \
 N_RN_c_8540_n N_RN_c_8543_n N_RN_c_9216_p N_RN_c_9217_p N_RN_c_8302_n \
 N_RN_c_8303_n N_RN_c_8304_n N_RN_c_8305_n N_RN_c_8173_n N_RN_c_8410_n \
 N_RN_c_8412_n N_RN_c_8415_n N_RN_c_8416_n N_RN_c_8418_n N_RN_c_8422_n \
 N_RN_c_8424_n N_RN_c_8310_n N_RN_c_8313_n N_RN_c_9258_p N_RN_c_9259_p \
 N_RN_c_8315_n N_RN_c_8316_n N_RN_c_8317_n N_RN_c_8318_n N_RN_c_8174_n \
 N_RN_c_8551_n N_RN_c_8554_n N_RN_c_9281_p N_RN_c_9282_p N_RN_c_8556_n \
 N_RN_c_8557_n N_RN_c_8558_n N_RN_c_8559_n N_RN_c_8175_n N_RN_c_8723_n \
 N_RN_c_8724_n N_RN_c_8725_n N_RN_c_8964_p N_RN_c_8965_p N_RN_c_8966_p \
 N_RN_c_8967_p N_RN_c_8824_n N_RN_c_8827_n N_RN_c_9321_p N_RN_c_9322_p \
 N_RN_c_8829_n N_RN_c_8830_n N_RN_c_8831_n N_RN_c_8832_n N_RN_c_8854_p \
 N_RN_c_7884_n N_RN_c_8100_n N_RN_c_8101_n N_RN_c_8103_n N_RN_c_7996_n \
 N_RN_c_8216_n N_RN_c_8428_n N_RN_c_8429_n N_RN_c_8179_n N_RN_c_8324_n \
 N_RN_c_8570_n N_RN_c_8742_n N_RN_c_8745_n N_RN_c_8180_n N_RN_c_8838_n )  \
 PM_TMRDFFSNRNQX1\%RN
x_PM_TMRDFFSNRNQX1\%noxref_18 ( N_noxref_18_c_9556_n N_noxref_18_c_9568_n \
 N_noxref_18_c_9654_p N_noxref_18_c_9551_n N_noxref_18_c_9640_p \
 N_noxref_18_c_9696_p N_noxref_18_c_9653_p N_noxref_18_c_9632_p \
 N_noxref_18_c_9583_p N_noxref_18_c_9597_p N_noxref_18_c_9552_n \
 N_noxref_18_c_9580_p N_noxref_18_c_9584_p N_noxref_18_c_9585_p \
 N_noxref_18_c_9553_n N_noxref_18_c_9554_n N_noxref_18_c_9555_n \
 N_noxref_18_c_9648_p N_noxref_18_c_9649_p N_noxref_18_c_9587_p \
 N_noxref_18_c_9601_p N_noxref_18_c_9588_p N_noxref_18_c_9603_p \
 N_noxref_18_c_9560_n N_noxref_18_c_9576_n N_noxref_18_c_9651_p \
 N_noxref_18_c_9581_p N_noxref_18_c_9593_p N_noxref_18_M51_noxref_g \
 N_noxref_18_M163_noxref_g N_noxref_18_M164_noxref_g N_noxref_18_c_9615_p \
 N_noxref_18_c_9616_p N_noxref_18_c_9618_p N_noxref_18_c_9582_p \
 N_noxref_18_c_9787_p N_noxref_18_c_9797_p N_noxref_18_c_9617_p \
 N_noxref_18_c_9619_p N_noxref_18_c_9594_p N_noxref_18_c_9595_p \
 N_noxref_18_M50_noxref_d N_noxref_18_M157_noxref_d N_noxref_18_M159_noxref_d \
 N_noxref_18_M161_noxref_d )  PM_TMRDFFSNRNQX1\%noxref_18
x_PM_TMRDFFSNRNQX1\%SN ( SN SN SN SN SN SN SN SN SN SN N_SN_c_9841_n \
 N_SN_c_9844_n N_SN_c_9845_n N_SN_c_9931_n N_SN_c_9934_n N_SN_c_9935_n \
 N_SN_c_10111_n N_SN_c_10114_n N_SN_c_10068_n N_SN_c_10239_n N_SN_c_10242_n \
 N_SN_c_10069_n N_SN_c_10394_n N_SN_c_10397_n N_SN_c_10070_n N_SN_c_10624_n \
 N_SN_c_10627_n N_SN_c_10634_n N_SN_c_10071_n N_SN_c_10640_n N_SN_c_9884_n \
 N_SN_c_9887_n N_SN_c_9890_n N_SN_c_9894_n N_SN_c_9915_n N_SN_c_9918_n \
 N_SN_c_10119_n N_SN_c_9921_n N_SN_c_10122_n N_SN_c_10126_n N_SN_c_10131_n \
 N_SN_c_10134_n N_SN_c_10135_n N_SN_c_10137_n N_SN_c_10141_n N_SN_c_10178_n \
 N_SN_c_10143_n N_SN_c_10184_n N_SN_c_10188_n N_SN_c_10225_n N_SN_c_10228_n \
 N_SN_c_10790_p N_SN_c_10248_n N_SN_c_10402_n N_SN_c_10255_n N_SN_c_10405_n \
 N_SN_c_10409_n N_SN_c_10414_n N_SN_c_10417_n N_SN_c_10418_n N_SN_c_10420_n \
 N_SN_c_10424_n N_SN_c_10461_n N_SN_c_10426_n N_SN_c_10467_n N_SN_c_10471_n \
 N_SN_c_10502_n N_SN_c_10530_n N_SN_c_9849_n N_SN_c_10256_n N_SN_c_9850_n \
 N_SN_c_9854_n N_SN_c_9947_n N_SN_c_9951_n N_SN_c_10144_n N_SN_c_10083_n \
 N_SN_c_10257_n N_SN_c_10084_n N_SN_c_10427_n N_SN_c_10085_n N_SN_c_10648_n \
 N_SN_c_10652_n N_SN_M7_noxref_g N_SN_M16_noxref_g N_SN_M25_noxref_g \
 N_SN_M34_noxref_g N_SN_M43_noxref_g N_SN_M52_noxref_g N_SN_M75_noxref_g \
 N_SN_M76_noxref_g N_SN_M93_noxref_g N_SN_M94_noxref_g N_SN_M111_noxref_g \
 N_SN_M112_noxref_g N_SN_M129_noxref_g N_SN_M130_noxref_g N_SN_M147_noxref_g \
 N_SN_M148_noxref_g N_SN_M165_noxref_g N_SN_M166_noxref_g N_SN_c_9861_n \
 N_SN_c_9864_n N_SN_c_10866_p N_SN_c_10867_p N_SN_c_9866_n N_SN_c_9867_n \
 N_SN_c_9868_n N_SN_c_9869_n N_SN_c_9904_n N_SN_c_9958_n N_SN_c_9961_n \
 N_SN_c_10882_p N_SN_c_10883_p N_SN_c_9963_n N_SN_c_9964_n N_SN_c_9965_n \
 N_SN_c_9966_n N_SN_c_10049_n N_SN_c_10155_n N_SN_c_10158_n N_SN_c_10897_p \
 N_SN_c_10898_p N_SN_c_10160_n N_SN_c_10161_n N_SN_c_10162_n N_SN_c_10163_n \
 N_SN_c_10100_n N_SN_c_10268_n N_SN_c_10271_n N_SN_c_10913_p N_SN_c_10914_p \
 N_SN_c_10273_n N_SN_c_10274_n N_SN_c_10275_n N_SN_c_10276_n N_SN_c_10101_n \
 N_SN_c_10438_n N_SN_c_10441_n N_SN_c_10928_p N_SN_c_10929_p N_SN_c_10443_n \
 N_SN_c_10444_n N_SN_c_10445_n N_SN_c_10446_n N_SN_c_10102_n N_SN_c_10659_n \
 N_SN_c_10662_n N_SN_c_10946_p N_SN_c_10947_p N_SN_c_10664_n N_SN_c_10665_n \
 N_SN_c_10666_n N_SN_c_10667_n N_SN_c_10758_p N_SN_c_9872_n N_SN_c_9969_n \
 N_SN_c_10166_n N_SN_c_10279_n N_SN_c_10449_n N_SN_c_10670_n )  \
 PM_TMRDFFSNRNQX1\%SN
x_PM_TMRDFFSNRNQX1\%noxref_20 ( N_noxref_20_c_11147_n N_noxref_20_c_11071_n \
 N_noxref_20_c_11152_n N_noxref_20_c_11043_n N_noxref_20_c_11082_n \
 N_noxref_20_c_11078_n N_noxref_20_c_11090_n N_noxref_20_c_11044_n \
 N_noxref_20_c_11045_n N_noxref_20_c_11047_n N_noxref_20_c_11284_n \
 N_noxref_20_c_11050_n N_noxref_20_c_11289_n N_noxref_20_c_11297_n \
 N_noxref_20_c_11302_n N_noxref_20_c_11099_n N_noxref_20_c_11164_n \
 N_noxref_20_c_11225_n N_noxref_20_c_11051_n N_noxref_20_c_11367_n \
 N_noxref_20_c_11054_n N_noxref_20_c_11376_n N_noxref_20_c_11055_n \
 N_noxref_20_c_11166_n N_noxref_20_c_11100_n N_noxref_20_c_11057_n \
 N_noxref_20_c_11059_n N_noxref_20_c_11319_n N_noxref_20_c_11323_n \
 N_noxref_20_c_11381_n N_noxref_20_c_11060_n N_noxref_20_c_11063_n \
 N_noxref_20_c_11064_n N_noxref_20_c_11174_n N_noxref_20_c_11081_n \
 N_noxref_20_c_11108_n N_noxref_20_c_11176_n N_noxref_20_c_11180_n \
 N_noxref_20_c_11109_n N_noxref_20_c_11110_n N_noxref_20_c_11114_n \
 N_noxref_20_c_11183_n N_noxref_20_c_11330_n N_noxref_20_c_11403_n \
 N_noxref_20_c_11407_n N_noxref_20_M41_noxref_g N_noxref_20_M44_noxref_g \
 N_noxref_20_M53_noxref_g N_noxref_20_M143_noxref_g N_noxref_20_M144_noxref_g \
 N_noxref_20_M149_noxref_g N_noxref_20_M150_noxref_g N_noxref_20_M167_noxref_g \
 N_noxref_20_M168_noxref_g N_noxref_20_c_11190_n N_noxref_20_c_11191_n \
 N_noxref_20_c_11192_n N_noxref_20_c_11261_n N_noxref_20_c_11263_n \
 N_noxref_20_c_11267_n N_noxref_20_c_11269_n N_noxref_20_c_11123_n \
 N_noxref_20_c_11125_n N_noxref_20_c_11128_n N_noxref_20_c_11129_n \
 N_noxref_20_c_11131_n N_noxref_20_c_11135_n N_noxref_20_c_11137_n \
 N_noxref_20_c_11419_n N_noxref_20_c_11420_n N_noxref_20_c_11421_n \
 N_noxref_20_c_11449_p N_noxref_20_c_11450_p N_noxref_20_c_11451_p \
 N_noxref_20_c_11452_p N_noxref_20_c_11193_n N_noxref_20_c_11196_n \
 N_noxref_20_c_11069_n N_noxref_20_c_11141_n N_noxref_20_c_11142_n \
 N_noxref_20_c_11070_n N_noxref_20_c_11430_n N_noxref_20_c_11433_n \
 N_noxref_20_c_11434_n N_noxref_20_M47_noxref_d N_noxref_20_M151_noxref_d \
 N_noxref_20_M153_noxref_d N_noxref_20_M155_noxref_d )  \
 PM_TMRDFFSNRNQX1\%noxref_20
x_PM_TMRDFFSNRNQX1\%noxref_21 ( N_noxref_21_c_11711_n N_noxref_21_c_11652_n \
 N_noxref_21_c_11756_n N_noxref_21_c_11828_n N_noxref_21_c_11854_n \
 N_noxref_21_c_11653_n N_noxref_21_c_11860_n N_noxref_21_c_11866_n \
 N_noxref_21_c_11871_n N_noxref_21_c_11757_n N_noxref_21_c_11654_n \
 N_noxref_21_c_11655_n N_noxref_21_c_11657_n N_noxref_21_c_11661_n \
 N_noxref_21_c_11664_n N_noxref_21_c_11921_p N_noxref_21_c_11669_n \
 N_noxref_21_c_11670_n N_noxref_21_c_11671_n N_noxref_21_c_11888_n \
 N_noxref_21_c_11891_n N_noxref_21_c_11763_n N_noxref_21_c_11767_n \
 N_noxref_21_c_11771_n N_noxref_21_c_11775_n N_noxref_21_c_11672_n \
 N_noxref_21_c_11681_n N_noxref_21_c_11684_n N_noxref_21_c_11721_n \
 N_noxref_21_c_11922_p N_noxref_21_c_11953_p N_noxref_21_c_11723_n \
 N_noxref_21_c_11726_n N_noxref_21_c_11788_n N_noxref_21_c_11847_n \
 N_noxref_21_c_11903_n N_noxref_21_c_11685_n N_noxref_21_c_11689_n \
 N_noxref_21_c_11923_p N_noxref_21_c_11932_p N_noxref_21_M50_noxref_g \
 N_noxref_21_M57_noxref_g N_noxref_21_M58_noxref_g N_noxref_21_M161_noxref_g \
 N_noxref_21_M162_noxref_g N_noxref_21_M175_noxref_g N_noxref_21_M176_noxref_g \
 N_noxref_21_M177_noxref_g N_noxref_21_M178_noxref_g N_noxref_21_c_11733_n \
 N_noxref_21_c_11734_n N_noxref_21_c_11735_n N_noxref_21_c_11803_n \
 N_noxref_21_c_11805_n N_noxref_21_c_11809_n N_noxref_21_c_11811_n \
 N_noxref_21_c_11695_n N_noxref_21_c_11698_n N_noxref_21_c_12141_p \
 N_noxref_21_c_11700_n N_noxref_21_c_11994_p N_noxref_21_c_11995_p \
 N_noxref_21_c_11702_n N_noxref_21_c_11704_n N_noxref_21_c_11705_n \
 N_noxref_21_c_11706_n N_noxref_21_c_11707_n N_noxref_21_c_11965_p \
 N_noxref_21_c_11966_p N_noxref_21_c_11968_p N_noxref_21_c_11971_p \
 N_noxref_21_c_12165_p N_noxref_21_c_12166_p N_noxref_21_c_11933_p \
 N_noxref_21_c_11934_p N_noxref_21_c_11967_p N_noxref_21_c_11969_p \
 N_noxref_21_c_11736_n N_noxref_21_c_11738_n N_noxref_21_c_11739_n \
 N_noxref_21_c_11924_p N_noxref_21_M53_noxref_d N_noxref_21_M163_noxref_d \
 N_noxref_21_M165_noxref_d N_noxref_21_M167_noxref_d )  \
 PM_TMRDFFSNRNQX1\%noxref_21
x_PM_TMRDFFSNRNQX1\%noxref_22 ( N_noxref_22_c_12335_n N_noxref_22_c_12331_n \
 N_noxref_22_c_12343_n N_noxref_22_c_12247_n N_noxref_22_c_12353_n \
 N_noxref_22_c_12405_n N_noxref_22_c_12407_n N_noxref_22_c_12409_n \
 N_noxref_22_c_12413_n N_noxref_22_c_12419_n N_noxref_22_c_12424_n \
 N_noxref_22_c_12354_n N_noxref_22_c_12426_n N_noxref_22_c_12431_n \
 N_noxref_22_c_12248_n N_noxref_22_c_12249_n N_noxref_22_c_12253_n \
 N_noxref_22_c_12256_n N_noxref_22_c_12259_n N_noxref_22_c_12668_n \
 N_noxref_22_c_12672_n N_noxref_22_c_12676_n N_noxref_22_c_12677_n \
 N_noxref_22_c_12333_n N_noxref_22_c_12269_n N_noxref_22_c_12600_n \
 N_noxref_22_c_12439_n N_noxref_22_c_12442_n N_noxref_22_c_12270_n \
 N_noxref_22_c_12682_n N_noxref_22_c_12361_n N_noxref_22_c_12334_n \
 N_noxref_22_c_12445_n N_noxref_22_c_12447_n N_noxref_22_c_12450_n \
 N_noxref_22_c_12480_n N_noxref_22_c_12453_n N_noxref_22_c_12271_n \
 N_noxref_22_c_12272_n N_noxref_22_c_12273_n N_noxref_22_c_12507_n \
 N_noxref_22_c_12275_n N_noxref_22_c_12277_n N_noxref_22_c_12278_n \
 N_noxref_22_c_12279_n N_noxref_22_c_12280_n N_noxref_22_c_12285_n \
 N_noxref_22_c_12286_n N_noxref_22_c_12287_n N_noxref_22_c_12288_n \
 N_noxref_22_c_12290_n N_noxref_22_c_12294_n N_noxref_22_c_12692_n \
 N_noxref_22_c_12297_n N_noxref_22_c_12365_n N_noxref_22_c_12366_n \
 N_noxref_22_c_12370_n N_noxref_22_c_12629_n N_noxref_22_c_12456_n \
 N_noxref_22_c_12301_n N_noxref_22_c_12305_n N_noxref_22_c_12702_n \
 N_noxref_22_c_12705_n N_noxref_22_M32_noxref_g N_noxref_22_M55_noxref_g \
 N_noxref_22_M59_noxref_g N_noxref_22_M125_noxref_g N_noxref_22_M126_noxref_g \
 N_noxref_22_M171_noxref_g N_noxref_22_M172_noxref_g N_noxref_22_M179_noxref_g \
 N_noxref_22_M180_noxref_g N_noxref_22_c_12379_n N_noxref_22_c_12381_n \
 N_noxref_22_c_12384_n N_noxref_22_c_12385_n N_noxref_22_c_12387_n \
 N_noxref_22_c_12391_n N_noxref_22_c_12393_n N_noxref_22_c_12313_n \
 N_noxref_22_c_12316_n N_noxref_22_c_12318_n N_noxref_22_c_12860_p \
 N_noxref_22_c_12773_p N_noxref_22_c_12774_p N_noxref_22_c_12321_n \
 N_noxref_22_c_12322_n N_noxref_22_c_12712_n N_noxref_22_c_12715_n \
 N_noxref_22_c_12717_n N_noxref_22_c_12766_p N_noxref_22_c_12743_p \
 N_noxref_22_c_12720_n N_noxref_22_c_12721_n N_noxref_22_c_12722_n \
 N_noxref_22_c_12397_n N_noxref_22_c_12398_n N_noxref_22_c_12323_n \
 N_noxref_22_c_12324_n N_noxref_22_c_12976_p N_noxref_22_c_12327_n \
 N_noxref_22_c_12724_n N_noxref_22_c_12752_p N_noxref_22_c_12727_n \
 N_noxref_22_M35_noxref_d N_noxref_22_M127_noxref_d N_noxref_22_M129_noxref_d \
 N_noxref_22_M131_noxref_d )  PM_TMRDFFSNRNQX1\%noxref_22
x_PM_TMRDFFSNRNQX1\%noxref_23 ( N_noxref_23_c_12994_n N_noxref_23_c_13044_n \
 N_noxref_23_c_13054_n N_noxref_23_c_13056_n N_noxref_23_c_13057_n \
 N_noxref_23_c_13058_n N_noxref_23_c_12995_n N_noxref_23_c_13066_n \
 N_noxref_23_c_12997_n N_noxref_23_c_13074_n N_noxref_23_c_13138_p \
 N_noxref_23_c_13075_n N_noxref_23_c_12998_n N_noxref_23_c_13001_n \
 N_noxref_23_c_13009_n N_noxref_23_c_13084_n N_noxref_23_c_13088_n \
 N_noxref_23_c_13144_p N_noxref_23_c_13139_p N_noxref_23_c_13012_n \
 N_noxref_23_c_12990_n N_noxref_23_c_13015_n N_noxref_23_c_13091_n \
 N_noxref_23_c_13016_n N_noxref_23_c_13096_n N_noxref_23_c_13145_p \
 N_noxref_23_c_13195_p N_noxref_23_c_13027_n N_noxref_23_c_13099_n \
 N_noxref_23_c_13140_p N_noxref_23_c_13149_p N_noxref_23_M60_noxref_g \
 N_noxref_23_M181_noxref_g N_noxref_23_M182_noxref_g N_noxref_23_c_13154_p \
 N_noxref_23_c_13120_p N_noxref_23_c_13121_p N_noxref_23_c_13122_p \
 N_noxref_23_c_13135_p N_noxref_23_c_13151_p N_noxref_23_c_13156_p \
 N_noxref_23_c_13123_p N_noxref_23_c_13158_p N_noxref_23_c_13124_p \
 N_noxref_23_c_13131_p N_noxref_23_M55_noxref_d N_noxref_23_M57_noxref_d \
 N_noxref_23_M59_noxref_d N_noxref_23_M177_noxref_d N_noxref_23_M179_noxref_d ) \
 PM_TMRDFFSNRNQX1\%noxref_23
x_PM_TMRDFFSNRNQX1\%Q ( N_Q_c_13334_n N_Q_c_13343_n N_Q_c_13347_n \
 N_Q_c_13348_n N_Q_c_13350_n N_Q_c_13351_n N_Q_c_13354_n N_Q_c_13360_n \
 N_Q_c_13365_n N_Q_c_13370_n N_Q_c_13378_n Q N_Q_c_13383_n N_Q_M60_noxref_d \
 N_Q_M181_noxref_d )  PM_TMRDFFSNRNQX1\%Q
x_PM_TMRDFFSNRNQX1\%VDD ( VDD N_VDD_c_13434_n N_VDD_c_13737_n N_VDD_c_13738_n \
 N_VDD_c_14756_p N_VDD_c_13739_n N_VDD_c_13740_n N_VDD_c_14758_p \
 N_VDD_c_14628_n N_VDD_c_14629_n N_VDD_c_14694_n N_VDD_c_14116_n \
 N_VDD_c_13443_n N_VDD_c_13445_n N_VDD_c_13448_n N_VDD_c_13452_n \
 N_VDD_c_13456_n N_VDD_c_13457_n N_VDD_c_13563_n N_VDD_c_13567_n \
 N_VDD_c_13571_n N_VDD_c_13459_n N_VDD_c_13508_n N_VDD_c_13512_n \
 N_VDD_c_13516_n N_VDD_c_13517_n N_VDD_c_13674_n N_VDD_c_13678_n \
 N_VDD_c_13682_n N_VDD_c_13572_n N_VDD_c_13618_n N_VDD_c_13622_n \
 N_VDD_c_13626_n N_VDD_c_13627_n N_VDD_c_13746_n N_VDD_c_13683_n \
 N_VDD_c_13754_n N_VDD_c_13844_n N_VDD_c_13847_n N_VDD_c_13851_n \
 N_VDD_c_13855_n N_VDD_c_13856_n N_VDD_c_13964_n N_VDD_c_13968_n \
 N_VDD_c_13972_n N_VDD_c_13858_n N_VDD_c_13909_n N_VDD_c_13913_n \
 N_VDD_c_13917_n N_VDD_c_13918_n N_VDD_c_14074_n N_VDD_c_14078_n \
 N_VDD_c_14082_n N_VDD_c_13973_n N_VDD_c_14018_n N_VDD_c_14022_n \
 N_VDD_c_14026_n N_VDD_c_14027_n N_VDD_c_14484_n N_VDD_c_14083_n \
 N_VDD_c_14643_n N_VDD_c_14128_n N_VDD_c_14129_n N_VDD_c_14187_n \
 N_VDD_c_14191_n N_VDD_c_14195_n N_VDD_c_14196_n N_VDD_c_14296_n \
 N_VDD_c_14347_n N_VDD_c_14351_n N_VDD_c_14198_n N_VDD_c_14249_n \
 N_VDD_c_14253_n N_VDD_c_14257_n N_VDD_c_14258_n N_VDD_c_14298_n \
 N_VDD_c_14400_n N_VDD_c_14527_n N_VDD_c_14352_n N_VDD_c_14402_n \
 N_VDD_c_14443_n N_VDD_c_14447_n N_VDD_c_14448_n N_VDD_c_14488_n \
 N_VDD_c_14528_n N_VDD_c_14581_n N_VDD_c_13757_n N_VDD_c_13760_n \
 N_VDD_c_14584_n N_VDD_c_14703_n N_VDD_c_13461_n N_VDD_c_13467_n \
 N_VDD_c_13521_n N_VDD_c_13581_n N_VDD_c_13631_n N_VDD_c_13694_n \
 N_VDD_c_13773_n N_VDD_c_13775_n N_VDD_c_13776_n N_VDD_c_13778_n \
 N_VDD_c_13779_n N_VDD_c_13780_n N_VDD_c_13781_n N_VDD_c_13783_n \
 N_VDD_c_13784_n N_VDD_c_13786_n N_VDD_c_13787_n N_VDD_c_13788_n \
 N_VDD_c_13794_n N_VDD_c_13800_n N_VDD_c_14673_n N_VDD_c_14720_n \
 N_VDD_M61_noxref_s N_VDD_M62_noxref_d N_VDD_M64_noxref_d N_VDD_M66_noxref_d \
 N_VDD_M67_noxref_s N_VDD_M68_noxref_d N_VDD_M70_noxref_d N_VDD_M72_noxref_d \
 N_VDD_M73_noxref_s N_VDD_M74_noxref_d N_VDD_M76_noxref_d N_VDD_M78_noxref_d \
 N_VDD_M79_noxref_s N_VDD_M80_noxref_d N_VDD_M82_noxref_d N_VDD_M84_noxref_d \
 N_VDD_M85_noxref_s N_VDD_M86_noxref_d N_VDD_M88_noxref_d N_VDD_M90_noxref_d \
 N_VDD_M91_noxref_s N_VDD_M92_noxref_d N_VDD_M94_noxref_d N_VDD_M96_noxref_d \
 N_VDD_M97_noxref_s N_VDD_M98_noxref_d N_VDD_M100_noxref_d N_VDD_M102_noxref_d \
 N_VDD_M103_noxref_s N_VDD_M104_noxref_d N_VDD_M106_noxref_d \
 N_VDD_M108_noxref_d N_VDD_M109_noxref_s N_VDD_M110_noxref_d \
 N_VDD_M112_noxref_d N_VDD_M114_noxref_d N_VDD_M115_noxref_s \
 N_VDD_M116_noxref_d N_VDD_M118_noxref_d N_VDD_M120_noxref_d \
 N_VDD_M121_noxref_s N_VDD_M122_noxref_d N_VDD_M124_noxref_d \
 N_VDD_M126_noxref_d N_VDD_M127_noxref_s N_VDD_M128_noxref_d \
 N_VDD_M130_noxref_d N_VDD_M132_noxref_d N_VDD_M133_noxref_s \
 N_VDD_M134_noxref_d N_VDD_M136_noxref_d N_VDD_M138_noxref_d \
 N_VDD_M139_noxref_s N_VDD_M140_noxref_d N_VDD_M142_noxref_d \
 N_VDD_M144_noxref_d N_VDD_M145_noxref_s N_VDD_M146_noxref_d \
 N_VDD_M148_noxref_d N_VDD_M150_noxref_d N_VDD_M151_noxref_s \
 N_VDD_M152_noxref_d N_VDD_M154_noxref_d N_VDD_M156_noxref_d \
 N_VDD_M157_noxref_s N_VDD_M158_noxref_d N_VDD_M160_noxref_d \
 N_VDD_M162_noxref_d N_VDD_M163_noxref_s N_VDD_M164_noxref_d \
 N_VDD_M166_noxref_d N_VDD_M168_noxref_d N_VDD_M169_noxref_s \
 N_VDD_M170_noxref_d N_VDD_M172_noxref_d N_VDD_M181_noxref_s \
 N_VDD_M182_noxref_d )  PM_TMRDFFSNRNQX1\%VDD
x_PM_TMRDFFSNRNQX1\%noxref_26 ( N_noxref_26_c_14902_n N_noxref_26_c_14922_p \
 N_noxref_26_c_14881_n N_noxref_26_c_14924_p N_noxref_26_c_14884_n \
 N_noxref_26_M1_noxref_d N_noxref_26_M2_noxref_s )  PM_TMRDFFSNRNQX1\%noxref_26
x_PM_TMRDFFSNRNQX1\%noxref_27 ( N_noxref_27_c_14969_n N_noxref_27_c_14989_p \
 N_noxref_27_c_14948_n N_noxref_27_c_14991_p N_noxref_27_c_14951_n \
 N_noxref_27_M4_noxref_d N_noxref_27_M5_noxref_s )  PM_TMRDFFSNRNQX1\%noxref_27
x_PM_TMRDFFSNRNQX1\%noxref_28 ( N_noxref_28_c_15037_n N_noxref_28_c_15057_p \
 N_noxref_28_c_15014_n N_noxref_28_c_15059_p N_noxref_28_c_15017_n \
 N_noxref_28_M7_noxref_d N_noxref_28_M8_noxref_s )  PM_TMRDFFSNRNQX1\%noxref_28
x_PM_TMRDFFSNRNQX1\%noxref_29 ( N_noxref_29_c_15094_n N_noxref_29_c_15124_p \
 N_noxref_29_c_15083_n N_noxref_29_c_15126_p N_noxref_29_c_15086_n \
 N_noxref_29_M10_noxref_d N_noxref_29_M11_noxref_s )  \
 PM_TMRDFFSNRNQX1\%noxref_29
x_PM_TMRDFFSNRNQX1\%noxref_30 ( N_noxref_30_c_15171_n N_noxref_30_c_15192_p \
 N_noxref_30_c_15149_n N_noxref_30_c_15194_p N_noxref_30_c_15152_n \
 N_noxref_30_M13_noxref_d N_noxref_30_M14_noxref_s )  \
 PM_TMRDFFSNRNQX1\%noxref_30
x_PM_TMRDFFSNRNQX1\%noxref_31 ( N_noxref_31_c_15240_n N_noxref_31_c_15261_p \
 N_noxref_31_c_15218_n N_noxref_31_c_15263_p N_noxref_31_c_15223_n \
 N_noxref_31_M16_noxref_d N_noxref_31_M17_noxref_s )  \
 PM_TMRDFFSNRNQX1\%noxref_31
x_PM_TMRDFFSNRNQX1\%noxref_32 ( N_noxref_32_c_15308_n N_noxref_32_c_15328_p \
 N_noxref_32_c_15287_n N_noxref_32_c_15330_p N_noxref_32_c_15290_n \
 N_noxref_32_M19_noxref_d N_noxref_32_M20_noxref_s )  \
 PM_TMRDFFSNRNQX1\%noxref_32
x_PM_TMRDFFSNRNQX1\%noxref_33 ( N_noxref_33_c_15375_n N_noxref_33_c_15395_p \
 N_noxref_33_c_15354_n N_noxref_33_c_15397_p N_noxref_33_c_15357_n \
 N_noxref_33_M22_noxref_d N_noxref_33_M23_noxref_s )  \
 PM_TMRDFFSNRNQX1\%noxref_33
x_PM_TMRDFFSNRNQX1\%noxref_34 ( N_noxref_34_c_15443_n N_noxref_34_c_15463_p \
 N_noxref_34_c_15420_n N_noxref_34_c_15465_p N_noxref_34_c_15423_n \
 N_noxref_34_M25_noxref_d N_noxref_34_M26_noxref_s )  \
 PM_TMRDFFSNRNQX1\%noxref_34
x_PM_TMRDFFSNRNQX1\%noxref_35 ( N_noxref_35_c_15500_n N_noxref_35_c_15530_p \
 N_noxref_35_c_15489_n N_noxref_35_c_15532_p N_noxref_35_c_15492_n \
 N_noxref_35_M28_noxref_d N_noxref_35_M29_noxref_s )  \
 PM_TMRDFFSNRNQX1\%noxref_35
x_PM_TMRDFFSNRNQX1\%noxref_36 ( N_noxref_36_c_15567_n N_noxref_36_c_15598_p \
 N_noxref_36_c_15555_n N_noxref_36_c_15600_p N_noxref_36_c_15558_n \
 N_noxref_36_M31_noxref_d N_noxref_36_M32_noxref_s )  \
 PM_TMRDFFSNRNQX1\%noxref_36
x_PM_TMRDFFSNRNQX1\%noxref_37 ( N_noxref_37_c_15635_n N_noxref_37_c_15667_p \
 N_noxref_37_c_15624_n N_noxref_37_c_15669_p N_noxref_37_c_15629_n \
 N_noxref_37_M34_noxref_d N_noxref_37_M35_noxref_s )  \
 PM_TMRDFFSNRNQX1\%noxref_37
x_PM_TMRDFFSNRNQX1\%noxref_38 ( N_noxref_38_c_15713_n N_noxref_38_c_15734_p \
 N_noxref_38_c_15692_n N_noxref_38_c_15736_p N_noxref_38_c_15695_n \
 N_noxref_38_M37_noxref_d N_noxref_38_M38_noxref_s )  \
 PM_TMRDFFSNRNQX1\%noxref_38
x_PM_TMRDFFSNRNQX1\%noxref_39 ( N_noxref_39_c_15760_n N_noxref_39_c_15801_p \
 N_noxref_39_c_15775_n N_noxref_39_c_15803_p N_noxref_39_c_15778_n \
 N_noxref_39_M40_noxref_d N_noxref_39_M41_noxref_s )  \
 PM_TMRDFFSNRNQX1\%noxref_39
x_PM_TMRDFFSNRNQX1\%noxref_40 ( N_noxref_40_c_15838_n N_noxref_40_c_15869_p \
 N_noxref_40_c_15826_n N_noxref_40_c_15871_p N_noxref_40_c_15829_n \
 N_noxref_40_M43_noxref_d N_noxref_40_M44_noxref_s )  \
 PM_TMRDFFSNRNQX1\%noxref_40
x_PM_TMRDFFSNRNQX1\%noxref_41 ( N_noxref_41_c_15895_n N_noxref_41_c_15936_p \
 N_noxref_41_c_15911_n N_noxref_41_c_15938_p N_noxref_41_c_15916_n \
 N_noxref_41_M46_noxref_d N_noxref_41_M47_noxref_s )  \
 PM_TMRDFFSNRNQX1\%noxref_41
x_PM_TMRDFFSNRNQX1\%noxref_42 ( N_noxref_42_c_15961_n N_noxref_42_c_16004_p \
 N_noxref_42_c_15978_n N_noxref_42_c_16006_p N_noxref_42_c_15981_n \
 N_noxref_42_M49_noxref_d N_noxref_42_M50_noxref_s )  \
 PM_TMRDFFSNRNQX1\%noxref_42
x_PM_TMRDFFSNRNQX1\%noxref_43 ( N_noxref_43_c_16030_n N_noxref_43_c_16073_p \
 N_noxref_43_c_16046_n N_noxref_43_c_16075_p N_noxref_43_c_16051_n \
 N_noxref_43_M52_noxref_d N_noxref_43_M53_noxref_s )  \
 PM_TMRDFFSNRNQX1\%noxref_43
x_PM_TMRDFFSNRNQX1\%noxref_44 ( N_noxref_44_c_16098_n N_noxref_44_c_16100_n \
 N_noxref_44_c_16103_n N_noxref_44_c_16104_n N_noxref_44_c_16127_n \
 N_noxref_44_c_16110_n N_noxref_44_c_16114_n N_noxref_44_c_16115_n \
 N_noxref_44_c_16132_n N_noxref_44_c_16116_n N_noxref_44_c_16119_n \
 N_noxref_44_c_16120_n N_noxref_44_M169_noxref_d N_noxref_44_M171_noxref_d \
 N_noxref_44_M173_noxref_s N_noxref_44_M174_noxref_d N_noxref_44_M176_noxref_d \
 )  PM_TMRDFFSNRNQX1\%noxref_44
x_PM_TMRDFFSNRNQX1\%noxref_45 ( N_noxref_45_c_16258_n N_noxref_45_c_16271_n \
 N_noxref_45_c_16281_n N_noxref_45_c_16283_n N_noxref_45_c_16297_n \
 N_noxref_45_c_16259_n N_noxref_45_c_16285_n N_noxref_45_c_16286_n \
 N_noxref_45_c_16301_n N_noxref_45_c_16265_n N_noxref_45_c_16287_n \
 N_noxref_45_c_16290_n N_noxref_45_M173_noxref_d N_noxref_45_M175_noxref_d \
 N_noxref_45_M177_noxref_s N_noxref_45_M178_noxref_d N_noxref_45_M180_noxref_d \
 )  PM_TMRDFFSNRNQX1\%noxref_45
x_PM_TMRDFFSNRNQX1\%GND ( GND N_GND_c_16870_n N_GND_c_16871_n N_GND_c_16390_n \
 N_GND_c_16394_n N_GND_c_16501_n N_GND_c_16397_n N_GND_c_16460_n \
 N_GND_c_16464_n N_GND_c_16584_n N_GND_c_16505_n N_GND_c_16542_n \
 N_GND_c_16546_n N_GND_c_16588_n N_GND_c_16874_n N_GND_c_16658_n \
 N_GND_c_16662_n N_GND_c_16769_n N_GND_c_16665_n N_GND_c_16728_n \
 N_GND_c_16732_n N_GND_c_16850_n N_GND_c_16773_n N_GND_c_16808_n \
 N_GND_c_16812_n N_GND_c_16854_n N_GND_c_16877_n N_GND_c_16949_n \
 N_GND_c_16953_n N_GND_c_17063_n N_GND_c_16956_n N_GND_c_17019_n \
 N_GND_c_17023_n N_GND_c_17064_n N_GND_c_17070_n N_GND_c_17141_n \
 N_GND_c_17197_n N_GND_c_16607_n N_GND_c_16608_n N_GND_c_17290_n \
 N_GND_c_16615_n N_GND_c_17291_n N_GND_c_17294_n N_GND_c_17344_n \
 N_GND_c_16880_n N_GND_c_16400_n N_GND_c_16411_n N_GND_c_16467_n \
 N_GND_c_16509_n N_GND_c_16549_n N_GND_c_16624_n N_GND_c_16668_n \
 N_GND_c_16679_n N_GND_c_16735_n N_GND_c_16777_n N_GND_c_16815_n \
 N_GND_c_16900_n N_GND_c_16959_n N_GND_c_16970_n N_GND_c_17026_n \
 N_GND_c_17074_n N_GND_c_17200_n N_GND_c_16421_n N_GND_c_16911_n \
 N_GND_c_16423_n N_GND_c_16424_n N_GND_c_16480_n N_GND_c_16522_n \
 N_GND_c_16562_n N_GND_c_16689_n N_GND_c_16691_n N_GND_c_16692_n \
 N_GND_c_16748_n N_GND_c_16790_n N_GND_c_16828_n N_GND_c_16917_n \
 N_GND_c_16982_n N_GND_c_16983_n N_GND_c_17039_n N_GND_c_17087_n \
 N_GND_c_17213_n N_GND_c_16628_n N_GND_c_16629_n N_GND_c_17306_n \
 N_GND_c_18126_p N_GND_c_17397_n N_GND_c_17401_n N_GND_c_16425_n \
 N_GND_c_16438_n N_GND_c_16481_n N_GND_c_16530_n N_GND_c_16563_n \
 N_GND_c_16600_n N_GND_c_16693_n N_GND_c_16706_n N_GND_c_16749_n \
 N_GND_c_16796_n N_GND_c_16829_n N_GND_c_16867_n N_GND_c_16984_n \
 N_GND_c_16997_n N_GND_c_17040_n N_GND_c_17093_n N_GND_c_17214_n \
 N_GND_c_16635_n N_GND_c_16641_n N_GND_c_17321_n N_GND_c_17332_n \
 N_GND_c_17416_n N_GND_M0_noxref_d N_GND_M3_noxref_d N_GND_M6_noxref_d \
 N_GND_M9_noxref_d N_GND_M12_noxref_d N_GND_M15_noxref_d N_GND_M18_noxref_d \
 N_GND_M21_noxref_d N_GND_M24_noxref_d N_GND_M27_noxref_d N_GND_M30_noxref_d \
 N_GND_M33_noxref_d N_GND_M36_noxref_d N_GND_M39_noxref_d N_GND_M42_noxref_d \
 N_GND_M45_noxref_d N_GND_M48_noxref_d N_GND_M51_noxref_d N_GND_M54_noxref_d \
 N_GND_M56_noxref_d N_GND_M58_noxref_d N_GND_M60_noxref_s )  \
 PM_TMRDFFSNRNQX1\%GND
x_PM_TMRDFFSNRNQX1\%noxref_47 ( N_noxref_47_c_18135_n N_noxref_47_c_18136_n \
 N_noxref_47_c_18161_n N_noxref_47_c_18150_n N_noxref_47_c_18144_n \
 N_noxref_47_M0_noxref_s )  PM_TMRDFFSNRNQX1\%noxref_47
x_PM_TMRDFFSNRNQX1\%noxref_48 ( N_noxref_48_c_18190_n N_noxref_48_c_18191_n \
 N_noxref_48_c_18218_n N_noxref_48_c_18202_n N_noxref_48_c_18204_n \
 N_noxref_48_M3_noxref_s )  PM_TMRDFFSNRNQX1\%noxref_48
x_PM_TMRDFFSNRNQX1\%noxref_49 ( N_noxref_49_c_18247_n N_noxref_49_c_18248_n \
 N_noxref_49_c_18276_n N_noxref_49_c_18263_n N_noxref_49_c_18261_n \
 N_noxref_49_M6_noxref_s )  PM_TMRDFFSNRNQX1\%noxref_49
x_PM_TMRDFFSNRNQX1\%noxref_50 ( N_noxref_50_c_18305_n N_noxref_50_c_18306_n \
 N_noxref_50_c_18335_n N_noxref_50_c_18317_n N_noxref_50_c_18319_n \
 N_noxref_50_M9_noxref_s )  PM_TMRDFFSNRNQX1\%noxref_50
x_PM_TMRDFFSNRNQX1\%noxref_51 ( N_noxref_51_c_18364_n N_noxref_51_c_18365_n \
 N_noxref_51_c_18393_n N_noxref_51_c_18378_n N_noxref_51_c_18380_n \
 N_noxref_51_M12_noxref_s )  PM_TMRDFFSNRNQX1\%noxref_51
x_PM_TMRDFFSNRNQX1\%noxref_52 ( N_noxref_52_c_18422_n N_noxref_52_c_18423_n \
 N_noxref_52_c_18452_n N_noxref_52_c_18440_n N_noxref_52_c_18438_n \
 N_noxref_52_M15_noxref_s )  PM_TMRDFFSNRNQX1\%noxref_52
x_PM_TMRDFFSNRNQX1\%noxref_53 ( N_noxref_53_c_18481_n N_noxref_53_c_18482_n \
 N_noxref_53_c_18508_n N_noxref_53_c_18495_n N_noxref_53_c_18497_n \
 N_noxref_53_M18_noxref_s )  PM_TMRDFFSNRNQX1\%noxref_53
x_PM_TMRDFFSNRNQX1\%noxref_54 ( N_noxref_54_c_18537_n N_noxref_54_c_18538_n \
 N_noxref_54_c_18565_n N_noxref_54_c_18549_n N_noxref_54_c_18551_n \
 N_noxref_54_M21_noxref_s )  PM_TMRDFFSNRNQX1\%noxref_54
x_PM_TMRDFFSNRNQX1\%noxref_55 ( N_noxref_55_c_18594_n N_noxref_55_c_18595_n \
 N_noxref_55_c_18623_n N_noxref_55_c_18610_n N_noxref_55_c_18608_n \
 N_noxref_55_M24_noxref_s )  PM_TMRDFFSNRNQX1\%noxref_55
x_PM_TMRDFFSNRNQX1\%noxref_56 ( N_noxref_56_c_18652_n N_noxref_56_c_18653_n \
 N_noxref_56_c_18682_n N_noxref_56_c_18664_n N_noxref_56_c_18666_n \
 N_noxref_56_M27_noxref_s )  PM_TMRDFFSNRNQX1\%noxref_56
x_PM_TMRDFFSNRNQX1\%noxref_57 ( N_noxref_57_c_18711_n N_noxref_57_c_18712_n \
 N_noxref_57_c_18740_n N_noxref_57_c_18725_n N_noxref_57_c_18727_n \
 N_noxref_57_M30_noxref_s )  PM_TMRDFFSNRNQX1\%noxref_57
x_PM_TMRDFFSNRNQX1\%noxref_58 ( N_noxref_58_c_18769_n N_noxref_58_c_18770_n \
 N_noxref_58_c_18799_n N_noxref_58_c_18787_n N_noxref_58_c_18785_n \
 N_noxref_58_M33_noxref_s )  PM_TMRDFFSNRNQX1\%noxref_58
x_PM_TMRDFFSNRNQX1\%noxref_59 ( N_noxref_59_c_18828_n N_noxref_59_c_18829_n \
 N_noxref_59_c_18855_n N_noxref_59_c_18842_n N_noxref_59_c_18844_n \
 N_noxref_59_M36_noxref_s )  PM_TMRDFFSNRNQX1\%noxref_59
x_PM_TMRDFFSNRNQX1\%noxref_60 ( N_noxref_60_c_18884_n N_noxref_60_c_18885_n \
 N_noxref_60_c_18912_n N_noxref_60_c_18896_n N_noxref_60_c_18898_n \
 N_noxref_60_M39_noxref_s )  PM_TMRDFFSNRNQX1\%noxref_60
x_PM_TMRDFFSNRNQX1\%noxref_61 ( N_noxref_61_c_18941_n N_noxref_61_c_18942_n \
 N_noxref_61_c_18970_n N_noxref_61_c_18957_n N_noxref_61_c_18955_n \
 N_noxref_61_M42_noxref_s )  PM_TMRDFFSNRNQX1\%noxref_61
x_PM_TMRDFFSNRNQX1\%noxref_62 ( N_noxref_62_c_18999_n N_noxref_62_c_19000_n \
 N_noxref_62_c_19029_n N_noxref_62_c_19011_n N_noxref_62_c_19013_n \
 N_noxref_62_M45_noxref_s )  PM_TMRDFFSNRNQX1\%noxref_62
x_PM_TMRDFFSNRNQX1\%noxref_63 ( N_noxref_63_c_19058_n N_noxref_63_c_19059_n \
 N_noxref_63_c_19087_n N_noxref_63_c_19072_n N_noxref_63_c_19074_n \
 N_noxref_63_M48_noxref_s )  PM_TMRDFFSNRNQX1\%noxref_63
x_PM_TMRDFFSNRNQX1\%noxref_64 ( N_noxref_64_c_19116_n N_noxref_64_c_19117_n \
 N_noxref_64_c_19146_n N_noxref_64_c_19128_n N_noxref_64_c_19130_n \
 N_noxref_64_M51_noxref_s )  PM_TMRDFFSNRNQX1\%noxref_64
x_PM_TMRDFFSNRNQX1\%noxref_65 ( N_noxref_65_c_19175_n N_noxref_65_c_19179_n \
 N_noxref_65_c_19223_n N_noxref_65_c_19187_n N_noxref_65_c_19194_n \
 N_noxref_65_c_19231_n N_noxref_65_M54_noxref_s )  PM_TMRDFFSNRNQX1\%noxref_65
x_PM_TMRDFFSNRNQX1\%noxref_66 ( N_noxref_66_c_19242_n N_noxref_66_c_19243_n \
 N_noxref_66_c_19283_n N_noxref_66_c_19250_n N_noxref_66_c_19258_n \
 N_noxref_66_c_19291_n N_noxref_66_M56_noxref_s )  PM_TMRDFFSNRNQX1\%noxref_66
x_PM_TMRDFFSNRNQX1\%noxref_67 ( N_noxref_67_c_19304_n N_noxref_67_c_19308_n \
 N_noxref_67_c_19352_n N_noxref_67_c_19315_n N_noxref_67_c_19324_n \
 N_noxref_67_c_19360_n N_noxref_67_M58_noxref_s )  PM_TMRDFFSNRNQX1\%noxref_67
cc_1 ( N_noxref_1_M74_noxref_g N_noxref_2_c_413_n ) capacitor c=0.00893512f \
 //x=11.86 //y=6.2 //x2=12.4 //y2=5.335
cc_2 ( N_noxref_1_M73_noxref_g N_noxref_2_c_414_n ) capacitor c=0.00461408f \
 //x=11.42 //y=6.2 //x2=11.642 //y2=5.335
cc_3 ( N_noxref_1_M74_noxref_g N_noxref_2_c_414_n ) capacitor c=0.00229208f \
 //x=11.86 //y=6.2 //x2=11.642 //y2=5.335
cc_4 ( N_noxref_1_c_4_p N_noxref_2_c_414_n ) capacitor c=0.00171885f \
 //x=11.785 //y=4.97 //x2=11.642 //y2=5.335
cc_5 ( N_noxref_1_c_5_p N_noxref_2_c_417_n ) capacitor c=4.2553e-19 //x=11.22 \
 //y=2.77 //x2=14.18 //y2=2.77
cc_6 ( N_noxref_1_M73_noxref_g N_noxref_2_c_418_n ) capacitor c=0.0162284f \
 //x=11.42 //y=6.2 //x2=11.64 //y2=5.56
cc_7 ( N_noxref_1_M74_noxref_g N_noxref_2_c_418_n ) capacitor c=0.0179041f \
 //x=11.86 //y=6.2 //x2=11.64 //y2=5.56
cc_8 ( N_noxref_1_c_4_p N_noxref_2_c_418_n ) capacitor c=0.00291477f \
 //x=11.785 //y=4.97 //x2=11.64 //y2=5.56
cc_9 ( N_noxref_1_c_9_p N_noxref_3_c_706_n ) capacitor c=0.0139504f //x=4.56 \
 //y=2.625 //x2=3.82 //y2=2.375
cc_10 ( N_noxref_1_c_9_p N_noxref_3_c_707_n ) capacitor c=0.00894987f //x=4.56 \
 //y=2.625 //x2=3.82 //y2=3.355
cc_11 ( N_noxref_1_c_11_p N_noxref_3_c_707_n ) capacitor c=0.014957f //x=4.56 \
 //y=2.945 //x2=3.82 //y2=3.355
cc_12 ( N_noxref_1_c_12_p N_noxref_3_c_707_n ) capacitor c=0.0194668f //x=4.56 \
 //y=5.25 //x2=3.82 //y2=3.355
cc_13 ( N_noxref_1_c_13_p N_noxref_3_c_707_n ) capacitor c=4.63723e-19 \
 //x=6.41 //y=2.625 //x2=3.82 //y2=3.355
cc_14 ( N_noxref_1_c_14_p N_noxref_3_c_707_n ) capacitor c=4.18822e-19 \
 //x=6.41 //y=4.755 //x2=3.82 //y2=3.355
cc_15 ( N_noxref_1_c_15_p N_noxref_3_c_707_n ) capacitor c=7.6985e-19 //x=4.56 \
 //y=2.77 //x2=3.82 //y2=3.355
cc_16 ( N_noxref_1_c_16_p N_noxref_3_c_707_n ) capacitor c=0.0068343f \
 //x=4.725 //y=2.785 //x2=3.82 //y2=3.355
cc_17 ( N_noxref_1_c_17_p N_noxref_3_c_714_n ) capacitor c=0.00123081f \
 //x=4.475 //y=5.335 //x2=3.82 //y2=3.675
cc_18 ( N_noxref_1_c_18_p N_noxref_3_c_714_n ) capacitor c=2.35691e-19 \
 //x=4.075 //y=1.305 //x2=3.82 //y2=3.675
cc_19 ( N_noxref_1_c_19_p N_noxref_3_c_714_n ) capacitor c=0.00102808f \
 //x=4.16 //y=1.845 //x2=3.82 //y2=3.675
cc_20 ( N_noxref_1_c_12_p N_noxref_3_c_714_n ) capacitor c=0.0174568f //x=4.56 \
 //y=5.25 //x2=3.82 //y2=3.675
cc_21 ( N_noxref_1_c_21_p N_noxref_3_c_714_n ) capacitor c=6.37467e-19 \
 //x=3.78 //y=5.335 //x2=3.82 //y2=3.675
cc_22 ( N_noxref_1_c_17_p N_noxref_3_c_719_n ) capacitor c=0.0023499f \
 //x=4.475 //y=5.335 //x2=3.82 //y2=4.75
cc_23 ( N_noxref_1_c_12_p N_noxref_3_c_719_n ) capacitor c=0.0618015f //x=4.56 \
 //y=5.25 //x2=3.82 //y2=4.75
cc_24 ( N_noxref_1_c_14_p N_noxref_3_c_719_n ) capacitor c=0.00181765f \
 //x=6.41 //y=4.755 //x2=3.82 //y2=4.75
cc_25 ( N_noxref_1_c_21_p N_noxref_3_c_719_n ) capacitor c=0.0225136f //x=3.78 \
 //y=5.335 //x2=3.82 //y2=4.75
cc_26 ( N_noxref_1_c_26_p N_noxref_3_c_719_n ) capacitor c=0.00217653f \
 //x=3.78 //y=5.56 //x2=3.82 //y2=4.75
cc_27 ( N_noxref_1_M68_noxref_g N_noxref_3_c_724_n ) capacitor c=0.00973141f \
 //x=7.05 //y=6.2 //x2=7.59 //y2=5.335
cc_28 ( N_noxref_1_c_28_p N_noxref_3_c_725_n ) capacitor c=0.00163399f \
 //x=4.475 //y=1.845 //x2=8.97 //y2=1.845
cc_29 ( N_noxref_1_c_29_p N_noxref_3_c_726_n ) capacitor c=0.00357748f \
 //x=11.22 //y=2.375 //x2=9.37 //y2=3.335
cc_30 ( N_noxref_1_c_30_p N_noxref_3_c_726_n ) capacitor c=0.00243104f \
 //x=11.22 //y=2.625 //x2=9.37 //y2=3.335
cc_31 ( N_noxref_1_c_31_p N_noxref_3_c_726_n ) capacitor c=0.00248785f \
 //x=11.22 //y=2.945 //x2=9.37 //y2=3.335
cc_32 ( N_noxref_1_c_32_p N_noxref_3_c_726_n ) capacitor c=0.00734525f \
 //x=11.22 //y=4.755 //x2=9.37 //y2=3.335
cc_33 ( N_noxref_1_c_33_p N_noxref_3_c_726_n ) capacitor c=0.00159838f \
 //x=11.22 //y=2.785 //x2=9.37 //y2=3.335
cc_34 ( N_noxref_1_c_34_p N_noxref_3_c_726_n ) capacitor c=0.0252332f \
 //x=11.06 //y=2.785 //x2=9.37 //y2=3.335
cc_35 ( N_noxref_1_c_32_p N_noxref_3_c_732_n ) capacitor c=0.00254697f \
 //x=11.22 //y=4.755 //x2=9.37 //y2=3.655
cc_36 ( N_noxref_1_c_34_p N_noxref_3_c_732_n ) capacitor c=0.00511475f \
 //x=11.06 //y=2.785 //x2=9.37 //y2=3.655
cc_37 ( N_noxref_1_c_32_p N_noxref_3_c_734_n ) capacitor c=0.016397f //x=11.22 \
 //y=4.755 //x2=9.37 //y2=5.25
cc_38 ( N_noxref_1_c_12_p N_noxref_3_c_735_n ) capacitor c=6.89957e-19 \
 //x=4.56 //y=5.25 //x2=3.82 //y2=3.51
cc_39 ( N_noxref_1_c_39_p N_noxref_3_c_736_n ) capacitor c=6.09703e-19 \
 //x=3.78 //y=5.56 //x2=6.832 //y2=5.335
cc_40 ( N_noxref_1_c_17_p N_noxref_3_c_736_n ) capacitor c=0.00306432f \
 //x=4.475 //y=5.335 //x2=6.832 //y2=5.335
cc_41 ( N_noxref_1_M67_noxref_g N_noxref_3_c_736_n ) capacitor c=0.00461408f \
 //x=6.61 //y=6.2 //x2=6.832 //y2=5.335
cc_42 ( N_noxref_1_M68_noxref_g N_noxref_3_c_736_n ) capacitor c=0.00229208f \
 //x=7.05 //y=6.2 //x2=6.832 //y2=5.335
cc_43 ( N_noxref_1_c_43_p N_noxref_3_c_736_n ) capacitor c=0.00171885f \
 //x=6.975 //y=4.97 //x2=6.832 //y2=5.335
cc_44 ( N_noxref_1_c_31_p N_noxref_3_c_741_n ) capacitor c=0.00481573f \
 //x=11.22 //y=2.945 //x2=20.675 //y2=3.51
cc_45 ( N_noxref_1_c_32_p N_noxref_3_c_741_n ) capacitor c=0.0266779f \
 //x=11.22 //y=4.755 //x2=20.675 //y2=3.51
cc_46 ( N_noxref_1_c_33_p N_noxref_3_c_741_n ) capacitor c=0.01611f //x=11.22 \
 //y=2.785 //x2=20.675 //y2=3.51
cc_47 ( N_noxref_1_c_34_p N_noxref_3_c_741_n ) capacitor c=0.0688583f \
 //x=11.06 //y=2.785 //x2=20.675 //y2=3.51
cc_48 ( N_noxref_1_c_12_p N_noxref_3_c_745_n ) capacitor c=0.00330634f \
 //x=4.56 //y=5.25 //x2=3.99 //y2=3.515
cc_49 ( N_noxref_1_c_11_p N_noxref_3_c_746_n ) capacitor c=0.00653648f \
 //x=4.56 //y=2.945 //x2=9.21 //y2=3.495
cc_50 ( N_noxref_1_c_12_p N_noxref_3_c_746_n ) capacitor c=0.0270498f //x=4.56 \
 //y=5.25 //x2=9.21 //y2=3.495
cc_51 ( N_noxref_1_c_51_p N_noxref_3_c_746_n ) capacitor c=0.00471438f \
 //x=6.41 //y=2.945 //x2=9.21 //y2=3.495
cc_52 ( N_noxref_1_c_14_p N_noxref_3_c_746_n ) capacitor c=0.0295778f //x=6.41 \
 //y=4.755 //x2=9.21 //y2=3.495
cc_53 ( N_noxref_1_c_16_p N_noxref_3_c_746_n ) capacitor c=0.01611f //x=4.725 \
 //y=2.785 //x2=9.21 //y2=3.495
cc_54 ( N_noxref_1_c_54_p N_noxref_3_c_746_n ) capacitor c=0.0698472f \
 //x=6.255 //y=2.785 //x2=9.21 //y2=3.495
cc_55 ( N_noxref_1_c_55_p N_noxref_3_c_746_n ) capacitor c=0.01611f //x=6.575 \
 //y=2.785 //x2=9.21 //y2=3.495
cc_56 ( N_noxref_1_c_34_p N_noxref_3_c_746_n ) capacitor c=0.108993f //x=11.06 \
 //y=2.785 //x2=9.21 //y2=3.495
cc_57 ( N_noxref_1_c_32_p N_noxref_3_c_754_n ) capacitor c=0.00159838f \
 //x=11.22 //y=4.755 //x2=9.53 //y2=3.495
cc_58 ( N_noxref_1_c_34_p N_noxref_3_c_754_n ) capacitor c=0.0161465f \
 //x=11.06 //y=2.785 //x2=9.53 //y2=3.495
cc_59 ( N_noxref_1_c_9_p N_noxref_3_c_756_n ) capacitor c=0.0015536f //x=4.56 \
 //y=2.625 //x2=3.82 //y2=2.26
cc_60 ( N_noxref_1_c_17_p N_noxref_3_c_757_n ) capacitor c=0.00130631f \
 //x=4.475 //y=5.335 //x2=3.82 //y2=4.88
cc_61 ( N_noxref_1_c_12_p N_noxref_3_c_757_n ) capacitor c=0.00131258f \
 //x=4.56 //y=5.25 //x2=3.82 //y2=4.88
cc_62 ( N_noxref_1_c_21_p N_noxref_3_c_757_n ) capacitor c=0.00346456f \
 //x=3.78 //y=5.335 //x2=3.82 //y2=4.88
cc_63 ( N_noxref_1_c_26_p N_noxref_3_c_757_n ) capacitor c=0.00552343f \
 //x=3.78 //y=5.56 //x2=3.82 //y2=4.88
cc_64 ( N_noxref_1_M67_noxref_g N_noxref_3_c_761_n ) capacitor c=0.0162284f \
 //x=6.61 //y=6.2 //x2=6.83 //y2=5.56
cc_65 ( N_noxref_1_M68_noxref_g N_noxref_3_c_761_n ) capacitor c=0.0179041f \
 //x=7.05 //y=6.2 //x2=6.83 //y2=5.56
cc_66 ( N_noxref_1_c_43_p N_noxref_3_c_761_n ) capacitor c=0.00291477f \
 //x=6.975 //y=4.97 //x2=6.83 //y2=5.56
cc_67 ( N_noxref_1_c_67_p N_noxref_3_M65_noxref_g ) capacitor c=0.0103546f \
 //x=3.665 //y=5.335 //x2=3.56 //y2=6.2
cc_68 ( N_noxref_1_c_39_p N_noxref_3_M65_noxref_g ) capacitor c=0.00226521f \
 //x=3.78 //y=5.56 //x2=3.56 //y2=6.2
cc_69 ( N_noxref_1_c_26_p N_noxref_3_M65_noxref_g ) capacitor c=0.0178885f \
 //x=3.78 //y=5.56 //x2=3.56 //y2=6.2
cc_70 ( N_noxref_1_c_39_p N_noxref_3_M66_noxref_g ) capacitor c=0.00381703f \
 //x=3.78 //y=5.56 //x2=4 //y2=6.2
cc_71 ( N_noxref_1_c_17_p N_noxref_3_M66_noxref_g ) capacitor c=0.0112427f \
 //x=4.475 //y=5.335 //x2=4 //y2=6.2
cc_72 ( N_noxref_1_c_26_p N_noxref_3_M66_noxref_g ) capacitor c=0.0188608f \
 //x=3.78 //y=5.56 //x2=4 //y2=6.2
cc_73 ( N_noxref_1_c_18_p N_noxref_3_c_770_n ) capacitor c=4.64015e-19 \
 //x=4.075 //y=1.305 //x2=3.81 //y2=1.095
cc_74 ( N_noxref_1_M2_noxref_d N_noxref_3_c_770_n ) capacitor c=0.00137165f \
 //x=3.885 //y=1.095 //x2=3.81 //y2=1.095
cc_75 ( N_noxref_1_c_18_p N_noxref_3_c_772_n ) capacitor c=0.0026012f \
 //x=4.075 //y=1.305 //x2=3.81 //y2=1.44
cc_76 ( N_noxref_1_c_76_p N_noxref_3_c_772_n ) capacitor c=0.00127432f \
 //x=4.075 //y=1.76 //x2=3.81 //y2=1.44
cc_77 ( N_noxref_1_M2_noxref_d N_noxref_3_c_772_n ) capacitor c=0.00237422f \
 //x=3.885 //y=1.095 //x2=3.81 //y2=1.44
cc_78 ( N_noxref_1_c_76_p N_noxref_3_c_775_n ) capacitor c=0.00429966f \
 //x=4.075 //y=1.76 //x2=3.81 //y2=1.75
cc_79 ( N_noxref_1_c_18_p N_noxref_3_c_776_n ) capacitor c=5.29969e-19 \
 //x=4.075 //y=1.305 //x2=4.185 //y2=0.94
cc_80 ( N_noxref_1_M2_noxref_d N_noxref_3_c_776_n ) capacitor c=0.0020782f \
 //x=3.885 //y=1.095 //x2=4.185 //y2=0.94
cc_81 ( N_noxref_1_c_18_p N_noxref_3_c_778_n ) capacitor c=5.00148e-19 \
 //x=4.075 //y=1.305 //x2=4.185 //y2=1.595
cc_82 ( N_noxref_1_c_76_p N_noxref_3_c_778_n ) capacitor c=0.00942306f \
 //x=4.075 //y=1.76 //x2=4.185 //y2=1.595
cc_83 ( N_noxref_1_c_28_p N_noxref_3_c_778_n ) capacitor c=0.00194716f \
 //x=4.475 //y=1.845 //x2=4.185 //y2=1.595
cc_84 ( N_noxref_1_M2_noxref_d N_noxref_3_c_778_n ) capacitor c=0.00356097f \
 //x=3.885 //y=1.095 //x2=4.185 //y2=1.595
cc_85 ( N_noxref_1_c_18_p N_noxref_3_c_782_n ) capacitor c=5.24634e-19 \
 //x=4.075 //y=1.305 //x2=4.34 //y2=1.095
cc_86 ( N_noxref_1_M2_noxref_d N_noxref_3_c_782_n ) capacitor c=0.00139206f \
 //x=3.885 //y=1.095 //x2=4.34 //y2=1.095
cc_87 ( N_noxref_1_c_18_p N_noxref_3_c_784_n ) capacitor c=0.00307978f \
 //x=4.075 //y=1.305 //x2=4.34 //y2=1.44
cc_88 ( N_noxref_1_c_76_p N_noxref_3_c_784_n ) capacitor c=0.00363411f \
 //x=4.075 //y=1.76 //x2=4.34 //y2=1.44
cc_89 ( N_noxref_1_c_28_p N_noxref_3_c_784_n ) capacitor c=0.00323576f \
 //x=4.475 //y=1.845 //x2=4.34 //y2=1.44
cc_90 ( N_noxref_1_M2_noxref_d N_noxref_3_c_784_n ) capacitor c=0.00237422f \
 //x=3.885 //y=1.095 //x2=4.34 //y2=1.44
cc_91 ( N_noxref_1_c_9_p N_noxref_3_c_788_n ) capacitor c=0.0024584f //x=4.56 \
 //y=2.625 //x2=3.82 //y2=2.26
cc_92 ( N_noxref_1_c_76_p N_noxref_3_c_789_n ) capacitor c=0.00372124f \
 //x=4.075 //y=1.76 //x2=3.82 //y2=2.095
cc_93 ( N_noxref_1_c_9_p N_noxref_3_c_789_n ) capacitor c=0.00282067f //x=4.56 \
 //y=2.625 //x2=3.82 //y2=2.095
cc_94 ( N_noxref_1_c_12_p N_noxref_3_c_791_n ) capacitor c=0.00739875f \
 //x=4.56 //y=5.25 //x2=3.82 //y2=4.88
cc_95 ( N_noxref_1_c_21_p N_noxref_3_c_791_n ) capacitor c=0.00203307f \
 //x=3.78 //y=5.335 //x2=3.82 //y2=4.88
cc_96 ( N_noxref_1_c_26_p N_noxref_3_c_791_n ) capacitor c=0.00375636f \
 //x=3.78 //y=5.56 //x2=3.82 //y2=4.88
cc_97 ( N_noxref_1_c_13_p N_noxref_5_c_1468_n ) capacitor c=2.88859e-19 \
 //x=6.41 //y=2.625 //x2=8.63 //y2=3.735
cc_98 ( N_noxref_1_c_14_p N_noxref_5_c_1468_n ) capacitor c=7.72134e-19 \
 //x=6.41 //y=4.755 //x2=8.63 //y2=3.735
cc_99 ( N_noxref_1_c_30_p N_noxref_5_c_1468_n ) capacitor c=4.65873e-19 \
 //x=11.22 //y=2.625 //x2=8.63 //y2=3.735
cc_100 ( N_noxref_1_c_32_p N_noxref_5_c_1468_n ) capacitor c=0.00103409f \
 //x=11.22 //y=4.755 //x2=8.63 //y2=3.735
cc_101 ( N_noxref_1_c_34_p N_noxref_5_c_1468_n ) capacitor c=0.0247205f \
 //x=11.06 //y=2.785 //x2=8.63 //y2=3.735
cc_102 ( N_noxref_1_c_14_p N_noxref_5_c_1473_n ) capacitor c=8.51977e-19 \
 //x=6.41 //y=4.755 //x2=8.63 //y2=4.75
cc_103 ( N_noxref_1_c_32_p N_noxref_5_c_1473_n ) capacitor c=8.29068e-19 \
 //x=11.22 //y=4.755 //x2=8.63 //y2=4.75
cc_104 ( N_noxref_1_c_30_p N_noxref_5_c_1475_n ) capacitor c=2.88859e-19 \
 //x=11.22 //y=2.625 //x2=13.44 //y2=3.735
cc_105 ( N_noxref_1_c_32_p N_noxref_5_c_1475_n ) capacitor c=0.00107979f \
 //x=11.22 //y=4.755 //x2=13.44 //y2=3.735
cc_106 ( N_noxref_1_c_32_p N_noxref_5_c_1477_n ) capacitor c=6.01094e-19 \
 //x=11.22 //y=4.755 //x2=13.44 //y2=4.75
cc_107 ( N_noxref_1_c_32_p N_noxref_5_c_1478_n ) capacitor c=0.0247411f \
 //x=11.22 //y=4.755 //x2=13.28 //y2=3.895
cc_108 ( N_noxref_1_c_34_p N_noxref_5_c_1478_n ) capacitor c=0.0110956f \
 //x=11.06 //y=2.785 //x2=13.28 //y2=3.895
cc_109 ( N_noxref_1_c_17_p N_D_c_5110_n ) capacitor c=0.0155792f //x=4.475 \
 //y=5.335 //x2=8.245 //y2=4.25
cc_110 ( N_noxref_1_c_12_p N_D_c_5110_n ) capacitor c=0.0327066f //x=4.56 \
 //y=5.25 //x2=8.245 //y2=4.25
cc_111 ( N_noxref_1_c_14_p N_D_c_5110_n ) capacitor c=0.0351337f //x=6.41 \
 //y=4.755 //x2=8.245 //y2=4.25
cc_112 ( N_noxref_1_c_112_p N_D_c_5110_n ) capacitor c=0.0237747f //x=2.022 \
 //y=5.335 //x2=8.245 //y2=4.25
cc_113 ( N_noxref_1_c_113_p N_D_c_5110_n ) capacitor c=0.0333568f //x=2.9 \
 //y=5.335 //x2=8.245 //y2=4.25
cc_114 ( N_noxref_1_c_54_p N_D_c_5110_n ) capacitor c=0.00386398f //x=6.255 \
 //y=2.785 //x2=8.245 //y2=4.25
cc_115 ( N_noxref_1_c_34_p N_D_c_5110_n ) capacitor c=0.00782979f //x=11.06 \
 //y=2.785 //x2=8.245 //y2=4.25
cc_116 ( N_noxref_1_c_32_p N_D_c_5117_n ) capacitor c=0.0247356f //x=11.22 \
 //y=4.755 //x2=8.845 //y2=4.28
cc_117 ( N_noxref_1_c_112_p N_D_M61_noxref_g ) capacitor c=0.00501342f \
 //x=2.022 //y=5.335 //x2=1.8 //y2=6.2
cc_118 ( N_noxref_1_c_118_p N_D_M61_noxref_g ) capacitor c=0.0162284f //x=2.02 \
 //y=5.56 //x2=1.8 //y2=6.2
cc_119 ( N_noxref_1_c_119_p N_D_M62_noxref_g ) capacitor c=0.00973141f \
 //x=2.78 //y=5.335 //x2=2.24 //y2=6.2
cc_120 ( N_noxref_1_c_112_p N_D_M62_noxref_g ) capacitor c=0.00229208f \
 //x=2.022 //y=5.335 //x2=2.24 //y2=6.2
cc_121 ( N_noxref_1_c_118_p N_D_M62_noxref_g ) capacitor c=0.0179041f //x=2.02 \
 //y=5.56 //x2=2.24 //y2=6.2
cc_122 ( N_noxref_1_c_112_p N_D_c_5123_n ) capacitor c=0.00171885f //x=2.022 \
 //y=5.335 //x2=2.165 //y2=4.97
cc_123 ( N_noxref_1_c_118_p N_D_c_5123_n ) capacitor c=0.00291477f //x=2.02 \
 //y=5.56 //x2=2.165 //y2=4.97
cc_124 ( N_noxref_1_c_9_p CLK ) capacitor c=3.44709e-19 //x=4.56 //y=2.625 \
 //x2=7.52 //y2=3.14
cc_125 ( N_noxref_1_c_12_p CLK ) capacitor c=0.00131938f //x=4.56 //y=5.25 \
 //x2=7.52 //y2=3.14
cc_126 ( N_noxref_1_c_13_p CLK ) capacitor c=0.00510083f //x=6.41 //y=2.625 \
 //x2=7.52 //y2=3.14
cc_127 ( N_noxref_1_c_51_p CLK ) capacitor c=0.00782284f //x=6.41 //y=2.945 \
 //x2=7.52 //y2=3.14
cc_128 ( N_noxref_1_c_14_p CLK ) capacitor c=0.0464367f //x=6.41 //y=4.755 \
 //x2=7.52 //y2=3.14
cc_129 ( N_noxref_1_c_129_p CLK ) capacitor c=4.11345e-19 //x=6.41 //y=2.77 \
 //x2=7.52 //y2=3.14
cc_130 ( N_noxref_1_c_55_p CLK ) capacitor c=0.00248676f //x=6.575 //y=2.785 \
 //x2=7.52 //y2=3.14
cc_131 ( N_noxref_1_c_34_p CLK ) capacitor c=0.0255817f //x=11.06 //y=2.785 \
 //x2=7.52 //y2=3.14
cc_132 ( N_noxref_1_c_132_p CLK ) capacitor c=3.9149e-19 //x=6.41 //y=2.26 \
 //x2=7.52 //y2=3.14
cc_133 ( N_noxref_1_c_133_p N_CLK_c_6419_n ) capacitor c=0.00932261f //x=6.41 \
 //y=2.375 //x2=7.52 //y2=2.375
cc_134 ( N_noxref_1_c_132_p N_CLK_c_6419_n ) capacitor c=5.40058e-19 //x=6.41 \
 //y=2.26 //x2=7.52 //y2=2.375
cc_135 ( N_noxref_1_c_135_p N_CLK_c_6419_n ) capacitor c=0.00142893f //x=6.11 \
 //y=2.095 //x2=7.52 //y2=2.375
cc_136 ( N_noxref_1_c_14_p N_CLK_c_6422_n ) capacitor c=0.0091087f //x=6.41 \
 //y=4.755 //x2=7.515 //y2=4.835
cc_137 ( N_noxref_1_c_137_p N_CLK_c_6422_n ) capacitor c=6.32742e-19 //x=6.41 \
 //y=4.88 //x2=7.515 //y2=4.835
cc_138 ( N_noxref_1_c_43_p N_CLK_c_6422_n ) capacitor c=7.15803e-19 //x=6.975 \
 //y=4.97 //x2=7.515 //y2=4.835
cc_139 ( N_noxref_1_c_139_p N_CLK_c_6422_n ) capacitor c=8.67242e-19 //x=6.685 \
 //y=4.97 //x2=7.515 //y2=4.835
cc_140 ( N_noxref_1_c_32_p N_CLK_c_6426_n ) capacitor c=0.032942f //x=11.22 \
 //y=4.755 //x2=16.985 //y2=4.62
cc_141 ( N_noxref_1_c_14_p N_CLK_c_6427_n ) capacitor c=0.0102588f //x=6.41 \
 //y=4.755 //x2=7.515 //y2=4.62
cc_142 ( N_noxref_1_c_133_p N_CLK_c_6428_n ) capacitor c=5.39999e-19 //x=6.41 \
 //y=2.375 //x2=7.52 //y2=2.26
cc_143 ( N_noxref_1_c_13_p N_CLK_c_6428_n ) capacitor c=3.9149e-19 //x=6.41 \
 //y=2.625 //x2=7.52 //y2=2.26
cc_144 ( N_noxref_1_c_132_p N_CLK_c_6428_n ) capacitor c=0.00125213f //x=6.41 \
 //y=2.26 //x2=7.52 //y2=2.26
cc_145 ( N_noxref_1_c_135_p N_CLK_c_6428_n ) capacitor c=0.00214573f //x=6.11 \
 //y=2.095 //x2=7.52 //y2=2.26
cc_146 ( N_noxref_1_c_14_p N_CLK_c_6432_n ) capacitor c=5.64453e-19 //x=6.41 \
 //y=4.755 //x2=7.52 //y2=4.88
cc_147 ( N_noxref_1_c_137_p N_CLK_c_6432_n ) capacitor c=0.00113666f //x=6.41 \
 //y=4.88 //x2=7.52 //y2=4.88
cc_148 ( N_noxref_1_c_43_p N_CLK_c_6432_n ) capacitor c=0.00116563f //x=6.975 \
 //y=4.97 //x2=7.52 //y2=4.88
cc_149 ( N_noxref_1_c_139_p N_CLK_c_6432_n ) capacitor c=0.0012974f //x=6.685 \
 //y=4.97 //x2=7.52 //y2=4.88
cc_150 ( N_noxref_1_M67_noxref_g N_CLK_M69_noxref_g ) capacitor c=0.0106276f \
 //x=6.61 //y=6.2 //x2=7.49 //y2=6.2
cc_151 ( N_noxref_1_M68_noxref_g N_CLK_M69_noxref_g ) capacitor c=0.107144f \
 //x=7.05 //y=6.2 //x2=7.49 //y2=6.2
cc_152 ( N_noxref_1_M68_noxref_g N_CLK_M70_noxref_g ) capacitor c=0.0101598f \
 //x=7.05 //y=6.2 //x2=7.93 //y2=6.2
cc_153 ( N_noxref_1_c_153_p N_CLK_c_6439_n ) capacitor c=5.72528e-19 //x=6.11 \
 //y=1.055 //x2=7.085 //y2=1.09
cc_154 ( N_noxref_1_c_154_p N_CLK_c_6439_n ) capacitor c=0.00150277f //x=6.11 \
 //y=1.4 //x2=7.085 //y2=1.09
cc_155 ( N_noxref_1_c_155_p N_CLK_c_6439_n ) capacitor c=0.0160123f //x=6.64 \
 //y=1.055 //x2=7.085 //y2=1.09
cc_156 ( N_noxref_1_c_156_p N_CLK_c_6442_n ) capacitor c=0.00111227f //x=6.11 \
 //y=1.71 //x2=7.085 //y2=1.4
cc_157 ( N_noxref_1_c_157_p N_CLK_c_6442_n ) capacitor c=0.0124075f //x=6.64 \
 //y=1.4 //x2=7.085 //y2=1.4
cc_158 ( N_noxref_1_c_155_p N_CLK_c_6444_n ) capacitor c=9.19165e-19 //x=6.64 \
 //y=1.055 //x2=7.61 //y2=1.09
cc_159 ( N_noxref_1_c_157_p N_CLK_c_6445_n ) capacitor c=0.0010154f //x=6.64 \
 //y=1.4 //x2=7.61 //y2=1.4
cc_160 ( N_noxref_1_c_157_p N_CLK_c_6446_n ) capacitor c=9.23422e-19 //x=6.64 \
 //y=1.4 //x2=7.61 //y2=1.63
cc_161 ( N_noxref_1_c_133_p N_CLK_c_6447_n ) capacitor c=0.00136403f //x=6.41 \
 //y=2.375 //x2=7.61 //y2=2.095
cc_162 ( N_noxref_1_c_132_p N_CLK_c_6447_n ) capacitor c=0.0020754f //x=6.41 \
 //y=2.26 //x2=7.61 //y2=2.095
cc_163 ( N_noxref_1_c_135_p N_CLK_c_6447_n ) capacitor c=0.00964411f //x=6.11 \
 //y=2.095 //x2=7.61 //y2=2.095
cc_164 ( N_noxref_1_c_137_p N_CLK_c_6450_n ) capacitor c=0.00123917f //x=6.41 \
 //y=4.88 //x2=7.52 //y2=4.88
cc_165 ( N_noxref_1_c_43_p N_CLK_c_6450_n ) capacitor c=0.0169508f //x=6.975 \
 //y=4.97 //x2=7.52 //y2=4.88
cc_166 ( N_noxref_1_c_139_p N_CLK_c_6450_n ) capacitor c=0.00406071f //x=6.685 \
 //y=4.97 //x2=7.52 //y2=4.88
cc_167 ( N_noxref_1_c_12_p RN ) capacitor c=0.00340415f //x=4.56 //y=5.25 \
 //x2=2.71 //y2=2.77
cc_168 ( N_noxref_1_c_119_p N_RN_c_7850_n ) capacitor c=3.59838e-19 //x=2.78 \
 //y=5.335 //x2=2.71 //y2=2.56
cc_169 ( N_noxref_1_c_113_p N_RN_c_7850_n ) capacitor c=4.64314e-19 //x=2.9 \
 //y=5.335 //x2=2.71 //y2=2.56
cc_170 ( N_noxref_1_c_119_p N_RN_c_7852_n ) capacitor c=0.0218571f //x=2.78 \
 //y=5.335 //x2=2.71 //y2=4.765
cc_171 ( N_noxref_1_c_113_p N_RN_c_7852_n ) capacitor c=0.00244335f //x=2.9 \
 //y=5.335 //x2=2.71 //y2=4.765
cc_172 ( N_noxref_1_c_172_p N_RN_c_7852_n ) capacitor c=7.85344e-19 //x=2.9 \
 //y=5.56 //x2=2.71 //y2=4.765
cc_173 ( N_noxref_1_c_18_p N_RN_c_7855_n ) capacitor c=6.87062e-19 //x=4.075 \
 //y=1.305 //x2=13.795 //y2=2.4
cc_174 ( N_noxref_1_c_19_p N_RN_c_7855_n ) capacitor c=0.0206216f //x=4.16 \
 //y=1.845 //x2=13.795 //y2=2.4
cc_175 ( N_noxref_1_c_9_p N_RN_c_7855_n ) capacitor c=0.027263f //x=4.56 \
 //y=2.625 //x2=13.795 //y2=2.4
cc_176 ( N_noxref_1_c_11_p N_RN_c_7855_n ) capacitor c=0.00571008f //x=4.56 \
 //y=2.945 //x2=13.795 //y2=2.4
cc_177 ( N_noxref_1_c_133_p N_RN_c_7855_n ) capacitor c=0.0155883f //x=6.41 \
 //y=2.375 //x2=13.795 //y2=2.4
cc_178 ( N_noxref_1_c_13_p N_RN_c_7855_n ) capacitor c=0.0138002f //x=6.41 \
 //y=2.625 //x2=13.795 //y2=2.4
cc_179 ( N_noxref_1_c_51_p N_RN_c_7855_n ) capacitor c=0.00747608f //x=6.41 \
 //y=2.945 //x2=13.795 //y2=2.4
cc_180 ( N_noxref_1_c_29_p N_RN_c_7855_n ) capacitor c=0.0155623f //x=11.22 \
 //y=2.375 //x2=13.795 //y2=2.4
cc_181 ( N_noxref_1_c_30_p N_RN_c_7855_n ) capacitor c=0.0137567f //x=11.22 \
 //y=2.625 //x2=13.795 //y2=2.4
cc_182 ( N_noxref_1_c_31_p N_RN_c_7855_n ) capacitor c=0.00802015f //x=11.22 \
 //y=2.945 //x2=13.795 //y2=2.4
cc_183 ( N_noxref_1_c_16_p N_RN_c_7855_n ) capacitor c=0.0365231f //x=4.725 \
 //y=2.785 //x2=13.795 //y2=2.4
cc_184 ( N_noxref_1_c_54_p N_RN_c_7855_n ) capacitor c=0.1407f //x=6.255 \
 //y=2.785 //x2=13.795 //y2=2.4
cc_185 ( N_noxref_1_c_55_p N_RN_c_7855_n ) capacitor c=0.0370413f //x=6.575 \
 //y=2.785 //x2=13.795 //y2=2.4
cc_186 ( N_noxref_1_c_33_p N_RN_c_7855_n ) capacitor c=0.0370413f //x=11.22 \
 //y=2.785 //x2=13.795 //y2=2.4
cc_187 ( N_noxref_1_c_34_p N_RN_c_7855_n ) capacitor c=0.404559f //x=11.06 \
 //y=2.785 //x2=13.795 //y2=2.4
cc_188 ( N_noxref_1_c_132_p N_RN_c_7855_n ) capacitor c=5.18204e-19 //x=6.41 \
 //y=2.26 //x2=13.795 //y2=2.4
cc_189 ( N_noxref_1_c_189_p N_RN_c_7855_n ) capacitor c=5.18204e-19 //x=11.22 \
 //y=2.26 //x2=13.795 //y2=2.4
cc_190 ( N_noxref_1_c_135_p N_RN_c_7855_n ) capacitor c=3.41298e-19 //x=6.11 \
 //y=2.095 //x2=13.795 //y2=2.4
cc_191 ( N_noxref_1_c_191_p N_RN_c_7855_n ) capacitor c=3.41298e-19 //x=10.92 \
 //y=2.095 //x2=13.795 //y2=2.4
cc_192 ( N_noxref_1_c_119_p N_RN_c_7874_n ) capacitor c=0.00492634f //x=2.78 \
 //y=5.335 //x2=2.71 //y2=4.88
cc_193 ( N_noxref_1_c_113_p N_RN_c_7874_n ) capacitor c=0.00132214f //x=2.9 \
 //y=5.335 //x2=2.71 //y2=4.88
cc_194 ( N_noxref_1_c_119_p N_RN_M63_noxref_g ) capacitor c=0.00858241f \
 //x=2.78 //y=5.335 //x2=2.68 //y2=6.2
cc_195 ( N_noxref_1_c_113_p N_RN_M63_noxref_g ) capacitor c=0.00229818f \
 //x=2.9 //y=5.335 //x2=2.68 //y2=6.2
cc_196 ( N_noxref_1_c_172_p N_RN_M63_noxref_g ) capacitor c=0.0179041f //x=2.9 \
 //y=5.56 //x2=2.68 //y2=6.2
cc_197 ( N_noxref_1_c_67_p N_RN_M64_noxref_g ) capacitor c=0.0103546f \
 //x=3.665 //y=5.335 //x2=3.12 //y2=6.2
cc_198 ( N_noxref_1_c_113_p N_RN_M64_noxref_g ) capacitor c=0.00230699f \
 //x=2.9 //y=5.335 //x2=3.12 //y2=6.2
cc_199 ( N_noxref_1_c_172_p N_RN_M64_noxref_g ) capacitor c=0.0179041f //x=2.9 \
 //y=5.56 //x2=3.12 //y2=6.2
cc_200 ( N_noxref_1_c_113_p N_RN_c_7882_n ) capacitor c=0.00180979f //x=2.9 \
 //y=5.335 //x2=3.045 //y2=4.97
cc_201 ( N_noxref_1_c_172_p N_RN_c_7882_n ) capacitor c=0.00290085f //x=2.9 \
 //y=5.56 //x2=3.045 //y2=4.97
cc_202 ( N_noxref_1_c_119_p N_RN_c_7884_n ) capacitor c=6.14463e-19 //x=2.78 \
 //y=5.335 //x2=2.71 //y2=4.88
cc_203 ( N_noxref_1_c_30_p SN ) capacitor c=0.00510184f //x=11.22 //y=2.625 \
 //x2=12.33 //y2=2.77
cc_204 ( N_noxref_1_c_31_p SN ) capacitor c=0.00782712f //x=11.22 //y=2.945 \
 //x2=12.33 //y2=2.77
cc_205 ( N_noxref_1_c_32_p SN ) capacitor c=6.32157e-19 //x=11.22 //y=4.755 \
 //x2=12.33 //y2=2.77
cc_206 ( N_noxref_1_c_5_p SN ) capacitor c=3.49492e-19 //x=11.22 //y=2.77 \
 //x2=12.33 //y2=2.77
cc_207 ( N_noxref_1_c_33_p SN ) capacitor c=0.00513442f //x=11.22 //y=2.785 \
 //x2=12.33 //y2=2.77
cc_208 ( N_noxref_1_c_189_p SN ) capacitor c=3.9149e-19 //x=11.22 //y=2.26 \
 //x2=12.33 //y2=2.77
cc_209 ( N_noxref_1_c_32_p SN ) capacitor c=5.01652e-19 //x=11.22 //y=4.755 \
 //x2=12.33 //y2=3.14
cc_210 ( N_noxref_1_c_29_p N_SN_c_9841_n ) capacitor c=0.00932261f //x=11.22 \
 //y=2.375 //x2=12.33 //y2=2.375
cc_211 ( N_noxref_1_c_189_p N_SN_c_9841_n ) capacitor c=5.40058e-19 //x=11.22 \
 //y=2.26 //x2=12.33 //y2=2.375
cc_212 ( N_noxref_1_c_191_p N_SN_c_9841_n ) capacitor c=0.00142893f //x=10.92 \
 //y=2.095 //x2=12.33 //y2=2.375
cc_213 ( N_noxref_1_c_32_p N_SN_c_9844_n ) capacitor c=0.00782712f //x=11.22 \
 //y=4.755 //x2=12.33 //y2=3.285
cc_214 ( N_noxref_1_c_32_p N_SN_c_9845_n ) capacitor c=0.0438274f //x=11.22 \
 //y=4.755 //x2=12.33 //y2=4.765
cc_215 ( N_noxref_1_c_215_p N_SN_c_9845_n ) capacitor c=6.26008e-19 //x=11.22 \
 //y=4.88 //x2=12.33 //y2=4.765
cc_216 ( N_noxref_1_c_4_p N_SN_c_9845_n ) capacitor c=7.66769e-19 //x=11.785 \
 //y=4.97 //x2=12.33 //y2=4.765
cc_217 ( N_noxref_1_c_217_p N_SN_c_9845_n ) capacitor c=7.54501e-19 //x=11.495 \
 //y=4.97 //x2=12.33 //y2=4.765
cc_218 ( N_noxref_1_c_32_p N_SN_c_9849_n ) capacitor c=0.00513501f //x=11.22 \
 //y=4.755 //x2=12.49 //y2=3.125
cc_219 ( N_noxref_1_c_29_p N_SN_c_9850_n ) capacitor c=5.39999e-19 //x=11.22 \
 //y=2.375 //x2=12.33 //y2=2.26
cc_220 ( N_noxref_1_c_30_p N_SN_c_9850_n ) capacitor c=3.9149e-19 //x=11.22 \
 //y=2.625 //x2=12.33 //y2=2.26
cc_221 ( N_noxref_1_c_189_p N_SN_c_9850_n ) capacitor c=0.00125213f //x=11.22 \
 //y=2.26 //x2=12.33 //y2=2.26
cc_222 ( N_noxref_1_c_191_p N_SN_c_9850_n ) capacitor c=0.00214573f //x=10.92 \
 //y=2.095 //x2=12.33 //y2=2.26
cc_223 ( N_noxref_1_c_32_p N_SN_c_9854_n ) capacitor c=0.00103399f //x=11.22 \
 //y=4.755 //x2=12.33 //y2=4.88
cc_224 ( N_noxref_1_c_215_p N_SN_c_9854_n ) capacitor c=0.00113984f //x=11.22 \
 //y=4.88 //x2=12.33 //y2=4.88
cc_225 ( N_noxref_1_c_4_p N_SN_c_9854_n ) capacitor c=0.00116563f //x=11.785 \
 //y=4.97 //x2=12.33 //y2=4.88
cc_226 ( N_noxref_1_c_217_p N_SN_c_9854_n ) capacitor c=0.00129812f //x=11.495 \
 //y=4.97 //x2=12.33 //y2=4.88
cc_227 ( N_noxref_1_M73_noxref_g N_SN_M75_noxref_g ) capacitor c=0.0106276f \
 //x=11.42 //y=6.2 //x2=12.3 //y2=6.2
cc_228 ( N_noxref_1_M74_noxref_g N_SN_M75_noxref_g ) capacitor c=0.107144f \
 //x=11.86 //y=6.2 //x2=12.3 //y2=6.2
cc_229 ( N_noxref_1_M74_noxref_g N_SN_M76_noxref_g ) capacitor c=0.0101598f \
 //x=11.86 //y=6.2 //x2=12.74 //y2=6.2
cc_230 ( N_noxref_1_c_230_p N_SN_c_9861_n ) capacitor c=5.72528e-19 //x=10.92 \
 //y=1.055 //x2=11.895 //y2=1.09
cc_231 ( N_noxref_1_c_231_p N_SN_c_9861_n ) capacitor c=0.00150277f //x=10.92 \
 //y=1.4 //x2=11.895 //y2=1.09
cc_232 ( N_noxref_1_c_232_p N_SN_c_9861_n ) capacitor c=0.0160123f //x=11.45 \
 //y=1.055 //x2=11.895 //y2=1.09
cc_233 ( N_noxref_1_c_233_p N_SN_c_9864_n ) capacitor c=0.00111227f //x=10.92 \
 //y=1.71 //x2=11.895 //y2=1.4
cc_234 ( N_noxref_1_c_234_p N_SN_c_9864_n ) capacitor c=0.0124075f //x=11.45 \
 //y=1.4 //x2=11.895 //y2=1.4
cc_235 ( N_noxref_1_c_232_p N_SN_c_9866_n ) capacitor c=9.19165e-19 //x=11.45 \
 //y=1.055 //x2=12.42 //y2=1.09
cc_236 ( N_noxref_1_c_234_p N_SN_c_9867_n ) capacitor c=0.0010154f //x=11.45 \
 //y=1.4 //x2=12.42 //y2=1.4
cc_237 ( N_noxref_1_c_234_p N_SN_c_9868_n ) capacitor c=9.23422e-19 //x=11.45 \
 //y=1.4 //x2=12.42 //y2=1.63
cc_238 ( N_noxref_1_c_29_p N_SN_c_9869_n ) capacitor c=0.00136403f //x=11.22 \
 //y=2.375 //x2=12.42 //y2=2.095
cc_239 ( N_noxref_1_c_189_p N_SN_c_9869_n ) capacitor c=0.0020754f //x=11.22 \
 //y=2.26 //x2=12.42 //y2=2.095
cc_240 ( N_noxref_1_c_191_p N_SN_c_9869_n ) capacitor c=0.00964411f //x=10.92 \
 //y=2.095 //x2=12.42 //y2=2.095
cc_241 ( N_noxref_1_c_32_p N_SN_c_9872_n ) capacitor c=0.00116212f //x=11.22 \
 //y=4.755 //x2=12.33 //y2=4.88
cc_242 ( N_noxref_1_c_215_p N_SN_c_9872_n ) capacitor c=0.00155973f //x=11.22 \
 //y=4.88 //x2=12.33 //y2=4.88
cc_243 ( N_noxref_1_c_4_p N_SN_c_9872_n ) capacitor c=0.0171374f //x=11.785 \
 //y=4.97 //x2=12.33 //y2=4.88
cc_244 ( N_noxref_1_c_217_p N_SN_c_9872_n ) capacitor c=0.00484466f //x=11.495 \
 //y=4.97 //x2=12.33 //y2=4.88
cc_245 ( N_noxref_1_c_119_p N_VDD_c_13434_n ) capacitor c=0.00621363f //x=2.78 \
 //y=5.335 //x2=87.775 //y2=7.585
cc_246 ( N_noxref_1_c_67_p N_VDD_c_13434_n ) capacitor c=0.00627192f //x=3.665 \
 //y=5.335 //x2=87.775 //y2=7.585
cc_247 ( N_noxref_1_c_39_p N_VDD_c_13434_n ) capacitor c=0.00256022f //x=3.78 \
 //y=5.56 //x2=87.775 //y2=7.585
cc_248 ( N_noxref_1_c_17_p N_VDD_c_13434_n ) capacitor c=0.00824064f //x=4.475 \
 //y=5.335 //x2=87.775 //y2=7.585
cc_249 ( N_noxref_1_c_112_p N_VDD_c_13434_n ) capacitor c=0.00261804f \
 //x=2.022 //y=5.335 //x2=87.775 //y2=7.585
cc_250 ( N_noxref_1_c_113_p N_VDD_c_13434_n ) capacitor c=0.00270108f //x=2.9 \
 //y=5.335 //x2=87.775 //y2=7.585
cc_251 ( N_noxref_1_c_118_p N_VDD_c_13434_n ) capacitor c=0.0024232f //x=2.02 \
 //y=5.56 //x2=87.775 //y2=7.585
cc_252 ( N_noxref_1_c_172_p N_VDD_c_13434_n ) capacitor c=0.0024232f //x=2.9 \
 //y=5.56 //x2=87.775 //y2=7.585
cc_253 ( N_noxref_1_c_26_p N_VDD_c_13434_n ) capacitor c=0.0024232f //x=3.78 \
 //y=5.56 //x2=87.775 //y2=7.585
cc_254 ( N_noxref_1_c_112_p N_VDD_c_13443_n ) capacitor c=0.00331944f \
 //x=2.022 //y=5.335 //x2=1.23 //y2=7.58
cc_255 ( N_noxref_1_c_118_p N_VDD_c_13443_n ) capacitor c=0.00509469f //x=2.02 \
 //y=5.56 //x2=1.23 //y2=7.58
cc_256 ( N_noxref_1_c_119_p N_VDD_c_13445_n ) capacitor c=0.00202922f //x=2.78 \
 //y=5.335 //x2=2.375 //y2=7.585
cc_257 ( N_noxref_1_c_112_p N_VDD_c_13445_n ) capacitor c=9.3757e-19 //x=2.022 \
 //y=5.335 //x2=2.375 //y2=7.585
cc_258 ( N_noxref_1_c_118_p N_VDD_c_13445_n ) capacitor c=0.0138074f //x=2.02 \
 //y=5.56 //x2=2.375 //y2=7.585
cc_259 ( N_noxref_1_c_119_p N_VDD_c_13448_n ) capacitor c=0.0017708f //x=2.78 \
 //y=5.335 //x2=3.255 //y2=7.585
cc_260 ( N_noxref_1_c_67_p N_VDD_c_13448_n ) capacitor c=0.00202922f //x=3.665 \
 //y=5.335 //x2=3.255 //y2=7.585
cc_261 ( N_noxref_1_c_113_p N_VDD_c_13448_n ) capacitor c=9.4822e-19 //x=2.9 \
 //y=5.335 //x2=3.255 //y2=7.585
cc_262 ( N_noxref_1_c_172_p N_VDD_c_13448_n ) capacitor c=0.0138074f //x=2.9 \
 //y=5.56 //x2=3.255 //y2=7.585
cc_263 ( N_noxref_1_c_67_p N_VDD_c_13452_n ) capacitor c=0.00205906f //x=3.665 \
 //y=5.335 //x2=4.135 //y2=7.585
cc_264 ( N_noxref_1_c_39_p N_VDD_c_13452_n ) capacitor c=8.49654e-19 //x=3.78 \
 //y=5.56 //x2=4.135 //y2=7.585
cc_265 ( N_noxref_1_c_17_p N_VDD_c_13452_n ) capacitor c=0.00204238f //x=4.475 \
 //y=5.335 //x2=4.135 //y2=7.585
cc_266 ( N_noxref_1_c_26_p N_VDD_c_13452_n ) capacitor c=0.0138074f //x=3.78 \
 //y=5.56 //x2=4.135 //y2=7.585
cc_267 ( N_noxref_1_c_17_p N_VDD_c_13456_n ) capacitor c=0.00183742f //x=4.475 \
 //y=5.335 //x2=5.13 //y2=7.585
cc_268 ( N_noxref_1_M67_noxref_g N_VDD_c_13457_n ) capacitor c=0.00755614f \
 //x=6.61 //y=6.2 //x2=7.185 //y2=7.585
cc_269 ( N_noxref_1_M68_noxref_g N_VDD_c_13457_n ) capacitor c=0.00755544f \
 //x=7.05 //y=6.2 //x2=7.185 //y2=7.585
cc_270 ( N_noxref_1_M73_noxref_g N_VDD_c_13459_n ) capacitor c=0.00755614f \
 //x=11.42 //y=6.2 //x2=11.995 //y2=7.585
cc_271 ( N_noxref_1_M74_noxref_g N_VDD_c_13459_n ) capacitor c=0.00755544f \
 //x=11.86 //y=6.2 //x2=11.995 //y2=7.585
cc_272 ( N_noxref_1_c_39_p N_VDD_c_13461_n ) capacitor c=0.00282782f //x=3.78 \
 //y=5.56 //x2=5.3 //y2=7.585
cc_273 ( N_noxref_1_c_12_p N_VDD_c_13461_n ) capacitor c=0.0352413f //x=4.56 \
 //y=5.25 //x2=5.3 //y2=7.585
cc_274 ( N_noxref_1_c_14_p N_VDD_c_13461_n ) capacitor c=0.0139369f //x=6.41 \
 //y=4.755 //x2=5.3 //y2=7.585
cc_275 ( N_noxref_1_c_26_p N_VDD_c_13461_n ) capacitor c=0.00777981f //x=3.78 \
 //y=5.56 //x2=5.3 //y2=7.585
cc_276 ( N_noxref_1_c_137_p N_VDD_c_13461_n ) capacitor c=0.00370784f //x=6.41 \
 //y=4.88 //x2=5.3 //y2=7.585
cc_277 ( N_noxref_1_c_139_p N_VDD_c_13461_n ) capacitor c=0.00590568f \
 //x=6.685 //y=4.97 //x2=5.3 //y2=7.585
cc_278 ( N_noxref_1_c_32_p N_VDD_c_13467_n ) capacitor c=0.0118088f //x=11.22 \
 //y=4.755 //x2=10.11 //y2=7.585
cc_279 ( N_noxref_1_c_215_p N_VDD_c_13467_n ) capacitor c=0.00370784f \
 //x=11.22 //y=4.88 //x2=10.11 //y2=7.585
cc_280 ( N_noxref_1_c_217_p N_VDD_c_13467_n ) capacitor c=0.00590568f \
 //x=11.495 //y=4.97 //x2=10.11 //y2=7.585
cc_281 ( N_noxref_1_c_112_p N_VDD_M61_noxref_s ) capacitor c=0.0453361f \
 //x=2.022 //y=5.335 //x2=1.445 //y2=5.2
cc_282 ( N_noxref_1_c_113_p N_VDD_M61_noxref_s ) capacitor c=7.80122e-19 \
 //x=2.9 //y=5.335 //x2=1.445 //y2=5.2
cc_283 ( N_noxref_1_c_118_p N_VDD_M61_noxref_s ) capacitor c=0.09305f //x=2.02 \
 //y=5.56 //x2=1.445 //y2=5.2
cc_284 ( N_noxref_1_c_119_p N_VDD_M62_noxref_d ) capacitor c=0.00700141f \
 //x=2.78 //y=5.335 //x2=2.315 //y2=5.2
cc_285 ( N_noxref_1_c_118_p N_VDD_M62_noxref_d ) capacitor c=0.0674491f \
 //x=2.02 //y=5.56 //x2=2.315 //y2=5.2
cc_286 ( N_noxref_1_c_172_p N_VDD_M62_noxref_d ) capacitor c=0.0674762f \
 //x=2.9 //y=5.56 //x2=2.315 //y2=5.2
cc_287 ( N_noxref_1_c_67_p N_VDD_M64_noxref_d ) capacitor c=0.00700141f \
 //x=3.665 //y=5.335 //x2=3.195 //y2=5.2
cc_288 ( N_noxref_1_c_172_p N_VDD_M64_noxref_d ) capacitor c=0.067493f //x=2.9 \
 //y=5.56 //x2=3.195 //y2=5.2
cc_289 ( N_noxref_1_c_26_p N_VDD_M64_noxref_d ) capacitor c=0.0674979f \
 //x=3.78 //y=5.56 //x2=3.195 //y2=5.2
cc_290 ( N_noxref_1_c_17_p N_VDD_M66_noxref_d ) capacitor c=0.00700141f \
 //x=4.475 //y=5.335 //x2=4.075 //y2=5.2
cc_291 ( N_noxref_1_c_26_p N_VDD_M66_noxref_d ) capacitor c=0.0675002f \
 //x=3.78 //y=5.56 //x2=4.075 //y2=5.2
cc_292 ( N_noxref_1_c_39_p N_VDD_M67_noxref_s ) capacitor c=0.00492616f \
 //x=3.78 //y=5.56 //x2=6.255 //y2=5.2
cc_293 ( N_noxref_1_c_17_p N_VDD_M67_noxref_s ) capacitor c=9.42705e-19 \
 //x=4.475 //y=5.335 //x2=6.255 //y2=5.2
cc_294 ( N_noxref_1_c_51_p N_VDD_M67_noxref_s ) capacitor c=4.51972e-19 \
 //x=6.41 //y=2.945 //x2=6.255 //y2=5.2
cc_295 ( N_noxref_1_c_14_p N_VDD_M67_noxref_s ) capacitor c=0.0224586f \
 //x=6.41 //y=4.755 //x2=6.255 //y2=5.2
cc_296 ( N_noxref_1_c_113_p N_VDD_M67_noxref_s ) capacitor c=2.11884e-19 \
 //x=2.9 //y=5.335 //x2=6.255 //y2=5.2
cc_297 ( N_noxref_1_c_137_p N_VDD_M67_noxref_s ) capacitor c=0.00983413f \
 //x=6.41 //y=4.88 //x2=6.255 //y2=5.2
cc_298 ( N_noxref_1_M67_noxref_g N_VDD_M67_noxref_s ) capacitor c=0.053419f \
 //x=6.61 //y=6.2 //x2=6.255 //y2=5.2
cc_299 ( N_noxref_1_c_139_p N_VDD_M67_noxref_s ) capacitor c=0.0060887f \
 //x=6.685 //y=4.97 //x2=6.255 //y2=5.2
cc_300 ( N_noxref_1_M68_noxref_g N_VDD_M68_noxref_d ) capacitor c=0.015318f \
 //x=7.05 //y=6.2 //x2=7.125 //y2=5.2
cc_301 ( N_noxref_1_c_31_p N_VDD_M73_noxref_s ) capacitor c=4.37211e-19 \
 //x=11.22 //y=2.945 //x2=11.065 //y2=5.2
cc_302 ( N_noxref_1_c_32_p N_VDD_M73_noxref_s ) capacitor c=0.0217981f \
 //x=11.22 //y=4.755 //x2=11.065 //y2=5.2
cc_303 ( N_noxref_1_c_215_p N_VDD_M73_noxref_s ) capacitor c=0.00983846f \
 //x=11.22 //y=4.88 //x2=11.065 //y2=5.2
cc_304 ( N_noxref_1_M73_noxref_g N_VDD_M73_noxref_s ) capacitor c=0.053419f \
 //x=11.42 //y=6.2 //x2=11.065 //y2=5.2
cc_305 ( N_noxref_1_c_217_p N_VDD_M73_noxref_s ) capacitor c=0.0060887f \
 //x=11.495 //y=4.97 //x2=11.065 //y2=5.2
cc_306 ( N_noxref_1_M74_noxref_g N_VDD_M74_noxref_d ) capacitor c=0.015318f \
 //x=11.86 //y=6.2 //x2=11.935 //y2=5.2
cc_307 ( N_noxref_1_c_18_p N_noxref_26_c_14881_n ) capacitor c=0.0036878f \
 //x=4.075 //y=1.305 //x2=4.475 //y2=0.72
cc_308 ( N_noxref_1_c_28_p N_noxref_26_c_14881_n ) capacitor c=0.00399931f \
 //x=4.475 //y=1.845 //x2=4.475 //y2=0.72
cc_309 ( N_noxref_1_M2_noxref_d N_noxref_26_c_14881_n ) capacitor \
 c=0.00910163f //x=3.885 //y=1.095 //x2=4.475 //y2=0.72
cc_310 ( N_noxref_1_M2_noxref_d N_noxref_26_c_14884_n ) capacitor \
 c=0.00120711f //x=3.885 //y=1.095 //x2=3.59 //y2=1.175
cc_311 ( N_noxref_1_c_119_p N_noxref_26_M1_noxref_d ) capacitor c=0.00143811f \
 //x=2.78 //y=5.335 //x2=2.35 //y2=1.09
cc_312 ( N_noxref_1_c_18_p N_noxref_26_M1_noxref_d ) capacitor c=0.00802417f \
 //x=4.075 //y=1.305 //x2=2.35 //y2=1.09
cc_313 ( N_noxref_1_c_18_p N_noxref_26_M2_noxref_s ) capacitor c=0.0098487f \
 //x=4.075 //y=1.305 //x2=3.455 //y2=0.555
cc_314 ( N_noxref_1_c_76_p N_noxref_26_M2_noxref_s ) capacitor c=0.028602f \
 //x=4.075 //y=1.76 //x2=3.455 //y2=0.555
cc_315 ( N_noxref_1_c_28_p N_noxref_26_M2_noxref_s ) capacitor c=0.00752108f \
 //x=4.475 //y=1.845 //x2=3.455 //y2=0.555
cc_316 ( N_noxref_1_c_15_p N_noxref_26_M2_noxref_s ) capacitor c=0.00309975f \
 //x=4.56 //y=2.77 //x2=3.455 //y2=0.555
cc_317 ( N_noxref_1_M2_noxref_d N_noxref_26_M2_noxref_s ) capacitor \
 c=0.0279003f //x=3.885 //y=1.095 //x2=3.455 //y2=0.555
cc_318 ( N_noxref_1_c_18_p N_noxref_27_M4_noxref_d ) capacitor c=3.20746e-19 \
 //x=4.075 //y=1.305 //x2=7.16 //y2=1.09
cc_319 ( N_noxref_1_c_18_p N_GND_c_16390_n ) capacitor c=0.00884249f //x=4.075 \
 //y=1.305 //x2=6.29 //y2=0.175
cc_320 ( N_noxref_1_c_28_p N_GND_c_16390_n ) capacitor c=0.00662992f //x=4.475 \
 //y=1.845 //x2=6.29 //y2=0.175
cc_321 ( N_noxref_1_c_11_p N_GND_c_16390_n ) capacitor c=4.3138e-19 //x=4.56 \
 //y=2.945 //x2=6.29 //y2=0.175
cc_322 ( N_noxref_1_M2_noxref_d N_GND_c_16390_n ) capacitor c=2.9462e-19 \
 //x=3.885 //y=1.095 //x2=6.29 //y2=0.175
cc_323 ( N_noxref_1_c_153_p N_GND_c_16394_n ) capacitor c=3.97665e-19 //x=6.11 \
 //y=1.055 //x2=6.375 //y2=1.015
cc_324 ( N_noxref_1_c_324_p N_GND_c_16394_n ) capacitor c=0.00864776f \
 //x=6.485 //y=0.9 //x2=6.375 //y2=1.015
cc_325 ( N_noxref_1_c_155_p N_GND_c_16394_n ) capacitor c=4.45447e-19 //x=6.64 \
 //y=1.055 //x2=6.375 //y2=1.015
cc_326 ( N_noxref_1_c_230_p N_GND_c_16397_n ) capacitor c=3.97665e-19 \
 //x=10.92 //y=1.055 //x2=11.185 //y2=1.015
cc_327 ( N_noxref_1_c_327_p N_GND_c_16397_n ) capacitor c=0.00864776f \
 //x=11.295 //y=0.9 //x2=11.185 //y2=1.015
cc_328 ( N_noxref_1_c_232_p N_GND_c_16397_n ) capacitor c=4.45447e-19 \
 //x=11.45 //y=1.055 //x2=11.185 //y2=1.015
cc_329 ( N_noxref_1_c_18_p N_GND_c_16400_n ) capacitor c=0.00543195f //x=4.075 \
 //y=1.305 //x2=6.375 //y2=1.145
cc_330 ( N_noxref_1_c_133_p N_GND_c_16400_n ) capacitor c=0.00772482f //x=6.41 \
 //y=2.375 //x2=6.375 //y2=1.145
cc_331 ( N_noxref_1_c_51_p N_GND_c_16400_n ) capacitor c=9.18427e-19 //x=6.41 \
 //y=2.945 //x2=6.375 //y2=1.145
cc_332 ( N_noxref_1_c_132_p N_GND_c_16400_n ) capacitor c=2.22883e-19 //x=6.41 \
 //y=2.26 //x2=6.375 //y2=1.145
cc_333 ( N_noxref_1_c_153_p N_GND_c_16400_n ) capacitor c=0.00156339f //x=6.11 \
 //y=1.055 //x2=6.375 //y2=1.145
cc_334 ( N_noxref_1_c_154_p N_GND_c_16400_n ) capacitor c=0.00352472f //x=6.11 \
 //y=1.4 //x2=6.375 //y2=1.145
cc_335 ( N_noxref_1_c_156_p N_GND_c_16400_n ) capacitor c=4.35713e-19 //x=6.11 \
 //y=1.71 //x2=6.375 //y2=1.145
cc_336 ( N_noxref_1_c_324_p N_GND_c_16400_n ) capacitor c=9.36995e-19 \
 //x=6.485 //y=0.9 //x2=6.375 //y2=1.145
cc_337 ( N_noxref_1_c_337_p N_GND_c_16400_n ) capacitor c=5.29132e-19 \
 //x=6.485 //y=1.555 //x2=6.375 //y2=1.145
cc_338 ( N_noxref_1_c_155_p N_GND_c_16400_n ) capacitor c=0.0017438f //x=6.64 \
 //y=1.055 //x2=6.375 //y2=1.145
cc_339 ( N_noxref_1_c_157_p N_GND_c_16400_n ) capacitor c=0.00276804f //x=6.64 \
 //y=1.4 //x2=6.375 //y2=1.145
cc_340 ( N_noxref_1_c_29_p N_GND_c_16411_n ) capacitor c=0.00772482f //x=11.22 \
 //y=2.375 //x2=11.185 //y2=1.145
cc_341 ( N_noxref_1_c_31_p N_GND_c_16411_n ) capacitor c=0.00117625f //x=11.22 \
 //y=2.945 //x2=11.185 //y2=1.145
cc_342 ( N_noxref_1_c_189_p N_GND_c_16411_n ) capacitor c=2.22883e-19 \
 //x=11.22 //y=2.26 //x2=11.185 //y2=1.145
cc_343 ( N_noxref_1_c_230_p N_GND_c_16411_n ) capacitor c=0.00156339f \
 //x=10.92 //y=1.055 //x2=11.185 //y2=1.145
cc_344 ( N_noxref_1_c_231_p N_GND_c_16411_n ) capacitor c=0.00352472f \
 //x=10.92 //y=1.4 //x2=11.185 //y2=1.145
cc_345 ( N_noxref_1_c_233_p N_GND_c_16411_n ) capacitor c=3.86356e-19 \
 //x=10.92 //y=1.71 //x2=11.185 //y2=1.145
cc_346 ( N_noxref_1_c_327_p N_GND_c_16411_n ) capacitor c=9.36995e-19 \
 //x=11.295 //y=0.9 //x2=11.185 //y2=1.145
cc_347 ( N_noxref_1_c_347_p N_GND_c_16411_n ) capacitor c=5.29132e-19 \
 //x=11.295 //y=1.555 //x2=11.185 //y2=1.145
cc_348 ( N_noxref_1_c_232_p N_GND_c_16411_n ) capacitor c=0.0017438f //x=11.45 \
 //y=1.055 //x2=11.185 //y2=1.145
cc_349 ( N_noxref_1_c_234_p N_GND_c_16411_n ) capacitor c=0.00276804f \
 //x=11.45 //y=1.4 //x2=11.185 //y2=1.145
cc_350 ( N_noxref_1_c_28_p N_GND_c_16421_n ) capacitor c=6.86343e-19 //x=4.475 \
 //y=1.845 //x2=5.13 //y2=0.175
cc_351 ( N_noxref_1_c_11_p N_GND_c_16421_n ) capacitor c=6.00694e-19 //x=4.56 \
 //y=2.945 //x2=5.13 //y2=0.175
cc_352 ( N_noxref_1_c_153_p N_GND_c_16423_n ) capacitor c=0.00677932f //x=6.11 \
 //y=1.055 //x2=9.94 //y2=0.175
cc_353 ( N_noxref_1_c_230_p N_GND_c_16424_n ) capacitor c=0.00677849f \
 //x=10.92 //y=1.055 //x2=14.75 //y2=0.175
cc_354 ( N_noxref_1_c_76_p N_GND_c_16425_n ) capacitor c=0.0045138f //x=4.075 \
 //y=1.76 //x2=5.3 //y2=0.175
cc_355 ( N_noxref_1_c_28_p N_GND_c_16425_n ) capacitor c=0.0229887f //x=4.475 \
 //y=1.845 //x2=5.3 //y2=0.175
cc_356 ( N_noxref_1_c_9_p N_GND_c_16425_n ) capacitor c=2.00878e-19 //x=4.56 \
 //y=2.625 //x2=5.3 //y2=0.175
cc_357 ( N_noxref_1_c_11_p N_GND_c_16425_n ) capacitor c=0.00411109f //x=4.56 \
 //y=2.945 //x2=5.3 //y2=0.175
cc_358 ( N_noxref_1_c_133_p N_GND_c_16425_n ) capacitor c=0.00343139f //x=6.41 \
 //y=2.375 //x2=5.3 //y2=0.175
cc_359 ( N_noxref_1_c_13_p N_GND_c_16425_n ) capacitor c=0.00401621f //x=6.41 \
 //y=2.625 //x2=5.3 //y2=0.175
cc_360 ( N_noxref_1_c_51_p N_GND_c_16425_n ) capacitor c=0.00256181f //x=6.41 \
 //y=2.945 //x2=5.3 //y2=0.175
cc_361 ( N_noxref_1_c_15_p N_GND_c_16425_n ) capacitor c=0.0104119f //x=4.56 \
 //y=2.77 //x2=5.3 //y2=0.175
cc_362 ( N_noxref_1_c_129_p N_GND_c_16425_n ) capacitor c=0.00527261f //x=6.41 \
 //y=2.77 //x2=5.3 //y2=0.175
cc_363 ( N_noxref_1_c_54_p N_GND_c_16425_n ) capacitor c=0.0106006f //x=6.255 \
 //y=2.785 //x2=5.3 //y2=0.175
cc_364 ( N_noxref_1_c_132_p N_GND_c_16425_n ) capacitor c=0.0039621f //x=6.41 \
 //y=2.26 //x2=5.3 //y2=0.175
cc_365 ( N_noxref_1_c_156_p N_GND_c_16425_n ) capacitor c=0.00170145f //x=6.11 \
 //y=1.71 //x2=5.3 //y2=0.175
cc_366 ( N_noxref_1_c_135_p N_GND_c_16425_n ) capacitor c=0.0102191f //x=6.11 \
 //y=2.095 //x2=5.3 //y2=0.175
cc_367 ( N_noxref_1_c_29_p N_GND_c_16438_n ) capacitor c=0.00343139f //x=11.22 \
 //y=2.375 //x2=10.11 //y2=0.175
cc_368 ( N_noxref_1_c_30_p N_GND_c_16438_n ) capacitor c=0.00401621f //x=11.22 \
 //y=2.625 //x2=10.11 //y2=0.175
cc_369 ( N_noxref_1_c_31_p N_GND_c_16438_n ) capacitor c=0.0030172f //x=11.22 \
 //y=2.945 //x2=10.11 //y2=0.175
cc_370 ( N_noxref_1_c_5_p N_GND_c_16438_n ) capacitor c=0.00528783f //x=11.22 \
 //y=2.77 //x2=10.11 //y2=0.175
cc_371 ( N_noxref_1_c_34_p N_GND_c_16438_n ) capacitor c=0.0129556f //x=11.06 \
 //y=2.785 //x2=10.11 //y2=0.175
cc_372 ( N_noxref_1_c_189_p N_GND_c_16438_n ) capacitor c=0.0039621f //x=11.22 \
 //y=2.26 //x2=10.11 //y2=0.175
cc_373 ( N_noxref_1_c_233_p N_GND_c_16438_n ) capacitor c=0.00170145f \
 //x=10.92 //y=1.71 //x2=10.11 //y2=0.175
cc_374 ( N_noxref_1_c_191_p N_GND_c_16438_n ) capacitor c=0.0102191f //x=10.92 \
 //y=2.095 //x2=10.11 //y2=0.175
cc_375 ( N_noxref_1_c_133_p N_GND_M3_noxref_d ) capacitor c=4.4417e-19 \
 //x=6.41 //y=2.375 //x2=6.185 //y2=1.055
cc_376 ( N_noxref_1_c_153_p N_GND_M3_noxref_d ) capacitor c=0.00184354f \
 //x=6.11 //y=1.055 //x2=6.185 //y2=1.055
cc_377 ( N_noxref_1_c_154_p N_GND_M3_noxref_d ) capacitor c=0.00210798f \
 //x=6.11 //y=1.4 //x2=6.185 //y2=1.055
cc_378 ( N_noxref_1_c_324_p N_GND_M3_noxref_d ) capacitor c=0.00474029f \
 //x=6.485 //y=0.9 //x2=6.185 //y2=1.055
cc_379 ( N_noxref_1_c_337_p N_GND_M3_noxref_d ) capacitor c=0.00166857f \
 //x=6.485 //y=1.555 //x2=6.185 //y2=1.055
cc_380 ( N_noxref_1_c_155_p N_GND_M3_noxref_d ) capacitor c=0.00230174f \
 //x=6.64 //y=1.055 //x2=6.185 //y2=1.055
cc_381 ( N_noxref_1_c_157_p N_GND_M3_noxref_d ) capacitor c=0.00210798f \
 //x=6.64 //y=1.4 //x2=6.185 //y2=1.055
cc_382 ( N_noxref_1_c_29_p N_GND_M6_noxref_d ) capacitor c=4.4417e-19 \
 //x=11.22 //y=2.375 //x2=10.995 //y2=1.055
cc_383 ( N_noxref_1_c_230_p N_GND_M6_noxref_d ) capacitor c=0.00184354f \
 //x=10.92 //y=1.055 //x2=10.995 //y2=1.055
cc_384 ( N_noxref_1_c_231_p N_GND_M6_noxref_d ) capacitor c=0.00210798f \
 //x=10.92 //y=1.4 //x2=10.995 //y2=1.055
cc_385 ( N_noxref_1_c_327_p N_GND_M6_noxref_d ) capacitor c=0.00474029f \
 //x=11.295 //y=0.9 //x2=10.995 //y2=1.055
cc_386 ( N_noxref_1_c_347_p N_GND_M6_noxref_d ) capacitor c=0.00166857f \
 //x=11.295 //y=1.555 //x2=10.995 //y2=1.055
cc_387 ( N_noxref_1_c_232_p N_GND_M6_noxref_d ) capacitor c=0.00230174f \
 //x=11.45 //y=1.055 //x2=10.995 //y2=1.055
cc_388 ( N_noxref_1_c_234_p N_GND_M6_noxref_d ) capacitor c=0.00210798f \
 //x=11.45 //y=1.4 //x2=10.995 //y2=1.055
cc_389 ( N_noxref_1_c_135_p N_noxref_48_c_18190_n ) capacitor c=0.00262672f \
 //x=6.11 //y=2.095 //x2=5.89 //y2=1.685
cc_390 ( N_noxref_1_c_133_p N_noxref_48_c_18191_n ) capacitor c=0.00428451f \
 //x=6.41 //y=2.375 //x2=6.775 //y2=1.77
cc_391 ( N_noxref_1_c_51_p N_noxref_48_c_18191_n ) capacitor c=0.00361907f \
 //x=6.41 //y=2.945 //x2=6.775 //y2=1.77
cc_392 ( N_noxref_1_c_132_p N_noxref_48_c_18191_n ) capacitor c=0.0104666f \
 //x=6.41 //y=2.26 //x2=6.775 //y2=1.77
cc_393 ( N_noxref_1_c_156_p N_noxref_48_c_18191_n ) capacitor c=0.00705077f \
 //x=6.11 //y=1.71 //x2=6.775 //y2=1.77
cc_394 ( N_noxref_1_c_135_p N_noxref_48_c_18191_n ) capacitor c=0.0204935f \
 //x=6.11 //y=2.095 //x2=6.775 //y2=1.77
cc_395 ( N_noxref_1_c_337_p N_noxref_48_c_18191_n ) capacitor c=0.00588627f \
 //x=6.485 //y=1.555 //x2=6.775 //y2=1.77
cc_396 ( N_noxref_1_c_157_p N_noxref_48_c_18191_n ) capacitor c=0.00698822f \
 //x=6.64 //y=1.4 //x2=6.775 //y2=1.77
cc_397 ( N_noxref_1_c_153_p N_noxref_48_M3_noxref_s ) capacitor c=0.0295256f \
 //x=6.11 //y=1.055 //x2=5.755 //y2=0.555
cc_398 ( N_noxref_1_c_156_p N_noxref_48_M3_noxref_s ) capacitor c=7.99997e-19 \
 //x=6.11 //y=1.71 //x2=5.755 //y2=0.555
cc_399 ( N_noxref_1_c_135_p N_noxref_48_M3_noxref_s ) capacitor c=0.00122123f \
 //x=6.11 //y=2.095 //x2=5.755 //y2=0.555
cc_400 ( N_noxref_1_c_155_p N_noxref_48_M3_noxref_s ) capacitor c=0.0125924f \
 //x=6.64 //y=1.055 //x2=5.755 //y2=0.555
cc_401 ( N_noxref_1_c_191_p N_noxref_49_c_18247_n ) capacitor c=0.00262672f \
 //x=10.92 //y=2.095 //x2=10.7 //y2=1.685
cc_402 ( N_noxref_1_c_29_p N_noxref_49_c_18248_n ) capacitor c=0.00428451f \
 //x=11.22 //y=2.375 //x2=11.585 //y2=1.77
cc_403 ( N_noxref_1_c_31_p N_noxref_49_c_18248_n ) capacitor c=0.00447635f \
 //x=11.22 //y=2.945 //x2=11.585 //y2=1.77
cc_404 ( N_noxref_1_c_189_p N_noxref_49_c_18248_n ) capacitor c=0.0104666f \
 //x=11.22 //y=2.26 //x2=11.585 //y2=1.77
cc_405 ( N_noxref_1_c_233_p N_noxref_49_c_18248_n ) capacitor c=0.00705077f \
 //x=10.92 //y=1.71 //x2=11.585 //y2=1.77
cc_406 ( N_noxref_1_c_191_p N_noxref_49_c_18248_n ) capacitor c=0.0197834f \
 //x=10.92 //y=2.095 //x2=11.585 //y2=1.77
cc_407 ( N_noxref_1_c_347_p N_noxref_49_c_18248_n ) capacitor c=0.00588627f \
 //x=11.295 //y=1.555 //x2=11.585 //y2=1.77
cc_408 ( N_noxref_1_c_234_p N_noxref_49_c_18248_n ) capacitor c=0.00698822f \
 //x=11.45 //y=1.4 //x2=11.585 //y2=1.77
cc_409 ( N_noxref_1_c_230_p N_noxref_49_M6_noxref_s ) capacitor c=0.0295256f \
 //x=10.92 //y=1.055 //x2=10.565 //y2=0.555
cc_410 ( N_noxref_1_c_233_p N_noxref_49_M6_noxref_s ) capacitor c=7.99997e-19 \
 //x=10.92 //y=1.71 //x2=10.565 //y2=0.555
cc_411 ( N_noxref_1_c_191_p N_noxref_49_M6_noxref_s ) capacitor c=0.00122123f \
 //x=10.92 //y=2.095 //x2=10.565 //y2=0.555
cc_412 ( N_noxref_1_c_232_p N_noxref_49_M6_noxref_s ) capacitor c=0.0125924f \
 //x=11.45 //y=1.055 //x2=10.565 //y2=0.555
cc_413 ( N_noxref_2_c_414_n N_noxref_3_c_794_n ) capacitor c=6.09703e-19 \
 //x=11.642 //y=5.335 //x2=8.59 //y2=5.56
cc_414 ( N_noxref_2_c_414_n N_noxref_3_c_795_n ) capacitor c=0.00306432f \
 //x=11.642 //y=5.335 //x2=9.285 //y2=5.335
cc_415 ( N_noxref_2_c_423_p N_noxref_3_c_796_n ) capacitor c=0.00163399f \
 //x=13.78 //y=1.845 //x2=9.285 //y2=1.845
cc_416 ( N_noxref_2_c_424_p N_noxref_3_c_741_n ) capacitor c=0.0232184f \
 //x=14.18 //y=5.25 //x2=20.675 //y2=3.51
cc_417 ( N_noxref_2_c_425_p N_noxref_3_c_741_n ) capacitor c=0.0246617f \
 //x=16.03 //y=4.755 //x2=20.675 //y2=3.51
cc_418 ( N_noxref_2_c_426_p N_noxref_3_c_741_n ) capacitor c=0.008565f \
 //x=15.88 //y=2.77 //x2=20.675 //y2=3.51
cc_419 ( N_noxref_2_c_427_p N_noxref_5_c_1480_n ) capacitor c=0.013767f \
 //x=14.18 //y=2.61 //x2=13.44 //y2=2.375
cc_420 ( N_noxref_2_c_427_p N_noxref_5_c_1475_n ) capacitor c=0.0086632f \
 //x=14.18 //y=2.61 //x2=13.44 //y2=3.735
cc_421 ( N_noxref_2_c_429_p N_noxref_5_c_1475_n ) capacitor c=0.0148501f \
 //x=14.18 //y=2.93 //x2=13.44 //y2=3.735
cc_422 ( N_noxref_2_c_424_p N_noxref_5_c_1475_n ) capacitor c=0.0317529f \
 //x=14.18 //y=5.25 //x2=13.44 //y2=3.735
cc_423 ( N_noxref_2_c_431_p N_noxref_5_c_1475_n ) capacitor c=4.40369e-19 \
 //x=16.03 //y=2.61 //x2=13.44 //y2=3.735
cc_424 ( N_noxref_2_c_425_p N_noxref_5_c_1475_n ) capacitor c=5.12503e-19 \
 //x=16.03 //y=4.755 //x2=13.44 //y2=3.735
cc_425 ( N_noxref_2_c_417_n N_noxref_5_c_1475_n ) capacitor c=5.64873e-19 \
 //x=14.18 //y=2.77 //x2=13.44 //y2=3.735
cc_426 ( N_noxref_2_c_434_p N_noxref_5_c_1475_n ) capacitor c=0.00687494f \
 //x=14.34 //y=2.77 //x2=13.44 //y2=3.735
cc_427 ( N_noxref_2_c_435_p N_noxref_5_c_1488_n ) capacitor c=0.00169109f \
 //x=13.285 //y=5.335 //x2=13.44 //y2=4.055
cc_428 ( N_noxref_2_c_436_p N_noxref_5_c_1488_n ) capacitor c=4.27841e-19 \
 //x=14.095 //y=5.335 //x2=13.44 //y2=4.055
cc_429 ( N_noxref_2_c_424_p N_noxref_5_c_1488_n ) capacitor c=0.0148932f \
 //x=14.18 //y=5.25 //x2=13.44 //y2=4.055
cc_430 ( N_noxref_2_c_436_p N_noxref_5_c_1477_n ) capacitor c=0.00228791f \
 //x=14.095 //y=5.335 //x2=13.44 //y2=4.75
cc_431 ( N_noxref_2_c_424_p N_noxref_5_c_1477_n ) capacitor c=0.0412079f \
 //x=14.18 //y=5.25 //x2=13.44 //y2=4.75
cc_432 ( N_noxref_2_c_425_p N_noxref_5_c_1477_n ) capacitor c=8.18246e-19 \
 //x=16.03 //y=4.755 //x2=13.44 //y2=4.75
cc_433 ( N_noxref_2_c_441_p N_noxref_5_c_1477_n ) capacitor c=0.0221235f \
 //x=13.4 //y=5.335 //x2=13.44 //y2=4.75
cc_434 ( N_noxref_2_c_442_p N_noxref_5_c_1477_n ) capacitor c=0.00217653f \
 //x=13.4 //y=5.56 //x2=13.44 //y2=4.75
cc_435 ( N_noxref_2_M80_noxref_g N_noxref_5_c_1496_n ) capacitor c=0.00893512f \
 //x=16.67 //y=6.2 //x2=17.21 //y2=5.335
cc_436 ( N_noxref_2_c_444_p N_noxref_5_c_1497_n ) capacitor c=0.00163399f \
 //x=14.095 //y=1.845 //x2=18.59 //y2=1.845
cc_437 ( N_noxref_2_c_424_p N_noxref_5_c_1498_n ) capacitor c=9.19401e-19 \
 //x=14.18 //y=5.25 //x2=13.44 //y2=3.88
cc_438 ( N_noxref_2_c_446_p N_noxref_5_c_1499_n ) capacitor c=6.09703e-19 \
 //x=13.4 //y=5.56 //x2=16.452 //y2=5.335
cc_439 ( N_noxref_2_c_436_p N_noxref_5_c_1499_n ) capacitor c=0.00306432f \
 //x=14.095 //y=5.335 //x2=16.452 //y2=5.335
cc_440 ( N_noxref_2_M79_noxref_g N_noxref_5_c_1499_n ) capacitor c=0.00461408f \
 //x=16.23 //y=6.2 //x2=16.452 //y2=5.335
cc_441 ( N_noxref_2_M80_noxref_g N_noxref_5_c_1499_n ) capacitor c=0.00229208f \
 //x=16.67 //y=6.2 //x2=16.452 //y2=5.335
cc_442 ( N_noxref_2_c_450_p N_noxref_5_c_1499_n ) capacitor c=0.00171885f \
 //x=16.595 //y=4.97 //x2=16.452 //y2=5.335
cc_443 ( N_noxref_2_c_424_p N_noxref_5_c_1504_n ) capacitor c=0.0229483f \
 //x=14.18 //y=5.25 //x2=18.82 //y2=3.88
cc_444 ( N_noxref_2_c_425_p N_noxref_5_c_1504_n ) capacitor c=0.024803f \
 //x=16.03 //y=4.755 //x2=18.82 //y2=3.88
cc_445 ( N_noxref_2_c_424_p N_noxref_5_c_1506_n ) capacitor c=0.00336755f \
 //x=14.18 //y=5.25 //x2=13.6 //y2=3.895
cc_446 ( N_noxref_2_c_427_p N_noxref_5_c_1507_n ) capacitor c=0.0015536f \
 //x=14.18 //y=2.61 //x2=13.44 //y2=2.26
cc_447 ( N_noxref_2_c_436_p N_noxref_5_c_1508_n ) capacitor c=0.00130631f \
 //x=14.095 //y=5.335 //x2=13.44 //y2=4.88
cc_448 ( N_noxref_2_c_424_p N_noxref_5_c_1508_n ) capacitor c=0.00131258f \
 //x=14.18 //y=5.25 //x2=13.44 //y2=4.88
cc_449 ( N_noxref_2_c_441_p N_noxref_5_c_1508_n ) capacitor c=0.00346456f \
 //x=13.4 //y=5.335 //x2=13.44 //y2=4.88
cc_450 ( N_noxref_2_c_442_p N_noxref_5_c_1508_n ) capacitor c=0.00624059f \
 //x=13.4 //y=5.56 //x2=13.44 //y2=4.88
cc_451 ( N_noxref_2_M79_noxref_g N_noxref_5_c_1512_n ) capacitor c=0.0162284f \
 //x=16.23 //y=6.2 //x2=16.45 //y2=5.56
cc_452 ( N_noxref_2_M80_noxref_g N_noxref_5_c_1512_n ) capacitor c=0.0179041f \
 //x=16.67 //y=6.2 //x2=16.45 //y2=5.56
cc_453 ( N_noxref_2_c_450_p N_noxref_5_c_1512_n ) capacitor c=0.00291477f \
 //x=16.595 //y=4.97 //x2=16.45 //y2=5.56
cc_454 ( N_noxref_2_c_435_p N_noxref_5_M77_noxref_g ) capacitor c=0.00952006f \
 //x=13.285 //y=5.335 //x2=13.18 //y2=6.2
cc_455 ( N_noxref_2_c_446_p N_noxref_5_M77_noxref_g ) capacitor c=0.00226521f \
 //x=13.4 //y=5.56 //x2=13.18 //y2=6.2
cc_456 ( N_noxref_2_c_442_p N_noxref_5_M77_noxref_g ) capacitor c=0.0178885f \
 //x=13.4 //y=5.56 //x2=13.18 //y2=6.2
cc_457 ( N_noxref_2_c_446_p N_noxref_5_M78_noxref_g ) capacitor c=0.00381703f \
 //x=13.4 //y=5.56 //x2=13.62 //y2=6.2
cc_458 ( N_noxref_2_c_436_p N_noxref_5_M78_noxref_g ) capacitor c=0.0108571f \
 //x=14.095 //y=5.335 //x2=13.62 //y2=6.2
cc_459 ( N_noxref_2_c_442_p N_noxref_5_M78_noxref_g ) capacitor c=0.0188608f \
 //x=13.4 //y=5.56 //x2=13.62 //y2=6.2
cc_460 ( N_noxref_2_c_468_p N_noxref_5_c_1521_n ) capacitor c=4.64015e-19 \
 //x=13.695 //y=1.305 //x2=13.43 //y2=1.095
cc_461 ( N_noxref_2_M8_noxref_d N_noxref_5_c_1521_n ) capacitor c=0.00137165f \
 //x=13.505 //y=1.095 //x2=13.43 //y2=1.095
cc_462 ( N_noxref_2_c_468_p N_noxref_5_c_1523_n ) capacitor c=0.0026012f \
 //x=13.695 //y=1.305 //x2=13.43 //y2=1.44
cc_463 ( N_noxref_2_c_471_p N_noxref_5_c_1523_n ) capacitor c=0.00127432f \
 //x=13.695 //y=1.76 //x2=13.43 //y2=1.44
cc_464 ( N_noxref_2_M8_noxref_d N_noxref_5_c_1523_n ) capacitor c=0.00237422f \
 //x=13.505 //y=1.095 //x2=13.43 //y2=1.44
cc_465 ( N_noxref_2_c_471_p N_noxref_5_c_1526_n ) capacitor c=0.00429966f \
 //x=13.695 //y=1.76 //x2=13.43 //y2=1.75
cc_466 ( N_noxref_2_c_468_p N_noxref_5_c_1527_n ) capacitor c=5.29969e-19 \
 //x=13.695 //y=1.305 //x2=13.805 //y2=0.94
cc_467 ( N_noxref_2_M8_noxref_d N_noxref_5_c_1527_n ) capacitor c=0.0020782f \
 //x=13.505 //y=1.095 //x2=13.805 //y2=0.94
cc_468 ( N_noxref_2_c_468_p N_noxref_5_c_1529_n ) capacitor c=5.32228e-19 \
 //x=13.695 //y=1.305 //x2=13.805 //y2=1.595
cc_469 ( N_noxref_2_c_471_p N_noxref_5_c_1529_n ) capacitor c=0.00942306f \
 //x=13.695 //y=1.76 //x2=13.805 //y2=1.595
cc_470 ( N_noxref_2_c_444_p N_noxref_5_c_1529_n ) capacitor c=0.00194716f \
 //x=14.095 //y=1.845 //x2=13.805 //y2=1.595
cc_471 ( N_noxref_2_M8_noxref_d N_noxref_5_c_1529_n ) capacitor c=0.00356097f \
 //x=13.505 //y=1.095 //x2=13.805 //y2=1.595
cc_472 ( N_noxref_2_c_468_p N_noxref_5_c_1533_n ) capacitor c=5.24634e-19 \
 //x=13.695 //y=1.305 //x2=13.96 //y2=1.095
cc_473 ( N_noxref_2_M8_noxref_d N_noxref_5_c_1533_n ) capacitor c=0.00139206f \
 //x=13.505 //y=1.095 //x2=13.96 //y2=1.095
cc_474 ( N_noxref_2_c_468_p N_noxref_5_c_1535_n ) capacitor c=0.00307978f \
 //x=13.695 //y=1.305 //x2=13.96 //y2=1.44
cc_475 ( N_noxref_2_c_471_p N_noxref_5_c_1535_n ) capacitor c=0.00363411f \
 //x=13.695 //y=1.76 //x2=13.96 //y2=1.44
cc_476 ( N_noxref_2_c_444_p N_noxref_5_c_1535_n ) capacitor c=0.00323576f \
 //x=14.095 //y=1.845 //x2=13.96 //y2=1.44
cc_477 ( N_noxref_2_M8_noxref_d N_noxref_5_c_1535_n ) capacitor c=0.00237422f \
 //x=13.505 //y=1.095 //x2=13.96 //y2=1.44
cc_478 ( N_noxref_2_c_427_p N_noxref_5_c_1539_n ) capacitor c=0.00244157f \
 //x=14.18 //y=2.61 //x2=13.44 //y2=2.26
cc_479 ( N_noxref_2_c_471_p N_noxref_5_c_1540_n ) capacitor c=0.0036273f \
 //x=13.695 //y=1.76 //x2=13.44 //y2=2.095
cc_480 ( N_noxref_2_c_427_p N_noxref_5_c_1540_n ) capacitor c=0.00282067f \
 //x=14.18 //y=2.61 //x2=13.44 //y2=2.095
cc_481 ( N_noxref_2_c_424_p N_noxref_5_c_1542_n ) capacitor c=0.00739875f \
 //x=14.18 //y=5.25 //x2=13.44 //y2=4.88
cc_482 ( N_noxref_2_c_441_p N_noxref_5_c_1542_n ) capacitor c=0.00203307f \
 //x=13.4 //y=5.335 //x2=13.44 //y2=4.88
cc_483 ( N_noxref_2_c_442_p N_noxref_5_c_1542_n ) capacitor c=0.00375636f \
 //x=13.4 //y=5.56 //x2=13.44 //y2=4.88
cc_484 ( N_noxref_2_c_424_p N_D_c_5125_n ) capacitor c=0.00234807f //x=14.18 \
 //y=5.25 //x2=13.655 //y2=4.31
cc_485 ( N_noxref_2_c_424_p N_D_c_5126_n ) capacitor c=0.022937f //x=14.18 \
 //y=5.25 //x2=18.595 //y2=4.25
cc_486 ( N_noxref_2_c_425_p N_D_c_5126_n ) capacitor c=0.0247757f //x=16.03 \
 //y=4.755 //x2=18.595 //y2=4.25
cc_487 ( N_noxref_2_c_427_p CLK ) capacitor c=3.32566e-19 //x=14.18 //y=2.61 \
 //x2=17.14 //y2=2.77
cc_488 ( N_noxref_2_c_424_p CLK ) capacitor c=0.00101179f //x=14.18 //y=5.25 \
 //x2=17.14 //y2=2.77
cc_489 ( N_noxref_2_c_431_p CLK ) capacitor c=0.00460058f //x=16.03 //y=2.61 \
 //x2=17.14 //y2=2.77
cc_490 ( N_noxref_2_c_498_p CLK ) capacitor c=0.00787446f //x=16.03 //y=2.93 \
 //x2=17.14 //y2=2.77
cc_491 ( N_noxref_2_c_425_p CLK ) capacitor c=0.0399611f //x=16.03 //y=4.755 \
 //x2=17.14 //y2=2.77
cc_492 ( N_noxref_2_c_500_p CLK ) capacitor c=2.90818e-19 //x=16.03 //y=2.77 \
 //x2=17.14 //y2=2.77
cc_493 ( N_noxref_2_c_501_p CLK ) capacitor c=0.00512134f //x=16.04 //y=2.77 \
 //x2=17.14 //y2=2.77
cc_494 ( N_noxref_2_c_502_p CLK ) capacitor c=3.9149e-19 //x=16.03 //y=2.26 \
 //x2=17.14 //y2=2.77
cc_495 ( N_noxref_2_c_503_p N_CLK_c_6461_n ) capacitor c=0.00898333f //x=16.03 \
 //y=2.375 //x2=17.14 //y2=2.375
cc_496 ( N_noxref_2_c_502_p N_CLK_c_6461_n ) capacitor c=5.40058e-19 //x=16.03 \
 //y=2.26 //x2=17.14 //y2=2.375
cc_497 ( N_noxref_2_c_505_p N_CLK_c_6461_n ) capacitor c=0.00142893f //x=15.73 \
 //y=2.095 //x2=17.14 //y2=2.375
cc_498 ( N_noxref_2_c_425_p N_CLK_c_6464_n ) capacitor c=0.00876228f //x=16.03 \
 //y=4.755 //x2=17.145 //y2=4.835
cc_499 ( N_noxref_2_c_507_p N_CLK_c_6464_n ) capacitor c=6.25125e-19 //x=16.03 \
 //y=4.88 //x2=17.145 //y2=4.835
cc_500 ( N_noxref_2_c_450_p N_CLK_c_6464_n ) capacitor c=7.07965e-19 \
 //x=16.595 //y=4.97 //x2=17.145 //y2=4.835
cc_501 ( N_noxref_2_c_509_p N_CLK_c_6464_n ) capacitor c=8.59438e-19 \
 //x=16.305 //y=4.97 //x2=17.145 //y2=4.835
cc_502 ( N_noxref_2_c_436_p N_CLK_c_6426_n ) capacitor c=0.0218009f //x=14.095 \
 //y=5.335 //x2=16.985 //y2=4.62
cc_503 ( N_noxref_2_c_424_p N_CLK_c_6426_n ) capacitor c=0.0300565f //x=14.18 \
 //y=5.25 //x2=16.985 //y2=4.62
cc_504 ( N_noxref_2_c_425_p N_CLK_c_6426_n ) capacitor c=0.0329753f //x=16.03 \
 //y=4.755 //x2=16.985 //y2=4.62
cc_505 ( N_noxref_2_c_414_n N_CLK_c_6426_n ) capacitor c=0.0296692f //x=11.642 \
 //y=5.335 //x2=16.985 //y2=4.62
cc_506 ( N_noxref_2_c_514_p N_CLK_c_6426_n ) capacitor c=0.0373783f //x=12.52 \
 //y=5.335 //x2=16.985 //y2=4.62
cc_507 ( N_noxref_2_c_425_p N_CLK_c_6473_n ) capacitor c=0.00655873f //x=16.03 \
 //y=4.755 //x2=28.395 //y2=4.61
cc_508 ( N_noxref_2_c_503_p N_CLK_c_6474_n ) capacitor c=5.39999e-19 //x=16.03 \
 //y=2.375 //x2=17.14 //y2=2.26
cc_509 ( N_noxref_2_c_431_p N_CLK_c_6474_n ) capacitor c=3.9149e-19 //x=16.03 \
 //y=2.61 //x2=17.14 //y2=2.26
cc_510 ( N_noxref_2_c_502_p N_CLK_c_6474_n ) capacitor c=0.00125213f //x=16.03 \
 //y=2.26 //x2=17.14 //y2=2.26
cc_511 ( N_noxref_2_c_505_p N_CLK_c_6474_n ) capacitor c=0.00214573f //x=15.73 \
 //y=2.095 //x2=17.14 //y2=2.26
cc_512 ( N_noxref_2_c_425_p N_CLK_c_6478_n ) capacitor c=5.64453e-19 //x=16.03 \
 //y=4.755 //x2=17.14 //y2=4.88
cc_513 ( N_noxref_2_c_507_p N_CLK_c_6478_n ) capacitor c=0.00113671f //x=16.03 \
 //y=4.88 //x2=17.14 //y2=4.88
cc_514 ( N_noxref_2_c_450_p N_CLK_c_6478_n ) capacitor c=0.00116563f \
 //x=16.595 //y=4.97 //x2=17.14 //y2=4.88
cc_515 ( N_noxref_2_c_509_p N_CLK_c_6478_n ) capacitor c=0.0012974f //x=16.305 \
 //y=4.97 //x2=17.14 //y2=4.88
cc_516 ( N_noxref_2_M79_noxref_g N_CLK_M81_noxref_g ) capacitor c=0.0106276f \
 //x=16.23 //y=6.2 //x2=17.11 //y2=6.2
cc_517 ( N_noxref_2_M80_noxref_g N_CLK_M81_noxref_g ) capacitor c=0.107144f \
 //x=16.67 //y=6.2 //x2=17.11 //y2=6.2
cc_518 ( N_noxref_2_M80_noxref_g N_CLK_M82_noxref_g ) capacitor c=0.0101598f \
 //x=16.67 //y=6.2 //x2=17.55 //y2=6.2
cc_519 ( N_noxref_2_c_527_p N_CLK_c_6485_n ) capacitor c=5.72528e-19 //x=15.73 \
 //y=1.055 //x2=16.705 //y2=1.09
cc_520 ( N_noxref_2_c_528_p N_CLK_c_6485_n ) capacitor c=0.00150277f //x=15.73 \
 //y=1.4 //x2=16.705 //y2=1.09
cc_521 ( N_noxref_2_c_529_p N_CLK_c_6485_n ) capacitor c=0.0160123f //x=16.26 \
 //y=1.055 //x2=16.705 //y2=1.09
cc_522 ( N_noxref_2_c_530_p N_CLK_c_6488_n ) capacitor c=0.00111227f //x=15.73 \
 //y=1.71 //x2=16.705 //y2=1.4
cc_523 ( N_noxref_2_c_531_p N_CLK_c_6488_n ) capacitor c=0.0124075f //x=16.26 \
 //y=1.4 //x2=16.705 //y2=1.4
cc_524 ( N_noxref_2_c_529_p N_CLK_c_6490_n ) capacitor c=9.19165e-19 //x=16.26 \
 //y=1.055 //x2=17.23 //y2=1.09
cc_525 ( N_noxref_2_c_531_p N_CLK_c_6491_n ) capacitor c=0.0010154f //x=16.26 \
 //y=1.4 //x2=17.23 //y2=1.4
cc_526 ( N_noxref_2_c_531_p N_CLK_c_6492_n ) capacitor c=9.23422e-19 //x=16.26 \
 //y=1.4 //x2=17.23 //y2=1.63
cc_527 ( N_noxref_2_c_503_p N_CLK_c_6493_n ) capacitor c=0.0013537f //x=16.03 \
 //y=2.375 //x2=17.23 //y2=2.095
cc_528 ( N_noxref_2_c_502_p N_CLK_c_6493_n ) capacitor c=0.0020754f //x=16.03 \
 //y=2.26 //x2=17.23 //y2=2.095
cc_529 ( N_noxref_2_c_505_p N_CLK_c_6493_n ) capacitor c=0.00964411f //x=15.73 \
 //y=2.095 //x2=17.23 //y2=2.095
cc_530 ( N_noxref_2_c_507_p N_CLK_c_6496_n ) capacitor c=0.00123917f //x=16.03 \
 //y=4.88 //x2=17.14 //y2=4.88
cc_531 ( N_noxref_2_c_450_p N_CLK_c_6496_n ) capacitor c=0.0169508f //x=16.595 \
 //y=4.97 //x2=17.14 //y2=4.88
cc_532 ( N_noxref_2_c_509_p N_CLK_c_6496_n ) capacitor c=0.00406071f \
 //x=16.305 //y=4.97 //x2=17.14 //y2=4.88
cc_533 ( N_noxref_2_c_425_p RN ) capacitor c=0.00134736f //x=16.03 //y=4.755 \
 //x2=18.25 //y2=2.77
cc_534 ( N_noxref_2_c_468_p N_RN_c_7855_n ) capacitor c=7.09906e-19 //x=13.695 \
 //y=1.305 //x2=13.795 //y2=2.4
cc_535 ( N_noxref_2_c_444_p N_RN_c_7855_n ) capacitor c=0.00861999f //x=14.095 \
 //y=1.845 //x2=13.795 //y2=2.4
cc_536 ( N_noxref_2_c_423_p N_RN_c_7855_n ) capacitor c=0.0125707f //x=13.78 \
 //y=1.845 //x2=13.795 //y2=2.4
cc_537 ( N_noxref_2_c_427_p N_RN_c_7855_n ) capacitor c=3.12067e-19 //x=14.18 \
 //y=2.61 //x2=13.795 //y2=2.4
cc_538 ( N_noxref_2_c_427_p N_RN_c_7890_n ) capacitor c=0.0272405f //x=14.18 \
 //y=2.61 //x2=14.395 //y2=2.385
cc_539 ( N_noxref_2_c_429_p N_RN_c_7890_n ) capacitor c=0.00570792f //x=14.18 \
 //y=2.93 //x2=14.395 //y2=2.385
cc_540 ( N_noxref_2_c_426_p N_RN_c_7890_n ) capacitor c=0.133465f //x=15.88 \
 //y=2.77 //x2=14.395 //y2=2.385
cc_541 ( N_noxref_2_c_434_p N_RN_c_7890_n ) capacitor c=0.0365231f //x=14.34 \
 //y=2.77 //x2=14.395 //y2=2.385
cc_542 ( N_noxref_2_c_431_p N_RN_c_7894_n ) capacitor c=5.11045e-19 //x=16.03 \
 //y=2.61 //x2=15.655 //y2=2.4
cc_543 ( N_noxref_2_c_498_p N_RN_c_7894_n ) capacitor c=0.00348052f //x=16.03 \
 //y=2.93 //x2=15.655 //y2=2.4
cc_544 ( N_noxref_2_c_426_p N_RN_c_7894_n ) capacitor c=0.0109101f //x=15.88 \
 //y=2.77 //x2=15.655 //y2=2.4
cc_545 ( N_noxref_2_c_503_p N_RN_c_7897_n ) capacitor c=0.0168589f //x=16.03 \
 //y=2.375 //x2=16.255 //y2=2.385
cc_546 ( N_noxref_2_c_431_p N_RN_c_7897_n ) capacitor c=0.012163f //x=16.03 \
 //y=2.61 //x2=16.255 //y2=2.385
cc_547 ( N_noxref_2_c_498_p N_RN_c_7897_n ) capacitor c=0.00478203f //x=16.03 \
 //y=2.93 //x2=16.255 //y2=2.385
cc_548 ( N_noxref_2_c_501_p N_RN_c_7897_n ) capacitor c=0.0370412f //x=16.04 \
 //y=2.77 //x2=16.255 //y2=2.385
cc_549 ( N_noxref_2_c_502_p N_RN_c_7897_n ) capacitor c=5.18204e-19 //x=16.03 \
 //y=2.26 //x2=16.255 //y2=2.385
cc_550 ( N_noxref_2_c_505_p N_RN_c_7897_n ) capacitor c=3.41298e-19 //x=15.73 \
 //y=2.095 //x2=16.255 //y2=2.385
cc_551 ( N_noxref_2_c_431_p N_RN_c_7903_n ) capacitor c=3.71593e-19 //x=16.03 \
 //y=2.61 //x2=18.415 //y2=2.4
cc_552 ( N_noxref_2_c_427_p SN ) capacitor c=3.42202e-19 //x=14.18 //y=2.61 \
 //x2=12.33 //y2=2.77
cc_553 ( N_noxref_2_c_413_n N_SN_c_9844_n ) capacitor c=4.73573e-19 //x=12.4 \
 //y=5.335 //x2=12.33 //y2=3.285
cc_554 ( N_noxref_2_c_514_p N_SN_c_9844_n ) capacitor c=0.00141981f //x=12.52 \
 //y=5.335 //x2=12.33 //y2=3.285
cc_555 ( N_noxref_2_c_563_p N_SN_c_9844_n ) capacitor c=4.8301e-19 //x=12.52 \
 //y=5.56 //x2=12.33 //y2=3.285
cc_556 ( N_noxref_2_c_413_n N_SN_c_9845_n ) capacitor c=0.0213631f //x=12.4 \
 //y=5.335 //x2=12.33 //y2=4.765
cc_557 ( N_noxref_2_c_424_p N_SN_c_9845_n ) capacitor c=0.00188783f //x=14.18 \
 //y=5.25 //x2=12.33 //y2=4.765
cc_558 ( N_noxref_2_c_514_p N_SN_c_9845_n ) capacitor c=0.00239361f //x=12.52 \
 //y=5.335 //x2=12.33 //y2=4.765
cc_559 ( N_noxref_2_c_563_p N_SN_c_9845_n ) capacitor c=6.21282e-19 //x=12.52 \
 //y=5.56 //x2=12.33 //y2=4.765
cc_560 ( N_noxref_2_c_429_p N_SN_c_9884_n ) capacitor c=0.00153128f //x=14.18 \
 //y=2.93 //x2=13.795 //y2=3.14
cc_561 ( N_noxref_2_c_424_p N_SN_c_9884_n ) capacitor c=3.29006e-19 //x=14.18 \
 //y=5.25 //x2=13.795 //y2=3.14
cc_562 ( N_noxref_2_c_434_p N_SN_c_9884_n ) capacitor c=0.0358254f //x=14.34 \
 //y=2.77 //x2=13.795 //y2=3.14
cc_563 ( N_noxref_2_c_429_p N_SN_c_9887_n ) capacitor c=0.0102778f //x=14.18 \
 //y=2.93 //x2=14.395 //y2=3.155
cc_564 ( N_noxref_2_c_424_p N_SN_c_9887_n ) capacitor c=0.0226563f //x=14.18 \
 //y=5.25 //x2=14.395 //y2=3.155
cc_565 ( N_noxref_2_c_426_p N_SN_c_9887_n ) capacitor c=0.128848f //x=15.88 \
 //y=2.77 //x2=14.395 //y2=3.155
cc_566 ( N_noxref_2_c_498_p N_SN_c_9890_n ) capacitor c=0.00511674f //x=16.03 \
 //y=2.93 //x2=15.655 //y2=3.14
cc_567 ( N_noxref_2_c_425_p N_SN_c_9890_n ) capacitor c=5.11045e-19 //x=16.03 \
 //y=4.755 //x2=15.655 //y2=3.14
cc_568 ( N_noxref_2_c_426_p N_SN_c_9890_n ) capacitor c=0.0107306f //x=15.88 \
 //y=2.77 //x2=15.655 //y2=3.14
cc_569 ( N_noxref_2_c_501_p N_SN_c_9890_n ) capacitor c=0.0358254f //x=16.04 \
 //y=2.77 //x2=15.655 //y2=3.14
cc_570 ( N_noxref_2_c_498_p N_SN_c_9894_n ) capacitor c=0.00397194f //x=16.03 \
 //y=2.93 //x2=16.255 //y2=3.155
cc_571 ( N_noxref_2_c_425_p N_SN_c_9894_n ) capacitor c=0.023934f //x=16.03 \
 //y=4.755 //x2=16.255 //y2=3.155
cc_572 ( N_noxref_2_c_413_n N_SN_c_9854_n ) capacitor c=0.00492634f //x=12.4 \
 //y=5.335 //x2=12.33 //y2=4.88
cc_573 ( N_noxref_2_c_514_p N_SN_c_9854_n ) capacitor c=0.00132214f //x=12.52 \
 //y=5.335 //x2=12.33 //y2=4.88
cc_574 ( N_noxref_2_c_413_n N_SN_M75_noxref_g ) capacitor c=0.00858241f \
 //x=12.4 //y=5.335 //x2=12.3 //y2=6.2
cc_575 ( N_noxref_2_c_514_p N_SN_M75_noxref_g ) capacitor c=0.00229818f \
 //x=12.52 //y=5.335 //x2=12.3 //y2=6.2
cc_576 ( N_noxref_2_c_563_p N_SN_M75_noxref_g ) capacitor c=0.0179041f \
 //x=12.52 //y=5.56 //x2=12.3 //y2=6.2
cc_577 ( N_noxref_2_c_435_p N_SN_M76_noxref_g ) capacitor c=0.00955829f \
 //x=13.285 //y=5.335 //x2=12.74 //y2=6.2
cc_578 ( N_noxref_2_c_514_p N_SN_M76_noxref_g ) capacitor c=0.00230699f \
 //x=12.52 //y=5.335 //x2=12.74 //y2=6.2
cc_579 ( N_noxref_2_c_563_p N_SN_M76_noxref_g ) capacitor c=0.0179041f \
 //x=12.52 //y=5.56 //x2=12.74 //y2=6.2
cc_580 ( N_noxref_2_c_514_p N_SN_c_9904_n ) capacitor c=0.00201022f //x=12.52 \
 //y=5.335 //x2=12.665 //y2=4.97
cc_581 ( N_noxref_2_c_563_p N_SN_c_9904_n ) capacitor c=0.00290085f //x=12.52 \
 //y=5.56 //x2=12.665 //y2=4.97
cc_582 ( N_noxref_2_c_413_n N_SN_c_9872_n ) capacitor c=5.877e-19 //x=12.4 \
 //y=5.335 //x2=12.33 //y2=4.88
cc_583 ( N_noxref_2_c_413_n N_VDD_c_13434_n ) capacitor c=0.00621353f //x=12.4 \
 //y=5.335 //x2=87.775 //y2=7.585
cc_584 ( N_noxref_2_c_435_p N_VDD_c_13434_n ) capacitor c=0.00627186f \
 //x=13.285 //y=5.335 //x2=87.775 //y2=7.585
cc_585 ( N_noxref_2_c_446_p N_VDD_c_13434_n ) capacitor c=0.00256019f //x=13.4 \
 //y=5.56 //x2=87.775 //y2=7.585
cc_586 ( N_noxref_2_c_436_p N_VDD_c_13434_n ) capacitor c=0.00824067f \
 //x=14.095 //y=5.335 //x2=87.775 //y2=7.585
cc_587 ( N_noxref_2_c_414_n N_VDD_c_13434_n ) capacitor c=0.00261804f \
 //x=11.642 //y=5.335 //x2=87.775 //y2=7.585
cc_588 ( N_noxref_2_c_514_p N_VDD_c_13434_n ) capacitor c=0.00270108f \
 //x=12.52 //y=5.335 //x2=87.775 //y2=7.585
cc_589 ( N_noxref_2_c_418_n N_VDD_c_13434_n ) capacitor c=0.0024232f //x=11.64 \
 //y=5.56 //x2=87.775 //y2=7.585
cc_590 ( N_noxref_2_c_563_p N_VDD_c_13434_n ) capacitor c=0.0024232f //x=12.52 \
 //y=5.56 //x2=87.775 //y2=7.585
cc_591 ( N_noxref_2_c_442_p N_VDD_c_13434_n ) capacitor c=0.0024232f //x=13.4 \
 //y=5.56 //x2=87.775 //y2=7.585
cc_592 ( N_noxref_2_c_413_n N_VDD_c_13459_n ) capacitor c=0.00202922f //x=12.4 \
 //y=5.335 //x2=11.995 //y2=7.585
cc_593 ( N_noxref_2_c_414_n N_VDD_c_13459_n ) capacitor c=9.3757e-19 \
 //x=11.642 //y=5.335 //x2=11.995 //y2=7.585
cc_594 ( N_noxref_2_c_418_n N_VDD_c_13459_n ) capacitor c=0.0138074f //x=11.64 \
 //y=5.56 //x2=11.995 //y2=7.585
cc_595 ( N_noxref_2_c_413_n N_VDD_c_13508_n ) capacitor c=0.0017708f //x=12.4 \
 //y=5.335 //x2=12.875 //y2=7.585
cc_596 ( N_noxref_2_c_435_p N_VDD_c_13508_n ) capacitor c=0.00202922f \
 //x=13.285 //y=5.335 //x2=12.875 //y2=7.585
cc_597 ( N_noxref_2_c_514_p N_VDD_c_13508_n ) capacitor c=9.4822e-19 //x=12.52 \
 //y=5.335 //x2=12.875 //y2=7.585
cc_598 ( N_noxref_2_c_563_p N_VDD_c_13508_n ) capacitor c=0.0138074f //x=12.52 \
 //y=5.56 //x2=12.875 //y2=7.585
cc_599 ( N_noxref_2_c_435_p N_VDD_c_13512_n ) capacitor c=0.00205906f \
 //x=13.285 //y=5.335 //x2=13.755 //y2=7.585
cc_600 ( N_noxref_2_c_446_p N_VDD_c_13512_n ) capacitor c=8.49654e-19 //x=13.4 \
 //y=5.56 //x2=13.755 //y2=7.585
cc_601 ( N_noxref_2_c_436_p N_VDD_c_13512_n ) capacitor c=0.00204238f \
 //x=14.095 //y=5.335 //x2=13.755 //y2=7.585
cc_602 ( N_noxref_2_c_442_p N_VDD_c_13512_n ) capacitor c=0.0135103f //x=13.4 \
 //y=5.56 //x2=13.755 //y2=7.585
cc_603 ( N_noxref_2_c_436_p N_VDD_c_13516_n ) capacitor c=0.00183742f \
 //x=14.095 //y=5.335 //x2=14.75 //y2=7.585
cc_604 ( N_noxref_2_M79_noxref_g N_VDD_c_13517_n ) capacitor c=0.00755614f \
 //x=16.23 //y=6.2 //x2=16.805 //y2=7.585
cc_605 ( N_noxref_2_M80_noxref_g N_VDD_c_13517_n ) capacitor c=0.00755544f \
 //x=16.67 //y=6.2 //x2=16.805 //y2=7.585
cc_606 ( N_noxref_2_c_414_n N_VDD_c_13467_n ) capacitor c=0.0022955f \
 //x=11.642 //y=5.335 //x2=10.11 //y2=7.585
cc_607 ( N_noxref_2_c_418_n N_VDD_c_13467_n ) capacitor c=0.00509469f \
 //x=11.64 //y=5.56 //x2=10.11 //y2=7.585
cc_608 ( N_noxref_2_c_446_p N_VDD_c_13521_n ) capacitor c=0.00282782f //x=13.4 \
 //y=5.56 //x2=14.92 //y2=7.585
cc_609 ( N_noxref_2_c_424_p N_VDD_c_13521_n ) capacitor c=0.0327878f //x=14.18 \
 //y=5.25 //x2=14.92 //y2=7.585
cc_610 ( N_noxref_2_c_425_p N_VDD_c_13521_n ) capacitor c=0.0122712f //x=16.03 \
 //y=4.755 //x2=14.92 //y2=7.585
cc_611 ( N_noxref_2_c_442_p N_VDD_c_13521_n ) capacitor c=0.00777981f //x=13.4 \
 //y=5.56 //x2=14.92 //y2=7.585
cc_612 ( N_noxref_2_c_507_p N_VDD_c_13521_n ) capacitor c=0.00370784f \
 //x=16.03 //y=4.88 //x2=14.92 //y2=7.585
cc_613 ( N_noxref_2_c_509_p N_VDD_c_13521_n ) capacitor c=0.00590568f \
 //x=16.305 //y=4.97 //x2=14.92 //y2=7.585
cc_614 ( N_noxref_2_c_414_n N_VDD_M73_noxref_s ) capacitor c=0.0442713f \
 //x=11.642 //y=5.335 //x2=11.065 //y2=5.2
cc_615 ( N_noxref_2_c_514_p N_VDD_M73_noxref_s ) capacitor c=7.80122e-19 \
 //x=12.52 //y=5.335 //x2=11.065 //y2=5.2
cc_616 ( N_noxref_2_c_418_n N_VDD_M73_noxref_s ) capacitor c=0.09305f \
 //x=11.64 //y=5.56 //x2=11.065 //y2=5.2
cc_617 ( N_noxref_2_c_413_n N_VDD_M74_noxref_d ) capacitor c=0.00700141f \
 //x=12.4 //y=5.335 //x2=11.935 //y2=5.2
cc_618 ( N_noxref_2_c_418_n N_VDD_M74_noxref_d ) capacitor c=0.0674491f \
 //x=11.64 //y=5.56 //x2=11.935 //y2=5.2
cc_619 ( N_noxref_2_c_563_p N_VDD_M74_noxref_d ) capacitor c=0.0674762f \
 //x=12.52 //y=5.56 //x2=11.935 //y2=5.2
cc_620 ( N_noxref_2_c_435_p N_VDD_M76_noxref_d ) capacitor c=0.00700141f \
 //x=13.285 //y=5.335 //x2=12.815 //y2=5.2
cc_621 ( N_noxref_2_c_563_p N_VDD_M76_noxref_d ) capacitor c=0.067493f \
 //x=12.52 //y=5.56 //x2=12.815 //y2=5.2
cc_622 ( N_noxref_2_c_442_p N_VDD_M76_noxref_d ) capacitor c=0.0674979f \
 //x=13.4 //y=5.56 //x2=12.815 //y2=5.2
cc_623 ( N_noxref_2_c_436_p N_VDD_M78_noxref_d ) capacitor c=0.00700141f \
 //x=14.095 //y=5.335 //x2=13.695 //y2=5.2
cc_624 ( N_noxref_2_c_442_p N_VDD_M78_noxref_d ) capacitor c=0.0675002f \
 //x=13.4 //y=5.56 //x2=13.695 //y2=5.2
cc_625 ( N_noxref_2_c_446_p N_VDD_M79_noxref_s ) capacitor c=0.00492616f \
 //x=13.4 //y=5.56 //x2=15.875 //y2=5.2
cc_626 ( N_noxref_2_c_436_p N_VDD_M79_noxref_s ) capacitor c=9.42705e-19 \
 //x=14.095 //y=5.335 //x2=15.875 //y2=5.2
cc_627 ( N_noxref_2_c_498_p N_VDD_M79_noxref_s ) capacitor c=4.32734e-19 \
 //x=16.03 //y=2.93 //x2=15.875 //y2=5.2
cc_628 ( N_noxref_2_c_425_p N_VDD_M79_noxref_s ) capacitor c=0.0217981f \
 //x=16.03 //y=4.755 //x2=15.875 //y2=5.2
cc_629 ( N_noxref_2_c_514_p N_VDD_M79_noxref_s ) capacitor c=2.11884e-19 \
 //x=12.52 //y=5.335 //x2=15.875 //y2=5.2
cc_630 ( N_noxref_2_c_507_p N_VDD_M79_noxref_s ) capacitor c=0.00983846f \
 //x=16.03 //y=4.88 //x2=15.875 //y2=5.2
cc_631 ( N_noxref_2_M79_noxref_g N_VDD_M79_noxref_s ) capacitor c=0.053419f \
 //x=16.23 //y=6.2 //x2=15.875 //y2=5.2
cc_632 ( N_noxref_2_c_509_p N_VDD_M79_noxref_s ) capacitor c=0.00608913f \
 //x=16.305 //y=4.97 //x2=15.875 //y2=5.2
cc_633 ( N_noxref_2_M80_noxref_g N_VDD_M80_noxref_d ) capacitor c=0.015318f \
 //x=16.67 //y=6.2 //x2=16.745 //y2=5.2
cc_634 ( N_noxref_2_c_468_p N_noxref_28_c_15014_n ) capacitor c=0.0036878f \
 //x=13.695 //y=1.305 //x2=14.095 //y2=0.72
cc_635 ( N_noxref_2_c_444_p N_noxref_28_c_15014_n ) capacitor c=0.00399931f \
 //x=14.095 //y=1.845 //x2=14.095 //y2=0.72
cc_636 ( N_noxref_2_M8_noxref_d N_noxref_28_c_15014_n ) capacitor \
 c=0.00910163f //x=13.505 //y=1.095 //x2=14.095 //y2=0.72
cc_637 ( N_noxref_2_M8_noxref_d N_noxref_28_c_15017_n ) capacitor \
 c=0.00120711f //x=13.505 //y=1.095 //x2=13.21 //y2=1.175
cc_638 ( N_noxref_2_c_413_n N_noxref_28_M7_noxref_d ) capacitor c=0.00135164f \
 //x=12.4 //y=5.335 //x2=11.97 //y2=1.09
cc_639 ( N_noxref_2_c_468_p N_noxref_28_M7_noxref_d ) capacitor c=0.00802417f \
 //x=13.695 //y=1.305 //x2=11.97 //y2=1.09
cc_640 ( N_noxref_2_c_468_p N_noxref_28_M8_noxref_s ) capacitor c=0.0098487f \
 //x=13.695 //y=1.305 //x2=13.075 //y2=0.555
cc_641 ( N_noxref_2_c_471_p N_noxref_28_M8_noxref_s ) capacitor c=0.0283243f \
 //x=13.695 //y=1.76 //x2=13.075 //y2=0.555
cc_642 ( N_noxref_2_c_444_p N_noxref_28_M8_noxref_s ) capacitor c=0.00752108f \
 //x=14.095 //y=1.845 //x2=13.075 //y2=0.555
cc_643 ( N_noxref_2_c_417_n N_noxref_28_M8_noxref_s ) capacitor c=0.00309975f \
 //x=14.18 //y=2.77 //x2=13.075 //y2=0.555
cc_644 ( N_noxref_2_M8_noxref_d N_noxref_28_M8_noxref_s ) capacitor \
 c=0.0279003f //x=13.505 //y=1.095 //x2=13.075 //y2=0.555
cc_645 ( N_noxref_2_c_468_p N_noxref_29_M10_noxref_d ) capacitor c=3.20746e-19 \
 //x=13.695 //y=1.305 //x2=16.78 //y2=1.09
cc_646 ( N_noxref_2_c_468_p N_GND_c_16460_n ) capacitor c=0.00884249f \
 //x=13.695 //y=1.305 //x2=15.91 //y2=0.175
cc_647 ( N_noxref_2_c_444_p N_GND_c_16460_n ) capacitor c=0.00662553f \
 //x=14.095 //y=1.845 //x2=15.91 //y2=0.175
cc_648 ( N_noxref_2_c_429_p N_GND_c_16460_n ) capacitor c=4.31179e-19 \
 //x=14.18 //y=2.93 //x2=15.91 //y2=0.175
cc_649 ( N_noxref_2_M8_noxref_d N_GND_c_16460_n ) capacitor c=2.9462e-19 \
 //x=13.505 //y=1.095 //x2=15.91 //y2=0.175
cc_650 ( N_noxref_2_c_527_p N_GND_c_16464_n ) capacitor c=3.97665e-19 \
 //x=15.73 //y=1.055 //x2=15.995 //y2=1.015
cc_651 ( N_noxref_2_c_659_p N_GND_c_16464_n ) capacitor c=0.00864776f \
 //x=16.105 //y=0.9 //x2=15.995 //y2=1.015
cc_652 ( N_noxref_2_c_529_p N_GND_c_16464_n ) capacitor c=4.45447e-19 \
 //x=16.26 //y=1.055 //x2=15.995 //y2=1.015
cc_653 ( N_noxref_2_c_468_p N_GND_c_16467_n ) capacitor c=0.00543195f \
 //x=13.695 //y=1.305 //x2=15.995 //y2=1.145
cc_654 ( N_noxref_2_c_503_p N_GND_c_16467_n ) capacitor c=0.00771144f \
 //x=16.03 //y=2.375 //x2=15.995 //y2=1.145
cc_655 ( N_noxref_2_c_498_p N_GND_c_16467_n ) capacitor c=0.0011623f //x=16.03 \
 //y=2.93 //x2=15.995 //y2=1.145
cc_656 ( N_noxref_2_c_502_p N_GND_c_16467_n ) capacitor c=2.22883e-19 \
 //x=16.03 //y=2.26 //x2=15.995 //y2=1.145
cc_657 ( N_noxref_2_c_527_p N_GND_c_16467_n ) capacitor c=0.00156339f \
 //x=15.73 //y=1.055 //x2=15.995 //y2=1.145
cc_658 ( N_noxref_2_c_528_p N_GND_c_16467_n ) capacitor c=0.00352472f \
 //x=15.73 //y=1.4 //x2=15.995 //y2=1.145
cc_659 ( N_noxref_2_c_530_p N_GND_c_16467_n ) capacitor c=3.88232e-19 \
 //x=15.73 //y=1.71 //x2=15.995 //y2=1.145
cc_660 ( N_noxref_2_c_659_p N_GND_c_16467_n ) capacitor c=9.36995e-19 \
 //x=16.105 //y=0.9 //x2=15.995 //y2=1.145
cc_661 ( N_noxref_2_c_669_p N_GND_c_16467_n ) capacitor c=5.27793e-19 \
 //x=16.105 //y=1.555 //x2=15.995 //y2=1.145
cc_662 ( N_noxref_2_c_529_p N_GND_c_16467_n ) capacitor c=0.0017438f //x=16.26 \
 //y=1.055 //x2=15.995 //y2=1.145
cc_663 ( N_noxref_2_c_531_p N_GND_c_16467_n ) capacitor c=0.00276804f \
 //x=16.26 //y=1.4 //x2=15.995 //y2=1.145
cc_664 ( N_noxref_2_c_444_p N_GND_c_16424_n ) capacitor c=6.86343e-19 \
 //x=14.095 //y=1.845 //x2=14.75 //y2=0.175
cc_665 ( N_noxref_2_c_429_p N_GND_c_16424_n ) capacitor c=6.02672e-19 \
 //x=14.18 //y=2.93 //x2=14.75 //y2=0.175
cc_666 ( N_noxref_2_c_527_p N_GND_c_16480_n ) capacitor c=0.00678016f \
 //x=15.73 //y=1.055 //x2=19.56 //y2=0.175
cc_667 ( N_noxref_2_c_471_p N_GND_c_16481_n ) capacitor c=0.0045138f \
 //x=13.695 //y=1.76 //x2=14.92 //y2=0.175
cc_668 ( N_noxref_2_c_444_p N_GND_c_16481_n ) capacitor c=0.0233604f \
 //x=14.095 //y=1.845 //x2=14.92 //y2=0.175
cc_669 ( N_noxref_2_c_429_p N_GND_c_16481_n ) capacitor c=0.00422913f \
 //x=14.18 //y=2.93 //x2=14.92 //y2=0.175
cc_670 ( N_noxref_2_c_503_p N_GND_c_16481_n ) capacitor c=0.003423f //x=16.03 \
 //y=2.375 //x2=14.92 //y2=0.175
cc_671 ( N_noxref_2_c_431_p N_GND_c_16481_n ) capacitor c=0.0036684f //x=16.03 \
 //y=2.61 //x2=14.92 //y2=0.175
cc_672 ( N_noxref_2_c_498_p N_GND_c_16481_n ) capacitor c=0.00305356f \
 //x=16.03 //y=2.93 //x2=14.92 //y2=0.175
cc_673 ( N_noxref_2_c_417_n N_GND_c_16481_n ) capacitor c=0.0103933f //x=14.18 \
 //y=2.77 //x2=14.92 //y2=0.175
cc_674 ( N_noxref_2_c_500_p N_GND_c_16481_n ) capacitor c=0.00527139f \
 //x=16.03 //y=2.77 //x2=14.92 //y2=0.175
cc_675 ( N_noxref_2_c_426_p N_GND_c_16481_n ) capacitor c=0.00947774f \
 //x=15.88 //y=2.77 //x2=14.92 //y2=0.175
cc_676 ( N_noxref_2_c_502_p N_GND_c_16481_n ) capacitor c=0.0039621f //x=16.03 \
 //y=2.26 //x2=14.92 //y2=0.175
cc_677 ( N_noxref_2_c_530_p N_GND_c_16481_n ) capacitor c=0.00170145f \
 //x=15.73 //y=1.71 //x2=14.92 //y2=0.175
cc_678 ( N_noxref_2_c_505_p N_GND_c_16481_n ) capacitor c=0.0102191f //x=15.73 \
 //y=2.095 //x2=14.92 //y2=0.175
cc_679 ( N_noxref_2_c_503_p N_GND_M9_noxref_d ) capacitor c=4.4417e-19 \
 //x=16.03 //y=2.375 //x2=15.805 //y2=1.055
cc_680 ( N_noxref_2_c_527_p N_GND_M9_noxref_d ) capacitor c=0.00184354f \
 //x=15.73 //y=1.055 //x2=15.805 //y2=1.055
cc_681 ( N_noxref_2_c_528_p N_GND_M9_noxref_d ) capacitor c=0.00210798f \
 //x=15.73 //y=1.4 //x2=15.805 //y2=1.055
cc_682 ( N_noxref_2_c_659_p N_GND_M9_noxref_d ) capacitor c=0.00474029f \
 //x=16.105 //y=0.9 //x2=15.805 //y2=1.055
cc_683 ( N_noxref_2_c_669_p N_GND_M9_noxref_d ) capacitor c=0.00166857f \
 //x=16.105 //y=1.555 //x2=15.805 //y2=1.055
cc_684 ( N_noxref_2_c_529_p N_GND_M9_noxref_d ) capacitor c=0.00230174f \
 //x=16.26 //y=1.055 //x2=15.805 //y2=1.055
cc_685 ( N_noxref_2_c_531_p N_GND_M9_noxref_d ) capacitor c=0.00210798f \
 //x=16.26 //y=1.4 //x2=15.805 //y2=1.055
cc_686 ( N_noxref_2_c_505_p N_noxref_50_c_18305_n ) capacitor c=0.00262672f \
 //x=15.73 //y=2.095 //x2=15.51 //y2=1.685
cc_687 ( N_noxref_2_c_503_p N_noxref_50_c_18306_n ) capacitor c=0.00428451f \
 //x=16.03 //y=2.375 //x2=16.395 //y2=1.77
cc_688 ( N_noxref_2_c_498_p N_noxref_50_c_18306_n ) capacitor c=0.0046919f \
 //x=16.03 //y=2.93 //x2=16.395 //y2=1.77
cc_689 ( N_noxref_2_c_502_p N_noxref_50_c_18306_n ) capacitor c=0.0104666f \
 //x=16.03 //y=2.26 //x2=16.395 //y2=1.77
cc_690 ( N_noxref_2_c_530_p N_noxref_50_c_18306_n ) capacitor c=0.00705077f \
 //x=15.73 //y=1.71 //x2=16.395 //y2=1.77
cc_691 ( N_noxref_2_c_505_p N_noxref_50_c_18306_n ) capacitor c=0.0197809f \
 //x=15.73 //y=2.095 //x2=16.395 //y2=1.77
cc_692 ( N_noxref_2_c_669_p N_noxref_50_c_18306_n ) capacitor c=0.00588627f \
 //x=16.105 //y=1.555 //x2=16.395 //y2=1.77
cc_693 ( N_noxref_2_c_531_p N_noxref_50_c_18306_n ) capacitor c=0.00698822f \
 //x=16.26 //y=1.4 //x2=16.395 //y2=1.77
cc_694 ( N_noxref_2_c_527_p N_noxref_50_M9_noxref_s ) capacitor c=0.0295256f \
 //x=15.73 //y=1.055 //x2=15.375 //y2=0.555
cc_695 ( N_noxref_2_c_530_p N_noxref_50_M9_noxref_s ) capacitor c=7.99997e-19 \
 //x=15.73 //y=1.71 //x2=15.375 //y2=0.555
cc_696 ( N_noxref_2_c_505_p N_noxref_50_M9_noxref_s ) capacitor c=0.00122123f \
 //x=15.73 //y=2.095 //x2=15.375 //y2=0.555
cc_697 ( N_noxref_2_c_529_p N_noxref_50_M9_noxref_s ) capacitor c=0.0125924f \
 //x=16.26 //y=1.055 //x2=15.375 //y2=0.555
cc_698 ( N_noxref_3_M86_noxref_g N_noxref_4_c_1177_n ) capacitor c=0.00893512f \
 //x=21.48 //y=6.2 //x2=22.02 //y2=5.335
cc_699 ( N_noxref_3_M85_noxref_g N_noxref_4_c_1178_n ) capacitor c=0.00461408f \
 //x=21.04 //y=6.2 //x2=21.262 //y2=5.335
cc_700 ( N_noxref_3_M86_noxref_g N_noxref_4_c_1178_n ) capacitor c=0.00229208f \
 //x=21.48 //y=6.2 //x2=21.262 //y2=5.335
cc_701 ( N_noxref_3_c_803_p N_noxref_4_c_1178_n ) capacitor c=0.00171885f \
 //x=21.405 //y=4.97 //x2=21.262 //y2=5.335
cc_702 ( N_noxref_3_M85_noxref_g N_noxref_4_c_1181_n ) capacitor c=0.0162284f \
 //x=21.04 //y=6.2 //x2=21.26 //y2=5.56
cc_703 ( N_noxref_3_M86_noxref_g N_noxref_4_c_1181_n ) capacitor c=0.0179041f \
 //x=21.48 //y=6.2 //x2=21.26 //y2=5.56
cc_704 ( N_noxref_3_c_803_p N_noxref_4_c_1181_n ) capacitor c=0.00291477f \
 //x=21.405 //y=4.97 //x2=21.26 //y2=5.56
cc_705 ( N_noxref_3_c_726_n N_noxref_5_c_1545_n ) capacitor c=0.0140058f \
 //x=9.37 //y=3.335 //x2=8.63 //y2=2.375
cc_706 ( N_noxref_3_c_726_n N_noxref_5_c_1468_n ) capacitor c=0.039474f \
 //x=9.37 //y=3.335 //x2=8.63 //y2=3.735
cc_707 ( N_noxref_3_c_732_n N_noxref_5_c_1468_n ) capacitor c=0.0148932f \
 //x=9.37 //y=3.655 //x2=8.63 //y2=3.735
cc_708 ( N_noxref_3_c_734_n N_noxref_5_c_1468_n ) capacitor c=0.00340923f \
 //x=9.37 //y=5.25 //x2=8.63 //y2=3.735
cc_709 ( N_noxref_3_c_811_p N_noxref_5_c_1468_n ) capacitor c=9.19401e-19 \
 //x=9.37 //y=3.51 //x2=8.63 //y2=3.735
cc_710 ( N_noxref_3_c_746_n N_noxref_5_c_1468_n ) capacitor c=0.0237398f \
 //x=9.21 //y=3.495 //x2=8.63 //y2=3.735
cc_711 ( N_noxref_3_c_754_n N_noxref_5_c_1468_n ) capacitor c=0.00336755f \
 //x=9.53 //y=3.495 //x2=8.63 //y2=3.735
cc_712 ( N_noxref_3_c_814_p N_noxref_5_c_1552_n ) capacitor c=8.49432e-19 \
 //x=8.475 //y=5.335 //x2=8.63 //y2=4.055
cc_713 ( N_noxref_3_c_795_n N_noxref_5_c_1552_n ) capacitor c=0.00118353f \
 //x=9.285 //y=5.335 //x2=8.63 //y2=4.055
cc_714 ( N_noxref_3_c_725_n N_noxref_5_c_1552_n ) capacitor c=8.07658e-19 \
 //x=8.97 //y=1.845 //x2=8.63 //y2=4.055
cc_715 ( N_noxref_3_c_734_n N_noxref_5_c_1552_n ) capacitor c=0.01761f \
 //x=9.37 //y=5.25 //x2=8.63 //y2=4.055
cc_716 ( N_noxref_3_c_746_n N_noxref_5_c_1552_n ) capacitor c=0.00611939f \
 //x=9.21 //y=3.495 //x2=8.63 //y2=4.055
cc_717 ( N_noxref_3_c_795_n N_noxref_5_c_1473_n ) capacitor c=0.00228791f \
 //x=9.285 //y=5.335 //x2=8.63 //y2=4.75
cc_718 ( N_noxref_3_c_734_n N_noxref_5_c_1473_n ) capacitor c=0.0412357f \
 //x=9.37 //y=5.25 //x2=8.63 //y2=4.75
cc_719 ( N_noxref_3_c_821_p N_noxref_5_c_1473_n ) capacitor c=0.0221235f \
 //x=8.59 //y=5.335 //x2=8.63 //y2=4.75
cc_720 ( N_noxref_3_c_822_p N_noxref_5_c_1473_n ) capacitor c=0.00217653f \
 //x=8.59 //y=5.56 //x2=8.63 //y2=4.75
cc_721 ( N_noxref_3_c_741_n N_noxref_5_c_1475_n ) capacitor c=0.0214961f \
 //x=20.675 //y=3.51 //x2=13.44 //y2=3.735
cc_722 ( N_noxref_3_c_741_n N_noxref_5_c_1488_n ) capacitor c=0.00642248f \
 //x=20.675 //y=3.51 //x2=13.44 //y2=4.055
cc_723 ( N_noxref_3_c_825_p N_noxref_5_c_1563_n ) capacitor c=0.0034682f \
 //x=20.84 //y=2.375 //x2=18.99 //y2=3.735
cc_724 ( N_noxref_3_c_826_p N_noxref_5_c_1563_n ) capacitor c=0.0130127f \
 //x=20.84 //y=3.35 //x2=18.99 //y2=3.735
cc_725 ( N_noxref_3_c_827_p N_noxref_5_c_1563_n ) capacitor c=0.00255078f \
 //x=20.84 //y=3.67 //x2=18.99 //y2=3.735
cc_726 ( N_noxref_3_c_828_p N_noxref_5_c_1563_n ) capacitor c=0.0011073f \
 //x=20.84 //y=4.755 //x2=18.99 //y2=3.735
cc_727 ( N_noxref_3_c_741_n N_noxref_5_c_1563_n ) capacitor c=0.0225414f \
 //x=20.675 //y=3.51 //x2=18.99 //y2=3.735
cc_728 ( N_noxref_3_c_830_p N_noxref_5_c_1563_n ) capacitor c=0.00158465f \
 //x=20.835 //y=3.51 //x2=18.99 //y2=3.735
cc_729 ( N_noxref_3_c_828_p N_noxref_5_c_1569_n ) capacitor c=0.0025694f \
 //x=20.84 //y=4.755 //x2=18.99 //y2=4.055
cc_730 ( N_noxref_3_c_741_n N_noxref_5_c_1569_n ) capacitor c=0.00926238f \
 //x=20.675 //y=3.51 //x2=18.99 //y2=4.055
cc_731 ( N_noxref_3_c_828_p N_noxref_5_c_1571_n ) capacitor c=0.0116283f \
 //x=20.84 //y=4.755 //x2=18.99 //y2=5.25
cc_732 ( N_noxref_3_c_734_n N_noxref_5_c_1572_n ) capacitor c=9.19401e-19 \
 //x=9.37 //y=5.25 //x2=8.63 //y2=3.88
cc_733 ( N_noxref_3_c_741_n N_noxref_5_c_1504_n ) capacitor c=0.450598f \
 //x=20.675 //y=3.51 //x2=18.82 //y2=3.88
cc_734 ( N_noxref_3_c_827_p N_noxref_5_c_1574_n ) capacitor c=0.00269024f \
 //x=20.84 //y=3.67 //x2=21.05 //y2=3.895
cc_735 ( N_noxref_3_c_828_p N_noxref_5_c_1574_n ) capacitor c=0.0237144f \
 //x=20.84 //y=4.755 //x2=21.05 //y2=3.895
cc_736 ( N_noxref_3_c_827_p N_noxref_5_c_1576_n ) capacitor c=0.00347895f \
 //x=20.84 //y=3.67 //x2=20.705 //y2=3.895
cc_737 ( N_noxref_3_c_828_p N_noxref_5_c_1576_n ) capacitor c=0.00196004f \
 //x=20.84 //y=4.755 //x2=20.705 //y2=3.895
cc_738 ( N_noxref_3_c_741_n N_noxref_5_c_1576_n ) capacitor c=0.170154f \
 //x=20.675 //y=3.51 //x2=20.705 //y2=3.895
cc_739 ( N_noxref_3_c_830_p N_noxref_5_c_1576_n ) capacitor c=0.0358254f \
 //x=20.835 //y=3.51 //x2=20.705 //y2=3.895
cc_740 ( N_noxref_3_c_734_n N_noxref_5_c_1580_n ) capacitor c=0.00336755f \
 //x=9.37 //y=5.25 //x2=8.79 //y2=3.895
cc_741 ( N_noxref_3_c_746_n N_noxref_5_c_1580_n ) capacitor c=0.0358686f \
 //x=9.21 //y=3.495 //x2=8.79 //y2=3.895
cc_742 ( N_noxref_3_c_732_n N_noxref_5_c_1478_n ) capacitor c=0.00917068f \
 //x=9.37 //y=3.655 //x2=13.28 //y2=3.895
cc_743 ( N_noxref_3_c_734_n N_noxref_5_c_1478_n ) capacitor c=0.0216307f \
 //x=9.37 //y=5.25 //x2=13.28 //y2=3.895
cc_744 ( N_noxref_3_c_741_n N_noxref_5_c_1478_n ) capacitor c=0.323902f \
 //x=20.675 //y=3.51 //x2=13.28 //y2=3.895
cc_745 ( N_noxref_3_c_746_n N_noxref_5_c_1478_n ) capacitor c=0.035195f \
 //x=9.21 //y=3.495 //x2=13.28 //y2=3.895
cc_746 ( N_noxref_3_c_754_n N_noxref_5_c_1478_n ) capacitor c=0.0358686f \
 //x=9.53 //y=3.495 //x2=13.28 //y2=3.895
cc_747 ( N_noxref_3_c_741_n N_noxref_5_c_1506_n ) capacitor c=0.0358686f \
 //x=20.675 //y=3.51 //x2=13.6 //y2=3.895
cc_748 ( N_noxref_3_c_726_n N_noxref_5_c_1588_n ) capacitor c=0.0015536f \
 //x=9.37 //y=3.335 //x2=8.63 //y2=2.26
cc_749 ( N_noxref_3_c_795_n N_noxref_5_c_1589_n ) capacitor c=0.00130631f \
 //x=9.285 //y=5.335 //x2=8.63 //y2=4.88
cc_750 ( N_noxref_3_c_734_n N_noxref_5_c_1589_n ) capacitor c=0.00131258f \
 //x=9.37 //y=5.25 //x2=8.63 //y2=4.88
cc_751 ( N_noxref_3_c_821_p N_noxref_5_c_1589_n ) capacitor c=0.00346456f \
 //x=8.59 //y=5.335 //x2=8.63 //y2=4.88
cc_752 ( N_noxref_3_c_822_p N_noxref_5_c_1589_n ) capacitor c=0.00624059f \
 //x=8.59 //y=5.56 //x2=8.63 //y2=4.88
cc_753 ( N_noxref_3_c_814_p N_noxref_5_M71_noxref_g ) capacitor c=0.00955829f \
 //x=8.475 //y=5.335 //x2=8.37 //y2=6.2
cc_754 ( N_noxref_3_c_794_n N_noxref_5_M71_noxref_g ) capacitor c=0.00226521f \
 //x=8.59 //y=5.56 //x2=8.37 //y2=6.2
cc_755 ( N_noxref_3_c_822_p N_noxref_5_M71_noxref_g ) capacitor c=0.0178885f \
 //x=8.59 //y=5.56 //x2=8.37 //y2=6.2
cc_756 ( N_noxref_3_c_794_n N_noxref_5_M72_noxref_g ) capacitor c=0.00381703f \
 //x=8.59 //y=5.56 //x2=8.81 //y2=6.2
cc_757 ( N_noxref_3_c_795_n N_noxref_5_M72_noxref_g ) capacitor c=0.0109636f \
 //x=9.285 //y=5.335 //x2=8.81 //y2=6.2
cc_758 ( N_noxref_3_c_822_p N_noxref_5_M72_noxref_g ) capacitor c=0.0188608f \
 //x=8.59 //y=5.56 //x2=8.81 //y2=6.2
cc_759 ( N_noxref_3_c_861_p N_noxref_5_c_1599_n ) capacitor c=4.64015e-19 \
 //x=8.885 //y=1.305 //x2=8.62 //y2=1.095
cc_760 ( N_noxref_3_M5_noxref_d N_noxref_5_c_1599_n ) capacitor c=0.00137165f \
 //x=8.695 //y=1.095 //x2=8.62 //y2=1.095
cc_761 ( N_noxref_3_c_861_p N_noxref_5_c_1601_n ) capacitor c=0.0026012f \
 //x=8.885 //y=1.305 //x2=8.62 //y2=1.44
cc_762 ( N_noxref_3_c_864_p N_noxref_5_c_1601_n ) capacitor c=0.00127432f \
 //x=8.885 //y=1.76 //x2=8.62 //y2=1.44
cc_763 ( N_noxref_3_M5_noxref_d N_noxref_5_c_1601_n ) capacitor c=0.00237422f \
 //x=8.695 //y=1.095 //x2=8.62 //y2=1.44
cc_764 ( N_noxref_3_c_864_p N_noxref_5_c_1604_n ) capacitor c=0.00429966f \
 //x=8.885 //y=1.76 //x2=8.62 //y2=1.75
cc_765 ( N_noxref_3_c_861_p N_noxref_5_c_1605_n ) capacitor c=5.29969e-19 \
 //x=8.885 //y=1.305 //x2=8.995 //y2=0.94
cc_766 ( N_noxref_3_M5_noxref_d N_noxref_5_c_1605_n ) capacitor c=0.0020782f \
 //x=8.695 //y=1.095 //x2=8.995 //y2=0.94
cc_767 ( N_noxref_3_c_861_p N_noxref_5_c_1607_n ) capacitor c=5.18355e-19 \
 //x=8.885 //y=1.305 //x2=8.995 //y2=1.595
cc_768 ( N_noxref_3_c_864_p N_noxref_5_c_1607_n ) capacitor c=0.00942306f \
 //x=8.885 //y=1.76 //x2=8.995 //y2=1.595
cc_769 ( N_noxref_3_c_796_n N_noxref_5_c_1607_n ) capacitor c=0.00194716f \
 //x=9.285 //y=1.845 //x2=8.995 //y2=1.595
cc_770 ( N_noxref_3_M5_noxref_d N_noxref_5_c_1607_n ) capacitor c=0.00356097f \
 //x=8.695 //y=1.095 //x2=8.995 //y2=1.595
cc_771 ( N_noxref_3_c_861_p N_noxref_5_c_1611_n ) capacitor c=5.24634e-19 \
 //x=8.885 //y=1.305 //x2=9.15 //y2=1.095
cc_772 ( N_noxref_3_M5_noxref_d N_noxref_5_c_1611_n ) capacitor c=0.00139206f \
 //x=8.695 //y=1.095 //x2=9.15 //y2=1.095
cc_773 ( N_noxref_3_c_861_p N_noxref_5_c_1613_n ) capacitor c=0.00307978f \
 //x=8.885 //y=1.305 //x2=9.15 //y2=1.44
cc_774 ( N_noxref_3_c_864_p N_noxref_5_c_1613_n ) capacitor c=0.00363411f \
 //x=8.885 //y=1.76 //x2=9.15 //y2=1.44
cc_775 ( N_noxref_3_c_796_n N_noxref_5_c_1613_n ) capacitor c=0.00323576f \
 //x=9.285 //y=1.845 //x2=9.15 //y2=1.44
cc_776 ( N_noxref_3_M5_noxref_d N_noxref_5_c_1613_n ) capacitor c=0.00237422f \
 //x=8.695 //y=1.095 //x2=9.15 //y2=1.44
cc_777 ( N_noxref_3_c_726_n N_noxref_5_c_1617_n ) capacitor c=0.0024584f \
 //x=9.37 //y=3.335 //x2=8.63 //y2=2.26
cc_778 ( N_noxref_3_c_864_p N_noxref_5_c_1618_n ) capacitor c=0.0036273f \
 //x=8.885 //y=1.76 //x2=8.63 //y2=2.095
cc_779 ( N_noxref_3_c_726_n N_noxref_5_c_1618_n ) capacitor c=0.00282067f \
 //x=9.37 //y=3.335 //x2=8.63 //y2=2.095
cc_780 ( N_noxref_3_c_734_n N_noxref_5_c_1620_n ) capacitor c=0.00739875f \
 //x=9.37 //y=5.25 //x2=8.63 //y2=4.88
cc_781 ( N_noxref_3_c_821_p N_noxref_5_c_1620_n ) capacitor c=0.00203307f \
 //x=8.59 //y=5.335 //x2=8.63 //y2=4.88
cc_782 ( N_noxref_3_c_822_p N_noxref_5_c_1620_n ) capacitor c=0.00375636f \
 //x=8.59 //y=5.56 //x2=8.63 //y2=4.88
cc_783 ( N_noxref_3_c_826_p N_noxref_6_c_2065_n ) capacitor c=0.00166793f \
 //x=20.84 //y=3.35 //x2=23.06 //y2=3.365
cc_784 ( N_noxref_3_c_828_p N_noxref_6_c_2066_n ) capacitor c=7.69262e-19 \
 //x=20.84 //y=4.755 //x2=23.06 //y2=4.75
cc_785 ( N_noxref_3_c_887_p N_noxref_6_c_2067_n ) capacitor c=8.84157e-19 \
 //x=20.835 //y=3.51 //x2=23.06 //y2=3.51
cc_786 ( N_noxref_3_c_830_p N_noxref_6_c_2068_n ) capacitor c=0.0022513f \
 //x=20.835 //y=3.51 //x2=23.22 //y2=3.51
cc_787 ( N_noxref_3_c_707_n D ) capacitor c=0.00189402f //x=3.82 //y=3.355 \
 //x2=1.6 //y2=2.4
cc_788 ( N_noxref_3_c_719_n D ) capacitor c=3.9613e-19 //x=3.82 //y=4.75 \
 //x2=1.6 //y2=2.4
cc_789 ( N_noxref_3_c_719_n D ) capacitor c=6.27726e-19 //x=3.82 //y=4.75 \
 //x2=1.6 //y2=4.62
cc_790 ( N_noxref_3_c_714_n N_D_c_5110_n ) capacitor c=0.00311914f //x=3.82 \
 //y=3.675 //x2=8.245 //y2=4.25
cc_791 ( N_noxref_3_c_719_n N_D_c_5110_n ) capacitor c=0.0306035f //x=3.82 \
 //y=4.75 //x2=8.245 //y2=4.25
cc_792 ( N_noxref_3_c_736_n N_D_c_5110_n ) capacitor c=0.0218433f //x=6.832 \
 //y=5.335 //x2=8.245 //y2=4.25
cc_793 ( N_noxref_3_c_745_n N_D_c_5110_n ) capacitor c=0.0158965f //x=3.99 \
 //y=3.515 //x2=8.245 //y2=4.25
cc_794 ( N_noxref_3_c_746_n N_D_c_5110_n ) capacitor c=0.199703f //x=9.21 \
 //y=3.495 //x2=8.245 //y2=4.25
cc_795 ( N_noxref_3_c_734_n N_D_c_5117_n ) capacitor c=0.0241507f //x=9.37 \
 //y=5.25 //x2=8.845 //y2=4.28
cc_796 ( N_noxref_3_c_741_n N_D_c_5117_n ) capacitor c=0.0310006f //x=20.675 \
 //y=3.51 //x2=8.845 //y2=4.28
cc_797 ( N_noxref_3_c_746_n N_D_c_5117_n ) capacitor c=0.002911f //x=9.21 \
 //y=3.495 //x2=8.845 //y2=4.28
cc_798 ( N_noxref_3_c_741_n N_D_c_5125_n ) capacitor c=0.0373406f //x=20.675 \
 //y=3.51 //x2=13.655 //y2=4.31
cc_799 ( N_noxref_3_c_741_n N_D_c_5126_n ) capacitor c=0.00404818f //x=20.675 \
 //y=3.51 //x2=18.595 //y2=4.25
cc_800 ( N_noxref_3_c_828_p N_D_c_5141_n ) capacitor c=4.8624e-19 //x=20.84 \
 //y=4.755 //x2=19.195 //y2=4.28
cc_801 ( N_noxref_3_c_741_n N_D_c_5141_n ) capacitor c=0.00963112f //x=20.675 \
 //y=3.51 //x2=19.195 //y2=4.28
cc_802 ( N_noxref_3_c_828_p N_D_c_5143_n ) capacitor c=0.0245517f //x=20.84 \
 //y=4.755 //x2=27.485 //y2=4.25
cc_803 ( N_noxref_3_c_726_n CLK ) capacitor c=0.00145246f //x=9.37 //y=3.335 \
 //x2=7.52 //y2=3.14
cc_804 ( N_noxref_3_c_734_n CLK ) capacitor c=0.00169781f //x=9.37 //y=5.25 \
 //x2=7.52 //y2=3.14
cc_805 ( N_noxref_3_c_746_n CLK ) capacitor c=0.0288443f //x=9.21 //y=3.495 \
 //x2=7.52 //y2=3.14
cc_806 ( N_noxref_3_c_741_n CLK ) capacitor c=0.0235252f //x=20.675 //y=3.51 \
 //x2=17.14 //y2=2.77
cc_807 ( N_noxref_3_c_724_n N_CLK_c_6422_n ) capacitor c=0.0236366f //x=7.59 \
 //y=5.335 //x2=7.515 //y2=4.835
cc_808 ( N_noxref_3_c_910_p N_CLK_c_6422_n ) capacitor c=0.00512107f //x=7.71 \
 //y=5.335 //x2=7.515 //y2=4.835
cc_809 ( N_noxref_3_c_911_p N_CLK_c_6422_n ) capacitor c=0.00134045f //x=7.71 \
 //y=5.56 //x2=7.515 //y2=4.835
cc_810 ( N_noxref_3_c_795_n N_CLK_c_6426_n ) capacitor c=0.0201076f //x=9.285 \
 //y=5.335 //x2=16.985 //y2=4.62
cc_811 ( N_noxref_3_c_734_n N_CLK_c_6426_n ) capacitor c=0.0299914f //x=9.37 \
 //y=5.25 //x2=16.985 //y2=4.62
cc_812 ( N_noxref_3_c_910_p N_CLK_c_6426_n ) capacitor c=0.0381552f //x=7.71 \
 //y=5.335 //x2=16.985 //y2=4.62
cc_813 ( N_noxref_3_c_828_p N_CLK_c_6473_n ) capacitor c=0.0323468f //x=20.84 \
 //y=4.755 //x2=28.395 //y2=4.61
cc_814 ( N_noxref_3_c_724_n N_CLK_c_6427_n ) capacitor c=0.00243099f //x=7.59 \
 //y=5.335 //x2=7.515 //y2=4.62
cc_815 ( N_noxref_3_c_910_p N_CLK_c_6427_n ) capacitor c=0.00207204f //x=7.71 \
 //y=5.335 //x2=7.515 //y2=4.62
cc_816 ( N_noxref_3_c_746_n N_CLK_c_6427_n ) capacitor c=0.00474919f //x=9.21 \
 //y=3.495 //x2=7.515 //y2=4.62
cc_817 ( N_noxref_3_c_724_n N_CLK_c_6432_n ) capacitor c=0.00492634f //x=7.59 \
 //y=5.335 //x2=7.52 //y2=4.88
cc_818 ( N_noxref_3_c_910_p N_CLK_c_6432_n ) capacitor c=0.00132214f //x=7.71 \
 //y=5.335 //x2=7.52 //y2=4.88
cc_819 ( N_noxref_3_c_724_n N_CLK_M69_noxref_g ) capacitor c=0.00858222f \
 //x=7.59 //y=5.335 //x2=7.49 //y2=6.2
cc_820 ( N_noxref_3_c_910_p N_CLK_M69_noxref_g ) capacitor c=0.00229818f \
 //x=7.71 //y=5.335 //x2=7.49 //y2=6.2
cc_821 ( N_noxref_3_c_911_p N_CLK_M69_noxref_g ) capacitor c=0.0179041f \
 //x=7.71 //y=5.56 //x2=7.49 //y2=6.2
cc_822 ( N_noxref_3_c_814_p N_CLK_M70_noxref_g ) capacitor c=0.00955829f \
 //x=8.475 //y=5.335 //x2=7.93 //y2=6.2
cc_823 ( N_noxref_3_c_910_p N_CLK_M70_noxref_g ) capacitor c=0.00230699f \
 //x=7.71 //y=5.335 //x2=7.93 //y2=6.2
cc_824 ( N_noxref_3_c_911_p N_CLK_M70_noxref_g ) capacitor c=0.0179041f \
 //x=7.71 //y=5.56 //x2=7.93 //y2=6.2
cc_825 ( N_noxref_3_c_910_p N_CLK_c_6521_n ) capacitor c=0.00170733f //x=7.71 \
 //y=5.335 //x2=7.855 //y2=4.97
cc_826 ( N_noxref_3_c_911_p N_CLK_c_6521_n ) capacitor c=0.00293647f //x=7.71 \
 //y=5.56 //x2=7.855 //y2=4.97
cc_827 ( N_noxref_3_c_724_n N_CLK_c_6450_n ) capacitor c=3.54644e-19 //x=7.59 \
 //y=5.335 //x2=7.52 //y2=4.88
cc_828 ( N_noxref_3_c_707_n RN ) capacitor c=0.0241688f //x=3.82 //y=3.355 \
 //x2=2.71 //y2=2.77
cc_829 ( N_noxref_3_c_714_n RN ) capacitor c=0.00763467f //x=3.82 //y=3.675 \
 //x2=2.71 //y2=2.77
cc_830 ( N_noxref_3_c_719_n RN ) capacitor c=0.0300369f //x=3.82 //y=4.75 \
 //x2=2.71 //y2=2.77
cc_831 ( N_noxref_3_c_735_n RN ) capacitor c=3.43503e-19 //x=3.82 //y=3.51 \
 //x2=2.71 //y2=2.77
cc_832 ( N_noxref_3_c_745_n RN ) capacitor c=0.00504602f //x=3.99 //y=3.515 \
 //x2=2.71 //y2=2.77
cc_833 ( N_noxref_3_c_757_n RN ) capacitor c=2.94497e-19 //x=3.82 //y=4.88 \
 //x2=2.71 //y2=2.77
cc_834 ( N_noxref_3_c_826_p RN ) capacitor c=0.00148823f //x=20.84 //y=3.35 \
 //x2=18.25 //y2=2.77
cc_835 ( N_noxref_3_c_828_p RN ) capacitor c=0.00146042f //x=20.84 //y=4.755 \
 //x2=18.25 //y2=2.77
cc_836 ( N_noxref_3_c_741_n RN ) capacitor c=0.0220806f //x=20.675 //y=3.51 \
 //x2=18.25 //y2=2.77
cc_837 ( N_noxref_3_c_826_p RN ) capacitor c=0.0204304f //x=20.84 //y=3.35 \
 //x2=21.95 //y2=2.77
cc_838 ( N_noxref_3_c_827_p RN ) capacitor c=0.00769355f //x=20.84 //y=3.67 \
 //x2=21.95 //y2=2.77
cc_839 ( N_noxref_3_c_828_p RN ) capacitor c=0.0242557f //x=20.84 //y=4.755 \
 //x2=21.95 //y2=2.77
cc_840 ( N_noxref_3_c_887_p RN ) capacitor c=2.61099e-19 //x=20.835 //y=3.51 \
 //x2=21.95 //y2=2.77
cc_841 ( N_noxref_3_c_830_p RN ) capacitor c=0.0032986f //x=20.835 //y=3.51 \
 //x2=21.95 //y2=2.77
cc_842 ( N_noxref_3_c_944_p RN ) capacitor c=3.36194e-19 //x=20.84 //y=4.88 \
 //x2=21.95 //y2=2.77
cc_843 ( N_noxref_3_c_706_n N_RN_c_7850_n ) capacitor c=0.00806473f //x=3.82 \
 //y=2.375 //x2=2.71 //y2=2.56
cc_844 ( N_noxref_3_c_707_n N_RN_c_7850_n ) capacitor c=0.00361597f //x=3.82 \
 //y=3.355 //x2=2.71 //y2=2.56
cc_845 ( N_noxref_3_c_756_n N_RN_c_7850_n ) capacitor c=0.00116634f //x=3.82 \
 //y=2.26 //x2=2.71 //y2=2.56
cc_846 ( N_noxref_3_c_788_n N_RN_c_7850_n ) capacitor c=0.00149512f //x=3.82 \
 //y=2.26 //x2=2.71 //y2=2.56
cc_847 ( N_noxref_3_c_719_n N_RN_c_7852_n ) capacitor c=0.0107551f //x=3.82 \
 //y=4.75 //x2=2.71 //y2=4.765
cc_848 ( N_noxref_3_c_757_n N_RN_c_7852_n ) capacitor c=4.56604e-19 //x=3.82 \
 //y=4.88 //x2=2.71 //y2=4.765
cc_849 ( N_noxref_3_c_791_n N_RN_c_7852_n ) capacitor c=0.00124604f //x=3.82 \
 //y=4.88 //x2=2.71 //y2=4.765
cc_850 ( N_noxref_3_c_825_p N_RN_c_7926_n ) capacitor c=0.00820823f //x=20.84 \
 //y=2.375 //x2=21.95 //y2=2.57
cc_851 ( N_noxref_3_c_826_p N_RN_c_7926_n ) capacitor c=0.00387426f //x=20.84 \
 //y=3.35 //x2=21.95 //y2=2.57
cc_852 ( N_noxref_3_c_954_p N_RN_c_7926_n ) capacitor c=0.00116826f //x=20.84 \
 //y=2.26 //x2=21.95 //y2=2.57
cc_853 ( N_noxref_3_c_955_p N_RN_c_7926_n ) capacitor c=0.00158832f //x=20.54 \
 //y=2.095 //x2=21.95 //y2=2.57
cc_854 ( N_noxref_3_c_828_p N_RN_c_7930_n ) capacitor c=0.0110307f //x=20.84 \
 //y=4.755 //x2=21.95 //y2=4.765
cc_855 ( N_noxref_3_c_944_p N_RN_c_7930_n ) capacitor c=2.89813e-19 //x=20.84 \
 //y=4.88 //x2=21.95 //y2=4.765
cc_856 ( N_noxref_3_c_803_p N_RN_c_7930_n ) capacitor c=7.66769e-19 //x=21.405 \
 //y=4.97 //x2=21.95 //y2=4.765
cc_857 ( N_noxref_3_c_959_p N_RN_c_7930_n ) capacitor c=7.54501e-19 //x=21.115 \
 //y=4.97 //x2=21.95 //y2=4.765
cc_858 ( N_noxref_3_c_706_n N_RN_c_7855_n ) capacitor c=0.0157182f //x=3.82 \
 //y=2.375 //x2=13.795 //y2=2.4
cc_859 ( N_noxref_3_c_707_n N_RN_c_7855_n ) capacitor c=0.0168553f //x=3.82 \
 //y=3.355 //x2=13.795 //y2=2.4
cc_860 ( N_noxref_3_c_714_n N_RN_c_7855_n ) capacitor c=0.00239988f //x=3.82 \
 //y=3.675 //x2=13.795 //y2=2.4
cc_861 ( N_noxref_3_c_861_p N_RN_c_7855_n ) capacitor c=7.15814e-19 //x=8.885 \
 //y=1.305 //x2=13.795 //y2=2.4
cc_862 ( N_noxref_3_c_725_n N_RN_c_7855_n ) capacitor c=0.0211903f //x=8.97 \
 //y=1.845 //x2=13.795 //y2=2.4
cc_863 ( N_noxref_3_c_726_n N_RN_c_7855_n ) capacitor c=0.0277836f //x=9.37 \
 //y=3.335 //x2=13.795 //y2=2.4
cc_864 ( N_noxref_3_c_741_n N_RN_c_7855_n ) capacitor c=0.0428601f //x=20.675 \
 //y=3.51 //x2=13.795 //y2=2.4
cc_865 ( N_noxref_3_c_745_n N_RN_c_7855_n ) capacitor c=0.00830349f //x=3.99 \
 //y=3.515 //x2=13.795 //y2=2.4
cc_866 ( N_noxref_3_c_746_n N_RN_c_7855_n ) capacitor c=0.033172f //x=9.21 \
 //y=3.495 //x2=13.795 //y2=2.4
cc_867 ( N_noxref_3_c_788_n N_RN_c_7855_n ) capacitor c=3.41298e-19 //x=3.82 \
 //y=2.26 //x2=13.795 //y2=2.4
cc_868 ( N_noxref_3_c_706_n N_RN_c_7944_n ) capacitor c=0.00172487f //x=3.82 \
 //y=2.375 //x2=2.87 //y2=2.4
cc_869 ( N_noxref_3_c_707_n N_RN_c_7944_n ) capacitor c=0.00121233f //x=3.82 \
 //y=3.355 //x2=2.87 //y2=2.4
cc_870 ( N_noxref_3_c_741_n N_RN_c_7897_n ) capacitor c=8.6713e-19 //x=20.675 \
 //y=3.51 //x2=16.255 //y2=2.385
cc_871 ( N_noxref_3_c_825_p N_RN_c_7947_n ) capacitor c=0.0165384f //x=20.84 \
 //y=2.375 //x2=21.785 //y2=2.4
cc_872 ( N_noxref_3_c_826_p N_RN_c_7947_n ) capacitor c=0.0167844f //x=20.84 \
 //y=3.35 //x2=21.785 //y2=2.4
cc_873 ( N_noxref_3_c_741_n N_RN_c_7947_n ) capacitor c=0.0101903f //x=20.675 \
 //y=3.51 //x2=21.785 //y2=2.4
cc_874 ( N_noxref_3_c_954_p N_RN_c_7947_n ) capacitor c=2.54369e-19 //x=20.84 \
 //y=2.26 //x2=21.785 //y2=2.4
cc_875 ( N_noxref_3_c_955_p N_RN_c_7947_n ) capacitor c=3.41298e-19 //x=20.54 \
 //y=2.095 //x2=21.785 //y2=2.4
cc_876 ( N_noxref_3_c_741_n N_RN_c_7903_n ) capacitor c=0.00983057f //x=20.675 \
 //y=3.51 //x2=18.415 //y2=2.4
cc_877 ( N_noxref_3_c_825_p N_RN_c_7953_n ) capacitor c=0.00149687f //x=20.84 \
 //y=2.375 //x2=23.57 //y2=2.37
cc_878 ( N_noxref_3_c_826_p N_RN_c_7953_n ) capacitor c=0.00137876f //x=20.84 \
 //y=3.35 //x2=23.57 //y2=2.37
cc_879 ( N_noxref_3_c_706_n N_RN_c_7955_n ) capacitor c=5.39999e-19 //x=3.82 \
 //y=2.375 //x2=2.71 //y2=2.26
cc_880 ( N_noxref_3_c_756_n N_RN_c_7955_n ) capacitor c=0.00124907f //x=3.82 \
 //y=2.26 //x2=2.71 //y2=2.26
cc_881 ( N_noxref_3_c_788_n N_RN_c_7955_n ) capacitor c=0.00204796f //x=3.82 \
 //y=2.26 //x2=2.71 //y2=2.26
cc_882 ( N_noxref_3_c_719_n N_RN_c_7874_n ) capacitor c=9.52396e-19 //x=3.82 \
 //y=4.75 //x2=2.71 //y2=4.88
cc_883 ( N_noxref_3_c_757_n N_RN_c_7874_n ) capacitor c=0.00113985f //x=3.82 \
 //y=4.88 //x2=2.71 //y2=4.88
cc_884 ( N_noxref_3_c_791_n N_RN_c_7874_n ) capacitor c=0.00187046f //x=3.82 \
 //y=4.88 //x2=2.71 //y2=4.88
cc_885 ( N_noxref_3_c_825_p N_RN_c_7961_n ) capacitor c=5.39999e-19 //x=20.84 \
 //y=2.375 //x2=21.95 //y2=2.26
cc_886 ( N_noxref_3_c_954_p N_RN_c_7961_n ) capacitor c=0.00124906f //x=20.84 \
 //y=2.26 //x2=21.95 //y2=2.26
cc_887 ( N_noxref_3_c_955_p N_RN_c_7961_n ) capacitor c=0.00214501f //x=20.54 \
 //y=2.095 //x2=21.95 //y2=2.26
cc_888 ( N_noxref_3_c_828_p N_RN_c_7964_n ) capacitor c=0.00103399f //x=20.84 \
 //y=4.755 //x2=21.95 //y2=4.88
cc_889 ( N_noxref_3_c_944_p N_RN_c_7964_n ) capacitor c=0.00113984f //x=20.84 \
 //y=4.88 //x2=21.95 //y2=4.88
cc_890 ( N_noxref_3_c_803_p N_RN_c_7964_n ) capacitor c=0.00116563f //x=21.405 \
 //y=4.97 //x2=21.95 //y2=4.88
cc_891 ( N_noxref_3_c_959_p N_RN_c_7964_n ) capacitor c=0.00129812f //x=21.115 \
 //y=4.97 //x2=21.95 //y2=4.88
cc_892 ( N_noxref_3_M65_noxref_g N_RN_M63_noxref_g ) capacitor c=0.0101598f \
 //x=3.56 //y=6.2 //x2=2.68 //y2=6.2
cc_893 ( N_noxref_3_M65_noxref_g N_RN_M64_noxref_g ) capacitor c=0.0607518f \
 //x=3.56 //y=6.2 //x2=3.12 //y2=6.2
cc_894 ( N_noxref_3_M66_noxref_g N_RN_M64_noxref_g ) capacitor c=0.0101598f \
 //x=4 //y=6.2 //x2=3.12 //y2=6.2
cc_895 ( N_noxref_3_M85_noxref_g N_RN_M87_noxref_g ) capacitor c=0.0106276f \
 //x=21.04 //y=6.2 //x2=21.92 //y2=6.2
cc_896 ( N_noxref_3_M86_noxref_g N_RN_M87_noxref_g ) capacitor c=0.107144f \
 //x=21.48 //y=6.2 //x2=21.92 //y2=6.2
cc_897 ( N_noxref_3_M86_noxref_g N_RN_M88_noxref_g ) capacitor c=0.0101598f \
 //x=21.48 //y=6.2 //x2=22.36 //y2=6.2
cc_898 ( N_noxref_3_c_770_n N_RN_c_7974_n ) capacitor c=0.00456962f //x=3.81 \
 //y=1.095 //x2=2.8 //y2=1.09
cc_899 ( N_noxref_3_c_772_n N_RN_c_7975_n ) capacitor c=0.00438372f //x=3.81 \
 //y=1.44 //x2=2.8 //y2=1.4
cc_900 ( N_noxref_3_c_775_n N_RN_c_7976_n ) capacitor c=0.00438372f //x=3.81 \
 //y=1.75 //x2=2.8 //y2=1.63
cc_901 ( N_noxref_3_c_706_n N_RN_c_7977_n ) capacitor c=6.57681e-19 //x=3.82 \
 //y=2.375 //x2=2.8 //y2=2.095
cc_902 ( N_noxref_3_c_756_n N_RN_c_7977_n ) capacitor c=0.00177608f //x=3.82 \
 //y=2.26 //x2=2.8 //y2=2.095
cc_903 ( N_noxref_3_c_788_n N_RN_c_7977_n ) capacitor c=0.00873247f //x=3.82 \
 //y=2.26 //x2=2.8 //y2=2.095
cc_904 ( N_noxref_3_c_789_n N_RN_c_7977_n ) capacitor c=0.00438372f //x=3.82 \
 //y=2.095 //x2=2.8 //y2=2.095
cc_905 ( N_noxref_3_c_791_n N_RN_c_7882_n ) capacitor c=0.0616777f //x=3.82 \
 //y=4.88 //x2=3.045 //y2=4.97
cc_906 ( N_noxref_3_c_1008_p N_RN_c_7982_n ) capacitor c=5.72528e-19 //x=20.54 \
 //y=1.055 //x2=21.515 //y2=1.09
cc_907 ( N_noxref_3_c_1009_p N_RN_c_7982_n ) capacitor c=0.00150277f //x=20.54 \
 //y=1.4 //x2=21.515 //y2=1.09
cc_908 ( N_noxref_3_c_1010_p N_RN_c_7982_n ) capacitor c=0.0160123f //x=21.07 \
 //y=1.055 //x2=21.515 //y2=1.09
cc_909 ( N_noxref_3_c_1011_p N_RN_c_7985_n ) capacitor c=0.00111227f //x=20.54 \
 //y=1.71 //x2=21.515 //y2=1.4
cc_910 ( N_noxref_3_c_1012_p N_RN_c_7985_n ) capacitor c=0.0124075f //x=21.07 \
 //y=1.4 //x2=21.515 //y2=1.4
cc_911 ( N_noxref_3_c_1010_p N_RN_c_7987_n ) capacitor c=9.19165e-19 //x=21.07 \
 //y=1.055 //x2=22.04 //y2=1.09
cc_912 ( N_noxref_3_c_1012_p N_RN_c_7988_n ) capacitor c=0.0010154f //x=21.07 \
 //y=1.4 //x2=22.04 //y2=1.4
cc_913 ( N_noxref_3_c_1012_p N_RN_c_7989_n ) capacitor c=9.23422e-19 //x=21.07 \
 //y=1.4 //x2=22.04 //y2=1.63
cc_914 ( N_noxref_3_c_825_p N_RN_c_7990_n ) capacitor c=6.79315e-19 //x=20.84 \
 //y=2.375 //x2=22.04 //y2=2.095
cc_915 ( N_noxref_3_c_954_p N_RN_c_7990_n ) capacitor c=0.00176374f //x=20.84 \
 //y=2.26 //x2=22.04 //y2=2.095
cc_916 ( N_noxref_3_c_955_p N_RN_c_7990_n ) capacitor c=0.00887699f //x=20.54 \
 //y=2.095 //x2=22.04 //y2=2.095
cc_917 ( N_noxref_3_c_719_n N_RN_c_7884_n ) capacitor c=8.42568e-19 //x=3.82 \
 //y=4.75 //x2=2.71 //y2=4.88
cc_918 ( N_noxref_3_c_757_n N_RN_c_7884_n ) capacitor c=0.00129812f //x=3.82 \
 //y=4.88 //x2=2.71 //y2=4.88
cc_919 ( N_noxref_3_c_791_n N_RN_c_7884_n ) capacitor c=0.00487508f //x=3.82 \
 //y=4.88 //x2=2.71 //y2=4.88
cc_920 ( N_noxref_3_c_828_p N_RN_c_7996_n ) capacitor c=0.00116212f //x=20.84 \
 //y=4.755 //x2=21.95 //y2=4.88
cc_921 ( N_noxref_3_c_944_p N_RN_c_7996_n ) capacitor c=0.00155973f //x=20.84 \
 //y=4.88 //x2=21.95 //y2=4.88
cc_922 ( N_noxref_3_c_803_p N_RN_c_7996_n ) capacitor c=0.0171374f //x=21.405 \
 //y=4.97 //x2=21.95 //y2=4.88
cc_923 ( N_noxref_3_c_959_p N_RN_c_7996_n ) capacitor c=0.00484466f //x=21.115 \
 //y=4.97 //x2=21.95 //y2=4.88
cc_924 ( N_noxref_3_c_726_n SN ) capacitor c=0.00102767f //x=9.37 //y=3.335 \
 //x2=12.33 //y2=2.77
cc_925 ( N_noxref_3_c_741_n N_SN_c_9844_n ) capacitor c=0.00591344f //x=20.675 \
 //y=3.51 //x2=12.33 //y2=3.285
cc_926 ( N_noxref_3_c_734_n N_SN_c_9845_n ) capacitor c=8.30912e-19 //x=9.37 \
 //y=5.25 //x2=12.33 //y2=4.765
cc_927 ( N_noxref_3_c_741_n N_SN_c_9845_n ) capacitor c=0.0229415f //x=20.675 \
 //y=3.51 //x2=12.33 //y2=4.765
cc_928 ( N_noxref_3_c_741_n N_SN_c_9884_n ) capacitor c=0.174593f //x=20.675 \
 //y=3.51 //x2=13.795 //y2=3.14
cc_929 ( N_noxref_3_c_741_n N_SN_c_9887_n ) capacitor c=0.112359f //x=20.675 \
 //y=3.51 //x2=14.395 //y2=3.155
cc_930 ( N_noxref_3_c_741_n N_SN_c_9890_n ) capacitor c=0.0578136f //x=20.675 \
 //y=3.51 //x2=15.655 //y2=3.14
cc_931 ( N_noxref_3_c_741_n N_SN_c_9894_n ) capacitor c=0.361595f //x=20.675 \
 //y=3.51 //x2=16.255 //y2=3.155
cc_932 ( N_noxref_3_c_826_p N_SN_c_9915_n ) capacitor c=4.64545e-19 //x=20.84 \
 //y=3.35 //x2=20.45 //y2=3.14
cc_933 ( N_noxref_3_c_827_p N_SN_c_9915_n ) capacitor c=0.00323523f //x=20.84 \
 //y=3.67 //x2=20.45 //y2=3.14
cc_934 ( N_noxref_3_c_741_n N_SN_c_9915_n ) capacitor c=0.010873f //x=20.675 \
 //y=3.51 //x2=20.45 //y2=3.14
cc_935 ( N_noxref_3_c_826_p N_SN_c_9918_n ) capacitor c=0.0265459f //x=20.84 \
 //y=3.35 //x2=21.05 //y2=3.125
cc_936 ( N_noxref_3_c_827_p N_SN_c_9918_n ) capacitor c=0.00485165f //x=20.84 \
 //y=3.67 //x2=21.05 //y2=3.125
cc_937 ( N_noxref_3_c_830_p N_SN_c_9918_n ) capacitor c=0.0358686f //x=20.835 \
 //y=3.51 //x2=21.05 //y2=3.125
cc_938 ( N_noxref_3_c_826_p N_SN_c_9921_n ) capacitor c=3.81384e-19 //x=20.84 \
 //y=3.35 //x2=32.475 //y2=3.13
cc_939 ( N_noxref_3_c_741_n N_SN_c_9849_n ) capacitor c=0.0358686f //x=20.675 \
 //y=3.51 //x2=12.49 //y2=3.125
cc_940 ( N_noxref_3_c_724_n N_VDD_c_13434_n ) capacitor c=0.00599866f //x=7.59 \
 //y=5.335 //x2=87.775 //y2=7.585
cc_941 ( N_noxref_3_c_814_p N_VDD_c_13434_n ) capacitor c=0.00627191f \
 //x=8.475 //y=5.335 //x2=87.775 //y2=7.585
cc_942 ( N_noxref_3_c_794_n N_VDD_c_13434_n ) capacitor c=0.00256019f //x=8.59 \
 //y=5.56 //x2=87.775 //y2=7.585
cc_943 ( N_noxref_3_c_795_n N_VDD_c_13434_n ) capacitor c=0.00829247f \
 //x=9.285 //y=5.335 //x2=87.775 //y2=7.585
cc_944 ( N_noxref_3_c_732_n N_VDD_c_13434_n ) capacitor c=4.57419e-19 //x=9.37 \
 //y=3.655 //x2=87.775 //y2=7.585
cc_945 ( N_noxref_3_c_827_p N_VDD_c_13434_n ) capacitor c=3.78831e-19 \
 //x=20.84 //y=3.67 //x2=87.775 //y2=7.585
cc_946 ( N_noxref_3_c_736_n N_VDD_c_13434_n ) capacitor c=0.00261804f \
 //x=6.832 //y=5.335 //x2=87.775 //y2=7.585
cc_947 ( N_noxref_3_c_910_p N_VDD_c_13434_n ) capacitor c=0.00262723f //x=7.71 \
 //y=5.335 //x2=87.775 //y2=7.585
cc_948 ( N_noxref_3_c_761_n N_VDD_c_13434_n ) capacitor c=0.0024232f //x=6.83 \
 //y=5.56 //x2=87.775 //y2=7.585
cc_949 ( N_noxref_3_c_911_p N_VDD_c_13434_n ) capacitor c=0.0024232f //x=7.71 \
 //y=5.56 //x2=87.775 //y2=7.585
cc_950 ( N_noxref_3_c_822_p N_VDD_c_13434_n ) capacitor c=0.0024232f //x=8.59 \
 //y=5.56 //x2=87.775 //y2=7.585
cc_951 ( N_noxref_3_M65_noxref_g N_VDD_c_13452_n ) capacitor c=0.00755544f \
 //x=3.56 //y=6.2 //x2=4.135 //y2=7.585
cc_952 ( N_noxref_3_M66_noxref_g N_VDD_c_13452_n ) capacitor c=0.00755754f \
 //x=4 //y=6.2 //x2=4.135 //y2=7.585
cc_953 ( N_noxref_3_c_724_n N_VDD_c_13457_n ) capacitor c=0.00202922f //x=7.59 \
 //y=5.335 //x2=7.185 //y2=7.585
cc_954 ( N_noxref_3_c_736_n N_VDD_c_13457_n ) capacitor c=9.3757e-19 //x=6.832 \
 //y=5.335 //x2=7.185 //y2=7.585
cc_955 ( N_noxref_3_c_761_n N_VDD_c_13457_n ) capacitor c=0.0138074f //x=6.83 \
 //y=5.56 //x2=7.185 //y2=7.585
cc_956 ( N_noxref_3_c_724_n N_VDD_c_13563_n ) capacitor c=0.0017708f //x=7.59 \
 //y=5.335 //x2=8.065 //y2=7.585
cc_957 ( N_noxref_3_c_814_p N_VDD_c_13563_n ) capacitor c=0.00202922f \
 //x=8.475 //y=5.335 //x2=8.065 //y2=7.585
cc_958 ( N_noxref_3_c_910_p N_VDD_c_13563_n ) capacitor c=9.4822e-19 //x=7.71 \
 //y=5.335 //x2=8.065 //y2=7.585
cc_959 ( N_noxref_3_c_911_p N_VDD_c_13563_n ) capacitor c=0.0138074f //x=7.71 \
 //y=5.56 //x2=8.065 //y2=7.585
cc_960 ( N_noxref_3_c_814_p N_VDD_c_13567_n ) capacitor c=0.00205906f \
 //x=8.475 //y=5.335 //x2=8.945 //y2=7.585
cc_961 ( N_noxref_3_c_794_n N_VDD_c_13567_n ) capacitor c=8.49654e-19 //x=8.59 \
 //y=5.56 //x2=8.945 //y2=7.585
cc_962 ( N_noxref_3_c_795_n N_VDD_c_13567_n ) capacitor c=0.00204238f \
 //x=9.285 //y=5.335 //x2=8.945 //y2=7.585
cc_963 ( N_noxref_3_c_822_p N_VDD_c_13567_n ) capacitor c=0.0135103f //x=8.59 \
 //y=5.56 //x2=8.945 //y2=7.585
cc_964 ( N_noxref_3_c_795_n N_VDD_c_13571_n ) capacitor c=0.00183742f \
 //x=9.285 //y=5.335 //x2=9.94 //y2=7.585
cc_965 ( N_noxref_3_M85_noxref_g N_VDD_c_13572_n ) capacitor c=0.00755614f \
 //x=21.04 //y=6.2 //x2=21.615 //y2=7.585
cc_966 ( N_noxref_3_M86_noxref_g N_VDD_c_13572_n ) capacitor c=0.00755544f \
 //x=21.48 //y=6.2 //x2=21.615 //y2=7.585
cc_967 ( N_noxref_3_c_736_n N_VDD_c_13461_n ) capacitor c=0.0022955f //x=6.832 \
 //y=5.335 //x2=5.3 //y2=7.585
cc_968 ( N_noxref_3_c_757_n N_VDD_c_13461_n ) capacitor c=0.00224736f //x=3.82 \
 //y=4.88 //x2=5.3 //y2=7.585
cc_969 ( N_noxref_3_c_761_n N_VDD_c_13461_n ) capacitor c=0.00509469f //x=6.83 \
 //y=5.56 //x2=5.3 //y2=7.585
cc_970 ( N_noxref_3_c_791_n N_VDD_c_13461_n ) capacitor c=2.63786e-19 //x=3.82 \
 //y=4.88 //x2=5.3 //y2=7.585
cc_971 ( N_noxref_3_c_794_n N_VDD_c_13467_n ) capacitor c=0.00282782f //x=8.59 \
 //y=5.56 //x2=10.11 //y2=7.585
cc_972 ( N_noxref_3_c_734_n N_VDD_c_13467_n ) capacitor c=0.0328868f //x=9.37 \
 //y=5.25 //x2=10.11 //y2=7.585
cc_973 ( N_noxref_3_c_822_p N_VDD_c_13467_n ) capacitor c=0.00777981f //x=8.59 \
 //y=5.56 //x2=10.11 //y2=7.585
cc_974 ( N_noxref_3_c_828_p N_VDD_c_13581_n ) capacitor c=0.0119138f //x=20.84 \
 //y=4.755 //x2=19.73 //y2=7.585
cc_975 ( N_noxref_3_c_944_p N_VDD_c_13581_n ) capacitor c=0.00370784f \
 //x=20.84 //y=4.88 //x2=19.73 //y2=7.585
cc_976 ( N_noxref_3_c_959_p N_VDD_c_13581_n ) capacitor c=0.00590568f \
 //x=21.115 //y=4.97 //x2=19.73 //y2=7.585
cc_977 ( N_noxref_3_M65_noxref_g N_VDD_M64_noxref_d ) capacitor c=0.015318f \
 //x=3.56 //y=6.2 //x2=3.195 //y2=5.2
cc_978 ( N_noxref_3_M66_noxref_g N_VDD_M66_noxref_d ) capacitor c=0.0394719f \
 //x=4 //y=6.2 //x2=4.075 //y2=5.2
cc_979 ( N_noxref_3_c_736_n N_VDD_M67_noxref_s ) capacitor c=0.0442713f \
 //x=6.832 //y=5.335 //x2=6.255 //y2=5.2
cc_980 ( N_noxref_3_c_910_p N_VDD_M67_noxref_s ) capacitor c=7.80122e-19 \
 //x=7.71 //y=5.335 //x2=6.255 //y2=5.2
cc_981 ( N_noxref_3_c_761_n N_VDD_M67_noxref_s ) capacitor c=0.09305f //x=6.83 \
 //y=5.56 //x2=6.255 //y2=5.2
cc_982 ( N_noxref_3_c_724_n N_VDD_M68_noxref_d ) capacitor c=0.00700141f \
 //x=7.59 //y=5.335 //x2=7.125 //y2=5.2
cc_983 ( N_noxref_3_c_761_n N_VDD_M68_noxref_d ) capacitor c=0.0674491f \
 //x=6.83 //y=5.56 //x2=7.125 //y2=5.2
cc_984 ( N_noxref_3_c_911_p N_VDD_M68_noxref_d ) capacitor c=0.0674762f \
 //x=7.71 //y=5.56 //x2=7.125 //y2=5.2
cc_985 ( N_noxref_3_c_814_p N_VDD_M70_noxref_d ) capacitor c=0.00700141f \
 //x=8.475 //y=5.335 //x2=8.005 //y2=5.2
cc_986 ( N_noxref_3_c_911_p N_VDD_M70_noxref_d ) capacitor c=0.067493f \
 //x=7.71 //y=5.56 //x2=8.005 //y2=5.2
cc_987 ( N_noxref_3_c_822_p N_VDD_M70_noxref_d ) capacitor c=0.0674979f \
 //x=8.59 //y=5.56 //x2=8.005 //y2=5.2
cc_988 ( N_noxref_3_c_795_n N_VDD_M72_noxref_d ) capacitor c=0.00700141f \
 //x=9.285 //y=5.335 //x2=8.885 //y2=5.2
cc_989 ( N_noxref_3_c_822_p N_VDD_M72_noxref_d ) capacitor c=0.0675002f \
 //x=8.59 //y=5.56 //x2=8.885 //y2=5.2
cc_990 ( N_noxref_3_c_794_n N_VDD_M73_noxref_s ) capacitor c=0.00492616f \
 //x=8.59 //y=5.56 //x2=11.065 //y2=5.2
cc_991 ( N_noxref_3_c_795_n N_VDD_M73_noxref_s ) capacitor c=9.42705e-19 \
 //x=9.285 //y=5.335 //x2=11.065 //y2=5.2
cc_992 ( N_noxref_3_c_910_p N_VDD_M73_noxref_s ) capacitor c=2.11884e-19 \
 //x=7.71 //y=5.335 //x2=11.065 //y2=5.2
cc_993 ( N_noxref_3_c_827_p N_VDD_M85_noxref_s ) capacitor c=6.00483e-19 \
 //x=20.84 //y=3.67 //x2=20.685 //y2=5.2
cc_994 ( N_noxref_3_c_828_p N_VDD_M85_noxref_s ) capacitor c=0.0217981f \
 //x=20.84 //y=4.755 //x2=20.685 //y2=5.2
cc_995 ( N_noxref_3_c_944_p N_VDD_M85_noxref_s ) capacitor c=0.00983846f \
 //x=20.84 //y=4.88 //x2=20.685 //y2=5.2
cc_996 ( N_noxref_3_M85_noxref_g N_VDD_M85_noxref_s ) capacitor c=0.053419f \
 //x=21.04 //y=6.2 //x2=20.685 //y2=5.2
cc_997 ( N_noxref_3_c_959_p N_VDD_M85_noxref_s ) capacitor c=0.00606273f \
 //x=21.115 //y=4.97 //x2=20.685 //y2=5.2
cc_998 ( N_noxref_3_M86_noxref_g N_VDD_M86_noxref_d ) capacitor c=0.015318f \
 //x=21.48 //y=6.2 //x2=21.555 //y2=5.2
cc_999 ( N_noxref_3_c_706_n N_noxref_26_c_14881_n ) capacitor c=0.00177186f \
 //x=3.82 //y=2.375 //x2=4.475 //y2=0.72
cc_1000 ( N_noxref_3_c_756_n N_noxref_26_c_14881_n ) capacitor c=0.00117306f \
 //x=3.82 //y=2.26 //x2=4.475 //y2=0.72
cc_1001 ( N_noxref_3_c_770_n N_noxref_26_c_14881_n ) capacitor c=0.0206349f \
 //x=3.81 //y=1.095 //x2=4.475 //y2=0.72
cc_1002 ( N_noxref_3_c_782_n N_noxref_26_c_14881_n ) capacitor c=0.00825432f \
 //x=4.34 //y=1.095 //x2=4.475 //y2=0.72
cc_1003 ( N_noxref_3_c_788_n N_noxref_26_c_14881_n ) capacitor c=2.20712e-19 \
 //x=3.82 //y=2.26 //x2=4.475 //y2=0.72
cc_1004 ( N_noxref_3_c_772_n N_noxref_26_c_14884_n ) capacitor c=0.0071177f \
 //x=3.81 //y=1.44 //x2=3.59 //y2=1.175
cc_1005 ( N_noxref_3_c_770_n N_noxref_26_M2_noxref_s ) capacitor c=0.0071177f \
 //x=3.81 //y=1.095 //x2=3.455 //y2=0.555
cc_1006 ( N_noxref_3_c_775_n N_noxref_26_M2_noxref_s ) capacitor c=0.0071177f \
 //x=3.81 //y=1.75 //x2=3.455 //y2=0.555
cc_1007 ( N_noxref_3_c_782_n N_noxref_26_M2_noxref_s ) capacitor c=0.015333f \
 //x=4.34 //y=1.095 //x2=3.455 //y2=0.555
cc_1008 ( N_noxref_3_c_784_n N_noxref_26_M2_noxref_s ) capacitor c=0.00248746f \
 //x=4.34 //y=1.44 //x2=3.455 //y2=0.555
cc_1009 ( N_noxref_3_c_861_p N_noxref_27_c_14948_n ) capacitor c=0.0036878f \
 //x=8.885 //y=1.305 //x2=9.285 //y2=0.72
cc_1010 ( N_noxref_3_c_796_n N_noxref_27_c_14948_n ) capacitor c=0.00399931f \
 //x=9.285 //y=1.845 //x2=9.285 //y2=0.72
cc_1011 ( N_noxref_3_M5_noxref_d N_noxref_27_c_14948_n ) capacitor \
 c=0.00910163f //x=8.695 //y=1.095 //x2=9.285 //y2=0.72
cc_1012 ( N_noxref_3_M5_noxref_d N_noxref_27_c_14951_n ) capacitor \
 c=0.00120711f //x=8.695 //y=1.095 //x2=8.4 //y2=1.175
cc_1013 ( N_noxref_3_c_724_n N_noxref_27_M4_noxref_d ) capacitor c=0.00151601f \
 //x=7.59 //y=5.335 //x2=7.16 //y2=1.09
cc_1014 ( N_noxref_3_c_861_p N_noxref_27_M4_noxref_d ) capacitor c=0.00802417f \
 //x=8.885 //y=1.305 //x2=7.16 //y2=1.09
cc_1015 ( N_noxref_3_c_861_p N_noxref_27_M5_noxref_s ) capacitor c=0.0098487f \
 //x=8.885 //y=1.305 //x2=8.265 //y2=0.555
cc_1016 ( N_noxref_3_c_864_p N_noxref_27_M5_noxref_s ) capacitor c=0.0283243f \
 //x=8.885 //y=1.76 //x2=8.265 //y2=0.555
cc_1017 ( N_noxref_3_c_796_n N_noxref_27_M5_noxref_s ) capacitor c=0.00871957f \
 //x=9.285 //y=1.845 //x2=8.265 //y2=0.555
cc_1018 ( N_noxref_3_c_811_p N_noxref_27_M5_noxref_s ) capacitor c=0.0016218f \
 //x=9.37 //y=3.51 //x2=8.265 //y2=0.555
cc_1019 ( N_noxref_3_M5_noxref_d N_noxref_27_M5_noxref_s ) capacitor \
 c=0.0279003f //x=8.695 //y=1.095 //x2=8.265 //y2=0.555
cc_1020 ( N_noxref_3_c_861_p N_noxref_28_M7_noxref_d ) capacitor c=3.20746e-19 \
 //x=8.885 //y=1.305 //x2=11.97 //y2=1.09
cc_1021 ( N_noxref_3_c_706_n N_GND_c_16390_n ) capacitor c=0.00196498f \
 //x=3.82 //y=2.375 //x2=6.29 //y2=0.175
cc_1022 ( N_noxref_3_c_861_p N_GND_c_16501_n ) capacitor c=0.00884249f \
 //x=8.885 //y=1.305 //x2=11.1 //y2=0.175
cc_1023 ( N_noxref_3_c_796_n N_GND_c_16501_n ) capacitor c=0.00662992f \
 //x=9.285 //y=1.845 //x2=11.1 //y2=0.175
cc_1024 ( N_noxref_3_c_732_n N_GND_c_16501_n ) capacitor c=2.95105e-19 \
 //x=9.37 //y=3.655 //x2=11.1 //y2=0.175
cc_1025 ( N_noxref_3_M5_noxref_d N_GND_c_16501_n ) capacitor c=2.9462e-19 \
 //x=8.695 //y=1.095 //x2=11.1 //y2=0.175
cc_1026 ( N_noxref_3_c_1008_p N_GND_c_16505_n ) capacitor c=3.97665e-19 \
 //x=20.54 //y=1.055 //x2=20.805 //y2=1.015
cc_1027 ( N_noxref_3_c_1129_p N_GND_c_16505_n ) capacitor c=0.00864776f \
 //x=20.915 //y=0.9 //x2=20.805 //y2=1.015
cc_1028 ( N_noxref_3_c_1010_p N_GND_c_16505_n ) capacitor c=4.45447e-19 \
 //x=21.07 //y=1.055 //x2=20.805 //y2=1.015
cc_1029 ( N_noxref_3_c_861_p N_GND_c_16411_n ) capacitor c=0.00543195f \
 //x=8.885 //y=1.305 //x2=11.185 //y2=1.145
cc_1030 ( N_noxref_3_c_825_p N_GND_c_16509_n ) capacitor c=0.00772482f \
 //x=20.84 //y=2.375 //x2=20.805 //y2=1.145
cc_1031 ( N_noxref_3_c_827_p N_GND_c_16509_n ) capacitor c=7.73977e-19 \
 //x=20.84 //y=3.67 //x2=20.805 //y2=1.145
cc_1032 ( N_noxref_3_c_954_p N_GND_c_16509_n ) capacitor c=2.22883e-19 \
 //x=20.84 //y=2.26 //x2=20.805 //y2=1.145
cc_1033 ( N_noxref_3_c_1008_p N_GND_c_16509_n ) capacitor c=0.00156339f \
 //x=20.54 //y=1.055 //x2=20.805 //y2=1.145
cc_1034 ( N_noxref_3_c_1009_p N_GND_c_16509_n ) capacitor c=0.00352472f \
 //x=20.54 //y=1.4 //x2=20.805 //y2=1.145
cc_1035 ( N_noxref_3_c_1011_p N_GND_c_16509_n ) capacitor c=4.26589e-19 \
 //x=20.54 //y=1.71 //x2=20.805 //y2=1.145
cc_1036 ( N_noxref_3_c_1129_p N_GND_c_16509_n ) capacitor c=9.36995e-19 \
 //x=20.915 //y=0.9 //x2=20.805 //y2=1.145
cc_1037 ( N_noxref_3_c_1139_p N_GND_c_16509_n ) capacitor c=5.79272e-19 \
 //x=20.915 //y=1.555 //x2=20.805 //y2=1.145
cc_1038 ( N_noxref_3_c_1010_p N_GND_c_16509_n ) capacitor c=0.0017438f \
 //x=21.07 //y=1.055 //x2=20.805 //y2=1.145
cc_1039 ( N_noxref_3_c_1012_p N_GND_c_16509_n ) capacitor c=0.00276804f \
 //x=21.07 //y=1.4 //x2=20.805 //y2=1.145
cc_1040 ( N_noxref_3_c_706_n N_GND_c_16421_n ) capacitor c=2.016e-19 //x=3.82 \
 //y=2.375 //x2=5.13 //y2=0.175
cc_1041 ( N_noxref_3_c_796_n N_GND_c_16423_n ) capacitor c=6.86343e-19 \
 //x=9.285 //y=1.845 //x2=9.94 //y2=0.175
cc_1042 ( N_noxref_3_c_732_n N_GND_c_16423_n ) capacitor c=4.03806e-19 \
 //x=9.37 //y=3.655 //x2=9.94 //y2=0.175
cc_1043 ( N_noxref_3_c_1008_p N_GND_c_16522_n ) capacitor c=0.00677766f \
 //x=20.54 //y=1.055 //x2=24.37 //y2=0.175
cc_1044 ( N_noxref_3_c_746_n N_GND_c_16425_n ) capacitor c=0.00341388f \
 //x=9.21 //y=3.495 //x2=5.3 //y2=0.175
cc_1045 ( N_noxref_3_c_756_n N_GND_c_16425_n ) capacitor c=0.00222376f \
 //x=3.82 //y=2.26 //x2=5.3 //y2=0.175
cc_1046 ( N_noxref_3_c_784_n N_GND_c_16425_n ) capacitor c=0.00262688f \
 //x=4.34 //y=1.44 //x2=5.3 //y2=0.175
cc_1047 ( N_noxref_3_c_788_n N_GND_c_16425_n ) capacitor c=2.63786e-19 \
 //x=3.82 //y=2.26 //x2=5.3 //y2=0.175
cc_1048 ( N_noxref_3_c_864_p N_GND_c_16438_n ) capacitor c=0.0045138f \
 //x=8.885 //y=1.76 //x2=10.11 //y2=0.175
cc_1049 ( N_noxref_3_c_796_n N_GND_c_16438_n ) capacitor c=0.0304827f \
 //x=9.285 //y=1.845 //x2=10.11 //y2=0.175
cc_1050 ( N_noxref_3_c_741_n N_GND_c_16438_n ) capacitor c=0.00341388f \
 //x=20.675 //y=3.51 //x2=10.11 //y2=0.175
cc_1051 ( N_noxref_3_c_825_p N_GND_c_16530_n ) capacitor c=0.00358368f \
 //x=20.84 //y=2.375 //x2=19.73 //y2=0.175
cc_1052 ( N_noxref_3_c_826_p N_GND_c_16530_n ) capacitor c=0.00963712f \
 //x=20.84 //y=3.35 //x2=19.73 //y2=0.175
cc_1053 ( N_noxref_3_c_954_p N_GND_c_16530_n ) capacitor c=0.0039621f \
 //x=20.84 //y=2.26 //x2=19.73 //y2=0.175
cc_1054 ( N_noxref_3_c_1011_p N_GND_c_16530_n ) capacitor c=0.00170145f \
 //x=20.54 //y=1.71 //x2=19.73 //y2=0.175
cc_1055 ( N_noxref_3_c_955_p N_GND_c_16530_n ) capacitor c=0.0102191f \
 //x=20.54 //y=2.095 //x2=19.73 //y2=0.175
cc_1056 ( N_noxref_3_c_825_p N_GND_M12_noxref_d ) capacitor c=4.4417e-19 \
 //x=20.84 //y=2.375 //x2=20.615 //y2=1.055
cc_1057 ( N_noxref_3_c_1008_p N_GND_M12_noxref_d ) capacitor c=0.00184354f \
 //x=20.54 //y=1.055 //x2=20.615 //y2=1.055
cc_1058 ( N_noxref_3_c_1009_p N_GND_M12_noxref_d ) capacitor c=0.00210798f \
 //x=20.54 //y=1.4 //x2=20.615 //y2=1.055
cc_1059 ( N_noxref_3_c_1129_p N_GND_M12_noxref_d ) capacitor c=0.00474029f \
 //x=20.915 //y=0.9 //x2=20.615 //y2=1.055
cc_1060 ( N_noxref_3_c_1139_p N_GND_M12_noxref_d ) capacitor c=0.00166857f \
 //x=20.915 //y=1.555 //x2=20.615 //y2=1.055
cc_1061 ( N_noxref_3_c_1010_p N_GND_M12_noxref_d ) capacitor c=0.00230174f \
 //x=21.07 //y=1.055 //x2=20.615 //y2=1.055
cc_1062 ( N_noxref_3_c_1012_p N_GND_M12_noxref_d ) capacitor c=0.00210798f \
 //x=21.07 //y=1.4 //x2=20.615 //y2=1.055
cc_1063 ( N_noxref_3_c_955_p N_noxref_51_c_18364_n ) capacitor c=0.00262672f \
 //x=20.54 //y=2.095 //x2=20.32 //y2=1.685
cc_1064 ( N_noxref_3_c_825_p N_noxref_51_c_18365_n ) capacitor c=0.00428451f \
 //x=20.84 //y=2.375 //x2=21.205 //y2=1.77
cc_1065 ( N_noxref_3_c_827_p N_noxref_51_c_18365_n ) capacitor c=0.00260186f \
 //x=20.84 //y=3.67 //x2=21.205 //y2=1.77
cc_1066 ( N_noxref_3_c_954_p N_noxref_51_c_18365_n ) capacitor c=0.0104666f \
 //x=20.84 //y=2.26 //x2=21.205 //y2=1.77
cc_1067 ( N_noxref_3_c_1011_p N_noxref_51_c_18365_n ) capacitor c=0.00705077f \
 //x=20.54 //y=1.71 //x2=21.205 //y2=1.77
cc_1068 ( N_noxref_3_c_955_p N_noxref_51_c_18365_n ) capacitor c=0.020708f \
 //x=20.54 //y=2.095 //x2=21.205 //y2=1.77
cc_1069 ( N_noxref_3_c_1139_p N_noxref_51_c_18365_n ) capacitor c=0.00588627f \
 //x=20.915 //y=1.555 //x2=21.205 //y2=1.77
cc_1070 ( N_noxref_3_c_1012_p N_noxref_51_c_18365_n ) capacitor c=0.00698822f \
 //x=21.07 //y=1.4 //x2=21.205 //y2=1.77
cc_1071 ( N_noxref_3_c_1008_p N_noxref_51_M12_noxref_s ) capacitor \
 c=0.0295256f //x=20.54 //y=1.055 //x2=20.185 //y2=0.555
cc_1072 ( N_noxref_3_c_1011_p N_noxref_51_M12_noxref_s ) capacitor \
 c=7.99997e-19 //x=20.54 //y=1.71 //x2=20.185 //y2=0.555
cc_1073 ( N_noxref_3_c_955_p N_noxref_51_M12_noxref_s ) capacitor \
 c=0.00122123f //x=20.54 //y=2.095 //x2=20.185 //y2=0.555
cc_1074 ( N_noxref_3_c_1010_p N_noxref_51_M12_noxref_s ) capacitor \
 c=0.0125924f //x=21.07 //y=1.055 //x2=20.185 //y2=0.555
cc_1075 ( N_noxref_4_c_1178_n N_noxref_5_c_1623_n ) capacitor c=6.09703e-19 \
 //x=21.262 //y=5.335 //x2=18.21 //y2=5.56
cc_1076 ( N_noxref_4_c_1178_n N_noxref_5_c_1624_n ) capacitor c=0.00306432f \
 //x=21.262 //y=5.335 //x2=18.905 //y2=5.335
cc_1077 ( N_noxref_4_c_1186_p N_noxref_5_c_1625_n ) capacitor c=0.00163399f \
 //x=23.4 //y=1.845 //x2=18.905 //y2=1.845
cc_1078 ( N_noxref_4_c_1187_p N_noxref_5_c_1626_n ) capacitor c=2.76107e-19 \
 //x=25.65 //y=2.595 //x2=27.87 //y2=3.725
cc_1079 ( N_noxref_4_c_1188_p N_noxref_5_c_1626_n ) capacitor c=0.0010345f \
 //x=25.65 //y=4.755 //x2=27.87 //y2=3.725
cc_1080 ( N_noxref_4_c_1188_p N_noxref_5_c_1628_n ) capacitor c=5.73787e-19 \
 //x=25.65 //y=4.755 //x2=27.87 //y2=4.75
cc_1081 ( N_noxref_4_c_1190_p N_noxref_5_c_1574_n ) capacitor c=0.0233632f \
 //x=23.8 //y=5.25 //x2=21.05 //y2=3.895
cc_1082 ( N_noxref_4_c_1188_p N_noxref_5_c_1574_n ) capacitor c=0.024803f \
 //x=25.65 //y=4.755 //x2=21.05 //y2=3.895
cc_1083 ( N_noxref_4_c_1192_p N_noxref_6_c_2069_n ) capacitor c=0.0134952f \
 //x=23.8 //y=2.595 //x2=23.06 //y2=2.375
cc_1084 ( N_noxref_4_c_1192_p N_noxref_6_c_2065_n ) capacitor c=0.00777198f \
 //x=23.8 //y=2.595 //x2=23.06 //y2=3.365
cc_1085 ( N_noxref_4_c_1194_p N_noxref_6_c_2065_n ) capacitor c=0.015613f \
 //x=23.8 //y=2.915 //x2=23.06 //y2=3.365
cc_1086 ( N_noxref_4_c_1190_p N_noxref_6_c_2065_n ) capacitor c=0.0182303f \
 //x=23.8 //y=5.25 //x2=23.06 //y2=3.365
cc_1087 ( N_noxref_4_c_1187_p N_noxref_6_c_2065_n ) capacitor c=4.0519e-19 \
 //x=25.65 //y=2.595 //x2=23.06 //y2=3.365
cc_1088 ( N_noxref_4_c_1188_p N_noxref_6_c_2065_n ) capacitor c=3.13322e-19 \
 //x=25.65 //y=4.755 //x2=23.06 //y2=3.365
cc_1089 ( N_noxref_4_c_1198_p N_noxref_6_c_2065_n ) capacitor c=7.6985e-19 \
 //x=23.8 //y=2.77 //x2=23.06 //y2=3.365
cc_1090 ( N_noxref_4_c_1199_p N_noxref_6_c_2065_n ) capacitor c=0.00697965f \
 //x=23.945 //y=2.755 //x2=23.06 //y2=3.365
cc_1091 ( N_noxref_4_c_1200_p N_noxref_6_c_2077_n ) capacitor c=7.29766e-19 \
 //x=22.905 //y=5.335 //x2=23.06 //y2=3.655
cc_1092 ( N_noxref_4_c_1201_p N_noxref_6_c_2077_n ) capacitor c=0.00106027f \
 //x=23.715 //y=5.335 //x2=23.06 //y2=3.655
cc_1093 ( N_noxref_4_c_1202_p N_noxref_6_c_2077_n ) capacitor c=2.27923e-19 \
 //x=23.315 //y=1.305 //x2=23.06 //y2=3.655
cc_1094 ( N_noxref_4_c_1186_p N_noxref_6_c_2077_n ) capacitor c=0.00103023f \
 //x=23.4 //y=1.845 //x2=23.06 //y2=3.655
cc_1095 ( N_noxref_4_c_1190_p N_noxref_6_c_2077_n ) capacitor c=0.0164174f \
 //x=23.8 //y=5.25 //x2=23.06 //y2=3.655
cc_1096 ( N_noxref_4_c_1201_p N_noxref_6_c_2066_n ) capacitor c=0.00228791f \
 //x=23.715 //y=5.335 //x2=23.06 //y2=4.75
cc_1097 ( N_noxref_4_c_1190_p N_noxref_6_c_2066_n ) capacitor c=0.0577991f \
 //x=23.8 //y=5.25 //x2=23.06 //y2=4.75
cc_1098 ( N_noxref_4_c_1188_p N_noxref_6_c_2066_n ) capacitor c=0.00107571f \
 //x=25.65 //y=4.755 //x2=23.06 //y2=4.75
cc_1099 ( N_noxref_4_c_1208_p N_noxref_6_c_2066_n ) capacitor c=0.0228808f \
 //x=23.02 //y=5.335 //x2=23.06 //y2=4.75
cc_1100 ( N_noxref_4_c_1209_p N_noxref_6_c_2066_n ) capacitor c=0.00217653f \
 //x=23.02 //y=5.56 //x2=23.06 //y2=4.75
cc_1101 ( N_noxref_4_M92_noxref_g N_noxref_6_c_2087_n ) capacitor \
 c=0.00893512f //x=26.29 //y=6.2 //x2=26.83 //y2=5.335
cc_1102 ( N_noxref_4_c_1211_p N_noxref_6_c_2088_n ) capacitor c=0.00163399f \
 //x=23.715 //y=1.845 //x2=28.21 //y2=1.845
cc_1103 ( N_noxref_4_c_1190_p N_noxref_6_c_2067_n ) capacitor c=0.0010679f \
 //x=23.8 //y=5.25 //x2=23.06 //y2=3.51
cc_1104 ( N_noxref_4_c_1213_p N_noxref_6_c_2090_n ) capacitor c=6.09703e-19 \
 //x=23.02 //y=5.56 //x2=26.072 //y2=5.335
cc_1105 ( N_noxref_4_c_1201_p N_noxref_6_c_2090_n ) capacitor c=0.00306432f \
 //x=23.715 //y=5.335 //x2=26.072 //y2=5.335
cc_1106 ( N_noxref_4_M91_noxref_g N_noxref_6_c_2090_n ) capacitor \
 c=0.00461408f //x=25.85 //y=6.2 //x2=26.072 //y2=5.335
cc_1107 ( N_noxref_4_M92_noxref_g N_noxref_6_c_2090_n ) capacitor \
 c=0.00229208f //x=26.29 //y=6.2 //x2=26.072 //y2=5.335
cc_1108 ( N_noxref_4_c_1217_p N_noxref_6_c_2090_n ) capacitor c=0.00171885f \
 //x=26.215 //y=4.97 //x2=26.072 //y2=5.335
cc_1109 ( N_noxref_4_c_1190_p N_noxref_6_c_2095_n ) capacitor c=0.0222573f \
 //x=23.8 //y=5.25 //x2=26.375 //y2=3.51
cc_1110 ( N_noxref_4_c_1188_p N_noxref_6_c_2095_n ) capacitor c=0.0252489f \
 //x=25.65 //y=4.755 //x2=26.375 //y2=3.51
cc_1111 ( N_noxref_4_c_1220_p N_noxref_6_c_2095_n ) capacitor c=0.0085558f \
 //x=25.49 //y=2.755 //x2=26.375 //y2=3.51
cc_1112 ( N_noxref_4_c_1190_p N_noxref_6_c_2068_n ) capacitor c=0.0026188f \
 //x=23.8 //y=5.25 //x2=23.22 //y2=3.51
cc_1113 ( N_noxref_4_c_1192_p N_noxref_6_c_2099_n ) capacitor c=0.0015536f \
 //x=23.8 //y=2.595 //x2=23.06 //y2=2.26
cc_1114 ( N_noxref_4_c_1201_p N_noxref_6_c_2100_n ) capacitor c=0.00130631f \
 //x=23.715 //y=5.335 //x2=23.06 //y2=4.88
cc_1115 ( N_noxref_4_c_1190_p N_noxref_6_c_2100_n ) capacitor c=0.00131258f \
 //x=23.8 //y=5.25 //x2=23.06 //y2=4.88
cc_1116 ( N_noxref_4_c_1208_p N_noxref_6_c_2100_n ) capacitor c=0.00346456f \
 //x=23.02 //y=5.335 //x2=23.06 //y2=4.88
cc_1117 ( N_noxref_4_c_1209_p N_noxref_6_c_2100_n ) capacitor c=0.00624059f \
 //x=23.02 //y=5.56 //x2=23.06 //y2=4.88
cc_1118 ( N_noxref_4_M91_noxref_g N_noxref_6_c_2104_n ) capacitor c=0.0162284f \
 //x=25.85 //y=6.2 //x2=26.07 //y2=5.56
cc_1119 ( N_noxref_4_M92_noxref_g N_noxref_6_c_2104_n ) capacitor c=0.0179041f \
 //x=26.29 //y=6.2 //x2=26.07 //y2=5.56
cc_1120 ( N_noxref_4_c_1217_p N_noxref_6_c_2104_n ) capacitor c=0.00291477f \
 //x=26.215 //y=4.97 //x2=26.07 //y2=5.56
cc_1121 ( N_noxref_4_c_1200_p N_noxref_6_M89_noxref_g ) capacitor \
 c=0.00955829f //x=22.905 //y=5.335 //x2=22.8 //y2=6.2
cc_1122 ( N_noxref_4_c_1213_p N_noxref_6_M89_noxref_g ) capacitor \
 c=0.00226521f //x=23.02 //y=5.56 //x2=22.8 //y2=6.2
cc_1123 ( N_noxref_4_c_1209_p N_noxref_6_M89_noxref_g ) capacitor c=0.0178885f \
 //x=23.02 //y=5.56 //x2=22.8 //y2=6.2
cc_1124 ( N_noxref_4_c_1213_p N_noxref_6_M90_noxref_g ) capacitor \
 c=0.00381703f //x=23.02 //y=5.56 //x2=23.24 //y2=6.2
cc_1125 ( N_noxref_4_c_1201_p N_noxref_6_M90_noxref_g ) capacitor c=0.0110532f \
 //x=23.715 //y=5.335 //x2=23.24 //y2=6.2
cc_1126 ( N_noxref_4_c_1209_p N_noxref_6_M90_noxref_g ) capacitor c=0.0188608f \
 //x=23.02 //y=5.56 //x2=23.24 //y2=6.2
cc_1127 ( N_noxref_4_c_1202_p N_noxref_6_c_2113_n ) capacitor c=4.64015e-19 \
 //x=23.315 //y=1.305 //x2=23.05 //y2=1.095
cc_1128 ( N_noxref_4_M14_noxref_d N_noxref_6_c_2113_n ) capacitor \
 c=0.00137165f //x=23.125 //y=1.095 //x2=23.05 //y2=1.095
cc_1129 ( N_noxref_4_c_1202_p N_noxref_6_c_2115_n ) capacitor c=0.0026012f \
 //x=23.315 //y=1.305 //x2=23.05 //y2=1.44
cc_1130 ( N_noxref_4_c_1239_p N_noxref_6_c_2115_n ) capacitor c=0.00127432f \
 //x=23.315 //y=1.76 //x2=23.05 //y2=1.44
cc_1131 ( N_noxref_4_M14_noxref_d N_noxref_6_c_2115_n ) capacitor \
 c=0.00237422f //x=23.125 //y=1.095 //x2=23.05 //y2=1.44
cc_1132 ( N_noxref_4_c_1239_p N_noxref_6_c_2118_n ) capacitor c=0.00429966f \
 //x=23.315 //y=1.76 //x2=23.05 //y2=1.75
cc_1133 ( N_noxref_4_c_1202_p N_noxref_6_c_2119_n ) capacitor c=5.29969e-19 \
 //x=23.315 //y=1.305 //x2=23.425 //y2=0.94
cc_1134 ( N_noxref_4_M14_noxref_d N_noxref_6_c_2119_n ) capacitor c=0.0020782f \
 //x=23.125 //y=1.095 //x2=23.425 //y2=0.94
cc_1135 ( N_noxref_4_c_1202_p N_noxref_6_c_2121_n ) capacitor c=5.01873e-19 \
 //x=23.315 //y=1.305 //x2=23.425 //y2=1.595
cc_1136 ( N_noxref_4_c_1239_p N_noxref_6_c_2121_n ) capacitor c=0.00942306f \
 //x=23.315 //y=1.76 //x2=23.425 //y2=1.595
cc_1137 ( N_noxref_4_c_1211_p N_noxref_6_c_2121_n ) capacitor c=0.00194716f \
 //x=23.715 //y=1.845 //x2=23.425 //y2=1.595
cc_1138 ( N_noxref_4_M14_noxref_d N_noxref_6_c_2121_n ) capacitor \
 c=0.00356097f //x=23.125 //y=1.095 //x2=23.425 //y2=1.595
cc_1139 ( N_noxref_4_c_1202_p N_noxref_6_c_2125_n ) capacitor c=5.24634e-19 \
 //x=23.315 //y=1.305 //x2=23.58 //y2=1.095
cc_1140 ( N_noxref_4_M14_noxref_d N_noxref_6_c_2125_n ) capacitor \
 c=0.00139206f //x=23.125 //y=1.095 //x2=23.58 //y2=1.095
cc_1141 ( N_noxref_4_c_1202_p N_noxref_6_c_2127_n ) capacitor c=0.00307978f \
 //x=23.315 //y=1.305 //x2=23.58 //y2=1.44
cc_1142 ( N_noxref_4_c_1239_p N_noxref_6_c_2127_n ) capacitor c=0.00363411f \
 //x=23.315 //y=1.76 //x2=23.58 //y2=1.44
cc_1143 ( N_noxref_4_c_1211_p N_noxref_6_c_2127_n ) capacitor c=0.00323576f \
 //x=23.715 //y=1.845 //x2=23.58 //y2=1.44
cc_1144 ( N_noxref_4_M14_noxref_d N_noxref_6_c_2127_n ) capacitor \
 c=0.00237422f //x=23.125 //y=1.095 //x2=23.58 //y2=1.44
cc_1145 ( N_noxref_4_c_1192_p N_noxref_6_c_2131_n ) capacitor c=0.00242474f \
 //x=23.8 //y=2.595 //x2=23.06 //y2=2.26
cc_1146 ( N_noxref_4_c_1239_p N_noxref_6_c_2132_n ) capacitor c=0.0036273f \
 //x=23.315 //y=1.76 //x2=23.06 //y2=2.095
cc_1147 ( N_noxref_4_c_1192_p N_noxref_6_c_2132_n ) capacitor c=0.00282067f \
 //x=23.8 //y=2.595 //x2=23.06 //y2=2.095
cc_1148 ( N_noxref_4_c_1190_p N_noxref_6_c_2134_n ) capacitor c=0.00739875f \
 //x=23.8 //y=5.25 //x2=23.06 //y2=4.88
cc_1149 ( N_noxref_4_c_1208_p N_noxref_6_c_2134_n ) capacitor c=0.00203307f \
 //x=23.02 //y=5.335 //x2=23.06 //y2=4.88
cc_1150 ( N_noxref_4_c_1209_p N_noxref_6_c_2134_n ) capacitor c=0.00375636f \
 //x=23.02 //y=5.56 //x2=23.06 //y2=4.88
cc_1151 ( N_noxref_4_c_1190_p N_D_c_5143_n ) capacitor c=0.0233585f //x=23.8 \
 //y=5.25 //x2=27.485 //y2=4.25
cc_1152 ( N_noxref_4_c_1188_p N_D_c_5143_n ) capacitor c=0.0247975f //x=25.65 \
 //y=4.755 //x2=27.485 //y2=4.25
cc_1153 ( N_noxref_4_c_1201_p N_CLK_c_6473_n ) capacitor c=0.0210748f \
 //x=23.715 //y=5.335 //x2=28.395 //y2=4.61
cc_1154 ( N_noxref_4_c_1190_p N_CLK_c_6473_n ) capacitor c=0.0300565f //x=23.8 \
 //y=5.25 //x2=28.395 //y2=4.61
cc_1155 ( N_noxref_4_c_1188_p N_CLK_c_6473_n ) capacitor c=0.033021f //x=25.65 \
 //y=4.755 //x2=28.395 //y2=4.61
cc_1156 ( N_noxref_4_c_1178_n N_CLK_c_6473_n ) capacitor c=0.0297739f \
 //x=21.262 //y=5.335 //x2=28.395 //y2=4.61
cc_1157 ( N_noxref_4_c_1266_p N_CLK_c_6473_n ) capacitor c=0.0399347f \
 //x=22.14 //y=5.335 //x2=28.395 //y2=4.61
cc_1158 ( N_noxref_4_c_1190_p RN ) capacitor c=0.00230993f //x=23.8 //y=5.25 \
 //x2=21.95 //y2=2.77
cc_1159 ( N_noxref_4_c_1177_n N_RN_c_7926_n ) capacitor c=3.77334e-19 \
 //x=22.02 //y=5.335 //x2=21.95 //y2=2.57
cc_1160 ( N_noxref_4_c_1266_p N_RN_c_7926_n ) capacitor c=4.13352e-19 \
 //x=22.14 //y=5.335 //x2=21.95 //y2=2.57
cc_1161 ( N_noxref_4_c_1177_n N_RN_c_7930_n ) capacitor c=0.0213631f //x=22.02 \
 //y=5.335 //x2=21.95 //y2=4.765
cc_1162 ( N_noxref_4_c_1266_p N_RN_c_7930_n ) capacitor c=0.00239361f \
 //x=22.14 //y=5.335 //x2=21.95 //y2=4.765
cc_1163 ( N_noxref_4_c_1272_p N_RN_c_7930_n ) capacitor c=7.85344e-19 \
 //x=22.14 //y=5.56 //x2=21.95 //y2=4.765
cc_1164 ( N_noxref_4_c_1192_p N_RN_c_8006_n ) capacitor c=0.0272396f //x=23.8 \
 //y=2.595 //x2=24 //y2=2.37
cc_1165 ( N_noxref_4_c_1194_p N_RN_c_8006_n ) capacitor c=0.00582133f //x=23.8 \
 //y=2.915 //x2=24 //y2=2.37
cc_1166 ( N_noxref_4_c_1199_p N_RN_c_8006_n ) capacitor c=0.0365231f \
 //x=23.945 //y=2.755 //x2=24 //y2=2.37
cc_1167 ( N_noxref_4_c_1220_p N_RN_c_8006_n ) capacitor c=0.13334f //x=25.49 \
 //y=2.755 //x2=24 //y2=2.37
cc_1168 ( N_noxref_4_c_1202_p N_RN_c_7953_n ) capacitor c=6.89366e-19 \
 //x=23.315 //y=1.305 //x2=23.57 //y2=2.37
cc_1169 ( N_noxref_4_c_1211_p N_RN_c_7953_n ) capacitor c=0.00926071f \
 //x=23.715 //y=1.845 //x2=23.57 //y2=2.37
cc_1170 ( N_noxref_4_c_1186_p N_RN_c_7953_n ) capacitor c=0.0114124f //x=23.4 \
 //y=1.845 //x2=23.57 //y2=2.37
cc_1171 ( N_noxref_4_c_1192_p N_RN_c_7953_n ) capacitor c=6.07626e-19 //x=23.8 \
 //y=2.595 //x2=23.57 //y2=2.37
cc_1172 ( N_noxref_4_c_1192_p N_RN_c_8014_n ) capacitor c=2.0413e-19 //x=23.8 \
 //y=2.595 //x2=25.265 //y2=2.4
cc_1173 ( N_noxref_4_c_1187_p N_RN_c_8014_n ) capacitor c=0.00100591f \
 //x=25.65 //y=2.595 //x2=25.265 //y2=2.4
cc_1174 ( N_noxref_4_c_1283_p N_RN_c_8014_n ) capacitor c=0.00322016f \
 //x=25.65 //y=2.915 //x2=25.265 //y2=2.4
cc_1175 ( N_noxref_4_c_1220_p N_RN_c_8014_n ) capacitor c=0.0106621f //x=25.49 \
 //y=2.755 //x2=25.265 //y2=2.4
cc_1176 ( N_noxref_4_c_1285_p N_RN_c_8018_n ) capacitor c=0.0181219f //x=25.65 \
 //y=2.375 //x2=25.865 //y2=2.37
cc_1177 ( N_noxref_4_c_1187_p N_RN_c_8018_n ) capacitor c=0.0105258f //x=25.65 \
 //y=2.595 //x2=25.865 //y2=2.37
cc_1178 ( N_noxref_4_c_1283_p N_RN_c_8018_n ) capacitor c=0.00454054f \
 //x=25.65 //y=2.915 //x2=25.865 //y2=2.37
cc_1179 ( N_noxref_4_c_1288_p N_RN_c_8018_n ) capacitor c=0.0370412f //x=25.65 \
 //y=2.755 //x2=25.865 //y2=2.37
cc_1180 ( N_noxref_4_c_1289_p N_RN_c_8018_n ) capacitor c=5.18204e-19 \
 //x=25.65 //y=2.26 //x2=25.865 //y2=2.37
cc_1181 ( N_noxref_4_c_1290_p N_RN_c_8018_n ) capacitor c=3.41298e-19 \
 //x=25.35 //y=2.095 //x2=25.865 //y2=2.37
cc_1182 ( N_noxref_4_c_1187_p N_RN_c_8024_n ) capacitor c=7.5617e-19 //x=25.65 \
 //y=2.595 //x2=42.825 //y2=2.385
cc_1183 ( N_noxref_4_c_1177_n N_RN_c_7964_n ) capacitor c=0.00492634f \
 //x=22.02 //y=5.335 //x2=21.95 //y2=4.88
cc_1184 ( N_noxref_4_c_1266_p N_RN_c_7964_n ) capacitor c=0.00132214f \
 //x=22.14 //y=5.335 //x2=21.95 //y2=4.88
cc_1185 ( N_noxref_4_c_1177_n N_RN_M87_noxref_g ) capacitor c=0.00858241f \
 //x=22.02 //y=5.335 //x2=21.92 //y2=6.2
cc_1186 ( N_noxref_4_c_1266_p N_RN_M87_noxref_g ) capacitor c=0.00229818f \
 //x=22.14 //y=5.335 //x2=21.92 //y2=6.2
cc_1187 ( N_noxref_4_c_1272_p N_RN_M87_noxref_g ) capacitor c=0.0179041f \
 //x=22.14 //y=5.56 //x2=21.92 //y2=6.2
cc_1188 ( N_noxref_4_c_1200_p N_RN_M88_noxref_g ) capacitor c=0.00955829f \
 //x=22.905 //y=5.335 //x2=22.36 //y2=6.2
cc_1189 ( N_noxref_4_c_1266_p N_RN_M88_noxref_g ) capacitor c=0.00230699f \
 //x=22.14 //y=5.335 //x2=22.36 //y2=6.2
cc_1190 ( N_noxref_4_c_1272_p N_RN_M88_noxref_g ) capacitor c=0.0179041f \
 //x=22.14 //y=5.56 //x2=22.36 //y2=6.2
cc_1191 ( N_noxref_4_c_1266_p N_RN_c_8033_n ) capacitor c=0.0017897f //x=22.14 \
 //y=5.335 //x2=22.285 //y2=4.97
cc_1192 ( N_noxref_4_c_1272_p N_RN_c_8033_n ) capacitor c=0.00290085f \
 //x=22.14 //y=5.56 //x2=22.285 //y2=4.97
cc_1193 ( N_noxref_4_c_1177_n N_RN_c_7996_n ) capacitor c=6.1418e-19 //x=22.02 \
 //y=5.335 //x2=21.95 //y2=4.88
cc_1194 ( N_noxref_4_c_1192_p SN ) capacitor c=3.09428e-19 //x=23.8 //y=2.595 \
 //x2=26.76 //y2=2.77
cc_1195 ( N_noxref_4_c_1187_p SN ) capacitor c=0.00449334f //x=25.65 //y=2.595 \
 //x2=26.76 //y2=2.77
cc_1196 ( N_noxref_4_c_1283_p SN ) capacitor c=0.00782592f //x=25.65 //y=2.915 \
 //x2=26.76 //y2=2.77
cc_1197 ( N_noxref_4_c_1188_p SN ) capacitor c=0.00199877f //x=25.65 //y=4.755 \
 //x2=26.76 //y2=2.77
cc_1198 ( N_noxref_4_c_1307_p SN ) capacitor c=4.11345e-19 //x=25.65 //y=2.77 \
 //x2=26.76 //y2=2.77
cc_1199 ( N_noxref_4_c_1288_p SN ) capacitor c=0.00508565f //x=25.65 //y=2.755 \
 //x2=26.76 //y2=2.77
cc_1200 ( N_noxref_4_c_1289_p SN ) capacitor c=3.9149e-19 //x=25.65 //y=2.26 \
 //x2=26.76 //y2=2.77
cc_1201 ( N_noxref_4_c_1188_p SN ) capacitor c=3.43503e-19 //x=25.65 //y=4.755 \
 //x2=26.76 //y2=3.14
cc_1202 ( N_noxref_4_c_1285_p N_SN_c_9931_n ) capacitor c=0.00883959f \
 //x=25.65 //y=2.375 //x2=26.76 //y2=2.375
cc_1203 ( N_noxref_4_c_1289_p N_SN_c_9931_n ) capacitor c=5.40058e-19 \
 //x=25.65 //y=2.26 //x2=26.76 //y2=2.375
cc_1204 ( N_noxref_4_c_1290_p N_SN_c_9931_n ) capacitor c=0.00142893f \
 //x=25.35 //y=2.095 //x2=26.76 //y2=2.375
cc_1205 ( N_noxref_4_c_1188_p N_SN_c_9934_n ) capacitor c=0.00772613f \
 //x=25.65 //y=4.755 //x2=26.76 //y2=3.305
cc_1206 ( N_noxref_4_c_1190_p N_SN_c_9935_n ) capacitor c=9.43045e-19 //x=23.8 \
 //y=5.25 //x2=26.76 //y2=4.765
cc_1207 ( N_noxref_4_c_1188_p N_SN_c_9935_n ) capacitor c=0.043384f //x=25.65 \
 //y=4.755 //x2=26.76 //y2=4.765
cc_1208 ( N_noxref_4_c_1317_p N_SN_c_9935_n ) capacitor c=6.26008e-19 \
 //x=25.65 //y=4.88 //x2=26.76 //y2=4.765
cc_1209 ( N_noxref_4_c_1217_p N_SN_c_9935_n ) capacitor c=7.66769e-19 \
 //x=26.215 //y=4.97 //x2=26.76 //y2=4.765
cc_1210 ( N_noxref_4_c_1319_p N_SN_c_9935_n ) capacitor c=7.54501e-19 \
 //x=25.925 //y=4.97 //x2=26.76 //y2=4.765
cc_1211 ( N_noxref_4_c_1194_p N_SN_c_9921_n ) capacitor c=0.0121671f //x=23.8 \
 //y=2.915 //x2=32.475 //y2=3.13
cc_1212 ( N_noxref_4_c_1190_p N_SN_c_9921_n ) capacitor c=0.0227809f //x=23.8 \
 //y=5.25 //x2=32.475 //y2=3.13
cc_1213 ( N_noxref_4_c_1283_p N_SN_c_9921_n ) capacitor c=0.0088939f //x=25.65 \
 //y=2.915 //x2=32.475 //y2=3.13
cc_1214 ( N_noxref_4_c_1188_p N_SN_c_9921_n ) capacitor c=0.026055f //x=25.65 \
 //y=4.755 //x2=32.475 //y2=3.13
cc_1215 ( N_noxref_4_c_1199_p N_SN_c_9921_n ) capacitor c=0.0358686f \
 //x=23.945 //y=2.755 //x2=32.475 //y2=3.13
cc_1216 ( N_noxref_4_c_1288_p N_SN_c_9921_n ) capacitor c=0.0358686f //x=25.65 \
 //y=2.755 //x2=32.475 //y2=3.13
cc_1217 ( N_noxref_4_c_1220_p N_SN_c_9921_n ) capacitor c=0.13566f //x=25.49 \
 //y=2.755 //x2=32.475 //y2=3.13
cc_1218 ( N_noxref_4_c_1285_p N_SN_c_9947_n ) capacitor c=5.39999e-19 \
 //x=25.65 //y=2.375 //x2=26.76 //y2=2.26
cc_1219 ( N_noxref_4_c_1187_p N_SN_c_9947_n ) capacitor c=3.9149e-19 //x=25.65 \
 //y=2.595 //x2=26.76 //y2=2.26
cc_1220 ( N_noxref_4_c_1289_p N_SN_c_9947_n ) capacitor c=0.00125213f \
 //x=25.65 //y=2.26 //x2=26.76 //y2=2.26
cc_1221 ( N_noxref_4_c_1290_p N_SN_c_9947_n ) capacitor c=0.00214573f \
 //x=25.35 //y=2.095 //x2=26.76 //y2=2.26
cc_1222 ( N_noxref_4_c_1188_p N_SN_c_9951_n ) capacitor c=0.00103399f \
 //x=25.65 //y=4.755 //x2=26.76 //y2=4.88
cc_1223 ( N_noxref_4_c_1317_p N_SN_c_9951_n ) capacitor c=0.00113984f \
 //x=25.65 //y=4.88 //x2=26.76 //y2=4.88
cc_1224 ( N_noxref_4_c_1217_p N_SN_c_9951_n ) capacitor c=0.00116563f \
 //x=26.215 //y=4.97 //x2=26.76 //y2=4.88
cc_1225 ( N_noxref_4_c_1319_p N_SN_c_9951_n ) capacitor c=0.00129812f \
 //x=25.925 //y=4.97 //x2=26.76 //y2=4.88
cc_1226 ( N_noxref_4_M91_noxref_g N_SN_M93_noxref_g ) capacitor c=0.0106276f \
 //x=25.85 //y=6.2 //x2=26.73 //y2=6.2
cc_1227 ( N_noxref_4_M92_noxref_g N_SN_M93_noxref_g ) capacitor c=0.107144f \
 //x=26.29 //y=6.2 //x2=26.73 //y2=6.2
cc_1228 ( N_noxref_4_M92_noxref_g N_SN_M94_noxref_g ) capacitor c=0.0101598f \
 //x=26.29 //y=6.2 //x2=27.17 //y2=6.2
cc_1229 ( N_noxref_4_c_1338_p N_SN_c_9958_n ) capacitor c=5.72528e-19 \
 //x=25.35 //y=1.055 //x2=26.325 //y2=1.09
cc_1230 ( N_noxref_4_c_1339_p N_SN_c_9958_n ) capacitor c=0.00150277f \
 //x=25.35 //y=1.4 //x2=26.325 //y2=1.09
cc_1231 ( N_noxref_4_c_1340_p N_SN_c_9958_n ) capacitor c=0.0160123f //x=25.88 \
 //y=1.055 //x2=26.325 //y2=1.09
cc_1232 ( N_noxref_4_c_1341_p N_SN_c_9961_n ) capacitor c=0.00111227f \
 //x=25.35 //y=1.71 //x2=26.325 //y2=1.4
cc_1233 ( N_noxref_4_c_1342_p N_SN_c_9961_n ) capacitor c=0.0124075f //x=25.88 \
 //y=1.4 //x2=26.325 //y2=1.4
cc_1234 ( N_noxref_4_c_1340_p N_SN_c_9963_n ) capacitor c=9.19165e-19 \
 //x=25.88 //y=1.055 //x2=26.85 //y2=1.09
cc_1235 ( N_noxref_4_c_1342_p N_SN_c_9964_n ) capacitor c=0.0010154f //x=25.88 \
 //y=1.4 //x2=26.85 //y2=1.4
cc_1236 ( N_noxref_4_c_1342_p N_SN_c_9965_n ) capacitor c=9.23422e-19 \
 //x=25.88 //y=1.4 //x2=26.85 //y2=1.63
cc_1237 ( N_noxref_4_c_1285_p N_SN_c_9966_n ) capacitor c=0.00134337f \
 //x=25.65 //y=2.375 //x2=26.85 //y2=2.095
cc_1238 ( N_noxref_4_c_1289_p N_SN_c_9966_n ) capacitor c=0.0020754f //x=25.65 \
 //y=2.26 //x2=26.85 //y2=2.095
cc_1239 ( N_noxref_4_c_1290_p N_SN_c_9966_n ) capacitor c=0.00964411f \
 //x=25.35 //y=2.095 //x2=26.85 //y2=2.095
cc_1240 ( N_noxref_4_c_1188_p N_SN_c_9969_n ) capacitor c=0.00116212f \
 //x=25.65 //y=4.755 //x2=26.76 //y2=4.88
cc_1241 ( N_noxref_4_c_1317_p N_SN_c_9969_n ) capacitor c=0.00155973f \
 //x=25.65 //y=4.88 //x2=26.76 //y2=4.88
cc_1242 ( N_noxref_4_c_1217_p N_SN_c_9969_n ) capacitor c=0.0171374f \
 //x=26.215 //y=4.97 //x2=26.76 //y2=4.88
cc_1243 ( N_noxref_4_c_1319_p N_SN_c_9969_n ) capacitor c=0.00484466f \
 //x=25.925 //y=4.97 //x2=26.76 //y2=4.88
cc_1244 ( N_noxref_4_c_1177_n N_VDD_c_13434_n ) capacitor c=0.00621363f \
 //x=22.02 //y=5.335 //x2=87.775 //y2=7.585
cc_1245 ( N_noxref_4_c_1200_p N_VDD_c_13434_n ) capacitor c=0.00627191f \
 //x=22.905 //y=5.335 //x2=87.775 //y2=7.585
cc_1246 ( N_noxref_4_c_1213_p N_VDD_c_13434_n ) capacitor c=0.00256019f \
 //x=23.02 //y=5.56 //x2=87.775 //y2=7.585
cc_1247 ( N_noxref_4_c_1201_p N_VDD_c_13434_n ) capacitor c=0.00824064f \
 //x=23.715 //y=5.335 //x2=87.775 //y2=7.585
cc_1248 ( N_noxref_4_c_1178_n N_VDD_c_13434_n ) capacitor c=0.00261804f \
 //x=21.262 //y=5.335 //x2=87.775 //y2=7.585
cc_1249 ( N_noxref_4_c_1266_p N_VDD_c_13434_n ) capacitor c=0.00270108f \
 //x=22.14 //y=5.335 //x2=87.775 //y2=7.585
cc_1250 ( N_noxref_4_c_1181_n N_VDD_c_13434_n ) capacitor c=0.0024232f \
 //x=21.26 //y=5.56 //x2=87.775 //y2=7.585
cc_1251 ( N_noxref_4_c_1272_p N_VDD_c_13434_n ) capacitor c=0.0024232f \
 //x=22.14 //y=5.56 //x2=87.775 //y2=7.585
cc_1252 ( N_noxref_4_c_1209_p N_VDD_c_13434_n ) capacitor c=0.0024232f \
 //x=23.02 //y=5.56 //x2=87.775 //y2=7.585
cc_1253 ( N_noxref_4_c_1177_n N_VDD_c_13572_n ) capacitor c=0.00202922f \
 //x=22.02 //y=5.335 //x2=21.615 //y2=7.585
cc_1254 ( N_noxref_4_c_1178_n N_VDD_c_13572_n ) capacitor c=9.3757e-19 \
 //x=21.262 //y=5.335 //x2=21.615 //y2=7.585
cc_1255 ( N_noxref_4_c_1181_n N_VDD_c_13572_n ) capacitor c=0.0138074f \
 //x=21.26 //y=5.56 //x2=21.615 //y2=7.585
cc_1256 ( N_noxref_4_c_1177_n N_VDD_c_13618_n ) capacitor c=0.0017708f \
 //x=22.02 //y=5.335 //x2=22.495 //y2=7.585
cc_1257 ( N_noxref_4_c_1200_p N_VDD_c_13618_n ) capacitor c=0.00202922f \
 //x=22.905 //y=5.335 //x2=22.495 //y2=7.585
cc_1258 ( N_noxref_4_c_1266_p N_VDD_c_13618_n ) capacitor c=9.4822e-19 \
 //x=22.14 //y=5.335 //x2=22.495 //y2=7.585
cc_1259 ( N_noxref_4_c_1272_p N_VDD_c_13618_n ) capacitor c=0.0138074f \
 //x=22.14 //y=5.56 //x2=22.495 //y2=7.585
cc_1260 ( N_noxref_4_c_1200_p N_VDD_c_13622_n ) capacitor c=0.00205906f \
 //x=22.905 //y=5.335 //x2=23.375 //y2=7.585
cc_1261 ( N_noxref_4_c_1213_p N_VDD_c_13622_n ) capacitor c=8.49654e-19 \
 //x=23.02 //y=5.56 //x2=23.375 //y2=7.585
cc_1262 ( N_noxref_4_c_1201_p N_VDD_c_13622_n ) capacitor c=0.00204238f \
 //x=23.715 //y=5.335 //x2=23.375 //y2=7.585
cc_1263 ( N_noxref_4_c_1209_p N_VDD_c_13622_n ) capacitor c=0.0138074f \
 //x=23.02 //y=5.56 //x2=23.375 //y2=7.585
cc_1264 ( N_noxref_4_c_1201_p N_VDD_c_13626_n ) capacitor c=0.00183742f \
 //x=23.715 //y=5.335 //x2=24.37 //y2=7.585
cc_1265 ( N_noxref_4_M91_noxref_g N_VDD_c_13627_n ) capacitor c=0.00755614f \
 //x=25.85 //y=6.2 //x2=26.425 //y2=7.585
cc_1266 ( N_noxref_4_M92_noxref_g N_VDD_c_13627_n ) capacitor c=0.00755544f \
 //x=26.29 //y=6.2 //x2=26.425 //y2=7.585
cc_1267 ( N_noxref_4_c_1178_n N_VDD_c_13581_n ) capacitor c=0.0022955f \
 //x=21.262 //y=5.335 //x2=19.73 //y2=7.585
cc_1268 ( N_noxref_4_c_1181_n N_VDD_c_13581_n ) capacitor c=0.00509469f \
 //x=21.26 //y=5.56 //x2=19.73 //y2=7.585
cc_1269 ( N_noxref_4_c_1213_p N_VDD_c_13631_n ) capacitor c=0.00282782f \
 //x=23.02 //y=5.56 //x2=24.54 //y2=7.585
cc_1270 ( N_noxref_4_c_1190_p N_VDD_c_13631_n ) capacitor c=0.0330847f \
 //x=23.8 //y=5.25 //x2=24.54 //y2=7.585
cc_1271 ( N_noxref_4_c_1188_p N_VDD_c_13631_n ) capacitor c=0.0119487f \
 //x=25.65 //y=4.755 //x2=24.54 //y2=7.585
cc_1272 ( N_noxref_4_c_1209_p N_VDD_c_13631_n ) capacitor c=0.00777981f \
 //x=23.02 //y=5.56 //x2=24.54 //y2=7.585
cc_1273 ( N_noxref_4_c_1317_p N_VDD_c_13631_n ) capacitor c=0.00370784f \
 //x=25.65 //y=4.88 //x2=24.54 //y2=7.585
cc_1274 ( N_noxref_4_c_1319_p N_VDD_c_13631_n ) capacitor c=0.00590568f \
 //x=25.925 //y=4.97 //x2=24.54 //y2=7.585
cc_1275 ( N_noxref_4_c_1178_n N_VDD_M85_noxref_s ) capacitor c=0.0442713f \
 //x=21.262 //y=5.335 //x2=20.685 //y2=5.2
cc_1276 ( N_noxref_4_c_1266_p N_VDD_M85_noxref_s ) capacitor c=7.80122e-19 \
 //x=22.14 //y=5.335 //x2=20.685 //y2=5.2
cc_1277 ( N_noxref_4_c_1181_n N_VDD_M85_noxref_s ) capacitor c=0.09305f \
 //x=21.26 //y=5.56 //x2=20.685 //y2=5.2
cc_1278 ( N_noxref_4_c_1177_n N_VDD_M86_noxref_d ) capacitor c=0.00700141f \
 //x=22.02 //y=5.335 //x2=21.555 //y2=5.2
cc_1279 ( N_noxref_4_c_1181_n N_VDD_M86_noxref_d ) capacitor c=0.0674491f \
 //x=21.26 //y=5.56 //x2=21.555 //y2=5.2
cc_1280 ( N_noxref_4_c_1272_p N_VDD_M86_noxref_d ) capacitor c=0.0674762f \
 //x=22.14 //y=5.56 //x2=21.555 //y2=5.2
cc_1281 ( N_noxref_4_c_1200_p N_VDD_M88_noxref_d ) capacitor c=0.00700141f \
 //x=22.905 //y=5.335 //x2=22.435 //y2=5.2
cc_1282 ( N_noxref_4_c_1272_p N_VDD_M88_noxref_d ) capacitor c=0.067493f \
 //x=22.14 //y=5.56 //x2=22.435 //y2=5.2
cc_1283 ( N_noxref_4_c_1209_p N_VDD_M88_noxref_d ) capacitor c=0.0674979f \
 //x=23.02 //y=5.56 //x2=22.435 //y2=5.2
cc_1284 ( N_noxref_4_c_1201_p N_VDD_M90_noxref_d ) capacitor c=0.00700141f \
 //x=23.715 //y=5.335 //x2=23.315 //y2=5.2
cc_1285 ( N_noxref_4_c_1209_p N_VDD_M90_noxref_d ) capacitor c=0.0675002f \
 //x=23.02 //y=5.56 //x2=23.315 //y2=5.2
cc_1286 ( N_noxref_4_c_1213_p N_VDD_M91_noxref_s ) capacitor c=0.00492616f \
 //x=23.02 //y=5.56 //x2=25.495 //y2=5.2
cc_1287 ( N_noxref_4_c_1201_p N_VDD_M91_noxref_s ) capacitor c=9.42705e-19 \
 //x=23.715 //y=5.335 //x2=25.495 //y2=5.2
cc_1288 ( N_noxref_4_c_1283_p N_VDD_M91_noxref_s ) capacitor c=4.30405e-19 \
 //x=25.65 //y=2.915 //x2=25.495 //y2=5.2
cc_1289 ( N_noxref_4_c_1188_p N_VDD_M91_noxref_s ) capacitor c=0.0217981f \
 //x=25.65 //y=4.755 //x2=25.495 //y2=5.2
cc_1290 ( N_noxref_4_c_1266_p N_VDD_M91_noxref_s ) capacitor c=2.11884e-19 \
 //x=22.14 //y=5.335 //x2=25.495 //y2=5.2
cc_1291 ( N_noxref_4_c_1317_p N_VDD_M91_noxref_s ) capacitor c=0.00983846f \
 //x=25.65 //y=4.88 //x2=25.495 //y2=5.2
cc_1292 ( N_noxref_4_M91_noxref_g N_VDD_M91_noxref_s ) capacitor c=0.053419f \
 //x=25.85 //y=6.2 //x2=25.495 //y2=5.2
cc_1293 ( N_noxref_4_c_1319_p N_VDD_M91_noxref_s ) capacitor c=0.00608955f \
 //x=25.925 //y=4.97 //x2=25.495 //y2=5.2
cc_1294 ( N_noxref_4_M92_noxref_g N_VDD_M92_noxref_d ) capacitor c=0.015318f \
 //x=26.29 //y=6.2 //x2=26.365 //y2=5.2
cc_1295 ( N_noxref_4_c_1202_p N_noxref_30_c_15149_n ) capacitor c=0.0036878f \
 //x=23.315 //y=1.305 //x2=23.715 //y2=0.72
cc_1296 ( N_noxref_4_c_1211_p N_noxref_30_c_15149_n ) capacitor c=0.00399931f \
 //x=23.715 //y=1.845 //x2=23.715 //y2=0.72
cc_1297 ( N_noxref_4_M14_noxref_d N_noxref_30_c_15149_n ) capacitor \
 c=0.00910163f //x=23.125 //y=1.095 //x2=23.715 //y2=0.72
cc_1298 ( N_noxref_4_M14_noxref_d N_noxref_30_c_15152_n ) capacitor \
 c=0.00120711f //x=23.125 //y=1.095 //x2=22.83 //y2=1.175
cc_1299 ( N_noxref_4_c_1177_n N_noxref_30_M13_noxref_d ) capacitor \
 c=0.00127654f //x=22.02 //y=5.335 //x2=21.59 //y2=1.09
cc_1300 ( N_noxref_4_c_1202_p N_noxref_30_M13_noxref_d ) capacitor \
 c=0.00802417f //x=23.315 //y=1.305 //x2=21.59 //y2=1.09
cc_1301 ( N_noxref_4_c_1202_p N_noxref_30_M14_noxref_s ) capacitor \
 c=0.0098487f //x=23.315 //y=1.305 //x2=22.695 //y2=0.555
cc_1302 ( N_noxref_4_c_1239_p N_noxref_30_M14_noxref_s ) capacitor \
 c=0.0283243f //x=23.315 //y=1.76 //x2=22.695 //y2=0.555
cc_1303 ( N_noxref_4_c_1211_p N_noxref_30_M14_noxref_s ) capacitor \
 c=0.00752108f //x=23.715 //y=1.845 //x2=22.695 //y2=0.555
cc_1304 ( N_noxref_4_c_1198_p N_noxref_30_M14_noxref_s ) capacitor \
 c=0.00309975f //x=23.8 //y=2.77 //x2=22.695 //y2=0.555
cc_1305 ( N_noxref_4_M14_noxref_d N_noxref_30_M14_noxref_s ) capacitor \
 c=0.0279003f //x=23.125 //y=1.095 //x2=22.695 //y2=0.555
cc_1306 ( N_noxref_4_c_1202_p N_noxref_31_M16_noxref_d ) capacitor \
 c=3.20746e-19 //x=23.315 //y=1.305 //x2=26.4 //y2=1.09
cc_1307 ( N_noxref_4_c_1202_p N_GND_c_16542_n ) capacitor c=0.00884249f \
 //x=23.315 //y=1.305 //x2=25.53 //y2=0.175
cc_1308 ( N_noxref_4_c_1211_p N_GND_c_16542_n ) capacitor c=0.00662077f \
 //x=23.715 //y=1.845 //x2=25.53 //y2=0.175
cc_1309 ( N_noxref_4_c_1194_p N_GND_c_16542_n ) capacitor c=4.28453e-19 \
 //x=23.8 //y=2.915 //x2=25.53 //y2=0.175
cc_1310 ( N_noxref_4_M14_noxref_d N_GND_c_16542_n ) capacitor c=2.9462e-19 \
 //x=23.125 //y=1.095 //x2=25.53 //y2=0.175
cc_1311 ( N_noxref_4_c_1338_p N_GND_c_16546_n ) capacitor c=3.97665e-19 \
 //x=25.35 //y=1.055 //x2=25.615 //y2=1.015
cc_1312 ( N_noxref_4_c_1421_p N_GND_c_16546_n ) capacitor c=0.00864776f \
 //x=25.725 //y=0.9 //x2=25.615 //y2=1.015
cc_1313 ( N_noxref_4_c_1340_p N_GND_c_16546_n ) capacitor c=4.45447e-19 \
 //x=25.88 //y=1.055 //x2=25.615 //y2=1.015
cc_1314 ( N_noxref_4_c_1202_p N_GND_c_16549_n ) capacitor c=0.00543195f \
 //x=23.315 //y=1.305 //x2=25.615 //y2=1.145
cc_1315 ( N_noxref_4_c_1285_p N_GND_c_16549_n ) capacitor c=0.00769783f \
 //x=25.65 //y=2.375 //x2=25.615 //y2=1.145
cc_1316 ( N_noxref_4_c_1283_p N_GND_c_16549_n ) capacitor c=0.00119935f \
 //x=25.65 //y=2.915 //x2=25.615 //y2=1.145
cc_1317 ( N_noxref_4_c_1289_p N_GND_c_16549_n ) capacitor c=2.22883e-19 \
 //x=25.65 //y=2.26 //x2=25.615 //y2=1.145
cc_1318 ( N_noxref_4_c_1338_p N_GND_c_16549_n ) capacitor c=0.00156339f \
 //x=25.35 //y=1.055 //x2=25.615 //y2=1.145
cc_1319 ( N_noxref_4_c_1339_p N_GND_c_16549_n ) capacitor c=0.00352472f \
 //x=25.35 //y=1.4 //x2=25.615 //y2=1.145
cc_1320 ( N_noxref_4_c_1341_p N_GND_c_16549_n ) capacitor c=3.84689e-19 \
 //x=25.35 //y=1.71 //x2=25.615 //y2=1.145
cc_1321 ( N_noxref_4_c_1421_p N_GND_c_16549_n ) capacitor c=9.36995e-19 \
 //x=25.725 //y=0.9 //x2=25.615 //y2=1.145
cc_1322 ( N_noxref_4_c_1431_p N_GND_c_16549_n ) capacitor c=5.2644e-19 \
 //x=25.725 //y=1.555 //x2=25.615 //y2=1.145
cc_1323 ( N_noxref_4_c_1340_p N_GND_c_16549_n ) capacitor c=0.0017438f \
 //x=25.88 //y=1.055 //x2=25.615 //y2=1.145
cc_1324 ( N_noxref_4_c_1342_p N_GND_c_16549_n ) capacitor c=0.00276804f \
 //x=25.88 //y=1.4 //x2=25.615 //y2=1.145
cc_1325 ( N_noxref_4_c_1211_p N_GND_c_16522_n ) capacitor c=6.86343e-19 \
 //x=23.715 //y=1.845 //x2=24.37 //y2=0.175
cc_1326 ( N_noxref_4_c_1194_p N_GND_c_16522_n ) capacitor c=6.03046e-19 \
 //x=23.8 //y=2.915 //x2=24.37 //y2=0.175
cc_1327 ( N_noxref_4_c_1338_p N_GND_c_16562_n ) capacitor c=0.00677849f \
 //x=25.35 //y=1.055 //x2=29.18 //y2=0.175
cc_1328 ( N_noxref_4_c_1239_p N_GND_c_16563_n ) capacitor c=0.0045138f \
 //x=23.315 //y=1.76 //x2=24.54 //y2=0.175
cc_1329 ( N_noxref_4_c_1211_p N_GND_c_16563_n ) capacitor c=0.0225712f \
 //x=23.715 //y=1.845 //x2=24.54 //y2=0.175
cc_1330 ( N_noxref_4_c_1194_p N_GND_c_16563_n ) capacitor c=0.00456444f \
 //x=23.8 //y=2.915 //x2=24.54 //y2=0.175
cc_1331 ( N_noxref_4_c_1285_p N_GND_c_16563_n ) capacitor c=0.00317529f \
 //x=25.65 //y=2.375 //x2=24.54 //y2=0.175
cc_1332 ( N_noxref_4_c_1187_p N_GND_c_16563_n ) capacitor c=0.00371217f \
 //x=25.65 //y=2.595 //x2=24.54 //y2=0.175
cc_1333 ( N_noxref_4_c_1283_p N_GND_c_16563_n ) capacitor c=0.0033154f \
 //x=25.65 //y=2.915 //x2=24.54 //y2=0.175
cc_1334 ( N_noxref_4_c_1198_p N_GND_c_16563_n ) capacitor c=0.0104251f \
 //x=23.8 //y=2.77 //x2=24.54 //y2=0.175
cc_1335 ( N_noxref_4_c_1307_p N_GND_c_16563_n ) capacitor c=0.00528339f \
 //x=25.65 //y=2.77 //x2=24.54 //y2=0.175
cc_1336 ( N_noxref_4_c_1220_p N_GND_c_16563_n ) capacitor c=0.00947774f \
 //x=25.49 //y=2.755 //x2=24.54 //y2=0.175
cc_1337 ( N_noxref_4_c_1289_p N_GND_c_16563_n ) capacitor c=0.0039621f \
 //x=25.65 //y=2.26 //x2=24.54 //y2=0.175
cc_1338 ( N_noxref_4_c_1341_p N_GND_c_16563_n ) capacitor c=0.00170145f \
 //x=25.35 //y=1.71 //x2=24.54 //y2=0.175
cc_1339 ( N_noxref_4_c_1290_p N_GND_c_16563_n ) capacitor c=0.0102191f \
 //x=25.35 //y=2.095 //x2=24.54 //y2=0.175
cc_1340 ( N_noxref_4_c_1285_p N_GND_M15_noxref_d ) capacitor c=4.4417e-19 \
 //x=25.65 //y=2.375 //x2=25.425 //y2=1.055
cc_1341 ( N_noxref_4_c_1338_p N_GND_M15_noxref_d ) capacitor c=0.00184354f \
 //x=25.35 //y=1.055 //x2=25.425 //y2=1.055
cc_1342 ( N_noxref_4_c_1339_p N_GND_M15_noxref_d ) capacitor c=0.00210798f \
 //x=25.35 //y=1.4 //x2=25.425 //y2=1.055
cc_1343 ( N_noxref_4_c_1421_p N_GND_M15_noxref_d ) capacitor c=0.00474029f \
 //x=25.725 //y=0.9 //x2=25.425 //y2=1.055
cc_1344 ( N_noxref_4_c_1431_p N_GND_M15_noxref_d ) capacitor c=0.00166857f \
 //x=25.725 //y=1.555 //x2=25.425 //y2=1.055
cc_1345 ( N_noxref_4_c_1340_p N_GND_M15_noxref_d ) capacitor c=0.00230174f \
 //x=25.88 //y=1.055 //x2=25.425 //y2=1.055
cc_1346 ( N_noxref_4_c_1342_p N_GND_M15_noxref_d ) capacitor c=0.00210798f \
 //x=25.88 //y=1.4 //x2=25.425 //y2=1.055
cc_1347 ( N_noxref_4_c_1290_p N_noxref_52_c_18422_n ) capacitor c=0.00262672f \
 //x=25.35 //y=2.095 //x2=25.13 //y2=1.685
cc_1348 ( N_noxref_4_c_1285_p N_noxref_52_c_18423_n ) capacitor c=0.00428451f \
 //x=25.65 //y=2.375 //x2=26.015 //y2=1.77
cc_1349 ( N_noxref_4_c_1283_p N_noxref_52_c_18423_n ) capacitor c=0.0045315f \
 //x=25.65 //y=2.915 //x2=26.015 //y2=1.77
cc_1350 ( N_noxref_4_c_1289_p N_noxref_52_c_18423_n ) capacitor c=0.0104666f \
 //x=25.65 //y=2.26 //x2=26.015 //y2=1.77
cc_1351 ( N_noxref_4_c_1341_p N_noxref_52_c_18423_n ) capacitor c=0.00705077f \
 //x=25.35 //y=1.71 //x2=26.015 //y2=1.77
cc_1352 ( N_noxref_4_c_1290_p N_noxref_52_c_18423_n ) capacitor c=0.0197765f \
 //x=25.35 //y=2.095 //x2=26.015 //y2=1.77
cc_1353 ( N_noxref_4_c_1431_p N_noxref_52_c_18423_n ) capacitor c=0.00560218f \
 //x=25.725 //y=1.555 //x2=26.015 //y2=1.77
cc_1354 ( N_noxref_4_c_1342_p N_noxref_52_c_18423_n ) capacitor c=0.00698822f \
 //x=25.88 //y=1.4 //x2=26.015 //y2=1.77
cc_1355 ( N_noxref_4_c_1338_p N_noxref_52_M15_noxref_s ) capacitor \
 c=0.0295256f //x=25.35 //y=1.055 //x2=24.995 //y2=0.555
cc_1356 ( N_noxref_4_c_1341_p N_noxref_52_M15_noxref_s ) capacitor \
 c=7.99997e-19 //x=25.35 //y=1.71 //x2=24.995 //y2=0.555
cc_1357 ( N_noxref_4_c_1290_p N_noxref_52_M15_noxref_s ) capacitor \
 c=0.00122123f //x=25.35 //y=2.095 //x2=24.995 //y2=0.555
cc_1358 ( N_noxref_4_c_1340_p N_noxref_52_M15_noxref_s ) capacitor \
 c=0.0125924f //x=25.88 //y=1.055 //x2=24.995 //y2=0.555
cc_1359 ( N_noxref_5_c_1574_n N_noxref_6_c_2077_n ) capacitor c=0.0056341f \
 //x=21.05 //y=3.895 //x2=23.06 //y2=3.655
cc_1360 ( N_noxref_5_c_1574_n N_noxref_6_c_2066_n ) capacitor c=0.0214933f \
 //x=21.05 //y=3.895 //x2=23.06 //y2=4.75
cc_1361 ( N_noxref_5_c_1633_p N_noxref_6_c_2139_n ) capacitor c=0.00168689f \
 //x=27.87 //y=4.045 //x2=27.715 //y2=5.335
cc_1362 ( N_noxref_5_M95_noxref_g N_noxref_6_c_2139_n ) capacitor \
 c=0.00952006f //x=27.61 //y=6.2 //x2=27.715 //y2=5.335
cc_1363 ( N_noxref_5_M95_noxref_g N_noxref_6_c_2141_n ) capacitor \
 c=0.00226521f //x=27.61 //y=6.2 //x2=27.83 //y2=5.56
cc_1364 ( N_noxref_5_M96_noxref_g N_noxref_6_c_2141_n ) capacitor \
 c=0.00381703f //x=28.05 //y=6.2 //x2=27.83 //y2=5.56
cc_1365 ( N_noxref_5_c_1633_p N_noxref_6_c_2143_n ) capacitor c=4.21338e-19 \
 //x=27.87 //y=4.045 //x2=28.45 //y2=5.335
cc_1366 ( N_noxref_5_c_1628_n N_noxref_6_c_2143_n ) capacitor c=0.00228791f \
 //x=27.87 //y=4.75 //x2=28.45 //y2=5.335
cc_1367 ( N_noxref_5_c_1639_p N_noxref_6_c_2143_n ) capacitor c=0.00130631f \
 //x=27.87 //y=4.88 //x2=28.45 //y2=5.335
cc_1368 ( N_noxref_5_M96_noxref_g N_noxref_6_c_2143_n ) capacitor c=0.0108585f \
 //x=28.05 //y=6.2 //x2=28.45 //y2=5.335
cc_1369 ( N_noxref_5_c_1641_p N_noxref_6_c_2147_n ) capacitor c=4.64015e-19 \
 //x=27.86 //y=1.095 //x2=28.125 //y2=1.305
cc_1370 ( N_noxref_5_c_1642_p N_noxref_6_c_2147_n ) capacitor c=0.0026012f \
 //x=27.86 //y=1.44 //x2=28.125 //y2=1.305
cc_1371 ( N_noxref_5_c_1643_p N_noxref_6_c_2147_n ) capacitor c=5.29969e-19 \
 //x=28.235 //y=0.94 //x2=28.125 //y2=1.305
cc_1372 ( N_noxref_5_c_1644_p N_noxref_6_c_2147_n ) capacitor c=5.31989e-19 \
 //x=28.235 //y=1.595 //x2=28.125 //y2=1.305
cc_1373 ( N_noxref_5_c_1645_p N_noxref_6_c_2147_n ) capacitor c=5.24634e-19 \
 //x=28.39 //y=1.095 //x2=28.125 //y2=1.305
cc_1374 ( N_noxref_5_c_1646_p N_noxref_6_c_2147_n ) capacitor c=0.00307978f \
 //x=28.39 //y=1.44 //x2=28.125 //y2=1.305
cc_1375 ( N_noxref_5_c_1642_p N_noxref_6_c_2153_n ) capacitor c=0.00127432f \
 //x=27.86 //y=1.44 //x2=28.125 //y2=1.76
cc_1376 ( N_noxref_5_c_1648_p N_noxref_6_c_2153_n ) capacitor c=0.00429966f \
 //x=27.86 //y=1.75 //x2=28.125 //y2=1.76
cc_1377 ( N_noxref_5_c_1644_p N_noxref_6_c_2153_n ) capacitor c=0.00942306f \
 //x=28.235 //y=1.595 //x2=28.125 //y2=1.76
cc_1378 ( N_noxref_5_c_1646_p N_noxref_6_c_2153_n ) capacitor c=0.00363411f \
 //x=28.39 //y=1.44 //x2=28.125 //y2=1.76
cc_1379 ( N_noxref_5_c_1651_p N_noxref_6_c_2153_n ) capacitor c=0.0036273f \
 //x=27.87 //y=2.095 //x2=28.125 //y2=1.76
cc_1380 ( N_noxref_5_c_1644_p N_noxref_6_c_2158_n ) capacitor c=0.00194716f \
 //x=28.235 //y=1.595 //x2=28.525 //y2=1.845
cc_1381 ( N_noxref_5_c_1646_p N_noxref_6_c_2158_n ) capacitor c=0.00323576f \
 //x=28.39 //y=1.44 //x2=28.525 //y2=1.845
cc_1382 ( N_noxref_5_c_1654_p N_noxref_6_c_2160_n ) capacitor c=0.0140058f \
 //x=27.87 //y=2.375 //x2=28.61 //y2=3.365
cc_1383 ( N_noxref_5_c_1626_n N_noxref_6_c_2160_n ) capacitor c=0.0393254f \
 //x=27.87 //y=3.725 //x2=28.61 //y2=3.365
cc_1384 ( N_noxref_5_c_1656_p N_noxref_6_c_2160_n ) capacitor c=0.0015536f \
 //x=27.87 //y=2.26 //x2=28.61 //y2=3.365
cc_1385 ( N_noxref_5_c_1657_p N_noxref_6_c_2160_n ) capacitor c=0.0024584f \
 //x=27.87 //y=2.26 //x2=28.61 //y2=3.365
cc_1386 ( N_noxref_5_c_1651_p N_noxref_6_c_2160_n ) capacitor c=0.00282067f \
 //x=27.87 //y=2.095 //x2=28.61 //y2=3.365
cc_1387 ( N_noxref_5_c_1626_n N_noxref_6_c_2165_n ) capacitor c=0.017421f \
 //x=27.87 //y=3.725 //x2=28.61 //y2=3.685
cc_1388 ( N_noxref_5_c_1626_n N_noxref_6_c_2166_n ) capacitor c=0.00177543f \
 //x=27.87 //y=3.725 //x2=28.61 //y2=4.835
cc_1389 ( N_noxref_5_c_1633_p N_noxref_6_c_2166_n ) capacitor c=0.0148501f \
 //x=27.87 //y=4.045 //x2=28.61 //y2=4.835
cc_1390 ( N_noxref_5_c_1628_n N_noxref_6_c_2166_n ) capacitor c=0.0316998f \
 //x=27.87 //y=4.75 //x2=28.61 //y2=4.835
cc_1391 ( N_noxref_5_c_1663_p N_noxref_6_c_2166_n ) capacitor c=6.89957e-19 \
 //x=27.87 //y=3.88 //x2=28.61 //y2=4.835
cc_1392 ( N_noxref_5_c_1574_n N_noxref_6_c_2166_n ) capacitor c=0.00686827f \
 //x=21.05 //y=3.895 //x2=28.61 //y2=4.835
cc_1393 ( N_noxref_5_c_1639_p N_noxref_6_c_2166_n ) capacitor c=9.26357e-19 \
 //x=27.87 //y=4.88 //x2=28.61 //y2=4.835
cc_1394 ( N_noxref_5_c_1666_p N_noxref_6_c_2166_n ) capacitor c=8.62155e-19 \
 //x=27.87 //y=4.88 //x2=28.61 //y2=4.835
cc_1395 ( N_noxref_5_c_1628_n N_noxref_6_c_2173_n ) capacitor c=0.0221235f \
 //x=27.87 //y=4.75 //x2=27.83 //y2=5.335
cc_1396 ( N_noxref_5_c_1639_p N_noxref_6_c_2173_n ) capacitor c=0.00346456f \
 //x=27.87 //y=4.88 //x2=27.83 //y2=5.335
cc_1397 ( N_noxref_5_c_1666_p N_noxref_6_c_2173_n ) capacitor c=0.00203307f \
 //x=27.87 //y=4.88 //x2=27.83 //y2=5.335
cc_1398 ( N_noxref_5_c_1626_n N_noxref_6_c_2176_n ) capacitor c=9.19401e-19 \
 //x=27.87 //y=3.725 //x2=28.61 //y2=3.51
cc_1399 ( N_noxref_5_c_1628_n N_noxref_6_c_2177_n ) capacitor c=0.00108899f \
 //x=27.87 //y=4.75 //x2=28.61 //y2=4.99
cc_1400 ( N_noxref_5_c_1639_p N_noxref_6_c_2177_n ) capacitor c=0.00442358f \
 //x=27.87 //y=4.88 //x2=28.61 //y2=4.99
cc_1401 ( N_noxref_5_c_1666_p N_noxref_6_c_2177_n ) capacitor c=0.00765778f \
 //x=27.87 //y=4.88 //x2=28.61 //y2=4.99
cc_1402 ( N_noxref_5_c_1628_n N_noxref_6_c_2180_n ) capacitor c=0.0086202f \
 //x=27.87 //y=4.75 //x2=28.61 //y2=4.995
cc_1403 ( N_noxref_5_c_1639_p N_noxref_6_c_2180_n ) capacitor c=8.49211e-19 \
 //x=27.87 //y=4.88 //x2=28.61 //y2=4.995
cc_1404 ( N_noxref_5_c_1666_p N_noxref_6_c_2180_n ) capacitor c=0.00770263f \
 //x=27.87 //y=4.88 //x2=28.61 //y2=4.995
cc_1405 ( N_noxref_5_c_1574_n N_noxref_6_c_2095_n ) capacitor c=0.337582f \
 //x=21.05 //y=3.895 //x2=26.375 //y2=3.51
cc_1406 ( N_noxref_5_c_1574_n N_noxref_6_c_2068_n ) capacitor c=0.0357422f \
 //x=21.05 //y=3.895 //x2=23.22 //y2=3.51
cc_1407 ( N_noxref_5_c_1626_n N_noxref_6_c_2185_n ) capacitor c=3.2936e-19 \
 //x=27.87 //y=3.725 //x2=26.975 //y2=3.53
cc_1408 ( N_noxref_5_c_1574_n N_noxref_6_c_2185_n ) capacitor c=0.0449969f \
 //x=21.05 //y=3.895 //x2=26.975 //y2=3.53
cc_1409 ( N_noxref_5_c_1626_n N_noxref_6_c_2187_n ) capacitor c=2.52001e-19 \
 //x=27.87 //y=3.725 //x2=27.485 //y2=3.51
cc_1410 ( N_noxref_5_c_1633_p N_noxref_6_c_2187_n ) capacitor c=0.00203652f \
 //x=27.87 //y=4.045 //x2=27.485 //y2=3.51
cc_1411 ( N_noxref_5_c_1574_n N_noxref_6_c_2187_n ) capacitor c=0.0108859f \
 //x=21.05 //y=3.895 //x2=27.485 //y2=3.51
cc_1412 ( N_noxref_5_c_1626_n N_noxref_6_c_2190_n ) capacitor c=0.0232327f \
 //x=27.87 //y=3.725 //x2=28.085 //y2=3.5
cc_1413 ( N_noxref_5_c_1633_p N_noxref_6_c_2190_n ) capacitor c=0.00435339f \
 //x=27.87 //y=4.045 //x2=28.085 //y2=3.5
cc_1414 ( N_noxref_5_c_1574_n N_noxref_6_c_2190_n ) capacitor c=0.0358686f \
 //x=21.05 //y=3.895 //x2=28.085 //y2=3.5
cc_1415 ( N_noxref_5_c_1628_n N_noxref_6_c_2193_n ) capacitor c=0.00493325f \
 //x=27.87 //y=4.75 //x2=28.77 //y2=4.995
cc_1416 ( N_noxref_5_c_1628_n N_noxref_6_c_2194_n ) capacitor c=0.00217653f \
 //x=27.87 //y=4.75 //x2=27.83 //y2=5.56
cc_1417 ( N_noxref_5_c_1639_p N_noxref_6_c_2194_n ) capacitor c=0.00624059f \
 //x=27.87 //y=4.88 //x2=27.83 //y2=5.56
cc_1418 ( N_noxref_5_M95_noxref_g N_noxref_6_c_2194_n ) capacitor c=0.0178885f \
 //x=27.61 //y=6.2 //x2=27.83 //y2=5.56
cc_1419 ( N_noxref_5_M96_noxref_g N_noxref_6_c_2194_n ) capacitor c=0.0188608f \
 //x=28.05 //y=6.2 //x2=27.83 //y2=5.56
cc_1420 ( N_noxref_5_c_1666_p N_noxref_6_c_2194_n ) capacitor c=0.00375636f \
 //x=27.87 //y=4.88 //x2=27.83 //y2=5.56
cc_1421 ( N_noxref_5_c_1641_p N_noxref_6_M17_noxref_d ) capacitor \
 c=0.00137165f //x=27.86 //y=1.095 //x2=27.935 //y2=1.095
cc_1422 ( N_noxref_5_c_1642_p N_noxref_6_M17_noxref_d ) capacitor \
 c=0.00237422f //x=27.86 //y=1.44 //x2=27.935 //y2=1.095
cc_1423 ( N_noxref_5_c_1643_p N_noxref_6_M17_noxref_d ) capacitor c=0.0020782f \
 //x=28.235 //y=0.94 //x2=27.935 //y2=1.095
cc_1424 ( N_noxref_5_c_1644_p N_noxref_6_M17_noxref_d ) capacitor \
 c=0.00356097f //x=28.235 //y=1.595 //x2=27.935 //y2=1.095
cc_1425 ( N_noxref_5_c_1645_p N_noxref_6_M17_noxref_d ) capacitor \
 c=0.00139206f //x=28.39 //y=1.095 //x2=27.935 //y2=1.095
cc_1426 ( N_noxref_5_c_1646_p N_noxref_6_M17_noxref_d ) capacitor \
 c=0.00237422f //x=28.39 //y=1.44 //x2=27.935 //y2=1.095
cc_1427 ( N_noxref_5_c_1626_n D ) capacitor c=0.00249563f //x=27.87 //y=3.725 \
 //x2=30.46 //y2=2.77
cc_1428 ( N_noxref_5_c_1628_n N_D_c_5147_n ) capacitor c=4.96623e-19 //x=27.87 \
 //y=4.75 //x2=30.46 //y2=4.755
cc_1429 ( N_noxref_5_c_1552_n N_D_c_5110_n ) capacitor c=0.00119935f //x=8.63 \
 //y=4.055 //x2=8.245 //y2=4.25
cc_1430 ( N_noxref_5_c_1473_n N_D_c_5110_n ) capacitor c=7.5617e-19 //x=8.63 \
 //y=4.75 //x2=8.245 //y2=4.25
cc_1431 ( N_noxref_5_c_1580_n N_D_c_5110_n ) capacitor c=0.0358254f //x=8.79 \
 //y=3.895 //x2=8.245 //y2=4.25
cc_1432 ( N_noxref_5_c_1552_n N_D_c_5117_n ) capacitor c=0.00400537f //x=8.63 \
 //y=4.055 //x2=8.845 //y2=4.28
cc_1433 ( N_noxref_5_c_1473_n N_D_c_5117_n ) capacitor c=0.0208405f //x=8.63 \
 //y=4.75 //x2=8.845 //y2=4.28
cc_1434 ( N_noxref_5_c_1488_n N_D_c_5117_n ) capacitor c=0.00258295f //x=13.44 \
 //y=4.055 //x2=8.845 //y2=4.28
cc_1435 ( N_noxref_5_c_1477_n N_D_c_5117_n ) capacitor c=0.0015119f //x=13.44 \
 //y=4.75 //x2=8.845 //y2=4.28
cc_1436 ( N_noxref_5_c_1478_n N_D_c_5117_n ) capacitor c=0.38895f //x=13.28 \
 //y=3.895 //x2=8.845 //y2=4.28
cc_1437 ( N_noxref_5_c_1506_n N_D_c_5117_n ) capacitor c=0.0330132f //x=13.6 \
 //y=3.895 //x2=8.845 //y2=4.28
cc_1438 ( N_noxref_5_c_1488_n N_D_c_5125_n ) capacitor c=0.00220848f //x=13.44 \
 //y=4.055 //x2=13.655 //y2=4.31
cc_1439 ( N_noxref_5_c_1477_n N_D_c_5125_n ) capacitor c=0.0210695f //x=13.44 \
 //y=4.75 //x2=13.655 //y2=4.31
cc_1440 ( N_noxref_5_c_1504_n N_D_c_5125_n ) capacitor c=0.441619f //x=18.82 \
 //y=3.88 //x2=13.655 //y2=4.31
cc_1441 ( N_noxref_5_c_1569_n N_D_c_5126_n ) capacitor c=0.00143862f //x=18.99 \
 //y=4.055 //x2=18.595 //y2=4.25
cc_1442 ( N_noxref_5_c_1571_n N_D_c_5126_n ) capacitor c=6.13038e-19 //x=18.99 \
 //y=5.25 //x2=18.595 //y2=4.25
cc_1443 ( N_noxref_5_c_1504_n N_D_c_5126_n ) capacitor c=0.0112109f //x=18.82 \
 //y=3.88 //x2=18.595 //y2=4.25
cc_1444 ( N_noxref_5_c_1576_n N_D_c_5126_n ) capacitor c=0.0358254f //x=20.705 \
 //y=3.895 //x2=18.595 //y2=4.25
cc_1445 ( N_noxref_5_c_1569_n N_D_c_5141_n ) capacitor c=0.00743351f //x=18.99 \
 //y=4.055 //x2=19.195 //y2=4.28
cc_1446 ( N_noxref_5_c_1571_n N_D_c_5141_n ) capacitor c=0.0224219f //x=18.99 \
 //y=5.25 //x2=19.195 //y2=4.28
cc_1447 ( N_noxref_5_c_1576_n N_D_c_5141_n ) capacitor c=0.125288f //x=20.705 \
 //y=3.895 //x2=19.195 //y2=4.28
cc_1448 ( N_noxref_5_c_1633_p N_D_c_5143_n ) capacitor c=0.00275311f //x=27.87 \
 //y=4.045 //x2=27.485 //y2=4.25
cc_1449 ( N_noxref_5_c_1628_n N_D_c_5143_n ) capacitor c=5.04113e-19 //x=27.87 \
 //y=4.75 //x2=27.485 //y2=4.25
cc_1450 ( N_noxref_5_c_1574_n N_D_c_5143_n ) capacitor c=0.601938f //x=21.05 \
 //y=3.895 //x2=27.485 //y2=4.25
cc_1451 ( N_noxref_5_c_1576_n N_D_c_5143_n ) capacitor c=0.0578277f //x=20.705 \
 //y=3.895 //x2=27.485 //y2=4.25
cc_1452 ( N_noxref_5_c_1633_p N_D_c_5171_n ) capacitor c=0.002495f //x=27.87 \
 //y=4.045 //x2=28.085 //y2=4.27
cc_1453 ( N_noxref_5_c_1628_n N_D_c_5171_n ) capacitor c=0.0206383f //x=27.87 \
 //y=4.75 //x2=28.085 //y2=4.27
cc_1454 ( N_noxref_5_c_1628_n N_D_c_5173_n ) capacitor c=4.16089e-19 //x=27.87 \
 //y=4.75 //x2=37.36 //y2=4.28
cc_1455 ( N_noxref_5_c_1468_n CLK ) capacitor c=0.0332928f //x=8.63 //y=3.735 \
 //x2=7.52 //y2=3.14
cc_1456 ( N_noxref_5_c_1552_n CLK ) capacitor c=0.00782712f //x=8.63 //y=4.055 \
 //x2=7.52 //y2=3.14
cc_1457 ( N_noxref_5_c_1473_n CLK ) capacitor c=0.0130238f //x=8.63 //y=4.75 \
 //x2=7.52 //y2=3.14
cc_1458 ( N_noxref_5_c_1572_n CLK ) capacitor c=5.01652e-19 //x=8.63 //y=3.88 \
 //x2=7.52 //y2=3.14
cc_1459 ( N_noxref_5_c_1580_n CLK ) capacitor c=0.00513442f //x=8.79 //y=3.895 \
 //x2=7.52 //y2=3.14
cc_1460 ( N_noxref_5_c_1588_n CLK ) capacitor c=3.9149e-19 //x=8.63 //y=2.26 \
 //x2=7.52 //y2=3.14
cc_1461 ( N_noxref_5_c_1563_n CLK ) capacitor c=0.00239078f //x=18.99 \
 //y=3.735 //x2=17.14 //y2=2.77
cc_1462 ( N_noxref_5_c_1571_n CLK ) capacitor c=6.81624e-19 //x=18.99 //y=5.25 \
 //x2=17.14 //y2=2.77
cc_1463 ( N_noxref_5_c_1504_n CLK ) capacitor c=0.0235232f //x=18.82 //y=3.88 \
 //x2=17.14 //y2=2.77
cc_1464 ( N_noxref_5_c_1545_n N_CLK_c_6419_n ) capacitor c=0.00939109f \
 //x=8.63 //y=2.375 //x2=7.52 //y2=2.375
cc_1465 ( N_noxref_5_c_1588_n N_CLK_c_6419_n ) capacitor c=5.42289e-19 \
 //x=8.63 //y=2.26 //x2=7.52 //y2=2.375
cc_1466 ( N_noxref_5_c_1617_n N_CLK_c_6419_n ) capacitor c=0.00134951f \
 //x=8.63 //y=2.26 //x2=7.52 //y2=2.375
cc_1467 ( N_noxref_5_c_1473_n N_CLK_c_6422_n ) capacitor c=0.0082089f //x=8.63 \
 //y=4.75 //x2=7.515 //y2=4.835
cc_1468 ( N_noxref_5_c_1589_n N_CLK_c_6422_n ) capacitor c=7.52809e-19 \
 //x=8.63 //y=4.88 //x2=7.515 //y2=4.835
cc_1469 ( N_noxref_5_c_1620_n N_CLK_c_6422_n ) capacitor c=0.0013272f //x=8.63 \
 //y=4.88 //x2=7.515 //y2=4.835
cc_1470 ( N_noxref_5_c_1496_n N_CLK_c_6464_n ) capacitor c=0.0229393f \
 //x=17.21 //y=5.335 //x2=17.145 //y2=4.835
cc_1471 ( N_noxref_5_c_1743_p N_CLK_c_6464_n ) capacitor c=0.00585991f \
 //x=17.33 //y=5.335 //x2=17.145 //y2=4.835
cc_1472 ( N_noxref_5_c_1744_p N_CLK_c_6464_n ) capacitor c=0.00148364f \
 //x=17.33 //y=5.56 //x2=17.145 //y2=4.835
cc_1473 ( N_noxref_5_c_1473_n N_CLK_c_6426_n ) capacitor c=0.0283594f //x=8.63 \
 //y=4.75 //x2=16.985 //y2=4.62
cc_1474 ( N_noxref_5_c_1477_n N_CLK_c_6426_n ) capacitor c=0.028106f //x=13.44 \
 //y=4.75 //x2=16.985 //y2=4.62
cc_1475 ( N_noxref_5_c_1499_n N_CLK_c_6426_n ) capacitor c=0.0282483f \
 //x=16.452 //y=5.335 //x2=16.985 //y2=4.62
cc_1476 ( N_noxref_5_c_1504_n N_CLK_c_6426_n ) capacitor c=0.0316047f \
 //x=18.82 //y=3.88 //x2=16.985 //y2=4.62
cc_1477 ( N_noxref_5_c_1478_n N_CLK_c_6426_n ) capacitor c=0.0268805f \
 //x=13.28 //y=3.895 //x2=16.985 //y2=4.62
cc_1478 ( N_noxref_5_c_1496_n N_CLK_c_6473_n ) capacitor c=0.00213056f \
 //x=17.21 //y=5.335 //x2=28.395 //y2=4.61
cc_1479 ( N_noxref_5_c_1624_n N_CLK_c_6473_n ) capacitor c=0.0218036f \
 //x=18.905 //y=5.335 //x2=28.395 //y2=4.61
cc_1480 ( N_noxref_5_c_1571_n N_CLK_c_6473_n ) capacitor c=0.0297057f \
 //x=18.99 //y=5.25 //x2=28.395 //y2=4.61
cc_1481 ( N_noxref_5_c_1628_n N_CLK_c_6473_n ) capacitor c=0.0287144f \
 //x=27.87 //y=4.75 //x2=28.395 //y2=4.61
cc_1482 ( N_noxref_5_c_1743_p N_CLK_c_6473_n ) capacitor c=0.0405169f \
 //x=17.33 //y=5.335 //x2=28.395 //y2=4.61
cc_1483 ( N_noxref_5_c_1574_n N_CLK_c_6473_n ) capacitor c=0.0413764f \
 //x=21.05 //y=3.895 //x2=28.395 //y2=4.61
cc_1484 ( N_noxref_5_c_1576_n N_CLK_c_6473_n ) capacitor c=0.00995922f \
 //x=20.705 //y=3.895 //x2=28.395 //y2=4.61
cc_1485 ( N_noxref_5_c_1473_n N_CLK_c_6427_n ) capacitor c=0.00655852f \
 //x=8.63 //y=4.75 //x2=7.515 //y2=4.62
cc_1486 ( N_noxref_5_c_1545_n N_CLK_c_6428_n ) capacitor c=5.39999e-19 \
 //x=8.63 //y=2.375 //x2=7.52 //y2=2.26
cc_1487 ( N_noxref_5_c_1468_n N_CLK_c_6428_n ) capacitor c=3.9149e-19 //x=8.63 \
 //y=3.735 //x2=7.52 //y2=2.26
cc_1488 ( N_noxref_5_c_1588_n N_CLK_c_6428_n ) capacitor c=0.00125213f \
 //x=8.63 //y=2.26 //x2=7.52 //y2=2.26
cc_1489 ( N_noxref_5_c_1617_n N_CLK_c_6428_n ) capacitor c=0.00204868f \
 //x=8.63 //y=2.26 //x2=7.52 //y2=2.26
cc_1490 ( N_noxref_5_c_1473_n N_CLK_c_6432_n ) capacitor c=4.56604e-19 \
 //x=8.63 //y=4.75 //x2=7.52 //y2=4.88
cc_1491 ( N_noxref_5_c_1589_n N_CLK_c_6432_n ) capacitor c=0.00113671f \
 //x=8.63 //y=4.88 //x2=7.52 //y2=4.88
cc_1492 ( N_noxref_5_c_1620_n N_CLK_c_6432_n ) capacitor c=0.00186974f \
 //x=8.63 //y=4.88 //x2=7.52 //y2=4.88
cc_1493 ( N_noxref_5_c_1496_n N_CLK_c_6478_n ) capacitor c=0.00492634f \
 //x=17.21 //y=5.335 //x2=17.14 //y2=4.88
cc_1494 ( N_noxref_5_c_1743_p N_CLK_c_6478_n ) capacitor c=0.00132214f \
 //x=17.33 //y=5.335 //x2=17.14 //y2=4.88
cc_1495 ( N_noxref_5_M71_noxref_g N_CLK_M69_noxref_g ) capacitor c=0.0101598f \
 //x=8.37 //y=6.2 //x2=7.49 //y2=6.2
cc_1496 ( N_noxref_5_M71_noxref_g N_CLK_M70_noxref_g ) capacitor c=0.0607518f \
 //x=8.37 //y=6.2 //x2=7.93 //y2=6.2
cc_1497 ( N_noxref_5_M72_noxref_g N_CLK_M70_noxref_g ) capacitor c=0.0101598f \
 //x=8.81 //y=6.2 //x2=7.93 //y2=6.2
cc_1498 ( N_noxref_5_c_1496_n N_CLK_M81_noxref_g ) capacitor c=0.00858222f \
 //x=17.21 //y=5.335 //x2=17.11 //y2=6.2
cc_1499 ( N_noxref_5_c_1743_p N_CLK_M81_noxref_g ) capacitor c=0.00229818f \
 //x=17.33 //y=5.335 //x2=17.11 //y2=6.2
cc_1500 ( N_noxref_5_c_1744_p N_CLK_M81_noxref_g ) capacitor c=0.0179041f \
 //x=17.33 //y=5.56 //x2=17.11 //y2=6.2
cc_1501 ( N_noxref_5_c_1773_p N_CLK_M82_noxref_g ) capacitor c=0.00955829f \
 //x=18.095 //y=5.335 //x2=17.55 //y2=6.2
cc_1502 ( N_noxref_5_c_1743_p N_CLK_M82_noxref_g ) capacitor c=0.00230699f \
 //x=17.33 //y=5.335 //x2=17.55 //y2=6.2
cc_1503 ( N_noxref_5_c_1744_p N_CLK_M82_noxref_g ) capacitor c=0.0179041f \
 //x=17.33 //y=5.56 //x2=17.55 //y2=6.2
cc_1504 ( N_noxref_5_c_1599_n N_CLK_c_6444_n ) capacitor c=0.00456962f \
 //x=8.62 //y=1.095 //x2=7.61 //y2=1.09
cc_1505 ( N_noxref_5_c_1601_n N_CLK_c_6445_n ) capacitor c=0.00438372f \
 //x=8.62 //y=1.44 //x2=7.61 //y2=1.4
cc_1506 ( N_noxref_5_c_1604_n N_CLK_c_6446_n ) capacitor c=0.00438372f \
 //x=8.62 //y=1.75 //x2=7.61 //y2=1.63
cc_1507 ( N_noxref_5_c_1545_n N_CLK_c_6447_n ) capacitor c=0.00137098f \
 //x=8.63 //y=2.375 //x2=7.61 //y2=2.095
cc_1508 ( N_noxref_5_c_1588_n N_CLK_c_6447_n ) capacitor c=0.00209664f \
 //x=8.63 //y=2.26 //x2=7.61 //y2=2.095
cc_1509 ( N_noxref_5_c_1617_n N_CLK_c_6447_n ) capacitor c=0.00933826f \
 //x=8.63 //y=2.26 //x2=7.61 //y2=2.095
cc_1510 ( N_noxref_5_c_1618_n N_CLK_c_6447_n ) capacitor c=0.00438372f \
 //x=8.63 //y=2.095 //x2=7.61 //y2=2.095
cc_1511 ( N_noxref_5_c_1620_n N_CLK_c_6521_n ) capacitor c=0.0616777f //x=8.63 \
 //y=4.88 //x2=7.855 //y2=4.97
cc_1512 ( N_noxref_5_c_1743_p N_CLK_c_6586_n ) capacitor c=0.00170831f \
 //x=17.33 //y=5.335 //x2=17.475 //y2=4.97
cc_1513 ( N_noxref_5_c_1744_p N_CLK_c_6586_n ) capacitor c=0.00295522f \
 //x=17.33 //y=5.56 //x2=17.475 //y2=4.97
cc_1514 ( N_noxref_5_c_1589_n N_CLK_c_6450_n ) capacitor c=9.77556e-19 \
 //x=8.63 //y=4.88 //x2=7.52 //y2=4.88
cc_1515 ( N_noxref_5_c_1620_n N_CLK_c_6450_n ) capacitor c=0.0042693f //x=8.63 \
 //y=4.88 //x2=7.52 //y2=4.88
cc_1516 ( N_noxref_5_c_1496_n N_CLK_c_6496_n ) capacitor c=3.54644e-19 \
 //x=17.21 //y=5.335 //x2=17.14 //y2=4.88
cc_1517 ( N_noxref_5_c_1563_n RN ) capacitor c=0.0475066f //x=18.99 //y=3.735 \
 //x2=18.25 //y2=2.77
cc_1518 ( N_noxref_5_c_1569_n RN ) capacitor c=0.0152522f //x=18.99 //y=4.055 \
 //x2=18.25 //y2=2.77
cc_1519 ( N_noxref_5_c_1571_n RN ) capacitor c=0.0261307f //x=18.99 //y=5.25 \
 //x2=18.25 //y2=2.77
cc_1520 ( N_noxref_5_c_1792_p RN ) capacitor c=9.19401e-19 //x=18.99 //y=3.88 \
 //x2=18.25 //y2=2.77
cc_1521 ( N_noxref_5_c_1504_n RN ) capacitor c=0.0216043f //x=18.82 //y=3.88 \
 //x2=18.25 //y2=2.77
cc_1522 ( N_noxref_5_c_1576_n RN ) capacitor c=0.00340182f //x=20.705 \
 //y=3.895 //x2=18.25 //y2=2.77
cc_1523 ( N_noxref_5_c_1563_n RN ) capacitor c=0.00180128f //x=18.99 //y=3.735 \
 //x2=21.95 //y2=2.77
cc_1524 ( N_noxref_5_c_1571_n RN ) capacitor c=6.61562e-19 //x=18.99 //y=5.25 \
 //x2=21.95 //y2=2.77
cc_1525 ( N_noxref_5_c_1574_n RN ) capacitor c=0.0265996f //x=21.05 //y=3.895 \
 //x2=21.95 //y2=2.77
cc_1526 ( N_noxref_5_c_1798_p N_RN_c_8045_n ) capacitor c=4.88647e-19 \
 //x=18.505 //y=1.305 //x2=18.25 //y2=2.565
cc_1527 ( N_noxref_5_c_1563_n N_RN_c_8045_n ) capacitor c=0.0217159f //x=18.99 \
 //y=3.735 //x2=18.25 //y2=2.565
cc_1528 ( N_noxref_5_c_1800_p N_RN_c_8045_n ) capacitor c=4.4094e-19 //x=18.21 \
 //y=5.335 //x2=18.25 //y2=2.565
cc_1529 ( N_noxref_5_c_1624_n N_RN_c_8048_n ) capacitor c=0.00228791f \
 //x=18.905 //y=5.335 //x2=18.25 //y2=4.75
cc_1530 ( N_noxref_5_c_1571_n N_RN_c_8048_n ) capacitor c=0.0150881f //x=18.99 \
 //y=5.25 //x2=18.25 //y2=4.75
cc_1531 ( N_noxref_5_c_1800_p N_RN_c_8048_n ) capacitor c=0.0221596f //x=18.21 \
 //y=5.335 //x2=18.25 //y2=4.75
cc_1532 ( N_noxref_5_c_1804_p N_RN_c_8048_n ) capacitor c=0.00266871f \
 //x=18.21 //y=5.56 //x2=18.25 //y2=4.75
cc_1533 ( N_noxref_5_c_1545_n N_RN_c_7855_n ) capacitor c=0.0160806f //x=8.63 \
 //y=2.375 //x2=13.795 //y2=2.4
cc_1534 ( N_noxref_5_c_1468_n N_RN_c_7855_n ) capacitor c=0.0129637f //x=8.63 \
 //y=3.735 //x2=13.795 //y2=2.4
cc_1535 ( N_noxref_5_c_1480_n N_RN_c_7855_n ) capacitor c=0.0167111f //x=13.44 \
 //y=2.375 //x2=13.795 //y2=2.4
cc_1536 ( N_noxref_5_c_1475_n N_RN_c_7855_n ) capacitor c=0.0154065f //x=13.44 \
 //y=3.735 //x2=13.795 //y2=2.4
cc_1537 ( N_noxref_5_c_1478_n N_RN_c_7855_n ) capacitor c=0.00451461f \
 //x=13.28 //y=3.895 //x2=13.795 //y2=2.4
cc_1538 ( N_noxref_5_c_1588_n N_RN_c_7855_n ) capacitor c=2.63835e-19 //x=8.63 \
 //y=2.26 //x2=13.795 //y2=2.4
cc_1539 ( N_noxref_5_c_1507_n N_RN_c_7855_n ) capacitor c=2.63835e-19 \
 //x=13.44 //y=2.26 //x2=13.795 //y2=2.4
cc_1540 ( N_noxref_5_c_1617_n N_RN_c_7855_n ) capacitor c=3.41298e-19 //x=8.63 \
 //y=2.26 //x2=13.795 //y2=2.4
cc_1541 ( N_noxref_5_c_1539_n N_RN_c_7855_n ) capacitor c=3.41298e-19 \
 //x=13.44 //y=2.26 //x2=13.795 //y2=2.4
cc_1542 ( N_noxref_5_c_1497_n N_RN_c_7947_n ) capacitor c=0.021648f //x=18.59 \
 //y=1.845 //x2=21.785 //y2=2.4
cc_1543 ( N_noxref_5_c_1563_n N_RN_c_7947_n ) capacitor c=0.0300597f //x=18.99 \
 //y=3.735 //x2=21.785 //y2=2.4
cc_1544 ( N_noxref_5_c_1574_n N_RN_c_7947_n ) capacitor c=0.00274327f \
 //x=21.05 //y=3.895 //x2=21.785 //y2=2.4
cc_1545 ( N_noxref_5_c_1798_p N_RN_c_7903_n ) capacitor c=3.86337e-19 \
 //x=18.505 //y=1.305 //x2=18.415 //y2=2.4
cc_1546 ( N_noxref_5_c_1563_n N_RN_c_7903_n ) capacitor c=0.00328982f \
 //x=18.99 //y=3.735 //x2=18.415 //y2=2.4
cc_1547 ( N_noxref_5_c_1574_n N_RN_c_7953_n ) capacitor c=0.00211409f \
 //x=21.05 //y=3.895 //x2=23.57 //y2=2.37
cc_1548 ( N_noxref_5_c_1654_p N_RN_c_8024_n ) capacitor c=0.0160734f //x=27.87 \
 //y=2.375 //x2=42.825 //y2=2.385
cc_1549 ( N_noxref_5_c_1626_n N_RN_c_8024_n ) capacitor c=0.0156253f //x=27.87 \
 //y=3.725 //x2=42.825 //y2=2.385
cc_1550 ( N_noxref_5_c_1656_p N_RN_c_8024_n ) capacitor c=2.63835e-19 \
 //x=27.87 //y=2.26 //x2=42.825 //y2=2.385
cc_1551 ( N_noxref_5_c_1657_p N_RN_c_8024_n ) capacitor c=3.41298e-19 \
 //x=27.87 //y=2.26 //x2=42.825 //y2=2.385
cc_1552 ( N_noxref_5_c_1563_n N_RN_c_8071_n ) capacitor c=9.86766e-19 \
 //x=18.99 //y=3.735 //x2=18.25 //y2=2.26
cc_1553 ( N_noxref_5_c_1624_n N_RN_c_8072_n ) capacitor c=0.00130631f \
 //x=18.905 //y=5.335 //x2=18.25 //y2=4.88
cc_1554 ( N_noxref_5_c_1571_n N_RN_c_8072_n ) capacitor c=0.00131258f \
 //x=18.99 //y=5.25 //x2=18.25 //y2=4.88
cc_1555 ( N_noxref_5_c_1800_p N_RN_c_8072_n ) capacitor c=0.00346456f \
 //x=18.21 //y=5.335 //x2=18.25 //y2=4.88
cc_1556 ( N_noxref_5_c_1804_p N_RN_c_8072_n ) capacitor c=0.00624059f \
 //x=18.21 //y=5.56 //x2=18.25 //y2=4.88
cc_1557 ( N_noxref_5_c_1773_p N_RN_M83_noxref_g ) capacitor c=0.00955829f \
 //x=18.095 //y=5.335 //x2=17.99 //y2=6.2
cc_1558 ( N_noxref_5_c_1623_n N_RN_M83_noxref_g ) capacitor c=0.00226521f \
 //x=18.21 //y=5.56 //x2=17.99 //y2=6.2
cc_1559 ( N_noxref_5_c_1804_p N_RN_M83_noxref_g ) capacitor c=0.0178885f \
 //x=18.21 //y=5.56 //x2=17.99 //y2=6.2
cc_1560 ( N_noxref_5_c_1623_n N_RN_M84_noxref_g ) capacitor c=0.00381703f \
 //x=18.21 //y=5.56 //x2=18.43 //y2=6.2
cc_1561 ( N_noxref_5_c_1624_n N_RN_M84_noxref_g ) capacitor c=0.0108688f \
 //x=18.905 //y=5.335 //x2=18.43 //y2=6.2
cc_1562 ( N_noxref_5_c_1804_p N_RN_M84_noxref_g ) capacitor c=0.0188608f \
 //x=18.21 //y=5.56 //x2=18.43 //y2=6.2
cc_1563 ( N_noxref_5_c_1798_p N_RN_c_8082_n ) capacitor c=4.64015e-19 \
 //x=18.505 //y=1.305 //x2=18.24 //y2=1.095
cc_1564 ( N_noxref_5_M11_noxref_d N_RN_c_8082_n ) capacitor c=0.00137165f \
 //x=18.315 //y=1.095 //x2=18.24 //y2=1.095
cc_1565 ( N_noxref_5_c_1798_p N_RN_c_8084_n ) capacitor c=0.0026012f \
 //x=18.505 //y=1.305 //x2=18.24 //y2=1.44
cc_1566 ( N_noxref_5_c_1838_p N_RN_c_8084_n ) capacitor c=0.00127432f \
 //x=18.505 //y=1.76 //x2=18.24 //y2=1.44
cc_1567 ( N_noxref_5_M11_noxref_d N_RN_c_8084_n ) capacitor c=0.00237422f \
 //x=18.315 //y=1.095 //x2=18.24 //y2=1.44
cc_1568 ( N_noxref_5_c_1838_p N_RN_c_8087_n ) capacitor c=0.00441386f \
 //x=18.505 //y=1.76 //x2=18.24 //y2=1.75
cc_1569 ( N_noxref_5_c_1798_p N_RN_c_8088_n ) capacitor c=5.29969e-19 \
 //x=18.505 //y=1.305 //x2=18.615 //y2=0.94
cc_1570 ( N_noxref_5_M11_noxref_d N_RN_c_8088_n ) capacitor c=0.0020782f \
 //x=18.315 //y=1.095 //x2=18.615 //y2=0.94
cc_1571 ( N_noxref_5_c_1798_p N_RN_c_8090_n ) capacitor c=4.41409e-19 \
 //x=18.505 //y=1.305 //x2=18.615 //y2=1.595
cc_1572 ( N_noxref_5_c_1838_p N_RN_c_8090_n ) capacitor c=0.00942306f \
 //x=18.505 //y=1.76 //x2=18.615 //y2=1.595
cc_1573 ( N_noxref_5_c_1625_n N_RN_c_8090_n ) capacitor c=0.00194716f \
 //x=18.905 //y=1.845 //x2=18.615 //y2=1.595
cc_1574 ( N_noxref_5_M11_noxref_d N_RN_c_8090_n ) capacitor c=0.00356097f \
 //x=18.315 //y=1.095 //x2=18.615 //y2=1.595
cc_1575 ( N_noxref_5_c_1798_p N_RN_c_8094_n ) capacitor c=5.24634e-19 \
 //x=18.505 //y=1.305 //x2=18.77 //y2=1.095
cc_1576 ( N_noxref_5_M11_noxref_d N_RN_c_8094_n ) capacitor c=0.00139206f \
 //x=18.315 //y=1.095 //x2=18.77 //y2=1.095
cc_1577 ( N_noxref_5_c_1798_p N_RN_c_8096_n ) capacitor c=0.00307978f \
 //x=18.505 //y=1.305 //x2=18.77 //y2=1.44
cc_1578 ( N_noxref_5_c_1838_p N_RN_c_8096_n ) capacitor c=0.00363411f \
 //x=18.505 //y=1.76 //x2=18.77 //y2=1.44
cc_1579 ( N_noxref_5_c_1625_n N_RN_c_8096_n ) capacitor c=0.00323576f \
 //x=18.905 //y=1.845 //x2=18.77 //y2=1.44
cc_1580 ( N_noxref_5_M11_noxref_d N_RN_c_8096_n ) capacitor c=0.00237422f \
 //x=18.315 //y=1.095 //x2=18.77 //y2=1.44
cc_1581 ( N_noxref_5_c_1563_n N_RN_c_8100_n ) capacitor c=0.00117465f \
 //x=18.99 //y=3.735 //x2=18.25 //y2=2.26
cc_1582 ( N_noxref_5_c_1838_p N_RN_c_8101_n ) capacitor c=0.0036273f \
 //x=18.505 //y=1.76 //x2=18.25 //y2=2.095
cc_1583 ( N_noxref_5_c_1563_n N_RN_c_8101_n ) capacitor c=0.00282067f \
 //x=18.99 //y=3.735 //x2=18.25 //y2=2.095
cc_1584 ( N_noxref_5_c_1571_n N_RN_c_8103_n ) capacitor c=0.00739875f \
 //x=18.99 //y=5.25 //x2=18.25 //y2=4.88
cc_1585 ( N_noxref_5_c_1800_p N_RN_c_8103_n ) capacitor c=0.00203307f \
 //x=18.21 //y=5.335 //x2=18.25 //y2=4.88
cc_1586 ( N_noxref_5_c_1804_p N_RN_c_8103_n ) capacitor c=0.00375636f \
 //x=18.21 //y=5.56 //x2=18.25 //y2=4.88
cc_1587 ( N_noxref_5_c_1475_n SN ) capacitor c=0.0141637f //x=13.44 //y=3.735 \
 //x2=12.33 //y2=2.77
cc_1588 ( N_noxref_5_c_1507_n SN ) capacitor c=3.9149e-19 //x=13.44 //y=2.26 \
 //x2=12.33 //y2=2.77
cc_1589 ( N_noxref_5_c_1626_n SN ) capacitor c=0.0150475f //x=27.87 //y=3.725 \
 //x2=26.76 //y2=2.77
cc_1590 ( N_noxref_5_c_1656_p SN ) capacitor c=3.9149e-19 //x=27.87 //y=2.26 \
 //x2=26.76 //y2=2.77
cc_1591 ( N_noxref_5_c_1475_n SN ) capacitor c=5.01652e-19 //x=13.44 //y=3.735 \
 //x2=12.33 //y2=3.14
cc_1592 ( N_noxref_5_c_1626_n SN ) capacitor c=3.43503e-19 //x=27.87 //y=3.725 \
 //x2=26.76 //y2=3.14
cc_1593 ( N_noxref_5_c_1480_n N_SN_c_9841_n ) capacitor c=0.00934497f \
 //x=13.44 //y=2.375 //x2=12.33 //y2=2.375
cc_1594 ( N_noxref_5_c_1507_n N_SN_c_9841_n ) capacitor c=5.42289e-19 \
 //x=13.44 //y=2.26 //x2=12.33 //y2=2.375
cc_1595 ( N_noxref_5_c_1539_n N_SN_c_9841_n ) capacitor c=0.00134951f \
 //x=13.44 //y=2.26 //x2=12.33 //y2=2.375
cc_1596 ( N_noxref_5_c_1475_n N_SN_c_9844_n ) capacitor c=0.00786461f \
 //x=13.44 //y=3.735 //x2=12.33 //y2=3.285
cc_1597 ( N_noxref_5_c_1475_n N_SN_c_9845_n ) capacitor c=0.0110327f //x=13.44 \
 //y=3.735 //x2=12.33 //y2=4.765
cc_1598 ( N_noxref_5_c_1488_n N_SN_c_9845_n ) capacitor c=0.0078001f //x=13.44 \
 //y=4.055 //x2=12.33 //y2=4.765
cc_1599 ( N_noxref_5_c_1477_n N_SN_c_9845_n ) capacitor c=0.0256195f //x=13.44 \
 //y=4.75 //x2=12.33 //y2=4.765
cc_1600 ( N_noxref_5_c_1498_n N_SN_c_9845_n ) capacitor c=5.01652e-19 \
 //x=13.44 //y=3.88 //x2=12.33 //y2=4.765
cc_1601 ( N_noxref_5_c_1478_n N_SN_c_9845_n ) capacitor c=0.0229186f //x=13.28 \
 //y=3.895 //x2=12.33 //y2=4.765
cc_1602 ( N_noxref_5_c_1506_n N_SN_c_9845_n ) capacitor c=0.0024779f //x=13.6 \
 //y=3.895 //x2=12.33 //y2=4.765
cc_1603 ( N_noxref_5_c_1508_n N_SN_c_9845_n ) capacitor c=7.51101e-19 \
 //x=13.44 //y=4.88 //x2=12.33 //y2=4.765
cc_1604 ( N_noxref_5_c_1542_n N_SN_c_9845_n ) capacitor c=0.00124604f \
 //x=13.44 //y=4.88 //x2=12.33 //y2=4.765
cc_1605 ( N_noxref_5_c_1654_p N_SN_c_9931_n ) capacitor c=0.00932964f \
 //x=27.87 //y=2.375 //x2=26.76 //y2=2.375
cc_1606 ( N_noxref_5_c_1656_p N_SN_c_9931_n ) capacitor c=5.42289e-19 \
 //x=27.87 //y=2.26 //x2=26.76 //y2=2.375
cc_1607 ( N_noxref_5_c_1657_p N_SN_c_9931_n ) capacitor c=0.00134951f \
 //x=27.87 //y=2.26 //x2=26.76 //y2=2.375
cc_1608 ( N_noxref_5_c_1626_n N_SN_c_9934_n ) capacitor c=0.00671686f \
 //x=27.87 //y=3.725 //x2=26.76 //y2=3.305
cc_1609 ( N_noxref_5_c_1626_n N_SN_c_9935_n ) capacitor c=0.00961333f \
 //x=27.87 //y=3.725 //x2=26.76 //y2=4.765
cc_1610 ( N_noxref_5_c_1633_p N_SN_c_9935_n ) capacitor c=0.00772613f \
 //x=27.87 //y=4.045 //x2=26.76 //y2=4.765
cc_1611 ( N_noxref_5_c_1628_n N_SN_c_9935_n ) capacitor c=0.0254652f //x=27.87 \
 //y=4.75 //x2=26.76 //y2=4.765
cc_1612 ( N_noxref_5_c_1663_p N_SN_c_9935_n ) capacitor c=3.43503e-19 \
 //x=27.87 //y=3.88 //x2=26.76 //y2=4.765
cc_1613 ( N_noxref_5_c_1574_n N_SN_c_9935_n ) capacitor c=0.0251585f //x=21.05 \
 //y=3.895 //x2=26.76 //y2=4.765
cc_1614 ( N_noxref_5_c_1639_p N_SN_c_9935_n ) capacitor c=7.51101e-19 \
 //x=27.87 //y=4.88 //x2=26.76 //y2=4.765
cc_1615 ( N_noxref_5_c_1666_p N_SN_c_9935_n ) capacitor c=0.00124604f \
 //x=27.87 //y=4.88 //x2=26.76 //y2=4.765
cc_1616 ( N_noxref_5_c_1475_n N_SN_c_9884_n ) capacitor c=0.0242609f //x=13.44 \
 //y=3.735 //x2=13.795 //y2=3.14
cc_1617 ( N_noxref_5_c_1504_n N_SN_c_9884_n ) capacitor c=0.00667238f \
 //x=18.82 //y=3.88 //x2=13.795 //y2=3.14
cc_1618 ( N_noxref_5_c_1478_n N_SN_c_9884_n ) capacitor c=0.0059666f //x=13.28 \
 //y=3.895 //x2=13.795 //y2=3.14
cc_1619 ( N_noxref_5_c_1504_n N_SN_c_9887_n ) capacitor c=0.00888265f \
 //x=18.82 //y=3.88 //x2=14.395 //y2=3.155
cc_1620 ( N_noxref_5_c_1504_n N_SN_c_9890_n ) capacitor c=0.00356173f \
 //x=18.82 //y=3.88 //x2=15.655 //y2=3.14
cc_1621 ( N_noxref_5_c_1504_n N_SN_c_9894_n ) capacitor c=0.0211848f //x=18.82 \
 //y=3.88 //x2=16.255 //y2=3.155
cc_1622 ( N_noxref_5_c_1563_n N_SN_c_9915_n ) capacitor c=0.0262127f //x=18.99 \
 //y=3.735 //x2=20.45 //y2=3.14
cc_1623 ( N_noxref_5_c_1576_n N_SN_c_9915_n ) capacitor c=0.0138642f \
 //x=20.705 //y=3.895 //x2=20.45 //y2=3.14
cc_1624 ( N_noxref_5_c_1574_n N_SN_c_9918_n ) capacitor c=0.00436932f \
 //x=21.05 //y=3.895 //x2=21.05 //y2=3.125
cc_1625 ( N_noxref_5_c_1626_n N_SN_c_9921_n ) capacitor c=0.026821f //x=27.87 \
 //y=3.725 //x2=32.475 //y2=3.13
cc_1626 ( N_noxref_5_c_1574_n N_SN_c_9921_n ) capacitor c=0.10817f //x=21.05 \
 //y=3.895 //x2=32.475 //y2=3.13
cc_1627 ( N_noxref_5_c_1475_n N_SN_c_9849_n ) capacitor c=0.00237766f \
 //x=13.44 //y=3.735 //x2=12.49 //y2=3.125
cc_1628 ( N_noxref_5_c_1480_n N_SN_c_9850_n ) capacitor c=5.39999e-19 \
 //x=13.44 //y=2.375 //x2=12.33 //y2=2.26
cc_1629 ( N_noxref_5_c_1475_n N_SN_c_9850_n ) capacitor c=3.9149e-19 //x=13.44 \
 //y=3.735 //x2=12.33 //y2=2.26
cc_1630 ( N_noxref_5_c_1507_n N_SN_c_9850_n ) capacitor c=0.00125213f \
 //x=13.44 //y=2.26 //x2=12.33 //y2=2.26
cc_1631 ( N_noxref_5_c_1539_n N_SN_c_9850_n ) capacitor c=0.00204868f \
 //x=13.44 //y=2.26 //x2=12.33 //y2=2.26
cc_1632 ( N_noxref_5_c_1477_n N_SN_c_9854_n ) capacitor c=9.52396e-19 \
 //x=13.44 //y=4.75 //x2=12.33 //y2=4.88
cc_1633 ( N_noxref_5_c_1508_n N_SN_c_9854_n ) capacitor c=0.00113985f \
 //x=13.44 //y=4.88 //x2=12.33 //y2=4.88
cc_1634 ( N_noxref_5_c_1542_n N_SN_c_9854_n ) capacitor c=0.00187046f \
 //x=13.44 //y=4.88 //x2=12.33 //y2=4.88
cc_1635 ( N_noxref_5_c_1654_p N_SN_c_9947_n ) capacitor c=5.39999e-19 \
 //x=27.87 //y=2.375 //x2=26.76 //y2=2.26
cc_1636 ( N_noxref_5_c_1626_n N_SN_c_9947_n ) capacitor c=3.9149e-19 //x=27.87 \
 //y=3.725 //x2=26.76 //y2=2.26
cc_1637 ( N_noxref_5_c_1656_p N_SN_c_9947_n ) capacitor c=0.00125213f \
 //x=27.87 //y=2.26 //x2=26.76 //y2=2.26
cc_1638 ( N_noxref_5_c_1657_p N_SN_c_9947_n ) capacitor c=0.00204868f \
 //x=27.87 //y=2.26 //x2=26.76 //y2=2.26
cc_1639 ( N_noxref_5_c_1628_n N_SN_c_9951_n ) capacitor c=9.52396e-19 \
 //x=27.87 //y=4.75 //x2=26.76 //y2=4.88
cc_1640 ( N_noxref_5_c_1639_p N_SN_c_9951_n ) capacitor c=0.00113985f \
 //x=27.87 //y=4.88 //x2=26.76 //y2=4.88
cc_1641 ( N_noxref_5_c_1666_p N_SN_c_9951_n ) capacitor c=0.00187046f \
 //x=27.87 //y=4.88 //x2=26.76 //y2=4.88
cc_1642 ( N_noxref_5_M77_noxref_g N_SN_M75_noxref_g ) capacitor c=0.0101598f \
 //x=13.18 //y=6.2 //x2=12.3 //y2=6.2
cc_1643 ( N_noxref_5_M77_noxref_g N_SN_M76_noxref_g ) capacitor c=0.0607518f \
 //x=13.18 //y=6.2 //x2=12.74 //y2=6.2
cc_1644 ( N_noxref_5_M78_noxref_g N_SN_M76_noxref_g ) capacitor c=0.0101598f \
 //x=13.62 //y=6.2 //x2=12.74 //y2=6.2
cc_1645 ( N_noxref_5_M95_noxref_g N_SN_M93_noxref_g ) capacitor c=0.0101598f \
 //x=27.61 //y=6.2 //x2=26.73 //y2=6.2
cc_1646 ( N_noxref_5_M95_noxref_g N_SN_M94_noxref_g ) capacitor c=0.0607518f \
 //x=27.61 //y=6.2 //x2=27.17 //y2=6.2
cc_1647 ( N_noxref_5_M96_noxref_g N_SN_M94_noxref_g ) capacitor c=0.0101598f \
 //x=28.05 //y=6.2 //x2=27.17 //y2=6.2
cc_1648 ( N_noxref_5_c_1521_n N_SN_c_9866_n ) capacitor c=0.00456962f \
 //x=13.43 //y=1.095 //x2=12.42 //y2=1.09
cc_1649 ( N_noxref_5_c_1523_n N_SN_c_9867_n ) capacitor c=0.00438372f \
 //x=13.43 //y=1.44 //x2=12.42 //y2=1.4
cc_1650 ( N_noxref_5_c_1526_n N_SN_c_9868_n ) capacitor c=0.00438372f \
 //x=13.43 //y=1.75 //x2=12.42 //y2=1.63
cc_1651 ( N_noxref_5_c_1480_n N_SN_c_9869_n ) capacitor c=0.00137098f \
 //x=13.44 //y=2.375 //x2=12.42 //y2=2.095
cc_1652 ( N_noxref_5_c_1507_n N_SN_c_9869_n ) capacitor c=0.00209664f \
 //x=13.44 //y=2.26 //x2=12.42 //y2=2.095
cc_1653 ( N_noxref_5_c_1539_n N_SN_c_9869_n ) capacitor c=0.00933826f \
 //x=13.44 //y=2.26 //x2=12.42 //y2=2.095
cc_1654 ( N_noxref_5_c_1540_n N_SN_c_9869_n ) capacitor c=0.00438372f \
 //x=13.44 //y=2.095 //x2=12.42 //y2=2.095
cc_1655 ( N_noxref_5_c_1542_n N_SN_c_9904_n ) capacitor c=0.0616777f //x=13.44 \
 //y=4.88 //x2=12.665 //y2=4.97
cc_1656 ( N_noxref_5_c_1641_p N_SN_c_9963_n ) capacitor c=0.00456962f \
 //x=27.86 //y=1.095 //x2=26.85 //y2=1.09
cc_1657 ( N_noxref_5_c_1642_p N_SN_c_9964_n ) capacitor c=0.00438372f \
 //x=27.86 //y=1.44 //x2=26.85 //y2=1.4
cc_1658 ( N_noxref_5_c_1648_p N_SN_c_9965_n ) capacitor c=0.00438372f \
 //x=27.86 //y=1.75 //x2=26.85 //y2=1.63
cc_1659 ( N_noxref_5_c_1654_p N_SN_c_9966_n ) capacitor c=0.00137098f \
 //x=27.87 //y=2.375 //x2=26.85 //y2=2.095
cc_1660 ( N_noxref_5_c_1656_p N_SN_c_9966_n ) capacitor c=0.00209664f \
 //x=27.87 //y=2.26 //x2=26.85 //y2=2.095
cc_1661 ( N_noxref_5_c_1657_p N_SN_c_9966_n ) capacitor c=0.00933826f \
 //x=27.87 //y=2.26 //x2=26.85 //y2=2.095
cc_1662 ( N_noxref_5_c_1651_p N_SN_c_9966_n ) capacitor c=0.00438372f \
 //x=27.87 //y=2.095 //x2=26.85 //y2=2.095
cc_1663 ( N_noxref_5_c_1666_p N_SN_c_10049_n ) capacitor c=0.0616777f \
 //x=27.87 //y=4.88 //x2=27.095 //y2=4.97
cc_1664 ( N_noxref_5_c_1477_n N_SN_c_9872_n ) capacitor c=8.42568e-19 \
 //x=13.44 //y=4.75 //x2=12.33 //y2=4.88
cc_1665 ( N_noxref_5_c_1508_n N_SN_c_9872_n ) capacitor c=0.00129812f \
 //x=13.44 //y=4.88 //x2=12.33 //y2=4.88
cc_1666 ( N_noxref_5_c_1542_n N_SN_c_9872_n ) capacitor c=0.00487508f \
 //x=13.44 //y=4.88 //x2=12.33 //y2=4.88
cc_1667 ( N_noxref_5_c_1628_n N_SN_c_9969_n ) capacitor c=8.42568e-19 \
 //x=27.87 //y=4.75 //x2=26.76 //y2=4.88
cc_1668 ( N_noxref_5_c_1639_p N_SN_c_9969_n ) capacitor c=0.00129812f \
 //x=27.87 //y=4.88 //x2=26.76 //y2=4.88
cc_1669 ( N_noxref_5_c_1666_p N_SN_c_9969_n ) capacitor c=0.00487508f \
 //x=27.87 //y=4.88 //x2=26.76 //y2=4.88
cc_1670 ( N_noxref_5_c_1496_n N_VDD_c_13434_n ) capacitor c=0.0060074f \
 //x=17.21 //y=5.335 //x2=87.775 //y2=7.585
cc_1671 ( N_noxref_5_c_1773_p N_VDD_c_13434_n ) capacitor c=0.00627192f \
 //x=18.095 //y=5.335 //x2=87.775 //y2=7.585
cc_1672 ( N_noxref_5_c_1623_n N_VDD_c_13434_n ) capacitor c=0.00256036f \
 //x=18.21 //y=5.56 //x2=87.775 //y2=7.585
cc_1673 ( N_noxref_5_c_1624_n N_VDD_c_13434_n ) capacitor c=0.00829247f \
 //x=18.905 //y=5.335 //x2=87.775 //y2=7.585
cc_1674 ( N_noxref_5_c_1569_n N_VDD_c_13434_n ) capacitor c=5.13442e-19 \
 //x=18.99 //y=4.055 //x2=87.775 //y2=7.585
cc_1675 ( N_noxref_5_c_1499_n N_VDD_c_13434_n ) capacitor c=0.00261804f \
 //x=16.452 //y=5.335 //x2=87.775 //y2=7.585
cc_1676 ( N_noxref_5_c_1743_p N_VDD_c_13434_n ) capacitor c=0.00261962f \
 //x=17.33 //y=5.335 //x2=87.775 //y2=7.585
cc_1677 ( N_noxref_5_c_1512_n N_VDD_c_13434_n ) capacitor c=0.0024232f \
 //x=16.45 //y=5.56 //x2=87.775 //y2=7.585
cc_1678 ( N_noxref_5_c_1744_p N_VDD_c_13434_n ) capacitor c=0.0024232f \
 //x=17.33 //y=5.56 //x2=87.775 //y2=7.585
cc_1679 ( N_noxref_5_c_1804_p N_VDD_c_13434_n ) capacitor c=0.0024232f \
 //x=18.21 //y=5.56 //x2=87.775 //y2=7.585
cc_1680 ( N_noxref_5_M71_noxref_g N_VDD_c_13567_n ) capacitor c=0.00755544f \
 //x=8.37 //y=6.2 //x2=8.945 //y2=7.585
cc_1681 ( N_noxref_5_M72_noxref_g N_VDD_c_13567_n ) capacitor c=0.00755754f \
 //x=8.81 //y=6.2 //x2=8.945 //y2=7.585
cc_1682 ( N_noxref_5_M77_noxref_g N_VDD_c_13512_n ) capacitor c=0.00755544f \
 //x=13.18 //y=6.2 //x2=13.755 //y2=7.585
cc_1683 ( N_noxref_5_M78_noxref_g N_VDD_c_13512_n ) capacitor c=0.00755754f \
 //x=13.62 //y=6.2 //x2=13.755 //y2=7.585
cc_1684 ( N_noxref_5_c_1496_n N_VDD_c_13517_n ) capacitor c=0.00202922f \
 //x=17.21 //y=5.335 //x2=16.805 //y2=7.585
cc_1685 ( N_noxref_5_c_1499_n N_VDD_c_13517_n ) capacitor c=9.3757e-19 \
 //x=16.452 //y=5.335 //x2=16.805 //y2=7.585
cc_1686 ( N_noxref_5_c_1512_n N_VDD_c_13517_n ) capacitor c=0.0138074f \
 //x=16.45 //y=5.56 //x2=16.805 //y2=7.585
cc_1687 ( N_noxref_5_c_1496_n N_VDD_c_13674_n ) capacitor c=0.0017708f \
 //x=17.21 //y=5.335 //x2=17.685 //y2=7.585
cc_1688 ( N_noxref_5_c_1773_p N_VDD_c_13674_n ) capacitor c=0.00202922f \
 //x=18.095 //y=5.335 //x2=17.685 //y2=7.585
cc_1689 ( N_noxref_5_c_1743_p N_VDD_c_13674_n ) capacitor c=9.4822e-19 \
 //x=17.33 //y=5.335 //x2=17.685 //y2=7.585
cc_1690 ( N_noxref_5_c_1744_p N_VDD_c_13674_n ) capacitor c=0.0138074f \
 //x=17.33 //y=5.56 //x2=17.685 //y2=7.585
cc_1691 ( N_noxref_5_c_1773_p N_VDD_c_13678_n ) capacitor c=0.00205906f \
 //x=18.095 //y=5.335 //x2=18.565 //y2=7.585
cc_1692 ( N_noxref_5_c_1623_n N_VDD_c_13678_n ) capacitor c=8.49654e-19 \
 //x=18.21 //y=5.56 //x2=18.565 //y2=7.585
cc_1693 ( N_noxref_5_c_1624_n N_VDD_c_13678_n ) capacitor c=0.00204238f \
 //x=18.905 //y=5.335 //x2=18.565 //y2=7.585
cc_1694 ( N_noxref_5_c_1804_p N_VDD_c_13678_n ) capacitor c=0.0138074f \
 //x=18.21 //y=5.56 //x2=18.565 //y2=7.585
cc_1695 ( N_noxref_5_c_1624_n N_VDD_c_13682_n ) capacitor c=0.00183742f \
 //x=18.905 //y=5.335 //x2=19.56 //y2=7.585
cc_1696 ( N_noxref_5_M95_noxref_g N_VDD_c_13683_n ) capacitor c=0.00755544f \
 //x=27.61 //y=6.2 //x2=28.185 //y2=7.585
cc_1697 ( N_noxref_5_M96_noxref_g N_VDD_c_13683_n ) capacitor c=0.00755754f \
 //x=28.05 //y=6.2 //x2=28.185 //y2=7.585
cc_1698 ( N_noxref_5_c_1589_n N_VDD_c_13467_n ) capacitor c=0.00224736f \
 //x=8.63 //y=4.88 //x2=10.11 //y2=7.585
cc_1699 ( N_noxref_5_c_1620_n N_VDD_c_13467_n ) capacitor c=2.63786e-19 \
 //x=8.63 //y=4.88 //x2=10.11 //y2=7.585
cc_1700 ( N_noxref_5_c_1499_n N_VDD_c_13521_n ) capacitor c=0.0022955f \
 //x=16.452 //y=5.335 //x2=14.92 //y2=7.585
cc_1701 ( N_noxref_5_c_1508_n N_VDD_c_13521_n ) capacitor c=0.00224736f \
 //x=13.44 //y=4.88 //x2=14.92 //y2=7.585
cc_1702 ( N_noxref_5_c_1512_n N_VDD_c_13521_n ) capacitor c=0.00509469f \
 //x=16.45 //y=5.56 //x2=14.92 //y2=7.585
cc_1703 ( N_noxref_5_c_1542_n N_VDD_c_13521_n ) capacitor c=2.63786e-19 \
 //x=13.44 //y=4.88 //x2=14.92 //y2=7.585
cc_1704 ( N_noxref_5_c_1623_n N_VDD_c_13581_n ) capacitor c=0.00282782f \
 //x=18.21 //y=5.56 //x2=19.73 //y2=7.585
cc_1705 ( N_noxref_5_c_1571_n N_VDD_c_13581_n ) capacitor c=0.0327633f \
 //x=18.99 //y=5.25 //x2=19.73 //y2=7.585
cc_1706 ( N_noxref_5_c_1804_p N_VDD_c_13581_n ) capacitor c=0.00777981f \
 //x=18.21 //y=5.56 //x2=19.73 //y2=7.585
cc_1707 ( N_noxref_5_c_1639_p N_VDD_c_13694_n ) capacitor c=0.00102691f \
 //x=27.87 //y=4.88 //x2=29.35 //y2=7.585
cc_1708 ( N_noxref_5_M71_noxref_g N_VDD_M70_noxref_d ) capacitor c=0.015318f \
 //x=8.37 //y=6.2 //x2=8.005 //y2=5.2
cc_1709 ( N_noxref_5_M72_noxref_g N_VDD_M72_noxref_d ) capacitor c=0.0394719f \
 //x=8.81 //y=6.2 //x2=8.885 //y2=5.2
cc_1710 ( N_noxref_5_M77_noxref_g N_VDD_M76_noxref_d ) capacitor c=0.015318f \
 //x=13.18 //y=6.2 //x2=12.815 //y2=5.2
cc_1711 ( N_noxref_5_M78_noxref_g N_VDD_M78_noxref_d ) capacitor c=0.0394719f \
 //x=13.62 //y=6.2 //x2=13.695 //y2=5.2
cc_1712 ( N_noxref_5_c_1499_n N_VDD_M79_noxref_s ) capacitor c=0.0442713f \
 //x=16.452 //y=5.335 //x2=15.875 //y2=5.2
cc_1713 ( N_noxref_5_c_1743_p N_VDD_M79_noxref_s ) capacitor c=7.80122e-19 \
 //x=17.33 //y=5.335 //x2=15.875 //y2=5.2
cc_1714 ( N_noxref_5_c_1512_n N_VDD_M79_noxref_s ) capacitor c=0.09305f \
 //x=16.45 //y=5.56 //x2=15.875 //y2=5.2
cc_1715 ( N_noxref_5_c_1496_n N_VDD_M80_noxref_d ) capacitor c=0.00700141f \
 //x=17.21 //y=5.335 //x2=16.745 //y2=5.2
cc_1716 ( N_noxref_5_c_1512_n N_VDD_M80_noxref_d ) capacitor c=0.0674491f \
 //x=16.45 //y=5.56 //x2=16.745 //y2=5.2
cc_1717 ( N_noxref_5_c_1744_p N_VDD_M80_noxref_d ) capacitor c=0.0674762f \
 //x=17.33 //y=5.56 //x2=16.745 //y2=5.2
cc_1718 ( N_noxref_5_c_1773_p N_VDD_M82_noxref_d ) capacitor c=0.00700141f \
 //x=18.095 //y=5.335 //x2=17.625 //y2=5.2
cc_1719 ( N_noxref_5_c_1744_p N_VDD_M82_noxref_d ) capacitor c=0.067493f \
 //x=17.33 //y=5.56 //x2=17.625 //y2=5.2
cc_1720 ( N_noxref_5_c_1804_p N_VDD_M82_noxref_d ) capacitor c=0.0674979f \
 //x=18.21 //y=5.56 //x2=17.625 //y2=5.2
cc_1721 ( N_noxref_5_c_1624_n N_VDD_M84_noxref_d ) capacitor c=0.00700141f \
 //x=18.905 //y=5.335 //x2=18.505 //y2=5.2
cc_1722 ( N_noxref_5_c_1804_p N_VDD_M84_noxref_d ) capacitor c=0.0675002f \
 //x=18.21 //y=5.56 //x2=18.505 //y2=5.2
cc_1723 ( N_noxref_5_c_1623_n N_VDD_M85_noxref_s ) capacitor c=0.00492616f \
 //x=18.21 //y=5.56 //x2=20.685 //y2=5.2
cc_1724 ( N_noxref_5_c_1624_n N_VDD_M85_noxref_s ) capacitor c=9.42705e-19 \
 //x=18.905 //y=5.335 //x2=20.685 //y2=5.2
cc_1725 ( N_noxref_5_c_1743_p N_VDD_M85_noxref_s ) capacitor c=2.11884e-19 \
 //x=17.33 //y=5.335 //x2=20.685 //y2=5.2
cc_1726 ( N_noxref_5_M95_noxref_g N_VDD_M94_noxref_d ) capacitor c=0.015318f \
 //x=27.61 //y=6.2 //x2=27.245 //y2=5.2
cc_1727 ( N_noxref_5_M96_noxref_g N_VDD_M96_noxref_d ) capacitor c=0.0394719f \
 //x=28.05 //y=6.2 //x2=28.125 //y2=5.2
cc_1728 ( N_noxref_5_c_1545_n N_noxref_27_c_14948_n ) capacitor c=0.00177186f \
 //x=8.63 //y=2.375 //x2=9.285 //y2=0.72
cc_1729 ( N_noxref_5_c_1588_n N_noxref_27_c_14948_n ) capacitor c=0.00117306f \
 //x=8.63 //y=2.26 //x2=9.285 //y2=0.72
cc_1730 ( N_noxref_5_c_1599_n N_noxref_27_c_14948_n ) capacitor c=0.0206349f \
 //x=8.62 //y=1.095 //x2=9.285 //y2=0.72
cc_1731 ( N_noxref_5_c_1611_n N_noxref_27_c_14948_n ) capacitor c=0.00825432f \
 //x=9.15 //y=1.095 //x2=9.285 //y2=0.72
cc_1732 ( N_noxref_5_c_1617_n N_noxref_27_c_14948_n ) capacitor c=2.20712e-19 \
 //x=8.63 //y=2.26 //x2=9.285 //y2=0.72
cc_1733 ( N_noxref_5_c_1601_n N_noxref_27_c_14951_n ) capacitor c=0.0071177f \
 //x=8.62 //y=1.44 //x2=8.4 //y2=1.175
cc_1734 ( N_noxref_5_c_1599_n N_noxref_27_M5_noxref_s ) capacitor c=0.0071177f \
 //x=8.62 //y=1.095 //x2=8.265 //y2=0.555
cc_1735 ( N_noxref_5_c_1604_n N_noxref_27_M5_noxref_s ) capacitor c=0.0071177f \
 //x=8.62 //y=1.75 //x2=8.265 //y2=0.555
cc_1736 ( N_noxref_5_c_1611_n N_noxref_27_M5_noxref_s ) capacitor c=0.015333f \
 //x=9.15 //y=1.095 //x2=8.265 //y2=0.555
cc_1737 ( N_noxref_5_c_1613_n N_noxref_27_M5_noxref_s ) capacitor \
 c=0.00248746f //x=9.15 //y=1.44 //x2=8.265 //y2=0.555
cc_1738 ( N_noxref_5_c_1480_n N_noxref_28_c_15014_n ) capacitor c=0.00177186f \
 //x=13.44 //y=2.375 //x2=14.095 //y2=0.72
cc_1739 ( N_noxref_5_c_1507_n N_noxref_28_c_15014_n ) capacitor c=0.00117306f \
 //x=13.44 //y=2.26 //x2=14.095 //y2=0.72
cc_1740 ( N_noxref_5_c_1521_n N_noxref_28_c_15014_n ) capacitor c=0.0206349f \
 //x=13.43 //y=1.095 //x2=14.095 //y2=0.72
cc_1741 ( N_noxref_5_c_1533_n N_noxref_28_c_15014_n ) capacitor c=0.00825432f \
 //x=13.96 //y=1.095 //x2=14.095 //y2=0.72
cc_1742 ( N_noxref_5_c_1539_n N_noxref_28_c_15014_n ) capacitor c=2.20712e-19 \
 //x=13.44 //y=2.26 //x2=14.095 //y2=0.72
cc_1743 ( N_noxref_5_c_1523_n N_noxref_28_c_15017_n ) capacitor c=0.0071177f \
 //x=13.43 //y=1.44 //x2=13.21 //y2=1.175
cc_1744 ( N_noxref_5_c_1488_n N_noxref_28_M8_noxref_s ) capacitor \
 c=9.71372e-19 //x=13.44 //y=4.055 //x2=13.075 //y2=0.555
cc_1745 ( N_noxref_5_c_1521_n N_noxref_28_M8_noxref_s ) capacitor c=0.0071177f \
 //x=13.43 //y=1.095 //x2=13.075 //y2=0.555
cc_1746 ( N_noxref_5_c_1526_n N_noxref_28_M8_noxref_s ) capacitor c=0.0071177f \
 //x=13.43 //y=1.75 //x2=13.075 //y2=0.555
cc_1747 ( N_noxref_5_c_1533_n N_noxref_28_M8_noxref_s ) capacitor c=0.015333f \
 //x=13.96 //y=1.095 //x2=13.075 //y2=0.555
cc_1748 ( N_noxref_5_c_1535_n N_noxref_28_M8_noxref_s ) capacitor \
 c=0.00248746f //x=13.96 //y=1.44 //x2=13.075 //y2=0.555
cc_1749 ( N_noxref_5_c_1798_p N_noxref_29_c_15083_n ) capacitor c=0.0036878f \
 //x=18.505 //y=1.305 //x2=18.905 //y2=0.72
cc_1750 ( N_noxref_5_c_1625_n N_noxref_29_c_15083_n ) capacitor c=0.00399931f \
 //x=18.905 //y=1.845 //x2=18.905 //y2=0.72
cc_1751 ( N_noxref_5_M11_noxref_d N_noxref_29_c_15083_n ) capacitor \
 c=0.00910163f //x=18.315 //y=1.095 //x2=18.905 //y2=0.72
cc_1752 ( N_noxref_5_M11_noxref_d N_noxref_29_c_15086_n ) capacitor \
 c=0.00120711f //x=18.315 //y=1.095 //x2=18.02 //y2=1.175
cc_1753 ( N_noxref_5_c_1496_n N_noxref_29_M10_noxref_d ) capacitor \
 c=0.00149054f //x=17.21 //y=5.335 //x2=16.78 //y2=1.09
cc_1754 ( N_noxref_5_c_1798_p N_noxref_29_M10_noxref_d ) capacitor \
 c=0.00802417f //x=18.505 //y=1.305 //x2=16.78 //y2=1.09
cc_1755 ( N_noxref_5_c_1798_p N_noxref_29_M11_noxref_s ) capacitor \
 c=0.0098487f //x=18.505 //y=1.305 //x2=17.885 //y2=0.555
cc_1756 ( N_noxref_5_c_1838_p N_noxref_29_M11_noxref_s ) capacitor \
 c=0.0283243f //x=18.505 //y=1.76 //x2=17.885 //y2=0.555
cc_1757 ( N_noxref_5_c_1625_n N_noxref_29_M11_noxref_s ) capacitor \
 c=0.00911719f //x=18.905 //y=1.845 //x2=17.885 //y2=0.555
cc_1758 ( N_noxref_5_c_1792_p N_noxref_29_M11_noxref_s ) capacitor \
 c=0.00129723f //x=18.99 //y=3.88 //x2=17.885 //y2=0.555
cc_1759 ( N_noxref_5_M11_noxref_d N_noxref_29_M11_noxref_s ) capacitor \
 c=0.0279003f //x=18.315 //y=1.095 //x2=17.885 //y2=0.555
cc_1760 ( N_noxref_5_c_1798_p N_noxref_30_M13_noxref_d ) capacitor \
 c=3.20746e-19 //x=18.505 //y=1.305 //x2=21.59 //y2=1.09
cc_1761 ( N_noxref_5_c_1654_p N_noxref_31_c_15218_n ) capacitor c=0.00177186f \
 //x=27.87 //y=2.375 //x2=28.525 //y2=0.72
cc_1762 ( N_noxref_5_c_1656_p N_noxref_31_c_15218_n ) capacitor c=0.00117306f \
 //x=27.87 //y=2.26 //x2=28.525 //y2=0.72
cc_1763 ( N_noxref_5_c_1641_p N_noxref_31_c_15218_n ) capacitor c=0.0206349f \
 //x=27.86 //y=1.095 //x2=28.525 //y2=0.72
cc_1764 ( N_noxref_5_c_1645_p N_noxref_31_c_15218_n ) capacitor c=0.00825432f \
 //x=28.39 //y=1.095 //x2=28.525 //y2=0.72
cc_1765 ( N_noxref_5_c_1657_p N_noxref_31_c_15218_n ) capacitor c=2.20712e-19 \
 //x=27.87 //y=2.26 //x2=28.525 //y2=0.72
cc_1766 ( N_noxref_5_c_1642_p N_noxref_31_c_15223_n ) capacitor c=0.0071177f \
 //x=27.86 //y=1.44 //x2=27.64 //y2=1.175
cc_1767 ( N_noxref_5_c_1633_p N_noxref_31_M17_noxref_s ) capacitor \
 c=9.73433e-19 //x=27.87 //y=4.045 //x2=27.505 //y2=0.555
cc_1768 ( N_noxref_5_c_1641_p N_noxref_31_M17_noxref_s ) capacitor \
 c=0.0071177f //x=27.86 //y=1.095 //x2=27.505 //y2=0.555
cc_1769 ( N_noxref_5_c_1648_p N_noxref_31_M17_noxref_s ) capacitor \
 c=0.0071177f //x=27.86 //y=1.75 //x2=27.505 //y2=0.555
cc_1770 ( N_noxref_5_c_1645_p N_noxref_31_M17_noxref_s ) capacitor c=0.015333f \
 //x=28.39 //y=1.095 //x2=27.505 //y2=0.555
cc_1771 ( N_noxref_5_c_1646_p N_noxref_31_M17_noxref_s ) capacitor \
 c=0.00248746f //x=28.39 //y=1.44 //x2=27.505 //y2=0.555
cc_1772 ( N_noxref_5_c_1545_n N_GND_c_16501_n ) capacitor c=0.00196498f \
 //x=8.63 //y=2.375 //x2=11.1 //y2=0.175
cc_1773 ( N_noxref_5_c_1480_n N_GND_c_16460_n ) capacitor c=0.00196498f \
 //x=13.44 //y=2.375 //x2=15.91 //y2=0.175
cc_1774 ( N_noxref_5_c_1798_p N_GND_c_16584_n ) capacitor c=0.00884007f \
 //x=18.505 //y=1.305 //x2=20.72 //y2=0.175
cc_1775 ( N_noxref_5_c_1625_n N_GND_c_16584_n ) capacitor c=0.00662992f \
 //x=18.905 //y=1.845 //x2=20.72 //y2=0.175
cc_1776 ( N_noxref_5_c_1569_n N_GND_c_16584_n ) capacitor c=3.09244e-19 \
 //x=18.99 //y=4.055 //x2=20.72 //y2=0.175
cc_1777 ( N_noxref_5_M11_noxref_d N_GND_c_16584_n ) capacitor c=2.9462e-19 \
 //x=18.315 //y=1.095 //x2=20.72 //y2=0.175
cc_1778 ( N_noxref_5_c_1654_p N_GND_c_16588_n ) capacitor c=0.00196498f \
 //x=27.87 //y=2.375 //x2=30.34 //y2=0.175
cc_1779 ( N_noxref_5_c_1798_p N_GND_c_16509_n ) capacitor c=0.00543195f \
 //x=18.505 //y=1.305 //x2=20.805 //y2=1.145
cc_1780 ( N_noxref_5_c_1545_n N_GND_c_16423_n ) capacitor c=2.016e-19 //x=8.63 \
 //y=2.375 //x2=9.94 //y2=0.175
cc_1781 ( N_noxref_5_c_1480_n N_GND_c_16424_n ) capacitor c=2.016e-19 \
 //x=13.44 //y=2.375 //x2=14.75 //y2=0.175
cc_1782 ( N_noxref_5_c_1625_n N_GND_c_16480_n ) capacitor c=6.86343e-19 \
 //x=18.905 //y=1.845 //x2=19.56 //y2=0.175
cc_1783 ( N_noxref_5_c_1654_p N_GND_c_16562_n ) capacitor c=2.016e-19 \
 //x=27.87 //y=2.375 //x2=29.18 //y2=0.175
cc_1784 ( N_noxref_5_c_1588_n N_GND_c_16438_n ) capacitor c=0.00222376f \
 //x=8.63 //y=2.26 //x2=10.11 //y2=0.175
cc_1785 ( N_noxref_5_c_1613_n N_GND_c_16438_n ) capacitor c=0.00262688f \
 //x=9.15 //y=1.44 //x2=10.11 //y2=0.175
cc_1786 ( N_noxref_5_c_1507_n N_GND_c_16481_n ) capacitor c=0.00222376f \
 //x=13.44 //y=2.26 //x2=14.92 //y2=0.175
cc_1787 ( N_noxref_5_c_1535_n N_GND_c_16481_n ) capacitor c=0.00262688f \
 //x=13.96 //y=1.44 //x2=14.92 //y2=0.175
cc_1788 ( N_noxref_5_c_1838_p N_GND_c_16530_n ) capacitor c=0.0045138f \
 //x=18.505 //y=1.76 //x2=19.73 //y2=0.175
cc_1789 ( N_noxref_5_c_1625_n N_GND_c_16530_n ) capacitor c=0.0319165f \
 //x=18.905 //y=1.845 //x2=19.73 //y2=0.175
cc_1790 ( N_noxref_5_c_1656_p N_GND_c_16600_n ) capacitor c=0.00222376f \
 //x=27.87 //y=2.26 //x2=29.35 //y2=0.175
cc_1791 ( N_noxref_5_c_1646_p N_GND_c_16600_n ) capacitor c=0.00262688f \
 //x=28.39 //y=1.44 //x2=29.35 //y2=0.175
cc_1792 ( N_noxref_5_c_1657_p N_GND_c_16600_n ) capacitor c=2.63786e-19 \
 //x=27.87 //y=2.26 //x2=29.35 //y2=0.175
cc_1793 ( N_noxref_6_c_2205_p N_noxref_7_c_2977_n ) capacitor c=0.00126312f \
 //x=35.94 //y=5.3 //x2=33.335 //y2=5.335
cc_1794 ( N_noxref_6_c_2158_n N_noxref_7_c_2978_n ) capacitor c=0.00163399f \
 //x=28.525 //y=1.845 //x2=33.02 //y2=1.845
cc_1795 ( N_noxref_6_c_2207_p N_noxref_7_c_2979_n ) capacitor c=0.0276242f \
 //x=35.77 //y=4.99 //x2=33.42 //y2=5.25
cc_1796 ( N_noxref_6_c_2208_p N_noxref_7_c_2979_n ) capacitor c=0.00263238f \
 //x=35.855 //y=5.215 //x2=33.42 //y2=5.25
cc_1797 ( N_noxref_6_c_2207_p N_noxref_7_c_2981_n ) capacitor c=0.0198527f \
 //x=35.77 //y=4.99 //x2=35.27 //y2=4.755
cc_1798 ( N_noxref_6_c_2210_p N_noxref_7_c_2982_n ) capacitor c=0.020103f \
 //x=45.28 //y=4.99 //x2=40.08 //y2=4.755
cc_1799 ( N_noxref_6_c_2141_n N_noxref_7_c_2983_n ) capacitor c=6.09703e-19 \
 //x=27.83 //y=5.56 //x2=30.882 //y2=5.335
cc_1800 ( N_noxref_6_c_2180_n N_noxref_7_c_2983_n ) capacitor c=0.00306432f \
 //x=28.61 //y=4.995 //x2=30.882 //y2=5.335
cc_1801 ( N_noxref_6_c_2207_p N_noxref_7_c_2983_n ) capacitor c=0.151451f \
 //x=35.77 //y=4.99 //x2=30.882 //y2=5.335
cc_1802 ( N_noxref_6_c_2207_p N_noxref_7_M103_noxref_g ) capacitor \
 c=0.00367571f //x=35.77 //y=4.99 //x2=35.47 //y2=6.2
cc_1803 ( N_noxref_6_c_2208_p N_noxref_7_M104_noxref_g ) capacitor \
 c=5.42926e-19 //x=35.855 //y=5.215 //x2=35.91 //y2=6.2
cc_1804 ( N_noxref_6_c_2210_p N_noxref_7_M109_noxref_g ) capacitor \
 c=0.00367571f //x=45.28 //y=4.99 //x2=40.28 //y2=6.2
cc_1805 ( N_noxref_6_c_2210_p N_noxref_7_M110_noxref_g ) capacitor \
 c=9.21451e-19 //x=45.28 //y=4.99 //x2=40.72 //y2=6.2
cc_1806 ( N_noxref_6_c_2207_p N_noxref_7_c_2990_n ) capacitor c=3.3021e-19 \
 //x=35.77 //y=4.99 //x2=35.835 //y2=4.97
cc_1807 ( N_noxref_6_c_2210_p N_noxref_7_c_2991_n ) capacitor c=9.76057e-19 \
 //x=45.28 //y=4.99 //x2=40.645 //y2=4.97
cc_1808 ( N_noxref_6_c_2210_p N_noxref_7_c_2992_n ) capacitor c=6.58497e-19 \
 //x=45.28 //y=4.99 //x2=40.355 //y2=4.97
cc_1809 ( N_noxref_6_c_2221_p N_noxref_8_c_3416_n ) capacitor c=0.00133566f \
 //x=45.45 //y=5.3 //x2=42.955 //y2=5.335
cc_1810 ( N_noxref_6_c_2210_p N_noxref_8_c_3417_n ) capacitor c=0.0276242f \
 //x=45.28 //y=4.99 //x2=43.04 //y2=5.25
cc_1811 ( N_noxref_6_c_2223_p N_noxref_8_c_3417_n ) capacitor c=0.00199128f \
 //x=45.365 //y=5.215 //x2=43.04 //y2=5.25
cc_1812 ( N_noxref_6_c_2210_p N_noxref_8_c_3419_n ) capacitor c=0.0196059f \
 //x=45.28 //y=4.99 //x2=44.89 //y2=4.755
cc_1813 ( N_noxref_6_c_2210_p N_noxref_8_c_3420_n ) capacitor c=0.150035f \
 //x=45.28 //y=4.99 //x2=40.502 //y2=5.335
cc_1814 ( N_noxref_6_c_2210_p N_noxref_8_M115_noxref_g ) capacitor \
 c=0.00367571f //x=45.28 //y=4.99 //x2=45.09 //y2=6.2
cc_1815 ( N_noxref_6_c_2227_p N_noxref_8_M116_noxref_g ) capacitor \
 c=4.67989e-19 //x=46.515 //y=5.3 //x2=45.53 //y2=6.2
cc_1816 ( N_noxref_6_c_2210_p N_noxref_8_c_3423_n ) capacitor c=3.74596e-19 \
 //x=45.28 //y=4.99 //x2=45.455 //y2=4.97
cc_1817 ( N_noxref_6_c_2210_p N_noxref_8_c_3424_n ) capacitor c=6.11874e-19 \
 //x=45.28 //y=4.99 //x2=45.165 //y2=4.97
cc_1818 ( N_noxref_6_c_2207_p N_noxref_9_c_3715_n ) capacitor c=0.0165599f \
 //x=35.77 //y=4.99 //x2=32.68 //y2=4.75
cc_1819 ( N_noxref_6_c_2231_p N_noxref_9_c_3716_n ) capacitor c=0.03415f \
 //x=36.805 //y=5.3 //x2=36.45 //y2=5.335
cc_1820 ( N_noxref_6_c_2205_p N_noxref_9_c_3716_n ) capacitor c=0.014872f \
 //x=35.94 //y=5.3 //x2=36.45 //y2=5.335
cc_1821 ( N_noxref_6_c_2231_p N_noxref_9_c_3718_n ) capacitor c=0.0356604f \
 //x=36.805 //y=5.3 //x2=37.335 //y2=5.335
cc_1822 ( N_noxref_6_c_2210_p N_noxref_9_c_3718_n ) capacitor c=0.0655937f \
 //x=45.28 //y=4.99 //x2=37.335 //y2=5.335
cc_1823 ( N_noxref_6_c_2207_p N_noxref_9_c_3720_n ) capacitor c=5.35278e-19 \
 //x=35.77 //y=4.99 //x2=38.23 //y2=5.25
cc_1824 ( N_noxref_6_c_2236_p N_noxref_9_c_3720_n ) capacitor c=0.00399569f \
 //x=36.89 //y=5.215 //x2=38.23 //y2=5.25
cc_1825 ( N_noxref_6_c_2210_p N_noxref_9_c_3720_n ) capacitor c=0.0276234f \
 //x=45.28 //y=4.99 //x2=38.23 //y2=5.25
cc_1826 ( N_noxref_6_c_2238_p N_noxref_9_c_3723_n ) capacitor c=0.0201022f \
 //x=64.495 //y=4.99 //x2=49.7 //y2=4.755
cc_1827 ( N_noxref_6_c_2207_p N_noxref_9_c_3724_n ) capacitor c=0.0112219f \
 //x=35.77 //y=4.99 //x2=35.692 //y2=5.335
cc_1828 ( N_noxref_6_c_2205_p N_noxref_9_c_3724_n ) capacitor c=0.0120368f \
 //x=35.94 //y=5.3 //x2=35.692 //y2=5.335
cc_1829 ( N_noxref_6_c_2231_p N_noxref_9_c_3726_n ) capacitor c=0.021912f \
 //x=36.805 //y=5.3 //x2=36.57 //y2=5.335
cc_1830 ( N_noxref_6_c_2207_p N_noxref_9_M101_noxref_g ) capacitor \
 c=8.65429e-19 //x=35.77 //y=4.99 //x2=32.42 //y2=6.2
cc_1831 ( N_noxref_6_c_2207_p N_noxref_9_M102_noxref_g ) capacitor \
 c=8.65429e-19 //x=35.77 //y=4.99 //x2=32.86 //y2=6.2
cc_1832 ( N_noxref_6_c_2238_p N_noxref_9_M121_noxref_g ) capacitor \
 c=0.00367571f //x=64.495 //y=4.99 //x2=49.9 //y2=6.2
cc_1833 ( N_noxref_6_c_2238_p N_noxref_9_M122_noxref_g ) capacitor \
 c=9.21451e-19 //x=64.495 //y=4.99 //x2=50.34 //y2=6.2
cc_1834 ( N_noxref_6_c_2238_p N_noxref_9_c_3731_n ) capacitor c=9.76057e-19 \
 //x=64.495 //y=4.99 //x2=50.265 //y2=4.97
cc_1835 ( N_noxref_6_c_2238_p N_noxref_9_c_3732_n ) capacitor c=6.81808e-19 \
 //x=64.495 //y=4.99 //x2=49.975 //y2=4.97
cc_1836 ( N_noxref_6_c_2207_p N_noxref_9_c_3733_n ) capacitor c=2.37957e-19 \
 //x=35.77 //y=4.99 //x2=32.68 //y2=4.88
cc_1837 ( N_noxref_6_c_2238_p N_noxref_10_c_4200_n ) capacitor c=0.0276617f \
 //x=64.495 //y=4.99 //x2=52.66 //y2=5.25
cc_1838 ( N_noxref_6_c_2238_p N_noxref_10_c_4201_n ) capacitor c=0.0201537f \
 //x=64.495 //y=4.99 //x2=54.51 //y2=4.755
cc_1839 ( N_noxref_6_c_2238_p N_noxref_10_c_4202_n ) capacitor c=0.151443f \
 //x=64.495 //y=4.99 //x2=50.122 //y2=5.335
cc_1840 ( N_noxref_6_c_2238_p N_noxref_10_M127_noxref_g ) capacitor \
 c=0.00367571f //x=64.495 //y=4.99 //x2=54.71 //y2=6.2
cc_1841 ( N_noxref_6_c_2238_p N_noxref_10_M128_noxref_g ) capacitor \
 c=9.21451e-19 //x=64.495 //y=4.99 //x2=55.15 //y2=6.2
cc_1842 ( N_noxref_6_c_2238_p N_noxref_10_c_4205_n ) capacitor c=9.76057e-19 \
 //x=64.495 //y=4.99 //x2=55.075 //y2=4.97
cc_1843 ( N_noxref_6_c_2238_p N_noxref_10_c_4206_n ) capacitor c=7.28431e-19 \
 //x=64.495 //y=4.99 //x2=54.785 //y2=4.97
cc_1844 ( N_noxref_6_c_2210_p N_noxref_11_c_4499_n ) capacitor c=0.0163368f \
 //x=45.28 //y=4.99 //x2=37.49 //y2=4.75
cc_1845 ( N_noxref_6_c_2210_p N_noxref_11_c_4500_n ) capacitor c=0.0165573f \
 //x=45.28 //y=4.99 //x2=42.3 //y2=4.75
cc_1846 ( N_noxref_6_c_2227_p N_noxref_11_c_4501_n ) capacitor c=0.0442071f \
 //x=46.515 //y=5.3 //x2=46.07 //y2=5.335
cc_1847 ( N_noxref_6_c_2221_p N_noxref_11_c_4501_n ) capacitor c=0.00204112f \
 //x=45.45 //y=5.3 //x2=46.07 //y2=5.335
cc_1848 ( N_noxref_6_c_2227_p N_noxref_11_c_4503_n ) capacitor c=0.0415037f \
 //x=46.515 //y=5.3 //x2=46.955 //y2=5.335
cc_1849 ( N_noxref_6_c_2238_p N_noxref_11_c_4503_n ) capacitor c=0.0629265f \
 //x=64.495 //y=4.99 //x2=46.955 //y2=5.335
cc_1850 ( N_noxref_6_c_2210_p N_noxref_11_c_4505_n ) capacitor c=4.66265e-19 \
 //x=45.28 //y=4.99 //x2=47.85 //y2=5.25
cc_1851 ( N_noxref_6_c_2263_p N_noxref_11_c_4505_n ) capacitor c=0.00425565f \
 //x=46.6 //y=5.215 //x2=47.85 //y2=5.25
cc_1852 ( N_noxref_6_c_2238_p N_noxref_11_c_4505_n ) capacitor c=0.0276208f \
 //x=64.495 //y=4.99 //x2=47.85 //y2=5.25
cc_1853 ( N_noxref_6_c_2238_p N_noxref_11_c_4508_n ) capacitor c=0.0165573f \
 //x=64.495 //y=4.99 //x2=56.73 //y2=4.75
cc_1854 ( N_noxref_6_c_2210_p N_noxref_11_c_4509_n ) capacitor c=0.00451054f \
 //x=45.28 //y=4.99 //x2=45.312 //y2=5.335
cc_1855 ( N_noxref_6_c_2221_p N_noxref_11_c_4509_n ) capacitor c=0.0240391f \
 //x=45.45 //y=5.3 //x2=45.312 //y2=5.335
cc_1856 ( N_noxref_6_c_2227_p N_noxref_11_c_4511_n ) capacitor c=0.0215809f \
 //x=46.515 //y=5.3 //x2=46.19 //y2=5.335
cc_1857 ( N_noxref_6_c_2210_p N_noxref_11_M107_noxref_g ) capacitor \
 c=8.65429e-19 //x=45.28 //y=4.99 //x2=37.23 //y2=6.2
cc_1858 ( N_noxref_6_c_2210_p N_noxref_11_M108_noxref_g ) capacitor \
 c=8.65429e-19 //x=45.28 //y=4.99 //x2=37.67 //y2=6.2
cc_1859 ( N_noxref_6_c_2210_p N_noxref_11_M113_noxref_g ) capacitor \
 c=8.65429e-19 //x=45.28 //y=4.99 //x2=42.04 //y2=6.2
cc_1860 ( N_noxref_6_c_2210_p N_noxref_11_M114_noxref_g ) capacitor \
 c=8.65429e-19 //x=45.28 //y=4.99 //x2=42.48 //y2=6.2
cc_1861 ( N_noxref_6_c_2238_p N_noxref_11_M131_noxref_g ) capacitor \
 c=8.65429e-19 //x=64.495 //y=4.99 //x2=56.47 //y2=6.2
cc_1862 ( N_noxref_6_c_2238_p N_noxref_11_M132_noxref_g ) capacitor \
 c=8.65429e-19 //x=64.495 //y=4.99 //x2=56.91 //y2=6.2
cc_1863 ( N_noxref_6_c_2210_p N_noxref_11_c_4518_n ) capacitor c=2.37957e-19 \
 //x=45.28 //y=4.99 //x2=37.49 //y2=4.88
cc_1864 ( N_noxref_6_c_2210_p N_noxref_11_c_4519_n ) capacitor c=2.37957e-19 \
 //x=45.28 //y=4.99 //x2=42.3 //y2=4.88
cc_1865 ( N_noxref_6_c_2238_p N_noxref_11_c_4520_n ) capacitor c=2.37957e-19 \
 //x=64.495 //y=4.99 //x2=56.73 //y2=4.88
cc_1866 ( N_noxref_6_c_2160_n D ) capacitor c=0.0132783f //x=28.61 //y=3.365 \
 //x2=30.46 //y2=2.77
cc_1867 ( N_noxref_6_c_2165_n D ) capacitor c=0.00362338f //x=28.61 //y=3.685 \
 //x2=30.46 //y2=2.77
cc_1868 ( N_noxref_6_c_2166_n D ) capacitor c=0.0073f //x=28.61 //y=4.835 \
 //x2=30.46 //y2=2.77
cc_1869 ( N_noxref_6_c_2190_n D ) capacitor c=0.00339017f //x=28.085 //y=3.5 \
 //x2=30.46 //y2=2.77
cc_1870 ( N_noxref_6_c_2160_n N_D_c_5178_n ) capacitor c=0.00357748f //x=28.61 \
 //y=3.365 //x2=30.46 //y2=2.375
cc_1871 ( N_noxref_6_c_2166_n N_D_c_5179_n ) capacitor c=0.00234245f //x=28.61 \
 //y=4.835 //x2=30.46 //y2=4.395
cc_1872 ( N_noxref_6_c_2166_n N_D_c_5147_n ) capacitor c=0.00474295f //x=28.61 \
 //y=4.835 //x2=30.46 //y2=4.755
cc_1873 ( N_noxref_6_c_2180_n N_D_c_5147_n ) capacitor c=0.00105216f //x=28.61 \
 //y=4.995 //x2=30.46 //y2=4.755
cc_1874 ( N_noxref_6_c_2207_p N_D_c_5147_n ) capacitor c=0.0200065f //x=35.77 \
 //y=4.99 //x2=30.46 //y2=4.755
cc_1875 ( N_noxref_6_c_2193_n N_D_c_5147_n ) capacitor c=0.00137898f //x=28.77 \
 //y=4.995 //x2=30.46 //y2=4.755
cc_1876 ( N_noxref_6_c_2238_p N_D_c_5184_n ) capacitor c=0.019927f //x=64.495 \
 //y=4.99 //x2=59.32 //y2=4.755
cc_1877 ( N_noxref_6_c_2066_n N_D_c_5143_n ) capacitor c=0.0220533f //x=23.06 \
 //y=4.75 //x2=27.485 //y2=4.25
cc_1878 ( N_noxref_6_c_2095_n N_D_c_5143_n ) capacitor c=0.0282161f //x=26.375 \
 //y=3.51 //x2=27.485 //y2=4.25
cc_1879 ( N_noxref_6_c_2185_n N_D_c_5143_n ) capacitor c=0.00419069f \
 //x=26.975 //y=3.53 //x2=27.485 //y2=4.25
cc_1880 ( N_noxref_6_c_2187_n N_D_c_5143_n ) capacitor c=0.00425573f \
 //x=27.485 //y=3.51 //x2=27.485 //y2=4.25
cc_1881 ( N_noxref_6_c_2190_n N_D_c_5171_n ) capacitor c=0.00425573f \
 //x=28.085 //y=3.5 //x2=28.085 //y2=4.27
cc_1882 ( N_noxref_6_c_2210_p N_D_c_5190_n ) capacitor c=0.0229949f //x=45.28 \
 //y=4.99 //x2=37.705 //y2=4.28
cc_1883 ( N_noxref_6_c_2165_n N_D_c_5173_n ) capacitor c=0.003373f //x=28.61 \
 //y=3.685 //x2=37.36 //y2=4.28
cc_1884 ( N_noxref_6_c_2166_n N_D_c_5173_n ) capacitor c=0.0271931f //x=28.61 \
 //y=4.835 //x2=37.36 //y2=4.28
cc_1885 ( N_noxref_6_c_2190_n N_D_c_5173_n ) capacitor c=0.0280883f //x=28.085 \
 //y=3.5 //x2=37.36 //y2=4.28
cc_1886 ( N_noxref_6_c_2207_p N_D_c_5173_n ) capacitor c=0.0293356f //x=35.77 \
 //y=4.99 //x2=37.36 //y2=4.28
cc_1887 ( N_noxref_6_c_2231_p N_D_c_5173_n ) capacitor c=0.00423099f \
 //x=36.805 //y=5.3 //x2=37.36 //y2=4.28
cc_1888 ( N_noxref_6_c_2210_p N_D_c_5173_n ) capacitor c=0.00236773f //x=45.28 \
 //y=4.99 //x2=37.36 //y2=4.28
cc_1889 ( N_noxref_6_c_2301_p N_D_c_5173_n ) capacitor c=0.00265818f \
 //x=36.975 //y=4.99 //x2=37.36 //y2=4.28
cc_1890 ( N_noxref_6_c_2210_p N_D_c_5198_n ) capacitor c=0.0111809f //x=45.28 \
 //y=4.99 //x2=47.455 //y2=4.25
cc_1891 ( N_noxref_6_c_2227_p N_D_c_5198_n ) capacitor c=0.00525852f \
 //x=46.515 //y=5.3 //x2=47.455 //y2=4.25
cc_1892 ( N_noxref_6_c_2238_p N_D_c_5198_n ) capacitor c=0.0034507f //x=64.495 \
 //y=4.99 //x2=47.455 //y2=4.25
cc_1893 ( N_noxref_6_c_2305_p N_D_c_5198_n ) capacitor c=0.00534911f \
 //x=46.685 //y=4.99 //x2=47.455 //y2=4.25
cc_1894 ( N_noxref_6_c_2238_p N_D_c_5202_n ) capacitor c=0.0372486f //x=64.495 \
 //y=4.99 //x2=48.055 //y2=4.28
cc_1895 ( N_noxref_6_c_2238_p N_D_c_5203_n ) capacitor c=0.00230512f \
 //x=64.495 //y=4.99 //x2=56.345 //y2=4.25
cc_1896 ( N_noxref_6_c_2238_p N_D_c_5204_n ) capacitor c=0.0095558f //x=64.495 \
 //y=4.99 //x2=56.945 //y2=4.27
cc_1897 ( N_noxref_6_c_2207_p N_D_M97_noxref_g ) capacitor c=0.00367571f \
 //x=35.77 //y=4.99 //x2=30.66 //y2=6.2
cc_1898 ( N_noxref_6_c_2207_p N_D_M98_noxref_g ) capacitor c=9.21451e-19 \
 //x=35.77 //y=4.99 //x2=31.1 //y2=6.2
cc_1899 ( N_noxref_6_c_2238_p N_D_M133_noxref_g ) capacitor c=0.00367571f \
 //x=64.495 //y=4.99 //x2=59.52 //y2=6.2
cc_1900 ( N_noxref_6_c_2238_p N_D_M134_noxref_g ) capacitor c=9.21451e-19 \
 //x=64.495 //y=4.99 //x2=59.96 //y2=6.2
cc_1901 ( N_noxref_6_c_2207_p N_D_c_5209_n ) capacitor c=9.76057e-19 //x=35.77 \
 //y=4.99 //x2=31.025 //y2=4.97
cc_1902 ( N_noxref_6_c_2238_p N_D_c_5210_n ) capacitor c=9.76057e-19 \
 //x=64.495 //y=4.99 //x2=59.885 //y2=4.97
cc_1903 ( N_noxref_6_c_2238_p N_D_c_5211_n ) capacitor c=7.17648e-19 \
 //x=64.495 //y=4.99 //x2=59.595 //y2=4.97
cc_1904 ( N_noxref_6_c_2316_p N_noxref_13_c_5671_n ) capacitor c=0.00145407f \
 //x=64.665 //y=5.325 //x2=62.195 //y2=5.335
cc_1905 ( N_noxref_6_c_2238_p N_noxref_13_c_5672_n ) capacitor c=0.0276242f \
 //x=64.495 //y=4.99 //x2=62.28 //y2=5.25
cc_1906 ( N_noxref_6_c_2318_p N_noxref_13_c_5672_n ) capacitor c=0.00200091f \
 //x=64.58 //y=5.24 //x2=62.28 //y2=5.25
cc_1907 ( N_noxref_6_c_2238_p N_noxref_13_c_5674_n ) capacitor c=0.0195316f \
 //x=64.495 //y=4.99 //x2=64.13 //y2=4.755
cc_1908 ( N_noxref_6_c_2320_p N_noxref_13_c_5675_n ) capacitor c=0.020103f \
 //x=74.21 //y=4.99 //x2=68.94 //y2=4.755
cc_1909 ( N_noxref_6_c_2238_p N_noxref_13_c_5676_n ) capacitor c=0.151451f \
 //x=64.495 //y=4.99 //x2=59.742 //y2=5.335
cc_1910 ( N_noxref_6_c_2238_p N_noxref_13_M139_noxref_g ) capacitor \
 c=0.00367571f //x=64.495 //y=4.99 //x2=64.33 //y2=6.2
cc_1911 ( N_noxref_6_c_2323_p N_noxref_13_M140_noxref_g ) capacitor \
 c=0.00398202f //x=65.76 //y=5.325 //x2=64.77 //y2=6.2
cc_1912 ( N_noxref_6_c_2320_p N_noxref_13_M145_noxref_g ) capacitor \
 c=0.00367571f //x=74.21 //y=4.99 //x2=69.14 //y2=6.2
cc_1913 ( N_noxref_6_c_2320_p N_noxref_13_M146_noxref_g ) capacitor \
 c=9.21451e-19 //x=74.21 //y=4.99 //x2=69.58 //y2=6.2
cc_1914 ( N_noxref_6_c_2238_p N_noxref_13_c_5681_n ) capacitor c=3.84419e-19 \
 //x=64.495 //y=4.99 //x2=64.695 //y2=4.97
cc_1915 ( N_noxref_6_c_2320_p N_noxref_13_c_5682_n ) capacitor c=9.76057e-19 \
 //x=74.21 //y=4.99 //x2=69.505 //y2=4.97
cc_1916 ( N_noxref_6_c_2320_p N_noxref_13_c_5683_n ) capacitor c=6.58497e-19 \
 //x=74.21 //y=4.99 //x2=69.215 //y2=4.97
cc_1917 ( N_noxref_6_c_2329_p N_noxref_14_c_6110_n ) capacitor c=0.00128957f \
 //x=74.38 //y=5.3 //x2=71.815 //y2=5.335
cc_1918 ( N_noxref_6_c_2320_p N_noxref_14_c_6111_n ) capacitor c=0.0276242f \
 //x=74.21 //y=4.99 //x2=71.9 //y2=5.25
cc_1919 ( N_noxref_6_c_2331_p N_noxref_14_c_6111_n ) capacitor c=0.00257302f \
 //x=74.295 //y=5.215 //x2=71.9 //y2=5.25
cc_1920 ( N_noxref_6_c_2320_p N_noxref_14_c_6113_n ) capacitor c=0.0197737f \
 //x=74.21 //y=4.99 //x2=73.75 //y2=4.755
cc_1921 ( N_noxref_6_c_2320_p N_noxref_14_c_6114_n ) capacitor c=0.150035f \
 //x=74.21 //y=4.99 //x2=69.362 //y2=5.335
cc_1922 ( N_noxref_6_c_2320_p N_noxref_14_M151_noxref_g ) capacitor \
 c=0.00367571f //x=74.21 //y=4.99 //x2=73.95 //y2=6.2
cc_1923 ( N_noxref_6_c_2331_p N_noxref_14_M152_noxref_g ) capacitor \
 c=5.97742e-19 //x=74.295 //y=5.215 //x2=74.39 //y2=6.2
cc_1924 ( N_noxref_6_c_2336_p N_noxref_14_M152_noxref_g ) capacitor \
 c=2.62074e-19 //x=75.28 //y=5.3 //x2=74.39 //y2=6.2
cc_1925 ( N_noxref_6_c_2320_p N_noxref_14_c_6118_n ) capacitor c=3.35214e-19 \
 //x=74.21 //y=4.99 //x2=74.315 //y2=4.97
cc_1926 ( N_noxref_6_c_2320_p N_noxref_14_c_6119_n ) capacitor c=6.11874e-19 \
 //x=74.21 //y=4.99 //x2=74.025 //y2=4.97
cc_1927 ( N_noxref_6_c_2339_p CLK ) capacitor c=0.00154432f //x=75.685 \
 //y=4.62 //x2=74.86 //y2=2.77
cc_1928 ( N_noxref_6_c_2207_p N_CLK_c_6592_n ) capacitor c=0.00333591f \
 //x=35.77 //y=4.99 //x2=36.375 //y2=4.835
cc_1929 ( N_noxref_6_c_2231_p N_CLK_c_6592_n ) capacitor c=0.00605322f \
 //x=36.805 //y=5.3 //x2=36.375 //y2=4.835
cc_1930 ( N_noxref_6_c_2301_p N_CLK_c_6592_n ) capacitor c=0.00386248f \
 //x=36.975 //y=4.99 //x2=36.375 //y2=4.835
cc_1931 ( N_noxref_6_c_2210_p N_CLK_c_6595_n ) capacitor c=0.00296333f \
 //x=45.28 //y=4.99 //x2=46.005 //y2=4.835
cc_1932 ( N_noxref_6_c_2227_p N_CLK_c_6595_n ) capacitor c=0.00605828f \
 //x=46.515 //y=5.3 //x2=46.005 //y2=4.835
cc_1933 ( N_noxref_6_c_2305_p N_CLK_c_6595_n ) capacitor c=0.00298009f \
 //x=46.685 //y=4.99 //x2=46.005 //y2=4.835
cc_1934 ( N_noxref_6_c_2238_p N_CLK_c_6598_n ) capacitor c=0.0029147f \
 //x=64.495 //y=4.99 //x2=65.235 //y2=4.835
cc_1935 ( N_noxref_6_c_2323_p N_CLK_c_6598_n ) capacitor c=0.00594909f \
 //x=65.76 //y=5.325 //x2=65.235 //y2=4.835
cc_1936 ( N_noxref_6_c_2348_p N_CLK_c_6598_n ) capacitor c=0.00295067f \
 //x=65.93 //y=4.99 //x2=65.235 //y2=4.835
cc_1937 ( N_noxref_6_c_2320_p N_CLK_c_6601_n ) capacitor c=0.0031547f \
 //x=74.21 //y=4.99 //x2=74.865 //y2=4.835
cc_1938 ( N_noxref_6_c_2336_p N_CLK_c_6601_n ) capacitor c=0.00605968f \
 //x=75.28 //y=5.3 //x2=74.865 //y2=4.835
cc_1939 ( N_noxref_6_c_2351_p N_CLK_c_6601_n ) capacitor c=2.56782e-19 \
 //x=75.6 //y=4.905 //x2=74.865 //y2=4.835
cc_1940 ( N_noxref_6_c_2339_p N_CLK_c_6601_n ) capacitor c=0.00258364f \
 //x=75.685 //y=4.62 //x2=74.865 //y2=4.835
cc_1941 ( N_noxref_6_c_2353_p N_CLK_c_6601_n ) capacitor c=0.00383931f \
 //x=75.6 //y=4.99 //x2=74.865 //y2=4.835
cc_1942 ( N_noxref_6_c_2166_n N_CLK_c_6606_n ) capacitor c=0.0223013f \
 //x=28.61 //y=4.835 //x2=28.825 //y2=4.61
cc_1943 ( N_noxref_6_c_2180_n N_CLK_c_6606_n ) capacitor c=0.00818915f \
 //x=28.61 //y=4.995 //x2=28.825 //y2=4.61
cc_1944 ( N_noxref_6_c_2207_p N_CLK_c_6606_n ) capacitor c=0.0115762f \
 //x=35.77 //y=4.99 //x2=28.825 //y2=4.61
cc_1945 ( N_noxref_6_c_2193_n N_CLK_c_6606_n ) capacitor c=0.0368432f \
 //x=28.77 //y=4.995 //x2=28.825 //y2=4.61
cc_1946 ( N_noxref_6_c_2066_n N_CLK_c_6473_n ) capacitor c=0.0291081f \
 //x=23.06 //y=4.75 //x2=28.395 //y2=4.61
cc_1947 ( N_noxref_6_c_2143_n N_CLK_c_6473_n ) capacitor c=0.0185163f \
 //x=28.45 //y=5.335 //x2=28.395 //y2=4.61
cc_1948 ( N_noxref_6_c_2166_n N_CLK_c_6473_n ) capacitor c=2.08045e-19 \
 //x=28.61 //y=4.835 //x2=28.395 //y2=4.61
cc_1949 ( N_noxref_6_c_2090_n N_CLK_c_6473_n ) capacitor c=0.0294454f \
 //x=26.072 //y=5.335 //x2=28.395 //y2=4.61
cc_1950 ( N_noxref_6_c_2362_p N_CLK_c_6473_n ) capacitor c=0.0378592f \
 //x=26.95 //y=5.335 //x2=28.395 //y2=4.61
cc_1951 ( N_noxref_6_c_2190_n N_CLK_c_6473_n ) capacitor c=0.00219153f \
 //x=28.085 //y=3.5 //x2=28.395 //y2=4.61
cc_1952 ( N_noxref_6_c_2231_p N_CLK_c_6616_n ) capacitor c=0.0135005f \
 //x=36.805 //y=5.3 //x2=45.845 //y2=4.62
cc_1953 ( N_noxref_6_c_2301_p N_CLK_c_6616_n ) capacitor c=0.783269f \
 //x=36.975 //y=4.99 //x2=45.845 //y2=4.62
cc_1954 ( N_noxref_6_c_2227_p N_CLK_c_6616_n ) capacitor c=0.0197703f \
 //x=46.515 //y=5.3 //x2=45.845 //y2=4.62
cc_1955 ( N_noxref_6_c_2166_n N_CLK_c_6619_n ) capacitor c=3.122e-19 //x=28.61 \
 //y=4.835 //x2=36.535 //y2=4.62
cc_1956 ( N_noxref_6_c_2207_p N_CLK_c_6619_n ) capacitor c=0.642974f //x=35.77 \
 //y=4.99 //x2=36.535 //y2=4.62
cc_1957 ( N_noxref_6_c_2231_p N_CLK_c_6619_n ) capacitor c=0.0457381f \
 //x=36.805 //y=5.3 //x2=36.535 //y2=4.62
cc_1958 ( N_noxref_6_c_2301_p N_CLK_c_6619_n ) capacitor c=0.00745748f \
 //x=36.975 //y=4.99 //x2=36.535 //y2=4.62
cc_1959 ( N_noxref_6_c_2210_p N_CLK_c_6623_n ) capacitor c=0.00578834f \
 //x=45.28 //y=4.99 //x2=59.19 //y2=4.635
cc_1960 ( N_noxref_6_c_2227_p N_CLK_c_6623_n ) capacitor c=0.0494871f \
 //x=46.515 //y=5.3 //x2=59.19 //y2=4.635
cc_1961 ( N_noxref_6_c_2238_p N_CLK_c_6623_n ) capacitor c=0.0605963f \
 //x=64.495 //y=4.99 //x2=59.19 //y2=4.635
cc_1962 ( N_noxref_6_c_2305_p N_CLK_c_6623_n ) capacitor c=1.1306f //x=46.685 \
 //y=4.99 //x2=59.19 //y2=4.635
cc_1963 ( N_noxref_6_c_2323_p N_CLK_c_6627_n ) capacitor c=0.0176022f \
 //x=65.76 //y=5.325 //x2=74.705 //y2=4.62
cc_1964 ( N_noxref_6_c_2348_p N_CLK_c_6627_n ) capacitor c=0.781044f //x=65.93 \
 //y=4.99 //x2=74.705 //y2=4.62
cc_1965 ( N_noxref_6_c_2336_p N_CLK_c_6627_n ) capacitor c=0.0162651f \
 //x=75.28 //y=5.3 //x2=74.705 //y2=4.62
cc_1966 ( N_noxref_6_c_2238_p N_CLK_c_6630_n ) capacitor c=0.461194f \
 //x=64.495 //y=4.99 //x2=65.395 //y2=4.62
cc_1967 ( N_noxref_6_c_2323_p N_CLK_c_6630_n ) capacitor c=0.0498229f \
 //x=65.76 //y=5.325 //x2=65.395 //y2=4.62
cc_1968 ( N_noxref_6_c_2348_p N_CLK_c_6630_n ) capacitor c=0.00556679f \
 //x=65.93 //y=4.99 //x2=65.395 //y2=4.62
cc_1969 ( N_noxref_6_c_2320_p N_CLK_c_6633_n ) capacitor c=0.00663872f \
 //x=74.21 //y=4.99 //x2=74.865 //y2=4.62
cc_1970 ( N_noxref_6_c_2336_p N_CLK_c_6633_n ) capacitor c=0.0318398f \
 //x=75.28 //y=5.3 //x2=74.865 //y2=4.62
cc_1971 ( N_noxref_6_c_2339_p N_CLK_c_6633_n ) capacitor c=0.0197188f \
 //x=75.685 //y=4.62 //x2=74.865 //y2=4.62
cc_1972 ( N_noxref_6_c_2353_p N_CLK_c_6633_n ) capacitor c=0.00951091f \
 //x=75.6 //y=4.99 //x2=74.865 //y2=4.62
cc_1973 ( N_noxref_6_c_2231_p N_CLK_M105_noxref_g ) capacitor c=3.56592e-19 \
 //x=36.805 //y=5.3 //x2=36.35 //y2=6.2
cc_1974 ( N_noxref_6_c_2231_p N_CLK_M106_noxref_g ) capacitor c=2.77674e-19 \
 //x=36.805 //y=5.3 //x2=36.79 //y2=6.2
cc_1975 ( N_noxref_6_c_2236_p N_CLK_M106_noxref_g ) capacitor c=5.8577e-19 \
 //x=36.89 //y=5.215 //x2=36.79 //y2=6.2
cc_1976 ( N_noxref_6_c_2227_p N_CLK_M117_noxref_g ) capacitor c=3.56592e-19 \
 //x=46.515 //y=5.3 //x2=45.97 //y2=6.2
cc_1977 ( N_noxref_6_c_2227_p N_CLK_M118_noxref_g ) capacitor c=4.67989e-19 \
 //x=46.515 //y=5.3 //x2=46.41 //y2=6.2
cc_1978 ( N_noxref_6_c_2323_p N_CLK_M141_noxref_g ) capacitor c=0.00380389f \
 //x=65.76 //y=5.325 //x2=65.21 //y2=6.2
cc_1979 ( N_noxref_6_c_2323_p N_CLK_M142_noxref_g ) capacitor c=0.00398202f \
 //x=65.76 //y=5.325 //x2=65.65 //y2=6.2
cc_1980 ( N_noxref_6_c_2336_p N_CLK_M153_noxref_g ) capacitor c=3.56592e-19 \
 //x=75.28 //y=5.3 //x2=74.83 //y2=6.2
cc_1981 ( N_noxref_6_c_2336_p N_CLK_M154_noxref_g ) capacitor c=3.89936e-19 \
 //x=75.28 //y=5.3 //x2=75.27 //y2=6.2
cc_1982 ( N_noxref_6_c_2394_p N_CLK_M154_noxref_g ) capacitor c=5.97742e-19 \
 //x=75.365 //y=5.215 //x2=75.27 //y2=6.2
cc_1983 ( N_noxref_6_c_2301_p N_CLK_c_6647_n ) capacitor c=5.20232e-19 \
 //x=36.975 //y=4.99 //x2=36.715 //y2=4.97
cc_1984 ( N_noxref_6_c_2353_p N_CLK_c_6648_n ) capacitor c=5.27042e-19 \
 //x=75.6 //y=4.99 //x2=75.195 //y2=4.97
cc_1985 ( N_noxref_6_c_2238_p N_noxref_16_c_7371_n ) capacitor c=0.0165599f \
 //x=64.495 //y=4.99 //x2=61.54 //y2=4.75
cc_1986 ( N_noxref_6_c_2323_p N_noxref_16_c_7372_n ) capacitor c=0.0422742f \
 //x=65.76 //y=5.325 //x2=65.31 //y2=5.335
cc_1987 ( N_noxref_6_c_2323_p N_noxref_16_c_7373_n ) capacitor c=0.0386704f \
 //x=65.76 //y=5.325 //x2=66.195 //y2=5.335
cc_1988 ( N_noxref_6_c_2320_p N_noxref_16_c_7373_n ) capacitor c=0.0608764f \
 //x=74.21 //y=4.99 //x2=66.195 //y2=5.335
cc_1989 ( N_noxref_6_c_2238_p N_noxref_16_c_7375_n ) capacitor c=4.66296e-19 \
 //x=64.495 //y=4.99 //x2=67.09 //y2=5.25
cc_1990 ( N_noxref_6_c_2402_p N_noxref_16_c_7375_n ) capacitor c=0.00422731f \
 //x=65.845 //y=5.24 //x2=67.09 //y2=5.25
cc_1991 ( N_noxref_6_c_2320_p N_noxref_16_c_7375_n ) capacitor c=0.0276234f \
 //x=74.21 //y=4.99 //x2=67.09 //y2=5.25
cc_1992 ( N_noxref_6_c_2404_p N_noxref_16_c_7378_n ) capacitor c=0.0323468f \
 //x=87.655 //y=4.62 //x2=78.56 //y2=4.755
cc_1993 ( N_noxref_6_c_2238_p N_noxref_16_c_7379_n ) capacitor c=0.00294181f \
 //x=64.495 //y=4.99 //x2=64.552 //y2=5.335
cc_1994 ( N_noxref_6_c_2316_p N_noxref_16_c_7379_n ) capacitor c=0.0288934f \
 //x=64.665 //y=5.325 //x2=64.552 //y2=5.335
cc_1995 ( N_noxref_6_c_2323_p N_noxref_16_c_7381_n ) capacitor c=0.0200387f \
 //x=65.76 //y=5.325 //x2=65.43 //y2=5.335
cc_1996 ( N_noxref_6_c_2238_p N_noxref_16_M137_noxref_g ) capacitor \
 c=8.65429e-19 //x=64.495 //y=4.99 //x2=61.28 //y2=6.2
cc_1997 ( N_noxref_6_c_2238_p N_noxref_16_M138_noxref_g ) capacitor \
 c=8.65429e-19 //x=64.495 //y=4.99 //x2=61.72 //y2=6.2
cc_1998 ( N_noxref_6_c_2238_p N_noxref_16_c_7384_n ) capacitor c=2.37957e-19 \
 //x=64.495 //y=4.99 //x2=61.54 //y2=4.88
cc_1999 ( N_noxref_6_c_2065_n RN ) capacitor c=0.0205749f //x=23.06 //y=3.365 \
 //x2=21.95 //y2=2.77
cc_2000 ( N_noxref_6_c_2077_n RN ) capacitor c=0.00718194f //x=23.06 //y=3.655 \
 //x2=21.95 //y2=2.77
cc_2001 ( N_noxref_6_c_2066_n RN ) capacitor c=0.0246246f //x=23.06 //y=4.75 \
 //x2=21.95 //y2=2.77
cc_2002 ( N_noxref_6_c_2067_n RN ) capacitor c=4.88641e-19 //x=23.06 //y=3.51 \
 //x2=21.95 //y2=2.77
cc_2003 ( N_noxref_6_c_2068_n RN ) capacitor c=0.00282377f //x=23.22 //y=3.51 \
 //x2=21.95 //y2=2.77
cc_2004 ( N_noxref_6_c_2100_n RN ) capacitor c=2.94497e-19 //x=23.06 //y=4.88 \
 //x2=21.95 //y2=2.77
cc_2005 ( N_noxref_6_c_2160_n RN ) capacitor c=0.00109186f //x=28.61 //y=3.365 \
 //x2=31.57 //y2=2.77
cc_2006 ( N_noxref_6_c_2166_n RN ) capacitor c=0.00107036f //x=28.61 //y=4.835 \
 //x2=31.57 //y2=2.77
cc_2007 ( N_noxref_6_c_2351_p RN ) capacitor c=0.00205929f //x=75.6 //y=4.905 \
 //x2=75.97 //y2=2.77
cc_2008 ( N_noxref_6_c_2404_p RN ) capacitor c=0.0242852f //x=87.655 //y=4.62 \
 //x2=75.97 //y2=2.77
cc_2009 ( N_noxref_6_c_2404_p RN ) capacitor c=0.0268258f //x=87.655 //y=4.62 \
 //x2=79.67 //y2=2.77
cc_2010 ( N_noxref_6_c_2069_n N_RN_c_7926_n ) capacitor c=0.00816784f \
 //x=23.06 //y=2.375 //x2=21.95 //y2=2.57
cc_2011 ( N_noxref_6_c_2065_n N_RN_c_7926_n ) capacitor c=0.00379733f \
 //x=23.06 //y=3.365 //x2=21.95 //y2=2.57
cc_2012 ( N_noxref_6_c_2099_n N_RN_c_7926_n ) capacitor c=0.00116223f \
 //x=23.06 //y=2.26 //x2=21.95 //y2=2.57
cc_2013 ( N_noxref_6_c_2131_n N_RN_c_7926_n ) capacitor c=0.00149853f \
 //x=23.06 //y=2.26 //x2=21.95 //y2=2.57
cc_2014 ( N_noxref_6_c_2066_n N_RN_c_7930_n ) capacitor c=0.0107551f //x=23.06 \
 //y=4.75 //x2=21.95 //y2=4.765
cc_2015 ( N_noxref_6_c_2100_n N_RN_c_7930_n ) capacitor c=4.56604e-19 \
 //x=23.06 //y=4.88 //x2=21.95 //y2=4.765
cc_2016 ( N_noxref_6_c_2134_n N_RN_c_7930_n ) capacitor c=0.00124604f \
 //x=23.06 //y=4.88 //x2=21.95 //y2=4.765
cc_2017 ( N_noxref_6_c_2207_p N_RN_c_8124_n ) capacitor c=0.0174005f //x=35.77 \
 //y=4.99 //x2=31.57 //y2=4.765
cc_2018 ( N_noxref_6_c_2238_p N_RN_c_8125_n ) capacitor c=0.0161509f \
 //x=64.495 //y=4.99 //x2=47.11 //y2=4.75
cc_2019 ( N_noxref_6_c_2238_p N_RN_c_8126_n ) capacitor c=0.0174005f \
 //x=64.495 //y=4.99 //x2=50.81 //y2=4.765
cc_2020 ( N_noxref_6_c_2238_p N_RN_c_8127_n ) capacitor c=0.0174005f \
 //x=64.495 //y=4.99 //x2=60.43 //y2=4.765
cc_2021 ( N_noxref_6_c_2351_p N_RN_c_8128_n ) capacitor c=0.0136817f //x=75.6 \
 //y=4.905 //x2=75.97 //y2=4.75
cc_2022 ( N_noxref_6_c_2404_p N_RN_c_8128_n ) capacitor c=0.00436785f \
 //x=87.655 //y=4.62 //x2=75.97 //y2=4.75
cc_2023 ( N_noxref_6_c_2353_p N_RN_c_8128_n ) capacitor c=0.00190712f //x=75.6 \
 //y=4.99 //x2=75.97 //y2=4.75
cc_2024 ( N_noxref_6_c_2404_p N_RN_c_8131_n ) capacitor c=0.00430801f \
 //x=87.655 //y=4.62 //x2=79.67 //y2=4.765
cc_2025 ( N_noxref_6_c_2069_n N_RN_c_7953_n ) capacitor c=0.0179285f //x=23.06 \
 //y=2.375 //x2=23.57 //y2=2.37
cc_2026 ( N_noxref_6_c_2065_n N_RN_c_7953_n ) capacitor c=0.0164373f //x=23.06 \
 //y=3.365 //x2=23.57 //y2=2.37
cc_2027 ( N_noxref_6_c_2095_n N_RN_c_7953_n ) capacitor c=0.00206365f \
 //x=26.375 //y=3.51 //x2=23.57 //y2=2.37
cc_2028 ( N_noxref_6_c_2131_n N_RN_c_7953_n ) capacitor c=3.41298e-19 \
 //x=23.06 //y=2.26 //x2=23.57 //y2=2.37
cc_2029 ( N_noxref_6_c_2095_n N_RN_c_8018_n ) capacitor c=8.44848e-19 \
 //x=26.375 //y=3.51 //x2=25.865 //y2=2.37
cc_2030 ( N_noxref_6_c_2147_n N_RN_c_8024_n ) capacitor c=7.09459e-19 \
 //x=28.125 //y=1.305 //x2=42.825 //y2=2.385
cc_2031 ( N_noxref_6_c_2088_n N_RN_c_8024_n ) capacitor c=0.0210557f //x=28.21 \
 //y=1.845 //x2=42.825 //y2=2.385
cc_2032 ( N_noxref_6_c_2160_n N_RN_c_8024_n ) capacitor c=0.0304392f //x=28.61 \
 //y=3.365 //x2=42.825 //y2=2.385
cc_2033 ( N_noxref_6_c_2095_n N_RN_c_8024_n ) capacitor c=0.00588233f \
 //x=26.375 //y=3.51 //x2=42.825 //y2=2.385
cc_2034 ( N_noxref_6_c_2185_n N_RN_c_8024_n ) capacitor c=0.00312605f \
 //x=26.975 //y=3.53 //x2=42.825 //y2=2.385
cc_2035 ( N_noxref_6_c_2187_n N_RN_c_8024_n ) capacitor c=0.00280135f \
 //x=27.485 //y=3.51 //x2=42.825 //y2=2.385
cc_2036 ( N_noxref_6_c_2190_n N_RN_c_8024_n ) capacitor c=0.00135422f \
 //x=28.085 //y=3.5 //x2=42.825 //y2=2.385
cc_2037 ( N_noxref_6_c_2069_n N_RN_c_7961_n ) capacitor c=5.39999e-19 \
 //x=23.06 //y=2.375 //x2=21.95 //y2=2.26
cc_2038 ( N_noxref_6_c_2099_n N_RN_c_7961_n ) capacitor c=0.00124908f \
 //x=23.06 //y=2.26 //x2=21.95 //y2=2.26
cc_2039 ( N_noxref_6_c_2131_n N_RN_c_7961_n ) capacitor c=0.00204796f \
 //x=23.06 //y=2.26 //x2=21.95 //y2=2.26
cc_2040 ( N_noxref_6_c_2066_n N_RN_c_7964_n ) capacitor c=9.52396e-19 \
 //x=23.06 //y=4.75 //x2=21.95 //y2=4.88
cc_2041 ( N_noxref_6_c_2100_n N_RN_c_7964_n ) capacitor c=0.00113985f \
 //x=23.06 //y=4.88 //x2=21.95 //y2=4.88
cc_2042 ( N_noxref_6_c_2134_n N_RN_c_7964_n ) capacitor c=0.00187046f \
 //x=23.06 //y=4.88 //x2=21.95 //y2=4.88
cc_2043 ( N_noxref_6_c_2207_p N_RN_c_8150_n ) capacitor c=2.3452e-19 //x=35.77 \
 //y=4.99 //x2=31.57 //y2=4.88
cc_2044 ( N_noxref_6_c_2238_p N_RN_c_8151_n ) capacitor c=2.3452e-19 \
 //x=64.495 //y=4.99 //x2=50.81 //y2=4.88
cc_2045 ( N_noxref_6_c_2238_p N_RN_c_8152_n ) capacitor c=2.3452e-19 \
 //x=64.495 //y=4.99 //x2=60.43 //y2=4.88
cc_2046 ( N_noxref_6_M89_noxref_g N_RN_M87_noxref_g ) capacitor c=0.0101598f \
 //x=22.8 //y=6.2 //x2=21.92 //y2=6.2
cc_2047 ( N_noxref_6_M89_noxref_g N_RN_M88_noxref_g ) capacitor c=0.0607518f \
 //x=22.8 //y=6.2 //x2=22.36 //y2=6.2
cc_2048 ( N_noxref_6_M90_noxref_g N_RN_M88_noxref_g ) capacitor c=0.0101598f \
 //x=23.24 //y=6.2 //x2=22.36 //y2=6.2
cc_2049 ( N_noxref_6_c_2207_p N_RN_M99_noxref_g ) capacitor c=8.65429e-19 \
 //x=35.77 //y=4.99 //x2=31.54 //y2=6.2
cc_2050 ( N_noxref_6_c_2207_p N_RN_M100_noxref_g ) capacitor c=8.73432e-19 \
 //x=35.77 //y=4.99 //x2=31.98 //y2=6.2
cc_2051 ( N_noxref_6_c_2238_p N_RN_M119_noxref_g ) capacitor c=8.65429e-19 \
 //x=64.495 //y=4.99 //x2=46.85 //y2=6.2
cc_2052 ( N_noxref_6_c_2238_p N_RN_M120_noxref_g ) capacitor c=8.65429e-19 \
 //x=64.495 //y=4.99 //x2=47.29 //y2=6.2
cc_2053 ( N_noxref_6_c_2238_p N_RN_M123_noxref_g ) capacitor c=8.65429e-19 \
 //x=64.495 //y=4.99 //x2=50.78 //y2=6.2
cc_2054 ( N_noxref_6_c_2238_p N_RN_M124_noxref_g ) capacitor c=8.73432e-19 \
 //x=64.495 //y=4.99 //x2=51.22 //y2=6.2
cc_2055 ( N_noxref_6_c_2238_p N_RN_M135_noxref_g ) capacitor c=8.65429e-19 \
 //x=64.495 //y=4.99 //x2=60.4 //y2=6.2
cc_2056 ( N_noxref_6_c_2238_p N_RN_M136_noxref_g ) capacitor c=8.73432e-19 \
 //x=64.495 //y=4.99 //x2=60.84 //y2=6.2
cc_2057 ( N_noxref_6_c_2353_p N_RN_M155_noxref_g ) capacitor c=7.56358e-19 \
 //x=75.6 //y=4.99 //x2=75.71 //y2=6.2
cc_2058 ( N_noxref_6_c_2113_n N_RN_c_7987_n ) capacitor c=0.00456962f \
 //x=23.05 //y=1.095 //x2=22.04 //y2=1.09
cc_2059 ( N_noxref_6_c_2115_n N_RN_c_7988_n ) capacitor c=0.00438372f \
 //x=23.05 //y=1.44 //x2=22.04 //y2=1.4
cc_2060 ( N_noxref_6_c_2118_n N_RN_c_7989_n ) capacitor c=0.00438372f \
 //x=23.05 //y=1.75 //x2=22.04 //y2=1.63
cc_2061 ( N_noxref_6_c_2069_n N_RN_c_7990_n ) capacitor c=6.8688e-19 //x=23.06 \
 //y=2.375 //x2=22.04 //y2=2.095
cc_2062 ( N_noxref_6_c_2099_n N_RN_c_7990_n ) capacitor c=0.00178498f \
 //x=23.06 //y=2.26 //x2=22.04 //y2=2.095
cc_2063 ( N_noxref_6_c_2131_n N_RN_c_7990_n ) capacitor c=0.0087493f //x=23.06 \
 //y=2.26 //x2=22.04 //y2=2.095
cc_2064 ( N_noxref_6_c_2132_n N_RN_c_7990_n ) capacitor c=0.00438372f \
 //x=23.06 //y=2.095 //x2=22.04 //y2=2.095
cc_2065 ( N_noxref_6_c_2134_n N_RN_c_8033_n ) capacitor c=0.0616777f //x=23.06 \
 //y=4.88 //x2=22.285 //y2=4.97
cc_2066 ( N_noxref_6_c_2207_p N_RN_c_8173_n ) capacitor c=2.33981e-19 \
 //x=35.77 //y=4.99 //x2=31.905 //y2=4.97
cc_2067 ( N_noxref_6_c_2238_p N_RN_c_8174_n ) capacitor c=2.33981e-19 \
 //x=64.495 //y=4.99 //x2=51.145 //y2=4.97
cc_2068 ( N_noxref_6_c_2238_p N_RN_c_8175_n ) capacitor c=2.33981e-19 \
 //x=64.495 //y=4.99 //x2=60.765 //y2=4.97
cc_2069 ( N_noxref_6_c_2066_n N_RN_c_7996_n ) capacitor c=8.42568e-19 \
 //x=23.06 //y=4.75 //x2=21.95 //y2=4.88
cc_2070 ( N_noxref_6_c_2100_n N_RN_c_7996_n ) capacitor c=0.00129812f \
 //x=23.06 //y=4.88 //x2=21.95 //y2=4.88
cc_2071 ( N_noxref_6_c_2134_n N_RN_c_7996_n ) capacitor c=0.00487508f \
 //x=23.06 //y=4.88 //x2=21.95 //y2=4.88
cc_2072 ( N_noxref_6_c_2238_p N_RN_c_8179_n ) capacitor c=2.37957e-19 \
 //x=64.495 //y=4.99 //x2=47.11 //y2=4.88
cc_2073 ( N_noxref_6_c_2353_p N_RN_c_8180_n ) capacitor c=0.00104288f //x=75.6 \
 //y=4.99 //x2=75.97 //y2=4.88
cc_2074 ( N_noxref_6_c_2404_p N_noxref_18_c_9551_n ) capacitor c=0.0224825f \
 //x=87.655 //y=4.62 //x2=81.435 //y2=5.335
cc_2075 ( N_noxref_6_c_2404_p N_noxref_18_c_9552_n ) capacitor c=0.0300565f \
 //x=87.655 //y=4.62 //x2=81.52 //y2=5.25
cc_2076 ( N_noxref_6_c_2404_p N_noxref_18_c_9553_n ) capacitor c=0.033021f \
 //x=87.655 //y=4.62 //x2=83.37 //y2=4.755
cc_2077 ( N_noxref_6_c_2404_p N_noxref_18_c_9554_n ) capacitor c=0.0297739f \
 //x=87.655 //y=4.62 //x2=78.982 //y2=5.335
cc_2078 ( N_noxref_6_c_2404_p N_noxref_18_c_9555_n ) capacitor c=0.0401707f \
 //x=87.655 //y=4.62 //x2=79.86 //y2=5.335
cc_2079 ( N_noxref_6_c_2160_n SN ) capacitor c=0.00173125f //x=28.61 //y=3.365 \
 //x2=26.76 //y2=2.77
cc_2080 ( N_noxref_6_c_2087_n N_SN_c_9934_n ) capacitor c=0.00127688f \
 //x=26.83 //y=5.335 //x2=26.76 //y2=3.305
cc_2081 ( N_noxref_6_c_2362_p N_SN_c_9934_n ) capacitor c=5.49982e-19 \
 //x=26.95 //y=5.335 //x2=26.76 //y2=3.305
cc_2082 ( N_noxref_6_c_2095_n N_SN_c_9934_n ) capacitor c=0.0031504f \
 //x=26.375 //y=3.51 //x2=26.76 //y2=3.305
cc_2083 ( N_noxref_6_c_2185_n N_SN_c_9934_n ) capacitor c=0.00270239f \
 //x=26.975 //y=3.53 //x2=26.76 //y2=3.305
cc_2084 ( N_noxref_6_c_2087_n N_SN_c_9935_n ) capacitor c=0.0213631f //x=26.83 \
 //y=5.335 //x2=26.76 //y2=4.765
cc_2085 ( N_noxref_6_c_2166_n N_SN_c_9935_n ) capacitor c=0.00190993f \
 //x=28.61 //y=4.835 //x2=26.76 //y2=4.765
cc_2086 ( N_noxref_6_c_2362_p N_SN_c_9935_n ) capacitor c=0.00239361f \
 //x=26.95 //y=5.335 //x2=26.76 //y2=4.765
cc_2087 ( N_noxref_6_c_2095_n N_SN_c_9935_n ) capacitor c=5.03481e-19 \
 //x=26.375 //y=3.51 //x2=26.76 //y2=4.765
cc_2088 ( N_noxref_6_c_2185_n N_SN_c_9935_n ) capacitor c=0.0226039f \
 //x=26.975 //y=3.53 //x2=26.76 //y2=4.765
cc_2089 ( N_noxref_6_c_2187_n N_SN_c_9935_n ) capacitor c=2.67406e-19 \
 //x=27.485 //y=3.51 //x2=26.76 //y2=4.765
cc_2090 ( N_noxref_6_c_2502_p N_SN_c_9935_n ) capacitor c=6.21282e-19 \
 //x=26.95 //y=5.56 //x2=26.76 //y2=4.765
cc_2091 ( N_noxref_6_c_2210_p N_SN_c_10068_n ) capacitor c=0.0174003f \
 //x=45.28 //y=4.99 //x2=41.19 //y2=4.765
cc_2092 ( N_noxref_6_c_2238_p N_SN_c_10069_n ) capacitor c=0.0174003f \
 //x=64.495 //y=4.99 //x2=55.62 //y2=4.765
cc_2093 ( N_noxref_6_c_2320_p N_SN_c_10070_n ) capacitor c=0.0174003f \
 //x=74.21 //y=4.99 //x2=70.05 //y2=4.765
cc_2094 ( N_noxref_6_c_2404_p N_SN_c_10071_n ) capacitor c=0.0307706f \
 //x=87.655 //y=4.62 //x2=84.48 //y2=4.765
cc_2095 ( N_noxref_6_c_2065_n N_SN_c_9921_n ) capacitor c=0.0241393f //x=23.06 \
 //y=3.365 //x2=32.475 //y2=3.13
cc_2096 ( N_noxref_6_c_2077_n N_SN_c_9921_n ) capacitor c=0.0061299f //x=23.06 \
 //y=3.655 //x2=32.475 //y2=3.13
cc_2097 ( N_noxref_6_c_2160_n N_SN_c_9921_n ) capacitor c=0.0253818f //x=28.61 \
 //y=3.365 //x2=32.475 //y2=3.13
cc_2098 ( N_noxref_6_c_2165_n N_SN_c_9921_n ) capacitor c=0.00624807f \
 //x=28.61 //y=3.685 //x2=32.475 //y2=3.13
cc_2099 ( N_noxref_6_c_2095_n N_SN_c_9921_n ) capacitor c=0.326322f //x=26.375 \
 //y=3.51 //x2=32.475 //y2=3.13
cc_2100 ( N_noxref_6_c_2068_n N_SN_c_9921_n ) capacitor c=0.0357422f //x=23.22 \
 //y=3.51 //x2=32.475 //y2=3.13
cc_2101 ( N_noxref_6_c_2185_n N_SN_c_9921_n ) capacitor c=0.0557366f \
 //x=26.975 //y=3.53 //x2=32.475 //y2=3.13
cc_2102 ( N_noxref_6_c_2187_n N_SN_c_9921_n ) capacitor c=0.0558942f \
 //x=27.485 //y=3.51 //x2=32.475 //y2=3.13
cc_2103 ( N_noxref_6_c_2190_n N_SN_c_9921_n ) capacitor c=0.0602407f \
 //x=28.085 //y=3.5 //x2=32.475 //y2=3.13
cc_2104 ( N_noxref_6_c_2087_n N_SN_c_9951_n ) capacitor c=0.00492634f \
 //x=26.83 //y=5.335 //x2=26.76 //y2=4.88
cc_2105 ( N_noxref_6_c_2362_p N_SN_c_9951_n ) capacitor c=0.00132214f \
 //x=26.95 //y=5.335 //x2=26.76 //y2=4.88
cc_2106 ( N_noxref_6_c_2210_p N_SN_c_10083_n ) capacitor c=2.3452e-19 \
 //x=45.28 //y=4.99 //x2=41.19 //y2=4.88
cc_2107 ( N_noxref_6_c_2238_p N_SN_c_10084_n ) capacitor c=2.3452e-19 \
 //x=64.495 //y=4.99 //x2=55.62 //y2=4.88
cc_2108 ( N_noxref_6_c_2320_p N_SN_c_10085_n ) capacitor c=2.3452e-19 \
 //x=74.21 //y=4.99 //x2=70.05 //y2=4.88
cc_2109 ( N_noxref_6_c_2087_n N_SN_M93_noxref_g ) capacitor c=0.00858241f \
 //x=26.83 //y=5.335 //x2=26.73 //y2=6.2
cc_2110 ( N_noxref_6_c_2362_p N_SN_M93_noxref_g ) capacitor c=0.00229818f \
 //x=26.95 //y=5.335 //x2=26.73 //y2=6.2
cc_2111 ( N_noxref_6_c_2502_p N_SN_M93_noxref_g ) capacitor c=0.0179041f \
 //x=26.95 //y=5.56 //x2=26.73 //y2=6.2
cc_2112 ( N_noxref_6_c_2139_n N_SN_M94_noxref_g ) capacitor c=0.00955829f \
 //x=27.715 //y=5.335 //x2=27.17 //y2=6.2
cc_2113 ( N_noxref_6_c_2362_p N_SN_M94_noxref_g ) capacitor c=0.00230699f \
 //x=26.95 //y=5.335 //x2=27.17 //y2=6.2
cc_2114 ( N_noxref_6_c_2502_p N_SN_M94_noxref_g ) capacitor c=0.0179041f \
 //x=26.95 //y=5.56 //x2=27.17 //y2=6.2
cc_2115 ( N_noxref_6_c_2210_p N_SN_M111_noxref_g ) capacitor c=8.65429e-19 \
 //x=45.28 //y=4.99 //x2=41.16 //y2=6.2
cc_2116 ( N_noxref_6_c_2210_p N_SN_M112_noxref_g ) capacitor c=8.73432e-19 \
 //x=45.28 //y=4.99 //x2=41.6 //y2=6.2
cc_2117 ( N_noxref_6_c_2238_p N_SN_M129_noxref_g ) capacitor c=8.65429e-19 \
 //x=64.495 //y=4.99 //x2=55.59 //y2=6.2
cc_2118 ( N_noxref_6_c_2238_p N_SN_M130_noxref_g ) capacitor c=8.73432e-19 \
 //x=64.495 //y=4.99 //x2=56.03 //y2=6.2
cc_2119 ( N_noxref_6_c_2320_p N_SN_M147_noxref_g ) capacitor c=8.65429e-19 \
 //x=74.21 //y=4.99 //x2=70.02 //y2=6.2
cc_2120 ( N_noxref_6_c_2320_p N_SN_M148_noxref_g ) capacitor c=8.73432e-19 \
 //x=74.21 //y=4.99 //x2=70.46 //y2=6.2
cc_2121 ( N_noxref_6_c_2362_p N_SN_c_10049_n ) capacitor c=0.00177491f \
 //x=26.95 //y=5.335 //x2=27.095 //y2=4.97
cc_2122 ( N_noxref_6_c_2502_p N_SN_c_10049_n ) capacitor c=0.00290085f \
 //x=26.95 //y=5.56 //x2=27.095 //y2=4.97
cc_2123 ( N_noxref_6_c_2210_p N_SN_c_10100_n ) capacitor c=2.33981e-19 \
 //x=45.28 //y=4.99 //x2=41.525 //y2=4.97
cc_2124 ( N_noxref_6_c_2238_p N_SN_c_10101_n ) capacitor c=2.33981e-19 \
 //x=64.495 //y=4.99 //x2=55.955 //y2=4.97
cc_2125 ( N_noxref_6_c_2320_p N_SN_c_10102_n ) capacitor c=2.33981e-19 \
 //x=74.21 //y=4.99 //x2=70.385 //y2=4.97
cc_2126 ( N_noxref_6_c_2087_n N_SN_c_9969_n ) capacitor c=5.8675e-19 //x=26.83 \
 //y=5.335 //x2=26.76 //y2=4.88
cc_2127 ( N_noxref_6_c_2320_p N_noxref_20_c_11043_n ) capacitor c=0.0161448f \
 //x=74.21 //y=4.99 //x2=66.35 //y2=4.75
cc_2128 ( N_noxref_6_c_2320_p N_noxref_20_c_11044_n ) capacitor c=0.0165573f \
 //x=74.21 //y=4.99 //x2=71.16 //y2=4.75
cc_2129 ( N_noxref_6_c_2336_p N_noxref_20_c_11045_n ) capacitor c=0.0379864f \
 //x=75.28 //y=5.3 //x2=74.93 //y2=5.335
cc_2130 ( N_noxref_6_c_2329_p N_noxref_20_c_11045_n ) capacitor c=0.0103233f \
 //x=74.38 //y=5.3 //x2=74.93 //y2=5.335
cc_2131 ( N_noxref_6_c_2336_p N_noxref_20_c_11047_n ) capacitor c=0.0356628f \
 //x=75.28 //y=5.3 //x2=75.815 //y2=5.335
cc_2132 ( N_noxref_6_c_2404_p N_noxref_20_c_11047_n ) capacitor c=0.00888997f \
 //x=87.655 //y=4.62 //x2=75.815 //y2=5.335
cc_2133 ( N_noxref_6_c_2353_p N_noxref_20_c_11047_n ) capacitor c=0.0145965f \
 //x=75.6 //y=4.99 //x2=75.815 //y2=5.335
cc_2134 ( N_noxref_6_c_2404_p N_noxref_20_c_11050_n ) capacitor c=0.0218036f \
 //x=87.655 //y=4.62 //x2=76.625 //y2=5.335
cc_2135 ( N_noxref_6_c_2394_p N_noxref_20_c_11051_n ) capacitor c=0.00397983f \
 //x=75.365 //y=5.215 //x2=76.71 //y2=5.25
cc_2136 ( N_noxref_6_c_2404_p N_noxref_20_c_11051_n ) capacitor c=0.0297057f \
 //x=87.655 //y=4.62 //x2=76.71 //y2=5.25
cc_2137 ( N_noxref_6_c_2353_p N_noxref_20_c_11051_n ) capacitor c=0.00269793f \
 //x=75.6 //y=4.99 //x2=76.71 //y2=5.25
cc_2138 ( N_noxref_6_c_2550_p N_noxref_20_c_11054_n ) capacitor c=0.002759f \
 //x=87.81 //y=4.46 //x2=85.59 //y2=3.725
cc_2139 ( N_noxref_6_c_2550_p N_noxref_20_c_11055_n ) capacitor c=7.24481e-19 \
 //x=87.81 //y=4.46 //x2=85.59 //y2=4.75
cc_2140 ( N_noxref_6_c_2404_p N_noxref_20_c_11055_n ) capacitor c=0.0285034f \
 //x=87.655 //y=4.62 //x2=85.59 //y2=4.75
cc_2141 ( N_noxref_6_c_2320_p N_noxref_20_c_11057_n ) capacitor c=0.00890299f \
 //x=74.21 //y=4.99 //x2=74.172 //y2=5.335
cc_2142 ( N_noxref_6_c_2329_p N_noxref_20_c_11057_n ) capacitor c=0.0163985f \
 //x=74.38 //y=5.3 //x2=74.172 //y2=5.335
cc_2143 ( N_noxref_6_c_2336_p N_noxref_20_c_11059_n ) capacitor c=0.0215809f \
 //x=75.28 //y=5.3 //x2=75.05 //y2=5.335
cc_2144 ( N_noxref_6_c_2336_p N_noxref_20_c_11060_n ) capacitor c=0.00138749f \
 //x=75.28 //y=5.3 //x2=76.54 //y2=3.88
cc_2145 ( N_noxref_6_c_2339_p N_noxref_20_c_11060_n ) capacitor c=0.00688774f \
 //x=75.685 //y=4.62 //x2=76.54 //y2=3.88
cc_2146 ( N_noxref_6_c_2353_p N_noxref_20_c_11060_n ) capacitor c=0.00136601f \
 //x=75.6 //y=4.99 //x2=76.54 //y2=3.88
cc_2147 ( N_noxref_6_c_2404_p N_noxref_20_c_11063_n ) capacitor c=0.0410983f \
 //x=87.655 //y=4.62 //x2=78.77 //y2=3.895
cc_2148 ( N_noxref_6_c_2404_p N_noxref_20_c_11064_n ) capacitor c=0.00995922f \
 //x=87.655 //y=4.62 //x2=78.425 //y2=3.895
cc_2149 ( N_noxref_6_c_2320_p N_noxref_20_M143_noxref_g ) capacitor \
 c=8.65429e-19 //x=74.21 //y=4.99 //x2=66.09 //y2=6.2
cc_2150 ( N_noxref_6_c_2320_p N_noxref_20_M144_noxref_g ) capacitor \
 c=8.65429e-19 //x=74.21 //y=4.99 //x2=66.53 //y2=6.2
cc_2151 ( N_noxref_6_c_2320_p N_noxref_20_M149_noxref_g ) capacitor \
 c=8.65429e-19 //x=74.21 //y=4.99 //x2=70.9 //y2=6.2
cc_2152 ( N_noxref_6_c_2320_p N_noxref_20_M150_noxref_g ) capacitor \
 c=8.65429e-19 //x=74.21 //y=4.99 //x2=71.34 //y2=6.2
cc_2153 ( N_noxref_6_c_2320_p N_noxref_20_c_11069_n ) capacitor c=2.37957e-19 \
 //x=74.21 //y=4.99 //x2=66.35 //y2=4.88
cc_2154 ( N_noxref_6_c_2320_p N_noxref_20_c_11070_n ) capacitor c=2.37957e-19 \
 //x=74.21 //y=4.99 //x2=71.16 //y2=4.88
cc_2155 ( N_noxref_6_c_2404_p N_noxref_21_c_11652_n ) capacitor c=0.0297766f \
 //x=87.655 //y=4.62 //x2=80.78 //y2=4.75
cc_2156 ( N_noxref_6_c_2404_p N_noxref_21_c_11653_n ) capacitor c=0.0218849f \
 //x=87.655 //y=4.62 //x2=86.245 //y2=5.335
cc_2157 ( N_noxref_6_c_2569_p N_noxref_21_c_11654_n ) capacitor c=0.00269961f \
 //x=87.81 //y=2.375 //x2=86.33 //y2=2.245
cc_2158 ( N_noxref_6_c_2569_p N_noxref_21_c_11655_n ) capacitor c=0.00137247f \
 //x=87.81 //y=2.375 //x2=86.33 //y2=2.565
cc_2159 ( N_noxref_6_c_2550_p N_noxref_21_c_11655_n ) capacitor c=0.0018829f \
 //x=87.81 //y=4.46 //x2=86.33 //y2=2.565
cc_2160 ( N_noxref_6_c_2550_p N_noxref_21_c_11657_n ) capacitor c=0.0399709f \
 //x=87.81 //y=4.46 //x2=86.33 //y2=5.25
cc_2161 ( N_noxref_6_c_2573_p N_noxref_21_c_11657_n ) capacitor c=0.00519395f \
 //x=87.81 //y=4.62 //x2=86.33 //y2=5.25
cc_2162 ( N_noxref_6_c_2404_p N_noxref_21_c_11657_n ) capacitor c=0.0294482f \
 //x=87.655 //y=4.62 //x2=86.33 //y2=5.25
cc_2163 ( N_noxref_6_c_2575_p N_noxref_21_c_11657_n ) capacitor c=0.00191609f \
 //x=87.975 //y=4.62 //x2=86.33 //y2=5.25
cc_2164 ( N_noxref_6_c_2576_p N_noxref_21_c_11661_n ) capacitor c=0.00285505f \
 //x=91.51 //y=2.385 //x2=92.99 //y2=2.43
cc_2165 ( N_noxref_6_c_2577_p N_noxref_21_c_11661_n ) capacitor c=3.9525e-19 \
 //x=91.51 //y=4.475 //x2=92.99 //y2=2.43
cc_2166 ( N_noxref_6_c_2578_p N_noxref_21_c_11661_n ) capacitor c=5.86738e-19 \
 //x=91.51 //y=2.26 //x2=92.99 //y2=2.43
cc_2167 ( N_noxref_6_c_2577_p N_noxref_21_c_11664_n ) capacitor c=0.0446037f \
 //x=91.51 //y=4.475 //x2=92.99 //y2=4.76
cc_2168 ( N_noxref_6_c_2580_p N_noxref_21_c_11664_n ) capacitor c=0.0047666f \
 //x=91.51 //y=4.62 //x2=92.99 //y2=4.76
cc_2169 ( N_noxref_6_c_2581_p N_noxref_21_c_11664_n ) capacitor c=0.00487822f \
 //x=91.515 //y=4.64 //x2=92.99 //y2=4.76
cc_2170 ( N_noxref_6_c_2582_p N_noxref_21_c_11664_n ) capacitor c=0.00414268f \
 //x=91.51 //y=4.62 //x2=92.99 //y2=4.76
cc_2171 ( N_noxref_6_c_2583_p N_noxref_21_c_11664_n ) capacitor c=5.58186e-19 \
 //x=91.51 //y=4.885 //x2=92.99 //y2=4.76
cc_2172 ( N_noxref_6_c_2577_p N_noxref_21_c_11669_n ) capacitor c=0.00206328f \
 //x=91.51 //y=4.475 //x2=94.47 //y2=4.755
cc_2173 ( N_noxref_6_c_2404_p N_noxref_21_c_11670_n ) capacitor c=0.0294454f \
 //x=87.655 //y=4.62 //x2=83.792 //y2=5.335
cc_2174 ( N_noxref_6_c_2404_p N_noxref_21_c_11671_n ) capacitor c=0.0378181f \
 //x=87.655 //y=4.62 //x2=84.67 //y2=5.335
cc_2175 ( N_noxref_6_c_2569_p N_noxref_21_c_11672_n ) capacitor c=0.0170826f \
 //x=87.81 //y=2.375 //x2=92.825 //y2=2.4
cc_2176 ( N_noxref_6_c_2550_p N_noxref_21_c_11672_n ) capacitor c=0.0199217f \
 //x=87.81 //y=4.46 //x2=92.825 //y2=2.4
cc_2177 ( N_noxref_6_c_2576_p N_noxref_21_c_11672_n ) capacitor c=0.0158517f \
 //x=91.51 //y=2.385 //x2=92.825 //y2=2.4
cc_2178 ( N_noxref_6_c_2577_p N_noxref_21_c_11672_n ) capacitor c=0.0197317f \
 //x=91.51 //y=4.475 //x2=92.825 //y2=2.4
cc_2179 ( N_noxref_6_c_2404_p N_noxref_21_c_11672_n ) capacitor c=0.00214036f \
 //x=87.655 //y=4.62 //x2=92.825 //y2=2.4
cc_2180 ( N_noxref_6_c_2592_p N_noxref_21_c_11672_n ) capacitor c=0.00793336f \
 //x=91.355 //y=4.64 //x2=92.825 //y2=2.4
cc_2181 ( N_noxref_6_c_2593_p N_noxref_21_c_11672_n ) capacitor c=4.52643e-19 \
 //x=87.81 //y=2.26 //x2=92.825 //y2=2.4
cc_2182 ( N_noxref_6_c_2578_p N_noxref_21_c_11672_n ) capacitor c=4.72486e-19 \
 //x=91.51 //y=2.26 //x2=92.825 //y2=2.4
cc_2183 ( N_noxref_6_c_2595_p N_noxref_21_c_11672_n ) capacitor c=4.81811e-19 \
 //x=87.81 //y=2.26 //x2=92.825 //y2=2.4
cc_2184 ( N_noxref_6_c_2569_p N_noxref_21_c_11681_n ) capacitor c=0.00147866f \
 //x=87.81 //y=2.375 //x2=86.485 //y2=2.4
cc_2185 ( N_noxref_6_c_2550_p N_noxref_21_c_11681_n ) capacitor c=0.00102192f \
 //x=87.81 //y=4.46 //x2=86.485 //y2=2.4
cc_2186 ( N_noxref_6_c_2404_p N_noxref_21_c_11681_n ) capacitor c=0.00134476f \
 //x=87.655 //y=4.62 //x2=86.485 //y2=2.4
cc_2187 ( N_noxref_6_c_2576_p N_noxref_21_c_11684_n ) capacitor c=0.00424788f \
 //x=91.51 //y=2.385 //x2=93.155 //y2=2.26
cc_2188 ( N_noxref_6_c_2576_p N_noxref_21_c_11685_n ) capacitor c=0.00310765f \
 //x=91.51 //y=2.385 //x2=92.99 //y2=2.26
cc_2189 ( N_noxref_6_c_2577_p N_noxref_21_c_11685_n ) capacitor c=2.86836e-19 \
 //x=91.51 //y=4.475 //x2=92.99 //y2=2.26
cc_2190 ( N_noxref_6_c_2578_p N_noxref_21_c_11685_n ) capacitor c=3.19688e-19 \
 //x=91.51 //y=2.26 //x2=92.99 //y2=2.26
cc_2191 ( N_noxref_6_c_2603_p N_noxref_21_c_11685_n ) capacitor c=2.35599e-19 \
 //x=91.315 //y=2.095 //x2=92.99 //y2=2.26
cc_2192 ( N_noxref_6_c_2580_p N_noxref_21_c_11689_n ) capacitor c=5.34267e-19 \
 //x=91.51 //y=4.62 //x2=92.99 //y2=4.885
cc_2193 ( N_noxref_6_c_2582_p N_noxref_21_c_11689_n ) capacitor c=8.5191e-19 \
 //x=91.51 //y=4.62 //x2=92.99 //y2=4.885
cc_2194 ( N_noxref_6_c_2583_p N_noxref_21_c_11689_n ) capacitor c=2.35599e-19 \
 //x=91.51 //y=4.885 //x2=92.99 //y2=4.885
cc_2195 ( N_noxref_6_M173_noxref_g N_noxref_21_M175_noxref_g ) capacitor \
 c=0.00948424f //x=91.4 //y=6.205 //x2=92.28 //y2=6.205
cc_2196 ( N_noxref_6_M174_noxref_g N_noxref_21_M175_noxref_g ) capacitor \
 c=0.0633522f //x=91.84 //y=6.205 //x2=92.28 //y2=6.205
cc_2197 ( N_noxref_6_M174_noxref_g N_noxref_21_M176_noxref_g ) capacitor \
 c=0.00899012f //x=91.84 //y=6.205 //x2=92.72 //y2=6.205
cc_2198 ( N_noxref_6_c_2610_p N_noxref_21_c_11695_n ) capacitor c=4.86545e-19 \
 //x=91.315 //y=1.045 //x2=92.285 //y2=1.085
cc_2199 ( N_noxref_6_c_2611_p N_noxref_21_c_11695_n ) capacitor c=0.00152104f \
 //x=91.315 //y=1.39 //x2=92.285 //y2=1.085
cc_2200 ( N_noxref_6_c_2612_p N_noxref_21_c_11695_n ) capacitor c=0.0159151f \
 //x=91.845 //y=1.045 //x2=92.285 //y2=1.085
cc_2201 ( N_noxref_6_c_2613_p N_noxref_21_c_11698_n ) capacitor c=0.00109982f \
 //x=91.315 //y=1.7 //x2=92.285 //y2=1.43
cc_2202 ( N_noxref_6_c_2614_p N_noxref_21_c_11698_n ) capacitor c=0.0158526f \
 //x=91.845 //y=1.39 //x2=92.285 //y2=1.43
cc_2203 ( N_noxref_6_c_2582_p N_noxref_21_c_11700_n ) capacitor c=0.00110488f \
 //x=91.51 //y=4.62 //x2=92.355 //y2=4.975
cc_2204 ( N_noxref_6_c_2583_p N_noxref_21_c_11700_n ) capacitor c=0.0640858f \
 //x=91.51 //y=4.885 //x2=92.355 //y2=4.975
cc_2205 ( N_noxref_6_c_2582_p N_noxref_21_c_11702_n ) capacitor c=2.35599e-19 \
 //x=91.51 //y=4.62 //x2=92.72 //y2=5.05
cc_2206 ( N_noxref_6_c_2583_p N_noxref_21_c_11702_n ) capacitor c=5.35364e-19 \
 //x=91.51 //y=4.885 //x2=92.72 //y2=5.05
cc_2207 ( N_noxref_6_c_2612_p N_noxref_21_c_11704_n ) capacitor c=0.00124821f \
 //x=91.845 //y=1.045 //x2=92.815 //y2=1.085
cc_2208 ( N_noxref_6_c_2614_p N_noxref_21_c_11705_n ) capacitor c=0.00150765f \
 //x=91.845 //y=1.39 //x2=92.815 //y2=1.43
cc_2209 ( N_noxref_6_c_2614_p N_noxref_21_c_11706_n ) capacitor c=4.38654e-19 \
 //x=91.845 //y=1.39 //x2=92.815 //y2=1.74
cc_2210 ( N_noxref_6_c_2578_p N_noxref_21_c_11707_n ) capacitor c=2.35599e-19 \
 //x=91.51 //y=2.26 //x2=92.815 //y2=2.095
cc_2211 ( N_noxref_6_c_2603_p N_noxref_21_c_11707_n ) capacitor c=4.61972e-19 \
 //x=91.315 //y=2.095 //x2=92.815 //y2=2.095
cc_2212 ( N_noxref_6_c_2238_p N_noxref_22_c_12247_n ) capacitor c=0.0165599f \
 //x=64.495 //y=4.99 //x2=51.92 //y2=4.75
cc_2213 ( N_noxref_6_c_2238_p N_noxref_22_c_12248_n ) capacitor c=0.0276174f \
 //x=64.495 //y=4.99 //x2=57.47 //y2=5.25
cc_2214 ( N_noxref_6_c_2569_p N_noxref_22_c_12249_n ) capacitor c=0.00873916f \
 //x=87.81 //y=2.375 //x2=88.92 //y2=2.375
cc_2215 ( N_noxref_6_c_2576_p N_noxref_22_c_12249_n ) capacitor c=0.00195819f \
 //x=91.51 //y=2.385 //x2=88.92 //y2=2.375
cc_2216 ( N_noxref_6_c_2593_p N_noxref_22_c_12249_n ) capacitor c=0.00314367f \
 //x=87.81 //y=2.26 //x2=88.92 //y2=2.375
cc_2217 ( N_noxref_6_c_2595_p N_noxref_22_c_12249_n ) capacitor c=0.00135924f \
 //x=87.81 //y=2.26 //x2=88.92 //y2=2.375
cc_2218 ( N_noxref_6_c_2550_p N_noxref_22_c_12253_n ) capacitor c=0.0496576f \
 //x=87.81 //y=4.46 //x2=88.92 //y2=4.045
cc_2219 ( N_noxref_6_c_2577_p N_noxref_22_c_12253_n ) capacitor c=0.0212354f \
 //x=91.51 //y=4.475 //x2=88.92 //y2=4.045
cc_2220 ( N_noxref_6_c_2593_p N_noxref_22_c_12253_n ) capacitor c=3.9149e-19 \
 //x=87.81 //y=2.26 //x2=88.92 //y2=4.045
cc_2221 ( N_noxref_6_c_2550_p N_noxref_22_c_12256_n ) capacitor c=0.00684828f \
 //x=87.81 //y=4.46 //x2=88.92 //y2=4.365
cc_2222 ( N_noxref_6_c_2577_p N_noxref_22_c_12256_n ) capacitor c=0.00149249f \
 //x=91.51 //y=4.475 //x2=88.92 //y2=4.365
cc_2223 ( N_noxref_6_c_2592_p N_noxref_22_c_12256_n ) capacitor c=0.00452722f \
 //x=91.355 //y=4.64 //x2=88.92 //y2=4.365
cc_2224 ( N_noxref_6_c_2550_p N_noxref_22_c_12259_n ) capacitor c=0.00234994f \
 //x=87.81 //y=4.46 //x2=88.92 //y2=4.71
cc_2225 ( N_noxref_6_c_2577_p N_noxref_22_c_12259_n ) capacitor c=0.00106529f \
 //x=91.51 //y=4.475 //x2=88.92 //y2=4.71
cc_2226 ( N_noxref_6_c_2573_p N_noxref_22_c_12259_n ) capacitor c=0.0101017f \
 //x=87.81 //y=4.62 //x2=88.92 //y2=4.71
cc_2227 ( N_noxref_6_c_2580_p N_noxref_22_c_12259_n ) capacitor c=0.00146299f \
 //x=91.51 //y=4.62 //x2=88.92 //y2=4.71
cc_2228 ( N_noxref_6_c_2575_p N_noxref_22_c_12259_n ) capacitor c=0.00282565f \
 //x=87.975 //y=4.62 //x2=88.92 //y2=4.71
cc_2229 ( N_noxref_6_c_2581_p N_noxref_22_c_12259_n ) capacitor c=0.00206738f \
 //x=91.515 //y=4.64 //x2=88.92 //y2=4.71
cc_2230 ( N_noxref_6_c_2592_p N_noxref_22_c_12259_n ) capacitor c=0.0312701f \
 //x=91.355 //y=4.64 //x2=88.92 //y2=4.71
cc_2231 ( N_noxref_6_c_2643_p N_noxref_22_c_12259_n ) capacitor c=0.00670492f \
 //x=87.81 //y=4.62 //x2=88.92 //y2=4.71
cc_2232 ( N_noxref_6_c_2644_p N_noxref_22_c_12259_n ) capacitor c=0.00117926f \
 //x=88.445 //y=4.975 //x2=88.92 //y2=4.71
cc_2233 ( N_noxref_6_c_2645_p N_noxref_22_c_12259_n ) capacitor c=0.00104403f \
 //x=88.155 //y=4.975 //x2=88.92 //y2=4.71
cc_2234 ( N_noxref_6_c_2238_p N_noxref_22_c_12269_n ) capacitor c=0.14942f \
 //x=64.495 //y=4.99 //x2=54.932 //y2=5.335
cc_2235 ( N_noxref_6_c_2550_p N_noxref_22_c_12270_n ) capacitor c=5.51775e-19 \
 //x=87.81 //y=4.46 //x2=88.92 //y2=4.25
cc_2236 ( N_noxref_6_c_2238_p N_noxref_22_c_12271_n ) capacitor c=0.00507061f \
 //x=64.495 //y=4.99 //x2=59.535 //y2=3.865
cc_2237 ( N_noxref_6_c_2238_p N_noxref_22_c_12272_n ) capacitor c=0.00125993f \
 //x=64.495 //y=4.99 //x2=61.165 //y2=3.88
cc_2238 ( N_noxref_6_c_2238_p N_noxref_22_c_12273_n ) capacitor c=0.00863651f \
 //x=64.495 //y=4.99 //x2=61.765 //y2=3.9
cc_2239 ( N_noxref_6_c_2323_p N_noxref_22_c_12273_n ) capacitor c=0.00245465f \
 //x=65.76 //y=5.325 //x2=61.765 //y2=3.9
cc_2240 ( N_noxref_6_c_2320_p N_noxref_22_c_12275_n ) capacitor c=0.00236773f \
 //x=74.21 //y=4.99 //x2=65.965 //y2=4.25
cc_2241 ( N_noxref_6_c_2348_p N_noxref_22_c_12275_n ) capacitor c=0.00211105f \
 //x=65.93 //y=4.99 //x2=65.965 //y2=4.25
cc_2242 ( N_noxref_6_c_2323_p N_noxref_22_c_12277_n ) capacitor c=0.00136092f \
 //x=65.76 //y=5.325 //x2=65.695 //y2=4.25
cc_2243 ( N_noxref_6_c_2320_p N_noxref_22_c_12278_n ) capacitor c=0.022007f \
 //x=74.21 //y=4.99 //x2=66.565 //y2=4.28
cc_2244 ( N_noxref_6_c_2320_p N_noxref_22_c_12279_n ) capacitor c=0.00109587f \
 //x=74.21 //y=4.99 //x2=71.375 //y2=4.31
cc_2245 ( N_noxref_6_c_2320_p N_noxref_22_c_12280_n ) capacitor c=0.011529f \
 //x=74.21 //y=4.99 //x2=76.315 //y2=4.25
cc_2246 ( N_noxref_6_c_2336_p N_noxref_22_c_12280_n ) capacitor c=0.0114581f \
 //x=75.28 //y=5.3 //x2=76.315 //y2=4.25
cc_2247 ( N_noxref_6_c_2404_p N_noxref_22_c_12280_n ) capacitor c=0.061393f \
 //x=87.655 //y=4.62 //x2=76.315 //y2=4.25
cc_2248 ( N_noxref_6_c_2339_p N_noxref_22_c_12280_n ) capacitor c=0.0793445f \
 //x=75.685 //y=4.62 //x2=76.315 //y2=4.25
cc_2249 ( N_noxref_6_c_2353_p N_noxref_22_c_12280_n ) capacitor c=0.0114315f \
 //x=75.6 //y=4.99 //x2=76.315 //y2=4.25
cc_2250 ( N_noxref_6_c_2404_p N_noxref_22_c_12285_n ) capacitor c=0.752672f \
 //x=87.655 //y=4.62 //x2=76.915 //y2=4.28
cc_2251 ( N_noxref_6_c_2404_p N_noxref_22_c_12286_n ) capacitor c=0.059199f \
 //x=87.655 //y=4.62 //x2=85.205 //y2=4.25
cc_2252 ( N_noxref_6_c_2404_p N_noxref_22_c_12287_n ) capacitor c=0.148563f \
 //x=87.655 //y=4.62 //x2=85.805 //y2=4.27
cc_2253 ( N_noxref_6_c_2550_p N_noxref_22_c_12288_n ) capacitor c=4.3262e-19 \
 //x=87.81 //y=4.46 //x2=87.43 //y2=4.25
cc_2254 ( N_noxref_6_c_2404_p N_noxref_22_c_12288_n ) capacitor c=0.0127789f \
 //x=87.655 //y=4.62 //x2=87.43 //y2=4.25
cc_2255 ( N_noxref_6_c_2550_p N_noxref_22_c_12290_n ) capacitor c=0.0288068f \
 //x=87.81 //y=4.46 //x2=88.03 //y2=4.235
cc_2256 ( N_noxref_6_c_2573_p N_noxref_22_c_12290_n ) capacitor c=0.00936091f \
 //x=87.81 //y=4.62 //x2=88.03 //y2=4.235
cc_2257 ( N_noxref_6_c_2575_p N_noxref_22_c_12290_n ) capacitor c=0.0368432f \
 //x=87.975 //y=4.62 //x2=88.03 //y2=4.235
cc_2258 ( N_noxref_6_c_2592_p N_noxref_22_c_12290_n ) capacitor c=0.0115052f \
 //x=91.355 //y=4.64 //x2=88.03 //y2=4.235
cc_2259 ( N_noxref_6_c_2550_p N_noxref_22_c_12294_n ) capacitor c=0.00286218f \
 //x=87.81 //y=4.46 //x2=89.08 //y2=4.252
cc_2260 ( N_noxref_6_c_2577_p N_noxref_22_c_12294_n ) capacitor c=0.00110824f \
 //x=91.51 //y=4.475 //x2=89.08 //y2=4.252
cc_2261 ( N_noxref_6_c_2592_p N_noxref_22_c_12294_n ) capacitor c=0.093269f \
 //x=91.355 //y=4.64 //x2=89.08 //y2=4.252
cc_2262 ( N_noxref_6_c_2577_p N_noxref_22_c_12297_n ) capacitor c=0.0312689f \
 //x=91.51 //y=4.475 //x2=95.435 //y2=4.21
cc_2263 ( N_noxref_6_c_2580_p N_noxref_22_c_12297_n ) capacitor c=0.0102462f \
 //x=91.51 //y=4.62 //x2=95.435 //y2=4.21
cc_2264 ( N_noxref_6_c_2581_p N_noxref_22_c_12297_n ) capacitor c=0.0369071f \
 //x=91.515 //y=4.64 //x2=95.435 //y2=4.21
cc_2265 ( N_noxref_6_c_2592_p N_noxref_22_c_12297_n ) capacitor c=0.208741f \
 //x=91.355 //y=4.64 //x2=95.435 //y2=4.21
cc_2266 ( N_noxref_6_c_2569_p N_noxref_22_c_12301_n ) capacitor c=4.56604e-19 \
 //x=87.81 //y=2.375 //x2=88.92 //y2=2.26
cc_2267 ( N_noxref_6_c_2550_p N_noxref_22_c_12301_n ) capacitor c=3.9149e-19 \
 //x=87.81 //y=4.46 //x2=88.92 //y2=2.26
cc_2268 ( N_noxref_6_c_2593_p N_noxref_22_c_12301_n ) capacitor c=0.00113699f \
 //x=87.81 //y=2.26 //x2=88.92 //y2=2.26
cc_2269 ( N_noxref_6_c_2595_p N_noxref_22_c_12301_n ) capacitor c=0.00201914f \
 //x=87.81 //y=2.26 //x2=88.92 //y2=2.26
cc_2270 ( N_noxref_6_c_2643_p N_noxref_22_c_12305_n ) capacitor c=0.00145613f \
 //x=87.81 //y=4.62 //x2=88.96 //y2=4.885
cc_2271 ( N_noxref_6_c_2644_p N_noxref_22_c_12305_n ) capacitor c=0.00122675f \
 //x=88.445 //y=4.975 //x2=88.96 //y2=4.885
cc_2272 ( N_noxref_6_c_2645_p N_noxref_22_c_12305_n ) capacitor c=0.00114302f \
 //x=88.155 //y=4.975 //x2=88.96 //y2=4.885
cc_2273 ( N_noxref_6_c_2238_p N_noxref_22_M125_noxref_g ) capacitor \
 c=8.65429e-19 //x=64.495 //y=4.99 //x2=51.66 //y2=6.2
cc_2274 ( N_noxref_6_c_2238_p N_noxref_22_M126_noxref_g ) capacitor \
 c=8.65429e-19 //x=64.495 //y=4.99 //x2=52.1 //y2=6.2
cc_2275 ( N_noxref_6_M169_noxref_g N_noxref_22_M171_noxref_g ) capacitor \
 c=0.0106808f //x=88.08 //y=6.205 //x2=88.96 //y2=6.205
cc_2276 ( N_noxref_6_M170_noxref_g N_noxref_22_M171_noxref_g ) capacitor \
 c=0.108153f //x=88.52 //y=6.205 //x2=88.96 //y2=6.205
cc_2277 ( N_noxref_6_M170_noxref_g N_noxref_22_M172_noxref_g ) capacitor \
 c=0.0103194f //x=88.52 //y=6.205 //x2=89.4 //y2=6.205
cc_2278 ( N_noxref_6_c_2690_p N_noxref_22_c_12313_n ) capacitor c=4.86545e-19 \
 //x=87.985 //y=1.045 //x2=88.955 //y2=1.085
cc_2279 ( N_noxref_6_c_2691_p N_noxref_22_c_12313_n ) capacitor c=0.00152405f \
 //x=87.985 //y=1.39 //x2=88.955 //y2=1.085
cc_2280 ( N_noxref_6_c_2692_p N_noxref_22_c_12313_n ) capacitor c=0.0151475f \
 //x=88.515 //y=1.045 //x2=88.955 //y2=1.085
cc_2281 ( N_noxref_6_c_2693_p N_noxref_22_c_12316_n ) capacitor c=0.00109982f \
 //x=87.985 //y=1.7 //x2=88.955 //y2=1.43
cc_2282 ( N_noxref_6_c_2694_p N_noxref_22_c_12316_n ) capacitor c=0.0111064f \
 //x=88.515 //y=1.39 //x2=88.955 //y2=1.43
cc_2283 ( N_noxref_6_c_2693_p N_noxref_22_c_12318_n ) capacitor c=0.00179029f \
 //x=87.985 //y=1.7 //x2=88.955 //y2=1.74
cc_2284 ( N_noxref_6_c_2696_p N_noxref_22_c_12318_n ) capacitor c=0.00662747f \
 //x=87.985 //y=2.095 //x2=88.955 //y2=1.74
cc_2285 ( N_noxref_6_c_2694_p N_noxref_22_c_12318_n ) capacitor c=0.00862358f \
 //x=88.515 //y=1.39 //x2=88.955 //y2=1.74
cc_2286 ( N_noxref_6_c_2692_p N_noxref_22_c_12321_n ) capacitor c=0.00124846f \
 //x=88.515 //y=1.045 //x2=89.485 //y2=1.085
cc_2287 ( N_noxref_6_c_2694_p N_noxref_22_c_12322_n ) capacitor c=0.00161183f \
 //x=88.515 //y=1.39 //x2=89.485 //y2=1.43
cc_2288 ( N_noxref_6_c_2238_p N_noxref_22_c_12323_n ) capacitor c=2.37957e-19 \
 //x=64.495 //y=4.99 //x2=51.92 //y2=4.88
cc_2289 ( N_noxref_6_c_2569_p N_noxref_22_c_12324_n ) capacitor c=0.00126005f \
 //x=87.81 //y=2.375 //x2=88.92 //y2=2.26
cc_2290 ( N_noxref_6_c_2593_p N_noxref_22_c_12324_n ) capacitor c=0.00191372f \
 //x=87.81 //y=2.26 //x2=88.92 //y2=2.26
cc_2291 ( N_noxref_6_c_2595_p N_noxref_22_c_12324_n ) capacitor c=0.00949697f \
 //x=87.81 //y=2.26 //x2=88.92 //y2=2.26
cc_2292 ( N_noxref_6_c_2573_p N_noxref_22_c_12327_n ) capacitor c=2.84639e-19 \
 //x=87.81 //y=4.62 //x2=88.96 //y2=4.885
cc_2293 ( N_noxref_6_c_2643_p N_noxref_22_c_12327_n ) capacitor c=0.00197201f \
 //x=87.81 //y=4.62 //x2=88.96 //y2=4.885
cc_2294 ( N_noxref_6_c_2644_p N_noxref_22_c_12327_n ) capacitor c=0.0203213f \
 //x=88.445 //y=4.975 //x2=88.96 //y2=4.885
cc_2295 ( N_noxref_6_c_2645_p N_noxref_22_c_12327_n ) capacitor c=0.00427779f \
 //x=88.155 //y=4.975 //x2=88.96 //y2=4.885
cc_2296 ( N_noxref_6_c_2576_p N_noxref_23_c_12990_n ) capacitor c=0.0070066f \
 //x=91.51 //y=2.385 //x2=92.42 //y2=1.405
cc_2297 ( N_noxref_6_c_2611_p N_noxref_23_c_12990_n ) capacitor c=0.00242807f \
 //x=91.315 //y=1.39 //x2=92.42 //y2=1.405
cc_2298 ( N_noxref_6_c_2613_p N_noxref_23_c_12990_n ) capacitor c=0.00111233f \
 //x=91.315 //y=1.7 //x2=92.42 //y2=1.405
cc_2299 ( N_noxref_6_c_2614_p N_noxref_23_c_12990_n ) capacitor c=0.00333115f \
 //x=91.845 //y=1.39 //x2=92.42 //y2=1.405
cc_2300 ( N_noxref_6_c_2087_n N_VDD_c_13434_n ) capacitor c=0.00621329f \
 //x=26.83 //y=5.335 //x2=87.775 //y2=7.585
cc_2301 ( N_noxref_6_c_2139_n N_VDD_c_13434_n ) capacitor c=0.00627186f \
 //x=27.715 //y=5.335 //x2=87.775 //y2=7.585
cc_2302 ( N_noxref_6_c_2141_n N_VDD_c_13434_n ) capacitor c=0.00256019f \
 //x=27.83 //y=5.56 //x2=87.775 //y2=7.585
cc_2303 ( N_noxref_6_c_2143_n N_VDD_c_13434_n ) capacitor c=0.00808134f \
 //x=28.45 //y=5.335 //x2=87.775 //y2=7.585
cc_2304 ( N_noxref_6_c_2090_n N_VDD_c_13434_n ) capacitor c=0.00261804f \
 //x=26.072 //y=5.335 //x2=87.775 //y2=7.585
cc_2305 ( N_noxref_6_c_2362_p N_VDD_c_13434_n ) capacitor c=0.00270108f \
 //x=26.95 //y=5.335 //x2=87.775 //y2=7.585
cc_2306 ( N_noxref_6_c_2177_n N_VDD_c_13434_n ) capacitor c=5.30543e-19 \
 //x=28.61 //y=4.99 //x2=87.775 //y2=7.585
cc_2307 ( N_noxref_6_c_2180_n N_VDD_c_13434_n ) capacitor c=4.60857e-19 \
 //x=28.61 //y=4.995 //x2=87.775 //y2=7.585
cc_2308 ( N_noxref_6_c_2573_p N_VDD_c_13434_n ) capacitor c=2.89886e-19 \
 //x=87.81 //y=4.62 //x2=87.775 //y2=7.585
cc_2309 ( N_noxref_6_c_2207_p N_VDD_c_13434_n ) capacitor c=0.17413f //x=35.77 \
 //y=4.99 //x2=87.775 //y2=7.585
cc_2310 ( N_noxref_6_c_2205_p N_VDD_c_13434_n ) capacitor c=0.020557f \
 //x=35.94 //y=5.3 //x2=87.775 //y2=7.585
cc_2311 ( N_noxref_6_c_2210_p N_VDD_c_13434_n ) capacitor c=0.181275f \
 //x=45.28 //y=4.99 //x2=87.775 //y2=7.585
cc_2312 ( N_noxref_6_c_2221_p N_VDD_c_13434_n ) capacitor c=0.0238954f \
 //x=45.45 //y=5.3 //x2=87.775 //y2=7.585
cc_2313 ( N_noxref_6_c_2238_p N_VDD_c_13434_n ) capacitor c=0.383704f \
 //x=64.495 //y=4.99 //x2=87.775 //y2=7.585
cc_2314 ( N_noxref_6_c_2323_p N_VDD_c_13434_n ) capacitor c=0.0102894f \
 //x=65.76 //y=5.325 //x2=87.775 //y2=7.585
cc_2315 ( N_noxref_6_c_2316_p N_VDD_c_13434_n ) capacitor c=0.0143397f \
 //x=64.665 //y=5.325 //x2=87.775 //y2=7.585
cc_2316 ( N_noxref_6_c_2320_p N_VDD_c_13434_n ) capacitor c=0.181918f \
 //x=74.21 //y=4.99 //x2=87.775 //y2=7.585
cc_2317 ( N_noxref_6_c_2329_p N_VDD_c_13434_n ) capacitor c=0.0211095f \
 //x=74.38 //y=5.3 //x2=87.775 //y2=7.585
cc_2318 ( N_noxref_6_c_2193_n N_VDD_c_13434_n ) capacitor c=0.00510184f \
 //x=28.77 //y=4.995 //x2=87.775 //y2=7.585
cc_2319 ( N_noxref_6_c_2104_n N_VDD_c_13434_n ) capacitor c=0.0024232f \
 //x=26.07 //y=5.56 //x2=87.775 //y2=7.585
cc_2320 ( N_noxref_6_c_2502_p N_VDD_c_13434_n ) capacitor c=0.0024232f \
 //x=26.95 //y=5.56 //x2=87.775 //y2=7.585
cc_2321 ( N_noxref_6_c_2194_n N_VDD_c_13434_n ) capacitor c=0.0024232f \
 //x=27.83 //y=5.56 //x2=87.775 //y2=7.585
cc_2322 ( N_noxref_6_M169_noxref_g N_VDD_c_13737_n ) capacitor c=0.00374549f \
 //x=88.08 //y=6.205 //x2=87.86 //y2=7.035
cc_2323 ( N_noxref_6_M169_noxref_g N_VDD_c_13738_n ) capacitor c=0.00441594f \
 //x=88.08 //y=6.205 //x2=87.86 //y2=7.41
cc_2324 ( N_noxref_6_M170_noxref_g N_VDD_c_13739_n ) capacitor c=0.00123273f \
 //x=88.52 //y=6.205 //x2=88.74 //y2=7.035
cc_2325 ( N_noxref_6_M170_noxref_g N_VDD_c_13740_n ) capacitor c=0.00137209f \
 //x=88.52 //y=6.205 //x2=88.74 //y2=7.41
cc_2326 ( N_noxref_6_M89_noxref_g N_VDD_c_13622_n ) capacitor c=0.00755544f \
 //x=22.8 //y=6.2 //x2=23.375 //y2=7.585
cc_2327 ( N_noxref_6_M90_noxref_g N_VDD_c_13622_n ) capacitor c=0.00755754f \
 //x=23.24 //y=6.2 //x2=23.375 //y2=7.585
cc_2328 ( N_noxref_6_c_2087_n N_VDD_c_13627_n ) capacitor c=0.00202922f \
 //x=26.83 //y=5.335 //x2=26.425 //y2=7.585
cc_2329 ( N_noxref_6_c_2090_n N_VDD_c_13627_n ) capacitor c=9.3757e-19 \
 //x=26.072 //y=5.335 //x2=26.425 //y2=7.585
cc_2330 ( N_noxref_6_c_2104_n N_VDD_c_13627_n ) capacitor c=0.0138074f \
 //x=26.07 //y=5.56 //x2=26.425 //y2=7.585
cc_2331 ( N_noxref_6_c_2087_n N_VDD_c_13746_n ) capacitor c=0.0017708f \
 //x=26.83 //y=5.335 //x2=27.305 //y2=7.585
cc_2332 ( N_noxref_6_c_2139_n N_VDD_c_13746_n ) capacitor c=0.00202922f \
 //x=27.715 //y=5.335 //x2=27.305 //y2=7.585
cc_2333 ( N_noxref_6_c_2362_p N_VDD_c_13746_n ) capacitor c=9.4822e-19 \
 //x=26.95 //y=5.335 //x2=27.305 //y2=7.585
cc_2334 ( N_noxref_6_c_2502_p N_VDD_c_13746_n ) capacitor c=0.0138074f \
 //x=26.95 //y=5.56 //x2=27.305 //y2=7.585
cc_2335 ( N_noxref_6_c_2139_n N_VDD_c_13683_n ) capacitor c=0.00205906f \
 //x=27.715 //y=5.335 //x2=28.185 //y2=7.585
cc_2336 ( N_noxref_6_c_2141_n N_VDD_c_13683_n ) capacitor c=8.49654e-19 \
 //x=27.83 //y=5.56 //x2=28.185 //y2=7.585
cc_2337 ( N_noxref_6_c_2143_n N_VDD_c_13683_n ) capacitor c=0.00204238f \
 //x=28.45 //y=5.335 //x2=28.185 //y2=7.585
cc_2338 ( N_noxref_6_c_2194_n N_VDD_c_13683_n ) capacitor c=0.0135103f \
 //x=27.83 //y=5.56 //x2=28.185 //y2=7.585
cc_2339 ( N_noxref_6_c_2143_n N_VDD_c_13754_n ) capacitor c=0.00155573f \
 //x=28.45 //y=5.335 //x2=29.18 //y2=7.585
cc_2340 ( N_noxref_6_c_2177_n N_VDD_c_13754_n ) capacitor c=2.52257e-19 \
 //x=28.61 //y=4.99 //x2=29.18 //y2=7.585
cc_2341 ( N_noxref_6_c_2180_n N_VDD_c_13754_n ) capacitor c=6.03455e-19 \
 //x=28.61 //y=4.995 //x2=29.18 //y2=7.585
cc_2342 ( N_noxref_6_c_2573_p N_VDD_c_13757_n ) capacitor c=5.35585e-19 \
 //x=87.81 //y=4.62 //x2=90.23 //y2=7.585
cc_2343 ( N_noxref_6_M169_noxref_g N_VDD_c_13757_n ) capacitor c=0.00778439f \
 //x=88.08 //y=6.205 //x2=90.23 //y2=7.585
cc_2344 ( N_noxref_6_M170_noxref_g N_VDD_c_13757_n ) capacitor c=0.00778439f \
 //x=88.52 //y=6.205 //x2=90.23 //y2=7.585
cc_2345 ( N_noxref_6_c_2582_p N_VDD_c_13760_n ) capacitor c=2.11259e-19 \
 //x=91.51 //y=4.62 //x2=93.56 //y2=7.585
cc_2346 ( N_noxref_6_M173_noxref_g N_VDD_c_13760_n ) capacitor c=0.00763665f \
 //x=91.4 //y=6.205 //x2=93.56 //y2=7.585
cc_2347 ( N_noxref_6_M174_noxref_g N_VDD_c_13760_n ) capacitor c=0.00782837f \
 //x=91.84 //y=6.205 //x2=93.56 //y2=7.585
cc_2348 ( N_noxref_6_c_2090_n N_VDD_c_13631_n ) capacitor c=0.0022955f \
 //x=26.072 //y=5.335 //x2=24.54 //y2=7.585
cc_2349 ( N_noxref_6_c_2100_n N_VDD_c_13631_n ) capacitor c=0.00224736f \
 //x=23.06 //y=4.88 //x2=24.54 //y2=7.585
cc_2350 ( N_noxref_6_c_2104_n N_VDD_c_13631_n ) capacitor c=0.00509469f \
 //x=26.07 //y=5.56 //x2=24.54 //y2=7.585
cc_2351 ( N_noxref_6_c_2134_n N_VDD_c_13631_n ) capacitor c=2.63786e-19 \
 //x=23.06 //y=4.88 //x2=24.54 //y2=7.585
cc_2352 ( N_noxref_6_c_2141_n N_VDD_c_13694_n ) capacitor c=0.00282782f \
 //x=27.83 //y=5.56 //x2=29.35 //y2=7.585
cc_2353 ( N_noxref_6_c_2166_n N_VDD_c_13694_n ) capacitor c=0.0136712f \
 //x=28.61 //y=4.835 //x2=29.35 //y2=7.585
cc_2354 ( N_noxref_6_c_2177_n N_VDD_c_13694_n ) capacitor c=0.0113688f \
 //x=28.61 //y=4.99 //x2=29.35 //y2=7.585
cc_2355 ( N_noxref_6_c_2180_n N_VDD_c_13694_n ) capacitor c=0.0160652f \
 //x=28.61 //y=4.995 //x2=29.35 //y2=7.585
cc_2356 ( N_noxref_6_c_2207_p N_VDD_c_13694_n ) capacitor c=0.0212315f \
 //x=35.77 //y=4.99 //x2=29.35 //y2=7.585
cc_2357 ( N_noxref_6_c_2194_n N_VDD_c_13694_n ) capacitor c=0.00777981f \
 //x=27.83 //y=5.56 //x2=29.35 //y2=7.585
cc_2358 ( N_noxref_6_c_2207_p N_VDD_c_13773_n ) capacitor c=0.022973f \
 //x=35.77 //y=4.99 //x2=34.16 //y2=7.585
cc_2359 ( N_noxref_6_c_2208_p N_VDD_c_13773_n ) capacitor c=0.00253607f \
 //x=35.855 //y=5.215 //x2=34.16 //y2=7.585
cc_2360 ( N_noxref_6_c_2210_p N_VDD_c_13775_n ) capacitor c=0.0229731f \
 //x=45.28 //y=4.99 //x2=38.97 //y2=7.585
cc_2361 ( N_noxref_6_c_2210_p N_VDD_c_13776_n ) capacitor c=0.0229729f \
 //x=45.28 //y=4.99 //x2=43.78 //y2=7.585
cc_2362 ( N_noxref_6_c_2223_p N_VDD_c_13776_n ) capacitor c=0.0021645f \
 //x=45.365 //y=5.215 //x2=43.78 //y2=7.585
cc_2363 ( N_noxref_6_c_2238_p N_VDD_c_13778_n ) capacitor c=0.0229731f \
 //x=64.495 //y=4.99 //x2=48.59 //y2=7.585
cc_2364 ( N_noxref_6_c_2238_p N_VDD_c_13779_n ) capacitor c=0.0230359f \
 //x=64.495 //y=4.99 //x2=53.4 //y2=7.585
cc_2365 ( N_noxref_6_c_2238_p N_VDD_c_13780_n ) capacitor c=0.0230359f \
 //x=64.495 //y=4.99 //x2=58.21 //y2=7.585
cc_2366 ( N_noxref_6_c_2238_p N_VDD_c_13781_n ) capacitor c=0.0229729f \
 //x=64.495 //y=4.99 //x2=63.02 //y2=7.585
cc_2367 ( N_noxref_6_c_2318_p N_VDD_c_13781_n ) capacitor c=0.00214686f \
 //x=64.58 //y=5.24 //x2=63.02 //y2=7.585
cc_2368 ( N_noxref_6_c_2320_p N_VDD_c_13783_n ) capacitor c=0.0229731f \
 //x=74.21 //y=4.99 //x2=67.83 //y2=7.585
cc_2369 ( N_noxref_6_c_2320_p N_VDD_c_13784_n ) capacitor c=0.022973f \
 //x=74.21 //y=4.99 //x2=72.64 //y2=7.585
cc_2370 ( N_noxref_6_c_2331_p N_VDD_c_13784_n ) capacitor c=0.00258155f \
 //x=74.295 //y=5.215 //x2=72.64 //y2=7.585
cc_2371 ( N_noxref_6_c_2404_p N_VDD_c_13786_n ) capacitor c=0.0263782f \
 //x=87.655 //y=4.62 //x2=77.45 //y2=7.585
cc_2372 ( N_noxref_6_c_2404_p N_VDD_c_13787_n ) capacitor c=0.0265917f \
 //x=87.655 //y=4.62 //x2=82.26 //y2=7.585
cc_2373 ( N_noxref_6_c_2550_p N_VDD_c_13788_n ) capacitor c=0.00354615f \
 //x=87.81 //y=4.46 //x2=87.07 //y2=7.585
cc_2374 ( N_noxref_6_c_2573_p N_VDD_c_13788_n ) capacitor c=0.00496271f \
 //x=87.81 //y=4.62 //x2=87.07 //y2=7.585
cc_2375 ( N_noxref_6_c_2404_p N_VDD_c_13788_n ) capacitor c=0.0246205f \
 //x=87.655 //y=4.62 //x2=87.07 //y2=7.585
cc_2376 ( N_noxref_6_c_2643_p N_VDD_c_13788_n ) capacitor c=0.0181477f \
 //x=87.81 //y=4.62 //x2=87.07 //y2=7.585
cc_2377 ( N_noxref_6_M169_noxref_g N_VDD_c_13788_n ) capacitor c=0.00973553f \
 //x=88.08 //y=6.205 //x2=87.07 //y2=7.585
cc_2378 ( N_noxref_6_c_2645_p N_VDD_c_13788_n ) capacitor c=0.00774458f \
 //x=88.155 //y=4.975 //x2=87.07 //y2=7.585
cc_2379 ( N_noxref_6_c_2577_p N_VDD_c_13794_n ) capacitor c=0.00285166f \
 //x=91.51 //y=4.475 //x2=90.4 //y2=7.585
cc_2380 ( N_noxref_6_c_2580_p N_VDD_c_13794_n ) capacitor c=0.00331684f \
 //x=91.51 //y=4.62 //x2=90.4 //y2=7.585
cc_2381 ( N_noxref_6_c_2592_p N_VDD_c_13794_n ) capacitor c=0.0167947f \
 //x=91.355 //y=4.64 //x2=90.4 //y2=7.585
cc_2382 ( N_noxref_6_c_2643_p N_VDD_c_13794_n ) capacitor c=0.00117386f \
 //x=87.81 //y=4.62 //x2=90.4 //y2=7.585
cc_2383 ( N_noxref_6_c_2582_p N_VDD_c_13794_n ) capacitor c=0.0104424f \
 //x=91.51 //y=4.62 //x2=90.4 //y2=7.585
cc_2384 ( N_noxref_6_c_2583_p N_VDD_c_13794_n ) capacitor c=0.0137051f \
 //x=91.51 //y=4.885 //x2=90.4 //y2=7.585
cc_2385 ( N_noxref_6_c_2582_p N_VDD_c_13800_n ) capacitor c=0.00221916f \
 //x=91.51 //y=4.62 //x2=93.73 //y2=7.585
cc_2386 ( N_noxref_6_M89_noxref_g N_VDD_M88_noxref_d ) capacitor c=0.015318f \
 //x=22.8 //y=6.2 //x2=22.435 //y2=5.2
cc_2387 ( N_noxref_6_M90_noxref_g N_VDD_M90_noxref_d ) capacitor c=0.0394719f \
 //x=23.24 //y=6.2 //x2=23.315 //y2=5.2
cc_2388 ( N_noxref_6_c_2090_n N_VDD_M91_noxref_s ) capacitor c=0.0442713f \
 //x=26.072 //y=5.335 //x2=25.495 //y2=5.2
cc_2389 ( N_noxref_6_c_2362_p N_VDD_M91_noxref_s ) capacitor c=7.80122e-19 \
 //x=26.95 //y=5.335 //x2=25.495 //y2=5.2
cc_2390 ( N_noxref_6_c_2104_n N_VDD_M91_noxref_s ) capacitor c=0.09305f \
 //x=26.07 //y=5.56 //x2=25.495 //y2=5.2
cc_2391 ( N_noxref_6_c_2087_n N_VDD_M92_noxref_d ) capacitor c=0.00700141f \
 //x=26.83 //y=5.335 //x2=26.365 //y2=5.2
cc_2392 ( N_noxref_6_c_2104_n N_VDD_M92_noxref_d ) capacitor c=0.0674491f \
 //x=26.07 //y=5.56 //x2=26.365 //y2=5.2
cc_2393 ( N_noxref_6_c_2502_p N_VDD_M92_noxref_d ) capacitor c=0.0674762f \
 //x=26.95 //y=5.56 //x2=26.365 //y2=5.2
cc_2394 ( N_noxref_6_c_2139_n N_VDD_M94_noxref_d ) capacitor c=0.00700141f \
 //x=27.715 //y=5.335 //x2=27.245 //y2=5.2
cc_2395 ( N_noxref_6_c_2502_p N_VDD_M94_noxref_d ) capacitor c=0.067493f \
 //x=26.95 //y=5.56 //x2=27.245 //y2=5.2
cc_2396 ( N_noxref_6_c_2194_n N_VDD_M94_noxref_d ) capacitor c=0.0674979f \
 //x=27.83 //y=5.56 //x2=27.245 //y2=5.2
cc_2397 ( N_noxref_6_c_2143_n N_VDD_M96_noxref_d ) capacitor c=0.00700141f \
 //x=28.45 //y=5.335 //x2=28.125 //y2=5.2
cc_2398 ( N_noxref_6_c_2194_n N_VDD_M96_noxref_d ) capacitor c=0.0675002f \
 //x=27.83 //y=5.56 //x2=28.125 //y2=5.2
cc_2399 ( N_noxref_6_c_2141_n N_VDD_M97_noxref_s ) capacitor c=0.00492616f \
 //x=27.83 //y=5.56 //x2=30.305 //y2=5.2
cc_2400 ( N_noxref_6_c_2362_p N_VDD_M97_noxref_s ) capacitor c=2.11884e-19 \
 //x=26.95 //y=5.335 //x2=30.305 //y2=5.2
cc_2401 ( N_noxref_6_c_2180_n N_VDD_M97_noxref_s ) capacitor c=9.42705e-19 \
 //x=28.61 //y=4.995 //x2=30.305 //y2=5.2
cc_2402 ( N_noxref_6_c_2207_p N_VDD_M97_noxref_s ) capacitor c=0.00865685f \
 //x=35.77 //y=4.99 //x2=30.305 //y2=5.2
cc_2403 ( N_noxref_6_c_2207_p N_VDD_M103_noxref_s ) capacitor c=0.00887553f \
 //x=35.77 //y=4.99 //x2=35.115 //y2=5.2
cc_2404 ( N_noxref_6_c_2210_p N_VDD_M109_noxref_s ) capacitor c=0.00887553f \
 //x=45.28 //y=4.99 //x2=39.925 //y2=5.2
cc_2405 ( N_noxref_6_c_2210_p N_VDD_M115_noxref_s ) capacitor c=0.00887691f \
 //x=45.28 //y=4.99 //x2=44.735 //y2=5.2
cc_2406 ( N_noxref_6_c_2238_p N_VDD_M121_noxref_s ) capacitor c=0.00879092f \
 //x=64.495 //y=4.99 //x2=49.545 //y2=5.2
cc_2407 ( N_noxref_6_c_2238_p N_VDD_M127_noxref_s ) capacitor c=0.00887826f \
 //x=64.495 //y=4.99 //x2=54.355 //y2=5.2
cc_2408 ( N_noxref_6_c_2238_p N_VDD_M133_noxref_s ) capacitor c=0.00865337f \
 //x=64.495 //y=4.99 //x2=59.165 //y2=5.2
cc_2409 ( N_noxref_6_c_2238_p N_VDD_M139_noxref_s ) capacitor c=0.00887553f \
 //x=64.495 //y=4.99 //x2=63.975 //y2=5.2
cc_2410 ( N_noxref_6_c_2320_p N_VDD_M145_noxref_s ) capacitor c=0.00887553f \
 //x=74.21 //y=4.99 //x2=68.785 //y2=5.2
cc_2411 ( N_noxref_6_c_2320_p N_VDD_M151_noxref_s ) capacitor c=0.00887691f \
 //x=74.21 //y=4.99 //x2=73.595 //y2=5.2
cc_2412 ( N_noxref_6_c_2404_p N_VDD_M157_noxref_s ) capacitor c=7.81352e-19 \
 //x=87.655 //y=4.62 //x2=78.405 //y2=5.2
cc_2413 ( N_noxref_6_c_2404_p N_VDD_M163_noxref_s ) capacitor c=8.59047e-19 \
 //x=87.655 //y=4.62 //x2=83.215 //y2=5.2
cc_2414 ( N_noxref_6_c_2573_p N_VDD_M169_noxref_s ) capacitor c=0.0166208f \
 //x=87.81 //y=4.62 //x2=87.725 //y2=5.205
cc_2415 ( N_noxref_6_c_2575_p N_VDD_M169_noxref_s ) capacitor c=0.00180521f \
 //x=87.975 //y=4.62 //x2=87.725 //y2=5.205
cc_2416 ( N_noxref_6_c_2643_p N_VDD_M169_noxref_s ) capacitor c=0.0122195f \
 //x=87.81 //y=4.62 //x2=87.725 //y2=5.205
cc_2417 ( N_noxref_6_M169_noxref_g N_VDD_M169_noxref_s ) capacitor \
 c=0.0510401f //x=88.08 //y=6.205 //x2=87.725 //y2=5.205
cc_2418 ( N_noxref_6_c_2645_p N_VDD_M169_noxref_s ) capacitor c=0.00621646f \
 //x=88.155 //y=4.975 //x2=87.725 //y2=5.205
cc_2419 ( N_noxref_6_M170_noxref_g N_VDD_M170_noxref_d ) capacitor \
 c=0.0127979f //x=88.52 //y=6.205 //x2=88.595 //y2=5.205
cc_2420 ( N_noxref_6_c_2069_n N_noxref_30_c_15149_n ) capacitor c=0.00177186f \
 //x=23.06 //y=2.375 //x2=23.715 //y2=0.72
cc_2421 ( N_noxref_6_c_2099_n N_noxref_30_c_15149_n ) capacitor c=0.00117306f \
 //x=23.06 //y=2.26 //x2=23.715 //y2=0.72
cc_2422 ( N_noxref_6_c_2113_n N_noxref_30_c_15149_n ) capacitor c=0.0206349f \
 //x=23.05 //y=1.095 //x2=23.715 //y2=0.72
cc_2423 ( N_noxref_6_c_2125_n N_noxref_30_c_15149_n ) capacitor c=0.00825432f \
 //x=23.58 //y=1.095 //x2=23.715 //y2=0.72
cc_2424 ( N_noxref_6_c_2131_n N_noxref_30_c_15149_n ) capacitor c=2.20712e-19 \
 //x=23.06 //y=2.26 //x2=23.715 //y2=0.72
cc_2425 ( N_noxref_6_c_2115_n N_noxref_30_c_15152_n ) capacitor c=0.0071177f \
 //x=23.05 //y=1.44 //x2=22.83 //y2=1.175
cc_2426 ( N_noxref_6_c_2113_n N_noxref_30_M14_noxref_s ) capacitor \
 c=0.0071177f //x=23.05 //y=1.095 //x2=22.695 //y2=0.555
cc_2427 ( N_noxref_6_c_2118_n N_noxref_30_M14_noxref_s ) capacitor \
 c=0.0071177f //x=23.05 //y=1.75 //x2=22.695 //y2=0.555
cc_2428 ( N_noxref_6_c_2125_n N_noxref_30_M14_noxref_s ) capacitor c=0.015333f \
 //x=23.58 //y=1.095 //x2=22.695 //y2=0.555
cc_2429 ( N_noxref_6_c_2127_n N_noxref_30_M14_noxref_s ) capacitor \
 c=0.00248746f //x=23.58 //y=1.44 //x2=22.695 //y2=0.555
cc_2430 ( N_noxref_6_c_2147_n N_noxref_31_c_15218_n ) capacitor c=0.0036878f \
 //x=28.125 //y=1.305 //x2=28.525 //y2=0.72
cc_2431 ( N_noxref_6_c_2158_n N_noxref_31_c_15218_n ) capacitor c=0.00399931f \
 //x=28.525 //y=1.845 //x2=28.525 //y2=0.72
cc_2432 ( N_noxref_6_M17_noxref_d N_noxref_31_c_15218_n ) capacitor \
 c=0.00910163f //x=27.935 //y=1.095 //x2=28.525 //y2=0.72
cc_2433 ( N_noxref_6_M17_noxref_d N_noxref_31_c_15223_n ) capacitor \
 c=0.00120711f //x=27.935 //y=1.095 //x2=27.64 //y2=1.175
cc_2434 ( N_noxref_6_c_2087_n N_noxref_31_M16_noxref_d ) capacitor \
 c=9.41274e-19 //x=26.83 //y=5.335 //x2=26.4 //y2=1.09
cc_2435 ( N_noxref_6_c_2147_n N_noxref_31_M16_noxref_d ) capacitor \
 c=0.00802417f //x=28.125 //y=1.305 //x2=26.4 //y2=1.09
cc_2436 ( N_noxref_6_c_2147_n N_noxref_31_M17_noxref_s ) capacitor \
 c=0.0098487f //x=28.125 //y=1.305 //x2=27.505 //y2=0.555
cc_2437 ( N_noxref_6_c_2153_n N_noxref_31_M17_noxref_s ) capacitor \
 c=0.0283243f //x=28.125 //y=1.76 //x2=27.505 //y2=0.555
cc_2438 ( N_noxref_6_c_2158_n N_noxref_31_M17_noxref_s ) capacitor \
 c=0.00871957f //x=28.525 //y=1.845 //x2=27.505 //y2=0.555
cc_2439 ( N_noxref_6_c_2176_n N_noxref_31_M17_noxref_s ) capacitor \
 c=0.00147976f //x=28.61 //y=3.51 //x2=27.505 //y2=0.555
cc_2440 ( N_noxref_6_M17_noxref_d N_noxref_31_M17_noxref_s ) capacitor \
 c=0.0279003f //x=27.935 //y=1.095 //x2=27.505 //y2=0.555
cc_2441 ( N_noxref_6_c_2147_n N_noxref_32_M19_noxref_d ) capacitor \
 c=3.20746e-19 //x=28.125 //y=1.305 //x2=31.21 //y2=1.09
cc_2442 ( N_noxref_6_c_2592_p N_noxref_44_c_16098_n ) capacitor c=0.00314988f \
 //x=91.355 //y=4.64 //x2=89.065 //y2=5.39
cc_2443 ( N_noxref_6_M170_noxref_g N_noxref_44_c_16098_n ) capacitor \
 c=0.00962216f //x=88.52 //y=6.205 //x2=89.065 //y2=5.39
cc_2444 ( N_noxref_6_c_2580_p N_noxref_44_c_16100_n ) capacitor c=0.00378061f \
 //x=91.51 //y=4.62 //x2=91.065 //y2=5.39
cc_2445 ( N_noxref_6_c_2592_p N_noxref_44_c_16100_n ) capacitor c=0.0894443f \
 //x=91.355 //y=4.64 //x2=91.065 //y2=5.39
cc_2446 ( N_noxref_6_M173_noxref_g N_noxref_44_c_16100_n ) capacitor \
 c=0.00366801f //x=91.4 //y=6.205 //x2=91.065 //y2=5.39
cc_2447 ( N_noxref_6_c_2592_p N_noxref_44_c_16103_n ) capacitor c=0.00878121f \
 //x=91.355 //y=4.64 //x2=89.295 //y2=5.39
cc_2448 ( N_noxref_6_c_2580_p N_noxref_44_c_16104_n ) capacitor c=8.16607e-19 \
 //x=91.51 //y=4.62 //x2=91.94 //y2=7.09
cc_2449 ( N_noxref_6_c_2581_p N_noxref_44_c_16104_n ) capacitor c=0.00566393f \
 //x=91.515 //y=4.64 //x2=91.94 //y2=7.09
cc_2450 ( N_noxref_6_c_2592_p N_noxref_44_c_16104_n ) capacitor c=5.18143e-19 \
 //x=91.355 //y=4.64 //x2=91.94 //y2=7.09
cc_2451 ( N_noxref_6_c_2582_p N_noxref_44_c_16104_n ) capacitor c=0.00134225f \
 //x=91.51 //y=4.62 //x2=91.94 //y2=7.09
cc_2452 ( N_noxref_6_M173_noxref_g N_noxref_44_c_16104_n ) capacitor \
 c=0.00985075f //x=91.4 //y=6.205 //x2=91.94 //y2=7.09
cc_2453 ( N_noxref_6_M174_noxref_g N_noxref_44_c_16104_n ) capacitor \
 c=0.00814026f //x=91.84 //y=6.205 //x2=91.94 //y2=7.09
cc_2454 ( N_noxref_6_c_2592_p N_noxref_44_c_16110_n ) capacitor c=0.0260948f \
 //x=91.355 //y=4.64 //x2=88.302 //y2=5.39
cc_2455 ( N_noxref_6_M169_noxref_g N_noxref_44_c_16110_n ) capacitor \
 c=0.0018075f //x=88.08 //y=6.205 //x2=88.302 //y2=5.39
cc_2456 ( N_noxref_6_M170_noxref_g N_noxref_44_c_16110_n ) capacitor \
 c=0.00310294f //x=88.52 //y=6.205 //x2=88.302 //y2=5.39
cc_2457 ( N_noxref_6_c_2644_p N_noxref_44_c_16110_n ) capacitor c=0.00218288f \
 //x=88.445 //y=4.975 //x2=88.302 //y2=5.39
cc_2458 ( N_noxref_6_M173_noxref_g N_noxref_44_c_16114_n ) capacitor \
 c=0.00395967f //x=91.4 //y=6.205 //x2=91.18 //y2=6.92
cc_2459 ( N_noxref_6_M174_noxref_g N_noxref_44_c_16115_n ) capacitor \
 c=0.00179771f //x=91.84 //y=6.205 //x2=92.057 //y2=7.09
cc_2460 ( N_noxref_6_M169_noxref_g N_noxref_44_c_16116_n ) capacitor \
 c=0.0161645f //x=88.08 //y=6.205 //x2=88.3 //y2=5.56
cc_2461 ( N_noxref_6_M170_noxref_g N_noxref_44_c_16116_n ) capacitor \
 c=0.0177598f //x=88.52 //y=6.205 //x2=88.3 //y2=5.56
cc_2462 ( N_noxref_6_c_2644_p N_noxref_44_c_16116_n ) capacitor c=0.00293723f \
 //x=88.445 //y=4.975 //x2=88.3 //y2=5.56
cc_2463 ( N_noxref_6_c_2592_p N_noxref_44_c_16119_n ) capacitor c=0.00371683f \
 //x=91.355 //y=4.64 //x2=89.18 //y2=5.39
cc_2464 ( N_noxref_6_c_2580_p N_noxref_44_c_16120_n ) capacitor c=8.93089e-19 \
 //x=91.51 //y=4.62 //x2=91.18 //y2=5.39
cc_2465 ( N_noxref_6_c_2592_p N_noxref_44_c_16120_n ) capacitor c=0.00277723f \
 //x=91.355 //y=4.64 //x2=91.18 //y2=5.39
cc_2466 ( N_noxref_6_M173_noxref_g N_noxref_44_c_16120_n ) capacitor \
 c=0.0503042f //x=91.4 //y=6.205 //x2=91.18 //y2=5.39
cc_2467 ( N_noxref_6_M169_noxref_g N_noxref_44_M169_noxref_d ) capacitor \
 c=0.00124621f //x=88.08 //y=6.205 //x2=88.155 //y2=5.205
cc_2468 ( N_noxref_6_M170_noxref_g N_noxref_44_M169_noxref_d ) capacitor \
 c=0.00125665f //x=88.52 //y=6.205 //x2=88.155 //y2=5.205
cc_2469 ( N_noxref_6_M174_noxref_g N_noxref_44_M174_noxref_d ) capacitor \
 c=0.0142133f //x=91.84 //y=6.205 //x2=91.915 //y2=5.205
cc_2470 ( N_noxref_6_M174_noxref_g N_noxref_45_c_16258_n ) capacitor \
 c=0.00969072f //x=91.84 //y=6.205 //x2=92.385 //y2=5.39
cc_2471 ( N_noxref_6_c_2580_p N_noxref_45_c_16259_n ) capacitor c=0.00879697f \
 //x=91.51 //y=4.62 //x2=91.62 //y2=5.39
cc_2472 ( N_noxref_6_c_2581_p N_noxref_45_c_16259_n ) capacitor c=0.00708476f \
 //x=91.515 //y=4.64 //x2=91.62 //y2=5.39
cc_2473 ( N_noxref_6_c_2582_p N_noxref_45_c_16259_n ) capacitor c=0.00212816f \
 //x=91.51 //y=4.62 //x2=91.62 //y2=5.39
cc_2474 ( N_noxref_6_M173_noxref_g N_noxref_45_c_16259_n ) capacitor \
 c=0.00349804f //x=91.4 //y=6.205 //x2=91.62 //y2=5.39
cc_2475 ( N_noxref_6_M174_noxref_g N_noxref_45_c_16259_n ) capacitor \
 c=0.00297228f //x=91.84 //y=6.205 //x2=91.62 //y2=5.39
cc_2476 ( N_noxref_6_c_2583_p N_noxref_45_c_16259_n ) capacitor c=0.00149603f \
 //x=91.51 //y=4.885 //x2=91.62 //y2=5.39
cc_2477 ( N_noxref_6_c_2580_p N_noxref_45_c_16265_n ) capacitor c=0.0012994f \
 //x=91.51 //y=4.62 //x2=91.62 //y2=5.56
cc_2478 ( N_noxref_6_c_2582_p N_noxref_45_c_16265_n ) capacitor c=0.00447469f \
 //x=91.51 //y=4.62 //x2=91.62 //y2=5.56
cc_2479 ( N_noxref_6_M173_noxref_g N_noxref_45_c_16265_n ) capacitor \
 c=0.0120591f //x=91.4 //y=6.205 //x2=91.62 //y2=5.56
cc_2480 ( N_noxref_6_M174_noxref_g N_noxref_45_c_16265_n ) capacitor \
 c=0.0142133f //x=91.84 //y=6.205 //x2=91.62 //y2=5.56
cc_2481 ( N_noxref_6_c_2583_p N_noxref_45_c_16265_n ) capacitor c=0.00417478f \
 //x=91.51 //y=4.885 //x2=91.62 //y2=5.56
cc_2482 ( N_noxref_6_c_2069_n N_GND_c_16542_n ) capacitor c=0.00196498f \
 //x=23.06 //y=2.375 //x2=25.53 //y2=0.175
cc_2483 ( N_noxref_6_c_2147_n N_GND_c_16588_n ) capacitor c=0.00884249f \
 //x=28.125 //y=1.305 //x2=30.34 //y2=0.175
cc_2484 ( N_noxref_6_c_2158_n N_GND_c_16588_n ) capacitor c=0.00662992f \
 //x=28.525 //y=1.845 //x2=30.34 //y2=0.175
cc_2485 ( N_noxref_6_M17_noxref_d N_GND_c_16588_n ) capacitor c=2.9462e-19 \
 //x=27.935 //y=1.095 //x2=30.34 //y2=0.175
cc_2486 ( N_noxref_6_c_2569_p N_GND_c_16607_n ) capacitor c=0.00156887f \
 //x=87.81 //y=2.375 //x2=88.165 //y2=0.175
cc_2487 ( N_noxref_6_c_2690_p N_GND_c_16608_n ) capacitor c=0.00178846f \
 //x=87.985 //y=1.045 //x2=88.25 //y2=1.015
cc_2488 ( N_noxref_6_c_2691_p N_GND_c_16608_n ) capacitor c=0.00324602f \
 //x=87.985 //y=1.39 //x2=88.25 //y2=1.015
cc_2489 ( N_noxref_6_c_2693_p N_GND_c_16608_n ) capacitor c=3.46977e-19 \
 //x=87.985 //y=1.7 //x2=88.25 //y2=1.015
cc_2490 ( N_noxref_6_c_2902_p N_GND_c_16608_n ) capacitor c=0.00943875f \
 //x=88.36 //y=0.89 //x2=88.25 //y2=1.015
cc_2491 ( N_noxref_6_c_2903_p N_GND_c_16608_n ) capacitor c=7.91264e-19 \
 //x=88.36 //y=1.545 //x2=88.25 //y2=1.015
cc_2492 ( N_noxref_6_c_2692_p N_GND_c_16608_n ) capacitor c=0.00205842f \
 //x=88.515 //y=1.045 //x2=88.25 //y2=1.015
cc_2493 ( N_noxref_6_c_2694_p N_GND_c_16608_n ) capacitor c=0.00402617f \
 //x=88.515 //y=1.39 //x2=88.25 //y2=1.015
cc_2494 ( N_noxref_6_c_2576_p N_GND_c_16615_n ) capacitor c=0.0047328f \
 //x=91.51 //y=2.385 //x2=91.58 //y2=1.015
cc_2495 ( N_noxref_6_c_2578_p N_GND_c_16615_n ) capacitor c=4.39516e-19 \
 //x=91.51 //y=2.26 //x2=91.58 //y2=1.015
cc_2496 ( N_noxref_6_c_2610_p N_GND_c_16615_n ) capacitor c=0.00183126f \
 //x=91.315 //y=1.045 //x2=91.58 //y2=1.015
cc_2497 ( N_noxref_6_c_2611_p N_GND_c_16615_n ) capacitor c=0.00370593f \
 //x=91.315 //y=1.39 //x2=91.58 //y2=1.015
cc_2498 ( N_noxref_6_c_2613_p N_GND_c_16615_n ) capacitor c=3.23691e-19 \
 //x=91.315 //y=1.7 //x2=91.58 //y2=1.015
cc_2499 ( N_noxref_6_c_2911_p N_GND_c_16615_n ) capacitor c=0.00937432f \
 //x=91.69 //y=0.89 //x2=91.58 //y2=1.015
cc_2500 ( N_noxref_6_c_2912_p N_GND_c_16615_n ) capacitor c=0.00221386f \
 //x=91.69 //y=1.545 //x2=91.58 //y2=1.015
cc_2501 ( N_noxref_6_c_2612_p N_GND_c_16615_n ) capacitor c=0.00221432f \
 //x=91.845 //y=1.045 //x2=91.58 //y2=1.015
cc_2502 ( N_noxref_6_c_2614_p N_GND_c_16615_n ) capacitor c=0.00451365f \
 //x=91.845 //y=1.39 //x2=91.58 //y2=1.015
cc_2503 ( N_noxref_6_c_2147_n N_GND_c_16624_n ) capacitor c=0.00543195f \
 //x=28.125 //y=1.305 //x2=30.425 //y2=1.145
cc_2504 ( N_noxref_6_c_2069_n N_GND_c_16522_n ) capacitor c=2.016e-19 \
 //x=23.06 //y=2.375 //x2=24.37 //y2=0.175
cc_2505 ( N_noxref_6_c_2158_n N_GND_c_16562_n ) capacitor c=6.86343e-19 \
 //x=28.525 //y=1.845 //x2=29.18 //y2=0.175
cc_2506 ( N_noxref_6_c_2165_n N_GND_c_16562_n ) capacitor c=2.0172e-19 \
 //x=28.61 //y=3.685 //x2=29.18 //y2=0.175
cc_2507 ( N_noxref_6_c_2690_p N_GND_c_16628_n ) capacitor c=0.00694747f \
 //x=87.985 //y=1.045 //x2=90.23 //y2=0.175
cc_2508 ( N_noxref_6_c_2610_p N_GND_c_16629_n ) capacitor c=0.00688359f \
 //x=91.315 //y=1.045 //x2=93.56 //y2=0.175
cc_2509 ( N_noxref_6_c_2099_n N_GND_c_16563_n ) capacitor c=0.00222376f \
 //x=23.06 //y=2.26 //x2=24.54 //y2=0.175
cc_2510 ( N_noxref_6_c_2127_n N_GND_c_16563_n ) capacitor c=0.00262688f \
 //x=23.58 //y=1.44 //x2=24.54 //y2=0.175
cc_2511 ( N_noxref_6_c_2131_n N_GND_c_16563_n ) capacitor c=2.63786e-19 \
 //x=23.06 //y=2.26 //x2=24.54 //y2=0.175
cc_2512 ( N_noxref_6_c_2153_n N_GND_c_16600_n ) capacitor c=0.0045138f \
 //x=28.125 //y=1.76 //x2=29.35 //y2=0.175
cc_2513 ( N_noxref_6_c_2158_n N_GND_c_16600_n ) capacitor c=0.0323123f \
 //x=28.525 //y=1.845 //x2=29.35 //y2=0.175
cc_2514 ( N_noxref_6_c_2569_p N_GND_c_16635_n ) capacitor c=0.00422697f \
 //x=87.81 //y=2.375 //x2=87.07 //y2=0.175
cc_2515 ( N_noxref_6_c_2550_p N_GND_c_16635_n ) capacitor c=0.0118531f \
 //x=87.81 //y=4.46 //x2=87.07 //y2=0.175
cc_2516 ( N_noxref_6_c_2593_p N_GND_c_16635_n ) capacitor c=0.00812231f \
 //x=87.81 //y=2.26 //x2=87.07 //y2=0.175
cc_2517 ( N_noxref_6_c_2693_p N_GND_c_16635_n ) capacitor c=0.0015404f \
 //x=87.985 //y=1.7 //x2=87.07 //y2=0.175
cc_2518 ( N_noxref_6_c_2696_p N_GND_c_16635_n ) capacitor c=0.00366398f \
 //x=87.985 //y=2.095 //x2=87.07 //y2=0.175
cc_2519 ( N_noxref_6_c_2595_p N_GND_c_16635_n ) capacitor c=0.00791541f \
 //x=87.81 //y=2.26 //x2=87.07 //y2=0.175
cc_2520 ( N_noxref_6_c_2576_p N_GND_c_16641_n ) capacitor c=0.00428337f \
 //x=91.51 //y=2.385 //x2=90.4 //y2=0.175
cc_2521 ( N_noxref_6_c_2577_p N_GND_c_16641_n ) capacitor c=0.00865061f \
 //x=91.51 //y=4.475 //x2=90.4 //y2=0.175
cc_2522 ( N_noxref_6_c_2578_p N_GND_c_16641_n ) capacitor c=0.00354577f \
 //x=91.51 //y=2.26 //x2=90.4 //y2=0.175
cc_2523 ( N_noxref_6_c_2603_p N_GND_c_16641_n ) capacitor c=0.00942113f \
 //x=91.315 //y=2.095 //x2=90.4 //y2=0.175
cc_2524 ( N_noxref_6_c_2690_p N_GND_M54_noxref_d ) capacitor c=0.00192399f \
 //x=87.985 //y=1.045 //x2=88.06 //y2=1.045
cc_2525 ( N_noxref_6_c_2691_p N_GND_M54_noxref_d ) capacitor c=0.00210798f \
 //x=87.985 //y=1.39 //x2=88.06 //y2=1.045
cc_2526 ( N_noxref_6_c_2902_p N_GND_M54_noxref_d ) capacitor c=0.00472259f \
 //x=88.36 //y=0.89 //x2=88.06 //y2=1.045
cc_2527 ( N_noxref_6_c_2903_p N_GND_M54_noxref_d ) capacitor c=0.00166857f \
 //x=88.36 //y=1.545 //x2=88.06 //y2=1.045
cc_2528 ( N_noxref_6_c_2692_p N_GND_M54_noxref_d ) capacitor c=0.00230174f \
 //x=88.515 //y=1.045 //x2=88.06 //y2=1.045
cc_2529 ( N_noxref_6_c_2694_p N_GND_M54_noxref_d ) capacitor c=0.00210798f \
 //x=88.515 //y=1.39 //x2=88.06 //y2=1.045
cc_2530 ( N_noxref_6_c_2576_p N_GND_M56_noxref_d ) capacitor c=4.20217e-19 \
 //x=91.51 //y=2.385 //x2=91.39 //y2=1.045
cc_2531 ( N_noxref_6_c_2610_p N_GND_M56_noxref_d ) capacitor c=0.00192399f \
 //x=91.315 //y=1.045 //x2=91.39 //y2=1.045
cc_2532 ( N_noxref_6_c_2611_p N_GND_M56_noxref_d ) capacitor c=0.00228784f \
 //x=91.315 //y=1.39 //x2=91.39 //y2=1.045
cc_2533 ( N_noxref_6_c_2911_p N_GND_M56_noxref_d ) capacitor c=0.0047434f \
 //x=91.69 //y=0.89 //x2=91.39 //y2=1.045
cc_2534 ( N_noxref_6_c_2912_p N_GND_M56_noxref_d ) capacitor c=0.00172481f \
 //x=91.69 //y=1.545 //x2=91.39 //y2=1.045
cc_2535 ( N_noxref_6_c_2612_p N_GND_M56_noxref_d ) capacitor c=0.00230174f \
 //x=91.845 //y=1.045 //x2=91.39 //y2=1.045
cc_2536 ( N_noxref_6_c_2614_p N_GND_M56_noxref_d ) capacitor c=0.00228784f \
 //x=91.845 //y=1.39 //x2=91.39 //y2=1.045
cc_2537 ( N_noxref_6_c_2569_p N_noxref_65_c_19175_n ) capacitor c=0.0033606f \
 //x=87.81 //y=2.375 //x2=87.765 //y2=1.675
cc_2538 ( N_noxref_6_c_2593_p N_noxref_65_c_19175_n ) capacitor c=0.00844774f \
 //x=87.81 //y=2.26 //x2=87.765 //y2=1.675
cc_2539 ( N_noxref_6_c_2696_p N_noxref_65_c_19175_n ) capacitor c=0.00262672f \
 //x=87.985 //y=2.095 //x2=87.765 //y2=1.675
cc_2540 ( N_noxref_6_c_2595_p N_noxref_65_c_19175_n ) capacitor c=0.0079898f \
 //x=87.81 //y=2.26 //x2=87.765 //y2=1.675
cc_2541 ( N_noxref_6_c_2569_p N_noxref_65_c_19179_n ) capacitor c=0.00202154f \
 //x=87.81 //y=2.375 //x2=88.65 //y2=1.76
cc_2542 ( N_noxref_6_c_2573_p N_noxref_65_c_19179_n ) capacitor c=0.00277063f \
 //x=87.81 //y=4.62 //x2=88.65 //y2=1.76
cc_2543 ( N_noxref_6_c_2593_p N_noxref_65_c_19179_n ) capacitor c=0.00302338f \
 //x=87.81 //y=2.26 //x2=88.65 //y2=1.76
cc_2544 ( N_noxref_6_c_2693_p N_noxref_65_c_19179_n ) capacitor c=0.0072172f \
 //x=87.985 //y=1.7 //x2=88.65 //y2=1.76
cc_2545 ( N_noxref_6_c_2696_p N_noxref_65_c_19179_n ) capacitor c=0.0134418f \
 //x=87.985 //y=2.095 //x2=88.65 //y2=1.76
cc_2546 ( N_noxref_6_c_2903_p N_noxref_65_c_19179_n ) capacitor c=0.0094838f \
 //x=88.36 //y=1.545 //x2=88.65 //y2=1.76
cc_2547 ( N_noxref_6_c_2694_p N_noxref_65_c_19179_n ) capacitor c=0.00339872f \
 //x=88.515 //y=1.39 //x2=88.65 //y2=1.76
cc_2548 ( N_noxref_6_c_2595_p N_noxref_65_c_19179_n ) capacitor c=0.00168953f \
 //x=87.81 //y=2.26 //x2=88.65 //y2=1.76
cc_2549 ( N_noxref_6_c_2696_p N_noxref_65_c_19187_n ) capacitor c=6.71402e-19 \
 //x=87.985 //y=2.095 //x2=88.735 //y2=1.675
cc_2550 ( N_noxref_6_c_2690_p N_noxref_65_M54_noxref_s ) capacitor \
 c=0.0295366f //x=87.985 //y=1.045 //x2=87.63 //y2=0.545
cc_2551 ( N_noxref_6_c_2693_p N_noxref_65_M54_noxref_s ) capacitor \
 c=0.00110192f //x=87.985 //y=1.7 //x2=87.63 //y2=0.545
cc_2552 ( N_noxref_6_c_2692_p N_noxref_65_M54_noxref_s ) capacitor \
 c=0.0125442f //x=88.515 //y=1.045 //x2=87.63 //y2=0.545
cc_2553 ( N_noxref_6_c_2603_p N_noxref_66_c_19242_n ) capacitor c=0.0034165f \
 //x=91.315 //y=2.095 //x2=91.095 //y2=1.675
cc_2554 ( N_noxref_6_c_2576_p N_noxref_66_c_19243_n ) capacitor c=0.00534973f \
 //x=91.51 //y=2.385 //x2=91.98 //y2=1.76
cc_2555 ( N_noxref_6_c_2580_p N_noxref_66_c_19243_n ) capacitor c=0.00299238f \
 //x=91.51 //y=4.62 //x2=91.98 //y2=1.76
cc_2556 ( N_noxref_6_c_2578_p N_noxref_66_c_19243_n ) capacitor c=0.00763108f \
 //x=91.51 //y=2.26 //x2=91.98 //y2=1.76
cc_2557 ( N_noxref_6_c_2613_p N_noxref_66_c_19243_n ) capacitor c=0.00688171f \
 //x=91.315 //y=1.7 //x2=91.98 //y2=1.76
cc_2558 ( N_noxref_6_c_2603_p N_noxref_66_c_19243_n ) capacitor c=0.017548f \
 //x=91.315 //y=2.095 //x2=91.98 //y2=1.76
cc_2559 ( N_noxref_6_c_2912_p N_noxref_66_c_19243_n ) capacitor c=0.00717883f \
 //x=91.69 //y=1.545 //x2=91.98 //y2=1.76
cc_2560 ( N_noxref_6_c_2614_p N_noxref_66_c_19243_n ) capacitor c=0.0059368f \
 //x=91.845 //y=1.39 //x2=91.98 //y2=1.76
cc_2561 ( N_noxref_6_c_2603_p N_noxref_66_c_19250_n ) capacitor c=0.00122123f \
 //x=91.315 //y=2.095 //x2=92.065 //y2=1.675
cc_2562 ( N_noxref_6_c_2610_p N_noxref_66_M56_noxref_s ) capacitor \
 c=0.0303347f //x=91.315 //y=1.045 //x2=90.96 //y2=0.545
cc_2563 ( N_noxref_6_c_2613_p N_noxref_66_M56_noxref_s ) capacitor \
 c=3.48408e-19 //x=91.315 //y=1.7 //x2=90.96 //y2=0.545
cc_2564 ( N_noxref_6_c_2612_p N_noxref_66_M56_noxref_s ) capacitor c=0.012348f \
 //x=91.845 //y=1.045 //x2=90.96 //y2=0.545
cc_2565 ( N_noxref_7_M110_noxref_g N_noxref_8_c_3425_n ) capacitor \
 c=0.00813346f //x=40.72 //y=6.2 //x2=41.26 //y2=5.335
cc_2566 ( N_noxref_7_M109_noxref_g N_noxref_8_c_3420_n ) capacitor \
 c=0.00461408f //x=40.28 //y=6.2 //x2=40.502 //y2=5.335
cc_2567 ( N_noxref_7_M110_noxref_g N_noxref_8_c_3420_n ) capacitor \
 c=0.00229208f //x=40.72 //y=6.2 //x2=40.502 //y2=5.335
cc_2568 ( N_noxref_7_c_2991_n N_noxref_8_c_3420_n ) capacitor c=0.00171885f \
 //x=40.645 //y=4.97 //x2=40.502 //y2=5.335
cc_2569 ( N_noxref_7_c_2997_p N_noxref_8_c_3429_n ) capacitor c=4.2553e-19 \
 //x=40.08 //y=2.77 //x2=43.04 //y2=2.77
cc_2570 ( N_noxref_7_M109_noxref_g N_noxref_8_c_3430_n ) capacitor \
 c=0.0162284f //x=40.28 //y=6.2 //x2=40.5 //y2=5.56
cc_2571 ( N_noxref_7_M110_noxref_g N_noxref_8_c_3430_n ) capacitor \
 c=0.0179041f //x=40.72 //y=6.2 //x2=40.5 //y2=5.56
cc_2572 ( N_noxref_7_c_2991_n N_noxref_8_c_3430_n ) capacitor c=0.00291477f \
 //x=40.645 //y=4.97 //x2=40.5 //y2=5.56
cc_2573 ( N_noxref_7_c_3001_p N_noxref_9_c_3734_n ) capacitor c=0.0139504f \
 //x=33.42 //y=2.625 //x2=32.68 //y2=2.375
cc_2574 ( N_noxref_7_c_3001_p N_noxref_9_c_3735_n ) capacitor c=0.00894987f \
 //x=33.42 //y=2.625 //x2=32.68 //y2=3.355
cc_2575 ( N_noxref_7_c_3003_p N_noxref_9_c_3735_n ) capacitor c=0.014957f \
 //x=33.42 //y=2.945 //x2=32.68 //y2=3.355
cc_2576 ( N_noxref_7_c_2979_n N_noxref_9_c_3735_n ) capacitor c=0.0161307f \
 //x=33.42 //y=5.25 //x2=32.68 //y2=3.355
cc_2577 ( N_noxref_7_c_3005_p N_noxref_9_c_3735_n ) capacitor c=4.63723e-19 \
 //x=35.27 //y=2.625 //x2=32.68 //y2=3.355
cc_2578 ( N_noxref_7_c_2981_n N_noxref_9_c_3735_n ) capacitor c=3.2751e-19 \
 //x=35.27 //y=4.755 //x2=32.68 //y2=3.355
cc_2579 ( N_noxref_7_c_3007_p N_noxref_9_c_3735_n ) capacitor c=7.6985e-19 \
 //x=33.42 //y=2.77 //x2=32.68 //y2=3.355
cc_2580 ( N_noxref_7_c_3008_p N_noxref_9_c_3735_n ) capacitor c=0.0068343f \
 //x=33.585 //y=2.785 //x2=32.68 //y2=3.355
cc_2581 ( N_noxref_7_c_2977_n N_noxref_9_c_3742_n ) capacitor c=9.76941e-19 \
 //x=33.335 //y=5.335 //x2=32.68 //y2=3.675
cc_2582 ( N_noxref_7_c_3010_p N_noxref_9_c_3742_n ) capacitor c=2.35691e-19 \
 //x=32.935 //y=1.305 //x2=32.68 //y2=3.675
cc_2583 ( N_noxref_7_c_2978_n N_noxref_9_c_3742_n ) capacitor c=0.00102808f \
 //x=33.02 //y=1.845 //x2=32.68 //y2=3.675
cc_2584 ( N_noxref_7_c_2979_n N_noxref_9_c_3742_n ) capacitor c=0.0174568f \
 //x=33.42 //y=5.25 //x2=32.68 //y2=3.675
cc_2585 ( N_noxref_7_c_3013_p N_noxref_9_c_3742_n ) capacitor c=5.90358e-19 \
 //x=32.64 //y=5.335 //x2=32.68 //y2=3.675
cc_2586 ( N_noxref_7_c_2977_n N_noxref_9_c_3715_n ) capacitor c=0.00198098f \
 //x=33.335 //y=5.335 //x2=32.68 //y2=4.75
cc_2587 ( N_noxref_7_c_2979_n N_noxref_9_c_3715_n ) capacitor c=0.0572201f \
 //x=33.42 //y=5.25 //x2=32.68 //y2=4.75
cc_2588 ( N_noxref_7_c_2981_n N_noxref_9_c_3715_n ) capacitor c=0.00122814f \
 //x=35.27 //y=4.755 //x2=32.68 //y2=4.75
cc_2589 ( N_noxref_7_c_3013_p N_noxref_9_c_3715_n ) capacitor c=0.0193619f \
 //x=32.64 //y=5.335 //x2=32.68 //y2=4.75
cc_2590 ( N_noxref_7_c_3018_p N_noxref_9_c_3715_n ) capacitor c=0.00217979f \
 //x=32.64 //y=5.56 //x2=32.68 //y2=4.75
cc_2591 ( N_noxref_7_M104_noxref_g N_noxref_9_c_3716_n ) capacitor \
 c=0.00889148f //x=35.91 //y=6.2 //x2=36.45 //y2=5.335
cc_2592 ( N_noxref_7_c_3020_p N_noxref_9_c_3753_n ) capacitor c=0.00163399f \
 //x=33.335 //y=1.845 //x2=37.83 //y2=1.845
cc_2593 ( N_noxref_7_c_3021_p N_noxref_9_c_3754_n ) capacitor c=0.00357748f \
 //x=40.08 //y=2.375 //x2=38.23 //y2=3.335
cc_2594 ( N_noxref_7_c_3022_p N_noxref_9_c_3754_n ) capacitor c=0.00243104f \
 //x=40.08 //y=2.625 //x2=38.23 //y2=3.335
cc_2595 ( N_noxref_7_c_3023_p N_noxref_9_c_3754_n ) capacitor c=0.00248785f \
 //x=40.08 //y=2.945 //x2=38.23 //y2=3.335
cc_2596 ( N_noxref_7_c_2982_n N_noxref_9_c_3754_n ) capacitor c=0.00451274f \
 //x=40.08 //y=4.755 //x2=38.23 //y2=3.335
cc_2597 ( N_noxref_7_c_3025_p N_noxref_9_c_3754_n ) capacitor c=0.00159838f \
 //x=40.08 //y=2.785 //x2=38.23 //y2=3.335
cc_2598 ( N_noxref_7_c_3026_p N_noxref_9_c_3754_n ) capacitor c=0.0228367f \
 //x=39.92 //y=2.785 //x2=38.23 //y2=3.335
cc_2599 ( N_noxref_7_c_2982_n N_noxref_9_c_3760_n ) capacitor c=0.00254697f \
 //x=40.08 //y=4.755 //x2=38.23 //y2=3.655
cc_2600 ( N_noxref_7_c_2982_n N_noxref_9_c_3720_n ) capacitor c=0.0146976f \
 //x=40.08 //y=4.755 //x2=38.23 //y2=5.25
cc_2601 ( N_noxref_7_c_2979_n N_noxref_9_c_3762_n ) capacitor c=6.89957e-19 \
 //x=33.42 //y=5.25 //x2=32.68 //y2=3.51
cc_2602 ( N_noxref_7_c_3030_p N_noxref_9_c_3724_n ) capacitor c=6.09703e-19 \
 //x=32.64 //y=5.56 //x2=35.692 //y2=5.335
cc_2603 ( N_noxref_7_c_2977_n N_noxref_9_c_3724_n ) capacitor c=0.00301278f \
 //x=33.335 //y=5.335 //x2=35.692 //y2=5.335
cc_2604 ( N_noxref_7_M103_noxref_g N_noxref_9_c_3724_n ) capacitor \
 c=0.00461408f //x=35.47 //y=6.2 //x2=35.692 //y2=5.335
cc_2605 ( N_noxref_7_M104_noxref_g N_noxref_9_c_3724_n ) capacitor \
 c=0.00229208f //x=35.91 //y=6.2 //x2=35.692 //y2=5.335
cc_2606 ( N_noxref_7_c_2990_n N_noxref_9_c_3724_n ) capacitor c=0.00171885f \
 //x=35.835 //y=4.97 //x2=35.692 //y2=5.335
cc_2607 ( N_noxref_7_c_2982_n N_noxref_9_c_3768_n ) capacitor c=0.0242814f \
 //x=40.08 //y=4.755 //x2=49.535 //y2=3.51
cc_2608 ( N_noxref_7_c_3026_p N_noxref_9_c_3768_n ) capacitor c=0.00854491f \
 //x=39.92 //y=2.785 //x2=49.535 //y2=3.51
cc_2609 ( N_noxref_7_c_2979_n N_noxref_9_c_3770_n ) capacitor c=0.00330634f \
 //x=33.42 //y=5.25 //x2=32.85 //y2=3.515
cc_2610 ( N_noxref_7_c_2979_n N_noxref_9_c_3771_n ) capacitor c=0.0246533f \
 //x=33.42 //y=5.25 //x2=38.07 //y2=3.495
cc_2611 ( N_noxref_7_c_2981_n N_noxref_9_c_3771_n ) capacitor c=0.0271813f \
 //x=35.27 //y=4.755 //x2=38.07 //y2=3.495
cc_2612 ( N_noxref_7_c_3040_p N_noxref_9_c_3771_n ) capacitor c=0.00883258f \
 //x=35.115 //y=2.785 //x2=38.07 //y2=3.495
cc_2613 ( N_noxref_7_c_3026_p N_noxref_9_c_3771_n ) capacitor c=0.022994f \
 //x=39.92 //y=2.785 //x2=38.07 //y2=3.495
cc_2614 ( N_noxref_7_c_2982_n N_noxref_9_c_3775_n ) capacitor c=0.00159838f \
 //x=40.08 //y=4.755 //x2=38.39 //y2=3.495
cc_2615 ( N_noxref_7_c_3001_p N_noxref_9_c_3776_n ) capacitor c=0.0015536f \
 //x=33.42 //y=2.625 //x2=32.68 //y2=2.26
cc_2616 ( N_noxref_7_c_2977_n N_noxref_9_c_3777_n ) capacitor c=0.00130631f \
 //x=33.335 //y=5.335 //x2=32.68 //y2=4.88
cc_2617 ( N_noxref_7_c_2979_n N_noxref_9_c_3777_n ) capacitor c=0.00126408f \
 //x=33.42 //y=5.25 //x2=32.68 //y2=4.88
cc_2618 ( N_noxref_7_c_3013_p N_noxref_9_c_3777_n ) capacitor c=0.00346456f \
 //x=32.64 //y=5.335 //x2=32.68 //y2=4.88
cc_2619 ( N_noxref_7_c_3018_p N_noxref_9_c_3777_n ) capacitor c=0.00624059f \
 //x=32.64 //y=5.56 //x2=32.68 //y2=4.88
cc_2620 ( N_noxref_7_M103_noxref_g N_noxref_9_c_3781_n ) capacitor \
 c=0.0162284f //x=35.47 //y=6.2 //x2=35.69 //y2=5.56
cc_2621 ( N_noxref_7_M104_noxref_g N_noxref_9_c_3781_n ) capacitor \
 c=0.0179041f //x=35.91 //y=6.2 //x2=35.69 //y2=5.56
cc_2622 ( N_noxref_7_c_2990_n N_noxref_9_c_3781_n ) capacitor c=0.00291477f \
 //x=35.835 //y=4.97 //x2=35.69 //y2=5.56
cc_2623 ( N_noxref_7_c_3051_p N_noxref_9_M101_noxref_g ) capacitor \
 c=0.00875663f //x=32.525 //y=5.335 //x2=32.42 //y2=6.2
cc_2624 ( N_noxref_7_c_3030_p N_noxref_9_M101_noxref_g ) capacitor \
 c=0.00226521f //x=32.64 //y=5.56 //x2=32.42 //y2=6.2
cc_2625 ( N_noxref_7_c_3018_p N_noxref_9_M101_noxref_g ) capacitor \
 c=0.0178885f //x=32.64 //y=5.56 //x2=32.42 //y2=6.2
cc_2626 ( N_noxref_7_c_3030_p N_noxref_9_M102_noxref_g ) capacitor \
 c=0.00381703f //x=32.64 //y=5.56 //x2=32.86 //y2=6.2
cc_2627 ( N_noxref_7_c_2977_n N_noxref_9_M102_noxref_g ) capacitor \
 c=0.0106087f //x=33.335 //y=5.335 //x2=32.86 //y2=6.2
cc_2628 ( N_noxref_7_c_3018_p N_noxref_9_M102_noxref_g ) capacitor \
 c=0.0188608f //x=32.64 //y=5.56 //x2=32.86 //y2=6.2
cc_2629 ( N_noxref_7_c_3010_p N_noxref_9_c_3790_n ) capacitor c=4.64015e-19 \
 //x=32.935 //y=1.305 //x2=32.67 //y2=1.095
cc_2630 ( N_noxref_7_M20_noxref_d N_noxref_9_c_3790_n ) capacitor \
 c=0.00137165f //x=32.745 //y=1.095 //x2=32.67 //y2=1.095
cc_2631 ( N_noxref_7_c_3010_p N_noxref_9_c_3792_n ) capacitor c=0.0026012f \
 //x=32.935 //y=1.305 //x2=32.67 //y2=1.44
cc_2632 ( N_noxref_7_c_3060_p N_noxref_9_c_3792_n ) capacitor c=0.00127432f \
 //x=32.935 //y=1.76 //x2=32.67 //y2=1.44
cc_2633 ( N_noxref_7_M20_noxref_d N_noxref_9_c_3792_n ) capacitor \
 c=0.00237422f //x=32.745 //y=1.095 //x2=32.67 //y2=1.44
cc_2634 ( N_noxref_7_c_3060_p N_noxref_9_c_3795_n ) capacitor c=0.00429966f \
 //x=32.935 //y=1.76 //x2=32.67 //y2=1.75
cc_2635 ( N_noxref_7_c_3010_p N_noxref_9_c_3796_n ) capacitor c=5.29969e-19 \
 //x=32.935 //y=1.305 //x2=33.045 //y2=0.94
cc_2636 ( N_noxref_7_M20_noxref_d N_noxref_9_c_3796_n ) capacitor c=0.0020782f \
 //x=32.745 //y=1.095 //x2=33.045 //y2=0.94
cc_2637 ( N_noxref_7_c_3010_p N_noxref_9_c_3798_n ) capacitor c=5.00148e-19 \
 //x=32.935 //y=1.305 //x2=33.045 //y2=1.595
cc_2638 ( N_noxref_7_c_3060_p N_noxref_9_c_3798_n ) capacitor c=0.00942306f \
 //x=32.935 //y=1.76 //x2=33.045 //y2=1.595
cc_2639 ( N_noxref_7_c_3020_p N_noxref_9_c_3798_n ) capacitor c=0.00194716f \
 //x=33.335 //y=1.845 //x2=33.045 //y2=1.595
cc_2640 ( N_noxref_7_M20_noxref_d N_noxref_9_c_3798_n ) capacitor \
 c=0.00356097f //x=32.745 //y=1.095 //x2=33.045 //y2=1.595
cc_2641 ( N_noxref_7_c_3010_p N_noxref_9_c_3802_n ) capacitor c=5.24634e-19 \
 //x=32.935 //y=1.305 //x2=33.2 //y2=1.095
cc_2642 ( N_noxref_7_M20_noxref_d N_noxref_9_c_3802_n ) capacitor \
 c=0.00139206f //x=32.745 //y=1.095 //x2=33.2 //y2=1.095
cc_2643 ( N_noxref_7_c_3010_p N_noxref_9_c_3804_n ) capacitor c=0.00307978f \
 //x=32.935 //y=1.305 //x2=33.2 //y2=1.44
cc_2644 ( N_noxref_7_c_3060_p N_noxref_9_c_3804_n ) capacitor c=0.00363411f \
 //x=32.935 //y=1.76 //x2=33.2 //y2=1.44
cc_2645 ( N_noxref_7_c_3020_p N_noxref_9_c_3804_n ) capacitor c=0.00323576f \
 //x=33.335 //y=1.845 //x2=33.2 //y2=1.44
cc_2646 ( N_noxref_7_M20_noxref_d N_noxref_9_c_3804_n ) capacitor \
 c=0.00237422f //x=32.745 //y=1.095 //x2=33.2 //y2=1.44
cc_2647 ( N_noxref_7_c_3001_p N_noxref_9_c_3808_n ) capacitor c=0.0024584f \
 //x=33.42 //y=2.625 //x2=32.68 //y2=2.26
cc_2648 ( N_noxref_7_c_3060_p N_noxref_9_c_3809_n ) capacitor c=0.0036273f \
 //x=32.935 //y=1.76 //x2=32.68 //y2=2.095
cc_2649 ( N_noxref_7_c_3001_p N_noxref_9_c_3809_n ) capacitor c=0.00282067f \
 //x=33.42 //y=2.625 //x2=32.68 //y2=2.095
cc_2650 ( N_noxref_7_c_2979_n N_noxref_9_c_3733_n ) capacitor c=0.00714556f \
 //x=33.42 //y=5.25 //x2=32.68 //y2=4.88
cc_2651 ( N_noxref_7_c_3013_p N_noxref_9_c_3733_n ) capacitor c=0.00203307f \
 //x=32.64 //y=5.335 //x2=32.68 //y2=4.88
cc_2652 ( N_noxref_7_c_3018_p N_noxref_9_c_3733_n ) capacitor c=0.00375636f \
 //x=32.64 //y=5.56 //x2=32.68 //y2=4.88
cc_2653 ( N_noxref_7_c_3005_p N_noxref_11_c_4521_n ) capacitor c=2.88859e-19 \
 //x=35.27 //y=2.625 //x2=37.49 //y2=3.735
cc_2654 ( N_noxref_7_c_2981_n N_noxref_11_c_4521_n ) capacitor c=6.82234e-19 \
 //x=35.27 //y=4.755 //x2=37.49 //y2=3.735
cc_2655 ( N_noxref_7_c_3022_p N_noxref_11_c_4521_n ) capacitor c=4.65873e-19 \
 //x=40.08 //y=2.625 //x2=37.49 //y2=3.735
cc_2656 ( N_noxref_7_c_2982_n N_noxref_11_c_4521_n ) capacitor c=9.95563e-19 \
 //x=40.08 //y=4.755 //x2=37.49 //y2=3.735
cc_2657 ( N_noxref_7_c_3026_p N_noxref_11_c_4521_n ) capacitor c=0.0220649f \
 //x=39.92 //y=2.785 //x2=37.49 //y2=3.735
cc_2658 ( N_noxref_7_c_2981_n N_noxref_11_c_4499_n ) capacitor c=5.85612e-19 \
 //x=35.27 //y=4.755 //x2=37.49 //y2=4.75
cc_2659 ( N_noxref_7_c_2982_n N_noxref_11_c_4499_n ) capacitor c=8.29068e-19 \
 //x=40.08 //y=4.755 //x2=37.49 //y2=4.75
cc_2660 ( N_noxref_7_c_3022_p N_noxref_11_c_4528_n ) capacitor c=2.88859e-19 \
 //x=40.08 //y=2.625 //x2=42.3 //y2=3.735
cc_2661 ( N_noxref_7_c_2982_n N_noxref_11_c_4528_n ) capacitor c=8.06128e-19 \
 //x=40.08 //y=4.755 //x2=42.3 //y2=3.735
cc_2662 ( N_noxref_7_c_2982_n N_noxref_11_c_4500_n ) capacitor c=6.20497e-19 \
 //x=40.08 //y=4.755 //x2=42.3 //y2=4.75
cc_2663 ( N_noxref_7_c_2982_n N_noxref_11_c_4531_n ) capacitor c=0.0247411f \
 //x=40.08 //y=4.755 //x2=42.14 //y2=3.895
cc_2664 ( N_noxref_7_c_2982_n N_D_c_5190_n ) capacitor c=0.0247356f //x=40.08 \
 //y=4.755 //x2=37.705 //y2=4.28
cc_2665 ( N_noxref_7_c_2979_n N_D_c_5173_n ) capacitor c=0.0260165f //x=33.42 \
 //y=5.25 //x2=37.36 //y2=4.28
cc_2666 ( N_noxref_7_c_2981_n N_D_c_5173_n ) capacitor c=0.0274592f //x=35.27 \
 //y=4.755 //x2=37.36 //y2=4.28
cc_2667 ( N_noxref_7_c_2983_n N_D_M97_noxref_g ) capacitor c=0.00461408f \
 //x=30.882 //y=5.335 //x2=30.66 //y2=6.2
cc_2668 ( N_noxref_7_c_3096_p N_D_M97_noxref_g ) capacitor c=0.0162284f \
 //x=30.88 //y=5.56 //x2=30.66 //y2=6.2
cc_2669 ( N_noxref_7_c_3097_p N_D_M98_noxref_g ) capacitor c=0.00813346f \
 //x=31.64 //y=5.335 //x2=31.1 //y2=6.2
cc_2670 ( N_noxref_7_c_2983_n N_D_M98_noxref_g ) capacitor c=0.00229208f \
 //x=30.882 //y=5.335 //x2=31.1 //y2=6.2
cc_2671 ( N_noxref_7_c_3096_p N_D_M98_noxref_g ) capacitor c=0.0179041f \
 //x=30.88 //y=5.56 //x2=31.1 //y2=6.2
cc_2672 ( N_noxref_7_c_2983_n N_D_c_5209_n ) capacitor c=0.00171885f \
 //x=30.882 //y=5.335 //x2=31.025 //y2=4.97
cc_2673 ( N_noxref_7_c_3096_p N_D_c_5209_n ) capacitor c=0.00291477f //x=30.88 \
 //y=5.56 //x2=31.025 //y2=4.97
cc_2674 ( N_noxref_7_c_3001_p CLK ) capacitor c=3.44709e-19 //x=33.42 \
 //y=2.625 //x2=36.38 //y2=3.88
cc_2675 ( N_noxref_7_c_2979_n CLK ) capacitor c=0.00113117f //x=33.42 //y=5.25 \
 //x2=36.38 //y2=3.88
cc_2676 ( N_noxref_7_c_3005_p CLK ) capacitor c=0.00510083f //x=35.27 \
 //y=2.625 //x2=36.38 //y2=3.88
cc_2677 ( N_noxref_7_c_3105_p CLK ) capacitor c=0.00782284f //x=35.27 \
 //y=2.945 //x2=36.38 //y2=3.88
cc_2678 ( N_noxref_7_c_2981_n CLK ) capacitor c=0.0417473f //x=35.27 //y=4.755 \
 //x2=36.38 //y2=3.88
cc_2679 ( N_noxref_7_c_3107_p CLK ) capacitor c=4.11345e-19 //x=35.27 //y=2.77 \
 //x2=36.38 //y2=3.88
cc_2680 ( N_noxref_7_c_3108_p CLK ) capacitor c=0.00248676f //x=35.435 \
 //y=2.785 //x2=36.38 //y2=3.88
cc_2681 ( N_noxref_7_c_3026_p CLK ) capacitor c=0.0229179f //x=39.92 //y=2.785 \
 //x2=36.38 //y2=3.88
cc_2682 ( N_noxref_7_c_3110_p CLK ) capacitor c=3.9149e-19 //x=35.27 //y=2.26 \
 //x2=36.38 //y2=3.88
cc_2683 ( N_noxref_7_c_3111_p N_CLK_c_6658_n ) capacitor c=0.00932261f \
 //x=35.27 //y=2.375 //x2=36.38 //y2=2.375
cc_2684 ( N_noxref_7_c_3110_p N_CLK_c_6658_n ) capacitor c=5.40058e-19 \
 //x=35.27 //y=2.26 //x2=36.38 //y2=2.375
cc_2685 ( N_noxref_7_c_3113_p N_CLK_c_6658_n ) capacitor c=0.00142893f \
 //x=34.97 //y=2.095 //x2=36.38 //y2=2.375
cc_2686 ( N_noxref_7_c_2981_n N_CLK_c_6592_n ) capacitor c=0.00776139f \
 //x=35.27 //y=4.755 //x2=36.375 //y2=4.835
cc_2687 ( N_noxref_7_c_3115_p N_CLK_c_6592_n ) capacitor c=6.32742e-19 \
 //x=35.27 //y=4.88 //x2=36.375 //y2=4.835
cc_2688 ( N_noxref_7_c_2990_n N_CLK_c_6592_n ) capacitor c=7.15803e-19 \
 //x=35.835 //y=4.97 //x2=36.375 //y2=4.835
cc_2689 ( N_noxref_7_c_3117_p N_CLK_c_6592_n ) capacitor c=8.67242e-19 \
 //x=35.545 //y=4.97 //x2=36.375 //y2=4.835
cc_2690 ( N_noxref_7_c_2982_n N_CLK_c_6616_n ) capacitor c=0.0275006f \
 //x=40.08 //y=4.755 //x2=45.845 //y2=4.62
cc_2691 ( N_noxref_7_c_2979_n N_CLK_c_6619_n ) capacitor c=0.0233664f \
 //x=33.42 //y=5.25 //x2=36.535 //y2=4.62
cc_2692 ( N_noxref_7_c_2981_n N_CLK_c_6619_n ) capacitor c=0.0320227f \
 //x=35.27 //y=4.755 //x2=36.535 //y2=4.62
cc_2693 ( N_noxref_7_c_3111_p N_CLK_c_6668_n ) capacitor c=5.39999e-19 \
 //x=35.27 //y=2.375 //x2=36.38 //y2=2.26
cc_2694 ( N_noxref_7_c_3005_p N_CLK_c_6668_n ) capacitor c=3.9149e-19 \
 //x=35.27 //y=2.625 //x2=36.38 //y2=2.26
cc_2695 ( N_noxref_7_c_3110_p N_CLK_c_6668_n ) capacitor c=0.00125213f \
 //x=35.27 //y=2.26 //x2=36.38 //y2=2.26
cc_2696 ( N_noxref_7_c_3113_p N_CLK_c_6668_n ) capacitor c=0.00214573f \
 //x=34.97 //y=2.095 //x2=36.38 //y2=2.26
cc_2697 ( N_noxref_7_c_2981_n N_CLK_c_6672_n ) capacitor c=4.24307e-19 \
 //x=35.27 //y=4.755 //x2=36.38 //y2=4.88
cc_2698 ( N_noxref_7_c_3115_p N_CLK_c_6672_n ) capacitor c=0.00113666f \
 //x=35.27 //y=4.88 //x2=36.38 //y2=4.88
cc_2699 ( N_noxref_7_c_2990_n N_CLK_c_6672_n ) capacitor c=0.00116563f \
 //x=35.835 //y=4.97 //x2=36.38 //y2=4.88
cc_2700 ( N_noxref_7_c_3117_p N_CLK_c_6672_n ) capacitor c=0.0012974f \
 //x=35.545 //y=4.97 //x2=36.38 //y2=4.88
cc_2701 ( N_noxref_7_M103_noxref_g N_CLK_M105_noxref_g ) capacitor \
 c=0.0106276f //x=35.47 //y=6.2 //x2=36.35 //y2=6.2
cc_2702 ( N_noxref_7_M104_noxref_g N_CLK_M105_noxref_g ) capacitor c=0.107144f \
 //x=35.91 //y=6.2 //x2=36.35 //y2=6.2
cc_2703 ( N_noxref_7_M104_noxref_g N_CLK_M106_noxref_g ) capacitor \
 c=0.0101598f //x=35.91 //y=6.2 //x2=36.79 //y2=6.2
cc_2704 ( N_noxref_7_c_3132_p N_CLK_c_6679_n ) capacitor c=5.72528e-19 \
 //x=34.97 //y=1.055 //x2=35.945 //y2=1.09
cc_2705 ( N_noxref_7_c_3133_p N_CLK_c_6679_n ) capacitor c=0.00150277f \
 //x=34.97 //y=1.4 //x2=35.945 //y2=1.09
cc_2706 ( N_noxref_7_c_3134_p N_CLK_c_6679_n ) capacitor c=0.0160123f //x=35.5 \
 //y=1.055 //x2=35.945 //y2=1.09
cc_2707 ( N_noxref_7_c_3135_p N_CLK_c_6682_n ) capacitor c=0.00111227f \
 //x=34.97 //y=1.71 //x2=35.945 //y2=1.4
cc_2708 ( N_noxref_7_c_3136_p N_CLK_c_6682_n ) capacitor c=0.0124075f //x=35.5 \
 //y=1.4 //x2=35.945 //y2=1.4
cc_2709 ( N_noxref_7_c_3134_p N_CLK_c_6684_n ) capacitor c=9.19165e-19 \
 //x=35.5 //y=1.055 //x2=36.47 //y2=1.09
cc_2710 ( N_noxref_7_c_3136_p N_CLK_c_6685_n ) capacitor c=0.0010154f //x=35.5 \
 //y=1.4 //x2=36.47 //y2=1.4
cc_2711 ( N_noxref_7_c_3136_p N_CLK_c_6686_n ) capacitor c=9.23422e-19 \
 //x=35.5 //y=1.4 //x2=36.47 //y2=1.63
cc_2712 ( N_noxref_7_c_3111_p N_CLK_c_6687_n ) capacitor c=0.00136403f \
 //x=35.27 //y=2.375 //x2=36.47 //y2=2.095
cc_2713 ( N_noxref_7_c_3110_p N_CLK_c_6687_n ) capacitor c=0.0020754f \
 //x=35.27 //y=2.26 //x2=36.47 //y2=2.095
cc_2714 ( N_noxref_7_c_3113_p N_CLK_c_6687_n ) capacitor c=0.00964411f \
 //x=34.97 //y=2.095 //x2=36.47 //y2=2.095
cc_2715 ( N_noxref_7_c_3115_p N_CLK_c_6690_n ) capacitor c=0.00123917f \
 //x=35.27 //y=4.88 //x2=36.38 //y2=4.88
cc_2716 ( N_noxref_7_c_2990_n N_CLK_c_6690_n ) capacitor c=0.0169508f \
 //x=35.835 //y=4.97 //x2=36.38 //y2=4.88
cc_2717 ( N_noxref_7_c_3117_p N_CLK_c_6690_n ) capacitor c=0.00406071f \
 //x=35.545 //y=4.97 //x2=36.38 //y2=4.88
cc_2718 ( N_noxref_7_c_2979_n RN ) capacitor c=0.00285501f //x=33.42 //y=5.25 \
 //x2=31.57 //y2=2.77
cc_2719 ( N_noxref_7_c_3097_p N_RN_c_8182_n ) capacitor c=3.27333e-19 \
 //x=31.64 //y=5.335 //x2=31.57 //y2=2.56
cc_2720 ( N_noxref_7_c_3148_p N_RN_c_8182_n ) capacitor c=4.2393e-19 //x=31.76 \
 //y=5.335 //x2=31.57 //y2=2.56
cc_2721 ( N_noxref_7_c_3097_p N_RN_c_8124_n ) capacitor c=0.0179739f //x=31.64 \
 //y=5.335 //x2=31.57 //y2=4.765
cc_2722 ( N_noxref_7_c_3148_p N_RN_c_8124_n ) capacitor c=0.00209649f \
 //x=31.76 //y=5.335 //x2=31.57 //y2=4.765
cc_2723 ( N_noxref_7_c_3151_p N_RN_c_8124_n ) capacitor c=7.63434e-19 \
 //x=31.76 //y=5.56 //x2=31.57 //y2=4.765
cc_2724 ( N_noxref_7_c_3010_p N_RN_c_8024_n ) capacitor c=6.87062e-19 \
 //x=32.935 //y=1.305 //x2=42.825 //y2=2.385
cc_2725 ( N_noxref_7_c_2978_n N_RN_c_8024_n ) capacitor c=0.0206216f //x=33.02 \
 //y=1.845 //x2=42.825 //y2=2.385
cc_2726 ( N_noxref_7_c_3001_p N_RN_c_8024_n ) capacitor c=0.027263f //x=33.42 \
 //y=2.625 //x2=42.825 //y2=2.385
cc_2727 ( N_noxref_7_c_3003_p N_RN_c_8024_n ) capacitor c=0.00571008f \
 //x=33.42 //y=2.945 //x2=42.825 //y2=2.385
cc_2728 ( N_noxref_7_c_3111_p N_RN_c_8024_n ) capacitor c=0.0155883f //x=35.27 \
 //y=2.375 //x2=42.825 //y2=2.385
cc_2729 ( N_noxref_7_c_3005_p N_RN_c_8024_n ) capacitor c=0.0138002f //x=35.27 \
 //y=2.625 //x2=42.825 //y2=2.385
cc_2730 ( N_noxref_7_c_3105_p N_RN_c_8024_n ) capacitor c=0.00747608f \
 //x=35.27 //y=2.945 //x2=42.825 //y2=2.385
cc_2731 ( N_noxref_7_c_3021_p N_RN_c_8024_n ) capacitor c=0.0155623f //x=40.08 \
 //y=2.375 //x2=42.825 //y2=2.385
cc_2732 ( N_noxref_7_c_3022_p N_RN_c_8024_n ) capacitor c=0.0137567f //x=40.08 \
 //y=2.625 //x2=42.825 //y2=2.385
cc_2733 ( N_noxref_7_c_3023_p N_RN_c_8024_n ) capacitor c=0.00802015f \
 //x=40.08 //y=2.945 //x2=42.825 //y2=2.385
cc_2734 ( N_noxref_7_c_3008_p N_RN_c_8024_n ) capacitor c=0.0365231f \
 //x=33.585 //y=2.785 //x2=42.825 //y2=2.385
cc_2735 ( N_noxref_7_c_3040_p N_RN_c_8024_n ) capacitor c=0.1407f //x=35.115 \
 //y=2.785 //x2=42.825 //y2=2.385
cc_2736 ( N_noxref_7_c_3108_p N_RN_c_8024_n ) capacitor c=0.0370413f \
 //x=35.435 //y=2.785 //x2=42.825 //y2=2.385
cc_2737 ( N_noxref_7_c_3025_p N_RN_c_8024_n ) capacitor c=0.0370413f //x=40.08 \
 //y=2.785 //x2=42.825 //y2=2.385
cc_2738 ( N_noxref_7_c_3026_p N_RN_c_8024_n ) capacitor c=0.404559f //x=39.92 \
 //y=2.785 //x2=42.825 //y2=2.385
cc_2739 ( N_noxref_7_c_3110_p N_RN_c_8024_n ) capacitor c=5.18204e-19 \
 //x=35.27 //y=2.26 //x2=42.825 //y2=2.385
cc_2740 ( N_noxref_7_c_3168_p N_RN_c_8024_n ) capacitor c=5.18204e-19 \
 //x=40.08 //y=2.26 //x2=42.825 //y2=2.385
cc_2741 ( N_noxref_7_c_3113_p N_RN_c_8024_n ) capacitor c=3.41298e-19 \
 //x=34.97 //y=2.095 //x2=42.825 //y2=2.385
cc_2742 ( N_noxref_7_c_3170_p N_RN_c_8024_n ) capacitor c=3.41298e-19 \
 //x=39.78 //y=2.095 //x2=42.825 //y2=2.385
cc_2743 ( N_noxref_7_c_3097_p N_RN_c_8150_n ) capacitor c=0.00492634f \
 //x=31.64 //y=5.335 //x2=31.57 //y2=4.88
cc_2744 ( N_noxref_7_c_3148_p N_RN_c_8150_n ) capacitor c=0.00132214f \
 //x=31.76 //y=5.335 //x2=31.57 //y2=4.88
cc_2745 ( N_noxref_7_c_3097_p N_RN_M99_noxref_g ) capacitor c=0.00858183f \
 //x=31.64 //y=5.335 //x2=31.54 //y2=6.2
cc_2746 ( N_noxref_7_c_3148_p N_RN_M99_noxref_g ) capacitor c=0.00229818f \
 //x=31.76 //y=5.335 //x2=31.54 //y2=6.2
cc_2747 ( N_noxref_7_c_3151_p N_RN_M99_noxref_g ) capacitor c=0.0179041f \
 //x=31.76 //y=5.56 //x2=31.54 //y2=6.2
cc_2748 ( N_noxref_7_c_3051_p N_RN_M100_noxref_g ) capacitor c=0.00875663f \
 //x=32.525 //y=5.335 //x2=31.98 //y2=6.2
cc_2749 ( N_noxref_7_c_3148_p N_RN_M100_noxref_g ) capacitor c=0.00230699f \
 //x=31.76 //y=5.335 //x2=31.98 //y2=6.2
cc_2750 ( N_noxref_7_c_3151_p N_RN_M100_noxref_g ) capacitor c=0.0179041f \
 //x=31.76 //y=5.56 //x2=31.98 //y2=6.2
cc_2751 ( N_noxref_7_c_3148_p N_RN_c_8173_n ) capacitor c=0.00180979f \
 //x=31.76 //y=5.335 //x2=31.905 //y2=4.97
cc_2752 ( N_noxref_7_c_3151_p N_RN_c_8173_n ) capacitor c=0.00290085f \
 //x=31.76 //y=5.56 //x2=31.905 //y2=4.97
cc_2753 ( N_noxref_7_c_3097_p N_RN_c_8216_n ) capacitor c=6.14463e-19 \
 //x=31.64 //y=5.335 //x2=31.57 //y2=4.88
cc_2754 ( N_noxref_7_c_3022_p SN ) capacitor c=0.00510184f //x=40.08 //y=2.625 \
 //x2=41.19 //y2=2.77
cc_2755 ( N_noxref_7_c_3023_p SN ) capacitor c=0.00782712f //x=40.08 //y=2.945 \
 //x2=41.19 //y2=2.77
cc_2756 ( N_noxref_7_c_2982_n SN ) capacitor c=6.32157e-19 //x=40.08 //y=4.755 \
 //x2=41.19 //y2=2.77
cc_2757 ( N_noxref_7_c_2997_p SN ) capacitor c=3.49492e-19 //x=40.08 //y=2.77 \
 //x2=41.19 //y2=2.77
cc_2758 ( N_noxref_7_c_3025_p SN ) capacitor c=0.00513442f //x=40.08 //y=2.785 \
 //x2=41.19 //y2=2.77
cc_2759 ( N_noxref_7_c_3168_p SN ) capacitor c=3.9149e-19 //x=40.08 //y=2.26 \
 //x2=41.19 //y2=2.77
cc_2760 ( N_noxref_7_c_2982_n SN ) capacitor c=5.01652e-19 //x=40.08 //y=4.755 \
 //x2=41.19 //y2=3.14
cc_2761 ( N_noxref_7_c_3021_p N_SN_c_10111_n ) capacitor c=0.00932261f \
 //x=40.08 //y=2.375 //x2=41.19 //y2=2.375
cc_2762 ( N_noxref_7_c_3168_p N_SN_c_10111_n ) capacitor c=5.40058e-19 \
 //x=40.08 //y=2.26 //x2=41.19 //y2=2.375
cc_2763 ( N_noxref_7_c_3170_p N_SN_c_10111_n ) capacitor c=0.00142893f \
 //x=39.78 //y=2.095 //x2=41.19 //y2=2.375
cc_2764 ( N_noxref_7_c_2982_n N_SN_c_10114_n ) capacitor c=0.00694134f \
 //x=40.08 //y=4.755 //x2=41.19 //y2=3.285
cc_2765 ( N_noxref_7_c_2982_n N_SN_c_10068_n ) capacitor c=0.0406366f \
 //x=40.08 //y=4.755 //x2=41.19 //y2=4.765
cc_2766 ( N_noxref_7_c_3194_p N_SN_c_10068_n ) capacitor c=6.20857e-19 \
 //x=40.08 //y=4.88 //x2=41.19 //y2=4.765
cc_2767 ( N_noxref_7_c_2991_n N_SN_c_10068_n ) capacitor c=6.98043e-19 \
 //x=40.645 //y=4.97 //x2=41.19 //y2=4.765
cc_2768 ( N_noxref_7_c_2992_n N_SN_c_10068_n ) capacitor c=7.54501e-19 \
 //x=40.355 //y=4.97 //x2=41.19 //y2=4.765
cc_2769 ( N_noxref_7_c_3003_p N_SN_c_10119_n ) capacitor c=0.0014263f \
 //x=33.42 //y=2.945 //x2=32.905 //y2=3.13
cc_2770 ( N_noxref_7_c_2979_n N_SN_c_10119_n ) capacitor c=0.0011062f \
 //x=33.42 //y=5.25 //x2=32.905 //y2=3.13
cc_2771 ( N_noxref_7_c_3008_p N_SN_c_10119_n ) capacitor c=0.0358254f \
 //x=33.585 //y=2.785 //x2=32.905 //y2=3.13
cc_2772 ( N_noxref_7_c_3003_p N_SN_c_10122_n ) capacitor c=0.0101938f \
 //x=33.42 //y=2.945 //x2=33.64 //y2=3.17
cc_2773 ( N_noxref_7_c_2979_n N_SN_c_10122_n ) capacitor c=0.0223753f \
 //x=33.42 //y=5.25 //x2=33.64 //y2=3.17
cc_2774 ( N_noxref_7_c_2981_n N_SN_c_10122_n ) capacitor c=2.04398e-19 \
 //x=35.27 //y=4.755 //x2=33.64 //y2=3.17
cc_2775 ( N_noxref_7_c_3040_p N_SN_c_10122_n ) capacitor c=0.12763f //x=35.115 \
 //y=2.785 //x2=33.64 //y2=3.17
cc_2776 ( N_noxref_7_c_2979_n N_SN_c_10126_n ) capacitor c=2.02793e-19 \
 //x=33.42 //y=5.25 //x2=34.89 //y2=3.14
cc_2777 ( N_noxref_7_c_3105_p N_SN_c_10126_n ) capacitor c=0.00158626f \
 //x=35.27 //y=2.945 //x2=34.89 //y2=3.14
cc_2778 ( N_noxref_7_c_2981_n N_SN_c_10126_n ) capacitor c=0.00101371f \
 //x=35.27 //y=4.755 //x2=34.89 //y2=3.14
cc_2779 ( N_noxref_7_c_3040_p N_SN_c_10126_n ) capacitor c=0.0115746f \
 //x=35.115 //y=2.785 //x2=34.89 //y2=3.14
cc_2780 ( N_noxref_7_c_3108_p N_SN_c_10126_n ) capacitor c=0.0358254f \
 //x=35.435 //y=2.785 //x2=34.89 //y2=3.14
cc_2781 ( N_noxref_7_c_3105_p N_SN_c_10131_n ) capacitor c=0.00689807f \
 //x=35.27 //y=2.945 //x2=35.49 //y2=3.17
cc_2782 ( N_noxref_7_c_2981_n N_SN_c_10131_n ) capacitor c=0.0236429f \
 //x=35.27 //y=4.755 //x2=35.49 //y2=3.17
cc_2783 ( N_noxref_7_c_3026_p N_SN_c_10131_n ) capacitor c=0.2105f //x=39.92 \
 //y=2.785 //x2=35.49 //y2=3.17
cc_2784 ( N_noxref_7_c_3026_p N_SN_c_10134_n ) capacitor c=0.0588312f \
 //x=39.92 //y=2.785 //x2=37.845 //y2=3.14
cc_2785 ( N_noxref_7_c_2982_n N_SN_c_10135_n ) capacitor c=3.96979e-19 \
 //x=40.08 //y=4.755 //x2=38.445 //y2=3.11
cc_2786 ( N_noxref_7_c_3026_p N_SN_c_10135_n ) capacitor c=0.111846f //x=39.92 \
 //y=2.785 //x2=38.445 //y2=3.11
cc_2787 ( N_noxref_7_c_3023_p N_SN_c_10137_n ) capacitor c=0.00507903f \
 //x=40.08 //y=2.945 //x2=39.695 //y2=3.14
cc_2788 ( N_noxref_7_c_2982_n N_SN_c_10137_n ) capacitor c=9.36156e-19 \
 //x=40.08 //y=4.755 //x2=39.695 //y2=3.14
cc_2789 ( N_noxref_7_c_3025_p N_SN_c_10137_n ) capacitor c=0.0358254f \
 //x=40.08 //y=2.785 //x2=39.695 //y2=3.14
cc_2790 ( N_noxref_7_c_3026_p N_SN_c_10137_n ) capacitor c=0.0104657f \
 //x=39.92 //y=2.785 //x2=39.695 //y2=3.14
cc_2791 ( N_noxref_7_c_3023_p N_SN_c_10141_n ) capacitor c=0.00356749f \
 //x=40.08 //y=2.945 //x2=40.295 //y2=3.17
cc_2792 ( N_noxref_7_c_2982_n N_SN_c_10141_n ) capacitor c=0.0225908f \
 //x=40.08 //y=4.755 //x2=40.295 //y2=3.17
cc_2793 ( N_noxref_7_c_2982_n N_SN_c_10143_n ) capacitor c=0.0028832f \
 //x=40.08 //y=4.755 //x2=42.91 //y2=3.155
cc_2794 ( N_noxref_7_c_3021_p N_SN_c_10144_n ) capacitor c=5.39999e-19 \
 //x=40.08 //y=2.375 //x2=41.19 //y2=2.26
cc_2795 ( N_noxref_7_c_3022_p N_SN_c_10144_n ) capacitor c=3.9149e-19 \
 //x=40.08 //y=2.625 //x2=41.19 //y2=2.26
cc_2796 ( N_noxref_7_c_3168_p N_SN_c_10144_n ) capacitor c=0.00125213f \
 //x=40.08 //y=2.26 //x2=41.19 //y2=2.26
cc_2797 ( N_noxref_7_c_3170_p N_SN_c_10144_n ) capacitor c=0.00214573f \
 //x=39.78 //y=2.095 //x2=41.19 //y2=2.26
cc_2798 ( N_noxref_7_c_2982_n N_SN_c_10083_n ) capacitor c=8.93844e-19 \
 //x=40.08 //y=4.755 //x2=41.19 //y2=4.88
cc_2799 ( N_noxref_7_c_3194_p N_SN_c_10083_n ) capacitor c=0.00113984f \
 //x=40.08 //y=4.88 //x2=41.19 //y2=4.88
cc_2800 ( N_noxref_7_c_2991_n N_SN_c_10083_n ) capacitor c=0.00116563f \
 //x=40.645 //y=4.97 //x2=41.19 //y2=4.88
cc_2801 ( N_noxref_7_c_2992_n N_SN_c_10083_n ) capacitor c=0.00129812f \
 //x=40.355 //y=4.97 //x2=41.19 //y2=4.88
cc_2802 ( N_noxref_7_M109_noxref_g N_SN_M111_noxref_g ) capacitor c=0.0106276f \
 //x=40.28 //y=6.2 //x2=41.16 //y2=6.2
cc_2803 ( N_noxref_7_M110_noxref_g N_SN_M111_noxref_g ) capacitor c=0.107144f \
 //x=40.72 //y=6.2 //x2=41.16 //y2=6.2
cc_2804 ( N_noxref_7_M110_noxref_g N_SN_M112_noxref_g ) capacitor c=0.0101598f \
 //x=40.72 //y=6.2 //x2=41.6 //y2=6.2
cc_2805 ( N_noxref_7_c_3233_p N_SN_c_10155_n ) capacitor c=5.72528e-19 \
 //x=39.78 //y=1.055 //x2=40.755 //y2=1.09
cc_2806 ( N_noxref_7_c_3234_p N_SN_c_10155_n ) capacitor c=0.00150277f \
 //x=39.78 //y=1.4 //x2=40.755 //y2=1.09
cc_2807 ( N_noxref_7_c_3235_p N_SN_c_10155_n ) capacitor c=0.0160123f \
 //x=40.31 //y=1.055 //x2=40.755 //y2=1.09
cc_2808 ( N_noxref_7_c_3236_p N_SN_c_10158_n ) capacitor c=0.00111227f \
 //x=39.78 //y=1.71 //x2=40.755 //y2=1.4
cc_2809 ( N_noxref_7_c_3237_p N_SN_c_10158_n ) capacitor c=0.0124075f \
 //x=40.31 //y=1.4 //x2=40.755 //y2=1.4
cc_2810 ( N_noxref_7_c_3235_p N_SN_c_10160_n ) capacitor c=9.19165e-19 \
 //x=40.31 //y=1.055 //x2=41.28 //y2=1.09
cc_2811 ( N_noxref_7_c_3237_p N_SN_c_10161_n ) capacitor c=0.0010154f \
 //x=40.31 //y=1.4 //x2=41.28 //y2=1.4
cc_2812 ( N_noxref_7_c_3237_p N_SN_c_10162_n ) capacitor c=9.23422e-19 \
 //x=40.31 //y=1.4 //x2=41.28 //y2=1.63
cc_2813 ( N_noxref_7_c_3021_p N_SN_c_10163_n ) capacitor c=0.00136403f \
 //x=40.08 //y=2.375 //x2=41.28 //y2=2.095
cc_2814 ( N_noxref_7_c_3168_p N_SN_c_10163_n ) capacitor c=0.0020754f \
 //x=40.08 //y=2.26 //x2=41.28 //y2=2.095
cc_2815 ( N_noxref_7_c_3170_p N_SN_c_10163_n ) capacitor c=0.00964411f \
 //x=39.78 //y=2.095 //x2=41.28 //y2=2.095
cc_2816 ( N_noxref_7_c_2982_n N_SN_c_10166_n ) capacitor c=0.00108708f \
 //x=40.08 //y=4.755 //x2=41.19 //y2=4.88
cc_2817 ( N_noxref_7_c_3194_p N_SN_c_10166_n ) capacitor c=0.00155973f \
 //x=40.08 //y=4.88 //x2=41.19 //y2=4.88
cc_2818 ( N_noxref_7_c_2991_n N_SN_c_10166_n ) capacitor c=0.0171374f \
 //x=40.645 //y=4.97 //x2=41.19 //y2=4.88
cc_2819 ( N_noxref_7_c_2992_n N_SN_c_10166_n ) capacitor c=0.00484466f \
 //x=40.355 //y=4.97 //x2=41.19 //y2=4.88
cc_2820 ( N_noxref_7_c_3097_p N_VDD_c_13434_n ) capacitor c=0.00559514f \
 //x=31.64 //y=5.335 //x2=87.775 //y2=7.585
cc_2821 ( N_noxref_7_c_3051_p N_VDD_c_13434_n ) capacitor c=0.00564834f \
 //x=32.525 //y=5.335 //x2=87.775 //y2=7.585
cc_2822 ( N_noxref_7_c_3030_p N_VDD_c_13434_n ) capacitor c=0.00236065f \
 //x=32.64 //y=5.56 //x2=87.775 //y2=7.585
cc_2823 ( N_noxref_7_c_2977_n N_VDD_c_13434_n ) capacitor c=0.00753358f \
 //x=33.335 //y=5.335 //x2=87.775 //y2=7.585
cc_2824 ( N_noxref_7_c_2983_n N_VDD_c_13434_n ) capacitor c=0.00241373f \
 //x=30.882 //y=5.335 //x2=87.775 //y2=7.585
cc_2825 ( N_noxref_7_c_3148_p N_VDD_c_13434_n ) capacitor c=0.00249074f \
 //x=31.76 //y=5.335 //x2=87.775 //y2=7.585
cc_2826 ( N_noxref_7_c_3096_p N_VDD_c_13434_n ) capacitor c=0.0024232f \
 //x=30.88 //y=5.56 //x2=87.775 //y2=7.585
cc_2827 ( N_noxref_7_c_3151_p N_VDD_c_13434_n ) capacitor c=0.0024232f \
 //x=31.76 //y=5.56 //x2=87.775 //y2=7.585
cc_2828 ( N_noxref_7_c_3018_p N_VDD_c_13434_n ) capacitor c=0.0024232f \
 //x=32.64 //y=5.56 //x2=87.775 //y2=7.585
cc_2829 ( N_noxref_7_c_3097_p N_VDD_c_13844_n ) capacitor c=0.00202922f \
 //x=31.64 //y=5.335 //x2=31.235 //y2=7.585
cc_2830 ( N_noxref_7_c_2983_n N_VDD_c_13844_n ) capacitor c=9.3757e-19 \
 //x=30.882 //y=5.335 //x2=31.235 //y2=7.585
cc_2831 ( N_noxref_7_c_3096_p N_VDD_c_13844_n ) capacitor c=0.0138074f \
 //x=30.88 //y=5.56 //x2=31.235 //y2=7.585
cc_2832 ( N_noxref_7_c_3097_p N_VDD_c_13847_n ) capacitor c=0.0017708f \
 //x=31.64 //y=5.335 //x2=32.115 //y2=7.585
cc_2833 ( N_noxref_7_c_3051_p N_VDD_c_13847_n ) capacitor c=0.00202922f \
 //x=32.525 //y=5.335 //x2=32.115 //y2=7.585
cc_2834 ( N_noxref_7_c_3148_p N_VDD_c_13847_n ) capacitor c=9.4822e-19 \
 //x=31.76 //y=5.335 //x2=32.115 //y2=7.585
cc_2835 ( N_noxref_7_c_3151_p N_VDD_c_13847_n ) capacitor c=0.0138074f \
 //x=31.76 //y=5.56 //x2=32.115 //y2=7.585
cc_2836 ( N_noxref_7_c_3051_p N_VDD_c_13851_n ) capacitor c=0.00205906f \
 //x=32.525 //y=5.335 //x2=32.995 //y2=7.585
cc_2837 ( N_noxref_7_c_3030_p N_VDD_c_13851_n ) capacitor c=8.49654e-19 \
 //x=32.64 //y=5.56 //x2=32.995 //y2=7.585
cc_2838 ( N_noxref_7_c_2977_n N_VDD_c_13851_n ) capacitor c=0.00204238f \
 //x=33.335 //y=5.335 //x2=32.995 //y2=7.585
cc_2839 ( N_noxref_7_c_3018_p N_VDD_c_13851_n ) capacitor c=0.0129519f \
 //x=32.64 //y=5.56 //x2=32.995 //y2=7.585
cc_2840 ( N_noxref_7_c_2977_n N_VDD_c_13855_n ) capacitor c=0.00183742f \
 //x=33.335 //y=5.335 //x2=33.99 //y2=7.585
cc_2841 ( N_noxref_7_M103_noxref_g N_VDD_c_13856_n ) capacitor c=0.00755614f \
 //x=35.47 //y=6.2 //x2=36.045 //y2=7.585
cc_2842 ( N_noxref_7_M104_noxref_g N_VDD_c_13856_n ) capacitor c=0.00755544f \
 //x=35.91 //y=6.2 //x2=36.045 //y2=7.585
cc_2843 ( N_noxref_7_M109_noxref_g N_VDD_c_13858_n ) capacitor c=0.00755614f \
 //x=40.28 //y=6.2 //x2=40.855 //y2=7.585
cc_2844 ( N_noxref_7_M110_noxref_g N_VDD_c_13858_n ) capacitor c=0.00755544f \
 //x=40.72 //y=6.2 //x2=40.855 //y2=7.585
cc_2845 ( N_noxref_7_c_2983_n N_VDD_c_13694_n ) capacitor c=0.0022955f \
 //x=30.882 //y=5.335 //x2=29.35 //y2=7.585
cc_2846 ( N_noxref_7_c_3096_p N_VDD_c_13694_n ) capacitor c=0.00509469f \
 //x=30.88 //y=5.56 //x2=29.35 //y2=7.585
cc_2847 ( N_noxref_7_c_3030_p N_VDD_c_13773_n ) capacitor c=0.00282782f \
 //x=32.64 //y=5.56 //x2=34.16 //y2=7.585
cc_2848 ( N_noxref_7_c_2979_n N_VDD_c_13773_n ) capacitor c=0.0316131f \
 //x=33.42 //y=5.25 //x2=34.16 //y2=7.585
cc_2849 ( N_noxref_7_c_2981_n N_VDD_c_13773_n ) capacitor c=0.0109781f \
 //x=35.27 //y=4.755 //x2=34.16 //y2=7.585
cc_2850 ( N_noxref_7_c_3018_p N_VDD_c_13773_n ) capacitor c=0.00777981f \
 //x=32.64 //y=5.56 //x2=34.16 //y2=7.585
cc_2851 ( N_noxref_7_c_3115_p N_VDD_c_13773_n ) capacitor c=0.00354568f \
 //x=35.27 //y=4.88 //x2=34.16 //y2=7.585
cc_2852 ( N_noxref_7_c_3117_p N_VDD_c_13773_n ) capacitor c=0.00572368f \
 //x=35.545 //y=4.97 //x2=34.16 //y2=7.585
cc_2853 ( N_noxref_7_c_2982_n N_VDD_c_13775_n ) capacitor c=0.0106847f \
 //x=40.08 //y=4.755 //x2=38.97 //y2=7.585
cc_2854 ( N_noxref_7_c_3194_p N_VDD_c_13775_n ) capacitor c=0.00354568f \
 //x=40.08 //y=4.88 //x2=38.97 //y2=7.585
cc_2855 ( N_noxref_7_c_2992_n N_VDD_c_13775_n ) capacitor c=0.00572368f \
 //x=40.355 //y=4.97 //x2=38.97 //y2=7.585
cc_2856 ( N_noxref_7_c_2983_n N_VDD_M97_noxref_s ) capacitor c=0.0442713f \
 //x=30.882 //y=5.335 //x2=30.305 //y2=5.2
cc_2857 ( N_noxref_7_c_3148_p N_VDD_M97_noxref_s ) capacitor c=7.80122e-19 \
 //x=31.76 //y=5.335 //x2=30.305 //y2=5.2
cc_2858 ( N_noxref_7_c_3096_p N_VDD_M97_noxref_s ) capacitor c=0.09305f \
 //x=30.88 //y=5.56 //x2=30.305 //y2=5.2
cc_2859 ( N_noxref_7_c_3097_p N_VDD_M98_noxref_d ) capacitor c=0.00700141f \
 //x=31.64 //y=5.335 //x2=31.175 //y2=5.2
cc_2860 ( N_noxref_7_c_3096_p N_VDD_M98_noxref_d ) capacitor c=0.0674491f \
 //x=30.88 //y=5.56 //x2=31.175 //y2=5.2
cc_2861 ( N_noxref_7_c_3151_p N_VDD_M98_noxref_d ) capacitor c=0.0674762f \
 //x=31.76 //y=5.56 //x2=31.175 //y2=5.2
cc_2862 ( N_noxref_7_c_3051_p N_VDD_M100_noxref_d ) capacitor c=0.00700141f \
 //x=32.525 //y=5.335 //x2=32.055 //y2=5.2
cc_2863 ( N_noxref_7_c_3151_p N_VDD_M100_noxref_d ) capacitor c=0.067493f \
 //x=31.76 //y=5.56 //x2=32.055 //y2=5.2
cc_2864 ( N_noxref_7_c_3018_p N_VDD_M100_noxref_d ) capacitor c=0.0674979f \
 //x=32.64 //y=5.56 //x2=32.055 //y2=5.2
cc_2865 ( N_noxref_7_c_2977_n N_VDD_M102_noxref_d ) capacitor c=0.00700141f \
 //x=33.335 //y=5.335 //x2=32.935 //y2=5.2
cc_2866 ( N_noxref_7_c_3018_p N_VDD_M102_noxref_d ) capacitor c=0.0675002f \
 //x=32.64 //y=5.56 //x2=32.935 //y2=5.2
cc_2867 ( N_noxref_7_c_3030_p N_VDD_M103_noxref_s ) capacitor c=0.00492616f \
 //x=32.64 //y=5.56 //x2=35.115 //y2=5.2
cc_2868 ( N_noxref_7_c_2977_n N_VDD_M103_noxref_s ) capacitor c=9.42705e-19 \
 //x=33.335 //y=5.335 //x2=35.115 //y2=5.2
cc_2869 ( N_noxref_7_c_3105_p N_VDD_M103_noxref_s ) capacitor c=4.15021e-19 \
 //x=35.27 //y=2.945 //x2=35.115 //y2=5.2
cc_2870 ( N_noxref_7_c_2981_n N_VDD_M103_noxref_s ) capacitor c=0.0167311f \
 //x=35.27 //y=4.755 //x2=35.115 //y2=5.2
cc_2871 ( N_noxref_7_c_3148_p N_VDD_M103_noxref_s ) capacitor c=2.11884e-19 \
 //x=31.76 //y=5.335 //x2=35.115 //y2=5.2
cc_2872 ( N_noxref_7_c_3115_p N_VDD_M103_noxref_s ) capacitor c=0.00983846f \
 //x=35.27 //y=4.88 //x2=35.115 //y2=5.2
cc_2873 ( N_noxref_7_M103_noxref_g N_VDD_M103_noxref_s ) capacitor c=0.053419f \
 //x=35.47 //y=6.2 //x2=35.115 //y2=5.2
cc_2874 ( N_noxref_7_c_3117_p N_VDD_M103_noxref_s ) capacitor c=0.0060887f \
 //x=35.545 //y=4.97 //x2=35.115 //y2=5.2
cc_2875 ( N_noxref_7_M104_noxref_g N_VDD_M104_noxref_d ) capacitor c=0.015318f \
 //x=35.91 //y=6.2 //x2=35.985 //y2=5.2
cc_2876 ( N_noxref_7_c_3023_p N_VDD_M109_noxref_s ) capacitor c=4.15021e-19 \
 //x=40.08 //y=2.945 //x2=39.925 //y2=5.2
cc_2877 ( N_noxref_7_c_2982_n N_VDD_M109_noxref_s ) capacitor c=0.0167311f \
 //x=40.08 //y=4.755 //x2=39.925 //y2=5.2
cc_2878 ( N_noxref_7_c_3194_p N_VDD_M109_noxref_s ) capacitor c=0.00983846f \
 //x=40.08 //y=4.88 //x2=39.925 //y2=5.2
cc_2879 ( N_noxref_7_M109_noxref_g N_VDD_M109_noxref_s ) capacitor c=0.053419f \
 //x=40.28 //y=6.2 //x2=39.925 //y2=5.2
cc_2880 ( N_noxref_7_c_2992_n N_VDD_M109_noxref_s ) capacitor c=0.0060887f \
 //x=40.355 //y=4.97 //x2=39.925 //y2=5.2
cc_2881 ( N_noxref_7_M110_noxref_g N_VDD_M110_noxref_d ) capacitor c=0.015318f \
 //x=40.72 //y=6.2 //x2=40.795 //y2=5.2
cc_2882 ( N_noxref_7_c_3010_p N_noxref_32_c_15287_n ) capacitor c=0.0036878f \
 //x=32.935 //y=1.305 //x2=33.335 //y2=0.72
cc_2883 ( N_noxref_7_c_3020_p N_noxref_32_c_15287_n ) capacitor c=0.00399931f \
 //x=33.335 //y=1.845 //x2=33.335 //y2=0.72
cc_2884 ( N_noxref_7_M20_noxref_d N_noxref_32_c_15287_n ) capacitor \
 c=0.00910163f //x=32.745 //y=1.095 //x2=33.335 //y2=0.72
cc_2885 ( N_noxref_7_M20_noxref_d N_noxref_32_c_15290_n ) capacitor \
 c=0.00120711f //x=32.745 //y=1.095 //x2=32.45 //y2=1.175
cc_2886 ( N_noxref_7_c_3097_p N_noxref_32_M19_noxref_d ) capacitor \
 c=0.00125893f //x=31.64 //y=5.335 //x2=31.21 //y2=1.09
cc_2887 ( N_noxref_7_c_3010_p N_noxref_32_M19_noxref_d ) capacitor \
 c=0.00802417f //x=32.935 //y=1.305 //x2=31.21 //y2=1.09
cc_2888 ( N_noxref_7_c_3010_p N_noxref_32_M20_noxref_s ) capacitor \
 c=0.0098487f //x=32.935 //y=1.305 //x2=32.315 //y2=0.555
cc_2889 ( N_noxref_7_c_3060_p N_noxref_32_M20_noxref_s ) capacitor \
 c=0.0283243f //x=32.935 //y=1.76 //x2=32.315 //y2=0.555
cc_2890 ( N_noxref_7_c_3020_p N_noxref_32_M20_noxref_s ) capacitor \
 c=0.00752108f //x=33.335 //y=1.845 //x2=32.315 //y2=0.555
cc_2891 ( N_noxref_7_c_3007_p N_noxref_32_M20_noxref_s ) capacitor \
 c=0.00309975f //x=33.42 //y=2.77 //x2=32.315 //y2=0.555
cc_2892 ( N_noxref_7_M20_noxref_d N_noxref_32_M20_noxref_s ) capacitor \
 c=0.0279003f //x=32.745 //y=1.095 //x2=32.315 //y2=0.555
cc_2893 ( N_noxref_7_c_3010_p N_noxref_33_M22_noxref_d ) capacitor \
 c=3.20746e-19 //x=32.935 //y=1.305 //x2=36.02 //y2=1.09
cc_2894 ( N_noxref_7_c_3010_p N_GND_c_16658_n ) capacitor c=0.00884249f \
 //x=32.935 //y=1.305 //x2=35.15 //y2=0.175
cc_2895 ( N_noxref_7_c_3020_p N_GND_c_16658_n ) capacitor c=0.00662992f \
 //x=33.335 //y=1.845 //x2=35.15 //y2=0.175
cc_2896 ( N_noxref_7_c_3003_p N_GND_c_16658_n ) capacitor c=4.3138e-19 \
 //x=33.42 //y=2.945 //x2=35.15 //y2=0.175
cc_2897 ( N_noxref_7_M20_noxref_d N_GND_c_16658_n ) capacitor c=2.9462e-19 \
 //x=32.745 //y=1.095 //x2=35.15 //y2=0.175
cc_2898 ( N_noxref_7_c_3132_p N_GND_c_16662_n ) capacitor c=3.97665e-19 \
 //x=34.97 //y=1.055 //x2=35.235 //y2=1.015
cc_2899 ( N_noxref_7_c_3327_p N_GND_c_16662_n ) capacitor c=0.00864776f \
 //x=35.345 //y=0.9 //x2=35.235 //y2=1.015
cc_2900 ( N_noxref_7_c_3134_p N_GND_c_16662_n ) capacitor c=4.45447e-19 \
 //x=35.5 //y=1.055 //x2=35.235 //y2=1.015
cc_2901 ( N_noxref_7_c_3233_p N_GND_c_16665_n ) capacitor c=3.97665e-19 \
 //x=39.78 //y=1.055 //x2=40.045 //y2=1.015
cc_2902 ( N_noxref_7_c_3330_p N_GND_c_16665_n ) capacitor c=0.00864776f \
 //x=40.155 //y=0.9 //x2=40.045 //y2=1.015
cc_2903 ( N_noxref_7_c_3235_p N_GND_c_16665_n ) capacitor c=4.45447e-19 \
 //x=40.31 //y=1.055 //x2=40.045 //y2=1.015
cc_2904 ( N_noxref_7_c_3010_p N_GND_c_16668_n ) capacitor c=0.00543195f \
 //x=32.935 //y=1.305 //x2=35.235 //y2=1.145
cc_2905 ( N_noxref_7_c_3111_p N_GND_c_16668_n ) capacitor c=0.00772482f \
 //x=35.27 //y=2.375 //x2=35.235 //y2=1.145
cc_2906 ( N_noxref_7_c_3105_p N_GND_c_16668_n ) capacitor c=9.18427e-19 \
 //x=35.27 //y=2.945 //x2=35.235 //y2=1.145
cc_2907 ( N_noxref_7_c_3110_p N_GND_c_16668_n ) capacitor c=2.22883e-19 \
 //x=35.27 //y=2.26 //x2=35.235 //y2=1.145
cc_2908 ( N_noxref_7_c_3132_p N_GND_c_16668_n ) capacitor c=0.00156339f \
 //x=34.97 //y=1.055 //x2=35.235 //y2=1.145
cc_2909 ( N_noxref_7_c_3133_p N_GND_c_16668_n ) capacitor c=0.00352472f \
 //x=34.97 //y=1.4 //x2=35.235 //y2=1.145
cc_2910 ( N_noxref_7_c_3135_p N_GND_c_16668_n ) capacitor c=4.35713e-19 \
 //x=34.97 //y=1.71 //x2=35.235 //y2=1.145
cc_2911 ( N_noxref_7_c_3327_p N_GND_c_16668_n ) capacitor c=9.36995e-19 \
 //x=35.345 //y=0.9 //x2=35.235 //y2=1.145
cc_2912 ( N_noxref_7_c_3340_p N_GND_c_16668_n ) capacitor c=5.29132e-19 \
 //x=35.345 //y=1.555 //x2=35.235 //y2=1.145
cc_2913 ( N_noxref_7_c_3134_p N_GND_c_16668_n ) capacitor c=0.0017438f \
 //x=35.5 //y=1.055 //x2=35.235 //y2=1.145
cc_2914 ( N_noxref_7_c_3136_p N_GND_c_16668_n ) capacitor c=0.00276804f \
 //x=35.5 //y=1.4 //x2=35.235 //y2=1.145
cc_2915 ( N_noxref_7_c_3021_p N_GND_c_16679_n ) capacitor c=0.00772482f \
 //x=40.08 //y=2.375 //x2=40.045 //y2=1.145
cc_2916 ( N_noxref_7_c_3023_p N_GND_c_16679_n ) capacitor c=0.00117625f \
 //x=40.08 //y=2.945 //x2=40.045 //y2=1.145
cc_2917 ( N_noxref_7_c_3168_p N_GND_c_16679_n ) capacitor c=2.22883e-19 \
 //x=40.08 //y=2.26 //x2=40.045 //y2=1.145
cc_2918 ( N_noxref_7_c_3233_p N_GND_c_16679_n ) capacitor c=0.00156339f \
 //x=39.78 //y=1.055 //x2=40.045 //y2=1.145
cc_2919 ( N_noxref_7_c_3234_p N_GND_c_16679_n ) capacitor c=0.00352472f \
 //x=39.78 //y=1.4 //x2=40.045 //y2=1.145
cc_2920 ( N_noxref_7_c_3236_p N_GND_c_16679_n ) capacitor c=3.86356e-19 \
 //x=39.78 //y=1.71 //x2=40.045 //y2=1.145
cc_2921 ( N_noxref_7_c_3330_p N_GND_c_16679_n ) capacitor c=9.36995e-19 \
 //x=40.155 //y=0.9 //x2=40.045 //y2=1.145
cc_2922 ( N_noxref_7_c_3350_p N_GND_c_16679_n ) capacitor c=5.29132e-19 \
 //x=40.155 //y=1.555 //x2=40.045 //y2=1.145
cc_2923 ( N_noxref_7_c_3235_p N_GND_c_16679_n ) capacitor c=0.0017438f \
 //x=40.31 //y=1.055 //x2=40.045 //y2=1.145
cc_2924 ( N_noxref_7_c_3237_p N_GND_c_16679_n ) capacitor c=0.00276804f \
 //x=40.31 //y=1.4 //x2=40.045 //y2=1.145
cc_2925 ( N_noxref_7_c_3020_p N_GND_c_16689_n ) capacitor c=6.86343e-19 \
 //x=33.335 //y=1.845 //x2=33.99 //y2=0.175
cc_2926 ( N_noxref_7_c_3003_p N_GND_c_16689_n ) capacitor c=6.00694e-19 \
 //x=33.42 //y=2.945 //x2=33.99 //y2=0.175
cc_2927 ( N_noxref_7_c_3132_p N_GND_c_16691_n ) capacitor c=0.00677932f \
 //x=34.97 //y=1.055 //x2=38.8 //y2=0.175
cc_2928 ( N_noxref_7_c_3233_p N_GND_c_16692_n ) capacitor c=0.00677849f \
 //x=39.78 //y=1.055 //x2=43.61 //y2=0.175
cc_2929 ( N_noxref_7_c_3060_p N_GND_c_16693_n ) capacitor c=0.0045138f \
 //x=32.935 //y=1.76 //x2=34.16 //y2=0.175
cc_2930 ( N_noxref_7_c_3020_p N_GND_c_16693_n ) capacitor c=0.0229887f \
 //x=33.335 //y=1.845 //x2=34.16 //y2=0.175
cc_2931 ( N_noxref_7_c_3001_p N_GND_c_16693_n ) capacitor c=2.00878e-19 \
 //x=33.42 //y=2.625 //x2=34.16 //y2=0.175
cc_2932 ( N_noxref_7_c_3003_p N_GND_c_16693_n ) capacitor c=0.00411109f \
 //x=33.42 //y=2.945 //x2=34.16 //y2=0.175
cc_2933 ( N_noxref_7_c_3111_p N_GND_c_16693_n ) capacitor c=0.00343139f \
 //x=35.27 //y=2.375 //x2=34.16 //y2=0.175
cc_2934 ( N_noxref_7_c_3005_p N_GND_c_16693_n ) capacitor c=0.00401621f \
 //x=35.27 //y=2.625 //x2=34.16 //y2=0.175
cc_2935 ( N_noxref_7_c_3105_p N_GND_c_16693_n ) capacitor c=0.00256181f \
 //x=35.27 //y=2.945 //x2=34.16 //y2=0.175
cc_2936 ( N_noxref_7_c_3007_p N_GND_c_16693_n ) capacitor c=0.0104119f \
 //x=33.42 //y=2.77 //x2=34.16 //y2=0.175
cc_2937 ( N_noxref_7_c_3107_p N_GND_c_16693_n ) capacitor c=0.00527261f \
 //x=35.27 //y=2.77 //x2=34.16 //y2=0.175
cc_2938 ( N_noxref_7_c_3040_p N_GND_c_16693_n ) capacitor c=0.00947774f \
 //x=35.115 //y=2.785 //x2=34.16 //y2=0.175
cc_2939 ( N_noxref_7_c_3110_p N_GND_c_16693_n ) capacitor c=0.0039621f \
 //x=35.27 //y=2.26 //x2=34.16 //y2=0.175
cc_2940 ( N_noxref_7_c_3135_p N_GND_c_16693_n ) capacitor c=0.00170145f \
 //x=34.97 //y=1.71 //x2=34.16 //y2=0.175
cc_2941 ( N_noxref_7_c_3113_p N_GND_c_16693_n ) capacitor c=0.0102191f \
 //x=34.97 //y=2.095 //x2=34.16 //y2=0.175
cc_2942 ( N_noxref_7_c_3021_p N_GND_c_16706_n ) capacitor c=0.00343139f \
 //x=40.08 //y=2.375 //x2=38.97 //y2=0.175
cc_2943 ( N_noxref_7_c_3022_p N_GND_c_16706_n ) capacitor c=0.00401621f \
 //x=40.08 //y=2.625 //x2=38.97 //y2=0.175
cc_2944 ( N_noxref_7_c_3023_p N_GND_c_16706_n ) capacitor c=0.0030172f \
 //x=40.08 //y=2.945 //x2=38.97 //y2=0.175
cc_2945 ( N_noxref_7_c_2997_p N_GND_c_16706_n ) capacitor c=0.00528783f \
 //x=40.08 //y=2.77 //x2=38.97 //y2=0.175
cc_2946 ( N_noxref_7_c_3026_p N_GND_c_16706_n ) capacitor c=0.0118327f \
 //x=39.92 //y=2.785 //x2=38.97 //y2=0.175
cc_2947 ( N_noxref_7_c_3168_p N_GND_c_16706_n ) capacitor c=0.0039621f \
 //x=40.08 //y=2.26 //x2=38.97 //y2=0.175
cc_2948 ( N_noxref_7_c_3236_p N_GND_c_16706_n ) capacitor c=0.00170145f \
 //x=39.78 //y=1.71 //x2=38.97 //y2=0.175
cc_2949 ( N_noxref_7_c_3170_p N_GND_c_16706_n ) capacitor c=0.0102191f \
 //x=39.78 //y=2.095 //x2=38.97 //y2=0.175
cc_2950 ( N_noxref_7_c_3111_p N_GND_M21_noxref_d ) capacitor c=4.4417e-19 \
 //x=35.27 //y=2.375 //x2=35.045 //y2=1.055
cc_2951 ( N_noxref_7_c_3132_p N_GND_M21_noxref_d ) capacitor c=0.00184354f \
 //x=34.97 //y=1.055 //x2=35.045 //y2=1.055
cc_2952 ( N_noxref_7_c_3133_p N_GND_M21_noxref_d ) capacitor c=0.00210798f \
 //x=34.97 //y=1.4 //x2=35.045 //y2=1.055
cc_2953 ( N_noxref_7_c_3327_p N_GND_M21_noxref_d ) capacitor c=0.00474029f \
 //x=35.345 //y=0.9 //x2=35.045 //y2=1.055
cc_2954 ( N_noxref_7_c_3340_p N_GND_M21_noxref_d ) capacitor c=0.00166857f \
 //x=35.345 //y=1.555 //x2=35.045 //y2=1.055
cc_2955 ( N_noxref_7_c_3134_p N_GND_M21_noxref_d ) capacitor c=0.00230174f \
 //x=35.5 //y=1.055 //x2=35.045 //y2=1.055
cc_2956 ( N_noxref_7_c_3136_p N_GND_M21_noxref_d ) capacitor c=0.00210798f \
 //x=35.5 //y=1.4 //x2=35.045 //y2=1.055
cc_2957 ( N_noxref_7_c_3021_p N_GND_M24_noxref_d ) capacitor c=4.4417e-19 \
 //x=40.08 //y=2.375 //x2=39.855 //y2=1.055
cc_2958 ( N_noxref_7_c_3233_p N_GND_M24_noxref_d ) capacitor c=0.00184354f \
 //x=39.78 //y=1.055 //x2=39.855 //y2=1.055
cc_2959 ( N_noxref_7_c_3234_p N_GND_M24_noxref_d ) capacitor c=0.00210798f \
 //x=39.78 //y=1.4 //x2=39.855 //y2=1.055
cc_2960 ( N_noxref_7_c_3330_p N_GND_M24_noxref_d ) capacitor c=0.00474029f \
 //x=40.155 //y=0.9 //x2=39.855 //y2=1.055
cc_2961 ( N_noxref_7_c_3350_p N_GND_M24_noxref_d ) capacitor c=0.00166857f \
 //x=40.155 //y=1.555 //x2=39.855 //y2=1.055
cc_2962 ( N_noxref_7_c_3235_p N_GND_M24_noxref_d ) capacitor c=0.00230174f \
 //x=40.31 //y=1.055 //x2=39.855 //y2=1.055
cc_2963 ( N_noxref_7_c_3237_p N_GND_M24_noxref_d ) capacitor c=0.00210798f \
 //x=40.31 //y=1.4 //x2=39.855 //y2=1.055
cc_2964 ( N_noxref_7_c_3113_p N_noxref_54_c_18537_n ) capacitor c=0.00262672f \
 //x=34.97 //y=2.095 //x2=34.75 //y2=1.685
cc_2965 ( N_noxref_7_c_3111_p N_noxref_54_c_18538_n ) capacitor c=0.00428451f \
 //x=35.27 //y=2.375 //x2=35.635 //y2=1.77
cc_2966 ( N_noxref_7_c_3105_p N_noxref_54_c_18538_n ) capacitor c=0.00361907f \
 //x=35.27 //y=2.945 //x2=35.635 //y2=1.77
cc_2967 ( N_noxref_7_c_3110_p N_noxref_54_c_18538_n ) capacitor c=0.0104666f \
 //x=35.27 //y=2.26 //x2=35.635 //y2=1.77
cc_2968 ( N_noxref_7_c_3135_p N_noxref_54_c_18538_n ) capacitor c=0.00705077f \
 //x=34.97 //y=1.71 //x2=35.635 //y2=1.77
cc_2969 ( N_noxref_7_c_3113_p N_noxref_54_c_18538_n ) capacitor c=0.0204935f \
 //x=34.97 //y=2.095 //x2=35.635 //y2=1.77
cc_2970 ( N_noxref_7_c_3340_p N_noxref_54_c_18538_n ) capacitor c=0.00588627f \
 //x=35.345 //y=1.555 //x2=35.635 //y2=1.77
cc_2971 ( N_noxref_7_c_3136_p N_noxref_54_c_18538_n ) capacitor c=0.00698822f \
 //x=35.5 //y=1.4 //x2=35.635 //y2=1.77
cc_2972 ( N_noxref_7_c_3132_p N_noxref_54_M21_noxref_s ) capacitor \
 c=0.0295256f //x=34.97 //y=1.055 //x2=34.615 //y2=0.555
cc_2973 ( N_noxref_7_c_3135_p N_noxref_54_M21_noxref_s ) capacitor \
 c=7.99997e-19 //x=34.97 //y=1.71 //x2=34.615 //y2=0.555
cc_2974 ( N_noxref_7_c_3113_p N_noxref_54_M21_noxref_s ) capacitor \
 c=0.00122123f //x=34.97 //y=2.095 //x2=34.615 //y2=0.555
cc_2975 ( N_noxref_7_c_3134_p N_noxref_54_M21_noxref_s ) capacitor \
 c=0.0125924f //x=35.5 //y=1.055 //x2=34.615 //y2=0.555
cc_2976 ( N_noxref_7_c_3170_p N_noxref_55_c_18594_n ) capacitor c=0.00262672f \
 //x=39.78 //y=2.095 //x2=39.56 //y2=1.685
cc_2977 ( N_noxref_7_c_3021_p N_noxref_55_c_18595_n ) capacitor c=0.00428451f \
 //x=40.08 //y=2.375 //x2=40.445 //y2=1.77
cc_2978 ( N_noxref_7_c_3023_p N_noxref_55_c_18595_n ) capacitor c=0.00447635f \
 //x=40.08 //y=2.945 //x2=40.445 //y2=1.77
cc_2979 ( N_noxref_7_c_3168_p N_noxref_55_c_18595_n ) capacitor c=0.0104666f \
 //x=40.08 //y=2.26 //x2=40.445 //y2=1.77
cc_2980 ( N_noxref_7_c_3236_p N_noxref_55_c_18595_n ) capacitor c=0.00705077f \
 //x=39.78 //y=1.71 //x2=40.445 //y2=1.77
cc_2981 ( N_noxref_7_c_3170_p N_noxref_55_c_18595_n ) capacitor c=0.0197834f \
 //x=39.78 //y=2.095 //x2=40.445 //y2=1.77
cc_2982 ( N_noxref_7_c_3350_p N_noxref_55_c_18595_n ) capacitor c=0.00588627f \
 //x=40.155 //y=1.555 //x2=40.445 //y2=1.77
cc_2983 ( N_noxref_7_c_3237_p N_noxref_55_c_18595_n ) capacitor c=0.00698822f \
 //x=40.31 //y=1.4 //x2=40.445 //y2=1.77
cc_2984 ( N_noxref_7_c_3233_p N_noxref_55_M24_noxref_s ) capacitor \
 c=0.0295256f //x=39.78 //y=1.055 //x2=39.425 //y2=0.555
cc_2985 ( N_noxref_7_c_3236_p N_noxref_55_M24_noxref_s ) capacitor \
 c=7.99997e-19 //x=39.78 //y=1.71 //x2=39.425 //y2=0.555
cc_2986 ( N_noxref_7_c_3170_p N_noxref_55_M24_noxref_s ) capacitor \
 c=0.00122123f //x=39.78 //y=2.095 //x2=39.425 //y2=0.555
cc_2987 ( N_noxref_7_c_3235_p N_noxref_55_M24_noxref_s ) capacitor \
 c=0.0125924f //x=40.31 //y=1.055 //x2=39.425 //y2=0.555
cc_2988 ( N_noxref_8_c_3420_n N_noxref_9_c_3814_n ) capacitor c=6.09703e-19 \
 //x=40.502 //y=5.335 //x2=37.45 //y2=5.56
cc_2989 ( N_noxref_8_c_3420_n N_noxref_9_c_3815_n ) capacitor c=0.00306432f \
 //x=40.502 //y=5.335 //x2=38.145 //y2=5.335
cc_2990 ( N_noxref_8_c_3435_p N_noxref_9_c_3816_n ) capacitor c=0.00163399f \
 //x=42.64 //y=1.845 //x2=38.145 //y2=1.845
cc_2991 ( N_noxref_8_c_3417_n N_noxref_9_c_3768_n ) capacitor c=0.0232184f \
 //x=43.04 //y=5.25 //x2=49.535 //y2=3.51
cc_2992 ( N_noxref_8_c_3419_n N_noxref_9_c_3768_n ) capacitor c=0.0246617f \
 //x=44.89 //y=4.755 //x2=49.535 //y2=3.51
cc_2993 ( N_noxref_8_c_3438_p N_noxref_9_c_3768_n ) capacitor c=0.008565f \
 //x=44.74 //y=2.77 //x2=49.535 //y2=3.51
cc_2994 ( N_noxref_8_c_3439_p N_noxref_11_c_4532_n ) capacitor c=0.013767f \
 //x=43.04 //y=2.61 //x2=42.3 //y2=2.375
cc_2995 ( N_noxref_8_c_3439_p N_noxref_11_c_4528_n ) capacitor c=0.0086632f \
 //x=43.04 //y=2.61 //x2=42.3 //y2=3.735
cc_2996 ( N_noxref_8_c_3441_p N_noxref_11_c_4528_n ) capacitor c=0.0148501f \
 //x=43.04 //y=2.93 //x2=42.3 //y2=3.735
cc_2997 ( N_noxref_8_c_3417_n N_noxref_11_c_4528_n ) capacitor c=0.0317529f \
 //x=43.04 //y=5.25 //x2=42.3 //y2=3.735
cc_2998 ( N_noxref_8_c_3443_p N_noxref_11_c_4528_n ) capacitor c=4.40369e-19 \
 //x=44.89 //y=2.61 //x2=42.3 //y2=3.735
cc_2999 ( N_noxref_8_c_3419_n N_noxref_11_c_4528_n ) capacitor c=5.12503e-19 \
 //x=44.89 //y=4.755 //x2=42.3 //y2=3.735
cc_3000 ( N_noxref_8_c_3429_n N_noxref_11_c_4528_n ) capacitor c=5.64873e-19 \
 //x=43.04 //y=2.77 //x2=42.3 //y2=3.735
cc_3001 ( N_noxref_8_c_3446_p N_noxref_11_c_4528_n ) capacitor c=0.00687494f \
 //x=43.2 //y=2.77 //x2=42.3 //y2=3.735
cc_3002 ( N_noxref_8_c_3447_p N_noxref_11_c_4540_n ) capacitor c=0.0015317f \
 //x=42.145 //y=5.335 //x2=42.3 //y2=4.055
cc_3003 ( N_noxref_8_c_3416_n N_noxref_11_c_4540_n ) capacitor c=3.5029e-19 \
 //x=42.955 //y=5.335 //x2=42.3 //y2=4.055
cc_3004 ( N_noxref_8_c_3417_n N_noxref_11_c_4540_n ) capacitor c=0.0148932f \
 //x=43.04 //y=5.25 //x2=42.3 //y2=4.055
cc_3005 ( N_noxref_8_c_3416_n N_noxref_11_c_4500_n ) capacitor c=0.00198098f \
 //x=42.955 //y=5.335 //x2=42.3 //y2=4.75
cc_3006 ( N_noxref_8_c_3417_n N_noxref_11_c_4500_n ) capacitor c=0.0392398f \
 //x=43.04 //y=5.25 //x2=42.3 //y2=4.75
cc_3007 ( N_noxref_8_c_3419_n N_noxref_11_c_4500_n ) capacitor c=8.91555e-19 \
 //x=44.89 //y=4.755 //x2=42.3 //y2=4.75
cc_3008 ( N_noxref_8_c_3453_p N_noxref_11_c_4500_n ) capacitor c=0.018645f \
 //x=42.26 //y=5.335 //x2=42.3 //y2=4.75
cc_3009 ( N_noxref_8_c_3454_p N_noxref_11_c_4500_n ) capacitor c=0.00217979f \
 //x=42.26 //y=5.56 //x2=42.3 //y2=4.75
cc_3010 ( N_noxref_8_M116_noxref_g N_noxref_11_c_4501_n ) capacitor \
 c=0.00890386f //x=45.53 //y=6.2 //x2=46.07 //y2=5.335
cc_3011 ( N_noxref_8_c_3456_p N_noxref_11_c_4549_n ) capacitor c=0.00163399f \
 //x=42.955 //y=1.845 //x2=47.45 //y2=1.845
cc_3012 ( N_noxref_8_c_3417_n N_noxref_11_c_4550_n ) capacitor c=9.19401e-19 \
 //x=43.04 //y=5.25 //x2=42.3 //y2=3.88
cc_3013 ( N_noxref_8_c_3458_p N_noxref_11_c_4509_n ) capacitor c=6.09703e-19 \
 //x=42.26 //y=5.56 //x2=45.312 //y2=5.335
cc_3014 ( N_noxref_8_c_3416_n N_noxref_11_c_4509_n ) capacitor c=0.00300968f \
 //x=42.955 //y=5.335 //x2=45.312 //y2=5.335
cc_3015 ( N_noxref_8_M115_noxref_g N_noxref_11_c_4509_n ) capacitor \
 c=0.00461408f //x=45.09 //y=6.2 //x2=45.312 //y2=5.335
cc_3016 ( N_noxref_8_M116_noxref_g N_noxref_11_c_4509_n ) capacitor \
 c=0.00229208f //x=45.53 //y=6.2 //x2=45.312 //y2=5.335
cc_3017 ( N_noxref_8_c_3423_n N_noxref_11_c_4509_n ) capacitor c=0.00189519f \
 //x=45.455 //y=4.97 //x2=45.312 //y2=5.335
cc_3018 ( N_noxref_8_c_3417_n N_noxref_11_c_4556_n ) capacitor c=0.0229483f \
 //x=43.04 //y=5.25 //x2=47.68 //y2=3.88
cc_3019 ( N_noxref_8_c_3419_n N_noxref_11_c_4556_n ) capacitor c=0.024803f \
 //x=44.89 //y=4.755 //x2=47.68 //y2=3.88
cc_3020 ( N_noxref_8_c_3417_n N_noxref_11_c_4558_n ) capacitor c=0.00336755f \
 //x=43.04 //y=5.25 //x2=42.46 //y2=3.895
cc_3021 ( N_noxref_8_c_3439_p N_noxref_11_c_4559_n ) capacitor c=0.0015536f \
 //x=43.04 //y=2.61 //x2=42.3 //y2=2.26
cc_3022 ( N_noxref_8_c_3416_n N_noxref_11_c_4560_n ) capacitor c=0.00130631f \
 //x=42.955 //y=5.335 //x2=42.3 //y2=4.88
cc_3023 ( N_noxref_8_c_3417_n N_noxref_11_c_4560_n ) capacitor c=0.00126408f \
 //x=43.04 //y=5.25 //x2=42.3 //y2=4.88
cc_3024 ( N_noxref_8_c_3453_p N_noxref_11_c_4560_n ) capacitor c=0.00346456f \
 //x=42.26 //y=5.335 //x2=42.3 //y2=4.88
cc_3025 ( N_noxref_8_c_3454_p N_noxref_11_c_4560_n ) capacitor c=0.00624059f \
 //x=42.26 //y=5.56 //x2=42.3 //y2=4.88
cc_3026 ( N_noxref_8_M115_noxref_g N_noxref_11_c_4564_n ) capacitor \
 c=0.0162284f //x=45.09 //y=6.2 //x2=45.31 //y2=5.56
cc_3027 ( N_noxref_8_M116_noxref_g N_noxref_11_c_4564_n ) capacitor \
 c=0.0179041f //x=45.53 //y=6.2 //x2=45.31 //y2=5.56
cc_3028 ( N_noxref_8_c_3423_n N_noxref_11_c_4564_n ) capacitor c=0.00291477f \
 //x=45.455 //y=4.97 //x2=45.31 //y2=5.56
cc_3029 ( N_noxref_8_c_3447_p N_noxref_11_M113_noxref_g ) capacitor \
 c=0.00895456f //x=42.145 //y=5.335 //x2=42.04 //y2=6.2
cc_3030 ( N_noxref_8_c_3458_p N_noxref_11_M113_noxref_g ) capacitor \
 c=0.00226521f //x=42.26 //y=5.56 //x2=42.04 //y2=6.2
cc_3031 ( N_noxref_8_c_3454_p N_noxref_11_M113_noxref_g ) capacitor \
 c=0.0178885f //x=42.26 //y=5.56 //x2=42.04 //y2=6.2
cc_3032 ( N_noxref_8_c_3458_p N_noxref_11_M114_noxref_g ) capacitor \
 c=0.00381703f //x=42.26 //y=5.56 //x2=42.48 //y2=6.2
cc_3033 ( N_noxref_8_c_3416_n N_noxref_11_M114_noxref_g ) capacitor \
 c=0.0103821f //x=42.955 //y=5.335 //x2=42.48 //y2=6.2
cc_3034 ( N_noxref_8_c_3454_p N_noxref_11_M114_noxref_g ) capacitor \
 c=0.0188608f //x=42.26 //y=5.56 //x2=42.48 //y2=6.2
cc_3035 ( N_noxref_8_c_3480_p N_noxref_11_c_4573_n ) capacitor c=4.64015e-19 \
 //x=42.555 //y=1.305 //x2=42.29 //y2=1.095
cc_3036 ( N_noxref_8_M26_noxref_d N_noxref_11_c_4573_n ) capacitor \
 c=0.00137165f //x=42.365 //y=1.095 //x2=42.29 //y2=1.095
cc_3037 ( N_noxref_8_c_3480_p N_noxref_11_c_4575_n ) capacitor c=0.0026012f \
 //x=42.555 //y=1.305 //x2=42.29 //y2=1.44
cc_3038 ( N_noxref_8_c_3483_p N_noxref_11_c_4575_n ) capacitor c=0.00127432f \
 //x=42.555 //y=1.76 //x2=42.29 //y2=1.44
cc_3039 ( N_noxref_8_M26_noxref_d N_noxref_11_c_4575_n ) capacitor \
 c=0.00237422f //x=42.365 //y=1.095 //x2=42.29 //y2=1.44
cc_3040 ( N_noxref_8_c_3483_p N_noxref_11_c_4578_n ) capacitor c=0.00429966f \
 //x=42.555 //y=1.76 //x2=42.29 //y2=1.75
cc_3041 ( N_noxref_8_c_3480_p N_noxref_11_c_4579_n ) capacitor c=5.29969e-19 \
 //x=42.555 //y=1.305 //x2=42.665 //y2=0.94
cc_3042 ( N_noxref_8_M26_noxref_d N_noxref_11_c_4579_n ) capacitor \
 c=0.0020782f //x=42.365 //y=1.095 //x2=42.665 //y2=0.94
cc_3043 ( N_noxref_8_c_3480_p N_noxref_11_c_4581_n ) capacitor c=5.32228e-19 \
 //x=42.555 //y=1.305 //x2=42.665 //y2=1.595
cc_3044 ( N_noxref_8_c_3483_p N_noxref_11_c_4581_n ) capacitor c=0.00942306f \
 //x=42.555 //y=1.76 //x2=42.665 //y2=1.595
cc_3045 ( N_noxref_8_c_3456_p N_noxref_11_c_4581_n ) capacitor c=0.00194716f \
 //x=42.955 //y=1.845 //x2=42.665 //y2=1.595
cc_3046 ( N_noxref_8_M26_noxref_d N_noxref_11_c_4581_n ) capacitor \
 c=0.00356097f //x=42.365 //y=1.095 //x2=42.665 //y2=1.595
cc_3047 ( N_noxref_8_c_3480_p N_noxref_11_c_4585_n ) capacitor c=5.24634e-19 \
 //x=42.555 //y=1.305 //x2=42.82 //y2=1.095
cc_3048 ( N_noxref_8_M26_noxref_d N_noxref_11_c_4585_n ) capacitor \
 c=0.00139206f //x=42.365 //y=1.095 //x2=42.82 //y2=1.095
cc_3049 ( N_noxref_8_c_3480_p N_noxref_11_c_4587_n ) capacitor c=0.00307978f \
 //x=42.555 //y=1.305 //x2=42.82 //y2=1.44
cc_3050 ( N_noxref_8_c_3483_p N_noxref_11_c_4587_n ) capacitor c=0.00363411f \
 //x=42.555 //y=1.76 //x2=42.82 //y2=1.44
cc_3051 ( N_noxref_8_c_3456_p N_noxref_11_c_4587_n ) capacitor c=0.00323576f \
 //x=42.955 //y=1.845 //x2=42.82 //y2=1.44
cc_3052 ( N_noxref_8_M26_noxref_d N_noxref_11_c_4587_n ) capacitor \
 c=0.00237422f //x=42.365 //y=1.095 //x2=42.82 //y2=1.44
cc_3053 ( N_noxref_8_c_3439_p N_noxref_11_c_4591_n ) capacitor c=0.00244157f \
 //x=43.04 //y=2.61 //x2=42.3 //y2=2.26
cc_3054 ( N_noxref_8_c_3483_p N_noxref_11_c_4592_n ) capacitor c=0.0036273f \
 //x=42.555 //y=1.76 //x2=42.3 //y2=2.095
cc_3055 ( N_noxref_8_c_3439_p N_noxref_11_c_4592_n ) capacitor c=0.00282067f \
 //x=43.04 //y=2.61 //x2=42.3 //y2=2.095
cc_3056 ( N_noxref_8_c_3417_n N_noxref_11_c_4519_n ) capacitor c=0.00714556f \
 //x=43.04 //y=5.25 //x2=42.3 //y2=4.88
cc_3057 ( N_noxref_8_c_3453_p N_noxref_11_c_4519_n ) capacitor c=0.00203307f \
 //x=42.26 //y=5.335 //x2=42.3 //y2=4.88
cc_3058 ( N_noxref_8_c_3454_p N_noxref_11_c_4519_n ) capacitor c=0.00375636f \
 //x=42.26 //y=5.56 //x2=42.3 //y2=4.88
cc_3059 ( N_noxref_8_c_3417_n N_D_c_5222_n ) capacitor c=0.00149051f //x=43.04 \
 //y=5.25 //x2=42.595 //y2=4.3
cc_3060 ( N_noxref_8_c_3417_n N_D_c_5198_n ) capacitor c=0.0229022f //x=43.04 \
 //y=5.25 //x2=47.455 //y2=4.25
cc_3061 ( N_noxref_8_c_3419_n N_D_c_5198_n ) capacitor c=0.0247739f //x=44.89 \
 //y=4.755 //x2=47.455 //y2=4.25
cc_3062 ( N_noxref_8_c_3439_p CLK ) capacitor c=3.32566e-19 //x=43.04 //y=2.61 \
 //x2=46 //y2=2.77
cc_3063 ( N_noxref_8_c_3417_n CLK ) capacitor c=0.00101179f //x=43.04 //y=5.25 \
 //x2=46 //y2=2.77
cc_3064 ( N_noxref_8_c_3443_p CLK ) capacitor c=0.00460058f //x=44.89 //y=2.61 \
 //x2=46 //y2=2.77
cc_3065 ( N_noxref_8_c_3510_p CLK ) capacitor c=0.00787446f //x=44.89 //y=2.93 \
 //x2=46 //y2=2.77
cc_3066 ( N_noxref_8_c_3419_n CLK ) capacitor c=0.0399611f //x=44.89 //y=4.755 \
 //x2=46 //y2=2.77
cc_3067 ( N_noxref_8_c_3512_p CLK ) capacitor c=2.90818e-19 //x=44.89 //y=2.77 \
 //x2=46 //y2=2.77
cc_3068 ( N_noxref_8_c_3513_p CLK ) capacitor c=0.00512134f //x=44.9 //y=2.77 \
 //x2=46 //y2=2.77
cc_3069 ( N_noxref_8_c_3514_p CLK ) capacitor c=3.9149e-19 //x=44.89 //y=2.26 \
 //x2=46 //y2=2.77
cc_3070 ( N_noxref_8_c_3515_p N_CLK_c_6701_n ) capacitor c=0.00898333f \
 //x=44.89 //y=2.375 //x2=46 //y2=2.375
cc_3071 ( N_noxref_8_c_3514_p N_CLK_c_6701_n ) capacitor c=5.40058e-19 \
 //x=44.89 //y=2.26 //x2=46 //y2=2.375
cc_3072 ( N_noxref_8_c_3517_p N_CLK_c_6701_n ) capacitor c=0.00142893f \
 //x=44.59 //y=2.095 //x2=46 //y2=2.375
cc_3073 ( N_noxref_8_c_3419_n N_CLK_c_6595_n ) capacitor c=0.00762446f \
 //x=44.89 //y=4.755 //x2=46.005 //y2=4.835
cc_3074 ( N_noxref_8_c_3519_p N_CLK_c_6595_n ) capacitor c=6.25125e-19 \
 //x=44.89 //y=4.88 //x2=46.005 //y2=4.835
cc_3075 ( N_noxref_8_c_3423_n N_CLK_c_6595_n ) capacitor c=7.07965e-19 \
 //x=45.455 //y=4.97 //x2=46.005 //y2=4.835
cc_3076 ( N_noxref_8_c_3424_n N_CLK_c_6595_n ) capacitor c=8.59438e-19 \
 //x=45.165 //y=4.97 //x2=46.005 //y2=4.835
cc_3077 ( N_noxref_8_c_3417_n N_CLK_c_6616_n ) capacitor c=0.0233664f \
 //x=43.04 //y=5.25 //x2=45.845 //y2=4.62
cc_3078 ( N_noxref_8_c_3419_n N_CLK_c_6616_n ) capacitor c=0.0275338f \
 //x=44.89 //y=4.755 //x2=45.845 //y2=4.62
cc_3079 ( N_noxref_8_c_3419_n N_CLK_c_6623_n ) capacitor c=0.00449034f \
 //x=44.89 //y=4.755 //x2=59.19 //y2=4.635
cc_3080 ( N_noxref_8_c_3515_p N_CLK_c_6711_n ) capacitor c=5.39999e-19 \
 //x=44.89 //y=2.375 //x2=46 //y2=2.26
cc_3081 ( N_noxref_8_c_3443_p N_CLK_c_6711_n ) capacitor c=3.9149e-19 \
 //x=44.89 //y=2.61 //x2=46 //y2=2.26
cc_3082 ( N_noxref_8_c_3514_p N_CLK_c_6711_n ) capacitor c=0.00125213f \
 //x=44.89 //y=2.26 //x2=46 //y2=2.26
cc_3083 ( N_noxref_8_c_3517_p N_CLK_c_6711_n ) capacitor c=0.00214573f \
 //x=44.59 //y=2.095 //x2=46 //y2=2.26
cc_3084 ( N_noxref_8_c_3419_n N_CLK_c_6715_n ) capacitor c=4.24307e-19 \
 //x=44.89 //y=4.755 //x2=46 //y2=4.88
cc_3085 ( N_noxref_8_c_3519_p N_CLK_c_6715_n ) capacitor c=0.00113671f \
 //x=44.89 //y=4.88 //x2=46 //y2=4.88
cc_3086 ( N_noxref_8_c_3423_n N_CLK_c_6715_n ) capacitor c=0.00116563f \
 //x=45.455 //y=4.97 //x2=46 //y2=4.88
cc_3087 ( N_noxref_8_c_3424_n N_CLK_c_6715_n ) capacitor c=0.0012974f \
 //x=45.165 //y=4.97 //x2=46 //y2=4.88
cc_3088 ( N_noxref_8_M115_noxref_g N_CLK_M117_noxref_g ) capacitor \
 c=0.0106276f //x=45.09 //y=6.2 //x2=45.97 //y2=6.2
cc_3089 ( N_noxref_8_M116_noxref_g N_CLK_M117_noxref_g ) capacitor c=0.107144f \
 //x=45.53 //y=6.2 //x2=45.97 //y2=6.2
cc_3090 ( N_noxref_8_M116_noxref_g N_CLK_M118_noxref_g ) capacitor \
 c=0.0101598f //x=45.53 //y=6.2 //x2=46.41 //y2=6.2
cc_3091 ( N_noxref_8_c_3536_p N_CLK_c_6722_n ) capacitor c=5.72528e-19 \
 //x=44.59 //y=1.055 //x2=45.565 //y2=1.09
cc_3092 ( N_noxref_8_c_3537_p N_CLK_c_6722_n ) capacitor c=0.00150277f \
 //x=44.59 //y=1.4 //x2=45.565 //y2=1.09
cc_3093 ( N_noxref_8_c_3538_p N_CLK_c_6722_n ) capacitor c=0.0160123f \
 //x=45.12 //y=1.055 //x2=45.565 //y2=1.09
cc_3094 ( N_noxref_8_c_3539_p N_CLK_c_6725_n ) capacitor c=0.00111227f \
 //x=44.59 //y=1.71 //x2=45.565 //y2=1.4
cc_3095 ( N_noxref_8_c_3540_p N_CLK_c_6725_n ) capacitor c=0.0124075f \
 //x=45.12 //y=1.4 //x2=45.565 //y2=1.4
cc_3096 ( N_noxref_8_c_3538_p N_CLK_c_6727_n ) capacitor c=9.19165e-19 \
 //x=45.12 //y=1.055 //x2=46.09 //y2=1.09
cc_3097 ( N_noxref_8_c_3540_p N_CLK_c_6728_n ) capacitor c=0.0010154f \
 //x=45.12 //y=1.4 //x2=46.09 //y2=1.4
cc_3098 ( N_noxref_8_c_3540_p N_CLK_c_6729_n ) capacitor c=9.23422e-19 \
 //x=45.12 //y=1.4 //x2=46.09 //y2=1.63
cc_3099 ( N_noxref_8_c_3515_p N_CLK_c_6730_n ) capacitor c=0.0013537f \
 //x=44.89 //y=2.375 //x2=46.09 //y2=2.095
cc_3100 ( N_noxref_8_c_3514_p N_CLK_c_6730_n ) capacitor c=0.0020754f \
 //x=44.89 //y=2.26 //x2=46.09 //y2=2.095
cc_3101 ( N_noxref_8_c_3517_p N_CLK_c_6730_n ) capacitor c=0.00964411f \
 //x=44.59 //y=2.095 //x2=46.09 //y2=2.095
cc_3102 ( N_noxref_8_c_3519_p N_CLK_c_6733_n ) capacitor c=0.00123917f \
 //x=44.89 //y=4.88 //x2=46 //y2=4.88
cc_3103 ( N_noxref_8_c_3423_n N_CLK_c_6733_n ) capacitor c=0.0169508f \
 //x=45.455 //y=4.97 //x2=46 //y2=4.88
cc_3104 ( N_noxref_8_c_3424_n N_CLK_c_6733_n ) capacitor c=0.00406071f \
 //x=45.165 //y=4.97 //x2=46 //y2=4.88
cc_3105 ( N_noxref_8_c_3419_n RN ) capacitor c=0.00134736f //x=44.89 //y=4.755 \
 //x2=47.11 //y2=2.77
cc_3106 ( N_noxref_8_c_3439_p N_RN_c_8218_n ) capacitor c=0.0272405f //x=43.04 \
 //y=2.61 //x2=43.255 //y2=2.385
cc_3107 ( N_noxref_8_c_3441_p N_RN_c_8218_n ) capacitor c=0.00570792f \
 //x=43.04 //y=2.93 //x2=43.255 //y2=2.385
cc_3108 ( N_noxref_8_c_3438_p N_RN_c_8218_n ) capacitor c=0.133465f //x=44.74 \
 //y=2.77 //x2=43.255 //y2=2.385
cc_3109 ( N_noxref_8_c_3446_p N_RN_c_8218_n ) capacitor c=0.0365231f //x=43.2 \
 //y=2.77 //x2=43.255 //y2=2.385
cc_3110 ( N_noxref_8_c_3480_p N_RN_c_8024_n ) capacitor c=7.09906e-19 \
 //x=42.555 //y=1.305 //x2=42.825 //y2=2.385
cc_3111 ( N_noxref_8_c_3456_p N_RN_c_8024_n ) capacitor c=0.00861999f \
 //x=42.955 //y=1.845 //x2=42.825 //y2=2.385
cc_3112 ( N_noxref_8_c_3435_p N_RN_c_8024_n ) capacitor c=0.0125921f //x=42.64 \
 //y=1.845 //x2=42.825 //y2=2.385
cc_3113 ( N_noxref_8_c_3439_p N_RN_c_8024_n ) capacitor c=3.12067e-19 \
 //x=43.04 //y=2.61 //x2=42.825 //y2=2.385
cc_3114 ( N_noxref_8_c_3443_p N_RN_c_8226_n ) capacitor c=5.11045e-19 \
 //x=44.89 //y=2.61 //x2=44.515 //y2=2.4
cc_3115 ( N_noxref_8_c_3510_p N_RN_c_8226_n ) capacitor c=0.00348052f \
 //x=44.89 //y=2.93 //x2=44.515 //y2=2.4
cc_3116 ( N_noxref_8_c_3438_p N_RN_c_8226_n ) capacitor c=0.0109101f //x=44.74 \
 //y=2.77 //x2=44.515 //y2=2.4
cc_3117 ( N_noxref_8_c_3515_p N_RN_c_8229_n ) capacitor c=0.0168589f //x=44.89 \
 //y=2.375 //x2=45.115 //y2=2.385
cc_3118 ( N_noxref_8_c_3443_p N_RN_c_8229_n ) capacitor c=0.012163f //x=44.89 \
 //y=2.61 //x2=45.115 //y2=2.385
cc_3119 ( N_noxref_8_c_3510_p N_RN_c_8229_n ) capacitor c=0.00478203f \
 //x=44.89 //y=2.93 //x2=45.115 //y2=2.385
cc_3120 ( N_noxref_8_c_3513_p N_RN_c_8229_n ) capacitor c=0.0370412f //x=44.9 \
 //y=2.77 //x2=45.115 //y2=2.385
cc_3121 ( N_noxref_8_c_3514_p N_RN_c_8229_n ) capacitor c=5.18204e-19 \
 //x=44.89 //y=2.26 //x2=45.115 //y2=2.385
cc_3122 ( N_noxref_8_c_3517_p N_RN_c_8229_n ) capacitor c=3.41298e-19 \
 //x=44.59 //y=2.095 //x2=45.115 //y2=2.385
cc_3123 ( N_noxref_8_c_3443_p N_RN_c_8235_n ) capacitor c=3.71593e-19 \
 //x=44.89 //y=2.61 //x2=47.275 //y2=2.4
cc_3124 ( N_noxref_8_c_3439_p SN ) capacitor c=3.42202e-19 //x=43.04 //y=2.61 \
 //x2=41.19 //y2=2.77
cc_3125 ( N_noxref_8_c_3425_n N_SN_c_10114_n ) capacitor c=4.55325e-19 \
 //x=41.26 //y=5.335 //x2=41.19 //y2=3.285
cc_3126 ( N_noxref_8_c_3571_p N_SN_c_10114_n ) capacitor c=0.0013539f \
 //x=41.38 //y=5.335 //x2=41.19 //y2=3.285
cc_3127 ( N_noxref_8_c_3572_p N_SN_c_10114_n ) capacitor c=4.8336e-19 \
 //x=41.38 //y=5.56 //x2=41.19 //y2=3.285
cc_3128 ( N_noxref_8_c_3425_n N_SN_c_10068_n ) capacitor c=0.0178828f \
 //x=41.26 //y=5.335 //x2=41.19 //y2=4.765
cc_3129 ( N_noxref_8_c_3417_n N_SN_c_10068_n ) capacitor c=0.00185754f \
 //x=43.04 //y=5.25 //x2=41.19 //y2=4.765
cc_3130 ( N_noxref_8_c_3571_p N_SN_c_10068_n ) capacitor c=0.00209649f \
 //x=41.38 //y=5.335 //x2=41.19 //y2=4.765
cc_3131 ( N_noxref_8_c_3572_p N_SN_c_10068_n ) capacitor c=6.21282e-19 \
 //x=41.38 //y=5.56 //x2=41.19 //y2=4.765
cc_3132 ( N_noxref_8_c_3441_p N_SN_c_10178_n ) capacitor c=0.0102778f \
 //x=43.04 //y=2.93 //x2=43.255 //y2=3.155
cc_3133 ( N_noxref_8_c_3417_n N_SN_c_10178_n ) capacitor c=0.0226563f \
 //x=43.04 //y=5.25 //x2=43.255 //y2=3.155
cc_3134 ( N_noxref_8_c_3438_p N_SN_c_10178_n ) capacitor c=0.128848f //x=44.74 \
 //y=2.77 //x2=43.255 //y2=3.155
cc_3135 ( N_noxref_8_c_3441_p N_SN_c_10143_n ) capacitor c=0.00153128f \
 //x=43.04 //y=2.93 //x2=42.91 //y2=3.155
cc_3136 ( N_noxref_8_c_3417_n N_SN_c_10143_n ) capacitor c=3.10774e-19 \
 //x=43.04 //y=5.25 //x2=42.91 //y2=3.155
cc_3137 ( N_noxref_8_c_3446_p N_SN_c_10143_n ) capacitor c=0.0358254f //x=43.2 \
 //y=2.77 //x2=42.91 //y2=3.155
cc_3138 ( N_noxref_8_c_3510_p N_SN_c_10184_n ) capacitor c=0.00511674f \
 //x=44.89 //y=2.93 //x2=44.515 //y2=3.14
cc_3139 ( N_noxref_8_c_3419_n N_SN_c_10184_n ) capacitor c=5.11045e-19 \
 //x=44.89 //y=4.755 //x2=44.515 //y2=3.14
cc_3140 ( N_noxref_8_c_3438_p N_SN_c_10184_n ) capacitor c=0.0107306f \
 //x=44.74 //y=2.77 //x2=44.515 //y2=3.14
cc_3141 ( N_noxref_8_c_3513_p N_SN_c_10184_n ) capacitor c=0.0358254f //x=44.9 \
 //y=2.77 //x2=44.515 //y2=3.14
cc_3142 ( N_noxref_8_c_3510_p N_SN_c_10188_n ) capacitor c=0.00397194f \
 //x=44.89 //y=2.93 //x2=45.115 //y2=3.155
cc_3143 ( N_noxref_8_c_3419_n N_SN_c_10188_n ) capacitor c=0.023934f //x=44.89 \
 //y=4.755 //x2=45.115 //y2=3.155
cc_3144 ( N_noxref_8_c_3425_n N_SN_c_10083_n ) capacitor c=0.00492634f \
 //x=41.26 //y=5.335 //x2=41.19 //y2=4.88
cc_3145 ( N_noxref_8_c_3571_p N_SN_c_10083_n ) capacitor c=0.00132214f \
 //x=41.38 //y=5.335 //x2=41.19 //y2=4.88
cc_3146 ( N_noxref_8_c_3425_n N_SN_M111_noxref_g ) capacitor c=0.00858183f \
 //x=41.26 //y=5.335 //x2=41.16 //y2=6.2
cc_3147 ( N_noxref_8_c_3571_p N_SN_M111_noxref_g ) capacitor c=0.00229818f \
 //x=41.38 //y=5.335 //x2=41.16 //y2=6.2
cc_3148 ( N_noxref_8_c_3572_p N_SN_M111_noxref_g ) capacitor c=0.0179041f \
 //x=41.38 //y=5.56 //x2=41.16 //y2=6.2
cc_3149 ( N_noxref_8_c_3447_p N_SN_M112_noxref_g ) capacitor c=0.00875663f \
 //x=42.145 //y=5.335 //x2=41.6 //y2=6.2
cc_3150 ( N_noxref_8_c_3571_p N_SN_M112_noxref_g ) capacitor c=0.00230699f \
 //x=41.38 //y=5.335 //x2=41.6 //y2=6.2
cc_3151 ( N_noxref_8_c_3572_p N_SN_M112_noxref_g ) capacitor c=0.0179041f \
 //x=41.38 //y=5.56 //x2=41.6 //y2=6.2
cc_3152 ( N_noxref_8_c_3571_p N_SN_c_10100_n ) capacitor c=0.00201022f \
 //x=41.38 //y=5.335 //x2=41.525 //y2=4.97
cc_3153 ( N_noxref_8_c_3572_p N_SN_c_10100_n ) capacitor c=0.00290085f \
 //x=41.38 //y=5.56 //x2=41.525 //y2=4.97
cc_3154 ( N_noxref_8_c_3425_n N_SN_c_10166_n ) capacitor c=5.877e-19 //x=41.26 \
 //y=5.335 //x2=41.19 //y2=4.88
cc_3155 ( N_noxref_8_c_3425_n N_VDD_c_13434_n ) capacitor c=0.00559514f \
 //x=41.26 //y=5.335 //x2=87.775 //y2=7.585
cc_3156 ( N_noxref_8_c_3447_p N_VDD_c_13434_n ) capacitor c=0.00564834f \
 //x=42.145 //y=5.335 //x2=87.775 //y2=7.585
cc_3157 ( N_noxref_8_c_3458_p N_VDD_c_13434_n ) capacitor c=0.00236065f \
 //x=42.26 //y=5.56 //x2=87.775 //y2=7.585
cc_3158 ( N_noxref_8_c_3416_n N_VDD_c_13434_n ) capacitor c=0.00753358f \
 //x=42.955 //y=5.335 //x2=87.775 //y2=7.585
cc_3159 ( N_noxref_8_c_3420_n N_VDD_c_13434_n ) capacitor c=0.00241373f \
 //x=40.502 //y=5.335 //x2=87.775 //y2=7.585
cc_3160 ( N_noxref_8_c_3571_p N_VDD_c_13434_n ) capacitor c=0.00249074f \
 //x=41.38 //y=5.335 //x2=87.775 //y2=7.585
cc_3161 ( N_noxref_8_c_3430_n N_VDD_c_13434_n ) capacitor c=0.0024232f \
 //x=40.5 //y=5.56 //x2=87.775 //y2=7.585
cc_3162 ( N_noxref_8_c_3572_p N_VDD_c_13434_n ) capacitor c=0.0024232f \
 //x=41.38 //y=5.56 //x2=87.775 //y2=7.585
cc_3163 ( N_noxref_8_c_3454_p N_VDD_c_13434_n ) capacitor c=0.0024232f \
 //x=42.26 //y=5.56 //x2=87.775 //y2=7.585
cc_3164 ( N_noxref_8_c_3425_n N_VDD_c_13858_n ) capacitor c=0.00202922f \
 //x=41.26 //y=5.335 //x2=40.855 //y2=7.585
cc_3165 ( N_noxref_8_c_3420_n N_VDD_c_13858_n ) capacitor c=9.3757e-19 \
 //x=40.502 //y=5.335 //x2=40.855 //y2=7.585
cc_3166 ( N_noxref_8_c_3430_n N_VDD_c_13858_n ) capacitor c=0.0138074f \
 //x=40.5 //y=5.56 //x2=40.855 //y2=7.585
cc_3167 ( N_noxref_8_c_3425_n N_VDD_c_13909_n ) capacitor c=0.0017708f \
 //x=41.26 //y=5.335 //x2=41.735 //y2=7.585
cc_3168 ( N_noxref_8_c_3447_p N_VDD_c_13909_n ) capacitor c=0.00202922f \
 //x=42.145 //y=5.335 //x2=41.735 //y2=7.585
cc_3169 ( N_noxref_8_c_3571_p N_VDD_c_13909_n ) capacitor c=9.4822e-19 \
 //x=41.38 //y=5.335 //x2=41.735 //y2=7.585
cc_3170 ( N_noxref_8_c_3572_p N_VDD_c_13909_n ) capacitor c=0.0138074f \
 //x=41.38 //y=5.56 //x2=41.735 //y2=7.585
cc_3171 ( N_noxref_8_c_3447_p N_VDD_c_13913_n ) capacitor c=0.00205906f \
 //x=42.145 //y=5.335 //x2=42.615 //y2=7.585
cc_3172 ( N_noxref_8_c_3458_p N_VDD_c_13913_n ) capacitor c=8.49654e-19 \
 //x=42.26 //y=5.56 //x2=42.615 //y2=7.585
cc_3173 ( N_noxref_8_c_3416_n N_VDD_c_13913_n ) capacitor c=0.00204238f \
 //x=42.955 //y=5.335 //x2=42.615 //y2=7.585
cc_3174 ( N_noxref_8_c_3454_p N_VDD_c_13913_n ) capacitor c=0.013249f \
 //x=42.26 //y=5.56 //x2=42.615 //y2=7.585
cc_3175 ( N_noxref_8_c_3416_n N_VDD_c_13917_n ) capacitor c=0.00183742f \
 //x=42.955 //y=5.335 //x2=43.61 //y2=7.585
cc_3176 ( N_noxref_8_M115_noxref_g N_VDD_c_13918_n ) capacitor c=0.00755614f \
 //x=45.09 //y=6.2 //x2=45.665 //y2=7.585
cc_3177 ( N_noxref_8_M116_noxref_g N_VDD_c_13918_n ) capacitor c=0.00755544f \
 //x=45.53 //y=6.2 //x2=45.665 //y2=7.585
cc_3178 ( N_noxref_8_c_3420_n N_VDD_c_13775_n ) capacitor c=0.0022955f \
 //x=40.502 //y=5.335 //x2=38.97 //y2=7.585
cc_3179 ( N_noxref_8_c_3430_n N_VDD_c_13775_n ) capacitor c=0.00509469f \
 //x=40.5 //y=5.56 //x2=38.97 //y2=7.585
cc_3180 ( N_noxref_8_c_3458_p N_VDD_c_13776_n ) capacitor c=0.00282782f \
 //x=42.26 //y=5.56 //x2=43.78 //y2=7.585
cc_3181 ( N_noxref_8_c_3417_n N_VDD_c_13776_n ) capacitor c=0.0318337f \
 //x=43.04 //y=5.25 //x2=43.78 //y2=7.585
cc_3182 ( N_noxref_8_c_3419_n N_VDD_c_13776_n ) capacitor c=0.0109606f \
 //x=44.89 //y=4.755 //x2=43.78 //y2=7.585
cc_3183 ( N_noxref_8_c_3454_p N_VDD_c_13776_n ) capacitor c=0.00777981f \
 //x=42.26 //y=5.56 //x2=43.78 //y2=7.585
cc_3184 ( N_noxref_8_c_3519_p N_VDD_c_13776_n ) capacitor c=0.00354568f \
 //x=44.89 //y=4.88 //x2=43.78 //y2=7.585
cc_3185 ( N_noxref_8_c_3424_n N_VDD_c_13776_n ) capacitor c=0.00572368f \
 //x=45.165 //y=4.97 //x2=43.78 //y2=7.585
cc_3186 ( N_noxref_8_c_3420_n N_VDD_M109_noxref_s ) capacitor c=0.0442713f \
 //x=40.502 //y=5.335 //x2=39.925 //y2=5.2
cc_3187 ( N_noxref_8_c_3571_p N_VDD_M109_noxref_s ) capacitor c=7.80122e-19 \
 //x=41.38 //y=5.335 //x2=39.925 //y2=5.2
cc_3188 ( N_noxref_8_c_3430_n N_VDD_M109_noxref_s ) capacitor c=0.09305f \
 //x=40.5 //y=5.56 //x2=39.925 //y2=5.2
cc_3189 ( N_noxref_8_c_3425_n N_VDD_M110_noxref_d ) capacitor c=0.00700141f \
 //x=41.26 //y=5.335 //x2=40.795 //y2=5.2
cc_3190 ( N_noxref_8_c_3430_n N_VDD_M110_noxref_d ) capacitor c=0.0674491f \
 //x=40.5 //y=5.56 //x2=40.795 //y2=5.2
cc_3191 ( N_noxref_8_c_3572_p N_VDD_M110_noxref_d ) capacitor c=0.0674762f \
 //x=41.38 //y=5.56 //x2=40.795 //y2=5.2
cc_3192 ( N_noxref_8_c_3447_p N_VDD_M112_noxref_d ) capacitor c=0.00700141f \
 //x=42.145 //y=5.335 //x2=41.675 //y2=5.2
cc_3193 ( N_noxref_8_c_3572_p N_VDD_M112_noxref_d ) capacitor c=0.067493f \
 //x=41.38 //y=5.56 //x2=41.675 //y2=5.2
cc_3194 ( N_noxref_8_c_3454_p N_VDD_M112_noxref_d ) capacitor c=0.0674979f \
 //x=42.26 //y=5.56 //x2=41.675 //y2=5.2
cc_3195 ( N_noxref_8_c_3416_n N_VDD_M114_noxref_d ) capacitor c=0.00700141f \
 //x=42.955 //y=5.335 //x2=42.555 //y2=5.2
cc_3196 ( N_noxref_8_c_3454_p N_VDD_M114_noxref_d ) capacitor c=0.0675002f \
 //x=42.26 //y=5.56 //x2=42.555 //y2=5.2
cc_3197 ( N_noxref_8_c_3458_p N_VDD_M115_noxref_s ) capacitor c=0.00492616f \
 //x=42.26 //y=5.56 //x2=44.735 //y2=5.2
cc_3198 ( N_noxref_8_c_3416_n N_VDD_M115_noxref_s ) capacitor c=9.42705e-19 \
 //x=42.955 //y=5.335 //x2=44.735 //y2=5.2
cc_3199 ( N_noxref_8_c_3510_p N_VDD_M115_noxref_s ) capacitor c=4.12751e-19 \
 //x=44.89 //y=2.93 //x2=44.735 //y2=5.2
cc_3200 ( N_noxref_8_c_3419_n N_VDD_M115_noxref_s ) capacitor c=0.0167311f \
 //x=44.89 //y=4.755 //x2=44.735 //y2=5.2
cc_3201 ( N_noxref_8_c_3571_p N_VDD_M115_noxref_s ) capacitor c=2.11884e-19 \
 //x=41.38 //y=5.335 //x2=44.735 //y2=5.2
cc_3202 ( N_noxref_8_c_3519_p N_VDD_M115_noxref_s ) capacitor c=0.00983846f \
 //x=44.89 //y=4.88 //x2=44.735 //y2=5.2
cc_3203 ( N_noxref_8_M115_noxref_g N_VDD_M115_noxref_s ) capacitor c=0.053419f \
 //x=45.09 //y=6.2 //x2=44.735 //y2=5.2
cc_3204 ( N_noxref_8_c_3424_n N_VDD_M115_noxref_s ) capacitor c=0.00608913f \
 //x=45.165 //y=4.97 //x2=44.735 //y2=5.2
cc_3205 ( N_noxref_8_M116_noxref_g N_VDD_M116_noxref_d ) capacitor c=0.015318f \
 //x=45.53 //y=6.2 //x2=45.605 //y2=5.2
cc_3206 ( N_noxref_8_c_3480_p N_noxref_34_c_15420_n ) capacitor c=0.0036878f \
 //x=42.555 //y=1.305 //x2=42.955 //y2=0.72
cc_3207 ( N_noxref_8_c_3456_p N_noxref_34_c_15420_n ) capacitor c=0.00399931f \
 //x=42.955 //y=1.845 //x2=42.955 //y2=0.72
cc_3208 ( N_noxref_8_M26_noxref_d N_noxref_34_c_15420_n ) capacitor \
 c=0.00910163f //x=42.365 //y=1.095 //x2=42.955 //y2=0.72
cc_3209 ( N_noxref_8_M26_noxref_d N_noxref_34_c_15423_n ) capacitor \
 c=0.00120711f //x=42.365 //y=1.095 //x2=42.07 //y2=1.175
cc_3210 ( N_noxref_8_c_3425_n N_noxref_34_M25_noxref_d ) capacitor \
 c=0.00131192f //x=41.26 //y=5.335 //x2=40.83 //y2=1.09
cc_3211 ( N_noxref_8_c_3480_p N_noxref_34_M25_noxref_d ) capacitor \
 c=0.00802417f //x=42.555 //y=1.305 //x2=40.83 //y2=1.09
cc_3212 ( N_noxref_8_c_3480_p N_noxref_34_M26_noxref_s ) capacitor \
 c=0.0098487f //x=42.555 //y=1.305 //x2=41.935 //y2=0.555
cc_3213 ( N_noxref_8_c_3483_p N_noxref_34_M26_noxref_s ) capacitor \
 c=0.0283243f //x=42.555 //y=1.76 //x2=41.935 //y2=0.555
cc_3214 ( N_noxref_8_c_3456_p N_noxref_34_M26_noxref_s ) capacitor \
 c=0.00752108f //x=42.955 //y=1.845 //x2=41.935 //y2=0.555
cc_3215 ( N_noxref_8_c_3429_n N_noxref_34_M26_noxref_s ) capacitor \
 c=0.00309975f //x=43.04 //y=2.77 //x2=41.935 //y2=0.555
cc_3216 ( N_noxref_8_M26_noxref_d N_noxref_34_M26_noxref_s ) capacitor \
 c=0.0279003f //x=42.365 //y=1.095 //x2=41.935 //y2=0.555
cc_3217 ( N_noxref_8_c_3480_p N_noxref_35_M28_noxref_d ) capacitor \
 c=3.20746e-19 //x=42.555 //y=1.305 //x2=45.64 //y2=1.09
cc_3218 ( N_noxref_8_c_3480_p N_GND_c_16728_n ) capacitor c=0.00884249f \
 //x=42.555 //y=1.305 //x2=44.77 //y2=0.175
cc_3219 ( N_noxref_8_c_3456_p N_GND_c_16728_n ) capacitor c=0.00662553f \
 //x=42.955 //y=1.845 //x2=44.77 //y2=0.175
cc_3220 ( N_noxref_8_c_3441_p N_GND_c_16728_n ) capacitor c=4.31179e-19 \
 //x=43.04 //y=2.93 //x2=44.77 //y2=0.175
cc_3221 ( N_noxref_8_M26_noxref_d N_GND_c_16728_n ) capacitor c=2.9462e-19 \
 //x=42.365 //y=1.095 //x2=44.77 //y2=0.175
cc_3222 ( N_noxref_8_c_3536_p N_GND_c_16732_n ) capacitor c=3.97665e-19 \
 //x=44.59 //y=1.055 //x2=44.855 //y2=1.015
cc_3223 ( N_noxref_8_c_3668_p N_GND_c_16732_n ) capacitor c=0.00864776f \
 //x=44.965 //y=0.9 //x2=44.855 //y2=1.015
cc_3224 ( N_noxref_8_c_3538_p N_GND_c_16732_n ) capacitor c=4.45447e-19 \
 //x=45.12 //y=1.055 //x2=44.855 //y2=1.015
cc_3225 ( N_noxref_8_c_3480_p N_GND_c_16735_n ) capacitor c=0.00543195f \
 //x=42.555 //y=1.305 //x2=44.855 //y2=1.145
cc_3226 ( N_noxref_8_c_3515_p N_GND_c_16735_n ) capacitor c=0.00771144f \
 //x=44.89 //y=2.375 //x2=44.855 //y2=1.145
cc_3227 ( N_noxref_8_c_3510_p N_GND_c_16735_n ) capacitor c=0.0011623f \
 //x=44.89 //y=2.93 //x2=44.855 //y2=1.145
cc_3228 ( N_noxref_8_c_3514_p N_GND_c_16735_n ) capacitor c=2.22883e-19 \
 //x=44.89 //y=2.26 //x2=44.855 //y2=1.145
cc_3229 ( N_noxref_8_c_3536_p N_GND_c_16735_n ) capacitor c=0.00156339f \
 //x=44.59 //y=1.055 //x2=44.855 //y2=1.145
cc_3230 ( N_noxref_8_c_3537_p N_GND_c_16735_n ) capacitor c=0.00352472f \
 //x=44.59 //y=1.4 //x2=44.855 //y2=1.145
cc_3231 ( N_noxref_8_c_3539_p N_GND_c_16735_n ) capacitor c=3.88232e-19 \
 //x=44.59 //y=1.71 //x2=44.855 //y2=1.145
cc_3232 ( N_noxref_8_c_3668_p N_GND_c_16735_n ) capacitor c=9.36995e-19 \
 //x=44.965 //y=0.9 //x2=44.855 //y2=1.145
cc_3233 ( N_noxref_8_c_3678_p N_GND_c_16735_n ) capacitor c=5.27793e-19 \
 //x=44.965 //y=1.555 //x2=44.855 //y2=1.145
cc_3234 ( N_noxref_8_c_3538_p N_GND_c_16735_n ) capacitor c=0.0017438f \
 //x=45.12 //y=1.055 //x2=44.855 //y2=1.145
cc_3235 ( N_noxref_8_c_3540_p N_GND_c_16735_n ) capacitor c=0.00276804f \
 //x=45.12 //y=1.4 //x2=44.855 //y2=1.145
cc_3236 ( N_noxref_8_c_3456_p N_GND_c_16692_n ) capacitor c=6.86343e-19 \
 //x=42.955 //y=1.845 //x2=43.61 //y2=0.175
cc_3237 ( N_noxref_8_c_3441_p N_GND_c_16692_n ) capacitor c=6.02672e-19 \
 //x=43.04 //y=2.93 //x2=43.61 //y2=0.175
cc_3238 ( N_noxref_8_c_3536_p N_GND_c_16748_n ) capacitor c=0.00678016f \
 //x=44.59 //y=1.055 //x2=48.42 //y2=0.175
cc_3239 ( N_noxref_8_c_3483_p N_GND_c_16749_n ) capacitor c=0.0045138f \
 //x=42.555 //y=1.76 //x2=43.78 //y2=0.175
cc_3240 ( N_noxref_8_c_3456_p N_GND_c_16749_n ) capacitor c=0.0233604f \
 //x=42.955 //y=1.845 //x2=43.78 //y2=0.175
cc_3241 ( N_noxref_8_c_3441_p N_GND_c_16749_n ) capacitor c=0.00422913f \
 //x=43.04 //y=2.93 //x2=43.78 //y2=0.175
cc_3242 ( N_noxref_8_c_3515_p N_GND_c_16749_n ) capacitor c=0.003423f \
 //x=44.89 //y=2.375 //x2=43.78 //y2=0.175
cc_3243 ( N_noxref_8_c_3443_p N_GND_c_16749_n ) capacitor c=0.0036684f \
 //x=44.89 //y=2.61 //x2=43.78 //y2=0.175
cc_3244 ( N_noxref_8_c_3510_p N_GND_c_16749_n ) capacitor c=0.00305356f \
 //x=44.89 //y=2.93 //x2=43.78 //y2=0.175
cc_3245 ( N_noxref_8_c_3429_n N_GND_c_16749_n ) capacitor c=0.0103933f \
 //x=43.04 //y=2.77 //x2=43.78 //y2=0.175
cc_3246 ( N_noxref_8_c_3512_p N_GND_c_16749_n ) capacitor c=0.00527139f \
 //x=44.89 //y=2.77 //x2=43.78 //y2=0.175
cc_3247 ( N_noxref_8_c_3438_p N_GND_c_16749_n ) capacitor c=0.00947774f \
 //x=44.74 //y=2.77 //x2=43.78 //y2=0.175
cc_3248 ( N_noxref_8_c_3514_p N_GND_c_16749_n ) capacitor c=0.0039621f \
 //x=44.89 //y=2.26 //x2=43.78 //y2=0.175
cc_3249 ( N_noxref_8_c_3539_p N_GND_c_16749_n ) capacitor c=0.00170145f \
 //x=44.59 //y=1.71 //x2=43.78 //y2=0.175
cc_3250 ( N_noxref_8_c_3517_p N_GND_c_16749_n ) capacitor c=0.0102191f \
 //x=44.59 //y=2.095 //x2=43.78 //y2=0.175
cc_3251 ( N_noxref_8_c_3515_p N_GND_M27_noxref_d ) capacitor c=4.4417e-19 \
 //x=44.89 //y=2.375 //x2=44.665 //y2=1.055
cc_3252 ( N_noxref_8_c_3536_p N_GND_M27_noxref_d ) capacitor c=0.00184354f \
 //x=44.59 //y=1.055 //x2=44.665 //y2=1.055
cc_3253 ( N_noxref_8_c_3537_p N_GND_M27_noxref_d ) capacitor c=0.00210798f \
 //x=44.59 //y=1.4 //x2=44.665 //y2=1.055
cc_3254 ( N_noxref_8_c_3668_p N_GND_M27_noxref_d ) capacitor c=0.00474029f \
 //x=44.965 //y=0.9 //x2=44.665 //y2=1.055
cc_3255 ( N_noxref_8_c_3678_p N_GND_M27_noxref_d ) capacitor c=0.00166857f \
 //x=44.965 //y=1.555 //x2=44.665 //y2=1.055
cc_3256 ( N_noxref_8_c_3538_p N_GND_M27_noxref_d ) capacitor c=0.00230174f \
 //x=45.12 //y=1.055 //x2=44.665 //y2=1.055
cc_3257 ( N_noxref_8_c_3540_p N_GND_M27_noxref_d ) capacitor c=0.00210798f \
 //x=45.12 //y=1.4 //x2=44.665 //y2=1.055
cc_3258 ( N_noxref_8_c_3517_p N_noxref_56_c_18652_n ) capacitor c=0.00262672f \
 //x=44.59 //y=2.095 //x2=44.37 //y2=1.685
cc_3259 ( N_noxref_8_c_3515_p N_noxref_56_c_18653_n ) capacitor c=0.00428451f \
 //x=44.89 //y=2.375 //x2=45.255 //y2=1.77
cc_3260 ( N_noxref_8_c_3510_p N_noxref_56_c_18653_n ) capacitor c=0.0046919f \
 //x=44.89 //y=2.93 //x2=45.255 //y2=1.77
cc_3261 ( N_noxref_8_c_3514_p N_noxref_56_c_18653_n ) capacitor c=0.0104666f \
 //x=44.89 //y=2.26 //x2=45.255 //y2=1.77
cc_3262 ( N_noxref_8_c_3539_p N_noxref_56_c_18653_n ) capacitor c=0.00705077f \
 //x=44.59 //y=1.71 //x2=45.255 //y2=1.77
cc_3263 ( N_noxref_8_c_3517_p N_noxref_56_c_18653_n ) capacitor c=0.0197809f \
 //x=44.59 //y=2.095 //x2=45.255 //y2=1.77
cc_3264 ( N_noxref_8_c_3678_p N_noxref_56_c_18653_n ) capacitor c=0.00588627f \
 //x=44.965 //y=1.555 //x2=45.255 //y2=1.77
cc_3265 ( N_noxref_8_c_3540_p N_noxref_56_c_18653_n ) capacitor c=0.00698822f \
 //x=45.12 //y=1.4 //x2=45.255 //y2=1.77
cc_3266 ( N_noxref_8_c_3536_p N_noxref_56_M27_noxref_s ) capacitor \
 c=0.0295256f //x=44.59 //y=1.055 //x2=44.235 //y2=0.555
cc_3267 ( N_noxref_8_c_3539_p N_noxref_56_M27_noxref_s ) capacitor \
 c=7.99997e-19 //x=44.59 //y=1.71 //x2=44.235 //y2=0.555
cc_3268 ( N_noxref_8_c_3517_p N_noxref_56_M27_noxref_s ) capacitor \
 c=0.00122123f //x=44.59 //y=2.095 //x2=44.235 //y2=0.555
cc_3269 ( N_noxref_8_c_3538_p N_noxref_56_M27_noxref_s ) capacitor \
 c=0.0125924f //x=45.12 //y=1.055 //x2=44.235 //y2=0.555
cc_3270 ( N_noxref_9_M122_noxref_g N_noxref_10_c_4207_n ) capacitor \
 c=0.00813346f //x=50.34 //y=6.2 //x2=50.88 //y2=5.335
cc_3271 ( N_noxref_9_M121_noxref_g N_noxref_10_c_4202_n ) capacitor \
 c=0.00461408f //x=49.9 //y=6.2 //x2=50.122 //y2=5.335
cc_3272 ( N_noxref_9_M122_noxref_g N_noxref_10_c_4202_n ) capacitor \
 c=0.00229208f //x=50.34 //y=6.2 //x2=50.122 //y2=5.335
cc_3273 ( N_noxref_9_c_3731_n N_noxref_10_c_4202_n ) capacitor c=0.00171885f \
 //x=50.265 //y=4.97 //x2=50.122 //y2=5.335
cc_3274 ( N_noxref_9_M121_noxref_g N_noxref_10_c_4211_n ) capacitor \
 c=0.0162284f //x=49.9 //y=6.2 //x2=50.12 //y2=5.56
cc_3275 ( N_noxref_9_M122_noxref_g N_noxref_10_c_4211_n ) capacitor \
 c=0.0179041f //x=50.34 //y=6.2 //x2=50.12 //y2=5.56
cc_3276 ( N_noxref_9_c_3731_n N_noxref_10_c_4211_n ) capacitor c=0.00291477f \
 //x=50.265 //y=4.97 //x2=50.12 //y2=5.56
cc_3277 ( N_noxref_9_c_3754_n N_noxref_11_c_4597_n ) capacitor c=0.0140058f \
 //x=38.23 //y=3.335 //x2=37.49 //y2=2.375
cc_3278 ( N_noxref_9_c_3754_n N_noxref_11_c_4521_n ) capacitor c=0.0361648f \
 //x=38.23 //y=3.335 //x2=37.49 //y2=3.735
cc_3279 ( N_noxref_9_c_3760_n N_noxref_11_c_4521_n ) capacitor c=0.0148932f \
 //x=38.23 //y=3.655 //x2=37.49 //y2=3.735
cc_3280 ( N_noxref_9_c_3720_n N_noxref_11_c_4521_n ) capacitor c=0.00340923f \
 //x=38.23 //y=5.25 //x2=37.49 //y2=3.735
cc_3281 ( N_noxref_9_c_3831_p N_noxref_11_c_4521_n ) capacitor c=9.19401e-19 \
 //x=38.23 //y=3.51 //x2=37.49 //y2=3.735
cc_3282 ( N_noxref_9_c_3771_n N_noxref_11_c_4521_n ) capacitor c=0.0210812f \
 //x=38.07 //y=3.495 //x2=37.49 //y2=3.735
cc_3283 ( N_noxref_9_c_3775_n N_noxref_11_c_4521_n ) capacitor c=0.00336755f \
 //x=38.39 //y=3.495 //x2=37.49 //y2=3.735
cc_3284 ( N_noxref_9_c_3718_n N_noxref_11_c_4604_n ) capacitor c=8.13142e-19 \
 //x=37.335 //y=5.335 //x2=37.49 //y2=4.055
cc_3285 ( N_noxref_9_c_3815_n N_noxref_11_c_4604_n ) capacitor c=9.7144e-19 \
 //x=38.145 //y=5.335 //x2=37.49 //y2=4.055
cc_3286 ( N_noxref_9_c_3753_n N_noxref_11_c_4604_n ) capacitor c=8.07658e-19 \
 //x=37.83 //y=1.845 //x2=37.49 //y2=4.055
cc_3287 ( N_noxref_9_c_3720_n N_noxref_11_c_4604_n ) capacitor c=0.01761f \
 //x=38.23 //y=5.25 //x2=37.49 //y2=4.055
cc_3288 ( N_noxref_9_c_3771_n N_noxref_11_c_4604_n ) capacitor c=0.00611939f \
 //x=38.07 //y=3.495 //x2=37.49 //y2=4.055
cc_3289 ( N_noxref_9_c_3815_n N_noxref_11_c_4499_n ) capacitor c=0.00198098f \
 //x=38.145 //y=5.335 //x2=37.49 //y2=4.75
cc_3290 ( N_noxref_9_c_3720_n N_noxref_11_c_4499_n ) capacitor c=0.0390512f \
 //x=38.23 //y=5.25 //x2=37.49 //y2=4.75
cc_3291 ( N_noxref_9_c_3841_p N_noxref_11_c_4499_n ) capacitor c=0.018645f \
 //x=37.45 //y=5.335 //x2=37.49 //y2=4.75
cc_3292 ( N_noxref_9_c_3842_p N_noxref_11_c_4499_n ) capacitor c=0.00217979f \
 //x=37.45 //y=5.56 //x2=37.49 //y2=4.75
cc_3293 ( N_noxref_9_c_3768_n N_noxref_11_c_4528_n ) capacitor c=0.0214961f \
 //x=49.535 //y=3.51 //x2=42.3 //y2=3.735
cc_3294 ( N_noxref_9_c_3768_n N_noxref_11_c_4540_n ) capacitor c=0.00642248f \
 //x=49.535 //y=3.51 //x2=42.3 //y2=4.055
cc_3295 ( N_noxref_9_c_3845_p N_noxref_11_c_4615_n ) capacitor c=0.0034682f \
 //x=49.7 //y=2.375 //x2=47.85 //y2=3.735
cc_3296 ( N_noxref_9_c_3846_p N_noxref_11_c_4615_n ) capacitor c=0.0130127f \
 //x=49.7 //y=3.35 //x2=47.85 //y2=3.735
cc_3297 ( N_noxref_9_c_3847_p N_noxref_11_c_4615_n ) capacitor c=0.00255078f \
 //x=49.7 //y=3.67 //x2=47.85 //y2=3.735
cc_3298 ( N_noxref_9_c_3723_n N_noxref_11_c_4615_n ) capacitor c=0.0011073f \
 //x=49.7 //y=4.755 //x2=47.85 //y2=3.735
cc_3299 ( N_noxref_9_c_3768_n N_noxref_11_c_4615_n ) capacitor c=0.0225414f \
 //x=49.535 //y=3.51 //x2=47.85 //y2=3.735
cc_3300 ( N_noxref_9_c_3850_p N_noxref_11_c_4615_n ) capacitor c=0.00158465f \
 //x=49.695 //y=3.51 //x2=47.85 //y2=3.735
cc_3301 ( N_noxref_9_c_3723_n N_noxref_11_c_4621_n ) capacitor c=0.0025694f \
 //x=49.7 //y=4.755 //x2=47.85 //y2=4.055
cc_3302 ( N_noxref_9_c_3768_n N_noxref_11_c_4621_n ) capacitor c=0.00926238f \
 //x=49.535 //y=3.51 //x2=47.85 //y2=4.055
cc_3303 ( N_noxref_9_c_3723_n N_noxref_11_c_4505_n ) capacitor c=0.00992894f \
 //x=49.7 //y=4.755 //x2=47.85 //y2=5.25
cc_3304 ( N_noxref_9_c_3720_n N_noxref_11_c_4624_n ) capacitor c=9.19401e-19 \
 //x=38.23 //y=5.25 //x2=37.49 //y2=3.88
cc_3305 ( N_noxref_9_c_3768_n N_noxref_11_c_4556_n ) capacitor c=0.450598f \
 //x=49.535 //y=3.51 //x2=47.68 //y2=3.88
cc_3306 ( N_noxref_9_c_3847_p N_noxref_11_c_4626_n ) capacitor c=0.00269024f \
 //x=49.7 //y=3.67 //x2=49.91 //y2=3.895
cc_3307 ( N_noxref_9_c_3723_n N_noxref_11_c_4626_n ) capacitor c=0.0237144f \
 //x=49.7 //y=4.755 //x2=49.91 //y2=3.895
cc_3308 ( N_noxref_9_c_3847_p N_noxref_11_c_4628_n ) capacitor c=0.00347895f \
 //x=49.7 //y=3.67 //x2=49.565 //y2=3.895
cc_3309 ( N_noxref_9_c_3723_n N_noxref_11_c_4628_n ) capacitor c=0.00196004f \
 //x=49.7 //y=4.755 //x2=49.565 //y2=3.895
cc_3310 ( N_noxref_9_c_3768_n N_noxref_11_c_4628_n ) capacitor c=0.170154f \
 //x=49.535 //y=3.51 //x2=49.565 //y2=3.895
cc_3311 ( N_noxref_9_c_3850_p N_noxref_11_c_4628_n ) capacitor c=0.0358254f \
 //x=49.695 //y=3.51 //x2=49.565 //y2=3.895
cc_3312 ( N_noxref_9_c_3720_n N_noxref_11_c_4632_n ) capacitor c=0.00336755f \
 //x=38.23 //y=5.25 //x2=37.65 //y2=3.895
cc_3313 ( N_noxref_9_c_3771_n N_noxref_11_c_4632_n ) capacitor c=0.0358686f \
 //x=38.07 //y=3.495 //x2=37.65 //y2=3.895
cc_3314 ( N_noxref_9_c_3760_n N_noxref_11_c_4531_n ) capacitor c=0.00917068f \
 //x=38.23 //y=3.655 //x2=42.14 //y2=3.895
cc_3315 ( N_noxref_9_c_3720_n N_noxref_11_c_4531_n ) capacitor c=0.0216307f \
 //x=38.23 //y=5.25 //x2=42.14 //y2=3.895
cc_3316 ( N_noxref_9_c_3768_n N_noxref_11_c_4531_n ) capacitor c=0.323902f \
 //x=49.535 //y=3.51 //x2=42.14 //y2=3.895
cc_3317 ( N_noxref_9_c_3771_n N_noxref_11_c_4531_n ) capacitor c=0.035195f \
 //x=38.07 //y=3.495 //x2=42.14 //y2=3.895
cc_3318 ( N_noxref_9_c_3775_n N_noxref_11_c_4531_n ) capacitor c=0.0358686f \
 //x=38.39 //y=3.495 //x2=42.14 //y2=3.895
cc_3319 ( N_noxref_9_c_3768_n N_noxref_11_c_4558_n ) capacitor c=0.0358686f \
 //x=49.535 //y=3.51 //x2=42.46 //y2=3.895
cc_3320 ( N_noxref_9_c_3754_n N_noxref_11_c_4640_n ) capacitor c=0.0015536f \
 //x=38.23 //y=3.335 //x2=37.49 //y2=2.26
cc_3321 ( N_noxref_9_c_3815_n N_noxref_11_c_4641_n ) capacitor c=0.00130631f \
 //x=38.145 //y=5.335 //x2=37.49 //y2=4.88
cc_3322 ( N_noxref_9_c_3720_n N_noxref_11_c_4641_n ) capacitor c=0.00126408f \
 //x=38.23 //y=5.25 //x2=37.49 //y2=4.88
cc_3323 ( N_noxref_9_c_3841_p N_noxref_11_c_4641_n ) capacitor c=0.00346456f \
 //x=37.45 //y=5.335 //x2=37.49 //y2=4.88
cc_3324 ( N_noxref_9_c_3842_p N_noxref_11_c_4641_n ) capacitor c=0.00624059f \
 //x=37.45 //y=5.56 //x2=37.49 //y2=4.88
cc_3325 ( N_noxref_9_c_3718_n N_noxref_11_M107_noxref_g ) capacitor \
 c=0.00875663f //x=37.335 //y=5.335 //x2=37.23 //y2=6.2
cc_3326 ( N_noxref_9_c_3814_n N_noxref_11_M107_noxref_g ) capacitor \
 c=0.00226521f //x=37.45 //y=5.56 //x2=37.23 //y2=6.2
cc_3327 ( N_noxref_9_c_3842_p N_noxref_11_M107_noxref_g ) capacitor \
 c=0.0178885f //x=37.45 //y=5.56 //x2=37.23 //y2=6.2
cc_3328 ( N_noxref_9_c_3814_n N_noxref_11_M108_noxref_g ) capacitor \
 c=0.00381703f //x=37.45 //y=5.56 //x2=37.67 //y2=6.2
cc_3329 ( N_noxref_9_c_3815_n N_noxref_11_M108_noxref_g ) capacitor \
 c=0.0106307f //x=38.145 //y=5.335 //x2=37.67 //y2=6.2
cc_3330 ( N_noxref_9_c_3842_p N_noxref_11_M108_noxref_g ) capacitor \
 c=0.0188608f //x=37.45 //y=5.56 //x2=37.67 //y2=6.2
cc_3331 ( N_noxref_9_c_3881_p N_noxref_11_c_4651_n ) capacitor c=4.64015e-19 \
 //x=37.745 //y=1.305 //x2=37.48 //y2=1.095
cc_3332 ( N_noxref_9_M23_noxref_d N_noxref_11_c_4651_n ) capacitor \
 c=0.00137165f //x=37.555 //y=1.095 //x2=37.48 //y2=1.095
cc_3333 ( N_noxref_9_c_3881_p N_noxref_11_c_4653_n ) capacitor c=0.0026012f \
 //x=37.745 //y=1.305 //x2=37.48 //y2=1.44
cc_3334 ( N_noxref_9_c_3884_p N_noxref_11_c_4653_n ) capacitor c=0.00127432f \
 //x=37.745 //y=1.76 //x2=37.48 //y2=1.44
cc_3335 ( N_noxref_9_M23_noxref_d N_noxref_11_c_4653_n ) capacitor \
 c=0.00237422f //x=37.555 //y=1.095 //x2=37.48 //y2=1.44
cc_3336 ( N_noxref_9_c_3884_p N_noxref_11_c_4656_n ) capacitor c=0.00429966f \
 //x=37.745 //y=1.76 //x2=37.48 //y2=1.75
cc_3337 ( N_noxref_9_c_3881_p N_noxref_11_c_4657_n ) capacitor c=5.29969e-19 \
 //x=37.745 //y=1.305 //x2=37.855 //y2=0.94
cc_3338 ( N_noxref_9_M23_noxref_d N_noxref_11_c_4657_n ) capacitor \
 c=0.0020782f //x=37.555 //y=1.095 //x2=37.855 //y2=0.94
cc_3339 ( N_noxref_9_c_3881_p N_noxref_11_c_4659_n ) capacitor c=5.18355e-19 \
 //x=37.745 //y=1.305 //x2=37.855 //y2=1.595
cc_3340 ( N_noxref_9_c_3884_p N_noxref_11_c_4659_n ) capacitor c=0.00942306f \
 //x=37.745 //y=1.76 //x2=37.855 //y2=1.595
cc_3341 ( N_noxref_9_c_3816_n N_noxref_11_c_4659_n ) capacitor c=0.00194716f \
 //x=38.145 //y=1.845 //x2=37.855 //y2=1.595
cc_3342 ( N_noxref_9_M23_noxref_d N_noxref_11_c_4659_n ) capacitor \
 c=0.00356097f //x=37.555 //y=1.095 //x2=37.855 //y2=1.595
cc_3343 ( N_noxref_9_c_3881_p N_noxref_11_c_4663_n ) capacitor c=5.24634e-19 \
 //x=37.745 //y=1.305 //x2=38.01 //y2=1.095
cc_3344 ( N_noxref_9_M23_noxref_d N_noxref_11_c_4663_n ) capacitor \
 c=0.00139206f //x=37.555 //y=1.095 //x2=38.01 //y2=1.095
cc_3345 ( N_noxref_9_c_3881_p N_noxref_11_c_4665_n ) capacitor c=0.00307978f \
 //x=37.745 //y=1.305 //x2=38.01 //y2=1.44
cc_3346 ( N_noxref_9_c_3884_p N_noxref_11_c_4665_n ) capacitor c=0.00363411f \
 //x=37.745 //y=1.76 //x2=38.01 //y2=1.44
cc_3347 ( N_noxref_9_c_3816_n N_noxref_11_c_4665_n ) capacitor c=0.00323576f \
 //x=38.145 //y=1.845 //x2=38.01 //y2=1.44
cc_3348 ( N_noxref_9_M23_noxref_d N_noxref_11_c_4665_n ) capacitor \
 c=0.00237422f //x=37.555 //y=1.095 //x2=38.01 //y2=1.44
cc_3349 ( N_noxref_9_c_3754_n N_noxref_11_c_4669_n ) capacitor c=0.0024584f \
 //x=38.23 //y=3.335 //x2=37.49 //y2=2.26
cc_3350 ( N_noxref_9_c_3884_p N_noxref_11_c_4670_n ) capacitor c=0.0036273f \
 //x=37.745 //y=1.76 //x2=37.49 //y2=2.095
cc_3351 ( N_noxref_9_c_3754_n N_noxref_11_c_4670_n ) capacitor c=0.00282067f \
 //x=38.23 //y=3.335 //x2=37.49 //y2=2.095
cc_3352 ( N_noxref_9_c_3720_n N_noxref_11_c_4518_n ) capacitor c=0.00714556f \
 //x=38.23 //y=5.25 //x2=37.49 //y2=4.88
cc_3353 ( N_noxref_9_c_3841_p N_noxref_11_c_4518_n ) capacitor c=0.00203307f \
 //x=37.45 //y=5.335 //x2=37.49 //y2=4.88
cc_3354 ( N_noxref_9_c_3842_p N_noxref_11_c_4518_n ) capacitor c=0.00375636f \
 //x=37.45 //y=5.56 //x2=37.49 //y2=4.88
cc_3355 ( N_noxref_9_c_3735_n D ) capacitor c=0.00166215f //x=32.68 //y=3.355 \
 //x2=30.46 //y2=2.77
cc_3356 ( N_noxref_9_c_3715_n D ) capacitor c=3.61617e-19 //x=32.68 //y=4.75 \
 //x2=30.46 //y2=2.77
cc_3357 ( N_noxref_9_c_3715_n N_D_c_5147_n ) capacitor c=3.10153e-19 //x=32.68 \
 //y=4.75 //x2=30.46 //y2=4.755
cc_3358 ( N_noxref_9_c_3720_n N_D_c_5190_n ) capacitor c=0.0241507f //x=38.23 \
 //y=5.25 //x2=37.705 //y2=4.28
cc_3359 ( N_noxref_9_c_3768_n N_D_c_5190_n ) capacitor c=0.0269461f //x=49.535 \
 //y=3.51 //x2=37.705 //y2=4.28
cc_3360 ( N_noxref_9_c_3771_n N_D_c_5190_n ) capacitor c=0.002911f //x=38.07 \
 //y=3.495 //x2=37.705 //y2=4.28
cc_3361 ( N_noxref_9_c_3742_n N_D_c_5173_n ) capacitor c=0.00311914f //x=32.68 \
 //y=3.675 //x2=37.36 //y2=4.28
cc_3362 ( N_noxref_9_c_3715_n N_D_c_5173_n ) capacitor c=0.0242324f //x=32.68 \
 //y=4.75 //x2=37.36 //y2=4.28
cc_3363 ( N_noxref_9_c_3770_n N_D_c_5173_n ) capacitor c=0.0158459f //x=32.85 \
 //y=3.515 //x2=37.36 //y2=4.28
cc_3364 ( N_noxref_9_c_3771_n N_D_c_5173_n ) capacitor c=0.194971f //x=38.07 \
 //y=3.495 //x2=37.36 //y2=4.28
cc_3365 ( N_noxref_9_c_3768_n N_D_c_5222_n ) capacitor c=0.0413349f //x=49.535 \
 //y=3.51 //x2=42.595 //y2=4.3
cc_3366 ( N_noxref_9_c_3768_n N_D_c_5198_n ) capacitor c=0.00404818f \
 //x=49.535 //y=3.51 //x2=47.455 //y2=4.25
cc_3367 ( N_noxref_9_c_3723_n N_D_c_5202_n ) capacitor c=4.8624e-19 //x=49.7 \
 //y=4.755 //x2=48.055 //y2=4.28
cc_3368 ( N_noxref_9_c_3768_n N_D_c_5202_n ) capacitor c=0.00963112f \
 //x=49.535 //y=3.51 //x2=48.055 //y2=4.28
cc_3369 ( N_noxref_9_c_3723_n N_D_c_5203_n ) capacitor c=0.0245517f //x=49.7 \
 //y=4.755 //x2=56.345 //y2=4.25
cc_3370 ( N_noxref_9_c_3754_n CLK ) capacitor c=0.00130644f //x=38.23 \
 //y=3.335 //x2=36.38 //y2=3.88
cc_3371 ( N_noxref_9_c_3720_n CLK ) capacitor c=0.00169781f //x=38.23 //y=5.25 \
 //x2=36.38 //y2=3.88
cc_3372 ( N_noxref_9_c_3771_n CLK ) capacitor c=0.0261857f //x=38.07 //y=3.495 \
 //x2=36.38 //y2=3.88
cc_3373 ( N_noxref_9_c_3768_n CLK ) capacitor c=0.0235252f //x=49.535 //y=3.51 \
 //x2=46 //y2=2.77
cc_3374 ( N_noxref_9_c_3716_n N_CLK_c_6592_n ) capacitor c=0.0211029f \
 //x=36.45 //y=5.335 //x2=36.375 //y2=4.835
cc_3375 ( N_noxref_9_c_3726_n N_CLK_c_6592_n ) capacitor c=0.00474857f \
 //x=36.57 //y=5.335 //x2=36.375 //y2=4.835
cc_3376 ( N_noxref_9_c_3926_p N_CLK_c_6592_n ) capacitor c=0.00134045f \
 //x=36.57 //y=5.56 //x2=36.375 //y2=4.835
cc_3377 ( N_noxref_9_c_3720_n N_CLK_c_6616_n ) capacitor c=0.0233014f \
 //x=38.23 //y=5.25 //x2=45.845 //y2=4.62
cc_3378 ( N_noxref_9_c_3715_n N_CLK_c_6619_n ) capacitor c=0.0238767f \
 //x=32.68 //y=4.75 //x2=36.535 //y2=4.62
cc_3379 ( N_noxref_9_c_3771_n N_CLK_c_6619_n ) capacitor c=0.0182459f \
 //x=38.07 //y=3.495 //x2=36.535 //y2=4.62
cc_3380 ( N_noxref_9_c_3723_n N_CLK_c_6623_n ) capacitor c=0.0269264f //x=49.7 \
 //y=4.755 //x2=59.19 //y2=4.635
cc_3381 ( N_noxref_9_c_3716_n N_CLK_c_6672_n ) capacitor c=0.00462965f \
 //x=36.45 //y=5.335 //x2=36.38 //y2=4.88
cc_3382 ( N_noxref_9_c_3726_n N_CLK_c_6672_n ) capacitor c=0.00132214f \
 //x=36.57 //y=5.335 //x2=36.38 //y2=4.88
cc_3383 ( N_noxref_9_c_3716_n N_CLK_M105_noxref_g ) capacitor c=0.00856454f \
 //x=36.45 //y=5.335 //x2=36.35 //y2=6.2
cc_3384 ( N_noxref_9_c_3726_n N_CLK_M105_noxref_g ) capacitor c=0.00229818f \
 //x=36.57 //y=5.335 //x2=36.35 //y2=6.2
cc_3385 ( N_noxref_9_c_3926_p N_CLK_M105_noxref_g ) capacitor c=0.0179041f \
 //x=36.57 //y=5.56 //x2=36.35 //y2=6.2
cc_3386 ( N_noxref_9_c_3718_n N_CLK_M106_noxref_g ) capacitor c=0.00951465f \
 //x=37.335 //y=5.335 //x2=36.79 //y2=6.2
cc_3387 ( N_noxref_9_c_3726_n N_CLK_M106_noxref_g ) capacitor c=0.00230699f \
 //x=36.57 //y=5.335 //x2=36.79 //y2=6.2
cc_3388 ( N_noxref_9_c_3926_p N_CLK_M106_noxref_g ) capacitor c=0.0179041f \
 //x=36.57 //y=5.56 //x2=36.79 //y2=6.2
cc_3389 ( N_noxref_9_c_3726_n N_CLK_c_6647_n ) capacitor c=0.00188023f \
 //x=36.57 //y=5.335 //x2=36.715 //y2=4.97
cc_3390 ( N_noxref_9_c_3926_p N_CLK_c_6647_n ) capacitor c=0.00293647f \
 //x=36.57 //y=5.56 //x2=36.715 //y2=4.97
cc_3391 ( N_noxref_9_c_3716_n N_CLK_c_6690_n ) capacitor c=3.34061e-19 \
 //x=36.45 //y=5.335 //x2=36.38 //y2=4.88
cc_3392 ( N_noxref_9_c_3735_n RN ) capacitor c=0.0204772f //x=32.68 //y=3.355 \
 //x2=31.57 //y2=2.77
cc_3393 ( N_noxref_9_c_3742_n RN ) capacitor c=0.00763467f //x=32.68 //y=3.675 \
 //x2=31.57 //y2=2.77
cc_3394 ( N_noxref_9_c_3715_n RN ) capacitor c=0.0274246f //x=32.68 //y=4.75 \
 //x2=31.57 //y2=2.77
cc_3395 ( N_noxref_9_c_3762_n RN ) capacitor c=2.98349e-19 //x=32.68 //y=3.51 \
 //x2=31.57 //y2=2.77
cc_3396 ( N_noxref_9_c_3770_n RN ) capacitor c=0.00504602f //x=32.85 //y=3.515 \
 //x2=31.57 //y2=2.77
cc_3397 ( N_noxref_9_c_3777_n RN ) capacitor c=2.94497e-19 //x=32.68 //y=4.88 \
 //x2=31.57 //y2=2.77
cc_3398 ( N_noxref_9_c_3846_p RN ) capacitor c=0.00148823f //x=49.7 //y=3.35 \
 //x2=47.11 //y2=2.77
cc_3399 ( N_noxref_9_c_3723_n RN ) capacitor c=0.00146042f //x=49.7 //y=4.755 \
 //x2=47.11 //y2=2.77
cc_3400 ( N_noxref_9_c_3768_n RN ) capacitor c=0.0220806f //x=49.535 //y=3.51 \
 //x2=47.11 //y2=2.77
cc_3401 ( N_noxref_9_c_3846_p RN ) capacitor c=0.0203848f //x=49.7 //y=3.35 \
 //x2=50.81 //y2=2.77
cc_3402 ( N_noxref_9_c_3847_p RN ) capacitor c=0.00769355f //x=49.7 //y=3.67 \
 //x2=50.81 //y2=2.77
cc_3403 ( N_noxref_9_c_3723_n RN ) capacitor c=0.0242557f //x=49.7 //y=4.755 \
 //x2=50.81 //y2=2.77
cc_3404 ( N_noxref_9_c_3954_p RN ) capacitor c=2.61099e-19 //x=49.695 //y=3.51 \
 //x2=50.81 //y2=2.77
cc_3405 ( N_noxref_9_c_3850_p RN ) capacitor c=0.0032986f //x=49.695 //y=3.51 \
 //x2=50.81 //y2=2.77
cc_3406 ( N_noxref_9_c_3956_p RN ) capacitor c=3.36194e-19 //x=49.7 //y=4.88 \
 //x2=50.81 //y2=2.77
cc_3407 ( N_noxref_9_c_3734_n N_RN_c_8182_n ) capacitor c=0.00806473f \
 //x=32.68 //y=2.375 //x2=31.57 //y2=2.56
cc_3408 ( N_noxref_9_c_3735_n N_RN_c_8182_n ) capacitor c=0.00361597f \
 //x=32.68 //y=3.355 //x2=31.57 //y2=2.56
cc_3409 ( N_noxref_9_c_3776_n N_RN_c_8182_n ) capacitor c=0.00116634f \
 //x=32.68 //y=2.26 //x2=31.57 //y2=2.56
cc_3410 ( N_noxref_9_c_3808_n N_RN_c_8182_n ) capacitor c=0.00149512f \
 //x=32.68 //y=2.26 //x2=31.57 //y2=2.56
cc_3411 ( N_noxref_9_c_3715_n N_RN_c_8124_n ) capacitor c=0.00753615f \
 //x=32.68 //y=4.75 //x2=31.57 //y2=4.765
cc_3412 ( N_noxref_9_c_3777_n N_RN_c_8124_n ) capacitor c=4.41153e-19 \
 //x=32.68 //y=4.88 //x2=31.57 //y2=4.765
cc_3413 ( N_noxref_9_c_3733_n N_RN_c_8124_n ) capacitor c=0.00118533f \
 //x=32.68 //y=4.88 //x2=31.57 //y2=4.765
cc_3414 ( N_noxref_9_c_3845_p N_RN_c_8258_n ) capacitor c=0.00820823f //x=49.7 \
 //y=2.375 //x2=50.81 //y2=2.57
cc_3415 ( N_noxref_9_c_3846_p N_RN_c_8258_n ) capacitor c=0.00387426f //x=49.7 \
 //y=3.35 //x2=50.81 //y2=2.57
cc_3416 ( N_noxref_9_c_3966_p N_RN_c_8258_n ) capacitor c=0.00116826f //x=49.7 \
 //y=2.26 //x2=50.81 //y2=2.57
cc_3417 ( N_noxref_9_c_3967_p N_RN_c_8258_n ) capacitor c=0.00158832f //x=49.4 \
 //y=2.095 //x2=50.81 //y2=2.57
cc_3418 ( N_noxref_9_c_3723_n N_RN_c_8126_n ) capacitor c=0.00776434f //x=49.7 \
 //y=4.755 //x2=50.81 //y2=4.765
cc_3419 ( N_noxref_9_c_3956_p N_RN_c_8126_n ) capacitor c=2.84663e-19 //x=49.7 \
 //y=4.88 //x2=50.81 //y2=4.765
cc_3420 ( N_noxref_9_c_3731_n N_RN_c_8126_n ) capacitor c=6.98043e-19 \
 //x=50.265 //y=4.97 //x2=50.81 //y2=4.765
cc_3421 ( N_noxref_9_c_3732_n N_RN_c_8126_n ) capacitor c=7.54501e-19 \
 //x=49.975 //y=4.97 //x2=50.81 //y2=4.765
cc_3422 ( N_noxref_9_c_3734_n N_RN_c_8024_n ) capacitor c=0.0174431f //x=32.68 \
 //y=2.375 //x2=42.825 //y2=2.385
cc_3423 ( N_noxref_9_c_3735_n N_RN_c_8024_n ) capacitor c=0.0166553f //x=32.68 \
 //y=3.355 //x2=42.825 //y2=2.385
cc_3424 ( N_noxref_9_c_3881_p N_RN_c_8024_n ) capacitor c=7.15814e-19 \
 //x=37.745 //y=1.305 //x2=42.825 //y2=2.385
cc_3425 ( N_noxref_9_c_3753_n N_RN_c_8024_n ) capacitor c=0.0211903f //x=37.83 \
 //y=1.845 //x2=42.825 //y2=2.385
cc_3426 ( N_noxref_9_c_3754_n N_RN_c_8024_n ) capacitor c=0.0277836f //x=38.23 \
 //y=3.335 //x2=42.825 //y2=2.385
cc_3427 ( N_noxref_9_c_3768_n N_RN_c_8024_n ) capacitor c=0.0144654f \
 //x=49.535 //y=3.51 //x2=42.825 //y2=2.385
cc_3428 ( N_noxref_9_c_3771_n N_RN_c_8024_n ) capacitor c=0.00220308f \
 //x=38.07 //y=3.495 //x2=42.825 //y2=2.385
cc_3429 ( N_noxref_9_c_3808_n N_RN_c_8024_n ) capacitor c=3.41298e-19 \
 //x=32.68 //y=2.26 //x2=42.825 //y2=2.385
cc_3430 ( N_noxref_9_c_3768_n N_RN_c_8229_n ) capacitor c=8.6713e-19 \
 //x=49.535 //y=3.51 //x2=45.115 //y2=2.385
cc_3431 ( N_noxref_9_c_3845_p N_RN_c_8275_n ) capacitor c=0.0165384f //x=49.7 \
 //y=2.375 //x2=50.645 //y2=2.4
cc_3432 ( N_noxref_9_c_3846_p N_RN_c_8275_n ) capacitor c=0.0167844f //x=49.7 \
 //y=3.35 //x2=50.645 //y2=2.4
cc_3433 ( N_noxref_9_c_3768_n N_RN_c_8275_n ) capacitor c=0.0101903f \
 //x=49.535 //y=3.51 //x2=50.645 //y2=2.4
cc_3434 ( N_noxref_9_c_3966_p N_RN_c_8275_n ) capacitor c=2.54369e-19 //x=49.7 \
 //y=2.26 //x2=50.645 //y2=2.4
cc_3435 ( N_noxref_9_c_3967_p N_RN_c_8275_n ) capacitor c=3.41298e-19 //x=49.4 \
 //y=2.095 //x2=50.645 //y2=2.4
cc_3436 ( N_noxref_9_c_3768_n N_RN_c_8235_n ) capacitor c=0.00983057f \
 //x=49.535 //y=3.51 //x2=47.275 //y2=2.4
cc_3437 ( N_noxref_9_c_3845_p N_RN_c_8281_n ) capacitor c=0.00149687f //x=49.7 \
 //y=2.375 //x2=52.49 //y2=2.37
cc_3438 ( N_noxref_9_c_3846_p N_RN_c_8281_n ) capacitor c=0.00137876f //x=49.7 \
 //y=3.35 //x2=52.49 //y2=2.37
cc_3439 ( N_noxref_9_c_3734_n N_RN_c_8283_n ) capacitor c=5.39999e-19 \
 //x=32.68 //y=2.375 //x2=31.57 //y2=2.26
cc_3440 ( N_noxref_9_c_3776_n N_RN_c_8283_n ) capacitor c=0.00124907f \
 //x=32.68 //y=2.26 //x2=31.57 //y2=2.26
cc_3441 ( N_noxref_9_c_3808_n N_RN_c_8283_n ) capacitor c=0.00204796f \
 //x=32.68 //y=2.26 //x2=31.57 //y2=2.26
cc_3442 ( N_noxref_9_c_3715_n N_RN_c_8150_n ) capacitor c=9.36945e-19 \
 //x=32.68 //y=4.75 //x2=31.57 //y2=4.88
cc_3443 ( N_noxref_9_c_3777_n N_RN_c_8150_n ) capacitor c=0.00113985f \
 //x=32.68 //y=4.88 //x2=31.57 //y2=4.88
cc_3444 ( N_noxref_9_c_3733_n N_RN_c_8150_n ) capacitor c=0.00187046f \
 //x=32.68 //y=4.88 //x2=31.57 //y2=4.88
cc_3445 ( N_noxref_9_c_3845_p N_RN_c_8289_n ) capacitor c=5.39999e-19 //x=49.7 \
 //y=2.375 //x2=50.81 //y2=2.26
cc_3446 ( N_noxref_9_c_3966_p N_RN_c_8289_n ) capacitor c=0.00124906f //x=49.7 \
 //y=2.26 //x2=50.81 //y2=2.26
cc_3447 ( N_noxref_9_c_3967_p N_RN_c_8289_n ) capacitor c=0.00214501f //x=49.4 \
 //y=2.095 //x2=50.81 //y2=2.26
cc_3448 ( N_noxref_9_c_3723_n N_RN_c_8151_n ) capacitor c=8.93844e-19 //x=49.7 \
 //y=4.755 //x2=50.81 //y2=4.88
cc_3449 ( N_noxref_9_c_3956_p N_RN_c_8151_n ) capacitor c=0.00113984f //x=49.7 \
 //y=4.88 //x2=50.81 //y2=4.88
cc_3450 ( N_noxref_9_c_3731_n N_RN_c_8151_n ) capacitor c=0.00116563f \
 //x=50.265 //y=4.97 //x2=50.81 //y2=4.88
cc_3451 ( N_noxref_9_c_3732_n N_RN_c_8151_n ) capacitor c=0.00129812f \
 //x=49.975 //y=4.97 //x2=50.81 //y2=4.88
cc_3452 ( N_noxref_9_M101_noxref_g N_RN_M99_noxref_g ) capacitor c=0.0101598f \
 //x=32.42 //y=6.2 //x2=31.54 //y2=6.2
cc_3453 ( N_noxref_9_M101_noxref_g N_RN_M100_noxref_g ) capacitor c=0.0607518f \
 //x=32.42 //y=6.2 //x2=31.98 //y2=6.2
cc_3454 ( N_noxref_9_M102_noxref_g N_RN_M100_noxref_g ) capacitor c=0.0101598f \
 //x=32.86 //y=6.2 //x2=31.98 //y2=6.2
cc_3455 ( N_noxref_9_M121_noxref_g N_RN_M123_noxref_g ) capacitor c=0.0106276f \
 //x=49.9 //y=6.2 //x2=50.78 //y2=6.2
cc_3456 ( N_noxref_9_M122_noxref_g N_RN_M123_noxref_g ) capacitor c=0.107144f \
 //x=50.34 //y=6.2 //x2=50.78 //y2=6.2
cc_3457 ( N_noxref_9_M122_noxref_g N_RN_M124_noxref_g ) capacitor c=0.0101598f \
 //x=50.34 //y=6.2 //x2=51.22 //y2=6.2
cc_3458 ( N_noxref_9_c_3790_n N_RN_c_8302_n ) capacitor c=0.00456962f \
 //x=32.67 //y=1.095 //x2=31.66 //y2=1.09
cc_3459 ( N_noxref_9_c_3792_n N_RN_c_8303_n ) capacitor c=0.00438372f \
 //x=32.67 //y=1.44 //x2=31.66 //y2=1.4
cc_3460 ( N_noxref_9_c_3795_n N_RN_c_8304_n ) capacitor c=0.00438372f \
 //x=32.67 //y=1.75 //x2=31.66 //y2=1.63
cc_3461 ( N_noxref_9_c_3734_n N_RN_c_8305_n ) capacitor c=6.57681e-19 \
 //x=32.68 //y=2.375 //x2=31.66 //y2=2.095
cc_3462 ( N_noxref_9_c_3776_n N_RN_c_8305_n ) capacitor c=0.00177608f \
 //x=32.68 //y=2.26 //x2=31.66 //y2=2.095
cc_3463 ( N_noxref_9_c_3808_n N_RN_c_8305_n ) capacitor c=0.00873247f \
 //x=32.68 //y=2.26 //x2=31.66 //y2=2.095
cc_3464 ( N_noxref_9_c_3809_n N_RN_c_8305_n ) capacitor c=0.00438372f \
 //x=32.68 //y=2.095 //x2=31.66 //y2=2.095
cc_3465 ( N_noxref_9_c_3733_n N_RN_c_8173_n ) capacitor c=0.0616777f //x=32.68 \
 //y=4.88 //x2=31.905 //y2=4.97
cc_3466 ( N_noxref_9_c_4016_p N_RN_c_8310_n ) capacitor c=5.72528e-19 //x=49.4 \
 //y=1.055 //x2=50.375 //y2=1.09
cc_3467 ( N_noxref_9_c_4017_p N_RN_c_8310_n ) capacitor c=0.00150277f //x=49.4 \
 //y=1.4 //x2=50.375 //y2=1.09
cc_3468 ( N_noxref_9_c_4018_p N_RN_c_8310_n ) capacitor c=0.0160123f //x=49.93 \
 //y=1.055 //x2=50.375 //y2=1.09
cc_3469 ( N_noxref_9_c_4019_p N_RN_c_8313_n ) capacitor c=0.00111227f //x=49.4 \
 //y=1.71 //x2=50.375 //y2=1.4
cc_3470 ( N_noxref_9_c_4020_p N_RN_c_8313_n ) capacitor c=0.0124075f //x=49.93 \
 //y=1.4 //x2=50.375 //y2=1.4
cc_3471 ( N_noxref_9_c_4018_p N_RN_c_8315_n ) capacitor c=9.19165e-19 \
 //x=49.93 //y=1.055 //x2=50.9 //y2=1.09
cc_3472 ( N_noxref_9_c_4020_p N_RN_c_8316_n ) capacitor c=0.0010154f //x=49.93 \
 //y=1.4 //x2=50.9 //y2=1.4
cc_3473 ( N_noxref_9_c_4020_p N_RN_c_8317_n ) capacitor c=9.23422e-19 \
 //x=49.93 //y=1.4 //x2=50.9 //y2=1.63
cc_3474 ( N_noxref_9_c_3845_p N_RN_c_8318_n ) capacitor c=6.79315e-19 //x=49.7 \
 //y=2.375 //x2=50.9 //y2=2.095
cc_3475 ( N_noxref_9_c_3966_p N_RN_c_8318_n ) capacitor c=0.00176374f //x=49.7 \
 //y=2.26 //x2=50.9 //y2=2.095
cc_3476 ( N_noxref_9_c_3967_p N_RN_c_8318_n ) capacitor c=0.00887699f //x=49.4 \
 //y=2.095 //x2=50.9 //y2=2.095
cc_3477 ( N_noxref_9_c_3715_n N_RN_c_8216_n ) capacitor c=8.42568e-19 \
 //x=32.68 //y=4.75 //x2=31.57 //y2=4.88
cc_3478 ( N_noxref_9_c_3777_n N_RN_c_8216_n ) capacitor c=0.00129812f \
 //x=32.68 //y=4.88 //x2=31.57 //y2=4.88
cc_3479 ( N_noxref_9_c_3733_n N_RN_c_8216_n ) capacitor c=0.00487508f \
 //x=32.68 //y=4.88 //x2=31.57 //y2=4.88
cc_3480 ( N_noxref_9_c_3723_n N_RN_c_8324_n ) capacitor c=0.00108708f //x=49.7 \
 //y=4.755 //x2=50.81 //y2=4.88
cc_3481 ( N_noxref_9_c_3956_p N_RN_c_8324_n ) capacitor c=0.00155973f //x=49.7 \
 //y=4.88 //x2=50.81 //y2=4.88
cc_3482 ( N_noxref_9_c_3731_n N_RN_c_8324_n ) capacitor c=0.0171374f \
 //x=50.265 //y=4.97 //x2=50.81 //y2=4.88
cc_3483 ( N_noxref_9_c_3732_n N_RN_c_8324_n ) capacitor c=0.00484466f \
 //x=49.975 //y=4.97 //x2=50.81 //y2=4.88
cc_3484 ( N_noxref_9_c_3754_n SN ) capacitor c=0.00102767f //x=38.23 //y=3.335 \
 //x2=41.19 //y2=2.77
cc_3485 ( N_noxref_9_c_3768_n N_SN_c_10114_n ) capacitor c=0.00592673f \
 //x=49.535 //y=3.51 //x2=41.19 //y2=3.285
cc_3486 ( N_noxref_9_c_3720_n N_SN_c_10068_n ) capacitor c=8.30912e-19 \
 //x=38.23 //y=5.25 //x2=41.19 //y2=4.765
cc_3487 ( N_noxref_9_c_3768_n N_SN_c_10068_n ) capacitor c=0.0229415f \
 //x=49.535 //y=3.51 //x2=41.19 //y2=4.765
cc_3488 ( N_noxref_9_c_3735_n N_SN_c_10119_n ) capacitor c=0.024888f //x=32.68 \
 //y=3.355 //x2=32.905 //y2=3.13
cc_3489 ( N_noxref_9_c_3742_n N_SN_c_10119_n ) capacitor c=0.00563294f \
 //x=32.68 //y=3.675 //x2=32.905 //y2=3.13
cc_3490 ( N_noxref_9_c_3770_n N_SN_c_10119_n ) capacitor c=0.0358686f \
 //x=32.85 //y=3.515 //x2=32.905 //y2=3.13
cc_3491 ( N_noxref_9_c_3771_n N_SN_c_10119_n ) capacitor c=0.0817066f \
 //x=38.07 //y=3.495 //x2=32.905 //y2=3.13
cc_3492 ( N_noxref_9_c_3735_n N_SN_c_9921_n ) capacitor c=2.5648e-19 //x=32.68 \
 //y=3.355 //x2=32.475 //y2=3.13
cc_3493 ( N_noxref_9_c_3771_n N_SN_c_10122_n ) capacitor c=0.111452f //x=38.07 \
 //y=3.495 //x2=33.64 //y2=3.17
cc_3494 ( N_noxref_9_c_3771_n N_SN_c_10126_n ) capacitor c=0.0595578f \
 //x=38.07 //y=3.495 //x2=34.89 //y2=3.14
cc_3495 ( N_noxref_9_c_3771_n N_SN_c_10131_n ) capacitor c=0.20009f //x=38.07 \
 //y=3.495 //x2=35.49 //y2=3.17
cc_3496 ( N_noxref_9_c_3754_n N_SN_c_10134_n ) capacitor c=6.24124e-19 \
 //x=38.23 //y=3.335 //x2=37.845 //y2=3.14
cc_3497 ( N_noxref_9_c_3771_n N_SN_c_10134_n ) capacitor c=0.0112023f \
 //x=38.07 //y=3.495 //x2=37.845 //y2=3.14
cc_3498 ( N_noxref_9_c_3754_n N_SN_c_10135_n ) capacitor c=0.0223718f \
 //x=38.23 //y=3.335 //x2=38.445 //y2=3.11
cc_3499 ( N_noxref_9_c_3760_n N_SN_c_10135_n ) capacitor c=0.00870162f \
 //x=38.23 //y=3.655 //x2=38.445 //y2=3.11
cc_3500 ( N_noxref_9_c_3768_n N_SN_c_10135_n ) capacitor c=0.121998f \
 //x=49.535 //y=3.51 //x2=38.445 //y2=3.11
cc_3501 ( N_noxref_9_c_3775_n N_SN_c_10135_n ) capacitor c=0.0358686f \
 //x=38.39 //y=3.495 //x2=38.445 //y2=3.11
cc_3502 ( N_noxref_9_c_3754_n N_SN_c_10137_n ) capacitor c=4.89619e-19 \
 //x=38.23 //y=3.335 //x2=39.695 //y2=3.14
cc_3503 ( N_noxref_9_c_3768_n N_SN_c_10137_n ) capacitor c=0.0595405f \
 //x=49.535 //y=3.51 //x2=39.695 //y2=3.14
cc_3504 ( N_noxref_9_c_3768_n N_SN_c_10178_n ) capacitor c=0.112359f \
 //x=49.535 //y=3.51 //x2=43.255 //y2=3.155
cc_3505 ( N_noxref_9_c_3768_n N_SN_c_10143_n ) capacitor c=0.266759f \
 //x=49.535 //y=3.51 //x2=42.91 //y2=3.155
cc_3506 ( N_noxref_9_c_3768_n N_SN_c_10184_n ) capacitor c=0.0578136f \
 //x=49.535 //y=3.51 //x2=44.515 //y2=3.14
cc_3507 ( N_noxref_9_c_3768_n N_SN_c_10188_n ) capacitor c=0.361595f \
 //x=49.535 //y=3.51 //x2=45.115 //y2=3.155
cc_3508 ( N_noxref_9_c_3846_p N_SN_c_10225_n ) capacitor c=4.64545e-19 \
 //x=49.7 //y=3.35 //x2=49.31 //y2=3.14
cc_3509 ( N_noxref_9_c_3847_p N_SN_c_10225_n ) capacitor c=0.00323523f \
 //x=49.7 //y=3.67 //x2=49.31 //y2=3.14
cc_3510 ( N_noxref_9_c_3768_n N_SN_c_10225_n ) capacitor c=0.010873f \
 //x=49.535 //y=3.51 //x2=49.31 //y2=3.14
cc_3511 ( N_noxref_9_c_3846_p N_SN_c_10228_n ) capacitor c=0.0265841f //x=49.7 \
 //y=3.35 //x2=49.91 //y2=3.125
cc_3512 ( N_noxref_9_c_3847_p N_SN_c_10228_n ) capacitor c=0.00485165f \
 //x=49.7 //y=3.67 //x2=49.91 //y2=3.125
cc_3513 ( N_noxref_9_c_3850_p N_SN_c_10228_n ) capacitor c=0.0358686f \
 //x=49.695 //y=3.51 //x2=49.91 //y2=3.125
cc_3514 ( N_noxref_9_c_3846_p N_noxref_22_c_12331_n ) capacitor c=0.00165433f \
 //x=49.7 //y=3.35 //x2=51.92 //y2=3.365
cc_3515 ( N_noxref_9_c_3723_n N_noxref_22_c_12247_n ) capacitor c=7.69262e-19 \
 //x=49.7 //y=4.755 //x2=51.92 //y2=4.75
cc_3516 ( N_noxref_9_c_3954_p N_noxref_22_c_12333_n ) capacitor c=8.84157e-19 \
 //x=49.695 //y=3.51 //x2=51.92 //y2=3.51
cc_3517 ( N_noxref_9_c_3850_p N_noxref_22_c_12334_n ) capacitor c=0.0022513f \
 //x=49.695 //y=3.51 //x2=52.08 //y2=3.51
cc_3518 ( N_noxref_9_c_3716_n N_VDD_c_13434_n ) capacitor c=0.00564708f \
 //x=36.45 //y=5.335 //x2=87.775 //y2=7.585
cc_3519 ( N_noxref_9_c_3718_n N_VDD_c_13434_n ) capacitor c=0.00565043f \
 //x=37.335 //y=5.335 //x2=87.775 //y2=7.585
cc_3520 ( N_noxref_9_c_3814_n N_VDD_c_13434_n ) capacitor c=0.00236065f \
 //x=37.45 //y=5.56 //x2=87.775 //y2=7.585
cc_3521 ( N_noxref_9_c_3815_n N_VDD_c_13434_n ) capacitor c=0.00753358f \
 //x=38.145 //y=5.335 //x2=87.775 //y2=7.585
cc_3522 ( N_noxref_9_c_3760_n N_VDD_c_13434_n ) capacitor c=2.75833e-19 \
 //x=38.23 //y=3.655 //x2=87.775 //y2=7.585
cc_3523 ( N_noxref_9_c_3847_p N_VDD_c_13434_n ) capacitor c=2.30885e-19 \
 //x=49.7 //y=3.67 //x2=87.775 //y2=7.585
cc_3524 ( N_noxref_9_c_3724_n N_VDD_c_13434_n ) capacitor c=0.00240598f \
 //x=35.692 //y=5.335 //x2=87.775 //y2=7.585
cc_3525 ( N_noxref_9_c_3726_n N_VDD_c_13434_n ) capacitor c=0.00245065f \
 //x=36.57 //y=5.335 //x2=87.775 //y2=7.585
cc_3526 ( N_noxref_9_c_3781_n N_VDD_c_13434_n ) capacitor c=0.0024232f \
 //x=35.69 //y=5.56 //x2=87.775 //y2=7.585
cc_3527 ( N_noxref_9_c_3926_p N_VDD_c_13434_n ) capacitor c=0.0024232f \
 //x=36.57 //y=5.56 //x2=87.775 //y2=7.585
cc_3528 ( N_noxref_9_c_3842_p N_VDD_c_13434_n ) capacitor c=0.0024232f \
 //x=37.45 //y=5.56 //x2=87.775 //y2=7.585
cc_3529 ( N_noxref_9_M101_noxref_g N_VDD_c_13851_n ) capacitor c=0.00755544f \
 //x=32.42 //y=6.2 //x2=32.995 //y2=7.585
cc_3530 ( N_noxref_9_M102_noxref_g N_VDD_c_13851_n ) capacitor c=0.00755754f \
 //x=32.86 //y=6.2 //x2=32.995 //y2=7.585
cc_3531 ( N_noxref_9_c_3716_n N_VDD_c_13856_n ) capacitor c=0.00202922f \
 //x=36.45 //y=5.335 //x2=36.045 //y2=7.585
cc_3532 ( N_noxref_9_c_3724_n N_VDD_c_13856_n ) capacitor c=9.3757e-19 \
 //x=35.692 //y=5.335 //x2=36.045 //y2=7.585
cc_3533 ( N_noxref_9_c_3781_n N_VDD_c_13856_n ) capacitor c=0.0138074f \
 //x=35.69 //y=5.56 //x2=36.045 //y2=7.585
cc_3534 ( N_noxref_9_c_3716_n N_VDD_c_13964_n ) capacitor c=0.0017708f \
 //x=36.45 //y=5.335 //x2=36.925 //y2=7.585
cc_3535 ( N_noxref_9_c_3718_n N_VDD_c_13964_n ) capacitor c=0.00202922f \
 //x=37.335 //y=5.335 //x2=36.925 //y2=7.585
cc_3536 ( N_noxref_9_c_3726_n N_VDD_c_13964_n ) capacitor c=9.4822e-19 \
 //x=36.57 //y=5.335 //x2=36.925 //y2=7.585
cc_3537 ( N_noxref_9_c_3926_p N_VDD_c_13964_n ) capacitor c=0.0138074f \
 //x=36.57 //y=5.56 //x2=36.925 //y2=7.585
cc_3538 ( N_noxref_9_c_3718_n N_VDD_c_13968_n ) capacitor c=0.00205906f \
 //x=37.335 //y=5.335 //x2=37.805 //y2=7.585
cc_3539 ( N_noxref_9_c_3814_n N_VDD_c_13968_n ) capacitor c=8.49654e-19 \
 //x=37.45 //y=5.56 //x2=37.805 //y2=7.585
cc_3540 ( N_noxref_9_c_3815_n N_VDD_c_13968_n ) capacitor c=0.00204238f \
 //x=38.145 //y=5.335 //x2=37.805 //y2=7.585
cc_3541 ( N_noxref_9_c_3842_p N_VDD_c_13968_n ) capacitor c=0.013249f \
 //x=37.45 //y=5.56 //x2=37.805 //y2=7.585
cc_3542 ( N_noxref_9_c_3815_n N_VDD_c_13972_n ) capacitor c=0.00183742f \
 //x=38.145 //y=5.335 //x2=38.8 //y2=7.585
cc_3543 ( N_noxref_9_M121_noxref_g N_VDD_c_13973_n ) capacitor c=0.00755614f \
 //x=49.9 //y=6.2 //x2=50.475 //y2=7.585
cc_3544 ( N_noxref_9_M122_noxref_g N_VDD_c_13973_n ) capacitor c=0.00755544f \
 //x=50.34 //y=6.2 //x2=50.475 //y2=7.585
cc_3545 ( N_noxref_9_c_3724_n N_VDD_c_13773_n ) capacitor c=0.00244337f \
 //x=35.692 //y=5.335 //x2=34.16 //y2=7.585
cc_3546 ( N_noxref_9_c_3777_n N_VDD_c_13773_n ) capacitor c=0.00205049f \
 //x=32.68 //y=4.88 //x2=34.16 //y2=7.585
cc_3547 ( N_noxref_9_c_3781_n N_VDD_c_13773_n ) capacitor c=0.00509469f \
 //x=35.69 //y=5.56 //x2=34.16 //y2=7.585
cc_3548 ( N_noxref_9_c_3814_n N_VDD_c_13775_n ) capacitor c=0.00282782f \
 //x=37.45 //y=5.56 //x2=38.97 //y2=7.585
cc_3549 ( N_noxref_9_c_3720_n N_VDD_c_13775_n ) capacitor c=0.0315052f \
 //x=38.23 //y=5.25 //x2=38.97 //y2=7.585
cc_3550 ( N_noxref_9_c_3842_p N_VDD_c_13775_n ) capacitor c=0.00777981f \
 //x=37.45 //y=5.56 //x2=38.97 //y2=7.585
cc_3551 ( N_noxref_9_c_3723_n N_VDD_c_13778_n ) capacitor c=0.0107022f \
 //x=49.7 //y=4.755 //x2=48.59 //y2=7.585
cc_3552 ( N_noxref_9_c_3956_p N_VDD_c_13778_n ) capacitor c=0.00354568f \
 //x=49.7 //y=4.88 //x2=48.59 //y2=7.585
cc_3553 ( N_noxref_9_c_3732_n N_VDD_c_13778_n ) capacitor c=0.00572368f \
 //x=49.975 //y=4.97 //x2=48.59 //y2=7.585
cc_3554 ( N_noxref_9_M101_noxref_g N_VDD_M100_noxref_d ) capacitor c=0.015318f \
 //x=32.42 //y=6.2 //x2=32.055 //y2=5.2
cc_3555 ( N_noxref_9_M102_noxref_g N_VDD_M102_noxref_d ) capacitor \
 c=0.0394719f //x=32.86 //y=6.2 //x2=32.935 //y2=5.2
cc_3556 ( N_noxref_9_c_3724_n N_VDD_M103_noxref_s ) capacitor c=0.0442713f \
 //x=35.692 //y=5.335 //x2=35.115 //y2=5.2
cc_3557 ( N_noxref_9_c_3726_n N_VDD_M103_noxref_s ) capacitor c=7.80122e-19 \
 //x=36.57 //y=5.335 //x2=35.115 //y2=5.2
cc_3558 ( N_noxref_9_c_3781_n N_VDD_M103_noxref_s ) capacitor c=0.09305f \
 //x=35.69 //y=5.56 //x2=35.115 //y2=5.2
cc_3559 ( N_noxref_9_c_3716_n N_VDD_M104_noxref_d ) capacitor c=0.00700141f \
 //x=36.45 //y=5.335 //x2=35.985 //y2=5.2
cc_3560 ( N_noxref_9_c_3781_n N_VDD_M104_noxref_d ) capacitor c=0.0674491f \
 //x=35.69 //y=5.56 //x2=35.985 //y2=5.2
cc_3561 ( N_noxref_9_c_3926_p N_VDD_M104_noxref_d ) capacitor c=0.0674762f \
 //x=36.57 //y=5.56 //x2=35.985 //y2=5.2
cc_3562 ( N_noxref_9_c_3718_n N_VDD_M106_noxref_d ) capacitor c=0.00700141f \
 //x=37.335 //y=5.335 //x2=36.865 //y2=5.2
cc_3563 ( N_noxref_9_c_3926_p N_VDD_M106_noxref_d ) capacitor c=0.067493f \
 //x=36.57 //y=5.56 //x2=36.865 //y2=5.2
cc_3564 ( N_noxref_9_c_3842_p N_VDD_M106_noxref_d ) capacitor c=0.0674979f \
 //x=37.45 //y=5.56 //x2=36.865 //y2=5.2
cc_3565 ( N_noxref_9_c_3815_n N_VDD_M108_noxref_d ) capacitor c=0.00700141f \
 //x=38.145 //y=5.335 //x2=37.745 //y2=5.2
cc_3566 ( N_noxref_9_c_3842_p N_VDD_M108_noxref_d ) capacitor c=0.0675002f \
 //x=37.45 //y=5.56 //x2=37.745 //y2=5.2
cc_3567 ( N_noxref_9_c_3814_n N_VDD_M109_noxref_s ) capacitor c=0.00492616f \
 //x=37.45 //y=5.56 //x2=39.925 //y2=5.2
cc_3568 ( N_noxref_9_c_3815_n N_VDD_M109_noxref_s ) capacitor c=9.42705e-19 \
 //x=38.145 //y=5.335 //x2=39.925 //y2=5.2
cc_3569 ( N_noxref_9_c_3726_n N_VDD_M109_noxref_s ) capacitor c=2.11884e-19 \
 //x=36.57 //y=5.335 //x2=39.925 //y2=5.2
cc_3570 ( N_noxref_9_c_3847_p N_VDD_M121_noxref_s ) capacitor c=5.74363e-19 \
 //x=49.7 //y=3.67 //x2=49.545 //y2=5.2
cc_3571 ( N_noxref_9_c_3723_n N_VDD_M121_noxref_s ) capacitor c=0.0167311f \
 //x=49.7 //y=4.755 //x2=49.545 //y2=5.2
cc_3572 ( N_noxref_9_c_3956_p N_VDD_M121_noxref_s ) capacitor c=0.00983846f \
 //x=49.7 //y=4.88 //x2=49.545 //y2=5.2
cc_3573 ( N_noxref_9_M121_noxref_g N_VDD_M121_noxref_s ) capacitor c=0.053419f \
 //x=49.9 //y=6.2 //x2=49.545 //y2=5.2
cc_3574 ( N_noxref_9_c_3732_n N_VDD_M121_noxref_s ) capacitor c=0.00606273f \
 //x=49.975 //y=4.97 //x2=49.545 //y2=5.2
cc_3575 ( N_noxref_9_M122_noxref_g N_VDD_M122_noxref_d ) capacitor c=0.015318f \
 //x=50.34 //y=6.2 //x2=50.415 //y2=5.2
cc_3576 ( N_noxref_9_c_3734_n N_noxref_32_c_15287_n ) capacitor c=0.00177186f \
 //x=32.68 //y=2.375 //x2=33.335 //y2=0.72
cc_3577 ( N_noxref_9_c_3776_n N_noxref_32_c_15287_n ) capacitor c=0.00117306f \
 //x=32.68 //y=2.26 //x2=33.335 //y2=0.72
cc_3578 ( N_noxref_9_c_3790_n N_noxref_32_c_15287_n ) capacitor c=0.0206349f \
 //x=32.67 //y=1.095 //x2=33.335 //y2=0.72
cc_3579 ( N_noxref_9_c_3802_n N_noxref_32_c_15287_n ) capacitor c=0.00825432f \
 //x=33.2 //y=1.095 //x2=33.335 //y2=0.72
cc_3580 ( N_noxref_9_c_3808_n N_noxref_32_c_15287_n ) capacitor c=2.20712e-19 \
 //x=32.68 //y=2.26 //x2=33.335 //y2=0.72
cc_3581 ( N_noxref_9_c_3792_n N_noxref_32_c_15290_n ) capacitor c=0.0071177f \
 //x=32.67 //y=1.44 //x2=32.45 //y2=1.175
cc_3582 ( N_noxref_9_c_3790_n N_noxref_32_M20_noxref_s ) capacitor \
 c=0.0071177f //x=32.67 //y=1.095 //x2=32.315 //y2=0.555
cc_3583 ( N_noxref_9_c_3795_n N_noxref_32_M20_noxref_s ) capacitor \
 c=0.0071177f //x=32.67 //y=1.75 //x2=32.315 //y2=0.555
cc_3584 ( N_noxref_9_c_3802_n N_noxref_32_M20_noxref_s ) capacitor c=0.015333f \
 //x=33.2 //y=1.095 //x2=32.315 //y2=0.555
cc_3585 ( N_noxref_9_c_3804_n N_noxref_32_M20_noxref_s ) capacitor \
 c=0.00248746f //x=33.2 //y=1.44 //x2=32.315 //y2=0.555
cc_3586 ( N_noxref_9_c_3881_p N_noxref_33_c_15354_n ) capacitor c=0.0036878f \
 //x=37.745 //y=1.305 //x2=38.145 //y2=0.72
cc_3587 ( N_noxref_9_c_3816_n N_noxref_33_c_15354_n ) capacitor c=0.00399931f \
 //x=38.145 //y=1.845 //x2=38.145 //y2=0.72
cc_3588 ( N_noxref_9_M23_noxref_d N_noxref_33_c_15354_n ) capacitor \
 c=0.00910163f //x=37.555 //y=1.095 //x2=38.145 //y2=0.72
cc_3589 ( N_noxref_9_M23_noxref_d N_noxref_33_c_15357_n ) capacitor \
 c=0.00120711f //x=37.555 //y=1.095 //x2=37.26 //y2=1.175
cc_3590 ( N_noxref_9_c_3716_n N_noxref_33_M22_noxref_d ) capacitor \
 c=6.95923e-19 //x=36.45 //y=5.335 //x2=36.02 //y2=1.09
cc_3591 ( N_noxref_9_c_3881_p N_noxref_33_M22_noxref_d ) capacitor \
 c=0.00802417f //x=37.745 //y=1.305 //x2=36.02 //y2=1.09
cc_3592 ( N_noxref_9_c_3881_p N_noxref_33_M23_noxref_s ) capacitor \
 c=0.0098487f //x=37.745 //y=1.305 //x2=37.125 //y2=0.555
cc_3593 ( N_noxref_9_c_3884_p N_noxref_33_M23_noxref_s ) capacitor \
 c=0.0283243f //x=37.745 //y=1.76 //x2=37.125 //y2=0.555
cc_3594 ( N_noxref_9_c_3816_n N_noxref_33_M23_noxref_s ) capacitor \
 c=0.00871957f //x=38.145 //y=1.845 //x2=37.125 //y2=0.555
cc_3595 ( N_noxref_9_c_3831_p N_noxref_33_M23_noxref_s ) capacitor \
 c=0.0016218f //x=38.23 //y=3.51 //x2=37.125 //y2=0.555
cc_3596 ( N_noxref_9_M23_noxref_d N_noxref_33_M23_noxref_s ) capacitor \
 c=0.0279003f //x=37.555 //y=1.095 //x2=37.125 //y2=0.555
cc_3597 ( N_noxref_9_c_3881_p N_noxref_34_M25_noxref_d ) capacitor \
 c=3.20746e-19 //x=37.745 //y=1.305 //x2=40.83 //y2=1.09
cc_3598 ( N_noxref_9_c_3734_n N_GND_c_16658_n ) capacitor c=0.00196498f \
 //x=32.68 //y=2.375 //x2=35.15 //y2=0.175
cc_3599 ( N_noxref_9_c_3881_p N_GND_c_16769_n ) capacitor c=0.00884249f \
 //x=37.745 //y=1.305 //x2=39.96 //y2=0.175
cc_3600 ( N_noxref_9_c_3816_n N_GND_c_16769_n ) capacitor c=0.00662992f \
 //x=38.145 //y=1.845 //x2=39.96 //y2=0.175
cc_3601 ( N_noxref_9_c_3760_n N_GND_c_16769_n ) capacitor c=2.95105e-19 \
 //x=38.23 //y=3.655 //x2=39.96 //y2=0.175
cc_3602 ( N_noxref_9_M23_noxref_d N_GND_c_16769_n ) capacitor c=2.9462e-19 \
 //x=37.555 //y=1.095 //x2=39.96 //y2=0.175
cc_3603 ( N_noxref_9_c_4016_p N_GND_c_16773_n ) capacitor c=3.97665e-19 \
 //x=49.4 //y=1.055 //x2=49.665 //y2=1.015
cc_3604 ( N_noxref_9_c_4154_p N_GND_c_16773_n ) capacitor c=0.00864776f \
 //x=49.775 //y=0.9 //x2=49.665 //y2=1.015
cc_3605 ( N_noxref_9_c_4018_p N_GND_c_16773_n ) capacitor c=4.45447e-19 \
 //x=49.93 //y=1.055 //x2=49.665 //y2=1.015
cc_3606 ( N_noxref_9_c_3881_p N_GND_c_16679_n ) capacitor c=0.00543195f \
 //x=37.745 //y=1.305 //x2=40.045 //y2=1.145
cc_3607 ( N_noxref_9_c_3845_p N_GND_c_16777_n ) capacitor c=0.00772482f \
 //x=49.7 //y=2.375 //x2=49.665 //y2=1.145
cc_3608 ( N_noxref_9_c_3847_p N_GND_c_16777_n ) capacitor c=7.73977e-19 \
 //x=49.7 //y=3.67 //x2=49.665 //y2=1.145
cc_3609 ( N_noxref_9_c_3966_p N_GND_c_16777_n ) capacitor c=2.22883e-19 \
 //x=49.7 //y=2.26 //x2=49.665 //y2=1.145
cc_3610 ( N_noxref_9_c_4016_p N_GND_c_16777_n ) capacitor c=0.00156339f \
 //x=49.4 //y=1.055 //x2=49.665 //y2=1.145
cc_3611 ( N_noxref_9_c_4017_p N_GND_c_16777_n ) capacitor c=0.00352472f \
 //x=49.4 //y=1.4 //x2=49.665 //y2=1.145
cc_3612 ( N_noxref_9_c_4019_p N_GND_c_16777_n ) capacitor c=4.26589e-19 \
 //x=49.4 //y=1.71 //x2=49.665 //y2=1.145
cc_3613 ( N_noxref_9_c_4154_p N_GND_c_16777_n ) capacitor c=9.36995e-19 \
 //x=49.775 //y=0.9 //x2=49.665 //y2=1.145
cc_3614 ( N_noxref_9_c_4164_p N_GND_c_16777_n ) capacitor c=5.79272e-19 \
 //x=49.775 //y=1.555 //x2=49.665 //y2=1.145
cc_3615 ( N_noxref_9_c_4018_p N_GND_c_16777_n ) capacitor c=0.0017438f \
 //x=49.93 //y=1.055 //x2=49.665 //y2=1.145
cc_3616 ( N_noxref_9_c_4020_p N_GND_c_16777_n ) capacitor c=0.00276804f \
 //x=49.93 //y=1.4 //x2=49.665 //y2=1.145
cc_3617 ( N_noxref_9_c_3734_n N_GND_c_16689_n ) capacitor c=2.016e-19 \
 //x=32.68 //y=2.375 //x2=33.99 //y2=0.175
cc_3618 ( N_noxref_9_c_3816_n N_GND_c_16691_n ) capacitor c=6.86343e-19 \
 //x=38.145 //y=1.845 //x2=38.8 //y2=0.175
cc_3619 ( N_noxref_9_c_3760_n N_GND_c_16691_n ) capacitor c=4.03806e-19 \
 //x=38.23 //y=3.655 //x2=38.8 //y2=0.175
cc_3620 ( N_noxref_9_c_4016_p N_GND_c_16790_n ) capacitor c=0.00677766f \
 //x=49.4 //y=1.055 //x2=53.23 //y2=0.175
cc_3621 ( N_noxref_9_c_3776_n N_GND_c_16693_n ) capacitor c=0.00216084f \
 //x=32.68 //y=2.26 //x2=34.16 //y2=0.175
cc_3622 ( N_noxref_9_c_3804_n N_GND_c_16693_n ) capacitor c=0.00262688f \
 //x=33.2 //y=1.44 //x2=34.16 //y2=0.175
cc_3623 ( N_noxref_9_c_3808_n N_GND_c_16693_n ) capacitor c=2.63786e-19 \
 //x=32.68 //y=2.26 //x2=34.16 //y2=0.175
cc_3624 ( N_noxref_9_c_3884_p N_GND_c_16706_n ) capacitor c=0.0045138f \
 //x=37.745 //y=1.76 //x2=38.97 //y2=0.175
cc_3625 ( N_noxref_9_c_3816_n N_GND_c_16706_n ) capacitor c=0.0304827f \
 //x=38.145 //y=1.845 //x2=38.97 //y2=0.175
cc_3626 ( N_noxref_9_c_3845_p N_GND_c_16796_n ) capacitor c=0.00358368f \
 //x=49.7 //y=2.375 //x2=48.59 //y2=0.175
cc_3627 ( N_noxref_9_c_3846_p N_GND_c_16796_n ) capacitor c=0.00963712f \
 //x=49.7 //y=3.35 //x2=48.59 //y2=0.175
cc_3628 ( N_noxref_9_c_3966_p N_GND_c_16796_n ) capacitor c=0.0039621f \
 //x=49.7 //y=2.26 //x2=48.59 //y2=0.175
cc_3629 ( N_noxref_9_c_4019_p N_GND_c_16796_n ) capacitor c=0.00170145f \
 //x=49.4 //y=1.71 //x2=48.59 //y2=0.175
cc_3630 ( N_noxref_9_c_3967_p N_GND_c_16796_n ) capacitor c=0.0102191f \
 //x=49.4 //y=2.095 //x2=48.59 //y2=0.175
cc_3631 ( N_noxref_9_c_3845_p N_GND_M30_noxref_d ) capacitor c=4.4417e-19 \
 //x=49.7 //y=2.375 //x2=49.475 //y2=1.055
cc_3632 ( N_noxref_9_c_4016_p N_GND_M30_noxref_d ) capacitor c=0.00184354f \
 //x=49.4 //y=1.055 //x2=49.475 //y2=1.055
cc_3633 ( N_noxref_9_c_4017_p N_GND_M30_noxref_d ) capacitor c=0.00210798f \
 //x=49.4 //y=1.4 //x2=49.475 //y2=1.055
cc_3634 ( N_noxref_9_c_4154_p N_GND_M30_noxref_d ) capacitor c=0.00474029f \
 //x=49.775 //y=0.9 //x2=49.475 //y2=1.055
cc_3635 ( N_noxref_9_c_4164_p N_GND_M30_noxref_d ) capacitor c=0.00166857f \
 //x=49.775 //y=1.555 //x2=49.475 //y2=1.055
cc_3636 ( N_noxref_9_c_4018_p N_GND_M30_noxref_d ) capacitor c=0.00230174f \
 //x=49.93 //y=1.055 //x2=49.475 //y2=1.055
cc_3637 ( N_noxref_9_c_4020_p N_GND_M30_noxref_d ) capacitor c=0.00210798f \
 //x=49.93 //y=1.4 //x2=49.475 //y2=1.055
cc_3638 ( N_noxref_9_c_3967_p N_noxref_57_c_18711_n ) capacitor c=0.00262672f \
 //x=49.4 //y=2.095 //x2=49.18 //y2=1.685
cc_3639 ( N_noxref_9_c_3845_p N_noxref_57_c_18712_n ) capacitor c=0.00428451f \
 //x=49.7 //y=2.375 //x2=50.065 //y2=1.77
cc_3640 ( N_noxref_9_c_3847_p N_noxref_57_c_18712_n ) capacitor c=0.00260186f \
 //x=49.7 //y=3.67 //x2=50.065 //y2=1.77
cc_3641 ( N_noxref_9_c_3966_p N_noxref_57_c_18712_n ) capacitor c=0.0104666f \
 //x=49.7 //y=2.26 //x2=50.065 //y2=1.77
cc_3642 ( N_noxref_9_c_4019_p N_noxref_57_c_18712_n ) capacitor c=0.00705077f \
 //x=49.4 //y=1.71 //x2=50.065 //y2=1.77
cc_3643 ( N_noxref_9_c_3967_p N_noxref_57_c_18712_n ) capacitor c=0.020708f \
 //x=49.4 //y=2.095 //x2=50.065 //y2=1.77
cc_3644 ( N_noxref_9_c_4164_p N_noxref_57_c_18712_n ) capacitor c=0.00588627f \
 //x=49.775 //y=1.555 //x2=50.065 //y2=1.77
cc_3645 ( N_noxref_9_c_4020_p N_noxref_57_c_18712_n ) capacitor c=0.00698822f \
 //x=49.93 //y=1.4 //x2=50.065 //y2=1.77
cc_3646 ( N_noxref_9_c_4016_p N_noxref_57_M30_noxref_s ) capacitor \
 c=0.0295256f //x=49.4 //y=1.055 //x2=49.045 //y2=0.555
cc_3647 ( N_noxref_9_c_4019_p N_noxref_57_M30_noxref_s ) capacitor \
 c=7.99997e-19 //x=49.4 //y=1.71 //x2=49.045 //y2=0.555
cc_3648 ( N_noxref_9_c_3967_p N_noxref_57_M30_noxref_s ) capacitor \
 c=0.00122123f //x=49.4 //y=2.095 //x2=49.045 //y2=0.555
cc_3649 ( N_noxref_9_c_4018_p N_noxref_57_M30_noxref_s ) capacitor \
 c=0.0125924f //x=49.93 //y=1.055 //x2=49.045 //y2=0.555
cc_3650 ( N_noxref_10_c_4202_n N_noxref_11_c_4675_n ) capacitor c=6.09703e-19 \
 //x=50.122 //y=5.335 //x2=47.07 //y2=5.56
cc_3651 ( N_noxref_10_c_4202_n N_noxref_11_c_4676_n ) capacitor c=0.00306432f \
 //x=50.122 //y=5.335 //x2=47.765 //y2=5.335
cc_3652 ( N_noxref_10_c_4216_p N_noxref_11_c_4677_n ) capacitor c=0.00163399f \
 //x=52.26 //y=1.845 //x2=47.765 //y2=1.845
cc_3653 ( N_noxref_10_c_4217_p N_noxref_11_c_4678_n ) capacitor c=2.75855e-19 \
 //x=54.51 //y=2.595 //x2=56.73 //y2=3.725
cc_3654 ( N_noxref_10_c_4218_p N_noxref_11_c_4678_n ) capacitor c=3.74785e-19 \
 //x=54.51 //y=2.915 //x2=56.73 //y2=3.725
cc_3655 ( N_noxref_10_c_4201_n N_noxref_11_c_4678_n ) capacitor c=0.0010345f \
 //x=54.51 //y=4.755 //x2=56.73 //y2=3.725
cc_3656 ( N_noxref_10_c_4201_n N_noxref_11_c_4508_n ) capacitor c=5.73787e-19 \
 //x=54.51 //y=4.755 //x2=56.73 //y2=4.75
cc_3657 ( N_noxref_10_c_4200_n N_noxref_11_c_4626_n ) capacitor c=0.0233632f \
 //x=52.66 //y=5.25 //x2=49.91 //y2=3.895
cc_3658 ( N_noxref_10_c_4201_n N_noxref_11_c_4626_n ) capacitor c=0.024803f \
 //x=54.51 //y=4.755 //x2=49.91 //y2=3.895
cc_3659 ( N_noxref_10_c_4200_n N_D_c_5203_n ) capacitor c=0.0233585f //x=52.66 \
 //y=5.25 //x2=56.345 //y2=4.25
cc_3660 ( N_noxref_10_c_4201_n N_D_c_5203_n ) capacitor c=0.0247975f //x=54.51 \
 //y=4.755 //x2=56.345 //y2=4.25
cc_3661 ( N_noxref_10_c_4200_n N_CLK_c_6623_n ) capacitor c=0.0233664f \
 //x=52.66 //y=5.25 //x2=59.19 //y2=4.635
cc_3662 ( N_noxref_10_c_4201_n N_CLK_c_6623_n ) capacitor c=0.0275817f \
 //x=54.51 //y=4.755 //x2=59.19 //y2=4.635
cc_3663 ( N_noxref_10_c_4227_p RN ) capacitor c=4.59987e-19 //x=52.66 \
 //y=2.915 //x2=50.81 //y2=2.77
cc_3664 ( N_noxref_10_c_4200_n RN ) capacitor c=0.00238262f //x=52.66 //y=5.25 \
 //x2=50.81 //y2=2.77
cc_3665 ( N_noxref_10_c_4207_n N_RN_c_8258_n ) capacitor c=3.61396e-19 \
 //x=50.88 //y=5.335 //x2=50.81 //y2=2.57
cc_3666 ( N_noxref_10_c_4230_p N_RN_c_8258_n ) capacitor c=3.92862e-19 //x=51 \
 //y=5.335 //x2=50.81 //y2=2.57
cc_3667 ( N_noxref_10_c_4207_n N_RN_c_8126_n ) capacitor c=0.0179739f \
 //x=50.88 //y=5.335 //x2=50.81 //y2=4.765
cc_3668 ( N_noxref_10_c_4230_p N_RN_c_8126_n ) capacitor c=0.00209649f //x=51 \
 //y=5.335 //x2=50.81 //y2=4.765
cc_3669 ( N_noxref_10_c_4233_p N_RN_c_8126_n ) capacitor c=7.63434e-19 //x=51 \
 //y=5.56 //x2=50.81 //y2=4.765
cc_3670 ( N_noxref_10_c_4234_p N_RN_c_8335_n ) capacitor c=0.0271513f \
 //x=52.66 //y=2.595 //x2=52.92 //y2=2.37
cc_3671 ( N_noxref_10_c_4227_p N_RN_c_8335_n ) capacitor c=0.00578698f \
 //x=52.66 //y=2.915 //x2=52.92 //y2=2.37
cc_3672 ( N_noxref_10_c_4236_p N_RN_c_8335_n ) capacitor c=0.0365231f \
 //x=52.865 //y=2.755 //x2=52.92 //y2=2.37
cc_3673 ( N_noxref_10_c_4237_p N_RN_c_8335_n ) capacitor c=0.12439f //x=54.305 \
 //y=2.755 //x2=52.92 //y2=2.37
cc_3674 ( N_noxref_10_c_4238_p N_RN_c_8281_n ) capacitor c=6.89366e-19 \
 //x=52.175 //y=1.305 //x2=52.49 //y2=2.37
cc_3675 ( N_noxref_10_c_4239_p N_RN_c_8281_n ) capacitor c=0.0069376f \
 //x=52.575 //y=1.845 //x2=52.49 //y2=2.37
cc_3676 ( N_noxref_10_c_4216_p N_RN_c_8281_n ) capacitor c=0.0140113f \
 //x=52.26 //y=1.845 //x2=52.49 //y2=2.37
cc_3677 ( N_noxref_10_c_4234_p N_RN_c_8281_n ) capacitor c=6.77208e-19 \
 //x=52.66 //y=2.595 //x2=52.49 //y2=2.37
cc_3678 ( N_noxref_10_c_4234_p N_RN_c_8343_n ) capacitor c=2.03478e-19 \
 //x=52.66 //y=2.595 //x2=54.08 //y2=2.4
cc_3679 ( N_noxref_10_c_4217_p N_RN_c_8343_n ) capacitor c=9.34345e-19 \
 //x=54.51 //y=2.595 //x2=54.08 //y2=2.4
cc_3680 ( N_noxref_10_c_4218_p N_RN_c_8343_n ) capacitor c=0.00186484f \
 //x=54.51 //y=2.915 //x2=54.08 //y2=2.4
cc_3681 ( N_noxref_10_c_4237_p N_RN_c_8343_n ) capacitor c=0.0112717f \
 //x=54.305 //y=2.755 //x2=54.08 //y2=2.4
cc_3682 ( N_noxref_10_c_4246_p N_RN_c_8347_n ) capacitor c=0.0181219f \
 //x=54.51 //y=2.375 //x2=54.68 //y2=2.37
cc_3683 ( N_noxref_10_c_4217_p N_RN_c_8347_n ) capacitor c=0.0105258f \
 //x=54.51 //y=2.595 //x2=54.68 //y2=2.37
cc_3684 ( N_noxref_10_c_4218_p N_RN_c_8347_n ) capacitor c=0.00545105f \
 //x=54.51 //y=2.915 //x2=54.68 //y2=2.37
cc_3685 ( N_noxref_10_c_4249_p N_RN_c_8347_n ) capacitor c=0.0370411f \
 //x=54.465 //y=2.755 //x2=54.68 //y2=2.37
cc_3686 ( N_noxref_10_c_4250_p N_RN_c_8347_n ) capacitor c=5.18204e-19 \
 //x=54.51 //y=2.26 //x2=54.68 //y2=2.37
cc_3687 ( N_noxref_10_c_4251_p N_RN_c_8347_n ) capacitor c=3.41298e-19 \
 //x=54.21 //y=2.095 //x2=54.68 //y2=2.37
cc_3688 ( N_noxref_10_c_4217_p N_RN_c_8353_n ) capacitor c=8.18253e-19 \
 //x=54.51 //y=2.595 //x2=71.685 //y2=2.385
cc_3689 ( N_noxref_10_c_4207_n N_RN_c_8151_n ) capacitor c=0.00492634f \
 //x=50.88 //y=5.335 //x2=50.81 //y2=4.88
cc_3690 ( N_noxref_10_c_4230_p N_RN_c_8151_n ) capacitor c=0.00132214f //x=51 \
 //y=5.335 //x2=50.81 //y2=4.88
cc_3691 ( N_noxref_10_c_4207_n N_RN_M123_noxref_g ) capacitor c=0.00858183f \
 //x=50.88 //y=5.335 //x2=50.78 //y2=6.2
cc_3692 ( N_noxref_10_c_4230_p N_RN_M123_noxref_g ) capacitor c=0.00229818f \
 //x=51 //y=5.335 //x2=50.78 //y2=6.2
cc_3693 ( N_noxref_10_c_4233_p N_RN_M123_noxref_g ) capacitor c=0.0179041f \
 //x=51 //y=5.56 //x2=50.78 //y2=6.2
cc_3694 ( N_noxref_10_c_4258_p N_RN_M124_noxref_g ) capacitor c=0.00875663f \
 //x=51.765 //y=5.335 //x2=51.22 //y2=6.2
cc_3695 ( N_noxref_10_c_4230_p N_RN_M124_noxref_g ) capacitor c=0.00230699f \
 //x=51 //y=5.335 //x2=51.22 //y2=6.2
cc_3696 ( N_noxref_10_c_4233_p N_RN_M124_noxref_g ) capacitor c=0.0179041f \
 //x=51 //y=5.56 //x2=51.22 //y2=6.2
cc_3697 ( N_noxref_10_c_4230_p N_RN_c_8174_n ) capacitor c=0.0017897f //x=51 \
 //y=5.335 //x2=51.145 //y2=4.97
cc_3698 ( N_noxref_10_c_4233_p N_RN_c_8174_n ) capacitor c=0.00290085f //x=51 \
 //y=5.56 //x2=51.145 //y2=4.97
cc_3699 ( N_noxref_10_c_4207_n N_RN_c_8324_n ) capacitor c=6.1418e-19 \
 //x=50.88 //y=5.335 //x2=50.81 //y2=4.88
cc_3700 ( N_noxref_10_c_4234_p SN ) capacitor c=3.09634e-19 //x=52.66 \
 //y=2.595 //x2=55.62 //y2=2.77
cc_3701 ( N_noxref_10_c_4217_p SN ) capacitor c=0.00449124f //x=54.51 \
 //y=2.595 //x2=55.62 //y2=2.77
cc_3702 ( N_noxref_10_c_4218_p SN ) capacitor c=0.0107146f //x=54.51 //y=2.915 \
 //x2=55.62 //y2=2.77
cc_3703 ( N_noxref_10_c_4201_n SN ) capacitor c=0.00199877f //x=54.51 \
 //y=4.755 //x2=55.62 //y2=2.77
cc_3704 ( N_noxref_10_c_4268_p SN ) capacitor c=4.11345e-19 //x=54.51 //y=2.77 \
 //x2=55.62 //y2=2.77
cc_3705 ( N_noxref_10_c_4249_p SN ) capacitor c=0.00235104f //x=54.465 \
 //y=2.755 //x2=55.62 //y2=2.77
cc_3706 ( N_noxref_10_c_4250_p SN ) capacitor c=3.9149e-19 //x=54.51 //y=2.26 \
 //x2=55.62 //y2=2.77
cc_3707 ( N_noxref_10_c_4201_n SN ) capacitor c=3.43503e-19 //x=54.51 \
 //y=4.755 //x2=55.62 //y2=3.14
cc_3708 ( N_noxref_10_c_4246_p N_SN_c_10239_n ) capacitor c=0.00884862f \
 //x=54.51 //y=2.375 //x2=55.62 //y2=2.375
cc_3709 ( N_noxref_10_c_4250_p N_SN_c_10239_n ) capacitor c=5.40058e-19 \
 //x=54.51 //y=2.26 //x2=55.62 //y2=2.375
cc_3710 ( N_noxref_10_c_4251_p N_SN_c_10239_n ) capacitor c=0.00142893f \
 //x=54.21 //y=2.095 //x2=55.62 //y2=2.375
cc_3711 ( N_noxref_10_c_4201_n N_SN_c_10242_n ) capacitor c=0.00772613f \
 //x=54.51 //y=4.755 //x2=55.62 //y2=3.305
cc_3712 ( N_noxref_10_c_4200_n N_SN_c_10069_n ) capacitor c=9.43045e-19 \
 //x=52.66 //y=5.25 //x2=55.62 //y2=4.765
cc_3713 ( N_noxref_10_c_4201_n N_SN_c_10069_n ) capacitor c=0.0401177f \
 //x=54.51 //y=4.755 //x2=55.62 //y2=4.765
cc_3714 ( N_noxref_10_c_4278_p N_SN_c_10069_n ) capacitor c=6.20857e-19 \
 //x=54.51 //y=4.88 //x2=55.62 //y2=4.765
cc_3715 ( N_noxref_10_c_4205_n N_SN_c_10069_n ) capacitor c=6.98043e-19 \
 //x=55.075 //y=4.97 //x2=55.62 //y2=4.765
cc_3716 ( N_noxref_10_c_4206_n N_SN_c_10069_n ) capacitor c=7.54501e-19 \
 //x=54.785 //y=4.97 //x2=55.62 //y2=4.765
cc_3717 ( N_noxref_10_c_4227_p N_SN_c_10248_n ) capacitor c=0.0124691f \
 //x=52.66 //y=2.915 //x2=55.46 //y2=3.14
cc_3718 ( N_noxref_10_c_4200_n N_SN_c_10248_n ) capacitor c=0.0227809f \
 //x=52.66 //y=5.25 //x2=55.46 //y2=3.14
cc_3719 ( N_noxref_10_c_4218_p N_SN_c_10248_n ) capacitor c=0.00861586f \
 //x=54.51 //y=2.915 //x2=55.46 //y2=3.14
cc_3720 ( N_noxref_10_c_4201_n N_SN_c_10248_n ) capacitor c=0.0236303f \
 //x=54.51 //y=4.755 //x2=55.46 //y2=3.14
cc_3721 ( N_noxref_10_c_4236_p N_SN_c_10248_n ) capacitor c=0.0358686f \
 //x=52.865 //y=2.755 //x2=55.46 //y2=3.14
cc_3722 ( N_noxref_10_c_4249_p N_SN_c_10248_n ) capacitor c=0.0358686f \
 //x=54.465 //y=2.755 //x2=55.46 //y2=3.14
cc_3723 ( N_noxref_10_c_4237_p N_SN_c_10248_n ) capacitor c=0.127505f \
 //x=54.305 //y=2.755 //x2=55.46 //y2=3.14
cc_3724 ( N_noxref_10_c_4201_n N_SN_c_10255_n ) capacitor c=0.00242466f \
 //x=54.51 //y=4.755 //x2=61.335 //y2=3.13
cc_3725 ( N_noxref_10_c_4200_n N_SN_c_10256_n ) capacitor c=0.00107049f \
 //x=52.66 //y=5.25 //x2=52.22 //y2=3.125
cc_3726 ( N_noxref_10_c_4246_p N_SN_c_10257_n ) capacitor c=5.39999e-19 \
 //x=54.51 //y=2.375 //x2=55.62 //y2=2.26
cc_3727 ( N_noxref_10_c_4217_p N_SN_c_10257_n ) capacitor c=3.9149e-19 \
 //x=54.51 //y=2.595 //x2=55.62 //y2=2.26
cc_3728 ( N_noxref_10_c_4250_p N_SN_c_10257_n ) capacitor c=0.00125213f \
 //x=54.51 //y=2.26 //x2=55.62 //y2=2.26
cc_3729 ( N_noxref_10_c_4251_p N_SN_c_10257_n ) capacitor c=0.00214573f \
 //x=54.21 //y=2.095 //x2=55.62 //y2=2.26
cc_3730 ( N_noxref_10_c_4201_n N_SN_c_10084_n ) capacitor c=8.93844e-19 \
 //x=54.51 //y=4.755 //x2=55.62 //y2=4.88
cc_3731 ( N_noxref_10_c_4278_p N_SN_c_10084_n ) capacitor c=0.00113984f \
 //x=54.51 //y=4.88 //x2=55.62 //y2=4.88
cc_3732 ( N_noxref_10_c_4205_n N_SN_c_10084_n ) capacitor c=0.00116563f \
 //x=55.075 //y=4.97 //x2=55.62 //y2=4.88
cc_3733 ( N_noxref_10_c_4206_n N_SN_c_10084_n ) capacitor c=0.00129812f \
 //x=54.785 //y=4.97 //x2=55.62 //y2=4.88
cc_3734 ( N_noxref_10_M127_noxref_g N_SN_M129_noxref_g ) capacitor \
 c=0.0106276f //x=54.71 //y=6.2 //x2=55.59 //y2=6.2
cc_3735 ( N_noxref_10_M128_noxref_g N_SN_M129_noxref_g ) capacitor c=0.107144f \
 //x=55.15 //y=6.2 //x2=55.59 //y2=6.2
cc_3736 ( N_noxref_10_M128_noxref_g N_SN_M130_noxref_g ) capacitor \
 c=0.0101598f //x=55.15 //y=6.2 //x2=56.03 //y2=6.2
cc_3737 ( N_noxref_10_c_4301_p N_SN_c_10268_n ) capacitor c=5.72528e-19 \
 //x=54.21 //y=1.055 //x2=55.185 //y2=1.09
cc_3738 ( N_noxref_10_c_4302_p N_SN_c_10268_n ) capacitor c=0.00150277f \
 //x=54.21 //y=1.4 //x2=55.185 //y2=1.09
cc_3739 ( N_noxref_10_c_4303_p N_SN_c_10268_n ) capacitor c=0.0160123f \
 //x=54.74 //y=1.055 //x2=55.185 //y2=1.09
cc_3740 ( N_noxref_10_c_4304_p N_SN_c_10271_n ) capacitor c=0.00111227f \
 //x=54.21 //y=1.71 //x2=55.185 //y2=1.4
cc_3741 ( N_noxref_10_c_4305_p N_SN_c_10271_n ) capacitor c=0.0124075f \
 //x=54.74 //y=1.4 //x2=55.185 //y2=1.4
cc_3742 ( N_noxref_10_c_4303_p N_SN_c_10273_n ) capacitor c=9.19165e-19 \
 //x=54.74 //y=1.055 //x2=55.71 //y2=1.09
cc_3743 ( N_noxref_10_c_4305_p N_SN_c_10274_n ) capacitor c=0.0010154f \
 //x=54.74 //y=1.4 //x2=55.71 //y2=1.4
cc_3744 ( N_noxref_10_c_4305_p N_SN_c_10275_n ) capacitor c=9.23422e-19 \
 //x=54.74 //y=1.4 //x2=55.71 //y2=1.63
cc_3745 ( N_noxref_10_c_4246_p N_SN_c_10276_n ) capacitor c=0.00134337f \
 //x=54.51 //y=2.375 //x2=55.71 //y2=2.095
cc_3746 ( N_noxref_10_c_4250_p N_SN_c_10276_n ) capacitor c=0.0020754f \
 //x=54.51 //y=2.26 //x2=55.71 //y2=2.095
cc_3747 ( N_noxref_10_c_4251_p N_SN_c_10276_n ) capacitor c=0.00964411f \
 //x=54.21 //y=2.095 //x2=55.71 //y2=2.095
cc_3748 ( N_noxref_10_c_4201_n N_SN_c_10279_n ) capacitor c=0.00108708f \
 //x=54.51 //y=4.755 //x2=55.62 //y2=4.88
cc_3749 ( N_noxref_10_c_4278_p N_SN_c_10279_n ) capacitor c=0.00155973f \
 //x=54.51 //y=4.88 //x2=55.62 //y2=4.88
cc_3750 ( N_noxref_10_c_4205_n N_SN_c_10279_n ) capacitor c=0.0171374f \
 //x=55.075 //y=4.97 //x2=55.62 //y2=4.88
cc_3751 ( N_noxref_10_c_4206_n N_SN_c_10279_n ) capacitor c=0.00484466f \
 //x=54.785 //y=4.97 //x2=55.62 //y2=4.88
cc_3752 ( N_noxref_10_c_4234_p N_noxref_22_c_12335_n ) capacitor c=0.0135238f \
 //x=52.66 //y=2.595 //x2=51.92 //y2=2.375
cc_3753 ( N_noxref_10_c_4234_p N_noxref_22_c_12331_n ) capacitor c=0.00776764f \
 //x=52.66 //y=2.595 //x2=51.92 //y2=3.365
cc_3754 ( N_noxref_10_c_4227_p N_noxref_22_c_12331_n ) capacitor c=0.01696f \
 //x=52.66 //y=2.915 //x2=51.92 //y2=3.365
cc_3755 ( N_noxref_10_c_4200_n N_noxref_22_c_12331_n ) capacitor c=0.017808f \
 //x=52.66 //y=5.25 //x2=51.92 //y2=3.365
cc_3756 ( N_noxref_10_c_4217_p N_noxref_22_c_12331_n ) capacitor c=4.05352e-19 \
 //x=54.51 //y=2.595 //x2=51.92 //y2=3.365
cc_3757 ( N_noxref_10_c_4201_n N_noxref_22_c_12331_n ) capacitor c=3.1295e-19 \
 //x=54.51 //y=4.755 //x2=51.92 //y2=3.365
cc_3758 ( N_noxref_10_c_4322_p N_noxref_22_c_12331_n ) capacitor c=7.6985e-19 \
 //x=52.66 //y=2.77 //x2=51.92 //y2=3.365
cc_3759 ( N_noxref_10_c_4236_p N_noxref_22_c_12331_n ) capacitor c=0.00313536f \
 //x=52.865 //y=2.755 //x2=51.92 //y2=3.365
cc_3760 ( N_noxref_10_c_4258_p N_noxref_22_c_12343_n ) capacitor c=6.99887e-19 \
 //x=51.765 //y=5.335 //x2=51.92 //y2=3.655
cc_3761 ( N_noxref_10_c_4325_p N_noxref_22_c_12343_n ) capacitor c=9.35081e-19 \
 //x=52.575 //y=5.335 //x2=51.92 //y2=3.655
cc_3762 ( N_noxref_10_c_4238_p N_noxref_22_c_12343_n ) capacitor c=2.27923e-19 \
 //x=52.175 //y=1.305 //x2=51.92 //y2=3.655
cc_3763 ( N_noxref_10_c_4216_p N_noxref_22_c_12343_n ) capacitor c=0.00103023f \
 //x=52.26 //y=1.845 //x2=51.92 //y2=3.655
cc_3764 ( N_noxref_10_c_4200_n N_noxref_22_c_12343_n ) capacitor c=0.0164174f \
 //x=52.66 //y=5.25 //x2=51.92 //y2=3.655
cc_3765 ( N_noxref_10_c_4325_p N_noxref_22_c_12247_n ) capacitor c=0.00198098f \
 //x=52.575 //y=5.335 //x2=51.92 //y2=4.75
cc_3766 ( N_noxref_10_c_4200_n N_noxref_22_c_12247_n ) capacitor c=0.0555484f \
 //x=52.66 //y=5.25 //x2=51.92 //y2=4.75
cc_3767 ( N_noxref_10_c_4201_n N_noxref_22_c_12247_n ) capacitor c=0.00107571f \
 //x=54.51 //y=4.755 //x2=51.92 //y2=4.75
cc_3768 ( N_noxref_10_c_4332_p N_noxref_22_c_12247_n ) capacitor c=0.0186792f \
 //x=51.88 //y=5.335 //x2=51.92 //y2=4.75
cc_3769 ( N_noxref_10_c_4333_p N_noxref_22_c_12247_n ) capacitor c=0.00217979f \
 //x=51.88 //y=5.56 //x2=51.92 //y2=4.75
cc_3770 ( N_noxref_10_M128_noxref_g N_noxref_22_c_12353_n ) capacitor \
 c=0.00813346f //x=55.15 //y=6.2 //x2=55.69 //y2=5.335
cc_3771 ( N_noxref_10_c_4239_p N_noxref_22_c_12354_n ) capacitor c=0.00163399f \
 //x=52.575 //y=1.845 //x2=57.07 //y2=1.845
cc_3772 ( N_noxref_10_c_4200_n N_noxref_22_c_12333_n ) capacitor c=0.0010679f \
 //x=52.66 //y=5.25 //x2=51.92 //y2=3.51
cc_3773 ( N_noxref_10_c_4337_p N_noxref_22_c_12269_n ) capacitor c=6.09703e-19 \
 //x=51.88 //y=5.56 //x2=54.932 //y2=5.335
cc_3774 ( N_noxref_10_c_4325_p N_noxref_22_c_12269_n ) capacitor c=0.00306432f \
 //x=52.575 //y=5.335 //x2=54.932 //y2=5.335
cc_3775 ( N_noxref_10_M127_noxref_g N_noxref_22_c_12269_n ) capacitor \
 c=0.00461408f //x=54.71 //y=6.2 //x2=54.932 //y2=5.335
cc_3776 ( N_noxref_10_M128_noxref_g N_noxref_22_c_12269_n ) capacitor \
 c=0.00229208f //x=55.15 //y=6.2 //x2=54.932 //y2=5.335
cc_3777 ( N_noxref_10_c_4205_n N_noxref_22_c_12269_n ) capacitor c=0.00171885f \
 //x=55.075 //y=4.97 //x2=54.932 //y2=5.335
cc_3778 ( N_noxref_10_c_4200_n N_noxref_22_c_12361_n ) capacitor c=0.0222573f \
 //x=52.66 //y=5.25 //x2=55.235 //y2=3.51
cc_3779 ( N_noxref_10_c_4201_n N_noxref_22_c_12361_n ) capacitor c=0.0252489f \
 //x=54.51 //y=4.755 //x2=55.235 //y2=3.51
cc_3780 ( N_noxref_10_c_4237_p N_noxref_22_c_12361_n ) capacitor c=0.0080513f \
 //x=54.305 //y=2.755 //x2=55.235 //y2=3.51
cc_3781 ( N_noxref_10_c_4200_n N_noxref_22_c_12334_n ) capacitor c=0.0026188f \
 //x=52.66 //y=5.25 //x2=52.08 //y2=3.51
cc_3782 ( N_noxref_10_c_4234_p N_noxref_22_c_12365_n ) capacitor c=0.0015536f \
 //x=52.66 //y=2.595 //x2=51.92 //y2=2.26
cc_3783 ( N_noxref_10_c_4325_p N_noxref_22_c_12366_n ) capacitor c=0.00130631f \
 //x=52.575 //y=5.335 //x2=51.92 //y2=4.88
cc_3784 ( N_noxref_10_c_4200_n N_noxref_22_c_12366_n ) capacitor c=0.00126408f \
 //x=52.66 //y=5.25 //x2=51.92 //y2=4.88
cc_3785 ( N_noxref_10_c_4332_p N_noxref_22_c_12366_n ) capacitor c=0.00346456f \
 //x=51.88 //y=5.335 //x2=51.92 //y2=4.88
cc_3786 ( N_noxref_10_c_4333_p N_noxref_22_c_12366_n ) capacitor c=0.00624059f \
 //x=51.88 //y=5.56 //x2=51.92 //y2=4.88
cc_3787 ( N_noxref_10_M127_noxref_g N_noxref_22_c_12370_n ) capacitor \
 c=0.0162284f //x=54.71 //y=6.2 //x2=54.93 //y2=5.56
cc_3788 ( N_noxref_10_M128_noxref_g N_noxref_22_c_12370_n ) capacitor \
 c=0.0179041f //x=55.15 //y=6.2 //x2=54.93 //y2=5.56
cc_3789 ( N_noxref_10_c_4205_n N_noxref_22_c_12370_n ) capacitor c=0.00291477f \
 //x=55.075 //y=4.97 //x2=54.93 //y2=5.56
cc_3790 ( N_noxref_10_c_4258_p N_noxref_22_M125_noxref_g ) capacitor \
 c=0.00875663f //x=51.765 //y=5.335 //x2=51.66 //y2=6.2
cc_3791 ( N_noxref_10_c_4337_p N_noxref_22_M125_noxref_g ) capacitor \
 c=0.00226521f //x=51.88 //y=5.56 //x2=51.66 //y2=6.2
cc_3792 ( N_noxref_10_c_4333_p N_noxref_22_M125_noxref_g ) capacitor \
 c=0.0178885f //x=51.88 //y=5.56 //x2=51.66 //y2=6.2
cc_3793 ( N_noxref_10_c_4337_p N_noxref_22_M126_noxref_g ) capacitor \
 c=0.00381703f //x=51.88 //y=5.56 //x2=52.1 //y2=6.2
cc_3794 ( N_noxref_10_c_4325_p N_noxref_22_M126_noxref_g ) capacitor \
 c=0.0106072f //x=52.575 //y=5.335 //x2=52.1 //y2=6.2
cc_3795 ( N_noxref_10_c_4333_p N_noxref_22_M126_noxref_g ) capacitor \
 c=0.0188608f //x=51.88 //y=5.56 //x2=52.1 //y2=6.2
cc_3796 ( N_noxref_10_c_4238_p N_noxref_22_c_12379_n ) capacitor c=4.64015e-19 \
 //x=52.175 //y=1.305 //x2=51.91 //y2=1.095
cc_3797 ( N_noxref_10_M32_noxref_d N_noxref_22_c_12379_n ) capacitor \
 c=0.00137165f //x=51.985 //y=1.095 //x2=51.91 //y2=1.095
cc_3798 ( N_noxref_10_c_4238_p N_noxref_22_c_12381_n ) capacitor c=0.0026012f \
 //x=52.175 //y=1.305 //x2=51.91 //y2=1.44
cc_3799 ( N_noxref_10_c_4363_p N_noxref_22_c_12381_n ) capacitor c=0.00127432f \
 //x=52.175 //y=1.76 //x2=51.91 //y2=1.44
cc_3800 ( N_noxref_10_M32_noxref_d N_noxref_22_c_12381_n ) capacitor \
 c=0.00237422f //x=51.985 //y=1.095 //x2=51.91 //y2=1.44
cc_3801 ( N_noxref_10_c_4363_p N_noxref_22_c_12384_n ) capacitor c=0.00429966f \
 //x=52.175 //y=1.76 //x2=51.91 //y2=1.75
cc_3802 ( N_noxref_10_c_4238_p N_noxref_22_c_12385_n ) capacitor c=5.29969e-19 \
 //x=52.175 //y=1.305 //x2=52.285 //y2=0.94
cc_3803 ( N_noxref_10_M32_noxref_d N_noxref_22_c_12385_n ) capacitor \
 c=0.0020782f //x=51.985 //y=1.095 //x2=52.285 //y2=0.94
cc_3804 ( N_noxref_10_c_4238_p N_noxref_22_c_12387_n ) capacitor c=5.01873e-19 \
 //x=52.175 //y=1.305 //x2=52.285 //y2=1.595
cc_3805 ( N_noxref_10_c_4363_p N_noxref_22_c_12387_n ) capacitor c=0.00942306f \
 //x=52.175 //y=1.76 //x2=52.285 //y2=1.595
cc_3806 ( N_noxref_10_c_4239_p N_noxref_22_c_12387_n ) capacitor c=0.00194716f \
 //x=52.575 //y=1.845 //x2=52.285 //y2=1.595
cc_3807 ( N_noxref_10_M32_noxref_d N_noxref_22_c_12387_n ) capacitor \
 c=0.00356097f //x=51.985 //y=1.095 //x2=52.285 //y2=1.595
cc_3808 ( N_noxref_10_c_4238_p N_noxref_22_c_12391_n ) capacitor c=5.24634e-19 \
 //x=52.175 //y=1.305 //x2=52.44 //y2=1.095
cc_3809 ( N_noxref_10_M32_noxref_d N_noxref_22_c_12391_n ) capacitor \
 c=0.00139206f //x=51.985 //y=1.095 //x2=52.44 //y2=1.095
cc_3810 ( N_noxref_10_c_4238_p N_noxref_22_c_12393_n ) capacitor c=0.00307978f \
 //x=52.175 //y=1.305 //x2=52.44 //y2=1.44
cc_3811 ( N_noxref_10_c_4363_p N_noxref_22_c_12393_n ) capacitor c=0.00363411f \
 //x=52.175 //y=1.76 //x2=52.44 //y2=1.44
cc_3812 ( N_noxref_10_c_4239_p N_noxref_22_c_12393_n ) capacitor c=0.00323576f \
 //x=52.575 //y=1.845 //x2=52.44 //y2=1.44
cc_3813 ( N_noxref_10_M32_noxref_d N_noxref_22_c_12393_n ) capacitor \
 c=0.00237422f //x=51.985 //y=1.095 //x2=52.44 //y2=1.44
cc_3814 ( N_noxref_10_c_4234_p N_noxref_22_c_12397_n ) capacitor c=0.00242474f \
 //x=52.66 //y=2.595 //x2=51.92 //y2=2.26
cc_3815 ( N_noxref_10_c_4363_p N_noxref_22_c_12398_n ) capacitor c=0.0036273f \
 //x=52.175 //y=1.76 //x2=51.92 //y2=2.095
cc_3816 ( N_noxref_10_c_4234_p N_noxref_22_c_12398_n ) capacitor c=0.00282067f \
 //x=52.66 //y=2.595 //x2=51.92 //y2=2.095
cc_3817 ( N_noxref_10_c_4200_n N_noxref_22_c_12323_n ) capacitor c=0.00714556f \
 //x=52.66 //y=5.25 //x2=51.92 //y2=4.88
cc_3818 ( N_noxref_10_c_4332_p N_noxref_22_c_12323_n ) capacitor c=0.00203307f \
 //x=51.88 //y=5.335 //x2=51.92 //y2=4.88
cc_3819 ( N_noxref_10_c_4333_p N_noxref_22_c_12323_n ) capacitor c=0.00375636f \
 //x=51.88 //y=5.56 //x2=51.92 //y2=4.88
cc_3820 ( N_noxref_10_c_4207_n N_VDD_c_13434_n ) capacitor c=0.00559514f \
 //x=50.88 //y=5.335 //x2=87.775 //y2=7.585
cc_3821 ( N_noxref_10_c_4258_p N_VDD_c_13434_n ) capacitor c=0.00564834f \
 //x=51.765 //y=5.335 //x2=87.775 //y2=7.585
cc_3822 ( N_noxref_10_c_4337_p N_VDD_c_13434_n ) capacitor c=0.00236065f \
 //x=51.88 //y=5.56 //x2=87.775 //y2=7.585
cc_3823 ( N_noxref_10_c_4325_p N_VDD_c_13434_n ) capacitor c=0.00753358f \
 //x=52.575 //y=5.335 //x2=87.775 //y2=7.585
cc_3824 ( N_noxref_10_c_4202_n N_VDD_c_13434_n ) capacitor c=0.00241373f \
 //x=50.122 //y=5.335 //x2=87.775 //y2=7.585
cc_3825 ( N_noxref_10_c_4230_p N_VDD_c_13434_n ) capacitor c=0.00249074f \
 //x=51 //y=5.335 //x2=87.775 //y2=7.585
cc_3826 ( N_noxref_10_c_4211_n N_VDD_c_13434_n ) capacitor c=0.0024232f \
 //x=50.12 //y=5.56 //x2=87.775 //y2=7.585
cc_3827 ( N_noxref_10_c_4233_p N_VDD_c_13434_n ) capacitor c=0.0024232f //x=51 \
 //y=5.56 //x2=87.775 //y2=7.585
cc_3828 ( N_noxref_10_c_4333_p N_VDD_c_13434_n ) capacitor c=0.0024232f \
 //x=51.88 //y=5.56 //x2=87.775 //y2=7.585
cc_3829 ( N_noxref_10_c_4207_n N_VDD_c_13973_n ) capacitor c=0.00202922f \
 //x=50.88 //y=5.335 //x2=50.475 //y2=7.585
cc_3830 ( N_noxref_10_c_4202_n N_VDD_c_13973_n ) capacitor c=9.3757e-19 \
 //x=50.122 //y=5.335 //x2=50.475 //y2=7.585
cc_3831 ( N_noxref_10_c_4211_n N_VDD_c_13973_n ) capacitor c=0.0138074f \
 //x=50.12 //y=5.56 //x2=50.475 //y2=7.585
cc_3832 ( N_noxref_10_c_4207_n N_VDD_c_14018_n ) capacitor c=0.0017708f \
 //x=50.88 //y=5.335 //x2=51.355 //y2=7.585
cc_3833 ( N_noxref_10_c_4258_p N_VDD_c_14018_n ) capacitor c=0.00202922f \
 //x=51.765 //y=5.335 //x2=51.355 //y2=7.585
cc_3834 ( N_noxref_10_c_4230_p N_VDD_c_14018_n ) capacitor c=9.4822e-19 //x=51 \
 //y=5.335 //x2=51.355 //y2=7.585
cc_3835 ( N_noxref_10_c_4233_p N_VDD_c_14018_n ) capacitor c=0.0138074f //x=51 \
 //y=5.56 //x2=51.355 //y2=7.585
cc_3836 ( N_noxref_10_c_4258_p N_VDD_c_14022_n ) capacitor c=0.00205906f \
 //x=51.765 //y=5.335 //x2=52.235 //y2=7.585
cc_3837 ( N_noxref_10_c_4337_p N_VDD_c_14022_n ) capacitor c=8.49654e-19 \
 //x=51.88 //y=5.56 //x2=52.235 //y2=7.585
cc_3838 ( N_noxref_10_c_4325_p N_VDD_c_14022_n ) capacitor c=0.00204238f \
 //x=52.575 //y=5.335 //x2=52.235 //y2=7.585
cc_3839 ( N_noxref_10_c_4333_p N_VDD_c_14022_n ) capacitor c=0.0129519f \
 //x=51.88 //y=5.56 //x2=52.235 //y2=7.585
cc_3840 ( N_noxref_10_c_4325_p N_VDD_c_14026_n ) capacitor c=0.00183742f \
 //x=52.575 //y=5.335 //x2=53.23 //y2=7.585
cc_3841 ( N_noxref_10_M127_noxref_g N_VDD_c_14027_n ) capacitor c=0.00755614f \
 //x=54.71 //y=6.2 //x2=55.285 //y2=7.585
cc_3842 ( N_noxref_10_M128_noxref_g N_VDD_c_14027_n ) capacitor c=0.00755544f \
 //x=55.15 //y=6.2 //x2=55.285 //y2=7.585
cc_3843 ( N_noxref_10_c_4202_n N_VDD_c_13778_n ) capacitor c=0.0022955f \
 //x=50.122 //y=5.335 //x2=48.59 //y2=7.585
cc_3844 ( N_noxref_10_c_4211_n N_VDD_c_13778_n ) capacitor c=0.00509469f \
 //x=50.12 //y=5.56 //x2=48.59 //y2=7.585
cc_3845 ( N_noxref_10_c_4337_p N_VDD_c_13779_n ) capacitor c=0.00282782f \
 //x=51.88 //y=5.56 //x2=53.4 //y2=7.585
cc_3846 ( N_noxref_10_c_4200_n N_VDD_c_13779_n ) capacitor c=0.0321549f \
 //x=52.66 //y=5.25 //x2=53.4 //y2=7.585
cc_3847 ( N_noxref_10_c_4201_n N_VDD_c_13779_n ) capacitor c=0.0107371f \
 //x=54.51 //y=4.755 //x2=53.4 //y2=7.585
cc_3848 ( N_noxref_10_c_4333_p N_VDD_c_13779_n ) capacitor c=0.00777981f \
 //x=51.88 //y=5.56 //x2=53.4 //y2=7.585
cc_3849 ( N_noxref_10_c_4278_p N_VDD_c_13779_n ) capacitor c=0.00371211f \
 //x=54.51 //y=4.88 //x2=53.4 //y2=7.585
cc_3850 ( N_noxref_10_c_4206_n N_VDD_c_13779_n ) capacitor c=0.00572368f \
 //x=54.785 //y=4.97 //x2=53.4 //y2=7.585
cc_3851 ( N_noxref_10_c_4202_n N_VDD_M121_noxref_s ) capacitor c=0.0442713f \
 //x=50.122 //y=5.335 //x2=49.545 //y2=5.2
cc_3852 ( N_noxref_10_c_4230_p N_VDD_M121_noxref_s ) capacitor c=7.80122e-19 \
 //x=51 //y=5.335 //x2=49.545 //y2=5.2
cc_3853 ( N_noxref_10_c_4211_n N_VDD_M121_noxref_s ) capacitor c=0.09305f \
 //x=50.12 //y=5.56 //x2=49.545 //y2=5.2
cc_3854 ( N_noxref_10_c_4207_n N_VDD_M122_noxref_d ) capacitor c=0.00700141f \
 //x=50.88 //y=5.335 //x2=50.415 //y2=5.2
cc_3855 ( N_noxref_10_c_4211_n N_VDD_M122_noxref_d ) capacitor c=0.0674491f \
 //x=50.12 //y=5.56 //x2=50.415 //y2=5.2
cc_3856 ( N_noxref_10_c_4233_p N_VDD_M122_noxref_d ) capacitor c=0.0674762f \
 //x=51 //y=5.56 //x2=50.415 //y2=5.2
cc_3857 ( N_noxref_10_c_4258_p N_VDD_M124_noxref_d ) capacitor c=0.00700141f \
 //x=51.765 //y=5.335 //x2=51.295 //y2=5.2
cc_3858 ( N_noxref_10_c_4233_p N_VDD_M124_noxref_d ) capacitor c=0.067493f \
 //x=51 //y=5.56 //x2=51.295 //y2=5.2
cc_3859 ( N_noxref_10_c_4333_p N_VDD_M124_noxref_d ) capacitor c=0.0674979f \
 //x=51.88 //y=5.56 //x2=51.295 //y2=5.2
cc_3860 ( N_noxref_10_c_4325_p N_VDD_M126_noxref_d ) capacitor c=0.00700141f \
 //x=52.575 //y=5.335 //x2=52.175 //y2=5.2
cc_3861 ( N_noxref_10_c_4333_p N_VDD_M126_noxref_d ) capacitor c=0.0675002f \
 //x=51.88 //y=5.56 //x2=52.175 //y2=5.2
cc_3862 ( N_noxref_10_c_4337_p N_VDD_M127_noxref_s ) capacitor c=0.00492616f \
 //x=51.88 //y=5.56 //x2=54.355 //y2=5.2
cc_3863 ( N_noxref_10_c_4325_p N_VDD_M127_noxref_s ) capacitor c=9.42705e-19 \
 //x=52.575 //y=5.335 //x2=54.355 //y2=5.2
cc_3864 ( N_noxref_10_c_4218_p N_VDD_M127_noxref_s ) capacitor c=4.10511e-19 \
 //x=54.51 //y=2.915 //x2=54.355 //y2=5.2
cc_3865 ( N_noxref_10_c_4201_n N_VDD_M127_noxref_s ) capacitor c=0.0167311f \
 //x=54.51 //y=4.755 //x2=54.355 //y2=5.2
cc_3866 ( N_noxref_10_c_4230_p N_VDD_M127_noxref_s ) capacitor c=2.11884e-19 \
 //x=51 //y=5.335 //x2=54.355 //y2=5.2
cc_3867 ( N_noxref_10_c_4278_p N_VDD_M127_noxref_s ) capacitor c=0.00983846f \
 //x=54.51 //y=4.88 //x2=54.355 //y2=5.2
cc_3868 ( N_noxref_10_M127_noxref_g N_VDD_M127_noxref_s ) capacitor \
 c=0.053419f //x=54.71 //y=6.2 //x2=54.355 //y2=5.2
cc_3869 ( N_noxref_10_c_4206_n N_VDD_M127_noxref_s ) capacitor c=0.00608955f \
 //x=54.785 //y=4.97 //x2=54.355 //y2=5.2
cc_3870 ( N_noxref_10_M128_noxref_g N_VDD_M128_noxref_d ) capacitor \
 c=0.015318f //x=55.15 //y=6.2 //x2=55.225 //y2=5.2
cc_3871 ( N_noxref_10_c_4238_p N_noxref_36_c_15555_n ) capacitor c=0.0036878f \
 //x=52.175 //y=1.305 //x2=52.575 //y2=0.72
cc_3872 ( N_noxref_10_c_4239_p N_noxref_36_c_15555_n ) capacitor c=0.00399931f \
 //x=52.575 //y=1.845 //x2=52.575 //y2=0.72
cc_3873 ( N_noxref_10_M32_noxref_d N_noxref_36_c_15555_n ) capacitor \
 c=0.00910163f //x=51.985 //y=1.095 //x2=52.575 //y2=0.72
cc_3874 ( N_noxref_10_M32_noxref_d N_noxref_36_c_15558_n ) capacitor \
 c=0.00120711f //x=51.985 //y=1.095 //x2=51.69 //y2=1.175
cc_3875 ( N_noxref_10_c_4207_n N_noxref_36_M31_noxref_d ) capacitor \
 c=0.00123819f //x=50.88 //y=5.335 //x2=50.45 //y2=1.09
cc_3876 ( N_noxref_10_c_4238_p N_noxref_36_M31_noxref_d ) capacitor \
 c=0.00802417f //x=52.175 //y=1.305 //x2=50.45 //y2=1.09
cc_3877 ( N_noxref_10_c_4238_p N_noxref_36_M32_noxref_s ) capacitor \
 c=0.0098487f //x=52.175 //y=1.305 //x2=51.555 //y2=0.555
cc_3878 ( N_noxref_10_c_4363_p N_noxref_36_M32_noxref_s ) capacitor \
 c=0.0283243f //x=52.175 //y=1.76 //x2=51.555 //y2=0.555
cc_3879 ( N_noxref_10_c_4239_p N_noxref_36_M32_noxref_s ) capacitor \
 c=0.00752108f //x=52.575 //y=1.845 //x2=51.555 //y2=0.555
cc_3880 ( N_noxref_10_c_4322_p N_noxref_36_M32_noxref_s ) capacitor \
 c=0.00309975f //x=52.66 //y=2.77 //x2=51.555 //y2=0.555
cc_3881 ( N_noxref_10_M32_noxref_d N_noxref_36_M32_noxref_s ) capacitor \
 c=0.0279003f //x=51.985 //y=1.095 //x2=51.555 //y2=0.555
cc_3882 ( N_noxref_10_c_4238_p N_noxref_37_M34_noxref_d ) capacitor \
 c=3.20746e-19 //x=52.175 //y=1.305 //x2=55.26 //y2=1.09
cc_3883 ( N_noxref_10_c_4238_p N_GND_c_16808_n ) capacitor c=0.00884249f \
 //x=52.175 //y=1.305 //x2=54.39 //y2=0.175
cc_3884 ( N_noxref_10_c_4239_p N_GND_c_16808_n ) capacitor c=0.00662211f \
 //x=52.575 //y=1.845 //x2=54.39 //y2=0.175
cc_3885 ( N_noxref_10_c_4227_p N_GND_c_16808_n ) capacitor c=4.42213e-19 \
 //x=52.66 //y=2.915 //x2=54.39 //y2=0.175
cc_3886 ( N_noxref_10_M32_noxref_d N_GND_c_16808_n ) capacitor c=2.9462e-19 \
 //x=51.985 //y=1.095 //x2=54.39 //y2=0.175
cc_3887 ( N_noxref_10_c_4301_p N_GND_c_16812_n ) capacitor c=3.97665e-19 \
 //x=54.21 //y=1.055 //x2=54.475 //y2=1.015
cc_3888 ( N_noxref_10_c_4452_p N_GND_c_16812_n ) capacitor c=0.00864776f \
 //x=54.585 //y=0.9 //x2=54.475 //y2=1.015
cc_3889 ( N_noxref_10_c_4303_p N_GND_c_16812_n ) capacitor c=4.45447e-19 \
 //x=54.74 //y=1.055 //x2=54.475 //y2=1.015
cc_3890 ( N_noxref_10_c_4238_p N_GND_c_16815_n ) capacitor c=0.00543195f \
 //x=52.175 //y=1.305 //x2=54.475 //y2=1.145
cc_3891 ( N_noxref_10_c_4246_p N_GND_c_16815_n ) capacitor c=0.00769783f \
 //x=54.51 //y=2.375 //x2=54.475 //y2=1.145
cc_3892 ( N_noxref_10_c_4218_p N_GND_c_16815_n ) capacitor c=0.00121612f \
 //x=54.51 //y=2.915 //x2=54.475 //y2=1.145
cc_3893 ( N_noxref_10_c_4250_p N_GND_c_16815_n ) capacitor c=2.22883e-19 \
 //x=54.51 //y=2.26 //x2=54.475 //y2=1.145
cc_3894 ( N_noxref_10_c_4301_p N_GND_c_16815_n ) capacitor c=0.00156339f \
 //x=54.21 //y=1.055 //x2=54.475 //y2=1.145
cc_3895 ( N_noxref_10_c_4302_p N_GND_c_16815_n ) capacitor c=0.00352472f \
 //x=54.21 //y=1.4 //x2=54.475 //y2=1.145
cc_3896 ( N_noxref_10_c_4304_p N_GND_c_16815_n ) capacitor c=3.83057e-19 \
 //x=54.21 //y=1.71 //x2=54.475 //y2=1.145
cc_3897 ( N_noxref_10_c_4452_p N_GND_c_16815_n ) capacitor c=9.36995e-19 \
 //x=54.585 //y=0.9 //x2=54.475 //y2=1.145
cc_3898 ( N_noxref_10_c_4462_p N_GND_c_16815_n ) capacitor c=5.2644e-19 \
 //x=54.585 //y=1.555 //x2=54.475 //y2=1.145
cc_3899 ( N_noxref_10_c_4303_p N_GND_c_16815_n ) capacitor c=0.0017438f \
 //x=54.74 //y=1.055 //x2=54.475 //y2=1.145
cc_3900 ( N_noxref_10_c_4305_p N_GND_c_16815_n ) capacitor c=0.00276804f \
 //x=54.74 //y=1.4 //x2=54.475 //y2=1.145
cc_3901 ( N_noxref_10_c_4239_p N_GND_c_16790_n ) capacitor c=6.86343e-19 \
 //x=52.575 //y=1.845 //x2=53.23 //y2=0.175
cc_3902 ( N_noxref_10_c_4227_p N_GND_c_16790_n ) capacitor c=6.10988e-19 \
 //x=52.66 //y=2.915 //x2=53.23 //y2=0.175
cc_3903 ( N_noxref_10_c_4301_p N_GND_c_16828_n ) capacitor c=0.00677766f \
 //x=54.21 //y=1.055 //x2=58.04 //y2=0.175
cc_3904 ( N_noxref_10_c_4363_p N_GND_c_16829_n ) capacitor c=0.0045138f \
 //x=52.175 //y=1.76 //x2=53.4 //y2=0.175
cc_3905 ( N_noxref_10_c_4239_p N_GND_c_16829_n ) capacitor c=0.0225712f \
 //x=52.575 //y=1.845 //x2=53.4 //y2=0.175
cc_3906 ( N_noxref_10_c_4227_p N_GND_c_16829_n ) capacitor c=0.00472354f \
 //x=52.66 //y=2.915 //x2=53.4 //y2=0.175
cc_3907 ( N_noxref_10_c_4246_p N_GND_c_16829_n ) capacitor c=0.00317529f \
 //x=54.51 //y=2.375 //x2=53.4 //y2=0.175
cc_3908 ( N_noxref_10_c_4217_p N_GND_c_16829_n ) capacitor c=0.00371217f \
 //x=54.51 //y=2.595 //x2=53.4 //y2=0.175
cc_3909 ( N_noxref_10_c_4218_p N_GND_c_16829_n ) capacitor c=0.00337857f \
 //x=54.51 //y=2.915 //x2=53.4 //y2=0.175
cc_3910 ( N_noxref_10_c_4322_p N_GND_c_16829_n ) capacitor c=0.0103954f \
 //x=52.66 //y=2.77 //x2=53.4 //y2=0.175
cc_3911 ( N_noxref_10_c_4268_p N_GND_c_16829_n ) capacitor c=0.00527037f \
 //x=54.51 //y=2.77 //x2=53.4 //y2=0.175
cc_3912 ( N_noxref_10_c_4237_p N_GND_c_16829_n ) capacitor c=0.00947774f \
 //x=54.305 //y=2.755 //x2=53.4 //y2=0.175
cc_3913 ( N_noxref_10_c_4250_p N_GND_c_16829_n ) capacitor c=0.0039621f \
 //x=54.51 //y=2.26 //x2=53.4 //y2=0.175
cc_3914 ( N_noxref_10_c_4304_p N_GND_c_16829_n ) capacitor c=0.00170145f \
 //x=54.21 //y=1.71 //x2=53.4 //y2=0.175
cc_3915 ( N_noxref_10_c_4251_p N_GND_c_16829_n ) capacitor c=0.0102191f \
 //x=54.21 //y=2.095 //x2=53.4 //y2=0.175
cc_3916 ( N_noxref_10_c_4246_p N_GND_M33_noxref_d ) capacitor c=4.4417e-19 \
 //x=54.51 //y=2.375 //x2=54.285 //y2=1.055
cc_3917 ( N_noxref_10_c_4301_p N_GND_M33_noxref_d ) capacitor c=0.00184354f \
 //x=54.21 //y=1.055 //x2=54.285 //y2=1.055
cc_3918 ( N_noxref_10_c_4302_p N_GND_M33_noxref_d ) capacitor c=0.00210798f \
 //x=54.21 //y=1.4 //x2=54.285 //y2=1.055
cc_3919 ( N_noxref_10_c_4452_p N_GND_M33_noxref_d ) capacitor c=0.00474029f \
 //x=54.585 //y=0.9 //x2=54.285 //y2=1.055
cc_3920 ( N_noxref_10_c_4462_p N_GND_M33_noxref_d ) capacitor c=0.00166857f \
 //x=54.585 //y=1.555 //x2=54.285 //y2=1.055
cc_3921 ( N_noxref_10_c_4303_p N_GND_M33_noxref_d ) capacitor c=0.00230174f \
 //x=54.74 //y=1.055 //x2=54.285 //y2=1.055
cc_3922 ( N_noxref_10_c_4305_p N_GND_M33_noxref_d ) capacitor c=0.00210798f \
 //x=54.74 //y=1.4 //x2=54.285 //y2=1.055
cc_3923 ( N_noxref_10_c_4251_p N_noxref_58_c_18769_n ) capacitor c=0.00262672f \
 //x=54.21 //y=2.095 //x2=53.99 //y2=1.685
cc_3924 ( N_noxref_10_c_4246_p N_noxref_58_c_18770_n ) capacitor c=0.00428451f \
 //x=54.51 //y=2.375 //x2=54.875 //y2=1.77
cc_3925 ( N_noxref_10_c_4218_p N_noxref_58_c_18770_n ) capacitor c=0.00441095f \
 //x=54.51 //y=2.915 //x2=54.875 //y2=1.77
cc_3926 ( N_noxref_10_c_4250_p N_noxref_58_c_18770_n ) capacitor c=0.0104666f \
 //x=54.51 //y=2.26 //x2=54.875 //y2=1.77
cc_3927 ( N_noxref_10_c_4304_p N_noxref_58_c_18770_n ) capacitor c=0.00703906f \
 //x=54.21 //y=1.71 //x2=54.875 //y2=1.77
cc_3928 ( N_noxref_10_c_4251_p N_noxref_58_c_18770_n ) capacitor c=0.0197675f \
 //x=54.21 //y=2.095 //x2=54.875 //y2=1.77
cc_3929 ( N_noxref_10_c_4462_p N_noxref_58_c_18770_n ) capacitor c=0.00588627f \
 //x=54.585 //y=1.555 //x2=54.875 //y2=1.77
cc_3930 ( N_noxref_10_c_4305_p N_noxref_58_c_18770_n ) capacitor c=0.00698822f \
 //x=54.74 //y=1.4 //x2=54.875 //y2=1.77
cc_3931 ( N_noxref_10_c_4301_p N_noxref_58_M33_noxref_s ) capacitor \
 c=0.0295256f //x=54.21 //y=1.055 //x2=53.855 //y2=0.555
cc_3932 ( N_noxref_10_c_4304_p N_noxref_58_M33_noxref_s ) capacitor \
 c=7.99997e-19 //x=54.21 //y=1.71 //x2=53.855 //y2=0.555
cc_3933 ( N_noxref_10_c_4251_p N_noxref_58_M33_noxref_s ) capacitor \
 c=0.00122123f //x=54.21 //y=2.095 //x2=53.855 //y2=0.555
cc_3934 ( N_noxref_10_c_4303_p N_noxref_58_M33_noxref_s ) capacitor \
 c=0.0125924f //x=54.74 //y=1.055 //x2=53.855 //y2=0.555
cc_3935 ( N_noxref_11_c_4678_n D ) capacitor c=0.00256702f //x=56.73 //y=3.725 \
 //x2=59.32 //y2=2.77
cc_3936 ( N_noxref_11_c_4508_n N_D_c_5184_n ) capacitor c=4.65366e-19 \
 //x=56.73 //y=4.75 //x2=59.32 //y2=4.755
cc_3937 ( N_noxref_11_c_4604_n N_D_c_5190_n ) capacitor c=0.00400537f \
 //x=37.49 //y=4.055 //x2=37.705 //y2=4.28
cc_3938 ( N_noxref_11_c_4499_n N_D_c_5190_n ) capacitor c=0.0208405f //x=37.49 \
 //y=4.75 //x2=37.705 //y2=4.28
cc_3939 ( N_noxref_11_c_4500_n N_D_c_5190_n ) capacitor c=0.00163716f //x=42.3 \
 //y=4.75 //x2=37.705 //y2=4.28
cc_3940 ( N_noxref_11_c_4531_n N_D_c_5190_n ) capacitor c=0.379293f //x=42.14 \
 //y=3.895 //x2=37.705 //y2=4.28
cc_3941 ( N_noxref_11_c_4604_n N_D_c_5173_n ) capacitor c=0.00119935f \
 //x=37.49 //y=4.055 //x2=37.36 //y2=4.28
cc_3942 ( N_noxref_11_c_4499_n N_D_c_5173_n ) capacitor c=7.5617e-19 //x=37.49 \
 //y=4.75 //x2=37.36 //y2=4.28
cc_3943 ( N_noxref_11_c_4632_n N_D_c_5173_n ) capacitor c=0.0358254f //x=37.65 \
 //y=3.895 //x2=37.36 //y2=4.28
cc_3944 ( N_noxref_11_c_4540_n N_D_c_5222_n ) capacitor c=0.00472697f //x=42.3 \
 //y=4.055 //x2=42.595 //y2=4.3
cc_3945 ( N_noxref_11_c_4500_n N_D_c_5222_n ) capacitor c=0.0195373f //x=42.3 \
 //y=4.75 //x2=42.595 //y2=4.3
cc_3946 ( N_noxref_11_c_4556_n N_D_c_5222_n ) capacitor c=0.441395f //x=47.68 \
 //y=3.88 //x2=42.595 //y2=4.3
cc_3947 ( N_noxref_11_c_4531_n N_D_c_5222_n ) capacitor c=0.00941167f \
 //x=42.14 //y=3.895 //x2=42.595 //y2=4.3
cc_3948 ( N_noxref_11_c_4558_n N_D_c_5222_n ) capacitor c=0.0322014f //x=42.46 \
 //y=3.895 //x2=42.595 //y2=4.3
cc_3949 ( N_noxref_11_c_4621_n N_D_c_5198_n ) capacitor c=0.00143862f \
 //x=47.85 //y=4.055 //x2=47.455 //y2=4.25
cc_3950 ( N_noxref_11_c_4505_n N_D_c_5198_n ) capacitor c=6.13038e-19 \
 //x=47.85 //y=5.25 //x2=47.455 //y2=4.25
cc_3951 ( N_noxref_11_c_4556_n N_D_c_5198_n ) capacitor c=0.0112109f //x=47.68 \
 //y=3.88 //x2=47.455 //y2=4.25
cc_3952 ( N_noxref_11_c_4628_n N_D_c_5198_n ) capacitor c=0.0358254f \
 //x=49.565 //y=3.895 //x2=47.455 //y2=4.25
cc_3953 ( N_noxref_11_c_4621_n N_D_c_5202_n ) capacitor c=0.00743351f \
 //x=47.85 //y=4.055 //x2=48.055 //y2=4.28
cc_3954 ( N_noxref_11_c_4505_n N_D_c_5202_n ) capacitor c=0.0224219f //x=47.85 \
 //y=5.25 //x2=48.055 //y2=4.28
cc_3955 ( N_noxref_11_c_4628_n N_D_c_5202_n ) capacitor c=0.125288f //x=49.565 \
 //y=3.895 //x2=48.055 //y2=4.28
cc_3956 ( N_noxref_11_c_4705_p N_D_c_5203_n ) capacitor c=0.00275311f \
 //x=56.73 //y=4.045 //x2=56.345 //y2=4.25
cc_3957 ( N_noxref_11_c_4508_n N_D_c_5203_n ) capacitor c=5.04113e-19 \
 //x=56.73 //y=4.75 //x2=56.345 //y2=4.25
cc_3958 ( N_noxref_11_c_4626_n N_D_c_5203_n ) capacitor c=0.601993f //x=49.91 \
 //y=3.895 //x2=56.345 //y2=4.25
cc_3959 ( N_noxref_11_c_4628_n N_D_c_5203_n ) capacitor c=0.0578277f \
 //x=49.565 //y=3.895 //x2=56.345 //y2=4.25
cc_3960 ( N_noxref_11_c_4705_p N_D_c_5204_n ) capacitor c=0.002495f //x=56.73 \
 //y=4.045 //x2=56.945 //y2=4.27
cc_3961 ( N_noxref_11_c_4508_n N_D_c_5204_n ) capacitor c=0.0210528f //x=56.73 \
 //y=4.75 //x2=56.945 //y2=4.27
cc_3962 ( N_noxref_11_c_4521_n CLK ) capacitor c=0.0295989f //x=37.49 \
 //y=3.735 //x2=36.38 //y2=3.88
cc_3963 ( N_noxref_11_c_4604_n CLK ) capacitor c=0.00782712f //x=37.49 \
 //y=4.055 //x2=36.38 //y2=3.88
cc_3964 ( N_noxref_11_c_4499_n CLK ) capacitor c=0.0130238f //x=37.49 //y=4.75 \
 //x2=36.38 //y2=3.88
cc_3965 ( N_noxref_11_c_4624_n CLK ) capacitor c=5.01652e-19 //x=37.49 \
 //y=3.88 //x2=36.38 //y2=3.88
cc_3966 ( N_noxref_11_c_4632_n CLK ) capacitor c=0.00513442f //x=37.65 \
 //y=3.895 //x2=36.38 //y2=3.88
cc_3967 ( N_noxref_11_c_4640_n CLK ) capacitor c=3.9149e-19 //x=37.49 //y=2.26 \
 //x2=36.38 //y2=3.88
cc_3968 ( N_noxref_11_c_4615_n CLK ) capacitor c=0.00239078f //x=47.85 \
 //y=3.735 //x2=46 //y2=2.77
cc_3969 ( N_noxref_11_c_4505_n CLK ) capacitor c=6.81624e-19 //x=47.85 \
 //y=5.25 //x2=46 //y2=2.77
cc_3970 ( N_noxref_11_c_4556_n CLK ) capacitor c=0.0235232f //x=47.68 //y=3.88 \
 //x2=46 //y2=2.77
cc_3971 ( N_noxref_11_c_4597_n N_CLK_c_6658_n ) capacitor c=0.00939109f \
 //x=37.49 //y=2.375 //x2=36.38 //y2=2.375
cc_3972 ( N_noxref_11_c_4640_n N_CLK_c_6658_n ) capacitor c=5.42289e-19 \
 //x=37.49 //y=2.26 //x2=36.38 //y2=2.375
cc_3973 ( N_noxref_11_c_4669_n N_CLK_c_6658_n ) capacitor c=0.00134951f \
 //x=37.49 //y=2.26 //x2=36.38 //y2=2.375
cc_3974 ( N_noxref_11_c_4499_n N_CLK_c_6592_n ) capacitor c=0.00723254f \
 //x=37.49 //y=4.75 //x2=36.375 //y2=4.835
cc_3975 ( N_noxref_11_c_4641_n N_CLK_c_6592_n ) capacitor c=7.52809e-19 \
 //x=37.49 //y=4.88 //x2=36.375 //y2=4.835
cc_3976 ( N_noxref_11_c_4518_n N_CLK_c_6592_n ) capacitor c=0.0013272f \
 //x=37.49 //y=4.88 //x2=36.375 //y2=4.835
cc_3977 ( N_noxref_11_c_4501_n N_CLK_c_6595_n ) capacitor c=0.020455f \
 //x=46.07 //y=5.335 //x2=46.005 //y2=4.835
cc_3978 ( N_noxref_11_c_4511_n N_CLK_c_6595_n ) capacitor c=0.00547176f \
 //x=46.19 //y=5.335 //x2=46.005 //y2=4.835
cc_3979 ( N_noxref_11_c_4728_p N_CLK_c_6595_n ) capacitor c=0.00148364f \
 //x=46.19 //y=5.56 //x2=46.005 //y2=4.835
cc_3980 ( N_noxref_11_c_4499_n N_CLK_c_6616_n ) capacitor c=0.0231461f \
 //x=37.49 //y=4.75 //x2=45.845 //y2=4.62
cc_3981 ( N_noxref_11_c_4500_n N_CLK_c_6616_n ) capacitor c=0.0231356f \
 //x=42.3 //y=4.75 //x2=45.845 //y2=4.62
cc_3982 ( N_noxref_11_c_4556_n N_CLK_c_6616_n ) capacitor c=0.0315795f \
 //x=47.68 //y=3.88 //x2=45.845 //y2=4.62
cc_3983 ( N_noxref_11_c_4531_n N_CLK_c_6616_n ) capacitor c=0.0268593f \
 //x=42.14 //y=3.895 //x2=45.845 //y2=4.62
cc_3984 ( N_noxref_11_c_4499_n N_CLK_c_6619_n ) capacitor c=0.00449139f \
 //x=37.49 //y=4.75 //x2=36.535 //y2=4.62
cc_3985 ( N_noxref_11_c_4505_n N_CLK_c_6623_n ) capacitor c=0.0230156f \
 //x=47.85 //y=5.25 //x2=59.19 //y2=4.635
cc_3986 ( N_noxref_11_c_4508_n N_CLK_c_6623_n ) capacitor c=0.02329f //x=56.73 \
 //y=4.75 //x2=59.19 //y2=4.635
cc_3987 ( N_noxref_11_c_4626_n N_CLK_c_6623_n ) capacitor c=0.0412545f \
 //x=49.91 //y=3.895 //x2=59.19 //y2=4.635
cc_3988 ( N_noxref_11_c_4628_n N_CLK_c_6623_n ) capacitor c=0.00995922f \
 //x=49.565 //y=3.895 //x2=59.19 //y2=4.635
cc_3989 ( N_noxref_11_c_4597_n N_CLK_c_6668_n ) capacitor c=5.39999e-19 \
 //x=37.49 //y=2.375 //x2=36.38 //y2=2.26
cc_3990 ( N_noxref_11_c_4521_n N_CLK_c_6668_n ) capacitor c=3.9149e-19 \
 //x=37.49 //y=3.735 //x2=36.38 //y2=2.26
cc_3991 ( N_noxref_11_c_4640_n N_CLK_c_6668_n ) capacitor c=0.00125213f \
 //x=37.49 //y=2.26 //x2=36.38 //y2=2.26
cc_3992 ( N_noxref_11_c_4669_n N_CLK_c_6668_n ) capacitor c=0.00204868f \
 //x=37.49 //y=2.26 //x2=36.38 //y2=2.26
cc_3993 ( N_noxref_11_c_4499_n N_CLK_c_6672_n ) capacitor c=4.41153e-19 \
 //x=37.49 //y=4.75 //x2=36.38 //y2=4.88
cc_3994 ( N_noxref_11_c_4641_n N_CLK_c_6672_n ) capacitor c=0.00113671f \
 //x=37.49 //y=4.88 //x2=36.38 //y2=4.88
cc_3995 ( N_noxref_11_c_4518_n N_CLK_c_6672_n ) capacitor c=0.00186974f \
 //x=37.49 //y=4.88 //x2=36.38 //y2=4.88
cc_3996 ( N_noxref_11_c_4501_n N_CLK_c_6715_n ) capacitor c=0.00462965f \
 //x=46.07 //y=5.335 //x2=46 //y2=4.88
cc_3997 ( N_noxref_11_c_4511_n N_CLK_c_6715_n ) capacitor c=0.00132214f \
 //x=46.19 //y=5.335 //x2=46 //y2=4.88
cc_3998 ( N_noxref_11_M107_noxref_g N_CLK_M105_noxref_g ) capacitor \
 c=0.0101598f //x=37.23 //y=6.2 //x2=36.35 //y2=6.2
cc_3999 ( N_noxref_11_M107_noxref_g N_CLK_M106_noxref_g ) capacitor \
 c=0.0607518f //x=37.23 //y=6.2 //x2=36.79 //y2=6.2
cc_4000 ( N_noxref_11_M108_noxref_g N_CLK_M106_noxref_g ) capacitor \
 c=0.0101598f //x=37.67 //y=6.2 //x2=36.79 //y2=6.2
cc_4001 ( N_noxref_11_c_4501_n N_CLK_M117_noxref_g ) capacitor c=0.00856454f \
 //x=46.07 //y=5.335 //x2=45.97 //y2=6.2
cc_4002 ( N_noxref_11_c_4511_n N_CLK_M117_noxref_g ) capacitor c=0.00229818f \
 //x=46.19 //y=5.335 //x2=45.97 //y2=6.2
cc_4003 ( N_noxref_11_c_4728_p N_CLK_M117_noxref_g ) capacitor c=0.0179041f \
 //x=46.19 //y=5.56 //x2=45.97 //y2=6.2
cc_4004 ( N_noxref_11_c_4503_n N_CLK_M118_noxref_g ) capacitor c=0.00952703f \
 //x=46.955 //y=5.335 //x2=46.41 //y2=6.2
cc_4005 ( N_noxref_11_c_4511_n N_CLK_M118_noxref_g ) capacitor c=0.00230699f \
 //x=46.19 //y=5.335 //x2=46.41 //y2=6.2
cc_4006 ( N_noxref_11_c_4728_p N_CLK_M118_noxref_g ) capacitor c=0.0179041f \
 //x=46.19 //y=5.56 //x2=46.41 //y2=6.2
cc_4007 ( N_noxref_11_c_4651_n N_CLK_c_6684_n ) capacitor c=0.00456962f \
 //x=37.48 //y=1.095 //x2=36.47 //y2=1.09
cc_4008 ( N_noxref_11_c_4653_n N_CLK_c_6685_n ) capacitor c=0.00438372f \
 //x=37.48 //y=1.44 //x2=36.47 //y2=1.4
cc_4009 ( N_noxref_11_c_4656_n N_CLK_c_6686_n ) capacitor c=0.00438372f \
 //x=37.48 //y=1.75 //x2=36.47 //y2=1.63
cc_4010 ( N_noxref_11_c_4597_n N_CLK_c_6687_n ) capacitor c=0.00137098f \
 //x=37.49 //y=2.375 //x2=36.47 //y2=2.095
cc_4011 ( N_noxref_11_c_4640_n N_CLK_c_6687_n ) capacitor c=0.00209664f \
 //x=37.49 //y=2.26 //x2=36.47 //y2=2.095
cc_4012 ( N_noxref_11_c_4669_n N_CLK_c_6687_n ) capacitor c=0.00933826f \
 //x=37.49 //y=2.26 //x2=36.47 //y2=2.095
cc_4013 ( N_noxref_11_c_4670_n N_CLK_c_6687_n ) capacitor c=0.00438372f \
 //x=37.49 //y=2.095 //x2=36.47 //y2=2.095
cc_4014 ( N_noxref_11_c_4518_n N_CLK_c_6647_n ) capacitor c=0.0616777f \
 //x=37.49 //y=4.88 //x2=36.715 //y2=4.97
cc_4015 ( N_noxref_11_c_4511_n N_CLK_c_6813_n ) capacitor c=0.00185356f \
 //x=46.19 //y=5.335 //x2=46.335 //y2=4.97
cc_4016 ( N_noxref_11_c_4728_p N_CLK_c_6813_n ) capacitor c=0.00295522f \
 //x=46.19 //y=5.56 //x2=46.335 //y2=4.97
cc_4017 ( N_noxref_11_c_4641_n N_CLK_c_6690_n ) capacitor c=9.77556e-19 \
 //x=37.49 //y=4.88 //x2=36.38 //y2=4.88
cc_4018 ( N_noxref_11_c_4518_n N_CLK_c_6690_n ) capacitor c=0.0042693f \
 //x=37.49 //y=4.88 //x2=36.38 //y2=4.88
cc_4019 ( N_noxref_11_c_4501_n N_CLK_c_6733_n ) capacitor c=3.34061e-19 \
 //x=46.07 //y=5.335 //x2=46 //y2=4.88
cc_4020 ( N_noxref_11_c_4615_n RN ) capacitor c=0.0475066f //x=47.85 //y=3.735 \
 //x2=47.11 //y2=2.77
cc_4021 ( N_noxref_11_c_4621_n RN ) capacitor c=0.0152522f //x=47.85 //y=4.055 \
 //x2=47.11 //y2=2.77
cc_4022 ( N_noxref_11_c_4505_n RN ) capacitor c=0.0261307f //x=47.85 //y=5.25 \
 //x2=47.11 //y2=2.77
cc_4023 ( N_noxref_11_c_4772_p RN ) capacitor c=9.19401e-19 //x=47.85 //y=3.88 \
 //x2=47.11 //y2=2.77
cc_4024 ( N_noxref_11_c_4556_n RN ) capacitor c=0.0216043f //x=47.68 //y=3.88 \
 //x2=47.11 //y2=2.77
cc_4025 ( N_noxref_11_c_4628_n RN ) capacitor c=0.00340182f //x=49.565 \
 //y=3.895 //x2=47.11 //y2=2.77
cc_4026 ( N_noxref_11_c_4615_n RN ) capacitor c=0.00180128f //x=47.85 \
 //y=3.735 //x2=50.81 //y2=2.77
cc_4027 ( N_noxref_11_c_4505_n RN ) capacitor c=6.61562e-19 //x=47.85 //y=5.25 \
 //x2=50.81 //y2=2.77
cc_4028 ( N_noxref_11_c_4626_n RN ) capacitor c=0.0265996f //x=49.91 //y=3.895 \
 //x2=50.81 //y2=2.77
cc_4029 ( N_noxref_11_c_4778_p N_RN_c_8374_n ) capacitor c=4.88647e-19 \
 //x=47.365 //y=1.305 //x2=47.11 //y2=2.565
cc_4030 ( N_noxref_11_c_4615_n N_RN_c_8374_n ) capacitor c=0.0217159f \
 //x=47.85 //y=3.735 //x2=47.11 //y2=2.565
cc_4031 ( N_noxref_11_c_4780_p N_RN_c_8374_n ) capacitor c=4.20274e-19 \
 //x=47.07 //y=5.335 //x2=47.11 //y2=2.565
cc_4032 ( N_noxref_11_c_4676_n N_RN_c_8125_n ) capacitor c=0.00198098f \
 //x=47.765 //y=5.335 //x2=47.11 //y2=4.75
cc_4033 ( N_noxref_11_c_4505_n N_RN_c_8125_n ) capacitor c=0.0129043f \
 //x=47.85 //y=5.25 //x2=47.11 //y2=4.75
cc_4034 ( N_noxref_11_c_4780_p N_RN_c_8125_n ) capacitor c=0.0186792f \
 //x=47.07 //y=5.335 //x2=47.11 //y2=4.75
cc_4035 ( N_noxref_11_c_4784_p N_RN_c_8125_n ) capacitor c=0.00260684f \
 //x=47.07 //y=5.56 //x2=47.11 //y2=4.75
cc_4036 ( N_noxref_11_c_4597_n N_RN_c_8024_n ) capacitor c=0.0160806f \
 //x=37.49 //y=2.375 //x2=42.825 //y2=2.385
cc_4037 ( N_noxref_11_c_4521_n N_RN_c_8024_n ) capacitor c=0.0129637f \
 //x=37.49 //y=3.735 //x2=42.825 //y2=2.385
cc_4038 ( N_noxref_11_c_4532_n N_RN_c_8024_n ) capacitor c=0.0167111f //x=42.3 \
 //y=2.375 //x2=42.825 //y2=2.385
cc_4039 ( N_noxref_11_c_4528_n N_RN_c_8024_n ) capacitor c=0.0154065f //x=42.3 \
 //y=3.735 //x2=42.825 //y2=2.385
cc_4040 ( N_noxref_11_c_4640_n N_RN_c_8024_n ) capacitor c=2.63835e-19 \
 //x=37.49 //y=2.26 //x2=42.825 //y2=2.385
cc_4041 ( N_noxref_11_c_4559_n N_RN_c_8024_n ) capacitor c=2.63835e-19 \
 //x=42.3 //y=2.26 //x2=42.825 //y2=2.385
cc_4042 ( N_noxref_11_c_4669_n N_RN_c_8024_n ) capacitor c=3.41298e-19 \
 //x=37.49 //y=2.26 //x2=42.825 //y2=2.385
cc_4043 ( N_noxref_11_c_4591_n N_RN_c_8024_n ) capacitor c=3.41298e-19 \
 //x=42.3 //y=2.26 //x2=42.825 //y2=2.385
cc_4044 ( N_noxref_11_c_4549_n N_RN_c_8275_n ) capacitor c=0.021648f //x=47.45 \
 //y=1.845 //x2=50.645 //y2=2.4
cc_4045 ( N_noxref_11_c_4615_n N_RN_c_8275_n ) capacitor c=0.0300597f \
 //x=47.85 //y=3.735 //x2=50.645 //y2=2.4
cc_4046 ( N_noxref_11_c_4626_n N_RN_c_8275_n ) capacitor c=0.00274327f \
 //x=49.91 //y=3.895 //x2=50.645 //y2=2.4
cc_4047 ( N_noxref_11_c_4778_p N_RN_c_8235_n ) capacitor c=3.86337e-19 \
 //x=47.365 //y=1.305 //x2=47.275 //y2=2.4
cc_4048 ( N_noxref_11_c_4615_n N_RN_c_8235_n ) capacitor c=0.00328982f \
 //x=47.85 //y=3.735 //x2=47.275 //y2=2.4
cc_4049 ( N_noxref_11_c_4626_n N_RN_c_8281_n ) capacitor c=0.00212385f \
 //x=49.91 //y=3.895 //x2=52.49 //y2=2.37
cc_4050 ( N_noxref_11_c_4799_p N_RN_c_8353_n ) capacitor c=0.0160734f \
 //x=56.73 //y=2.375 //x2=71.685 //y2=2.385
cc_4051 ( N_noxref_11_c_4678_n N_RN_c_8353_n ) capacitor c=0.0156253f \
 //x=56.73 //y=3.725 //x2=71.685 //y2=2.385
cc_4052 ( N_noxref_11_c_4801_p N_RN_c_8353_n ) capacitor c=2.63835e-19 \
 //x=56.73 //y=2.26 //x2=71.685 //y2=2.385
cc_4053 ( N_noxref_11_c_4802_p N_RN_c_8353_n ) capacitor c=3.41298e-19 \
 //x=56.73 //y=2.26 //x2=71.685 //y2=2.385
cc_4054 ( N_noxref_11_c_4615_n N_RN_c_8399_n ) capacitor c=9.86766e-19 \
 //x=47.85 //y=3.735 //x2=47.11 //y2=2.26
cc_4055 ( N_noxref_11_c_4676_n N_RN_c_8400_n ) capacitor c=0.00130631f \
 //x=47.765 //y=5.335 //x2=47.11 //y2=4.88
cc_4056 ( N_noxref_11_c_4505_n N_RN_c_8400_n ) capacitor c=0.00126408f \
 //x=47.85 //y=5.25 //x2=47.11 //y2=4.88
cc_4057 ( N_noxref_11_c_4780_p N_RN_c_8400_n ) capacitor c=0.00346456f \
 //x=47.07 //y=5.335 //x2=47.11 //y2=4.88
cc_4058 ( N_noxref_11_c_4784_p N_RN_c_8400_n ) capacitor c=0.00624059f \
 //x=47.07 //y=5.56 //x2=47.11 //y2=4.88
cc_4059 ( N_noxref_11_c_4503_n N_RN_M119_noxref_g ) capacitor c=0.00875663f \
 //x=46.955 //y=5.335 //x2=46.85 //y2=6.2
cc_4060 ( N_noxref_11_c_4675_n N_RN_M119_noxref_g ) capacitor c=0.00226521f \
 //x=47.07 //y=5.56 //x2=46.85 //y2=6.2
cc_4061 ( N_noxref_11_c_4784_p N_RN_M119_noxref_g ) capacitor c=0.0178885f \
 //x=47.07 //y=5.56 //x2=46.85 //y2=6.2
cc_4062 ( N_noxref_11_c_4675_n N_RN_M120_noxref_g ) capacitor c=0.00381703f \
 //x=47.07 //y=5.56 //x2=47.29 //y2=6.2
cc_4063 ( N_noxref_11_c_4676_n N_RN_M120_noxref_g ) capacitor c=0.0103093f \
 //x=47.765 //y=5.335 //x2=47.29 //y2=6.2
cc_4064 ( N_noxref_11_c_4784_p N_RN_M120_noxref_g ) capacitor c=0.0188608f \
 //x=47.07 //y=5.56 //x2=47.29 //y2=6.2
cc_4065 ( N_noxref_11_c_4778_p N_RN_c_8410_n ) capacitor c=4.64015e-19 \
 //x=47.365 //y=1.305 //x2=47.1 //y2=1.095
cc_4066 ( N_noxref_11_M29_noxref_d N_RN_c_8410_n ) capacitor c=0.00137165f \
 //x=47.175 //y=1.095 //x2=47.1 //y2=1.095
cc_4067 ( N_noxref_11_c_4778_p N_RN_c_8412_n ) capacitor c=0.0026012f \
 //x=47.365 //y=1.305 //x2=47.1 //y2=1.44
cc_4068 ( N_noxref_11_c_4817_p N_RN_c_8412_n ) capacitor c=0.00127432f \
 //x=47.365 //y=1.76 //x2=47.1 //y2=1.44
cc_4069 ( N_noxref_11_M29_noxref_d N_RN_c_8412_n ) capacitor c=0.00237422f \
 //x=47.175 //y=1.095 //x2=47.1 //y2=1.44
cc_4070 ( N_noxref_11_c_4817_p N_RN_c_8415_n ) capacitor c=0.00441386f \
 //x=47.365 //y=1.76 //x2=47.1 //y2=1.75
cc_4071 ( N_noxref_11_c_4778_p N_RN_c_8416_n ) capacitor c=5.29969e-19 \
 //x=47.365 //y=1.305 //x2=47.475 //y2=0.94
cc_4072 ( N_noxref_11_M29_noxref_d N_RN_c_8416_n ) capacitor c=0.0020782f \
 //x=47.175 //y=1.095 //x2=47.475 //y2=0.94
cc_4073 ( N_noxref_11_c_4778_p N_RN_c_8418_n ) capacitor c=4.41409e-19 \
 //x=47.365 //y=1.305 //x2=47.475 //y2=1.595
cc_4074 ( N_noxref_11_c_4817_p N_RN_c_8418_n ) capacitor c=0.00942306f \
 //x=47.365 //y=1.76 //x2=47.475 //y2=1.595
cc_4075 ( N_noxref_11_c_4677_n N_RN_c_8418_n ) capacitor c=0.00194716f \
 //x=47.765 //y=1.845 //x2=47.475 //y2=1.595
cc_4076 ( N_noxref_11_M29_noxref_d N_RN_c_8418_n ) capacitor c=0.00356097f \
 //x=47.175 //y=1.095 //x2=47.475 //y2=1.595
cc_4077 ( N_noxref_11_c_4778_p N_RN_c_8422_n ) capacitor c=5.24634e-19 \
 //x=47.365 //y=1.305 //x2=47.63 //y2=1.095
cc_4078 ( N_noxref_11_M29_noxref_d N_RN_c_8422_n ) capacitor c=0.00139206f \
 //x=47.175 //y=1.095 //x2=47.63 //y2=1.095
cc_4079 ( N_noxref_11_c_4778_p N_RN_c_8424_n ) capacitor c=0.00307978f \
 //x=47.365 //y=1.305 //x2=47.63 //y2=1.44
cc_4080 ( N_noxref_11_c_4817_p N_RN_c_8424_n ) capacitor c=0.00363411f \
 //x=47.365 //y=1.76 //x2=47.63 //y2=1.44
cc_4081 ( N_noxref_11_c_4677_n N_RN_c_8424_n ) capacitor c=0.00323576f \
 //x=47.765 //y=1.845 //x2=47.63 //y2=1.44
cc_4082 ( N_noxref_11_M29_noxref_d N_RN_c_8424_n ) capacitor c=0.00237422f \
 //x=47.175 //y=1.095 //x2=47.63 //y2=1.44
cc_4083 ( N_noxref_11_c_4615_n N_RN_c_8428_n ) capacitor c=0.00117465f \
 //x=47.85 //y=3.735 //x2=47.11 //y2=2.26
cc_4084 ( N_noxref_11_c_4817_p N_RN_c_8429_n ) capacitor c=0.0036273f \
 //x=47.365 //y=1.76 //x2=47.11 //y2=2.095
cc_4085 ( N_noxref_11_c_4615_n N_RN_c_8429_n ) capacitor c=0.00282067f \
 //x=47.85 //y=3.735 //x2=47.11 //y2=2.095
cc_4086 ( N_noxref_11_c_4505_n N_RN_c_8179_n ) capacitor c=0.00714556f \
 //x=47.85 //y=5.25 //x2=47.11 //y2=4.88
cc_4087 ( N_noxref_11_c_4780_p N_RN_c_8179_n ) capacitor c=0.00203307f \
 //x=47.07 //y=5.335 //x2=47.11 //y2=4.88
cc_4088 ( N_noxref_11_c_4784_p N_RN_c_8179_n ) capacitor c=0.00375636f \
 //x=47.07 //y=5.56 //x2=47.11 //y2=4.88
cc_4089 ( N_noxref_11_c_4528_n SN ) capacitor c=0.0141637f //x=42.3 //y=3.735 \
 //x2=41.19 //y2=2.77
cc_4090 ( N_noxref_11_c_4559_n SN ) capacitor c=3.9149e-19 //x=42.3 //y=2.26 \
 //x2=41.19 //y2=2.77
cc_4091 ( N_noxref_11_c_4678_n SN ) capacitor c=0.0150527f //x=56.73 //y=3.725 \
 //x2=55.62 //y2=2.77
cc_4092 ( N_noxref_11_c_4801_p SN ) capacitor c=3.9149e-19 //x=56.73 //y=2.26 \
 //x2=55.62 //y2=2.77
cc_4093 ( N_noxref_11_c_4528_n SN ) capacitor c=5.01652e-19 //x=42.3 //y=3.735 \
 //x2=41.19 //y2=3.14
cc_4094 ( N_noxref_11_c_4678_n SN ) capacitor c=3.43503e-19 //x=56.73 \
 //y=3.725 //x2=55.62 //y2=3.14
cc_4095 ( N_noxref_11_c_4532_n N_SN_c_10111_n ) capacitor c=0.00934497f \
 //x=42.3 //y=2.375 //x2=41.19 //y2=2.375
cc_4096 ( N_noxref_11_c_4559_n N_SN_c_10111_n ) capacitor c=5.42289e-19 \
 //x=42.3 //y=2.26 //x2=41.19 //y2=2.375
cc_4097 ( N_noxref_11_c_4591_n N_SN_c_10111_n ) capacitor c=0.00134951f \
 //x=42.3 //y=2.26 //x2=41.19 //y2=2.375
cc_4098 ( N_noxref_11_c_4528_n N_SN_c_10114_n ) capacitor c=0.00786461f \
 //x=42.3 //y=3.735 //x2=41.19 //y2=3.285
cc_4099 ( N_noxref_11_c_4528_n N_SN_c_10068_n ) capacitor c=0.0110327f \
 //x=42.3 //y=3.735 //x2=41.19 //y2=4.765
cc_4100 ( N_noxref_11_c_4540_n N_SN_c_10068_n ) capacitor c=0.0078001f \
 //x=42.3 //y=4.055 //x2=41.19 //y2=4.765
cc_4101 ( N_noxref_11_c_4500_n N_SN_c_10068_n ) capacitor c=0.0226505f \
 //x=42.3 //y=4.75 //x2=41.19 //y2=4.765
cc_4102 ( N_noxref_11_c_4550_n N_SN_c_10068_n ) capacitor c=5.01652e-19 \
 //x=42.3 //y=3.88 //x2=41.19 //y2=4.765
cc_4103 ( N_noxref_11_c_4531_n N_SN_c_10068_n ) capacitor c=0.0229186f \
 //x=42.14 //y=3.895 //x2=41.19 //y2=4.765
cc_4104 ( N_noxref_11_c_4558_n N_SN_c_10068_n ) capacitor c=0.0024779f \
 //x=42.46 //y=3.895 //x2=41.19 //y2=4.765
cc_4105 ( N_noxref_11_c_4560_n N_SN_c_10068_n ) capacitor c=7.3565e-19 \
 //x=42.3 //y=4.88 //x2=41.19 //y2=4.765
cc_4106 ( N_noxref_11_c_4519_n N_SN_c_10068_n ) capacitor c=0.00118533f \
 //x=42.3 //y=4.88 //x2=41.19 //y2=4.765
cc_4107 ( N_noxref_11_c_4799_p N_SN_c_10239_n ) capacitor c=0.00933257f \
 //x=56.73 //y=2.375 //x2=55.62 //y2=2.375
cc_4108 ( N_noxref_11_c_4801_p N_SN_c_10239_n ) capacitor c=5.42289e-19 \
 //x=56.73 //y=2.26 //x2=55.62 //y2=2.375
cc_4109 ( N_noxref_11_c_4802_p N_SN_c_10239_n ) capacitor c=0.00134951f \
 //x=56.73 //y=2.26 //x2=55.62 //y2=2.375
cc_4110 ( N_noxref_11_c_4678_n N_SN_c_10242_n ) capacitor c=0.00671686f \
 //x=56.73 //y=3.725 //x2=55.62 //y2=3.305
cc_4111 ( N_noxref_11_c_4678_n N_SN_c_10069_n ) capacitor c=0.00951468f \
 //x=56.73 //y=3.725 //x2=55.62 //y2=4.765
cc_4112 ( N_noxref_11_c_4705_p N_SN_c_10069_n ) capacitor c=0.00772613f \
 //x=56.73 //y=4.045 //x2=55.62 //y2=4.765
cc_4113 ( N_noxref_11_c_4508_n N_SN_c_10069_n ) capacitor c=0.0228817f \
 //x=56.73 //y=4.75 //x2=55.62 //y2=4.765
cc_4114 ( N_noxref_11_c_4863_p N_SN_c_10069_n ) capacitor c=2.98349e-19 \
 //x=56.73 //y=3.88 //x2=55.62 //y2=4.765
cc_4115 ( N_noxref_11_c_4626_n N_SN_c_10069_n ) capacitor c=0.0251585f \
 //x=49.91 //y=3.895 //x2=55.62 //y2=4.765
cc_4116 ( N_noxref_11_c_4865_p N_SN_c_10069_n ) capacitor c=7.3565e-19 \
 //x=56.73 //y=4.88 //x2=55.62 //y2=4.765
cc_4117 ( N_noxref_11_c_4520_n N_SN_c_10069_n ) capacitor c=0.00118533f \
 //x=56.73 //y=4.88 //x2=55.62 //y2=4.765
cc_4118 ( N_noxref_11_c_4521_n N_SN_c_10134_n ) capacitor c=0.0230421f \
 //x=37.49 //y=3.735 //x2=37.845 //y2=3.14
cc_4119 ( N_noxref_11_c_4531_n N_SN_c_10134_n ) capacitor c=0.0063321f \
 //x=42.14 //y=3.895 //x2=37.845 //y2=3.14
cc_4120 ( N_noxref_11_c_4531_n N_SN_c_10135_n ) capacitor c=0.00880561f \
 //x=42.14 //y=3.895 //x2=38.445 //y2=3.11
cc_4121 ( N_noxref_11_c_4531_n N_SN_c_10137_n ) capacitor c=0.00359897f \
 //x=42.14 //y=3.895 //x2=39.695 //y2=3.14
cc_4122 ( N_noxref_11_c_4556_n N_SN_c_10178_n ) capacitor c=0.00888265f \
 //x=47.68 //y=3.88 //x2=43.255 //y2=3.155
cc_4123 ( N_noxref_11_c_4528_n N_SN_c_10143_n ) capacitor c=0.0266386f \
 //x=42.3 //y=3.735 //x2=42.91 //y2=3.155
cc_4124 ( N_noxref_11_c_4556_n N_SN_c_10143_n ) capacitor c=0.0066776f \
 //x=47.68 //y=3.88 //x2=42.91 //y2=3.155
cc_4125 ( N_noxref_11_c_4531_n N_SN_c_10143_n ) capacitor c=0.0127497f \
 //x=42.14 //y=3.895 //x2=42.91 //y2=3.155
cc_4126 ( N_noxref_11_c_4556_n N_SN_c_10184_n ) capacitor c=0.00356173f \
 //x=47.68 //y=3.88 //x2=44.515 //y2=3.14
cc_4127 ( N_noxref_11_c_4556_n N_SN_c_10188_n ) capacitor c=0.0211848f \
 //x=47.68 //y=3.88 //x2=45.115 //y2=3.155
cc_4128 ( N_noxref_11_c_4615_n N_SN_c_10225_n ) capacitor c=0.0262127f \
 //x=47.85 //y=3.735 //x2=49.31 //y2=3.14
cc_4129 ( N_noxref_11_c_4628_n N_SN_c_10225_n ) capacitor c=0.0138642f \
 //x=49.565 //y=3.895 //x2=49.31 //y2=3.14
cc_4130 ( N_noxref_11_c_4626_n N_SN_c_10228_n ) capacitor c=0.10601f //x=49.91 \
 //y=3.895 //x2=49.91 //y2=3.125
cc_4131 ( N_noxref_11_c_4678_n N_SN_c_10255_n ) capacitor c=0.026821f \
 //x=56.73 //y=3.725 //x2=61.335 //y2=3.13
cc_4132 ( N_noxref_11_c_4626_n N_SN_c_10255_n ) capacitor c=0.00656884f \
 //x=49.91 //y=3.895 //x2=61.335 //y2=3.13
cc_4133 ( N_noxref_11_c_4532_n N_SN_c_10144_n ) capacitor c=5.39999e-19 \
 //x=42.3 //y=2.375 //x2=41.19 //y2=2.26
cc_4134 ( N_noxref_11_c_4528_n N_SN_c_10144_n ) capacitor c=3.9149e-19 \
 //x=42.3 //y=3.735 //x2=41.19 //y2=2.26
cc_4135 ( N_noxref_11_c_4559_n N_SN_c_10144_n ) capacitor c=0.00125213f \
 //x=42.3 //y=2.26 //x2=41.19 //y2=2.26
cc_4136 ( N_noxref_11_c_4591_n N_SN_c_10144_n ) capacitor c=0.00204868f \
 //x=42.3 //y=2.26 //x2=41.19 //y2=2.26
cc_4137 ( N_noxref_11_c_4500_n N_SN_c_10083_n ) capacitor c=9.36945e-19 \
 //x=42.3 //y=4.75 //x2=41.19 //y2=4.88
cc_4138 ( N_noxref_11_c_4560_n N_SN_c_10083_n ) capacitor c=0.00113985f \
 //x=42.3 //y=4.88 //x2=41.19 //y2=4.88
cc_4139 ( N_noxref_11_c_4519_n N_SN_c_10083_n ) capacitor c=0.00187046f \
 //x=42.3 //y=4.88 //x2=41.19 //y2=4.88
cc_4140 ( N_noxref_11_c_4799_p N_SN_c_10257_n ) capacitor c=5.39999e-19 \
 //x=56.73 //y=2.375 //x2=55.62 //y2=2.26
cc_4141 ( N_noxref_11_c_4678_n N_SN_c_10257_n ) capacitor c=3.9149e-19 \
 //x=56.73 //y=3.725 //x2=55.62 //y2=2.26
cc_4142 ( N_noxref_11_c_4801_p N_SN_c_10257_n ) capacitor c=0.00125213f \
 //x=56.73 //y=2.26 //x2=55.62 //y2=2.26
cc_4143 ( N_noxref_11_c_4802_p N_SN_c_10257_n ) capacitor c=0.00204868f \
 //x=56.73 //y=2.26 //x2=55.62 //y2=2.26
cc_4144 ( N_noxref_11_c_4508_n N_SN_c_10084_n ) capacitor c=9.36945e-19 \
 //x=56.73 //y=4.75 //x2=55.62 //y2=4.88
cc_4145 ( N_noxref_11_c_4865_p N_SN_c_10084_n ) capacitor c=0.00113985f \
 //x=56.73 //y=4.88 //x2=55.62 //y2=4.88
cc_4146 ( N_noxref_11_c_4520_n N_SN_c_10084_n ) capacitor c=0.00187046f \
 //x=56.73 //y=4.88 //x2=55.62 //y2=4.88
cc_4147 ( N_noxref_11_M113_noxref_g N_SN_M111_noxref_g ) capacitor \
 c=0.0101598f //x=42.04 //y=6.2 //x2=41.16 //y2=6.2
cc_4148 ( N_noxref_11_M113_noxref_g N_SN_M112_noxref_g ) capacitor \
 c=0.0607518f //x=42.04 //y=6.2 //x2=41.6 //y2=6.2
cc_4149 ( N_noxref_11_M114_noxref_g N_SN_M112_noxref_g ) capacitor \
 c=0.0101598f //x=42.48 //y=6.2 //x2=41.6 //y2=6.2
cc_4150 ( N_noxref_11_M131_noxref_g N_SN_M129_noxref_g ) capacitor \
 c=0.0101598f //x=56.47 //y=6.2 //x2=55.59 //y2=6.2
cc_4151 ( N_noxref_11_M131_noxref_g N_SN_M130_noxref_g ) capacitor \
 c=0.0607518f //x=56.47 //y=6.2 //x2=56.03 //y2=6.2
cc_4152 ( N_noxref_11_M132_noxref_g N_SN_M130_noxref_g ) capacitor \
 c=0.0101598f //x=56.91 //y=6.2 //x2=56.03 //y2=6.2
cc_4153 ( N_noxref_11_c_4573_n N_SN_c_10160_n ) capacitor c=0.00456962f \
 //x=42.29 //y=1.095 //x2=41.28 //y2=1.09
cc_4154 ( N_noxref_11_c_4575_n N_SN_c_10161_n ) capacitor c=0.00438372f \
 //x=42.29 //y=1.44 //x2=41.28 //y2=1.4
cc_4155 ( N_noxref_11_c_4578_n N_SN_c_10162_n ) capacitor c=0.00438372f \
 //x=42.29 //y=1.75 //x2=41.28 //y2=1.63
cc_4156 ( N_noxref_11_c_4532_n N_SN_c_10163_n ) capacitor c=0.00137098f \
 //x=42.3 //y=2.375 //x2=41.28 //y2=2.095
cc_4157 ( N_noxref_11_c_4559_n N_SN_c_10163_n ) capacitor c=0.00209664f \
 //x=42.3 //y=2.26 //x2=41.28 //y2=2.095
cc_4158 ( N_noxref_11_c_4591_n N_SN_c_10163_n ) capacitor c=0.00933826f \
 //x=42.3 //y=2.26 //x2=41.28 //y2=2.095
cc_4159 ( N_noxref_11_c_4592_n N_SN_c_10163_n ) capacitor c=0.00438372f \
 //x=42.3 //y=2.095 //x2=41.28 //y2=2.095
cc_4160 ( N_noxref_11_c_4519_n N_SN_c_10100_n ) capacitor c=0.0616777f \
 //x=42.3 //y=4.88 //x2=41.525 //y2=4.97
cc_4161 ( N_noxref_11_c_4910_p N_SN_c_10273_n ) capacitor c=0.00456962f \
 //x=56.72 //y=1.095 //x2=55.71 //y2=1.09
cc_4162 ( N_noxref_11_c_4911_p N_SN_c_10274_n ) capacitor c=0.00438372f \
 //x=56.72 //y=1.44 //x2=55.71 //y2=1.4
cc_4163 ( N_noxref_11_c_4912_p N_SN_c_10275_n ) capacitor c=0.00438372f \
 //x=56.72 //y=1.75 //x2=55.71 //y2=1.63
cc_4164 ( N_noxref_11_c_4799_p N_SN_c_10276_n ) capacitor c=0.00137098f \
 //x=56.73 //y=2.375 //x2=55.71 //y2=2.095
cc_4165 ( N_noxref_11_c_4801_p N_SN_c_10276_n ) capacitor c=0.00209664f \
 //x=56.73 //y=2.26 //x2=55.71 //y2=2.095
cc_4166 ( N_noxref_11_c_4802_p N_SN_c_10276_n ) capacitor c=0.00933826f \
 //x=56.73 //y=2.26 //x2=55.71 //y2=2.095
cc_4167 ( N_noxref_11_c_4916_p N_SN_c_10276_n ) capacitor c=0.00438372f \
 //x=56.73 //y=2.095 //x2=55.71 //y2=2.095
cc_4168 ( N_noxref_11_c_4520_n N_SN_c_10101_n ) capacitor c=0.0616777f \
 //x=56.73 //y=4.88 //x2=55.955 //y2=4.97
cc_4169 ( N_noxref_11_c_4500_n N_SN_c_10166_n ) capacitor c=8.42568e-19 \
 //x=42.3 //y=4.75 //x2=41.19 //y2=4.88
cc_4170 ( N_noxref_11_c_4560_n N_SN_c_10166_n ) capacitor c=0.00129812f \
 //x=42.3 //y=4.88 //x2=41.19 //y2=4.88
cc_4171 ( N_noxref_11_c_4519_n N_SN_c_10166_n ) capacitor c=0.00487508f \
 //x=42.3 //y=4.88 //x2=41.19 //y2=4.88
cc_4172 ( N_noxref_11_c_4508_n N_SN_c_10279_n ) capacitor c=8.42568e-19 \
 //x=56.73 //y=4.75 //x2=55.62 //y2=4.88
cc_4173 ( N_noxref_11_c_4865_p N_SN_c_10279_n ) capacitor c=0.00129812f \
 //x=56.73 //y=4.88 //x2=55.62 //y2=4.88
cc_4174 ( N_noxref_11_c_4520_n N_SN_c_10279_n ) capacitor c=0.00487508f \
 //x=56.73 //y=4.88 //x2=55.62 //y2=4.88
cc_4175 ( N_noxref_11_c_4626_n N_noxref_22_c_12343_n ) capacitor c=0.0056341f \
 //x=49.91 //y=3.895 //x2=51.92 //y2=3.655
cc_4176 ( N_noxref_11_c_4626_n N_noxref_22_c_12247_n ) capacitor c=0.0214933f \
 //x=49.91 //y=3.895 //x2=51.92 //y2=4.75
cc_4177 ( N_noxref_11_c_4705_p N_noxref_22_c_12405_n ) capacitor c=0.0015277f \
 //x=56.73 //y=4.045 //x2=56.575 //y2=5.335
cc_4178 ( N_noxref_11_M131_noxref_g N_noxref_22_c_12405_n ) capacitor \
 c=0.00895456f //x=56.47 //y=6.2 //x2=56.575 //y2=5.335
cc_4179 ( N_noxref_11_M131_noxref_g N_noxref_22_c_12407_n ) capacitor \
 c=0.00226521f //x=56.47 //y=6.2 //x2=56.69 //y2=5.56
cc_4180 ( N_noxref_11_M132_noxref_g N_noxref_22_c_12407_n ) capacitor \
 c=0.00381703f //x=56.91 //y=6.2 //x2=56.69 //y2=5.56
cc_4181 ( N_noxref_11_c_4705_p N_noxref_22_c_12409_n ) capacitor c=3.44988e-19 \
 //x=56.73 //y=4.045 //x2=57.385 //y2=5.335
cc_4182 ( N_noxref_11_c_4508_n N_noxref_22_c_12409_n ) capacitor c=0.00198098f \
 //x=56.73 //y=4.75 //x2=57.385 //y2=5.335
cc_4183 ( N_noxref_11_c_4865_p N_noxref_22_c_12409_n ) capacitor c=0.00130631f \
 //x=56.73 //y=4.88 //x2=57.385 //y2=5.335
cc_4184 ( N_noxref_11_M132_noxref_g N_noxref_22_c_12409_n ) capacitor \
 c=0.0103821f //x=56.91 //y=6.2 //x2=57.385 //y2=5.335
cc_4185 ( N_noxref_11_c_4910_p N_noxref_22_c_12413_n ) capacitor c=4.64015e-19 \
 //x=56.72 //y=1.095 //x2=56.985 //y2=1.305
cc_4186 ( N_noxref_11_c_4911_p N_noxref_22_c_12413_n ) capacitor c=0.0026012f \
 //x=56.72 //y=1.44 //x2=56.985 //y2=1.305
cc_4187 ( N_noxref_11_c_4936_p N_noxref_22_c_12413_n ) capacitor c=5.29969e-19 \
 //x=57.095 //y=0.94 //x2=56.985 //y2=1.305
cc_4188 ( N_noxref_11_c_4937_p N_noxref_22_c_12413_n ) capacitor c=5.31989e-19 \
 //x=57.095 //y=1.595 //x2=56.985 //y2=1.305
cc_4189 ( N_noxref_11_c_4938_p N_noxref_22_c_12413_n ) capacitor c=5.24634e-19 \
 //x=57.25 //y=1.095 //x2=56.985 //y2=1.305
cc_4190 ( N_noxref_11_c_4939_p N_noxref_22_c_12413_n ) capacitor c=0.00307978f \
 //x=57.25 //y=1.44 //x2=56.985 //y2=1.305
cc_4191 ( N_noxref_11_c_4911_p N_noxref_22_c_12419_n ) capacitor c=0.00127432f \
 //x=56.72 //y=1.44 //x2=56.985 //y2=1.76
cc_4192 ( N_noxref_11_c_4912_p N_noxref_22_c_12419_n ) capacitor c=0.00429966f \
 //x=56.72 //y=1.75 //x2=56.985 //y2=1.76
cc_4193 ( N_noxref_11_c_4937_p N_noxref_22_c_12419_n ) capacitor c=0.00942306f \
 //x=57.095 //y=1.595 //x2=56.985 //y2=1.76
cc_4194 ( N_noxref_11_c_4939_p N_noxref_22_c_12419_n ) capacitor c=0.00363411f \
 //x=57.25 //y=1.44 //x2=56.985 //y2=1.76
cc_4195 ( N_noxref_11_c_4916_p N_noxref_22_c_12419_n ) capacitor c=0.0036273f \
 //x=56.73 //y=2.095 //x2=56.985 //y2=1.76
cc_4196 ( N_noxref_11_c_4937_p N_noxref_22_c_12424_n ) capacitor c=0.00194716f \
 //x=57.095 //y=1.595 //x2=57.385 //y2=1.845
cc_4197 ( N_noxref_11_c_4939_p N_noxref_22_c_12424_n ) capacitor c=0.00323576f \
 //x=57.25 //y=1.44 //x2=57.385 //y2=1.845
cc_4198 ( N_noxref_11_c_4799_p N_noxref_22_c_12426_n ) capacitor c=0.0140058f \
 //x=56.73 //y=2.375 //x2=57.47 //y2=3.365
cc_4199 ( N_noxref_11_c_4678_n N_noxref_22_c_12426_n ) capacitor c=0.0393254f \
 //x=56.73 //y=3.725 //x2=57.47 //y2=3.365
cc_4200 ( N_noxref_11_c_4801_p N_noxref_22_c_12426_n ) capacitor c=0.0015536f \
 //x=56.73 //y=2.26 //x2=57.47 //y2=3.365
cc_4201 ( N_noxref_11_c_4802_p N_noxref_22_c_12426_n ) capacitor c=0.0024584f \
 //x=56.73 //y=2.26 //x2=57.47 //y2=3.365
cc_4202 ( N_noxref_11_c_4916_p N_noxref_22_c_12426_n ) capacitor c=0.00282067f \
 //x=56.73 //y=2.095 //x2=57.47 //y2=3.365
cc_4203 ( N_noxref_11_c_4678_n N_noxref_22_c_12431_n ) capacitor c=0.0175988f \
 //x=56.73 //y=3.725 //x2=57.47 //y2=3.685
cc_4204 ( N_noxref_11_c_4678_n N_noxref_22_c_12248_n ) capacitor c=0.00127953f \
 //x=56.73 //y=3.725 //x2=57.47 //y2=5.25
cc_4205 ( N_noxref_11_c_4705_p N_noxref_22_c_12248_n ) capacitor c=0.0146192f \
 //x=56.73 //y=4.045 //x2=57.47 //y2=5.25
cc_4206 ( N_noxref_11_c_4508_n N_noxref_22_c_12248_n ) capacitor c=0.039522f \
 //x=56.73 //y=4.75 //x2=57.47 //y2=5.25
cc_4207 ( N_noxref_11_c_4863_p N_noxref_22_c_12248_n ) capacitor c=5.99013e-19 \
 //x=56.73 //y=3.88 //x2=57.47 //y2=5.25
cc_4208 ( N_noxref_11_c_4626_n N_noxref_22_c_12248_n ) capacitor c=0.00387472f \
 //x=49.91 //y=3.895 //x2=57.47 //y2=5.25
cc_4209 ( N_noxref_11_c_4865_p N_noxref_22_c_12248_n ) capacitor c=0.00126408f \
 //x=56.73 //y=4.88 //x2=57.47 //y2=5.25
cc_4210 ( N_noxref_11_c_4520_n N_noxref_22_c_12248_n ) capacitor c=0.00714556f \
 //x=56.73 //y=4.88 //x2=57.47 //y2=5.25
cc_4211 ( N_noxref_11_c_4508_n N_noxref_22_c_12439_n ) capacitor c=0.018645f \
 //x=56.73 //y=4.75 //x2=56.69 //y2=5.335
cc_4212 ( N_noxref_11_c_4865_p N_noxref_22_c_12439_n ) capacitor c=0.00346456f \
 //x=56.73 //y=4.88 //x2=56.69 //y2=5.335
cc_4213 ( N_noxref_11_c_4520_n N_noxref_22_c_12439_n ) capacitor c=0.00203307f \
 //x=56.73 //y=4.88 //x2=56.69 //y2=5.335
cc_4214 ( N_noxref_11_c_4678_n N_noxref_22_c_12442_n ) capacitor c=9.19401e-19 \
 //x=56.73 //y=3.725 //x2=57.47 //y2=3.51
cc_4215 ( N_noxref_11_c_4626_n N_noxref_22_c_12361_n ) capacitor c=0.337668f \
 //x=49.91 //y=3.895 //x2=55.235 //y2=3.51
cc_4216 ( N_noxref_11_c_4626_n N_noxref_22_c_12334_n ) capacitor c=0.0357422f \
 //x=49.91 //y=3.895 //x2=52.08 //y2=3.51
cc_4217 ( N_noxref_11_c_4678_n N_noxref_22_c_12445_n ) capacitor c=3.27922e-19 \
 //x=56.73 //y=3.725 //x2=55.835 //y2=3.53
cc_4218 ( N_noxref_11_c_4626_n N_noxref_22_c_12445_n ) capacitor c=0.0449969f \
 //x=49.91 //y=3.895 //x2=55.835 //y2=3.53
cc_4219 ( N_noxref_11_c_4678_n N_noxref_22_c_12447_n ) capacitor c=2.52001e-19 \
 //x=56.73 //y=3.725 //x2=56.345 //y2=3.51
cc_4220 ( N_noxref_11_c_4705_p N_noxref_22_c_12447_n ) capacitor c=0.00203652f \
 //x=56.73 //y=4.045 //x2=56.345 //y2=3.51
cc_4221 ( N_noxref_11_c_4626_n N_noxref_22_c_12447_n ) capacitor c=0.0108859f \
 //x=49.91 //y=3.895 //x2=56.345 //y2=3.51
cc_4222 ( N_noxref_11_c_4678_n N_noxref_22_c_12450_n ) capacitor c=0.0200562f \
 //x=56.73 //y=3.725 //x2=56.945 //y2=3.5
cc_4223 ( N_noxref_11_c_4705_p N_noxref_22_c_12450_n ) capacitor c=0.00435339f \
 //x=56.73 //y=4.045 //x2=56.945 //y2=3.5
cc_4224 ( N_noxref_11_c_4626_n N_noxref_22_c_12450_n ) capacitor c=0.0358686f \
 //x=49.91 //y=3.895 //x2=56.945 //y2=3.5
cc_4225 ( N_noxref_11_c_4678_n N_noxref_22_c_12453_n ) capacitor c=0.00429473f \
 //x=56.73 //y=3.725 //x2=57.63 //y2=3.88
cc_4226 ( N_noxref_11_c_4705_p N_noxref_22_c_12453_n ) capacitor c=0.00228619f \
 //x=56.73 //y=4.045 //x2=57.63 //y2=3.88
cc_4227 ( N_noxref_11_c_4626_n N_noxref_22_c_12453_n ) capacitor c=0.0128167f \
 //x=49.91 //y=3.895 //x2=57.63 //y2=3.88
cc_4228 ( N_noxref_11_c_4508_n N_noxref_22_c_12456_n ) capacitor c=0.00217979f \
 //x=56.73 //y=4.75 //x2=56.69 //y2=5.56
cc_4229 ( N_noxref_11_c_4865_p N_noxref_22_c_12456_n ) capacitor c=0.00624059f \
 //x=56.73 //y=4.88 //x2=56.69 //y2=5.56
cc_4230 ( N_noxref_11_M131_noxref_g N_noxref_22_c_12456_n ) capacitor \
 c=0.0178885f //x=56.47 //y=6.2 //x2=56.69 //y2=5.56
cc_4231 ( N_noxref_11_M132_noxref_g N_noxref_22_c_12456_n ) capacitor \
 c=0.0188608f //x=56.91 //y=6.2 //x2=56.69 //y2=5.56
cc_4232 ( N_noxref_11_c_4520_n N_noxref_22_c_12456_n ) capacitor c=0.00375636f \
 //x=56.73 //y=4.88 //x2=56.69 //y2=5.56
cc_4233 ( N_noxref_11_c_4910_p N_noxref_22_M35_noxref_d ) capacitor \
 c=0.00137165f //x=56.72 //y=1.095 //x2=56.795 //y2=1.095
cc_4234 ( N_noxref_11_c_4911_p N_noxref_22_M35_noxref_d ) capacitor \
 c=0.00237422f //x=56.72 //y=1.44 //x2=56.795 //y2=1.095
cc_4235 ( N_noxref_11_c_4936_p N_noxref_22_M35_noxref_d ) capacitor \
 c=0.0020782f //x=57.095 //y=0.94 //x2=56.795 //y2=1.095
cc_4236 ( N_noxref_11_c_4937_p N_noxref_22_M35_noxref_d ) capacitor \
 c=0.00356097f //x=57.095 //y=1.595 //x2=56.795 //y2=1.095
cc_4237 ( N_noxref_11_c_4938_p N_noxref_22_M35_noxref_d ) capacitor \
 c=0.00139206f //x=57.25 //y=1.095 //x2=56.795 //y2=1.095
cc_4238 ( N_noxref_11_c_4939_p N_noxref_22_M35_noxref_d ) capacitor \
 c=0.00237422f //x=57.25 //y=1.44 //x2=56.795 //y2=1.095
cc_4239 ( N_noxref_11_c_4501_n N_VDD_c_13434_n ) capacitor c=0.00564708f \
 //x=46.07 //y=5.335 //x2=87.775 //y2=7.585
cc_4240 ( N_noxref_11_c_4503_n N_VDD_c_13434_n ) capacitor c=0.00571183f \
 //x=46.955 //y=5.335 //x2=87.775 //y2=7.585
cc_4241 ( N_noxref_11_c_4675_n N_VDD_c_13434_n ) capacitor c=0.00236065f \
 //x=47.07 //y=5.56 //x2=87.775 //y2=7.585
cc_4242 ( N_noxref_11_c_4676_n N_VDD_c_13434_n ) capacitor c=0.00753358f \
 //x=47.765 //y=5.335 //x2=87.775 //y2=7.585
cc_4243 ( N_noxref_11_c_4621_n N_VDD_c_13434_n ) capacitor c=3.31354e-19 \
 //x=47.85 //y=4.055 //x2=87.775 //y2=7.585
cc_4244 ( N_noxref_11_c_4509_n N_VDD_c_13434_n ) capacitor c=0.00238907f \
 //x=45.312 //y=5.335 //x2=87.775 //y2=7.585
cc_4245 ( N_noxref_11_c_4511_n N_VDD_c_13434_n ) capacitor c=0.00245065f \
 //x=46.19 //y=5.335 //x2=87.775 //y2=7.585
cc_4246 ( N_noxref_11_c_4564_n N_VDD_c_13434_n ) capacitor c=0.0024232f \
 //x=45.31 //y=5.56 //x2=87.775 //y2=7.585
cc_4247 ( N_noxref_11_c_4728_p N_VDD_c_13434_n ) capacitor c=0.0024232f \
 //x=46.19 //y=5.56 //x2=87.775 //y2=7.585
cc_4248 ( N_noxref_11_c_4784_p N_VDD_c_13434_n ) capacitor c=0.0024232f \
 //x=47.07 //y=5.56 //x2=87.775 //y2=7.585
cc_4249 ( N_noxref_11_M107_noxref_g N_VDD_c_13968_n ) capacitor c=0.00755544f \
 //x=37.23 //y=6.2 //x2=37.805 //y2=7.585
cc_4250 ( N_noxref_11_M108_noxref_g N_VDD_c_13968_n ) capacitor c=0.00755754f \
 //x=37.67 //y=6.2 //x2=37.805 //y2=7.585
cc_4251 ( N_noxref_11_M113_noxref_g N_VDD_c_13913_n ) capacitor c=0.00755544f \
 //x=42.04 //y=6.2 //x2=42.615 //y2=7.585
cc_4252 ( N_noxref_11_M114_noxref_g N_VDD_c_13913_n ) capacitor c=0.00755754f \
 //x=42.48 //y=6.2 //x2=42.615 //y2=7.585
cc_4253 ( N_noxref_11_c_4501_n N_VDD_c_13918_n ) capacitor c=0.00202922f \
 //x=46.07 //y=5.335 //x2=45.665 //y2=7.585
cc_4254 ( N_noxref_11_c_4509_n N_VDD_c_13918_n ) capacitor c=9.3757e-19 \
 //x=45.312 //y=5.335 //x2=45.665 //y2=7.585
cc_4255 ( N_noxref_11_c_4564_n N_VDD_c_13918_n ) capacitor c=0.0138074f \
 //x=45.31 //y=5.56 //x2=45.665 //y2=7.585
cc_4256 ( N_noxref_11_c_4501_n N_VDD_c_14074_n ) capacitor c=0.0017708f \
 //x=46.07 //y=5.335 //x2=46.545 //y2=7.585
cc_4257 ( N_noxref_11_c_4503_n N_VDD_c_14074_n ) capacitor c=0.00202922f \
 //x=46.955 //y=5.335 //x2=46.545 //y2=7.585
cc_4258 ( N_noxref_11_c_4511_n N_VDD_c_14074_n ) capacitor c=9.4822e-19 \
 //x=46.19 //y=5.335 //x2=46.545 //y2=7.585
cc_4259 ( N_noxref_11_c_4728_p N_VDD_c_14074_n ) capacitor c=0.0138074f \
 //x=46.19 //y=5.56 //x2=46.545 //y2=7.585
cc_4260 ( N_noxref_11_c_4503_n N_VDD_c_14078_n ) capacitor c=0.00205906f \
 //x=46.955 //y=5.335 //x2=47.425 //y2=7.585
cc_4261 ( N_noxref_11_c_4675_n N_VDD_c_14078_n ) capacitor c=8.49654e-19 \
 //x=47.07 //y=5.56 //x2=47.425 //y2=7.585
cc_4262 ( N_noxref_11_c_4676_n N_VDD_c_14078_n ) capacitor c=0.00204238f \
 //x=47.765 //y=5.335 //x2=47.425 //y2=7.585
cc_4263 ( N_noxref_11_c_4784_p N_VDD_c_14078_n ) capacitor c=0.0129519f \
 //x=47.07 //y=5.56 //x2=47.425 //y2=7.585
cc_4264 ( N_noxref_11_c_4676_n N_VDD_c_14082_n ) capacitor c=0.00183742f \
 //x=47.765 //y=5.335 //x2=48.42 //y2=7.585
cc_4265 ( N_noxref_11_M131_noxref_g N_VDD_c_14083_n ) capacitor c=0.00755544f \
 //x=56.47 //y=6.2 //x2=57.045 //y2=7.585
cc_4266 ( N_noxref_11_M132_noxref_g N_VDD_c_14083_n ) capacitor c=0.00755754f \
 //x=56.91 //y=6.2 //x2=57.045 //y2=7.585
cc_4267 ( N_noxref_11_c_4641_n N_VDD_c_13775_n ) capacitor c=0.00205049f \
 //x=37.49 //y=4.88 //x2=38.97 //y2=7.585
cc_4268 ( N_noxref_11_c_4509_n N_VDD_c_13776_n ) capacitor c=0.00244337f \
 //x=45.312 //y=5.335 //x2=43.78 //y2=7.585
cc_4269 ( N_noxref_11_c_4560_n N_VDD_c_13776_n ) capacitor c=0.00205049f \
 //x=42.3 //y=4.88 //x2=43.78 //y2=7.585
cc_4270 ( N_noxref_11_c_4564_n N_VDD_c_13776_n ) capacitor c=0.00509469f \
 //x=45.31 //y=5.56 //x2=43.78 //y2=7.585
cc_4271 ( N_noxref_11_c_4675_n N_VDD_c_13778_n ) capacitor c=0.00282782f \
 //x=47.07 //y=5.56 //x2=48.59 //y2=7.585
cc_4272 ( N_noxref_11_c_4505_n N_VDD_c_13778_n ) capacitor c=0.0313791f \
 //x=47.85 //y=5.25 //x2=48.59 //y2=7.585
cc_4273 ( N_noxref_11_c_4784_p N_VDD_c_13778_n ) capacitor c=0.00777981f \
 //x=47.07 //y=5.56 //x2=48.59 //y2=7.585
cc_4274 ( N_noxref_11_c_4865_p N_VDD_c_13780_n ) capacitor c=0.00205049f \
 //x=56.73 //y=4.88 //x2=58.21 //y2=7.585
cc_4275 ( N_noxref_11_M107_noxref_g N_VDD_M106_noxref_d ) capacitor \
 c=0.015318f //x=37.23 //y=6.2 //x2=36.865 //y2=5.2
cc_4276 ( N_noxref_11_M108_noxref_g N_VDD_M108_noxref_d ) capacitor \
 c=0.0394719f //x=37.67 //y=6.2 //x2=37.745 //y2=5.2
cc_4277 ( N_noxref_11_M113_noxref_g N_VDD_M112_noxref_d ) capacitor \
 c=0.015318f //x=42.04 //y=6.2 //x2=41.675 //y2=5.2
cc_4278 ( N_noxref_11_M114_noxref_g N_VDD_M114_noxref_d ) capacitor \
 c=0.0394719f //x=42.48 //y=6.2 //x2=42.555 //y2=5.2
cc_4279 ( N_noxref_11_c_4509_n N_VDD_M115_noxref_s ) capacitor c=0.0442713f \
 //x=45.312 //y=5.335 //x2=44.735 //y2=5.2
cc_4280 ( N_noxref_11_c_4511_n N_VDD_M115_noxref_s ) capacitor c=7.80122e-19 \
 //x=46.19 //y=5.335 //x2=44.735 //y2=5.2
cc_4281 ( N_noxref_11_c_4564_n N_VDD_M115_noxref_s ) capacitor c=0.09305f \
 //x=45.31 //y=5.56 //x2=44.735 //y2=5.2
cc_4282 ( N_noxref_11_c_4501_n N_VDD_M116_noxref_d ) capacitor c=0.00700141f \
 //x=46.07 //y=5.335 //x2=45.605 //y2=5.2
cc_4283 ( N_noxref_11_c_4564_n N_VDD_M116_noxref_d ) capacitor c=0.0674491f \
 //x=45.31 //y=5.56 //x2=45.605 //y2=5.2
cc_4284 ( N_noxref_11_c_4728_p N_VDD_M116_noxref_d ) capacitor c=0.0674762f \
 //x=46.19 //y=5.56 //x2=45.605 //y2=5.2
cc_4285 ( N_noxref_11_c_4503_n N_VDD_M118_noxref_d ) capacitor c=0.00700141f \
 //x=46.955 //y=5.335 //x2=46.485 //y2=5.2
cc_4286 ( N_noxref_11_c_4728_p N_VDD_M118_noxref_d ) capacitor c=0.067493f \
 //x=46.19 //y=5.56 //x2=46.485 //y2=5.2
cc_4287 ( N_noxref_11_c_4784_p N_VDD_M118_noxref_d ) capacitor c=0.0674979f \
 //x=47.07 //y=5.56 //x2=46.485 //y2=5.2
cc_4288 ( N_noxref_11_c_4676_n N_VDD_M120_noxref_d ) capacitor c=0.00700141f \
 //x=47.765 //y=5.335 //x2=47.365 //y2=5.2
cc_4289 ( N_noxref_11_c_4784_p N_VDD_M120_noxref_d ) capacitor c=0.0675002f \
 //x=47.07 //y=5.56 //x2=47.365 //y2=5.2
cc_4290 ( N_noxref_11_c_4675_n N_VDD_M121_noxref_s ) capacitor c=0.00492616f \
 //x=47.07 //y=5.56 //x2=49.545 //y2=5.2
cc_4291 ( N_noxref_11_c_4676_n N_VDD_M121_noxref_s ) capacitor c=9.42705e-19 \
 //x=47.765 //y=5.335 //x2=49.545 //y2=5.2
cc_4292 ( N_noxref_11_c_4511_n N_VDD_M121_noxref_s ) capacitor c=2.11884e-19 \
 //x=46.19 //y=5.335 //x2=49.545 //y2=5.2
cc_4293 ( N_noxref_11_M131_noxref_g N_VDD_M130_noxref_d ) capacitor \
 c=0.015318f //x=56.47 //y=6.2 //x2=56.105 //y2=5.2
cc_4294 ( N_noxref_11_M132_noxref_g N_VDD_M132_noxref_d ) capacitor \
 c=0.0394719f //x=56.91 //y=6.2 //x2=56.985 //y2=5.2
cc_4295 ( N_noxref_11_c_4597_n N_noxref_33_c_15354_n ) capacitor c=0.00177186f \
 //x=37.49 //y=2.375 //x2=38.145 //y2=0.72
cc_4296 ( N_noxref_11_c_4640_n N_noxref_33_c_15354_n ) capacitor c=0.00117306f \
 //x=37.49 //y=2.26 //x2=38.145 //y2=0.72
cc_4297 ( N_noxref_11_c_4651_n N_noxref_33_c_15354_n ) capacitor c=0.0206349f \
 //x=37.48 //y=1.095 //x2=38.145 //y2=0.72
cc_4298 ( N_noxref_11_c_4663_n N_noxref_33_c_15354_n ) capacitor c=0.00825432f \
 //x=38.01 //y=1.095 //x2=38.145 //y2=0.72
cc_4299 ( N_noxref_11_c_4669_n N_noxref_33_c_15354_n ) capacitor c=2.20712e-19 \
 //x=37.49 //y=2.26 //x2=38.145 //y2=0.72
cc_4300 ( N_noxref_11_c_4653_n N_noxref_33_c_15357_n ) capacitor c=0.0071177f \
 //x=37.48 //y=1.44 //x2=37.26 //y2=1.175
cc_4301 ( N_noxref_11_c_4651_n N_noxref_33_M23_noxref_s ) capacitor \
 c=0.0071177f //x=37.48 //y=1.095 //x2=37.125 //y2=0.555
cc_4302 ( N_noxref_11_c_4656_n N_noxref_33_M23_noxref_s ) capacitor \
 c=0.0071177f //x=37.48 //y=1.75 //x2=37.125 //y2=0.555
cc_4303 ( N_noxref_11_c_4663_n N_noxref_33_M23_noxref_s ) capacitor \
 c=0.015333f //x=38.01 //y=1.095 //x2=37.125 //y2=0.555
cc_4304 ( N_noxref_11_c_4665_n N_noxref_33_M23_noxref_s ) capacitor \
 c=0.00248746f //x=38.01 //y=1.44 //x2=37.125 //y2=0.555
cc_4305 ( N_noxref_11_c_4532_n N_noxref_34_c_15420_n ) capacitor c=0.00177186f \
 //x=42.3 //y=2.375 //x2=42.955 //y2=0.72
cc_4306 ( N_noxref_11_c_4559_n N_noxref_34_c_15420_n ) capacitor c=0.00117306f \
 //x=42.3 //y=2.26 //x2=42.955 //y2=0.72
cc_4307 ( N_noxref_11_c_4573_n N_noxref_34_c_15420_n ) capacitor c=0.0206349f \
 //x=42.29 //y=1.095 //x2=42.955 //y2=0.72
cc_4308 ( N_noxref_11_c_4585_n N_noxref_34_c_15420_n ) capacitor c=0.00825432f \
 //x=42.82 //y=1.095 //x2=42.955 //y2=0.72
cc_4309 ( N_noxref_11_c_4591_n N_noxref_34_c_15420_n ) capacitor c=2.20712e-19 \
 //x=42.3 //y=2.26 //x2=42.955 //y2=0.72
cc_4310 ( N_noxref_11_c_4575_n N_noxref_34_c_15423_n ) capacitor c=0.0071177f \
 //x=42.29 //y=1.44 //x2=42.07 //y2=1.175
cc_4311 ( N_noxref_11_c_4540_n N_noxref_34_M26_noxref_s ) capacitor \
 c=9.71372e-19 //x=42.3 //y=4.055 //x2=41.935 //y2=0.555
cc_4312 ( N_noxref_11_c_4573_n N_noxref_34_M26_noxref_s ) capacitor \
 c=0.0071177f //x=42.29 //y=1.095 //x2=41.935 //y2=0.555
cc_4313 ( N_noxref_11_c_4578_n N_noxref_34_M26_noxref_s ) capacitor \
 c=0.0071177f //x=42.29 //y=1.75 //x2=41.935 //y2=0.555
cc_4314 ( N_noxref_11_c_4585_n N_noxref_34_M26_noxref_s ) capacitor \
 c=0.015333f //x=42.82 //y=1.095 //x2=41.935 //y2=0.555
cc_4315 ( N_noxref_11_c_4587_n N_noxref_34_M26_noxref_s ) capacitor \
 c=0.00248746f //x=42.82 //y=1.44 //x2=41.935 //y2=0.555
cc_4316 ( N_noxref_11_c_4778_p N_noxref_35_c_15489_n ) capacitor c=0.0036878f \
 //x=47.365 //y=1.305 //x2=47.765 //y2=0.72
cc_4317 ( N_noxref_11_c_4677_n N_noxref_35_c_15489_n ) capacitor c=0.00399931f \
 //x=47.765 //y=1.845 //x2=47.765 //y2=0.72
cc_4318 ( N_noxref_11_M29_noxref_d N_noxref_35_c_15489_n ) capacitor \
 c=0.00910163f //x=47.175 //y=1.095 //x2=47.765 //y2=0.72
cc_4319 ( N_noxref_11_M29_noxref_d N_noxref_35_c_15492_n ) capacitor \
 c=0.00120711f //x=47.175 //y=1.095 //x2=46.88 //y2=1.175
cc_4320 ( N_noxref_11_c_4501_n N_noxref_35_M28_noxref_d ) capacitor \
 c=7.30522e-19 //x=46.07 //y=5.335 //x2=45.64 //y2=1.09
cc_4321 ( N_noxref_11_c_4778_p N_noxref_35_M28_noxref_d ) capacitor \
 c=0.00802417f //x=47.365 //y=1.305 //x2=45.64 //y2=1.09
cc_4322 ( N_noxref_11_c_4778_p N_noxref_35_M29_noxref_s ) capacitor \
 c=0.0098487f //x=47.365 //y=1.305 //x2=46.745 //y2=0.555
cc_4323 ( N_noxref_11_c_4817_p N_noxref_35_M29_noxref_s ) capacitor \
 c=0.0283243f //x=47.365 //y=1.76 //x2=46.745 //y2=0.555
cc_4324 ( N_noxref_11_c_4677_n N_noxref_35_M29_noxref_s ) capacitor \
 c=0.00911719f //x=47.765 //y=1.845 //x2=46.745 //y2=0.555
cc_4325 ( N_noxref_11_c_4772_p N_noxref_35_M29_noxref_s ) capacitor \
 c=0.00129723f //x=47.85 //y=3.88 //x2=46.745 //y2=0.555
cc_4326 ( N_noxref_11_M29_noxref_d N_noxref_35_M29_noxref_s ) capacitor \
 c=0.0279003f //x=47.175 //y=1.095 //x2=46.745 //y2=0.555
cc_4327 ( N_noxref_11_c_4778_p N_noxref_36_M31_noxref_d ) capacitor \
 c=3.20746e-19 //x=47.365 //y=1.305 //x2=50.45 //y2=1.09
cc_4328 ( N_noxref_11_c_4799_p N_noxref_37_c_15624_n ) capacitor c=0.00177186f \
 //x=56.73 //y=2.375 //x2=57.385 //y2=0.72
cc_4329 ( N_noxref_11_c_4801_p N_noxref_37_c_15624_n ) capacitor c=0.00117306f \
 //x=56.73 //y=2.26 //x2=57.385 //y2=0.72
cc_4330 ( N_noxref_11_c_4910_p N_noxref_37_c_15624_n ) capacitor c=0.0206349f \
 //x=56.72 //y=1.095 //x2=57.385 //y2=0.72
cc_4331 ( N_noxref_11_c_4938_p N_noxref_37_c_15624_n ) capacitor c=0.00825432f \
 //x=57.25 //y=1.095 //x2=57.385 //y2=0.72
cc_4332 ( N_noxref_11_c_4802_p N_noxref_37_c_15624_n ) capacitor c=2.20712e-19 \
 //x=56.73 //y=2.26 //x2=57.385 //y2=0.72
cc_4333 ( N_noxref_11_c_4911_p N_noxref_37_c_15629_n ) capacitor c=0.0071177f \
 //x=56.72 //y=1.44 //x2=56.5 //y2=1.175
cc_4334 ( N_noxref_11_c_4705_p N_noxref_37_M35_noxref_s ) capacitor \
 c=9.73433e-19 //x=56.73 //y=4.045 //x2=56.365 //y2=0.555
cc_4335 ( N_noxref_11_c_4910_p N_noxref_37_M35_noxref_s ) capacitor \
 c=0.0071177f //x=56.72 //y=1.095 //x2=56.365 //y2=0.555
cc_4336 ( N_noxref_11_c_4912_p N_noxref_37_M35_noxref_s ) capacitor \
 c=0.0071177f //x=56.72 //y=1.75 //x2=56.365 //y2=0.555
cc_4337 ( N_noxref_11_c_4938_p N_noxref_37_M35_noxref_s ) capacitor \
 c=0.015333f //x=57.25 //y=1.095 //x2=56.365 //y2=0.555
cc_4338 ( N_noxref_11_c_4939_p N_noxref_37_M35_noxref_s ) capacitor \
 c=0.00248746f //x=57.25 //y=1.44 //x2=56.365 //y2=0.555
cc_4339 ( N_noxref_11_c_4597_n N_GND_c_16769_n ) capacitor c=0.00196498f \
 //x=37.49 //y=2.375 //x2=39.96 //y2=0.175
cc_4340 ( N_noxref_11_c_4532_n N_GND_c_16728_n ) capacitor c=0.00196498f \
 //x=42.3 //y=2.375 //x2=44.77 //y2=0.175
cc_4341 ( N_noxref_11_c_4778_p N_GND_c_16850_n ) capacitor c=0.00884007f \
 //x=47.365 //y=1.305 //x2=49.58 //y2=0.175
cc_4342 ( N_noxref_11_c_4677_n N_GND_c_16850_n ) capacitor c=0.00662992f \
 //x=47.765 //y=1.845 //x2=49.58 //y2=0.175
cc_4343 ( N_noxref_11_c_4621_n N_GND_c_16850_n ) capacitor c=3.09244e-19 \
 //x=47.85 //y=4.055 //x2=49.58 //y2=0.175
cc_4344 ( N_noxref_11_M29_noxref_d N_GND_c_16850_n ) capacitor c=2.9462e-19 \
 //x=47.175 //y=1.095 //x2=49.58 //y2=0.175
cc_4345 ( N_noxref_11_c_4799_p N_GND_c_16854_n ) capacitor c=0.00196498f \
 //x=56.73 //y=2.375 //x2=59.2 //y2=0.175
cc_4346 ( N_noxref_11_c_4778_p N_GND_c_16777_n ) capacitor c=0.00543195f \
 //x=47.365 //y=1.305 //x2=49.665 //y2=1.145
cc_4347 ( N_noxref_11_c_4597_n N_GND_c_16691_n ) capacitor c=2.016e-19 \
 //x=37.49 //y=2.375 //x2=38.8 //y2=0.175
cc_4348 ( N_noxref_11_c_4532_n N_GND_c_16692_n ) capacitor c=2.016e-19 \
 //x=42.3 //y=2.375 //x2=43.61 //y2=0.175
cc_4349 ( N_noxref_11_c_4677_n N_GND_c_16748_n ) capacitor c=6.86343e-19 \
 //x=47.765 //y=1.845 //x2=48.42 //y2=0.175
cc_4350 ( N_noxref_11_c_4799_p N_GND_c_16828_n ) capacitor c=2.016e-19 \
 //x=56.73 //y=2.375 //x2=58.04 //y2=0.175
cc_4351 ( N_noxref_11_c_4640_n N_GND_c_16706_n ) capacitor c=0.00222376f \
 //x=37.49 //y=2.26 //x2=38.97 //y2=0.175
cc_4352 ( N_noxref_11_c_4665_n N_GND_c_16706_n ) capacitor c=0.00262688f \
 //x=38.01 //y=1.44 //x2=38.97 //y2=0.175
cc_4353 ( N_noxref_11_c_4559_n N_GND_c_16749_n ) capacitor c=0.00222376f \
 //x=42.3 //y=2.26 //x2=43.78 //y2=0.175
cc_4354 ( N_noxref_11_c_4587_n N_GND_c_16749_n ) capacitor c=0.00262688f \
 //x=42.82 //y=1.44 //x2=43.78 //y2=0.175
cc_4355 ( N_noxref_11_c_4591_n N_GND_c_16749_n ) capacitor c=2.63786e-19 \
 //x=42.3 //y=2.26 //x2=43.78 //y2=0.175
cc_4356 ( N_noxref_11_c_4817_p N_GND_c_16796_n ) capacitor c=0.0045138f \
 //x=47.365 //y=1.76 //x2=48.59 //y2=0.175
cc_4357 ( N_noxref_11_c_4677_n N_GND_c_16796_n ) capacitor c=0.0319165f \
 //x=47.765 //y=1.845 //x2=48.59 //y2=0.175
cc_4358 ( N_noxref_11_c_4801_p N_GND_c_16867_n ) capacitor c=0.00216084f \
 //x=56.73 //y=2.26 //x2=58.21 //y2=0.175
cc_4359 ( N_noxref_11_c_4939_p N_GND_c_16867_n ) capacitor c=0.00262688f \
 //x=57.25 //y=1.44 //x2=58.21 //y2=0.175
cc_4360 ( N_noxref_11_c_4802_p N_GND_c_16867_n ) capacitor c=2.63786e-19 \
 //x=56.73 //y=2.26 //x2=58.21 //y2=0.175
cc_4361 ( N_D_M134_noxref_g N_noxref_13_c_5684_n ) capacitor c=0.00813346f \
 //x=59.96 //y=6.2 //x2=60.5 //y2=5.335
cc_4362 ( N_D_M133_noxref_g N_noxref_13_c_5676_n ) capacitor c=0.00461408f \
 //x=59.52 //y=6.2 //x2=59.742 //y2=5.335
cc_4363 ( N_D_M134_noxref_g N_noxref_13_c_5676_n ) capacitor c=0.00229208f \
 //x=59.96 //y=6.2 //x2=59.742 //y2=5.335
cc_4364 ( N_D_c_5210_n N_noxref_13_c_5676_n ) capacitor c=0.00171885f \
 //x=59.885 //y=4.97 //x2=59.742 //y2=5.335
cc_4365 ( N_D_M133_noxref_g N_noxref_13_c_5688_n ) capacitor c=0.0162284f \
 //x=59.52 //y=6.2 //x2=59.74 //y2=5.56
cc_4366 ( N_D_M134_noxref_g N_noxref_13_c_5688_n ) capacitor c=0.0179041f \
 //x=59.96 //y=6.2 //x2=59.74 //y2=5.56
cc_4367 ( N_D_c_5210_n N_noxref_13_c_5688_n ) capacitor c=0.00291477f \
 //x=59.885 //y=4.97 //x2=59.74 //y2=5.56
cc_4368 ( N_D_c_5110_n CLK ) capacitor c=0.0270015f //x=8.245 //y=4.25 \
 //x2=7.52 //y2=3.14
cc_4369 ( N_D_c_5126_n CLK ) capacitor c=0.023508f //x=18.595 //y=4.25 \
 //x2=17.14 //y2=2.77
cc_4370 ( N_D_c_5173_n CLK ) capacitor c=0.0270015f //x=37.36 //y=4.28 \
 //x2=36.38 //y2=3.88
cc_4371 ( N_D_c_5198_n CLK ) capacitor c=0.023508f //x=47.455 //y=4.25 //x2=46 \
 //y2=2.77
cc_4372 ( N_D_c_5110_n N_CLK_c_6422_n ) capacitor c=0.00120292f //x=8.245 \
 //y=4.25 //x2=7.515 //y2=4.835
cc_4373 ( N_D_c_5126_n N_CLK_c_6464_n ) capacitor c=4.73489e-19 //x=18.595 \
 //y=4.25 //x2=17.145 //y2=4.835
cc_4374 ( N_D_c_5173_n N_CLK_c_6592_n ) capacitor c=4.73489e-19 //x=37.36 \
 //y=4.28 //x2=36.375 //y2=4.835
cc_4375 ( N_D_c_5198_n N_CLK_c_6595_n ) capacitor c=4.73489e-19 //x=47.455 \
 //y=4.25 //x2=46.005 //y2=4.835
cc_4376 ( N_D_c_5110_n N_CLK_c_6426_n ) capacitor c=0.0603257f //x=8.245 \
 //y=4.25 //x2=16.985 //y2=4.62
cc_4377 ( N_D_c_5117_n N_CLK_c_6426_n ) capacitor c=0.446419f //x=8.845 \
 //y=4.28 //x2=16.985 //y2=4.62
cc_4378 ( N_D_c_5125_n N_CLK_c_6426_n ) capacitor c=0.0137177f //x=13.655 \
 //y=4.31 //x2=16.985 //y2=4.62
cc_4379 ( N_D_c_5126_n N_CLK_c_6426_n ) capacitor c=0.435706f //x=18.595 \
 //y=4.25 //x2=16.985 //y2=4.62
cc_4380 ( N_D_c_5126_n N_CLK_c_6473_n ) capacitor c=0.061393f //x=18.595 \
 //y=4.25 //x2=28.395 //y2=4.61
cc_4381 ( N_D_c_5141_n N_CLK_c_6473_n ) capacitor c=0.751784f //x=19.195 \
 //y=4.28 //x2=28.395 //y2=4.61
cc_4382 ( N_D_c_5143_n N_CLK_c_6473_n ) capacitor c=0.059199f //x=27.485 \
 //y=4.25 //x2=28.395 //y2=4.61
cc_4383 ( N_D_c_5173_n N_CLK_c_6473_n ) capacitor c=0.0694748f //x=37.36 \
 //y=4.28 //x2=28.395 //y2=4.61
cc_4384 ( N_D_c_5190_n N_CLK_c_6616_n ) capacitor c=0.439136f //x=37.705 \
 //y=4.28 //x2=45.845 //y2=4.62
cc_4385 ( N_D_c_5173_n N_CLK_c_6616_n ) capacitor c=0.0574758f //x=37.36 \
 //y=4.28 //x2=45.845 //y2=4.62
cc_4386 ( N_D_c_5198_n N_CLK_c_6616_n ) capacitor c=0.419304f //x=47.455 \
 //y=4.25 //x2=45.845 //y2=4.62
cc_4387 ( N_D_c_5179_n N_CLK_c_6619_n ) capacitor c=0.00775718f //x=30.46 \
 //y=4.395 //x2=36.535 //y2=4.62
cc_4388 ( N_D_c_5147_n N_CLK_c_6619_n ) capacitor c=0.0254457f //x=30.46 \
 //y=4.755 //x2=36.535 //y2=4.62
cc_4389 ( N_D_c_5173_n N_CLK_c_6619_n ) capacitor c=0.733542f //x=37.36 \
 //y=4.28 //x2=36.535 //y2=4.62
cc_4390 ( N_D_c_5298_p N_CLK_c_6840_n ) capacitor c=0.00322854f //x=59.32 \
 //y=4.41 //x2=59.535 //y2=4.635
cc_4391 ( N_D_c_5184_n N_CLK_c_6840_n ) capacitor c=0.0260286f //x=59.32 \
 //y=4.755 //x2=59.535 //y2=4.635
cc_4392 ( N_D_c_5211_n N_CLK_c_6840_n ) capacitor c=2.89511e-19 //x=59.595 \
 //y=4.97 //x2=59.535 //y2=4.635
cc_4393 ( N_D_c_5298_p N_CLK_c_6623_n ) capacitor c=0.00475403f //x=59.32 \
 //y=4.41 //x2=59.19 //y2=4.635
cc_4394 ( N_D_c_5184_n N_CLK_c_6623_n ) capacitor c=4.68301e-19 //x=59.32 \
 //y=4.755 //x2=59.19 //y2=4.635
cc_4395 ( N_D_c_5198_n N_CLK_c_6623_n ) capacitor c=0.0588709f //x=47.455 \
 //y=4.25 //x2=59.19 //y2=4.635
cc_4396 ( N_D_c_5202_n N_CLK_c_6623_n ) capacitor c=0.723646f //x=48.055 \
 //y=4.28 //x2=59.19 //y2=4.635
cc_4397 ( N_D_c_5203_n N_CLK_c_6623_n ) capacitor c=0.0564068f //x=56.345 \
 //y=4.25 //x2=59.19 //y2=4.635
cc_4398 ( N_D_c_5204_n N_CLK_c_6623_n ) capacitor c=0.223974f //x=56.945 \
 //y=4.27 //x2=59.19 //y2=4.635
cc_4399 ( N_D_c_5184_n N_CLK_c_6630_n ) capacitor c=3.78085e-19 //x=59.32 \
 //y=4.755 //x2=65.395 //y2=4.62
cc_4400 ( N_D_c_5110_n N_CLK_c_6427_n ) capacitor c=0.0866679f //x=8.245 \
 //y=4.25 //x2=7.515 //y2=4.62
cc_4401 ( D N_noxref_16_c_7385_n ) capacitor c=0.00166215f //x=59.32 //y=2.77 \
 //x2=61.54 //y2=3.355
cc_4402 ( D N_noxref_16_c_7371_n ) capacitor c=3.00207e-19 //x=59.32 //y=2.77 \
 //x2=61.54 //y2=4.75
cc_4403 ( N_D_c_5184_n N_noxref_16_c_7371_n ) capacitor c=3.01339e-19 \
 //x=59.32 //y=4.755 //x2=61.54 //y2=4.75
cc_4404 ( D RN ) capacitor c=0.0491322f //x=1.6 //y=2.4 //x2=2.71 //y2=2.77
cc_4405 ( D RN ) capacitor c=0.0101833f //x=1.6 //y=4.62 //x2=2.71 //y2=2.77
cc_4406 ( D RN ) capacitor c=4.22577e-19 //x=1.6 //y=4.25 //x2=2.71 //y2=2.77
cc_4407 ( N_D_c_5315_p RN ) capacitor c=0.00695065f //x=1.6 //y=4.42 //x2=2.71 \
 //y2=2.77
cc_4408 ( N_D_c_5316_p RN ) capacitor c=4.22428e-19 //x=1.6 //y=4.755 \
 //x2=2.71 //y2=2.77
cc_4409 ( N_D_c_5110_n RN ) capacitor c=0.0327539f //x=8.245 //y=4.25 \
 //x2=2.71 //y2=2.77
cc_4410 ( N_D_c_5318_p RN ) capacitor c=0.00242466f //x=1.76 //y=4.26 \
 //x2=2.71 //y2=2.77
cc_4411 ( N_D_c_5319_p RN ) capacitor c=3.36194e-19 //x=1.6 //y=4.88 //x2=2.71 \
 //y2=2.77
cc_4412 ( N_D_c_5126_n RN ) capacitor c=0.0229256f //x=18.595 //y=4.25 \
 //x2=18.25 //y2=2.77
cc_4413 ( N_D_c_5143_n RN ) capacitor c=0.023508f //x=27.485 //y=4.25 \
 //x2=21.95 //y2=2.77
cc_4414 ( D RN ) capacitor c=0.0431027f //x=30.46 //y=2.77 //x2=31.57 //y2=2.77
cc_4415 ( D RN ) capacitor c=4.11345e-19 //x=30.46 //y=4.25 //x2=31.57 //y2=2.77
cc_4416 ( N_D_c_5179_n RN ) capacitor c=0.00784585f //x=30.46 //y=4.395 \
 //x2=31.57 //y2=2.77
cc_4417 ( N_D_c_5147_n RN ) capacitor c=0.00773639f //x=30.46 //y=4.755 \
 //x2=31.57 //y2=2.77
cc_4418 ( N_D_c_5173_n RN ) capacitor c=0.0296858f //x=37.36 //y=4.28 \
 //x2=31.57 //y2=2.77
cc_4419 ( N_D_c_5327_p RN ) capacitor c=3.36194e-19 //x=30.46 //y=4.88 \
 //x2=31.57 //y2=2.77
cc_4420 ( N_D_c_5198_n RN ) capacitor c=0.0229256f //x=47.455 //y=4.25 \
 //x2=47.11 //y2=2.77
cc_4421 ( N_D_c_5203_n RN ) capacitor c=0.023508f //x=56.345 //y=4.25 \
 //x2=50.81 //y2=2.77
cc_4422 ( D RN ) capacitor c=0.0398574f //x=59.32 //y=2.77 //x2=60.43 //y2=2.77
cc_4423 ( D RN ) capacitor c=3.13394e-19 //x=59.32 //y=4.25 //x2=60.43 //y2=2.77
cc_4424 ( N_D_c_5298_p RN ) capacitor c=0.00775314f //x=59.32 //y=4.41 \
 //x2=60.43 //y2=2.77
cc_4425 ( N_D_c_5184_n RN ) capacitor c=0.00730065f //x=59.32 //y=4.755 \
 //x2=60.43 //y2=2.77
cc_4426 ( N_D_c_5204_n RN ) capacitor c=0.00508161f //x=56.945 //y=4.27 \
 //x2=60.43 //y2=2.77
cc_4427 ( N_D_c_5335_p RN ) capacitor c=3.36194e-19 //x=59.32 //y=4.88 \
 //x2=60.43 //y2=2.77
cc_4428 ( D N_RN_c_7850_n ) capacitor c=0.004205f //x=1.6 //y=2.4 //x2=2.71 \
 //y2=2.56
cc_4429 ( N_D_c_5337_p N_RN_c_7850_n ) capacitor c=0.00852402f //x=1.6 \
 //y=2.375 //x2=2.71 //y2=2.56
cc_4430 ( N_D_c_5110_n N_RN_c_7850_n ) capacitor c=0.00105989f //x=8.245 \
 //y=4.25 //x2=2.71 //y2=2.56
cc_4431 ( N_D_c_5339_p N_RN_c_7850_n ) capacitor c=0.00116411f //x=1.6 \
 //y=2.26 //x2=2.71 //y2=2.56
cc_4432 ( N_D_c_5340_p N_RN_c_7850_n ) capacitor c=0.00157447f //x=1.3 \
 //y=2.095 //x2=2.71 //y2=2.56
cc_4433 ( N_D_c_5316_p N_RN_c_7852_n ) capacitor c=0.0110307f //x=1.6 \
 //y=4.755 //x2=2.71 //y2=4.765
cc_4434 ( N_D_c_5110_n N_RN_c_7852_n ) capacitor c=0.0032507f //x=8.245 \
 //y=4.25 //x2=2.71 //y2=4.765
cc_4435 ( N_D_c_5319_p N_RN_c_7852_n ) capacitor c=2.89813e-19 //x=1.6 \
 //y=4.88 //x2=2.71 //y2=4.765
cc_4436 ( N_D_c_5123_n N_RN_c_7852_n ) capacitor c=7.66769e-19 //x=2.165 \
 //y=4.97 //x2=2.71 //y2=4.765
cc_4437 ( N_D_c_5345_p N_RN_c_7852_n ) capacitor c=7.54501e-19 //x=1.875 \
 //y=4.97 //x2=2.71 //y2=4.765
cc_4438 ( D N_RN_c_8182_n ) capacitor c=0.00361756f //x=30.46 //y=2.77 \
 //x2=31.57 //y2=2.56
cc_4439 ( N_D_c_5178_n N_RN_c_8182_n ) capacitor c=0.00805781f //x=30.46 \
 //y=2.375 //x2=31.57 //y2=2.56
cc_4440 ( N_D_c_5348_p N_RN_c_8182_n ) capacitor c=0.00116411f //x=30.46 \
 //y=2.26 //x2=31.57 //y2=2.56
cc_4441 ( N_D_c_5349_p N_RN_c_8182_n ) capacitor c=0.00157447f //x=30.16 \
 //y=2.095 //x2=31.57 //y2=2.56
cc_4442 ( N_D_c_5147_n N_RN_c_8124_n ) capacitor c=0.00776434f //x=30.46 \
 //y=4.755 //x2=31.57 //y2=4.765
cc_4443 ( N_D_c_5327_p N_RN_c_8124_n ) capacitor c=2.84663e-19 //x=30.46 \
 //y=4.88 //x2=31.57 //y2=4.765
cc_4444 ( N_D_c_5209_n N_RN_c_8124_n ) capacitor c=6.98043e-19 //x=31.025 \
 //y=4.97 //x2=31.57 //y2=4.765
cc_4445 ( N_D_c_5353_p N_RN_c_8124_n ) capacitor c=7.54501e-19 //x=30.735 \
 //y=4.97 //x2=31.57 //y2=4.765
cc_4446 ( D N_RN_c_8476_n ) capacitor c=0.00361756f //x=59.32 //y=2.77 \
 //x2=60.43 //y2=2.56
cc_4447 ( N_D_c_5355_p N_RN_c_8476_n ) capacitor c=0.00805781f //x=59.32 \
 //y=2.375 //x2=60.43 //y2=2.56
cc_4448 ( N_D_c_5356_p N_RN_c_8476_n ) capacitor c=0.00116411f //x=59.32 \
 //y=2.26 //x2=60.43 //y2=2.56
cc_4449 ( N_D_c_5357_p N_RN_c_8476_n ) capacitor c=0.00157447f //x=59.02 \
 //y=2.095 //x2=60.43 //y2=2.56
cc_4450 ( N_D_c_5184_n N_RN_c_8127_n ) capacitor c=0.00776434f //x=59.32 \
 //y=4.755 //x2=60.43 //y2=4.765
cc_4451 ( N_D_c_5335_p N_RN_c_8127_n ) capacitor c=2.84663e-19 //x=59.32 \
 //y=4.88 //x2=60.43 //y2=4.765
cc_4452 ( N_D_c_5210_n N_RN_c_8127_n ) capacitor c=6.98043e-19 //x=59.885 \
 //y=4.97 //x2=60.43 //y2=4.765
cc_4453 ( N_D_c_5211_n N_RN_c_8127_n ) capacitor c=7.54501e-19 //x=59.595 \
 //y=4.97 //x2=60.43 //y2=4.765
cc_4454 ( N_D_c_5110_n N_RN_c_7855_n ) capacitor c=0.0194152f //x=8.245 \
 //y=4.25 //x2=13.795 //y2=2.4
cc_4455 ( D N_RN_c_7944_n ) capacitor c=0.00324704f //x=1.6 //y=2.4 //x2=2.87 \
 //y2=2.4
cc_4456 ( N_D_c_5337_p N_RN_c_7944_n ) capacitor c=0.00308547f //x=1.6 \
 //y=2.375 //x2=2.87 //y2=2.4
cc_4457 ( N_D_c_5110_n N_RN_c_7944_n ) capacitor c=0.00380226f //x=8.245 \
 //y=4.25 //x2=2.87 //y2=2.4
cc_4458 ( D N_RN_c_8024_n ) capacitor c=0.0180999f //x=30.46 //y=2.77 \
 //x2=42.825 //y2=2.385
cc_4459 ( N_D_c_5178_n N_RN_c_8024_n ) capacitor c=0.0188054f //x=30.46 \
 //y=2.375 //x2=42.825 //y2=2.385
cc_4460 ( N_D_c_5173_n N_RN_c_8024_n ) capacitor c=0.00664099f //x=37.36 \
 //y=4.28 //x2=42.825 //y2=2.385
cc_4461 ( N_D_c_5348_p N_RN_c_8024_n ) capacitor c=2.54369e-19 //x=30.46 \
 //y=2.26 //x2=42.825 //y2=2.385
cc_4462 ( N_D_c_5349_p N_RN_c_8024_n ) capacitor c=3.41298e-19 //x=30.16 \
 //y=2.095 //x2=42.825 //y2=2.385
cc_4463 ( D N_RN_c_8353_n ) capacitor c=0.0180999f //x=59.32 //y=2.77 \
 //x2=71.685 //y2=2.385
cc_4464 ( N_D_c_5355_p N_RN_c_8353_n ) capacitor c=0.0188133f //x=59.32 \
 //y=2.375 //x2=71.685 //y2=2.385
cc_4465 ( N_D_c_5356_p N_RN_c_8353_n ) capacitor c=2.54369e-19 //x=59.32 \
 //y=2.26 //x2=71.685 //y2=2.385
cc_4466 ( N_D_c_5357_p N_RN_c_8353_n ) capacitor c=3.41298e-19 //x=59.02 \
 //y=2.095 //x2=71.685 //y2=2.385
cc_4467 ( D N_RN_c_7955_n ) capacitor c=4.09877e-19 //x=1.6 //y=2.4 //x2=2.71 \
 //y2=2.26
cc_4468 ( N_D_c_5337_p N_RN_c_7955_n ) capacitor c=0.00371135f //x=1.6 \
 //y=2.375 //x2=2.71 //y2=2.26
cc_4469 ( N_D_c_5339_p N_RN_c_7955_n ) capacitor c=0.00124907f //x=1.6 \
 //y=2.26 //x2=2.71 //y2=2.26
cc_4470 ( N_D_c_5340_p N_RN_c_7955_n ) capacitor c=0.00214501f //x=1.3 \
 //y=2.095 //x2=2.71 //y2=2.26
cc_4471 ( D N_RN_c_7874_n ) capacitor c=3.30718e-19 //x=1.6 //y=4.62 //x2=2.71 \
 //y2=4.88
cc_4472 ( N_D_c_5316_p N_RN_c_7874_n ) capacitor c=0.0037876f //x=1.6 \
 //y=4.755 //x2=2.71 //y2=4.88
cc_4473 ( N_D_c_5319_p N_RN_c_7874_n ) capacitor c=0.00113984f //x=1.6 \
 //y=4.88 //x2=2.71 //y2=4.88
cc_4474 ( N_D_c_5123_n N_RN_c_7874_n ) capacitor c=0.00116563f //x=2.165 \
 //y=4.97 //x2=2.71 //y2=4.88
cc_4475 ( N_D_c_5345_p N_RN_c_7874_n ) capacitor c=0.00129812f //x=1.875 \
 //y=4.97 //x2=2.71 //y2=4.88
cc_4476 ( N_D_c_5178_n N_RN_c_8283_n ) capacitor c=5.39999e-19 //x=30.46 \
 //y=2.375 //x2=31.57 //y2=2.26
cc_4477 ( N_D_c_5348_p N_RN_c_8283_n ) capacitor c=0.00124907f //x=30.46 \
 //y=2.26 //x2=31.57 //y2=2.26
cc_4478 ( N_D_c_5349_p N_RN_c_8283_n ) capacitor c=0.00214501f //x=30.16 \
 //y=2.095 //x2=31.57 //y2=2.26
cc_4479 ( N_D_c_5147_n N_RN_c_8150_n ) capacitor c=8.93844e-19 //x=30.46 \
 //y=4.755 //x2=31.57 //y2=4.88
cc_4480 ( N_D_c_5327_p N_RN_c_8150_n ) capacitor c=0.00113984f //x=30.46 \
 //y=4.88 //x2=31.57 //y2=4.88
cc_4481 ( N_D_c_5209_n N_RN_c_8150_n ) capacitor c=0.00116563f //x=31.025 \
 //y=4.97 //x2=31.57 //y2=4.88
cc_4482 ( N_D_c_5353_p N_RN_c_8150_n ) capacitor c=0.00129812f //x=30.735 \
 //y=4.97 //x2=31.57 //y2=4.88
cc_4483 ( N_D_c_5355_p N_RN_c_8513_n ) capacitor c=5.39999e-19 //x=59.32 \
 //y=2.375 //x2=60.43 //y2=2.26
cc_4484 ( N_D_c_5356_p N_RN_c_8513_n ) capacitor c=0.00124907f //x=59.32 \
 //y=2.26 //x2=60.43 //y2=2.26
cc_4485 ( N_D_c_5357_p N_RN_c_8513_n ) capacitor c=0.00214501f //x=59.02 \
 //y=2.095 //x2=60.43 //y2=2.26
cc_4486 ( N_D_c_5184_n N_RN_c_8152_n ) capacitor c=8.91269e-19 //x=59.32 \
 //y=4.755 //x2=60.43 //y2=4.88
cc_4487 ( N_D_c_5335_p N_RN_c_8152_n ) capacitor c=0.00113984f //x=59.32 \
 //y=4.88 //x2=60.43 //y2=4.88
cc_4488 ( N_D_c_5210_n N_RN_c_8152_n ) capacitor c=0.00116563f //x=59.885 \
 //y=4.97 //x2=60.43 //y2=4.88
cc_4489 ( N_D_c_5211_n N_RN_c_8152_n ) capacitor c=0.00129812f //x=59.595 \
 //y=4.97 //x2=60.43 //y2=4.88
cc_4490 ( N_D_M61_noxref_g N_RN_M63_noxref_g ) capacitor c=0.0106276f //x=1.8 \
 //y=6.2 //x2=2.68 //y2=6.2
cc_4491 ( N_D_M62_noxref_g N_RN_M63_noxref_g ) capacitor c=0.107144f //x=2.24 \
 //y=6.2 //x2=2.68 //y2=6.2
cc_4492 ( N_D_M62_noxref_g N_RN_M64_noxref_g ) capacitor c=0.0101598f //x=2.24 \
 //y=6.2 //x2=3.12 //y2=6.2
cc_4493 ( N_D_M97_noxref_g N_RN_M99_noxref_g ) capacitor c=0.0106276f \
 //x=30.66 //y=6.2 //x2=31.54 //y2=6.2
cc_4494 ( N_D_M98_noxref_g N_RN_M99_noxref_g ) capacitor c=0.107144f //x=31.1 \
 //y=6.2 //x2=31.54 //y2=6.2
cc_4495 ( N_D_M98_noxref_g N_RN_M100_noxref_g ) capacitor c=0.0101598f \
 //x=31.1 //y=6.2 //x2=31.98 //y2=6.2
cc_4496 ( N_D_M133_noxref_g N_RN_M135_noxref_g ) capacitor c=0.0106276f \
 //x=59.52 //y=6.2 //x2=60.4 //y2=6.2
cc_4497 ( N_D_M134_noxref_g N_RN_M135_noxref_g ) capacitor c=0.107144f \
 //x=59.96 //y=6.2 //x2=60.4 //y2=6.2
cc_4498 ( N_D_M134_noxref_g N_RN_M136_noxref_g ) capacitor c=0.0101598f \
 //x=59.96 //y=6.2 //x2=60.84 //y2=6.2
cc_4499 ( N_D_c_5407_p N_RN_c_8529_n ) capacitor c=5.72528e-19 //x=1.3 \
 //y=1.055 //x2=2.275 //y2=1.09
cc_4500 ( N_D_c_5408_p N_RN_c_8529_n ) capacitor c=0.00150277f //x=1.3 //y=1.4 \
 //x2=2.275 //y2=1.09
cc_4501 ( N_D_c_5409_p N_RN_c_8529_n ) capacitor c=0.0160123f //x=1.83 \
 //y=1.055 //x2=2.275 //y2=1.09
cc_4502 ( N_D_c_5410_p N_RN_c_8532_n ) capacitor c=0.00111227f //x=1.3 \
 //y=1.71 //x2=2.275 //y2=1.4
cc_4503 ( N_D_c_5411_p N_RN_c_8532_n ) capacitor c=0.0124075f //x=1.83 //y=1.4 \
 //x2=2.275 //y2=1.4
cc_4504 ( N_D_c_5409_p N_RN_c_7974_n ) capacitor c=9.19165e-19 //x=1.83 \
 //y=1.055 //x2=2.8 //y2=1.09
cc_4505 ( N_D_c_5411_p N_RN_c_7975_n ) capacitor c=0.0010154f //x=1.83 //y=1.4 \
 //x2=2.8 //y2=1.4
cc_4506 ( N_D_c_5411_p N_RN_c_7976_n ) capacitor c=9.23422e-19 //x=1.83 \
 //y=1.4 //x2=2.8 //y2=1.63
cc_4507 ( N_D_c_5337_p N_RN_c_7977_n ) capacitor c=0.00138458f //x=1.6 \
 //y=2.375 //x2=2.8 //y2=2.095
cc_4508 ( N_D_c_5339_p N_RN_c_7977_n ) capacitor c=0.00174566f //x=1.6 \
 //y=2.26 //x2=2.8 //y2=2.095
cc_4509 ( N_D_c_5340_p N_RN_c_7977_n ) capacitor c=0.0088427f //x=1.3 \
 //y=2.095 //x2=2.8 //y2=2.095
cc_4510 ( N_D_c_5418_p N_RN_c_8540_n ) capacitor c=5.72528e-19 //x=30.16 \
 //y=1.055 //x2=31.135 //y2=1.09
cc_4511 ( N_D_c_5419_p N_RN_c_8540_n ) capacitor c=0.00150277f //x=30.16 \
 //y=1.4 //x2=31.135 //y2=1.09
cc_4512 ( N_D_c_5420_p N_RN_c_8540_n ) capacitor c=0.0160123f //x=30.69 \
 //y=1.055 //x2=31.135 //y2=1.09
cc_4513 ( N_D_c_5421_p N_RN_c_8543_n ) capacitor c=0.00111227f //x=30.16 \
 //y=1.71 //x2=31.135 //y2=1.4
cc_4514 ( N_D_c_5422_p N_RN_c_8543_n ) capacitor c=0.0124075f //x=30.69 \
 //y=1.4 //x2=31.135 //y2=1.4
cc_4515 ( N_D_c_5420_p N_RN_c_8302_n ) capacitor c=9.19165e-19 //x=30.69 \
 //y=1.055 //x2=31.66 //y2=1.09
cc_4516 ( N_D_c_5422_p N_RN_c_8303_n ) capacitor c=0.0010154f //x=30.69 \
 //y=1.4 //x2=31.66 //y2=1.4
cc_4517 ( N_D_c_5422_p N_RN_c_8304_n ) capacitor c=9.23422e-19 //x=30.69 \
 //y=1.4 //x2=31.66 //y2=1.63
cc_4518 ( N_D_c_5178_n N_RN_c_8305_n ) capacitor c=6.20716e-19 //x=30.46 \
 //y=2.375 //x2=31.66 //y2=2.095
cc_4519 ( N_D_c_5348_p N_RN_c_8305_n ) capacitor c=0.00174566f //x=30.46 \
 //y=2.26 //x2=31.66 //y2=2.095
cc_4520 ( N_D_c_5349_p N_RN_c_8305_n ) capacitor c=0.0088427f //x=30.16 \
 //y=2.095 //x2=31.66 //y2=2.095
cc_4521 ( N_D_c_5429_p N_RN_c_8551_n ) capacitor c=5.72528e-19 //x=59.02 \
 //y=1.055 //x2=59.995 //y2=1.09
cc_4522 ( N_D_c_5430_p N_RN_c_8551_n ) capacitor c=0.00150277f //x=59.02 \
 //y=1.4 //x2=59.995 //y2=1.09
cc_4523 ( N_D_c_5431_p N_RN_c_8551_n ) capacitor c=0.0160123f //x=59.55 \
 //y=1.055 //x2=59.995 //y2=1.09
cc_4524 ( N_D_c_5432_p N_RN_c_8554_n ) capacitor c=0.00111227f //x=59.02 \
 //y=1.71 //x2=59.995 //y2=1.4
cc_4525 ( N_D_c_5433_p N_RN_c_8554_n ) capacitor c=0.0124075f //x=59.55 \
 //y=1.4 //x2=59.995 //y2=1.4
cc_4526 ( N_D_c_5431_p N_RN_c_8556_n ) capacitor c=9.19165e-19 //x=59.55 \
 //y=1.055 //x2=60.52 //y2=1.09
cc_4527 ( N_D_c_5433_p N_RN_c_8557_n ) capacitor c=0.0010154f //x=59.55 \
 //y=1.4 //x2=60.52 //y2=1.4
cc_4528 ( N_D_c_5433_p N_RN_c_8558_n ) capacitor c=9.23422e-19 //x=59.55 \
 //y=1.4 //x2=60.52 //y2=1.63
cc_4529 ( N_D_c_5355_p N_RN_c_8559_n ) capacitor c=6.20716e-19 //x=59.32 \
 //y=2.375 //x2=60.52 //y2=2.095
cc_4530 ( N_D_c_5356_p N_RN_c_8559_n ) capacitor c=0.00174566f //x=59.32 \
 //y=2.26 //x2=60.52 //y2=2.095
cc_4531 ( N_D_c_5357_p N_RN_c_8559_n ) capacitor c=0.0088427f //x=59.02 \
 //y=2.095 //x2=60.52 //y2=2.095
cc_4532 ( N_D_c_5316_p N_RN_c_7884_n ) capacitor c=0.00116212f //x=1.6 \
 //y=4.755 //x2=2.71 //y2=4.88
cc_4533 ( N_D_c_5319_p N_RN_c_7884_n ) capacitor c=0.00155973f //x=1.6 \
 //y=4.88 //x2=2.71 //y2=4.88
cc_4534 ( N_D_c_5123_n N_RN_c_7884_n ) capacitor c=0.0171374f //x=2.165 \
 //y=4.97 //x2=2.71 //y2=4.88
cc_4535 ( N_D_c_5345_p N_RN_c_7884_n ) capacitor c=0.00484466f //x=1.875 \
 //y=4.97 //x2=2.71 //y2=4.88
cc_4536 ( N_D_c_5147_n N_RN_c_8216_n ) capacitor c=0.00108708f //x=30.46 \
 //y=4.755 //x2=31.57 //y2=4.88
cc_4537 ( N_D_c_5327_p N_RN_c_8216_n ) capacitor c=0.00155973f //x=30.46 \
 //y=4.88 //x2=31.57 //y2=4.88
cc_4538 ( N_D_c_5209_n N_RN_c_8216_n ) capacitor c=0.0171374f //x=31.025 \
 //y=4.97 //x2=31.57 //y2=4.88
cc_4539 ( N_D_c_5353_p N_RN_c_8216_n ) capacitor c=0.00484466f //x=30.735 \
 //y=4.97 //x2=31.57 //y2=4.88
cc_4540 ( N_D_c_5184_n N_RN_c_8570_n ) capacitor c=0.00108708f //x=59.32 \
 //y=4.755 //x2=60.43 //y2=4.88
cc_4541 ( N_D_c_5335_p N_RN_c_8570_n ) capacitor c=0.00155973f //x=59.32 \
 //y=4.88 //x2=60.43 //y2=4.88
cc_4542 ( N_D_c_5210_n N_RN_c_8570_n ) capacitor c=0.0171374f //x=59.885 \
 //y=4.97 //x2=60.43 //y2=4.88
cc_4543 ( N_D_c_5211_n N_RN_c_8570_n ) capacitor c=0.00484466f //x=59.595 \
 //y=4.97 //x2=60.43 //y2=4.88
cc_4544 ( N_D_c_5117_n N_SN_c_9845_n ) capacitor c=0.0253008f //x=8.845 \
 //y=4.28 //x2=12.33 //y2=4.765
cc_4545 ( N_D_c_5143_n N_SN_c_9935_n ) capacitor c=0.0240579f //x=27.485 \
 //y=4.25 //x2=26.76 //y2=4.765
cc_4546 ( N_D_c_5190_n N_SN_c_10068_n ) capacitor c=0.0246596f //x=37.705 \
 //y=4.28 //x2=41.19 //y2=4.765
cc_4547 ( N_D_c_5203_n N_SN_c_10069_n ) capacitor c=0.0240579f //x=56.345 \
 //y=4.25 //x2=55.62 //y2=4.765
cc_4548 ( N_D_c_5143_n N_SN_c_9918_n ) capacitor c=8.7606e-19 //x=27.485 \
 //y=4.25 //x2=21.05 //y2=3.125
cc_4549 ( N_D_c_5173_n N_SN_c_10119_n ) capacitor c=0.00382017f //x=37.36 \
 //y=4.28 //x2=32.905 //y2=3.13
cc_4550 ( D N_SN_c_9921_n ) capacitor c=0.0313253f //x=30.46 //y=2.77 \
 //x2=32.475 //y2=3.13
cc_4551 ( N_D_c_5179_n N_SN_c_9921_n ) capacitor c=0.00322192f //x=30.46 \
 //y=4.395 //x2=32.475 //y2=3.13
cc_4552 ( N_D_c_5143_n N_SN_c_9921_n ) capacitor c=0.0113229f //x=27.485 \
 //y=4.25 //x2=32.475 //y2=3.13
cc_4553 ( N_D_c_5171_n N_SN_c_9921_n ) capacitor c=0.00107273f //x=28.085 \
 //y=4.27 //x2=32.475 //y2=3.13
cc_4554 ( N_D_c_5173_n N_SN_c_9921_n ) capacitor c=0.116349f //x=37.36 \
 //y=4.28 //x2=32.475 //y2=3.13
cc_4555 ( N_D_c_5173_n N_SN_c_10122_n ) capacitor c=0.00619588f //x=37.36 \
 //y=4.28 //x2=33.64 //y2=3.17
cc_4556 ( N_D_c_5173_n N_SN_c_10126_n ) capacitor c=0.00250708f //x=37.36 \
 //y=4.28 //x2=34.89 //y2=3.14
cc_4557 ( N_D_c_5173_n N_SN_c_10131_n ) capacitor c=0.0105841f //x=37.36 \
 //y=4.28 //x2=35.49 //y2=3.17
cc_4558 ( N_D_c_5173_n N_SN_c_10134_n ) capacitor c=0.00107729f //x=37.36 \
 //y=4.28 //x2=37.845 //y2=3.14
cc_4559 ( N_D_c_5203_n N_SN_c_10228_n ) capacitor c=0.0122034f //x=56.345 \
 //y=4.25 //x2=49.91 //y2=3.125
cc_4560 ( D N_SN_c_10255_n ) capacitor c=0.0299591f //x=59.32 //y=2.77 \
 //x2=61.335 //y2=3.13
cc_4561 ( N_D_c_5204_n N_SN_c_10255_n ) capacitor c=0.0119598f //x=56.945 \
 //y=4.27 //x2=61.335 //y2=3.13
cc_4562 ( N_D_c_5203_n N_noxref_22_c_12247_n ) capacitor c=0.0220533f \
 //x=56.345 //y=4.25 //x2=51.92 //y2=4.75
cc_4563 ( D N_noxref_22_c_12426_n ) capacitor c=0.0132783f //x=59.32 //y=2.77 \
 //x2=57.47 //y2=3.365
cc_4564 ( N_D_c_5355_p N_noxref_22_c_12426_n ) capacitor c=0.00357748f \
 //x=59.32 //y=2.375 //x2=57.47 //y2=3.365
cc_4565 ( D N_noxref_22_c_12431_n ) capacitor c=0.00358485f //x=59.32 //y=2.77 \
 //x2=57.47 //y2=3.685
cc_4566 ( N_D_c_5204_n N_noxref_22_c_12431_n ) capacitor c=0.00238995f \
 //x=56.945 //y=4.27 //x2=57.47 //y2=3.685
cc_4567 ( D N_noxref_22_c_12248_n ) capacitor c=0.00398412f //x=59.32 //y=2.77 \
 //x2=57.47 //y2=5.25
cc_4568 ( N_D_c_5298_p N_noxref_22_c_12248_n ) capacitor c=0.00250358f \
 //x=59.32 //y=4.41 //x2=57.47 //y2=5.25
cc_4569 ( N_D_c_5184_n N_noxref_22_c_12248_n ) capacitor c=0.00597419f \
 //x=59.32 //y=4.755 //x2=57.47 //y2=5.25
cc_4570 ( N_D_c_5204_n N_noxref_22_c_12248_n ) capacitor c=0.0250469f \
 //x=56.945 //y=4.27 //x2=57.47 //y2=5.25
cc_4571 ( N_D_c_5203_n N_noxref_22_c_12361_n ) capacitor c=0.0282228f \
 //x=56.345 //y=4.25 //x2=55.235 //y2=3.51
cc_4572 ( N_D_c_5203_n N_noxref_22_c_12445_n ) capacitor c=0.00419069f \
 //x=56.345 //y=4.25 //x2=55.835 //y2=3.53
cc_4573 ( N_D_c_5203_n N_noxref_22_c_12447_n ) capacitor c=0.00425573f \
 //x=56.345 //y=4.25 //x2=56.345 //y2=3.51
cc_4574 ( N_D_c_5204_n N_noxref_22_c_12450_n ) capacitor c=0.00425573f \
 //x=56.945 //y=4.27 //x2=56.945 //y2=3.5
cc_4575 ( D N_noxref_22_c_12480_n ) capacitor c=5.0585e-19 //x=59.32 //y=2.77 \
 //x2=58.935 //y2=3.88
cc_4576 ( N_D_c_5298_p N_noxref_22_c_12480_n ) capacitor c=0.00335556f \
 //x=59.32 //y=4.41 //x2=58.935 //y2=3.88
cc_4577 ( N_D_c_5204_n N_noxref_22_c_12480_n ) capacitor c=0.010872f \
 //x=56.945 //y=4.27 //x2=58.935 //y2=3.88
cc_4578 ( D N_noxref_22_c_12453_n ) capacitor c=0.00440454f //x=59.32 //y=2.77 \
 //x2=57.63 //y2=3.88
cc_4579 ( N_D_c_5204_n N_noxref_22_c_12453_n ) capacitor c=0.165086f \
 //x=56.945 //y=4.27 //x2=57.63 //y2=3.88
cc_4580 ( D N_noxref_22_c_12271_n ) capacitor c=0.0266017f //x=59.32 //y=2.77 \
 //x2=59.535 //y2=3.865
cc_4581 ( N_D_c_5298_p N_noxref_22_c_12271_n ) capacitor c=0.00520031f \
 //x=59.32 //y=4.41 //x2=59.535 //y2=3.865
cc_4582 ( N_D_c_5204_n N_noxref_22_c_12271_n ) capacitor c=0.0358686f \
 //x=56.945 //y=4.27 //x2=59.535 //y2=3.865
cc_4583 ( N_D_c_5315_p N_VDD_c_13434_n ) capacitor c=9.84378e-19 //x=1.6 \
 //y=4.42 //x2=87.775 //y2=7.585
cc_4584 ( N_D_c_5179_n N_VDD_c_13434_n ) capacitor c=2.35277e-19 //x=30.46 \
 //y=4.395 //x2=87.775 //y2=7.585
cc_4585 ( N_D_c_5298_p N_VDD_c_13434_n ) capacitor c=2.78154e-19 //x=59.32 \
 //y=4.41 //x2=87.775 //y2=7.585
cc_4586 ( N_D_c_5315_p N_VDD_c_14116_n ) capacitor c=3.78126e-19 //x=1.6 \
 //y=4.42 //x2=1.495 //y2=7.585
cc_4587 ( D N_VDD_c_13443_n ) capacitor c=0.00793737f //x=1.6 //y=4.62 \
 //x2=1.23 //y2=7.58
cc_4588 ( D N_VDD_c_13443_n ) capacitor c=0.00228842f //x=1.6 //y=4.25 \
 //x2=1.23 //y2=7.58
cc_4589 ( N_D_c_5315_p N_VDD_c_13443_n ) capacitor c=0.00233963f //x=1.6 \
 //y=4.42 //x2=1.23 //y2=7.58
cc_4590 ( N_D_c_5316_p N_VDD_c_13443_n ) capacitor c=0.00805425f //x=1.6 \
 //y=4.755 //x2=1.23 //y2=7.58
cc_4591 ( N_D_c_5319_p N_VDD_c_13443_n ) capacitor c=0.00371026f //x=1.6 \
 //y=4.88 //x2=1.23 //y2=7.58
cc_4592 ( N_D_c_5345_p N_VDD_c_13443_n ) capacitor c=0.00594885f //x=1.875 \
 //y=4.97 //x2=1.23 //y2=7.58
cc_4593 ( N_D_M61_noxref_g N_VDD_c_13445_n ) capacitor c=0.00755614f //x=1.8 \
 //y=6.2 //x2=2.375 //y2=7.585
cc_4594 ( N_D_M62_noxref_g N_VDD_c_13445_n ) capacitor c=0.00755544f //x=2.24 \
 //y=6.2 //x2=2.375 //y2=7.585
cc_4595 ( N_D_c_5179_n N_VDD_c_13844_n ) capacitor c=3.23213e-19 //x=30.46 \
 //y=4.395 //x2=31.235 //y2=7.585
cc_4596 ( N_D_M97_noxref_g N_VDD_c_13844_n ) capacitor c=0.00755614f //x=30.66 \
 //y=6.2 //x2=31.235 //y2=7.585
cc_4597 ( N_D_M98_noxref_g N_VDD_c_13844_n ) capacitor c=0.00755544f //x=31.1 \
 //y=6.2 //x2=31.235 //y2=7.585
cc_4598 ( N_D_c_5298_p N_VDD_c_14128_n ) capacitor c=2.44558e-19 //x=59.32 \
 //y=4.41 //x2=59.215 //y2=7.585
cc_4599 ( N_D_M133_noxref_g N_VDD_c_14129_n ) capacitor c=0.00755614f \
 //x=59.52 //y=6.2 //x2=60.095 //y2=7.585
cc_4600 ( N_D_M134_noxref_g N_VDD_c_14129_n ) capacitor c=0.00755544f \
 //x=59.96 //y=6.2 //x2=60.095 //y2=7.585
cc_4601 ( N_D_c_5110_n N_VDD_c_13461_n ) capacitor c=0.0197484f //x=8.245 \
 //y=4.25 //x2=5.3 //y2=7.585
cc_4602 ( N_D_c_5117_n N_VDD_c_13467_n ) capacitor c=0.00887763f //x=8.845 \
 //y=4.28 //x2=10.11 //y2=7.585
cc_4603 ( N_D_c_5126_n N_VDD_c_13521_n ) capacitor c=0.00887763f //x=18.595 \
 //y=4.25 //x2=14.92 //y2=7.585
cc_4604 ( N_D_c_5141_n N_VDD_c_13581_n ) capacitor c=9.93762e-19 //x=19.195 \
 //y=4.28 //x2=19.73 //y2=7.585
cc_4605 ( N_D_c_5143_n N_VDD_c_13581_n ) capacitor c=0.00879861f //x=27.485 \
 //y=4.25 //x2=19.73 //y2=7.585
cc_4606 ( N_D_c_5143_n N_VDD_c_13631_n ) capacitor c=0.00887763f //x=27.485 \
 //y=4.25 //x2=24.54 //y2=7.585
cc_4607 ( D N_VDD_c_13694_n ) capacitor c=0.00255369f //x=30.46 //y=4.25 \
 //x2=29.35 //y2=7.585
cc_4608 ( N_D_c_5179_n N_VDD_c_13694_n ) capacitor c=9.89313e-19 //x=30.46 \
 //y=4.395 //x2=29.35 //y2=7.585
cc_4609 ( N_D_c_5147_n N_VDD_c_13694_n ) capacitor c=0.00857817f //x=30.46 \
 //y=4.755 //x2=29.35 //y2=7.585
cc_4610 ( N_D_c_5173_n N_VDD_c_13694_n ) capacitor c=0.00854866f //x=37.36 \
 //y=4.28 //x2=29.35 //y2=7.585
cc_4611 ( N_D_c_5327_p N_VDD_c_13694_n ) capacitor c=0.00354568f //x=30.46 \
 //y=4.88 //x2=29.35 //y2=7.585
cc_4612 ( N_D_c_5353_p N_VDD_c_13694_n ) capacitor c=0.00572368f //x=30.735 \
 //y=4.97 //x2=29.35 //y2=7.585
cc_4613 ( N_D_c_5173_n N_VDD_c_13773_n ) capacitor c=0.00887803f //x=37.36 \
 //y=4.28 //x2=34.16 //y2=7.585
cc_4614 ( N_D_c_5190_n N_VDD_c_13775_n ) capacitor c=0.00887763f //x=37.705 \
 //y=4.28 //x2=38.97 //y2=7.585
cc_4615 ( N_D_c_5198_n N_VDD_c_13776_n ) capacitor c=0.00887763f //x=47.455 \
 //y=4.25 //x2=43.78 //y2=7.585
cc_4616 ( N_D_c_5202_n N_VDD_c_13778_n ) capacitor c=9.93762e-19 //x=48.055 \
 //y=4.28 //x2=48.59 //y2=7.585
cc_4617 ( N_D_c_5203_n N_VDD_c_13778_n ) capacitor c=0.00879861f //x=56.345 \
 //y=4.25 //x2=48.59 //y2=7.585
cc_4618 ( N_D_c_5203_n N_VDD_c_13779_n ) capacitor c=0.00887763f //x=56.345 \
 //y=4.25 //x2=53.4 //y2=7.585
cc_4619 ( D N_VDD_c_13780_n ) capacitor c=0.0025511f //x=59.32 //y=4.25 \
 //x2=58.21 //y2=7.585
cc_4620 ( N_D_c_5298_p N_VDD_c_13780_n ) capacitor c=0.00124121f //x=59.32 \
 //y=4.41 //x2=58.21 //y2=7.585
cc_4621 ( N_D_c_5184_n N_VDD_c_13780_n ) capacitor c=0.00838445f //x=59.32 \
 //y=4.755 //x2=58.21 //y2=7.585
cc_4622 ( N_D_c_5204_n N_VDD_c_13780_n ) capacitor c=0.00854767f //x=56.945 \
 //y=4.27 //x2=58.21 //y2=7.585
cc_4623 ( N_D_c_5335_p N_VDD_c_13780_n ) capacitor c=0.00354568f //x=59.32 \
 //y=4.88 //x2=58.21 //y2=7.585
cc_4624 ( N_D_c_5211_n N_VDD_c_13780_n ) capacitor c=0.00572368f //x=59.595 \
 //y=4.97 //x2=58.21 //y2=7.585
cc_4625 ( N_D_c_5315_p N_VDD_M61_noxref_s ) capacitor c=9.65642e-19 //x=1.6 \
 //y=4.42 //x2=1.445 //y2=5.2
cc_4626 ( N_D_c_5316_p N_VDD_M61_noxref_s ) capacitor c=0.0223496f //x=1.6 \
 //y=4.755 //x2=1.445 //y2=5.2
cc_4627 ( N_D_c_5318_p N_VDD_M61_noxref_s ) capacitor c=4.28833e-19 //x=1.76 \
 //y=4.26 //x2=1.445 //y2=5.2
cc_4628 ( N_D_c_5319_p N_VDD_M61_noxref_s ) capacitor c=0.00911317f //x=1.6 \
 //y=4.88 //x2=1.445 //y2=5.2
cc_4629 ( N_D_M61_noxref_g N_VDD_M61_noxref_s ) capacitor c=0.053419f //x=1.8 \
 //y=6.2 //x2=1.445 //y2=5.2
cc_4630 ( N_D_c_5345_p N_VDD_M61_noxref_s ) capacitor c=0.00597604f //x=1.875 \
 //y=4.97 //x2=1.445 //y2=5.2
cc_4631 ( N_D_M62_noxref_g N_VDD_M62_noxref_d ) capacitor c=0.015318f //x=2.24 \
 //y=6.2 //x2=2.315 //y2=5.2
cc_4632 ( N_D_c_5110_n N_VDD_M67_noxref_s ) capacitor c=6.10845e-19 //x=8.245 \
 //y=4.25 //x2=6.255 //y2=5.2
cc_4633 ( N_D_c_5179_n N_VDD_M97_noxref_s ) capacitor c=9.08476e-19 //x=30.46 \
 //y=4.395 //x2=30.305 //y2=5.2
cc_4634 ( N_D_c_5147_n N_VDD_M97_noxref_s ) capacitor c=0.0167311f //x=30.46 \
 //y=4.755 //x2=30.305 //y2=5.2
cc_4635 ( N_D_c_5327_p N_VDD_M97_noxref_s ) capacitor c=0.00983846f //x=30.46 \
 //y=4.88 //x2=30.305 //y2=5.2
cc_4636 ( N_D_M97_noxref_g N_VDD_M97_noxref_s ) capacitor c=0.053419f \
 //x=30.66 //y=6.2 //x2=30.305 //y2=5.2
cc_4637 ( N_D_c_5353_p N_VDD_M97_noxref_s ) capacitor c=0.00597878f //x=30.735 \
 //y=4.97 //x2=30.305 //y2=5.2
cc_4638 ( N_D_M98_noxref_g N_VDD_M98_noxref_d ) capacitor c=0.015318f //x=31.1 \
 //y=6.2 //x2=31.175 //y2=5.2
cc_4639 ( N_D_c_5298_p N_VDD_M133_noxref_s ) capacitor c=9.21974e-19 //x=59.32 \
 //y=4.41 //x2=59.165 //y2=5.2
cc_4640 ( N_D_c_5184_n N_VDD_M133_noxref_s ) capacitor c=0.0167311f //x=59.32 \
 //y=4.755 //x2=59.165 //y2=5.2
cc_4641 ( N_D_c_5335_p N_VDD_M133_noxref_s ) capacitor c=0.00911751f //x=59.32 \
 //y=4.88 //x2=59.165 //y2=5.2
cc_4642 ( N_D_M133_noxref_g N_VDD_M133_noxref_s ) capacitor c=0.053419f \
 //x=59.52 //y=6.2 //x2=59.165 //y2=5.2
cc_4643 ( N_D_c_5211_n N_VDD_M133_noxref_s ) capacitor c=0.00597714f \
 //x=59.595 //y=4.97 //x2=59.165 //y2=5.2
cc_4644 ( N_D_M134_noxref_g N_VDD_M134_noxref_d ) capacitor c=0.015318f \
 //x=59.96 //y=6.2 //x2=60.035 //y2=5.2
cc_4645 ( N_D_c_5315_p N_GND_c_16870_n ) capacitor c=6.35651e-19 //x=1.6 \
 //y=4.42 //x2=1.48 //y2=0.175
cc_4646 ( N_D_c_5407_p N_GND_c_16871_n ) capacitor c=3.97665e-19 //x=1.3 \
 //y=1.055 //x2=1.565 //y2=1.015
cc_4647 ( N_D_c_5555_p N_GND_c_16871_n ) capacitor c=0.00864776f //x=1.675 \
 //y=0.9 //x2=1.565 //y2=1.015
cc_4648 ( N_D_c_5409_p N_GND_c_16871_n ) capacitor c=4.45447e-19 //x=1.83 \
 //y=1.055 //x2=1.565 //y2=1.015
cc_4649 ( N_D_c_5418_p N_GND_c_16874_n ) capacitor c=3.97665e-19 //x=30.16 \
 //y=1.055 //x2=30.425 //y2=1.015
cc_4650 ( N_D_c_5558_p N_GND_c_16874_n ) capacitor c=0.00864776f //x=30.535 \
 //y=0.9 //x2=30.425 //y2=1.015
cc_4651 ( N_D_c_5420_p N_GND_c_16874_n ) capacitor c=4.45447e-19 //x=30.69 \
 //y=1.055 //x2=30.425 //y2=1.015
cc_4652 ( N_D_c_5429_p N_GND_c_16877_n ) capacitor c=3.97665e-19 //x=59.02 \
 //y=1.055 //x2=59.285 //y2=1.015
cc_4653 ( N_D_c_5561_p N_GND_c_16877_n ) capacitor c=0.00864776f //x=59.395 \
 //y=0.9 //x2=59.285 //y2=1.015
cc_4654 ( N_D_c_5431_p N_GND_c_16877_n ) capacitor c=4.45447e-19 //x=59.55 \
 //y=1.055 //x2=59.285 //y2=1.015
cc_4655 ( N_D_c_5337_p N_GND_c_16880_n ) capacitor c=0.00849742f //x=1.6 \
 //y=2.375 //x2=1.565 //y2=1.145
cc_4656 ( N_D_c_5315_p N_GND_c_16880_n ) capacitor c=6.54578e-19 //x=1.6 \
 //y=4.42 //x2=1.565 //y2=1.145
cc_4657 ( N_D_c_5339_p N_GND_c_16880_n ) capacitor c=2.22883e-19 //x=1.6 \
 //y=2.26 //x2=1.565 //y2=1.145
cc_4658 ( N_D_c_5407_p N_GND_c_16880_n ) capacitor c=0.00142616f //x=1.3 \
 //y=1.055 //x2=1.565 //y2=1.145
cc_4659 ( N_D_c_5408_p N_GND_c_16880_n ) capacitor c=0.00411286f //x=1.3 \
 //y=1.4 //x2=1.565 //y2=1.145
cc_4660 ( N_D_c_5410_p N_GND_c_16880_n ) capacitor c=4.52012e-19 //x=1.3 \
 //y=1.71 //x2=1.565 //y2=1.145
cc_4661 ( N_D_c_5555_p N_GND_c_16880_n ) capacitor c=7.3749e-19 //x=1.675 \
 //y=0.9 //x2=1.565 //y2=1.145
cc_4662 ( N_D_c_5570_p N_GND_c_16880_n ) capacitor c=6.09813e-19 //x=1.675 \
 //y=1.555 //x2=1.565 //y2=1.145
cc_4663 ( N_D_c_5409_p N_GND_c_16880_n ) capacitor c=0.0017438f //x=1.83 \
 //y=1.055 //x2=1.565 //y2=1.145
cc_4664 ( N_D_c_5411_p N_GND_c_16880_n ) capacitor c=0.00276804f //x=1.83 \
 //y=1.4 //x2=1.565 //y2=1.145
cc_4665 ( N_D_c_5178_n N_GND_c_16624_n ) capacitor c=0.00772482f //x=30.46 \
 //y=2.375 //x2=30.425 //y2=1.145
cc_4666 ( N_D_c_5179_n N_GND_c_16624_n ) capacitor c=3.86451e-19 //x=30.46 \
 //y=4.395 //x2=30.425 //y2=1.145
cc_4667 ( N_D_c_5348_p N_GND_c_16624_n ) capacitor c=2.22883e-19 //x=30.46 \
 //y=2.26 //x2=30.425 //y2=1.145
cc_4668 ( N_D_c_5418_p N_GND_c_16624_n ) capacitor c=0.00156339f //x=30.16 \
 //y=1.055 //x2=30.425 //y2=1.145
cc_4669 ( N_D_c_5419_p N_GND_c_16624_n ) capacitor c=0.00352472f //x=30.16 \
 //y=1.4 //x2=30.425 //y2=1.145
cc_4670 ( N_D_c_5421_p N_GND_c_16624_n ) capacitor c=4.77354e-19 //x=30.16 \
 //y=1.71 //x2=30.425 //y2=1.145
cc_4671 ( N_D_c_5558_p N_GND_c_16624_n ) capacitor c=9.36995e-19 //x=30.535 \
 //y=0.9 //x2=30.425 //y2=1.145
cc_4672 ( N_D_c_5580_p N_GND_c_16624_n ) capacitor c=6.09038e-19 //x=30.535 \
 //y=1.555 //x2=30.425 //y2=1.145
cc_4673 ( N_D_c_5420_p N_GND_c_16624_n ) capacitor c=0.0017438f //x=30.69 \
 //y=1.055 //x2=30.425 //y2=1.145
cc_4674 ( N_D_c_5422_p N_GND_c_16624_n ) capacitor c=0.00276804f //x=30.69 \
 //y=1.4 //x2=30.425 //y2=1.145
cc_4675 ( N_D_c_5355_p N_GND_c_16900_n ) capacitor c=0.00772482f //x=59.32 \
 //y=2.375 //x2=59.285 //y2=1.145
cc_4676 ( N_D_c_5298_p N_GND_c_16900_n ) capacitor c=5.85973e-19 //x=59.32 \
 //y=4.41 //x2=59.285 //y2=1.145
cc_4677 ( N_D_c_5356_p N_GND_c_16900_n ) capacitor c=2.22883e-19 //x=59.32 \
 //y=2.26 //x2=59.285 //y2=1.145
cc_4678 ( N_D_c_5429_p N_GND_c_16900_n ) capacitor c=0.00156339f //x=59.02 \
 //y=1.055 //x2=59.285 //y2=1.145
cc_4679 ( N_D_c_5430_p N_GND_c_16900_n ) capacitor c=0.00352472f //x=59.02 \
 //y=1.4 //x2=59.285 //y2=1.145
cc_4680 ( N_D_c_5432_p N_GND_c_16900_n ) capacitor c=4.51823e-19 //x=59.02 \
 //y=1.71 //x2=59.285 //y2=1.145
cc_4681 ( N_D_c_5561_p N_GND_c_16900_n ) capacitor c=9.36995e-19 //x=59.395 \
 //y=0.9 //x2=59.285 //y2=1.145
cc_4682 ( N_D_c_5590_p N_GND_c_16900_n ) capacitor c=6.09504e-19 //x=59.395 \
 //y=1.555 //x2=59.285 //y2=1.145
cc_4683 ( N_D_c_5431_p N_GND_c_16900_n ) capacitor c=0.0017438f //x=59.55 \
 //y=1.055 //x2=59.285 //y2=1.145
cc_4684 ( N_D_c_5433_p N_GND_c_16900_n ) capacitor c=0.00276804f //x=59.55 \
 //y=1.4 //x2=59.285 //y2=1.145
cc_4685 ( N_D_c_5407_p N_GND_c_16421_n ) capacitor c=0.00680635f //x=1.3 \
 //y=1.055 //x2=5.13 //y2=0.175
cc_4686 ( D N_GND_c_16911_n ) capacitor c=0.0125306f //x=1.6 //y=2.4 //x2=1.23 \
 //y2=0.18
cc_4687 ( N_D_c_5337_p N_GND_c_16911_n ) capacitor c=0.00779049f //x=1.6 \
 //y=2.375 //x2=1.23 //y2=0.18
cc_4688 ( N_D_c_5339_p N_GND_c_16911_n ) capacitor c=0.00394776f //x=1.6 \
 //y=2.26 //x2=1.23 //y2=0.18
cc_4689 ( N_D_c_5410_p N_GND_c_16911_n ) capacitor c=0.00295461f //x=1.3 \
 //y=1.71 //x2=1.23 //y2=0.18
cc_4690 ( N_D_c_5340_p N_GND_c_16911_n ) capacitor c=0.0112432f //x=1.3 \
 //y=2.095 //x2=1.23 //y2=0.18
cc_4691 ( N_D_c_5418_p N_GND_c_16689_n ) capacitor c=0.00677766f //x=30.16 \
 //y=1.055 //x2=33.99 //y2=0.175
cc_4692 ( N_D_c_5429_p N_GND_c_16917_n ) capacitor c=0.00677766f //x=59.02 \
 //y=1.055 //x2=62.85 //y2=0.175
cc_4693 ( D N_GND_c_16600_n ) capacitor c=0.00967211f //x=30.46 //y=2.77 \
 //x2=29.35 //y2=0.175
cc_4694 ( N_D_c_5178_n N_GND_c_16600_n ) capacitor c=0.00359456f //x=30.46 \
 //y=2.375 //x2=29.35 //y2=0.175
cc_4695 ( N_D_c_5348_p N_GND_c_16600_n ) capacitor c=0.0039621f //x=30.46 \
 //y=2.26 //x2=29.35 //y2=0.175
cc_4696 ( N_D_c_5421_p N_GND_c_16600_n ) capacitor c=0.00170145f //x=30.16 \
 //y=1.71 //x2=29.35 //y2=0.175
cc_4697 ( N_D_c_5349_p N_GND_c_16600_n ) capacitor c=0.0102191f //x=30.16 \
 //y=2.095 //x2=29.35 //y2=0.175
cc_4698 ( D N_GND_c_16867_n ) capacitor c=0.00967211f //x=59.32 //y=2.77 \
 //x2=58.21 //y2=0.175
cc_4699 ( N_D_c_5355_p N_GND_c_16867_n ) capacitor c=0.00359456f //x=59.32 \
 //y=2.375 //x2=58.21 //y2=0.175
cc_4700 ( N_D_c_5356_p N_GND_c_16867_n ) capacitor c=0.00379567f //x=59.32 \
 //y=2.26 //x2=58.21 //y2=0.175
cc_4701 ( N_D_c_5432_p N_GND_c_16867_n ) capacitor c=0.00170145f //x=59.02 \
 //y=1.71 //x2=58.21 //y2=0.175
cc_4702 ( N_D_c_5357_p N_GND_c_16867_n ) capacitor c=0.0102191f //x=59.02 \
 //y=2.095 //x2=58.21 //y2=0.175
cc_4703 ( N_D_c_5337_p N_GND_M0_noxref_d ) capacitor c=4.4417e-19 //x=1.6 \
 //y=2.375 //x2=1.375 //y2=1.055
cc_4704 ( N_D_c_5407_p N_GND_M0_noxref_d ) capacitor c=0.00184354f //x=1.3 \
 //y=1.055 //x2=1.375 //y2=1.055
cc_4705 ( N_D_c_5408_p N_GND_M0_noxref_d ) capacitor c=0.00210798f //x=1.3 \
 //y=1.4 //x2=1.375 //y2=1.055
cc_4706 ( N_D_c_5555_p N_GND_M0_noxref_d ) capacitor c=0.00474029f //x=1.675 \
 //y=0.9 //x2=1.375 //y2=1.055
cc_4707 ( N_D_c_5570_p N_GND_M0_noxref_d ) capacitor c=0.00166857f //x=1.675 \
 //y=1.555 //x2=1.375 //y2=1.055
cc_4708 ( N_D_c_5409_p N_GND_M0_noxref_d ) capacitor c=0.00230174f //x=1.83 \
 //y=1.055 //x2=1.375 //y2=1.055
cc_4709 ( N_D_c_5411_p N_GND_M0_noxref_d ) capacitor c=0.00210798f //x=1.83 \
 //y=1.4 //x2=1.375 //y2=1.055
cc_4710 ( N_D_c_5178_n N_GND_M18_noxref_d ) capacitor c=4.4417e-19 //x=30.46 \
 //y=2.375 //x2=30.235 //y2=1.055
cc_4711 ( N_D_c_5418_p N_GND_M18_noxref_d ) capacitor c=0.00184354f //x=30.16 \
 //y=1.055 //x2=30.235 //y2=1.055
cc_4712 ( N_D_c_5419_p N_GND_M18_noxref_d ) capacitor c=0.00210798f //x=30.16 \
 //y=1.4 //x2=30.235 //y2=1.055
cc_4713 ( N_D_c_5558_p N_GND_M18_noxref_d ) capacitor c=0.00474029f //x=30.535 \
 //y=0.9 //x2=30.235 //y2=1.055
cc_4714 ( N_D_c_5580_p N_GND_M18_noxref_d ) capacitor c=0.00166857f //x=30.535 \
 //y=1.555 //x2=30.235 //y2=1.055
cc_4715 ( N_D_c_5420_p N_GND_M18_noxref_d ) capacitor c=0.00230174f //x=30.69 \
 //y=1.055 //x2=30.235 //y2=1.055
cc_4716 ( N_D_c_5422_p N_GND_M18_noxref_d ) capacitor c=0.00210798f //x=30.69 \
 //y=1.4 //x2=30.235 //y2=1.055
cc_4717 ( N_D_c_5355_p N_GND_M36_noxref_d ) capacitor c=4.4417e-19 //x=59.32 \
 //y=2.375 //x2=59.095 //y2=1.055
cc_4718 ( N_D_c_5429_p N_GND_M36_noxref_d ) capacitor c=0.00184354f //x=59.02 \
 //y=1.055 //x2=59.095 //y2=1.055
cc_4719 ( N_D_c_5430_p N_GND_M36_noxref_d ) capacitor c=0.00210798f //x=59.02 \
 //y=1.4 //x2=59.095 //y2=1.055
cc_4720 ( N_D_c_5561_p N_GND_M36_noxref_d ) capacitor c=0.00474029f //x=59.395 \
 //y=0.9 //x2=59.095 //y2=1.055
cc_4721 ( N_D_c_5590_p N_GND_M36_noxref_d ) capacitor c=0.00166857f //x=59.395 \
 //y=1.555 //x2=59.095 //y2=1.055
cc_4722 ( N_D_c_5431_p N_GND_M36_noxref_d ) capacitor c=0.00230174f //x=59.55 \
 //y=1.055 //x2=59.095 //y2=1.055
cc_4723 ( N_D_c_5433_p N_GND_M36_noxref_d ) capacitor c=0.00210798f //x=59.55 \
 //y=1.4 //x2=59.095 //y2=1.055
cc_4724 ( N_D_c_5340_p N_noxref_47_c_18135_n ) capacitor c=0.00267608f //x=1.3 \
 //y=2.095 //x2=1.08 //y2=1.685
cc_4725 ( N_D_c_5337_p N_noxref_47_c_18136_n ) capacitor c=0.00428451f //x=1.6 \
 //y=2.375 //x2=1.965 //y2=1.77
cc_4726 ( N_D_c_5315_p N_noxref_47_c_18136_n ) capacitor c=0.00193816f //x=1.6 \
 //y=4.42 //x2=1.965 //y2=1.77
cc_4727 ( N_D_c_5110_n N_noxref_47_c_18136_n ) capacitor c=0.00238944f \
 //x=8.245 //y=4.25 //x2=1.965 //y2=1.77
cc_4728 ( N_D_c_5339_p N_noxref_47_c_18136_n ) capacitor c=0.0104666f //x=1.6 \
 //y=2.26 //x2=1.965 //y2=1.77
cc_4729 ( N_D_c_5410_p N_noxref_47_c_18136_n ) capacitor c=0.00703864f //x=1.3 \
 //y=1.71 //x2=1.965 //y2=1.77
cc_4730 ( N_D_c_5340_p N_noxref_47_c_18136_n ) capacitor c=0.0230761f //x=1.3 \
 //y=2.095 //x2=1.965 //y2=1.77
cc_4731 ( N_D_c_5570_p N_noxref_47_c_18136_n ) capacitor c=0.00588627f \
 //x=1.675 //y=1.555 //x2=1.965 //y2=1.77
cc_4732 ( N_D_c_5411_p N_noxref_47_c_18136_n ) capacitor c=0.00754339f \
 //x=1.83 //y=1.4 //x2=1.965 //y2=1.77
cc_4733 ( N_D_c_5110_n N_noxref_47_c_18144_n ) capacitor c=0.00412578f \
 //x=8.245 //y=4.25 //x2=2.935 //y2=1.77
cc_4734 ( N_D_c_5110_n N_noxref_47_M0_noxref_s ) capacitor c=0.0018013f \
 //x=8.245 //y=4.25 //x2=0.945 //y2=0.555
cc_4735 ( N_D_c_5407_p N_noxref_47_M0_noxref_s ) capacitor c=0.0295256f \
 //x=1.3 //y=1.055 //x2=0.945 //y2=0.555
cc_4736 ( N_D_c_5410_p N_noxref_47_M0_noxref_s ) capacitor c=7.99997e-19 \
 //x=1.3 //y=1.71 //x2=0.945 //y2=0.555
cc_4737 ( N_D_c_5340_p N_noxref_47_M0_noxref_s ) capacitor c=0.00122123f \
 //x=1.3 //y=2.095 //x2=0.945 //y2=0.555
cc_4738 ( N_D_c_5409_p N_noxref_47_M0_noxref_s ) capacitor c=0.0125924f \
 //x=1.83 //y=1.055 //x2=0.945 //y2=0.555
cc_4739 ( N_D_c_5349_p N_noxref_53_c_18481_n ) capacitor c=0.00262672f \
 //x=30.16 //y=2.095 //x2=29.94 //y2=1.685
cc_4740 ( N_D_c_5178_n N_noxref_53_c_18482_n ) capacitor c=0.00428451f \
 //x=30.46 //y=2.375 //x2=30.825 //y2=1.77
cc_4741 ( N_D_c_5179_n N_noxref_53_c_18482_n ) capacitor c=0.00105929f \
 //x=30.46 //y=4.395 //x2=30.825 //y2=1.77
cc_4742 ( N_D_c_5348_p N_noxref_53_c_18482_n ) capacitor c=0.0104666f \
 //x=30.46 //y=2.26 //x2=30.825 //y2=1.77
cc_4743 ( N_D_c_5421_p N_noxref_53_c_18482_n ) capacitor c=0.00705077f \
 //x=30.16 //y=1.71 //x2=30.825 //y2=1.77
cc_4744 ( N_D_c_5349_p N_noxref_53_c_18482_n ) capacitor c=0.020708f //x=30.16 \
 //y=2.095 //x2=30.825 //y2=1.77
cc_4745 ( N_D_c_5580_p N_noxref_53_c_18482_n ) capacitor c=0.00588627f \
 //x=30.535 //y=1.555 //x2=30.825 //y2=1.77
cc_4746 ( N_D_c_5422_p N_noxref_53_c_18482_n ) capacitor c=0.00698822f \
 //x=30.69 //y=1.4 //x2=30.825 //y2=1.77
cc_4747 ( N_D_c_5418_p N_noxref_53_M18_noxref_s ) capacitor c=0.0295256f \
 //x=30.16 //y=1.055 //x2=29.805 //y2=0.555
cc_4748 ( N_D_c_5421_p N_noxref_53_M18_noxref_s ) capacitor c=7.99997e-19 \
 //x=30.16 //y=1.71 //x2=29.805 //y2=0.555
cc_4749 ( N_D_c_5349_p N_noxref_53_M18_noxref_s ) capacitor c=0.00122123f \
 //x=30.16 //y=2.095 //x2=29.805 //y2=0.555
cc_4750 ( N_D_c_5420_p N_noxref_53_M18_noxref_s ) capacitor c=0.0125924f \
 //x=30.69 //y=1.055 //x2=29.805 //y2=0.555
cc_4751 ( N_D_c_5357_p N_noxref_59_c_18828_n ) capacitor c=0.00262672f \
 //x=59.02 //y=2.095 //x2=58.8 //y2=1.685
cc_4752 ( N_D_c_5355_p N_noxref_59_c_18829_n ) capacitor c=0.00428451f \
 //x=59.32 //y=2.375 //x2=59.685 //y2=1.77
cc_4753 ( N_D_c_5298_p N_noxref_59_c_18829_n ) capacitor c=0.00174369f \
 //x=59.32 //y=4.41 //x2=59.685 //y2=1.77
cc_4754 ( N_D_c_5356_p N_noxref_59_c_18829_n ) capacitor c=0.0104666f \
 //x=59.32 //y=2.26 //x2=59.685 //y2=1.77
cc_4755 ( N_D_c_5432_p N_noxref_59_c_18829_n ) capacitor c=0.00705077f \
 //x=59.02 //y=1.71 //x2=59.685 //y2=1.77
cc_4756 ( N_D_c_5357_p N_noxref_59_c_18829_n ) capacitor c=0.020708f //x=59.02 \
 //y=2.095 //x2=59.685 //y2=1.77
cc_4757 ( N_D_c_5590_p N_noxref_59_c_18829_n ) capacitor c=0.00588627f \
 //x=59.395 //y=1.555 //x2=59.685 //y2=1.77
cc_4758 ( N_D_c_5433_p N_noxref_59_c_18829_n ) capacitor c=0.00698822f \
 //x=59.55 //y=1.4 //x2=59.685 //y2=1.77
cc_4759 ( N_D_c_5429_p N_noxref_59_M36_noxref_s ) capacitor c=0.0295256f \
 //x=59.02 //y=1.055 //x2=58.665 //y2=0.555
cc_4760 ( N_D_c_5432_p N_noxref_59_M36_noxref_s ) capacitor c=7.99997e-19 \
 //x=59.02 //y=1.71 //x2=58.665 //y2=0.555
cc_4761 ( N_D_c_5357_p N_noxref_59_M36_noxref_s ) capacitor c=0.00122123f \
 //x=59.02 //y=2.095 //x2=58.665 //y2=0.555
cc_4762 ( N_D_c_5431_p N_noxref_59_M36_noxref_s ) capacitor c=0.0125924f \
 //x=59.55 //y=1.055 //x2=58.665 //y2=0.555
cc_4763 ( N_noxref_13_M146_noxref_g N_noxref_14_c_6120_n ) capacitor \
 c=0.00813346f //x=69.58 //y=6.2 //x2=70.12 //y2=5.335
cc_4764 ( N_noxref_13_M145_noxref_g N_noxref_14_c_6114_n ) capacitor \
 c=0.00461408f //x=69.14 //y=6.2 //x2=69.362 //y2=5.335
cc_4765 ( N_noxref_13_M146_noxref_g N_noxref_14_c_6114_n ) capacitor \
 c=0.00229208f //x=69.58 //y=6.2 //x2=69.362 //y2=5.335
cc_4766 ( N_noxref_13_c_5682_n N_noxref_14_c_6114_n ) capacitor c=0.00171885f \
 //x=69.505 //y=4.97 //x2=69.362 //y2=5.335
cc_4767 ( N_noxref_13_c_5695_p N_noxref_14_c_6124_n ) capacitor c=4.2553e-19 \
 //x=68.94 //y=2.77 //x2=71.9 //y2=2.77
cc_4768 ( N_noxref_13_M145_noxref_g N_noxref_14_c_6125_n ) capacitor \
 c=0.0162284f //x=69.14 //y=6.2 //x2=69.36 //y2=5.56
cc_4769 ( N_noxref_13_M146_noxref_g N_noxref_14_c_6125_n ) capacitor \
 c=0.0179041f //x=69.58 //y=6.2 //x2=69.36 //y2=5.56
cc_4770 ( N_noxref_13_c_5682_n N_noxref_14_c_6125_n ) capacitor c=0.00291477f \
 //x=69.505 //y=4.97 //x2=69.36 //y2=5.56
cc_4771 ( N_noxref_13_c_5699_p CLK ) capacitor c=3.44709e-19 //x=62.28 \
 //y=2.625 //x2=65.24 //y2=4.62
cc_4772 ( N_noxref_13_c_5672_n CLK ) capacitor c=0.00121985f //x=62.28 \
 //y=5.25 //x2=65.24 //y2=4.62
cc_4773 ( N_noxref_13_c_5701_p CLK ) capacitor c=0.00510083f //x=64.13 \
 //y=2.625 //x2=65.24 //y2=4.62
cc_4774 ( N_noxref_13_c_5702_p CLK ) capacitor c=0.00782284f //x=64.13 \
 //y=2.945 //x2=65.24 //y2=4.62
cc_4775 ( N_noxref_13_c_5674_n CLK ) capacitor c=0.041174f //x=64.13 //y=4.755 \
 //x2=65.24 //y2=4.62
cc_4776 ( N_noxref_13_c_5704_p CLK ) capacitor c=4.11345e-19 //x=64.13 \
 //y=2.77 //x2=65.24 //y2=4.62
cc_4777 ( N_noxref_13_c_5705_p CLK ) capacitor c=0.00248676f //x=64.295 \
 //y=2.785 //x2=65.24 //y2=4.62
cc_4778 ( N_noxref_13_c_5706_p CLK ) capacitor c=0.0229179f //x=68.78 \
 //y=2.785 //x2=65.24 //y2=4.62
cc_4779 ( N_noxref_13_c_5707_p CLK ) capacitor c=3.9149e-19 //x=64.13 //y=2.26 \
 //x2=65.24 //y2=4.62
cc_4780 ( N_noxref_13_c_5708_p N_CLK_c_6860_n ) capacitor c=0.00932261f \
 //x=64.13 //y=2.375 //x2=65.24 //y2=2.375
cc_4781 ( N_noxref_13_c_5707_p N_CLK_c_6860_n ) capacitor c=5.40058e-19 \
 //x=64.13 //y=2.26 //x2=65.24 //y2=2.375
cc_4782 ( N_noxref_13_c_5710_p N_CLK_c_6860_n ) capacitor c=0.00142893f \
 //x=63.83 //y=2.095 //x2=65.24 //y2=2.375
cc_4783 ( N_noxref_13_c_5674_n N_CLK_c_6598_n ) capacitor c=0.00778243f \
 //x=64.13 //y=4.755 //x2=65.235 //y2=4.835
cc_4784 ( N_noxref_13_c_5712_p N_CLK_c_6598_n ) capacitor c=6.32742e-19 \
 //x=64.13 //y=4.88 //x2=65.235 //y2=4.835
cc_4785 ( N_noxref_13_c_5681_n N_CLK_c_6598_n ) capacitor c=7.15803e-19 \
 //x=64.695 //y=4.97 //x2=65.235 //y2=4.835
cc_4786 ( N_noxref_13_c_5714_p N_CLK_c_6598_n ) capacitor c=8.67242e-19 \
 //x=64.405 //y=4.97 //x2=65.235 //y2=4.835
cc_4787 ( N_noxref_13_c_5675_n N_CLK_c_6627_n ) capacitor c=0.0275006f \
 //x=68.94 //y=4.755 //x2=74.705 //y2=4.62
cc_4788 ( N_noxref_13_c_5672_n N_CLK_c_6630_n ) capacitor c=0.0260299f \
 //x=62.28 //y=5.25 //x2=65.395 //y2=4.62
cc_4789 ( N_noxref_13_c_5674_n N_CLK_c_6630_n ) capacitor c=0.0346861f \
 //x=64.13 //y=4.755 //x2=65.395 //y2=4.62
cc_4790 ( N_noxref_13_c_5708_p N_CLK_c_6870_n ) capacitor c=5.39999e-19 \
 //x=64.13 //y=2.375 //x2=65.24 //y2=2.26
cc_4791 ( N_noxref_13_c_5701_p N_CLK_c_6870_n ) capacitor c=3.9149e-19 \
 //x=64.13 //y=2.625 //x2=65.24 //y2=2.26
cc_4792 ( N_noxref_13_c_5707_p N_CLK_c_6870_n ) capacitor c=0.00125213f \
 //x=64.13 //y=2.26 //x2=65.24 //y2=2.26
cc_4793 ( N_noxref_13_c_5710_p N_CLK_c_6870_n ) capacitor c=0.00214573f \
 //x=63.83 //y=2.095 //x2=65.24 //y2=2.26
cc_4794 ( N_noxref_13_c_5674_n N_CLK_c_6874_n ) capacitor c=4.24307e-19 \
 //x=64.13 //y=4.755 //x2=65.24 //y2=4.88
cc_4795 ( N_noxref_13_c_5712_p N_CLK_c_6874_n ) capacitor c=0.00113666f \
 //x=64.13 //y=4.88 //x2=65.24 //y2=4.88
cc_4796 ( N_noxref_13_c_5681_n N_CLK_c_6874_n ) capacitor c=0.00116563f \
 //x=64.695 //y=4.97 //x2=65.24 //y2=4.88
cc_4797 ( N_noxref_13_c_5714_p N_CLK_c_6874_n ) capacitor c=0.0012974f \
 //x=64.405 //y=4.97 //x2=65.24 //y2=4.88
cc_4798 ( N_noxref_13_M139_noxref_g N_CLK_M141_noxref_g ) capacitor \
 c=0.0106544f //x=64.33 //y=6.2 //x2=65.21 //y2=6.2
cc_4799 ( N_noxref_13_M140_noxref_g N_CLK_M141_noxref_g ) capacitor \
 c=0.107063f //x=64.77 //y=6.2 //x2=65.21 //y2=6.2
cc_4800 ( N_noxref_13_M140_noxref_g N_CLK_M142_noxref_g ) capacitor \
 c=0.0102118f //x=64.77 //y=6.2 //x2=65.65 //y2=6.2
cc_4801 ( N_noxref_13_c_5729_p N_CLK_c_6881_n ) capacitor c=5.72528e-19 \
 //x=63.83 //y=1.055 //x2=64.805 //y2=1.09
cc_4802 ( N_noxref_13_c_5730_p N_CLK_c_6881_n ) capacitor c=0.00150277f \
 //x=63.83 //y=1.4 //x2=64.805 //y2=1.09
cc_4803 ( N_noxref_13_c_5731_p N_CLK_c_6881_n ) capacitor c=0.0160123f \
 //x=64.36 //y=1.055 //x2=64.805 //y2=1.09
cc_4804 ( N_noxref_13_c_5732_p N_CLK_c_6884_n ) capacitor c=0.00111227f \
 //x=63.83 //y=1.71 //x2=64.805 //y2=1.4
cc_4805 ( N_noxref_13_c_5733_p N_CLK_c_6884_n ) capacitor c=0.0124075f \
 //x=64.36 //y=1.4 //x2=64.805 //y2=1.4
cc_4806 ( N_noxref_13_c_5731_p N_CLK_c_6886_n ) capacitor c=9.19165e-19 \
 //x=64.36 //y=1.055 //x2=65.33 //y2=1.09
cc_4807 ( N_noxref_13_c_5733_p N_CLK_c_6887_n ) capacitor c=0.0010154f \
 //x=64.36 //y=1.4 //x2=65.33 //y2=1.4
cc_4808 ( N_noxref_13_c_5733_p N_CLK_c_6888_n ) capacitor c=9.23422e-19 \
 //x=64.36 //y=1.4 //x2=65.33 //y2=1.63
cc_4809 ( N_noxref_13_c_5708_p N_CLK_c_6889_n ) capacitor c=0.00136403f \
 //x=64.13 //y=2.375 //x2=65.33 //y2=2.095
cc_4810 ( N_noxref_13_c_5707_p N_CLK_c_6889_n ) capacitor c=0.0020754f \
 //x=64.13 //y=2.26 //x2=65.33 //y2=2.095
cc_4811 ( N_noxref_13_c_5710_p N_CLK_c_6889_n ) capacitor c=0.00964411f \
 //x=63.83 //y=2.095 //x2=65.33 //y2=2.095
cc_4812 ( N_noxref_13_c_5712_p N_CLK_c_6892_n ) capacitor c=0.00123917f \
 //x=64.13 //y=4.88 //x2=65.24 //y2=4.88
cc_4813 ( N_noxref_13_c_5681_n N_CLK_c_6892_n ) capacitor c=0.0169508f \
 //x=64.695 //y=4.97 //x2=65.24 //y2=4.88
cc_4814 ( N_noxref_13_c_5714_p N_CLK_c_6892_n ) capacitor c=0.00406071f \
 //x=64.405 //y=4.97 //x2=65.24 //y2=4.88
cc_4815 ( N_noxref_13_c_5699_p N_noxref_16_c_7388_n ) capacitor c=0.0139504f \
 //x=62.28 //y=2.625 //x2=61.54 //y2=2.375
cc_4816 ( N_noxref_13_c_5699_p N_noxref_16_c_7385_n ) capacitor c=0.00894987f \
 //x=62.28 //y=2.625 //x2=61.54 //y2=3.355
cc_4817 ( N_noxref_13_c_5745_p N_noxref_16_c_7385_n ) capacitor c=0.014957f \
 //x=62.28 //y=2.945 //x2=61.54 //y2=3.355
cc_4818 ( N_noxref_13_c_5672_n N_noxref_16_c_7385_n ) capacitor c=0.0161307f \
 //x=62.28 //y=5.25 //x2=61.54 //y2=3.355
cc_4819 ( N_noxref_13_c_5701_p N_noxref_16_c_7385_n ) capacitor c=4.63723e-19 \
 //x=64.13 //y=2.625 //x2=61.54 //y2=3.355
cc_4820 ( N_noxref_13_c_5674_n N_noxref_16_c_7385_n ) capacitor c=3.2751e-19 \
 //x=64.13 //y=4.755 //x2=61.54 //y2=3.355
cc_4821 ( N_noxref_13_c_5749_p N_noxref_16_c_7385_n ) capacitor c=7.6985e-19 \
 //x=62.28 //y=2.77 //x2=61.54 //y2=3.355
cc_4822 ( N_noxref_13_c_5750_p N_noxref_16_c_7385_n ) capacitor c=0.0068343f \
 //x=62.445 //y=2.785 //x2=61.54 //y2=3.355
cc_4823 ( N_noxref_13_c_5671_n N_noxref_16_c_7396_n ) capacitor c=9.47139e-19 \
 //x=62.195 //y=5.335 //x2=61.54 //y2=3.675
cc_4824 ( N_noxref_13_c_5752_p N_noxref_16_c_7396_n ) capacitor c=2.35691e-19 \
 //x=61.795 //y=1.305 //x2=61.54 //y2=3.675
cc_4825 ( N_noxref_13_c_5753_p N_noxref_16_c_7396_n ) capacitor c=0.00102808f \
 //x=61.88 //y=1.845 //x2=61.54 //y2=3.675
cc_4826 ( N_noxref_13_c_5672_n N_noxref_16_c_7396_n ) capacitor c=0.0174568f \
 //x=62.28 //y=5.25 //x2=61.54 //y2=3.675
cc_4827 ( N_noxref_13_c_5755_p N_noxref_16_c_7396_n ) capacitor c=5.85102e-19 \
 //x=61.5 //y=5.335 //x2=61.54 //y2=3.675
cc_4828 ( N_noxref_13_c_5671_n N_noxref_16_c_7371_n ) capacitor c=0.00198098f \
 //x=62.195 //y=5.335 //x2=61.54 //y2=4.75
cc_4829 ( N_noxref_13_c_5672_n N_noxref_16_c_7371_n ) capacitor c=0.0563913f \
 //x=62.28 //y=5.25 //x2=61.54 //y2=4.75
cc_4830 ( N_noxref_13_c_5674_n N_noxref_16_c_7371_n ) capacitor c=0.00138094f \
 //x=64.13 //y=4.755 //x2=61.54 //y2=4.75
cc_4831 ( N_noxref_13_c_5755_p N_noxref_16_c_7371_n ) capacitor c=0.0193619f \
 //x=61.5 //y=5.335 //x2=61.54 //y2=4.75
cc_4832 ( N_noxref_13_c_5760_p N_noxref_16_c_7371_n ) capacitor c=0.00217979f \
 //x=61.5 //y=5.56 //x2=61.54 //y2=4.75
cc_4833 ( N_noxref_13_M140_noxref_g N_noxref_16_c_7372_n ) capacitor \
 c=0.0072583f //x=64.77 //y=6.2 //x2=65.31 //y2=5.335
cc_4834 ( N_noxref_13_c_5762_p N_noxref_16_c_7407_n ) capacitor c=0.00163399f \
 //x=62.195 //y=1.845 //x2=66.69 //y2=1.845
cc_4835 ( N_noxref_13_c_5763_p N_noxref_16_c_7408_n ) capacitor c=0.00357748f \
 //x=68.94 //y=2.375 //x2=67.09 //y2=3.335
cc_4836 ( N_noxref_13_c_5764_p N_noxref_16_c_7408_n ) capacitor c=0.00243104f \
 //x=68.94 //y=2.625 //x2=67.09 //y2=3.335
cc_4837 ( N_noxref_13_c_5765_p N_noxref_16_c_7408_n ) capacitor c=0.00248785f \
 //x=68.94 //y=2.945 //x2=67.09 //y2=3.335
cc_4838 ( N_noxref_13_c_5675_n N_noxref_16_c_7408_n ) capacitor c=0.00451274f \
 //x=68.94 //y=4.755 //x2=67.09 //y2=3.335
cc_4839 ( N_noxref_13_c_5767_p N_noxref_16_c_7408_n ) capacitor c=0.00159838f \
 //x=68.94 //y=2.785 //x2=67.09 //y2=3.335
cc_4840 ( N_noxref_13_c_5706_p N_noxref_16_c_7408_n ) capacitor c=0.0228367f \
 //x=68.78 //y=2.785 //x2=67.09 //y2=3.335
cc_4841 ( N_noxref_13_c_5675_n N_noxref_16_c_7414_n ) capacitor c=0.00254697f \
 //x=68.94 //y=4.755 //x2=67.09 //y2=3.655
cc_4842 ( N_noxref_13_c_5675_n N_noxref_16_c_7375_n ) capacitor c=0.0146976f \
 //x=68.94 //y=4.755 //x2=67.09 //y2=5.25
cc_4843 ( N_noxref_13_c_5672_n N_noxref_16_c_7416_n ) capacitor c=6.89957e-19 \
 //x=62.28 //y=5.25 //x2=61.54 //y2=3.51
cc_4844 ( N_noxref_13_c_5772_p N_noxref_16_c_7379_n ) capacitor c=6.09703e-19 \
 //x=61.5 //y=5.56 //x2=64.552 //y2=5.335
cc_4845 ( N_noxref_13_c_5671_n N_noxref_16_c_7379_n ) capacitor c=0.00300445f \
 //x=62.195 //y=5.335 //x2=64.552 //y2=5.335
cc_4846 ( N_noxref_13_M139_noxref_g N_noxref_16_c_7379_n ) capacitor \
 c=0.00461408f //x=64.33 //y=6.2 //x2=64.552 //y2=5.335
cc_4847 ( N_noxref_13_M140_noxref_g N_noxref_16_c_7379_n ) capacitor \
 c=0.0026299f //x=64.77 //y=6.2 //x2=64.552 //y2=5.335
cc_4848 ( N_noxref_13_c_5681_n N_noxref_16_c_7379_n ) capacitor c=0.00194706f \
 //x=64.695 //y=4.97 //x2=64.552 //y2=5.335
cc_4849 ( N_noxref_13_c_5675_n N_noxref_16_c_7422_n ) capacitor c=0.0242814f \
 //x=68.94 //y=4.755 //x2=78.395 //y2=3.51
cc_4850 ( N_noxref_13_c_5706_p N_noxref_16_c_7422_n ) capacitor c=0.00854491f \
 //x=68.78 //y=2.785 //x2=78.395 //y2=3.51
cc_4851 ( N_noxref_13_c_5672_n N_noxref_16_c_7424_n ) capacitor c=0.00330634f \
 //x=62.28 //y=5.25 //x2=61.71 //y2=3.515
cc_4852 ( N_noxref_13_c_5672_n N_noxref_16_c_7425_n ) capacitor c=0.0219892f \
 //x=62.28 //y=5.25 //x2=66.93 //y2=3.495
cc_4853 ( N_noxref_13_c_5674_n N_noxref_16_c_7425_n ) capacitor c=0.0245208f \
 //x=64.13 //y=4.755 //x2=66.93 //y2=3.495
cc_4854 ( N_noxref_13_c_5782_p N_noxref_16_c_7425_n ) capacitor c=0.00883258f \
 //x=63.975 //y=2.785 //x2=66.93 //y2=3.495
cc_4855 ( N_noxref_13_c_5706_p N_noxref_16_c_7425_n ) capacitor c=0.022994f \
 //x=68.78 //y=2.785 //x2=66.93 //y2=3.495
cc_4856 ( N_noxref_13_c_5675_n N_noxref_16_c_7429_n ) capacitor c=0.00159838f \
 //x=68.94 //y=4.755 //x2=67.25 //y2=3.495
cc_4857 ( N_noxref_13_c_5699_p N_noxref_16_c_7430_n ) capacitor c=0.0015536f \
 //x=62.28 //y=2.625 //x2=61.54 //y2=2.26
cc_4858 ( N_noxref_13_c_5671_n N_noxref_16_c_7431_n ) capacitor c=0.00130631f \
 //x=62.195 //y=5.335 //x2=61.54 //y2=4.88
cc_4859 ( N_noxref_13_c_5672_n N_noxref_16_c_7431_n ) capacitor c=0.00126408f \
 //x=62.28 //y=5.25 //x2=61.54 //y2=4.88
cc_4860 ( N_noxref_13_c_5755_p N_noxref_16_c_7431_n ) capacitor c=0.00346456f \
 //x=61.5 //y=5.335 //x2=61.54 //y2=4.88
cc_4861 ( N_noxref_13_c_5760_p N_noxref_16_c_7431_n ) capacitor c=0.00624059f \
 //x=61.5 //y=5.56 //x2=61.54 //y2=4.88
cc_4862 ( N_noxref_13_M139_noxref_g N_noxref_16_c_7435_n ) capacitor \
 c=0.0162284f //x=64.33 //y=6.2 //x2=64.55 //y2=5.56
cc_4863 ( N_noxref_13_M140_noxref_g N_noxref_16_c_7435_n ) capacitor \
 c=0.0178171f //x=64.77 //y=6.2 //x2=64.55 //y2=5.56
cc_4864 ( N_noxref_13_c_5681_n N_noxref_16_c_7435_n ) capacitor c=0.00291477f \
 //x=64.695 //y=4.97 //x2=64.55 //y2=5.56
cc_4865 ( N_noxref_13_c_5793_p N_noxref_16_M137_noxref_g ) capacitor \
 c=0.00875663f //x=61.385 //y=5.335 //x2=61.28 //y2=6.2
cc_4866 ( N_noxref_13_c_5772_p N_noxref_16_M137_noxref_g ) capacitor \
 c=0.00226521f //x=61.5 //y=5.56 //x2=61.28 //y2=6.2
cc_4867 ( N_noxref_13_c_5760_p N_noxref_16_M137_noxref_g ) capacitor \
 c=0.0178885f //x=61.5 //y=5.56 //x2=61.28 //y2=6.2
cc_4868 ( N_noxref_13_c_5772_p N_noxref_16_M138_noxref_g ) capacitor \
 c=0.00381703f //x=61.5 //y=5.56 //x2=61.72 //y2=6.2
cc_4869 ( N_noxref_13_c_5671_n N_noxref_16_M138_noxref_g ) capacitor \
 c=0.0106087f //x=62.195 //y=5.335 //x2=61.72 //y2=6.2
cc_4870 ( N_noxref_13_c_5760_p N_noxref_16_M138_noxref_g ) capacitor \
 c=0.0188608f //x=61.5 //y=5.56 //x2=61.72 //y2=6.2
cc_4871 ( N_noxref_13_c_5752_p N_noxref_16_c_7444_n ) capacitor c=4.64015e-19 \
 //x=61.795 //y=1.305 //x2=61.53 //y2=1.095
cc_4872 ( N_noxref_13_M38_noxref_d N_noxref_16_c_7444_n ) capacitor \
 c=0.00137165f //x=61.605 //y=1.095 //x2=61.53 //y2=1.095
cc_4873 ( N_noxref_13_c_5752_p N_noxref_16_c_7446_n ) capacitor c=0.0026012f \
 //x=61.795 //y=1.305 //x2=61.53 //y2=1.44
cc_4874 ( N_noxref_13_c_5802_p N_noxref_16_c_7446_n ) capacitor c=0.00127432f \
 //x=61.795 //y=1.76 //x2=61.53 //y2=1.44
cc_4875 ( N_noxref_13_M38_noxref_d N_noxref_16_c_7446_n ) capacitor \
 c=0.00237422f //x=61.605 //y=1.095 //x2=61.53 //y2=1.44
cc_4876 ( N_noxref_13_c_5802_p N_noxref_16_c_7449_n ) capacitor c=0.00429966f \
 //x=61.795 //y=1.76 //x2=61.53 //y2=1.75
cc_4877 ( N_noxref_13_c_5752_p N_noxref_16_c_7450_n ) capacitor c=5.29969e-19 \
 //x=61.795 //y=1.305 //x2=61.905 //y2=0.94
cc_4878 ( N_noxref_13_M38_noxref_d N_noxref_16_c_7450_n ) capacitor \
 c=0.0020782f //x=61.605 //y=1.095 //x2=61.905 //y2=0.94
cc_4879 ( N_noxref_13_c_5752_p N_noxref_16_c_7452_n ) capacitor c=5.00148e-19 \
 //x=61.795 //y=1.305 //x2=61.905 //y2=1.595
cc_4880 ( N_noxref_13_c_5802_p N_noxref_16_c_7452_n ) capacitor c=0.00942306f \
 //x=61.795 //y=1.76 //x2=61.905 //y2=1.595
cc_4881 ( N_noxref_13_c_5762_p N_noxref_16_c_7452_n ) capacitor c=0.00194716f \
 //x=62.195 //y=1.845 //x2=61.905 //y2=1.595
cc_4882 ( N_noxref_13_M38_noxref_d N_noxref_16_c_7452_n ) capacitor \
 c=0.00356097f //x=61.605 //y=1.095 //x2=61.905 //y2=1.595
cc_4883 ( N_noxref_13_c_5752_p N_noxref_16_c_7456_n ) capacitor c=5.24634e-19 \
 //x=61.795 //y=1.305 //x2=62.06 //y2=1.095
cc_4884 ( N_noxref_13_M38_noxref_d N_noxref_16_c_7456_n ) capacitor \
 c=0.00139206f //x=61.605 //y=1.095 //x2=62.06 //y2=1.095
cc_4885 ( N_noxref_13_c_5752_p N_noxref_16_c_7458_n ) capacitor c=0.00307978f \
 //x=61.795 //y=1.305 //x2=62.06 //y2=1.44
cc_4886 ( N_noxref_13_c_5802_p N_noxref_16_c_7458_n ) capacitor c=0.00363411f \
 //x=61.795 //y=1.76 //x2=62.06 //y2=1.44
cc_4887 ( N_noxref_13_c_5762_p N_noxref_16_c_7458_n ) capacitor c=0.00323576f \
 //x=62.195 //y=1.845 //x2=62.06 //y2=1.44
cc_4888 ( N_noxref_13_M38_noxref_d N_noxref_16_c_7458_n ) capacitor \
 c=0.00237422f //x=61.605 //y=1.095 //x2=62.06 //y2=1.44
cc_4889 ( N_noxref_13_c_5699_p N_noxref_16_c_7462_n ) capacitor c=0.0024584f \
 //x=62.28 //y=2.625 //x2=61.54 //y2=2.26
cc_4890 ( N_noxref_13_c_5802_p N_noxref_16_c_7463_n ) capacitor c=0.0036273f \
 //x=61.795 //y=1.76 //x2=61.54 //y2=2.095
cc_4891 ( N_noxref_13_c_5699_p N_noxref_16_c_7463_n ) capacitor c=0.00282067f \
 //x=62.28 //y=2.625 //x2=61.54 //y2=2.095
cc_4892 ( N_noxref_13_c_5672_n N_noxref_16_c_7384_n ) capacitor c=0.00714556f \
 //x=62.28 //y=5.25 //x2=61.54 //y2=4.88
cc_4893 ( N_noxref_13_c_5755_p N_noxref_16_c_7384_n ) capacitor c=0.00203307f \
 //x=61.5 //y=5.335 //x2=61.54 //y2=4.88
cc_4894 ( N_noxref_13_c_5760_p N_noxref_16_c_7384_n ) capacitor c=0.00375636f \
 //x=61.5 //y=5.56 //x2=61.54 //y2=4.88
cc_4895 ( N_noxref_13_c_5672_n RN ) capacitor c=0.00324974f //x=62.28 //y=5.25 \
 //x2=60.43 //y2=2.77
cc_4896 ( N_noxref_13_c_5684_n N_RN_c_8476_n ) capacitor c=3.27333e-19 \
 //x=60.5 //y=5.335 //x2=60.43 //y2=2.56
cc_4897 ( N_noxref_13_c_5825_p N_RN_c_8476_n ) capacitor c=4.2393e-19 \
 //x=60.62 //y=5.335 //x2=60.43 //y2=2.56
cc_4898 ( N_noxref_13_c_5684_n N_RN_c_8127_n ) capacitor c=0.0179739f //x=60.5 \
 //y=5.335 //x2=60.43 //y2=4.765
cc_4899 ( N_noxref_13_c_5825_p N_RN_c_8127_n ) capacitor c=0.00209649f \
 //x=60.62 //y=5.335 //x2=60.43 //y2=4.765
cc_4900 ( N_noxref_13_c_5828_p N_RN_c_8127_n ) capacitor c=7.63434e-19 \
 //x=60.62 //y=5.56 //x2=60.43 //y2=4.765
cc_4901 ( N_noxref_13_c_5752_p N_RN_c_8353_n ) capacitor c=6.87062e-19 \
 //x=61.795 //y=1.305 //x2=71.685 //y2=2.385
cc_4902 ( N_noxref_13_c_5753_p N_RN_c_8353_n ) capacitor c=0.0206216f \
 //x=61.88 //y=1.845 //x2=71.685 //y2=2.385
cc_4903 ( N_noxref_13_c_5699_p N_RN_c_8353_n ) capacitor c=0.027263f //x=62.28 \
 //y=2.625 //x2=71.685 //y2=2.385
cc_4904 ( N_noxref_13_c_5745_p N_RN_c_8353_n ) capacitor c=0.00571008f \
 //x=62.28 //y=2.945 //x2=71.685 //y2=2.385
cc_4905 ( N_noxref_13_c_5708_p N_RN_c_8353_n ) capacitor c=0.0155883f \
 //x=64.13 //y=2.375 //x2=71.685 //y2=2.385
cc_4906 ( N_noxref_13_c_5701_p N_RN_c_8353_n ) capacitor c=0.0138002f \
 //x=64.13 //y=2.625 //x2=71.685 //y2=2.385
cc_4907 ( N_noxref_13_c_5702_p N_RN_c_8353_n ) capacitor c=0.00747608f \
 //x=64.13 //y=2.945 //x2=71.685 //y2=2.385
cc_4908 ( N_noxref_13_c_5763_p N_RN_c_8353_n ) capacitor c=0.0155623f \
 //x=68.94 //y=2.375 //x2=71.685 //y2=2.385
cc_4909 ( N_noxref_13_c_5764_p N_RN_c_8353_n ) capacitor c=0.0137567f \
 //x=68.94 //y=2.625 //x2=71.685 //y2=2.385
cc_4910 ( N_noxref_13_c_5765_p N_RN_c_8353_n ) capacitor c=0.00802015f \
 //x=68.94 //y=2.945 //x2=71.685 //y2=2.385
cc_4911 ( N_noxref_13_c_5750_p N_RN_c_8353_n ) capacitor c=0.0365231f \
 //x=62.445 //y=2.785 //x2=71.685 //y2=2.385
cc_4912 ( N_noxref_13_c_5782_p N_RN_c_8353_n ) capacitor c=0.1407f //x=63.975 \
 //y=2.785 //x2=71.685 //y2=2.385
cc_4913 ( N_noxref_13_c_5705_p N_RN_c_8353_n ) capacitor c=0.0370413f \
 //x=64.295 //y=2.785 //x2=71.685 //y2=2.385
cc_4914 ( N_noxref_13_c_5767_p N_RN_c_8353_n ) capacitor c=0.0370413f \
 //x=68.94 //y=2.785 //x2=71.685 //y2=2.385
cc_4915 ( N_noxref_13_c_5706_p N_RN_c_8353_n ) capacitor c=0.404559f //x=68.78 \
 //y=2.785 //x2=71.685 //y2=2.385
cc_4916 ( N_noxref_13_c_5707_p N_RN_c_8353_n ) capacitor c=5.18204e-19 \
 //x=64.13 //y=2.26 //x2=71.685 //y2=2.385
cc_4917 ( N_noxref_13_c_5845_p N_RN_c_8353_n ) capacitor c=5.18204e-19 \
 //x=68.94 //y=2.26 //x2=71.685 //y2=2.385
cc_4918 ( N_noxref_13_c_5710_p N_RN_c_8353_n ) capacitor c=3.41298e-19 \
 //x=63.83 //y=2.095 //x2=71.685 //y2=2.385
cc_4919 ( N_noxref_13_c_5847_p N_RN_c_8353_n ) capacitor c=3.41298e-19 \
 //x=68.64 //y=2.095 //x2=71.685 //y2=2.385
cc_4920 ( N_noxref_13_c_5684_n N_RN_c_8152_n ) capacitor c=0.00492634f \
 //x=60.5 //y=5.335 //x2=60.43 //y2=4.88
cc_4921 ( N_noxref_13_c_5825_p N_RN_c_8152_n ) capacitor c=0.00132214f \
 //x=60.62 //y=5.335 //x2=60.43 //y2=4.88
cc_4922 ( N_noxref_13_c_5684_n N_RN_M135_noxref_g ) capacitor c=0.00858183f \
 //x=60.5 //y=5.335 //x2=60.4 //y2=6.2
cc_4923 ( N_noxref_13_c_5825_p N_RN_M135_noxref_g ) capacitor c=0.00229818f \
 //x=60.62 //y=5.335 //x2=60.4 //y2=6.2
cc_4924 ( N_noxref_13_c_5828_p N_RN_M135_noxref_g ) capacitor c=0.0179041f \
 //x=60.62 //y=5.56 //x2=60.4 //y2=6.2
cc_4925 ( N_noxref_13_c_5793_p N_RN_M136_noxref_g ) capacitor c=0.00875663f \
 //x=61.385 //y=5.335 //x2=60.84 //y2=6.2
cc_4926 ( N_noxref_13_c_5825_p N_RN_M136_noxref_g ) capacitor c=0.00230699f \
 //x=60.62 //y=5.335 //x2=60.84 //y2=6.2
cc_4927 ( N_noxref_13_c_5828_p N_RN_M136_noxref_g ) capacitor c=0.0179041f \
 //x=60.62 //y=5.56 //x2=60.84 //y2=6.2
cc_4928 ( N_noxref_13_c_5825_p N_RN_c_8175_n ) capacitor c=0.00180979f \
 //x=60.62 //y=5.335 //x2=60.765 //y2=4.97
cc_4929 ( N_noxref_13_c_5828_p N_RN_c_8175_n ) capacitor c=0.00290085f \
 //x=60.62 //y=5.56 //x2=60.765 //y2=4.97
cc_4930 ( N_noxref_13_c_5684_n N_RN_c_8570_n ) capacitor c=6.14463e-19 \
 //x=60.5 //y=5.335 //x2=60.43 //y2=4.88
cc_4931 ( N_noxref_13_c_5764_p SN ) capacitor c=0.00510184f //x=68.94 \
 //y=2.625 //x2=70.05 //y2=2.77
cc_4932 ( N_noxref_13_c_5765_p SN ) capacitor c=0.00782712f //x=68.94 \
 //y=2.945 //x2=70.05 //y2=2.77
cc_4933 ( N_noxref_13_c_5675_n SN ) capacitor c=6.32157e-19 //x=68.94 \
 //y=4.755 //x2=70.05 //y2=2.77
cc_4934 ( N_noxref_13_c_5695_p SN ) capacitor c=3.49492e-19 //x=68.94 //y=2.77 \
 //x2=70.05 //y2=2.77
cc_4935 ( N_noxref_13_c_5767_p SN ) capacitor c=0.00513442f //x=68.94 \
 //y=2.785 //x2=70.05 //y2=2.77
cc_4936 ( N_noxref_13_c_5845_p SN ) capacitor c=3.9149e-19 //x=68.94 //y=2.26 \
 //x2=70.05 //y2=2.77
cc_4937 ( N_noxref_13_c_5675_n SN ) capacitor c=5.01652e-19 //x=68.94 \
 //y=4.755 //x2=70.05 //y2=3.14
cc_4938 ( N_noxref_13_c_5763_p N_SN_c_10394_n ) capacitor c=0.00932261f \
 //x=68.94 //y=2.375 //x2=70.05 //y2=2.375
cc_4939 ( N_noxref_13_c_5845_p N_SN_c_10394_n ) capacitor c=5.40058e-19 \
 //x=68.94 //y=2.26 //x2=70.05 //y2=2.375
cc_4940 ( N_noxref_13_c_5847_p N_SN_c_10394_n ) capacitor c=0.00142893f \
 //x=68.64 //y=2.095 //x2=70.05 //y2=2.375
cc_4941 ( N_noxref_13_c_5675_n N_SN_c_10397_n ) capacitor c=0.00694134f \
 //x=68.94 //y=4.755 //x2=70.05 //y2=3.285
cc_4942 ( N_noxref_13_c_5675_n N_SN_c_10070_n ) capacitor c=0.040561f \
 //x=68.94 //y=4.755 //x2=70.05 //y2=4.765
cc_4943 ( N_noxref_13_c_5871_p N_SN_c_10070_n ) capacitor c=6.20857e-19 \
 //x=68.94 //y=4.88 //x2=70.05 //y2=4.765
cc_4944 ( N_noxref_13_c_5682_n N_SN_c_10070_n ) capacitor c=6.98043e-19 \
 //x=69.505 //y=4.97 //x2=70.05 //y2=4.765
cc_4945 ( N_noxref_13_c_5683_n N_SN_c_10070_n ) capacitor c=7.54501e-19 \
 //x=69.215 //y=4.97 //x2=70.05 //y2=4.765
cc_4946 ( N_noxref_13_c_5745_p N_SN_c_10402_n ) capacitor c=0.0014263f \
 //x=62.28 //y=2.945 //x2=61.765 //y2=3.13
cc_4947 ( N_noxref_13_c_5672_n N_SN_c_10402_n ) capacitor c=0.0011062f \
 //x=62.28 //y=5.25 //x2=61.765 //y2=3.13
cc_4948 ( N_noxref_13_c_5750_p N_SN_c_10402_n ) capacitor c=0.0358254f \
 //x=62.445 //y=2.785 //x2=61.765 //y2=3.13
cc_4949 ( N_noxref_13_c_5745_p N_SN_c_10405_n ) capacitor c=0.0101938f \
 //x=62.28 //y=2.945 //x2=62.5 //y2=3.17
cc_4950 ( N_noxref_13_c_5672_n N_SN_c_10405_n ) capacitor c=0.0223753f \
 //x=62.28 //y=5.25 //x2=62.5 //y2=3.17
cc_4951 ( N_noxref_13_c_5674_n N_SN_c_10405_n ) capacitor c=2.04398e-19 \
 //x=64.13 //y=4.755 //x2=62.5 //y2=3.17
cc_4952 ( N_noxref_13_c_5782_p N_SN_c_10405_n ) capacitor c=0.12763f \
 //x=63.975 //y=2.785 //x2=62.5 //y2=3.17
cc_4953 ( N_noxref_13_c_5672_n N_SN_c_10409_n ) capacitor c=2.02793e-19 \
 //x=62.28 //y=5.25 //x2=63.75 //y2=3.14
cc_4954 ( N_noxref_13_c_5702_p N_SN_c_10409_n ) capacitor c=0.00158626f \
 //x=64.13 //y=2.945 //x2=63.75 //y2=3.14
cc_4955 ( N_noxref_13_c_5674_n N_SN_c_10409_n ) capacitor c=0.00101371f \
 //x=64.13 //y=4.755 //x2=63.75 //y2=3.14
cc_4956 ( N_noxref_13_c_5782_p N_SN_c_10409_n ) capacitor c=0.0115746f \
 //x=63.975 //y=2.785 //x2=63.75 //y2=3.14
cc_4957 ( N_noxref_13_c_5705_p N_SN_c_10409_n ) capacitor c=0.0358254f \
 //x=64.295 //y=2.785 //x2=63.75 //y2=3.14
cc_4958 ( N_noxref_13_c_5702_p N_SN_c_10414_n ) capacitor c=0.00689807f \
 //x=64.13 //y=2.945 //x2=64.35 //y2=3.17
cc_4959 ( N_noxref_13_c_5674_n N_SN_c_10414_n ) capacitor c=0.0236429f \
 //x=64.13 //y=4.755 //x2=64.35 //y2=3.17
cc_4960 ( N_noxref_13_c_5706_p N_SN_c_10414_n ) capacitor c=0.2105f //x=68.78 \
 //y=2.785 //x2=64.35 //y2=3.17
cc_4961 ( N_noxref_13_c_5706_p N_SN_c_10417_n ) capacitor c=0.0588312f \
 //x=68.78 //y=2.785 //x2=66.705 //y2=3.14
cc_4962 ( N_noxref_13_c_5675_n N_SN_c_10418_n ) capacitor c=3.96979e-19 \
 //x=68.94 //y=4.755 //x2=67.305 //y2=3.11
cc_4963 ( N_noxref_13_c_5706_p N_SN_c_10418_n ) capacitor c=0.111846f \
 //x=68.78 //y=2.785 //x2=67.305 //y2=3.11
cc_4964 ( N_noxref_13_c_5765_p N_SN_c_10420_n ) capacitor c=0.00507903f \
 //x=68.94 //y=2.945 //x2=68.555 //y2=3.14
cc_4965 ( N_noxref_13_c_5675_n N_SN_c_10420_n ) capacitor c=9.36156e-19 \
 //x=68.94 //y=4.755 //x2=68.555 //y2=3.14
cc_4966 ( N_noxref_13_c_5767_p N_SN_c_10420_n ) capacitor c=0.0358254f \
 //x=68.94 //y=2.785 //x2=68.555 //y2=3.14
cc_4967 ( N_noxref_13_c_5706_p N_SN_c_10420_n ) capacitor c=0.0104657f \
 //x=68.78 //y=2.785 //x2=68.555 //y2=3.14
cc_4968 ( N_noxref_13_c_5765_p N_SN_c_10424_n ) capacitor c=0.00356749f \
 //x=68.94 //y=2.945 //x2=69.155 //y2=3.17
cc_4969 ( N_noxref_13_c_5675_n N_SN_c_10424_n ) capacitor c=0.0225908f \
 //x=68.94 //y=4.755 //x2=69.155 //y2=3.17
cc_4970 ( N_noxref_13_c_5675_n N_SN_c_10426_n ) capacitor c=0.0028832f \
 //x=68.94 //y=4.755 //x2=71.77 //y2=3.155
cc_4971 ( N_noxref_13_c_5763_p N_SN_c_10427_n ) capacitor c=5.39999e-19 \
 //x=68.94 //y=2.375 //x2=70.05 //y2=2.26
cc_4972 ( N_noxref_13_c_5764_p N_SN_c_10427_n ) capacitor c=3.9149e-19 \
 //x=68.94 //y=2.625 //x2=70.05 //y2=2.26
cc_4973 ( N_noxref_13_c_5845_p N_SN_c_10427_n ) capacitor c=0.00125213f \
 //x=68.94 //y=2.26 //x2=70.05 //y2=2.26
cc_4974 ( N_noxref_13_c_5847_p N_SN_c_10427_n ) capacitor c=0.00214573f \
 //x=68.64 //y=2.095 //x2=70.05 //y2=2.26
cc_4975 ( N_noxref_13_c_5675_n N_SN_c_10085_n ) capacitor c=8.93844e-19 \
 //x=68.94 //y=4.755 //x2=70.05 //y2=4.88
cc_4976 ( N_noxref_13_c_5871_p N_SN_c_10085_n ) capacitor c=0.00113984f \
 //x=68.94 //y=4.88 //x2=70.05 //y2=4.88
cc_4977 ( N_noxref_13_c_5682_n N_SN_c_10085_n ) capacitor c=0.00116563f \
 //x=69.505 //y=4.97 //x2=70.05 //y2=4.88
cc_4978 ( N_noxref_13_c_5683_n N_SN_c_10085_n ) capacitor c=0.00129812f \
 //x=69.215 //y=4.97 //x2=70.05 //y2=4.88
cc_4979 ( N_noxref_13_M145_noxref_g N_SN_M147_noxref_g ) capacitor \
 c=0.0106276f //x=69.14 //y=6.2 //x2=70.02 //y2=6.2
cc_4980 ( N_noxref_13_M146_noxref_g N_SN_M147_noxref_g ) capacitor c=0.107144f \
 //x=69.58 //y=6.2 //x2=70.02 //y2=6.2
cc_4981 ( N_noxref_13_M146_noxref_g N_SN_M148_noxref_g ) capacitor \
 c=0.0101598f //x=69.58 //y=6.2 //x2=70.46 //y2=6.2
cc_4982 ( N_noxref_13_c_5910_p N_SN_c_10438_n ) capacitor c=5.72528e-19 \
 //x=68.64 //y=1.055 //x2=69.615 //y2=1.09
cc_4983 ( N_noxref_13_c_5911_p N_SN_c_10438_n ) capacitor c=0.00150277f \
 //x=68.64 //y=1.4 //x2=69.615 //y2=1.09
cc_4984 ( N_noxref_13_c_5912_p N_SN_c_10438_n ) capacitor c=0.0160123f \
 //x=69.17 //y=1.055 //x2=69.615 //y2=1.09
cc_4985 ( N_noxref_13_c_5913_p N_SN_c_10441_n ) capacitor c=0.00111227f \
 //x=68.64 //y=1.71 //x2=69.615 //y2=1.4
cc_4986 ( N_noxref_13_c_5914_p N_SN_c_10441_n ) capacitor c=0.0124075f \
 //x=69.17 //y=1.4 //x2=69.615 //y2=1.4
cc_4987 ( N_noxref_13_c_5912_p N_SN_c_10443_n ) capacitor c=9.19165e-19 \
 //x=69.17 //y=1.055 //x2=70.14 //y2=1.09
cc_4988 ( N_noxref_13_c_5914_p N_SN_c_10444_n ) capacitor c=0.0010154f \
 //x=69.17 //y=1.4 //x2=70.14 //y2=1.4
cc_4989 ( N_noxref_13_c_5914_p N_SN_c_10445_n ) capacitor c=9.23422e-19 \
 //x=69.17 //y=1.4 //x2=70.14 //y2=1.63
cc_4990 ( N_noxref_13_c_5763_p N_SN_c_10446_n ) capacitor c=0.00136403f \
 //x=68.94 //y=2.375 //x2=70.14 //y2=2.095
cc_4991 ( N_noxref_13_c_5845_p N_SN_c_10446_n ) capacitor c=0.0020754f \
 //x=68.94 //y=2.26 //x2=70.14 //y2=2.095
cc_4992 ( N_noxref_13_c_5847_p N_SN_c_10446_n ) capacitor c=0.00964411f \
 //x=68.64 //y=2.095 //x2=70.14 //y2=2.095
cc_4993 ( N_noxref_13_c_5675_n N_SN_c_10449_n ) capacitor c=0.00108708f \
 //x=68.94 //y=4.755 //x2=70.05 //y2=4.88
cc_4994 ( N_noxref_13_c_5871_p N_SN_c_10449_n ) capacitor c=0.00155973f \
 //x=68.94 //y=4.88 //x2=70.05 //y2=4.88
cc_4995 ( N_noxref_13_c_5682_n N_SN_c_10449_n ) capacitor c=0.0171374f \
 //x=69.505 //y=4.97 //x2=70.05 //y2=4.88
cc_4996 ( N_noxref_13_c_5683_n N_SN_c_10449_n ) capacitor c=0.00484466f \
 //x=69.215 //y=4.97 //x2=70.05 //y2=4.88
cc_4997 ( N_noxref_13_c_5701_p N_noxref_20_c_11071_n ) capacitor c=2.88859e-19 \
 //x=64.13 //y=2.625 //x2=66.35 //y2=3.735
cc_4998 ( N_noxref_13_c_5674_n N_noxref_20_c_11071_n ) capacitor c=6.82234e-19 \
 //x=64.13 //y=4.755 //x2=66.35 //y2=3.735
cc_4999 ( N_noxref_13_c_5764_p N_noxref_20_c_11071_n ) capacitor c=4.65873e-19 \
 //x=68.94 //y=2.625 //x2=66.35 //y2=3.735
cc_5000 ( N_noxref_13_c_5675_n N_noxref_20_c_11071_n ) capacitor c=9.95563e-19 \
 //x=68.94 //y=4.755 //x2=66.35 //y2=3.735
cc_5001 ( N_noxref_13_c_5706_p N_noxref_20_c_11071_n ) capacitor c=0.0220649f \
 //x=68.78 //y=2.785 //x2=66.35 //y2=3.735
cc_5002 ( N_noxref_13_c_5674_n N_noxref_20_c_11043_n ) capacitor c=0.00109539f \
 //x=64.13 //y=4.755 //x2=66.35 //y2=4.75
cc_5003 ( N_noxref_13_c_5675_n N_noxref_20_c_11043_n ) capacitor c=8.29068e-19 \
 //x=68.94 //y=4.755 //x2=66.35 //y2=4.75
cc_5004 ( N_noxref_13_c_5764_p N_noxref_20_c_11078_n ) capacitor c=2.88859e-19 \
 //x=68.94 //y=2.625 //x2=71.16 //y2=3.735
cc_5005 ( N_noxref_13_c_5675_n N_noxref_20_c_11078_n ) capacitor c=8.06128e-19 \
 //x=68.94 //y=4.755 //x2=71.16 //y2=3.735
cc_5006 ( N_noxref_13_c_5675_n N_noxref_20_c_11044_n ) capacitor c=6.01094e-19 \
 //x=68.94 //y=4.755 //x2=71.16 //y2=4.75
cc_5007 ( N_noxref_13_c_5675_n N_noxref_20_c_11081_n ) capacitor c=0.0247411f \
 //x=68.94 //y=4.755 //x2=71 //y2=3.895
cc_5008 ( N_noxref_13_c_5676_n N_noxref_22_c_12407_n ) capacitor c=6.09703e-19 \
 //x=59.742 //y=5.335 //x2=56.69 //y2=5.56
cc_5009 ( N_noxref_13_c_5676_n N_noxref_22_c_12409_n ) capacitor c=0.00306432f \
 //x=59.742 //y=5.335 //x2=57.385 //y2=5.335
cc_5010 ( N_noxref_13_c_5753_p N_noxref_22_c_12424_n ) capacitor c=0.00163399f \
 //x=61.88 //y=1.845 //x2=57.385 //y2=1.845
cc_5011 ( N_noxref_13_c_5672_n N_noxref_22_c_12273_n ) capacitor c=0.026626f \
 //x=62.28 //y=5.25 //x2=61.765 //y2=3.9
cc_5012 ( N_noxref_13_c_5674_n N_noxref_22_c_12273_n ) capacitor c=0.0274482f \
 //x=64.13 //y=4.755 //x2=61.765 //y2=3.9
cc_5013 ( N_noxref_13_c_5675_n N_noxref_22_c_12278_n ) capacitor c=0.0247356f \
 //x=68.94 //y=4.755 //x2=66.565 //y2=4.28
cc_5014 ( N_noxref_13_c_5684_n N_VDD_c_13434_n ) capacitor c=0.00559514f \
 //x=60.5 //y=5.335 //x2=87.775 //y2=7.585
cc_5015 ( N_noxref_13_c_5793_p N_VDD_c_13434_n ) capacitor c=0.00564834f \
 //x=61.385 //y=5.335 //x2=87.775 //y2=7.585
cc_5016 ( N_noxref_13_c_5772_p N_VDD_c_13434_n ) capacitor c=0.00236065f \
 //x=61.5 //y=5.56 //x2=87.775 //y2=7.585
cc_5017 ( N_noxref_13_c_5671_n N_VDD_c_13434_n ) capacitor c=0.00753358f \
 //x=62.195 //y=5.335 //x2=87.775 //y2=7.585
cc_5018 ( N_noxref_13_c_5676_n N_VDD_c_13434_n ) capacitor c=0.00241373f \
 //x=59.742 //y=5.335 //x2=87.775 //y2=7.585
cc_5019 ( N_noxref_13_c_5825_p N_VDD_c_13434_n ) capacitor c=0.00249074f \
 //x=60.62 //y=5.335 //x2=87.775 //y2=7.585
cc_5020 ( N_noxref_13_c_5688_n N_VDD_c_13434_n ) capacitor c=0.0024232f \
 //x=59.74 //y=5.56 //x2=87.775 //y2=7.585
cc_5021 ( N_noxref_13_c_5828_p N_VDD_c_13434_n ) capacitor c=0.0024232f \
 //x=60.62 //y=5.56 //x2=87.775 //y2=7.585
cc_5022 ( N_noxref_13_c_5760_p N_VDD_c_13434_n ) capacitor c=0.0024232f \
 //x=61.5 //y=5.56 //x2=87.775 //y2=7.585
cc_5023 ( N_noxref_13_c_5684_n N_VDD_c_14129_n ) capacitor c=0.00202922f \
 //x=60.5 //y=5.335 //x2=60.095 //y2=7.585
cc_5024 ( N_noxref_13_c_5676_n N_VDD_c_14129_n ) capacitor c=9.3757e-19 \
 //x=59.742 //y=5.335 //x2=60.095 //y2=7.585
cc_5025 ( N_noxref_13_c_5688_n N_VDD_c_14129_n ) capacitor c=0.0138074f \
 //x=59.74 //y=5.56 //x2=60.095 //y2=7.585
cc_5026 ( N_noxref_13_c_5684_n N_VDD_c_14187_n ) capacitor c=0.0017708f \
 //x=60.5 //y=5.335 //x2=60.975 //y2=7.585
cc_5027 ( N_noxref_13_c_5793_p N_VDD_c_14187_n ) capacitor c=0.00202922f \
 //x=61.385 //y=5.335 //x2=60.975 //y2=7.585
cc_5028 ( N_noxref_13_c_5825_p N_VDD_c_14187_n ) capacitor c=9.4822e-19 \
 //x=60.62 //y=5.335 //x2=60.975 //y2=7.585
cc_5029 ( N_noxref_13_c_5828_p N_VDD_c_14187_n ) capacitor c=0.0138074f \
 //x=60.62 //y=5.56 //x2=60.975 //y2=7.585
cc_5030 ( N_noxref_13_c_5793_p N_VDD_c_14191_n ) capacitor c=0.00205906f \
 //x=61.385 //y=5.335 //x2=61.855 //y2=7.585
cc_5031 ( N_noxref_13_c_5772_p N_VDD_c_14191_n ) capacitor c=8.49654e-19 \
 //x=61.5 //y=5.56 //x2=61.855 //y2=7.585
cc_5032 ( N_noxref_13_c_5671_n N_VDD_c_14191_n ) capacitor c=0.00204238f \
 //x=62.195 //y=5.335 //x2=61.855 //y2=7.585
cc_5033 ( N_noxref_13_c_5760_p N_VDD_c_14191_n ) capacitor c=0.0129519f \
 //x=61.5 //y=5.56 //x2=61.855 //y2=7.585
cc_5034 ( N_noxref_13_c_5671_n N_VDD_c_14195_n ) capacitor c=0.00183742f \
 //x=62.195 //y=5.335 //x2=62.85 //y2=7.585
cc_5035 ( N_noxref_13_M139_noxref_g N_VDD_c_14196_n ) capacitor c=0.00755614f \
 //x=64.33 //y=6.2 //x2=64.905 //y2=7.585
cc_5036 ( N_noxref_13_M140_noxref_g N_VDD_c_14196_n ) capacitor c=0.00755544f \
 //x=64.77 //y=6.2 //x2=64.905 //y2=7.585
cc_5037 ( N_noxref_13_M145_noxref_g N_VDD_c_14198_n ) capacitor c=0.00755614f \
 //x=69.14 //y=6.2 //x2=69.715 //y2=7.585
cc_5038 ( N_noxref_13_M146_noxref_g N_VDD_c_14198_n ) capacitor c=0.00755544f \
 //x=69.58 //y=6.2 //x2=69.715 //y2=7.585
cc_5039 ( N_noxref_13_c_5676_n N_VDD_c_13780_n ) capacitor c=0.0022955f \
 //x=59.742 //y=5.335 //x2=58.21 //y2=7.585
cc_5040 ( N_noxref_13_c_5688_n N_VDD_c_13780_n ) capacitor c=0.00509469f \
 //x=59.74 //y=5.56 //x2=58.21 //y2=7.585
cc_5041 ( N_noxref_13_c_5772_p N_VDD_c_13781_n ) capacitor c=0.00282782f \
 //x=61.5 //y=5.56 //x2=63.02 //y2=7.585
cc_5042 ( N_noxref_13_c_5672_n N_VDD_c_13781_n ) capacitor c=0.0320635f \
 //x=62.28 //y=5.25 //x2=63.02 //y2=7.585
cc_5043 ( N_noxref_13_c_5674_n N_VDD_c_13781_n ) capacitor c=0.0113912f \
 //x=64.13 //y=4.755 //x2=63.02 //y2=7.585
cc_5044 ( N_noxref_13_c_5760_p N_VDD_c_13781_n ) capacitor c=0.00777981f \
 //x=61.5 //y=5.56 //x2=63.02 //y2=7.585
cc_5045 ( N_noxref_13_c_5712_p N_VDD_c_13781_n ) capacitor c=0.00354568f \
 //x=64.13 //y=4.88 //x2=63.02 //y2=7.585
cc_5046 ( N_noxref_13_c_5714_p N_VDD_c_13781_n ) capacitor c=0.00572368f \
 //x=64.405 //y=4.97 //x2=63.02 //y2=7.585
cc_5047 ( N_noxref_13_c_5675_n N_VDD_c_13783_n ) capacitor c=0.0105972f \
 //x=68.94 //y=4.755 //x2=67.83 //y2=7.585
cc_5048 ( N_noxref_13_c_5871_p N_VDD_c_13783_n ) capacitor c=0.00354568f \
 //x=68.94 //y=4.88 //x2=67.83 //y2=7.585
cc_5049 ( N_noxref_13_c_5683_n N_VDD_c_13783_n ) capacitor c=0.00572368f \
 //x=69.215 //y=4.97 //x2=67.83 //y2=7.585
cc_5050 ( N_noxref_13_c_5676_n N_VDD_M133_noxref_s ) capacitor c=0.0442713f \
 //x=59.742 //y=5.335 //x2=59.165 //y2=5.2
cc_5051 ( N_noxref_13_c_5825_p N_VDD_M133_noxref_s ) capacitor c=7.80122e-19 \
 //x=60.62 //y=5.335 //x2=59.165 //y2=5.2
cc_5052 ( N_noxref_13_c_5688_n N_VDD_M133_noxref_s ) capacitor c=0.09305f \
 //x=59.74 //y=5.56 //x2=59.165 //y2=5.2
cc_5053 ( N_noxref_13_c_5684_n N_VDD_M134_noxref_d ) capacitor c=0.00700141f \
 //x=60.5 //y=5.335 //x2=60.035 //y2=5.2
cc_5054 ( N_noxref_13_c_5688_n N_VDD_M134_noxref_d ) capacitor c=0.0674491f \
 //x=59.74 //y=5.56 //x2=60.035 //y2=5.2
cc_5055 ( N_noxref_13_c_5828_p N_VDD_M134_noxref_d ) capacitor c=0.0674762f \
 //x=60.62 //y=5.56 //x2=60.035 //y2=5.2
cc_5056 ( N_noxref_13_c_5793_p N_VDD_M136_noxref_d ) capacitor c=0.00700141f \
 //x=61.385 //y=5.335 //x2=60.915 //y2=5.2
cc_5057 ( N_noxref_13_c_5828_p N_VDD_M136_noxref_d ) capacitor c=0.067493f \
 //x=60.62 //y=5.56 //x2=60.915 //y2=5.2
cc_5058 ( N_noxref_13_c_5760_p N_VDD_M136_noxref_d ) capacitor c=0.0674979f \
 //x=61.5 //y=5.56 //x2=60.915 //y2=5.2
cc_5059 ( N_noxref_13_c_5671_n N_VDD_M138_noxref_d ) capacitor c=0.00700141f \
 //x=62.195 //y=5.335 //x2=61.795 //y2=5.2
cc_5060 ( N_noxref_13_c_5760_p N_VDD_M138_noxref_d ) capacitor c=0.0675002f \
 //x=61.5 //y=5.56 //x2=61.795 //y2=5.2
cc_5061 ( N_noxref_13_c_5772_p N_VDD_M139_noxref_s ) capacitor c=0.00492616f \
 //x=61.5 //y=5.56 //x2=63.975 //y2=5.2
cc_5062 ( N_noxref_13_c_5671_n N_VDD_M139_noxref_s ) capacitor c=9.40096e-19 \
 //x=62.195 //y=5.335 //x2=63.975 //y2=5.2
cc_5063 ( N_noxref_13_c_5702_p N_VDD_M139_noxref_s ) capacitor c=4.15021e-19 \
 //x=64.13 //y=2.945 //x2=63.975 //y2=5.2
cc_5064 ( N_noxref_13_c_5674_n N_VDD_M139_noxref_s ) capacitor c=0.0167311f \
 //x=64.13 //y=4.755 //x2=63.975 //y2=5.2
cc_5065 ( N_noxref_13_c_5825_p N_VDD_M139_noxref_s ) capacitor c=2.11884e-19 \
 //x=60.62 //y=5.335 //x2=63.975 //y2=5.2
cc_5066 ( N_noxref_13_c_5712_p N_VDD_M139_noxref_s ) capacitor c=0.00983846f \
 //x=64.13 //y=4.88 //x2=63.975 //y2=5.2
cc_5067 ( N_noxref_13_M139_noxref_g N_VDD_M139_noxref_s ) capacitor \
 c=0.053419f //x=64.33 //y=6.2 //x2=63.975 //y2=5.2
cc_5068 ( N_noxref_13_c_5714_p N_VDD_M139_noxref_s ) capacitor c=0.0060887f \
 //x=64.405 //y=4.97 //x2=63.975 //y2=5.2
cc_5069 ( N_noxref_13_M140_noxref_g N_VDD_M140_noxref_d ) capacitor \
 c=0.015318f //x=64.77 //y=6.2 //x2=64.845 //y2=5.2
cc_5070 ( N_noxref_13_c_5765_p N_VDD_M145_noxref_s ) capacitor c=4.15021e-19 \
 //x=68.94 //y=2.945 //x2=68.785 //y2=5.2
cc_5071 ( N_noxref_13_c_5675_n N_VDD_M145_noxref_s ) capacitor c=0.0167311f \
 //x=68.94 //y=4.755 //x2=68.785 //y2=5.2
cc_5072 ( N_noxref_13_c_5871_p N_VDD_M145_noxref_s ) capacitor c=0.00983846f \
 //x=68.94 //y=4.88 //x2=68.785 //y2=5.2
cc_5073 ( N_noxref_13_M145_noxref_g N_VDD_M145_noxref_s ) capacitor \
 c=0.053419f //x=69.14 //y=6.2 //x2=68.785 //y2=5.2
cc_5074 ( N_noxref_13_c_5683_n N_VDD_M145_noxref_s ) capacitor c=0.0060887f \
 //x=69.215 //y=4.97 //x2=68.785 //y2=5.2
cc_5075 ( N_noxref_13_M146_noxref_g N_VDD_M146_noxref_d ) capacitor \
 c=0.015318f //x=69.58 //y=6.2 //x2=69.655 //y2=5.2
cc_5076 ( N_noxref_13_c_5752_p N_noxref_38_c_15692_n ) capacitor c=0.0036878f \
 //x=61.795 //y=1.305 //x2=62.195 //y2=0.72
cc_5077 ( N_noxref_13_c_5762_p N_noxref_38_c_15692_n ) capacitor c=0.00399931f \
 //x=62.195 //y=1.845 //x2=62.195 //y2=0.72
cc_5078 ( N_noxref_13_M38_noxref_d N_noxref_38_c_15692_n ) capacitor \
 c=0.00910163f //x=61.605 //y=1.095 //x2=62.195 //y2=0.72
cc_5079 ( N_noxref_13_M38_noxref_d N_noxref_38_c_15695_n ) capacitor \
 c=0.00120711f //x=61.605 //y=1.095 //x2=61.31 //y2=1.175
cc_5080 ( N_noxref_13_c_5684_n N_noxref_38_M37_noxref_d ) capacitor \
 c=0.00125893f //x=60.5 //y=5.335 //x2=60.07 //y2=1.09
cc_5081 ( N_noxref_13_c_5752_p N_noxref_38_M37_noxref_d ) capacitor \
 c=0.00802417f //x=61.795 //y=1.305 //x2=60.07 //y2=1.09
cc_5082 ( N_noxref_13_c_5752_p N_noxref_38_M38_noxref_s ) capacitor \
 c=0.0098487f //x=61.795 //y=1.305 //x2=61.175 //y2=0.555
cc_5083 ( N_noxref_13_c_5802_p N_noxref_38_M38_noxref_s ) capacitor \
 c=0.0283243f //x=61.795 //y=1.76 //x2=61.175 //y2=0.555
cc_5084 ( N_noxref_13_c_5762_p N_noxref_38_M38_noxref_s ) capacitor \
 c=0.00752108f //x=62.195 //y=1.845 //x2=61.175 //y2=0.555
cc_5085 ( N_noxref_13_c_5749_p N_noxref_38_M38_noxref_s ) capacitor \
 c=0.00309975f //x=62.28 //y=2.77 //x2=61.175 //y2=0.555
cc_5086 ( N_noxref_13_M38_noxref_d N_noxref_38_M38_noxref_s ) capacitor \
 c=0.0279003f //x=61.605 //y=1.095 //x2=61.175 //y2=0.555
cc_5087 ( N_noxref_13_c_5752_p N_noxref_39_M40_noxref_d ) capacitor \
 c=3.20746e-19 //x=61.795 //y=1.305 //x2=64.88 //y2=1.09
cc_5088 ( N_noxref_13_c_5752_p N_GND_c_16949_n ) capacitor c=0.00884249f \
 //x=61.795 //y=1.305 //x2=64.01 //y2=0.175
cc_5089 ( N_noxref_13_c_5762_p N_GND_c_16949_n ) capacitor c=0.00662992f \
 //x=62.195 //y=1.845 //x2=64.01 //y2=0.175
cc_5090 ( N_noxref_13_c_5745_p N_GND_c_16949_n ) capacitor c=4.3138e-19 \
 //x=62.28 //y=2.945 //x2=64.01 //y2=0.175
cc_5091 ( N_noxref_13_M38_noxref_d N_GND_c_16949_n ) capacitor c=2.9462e-19 \
 //x=61.605 //y=1.095 //x2=64.01 //y2=0.175
cc_5092 ( N_noxref_13_c_5729_p N_GND_c_16953_n ) capacitor c=3.97665e-19 \
 //x=63.83 //y=1.055 //x2=64.095 //y2=1.015
cc_5093 ( N_noxref_13_c_6021_p N_GND_c_16953_n ) capacitor c=0.00864776f \
 //x=64.205 //y=0.9 //x2=64.095 //y2=1.015
cc_5094 ( N_noxref_13_c_5731_p N_GND_c_16953_n ) capacitor c=4.45447e-19 \
 //x=64.36 //y=1.055 //x2=64.095 //y2=1.015
cc_5095 ( N_noxref_13_c_5910_p N_GND_c_16956_n ) capacitor c=3.97665e-19 \
 //x=68.64 //y=1.055 //x2=68.905 //y2=1.015
cc_5096 ( N_noxref_13_c_6024_p N_GND_c_16956_n ) capacitor c=0.00864776f \
 //x=69.015 //y=0.9 //x2=68.905 //y2=1.015
cc_5097 ( N_noxref_13_c_5912_p N_GND_c_16956_n ) capacitor c=4.45447e-19 \
 //x=69.17 //y=1.055 //x2=68.905 //y2=1.015
cc_5098 ( N_noxref_13_c_5752_p N_GND_c_16959_n ) capacitor c=0.00543195f \
 //x=61.795 //y=1.305 //x2=64.095 //y2=1.145
cc_5099 ( N_noxref_13_c_5708_p N_GND_c_16959_n ) capacitor c=0.00772482f \
 //x=64.13 //y=2.375 //x2=64.095 //y2=1.145
cc_5100 ( N_noxref_13_c_5702_p N_GND_c_16959_n ) capacitor c=9.18427e-19 \
 //x=64.13 //y=2.945 //x2=64.095 //y2=1.145
cc_5101 ( N_noxref_13_c_5707_p N_GND_c_16959_n ) capacitor c=2.22883e-19 \
 //x=64.13 //y=2.26 //x2=64.095 //y2=1.145
cc_5102 ( N_noxref_13_c_5729_p N_GND_c_16959_n ) capacitor c=0.00156339f \
 //x=63.83 //y=1.055 //x2=64.095 //y2=1.145
cc_5103 ( N_noxref_13_c_5730_p N_GND_c_16959_n ) capacitor c=0.00352472f \
 //x=63.83 //y=1.4 //x2=64.095 //y2=1.145
cc_5104 ( N_noxref_13_c_5732_p N_GND_c_16959_n ) capacitor c=4.35713e-19 \
 //x=63.83 //y=1.71 //x2=64.095 //y2=1.145
cc_5105 ( N_noxref_13_c_6021_p N_GND_c_16959_n ) capacitor c=9.36995e-19 \
 //x=64.205 //y=0.9 //x2=64.095 //y2=1.145
cc_5106 ( N_noxref_13_c_6034_p N_GND_c_16959_n ) capacitor c=5.29132e-19 \
 //x=64.205 //y=1.555 //x2=64.095 //y2=1.145
cc_5107 ( N_noxref_13_c_5731_p N_GND_c_16959_n ) capacitor c=0.0017438f \
 //x=64.36 //y=1.055 //x2=64.095 //y2=1.145
cc_5108 ( N_noxref_13_c_5733_p N_GND_c_16959_n ) capacitor c=0.00276804f \
 //x=64.36 //y=1.4 //x2=64.095 //y2=1.145
cc_5109 ( N_noxref_13_c_5763_p N_GND_c_16970_n ) capacitor c=0.00772482f \
 //x=68.94 //y=2.375 //x2=68.905 //y2=1.145
cc_5110 ( N_noxref_13_c_5765_p N_GND_c_16970_n ) capacitor c=0.00117625f \
 //x=68.94 //y=2.945 //x2=68.905 //y2=1.145
cc_5111 ( N_noxref_13_c_5845_p N_GND_c_16970_n ) capacitor c=2.22883e-19 \
 //x=68.94 //y=2.26 //x2=68.905 //y2=1.145
cc_5112 ( N_noxref_13_c_5910_p N_GND_c_16970_n ) capacitor c=0.00156339f \
 //x=68.64 //y=1.055 //x2=68.905 //y2=1.145
cc_5113 ( N_noxref_13_c_5911_p N_GND_c_16970_n ) capacitor c=0.00352472f \
 //x=68.64 //y=1.4 //x2=68.905 //y2=1.145
cc_5114 ( N_noxref_13_c_5913_p N_GND_c_16970_n ) capacitor c=3.86356e-19 \
 //x=68.64 //y=1.71 //x2=68.905 //y2=1.145
cc_5115 ( N_noxref_13_c_6024_p N_GND_c_16970_n ) capacitor c=9.36995e-19 \
 //x=69.015 //y=0.9 //x2=68.905 //y2=1.145
cc_5116 ( N_noxref_13_c_6044_p N_GND_c_16970_n ) capacitor c=5.29132e-19 \
 //x=69.015 //y=1.555 //x2=68.905 //y2=1.145
cc_5117 ( N_noxref_13_c_5912_p N_GND_c_16970_n ) capacitor c=0.0017438f \
 //x=69.17 //y=1.055 //x2=68.905 //y2=1.145
cc_5118 ( N_noxref_13_c_5914_p N_GND_c_16970_n ) capacitor c=0.00276804f \
 //x=69.17 //y=1.4 //x2=68.905 //y2=1.145
cc_5119 ( N_noxref_13_c_5762_p N_GND_c_16917_n ) capacitor c=6.86343e-19 \
 //x=62.195 //y=1.845 //x2=62.85 //y2=0.175
cc_5120 ( N_noxref_13_c_5745_p N_GND_c_16917_n ) capacitor c=6.00694e-19 \
 //x=62.28 //y=2.945 //x2=62.85 //y2=0.175
cc_5121 ( N_noxref_13_c_5729_p N_GND_c_16982_n ) capacitor c=0.00677932f \
 //x=63.83 //y=1.055 //x2=67.66 //y2=0.175
cc_5122 ( N_noxref_13_c_5910_p N_GND_c_16983_n ) capacitor c=0.00677849f \
 //x=68.64 //y=1.055 //x2=72.47 //y2=0.175
cc_5123 ( N_noxref_13_c_5802_p N_GND_c_16984_n ) capacitor c=0.0045138f \
 //x=61.795 //y=1.76 //x2=63.02 //y2=0.175
cc_5124 ( N_noxref_13_c_5762_p N_GND_c_16984_n ) capacitor c=0.0229887f \
 //x=62.195 //y=1.845 //x2=63.02 //y2=0.175
cc_5125 ( N_noxref_13_c_5699_p N_GND_c_16984_n ) capacitor c=2.00878e-19 \
 //x=62.28 //y=2.625 //x2=63.02 //y2=0.175
cc_5126 ( N_noxref_13_c_5745_p N_GND_c_16984_n ) capacitor c=0.00411109f \
 //x=62.28 //y=2.945 //x2=63.02 //y2=0.175
cc_5127 ( N_noxref_13_c_5708_p N_GND_c_16984_n ) capacitor c=0.00343139f \
 //x=64.13 //y=2.375 //x2=63.02 //y2=0.175
cc_5128 ( N_noxref_13_c_5701_p N_GND_c_16984_n ) capacitor c=0.00401621f \
 //x=64.13 //y=2.625 //x2=63.02 //y2=0.175
cc_5129 ( N_noxref_13_c_5702_p N_GND_c_16984_n ) capacitor c=0.00256181f \
 //x=64.13 //y=2.945 //x2=63.02 //y2=0.175
cc_5130 ( N_noxref_13_c_5749_p N_GND_c_16984_n ) capacitor c=0.0104119f \
 //x=62.28 //y=2.77 //x2=63.02 //y2=0.175
cc_5131 ( N_noxref_13_c_5704_p N_GND_c_16984_n ) capacitor c=0.00527261f \
 //x=64.13 //y=2.77 //x2=63.02 //y2=0.175
cc_5132 ( N_noxref_13_c_5782_p N_GND_c_16984_n ) capacitor c=0.00947774f \
 //x=63.975 //y=2.785 //x2=63.02 //y2=0.175
cc_5133 ( N_noxref_13_c_5707_p N_GND_c_16984_n ) capacitor c=0.0039621f \
 //x=64.13 //y=2.26 //x2=63.02 //y2=0.175
cc_5134 ( N_noxref_13_c_5732_p N_GND_c_16984_n ) capacitor c=0.00170145f \
 //x=63.83 //y=1.71 //x2=63.02 //y2=0.175
cc_5135 ( N_noxref_13_c_5710_p N_GND_c_16984_n ) capacitor c=0.0102191f \
 //x=63.83 //y=2.095 //x2=63.02 //y2=0.175
cc_5136 ( N_noxref_13_c_5763_p N_GND_c_16997_n ) capacitor c=0.00343139f \
 //x=68.94 //y=2.375 //x2=67.83 //y2=0.175
cc_5137 ( N_noxref_13_c_5764_p N_GND_c_16997_n ) capacitor c=0.00401621f \
 //x=68.94 //y=2.625 //x2=67.83 //y2=0.175
cc_5138 ( N_noxref_13_c_5765_p N_GND_c_16997_n ) capacitor c=0.0030172f \
 //x=68.94 //y=2.945 //x2=67.83 //y2=0.175
cc_5139 ( N_noxref_13_c_5695_p N_GND_c_16997_n ) capacitor c=0.00528783f \
 //x=68.94 //y=2.77 //x2=67.83 //y2=0.175
cc_5140 ( N_noxref_13_c_5706_p N_GND_c_16997_n ) capacitor c=0.0118327f \
 //x=68.78 //y=2.785 //x2=67.83 //y2=0.175
cc_5141 ( N_noxref_13_c_5845_p N_GND_c_16997_n ) capacitor c=0.0039621f \
 //x=68.94 //y=2.26 //x2=67.83 //y2=0.175
cc_5142 ( N_noxref_13_c_5913_p N_GND_c_16997_n ) capacitor c=0.00170145f \
 //x=68.64 //y=1.71 //x2=67.83 //y2=0.175
cc_5143 ( N_noxref_13_c_5847_p N_GND_c_16997_n ) capacitor c=0.0102191f \
 //x=68.64 //y=2.095 //x2=67.83 //y2=0.175
cc_5144 ( N_noxref_13_c_5708_p N_GND_M39_noxref_d ) capacitor c=4.4417e-19 \
 //x=64.13 //y=2.375 //x2=63.905 //y2=1.055
cc_5145 ( N_noxref_13_c_5729_p N_GND_M39_noxref_d ) capacitor c=0.00184354f \
 //x=63.83 //y=1.055 //x2=63.905 //y2=1.055
cc_5146 ( N_noxref_13_c_5730_p N_GND_M39_noxref_d ) capacitor c=0.00210798f \
 //x=63.83 //y=1.4 //x2=63.905 //y2=1.055
cc_5147 ( N_noxref_13_c_6021_p N_GND_M39_noxref_d ) capacitor c=0.00474029f \
 //x=64.205 //y=0.9 //x2=63.905 //y2=1.055
cc_5148 ( N_noxref_13_c_6034_p N_GND_M39_noxref_d ) capacitor c=0.00166857f \
 //x=64.205 //y=1.555 //x2=63.905 //y2=1.055
cc_5149 ( N_noxref_13_c_5731_p N_GND_M39_noxref_d ) capacitor c=0.00230174f \
 //x=64.36 //y=1.055 //x2=63.905 //y2=1.055
cc_5150 ( N_noxref_13_c_5733_p N_GND_M39_noxref_d ) capacitor c=0.00210798f \
 //x=64.36 //y=1.4 //x2=63.905 //y2=1.055
cc_5151 ( N_noxref_13_c_5763_p N_GND_M42_noxref_d ) capacitor c=4.4417e-19 \
 //x=68.94 //y=2.375 //x2=68.715 //y2=1.055
cc_5152 ( N_noxref_13_c_5910_p N_GND_M42_noxref_d ) capacitor c=0.00184354f \
 //x=68.64 //y=1.055 //x2=68.715 //y2=1.055
cc_5153 ( N_noxref_13_c_5911_p N_GND_M42_noxref_d ) capacitor c=0.00210798f \
 //x=68.64 //y=1.4 //x2=68.715 //y2=1.055
cc_5154 ( N_noxref_13_c_6024_p N_GND_M42_noxref_d ) capacitor c=0.00474029f \
 //x=69.015 //y=0.9 //x2=68.715 //y2=1.055
cc_5155 ( N_noxref_13_c_6044_p N_GND_M42_noxref_d ) capacitor c=0.00166857f \
 //x=69.015 //y=1.555 //x2=68.715 //y2=1.055
cc_5156 ( N_noxref_13_c_5912_p N_GND_M42_noxref_d ) capacitor c=0.00230174f \
 //x=69.17 //y=1.055 //x2=68.715 //y2=1.055
cc_5157 ( N_noxref_13_c_5914_p N_GND_M42_noxref_d ) capacitor c=0.00210798f \
 //x=69.17 //y=1.4 //x2=68.715 //y2=1.055
cc_5158 ( N_noxref_13_c_5710_p N_noxref_60_c_18884_n ) capacitor c=0.00262672f \
 //x=63.83 //y=2.095 //x2=63.61 //y2=1.685
cc_5159 ( N_noxref_13_c_5708_p N_noxref_60_c_18885_n ) capacitor c=0.00428451f \
 //x=64.13 //y=2.375 //x2=64.495 //y2=1.77
cc_5160 ( N_noxref_13_c_5702_p N_noxref_60_c_18885_n ) capacitor c=0.00361907f \
 //x=64.13 //y=2.945 //x2=64.495 //y2=1.77
cc_5161 ( N_noxref_13_c_5707_p N_noxref_60_c_18885_n ) capacitor c=0.0104666f \
 //x=64.13 //y=2.26 //x2=64.495 //y2=1.77
cc_5162 ( N_noxref_13_c_5732_p N_noxref_60_c_18885_n ) capacitor c=0.00705077f \
 //x=63.83 //y=1.71 //x2=64.495 //y2=1.77
cc_5163 ( N_noxref_13_c_5710_p N_noxref_60_c_18885_n ) capacitor c=0.0204935f \
 //x=63.83 //y=2.095 //x2=64.495 //y2=1.77
cc_5164 ( N_noxref_13_c_6034_p N_noxref_60_c_18885_n ) capacitor c=0.00588627f \
 //x=64.205 //y=1.555 //x2=64.495 //y2=1.77
cc_5165 ( N_noxref_13_c_5733_p N_noxref_60_c_18885_n ) capacitor c=0.00698822f \
 //x=64.36 //y=1.4 //x2=64.495 //y2=1.77
cc_5166 ( N_noxref_13_c_5729_p N_noxref_60_M39_noxref_s ) capacitor \
 c=0.0295256f //x=63.83 //y=1.055 //x2=63.475 //y2=0.555
cc_5167 ( N_noxref_13_c_5732_p N_noxref_60_M39_noxref_s ) capacitor \
 c=7.99997e-19 //x=63.83 //y=1.71 //x2=63.475 //y2=0.555
cc_5168 ( N_noxref_13_c_5710_p N_noxref_60_M39_noxref_s ) capacitor \
 c=0.00122123f //x=63.83 //y=2.095 //x2=63.475 //y2=0.555
cc_5169 ( N_noxref_13_c_5731_p N_noxref_60_M39_noxref_s ) capacitor \
 c=0.0125924f //x=64.36 //y=1.055 //x2=63.475 //y2=0.555
cc_5170 ( N_noxref_13_c_5847_p N_noxref_61_c_18941_n ) capacitor c=0.00262672f \
 //x=68.64 //y=2.095 //x2=68.42 //y2=1.685
cc_5171 ( N_noxref_13_c_5763_p N_noxref_61_c_18942_n ) capacitor c=0.00428451f \
 //x=68.94 //y=2.375 //x2=69.305 //y2=1.77
cc_5172 ( N_noxref_13_c_5765_p N_noxref_61_c_18942_n ) capacitor c=0.00447635f \
 //x=68.94 //y=2.945 //x2=69.305 //y2=1.77
cc_5173 ( N_noxref_13_c_5845_p N_noxref_61_c_18942_n ) capacitor c=0.0104666f \
 //x=68.94 //y=2.26 //x2=69.305 //y2=1.77
cc_5174 ( N_noxref_13_c_5913_p N_noxref_61_c_18942_n ) capacitor c=0.00705077f \
 //x=68.64 //y=1.71 //x2=69.305 //y2=1.77
cc_5175 ( N_noxref_13_c_5847_p N_noxref_61_c_18942_n ) capacitor c=0.0197834f \
 //x=68.64 //y=2.095 //x2=69.305 //y2=1.77
cc_5176 ( N_noxref_13_c_6044_p N_noxref_61_c_18942_n ) capacitor c=0.00588627f \
 //x=69.015 //y=1.555 //x2=69.305 //y2=1.77
cc_5177 ( N_noxref_13_c_5914_p N_noxref_61_c_18942_n ) capacitor c=0.00698822f \
 //x=69.17 //y=1.4 //x2=69.305 //y2=1.77
cc_5178 ( N_noxref_13_c_5910_p N_noxref_61_M42_noxref_s ) capacitor \
 c=0.0295256f //x=68.64 //y=1.055 //x2=68.285 //y2=0.555
cc_5179 ( N_noxref_13_c_5913_p N_noxref_61_M42_noxref_s ) capacitor \
 c=7.99997e-19 //x=68.64 //y=1.71 //x2=68.285 //y2=0.555
cc_5180 ( N_noxref_13_c_5847_p N_noxref_61_M42_noxref_s ) capacitor \
 c=0.00122123f //x=68.64 //y=2.095 //x2=68.285 //y2=0.555
cc_5181 ( N_noxref_13_c_5912_p N_noxref_61_M42_noxref_s ) capacitor \
 c=0.0125924f //x=69.17 //y=1.055 //x2=68.285 //y2=0.555
cc_5182 ( N_noxref_14_c_6128_p CLK ) capacitor c=3.32566e-19 //x=71.9 //y=2.61 \
 //x2=74.86 //y2=2.77
cc_5183 ( N_noxref_14_c_6111_n CLK ) capacitor c=0.00102114f //x=71.9 //y=5.25 \
 //x2=74.86 //y2=2.77
cc_5184 ( N_noxref_14_c_6130_p CLK ) capacitor c=0.00460058f //x=73.75 \
 //y=2.61 //x2=74.86 //y2=2.77
cc_5185 ( N_noxref_14_c_6131_p CLK ) capacitor c=0.00787446f //x=73.75 \
 //y=2.93 //x2=74.86 //y2=2.77
cc_5186 ( N_noxref_14_c_6113_n CLK ) capacitor c=0.0399793f //x=73.75 \
 //y=4.755 //x2=74.86 //y2=2.77
cc_5187 ( N_noxref_14_c_6133_p CLK ) capacitor c=2.90818e-19 //x=73.75 \
 //y=2.77 //x2=74.86 //y2=2.77
cc_5188 ( N_noxref_14_c_6134_p CLK ) capacitor c=0.00512134f //x=73.76 \
 //y=2.77 //x2=74.86 //y2=2.77
cc_5189 ( N_noxref_14_c_6135_p CLK ) capacitor c=3.9149e-19 //x=73.75 //y=2.26 \
 //x2=74.86 //y2=2.77
cc_5190 ( N_noxref_14_c_6136_p N_CLK_c_6903_n ) capacitor c=0.00898333f \
 //x=73.75 //y=2.375 //x2=74.86 //y2=2.375
cc_5191 ( N_noxref_14_c_6135_p N_CLK_c_6903_n ) capacitor c=5.40058e-19 \
 //x=73.75 //y=2.26 //x2=74.86 //y2=2.375
cc_5192 ( N_noxref_14_c_6138_p N_CLK_c_6903_n ) capacitor c=0.00142893f \
 //x=73.45 //y=2.095 //x2=74.86 //y2=2.375
cc_5193 ( N_noxref_14_c_6113_n N_CLK_c_6601_n ) capacitor c=0.00761355f \
 //x=73.75 //y=4.755 //x2=74.865 //y2=4.835
cc_5194 ( N_noxref_14_c_6140_p N_CLK_c_6601_n ) capacitor c=6.25125e-19 \
 //x=73.75 //y=4.88 //x2=74.865 //y2=4.835
cc_5195 ( N_noxref_14_c_6118_n N_CLK_c_6601_n ) capacitor c=7.07965e-19 \
 //x=74.315 //y=4.97 //x2=74.865 //y2=4.835
cc_5196 ( N_noxref_14_c_6119_n N_CLK_c_6601_n ) capacitor c=8.59438e-19 \
 //x=74.025 //y=4.97 //x2=74.865 //y2=4.835
cc_5197 ( N_noxref_14_c_6111_n N_CLK_c_6627_n ) capacitor c=0.0233664f \
 //x=71.9 //y=5.25 //x2=74.705 //y2=4.62
cc_5198 ( N_noxref_14_c_6113_n N_CLK_c_6627_n ) capacitor c=0.0275338f \
 //x=73.75 //y=4.755 //x2=74.705 //y2=4.62
cc_5199 ( N_noxref_14_c_6113_n N_CLK_c_6633_n ) capacitor c=0.00449034f \
 //x=73.75 //y=4.755 //x2=74.865 //y2=4.62
cc_5200 ( N_noxref_14_c_6136_p N_CLK_c_6913_n ) capacitor c=5.39999e-19 \
 //x=73.75 //y=2.375 //x2=74.86 //y2=2.26
cc_5201 ( N_noxref_14_c_6130_p N_CLK_c_6913_n ) capacitor c=3.9149e-19 \
 //x=73.75 //y=2.61 //x2=74.86 //y2=2.26
cc_5202 ( N_noxref_14_c_6135_p N_CLK_c_6913_n ) capacitor c=0.00125213f \
 //x=73.75 //y=2.26 //x2=74.86 //y2=2.26
cc_5203 ( N_noxref_14_c_6138_p N_CLK_c_6913_n ) capacitor c=0.00214573f \
 //x=73.45 //y=2.095 //x2=74.86 //y2=2.26
cc_5204 ( N_noxref_14_c_6113_n N_CLK_c_6917_n ) capacitor c=4.24307e-19 \
 //x=73.75 //y=4.755 //x2=74.86 //y2=4.88
cc_5205 ( N_noxref_14_c_6140_p N_CLK_c_6917_n ) capacitor c=0.00113671f \
 //x=73.75 //y=4.88 //x2=74.86 //y2=4.88
cc_5206 ( N_noxref_14_c_6118_n N_CLK_c_6917_n ) capacitor c=0.00116563f \
 //x=74.315 //y=4.97 //x2=74.86 //y2=4.88
cc_5207 ( N_noxref_14_c_6119_n N_CLK_c_6917_n ) capacitor c=0.0012974f \
 //x=74.025 //y=4.97 //x2=74.86 //y2=4.88
cc_5208 ( N_noxref_14_M151_noxref_g N_CLK_M153_noxref_g ) capacitor \
 c=0.0106276f //x=73.95 //y=6.2 //x2=74.83 //y2=6.2
cc_5209 ( N_noxref_14_M152_noxref_g N_CLK_M153_noxref_g ) capacitor \
 c=0.107144f //x=74.39 //y=6.2 //x2=74.83 //y2=6.2
cc_5210 ( N_noxref_14_M152_noxref_g N_CLK_M154_noxref_g ) capacitor \
 c=0.0101598f //x=74.39 //y=6.2 //x2=75.27 //y2=6.2
cc_5211 ( N_noxref_14_c_6157_p N_CLK_c_6924_n ) capacitor c=5.72528e-19 \
 //x=73.45 //y=1.055 //x2=74.425 //y2=1.09
cc_5212 ( N_noxref_14_c_6158_p N_CLK_c_6924_n ) capacitor c=0.00150277f \
 //x=73.45 //y=1.4 //x2=74.425 //y2=1.09
cc_5213 ( N_noxref_14_c_6159_p N_CLK_c_6924_n ) capacitor c=0.0160123f \
 //x=73.98 //y=1.055 //x2=74.425 //y2=1.09
cc_5214 ( N_noxref_14_c_6160_p N_CLK_c_6927_n ) capacitor c=0.00111227f \
 //x=73.45 //y=1.71 //x2=74.425 //y2=1.4
cc_5215 ( N_noxref_14_c_6161_p N_CLK_c_6927_n ) capacitor c=0.0124075f \
 //x=73.98 //y=1.4 //x2=74.425 //y2=1.4
cc_5216 ( N_noxref_14_c_6159_p N_CLK_c_6929_n ) capacitor c=9.19165e-19 \
 //x=73.98 //y=1.055 //x2=74.95 //y2=1.09
cc_5217 ( N_noxref_14_c_6161_p N_CLK_c_6930_n ) capacitor c=0.0010154f \
 //x=73.98 //y=1.4 //x2=74.95 //y2=1.4
cc_5218 ( N_noxref_14_c_6161_p N_CLK_c_6931_n ) capacitor c=9.23422e-19 \
 //x=73.98 //y=1.4 //x2=74.95 //y2=1.63
cc_5219 ( N_noxref_14_c_6136_p N_CLK_c_6932_n ) capacitor c=0.0013537f \
 //x=73.75 //y=2.375 //x2=74.95 //y2=2.095
cc_5220 ( N_noxref_14_c_6135_p N_CLK_c_6932_n ) capacitor c=0.0020754f \
 //x=73.75 //y=2.26 //x2=74.95 //y2=2.095
cc_5221 ( N_noxref_14_c_6138_p N_CLK_c_6932_n ) capacitor c=0.00964411f \
 //x=73.45 //y=2.095 //x2=74.95 //y2=2.095
cc_5222 ( N_noxref_14_c_6140_p N_CLK_c_6935_n ) capacitor c=0.00123917f \
 //x=73.75 //y=4.88 //x2=74.86 //y2=4.88
cc_5223 ( N_noxref_14_c_6118_n N_CLK_c_6935_n ) capacitor c=0.0169508f \
 //x=74.315 //y=4.97 //x2=74.86 //y2=4.88
cc_5224 ( N_noxref_14_c_6119_n N_CLK_c_6935_n ) capacitor c=0.00406071f \
 //x=74.025 //y=4.97 //x2=74.86 //y2=4.88
cc_5225 ( N_noxref_14_c_6114_n N_noxref_16_c_7468_n ) capacitor c=6.09703e-19 \
 //x=69.362 //y=5.335 //x2=66.31 //y2=5.56
cc_5226 ( N_noxref_14_c_6114_n N_noxref_16_c_7469_n ) capacitor c=0.00306432f \
 //x=69.362 //y=5.335 //x2=67.005 //y2=5.335
cc_5227 ( N_noxref_14_c_6173_p N_noxref_16_c_7470_n ) capacitor c=0.00163399f \
 //x=71.5 //y=1.845 //x2=67.005 //y2=1.845
cc_5228 ( N_noxref_14_c_6111_n N_noxref_16_c_7422_n ) capacitor c=0.0232184f \
 //x=71.9 //y=5.25 //x2=78.395 //y2=3.51
cc_5229 ( N_noxref_14_c_6113_n N_noxref_16_c_7422_n ) capacitor c=0.0246617f \
 //x=73.75 //y=4.755 //x2=78.395 //y2=3.51
cc_5230 ( N_noxref_14_c_6176_p N_noxref_16_c_7422_n ) capacitor c=0.008565f \
 //x=73.6 //y=2.77 //x2=78.395 //y2=3.51
cc_5231 ( N_noxref_14_c_6113_n RN ) capacitor c=0.00134588f //x=73.75 \
 //y=4.755 //x2=75.97 //y2=2.77
cc_5232 ( N_noxref_14_c_6128_p N_RN_c_8611_n ) capacitor c=0.0272405f //x=71.9 \
 //y=2.61 //x2=72.115 //y2=2.385
cc_5233 ( N_noxref_14_c_6179_p N_RN_c_8611_n ) capacitor c=0.00570792f \
 //x=71.9 //y=2.93 //x2=72.115 //y2=2.385
cc_5234 ( N_noxref_14_c_6176_p N_RN_c_8611_n ) capacitor c=0.133465f //x=73.6 \
 //y=2.77 //x2=72.115 //y2=2.385
cc_5235 ( N_noxref_14_c_6181_p N_RN_c_8611_n ) capacitor c=0.0365231f \
 //x=72.06 //y=2.77 //x2=72.115 //y2=2.385
cc_5236 ( N_noxref_14_c_6182_p N_RN_c_8353_n ) capacitor c=7.09906e-19 \
 //x=71.415 //y=1.305 //x2=71.685 //y2=2.385
cc_5237 ( N_noxref_14_c_6183_p N_RN_c_8353_n ) capacitor c=0.00861999f \
 //x=71.815 //y=1.845 //x2=71.685 //y2=2.385
cc_5238 ( N_noxref_14_c_6173_p N_RN_c_8353_n ) capacitor c=0.0125921f //x=71.5 \
 //y=1.845 //x2=71.685 //y2=2.385
cc_5239 ( N_noxref_14_c_6128_p N_RN_c_8353_n ) capacitor c=3.12067e-19 \
 //x=71.9 //y=2.61 //x2=71.685 //y2=2.385
cc_5240 ( N_noxref_14_c_6130_p N_RN_c_8619_n ) capacitor c=5.11045e-19 \
 //x=73.75 //y=2.61 //x2=73.375 //y2=2.4
cc_5241 ( N_noxref_14_c_6131_p N_RN_c_8619_n ) capacitor c=0.00348052f \
 //x=73.75 //y=2.93 //x2=73.375 //y2=2.4
cc_5242 ( N_noxref_14_c_6176_p N_RN_c_8619_n ) capacitor c=0.0109101f //x=73.6 \
 //y=2.77 //x2=73.375 //y2=2.4
cc_5243 ( N_noxref_14_c_6136_p N_RN_c_8622_n ) capacitor c=0.0168589f \
 //x=73.75 //y=2.375 //x2=73.975 //y2=2.385
cc_5244 ( N_noxref_14_c_6130_p N_RN_c_8622_n ) capacitor c=0.012163f //x=73.75 \
 //y=2.61 //x2=73.975 //y2=2.385
cc_5245 ( N_noxref_14_c_6131_p N_RN_c_8622_n ) capacitor c=0.00478203f \
 //x=73.75 //y=2.93 //x2=73.975 //y2=2.385
cc_5246 ( N_noxref_14_c_6134_p N_RN_c_8622_n ) capacitor c=0.0370412f \
 //x=73.76 //y=2.77 //x2=73.975 //y2=2.385
cc_5247 ( N_noxref_14_c_6135_p N_RN_c_8622_n ) capacitor c=5.18204e-19 \
 //x=73.75 //y=2.26 //x2=73.975 //y2=2.385
cc_5248 ( N_noxref_14_c_6138_p N_RN_c_8622_n ) capacitor c=3.41298e-19 \
 //x=73.45 //y=2.095 //x2=73.975 //y2=2.385
cc_5249 ( N_noxref_14_c_6130_p N_RN_c_8628_n ) capacitor c=3.71593e-19 \
 //x=73.75 //y=2.61 //x2=76.135 //y2=2.4
cc_5250 ( N_noxref_14_c_6128_p SN ) capacitor c=3.42202e-19 //x=71.9 //y=2.61 \
 //x2=70.05 //y2=2.77
cc_5251 ( N_noxref_14_c_6120_n N_SN_c_10397_n ) capacitor c=4.55325e-19 \
 //x=70.12 //y=5.335 //x2=70.05 //y2=3.285
cc_5252 ( N_noxref_14_c_6198_p N_SN_c_10397_n ) capacitor c=0.0013539f \
 //x=70.24 //y=5.335 //x2=70.05 //y2=3.285
cc_5253 ( N_noxref_14_c_6199_p N_SN_c_10397_n ) capacitor c=4.8336e-19 \
 //x=70.24 //y=5.56 //x2=70.05 //y2=3.285
cc_5254 ( N_noxref_14_c_6120_n N_SN_c_10070_n ) capacitor c=0.0178828f \
 //x=70.12 //y=5.335 //x2=70.05 //y2=4.765
cc_5255 ( N_noxref_14_c_6111_n N_SN_c_10070_n ) capacitor c=0.00188783f \
 //x=71.9 //y=5.25 //x2=70.05 //y2=4.765
cc_5256 ( N_noxref_14_c_6198_p N_SN_c_10070_n ) capacitor c=0.00209649f \
 //x=70.24 //y=5.335 //x2=70.05 //y2=4.765
cc_5257 ( N_noxref_14_c_6199_p N_SN_c_10070_n ) capacitor c=6.21282e-19 \
 //x=70.24 //y=5.56 //x2=70.05 //y2=4.765
cc_5258 ( N_noxref_14_c_6179_p N_SN_c_10461_n ) capacitor c=0.0102778f \
 //x=71.9 //y=2.93 //x2=72.115 //y2=3.155
cc_5259 ( N_noxref_14_c_6111_n N_SN_c_10461_n ) capacitor c=0.0226563f \
 //x=71.9 //y=5.25 //x2=72.115 //y2=3.155
cc_5260 ( N_noxref_14_c_6176_p N_SN_c_10461_n ) capacitor c=0.128848f //x=73.6 \
 //y=2.77 //x2=72.115 //y2=3.155
cc_5261 ( N_noxref_14_c_6179_p N_SN_c_10426_n ) capacitor c=0.00153128f \
 //x=71.9 //y=2.93 //x2=71.77 //y2=3.155
cc_5262 ( N_noxref_14_c_6111_n N_SN_c_10426_n ) capacitor c=3.10774e-19 \
 //x=71.9 //y=5.25 //x2=71.77 //y2=3.155
cc_5263 ( N_noxref_14_c_6181_p N_SN_c_10426_n ) capacitor c=0.0358254f \
 //x=72.06 //y=2.77 //x2=71.77 //y2=3.155
cc_5264 ( N_noxref_14_c_6131_p N_SN_c_10467_n ) capacitor c=0.00511674f \
 //x=73.75 //y=2.93 //x2=73.375 //y2=3.14
cc_5265 ( N_noxref_14_c_6113_n N_SN_c_10467_n ) capacitor c=5.11045e-19 \
 //x=73.75 //y=4.755 //x2=73.375 //y2=3.14
cc_5266 ( N_noxref_14_c_6176_p N_SN_c_10467_n ) capacitor c=0.0107306f \
 //x=73.6 //y=2.77 //x2=73.375 //y2=3.14
cc_5267 ( N_noxref_14_c_6134_p N_SN_c_10467_n ) capacitor c=0.0358254f \
 //x=73.76 //y=2.77 //x2=73.375 //y2=3.14
cc_5268 ( N_noxref_14_c_6131_p N_SN_c_10471_n ) capacitor c=0.00397194f \
 //x=73.75 //y=2.93 //x2=73.975 //y2=3.155
cc_5269 ( N_noxref_14_c_6113_n N_SN_c_10471_n ) capacitor c=0.023934f \
 //x=73.75 //y=4.755 //x2=73.975 //y2=3.155
cc_5270 ( N_noxref_14_c_6120_n N_SN_c_10085_n ) capacitor c=0.00492634f \
 //x=70.12 //y=5.335 //x2=70.05 //y2=4.88
cc_5271 ( N_noxref_14_c_6198_p N_SN_c_10085_n ) capacitor c=0.00132214f \
 //x=70.24 //y=5.335 //x2=70.05 //y2=4.88
cc_5272 ( N_noxref_14_c_6120_n N_SN_M147_noxref_g ) capacitor c=0.00858183f \
 //x=70.12 //y=5.335 //x2=70.02 //y2=6.2
cc_5273 ( N_noxref_14_c_6198_p N_SN_M147_noxref_g ) capacitor c=0.00229818f \
 //x=70.24 //y=5.335 //x2=70.02 //y2=6.2
cc_5274 ( N_noxref_14_c_6199_p N_SN_M147_noxref_g ) capacitor c=0.0179041f \
 //x=70.24 //y=5.56 //x2=70.02 //y2=6.2
cc_5275 ( N_noxref_14_c_6221_p N_SN_M148_noxref_g ) capacitor c=0.00875663f \
 //x=71.005 //y=5.335 //x2=70.46 //y2=6.2
cc_5276 ( N_noxref_14_c_6198_p N_SN_M148_noxref_g ) capacitor c=0.00230699f \
 //x=70.24 //y=5.335 //x2=70.46 //y2=6.2
cc_5277 ( N_noxref_14_c_6199_p N_SN_M148_noxref_g ) capacitor c=0.0179041f \
 //x=70.24 //y=5.56 //x2=70.46 //y2=6.2
cc_5278 ( N_noxref_14_c_6198_p N_SN_c_10102_n ) capacitor c=0.00201022f \
 //x=70.24 //y=5.335 //x2=70.385 //y2=4.97
cc_5279 ( N_noxref_14_c_6199_p N_SN_c_10102_n ) capacitor c=0.00290085f \
 //x=70.24 //y=5.56 //x2=70.385 //y2=4.97
cc_5280 ( N_noxref_14_c_6120_n N_SN_c_10449_n ) capacitor c=5.877e-19 \
 //x=70.12 //y=5.335 //x2=70.05 //y2=4.88
cc_5281 ( N_noxref_14_c_6128_p N_noxref_20_c_11082_n ) capacitor c=0.013767f \
 //x=71.9 //y=2.61 //x2=71.16 //y2=2.375
cc_5282 ( N_noxref_14_c_6128_p N_noxref_20_c_11078_n ) capacitor c=0.0086632f \
 //x=71.9 //y=2.61 //x2=71.16 //y2=3.735
cc_5283 ( N_noxref_14_c_6179_p N_noxref_20_c_11078_n ) capacitor c=0.0148501f \
 //x=71.9 //y=2.93 //x2=71.16 //y2=3.735
cc_5284 ( N_noxref_14_c_6111_n N_noxref_20_c_11078_n ) capacitor c=0.0317529f \
 //x=71.9 //y=5.25 //x2=71.16 //y2=3.735
cc_5285 ( N_noxref_14_c_6130_p N_noxref_20_c_11078_n ) capacitor c=4.40369e-19 \
 //x=73.75 //y=2.61 //x2=71.16 //y2=3.735
cc_5286 ( N_noxref_14_c_6113_n N_noxref_20_c_11078_n ) capacitor c=5.12503e-19 \
 //x=73.75 //y=4.755 //x2=71.16 //y2=3.735
cc_5287 ( N_noxref_14_c_6124_n N_noxref_20_c_11078_n ) capacitor c=5.64873e-19 \
 //x=71.9 //y=2.77 //x2=71.16 //y2=3.735
cc_5288 ( N_noxref_14_c_6181_p N_noxref_20_c_11078_n ) capacitor c=0.00687494f \
 //x=72.06 //y=2.77 //x2=71.16 //y2=3.735
cc_5289 ( N_noxref_14_c_6221_p N_noxref_20_c_11090_n ) capacitor c=0.0015317f \
 //x=71.005 //y=5.335 //x2=71.16 //y2=4.055
cc_5290 ( N_noxref_14_c_6110_n N_noxref_20_c_11090_n ) capacitor c=3.5029e-19 \
 //x=71.815 //y=5.335 //x2=71.16 //y2=4.055
cc_5291 ( N_noxref_14_c_6111_n N_noxref_20_c_11090_n ) capacitor c=0.0148932f \
 //x=71.9 //y=5.25 //x2=71.16 //y2=4.055
cc_5292 ( N_noxref_14_c_6110_n N_noxref_20_c_11044_n ) capacitor c=0.00198098f \
 //x=71.815 //y=5.335 //x2=71.16 //y2=4.75
cc_5293 ( N_noxref_14_c_6111_n N_noxref_20_c_11044_n ) capacitor c=0.0389572f \
 //x=71.9 //y=5.25 //x2=71.16 //y2=4.75
cc_5294 ( N_noxref_14_c_6113_n N_noxref_20_c_11044_n ) capacitor c=8.18246e-19 \
 //x=73.75 //y=4.755 //x2=71.16 //y2=4.75
cc_5295 ( N_noxref_14_c_6241_p N_noxref_20_c_11044_n ) capacitor c=0.018645f \
 //x=71.12 //y=5.335 //x2=71.16 //y2=4.75
cc_5296 ( N_noxref_14_c_6242_p N_noxref_20_c_11044_n ) capacitor c=0.00217979f \
 //x=71.12 //y=5.56 //x2=71.16 //y2=4.75
cc_5297 ( N_noxref_14_M152_noxref_g N_noxref_20_c_11045_n ) capacitor \
 c=0.00889148f //x=74.39 //y=6.2 //x2=74.93 //y2=5.335
cc_5298 ( N_noxref_14_c_6183_p N_noxref_20_c_11099_n ) capacitor c=0.00163399f \
 //x=71.815 //y=1.845 //x2=76.31 //y2=1.845
cc_5299 ( N_noxref_14_c_6111_n N_noxref_20_c_11100_n ) capacitor c=9.19401e-19 \
 //x=71.9 //y=5.25 //x2=71.16 //y2=3.88
cc_5300 ( N_noxref_14_c_6246_p N_noxref_20_c_11057_n ) capacitor c=6.09703e-19 \
 //x=71.12 //y=5.56 //x2=74.172 //y2=5.335
cc_5301 ( N_noxref_14_c_6110_n N_noxref_20_c_11057_n ) capacitor c=0.0030117f \
 //x=71.815 //y=5.335 //x2=74.172 //y2=5.335
cc_5302 ( N_noxref_14_M151_noxref_g N_noxref_20_c_11057_n ) capacitor \
 c=0.00461408f //x=73.95 //y=6.2 //x2=74.172 //y2=5.335
cc_5303 ( N_noxref_14_M152_noxref_g N_noxref_20_c_11057_n ) capacitor \
 c=0.00229208f //x=74.39 //y=6.2 //x2=74.172 //y2=5.335
cc_5304 ( N_noxref_14_c_6118_n N_noxref_20_c_11057_n ) capacitor c=0.00174996f \
 //x=74.315 //y=4.97 //x2=74.172 //y2=5.335
cc_5305 ( N_noxref_14_c_6111_n N_noxref_20_c_11060_n ) capacitor c=0.0229483f \
 //x=71.9 //y=5.25 //x2=76.54 //y2=3.88
cc_5306 ( N_noxref_14_c_6113_n N_noxref_20_c_11060_n ) capacitor c=0.024803f \
 //x=73.75 //y=4.755 //x2=76.54 //y2=3.88
cc_5307 ( N_noxref_14_c_6111_n N_noxref_20_c_11108_n ) capacitor c=0.00336755f \
 //x=71.9 //y=5.25 //x2=71.32 //y2=3.895
cc_5308 ( N_noxref_14_c_6128_p N_noxref_20_c_11109_n ) capacitor c=0.0015536f \
 //x=71.9 //y=2.61 //x2=71.16 //y2=2.26
cc_5309 ( N_noxref_14_c_6110_n N_noxref_20_c_11110_n ) capacitor c=0.00130631f \
 //x=71.815 //y=5.335 //x2=71.16 //y2=4.88
cc_5310 ( N_noxref_14_c_6111_n N_noxref_20_c_11110_n ) capacitor c=0.00126408f \
 //x=71.9 //y=5.25 //x2=71.16 //y2=4.88
cc_5311 ( N_noxref_14_c_6241_p N_noxref_20_c_11110_n ) capacitor c=0.00346456f \
 //x=71.12 //y=5.335 //x2=71.16 //y2=4.88
cc_5312 ( N_noxref_14_c_6242_p N_noxref_20_c_11110_n ) capacitor c=0.00624059f \
 //x=71.12 //y=5.56 //x2=71.16 //y2=4.88
cc_5313 ( N_noxref_14_M151_noxref_g N_noxref_20_c_11114_n ) capacitor \
 c=0.0162284f //x=73.95 //y=6.2 //x2=74.17 //y2=5.56
cc_5314 ( N_noxref_14_M152_noxref_g N_noxref_20_c_11114_n ) capacitor \
 c=0.0179041f //x=74.39 //y=6.2 //x2=74.17 //y2=5.56
cc_5315 ( N_noxref_14_c_6118_n N_noxref_20_c_11114_n ) capacitor c=0.00291477f \
 //x=74.315 //y=4.97 //x2=74.17 //y2=5.56
cc_5316 ( N_noxref_14_c_6221_p N_noxref_20_M149_noxref_g ) capacitor \
 c=0.00895456f //x=71.005 //y=5.335 //x2=70.9 //y2=6.2
cc_5317 ( N_noxref_14_c_6246_p N_noxref_20_M149_noxref_g ) capacitor \
 c=0.00226521f //x=71.12 //y=5.56 //x2=70.9 //y2=6.2
cc_5318 ( N_noxref_14_c_6242_p N_noxref_20_M149_noxref_g ) capacitor \
 c=0.0178885f //x=71.12 //y=5.56 //x2=70.9 //y2=6.2
cc_5319 ( N_noxref_14_c_6246_p N_noxref_20_M150_noxref_g ) capacitor \
 c=0.00381703f //x=71.12 //y=5.56 //x2=71.34 //y2=6.2
cc_5320 ( N_noxref_14_c_6110_n N_noxref_20_M150_noxref_g ) capacitor \
 c=0.0103821f //x=71.815 //y=5.335 //x2=71.34 //y2=6.2
cc_5321 ( N_noxref_14_c_6242_p N_noxref_20_M150_noxref_g ) capacitor \
 c=0.0188608f //x=71.12 //y=5.56 //x2=71.34 //y2=6.2
cc_5322 ( N_noxref_14_c_6182_p N_noxref_20_c_11123_n ) capacitor c=4.64015e-19 \
 //x=71.415 //y=1.305 //x2=71.15 //y2=1.095
cc_5323 ( N_noxref_14_M44_noxref_d N_noxref_20_c_11123_n ) capacitor \
 c=0.00137165f //x=71.225 //y=1.095 //x2=71.15 //y2=1.095
cc_5324 ( N_noxref_14_c_6182_p N_noxref_20_c_11125_n ) capacitor c=0.0026012f \
 //x=71.415 //y=1.305 //x2=71.15 //y2=1.44
cc_5325 ( N_noxref_14_c_6271_p N_noxref_20_c_11125_n ) capacitor c=0.00127432f \
 //x=71.415 //y=1.76 //x2=71.15 //y2=1.44
cc_5326 ( N_noxref_14_M44_noxref_d N_noxref_20_c_11125_n ) capacitor \
 c=0.00237422f //x=71.225 //y=1.095 //x2=71.15 //y2=1.44
cc_5327 ( N_noxref_14_c_6271_p N_noxref_20_c_11128_n ) capacitor c=0.00429966f \
 //x=71.415 //y=1.76 //x2=71.15 //y2=1.75
cc_5328 ( N_noxref_14_c_6182_p N_noxref_20_c_11129_n ) capacitor c=5.29969e-19 \
 //x=71.415 //y=1.305 //x2=71.525 //y2=0.94
cc_5329 ( N_noxref_14_M44_noxref_d N_noxref_20_c_11129_n ) capacitor \
 c=0.0020782f //x=71.225 //y=1.095 //x2=71.525 //y2=0.94
cc_5330 ( N_noxref_14_c_6182_p N_noxref_20_c_11131_n ) capacitor c=5.32228e-19 \
 //x=71.415 //y=1.305 //x2=71.525 //y2=1.595
cc_5331 ( N_noxref_14_c_6271_p N_noxref_20_c_11131_n ) capacitor c=0.00942306f \
 //x=71.415 //y=1.76 //x2=71.525 //y2=1.595
cc_5332 ( N_noxref_14_c_6183_p N_noxref_20_c_11131_n ) capacitor c=0.00194716f \
 //x=71.815 //y=1.845 //x2=71.525 //y2=1.595
cc_5333 ( N_noxref_14_M44_noxref_d N_noxref_20_c_11131_n ) capacitor \
 c=0.00356097f //x=71.225 //y=1.095 //x2=71.525 //y2=1.595
cc_5334 ( N_noxref_14_c_6182_p N_noxref_20_c_11135_n ) capacitor c=5.24634e-19 \
 //x=71.415 //y=1.305 //x2=71.68 //y2=1.095
cc_5335 ( N_noxref_14_M44_noxref_d N_noxref_20_c_11135_n ) capacitor \
 c=0.00139206f //x=71.225 //y=1.095 //x2=71.68 //y2=1.095
cc_5336 ( N_noxref_14_c_6182_p N_noxref_20_c_11137_n ) capacitor c=0.00307978f \
 //x=71.415 //y=1.305 //x2=71.68 //y2=1.44
cc_5337 ( N_noxref_14_c_6271_p N_noxref_20_c_11137_n ) capacitor c=0.00363411f \
 //x=71.415 //y=1.76 //x2=71.68 //y2=1.44
cc_5338 ( N_noxref_14_c_6183_p N_noxref_20_c_11137_n ) capacitor c=0.00323576f \
 //x=71.815 //y=1.845 //x2=71.68 //y2=1.44
cc_5339 ( N_noxref_14_M44_noxref_d N_noxref_20_c_11137_n ) capacitor \
 c=0.00237422f //x=71.225 //y=1.095 //x2=71.68 //y2=1.44
cc_5340 ( N_noxref_14_c_6128_p N_noxref_20_c_11141_n ) capacitor c=0.00244157f \
 //x=71.9 //y=2.61 //x2=71.16 //y2=2.26
cc_5341 ( N_noxref_14_c_6271_p N_noxref_20_c_11142_n ) capacitor c=0.0036273f \
 //x=71.415 //y=1.76 //x2=71.16 //y2=2.095
cc_5342 ( N_noxref_14_c_6128_p N_noxref_20_c_11142_n ) capacitor c=0.00282067f \
 //x=71.9 //y=2.61 //x2=71.16 //y2=2.095
cc_5343 ( N_noxref_14_c_6111_n N_noxref_20_c_11070_n ) capacitor c=0.00714556f \
 //x=71.9 //y=5.25 //x2=71.16 //y2=4.88
cc_5344 ( N_noxref_14_c_6241_p N_noxref_20_c_11070_n ) capacitor c=0.00203307f \
 //x=71.12 //y=5.335 //x2=71.16 //y2=4.88
cc_5345 ( N_noxref_14_c_6242_p N_noxref_20_c_11070_n ) capacitor c=0.00375636f \
 //x=71.12 //y=5.56 //x2=71.16 //y2=4.88
cc_5346 ( N_noxref_14_c_6111_n N_noxref_22_c_12279_n ) capacitor c=0.00234807f \
 //x=71.9 //y=5.25 //x2=71.375 //y2=4.31
cc_5347 ( N_noxref_14_c_6111_n N_noxref_22_c_12280_n ) capacitor c=0.0224907f \
 //x=71.9 //y=5.25 //x2=76.315 //y2=4.25
cc_5348 ( N_noxref_14_c_6113_n N_noxref_22_c_12280_n ) capacitor c=0.0247757f \
 //x=73.75 //y=4.755 //x2=76.315 //y2=4.25
cc_5349 ( N_noxref_14_c_6120_n N_VDD_c_13434_n ) capacitor c=0.00559514f \
 //x=70.12 //y=5.335 //x2=87.775 //y2=7.585
cc_5350 ( N_noxref_14_c_6221_p N_VDD_c_13434_n ) capacitor c=0.00564834f \
 //x=71.005 //y=5.335 //x2=87.775 //y2=7.585
cc_5351 ( N_noxref_14_c_6246_p N_VDD_c_13434_n ) capacitor c=0.00236065f \
 //x=71.12 //y=5.56 //x2=87.775 //y2=7.585
cc_5352 ( N_noxref_14_c_6110_n N_VDD_c_13434_n ) capacitor c=0.00753358f \
 //x=71.815 //y=5.335 //x2=87.775 //y2=7.585
cc_5353 ( N_noxref_14_c_6114_n N_VDD_c_13434_n ) capacitor c=0.00241373f \
 //x=69.362 //y=5.335 //x2=87.775 //y2=7.585
cc_5354 ( N_noxref_14_c_6198_p N_VDD_c_13434_n ) capacitor c=0.00249074f \
 //x=70.24 //y=5.335 //x2=87.775 //y2=7.585
cc_5355 ( N_noxref_14_c_6125_n N_VDD_c_13434_n ) capacitor c=0.0024232f \
 //x=69.36 //y=5.56 //x2=87.775 //y2=7.585
cc_5356 ( N_noxref_14_c_6199_p N_VDD_c_13434_n ) capacitor c=0.0024232f \
 //x=70.24 //y=5.56 //x2=87.775 //y2=7.585
cc_5357 ( N_noxref_14_c_6242_p N_VDD_c_13434_n ) capacitor c=0.0024232f \
 //x=71.12 //y=5.56 //x2=87.775 //y2=7.585
cc_5358 ( N_noxref_14_c_6120_n N_VDD_c_14198_n ) capacitor c=0.00202922f \
 //x=70.12 //y=5.335 //x2=69.715 //y2=7.585
cc_5359 ( N_noxref_14_c_6114_n N_VDD_c_14198_n ) capacitor c=9.3757e-19 \
 //x=69.362 //y=5.335 //x2=69.715 //y2=7.585
cc_5360 ( N_noxref_14_c_6125_n N_VDD_c_14198_n ) capacitor c=0.0138074f \
 //x=69.36 //y=5.56 //x2=69.715 //y2=7.585
cc_5361 ( N_noxref_14_c_6120_n N_VDD_c_14249_n ) capacitor c=0.0017708f \
 //x=70.12 //y=5.335 //x2=70.595 //y2=7.585
cc_5362 ( N_noxref_14_c_6221_p N_VDD_c_14249_n ) capacitor c=0.00202922f \
 //x=71.005 //y=5.335 //x2=70.595 //y2=7.585
cc_5363 ( N_noxref_14_c_6198_p N_VDD_c_14249_n ) capacitor c=9.4822e-19 \
 //x=70.24 //y=5.335 //x2=70.595 //y2=7.585
cc_5364 ( N_noxref_14_c_6199_p N_VDD_c_14249_n ) capacitor c=0.0138074f \
 //x=70.24 //y=5.56 //x2=70.595 //y2=7.585
cc_5365 ( N_noxref_14_c_6221_p N_VDD_c_14253_n ) capacitor c=0.00205906f \
 //x=71.005 //y=5.335 //x2=71.475 //y2=7.585
cc_5366 ( N_noxref_14_c_6246_p N_VDD_c_14253_n ) capacitor c=8.49654e-19 \
 //x=71.12 //y=5.56 //x2=71.475 //y2=7.585
cc_5367 ( N_noxref_14_c_6110_n N_VDD_c_14253_n ) capacitor c=0.00204238f \
 //x=71.815 //y=5.335 //x2=71.475 //y2=7.585
cc_5368 ( N_noxref_14_c_6242_p N_VDD_c_14253_n ) capacitor c=0.013249f \
 //x=71.12 //y=5.56 //x2=71.475 //y2=7.585
cc_5369 ( N_noxref_14_c_6110_n N_VDD_c_14257_n ) capacitor c=0.00183742f \
 //x=71.815 //y=5.335 //x2=72.47 //y2=7.585
cc_5370 ( N_noxref_14_M151_noxref_g N_VDD_c_14258_n ) capacitor c=0.00755614f \
 //x=73.95 //y=6.2 //x2=74.525 //y2=7.585
cc_5371 ( N_noxref_14_M152_noxref_g N_VDD_c_14258_n ) capacitor c=0.00755544f \
 //x=74.39 //y=6.2 //x2=74.525 //y2=7.585
cc_5372 ( N_noxref_14_c_6114_n N_VDD_c_13783_n ) capacitor c=0.0022955f \
 //x=69.362 //y=5.335 //x2=67.83 //y2=7.585
cc_5373 ( N_noxref_14_c_6125_n N_VDD_c_13783_n ) capacitor c=0.00509469f \
 //x=69.36 //y=5.56 //x2=67.83 //y2=7.585
cc_5374 ( N_noxref_14_c_6246_p N_VDD_c_13784_n ) capacitor c=0.00282782f \
 //x=71.12 //y=5.56 //x2=72.64 //y2=7.585
cc_5375 ( N_noxref_14_c_6111_n N_VDD_c_13784_n ) capacitor c=0.0317114f \
 //x=71.9 //y=5.25 //x2=72.64 //y2=7.585
cc_5376 ( N_noxref_14_c_6113_n N_VDD_c_13784_n ) capacitor c=0.0108731f \
 //x=73.75 //y=4.755 //x2=72.64 //y2=7.585
cc_5377 ( N_noxref_14_c_6242_p N_VDD_c_13784_n ) capacitor c=0.00777981f \
 //x=71.12 //y=5.56 //x2=72.64 //y2=7.585
cc_5378 ( N_noxref_14_c_6140_p N_VDD_c_13784_n ) capacitor c=0.00354568f \
 //x=73.75 //y=4.88 //x2=72.64 //y2=7.585
cc_5379 ( N_noxref_14_c_6119_n N_VDD_c_13784_n ) capacitor c=0.00572368f \
 //x=74.025 //y=4.97 //x2=72.64 //y2=7.585
cc_5380 ( N_noxref_14_c_6114_n N_VDD_M145_noxref_s ) capacitor c=0.0442713f \
 //x=69.362 //y=5.335 //x2=68.785 //y2=5.2
cc_5381 ( N_noxref_14_c_6198_p N_VDD_M145_noxref_s ) capacitor c=7.80122e-19 \
 //x=70.24 //y=5.335 //x2=68.785 //y2=5.2
cc_5382 ( N_noxref_14_c_6125_n N_VDD_M145_noxref_s ) capacitor c=0.09305f \
 //x=69.36 //y=5.56 //x2=68.785 //y2=5.2
cc_5383 ( N_noxref_14_c_6120_n N_VDD_M146_noxref_d ) capacitor c=0.00700141f \
 //x=70.12 //y=5.335 //x2=69.655 //y2=5.2
cc_5384 ( N_noxref_14_c_6125_n N_VDD_M146_noxref_d ) capacitor c=0.0674491f \
 //x=69.36 //y=5.56 //x2=69.655 //y2=5.2
cc_5385 ( N_noxref_14_c_6199_p N_VDD_M146_noxref_d ) capacitor c=0.0674762f \
 //x=70.24 //y=5.56 //x2=69.655 //y2=5.2
cc_5386 ( N_noxref_14_c_6221_p N_VDD_M148_noxref_d ) capacitor c=0.00700141f \
 //x=71.005 //y=5.335 //x2=70.535 //y2=5.2
cc_5387 ( N_noxref_14_c_6199_p N_VDD_M148_noxref_d ) capacitor c=0.067493f \
 //x=70.24 //y=5.56 //x2=70.535 //y2=5.2
cc_5388 ( N_noxref_14_c_6242_p N_VDD_M148_noxref_d ) capacitor c=0.0674979f \
 //x=71.12 //y=5.56 //x2=70.535 //y2=5.2
cc_5389 ( N_noxref_14_c_6110_n N_VDD_M150_noxref_d ) capacitor c=0.00700141f \
 //x=71.815 //y=5.335 //x2=71.415 //y2=5.2
cc_5390 ( N_noxref_14_c_6242_p N_VDD_M150_noxref_d ) capacitor c=0.0675002f \
 //x=71.12 //y=5.56 //x2=71.415 //y2=5.2
cc_5391 ( N_noxref_14_c_6246_p N_VDD_M151_noxref_s ) capacitor c=0.00492616f \
 //x=71.12 //y=5.56 //x2=73.595 //y2=5.2
cc_5392 ( N_noxref_14_c_6110_n N_VDD_M151_noxref_s ) capacitor c=9.42705e-19 \
 //x=71.815 //y=5.335 //x2=73.595 //y2=5.2
cc_5393 ( N_noxref_14_c_6131_p N_VDD_M151_noxref_s ) capacitor c=4.12751e-19 \
 //x=73.75 //y=2.93 //x2=73.595 //y2=5.2
cc_5394 ( N_noxref_14_c_6113_n N_VDD_M151_noxref_s ) capacitor c=0.0167311f \
 //x=73.75 //y=4.755 //x2=73.595 //y2=5.2
cc_5395 ( N_noxref_14_c_6198_p N_VDD_M151_noxref_s ) capacitor c=2.11884e-19 \
 //x=70.24 //y=5.335 //x2=73.595 //y2=5.2
cc_5396 ( N_noxref_14_c_6140_p N_VDD_M151_noxref_s ) capacitor c=0.00983846f \
 //x=73.75 //y=4.88 //x2=73.595 //y2=5.2
cc_5397 ( N_noxref_14_M151_noxref_g N_VDD_M151_noxref_s ) capacitor \
 c=0.053419f //x=73.95 //y=6.2 //x2=73.595 //y2=5.2
cc_5398 ( N_noxref_14_c_6119_n N_VDD_M151_noxref_s ) capacitor c=0.00608913f \
 //x=74.025 //y=4.97 //x2=73.595 //y2=5.2
cc_5399 ( N_noxref_14_M152_noxref_g N_VDD_M152_noxref_d ) capacitor \
 c=0.015318f //x=74.39 //y=6.2 //x2=74.465 //y2=5.2
cc_5400 ( N_noxref_14_c_6182_p N_noxref_40_c_15826_n ) capacitor c=0.0036878f \
 //x=71.415 //y=1.305 //x2=71.815 //y2=0.72
cc_5401 ( N_noxref_14_c_6183_p N_noxref_40_c_15826_n ) capacitor c=0.00399931f \
 //x=71.815 //y=1.845 //x2=71.815 //y2=0.72
cc_5402 ( N_noxref_14_M44_noxref_d N_noxref_40_c_15826_n ) capacitor \
 c=0.00910163f //x=71.225 //y=1.095 //x2=71.815 //y2=0.72
cc_5403 ( N_noxref_14_M44_noxref_d N_noxref_40_c_15829_n ) capacitor \
 c=0.00120711f //x=71.225 //y=1.095 //x2=70.93 //y2=1.175
cc_5404 ( N_noxref_14_c_6120_n N_noxref_40_M43_noxref_d ) capacitor \
 c=0.00131192f //x=70.12 //y=5.335 //x2=69.69 //y2=1.09
cc_5405 ( N_noxref_14_c_6182_p N_noxref_40_M43_noxref_d ) capacitor \
 c=0.00802417f //x=71.415 //y=1.305 //x2=69.69 //y2=1.09
cc_5406 ( N_noxref_14_c_6182_p N_noxref_40_M44_noxref_s ) capacitor \
 c=0.0098487f //x=71.415 //y=1.305 //x2=70.795 //y2=0.555
cc_5407 ( N_noxref_14_c_6271_p N_noxref_40_M44_noxref_s ) capacitor \
 c=0.0283243f //x=71.415 //y=1.76 //x2=70.795 //y2=0.555
cc_5408 ( N_noxref_14_c_6183_p N_noxref_40_M44_noxref_s ) capacitor \
 c=0.00752108f //x=71.815 //y=1.845 //x2=70.795 //y2=0.555
cc_5409 ( N_noxref_14_c_6124_n N_noxref_40_M44_noxref_s ) capacitor \
 c=0.00309975f //x=71.9 //y=2.77 //x2=70.795 //y2=0.555
cc_5410 ( N_noxref_14_M44_noxref_d N_noxref_40_M44_noxref_s ) capacitor \
 c=0.0279003f //x=71.225 //y=1.095 //x2=70.795 //y2=0.555
cc_5411 ( N_noxref_14_c_6182_p N_noxref_41_M46_noxref_d ) capacitor \
 c=3.20746e-19 //x=71.415 //y=1.305 //x2=74.5 //y2=1.09
cc_5412 ( N_noxref_14_c_6182_p N_GND_c_17019_n ) capacitor c=0.00884249f \
 //x=71.415 //y=1.305 //x2=73.63 //y2=0.175
cc_5413 ( N_noxref_14_c_6183_p N_GND_c_17019_n ) capacitor c=0.00662553f \
 //x=71.815 //y=1.845 //x2=73.63 //y2=0.175
cc_5414 ( N_noxref_14_c_6179_p N_GND_c_17019_n ) capacitor c=4.31179e-19 \
 //x=71.9 //y=2.93 //x2=73.63 //y2=0.175
cc_5415 ( N_noxref_14_M44_noxref_d N_GND_c_17019_n ) capacitor c=2.9462e-19 \
 //x=71.225 //y=1.095 //x2=73.63 //y2=0.175
cc_5416 ( N_noxref_14_c_6157_p N_GND_c_17023_n ) capacitor c=3.97665e-19 \
 //x=73.45 //y=1.055 //x2=73.715 //y2=1.015
cc_5417 ( N_noxref_14_c_6363_p N_GND_c_17023_n ) capacitor c=0.00864776f \
 //x=73.825 //y=0.9 //x2=73.715 //y2=1.015
cc_5418 ( N_noxref_14_c_6159_p N_GND_c_17023_n ) capacitor c=4.45447e-19 \
 //x=73.98 //y=1.055 //x2=73.715 //y2=1.015
cc_5419 ( N_noxref_14_c_6182_p N_GND_c_17026_n ) capacitor c=0.00543195f \
 //x=71.415 //y=1.305 //x2=73.715 //y2=1.145
cc_5420 ( N_noxref_14_c_6136_p N_GND_c_17026_n ) capacitor c=0.00771144f \
 //x=73.75 //y=2.375 //x2=73.715 //y2=1.145
cc_5421 ( N_noxref_14_c_6131_p N_GND_c_17026_n ) capacitor c=0.0011623f \
 //x=73.75 //y=2.93 //x2=73.715 //y2=1.145
cc_5422 ( N_noxref_14_c_6135_p N_GND_c_17026_n ) capacitor c=2.22883e-19 \
 //x=73.75 //y=2.26 //x2=73.715 //y2=1.145
cc_5423 ( N_noxref_14_c_6157_p N_GND_c_17026_n ) capacitor c=0.00156339f \
 //x=73.45 //y=1.055 //x2=73.715 //y2=1.145
cc_5424 ( N_noxref_14_c_6158_p N_GND_c_17026_n ) capacitor c=0.00352472f \
 //x=73.45 //y=1.4 //x2=73.715 //y2=1.145
cc_5425 ( N_noxref_14_c_6160_p N_GND_c_17026_n ) capacitor c=3.88232e-19 \
 //x=73.45 //y=1.71 //x2=73.715 //y2=1.145
cc_5426 ( N_noxref_14_c_6363_p N_GND_c_17026_n ) capacitor c=9.36995e-19 \
 //x=73.825 //y=0.9 //x2=73.715 //y2=1.145
cc_5427 ( N_noxref_14_c_6373_p N_GND_c_17026_n ) capacitor c=5.27793e-19 \
 //x=73.825 //y=1.555 //x2=73.715 //y2=1.145
cc_5428 ( N_noxref_14_c_6159_p N_GND_c_17026_n ) capacitor c=0.0017438f \
 //x=73.98 //y=1.055 //x2=73.715 //y2=1.145
cc_5429 ( N_noxref_14_c_6161_p N_GND_c_17026_n ) capacitor c=0.00276804f \
 //x=73.98 //y=1.4 //x2=73.715 //y2=1.145
cc_5430 ( N_noxref_14_c_6183_p N_GND_c_16983_n ) capacitor c=6.86343e-19 \
 //x=71.815 //y=1.845 //x2=72.47 //y2=0.175
cc_5431 ( N_noxref_14_c_6179_p N_GND_c_16983_n ) capacitor c=6.02672e-19 \
 //x=71.9 //y=2.93 //x2=72.47 //y2=0.175
cc_5432 ( N_noxref_14_c_6157_p N_GND_c_17039_n ) capacitor c=0.00678016f \
 //x=73.45 //y=1.055 //x2=77.28 //y2=0.175
cc_5433 ( N_noxref_14_c_6271_p N_GND_c_17040_n ) capacitor c=0.0045138f \
 //x=71.415 //y=1.76 //x2=72.64 //y2=0.175
cc_5434 ( N_noxref_14_c_6183_p N_GND_c_17040_n ) capacitor c=0.0233604f \
 //x=71.815 //y=1.845 //x2=72.64 //y2=0.175
cc_5435 ( N_noxref_14_c_6179_p N_GND_c_17040_n ) capacitor c=0.00422913f \
 //x=71.9 //y=2.93 //x2=72.64 //y2=0.175
cc_5436 ( N_noxref_14_c_6136_p N_GND_c_17040_n ) capacitor c=0.003423f \
 //x=73.75 //y=2.375 //x2=72.64 //y2=0.175
cc_5437 ( N_noxref_14_c_6130_p N_GND_c_17040_n ) capacitor c=0.0036684f \
 //x=73.75 //y=2.61 //x2=72.64 //y2=0.175
cc_5438 ( N_noxref_14_c_6131_p N_GND_c_17040_n ) capacitor c=0.00305356f \
 //x=73.75 //y=2.93 //x2=72.64 //y2=0.175
cc_5439 ( N_noxref_14_c_6124_n N_GND_c_17040_n ) capacitor c=0.0103933f \
 //x=71.9 //y=2.77 //x2=72.64 //y2=0.175
cc_5440 ( N_noxref_14_c_6133_p N_GND_c_17040_n ) capacitor c=0.00527139f \
 //x=73.75 //y=2.77 //x2=72.64 //y2=0.175
cc_5441 ( N_noxref_14_c_6176_p N_GND_c_17040_n ) capacitor c=0.00947774f \
 //x=73.6 //y=2.77 //x2=72.64 //y2=0.175
cc_5442 ( N_noxref_14_c_6135_p N_GND_c_17040_n ) capacitor c=0.00379567f \
 //x=73.75 //y=2.26 //x2=72.64 //y2=0.175
cc_5443 ( N_noxref_14_c_6160_p N_GND_c_17040_n ) capacitor c=0.00170145f \
 //x=73.45 //y=1.71 //x2=72.64 //y2=0.175
cc_5444 ( N_noxref_14_c_6138_p N_GND_c_17040_n ) capacitor c=0.0102191f \
 //x=73.45 //y=2.095 //x2=72.64 //y2=0.175
cc_5445 ( N_noxref_14_c_6136_p N_GND_M45_noxref_d ) capacitor c=4.4417e-19 \
 //x=73.75 //y=2.375 //x2=73.525 //y2=1.055
cc_5446 ( N_noxref_14_c_6157_p N_GND_M45_noxref_d ) capacitor c=0.00184354f \
 //x=73.45 //y=1.055 //x2=73.525 //y2=1.055
cc_5447 ( N_noxref_14_c_6158_p N_GND_M45_noxref_d ) capacitor c=0.00210798f \
 //x=73.45 //y=1.4 //x2=73.525 //y2=1.055
cc_5448 ( N_noxref_14_c_6363_p N_GND_M45_noxref_d ) capacitor c=0.00474029f \
 //x=73.825 //y=0.9 //x2=73.525 //y2=1.055
cc_5449 ( N_noxref_14_c_6373_p N_GND_M45_noxref_d ) capacitor c=0.00166857f \
 //x=73.825 //y=1.555 //x2=73.525 //y2=1.055
cc_5450 ( N_noxref_14_c_6159_p N_GND_M45_noxref_d ) capacitor c=0.00230174f \
 //x=73.98 //y=1.055 //x2=73.525 //y2=1.055
cc_5451 ( N_noxref_14_c_6161_p N_GND_M45_noxref_d ) capacitor c=0.00210798f \
 //x=73.98 //y=1.4 //x2=73.525 //y2=1.055
cc_5452 ( N_noxref_14_c_6138_p N_noxref_62_c_18999_n ) capacitor c=0.00262672f \
 //x=73.45 //y=2.095 //x2=73.23 //y2=1.685
cc_5453 ( N_noxref_14_c_6136_p N_noxref_62_c_19000_n ) capacitor c=0.00428451f \
 //x=73.75 //y=2.375 //x2=74.115 //y2=1.77
cc_5454 ( N_noxref_14_c_6131_p N_noxref_62_c_19000_n ) capacitor c=0.0046919f \
 //x=73.75 //y=2.93 //x2=74.115 //y2=1.77
cc_5455 ( N_noxref_14_c_6135_p N_noxref_62_c_19000_n ) capacitor c=0.0104666f \
 //x=73.75 //y=2.26 //x2=74.115 //y2=1.77
cc_5456 ( N_noxref_14_c_6160_p N_noxref_62_c_19000_n ) capacitor c=0.00705077f \
 //x=73.45 //y=1.71 //x2=74.115 //y2=1.77
cc_5457 ( N_noxref_14_c_6138_p N_noxref_62_c_19000_n ) capacitor c=0.0197809f \
 //x=73.45 //y=2.095 //x2=74.115 //y2=1.77
cc_5458 ( N_noxref_14_c_6373_p N_noxref_62_c_19000_n ) capacitor c=0.00588627f \
 //x=73.825 //y=1.555 //x2=74.115 //y2=1.77
cc_5459 ( N_noxref_14_c_6161_p N_noxref_62_c_19000_n ) capacitor c=0.00698822f \
 //x=73.98 //y=1.4 //x2=74.115 //y2=1.77
cc_5460 ( N_noxref_14_c_6157_p N_noxref_62_M45_noxref_s ) capacitor \
 c=0.0295256f //x=73.45 //y=1.055 //x2=73.095 //y2=0.555
cc_5461 ( N_noxref_14_c_6160_p N_noxref_62_M45_noxref_s ) capacitor \
 c=7.99997e-19 //x=73.45 //y=1.71 //x2=73.095 //y2=0.555
cc_5462 ( N_noxref_14_c_6138_p N_noxref_62_M45_noxref_s ) capacitor \
 c=0.00122123f //x=73.45 //y=2.095 //x2=73.095 //y2=0.555
cc_5463 ( N_noxref_14_c_6159_p N_noxref_62_M45_noxref_s ) capacitor \
 c=0.0125924f //x=73.98 //y=1.055 //x2=73.095 //y2=0.555
cc_5464 ( N_CLK_c_6630_n N_noxref_16_c_7371_n ) capacitor c=0.0264205f \
 //x=65.395 //y=4.62 //x2=61.54 //y2=4.75
cc_5465 ( N_CLK_c_6598_n N_noxref_16_c_7372_n ) capacitor c=0.0211823f \
 //x=65.235 //y=4.835 //x2=65.31 //y2=5.335
cc_5466 ( N_CLK_c_6874_n N_noxref_16_c_7372_n ) capacitor c=0.00462397f \
 //x=65.24 //y=4.88 //x2=65.31 //y2=5.335
cc_5467 ( N_CLK_M141_noxref_g N_noxref_16_c_7372_n ) capacitor c=0.00688349f \
 //x=65.21 //y=6.2 //x2=65.31 //y2=5.335
cc_5468 ( N_CLK_c_6892_n N_noxref_16_c_7372_n ) capacitor c=3.29746e-19 \
 //x=65.24 //y=4.88 //x2=65.31 //y2=5.335
cc_5469 ( N_CLK_M142_noxref_g N_noxref_16_c_7373_n ) capacitor c=0.00806692f \
 //x=65.65 //y=6.2 //x2=66.195 //y2=5.335
cc_5470 ( CLK N_noxref_16_c_7408_n ) capacitor c=0.00130644f //x=65.24 \
 //y=4.62 //x2=67.09 //y2=3.335
cc_5471 ( CLK N_noxref_16_c_7375_n ) capacitor c=0.00193525f //x=65.24 \
 //y=4.62 //x2=67.09 //y2=5.25
cc_5472 ( N_CLK_c_6627_n N_noxref_16_c_7375_n ) capacitor c=0.0233014f \
 //x=74.705 //y=4.62 //x2=67.09 //y2=5.25
cc_5473 ( N_CLK_c_6598_n N_noxref_16_c_7381_n ) capacitor c=0.00474935f \
 //x=65.235 //y=4.835 //x2=65.43 //y2=5.335
cc_5474 ( N_CLK_c_6874_n N_noxref_16_c_7381_n ) capacitor c=0.00130526f \
 //x=65.24 //y=4.88 //x2=65.43 //y2=5.335
cc_5475 ( N_CLK_M141_noxref_g N_noxref_16_c_7381_n ) capacitor c=0.00252129f \
 //x=65.21 //y=6.2 //x2=65.43 //y2=5.335
cc_5476 ( N_CLK_M142_noxref_g N_noxref_16_c_7381_n ) capacitor c=0.00263496f \
 //x=65.65 //y=6.2 //x2=65.43 //y2=5.335
cc_5477 ( N_CLK_c_6951_p N_noxref_16_c_7381_n ) capacitor c=0.00188023f \
 //x=65.575 //y=4.97 //x2=65.43 //y2=5.335
cc_5478 ( CLK N_noxref_16_c_7422_n ) capacitor c=0.023525f //x=74.86 //y=2.77 \
 //x2=78.395 //y2=3.51
cc_5479 ( CLK N_noxref_16_c_7425_n ) capacitor c=0.0235252f //x=65.24 //y=4.62 \
 //x2=66.93 //y2=3.495
cc_5480 ( N_CLK_c_6630_n N_noxref_16_c_7425_n ) capacitor c=0.0201741f \
 //x=65.395 //y=4.62 //x2=66.93 //y2=3.495
cc_5481 ( N_CLK_c_6598_n N_noxref_16_c_7491_n ) capacitor c=0.00134045f \
 //x=65.235 //y=4.835 //x2=65.43 //y2=5.56
cc_5482 ( N_CLK_M141_noxref_g N_noxref_16_c_7491_n ) capacitor c=0.0178171f \
 //x=65.21 //y=6.2 //x2=65.43 //y2=5.56
cc_5483 ( N_CLK_M142_noxref_g N_noxref_16_c_7491_n ) capacitor c=0.0178171f \
 //x=65.65 //y=6.2 //x2=65.43 //y2=5.56
cc_5484 ( N_CLK_c_6951_p N_noxref_16_c_7491_n ) capacitor c=0.00293647f \
 //x=65.575 //y=4.97 //x2=65.43 //y2=5.56
cc_5485 ( CLK RN ) capacitor c=0.049536f //x=17.14 //y=2.77 //x2=18.25 //y2=2.77
cc_5486 ( N_CLK_c_6464_n RN ) capacitor c=0.00165235f //x=17.145 //y=4.835 \
 //x2=18.25 //y2=2.77
cc_5487 ( N_CLK_c_6473_n RN ) capacitor c=0.0262729f //x=28.395 //y=4.61 \
 //x2=18.25 //y2=2.77
cc_5488 ( N_CLK_c_6473_n RN ) capacitor c=0.0268258f //x=28.395 //y=4.61 \
 //x2=21.95 //y2=2.77
cc_5489 ( N_CLK_c_6619_n RN ) capacitor c=0.0234019f //x=36.535 //y=4.62 \
 //x2=31.57 //y2=2.77
cc_5490 ( CLK RN ) capacitor c=0.049536f //x=46 //y=2.77 //x2=47.11 //y2=2.77
cc_5491 ( N_CLK_c_6595_n RN ) capacitor c=0.00165235f //x=46.005 //y=4.835 \
 //x2=47.11 //y2=2.77
cc_5492 ( N_CLK_c_6623_n RN ) capacitor c=0.0228491f //x=59.19 //y=4.635 \
 //x2=47.11 //y2=2.77
cc_5493 ( N_CLK_c_6623_n RN ) capacitor c=0.0234019f //x=59.19 //y=4.635 \
 //x2=50.81 //y2=2.77
cc_5494 ( N_CLK_c_6630_n RN ) capacitor c=0.026513f //x=65.395 //y=4.62 \
 //x2=60.43 //y2=2.77
cc_5495 ( CLK RN ) capacitor c=0.0489849f //x=74.86 //y=2.77 //x2=75.97 \
 //y2=2.77
cc_5496 ( N_CLK_c_6601_n RN ) capacitor c=0.00151796f //x=74.865 //y=4.835 \
 //x2=75.97 //y2=2.77
cc_5497 ( N_CLK_c_6633_n RN ) capacitor c=0.00109494f //x=74.865 //y=4.62 \
 //x2=75.97 //y2=2.77
cc_5498 ( CLK N_RN_c_8045_n ) capacitor c=0.00368508f //x=17.14 //y=2.77 \
 //x2=18.25 //y2=2.565
cc_5499 ( N_CLK_c_6461_n N_RN_c_8045_n ) capacitor c=0.00814679f //x=17.14 \
 //y=2.375 //x2=18.25 //y2=2.565
cc_5500 ( N_CLK_c_6474_n N_RN_c_8045_n ) capacitor c=0.00115994f //x=17.14 \
 //y=2.26 //x2=18.25 //y2=2.565
cc_5501 ( N_CLK_c_6493_n N_RN_c_8045_n ) capacitor c=0.00151788f //x=17.23 \
 //y=2.095 //x2=18.25 //y2=2.565
cc_5502 ( N_CLK_c_6464_n N_RN_c_8048_n ) capacitor c=0.00670721f //x=17.145 \
 //y=4.835 //x2=18.25 //y2=4.75
cc_5503 ( N_CLK_c_6473_n N_RN_c_8048_n ) capacitor c=0.0100099f //x=28.395 \
 //y=4.61 //x2=18.25 //y2=4.75
cc_5504 ( N_CLK_c_6478_n N_RN_c_8048_n ) capacitor c=4.56604e-19 //x=17.14 \
 //y=4.88 //x2=18.25 //y2=4.75
cc_5505 ( N_CLK_c_6473_n N_RN_c_7930_n ) capacitor c=0.00430801f //x=28.395 \
 //y=4.61 //x2=21.95 //y2=4.765
cc_5506 ( N_CLK_c_6619_n N_RN_c_8124_n ) capacitor c=0.00255397f //x=36.535 \
 //y=4.62 //x2=31.57 //y2=4.765
cc_5507 ( CLK N_RN_c_8374_n ) capacitor c=0.00368508f //x=46 //y=2.77 \
 //x2=47.11 //y2=2.565
cc_5508 ( N_CLK_c_6701_n N_RN_c_8374_n ) capacitor c=0.00814679f //x=46 \
 //y=2.375 //x2=47.11 //y2=2.565
cc_5509 ( N_CLK_c_6711_n N_RN_c_8374_n ) capacitor c=0.00115994f //x=46 \
 //y=2.26 //x2=47.11 //y2=2.565
cc_5510 ( N_CLK_c_6730_n N_RN_c_8374_n ) capacitor c=0.00151788f //x=46.09 \
 //y=2.095 //x2=47.11 //y2=2.565
cc_5511 ( N_CLK_c_6595_n N_RN_c_8125_n ) capacitor c=0.0057484f //x=46.005 \
 //y=4.835 //x2=47.11 //y2=4.75
cc_5512 ( N_CLK_c_6623_n N_RN_c_8125_n ) capacitor c=0.00614778f //x=59.19 \
 //y=4.635 //x2=47.11 //y2=4.75
cc_5513 ( N_CLK_c_6715_n N_RN_c_8125_n ) capacitor c=4.41153e-19 //x=46 \
 //y=4.88 //x2=47.11 //y2=4.75
cc_5514 ( N_CLK_c_6623_n N_RN_c_8126_n ) capacitor c=0.00255041f //x=59.19 \
 //y=4.635 //x2=50.81 //y2=4.765
cc_5515 ( N_CLK_c_6630_n N_RN_c_8127_n ) capacitor c=0.00255397f //x=65.395 \
 //y=4.62 //x2=60.43 //y2=4.765
cc_5516 ( CLK N_RN_c_8660_n ) capacitor c=0.00368508f //x=74.86 //y=2.77 \
 //x2=75.97 //y2=2.565
cc_5517 ( N_CLK_c_6903_n N_RN_c_8660_n ) capacitor c=0.00814679f //x=74.86 \
 //y=2.375 //x2=75.97 //y2=2.565
cc_5518 ( N_CLK_c_6913_n N_RN_c_8660_n ) capacitor c=0.00115994f //x=74.86 \
 //y=2.26 //x2=75.97 //y2=2.565
cc_5519 ( N_CLK_c_6932_n N_RN_c_8660_n ) capacitor c=0.00151788f //x=74.95 \
 //y=2.095 //x2=75.97 //y2=2.565
cc_5520 ( N_CLK_c_6601_n N_RN_c_8128_n ) capacitor c=0.00437112f //x=74.865 \
 //y=4.835 //x2=75.97 //y2=4.75
cc_5521 ( N_CLK_c_6917_n N_RN_c_8128_n ) capacitor c=4.56604e-19 //x=74.86 \
 //y=4.88 //x2=75.97 //y2=4.75
cc_5522 ( CLK N_RN_c_7855_n ) capacitor c=0.0137581f //x=7.52 //y=3.14 \
 //x2=13.795 //y2=2.4
cc_5523 ( N_CLK_c_6419_n N_RN_c_7855_n ) capacitor c=0.017405f //x=7.52 \
 //y=2.375 //x2=13.795 //y2=2.4
cc_5524 ( N_CLK_c_6428_n N_RN_c_7855_n ) capacitor c=5.2767e-19 //x=7.52 \
 //y=2.26 //x2=13.795 //y2=2.4
cc_5525 ( N_CLK_c_6447_n N_RN_c_7855_n ) capacitor c=4.03361e-19 //x=7.61 \
 //y=2.095 //x2=13.795 //y2=2.4
cc_5526 ( CLK N_RN_c_7903_n ) capacitor c=0.0176131f //x=17.14 //y=2.77 \
 //x2=18.415 //y2=2.4
cc_5527 ( N_CLK_c_6461_n N_RN_c_7903_n ) capacitor c=0.019268f //x=17.14 \
 //y=2.375 //x2=18.415 //y2=2.4
cc_5528 ( N_CLK_c_6474_n N_RN_c_7903_n ) capacitor c=2.63835e-19 //x=17.14 \
 //y=2.26 //x2=18.415 //y2=2.4
cc_5529 ( N_CLK_c_6493_n N_RN_c_7903_n ) capacitor c=4.03361e-19 //x=17.23 \
 //y=2.095 //x2=18.415 //y2=2.4
cc_5530 ( CLK N_RN_c_8024_n ) capacitor c=0.0137581f //x=36.38 //y=3.88 \
 //x2=42.825 //y2=2.385
cc_5531 ( N_CLK_c_6658_n N_RN_c_8024_n ) capacitor c=0.017405f //x=36.38 \
 //y=2.375 //x2=42.825 //y2=2.385
cc_5532 ( N_CLK_c_6668_n N_RN_c_8024_n ) capacitor c=5.2767e-19 //x=36.38 \
 //y=2.26 //x2=42.825 //y2=2.385
cc_5533 ( N_CLK_c_6687_n N_RN_c_8024_n ) capacitor c=4.03361e-19 //x=36.47 \
 //y=2.095 //x2=42.825 //y2=2.385
cc_5534 ( CLK N_RN_c_8235_n ) capacitor c=0.0176131f //x=46 //y=2.77 \
 //x2=47.275 //y2=2.4
cc_5535 ( N_CLK_c_6701_n N_RN_c_8235_n ) capacitor c=0.019268f //x=46 \
 //y=2.375 //x2=47.275 //y2=2.4
cc_5536 ( N_CLK_c_6711_n N_RN_c_8235_n ) capacitor c=2.63835e-19 //x=46 \
 //y=2.26 //x2=47.275 //y2=2.4
cc_5537 ( N_CLK_c_6730_n N_RN_c_8235_n ) capacitor c=4.03361e-19 //x=46.09 \
 //y=2.095 //x2=47.275 //y2=2.4
cc_5538 ( CLK N_RN_c_8353_n ) capacitor c=0.0137581f //x=65.24 //y=4.62 \
 //x2=71.685 //y2=2.385
cc_5539 ( N_CLK_c_6860_n N_RN_c_8353_n ) capacitor c=0.017405f //x=65.24 \
 //y=2.375 //x2=71.685 //y2=2.385
cc_5540 ( N_CLK_c_6870_n N_RN_c_8353_n ) capacitor c=5.2767e-19 //x=65.24 \
 //y=2.26 //x2=71.685 //y2=2.385
cc_5541 ( N_CLK_c_6889_n N_RN_c_8353_n ) capacitor c=4.03361e-19 //x=65.33 \
 //y=2.095 //x2=71.685 //y2=2.385
cc_5542 ( CLK N_RN_c_8628_n ) capacitor c=0.0176131f //x=74.86 //y=2.77 \
 //x2=76.135 //y2=2.4
cc_5543 ( N_CLK_c_6903_n N_RN_c_8628_n ) capacitor c=0.019268f //x=74.86 \
 //y=2.375 //x2=76.135 //y2=2.4
cc_5544 ( N_CLK_c_6913_n N_RN_c_8628_n ) capacitor c=2.63835e-19 //x=74.86 \
 //y=2.26 //x2=76.135 //y2=2.4
cc_5545 ( N_CLK_c_6932_n N_RN_c_8628_n ) capacitor c=4.03361e-19 //x=74.95 \
 //y=2.095 //x2=76.135 //y2=2.4
cc_5546 ( N_CLK_c_6461_n N_RN_c_8071_n ) capacitor c=5.42289e-19 //x=17.14 \
 //y=2.375 //x2=18.25 //y2=2.26
cc_5547 ( N_CLK_c_6474_n N_RN_c_8071_n ) capacitor c=0.00124908f //x=17.14 \
 //y=2.26 //x2=18.25 //y2=2.26
cc_5548 ( N_CLK_c_6493_n N_RN_c_8071_n ) capacitor c=0.00209592f //x=17.23 \
 //y=2.095 //x2=18.25 //y2=2.26
cc_5549 ( N_CLK_c_6464_n N_RN_c_8072_n ) capacitor c=7.60106e-19 //x=17.145 \
 //y=4.835 //x2=18.25 //y2=4.88
cc_5550 ( N_CLK_c_6478_n N_RN_c_8072_n ) capacitor c=0.00113666f //x=17.14 \
 //y=4.88 //x2=18.25 //y2=4.88
cc_5551 ( N_CLK_c_6496_n N_RN_c_8072_n ) capacitor c=9.77556e-19 //x=17.14 \
 //y=4.88 //x2=18.25 //y2=4.88
cc_5552 ( N_CLK_c_6701_n N_RN_c_8399_n ) capacitor c=5.42289e-19 //x=46 \
 //y=2.375 //x2=47.11 //y2=2.26
cc_5553 ( N_CLK_c_6711_n N_RN_c_8399_n ) capacitor c=0.00124908f //x=46 \
 //y=2.26 //x2=47.11 //y2=2.26
cc_5554 ( N_CLK_c_6730_n N_RN_c_8399_n ) capacitor c=0.00209592f //x=46.09 \
 //y=2.095 //x2=47.11 //y2=2.26
cc_5555 ( N_CLK_c_6595_n N_RN_c_8400_n ) capacitor c=7.60106e-19 //x=46.005 \
 //y=4.835 //x2=47.11 //y2=4.88
cc_5556 ( N_CLK_c_6715_n N_RN_c_8400_n ) capacitor c=0.00113666f //x=46 \
 //y=4.88 //x2=47.11 //y2=4.88
cc_5557 ( N_CLK_c_6733_n N_RN_c_8400_n ) capacitor c=9.77556e-19 //x=46 \
 //y=4.88 //x2=47.11 //y2=4.88
cc_5558 ( N_CLK_c_6903_n N_RN_c_8702_n ) capacitor c=5.42289e-19 //x=74.86 \
 //y=2.375 //x2=75.97 //y2=2.26
cc_5559 ( N_CLK_c_6913_n N_RN_c_8702_n ) capacitor c=0.00124908f //x=74.86 \
 //y=2.26 //x2=75.97 //y2=2.26
cc_5560 ( N_CLK_c_6932_n N_RN_c_8702_n ) capacitor c=0.00209592f //x=74.95 \
 //y=2.095 //x2=75.97 //y2=2.26
cc_5561 ( N_CLK_c_6601_n N_RN_c_8705_n ) capacitor c=7.60106e-19 //x=74.865 \
 //y=4.835 //x2=75.97 //y2=4.88
cc_5562 ( N_CLK_c_6917_n N_RN_c_8705_n ) capacitor c=0.00113666f //x=74.86 \
 //y=4.88 //x2=75.97 //y2=4.88
cc_5563 ( N_CLK_c_6935_n N_RN_c_8705_n ) capacitor c=9.77556e-19 //x=74.86 \
 //y=4.88 //x2=75.97 //y2=4.88
cc_5564 ( N_CLK_M81_noxref_g N_RN_M83_noxref_g ) capacitor c=0.0101598f \
 //x=17.11 //y=6.2 //x2=17.99 //y2=6.2
cc_5565 ( N_CLK_M82_noxref_g N_RN_M83_noxref_g ) capacitor c=0.0607518f \
 //x=17.55 //y=6.2 //x2=17.99 //y2=6.2
cc_5566 ( N_CLK_M82_noxref_g N_RN_M84_noxref_g ) capacitor c=0.0101598f \
 //x=17.55 //y=6.2 //x2=18.43 //y2=6.2
cc_5567 ( N_CLK_M117_noxref_g N_RN_M119_noxref_g ) capacitor c=0.0101598f \
 //x=45.97 //y=6.2 //x2=46.85 //y2=6.2
cc_5568 ( N_CLK_M118_noxref_g N_RN_M119_noxref_g ) capacitor c=0.0607518f \
 //x=46.41 //y=6.2 //x2=46.85 //y2=6.2
cc_5569 ( N_CLK_M118_noxref_g N_RN_M120_noxref_g ) capacitor c=0.0101598f \
 //x=46.41 //y=6.2 //x2=47.29 //y2=6.2
cc_5570 ( N_CLK_M153_noxref_g N_RN_M155_noxref_g ) capacitor c=0.0101598f \
 //x=74.83 //y=6.2 //x2=75.71 //y2=6.2
cc_5571 ( N_CLK_M154_noxref_g N_RN_M155_noxref_g ) capacitor c=0.0607518f \
 //x=75.27 //y=6.2 //x2=75.71 //y2=6.2
cc_5572 ( N_CLK_M154_noxref_g N_RN_M156_noxref_g ) capacitor c=0.0101598f \
 //x=75.27 //y=6.2 //x2=76.15 //y2=6.2
cc_5573 ( N_CLK_c_6490_n N_RN_c_8082_n ) capacitor c=0.00456962f //x=17.23 \
 //y=1.09 //x2=18.24 //y2=1.095
cc_5574 ( N_CLK_c_6491_n N_RN_c_8084_n ) capacitor c=0.00438372f //x=17.23 \
 //y=1.4 //x2=18.24 //y2=1.44
cc_5575 ( N_CLK_c_6492_n N_RN_c_8087_n ) capacitor c=0.00438372f //x=17.23 \
 //y=1.63 //x2=18.24 //y2=1.75
cc_5576 ( N_CLK_c_6727_n N_RN_c_8410_n ) capacitor c=0.00456962f //x=46.09 \
 //y=1.09 //x2=47.1 //y2=1.095
cc_5577 ( N_CLK_c_6728_n N_RN_c_8412_n ) capacitor c=0.00438372f //x=46.09 \
 //y=1.4 //x2=47.1 //y2=1.44
cc_5578 ( N_CLK_c_6729_n N_RN_c_8415_n ) capacitor c=0.00438372f //x=46.09 \
 //y=1.63 //x2=47.1 //y2=1.75
cc_5579 ( N_CLK_c_6929_n N_RN_c_8723_n ) capacitor c=0.00456962f //x=74.95 \
 //y=1.09 //x2=75.96 //y2=1.095
cc_5580 ( N_CLK_c_6930_n N_RN_c_8724_n ) capacitor c=0.00438372f //x=74.95 \
 //y=1.4 //x2=75.96 //y2=1.44
cc_5581 ( N_CLK_c_6931_n N_RN_c_8725_n ) capacitor c=0.00438372f //x=74.95 \
 //y=1.63 //x2=75.96 //y2=1.75
cc_5582 ( N_CLK_c_6461_n N_RN_c_8100_n ) capacitor c=6.32114e-19 //x=17.14 \
 //y=2.375 //x2=18.25 //y2=2.26
cc_5583 ( N_CLK_c_6474_n N_RN_c_8100_n ) capacitor c=0.00172812f //x=17.14 \
 //y=2.26 //x2=18.25 //y2=2.26
cc_5584 ( N_CLK_c_6493_n N_RN_c_8100_n ) capacitor c=0.00865408f //x=17.23 \
 //y=2.095 //x2=18.25 //y2=2.26
cc_5585 ( N_CLK_c_6493_n N_RN_c_8101_n ) capacitor c=0.00438372f //x=17.23 \
 //y=2.095 //x2=18.25 //y2=2.095
cc_5586 ( N_CLK_c_6464_n N_RN_c_8103_n ) capacitor c=0.00133906f //x=17.145 \
 //y=4.835 //x2=18.25 //y2=4.88
cc_5587 ( N_CLK_c_6478_n N_RN_c_8103_n ) capacitor c=0.00186974f //x=17.14 \
 //y=4.88 //x2=18.25 //y2=4.88
cc_5588 ( N_CLK_c_6586_n N_RN_c_8103_n ) capacitor c=0.0616777f //x=17.475 \
 //y=4.97 //x2=18.25 //y2=4.88
cc_5589 ( N_CLK_c_6496_n N_RN_c_8103_n ) capacitor c=0.0042693f //x=17.14 \
 //y=4.88 //x2=18.25 //y2=4.88
cc_5590 ( N_CLK_c_6701_n N_RN_c_8428_n ) capacitor c=6.32114e-19 //x=46 \
 //y=2.375 //x2=47.11 //y2=2.26
cc_5591 ( N_CLK_c_6711_n N_RN_c_8428_n ) capacitor c=0.00172812f //x=46 \
 //y=2.26 //x2=47.11 //y2=2.26
cc_5592 ( N_CLK_c_6730_n N_RN_c_8428_n ) capacitor c=0.00865408f //x=46.09 \
 //y=2.095 //x2=47.11 //y2=2.26
cc_5593 ( N_CLK_c_6730_n N_RN_c_8429_n ) capacitor c=0.00438372f //x=46.09 \
 //y=2.095 //x2=47.11 //y2=2.095
cc_5594 ( N_CLK_c_6595_n N_RN_c_8179_n ) capacitor c=0.00133906f //x=46.005 \
 //y=4.835 //x2=47.11 //y2=4.88
cc_5595 ( N_CLK_c_6715_n N_RN_c_8179_n ) capacitor c=0.00186974f //x=46 \
 //y=4.88 //x2=47.11 //y2=4.88
cc_5596 ( N_CLK_c_6813_n N_RN_c_8179_n ) capacitor c=0.0616777f //x=46.335 \
 //y=4.97 //x2=47.11 //y2=4.88
cc_5597 ( N_CLK_c_6733_n N_RN_c_8179_n ) capacitor c=0.0042693f //x=46 \
 //y=4.88 //x2=47.11 //y2=4.88
cc_5598 ( N_CLK_c_6903_n N_RN_c_8742_n ) capacitor c=6.32114e-19 //x=74.86 \
 //y=2.375 //x2=75.97 //y2=2.26
cc_5599 ( N_CLK_c_6913_n N_RN_c_8742_n ) capacitor c=0.00172812f //x=74.86 \
 //y=2.26 //x2=75.97 //y2=2.26
cc_5600 ( N_CLK_c_6932_n N_RN_c_8742_n ) capacitor c=0.00865408f //x=74.95 \
 //y=2.095 //x2=75.97 //y2=2.26
cc_5601 ( N_CLK_c_6932_n N_RN_c_8745_n ) capacitor c=0.00438372f //x=74.95 \
 //y=2.095 //x2=75.97 //y2=2.095
cc_5602 ( N_CLK_c_6601_n N_RN_c_8180_n ) capacitor c=0.00133906f //x=74.865 \
 //y=4.835 //x2=75.97 //y2=4.88
cc_5603 ( N_CLK_c_6917_n N_RN_c_8180_n ) capacitor c=0.00186974f //x=74.86 \
 //y=4.88 //x2=75.97 //y2=4.88
cc_5604 ( N_CLK_c_6648_n N_RN_c_8180_n ) capacitor c=0.0616777f //x=75.195 \
 //y=4.97 //x2=75.97 //y2=4.88
cc_5605 ( N_CLK_c_6935_n N_RN_c_8180_n ) capacitor c=0.0042693f //x=74.86 \
 //y=4.88 //x2=75.97 //y2=4.88
cc_5606 ( N_CLK_c_6426_n N_SN_c_9845_n ) capacitor c=0.0307837f //x=16.985 \
 //y=4.62 //x2=12.33 //y2=4.765
cc_5607 ( N_CLK_c_6473_n N_SN_c_9935_n ) capacitor c=0.0307706f //x=28.395 \
 //y=4.61 //x2=26.76 //y2=4.765
cc_5608 ( N_CLK_c_6616_n N_SN_c_10068_n ) capacitor c=0.0256022f //x=45.845 \
 //y=4.62 //x2=41.19 //y2=4.765
cc_5609 ( N_CLK_c_6623_n N_SN_c_10069_n ) capacitor c=0.0255892f //x=59.19 \
 //y=4.635 //x2=55.62 //y2=4.765
cc_5610 ( N_CLK_c_6627_n N_SN_c_10070_n ) capacitor c=0.0256022f //x=74.705 \
 //y=4.62 //x2=70.05 //y2=4.765
cc_5611 ( CLK N_SN_c_9894_n ) capacitor c=5.00011e-19 //x=17.14 //y=2.77 \
 //x2=16.255 //y2=3.155
cc_5612 ( CLK N_SN_c_9915_n ) capacitor c=0.0261814f //x=17.14 //y=2.77 \
 //x2=20.45 //y2=3.14
cc_5613 ( N_CLK_c_6606_n N_SN_c_9921_n ) capacitor c=4.86936e-19 //x=28.825 \
 //y=4.61 //x2=32.475 //y2=3.13
cc_5614 ( N_CLK_c_6619_n N_SN_c_9921_n ) capacitor c=0.0125205f //x=36.535 \
 //y=4.62 //x2=32.475 //y2=3.13
cc_5615 ( CLK N_SN_c_10131_n ) capacitor c=9.94953e-19 //x=36.38 //y=3.88 \
 //x2=35.49 //y2=3.17
cc_5616 ( CLK N_SN_c_10134_n ) capacitor c=0.0235471f //x=36.38 //y=3.88 \
 //x2=37.845 //y2=3.14
cc_5617 ( CLK N_SN_c_10188_n ) capacitor c=5.00011e-19 //x=46 //y=2.77 \
 //x2=45.115 //y2=3.155
cc_5618 ( CLK N_SN_c_10225_n ) capacitor c=0.0261814f //x=46 //y=2.77 \
 //x2=49.31 //y2=3.14
cc_5619 ( N_CLK_c_6840_n N_SN_c_10255_n ) capacitor c=2.52385e-19 //x=59.535 \
 //y=4.635 //x2=61.335 //y2=3.13
cc_5620 ( N_CLK_c_6630_n N_SN_c_10255_n ) capacitor c=0.00579861f //x=65.395 \
 //y=4.62 //x2=61.335 //y2=3.13
cc_5621 ( CLK N_SN_c_10414_n ) capacitor c=9.94953e-19 //x=65.24 //y=4.62 \
 //x2=64.35 //y2=3.17
cc_5622 ( CLK N_SN_c_10417_n ) capacitor c=0.0235471f //x=65.24 //y=4.62 \
 //x2=66.705 //y2=3.14
cc_5623 ( CLK N_SN_c_10471_n ) capacitor c=5.00011e-19 //x=74.86 //y=2.77 \
 //x2=73.975 //y2=3.155
cc_5624 ( CLK N_SN_c_10502_n ) capacitor c=0.0261813f //x=74.86 //y=2.77 \
 //x2=78.17 //y2=3.14
cc_5625 ( N_CLK_c_6860_n N_noxref_20_c_11147_n ) capacitor c=0.00939109f \
 //x=65.24 //y=2.375 //x2=66.35 //y2=2.375
cc_5626 ( N_CLK_c_6870_n N_noxref_20_c_11147_n ) capacitor c=5.39999e-19 \
 //x=65.24 //y=2.26 //x2=66.35 //y2=2.375
cc_5627 ( N_CLK_c_6889_n N_noxref_20_c_11147_n ) capacitor c=0.00137098f \
 //x=65.33 //y=2.095 //x2=66.35 //y2=2.375
cc_5628 ( CLK N_noxref_20_c_11071_n ) capacitor c=0.0295989f //x=65.24 \
 //y=4.62 //x2=66.35 //y2=3.735
cc_5629 ( N_CLK_c_6870_n N_noxref_20_c_11071_n ) capacitor c=3.9149e-19 \
 //x=65.24 //y=2.26 //x2=66.35 //y2=3.735
cc_5630 ( CLK N_noxref_20_c_11152_n ) capacitor c=0.00778378f //x=65.24 \
 //y=4.62 //x2=66.35 //y2=4.055
cc_5631 ( CLK N_noxref_20_c_11043_n ) capacitor c=0.0129334f //x=65.24 \
 //y=4.62 //x2=66.35 //y2=4.75
cc_5632 ( N_CLK_c_6598_n N_noxref_20_c_11043_n ) capacitor c=0.00724653f \
 //x=65.235 //y=4.835 //x2=66.35 //y2=4.75
cc_5633 ( N_CLK_c_6627_n N_noxref_20_c_11043_n ) capacitor c=0.0231461f \
 //x=74.705 //y=4.62 //x2=66.35 //y2=4.75
cc_5634 ( N_CLK_c_6630_n N_noxref_20_c_11043_n ) capacitor c=0.00449139f \
 //x=65.395 //y=4.62 //x2=66.35 //y2=4.75
cc_5635 ( N_CLK_c_6874_n N_noxref_20_c_11043_n ) capacitor c=4.41153e-19 \
 //x=65.24 //y=4.88 //x2=66.35 //y2=4.75
cc_5636 ( N_CLK_c_6627_n N_noxref_20_c_11044_n ) capacitor c=0.0228926f \
 //x=74.705 //y=4.62 //x2=71.16 //y2=4.75
cc_5637 ( N_CLK_c_6601_n N_noxref_20_c_11045_n ) capacitor c=0.0204482f \
 //x=74.865 //y=4.835 //x2=74.93 //y2=5.335
cc_5638 ( N_CLK_c_6917_n N_noxref_20_c_11045_n ) capacitor c=0.0046287f \
 //x=74.86 //y=4.88 //x2=74.93 //y2=5.335
cc_5639 ( N_CLK_M153_noxref_g N_noxref_20_c_11045_n ) capacitor c=0.00856454f \
 //x=74.83 //y=6.2 //x2=74.93 //y2=5.335
cc_5640 ( N_CLK_c_6935_n N_noxref_20_c_11045_n ) capacitor c=3.34061e-19 \
 //x=74.86 //y=4.88 //x2=74.93 //y2=5.335
cc_5641 ( N_CLK_M154_noxref_g N_noxref_20_c_11047_n ) capacitor c=0.00951465f \
 //x=75.27 //y=6.2 //x2=75.815 //y2=5.335
cc_5642 ( CLK N_noxref_20_c_11164_n ) capacitor c=0.00239078f //x=74.86 \
 //y=2.77 //x2=76.71 //y2=3.735
cc_5643 ( CLK N_noxref_20_c_11051_n ) capacitor c=6.33867e-19 //x=74.86 \
 //y=2.77 //x2=76.71 //y2=5.25
cc_5644 ( CLK N_noxref_20_c_11166_n ) capacitor c=5.01652e-19 //x=65.24 \
 //y=4.62 //x2=66.35 //y2=3.88
cc_5645 ( N_CLK_c_6601_n N_noxref_20_c_11059_n ) capacitor c=0.00547176f \
 //x=74.865 //y=4.835 //x2=75.05 //y2=5.335
cc_5646 ( N_CLK_c_6917_n N_noxref_20_c_11059_n ) capacitor c=0.00132214f \
 //x=74.86 //y=4.88 //x2=75.05 //y2=5.335
cc_5647 ( N_CLK_M153_noxref_g N_noxref_20_c_11059_n ) capacitor c=0.00229818f \
 //x=74.83 //y=6.2 //x2=75.05 //y2=5.335
cc_5648 ( N_CLK_M154_noxref_g N_noxref_20_c_11059_n ) capacitor c=0.00230699f \
 //x=75.27 //y=6.2 //x2=75.05 //y2=5.335
cc_5649 ( N_CLK_c_6648_n N_noxref_20_c_11059_n ) capacitor c=0.00185356f \
 //x=75.195 //y=4.97 //x2=75.05 //y2=5.335
cc_5650 ( CLK N_noxref_20_c_11060_n ) capacitor c=0.0235216f //x=74.86 \
 //y=2.77 //x2=76.54 //y2=3.88
cc_5651 ( N_CLK_c_6627_n N_noxref_20_c_11060_n ) capacitor c=0.0203291f \
 //x=74.705 //y=4.62 //x2=76.54 //y2=3.88
cc_5652 ( CLK N_noxref_20_c_11174_n ) capacitor c=0.00209053f //x=65.24 \
 //y=4.62 //x2=66.51 //y2=3.895
cc_5653 ( N_CLK_c_6627_n N_noxref_20_c_11081_n ) capacitor c=0.0268805f \
 //x=74.705 //y=4.62 //x2=71 //y2=3.895
cc_5654 ( CLK N_noxref_20_c_11176_n ) capacitor c=3.9149e-19 //x=65.24 \
 //y=4.62 //x2=66.35 //y2=2.26
cc_5655 ( N_CLK_c_6860_n N_noxref_20_c_11176_n ) capacitor c=5.42289e-19 \
 //x=65.24 //y=2.375 //x2=66.35 //y2=2.26
cc_5656 ( N_CLK_c_6870_n N_noxref_20_c_11176_n ) capacitor c=0.00125213f \
 //x=65.24 //y=2.26 //x2=66.35 //y2=2.26
cc_5657 ( N_CLK_c_6889_n N_noxref_20_c_11176_n ) capacitor c=0.00209664f \
 //x=65.33 //y=2.095 //x2=66.35 //y2=2.26
cc_5658 ( N_CLK_c_6598_n N_noxref_20_c_11180_n ) capacitor c=7.52809e-19 \
 //x=65.235 //y=4.835 //x2=66.35 //y2=4.88
cc_5659 ( N_CLK_c_6874_n N_noxref_20_c_11180_n ) capacitor c=0.00113671f \
 //x=65.24 //y=4.88 //x2=66.35 //y2=4.88
cc_5660 ( N_CLK_c_6892_n N_noxref_20_c_11180_n ) capacitor c=9.77556e-19 \
 //x=65.24 //y=4.88 //x2=66.35 //y2=4.88
cc_5661 ( N_CLK_c_6601_n N_noxref_20_c_11183_n ) capacitor c=0.00148364f \
 //x=74.865 //y=4.835 //x2=75.05 //y2=5.56
cc_5662 ( N_CLK_M153_noxref_g N_noxref_20_c_11183_n ) capacitor c=0.0179041f \
 //x=74.83 //y=6.2 //x2=75.05 //y2=5.56
cc_5663 ( N_CLK_M154_noxref_g N_noxref_20_c_11183_n ) capacitor c=0.0179041f \
 //x=75.27 //y=6.2 //x2=75.05 //y2=5.56
cc_5664 ( N_CLK_c_6648_n N_noxref_20_c_11183_n ) capacitor c=0.00295522f \
 //x=75.195 //y=4.97 //x2=75.05 //y2=5.56
cc_5665 ( N_CLK_M141_noxref_g N_noxref_20_M143_noxref_g ) capacitor \
 c=0.010185f //x=65.21 //y=6.2 //x2=66.09 //y2=6.2
cc_5666 ( N_CLK_M142_noxref_g N_noxref_20_M143_noxref_g ) capacitor \
 c=0.0607295f //x=65.65 //y=6.2 //x2=66.09 //y2=6.2
cc_5667 ( N_CLK_M142_noxref_g N_noxref_20_M144_noxref_g ) capacitor \
 c=0.0101866f //x=65.65 //y=6.2 //x2=66.53 //y2=6.2
cc_5668 ( N_CLK_c_6886_n N_noxref_20_c_11190_n ) capacitor c=0.00456962f \
 //x=65.33 //y=1.09 //x2=66.34 //y2=1.095
cc_5669 ( N_CLK_c_6887_n N_noxref_20_c_11191_n ) capacitor c=0.00438372f \
 //x=65.33 //y=1.4 //x2=66.34 //y2=1.44
cc_5670 ( N_CLK_c_6888_n N_noxref_20_c_11192_n ) capacitor c=0.00438372f \
 //x=65.33 //y=1.63 //x2=66.34 //y2=1.75
cc_5671 ( N_CLK_c_6860_n N_noxref_20_c_11193_n ) capacitor c=0.00134951f \
 //x=65.24 //y=2.375 //x2=66.35 //y2=2.26
cc_5672 ( N_CLK_c_6870_n N_noxref_20_c_11193_n ) capacitor c=0.00204868f \
 //x=65.24 //y=2.26 //x2=66.35 //y2=2.26
cc_5673 ( N_CLK_c_6889_n N_noxref_20_c_11193_n ) capacitor c=0.00933826f \
 //x=65.33 //y=2.095 //x2=66.35 //y2=2.26
cc_5674 ( N_CLK_c_6889_n N_noxref_20_c_11196_n ) capacitor c=0.00438372f \
 //x=65.33 //y=2.095 //x2=66.35 //y2=2.095
cc_5675 ( N_CLK_c_6598_n N_noxref_20_c_11069_n ) capacitor c=0.0013272f \
 //x=65.235 //y=4.835 //x2=66.35 //y2=4.88
cc_5676 ( N_CLK_c_6874_n N_noxref_20_c_11069_n ) capacitor c=0.00186974f \
 //x=65.24 //y=4.88 //x2=66.35 //y2=4.88
cc_5677 ( N_CLK_c_6951_p N_noxref_20_c_11069_n ) capacitor c=0.0616554f \
 //x=65.575 //y=4.97 //x2=66.35 //y2=4.88
cc_5678 ( N_CLK_c_6892_n N_noxref_20_c_11069_n ) capacitor c=0.0042693f \
 //x=65.24 //y=4.88 //x2=66.35 //y2=4.88
cc_5679 ( N_CLK_c_6623_n N_noxref_22_c_12247_n ) capacitor c=0.0238948f \
 //x=59.19 //y=4.635 //x2=51.92 //y2=4.75
cc_5680 ( N_CLK_c_6623_n N_noxref_22_c_12248_n ) capacitor c=0.0235279f \
 //x=59.19 //y=4.635 //x2=57.47 //y2=5.25
cc_5681 ( N_CLK_c_6623_n N_noxref_22_c_12450_n ) capacitor c=7.08816e-19 \
 //x=59.19 //y=4.635 //x2=56.945 //y2=3.5
cc_5682 ( N_CLK_c_6623_n N_noxref_22_c_12480_n ) capacitor c=0.00448597f \
 //x=59.19 //y=4.635 //x2=58.935 //y2=3.88
cc_5683 ( N_CLK_c_6623_n N_noxref_22_c_12453_n ) capacitor c=0.00885409f \
 //x=59.19 //y=4.635 //x2=57.63 //y2=3.88
cc_5684 ( N_CLK_c_6840_n N_noxref_22_c_12271_n ) capacitor c=0.00448597f \
 //x=59.535 //y=4.635 //x2=59.535 //y2=3.865
cc_5685 ( N_CLK_c_6630_n N_noxref_22_c_12271_n ) capacitor c=0.0723411f \
 //x=65.395 //y=4.62 //x2=59.535 //y2=3.865
cc_5686 ( N_CLK_c_6630_n N_noxref_22_c_12272_n ) capacitor c=0.027361f \
 //x=65.395 //y=4.62 //x2=61.165 //y2=3.88
cc_5687 ( CLK N_noxref_22_c_12273_n ) capacitor c=0.0249706f //x=65.24 \
 //y=4.62 //x2=61.765 //y2=3.9
cc_5688 ( N_CLK_c_6630_n N_noxref_22_c_12273_n ) capacitor c=0.162541f \
 //x=65.395 //y=4.62 //x2=61.765 //y2=3.9
cc_5689 ( CLK N_noxref_22_c_12507_n ) capacitor c=0.0188231f //x=65.24 \
 //y=4.62 //x2=65.61 //y2=4.165
cc_5690 ( CLK N_noxref_22_c_12275_n ) capacitor c=8.02217e-19 //x=65.24 \
 //y=4.62 //x2=65.965 //y2=4.25
cc_5691 ( N_CLK_c_6627_n N_noxref_22_c_12275_n ) capacitor c=0.0574758f \
 //x=74.705 //y=4.62 //x2=65.965 //y2=4.25
cc_5692 ( N_CLK_c_6627_n N_noxref_22_c_12277_n ) capacitor c=0.0462231f \
 //x=74.705 //y=4.62 //x2=65.695 //y2=4.25
cc_5693 ( N_CLK_c_6627_n N_noxref_22_c_12278_n ) capacitor c=0.429099f \
 //x=74.705 //y=4.62 //x2=66.565 //y2=4.28
cc_5694 ( N_CLK_c_6627_n N_noxref_22_c_12279_n ) capacitor c=0.0130325f \
 //x=74.705 //y=4.62 //x2=71.375 //y2=4.31
cc_5695 ( CLK N_noxref_22_c_12280_n ) capacitor c=0.0234639f //x=74.86 \
 //y=2.77 //x2=76.315 //y2=4.25
cc_5696 ( N_CLK_c_6601_n N_noxref_22_c_12280_n ) capacitor c=0.00176629f \
 //x=74.865 //y=4.835 //x2=76.315 //y2=4.25
cc_5697 ( N_CLK_c_6627_n N_noxref_22_c_12280_n ) capacitor c=0.296163f \
 //x=74.705 //y=4.62 //x2=76.315 //y2=4.25
cc_5698 ( N_CLK_c_6633_n N_noxref_22_c_12280_n ) capacitor c=0.00492839f \
 //x=74.865 //y=4.62 //x2=76.315 //y2=4.25
cc_5699 ( N_CLK_M69_noxref_g N_VDD_c_13563_n ) capacitor c=0.00705252f \
 //x=7.49 //y=6.2 //x2=8.065 //y2=7.585
cc_5700 ( N_CLK_M70_noxref_g N_VDD_c_13563_n ) capacitor c=0.00755544f \
 //x=7.93 //y=6.2 //x2=8.065 //y2=7.585
cc_5701 ( N_CLK_M81_noxref_g N_VDD_c_13674_n ) capacitor c=0.00705252f \
 //x=17.11 //y=6.2 //x2=17.685 //y2=7.585
cc_5702 ( N_CLK_M82_noxref_g N_VDD_c_13674_n ) capacitor c=0.00755544f \
 //x=17.55 //y=6.2 //x2=17.685 //y2=7.585
cc_5703 ( N_CLK_M105_noxref_g N_VDD_c_13964_n ) capacitor c=0.00705252f \
 //x=36.35 //y=6.2 //x2=36.925 //y2=7.585
cc_5704 ( N_CLK_M106_noxref_g N_VDD_c_13964_n ) capacitor c=0.00755544f \
 //x=36.79 //y=6.2 //x2=36.925 //y2=7.585
cc_5705 ( N_CLK_M117_noxref_g N_VDD_c_14074_n ) capacitor c=0.00705252f \
 //x=45.97 //y=6.2 //x2=46.545 //y2=7.585
cc_5706 ( N_CLK_M118_noxref_g N_VDD_c_14074_n ) capacitor c=0.00755544f \
 //x=46.41 //y=6.2 //x2=46.545 //y2=7.585
cc_5707 ( N_CLK_M141_noxref_g N_VDD_c_14296_n ) capacitor c=0.00705252f \
 //x=65.21 //y=6.2 //x2=65.785 //y2=7.585
cc_5708 ( N_CLK_M142_noxref_g N_VDD_c_14296_n ) capacitor c=0.00755544f \
 //x=65.65 //y=6.2 //x2=65.785 //y2=7.585
cc_5709 ( N_CLK_M153_noxref_g N_VDD_c_14298_n ) capacitor c=0.00705252f \
 //x=74.83 //y=6.2 //x2=75.405 //y2=7.585
cc_5710 ( N_CLK_M154_noxref_g N_VDD_c_14298_n ) capacitor c=0.00755544f \
 //x=75.27 //y=6.2 //x2=75.405 //y2=7.585
cc_5711 ( N_CLK_c_6426_n N_VDD_c_13467_n ) capacitor c=0.0263783f //x=16.985 \
 //y=4.62 //x2=10.11 //y2=7.585
cc_5712 ( N_CLK_c_6426_n N_VDD_c_13521_n ) capacitor c=0.0265917f //x=16.985 \
 //y=4.62 //x2=14.92 //y2=7.585
cc_5713 ( N_CLK_c_6473_n N_VDD_c_13581_n ) capacitor c=0.0265917f //x=28.395 \
 //y=4.61 //x2=19.73 //y2=7.585
cc_5714 ( N_CLK_c_6473_n N_VDD_c_13631_n ) capacitor c=0.0265917f //x=28.395 \
 //y=4.61 //x2=24.54 //y2=7.585
cc_5715 ( N_CLK_c_6619_n N_VDD_c_13694_n ) capacitor c=0.0156563f //x=36.535 \
 //y=4.62 //x2=29.35 //y2=7.585
cc_5716 ( N_CLK_c_6619_n N_VDD_c_13773_n ) capacitor c=0.0157213f //x=36.535 \
 //y=4.62 //x2=34.16 //y2=7.585
cc_5717 ( N_CLK_c_6616_n N_VDD_c_13775_n ) capacitor c=0.0157213f //x=45.845 \
 //y=4.62 //x2=38.97 //y2=7.585
cc_5718 ( N_CLK_c_6616_n N_VDD_c_13776_n ) capacitor c=0.0157213f //x=45.845 \
 //y=4.62 //x2=43.78 //y2=7.585
cc_5719 ( N_CLK_c_6623_n N_VDD_c_13778_n ) capacitor c=0.0157213f //x=59.19 \
 //y=4.635 //x2=48.59 //y2=7.585
cc_5720 ( N_CLK_c_6623_n N_VDD_c_13779_n ) capacitor c=0.0157213f //x=59.19 \
 //y=4.635 //x2=53.4 //y2=7.585
cc_5721 ( N_CLK_c_6623_n N_VDD_c_13780_n ) capacitor c=0.0160747f //x=59.19 \
 //y=4.635 //x2=58.21 //y2=7.585
cc_5722 ( N_CLK_c_6630_n N_VDD_c_13781_n ) capacitor c=0.0147022f //x=65.395 \
 //y=4.62 //x2=63.02 //y2=7.585
cc_5723 ( N_CLK_c_6627_n N_VDD_c_13783_n ) capacitor c=0.0157213f //x=74.705 \
 //y=4.62 //x2=67.83 //y2=7.585
cc_5724 ( N_CLK_c_6627_n N_VDD_c_13784_n ) capacitor c=0.0155079f //x=74.705 \
 //y=4.62 //x2=72.64 //y2=7.585
cc_5725 ( N_CLK_M69_noxref_g N_VDD_M68_noxref_d ) capacitor c=0.015318f \
 //x=7.49 //y=6.2 //x2=7.125 //y2=5.2
cc_5726 ( N_CLK_M70_noxref_g N_VDD_M70_noxref_d ) capacitor c=0.015318f \
 //x=7.93 //y=6.2 //x2=8.005 //y2=5.2
cc_5727 ( N_CLK_c_6426_n N_VDD_M73_noxref_s ) capacitor c=8.56765e-19 \
 //x=16.985 //y=4.62 //x2=11.065 //y2=5.2
cc_5728 ( N_CLK_c_6426_n N_VDD_M79_noxref_s ) capacitor c=8.57911e-19 \
 //x=16.985 //y=4.62 //x2=15.875 //y2=5.2
cc_5729 ( N_CLK_M81_noxref_g N_VDD_M80_noxref_d ) capacitor c=0.015318f \
 //x=17.11 //y=6.2 //x2=16.745 //y2=5.2
cc_5730 ( N_CLK_M82_noxref_g N_VDD_M82_noxref_d ) capacitor c=0.015318f \
 //x=17.55 //y=6.2 //x2=17.625 //y2=5.2
cc_5731 ( N_CLK_c_6473_n N_VDD_M85_noxref_s ) capacitor c=7.81352e-19 \
 //x=28.395 //y=4.61 //x2=20.685 //y2=5.2
cc_5732 ( N_CLK_c_6473_n N_VDD_M91_noxref_s ) capacitor c=8.59047e-19 \
 //x=28.395 //y=4.61 //x2=25.495 //y2=5.2
cc_5733 ( N_CLK_M105_noxref_g N_VDD_M104_noxref_d ) capacitor c=0.015318f \
 //x=36.35 //y=6.2 //x2=35.985 //y2=5.2
cc_5734 ( N_CLK_M106_noxref_g N_VDD_M106_noxref_d ) capacitor c=0.015318f \
 //x=36.79 //y=6.2 //x2=36.865 //y2=5.2
cc_5735 ( N_CLK_M117_noxref_g N_VDD_M116_noxref_d ) capacitor c=0.015318f \
 //x=45.97 //y=6.2 //x2=45.605 //y2=5.2
cc_5736 ( N_CLK_M118_noxref_g N_VDD_M118_noxref_d ) capacitor c=0.015318f \
 //x=46.41 //y=6.2 //x2=46.485 //y2=5.2
cc_5737 ( N_CLK_M141_noxref_g N_VDD_M140_noxref_d ) capacitor c=0.015318f \
 //x=65.21 //y=6.2 //x2=64.845 //y2=5.2
cc_5738 ( N_CLK_M142_noxref_g N_VDD_M142_noxref_d ) capacitor c=0.015318f \
 //x=65.65 //y=6.2 //x2=65.725 //y2=5.2
cc_5739 ( N_CLK_M153_noxref_g N_VDD_M152_noxref_d ) capacitor c=0.015318f \
 //x=74.83 //y=6.2 //x2=74.465 //y2=5.2
cc_5740 ( N_CLK_M154_noxref_g N_VDD_M154_noxref_d ) capacitor c=0.015318f \
 //x=75.27 //y=6.2 //x2=75.345 //y2=5.2
cc_5741 ( N_CLK_c_6444_n N_noxref_27_c_14969_n ) capacitor c=0.00123426f \
 //x=7.61 //y=1.09 //x2=8.315 //y2=1.175
cc_5742 ( N_CLK_c_6445_n N_noxref_27_c_14969_n ) capacitor c=0.0129288f \
 //x=7.61 //y=1.4 //x2=8.315 //y2=1.175
cc_5743 ( N_CLK_c_6446_n N_noxref_27_c_14969_n ) capacitor c=0.00132209f \
 //x=7.61 //y=1.63 //x2=8.315 //y2=1.175
cc_5744 ( N_CLK_c_6419_n N_noxref_27_M4_noxref_d ) capacitor c=0.00600656f \
 //x=7.52 //y=2.375 //x2=7.16 //y2=1.09
cc_5745 ( N_CLK_c_6428_n N_noxref_27_M4_noxref_d ) capacitor c=2.2052e-19 \
 //x=7.52 //y=2.26 //x2=7.16 //y2=1.09
cc_5746 ( N_CLK_c_6439_n N_noxref_27_M4_noxref_d ) capacitor c=0.00253592f \
 //x=7.085 //y=1.09 //x2=7.16 //y2=1.09
cc_5747 ( N_CLK_c_6442_n N_noxref_27_M4_noxref_d ) capacitor c=0.00604087f \
 //x=7.085 //y=1.4 //x2=7.16 //y2=1.09
cc_5748 ( N_CLK_c_7222_p N_noxref_27_M4_noxref_d ) capacitor c=0.002686f \
 //x=7.455 //y=0.935 //x2=7.16 //y2=1.09
cc_5749 ( N_CLK_c_7223_p N_noxref_27_M4_noxref_d ) capacitor c=0.00251995f \
 //x=7.455 //y=1.555 //x2=7.16 //y2=1.09
cc_5750 ( N_CLK_c_6444_n N_noxref_27_M4_noxref_d ) capacitor c=0.00314523f \
 //x=7.61 //y=1.09 //x2=7.16 //y2=1.09
cc_5751 ( N_CLK_c_6445_n N_noxref_27_M4_noxref_d ) capacitor c=0.00168289f \
 //x=7.61 //y=1.4 //x2=7.16 //y2=1.09
cc_5752 ( N_CLK_c_6446_n N_noxref_27_M4_noxref_d ) capacitor c=0.00111165f \
 //x=7.61 //y=1.63 //x2=7.16 //y2=1.09
cc_5753 ( N_CLK_c_6444_n N_noxref_27_M5_noxref_s ) capacitor c=7.21316e-19 \
 //x=7.61 //y=1.09 //x2=8.265 //y2=0.555
cc_5754 ( N_CLK_c_6445_n N_noxref_27_M5_noxref_s ) capacitor c=0.00365271f \
 //x=7.61 //y=1.4 //x2=8.265 //y2=0.555
cc_5755 ( N_CLK_c_6447_n N_noxref_27_M5_noxref_s ) capacitor c=9.86711e-19 \
 //x=7.61 //y=2.095 //x2=8.265 //y2=0.555
cc_5756 ( N_CLK_c_6490_n N_noxref_29_c_15094_n ) capacitor c=0.00123426f \
 //x=17.23 //y=1.09 //x2=17.935 //y2=1.175
cc_5757 ( N_CLK_c_6491_n N_noxref_29_c_15094_n ) capacitor c=0.0129288f \
 //x=17.23 //y=1.4 //x2=17.935 //y2=1.175
cc_5758 ( N_CLK_c_6492_n N_noxref_29_c_15094_n ) capacitor c=0.00132209f \
 //x=17.23 //y=1.63 //x2=17.935 //y2=1.175
cc_5759 ( N_CLK_c_6461_n N_noxref_29_M10_noxref_d ) capacitor c=0.00600656f \
 //x=17.14 //y=2.375 //x2=16.78 //y2=1.09
cc_5760 ( N_CLK_c_6474_n N_noxref_29_M10_noxref_d ) capacitor c=2.2052e-19 \
 //x=17.14 //y=2.26 //x2=16.78 //y2=1.09
cc_5761 ( N_CLK_c_6485_n N_noxref_29_M10_noxref_d ) capacitor c=0.00253592f \
 //x=16.705 //y=1.09 //x2=16.78 //y2=1.09
cc_5762 ( N_CLK_c_6488_n N_noxref_29_M10_noxref_d ) capacitor c=0.00604087f \
 //x=16.705 //y=1.4 //x2=16.78 //y2=1.09
cc_5763 ( N_CLK_c_7237_p N_noxref_29_M10_noxref_d ) capacitor c=0.002686f \
 //x=17.075 //y=0.935 //x2=16.78 //y2=1.09
cc_5764 ( N_CLK_c_7238_p N_noxref_29_M10_noxref_d ) capacitor c=0.00251995f \
 //x=17.075 //y=1.555 //x2=16.78 //y2=1.09
cc_5765 ( N_CLK_c_6490_n N_noxref_29_M10_noxref_d ) capacitor c=0.00314523f \
 //x=17.23 //y=1.09 //x2=16.78 //y2=1.09
cc_5766 ( N_CLK_c_6491_n N_noxref_29_M10_noxref_d ) capacitor c=0.00168289f \
 //x=17.23 //y=1.4 //x2=16.78 //y2=1.09
cc_5767 ( N_CLK_c_6492_n N_noxref_29_M10_noxref_d ) capacitor c=0.00111165f \
 //x=17.23 //y=1.63 //x2=16.78 //y2=1.09
cc_5768 ( N_CLK_c_6490_n N_noxref_29_M11_noxref_s ) capacitor c=7.21316e-19 \
 //x=17.23 //y=1.09 //x2=17.885 //y2=0.555
cc_5769 ( N_CLK_c_6491_n N_noxref_29_M11_noxref_s ) capacitor c=0.00365271f \
 //x=17.23 //y=1.4 //x2=17.885 //y2=0.555
cc_5770 ( N_CLK_c_6493_n N_noxref_29_M11_noxref_s ) capacitor c=9.86711e-19 \
 //x=17.23 //y=2.095 //x2=17.885 //y2=0.555
cc_5771 ( N_CLK_c_6684_n N_noxref_33_c_15375_n ) capacitor c=0.00123426f \
 //x=36.47 //y=1.09 //x2=37.175 //y2=1.175
cc_5772 ( N_CLK_c_6685_n N_noxref_33_c_15375_n ) capacitor c=0.0129288f \
 //x=36.47 //y=1.4 //x2=37.175 //y2=1.175
cc_5773 ( N_CLK_c_6686_n N_noxref_33_c_15375_n ) capacitor c=0.00132209f \
 //x=36.47 //y=1.63 //x2=37.175 //y2=1.175
cc_5774 ( N_CLK_c_6658_n N_noxref_33_M22_noxref_d ) capacitor c=0.00600656f \
 //x=36.38 //y=2.375 //x2=36.02 //y2=1.09
cc_5775 ( N_CLK_c_6668_n N_noxref_33_M22_noxref_d ) capacitor c=2.2052e-19 \
 //x=36.38 //y=2.26 //x2=36.02 //y2=1.09
cc_5776 ( N_CLK_c_6679_n N_noxref_33_M22_noxref_d ) capacitor c=0.00253592f \
 //x=35.945 //y=1.09 //x2=36.02 //y2=1.09
cc_5777 ( N_CLK_c_6682_n N_noxref_33_M22_noxref_d ) capacitor c=0.00604087f \
 //x=35.945 //y=1.4 //x2=36.02 //y2=1.09
cc_5778 ( N_CLK_c_7252_p N_noxref_33_M22_noxref_d ) capacitor c=0.002686f \
 //x=36.315 //y=0.935 //x2=36.02 //y2=1.09
cc_5779 ( N_CLK_c_7253_p N_noxref_33_M22_noxref_d ) capacitor c=0.00251995f \
 //x=36.315 //y=1.555 //x2=36.02 //y2=1.09
cc_5780 ( N_CLK_c_6684_n N_noxref_33_M22_noxref_d ) capacitor c=0.00314523f \
 //x=36.47 //y=1.09 //x2=36.02 //y2=1.09
cc_5781 ( N_CLK_c_6685_n N_noxref_33_M22_noxref_d ) capacitor c=0.00168289f \
 //x=36.47 //y=1.4 //x2=36.02 //y2=1.09
cc_5782 ( N_CLK_c_6686_n N_noxref_33_M22_noxref_d ) capacitor c=0.00111165f \
 //x=36.47 //y=1.63 //x2=36.02 //y2=1.09
cc_5783 ( N_CLK_c_6684_n N_noxref_33_M23_noxref_s ) capacitor c=7.21316e-19 \
 //x=36.47 //y=1.09 //x2=37.125 //y2=0.555
cc_5784 ( N_CLK_c_6685_n N_noxref_33_M23_noxref_s ) capacitor c=0.00365271f \
 //x=36.47 //y=1.4 //x2=37.125 //y2=0.555
cc_5785 ( N_CLK_c_6687_n N_noxref_33_M23_noxref_s ) capacitor c=9.86711e-19 \
 //x=36.47 //y=2.095 //x2=37.125 //y2=0.555
cc_5786 ( N_CLK_c_6727_n N_noxref_35_c_15500_n ) capacitor c=0.00123426f \
 //x=46.09 //y=1.09 //x2=46.795 //y2=1.175
cc_5787 ( N_CLK_c_6728_n N_noxref_35_c_15500_n ) capacitor c=0.0129288f \
 //x=46.09 //y=1.4 //x2=46.795 //y2=1.175
cc_5788 ( N_CLK_c_6729_n N_noxref_35_c_15500_n ) capacitor c=0.00132209f \
 //x=46.09 //y=1.63 //x2=46.795 //y2=1.175
cc_5789 ( N_CLK_c_6701_n N_noxref_35_M28_noxref_d ) capacitor c=0.00600656f \
 //x=46 //y=2.375 //x2=45.64 //y2=1.09
cc_5790 ( N_CLK_c_6711_n N_noxref_35_M28_noxref_d ) capacitor c=2.2052e-19 \
 //x=46 //y=2.26 //x2=45.64 //y2=1.09
cc_5791 ( N_CLK_c_6722_n N_noxref_35_M28_noxref_d ) capacitor c=0.00253592f \
 //x=45.565 //y=1.09 //x2=45.64 //y2=1.09
cc_5792 ( N_CLK_c_6725_n N_noxref_35_M28_noxref_d ) capacitor c=0.00604087f \
 //x=45.565 //y=1.4 //x2=45.64 //y2=1.09
cc_5793 ( N_CLK_c_7267_p N_noxref_35_M28_noxref_d ) capacitor c=0.002686f \
 //x=45.935 //y=0.935 //x2=45.64 //y2=1.09
cc_5794 ( N_CLK_c_7268_p N_noxref_35_M28_noxref_d ) capacitor c=0.00251995f \
 //x=45.935 //y=1.555 //x2=45.64 //y2=1.09
cc_5795 ( N_CLK_c_6727_n N_noxref_35_M28_noxref_d ) capacitor c=0.00314523f \
 //x=46.09 //y=1.09 //x2=45.64 //y2=1.09
cc_5796 ( N_CLK_c_6728_n N_noxref_35_M28_noxref_d ) capacitor c=0.00168289f \
 //x=46.09 //y=1.4 //x2=45.64 //y2=1.09
cc_5797 ( N_CLK_c_6729_n N_noxref_35_M28_noxref_d ) capacitor c=0.00111165f \
 //x=46.09 //y=1.63 //x2=45.64 //y2=1.09
cc_5798 ( N_CLK_c_6727_n N_noxref_35_M29_noxref_s ) capacitor c=7.21316e-19 \
 //x=46.09 //y=1.09 //x2=46.745 //y2=0.555
cc_5799 ( N_CLK_c_6728_n N_noxref_35_M29_noxref_s ) capacitor c=0.00365271f \
 //x=46.09 //y=1.4 //x2=46.745 //y2=0.555
cc_5800 ( N_CLK_c_6730_n N_noxref_35_M29_noxref_s ) capacitor c=9.86711e-19 \
 //x=46.09 //y=2.095 //x2=46.745 //y2=0.555
cc_5801 ( N_CLK_c_6886_n N_noxref_39_c_15760_n ) capacitor c=0.00123426f \
 //x=65.33 //y=1.09 //x2=66.035 //y2=1.175
cc_5802 ( N_CLK_c_6887_n N_noxref_39_c_15760_n ) capacitor c=0.0129288f \
 //x=65.33 //y=1.4 //x2=66.035 //y2=1.175
cc_5803 ( N_CLK_c_6888_n N_noxref_39_c_15760_n ) capacitor c=0.00132209f \
 //x=65.33 //y=1.63 //x2=66.035 //y2=1.175
cc_5804 ( N_CLK_c_6860_n N_noxref_39_M40_noxref_d ) capacitor c=0.00600656f \
 //x=65.24 //y=2.375 //x2=64.88 //y2=1.09
cc_5805 ( N_CLK_c_6870_n N_noxref_39_M40_noxref_d ) capacitor c=2.2052e-19 \
 //x=65.24 //y=2.26 //x2=64.88 //y2=1.09
cc_5806 ( N_CLK_c_6881_n N_noxref_39_M40_noxref_d ) capacitor c=0.00253592f \
 //x=64.805 //y=1.09 //x2=64.88 //y2=1.09
cc_5807 ( N_CLK_c_6884_n N_noxref_39_M40_noxref_d ) capacitor c=0.00604087f \
 //x=64.805 //y=1.4 //x2=64.88 //y2=1.09
cc_5808 ( N_CLK_c_7282_p N_noxref_39_M40_noxref_d ) capacitor c=0.002686f \
 //x=65.175 //y=0.935 //x2=64.88 //y2=1.09
cc_5809 ( N_CLK_c_7283_p N_noxref_39_M40_noxref_d ) capacitor c=0.00251995f \
 //x=65.175 //y=1.555 //x2=64.88 //y2=1.09
cc_5810 ( N_CLK_c_6886_n N_noxref_39_M40_noxref_d ) capacitor c=0.00314523f \
 //x=65.33 //y=1.09 //x2=64.88 //y2=1.09
cc_5811 ( N_CLK_c_6887_n N_noxref_39_M40_noxref_d ) capacitor c=0.00168289f \
 //x=65.33 //y=1.4 //x2=64.88 //y2=1.09
cc_5812 ( N_CLK_c_6888_n N_noxref_39_M40_noxref_d ) capacitor c=0.00111165f \
 //x=65.33 //y=1.63 //x2=64.88 //y2=1.09
cc_5813 ( N_CLK_c_6886_n N_noxref_39_M41_noxref_s ) capacitor c=7.21316e-19 \
 //x=65.33 //y=1.09 //x2=65.985 //y2=0.555
cc_5814 ( N_CLK_c_6887_n N_noxref_39_M41_noxref_s ) capacitor c=0.00365271f \
 //x=65.33 //y=1.4 //x2=65.985 //y2=0.555
cc_5815 ( N_CLK_c_6889_n N_noxref_39_M41_noxref_s ) capacitor c=9.86711e-19 \
 //x=65.33 //y=2.095 //x2=65.985 //y2=0.555
cc_5816 ( N_CLK_c_6929_n N_noxref_41_c_15895_n ) capacitor c=0.00123426f \
 //x=74.95 //y=1.09 //x2=75.655 //y2=1.175
cc_5817 ( N_CLK_c_6930_n N_noxref_41_c_15895_n ) capacitor c=0.0129288f \
 //x=74.95 //y=1.4 //x2=75.655 //y2=1.175
cc_5818 ( N_CLK_c_6931_n N_noxref_41_c_15895_n ) capacitor c=0.00132209f \
 //x=74.95 //y=1.63 //x2=75.655 //y2=1.175
cc_5819 ( N_CLK_c_6903_n N_noxref_41_M46_noxref_d ) capacitor c=0.00600656f \
 //x=74.86 //y=2.375 //x2=74.5 //y2=1.09
cc_5820 ( N_CLK_c_6913_n N_noxref_41_M46_noxref_d ) capacitor c=2.2052e-19 \
 //x=74.86 //y=2.26 //x2=74.5 //y2=1.09
cc_5821 ( N_CLK_c_6924_n N_noxref_41_M46_noxref_d ) capacitor c=0.00253592f \
 //x=74.425 //y=1.09 //x2=74.5 //y2=1.09
cc_5822 ( N_CLK_c_6927_n N_noxref_41_M46_noxref_d ) capacitor c=0.00604087f \
 //x=74.425 //y=1.4 //x2=74.5 //y2=1.09
cc_5823 ( N_CLK_c_7297_p N_noxref_41_M46_noxref_d ) capacitor c=0.002686f \
 //x=74.795 //y=0.935 //x2=74.5 //y2=1.09
cc_5824 ( N_CLK_c_7298_p N_noxref_41_M46_noxref_d ) capacitor c=0.00251995f \
 //x=74.795 //y=1.555 //x2=74.5 //y2=1.09
cc_5825 ( N_CLK_c_6929_n N_noxref_41_M46_noxref_d ) capacitor c=0.00314523f \
 //x=74.95 //y=1.09 //x2=74.5 //y2=1.09
cc_5826 ( N_CLK_c_6930_n N_noxref_41_M46_noxref_d ) capacitor c=0.00168289f \
 //x=74.95 //y=1.4 //x2=74.5 //y2=1.09
cc_5827 ( N_CLK_c_6931_n N_noxref_41_M46_noxref_d ) capacitor c=0.00111165f \
 //x=74.95 //y=1.63 //x2=74.5 //y2=1.09
cc_5828 ( N_CLK_c_6929_n N_noxref_41_M47_noxref_s ) capacitor c=7.21316e-19 \
 //x=74.95 //y=1.09 //x2=75.605 //y2=0.555
cc_5829 ( N_CLK_c_6930_n N_noxref_41_M47_noxref_s ) capacitor c=0.00365271f \
 //x=74.95 //y=1.4 //x2=75.605 //y2=0.555
cc_5830 ( N_CLK_c_6932_n N_noxref_41_M47_noxref_s ) capacitor c=9.86711e-19 \
 //x=74.95 //y=2.095 //x2=75.605 //y2=0.555
cc_5831 ( N_CLK_c_6419_n N_GND_c_16501_n ) capacitor c=7.99941e-19 //x=7.52 \
 //y=2.375 //x2=11.1 //y2=0.175
cc_5832 ( N_CLK_c_6461_n N_GND_c_16584_n ) capacitor c=7.99941e-19 //x=17.14 \
 //y=2.375 //x2=20.72 //y2=0.175
cc_5833 ( N_CLK_c_6658_n N_GND_c_16769_n ) capacitor c=7.99941e-19 //x=36.38 \
 //y=2.375 //x2=39.96 //y2=0.175
cc_5834 ( N_CLK_c_6701_n N_GND_c_16850_n ) capacitor c=7.99941e-19 //x=46 \
 //y=2.375 //x2=49.58 //y2=0.175
cc_5835 ( N_CLK_c_6860_n N_GND_c_17063_n ) capacitor c=7.99941e-19 //x=65.24 \
 //y=2.375 //x2=68.82 //y2=0.175
cc_5836 ( N_CLK_c_6903_n N_GND_c_17064_n ) capacitor c=7.9993e-19 //x=74.86 \
 //y=2.375 //x2=78.44 //y2=0.175
cc_5837 ( N_CLK_c_6439_n N_noxref_48_c_18202_n ) capacitor c=0.0167228f \
 //x=7.085 //y=1.09 //x2=7.745 //y2=0.72
cc_5838 ( N_CLK_c_6444_n N_noxref_48_c_18202_n ) capacitor c=0.00534519f \
 //x=7.61 //y=1.09 //x2=7.745 //y2=0.72
cc_5839 ( N_CLK_c_6419_n N_noxref_48_c_18204_n ) capacitor c=0.0048147f \
 //x=7.52 //y=2.375 //x2=7.745 //y2=1.77
cc_5840 ( N_CLK_c_6422_n N_noxref_48_c_18204_n ) capacitor c=8.72493e-19 \
 //x=7.515 //y=4.835 //x2=7.745 //y2=1.77
cc_5841 ( N_CLK_c_6428_n N_noxref_48_c_18204_n ) capacitor c=0.0105652f \
 //x=7.52 //y=2.26 //x2=7.745 //y2=1.77
cc_5842 ( N_CLK_c_6442_n N_noxref_48_c_18204_n ) capacitor c=0.0153476f \
 //x=7.085 //y=1.4 //x2=7.745 //y2=1.77
cc_5843 ( N_CLK_c_6447_n N_noxref_48_c_18204_n ) capacitor c=0.0216832f \
 //x=7.61 //y=2.095 //x2=7.745 //y2=1.77
cc_5844 ( N_CLK_c_6439_n N_noxref_48_M3_noxref_s ) capacitor c=0.00798959f \
 //x=7.085 //y=1.09 //x2=5.755 //y2=0.555
cc_5845 ( N_CLK_c_6446_n N_noxref_48_M3_noxref_s ) capacitor c=0.00212176f \
 //x=7.61 //y=1.63 //x2=5.755 //y2=0.555
cc_5846 ( N_CLK_c_6447_n N_noxref_48_M3_noxref_s ) capacitor c=0.00298115f \
 //x=7.61 //y=2.095 //x2=5.755 //y2=0.555
cc_5847 ( N_CLK_c_6485_n N_noxref_50_c_18317_n ) capacitor c=0.0167228f \
 //x=16.705 //y=1.09 //x2=17.365 //y2=0.72
cc_5848 ( N_CLK_c_6490_n N_noxref_50_c_18317_n ) capacitor c=0.00534519f \
 //x=17.23 //y=1.09 //x2=17.365 //y2=0.72
cc_5849 ( N_CLK_c_6461_n N_noxref_50_c_18319_n ) capacitor c=0.0048147f \
 //x=17.14 //y=2.375 //x2=17.365 //y2=1.77
cc_5850 ( N_CLK_c_6464_n N_noxref_50_c_18319_n ) capacitor c=0.00102459f \
 //x=17.145 //y=4.835 //x2=17.365 //y2=1.77
cc_5851 ( N_CLK_c_6474_n N_noxref_50_c_18319_n ) capacitor c=0.0105652f \
 //x=17.14 //y=2.26 //x2=17.365 //y2=1.77
cc_5852 ( N_CLK_c_6488_n N_noxref_50_c_18319_n ) capacitor c=0.0153476f \
 //x=16.705 //y=1.4 //x2=17.365 //y2=1.77
cc_5853 ( N_CLK_c_6493_n N_noxref_50_c_18319_n ) capacitor c=0.019963f \
 //x=17.23 //y=2.095 //x2=17.365 //y2=1.77
cc_5854 ( N_CLK_c_6485_n N_noxref_50_M9_noxref_s ) capacitor c=0.00798959f \
 //x=16.705 //y=1.09 //x2=15.375 //y2=0.555
cc_5855 ( N_CLK_c_6492_n N_noxref_50_M9_noxref_s ) capacitor c=0.00212176f \
 //x=17.23 //y=1.63 //x2=15.375 //y2=0.555
cc_5856 ( N_CLK_c_6493_n N_noxref_50_M9_noxref_s ) capacitor c=0.00298115f \
 //x=17.23 //y=2.095 //x2=15.375 //y2=0.555
cc_5857 ( N_CLK_c_6679_n N_noxref_54_c_18549_n ) capacitor c=0.0167228f \
 //x=35.945 //y=1.09 //x2=36.605 //y2=0.72
cc_5858 ( N_CLK_c_6684_n N_noxref_54_c_18549_n ) capacitor c=0.00534519f \
 //x=36.47 //y=1.09 //x2=36.605 //y2=0.72
cc_5859 ( N_CLK_c_6658_n N_noxref_54_c_18551_n ) capacitor c=0.0048147f \
 //x=36.38 //y=2.375 //x2=36.605 //y2=1.77
cc_5860 ( N_CLK_c_6592_n N_noxref_54_c_18551_n ) capacitor c=8.72493e-19 \
 //x=36.375 //y=4.835 //x2=36.605 //y2=1.77
cc_5861 ( N_CLK_c_6668_n N_noxref_54_c_18551_n ) capacitor c=0.0105652f \
 //x=36.38 //y=2.26 //x2=36.605 //y2=1.77
cc_5862 ( N_CLK_c_6682_n N_noxref_54_c_18551_n ) capacitor c=0.0153476f \
 //x=35.945 //y=1.4 //x2=36.605 //y2=1.77
cc_5863 ( N_CLK_c_6687_n N_noxref_54_c_18551_n ) capacitor c=0.019963f \
 //x=36.47 //y=2.095 //x2=36.605 //y2=1.77
cc_5864 ( N_CLK_c_6679_n N_noxref_54_M21_noxref_s ) capacitor c=0.00798959f \
 //x=35.945 //y=1.09 //x2=34.615 //y2=0.555
cc_5865 ( N_CLK_c_6686_n N_noxref_54_M21_noxref_s ) capacitor c=0.00212176f \
 //x=36.47 //y=1.63 //x2=34.615 //y2=0.555
cc_5866 ( N_CLK_c_6687_n N_noxref_54_M21_noxref_s ) capacitor c=0.00298115f \
 //x=36.47 //y=2.095 //x2=34.615 //y2=0.555
cc_5867 ( N_CLK_c_6722_n N_noxref_56_c_18664_n ) capacitor c=0.0167228f \
 //x=45.565 //y=1.09 //x2=46.225 //y2=0.72
cc_5868 ( N_CLK_c_6727_n N_noxref_56_c_18664_n ) capacitor c=0.00534519f \
 //x=46.09 //y=1.09 //x2=46.225 //y2=0.72
cc_5869 ( N_CLK_c_6701_n N_noxref_56_c_18666_n ) capacitor c=0.0048147f //x=46 \
 //y=2.375 //x2=46.225 //y2=1.77
cc_5870 ( N_CLK_c_6595_n N_noxref_56_c_18666_n ) capacitor c=0.00102459f \
 //x=46.005 //y=4.835 //x2=46.225 //y2=1.77
cc_5871 ( N_CLK_c_6711_n N_noxref_56_c_18666_n ) capacitor c=0.0105652f //x=46 \
 //y=2.26 //x2=46.225 //y2=1.77
cc_5872 ( N_CLK_c_6725_n N_noxref_56_c_18666_n ) capacitor c=0.0153476f \
 //x=45.565 //y=1.4 //x2=46.225 //y2=1.77
cc_5873 ( N_CLK_c_6730_n N_noxref_56_c_18666_n ) capacitor c=0.019963f \
 //x=46.09 //y=2.095 //x2=46.225 //y2=1.77
cc_5874 ( N_CLK_c_6722_n N_noxref_56_M27_noxref_s ) capacitor c=0.00798959f \
 //x=45.565 //y=1.09 //x2=44.235 //y2=0.555
cc_5875 ( N_CLK_c_6729_n N_noxref_56_M27_noxref_s ) capacitor c=0.00212176f \
 //x=46.09 //y=1.63 //x2=44.235 //y2=0.555
cc_5876 ( N_CLK_c_6730_n N_noxref_56_M27_noxref_s ) capacitor c=0.00298115f \
 //x=46.09 //y=2.095 //x2=44.235 //y2=0.555
cc_5877 ( N_CLK_c_6881_n N_noxref_60_c_18896_n ) capacitor c=0.0167228f \
 //x=64.805 //y=1.09 //x2=65.465 //y2=0.72
cc_5878 ( N_CLK_c_6886_n N_noxref_60_c_18896_n ) capacitor c=0.00534519f \
 //x=65.33 //y=1.09 //x2=65.465 //y2=0.72
cc_5879 ( N_CLK_c_6860_n N_noxref_60_c_18898_n ) capacitor c=0.0048147f \
 //x=65.24 //y=2.375 //x2=65.465 //y2=1.77
cc_5880 ( N_CLK_c_6598_n N_noxref_60_c_18898_n ) capacitor c=8.72493e-19 \
 //x=65.235 //y=4.835 //x2=65.465 //y2=1.77
cc_5881 ( N_CLK_c_6870_n N_noxref_60_c_18898_n ) capacitor c=0.0105652f \
 //x=65.24 //y=2.26 //x2=65.465 //y2=1.77
cc_5882 ( N_CLK_c_6884_n N_noxref_60_c_18898_n ) capacitor c=0.0153476f \
 //x=64.805 //y=1.4 //x2=65.465 //y2=1.77
cc_5883 ( N_CLK_c_6889_n N_noxref_60_c_18898_n ) capacitor c=0.0216832f \
 //x=65.33 //y=2.095 //x2=65.465 //y2=1.77
cc_5884 ( N_CLK_c_6881_n N_noxref_60_M39_noxref_s ) capacitor c=0.00798959f \
 //x=64.805 //y=1.09 //x2=63.475 //y2=0.555
cc_5885 ( N_CLK_c_6888_n N_noxref_60_M39_noxref_s ) capacitor c=0.00212176f \
 //x=65.33 //y=1.63 //x2=63.475 //y2=0.555
cc_5886 ( N_CLK_c_6889_n N_noxref_60_M39_noxref_s ) capacitor c=0.00298115f \
 //x=65.33 //y=2.095 //x2=63.475 //y2=0.555
cc_5887 ( N_CLK_c_6924_n N_noxref_62_c_19011_n ) capacitor c=0.0167228f \
 //x=74.425 //y=1.09 //x2=75.085 //y2=0.72
cc_5888 ( N_CLK_c_6929_n N_noxref_62_c_19011_n ) capacitor c=0.00534519f \
 //x=74.95 //y=1.09 //x2=75.085 //y2=0.72
cc_5889 ( N_CLK_c_6903_n N_noxref_62_c_19013_n ) capacitor c=0.0048147f \
 //x=74.86 //y=2.375 //x2=75.085 //y2=1.77
cc_5890 ( N_CLK_c_6601_n N_noxref_62_c_19013_n ) capacitor c=0.00102459f \
 //x=74.865 //y=4.835 //x2=75.085 //y2=1.77
cc_5891 ( N_CLK_c_6913_n N_noxref_62_c_19013_n ) capacitor c=0.0105652f \
 //x=74.86 //y=2.26 //x2=75.085 //y2=1.77
cc_5892 ( N_CLK_c_6927_n N_noxref_62_c_19013_n ) capacitor c=0.0153476f \
 //x=74.425 //y=1.4 //x2=75.085 //y2=1.77
cc_5893 ( N_CLK_c_6932_n N_noxref_62_c_19013_n ) capacitor c=0.019963f \
 //x=74.95 //y=2.095 //x2=75.085 //y2=1.77
cc_5894 ( N_CLK_c_6924_n N_noxref_62_M45_noxref_s ) capacitor c=0.00798959f \
 //x=74.425 //y=1.09 //x2=73.095 //y2=0.555
cc_5895 ( N_CLK_c_6931_n N_noxref_62_M45_noxref_s ) capacitor c=0.00212176f \
 //x=74.95 //y=1.63 //x2=73.095 //y2=0.555
cc_5896 ( N_CLK_c_6932_n N_noxref_62_M45_noxref_s ) capacitor c=0.00298115f \
 //x=74.95 //y=2.095 //x2=73.095 //y2=0.555
cc_5897 ( N_noxref_16_c_7385_n RN ) capacitor c=0.0204772f //x=61.54 //y=3.355 \
 //x2=60.43 //y2=2.77
cc_5898 ( N_noxref_16_c_7396_n RN ) capacitor c=0.00763467f //x=61.54 \
 //y=3.675 //x2=60.43 //y2=2.77
cc_5899 ( N_noxref_16_c_7371_n RN ) capacitor c=0.0265707f //x=61.54 //y=4.75 \
 //x2=60.43 //y2=2.77
cc_5900 ( N_noxref_16_c_7416_n RN ) capacitor c=2.98349e-19 //x=61.54 //y=3.51 \
 //x2=60.43 //y2=2.77
cc_5901 ( N_noxref_16_c_7424_n RN ) capacitor c=0.00504602f //x=61.71 \
 //y=3.515 //x2=60.43 //y2=2.77
cc_5902 ( N_noxref_16_c_7431_n RN ) capacitor c=2.94497e-19 //x=61.54 //y=4.88 \
 //x2=60.43 //y2=2.77
cc_5903 ( N_noxref_16_c_7501_p RN ) capacitor c=0.00148823f //x=78.56 //y=3.35 \
 //x2=75.97 //y2=2.77
cc_5904 ( N_noxref_16_c_7378_n RN ) capacitor c=0.00146042f //x=78.56 \
 //y=4.755 //x2=75.97 //y2=2.77
cc_5905 ( N_noxref_16_c_7422_n RN ) capacitor c=0.0220806f //x=78.395 //y=3.51 \
 //x2=75.97 //y2=2.77
cc_5906 ( N_noxref_16_c_7501_p RN ) capacitor c=0.0204302f //x=78.56 //y=3.35 \
 //x2=79.67 //y2=2.77
cc_5907 ( N_noxref_16_c_7505_p RN ) capacitor c=0.00769355f //x=78.56 //y=3.67 \
 //x2=79.67 //y2=2.77
cc_5908 ( N_noxref_16_c_7378_n RN ) capacitor c=0.0242555f //x=78.56 //y=4.755 \
 //x2=79.67 //y2=2.77
cc_5909 ( N_noxref_16_c_7507_p RN ) capacitor c=3.35971e-19 //x=78.555 \
 //y=3.51 //x2=79.67 //y2=2.77
cc_5910 ( N_noxref_16_c_7508_p RN ) capacitor c=0.00506355f //x=78.555 \
 //y=3.51 //x2=79.67 //y2=2.77
cc_5911 ( N_noxref_16_c_7509_p RN ) capacitor c=3.36194e-19 //x=78.56 //y=4.88 \
 //x2=79.67 //y2=2.77
cc_5912 ( N_noxref_16_c_7388_n N_RN_c_8476_n ) capacitor c=0.00806473f \
 //x=61.54 //y=2.375 //x2=60.43 //y2=2.56
cc_5913 ( N_noxref_16_c_7385_n N_RN_c_8476_n ) capacitor c=0.00361597f \
 //x=61.54 //y=3.355 //x2=60.43 //y2=2.56
cc_5914 ( N_noxref_16_c_7430_n N_RN_c_8476_n ) capacitor c=0.00116634f \
 //x=61.54 //y=2.26 //x2=60.43 //y2=2.56
cc_5915 ( N_noxref_16_c_7462_n N_RN_c_8476_n ) capacitor c=0.00149512f \
 //x=61.54 //y=2.26 //x2=60.43 //y2=2.56
cc_5916 ( N_noxref_16_c_7371_n N_RN_c_8127_n ) capacitor c=0.00753615f \
 //x=61.54 //y=4.75 //x2=60.43 //y2=4.765
cc_5917 ( N_noxref_16_c_7431_n N_RN_c_8127_n ) capacitor c=4.41153e-19 \
 //x=61.54 //y=4.88 //x2=60.43 //y2=4.765
cc_5918 ( N_noxref_16_c_7384_n N_RN_c_8127_n ) capacitor c=0.00118533f \
 //x=61.54 //y=4.88 //x2=60.43 //y2=4.765
cc_5919 ( N_noxref_16_c_7517_p N_RN_c_8772_n ) capacitor c=0.00802134f \
 //x=78.56 //y=2.375 //x2=79.67 //y2=2.57
cc_5920 ( N_noxref_16_c_7501_p N_RN_c_8772_n ) capacitor c=0.00387426f \
 //x=78.56 //y=3.35 //x2=79.67 //y2=2.57
cc_5921 ( N_noxref_16_c_7519_p N_RN_c_8772_n ) capacitor c=0.00116826f \
 //x=78.56 //y=2.26 //x2=79.67 //y2=2.57
cc_5922 ( N_noxref_16_c_7520_p N_RN_c_8772_n ) capacitor c=0.00158832f \
 //x=78.26 //y=2.095 //x2=79.67 //y2=2.57
cc_5923 ( N_noxref_16_c_7378_n N_RN_c_8131_n ) capacitor c=0.0110307f \
 //x=78.56 //y=4.755 //x2=79.67 //y2=4.765
cc_5924 ( N_noxref_16_c_7509_p N_RN_c_8131_n ) capacitor c=2.89813e-19 \
 //x=78.56 //y=4.88 //x2=79.67 //y2=4.765
cc_5925 ( N_noxref_16_c_7523_p N_RN_c_8131_n ) capacitor c=7.66769e-19 \
 //x=79.125 //y=4.97 //x2=79.67 //y2=4.765
cc_5926 ( N_noxref_16_c_7524_p N_RN_c_8131_n ) capacitor c=7.54501e-19 \
 //x=78.835 //y=4.97 //x2=79.67 //y2=4.765
cc_5927 ( N_noxref_16_c_7388_n N_RN_c_8353_n ) capacitor c=0.0174431f \
 //x=61.54 //y=2.375 //x2=71.685 //y2=2.385
cc_5928 ( N_noxref_16_c_7385_n N_RN_c_8353_n ) capacitor c=0.0166553f \
 //x=61.54 //y=3.355 //x2=71.685 //y2=2.385
cc_5929 ( N_noxref_16_c_7527_p N_RN_c_8353_n ) capacitor c=7.15814e-19 \
 //x=66.605 //y=1.305 //x2=71.685 //y2=2.385
cc_5930 ( N_noxref_16_c_7407_n N_RN_c_8353_n ) capacitor c=0.0211903f \
 //x=66.69 //y=1.845 //x2=71.685 //y2=2.385
cc_5931 ( N_noxref_16_c_7408_n N_RN_c_8353_n ) capacitor c=0.0277836f \
 //x=67.09 //y=3.335 //x2=71.685 //y2=2.385
cc_5932 ( N_noxref_16_c_7422_n N_RN_c_8353_n ) capacitor c=0.0144654f \
 //x=78.395 //y=3.51 //x2=71.685 //y2=2.385
cc_5933 ( N_noxref_16_c_7425_n N_RN_c_8353_n ) capacitor c=0.00220308f \
 //x=66.93 //y=3.495 //x2=71.685 //y2=2.385
cc_5934 ( N_noxref_16_c_7462_n N_RN_c_8353_n ) capacitor c=3.41298e-19 \
 //x=61.54 //y=2.26 //x2=71.685 //y2=2.385
cc_5935 ( N_noxref_16_c_7422_n N_RN_c_8622_n ) capacitor c=8.6713e-19 \
 //x=78.395 //y=3.51 //x2=73.975 //y2=2.385
cc_5936 ( N_noxref_16_c_7422_n N_RN_c_8628_n ) capacitor c=0.00983057f \
 //x=78.395 //y=3.51 //x2=76.135 //y2=2.4
cc_5937 ( N_noxref_16_c_7517_p N_RN_c_8790_n ) capacitor c=0.00149687f \
 //x=78.56 //y=2.375 //x2=79.665 //y2=2.41
cc_5938 ( N_noxref_16_c_7501_p N_RN_c_8790_n ) capacitor c=0.00137876f \
 //x=78.56 //y=3.35 //x2=79.665 //y2=2.41
cc_5939 ( N_noxref_16_c_7517_p N_RN_c_8792_n ) capacitor c=0.0165384f \
 //x=78.56 //y=2.375 //x2=79.505 //y2=2.41
cc_5940 ( N_noxref_16_c_7501_p N_RN_c_8792_n ) capacitor c=0.0167844f \
 //x=78.56 //y=3.35 //x2=79.505 //y2=2.41
cc_5941 ( N_noxref_16_c_7422_n N_RN_c_8792_n ) capacitor c=0.0101903f \
 //x=78.395 //y=3.51 //x2=79.505 //y2=2.41
cc_5942 ( N_noxref_16_c_7519_p N_RN_c_8792_n ) capacitor c=2.54369e-19 \
 //x=78.56 //y=2.26 //x2=79.505 //y2=2.41
cc_5943 ( N_noxref_16_c_7520_p N_RN_c_8792_n ) capacitor c=3.41298e-19 \
 //x=78.26 //y=2.095 //x2=79.505 //y2=2.41
cc_5944 ( N_noxref_16_c_7388_n N_RN_c_8513_n ) capacitor c=5.39999e-19 \
 //x=61.54 //y=2.375 //x2=60.43 //y2=2.26
cc_5945 ( N_noxref_16_c_7430_n N_RN_c_8513_n ) capacitor c=0.00124907f \
 //x=61.54 //y=2.26 //x2=60.43 //y2=2.26
cc_5946 ( N_noxref_16_c_7462_n N_RN_c_8513_n ) capacitor c=0.00204796f \
 //x=61.54 //y=2.26 //x2=60.43 //y2=2.26
cc_5947 ( N_noxref_16_c_7371_n N_RN_c_8152_n ) capacitor c=9.36945e-19 \
 //x=61.54 //y=4.75 //x2=60.43 //y2=4.88
cc_5948 ( N_noxref_16_c_7431_n N_RN_c_8152_n ) capacitor c=0.00113985f \
 //x=61.54 //y=4.88 //x2=60.43 //y2=4.88
cc_5949 ( N_noxref_16_c_7384_n N_RN_c_8152_n ) capacitor c=0.00187046f \
 //x=61.54 //y=4.88 //x2=60.43 //y2=4.88
cc_5950 ( N_noxref_16_c_7517_p N_RN_c_8803_n ) capacitor c=5.39999e-19 \
 //x=78.56 //y=2.375 //x2=79.67 //y2=2.26
cc_5951 ( N_noxref_16_c_7519_p N_RN_c_8803_n ) capacitor c=0.00124906f \
 //x=78.56 //y=2.26 //x2=79.67 //y2=2.26
cc_5952 ( N_noxref_16_c_7520_p N_RN_c_8803_n ) capacitor c=0.00214501f \
 //x=78.26 //y=2.095 //x2=79.67 //y2=2.26
cc_5953 ( N_noxref_16_c_7378_n N_RN_c_8806_n ) capacitor c=0.00103399f \
 //x=78.56 //y=4.755 //x2=79.67 //y2=4.88
cc_5954 ( N_noxref_16_c_7509_p N_RN_c_8806_n ) capacitor c=0.00113984f \
 //x=78.56 //y=4.88 //x2=79.67 //y2=4.88
cc_5955 ( N_noxref_16_c_7523_p N_RN_c_8806_n ) capacitor c=0.00116563f \
 //x=79.125 //y=4.97 //x2=79.67 //y2=4.88
cc_5956 ( N_noxref_16_c_7524_p N_RN_c_8806_n ) capacitor c=0.00129812f \
 //x=78.835 //y=4.97 //x2=79.67 //y2=4.88
cc_5957 ( N_noxref_16_M137_noxref_g N_RN_M135_noxref_g ) capacitor \
 c=0.0101598f //x=61.28 //y=6.2 //x2=60.4 //y2=6.2
cc_5958 ( N_noxref_16_M137_noxref_g N_RN_M136_noxref_g ) capacitor \
 c=0.0607518f //x=61.28 //y=6.2 //x2=60.84 //y2=6.2
cc_5959 ( N_noxref_16_M138_noxref_g N_RN_M136_noxref_g ) capacitor \
 c=0.0101598f //x=61.72 //y=6.2 //x2=60.84 //y2=6.2
cc_5960 ( N_noxref_16_M157_noxref_g N_RN_M159_noxref_g ) capacitor \
 c=0.0106276f //x=78.76 //y=6.2 //x2=79.64 //y2=6.2
cc_5961 ( N_noxref_16_M158_noxref_g N_RN_M159_noxref_g ) capacitor c=0.107144f \
 //x=79.2 //y=6.2 //x2=79.64 //y2=6.2
cc_5962 ( N_noxref_16_M158_noxref_g N_RN_M160_noxref_g ) capacitor \
 c=0.0101598f //x=79.2 //y=6.2 //x2=80.08 //y2=6.2
cc_5963 ( N_noxref_16_c_7444_n N_RN_c_8556_n ) capacitor c=0.00456962f \
 //x=61.53 //y=1.095 //x2=60.52 //y2=1.09
cc_5964 ( N_noxref_16_c_7446_n N_RN_c_8557_n ) capacitor c=0.00438372f \
 //x=61.53 //y=1.44 //x2=60.52 //y2=1.4
cc_5965 ( N_noxref_16_c_7449_n N_RN_c_8558_n ) capacitor c=0.00438372f \
 //x=61.53 //y=1.75 //x2=60.52 //y2=1.63
cc_5966 ( N_noxref_16_c_7388_n N_RN_c_8559_n ) capacitor c=6.57681e-19 \
 //x=61.54 //y=2.375 //x2=60.52 //y2=2.095
cc_5967 ( N_noxref_16_c_7430_n N_RN_c_8559_n ) capacitor c=0.00177608f \
 //x=61.54 //y=2.26 //x2=60.52 //y2=2.095
cc_5968 ( N_noxref_16_c_7462_n N_RN_c_8559_n ) capacitor c=0.00873247f \
 //x=61.54 //y=2.26 //x2=60.52 //y2=2.095
cc_5969 ( N_noxref_16_c_7463_n N_RN_c_8559_n ) capacitor c=0.00438372f \
 //x=61.54 //y=2.095 //x2=60.52 //y2=2.095
cc_5970 ( N_noxref_16_c_7384_n N_RN_c_8175_n ) capacitor c=0.0616777f \
 //x=61.54 //y=4.88 //x2=60.765 //y2=4.97
cc_5971 ( N_noxref_16_c_7569_p N_RN_c_8824_n ) capacitor c=5.72528e-19 \
 //x=78.26 //y=1.055 //x2=79.235 //y2=1.09
cc_5972 ( N_noxref_16_c_7570_p N_RN_c_8824_n ) capacitor c=0.00150277f \
 //x=78.26 //y=1.4 //x2=79.235 //y2=1.09
cc_5973 ( N_noxref_16_c_7571_p N_RN_c_8824_n ) capacitor c=0.0160123f \
 //x=78.79 //y=1.055 //x2=79.235 //y2=1.09
cc_5974 ( N_noxref_16_c_7572_p N_RN_c_8827_n ) capacitor c=0.00111227f \
 //x=78.26 //y=1.71 //x2=79.235 //y2=1.4
cc_5975 ( N_noxref_16_c_7573_p N_RN_c_8827_n ) capacitor c=0.0124075f \
 //x=78.79 //y=1.4 //x2=79.235 //y2=1.4
cc_5976 ( N_noxref_16_c_7571_p N_RN_c_8829_n ) capacitor c=9.19165e-19 \
 //x=78.79 //y=1.055 //x2=79.76 //y2=1.09
cc_5977 ( N_noxref_16_c_7573_p N_RN_c_8830_n ) capacitor c=0.0010154f \
 //x=78.79 //y=1.4 //x2=79.76 //y2=1.4
cc_5978 ( N_noxref_16_c_7573_p N_RN_c_8831_n ) capacitor c=9.23422e-19 \
 //x=78.79 //y=1.4 //x2=79.76 //y2=1.63
cc_5979 ( N_noxref_16_c_7517_p N_RN_c_8832_n ) capacitor c=6.79315e-19 \
 //x=78.56 //y=2.375 //x2=79.76 //y2=2.095
cc_5980 ( N_noxref_16_c_7519_p N_RN_c_8832_n ) capacitor c=0.00176374f \
 //x=78.56 //y=2.26 //x2=79.76 //y2=2.095
cc_5981 ( N_noxref_16_c_7520_p N_RN_c_8832_n ) capacitor c=0.00887699f \
 //x=78.26 //y=2.095 //x2=79.76 //y2=2.095
cc_5982 ( N_noxref_16_c_7371_n N_RN_c_8570_n ) capacitor c=8.42568e-19 \
 //x=61.54 //y=4.75 //x2=60.43 //y2=4.88
cc_5983 ( N_noxref_16_c_7431_n N_RN_c_8570_n ) capacitor c=0.00129812f \
 //x=61.54 //y=4.88 //x2=60.43 //y2=4.88
cc_5984 ( N_noxref_16_c_7384_n N_RN_c_8570_n ) capacitor c=0.00487508f \
 //x=61.54 //y=4.88 //x2=60.43 //y2=4.88
cc_5985 ( N_noxref_16_c_7378_n N_RN_c_8838_n ) capacitor c=0.00116212f \
 //x=78.56 //y=4.755 //x2=79.67 //y2=4.88
cc_5986 ( N_noxref_16_c_7509_p N_RN_c_8838_n ) capacitor c=0.00155973f \
 //x=78.56 //y=4.88 //x2=79.67 //y2=4.88
cc_5987 ( N_noxref_16_c_7523_p N_RN_c_8838_n ) capacitor c=0.0171374f \
 //x=79.125 //y=4.97 //x2=79.67 //y2=4.88
cc_5988 ( N_noxref_16_c_7524_p N_RN_c_8838_n ) capacitor c=0.00484466f \
 //x=78.835 //y=4.97 //x2=79.67 //y2=4.88
cc_5989 ( N_noxref_16_M158_noxref_g N_noxref_18_c_9556_n ) capacitor \
 c=0.00893512f //x=79.2 //y=6.2 //x2=79.74 //y2=5.335
cc_5990 ( N_noxref_16_M157_noxref_g N_noxref_18_c_9554_n ) capacitor \
 c=0.00461408f //x=78.76 //y=6.2 //x2=78.982 //y2=5.335
cc_5991 ( N_noxref_16_M158_noxref_g N_noxref_18_c_9554_n ) capacitor \
 c=0.00229208f //x=79.2 //y=6.2 //x2=78.982 //y2=5.335
cc_5992 ( N_noxref_16_c_7523_p N_noxref_18_c_9554_n ) capacitor c=0.00171885f \
 //x=79.125 //y=4.97 //x2=78.982 //y2=5.335
cc_5993 ( N_noxref_16_M157_noxref_g N_noxref_18_c_9560_n ) capacitor \
 c=0.0162284f //x=78.76 //y=6.2 //x2=78.98 //y2=5.56
cc_5994 ( N_noxref_16_M158_noxref_g N_noxref_18_c_9560_n ) capacitor \
 c=0.0179041f //x=79.2 //y=6.2 //x2=78.98 //y2=5.56
cc_5995 ( N_noxref_16_c_7523_p N_noxref_18_c_9560_n ) capacitor c=0.00291477f \
 //x=79.125 //y=4.97 //x2=78.98 //y2=5.56
cc_5996 ( N_noxref_16_c_7408_n SN ) capacitor c=0.00102767f //x=67.09 \
 //y=3.335 //x2=70.05 //y2=2.77
cc_5997 ( N_noxref_16_c_7422_n N_SN_c_10397_n ) capacitor c=0.00592673f \
 //x=78.395 //y=3.51 //x2=70.05 //y2=3.285
cc_5998 ( N_noxref_16_c_7375_n N_SN_c_10070_n ) capacitor c=8.30912e-19 \
 //x=67.09 //y=5.25 //x2=70.05 //y2=4.765
cc_5999 ( N_noxref_16_c_7422_n N_SN_c_10070_n ) capacitor c=0.0229415f \
 //x=78.395 //y=3.51 //x2=70.05 //y2=4.765
cc_6000 ( N_noxref_16_c_7385_n N_SN_c_10402_n ) capacitor c=0.024888f \
 //x=61.54 //y=3.355 //x2=61.765 //y2=3.13
cc_6001 ( N_noxref_16_c_7396_n N_SN_c_10402_n ) capacitor c=0.00563294f \
 //x=61.54 //y=3.675 //x2=61.765 //y2=3.13
cc_6002 ( N_noxref_16_c_7424_n N_SN_c_10402_n ) capacitor c=0.0358686f \
 //x=61.71 //y=3.515 //x2=61.765 //y2=3.13
cc_6003 ( N_noxref_16_c_7425_n N_SN_c_10402_n ) capacitor c=0.0817066f \
 //x=66.93 //y=3.495 //x2=61.765 //y2=3.13
cc_6004 ( N_noxref_16_c_7385_n N_SN_c_10255_n ) capacitor c=2.5648e-19 \
 //x=61.54 //y=3.355 //x2=61.335 //y2=3.13
cc_6005 ( N_noxref_16_c_7425_n N_SN_c_10405_n ) capacitor c=0.111452f \
 //x=66.93 //y=3.495 //x2=62.5 //y2=3.17
cc_6006 ( N_noxref_16_c_7425_n N_SN_c_10409_n ) capacitor c=0.0595578f \
 //x=66.93 //y=3.495 //x2=63.75 //y2=3.14
cc_6007 ( N_noxref_16_c_7425_n N_SN_c_10414_n ) capacitor c=0.20009f //x=66.93 \
 //y=3.495 //x2=64.35 //y2=3.17
cc_6008 ( N_noxref_16_c_7408_n N_SN_c_10417_n ) capacitor c=6.24124e-19 \
 //x=67.09 //y=3.335 //x2=66.705 //y2=3.14
cc_6009 ( N_noxref_16_c_7425_n N_SN_c_10417_n ) capacitor c=0.0112023f \
 //x=66.93 //y=3.495 //x2=66.705 //y2=3.14
cc_6010 ( N_noxref_16_c_7408_n N_SN_c_10418_n ) capacitor c=0.0223718f \
 //x=67.09 //y=3.335 //x2=67.305 //y2=3.11
cc_6011 ( N_noxref_16_c_7414_n N_SN_c_10418_n ) capacitor c=0.00870162f \
 //x=67.09 //y=3.655 //x2=67.305 //y2=3.11
cc_6012 ( N_noxref_16_c_7422_n N_SN_c_10418_n ) capacitor c=0.121998f \
 //x=78.395 //y=3.51 //x2=67.305 //y2=3.11
cc_6013 ( N_noxref_16_c_7429_n N_SN_c_10418_n ) capacitor c=0.0358686f \
 //x=67.25 //y=3.495 //x2=67.305 //y2=3.11
cc_6014 ( N_noxref_16_c_7408_n N_SN_c_10420_n ) capacitor c=4.89619e-19 \
 //x=67.09 //y=3.335 //x2=68.555 //y2=3.14
cc_6015 ( N_noxref_16_c_7422_n N_SN_c_10420_n ) capacitor c=0.0595405f \
 //x=78.395 //y=3.51 //x2=68.555 //y2=3.14
cc_6016 ( N_noxref_16_c_7422_n N_SN_c_10461_n ) capacitor c=0.112359f \
 //x=78.395 //y=3.51 //x2=72.115 //y2=3.155
cc_6017 ( N_noxref_16_c_7422_n N_SN_c_10426_n ) capacitor c=0.266759f \
 //x=78.395 //y=3.51 //x2=71.77 //y2=3.155
cc_6018 ( N_noxref_16_c_7422_n N_SN_c_10467_n ) capacitor c=0.0578136f \
 //x=78.395 //y=3.51 //x2=73.375 //y2=3.14
cc_6019 ( N_noxref_16_c_7422_n N_SN_c_10471_n ) capacitor c=0.361595f \
 //x=78.395 //y=3.51 //x2=73.975 //y2=3.155
cc_6020 ( N_noxref_16_c_7501_p N_SN_c_10502_n ) capacitor c=4.64545e-19 \
 //x=78.56 //y=3.35 //x2=78.17 //y2=3.14
cc_6021 ( N_noxref_16_c_7505_p N_SN_c_10502_n ) capacitor c=0.00323523f \
 //x=78.56 //y=3.67 //x2=78.17 //y2=3.14
cc_6022 ( N_noxref_16_c_7422_n N_SN_c_10502_n ) capacitor c=0.010873f \
 //x=78.395 //y=3.51 //x2=78.17 //y2=3.14
cc_6023 ( N_noxref_16_c_7501_p N_SN_c_10530_n ) capacitor c=0.0269272f \
 //x=78.56 //y=3.35 //x2=78.77 //y2=3.125
cc_6024 ( N_noxref_16_c_7505_p N_SN_c_10530_n ) capacitor c=0.00485165f \
 //x=78.56 //y=3.67 //x2=78.77 //y2=3.125
cc_6025 ( N_noxref_16_c_7508_p N_SN_c_10530_n ) capacitor c=0.0358686f \
 //x=78.555 //y=3.51 //x2=78.77 //y2=3.125
cc_6026 ( N_noxref_16_c_7408_n N_noxref_20_c_11147_n ) capacitor c=0.0140058f \
 //x=67.09 //y=3.335 //x2=66.35 //y2=2.375
cc_6027 ( N_noxref_16_c_7408_n N_noxref_20_c_11071_n ) capacitor c=0.0361648f \
 //x=67.09 //y=3.335 //x2=66.35 //y2=3.735
cc_6028 ( N_noxref_16_c_7414_n N_noxref_20_c_11071_n ) capacitor c=0.0148932f \
 //x=67.09 //y=3.655 //x2=66.35 //y2=3.735
cc_6029 ( N_noxref_16_c_7375_n N_noxref_20_c_11071_n ) capacitor c=0.00340923f \
 //x=67.09 //y=5.25 //x2=66.35 //y2=3.735
cc_6030 ( N_noxref_16_c_7628_p N_noxref_20_c_11071_n ) capacitor c=9.19401e-19 \
 //x=67.09 //y=3.51 //x2=66.35 //y2=3.735
cc_6031 ( N_noxref_16_c_7425_n N_noxref_20_c_11071_n ) capacitor c=0.0210812f \
 //x=66.93 //y=3.495 //x2=66.35 //y2=3.735
cc_6032 ( N_noxref_16_c_7429_n N_noxref_20_c_11071_n ) capacitor c=0.00336755f \
 //x=67.25 //y=3.495 //x2=66.35 //y2=3.735
cc_6033 ( N_noxref_16_c_7373_n N_noxref_20_c_11152_n ) capacitor c=8.13142e-19 \
 //x=66.195 //y=5.335 //x2=66.35 //y2=4.055
cc_6034 ( N_noxref_16_c_7469_n N_noxref_20_c_11152_n ) capacitor c=9.7144e-19 \
 //x=67.005 //y=5.335 //x2=66.35 //y2=4.055
cc_6035 ( N_noxref_16_c_7407_n N_noxref_20_c_11152_n ) capacitor c=8.07658e-19 \
 //x=66.69 //y=1.845 //x2=66.35 //y2=4.055
cc_6036 ( N_noxref_16_c_7375_n N_noxref_20_c_11152_n ) capacitor c=0.01761f \
 //x=67.09 //y=5.25 //x2=66.35 //y2=4.055
cc_6037 ( N_noxref_16_c_7425_n N_noxref_20_c_11152_n ) capacitor c=0.00611939f \
 //x=66.93 //y=3.495 //x2=66.35 //y2=4.055
cc_6038 ( N_noxref_16_c_7469_n N_noxref_20_c_11043_n ) capacitor c=0.00198098f \
 //x=67.005 //y=5.335 //x2=66.35 //y2=4.75
cc_6039 ( N_noxref_16_c_7375_n N_noxref_20_c_11043_n ) capacitor c=0.038648f \
 //x=67.09 //y=5.25 //x2=66.35 //y2=4.75
cc_6040 ( N_noxref_16_c_7638_p N_noxref_20_c_11043_n ) capacitor c=0.018645f \
 //x=66.31 //y=5.335 //x2=66.35 //y2=4.75
cc_6041 ( N_noxref_16_c_7639_p N_noxref_20_c_11043_n ) capacitor c=0.00217979f \
 //x=66.31 //y=5.56 //x2=66.35 //y2=4.75
cc_6042 ( N_noxref_16_c_7422_n N_noxref_20_c_11078_n ) capacitor c=0.0214961f \
 //x=78.395 //y=3.51 //x2=71.16 //y2=3.735
cc_6043 ( N_noxref_16_c_7422_n N_noxref_20_c_11090_n ) capacitor c=0.00642248f \
 //x=78.395 //y=3.51 //x2=71.16 //y2=4.055
cc_6044 ( N_noxref_16_c_7517_p N_noxref_20_c_11164_n ) capacitor c=0.0034682f \
 //x=78.56 //y=2.375 //x2=76.71 //y2=3.735
cc_6045 ( N_noxref_16_c_7501_p N_noxref_20_c_11164_n ) capacitor c=0.0130127f \
 //x=78.56 //y=3.35 //x2=76.71 //y2=3.735
cc_6046 ( N_noxref_16_c_7505_p N_noxref_20_c_11164_n ) capacitor c=0.00255079f \
 //x=78.56 //y=3.67 //x2=76.71 //y2=3.735
cc_6047 ( N_noxref_16_c_7378_n N_noxref_20_c_11164_n ) capacitor c=0.0011073f \
 //x=78.56 //y=4.755 //x2=76.71 //y2=3.735
cc_6048 ( N_noxref_16_c_7422_n N_noxref_20_c_11164_n ) capacitor c=0.0225414f \
 //x=78.395 //y=3.51 //x2=76.71 //y2=3.735
cc_6049 ( N_noxref_16_c_7508_p N_noxref_20_c_11164_n ) capacitor c=0.00158465f \
 //x=78.555 //y=3.51 //x2=76.71 //y2=3.735
cc_6050 ( N_noxref_16_c_7378_n N_noxref_20_c_11225_n ) capacitor c=0.0025694f \
 //x=78.56 //y=4.755 //x2=76.71 //y2=4.055
cc_6051 ( N_noxref_16_c_7422_n N_noxref_20_c_11225_n ) capacitor c=0.00926238f \
 //x=78.395 //y=3.51 //x2=76.71 //y2=4.055
cc_6052 ( N_noxref_16_c_7378_n N_noxref_20_c_11051_n ) capacitor c=0.0116283f \
 //x=78.56 //y=4.755 //x2=76.71 //y2=5.25
cc_6053 ( N_noxref_16_c_7375_n N_noxref_20_c_11166_n ) capacitor c=9.19401e-19 \
 //x=67.09 //y=5.25 //x2=66.35 //y2=3.88
cc_6054 ( N_noxref_16_c_7422_n N_noxref_20_c_11060_n ) capacitor c=0.450598f \
 //x=78.395 //y=3.51 //x2=76.54 //y2=3.88
cc_6055 ( N_noxref_16_c_7505_p N_noxref_20_c_11063_n ) capacitor c=0.00269024f \
 //x=78.56 //y=3.67 //x2=78.77 //y2=3.895
cc_6056 ( N_noxref_16_c_7378_n N_noxref_20_c_11063_n ) capacitor c=0.0237144f \
 //x=78.56 //y=4.755 //x2=78.77 //y2=3.895
cc_6057 ( N_noxref_16_c_7505_p N_noxref_20_c_11064_n ) capacitor c=0.00347895f \
 //x=78.56 //y=3.67 //x2=78.425 //y2=3.895
cc_6058 ( N_noxref_16_c_7378_n N_noxref_20_c_11064_n ) capacitor c=0.00196004f \
 //x=78.56 //y=4.755 //x2=78.425 //y2=3.895
cc_6059 ( N_noxref_16_c_7422_n N_noxref_20_c_11064_n ) capacitor c=0.170154f \
 //x=78.395 //y=3.51 //x2=78.425 //y2=3.895
cc_6060 ( N_noxref_16_c_7508_p N_noxref_20_c_11064_n ) capacitor c=0.0358254f \
 //x=78.555 //y=3.51 //x2=78.425 //y2=3.895
cc_6061 ( N_noxref_16_c_7375_n N_noxref_20_c_11174_n ) capacitor c=0.0032735f \
 //x=67.09 //y=5.25 //x2=66.51 //y2=3.895
cc_6062 ( N_noxref_16_c_7425_n N_noxref_20_c_11174_n ) capacitor c=0.0358686f \
 //x=66.93 //y=3.495 //x2=66.51 //y2=3.895
cc_6063 ( N_noxref_16_c_7414_n N_noxref_20_c_11081_n ) capacitor c=0.00917068f \
 //x=67.09 //y=3.655 //x2=71 //y2=3.895
cc_6064 ( N_noxref_16_c_7375_n N_noxref_20_c_11081_n ) capacitor c=0.0216307f \
 //x=67.09 //y=5.25 //x2=71 //y2=3.895
cc_6065 ( N_noxref_16_c_7422_n N_noxref_20_c_11081_n ) capacitor c=0.323902f \
 //x=78.395 //y=3.51 //x2=71 //y2=3.895
cc_6066 ( N_noxref_16_c_7425_n N_noxref_20_c_11081_n ) capacitor c=0.035195f \
 //x=66.93 //y=3.495 //x2=71 //y2=3.895
cc_6067 ( N_noxref_16_c_7429_n N_noxref_20_c_11081_n ) capacitor c=0.0358686f \
 //x=67.25 //y=3.495 //x2=71 //y2=3.895
cc_6068 ( N_noxref_16_c_7422_n N_noxref_20_c_11108_n ) capacitor c=0.0358686f \
 //x=78.395 //y=3.51 //x2=71.32 //y2=3.895
cc_6069 ( N_noxref_16_c_7408_n N_noxref_20_c_11176_n ) capacitor c=0.0015536f \
 //x=67.09 //y=3.335 //x2=66.35 //y2=2.26
cc_6070 ( N_noxref_16_c_7469_n N_noxref_20_c_11180_n ) capacitor c=0.00130631f \
 //x=67.005 //y=5.335 //x2=66.35 //y2=4.88
cc_6071 ( N_noxref_16_c_7375_n N_noxref_20_c_11180_n ) capacitor c=0.00126408f \
 //x=67.09 //y=5.25 //x2=66.35 //y2=4.88
cc_6072 ( N_noxref_16_c_7638_p N_noxref_20_c_11180_n ) capacitor c=0.00346456f \
 //x=66.31 //y=5.335 //x2=66.35 //y2=4.88
cc_6073 ( N_noxref_16_c_7639_p N_noxref_20_c_11180_n ) capacitor c=0.00624059f \
 //x=66.31 //y=5.56 //x2=66.35 //y2=4.88
cc_6074 ( N_noxref_16_c_7373_n N_noxref_20_M143_noxref_g ) capacitor \
 c=0.00870811f //x=66.195 //y=5.335 //x2=66.09 //y2=6.2
cc_6075 ( N_noxref_16_c_7468_n N_noxref_20_M143_noxref_g ) capacitor \
 c=0.00226521f //x=66.31 //y=5.56 //x2=66.09 //y2=6.2
cc_6076 ( N_noxref_16_c_7639_p N_noxref_20_M143_noxref_g ) capacitor \
 c=0.0178885f //x=66.31 //y=5.56 //x2=66.09 //y2=6.2
cc_6077 ( N_noxref_16_c_7468_n N_noxref_20_M144_noxref_g ) capacitor \
 c=0.00381703f //x=66.31 //y=5.56 //x2=66.53 //y2=6.2
cc_6078 ( N_noxref_16_c_7469_n N_noxref_20_M144_noxref_g ) capacitor \
 c=0.0106312f //x=67.005 //y=5.335 //x2=66.53 //y2=6.2
cc_6079 ( N_noxref_16_c_7639_p N_noxref_20_M144_noxref_g ) capacitor \
 c=0.0188608f //x=66.31 //y=5.56 //x2=66.53 //y2=6.2
cc_6080 ( N_noxref_16_c_7527_p N_noxref_20_c_11190_n ) capacitor c=4.64015e-19 \
 //x=66.605 //y=1.305 //x2=66.34 //y2=1.095
cc_6081 ( N_noxref_16_M41_noxref_d N_noxref_20_c_11190_n ) capacitor \
 c=0.00137165f //x=66.415 //y=1.095 //x2=66.34 //y2=1.095
cc_6082 ( N_noxref_16_c_7527_p N_noxref_20_c_11191_n ) capacitor c=0.0026012f \
 //x=66.605 //y=1.305 //x2=66.34 //y2=1.44
cc_6083 ( N_noxref_16_c_7681_p N_noxref_20_c_11191_n ) capacitor c=0.00127432f \
 //x=66.605 //y=1.76 //x2=66.34 //y2=1.44
cc_6084 ( N_noxref_16_M41_noxref_d N_noxref_20_c_11191_n ) capacitor \
 c=0.00237422f //x=66.415 //y=1.095 //x2=66.34 //y2=1.44
cc_6085 ( N_noxref_16_c_7681_p N_noxref_20_c_11192_n ) capacitor c=0.00429966f \
 //x=66.605 //y=1.76 //x2=66.34 //y2=1.75
cc_6086 ( N_noxref_16_c_7527_p N_noxref_20_c_11261_n ) capacitor c=5.29969e-19 \
 //x=66.605 //y=1.305 //x2=66.715 //y2=0.94
cc_6087 ( N_noxref_16_M41_noxref_d N_noxref_20_c_11261_n ) capacitor \
 c=0.0020782f //x=66.415 //y=1.095 //x2=66.715 //y2=0.94
cc_6088 ( N_noxref_16_c_7527_p N_noxref_20_c_11263_n ) capacitor c=5.18355e-19 \
 //x=66.605 //y=1.305 //x2=66.715 //y2=1.595
cc_6089 ( N_noxref_16_c_7681_p N_noxref_20_c_11263_n ) capacitor c=0.00942306f \
 //x=66.605 //y=1.76 //x2=66.715 //y2=1.595
cc_6090 ( N_noxref_16_c_7470_n N_noxref_20_c_11263_n ) capacitor c=0.00194716f \
 //x=67.005 //y=1.845 //x2=66.715 //y2=1.595
cc_6091 ( N_noxref_16_M41_noxref_d N_noxref_20_c_11263_n ) capacitor \
 c=0.00356097f //x=66.415 //y=1.095 //x2=66.715 //y2=1.595
cc_6092 ( N_noxref_16_c_7527_p N_noxref_20_c_11267_n ) capacitor c=5.24634e-19 \
 //x=66.605 //y=1.305 //x2=66.87 //y2=1.095
cc_6093 ( N_noxref_16_M41_noxref_d N_noxref_20_c_11267_n ) capacitor \
 c=0.00139206f //x=66.415 //y=1.095 //x2=66.87 //y2=1.095
cc_6094 ( N_noxref_16_c_7527_p N_noxref_20_c_11269_n ) capacitor c=0.00307978f \
 //x=66.605 //y=1.305 //x2=66.87 //y2=1.44
cc_6095 ( N_noxref_16_c_7681_p N_noxref_20_c_11269_n ) capacitor c=0.00363411f \
 //x=66.605 //y=1.76 //x2=66.87 //y2=1.44
cc_6096 ( N_noxref_16_c_7470_n N_noxref_20_c_11269_n ) capacitor c=0.00323576f \
 //x=67.005 //y=1.845 //x2=66.87 //y2=1.44
cc_6097 ( N_noxref_16_M41_noxref_d N_noxref_20_c_11269_n ) capacitor \
 c=0.00237422f //x=66.415 //y=1.095 //x2=66.87 //y2=1.44
cc_6098 ( N_noxref_16_c_7408_n N_noxref_20_c_11193_n ) capacitor c=0.0024584f \
 //x=67.09 //y=3.335 //x2=66.35 //y2=2.26
cc_6099 ( N_noxref_16_c_7681_p N_noxref_20_c_11196_n ) capacitor c=0.0036273f \
 //x=66.605 //y=1.76 //x2=66.35 //y2=2.095
cc_6100 ( N_noxref_16_c_7408_n N_noxref_20_c_11196_n ) capacitor c=0.00282067f \
 //x=67.09 //y=3.335 //x2=66.35 //y2=2.095
cc_6101 ( N_noxref_16_c_7375_n N_noxref_20_c_11069_n ) capacitor c=0.00714556f \
 //x=67.09 //y=5.25 //x2=66.35 //y2=4.88
cc_6102 ( N_noxref_16_c_7638_p N_noxref_20_c_11069_n ) capacitor c=0.00203307f \
 //x=66.31 //y=5.335 //x2=66.35 //y2=4.88
cc_6103 ( N_noxref_16_c_7639_p N_noxref_20_c_11069_n ) capacitor c=0.00375636f \
 //x=66.31 //y=5.56 //x2=66.35 //y2=4.88
cc_6104 ( N_noxref_16_c_7501_p N_noxref_21_c_11652_n ) capacitor c=0.00167462f \
 //x=78.56 //y=3.35 //x2=80.78 //y2=4.75
cc_6105 ( N_noxref_16_c_7378_n N_noxref_21_c_11652_n ) capacitor c=7.77594e-19 \
 //x=78.56 //y=4.755 //x2=80.78 //y2=4.75
cc_6106 ( N_noxref_16_c_7396_n N_noxref_22_c_12272_n ) capacitor c=0.00113229f \
 //x=61.54 //y=3.675 //x2=61.165 //y2=3.88
cc_6107 ( N_noxref_16_c_7371_n N_noxref_22_c_12272_n ) capacitor c=5.12492e-19 \
 //x=61.54 //y=4.75 //x2=61.165 //y2=3.88
cc_6108 ( N_noxref_16_c_7424_n N_noxref_22_c_12272_n ) capacitor c=0.0358254f \
 //x=61.71 //y=3.515 //x2=61.165 //y2=3.88
cc_6109 ( N_noxref_16_c_7396_n N_noxref_22_c_12273_n ) capacitor c=0.00427018f \
 //x=61.54 //y=3.675 //x2=61.765 //y2=3.9
cc_6110 ( N_noxref_16_c_7371_n N_noxref_22_c_12273_n ) capacitor c=0.0243871f \
 //x=61.54 //y=4.75 //x2=61.765 //y2=3.9
cc_6111 ( N_noxref_16_c_7425_n N_noxref_22_c_12273_n ) capacitor c=0.349514f \
 //x=66.93 //y=3.495 //x2=61.765 //y2=3.9
cc_6112 ( N_noxref_16_c_7425_n N_noxref_22_c_12275_n ) capacitor c=0.024539f \
 //x=66.93 //y=3.495 //x2=65.965 //y2=4.25
cc_6113 ( N_noxref_16_c_7375_n N_noxref_22_c_12278_n ) capacitor c=0.0239275f \
 //x=67.09 //y=5.25 //x2=66.565 //y2=4.28
cc_6114 ( N_noxref_16_c_7422_n N_noxref_22_c_12278_n ) capacitor c=0.0310006f \
 //x=78.395 //y=3.51 //x2=66.565 //y2=4.28
cc_6115 ( N_noxref_16_c_7425_n N_noxref_22_c_12278_n ) capacitor c=0.002911f \
 //x=66.93 //y=3.495 //x2=66.565 //y2=4.28
cc_6116 ( N_noxref_16_c_7422_n N_noxref_22_c_12279_n ) capacitor c=0.0373406f \
 //x=78.395 //y=3.51 //x2=71.375 //y2=4.31
cc_6117 ( N_noxref_16_c_7422_n N_noxref_22_c_12280_n ) capacitor c=0.00404818f \
 //x=78.395 //y=3.51 //x2=76.315 //y2=4.25
cc_6118 ( N_noxref_16_c_7378_n N_noxref_22_c_12285_n ) capacitor c=4.8624e-19 \
 //x=78.56 //y=4.755 //x2=76.915 //y2=4.28
cc_6119 ( N_noxref_16_c_7422_n N_noxref_22_c_12285_n ) capacitor c=0.00963112f \
 //x=78.395 //y=3.51 //x2=76.915 //y2=4.28
cc_6120 ( N_noxref_16_c_7378_n N_noxref_22_c_12286_n ) capacitor c=0.0245517f \
 //x=78.56 //y=4.755 //x2=85.205 //y2=4.25
cc_6121 ( N_noxref_16_c_7373_n N_VDD_c_13434_n ) capacitor c=0.00214917f \
 //x=66.195 //y=5.335 //x2=87.775 //y2=7.585
cc_6122 ( N_noxref_16_c_7468_n N_VDD_c_13434_n ) capacitor c=0.00236065f \
 //x=66.31 //y=5.56 //x2=87.775 //y2=7.585
cc_6123 ( N_noxref_16_c_7469_n N_VDD_c_13434_n ) capacitor c=0.00753358f \
 //x=67.005 //y=5.335 //x2=87.775 //y2=7.585
cc_6124 ( N_noxref_16_c_7414_n N_VDD_c_13434_n ) capacitor c=2.75833e-19 \
 //x=67.09 //y=3.655 //x2=87.775 //y2=7.585
cc_6125 ( N_noxref_16_c_7505_p N_VDD_c_13434_n ) capacitor c=3.78831e-19 \
 //x=78.56 //y=3.67 //x2=87.775 //y2=7.585
cc_6126 ( N_noxref_16_c_7379_n N_VDD_c_13434_n ) capacitor c=0.0041197f \
 //x=64.552 //y=5.335 //x2=87.775 //y2=7.585
cc_6127 ( N_noxref_16_c_7381_n N_VDD_c_13434_n ) capacitor c=0.00349536f \
 //x=65.43 //y=5.335 //x2=87.775 //y2=7.585
cc_6128 ( N_noxref_16_c_7435_n N_VDD_c_13434_n ) capacitor c=0.0024232f \
 //x=64.55 //y=5.56 //x2=87.775 //y2=7.585
cc_6129 ( N_noxref_16_c_7491_n N_VDD_c_13434_n ) capacitor c=0.0024232f \
 //x=65.43 //y=5.56 //x2=87.775 //y2=7.585
cc_6130 ( N_noxref_16_c_7639_p N_VDD_c_13434_n ) capacitor c=0.0024232f \
 //x=66.31 //y=5.56 //x2=87.775 //y2=7.585
cc_6131 ( N_noxref_16_M137_noxref_g N_VDD_c_14191_n ) capacitor c=0.00755544f \
 //x=61.28 //y=6.2 //x2=61.855 //y2=7.585
cc_6132 ( N_noxref_16_M138_noxref_g N_VDD_c_14191_n ) capacitor c=0.00755754f \
 //x=61.72 //y=6.2 //x2=61.855 //y2=7.585
cc_6133 ( N_noxref_16_c_7379_n N_VDD_c_14196_n ) capacitor c=0.00165812f \
 //x=64.552 //y=5.335 //x2=64.905 //y2=7.585
cc_6134 ( N_noxref_16_c_7435_n N_VDD_c_14196_n ) capacitor c=0.0138074f \
 //x=64.55 //y=5.56 //x2=64.905 //y2=7.585
cc_6135 ( N_noxref_16_c_7372_n N_VDD_c_14296_n ) capacitor c=4.62132e-19 \
 //x=65.31 //y=5.335 //x2=65.785 //y2=7.585
cc_6136 ( N_noxref_16_c_7381_n N_VDD_c_14296_n ) capacitor c=0.00166996f \
 //x=65.43 //y=5.335 //x2=65.785 //y2=7.585
cc_6137 ( N_noxref_16_c_7491_n N_VDD_c_14296_n ) capacitor c=0.0138074f \
 //x=65.43 //y=5.56 //x2=65.785 //y2=7.585
cc_6138 ( N_noxref_16_c_7373_n N_VDD_c_14347_n ) capacitor c=0.00205906f \
 //x=66.195 //y=5.335 //x2=66.665 //y2=7.585
cc_6139 ( N_noxref_16_c_7468_n N_VDD_c_14347_n ) capacitor c=8.49654e-19 \
 //x=66.31 //y=5.56 //x2=66.665 //y2=7.585
cc_6140 ( N_noxref_16_c_7469_n N_VDD_c_14347_n ) capacitor c=0.00204238f \
 //x=67.005 //y=5.335 //x2=66.665 //y2=7.585
cc_6141 ( N_noxref_16_c_7639_p N_VDD_c_14347_n ) capacitor c=0.013249f \
 //x=66.31 //y=5.56 //x2=66.665 //y2=7.585
cc_6142 ( N_noxref_16_c_7469_n N_VDD_c_14351_n ) capacitor c=0.00183742f \
 //x=67.005 //y=5.335 //x2=67.66 //y2=7.585
cc_6143 ( N_noxref_16_M157_noxref_g N_VDD_c_14352_n ) capacitor c=0.00755614f \
 //x=78.76 //y=6.2 //x2=79.335 //y2=7.585
cc_6144 ( N_noxref_16_M158_noxref_g N_VDD_c_14352_n ) capacitor c=0.00755544f \
 //x=79.2 //y=6.2 //x2=79.335 //y2=7.585
cc_6145 ( N_noxref_16_c_7379_n N_VDD_c_13781_n ) capacitor c=0.00245433f \
 //x=64.552 //y=5.335 //x2=63.02 //y2=7.585
cc_6146 ( N_noxref_16_c_7431_n N_VDD_c_13781_n ) capacitor c=0.00205049f \
 //x=61.54 //y=4.88 //x2=63.02 //y2=7.585
cc_6147 ( N_noxref_16_c_7435_n N_VDD_c_13781_n ) capacitor c=0.00509469f \
 //x=64.55 //y=5.56 //x2=63.02 //y2=7.585
cc_6148 ( N_noxref_16_c_7384_n N_VDD_c_13781_n ) capacitor c=2.63786e-19 \
 //x=61.54 //y=4.88 //x2=63.02 //y2=7.585
cc_6149 ( N_noxref_16_c_7468_n N_VDD_c_13783_n ) capacitor c=0.00282782f \
 //x=66.31 //y=5.56 //x2=67.83 //y2=7.585
cc_6150 ( N_noxref_16_c_7375_n N_VDD_c_13783_n ) capacitor c=0.0314963f \
 //x=67.09 //y=5.25 //x2=67.83 //y2=7.585
cc_6151 ( N_noxref_16_c_7639_p N_VDD_c_13783_n ) capacitor c=0.00777981f \
 //x=66.31 //y=5.56 //x2=67.83 //y2=7.585
cc_6152 ( N_noxref_16_c_7378_n N_VDD_c_13786_n ) capacitor c=0.0119138f \
 //x=78.56 //y=4.755 //x2=77.45 //y2=7.585
cc_6153 ( N_noxref_16_c_7509_p N_VDD_c_13786_n ) capacitor c=0.00370784f \
 //x=78.56 //y=4.88 //x2=77.45 //y2=7.585
cc_6154 ( N_noxref_16_c_7524_p N_VDD_c_13786_n ) capacitor c=0.00590568f \
 //x=78.835 //y=4.97 //x2=77.45 //y2=7.585
cc_6155 ( N_noxref_16_M137_noxref_g N_VDD_M136_noxref_d ) capacitor \
 c=0.015318f //x=61.28 //y=6.2 //x2=60.915 //y2=5.2
cc_6156 ( N_noxref_16_M138_noxref_g N_VDD_M138_noxref_d ) capacitor \
 c=0.0394719f //x=61.72 //y=6.2 //x2=61.795 //y2=5.2
cc_6157 ( N_noxref_16_c_7379_n N_VDD_M139_noxref_s ) capacitor c=0.0440806f \
 //x=64.552 //y=5.335 //x2=63.975 //y2=5.2
cc_6158 ( N_noxref_16_c_7381_n N_VDD_M139_noxref_s ) capacitor c=0.00107278f \
 //x=65.43 //y=5.335 //x2=63.975 //y2=5.2
cc_6159 ( N_noxref_16_c_7435_n N_VDD_M139_noxref_s ) capacitor c=0.09305f \
 //x=64.55 //y=5.56 //x2=63.975 //y2=5.2
cc_6160 ( N_noxref_16_c_7372_n N_VDD_M140_noxref_d ) capacitor c=0.00596742f \
 //x=65.31 //y=5.335 //x2=64.845 //y2=5.2
cc_6161 ( N_noxref_16_c_7435_n N_VDD_M140_noxref_d ) capacitor c=0.0674491f \
 //x=64.55 //y=5.56 //x2=64.845 //y2=5.2
cc_6162 ( N_noxref_16_c_7491_n N_VDD_M140_noxref_d ) capacitor c=0.0674762f \
 //x=65.43 //y=5.56 //x2=64.845 //y2=5.2
cc_6163 ( N_noxref_16_c_7373_n N_VDD_M142_noxref_d ) capacitor c=0.00617264f \
 //x=66.195 //y=5.335 //x2=65.725 //y2=5.2
cc_6164 ( N_noxref_16_c_7491_n N_VDD_M142_noxref_d ) capacitor c=0.067493f \
 //x=65.43 //y=5.56 //x2=65.725 //y2=5.2
cc_6165 ( N_noxref_16_c_7639_p N_VDD_M142_noxref_d ) capacitor c=0.0674979f \
 //x=66.31 //y=5.56 //x2=65.725 //y2=5.2
cc_6166 ( N_noxref_16_c_7469_n N_VDD_M144_noxref_d ) capacitor c=0.00700141f \
 //x=67.005 //y=5.335 //x2=66.605 //y2=5.2
cc_6167 ( N_noxref_16_c_7639_p N_VDD_M144_noxref_d ) capacitor c=0.0675002f \
 //x=66.31 //y=5.56 //x2=66.605 //y2=5.2
cc_6168 ( N_noxref_16_c_7468_n N_VDD_M145_noxref_s ) capacitor c=0.00492616f \
 //x=66.31 //y=5.56 //x2=68.785 //y2=5.2
cc_6169 ( N_noxref_16_c_7469_n N_VDD_M145_noxref_s ) capacitor c=9.35574e-19 \
 //x=67.005 //y=5.335 //x2=68.785 //y2=5.2
cc_6170 ( N_noxref_16_c_7381_n N_VDD_M145_noxref_s ) capacitor c=3.07158e-19 \
 //x=65.43 //y=5.335 //x2=68.785 //y2=5.2
cc_6171 ( N_noxref_16_c_7505_p N_VDD_M157_noxref_s ) capacitor c=6.00483e-19 \
 //x=78.56 //y=3.67 //x2=78.405 //y2=5.2
cc_6172 ( N_noxref_16_c_7378_n N_VDD_M157_noxref_s ) capacitor c=0.0217981f \
 //x=78.56 //y=4.755 //x2=78.405 //y2=5.2
cc_6173 ( N_noxref_16_c_7509_p N_VDD_M157_noxref_s ) capacitor c=0.00983846f \
 //x=78.56 //y=4.88 //x2=78.405 //y2=5.2
cc_6174 ( N_noxref_16_M157_noxref_g N_VDD_M157_noxref_s ) capacitor \
 c=0.053419f //x=78.76 //y=6.2 //x2=78.405 //y2=5.2
cc_6175 ( N_noxref_16_c_7524_p N_VDD_M157_noxref_s ) capacitor c=0.00606273f \
 //x=78.835 //y=4.97 //x2=78.405 //y2=5.2
cc_6176 ( N_noxref_16_M158_noxref_g N_VDD_M158_noxref_d ) capacitor \
 c=0.015318f //x=79.2 //y=6.2 //x2=79.275 //y2=5.2
cc_6177 ( N_noxref_16_c_7388_n N_noxref_38_c_15692_n ) capacitor c=0.00177186f \
 //x=61.54 //y=2.375 //x2=62.195 //y2=0.72
cc_6178 ( N_noxref_16_c_7430_n N_noxref_38_c_15692_n ) capacitor c=0.00117306f \
 //x=61.54 //y=2.26 //x2=62.195 //y2=0.72
cc_6179 ( N_noxref_16_c_7444_n N_noxref_38_c_15692_n ) capacitor c=0.0206349f \
 //x=61.53 //y=1.095 //x2=62.195 //y2=0.72
cc_6180 ( N_noxref_16_c_7456_n N_noxref_38_c_15692_n ) capacitor c=0.00825432f \
 //x=62.06 //y=1.095 //x2=62.195 //y2=0.72
cc_6181 ( N_noxref_16_c_7462_n N_noxref_38_c_15692_n ) capacitor c=2.20712e-19 \
 //x=61.54 //y=2.26 //x2=62.195 //y2=0.72
cc_6182 ( N_noxref_16_c_7446_n N_noxref_38_c_15695_n ) capacitor c=0.0071177f \
 //x=61.53 //y=1.44 //x2=61.31 //y2=1.175
cc_6183 ( N_noxref_16_c_7444_n N_noxref_38_M38_noxref_s ) capacitor \
 c=0.0071177f //x=61.53 //y=1.095 //x2=61.175 //y2=0.555
cc_6184 ( N_noxref_16_c_7449_n N_noxref_38_M38_noxref_s ) capacitor \
 c=0.0071177f //x=61.53 //y=1.75 //x2=61.175 //y2=0.555
cc_6185 ( N_noxref_16_c_7456_n N_noxref_38_M38_noxref_s ) capacitor \
 c=0.015333f //x=62.06 //y=1.095 //x2=61.175 //y2=0.555
cc_6186 ( N_noxref_16_c_7458_n N_noxref_38_M38_noxref_s ) capacitor \
 c=0.00248746f //x=62.06 //y=1.44 //x2=61.175 //y2=0.555
cc_6187 ( N_noxref_16_c_7527_p N_noxref_39_c_15775_n ) capacitor c=0.0036878f \
 //x=66.605 //y=1.305 //x2=67.005 //y2=0.72
cc_6188 ( N_noxref_16_c_7470_n N_noxref_39_c_15775_n ) capacitor c=0.00399931f \
 //x=67.005 //y=1.845 //x2=67.005 //y2=0.72
cc_6189 ( N_noxref_16_M41_noxref_d N_noxref_39_c_15775_n ) capacitor \
 c=0.00910163f //x=66.415 //y=1.095 //x2=67.005 //y2=0.72
cc_6190 ( N_noxref_16_M41_noxref_d N_noxref_39_c_15778_n ) capacitor \
 c=0.00120711f //x=66.415 //y=1.095 //x2=66.12 //y2=1.175
cc_6191 ( N_noxref_16_c_7372_n N_noxref_39_M40_noxref_d ) capacitor \
 c=6.93499e-19 //x=65.31 //y=5.335 //x2=64.88 //y2=1.09
cc_6192 ( N_noxref_16_c_7527_p N_noxref_39_M40_noxref_d ) capacitor \
 c=0.00802417f //x=66.605 //y=1.305 //x2=64.88 //y2=1.09
cc_6193 ( N_noxref_16_c_7527_p N_noxref_39_M41_noxref_s ) capacitor \
 c=0.0098487f //x=66.605 //y=1.305 //x2=65.985 //y2=0.555
cc_6194 ( N_noxref_16_c_7681_p N_noxref_39_M41_noxref_s ) capacitor \
 c=0.0283243f //x=66.605 //y=1.76 //x2=65.985 //y2=0.555
cc_6195 ( N_noxref_16_c_7470_n N_noxref_39_M41_noxref_s ) capacitor \
 c=0.00871957f //x=67.005 //y=1.845 //x2=65.985 //y2=0.555
cc_6196 ( N_noxref_16_c_7628_p N_noxref_39_M41_noxref_s ) capacitor \
 c=0.0016218f //x=67.09 //y=3.51 //x2=65.985 //y2=0.555
cc_6197 ( N_noxref_16_M41_noxref_d N_noxref_39_M41_noxref_s ) capacitor \
 c=0.0279003f //x=66.415 //y=1.095 //x2=65.985 //y2=0.555
cc_6198 ( N_noxref_16_c_7527_p N_noxref_40_M43_noxref_d ) capacitor \
 c=3.20746e-19 //x=66.605 //y=1.305 //x2=69.69 //y2=1.09
cc_6199 ( N_noxref_16_c_7388_n N_GND_c_16949_n ) capacitor c=0.00196498f \
 //x=61.54 //y=2.375 //x2=64.01 //y2=0.175
cc_6200 ( N_noxref_16_c_7527_p N_GND_c_17063_n ) capacitor c=0.00884249f \
 //x=66.605 //y=1.305 //x2=68.82 //y2=0.175
cc_6201 ( N_noxref_16_c_7470_n N_GND_c_17063_n ) capacitor c=0.00662992f \
 //x=67.005 //y=1.845 //x2=68.82 //y2=0.175
cc_6202 ( N_noxref_16_c_7414_n N_GND_c_17063_n ) capacitor c=2.95105e-19 \
 //x=67.09 //y=3.655 //x2=68.82 //y2=0.175
cc_6203 ( N_noxref_16_M41_noxref_d N_GND_c_17063_n ) capacitor c=2.9462e-19 \
 //x=66.415 //y=1.095 //x2=68.82 //y2=0.175
cc_6204 ( N_noxref_16_c_7569_p N_GND_c_17070_n ) capacitor c=3.97665e-19 \
 //x=78.26 //y=1.055 //x2=78.525 //y2=1.015
cc_6205 ( N_noxref_16_c_7803_p N_GND_c_17070_n ) capacitor c=0.00864776f \
 //x=78.635 //y=0.9 //x2=78.525 //y2=1.015
cc_6206 ( N_noxref_16_c_7571_p N_GND_c_17070_n ) capacitor c=4.45447e-19 \
 //x=78.79 //y=1.055 //x2=78.525 //y2=1.015
cc_6207 ( N_noxref_16_c_7527_p N_GND_c_16970_n ) capacitor c=0.00543195f \
 //x=66.605 //y=1.305 //x2=68.905 //y2=1.145
cc_6208 ( N_noxref_16_c_7517_p N_GND_c_17074_n ) capacitor c=0.00772482f \
 //x=78.56 //y=2.375 //x2=78.525 //y2=1.145
cc_6209 ( N_noxref_16_c_7505_p N_GND_c_17074_n ) capacitor c=7.73977e-19 \
 //x=78.56 //y=3.67 //x2=78.525 //y2=1.145
cc_6210 ( N_noxref_16_c_7519_p N_GND_c_17074_n ) capacitor c=2.22883e-19 \
 //x=78.56 //y=2.26 //x2=78.525 //y2=1.145
cc_6211 ( N_noxref_16_c_7569_p N_GND_c_17074_n ) capacitor c=0.00156339f \
 //x=78.26 //y=1.055 //x2=78.525 //y2=1.145
cc_6212 ( N_noxref_16_c_7570_p N_GND_c_17074_n ) capacitor c=0.00352472f \
 //x=78.26 //y=1.4 //x2=78.525 //y2=1.145
cc_6213 ( N_noxref_16_c_7572_p N_GND_c_17074_n ) capacitor c=4.26589e-19 \
 //x=78.26 //y=1.71 //x2=78.525 //y2=1.145
cc_6214 ( N_noxref_16_c_7803_p N_GND_c_17074_n ) capacitor c=9.36995e-19 \
 //x=78.635 //y=0.9 //x2=78.525 //y2=1.145
cc_6215 ( N_noxref_16_c_7813_p N_GND_c_17074_n ) capacitor c=5.79272e-19 \
 //x=78.635 //y=1.555 //x2=78.525 //y2=1.145
cc_6216 ( N_noxref_16_c_7571_p N_GND_c_17074_n ) capacitor c=0.0017438f \
 //x=78.79 //y=1.055 //x2=78.525 //y2=1.145
cc_6217 ( N_noxref_16_c_7573_p N_GND_c_17074_n ) capacitor c=0.00276804f \
 //x=78.79 //y=1.4 //x2=78.525 //y2=1.145
cc_6218 ( N_noxref_16_c_7388_n N_GND_c_16917_n ) capacitor c=2.016e-19 \
 //x=61.54 //y=2.375 //x2=62.85 //y2=0.175
cc_6219 ( N_noxref_16_c_7470_n N_GND_c_16982_n ) capacitor c=6.86343e-19 \
 //x=67.005 //y=1.845 //x2=67.66 //y2=0.175
cc_6220 ( N_noxref_16_c_7414_n N_GND_c_16982_n ) capacitor c=4.03806e-19 \
 //x=67.09 //y=3.655 //x2=67.66 //y2=0.175
cc_6221 ( N_noxref_16_c_7569_p N_GND_c_17087_n ) capacitor c=0.00677766f \
 //x=78.26 //y=1.055 //x2=82.09 //y2=0.175
cc_6222 ( N_noxref_16_c_7430_n N_GND_c_16984_n ) capacitor c=0.00222376f \
 //x=61.54 //y=2.26 //x2=63.02 //y2=0.175
cc_6223 ( N_noxref_16_c_7458_n N_GND_c_16984_n ) capacitor c=0.00262688f \
 //x=62.06 //y=1.44 //x2=63.02 //y2=0.175
cc_6224 ( N_noxref_16_c_7462_n N_GND_c_16984_n ) capacitor c=2.63786e-19 \
 //x=61.54 //y=2.26 //x2=63.02 //y2=0.175
cc_6225 ( N_noxref_16_c_7681_p N_GND_c_16997_n ) capacitor c=0.0045138f \
 //x=66.605 //y=1.76 //x2=67.83 //y2=0.175
cc_6226 ( N_noxref_16_c_7470_n N_GND_c_16997_n ) capacitor c=0.0304827f \
 //x=67.005 //y=1.845 //x2=67.83 //y2=0.175
cc_6227 ( N_noxref_16_c_7517_p N_GND_c_17093_n ) capacitor c=0.00375773f \
 //x=78.56 //y=2.375 //x2=77.45 //y2=0.175
cc_6228 ( N_noxref_16_c_7501_p N_GND_c_17093_n ) capacitor c=0.00963712f \
 //x=78.56 //y=3.35 //x2=77.45 //y2=0.175
cc_6229 ( N_noxref_16_c_7519_p N_GND_c_17093_n ) capacitor c=0.00379567f \
 //x=78.56 //y=2.26 //x2=77.45 //y2=0.175
cc_6230 ( N_noxref_16_c_7572_p N_GND_c_17093_n ) capacitor c=0.00170145f \
 //x=78.26 //y=1.71 //x2=77.45 //y2=0.175
cc_6231 ( N_noxref_16_c_7520_p N_GND_c_17093_n ) capacitor c=0.0102191f \
 //x=78.26 //y=2.095 //x2=77.45 //y2=0.175
cc_6232 ( N_noxref_16_c_7517_p N_GND_M48_noxref_d ) capacitor c=4.4417e-19 \
 //x=78.56 //y=2.375 //x2=78.335 //y2=1.055
cc_6233 ( N_noxref_16_c_7569_p N_GND_M48_noxref_d ) capacitor c=0.00184354f \
 //x=78.26 //y=1.055 //x2=78.335 //y2=1.055
cc_6234 ( N_noxref_16_c_7570_p N_GND_M48_noxref_d ) capacitor c=0.00210798f \
 //x=78.26 //y=1.4 //x2=78.335 //y2=1.055
cc_6235 ( N_noxref_16_c_7803_p N_GND_M48_noxref_d ) capacitor c=0.00474029f \
 //x=78.635 //y=0.9 //x2=78.335 //y2=1.055
cc_6236 ( N_noxref_16_c_7813_p N_GND_M48_noxref_d ) capacitor c=0.00166857f \
 //x=78.635 //y=1.555 //x2=78.335 //y2=1.055
cc_6237 ( N_noxref_16_c_7571_p N_GND_M48_noxref_d ) capacitor c=0.00230174f \
 //x=78.79 //y=1.055 //x2=78.335 //y2=1.055
cc_6238 ( N_noxref_16_c_7573_p N_GND_M48_noxref_d ) capacitor c=0.00210798f \
 //x=78.79 //y=1.4 //x2=78.335 //y2=1.055
cc_6239 ( N_noxref_16_c_7520_p N_noxref_63_c_19058_n ) capacitor c=0.00262672f \
 //x=78.26 //y=2.095 //x2=78.04 //y2=1.685
cc_6240 ( N_noxref_16_c_7517_p N_noxref_63_c_19059_n ) capacitor c=0.00428451f \
 //x=78.56 //y=2.375 //x2=78.925 //y2=1.77
cc_6241 ( N_noxref_16_c_7505_p N_noxref_63_c_19059_n ) capacitor c=0.00260186f \
 //x=78.56 //y=3.67 //x2=78.925 //y2=1.77
cc_6242 ( N_noxref_16_c_7519_p N_noxref_63_c_19059_n ) capacitor c=0.0104666f \
 //x=78.56 //y=2.26 //x2=78.925 //y2=1.77
cc_6243 ( N_noxref_16_c_7572_p N_noxref_63_c_19059_n ) capacitor c=0.00705077f \
 //x=78.26 //y=1.71 //x2=78.925 //y2=1.77
cc_6244 ( N_noxref_16_c_7520_p N_noxref_63_c_19059_n ) capacitor c=0.020708f \
 //x=78.26 //y=2.095 //x2=78.925 //y2=1.77
cc_6245 ( N_noxref_16_c_7813_p N_noxref_63_c_19059_n ) capacitor c=0.00588627f \
 //x=78.635 //y=1.555 //x2=78.925 //y2=1.77
cc_6246 ( N_noxref_16_c_7573_p N_noxref_63_c_19059_n ) capacitor c=0.00698822f \
 //x=78.79 //y=1.4 //x2=78.925 //y2=1.77
cc_6247 ( N_noxref_16_c_7569_p N_noxref_63_M48_noxref_s ) capacitor \
 c=0.0295256f //x=78.26 //y=1.055 //x2=77.905 //y2=0.555
cc_6248 ( N_noxref_16_c_7572_p N_noxref_63_M48_noxref_s ) capacitor \
 c=7.99997e-19 //x=78.26 //y=1.71 //x2=77.905 //y2=0.555
cc_6249 ( N_noxref_16_c_7520_p N_noxref_63_M48_noxref_s ) capacitor \
 c=0.00122123f //x=78.26 //y=2.095 //x2=77.905 //y2=0.555
cc_6250 ( N_noxref_16_c_7571_p N_noxref_63_M48_noxref_s ) capacitor \
 c=0.0125924f //x=78.79 //y=1.055 //x2=77.905 //y2=0.555
cc_6251 ( N_RN_c_8772_n N_noxref_18_c_9556_n ) capacitor c=3.77334e-19 \
 //x=79.67 //y=2.57 //x2=79.74 //y2=5.335
cc_6252 ( N_RN_c_8131_n N_noxref_18_c_9556_n ) capacitor c=0.0213631f \
 //x=79.67 //y=4.765 //x2=79.74 //y2=5.335
cc_6253 ( N_RN_c_8806_n N_noxref_18_c_9556_n ) capacitor c=0.00492634f \
 //x=79.67 //y=4.88 //x2=79.74 //y2=5.335
cc_6254 ( N_RN_M159_noxref_g N_noxref_18_c_9556_n ) capacitor c=0.00858241f \
 //x=79.64 //y=6.2 //x2=79.74 //y2=5.335
cc_6255 ( N_RN_c_8838_n N_noxref_18_c_9556_n ) capacitor c=6.1418e-19 \
 //x=79.67 //y=4.88 //x2=79.74 //y2=5.335
cc_6256 ( N_RN_M160_noxref_g N_noxref_18_c_9568_n ) capacitor c=0.00955829f \
 //x=80.08 //y=6.2 //x2=80.625 //y2=5.335
cc_6257 ( RN N_noxref_18_c_9552_n ) capacitor c=0.0024f //x=79.67 //y=2.77 \
 //x2=81.52 //y2=5.25
cc_6258 ( N_RN_c_8772_n N_noxref_18_c_9555_n ) capacitor c=4.13352e-19 \
 //x=79.67 //y=2.57 //x2=79.86 //y2=5.335
cc_6259 ( N_RN_c_8131_n N_noxref_18_c_9555_n ) capacitor c=0.00239361f \
 //x=79.67 //y=4.765 //x2=79.86 //y2=5.335
cc_6260 ( N_RN_c_8806_n N_noxref_18_c_9555_n ) capacitor c=0.00132214f \
 //x=79.67 //y=4.88 //x2=79.86 //y2=5.335
cc_6261 ( N_RN_M159_noxref_g N_noxref_18_c_9555_n ) capacitor c=0.00229818f \
 //x=79.64 //y=6.2 //x2=79.86 //y2=5.335
cc_6262 ( N_RN_M160_noxref_g N_noxref_18_c_9555_n ) capacitor c=0.00230699f \
 //x=80.08 //y=6.2 //x2=79.86 //y2=5.335
cc_6263 ( N_RN_c_8854_p N_noxref_18_c_9555_n ) capacitor c=0.0017897f \
 //x=80.005 //y=4.97 //x2=79.86 //y2=5.335
cc_6264 ( N_RN_c_8131_n N_noxref_18_c_9576_n ) capacitor c=7.85344e-19 \
 //x=79.67 //y=4.765 //x2=79.86 //y2=5.56
cc_6265 ( N_RN_M159_noxref_g N_noxref_18_c_9576_n ) capacitor c=0.0179041f \
 //x=79.64 //y=6.2 //x2=79.86 //y2=5.56
cc_6266 ( N_RN_M160_noxref_g N_noxref_18_c_9576_n ) capacitor c=0.0179041f \
 //x=80.08 //y=6.2 //x2=79.86 //y2=5.56
cc_6267 ( N_RN_c_8854_p N_noxref_18_c_9576_n ) capacitor c=0.00290085f \
 //x=80.005 //y=4.97 //x2=79.86 //y2=5.56
cc_6268 ( N_RN_c_7855_n SN ) capacitor c=0.0158656f //x=13.795 //y=2.4 \
 //x2=12.33 //y2=2.77
cc_6269 ( N_RN_c_8024_n SN ) capacitor c=0.0160155f //x=42.825 //y=2.385 \
 //x2=26.76 //y2=2.77
cc_6270 ( N_RN_c_8024_n SN ) capacitor c=0.0158656f //x=42.825 //y=2.385 \
 //x2=41.19 //y2=2.77
cc_6271 ( N_RN_c_8353_n SN ) capacitor c=0.0160305f //x=71.685 //y=2.385 \
 //x2=55.62 //y2=2.77
cc_6272 ( N_RN_c_8353_n SN ) capacitor c=0.0158656f //x=71.685 //y=2.385 \
 //x2=70.05 //y2=2.77
cc_6273 ( N_RN_c_7855_n N_SN_c_9841_n ) capacitor c=0.0160575f //x=13.795 \
 //y=2.4 //x2=12.33 //y2=2.375
cc_6274 ( N_RN_c_7855_n N_SN_c_9844_n ) capacitor c=0.00335599f //x=13.795 \
 //y=2.4 //x2=12.33 //y2=3.285
cc_6275 ( N_RN_c_8024_n N_SN_c_9931_n ) capacitor c=0.0171377f //x=42.825 \
 //y=2.385 //x2=26.76 //y2=2.375
cc_6276 ( N_RN_c_8024_n N_SN_c_9934_n ) capacitor c=0.00322027f //x=42.825 \
 //y=2.385 //x2=26.76 //y2=3.305
cc_6277 ( N_RN_c_8024_n N_SN_c_10111_n ) capacitor c=0.0160575f //x=42.825 \
 //y=2.385 //x2=41.19 //y2=2.375
cc_6278 ( N_RN_c_8024_n N_SN_c_10114_n ) capacitor c=0.00336333f //x=42.825 \
 //y=2.385 //x2=41.19 //y2=3.285
cc_6279 ( N_RN_c_8353_n N_SN_c_10239_n ) capacitor c=0.0171011f //x=71.685 \
 //y=2.385 //x2=55.62 //y2=2.375
cc_6280 ( N_RN_c_8353_n N_SN_c_10242_n ) capacitor c=0.00321394f //x=71.685 \
 //y=2.385 //x2=55.62 //y2=3.305
cc_6281 ( N_RN_c_8353_n N_SN_c_10394_n ) capacitor c=0.0160575f //x=71.685 \
 //y=2.385 //x2=70.05 //y2=2.375
cc_6282 ( N_RN_c_8353_n N_SN_c_10397_n ) capacitor c=0.00336333f //x=71.685 \
 //y=2.385 //x2=70.05 //y2=3.285
cc_6283 ( N_RN_c_7855_n N_SN_c_9884_n ) capacitor c=0.0663257f //x=13.795 \
 //y=2.4 //x2=13.795 //y2=3.14
cc_6284 ( N_RN_c_7890_n N_SN_c_9887_n ) capacitor c=0.0079703f //x=14.395 \
 //y=2.385 //x2=14.395 //y2=3.155
cc_6285 ( N_RN_c_7894_n N_SN_c_9890_n ) capacitor c=0.00798153f //x=15.655 \
 //y=2.4 //x2=15.655 //y2=3.14
cc_6286 ( N_RN_c_7897_n N_SN_c_9894_n ) capacitor c=0.00444866f //x=16.255 \
 //y=2.385 //x2=16.255 //y2=3.155
cc_6287 ( N_RN_c_7903_n N_SN_c_9894_n ) capacitor c=0.080866f //x=18.415 \
 //y=2.4 //x2=16.255 //y2=3.155
cc_6288 ( RN N_SN_c_9915_n ) capacitor c=0.0242602f //x=18.25 //y=2.77 \
 //x2=20.45 //y2=3.14
cc_6289 ( N_RN_c_8045_n N_SN_c_9915_n ) capacitor c=0.00225794f //x=18.25 \
 //y=2.565 //x2=20.45 //y2=3.14
cc_6290 ( N_RN_c_7947_n N_SN_c_9915_n ) capacitor c=0.126859f //x=21.785 \
 //y=2.4 //x2=20.45 //y2=3.14
cc_6291 ( N_RN_c_7903_n N_SN_c_9915_n ) capacitor c=0.0161618f //x=18.415 \
 //y=2.4 //x2=20.45 //y2=3.14
cc_6292 ( N_RN_c_8024_n N_SN_c_10119_n ) capacitor c=0.0152443f //x=42.825 \
 //y=2.385 //x2=32.905 //y2=3.13
cc_6293 ( RN N_SN_c_9921_n ) capacitor c=0.0288444f //x=21.95 //y=2.77 \
 //x2=32.475 //y2=3.13
cc_6294 ( RN N_SN_c_9921_n ) capacitor c=0.0303478f //x=31.57 //y=2.77 \
 //x2=32.475 //y2=3.13
cc_6295 ( N_RN_c_7926_n N_SN_c_9921_n ) capacitor c=0.00227051f //x=21.95 \
 //y=2.57 //x2=32.475 //y2=3.13
cc_6296 ( N_RN_c_8182_n N_SN_c_9921_n ) capacitor c=0.00224718f //x=31.57 \
 //y=2.56 //x2=32.475 //y2=3.13
cc_6297 ( N_RN_c_7947_n N_SN_c_9921_n ) capacitor c=0.0308846f //x=21.785 \
 //y=2.4 //x2=32.475 //y2=3.13
cc_6298 ( N_RN_c_8006_n N_SN_c_9921_n ) capacitor c=0.00707123f //x=24 \
 //y=2.37 //x2=32.475 //y2=3.13
cc_6299 ( N_RN_c_7953_n N_SN_c_9921_n ) capacitor c=0.0878127f //x=23.57 \
 //y=2.37 //x2=32.475 //y2=3.13
cc_6300 ( N_RN_c_8014_n N_SN_c_9921_n ) capacitor c=0.00890924f //x=25.265 \
 //y=2.4 //x2=32.475 //y2=3.13
cc_6301 ( N_RN_c_8024_n N_SN_c_9921_n ) capacitor c=0.326303f //x=42.825 \
 //y=2.385 //x2=32.475 //y2=3.13
cc_6302 ( N_RN_c_8024_n N_SN_c_10122_n ) capacitor c=0.00700789f //x=42.825 \
 //y=2.385 //x2=33.64 //y2=3.17
cc_6303 ( N_RN_c_8024_n N_SN_c_10126_n ) capacitor c=0.00357143f //x=42.825 \
 //y=2.385 //x2=34.89 //y2=3.14
cc_6304 ( N_RN_c_8024_n N_SN_c_10131_n ) capacitor c=0.0159681f //x=42.825 \
 //y=2.385 //x2=35.49 //y2=3.17
cc_6305 ( N_RN_c_8024_n N_SN_c_10134_n ) capacitor c=0.00341774f //x=42.825 \
 //y=2.385 //x2=37.845 //y2=3.14
cc_6306 ( N_RN_c_8024_n N_SN_c_10135_n ) capacitor c=0.0069945f //x=42.825 \
 //y=2.385 //x2=38.445 //y2=3.11
cc_6307 ( N_RN_c_8024_n N_SN_c_10137_n ) capacitor c=0.00890914f //x=42.825 \
 //y=2.385 //x2=39.695 //y2=3.14
cc_6308 ( N_RN_c_8218_n N_SN_c_10178_n ) capacitor c=0.0079703f //x=43.255 \
 //y=2.385 //x2=43.255 //y2=3.155
cc_6309 ( N_RN_c_8024_n N_SN_c_10143_n ) capacitor c=0.113889f //x=42.825 \
 //y=2.385 //x2=42.91 //y2=3.155
cc_6310 ( N_RN_c_8226_n N_SN_c_10184_n ) capacitor c=0.00798153f //x=44.515 \
 //y=2.4 //x2=44.515 //y2=3.14
cc_6311 ( N_RN_c_8229_n N_SN_c_10188_n ) capacitor c=0.00444866f //x=45.115 \
 //y=2.385 //x2=45.115 //y2=3.155
cc_6312 ( N_RN_c_8235_n N_SN_c_10188_n ) capacitor c=0.080866f //x=47.275 \
 //y=2.4 //x2=45.115 //y2=3.155
cc_6313 ( RN N_SN_c_10225_n ) capacitor c=0.0242602f //x=47.11 //y=2.77 \
 //x2=49.31 //y2=3.14
cc_6314 ( N_RN_c_8374_n N_SN_c_10225_n ) capacitor c=0.00225794f //x=47.11 \
 //y=2.565 //x2=49.31 //y2=3.14
cc_6315 ( N_RN_c_8275_n N_SN_c_10225_n ) capacitor c=0.126859f //x=50.645 \
 //y=2.4 //x2=49.31 //y2=3.14
cc_6316 ( N_RN_c_8235_n N_SN_c_10225_n ) capacitor c=0.0161618f //x=47.275 \
 //y=2.4 //x2=49.31 //y2=3.14
cc_6317 ( RN N_SN_c_10228_n ) capacitor c=0.0293692f //x=50.81 //y=2.77 \
 //x2=49.91 //y2=3.125
cc_6318 ( N_RN_c_8258_n N_SN_c_10228_n ) capacitor c=0.00227051f //x=50.81 \
 //y=2.57 //x2=49.91 //y2=3.125
cc_6319 ( N_RN_c_8275_n N_SN_c_10228_n ) capacitor c=0.0308846f //x=50.645 \
 //y=2.4 //x2=49.91 //y2=3.125
cc_6320 ( N_RN_c_8281_n N_SN_c_10228_n ) capacitor c=0.0773025f //x=52.49 \
 //y=2.37 //x2=49.91 //y2=3.125
cc_6321 ( N_RN_c_8335_n N_SN_c_10248_n ) capacitor c=0.00643229f //x=52.92 \
 //y=2.37 //x2=55.46 //y2=3.14
cc_6322 ( N_RN_c_8281_n N_SN_c_10248_n ) capacitor c=0.0171792f //x=52.49 \
 //y=2.37 //x2=55.46 //y2=3.14
cc_6323 ( N_RN_c_8343_n N_SN_c_10248_n ) capacitor c=0.00862161f //x=54.08 \
 //y=2.4 //x2=55.46 //y2=3.14
cc_6324 ( N_RN_c_8353_n N_SN_c_10248_n ) capacitor c=0.0318747f //x=71.685 \
 //y=2.385 //x2=55.46 //y2=3.14
cc_6325 ( N_RN_c_8353_n N_SN_c_10402_n ) capacitor c=0.0152443f //x=71.685 \
 //y=2.385 //x2=61.765 //y2=3.13
cc_6326 ( RN N_SN_c_10255_n ) capacitor c=0.0287355f //x=60.43 //y=2.77 \
 //x2=61.335 //y2=3.13
cc_6327 ( N_RN_c_8476_n N_SN_c_10255_n ) capacitor c=0.00224718f //x=60.43 \
 //y=2.56 //x2=61.335 //y2=3.13
cc_6328 ( N_RN_c_8353_n N_SN_c_10255_n ) capacitor c=0.29681f //x=71.685 \
 //y=2.385 //x2=61.335 //y2=3.13
cc_6329 ( N_RN_c_8353_n N_SN_c_10405_n ) capacitor c=0.00700789f //x=71.685 \
 //y=2.385 //x2=62.5 //y2=3.17
cc_6330 ( N_RN_c_8353_n N_SN_c_10409_n ) capacitor c=0.00357143f //x=71.685 \
 //y=2.385 //x2=63.75 //y2=3.14
cc_6331 ( N_RN_c_8353_n N_SN_c_10414_n ) capacitor c=0.0159681f //x=71.685 \
 //y=2.385 //x2=64.35 //y2=3.17
cc_6332 ( N_RN_c_8353_n N_SN_c_10417_n ) capacitor c=0.00341774f //x=71.685 \
 //y=2.385 //x2=66.705 //y2=3.14
cc_6333 ( N_RN_c_8353_n N_SN_c_10418_n ) capacitor c=0.0069945f //x=71.685 \
 //y=2.385 //x2=67.305 //y2=3.11
cc_6334 ( N_RN_c_8353_n N_SN_c_10420_n ) capacitor c=0.00890914f //x=71.685 \
 //y=2.385 //x2=68.555 //y2=3.14
cc_6335 ( N_RN_c_8611_n N_SN_c_10461_n ) capacitor c=0.0079703f //x=72.115 \
 //y=2.385 //x2=72.115 //y2=3.155
cc_6336 ( N_RN_c_8353_n N_SN_c_10426_n ) capacitor c=0.113889f //x=71.685 \
 //y=2.385 //x2=71.77 //y2=3.155
cc_6337 ( N_RN_c_8619_n N_SN_c_10467_n ) capacitor c=0.00798153f //x=73.375 \
 //y=2.4 //x2=73.375 //y2=3.14
cc_6338 ( N_RN_c_8622_n N_SN_c_10471_n ) capacitor c=0.00444866f //x=73.975 \
 //y=2.385 //x2=73.975 //y2=3.155
cc_6339 ( N_RN_c_8628_n N_SN_c_10471_n ) capacitor c=0.080866f //x=76.135 \
 //y=2.4 //x2=73.975 //y2=3.155
cc_6340 ( RN N_SN_c_10502_n ) capacitor c=0.0242602f //x=75.97 //y=2.77 \
 //x2=78.17 //y2=3.14
cc_6341 ( N_RN_c_8660_n N_SN_c_10502_n ) capacitor c=0.00225794f //x=75.97 \
 //y=2.565 //x2=78.17 //y2=3.14
cc_6342 ( N_RN_c_8628_n N_SN_c_10502_n ) capacitor c=0.0161618f //x=76.135 \
 //y=2.4 //x2=78.17 //y2=3.14
cc_6343 ( N_RN_c_8792_n N_SN_c_10502_n ) capacitor c=0.126859f //x=79.505 \
 //y=2.41 //x2=78.17 //y2=3.14
cc_6344 ( RN N_SN_c_10530_n ) capacitor c=0.0288444f //x=79.67 //y=2.77 \
 //x2=78.77 //y2=3.125
cc_6345 ( N_RN_c_8772_n N_SN_c_10530_n ) capacitor c=0.00227051f //x=79.67 \
 //y=2.57 //x2=78.77 //y2=3.125
cc_6346 ( N_RN_c_8790_n N_SN_c_10530_n ) capacitor c=0.0163271f //x=79.665 \
 //y=2.41 //x2=78.77 //y2=3.125
cc_6347 ( N_RN_c_8792_n N_SN_c_10530_n ) capacitor c=0.0308846f //x=79.505 \
 //y=2.41 //x2=78.77 //y2=3.125
cc_6348 ( N_RN_c_7855_n N_SN_c_9849_n ) capacitor c=0.016591f //x=13.795 \
 //y=2.4 //x2=12.49 //y2=3.125
cc_6349 ( N_RN_c_7855_n N_SN_c_9850_n ) capacitor c=5.2767e-19 //x=13.795 \
 //y=2.4 //x2=12.33 //y2=2.26
cc_6350 ( N_RN_c_8024_n N_SN_c_9947_n ) capacitor c=5.2767e-19 //x=42.825 \
 //y=2.385 //x2=26.76 //y2=2.26
cc_6351 ( N_RN_c_8024_n N_SN_c_10144_n ) capacitor c=5.2767e-19 //x=42.825 \
 //y=2.385 //x2=41.19 //y2=2.26
cc_6352 ( N_RN_c_8353_n N_SN_c_10257_n ) capacitor c=5.2767e-19 //x=71.685 \
 //y=2.385 //x2=55.62 //y2=2.26
cc_6353 ( N_RN_c_8353_n N_SN_c_10427_n ) capacitor c=5.2767e-19 //x=71.685 \
 //y=2.385 //x2=70.05 //y2=2.26
cc_6354 ( N_RN_c_7855_n N_SN_c_9869_n ) capacitor c=4.03361e-19 //x=13.795 \
 //y=2.4 //x2=12.42 //y2=2.095
cc_6355 ( N_RN_c_8024_n N_SN_c_9966_n ) capacitor c=4.03361e-19 //x=42.825 \
 //y=2.385 //x2=26.85 //y2=2.095
cc_6356 ( N_RN_c_8024_n N_SN_c_10163_n ) capacitor c=4.03361e-19 //x=42.825 \
 //y=2.385 //x2=41.28 //y2=2.095
cc_6357 ( N_RN_c_8353_n N_SN_c_10276_n ) capacitor c=4.03361e-19 //x=71.685 \
 //y=2.385 //x2=55.71 //y2=2.095
cc_6358 ( N_RN_c_8353_n N_SN_c_10446_n ) capacitor c=4.03361e-19 //x=71.685 \
 //y=2.385 //x2=70.14 //y2=2.095
cc_6359 ( N_RN_c_8353_n N_noxref_20_c_11147_n ) capacitor c=0.0160806f \
 //x=71.685 //y=2.385 //x2=66.35 //y2=2.375
cc_6360 ( N_RN_c_8353_n N_noxref_20_c_11071_n ) capacitor c=0.0129637f \
 //x=71.685 //y=2.385 //x2=66.35 //y2=3.735
cc_6361 ( N_RN_c_8353_n N_noxref_20_c_11082_n ) capacitor c=0.0167111f \
 //x=71.685 //y=2.385 //x2=71.16 //y2=2.375
cc_6362 ( N_RN_c_8353_n N_noxref_20_c_11078_n ) capacitor c=0.0154065f \
 //x=71.685 //y=2.385 //x2=71.16 //y2=3.735
cc_6363 ( N_RN_M155_noxref_g N_noxref_20_c_11047_n ) capacitor c=0.00929107f \
 //x=75.71 //y=6.2 //x2=75.815 //y2=5.335
cc_6364 ( N_RN_M155_noxref_g N_noxref_20_c_11284_n ) capacitor c=0.00226521f \
 //x=75.71 //y=6.2 //x2=75.93 //y2=5.56
cc_6365 ( N_RN_M156_noxref_g N_noxref_20_c_11284_n ) capacitor c=0.00381703f \
 //x=76.15 //y=6.2 //x2=75.93 //y2=5.56
cc_6366 ( N_RN_c_8128_n N_noxref_20_c_11050_n ) capacitor c=0.00228791f \
 //x=75.97 //y=4.75 //x2=76.625 //y2=5.335
cc_6367 ( N_RN_c_8705_n N_noxref_20_c_11050_n ) capacitor c=0.00130631f \
 //x=75.97 //y=4.88 //x2=76.625 //y2=5.335
cc_6368 ( N_RN_M156_noxref_g N_noxref_20_c_11050_n ) capacitor c=0.0108688f \
 //x=76.15 //y=6.2 //x2=76.625 //y2=5.335
cc_6369 ( N_RN_c_8660_n N_noxref_20_c_11289_n ) capacitor c=4.88647e-19 \
 //x=75.97 //y=2.565 //x2=76.225 //y2=1.305
cc_6370 ( N_RN_c_8628_n N_noxref_20_c_11289_n ) capacitor c=3.86337e-19 \
 //x=76.135 //y=2.4 //x2=76.225 //y2=1.305
cc_6371 ( N_RN_c_8723_n N_noxref_20_c_11289_n ) capacitor c=4.64015e-19 \
 //x=75.96 //y=1.095 //x2=76.225 //y2=1.305
cc_6372 ( N_RN_c_8724_n N_noxref_20_c_11289_n ) capacitor c=0.0026012f \
 //x=75.96 //y=1.44 //x2=76.225 //y2=1.305
cc_6373 ( N_RN_c_8964_p N_noxref_20_c_11289_n ) capacitor c=5.29969e-19 \
 //x=76.335 //y=0.94 //x2=76.225 //y2=1.305
cc_6374 ( N_RN_c_8965_p N_noxref_20_c_11289_n ) capacitor c=4.41409e-19 \
 //x=76.335 //y=1.595 //x2=76.225 //y2=1.305
cc_6375 ( N_RN_c_8966_p N_noxref_20_c_11289_n ) capacitor c=5.24634e-19 \
 //x=76.49 //y=1.095 //x2=76.225 //y2=1.305
cc_6376 ( N_RN_c_8967_p N_noxref_20_c_11289_n ) capacitor c=0.00307978f \
 //x=76.49 //y=1.44 //x2=76.225 //y2=1.305
cc_6377 ( N_RN_c_8724_n N_noxref_20_c_11297_n ) capacitor c=0.00127432f \
 //x=75.96 //y=1.44 //x2=76.225 //y2=1.76
cc_6378 ( N_RN_c_8725_n N_noxref_20_c_11297_n ) capacitor c=0.00441386f \
 //x=75.96 //y=1.75 //x2=76.225 //y2=1.76
cc_6379 ( N_RN_c_8965_p N_noxref_20_c_11297_n ) capacitor c=0.00942306f \
 //x=76.335 //y=1.595 //x2=76.225 //y2=1.76
cc_6380 ( N_RN_c_8967_p N_noxref_20_c_11297_n ) capacitor c=0.00363411f \
 //x=76.49 //y=1.44 //x2=76.225 //y2=1.76
cc_6381 ( N_RN_c_8745_n N_noxref_20_c_11297_n ) capacitor c=0.0036273f \
 //x=75.97 //y=2.095 //x2=76.225 //y2=1.76
cc_6382 ( N_RN_c_8965_p N_noxref_20_c_11302_n ) capacitor c=0.00194716f \
 //x=76.335 //y=1.595 //x2=76.625 //y2=1.845
cc_6383 ( N_RN_c_8967_p N_noxref_20_c_11302_n ) capacitor c=0.00323576f \
 //x=76.49 //y=1.44 //x2=76.625 //y2=1.845
cc_6384 ( N_RN_c_8792_n N_noxref_20_c_11099_n ) capacitor c=0.021648f \
 //x=79.505 //y=2.41 //x2=76.31 //y2=1.845
cc_6385 ( RN N_noxref_20_c_11164_n ) capacitor c=0.0475066f //x=75.97 //y=2.77 \
 //x2=76.71 //y2=3.735
cc_6386 ( RN N_noxref_20_c_11164_n ) capacitor c=0.00180128f //x=79.67 \
 //y=2.77 //x2=76.71 //y2=3.735
cc_6387 ( N_RN_c_8660_n N_noxref_20_c_11164_n ) capacitor c=0.0217159f \
 //x=75.97 //y=2.565 //x2=76.71 //y2=3.735
cc_6388 ( N_RN_c_8628_n N_noxref_20_c_11164_n ) capacitor c=0.00328982f \
 //x=76.135 //y=2.4 //x2=76.71 //y2=3.735
cc_6389 ( N_RN_c_8792_n N_noxref_20_c_11164_n ) capacitor c=0.0300597f \
 //x=79.505 //y=2.41 //x2=76.71 //y2=3.735
cc_6390 ( N_RN_c_8702_n N_noxref_20_c_11164_n ) capacitor c=9.86766e-19 \
 //x=75.97 //y=2.26 //x2=76.71 //y2=3.735
cc_6391 ( N_RN_c_8742_n N_noxref_20_c_11164_n ) capacitor c=0.00117465f \
 //x=75.97 //y=2.26 //x2=76.71 //y2=3.735
cc_6392 ( N_RN_c_8745_n N_noxref_20_c_11164_n ) capacitor c=0.00282067f \
 //x=75.97 //y=2.095 //x2=76.71 //y2=3.735
cc_6393 ( RN N_noxref_20_c_11225_n ) capacitor c=0.0152522f //x=75.97 //y=2.77 \
 //x2=76.71 //y2=4.055
cc_6394 ( RN N_noxref_20_c_11051_n ) capacitor c=0.0260942f //x=75.97 //y=2.77 \
 //x2=76.71 //y2=5.25
cc_6395 ( RN N_noxref_20_c_11051_n ) capacitor c=6.61562e-19 //x=79.67 \
 //y=2.77 //x2=76.71 //y2=5.25
cc_6396 ( N_RN_c_8128_n N_noxref_20_c_11051_n ) capacitor c=0.0148347f \
 //x=75.97 //y=4.75 //x2=76.71 //y2=5.25
cc_6397 ( N_RN_c_8705_n N_noxref_20_c_11051_n ) capacitor c=0.00131258f \
 //x=75.97 //y=4.88 //x2=76.71 //y2=5.25
cc_6398 ( N_RN_c_8180_n N_noxref_20_c_11051_n ) capacitor c=0.00739875f \
 //x=75.97 //y=4.88 //x2=76.71 //y2=5.25
cc_6399 ( N_RN_c_8660_n N_noxref_20_c_11319_n ) capacitor c=4.4094e-19 \
 //x=75.97 //y=2.565 //x2=75.93 //y2=5.335
cc_6400 ( N_RN_c_8128_n N_noxref_20_c_11319_n ) capacitor c=0.0221596f \
 //x=75.97 //y=4.75 //x2=75.93 //y2=5.335
cc_6401 ( N_RN_c_8705_n N_noxref_20_c_11319_n ) capacitor c=0.00346456f \
 //x=75.97 //y=4.88 //x2=75.93 //y2=5.335
cc_6402 ( N_RN_c_8180_n N_noxref_20_c_11319_n ) capacitor c=0.00203307f \
 //x=75.97 //y=4.88 //x2=75.93 //y2=5.335
cc_6403 ( RN N_noxref_20_c_11323_n ) capacitor c=9.19401e-19 //x=75.97 \
 //y=2.77 //x2=76.71 //y2=3.88
cc_6404 ( RN N_noxref_20_c_11060_n ) capacitor c=0.0216043f //x=75.97 //y=2.77 \
 //x2=76.54 //y2=3.88
cc_6405 ( RN N_noxref_20_c_11063_n ) capacitor c=0.0265996f //x=79.67 //y=2.77 \
 //x2=78.77 //y2=3.895
cc_6406 ( N_RN_c_8792_n N_noxref_20_c_11063_n ) capacitor c=0.00274327f \
 //x=79.505 //y=2.41 //x2=78.77 //y2=3.895
cc_6407 ( RN N_noxref_20_c_11064_n ) capacitor c=0.00340182f //x=75.97 \
 //y=2.77 //x2=78.425 //y2=3.895
cc_6408 ( N_RN_c_8353_n N_noxref_20_c_11176_n ) capacitor c=2.63835e-19 \
 //x=71.685 //y=2.385 //x2=66.35 //y2=2.26
cc_6409 ( N_RN_c_8353_n N_noxref_20_c_11109_n ) capacitor c=2.63835e-19 \
 //x=71.685 //y=2.385 //x2=71.16 //y2=2.26
cc_6410 ( N_RN_c_8128_n N_noxref_20_c_11330_n ) capacitor c=0.00266871f \
 //x=75.97 //y=4.75 //x2=75.93 //y2=5.56
cc_6411 ( N_RN_c_8705_n N_noxref_20_c_11330_n ) capacitor c=0.00624059f \
 //x=75.97 //y=4.88 //x2=75.93 //y2=5.56
cc_6412 ( N_RN_M155_noxref_g N_noxref_20_c_11330_n ) capacitor c=0.0178885f \
 //x=75.71 //y=6.2 //x2=75.93 //y2=5.56
cc_6413 ( N_RN_M156_noxref_g N_noxref_20_c_11330_n ) capacitor c=0.0188608f \
 //x=76.15 //y=6.2 //x2=75.93 //y2=5.56
cc_6414 ( N_RN_c_8180_n N_noxref_20_c_11330_n ) capacitor c=0.00375636f \
 //x=75.97 //y=4.88 //x2=75.93 //y2=5.56
cc_6415 ( N_RN_c_8353_n N_noxref_20_c_11193_n ) capacitor c=3.41298e-19 \
 //x=71.685 //y=2.385 //x2=66.35 //y2=2.26
cc_6416 ( N_RN_c_8353_n N_noxref_20_c_11141_n ) capacitor c=3.41298e-19 \
 //x=71.685 //y=2.385 //x2=71.16 //y2=2.26
cc_6417 ( N_RN_c_8723_n N_noxref_20_M47_noxref_d ) capacitor c=0.00137165f \
 //x=75.96 //y=1.095 //x2=76.035 //y2=1.095
cc_6418 ( N_RN_c_8724_n N_noxref_20_M47_noxref_d ) capacitor c=0.00237422f \
 //x=75.96 //y=1.44 //x2=76.035 //y2=1.095
cc_6419 ( N_RN_c_8964_p N_noxref_20_M47_noxref_d ) capacitor c=0.0020782f \
 //x=76.335 //y=0.94 //x2=76.035 //y2=1.095
cc_6420 ( N_RN_c_8965_p N_noxref_20_M47_noxref_d ) capacitor c=0.00356097f \
 //x=76.335 //y=1.595 //x2=76.035 //y2=1.095
cc_6421 ( N_RN_c_8966_p N_noxref_20_M47_noxref_d ) capacitor c=0.00139206f \
 //x=76.49 //y=1.095 //x2=76.035 //y2=1.095
cc_6422 ( N_RN_c_8967_p N_noxref_20_M47_noxref_d ) capacitor c=0.00237422f \
 //x=76.49 //y=1.44 //x2=76.035 //y2=1.095
cc_6423 ( N_RN_c_8772_n N_noxref_21_c_11711_n ) capacitor c=0.00959563f \
 //x=79.67 //y=2.57 //x2=80.78 //y2=2.485
cc_6424 ( N_RN_c_8790_n N_noxref_21_c_11711_n ) capacitor c=0.00179573f \
 //x=79.665 //y=2.41 //x2=80.78 //y2=2.485
cc_6425 ( N_RN_c_8803_n N_noxref_21_c_11711_n ) capacitor c=5.67353e-19 \
 //x=79.67 //y=2.26 //x2=80.78 //y2=2.485
cc_6426 ( N_RN_c_8832_n N_noxref_21_c_11711_n ) capacitor c=6.05662e-19 \
 //x=79.76 //y=2.095 //x2=80.78 //y2=2.485
cc_6427 ( RN N_noxref_21_c_11652_n ) capacitor c=0.0543045f //x=79.67 //y=2.77 \
 //x2=80.78 //y2=4.75
cc_6428 ( N_RN_c_8772_n N_noxref_21_c_11652_n ) capacitor c=0.00227555f \
 //x=79.67 //y=2.57 //x2=80.78 //y2=4.75
cc_6429 ( N_RN_c_8131_n N_noxref_21_c_11652_n ) capacitor c=0.0107551f \
 //x=79.67 //y=4.765 //x2=80.78 //y2=4.75
cc_6430 ( N_RN_c_8790_n N_noxref_21_c_11652_n ) capacitor c=0.001364f \
 //x=79.665 //y=2.41 //x2=80.78 //y2=4.75
cc_6431 ( N_RN_c_8806_n N_noxref_21_c_11652_n ) capacitor c=9.52396e-19 \
 //x=79.67 //y=4.88 //x2=80.78 //y2=4.75
cc_6432 ( N_RN_c_8838_n N_noxref_21_c_11652_n ) capacitor c=8.42568e-19 \
 //x=79.67 //y=4.88 //x2=80.78 //y2=4.75
cc_6433 ( N_RN_c_8772_n N_noxref_21_c_11721_n ) capacitor c=0.00376136f \
 //x=79.67 //y=2.57 //x2=80.77 //y2=2.325
cc_6434 ( N_RN_c_8790_n N_noxref_21_c_11721_n ) capacitor c=0.00760524f \
 //x=79.665 //y=2.41 //x2=80.77 //y2=2.325
cc_6435 ( N_RN_c_8772_n N_noxref_21_c_11723_n ) capacitor c=7.68433e-19 \
 //x=79.67 //y=2.57 //x2=80.78 //y2=2.26
cc_6436 ( N_RN_c_8803_n N_noxref_21_c_11723_n ) capacitor c=0.00124638f \
 //x=79.67 //y=2.26 //x2=80.78 //y2=2.26
cc_6437 ( N_RN_c_8832_n N_noxref_21_c_11723_n ) capacitor c=0.00178426f \
 //x=79.76 //y=2.095 //x2=80.78 //y2=2.26
cc_6438 ( RN N_noxref_21_c_11726_n ) capacitor c=2.94497e-19 //x=79.67 \
 //y=2.77 //x2=80.78 //y2=4.88
cc_6439 ( N_RN_c_8131_n N_noxref_21_c_11726_n ) capacitor c=4.56604e-19 \
 //x=79.67 //y=4.765 //x2=80.78 //y2=4.88
cc_6440 ( N_RN_c_8806_n N_noxref_21_c_11726_n ) capacitor c=0.00113985f \
 //x=79.67 //y=4.88 //x2=80.78 //y2=4.88
cc_6441 ( N_RN_c_8838_n N_noxref_21_c_11726_n ) capacitor c=0.00129812f \
 //x=79.67 //y=4.88 //x2=80.78 //y2=4.88
cc_6442 ( N_RN_M159_noxref_g N_noxref_21_M161_noxref_g ) capacitor \
 c=0.0101598f //x=79.64 //y=6.2 //x2=80.52 //y2=6.2
cc_6443 ( N_RN_M160_noxref_g N_noxref_21_M161_noxref_g ) capacitor \
 c=0.0607518f //x=80.08 //y=6.2 //x2=80.52 //y2=6.2
cc_6444 ( N_RN_M160_noxref_g N_noxref_21_M162_noxref_g ) capacitor \
 c=0.0101598f //x=80.08 //y=6.2 //x2=80.96 //y2=6.2
cc_6445 ( N_RN_c_8829_n N_noxref_21_c_11733_n ) capacitor c=0.00456962f \
 //x=79.76 //y=1.09 //x2=80.77 //y2=1.095
cc_6446 ( N_RN_c_8830_n N_noxref_21_c_11734_n ) capacitor c=0.00438372f \
 //x=79.76 //y=1.4 //x2=80.77 //y2=1.44
cc_6447 ( N_RN_c_8831_n N_noxref_21_c_11735_n ) capacitor c=0.00438372f \
 //x=79.76 //y=1.63 //x2=80.77 //y2=1.75
cc_6448 ( N_RN_c_8803_n N_noxref_21_c_11736_n ) capacitor c=0.0015892f \
 //x=79.67 //y=2.26 //x2=80.78 //y2=2.26
cc_6449 ( N_RN_c_8832_n N_noxref_21_c_11736_n ) capacitor c=0.00779433f \
 //x=79.76 //y=2.095 //x2=80.78 //y2=2.26
cc_6450 ( N_RN_c_8832_n N_noxref_21_c_11738_n ) capacitor c=0.00438372f \
 //x=79.76 //y=2.095 //x2=80.78 //y2=2.095
cc_6451 ( N_RN_c_8131_n N_noxref_21_c_11739_n ) capacitor c=0.00124604f \
 //x=79.67 //y=4.765 //x2=80.78 //y2=4.88
cc_6452 ( N_RN_c_8806_n N_noxref_21_c_11739_n ) capacitor c=0.00187046f \
 //x=79.67 //y=4.88 //x2=80.78 //y2=4.88
cc_6453 ( N_RN_c_8854_p N_noxref_21_c_11739_n ) capacitor c=0.0616777f \
 //x=80.005 //y=4.97 //x2=80.78 //y2=4.88
cc_6454 ( N_RN_c_8838_n N_noxref_21_c_11739_n ) capacitor c=0.00487508f \
 //x=79.67 //y=4.88 //x2=80.78 //y2=4.88
cc_6455 ( N_RN_c_8258_n N_noxref_22_c_12335_n ) capacitor c=0.00816784f \
 //x=50.81 //y=2.57 //x2=51.92 //y2=2.375
cc_6456 ( N_RN_c_8281_n N_noxref_22_c_12335_n ) capacitor c=0.0178777f \
 //x=52.49 //y=2.37 //x2=51.92 //y2=2.375
cc_6457 ( N_RN_c_8289_n N_noxref_22_c_12335_n ) capacitor c=5.39999e-19 \
 //x=50.81 //y=2.26 //x2=51.92 //y2=2.375
cc_6458 ( N_RN_c_8318_n N_noxref_22_c_12335_n ) capacitor c=6.8688e-19 \
 //x=50.9 //y=2.095 //x2=51.92 //y2=2.375
cc_6459 ( RN N_noxref_22_c_12331_n ) capacitor c=0.0202016f //x=50.81 //y=2.77 \
 //x2=51.92 //y2=3.365
cc_6460 ( N_RN_c_8258_n N_noxref_22_c_12331_n ) capacitor c=0.00379733f \
 //x=50.81 //y=2.57 //x2=51.92 //y2=3.365
cc_6461 ( N_RN_c_8281_n N_noxref_22_c_12331_n ) capacitor c=0.0165188f \
 //x=52.49 //y=2.37 //x2=51.92 //y2=3.365
cc_6462 ( RN N_noxref_22_c_12343_n ) capacitor c=0.00718194f //x=50.81 \
 //y=2.77 //x2=51.92 //y2=3.655
cc_6463 ( RN N_noxref_22_c_12247_n ) capacitor c=0.0246246f //x=50.81 //y=2.77 \
 //x2=51.92 //y2=4.75
cc_6464 ( N_RN_c_8126_n N_noxref_22_c_12247_n ) capacitor c=0.00753615f \
 //x=50.81 //y=4.765 //x2=51.92 //y2=4.75
cc_6465 ( N_RN_c_8151_n N_noxref_22_c_12247_n ) capacitor c=9.36945e-19 \
 //x=50.81 //y=4.88 //x2=51.92 //y2=4.75
cc_6466 ( N_RN_c_8324_n N_noxref_22_c_12247_n ) capacitor c=8.42568e-19 \
 //x=50.81 //y=4.88 //x2=51.92 //y2=4.75
cc_6467 ( N_RN_c_8353_n N_noxref_22_c_12413_n ) capacitor c=7.09459e-19 \
 //x=71.685 //y=2.385 //x2=56.985 //y2=1.305
cc_6468 ( N_RN_c_8353_n N_noxref_22_c_12354_n ) capacitor c=0.0210502f \
 //x=71.685 //y=2.385 //x2=57.07 //y2=1.845
cc_6469 ( RN N_noxref_22_c_12426_n ) capacitor c=0.00109186f //x=60.43 \
 //y=2.77 //x2=57.47 //y2=3.365
cc_6470 ( N_RN_c_8353_n N_noxref_22_c_12426_n ) capacitor c=0.0304392f \
 //x=71.685 //y=2.385 //x2=57.47 //y2=3.365
cc_6471 ( RN N_noxref_22_c_12248_n ) capacitor c=0.00120439f //x=60.43 \
 //y=2.77 //x2=57.47 //y2=5.25
cc_6472 ( RN N_noxref_22_c_12333_n ) capacitor c=4.88641e-19 //x=50.81 \
 //y=2.77 //x2=51.92 //y2=3.51
cc_6473 ( N_RN_c_8281_n N_noxref_22_c_12361_n ) capacitor c=0.00246993f \
 //x=52.49 //y=2.37 //x2=55.235 //y2=3.51
cc_6474 ( N_RN_c_8347_n N_noxref_22_c_12361_n ) capacitor c=8.72603e-19 \
 //x=54.68 //y=2.37 //x2=55.235 //y2=3.51
cc_6475 ( N_RN_c_8353_n N_noxref_22_c_12361_n ) capacitor c=0.0061573f \
 //x=71.685 //y=2.385 //x2=55.235 //y2=3.51
cc_6476 ( RN N_noxref_22_c_12334_n ) capacitor c=0.00282377f //x=50.81 \
 //y=2.77 //x2=52.08 //y2=3.51
cc_6477 ( N_RN_c_8353_n N_noxref_22_c_12445_n ) capacitor c=0.00312605f \
 //x=71.685 //y=2.385 //x2=55.835 //y2=3.53
cc_6478 ( N_RN_c_8353_n N_noxref_22_c_12447_n ) capacitor c=0.00280135f \
 //x=71.685 //y=2.385 //x2=56.345 //y2=3.51
cc_6479 ( N_RN_c_8353_n N_noxref_22_c_12480_n ) capacitor c=0.00511288f \
 //x=71.685 //y=2.385 //x2=58.935 //y2=3.88
cc_6480 ( N_RN_c_8353_n N_noxref_22_c_12453_n ) capacitor c=0.00131739f \
 //x=71.685 //y=2.385 //x2=57.63 //y2=3.88
cc_6481 ( RN N_noxref_22_c_12271_n ) capacitor c=4.9496e-19 //x=60.43 //y=2.77 \
 //x2=59.535 //y2=3.865
cc_6482 ( N_RN_c_8353_n N_noxref_22_c_12271_n ) capacitor c=0.00226492f \
 //x=71.685 //y=2.385 //x2=59.535 //y2=3.865
cc_6483 ( RN N_noxref_22_c_12272_n ) capacitor c=0.0295261f //x=60.43 //y=2.77 \
 //x2=61.165 //y2=3.88
cc_6484 ( N_RN_c_8353_n N_noxref_22_c_12272_n ) capacitor c=0.00211964f \
 //x=71.685 //y=2.385 //x2=61.165 //y2=3.88
cc_6485 ( RN N_noxref_22_c_12280_n ) capacitor c=0.0227075f //x=75.97 //y=2.77 \
 //x2=76.315 //y2=4.25
cc_6486 ( RN N_noxref_22_c_12286_n ) capacitor c=0.023508f //x=79.67 //y=2.77 \
 //x2=85.205 //y2=4.25
cc_6487 ( N_RN_c_8258_n N_noxref_22_c_12365_n ) capacitor c=0.00116223f \
 //x=50.81 //y=2.57 //x2=51.92 //y2=2.26
cc_6488 ( N_RN_c_8289_n N_noxref_22_c_12365_n ) capacitor c=0.00124908f \
 //x=50.81 //y=2.26 //x2=51.92 //y2=2.26
cc_6489 ( N_RN_c_8318_n N_noxref_22_c_12365_n ) capacitor c=0.00178498f \
 //x=50.9 //y=2.095 //x2=51.92 //y2=2.26
cc_6490 ( RN N_noxref_22_c_12366_n ) capacitor c=2.94497e-19 //x=50.81 \
 //y=2.77 //x2=51.92 //y2=4.88
cc_6491 ( N_RN_c_8126_n N_noxref_22_c_12366_n ) capacitor c=4.41153e-19 \
 //x=50.81 //y=4.765 //x2=51.92 //y2=4.88
cc_6492 ( N_RN_c_8151_n N_noxref_22_c_12366_n ) capacitor c=0.00113985f \
 //x=50.81 //y=4.88 //x2=51.92 //y2=4.88
cc_6493 ( N_RN_c_8324_n N_noxref_22_c_12366_n ) capacitor c=0.00129812f \
 //x=50.81 //y=4.88 //x2=51.92 //y2=4.88
cc_6494 ( N_RN_M123_noxref_g N_noxref_22_M125_noxref_g ) capacitor \
 c=0.0101598f //x=50.78 //y=6.2 //x2=51.66 //y2=6.2
cc_6495 ( N_RN_M124_noxref_g N_noxref_22_M125_noxref_g ) capacitor \
 c=0.0607518f //x=51.22 //y=6.2 //x2=51.66 //y2=6.2
cc_6496 ( N_RN_M124_noxref_g N_noxref_22_M126_noxref_g ) capacitor \
 c=0.0101598f //x=51.22 //y=6.2 //x2=52.1 //y2=6.2
cc_6497 ( N_RN_c_8315_n N_noxref_22_c_12379_n ) capacitor c=0.00456962f \
 //x=50.9 //y=1.09 //x2=51.91 //y2=1.095
cc_6498 ( N_RN_c_8316_n N_noxref_22_c_12381_n ) capacitor c=0.00438372f \
 //x=50.9 //y=1.4 //x2=51.91 //y2=1.44
cc_6499 ( N_RN_c_8317_n N_noxref_22_c_12384_n ) capacitor c=0.00438372f \
 //x=50.9 //y=1.63 //x2=51.91 //y2=1.75
cc_6500 ( N_RN_c_8258_n N_noxref_22_c_12397_n ) capacitor c=0.00149853f \
 //x=50.81 //y=2.57 //x2=51.92 //y2=2.26
cc_6501 ( N_RN_c_8281_n N_noxref_22_c_12397_n ) capacitor c=3.41298e-19 \
 //x=52.49 //y=2.37 //x2=51.92 //y2=2.26
cc_6502 ( N_RN_c_8289_n N_noxref_22_c_12397_n ) capacitor c=0.00204796f \
 //x=50.81 //y=2.26 //x2=51.92 //y2=2.26
cc_6503 ( N_RN_c_8318_n N_noxref_22_c_12397_n ) capacitor c=0.0087493f \
 //x=50.9 //y=2.095 //x2=51.92 //y2=2.26
cc_6504 ( N_RN_c_8318_n N_noxref_22_c_12398_n ) capacitor c=0.00438372f \
 //x=50.9 //y=2.095 //x2=51.92 //y2=2.095
cc_6505 ( N_RN_c_8126_n N_noxref_22_c_12323_n ) capacitor c=0.00118533f \
 //x=50.81 //y=4.765 //x2=51.92 //y2=4.88
cc_6506 ( N_RN_c_8151_n N_noxref_22_c_12323_n ) capacitor c=0.00187046f \
 //x=50.81 //y=4.88 //x2=51.92 //y2=4.88
cc_6507 ( N_RN_c_8174_n N_noxref_22_c_12323_n ) capacitor c=0.0616777f \
 //x=51.145 //y=4.97 //x2=51.92 //y2=4.88
cc_6508 ( N_RN_c_8324_n N_noxref_22_c_12323_n ) capacitor c=0.00487508f \
 //x=50.81 //y=4.88 //x2=51.92 //y2=4.88
cc_6509 ( N_RN_M63_noxref_g N_VDD_c_13448_n ) capacitor c=0.00705252f //x=2.68 \
 //y=6.2 //x2=3.255 //y2=7.585
cc_6510 ( N_RN_M64_noxref_g N_VDD_c_13448_n ) capacitor c=0.00755544f //x=3.12 \
 //y=6.2 //x2=3.255 //y2=7.585
cc_6511 ( N_RN_M83_noxref_g N_VDD_c_13678_n ) capacitor c=0.00755544f \
 //x=17.99 //y=6.2 //x2=18.565 //y2=7.585
cc_6512 ( N_RN_M84_noxref_g N_VDD_c_13678_n ) capacitor c=0.00755754f \
 //x=18.43 //y=6.2 //x2=18.565 //y2=7.585
cc_6513 ( N_RN_M87_noxref_g N_VDD_c_13618_n ) capacitor c=0.00705252f \
 //x=21.92 //y=6.2 //x2=22.495 //y2=7.585
cc_6514 ( N_RN_M88_noxref_g N_VDD_c_13618_n ) capacitor c=0.00755544f \
 //x=22.36 //y=6.2 //x2=22.495 //y2=7.585
cc_6515 ( N_RN_M99_noxref_g N_VDD_c_13847_n ) capacitor c=0.00705252f \
 //x=31.54 //y=6.2 //x2=32.115 //y2=7.585
cc_6516 ( N_RN_M100_noxref_g N_VDD_c_13847_n ) capacitor c=0.00755544f \
 //x=31.98 //y=6.2 //x2=32.115 //y2=7.585
cc_6517 ( N_RN_M119_noxref_g N_VDD_c_14078_n ) capacitor c=0.00755544f \
 //x=46.85 //y=6.2 //x2=47.425 //y2=7.585
cc_6518 ( N_RN_M120_noxref_g N_VDD_c_14078_n ) capacitor c=0.00755754f \
 //x=47.29 //y=6.2 //x2=47.425 //y2=7.585
cc_6519 ( N_RN_M123_noxref_g N_VDD_c_14018_n ) capacitor c=0.00705252f \
 //x=50.78 //y=6.2 //x2=51.355 //y2=7.585
cc_6520 ( N_RN_M124_noxref_g N_VDD_c_14018_n ) capacitor c=0.00755544f \
 //x=51.22 //y=6.2 //x2=51.355 //y2=7.585
cc_6521 ( N_RN_M135_noxref_g N_VDD_c_14187_n ) capacitor c=0.00705252f \
 //x=60.4 //y=6.2 //x2=60.975 //y2=7.585
cc_6522 ( N_RN_M136_noxref_g N_VDD_c_14187_n ) capacitor c=0.00755544f \
 //x=60.84 //y=6.2 //x2=60.975 //y2=7.585
cc_6523 ( N_RN_M155_noxref_g N_VDD_c_14400_n ) capacitor c=0.00755544f \
 //x=75.71 //y=6.2 //x2=76.285 //y2=7.585
cc_6524 ( N_RN_M156_noxref_g N_VDD_c_14400_n ) capacitor c=0.00755754f \
 //x=76.15 //y=6.2 //x2=76.285 //y2=7.585
cc_6525 ( N_RN_M159_noxref_g N_VDD_c_14402_n ) capacitor c=0.00705252f \
 //x=79.64 //y=6.2 //x2=80.215 //y2=7.585
cc_6526 ( N_RN_M160_noxref_g N_VDD_c_14402_n ) capacitor c=0.00755544f \
 //x=80.08 //y=6.2 //x2=80.215 //y2=7.585
cc_6527 ( N_RN_c_8072_n N_VDD_c_13581_n ) capacitor c=0.00224736f //x=18.25 \
 //y=4.88 //x2=19.73 //y2=7.585
cc_6528 ( N_RN_c_8103_n N_VDD_c_13581_n ) capacitor c=2.63786e-19 //x=18.25 \
 //y=4.88 //x2=19.73 //y2=7.585
cc_6529 ( N_RN_c_8400_n N_VDD_c_13778_n ) capacitor c=0.00205049f //x=47.11 \
 //y=4.88 //x2=48.59 //y2=7.585
cc_6530 ( N_RN_c_8705_n N_VDD_c_13786_n ) capacitor c=0.00224736f //x=75.97 \
 //y=4.88 //x2=77.45 //y2=7.585
cc_6531 ( N_RN_c_8180_n N_VDD_c_13786_n ) capacitor c=2.63786e-19 //x=75.97 \
 //y=4.88 //x2=77.45 //y2=7.585
cc_6532 ( N_RN_M63_noxref_g N_VDD_M62_noxref_d ) capacitor c=0.015318f \
 //x=2.68 //y=6.2 //x2=2.315 //y2=5.2
cc_6533 ( N_RN_M64_noxref_g N_VDD_M64_noxref_d ) capacitor c=0.015318f \
 //x=3.12 //y=6.2 //x2=3.195 //y2=5.2
cc_6534 ( N_RN_M83_noxref_g N_VDD_M82_noxref_d ) capacitor c=0.015318f \
 //x=17.99 //y=6.2 //x2=17.625 //y2=5.2
cc_6535 ( N_RN_M84_noxref_g N_VDD_M84_noxref_d ) capacitor c=0.0394719f \
 //x=18.43 //y=6.2 //x2=18.505 //y2=5.2
cc_6536 ( N_RN_M87_noxref_g N_VDD_M86_noxref_d ) capacitor c=0.015318f \
 //x=21.92 //y=6.2 //x2=21.555 //y2=5.2
cc_6537 ( N_RN_M88_noxref_g N_VDD_M88_noxref_d ) capacitor c=0.015318f \
 //x=22.36 //y=6.2 //x2=22.435 //y2=5.2
cc_6538 ( N_RN_M99_noxref_g N_VDD_M98_noxref_d ) capacitor c=0.015318f \
 //x=31.54 //y=6.2 //x2=31.175 //y2=5.2
cc_6539 ( N_RN_M100_noxref_g N_VDD_M100_noxref_d ) capacitor c=0.015318f \
 //x=31.98 //y=6.2 //x2=32.055 //y2=5.2
cc_6540 ( N_RN_M119_noxref_g N_VDD_M118_noxref_d ) capacitor c=0.015318f \
 //x=46.85 //y=6.2 //x2=46.485 //y2=5.2
cc_6541 ( N_RN_M120_noxref_g N_VDD_M120_noxref_d ) capacitor c=0.0394719f \
 //x=47.29 //y=6.2 //x2=47.365 //y2=5.2
cc_6542 ( N_RN_M123_noxref_g N_VDD_M122_noxref_d ) capacitor c=0.015318f \
 //x=50.78 //y=6.2 //x2=50.415 //y2=5.2
cc_6543 ( N_RN_M124_noxref_g N_VDD_M124_noxref_d ) capacitor c=0.015318f \
 //x=51.22 //y=6.2 //x2=51.295 //y2=5.2
cc_6544 ( N_RN_M135_noxref_g N_VDD_M134_noxref_d ) capacitor c=0.015318f \
 //x=60.4 //y=6.2 //x2=60.035 //y2=5.2
cc_6545 ( N_RN_M136_noxref_g N_VDD_M136_noxref_d ) capacitor c=0.015318f \
 //x=60.84 //y=6.2 //x2=60.915 //y2=5.2
cc_6546 ( N_RN_M155_noxref_g N_VDD_M154_noxref_d ) capacitor c=0.015318f \
 //x=75.71 //y=6.2 //x2=75.345 //y2=5.2
cc_6547 ( N_RN_M156_noxref_g N_VDD_M156_noxref_d ) capacitor c=0.0394719f \
 //x=76.15 //y=6.2 //x2=76.225 //y2=5.2
cc_6548 ( N_RN_M159_noxref_g N_VDD_M158_noxref_d ) capacitor c=0.015318f \
 //x=79.64 //y=6.2 //x2=79.275 //y2=5.2
cc_6549 ( N_RN_M160_noxref_g N_VDD_M160_noxref_d ) capacitor c=0.015318f \
 //x=80.08 //y=6.2 //x2=80.155 //y2=5.2
cc_6550 ( N_RN_c_7855_n N_noxref_26_c_14902_n ) capacitor c=0.00519491f \
 //x=13.795 //y=2.4 //x2=3.505 //y2=1.175
cc_6551 ( N_RN_c_7974_n N_noxref_26_c_14902_n ) capacitor c=0.00123426f \
 //x=2.8 //y=1.09 //x2=3.505 //y2=1.175
cc_6552 ( N_RN_c_7975_n N_noxref_26_c_14902_n ) capacitor c=0.0129287f //x=2.8 \
 //y=1.4 //x2=3.505 //y2=1.175
cc_6553 ( N_RN_c_7976_n N_noxref_26_c_14902_n ) capacitor c=0.00132209f \
 //x=2.8 //y=1.63 //x2=3.505 //y2=1.175
cc_6554 ( N_RN_c_7855_n N_noxref_26_c_14881_n ) capacitor c=5.06634e-19 \
 //x=13.795 //y=2.4 //x2=4.475 //y2=0.72
cc_6555 ( N_RN_c_7850_n N_noxref_26_M1_noxref_d ) capacitor c=0.00672102f \
 //x=2.71 //y=2.56 //x2=2.35 //y2=1.09
cc_6556 ( N_RN_c_7944_n N_noxref_26_M1_noxref_d ) capacitor c=9.79219e-19 \
 //x=2.87 //y=2.4 //x2=2.35 //y2=1.09
cc_6557 ( N_RN_c_7955_n N_noxref_26_M1_noxref_d ) capacitor c=2.2052e-19 \
 //x=2.71 //y=2.26 //x2=2.35 //y2=1.09
cc_6558 ( N_RN_c_8529_n N_noxref_26_M1_noxref_d ) capacitor c=0.00253592f \
 //x=2.275 //y=1.09 //x2=2.35 //y2=1.09
cc_6559 ( N_RN_c_8532_n N_noxref_26_M1_noxref_d ) capacitor c=0.00604634f \
 //x=2.275 //y=1.4 //x2=2.35 //y2=1.09
cc_6560 ( N_RN_c_9151_p N_noxref_26_M1_noxref_d ) capacitor c=0.002686f \
 //x=2.645 //y=0.935 //x2=2.35 //y2=1.09
cc_6561 ( N_RN_c_9152_p N_noxref_26_M1_noxref_d ) capacitor c=0.00251995f \
 //x=2.645 //y=1.555 //x2=2.35 //y2=1.09
cc_6562 ( N_RN_c_7974_n N_noxref_26_M1_noxref_d ) capacitor c=0.00314523f \
 //x=2.8 //y=1.09 //x2=2.35 //y2=1.09
cc_6563 ( N_RN_c_7975_n N_noxref_26_M1_noxref_d ) capacitor c=0.00168289f \
 //x=2.8 //y=1.4 //x2=2.35 //y2=1.09
cc_6564 ( N_RN_c_7976_n N_noxref_26_M1_noxref_d ) capacitor c=0.00111165f \
 //x=2.8 //y=1.63 //x2=2.35 //y2=1.09
cc_6565 ( N_RN_c_7855_n N_noxref_26_M2_noxref_s ) capacitor c=0.00445937f \
 //x=13.795 //y=2.4 //x2=3.455 //y2=0.555
cc_6566 ( N_RN_c_7974_n N_noxref_26_M2_noxref_s ) capacitor c=7.21316e-19 \
 //x=2.8 //y=1.09 //x2=3.455 //y2=0.555
cc_6567 ( N_RN_c_7975_n N_noxref_26_M2_noxref_s ) capacitor c=0.00365271f \
 //x=2.8 //y=1.4 //x2=3.455 //y2=0.555
cc_6568 ( N_RN_c_7977_n N_noxref_26_M2_noxref_s ) capacitor c=9.86711e-19 \
 //x=2.8 //y=2.095 //x2=3.455 //y2=0.555
cc_6569 ( N_RN_c_7855_n N_noxref_27_c_14969_n ) capacitor c=0.00601428f \
 //x=13.795 //y=2.4 //x2=8.315 //y2=1.175
cc_6570 ( N_RN_c_7855_n N_noxref_27_c_14948_n ) capacitor c=5.06634e-19 \
 //x=13.795 //y=2.4 //x2=9.285 //y2=0.72
cc_6571 ( N_RN_c_7855_n N_noxref_27_M4_noxref_d ) capacitor c=0.00782377f \
 //x=13.795 //y=2.4 //x2=7.16 //y2=1.09
cc_6572 ( N_RN_c_7855_n N_noxref_27_M5_noxref_s ) capacitor c=0.00448124f \
 //x=13.795 //y=2.4 //x2=8.265 //y2=0.555
cc_6573 ( N_RN_c_7855_n N_noxref_28_c_15037_n ) capacitor c=0.00601428f \
 //x=13.795 //y=2.4 //x2=13.125 //y2=1.175
cc_6574 ( N_RN_c_7855_n N_noxref_28_c_15014_n ) capacitor c=5.06634e-19 \
 //x=13.795 //y=2.4 //x2=14.095 //y2=0.72
cc_6575 ( N_RN_c_7855_n N_noxref_28_M7_noxref_d ) capacitor c=0.00740355f \
 //x=13.795 //y=2.4 //x2=11.97 //y2=1.09
cc_6576 ( N_RN_c_7855_n N_noxref_28_M8_noxref_s ) capacitor c=0.00471087f \
 //x=13.795 //y=2.4 //x2=13.075 //y2=0.555
cc_6577 ( N_RN_c_7903_n N_noxref_29_c_15094_n ) capacitor c=0.00601428f \
 //x=18.415 //y=2.4 //x2=17.935 //y2=1.175
cc_6578 ( N_RN_c_8045_n N_noxref_29_c_15083_n ) capacitor c=0.00205753f \
 //x=18.25 //y=2.565 //x2=18.905 //y2=0.72
cc_6579 ( N_RN_c_8071_n N_noxref_29_c_15083_n ) capacitor c=0.00117306f \
 //x=18.25 //y=2.26 //x2=18.905 //y2=0.72
cc_6580 ( N_RN_c_8082_n N_noxref_29_c_15083_n ) capacitor c=0.0206349f \
 //x=18.24 //y=1.095 //x2=18.905 //y2=0.72
cc_6581 ( N_RN_c_8094_n N_noxref_29_c_15083_n ) capacitor c=0.00825432f \
 //x=18.77 //y=1.095 //x2=18.905 //y2=0.72
cc_6582 ( N_RN_c_8100_n N_noxref_29_c_15083_n ) capacitor c=2.20712e-19 \
 //x=18.25 //y=2.26 //x2=18.905 //y2=0.72
cc_6583 ( N_RN_c_8084_n N_noxref_29_c_15086_n ) capacitor c=0.0071177f \
 //x=18.24 //y=1.44 //x2=18.02 //y2=1.175
cc_6584 ( N_RN_c_7903_n N_noxref_29_M10_noxref_d ) capacitor c=0.00780914f \
 //x=18.415 //y=2.4 //x2=16.78 //y2=1.09
cc_6585 ( N_RN_c_8045_n N_noxref_29_M11_noxref_s ) capacitor c=4.02723e-19 \
 //x=18.25 //y=2.565 //x2=17.885 //y2=0.555
cc_6586 ( N_RN_c_7903_n N_noxref_29_M11_noxref_s ) capacitor c=0.00418676f \
 //x=18.415 //y=2.4 //x2=17.885 //y2=0.555
cc_6587 ( N_RN_c_8082_n N_noxref_29_M11_noxref_s ) capacitor c=0.0071177f \
 //x=18.24 //y=1.095 //x2=17.885 //y2=0.555
cc_6588 ( N_RN_c_8087_n N_noxref_29_M11_noxref_s ) capacitor c=0.0071177f \
 //x=18.24 //y=1.75 //x2=17.885 //y2=0.555
cc_6589 ( N_RN_c_8094_n N_noxref_29_M11_noxref_s ) capacitor c=0.015333f \
 //x=18.77 //y=1.095 //x2=17.885 //y2=0.555
cc_6590 ( N_RN_c_8096_n N_noxref_29_M11_noxref_s ) capacitor c=0.00248746f \
 //x=18.77 //y=1.44 //x2=17.885 //y2=0.555
cc_6591 ( N_RN_c_7953_n N_noxref_30_c_15171_n ) capacitor c=0.00601428f \
 //x=23.57 //y=2.37 //x2=22.745 //y2=1.175
cc_6592 ( N_RN_c_7987_n N_noxref_30_c_15171_n ) capacitor c=0.00123426f \
 //x=22.04 //y=1.09 //x2=22.745 //y2=1.175
cc_6593 ( N_RN_c_7988_n N_noxref_30_c_15171_n ) capacitor c=0.0129287f \
 //x=22.04 //y=1.4 //x2=22.745 //y2=1.175
cc_6594 ( N_RN_c_7989_n N_noxref_30_c_15171_n ) capacitor c=0.00132209f \
 //x=22.04 //y=1.63 //x2=22.745 //y2=1.175
cc_6595 ( N_RN_c_7953_n N_noxref_30_c_15149_n ) capacitor c=5.06634e-19 \
 //x=23.57 //y=2.37 //x2=23.715 //y2=0.72
cc_6596 ( N_RN_c_7926_n N_noxref_30_M13_noxref_d ) capacitor c=0.00676893f \
 //x=21.95 //y=2.57 //x2=21.59 //y2=1.09
cc_6597 ( N_RN_c_7947_n N_noxref_30_M13_noxref_d ) capacitor c=0.00528699f \
 //x=21.785 //y=2.4 //x2=21.59 //y2=1.09
cc_6598 ( N_RN_c_7953_n N_noxref_30_M13_noxref_d ) capacitor c=0.00108533f \
 //x=23.57 //y=2.37 //x2=21.59 //y2=1.09
cc_6599 ( N_RN_c_7961_n N_noxref_30_M13_noxref_d ) capacitor c=2.2052e-19 \
 //x=21.95 //y=2.26 //x2=21.59 //y2=1.09
cc_6600 ( N_RN_c_7982_n N_noxref_30_M13_noxref_d ) capacitor c=0.00253592f \
 //x=21.515 //y=1.09 //x2=21.59 //y2=1.09
cc_6601 ( N_RN_c_7985_n N_noxref_30_M13_noxref_d ) capacitor c=0.00604087f \
 //x=21.515 //y=1.4 //x2=21.59 //y2=1.09
cc_6602 ( N_RN_c_9193_p N_noxref_30_M13_noxref_d ) capacitor c=0.002686f \
 //x=21.885 //y=0.935 //x2=21.59 //y2=1.09
cc_6603 ( N_RN_c_9194_p N_noxref_30_M13_noxref_d ) capacitor c=0.00251995f \
 //x=21.885 //y=1.555 //x2=21.59 //y2=1.09
cc_6604 ( N_RN_c_7987_n N_noxref_30_M13_noxref_d ) capacitor c=0.00314523f \
 //x=22.04 //y=1.09 //x2=21.59 //y2=1.09
cc_6605 ( N_RN_c_7988_n N_noxref_30_M13_noxref_d ) capacitor c=0.00168289f \
 //x=22.04 //y=1.4 //x2=21.59 //y2=1.09
cc_6606 ( N_RN_c_7989_n N_noxref_30_M13_noxref_d ) capacitor c=0.00111165f \
 //x=22.04 //y=1.63 //x2=21.59 //y2=1.09
cc_6607 ( N_RN_c_7953_n N_noxref_30_M14_noxref_s ) capacitor c=0.00448124f \
 //x=23.57 //y=2.37 //x2=22.695 //y2=0.555
cc_6608 ( N_RN_c_7987_n N_noxref_30_M14_noxref_s ) capacitor c=7.21316e-19 \
 //x=22.04 //y=1.09 //x2=22.695 //y2=0.555
cc_6609 ( N_RN_c_7988_n N_noxref_30_M14_noxref_s ) capacitor c=0.00365271f \
 //x=22.04 //y=1.4 //x2=22.695 //y2=0.555
cc_6610 ( N_RN_c_7990_n N_noxref_30_M14_noxref_s ) capacitor c=9.86711e-19 \
 //x=22.04 //y=2.095 //x2=22.695 //y2=0.555
cc_6611 ( N_RN_c_8024_n N_noxref_31_c_15240_n ) capacitor c=0.00601428f \
 //x=42.825 //y=2.385 //x2=27.555 //y2=1.175
cc_6612 ( N_RN_c_8024_n N_noxref_31_c_15218_n ) capacitor c=5.06634e-19 \
 //x=42.825 //y=2.385 //x2=28.525 //y2=0.72
cc_6613 ( N_RN_c_8024_n N_noxref_31_M16_noxref_d ) capacitor c=0.00673057f \
 //x=42.825 //y=2.385 //x2=26.4 //y2=1.09
cc_6614 ( N_RN_c_8024_n N_noxref_31_M17_noxref_s ) capacitor c=0.00471087f \
 //x=42.825 //y=2.385 //x2=27.505 //y2=0.555
cc_6615 ( N_RN_c_8024_n N_noxref_32_c_15308_n ) capacitor c=0.00601428f \
 //x=42.825 //y=2.385 //x2=32.365 //y2=1.175
cc_6616 ( N_RN_c_8302_n N_noxref_32_c_15308_n ) capacitor c=0.00123426f \
 //x=31.66 //y=1.09 //x2=32.365 //y2=1.175
cc_6617 ( N_RN_c_8303_n N_noxref_32_c_15308_n ) capacitor c=0.0129287f \
 //x=31.66 //y=1.4 //x2=32.365 //y2=1.175
cc_6618 ( N_RN_c_8304_n N_noxref_32_c_15308_n ) capacitor c=0.00132209f \
 //x=31.66 //y=1.63 //x2=32.365 //y2=1.175
cc_6619 ( N_RN_c_8024_n N_noxref_32_c_15287_n ) capacitor c=5.06634e-19 \
 //x=42.825 //y=2.385 //x2=33.335 //y2=0.72
cc_6620 ( N_RN_c_8182_n N_noxref_32_M19_noxref_d ) capacitor c=0.00672102f \
 //x=31.57 //y=2.56 //x2=31.21 //y2=1.09
cc_6621 ( N_RN_c_8024_n N_noxref_32_M19_noxref_d ) capacitor c=0.00647633f \
 //x=42.825 //y=2.385 //x2=31.21 //y2=1.09
cc_6622 ( N_RN_c_8283_n N_noxref_32_M19_noxref_d ) capacitor c=2.2052e-19 \
 //x=31.57 //y=2.26 //x2=31.21 //y2=1.09
cc_6623 ( N_RN_c_8540_n N_noxref_32_M19_noxref_d ) capacitor c=0.00253592f \
 //x=31.135 //y=1.09 //x2=31.21 //y2=1.09
cc_6624 ( N_RN_c_8543_n N_noxref_32_M19_noxref_d ) capacitor c=0.00604087f \
 //x=31.135 //y=1.4 //x2=31.21 //y2=1.09
cc_6625 ( N_RN_c_9216_p N_noxref_32_M19_noxref_d ) capacitor c=0.002686f \
 //x=31.505 //y=0.935 //x2=31.21 //y2=1.09
cc_6626 ( N_RN_c_9217_p N_noxref_32_M19_noxref_d ) capacitor c=0.00251995f \
 //x=31.505 //y=1.555 //x2=31.21 //y2=1.09
cc_6627 ( N_RN_c_8302_n N_noxref_32_M19_noxref_d ) capacitor c=0.00314523f \
 //x=31.66 //y=1.09 //x2=31.21 //y2=1.09
cc_6628 ( N_RN_c_8303_n N_noxref_32_M19_noxref_d ) capacitor c=0.00168289f \
 //x=31.66 //y=1.4 //x2=31.21 //y2=1.09
cc_6629 ( N_RN_c_8304_n N_noxref_32_M19_noxref_d ) capacitor c=0.00111165f \
 //x=31.66 //y=1.63 //x2=31.21 //y2=1.09
cc_6630 ( N_RN_c_8024_n N_noxref_32_M20_noxref_s ) capacitor c=0.00445937f \
 //x=42.825 //y=2.385 //x2=32.315 //y2=0.555
cc_6631 ( N_RN_c_8302_n N_noxref_32_M20_noxref_s ) capacitor c=7.21316e-19 \
 //x=31.66 //y=1.09 //x2=32.315 //y2=0.555
cc_6632 ( N_RN_c_8303_n N_noxref_32_M20_noxref_s ) capacitor c=0.00365271f \
 //x=31.66 //y=1.4 //x2=32.315 //y2=0.555
cc_6633 ( N_RN_c_8305_n N_noxref_32_M20_noxref_s ) capacitor c=9.86711e-19 \
 //x=31.66 //y=2.095 //x2=32.315 //y2=0.555
cc_6634 ( N_RN_c_8024_n N_noxref_33_c_15375_n ) capacitor c=0.00601428f \
 //x=42.825 //y=2.385 //x2=37.175 //y2=1.175
cc_6635 ( N_RN_c_8024_n N_noxref_33_c_15354_n ) capacitor c=5.06634e-19 \
 //x=42.825 //y=2.385 //x2=38.145 //y2=0.72
cc_6636 ( N_RN_c_8024_n N_noxref_33_M22_noxref_d ) capacitor c=0.00782377f \
 //x=42.825 //y=2.385 //x2=36.02 //y2=1.09
cc_6637 ( N_RN_c_8024_n N_noxref_33_M23_noxref_s ) capacitor c=0.00448124f \
 //x=42.825 //y=2.385 //x2=37.125 //y2=0.555
cc_6638 ( N_RN_c_8024_n N_noxref_34_c_15443_n ) capacitor c=0.00601428f \
 //x=42.825 //y=2.385 //x2=41.985 //y2=1.175
cc_6639 ( N_RN_c_8024_n N_noxref_34_c_15420_n ) capacitor c=5.06634e-19 \
 //x=42.825 //y=2.385 //x2=42.955 //y2=0.72
cc_6640 ( N_RN_c_8024_n N_noxref_34_M25_noxref_d ) capacitor c=0.00740355f \
 //x=42.825 //y=2.385 //x2=40.83 //y2=1.09
cc_6641 ( N_RN_c_8024_n N_noxref_34_M26_noxref_s ) capacitor c=0.00471087f \
 //x=42.825 //y=2.385 //x2=41.935 //y2=0.555
cc_6642 ( N_RN_c_8235_n N_noxref_35_c_15500_n ) capacitor c=0.00601428f \
 //x=47.275 //y=2.4 //x2=46.795 //y2=1.175
cc_6643 ( N_RN_c_8374_n N_noxref_35_c_15489_n ) capacitor c=0.00205753f \
 //x=47.11 //y=2.565 //x2=47.765 //y2=0.72
cc_6644 ( N_RN_c_8399_n N_noxref_35_c_15489_n ) capacitor c=0.00117306f \
 //x=47.11 //y=2.26 //x2=47.765 //y2=0.72
cc_6645 ( N_RN_c_8410_n N_noxref_35_c_15489_n ) capacitor c=0.0206349f \
 //x=47.1 //y=1.095 //x2=47.765 //y2=0.72
cc_6646 ( N_RN_c_8422_n N_noxref_35_c_15489_n ) capacitor c=0.00825432f \
 //x=47.63 //y=1.095 //x2=47.765 //y2=0.72
cc_6647 ( N_RN_c_8428_n N_noxref_35_c_15489_n ) capacitor c=2.20712e-19 \
 //x=47.11 //y=2.26 //x2=47.765 //y2=0.72
cc_6648 ( N_RN_c_8412_n N_noxref_35_c_15492_n ) capacitor c=0.0071177f \
 //x=47.1 //y=1.44 //x2=46.88 //y2=1.175
cc_6649 ( N_RN_c_8235_n N_noxref_35_M28_noxref_d ) capacitor c=0.00780914f \
 //x=47.275 //y=2.4 //x2=45.64 //y2=1.09
cc_6650 ( N_RN_c_8374_n N_noxref_35_M29_noxref_s ) capacitor c=4.02723e-19 \
 //x=47.11 //y=2.565 //x2=46.745 //y2=0.555
cc_6651 ( N_RN_c_8235_n N_noxref_35_M29_noxref_s ) capacitor c=0.00418676f \
 //x=47.275 //y=2.4 //x2=46.745 //y2=0.555
cc_6652 ( N_RN_c_8410_n N_noxref_35_M29_noxref_s ) capacitor c=0.0071177f \
 //x=47.1 //y=1.095 //x2=46.745 //y2=0.555
cc_6653 ( N_RN_c_8415_n N_noxref_35_M29_noxref_s ) capacitor c=0.0071177f \
 //x=47.1 //y=1.75 //x2=46.745 //y2=0.555
cc_6654 ( N_RN_c_8422_n N_noxref_35_M29_noxref_s ) capacitor c=0.015333f \
 //x=47.63 //y=1.095 //x2=46.745 //y2=0.555
cc_6655 ( N_RN_c_8424_n N_noxref_35_M29_noxref_s ) capacitor c=0.00248746f \
 //x=47.63 //y=1.44 //x2=46.745 //y2=0.555
cc_6656 ( N_RN_c_8281_n N_noxref_36_c_15567_n ) capacitor c=0.00601428f \
 //x=52.49 //y=2.37 //x2=51.605 //y2=1.175
cc_6657 ( N_RN_c_8315_n N_noxref_36_c_15567_n ) capacitor c=0.00123426f \
 //x=50.9 //y=1.09 //x2=51.605 //y2=1.175
cc_6658 ( N_RN_c_8316_n N_noxref_36_c_15567_n ) capacitor c=0.0129287f \
 //x=50.9 //y=1.4 //x2=51.605 //y2=1.175
cc_6659 ( N_RN_c_8317_n N_noxref_36_c_15567_n ) capacitor c=0.00132209f \
 //x=50.9 //y=1.63 //x2=51.605 //y2=1.175
cc_6660 ( N_RN_c_8281_n N_noxref_36_c_15555_n ) capacitor c=5.06634e-19 \
 //x=52.49 //y=2.37 //x2=52.575 //y2=0.72
cc_6661 ( N_RN_c_8258_n N_noxref_36_M31_noxref_d ) capacitor c=0.00676893f \
 //x=50.81 //y=2.57 //x2=50.45 //y2=1.09
cc_6662 ( N_RN_c_8275_n N_noxref_36_M31_noxref_d ) capacitor c=0.00528699f \
 //x=50.645 //y=2.4 //x2=50.45 //y2=1.09
cc_6663 ( N_RN_c_8281_n N_noxref_36_M31_noxref_d ) capacitor c=0.00108533f \
 //x=52.49 //y=2.37 //x2=50.45 //y2=1.09
cc_6664 ( N_RN_c_8289_n N_noxref_36_M31_noxref_d ) capacitor c=2.2052e-19 \
 //x=50.81 //y=2.26 //x2=50.45 //y2=1.09
cc_6665 ( N_RN_c_8310_n N_noxref_36_M31_noxref_d ) capacitor c=0.00253592f \
 //x=50.375 //y=1.09 //x2=50.45 //y2=1.09
cc_6666 ( N_RN_c_8313_n N_noxref_36_M31_noxref_d ) capacitor c=0.00604087f \
 //x=50.375 //y=1.4 //x2=50.45 //y2=1.09
cc_6667 ( N_RN_c_9258_p N_noxref_36_M31_noxref_d ) capacitor c=0.002686f \
 //x=50.745 //y=0.935 //x2=50.45 //y2=1.09
cc_6668 ( N_RN_c_9259_p N_noxref_36_M31_noxref_d ) capacitor c=0.00251995f \
 //x=50.745 //y=1.555 //x2=50.45 //y2=1.09
cc_6669 ( N_RN_c_8315_n N_noxref_36_M31_noxref_d ) capacitor c=0.00314523f \
 //x=50.9 //y=1.09 //x2=50.45 //y2=1.09
cc_6670 ( N_RN_c_8316_n N_noxref_36_M31_noxref_d ) capacitor c=0.00168289f \
 //x=50.9 //y=1.4 //x2=50.45 //y2=1.09
cc_6671 ( N_RN_c_8317_n N_noxref_36_M31_noxref_d ) capacitor c=0.00111165f \
 //x=50.9 //y=1.63 //x2=50.45 //y2=1.09
cc_6672 ( N_RN_c_8281_n N_noxref_36_M32_noxref_s ) capacitor c=0.00448124f \
 //x=52.49 //y=2.37 //x2=51.555 //y2=0.555
cc_6673 ( N_RN_c_8315_n N_noxref_36_M32_noxref_s ) capacitor c=7.21316e-19 \
 //x=50.9 //y=1.09 //x2=51.555 //y2=0.555
cc_6674 ( N_RN_c_8316_n N_noxref_36_M32_noxref_s ) capacitor c=0.00365271f \
 //x=50.9 //y=1.4 //x2=51.555 //y2=0.555
cc_6675 ( N_RN_c_8318_n N_noxref_36_M32_noxref_s ) capacitor c=9.86711e-19 \
 //x=50.9 //y=2.095 //x2=51.555 //y2=0.555
cc_6676 ( N_RN_c_8353_n N_noxref_37_c_15635_n ) capacitor c=0.00601428f \
 //x=71.685 //y=2.385 //x2=56.415 //y2=1.175
cc_6677 ( N_RN_c_8353_n N_noxref_37_c_15624_n ) capacitor c=5.06634e-19 \
 //x=71.685 //y=2.385 //x2=57.385 //y2=0.72
cc_6678 ( N_RN_c_8353_n N_noxref_37_M34_noxref_d ) capacitor c=0.00673057f \
 //x=71.685 //y=2.385 //x2=55.26 //y2=1.09
cc_6679 ( N_RN_c_8353_n N_noxref_37_M35_noxref_s ) capacitor c=0.00471087f \
 //x=71.685 //y=2.385 //x2=56.365 //y2=0.555
cc_6680 ( N_RN_c_8353_n N_noxref_38_c_15713_n ) capacitor c=0.00601428f \
 //x=71.685 //y=2.385 //x2=61.225 //y2=1.175
cc_6681 ( N_RN_c_8556_n N_noxref_38_c_15713_n ) capacitor c=0.00123426f \
 //x=60.52 //y=1.09 //x2=61.225 //y2=1.175
cc_6682 ( N_RN_c_8557_n N_noxref_38_c_15713_n ) capacitor c=0.0129287f \
 //x=60.52 //y=1.4 //x2=61.225 //y2=1.175
cc_6683 ( N_RN_c_8558_n N_noxref_38_c_15713_n ) capacitor c=0.00132209f \
 //x=60.52 //y=1.63 //x2=61.225 //y2=1.175
cc_6684 ( N_RN_c_8353_n N_noxref_38_c_15692_n ) capacitor c=5.06634e-19 \
 //x=71.685 //y=2.385 //x2=62.195 //y2=0.72
cc_6685 ( N_RN_c_8476_n N_noxref_38_M37_noxref_d ) capacitor c=0.00672102f \
 //x=60.43 //y=2.56 //x2=60.07 //y2=1.09
cc_6686 ( N_RN_c_8353_n N_noxref_38_M37_noxref_d ) capacitor c=0.00647633f \
 //x=71.685 //y=2.385 //x2=60.07 //y2=1.09
cc_6687 ( N_RN_c_8513_n N_noxref_38_M37_noxref_d ) capacitor c=2.2052e-19 \
 //x=60.43 //y=2.26 //x2=60.07 //y2=1.09
cc_6688 ( N_RN_c_8551_n N_noxref_38_M37_noxref_d ) capacitor c=0.00253592f \
 //x=59.995 //y=1.09 //x2=60.07 //y2=1.09
cc_6689 ( N_RN_c_8554_n N_noxref_38_M37_noxref_d ) capacitor c=0.00604087f \
 //x=59.995 //y=1.4 //x2=60.07 //y2=1.09
cc_6690 ( N_RN_c_9281_p N_noxref_38_M37_noxref_d ) capacitor c=0.002686f \
 //x=60.365 //y=0.935 //x2=60.07 //y2=1.09
cc_6691 ( N_RN_c_9282_p N_noxref_38_M37_noxref_d ) capacitor c=0.00251995f \
 //x=60.365 //y=1.555 //x2=60.07 //y2=1.09
cc_6692 ( N_RN_c_8556_n N_noxref_38_M37_noxref_d ) capacitor c=0.00314523f \
 //x=60.52 //y=1.09 //x2=60.07 //y2=1.09
cc_6693 ( N_RN_c_8557_n N_noxref_38_M37_noxref_d ) capacitor c=0.00168289f \
 //x=60.52 //y=1.4 //x2=60.07 //y2=1.09
cc_6694 ( N_RN_c_8558_n N_noxref_38_M37_noxref_d ) capacitor c=0.00111165f \
 //x=60.52 //y=1.63 //x2=60.07 //y2=1.09
cc_6695 ( N_RN_c_8353_n N_noxref_38_M38_noxref_s ) capacitor c=0.00445937f \
 //x=71.685 //y=2.385 //x2=61.175 //y2=0.555
cc_6696 ( N_RN_c_8556_n N_noxref_38_M38_noxref_s ) capacitor c=7.21316e-19 \
 //x=60.52 //y=1.09 //x2=61.175 //y2=0.555
cc_6697 ( N_RN_c_8557_n N_noxref_38_M38_noxref_s ) capacitor c=0.00365271f \
 //x=60.52 //y=1.4 //x2=61.175 //y2=0.555
cc_6698 ( N_RN_c_8559_n N_noxref_38_M38_noxref_s ) capacitor c=9.86711e-19 \
 //x=60.52 //y=2.095 //x2=61.175 //y2=0.555
cc_6699 ( N_RN_c_8353_n N_noxref_39_c_15760_n ) capacitor c=0.00601429f \
 //x=71.685 //y=2.385 //x2=66.035 //y2=1.175
cc_6700 ( N_RN_c_8353_n N_noxref_39_c_15775_n ) capacitor c=5.06634e-19 \
 //x=71.685 //y=2.385 //x2=67.005 //y2=0.72
cc_6701 ( N_RN_c_8353_n N_noxref_39_M40_noxref_d ) capacitor c=0.00782377f \
 //x=71.685 //y=2.385 //x2=64.88 //y2=1.09
cc_6702 ( N_RN_c_8353_n N_noxref_39_M41_noxref_s ) capacitor c=0.00448124f \
 //x=71.685 //y=2.385 //x2=65.985 //y2=0.555
cc_6703 ( N_RN_c_8353_n N_noxref_40_c_15838_n ) capacitor c=0.00601428f \
 //x=71.685 //y=2.385 //x2=70.845 //y2=1.175
cc_6704 ( N_RN_c_8353_n N_noxref_40_c_15826_n ) capacitor c=5.06634e-19 \
 //x=71.685 //y=2.385 //x2=71.815 //y2=0.72
cc_6705 ( N_RN_c_8353_n N_noxref_40_M43_noxref_d ) capacitor c=0.00740355f \
 //x=71.685 //y=2.385 //x2=69.69 //y2=1.09
cc_6706 ( N_RN_c_8353_n N_noxref_40_M44_noxref_s ) capacitor c=0.00471087f \
 //x=71.685 //y=2.385 //x2=70.795 //y2=0.555
cc_6707 ( N_RN_c_8628_n N_noxref_41_c_15895_n ) capacitor c=0.00601428f \
 //x=76.135 //y=2.4 //x2=75.655 //y2=1.175
cc_6708 ( N_RN_c_8660_n N_noxref_41_c_15911_n ) capacitor c=0.00205753f \
 //x=75.97 //y=2.565 //x2=76.625 //y2=0.72
cc_6709 ( N_RN_c_8702_n N_noxref_41_c_15911_n ) capacitor c=0.00117306f \
 //x=75.97 //y=2.26 //x2=76.625 //y2=0.72
cc_6710 ( N_RN_c_8723_n N_noxref_41_c_15911_n ) capacitor c=0.0206349f \
 //x=75.96 //y=1.095 //x2=76.625 //y2=0.72
cc_6711 ( N_RN_c_8966_p N_noxref_41_c_15911_n ) capacitor c=0.00825432f \
 //x=76.49 //y=1.095 //x2=76.625 //y2=0.72
cc_6712 ( N_RN_c_8742_n N_noxref_41_c_15911_n ) capacitor c=2.20712e-19 \
 //x=75.97 //y=2.26 //x2=76.625 //y2=0.72
cc_6713 ( N_RN_c_8724_n N_noxref_41_c_15916_n ) capacitor c=0.0071177f \
 //x=75.96 //y=1.44 //x2=75.74 //y2=1.175
cc_6714 ( N_RN_c_8628_n N_noxref_41_M46_noxref_d ) capacitor c=0.00780914f \
 //x=76.135 //y=2.4 //x2=74.5 //y2=1.09
cc_6715 ( N_RN_c_8660_n N_noxref_41_M47_noxref_s ) capacitor c=4.02723e-19 \
 //x=75.97 //y=2.565 //x2=75.605 //y2=0.555
cc_6716 ( N_RN_c_8628_n N_noxref_41_M47_noxref_s ) capacitor c=0.00418676f \
 //x=76.135 //y=2.4 //x2=75.605 //y2=0.555
cc_6717 ( N_RN_c_8723_n N_noxref_41_M47_noxref_s ) capacitor c=0.0071177f \
 //x=75.96 //y=1.095 //x2=75.605 //y2=0.555
cc_6718 ( N_RN_c_8725_n N_noxref_41_M47_noxref_s ) capacitor c=0.0071177f \
 //x=75.96 //y=1.75 //x2=75.605 //y2=0.555
cc_6719 ( N_RN_c_8966_p N_noxref_41_M47_noxref_s ) capacitor c=0.015333f \
 //x=76.49 //y=1.095 //x2=75.605 //y2=0.555
cc_6720 ( N_RN_c_8967_p N_noxref_41_M47_noxref_s ) capacitor c=0.00248746f \
 //x=76.49 //y=1.44 //x2=75.605 //y2=0.555
cc_6721 ( N_RN_c_8829_n N_noxref_42_c_15961_n ) capacitor c=0.00123426f \
 //x=79.76 //y=1.09 //x2=80.465 //y2=1.175
cc_6722 ( N_RN_c_8830_n N_noxref_42_c_15961_n ) capacitor c=0.0129287f \
 //x=79.76 //y=1.4 //x2=80.465 //y2=1.175
cc_6723 ( N_RN_c_8831_n N_noxref_42_c_15961_n ) capacitor c=0.00132209f \
 //x=79.76 //y=1.63 //x2=80.465 //y2=1.175
cc_6724 ( N_RN_c_8772_n N_noxref_42_M49_noxref_d ) capacitor c=0.00676893f \
 //x=79.67 //y=2.57 //x2=79.31 //y2=1.09
cc_6725 ( N_RN_c_8790_n N_noxref_42_M49_noxref_d ) capacitor c=0.00108533f \
 //x=79.665 //y=2.41 //x2=79.31 //y2=1.09
cc_6726 ( N_RN_c_8792_n N_noxref_42_M49_noxref_d ) capacitor c=0.00528699f \
 //x=79.505 //y=2.41 //x2=79.31 //y2=1.09
cc_6727 ( N_RN_c_8803_n N_noxref_42_M49_noxref_d ) capacitor c=2.2052e-19 \
 //x=79.67 //y=2.26 //x2=79.31 //y2=1.09
cc_6728 ( N_RN_c_8824_n N_noxref_42_M49_noxref_d ) capacitor c=0.00253592f \
 //x=79.235 //y=1.09 //x2=79.31 //y2=1.09
cc_6729 ( N_RN_c_8827_n N_noxref_42_M49_noxref_d ) capacitor c=0.00604087f \
 //x=79.235 //y=1.4 //x2=79.31 //y2=1.09
cc_6730 ( N_RN_c_9321_p N_noxref_42_M49_noxref_d ) capacitor c=0.002686f \
 //x=79.605 //y=0.935 //x2=79.31 //y2=1.09
cc_6731 ( N_RN_c_9322_p N_noxref_42_M49_noxref_d ) capacitor c=0.00251995f \
 //x=79.605 //y=1.555 //x2=79.31 //y2=1.09
cc_6732 ( N_RN_c_8829_n N_noxref_42_M49_noxref_d ) capacitor c=0.00314523f \
 //x=79.76 //y=1.09 //x2=79.31 //y2=1.09
cc_6733 ( N_RN_c_8830_n N_noxref_42_M49_noxref_d ) capacitor c=0.00168289f \
 //x=79.76 //y=1.4 //x2=79.31 //y2=1.09
cc_6734 ( N_RN_c_8831_n N_noxref_42_M49_noxref_d ) capacitor c=0.00111165f \
 //x=79.76 //y=1.63 //x2=79.31 //y2=1.09
cc_6735 ( N_RN_c_8829_n N_noxref_42_M50_noxref_s ) capacitor c=7.21316e-19 \
 //x=79.76 //y=1.09 //x2=80.415 //y2=0.555
cc_6736 ( N_RN_c_8830_n N_noxref_42_M50_noxref_s ) capacitor c=0.00365271f \
 //x=79.76 //y=1.4 //x2=80.415 //y2=0.555
cc_6737 ( N_RN_c_8832_n N_noxref_42_M50_noxref_s ) capacitor c=9.86711e-19 \
 //x=79.76 //y=2.095 //x2=80.415 //y2=0.555
cc_6738 ( N_RN_c_7850_n N_GND_c_16390_n ) capacitor c=8.88317e-19 //x=2.71 \
 //y=2.56 //x2=6.29 //y2=0.175
cc_6739 ( N_RN_c_7855_n N_GND_c_16390_n ) capacitor c=0.100716f //x=13.795 \
 //y=2.4 //x2=6.29 //y2=0.175
cc_6740 ( N_RN_c_7944_n N_GND_c_16390_n ) capacitor c=0.0033291f //x=2.87 \
 //y=2.4 //x2=6.29 //y2=0.175
cc_6741 ( N_RN_c_7855_n N_GND_c_16501_n ) capacitor c=0.125624f //x=13.795 \
 //y=2.4 //x2=11.1 //y2=0.175
cc_6742 ( N_RN_c_7855_n N_GND_c_16460_n ) capacitor c=0.0592381f //x=13.795 \
 //y=2.4 //x2=15.91 //y2=0.175
cc_6743 ( N_RN_c_7890_n N_GND_c_16460_n ) capacitor c=0.0619243f //x=14.395 \
 //y=2.385 //x2=15.91 //y2=0.175
cc_6744 ( N_RN_c_8045_n N_GND_c_16584_n ) capacitor c=0.00212671f //x=18.25 \
 //y=2.565 //x2=20.72 //y2=0.175
cc_6745 ( N_RN_c_7947_n N_GND_c_16584_n ) capacitor c=0.0626645f //x=21.785 \
 //y=2.4 //x2=20.72 //y2=0.175
cc_6746 ( N_RN_c_7903_n N_GND_c_16584_n ) capacitor c=0.0584941f //x=18.415 \
 //y=2.4 //x2=20.72 //y2=0.175
cc_6747 ( N_RN_c_7926_n N_GND_c_16542_n ) capacitor c=8.9124e-19 //x=21.95 \
 //y=2.57 //x2=25.53 //y2=0.175
cc_6748 ( N_RN_c_7947_n N_GND_c_16542_n ) capacitor c=0.0204822f //x=21.785 \
 //y=2.4 //x2=25.53 //y2=0.175
cc_6749 ( N_RN_c_8006_n N_GND_c_16542_n ) capacitor c=0.061971f //x=24 \
 //y=2.37 //x2=25.53 //y2=0.175
cc_6750 ( N_RN_c_7953_n N_GND_c_16542_n ) capacitor c=0.0399672f //x=23.57 \
 //y=2.37 //x2=25.53 //y2=0.175
cc_6751 ( N_RN_c_8024_n N_GND_c_16588_n ) capacitor c=0.125852f //x=42.825 \
 //y=2.385 //x2=30.34 //y2=0.175
cc_6752 ( N_RN_c_8182_n N_GND_c_16658_n ) capacitor c=8.88317e-19 //x=31.57 \
 //y=2.56 //x2=35.15 //y2=0.175
cc_6753 ( N_RN_c_8024_n N_GND_c_16658_n ) capacitor c=0.124286f //x=42.825 \
 //y=2.385 //x2=35.15 //y2=0.175
cc_6754 ( N_RN_c_8024_n N_GND_c_16769_n ) capacitor c=0.125624f //x=42.825 \
 //y=2.385 //x2=39.96 //y2=0.175
cc_6755 ( N_RN_c_8218_n N_GND_c_16728_n ) capacitor c=0.0619243f //x=43.255 \
 //y=2.385 //x2=44.77 //y2=0.175
cc_6756 ( N_RN_c_8024_n N_GND_c_16728_n ) capacitor c=0.0592381f //x=42.825 \
 //y=2.385 //x2=44.77 //y2=0.175
cc_6757 ( N_RN_c_8374_n N_GND_c_16850_n ) capacitor c=0.00212671f //x=47.11 \
 //y=2.565 //x2=49.58 //y2=0.175
cc_6758 ( N_RN_c_8275_n N_GND_c_16850_n ) capacitor c=0.0626645f //x=50.645 \
 //y=2.4 //x2=49.58 //y2=0.175
cc_6759 ( N_RN_c_8235_n N_GND_c_16850_n ) capacitor c=0.0584941f //x=47.275 \
 //y=2.4 //x2=49.58 //y2=0.175
cc_6760 ( N_RN_c_8258_n N_GND_c_16808_n ) capacitor c=8.9124e-19 //x=50.81 \
 //y=2.57 //x2=54.39 //y2=0.175
cc_6761 ( N_RN_c_8275_n N_GND_c_16808_n ) capacitor c=0.0204822f //x=50.645 \
 //y=2.4 //x2=54.39 //y2=0.175
cc_6762 ( N_RN_c_8335_n N_GND_c_16808_n ) capacitor c=0.0603558f //x=52.92 \
 //y=2.37 //x2=54.39 //y2=0.175
cc_6763 ( N_RN_c_8281_n N_GND_c_16808_n ) capacitor c=0.0405306f //x=52.49 \
 //y=2.37 //x2=54.39 //y2=0.175
cc_6764 ( N_RN_c_8343_n N_GND_c_16808_n ) capacitor c=0.00162f //x=54.08 \
 //y=2.4 //x2=54.39 //y2=0.175
cc_6765 ( N_RN_c_8353_n N_GND_c_16854_n ) capacitor c=0.125998f //x=71.685 \
 //y=2.385 //x2=59.2 //y2=0.175
cc_6766 ( N_RN_c_8476_n N_GND_c_16949_n ) capacitor c=8.88317e-19 //x=60.43 \
 //y=2.56 //x2=64.01 //y2=0.175
cc_6767 ( N_RN_c_8353_n N_GND_c_16949_n ) capacitor c=0.124557f //x=71.685 \
 //y=2.385 //x2=64.01 //y2=0.175
cc_6768 ( N_RN_c_8353_n N_GND_c_17063_n ) capacitor c=0.125624f //x=71.685 \
 //y=2.385 //x2=68.82 //y2=0.175
cc_6769 ( N_RN_c_8611_n N_GND_c_17019_n ) capacitor c=0.0619243f //x=72.115 \
 //y=2.385 //x2=73.63 //y2=0.175
cc_6770 ( N_RN_c_8353_n N_GND_c_17019_n ) capacitor c=0.0592381f //x=71.685 \
 //y=2.385 //x2=73.63 //y2=0.175
cc_6771 ( N_RN_c_8660_n N_GND_c_17064_n ) capacitor c=0.00212671f //x=75.97 \
 //y=2.565 //x2=78.44 //y2=0.175
cc_6772 ( N_RN_c_8628_n N_GND_c_17064_n ) capacitor c=0.0584941f //x=76.135 \
 //y=2.4 //x2=78.44 //y2=0.175
cc_6773 ( N_RN_c_8792_n N_GND_c_17064_n ) capacitor c=0.0626645f //x=79.505 \
 //y=2.41 //x2=78.44 //y2=0.175
cc_6774 ( N_RN_c_8772_n N_GND_c_17141_n ) capacitor c=8.9124e-19 //x=79.67 \
 //y=2.57 //x2=83.25 //y2=0.175
cc_6775 ( N_RN_c_8790_n N_GND_c_17141_n ) capacitor c=0.00322605f //x=79.665 \
 //y=2.41 //x2=83.25 //y2=0.175
cc_6776 ( N_RN_c_8792_n N_GND_c_17141_n ) capacitor c=0.0204822f //x=79.505 \
 //y=2.41 //x2=83.25 //y2=0.175
cc_6777 ( N_RN_c_7855_n N_GND_c_16400_n ) capacitor c=0.00544496f //x=13.795 \
 //y=2.4 //x2=6.375 //y2=1.145
cc_6778 ( N_RN_c_7855_n N_GND_c_16411_n ) capacitor c=0.00539184f //x=13.795 \
 //y=2.4 //x2=11.185 //y2=1.145
cc_6779 ( N_RN_c_7897_n N_GND_c_16467_n ) capacitor c=0.00544619f //x=16.255 \
 //y=2.385 //x2=15.995 //y2=1.145
cc_6780 ( N_RN_c_7947_n N_GND_c_16509_n ) capacitor c=0.00551464f //x=21.785 \
 //y=2.4 //x2=20.805 //y2=1.145
cc_6781 ( N_RN_c_8018_n N_GND_c_16549_n ) capacitor c=0.00549637f //x=25.865 \
 //y=2.37 //x2=25.615 //y2=1.145
cc_6782 ( N_RN_c_8024_n N_GND_c_16624_n ) capacitor c=0.00563231f //x=42.825 \
 //y=2.385 //x2=30.425 //y2=1.145
cc_6783 ( N_RN_c_8024_n N_GND_c_16668_n ) capacitor c=0.00544496f //x=42.825 \
 //y=2.385 //x2=35.235 //y2=1.145
cc_6784 ( N_RN_c_8024_n N_GND_c_16679_n ) capacitor c=0.00539184f //x=42.825 \
 //y=2.385 //x2=40.045 //y2=1.145
cc_6785 ( N_RN_c_8229_n N_GND_c_16735_n ) capacitor c=0.00544619f //x=45.115 \
 //y=2.385 //x2=44.855 //y2=1.145
cc_6786 ( N_RN_c_8275_n N_GND_c_16777_n ) capacitor c=0.00551464f //x=50.645 \
 //y=2.4 //x2=49.665 //y2=1.145
cc_6787 ( N_RN_c_8347_n N_GND_c_16815_n ) capacitor c=0.00549479f //x=54.68 \
 //y=2.37 //x2=54.475 //y2=1.145
cc_6788 ( N_RN_c_8353_n N_GND_c_16900_n ) capacitor c=0.00561046f //x=71.685 \
 //y=2.385 //x2=59.285 //y2=1.145
cc_6789 ( N_RN_c_8353_n N_GND_c_16959_n ) capacitor c=0.00544496f //x=71.685 \
 //y=2.385 //x2=64.095 //y2=1.145
cc_6790 ( N_RN_c_8353_n N_GND_c_16970_n ) capacitor c=0.00539184f //x=71.685 \
 //y=2.385 //x2=68.905 //y2=1.145
cc_6791 ( N_RN_c_8622_n N_GND_c_17026_n ) capacitor c=0.00544619f //x=73.975 \
 //y=2.385 //x2=73.715 //y2=1.145
cc_6792 ( N_RN_c_8792_n N_GND_c_17074_n ) capacitor c=0.00551464f //x=79.505 \
 //y=2.41 //x2=78.525 //y2=1.145
cc_6793 ( N_RN_c_8045_n N_GND_c_16480_n ) capacitor c=2.47833e-19 //x=18.25 \
 //y=2.565 //x2=19.56 //y2=0.175
cc_6794 ( N_RN_c_8374_n N_GND_c_16748_n ) capacitor c=2.47833e-19 //x=47.11 \
 //y=2.565 //x2=48.42 //y2=0.175
cc_6795 ( N_RN_c_8660_n N_GND_c_17039_n ) capacitor c=2.47833e-19 //x=75.97 \
 //y=2.565 //x2=77.28 //y2=0.175
cc_6796 ( N_RN_c_7855_n N_GND_c_16425_n ) capacitor c=0.0209091f //x=13.795 \
 //y=2.4 //x2=5.3 //y2=0.175
cc_6797 ( N_RN_c_7855_n N_GND_c_16438_n ) capacitor c=0.0213456f //x=13.795 \
 //y=2.4 //x2=10.11 //y2=0.175
cc_6798 ( N_RN_c_7890_n N_GND_c_16481_n ) capacitor c=2.80619e-19 //x=14.395 \
 //y=2.385 //x2=14.92 //y2=0.175
cc_6799 ( N_RN_c_7894_n N_GND_c_16481_n ) capacitor c=0.0210751f //x=15.655 \
 //y=2.4 //x2=14.92 //y2=0.175
cc_6800 ( N_RN_c_7947_n N_GND_c_16530_n ) capacitor c=0.0205713f //x=21.785 \
 //y=2.4 //x2=19.73 //y2=0.175
cc_6801 ( N_RN_c_8071_n N_GND_c_16530_n ) capacitor c=0.00215938f //x=18.25 \
 //y=2.26 //x2=19.73 //y2=0.175
cc_6802 ( N_RN_c_8096_n N_GND_c_16530_n ) capacitor c=0.00262688f //x=18.77 \
 //y=1.44 //x2=19.73 //y2=0.175
cc_6803 ( N_RN_c_8100_n N_GND_c_16530_n ) capacitor c=2.63786e-19 //x=18.25 \
 //y=2.26 //x2=19.73 //y2=0.175
cc_6804 ( N_RN_c_8006_n N_GND_c_16563_n ) capacitor c=5.53196e-19 //x=24 \
 //y=2.37 //x2=24.54 //y2=0.175
cc_6805 ( N_RN_c_8014_n N_GND_c_16563_n ) capacitor c=0.0211747f //x=25.265 \
 //y=2.4 //x2=24.54 //y2=0.175
cc_6806 ( N_RN_c_8024_n N_GND_c_16600_n ) capacitor c=0.0205525f //x=42.825 \
 //y=2.385 //x2=29.35 //y2=0.175
cc_6807 ( N_RN_c_8024_n N_GND_c_16693_n ) capacitor c=0.0209843f //x=42.825 \
 //y=2.385 //x2=34.16 //y2=0.175
cc_6808 ( N_RN_c_8024_n N_GND_c_16706_n ) capacitor c=0.0213456f //x=42.825 \
 //y=2.385 //x2=38.97 //y2=0.175
cc_6809 ( N_RN_c_8218_n N_GND_c_16749_n ) capacitor c=2.80619e-19 //x=43.255 \
 //y=2.385 //x2=43.78 //y2=0.175
cc_6810 ( N_RN_c_8226_n N_GND_c_16749_n ) capacitor c=0.0210751f //x=44.515 \
 //y=2.4 //x2=43.78 //y2=0.175
cc_6811 ( N_RN_c_8275_n N_GND_c_16796_n ) capacitor c=0.0205713f //x=50.645 \
 //y=2.4 //x2=48.59 //y2=0.175
cc_6812 ( N_RN_c_8399_n N_GND_c_16796_n ) capacitor c=0.00215938f //x=47.11 \
 //y=2.26 //x2=48.59 //y2=0.175
cc_6813 ( N_RN_c_8424_n N_GND_c_16796_n ) capacitor c=0.00262688f //x=47.63 \
 //y=1.44 //x2=48.59 //y2=0.175
cc_6814 ( N_RN_c_8428_n N_GND_c_16796_n ) capacitor c=2.63786e-19 //x=47.11 \
 //y=2.26 //x2=48.59 //y2=0.175
cc_6815 ( N_RN_c_8335_n N_GND_c_16829_n ) capacitor c=5.73313e-19 //x=52.92 \
 //y=2.37 //x2=53.4 //y2=0.175
cc_6816 ( N_RN_c_8343_n N_GND_c_16829_n ) capacitor c=0.0211503f //x=54.08 \
 //y=2.4 //x2=53.4 //y2=0.175
cc_6817 ( N_RN_c_8353_n N_GND_c_16867_n ) capacitor c=0.0205525f //x=71.685 \
 //y=2.385 //x2=58.21 //y2=0.175
cc_6818 ( N_RN_c_8353_n N_GND_c_16984_n ) capacitor c=0.0209843f //x=71.685 \
 //y=2.385 //x2=63.02 //y2=0.175
cc_6819 ( N_RN_c_8353_n N_GND_c_16997_n ) capacitor c=0.0213456f //x=71.685 \
 //y=2.385 //x2=67.83 //y2=0.175
cc_6820 ( N_RN_c_8611_n N_GND_c_17040_n ) capacitor c=2.80619e-19 //x=72.115 \
 //y=2.385 //x2=72.64 //y2=0.175
cc_6821 ( N_RN_c_8619_n N_GND_c_17040_n ) capacitor c=0.0210751f //x=73.375 \
 //y=2.4 //x2=72.64 //y2=0.175
cc_6822 ( N_RN_c_8792_n N_GND_c_17093_n ) capacitor c=0.020496f //x=79.505 \
 //y=2.41 //x2=77.45 //y2=0.175
cc_6823 ( N_RN_c_8702_n N_GND_c_17093_n ) capacitor c=0.00215938f //x=75.97 \
 //y=2.26 //x2=77.45 //y2=0.175
cc_6824 ( N_RN_c_8967_p N_GND_c_17093_n ) capacitor c=0.00262688f //x=76.49 \
 //y=1.44 //x2=77.45 //y2=0.175
cc_6825 ( N_RN_c_8742_n N_GND_c_17093_n ) capacitor c=2.63786e-19 //x=75.97 \
 //y=2.26 //x2=77.45 //y2=0.175
cc_6826 ( N_RN_c_8529_n N_noxref_47_c_18150_n ) capacitor c=0.0167228f \
 //x=2.275 //y=1.09 //x2=2.935 //y2=0.72
cc_6827 ( N_RN_c_7974_n N_noxref_47_c_18150_n ) capacitor c=0.00534519f \
 //x=2.8 //y=1.09 //x2=2.935 //y2=0.72
cc_6828 ( N_RN_c_7850_n N_noxref_47_c_18144_n ) capacitor c=0.00749908f \
 //x=2.71 //y=2.56 //x2=2.935 //y2=1.77
cc_6829 ( N_RN_c_7855_n N_noxref_47_c_18144_n ) capacitor c=0.00129557f \
 //x=13.795 //y=2.4 //x2=2.935 //y2=1.77
cc_6830 ( N_RN_c_7955_n N_noxref_47_c_18144_n ) capacitor c=0.0105652f \
 //x=2.71 //y=2.26 //x2=2.935 //y2=1.77
cc_6831 ( N_RN_c_8532_n N_noxref_47_c_18144_n ) capacitor c=0.0154024f \
 //x=2.275 //y=1.4 //x2=2.935 //y2=1.77
cc_6832 ( N_RN_c_7977_n N_noxref_47_c_18144_n ) capacitor c=0.021204f //x=2.8 \
 //y=2.095 //x2=2.935 //y2=1.77
cc_6833 ( N_RN_c_7855_n N_noxref_47_M0_noxref_s ) capacitor c=0.00383739f \
 //x=13.795 //y=2.4 //x2=0.945 //y2=0.555
cc_6834 ( N_RN_c_8529_n N_noxref_47_M0_noxref_s ) capacitor c=0.00798959f \
 //x=2.275 //y=1.09 //x2=0.945 //y2=0.555
cc_6835 ( N_RN_c_7976_n N_noxref_47_M0_noxref_s ) capacitor c=0.00212176f \
 //x=2.8 //y=1.63 //x2=0.945 //y2=0.555
cc_6836 ( N_RN_c_7977_n N_noxref_47_M0_noxref_s ) capacitor c=0.00298115f \
 //x=2.8 //y=2.095 //x2=0.945 //y2=0.555
cc_6837 ( N_RN_c_7855_n N_noxref_48_c_18190_n ) capacitor c=0.00444844f \
 //x=13.795 //y=2.4 //x2=5.89 //y2=1.685
cc_6838 ( N_RN_c_7855_n N_noxref_48_c_18191_n ) capacitor c=0.0131757f \
 //x=13.795 //y=2.4 //x2=6.775 //y2=1.77
cc_6839 ( N_RN_c_7855_n N_noxref_48_c_18204_n ) capacitor c=0.0118733f \
 //x=13.795 //y=2.4 //x2=7.745 //y2=1.77
cc_6840 ( N_RN_c_7855_n N_noxref_48_M3_noxref_s ) capacitor c=0.00828583f \
 //x=13.795 //y=2.4 //x2=5.755 //y2=0.555
cc_6841 ( N_RN_c_7855_n N_noxref_49_c_18247_n ) capacitor c=0.00444844f \
 //x=13.795 //y=2.4 //x2=10.7 //y2=1.685
cc_6842 ( N_RN_c_7855_n N_noxref_49_c_18248_n ) capacitor c=0.0133464f \
 //x=13.795 //y=2.4 //x2=11.585 //y2=1.77
cc_6843 ( N_RN_c_7855_n N_noxref_49_c_18261_n ) capacitor c=0.0120668f \
 //x=13.795 //y=2.4 //x2=12.555 //y2=1.77
cc_6844 ( N_RN_c_7855_n N_noxref_49_M6_noxref_s ) capacitor c=0.00841698f \
 //x=13.795 //y=2.4 //x2=10.565 //y2=0.555
cc_6845 ( N_RN_c_7894_n N_noxref_50_c_18305_n ) capacitor c=0.00444844f \
 //x=15.655 //y=2.4 //x2=15.51 //y2=1.685
cc_6846 ( N_RN_c_7894_n N_noxref_50_c_18306_n ) capacitor c=0.00801206f \
 //x=15.655 //y=2.4 //x2=16.395 //y2=1.77
cc_6847 ( N_RN_c_7897_n N_noxref_50_c_18306_n ) capacitor c=0.00405465f \
 //x=16.255 //y=2.385 //x2=16.395 //y2=1.77
cc_6848 ( N_RN_c_7903_n N_noxref_50_c_18306_n ) capacitor c=0.00126965f \
 //x=18.415 //y=2.4 //x2=16.395 //y2=1.77
cc_6849 ( N_RN_c_7903_n N_noxref_50_c_18319_n ) capacitor c=0.0118621f \
 //x=18.415 //y=2.4 //x2=17.365 //y2=1.77
cc_6850 ( N_RN_c_7903_n N_noxref_50_M9_noxref_s ) capacitor c=0.00828583f \
 //x=18.415 //y=2.4 //x2=15.375 //y2=0.555
cc_6851 ( N_RN_c_7947_n N_noxref_51_c_18364_n ) capacitor c=0.00444844f \
 //x=21.785 //y=2.4 //x2=20.32 //y2=1.685
cc_6852 ( N_RN_c_7947_n N_noxref_51_c_18365_n ) capacitor c=0.0133578f \
 //x=21.785 //y=2.4 //x2=21.205 //y2=1.77
cc_6853 ( N_RN_c_7982_n N_noxref_51_c_18378_n ) capacitor c=0.0167228f \
 //x=21.515 //y=1.09 //x2=22.175 //y2=0.72
cc_6854 ( N_RN_c_7987_n N_noxref_51_c_18378_n ) capacitor c=0.00534519f \
 //x=22.04 //y=1.09 //x2=22.175 //y2=0.72
cc_6855 ( N_RN_c_7926_n N_noxref_51_c_18380_n ) capacitor c=0.00747132f \
 //x=21.95 //y=2.57 //x2=22.175 //y2=1.77
cc_6856 ( N_RN_c_7947_n N_noxref_51_c_18380_n ) capacitor c=0.00812797f \
 //x=21.785 //y=2.4 //x2=22.175 //y2=1.77
cc_6857 ( N_RN_c_7953_n N_noxref_51_c_18380_n ) capacitor c=0.00142903f \
 //x=23.57 //y=2.37 //x2=22.175 //y2=1.77
cc_6858 ( N_RN_c_7961_n N_noxref_51_c_18380_n ) capacitor c=0.0105652f \
 //x=21.95 //y=2.26 //x2=22.175 //y2=1.77
cc_6859 ( N_RN_c_7985_n N_noxref_51_c_18380_n ) capacitor c=0.0154134f \
 //x=21.515 //y=1.4 //x2=22.175 //y2=1.77
cc_6860 ( N_RN_c_7990_n N_noxref_51_c_18380_n ) capacitor c=0.0195512f \
 //x=22.04 //y=2.095 //x2=22.175 //y2=1.77
cc_6861 ( N_RN_c_7947_n N_noxref_51_M12_noxref_s ) capacitor c=0.00444844f \
 //x=21.785 //y=2.4 //x2=20.185 //y2=0.555
cc_6862 ( N_RN_c_7953_n N_noxref_51_M12_noxref_s ) capacitor c=0.00383739f \
 //x=23.57 //y=2.37 //x2=20.185 //y2=0.555
cc_6863 ( N_RN_c_7982_n N_noxref_51_M12_noxref_s ) capacitor c=0.00798959f \
 //x=21.515 //y=1.09 //x2=20.185 //y2=0.555
cc_6864 ( N_RN_c_7989_n N_noxref_51_M12_noxref_s ) capacitor c=0.00212176f \
 //x=22.04 //y=1.63 //x2=20.185 //y2=0.555
cc_6865 ( N_RN_c_7990_n N_noxref_51_M12_noxref_s ) capacitor c=0.00298115f \
 //x=22.04 //y=2.095 //x2=20.185 //y2=0.555
cc_6866 ( N_RN_c_8014_n N_noxref_52_c_18422_n ) capacitor c=0.00444844f \
 //x=25.265 //y=2.4 //x2=25.13 //y2=1.685
cc_6867 ( N_RN_c_8014_n N_noxref_52_c_18423_n ) capacitor c=0.00812986f \
 //x=25.265 //y=2.4 //x2=26.015 //y2=1.77
cc_6868 ( N_RN_c_8018_n N_noxref_52_c_18423_n ) capacitor c=0.00387359f \
 //x=25.865 //y=2.37 //x2=26.015 //y2=1.77
cc_6869 ( N_RN_c_8024_n N_noxref_52_c_18423_n ) capacitor c=0.00147953f \
 //x=42.825 //y=2.385 //x2=26.015 //y2=1.77
cc_6870 ( N_RN_c_8024_n N_noxref_52_c_18438_n ) capacitor c=0.0123073f \
 //x=42.825 //y=2.385 //x2=26.985 //y2=1.77
cc_6871 ( N_RN_c_8024_n N_noxref_52_M15_noxref_s ) capacitor c=0.00828583f \
 //x=42.825 //y=2.385 //x2=24.995 //y2=0.555
cc_6872 ( N_RN_c_8024_n N_noxref_53_c_18481_n ) capacitor c=0.00444844f \
 //x=42.825 //y=2.385 //x2=29.94 //y2=1.685
cc_6873 ( N_RN_c_8024_n N_noxref_53_c_18482_n ) capacitor c=0.0133242f \
 //x=42.825 //y=2.385 //x2=30.825 //y2=1.77
cc_6874 ( N_RN_c_8540_n N_noxref_53_c_18495_n ) capacitor c=0.0167228f \
 //x=31.135 //y=1.09 //x2=31.795 //y2=0.72
cc_6875 ( N_RN_c_8302_n N_noxref_53_c_18495_n ) capacitor c=0.00534519f \
 //x=31.66 //y=1.09 //x2=31.795 //y2=0.72
cc_6876 ( N_RN_c_8182_n N_noxref_53_c_18497_n ) capacitor c=0.00749908f \
 //x=31.57 //y=2.56 //x2=31.795 //y2=1.77
cc_6877 ( N_RN_c_8024_n N_noxref_53_c_18497_n ) capacitor c=0.00953276f \
 //x=42.825 //y=2.385 //x2=31.795 //y2=1.77
cc_6878 ( N_RN_c_8283_n N_noxref_53_c_18497_n ) capacitor c=0.0105652f \
 //x=31.57 //y=2.26 //x2=31.795 //y2=1.77
cc_6879 ( N_RN_c_8543_n N_noxref_53_c_18497_n ) capacitor c=0.0154024f \
 //x=31.135 //y=1.4 //x2=31.795 //y2=1.77
cc_6880 ( N_RN_c_8305_n N_noxref_53_c_18497_n ) capacitor c=0.0194838f \
 //x=31.66 //y=2.095 //x2=31.795 //y2=1.77
cc_6881 ( N_RN_c_8024_n N_noxref_53_M18_noxref_s ) capacitor c=0.00828583f \
 //x=42.825 //y=2.385 //x2=29.805 //y2=0.555
cc_6882 ( N_RN_c_8540_n N_noxref_53_M18_noxref_s ) capacitor c=0.00798959f \
 //x=31.135 //y=1.09 //x2=29.805 //y2=0.555
cc_6883 ( N_RN_c_8304_n N_noxref_53_M18_noxref_s ) capacitor c=0.00212176f \
 //x=31.66 //y=1.63 //x2=29.805 //y2=0.555
cc_6884 ( N_RN_c_8305_n N_noxref_53_M18_noxref_s ) capacitor c=0.00298115f \
 //x=31.66 //y=2.095 //x2=29.805 //y2=0.555
cc_6885 ( N_RN_c_8024_n N_noxref_54_c_18537_n ) capacitor c=0.00444844f \
 //x=42.825 //y=2.385 //x2=34.75 //y2=1.685
cc_6886 ( N_RN_c_8024_n N_noxref_54_c_18538_n ) capacitor c=0.0131757f \
 //x=42.825 //y=2.385 //x2=35.635 //y2=1.77
cc_6887 ( N_RN_c_8024_n N_noxref_54_c_18551_n ) capacitor c=0.0118733f \
 //x=42.825 //y=2.385 //x2=36.605 //y2=1.77
cc_6888 ( N_RN_c_8024_n N_noxref_54_M21_noxref_s ) capacitor c=0.00828583f \
 //x=42.825 //y=2.385 //x2=34.615 //y2=0.555
cc_6889 ( N_RN_c_8024_n N_noxref_55_c_18594_n ) capacitor c=0.00444844f \
 //x=42.825 //y=2.385 //x2=39.56 //y2=1.685
cc_6890 ( N_RN_c_8024_n N_noxref_55_c_18595_n ) capacitor c=0.0133215f \
 //x=42.825 //y=2.385 //x2=40.445 //y2=1.77
cc_6891 ( N_RN_c_8024_n N_noxref_55_c_18608_n ) capacitor c=0.0120668f \
 //x=42.825 //y=2.385 //x2=41.415 //y2=1.77
cc_6892 ( N_RN_c_8024_n N_noxref_55_M24_noxref_s ) capacitor c=0.00841698f \
 //x=42.825 //y=2.385 //x2=39.425 //y2=0.555
cc_6893 ( N_RN_c_8226_n N_noxref_56_c_18652_n ) capacitor c=0.00444844f \
 //x=44.515 //y=2.4 //x2=44.37 //y2=1.685
cc_6894 ( N_RN_c_8226_n N_noxref_56_c_18653_n ) capacitor c=0.00801206f \
 //x=44.515 //y=2.4 //x2=45.255 //y2=1.77
cc_6895 ( N_RN_c_8229_n N_noxref_56_c_18653_n ) capacitor c=0.00405465f \
 //x=45.115 //y=2.385 //x2=45.255 //y2=1.77
cc_6896 ( N_RN_c_8235_n N_noxref_56_c_18653_n ) capacitor c=0.00126965f \
 //x=47.275 //y=2.4 //x2=45.255 //y2=1.77
cc_6897 ( N_RN_c_8235_n N_noxref_56_c_18666_n ) capacitor c=0.0118621f \
 //x=47.275 //y=2.4 //x2=46.225 //y2=1.77
cc_6898 ( N_RN_c_8235_n N_noxref_56_M27_noxref_s ) capacitor c=0.00828583f \
 //x=47.275 //y=2.4 //x2=44.235 //y2=0.555
cc_6899 ( N_RN_c_8275_n N_noxref_57_c_18711_n ) capacitor c=0.00444844f \
 //x=50.645 //y=2.4 //x2=49.18 //y2=1.685
cc_6900 ( N_RN_c_8275_n N_noxref_57_c_18712_n ) capacitor c=0.0133578f \
 //x=50.645 //y=2.4 //x2=50.065 //y2=1.77
cc_6901 ( N_RN_c_8310_n N_noxref_57_c_18725_n ) capacitor c=0.0167228f \
 //x=50.375 //y=1.09 //x2=51.035 //y2=0.72
cc_6902 ( N_RN_c_8315_n N_noxref_57_c_18725_n ) capacitor c=0.00534519f \
 //x=50.9 //y=1.09 //x2=51.035 //y2=0.72
cc_6903 ( N_RN_c_8258_n N_noxref_57_c_18727_n ) capacitor c=0.00747132f \
 //x=50.81 //y=2.57 //x2=51.035 //y2=1.77
cc_6904 ( N_RN_c_8275_n N_noxref_57_c_18727_n ) capacitor c=0.00812797f \
 //x=50.645 //y=2.4 //x2=51.035 //y2=1.77
cc_6905 ( N_RN_c_8281_n N_noxref_57_c_18727_n ) capacitor c=0.00142903f \
 //x=52.49 //y=2.37 //x2=51.035 //y2=1.77
cc_6906 ( N_RN_c_8289_n N_noxref_57_c_18727_n ) capacitor c=0.0105652f \
 //x=50.81 //y=2.26 //x2=51.035 //y2=1.77
cc_6907 ( N_RN_c_8313_n N_noxref_57_c_18727_n ) capacitor c=0.0154134f \
 //x=50.375 //y=1.4 //x2=51.035 //y2=1.77
cc_6908 ( N_RN_c_8318_n N_noxref_57_c_18727_n ) capacitor c=0.0195512f \
 //x=50.9 //y=2.095 //x2=51.035 //y2=1.77
cc_6909 ( N_RN_c_8275_n N_noxref_57_M30_noxref_s ) capacitor c=0.00444844f \
 //x=50.645 //y=2.4 //x2=49.045 //y2=0.555
cc_6910 ( N_RN_c_8281_n N_noxref_57_M30_noxref_s ) capacitor c=0.00383739f \
 //x=52.49 //y=2.37 //x2=49.045 //y2=0.555
cc_6911 ( N_RN_c_8310_n N_noxref_57_M30_noxref_s ) capacitor c=0.00798959f \
 //x=50.375 //y=1.09 //x2=49.045 //y2=0.555
cc_6912 ( N_RN_c_8317_n N_noxref_57_M30_noxref_s ) capacitor c=0.00212176f \
 //x=50.9 //y=1.63 //x2=49.045 //y2=0.555
cc_6913 ( N_RN_c_8318_n N_noxref_57_M30_noxref_s ) capacitor c=0.00298115f \
 //x=50.9 //y=2.095 //x2=49.045 //y2=0.555
cc_6914 ( N_RN_c_8343_n N_noxref_58_c_18769_n ) capacitor c=0.00444844f \
 //x=54.08 //y=2.4 //x2=53.99 //y2=1.685
cc_6915 ( N_RN_c_8343_n N_noxref_58_c_18770_n ) capacitor c=0.0080551f \
 //x=54.08 //y=2.4 //x2=54.875 //y2=1.77
cc_6916 ( N_RN_c_8347_n N_noxref_58_c_18770_n ) capacitor c=0.00292686f \
 //x=54.68 //y=2.37 //x2=54.875 //y2=1.77
cc_6917 ( N_RN_c_8353_n N_noxref_58_c_18770_n ) capacitor c=0.002424f \
 //x=71.685 //y=2.385 //x2=54.875 //y2=1.77
cc_6918 ( N_RN_c_8353_n N_noxref_58_c_18785_n ) capacitor c=0.0123073f \
 //x=71.685 //y=2.385 //x2=55.845 //y2=1.77
cc_6919 ( N_RN_c_8353_n N_noxref_58_M33_noxref_s ) capacitor c=0.00828583f \
 //x=71.685 //y=2.385 //x2=53.855 //y2=0.555
cc_6920 ( N_RN_c_8353_n N_noxref_59_c_18828_n ) capacitor c=0.00444844f \
 //x=71.685 //y=2.385 //x2=58.8 //y2=1.685
cc_6921 ( N_RN_c_8353_n N_noxref_59_c_18829_n ) capacitor c=0.0133675f \
 //x=71.685 //y=2.385 //x2=59.685 //y2=1.77
cc_6922 ( N_RN_c_8551_n N_noxref_59_c_18842_n ) capacitor c=0.0167228f \
 //x=59.995 //y=1.09 //x2=60.655 //y2=0.72
cc_6923 ( N_RN_c_8556_n N_noxref_59_c_18842_n ) capacitor c=0.00534519f \
 //x=60.52 //y=1.09 //x2=60.655 //y2=0.72
cc_6924 ( N_RN_c_8476_n N_noxref_59_c_18844_n ) capacitor c=0.00749908f \
 //x=60.43 //y=2.56 //x2=60.655 //y2=1.77
cc_6925 ( N_RN_c_8353_n N_noxref_59_c_18844_n ) capacitor c=0.00953276f \
 //x=71.685 //y=2.385 //x2=60.655 //y2=1.77
cc_6926 ( N_RN_c_8513_n N_noxref_59_c_18844_n ) capacitor c=0.0105652f \
 //x=60.43 //y=2.26 //x2=60.655 //y2=1.77
cc_6927 ( N_RN_c_8554_n N_noxref_59_c_18844_n ) capacitor c=0.0154024f \
 //x=59.995 //y=1.4 //x2=60.655 //y2=1.77
cc_6928 ( N_RN_c_8559_n N_noxref_59_c_18844_n ) capacitor c=0.0194838f \
 //x=60.52 //y=2.095 //x2=60.655 //y2=1.77
cc_6929 ( N_RN_c_8353_n N_noxref_59_M36_noxref_s ) capacitor c=0.00828583f \
 //x=71.685 //y=2.385 //x2=58.665 //y2=0.555
cc_6930 ( N_RN_c_8551_n N_noxref_59_M36_noxref_s ) capacitor c=0.00798959f \
 //x=59.995 //y=1.09 //x2=58.665 //y2=0.555
cc_6931 ( N_RN_c_8558_n N_noxref_59_M36_noxref_s ) capacitor c=0.00212176f \
 //x=60.52 //y=1.63 //x2=58.665 //y2=0.555
cc_6932 ( N_RN_c_8559_n N_noxref_59_M36_noxref_s ) capacitor c=0.00298115f \
 //x=60.52 //y=2.095 //x2=58.665 //y2=0.555
cc_6933 ( N_RN_c_8353_n N_noxref_60_c_18884_n ) capacitor c=0.00444844f \
 //x=71.685 //y=2.385 //x2=63.61 //y2=1.685
cc_6934 ( N_RN_c_8353_n N_noxref_60_c_18885_n ) capacitor c=0.0131757f \
 //x=71.685 //y=2.385 //x2=64.495 //y2=1.77
cc_6935 ( N_RN_c_8353_n N_noxref_60_c_18898_n ) capacitor c=0.0118733f \
 //x=71.685 //y=2.385 //x2=65.465 //y2=1.77
cc_6936 ( N_RN_c_8353_n N_noxref_60_M39_noxref_s ) capacitor c=0.00828583f \
 //x=71.685 //y=2.385 //x2=63.475 //y2=0.555
cc_6937 ( N_RN_c_8353_n N_noxref_61_c_18941_n ) capacitor c=0.00444844f \
 //x=71.685 //y=2.385 //x2=68.42 //y2=1.685
cc_6938 ( N_RN_c_8353_n N_noxref_61_c_18942_n ) capacitor c=0.0133215f \
 //x=71.685 //y=2.385 //x2=69.305 //y2=1.77
cc_6939 ( N_RN_c_8353_n N_noxref_61_c_18955_n ) capacitor c=0.0120668f \
 //x=71.685 //y=2.385 //x2=70.275 //y2=1.77
cc_6940 ( N_RN_c_8353_n N_noxref_61_M42_noxref_s ) capacitor c=0.00841698f \
 //x=71.685 //y=2.385 //x2=68.285 //y2=0.555
cc_6941 ( N_RN_c_8619_n N_noxref_62_c_18999_n ) capacitor c=0.00444844f \
 //x=73.375 //y=2.4 //x2=73.23 //y2=1.685
cc_6942 ( N_RN_c_8619_n N_noxref_62_c_19000_n ) capacitor c=0.00801206f \
 //x=73.375 //y=2.4 //x2=74.115 //y2=1.77
cc_6943 ( N_RN_c_8622_n N_noxref_62_c_19000_n ) capacitor c=0.00405465f \
 //x=73.975 //y=2.385 //x2=74.115 //y2=1.77
cc_6944 ( N_RN_c_8628_n N_noxref_62_c_19000_n ) capacitor c=0.00126965f \
 //x=76.135 //y=2.4 //x2=74.115 //y2=1.77
cc_6945 ( N_RN_c_8628_n N_noxref_62_c_19013_n ) capacitor c=0.0118621f \
 //x=76.135 //y=2.4 //x2=75.085 //y2=1.77
cc_6946 ( N_RN_c_8628_n N_noxref_62_M45_noxref_s ) capacitor c=0.00828583f \
 //x=76.135 //y=2.4 //x2=73.095 //y2=0.555
cc_6947 ( N_RN_c_8792_n N_noxref_63_c_19058_n ) capacitor c=0.00444844f \
 //x=79.505 //y=2.41 //x2=78.04 //y2=1.685
cc_6948 ( N_RN_c_8792_n N_noxref_63_c_19059_n ) capacitor c=0.0133578f \
 //x=79.505 //y=2.41 //x2=78.925 //y2=1.77
cc_6949 ( N_RN_c_8824_n N_noxref_63_c_19072_n ) capacitor c=0.0167228f \
 //x=79.235 //y=1.09 //x2=79.895 //y2=0.72
cc_6950 ( N_RN_c_8829_n N_noxref_63_c_19072_n ) capacitor c=0.00534519f \
 //x=79.76 //y=1.09 //x2=79.895 //y2=0.72
cc_6951 ( N_RN_c_8772_n N_noxref_63_c_19074_n ) capacitor c=0.00747132f \
 //x=79.67 //y=2.57 //x2=79.895 //y2=1.77
cc_6952 ( N_RN_c_8792_n N_noxref_63_c_19074_n ) capacitor c=0.00812797f \
 //x=79.505 //y=2.41 //x2=79.895 //y2=1.77
cc_6953 ( N_RN_c_8803_n N_noxref_63_c_19074_n ) capacitor c=0.0105652f \
 //x=79.67 //y=2.26 //x2=79.895 //y2=1.77
cc_6954 ( N_RN_c_8827_n N_noxref_63_c_19074_n ) capacitor c=0.0154134f \
 //x=79.235 //y=1.4 //x2=79.895 //y2=1.77
cc_6955 ( N_RN_c_8832_n N_noxref_63_c_19074_n ) capacitor c=0.0196098f \
 //x=79.76 //y=2.095 //x2=79.895 //y2=1.77
cc_6956 ( N_RN_c_8792_n N_noxref_63_M48_noxref_s ) capacitor c=0.00444844f \
 //x=79.505 //y=2.41 //x2=77.905 //y2=0.555
cc_6957 ( N_RN_c_8824_n N_noxref_63_M48_noxref_s ) capacitor c=0.00798959f \
 //x=79.235 //y=1.09 //x2=77.905 //y2=0.555
cc_6958 ( N_RN_c_8831_n N_noxref_63_M48_noxref_s ) capacitor c=0.00212176f \
 //x=79.76 //y=1.63 //x2=77.905 //y2=0.555
cc_6959 ( N_RN_c_8832_n N_noxref_63_M48_noxref_s ) capacitor c=0.00298115f \
 //x=79.76 //y=2.095 //x2=77.905 //y2=0.555
cc_6960 ( N_noxref_18_c_9580_p N_SN_c_10624_n ) capacitor c=0.00884061f \
 //x=83.37 //y=2.375 //x2=84.48 //y2=2.375
cc_6961 ( N_noxref_18_c_9581_p N_SN_c_10624_n ) capacitor c=5.40058e-19 \
 //x=83.37 //y=2.26 //x2=84.48 //y2=2.375
cc_6962 ( N_noxref_18_c_9582_p N_SN_c_10624_n ) capacitor c=0.00142893f \
 //x=83.07 //y=2.095 //x2=84.48 //y2=2.375
cc_6963 ( N_noxref_18_c_9583_p N_SN_c_10627_n ) capacitor c=3.09477e-19 \
 //x=81.52 //y=2.595 //x2=84.48 //y2=2.985
cc_6964 ( N_noxref_18_c_9584_p N_SN_c_10627_n ) capacitor c=0.00427661f \
 //x=83.37 //y=2.595 //x2=84.48 //y2=2.985
cc_6965 ( N_noxref_18_c_9585_p N_SN_c_10627_n ) capacitor c=0.00776519f \
 //x=83.37 //y=2.915 //x2=84.48 //y2=2.985
cc_6966 ( N_noxref_18_c_9553_n N_SN_c_10627_n ) capacitor c=0.00199877f \
 //x=83.37 //y=4.755 //x2=84.48 //y2=2.985
cc_6967 ( N_noxref_18_c_9587_p N_SN_c_10627_n ) capacitor c=4.11345e-19 \
 //x=83.37 //y=2.77 //x2=84.48 //y2=2.985
cc_6968 ( N_noxref_18_c_9588_p N_SN_c_10627_n ) capacitor c=0.00506806f \
 //x=83.365 //y=2.755 //x2=84.48 //y2=2.985
cc_6969 ( N_noxref_18_c_9581_p N_SN_c_10627_n ) capacitor c=3.9149e-19 \
 //x=83.37 //y=2.26 //x2=84.48 //y2=2.985
cc_6970 ( N_noxref_18_c_9553_n N_SN_c_10634_n ) capacitor c=0.00772613f \
 //x=83.37 //y=4.755 //x2=84.48 //y2=3.305
cc_6971 ( N_noxref_18_c_9552_n N_SN_c_10071_n ) capacitor c=0.00103178f \
 //x=81.52 //y=5.25 //x2=84.48 //y2=4.765
cc_6972 ( N_noxref_18_c_9553_n N_SN_c_10071_n ) capacitor c=0.0474493f \
 //x=83.37 //y=4.755 //x2=84.48 //y2=4.765
cc_6973 ( N_noxref_18_c_9593_p N_SN_c_10071_n ) capacitor c=6.26008e-19 \
 //x=83.37 //y=4.88 //x2=84.48 //y2=4.765
cc_6974 ( N_noxref_18_c_9594_p N_SN_c_10071_n ) capacitor c=7.66769e-19 \
 //x=83.935 //y=4.97 //x2=84.48 //y2=4.765
cc_6975 ( N_noxref_18_c_9595_p N_SN_c_10071_n ) capacitor c=7.54501e-19 \
 //x=83.645 //y=4.97 //x2=84.48 //y2=4.765
cc_6976 ( N_noxref_18_c_9553_n N_SN_c_10640_n ) capacitor c=3.43503e-19 \
 //x=83.37 //y=4.755 //x2=84.48 //y2=3.14
cc_6977 ( N_noxref_18_c_9597_p N_SN_c_10530_n ) capacitor c=0.0119877f \
 //x=81.52 //y=2.915 //x2=78.77 //y2=3.125
cc_6978 ( N_noxref_18_c_9552_n N_SN_c_10530_n ) capacitor c=0.0254449f \
 //x=81.52 //y=5.25 //x2=78.77 //y2=3.125
cc_6979 ( N_noxref_18_c_9585_p N_SN_c_10530_n ) capacitor c=0.00872451f \
 //x=83.37 //y=2.915 //x2=78.77 //y2=3.125
cc_6980 ( N_noxref_18_c_9553_n N_SN_c_10530_n ) capacitor c=0.0287181f \
 //x=83.37 //y=4.755 //x2=78.77 //y2=3.125
cc_6981 ( N_noxref_18_c_9601_p N_SN_c_10530_n ) capacitor c=0.0358686f \
 //x=81.68 //y=2.755 //x2=78.77 //y2=3.125
cc_6982 ( N_noxref_18_c_9588_p N_SN_c_10530_n ) capacitor c=0.0358686f \
 //x=83.365 //y=2.755 //x2=78.77 //y2=3.125
cc_6983 ( N_noxref_18_c_9603_p N_SN_c_10530_n ) capacitor c=0.134106f \
 //x=83.205 //y=2.755 //x2=78.77 //y2=3.125
cc_6984 ( N_noxref_18_c_9580_p N_SN_c_10648_n ) capacitor c=5.39999e-19 \
 //x=83.37 //y=2.375 //x2=84.48 //y2=2.26
cc_6985 ( N_noxref_18_c_9584_p N_SN_c_10648_n ) capacitor c=3.9149e-19 \
 //x=83.37 //y=2.595 //x2=84.48 //y2=2.26
cc_6986 ( N_noxref_18_c_9581_p N_SN_c_10648_n ) capacitor c=0.00125213f \
 //x=83.37 //y=2.26 //x2=84.48 //y2=2.26
cc_6987 ( N_noxref_18_c_9582_p N_SN_c_10648_n ) capacitor c=0.00214573f \
 //x=83.07 //y=2.095 //x2=84.48 //y2=2.26
cc_6988 ( N_noxref_18_c_9553_n N_SN_c_10652_n ) capacitor c=0.00103399f \
 //x=83.37 //y=4.755 //x2=84.48 //y2=4.88
cc_6989 ( N_noxref_18_c_9593_p N_SN_c_10652_n ) capacitor c=0.00113984f \
 //x=83.37 //y=4.88 //x2=84.48 //y2=4.88
cc_6990 ( N_noxref_18_c_9594_p N_SN_c_10652_n ) capacitor c=0.00116563f \
 //x=83.935 //y=4.97 //x2=84.48 //y2=4.88
cc_6991 ( N_noxref_18_c_9595_p N_SN_c_10652_n ) capacitor c=0.00129812f \
 //x=83.645 //y=4.97 //x2=84.48 //y2=4.88
cc_6992 ( N_noxref_18_M163_noxref_g N_SN_M165_noxref_g ) capacitor \
 c=0.0106276f //x=83.57 //y=6.2 //x2=84.45 //y2=6.2
cc_6993 ( N_noxref_18_M164_noxref_g N_SN_M165_noxref_g ) capacitor c=0.107144f \
 //x=84.01 //y=6.2 //x2=84.45 //y2=6.2
cc_6994 ( N_noxref_18_M164_noxref_g N_SN_M166_noxref_g ) capacitor \
 c=0.0101598f //x=84.01 //y=6.2 //x2=84.89 //y2=6.2
cc_6995 ( N_noxref_18_c_9615_p N_SN_c_10659_n ) capacitor c=5.72528e-19 \
 //x=83.07 //y=1.055 //x2=84.045 //y2=1.09
cc_6996 ( N_noxref_18_c_9616_p N_SN_c_10659_n ) capacitor c=0.00150277f \
 //x=83.07 //y=1.4 //x2=84.045 //y2=1.09
cc_6997 ( N_noxref_18_c_9617_p N_SN_c_10659_n ) capacitor c=0.0160123f \
 //x=83.6 //y=1.055 //x2=84.045 //y2=1.09
cc_6998 ( N_noxref_18_c_9618_p N_SN_c_10662_n ) capacitor c=0.00111227f \
 //x=83.07 //y=1.71 //x2=84.045 //y2=1.4
cc_6999 ( N_noxref_18_c_9619_p N_SN_c_10662_n ) capacitor c=0.0124075f \
 //x=83.6 //y=1.4 //x2=84.045 //y2=1.4
cc_7000 ( N_noxref_18_c_9617_p N_SN_c_10664_n ) capacitor c=9.19165e-19 \
 //x=83.6 //y=1.055 //x2=84.57 //y2=1.09
cc_7001 ( N_noxref_18_c_9619_p N_SN_c_10665_n ) capacitor c=0.0010154f \
 //x=83.6 //y=1.4 //x2=84.57 //y2=1.4
cc_7002 ( N_noxref_18_c_9619_p N_SN_c_10666_n ) capacitor c=9.23422e-19 \
 //x=83.6 //y=1.4 //x2=84.57 //y2=1.63
cc_7003 ( N_noxref_18_c_9580_p N_SN_c_10667_n ) capacitor c=0.00134337f \
 //x=83.37 //y=2.375 //x2=84.57 //y2=2.095
cc_7004 ( N_noxref_18_c_9581_p N_SN_c_10667_n ) capacitor c=0.0020754f \
 //x=83.37 //y=2.26 //x2=84.57 //y2=2.095
cc_7005 ( N_noxref_18_c_9582_p N_SN_c_10667_n ) capacitor c=0.00964411f \
 //x=83.07 //y=2.095 //x2=84.57 //y2=2.095
cc_7006 ( N_noxref_18_c_9553_n N_SN_c_10670_n ) capacitor c=0.00116212f \
 //x=83.37 //y=4.755 //x2=84.48 //y2=4.88
cc_7007 ( N_noxref_18_c_9593_p N_SN_c_10670_n ) capacitor c=0.00155973f \
 //x=83.37 //y=4.88 //x2=84.48 //y2=4.88
cc_7008 ( N_noxref_18_c_9594_p N_SN_c_10670_n ) capacitor c=0.0171374f \
 //x=83.935 //y=4.97 //x2=84.48 //y2=4.88
cc_7009 ( N_noxref_18_c_9595_p N_SN_c_10670_n ) capacitor c=0.00484466f \
 //x=83.645 //y=4.97 //x2=84.48 //y2=4.88
cc_7010 ( N_noxref_18_c_9554_n N_noxref_20_c_11284_n ) capacitor c=6.09703e-19 \
 //x=78.982 //y=5.335 //x2=75.93 //y2=5.56
cc_7011 ( N_noxref_18_c_9554_n N_noxref_20_c_11050_n ) capacitor c=0.00306432f \
 //x=78.982 //y=5.335 //x2=76.625 //y2=5.335
cc_7012 ( N_noxref_18_c_9632_p N_noxref_20_c_11302_n ) capacitor c=0.00163399f \
 //x=81.12 //y=1.845 //x2=76.625 //y2=1.845
cc_7013 ( N_noxref_18_c_9584_p N_noxref_20_c_11054_n ) capacitor c=3.73717e-19 \
 //x=83.37 //y=2.595 //x2=85.59 //y2=3.725
cc_7014 ( N_noxref_18_c_9553_n N_noxref_20_c_11054_n ) capacitor c=0.00123555f \
 //x=83.37 //y=4.755 //x2=85.59 //y2=3.725
cc_7015 ( N_noxref_18_c_9553_n N_noxref_20_c_11055_n ) capacitor c=5.73787e-19 \
 //x=83.37 //y=4.755 //x2=85.59 //y2=4.75
cc_7016 ( N_noxref_18_c_9552_n N_noxref_20_c_11063_n ) capacitor c=0.0260189f \
 //x=81.52 //y=5.25 //x2=78.77 //y2=3.895
cc_7017 ( N_noxref_18_c_9553_n N_noxref_20_c_11063_n ) capacitor c=0.0274586f \
 //x=83.37 //y=4.755 //x2=78.77 //y2=3.895
cc_7018 ( N_noxref_18_c_9603_p N_noxref_20_c_11063_n ) capacitor c=0.00523856f \
 //x=83.205 //y=2.755 //x2=78.77 //y2=3.895
cc_7019 ( N_noxref_18_c_9568_n N_noxref_21_c_11711_n ) capacitor c=5.3431e-19 \
 //x=80.625 //y=5.335 //x2=80.78 //y2=2.485
cc_7020 ( N_noxref_18_c_9640_p N_noxref_21_c_11711_n ) capacitor c=2.17831e-19 \
 //x=81.035 //y=1.305 //x2=80.78 //y2=2.485
cc_7021 ( N_noxref_18_c_9583_p N_noxref_21_c_11711_n ) capacitor c=0.0174277f \
 //x=81.52 //y=2.595 //x2=80.78 //y2=2.485
cc_7022 ( N_noxref_18_c_9551_n N_noxref_21_c_11652_n ) capacitor c=0.00228791f \
 //x=81.435 //y=5.335 //x2=80.78 //y2=4.75
cc_7023 ( N_noxref_18_c_9583_p N_noxref_21_c_11652_n ) capacitor c=0.00458056f \
 //x=81.52 //y=2.595 //x2=80.78 //y2=4.75
cc_7024 ( N_noxref_18_c_9597_p N_noxref_21_c_11652_n ) capacitor c=0.0151131f \
 //x=81.52 //y=2.915 //x2=80.78 //y2=4.75
cc_7025 ( N_noxref_18_c_9552_n N_noxref_21_c_11652_n ) capacitor c=0.0894321f \
 //x=81.52 //y=5.25 //x2=80.78 //y2=4.75
cc_7026 ( N_noxref_18_c_9584_p N_noxref_21_c_11652_n ) capacitor c=3.77983e-19 \
 //x=83.37 //y=2.595 //x2=80.78 //y2=4.75
cc_7027 ( N_noxref_18_c_9553_n N_noxref_21_c_11652_n ) capacitor c=0.00168534f \
 //x=83.37 //y=4.755 //x2=80.78 //y2=4.75
cc_7028 ( N_noxref_18_c_9648_p N_noxref_21_c_11652_n ) capacitor c=0.0221596f \
 //x=80.74 //y=5.335 //x2=80.78 //y2=4.75
cc_7029 ( N_noxref_18_c_9649_p N_noxref_21_c_11652_n ) capacitor c=7.6985e-19 \
 //x=81.52 //y=2.77 //x2=80.78 //y2=4.75
cc_7030 ( N_noxref_18_c_9601_p N_noxref_21_c_11652_n ) capacitor c=0.00687503f \
 //x=81.68 //y=2.755 //x2=80.78 //y2=4.75
cc_7031 ( N_noxref_18_c_9651_p N_noxref_21_c_11652_n ) capacitor c=0.00266871f \
 //x=80.74 //y=5.56 //x2=80.78 //y2=4.75
cc_7032 ( N_noxref_18_M164_noxref_g N_noxref_21_c_11756_n ) capacitor \
 c=0.00893512f //x=84.01 //y=6.2 //x2=84.55 //y2=5.335
cc_7033 ( N_noxref_18_c_9653_p N_noxref_21_c_11757_n ) capacitor c=0.00163399f \
 //x=81.435 //y=1.845 //x2=85.93 //y2=1.845
cc_7034 ( N_noxref_18_c_9654_p N_noxref_21_c_11670_n ) capacitor c=6.09703e-19 \
 //x=80.74 //y=5.56 //x2=83.792 //y2=5.335
cc_7035 ( N_noxref_18_c_9551_n N_noxref_21_c_11670_n ) capacitor c=0.00306432f \
 //x=81.435 //y=5.335 //x2=83.792 //y2=5.335
cc_7036 ( N_noxref_18_M163_noxref_g N_noxref_21_c_11670_n ) capacitor \
 c=0.00461408f //x=83.57 //y=6.2 //x2=83.792 //y2=5.335
cc_7037 ( N_noxref_18_M164_noxref_g N_noxref_21_c_11670_n ) capacitor \
 c=0.00229208f //x=84.01 //y=6.2 //x2=83.792 //y2=5.335
cc_7038 ( N_noxref_18_c_9594_p N_noxref_21_c_11670_n ) capacitor c=0.00171885f \
 //x=83.935 //y=4.97 //x2=83.792 //y2=5.335
cc_7039 ( N_noxref_18_c_9640_p N_noxref_21_c_11763_n ) capacitor c=4.55408e-19 \
 //x=81.035 //y=1.305 //x2=81.135 //y2=2.4
cc_7040 ( N_noxref_18_c_9653_p N_noxref_21_c_11763_n ) capacitor c=0.00875832f \
 //x=81.435 //y=1.845 //x2=81.135 //y2=2.4
cc_7041 ( N_noxref_18_c_9632_p N_noxref_21_c_11763_n ) capacitor c=0.0125707f \
 //x=81.12 //y=1.845 //x2=81.135 //y2=2.4
cc_7042 ( N_noxref_18_c_9583_p N_noxref_21_c_11763_n ) capacitor c=6.0773e-19 \
 //x=81.52 //y=2.595 //x2=81.135 //y2=2.4
cc_7043 ( N_noxref_18_c_9583_p N_noxref_21_c_11767_n ) capacitor c=0.0269591f \
 //x=81.52 //y=2.595 //x2=81.735 //y2=2.37
cc_7044 ( N_noxref_18_c_9597_p N_noxref_21_c_11767_n ) capacitor c=0.00565443f \
 //x=81.52 //y=2.915 //x2=81.735 //y2=2.37
cc_7045 ( N_noxref_18_c_9601_p N_noxref_21_c_11767_n ) capacitor c=0.0365231f \
 //x=81.68 //y=2.755 //x2=81.735 //y2=2.37
cc_7046 ( N_noxref_18_c_9603_p N_noxref_21_c_11767_n ) capacitor c=0.131683f \
 //x=83.205 //y=2.755 //x2=81.735 //y2=2.37
cc_7047 ( N_noxref_18_c_9583_p N_noxref_21_c_11771_n ) capacitor c=2.03464e-19 \
 //x=81.52 //y=2.595 //x2=82.98 //y2=2.4
cc_7048 ( N_noxref_18_c_9584_p N_noxref_21_c_11771_n ) capacitor c=9.97486e-19 \
 //x=83.37 //y=2.595 //x2=82.98 //y2=2.4
cc_7049 ( N_noxref_18_c_9585_p N_noxref_21_c_11771_n ) capacitor c=0.00312914f \
 //x=83.37 //y=2.915 //x2=82.98 //y2=2.4
cc_7050 ( N_noxref_18_c_9603_p N_noxref_21_c_11771_n ) capacitor c=0.0107299f \
 //x=83.205 //y=2.755 //x2=82.98 //y2=2.4
cc_7051 ( N_noxref_18_c_9580_p N_noxref_21_c_11775_n ) capacitor c=0.0181219f \
 //x=83.37 //y=2.375 //x2=83.58 //y2=2.37
cc_7052 ( N_noxref_18_c_9584_p N_noxref_21_c_11775_n ) capacitor c=0.0105258f \
 //x=83.37 //y=2.595 //x2=83.58 //y2=2.37
cc_7053 ( N_noxref_18_c_9585_p N_noxref_21_c_11775_n ) capacitor c=0.00442601f \
 //x=83.37 //y=2.915 //x2=83.58 //y2=2.37
cc_7054 ( N_noxref_18_c_9588_p N_noxref_21_c_11775_n ) capacitor c=0.0370412f \
 //x=83.365 //y=2.755 //x2=83.58 //y2=2.37
cc_7055 ( N_noxref_18_c_9581_p N_noxref_21_c_11775_n ) capacitor c=5.18204e-19 \
 //x=83.37 //y=2.26 //x2=83.58 //y2=2.37
cc_7056 ( N_noxref_18_c_9582_p N_noxref_21_c_11775_n ) capacitor c=3.41298e-19 \
 //x=83.07 //y=2.095 //x2=83.58 //y2=2.37
cc_7057 ( N_noxref_18_c_9584_p N_noxref_21_c_11681_n ) capacitor c=7.62769e-19 \
 //x=83.37 //y=2.595 //x2=86.485 //y2=2.4
cc_7058 ( N_noxref_18_c_9583_p N_noxref_21_c_11721_n ) capacitor c=0.00259319f \
 //x=81.52 //y=2.595 //x2=80.77 //y2=2.325
cc_7059 ( N_noxref_18_c_9583_p N_noxref_21_c_11723_n ) capacitor c=9.86766e-19 \
 //x=81.52 //y=2.595 //x2=80.78 //y2=2.26
cc_7060 ( N_noxref_18_c_9551_n N_noxref_21_c_11726_n ) capacitor c=0.00130631f \
 //x=81.435 //y=5.335 //x2=80.78 //y2=4.88
cc_7061 ( N_noxref_18_c_9552_n N_noxref_21_c_11726_n ) capacitor c=0.00131258f \
 //x=81.52 //y=5.25 //x2=80.78 //y2=4.88
cc_7062 ( N_noxref_18_c_9648_p N_noxref_21_c_11726_n ) capacitor c=0.00346456f \
 //x=80.74 //y=5.335 //x2=80.78 //y2=4.88
cc_7063 ( N_noxref_18_c_9651_p N_noxref_21_c_11726_n ) capacitor c=0.00624059f \
 //x=80.74 //y=5.56 //x2=80.78 //y2=4.88
cc_7064 ( N_noxref_18_M163_noxref_g N_noxref_21_c_11788_n ) capacitor \
 c=0.0162284f //x=83.57 //y=6.2 //x2=83.79 //y2=5.56
cc_7065 ( N_noxref_18_M164_noxref_g N_noxref_21_c_11788_n ) capacitor \
 c=0.0179041f //x=84.01 //y=6.2 //x2=83.79 //y2=5.56
cc_7066 ( N_noxref_18_c_9594_p N_noxref_21_c_11788_n ) capacitor c=0.00291477f \
 //x=83.935 //y=4.97 //x2=83.79 //y2=5.56
cc_7067 ( N_noxref_18_c_9568_n N_noxref_21_M161_noxref_g ) capacitor \
 c=0.00955829f //x=80.625 //y=5.335 //x2=80.52 //y2=6.2
cc_7068 ( N_noxref_18_c_9654_p N_noxref_21_M161_noxref_g ) capacitor \
 c=0.00226521f //x=80.74 //y=5.56 //x2=80.52 //y2=6.2
cc_7069 ( N_noxref_18_c_9651_p N_noxref_21_M161_noxref_g ) capacitor \
 c=0.0178885f //x=80.74 //y=5.56 //x2=80.52 //y2=6.2
cc_7070 ( N_noxref_18_c_9654_p N_noxref_21_M162_noxref_g ) capacitor \
 c=0.00381703f //x=80.74 //y=5.56 //x2=80.96 //y2=6.2
cc_7071 ( N_noxref_18_c_9551_n N_noxref_21_M162_noxref_g ) capacitor \
 c=0.0108329f //x=81.435 //y=5.335 //x2=80.96 //y2=6.2
cc_7072 ( N_noxref_18_c_9651_p N_noxref_21_M162_noxref_g ) capacitor \
 c=0.0188608f //x=80.74 //y=5.56 //x2=80.96 //y2=6.2
cc_7073 ( N_noxref_18_c_9640_p N_noxref_21_c_11733_n ) capacitor c=4.64015e-19 \
 //x=81.035 //y=1.305 //x2=80.77 //y2=1.095
cc_7074 ( N_noxref_18_M50_noxref_d N_noxref_21_c_11733_n ) capacitor \
 c=0.00137165f //x=80.845 //y=1.095 //x2=80.77 //y2=1.095
cc_7075 ( N_noxref_18_c_9640_p N_noxref_21_c_11734_n ) capacitor c=0.0026012f \
 //x=81.035 //y=1.305 //x2=80.77 //y2=1.44
cc_7076 ( N_noxref_18_c_9696_p N_noxref_21_c_11734_n ) capacitor c=0.00127432f \
 //x=81.035 //y=1.76 //x2=80.77 //y2=1.44
cc_7077 ( N_noxref_18_M50_noxref_d N_noxref_21_c_11734_n ) capacitor \
 c=0.00237422f //x=80.845 //y=1.095 //x2=80.77 //y2=1.44
cc_7078 ( N_noxref_18_c_9696_p N_noxref_21_c_11735_n ) capacitor c=0.00441386f \
 //x=81.035 //y=1.76 //x2=80.77 //y2=1.75
cc_7079 ( N_noxref_18_c_9640_p N_noxref_21_c_11803_n ) capacitor c=5.29969e-19 \
 //x=81.035 //y=1.305 //x2=81.145 //y2=0.94
cc_7080 ( N_noxref_18_M50_noxref_d N_noxref_21_c_11803_n ) capacitor \
 c=0.0020782f //x=80.845 //y=1.095 //x2=81.145 //y2=0.94
cc_7081 ( N_noxref_18_c_9640_p N_noxref_21_c_11805_n ) capacitor c=5.24324e-19 \
 //x=81.035 //y=1.305 //x2=81.145 //y2=1.595
cc_7082 ( N_noxref_18_c_9696_p N_noxref_21_c_11805_n ) capacitor c=0.00942306f \
 //x=81.035 //y=1.76 //x2=81.145 //y2=1.595
cc_7083 ( N_noxref_18_c_9653_p N_noxref_21_c_11805_n ) capacitor c=0.00194716f \
 //x=81.435 //y=1.845 //x2=81.145 //y2=1.595
cc_7084 ( N_noxref_18_M50_noxref_d N_noxref_21_c_11805_n ) capacitor \
 c=0.00356097f //x=80.845 //y=1.095 //x2=81.145 //y2=1.595
cc_7085 ( N_noxref_18_c_9640_p N_noxref_21_c_11809_n ) capacitor c=5.24634e-19 \
 //x=81.035 //y=1.305 //x2=81.3 //y2=1.095
cc_7086 ( N_noxref_18_M50_noxref_d N_noxref_21_c_11809_n ) capacitor \
 c=0.00139206f //x=80.845 //y=1.095 //x2=81.3 //y2=1.095
cc_7087 ( N_noxref_18_c_9640_p N_noxref_21_c_11811_n ) capacitor c=0.00307978f \
 //x=81.035 //y=1.305 //x2=81.3 //y2=1.44
cc_7088 ( N_noxref_18_c_9696_p N_noxref_21_c_11811_n ) capacitor c=0.00363411f \
 //x=81.035 //y=1.76 //x2=81.3 //y2=1.44
cc_7089 ( N_noxref_18_c_9653_p N_noxref_21_c_11811_n ) capacitor c=0.00323576f \
 //x=81.435 //y=1.845 //x2=81.3 //y2=1.44
cc_7090 ( N_noxref_18_M50_noxref_d N_noxref_21_c_11811_n ) capacitor \
 c=0.00237422f //x=80.845 //y=1.095 //x2=81.3 //y2=1.44
cc_7091 ( N_noxref_18_c_9583_p N_noxref_21_c_11736_n ) capacitor c=5.50967e-19 \
 //x=81.52 //y=2.595 //x2=80.78 //y2=2.26
cc_7092 ( N_noxref_18_c_9696_p N_noxref_21_c_11738_n ) capacitor c=0.0036273f \
 //x=81.035 //y=1.76 //x2=80.78 //y2=2.095
cc_7093 ( N_noxref_18_c_9583_p N_noxref_21_c_11738_n ) capacitor c=0.00282067f \
 //x=81.52 //y=2.595 //x2=80.78 //y2=2.095
cc_7094 ( N_noxref_18_c_9552_n N_noxref_21_c_11739_n ) capacitor c=0.00739875f \
 //x=81.52 //y=5.25 //x2=80.78 //y2=4.88
cc_7095 ( N_noxref_18_c_9648_p N_noxref_21_c_11739_n ) capacitor c=0.00203307f \
 //x=80.74 //y=5.335 //x2=80.78 //y2=4.88
cc_7096 ( N_noxref_18_c_9651_p N_noxref_21_c_11739_n ) capacitor c=0.00375636f \
 //x=80.74 //y=5.56 //x2=80.78 //y2=4.88
cc_7097 ( N_noxref_18_c_9552_n N_noxref_22_c_12286_n ) capacitor c=0.0233585f \
 //x=81.52 //y=5.25 //x2=85.205 //y2=4.25
cc_7098 ( N_noxref_18_c_9553_n N_noxref_22_c_12286_n ) capacitor c=0.0247975f \
 //x=83.37 //y=4.755 //x2=85.205 //y2=4.25
cc_7099 ( N_noxref_18_c_9556_n N_VDD_c_13434_n ) capacitor c=0.00621363f \
 //x=79.74 //y=5.335 //x2=87.775 //y2=7.585
cc_7100 ( N_noxref_18_c_9568_n N_VDD_c_13434_n ) capacitor c=0.00627192f \
 //x=80.625 //y=5.335 //x2=87.775 //y2=7.585
cc_7101 ( N_noxref_18_c_9654_p N_VDD_c_13434_n ) capacitor c=0.00256036f \
 //x=80.74 //y=5.56 //x2=87.775 //y2=7.585
cc_7102 ( N_noxref_18_c_9551_n N_VDD_c_13434_n ) capacitor c=0.00824067f \
 //x=81.435 //y=5.335 //x2=87.775 //y2=7.585
cc_7103 ( N_noxref_18_c_9554_n N_VDD_c_13434_n ) capacitor c=0.00261804f \
 //x=78.982 //y=5.335 //x2=87.775 //y2=7.585
cc_7104 ( N_noxref_18_c_9555_n N_VDD_c_13434_n ) capacitor c=0.00270108f \
 //x=79.86 //y=5.335 //x2=87.775 //y2=7.585
cc_7105 ( N_noxref_18_c_9560_n N_VDD_c_13434_n ) capacitor c=0.0024232f \
 //x=78.98 //y=5.56 //x2=87.775 //y2=7.585
cc_7106 ( N_noxref_18_c_9576_n N_VDD_c_13434_n ) capacitor c=0.0024232f \
 //x=79.86 //y=5.56 //x2=87.775 //y2=7.585
cc_7107 ( N_noxref_18_c_9651_p N_VDD_c_13434_n ) capacitor c=0.0024232f \
 //x=80.74 //y=5.56 //x2=87.775 //y2=7.585
cc_7108 ( N_noxref_18_c_9556_n N_VDD_c_14352_n ) capacitor c=0.00202922f \
 //x=79.74 //y=5.335 //x2=79.335 //y2=7.585
cc_7109 ( N_noxref_18_c_9554_n N_VDD_c_14352_n ) capacitor c=9.3757e-19 \
 //x=78.982 //y=5.335 //x2=79.335 //y2=7.585
cc_7110 ( N_noxref_18_c_9560_n N_VDD_c_14352_n ) capacitor c=0.0138074f \
 //x=78.98 //y=5.56 //x2=79.335 //y2=7.585
cc_7111 ( N_noxref_18_c_9556_n N_VDD_c_14402_n ) capacitor c=0.0017708f \
 //x=79.74 //y=5.335 //x2=80.215 //y2=7.585
cc_7112 ( N_noxref_18_c_9568_n N_VDD_c_14402_n ) capacitor c=0.00202922f \
 //x=80.625 //y=5.335 //x2=80.215 //y2=7.585
cc_7113 ( N_noxref_18_c_9555_n N_VDD_c_14402_n ) capacitor c=9.4822e-19 \
 //x=79.86 //y=5.335 //x2=80.215 //y2=7.585
cc_7114 ( N_noxref_18_c_9576_n N_VDD_c_14402_n ) capacitor c=0.0138074f \
 //x=79.86 //y=5.56 //x2=80.215 //y2=7.585
cc_7115 ( N_noxref_18_c_9568_n N_VDD_c_14443_n ) capacitor c=0.00205906f \
 //x=80.625 //y=5.335 //x2=81.095 //y2=7.585
cc_7116 ( N_noxref_18_c_9654_p N_VDD_c_14443_n ) capacitor c=8.49654e-19 \
 //x=80.74 //y=5.56 //x2=81.095 //y2=7.585
cc_7117 ( N_noxref_18_c_9551_n N_VDD_c_14443_n ) capacitor c=0.00204238f \
 //x=81.435 //y=5.335 //x2=81.095 //y2=7.585
cc_7118 ( N_noxref_18_c_9651_p N_VDD_c_14443_n ) capacitor c=0.0138074f \
 //x=80.74 //y=5.56 //x2=81.095 //y2=7.585
cc_7119 ( N_noxref_18_c_9551_n N_VDD_c_14447_n ) capacitor c=0.00183742f \
 //x=81.435 //y=5.335 //x2=82.09 //y2=7.585
cc_7120 ( N_noxref_18_M163_noxref_g N_VDD_c_14448_n ) capacitor c=0.00755614f \
 //x=83.57 //y=6.2 //x2=84.145 //y2=7.585
cc_7121 ( N_noxref_18_M164_noxref_g N_VDD_c_14448_n ) capacitor c=0.00755544f \
 //x=84.01 //y=6.2 //x2=84.145 //y2=7.585
cc_7122 ( N_noxref_18_c_9554_n N_VDD_c_13786_n ) capacitor c=0.0022955f \
 //x=78.982 //y=5.335 //x2=77.45 //y2=7.585
cc_7123 ( N_noxref_18_c_9560_n N_VDD_c_13786_n ) capacitor c=0.00509469f \
 //x=78.98 //y=5.56 //x2=77.45 //y2=7.585
cc_7124 ( N_noxref_18_c_9654_p N_VDD_c_13787_n ) capacitor c=0.00282782f \
 //x=80.74 //y=5.56 //x2=82.26 //y2=7.585
cc_7125 ( N_noxref_18_c_9552_n N_VDD_c_13787_n ) capacitor c=0.0330847f \
 //x=81.52 //y=5.25 //x2=82.26 //y2=7.585
cc_7126 ( N_noxref_18_c_9553_n N_VDD_c_13787_n ) capacitor c=0.0119487f \
 //x=83.37 //y=4.755 //x2=82.26 //y2=7.585
cc_7127 ( N_noxref_18_c_9651_p N_VDD_c_13787_n ) capacitor c=0.00777981f \
 //x=80.74 //y=5.56 //x2=82.26 //y2=7.585
cc_7128 ( N_noxref_18_c_9593_p N_VDD_c_13787_n ) capacitor c=0.00370784f \
 //x=83.37 //y=4.88 //x2=82.26 //y2=7.585
cc_7129 ( N_noxref_18_c_9595_p N_VDD_c_13787_n ) capacitor c=0.00590568f \
 //x=83.645 //y=4.97 //x2=82.26 //y2=7.585
cc_7130 ( N_noxref_18_c_9554_n N_VDD_M157_noxref_s ) capacitor c=0.0442713f \
 //x=78.982 //y=5.335 //x2=78.405 //y2=5.2
cc_7131 ( N_noxref_18_c_9555_n N_VDD_M157_noxref_s ) capacitor c=7.80122e-19 \
 //x=79.86 //y=5.335 //x2=78.405 //y2=5.2
cc_7132 ( N_noxref_18_c_9560_n N_VDD_M157_noxref_s ) capacitor c=0.09305f \
 //x=78.98 //y=5.56 //x2=78.405 //y2=5.2
cc_7133 ( N_noxref_18_c_9556_n N_VDD_M158_noxref_d ) capacitor c=0.00700141f \
 //x=79.74 //y=5.335 //x2=79.275 //y2=5.2
cc_7134 ( N_noxref_18_c_9560_n N_VDD_M158_noxref_d ) capacitor c=0.0674491f \
 //x=78.98 //y=5.56 //x2=79.275 //y2=5.2
cc_7135 ( N_noxref_18_c_9576_n N_VDD_M158_noxref_d ) capacitor c=0.0674762f \
 //x=79.86 //y=5.56 //x2=79.275 //y2=5.2
cc_7136 ( N_noxref_18_c_9568_n N_VDD_M160_noxref_d ) capacitor c=0.00700141f \
 //x=80.625 //y=5.335 //x2=80.155 //y2=5.2
cc_7137 ( N_noxref_18_c_9576_n N_VDD_M160_noxref_d ) capacitor c=0.067493f \
 //x=79.86 //y=5.56 //x2=80.155 //y2=5.2
cc_7138 ( N_noxref_18_c_9651_p N_VDD_M160_noxref_d ) capacitor c=0.0674979f \
 //x=80.74 //y=5.56 //x2=80.155 //y2=5.2
cc_7139 ( N_noxref_18_c_9551_n N_VDD_M162_noxref_d ) capacitor c=0.00700141f \
 //x=81.435 //y=5.335 //x2=81.035 //y2=5.2
cc_7140 ( N_noxref_18_c_9651_p N_VDD_M162_noxref_d ) capacitor c=0.0675002f \
 //x=80.74 //y=5.56 //x2=81.035 //y2=5.2
cc_7141 ( N_noxref_18_c_9654_p N_VDD_M163_noxref_s ) capacitor c=0.00492616f \
 //x=80.74 //y=5.56 //x2=83.215 //y2=5.2
cc_7142 ( N_noxref_18_c_9551_n N_VDD_M163_noxref_s ) capacitor c=9.42705e-19 \
 //x=81.435 //y=5.335 //x2=83.215 //y2=5.2
cc_7143 ( N_noxref_18_c_9585_p N_VDD_M163_noxref_s ) capacitor c=4.30405e-19 \
 //x=83.37 //y=2.915 //x2=83.215 //y2=5.2
cc_7144 ( N_noxref_18_c_9553_n N_VDD_M163_noxref_s ) capacitor c=0.0217981f \
 //x=83.37 //y=4.755 //x2=83.215 //y2=5.2
cc_7145 ( N_noxref_18_c_9555_n N_VDD_M163_noxref_s ) capacitor c=2.11884e-19 \
 //x=79.86 //y=5.335 //x2=83.215 //y2=5.2
cc_7146 ( N_noxref_18_c_9593_p N_VDD_M163_noxref_s ) capacitor c=0.00983846f \
 //x=83.37 //y=4.88 //x2=83.215 //y2=5.2
cc_7147 ( N_noxref_18_M163_noxref_g N_VDD_M163_noxref_s ) capacitor \
 c=0.053419f //x=83.57 //y=6.2 //x2=83.215 //y2=5.2
cc_7148 ( N_noxref_18_c_9595_p N_VDD_M163_noxref_s ) capacitor c=0.00608955f \
 //x=83.645 //y=4.97 //x2=83.215 //y2=5.2
cc_7149 ( N_noxref_18_M164_noxref_g N_VDD_M164_noxref_d ) capacitor \
 c=0.015318f //x=84.01 //y=6.2 //x2=84.085 //y2=5.2
cc_7150 ( N_noxref_18_c_9640_p N_noxref_42_c_15978_n ) capacitor c=0.0036878f \
 //x=81.035 //y=1.305 //x2=81.435 //y2=0.72
cc_7151 ( N_noxref_18_c_9653_p N_noxref_42_c_15978_n ) capacitor c=0.00399931f \
 //x=81.435 //y=1.845 //x2=81.435 //y2=0.72
cc_7152 ( N_noxref_18_M50_noxref_d N_noxref_42_c_15978_n ) capacitor \
 c=0.00949319f //x=80.845 //y=1.095 //x2=81.435 //y2=0.72
cc_7153 ( N_noxref_18_M50_noxref_d N_noxref_42_c_15981_n ) capacitor \
 c=0.00120711f //x=80.845 //y=1.095 //x2=80.55 //y2=1.175
cc_7154 ( N_noxref_18_c_9556_n N_noxref_42_M49_noxref_d ) capacitor \
 c=0.00127654f //x=79.74 //y=5.335 //x2=79.31 //y2=1.09
cc_7155 ( N_noxref_18_c_9640_p N_noxref_42_M49_noxref_d ) capacitor \
 c=0.00802417f //x=81.035 //y=1.305 //x2=79.31 //y2=1.09
cc_7156 ( N_noxref_18_c_9640_p N_noxref_42_M50_noxref_s ) capacitor \
 c=0.0098487f //x=81.035 //y=1.305 //x2=80.415 //y2=0.555
cc_7157 ( N_noxref_18_c_9696_p N_noxref_42_M50_noxref_s ) capacitor \
 c=0.0283243f //x=81.035 //y=1.76 //x2=80.415 //y2=0.555
cc_7158 ( N_noxref_18_c_9653_p N_noxref_42_M50_noxref_s ) capacitor \
 c=0.00752108f //x=81.435 //y=1.845 //x2=80.415 //y2=0.555
cc_7159 ( N_noxref_18_c_9649_p N_noxref_42_M50_noxref_s ) capacitor \
 c=0.00309975f //x=81.52 //y=2.77 //x2=80.415 //y2=0.555
cc_7160 ( N_noxref_18_M50_noxref_d N_noxref_42_M50_noxref_s ) capacitor \
 c=0.0279003f //x=80.845 //y=1.095 //x2=80.415 //y2=0.555
cc_7161 ( N_noxref_18_c_9640_p N_noxref_43_M52_noxref_d ) capacitor \
 c=3.20746e-19 //x=81.035 //y=1.305 //x2=84.12 //y2=1.09
cc_7162 ( N_noxref_18_c_9640_p N_GND_c_17141_n ) capacitor c=0.0087847f \
 //x=81.035 //y=1.305 //x2=83.25 //y2=0.175
cc_7163 ( N_noxref_18_c_9653_p N_GND_c_17141_n ) capacitor c=0.0066211f \
 //x=81.435 //y=1.845 //x2=83.25 //y2=0.175
cc_7164 ( N_noxref_18_c_9597_p N_GND_c_17141_n ) capacitor c=4.31893e-19 \
 //x=81.52 //y=2.915 //x2=83.25 //y2=0.175
cc_7165 ( N_noxref_18_M50_noxref_d N_GND_c_17141_n ) capacitor c=2.9462e-19 \
 //x=80.845 //y=1.095 //x2=83.25 //y2=0.175
cc_7166 ( N_noxref_18_c_9615_p N_GND_c_17197_n ) capacitor c=3.97665e-19 \
 //x=83.07 //y=1.055 //x2=83.335 //y2=1.015
cc_7167 ( N_noxref_18_c_9787_p N_GND_c_17197_n ) capacitor c=0.00864776f \
 //x=83.445 //y=0.9 //x2=83.335 //y2=1.015
cc_7168 ( N_noxref_18_c_9617_p N_GND_c_17197_n ) capacitor c=4.45447e-19 \
 //x=83.6 //y=1.055 //x2=83.335 //y2=1.015
cc_7169 ( N_noxref_18_c_9640_p N_GND_c_17200_n ) capacitor c=0.00543195f \
 //x=81.035 //y=1.305 //x2=83.335 //y2=1.145
cc_7170 ( N_noxref_18_c_9580_p N_GND_c_17200_n ) capacitor c=0.00769783f \
 //x=83.37 //y=2.375 //x2=83.335 //y2=1.145
cc_7171 ( N_noxref_18_c_9585_p N_GND_c_17200_n ) capacitor c=0.00121612f \
 //x=83.37 //y=2.915 //x2=83.335 //y2=1.145
cc_7172 ( N_noxref_18_c_9581_p N_GND_c_17200_n ) capacitor c=2.22883e-19 \
 //x=83.37 //y=2.26 //x2=83.335 //y2=1.145
cc_7173 ( N_noxref_18_c_9615_p N_GND_c_17200_n ) capacitor c=0.00156339f \
 //x=83.07 //y=1.055 //x2=83.335 //y2=1.145
cc_7174 ( N_noxref_18_c_9616_p N_GND_c_17200_n ) capacitor c=0.00352472f \
 //x=83.07 //y=1.4 //x2=83.335 //y2=1.145
cc_7175 ( N_noxref_18_c_9618_p N_GND_c_17200_n ) capacitor c=3.83057e-19 \
 //x=83.07 //y=1.71 //x2=83.335 //y2=1.145
cc_7176 ( N_noxref_18_c_9787_p N_GND_c_17200_n ) capacitor c=9.36995e-19 \
 //x=83.445 //y=0.9 //x2=83.335 //y2=1.145
cc_7177 ( N_noxref_18_c_9797_p N_GND_c_17200_n ) capacitor c=5.2644e-19 \
 //x=83.445 //y=1.555 //x2=83.335 //y2=1.145
cc_7178 ( N_noxref_18_c_9617_p N_GND_c_17200_n ) capacitor c=0.0017438f \
 //x=83.6 //y=1.055 //x2=83.335 //y2=1.145
cc_7179 ( N_noxref_18_c_9619_p N_GND_c_17200_n ) capacitor c=0.00276804f \
 //x=83.6 //y=1.4 //x2=83.335 //y2=1.145
cc_7180 ( N_noxref_18_c_9653_p N_GND_c_17087_n ) capacitor c=6.86343e-19 \
 //x=81.435 //y=1.845 //x2=82.09 //y2=0.175
cc_7181 ( N_noxref_18_c_9597_p N_GND_c_17087_n ) capacitor c=6.05031e-19 \
 //x=81.52 //y=2.915 //x2=82.09 //y2=0.175
cc_7182 ( N_noxref_18_c_9615_p N_GND_c_17213_n ) capacitor c=0.00677766f \
 //x=83.07 //y=1.055 //x2=86.9 //y2=0.175
cc_7183 ( N_noxref_18_c_9696_p N_GND_c_17214_n ) capacitor c=0.0045138f \
 //x=81.035 //y=1.76 //x2=82.26 //y2=0.175
cc_7184 ( N_noxref_18_c_9653_p N_GND_c_17214_n ) capacitor c=0.0225712f \
 //x=81.435 //y=1.845 //x2=82.26 //y2=0.175
cc_7185 ( N_noxref_18_c_9597_p N_GND_c_17214_n ) capacitor c=0.00460181f \
 //x=81.52 //y=2.915 //x2=82.26 //y2=0.175
cc_7186 ( N_noxref_18_c_9580_p N_GND_c_17214_n ) capacitor c=0.00343637f \
 //x=83.37 //y=2.375 //x2=82.26 //y2=0.175
cc_7187 ( N_noxref_18_c_9584_p N_GND_c_17214_n ) capacitor c=0.0034323f \
 //x=83.37 //y=2.595 //x2=82.26 //y2=0.175
cc_7188 ( N_noxref_18_c_9585_p N_GND_c_17214_n ) capacitor c=0.00331872f \
 //x=83.37 //y=2.915 //x2=82.26 //y2=0.175
cc_7189 ( N_noxref_18_c_9649_p N_GND_c_17214_n ) capacitor c=0.0104186f \
 //x=81.52 //y=2.77 //x2=82.26 //y2=0.175
cc_7190 ( N_noxref_18_c_9587_p N_GND_c_17214_n ) capacitor c=0.0052814f \
 //x=83.37 //y=2.77 //x2=82.26 //y2=0.175
cc_7191 ( N_noxref_18_c_9603_p N_GND_c_17214_n ) capacitor c=0.00947774f \
 //x=83.205 //y=2.755 //x2=82.26 //y2=0.175
cc_7192 ( N_noxref_18_c_9581_p N_GND_c_17214_n ) capacitor c=0.0039621f \
 //x=83.37 //y=2.26 //x2=82.26 //y2=0.175
cc_7193 ( N_noxref_18_c_9618_p N_GND_c_17214_n ) capacitor c=0.00170145f \
 //x=83.07 //y=1.71 //x2=82.26 //y2=0.175
cc_7194 ( N_noxref_18_c_9582_p N_GND_c_17214_n ) capacitor c=0.0102191f \
 //x=83.07 //y=2.095 //x2=82.26 //y2=0.175
cc_7195 ( N_noxref_18_c_9580_p N_GND_M51_noxref_d ) capacitor c=4.4417e-19 \
 //x=83.37 //y=2.375 //x2=83.145 //y2=1.055
cc_7196 ( N_noxref_18_c_9615_p N_GND_M51_noxref_d ) capacitor c=0.00184354f \
 //x=83.07 //y=1.055 //x2=83.145 //y2=1.055
cc_7197 ( N_noxref_18_c_9616_p N_GND_M51_noxref_d ) capacitor c=0.00210798f \
 //x=83.07 //y=1.4 //x2=83.145 //y2=1.055
cc_7198 ( N_noxref_18_c_9787_p N_GND_M51_noxref_d ) capacitor c=0.00474029f \
 //x=83.445 //y=0.9 //x2=83.145 //y2=1.055
cc_7199 ( N_noxref_18_c_9797_p N_GND_M51_noxref_d ) capacitor c=0.00166857f \
 //x=83.445 //y=1.555 //x2=83.145 //y2=1.055
cc_7200 ( N_noxref_18_c_9617_p N_GND_M51_noxref_d ) capacitor c=0.00230174f \
 //x=83.6 //y=1.055 //x2=83.145 //y2=1.055
cc_7201 ( N_noxref_18_c_9619_p N_GND_M51_noxref_d ) capacitor c=0.00210798f \
 //x=83.6 //y=1.4 //x2=83.145 //y2=1.055
cc_7202 ( N_noxref_18_c_9582_p N_noxref_64_c_19116_n ) capacitor c=0.00262672f \
 //x=83.07 //y=2.095 //x2=82.85 //y2=1.685
cc_7203 ( N_noxref_18_c_9580_p N_noxref_64_c_19117_n ) capacitor c=0.00428451f \
 //x=83.37 //y=2.375 //x2=83.735 //y2=1.77
cc_7204 ( N_noxref_18_c_9585_p N_noxref_64_c_19117_n ) capacitor c=0.00443247f \
 //x=83.37 //y=2.915 //x2=83.735 //y2=1.77
cc_7205 ( N_noxref_18_c_9581_p N_noxref_64_c_19117_n ) capacitor c=0.0104666f \
 //x=83.37 //y=2.26 //x2=83.735 //y2=1.77
cc_7206 ( N_noxref_18_c_9618_p N_noxref_64_c_19117_n ) capacitor c=0.00705077f \
 //x=83.07 //y=1.71 //x2=83.735 //y2=1.77
cc_7207 ( N_noxref_18_c_9582_p N_noxref_64_c_19117_n ) capacitor c=0.0197755f \
 //x=83.07 //y=2.095 //x2=83.735 //y2=1.77
cc_7208 ( N_noxref_18_c_9797_p N_noxref_64_c_19117_n ) capacitor c=0.00560218f \
 //x=83.445 //y=1.555 //x2=83.735 //y2=1.77
cc_7209 ( N_noxref_18_c_9619_p N_noxref_64_c_19117_n ) capacitor c=0.00698822f \
 //x=83.6 //y=1.4 //x2=83.735 //y2=1.77
cc_7210 ( N_noxref_18_c_9615_p N_noxref_64_M51_noxref_s ) capacitor \
 c=0.0295256f //x=83.07 //y=1.055 //x2=82.715 //y2=0.555
cc_7211 ( N_noxref_18_c_9618_p N_noxref_64_M51_noxref_s ) capacitor \
 c=7.99997e-19 //x=83.07 //y=1.71 //x2=82.715 //y2=0.555
cc_7212 ( N_noxref_18_c_9582_p N_noxref_64_M51_noxref_s ) capacitor \
 c=0.00122123f //x=83.07 //y=2.095 //x2=82.715 //y2=0.555
cc_7213 ( N_noxref_18_c_9617_p N_noxref_64_M51_noxref_s ) capacitor \
 c=0.0125924f //x=83.6 //y=1.055 //x2=82.715 //y2=0.555
cc_7214 ( N_SN_c_10417_n N_noxref_20_c_11071_n ) capacitor c=0.0230421f \
 //x=66.705 //y=3.14 //x2=66.35 //y2=3.735
cc_7215 ( N_SN_c_10394_n N_noxref_20_c_11082_n ) capacitor c=0.00934497f \
 //x=70.05 //y=2.375 //x2=71.16 //y2=2.375
cc_7216 ( N_SN_c_10427_n N_noxref_20_c_11082_n ) capacitor c=5.39999e-19 \
 //x=70.05 //y=2.26 //x2=71.16 //y2=2.375
cc_7217 ( N_SN_c_10446_n N_noxref_20_c_11082_n ) capacitor c=0.00137098f \
 //x=70.14 //y=2.095 //x2=71.16 //y2=2.375
cc_7218 ( SN N_noxref_20_c_11078_n ) capacitor c=0.0141637f //x=70.05 //y=2.77 \
 //x2=71.16 //y2=3.735
cc_7219 ( SN N_noxref_20_c_11078_n ) capacitor c=5.01652e-19 //x=70.05 \
 //y=3.14 //x2=71.16 //y2=3.735
cc_7220 ( N_SN_c_10397_n N_noxref_20_c_11078_n ) capacitor c=0.00786461f \
 //x=70.05 //y=3.285 //x2=71.16 //y2=3.735
cc_7221 ( N_SN_c_10070_n N_noxref_20_c_11078_n ) capacitor c=0.0110327f \
 //x=70.05 //y=4.765 //x2=71.16 //y2=3.735
cc_7222 ( N_SN_c_10426_n N_noxref_20_c_11078_n ) capacitor c=0.0266386f \
 //x=71.77 //y=3.155 //x2=71.16 //y2=3.735
cc_7223 ( N_SN_c_10427_n N_noxref_20_c_11078_n ) capacitor c=3.9149e-19 \
 //x=70.05 //y=2.26 //x2=71.16 //y2=3.735
cc_7224 ( N_SN_c_10070_n N_noxref_20_c_11090_n ) capacitor c=0.0078001f \
 //x=70.05 //y=4.765 //x2=71.16 //y2=4.055
cc_7225 ( N_SN_c_10070_n N_noxref_20_c_11044_n ) capacitor c=0.0224005f \
 //x=70.05 //y=4.765 //x2=71.16 //y2=4.75
cc_7226 ( N_SN_c_10085_n N_noxref_20_c_11044_n ) capacitor c=9.36945e-19 \
 //x=70.05 //y=4.88 //x2=71.16 //y2=4.75
cc_7227 ( N_SN_c_10449_n N_noxref_20_c_11044_n ) capacitor c=8.42568e-19 \
 //x=70.05 //y=4.88 //x2=71.16 //y2=4.75
cc_7228 ( N_SN_c_10502_n N_noxref_20_c_11164_n ) capacitor c=0.0262127f \
 //x=78.17 //y=3.14 //x2=76.71 //y2=3.735
cc_7229 ( N_SN_c_10624_n N_noxref_20_c_11367_n ) capacitor c=0.00914397f \
 //x=84.48 //y=2.375 //x2=85.59 //y2=2.375
cc_7230 ( N_SN_c_10648_n N_noxref_20_c_11367_n ) capacitor c=5.39999e-19 \
 //x=84.48 //y=2.26 //x2=85.59 //y2=2.375
cc_7231 ( N_SN_c_10667_n N_noxref_20_c_11367_n ) capacitor c=0.00137098f \
 //x=84.57 //y=2.095 //x2=85.59 //y2=2.375
cc_7232 ( N_SN_c_10627_n N_noxref_20_c_11054_n ) capacitor c=0.015f //x=84.48 \
 //y=2.985 //x2=85.59 //y2=3.725
cc_7233 ( N_SN_c_10634_n N_noxref_20_c_11054_n ) capacitor c=0.00775314f \
 //x=84.48 //y=3.305 //x2=85.59 //y2=3.725
cc_7234 ( N_SN_c_10071_n N_noxref_20_c_11054_n ) capacitor c=0.0138441f \
 //x=84.48 //y=4.765 //x2=85.59 //y2=3.725
cc_7235 ( N_SN_c_10640_n N_noxref_20_c_11054_n ) capacitor c=3.43503e-19 \
 //x=84.48 //y=3.14 //x2=85.59 //y2=3.725
cc_7236 ( N_SN_c_10530_n N_noxref_20_c_11054_n ) capacitor c=0.00508119f \
 //x=78.77 //y=3.125 //x2=85.59 //y2=3.725
cc_7237 ( N_SN_c_10648_n N_noxref_20_c_11054_n ) capacitor c=3.9149e-19 \
 //x=84.48 //y=2.26 //x2=85.59 //y2=3.725
cc_7238 ( N_SN_c_10071_n N_noxref_20_c_11376_n ) capacitor c=0.00772613f \
 //x=84.48 //y=4.765 //x2=85.59 //y2=4.045
cc_7239 ( N_SN_c_10071_n N_noxref_20_c_11055_n ) capacitor c=0.0261007f \
 //x=84.48 //y=4.765 //x2=85.59 //y2=4.75
cc_7240 ( N_SN_c_10652_n N_noxref_20_c_11055_n ) capacitor c=9.52396e-19 \
 //x=84.48 //y=4.88 //x2=85.59 //y2=4.75
cc_7241 ( N_SN_c_10670_n N_noxref_20_c_11055_n ) capacitor c=8.42568e-19 \
 //x=84.48 //y=4.88 //x2=85.59 //y2=4.75
cc_7242 ( N_SN_c_10070_n N_noxref_20_c_11100_n ) capacitor c=5.01652e-19 \
 //x=70.05 //y=4.765 //x2=71.16 //y2=3.88
cc_7243 ( N_SN_c_10071_n N_noxref_20_c_11381_n ) capacitor c=3.43503e-19 \
 //x=84.48 //y=4.765 //x2=85.59 //y2=3.88
cc_7244 ( N_SN_c_10461_n N_noxref_20_c_11060_n ) capacitor c=0.00888265f \
 //x=72.115 //y=3.155 //x2=76.54 //y2=3.88
cc_7245 ( N_SN_c_10426_n N_noxref_20_c_11060_n ) capacitor c=0.0066776f \
 //x=71.77 //y=3.155 //x2=76.54 //y2=3.88
cc_7246 ( N_SN_c_10467_n N_noxref_20_c_11060_n ) capacitor c=0.00356173f \
 //x=73.375 //y=3.14 //x2=76.54 //y2=3.88
cc_7247 ( N_SN_c_10471_n N_noxref_20_c_11060_n ) capacitor c=0.0211848f \
 //x=73.975 //y=3.155 //x2=76.54 //y2=3.88
cc_7248 ( N_SN_c_10634_n N_noxref_20_c_11063_n ) capacitor c=0.00337062f \
 //x=84.48 //y=3.305 //x2=78.77 //y2=3.895
cc_7249 ( N_SN_c_10071_n N_noxref_20_c_11063_n ) capacitor c=0.0275224f \
 //x=84.48 //y=4.765 //x2=78.77 //y2=3.895
cc_7250 ( N_SN_c_10530_n N_noxref_20_c_11063_n ) capacitor c=0.25433f \
 //x=78.77 //y=3.125 //x2=78.77 //y2=3.895
cc_7251 ( N_SN_c_10502_n N_noxref_20_c_11064_n ) capacitor c=0.0138642f \
 //x=78.17 //y=3.14 //x2=78.425 //y2=3.895
cc_7252 ( N_SN_c_10070_n N_noxref_20_c_11081_n ) capacitor c=0.0229186f \
 //x=70.05 //y=4.765 //x2=71 //y2=3.895
cc_7253 ( N_SN_c_10417_n N_noxref_20_c_11081_n ) capacitor c=0.0063321f \
 //x=66.705 //y=3.14 //x2=71 //y2=3.895
cc_7254 ( N_SN_c_10418_n N_noxref_20_c_11081_n ) capacitor c=0.00880561f \
 //x=67.305 //y=3.11 //x2=71 //y2=3.895
cc_7255 ( N_SN_c_10420_n N_noxref_20_c_11081_n ) capacitor c=0.00359897f \
 //x=68.555 //y=3.14 //x2=71 //y2=3.895
cc_7256 ( N_SN_c_10426_n N_noxref_20_c_11081_n ) capacitor c=0.0127497f \
 //x=71.77 //y=3.155 //x2=71 //y2=3.895
cc_7257 ( N_SN_c_10070_n N_noxref_20_c_11108_n ) capacitor c=0.0024779f \
 //x=70.05 //y=4.765 //x2=71.32 //y2=3.895
cc_7258 ( SN N_noxref_20_c_11109_n ) capacitor c=3.9149e-19 //x=70.05 //y=2.77 \
 //x2=71.16 //y2=2.26
cc_7259 ( N_SN_c_10394_n N_noxref_20_c_11109_n ) capacitor c=5.42289e-19 \
 //x=70.05 //y=2.375 //x2=71.16 //y2=2.26
cc_7260 ( N_SN_c_10427_n N_noxref_20_c_11109_n ) capacitor c=0.00125213f \
 //x=70.05 //y=2.26 //x2=71.16 //y2=2.26
cc_7261 ( N_SN_c_10446_n N_noxref_20_c_11109_n ) capacitor c=0.00209664f \
 //x=70.14 //y=2.095 //x2=71.16 //y2=2.26
cc_7262 ( N_SN_c_10070_n N_noxref_20_c_11110_n ) capacitor c=7.3565e-19 \
 //x=70.05 //y=4.765 //x2=71.16 //y2=4.88
cc_7263 ( N_SN_c_10085_n N_noxref_20_c_11110_n ) capacitor c=0.00113985f \
 //x=70.05 //y=4.88 //x2=71.16 //y2=4.88
cc_7264 ( N_SN_c_10449_n N_noxref_20_c_11110_n ) capacitor c=0.00129812f \
 //x=70.05 //y=4.88 //x2=71.16 //y2=4.88
cc_7265 ( N_SN_c_10624_n N_noxref_20_c_11403_n ) capacitor c=5.42289e-19 \
 //x=84.48 //y=2.375 //x2=85.59 //y2=2.26
cc_7266 ( N_SN_c_10627_n N_noxref_20_c_11403_n ) capacitor c=3.9149e-19 \
 //x=84.48 //y=2.985 //x2=85.59 //y2=2.26
cc_7267 ( N_SN_c_10648_n N_noxref_20_c_11403_n ) capacitor c=0.00125213f \
 //x=84.48 //y=2.26 //x2=85.59 //y2=2.26
cc_7268 ( N_SN_c_10667_n N_noxref_20_c_11403_n ) capacitor c=0.00209664f \
 //x=84.57 //y=2.095 //x2=85.59 //y2=2.26
cc_7269 ( N_SN_c_10071_n N_noxref_20_c_11407_n ) capacitor c=7.51101e-19 \
 //x=84.48 //y=4.765 //x2=85.59 //y2=4.88
cc_7270 ( N_SN_c_10652_n N_noxref_20_c_11407_n ) capacitor c=0.00113985f \
 //x=84.48 //y=4.88 //x2=85.59 //y2=4.88
cc_7271 ( N_SN_c_10670_n N_noxref_20_c_11407_n ) capacitor c=0.00129812f \
 //x=84.48 //y=4.88 //x2=85.59 //y2=4.88
cc_7272 ( N_SN_M147_noxref_g N_noxref_20_M149_noxref_g ) capacitor \
 c=0.0101598f //x=70.02 //y=6.2 //x2=70.9 //y2=6.2
cc_7273 ( N_SN_M148_noxref_g N_noxref_20_M149_noxref_g ) capacitor \
 c=0.0607518f //x=70.46 //y=6.2 //x2=70.9 //y2=6.2
cc_7274 ( N_SN_M148_noxref_g N_noxref_20_M150_noxref_g ) capacitor \
 c=0.0101598f //x=70.46 //y=6.2 //x2=71.34 //y2=6.2
cc_7275 ( N_SN_M165_noxref_g N_noxref_20_M167_noxref_g ) capacitor \
 c=0.0101598f //x=84.45 //y=6.2 //x2=85.33 //y2=6.2
cc_7276 ( N_SN_M166_noxref_g N_noxref_20_M167_noxref_g ) capacitor \
 c=0.0607518f //x=84.89 //y=6.2 //x2=85.33 //y2=6.2
cc_7277 ( N_SN_M166_noxref_g N_noxref_20_M168_noxref_g ) capacitor \
 c=0.0101598f //x=84.89 //y=6.2 //x2=85.77 //y2=6.2
cc_7278 ( N_SN_c_10443_n N_noxref_20_c_11123_n ) capacitor c=0.00456962f \
 //x=70.14 //y=1.09 //x2=71.15 //y2=1.095
cc_7279 ( N_SN_c_10444_n N_noxref_20_c_11125_n ) capacitor c=0.00438372f \
 //x=70.14 //y=1.4 //x2=71.15 //y2=1.44
cc_7280 ( N_SN_c_10445_n N_noxref_20_c_11128_n ) capacitor c=0.00438372f \
 //x=70.14 //y=1.63 //x2=71.15 //y2=1.75
cc_7281 ( N_SN_c_10664_n N_noxref_20_c_11419_n ) capacitor c=0.00456962f \
 //x=84.57 //y=1.09 //x2=85.58 //y2=1.095
cc_7282 ( N_SN_c_10665_n N_noxref_20_c_11420_n ) capacitor c=0.00438372f \
 //x=84.57 //y=1.4 //x2=85.58 //y2=1.44
cc_7283 ( N_SN_c_10666_n N_noxref_20_c_11421_n ) capacitor c=0.00438372f \
 //x=84.57 //y=1.63 //x2=85.58 //y2=1.75
cc_7284 ( N_SN_c_10394_n N_noxref_20_c_11141_n ) capacitor c=0.00134951f \
 //x=70.05 //y=2.375 //x2=71.16 //y2=2.26
cc_7285 ( N_SN_c_10427_n N_noxref_20_c_11141_n ) capacitor c=0.00204868f \
 //x=70.05 //y=2.26 //x2=71.16 //y2=2.26
cc_7286 ( N_SN_c_10446_n N_noxref_20_c_11141_n ) capacitor c=0.00933826f \
 //x=70.14 //y=2.095 //x2=71.16 //y2=2.26
cc_7287 ( N_SN_c_10446_n N_noxref_20_c_11142_n ) capacitor c=0.00438372f \
 //x=70.14 //y=2.095 //x2=71.16 //y2=2.095
cc_7288 ( N_SN_c_10070_n N_noxref_20_c_11070_n ) capacitor c=0.00118533f \
 //x=70.05 //y=4.765 //x2=71.16 //y2=4.88
cc_7289 ( N_SN_c_10085_n N_noxref_20_c_11070_n ) capacitor c=0.00187046f \
 //x=70.05 //y=4.88 //x2=71.16 //y2=4.88
cc_7290 ( N_SN_c_10102_n N_noxref_20_c_11070_n ) capacitor c=0.0616777f \
 //x=70.385 //y=4.97 //x2=71.16 //y2=4.88
cc_7291 ( N_SN_c_10449_n N_noxref_20_c_11070_n ) capacitor c=0.00487508f \
 //x=70.05 //y=4.88 //x2=71.16 //y2=4.88
cc_7292 ( N_SN_c_10624_n N_noxref_20_c_11430_n ) capacitor c=0.00134951f \
 //x=84.48 //y=2.375 //x2=85.59 //y2=2.26
cc_7293 ( N_SN_c_10648_n N_noxref_20_c_11430_n ) capacitor c=0.00204868f \
 //x=84.48 //y=2.26 //x2=85.59 //y2=2.26
cc_7294 ( N_SN_c_10667_n N_noxref_20_c_11430_n ) capacitor c=0.00933826f \
 //x=84.57 //y=2.095 //x2=85.59 //y2=2.26
cc_7295 ( N_SN_c_10667_n N_noxref_20_c_11433_n ) capacitor c=0.00438372f \
 //x=84.57 //y=2.095 //x2=85.59 //y2=2.095
cc_7296 ( N_SN_c_10071_n N_noxref_20_c_11434_n ) capacitor c=0.00124604f \
 //x=84.48 //y=4.765 //x2=85.59 //y2=4.88
cc_7297 ( N_SN_c_10652_n N_noxref_20_c_11434_n ) capacitor c=0.00187046f \
 //x=84.48 //y=4.88 //x2=85.59 //y2=4.88
cc_7298 ( N_SN_c_10758_p N_noxref_20_c_11434_n ) capacitor c=0.0616777f \
 //x=84.815 //y=4.97 //x2=85.59 //y2=4.88
cc_7299 ( N_SN_c_10670_n N_noxref_20_c_11434_n ) capacitor c=0.00487508f \
 //x=84.48 //y=4.88 //x2=85.59 //y2=4.88
cc_7300 ( N_SN_c_10530_n N_noxref_21_c_11711_n ) capacitor c=0.00208927f \
 //x=78.77 //y=3.125 //x2=80.78 //y2=2.485
cc_7301 ( N_SN_c_10530_n N_noxref_21_c_11652_n ) capacitor c=0.0273879f \
 //x=78.77 //y=3.125 //x2=80.78 //y2=4.75
cc_7302 ( N_SN_c_10634_n N_noxref_21_c_11756_n ) capacitor c=0.00128396f \
 //x=84.48 //y=3.305 //x2=84.55 //y2=5.335
cc_7303 ( N_SN_c_10071_n N_noxref_21_c_11756_n ) capacitor c=0.0213631f \
 //x=84.48 //y=4.765 //x2=84.55 //y2=5.335
cc_7304 ( N_SN_c_10652_n N_noxref_21_c_11756_n ) capacitor c=0.00492634f \
 //x=84.48 //y=4.88 //x2=84.55 //y2=5.335
cc_7305 ( N_SN_M165_noxref_g N_noxref_21_c_11756_n ) capacitor c=0.00858241f \
 //x=84.45 //y=6.2 //x2=84.55 //y2=5.335
cc_7306 ( N_SN_c_10670_n N_noxref_21_c_11756_n ) capacitor c=5.8675e-19 \
 //x=84.48 //y=4.88 //x2=84.55 //y2=5.335
cc_7307 ( N_SN_M166_noxref_g N_noxref_21_c_11828_n ) capacitor c=0.00955829f \
 //x=84.89 //y=6.2 //x2=85.435 //y2=5.335
cc_7308 ( N_SN_c_10627_n N_noxref_21_c_11657_n ) capacitor c=0.00152933f \
 //x=84.48 //y=2.985 //x2=86.33 //y2=5.25
cc_7309 ( N_SN_c_10071_n N_noxref_21_c_11657_n ) capacitor c=0.00238986f \
 //x=84.48 //y=4.765 //x2=86.33 //y2=5.25
cc_7310 ( N_SN_c_10634_n N_noxref_21_c_11671_n ) capacitor c=5.49982e-19 \
 //x=84.48 //y=3.305 //x2=84.67 //y2=5.335
cc_7311 ( N_SN_c_10071_n N_noxref_21_c_11671_n ) capacitor c=0.00239361f \
 //x=84.48 //y=4.765 //x2=84.67 //y2=5.335
cc_7312 ( N_SN_c_10652_n N_noxref_21_c_11671_n ) capacitor c=0.00132214f \
 //x=84.48 //y=4.88 //x2=84.67 //y2=5.335
cc_7313 ( N_SN_M165_noxref_g N_noxref_21_c_11671_n ) capacitor c=0.00229818f \
 //x=84.45 //y=6.2 //x2=84.67 //y2=5.335
cc_7314 ( N_SN_M166_noxref_g N_noxref_21_c_11671_n ) capacitor c=0.00230699f \
 //x=84.89 //y=6.2 //x2=84.67 //y2=5.335
cc_7315 ( N_SN_c_10758_p N_noxref_21_c_11671_n ) capacitor c=0.00177491f \
 //x=84.815 //y=4.97 //x2=84.67 //y2=5.335
cc_7316 ( N_SN_c_10530_n N_noxref_21_c_11763_n ) capacitor c=0.00888156f \
 //x=78.77 //y=3.125 //x2=81.135 //y2=2.4
cc_7317 ( N_SN_c_10530_n N_noxref_21_c_11767_n ) capacitor c=0.0069591f \
 //x=78.77 //y=3.125 //x2=81.735 //y2=2.37
cc_7318 ( N_SN_c_10530_n N_noxref_21_c_11771_n ) capacitor c=0.00890166f \
 //x=78.77 //y=3.125 //x2=82.98 //y2=2.4
cc_7319 ( N_SN_c_10624_n N_noxref_21_c_11681_n ) capacitor c=0.0171335f \
 //x=84.48 //y=2.375 //x2=86.485 //y2=2.4
cc_7320 ( N_SN_c_10627_n N_noxref_21_c_11681_n ) capacitor c=0.0160172f \
 //x=84.48 //y=2.985 //x2=86.485 //y2=2.4
cc_7321 ( N_SN_c_10634_n N_noxref_21_c_11681_n ) capacitor c=0.00322027f \
 //x=84.48 //y=3.305 //x2=86.485 //y2=2.4
cc_7322 ( N_SN_c_10530_n N_noxref_21_c_11681_n ) capacitor c=0.0459145f \
 //x=78.77 //y=3.125 //x2=86.485 //y2=2.4
cc_7323 ( N_SN_c_10648_n N_noxref_21_c_11681_n ) capacitor c=5.2767e-19 \
 //x=84.48 //y=2.26 //x2=86.485 //y2=2.4
cc_7324 ( N_SN_c_10667_n N_noxref_21_c_11681_n ) capacitor c=4.03361e-19 \
 //x=84.57 //y=2.095 //x2=86.485 //y2=2.4
cc_7325 ( N_SN_c_10530_n N_noxref_21_c_11721_n ) capacitor c=0.027847f \
 //x=78.77 //y=3.125 //x2=80.77 //y2=2.325
cc_7326 ( N_SN_c_10071_n N_noxref_21_c_11847_n ) capacitor c=6.21282e-19 \
 //x=84.48 //y=4.765 //x2=84.67 //y2=5.56
cc_7327 ( N_SN_M165_noxref_g N_noxref_21_c_11847_n ) capacitor c=0.0179041f \
 //x=84.45 //y=6.2 //x2=84.67 //y2=5.56
cc_7328 ( N_SN_M166_noxref_g N_noxref_21_c_11847_n ) capacitor c=0.0179041f \
 //x=84.89 //y=6.2 //x2=84.67 //y2=5.56
cc_7329 ( N_SN_c_10758_p N_noxref_21_c_11847_n ) capacitor c=0.00290085f \
 //x=84.815 //y=4.97 //x2=84.67 //y2=5.56
cc_7330 ( N_SN_c_10790_p N_noxref_22_c_12331_n ) capacitor c=0.0262929f \
 //x=52.12 //y=3.125 //x2=51.92 //y2=3.365
cc_7331 ( N_SN_c_10790_p N_noxref_22_c_12343_n ) capacitor c=0.00612634f \
 //x=52.12 //y=3.125 //x2=51.92 //y2=3.655
cc_7332 ( N_SN_c_10242_n N_noxref_22_c_12353_n ) capacitor c=0.00121944f \
 //x=55.62 //y=3.305 //x2=55.69 //y2=5.335
cc_7333 ( N_SN_c_10069_n N_noxref_22_c_12353_n ) capacitor c=0.0178828f \
 //x=55.62 //y=4.765 //x2=55.69 //y2=5.335
cc_7334 ( N_SN_c_10084_n N_noxref_22_c_12353_n ) capacitor c=0.00492634f \
 //x=55.62 //y=4.88 //x2=55.69 //y2=5.335
cc_7335 ( N_SN_M129_noxref_g N_noxref_22_c_12353_n ) capacitor c=0.00858183f \
 //x=55.59 //y=6.2 //x2=55.69 //y2=5.335
cc_7336 ( N_SN_c_10279_n N_noxref_22_c_12353_n ) capacitor c=5.8675e-19 \
 //x=55.62 //y=4.88 //x2=55.69 //y2=5.335
cc_7337 ( N_SN_M130_noxref_g N_noxref_22_c_12405_n ) capacitor c=0.00875663f \
 //x=56.03 //y=6.2 //x2=56.575 //y2=5.335
cc_7338 ( SN N_noxref_22_c_12426_n ) capacitor c=0.00173125f //x=55.62 \
 //y=2.77 //x2=57.47 //y2=3.365
cc_7339 ( N_SN_c_10255_n N_noxref_22_c_12426_n ) capacitor c=0.0253818f \
 //x=61.335 //y=3.13 //x2=57.47 //y2=3.365
cc_7340 ( N_SN_c_10255_n N_noxref_22_c_12431_n ) capacitor c=0.0071287f \
 //x=61.335 //y=3.13 //x2=57.47 //y2=3.685
cc_7341 ( N_SN_c_10069_n N_noxref_22_c_12248_n ) capacitor c=0.00131902f \
 //x=55.62 //y=4.765 //x2=57.47 //y2=5.25
cc_7342 ( N_SN_c_10242_n N_noxref_22_c_12600_n ) capacitor c=5.23493e-19 \
 //x=55.62 //y=3.305 //x2=55.81 //y2=5.335
cc_7343 ( N_SN_c_10069_n N_noxref_22_c_12600_n ) capacitor c=0.00209649f \
 //x=55.62 //y=4.765 //x2=55.81 //y2=5.335
cc_7344 ( N_SN_c_10084_n N_noxref_22_c_12600_n ) capacitor c=0.00132214f \
 //x=55.62 //y=4.88 //x2=55.81 //y2=5.335
cc_7345 ( N_SN_M129_noxref_g N_noxref_22_c_12600_n ) capacitor c=0.00229818f \
 //x=55.59 //y=6.2 //x2=55.81 //y2=5.335
cc_7346 ( N_SN_M130_noxref_g N_noxref_22_c_12600_n ) capacitor c=0.00230699f \
 //x=56.03 //y=6.2 //x2=55.81 //y2=5.335
cc_7347 ( N_SN_c_10101_n N_noxref_22_c_12600_n ) capacitor c=0.00177491f \
 //x=55.955 //y=4.97 //x2=55.81 //y2=5.335
cc_7348 ( N_SN_c_10242_n N_noxref_22_c_12361_n ) capacitor c=0.00313789f \
 //x=55.62 //y=3.305 //x2=55.235 //y2=3.51
cc_7349 ( N_SN_c_10069_n N_noxref_22_c_12361_n ) capacitor c=5.03481e-19 \
 //x=55.62 //y=4.765 //x2=55.235 //y2=3.51
cc_7350 ( N_SN_c_10790_p N_noxref_22_c_12361_n ) capacitor c=0.279956f \
 //x=52.12 //y=3.125 //x2=55.235 //y2=3.51
cc_7351 ( N_SN_c_10248_n N_noxref_22_c_12361_n ) capacitor c=0.0106417f \
 //x=55.46 //y=3.14 //x2=55.235 //y2=3.51
cc_7352 ( N_SN_c_10255_n N_noxref_22_c_12361_n ) capacitor c=0.0358254f \
 //x=61.335 //y=3.13 //x2=55.235 //y2=3.51
cc_7353 ( N_SN_c_10790_p N_noxref_22_c_12334_n ) capacitor c=0.0360995f \
 //x=52.12 //y=3.125 //x2=52.08 //y2=3.51
cc_7354 ( N_SN_c_10242_n N_noxref_22_c_12445_n ) capacitor c=0.00270239f \
 //x=55.62 //y=3.305 //x2=55.835 //y2=3.53
cc_7355 ( N_SN_c_10069_n N_noxref_22_c_12445_n ) capacitor c=0.0226038f \
 //x=55.62 //y=4.765 //x2=55.835 //y2=3.53
cc_7356 ( N_SN_c_10255_n N_noxref_22_c_12445_n ) capacitor c=0.0557366f \
 //x=61.335 //y=3.13 //x2=55.835 //y2=3.53
cc_7357 ( N_SN_c_10069_n N_noxref_22_c_12447_n ) capacitor c=2.67406e-19 \
 //x=55.62 //y=4.765 //x2=56.345 //y2=3.51
cc_7358 ( N_SN_c_10255_n N_noxref_22_c_12447_n ) capacitor c=0.0558942f \
 //x=61.335 //y=3.13 //x2=56.345 //y2=3.51
cc_7359 ( N_SN_c_10255_n N_noxref_22_c_12480_n ) capacitor c=0.0914861f \
 //x=61.335 //y=3.13 //x2=58.935 //y2=3.88
cc_7360 ( N_SN_c_10255_n N_noxref_22_c_12453_n ) capacitor c=0.0595316f \
 //x=61.335 //y=3.13 //x2=57.63 //y2=3.88
cc_7361 ( N_SN_c_10255_n N_noxref_22_c_12271_n ) capacitor c=0.0692116f \
 //x=61.335 //y=3.13 //x2=59.535 //y2=3.865
cc_7362 ( N_SN_c_10255_n N_noxref_22_c_12272_n ) capacitor c=0.00426821f \
 //x=61.335 //y=3.13 //x2=61.165 //y2=3.88
cc_7363 ( N_SN_c_10402_n N_noxref_22_c_12273_n ) capacitor c=0.0094909f \
 //x=61.765 //y=3.13 //x2=61.765 //y2=3.9
cc_7364 ( N_SN_c_10405_n N_noxref_22_c_12273_n ) capacitor c=0.00881944f \
 //x=62.5 //y=3.17 //x2=61.765 //y2=3.9
cc_7365 ( N_SN_c_10409_n N_noxref_22_c_12273_n ) capacitor c=0.00360024f \
 //x=63.75 //y=3.14 //x2=61.765 //y2=3.9
cc_7366 ( N_SN_c_10414_n N_noxref_22_c_12273_n ) capacitor c=0.0113035f \
 //x=64.35 //y=3.17 //x2=61.765 //y2=3.9
cc_7367 ( N_SN_c_10417_n N_noxref_22_c_12275_n ) capacitor c=0.00327811f \
 //x=66.705 //y=3.14 //x2=65.965 //y2=4.25
cc_7368 ( N_SN_c_10070_n N_noxref_22_c_12278_n ) capacitor c=0.0253008f \
 //x=70.05 //y=4.765 //x2=66.565 //y2=4.28
cc_7369 ( N_SN_c_10071_n N_noxref_22_c_12286_n ) capacitor c=0.0240579f \
 //x=84.48 //y=4.765 //x2=85.205 //y2=4.25
cc_7370 ( N_SN_c_10530_n N_noxref_22_c_12286_n ) capacitor c=0.0324304f \
 //x=78.77 //y=3.125 //x2=85.205 //y2=4.25
cc_7371 ( N_SN_c_10069_n N_noxref_22_c_12629_n ) capacitor c=6.21282e-19 \
 //x=55.62 //y=4.765 //x2=55.81 //y2=5.56
cc_7372 ( N_SN_M129_noxref_g N_noxref_22_c_12629_n ) capacitor c=0.0179041f \
 //x=55.59 //y=6.2 //x2=55.81 //y2=5.56
cc_7373 ( N_SN_M130_noxref_g N_noxref_22_c_12629_n ) capacitor c=0.0179041f \
 //x=56.03 //y=6.2 //x2=55.81 //y2=5.56
cc_7374 ( N_SN_c_10101_n N_noxref_22_c_12629_n ) capacitor c=0.00290085f \
 //x=55.955 //y=4.97 //x2=55.81 //y2=5.56
cc_7375 ( N_SN_M75_noxref_g N_VDD_c_13508_n ) capacitor c=0.00705252f //x=12.3 \
 //y=6.2 //x2=12.875 //y2=7.585
cc_7376 ( N_SN_M76_noxref_g N_VDD_c_13508_n ) capacitor c=0.00755544f \
 //x=12.74 //y=6.2 //x2=12.875 //y2=7.585
cc_7377 ( N_SN_M93_noxref_g N_VDD_c_13746_n ) capacitor c=0.00705252f \
 //x=26.73 //y=6.2 //x2=27.305 //y2=7.585
cc_7378 ( N_SN_M94_noxref_g N_VDD_c_13746_n ) capacitor c=0.00755544f \
 //x=27.17 //y=6.2 //x2=27.305 //y2=7.585
cc_7379 ( N_SN_M111_noxref_g N_VDD_c_13909_n ) capacitor c=0.00705252f \
 //x=41.16 //y=6.2 //x2=41.735 //y2=7.585
cc_7380 ( N_SN_M112_noxref_g N_VDD_c_13909_n ) capacitor c=0.00755544f \
 //x=41.6 //y=6.2 //x2=41.735 //y2=7.585
cc_7381 ( N_SN_M129_noxref_g N_VDD_c_14484_n ) capacitor c=0.00705252f \
 //x=55.59 //y=6.2 //x2=56.165 //y2=7.585
cc_7382 ( N_SN_M130_noxref_g N_VDD_c_14484_n ) capacitor c=0.00755544f \
 //x=56.03 //y=6.2 //x2=56.165 //y2=7.585
cc_7383 ( N_SN_M147_noxref_g N_VDD_c_14249_n ) capacitor c=0.00705252f \
 //x=70.02 //y=6.2 //x2=70.595 //y2=7.585
cc_7384 ( N_SN_M148_noxref_g N_VDD_c_14249_n ) capacitor c=0.00755544f \
 //x=70.46 //y=6.2 //x2=70.595 //y2=7.585
cc_7385 ( N_SN_M165_noxref_g N_VDD_c_14488_n ) capacitor c=0.00705252f \
 //x=84.45 //y=6.2 //x2=85.025 //y2=7.585
cc_7386 ( N_SN_M166_noxref_g N_VDD_c_14488_n ) capacitor c=0.00755544f \
 //x=84.89 //y=6.2 //x2=85.025 //y2=7.585
cc_7387 ( N_SN_M75_noxref_g N_VDD_M74_noxref_d ) capacitor c=0.015318f \
 //x=12.3 //y=6.2 //x2=11.935 //y2=5.2
cc_7388 ( N_SN_M76_noxref_g N_VDD_M76_noxref_d ) capacitor c=0.015318f \
 //x=12.74 //y=6.2 //x2=12.815 //y2=5.2
cc_7389 ( N_SN_M93_noxref_g N_VDD_M92_noxref_d ) capacitor c=0.015318f \
 //x=26.73 //y=6.2 //x2=26.365 //y2=5.2
cc_7390 ( N_SN_M94_noxref_g N_VDD_M94_noxref_d ) capacitor c=0.015318f \
 //x=27.17 //y=6.2 //x2=27.245 //y2=5.2
cc_7391 ( N_SN_M111_noxref_g N_VDD_M110_noxref_d ) capacitor c=0.015318f \
 //x=41.16 //y=6.2 //x2=40.795 //y2=5.2
cc_7392 ( N_SN_M112_noxref_g N_VDD_M112_noxref_d ) capacitor c=0.015318f \
 //x=41.6 //y=6.2 //x2=41.675 //y2=5.2
cc_7393 ( N_SN_M129_noxref_g N_VDD_M128_noxref_d ) capacitor c=0.015318f \
 //x=55.59 //y=6.2 //x2=55.225 //y2=5.2
cc_7394 ( N_SN_M130_noxref_g N_VDD_M130_noxref_d ) capacitor c=0.015318f \
 //x=56.03 //y=6.2 //x2=56.105 //y2=5.2
cc_7395 ( N_SN_M147_noxref_g N_VDD_M146_noxref_d ) capacitor c=0.015318f \
 //x=70.02 //y=6.2 //x2=69.655 //y2=5.2
cc_7396 ( N_SN_M148_noxref_g N_VDD_M148_noxref_d ) capacitor c=0.015318f \
 //x=70.46 //y=6.2 //x2=70.535 //y2=5.2
cc_7397 ( N_SN_M165_noxref_g N_VDD_M164_noxref_d ) capacitor c=0.015318f \
 //x=84.45 //y=6.2 //x2=84.085 //y2=5.2
cc_7398 ( N_SN_M166_noxref_g N_VDD_M166_noxref_d ) capacitor c=0.015318f \
 //x=84.89 //y=6.2 //x2=84.965 //y2=5.2
cc_7399 ( N_SN_c_9866_n N_noxref_28_c_15037_n ) capacitor c=0.00123426f \
 //x=12.42 //y=1.09 //x2=13.125 //y2=1.175
cc_7400 ( N_SN_c_9867_n N_noxref_28_c_15037_n ) capacitor c=0.0129288f \
 //x=12.42 //y=1.4 //x2=13.125 //y2=1.175
cc_7401 ( N_SN_c_9868_n N_noxref_28_c_15037_n ) capacitor c=0.00132209f \
 //x=12.42 //y=1.63 //x2=13.125 //y2=1.175
cc_7402 ( N_SN_c_9841_n N_noxref_28_M7_noxref_d ) capacitor c=0.00600656f \
 //x=12.33 //y=2.375 //x2=11.97 //y2=1.09
cc_7403 ( N_SN_c_9850_n N_noxref_28_M7_noxref_d ) capacitor c=2.2052e-19 \
 //x=12.33 //y=2.26 //x2=11.97 //y2=1.09
cc_7404 ( N_SN_c_9861_n N_noxref_28_M7_noxref_d ) capacitor c=0.00253592f \
 //x=11.895 //y=1.09 //x2=11.97 //y2=1.09
cc_7405 ( N_SN_c_9864_n N_noxref_28_M7_noxref_d ) capacitor c=0.00604087f \
 //x=11.895 //y=1.4 //x2=11.97 //y2=1.09
cc_7406 ( N_SN_c_10866_p N_noxref_28_M7_noxref_d ) capacitor c=0.002686f \
 //x=12.265 //y=0.935 //x2=11.97 //y2=1.09
cc_7407 ( N_SN_c_10867_p N_noxref_28_M7_noxref_d ) capacitor c=0.00251995f \
 //x=12.265 //y=1.555 //x2=11.97 //y2=1.09
cc_7408 ( N_SN_c_9866_n N_noxref_28_M7_noxref_d ) capacitor c=0.00314523f \
 //x=12.42 //y=1.09 //x2=11.97 //y2=1.09
cc_7409 ( N_SN_c_9867_n N_noxref_28_M7_noxref_d ) capacitor c=0.00168289f \
 //x=12.42 //y=1.4 //x2=11.97 //y2=1.09
cc_7410 ( N_SN_c_9868_n N_noxref_28_M7_noxref_d ) capacitor c=0.00111165f \
 //x=12.42 //y=1.63 //x2=11.97 //y2=1.09
cc_7411 ( N_SN_c_9866_n N_noxref_28_M8_noxref_s ) capacitor c=7.21316e-19 \
 //x=12.42 //y=1.09 //x2=13.075 //y2=0.555
cc_7412 ( N_SN_c_9867_n N_noxref_28_M8_noxref_s ) capacitor c=0.00365271f \
 //x=12.42 //y=1.4 //x2=13.075 //y2=0.555
cc_7413 ( N_SN_c_9869_n N_noxref_28_M8_noxref_s ) capacitor c=9.86711e-19 \
 //x=12.42 //y=2.095 //x2=13.075 //y2=0.555
cc_7414 ( N_SN_c_9963_n N_noxref_31_c_15240_n ) capacitor c=0.00123426f \
 //x=26.85 //y=1.09 //x2=27.555 //y2=1.175
cc_7415 ( N_SN_c_9964_n N_noxref_31_c_15240_n ) capacitor c=0.0129288f \
 //x=26.85 //y=1.4 //x2=27.555 //y2=1.175
cc_7416 ( N_SN_c_9965_n N_noxref_31_c_15240_n ) capacitor c=0.00132209f \
 //x=26.85 //y=1.63 //x2=27.555 //y2=1.175
cc_7417 ( N_SN_c_9931_n N_noxref_31_M16_noxref_d ) capacitor c=0.00600656f \
 //x=26.76 //y=2.375 //x2=26.4 //y2=1.09
cc_7418 ( N_SN_c_9934_n N_noxref_31_M16_noxref_d ) capacitor c=4.81531e-19 \
 //x=26.76 //y=3.305 //x2=26.4 //y2=1.09
cc_7419 ( N_SN_c_9947_n N_noxref_31_M16_noxref_d ) capacitor c=2.2052e-19 \
 //x=26.76 //y=2.26 //x2=26.4 //y2=1.09
cc_7420 ( N_SN_c_9958_n N_noxref_31_M16_noxref_d ) capacitor c=0.00253592f \
 //x=26.325 //y=1.09 //x2=26.4 //y2=1.09
cc_7421 ( N_SN_c_9961_n N_noxref_31_M16_noxref_d ) capacitor c=0.00604087f \
 //x=26.325 //y=1.4 //x2=26.4 //y2=1.09
cc_7422 ( N_SN_c_10882_p N_noxref_31_M16_noxref_d ) capacitor c=0.002686f \
 //x=26.695 //y=0.935 //x2=26.4 //y2=1.09
cc_7423 ( N_SN_c_10883_p N_noxref_31_M16_noxref_d ) capacitor c=0.00249146f \
 //x=26.695 //y=1.555 //x2=26.4 //y2=1.09
cc_7424 ( N_SN_c_9963_n N_noxref_31_M16_noxref_d ) capacitor c=0.00314523f \
 //x=26.85 //y=1.09 //x2=26.4 //y2=1.09
cc_7425 ( N_SN_c_9964_n N_noxref_31_M16_noxref_d ) capacitor c=0.00168289f \
 //x=26.85 //y=1.4 //x2=26.4 //y2=1.09
cc_7426 ( N_SN_c_9965_n N_noxref_31_M16_noxref_d ) capacitor c=0.00111165f \
 //x=26.85 //y=1.63 //x2=26.4 //y2=1.09
cc_7427 ( N_SN_c_9963_n N_noxref_31_M17_noxref_s ) capacitor c=7.21316e-19 \
 //x=26.85 //y=1.09 //x2=27.505 //y2=0.555
cc_7428 ( N_SN_c_9964_n N_noxref_31_M17_noxref_s ) capacitor c=0.00365271f \
 //x=26.85 //y=1.4 //x2=27.505 //y2=0.555
cc_7429 ( N_SN_c_9966_n N_noxref_31_M17_noxref_s ) capacitor c=9.86711e-19 \
 //x=26.85 //y=2.095 //x2=27.505 //y2=0.555
cc_7430 ( N_SN_c_10160_n N_noxref_34_c_15443_n ) capacitor c=0.00123426f \
 //x=41.28 //y=1.09 //x2=41.985 //y2=1.175
cc_7431 ( N_SN_c_10161_n N_noxref_34_c_15443_n ) capacitor c=0.0129288f \
 //x=41.28 //y=1.4 //x2=41.985 //y2=1.175
cc_7432 ( N_SN_c_10162_n N_noxref_34_c_15443_n ) capacitor c=0.00132209f \
 //x=41.28 //y=1.63 //x2=41.985 //y2=1.175
cc_7433 ( N_SN_c_10111_n N_noxref_34_M25_noxref_d ) capacitor c=0.00600656f \
 //x=41.19 //y=2.375 //x2=40.83 //y2=1.09
cc_7434 ( N_SN_c_10144_n N_noxref_34_M25_noxref_d ) capacitor c=2.2052e-19 \
 //x=41.19 //y=2.26 //x2=40.83 //y2=1.09
cc_7435 ( N_SN_c_10155_n N_noxref_34_M25_noxref_d ) capacitor c=0.00253592f \
 //x=40.755 //y=1.09 //x2=40.83 //y2=1.09
cc_7436 ( N_SN_c_10158_n N_noxref_34_M25_noxref_d ) capacitor c=0.00604087f \
 //x=40.755 //y=1.4 //x2=40.83 //y2=1.09
cc_7437 ( N_SN_c_10897_p N_noxref_34_M25_noxref_d ) capacitor c=0.002686f \
 //x=41.125 //y=0.935 //x2=40.83 //y2=1.09
cc_7438 ( N_SN_c_10898_p N_noxref_34_M25_noxref_d ) capacitor c=0.00251995f \
 //x=41.125 //y=1.555 //x2=40.83 //y2=1.09
cc_7439 ( N_SN_c_10160_n N_noxref_34_M25_noxref_d ) capacitor c=0.00314523f \
 //x=41.28 //y=1.09 //x2=40.83 //y2=1.09
cc_7440 ( N_SN_c_10161_n N_noxref_34_M25_noxref_d ) capacitor c=0.00168289f \
 //x=41.28 //y=1.4 //x2=40.83 //y2=1.09
cc_7441 ( N_SN_c_10162_n N_noxref_34_M25_noxref_d ) capacitor c=0.00111165f \
 //x=41.28 //y=1.63 //x2=40.83 //y2=1.09
cc_7442 ( N_SN_c_10160_n N_noxref_34_M26_noxref_s ) capacitor c=7.21316e-19 \
 //x=41.28 //y=1.09 //x2=41.935 //y2=0.555
cc_7443 ( N_SN_c_10161_n N_noxref_34_M26_noxref_s ) capacitor c=0.00365271f \
 //x=41.28 //y=1.4 //x2=41.935 //y2=0.555
cc_7444 ( N_SN_c_10163_n N_noxref_34_M26_noxref_s ) capacitor c=9.86711e-19 \
 //x=41.28 //y=2.095 //x2=41.935 //y2=0.555
cc_7445 ( N_SN_c_10273_n N_noxref_37_c_15635_n ) capacitor c=0.00123426f \
 //x=55.71 //y=1.09 //x2=56.415 //y2=1.175
cc_7446 ( N_SN_c_10274_n N_noxref_37_c_15635_n ) capacitor c=0.0129288f \
 //x=55.71 //y=1.4 //x2=56.415 //y2=1.175
cc_7447 ( N_SN_c_10275_n N_noxref_37_c_15635_n ) capacitor c=0.00132209f \
 //x=55.71 //y=1.63 //x2=56.415 //y2=1.175
cc_7448 ( N_SN_c_10239_n N_noxref_37_M34_noxref_d ) capacitor c=0.00600656f \
 //x=55.62 //y=2.375 //x2=55.26 //y2=1.09
cc_7449 ( N_SN_c_10242_n N_noxref_37_M34_noxref_d ) capacitor c=4.80106e-19 \
 //x=55.62 //y=3.305 //x2=55.26 //y2=1.09
cc_7450 ( N_SN_c_10257_n N_noxref_37_M34_noxref_d ) capacitor c=2.2052e-19 \
 //x=55.62 //y=2.26 //x2=55.26 //y2=1.09
cc_7451 ( N_SN_c_10268_n N_noxref_37_M34_noxref_d ) capacitor c=0.00253592f \
 //x=55.185 //y=1.09 //x2=55.26 //y2=1.09
cc_7452 ( N_SN_c_10271_n N_noxref_37_M34_noxref_d ) capacitor c=0.00604087f \
 //x=55.185 //y=1.4 //x2=55.26 //y2=1.09
cc_7453 ( N_SN_c_10913_p N_noxref_37_M34_noxref_d ) capacitor c=0.002686f \
 //x=55.555 //y=0.935 //x2=55.26 //y2=1.09
cc_7454 ( N_SN_c_10914_p N_noxref_37_M34_noxref_d ) capacitor c=0.00249146f \
 //x=55.555 //y=1.555 //x2=55.26 //y2=1.09
cc_7455 ( N_SN_c_10273_n N_noxref_37_M34_noxref_d ) capacitor c=0.00314523f \
 //x=55.71 //y=1.09 //x2=55.26 //y2=1.09
cc_7456 ( N_SN_c_10274_n N_noxref_37_M34_noxref_d ) capacitor c=0.00168289f \
 //x=55.71 //y=1.4 //x2=55.26 //y2=1.09
cc_7457 ( N_SN_c_10275_n N_noxref_37_M34_noxref_d ) capacitor c=0.00111165f \
 //x=55.71 //y=1.63 //x2=55.26 //y2=1.09
cc_7458 ( N_SN_c_10273_n N_noxref_37_M35_noxref_s ) capacitor c=7.21316e-19 \
 //x=55.71 //y=1.09 //x2=56.365 //y2=0.555
cc_7459 ( N_SN_c_10274_n N_noxref_37_M35_noxref_s ) capacitor c=0.00365271f \
 //x=55.71 //y=1.4 //x2=56.365 //y2=0.555
cc_7460 ( N_SN_c_10276_n N_noxref_37_M35_noxref_s ) capacitor c=9.86711e-19 \
 //x=55.71 //y=2.095 //x2=56.365 //y2=0.555
cc_7461 ( N_SN_c_10443_n N_noxref_40_c_15838_n ) capacitor c=0.00123426f \
 //x=70.14 //y=1.09 //x2=70.845 //y2=1.175
cc_7462 ( N_SN_c_10444_n N_noxref_40_c_15838_n ) capacitor c=0.0129288f \
 //x=70.14 //y=1.4 //x2=70.845 //y2=1.175
cc_7463 ( N_SN_c_10445_n N_noxref_40_c_15838_n ) capacitor c=0.00132209f \
 //x=70.14 //y=1.63 //x2=70.845 //y2=1.175
cc_7464 ( N_SN_c_10394_n N_noxref_40_M43_noxref_d ) capacitor c=0.00600656f \
 //x=70.05 //y=2.375 //x2=69.69 //y2=1.09
cc_7465 ( N_SN_c_10427_n N_noxref_40_M43_noxref_d ) capacitor c=2.2052e-19 \
 //x=70.05 //y=2.26 //x2=69.69 //y2=1.09
cc_7466 ( N_SN_c_10438_n N_noxref_40_M43_noxref_d ) capacitor c=0.00253592f \
 //x=69.615 //y=1.09 //x2=69.69 //y2=1.09
cc_7467 ( N_SN_c_10441_n N_noxref_40_M43_noxref_d ) capacitor c=0.00604087f \
 //x=69.615 //y=1.4 //x2=69.69 //y2=1.09
cc_7468 ( N_SN_c_10928_p N_noxref_40_M43_noxref_d ) capacitor c=0.002686f \
 //x=69.985 //y=0.935 //x2=69.69 //y2=1.09
cc_7469 ( N_SN_c_10929_p N_noxref_40_M43_noxref_d ) capacitor c=0.00251995f \
 //x=69.985 //y=1.555 //x2=69.69 //y2=1.09
cc_7470 ( N_SN_c_10443_n N_noxref_40_M43_noxref_d ) capacitor c=0.00314523f \
 //x=70.14 //y=1.09 //x2=69.69 //y2=1.09
cc_7471 ( N_SN_c_10444_n N_noxref_40_M43_noxref_d ) capacitor c=0.00168289f \
 //x=70.14 //y=1.4 //x2=69.69 //y2=1.09
cc_7472 ( N_SN_c_10445_n N_noxref_40_M43_noxref_d ) capacitor c=0.00111165f \
 //x=70.14 //y=1.63 //x2=69.69 //y2=1.09
cc_7473 ( N_SN_c_10443_n N_noxref_40_M44_noxref_s ) capacitor c=7.21316e-19 \
 //x=70.14 //y=1.09 //x2=70.795 //y2=0.555
cc_7474 ( N_SN_c_10444_n N_noxref_40_M44_noxref_s ) capacitor c=0.00365271f \
 //x=70.14 //y=1.4 //x2=70.795 //y2=0.555
cc_7475 ( N_SN_c_10446_n N_noxref_40_M44_noxref_s ) capacitor c=9.86711e-19 \
 //x=70.14 //y=2.095 //x2=70.795 //y2=0.555
cc_7476 ( N_SN_c_10530_n N_noxref_42_c_15961_n ) capacitor c=0.00438875f \
 //x=78.77 //y=3.125 //x2=80.465 //y2=1.175
cc_7477 ( N_SN_c_10530_n N_noxref_42_M50_noxref_s ) capacitor c=0.0026119f \
 //x=78.77 //y=3.125 //x2=80.415 //y2=0.555
cc_7478 ( N_SN_c_10664_n N_noxref_43_c_16030_n ) capacitor c=0.00123426f \
 //x=84.57 //y=1.09 //x2=85.275 //y2=1.175
cc_7479 ( N_SN_c_10665_n N_noxref_43_c_16030_n ) capacitor c=0.0129288f \
 //x=84.57 //y=1.4 //x2=85.275 //y2=1.175
cc_7480 ( N_SN_c_10666_n N_noxref_43_c_16030_n ) capacitor c=0.00132209f \
 //x=84.57 //y=1.63 //x2=85.275 //y2=1.175
cc_7481 ( N_SN_c_10624_n N_noxref_43_M52_noxref_d ) capacitor c=0.00600656f \
 //x=84.48 //y=2.375 //x2=84.12 //y2=1.09
cc_7482 ( N_SN_c_10634_n N_noxref_43_M52_noxref_d ) capacitor c=4.81531e-19 \
 //x=84.48 //y=3.305 //x2=84.12 //y2=1.09
cc_7483 ( N_SN_c_10648_n N_noxref_43_M52_noxref_d ) capacitor c=2.2052e-19 \
 //x=84.48 //y=2.26 //x2=84.12 //y2=1.09
cc_7484 ( N_SN_c_10659_n N_noxref_43_M52_noxref_d ) capacitor c=0.00253592f \
 //x=84.045 //y=1.09 //x2=84.12 //y2=1.09
cc_7485 ( N_SN_c_10662_n N_noxref_43_M52_noxref_d ) capacitor c=0.00604087f \
 //x=84.045 //y=1.4 //x2=84.12 //y2=1.09
cc_7486 ( N_SN_c_10946_p N_noxref_43_M52_noxref_d ) capacitor c=0.002686f \
 //x=84.415 //y=0.935 //x2=84.12 //y2=1.09
cc_7487 ( N_SN_c_10947_p N_noxref_43_M52_noxref_d ) capacitor c=0.00249146f \
 //x=84.415 //y=1.555 //x2=84.12 //y2=1.09
cc_7488 ( N_SN_c_10664_n N_noxref_43_M52_noxref_d ) capacitor c=0.00314523f \
 //x=84.57 //y=1.09 //x2=84.12 //y2=1.09
cc_7489 ( N_SN_c_10665_n N_noxref_43_M52_noxref_d ) capacitor c=0.00168289f \
 //x=84.57 //y=1.4 //x2=84.12 //y2=1.09
cc_7490 ( N_SN_c_10666_n N_noxref_43_M52_noxref_d ) capacitor c=0.00111165f \
 //x=84.57 //y=1.63 //x2=84.12 //y2=1.09
cc_7491 ( N_SN_c_10664_n N_noxref_43_M53_noxref_s ) capacitor c=7.21316e-19 \
 //x=84.57 //y=1.09 //x2=85.225 //y2=0.555
cc_7492 ( N_SN_c_10665_n N_noxref_43_M53_noxref_s ) capacitor c=0.00365271f \
 //x=84.57 //y=1.4 //x2=85.225 //y2=0.555
cc_7493 ( N_SN_c_10667_n N_noxref_43_M53_noxref_s ) capacitor c=9.86711e-19 \
 //x=84.57 //y=2.095 //x2=85.225 //y2=0.555
cc_7494 ( N_SN_c_9841_n N_GND_c_16460_n ) capacitor c=7.99941e-19 //x=12.33 \
 //y=2.375 //x2=15.91 //y2=0.175
cc_7495 ( N_SN_c_9844_n N_GND_c_16460_n ) capacitor c=2.08315e-19 //x=12.33 \
 //y=3.285 //x2=15.91 //y2=0.175
cc_7496 ( N_SN_c_9931_n N_GND_c_16588_n ) capacitor c=7.99941e-19 //x=26.76 \
 //y=2.375 //x2=30.34 //y2=0.175
cc_7497 ( N_SN_c_10111_n N_GND_c_16728_n ) capacitor c=7.99941e-19 //x=41.19 \
 //y=2.375 //x2=44.77 //y2=0.175
cc_7498 ( N_SN_c_10114_n N_GND_c_16728_n ) capacitor c=2.09027e-19 //x=41.19 \
 //y=3.285 //x2=44.77 //y2=0.175
cc_7499 ( N_SN_c_10239_n N_GND_c_16854_n ) capacitor c=7.99941e-19 //x=55.62 \
 //y=2.375 //x2=59.2 //y2=0.175
cc_7500 ( N_SN_c_10394_n N_GND_c_17019_n ) capacitor c=7.99941e-19 //x=70.05 \
 //y=2.375 //x2=73.63 //y2=0.175
cc_7501 ( N_SN_c_10397_n N_GND_c_17019_n ) capacitor c=2.09027e-19 //x=70.05 \
 //y=3.285 //x2=73.63 //y2=0.175
cc_7502 ( N_SN_c_10624_n N_GND_c_16607_n ) capacitor c=7.99941e-19 //x=84.48 \
 //y=2.375 //x2=88.165 //y2=0.175
cc_7503 ( N_SN_c_9890_n N_GND_c_16481_n ) capacitor c=0.00411812f //x=15.655 \
 //y=3.14 //x2=14.92 //y2=0.175
cc_7504 ( N_SN_c_9915_n N_GND_c_16530_n ) capacitor c=0.00504399f //x=20.45 \
 //y=3.14 //x2=19.73 //y2=0.175
cc_7505 ( N_SN_c_9921_n N_GND_c_16563_n ) capacitor c=0.00411812f //x=32.475 \
 //y=3.13 //x2=24.54 //y2=0.175
cc_7506 ( N_SN_c_9921_n N_GND_c_16600_n ) capacitor c=0.00504399f //x=32.475 \
 //y=3.13 //x2=29.35 //y2=0.175
cc_7507 ( N_SN_c_10126_n N_GND_c_16693_n ) capacitor c=0.00411812f //x=34.89 \
 //y=3.14 //x2=34.16 //y2=0.175
cc_7508 ( N_SN_c_10137_n N_GND_c_16706_n ) capacitor c=0.00411812f //x=39.695 \
 //y=3.14 //x2=38.97 //y2=0.175
cc_7509 ( N_SN_c_10184_n N_GND_c_16749_n ) capacitor c=0.00411812f //x=44.515 \
 //y=3.14 //x2=43.78 //y2=0.175
cc_7510 ( N_SN_c_10225_n N_GND_c_16796_n ) capacitor c=0.00504399f //x=49.31 \
 //y=3.14 //x2=48.59 //y2=0.175
cc_7511 ( N_SN_c_10248_n N_GND_c_16829_n ) capacitor c=0.00411812f //x=55.46 \
 //y=3.14 //x2=53.4 //y2=0.175
cc_7512 ( N_SN_c_10255_n N_GND_c_16867_n ) capacitor c=0.00504399f //x=61.335 \
 //y=3.13 //x2=58.21 //y2=0.175
cc_7513 ( N_SN_c_10409_n N_GND_c_16984_n ) capacitor c=0.00411812f //x=63.75 \
 //y=3.14 //x2=63.02 //y2=0.175
cc_7514 ( N_SN_c_10420_n N_GND_c_16997_n ) capacitor c=0.00411812f //x=68.555 \
 //y=3.14 //x2=67.83 //y2=0.175
cc_7515 ( N_SN_c_10467_n N_GND_c_17040_n ) capacitor c=0.00411812f //x=73.375 \
 //y=3.14 //x2=72.64 //y2=0.175
cc_7516 ( N_SN_c_10502_n N_GND_c_17093_n ) capacitor c=0.00504399f //x=78.17 \
 //y=3.14 //x2=77.45 //y2=0.175
cc_7517 ( N_SN_c_10530_n N_GND_c_17214_n ) capacitor c=0.00411812f //x=78.77 \
 //y=3.125 //x2=82.26 //y2=0.175
cc_7518 ( N_SN_c_9861_n N_noxref_49_c_18263_n ) capacitor c=0.0167228f \
 //x=11.895 //y=1.09 //x2=12.555 //y2=0.72
cc_7519 ( N_SN_c_9866_n N_noxref_49_c_18263_n ) capacitor c=0.00534519f \
 //x=12.42 //y=1.09 //x2=12.555 //y2=0.72
cc_7520 ( N_SN_c_9841_n N_noxref_49_c_18261_n ) capacitor c=0.0048147f \
 //x=12.33 //y=2.375 //x2=12.555 //y2=1.77
cc_7521 ( N_SN_c_9844_n N_noxref_49_c_18261_n ) capacitor c=0.00254411f \
 //x=12.33 //y=3.285 //x2=12.555 //y2=1.77
cc_7522 ( N_SN_c_9850_n N_noxref_49_c_18261_n ) capacitor c=0.0105652f \
 //x=12.33 //y=2.26 //x2=12.555 //y2=1.77
cc_7523 ( N_SN_c_9864_n N_noxref_49_c_18261_n ) capacitor c=0.0153476f \
 //x=11.895 //y=1.4 //x2=12.555 //y2=1.77
cc_7524 ( N_SN_c_9869_n N_noxref_49_c_18261_n ) capacitor c=0.0216832f \
 //x=12.42 //y=2.095 //x2=12.555 //y2=1.77
cc_7525 ( N_SN_c_9844_n N_noxref_49_M6_noxref_s ) capacitor c=5.54826e-19 \
 //x=12.33 //y=3.285 //x2=10.565 //y2=0.555
cc_7526 ( N_SN_c_9861_n N_noxref_49_M6_noxref_s ) capacitor c=0.00798959f \
 //x=11.895 //y=1.09 //x2=10.565 //y2=0.555
cc_7527 ( N_SN_c_9868_n N_noxref_49_M6_noxref_s ) capacitor c=0.00212176f \
 //x=12.42 //y=1.63 //x2=10.565 //y2=0.555
cc_7528 ( N_SN_c_9869_n N_noxref_49_M6_noxref_s ) capacitor c=0.00298115f \
 //x=12.42 //y=2.095 //x2=10.565 //y2=0.555
cc_7529 ( N_SN_c_9958_n N_noxref_52_c_18440_n ) capacitor c=0.0167228f \
 //x=26.325 //y=1.09 //x2=26.985 //y2=0.72
cc_7530 ( N_SN_c_9963_n N_noxref_52_c_18440_n ) capacitor c=0.00534519f \
 //x=26.85 //y=1.09 //x2=26.985 //y2=0.72
cc_7531 ( N_SN_c_9931_n N_noxref_52_c_18438_n ) capacitor c=0.0048147f \
 //x=26.76 //y=2.375 //x2=26.985 //y2=1.77
cc_7532 ( N_SN_c_9934_n N_noxref_52_c_18438_n ) capacitor c=0.00288317f \
 //x=26.76 //y=3.305 //x2=26.985 //y2=1.77
cc_7533 ( N_SN_c_9947_n N_noxref_52_c_18438_n ) capacitor c=0.0105652f \
 //x=26.76 //y=2.26 //x2=26.985 //y2=1.77
cc_7534 ( N_SN_c_9961_n N_noxref_52_c_18438_n ) capacitor c=0.0153476f \
 //x=26.325 //y=1.4 //x2=26.985 //y2=1.77
cc_7535 ( N_SN_c_9966_n N_noxref_52_c_18438_n ) capacitor c=0.019963f \
 //x=26.85 //y=2.095 //x2=26.985 //y2=1.77
cc_7536 ( N_SN_c_9958_n N_noxref_52_M15_noxref_s ) capacitor c=0.00798959f \
 //x=26.325 //y=1.09 //x2=24.995 //y2=0.555
cc_7537 ( N_SN_c_9965_n N_noxref_52_M15_noxref_s ) capacitor c=0.00212176f \
 //x=26.85 //y=1.63 //x2=24.995 //y2=0.555
cc_7538 ( N_SN_c_9966_n N_noxref_52_M15_noxref_s ) capacitor c=0.00298115f \
 //x=26.85 //y=2.095 //x2=24.995 //y2=0.555
cc_7539 ( N_SN_c_10155_n N_noxref_55_c_18610_n ) capacitor c=0.0167228f \
 //x=40.755 //y=1.09 //x2=41.415 //y2=0.72
cc_7540 ( N_SN_c_10160_n N_noxref_55_c_18610_n ) capacitor c=0.00534519f \
 //x=41.28 //y=1.09 //x2=41.415 //y2=0.72
cc_7541 ( N_SN_c_10111_n N_noxref_55_c_18608_n ) capacitor c=0.0048147f \
 //x=41.19 //y=2.375 //x2=41.415 //y2=1.77
cc_7542 ( N_SN_c_10114_n N_noxref_55_c_18608_n ) capacitor c=0.00254651f \
 //x=41.19 //y=3.285 //x2=41.415 //y2=1.77
cc_7543 ( N_SN_c_10144_n N_noxref_55_c_18608_n ) capacitor c=0.0105652f \
 //x=41.19 //y=2.26 //x2=41.415 //y2=1.77
cc_7544 ( N_SN_c_10158_n N_noxref_55_c_18608_n ) capacitor c=0.0153476f \
 //x=40.755 //y=1.4 //x2=41.415 //y2=1.77
cc_7545 ( N_SN_c_10163_n N_noxref_55_c_18608_n ) capacitor c=0.019963f \
 //x=41.28 //y=2.095 //x2=41.415 //y2=1.77
cc_7546 ( N_SN_c_10114_n N_noxref_55_M24_noxref_s ) capacitor c=5.54826e-19 \
 //x=41.19 //y=3.285 //x2=39.425 //y2=0.555
cc_7547 ( N_SN_c_10155_n N_noxref_55_M24_noxref_s ) capacitor c=0.00798959f \
 //x=40.755 //y=1.09 //x2=39.425 //y2=0.555
cc_7548 ( N_SN_c_10162_n N_noxref_55_M24_noxref_s ) capacitor c=0.00212176f \
 //x=41.28 //y=1.63 //x2=39.425 //y2=0.555
cc_7549 ( N_SN_c_10163_n N_noxref_55_M24_noxref_s ) capacitor c=0.00298115f \
 //x=41.28 //y=2.095 //x2=39.425 //y2=0.555
cc_7550 ( N_SN_c_10268_n N_noxref_58_c_18787_n ) capacitor c=0.0167228f \
 //x=55.185 //y=1.09 //x2=55.845 //y2=0.72
cc_7551 ( N_SN_c_10273_n N_noxref_58_c_18787_n ) capacitor c=0.00534519f \
 //x=55.71 //y=1.09 //x2=55.845 //y2=0.72
cc_7552 ( N_SN_c_10239_n N_noxref_58_c_18785_n ) capacitor c=0.0048147f \
 //x=55.62 //y=2.375 //x2=55.845 //y2=1.77
cc_7553 ( N_SN_c_10242_n N_noxref_58_c_18785_n ) capacitor c=0.00288136f \
 //x=55.62 //y=3.305 //x2=55.845 //y2=1.77
cc_7554 ( N_SN_c_10257_n N_noxref_58_c_18785_n ) capacitor c=0.0105652f \
 //x=55.62 //y=2.26 //x2=55.845 //y2=1.77
cc_7555 ( N_SN_c_10271_n N_noxref_58_c_18785_n ) capacitor c=0.0153476f \
 //x=55.185 //y=1.4 //x2=55.845 //y2=1.77
cc_7556 ( N_SN_c_10276_n N_noxref_58_c_18785_n ) capacitor c=0.019963f \
 //x=55.71 //y=2.095 //x2=55.845 //y2=1.77
cc_7557 ( N_SN_c_10268_n N_noxref_58_M33_noxref_s ) capacitor c=0.00798959f \
 //x=55.185 //y=1.09 //x2=53.855 //y2=0.555
cc_7558 ( N_SN_c_10275_n N_noxref_58_M33_noxref_s ) capacitor c=0.00212176f \
 //x=55.71 //y=1.63 //x2=53.855 //y2=0.555
cc_7559 ( N_SN_c_10276_n N_noxref_58_M33_noxref_s ) capacitor c=0.00298115f \
 //x=55.71 //y=2.095 //x2=53.855 //y2=0.555
cc_7560 ( N_SN_c_10438_n N_noxref_61_c_18957_n ) capacitor c=0.0167228f \
 //x=69.615 //y=1.09 //x2=70.275 //y2=0.72
cc_7561 ( N_SN_c_10443_n N_noxref_61_c_18957_n ) capacitor c=0.00534519f \
 //x=70.14 //y=1.09 //x2=70.275 //y2=0.72
cc_7562 ( N_SN_c_10394_n N_noxref_61_c_18955_n ) capacitor c=0.0048147f \
 //x=70.05 //y=2.375 //x2=70.275 //y2=1.77
cc_7563 ( N_SN_c_10397_n N_noxref_61_c_18955_n ) capacitor c=0.00254651f \
 //x=70.05 //y=3.285 //x2=70.275 //y2=1.77
cc_7564 ( N_SN_c_10427_n N_noxref_61_c_18955_n ) capacitor c=0.0105652f \
 //x=70.05 //y=2.26 //x2=70.275 //y2=1.77
cc_7565 ( N_SN_c_10441_n N_noxref_61_c_18955_n ) capacitor c=0.0153476f \
 //x=69.615 //y=1.4 //x2=70.275 //y2=1.77
cc_7566 ( N_SN_c_10446_n N_noxref_61_c_18955_n ) capacitor c=0.019963f \
 //x=70.14 //y=2.095 //x2=70.275 //y2=1.77
cc_7567 ( N_SN_c_10397_n N_noxref_61_M42_noxref_s ) capacitor c=5.54826e-19 \
 //x=70.05 //y=3.285 //x2=68.285 //y2=0.555
cc_7568 ( N_SN_c_10438_n N_noxref_61_M42_noxref_s ) capacitor c=0.00798959f \
 //x=69.615 //y=1.09 //x2=68.285 //y2=0.555
cc_7569 ( N_SN_c_10445_n N_noxref_61_M42_noxref_s ) capacitor c=0.00212176f \
 //x=70.14 //y=1.63 //x2=68.285 //y2=0.555
cc_7570 ( N_SN_c_10446_n N_noxref_61_M42_noxref_s ) capacitor c=0.00298115f \
 //x=70.14 //y=2.095 //x2=68.285 //y2=0.555
cc_7571 ( N_SN_c_10530_n N_noxref_63_c_19074_n ) capacitor c=0.00121576f \
 //x=78.77 //y=3.125 //x2=79.895 //y2=1.77
cc_7572 ( N_SN_c_10530_n N_noxref_63_M48_noxref_s ) capacitor c=0.00316687f \
 //x=78.77 //y=3.125 //x2=77.905 //y2=0.555
cc_7573 ( N_SN_c_10659_n N_noxref_64_c_19128_n ) capacitor c=0.0167228f \
 //x=84.045 //y=1.09 //x2=84.705 //y2=0.72
cc_7574 ( N_SN_c_10664_n N_noxref_64_c_19128_n ) capacitor c=0.00534519f \
 //x=84.57 //y=1.09 //x2=84.705 //y2=0.72
cc_7575 ( N_SN_c_10624_n N_noxref_64_c_19130_n ) capacitor c=0.0048147f \
 //x=84.48 //y=2.375 //x2=84.705 //y2=1.77
cc_7576 ( N_SN_c_10634_n N_noxref_64_c_19130_n ) capacitor c=0.00288317f \
 //x=84.48 //y=3.305 //x2=84.705 //y2=1.77
cc_7577 ( N_SN_c_10648_n N_noxref_64_c_19130_n ) capacitor c=0.0105652f \
 //x=84.48 //y=2.26 //x2=84.705 //y2=1.77
cc_7578 ( N_SN_c_10662_n N_noxref_64_c_19130_n ) capacitor c=0.0153476f \
 //x=84.045 //y=1.4 //x2=84.705 //y2=1.77
cc_7579 ( N_SN_c_10667_n N_noxref_64_c_19130_n ) capacitor c=0.0216832f \
 //x=84.57 //y=2.095 //x2=84.705 //y2=1.77
cc_7580 ( N_SN_c_10659_n N_noxref_64_M51_noxref_s ) capacitor c=0.00798959f \
 //x=84.045 //y=1.09 //x2=82.715 //y2=0.555
cc_7581 ( N_SN_c_10666_n N_noxref_64_M51_noxref_s ) capacitor c=0.00212176f \
 //x=84.57 //y=1.63 //x2=82.715 //y2=0.555
cc_7582 ( N_SN_c_10667_n N_noxref_64_M51_noxref_s ) capacitor c=0.00298115f \
 //x=84.57 //y=2.095 //x2=82.715 //y2=0.555
cc_7583 ( N_noxref_20_c_11063_n N_noxref_21_c_11652_n ) capacitor c=0.0247412f \
 //x=78.77 //y=3.895 //x2=80.78 //y2=4.75
cc_7584 ( N_noxref_20_c_11376_n N_noxref_21_c_11828_n ) capacitor \
 c=0.00168689f //x=85.59 //y=4.045 //x2=85.435 //y2=5.335
cc_7585 ( N_noxref_20_M167_noxref_g N_noxref_21_c_11828_n ) capacitor \
 c=0.00952006f //x=85.33 //y=6.2 //x2=85.435 //y2=5.335
cc_7586 ( N_noxref_20_M167_noxref_g N_noxref_21_c_11854_n ) capacitor \
 c=0.00226521f //x=85.33 //y=6.2 //x2=85.55 //y2=5.56
cc_7587 ( N_noxref_20_M168_noxref_g N_noxref_21_c_11854_n ) capacitor \
 c=0.00368717f //x=85.77 //y=6.2 //x2=85.55 //y2=5.56
cc_7588 ( N_noxref_20_c_11376_n N_noxref_21_c_11653_n ) capacitor \
 c=4.21338e-19 //x=85.59 //y=4.045 //x2=86.245 //y2=5.335
cc_7589 ( N_noxref_20_c_11055_n N_noxref_21_c_11653_n ) capacitor \
 c=0.00228791f //x=85.59 //y=4.75 //x2=86.245 //y2=5.335
cc_7590 ( N_noxref_20_c_11407_n N_noxref_21_c_11653_n ) capacitor \
 c=0.00130631f //x=85.59 //y=4.88 //x2=86.245 //y2=5.335
cc_7591 ( N_noxref_20_M168_noxref_g N_noxref_21_c_11653_n ) capacitor \
 c=0.0108585f //x=85.77 //y=6.2 //x2=86.245 //y2=5.335
cc_7592 ( N_noxref_20_c_11419_n N_noxref_21_c_11860_n ) capacitor \
 c=4.64015e-19 //x=85.58 //y=1.095 //x2=85.845 //y2=1.305
cc_7593 ( N_noxref_20_c_11420_n N_noxref_21_c_11860_n ) capacitor c=0.0026012f \
 //x=85.58 //y=1.44 //x2=85.845 //y2=1.305
cc_7594 ( N_noxref_20_c_11449_p N_noxref_21_c_11860_n ) capacitor \
 c=5.29969e-19 //x=85.955 //y=0.94 //x2=85.845 //y2=1.305
cc_7595 ( N_noxref_20_c_11450_p N_noxref_21_c_11860_n ) capacitor \
 c=5.31989e-19 //x=85.955 //y=1.595 //x2=85.845 //y2=1.305
cc_7596 ( N_noxref_20_c_11451_p N_noxref_21_c_11860_n ) capacitor \
 c=5.29003e-19 //x=86.11 //y=1.095 //x2=85.845 //y2=1.305
cc_7597 ( N_noxref_20_c_11452_p N_noxref_21_c_11860_n ) capacitor \
 c=0.00312555f //x=86.11 //y=1.44 //x2=85.845 //y2=1.305
cc_7598 ( N_noxref_20_c_11420_n N_noxref_21_c_11866_n ) capacitor \
 c=0.00127432f //x=85.58 //y=1.44 //x2=85.845 //y2=1.76
cc_7599 ( N_noxref_20_c_11421_n N_noxref_21_c_11866_n ) capacitor \
 c=0.00429966f //x=85.58 //y=1.75 //x2=85.845 //y2=1.76
cc_7600 ( N_noxref_20_c_11450_p N_noxref_21_c_11866_n ) capacitor c=0.009385f \
 //x=85.955 //y=1.595 //x2=85.845 //y2=1.76
cc_7601 ( N_noxref_20_c_11452_p N_noxref_21_c_11866_n ) capacitor \
 c=0.00346682f //x=86.11 //y=1.44 //x2=85.845 //y2=1.76
cc_7602 ( N_noxref_20_c_11433_n N_noxref_21_c_11866_n ) capacitor c=0.0036273f \
 //x=85.59 //y=2.095 //x2=85.845 //y2=1.76
cc_7603 ( N_noxref_20_c_11450_p N_noxref_21_c_11871_n ) capacitor \
 c=0.00194716f //x=85.955 //y=1.595 //x2=86.245 //y2=1.845
cc_7604 ( N_noxref_20_c_11452_p N_noxref_21_c_11871_n ) capacitor \
 c=0.00323576f //x=86.11 //y=1.44 //x2=86.245 //y2=1.845
cc_7605 ( N_noxref_20_c_11367_n N_noxref_21_c_11654_n ) capacitor \
 c=0.00799437f //x=85.59 //y=2.375 //x2=86.33 //y2=2.245
cc_7606 ( N_noxref_20_c_11403_n N_noxref_21_c_11654_n ) capacitor \
 c=9.86766e-19 //x=85.59 //y=2.26 //x2=86.33 //y2=2.245
cc_7607 ( N_noxref_20_c_11430_n N_noxref_21_c_11654_n ) capacitor \
 c=0.00109669f //x=85.59 //y=2.26 //x2=86.33 //y2=2.245
cc_7608 ( N_noxref_20_c_11433_n N_noxref_21_c_11654_n ) capacitor \
 c=0.00282067f //x=85.59 //y=2.095 //x2=86.33 //y2=2.245
cc_7609 ( N_noxref_20_c_11367_n N_noxref_21_c_11655_n ) capacitor \
 c=0.00911863f //x=85.59 //y=2.375 //x2=86.33 //y2=2.565
cc_7610 ( N_noxref_20_c_11054_n N_noxref_21_c_11655_n ) capacitor \
 c=0.00981819f //x=85.59 //y=3.725 //x2=86.33 //y2=2.565
cc_7611 ( N_noxref_20_c_11403_n N_noxref_21_c_11655_n ) capacitor \
 c=0.00192198f //x=85.59 //y=2.26 //x2=86.33 //y2=2.565
cc_7612 ( N_noxref_20_c_11430_n N_noxref_21_c_11655_n ) capacitor \
 c=0.00277848f //x=85.59 //y=2.26 //x2=86.33 //y2=2.565
cc_7613 ( N_noxref_20_c_11054_n N_noxref_21_c_11657_n ) capacitor c=0.0521949f \
 //x=85.59 //y=3.725 //x2=86.33 //y2=5.25
cc_7614 ( N_noxref_20_c_11376_n N_noxref_21_c_11657_n ) capacitor c=0.0148501f \
 //x=85.59 //y=4.045 //x2=86.33 //y2=5.25
cc_7615 ( N_noxref_20_c_11055_n N_noxref_21_c_11657_n ) capacitor c=0.0417031f \
 //x=85.59 //y=4.75 //x2=86.33 //y2=5.25
cc_7616 ( N_noxref_20_c_11381_n N_noxref_21_c_11657_n ) capacitor \
 c=6.89957e-19 //x=85.59 //y=3.88 //x2=86.33 //y2=5.25
cc_7617 ( N_noxref_20_c_11063_n N_noxref_21_c_11657_n ) capacitor \
 c=0.00686827f //x=78.77 //y=3.895 //x2=86.33 //y2=5.25
cc_7618 ( N_noxref_20_c_11407_n N_noxref_21_c_11657_n ) capacitor \
 c=0.00386137f //x=85.59 //y=4.88 //x2=86.33 //y2=5.25
cc_7619 ( N_noxref_20_c_11434_n N_noxref_21_c_11657_n ) capacitor \
 c=0.00739875f //x=85.59 //y=4.88 //x2=86.33 //y2=5.25
cc_7620 ( N_noxref_20_c_11055_n N_noxref_21_c_11888_n ) capacitor c=0.0221235f \
 //x=85.59 //y=4.75 //x2=85.55 //y2=5.335
cc_7621 ( N_noxref_20_c_11407_n N_noxref_21_c_11888_n ) capacitor \
 c=0.00346456f //x=85.59 //y=4.88 //x2=85.55 //y2=5.335
cc_7622 ( N_noxref_20_c_11434_n N_noxref_21_c_11888_n ) capacitor \
 c=0.00203307f //x=85.59 //y=4.88 //x2=85.55 //y2=5.335
cc_7623 ( N_noxref_20_c_11367_n N_noxref_21_c_11891_n ) capacitor \
 c=6.17196e-19 //x=85.59 //y=2.375 //x2=86.33 //y2=2.4
cc_7624 ( N_noxref_20_c_11054_n N_noxref_21_c_11891_n ) capacitor \
 c=4.71798e-19 //x=85.59 //y=3.725 //x2=86.33 //y2=2.4
cc_7625 ( N_noxref_20_c_11403_n N_noxref_21_c_11891_n ) capacitor \
 c=0.00439343f //x=85.59 //y=2.26 //x2=86.33 //y2=2.4
cc_7626 ( N_noxref_20_c_11430_n N_noxref_21_c_11891_n ) capacitor \
 c=0.00389543f //x=85.59 //y=2.26 //x2=86.33 //y2=2.4
cc_7627 ( N_noxref_20_c_11063_n N_noxref_21_c_11763_n ) capacitor \
 c=0.00182406f //x=78.77 //y=3.895 //x2=81.135 //y2=2.4
cc_7628 ( N_noxref_20_c_11063_n N_noxref_21_c_11775_n ) capacitor \
 c=4.77958e-19 //x=78.77 //y=3.895 //x2=83.58 //y2=2.37
cc_7629 ( N_noxref_20_c_11367_n N_noxref_21_c_11681_n ) capacitor c=0.0175275f \
 //x=85.59 //y=2.375 //x2=86.485 //y2=2.4
cc_7630 ( N_noxref_20_c_11054_n N_noxref_21_c_11681_n ) capacitor c=0.0191578f \
 //x=85.59 //y=3.725 //x2=86.485 //y2=2.4
cc_7631 ( N_noxref_20_c_11376_n N_noxref_21_c_11681_n ) capacitor \
 c=0.00213235f //x=85.59 //y=4.045 //x2=86.485 //y2=2.4
cc_7632 ( N_noxref_20_c_11063_n N_noxref_21_c_11681_n ) capacitor c=0.0280863f \
 //x=78.77 //y=3.895 //x2=86.485 //y2=2.4
cc_7633 ( N_noxref_20_c_11403_n N_noxref_21_c_11681_n ) capacitor \
 c=2.63835e-19 //x=85.59 //y=2.26 //x2=86.485 //y2=2.4
cc_7634 ( N_noxref_20_c_11430_n N_noxref_21_c_11681_n ) capacitor \
 c=3.41298e-19 //x=85.59 //y=2.26 //x2=86.485 //y2=2.4
cc_7635 ( N_noxref_20_c_11055_n N_noxref_21_c_11903_n ) capacitor \
 c=0.00217653f //x=85.59 //y=4.75 //x2=85.55 //y2=5.56
cc_7636 ( N_noxref_20_c_11407_n N_noxref_21_c_11903_n ) capacitor \
 c=0.00624059f //x=85.59 //y=4.88 //x2=85.55 //y2=5.56
cc_7637 ( N_noxref_20_M167_noxref_g N_noxref_21_c_11903_n ) capacitor \
 c=0.0178885f //x=85.33 //y=6.2 //x2=85.55 //y2=5.56
cc_7638 ( N_noxref_20_M168_noxref_g N_noxref_21_c_11903_n ) capacitor \
 c=0.0188608f //x=85.77 //y=6.2 //x2=85.55 //y2=5.56
cc_7639 ( N_noxref_20_c_11434_n N_noxref_21_c_11903_n ) capacitor \
 c=0.00375636f //x=85.59 //y=4.88 //x2=85.55 //y2=5.56
cc_7640 ( N_noxref_20_c_11419_n N_noxref_21_M53_noxref_d ) capacitor \
 c=0.00137165f //x=85.58 //y=1.095 //x2=85.655 //y2=1.095
cc_7641 ( N_noxref_20_c_11420_n N_noxref_21_M53_noxref_d ) capacitor \
 c=0.00237422f //x=85.58 //y=1.44 //x2=85.655 //y2=1.095
cc_7642 ( N_noxref_20_c_11449_p N_noxref_21_M53_noxref_d ) capacitor \
 c=0.0020782f //x=85.955 //y=0.94 //x2=85.655 //y2=1.095
cc_7643 ( N_noxref_20_c_11450_p N_noxref_21_M53_noxref_d ) capacitor \
 c=0.00356097f //x=85.955 //y=1.595 //x2=85.655 //y2=1.095
cc_7644 ( N_noxref_20_c_11451_p N_noxref_21_M53_noxref_d ) capacitor \
 c=0.00139206f //x=86.11 //y=1.095 //x2=85.655 //y2=1.095
cc_7645 ( N_noxref_20_c_11452_p N_noxref_21_M53_noxref_d ) capacitor \
 c=0.00237422f //x=86.11 //y=1.44 //x2=85.655 //y2=1.095
cc_7646 ( N_noxref_20_c_11152_n N_noxref_22_c_12273_n ) capacitor \
 c=0.00334857f //x=66.35 //y=4.055 //x2=61.765 //y2=3.9
cc_7647 ( N_noxref_20_c_11174_n N_noxref_22_c_12273_n ) capacitor c=0.0156422f \
 //x=66.51 //y=3.895 //x2=61.765 //y2=3.9
cc_7648 ( N_noxref_20_c_11043_n N_noxref_22_c_12507_n ) capacitor \
 c=0.00384482f //x=66.35 //y=4.75 //x2=65.61 //y2=4.165
cc_7649 ( N_noxref_20_c_11152_n N_noxref_22_c_12275_n ) capacitor \
 c=0.00119935f //x=66.35 //y=4.055 //x2=65.965 //y2=4.25
cc_7650 ( N_noxref_20_c_11043_n N_noxref_22_c_12275_n ) capacitor \
 c=7.76755e-19 //x=66.35 //y=4.75 //x2=65.965 //y2=4.25
cc_7651 ( N_noxref_20_c_11174_n N_noxref_22_c_12275_n ) capacitor c=0.0358254f \
 //x=66.51 //y=3.895 //x2=65.965 //y2=4.25
cc_7652 ( N_noxref_20_c_11152_n N_noxref_22_c_12278_n ) capacitor \
 c=0.00400537f //x=66.35 //y=4.055 //x2=66.565 //y2=4.28
cc_7653 ( N_noxref_20_c_11043_n N_noxref_22_c_12278_n ) capacitor c=0.0209937f \
 //x=66.35 //y=4.75 //x2=66.565 //y2=4.28
cc_7654 ( N_noxref_20_c_11090_n N_noxref_22_c_12278_n ) capacitor \
 c=0.00258295f //x=71.16 //y=4.055 //x2=66.565 //y2=4.28
cc_7655 ( N_noxref_20_c_11044_n N_noxref_22_c_12278_n ) capacitor c=0.0015119f \
 //x=71.16 //y=4.75 //x2=66.565 //y2=4.28
cc_7656 ( N_noxref_20_c_11081_n N_noxref_22_c_12278_n ) capacitor c=0.38895f \
 //x=71 //y=3.895 //x2=66.565 //y2=4.28
cc_7657 ( N_noxref_20_c_11108_n N_noxref_22_c_12278_n ) capacitor c=0.0330132f \
 //x=71.32 //y=3.895 //x2=66.565 //y2=4.28
cc_7658 ( N_noxref_20_c_11090_n N_noxref_22_c_12279_n ) capacitor \
 c=0.00220848f //x=71.16 //y=4.055 //x2=71.375 //y2=4.31
cc_7659 ( N_noxref_20_c_11044_n N_noxref_22_c_12279_n ) capacitor c=0.0205263f \
 //x=71.16 //y=4.75 //x2=71.375 //y2=4.31
cc_7660 ( N_noxref_20_c_11060_n N_noxref_22_c_12279_n ) capacitor c=0.441619f \
 //x=76.54 //y=3.88 //x2=71.375 //y2=4.31
cc_7661 ( N_noxref_20_c_11225_n N_noxref_22_c_12280_n ) capacitor \
 c=0.00143862f //x=76.71 //y=4.055 //x2=76.315 //y2=4.25
cc_7662 ( N_noxref_20_c_11051_n N_noxref_22_c_12280_n ) capacitor \
 c=6.13038e-19 //x=76.71 //y=5.25 //x2=76.315 //y2=4.25
cc_7663 ( N_noxref_20_c_11060_n N_noxref_22_c_12280_n ) capacitor c=0.0112109f \
 //x=76.54 //y=3.88 //x2=76.315 //y2=4.25
cc_7664 ( N_noxref_20_c_11064_n N_noxref_22_c_12280_n ) capacitor c=0.0358254f \
 //x=78.425 //y=3.895 //x2=76.315 //y2=4.25
cc_7665 ( N_noxref_20_c_11225_n N_noxref_22_c_12285_n ) capacitor \
 c=0.00743351f //x=76.71 //y=4.055 //x2=76.915 //y2=4.28
cc_7666 ( N_noxref_20_c_11051_n N_noxref_22_c_12285_n ) capacitor c=0.0224219f \
 //x=76.71 //y=5.25 //x2=76.915 //y2=4.28
cc_7667 ( N_noxref_20_c_11064_n N_noxref_22_c_12285_n ) capacitor c=0.125288f \
 //x=78.425 //y=3.895 //x2=76.915 //y2=4.28
cc_7668 ( N_noxref_20_c_11376_n N_noxref_22_c_12286_n ) capacitor \
 c=0.00275311f //x=85.59 //y=4.045 //x2=85.205 //y2=4.25
cc_7669 ( N_noxref_20_c_11055_n N_noxref_22_c_12286_n ) capacitor \
 c=5.04113e-19 //x=85.59 //y=4.75 //x2=85.205 //y2=4.25
cc_7670 ( N_noxref_20_c_11063_n N_noxref_22_c_12286_n ) capacitor c=0.602899f \
 //x=78.77 //y=3.895 //x2=85.205 //y2=4.25
cc_7671 ( N_noxref_20_c_11064_n N_noxref_22_c_12286_n ) capacitor c=0.0578277f \
 //x=78.425 //y=3.895 //x2=85.205 //y2=4.25
cc_7672 ( N_noxref_20_c_11376_n N_noxref_22_c_12287_n ) capacitor c=0.002495f \
 //x=85.59 //y=4.045 //x2=85.805 //y2=4.27
cc_7673 ( N_noxref_20_c_11055_n N_noxref_22_c_12287_n ) capacitor c=0.0210544f \
 //x=85.59 //y=4.75 //x2=85.805 //y2=4.27
cc_7674 ( N_noxref_20_c_11045_n N_VDD_c_13434_n ) capacitor c=0.00564708f \
 //x=74.93 //y=5.335 //x2=87.775 //y2=7.585
cc_7675 ( N_noxref_20_c_11047_n N_VDD_c_13434_n ) capacitor c=0.00576972f \
 //x=75.815 //y=5.335 //x2=87.775 //y2=7.585
cc_7676 ( N_noxref_20_c_11284_n N_VDD_c_13434_n ) capacitor c=0.00256036f \
 //x=75.93 //y=5.56 //x2=87.775 //y2=7.585
cc_7677 ( N_noxref_20_c_11050_n N_VDD_c_13434_n ) capacitor c=0.00829247f \
 //x=76.625 //y=5.335 //x2=87.775 //y2=7.585
cc_7678 ( N_noxref_20_c_11225_n N_VDD_c_13434_n ) capacitor c=5.13442e-19 \
 //x=76.71 //y=4.055 //x2=87.775 //y2=7.585
cc_7679 ( N_noxref_20_c_11057_n N_VDD_c_13434_n ) capacitor c=0.00239983f \
 //x=74.172 //y=5.335 //x2=87.775 //y2=7.585
cc_7680 ( N_noxref_20_c_11059_n N_VDD_c_13434_n ) capacitor c=0.00245065f \
 //x=75.05 //y=5.335 //x2=87.775 //y2=7.585
cc_7681 ( N_noxref_20_c_11114_n N_VDD_c_13434_n ) capacitor c=0.0024232f \
 //x=74.17 //y=5.56 //x2=87.775 //y2=7.585
cc_7682 ( N_noxref_20_c_11183_n N_VDD_c_13434_n ) capacitor c=0.0024232f \
 //x=75.05 //y=5.56 //x2=87.775 //y2=7.585
cc_7683 ( N_noxref_20_c_11330_n N_VDD_c_13434_n ) capacitor c=0.0024232f \
 //x=75.93 //y=5.56 //x2=87.775 //y2=7.585
cc_7684 ( N_noxref_20_M143_noxref_g N_VDD_c_14347_n ) capacitor c=0.00755544f \
 //x=66.09 //y=6.2 //x2=66.665 //y2=7.585
cc_7685 ( N_noxref_20_M144_noxref_g N_VDD_c_14347_n ) capacitor c=0.00755754f \
 //x=66.53 //y=6.2 //x2=66.665 //y2=7.585
cc_7686 ( N_noxref_20_M149_noxref_g N_VDD_c_14253_n ) capacitor c=0.00755544f \
 //x=70.9 //y=6.2 //x2=71.475 //y2=7.585
cc_7687 ( N_noxref_20_M150_noxref_g N_VDD_c_14253_n ) capacitor c=0.00755754f \
 //x=71.34 //y=6.2 //x2=71.475 //y2=7.585
cc_7688 ( N_noxref_20_c_11045_n N_VDD_c_14258_n ) capacitor c=0.00202922f \
 //x=74.93 //y=5.335 //x2=74.525 //y2=7.585
cc_7689 ( N_noxref_20_c_11057_n N_VDD_c_14258_n ) capacitor c=9.3757e-19 \
 //x=74.172 //y=5.335 //x2=74.525 //y2=7.585
cc_7690 ( N_noxref_20_c_11114_n N_VDD_c_14258_n ) capacitor c=0.0138074f \
 //x=74.17 //y=5.56 //x2=74.525 //y2=7.585
cc_7691 ( N_noxref_20_c_11045_n N_VDD_c_14298_n ) capacitor c=0.0017708f \
 //x=74.93 //y=5.335 //x2=75.405 //y2=7.585
cc_7692 ( N_noxref_20_c_11047_n N_VDD_c_14298_n ) capacitor c=0.00202922f \
 //x=75.815 //y=5.335 //x2=75.405 //y2=7.585
cc_7693 ( N_noxref_20_c_11059_n N_VDD_c_14298_n ) capacitor c=9.4822e-19 \
 //x=75.05 //y=5.335 //x2=75.405 //y2=7.585
cc_7694 ( N_noxref_20_c_11183_n N_VDD_c_14298_n ) capacitor c=0.0138074f \
 //x=75.05 //y=5.56 //x2=75.405 //y2=7.585
cc_7695 ( N_noxref_20_c_11047_n N_VDD_c_14400_n ) capacitor c=0.00205906f \
 //x=75.815 //y=5.335 //x2=76.285 //y2=7.585
cc_7696 ( N_noxref_20_c_11284_n N_VDD_c_14400_n ) capacitor c=8.49654e-19 \
 //x=75.93 //y=5.56 //x2=76.285 //y2=7.585
cc_7697 ( N_noxref_20_c_11050_n N_VDD_c_14400_n ) capacitor c=0.00204238f \
 //x=76.625 //y=5.335 //x2=76.285 //y2=7.585
cc_7698 ( N_noxref_20_c_11330_n N_VDD_c_14400_n ) capacitor c=0.0138074f \
 //x=75.93 //y=5.56 //x2=76.285 //y2=7.585
cc_7699 ( N_noxref_20_c_11050_n N_VDD_c_14527_n ) capacitor c=0.00183742f \
 //x=76.625 //y=5.335 //x2=77.28 //y2=7.585
cc_7700 ( N_noxref_20_M167_noxref_g N_VDD_c_14528_n ) capacitor c=0.00755544f \
 //x=85.33 //y=6.2 //x2=85.905 //y2=7.585
cc_7701 ( N_noxref_20_M168_noxref_g N_VDD_c_14528_n ) capacitor c=0.00755754f \
 //x=85.77 //y=6.2 //x2=85.905 //y2=7.585
cc_7702 ( N_noxref_20_c_11180_n N_VDD_c_13783_n ) capacitor c=0.00205049f \
 //x=66.35 //y=4.88 //x2=67.83 //y2=7.585
cc_7703 ( N_noxref_20_c_11057_n N_VDD_c_13784_n ) capacitor c=0.00244337f \
 //x=74.172 //y=5.335 //x2=72.64 //y2=7.585
cc_7704 ( N_noxref_20_c_11110_n N_VDD_c_13784_n ) capacitor c=0.00205049f \
 //x=71.16 //y=4.88 //x2=72.64 //y2=7.585
cc_7705 ( N_noxref_20_c_11114_n N_VDD_c_13784_n ) capacitor c=0.00509469f \
 //x=74.17 //y=5.56 //x2=72.64 //y2=7.585
cc_7706 ( N_noxref_20_c_11284_n N_VDD_c_13786_n ) capacitor c=0.00282782f \
 //x=75.93 //y=5.56 //x2=77.45 //y2=7.585
cc_7707 ( N_noxref_20_c_11051_n N_VDD_c_13786_n ) capacitor c=0.0321907f \
 //x=76.71 //y=5.25 //x2=77.45 //y2=7.585
cc_7708 ( N_noxref_20_c_11330_n N_VDD_c_13786_n ) capacitor c=0.00777981f \
 //x=75.93 //y=5.56 //x2=77.45 //y2=7.585
cc_7709 ( N_noxref_20_c_11407_n N_VDD_c_13788_n ) capacitor c=0.00224736f \
 //x=85.59 //y=4.88 //x2=87.07 //y2=7.585
cc_7710 ( N_noxref_20_c_11434_n N_VDD_c_13788_n ) capacitor c=2.63786e-19 \
 //x=85.59 //y=4.88 //x2=87.07 //y2=7.585
cc_7711 ( N_noxref_20_M143_noxref_g N_VDD_M142_noxref_d ) capacitor \
 c=0.015318f //x=66.09 //y=6.2 //x2=65.725 //y2=5.2
cc_7712 ( N_noxref_20_M144_noxref_g N_VDD_M144_noxref_d ) capacitor \
 c=0.0394719f //x=66.53 //y=6.2 //x2=66.605 //y2=5.2
cc_7713 ( N_noxref_20_M149_noxref_g N_VDD_M148_noxref_d ) capacitor \
 c=0.015318f //x=70.9 //y=6.2 //x2=70.535 //y2=5.2
cc_7714 ( N_noxref_20_M150_noxref_g N_VDD_M150_noxref_d ) capacitor \
 c=0.0394719f //x=71.34 //y=6.2 //x2=71.415 //y2=5.2
cc_7715 ( N_noxref_20_c_11057_n N_VDD_M151_noxref_s ) capacitor c=0.0442713f \
 //x=74.172 //y=5.335 //x2=73.595 //y2=5.2
cc_7716 ( N_noxref_20_c_11059_n N_VDD_M151_noxref_s ) capacitor c=7.80122e-19 \
 //x=75.05 //y=5.335 //x2=73.595 //y2=5.2
cc_7717 ( N_noxref_20_c_11114_n N_VDD_M151_noxref_s ) capacitor c=0.09305f \
 //x=74.17 //y=5.56 //x2=73.595 //y2=5.2
cc_7718 ( N_noxref_20_c_11045_n N_VDD_M152_noxref_d ) capacitor c=0.00700141f \
 //x=74.93 //y=5.335 //x2=74.465 //y2=5.2
cc_7719 ( N_noxref_20_c_11114_n N_VDD_M152_noxref_d ) capacitor c=0.0674491f \
 //x=74.17 //y=5.56 //x2=74.465 //y2=5.2
cc_7720 ( N_noxref_20_c_11183_n N_VDD_M152_noxref_d ) capacitor c=0.0674762f \
 //x=75.05 //y=5.56 //x2=74.465 //y2=5.2
cc_7721 ( N_noxref_20_c_11047_n N_VDD_M154_noxref_d ) capacitor c=0.00700141f \
 //x=75.815 //y=5.335 //x2=75.345 //y2=5.2
cc_7722 ( N_noxref_20_c_11183_n N_VDD_M154_noxref_d ) capacitor c=0.067493f \
 //x=75.05 //y=5.56 //x2=75.345 //y2=5.2
cc_7723 ( N_noxref_20_c_11330_n N_VDD_M154_noxref_d ) capacitor c=0.0674979f \
 //x=75.93 //y=5.56 //x2=75.345 //y2=5.2
cc_7724 ( N_noxref_20_c_11050_n N_VDD_M156_noxref_d ) capacitor c=0.00700141f \
 //x=76.625 //y=5.335 //x2=76.225 //y2=5.2
cc_7725 ( N_noxref_20_c_11330_n N_VDD_M156_noxref_d ) capacitor c=0.0675002f \
 //x=75.93 //y=5.56 //x2=76.225 //y2=5.2
cc_7726 ( N_noxref_20_c_11284_n N_VDD_M157_noxref_s ) capacitor c=0.00492616f \
 //x=75.93 //y=5.56 //x2=78.405 //y2=5.2
cc_7727 ( N_noxref_20_c_11050_n N_VDD_M157_noxref_s ) capacitor c=9.42705e-19 \
 //x=76.625 //y=5.335 //x2=78.405 //y2=5.2
cc_7728 ( N_noxref_20_c_11059_n N_VDD_M157_noxref_s ) capacitor c=2.11884e-19 \
 //x=75.05 //y=5.335 //x2=78.405 //y2=5.2
cc_7729 ( N_noxref_20_M167_noxref_g N_VDD_M166_noxref_d ) capacitor \
 c=0.015318f //x=85.33 //y=6.2 //x2=84.965 //y2=5.2
cc_7730 ( N_noxref_20_M168_noxref_g N_VDD_M168_noxref_d ) capacitor \
 c=0.0394719f //x=85.77 //y=6.2 //x2=85.845 //y2=5.2
cc_7731 ( N_noxref_20_c_11147_n N_noxref_39_c_15775_n ) capacitor \
 c=0.00177186f //x=66.35 //y=2.375 //x2=67.005 //y2=0.72
cc_7732 ( N_noxref_20_c_11176_n N_noxref_39_c_15775_n ) capacitor \
 c=0.00117306f //x=66.35 //y=2.26 //x2=67.005 //y2=0.72
cc_7733 ( N_noxref_20_c_11190_n N_noxref_39_c_15775_n ) capacitor c=0.0206349f \
 //x=66.34 //y=1.095 //x2=67.005 //y2=0.72
cc_7734 ( N_noxref_20_c_11267_n N_noxref_39_c_15775_n ) capacitor \
 c=0.00825432f //x=66.87 //y=1.095 //x2=67.005 //y2=0.72
cc_7735 ( N_noxref_20_c_11193_n N_noxref_39_c_15775_n ) capacitor \
 c=2.20712e-19 //x=66.35 //y=2.26 //x2=67.005 //y2=0.72
cc_7736 ( N_noxref_20_c_11191_n N_noxref_39_c_15778_n ) capacitor c=0.0071177f \
 //x=66.34 //y=1.44 //x2=66.12 //y2=1.175
cc_7737 ( N_noxref_20_c_11190_n N_noxref_39_M41_noxref_s ) capacitor \
 c=0.0071177f //x=66.34 //y=1.095 //x2=65.985 //y2=0.555
cc_7738 ( N_noxref_20_c_11192_n N_noxref_39_M41_noxref_s ) capacitor \
 c=0.0071177f //x=66.34 //y=1.75 //x2=65.985 //y2=0.555
cc_7739 ( N_noxref_20_c_11267_n N_noxref_39_M41_noxref_s ) capacitor \
 c=0.015333f //x=66.87 //y=1.095 //x2=65.985 //y2=0.555
cc_7740 ( N_noxref_20_c_11269_n N_noxref_39_M41_noxref_s ) capacitor \
 c=0.00248746f //x=66.87 //y=1.44 //x2=65.985 //y2=0.555
cc_7741 ( N_noxref_20_c_11082_n N_noxref_40_c_15826_n ) capacitor \
 c=0.00177186f //x=71.16 //y=2.375 //x2=71.815 //y2=0.72
cc_7742 ( N_noxref_20_c_11109_n N_noxref_40_c_15826_n ) capacitor \
 c=0.00117306f //x=71.16 //y=2.26 //x2=71.815 //y2=0.72
cc_7743 ( N_noxref_20_c_11123_n N_noxref_40_c_15826_n ) capacitor c=0.0206349f \
 //x=71.15 //y=1.095 //x2=71.815 //y2=0.72
cc_7744 ( N_noxref_20_c_11135_n N_noxref_40_c_15826_n ) capacitor \
 c=0.00825432f //x=71.68 //y=1.095 //x2=71.815 //y2=0.72
cc_7745 ( N_noxref_20_c_11141_n N_noxref_40_c_15826_n ) capacitor \
 c=2.20712e-19 //x=71.16 //y=2.26 //x2=71.815 //y2=0.72
cc_7746 ( N_noxref_20_c_11125_n N_noxref_40_c_15829_n ) capacitor c=0.0071177f \
 //x=71.15 //y=1.44 //x2=70.93 //y2=1.175
cc_7747 ( N_noxref_20_c_11090_n N_noxref_40_M44_noxref_s ) capacitor \
 c=9.71372e-19 //x=71.16 //y=4.055 //x2=70.795 //y2=0.555
cc_7748 ( N_noxref_20_c_11123_n N_noxref_40_M44_noxref_s ) capacitor \
 c=0.0071177f //x=71.15 //y=1.095 //x2=70.795 //y2=0.555
cc_7749 ( N_noxref_20_c_11128_n N_noxref_40_M44_noxref_s ) capacitor \
 c=0.0071177f //x=71.15 //y=1.75 //x2=70.795 //y2=0.555
cc_7750 ( N_noxref_20_c_11135_n N_noxref_40_M44_noxref_s ) capacitor \
 c=0.015333f //x=71.68 //y=1.095 //x2=70.795 //y2=0.555
cc_7751 ( N_noxref_20_c_11137_n N_noxref_40_M44_noxref_s ) capacitor \
 c=0.00248746f //x=71.68 //y=1.44 //x2=70.795 //y2=0.555
cc_7752 ( N_noxref_20_c_11289_n N_noxref_41_c_15911_n ) capacitor c=0.0036878f \
 //x=76.225 //y=1.305 //x2=76.625 //y2=0.72
cc_7753 ( N_noxref_20_c_11302_n N_noxref_41_c_15911_n ) capacitor \
 c=0.00399931f //x=76.625 //y=1.845 //x2=76.625 //y2=0.72
cc_7754 ( N_noxref_20_M47_noxref_d N_noxref_41_c_15911_n ) capacitor \
 c=0.00910163f //x=76.035 //y=1.095 //x2=76.625 //y2=0.72
cc_7755 ( N_noxref_20_M47_noxref_d N_noxref_41_c_15916_n ) capacitor \
 c=0.00120711f //x=76.035 //y=1.095 //x2=75.74 //y2=1.175
cc_7756 ( N_noxref_20_c_11045_n N_noxref_41_M46_noxref_d ) capacitor \
 c=7.30522e-19 //x=74.93 //y=5.335 //x2=74.5 //y2=1.09
cc_7757 ( N_noxref_20_c_11289_n N_noxref_41_M46_noxref_d ) capacitor \
 c=0.00802417f //x=76.225 //y=1.305 //x2=74.5 //y2=1.09
cc_7758 ( N_noxref_20_c_11289_n N_noxref_41_M47_noxref_s ) capacitor \
 c=0.0098487f //x=76.225 //y=1.305 //x2=75.605 //y2=0.555
cc_7759 ( N_noxref_20_c_11297_n N_noxref_41_M47_noxref_s ) capacitor \
 c=0.0283243f //x=76.225 //y=1.76 //x2=75.605 //y2=0.555
cc_7760 ( N_noxref_20_c_11302_n N_noxref_41_M47_noxref_s ) capacitor \
 c=0.00911719f //x=76.625 //y=1.845 //x2=75.605 //y2=0.555
cc_7761 ( N_noxref_20_c_11323_n N_noxref_41_M47_noxref_s ) capacitor \
 c=0.00129723f //x=76.71 //y=3.88 //x2=75.605 //y2=0.555
cc_7762 ( N_noxref_20_M47_noxref_d N_noxref_41_M47_noxref_s ) capacitor \
 c=0.0279003f //x=76.035 //y=1.095 //x2=75.605 //y2=0.555
cc_7763 ( N_noxref_20_c_11289_n N_noxref_42_M49_noxref_d ) capacitor \
 c=3.20746e-19 //x=76.225 //y=1.305 //x2=79.31 //y2=1.09
cc_7764 ( N_noxref_20_c_11367_n N_noxref_43_c_16046_n ) capacitor \
 c=0.00177186f //x=85.59 //y=2.375 //x2=86.245 //y2=0.72
cc_7765 ( N_noxref_20_c_11403_n N_noxref_43_c_16046_n ) capacitor \
 c=0.00117306f //x=85.59 //y=2.26 //x2=86.245 //y2=0.72
cc_7766 ( N_noxref_20_c_11419_n N_noxref_43_c_16046_n ) capacitor c=0.0206349f \
 //x=85.58 //y=1.095 //x2=86.245 //y2=0.72
cc_7767 ( N_noxref_20_c_11451_p N_noxref_43_c_16046_n ) capacitor \
 c=0.00825432f //x=86.11 //y=1.095 //x2=86.245 //y2=0.72
cc_7768 ( N_noxref_20_c_11430_n N_noxref_43_c_16046_n ) capacitor \
 c=2.20712e-19 //x=85.59 //y=2.26 //x2=86.245 //y2=0.72
cc_7769 ( N_noxref_20_c_11420_n N_noxref_43_c_16051_n ) capacitor c=0.0071177f \
 //x=85.58 //y=1.44 //x2=85.36 //y2=1.175
cc_7770 ( N_noxref_20_c_11376_n N_noxref_43_M53_noxref_s ) capacitor \
 c=9.73433e-19 //x=85.59 //y=4.045 //x2=85.225 //y2=0.555
cc_7771 ( N_noxref_20_c_11419_n N_noxref_43_M53_noxref_s ) capacitor \
 c=0.0071177f //x=85.58 //y=1.095 //x2=85.225 //y2=0.555
cc_7772 ( N_noxref_20_c_11421_n N_noxref_43_M53_noxref_s ) capacitor \
 c=0.0071177f //x=85.58 //y=1.75 //x2=85.225 //y2=0.555
cc_7773 ( N_noxref_20_c_11451_p N_noxref_43_M53_noxref_s ) capacitor \
 c=0.015333f //x=86.11 //y=1.095 //x2=85.225 //y2=0.555
cc_7774 ( N_noxref_20_c_11452_p N_noxref_43_M53_noxref_s ) capacitor \
 c=0.00248746f //x=86.11 //y=1.44 //x2=85.225 //y2=0.555
cc_7775 ( N_noxref_20_c_11147_n N_GND_c_17063_n ) capacitor c=0.00196498f \
 //x=66.35 //y=2.375 //x2=68.82 //y2=0.175
cc_7776 ( N_noxref_20_c_11082_n N_GND_c_17019_n ) capacitor c=0.00196498f \
 //x=71.16 //y=2.375 //x2=73.63 //y2=0.175
cc_7777 ( N_noxref_20_c_11289_n N_GND_c_17064_n ) capacitor c=0.00884007f \
 //x=76.225 //y=1.305 //x2=78.44 //y2=0.175
cc_7778 ( N_noxref_20_c_11302_n N_GND_c_17064_n ) capacitor c=0.00662992f \
 //x=76.625 //y=1.845 //x2=78.44 //y2=0.175
cc_7779 ( N_noxref_20_c_11225_n N_GND_c_17064_n ) capacitor c=3.09244e-19 \
 //x=76.71 //y=4.055 //x2=78.44 //y2=0.175
cc_7780 ( N_noxref_20_M47_noxref_d N_GND_c_17064_n ) capacitor c=2.9462e-19 \
 //x=76.035 //y=1.095 //x2=78.44 //y2=0.175
cc_7781 ( N_noxref_20_c_11367_n N_GND_c_16607_n ) capacitor c=0.00196498f \
 //x=85.59 //y=2.375 //x2=88.165 //y2=0.175
cc_7782 ( N_noxref_20_c_11289_n N_GND_c_17074_n ) capacitor c=0.00543195f \
 //x=76.225 //y=1.305 //x2=78.525 //y2=1.145
cc_7783 ( N_noxref_20_c_11147_n N_GND_c_16982_n ) capacitor c=2.016e-19 \
 //x=66.35 //y=2.375 //x2=67.66 //y2=0.175
cc_7784 ( N_noxref_20_c_11082_n N_GND_c_16983_n ) capacitor c=2.016e-19 \
 //x=71.16 //y=2.375 //x2=72.47 //y2=0.175
cc_7785 ( N_noxref_20_c_11302_n N_GND_c_17039_n ) capacitor c=6.86343e-19 \
 //x=76.625 //y=1.845 //x2=77.28 //y2=0.175
cc_7786 ( N_noxref_20_c_11367_n N_GND_c_17213_n ) capacitor c=2.016e-19 \
 //x=85.59 //y=2.375 //x2=86.9 //y2=0.175
cc_7787 ( N_noxref_20_c_11176_n N_GND_c_16997_n ) capacitor c=0.00222376f \
 //x=66.35 //y=2.26 //x2=67.83 //y2=0.175
cc_7788 ( N_noxref_20_c_11269_n N_GND_c_16997_n ) capacitor c=0.00262688f \
 //x=66.87 //y=1.44 //x2=67.83 //y2=0.175
cc_7789 ( N_noxref_20_c_11109_n N_GND_c_17040_n ) capacitor c=0.00222376f \
 //x=71.16 //y=2.26 //x2=72.64 //y2=0.175
cc_7790 ( N_noxref_20_c_11137_n N_GND_c_17040_n ) capacitor c=0.00262688f \
 //x=71.68 //y=1.44 //x2=72.64 //y2=0.175
cc_7791 ( N_noxref_20_c_11141_n N_GND_c_17040_n ) capacitor c=2.63786e-19 \
 //x=71.16 //y=2.26 //x2=72.64 //y2=0.175
cc_7792 ( N_noxref_20_c_11297_n N_GND_c_17093_n ) capacitor c=0.0045138f \
 //x=76.225 //y=1.76 //x2=77.45 //y2=0.175
cc_7793 ( N_noxref_20_c_11302_n N_GND_c_17093_n ) capacitor c=0.0319165f \
 //x=76.625 //y=1.845 //x2=77.45 //y2=0.175
cc_7794 ( N_noxref_20_c_11403_n N_GND_c_16635_n ) capacitor c=0.0011747f \
 //x=85.59 //y=2.26 //x2=87.07 //y2=0.175
cc_7795 ( N_noxref_20_c_11452_p N_GND_c_16635_n ) capacitor c=0.00262688f \
 //x=86.11 //y=1.44 //x2=87.07 //y2=0.175
cc_7796 ( N_noxref_20_c_11430_n N_GND_c_16635_n ) capacitor c=2.63786e-19 \
 //x=85.59 //y=2.26 //x2=87.07 //y2=0.175
cc_7797 ( N_noxref_21_c_11672_n N_noxref_22_c_12249_n ) capacitor c=0.0171191f \
 //x=92.825 //y=2.4 //x2=88.92 //y2=2.375
cc_7798 ( N_noxref_21_c_11657_n N_noxref_22_c_12253_n ) capacitor \
 c=0.00217965f //x=86.33 //y=5.25 //x2=88.92 //y2=4.045
cc_7799 ( N_noxref_21_c_11664_n N_noxref_22_c_12253_n ) capacitor \
 c=0.00121672f //x=92.99 //y=4.76 //x2=88.92 //y2=4.045
cc_7800 ( N_noxref_21_c_11672_n N_noxref_22_c_12253_n ) capacitor c=0.0201758f \
 //x=92.825 //y=2.4 //x2=88.92 //y2=4.045
cc_7801 ( N_noxref_21_c_11672_n N_noxref_22_c_12256_n ) capacitor \
 c=0.00178925f //x=92.825 //y=2.4 //x2=88.92 //y2=4.365
cc_7802 ( N_noxref_21_c_11657_n N_noxref_22_c_12259_n ) capacitor \
 c=0.00202648f //x=86.33 //y=5.25 //x2=88.92 //y2=4.71
cc_7803 ( N_noxref_21_c_11664_n N_noxref_22_c_12259_n ) capacitor \
 c=0.00166637f //x=92.99 //y=4.76 //x2=88.92 //y2=4.71
cc_7804 ( N_noxref_21_c_11921_p N_noxref_22_c_12668_n ) capacitor c=0.0061363f \
 //x=94.47 //y=2.43 //x2=95.58 //y2=2.38
cc_7805 ( N_noxref_21_c_11922_p N_noxref_22_c_12668_n ) capacitor \
 c=0.00602303f //x=94.465 //y=2.27 //x2=95.58 //y2=2.38
cc_7806 ( N_noxref_21_c_11923_p N_noxref_22_c_12668_n ) capacitor \
 c=2.06418e-19 //x=94.47 //y=2.26 //x2=95.58 //y2=2.38
cc_7807 ( N_noxref_21_c_11924_p N_noxref_22_c_12668_n ) capacitor \
 c=6.73725e-19 //x=94.47 //y=2.26 //x2=95.58 //y2=2.38
cc_7808 ( N_noxref_21_c_11664_n N_noxref_22_c_12672_n ) capacitor \
 c=0.00209775f //x=92.99 //y=4.76 //x2=95.58 //y2=4.05
cc_7809 ( N_noxref_21_c_11921_p N_noxref_22_c_12672_n ) capacitor c=0.0011922f \
 //x=94.47 //y=2.43 //x2=95.58 //y2=4.05
cc_7810 ( N_noxref_21_c_11669_n N_noxref_22_c_12672_n ) capacitor c=0.0512343f \
 //x=94.47 //y=4.755 //x2=95.58 //y2=4.05
cc_7811 ( N_noxref_21_c_11922_p N_noxref_22_c_12672_n ) capacitor \
 c=0.00107415f //x=94.465 //y=2.27 //x2=95.58 //y2=4.05
cc_7812 ( N_noxref_21_c_11669_n N_noxref_22_c_12676_n ) capacitor \
 c=0.00771726f //x=94.47 //y=4.755 //x2=95.58 //y2=4.37
cc_7813 ( N_noxref_21_c_11664_n N_noxref_22_c_12677_n ) capacitor \
 c=9.13182e-19 //x=92.99 //y=4.76 //x2=95.58 //y2=4.74
cc_7814 ( N_noxref_21_c_11669_n N_noxref_22_c_12677_n ) capacitor c=0.021848f \
 //x=94.47 //y=4.755 //x2=95.58 //y2=4.74
cc_7815 ( N_noxref_21_c_11932_p N_noxref_22_c_12677_n ) capacitor \
 c=8.06413e-19 //x=94.47 //y=4.885 //x2=95.58 //y2=4.74
cc_7816 ( N_noxref_21_c_11933_p N_noxref_22_c_12677_n ) capacitor \
 c=0.00125146f //x=95.105 //y=4.975 //x2=95.58 //y2=4.74
cc_7817 ( N_noxref_21_c_11934_p N_noxref_22_c_12677_n ) capacitor \
 c=0.00103195f //x=94.815 //y=4.975 //x2=95.58 //y2=4.74
cc_7818 ( N_noxref_21_c_11669_n N_noxref_22_c_12682_n ) capacitor \
 c=5.15538e-19 //x=94.47 //y=4.755 //x2=95.58 //y2=4.25
cc_7819 ( N_noxref_21_c_11652_n N_noxref_22_c_12286_n ) capacitor c=0.0220634f \
 //x=80.78 //y=4.75 //x2=85.205 //y2=4.25
cc_7820 ( N_noxref_21_c_11681_n N_noxref_22_c_12286_n ) capacitor \
 c=0.00707306f //x=86.485 //y=2.4 //x2=85.205 //y2=4.25
cc_7821 ( N_noxref_21_c_11657_n N_noxref_22_c_12287_n ) capacitor c=7.1366e-19 \
 //x=86.33 //y=5.25 //x2=85.805 //y2=4.27
cc_7822 ( N_noxref_21_c_11681_n N_noxref_22_c_12287_n ) capacitor \
 c=0.00505004f //x=86.485 //y=2.4 //x2=85.805 //y2=4.27
cc_7823 ( N_noxref_21_c_11655_n N_noxref_22_c_12288_n ) capacitor \
 c=0.00211135f //x=86.33 //y=2.565 //x2=87.43 //y2=4.25
cc_7824 ( N_noxref_21_c_11657_n N_noxref_22_c_12288_n ) capacitor c=0.0286395f \
 //x=86.33 //y=5.25 //x2=87.43 //y2=4.25
cc_7825 ( N_noxref_21_c_11672_n N_noxref_22_c_12288_n ) capacitor c=0.0323519f \
 //x=92.825 //y=2.4 //x2=87.43 //y2=4.25
cc_7826 ( N_noxref_21_c_11681_n N_noxref_22_c_12288_n ) capacitor \
 c=0.00381345f //x=86.485 //y=2.4 //x2=87.43 //y2=4.25
cc_7827 ( N_noxref_21_c_11672_n N_noxref_22_c_12294_n ) capacitor c=0.0176403f \
 //x=92.825 //y=2.4 //x2=89.08 //y2=4.252
cc_7828 ( N_noxref_21_c_11669_n N_noxref_22_c_12692_n ) capacitor \
 c=0.00250167f //x=94.47 //y=4.755 //x2=95.595 //y2=4.21
cc_7829 ( N_noxref_21_c_11661_n N_noxref_22_c_12297_n ) capacitor \
 c=0.00230182f //x=92.99 //y=2.43 //x2=95.435 //y2=4.21
cc_7830 ( N_noxref_21_c_11664_n N_noxref_22_c_12297_n ) capacitor c=0.0404656f \
 //x=92.99 //y=4.76 //x2=95.435 //y2=4.21
cc_7831 ( N_noxref_21_c_11921_p N_noxref_22_c_12297_n ) capacitor \
 c=0.00231693f //x=94.47 //y=2.43 //x2=95.435 //y2=4.21
cc_7832 ( N_noxref_21_c_11669_n N_noxref_22_c_12297_n ) capacitor c=0.0387859f \
 //x=94.47 //y=4.755 //x2=95.435 //y2=4.21
cc_7833 ( N_noxref_21_c_11672_n N_noxref_22_c_12297_n ) capacitor c=0.0800483f \
 //x=92.825 //y=2.4 //x2=95.435 //y2=4.21
cc_7834 ( N_noxref_21_c_11684_n N_noxref_22_c_12297_n ) capacitor \
 c=8.35607e-19 //x=93.155 //y=2.26 //x2=95.435 //y2=4.21
cc_7835 ( N_noxref_21_c_11922_p N_noxref_22_c_12297_n ) capacitor \
 c=0.00472291f //x=94.465 //y=2.27 //x2=95.435 //y2=4.21
cc_7836 ( N_noxref_21_c_11953_p N_noxref_22_c_12297_n ) capacitor c=0.0202481f \
 //x=94.305 //y=2.27 //x2=95.435 //y2=4.21
cc_7837 ( N_noxref_21_c_11672_n N_noxref_22_c_12301_n ) capacitor \
 c=5.50058e-19 //x=92.825 //y=2.4 //x2=88.92 //y2=2.26
cc_7838 ( N_noxref_21_c_11921_p N_noxref_22_c_12702_n ) capacitor \
 c=7.58956e-19 //x=94.47 //y=2.43 //x2=95.58 //y2=2.26
cc_7839 ( N_noxref_21_c_11923_p N_noxref_22_c_12702_n ) capacitor \
 c=0.00113671f //x=94.47 //y=2.26 //x2=95.58 //y2=2.26
cc_7840 ( N_noxref_21_c_11924_p N_noxref_22_c_12702_n ) capacitor \
 c=0.00169858f //x=94.47 //y=2.26 //x2=95.58 //y2=2.26
cc_7841 ( N_noxref_21_c_11669_n N_noxref_22_c_12705_n ) capacitor \
 c=2.02321e-19 //x=94.47 //y=4.755 //x2=95.6 //y2=4.885
cc_7842 ( N_noxref_21_c_11932_p N_noxref_22_c_12705_n ) capacitor \
 c=0.00106454f //x=94.47 //y=4.885 //x2=95.6 //y2=4.885
cc_7843 ( N_noxref_21_c_11933_p N_noxref_22_c_12705_n ) capacitor \
 c=0.00147609f //x=95.105 //y=4.975 //x2=95.6 //y2=4.885
cc_7844 ( N_noxref_21_c_11934_p N_noxref_22_c_12705_n ) capacitor \
 c=0.00127381f //x=94.815 //y=4.975 //x2=95.6 //y2=4.885
cc_7845 ( N_noxref_21_M177_noxref_g N_noxref_22_M179_noxref_g ) capacitor \
 c=0.00935155f //x=94.74 //y=6.205 //x2=95.62 //y2=6.205
cc_7846 ( N_noxref_21_M178_noxref_g N_noxref_22_M179_noxref_g ) capacitor \
 c=0.111828f //x=95.18 //y=6.205 //x2=95.62 //y2=6.205
cc_7847 ( N_noxref_21_M178_noxref_g N_noxref_22_M180_noxref_g ) capacitor \
 c=0.00876656f //x=95.18 //y=6.205 //x2=96.06 //y2=6.205
cc_7848 ( N_noxref_21_c_11965_p N_noxref_22_c_12712_n ) capacitor \
 c=4.86545e-19 //x=94.645 //y=1.045 //x2=95.615 //y2=1.085
cc_7849 ( N_noxref_21_c_11966_p N_noxref_22_c_12712_n ) capacitor \
 c=0.00152405f //x=94.645 //y=1.39 //x2=95.615 //y2=1.085
cc_7850 ( N_noxref_21_c_11967_p N_noxref_22_c_12712_n ) capacitor c=0.0151424f \
 //x=95.175 //y=1.045 //x2=95.615 //y2=1.085
cc_7851 ( N_noxref_21_c_11968_p N_noxref_22_c_12715_n ) capacitor \
 c=0.00109722f //x=94.645 //y=1.7 //x2=95.615 //y2=1.435
cc_7852 ( N_noxref_21_c_11969_p N_noxref_22_c_12715_n ) capacitor c=0.0111013f \
 //x=95.175 //y=1.39 //x2=95.615 //y2=1.435
cc_7853 ( N_noxref_21_c_11968_p N_noxref_22_c_12717_n ) capacitor \
 c=0.00179029f //x=94.645 //y=1.7 //x2=95.615 //y2=1.74
cc_7854 ( N_noxref_21_c_11971_p N_noxref_22_c_12717_n ) capacitor \
 c=0.00662747f //x=94.645 //y=2.095 //x2=95.615 //y2=1.74
cc_7855 ( N_noxref_21_c_11969_p N_noxref_22_c_12717_n ) capacitor \
 c=0.00862358f //x=95.175 //y=1.39 //x2=95.615 //y2=1.74
cc_7856 ( N_noxref_21_c_11969_p N_noxref_22_c_12720_n ) capacitor \
 c=4.75927e-19 //x=95.175 //y=1.39 //x2=95.99 //y2=1.585
cc_7857 ( N_noxref_21_c_11967_p N_noxref_22_c_12721_n ) capacitor \
 c=0.00130607f //x=95.175 //y=1.045 //x2=96.145 //y2=1.085
cc_7858 ( N_noxref_21_c_11969_p N_noxref_22_c_12722_n ) capacitor \
 c=0.00153205f //x=95.175 //y=1.39 //x2=96.145 //y2=1.435
cc_7859 ( N_noxref_21_c_11672_n N_noxref_22_c_12324_n ) capacitor \
 c=3.41298e-19 //x=92.825 //y=2.4 //x2=88.92 //y2=2.26
cc_7860 ( N_noxref_21_c_11921_p N_noxref_22_c_12724_n ) capacitor \
 c=0.00157228f //x=94.47 //y=2.43 //x2=95.58 //y2=2.26
cc_7861 ( N_noxref_21_c_11923_p N_noxref_22_c_12724_n ) capacitor \
 c=0.00194209f //x=94.47 //y=2.26 //x2=95.58 //y2=2.26
cc_7862 ( N_noxref_21_c_11924_p N_noxref_22_c_12724_n ) capacitor \
 c=0.00887988f //x=94.47 //y=2.26 //x2=95.58 //y2=2.26
cc_7863 ( N_noxref_21_c_11669_n N_noxref_22_c_12727_n ) capacitor \
 c=0.00132485f //x=94.47 //y=4.755 //x2=95.6 //y2=4.885
cc_7864 ( N_noxref_21_c_11932_p N_noxref_22_c_12727_n ) capacitor \
 c=0.00167042f //x=94.47 //y=4.885 //x2=95.6 //y2=4.885
cc_7865 ( N_noxref_21_c_11933_p N_noxref_22_c_12727_n ) capacitor c=0.022796f \
 //x=95.105 //y=4.975 //x2=95.6 //y2=4.885
cc_7866 ( N_noxref_21_c_11934_p N_noxref_22_c_12727_n ) capacitor \
 c=0.00470299f //x=94.815 //y=4.975 //x2=95.6 //y2=4.885
cc_7867 ( N_noxref_21_M178_noxref_g N_noxref_23_c_12994_n ) capacitor \
 c=0.00969448f //x=95.18 //y=6.205 //x2=95.715 //y2=5.39
cc_7868 ( N_noxref_21_c_11921_p N_noxref_23_c_12995_n ) capacitor c=8.0528e-19 \
 //x=94.47 //y=2.43 //x2=96.32 //y2=4.095
cc_7869 ( N_noxref_21_c_11669_n N_noxref_23_c_12995_n ) capacitor \
 c=0.00363479f //x=94.47 //y=4.755 //x2=96.32 //y2=4.095
cc_7870 ( N_noxref_21_c_11669_n N_noxref_23_c_12997_n ) capacitor \
 c=0.00136963f //x=94.47 //y=4.755 //x2=96.32 //y2=5.305
cc_7871 ( N_noxref_21_c_11860_n N_noxref_23_c_12998_n ) capacitor \
 c=3.61332e-19 //x=85.845 //y=1.305 //x2=89.22 //y2=1.36
cc_7872 ( N_noxref_21_c_11866_n N_noxref_23_c_12998_n ) capacitor \
 c=0.00113094f //x=85.845 //y=1.76 //x2=89.22 //y2=1.36
cc_7873 ( N_noxref_21_c_11672_n N_noxref_23_c_12998_n ) capacitor \
 c=0.00995537f //x=92.825 //y=2.4 //x2=89.22 //y2=1.36
cc_7874 ( N_noxref_21_c_11672_n N_noxref_23_c_13001_n ) capacitor \
 c=0.00925691f //x=92.825 //y=2.4 //x2=92.55 //y2=1.36
cc_7875 ( N_noxref_21_c_11695_n N_noxref_23_c_13001_n ) capacitor \
 c=5.10033e-19 //x=92.285 //y=1.085 //x2=92.55 //y2=1.36
cc_7876 ( N_noxref_21_c_11698_n N_noxref_23_c_13001_n ) capacitor \
 c=0.00606483f //x=92.285 //y=1.43 //x2=92.55 //y2=1.36
cc_7877 ( N_noxref_21_c_11994_p N_noxref_23_c_13001_n ) capacitor \
 c=4.65567e-19 //x=92.66 //y=0.93 //x2=92.55 //y2=1.36
cc_7878 ( N_noxref_21_c_11995_p N_noxref_23_c_13001_n ) capacitor \
 c=0.00247382f //x=92.66 //y=1.585 //x2=92.55 //y2=1.36
cc_7879 ( N_noxref_21_c_11704_n N_noxref_23_c_13001_n ) capacitor \
 c=2.15736e-19 //x=92.815 //y=1.085 //x2=92.55 //y2=1.36
cc_7880 ( N_noxref_21_c_11705_n N_noxref_23_c_13001_n ) capacitor \
 c=0.00259159f //x=92.815 //y=1.43 //x2=92.55 //y2=1.36
cc_7881 ( N_noxref_21_c_11706_n N_noxref_23_c_13001_n ) capacitor \
 c=0.00150348f //x=92.815 //y=1.74 //x2=92.55 //y2=1.36
cc_7882 ( N_noxref_21_M177_noxref_g N_noxref_23_c_13009_n ) capacitor \
 c=0.00363978f //x=94.74 //y=6.205 //x2=94.96 //y2=5.39
cc_7883 ( N_noxref_21_M178_noxref_g N_noxref_23_c_13009_n ) capacitor \
 c=0.00185829f //x=95.18 //y=6.205 //x2=94.96 //y2=5.39
cc_7884 ( N_noxref_21_c_11933_p N_noxref_23_c_13009_n ) capacitor c=0.0021827f \
 //x=95.105 //y=4.975 //x2=94.96 //y2=5.39
cc_7885 ( N_noxref_21_c_11672_n N_noxref_23_c_13012_n ) capacitor c=0.0111982f \
 //x=92.825 //y=2.4 //x2=89.385 //y2=1.405
cc_7886 ( N_noxref_21_c_11672_n N_noxref_23_c_12990_n ) capacitor c=0.0989427f \
 //x=92.825 //y=2.4 //x2=92.42 //y2=1.405
cc_7887 ( N_noxref_21_c_11698_n N_noxref_23_c_12990_n ) capacitor \
 c=0.00142222f //x=92.285 //y=1.43 //x2=92.42 //y2=1.405
cc_7888 ( N_noxref_21_c_11672_n N_noxref_23_c_13015_n ) capacitor \
 c=0.00889668f //x=92.825 //y=2.4 //x2=92.68 //y2=1.405
cc_7889 ( N_noxref_21_c_11661_n N_noxref_23_c_13016_n ) capacitor \
 c=0.00831552f //x=92.99 //y=2.43 //x2=95.715 //y2=1.405
cc_7890 ( N_noxref_21_c_11921_p N_noxref_23_c_13016_n ) capacitor \
 c=0.00831552f //x=94.47 //y=2.43 //x2=95.715 //y2=1.405
cc_7891 ( N_noxref_21_c_11672_n N_noxref_23_c_13016_n ) capacitor \
 c=0.00484787f //x=92.825 //y=2.4 //x2=95.715 //y2=1.405
cc_7892 ( N_noxref_21_c_11684_n N_noxref_23_c_13016_n ) capacitor c=0.013262f \
 //x=93.155 //y=2.26 //x2=95.715 //y2=1.405
cc_7893 ( N_noxref_21_c_11922_p N_noxref_23_c_13016_n ) capacitor c=0.0128597f \
 //x=94.465 //y=2.27 //x2=95.715 //y2=1.405
cc_7894 ( N_noxref_21_c_11953_p N_noxref_23_c_13016_n ) capacitor c=0.0434154f \
 //x=94.305 //y=2.27 //x2=95.715 //y2=1.405
cc_7895 ( N_noxref_21_c_11705_n N_noxref_23_c_13016_n ) capacitor \
 c=0.00215337f //x=92.815 //y=1.43 //x2=95.715 //y2=1.405
cc_7896 ( N_noxref_21_c_11706_n N_noxref_23_c_13016_n ) capacitor \
 c=0.00127059f //x=92.815 //y=1.74 //x2=95.715 //y2=1.405
cc_7897 ( N_noxref_21_c_11966_p N_noxref_23_c_13016_n ) capacitor \
 c=0.00277413f //x=94.645 //y=1.39 //x2=95.715 //y2=1.405
cc_7898 ( N_noxref_21_c_11968_p N_noxref_23_c_13016_n ) capacitor \
 c=0.00245466f //x=94.645 //y=1.7 //x2=95.715 //y2=1.405
cc_7899 ( N_noxref_21_c_11969_p N_noxref_23_c_13016_n ) capacitor \
 c=0.00460244f //x=95.175 //y=1.39 //x2=95.715 //y2=1.405
cc_7900 ( N_noxref_21_M177_noxref_g N_noxref_23_c_13027_n ) capacitor \
 c=0.0120591f //x=94.74 //y=6.205 //x2=94.96 //y2=5.56
cc_7901 ( N_noxref_21_M178_noxref_g N_noxref_23_c_13027_n ) capacitor \
 c=0.0142133f //x=95.18 //y=6.205 //x2=94.96 //y2=5.56
cc_7902 ( N_noxref_21_c_11933_p N_noxref_23_c_13027_n ) capacitor \
 c=0.00293135f //x=95.105 //y=4.975 //x2=94.96 //y2=5.56
cc_7903 ( N_noxref_21_c_11695_n N_noxref_23_M57_noxref_d ) capacitor \
 c=0.00217566f //x=92.285 //y=1.085 //x2=92.36 //y2=1.085
cc_7904 ( N_noxref_21_c_11698_n N_noxref_23_M57_noxref_d ) capacitor \
 c=0.00693963f //x=92.285 //y=1.43 //x2=92.36 //y2=1.085
cc_7905 ( N_noxref_21_c_11994_p N_noxref_23_M57_noxref_d ) capacitor \
 c=0.00234223f //x=92.66 //y=0.93 //x2=92.36 //y2=1.085
cc_7906 ( N_noxref_21_c_11995_p N_noxref_23_M57_noxref_d ) capacitor \
 c=0.00513213f //x=92.66 //y=1.585 //x2=92.36 //y2=1.085
cc_7907 ( N_noxref_21_c_11704_n N_noxref_23_M57_noxref_d ) capacitor \
 c=0.00132245f //x=92.815 //y=1.085 //x2=92.36 //y2=1.085
cc_7908 ( N_noxref_21_c_11705_n N_noxref_23_M57_noxref_d ) capacitor \
 c=0.00326247f //x=92.815 //y=1.43 //x2=92.36 //y2=1.085
cc_7909 ( N_noxref_21_c_11706_n N_noxref_23_M57_noxref_d ) capacitor \
 c=0.00231463f //x=92.815 //y=1.74 //x2=92.36 //y2=1.085
cc_7910 ( N_noxref_21_c_11756_n N_VDD_c_13434_n ) capacitor c=0.00621329f \
 //x=84.55 //y=5.335 //x2=87.775 //y2=7.585
cc_7911 ( N_noxref_21_c_11828_n N_VDD_c_13434_n ) capacitor c=0.00627186f \
 //x=85.435 //y=5.335 //x2=87.775 //y2=7.585
cc_7912 ( N_noxref_21_c_11854_n N_VDD_c_13434_n ) capacitor c=0.00256019f \
 //x=85.55 //y=5.56 //x2=87.775 //y2=7.585
cc_7913 ( N_noxref_21_c_11653_n N_VDD_c_13434_n ) capacitor c=0.00824067f \
 //x=86.245 //y=5.335 //x2=87.775 //y2=7.585
cc_7914 ( N_noxref_21_c_11670_n N_VDD_c_13434_n ) capacitor c=0.00261804f \
 //x=83.792 //y=5.335 //x2=87.775 //y2=7.585
cc_7915 ( N_noxref_21_c_11671_n N_VDD_c_13434_n ) capacitor c=0.00270108f \
 //x=84.67 //y=5.335 //x2=87.775 //y2=7.585
cc_7916 ( N_noxref_21_c_11788_n N_VDD_c_13434_n ) capacitor c=0.0024232f \
 //x=83.79 //y=5.56 //x2=87.775 //y2=7.585
cc_7917 ( N_noxref_21_c_11847_n N_VDD_c_13434_n ) capacitor c=0.0024232f \
 //x=84.67 //y=5.56 //x2=87.775 //y2=7.585
cc_7918 ( N_noxref_21_c_11903_n N_VDD_c_13434_n ) capacitor c=0.0024232f \
 //x=85.55 //y=5.56 //x2=87.775 //y2=7.585
cc_7919 ( N_noxref_21_M161_noxref_g N_VDD_c_14443_n ) capacitor c=0.00755544f \
 //x=80.52 //y=6.2 //x2=81.095 //y2=7.585
cc_7920 ( N_noxref_21_M162_noxref_g N_VDD_c_14443_n ) capacitor c=0.00755754f \
 //x=80.96 //y=6.2 //x2=81.095 //y2=7.585
cc_7921 ( N_noxref_21_c_11756_n N_VDD_c_14448_n ) capacitor c=0.00202922f \
 //x=84.55 //y=5.335 //x2=84.145 //y2=7.585
cc_7922 ( N_noxref_21_c_11670_n N_VDD_c_14448_n ) capacitor c=9.3757e-19 \
 //x=83.792 //y=5.335 //x2=84.145 //y2=7.585
cc_7923 ( N_noxref_21_c_11788_n N_VDD_c_14448_n ) capacitor c=0.0138074f \
 //x=83.79 //y=5.56 //x2=84.145 //y2=7.585
cc_7924 ( N_noxref_21_c_11756_n N_VDD_c_14488_n ) capacitor c=0.0017708f \
 //x=84.55 //y=5.335 //x2=85.025 //y2=7.585
cc_7925 ( N_noxref_21_c_11828_n N_VDD_c_14488_n ) capacitor c=0.00202922f \
 //x=85.435 //y=5.335 //x2=85.025 //y2=7.585
cc_7926 ( N_noxref_21_c_11671_n N_VDD_c_14488_n ) capacitor c=9.4822e-19 \
 //x=84.67 //y=5.335 //x2=85.025 //y2=7.585
cc_7927 ( N_noxref_21_c_11847_n N_VDD_c_14488_n ) capacitor c=0.0138074f \
 //x=84.67 //y=5.56 //x2=85.025 //y2=7.585
cc_7928 ( N_noxref_21_c_11828_n N_VDD_c_14528_n ) capacitor c=0.00205906f \
 //x=85.435 //y=5.335 //x2=85.905 //y2=7.585
cc_7929 ( N_noxref_21_c_11854_n N_VDD_c_14528_n ) capacitor c=8.49654e-19 \
 //x=85.55 //y=5.56 //x2=85.905 //y2=7.585
cc_7930 ( N_noxref_21_c_11653_n N_VDD_c_14528_n ) capacitor c=0.00204238f \
 //x=86.245 //y=5.335 //x2=85.905 //y2=7.585
cc_7931 ( N_noxref_21_c_11903_n N_VDD_c_14528_n ) capacitor c=0.0135103f \
 //x=85.55 //y=5.56 //x2=85.905 //y2=7.585
cc_7932 ( N_noxref_21_c_11653_n N_VDD_c_14581_n ) capacitor c=0.00183742f \
 //x=86.245 //y=5.335 //x2=86.9 //y2=7.585
cc_7933 ( N_noxref_21_M175_noxref_g N_VDD_c_13760_n ) capacitor c=0.00782837f \
 //x=92.28 //y=6.205 //x2=93.56 //y2=7.585
cc_7934 ( N_noxref_21_M176_noxref_g N_VDD_c_13760_n ) capacitor c=0.00782837f \
 //x=92.72 //y=6.205 //x2=93.56 //y2=7.585
cc_7935 ( N_noxref_21_M177_noxref_g N_VDD_c_14584_n ) capacitor c=0.00782837f \
 //x=94.74 //y=6.205 //x2=96.89 //y2=7.585
cc_7936 ( N_noxref_21_M178_noxref_g N_VDD_c_14584_n ) capacitor c=0.00782837f \
 //x=95.18 //y=6.205 //x2=96.89 //y2=7.585
cc_7937 ( N_noxref_21_c_11670_n N_VDD_c_13787_n ) capacitor c=0.0022955f \
 //x=83.792 //y=5.335 //x2=82.26 //y2=7.585
cc_7938 ( N_noxref_21_c_11726_n N_VDD_c_13787_n ) capacitor c=0.00224736f \
 //x=80.78 //y=4.88 //x2=82.26 //y2=7.585
cc_7939 ( N_noxref_21_c_11788_n N_VDD_c_13787_n ) capacitor c=0.00509469f \
 //x=83.79 //y=5.56 //x2=82.26 //y2=7.585
cc_7940 ( N_noxref_21_c_11739_n N_VDD_c_13787_n ) capacitor c=2.63786e-19 \
 //x=80.78 //y=4.88 //x2=82.26 //y2=7.585
cc_7941 ( N_noxref_21_c_11854_n N_VDD_c_13788_n ) capacitor c=0.00269575f \
 //x=85.55 //y=5.56 //x2=87.07 //y2=7.585
cc_7942 ( N_noxref_21_c_11657_n N_VDD_c_13788_n ) capacitor c=0.0313739f \
 //x=86.33 //y=5.25 //x2=87.07 //y2=7.585
cc_7943 ( N_noxref_21_c_11672_n N_VDD_c_13788_n ) capacitor c=0.00158348f \
 //x=92.825 //y=2.4 //x2=87.07 //y2=7.585
cc_7944 ( N_noxref_21_c_11903_n N_VDD_c_13788_n ) capacitor c=0.00775197f \
 //x=85.55 //y=5.56 //x2=87.07 //y2=7.585
cc_7945 ( N_noxref_21_c_11664_n N_VDD_c_13800_n ) capacitor c=0.0156004f \
 //x=92.99 //y=4.76 //x2=93.73 //y2=7.585
cc_7946 ( N_noxref_21_c_11669_n N_VDD_c_13800_n ) capacitor c=0.0163412f \
 //x=94.47 //y=4.755 //x2=93.73 //y2=7.585
cc_7947 ( N_noxref_21_c_11689_n N_VDD_c_13800_n ) capacitor c=0.00790417f \
 //x=92.99 //y=4.885 //x2=93.73 //y2=7.585
cc_7948 ( N_noxref_21_c_11932_p N_VDD_c_13800_n ) capacitor c=0.00790205f \
 //x=94.47 //y=4.885 //x2=93.73 //y2=7.585
cc_7949 ( N_noxref_21_M176_noxref_g N_VDD_c_13800_n ) capacitor c=0.0132093f \
 //x=92.72 //y=6.205 //x2=93.73 //y2=7.585
cc_7950 ( N_noxref_21_M177_noxref_g N_VDD_c_13800_n ) capacitor c=0.00855037f \
 //x=94.74 //y=6.205 //x2=93.73 //y2=7.585
cc_7951 ( N_noxref_21_c_11702_n N_VDD_c_13800_n ) capacitor c=0.00722671f \
 //x=92.72 //y=5.05 //x2=93.73 //y2=7.585
cc_7952 ( N_noxref_21_c_11934_p N_VDD_c_13800_n ) capacitor c=0.00720105f \
 //x=94.815 //y=4.975 //x2=93.73 //y2=7.585
cc_7953 ( N_noxref_21_M161_noxref_g N_VDD_M160_noxref_d ) capacitor \
 c=0.015318f //x=80.52 //y=6.2 //x2=80.155 //y2=5.2
cc_7954 ( N_noxref_21_M162_noxref_g N_VDD_M162_noxref_d ) capacitor \
 c=0.0394719f //x=80.96 //y=6.2 //x2=81.035 //y2=5.2
cc_7955 ( N_noxref_21_c_11670_n N_VDD_M163_noxref_s ) capacitor c=0.0441176f \
 //x=83.792 //y=5.335 //x2=83.215 //y2=5.2
cc_7956 ( N_noxref_21_c_11671_n N_VDD_M163_noxref_s ) capacitor c=7.80122e-19 \
 //x=84.67 //y=5.335 //x2=83.215 //y2=5.2
cc_7957 ( N_noxref_21_c_11788_n N_VDD_M163_noxref_s ) capacitor c=0.09305f \
 //x=83.79 //y=5.56 //x2=83.215 //y2=5.2
cc_7958 ( N_noxref_21_c_11756_n N_VDD_M164_noxref_d ) capacitor c=0.00700141f \
 //x=84.55 //y=5.335 //x2=84.085 //y2=5.2
cc_7959 ( N_noxref_21_c_11788_n N_VDD_M164_noxref_d ) capacitor c=0.0674491f \
 //x=83.79 //y=5.56 //x2=84.085 //y2=5.2
cc_7960 ( N_noxref_21_c_11847_n N_VDD_M164_noxref_d ) capacitor c=0.0674762f \
 //x=84.67 //y=5.56 //x2=84.085 //y2=5.2
cc_7961 ( N_noxref_21_c_11828_n N_VDD_M166_noxref_d ) capacitor c=0.00700141f \
 //x=85.435 //y=5.335 //x2=84.965 //y2=5.2
cc_7962 ( N_noxref_21_c_11847_n N_VDD_M166_noxref_d ) capacitor c=0.0674034f \
 //x=84.67 //y=5.56 //x2=84.965 //y2=5.2
cc_7963 ( N_noxref_21_c_11903_n N_VDD_M166_noxref_d ) capacitor c=0.067364f \
 //x=85.55 //y=5.56 //x2=84.965 //y2=5.2
cc_7964 ( N_noxref_21_c_11653_n N_VDD_M168_noxref_d ) capacitor c=0.00700141f \
 //x=86.245 //y=5.335 //x2=85.845 //y2=5.2
cc_7965 ( N_noxref_21_c_11903_n N_VDD_M168_noxref_d ) capacitor c=0.067249f \
 //x=85.55 //y=5.56 //x2=85.845 //y2=5.2
cc_7966 ( N_noxref_21_c_11854_n N_VDD_M169_noxref_s ) capacitor c=0.00539362f \
 //x=85.55 //y=5.56 //x2=87.725 //y2=5.205
cc_7967 ( N_noxref_21_c_11653_n N_VDD_M169_noxref_s ) capacitor c=0.00177198f \
 //x=86.245 //y=5.335 //x2=87.725 //y2=5.205
cc_7968 ( N_noxref_21_c_11711_n N_noxref_42_c_15978_n ) capacitor c=0.002059f \
 //x=80.78 //y=2.485 //x2=81.435 //y2=0.72
cc_7969 ( N_noxref_21_c_11723_n N_noxref_42_c_15978_n ) capacitor \
 c=0.00117306f //x=80.78 //y=2.26 //x2=81.435 //y2=0.72
cc_7970 ( N_noxref_21_c_11733_n N_noxref_42_c_15978_n ) capacitor c=0.0206349f \
 //x=80.77 //y=1.095 //x2=81.435 //y2=0.72
cc_7971 ( N_noxref_21_c_11809_n N_noxref_42_c_15978_n ) capacitor \
 c=0.00825432f //x=81.3 //y=1.095 //x2=81.435 //y2=0.72
cc_7972 ( N_noxref_21_c_11736_n N_noxref_42_c_15978_n ) capacitor \
 c=2.20712e-19 //x=80.78 //y=2.26 //x2=81.435 //y2=0.72
cc_7973 ( N_noxref_21_c_11734_n N_noxref_42_c_15981_n ) capacitor c=0.0071177f \
 //x=80.77 //y=1.44 //x2=80.55 //y2=1.175
cc_7974 ( N_noxref_21_c_11711_n N_noxref_42_M50_noxref_s ) capacitor \
 c=0.00110956f //x=80.78 //y=2.485 //x2=80.415 //y2=0.555
cc_7975 ( N_noxref_21_c_11733_n N_noxref_42_M50_noxref_s ) capacitor \
 c=0.0071177f //x=80.77 //y=1.095 //x2=80.415 //y2=0.555
cc_7976 ( N_noxref_21_c_11735_n N_noxref_42_M50_noxref_s ) capacitor \
 c=0.0071177f //x=80.77 //y=1.75 //x2=80.415 //y2=0.555
cc_7977 ( N_noxref_21_c_11809_n N_noxref_42_M50_noxref_s ) capacitor \
 c=0.015333f //x=81.3 //y=1.095 //x2=80.415 //y2=0.555
cc_7978 ( N_noxref_21_c_11811_n N_noxref_42_M50_noxref_s ) capacitor \
 c=0.00248746f //x=81.3 //y=1.44 //x2=80.415 //y2=0.555
cc_7979 ( N_noxref_21_c_11681_n N_noxref_43_c_16030_n ) capacitor \
 c=0.00519491f //x=86.485 //y=2.4 //x2=85.275 //y2=1.175
cc_7980 ( N_noxref_21_c_11860_n N_noxref_43_c_16046_n ) capacitor c=0.0036878f \
 //x=85.845 //y=1.305 //x2=86.245 //y2=0.72
cc_7981 ( N_noxref_21_c_11871_n N_noxref_43_c_16046_n ) capacitor \
 c=0.00399931f //x=86.245 //y=1.845 //x2=86.245 //y2=0.72
cc_7982 ( N_noxref_21_c_11681_n N_noxref_43_c_16046_n ) capacitor \
 c=5.06634e-19 //x=86.485 //y=2.4 //x2=86.245 //y2=0.72
cc_7983 ( N_noxref_21_M53_noxref_d N_noxref_43_c_16046_n ) capacitor \
 c=0.00910163f //x=85.655 //y=1.095 //x2=86.245 //y2=0.72
cc_7984 ( N_noxref_21_M53_noxref_d N_noxref_43_c_16051_n ) capacitor \
 c=0.00120711f //x=85.655 //y=1.095 //x2=85.36 //y2=1.175
cc_7985 ( N_noxref_21_c_11756_n N_noxref_43_M52_noxref_d ) capacitor \
 c=9.1568e-19 //x=84.55 //y=5.335 //x2=84.12 //y2=1.09
cc_7986 ( N_noxref_21_c_11860_n N_noxref_43_M52_noxref_d ) capacitor \
 c=0.00802836f //x=85.845 //y=1.305 //x2=84.12 //y2=1.09
cc_7987 ( N_noxref_21_c_11681_n N_noxref_43_M52_noxref_d ) capacitor \
 c=0.00673057f //x=86.485 //y=2.4 //x2=84.12 //y2=1.09
cc_7988 ( N_noxref_21_c_11860_n N_noxref_43_M53_noxref_s ) capacitor \
 c=0.00993921f //x=85.845 //y=1.305 //x2=85.225 //y2=0.555
cc_7989 ( N_noxref_21_c_11866_n N_noxref_43_M53_noxref_s ) capacitor \
 c=0.0271229f //x=85.845 //y=1.76 //x2=85.225 //y2=0.555
cc_7990 ( N_noxref_21_c_11871_n N_noxref_43_M53_noxref_s ) capacitor \
 c=0.00663394f //x=86.245 //y=1.845 //x2=85.225 //y2=0.555
cc_7991 ( N_noxref_21_c_11891_n N_noxref_43_M53_noxref_s ) capacitor \
 c=0.00592116f //x=86.33 //y=2.4 //x2=85.225 //y2=0.555
cc_7992 ( N_noxref_21_c_11681_n N_noxref_43_M53_noxref_s ) capacitor \
 c=0.00471087f //x=86.485 //y=2.4 //x2=85.225 //y2=0.555
cc_7993 ( N_noxref_21_M53_noxref_d N_noxref_43_M53_noxref_s ) capacitor \
 c=0.0279003f //x=85.655 //y=1.095 //x2=85.225 //y2=0.555
cc_7994 ( N_noxref_21_c_11653_n N_noxref_44_c_16103_n ) capacitor \
 c=4.26706e-19 //x=86.245 //y=5.335 //x2=89.295 //y2=5.39
cc_7995 ( N_noxref_21_M175_noxref_g N_noxref_44_c_16127_n ) capacitor \
 c=0.00814026f //x=92.28 //y=6.205 //x2=92.825 //y2=7.09
cc_7996 ( N_noxref_21_M176_noxref_g N_noxref_44_c_16127_n ) capacitor \
 c=0.00937408f //x=92.72 //y=6.205 //x2=92.825 //y2=7.09
cc_7997 ( N_noxref_21_c_11854_n N_noxref_44_c_16110_n ) capacitor \
 c=5.91187e-19 //x=85.55 //y=5.56 //x2=88.302 //y2=5.39
cc_7998 ( N_noxref_21_c_11653_n N_noxref_44_c_16110_n ) capacitor \
 c=6.63525e-19 //x=86.245 //y=5.335 //x2=88.302 //y2=5.39
cc_7999 ( N_noxref_21_M175_noxref_g N_noxref_44_c_16115_n ) capacitor \
 c=0.0017976f //x=92.28 //y=6.205 //x2=92.057 //y2=7.09
cc_8000 ( N_noxref_21_M176_noxref_g N_noxref_44_c_16132_n ) capacitor \
 c=0.00395674f //x=92.72 //y=6.205 //x2=92.94 //y2=6.92
cc_8001 ( N_noxref_21_M175_noxref_g N_noxref_44_M174_noxref_d ) capacitor \
 c=0.0142133f //x=92.28 //y=6.205 //x2=91.915 //y2=5.205
cc_8002 ( N_noxref_21_c_11689_n N_noxref_44_M176_noxref_d ) capacitor \
 c=0.00256087f //x=92.99 //y=4.885 //x2=92.795 //y2=5.205
cc_8003 ( N_noxref_21_M176_noxref_g N_noxref_44_M176_noxref_d ) capacitor \
 c=0.0365939f //x=92.72 //y=6.205 //x2=92.795 //y2=5.205
cc_8004 ( N_noxref_21_c_11702_n N_noxref_44_M176_noxref_d ) capacitor \
 c=0.00447202f //x=92.72 //y=5.05 //x2=92.795 //y2=5.205
cc_8005 ( N_noxref_21_M175_noxref_g N_noxref_45_c_16258_n ) capacitor \
 c=0.00998198f //x=92.28 //y=6.205 //x2=92.385 //y2=5.39
cc_8006 ( N_noxref_21_c_11661_n N_noxref_45_c_16271_n ) capacitor \
 c=0.00143791f //x=92.99 //y=2.43 //x2=94.405 //y2=5.39
cc_8007 ( N_noxref_21_c_11664_n N_noxref_45_c_16271_n ) capacitor c=0.0227143f \
 //x=92.99 //y=4.76 //x2=94.405 //y2=5.39
cc_8008 ( N_noxref_21_c_11921_p N_noxref_45_c_16271_n ) capacitor \
 c=0.00141341f //x=94.47 //y=2.43 //x2=94.405 //y2=5.39
cc_8009 ( N_noxref_21_c_11669_n N_noxref_45_c_16271_n ) capacitor c=0.0274606f \
 //x=94.47 //y=4.755 //x2=94.405 //y2=5.39
cc_8010 ( N_noxref_21_c_11689_n N_noxref_45_c_16271_n ) capacitor c=0.0035251f \
 //x=92.99 //y=4.885 //x2=94.405 //y2=5.39
cc_8011 ( N_noxref_21_c_11932_p N_noxref_45_c_16271_n ) capacitor \
 c=0.00429429f //x=94.47 //y=4.885 //x2=94.405 //y2=5.39
cc_8012 ( N_noxref_21_M176_noxref_g N_noxref_45_c_16271_n ) capacitor \
 c=0.0119434f //x=92.72 //y=6.205 //x2=94.405 //y2=5.39
cc_8013 ( N_noxref_21_M177_noxref_g N_noxref_45_c_16271_n ) capacitor \
 c=0.00372569f //x=94.74 //y=6.205 //x2=94.405 //y2=5.39
cc_8014 ( N_noxref_21_c_11702_n N_noxref_45_c_16271_n ) capacitor \
 c=0.00500633f //x=92.72 //y=5.05 //x2=94.405 //y2=5.39
cc_8015 ( N_noxref_21_c_11934_p N_noxref_45_c_16271_n ) capacitor \
 c=0.00243015f //x=94.815 //y=4.975 //x2=94.405 //y2=5.39
cc_8016 ( N_noxref_21_M175_noxref_g N_noxref_45_c_16281_n ) capacitor \
 c=6.12451e-19 //x=92.28 //y=6.205 //x2=92.615 //y2=5.39
cc_8017 ( N_noxref_21_M176_noxref_g N_noxref_45_c_16281_n ) capacitor \
 c=8.33934e-19 //x=92.72 //y=6.205 //x2=92.615 //y2=5.39
cc_8018 ( N_noxref_21_M177_noxref_g N_noxref_45_c_16283_n ) capacitor \
 c=0.0109238f //x=94.74 //y=6.205 //x2=95.285 //y2=7.09
cc_8019 ( N_noxref_21_M178_noxref_g N_noxref_45_c_16283_n ) capacitor \
 c=0.00814026f //x=95.18 //y=6.205 //x2=95.285 //y2=7.09
cc_8020 ( N_noxref_21_M177_noxref_g N_noxref_45_c_16285_n ) capacitor \
 c=0.00394587f //x=94.74 //y=6.205 //x2=94.52 //y2=6.92
cc_8021 ( N_noxref_21_M178_noxref_g N_noxref_45_c_16286_n ) capacitor \
 c=0.00179267f //x=95.18 //y=6.205 //x2=95.4 //y2=7.09
cc_8022 ( N_noxref_21_M175_noxref_g N_noxref_45_c_16287_n ) capacitor \
 c=0.0179771f //x=92.28 //y=6.205 //x2=92.5 //y2=5.39
cc_8023 ( N_noxref_21_M176_noxref_g N_noxref_45_c_16287_n ) capacitor \
 c=0.0171712f //x=92.72 //y=6.205 //x2=92.5 //y2=5.39
cc_8024 ( N_noxref_21_c_12141_p N_noxref_45_c_16287_n ) capacitor \
 c=0.00438178f //x=92.645 //y=4.975 //x2=92.5 //y2=5.39
cc_8025 ( N_noxref_21_c_11669_n N_noxref_45_c_16290_n ) capacitor \
 c=0.00533094f //x=94.47 //y=4.755 //x2=94.52 //y2=5.39
cc_8026 ( N_noxref_21_c_11932_p N_noxref_45_c_16290_n ) capacitor c=0.013929f \
 //x=94.47 //y=4.885 //x2=94.52 //y2=5.39
cc_8027 ( N_noxref_21_M177_noxref_g N_noxref_45_c_16290_n ) capacitor \
 c=0.0510602f //x=94.74 //y=6.205 //x2=94.52 //y2=5.39
cc_8028 ( N_noxref_21_c_11934_p N_noxref_45_c_16290_n ) capacitor \
 c=0.00827092f //x=94.815 //y=4.975 //x2=94.52 //y2=5.39
cc_8029 ( N_noxref_21_M178_noxref_g N_noxref_45_M178_noxref_d ) capacitor \
 c=0.0142133f //x=95.18 //y=6.205 //x2=95.255 //y2=5.205
cc_8030 ( N_noxref_21_c_11711_n N_GND_c_17141_n ) capacitor c=0.00216989f \
 //x=80.78 //y=2.485 //x2=83.25 //y2=0.175
cc_8031 ( N_noxref_21_c_11767_n N_GND_c_17141_n ) capacitor c=0.0617905f \
 //x=81.735 //y=2.37 //x2=83.25 //y2=0.175
cc_8032 ( N_noxref_21_c_11721_n N_GND_c_17141_n ) capacitor c=0.00561641f \
 //x=80.77 //y=2.325 //x2=83.25 //y2=0.175
cc_8033 ( N_noxref_21_c_11860_n N_GND_c_16607_n ) capacitor c=0.00878689f \
 //x=85.845 //y=1.305 //x2=88.165 //y2=0.175
cc_8034 ( N_noxref_21_c_11871_n N_GND_c_16607_n ) capacitor c=0.00661622f \
 //x=86.245 //y=1.845 //x2=88.165 //y2=0.175
cc_8035 ( N_noxref_21_c_11655_n N_GND_c_16607_n ) capacitor c=2.38581e-19 \
 //x=86.33 //y=2.565 //x2=88.165 //y2=0.175
cc_8036 ( N_noxref_21_c_11672_n N_GND_c_16607_n ) capacitor c=0.0589567f \
 //x=92.825 //y=2.4 //x2=88.165 //y2=0.175
cc_8037 ( N_noxref_21_c_11681_n N_GND_c_16607_n ) capacitor c=0.0646569f \
 //x=86.485 //y=2.4 //x2=88.165 //y2=0.175
cc_8038 ( N_noxref_21_M53_noxref_d N_GND_c_16607_n ) capacitor c=2.9462e-19 \
 //x=85.655 //y=1.095 //x2=88.165 //y2=0.175
cc_8039 ( N_noxref_21_c_11860_n N_GND_c_16608_n ) capacitor c=0.00482429f \
 //x=85.845 //y=1.305 //x2=88.25 //y2=1.015
cc_8040 ( N_noxref_21_c_11672_n N_GND_c_16608_n ) capacitor c=0.00909714f \
 //x=92.825 //y=2.4 //x2=88.25 //y2=1.015
cc_8041 ( N_noxref_21_c_11672_n N_GND_c_17290_n ) capacitor c=0.0156784f \
 //x=92.825 //y=2.4 //x2=91.495 //y2=0.175
cc_8042 ( N_noxref_21_c_11661_n N_GND_c_17291_n ) capacitor c=9.61971e-19 \
 //x=92.99 //y=2.43 //x2=94.825 //y2=0.175
cc_8043 ( N_noxref_21_c_11921_p N_GND_c_17291_n ) capacitor c=0.00100426f \
 //x=94.47 //y=2.43 //x2=94.825 //y2=0.175
cc_8044 ( N_noxref_21_c_11923_p N_GND_c_17291_n ) capacitor c=2.64659e-19 \
 //x=94.47 //y=2.26 //x2=94.825 //y2=0.175
cc_8045 ( N_noxref_21_c_11965_p N_GND_c_17294_n ) capacitor c=0.00175484f \
 //x=94.645 //y=1.045 //x2=94.91 //y2=1.02
cc_8046 ( N_noxref_21_c_11966_p N_GND_c_17294_n ) capacitor c=0.00372705f \
 //x=94.645 //y=1.39 //x2=94.91 //y2=1.02
cc_8047 ( N_noxref_21_c_11968_p N_GND_c_17294_n ) capacitor c=3.99385e-19 \
 //x=94.645 //y=1.7 //x2=94.91 //y2=1.02
cc_8048 ( N_noxref_21_c_12165_p N_GND_c_17294_n ) capacitor c=0.00924233f \
 //x=95.02 //y=0.89 //x2=94.91 //y2=1.02
cc_8049 ( N_noxref_21_c_12166_p N_GND_c_17294_n ) capacitor c=6.20182e-19 \
 //x=95.02 //y=1.545 //x2=94.91 //y2=1.02
cc_8050 ( N_noxref_21_c_11967_p N_GND_c_17294_n ) capacitor c=0.00181395f \
 //x=95.175 //y=1.045 //x2=94.91 //y2=1.02
cc_8051 ( N_noxref_21_c_11969_p N_GND_c_17294_n ) capacitor c=0.00394995f \
 //x=95.175 //y=1.39 //x2=94.91 //y2=1.02
cc_8052 ( N_noxref_21_c_11775_n N_GND_c_17200_n ) capacitor c=0.00549479f \
 //x=83.58 //y=2.37 //x2=83.335 //y2=1.145
cc_8053 ( N_noxref_21_c_11711_n N_GND_c_17087_n ) capacitor c=2.63788e-19 \
 //x=80.78 //y=2.485 //x2=82.09 //y2=0.175
cc_8054 ( N_noxref_21_c_11871_n N_GND_c_17213_n ) capacitor c=6.86343e-19 \
 //x=86.245 //y=1.845 //x2=86.9 //y2=0.175
cc_8055 ( N_noxref_21_c_11655_n N_GND_c_17213_n ) capacitor c=3.02113e-19 \
 //x=86.33 //y=2.565 //x2=86.9 //y2=0.175
cc_8056 ( N_noxref_21_c_11661_n N_GND_c_16629_n ) capacitor c=9.4179e-19 \
 //x=92.99 //y=2.43 //x2=93.56 //y2=0.175
cc_8057 ( N_noxref_21_c_11921_p N_GND_c_17306_n ) capacitor c=6.59434e-19 \
 //x=94.47 //y=2.43 //x2=96.89 //y2=0.175
cc_8058 ( N_noxref_21_c_11965_p N_GND_c_17306_n ) capacitor c=0.00698682f \
 //x=94.645 //y=1.045 //x2=96.89 //y2=0.175
cc_8059 ( N_noxref_21_c_11767_n N_GND_c_17214_n ) capacitor c=5.59073e-19 \
 //x=81.735 //y=2.37 //x2=82.26 //y2=0.175
cc_8060 ( N_noxref_21_c_11771_n N_GND_c_17214_n ) capacitor c=0.0211306f \
 //x=82.98 //y=2.4 //x2=82.26 //y2=0.175
cc_8061 ( N_noxref_21_c_11723_n N_GND_c_17214_n ) capacitor c=0.0022223f \
 //x=80.78 //y=2.26 //x2=82.26 //y2=0.175
cc_8062 ( N_noxref_21_c_11811_n N_GND_c_17214_n ) capacitor c=0.00262688f \
 //x=81.3 //y=1.44 //x2=82.26 //y2=0.175
cc_8063 ( N_noxref_21_c_11736_n N_GND_c_17214_n ) capacitor c=2.63786e-19 \
 //x=80.78 //y=2.26 //x2=82.26 //y2=0.175
cc_8064 ( N_noxref_21_c_11866_n N_GND_c_16635_n ) capacitor c=0.00484127f \
 //x=85.845 //y=1.76 //x2=87.07 //y2=0.175
cc_8065 ( N_noxref_21_c_11871_n N_GND_c_16635_n ) capacitor c=0.0160224f \
 //x=86.245 //y=1.845 //x2=87.07 //y2=0.175
cc_8066 ( N_noxref_21_c_11655_n N_GND_c_16635_n ) capacitor c=0.00386585f \
 //x=86.33 //y=2.565 //x2=87.07 //y2=0.175
cc_8067 ( N_noxref_21_c_11657_n N_GND_c_16635_n ) capacitor c=0.00983443f \
 //x=86.33 //y=5.25 //x2=87.07 //y2=0.175
cc_8068 ( N_noxref_21_c_11891_n N_GND_c_16635_n ) capacitor c=0.0117342f \
 //x=86.33 //y=2.4 //x2=87.07 //y2=0.175
cc_8069 ( N_noxref_21_c_11672_n N_GND_c_16635_n ) capacitor c=0.0203532f \
 //x=92.825 //y=2.4 //x2=87.07 //y2=0.175
cc_8070 ( N_noxref_21_c_11672_n N_GND_c_16641_n ) capacitor c=0.018578f \
 //x=92.825 //y=2.4 //x2=90.4 //y2=0.175
cc_8071 ( N_noxref_21_c_11685_n N_GND_c_16641_n ) capacitor c=2.56964e-19 \
 //x=92.99 //y=2.26 //x2=90.4 //y2=0.175
cc_8072 ( N_noxref_21_c_11661_n N_GND_c_17321_n ) capacitor c=0.00414357f \
 //x=92.99 //y=2.43 //x2=93.73 //y2=0.175
cc_8073 ( N_noxref_21_c_11664_n N_GND_c_17321_n ) capacitor c=0.0115653f \
 //x=92.99 //y=4.76 //x2=93.73 //y2=0.175
cc_8074 ( N_noxref_21_c_11921_p N_GND_c_17321_n ) capacitor c=0.00414357f \
 //x=94.47 //y=2.43 //x2=93.73 //y2=0.175
cc_8075 ( N_noxref_21_c_11669_n N_GND_c_17321_n ) capacitor c=0.0117547f \
 //x=94.47 //y=4.755 //x2=93.73 //y2=0.175
cc_8076 ( N_noxref_21_c_11684_n N_GND_c_17321_n ) capacitor c=0.0015868f \
 //x=93.155 //y=2.26 //x2=93.73 //y2=0.175
cc_8077 ( N_noxref_21_c_11953_p N_GND_c_17321_n ) capacitor c=0.0153655f \
 //x=94.305 //y=2.27 //x2=93.73 //y2=0.175
cc_8078 ( N_noxref_21_c_11685_n N_GND_c_17321_n ) capacitor c=0.00780676f \
 //x=92.99 //y=2.26 //x2=93.73 //y2=0.175
cc_8079 ( N_noxref_21_c_11923_p N_GND_c_17321_n ) capacitor c=0.00780676f \
 //x=94.47 //y=2.26 //x2=93.73 //y2=0.175
cc_8080 ( N_noxref_21_c_11707_n N_GND_c_17321_n ) capacitor c=0.00967557f \
 //x=92.815 //y=2.095 //x2=93.73 //y2=0.175
cc_8081 ( N_noxref_21_c_11971_p N_GND_c_17321_n ) capacitor c=0.00347725f \
 //x=94.645 //y=2.095 //x2=93.73 //y2=0.175
cc_8082 ( N_noxref_21_c_11924_p N_GND_c_17321_n ) capacitor c=0.00619832f \
 //x=94.47 //y=2.26 //x2=93.73 //y2=0.175
cc_8083 ( N_noxref_21_c_11923_p N_GND_c_17332_n ) capacitor c=2.74348e-19 \
 //x=94.47 //y=2.26 //x2=97.06 //y2=0.175
cc_8084 ( N_noxref_21_c_11965_p N_GND_M58_noxref_d ) capacitor c=0.00192399f \
 //x=94.645 //y=1.045 //x2=94.72 //y2=1.045
cc_8085 ( N_noxref_21_c_11966_p N_GND_M58_noxref_d ) capacitor c=0.00210798f \
 //x=94.645 //y=1.39 //x2=94.72 //y2=1.045
cc_8086 ( N_noxref_21_c_12165_p N_GND_M58_noxref_d ) capacitor c=0.00472259f \
 //x=95.02 //y=0.89 //x2=94.72 //y2=1.045
cc_8087 ( N_noxref_21_c_12166_p N_GND_M58_noxref_d ) capacitor c=0.00166857f \
 //x=95.02 //y=1.545 //x2=94.72 //y2=1.045
cc_8088 ( N_noxref_21_c_11967_p N_GND_M58_noxref_d ) capacitor c=0.00230174f \
 //x=95.175 //y=1.045 //x2=94.72 //y2=1.045
cc_8089 ( N_noxref_21_c_11969_p N_GND_M58_noxref_d ) capacitor c=0.00210798f \
 //x=95.175 //y=1.39 //x2=94.72 //y2=1.045
cc_8090 ( N_noxref_21_c_11771_n N_noxref_64_c_19116_n ) capacitor \
 c=0.00444844f //x=82.98 //y=2.4 //x2=82.85 //y2=1.685
cc_8091 ( N_noxref_21_c_11771_n N_noxref_64_c_19117_n ) capacitor \
 c=0.00812155f //x=82.98 //y=2.4 //x2=83.735 //y2=1.77
cc_8092 ( N_noxref_21_c_11775_n N_noxref_64_c_19117_n ) capacitor \
 c=0.00376977f //x=83.58 //y=2.37 //x2=83.735 //y2=1.77
cc_8093 ( N_noxref_21_c_11681_n N_noxref_64_c_19117_n ) capacitor \
 c=0.00158447f //x=86.485 //y=2.4 //x2=83.735 //y2=1.77
cc_8094 ( N_noxref_21_c_11681_n N_noxref_64_c_19130_n ) capacitor c=0.0123073f \
 //x=86.485 //y=2.4 //x2=84.705 //y2=1.77
cc_8095 ( N_noxref_21_c_11681_n N_noxref_64_M51_noxref_s ) capacitor \
 c=0.00828583f //x=86.485 //y=2.4 //x2=82.715 //y2=0.555
cc_8096 ( N_noxref_21_c_11672_n N_noxref_65_c_19175_n ) capacitor \
 c=4.63368e-19 //x=92.825 //y=2.4 //x2=87.765 //y2=1.675
cc_8097 ( N_noxref_21_c_11672_n N_noxref_65_c_19179_n ) capacitor c=0.015552f \
 //x=92.825 //y=2.4 //x2=88.65 //y2=1.76
cc_8098 ( N_noxref_21_c_11672_n N_noxref_65_c_19187_n ) capacitor \
 c=0.00418562f //x=92.825 //y=2.4 //x2=88.735 //y2=1.675
cc_8099 ( N_noxref_21_c_11672_n N_noxref_65_c_19194_n ) capacitor \
 c=5.76925e-19 //x=92.825 //y=2.4 //x2=89.62 //y2=0.71
cc_8100 ( N_noxref_21_c_11672_n N_noxref_65_M54_noxref_s ) capacitor \
 c=0.00337188f //x=92.825 //y=2.4 //x2=87.63 //y2=0.545
cc_8101 ( N_noxref_21_c_11672_n N_noxref_66_c_19242_n ) capacitor \
 c=0.00320474f //x=92.825 //y=2.4 //x2=91.095 //y2=1.675
cc_8102 ( N_noxref_21_c_11672_n N_noxref_66_c_19243_n ) capacitor \
 c=0.00979979f //x=92.825 //y=2.4 //x2=91.98 //y2=1.76
cc_8103 ( N_noxref_21_c_11672_n N_noxref_66_c_19250_n ) capacitor \
 c=0.00337188f //x=92.825 //y=2.4 //x2=92.065 //y2=1.675
cc_8104 ( N_noxref_21_c_11707_n N_noxref_66_c_19250_n ) capacitor c=0.0028747f \
 //x=92.815 //y=2.095 //x2=92.065 //y2=1.675
cc_8105 ( N_noxref_21_c_11661_n N_noxref_66_c_19258_n ) capacitor \
 c=7.24043e-19 //x=92.99 //y=2.43 //x2=92.95 //y2=0.71
cc_8106 ( N_noxref_21_c_11695_n N_noxref_66_c_19258_n ) capacitor c=0.0214576f \
 //x=92.285 //y=1.085 //x2=92.95 //y2=0.71
cc_8107 ( N_noxref_21_c_11704_n N_noxref_66_c_19258_n ) capacitor \
 c=0.00781103f //x=92.815 //y=1.085 //x2=92.95 //y2=0.71
cc_8108 ( N_noxref_21_c_11661_n N_noxref_66_M56_noxref_s ) capacitor \
 c=0.00472586f //x=92.99 //y=2.43 //x2=90.96 //y2=0.545
cc_8109 ( N_noxref_21_c_11685_n N_noxref_66_M56_noxref_s ) capacitor \
 c=0.010408f //x=92.99 //y=2.26 //x2=90.96 //y2=0.545
cc_8110 ( N_noxref_21_c_11695_n N_noxref_66_M56_noxref_s ) capacitor \
 c=0.00506846f //x=92.285 //y=1.085 //x2=90.96 //y2=0.545
cc_8111 ( N_noxref_21_c_11698_n N_noxref_66_M56_noxref_s ) capacitor \
 c=0.00602248f //x=92.285 //y=1.43 //x2=90.96 //y2=0.545
cc_8112 ( N_noxref_21_c_11704_n N_noxref_66_M56_noxref_s ) capacitor \
 c=0.028957f //x=92.815 //y=1.085 //x2=90.96 //y2=0.545
cc_8113 ( N_noxref_21_c_11706_n N_noxref_66_M56_noxref_s ) capacitor \
 c=0.00369225f //x=92.815 //y=1.74 //x2=90.96 //y2=0.545
cc_8114 ( N_noxref_21_c_11707_n N_noxref_66_M56_noxref_s ) capacitor \
 c=0.00797698f //x=92.815 //y=2.095 //x2=90.96 //y2=0.545
cc_8115 ( N_noxref_21_c_11921_p N_noxref_67_c_19304_n ) capacitor \
 c=0.00472586f //x=94.47 //y=2.43 //x2=94.425 //y2=1.675
cc_8116 ( N_noxref_21_c_11923_p N_noxref_67_c_19304_n ) capacitor c=0.010408f \
 //x=94.47 //y=2.26 //x2=94.425 //y2=1.675
cc_8117 ( N_noxref_21_c_11971_p N_noxref_67_c_19304_n ) capacitor \
 c=0.00262672f //x=94.645 //y=2.095 //x2=94.425 //y2=1.675
cc_8118 ( N_noxref_21_c_11924_p N_noxref_67_c_19304_n ) capacitor \
 c=0.00544234f //x=94.47 //y=2.26 //x2=94.425 //y2=1.675
cc_8119 ( N_noxref_21_c_11921_p N_noxref_67_c_19308_n ) capacitor \
 c=0.00350518f //x=94.47 //y=2.43 //x2=95.31 //y2=1.76
cc_8120 ( N_noxref_21_c_11923_p N_noxref_67_c_19308_n ) capacitor \
 c=0.00305795f //x=94.47 //y=2.26 //x2=95.31 //y2=1.76
cc_8121 ( N_noxref_21_c_11968_p N_noxref_67_c_19308_n ) capacitor \
 c=0.00712798f //x=94.645 //y=1.7 //x2=95.31 //y2=1.76
cc_8122 ( N_noxref_21_c_11971_p N_noxref_67_c_19308_n ) capacitor c=0.013968f \
 //x=94.645 //y=2.095 //x2=95.31 //y2=1.76
cc_8123 ( N_noxref_21_c_12166_p N_noxref_67_c_19308_n ) capacitor \
 c=0.00948889f //x=95.02 //y=1.545 //x2=95.31 //y2=1.76
cc_8124 ( N_noxref_21_c_11969_p N_noxref_67_c_19308_n ) capacitor \
 c=0.00339872f //x=95.175 //y=1.39 //x2=95.31 //y2=1.76
cc_8125 ( N_noxref_21_c_11924_p N_noxref_67_c_19308_n ) capacitor \
 c=0.00168631f //x=94.47 //y=2.26 //x2=95.31 //y2=1.76
cc_8126 ( N_noxref_21_c_11971_p N_noxref_67_c_19315_n ) capacitor \
 c=6.71402e-19 //x=94.645 //y=2.095 //x2=95.395 //y2=1.675
cc_8127 ( N_noxref_21_c_11965_p N_noxref_67_M58_noxref_s ) capacitor \
 c=0.0293163f //x=94.645 //y=1.045 //x2=94.29 //y2=0.545
cc_8128 ( N_noxref_21_c_11968_p N_noxref_67_M58_noxref_s ) capacitor \
 c=0.00110192f //x=94.645 //y=1.7 //x2=94.29 //y2=0.545
cc_8129 ( N_noxref_21_c_11967_p N_noxref_67_M58_noxref_s ) capacitor \
 c=0.0123625f //x=95.175 //y=1.045 //x2=94.29 //y2=0.545
cc_8130 ( N_noxref_22_c_12676_n N_noxref_23_c_12994_n ) capacitor \
 c=0.00435926f //x=95.58 //y=4.37 //x2=95.715 //y2=5.39
cc_8131 ( N_noxref_22_c_12677_n N_noxref_23_c_12994_n ) capacitor c=0.0223378f \
 //x=95.58 //y=4.74 //x2=95.715 //y2=5.39
cc_8132 ( N_noxref_22_c_12692_n N_noxref_23_c_12994_n ) capacitor \
 c=7.70643e-19 //x=95.595 //y=4.21 //x2=95.715 //y2=5.39
cc_8133 ( N_noxref_22_c_12297_n N_noxref_23_c_12994_n ) capacitor c=0.0017832f \
 //x=95.435 //y=4.21 //x2=95.715 //y2=5.39
cc_8134 ( N_noxref_22_c_12705_n N_noxref_23_c_12994_n ) capacitor \
 c=0.00459858f //x=95.6 //y=4.885 //x2=95.715 //y2=5.39
cc_8135 ( N_noxref_22_M179_noxref_g N_noxref_23_c_12994_n ) capacitor \
 c=0.00846675f //x=95.62 //y=6.205 //x2=95.715 //y2=5.39
cc_8136 ( N_noxref_22_c_12727_n N_noxref_23_c_12994_n ) capacitor \
 c=7.28626e-19 //x=95.6 //y=4.885 //x2=95.715 //y2=5.39
cc_8137 ( N_noxref_22_c_12668_n N_noxref_23_c_13044_n ) capacitor \
 c=0.00233055f //x=95.58 //y=2.38 //x2=95.88 //y2=1.535
cc_8138 ( N_noxref_22_c_12702_n N_noxref_23_c_13044_n ) capacitor \
 c=8.15893e-19 //x=95.58 //y=2.26 //x2=95.88 //y2=1.535
cc_8139 ( N_noxref_22_c_12712_n N_noxref_23_c_13044_n ) capacitor \
 c=5.01861e-19 //x=95.615 //y=1.085 //x2=95.88 //y2=1.535
cc_8140 ( N_noxref_22_c_12715_n N_noxref_23_c_13044_n ) capacitor \
 c=0.00397521f //x=95.615 //y=1.435 //x2=95.88 //y2=1.535
cc_8141 ( N_noxref_22_c_12717_n N_noxref_23_c_13044_n ) capacitor \
 c=0.00205332f //x=95.615 //y=1.74 //x2=95.88 //y2=1.535
cc_8142 ( N_noxref_22_c_12743_p N_noxref_23_c_13044_n ) capacitor \
 c=3.72732e-19 //x=95.99 //y=0.93 //x2=95.88 //y2=1.535
cc_8143 ( N_noxref_22_c_12720_n N_noxref_23_c_13044_n ) capacitor \
 c=0.00187911f //x=95.99 //y=1.585 //x2=95.88 //y2=1.535
cc_8144 ( N_noxref_22_c_12721_n N_noxref_23_c_13044_n ) capacitor c=2.0901e-19 \
 //x=96.145 //y=1.085 //x2=95.88 //y2=1.535
cc_8145 ( N_noxref_22_c_12722_n N_noxref_23_c_13044_n ) capacitor \
 c=0.00241403f //x=96.145 //y=1.435 //x2=95.88 //y2=1.535
cc_8146 ( N_noxref_22_c_12724_n N_noxref_23_c_13044_n ) capacitor \
 c=2.48891e-19 //x=95.58 //y=2.26 //x2=95.88 //y2=1.535
cc_8147 ( N_noxref_22_c_12717_n N_noxref_23_c_13054_n ) capacitor c=0.0018678f \
 //x=95.615 //y=1.74 //x2=95.88 //y2=1.74
cc_8148 ( N_noxref_22_c_12720_n N_noxref_23_c_13054_n ) capacitor \
 c=0.00592669f //x=95.99 //y=1.585 //x2=95.88 //y2=1.74
cc_8149 ( N_noxref_22_M180_noxref_g N_noxref_23_c_13056_n ) capacitor \
 c=0.0116091f //x=96.06 //y=6.205 //x2=96.235 //y2=5.39
cc_8150 ( N_noxref_22_c_12720_n N_noxref_23_c_13057_n ) capacitor c=0.0048413f \
 //x=95.99 //y=1.585 //x2=96.235 //y2=1.825
cc_8151 ( N_noxref_22_c_12752_p N_noxref_23_c_13058_n ) capacitor \
 c=0.00368358f //x=95.58 //y=2.095 //x2=95.965 //y2=1.825
cc_8152 ( N_noxref_22_c_12668_n N_noxref_23_c_12995_n ) capacitor c=0.0146548f \
 //x=95.58 //y=2.38 //x2=96.32 //y2=4.095
cc_8153 ( N_noxref_22_c_12672_n N_noxref_23_c_12995_n ) capacitor c=0.0765587f \
 //x=95.58 //y=4.05 //x2=96.32 //y2=4.095
cc_8154 ( N_noxref_22_c_12676_n N_noxref_23_c_12995_n ) capacitor c=0.0029642f \
 //x=95.58 //y=4.37 //x2=96.32 //y2=4.095
cc_8155 ( N_noxref_22_c_12692_n N_noxref_23_c_12995_n ) capacitor \
 c=0.00136148f //x=95.595 //y=4.21 //x2=96.32 //y2=4.095
cc_8156 ( N_noxref_22_c_12702_n N_noxref_23_c_12995_n ) capacitor \
 c=0.00137695f //x=95.58 //y=2.26 //x2=96.32 //y2=4.095
cc_8157 ( N_noxref_22_c_12724_n N_noxref_23_c_12995_n ) capacitor \
 c=0.00284078f //x=95.58 //y=2.26 //x2=96.32 //y2=4.095
cc_8158 ( N_noxref_22_c_12752_p N_noxref_23_c_12995_n ) capacitor \
 c=0.00356275f //x=95.58 //y=2.095 //x2=96.32 //y2=4.095
cc_8159 ( N_noxref_22_c_12676_n N_noxref_23_c_13066_n ) capacitor c=0.0169977f \
 //x=95.58 //y=4.37 //x2=96.32 //y2=4.415
cc_8160 ( N_noxref_22_c_12677_n N_noxref_23_c_13066_n ) capacitor \
 c=0.00262509f //x=95.58 //y=4.74 //x2=96.32 //y2=4.415
cc_8161 ( N_noxref_22_c_12682_n N_noxref_23_c_13066_n ) capacitor \
 c=8.95907e-19 //x=95.58 //y=4.25 //x2=96.32 //y2=4.415
cc_8162 ( N_noxref_22_c_12692_n N_noxref_23_c_13066_n ) capacitor \
 c=0.00288053f //x=95.595 //y=4.21 //x2=96.32 //y2=4.415
cc_8163 ( N_noxref_22_c_12677_n N_noxref_23_c_12997_n ) capacitor c=0.0305973f \
 //x=95.58 //y=4.74 //x2=96.32 //y2=5.305
cc_8164 ( N_noxref_22_c_12705_n N_noxref_23_c_12997_n ) capacitor \
 c=0.00179503f //x=95.6 //y=4.885 //x2=96.32 //y2=5.305
cc_8165 ( N_noxref_22_c_12766_p N_noxref_23_c_12997_n ) capacitor \
 c=0.00864287f //x=95.985 //y=4.975 //x2=96.32 //y2=5.305
cc_8166 ( N_noxref_22_c_12727_n N_noxref_23_c_12997_n ) capacitor \
 c=0.00141883f //x=95.6 //y=4.885 //x2=96.32 //y2=5.305
cc_8167 ( N_noxref_22_c_12672_n N_noxref_23_c_13074_n ) capacitor \
 c=0.00300359f //x=95.58 //y=4.05 //x2=97.8 //y2=4.095
cc_8168 ( N_noxref_22_c_12677_n N_noxref_23_c_13075_n ) capacitor \
 c=0.00111022f //x=95.58 //y=4.74 //x2=97.8 //y2=4.76
cc_8169 ( N_noxref_22_c_12313_n N_noxref_23_c_12998_n ) capacitor \
 c=3.77121e-19 //x=88.955 //y=1.085 //x2=89.22 //y2=1.36
cc_8170 ( N_noxref_22_c_12316_n N_noxref_23_c_12998_n ) capacitor \
 c=0.00245317f //x=88.955 //y=1.43 //x2=89.22 //y2=1.36
cc_8171 ( N_noxref_22_c_12318_n N_noxref_23_c_12998_n ) capacitor \
 c=0.00150373f //x=88.955 //y=1.74 //x2=89.22 //y2=1.36
cc_8172 ( N_noxref_22_c_12773_p N_noxref_23_c_12998_n ) capacitor \
 c=3.38306e-19 //x=89.33 //y=0.93 //x2=89.22 //y2=1.36
cc_8173 ( N_noxref_22_c_12774_p N_noxref_23_c_12998_n ) capacitor c=0.0022369f \
 //x=89.33 //y=1.585 //x2=89.22 //y2=1.36
cc_8174 ( N_noxref_22_c_12321_n N_noxref_23_c_12998_n ) capacitor \
 c=3.16128e-19 //x=89.485 //y=1.085 //x2=89.22 //y2=1.36
cc_8175 ( N_noxref_22_c_12322_n N_noxref_23_c_12998_n ) capacitor \
 c=0.00792469f //x=89.485 //y=1.43 //x2=89.22 //y2=1.36
cc_8176 ( N_noxref_22_c_12297_n N_noxref_23_c_13009_n ) capacitor c=0.0169094f \
 //x=95.435 //y=4.21 //x2=94.96 //y2=5.39
cc_8177 ( N_noxref_22_c_12692_n N_noxref_23_c_13084_n ) capacitor \
 c=6.25661e-19 //x=95.595 //y=4.21 //x2=95.837 //y2=5.39
cc_8178 ( N_noxref_22_M179_noxref_g N_noxref_23_c_13084_n ) capacitor \
 c=0.00180711f //x=95.62 //y=6.205 //x2=95.837 //y2=5.39
cc_8179 ( N_noxref_22_M180_noxref_g N_noxref_23_c_13084_n ) capacitor \
 c=0.0027483f //x=96.06 //y=6.205 //x2=95.837 //y2=5.39
cc_8180 ( N_noxref_22_c_12766_p N_noxref_23_c_13084_n ) capacitor \
 c=0.00216603f //x=95.985 //y=4.975 //x2=95.837 //y2=5.39
cc_8181 ( N_noxref_22_c_12676_n N_noxref_23_c_13088_n ) capacitor c=6.9092e-19 \
 //x=95.58 //y=4.37 //x2=96.32 //y2=4.25
cc_8182 ( N_noxref_22_c_12682_n N_noxref_23_c_13088_n ) capacitor c=0.0102219f \
 //x=95.58 //y=4.25 //x2=96.32 //y2=4.25
cc_8183 ( N_noxref_22_c_12322_n N_noxref_23_c_12990_n ) capacitor \
 c=0.00142222f //x=89.485 //y=1.43 //x2=92.42 //y2=1.405
cc_8184 ( N_noxref_22_c_12717_n N_noxref_23_c_13091_n ) capacitor \
 c=0.00131018f //x=95.615 //y=1.74 //x2=95.875 //y2=1.405
cc_8185 ( N_noxref_22_c_12720_n N_noxref_23_c_13091_n ) capacitor \
 c=0.00184285f //x=95.99 //y=1.585 //x2=95.875 //y2=1.405
cc_8186 ( N_noxref_22_c_12668_n N_noxref_23_c_13016_n ) capacitor \
 c=0.00997796f //x=95.58 //y=2.38 //x2=95.715 //y2=1.405
cc_8187 ( N_noxref_22_c_12715_n N_noxref_23_c_13016_n ) capacitor \
 c=0.00107668f //x=95.615 //y=1.435 //x2=95.715 //y2=1.405
cc_8188 ( N_noxref_22_c_12717_n N_noxref_23_c_13016_n ) capacitor \
 c=8.64037e-19 //x=95.615 //y=1.74 //x2=95.715 //y2=1.405
cc_8189 ( N_noxref_22_c_12676_n N_noxref_23_c_13096_n ) capacitor c=0.0028493f \
 //x=95.58 //y=4.37 //x2=96.48 //y2=4.255
cc_8190 ( N_noxref_22_c_12677_n N_noxref_23_c_13096_n ) capacitor \
 c=0.00114496f //x=95.58 //y=4.74 //x2=96.48 //y2=4.255
cc_8191 ( N_noxref_22_c_12692_n N_noxref_23_c_13096_n ) capacitor c=0.018987f \
 //x=95.595 //y=4.21 //x2=96.48 //y2=4.255
cc_8192 ( N_noxref_22_M179_noxref_g N_noxref_23_c_13099_n ) capacitor \
 c=0.0141401f //x=95.62 //y=6.205 //x2=95.84 //y2=5.56
cc_8193 ( N_noxref_22_M180_noxref_g N_noxref_23_c_13099_n ) capacitor \
 c=0.0139971f //x=96.06 //y=6.205 //x2=95.84 //y2=5.56
cc_8194 ( N_noxref_22_c_12766_p N_noxref_23_c_13099_n ) capacitor \
 c=0.00293135f //x=95.985 //y=4.975 //x2=95.84 //y2=5.56
cc_8195 ( N_noxref_22_c_12313_n N_noxref_23_M55_noxref_d ) capacitor \
 c=0.00218556f //x=88.955 //y=1.085 //x2=89.03 //y2=1.085
cc_8196 ( N_noxref_22_c_12316_n N_noxref_23_M55_noxref_d ) capacitor \
 c=0.00327871f //x=88.955 //y=1.43 //x2=89.03 //y2=1.085
cc_8197 ( N_noxref_22_c_12318_n N_noxref_23_M55_noxref_d ) capacitor \
 c=0.00254845f //x=88.955 //y=1.74 //x2=89.03 //y2=1.085
cc_8198 ( N_noxref_22_c_12773_p N_noxref_23_M55_noxref_d ) capacitor \
 c=0.00235569f //x=89.33 //y=0.93 //x2=89.03 //y2=1.085
cc_8199 ( N_noxref_22_c_12774_p N_noxref_23_M55_noxref_d ) capacitor \
 c=0.00523156f //x=89.33 //y=1.585 //x2=89.03 //y2=1.085
cc_8200 ( N_noxref_22_c_12321_n N_noxref_23_M55_noxref_d ) capacitor \
 c=0.00131413f //x=89.485 //y=1.085 //x2=89.03 //y2=1.085
cc_8201 ( N_noxref_22_c_12322_n N_noxref_23_M55_noxref_d ) capacitor \
 c=0.0065758f //x=89.485 //y=1.43 //x2=89.03 //y2=1.085
cc_8202 ( N_noxref_22_c_12712_n N_noxref_23_M59_noxref_d ) capacitor \
 c=0.00226395f //x=95.615 //y=1.085 //x2=95.69 //y2=1.085
cc_8203 ( N_noxref_22_c_12715_n N_noxref_23_M59_noxref_d ) capacitor \
 c=0.004517f //x=95.615 //y=1.435 //x2=95.69 //y2=1.085
cc_8204 ( N_noxref_22_c_12717_n N_noxref_23_M59_noxref_d ) capacitor \
 c=0.00275912f //x=95.615 //y=1.74 //x2=95.69 //y2=1.085
cc_8205 ( N_noxref_22_c_12743_p N_noxref_23_M59_noxref_d ) capacitor \
 c=0.00234223f //x=95.99 //y=0.93 //x2=95.69 //y2=1.085
cc_8206 ( N_noxref_22_c_12720_n N_noxref_23_M59_noxref_d ) capacitor \
 c=0.00707878f //x=95.99 //y=1.585 //x2=95.69 //y2=1.085
cc_8207 ( N_noxref_22_c_12721_n N_noxref_23_M59_noxref_d ) capacitor \
 c=0.00132831f //x=96.145 //y=1.085 //x2=95.69 //y2=1.085
cc_8208 ( N_noxref_22_c_12722_n N_noxref_23_M59_noxref_d ) capacitor \
 c=0.00330743f //x=96.145 //y=1.435 //x2=95.69 //y2=1.085
cc_8209 ( N_noxref_22_c_12353_n N_VDD_c_13434_n ) capacitor c=0.00559514f \
 //x=55.69 //y=5.335 //x2=87.775 //y2=7.585
cc_8210 ( N_noxref_22_c_12405_n N_VDD_c_13434_n ) capacitor c=0.00564834f \
 //x=56.575 //y=5.335 //x2=87.775 //y2=7.585
cc_8211 ( N_noxref_22_c_12407_n N_VDD_c_13434_n ) capacitor c=0.00236065f \
 //x=56.69 //y=5.56 //x2=87.775 //y2=7.585
cc_8212 ( N_noxref_22_c_12409_n N_VDD_c_13434_n ) capacitor c=0.00753358f \
 //x=57.385 //y=5.335 //x2=87.775 //y2=7.585
cc_8213 ( N_noxref_22_c_12269_n N_VDD_c_13434_n ) capacitor c=0.00241373f \
 //x=54.932 //y=5.335 //x2=87.775 //y2=7.585
cc_8214 ( N_noxref_22_c_12600_n N_VDD_c_13434_n ) capacitor c=0.00249074f \
 //x=55.81 //y=5.335 //x2=87.775 //y2=7.585
cc_8215 ( N_noxref_22_c_12370_n N_VDD_c_13434_n ) capacitor c=0.0024232f \
 //x=54.93 //y=5.56 //x2=87.775 //y2=7.585
cc_8216 ( N_noxref_22_c_12629_n N_VDD_c_13434_n ) capacitor c=0.0024232f \
 //x=55.81 //y=5.56 //x2=87.775 //y2=7.585
cc_8217 ( N_noxref_22_c_12456_n N_VDD_c_13434_n ) capacitor c=0.0024232f \
 //x=56.69 //y=5.56 //x2=87.775 //y2=7.585
cc_8218 ( N_noxref_22_M171_noxref_g N_VDD_c_13739_n ) capacitor c=0.00125343f \
 //x=88.96 //y=6.205 //x2=88.74 //y2=7.035
cc_8219 ( N_noxref_22_M171_noxref_g N_VDD_c_13740_n ) capacitor c=0.00137209f \
 //x=88.96 //y=6.205 //x2=88.74 //y2=7.41
cc_8220 ( N_noxref_22_M172_noxref_g N_VDD_c_14628_n ) capacitor c=0.00373588f \
 //x=89.4 //y=6.205 //x2=89.62 //y2=7.035
cc_8221 ( N_noxref_22_M172_noxref_g N_VDD_c_14629_n ) capacitor c=0.00300944f \
 //x=89.4 //y=6.205 //x2=89.62 //y2=7.41
cc_8222 ( N_noxref_22_M125_noxref_g N_VDD_c_14022_n ) capacitor c=0.00755544f \
 //x=51.66 //y=6.2 //x2=52.235 //y2=7.585
cc_8223 ( N_noxref_22_M126_noxref_g N_VDD_c_14022_n ) capacitor c=0.00755754f \
 //x=52.1 //y=6.2 //x2=52.235 //y2=7.585
cc_8224 ( N_noxref_22_c_12353_n N_VDD_c_14027_n ) capacitor c=0.00202922f \
 //x=55.69 //y=5.335 //x2=55.285 //y2=7.585
cc_8225 ( N_noxref_22_c_12269_n N_VDD_c_14027_n ) capacitor c=9.3757e-19 \
 //x=54.932 //y=5.335 //x2=55.285 //y2=7.585
cc_8226 ( N_noxref_22_c_12370_n N_VDD_c_14027_n ) capacitor c=0.0138074f \
 //x=54.93 //y=5.56 //x2=55.285 //y2=7.585
cc_8227 ( N_noxref_22_c_12353_n N_VDD_c_14484_n ) capacitor c=0.0017708f \
 //x=55.69 //y=5.335 //x2=56.165 //y2=7.585
cc_8228 ( N_noxref_22_c_12405_n N_VDD_c_14484_n ) capacitor c=0.00202922f \
 //x=56.575 //y=5.335 //x2=56.165 //y2=7.585
cc_8229 ( N_noxref_22_c_12600_n N_VDD_c_14484_n ) capacitor c=9.4822e-19 \
 //x=55.81 //y=5.335 //x2=56.165 //y2=7.585
cc_8230 ( N_noxref_22_c_12629_n N_VDD_c_14484_n ) capacitor c=0.0138074f \
 //x=55.81 //y=5.56 //x2=56.165 //y2=7.585
cc_8231 ( N_noxref_22_c_12405_n N_VDD_c_14083_n ) capacitor c=0.00205906f \
 //x=56.575 //y=5.335 //x2=57.045 //y2=7.585
cc_8232 ( N_noxref_22_c_12407_n N_VDD_c_14083_n ) capacitor c=8.49654e-19 \
 //x=56.69 //y=5.56 //x2=57.045 //y2=7.585
cc_8233 ( N_noxref_22_c_12409_n N_VDD_c_14083_n ) capacitor c=0.00204238f \
 //x=57.385 //y=5.335 //x2=57.045 //y2=7.585
cc_8234 ( N_noxref_22_c_12456_n N_VDD_c_14083_n ) capacitor c=0.013249f \
 //x=56.69 //y=5.56 //x2=57.045 //y2=7.585
cc_8235 ( N_noxref_22_c_12409_n N_VDD_c_14643_n ) capacitor c=0.00183742f \
 //x=57.385 //y=5.335 //x2=58.04 //y2=7.585
cc_8236 ( N_noxref_22_M171_noxref_g N_VDD_c_13757_n ) capacitor c=0.007206f \
 //x=88.96 //y=6.205 //x2=90.23 //y2=7.585
cc_8237 ( N_noxref_22_M172_noxref_g N_VDD_c_13757_n ) capacitor c=0.00778439f \
 //x=89.4 //y=6.205 //x2=90.23 //y2=7.585
cc_8238 ( N_noxref_22_M179_noxref_g N_VDD_c_14584_n ) capacitor c=0.00728344f \
 //x=95.62 //y=6.205 //x2=96.89 //y2=7.585
cc_8239 ( N_noxref_22_M180_noxref_g N_VDD_c_14584_n ) capacitor c=0.00782837f \
 //x=96.06 //y=6.205 //x2=96.89 //y2=7.585
cc_8240 ( N_noxref_22_c_12269_n N_VDD_c_13779_n ) capacitor c=0.0022955f \
 //x=54.932 //y=5.335 //x2=53.4 //y2=7.585
cc_8241 ( N_noxref_22_c_12366_n N_VDD_c_13779_n ) capacitor c=0.00205049f \
 //x=51.92 //y=4.88 //x2=53.4 //y2=7.585
cc_8242 ( N_noxref_22_c_12370_n N_VDD_c_13779_n ) capacitor c=0.00509469f \
 //x=54.93 //y=5.56 //x2=53.4 //y2=7.585
cc_8243 ( N_noxref_22_c_12407_n N_VDD_c_13780_n ) capacitor c=0.00282782f \
 //x=56.69 //y=5.56 //x2=58.21 //y2=7.585
cc_8244 ( N_noxref_22_c_12248_n N_VDD_c_13780_n ) capacitor c=0.0316634f \
 //x=57.47 //y=5.25 //x2=58.21 //y2=7.585
cc_8245 ( N_noxref_22_c_12456_n N_VDD_c_13780_n ) capacitor c=0.00777981f \
 //x=56.69 //y=5.56 //x2=58.21 //y2=7.585
cc_8246 ( N_noxref_22_c_12273_n N_VDD_c_13781_n ) capacitor c=0.00419973f \
 //x=61.765 //y=3.9 //x2=63.02 //y2=7.585
cc_8247 ( N_noxref_22_c_12278_n N_VDD_c_13783_n ) capacitor c=0.00882116f \
 //x=66.565 //y=4.28 //x2=67.83 //y2=7.585
cc_8248 ( N_noxref_22_c_12280_n N_VDD_c_13784_n ) capacitor c=0.00887763f \
 //x=76.315 //y=4.25 //x2=72.64 //y2=7.585
cc_8249 ( N_noxref_22_c_12285_n N_VDD_c_13786_n ) capacitor c=9.93762e-19 \
 //x=76.915 //y=4.28 //x2=77.45 //y2=7.585
cc_8250 ( N_noxref_22_c_12286_n N_VDD_c_13786_n ) capacitor c=0.00879861f \
 //x=85.205 //y=4.25 //x2=77.45 //y2=7.585
cc_8251 ( N_noxref_22_c_12286_n N_VDD_c_13787_n ) capacitor c=0.00887763f \
 //x=85.205 //y=4.25 //x2=82.26 //y2=7.585
cc_8252 ( N_noxref_22_c_12270_n N_VDD_c_13788_n ) capacitor c=8.3644e-19 \
 //x=88.92 //y=4.25 //x2=87.07 //y2=7.585
cc_8253 ( N_noxref_22_c_12288_n N_VDD_c_13788_n ) capacitor c=0.00864541f \
 //x=87.43 //y=4.25 //x2=87.07 //y2=7.585
cc_8254 ( N_noxref_22_c_12256_n N_VDD_c_13794_n ) capacitor c=5.31543e-19 \
 //x=88.92 //y=4.365 //x2=90.4 //y2=7.585
cc_8255 ( N_noxref_22_c_12259_n N_VDD_c_13794_n ) capacitor c=0.00746843f \
 //x=88.92 //y=4.71 //x2=90.4 //y2=7.585
cc_8256 ( N_noxref_22_c_12270_n N_VDD_c_13794_n ) capacitor c=0.00144593f \
 //x=88.92 //y=4.25 //x2=90.4 //y2=7.585
cc_8257 ( N_noxref_22_c_12297_n N_VDD_c_13794_n ) capacitor c=0.00818904f \
 //x=95.435 //y=4.21 //x2=90.4 //y2=7.585
cc_8258 ( N_noxref_22_c_12305_n N_VDD_c_13794_n ) capacitor c=0.00250302f \
 //x=88.96 //y=4.885 //x2=90.4 //y2=7.585
cc_8259 ( N_noxref_22_c_12860_p N_VDD_c_13794_n ) capacitor c=0.0117152f \
 //x=89.325 //y=4.975 //x2=90.4 //y2=7.585
cc_8260 ( N_noxref_22_c_12327_n N_VDD_c_13794_n ) capacitor c=2.76772e-19 \
 //x=88.96 //y=4.885 //x2=90.4 //y2=7.585
cc_8261 ( N_noxref_22_c_12677_n N_VDD_c_13800_n ) capacitor c=5.18027e-19 \
 //x=95.58 //y=4.74 //x2=93.73 //y2=7.585
cc_8262 ( N_noxref_22_c_12682_n N_VDD_c_13800_n ) capacitor c=8.21577e-19 \
 //x=95.58 //y=4.25 //x2=93.73 //y2=7.585
cc_8263 ( N_noxref_22_c_12297_n N_VDD_c_13800_n ) capacitor c=0.0135112f \
 //x=95.435 //y=4.21 //x2=93.73 //y2=7.585
cc_8264 ( N_noxref_22_c_12705_n N_VDD_c_13800_n ) capacitor c=6.64651e-19 \
 //x=95.6 //y=4.885 //x2=93.73 //y2=7.585
cc_8265 ( N_noxref_22_c_12705_n N_VDD_c_14673_n ) capacitor c=0.00237807f \
 //x=95.6 //y=4.885 //x2=97.06 //y2=7.585
cc_8266 ( N_noxref_22_c_12766_p N_VDD_c_14673_n ) capacitor c=0.0170421f \
 //x=95.985 //y=4.975 //x2=97.06 //y2=7.585
cc_8267 ( N_noxref_22_c_12727_n N_VDD_c_14673_n ) capacitor c=2.70151e-19 \
 //x=95.6 //y=4.885 //x2=97.06 //y2=7.585
cc_8268 ( N_noxref_22_M125_noxref_g N_VDD_M124_noxref_d ) capacitor \
 c=0.015318f //x=51.66 //y=6.2 //x2=51.295 //y2=5.2
cc_8269 ( N_noxref_22_M126_noxref_g N_VDD_M126_noxref_d ) capacitor \
 c=0.0394719f //x=52.1 //y=6.2 //x2=52.175 //y2=5.2
cc_8270 ( N_noxref_22_c_12269_n N_VDD_M127_noxref_s ) capacitor c=0.0442713f \
 //x=54.932 //y=5.335 //x2=54.355 //y2=5.2
cc_8271 ( N_noxref_22_c_12600_n N_VDD_M127_noxref_s ) capacitor c=7.80122e-19 \
 //x=55.81 //y=5.335 //x2=54.355 //y2=5.2
cc_8272 ( N_noxref_22_c_12370_n N_VDD_M127_noxref_s ) capacitor c=0.09305f \
 //x=54.93 //y=5.56 //x2=54.355 //y2=5.2
cc_8273 ( N_noxref_22_c_12353_n N_VDD_M128_noxref_d ) capacitor c=0.00700141f \
 //x=55.69 //y=5.335 //x2=55.225 //y2=5.2
cc_8274 ( N_noxref_22_c_12370_n N_VDD_M128_noxref_d ) capacitor c=0.0674491f \
 //x=54.93 //y=5.56 //x2=55.225 //y2=5.2
cc_8275 ( N_noxref_22_c_12629_n N_VDD_M128_noxref_d ) capacitor c=0.0674762f \
 //x=55.81 //y=5.56 //x2=55.225 //y2=5.2
cc_8276 ( N_noxref_22_c_12405_n N_VDD_M130_noxref_d ) capacitor c=0.00700141f \
 //x=56.575 //y=5.335 //x2=56.105 //y2=5.2
cc_8277 ( N_noxref_22_c_12629_n N_VDD_M130_noxref_d ) capacitor c=0.067493f \
 //x=55.81 //y=5.56 //x2=56.105 //y2=5.2
cc_8278 ( N_noxref_22_c_12456_n N_VDD_M130_noxref_d ) capacitor c=0.0674979f \
 //x=56.69 //y=5.56 //x2=56.105 //y2=5.2
cc_8279 ( N_noxref_22_c_12409_n N_VDD_M132_noxref_d ) capacitor c=0.00700141f \
 //x=57.385 //y=5.335 //x2=56.985 //y2=5.2
cc_8280 ( N_noxref_22_c_12456_n N_VDD_M132_noxref_d ) capacitor c=0.0675002f \
 //x=56.69 //y=5.56 //x2=56.985 //y2=5.2
cc_8281 ( N_noxref_22_c_12407_n N_VDD_M133_noxref_s ) capacitor c=0.00492616f \
 //x=56.69 //y=5.56 //x2=59.165 //y2=5.2
cc_8282 ( N_noxref_22_c_12409_n N_VDD_M133_noxref_s ) capacitor c=9.42705e-19 \
 //x=57.385 //y=5.335 //x2=59.165 //y2=5.2
cc_8283 ( N_noxref_22_c_12600_n N_VDD_M133_noxref_s ) capacitor c=2.11884e-19 \
 //x=55.81 //y=5.335 //x2=59.165 //y2=5.2
cc_8284 ( N_noxref_22_M171_noxref_g N_VDD_M170_noxref_d ) capacitor \
 c=0.0127979f //x=88.96 //y=6.205 //x2=88.595 //y2=5.205
cc_8285 ( N_noxref_22_M172_noxref_g N_VDD_M172_noxref_d ) capacitor \
 c=0.0463918f //x=89.4 //y=6.205 //x2=89.475 //y2=5.205
cc_8286 ( N_noxref_22_c_12335_n N_noxref_36_c_15555_n ) capacitor \
 c=0.00177186f //x=51.92 //y=2.375 //x2=52.575 //y2=0.72
cc_8287 ( N_noxref_22_c_12365_n N_noxref_36_c_15555_n ) capacitor \
 c=0.00117306f //x=51.92 //y=2.26 //x2=52.575 //y2=0.72
cc_8288 ( N_noxref_22_c_12379_n N_noxref_36_c_15555_n ) capacitor c=0.0206349f \
 //x=51.91 //y=1.095 //x2=52.575 //y2=0.72
cc_8289 ( N_noxref_22_c_12391_n N_noxref_36_c_15555_n ) capacitor \
 c=0.00825432f //x=52.44 //y=1.095 //x2=52.575 //y2=0.72
cc_8290 ( N_noxref_22_c_12397_n N_noxref_36_c_15555_n ) capacitor \
 c=2.20712e-19 //x=51.92 //y=2.26 //x2=52.575 //y2=0.72
cc_8291 ( N_noxref_22_c_12381_n N_noxref_36_c_15558_n ) capacitor c=0.0071177f \
 //x=51.91 //y=1.44 //x2=51.69 //y2=1.175
cc_8292 ( N_noxref_22_c_12379_n N_noxref_36_M32_noxref_s ) capacitor \
 c=0.0071177f //x=51.91 //y=1.095 //x2=51.555 //y2=0.555
cc_8293 ( N_noxref_22_c_12384_n N_noxref_36_M32_noxref_s ) capacitor \
 c=0.0071177f //x=51.91 //y=1.75 //x2=51.555 //y2=0.555
cc_8294 ( N_noxref_22_c_12391_n N_noxref_36_M32_noxref_s ) capacitor \
 c=0.015333f //x=52.44 //y=1.095 //x2=51.555 //y2=0.555
cc_8295 ( N_noxref_22_c_12393_n N_noxref_36_M32_noxref_s ) capacitor \
 c=0.00248746f //x=52.44 //y=1.44 //x2=51.555 //y2=0.555
cc_8296 ( N_noxref_22_c_12413_n N_noxref_37_c_15624_n ) capacitor c=0.0036878f \
 //x=56.985 //y=1.305 //x2=57.385 //y2=0.72
cc_8297 ( N_noxref_22_c_12424_n N_noxref_37_c_15624_n ) capacitor \
 c=0.00399931f //x=57.385 //y=1.845 //x2=57.385 //y2=0.72
cc_8298 ( N_noxref_22_M35_noxref_d N_noxref_37_c_15624_n ) capacitor \
 c=0.00910163f //x=56.795 //y=1.095 //x2=57.385 //y2=0.72
cc_8299 ( N_noxref_22_M35_noxref_d N_noxref_37_c_15629_n ) capacitor \
 c=0.00120711f //x=56.795 //y=1.095 //x2=56.5 //y2=1.175
cc_8300 ( N_noxref_22_c_12353_n N_noxref_37_M34_noxref_d ) capacitor \
 c=9.20728e-19 //x=55.69 //y=5.335 //x2=55.26 //y2=1.09
cc_8301 ( N_noxref_22_c_12413_n N_noxref_37_M34_noxref_d ) capacitor \
 c=0.00802417f //x=56.985 //y=1.305 //x2=55.26 //y2=1.09
cc_8302 ( N_noxref_22_c_12413_n N_noxref_37_M35_noxref_s ) capacitor \
 c=0.0098487f //x=56.985 //y=1.305 //x2=56.365 //y2=0.555
cc_8303 ( N_noxref_22_c_12419_n N_noxref_37_M35_noxref_s ) capacitor \
 c=0.0283243f //x=56.985 //y=1.76 //x2=56.365 //y2=0.555
cc_8304 ( N_noxref_22_c_12424_n N_noxref_37_M35_noxref_s ) capacitor \
 c=0.00871957f //x=57.385 //y=1.845 //x2=56.365 //y2=0.555
cc_8305 ( N_noxref_22_c_12442_n N_noxref_37_M35_noxref_s ) capacitor \
 c=0.0016218f //x=57.47 //y=3.51 //x2=56.365 //y2=0.555
cc_8306 ( N_noxref_22_M35_noxref_d N_noxref_37_M35_noxref_s ) capacitor \
 c=0.0279003f //x=56.795 //y=1.095 //x2=56.365 //y2=0.555
cc_8307 ( N_noxref_22_c_12413_n N_noxref_38_M37_noxref_d ) capacitor \
 c=3.20746e-19 //x=56.985 //y=1.305 //x2=60.07 //y2=1.09
cc_8308 ( N_noxref_22_c_12256_n N_noxref_44_c_16098_n ) capacitor \
 c=0.00150537f //x=88.92 //y=4.365 //x2=89.065 //y2=5.39
cc_8309 ( N_noxref_22_c_12259_n N_noxref_44_c_16098_n ) capacitor c=0.0212118f \
 //x=88.92 //y=4.71 //x2=89.065 //y2=5.39
cc_8310 ( N_noxref_22_c_12270_n N_noxref_44_c_16098_n ) capacitor \
 c=3.71828e-19 //x=88.92 //y=4.25 //x2=89.065 //y2=5.39
cc_8311 ( N_noxref_22_c_12305_n N_noxref_44_c_16098_n ) capacitor c=0.004587f \
 //x=88.96 //y=4.885 //x2=89.065 //y2=5.39
cc_8312 ( N_noxref_22_M171_noxref_g N_noxref_44_c_16098_n ) capacitor \
 c=0.00913391f //x=88.96 //y=6.205 //x2=89.065 //y2=5.39
cc_8313 ( N_noxref_22_c_12327_n N_noxref_44_c_16098_n ) capacitor \
 c=6.87087e-19 //x=88.96 //y=4.885 //x2=89.065 //y2=5.39
cc_8314 ( N_noxref_22_M172_noxref_g N_noxref_44_c_16100_n ) capacitor \
 c=0.011434f //x=89.4 //y=6.205 //x2=91.065 //y2=5.39
cc_8315 ( N_noxref_22_c_12256_n N_noxref_44_c_16103_n ) capacitor \
 c=0.00145195f //x=88.92 //y=4.365 //x2=89.295 //y2=5.39
cc_8316 ( N_noxref_22_c_12259_n N_noxref_44_c_16103_n ) capacitor \
 c=0.00252287f //x=88.92 //y=4.71 //x2=89.295 //y2=5.39
cc_8317 ( N_noxref_22_M171_noxref_g N_noxref_44_c_16103_n ) capacitor \
 c=7.30299e-19 //x=88.96 //y=6.205 //x2=89.295 //y2=5.39
cc_8318 ( N_noxref_22_M172_noxref_g N_noxref_44_c_16103_n ) capacitor \
 c=8.30848e-19 //x=89.4 //y=6.205 //x2=89.295 //y2=5.39
cc_8319 ( N_noxref_22_c_12256_n N_noxref_44_c_16119_n ) capacitor \
 c=0.00167023f //x=88.92 //y=4.365 //x2=89.18 //y2=5.39
cc_8320 ( N_noxref_22_M171_noxref_g N_noxref_44_c_16119_n ) capacitor \
 c=0.021802f //x=88.96 //y=6.205 //x2=89.18 //y2=5.39
cc_8321 ( N_noxref_22_M172_noxref_g N_noxref_44_c_16119_n ) capacitor \
 c=0.0189969f //x=89.4 //y=6.205 //x2=89.18 //y2=5.39
cc_8322 ( N_noxref_22_c_12860_p N_noxref_44_c_16119_n ) capacitor \
 c=0.00449628f //x=89.325 //y=4.975 //x2=89.18 //y2=5.39
cc_8323 ( N_noxref_22_M171_noxref_g N_noxref_44_M171_noxref_d ) capacitor \
 c=0.00122946f //x=88.96 //y=6.205 //x2=89.035 //y2=5.205
cc_8324 ( N_noxref_22_M172_noxref_g N_noxref_44_M171_noxref_d ) capacitor \
 c=0.00123972f //x=89.4 //y=6.205 //x2=89.035 //y2=5.205
cc_8325 ( N_noxref_22_c_12297_n N_noxref_45_c_16271_n ) capacitor c=0.0620335f \
 //x=95.435 //y=4.21 //x2=94.405 //y2=5.39
cc_8326 ( N_noxref_22_c_12297_n N_noxref_45_c_16281_n ) capacitor \
 c=0.00869836f //x=95.435 //y=4.21 //x2=92.615 //y2=5.39
cc_8327 ( N_noxref_22_M179_noxref_g N_noxref_45_c_16297_n ) capacitor \
 c=0.00793695f //x=95.62 //y=6.205 //x2=96.15 //y2=7.09
cc_8328 ( N_noxref_22_M180_noxref_g N_noxref_45_c_16297_n ) capacitor \
 c=0.00937408f //x=96.06 //y=6.205 //x2=96.15 //y2=7.09
cc_8329 ( N_noxref_22_c_12297_n N_noxref_45_c_16259_n ) capacitor c=0.0270012f \
 //x=95.435 //y=4.21 //x2=91.62 //y2=5.39
cc_8330 ( N_noxref_22_M179_noxref_g N_noxref_45_c_16286_n ) capacitor \
 c=0.00177216f //x=95.62 //y=6.205 //x2=95.4 //y2=7.09
cc_8331 ( N_noxref_22_M180_noxref_g N_noxref_45_c_16301_n ) capacitor \
 c=0.00422002f //x=96.06 //y=6.205 //x2=96.28 //y2=6.92
cc_8332 ( N_noxref_22_c_12297_n N_noxref_45_c_16287_n ) capacitor \
 c=0.00183347f //x=95.435 //y=4.21 //x2=92.5 //y2=5.39
cc_8333 ( N_noxref_22_c_12297_n N_noxref_45_c_16290_n ) capacitor \
 c=2.11035e-19 //x=95.435 //y=4.21 //x2=94.52 //y2=5.39
cc_8334 ( N_noxref_22_M179_noxref_g N_noxref_45_M178_noxref_d ) capacitor \
 c=0.0142133f //x=95.62 //y=6.205 //x2=95.255 //y2=5.205
cc_8335 ( N_noxref_22_c_12727_n N_noxref_45_M178_noxref_d ) capacitor \
 c=6.61209e-19 //x=95.6 //y=4.885 //x2=95.255 //y2=5.205
cc_8336 ( N_noxref_22_M180_noxref_g N_noxref_45_M180_noxref_d ) capacitor \
 c=0.0365939f //x=96.06 //y=6.205 //x2=96.135 //y2=5.205
cc_8337 ( N_noxref_22_c_12335_n N_GND_c_16808_n ) capacitor c=0.00196498f \
 //x=51.92 //y=2.375 //x2=54.39 //y2=0.175
cc_8338 ( N_noxref_22_c_12413_n N_GND_c_16854_n ) capacitor c=0.00884249f \
 //x=56.985 //y=1.305 //x2=59.2 //y2=0.175
cc_8339 ( N_noxref_22_c_12424_n N_GND_c_16854_n ) capacitor c=0.00662992f \
 //x=57.385 //y=1.845 //x2=59.2 //y2=0.175
cc_8340 ( N_noxref_22_M35_noxref_d N_GND_c_16854_n ) capacitor c=2.9462e-19 \
 //x=56.795 //y=1.095 //x2=59.2 //y2=0.175
cc_8341 ( N_noxref_22_c_12249_n N_GND_c_17290_n ) capacitor c=0.00191816f \
 //x=88.92 //y=2.375 //x2=91.495 //y2=0.175
cc_8342 ( N_noxref_22_c_12668_n N_GND_c_17344_n ) capacitor c=4.6307e-19 \
 //x=95.58 //y=2.38 //x2=98.54 //y2=0.18
cc_8343 ( N_noxref_22_c_12413_n N_GND_c_16900_n ) capacitor c=0.00543195f \
 //x=56.985 //y=1.305 //x2=59.285 //y2=1.145
cc_8344 ( N_noxref_22_c_12335_n N_GND_c_16790_n ) capacitor c=2.016e-19 \
 //x=51.92 //y=2.375 //x2=53.23 //y2=0.175
cc_8345 ( N_noxref_22_c_12424_n N_GND_c_16828_n ) capacitor c=6.86343e-19 \
 //x=57.385 //y=1.845 //x2=58.04 //y2=0.175
cc_8346 ( N_noxref_22_c_12249_n N_GND_c_16628_n ) capacitor c=3.76947e-19 \
 //x=88.92 //y=2.375 //x2=90.23 //y2=0.175
cc_8347 ( N_noxref_22_c_12668_n N_GND_c_17306_n ) capacitor c=3.29013e-19 \
 //x=95.58 //y=2.38 //x2=96.89 //y2=0.175
cc_8348 ( N_noxref_22_c_12365_n N_GND_c_16829_n ) capacitor c=0.00216084f \
 //x=51.92 //y=2.26 //x2=53.4 //y2=0.175
cc_8349 ( N_noxref_22_c_12393_n N_GND_c_16829_n ) capacitor c=0.00262688f \
 //x=52.44 //y=1.44 //x2=53.4 //y2=0.175
cc_8350 ( N_noxref_22_c_12397_n N_GND_c_16829_n ) capacitor c=2.63786e-19 \
 //x=51.92 //y=2.26 //x2=53.4 //y2=0.175
cc_8351 ( N_noxref_22_c_12419_n N_GND_c_16867_n ) capacitor c=0.0045138f \
 //x=56.985 //y=1.76 //x2=58.21 //y2=0.175
cc_8352 ( N_noxref_22_c_12424_n N_GND_c_16867_n ) capacitor c=0.0323123f \
 //x=57.385 //y=1.845 //x2=58.21 //y2=0.175
cc_8353 ( N_noxref_22_c_12288_n N_GND_c_16635_n ) capacitor c=0.00245124f \
 //x=87.43 //y=4.25 //x2=87.07 //y2=0.175
cc_8354 ( N_noxref_22_c_12249_n N_GND_c_16641_n ) capacitor c=0.00249018f \
 //x=88.92 //y=2.375 //x2=90.4 //y2=0.175
cc_8355 ( N_noxref_22_c_12253_n N_GND_c_16641_n ) capacitor c=0.00566599f \
 //x=88.92 //y=4.045 //x2=90.4 //y2=0.175
cc_8356 ( N_noxref_22_c_12297_n N_GND_c_16641_n ) capacitor c=0.00247264f \
 //x=95.435 //y=4.21 //x2=90.4 //y2=0.175
cc_8357 ( N_noxref_22_c_12301_n N_GND_c_16641_n ) capacitor c=0.00220418f \
 //x=88.92 //y=2.26 //x2=90.4 //y2=0.175
cc_8358 ( N_noxref_22_c_12297_n N_GND_c_17321_n ) capacitor c=0.0025451f \
 //x=95.435 //y=4.21 //x2=93.73 //y2=0.175
cc_8359 ( N_noxref_22_c_12702_n N_GND_c_17332_n ) capacitor c=0.00224736f \
 //x=95.58 //y=2.26 //x2=97.06 //y2=0.175
cc_8360 ( N_noxref_22_c_12720_n N_GND_c_17332_n ) capacitor c=0.00264662f \
 //x=95.99 //y=1.585 //x2=97.06 //y2=0.175
cc_8361 ( N_noxref_22_c_12724_n N_GND_c_17332_n ) capacitor c=2.63786e-19 \
 //x=95.58 //y=2.26 //x2=97.06 //y2=0.175
cc_8362 ( N_noxref_22_c_12249_n N_noxref_65_c_19187_n ) capacitor \
 c=7.20375e-19 //x=88.92 //y=2.375 //x2=88.735 //y2=1.675
cc_8363 ( N_noxref_22_c_12256_n N_noxref_65_c_19187_n ) capacitor \
 c=3.32532e-19 //x=88.92 //y=4.365 //x2=88.735 //y2=1.675
cc_8364 ( N_noxref_22_c_12318_n N_noxref_65_c_19187_n ) capacitor \
 c=0.00746306f //x=88.955 //y=1.74 //x2=88.735 //y2=1.675
cc_8365 ( N_noxref_22_c_12324_n N_noxref_65_c_19187_n ) capacitor \
 c=0.00175173f //x=88.92 //y=2.26 //x2=88.735 //y2=1.675
cc_8366 ( N_noxref_22_c_12249_n N_noxref_65_c_19194_n ) capacitor \
 c=0.00135256f //x=88.92 //y=2.375 //x2=89.62 //y2=0.71
cc_8367 ( N_noxref_22_c_12301_n N_noxref_65_c_19194_n ) capacitor \
 c=8.82141e-19 //x=88.92 //y=2.26 //x2=89.62 //y2=0.71
cc_8368 ( N_noxref_22_c_12313_n N_noxref_65_c_19194_n ) capacitor c=0.0200392f \
 //x=88.955 //y=1.085 //x2=89.62 //y2=0.71
cc_8369 ( N_noxref_22_c_12321_n N_noxref_65_c_19194_n ) capacitor \
 c=0.00825432f //x=89.485 //y=1.085 //x2=89.62 //y2=0.71
cc_8370 ( N_noxref_22_c_12324_n N_noxref_65_c_19194_n ) capacitor c=2.1838e-19 \
 //x=88.92 //y=2.26 //x2=89.62 //y2=0.71
cc_8371 ( N_noxref_22_c_12313_n N_noxref_65_M54_noxref_s ) capacitor \
 c=0.00746306f //x=88.955 //y=1.085 //x2=87.63 //y2=0.545
cc_8372 ( N_noxref_22_c_12318_n N_noxref_65_M54_noxref_s ) capacitor \
 c=0.00211573f //x=88.955 //y=1.74 //x2=87.63 //y2=0.545
cc_8373 ( N_noxref_22_c_12321_n N_noxref_65_M54_noxref_s ) capacitor \
 c=0.014227f //x=89.485 //y=1.085 //x2=87.63 //y2=0.545
cc_8374 ( N_noxref_22_c_12322_n N_noxref_65_M54_noxref_s ) capacitor \
 c=0.00733269f //x=89.485 //y=1.43 //x2=87.63 //y2=0.545
cc_8375 ( N_noxref_22_c_12976_p N_noxref_65_M54_noxref_s ) capacitor \
 c=0.00293287f //x=88.92 //y=2.095 //x2=87.63 //y2=0.545
cc_8376 ( N_noxref_22_c_12297_n N_noxref_67_c_19308_n ) capacitor \
 c=0.00782785f //x=95.435 //y=4.21 //x2=95.31 //y2=1.76
cc_8377 ( N_noxref_22_c_12668_n N_noxref_67_c_19315_n ) capacitor \
 c=7.26555e-19 //x=95.58 //y=2.38 //x2=95.395 //y2=1.675
cc_8378 ( N_noxref_22_c_12676_n N_noxref_67_c_19315_n ) capacitor \
 c=9.42734e-19 //x=95.58 //y=4.37 //x2=95.395 //y2=1.675
cc_8379 ( N_noxref_22_c_12717_n N_noxref_67_c_19315_n ) capacitor \
 c=0.00830822f //x=95.615 //y=1.74 //x2=95.395 //y2=1.675
cc_8380 ( N_noxref_22_c_12724_n N_noxref_67_c_19315_n ) capacitor \
 c=0.00175172f //x=95.58 //y=2.26 //x2=95.395 //y2=1.675
cc_8381 ( N_noxref_22_c_12668_n N_noxref_67_c_19324_n ) capacitor \
 c=5.72205e-19 //x=95.58 //y=2.38 //x2=96.28 //y2=0.71
cc_8382 ( N_noxref_22_c_12702_n N_noxref_67_c_19324_n ) capacitor \
 c=8.37879e-19 //x=95.58 //y=2.26 //x2=96.28 //y2=0.71
cc_8383 ( N_noxref_22_c_12712_n N_noxref_67_c_19324_n ) capacitor c=0.0202024f \
 //x=95.615 //y=1.085 //x2=96.28 //y2=0.71
cc_8384 ( N_noxref_22_c_12721_n N_noxref_67_c_19324_n ) capacitor \
 c=0.00825432f //x=96.145 //y=1.085 //x2=96.28 //y2=0.71
cc_8385 ( N_noxref_22_c_12724_n N_noxref_67_c_19324_n ) capacitor c=2.1838e-19 \
 //x=95.58 //y=2.26 //x2=96.28 //y2=0.71
cc_8386 ( N_noxref_22_c_12712_n N_noxref_67_M58_noxref_s ) capacitor \
 c=0.00830822f //x=95.615 //y=1.085 //x2=94.29 //y2=0.545
cc_8387 ( N_noxref_22_c_12720_n N_noxref_67_M58_noxref_s ) capacitor \
 c=0.00271091f //x=95.99 //y=1.585 //x2=94.29 //y2=0.545
cc_8388 ( N_noxref_22_c_12721_n N_noxref_67_M58_noxref_s ) capacitor \
 c=0.0142835f //x=96.145 //y=1.085 //x2=94.29 //y2=0.545
cc_8389 ( N_noxref_23_c_13044_n N_Q_c_13334_n ) capacitor c=0.00149649f \
 //x=95.88 //y=1.535 //x2=98.17 //y2=1.935
cc_8390 ( N_noxref_23_c_13054_n N_Q_c_13334_n ) capacitor c=0.00189939f \
 //x=95.88 //y=1.74 //x2=98.17 //y2=1.935
cc_8391 ( N_noxref_23_c_13057_n N_Q_c_13334_n ) capacitor c=0.00329389f \
 //x=96.235 //y=1.825 //x2=98.17 //y2=1.935
cc_8392 ( N_noxref_23_c_13091_n N_Q_c_13334_n ) capacitor c=0.00587899f \
 //x=95.875 //y=1.405 //x2=98.17 //y2=1.935
cc_8393 ( N_noxref_23_c_13120_p N_Q_c_13334_n ) capacitor c=0.0010801f \
 //x=97.91 //y=1.435 //x2=98.17 //y2=1.935
cc_8394 ( N_noxref_23_c_13121_p N_Q_c_13334_n ) capacitor c=0.00523499f \
 //x=97.91 //y=1.745 //x2=98.17 //y2=1.935
cc_8395 ( N_noxref_23_c_13122_p N_Q_c_13334_n ) capacitor c=0.00376062f \
 //x=97.91 //y=2.1 //x2=98.17 //y2=1.935
cc_8396 ( N_noxref_23_c_13123_p N_Q_c_13334_n ) capacitor c=0.00934105f \
 //x=98.285 //y=1.59 //x2=98.17 //y2=1.935
cc_8397 ( N_noxref_23_c_13124_p N_Q_c_13334_n ) capacitor c=0.00362207f \
 //x=98.44 //y=1.435 //x2=98.17 //y2=1.935
cc_8398 ( N_noxref_23_c_13056_n N_Q_c_13343_n ) capacitor c=0.00315048f \
 //x=96.235 //y=5.39 //x2=98.175 //y2=5.42
cc_8399 ( N_noxref_23_c_13084_n N_Q_c_13343_n ) capacitor c=5.82161e-19 \
 //x=95.837 //y=5.39 //x2=98.175 //y2=5.42
cc_8400 ( N_noxref_23_M181_noxref_g N_Q_c_13343_n ) capacitor c=0.00141266f \
 //x=97.955 //y=6.2 //x2=98.175 //y2=5.42
cc_8401 ( N_noxref_23_M182_noxref_g N_Q_c_13343_n ) capacitor c=0.00377331f \
 //x=98.395 //y=6.2 //x2=98.175 //y2=5.42
cc_8402 ( N_noxref_23_c_13123_p N_Q_c_13347_n ) capacitor c=0.00180253f \
 //x=98.285 //y=1.59 //x2=98.455 //y2=2.02
cc_8403 ( N_noxref_23_c_12995_n N_Q_c_13348_n ) capacitor c=0.00329389f \
 //x=96.32 //y=4.095 //x2=98.255 //y2=2.02
cc_8404 ( N_noxref_23_c_13131_p N_Q_c_13348_n ) capacitor c=0.00376062f \
 //x=97.8 //y=2.265 //x2=98.255 //y2=2.02
cc_8405 ( N_noxref_23_M182_noxref_g N_Q_c_13350_n ) capacitor c=0.00913042f \
 //x=98.395 //y=6.2 //x2=98.455 //y2=5.14
cc_8406 ( N_noxref_23_c_12997_n N_Q_c_13351_n ) capacitor c=0.00293539f \
 //x=96.32 //y=5.305 //x2=98.26 //y2=5.14
cc_8407 ( N_noxref_23_M181_noxref_g N_Q_c_13351_n ) capacitor c=0.00427521f \
 //x=97.955 //y=6.2 //x2=98.26 //y2=5.14
cc_8408 ( N_noxref_23_c_13135_p N_Q_c_13351_n ) capacitor c=0.00262283f \
 //x=98.32 //y=4.97 //x2=98.26 //y2=5.14
cc_8409 ( N_noxref_23_c_12995_n N_Q_c_13354_n ) capacitor c=0.00421015f \
 //x=96.32 //y=4.095 //x2=98.54 //y2=4.1
cc_8410 ( N_noxref_23_c_13074_n N_Q_c_13354_n ) capacitor c=0.0784539f \
 //x=97.8 //y=4.095 //x2=98.54 //y2=4.1
cc_8411 ( N_noxref_23_c_13138_p N_Q_c_13354_n ) capacitor c=2.80283e-19 \
 //x=97.8 //y=4.415 //x2=98.54 //y2=4.1
cc_8412 ( N_noxref_23_c_13139_p N_Q_c_13354_n ) capacitor c=0.017436f //x=97.8 \
 //y=2.265 //x2=98.54 //y2=4.1
cc_8413 ( N_noxref_23_c_13140_p N_Q_c_13354_n ) capacitor c=0.0043838f \
 //x=97.8 //y=2.265 //x2=98.54 //y2=4.1
cc_8414 ( N_noxref_23_c_13131_p N_Q_c_13354_n ) capacitor c=0.00270592f \
 //x=97.8 //y=2.265 //x2=98.54 //y2=4.1
cc_8415 ( N_noxref_23_c_13138_p N_Q_c_13360_n ) capacitor c=0.0207072f \
 //x=97.8 //y=4.415 //x2=98.54 //y2=4.42
cc_8416 ( N_noxref_23_c_13075_n N_Q_c_13360_n ) capacitor c=3.165e-19 //x=97.8 \
 //y=4.76 //x2=98.54 //y2=4.42
cc_8417 ( N_noxref_23_c_13144_p N_Q_c_13360_n ) capacitor c=0.00264546f \
 //x=97.8 //y=4.25 //x2=98.54 //y2=4.42
cc_8418 ( N_noxref_23_c_13145_p N_Q_c_13360_n ) capacitor c=0.00319351f \
 //x=97.8 //y=4.255 //x2=98.54 //y2=4.42
cc_8419 ( N_noxref_23_c_13135_p N_Q_c_13360_n ) capacitor c=0.00107851f \
 //x=98.32 //y=4.97 //x2=98.54 //y2=4.42
cc_8420 ( N_noxref_23_c_12997_n N_Q_c_13365_n ) capacitor c=0.00182914f \
 //x=96.32 //y=5.305 //x2=98.54 //y2=5.055
cc_8421 ( N_noxref_23_c_13075_n N_Q_c_13365_n ) capacitor c=0.0312211f \
 //x=97.8 //y=4.76 //x2=98.54 //y2=5.055
cc_8422 ( N_noxref_23_c_13149_p N_Q_c_13365_n ) capacitor c=0.00503696f \
 //x=97.8 //y=4.88 //x2=98.54 //y2=5.055
cc_8423 ( N_noxref_23_c_13135_p N_Q_c_13365_n ) capacitor c=0.00208891f \
 //x=98.32 //y=4.97 //x2=98.54 //y2=5.055
cc_8424 ( N_noxref_23_c_13151_p N_Q_c_13365_n ) capacitor c=0.00140024f \
 //x=98.03 //y=4.97 //x2=98.54 //y2=5.055
cc_8425 ( N_noxref_23_c_13044_n N_Q_c_13370_n ) capacitor c=0.00142298f \
 //x=95.88 //y=1.535 //x2=98.17 //y2=1.185
cc_8426 ( N_noxref_23_c_13091_n N_Q_c_13370_n ) capacitor c=0.00109769f \
 //x=95.875 //y=1.405 //x2=98.17 //y2=1.185
cc_8427 ( N_noxref_23_c_13154_p N_Q_c_13370_n ) capacitor c=0.0018223f \
 //x=97.91 //y=1.09 //x2=98.17 //y2=1.185
cc_8428 ( N_noxref_23_c_13120_p N_Q_c_13370_n ) capacitor c=0.00375161f \
 //x=97.91 //y=1.435 //x2=98.17 //y2=1.185
cc_8429 ( N_noxref_23_c_13156_p N_Q_c_13370_n ) capacitor c=5.57924e-19 \
 //x=98.285 //y=0.935 //x2=98.17 //y2=1.185
cc_8430 ( N_noxref_23_c_13123_p N_Q_c_13370_n ) capacitor c=5.75878e-19 \
 //x=98.285 //y=1.59 //x2=98.17 //y2=1.185
cc_8431 ( N_noxref_23_c_13158_p N_Q_c_13370_n ) capacitor c=0.00160969f \
 //x=98.44 //y=1.09 //x2=98.17 //y2=1.185
cc_8432 ( N_noxref_23_c_13124_p N_Q_c_13370_n ) capacitor c=0.00411132f \
 //x=98.44 //y=1.435 //x2=98.17 //y2=1.185
cc_8433 ( N_noxref_23_c_13138_p N_Q_c_13378_n ) capacitor c=6.26985e-19 \
 //x=97.8 //y=4.415 //x2=98.54 //y2=4.25
cc_8434 ( N_noxref_23_c_13144_p N_Q_c_13378_n ) capacitor c=0.0102196f \
 //x=97.8 //y=4.25 //x2=98.54 //y2=4.25
cc_8435 ( N_noxref_23_c_13135_p N_Q_c_13378_n ) capacitor c=2.84121e-19 \
 //x=98.32 //y=4.97 //x2=98.54 //y2=4.25
cc_8436 ( N_noxref_23_c_13138_p Q ) capacitor c=0.00324397f //x=97.8 //y=4.415 \
 //x2=98.54 //y2=4.25
cc_8437 ( N_noxref_23_c_13145_p Q ) capacitor c=0.0218494f //x=97.8 //y=4.255 \
 //x2=98.54 //y2=4.25
cc_8438 ( N_noxref_23_M181_noxref_g N_Q_c_13383_n ) capacitor c=0.0162066f \
 //x=97.955 //y=6.2 //x2=98.175 //y2=5.56
cc_8439 ( N_noxref_23_M182_noxref_g N_Q_c_13383_n ) capacitor c=0.0162066f \
 //x=98.395 //y=6.2 //x2=98.175 //y2=5.56
cc_8440 ( N_noxref_23_c_13135_p N_Q_c_13383_n ) capacitor c=0.00290963f \
 //x=98.32 //y=4.97 //x2=98.175 //y2=5.56
cc_8441 ( N_noxref_23_c_13154_p N_Q_M60_noxref_d ) capacitor c=0.00137914f \
 //x=97.91 //y=1.09 //x2=97.985 //y2=1.09
cc_8442 ( N_noxref_23_c_13120_p N_Q_M60_noxref_d ) capacitor c=0.0023891f \
 //x=97.91 //y=1.435 //x2=97.985 //y2=1.09
cc_8443 ( N_noxref_23_c_13156_p N_Q_M60_noxref_d ) capacitor c=0.0020782f \
 //x=98.285 //y=0.935 //x2=97.985 //y2=1.09
cc_8444 ( N_noxref_23_c_13123_p N_Q_M60_noxref_d ) capacitor c=0.00356097f \
 //x=98.285 //y=1.59 //x2=97.985 //y2=1.09
cc_8445 ( N_noxref_23_c_13158_p N_Q_M60_noxref_d ) capacitor c=0.00138452f \
 //x=98.44 //y=1.09 //x2=97.985 //y2=1.09
cc_8446 ( N_noxref_23_c_13124_p N_Q_M60_noxref_d ) capacitor c=0.00235934f \
 //x=98.44 //y=1.435 //x2=97.985 //y2=1.09
cc_8447 ( N_noxref_23_c_13056_n N_VDD_c_14694_n ) capacitor c=2.26208e-19 \
 //x=96.235 //y=5.39 //x2=98.54 //y2=7.58
cc_8448 ( N_noxref_23_c_13066_n N_VDD_c_14694_n ) capacitor c=4.99801e-19 \
 //x=96.32 //y=4.415 //x2=98.54 //y2=7.58
cc_8449 ( N_noxref_23_c_13138_p N_VDD_c_14694_n ) capacitor c=3.0454e-19 \
 //x=97.8 //y=4.415 //x2=98.54 //y2=7.58
cc_8450 ( N_noxref_23_c_13075_n N_VDD_c_14694_n ) capacitor c=5.73169e-19 \
 //x=97.8 //y=4.76 //x2=98.54 //y2=7.58
cc_8451 ( N_noxref_23_c_13149_p N_VDD_c_14694_n ) capacitor c=3.40755e-19 \
 //x=97.8 //y=4.88 //x2=98.54 //y2=7.58
cc_8452 ( N_noxref_23_c_13056_n N_VDD_c_14584_n ) capacitor c=0.00135523f \
 //x=96.235 //y=5.39 //x2=96.89 //y2=7.585
cc_8453 ( N_noxref_23_c_13066_n N_VDD_c_14584_n ) capacitor c=4.02953e-19 \
 //x=96.32 //y=4.415 //x2=96.89 //y2=7.585
cc_8454 ( N_noxref_23_c_13027_n N_VDD_c_14584_n ) capacitor c=0.00488797f \
 //x=94.96 //y=5.56 //x2=96.89 //y2=7.585
cc_8455 ( N_noxref_23_c_13099_n N_VDD_c_14584_n ) capacitor c=0.00513429f \
 //x=95.84 //y=5.56 //x2=96.89 //y2=7.585
cc_8456 ( N_noxref_23_c_13075_n N_VDD_c_14703_n ) capacitor c=5.48929e-19 \
 //x=97.8 //y=4.76 //x2=98.53 //y2=7.585
cc_8457 ( N_noxref_23_M181_noxref_g N_VDD_c_14703_n ) capacitor c=0.00753931f \
 //x=97.955 //y=6.2 //x2=98.53 //y2=7.585
cc_8458 ( N_noxref_23_M182_noxref_g N_VDD_c_14703_n ) capacitor c=0.00751326f \
 //x=98.395 //y=6.2 //x2=98.53 //y2=7.585
cc_8459 ( N_noxref_23_c_12997_n N_VDD_c_13800_n ) capacitor c=0.00128037f \
 //x=96.32 //y=5.305 //x2=93.73 //y2=7.585
cc_8460 ( N_noxref_23_c_13027_n N_VDD_c_13800_n ) capacitor c=0.00535462f \
 //x=94.96 //y=5.56 //x2=93.73 //y2=7.585
cc_8461 ( N_noxref_23_c_13066_n N_VDD_c_14673_n ) capacitor c=0.0019054f \
 //x=96.32 //y=4.415 //x2=97.06 //y2=7.585
cc_8462 ( N_noxref_23_c_12997_n N_VDD_c_14673_n ) capacitor c=0.0249185f \
 //x=96.32 //y=5.305 //x2=97.06 //y2=7.585
cc_8463 ( N_noxref_23_c_13138_p N_VDD_c_14673_n ) capacitor c=0.0019054f \
 //x=97.8 //y=4.415 //x2=97.06 //y2=7.585
cc_8464 ( N_noxref_23_c_13075_n N_VDD_c_14673_n ) capacitor c=0.0128286f \
 //x=97.8 //y=4.76 //x2=97.06 //y2=7.585
cc_8465 ( N_noxref_23_c_13084_n N_VDD_c_14673_n ) capacitor c=0.00265362f \
 //x=95.837 //y=5.39 //x2=97.06 //y2=7.585
cc_8466 ( N_noxref_23_c_13088_n N_VDD_c_14673_n ) capacitor c=0.00486566f \
 //x=96.32 //y=4.25 //x2=97.06 //y2=7.585
cc_8467 ( N_noxref_23_c_13144_p N_VDD_c_14673_n ) capacitor c=0.00486566f \
 //x=97.8 //y=4.25 //x2=97.06 //y2=7.585
cc_8468 ( N_noxref_23_c_13195_p N_VDD_c_14673_n ) capacitor c=0.0183218f \
 //x=97.64 //y=4.255 //x2=97.06 //y2=7.585
cc_8469 ( N_noxref_23_c_13099_n N_VDD_c_14673_n ) capacitor c=0.00899475f \
 //x=95.84 //y=5.56 //x2=97.06 //y2=7.585
cc_8470 ( N_noxref_23_c_13149_p N_VDD_c_14673_n ) capacitor c=0.0079528f \
 //x=97.8 //y=4.88 //x2=97.06 //y2=7.585
cc_8471 ( N_noxref_23_M181_noxref_g N_VDD_c_14673_n ) capacitor c=0.00873098f \
 //x=97.955 //y=6.2 //x2=97.06 //y2=7.585
cc_8472 ( N_noxref_23_c_13151_p N_VDD_c_14673_n ) capacitor c=0.00799922f \
 //x=98.03 //y=4.97 //x2=97.06 //y2=7.585
cc_8473 ( N_noxref_23_c_13149_p N_VDD_c_14720_n ) capacitor c=0.00235165f \
 //x=97.8 //y=4.88 //x2=98.54 //y2=7.58
cc_8474 ( N_noxref_23_c_13135_p N_VDD_c_14720_n ) capacitor c=0.0195827f \
 //x=98.32 //y=4.97 //x2=98.54 //y2=7.58
cc_8475 ( N_noxref_23_c_13151_p N_VDD_c_14720_n ) capacitor c=2.63786e-19 \
 //x=98.03 //y=4.97 //x2=98.54 //y2=7.58
cc_8476 ( N_noxref_23_c_13056_n N_VDD_M181_noxref_s ) capacitor c=0.00343522f \
 //x=96.235 //y=5.39 //x2=97.6 //y2=5.2
cc_8477 ( N_noxref_23_c_13138_p N_VDD_M181_noxref_s ) capacitor c=0.00247632f \
 //x=97.8 //y=4.415 //x2=97.6 //y2=5.2
cc_8478 ( N_noxref_23_c_13075_n N_VDD_M181_noxref_s ) capacitor c=0.0208734f \
 //x=97.8 //y=4.76 //x2=97.6 //y2=5.2
cc_8479 ( N_noxref_23_c_13084_n N_VDD_M181_noxref_s ) capacitor c=0.00575207f \
 //x=95.837 //y=5.39 //x2=97.6 //y2=5.2
cc_8480 ( N_noxref_23_c_13145_p N_VDD_M181_noxref_s ) capacitor c=6.60267e-19 \
 //x=97.8 //y=4.255 //x2=97.6 //y2=5.2
cc_8481 ( N_noxref_23_c_13195_p N_VDD_M181_noxref_s ) capacitor c=3.46335e-19 \
 //x=97.64 //y=4.255 //x2=97.6 //y2=5.2
cc_8482 ( N_noxref_23_c_13149_p N_VDD_M181_noxref_s ) capacitor c=0.00986169f \
 //x=97.8 //y=4.88 //x2=97.6 //y2=5.2
cc_8483 ( N_noxref_23_M181_noxref_g N_VDD_M181_noxref_s ) capacitor \
 c=0.0573441f //x=97.955 //y=6.2 //x2=97.6 //y2=5.2
cc_8484 ( N_noxref_23_c_13151_p N_VDD_M181_noxref_s ) capacitor c=0.00410556f \
 //x=98.03 //y=4.97 //x2=97.6 //y2=5.2
cc_8485 ( N_noxref_23_M182_noxref_g N_VDD_M182_noxref_d ) capacitor \
 c=0.0572684f //x=98.395 //y=6.2 //x2=98.47 //y2=5.2
cc_8486 ( N_noxref_23_c_12998_n N_noxref_44_c_16100_n ) capacitor \
 c=2.94655e-19 //x=89.22 //y=1.36 //x2=91.065 //y2=5.39
cc_8487 ( N_noxref_23_c_12998_n N_noxref_44_c_16103_n ) capacitor \
 c=3.81263e-19 //x=89.22 //y=1.36 //x2=89.295 //y2=5.39
cc_8488 ( N_noxref_23_c_12997_n N_noxref_45_c_16271_n ) capacitor \
 c=5.76261e-19 //x=96.32 //y=5.305 //x2=94.405 //y2=5.39
cc_8489 ( N_noxref_23_c_13001_n N_noxref_45_c_16271_n ) capacitor \
 c=2.00354e-19 //x=92.55 //y=1.36 //x2=94.405 //y2=5.39
cc_8490 ( N_noxref_23_c_13009_n N_noxref_45_c_16271_n ) capacitor c=0.0327245f \
 //x=94.96 //y=5.39 //x2=94.405 //y2=5.39
cc_8491 ( N_noxref_23_c_13027_n N_noxref_45_c_16271_n ) capacitor \
 c=0.00238429f //x=94.96 //y=5.56 //x2=94.405 //y2=5.39
cc_8492 ( N_noxref_23_c_13001_n N_noxref_45_c_16281_n ) capacitor c=7.9384e-19 \
 //x=92.55 //y=1.36 //x2=92.615 //y2=5.39
cc_8493 ( N_noxref_23_c_12994_n N_noxref_45_c_16283_n ) capacitor \
 c=0.00311493f //x=95.715 //y=5.39 //x2=95.285 //y2=7.09
cc_8494 ( N_noxref_23_c_13009_n N_noxref_45_c_16283_n ) capacitor \
 c=0.00538798f //x=94.96 //y=5.39 //x2=95.285 //y2=7.09
cc_8495 ( N_noxref_23_c_13027_n N_noxref_45_c_16283_n ) capacitor \
 c=0.00406191f //x=94.96 //y=5.56 //x2=95.285 //y2=7.09
cc_8496 ( N_noxref_23_c_12994_n N_noxref_45_c_16297_n ) capacitor \
 c=0.00305195f //x=95.715 //y=5.39 //x2=96.15 //y2=7.09
cc_8497 ( N_noxref_23_c_13056_n N_noxref_45_c_16297_n ) capacitor \
 c=0.00291085f //x=96.235 //y=5.39 //x2=96.15 //y2=7.09
cc_8498 ( N_noxref_23_c_13084_n N_noxref_45_c_16297_n ) capacitor \
 c=0.00559082f //x=95.837 //y=5.39 //x2=96.15 //y2=7.09
cc_8499 ( N_noxref_23_c_13099_n N_noxref_45_c_16297_n ) capacitor \
 c=0.00396177f //x=95.84 //y=5.56 //x2=96.15 //y2=7.09
cc_8500 ( N_noxref_23_c_13009_n N_noxref_45_c_16259_n ) capacitor \
 c=0.00239626f //x=94.96 //y=5.39 //x2=91.62 //y2=5.39
cc_8501 ( N_noxref_23_c_12994_n N_noxref_45_c_16286_n ) capacitor \
 c=0.00459659f //x=95.715 //y=5.39 //x2=95.4 //y2=7.09
cc_8502 ( N_noxref_23_c_13056_n N_noxref_45_c_16301_n ) capacitor \
 c=0.00536247f //x=96.235 //y=5.39 //x2=96.28 //y2=6.92
cc_8503 ( N_noxref_23_c_12997_n N_noxref_45_c_16290_n ) capacitor \
 c=5.23099e-19 //x=96.32 //y=5.305 //x2=94.52 //y2=5.39
cc_8504 ( N_noxref_23_c_13009_n N_noxref_45_c_16290_n ) capacitor c=0.010446f \
 //x=94.96 //y=5.39 //x2=94.52 //y2=5.39
cc_8505 ( N_noxref_23_c_13027_n N_noxref_45_c_16290_n ) capacitor c=0.0649815f \
 //x=94.96 //y=5.56 //x2=94.52 //y2=5.39
cc_8506 ( N_noxref_23_c_12994_n N_noxref_45_M178_noxref_d ) capacitor \
 c=0.00678641f //x=95.715 //y=5.39 //x2=95.255 //y2=5.205
cc_8507 ( N_noxref_23_c_13084_n N_noxref_45_M178_noxref_d ) capacitor \
 c=0.00184359f //x=95.837 //y=5.39 //x2=95.255 //y2=5.205
cc_8508 ( N_noxref_23_c_13027_n N_noxref_45_M178_noxref_d ) capacitor \
 c=0.0476949f //x=94.96 //y=5.56 //x2=95.255 //y2=5.205
cc_8509 ( N_noxref_23_c_13099_n N_noxref_45_M178_noxref_d ) capacitor \
 c=0.0473507f //x=95.84 //y=5.56 //x2=95.255 //y2=5.205
cc_8510 ( N_noxref_23_c_13056_n N_noxref_45_M180_noxref_d ) capacitor \
 c=0.00735506f //x=96.235 //y=5.39 //x2=96.135 //y2=5.205
cc_8511 ( N_noxref_23_c_13084_n N_noxref_45_M180_noxref_d ) capacitor \
 c=0.0012641f //x=95.837 //y=5.39 //x2=96.135 //y2=5.205
cc_8512 ( N_noxref_23_c_13088_n N_noxref_45_M180_noxref_d ) capacitor \
 c=0.00165396f //x=96.32 //y=4.25 //x2=96.135 //y2=5.205
cc_8513 ( N_noxref_23_c_13099_n N_noxref_45_M180_noxref_d ) capacitor \
 c=0.0473507f //x=95.84 //y=5.56 //x2=96.135 //y2=5.205
cc_8514 ( N_noxref_23_c_12998_n N_GND_c_16608_n ) capacitor c=0.00185137f \
 //x=89.22 //y=1.36 //x2=88.25 //y2=1.015
cc_8515 ( N_noxref_23_c_13012_n N_GND_c_16608_n ) capacitor c=7.42708e-19 \
 //x=89.385 //y=1.405 //x2=88.25 //y2=1.015
cc_8516 ( N_noxref_23_M55_noxref_d N_GND_c_16608_n ) capacitor c=2.62581e-19 \
 //x=89.03 //y=1.085 //x2=88.25 //y2=1.015
cc_8517 ( N_noxref_23_c_12998_n N_GND_c_17290_n ) capacitor c=0.00560741f \
 //x=89.22 //y=1.36 //x2=91.495 //y2=0.175
cc_8518 ( N_noxref_23_c_13012_n N_GND_c_17290_n ) capacitor c=0.00701775f \
 //x=89.385 //y=1.405 //x2=91.495 //y2=0.175
cc_8519 ( N_noxref_23_c_12990_n N_GND_c_17290_n ) capacitor c=0.113183f \
 //x=92.42 //y=1.405 //x2=91.495 //y2=0.175
cc_8520 ( N_noxref_23_M55_noxref_d N_GND_c_17290_n ) capacitor c=2.01013e-19 \
 //x=89.03 //y=1.085 //x2=91.495 //y2=0.175
cc_8521 ( N_noxref_23_c_12998_n N_GND_c_16615_n ) capacitor c=4.96199e-19 \
 //x=89.22 //y=1.36 //x2=91.58 //y2=1.015
cc_8522 ( N_noxref_23_c_13001_n N_GND_c_16615_n ) capacitor c=0.00303749f \
 //x=92.55 //y=1.36 //x2=91.58 //y2=1.015
cc_8523 ( N_noxref_23_c_13012_n N_GND_c_16615_n ) capacitor c=3.47579e-19 \
 //x=89.385 //y=1.405 //x2=91.58 //y2=1.015
cc_8524 ( N_noxref_23_c_12990_n N_GND_c_16615_n ) capacitor c=0.0221823f \
 //x=92.42 //y=1.405 //x2=91.58 //y2=1.015
cc_8525 ( N_noxref_23_M57_noxref_d N_GND_c_16615_n ) capacitor c=2.62581e-19 \
 //x=92.36 //y=1.085 //x2=91.58 //y2=1.015
cc_8526 ( N_noxref_23_c_13001_n N_GND_c_17291_n ) capacitor c=0.00848351f \
 //x=92.55 //y=1.36 //x2=94.825 //y2=0.175
cc_8527 ( N_noxref_23_c_12990_n N_GND_c_17291_n ) capacitor c=0.0330907f \
 //x=92.42 //y=1.405 //x2=94.825 //y2=0.175
cc_8528 ( N_noxref_23_c_13015_n N_GND_c_17291_n ) capacitor c=0.00561615f \
 //x=92.68 //y=1.405 //x2=94.825 //y2=0.175
cc_8529 ( N_noxref_23_c_13016_n N_GND_c_17291_n ) capacitor c=0.105627f \
 //x=95.715 //y=1.405 //x2=94.825 //y2=0.175
cc_8530 ( N_noxref_23_M57_noxref_d N_GND_c_17291_n ) capacitor c=2.01013e-19 \
 //x=92.36 //y=1.085 //x2=94.825 //y2=0.175
cc_8531 ( N_noxref_23_c_13044_n N_GND_c_17294_n ) capacitor c=0.00195467f \
 //x=95.88 //y=1.535 //x2=94.91 //y2=1.02
cc_8532 ( N_noxref_23_c_13001_n N_GND_c_17294_n ) capacitor c=8.32974e-19 \
 //x=92.55 //y=1.36 //x2=94.91 //y2=1.02
cc_8533 ( N_noxref_23_c_13009_n N_GND_c_17294_n ) capacitor c=9.01285e-19 \
 //x=94.96 //y=5.39 //x2=94.91 //y2=1.02
cc_8534 ( N_noxref_23_c_13091_n N_GND_c_17294_n ) capacitor c=8.08914e-19 \
 //x=95.875 //y=1.405 //x2=94.91 //y2=1.02
cc_8535 ( N_noxref_23_c_13016_n N_GND_c_17294_n ) capacitor c=0.0204811f \
 //x=95.715 //y=1.405 //x2=94.91 //y2=1.02
cc_8536 ( N_noxref_23_M59_noxref_d N_GND_c_17294_n ) capacitor c=2.62581e-19 \
 //x=95.69 //y=1.085 //x2=94.91 //y2=1.02
cc_8537 ( N_noxref_23_c_13044_n N_GND_c_17344_n ) capacitor c=0.00524308f \
 //x=95.88 //y=1.535 //x2=98.54 //y2=0.18
cc_8538 ( N_noxref_23_c_13057_n N_GND_c_17344_n ) capacitor c=0.0062416f \
 //x=96.235 //y=1.825 //x2=98.54 //y2=0.18
cc_8539 ( N_noxref_23_c_13066_n N_GND_c_17344_n ) capacitor c=3.81645e-19 \
 //x=96.32 //y=4.415 //x2=98.54 //y2=0.18
cc_8540 ( N_noxref_23_c_13138_p N_GND_c_17344_n ) capacitor c=3.80542e-19 \
 //x=97.8 //y=4.415 //x2=98.54 //y2=0.18
cc_8541 ( N_noxref_23_c_13139_p N_GND_c_17344_n ) capacitor c=0.00249122f \
 //x=97.8 //y=2.265 //x2=98.54 //y2=0.18
cc_8542 ( N_noxref_23_c_13091_n N_GND_c_17344_n ) capacitor c=0.00777895f \
 //x=95.875 //y=1.405 //x2=98.54 //y2=0.18
cc_8543 ( N_noxref_23_c_13016_n N_GND_c_17344_n ) capacitor c=0.038217f \
 //x=95.715 //y=1.405 //x2=98.54 //y2=0.18
cc_8544 ( N_noxref_23_c_13140_p N_GND_c_17344_n ) capacitor c=7.5371e-19 \
 //x=97.8 //y=2.265 //x2=98.54 //y2=0.18
cc_8545 ( N_noxref_23_M59_noxref_d N_GND_c_17344_n ) capacitor c=2.01013e-19 \
 //x=95.69 //y=1.085 //x2=98.54 //y2=0.18
cc_8546 ( N_noxref_23_c_13057_n N_GND_c_17306_n ) capacitor c=7.45235e-19 \
 //x=96.235 //y=1.825 //x2=96.89 //y2=0.175
cc_8547 ( N_noxref_23_c_13139_p N_GND_c_17397_n ) capacitor c=0.00114179f \
 //x=97.8 //y=2.265 //x2=98.085 //y2=0.715
cc_8548 ( N_noxref_23_c_13140_p N_GND_c_17397_n ) capacitor c=3.95714e-19 \
 //x=97.8 //y=2.265 //x2=98.085 //y2=0.715
cc_8549 ( N_noxref_23_c_13154_p N_GND_c_17397_n ) capacitor c=0.0125549f \
 //x=97.91 //y=1.09 //x2=98.085 //y2=0.715
cc_8550 ( N_noxref_23_c_13131_p N_GND_c_17397_n ) capacitor c=2.1838e-19 \
 //x=97.8 //y=2.265 //x2=98.085 //y2=0.715
cc_8551 ( N_noxref_23_c_13158_p N_GND_c_17401_n ) capacitor c=0.0133145f \
 //x=98.44 //y=1.09 //x2=98.575 //y2=0.715
cc_8552 ( N_noxref_23_c_12990_n N_GND_c_16641_n ) capacitor c=0.0189706f \
 //x=92.42 //y=1.405 //x2=90.4 //y2=0.175
cc_8553 ( N_noxref_23_M55_noxref_d N_GND_c_16641_n ) capacitor c=0.00128649f \
 //x=89.03 //y=1.085 //x2=90.4 //y2=0.175
cc_8554 ( N_noxref_23_c_12995_n N_GND_c_17321_n ) capacitor c=0.00135353f \
 //x=96.32 //y=4.095 //x2=93.73 //y2=0.175
cc_8555 ( N_noxref_23_c_13016_n N_GND_c_17321_n ) capacitor c=0.0183315f \
 //x=95.715 //y=1.405 //x2=93.73 //y2=0.175
cc_8556 ( N_noxref_23_M57_noxref_d N_GND_c_17321_n ) capacitor c=0.00129112f \
 //x=92.36 //y=1.085 //x2=93.73 //y2=0.175
cc_8557 ( N_noxref_23_c_13054_n N_GND_c_17332_n ) capacitor c=0.00248396f \
 //x=95.88 //y=1.74 //x2=97.06 //y2=0.175
cc_8558 ( N_noxref_23_c_13057_n N_GND_c_17332_n ) capacitor c=0.0273278f \
 //x=96.235 //y=1.825 //x2=97.06 //y2=0.175
cc_8559 ( N_noxref_23_c_13074_n N_GND_c_17332_n ) capacitor c=0.0103129f \
 //x=97.8 //y=4.095 //x2=97.06 //y2=0.175
cc_8560 ( N_noxref_23_c_13139_p N_GND_c_17332_n ) capacitor c=0.00682461f \
 //x=97.8 //y=2.265 //x2=97.06 //y2=0.175
cc_8561 ( N_noxref_23_c_13195_p N_GND_c_17332_n ) capacitor c=0.0035382f \
 //x=97.64 //y=4.255 //x2=97.06 //y2=0.175
cc_8562 ( N_noxref_23_c_13140_p N_GND_c_17332_n ) capacitor c=0.00788922f \
 //x=97.8 //y=2.265 //x2=97.06 //y2=0.175
cc_8563 ( N_noxref_23_c_13122_p N_GND_c_17332_n ) capacitor c=0.00427116f \
 //x=97.91 //y=2.1 //x2=97.06 //y2=0.175
cc_8564 ( N_noxref_23_c_13131_p N_GND_c_17332_n ) capacitor c=0.00687518f \
 //x=97.8 //y=2.265 //x2=97.06 //y2=0.175
cc_8565 ( N_noxref_23_M59_noxref_d N_GND_c_17332_n ) capacitor c=0.00165161f \
 //x=95.69 //y=1.085 //x2=97.06 //y2=0.175
cc_8566 ( N_noxref_23_c_13140_p N_GND_c_17416_n ) capacitor c=0.00230732f \
 //x=97.8 //y=2.265 //x2=98.66 //y2=0.175
cc_8567 ( N_noxref_23_c_13138_p N_GND_M60_noxref_s ) capacitor c=4.66358e-19 \
 //x=97.8 //y=4.415 //x2=97.555 //y2=0.55
cc_8568 ( N_noxref_23_c_13139_p N_GND_M60_noxref_s ) capacitor c=0.00297876f \
 //x=97.8 //y=2.265 //x2=97.555 //y2=0.55
cc_8569 ( N_noxref_23_c_13140_p N_GND_M60_noxref_s ) capacitor c=0.00651326f \
 //x=97.8 //y=2.265 //x2=97.555 //y2=0.55
cc_8570 ( N_noxref_23_c_13154_p N_GND_M60_noxref_s ) capacitor c=0.0301091f \
 //x=97.91 //y=1.09 //x2=97.555 //y2=0.55
cc_8571 ( N_noxref_23_c_13121_p N_GND_M60_noxref_s ) capacitor c=0.002132f \
 //x=97.91 //y=1.745 //x2=97.555 //y2=0.55
cc_8572 ( N_noxref_23_c_13122_p N_GND_M60_noxref_s ) capacitor c=0.00304786f \
 //x=97.91 //y=2.1 //x2=97.555 //y2=0.55
cc_8573 ( N_noxref_23_c_13156_p N_GND_M60_noxref_s ) capacitor c=0.00517463f \
 //x=98.285 //y=0.935 //x2=97.555 //y2=0.55
cc_8574 ( N_noxref_23_c_13158_p N_GND_M60_noxref_s ) capacitor c=0.0153553f \
 //x=98.44 //y=1.09 //x2=97.555 //y2=0.55
cc_8575 ( N_noxref_23_c_13124_p N_GND_M60_noxref_s ) capacitor c=0.00629878f \
 //x=98.44 //y=1.435 //x2=97.555 //y2=0.55
cc_8576 ( N_noxref_23_c_13131_p N_GND_M60_noxref_s ) capacitor c=0.00660555f \
 //x=97.8 //y=2.265 //x2=97.555 //y2=0.55
cc_8577 ( N_noxref_23_c_12998_n N_noxref_65_c_19194_n ) capacitor \
 c=0.00587436f //x=89.22 //y=1.36 //x2=89.62 //y2=0.71
cc_8578 ( N_noxref_23_c_12990_n N_noxref_65_c_19194_n ) capacitor \
 c=0.00227706f //x=92.42 //y=1.405 //x2=89.62 //y2=0.71
cc_8579 ( N_noxref_23_M55_noxref_d N_noxref_65_c_19194_n ) capacitor \
 c=0.0136817f //x=89.03 //y=1.085 //x2=89.62 //y2=0.71
cc_8580 ( N_noxref_23_c_12998_n N_noxref_65_M54_noxref_s ) capacitor \
 c=0.0123673f //x=89.22 //y=1.36 //x2=87.63 //y2=0.545
cc_8581 ( N_noxref_23_c_12990_n N_noxref_65_M54_noxref_s ) capacitor \
 c=0.00765968f //x=92.42 //y=1.405 //x2=87.63 //y2=0.545
cc_8582 ( N_noxref_23_M55_noxref_d N_noxref_65_M54_noxref_s ) capacitor \
 c=0.0446274f //x=89.03 //y=1.085 //x2=87.63 //y2=0.545
cc_8583 ( N_noxref_23_c_12990_n N_noxref_66_c_19243_n ) capacitor c=0.0110578f \
 //x=92.42 //y=1.405 //x2=91.98 //y2=1.76
cc_8584 ( N_noxref_23_c_13001_n N_noxref_66_c_19258_n ) capacitor c=0.0057298f \
 //x=92.55 //y=1.36 //x2=92.95 //y2=0.71
cc_8585 ( N_noxref_23_c_12990_n N_noxref_66_c_19258_n ) capacitor \
 c=0.00227706f //x=92.42 //y=1.405 //x2=92.95 //y2=0.71
cc_8586 ( N_noxref_23_c_13016_n N_noxref_66_c_19258_n ) capacitor \
 c=0.00523591f //x=95.715 //y=1.405 //x2=92.95 //y2=0.71
cc_8587 ( N_noxref_23_M57_noxref_d N_noxref_66_c_19258_n ) capacitor \
 c=0.0130616f //x=92.36 //y=1.085 //x2=92.95 //y2=0.71
cc_8588 ( N_noxref_23_c_13001_n N_noxref_66_M56_noxref_s ) capacitor \
 c=0.0103741f //x=92.55 //y=1.36 //x2=90.96 //y2=0.545
cc_8589 ( N_noxref_23_c_12990_n N_noxref_66_M56_noxref_s ) capacitor \
 c=0.0176835f //x=92.42 //y=1.405 //x2=90.96 //y2=0.545
cc_8590 ( N_noxref_23_c_13016_n N_noxref_66_M56_noxref_s ) capacitor \
 c=0.00742061f //x=95.715 //y=1.405 //x2=90.96 //y2=0.545
cc_8591 ( N_noxref_23_M57_noxref_d N_noxref_66_M56_noxref_s ) capacitor \
 c=0.0441031f //x=92.36 //y=1.085 //x2=90.96 //y2=0.545
cc_8592 ( N_noxref_23_c_13016_n N_noxref_67_c_19308_n ) capacitor c=0.0135245f \
 //x=95.715 //y=1.405 //x2=95.31 //y2=1.76
cc_8593 ( N_noxref_23_c_13058_n N_noxref_67_c_19315_n ) capacitor \
 c=0.00714695f //x=95.965 //y=1.825 //x2=95.395 //y2=1.675
cc_8594 ( N_noxref_23_c_12995_n N_noxref_67_c_19315_n ) capacitor \
 c=2.92748e-19 //x=96.32 //y=4.095 //x2=95.395 //y2=1.675
cc_8595 ( N_noxref_23_c_13044_n N_noxref_67_c_19324_n ) capacitor \
 c=0.00515582f //x=95.88 //y=1.535 //x2=96.28 //y2=0.71
cc_8596 ( N_noxref_23_c_13057_n N_noxref_67_c_19324_n ) capacitor \
 c=0.00332518f //x=96.235 //y=1.825 //x2=96.28 //y2=0.71
cc_8597 ( N_noxref_23_c_13091_n N_noxref_67_c_19324_n ) capacitor \
 c=0.00224828f //x=95.875 //y=1.405 //x2=96.28 //y2=0.71
cc_8598 ( N_noxref_23_c_13016_n N_noxref_67_c_19324_n ) capacitor \
 c=0.00185838f //x=95.715 //y=1.405 //x2=96.28 //y2=0.71
cc_8599 ( N_noxref_23_M59_noxref_d N_noxref_67_c_19324_n ) capacitor \
 c=0.0135038f //x=95.69 //y=1.085 //x2=96.28 //y2=0.71
cc_8600 ( N_noxref_23_c_13044_n N_noxref_67_M58_noxref_s ) capacitor \
 c=0.010254f //x=95.88 //y=1.535 //x2=94.29 //y2=0.545
cc_8601 ( N_noxref_23_c_13054_n N_noxref_67_M58_noxref_s ) capacitor \
 c=0.00775201f //x=95.88 //y=1.74 //x2=94.29 //y2=0.545
cc_8602 ( N_noxref_23_c_13057_n N_noxref_67_M58_noxref_s ) capacitor \
 c=0.00706721f //x=96.235 //y=1.825 //x2=94.29 //y2=0.545
cc_8603 ( N_noxref_23_c_13088_n N_noxref_67_M58_noxref_s ) capacitor \
 c=7.05604e-19 //x=96.32 //y=4.25 //x2=94.29 //y2=0.545
cc_8604 ( N_noxref_23_c_13091_n N_noxref_67_M58_noxref_s ) capacitor \
 c=0.0090031f //x=95.875 //y=1.405 //x2=94.29 //y2=0.545
cc_8605 ( N_noxref_23_c_13016_n N_noxref_67_M58_noxref_s ) capacitor \
 c=0.0219823f //x=95.715 //y=1.405 //x2=94.29 //y2=0.545
cc_8606 ( N_noxref_23_M59_noxref_d N_noxref_67_M58_noxref_s ) capacitor \
 c=0.0431094f //x=95.69 //y=1.085 //x2=94.29 //y2=0.545
cc_8607 ( N_Q_c_13343_n N_VDD_c_14694_n ) capacitor c=0.00259721f //x=98.175 \
 //y=5.42 //x2=98.54 //y2=7.58
cc_8608 ( N_Q_c_13350_n N_VDD_c_14694_n ) capacitor c=0.00200156f //x=98.455 \
 //y=5.14 //x2=98.54 //y2=7.58
cc_8609 ( N_Q_c_13360_n N_VDD_c_14694_n ) capacitor c=5.67953e-19 //x=98.54 \
 //y=4.42 //x2=98.54 //y2=7.58
cc_8610 ( N_Q_c_13383_n N_VDD_c_14694_n ) capacitor c=0.00241566f //x=98.175 \
 //y=5.56 //x2=98.54 //y2=7.58
cc_8611 ( N_Q_c_13343_n N_VDD_c_14703_n ) capacitor c=0.00100699f //x=98.175 \
 //y=5.42 //x2=98.53 //y2=7.585
cc_8612 ( N_Q_c_13350_n N_VDD_c_14703_n ) capacitor c=0.00202591f //x=98.455 \
 //y=5.14 //x2=98.53 //y2=7.585
cc_8613 ( N_Q_c_13383_n N_VDD_c_14703_n ) capacitor c=0.0138017f //x=98.175 \
 //y=5.56 //x2=98.53 //y2=7.585
cc_8614 ( N_Q_c_13351_n N_VDD_c_14673_n ) capacitor c=0.00484013f //x=98.26 \
 //y=5.14 //x2=97.06 //y2=7.585
cc_8615 ( N_Q_c_13365_n N_VDD_c_14673_n ) capacitor c=6.41958e-19 //x=98.54 \
 //y=5.055 //x2=97.06 //y2=7.585
cc_8616 ( N_Q_c_13383_n N_VDD_c_14673_n ) capacitor c=0.00819514f //x=98.175 \
 //y=5.56 //x2=97.06 //y2=7.585
cc_8617 ( N_Q_c_13343_n N_VDD_c_14720_n ) capacitor c=0.00295945f //x=98.175 \
 //y=5.42 //x2=98.54 //y2=7.58
cc_8618 ( N_Q_c_13360_n N_VDD_c_14720_n ) capacitor c=0.0035216f //x=98.54 \
 //y=4.42 //x2=98.54 //y2=7.58
cc_8619 ( N_Q_c_13365_n N_VDD_c_14720_n ) capacitor c=0.0241236f //x=98.54 \
 //y=5.055 //x2=98.54 //y2=7.58
cc_8620 ( N_Q_c_13378_n N_VDD_c_14720_n ) capacitor c=0.00439804f //x=98.54 \
 //y=4.25 //x2=98.54 //y2=7.58
cc_8621 ( N_Q_c_13383_n N_VDD_c_14720_n ) capacitor c=0.00825846f //x=98.175 \
 //y=5.56 //x2=98.54 //y2=7.58
cc_8622 ( N_Q_c_13343_n N_VDD_M181_noxref_s ) capacitor c=0.0465774f \
 //x=98.175 //y=5.42 //x2=97.6 //y2=5.2
cc_8623 ( N_Q_c_13383_n N_VDD_M181_noxref_s ) capacitor c=0.0897898f \
 //x=98.175 //y=5.56 //x2=97.6 //y2=5.2
cc_8624 ( N_Q_c_13343_n N_VDD_M182_noxref_d ) capacitor c=0.0486749f \
 //x=98.175 //y=5.42 //x2=98.47 //y2=5.2
cc_8625 ( N_Q_c_13350_n N_VDD_M182_noxref_d ) capacitor c=0.0201545f \
 //x=98.455 //y=5.14 //x2=98.47 //y2=5.2
cc_8626 ( N_Q_c_13360_n N_VDD_M182_noxref_d ) capacitor c=0.00501942f \
 //x=98.54 //y=4.42 //x2=98.47 //y2=5.2
cc_8627 ( N_Q_c_13378_n N_VDD_M182_noxref_d ) capacitor c=0.00163743f \
 //x=98.54 //y=4.25 //x2=98.47 //y2=5.2
cc_8628 ( Q N_VDD_M182_noxref_d ) capacitor c=0.00109078f //x=98.54 //y=4.25 \
 //x2=98.47 //y2=5.2
cc_8629 ( N_Q_c_13383_n N_VDD_M182_noxref_d ) capacitor c=0.0929254f \
 //x=98.175 //y=5.56 //x2=98.47 //y2=5.2
cc_8630 ( N_Q_c_13370_n N_GND_c_17294_n ) capacitor c=0.00306788f //x=98.17 \
 //y=1.185 //x2=94.91 //y2=1.02
cc_8631 ( N_Q_c_13347_n N_GND_c_17344_n ) capacitor c=0.00499609f //x=98.455 \
 //y=2.02 //x2=98.54 //y2=0.18
cc_8632 ( N_Q_c_13360_n N_GND_c_17344_n ) capacitor c=8.63284e-19 //x=98.54 \
 //y=4.42 //x2=98.54 //y2=0.18
cc_8633 ( N_Q_c_13370_n N_GND_c_17344_n ) capacitor c=0.00998676f //x=98.17 \
 //y=1.185 //x2=98.54 //y2=0.18
cc_8634 ( N_Q_M60_noxref_d N_GND_c_17344_n ) capacitor c=0.00119455f \
 //x=97.985 //y=1.09 //x2=98.54 //y2=0.18
cc_8635 ( N_Q_c_13370_n N_GND_c_17397_n ) capacitor c=0.00124813f //x=98.17 \
 //y=1.185 //x2=98.085 //y2=0.715
cc_8636 ( N_Q_c_13347_n N_GND_c_17401_n ) capacitor c=0.00323289f //x=98.455 \
 //y=2.02 //x2=98.575 //y2=0.715
cc_8637 ( N_Q_c_13370_n N_GND_c_17401_n ) capacitor c=0.00130539f //x=98.17 \
 //y=1.185 //x2=98.575 //y2=0.715
cc_8638 ( N_Q_c_13378_n N_GND_c_17401_n ) capacitor c=2.04781e-19 //x=98.54 \
 //y=4.25 //x2=98.575 //y2=0.715
cc_8639 ( N_Q_c_13334_n N_GND_c_17332_n ) capacitor c=0.00272952f //x=98.17 \
 //y=1.935 //x2=97.06 //y2=0.175
cc_8640 ( N_Q_c_13354_n N_GND_c_17332_n ) capacitor c=0.00100204f //x=98.54 \
 //y=4.1 //x2=97.06 //y2=0.175
cc_8641 ( N_Q_c_13334_n N_GND_c_17416_n ) capacitor c=0.00122336f //x=98.17 \
 //y=1.935 //x2=98.66 //y2=0.175
cc_8642 ( N_Q_c_13347_n N_GND_c_17416_n ) capacitor c=0.0293238f //x=98.455 \
 //y=2.02 //x2=98.66 //y2=0.175
cc_8643 ( N_Q_c_13334_n N_GND_M60_noxref_s ) capacitor c=0.0325498f //x=98.17 \
 //y=1.935 //x2=97.555 //y2=0.55
cc_8644 ( N_Q_c_13347_n N_GND_M60_noxref_s ) capacitor c=0.0042252f //x=98.455 \
 //y=2.02 //x2=97.555 //y2=0.55
cc_8645 ( N_Q_c_13360_n N_GND_M60_noxref_s ) capacitor c=8.68292e-19 //x=98.54 \
 //y=4.42 //x2=97.555 //y2=0.55
cc_8646 ( N_Q_c_13370_n N_GND_M60_noxref_s ) capacitor c=0.0161656f //x=98.17 \
 //y=1.185 //x2=97.555 //y2=0.55
cc_8647 ( N_Q_c_13378_n N_GND_M60_noxref_s ) capacitor c=4.73387e-19 //x=98.54 \
 //y=4.25 //x2=97.555 //y2=0.55
cc_8648 ( N_Q_M60_noxref_d N_GND_M60_noxref_s ) capacitor c=0.0377642f \
 //x=97.985 //y=1.09 //x2=97.555 //y2=0.55
cc_8649 ( N_VDD_c_14756_p N_noxref_44_c_16098_n ) capacitor c=4.78686e-19 \
 //x=88.655 //y=7.585 //x2=89.065 //y2=5.39
cc_8650 ( N_VDD_c_13739_n N_noxref_44_c_16098_n ) capacitor c=0.00476346f \
 //x=88.74 //y=7.035 //x2=89.065 //y2=5.39
cc_8651 ( N_VDD_c_14758_p N_noxref_44_c_16098_n ) capacitor c=5.98042e-19 \
 //x=89.535 //y=7.585 //x2=89.065 //y2=5.39
cc_8652 ( N_VDD_c_13757_n N_noxref_44_c_16098_n ) capacitor c=0.00734603f \
 //x=90.23 //y=7.585 //x2=89.065 //y2=5.39
cc_8653 ( N_VDD_M170_noxref_d N_noxref_44_c_16098_n ) capacitor c=0.00679741f \
 //x=88.595 //y=5.205 //x2=89.065 //y2=5.39
cc_8654 ( N_VDD_c_14758_p N_noxref_44_c_16100_n ) capacitor c=5.52065e-19 \
 //x=89.535 //y=7.585 //x2=91.065 //y2=5.39
cc_8655 ( N_VDD_c_14628_n N_noxref_44_c_16100_n ) capacitor c=0.0040485f \
 //x=89.62 //y=7.035 //x2=91.065 //y2=5.39
cc_8656 ( N_VDD_c_14694_n N_noxref_44_c_16100_n ) capacitor c=0.0140204f \
 //x=98.54 //y=7.58 //x2=91.065 //y2=5.39
cc_8657 ( N_VDD_c_13757_n N_noxref_44_c_16100_n ) capacitor c=0.00703326f \
 //x=90.23 //y=7.585 //x2=91.065 //y2=5.39
cc_8658 ( N_VDD_c_13760_n N_noxref_44_c_16100_n ) capacitor c=0.00273146f \
 //x=93.56 //y=7.585 //x2=91.065 //y2=5.39
cc_8659 ( N_VDD_c_13794_n N_noxref_44_c_16100_n ) capacitor c=0.039327f \
 //x=90.4 //y=7.585 //x2=91.065 //y2=5.39
cc_8660 ( N_VDD_M172_noxref_d N_noxref_44_c_16100_n ) capacitor c=0.0138307f \
 //x=89.475 //y=5.205 //x2=91.065 //y2=5.39
cc_8661 ( N_VDD_c_13794_n N_noxref_44_c_16103_n ) capacitor c=3.35418e-19 \
 //x=90.4 //y=7.585 //x2=89.295 //y2=5.39
cc_8662 ( N_VDD_M172_noxref_d N_noxref_44_c_16103_n ) capacitor c=6.02701e-19 \
 //x=89.475 //y=5.205 //x2=89.295 //y2=5.39
cc_8663 ( N_VDD_M169_noxref_s N_noxref_44_c_16110_n ) capacitor c=0.0552377f \
 //x=87.725 //y=5.205 //x2=88.302 //y2=5.39
cc_8664 ( N_VDD_c_14628_n N_noxref_44_c_16114_n ) capacitor c=0.00979658f \
 //x=89.62 //y=7.035 //x2=91.18 //y2=6.92
cc_8665 ( N_VDD_c_14629_n N_noxref_44_c_16114_n ) capacitor c=0.00197255f \
 //x=89.62 //y=7.41 //x2=91.18 //y2=6.92
cc_8666 ( N_VDD_c_14694_n N_noxref_44_c_16114_n ) capacitor c=0.172093f \
 //x=98.54 //y=7.58 //x2=91.18 //y2=6.92
cc_8667 ( N_VDD_c_13760_n N_noxref_44_c_16114_n ) capacitor c=0.0401324f \
 //x=93.56 //y=7.585 //x2=91.18 //y2=6.92
cc_8668 ( N_VDD_c_13794_n N_noxref_44_c_16114_n ) capacitor c=0.00739076f \
 //x=90.4 //y=7.585 //x2=91.18 //y2=6.92
cc_8669 ( N_VDD_c_14694_n N_noxref_44_c_16132_n ) capacitor c=0.0021469f \
 //x=98.54 //y=7.58 //x2=92.94 //y2=6.92
cc_8670 ( N_VDD_c_13760_n N_noxref_44_c_16132_n ) capacitor c=4.35699e-19 \
 //x=93.56 //y=7.585 //x2=92.94 //y2=6.92
cc_8671 ( N_VDD_c_13800_n N_noxref_44_c_16132_n ) capacitor c=0.00733935f \
 //x=93.73 //y=7.585 //x2=92.94 //y2=6.92
cc_8672 ( N_VDD_c_13737_n N_noxref_44_c_16116_n ) capacitor c=0.0041288f \
 //x=87.86 //y=7.035 //x2=88.3 //y2=5.56
cc_8673 ( N_VDD_c_13738_n N_noxref_44_c_16116_n ) capacitor c=0.00145923f \
 //x=87.86 //y=7.41 //x2=88.3 //y2=5.56
cc_8674 ( N_VDD_c_14756_p N_noxref_44_c_16116_n ) capacitor c=0.00233559f \
 //x=88.655 //y=7.585 //x2=88.3 //y2=5.56
cc_8675 ( N_VDD_c_13739_n N_noxref_44_c_16116_n ) capacitor c=0.00220869f \
 //x=88.74 //y=7.035 //x2=88.3 //y2=5.56
cc_8676 ( N_VDD_c_13740_n N_noxref_44_c_16116_n ) capacitor c=0.00130452f \
 //x=88.74 //y=7.41 //x2=88.3 //y2=5.56
cc_8677 ( N_VDD_c_13757_n N_noxref_44_c_16116_n ) capacitor c=0.0112616f \
 //x=90.23 //y=7.585 //x2=88.3 //y2=5.56
cc_8678 ( N_VDD_c_13788_n N_noxref_44_c_16116_n ) capacitor c=0.00724603f \
 //x=87.07 //y=7.585 //x2=88.3 //y2=5.56
cc_8679 ( N_VDD_c_14720_n N_noxref_44_c_16116_n ) capacitor c=2.28864e-19 \
 //x=98.54 //y=7.58 //x2=88.3 //y2=5.56
cc_8680 ( N_VDD_M169_noxref_s N_noxref_44_c_16116_n ) capacitor c=0.0897259f \
 //x=87.725 //y=5.205 //x2=88.3 //y2=5.56
cc_8681 ( N_VDD_M170_noxref_d N_noxref_44_c_16116_n ) capacitor c=0.0724825f \
 //x=88.595 //y=5.205 //x2=88.3 //y2=5.56
cc_8682 ( N_VDD_c_13739_n N_noxref_44_c_16119_n ) capacitor c=0.00230229f \
 //x=88.74 //y=7.035 //x2=89.18 //y2=5.39
cc_8683 ( N_VDD_c_13740_n N_noxref_44_c_16119_n ) capacitor c=0.00130452f \
 //x=88.74 //y=7.41 //x2=89.18 //y2=5.39
cc_8684 ( N_VDD_c_14758_p N_noxref_44_c_16119_n ) capacitor c=0.00233409f \
 //x=89.535 //y=7.585 //x2=89.18 //y2=5.39
cc_8685 ( N_VDD_c_14628_n N_noxref_44_c_16119_n ) capacitor c=0.00225444f \
 //x=89.62 //y=7.035 //x2=89.18 //y2=5.39
cc_8686 ( N_VDD_c_14629_n N_noxref_44_c_16119_n ) capacitor c=0.00130452f \
 //x=89.62 //y=7.41 //x2=89.18 //y2=5.39
cc_8687 ( N_VDD_c_13757_n N_noxref_44_c_16119_n ) capacitor c=0.0112507f \
 //x=90.23 //y=7.585 //x2=89.18 //y2=5.39
cc_8688 ( N_VDD_c_13788_n N_noxref_44_c_16119_n ) capacitor c=0.00105173f \
 //x=87.07 //y=7.585 //x2=89.18 //y2=5.39
cc_8689 ( N_VDD_c_13794_n N_noxref_44_c_16119_n ) capacitor c=0.00924237f \
 //x=90.4 //y=7.585 //x2=89.18 //y2=5.39
cc_8690 ( N_VDD_c_14720_n N_noxref_44_c_16119_n ) capacitor c=2.28864e-19 \
 //x=98.54 //y=7.58 //x2=89.18 //y2=5.39
cc_8691 ( N_VDD_M169_noxref_s N_noxref_44_c_16119_n ) capacitor c=0.00114869f \
 //x=87.725 //y=5.205 //x2=89.18 //y2=5.39
cc_8692 ( N_VDD_M170_noxref_d N_noxref_44_c_16119_n ) capacitor c=0.0724825f \
 //x=88.595 //y=5.205 //x2=89.18 //y2=5.39
cc_8693 ( N_VDD_M172_noxref_d N_noxref_44_c_16119_n ) capacitor c=0.0886704f \
 //x=89.475 //y=5.205 //x2=89.18 //y2=5.39
cc_8694 ( N_VDD_c_14694_n N_noxref_44_c_16120_n ) capacitor c=0.00204931f \
 //x=98.54 //y=7.58 //x2=91.18 //y2=5.39
cc_8695 ( N_VDD_c_13760_n N_noxref_44_c_16120_n ) capacitor c=0.00853641f \
 //x=93.56 //y=7.585 //x2=91.18 //y2=5.39
cc_8696 ( N_VDD_c_13794_n N_noxref_44_c_16120_n ) capacitor c=0.0602194f \
 //x=90.4 //y=7.585 //x2=91.18 //y2=5.39
cc_8697 ( N_VDD_c_14720_n N_noxref_44_c_16120_n ) capacitor c=2.28864e-19 \
 //x=98.54 //y=7.58 //x2=91.18 //y2=5.39
cc_8698 ( N_VDD_M172_noxref_d N_noxref_44_c_16120_n ) capacitor c=0.00230512f \
 //x=89.475 //y=5.205 //x2=91.18 //y2=5.39
cc_8699 ( N_VDD_c_13737_n N_noxref_44_M169_noxref_d ) capacitor c=0.0391448f \
 //x=87.86 //y=7.035 //x2=88.155 //y2=5.205
cc_8700 ( N_VDD_c_13738_n N_noxref_44_M169_noxref_d ) capacitor c=0.00985747f \
 //x=87.86 //y=7.41 //x2=88.155 //y2=5.205
cc_8701 ( N_VDD_c_14756_p N_noxref_44_M169_noxref_d ) capacitor c=0.0238892f \
 //x=88.655 //y=7.585 //x2=88.155 //y2=5.205
cc_8702 ( N_VDD_c_13739_n N_noxref_44_M169_noxref_d ) capacitor c=0.0380657f \
 //x=88.74 //y=7.035 //x2=88.155 //y2=5.205
cc_8703 ( N_VDD_c_13740_n N_noxref_44_M169_noxref_d ) capacitor c=0.0100015f \
 //x=88.74 //y=7.41 //x2=88.155 //y2=5.205
cc_8704 ( N_VDD_c_13757_n N_noxref_44_M169_noxref_d ) capacitor c=0.00302682f \
 //x=90.23 //y=7.585 //x2=88.155 //y2=5.205
cc_8705 ( N_VDD_M169_noxref_s N_noxref_44_M169_noxref_d ) capacitor \
 c=0.00271779f //x=87.725 //y=5.205 //x2=88.155 //y2=5.205
cc_8706 ( N_VDD_M170_noxref_d N_noxref_44_M169_noxref_d ) capacitor \
 c=0.00360728f //x=88.595 //y=5.205 //x2=88.155 //y2=5.205
cc_8707 ( N_VDD_c_13739_n N_noxref_44_M171_noxref_d ) capacitor c=0.0379915f \
 //x=88.74 //y=7.035 //x2=89.035 //y2=5.205
cc_8708 ( N_VDD_c_13740_n N_noxref_44_M171_noxref_d ) capacitor c=0.0100015f \
 //x=88.74 //y=7.41 //x2=89.035 //y2=5.205
cc_8709 ( N_VDD_c_14758_p N_noxref_44_M171_noxref_d ) capacitor c=0.0230655f \
 //x=89.535 //y=7.585 //x2=89.035 //y2=5.205
cc_8710 ( N_VDD_c_14628_n N_noxref_44_M171_noxref_d ) capacitor c=0.0379915f \
 //x=89.62 //y=7.035 //x2=89.035 //y2=5.205
cc_8711 ( N_VDD_c_14629_n N_noxref_44_M171_noxref_d ) capacitor c=0.0100015f \
 //x=89.62 //y=7.41 //x2=89.035 //y2=5.205
cc_8712 ( N_VDD_c_13757_n N_noxref_44_M171_noxref_d ) capacitor c=0.00283306f \
 //x=90.23 //y=7.585 //x2=89.035 //y2=5.205
cc_8713 ( N_VDD_M170_noxref_d N_noxref_44_M171_noxref_d ) capacitor \
 c=0.00351276f //x=88.595 //y=5.205 //x2=89.035 //y2=5.205
cc_8714 ( N_VDD_M172_noxref_d N_noxref_44_M171_noxref_d ) capacitor \
 c=0.00355849f //x=89.475 //y=5.205 //x2=89.035 //y2=5.205
cc_8715 ( N_VDD_c_14694_n N_noxref_44_M174_noxref_d ) capacitor c=0.00206569f \
 //x=98.54 //y=7.58 //x2=91.915 //y2=5.205
cc_8716 ( N_VDD_c_13760_n N_noxref_44_M174_noxref_d ) capacitor c=0.00856914f \
 //x=93.56 //y=7.585 //x2=91.915 //y2=5.205
cc_8717 ( N_VDD_c_14720_n N_noxref_44_M174_noxref_d ) capacitor c=2.28864e-19 \
 //x=98.54 //y=7.58 //x2=91.915 //y2=5.205
cc_8718 ( N_VDD_c_14694_n N_noxref_44_M176_noxref_d ) capacitor c=0.00206569f \
 //x=98.54 //y=7.58 //x2=92.795 //y2=5.205
cc_8719 ( N_VDD_c_13760_n N_noxref_44_M176_noxref_d ) capacitor c=0.00856914f \
 //x=93.56 //y=7.585 //x2=92.795 //y2=5.205
cc_8720 ( N_VDD_c_13800_n N_noxref_44_M176_noxref_d ) capacitor c=0.0448255f \
 //x=93.73 //y=7.585 //x2=92.795 //y2=5.205
cc_8721 ( N_VDD_c_14720_n N_noxref_44_M176_noxref_d ) capacitor c=2.28864e-19 \
 //x=98.54 //y=7.58 //x2=92.795 //y2=5.205
cc_8722 ( N_VDD_c_14694_n N_noxref_45_c_16271_n ) capacitor c=0.0143613f \
 //x=98.54 //y=7.58 //x2=94.405 //y2=5.39
cc_8723 ( N_VDD_c_13760_n N_noxref_45_c_16271_n ) capacitor c=0.00398048f \
 //x=93.56 //y=7.585 //x2=94.405 //y2=5.39
cc_8724 ( N_VDD_c_14584_n N_noxref_45_c_16271_n ) capacitor c=0.00275849f \
 //x=96.89 //y=7.585 //x2=94.405 //y2=5.39
cc_8725 ( N_VDD_c_13800_n N_noxref_45_c_16271_n ) capacitor c=0.042287f \
 //x=93.73 //y=7.585 //x2=94.405 //y2=5.39
cc_8726 ( N_VDD_c_13800_n N_noxref_45_c_16281_n ) capacitor c=6.67754e-19 \
 //x=93.73 //y=7.585 //x2=92.615 //y2=5.39
cc_8727 ( N_VDD_M169_noxref_s N_noxref_45_c_16259_n ) capacitor c=4.98377e-19 \
 //x=87.725 //y=5.205 //x2=91.62 //y2=5.39
cc_8728 ( N_VDD_c_14694_n N_noxref_45_c_16285_n ) capacitor c=0.172244f \
 //x=98.54 //y=7.58 //x2=94.52 //y2=6.92
cc_8729 ( N_VDD_c_14584_n N_noxref_45_c_16285_n ) capacitor c=0.0392376f \
 //x=96.89 //y=7.585 //x2=94.52 //y2=6.92
cc_8730 ( N_VDD_c_13800_n N_noxref_45_c_16285_n ) capacitor c=0.00730382f \
 //x=93.73 //y=7.585 //x2=94.52 //y2=6.92
cc_8731 ( N_VDD_c_14694_n N_noxref_45_c_16301_n ) capacitor c=0.00215296f \
 //x=98.54 //y=7.58 //x2=96.28 //y2=6.92
cc_8732 ( N_VDD_c_14584_n N_noxref_45_c_16301_n ) capacitor c=4.60826e-19 \
 //x=96.89 //y=7.585 //x2=96.28 //y2=6.92
cc_8733 ( N_VDD_c_14673_n N_noxref_45_c_16301_n ) capacitor c=0.0114263f \
 //x=97.06 //y=7.585 //x2=96.28 //y2=6.92
cc_8734 ( N_VDD_c_13760_n N_noxref_45_c_16265_n ) capacitor c=0.00475693f \
 //x=93.56 //y=7.585 //x2=91.62 //y2=5.56
cc_8735 ( N_VDD_c_13794_n N_noxref_45_c_16265_n ) capacitor c=0.00539528f \
 //x=90.4 //y=7.585 //x2=91.62 //y2=5.56
cc_8736 ( N_VDD_c_13760_n N_noxref_45_c_16287_n ) capacitor c=0.00489838f \
 //x=93.56 //y=7.585 //x2=92.5 //y2=5.39
cc_8737 ( N_VDD_c_13800_n N_noxref_45_c_16287_n ) capacitor c=0.0122289f \
 //x=93.73 //y=7.585 //x2=92.5 //y2=5.39
cc_8738 ( N_VDD_c_14694_n N_noxref_45_c_16290_n ) capacitor c=0.00204931f \
 //x=98.54 //y=7.58 //x2=94.52 //y2=5.39
cc_8739 ( N_VDD_c_14584_n N_noxref_45_c_16290_n ) capacitor c=0.00853641f \
 //x=96.89 //y=7.585 //x2=94.52 //y2=5.39
cc_8740 ( N_VDD_c_13800_n N_noxref_45_c_16290_n ) capacitor c=0.0592438f \
 //x=93.73 //y=7.585 //x2=94.52 //y2=5.39
cc_8741 ( N_VDD_c_14673_n N_noxref_45_c_16290_n ) capacitor c=0.00100394f \
 //x=97.06 //y=7.585 //x2=94.52 //y2=5.39
cc_8742 ( N_VDD_c_14720_n N_noxref_45_c_16290_n ) capacitor c=2.28864e-19 \
 //x=98.54 //y=7.58 //x2=94.52 //y2=5.39
cc_8743 ( N_VDD_c_14694_n N_noxref_45_M178_noxref_d ) capacitor c=0.00206569f \
 //x=98.54 //y=7.58 //x2=95.255 //y2=5.205
cc_8744 ( N_VDD_c_14584_n N_noxref_45_M178_noxref_d ) capacitor c=0.00856914f \
 //x=96.89 //y=7.585 //x2=95.255 //y2=5.205
cc_8745 ( N_VDD_c_14720_n N_noxref_45_M178_noxref_d ) capacitor c=2.28864e-19 \
 //x=98.54 //y=7.58 //x2=95.255 //y2=5.205
cc_8746 ( N_VDD_c_14694_n N_noxref_45_M180_noxref_d ) capacitor c=0.00206569f \
 //x=98.54 //y=7.58 //x2=96.135 //y2=5.205
cc_8747 ( N_VDD_c_14584_n N_noxref_45_M180_noxref_d ) capacitor c=0.00856914f \
 //x=96.89 //y=7.585 //x2=96.135 //y2=5.205
cc_8748 ( N_VDD_c_14673_n N_noxref_45_M180_noxref_d ) capacitor c=0.0443649f \
 //x=97.06 //y=7.585 //x2=96.135 //y2=5.205
cc_8749 ( N_VDD_c_14720_n N_noxref_45_M180_noxref_d ) capacitor c=2.28864e-19 \
 //x=98.54 //y=7.58 //x2=96.135 //y2=5.205
cc_8750 ( N_VDD_M181_noxref_s N_noxref_45_M180_noxref_d ) capacitor \
 c=0.00249451f //x=97.6 //y=5.2 //x2=96.135 //y2=5.205
cc_8751 ( N_VDD_c_13443_n N_GND_c_16911_n ) capacitor c=0.00989514f //x=1.23 \
 //y=7.58 //x2=1.23 //y2=0.18
cc_8752 ( N_VDD_c_13461_n N_GND_c_16425_n ) capacitor c=0.00656819f //x=5.3 \
 //y=7.585 //x2=5.3 //y2=0.175
cc_8753 ( N_VDD_c_13467_n N_GND_c_16438_n ) capacitor c=0.00654453f //x=10.11 \
 //y=7.585 //x2=10.11 //y2=0.175
cc_8754 ( N_VDD_c_13521_n N_GND_c_16481_n ) capacitor c=0.00648088f //x=14.92 \
 //y=7.585 //x2=14.92 //y2=0.175
cc_8755 ( N_VDD_c_13581_n N_GND_c_16530_n ) capacitor c=0.00648088f //x=19.73 \
 //y=7.585 //x2=19.73 //y2=0.175
cc_8756 ( N_VDD_c_13631_n N_GND_c_16563_n ) capacitor c=0.00648088f //x=24.54 \
 //y=7.585 //x2=24.54 //y2=0.175
cc_8757 ( N_VDD_c_13694_n N_GND_c_16600_n ) capacitor c=0.00653385f //x=29.35 \
 //y=7.585 //x2=29.35 //y2=0.175
cc_8758 ( N_VDD_c_13773_n N_GND_c_16693_n ) capacitor c=0.00650455f //x=34.16 \
 //y=7.585 //x2=34.16 //y2=0.175
cc_8759 ( N_VDD_c_13775_n N_GND_c_16706_n ) capacitor c=0.00648088f //x=38.97 \
 //y=7.585 //x2=38.97 //y2=0.175
cc_8760 ( N_VDD_c_13776_n N_GND_c_16749_n ) capacitor c=0.00648088f //x=43.78 \
 //y=7.585 //x2=43.78 //y2=0.175
cc_8761 ( N_VDD_c_13778_n N_GND_c_16796_n ) capacitor c=0.00648088f //x=48.59 \
 //y=7.585 //x2=48.59 //y2=0.175
cc_8762 ( N_VDD_c_13779_n N_GND_c_16829_n ) capacitor c=0.00648088f //x=53.4 \
 //y=7.585 //x2=53.4 //y2=0.175
cc_8763 ( N_VDD_c_13780_n N_GND_c_16867_n ) capacitor c=0.00648088f //x=58.21 \
 //y=7.585 //x2=58.21 //y2=0.175
cc_8764 ( N_VDD_c_13781_n N_GND_c_16984_n ) capacitor c=0.00897677f //x=63.02 \
 //y=7.585 //x2=63.02 //y2=0.175
cc_8765 ( N_VDD_c_13783_n N_GND_c_16997_n ) capacitor c=0.00648088f //x=67.83 \
 //y=7.585 //x2=67.83 //y2=0.175
cc_8766 ( N_VDD_c_13784_n N_GND_c_17040_n ) capacitor c=0.00648088f //x=72.64 \
 //y=7.585 //x2=72.64 //y2=0.175
cc_8767 ( N_VDD_c_13786_n N_GND_c_17093_n ) capacitor c=0.00648088f //x=77.45 \
 //y=7.585 //x2=77.45 //y2=0.175
cc_8768 ( N_VDD_c_13787_n N_GND_c_17214_n ) capacitor c=0.00648088f //x=82.26 \
 //y=7.585 //x2=82.26 //y2=0.175
cc_8769 ( N_VDD_c_13788_n N_GND_c_16635_n ) capacitor c=0.00683425f //x=87.07 \
 //y=7.585 //x2=87.07 //y2=0.175
cc_8770 ( N_VDD_c_13794_n N_GND_c_16641_n ) capacitor c=0.00683425f //x=90.4 \
 //y=7.585 //x2=90.4 //y2=0.175
cc_8771 ( N_VDD_c_13800_n N_GND_c_17321_n ) capacitor c=0.00684375f //x=93.73 \
 //y=7.585 //x2=93.73 //y2=0.175
cc_8772 ( N_VDD_c_14673_n N_GND_c_17332_n ) capacitor c=0.00655202f //x=97.06 \
 //y=7.585 //x2=97.06 //y2=0.175
cc_8773 ( N_VDD_c_14720_n N_GND_c_17416_n ) capacitor c=0.00989514f //x=98.54 \
 //y=7.58 //x2=98.66 //y2=0.175
cc_8774 ( N_noxref_26_c_14902_n N_GND_c_16390_n ) capacitor c=0.00533679f \
 //x=3.505 //y=1.175 //x2=6.29 //y2=0.175
cc_8775 ( N_noxref_26_c_14922_p N_GND_c_16390_n ) capacitor c=0.00435261f \
 //x=3.59 //y=0.805 //x2=6.29 //y2=0.175
cc_8776 ( N_noxref_26_c_14881_n N_GND_c_16390_n ) capacitor c=0.00958312f \
 //x=4.475 //y=0.72 //x2=6.29 //y2=0.175
cc_8777 ( N_noxref_26_c_14924_p N_GND_c_16390_n ) capacitor c=0.00232964f \
 //x=4.56 //y=0.805 //x2=6.29 //y2=0.175
cc_8778 ( N_noxref_26_M1_noxref_d N_GND_c_16390_n ) capacitor c=0.0132534f \
 //x=2.35 //y=1.09 //x2=6.29 //y2=0.175
cc_8779 ( N_noxref_26_M1_noxref_d N_GND_c_16880_n ) capacitor c=0.0156367f \
 //x=2.35 //y=1.09 //x2=1.565 //y2=1.145
cc_8780 ( N_noxref_26_c_14902_n N_GND_c_16421_n ) capacitor c=0.0091517f \
 //x=3.505 //y=1.175 //x2=5.13 //y2=0.175
cc_8781 ( N_noxref_26_c_14922_p N_GND_c_16421_n ) capacitor c=0.0141638f \
 //x=3.59 //y=0.805 //x2=5.13 //y2=0.175
cc_8782 ( N_noxref_26_c_14881_n N_GND_c_16421_n ) capacitor c=0.0364778f \
 //x=4.475 //y=0.72 //x2=5.13 //y2=0.175
cc_8783 ( N_noxref_26_c_14924_p N_GND_c_16421_n ) capacitor c=0.013886f \
 //x=4.56 //y=0.805 //x2=5.13 //y2=0.175
cc_8784 ( N_noxref_26_M2_noxref_s N_GND_c_16911_n ) capacitor c=8.16352e-19 \
 //x=3.455 //y=0.555 //x2=1.23 //y2=0.18
cc_8785 ( N_noxref_26_c_14924_p N_GND_c_16425_n ) capacitor c=0.037873f \
 //x=4.56 //y=0.805 //x2=5.3 //y2=0.175
cc_8786 ( N_noxref_26_M2_noxref_s N_GND_c_16425_n ) capacitor c=0.0051897f \
 //x=3.455 //y=0.555 //x2=5.3 //y2=0.175
cc_8787 ( N_noxref_26_M1_noxref_d N_GND_M0_noxref_d ) capacitor c=3.12752e-19 \
 //x=2.35 //y=1.09 //x2=1.375 //y2=1.055
cc_8788 ( N_noxref_26_c_14922_p N_noxref_47_c_18161_n ) capacitor \
 c=2.15937e-19 //x=3.59 //y=0.805 //x2=2.05 //y2=0.805
cc_8789 ( N_noxref_26_c_14902_n N_noxref_47_c_18150_n ) capacitor c=0.0130708f \
 //x=3.505 //y=1.175 //x2=2.935 //y2=0.72
cc_8790 ( N_noxref_26_M1_noxref_d N_noxref_47_c_18150_n ) capacitor \
 c=0.0162022f //x=2.35 //y=1.09 //x2=2.935 //y2=0.72
cc_8791 ( N_noxref_26_c_14902_n N_noxref_47_c_18144_n ) capacitor \
 c=0.00940919f //x=3.505 //y=1.175 //x2=2.935 //y2=1.77
cc_8792 ( N_noxref_26_M1_noxref_d N_noxref_47_c_18144_n ) capacitor \
 c=0.0151199f //x=2.35 //y=1.09 //x2=2.935 //y2=1.77
cc_8793 ( N_noxref_26_c_14902_n N_noxref_47_M0_noxref_s ) capacitor \
 c=0.0223986f //x=3.505 //y=1.175 //x2=0.945 //y2=0.555
cc_8794 ( N_noxref_26_c_14922_p N_noxref_47_M0_noxref_s ) capacitor \
 c=0.0175461f //x=3.59 //y=0.805 //x2=0.945 //y2=0.555
cc_8795 ( N_noxref_26_c_14924_p N_noxref_47_M0_noxref_s ) capacitor \
 c=2.98576e-19 //x=4.56 //y=0.805 //x2=0.945 //y2=0.555
cc_8796 ( N_noxref_26_M1_noxref_d N_noxref_47_M0_noxref_s ) capacitor \
 c=0.0187969f //x=2.35 //y=1.09 //x2=0.945 //y2=0.555
cc_8797 ( N_noxref_26_M2_noxref_s N_noxref_47_M0_noxref_s ) capacitor \
 c=0.0210819f //x=3.455 //y=0.555 //x2=0.945 //y2=0.555
cc_8798 ( N_noxref_26_c_14924_p N_noxref_48_M3_noxref_s ) capacitor \
 c=0.00368328f //x=4.56 //y=0.805 //x2=5.755 //y2=0.555
cc_8799 ( N_noxref_26_M2_noxref_s N_noxref_48_M3_noxref_s ) capacitor \
 c=0.00125282f //x=3.455 //y=0.555 //x2=5.755 //y2=0.555
cc_8800 ( N_noxref_27_c_14969_n N_GND_c_16501_n ) capacitor c=0.00533679f \
 //x=8.315 //y=1.175 //x2=11.1 //y2=0.175
cc_8801 ( N_noxref_27_c_14989_p N_GND_c_16501_n ) capacitor c=0.00427059f \
 //x=8.4 //y=0.805 //x2=11.1 //y2=0.175
cc_8802 ( N_noxref_27_c_14948_n N_GND_c_16501_n ) capacitor c=0.00960919f \
 //x=9.285 //y=0.72 //x2=11.1 //y2=0.175
cc_8803 ( N_noxref_27_c_14991_p N_GND_c_16501_n ) capacitor c=0.00232964f \
 //x=9.37 //y=0.805 //x2=11.1 //y2=0.175
cc_8804 ( N_noxref_27_M4_noxref_d N_GND_c_16501_n ) capacitor c=0.0131076f \
 //x=7.16 //y=1.09 //x2=11.1 //y2=0.175
cc_8805 ( N_noxref_27_M4_noxref_d N_GND_c_16400_n ) capacitor c=0.0154456f \
 //x=7.16 //y=1.09 //x2=6.375 //y2=1.145
cc_8806 ( N_noxref_27_c_14969_n N_GND_c_16423_n ) capacitor c=0.0091517f \
 //x=8.315 //y=1.175 //x2=9.94 //y2=0.175
cc_8807 ( N_noxref_27_c_14989_p N_GND_c_16423_n ) capacitor c=0.0141638f \
 //x=8.4 //y=0.805 //x2=9.94 //y2=0.175
cc_8808 ( N_noxref_27_c_14948_n N_GND_c_16423_n ) capacitor c=0.0364778f \
 //x=9.285 //y=0.72 //x2=9.94 //y2=0.175
cc_8809 ( N_noxref_27_c_14991_p N_GND_c_16423_n ) capacitor c=0.013886f \
 //x=9.37 //y=0.805 //x2=9.94 //y2=0.175
cc_8810 ( N_noxref_27_M5_noxref_s N_GND_c_16425_n ) capacitor c=8.16352e-19 \
 //x=8.265 //y=0.555 //x2=5.3 //y2=0.175
cc_8811 ( N_noxref_27_c_14991_p N_GND_c_16438_n ) capacitor c=0.037873f \
 //x=9.37 //y=0.805 //x2=10.11 //y2=0.175
cc_8812 ( N_noxref_27_M5_noxref_s N_GND_c_16438_n ) capacitor c=0.0051897f \
 //x=8.265 //y=0.555 //x2=10.11 //y2=0.175
cc_8813 ( N_noxref_27_M4_noxref_d N_GND_M3_noxref_d ) capacitor c=3.12752e-19 \
 //x=7.16 //y=1.09 //x2=6.185 //y2=1.055
cc_8814 ( N_noxref_27_c_14989_p N_noxref_48_c_18218_n ) capacitor \
 c=2.15937e-19 //x=8.4 //y=0.805 //x2=6.86 //y2=0.805
cc_8815 ( N_noxref_27_c_14969_n N_noxref_48_c_18202_n ) capacitor c=0.0130857f \
 //x=8.315 //y=1.175 //x2=7.745 //y2=0.72
cc_8816 ( N_noxref_27_M4_noxref_d N_noxref_48_c_18202_n ) capacitor \
 c=0.0160925f //x=7.16 //y=1.09 //x2=7.745 //y2=0.72
cc_8817 ( N_noxref_27_c_14969_n N_noxref_48_c_18204_n ) capacitor \
 c=0.00944538f //x=8.315 //y=1.175 //x2=7.745 //y2=1.77
cc_8818 ( N_noxref_27_M4_noxref_d N_noxref_48_c_18204_n ) capacitor \
 c=0.0152674f //x=7.16 //y=1.09 //x2=7.745 //y2=1.77
cc_8819 ( N_noxref_27_c_14969_n N_noxref_48_M3_noxref_s ) capacitor \
 c=0.0223986f //x=8.315 //y=1.175 //x2=5.755 //y2=0.555
cc_8820 ( N_noxref_27_c_14989_p N_noxref_48_M3_noxref_s ) capacitor \
 c=0.0175461f //x=8.4 //y=0.805 //x2=5.755 //y2=0.555
cc_8821 ( N_noxref_27_c_14991_p N_noxref_48_M3_noxref_s ) capacitor \
 c=2.98576e-19 //x=9.37 //y=0.805 //x2=5.755 //y2=0.555
cc_8822 ( N_noxref_27_M4_noxref_d N_noxref_48_M3_noxref_s ) capacitor \
 c=0.0187685f //x=7.16 //y=1.09 //x2=5.755 //y2=0.555
cc_8823 ( N_noxref_27_M5_noxref_s N_noxref_48_M3_noxref_s ) capacitor \
 c=0.0210819f //x=8.265 //y=0.555 //x2=5.755 //y2=0.555
cc_8824 ( N_noxref_27_c_14991_p N_noxref_49_M6_noxref_s ) capacitor \
 c=0.00368328f //x=9.37 //y=0.805 //x2=10.565 //y2=0.555
cc_8825 ( N_noxref_27_M5_noxref_s N_noxref_49_M6_noxref_s ) capacitor \
 c=0.00125282f //x=8.265 //y=0.555 //x2=10.565 //y2=0.555
cc_8826 ( N_noxref_28_c_15037_n N_GND_c_16460_n ) capacitor c=0.00533679f \
 //x=13.125 //y=1.175 //x2=15.91 //y2=0.175
cc_8827 ( N_noxref_28_c_15057_p N_GND_c_16460_n ) capacitor c=0.00338855f \
 //x=13.21 //y=0.805 //x2=15.91 //y2=0.175
cc_8828 ( N_noxref_28_c_15014_n N_GND_c_16460_n ) capacitor c=0.00960919f \
 //x=14.095 //y=0.72 //x2=15.91 //y2=0.175
cc_8829 ( N_noxref_28_c_15059_p N_GND_c_16460_n ) capacitor c=0.00232964f \
 //x=14.18 //y=0.805 //x2=15.91 //y2=0.175
cc_8830 ( N_noxref_28_M7_noxref_d N_GND_c_16460_n ) capacitor c=0.0131076f \
 //x=11.97 //y=1.09 //x2=15.91 //y2=0.175
cc_8831 ( N_noxref_28_M7_noxref_d N_GND_c_16411_n ) capacitor c=0.0154456f \
 //x=11.97 //y=1.09 //x2=11.185 //y2=1.145
cc_8832 ( N_noxref_28_c_15037_n N_GND_c_16424_n ) capacitor c=0.0091517f \
 //x=13.125 //y=1.175 //x2=14.75 //y2=0.175
cc_8833 ( N_noxref_28_c_15057_p N_GND_c_16424_n ) capacitor c=0.0141638f \
 //x=13.21 //y=0.805 //x2=14.75 //y2=0.175
cc_8834 ( N_noxref_28_c_15014_n N_GND_c_16424_n ) capacitor c=0.0364778f \
 //x=14.095 //y=0.72 //x2=14.75 //y2=0.175
cc_8835 ( N_noxref_28_c_15059_p N_GND_c_16424_n ) capacitor c=0.013886f \
 //x=14.18 //y=0.805 //x2=14.75 //y2=0.175
cc_8836 ( N_noxref_28_M8_noxref_s N_GND_c_16438_n ) capacitor c=8.16352e-19 \
 //x=13.075 //y=0.555 //x2=10.11 //y2=0.175
cc_8837 ( N_noxref_28_c_15059_p N_GND_c_16481_n ) capacitor c=0.037873f \
 //x=14.18 //y=0.805 //x2=14.92 //y2=0.175
cc_8838 ( N_noxref_28_M8_noxref_s N_GND_c_16481_n ) capacitor c=0.0051897f \
 //x=13.075 //y=0.555 //x2=14.92 //y2=0.175
cc_8839 ( N_noxref_28_M7_noxref_d N_GND_M6_noxref_d ) capacitor c=3.12752e-19 \
 //x=11.97 //y=1.09 //x2=10.995 //y2=1.055
cc_8840 ( N_noxref_28_c_15057_p N_noxref_49_c_18276_n ) capacitor \
 c=2.15937e-19 //x=13.21 //y=0.805 //x2=11.67 //y2=0.805
cc_8841 ( N_noxref_28_c_15037_n N_noxref_49_c_18263_n ) capacitor c=0.0130857f \
 //x=13.125 //y=1.175 //x2=12.555 //y2=0.72
cc_8842 ( N_noxref_28_M7_noxref_d N_noxref_49_c_18263_n ) capacitor \
 c=0.0160925f //x=11.97 //y=1.09 //x2=12.555 //y2=0.72
cc_8843 ( N_noxref_28_c_15037_n N_noxref_49_c_18261_n ) capacitor \
 c=0.00944538f //x=13.125 //y=1.175 //x2=12.555 //y2=1.77
cc_8844 ( N_noxref_28_M7_noxref_d N_noxref_49_c_18261_n ) capacitor \
 c=0.0151784f //x=11.97 //y=1.09 //x2=12.555 //y2=1.77
cc_8845 ( N_noxref_28_c_15037_n N_noxref_49_M6_noxref_s ) capacitor \
 c=0.0223986f //x=13.125 //y=1.175 //x2=10.565 //y2=0.555
cc_8846 ( N_noxref_28_c_15057_p N_noxref_49_M6_noxref_s ) capacitor \
 c=0.0175461f //x=13.21 //y=0.805 //x2=10.565 //y2=0.555
cc_8847 ( N_noxref_28_c_15059_p N_noxref_49_M6_noxref_s ) capacitor \
 c=2.98576e-19 //x=14.18 //y=0.805 //x2=10.565 //y2=0.555
cc_8848 ( N_noxref_28_M7_noxref_d N_noxref_49_M6_noxref_s ) capacitor \
 c=0.0187685f //x=11.97 //y=1.09 //x2=10.565 //y2=0.555
cc_8849 ( N_noxref_28_M8_noxref_s N_noxref_49_M6_noxref_s ) capacitor \
 c=0.0210819f //x=13.075 //y=0.555 //x2=10.565 //y2=0.555
cc_8850 ( N_noxref_28_c_15059_p N_noxref_50_M9_noxref_s ) capacitor \
 c=0.00368328f //x=14.18 //y=0.805 //x2=15.375 //y2=0.555
cc_8851 ( N_noxref_28_M8_noxref_s N_noxref_50_M9_noxref_s ) capacitor \
 c=0.00125282f //x=13.075 //y=0.555 //x2=15.375 //y2=0.555
cc_8852 ( N_noxref_29_c_15094_n N_GND_c_16584_n ) capacitor c=0.00533679f \
 //x=17.935 //y=1.175 //x2=20.72 //y2=0.175
cc_8853 ( N_noxref_29_c_15124_p N_GND_c_16584_n ) capacitor c=0.00428749f \
 //x=18.02 //y=0.805 //x2=20.72 //y2=0.175
cc_8854 ( N_noxref_29_c_15083_n N_GND_c_16584_n ) capacitor c=0.00949233f \
 //x=18.905 //y=0.72 //x2=20.72 //y2=0.175
cc_8855 ( N_noxref_29_c_15126_p N_GND_c_16584_n ) capacitor c=0.00232964f \
 //x=18.99 //y=0.805 //x2=20.72 //y2=0.175
cc_8856 ( N_noxref_29_M10_noxref_d N_GND_c_16584_n ) capacitor c=0.0131076f \
 //x=16.78 //y=1.09 //x2=20.72 //y2=0.175
cc_8857 ( N_noxref_29_M10_noxref_d N_GND_c_16467_n ) capacitor c=0.0154456f \
 //x=16.78 //y=1.09 //x2=15.995 //y2=1.145
cc_8858 ( N_noxref_29_c_15094_n N_GND_c_16480_n ) capacitor c=0.0091517f \
 //x=17.935 //y=1.175 //x2=19.56 //y2=0.175
cc_8859 ( N_noxref_29_c_15124_p N_GND_c_16480_n ) capacitor c=0.0141599f \
 //x=18.02 //y=0.805 //x2=19.56 //y2=0.175
cc_8860 ( N_noxref_29_c_15083_n N_GND_c_16480_n ) capacitor c=0.0364691f \
 //x=18.905 //y=0.72 //x2=19.56 //y2=0.175
cc_8861 ( N_noxref_29_c_15126_p N_GND_c_16480_n ) capacitor c=0.013886f \
 //x=18.99 //y=0.805 //x2=19.56 //y2=0.175
cc_8862 ( N_noxref_29_M11_noxref_s N_GND_c_16481_n ) capacitor c=8.16352e-19 \
 //x=17.885 //y=0.555 //x2=14.92 //y2=0.175
cc_8863 ( N_noxref_29_c_15126_p N_GND_c_16530_n ) capacitor c=0.037873f \
 //x=18.99 //y=0.805 //x2=19.73 //y2=0.175
cc_8864 ( N_noxref_29_M11_noxref_s N_GND_c_16530_n ) capacitor c=0.0051897f \
 //x=17.885 //y=0.555 //x2=19.73 //y2=0.175
cc_8865 ( N_noxref_29_M10_noxref_d N_GND_M9_noxref_d ) capacitor c=3.12752e-19 \
 //x=16.78 //y=1.09 //x2=15.805 //y2=1.055
cc_8866 ( N_noxref_29_c_15124_p N_noxref_50_c_18335_n ) capacitor \
 c=2.15937e-19 //x=18.02 //y=0.805 //x2=16.48 //y2=0.805
cc_8867 ( N_noxref_29_c_15094_n N_noxref_50_c_18317_n ) capacitor c=0.0130857f \
 //x=17.935 //y=1.175 //x2=17.365 //y2=0.72
cc_8868 ( N_noxref_29_M10_noxref_d N_noxref_50_c_18317_n ) capacitor \
 c=0.0160925f //x=16.78 //y=1.09 //x2=17.365 //y2=0.72
cc_8869 ( N_noxref_29_c_15094_n N_noxref_50_c_18319_n ) capacitor \
 c=0.00944538f //x=17.935 //y=1.175 //x2=17.365 //y2=1.77
cc_8870 ( N_noxref_29_M10_noxref_d N_noxref_50_c_18319_n ) capacitor \
 c=0.0152727f //x=16.78 //y=1.09 //x2=17.365 //y2=1.77
cc_8871 ( N_noxref_29_c_15094_n N_noxref_50_M9_noxref_s ) capacitor \
 c=0.0223986f //x=17.935 //y=1.175 //x2=15.375 //y2=0.555
cc_8872 ( N_noxref_29_c_15124_p N_noxref_50_M9_noxref_s ) capacitor \
 c=0.0175461f //x=18.02 //y=0.805 //x2=15.375 //y2=0.555
cc_8873 ( N_noxref_29_c_15126_p N_noxref_50_M9_noxref_s ) capacitor \
 c=2.98576e-19 //x=18.99 //y=0.805 //x2=15.375 //y2=0.555
cc_8874 ( N_noxref_29_M10_noxref_d N_noxref_50_M9_noxref_s ) capacitor \
 c=0.0187685f //x=16.78 //y=1.09 //x2=15.375 //y2=0.555
cc_8875 ( N_noxref_29_M11_noxref_s N_noxref_50_M9_noxref_s ) capacitor \
 c=0.0210819f //x=17.885 //y=0.555 //x2=15.375 //y2=0.555
cc_8876 ( N_noxref_29_c_15126_p N_noxref_51_M12_noxref_s ) capacitor \
 c=0.00368328f //x=18.99 //y=0.805 //x2=20.185 //y2=0.555
cc_8877 ( N_noxref_29_M11_noxref_s N_noxref_51_M12_noxref_s ) capacitor \
 c=0.00125282f //x=17.885 //y=0.555 //x2=20.185 //y2=0.555
cc_8878 ( N_noxref_30_c_15171_n N_GND_c_16542_n ) capacitor c=0.00533679f \
 //x=22.745 //y=1.175 //x2=25.53 //y2=0.175
cc_8879 ( N_noxref_30_c_15192_p N_GND_c_16542_n ) capacitor c=0.00426228f \
 //x=22.83 //y=0.805 //x2=25.53 //y2=0.175
cc_8880 ( N_noxref_30_c_15149_n N_GND_c_16542_n ) capacitor c=0.00958383f \
 //x=23.715 //y=0.72 //x2=25.53 //y2=0.175
cc_8881 ( N_noxref_30_c_15194_p N_GND_c_16542_n ) capacitor c=0.00232964f \
 //x=23.8 //y=0.805 //x2=25.53 //y2=0.175
cc_8882 ( N_noxref_30_M13_noxref_d N_GND_c_16542_n ) capacitor c=0.0130924f \
 //x=21.59 //y=1.09 //x2=25.53 //y2=0.175
cc_8883 ( N_noxref_30_M13_noxref_d N_GND_c_16509_n ) capacitor c=0.0154456f \
 //x=21.59 //y=1.09 //x2=20.805 //y2=1.145
cc_8884 ( N_noxref_30_c_15171_n N_GND_c_16522_n ) capacitor c=0.0091517f \
 //x=22.745 //y=1.175 //x2=24.37 //y2=0.175
cc_8885 ( N_noxref_30_c_15192_p N_GND_c_16522_n ) capacitor c=0.0141638f \
 //x=22.83 //y=0.805 //x2=24.37 //y2=0.175
cc_8886 ( N_noxref_30_c_15149_n N_GND_c_16522_n ) capacitor c=0.0364778f \
 //x=23.715 //y=0.72 //x2=24.37 //y2=0.175
cc_8887 ( N_noxref_30_c_15194_p N_GND_c_16522_n ) capacitor c=0.013886f \
 //x=23.8 //y=0.805 //x2=24.37 //y2=0.175
cc_8888 ( N_noxref_30_M14_noxref_s N_GND_c_16530_n ) capacitor c=8.16352e-19 \
 //x=22.695 //y=0.555 //x2=19.73 //y2=0.175
cc_8889 ( N_noxref_30_c_15194_p N_GND_c_16563_n ) capacitor c=0.037873f \
 //x=23.8 //y=0.805 //x2=24.54 //y2=0.175
cc_8890 ( N_noxref_30_M14_noxref_s N_GND_c_16563_n ) capacitor c=0.0051897f \
 //x=22.695 //y=0.555 //x2=24.54 //y2=0.175
cc_8891 ( N_noxref_30_M13_noxref_d N_GND_M12_noxref_d ) capacitor \
 c=3.12752e-19 //x=21.59 //y=1.09 //x2=20.615 //y2=1.055
cc_8892 ( N_noxref_30_c_15192_p N_noxref_51_c_18393_n ) capacitor \
 c=2.15937e-19 //x=22.83 //y=0.805 //x2=21.29 //y2=0.805
cc_8893 ( N_noxref_30_c_15171_n N_noxref_51_c_18378_n ) capacitor c=0.0130732f \
 //x=22.745 //y=1.175 //x2=22.175 //y2=0.72
cc_8894 ( N_noxref_30_M13_noxref_d N_noxref_51_c_18378_n ) capacitor \
 c=0.0160925f //x=21.59 //y=1.09 //x2=22.175 //y2=0.72
cc_8895 ( N_noxref_30_c_15171_n N_noxref_51_c_18380_n ) capacitor \
 c=0.00941485f //x=22.745 //y=1.175 //x2=22.175 //y2=1.77
cc_8896 ( N_noxref_30_M13_noxref_d N_noxref_51_c_18380_n ) capacitor \
 c=0.0151017f //x=21.59 //y=1.09 //x2=22.175 //y2=1.77
cc_8897 ( N_noxref_30_c_15171_n N_noxref_51_M12_noxref_s ) capacitor \
 c=0.0223986f //x=22.745 //y=1.175 //x2=20.185 //y2=0.555
cc_8898 ( N_noxref_30_c_15192_p N_noxref_51_M12_noxref_s ) capacitor \
 c=0.0175461f //x=22.83 //y=0.805 //x2=20.185 //y2=0.555
cc_8899 ( N_noxref_30_c_15194_p N_noxref_51_M12_noxref_s ) capacitor \
 c=2.98576e-19 //x=23.8 //y=0.805 //x2=20.185 //y2=0.555
cc_8900 ( N_noxref_30_M13_noxref_d N_noxref_51_M12_noxref_s ) capacitor \
 c=0.0187685f //x=21.59 //y=1.09 //x2=20.185 //y2=0.555
cc_8901 ( N_noxref_30_M14_noxref_s N_noxref_51_M12_noxref_s ) capacitor \
 c=0.0210819f //x=22.695 //y=0.555 //x2=20.185 //y2=0.555
cc_8902 ( N_noxref_30_c_15194_p N_noxref_52_M15_noxref_s ) capacitor \
 c=0.00368328f //x=23.8 //y=0.805 //x2=24.995 //y2=0.555
cc_8903 ( N_noxref_30_M14_noxref_s N_noxref_52_M15_noxref_s ) capacitor \
 c=0.00125282f //x=22.695 //y=0.555 //x2=24.995 //y2=0.555
cc_8904 ( N_noxref_31_c_15240_n N_GND_c_16588_n ) capacitor c=0.00533679f \
 //x=27.555 //y=1.175 //x2=30.34 //y2=0.175
cc_8905 ( N_noxref_31_c_15261_p N_GND_c_16588_n ) capacitor c=0.00338834f \
 //x=27.64 //y=0.805 //x2=30.34 //y2=0.175
cc_8906 ( N_noxref_31_c_15218_n N_GND_c_16588_n ) capacitor c=0.00960852f \
 //x=28.525 //y=0.72 //x2=30.34 //y2=0.175
cc_8907 ( N_noxref_31_c_15263_p N_GND_c_16588_n ) capacitor c=0.00232964f \
 //x=28.61 //y=0.805 //x2=30.34 //y2=0.175
cc_8908 ( N_noxref_31_M16_noxref_d N_GND_c_16588_n ) capacitor c=0.0131076f \
 //x=26.4 //y=1.09 //x2=30.34 //y2=0.175
cc_8909 ( N_noxref_31_M16_noxref_d N_GND_c_16549_n ) capacitor c=0.0154456f \
 //x=26.4 //y=1.09 //x2=25.615 //y2=1.145
cc_8910 ( N_noxref_31_c_15240_n N_GND_c_16562_n ) capacitor c=0.0091517f \
 //x=27.555 //y=1.175 //x2=29.18 //y2=0.175
cc_8911 ( N_noxref_31_c_15261_p N_GND_c_16562_n ) capacitor c=0.0141638f \
 //x=27.64 //y=0.805 //x2=29.18 //y2=0.175
cc_8912 ( N_noxref_31_c_15218_n N_GND_c_16562_n ) capacitor c=0.0364778f \
 //x=28.525 //y=0.72 //x2=29.18 //y2=0.175
cc_8913 ( N_noxref_31_c_15263_p N_GND_c_16562_n ) capacitor c=0.013886f \
 //x=28.61 //y=0.805 //x2=29.18 //y2=0.175
cc_8914 ( N_noxref_31_M17_noxref_s N_GND_c_16563_n ) capacitor c=8.16352e-19 \
 //x=27.505 //y=0.555 //x2=24.54 //y2=0.175
cc_8915 ( N_noxref_31_c_15263_p N_GND_c_16600_n ) capacitor c=0.037873f \
 //x=28.61 //y=0.805 //x2=29.35 //y2=0.175
cc_8916 ( N_noxref_31_M17_noxref_s N_GND_c_16600_n ) capacitor c=0.0051897f \
 //x=27.505 //y=0.555 //x2=29.35 //y2=0.175
cc_8917 ( N_noxref_31_M16_noxref_d N_GND_M15_noxref_d ) capacitor \
 c=3.12752e-19 //x=26.4 //y=1.09 //x2=25.425 //y2=1.055
cc_8918 ( N_noxref_31_c_15261_p N_noxref_52_c_18452_n ) capacitor \
 c=2.15937e-19 //x=27.64 //y=0.805 //x2=26.1 //y2=0.805
cc_8919 ( N_noxref_31_c_15240_n N_noxref_52_c_18440_n ) capacitor c=0.0130857f \
 //x=27.555 //y=1.175 //x2=26.985 //y2=0.72
cc_8920 ( N_noxref_31_M16_noxref_d N_noxref_52_c_18440_n ) capacitor \
 c=0.0160925f //x=26.4 //y=1.09 //x2=26.985 //y2=0.72
cc_8921 ( N_noxref_31_c_15240_n N_noxref_52_c_18438_n ) capacitor \
 c=0.00944538f //x=27.555 //y=1.175 //x2=26.985 //y2=1.77
cc_8922 ( N_noxref_31_M16_noxref_d N_noxref_52_c_18438_n ) capacitor \
 c=0.0148972f //x=26.4 //y=1.09 //x2=26.985 //y2=1.77
cc_8923 ( N_noxref_31_c_15240_n N_noxref_52_M15_noxref_s ) capacitor \
 c=0.0223986f //x=27.555 //y=1.175 //x2=24.995 //y2=0.555
cc_8924 ( N_noxref_31_c_15261_p N_noxref_52_M15_noxref_s ) capacitor \
 c=0.0175461f //x=27.64 //y=0.805 //x2=24.995 //y2=0.555
cc_8925 ( N_noxref_31_c_15263_p N_noxref_52_M15_noxref_s ) capacitor \
 c=2.98576e-19 //x=28.61 //y=0.805 //x2=24.995 //y2=0.555
cc_8926 ( N_noxref_31_M16_noxref_d N_noxref_52_M15_noxref_s ) capacitor \
 c=0.0187685f //x=26.4 //y=1.09 //x2=24.995 //y2=0.555
cc_8927 ( N_noxref_31_M17_noxref_s N_noxref_52_M15_noxref_s ) capacitor \
 c=0.0210819f //x=27.505 //y=0.555 //x2=24.995 //y2=0.555
cc_8928 ( N_noxref_31_c_15263_p N_noxref_53_M18_noxref_s ) capacitor \
 c=0.00368328f //x=28.61 //y=0.805 //x2=29.805 //y2=0.555
cc_8929 ( N_noxref_31_M17_noxref_s N_noxref_53_M18_noxref_s ) capacitor \
 c=0.00125282f //x=27.505 //y=0.555 //x2=29.805 //y2=0.555
cc_8930 ( N_noxref_32_c_15308_n N_GND_c_16658_n ) capacitor c=0.00533679f \
 //x=32.365 //y=1.175 //x2=35.15 //y2=0.175
cc_8931 ( N_noxref_32_c_15328_p N_GND_c_16658_n ) capacitor c=0.00435261f \
 //x=32.45 //y=0.805 //x2=35.15 //y2=0.175
cc_8932 ( N_noxref_32_c_15287_n N_GND_c_16658_n ) capacitor c=0.00958312f \
 //x=33.335 //y=0.72 //x2=35.15 //y2=0.175
cc_8933 ( N_noxref_32_c_15330_p N_GND_c_16658_n ) capacitor c=0.00232964f \
 //x=33.42 //y=0.805 //x2=35.15 //y2=0.175
cc_8934 ( N_noxref_32_M19_noxref_d N_GND_c_16658_n ) capacitor c=0.0130905f \
 //x=31.21 //y=1.09 //x2=35.15 //y2=0.175
cc_8935 ( N_noxref_32_M19_noxref_d N_GND_c_16624_n ) capacitor c=0.0154456f \
 //x=31.21 //y=1.09 //x2=30.425 //y2=1.145
cc_8936 ( N_noxref_32_c_15308_n N_GND_c_16689_n ) capacitor c=0.0091517f \
 //x=32.365 //y=1.175 //x2=33.99 //y2=0.175
cc_8937 ( N_noxref_32_c_15328_p N_GND_c_16689_n ) capacitor c=0.0141638f \
 //x=32.45 //y=0.805 //x2=33.99 //y2=0.175
cc_8938 ( N_noxref_32_c_15287_n N_GND_c_16689_n ) capacitor c=0.0364778f \
 //x=33.335 //y=0.72 //x2=33.99 //y2=0.175
cc_8939 ( N_noxref_32_c_15330_p N_GND_c_16689_n ) capacitor c=0.013886f \
 //x=33.42 //y=0.805 //x2=33.99 //y2=0.175
cc_8940 ( N_noxref_32_M20_noxref_s N_GND_c_16600_n ) capacitor c=8.16352e-19 \
 //x=32.315 //y=0.555 //x2=29.35 //y2=0.175
cc_8941 ( N_noxref_32_c_15330_p N_GND_c_16693_n ) capacitor c=0.037873f \
 //x=33.42 //y=0.805 //x2=34.16 //y2=0.175
cc_8942 ( N_noxref_32_M20_noxref_s N_GND_c_16693_n ) capacitor c=0.0051897f \
 //x=32.315 //y=0.555 //x2=34.16 //y2=0.175
cc_8943 ( N_noxref_32_M19_noxref_d N_GND_M18_noxref_d ) capacitor \
 c=3.12752e-19 //x=31.21 //y=1.09 //x2=30.235 //y2=1.055
cc_8944 ( N_noxref_32_c_15328_p N_noxref_53_c_18508_n ) capacitor \
 c=2.15937e-19 //x=32.45 //y=0.805 //x2=30.91 //y2=0.805
cc_8945 ( N_noxref_32_c_15308_n N_noxref_53_c_18495_n ) capacitor c=0.0130708f \
 //x=32.365 //y=1.175 //x2=31.795 //y2=0.72
cc_8946 ( N_noxref_32_M19_noxref_d N_noxref_53_c_18495_n ) capacitor \
 c=0.0160925f //x=31.21 //y=1.09 //x2=31.795 //y2=0.72
cc_8947 ( N_noxref_32_c_15308_n N_noxref_53_c_18497_n ) capacitor \
 c=0.00940919f //x=32.365 //y=1.175 //x2=31.795 //y2=1.77
cc_8948 ( N_noxref_32_M19_noxref_d N_noxref_53_c_18497_n ) capacitor \
 c=0.0151199f //x=31.21 //y=1.09 //x2=31.795 //y2=1.77
cc_8949 ( N_noxref_32_c_15308_n N_noxref_53_M18_noxref_s ) capacitor \
 c=0.0223986f //x=32.365 //y=1.175 //x2=29.805 //y2=0.555
cc_8950 ( N_noxref_32_c_15328_p N_noxref_53_M18_noxref_s ) capacitor \
 c=0.0175461f //x=32.45 //y=0.805 //x2=29.805 //y2=0.555
cc_8951 ( N_noxref_32_c_15330_p N_noxref_53_M18_noxref_s ) capacitor \
 c=2.98576e-19 //x=33.42 //y=0.805 //x2=29.805 //y2=0.555
cc_8952 ( N_noxref_32_M19_noxref_d N_noxref_53_M18_noxref_s ) capacitor \
 c=0.0187685f //x=31.21 //y=1.09 //x2=29.805 //y2=0.555
cc_8953 ( N_noxref_32_M20_noxref_s N_noxref_53_M18_noxref_s ) capacitor \
 c=0.0210819f //x=32.315 //y=0.555 //x2=29.805 //y2=0.555
cc_8954 ( N_noxref_32_c_15330_p N_noxref_54_M21_noxref_s ) capacitor \
 c=0.00368328f //x=33.42 //y=0.805 //x2=34.615 //y2=0.555
cc_8955 ( N_noxref_32_M20_noxref_s N_noxref_54_M21_noxref_s ) capacitor \
 c=0.00125282f //x=32.315 //y=0.555 //x2=34.615 //y2=0.555
cc_8956 ( N_noxref_33_c_15375_n N_GND_c_16769_n ) capacitor c=0.00533679f \
 //x=37.175 //y=1.175 //x2=39.96 //y2=0.175
cc_8957 ( N_noxref_33_c_15395_p N_GND_c_16769_n ) capacitor c=0.00427059f \
 //x=37.26 //y=0.805 //x2=39.96 //y2=0.175
cc_8958 ( N_noxref_33_c_15354_n N_GND_c_16769_n ) capacitor c=0.00960919f \
 //x=38.145 //y=0.72 //x2=39.96 //y2=0.175
cc_8959 ( N_noxref_33_c_15397_p N_GND_c_16769_n ) capacitor c=0.00232964f \
 //x=38.23 //y=0.805 //x2=39.96 //y2=0.175
cc_8960 ( N_noxref_33_M22_noxref_d N_GND_c_16769_n ) capacitor c=0.0130498f \
 //x=36.02 //y=1.09 //x2=39.96 //y2=0.175
cc_8961 ( N_noxref_33_M22_noxref_d N_GND_c_16668_n ) capacitor c=0.0154456f \
 //x=36.02 //y=1.09 //x2=35.235 //y2=1.145
cc_8962 ( N_noxref_33_c_15375_n N_GND_c_16691_n ) capacitor c=0.0091517f \
 //x=37.175 //y=1.175 //x2=38.8 //y2=0.175
cc_8963 ( N_noxref_33_c_15395_p N_GND_c_16691_n ) capacitor c=0.0141638f \
 //x=37.26 //y=0.805 //x2=38.8 //y2=0.175
cc_8964 ( N_noxref_33_c_15354_n N_GND_c_16691_n ) capacitor c=0.0364778f \
 //x=38.145 //y=0.72 //x2=38.8 //y2=0.175
cc_8965 ( N_noxref_33_c_15397_p N_GND_c_16691_n ) capacitor c=0.013886f \
 //x=38.23 //y=0.805 //x2=38.8 //y2=0.175
cc_8966 ( N_noxref_33_M23_noxref_s N_GND_c_16693_n ) capacitor c=8.16352e-19 \
 //x=37.125 //y=0.555 //x2=34.16 //y2=0.175
cc_8967 ( N_noxref_33_c_15397_p N_GND_c_16706_n ) capacitor c=0.037873f \
 //x=38.23 //y=0.805 //x2=38.97 //y2=0.175
cc_8968 ( N_noxref_33_M23_noxref_s N_GND_c_16706_n ) capacitor c=0.0051897f \
 //x=37.125 //y=0.555 //x2=38.97 //y2=0.175
cc_8969 ( N_noxref_33_M22_noxref_d N_GND_M21_noxref_d ) capacitor \
 c=3.12752e-19 //x=36.02 //y=1.09 //x2=35.045 //y2=1.055
cc_8970 ( N_noxref_33_c_15395_p N_noxref_54_c_18565_n ) capacitor \
 c=2.15937e-19 //x=37.26 //y=0.805 //x2=35.72 //y2=0.805
cc_8971 ( N_noxref_33_c_15375_n N_noxref_54_c_18549_n ) capacitor c=0.0130857f \
 //x=37.175 //y=1.175 //x2=36.605 //y2=0.72
cc_8972 ( N_noxref_33_M22_noxref_d N_noxref_54_c_18549_n ) capacitor \
 c=0.0160925f //x=36.02 //y=1.09 //x2=36.605 //y2=0.72
cc_8973 ( N_noxref_33_c_15375_n N_noxref_54_c_18551_n ) capacitor \
 c=0.00944538f //x=37.175 //y=1.175 //x2=36.605 //y2=1.77
cc_8974 ( N_noxref_33_M22_noxref_d N_noxref_54_c_18551_n ) capacitor \
 c=0.0152674f //x=36.02 //y=1.09 //x2=36.605 //y2=1.77
cc_8975 ( N_noxref_33_c_15375_n N_noxref_54_M21_noxref_s ) capacitor \
 c=0.0223986f //x=37.175 //y=1.175 //x2=34.615 //y2=0.555
cc_8976 ( N_noxref_33_c_15395_p N_noxref_54_M21_noxref_s ) capacitor \
 c=0.0175461f //x=37.26 //y=0.805 //x2=34.615 //y2=0.555
cc_8977 ( N_noxref_33_c_15397_p N_noxref_54_M21_noxref_s ) capacitor \
 c=2.98576e-19 //x=38.23 //y=0.805 //x2=34.615 //y2=0.555
cc_8978 ( N_noxref_33_M22_noxref_d N_noxref_54_M21_noxref_s ) capacitor \
 c=0.0187685f //x=36.02 //y=1.09 //x2=34.615 //y2=0.555
cc_8979 ( N_noxref_33_M23_noxref_s N_noxref_54_M21_noxref_s ) capacitor \
 c=0.0210819f //x=37.125 //y=0.555 //x2=34.615 //y2=0.555
cc_8980 ( N_noxref_33_c_15397_p N_noxref_55_M24_noxref_s ) capacitor \
 c=0.00368328f //x=38.23 //y=0.805 //x2=39.425 //y2=0.555
cc_8981 ( N_noxref_33_M23_noxref_s N_noxref_55_M24_noxref_s ) capacitor \
 c=0.00125282f //x=37.125 //y=0.555 //x2=39.425 //y2=0.555
cc_8982 ( N_noxref_34_c_15443_n N_GND_c_16728_n ) capacitor c=0.00533679f \
 //x=41.985 //y=1.175 //x2=44.77 //y2=0.175
cc_8983 ( N_noxref_34_c_15463_p N_GND_c_16728_n ) capacitor c=0.00338855f \
 //x=42.07 //y=0.805 //x2=44.77 //y2=0.175
cc_8984 ( N_noxref_34_c_15420_n N_GND_c_16728_n ) capacitor c=0.00960919f \
 //x=42.955 //y=0.72 //x2=44.77 //y2=0.175
cc_8985 ( N_noxref_34_c_15465_p N_GND_c_16728_n ) capacitor c=0.00232964f \
 //x=43.04 //y=0.805 //x2=44.77 //y2=0.175
cc_8986 ( N_noxref_34_M25_noxref_d N_GND_c_16728_n ) capacitor c=0.0131076f \
 //x=40.83 //y=1.09 //x2=44.77 //y2=0.175
cc_8987 ( N_noxref_34_M25_noxref_d N_GND_c_16679_n ) capacitor c=0.0154456f \
 //x=40.83 //y=1.09 //x2=40.045 //y2=1.145
cc_8988 ( N_noxref_34_c_15443_n N_GND_c_16692_n ) capacitor c=0.0091517f \
 //x=41.985 //y=1.175 //x2=43.61 //y2=0.175
cc_8989 ( N_noxref_34_c_15463_p N_GND_c_16692_n ) capacitor c=0.0141638f \
 //x=42.07 //y=0.805 //x2=43.61 //y2=0.175
cc_8990 ( N_noxref_34_c_15420_n N_GND_c_16692_n ) capacitor c=0.0364778f \
 //x=42.955 //y=0.72 //x2=43.61 //y2=0.175
cc_8991 ( N_noxref_34_c_15465_p N_GND_c_16692_n ) capacitor c=0.013886f \
 //x=43.04 //y=0.805 //x2=43.61 //y2=0.175
cc_8992 ( N_noxref_34_M26_noxref_s N_GND_c_16706_n ) capacitor c=8.16352e-19 \
 //x=41.935 //y=0.555 //x2=38.97 //y2=0.175
cc_8993 ( N_noxref_34_c_15465_p N_GND_c_16749_n ) capacitor c=0.037873f \
 //x=43.04 //y=0.805 //x2=43.78 //y2=0.175
cc_8994 ( N_noxref_34_M26_noxref_s N_GND_c_16749_n ) capacitor c=0.0051897f \
 //x=41.935 //y=0.555 //x2=43.78 //y2=0.175
cc_8995 ( N_noxref_34_M25_noxref_d N_GND_M24_noxref_d ) capacitor \
 c=3.12752e-19 //x=40.83 //y=1.09 //x2=39.855 //y2=1.055
cc_8996 ( N_noxref_34_c_15463_p N_noxref_55_c_18623_n ) capacitor \
 c=2.15937e-19 //x=42.07 //y=0.805 //x2=40.53 //y2=0.805
cc_8997 ( N_noxref_34_c_15443_n N_noxref_55_c_18610_n ) capacitor c=0.0130857f \
 //x=41.985 //y=1.175 //x2=41.415 //y2=0.72
cc_8998 ( N_noxref_34_M25_noxref_d N_noxref_55_c_18610_n ) capacitor \
 c=0.0160925f //x=40.83 //y=1.09 //x2=41.415 //y2=0.72
cc_8999 ( N_noxref_34_c_15443_n N_noxref_55_c_18608_n ) capacitor \
 c=0.00944538f //x=41.985 //y=1.175 //x2=41.415 //y2=1.77
cc_9000 ( N_noxref_34_M25_noxref_d N_noxref_55_c_18608_n ) capacitor \
 c=0.0151784f //x=40.83 //y=1.09 //x2=41.415 //y2=1.77
cc_9001 ( N_noxref_34_c_15443_n N_noxref_55_M24_noxref_s ) capacitor \
 c=0.0223986f //x=41.985 //y=1.175 //x2=39.425 //y2=0.555
cc_9002 ( N_noxref_34_c_15463_p N_noxref_55_M24_noxref_s ) capacitor \
 c=0.0175461f //x=42.07 //y=0.805 //x2=39.425 //y2=0.555
cc_9003 ( N_noxref_34_c_15465_p N_noxref_55_M24_noxref_s ) capacitor \
 c=2.98576e-19 //x=43.04 //y=0.805 //x2=39.425 //y2=0.555
cc_9004 ( N_noxref_34_M25_noxref_d N_noxref_55_M24_noxref_s ) capacitor \
 c=0.0187685f //x=40.83 //y=1.09 //x2=39.425 //y2=0.555
cc_9005 ( N_noxref_34_M26_noxref_s N_noxref_55_M24_noxref_s ) capacitor \
 c=0.0210819f //x=41.935 //y=0.555 //x2=39.425 //y2=0.555
cc_9006 ( N_noxref_34_c_15465_p N_noxref_56_M27_noxref_s ) capacitor \
 c=0.00368328f //x=43.04 //y=0.805 //x2=44.235 //y2=0.555
cc_9007 ( N_noxref_34_M26_noxref_s N_noxref_56_M27_noxref_s ) capacitor \
 c=0.00125282f //x=41.935 //y=0.555 //x2=44.235 //y2=0.555
cc_9008 ( N_noxref_35_c_15500_n N_GND_c_16850_n ) capacitor c=0.00533679f \
 //x=46.795 //y=1.175 //x2=49.58 //y2=0.175
cc_9009 ( N_noxref_35_c_15530_p N_GND_c_16850_n ) capacitor c=0.00428749f \
 //x=46.88 //y=0.805 //x2=49.58 //y2=0.175
cc_9010 ( N_noxref_35_c_15489_n N_GND_c_16850_n ) capacitor c=0.00949233f \
 //x=47.765 //y=0.72 //x2=49.58 //y2=0.175
cc_9011 ( N_noxref_35_c_15532_p N_GND_c_16850_n ) capacitor c=0.00232964f \
 //x=47.85 //y=0.805 //x2=49.58 //y2=0.175
cc_9012 ( N_noxref_35_M28_noxref_d N_GND_c_16850_n ) capacitor c=0.0131076f \
 //x=45.64 //y=1.09 //x2=49.58 //y2=0.175
cc_9013 ( N_noxref_35_M28_noxref_d N_GND_c_16735_n ) capacitor c=0.0154456f \
 //x=45.64 //y=1.09 //x2=44.855 //y2=1.145
cc_9014 ( N_noxref_35_c_15500_n N_GND_c_16748_n ) capacitor c=0.0091517f \
 //x=46.795 //y=1.175 //x2=48.42 //y2=0.175
cc_9015 ( N_noxref_35_c_15530_p N_GND_c_16748_n ) capacitor c=0.0141599f \
 //x=46.88 //y=0.805 //x2=48.42 //y2=0.175
cc_9016 ( N_noxref_35_c_15489_n N_GND_c_16748_n ) capacitor c=0.0364691f \
 //x=47.765 //y=0.72 //x2=48.42 //y2=0.175
cc_9017 ( N_noxref_35_c_15532_p N_GND_c_16748_n ) capacitor c=0.013886f \
 //x=47.85 //y=0.805 //x2=48.42 //y2=0.175
cc_9018 ( N_noxref_35_M29_noxref_s N_GND_c_16749_n ) capacitor c=8.16352e-19 \
 //x=46.745 //y=0.555 //x2=43.78 //y2=0.175
cc_9019 ( N_noxref_35_c_15532_p N_GND_c_16796_n ) capacitor c=0.037873f \
 //x=47.85 //y=0.805 //x2=48.59 //y2=0.175
cc_9020 ( N_noxref_35_M29_noxref_s N_GND_c_16796_n ) capacitor c=0.0051897f \
 //x=46.745 //y=0.555 //x2=48.59 //y2=0.175
cc_9021 ( N_noxref_35_M28_noxref_d N_GND_M27_noxref_d ) capacitor \
 c=3.12752e-19 //x=45.64 //y=1.09 //x2=44.665 //y2=1.055
cc_9022 ( N_noxref_35_c_15530_p N_noxref_56_c_18682_n ) capacitor \
 c=2.15937e-19 //x=46.88 //y=0.805 //x2=45.34 //y2=0.805
cc_9023 ( N_noxref_35_c_15500_n N_noxref_56_c_18664_n ) capacitor c=0.0130857f \
 //x=46.795 //y=1.175 //x2=46.225 //y2=0.72
cc_9024 ( N_noxref_35_M28_noxref_d N_noxref_56_c_18664_n ) capacitor \
 c=0.0160925f //x=45.64 //y=1.09 //x2=46.225 //y2=0.72
cc_9025 ( N_noxref_35_c_15500_n N_noxref_56_c_18666_n ) capacitor \
 c=0.00944538f //x=46.795 //y=1.175 //x2=46.225 //y2=1.77
cc_9026 ( N_noxref_35_M28_noxref_d N_noxref_56_c_18666_n ) capacitor \
 c=0.0152727f //x=45.64 //y=1.09 //x2=46.225 //y2=1.77
cc_9027 ( N_noxref_35_c_15500_n N_noxref_56_M27_noxref_s ) capacitor \
 c=0.0223986f //x=46.795 //y=1.175 //x2=44.235 //y2=0.555
cc_9028 ( N_noxref_35_c_15530_p N_noxref_56_M27_noxref_s ) capacitor \
 c=0.0175461f //x=46.88 //y=0.805 //x2=44.235 //y2=0.555
cc_9029 ( N_noxref_35_c_15532_p N_noxref_56_M27_noxref_s ) capacitor \
 c=2.98576e-19 //x=47.85 //y=0.805 //x2=44.235 //y2=0.555
cc_9030 ( N_noxref_35_M28_noxref_d N_noxref_56_M27_noxref_s ) capacitor \
 c=0.0187685f //x=45.64 //y=1.09 //x2=44.235 //y2=0.555
cc_9031 ( N_noxref_35_M29_noxref_s N_noxref_56_M27_noxref_s ) capacitor \
 c=0.0210819f //x=46.745 //y=0.555 //x2=44.235 //y2=0.555
cc_9032 ( N_noxref_35_c_15532_p N_noxref_57_M30_noxref_s ) capacitor \
 c=0.00368328f //x=47.85 //y=0.805 //x2=49.045 //y2=0.555
cc_9033 ( N_noxref_35_M29_noxref_s N_noxref_57_M30_noxref_s ) capacitor \
 c=0.00125282f //x=46.745 //y=0.555 //x2=49.045 //y2=0.555
cc_9034 ( N_noxref_36_c_15567_n N_GND_c_16808_n ) capacitor c=0.00533679f \
 //x=51.605 //y=1.175 //x2=54.39 //y2=0.175
cc_9035 ( N_noxref_36_c_15598_p N_GND_c_16808_n ) capacitor c=0.00426228f \
 //x=51.69 //y=0.805 //x2=54.39 //y2=0.175
cc_9036 ( N_noxref_36_c_15555_n N_GND_c_16808_n ) capacitor c=0.00957691f \
 //x=52.575 //y=0.72 //x2=54.39 //y2=0.175
cc_9037 ( N_noxref_36_c_15600_p N_GND_c_16808_n ) capacitor c=0.00232964f \
 //x=52.66 //y=0.805 //x2=54.39 //y2=0.175
cc_9038 ( N_noxref_36_M31_noxref_d N_GND_c_16808_n ) capacitor c=0.0130924f \
 //x=50.45 //y=1.09 //x2=54.39 //y2=0.175
cc_9039 ( N_noxref_36_M31_noxref_d N_GND_c_16777_n ) capacitor c=0.0154456f \
 //x=50.45 //y=1.09 //x2=49.665 //y2=1.145
cc_9040 ( N_noxref_36_c_15567_n N_GND_c_16790_n ) capacitor c=0.0091517f \
 //x=51.605 //y=1.175 //x2=53.23 //y2=0.175
cc_9041 ( N_noxref_36_c_15598_p N_GND_c_16790_n ) capacitor c=0.0141638f \
 //x=51.69 //y=0.805 //x2=53.23 //y2=0.175
cc_9042 ( N_noxref_36_c_15555_n N_GND_c_16790_n ) capacitor c=0.0364262f \
 //x=52.575 //y=0.72 //x2=53.23 //y2=0.175
cc_9043 ( N_noxref_36_c_15600_p N_GND_c_16790_n ) capacitor c=0.013886f \
 //x=52.66 //y=0.805 //x2=53.23 //y2=0.175
cc_9044 ( N_noxref_36_M32_noxref_s N_GND_c_16796_n ) capacitor c=8.16352e-19 \
 //x=51.555 //y=0.555 //x2=48.59 //y2=0.175
cc_9045 ( N_noxref_36_c_15600_p N_GND_c_16829_n ) capacitor c=0.037873f \
 //x=52.66 //y=0.805 //x2=53.4 //y2=0.175
cc_9046 ( N_noxref_36_M32_noxref_s N_GND_c_16829_n ) capacitor c=0.0051897f \
 //x=51.555 //y=0.555 //x2=53.4 //y2=0.175
cc_9047 ( N_noxref_36_M31_noxref_d N_GND_M30_noxref_d ) capacitor \
 c=3.12752e-19 //x=50.45 //y=1.09 //x2=49.475 //y2=1.055
cc_9048 ( N_noxref_36_c_15598_p N_noxref_57_c_18740_n ) capacitor \
 c=2.15937e-19 //x=51.69 //y=0.805 //x2=50.15 //y2=0.805
cc_9049 ( N_noxref_36_c_15567_n N_noxref_57_c_18725_n ) capacitor c=0.0130732f \
 //x=51.605 //y=1.175 //x2=51.035 //y2=0.72
cc_9050 ( N_noxref_36_M31_noxref_d N_noxref_57_c_18725_n ) capacitor \
 c=0.0160925f //x=50.45 //y=1.09 //x2=51.035 //y2=0.72
cc_9051 ( N_noxref_36_c_15567_n N_noxref_57_c_18727_n ) capacitor \
 c=0.00941485f //x=51.605 //y=1.175 //x2=51.035 //y2=1.77
cc_9052 ( N_noxref_36_M31_noxref_d N_noxref_57_c_18727_n ) capacitor \
 c=0.0151017f //x=50.45 //y=1.09 //x2=51.035 //y2=1.77
cc_9053 ( N_noxref_36_c_15567_n N_noxref_57_M30_noxref_s ) capacitor \
 c=0.0223986f //x=51.605 //y=1.175 //x2=49.045 //y2=0.555
cc_9054 ( N_noxref_36_c_15598_p N_noxref_57_M30_noxref_s ) capacitor \
 c=0.0175461f //x=51.69 //y=0.805 //x2=49.045 //y2=0.555
cc_9055 ( N_noxref_36_c_15600_p N_noxref_57_M30_noxref_s ) capacitor \
 c=2.98576e-19 //x=52.66 //y=0.805 //x2=49.045 //y2=0.555
cc_9056 ( N_noxref_36_M31_noxref_d N_noxref_57_M30_noxref_s ) capacitor \
 c=0.0187685f //x=50.45 //y=1.09 //x2=49.045 //y2=0.555
cc_9057 ( N_noxref_36_M32_noxref_s N_noxref_57_M30_noxref_s ) capacitor \
 c=0.0210819f //x=51.555 //y=0.555 //x2=49.045 //y2=0.555
cc_9058 ( N_noxref_36_c_15600_p N_noxref_58_M33_noxref_s ) capacitor \
 c=0.00368328f //x=52.66 //y=0.805 //x2=53.855 //y2=0.555
cc_9059 ( N_noxref_36_M32_noxref_s N_noxref_58_M33_noxref_s ) capacitor \
 c=0.00125282f //x=51.555 //y=0.555 //x2=53.855 //y2=0.555
cc_9060 ( N_noxref_37_c_15635_n N_GND_c_16854_n ) capacitor c=0.00533679f \
 //x=56.415 //y=1.175 //x2=59.2 //y2=0.175
cc_9061 ( N_noxref_37_c_15667_p N_GND_c_16854_n ) capacitor c=0.00338834f \
 //x=56.5 //y=0.805 //x2=59.2 //y2=0.175
cc_9062 ( N_noxref_37_c_15624_n N_GND_c_16854_n ) capacitor c=0.00960852f \
 //x=57.385 //y=0.72 //x2=59.2 //y2=0.175
cc_9063 ( N_noxref_37_c_15669_p N_GND_c_16854_n ) capacitor c=0.00232964f \
 //x=57.47 //y=0.805 //x2=59.2 //y2=0.175
cc_9064 ( N_noxref_37_M34_noxref_d N_GND_c_16854_n ) capacitor c=0.0131076f \
 //x=55.26 //y=1.09 //x2=59.2 //y2=0.175
cc_9065 ( N_noxref_37_M34_noxref_d N_GND_c_16815_n ) capacitor c=0.0154456f \
 //x=55.26 //y=1.09 //x2=54.475 //y2=1.145
cc_9066 ( N_noxref_37_c_15635_n N_GND_c_16828_n ) capacitor c=0.0091517f \
 //x=56.415 //y=1.175 //x2=58.04 //y2=0.175
cc_9067 ( N_noxref_37_c_15667_p N_GND_c_16828_n ) capacitor c=0.0141638f \
 //x=56.5 //y=0.805 //x2=58.04 //y2=0.175
cc_9068 ( N_noxref_37_c_15624_n N_GND_c_16828_n ) capacitor c=0.0364778f \
 //x=57.385 //y=0.72 //x2=58.04 //y2=0.175
cc_9069 ( N_noxref_37_c_15669_p N_GND_c_16828_n ) capacitor c=0.013886f \
 //x=57.47 //y=0.805 //x2=58.04 //y2=0.175
cc_9070 ( N_noxref_37_M35_noxref_s N_GND_c_16829_n ) capacitor c=8.16352e-19 \
 //x=56.365 //y=0.555 //x2=53.4 //y2=0.175
cc_9071 ( N_noxref_37_c_15669_p N_GND_c_16867_n ) capacitor c=0.037873f \
 //x=57.47 //y=0.805 //x2=58.21 //y2=0.175
cc_9072 ( N_noxref_37_M35_noxref_s N_GND_c_16867_n ) capacitor c=0.0051897f \
 //x=56.365 //y=0.555 //x2=58.21 //y2=0.175
cc_9073 ( N_noxref_37_M34_noxref_d N_GND_M33_noxref_d ) capacitor \
 c=3.12752e-19 //x=55.26 //y=1.09 //x2=54.285 //y2=1.055
cc_9074 ( N_noxref_37_c_15667_p N_noxref_58_c_18799_n ) capacitor \
 c=2.15937e-19 //x=56.5 //y=0.805 //x2=54.96 //y2=0.805
cc_9075 ( N_noxref_37_c_15635_n N_noxref_58_c_18787_n ) capacitor c=0.0130857f \
 //x=56.415 //y=1.175 //x2=55.845 //y2=0.72
cc_9076 ( N_noxref_37_M34_noxref_d N_noxref_58_c_18787_n ) capacitor \
 c=0.0160925f //x=55.26 //y=1.09 //x2=55.845 //y2=0.72
cc_9077 ( N_noxref_37_c_15635_n N_noxref_58_c_18785_n ) capacitor \
 c=0.00944538f //x=56.415 //y=1.175 //x2=55.845 //y2=1.77
cc_9078 ( N_noxref_37_M34_noxref_d N_noxref_58_c_18785_n ) capacitor \
 c=0.0148972f //x=55.26 //y=1.09 //x2=55.845 //y2=1.77
cc_9079 ( N_noxref_37_c_15635_n N_noxref_58_M33_noxref_s ) capacitor \
 c=0.0223986f //x=56.415 //y=1.175 //x2=53.855 //y2=0.555
cc_9080 ( N_noxref_37_c_15667_p N_noxref_58_M33_noxref_s ) capacitor \
 c=0.0175461f //x=56.5 //y=0.805 //x2=53.855 //y2=0.555
cc_9081 ( N_noxref_37_c_15669_p N_noxref_58_M33_noxref_s ) capacitor \
 c=2.98576e-19 //x=57.47 //y=0.805 //x2=53.855 //y2=0.555
cc_9082 ( N_noxref_37_M34_noxref_d N_noxref_58_M33_noxref_s ) capacitor \
 c=0.0187685f //x=55.26 //y=1.09 //x2=53.855 //y2=0.555
cc_9083 ( N_noxref_37_M35_noxref_s N_noxref_58_M33_noxref_s ) capacitor \
 c=0.0210819f //x=56.365 //y=0.555 //x2=53.855 //y2=0.555
cc_9084 ( N_noxref_37_c_15669_p N_noxref_59_M36_noxref_s ) capacitor \
 c=0.00368328f //x=57.47 //y=0.805 //x2=58.665 //y2=0.555
cc_9085 ( N_noxref_37_M35_noxref_s N_noxref_59_M36_noxref_s ) capacitor \
 c=0.00125282f //x=56.365 //y=0.555 //x2=58.665 //y2=0.555
cc_9086 ( N_noxref_38_c_15713_n N_GND_c_16949_n ) capacitor c=0.00533679f \
 //x=61.225 //y=1.175 //x2=64.01 //y2=0.175
cc_9087 ( N_noxref_38_c_15734_p N_GND_c_16949_n ) capacitor c=0.00435261f \
 //x=61.31 //y=0.805 //x2=64.01 //y2=0.175
cc_9088 ( N_noxref_38_c_15692_n N_GND_c_16949_n ) capacitor c=0.00958312f \
 //x=62.195 //y=0.72 //x2=64.01 //y2=0.175
cc_9089 ( N_noxref_38_c_15736_p N_GND_c_16949_n ) capacitor c=0.00232964f \
 //x=62.28 //y=0.805 //x2=64.01 //y2=0.175
cc_9090 ( N_noxref_38_M37_noxref_d N_GND_c_16949_n ) capacitor c=0.0130905f \
 //x=60.07 //y=1.09 //x2=64.01 //y2=0.175
cc_9091 ( N_noxref_38_M37_noxref_d N_GND_c_16900_n ) capacitor c=0.0154456f \
 //x=60.07 //y=1.09 //x2=59.285 //y2=1.145
cc_9092 ( N_noxref_38_c_15713_n N_GND_c_16917_n ) capacitor c=0.0091517f \
 //x=61.225 //y=1.175 //x2=62.85 //y2=0.175
cc_9093 ( N_noxref_38_c_15734_p N_GND_c_16917_n ) capacitor c=0.0141638f \
 //x=61.31 //y=0.805 //x2=62.85 //y2=0.175
cc_9094 ( N_noxref_38_c_15692_n N_GND_c_16917_n ) capacitor c=0.0364778f \
 //x=62.195 //y=0.72 //x2=62.85 //y2=0.175
cc_9095 ( N_noxref_38_c_15736_p N_GND_c_16917_n ) capacitor c=0.013886f \
 //x=62.28 //y=0.805 //x2=62.85 //y2=0.175
cc_9096 ( N_noxref_38_M38_noxref_s N_GND_c_16867_n ) capacitor c=8.16352e-19 \
 //x=61.175 //y=0.555 //x2=58.21 //y2=0.175
cc_9097 ( N_noxref_38_c_15736_p N_GND_c_16984_n ) capacitor c=0.037873f \
 //x=62.28 //y=0.805 //x2=63.02 //y2=0.175
cc_9098 ( N_noxref_38_M38_noxref_s N_GND_c_16984_n ) capacitor c=0.0051897f \
 //x=61.175 //y=0.555 //x2=63.02 //y2=0.175
cc_9099 ( N_noxref_38_M37_noxref_d N_GND_M36_noxref_d ) capacitor \
 c=3.12752e-19 //x=60.07 //y=1.09 //x2=59.095 //y2=1.055
cc_9100 ( N_noxref_38_c_15734_p N_noxref_59_c_18855_n ) capacitor \
 c=2.15937e-19 //x=61.31 //y=0.805 //x2=59.77 //y2=0.805
cc_9101 ( N_noxref_38_c_15713_n N_noxref_59_c_18842_n ) capacitor c=0.0130708f \
 //x=61.225 //y=1.175 //x2=60.655 //y2=0.72
cc_9102 ( N_noxref_38_M37_noxref_d N_noxref_59_c_18842_n ) capacitor \
 c=0.0160925f //x=60.07 //y=1.09 //x2=60.655 //y2=0.72
cc_9103 ( N_noxref_38_c_15713_n N_noxref_59_c_18844_n ) capacitor \
 c=0.00940919f //x=61.225 //y=1.175 //x2=60.655 //y2=1.77
cc_9104 ( N_noxref_38_M37_noxref_d N_noxref_59_c_18844_n ) capacitor \
 c=0.0151199f //x=60.07 //y=1.09 //x2=60.655 //y2=1.77
cc_9105 ( N_noxref_38_c_15713_n N_noxref_59_M36_noxref_s ) capacitor \
 c=0.0223986f //x=61.225 //y=1.175 //x2=58.665 //y2=0.555
cc_9106 ( N_noxref_38_c_15734_p N_noxref_59_M36_noxref_s ) capacitor \
 c=0.0175461f //x=61.31 //y=0.805 //x2=58.665 //y2=0.555
cc_9107 ( N_noxref_38_c_15736_p N_noxref_59_M36_noxref_s ) capacitor \
 c=2.98576e-19 //x=62.28 //y=0.805 //x2=58.665 //y2=0.555
cc_9108 ( N_noxref_38_M37_noxref_d N_noxref_59_M36_noxref_s ) capacitor \
 c=0.0187685f //x=60.07 //y=1.09 //x2=58.665 //y2=0.555
cc_9109 ( N_noxref_38_M38_noxref_s N_noxref_59_M36_noxref_s ) capacitor \
 c=0.0210819f //x=61.175 //y=0.555 //x2=58.665 //y2=0.555
cc_9110 ( N_noxref_38_c_15736_p N_noxref_60_M39_noxref_s ) capacitor \
 c=0.00368328f //x=62.28 //y=0.805 //x2=63.475 //y2=0.555
cc_9111 ( N_noxref_38_M38_noxref_s N_noxref_60_M39_noxref_s ) capacitor \
 c=0.00125282f //x=61.175 //y=0.555 //x2=63.475 //y2=0.555
cc_9112 ( N_noxref_39_c_15760_n N_GND_c_17063_n ) capacitor c=0.00533679f \
 //x=66.035 //y=1.175 //x2=68.82 //y2=0.175
cc_9113 ( N_noxref_39_c_15801_p N_GND_c_17063_n ) capacitor c=0.00427059f \
 //x=66.12 //y=0.805 //x2=68.82 //y2=0.175
cc_9114 ( N_noxref_39_c_15775_n N_GND_c_17063_n ) capacitor c=0.00960919f \
 //x=67.005 //y=0.72 //x2=68.82 //y2=0.175
cc_9115 ( N_noxref_39_c_15803_p N_GND_c_17063_n ) capacitor c=0.00232964f \
 //x=67.09 //y=0.805 //x2=68.82 //y2=0.175
cc_9116 ( N_noxref_39_M40_noxref_d N_GND_c_17063_n ) capacitor c=0.0130498f \
 //x=64.88 //y=1.09 //x2=68.82 //y2=0.175
cc_9117 ( N_noxref_39_M40_noxref_d N_GND_c_16959_n ) capacitor c=0.0154456f \
 //x=64.88 //y=1.09 //x2=64.095 //y2=1.145
cc_9118 ( N_noxref_39_c_15760_n N_GND_c_16982_n ) capacitor c=0.0091517f \
 //x=66.035 //y=1.175 //x2=67.66 //y2=0.175
cc_9119 ( N_noxref_39_c_15801_p N_GND_c_16982_n ) capacitor c=0.0141638f \
 //x=66.12 //y=0.805 //x2=67.66 //y2=0.175
cc_9120 ( N_noxref_39_c_15775_n N_GND_c_16982_n ) capacitor c=0.0364778f \
 //x=67.005 //y=0.72 //x2=67.66 //y2=0.175
cc_9121 ( N_noxref_39_c_15803_p N_GND_c_16982_n ) capacitor c=0.013886f \
 //x=67.09 //y=0.805 //x2=67.66 //y2=0.175
cc_9122 ( N_noxref_39_M41_noxref_s N_GND_c_16984_n ) capacitor c=8.16352e-19 \
 //x=65.985 //y=0.555 //x2=63.02 //y2=0.175
cc_9123 ( N_noxref_39_c_15803_p N_GND_c_16997_n ) capacitor c=0.037873f \
 //x=67.09 //y=0.805 //x2=67.83 //y2=0.175
cc_9124 ( N_noxref_39_M41_noxref_s N_GND_c_16997_n ) capacitor c=0.0051897f \
 //x=65.985 //y=0.555 //x2=67.83 //y2=0.175
cc_9125 ( N_noxref_39_M40_noxref_d N_GND_M39_noxref_d ) capacitor \
 c=3.12752e-19 //x=64.88 //y=1.09 //x2=63.905 //y2=1.055
cc_9126 ( N_noxref_39_c_15801_p N_noxref_60_c_18912_n ) capacitor \
 c=2.15937e-19 //x=66.12 //y=0.805 //x2=64.58 //y2=0.805
cc_9127 ( N_noxref_39_c_15760_n N_noxref_60_c_18896_n ) capacitor c=0.0130857f \
 //x=66.035 //y=1.175 //x2=65.465 //y2=0.72
cc_9128 ( N_noxref_39_M40_noxref_d N_noxref_60_c_18896_n ) capacitor \
 c=0.0160925f //x=64.88 //y=1.09 //x2=65.465 //y2=0.72
cc_9129 ( N_noxref_39_c_15760_n N_noxref_60_c_18898_n ) capacitor \
 c=0.00944538f //x=66.035 //y=1.175 //x2=65.465 //y2=1.77
cc_9130 ( N_noxref_39_M40_noxref_d N_noxref_60_c_18898_n ) capacitor \
 c=0.0152674f //x=64.88 //y=1.09 //x2=65.465 //y2=1.77
cc_9131 ( N_noxref_39_c_15760_n N_noxref_60_M39_noxref_s ) capacitor \
 c=0.0223986f //x=66.035 //y=1.175 //x2=63.475 //y2=0.555
cc_9132 ( N_noxref_39_c_15801_p N_noxref_60_M39_noxref_s ) capacitor \
 c=0.0175461f //x=66.12 //y=0.805 //x2=63.475 //y2=0.555
cc_9133 ( N_noxref_39_c_15803_p N_noxref_60_M39_noxref_s ) capacitor \
 c=2.98576e-19 //x=67.09 //y=0.805 //x2=63.475 //y2=0.555
cc_9134 ( N_noxref_39_M40_noxref_d N_noxref_60_M39_noxref_s ) capacitor \
 c=0.0187685f //x=64.88 //y=1.09 //x2=63.475 //y2=0.555
cc_9135 ( N_noxref_39_M41_noxref_s N_noxref_60_M39_noxref_s ) capacitor \
 c=0.0210819f //x=65.985 //y=0.555 //x2=63.475 //y2=0.555
cc_9136 ( N_noxref_39_c_15803_p N_noxref_61_M42_noxref_s ) capacitor \
 c=0.00368328f //x=67.09 //y=0.805 //x2=68.285 //y2=0.555
cc_9137 ( N_noxref_39_M41_noxref_s N_noxref_61_M42_noxref_s ) capacitor \
 c=0.00125282f //x=65.985 //y=0.555 //x2=68.285 //y2=0.555
cc_9138 ( N_noxref_40_c_15838_n N_GND_c_17019_n ) capacitor c=0.00533679f \
 //x=70.845 //y=1.175 //x2=73.63 //y2=0.175
cc_9139 ( N_noxref_40_c_15869_p N_GND_c_17019_n ) capacitor c=0.00338855f \
 //x=70.93 //y=0.805 //x2=73.63 //y2=0.175
cc_9140 ( N_noxref_40_c_15826_n N_GND_c_17019_n ) capacitor c=0.00960919f \
 //x=71.815 //y=0.72 //x2=73.63 //y2=0.175
cc_9141 ( N_noxref_40_c_15871_p N_GND_c_17019_n ) capacitor c=0.00232964f \
 //x=71.9 //y=0.805 //x2=73.63 //y2=0.175
cc_9142 ( N_noxref_40_M43_noxref_d N_GND_c_17019_n ) capacitor c=0.0131076f \
 //x=69.69 //y=1.09 //x2=73.63 //y2=0.175
cc_9143 ( N_noxref_40_M43_noxref_d N_GND_c_16970_n ) capacitor c=0.0154456f \
 //x=69.69 //y=1.09 //x2=68.905 //y2=1.145
cc_9144 ( N_noxref_40_c_15838_n N_GND_c_16983_n ) capacitor c=0.0091517f \
 //x=70.845 //y=1.175 //x2=72.47 //y2=0.175
cc_9145 ( N_noxref_40_c_15869_p N_GND_c_16983_n ) capacitor c=0.0141638f \
 //x=70.93 //y=0.805 //x2=72.47 //y2=0.175
cc_9146 ( N_noxref_40_c_15826_n N_GND_c_16983_n ) capacitor c=0.0364778f \
 //x=71.815 //y=0.72 //x2=72.47 //y2=0.175
cc_9147 ( N_noxref_40_c_15871_p N_GND_c_16983_n ) capacitor c=0.013886f \
 //x=71.9 //y=0.805 //x2=72.47 //y2=0.175
cc_9148 ( N_noxref_40_M44_noxref_s N_GND_c_16997_n ) capacitor c=8.16352e-19 \
 //x=70.795 //y=0.555 //x2=67.83 //y2=0.175
cc_9149 ( N_noxref_40_c_15871_p N_GND_c_17040_n ) capacitor c=0.037873f \
 //x=71.9 //y=0.805 //x2=72.64 //y2=0.175
cc_9150 ( N_noxref_40_M44_noxref_s N_GND_c_17040_n ) capacitor c=0.0051897f \
 //x=70.795 //y=0.555 //x2=72.64 //y2=0.175
cc_9151 ( N_noxref_40_M43_noxref_d N_GND_M42_noxref_d ) capacitor \
 c=3.12752e-19 //x=69.69 //y=1.09 //x2=68.715 //y2=1.055
cc_9152 ( N_noxref_40_c_15869_p N_noxref_61_c_18970_n ) capacitor \
 c=2.15937e-19 //x=70.93 //y=0.805 //x2=69.39 //y2=0.805
cc_9153 ( N_noxref_40_c_15838_n N_noxref_61_c_18957_n ) capacitor c=0.0130857f \
 //x=70.845 //y=1.175 //x2=70.275 //y2=0.72
cc_9154 ( N_noxref_40_M43_noxref_d N_noxref_61_c_18957_n ) capacitor \
 c=0.0160925f //x=69.69 //y=1.09 //x2=70.275 //y2=0.72
cc_9155 ( N_noxref_40_c_15838_n N_noxref_61_c_18955_n ) capacitor \
 c=0.00944538f //x=70.845 //y=1.175 //x2=70.275 //y2=1.77
cc_9156 ( N_noxref_40_M43_noxref_d N_noxref_61_c_18955_n ) capacitor \
 c=0.0151784f //x=69.69 //y=1.09 //x2=70.275 //y2=1.77
cc_9157 ( N_noxref_40_c_15838_n N_noxref_61_M42_noxref_s ) capacitor \
 c=0.0223986f //x=70.845 //y=1.175 //x2=68.285 //y2=0.555
cc_9158 ( N_noxref_40_c_15869_p N_noxref_61_M42_noxref_s ) capacitor \
 c=0.0175461f //x=70.93 //y=0.805 //x2=68.285 //y2=0.555
cc_9159 ( N_noxref_40_c_15871_p N_noxref_61_M42_noxref_s ) capacitor \
 c=2.98576e-19 //x=71.9 //y=0.805 //x2=68.285 //y2=0.555
cc_9160 ( N_noxref_40_M43_noxref_d N_noxref_61_M42_noxref_s ) capacitor \
 c=0.0187685f //x=69.69 //y=1.09 //x2=68.285 //y2=0.555
cc_9161 ( N_noxref_40_M44_noxref_s N_noxref_61_M42_noxref_s ) capacitor \
 c=0.0210819f //x=70.795 //y=0.555 //x2=68.285 //y2=0.555
cc_9162 ( N_noxref_40_c_15871_p N_noxref_62_M45_noxref_s ) capacitor \
 c=0.00368328f //x=71.9 //y=0.805 //x2=73.095 //y2=0.555
cc_9163 ( N_noxref_40_M44_noxref_s N_noxref_62_M45_noxref_s ) capacitor \
 c=0.00125282f //x=70.795 //y=0.555 //x2=73.095 //y2=0.555
cc_9164 ( N_noxref_41_c_15895_n N_GND_c_17064_n ) capacitor c=0.00533679f \
 //x=75.655 //y=1.175 //x2=78.44 //y2=0.175
cc_9165 ( N_noxref_41_c_15936_p N_GND_c_17064_n ) capacitor c=0.00428749f \
 //x=75.74 //y=0.805 //x2=78.44 //y2=0.175
cc_9166 ( N_noxref_41_c_15911_n N_GND_c_17064_n ) capacitor c=0.00949233f \
 //x=76.625 //y=0.72 //x2=78.44 //y2=0.175
cc_9167 ( N_noxref_41_c_15938_p N_GND_c_17064_n ) capacitor c=0.00232964f \
 //x=76.71 //y=0.805 //x2=78.44 //y2=0.175
cc_9168 ( N_noxref_41_M46_noxref_d N_GND_c_17064_n ) capacitor c=0.0131076f \
 //x=74.5 //y=1.09 //x2=78.44 //y2=0.175
cc_9169 ( N_noxref_41_M46_noxref_d N_GND_c_17026_n ) capacitor c=0.0154456f \
 //x=74.5 //y=1.09 //x2=73.715 //y2=1.145
cc_9170 ( N_noxref_41_c_15895_n N_GND_c_17039_n ) capacitor c=0.0091517f \
 //x=75.655 //y=1.175 //x2=77.28 //y2=0.175
cc_9171 ( N_noxref_41_c_15936_p N_GND_c_17039_n ) capacitor c=0.0141599f \
 //x=75.74 //y=0.805 //x2=77.28 //y2=0.175
cc_9172 ( N_noxref_41_c_15911_n N_GND_c_17039_n ) capacitor c=0.0364691f \
 //x=76.625 //y=0.72 //x2=77.28 //y2=0.175
cc_9173 ( N_noxref_41_c_15938_p N_GND_c_17039_n ) capacitor c=0.013886f \
 //x=76.71 //y=0.805 //x2=77.28 //y2=0.175
cc_9174 ( N_noxref_41_M47_noxref_s N_GND_c_17040_n ) capacitor c=8.16352e-19 \
 //x=75.605 //y=0.555 //x2=72.64 //y2=0.175
cc_9175 ( N_noxref_41_c_15938_p N_GND_c_17093_n ) capacitor c=0.037873f \
 //x=76.71 //y=0.805 //x2=77.45 //y2=0.175
cc_9176 ( N_noxref_41_M47_noxref_s N_GND_c_17093_n ) capacitor c=0.0051897f \
 //x=75.605 //y=0.555 //x2=77.45 //y2=0.175
cc_9177 ( N_noxref_41_M46_noxref_d N_GND_M45_noxref_d ) capacitor \
 c=3.12752e-19 //x=74.5 //y=1.09 //x2=73.525 //y2=1.055
cc_9178 ( N_noxref_41_c_15936_p N_noxref_62_c_19029_n ) capacitor \
 c=2.15937e-19 //x=75.74 //y=0.805 //x2=74.2 //y2=0.805
cc_9179 ( N_noxref_41_c_15895_n N_noxref_62_c_19011_n ) capacitor c=0.0130857f \
 //x=75.655 //y=1.175 //x2=75.085 //y2=0.72
cc_9180 ( N_noxref_41_M46_noxref_d N_noxref_62_c_19011_n ) capacitor \
 c=0.0160925f //x=74.5 //y=1.09 //x2=75.085 //y2=0.72
cc_9181 ( N_noxref_41_c_15895_n N_noxref_62_c_19013_n ) capacitor \
 c=0.00944538f //x=75.655 //y=1.175 //x2=75.085 //y2=1.77
cc_9182 ( N_noxref_41_M46_noxref_d N_noxref_62_c_19013_n ) capacitor \
 c=0.0152727f //x=74.5 //y=1.09 //x2=75.085 //y2=1.77
cc_9183 ( N_noxref_41_c_15895_n N_noxref_62_M45_noxref_s ) capacitor \
 c=0.0223986f //x=75.655 //y=1.175 //x2=73.095 //y2=0.555
cc_9184 ( N_noxref_41_c_15936_p N_noxref_62_M45_noxref_s ) capacitor \
 c=0.0175461f //x=75.74 //y=0.805 //x2=73.095 //y2=0.555
cc_9185 ( N_noxref_41_c_15938_p N_noxref_62_M45_noxref_s ) capacitor \
 c=2.98576e-19 //x=76.71 //y=0.805 //x2=73.095 //y2=0.555
cc_9186 ( N_noxref_41_M46_noxref_d N_noxref_62_M45_noxref_s ) capacitor \
 c=0.0187685f //x=74.5 //y=1.09 //x2=73.095 //y2=0.555
cc_9187 ( N_noxref_41_M47_noxref_s N_noxref_62_M45_noxref_s ) capacitor \
 c=0.0210819f //x=75.605 //y=0.555 //x2=73.095 //y2=0.555
cc_9188 ( N_noxref_41_c_15938_p N_noxref_63_M48_noxref_s ) capacitor \
 c=0.00368328f //x=76.71 //y=0.805 //x2=77.905 //y2=0.555
cc_9189 ( N_noxref_41_M47_noxref_s N_noxref_63_M48_noxref_s ) capacitor \
 c=0.00125282f //x=75.605 //y=0.555 //x2=77.905 //y2=0.555
cc_9190 ( N_noxref_42_c_15961_n N_GND_c_17141_n ) capacitor c=0.00533679f \
 //x=80.465 //y=1.175 //x2=83.25 //y2=0.175
cc_9191 ( N_noxref_42_c_16004_p N_GND_c_17141_n ) capacitor c=0.0064302f \
 //x=80.55 //y=0.805 //x2=83.25 //y2=0.175
cc_9192 ( N_noxref_42_c_15978_n N_GND_c_17141_n ) capacitor c=0.0094846f \
 //x=81.435 //y=0.72 //x2=83.25 //y2=0.175
cc_9193 ( N_noxref_42_c_16006_p N_GND_c_17141_n ) capacitor c=0.00232964f \
 //x=81.52 //y=0.805 //x2=83.25 //y2=0.175
cc_9194 ( N_noxref_42_M49_noxref_d N_GND_c_17141_n ) capacitor c=0.0130924f \
 //x=79.31 //y=1.09 //x2=83.25 //y2=0.175
cc_9195 ( N_noxref_42_M49_noxref_d N_GND_c_17074_n ) capacitor c=0.0154456f \
 //x=79.31 //y=1.09 //x2=78.525 //y2=1.145
cc_9196 ( N_noxref_42_c_15961_n N_GND_c_17087_n ) capacitor c=0.0080792f \
 //x=80.465 //y=1.175 //x2=82.09 //y2=0.175
cc_9197 ( N_noxref_42_c_16004_p N_GND_c_17087_n ) capacitor c=0.0140625f \
 //x=80.55 //y=0.805 //x2=82.09 //y2=0.175
cc_9198 ( N_noxref_42_c_15978_n N_GND_c_17087_n ) capacitor c=0.0364663f \
 //x=81.435 //y=0.72 //x2=82.09 //y2=0.175
cc_9199 ( N_noxref_42_c_16006_p N_GND_c_17087_n ) capacitor c=0.013886f \
 //x=81.52 //y=0.805 //x2=82.09 //y2=0.175
cc_9200 ( N_noxref_42_M50_noxref_s N_GND_c_17093_n ) capacitor c=8.16352e-19 \
 //x=80.415 //y=0.555 //x2=77.45 //y2=0.175
cc_9201 ( N_noxref_42_c_16006_p N_GND_c_17214_n ) capacitor c=0.037873f \
 //x=81.52 //y=0.805 //x2=82.26 //y2=0.175
cc_9202 ( N_noxref_42_M50_noxref_s N_GND_c_17214_n ) capacitor c=0.0051897f \
 //x=80.415 //y=0.555 //x2=82.26 //y2=0.175
cc_9203 ( N_noxref_42_M49_noxref_d N_GND_M48_noxref_d ) capacitor \
 c=3.12752e-19 //x=79.31 //y=1.09 //x2=78.335 //y2=1.055
cc_9204 ( N_noxref_42_c_16004_p N_noxref_63_c_19087_n ) capacitor \
 c=2.15937e-19 //x=80.55 //y=0.805 //x2=79.01 //y2=0.805
cc_9205 ( N_noxref_42_c_15961_n N_noxref_63_c_19072_n ) capacitor c=0.0131053f \
 //x=80.465 //y=1.175 //x2=79.895 //y2=0.72
cc_9206 ( N_noxref_42_M49_noxref_d N_noxref_63_c_19072_n ) capacitor \
 c=0.0160925f //x=79.31 //y=1.09 //x2=79.895 //y2=0.72
cc_9207 ( N_noxref_42_c_15961_n N_noxref_63_c_19074_n ) capacitor \
 c=0.00945545f //x=80.465 //y=1.175 //x2=79.895 //y2=1.77
cc_9208 ( N_noxref_42_M49_noxref_d N_noxref_63_c_19074_n ) capacitor \
 c=0.0151017f //x=79.31 //y=1.09 //x2=79.895 //y2=1.77
cc_9209 ( N_noxref_42_c_15961_n N_noxref_63_M48_noxref_s ) capacitor \
 c=0.0226963f //x=80.465 //y=1.175 //x2=77.905 //y2=0.555
cc_9210 ( N_noxref_42_c_16004_p N_noxref_63_M48_noxref_s ) capacitor \
 c=0.0175461f //x=80.55 //y=0.805 //x2=77.905 //y2=0.555
cc_9211 ( N_noxref_42_c_16006_p N_noxref_63_M48_noxref_s ) capacitor \
 c=2.98576e-19 //x=81.52 //y=0.805 //x2=77.905 //y2=0.555
cc_9212 ( N_noxref_42_M49_noxref_d N_noxref_63_M48_noxref_s ) capacitor \
 c=0.0187685f //x=79.31 //y=1.09 //x2=77.905 //y2=0.555
cc_9213 ( N_noxref_42_M50_noxref_s N_noxref_63_M48_noxref_s ) capacitor \
 c=0.0210819f //x=80.415 //y=0.555 //x2=77.905 //y2=0.555
cc_9214 ( N_noxref_42_c_16006_p N_noxref_64_M51_noxref_s ) capacitor \
 c=0.00368328f //x=81.52 //y=0.805 //x2=82.715 //y2=0.555
cc_9215 ( N_noxref_42_M50_noxref_s N_noxref_64_M51_noxref_s ) capacitor \
 c=0.00125282f //x=80.415 //y=0.555 //x2=82.715 //y2=0.555
cc_9216 ( N_noxref_43_c_16030_n N_GND_c_16607_n ) capacitor c=0.00533679f \
 //x=85.275 //y=1.175 //x2=88.165 //y2=0.175
cc_9217 ( N_noxref_43_c_16073_p N_GND_c_16607_n ) capacitor c=0.00338834f \
 //x=85.36 //y=0.805 //x2=88.165 //y2=0.175
cc_9218 ( N_noxref_43_c_16046_n N_GND_c_16607_n ) capacitor c=0.00960852f \
 //x=86.245 //y=0.72 //x2=88.165 //y2=0.175
cc_9219 ( N_noxref_43_c_16075_p N_GND_c_16607_n ) capacitor c=0.00232964f \
 //x=86.33 //y=0.805 //x2=88.165 //y2=0.175
cc_9220 ( N_noxref_43_M52_noxref_d N_GND_c_16607_n ) capacitor c=0.0131076f \
 //x=84.12 //y=1.09 //x2=88.165 //y2=0.175
cc_9221 ( N_noxref_43_M52_noxref_d N_GND_c_17200_n ) capacitor c=0.0154456f \
 //x=84.12 //y=1.09 //x2=83.335 //y2=1.145
cc_9222 ( N_noxref_43_c_16030_n N_GND_c_17213_n ) capacitor c=0.0091517f \
 //x=85.275 //y=1.175 //x2=86.9 //y2=0.175
cc_9223 ( N_noxref_43_c_16073_p N_GND_c_17213_n ) capacitor c=0.0141638f \
 //x=85.36 //y=0.805 //x2=86.9 //y2=0.175
cc_9224 ( N_noxref_43_c_16046_n N_GND_c_17213_n ) capacitor c=0.0364778f \
 //x=86.245 //y=0.72 //x2=86.9 //y2=0.175
cc_9225 ( N_noxref_43_c_16075_p N_GND_c_17213_n ) capacitor c=0.013886f \
 //x=86.33 //y=0.805 //x2=86.9 //y2=0.175
cc_9226 ( N_noxref_43_M53_noxref_s N_GND_c_17214_n ) capacitor c=8.16352e-19 \
 //x=85.225 //y=0.555 //x2=82.26 //y2=0.175
cc_9227 ( N_noxref_43_c_16075_p N_GND_c_16635_n ) capacitor c=0.0374609f \
 //x=86.33 //y=0.805 //x2=87.07 //y2=0.175
cc_9228 ( N_noxref_43_M53_noxref_s N_GND_c_16635_n ) capacitor c=0.00519577f \
 //x=85.225 //y=0.555 //x2=87.07 //y2=0.175
cc_9229 ( N_noxref_43_M52_noxref_d N_GND_M51_noxref_d ) capacitor \
 c=3.12752e-19 //x=84.12 //y=1.09 //x2=83.145 //y2=1.055
cc_9230 ( N_noxref_43_c_16073_p N_noxref_64_c_19146_n ) capacitor \
 c=2.15937e-19 //x=85.36 //y=0.805 //x2=83.82 //y2=0.805
cc_9231 ( N_noxref_43_c_16030_n N_noxref_64_c_19128_n ) capacitor c=0.0130857f \
 //x=85.275 //y=1.175 //x2=84.705 //y2=0.72
cc_9232 ( N_noxref_43_M52_noxref_d N_noxref_64_c_19128_n ) capacitor \
 c=0.0160925f //x=84.12 //y=1.09 //x2=84.705 //y2=0.72
cc_9233 ( N_noxref_43_c_16030_n N_noxref_64_c_19130_n ) capacitor \
 c=0.00944538f //x=85.275 //y=1.175 //x2=84.705 //y2=1.77
cc_9234 ( N_noxref_43_M52_noxref_d N_noxref_64_c_19130_n ) capacitor \
 c=0.0148972f //x=84.12 //y=1.09 //x2=84.705 //y2=1.77
cc_9235 ( N_noxref_43_c_16030_n N_noxref_64_M51_noxref_s ) capacitor \
 c=0.0223986f //x=85.275 //y=1.175 //x2=82.715 //y2=0.555
cc_9236 ( N_noxref_43_c_16073_p N_noxref_64_M51_noxref_s ) capacitor \
 c=0.0175532f //x=85.36 //y=0.805 //x2=82.715 //y2=0.555
cc_9237 ( N_noxref_43_c_16075_p N_noxref_64_M51_noxref_s ) capacitor \
 c=2.98721e-19 //x=86.33 //y=0.805 //x2=82.715 //y2=0.555
cc_9238 ( N_noxref_43_M52_noxref_d N_noxref_64_M51_noxref_s ) capacitor \
 c=0.0187685f //x=84.12 //y=1.09 //x2=82.715 //y2=0.555
cc_9239 ( N_noxref_43_M53_noxref_s N_noxref_64_M51_noxref_s ) capacitor \
 c=0.021082f //x=85.225 //y=0.555 //x2=82.715 //y2=0.555
cc_9240 ( N_noxref_43_c_16075_p N_noxref_65_M54_noxref_s ) capacitor \
 c=0.00369575f //x=86.33 //y=0.805 //x2=87.63 //y2=0.545
cc_9241 ( N_noxref_43_M53_noxref_s N_noxref_65_M54_noxref_s ) capacitor \
 c=0.00101401f //x=85.225 //y=0.555 //x2=87.63 //y2=0.545
cc_9242 ( N_noxref_44_c_16104_n N_noxref_45_c_16258_n ) capacitor \
 c=0.00321697f //x=91.94 //y=7.09 //x2=92.385 //y2=5.39
cc_9243 ( N_noxref_44_c_16127_n N_noxref_45_c_16258_n ) capacitor \
 c=0.00331901f //x=92.825 //y=7.09 //x2=92.385 //y2=5.39
cc_9244 ( N_noxref_44_c_16115_n N_noxref_45_c_16258_n ) capacitor c=0.0047685f \
 //x=92.057 //y=7.09 //x2=92.385 //y2=5.39
cc_9245 ( N_noxref_44_M174_noxref_d N_noxref_45_c_16258_n ) capacitor \
 c=0.00678641f //x=91.915 //y=5.205 //x2=92.385 //y2=5.39
cc_9246 ( N_noxref_44_c_16127_n N_noxref_45_c_16271_n ) capacitor \
 c=0.00331901f //x=92.825 //y=7.09 //x2=94.405 //y2=5.39
cc_9247 ( N_noxref_44_c_16132_n N_noxref_45_c_16271_n ) capacitor \
 c=0.00466077f //x=92.94 //y=6.92 //x2=94.405 //y2=5.39
cc_9248 ( N_noxref_44_M176_noxref_d N_noxref_45_c_16271_n ) capacitor \
 c=0.00491419f //x=92.795 //y=5.205 //x2=94.405 //y2=5.39
cc_9249 ( N_noxref_44_c_16100_n N_noxref_45_c_16281_n ) capacitor c=9.81e-19 \
 //x=91.065 //y=5.39 //x2=92.615 //y2=5.39
cc_9250 ( N_noxref_44_c_16127_n N_noxref_45_c_16281_n ) capacitor \
 c=0.00460276f //x=92.825 //y=7.09 //x2=92.615 //y2=5.39
cc_9251 ( N_noxref_44_c_16100_n N_noxref_45_c_16259_n ) capacitor c=0.033638f \
 //x=91.065 //y=5.39 //x2=91.62 //y2=5.39
cc_9252 ( N_noxref_44_c_16104_n N_noxref_45_c_16259_n ) capacitor c=0.0048075f \
 //x=91.94 //y=7.09 //x2=91.62 //y2=5.39
cc_9253 ( N_noxref_44_c_16110_n N_noxref_45_c_16259_n ) capacitor \
 c=0.00241473f //x=88.302 //y=5.39 //x2=91.62 //y2=5.39
cc_9254 ( N_noxref_44_c_16120_n N_noxref_45_c_16259_n ) capacitor c=0.0100239f \
 //x=91.18 //y=5.39 //x2=91.62 //y2=5.39
cc_9255 ( N_noxref_44_c_16115_n N_noxref_45_c_16285_n ) capacitor \
 c=2.01993e-19 //x=92.057 //y=7.09 //x2=94.52 //y2=6.92
cc_9256 ( N_noxref_44_c_16132_n N_noxref_45_c_16285_n ) capacitor c=0.0130503f \
 //x=92.94 //y=6.92 //x2=94.52 //y2=6.92
cc_9257 ( N_noxref_44_c_16132_n N_noxref_45_c_16286_n ) capacitor \
 c=2.01769e-19 //x=92.94 //y=6.92 //x2=95.4 //y2=7.09
cc_9258 ( N_noxref_44_c_16100_n N_noxref_45_c_16265_n ) capacitor \
 c=0.00238961f //x=91.065 //y=5.39 //x2=91.62 //y2=5.56
cc_9259 ( N_noxref_44_c_16104_n N_noxref_45_c_16265_n ) capacitor \
 c=0.00406191f //x=91.94 //y=7.09 //x2=91.62 //y2=5.56
cc_9260 ( N_noxref_44_c_16120_n N_noxref_45_c_16265_n ) capacitor c=0.0651197f \
 //x=91.18 //y=5.39 //x2=91.62 //y2=5.56
cc_9261 ( N_noxref_44_M174_noxref_d N_noxref_45_c_16265_n ) capacitor \
 c=0.0479141f //x=91.915 //y=5.205 //x2=91.62 //y2=5.56
cc_9262 ( N_noxref_44_c_16100_n N_noxref_45_c_16287_n ) capacitor \
 c=5.61108e-19 //x=91.065 //y=5.39 //x2=92.5 //y2=5.39
cc_9263 ( N_noxref_44_c_16127_n N_noxref_45_c_16287_n ) capacitor \
 c=0.00424767f //x=92.825 //y=7.09 //x2=92.5 //y2=5.39
cc_9264 ( N_noxref_44_c_16120_n N_noxref_45_c_16287_n ) capacitor \
 c=0.00287683f //x=91.18 //y=5.39 //x2=92.5 //y2=5.39
cc_9265 ( N_noxref_44_M174_noxref_d N_noxref_45_c_16287_n ) capacitor \
 c=0.0479141f //x=91.915 //y=5.205 //x2=92.5 //y2=5.39
cc_9266 ( N_noxref_44_M176_noxref_d N_noxref_45_c_16287_n ) capacitor \
 c=0.0479025f //x=92.795 //y=5.205 //x2=92.5 //y2=5.39
cc_9267 ( N_noxref_44_M176_noxref_d N_noxref_45_c_16290_n ) capacitor \
 c=0.00143256f //x=92.795 //y=5.205 //x2=94.52 //y2=5.39
cc_9268 ( N_noxref_44_c_16110_n N_GND_c_16608_n ) capacitor c=0.00111773f \
 //x=88.302 //y=5.39 //x2=88.25 //y2=1.015
cc_9269 ( N_noxref_44_c_16100_n N_GND_c_16641_n ) capacitor c=0.00146427f \
 //x=91.065 //y=5.39 //x2=90.4 //y2=0.175
cc_9270 ( N_noxref_44_c_16120_n N_noxref_66_c_19242_n ) capacitor \
 c=0.00108317f //x=91.18 //y=5.39 //x2=91.095 //y2=1.675
cc_9271 ( N_noxref_45_c_16259_n N_GND_c_16615_n ) capacitor c=3.7374e-19 \
 //x=91.62 //y=5.39 //x2=91.58 //y2=1.015
cc_9272 ( N_noxref_45_c_16271_n N_GND_c_17321_n ) capacitor c=0.00146427f \
 //x=94.405 //y=5.39 //x2=93.73 //y2=0.175
cc_9273 ( N_GND_c_16870_n N_noxref_47_c_18136_n ) capacitor c=0.00274444f \
 //x=1.48 //y=0.175 //x2=1.965 //y2=1.77
cc_9274 ( N_GND_c_16390_n N_noxref_47_c_18136_n ) capacitor c=7.69197e-19 \
 //x=6.29 //y=0.175 //x2=1.965 //y2=1.77
cc_9275 ( N_GND_c_16880_n N_noxref_47_c_18136_n ) capacitor c=0.00375695f \
 //x=1.565 //y=1.145 //x2=1.965 //y2=1.77
cc_9276 ( N_GND_c_16421_n N_noxref_47_c_18136_n ) capacitor c=0.00371813f \
 //x=5.13 //y=0.175 //x2=1.965 //y2=1.77
cc_9277 ( N_GND_M0_noxref_d N_noxref_47_c_18136_n ) capacitor c=0.00578031f \
 //x=1.375 //y=1.055 //x2=1.965 //y2=1.77
cc_9278 ( N_GND_c_16871_n N_noxref_47_c_18161_n ) capacitor c=0.0169052f \
 //x=1.565 //y=1.015 //x2=2.05 //y2=0.805
cc_9279 ( N_GND_c_16390_n N_noxref_47_c_18161_n ) capacitor c=0.00710913f \
 //x=6.29 //y=0.175 //x2=2.05 //y2=0.805
cc_9280 ( N_GND_c_16421_n N_noxref_47_c_18161_n ) capacitor c=0.0140604f \
 //x=5.13 //y=0.175 //x2=2.05 //y2=0.805
cc_9281 ( N_GND_c_16911_n N_noxref_47_c_18161_n ) capacitor c=0.00323118f \
 //x=1.23 //y=0.18 //x2=2.05 //y2=0.805
cc_9282 ( N_GND_c_16390_n N_noxref_47_c_18150_n ) capacitor c=0.0130211f \
 //x=6.29 //y=0.175 //x2=2.935 //y2=0.72
cc_9283 ( N_GND_c_16421_n N_noxref_47_c_18150_n ) capacitor c=0.0358801f \
 //x=5.13 //y=0.175 //x2=2.935 //y2=0.72
cc_9284 ( N_GND_c_16870_n N_noxref_47_M0_noxref_s ) capacitor c=0.00710913f \
 //x=1.48 //y=0.175 //x2=0.945 //y2=0.555
cc_9285 ( N_GND_c_16871_n N_noxref_47_M0_noxref_s ) capacitor c=0.0173062f \
 //x=1.565 //y=1.015 //x2=0.945 //y2=0.555
cc_9286 ( N_GND_c_16390_n N_noxref_47_M0_noxref_s ) capacitor c=0.0044479f \
 //x=6.29 //y=0.175 //x2=0.945 //y2=0.555
cc_9287 ( N_GND_c_16880_n N_noxref_47_M0_noxref_s ) capacitor c=0.0113024f \
 //x=1.565 //y=1.145 //x2=0.945 //y2=0.555
cc_9288 ( N_GND_c_16421_n N_noxref_47_M0_noxref_s ) capacitor c=0.0272659f \
 //x=5.13 //y=0.175 //x2=0.945 //y2=0.555
cc_9289 ( N_GND_c_16911_n N_noxref_47_M0_noxref_s ) capacitor c=0.0675506f \
 //x=1.23 //y=0.18 //x2=0.945 //y2=0.555
cc_9290 ( N_GND_c_16425_n N_noxref_47_M0_noxref_s ) capacitor c=0.00166413f \
 //x=5.3 //y=0.175 //x2=0.945 //y2=0.555
cc_9291 ( N_GND_M0_noxref_d N_noxref_47_M0_noxref_s ) capacitor c=0.0271316f \
 //x=1.375 //y=1.055 //x2=0.945 //y2=0.555
cc_9292 ( N_GND_c_16390_n N_noxref_48_c_18191_n ) capacitor c=0.0011329f \
 //x=6.29 //y=0.175 //x2=6.775 //y2=1.77
cc_9293 ( N_GND_c_16501_n N_noxref_48_c_18191_n ) capacitor c=6.52594e-19 \
 //x=11.1 //y=0.175 //x2=6.775 //y2=1.77
cc_9294 ( N_GND_c_16400_n N_noxref_48_c_18191_n ) capacitor c=0.0035977f \
 //x=6.375 //y=1.145 //x2=6.775 //y2=1.77
cc_9295 ( N_GND_c_16423_n N_noxref_48_c_18191_n ) capacitor c=0.00392232f \
 //x=9.94 //y=0.175 //x2=6.775 //y2=1.77
cc_9296 ( N_GND_M3_noxref_d N_noxref_48_c_18191_n ) capacitor c=0.00578031f \
 //x=6.185 //y=1.055 //x2=6.775 //y2=1.77
cc_9297 ( N_GND_c_16394_n N_noxref_48_c_18218_n ) capacitor c=0.0169052f \
 //x=6.375 //y=1.015 //x2=6.86 //y2=0.805
cc_9298 ( N_GND_c_16501_n N_noxref_48_c_18218_n ) capacitor c=0.00439789f \
 //x=11.1 //y=0.175 //x2=6.86 //y2=0.805
cc_9299 ( N_GND_c_16423_n N_noxref_48_c_18218_n ) capacitor c=0.0141638f \
 //x=9.94 //y=0.175 //x2=6.86 //y2=0.805
cc_9300 ( N_GND_c_16425_n N_noxref_48_c_18218_n ) capacitor c=0.00322478f \
 //x=5.3 //y=0.175 //x2=6.86 //y2=0.805
cc_9301 ( N_GND_c_16501_n N_noxref_48_c_18202_n ) capacitor c=0.0124416f \
 //x=11.1 //y=0.175 //x2=7.745 //y2=0.72
cc_9302 ( N_GND_c_16423_n N_noxref_48_c_18202_n ) capacitor c=0.0361346f \
 //x=9.94 //y=0.175 //x2=7.745 //y2=0.72
cc_9303 ( N_GND_c_16390_n N_noxref_48_M3_noxref_s ) capacitor c=0.00439789f \
 //x=6.29 //y=0.175 //x2=5.755 //y2=0.555
cc_9304 ( N_GND_c_16394_n N_noxref_48_M3_noxref_s ) capacitor c=0.0173062f \
 //x=6.375 //y=1.015 //x2=5.755 //y2=0.555
cc_9305 ( N_GND_c_16501_n N_noxref_48_M3_noxref_s ) capacitor c=0.0044479f \
 //x=11.1 //y=0.175 //x2=5.755 //y2=0.555
cc_9306 ( N_GND_c_16400_n N_noxref_48_M3_noxref_s ) capacitor c=0.00988958f \
 //x=6.375 //y=1.145 //x2=5.755 //y2=0.555
cc_9307 ( N_GND_c_16423_n N_noxref_48_M3_noxref_s ) capacitor c=0.0273693f \
 //x=9.94 //y=0.175 //x2=5.755 //y2=0.555
cc_9308 ( N_GND_c_16425_n N_noxref_48_M3_noxref_s ) capacitor c=0.0634633f \
 //x=5.3 //y=0.175 //x2=5.755 //y2=0.555
cc_9309 ( N_GND_c_16438_n N_noxref_48_M3_noxref_s ) capacitor c=0.00166413f \
 //x=10.11 //y=0.175 //x2=5.755 //y2=0.555
cc_9310 ( N_GND_M3_noxref_d N_noxref_48_M3_noxref_s ) capacitor c=0.0271316f \
 //x=6.185 //y=1.055 //x2=5.755 //y2=0.555
cc_9311 ( N_GND_c_16501_n N_noxref_49_c_18248_n ) capacitor c=0.0011329f \
 //x=11.1 //y=0.175 //x2=11.585 //y2=1.77
cc_9312 ( N_GND_c_16460_n N_noxref_49_c_18248_n ) capacitor c=7.40908e-19 \
 //x=15.91 //y=0.175 //x2=11.585 //y2=1.77
cc_9313 ( N_GND_c_16411_n N_noxref_49_c_18248_n ) capacitor c=0.00350793f \
 //x=11.185 //y=1.145 //x2=11.585 //y2=1.77
cc_9314 ( N_GND_c_16424_n N_noxref_49_c_18248_n ) capacitor c=0.00392232f \
 //x=14.75 //y=0.175 //x2=11.585 //y2=1.77
cc_9315 ( N_GND_M6_noxref_d N_noxref_49_c_18248_n ) capacitor c=0.00578031f \
 //x=10.995 //y=1.055 //x2=11.585 //y2=1.77
cc_9316 ( N_GND_c_16397_n N_noxref_49_c_18276_n ) capacitor c=0.0169052f \
 //x=11.185 //y=1.015 //x2=11.67 //y2=0.805
cc_9317 ( N_GND_c_16460_n N_noxref_49_c_18276_n ) capacitor c=0.00439789f \
 //x=15.91 //y=0.175 //x2=11.67 //y2=0.805
cc_9318 ( N_GND_c_16424_n N_noxref_49_c_18276_n ) capacitor c=0.0141638f \
 //x=14.75 //y=0.175 //x2=11.67 //y2=0.805
cc_9319 ( N_GND_c_16438_n N_noxref_49_c_18276_n ) capacitor c=0.00322478f \
 //x=10.11 //y=0.175 //x2=11.67 //y2=0.805
cc_9320 ( N_GND_c_16460_n N_noxref_49_c_18263_n ) capacitor c=0.0118039f \
 //x=15.91 //y=0.175 //x2=12.555 //y2=0.72
cc_9321 ( N_GND_c_16424_n N_noxref_49_c_18263_n ) capacitor c=0.0361346f \
 //x=14.75 //y=0.175 //x2=12.555 //y2=0.72
cc_9322 ( N_GND_c_16501_n N_noxref_49_M6_noxref_s ) capacitor c=0.00439789f \
 //x=11.1 //y=0.175 //x2=10.565 //y2=0.555
cc_9323 ( N_GND_c_16397_n N_noxref_49_M6_noxref_s ) capacitor c=0.0173062f \
 //x=11.185 //y=1.015 //x2=10.565 //y2=0.555
cc_9324 ( N_GND_c_16460_n N_noxref_49_M6_noxref_s ) capacitor c=0.00405325f \
 //x=15.91 //y=0.175 //x2=10.565 //y2=0.555
cc_9325 ( N_GND_c_16411_n N_noxref_49_M6_noxref_s ) capacitor c=0.00988958f \
 //x=11.185 //y=1.145 //x2=10.565 //y2=0.555
cc_9326 ( N_GND_c_16424_n N_noxref_49_M6_noxref_s ) capacitor c=0.0273693f \
 //x=14.75 //y=0.175 //x2=10.565 //y2=0.555
cc_9327 ( N_GND_c_16438_n N_noxref_49_M6_noxref_s ) capacitor c=0.0634633f \
 //x=10.11 //y=0.175 //x2=10.565 //y2=0.555
cc_9328 ( N_GND_c_16481_n N_noxref_49_M6_noxref_s ) capacitor c=0.00166413f \
 //x=14.92 //y=0.175 //x2=10.565 //y2=0.555
cc_9329 ( N_GND_M6_noxref_d N_noxref_49_M6_noxref_s ) capacitor c=0.0271316f \
 //x=10.995 //y=1.055 //x2=10.565 //y2=0.555
cc_9330 ( N_GND_c_16460_n N_noxref_50_c_18306_n ) capacitor c=0.0011329f \
 //x=15.91 //y=0.175 //x2=16.395 //y2=1.77
cc_9331 ( N_GND_c_16584_n N_noxref_50_c_18306_n ) capacitor c=7.40908e-19 \
 //x=20.72 //y=0.175 //x2=16.395 //y2=1.77
cc_9332 ( N_GND_c_16467_n N_noxref_50_c_18306_n ) capacitor c=0.00350855f \
 //x=15.995 //y=1.145 //x2=16.395 //y2=1.77
cc_9333 ( N_GND_c_16480_n N_noxref_50_c_18306_n ) capacitor c=0.00392231f \
 //x=19.56 //y=0.175 //x2=16.395 //y2=1.77
cc_9334 ( N_GND_M9_noxref_d N_noxref_50_c_18306_n ) capacitor c=0.00578031f \
 //x=15.805 //y=1.055 //x2=16.395 //y2=1.77
cc_9335 ( N_GND_c_16464_n N_noxref_50_c_18335_n ) capacitor c=0.0169052f \
 //x=15.995 //y=1.015 //x2=16.48 //y2=0.805
cc_9336 ( N_GND_c_16584_n N_noxref_50_c_18335_n ) capacitor c=0.00439789f \
 //x=20.72 //y=0.175 //x2=16.48 //y2=0.805
cc_9337 ( N_GND_c_16480_n N_noxref_50_c_18335_n ) capacitor c=0.0141638f \
 //x=19.56 //y=0.175 //x2=16.48 //y2=0.805
cc_9338 ( N_GND_c_16481_n N_noxref_50_c_18335_n ) capacitor c=0.00322478f \
 //x=14.92 //y=0.175 //x2=16.48 //y2=0.805
cc_9339 ( N_GND_c_16584_n N_noxref_50_c_18317_n ) capacitor c=0.0123805f \
 //x=20.72 //y=0.175 //x2=17.365 //y2=0.72
cc_9340 ( N_GND_c_16480_n N_noxref_50_c_18317_n ) capacitor c=0.0361346f \
 //x=19.56 //y=0.175 //x2=17.365 //y2=0.72
cc_9341 ( N_GND_c_16460_n N_noxref_50_M9_noxref_s ) capacitor c=0.00439789f \
 //x=15.91 //y=0.175 //x2=15.375 //y2=0.555
cc_9342 ( N_GND_c_16464_n N_noxref_50_M9_noxref_s ) capacitor c=0.0173062f \
 //x=15.995 //y=1.015 //x2=15.375 //y2=0.555
cc_9343 ( N_GND_c_16584_n N_noxref_50_M9_noxref_s ) capacitor c=0.0044479f \
 //x=20.72 //y=0.175 //x2=15.375 //y2=0.555
cc_9344 ( N_GND_c_16467_n N_noxref_50_M9_noxref_s ) capacitor c=0.00988958f \
 //x=15.995 //y=1.145 //x2=15.375 //y2=0.555
cc_9345 ( N_GND_c_16480_n N_noxref_50_M9_noxref_s ) capacitor c=0.0273693f \
 //x=19.56 //y=0.175 //x2=15.375 //y2=0.555
cc_9346 ( N_GND_c_16481_n N_noxref_50_M9_noxref_s ) capacitor c=0.0634633f \
 //x=14.92 //y=0.175 //x2=15.375 //y2=0.555
cc_9347 ( N_GND_c_16530_n N_noxref_50_M9_noxref_s ) capacitor c=0.00166413f \
 //x=19.73 //y=0.175 //x2=15.375 //y2=0.555
cc_9348 ( N_GND_M9_noxref_d N_noxref_50_M9_noxref_s ) capacitor c=0.0271316f \
 //x=15.805 //y=1.055 //x2=15.375 //y2=0.555
cc_9349 ( N_GND_c_16584_n N_noxref_51_c_18365_n ) capacitor c=0.0011329f \
 //x=20.72 //y=0.175 //x2=21.205 //y2=1.77
cc_9350 ( N_GND_c_16542_n N_noxref_51_c_18365_n ) capacitor c=7.40908e-19 \
 //x=25.53 //y=0.175 //x2=21.205 //y2=1.77
cc_9351 ( N_GND_c_16509_n N_noxref_51_c_18365_n ) capacitor c=0.0036557f \
 //x=20.805 //y=1.145 //x2=21.205 //y2=1.77
cc_9352 ( N_GND_c_16522_n N_noxref_51_c_18365_n ) capacitor c=0.00392232f \
 //x=24.37 //y=0.175 //x2=21.205 //y2=1.77
cc_9353 ( N_GND_M12_noxref_d N_noxref_51_c_18365_n ) capacitor c=0.00578031f \
 //x=20.615 //y=1.055 //x2=21.205 //y2=1.77
cc_9354 ( N_GND_c_16505_n N_noxref_51_c_18393_n ) capacitor c=0.0169052f \
 //x=20.805 //y=1.015 //x2=21.29 //y2=0.805
cc_9355 ( N_GND_c_16542_n N_noxref_51_c_18393_n ) capacitor c=0.00439789f \
 //x=25.53 //y=0.175 //x2=21.29 //y2=0.805
cc_9356 ( N_GND_c_16522_n N_noxref_51_c_18393_n ) capacitor c=0.0141638f \
 //x=24.37 //y=0.175 //x2=21.29 //y2=0.805
cc_9357 ( N_GND_c_16530_n N_noxref_51_c_18393_n ) capacitor c=0.00322478f \
 //x=19.73 //y=0.175 //x2=21.29 //y2=0.805
cc_9358 ( N_GND_c_16542_n N_noxref_51_c_18378_n ) capacitor c=0.0123293f \
 //x=25.53 //y=0.175 //x2=22.175 //y2=0.72
cc_9359 ( N_GND_c_16522_n N_noxref_51_c_18378_n ) capacitor c=0.0361346f \
 //x=24.37 //y=0.175 //x2=22.175 //y2=0.72
cc_9360 ( N_GND_c_16584_n N_noxref_51_M12_noxref_s ) capacitor c=0.00439789f \
 //x=20.72 //y=0.175 //x2=20.185 //y2=0.555
cc_9361 ( N_GND_c_16505_n N_noxref_51_M12_noxref_s ) capacitor c=0.0173062f \
 //x=20.805 //y=1.015 //x2=20.185 //y2=0.555
cc_9362 ( N_GND_c_16542_n N_noxref_51_M12_noxref_s ) capacitor c=0.0044479f \
 //x=25.53 //y=0.175 //x2=20.185 //y2=0.555
cc_9363 ( N_GND_c_16509_n N_noxref_51_M12_noxref_s ) capacitor c=0.00988958f \
 //x=20.805 //y=1.145 //x2=20.185 //y2=0.555
cc_9364 ( N_GND_c_16522_n N_noxref_51_M12_noxref_s ) capacitor c=0.0273693f \
 //x=24.37 //y=0.175 //x2=20.185 //y2=0.555
cc_9365 ( N_GND_c_16530_n N_noxref_51_M12_noxref_s ) capacitor c=0.0634633f \
 //x=19.73 //y=0.175 //x2=20.185 //y2=0.555
cc_9366 ( N_GND_c_16563_n N_noxref_51_M12_noxref_s ) capacitor c=0.00166413f \
 //x=24.54 //y=0.175 //x2=20.185 //y2=0.555
cc_9367 ( N_GND_M12_noxref_d N_noxref_51_M12_noxref_s ) capacitor c=0.0271316f \
 //x=20.615 //y=1.055 //x2=20.185 //y2=0.555
cc_9368 ( N_GND_c_16542_n N_noxref_52_c_18423_n ) capacitor c=0.0011329f \
 //x=25.53 //y=0.175 //x2=26.015 //y2=1.77
cc_9369 ( N_GND_c_16588_n N_noxref_52_c_18423_n ) capacitor c=7.40908e-19 \
 //x=30.34 //y=0.175 //x2=26.015 //y2=1.77
cc_9370 ( N_GND_c_16549_n N_noxref_52_c_18423_n ) capacitor c=0.00350109f \
 //x=25.615 //y=1.145 //x2=26.015 //y2=1.77
cc_9371 ( N_GND_c_16562_n N_noxref_52_c_18423_n ) capacitor c=0.00392232f \
 //x=29.18 //y=0.175 //x2=26.015 //y2=1.77
cc_9372 ( N_GND_M15_noxref_d N_noxref_52_c_18423_n ) capacitor c=0.00578031f \
 //x=25.425 //y=1.055 //x2=26.015 //y2=1.77
cc_9373 ( N_GND_c_16546_n N_noxref_52_c_18452_n ) capacitor c=0.0169052f \
 //x=25.615 //y=1.015 //x2=26.1 //y2=0.805
cc_9374 ( N_GND_c_16588_n N_noxref_52_c_18452_n ) capacitor c=0.00439789f \
 //x=30.34 //y=0.175 //x2=26.1 //y2=0.805
cc_9375 ( N_GND_c_16562_n N_noxref_52_c_18452_n ) capacitor c=0.0141638f \
 //x=29.18 //y=0.175 //x2=26.1 //y2=0.805
cc_9376 ( N_GND_c_16563_n N_noxref_52_c_18452_n ) capacitor c=0.00322478f \
 //x=24.54 //y=0.175 //x2=26.1 //y2=0.805
cc_9377 ( N_GND_c_16588_n N_noxref_52_c_18440_n ) capacitor c=0.0123291f \
 //x=30.34 //y=0.175 //x2=26.985 //y2=0.72
cc_9378 ( N_GND_c_16562_n N_noxref_52_c_18440_n ) capacitor c=0.0361346f \
 //x=29.18 //y=0.175 //x2=26.985 //y2=0.72
cc_9379 ( N_GND_c_16542_n N_noxref_52_M15_noxref_s ) capacitor c=0.00439789f \
 //x=25.53 //y=0.175 //x2=24.995 //y2=0.555
cc_9380 ( N_GND_c_16546_n N_noxref_52_M15_noxref_s ) capacitor c=0.0173062f \
 //x=25.615 //y=1.015 //x2=24.995 //y2=0.555
cc_9381 ( N_GND_c_16588_n N_noxref_52_M15_noxref_s ) capacitor c=0.0044479f \
 //x=30.34 //y=0.175 //x2=24.995 //y2=0.555
cc_9382 ( N_GND_c_16549_n N_noxref_52_M15_noxref_s ) capacitor c=0.00988958f \
 //x=25.615 //y=1.145 //x2=24.995 //y2=0.555
cc_9383 ( N_GND_c_16562_n N_noxref_52_M15_noxref_s ) capacitor c=0.0273693f \
 //x=29.18 //y=0.175 //x2=24.995 //y2=0.555
cc_9384 ( N_GND_c_16563_n N_noxref_52_M15_noxref_s ) capacitor c=0.0634633f \
 //x=24.54 //y=0.175 //x2=24.995 //y2=0.555
cc_9385 ( N_GND_c_16600_n N_noxref_52_M15_noxref_s ) capacitor c=0.00166413f \
 //x=29.35 //y=0.175 //x2=24.995 //y2=0.555
cc_9386 ( N_GND_M15_noxref_d N_noxref_52_M15_noxref_s ) capacitor c=0.0271316f \
 //x=25.425 //y=1.055 //x2=24.995 //y2=0.555
cc_9387 ( N_GND_c_16588_n N_noxref_53_c_18482_n ) capacitor c=0.0011329f \
 //x=30.34 //y=0.175 //x2=30.825 //y2=1.77
cc_9388 ( N_GND_c_16658_n N_noxref_53_c_18482_n ) capacitor c=6.72491e-19 \
 //x=35.15 //y=0.175 //x2=30.825 //y2=1.77
cc_9389 ( N_GND_c_16624_n N_noxref_53_c_18482_n ) capacitor c=0.00381139f \
 //x=30.425 //y=1.145 //x2=30.825 //y2=1.77
cc_9390 ( N_GND_c_16689_n N_noxref_53_c_18482_n ) capacitor c=0.00392232f \
 //x=33.99 //y=0.175 //x2=30.825 //y2=1.77
cc_9391 ( N_GND_M18_noxref_d N_noxref_53_c_18482_n ) capacitor c=0.00578031f \
 //x=30.235 //y=1.055 //x2=30.825 //y2=1.77
cc_9392 ( N_GND_c_16874_n N_noxref_53_c_18508_n ) capacitor c=0.0169052f \
 //x=30.425 //y=1.015 //x2=30.91 //y2=0.805
cc_9393 ( N_GND_c_16658_n N_noxref_53_c_18508_n ) capacitor c=0.00439789f \
 //x=35.15 //y=0.175 //x2=30.91 //y2=0.805
cc_9394 ( N_GND_c_16689_n N_noxref_53_c_18508_n ) capacitor c=0.0141638f \
 //x=33.99 //y=0.175 //x2=30.91 //y2=0.805
cc_9395 ( N_GND_c_16600_n N_noxref_53_c_18508_n ) capacitor c=0.00322478f \
 //x=29.35 //y=0.175 //x2=30.91 //y2=0.805
cc_9396 ( N_GND_c_16658_n N_noxref_53_c_18495_n ) capacitor c=0.012282f \
 //x=35.15 //y=0.175 //x2=31.795 //y2=0.72
cc_9397 ( N_GND_c_16689_n N_noxref_53_c_18495_n ) capacitor c=0.0361346f \
 //x=33.99 //y=0.175 //x2=31.795 //y2=0.72
cc_9398 ( N_GND_c_16588_n N_noxref_53_M18_noxref_s ) capacitor c=0.00439789f \
 //x=30.34 //y=0.175 //x2=29.805 //y2=0.555
cc_9399 ( N_GND_c_16874_n N_noxref_53_M18_noxref_s ) capacitor c=0.0173062f \
 //x=30.425 //y=1.015 //x2=29.805 //y2=0.555
cc_9400 ( N_GND_c_16658_n N_noxref_53_M18_noxref_s ) capacitor c=0.0044479f \
 //x=35.15 //y=0.175 //x2=29.805 //y2=0.555
cc_9401 ( N_GND_c_16624_n N_noxref_53_M18_noxref_s ) capacitor c=0.00988958f \
 //x=30.425 //y=1.145 //x2=29.805 //y2=0.555
cc_9402 ( N_GND_c_16689_n N_noxref_53_M18_noxref_s ) capacitor c=0.0273693f \
 //x=33.99 //y=0.175 //x2=29.805 //y2=0.555
cc_9403 ( N_GND_c_16600_n N_noxref_53_M18_noxref_s ) capacitor c=0.0634633f \
 //x=29.35 //y=0.175 //x2=29.805 //y2=0.555
cc_9404 ( N_GND_c_16693_n N_noxref_53_M18_noxref_s ) capacitor c=0.00166413f \
 //x=34.16 //y=0.175 //x2=29.805 //y2=0.555
cc_9405 ( N_GND_M18_noxref_d N_noxref_53_M18_noxref_s ) capacitor c=0.0271316f \
 //x=30.235 //y=1.055 //x2=29.805 //y2=0.555
cc_9406 ( N_GND_c_16658_n N_noxref_54_c_18538_n ) capacitor c=0.0011329f \
 //x=35.15 //y=0.175 //x2=35.635 //y2=1.77
cc_9407 ( N_GND_c_16769_n N_noxref_54_c_18538_n ) capacitor c=6.52594e-19 \
 //x=39.96 //y=0.175 //x2=35.635 //y2=1.77
cc_9408 ( N_GND_c_16668_n N_noxref_54_c_18538_n ) capacitor c=0.0035977f \
 //x=35.235 //y=1.145 //x2=35.635 //y2=1.77
cc_9409 ( N_GND_c_16691_n N_noxref_54_c_18538_n ) capacitor c=0.00392232f \
 //x=38.8 //y=0.175 //x2=35.635 //y2=1.77
cc_9410 ( N_GND_M21_noxref_d N_noxref_54_c_18538_n ) capacitor c=0.00578031f \
 //x=35.045 //y=1.055 //x2=35.635 //y2=1.77
cc_9411 ( N_GND_c_16662_n N_noxref_54_c_18565_n ) capacitor c=0.0169052f \
 //x=35.235 //y=1.015 //x2=35.72 //y2=0.805
cc_9412 ( N_GND_c_16769_n N_noxref_54_c_18565_n ) capacitor c=0.00439789f \
 //x=39.96 //y=0.175 //x2=35.72 //y2=0.805
cc_9413 ( N_GND_c_16691_n N_noxref_54_c_18565_n ) capacitor c=0.0141638f \
 //x=38.8 //y=0.175 //x2=35.72 //y2=0.805
cc_9414 ( N_GND_c_16693_n N_noxref_54_c_18565_n ) capacitor c=0.00322478f \
 //x=34.16 //y=0.175 //x2=35.72 //y2=0.805
cc_9415 ( N_GND_c_16769_n N_noxref_54_c_18549_n ) capacitor c=0.0124416f \
 //x=39.96 //y=0.175 //x2=36.605 //y2=0.72
cc_9416 ( N_GND_c_16691_n N_noxref_54_c_18549_n ) capacitor c=0.0361346f \
 //x=38.8 //y=0.175 //x2=36.605 //y2=0.72
cc_9417 ( N_GND_c_16658_n N_noxref_54_M21_noxref_s ) capacitor c=0.00439789f \
 //x=35.15 //y=0.175 //x2=34.615 //y2=0.555
cc_9418 ( N_GND_c_16662_n N_noxref_54_M21_noxref_s ) capacitor c=0.0173062f \
 //x=35.235 //y=1.015 //x2=34.615 //y2=0.555
cc_9419 ( N_GND_c_16769_n N_noxref_54_M21_noxref_s ) capacitor c=0.0044479f \
 //x=39.96 //y=0.175 //x2=34.615 //y2=0.555
cc_9420 ( N_GND_c_16668_n N_noxref_54_M21_noxref_s ) capacitor c=0.00988958f \
 //x=35.235 //y=1.145 //x2=34.615 //y2=0.555
cc_9421 ( N_GND_c_16691_n N_noxref_54_M21_noxref_s ) capacitor c=0.0273693f \
 //x=38.8 //y=0.175 //x2=34.615 //y2=0.555
cc_9422 ( N_GND_c_16693_n N_noxref_54_M21_noxref_s ) capacitor c=0.0634633f \
 //x=34.16 //y=0.175 //x2=34.615 //y2=0.555
cc_9423 ( N_GND_c_16706_n N_noxref_54_M21_noxref_s ) capacitor c=0.00166413f \
 //x=38.97 //y=0.175 //x2=34.615 //y2=0.555
cc_9424 ( N_GND_M21_noxref_d N_noxref_54_M21_noxref_s ) capacitor c=0.0271316f \
 //x=35.045 //y=1.055 //x2=34.615 //y2=0.555
cc_9425 ( N_GND_c_16769_n N_noxref_55_c_18595_n ) capacitor c=0.0011329f \
 //x=39.96 //y=0.175 //x2=40.445 //y2=1.77
cc_9426 ( N_GND_c_16728_n N_noxref_55_c_18595_n ) capacitor c=7.40908e-19 \
 //x=44.77 //y=0.175 //x2=40.445 //y2=1.77
cc_9427 ( N_GND_c_16679_n N_noxref_55_c_18595_n ) capacitor c=0.00350793f \
 //x=40.045 //y=1.145 //x2=40.445 //y2=1.77
cc_9428 ( N_GND_c_16692_n N_noxref_55_c_18595_n ) capacitor c=0.00392232f \
 //x=43.61 //y=0.175 //x2=40.445 //y2=1.77
cc_9429 ( N_GND_M24_noxref_d N_noxref_55_c_18595_n ) capacitor c=0.00578031f \
 //x=39.855 //y=1.055 //x2=40.445 //y2=1.77
cc_9430 ( N_GND_c_16665_n N_noxref_55_c_18623_n ) capacitor c=0.0169052f \
 //x=40.045 //y=1.015 //x2=40.53 //y2=0.805
cc_9431 ( N_GND_c_16728_n N_noxref_55_c_18623_n ) capacitor c=0.00439789f \
 //x=44.77 //y=0.175 //x2=40.53 //y2=0.805
cc_9432 ( N_GND_c_16692_n N_noxref_55_c_18623_n ) capacitor c=0.0141638f \
 //x=43.61 //y=0.175 //x2=40.53 //y2=0.805
cc_9433 ( N_GND_c_16706_n N_noxref_55_c_18623_n ) capacitor c=0.00322478f \
 //x=38.97 //y=0.175 //x2=40.53 //y2=0.805
cc_9434 ( N_GND_c_16728_n N_noxref_55_c_18610_n ) capacitor c=0.0118039f \
 //x=44.77 //y=0.175 //x2=41.415 //y2=0.72
cc_9435 ( N_GND_c_16692_n N_noxref_55_c_18610_n ) capacitor c=0.0361346f \
 //x=43.61 //y=0.175 //x2=41.415 //y2=0.72
cc_9436 ( N_GND_c_16769_n N_noxref_55_M24_noxref_s ) capacitor c=0.00439789f \
 //x=39.96 //y=0.175 //x2=39.425 //y2=0.555
cc_9437 ( N_GND_c_16665_n N_noxref_55_M24_noxref_s ) capacitor c=0.0173062f \
 //x=40.045 //y=1.015 //x2=39.425 //y2=0.555
cc_9438 ( N_GND_c_16728_n N_noxref_55_M24_noxref_s ) capacitor c=0.00405325f \
 //x=44.77 //y=0.175 //x2=39.425 //y2=0.555
cc_9439 ( N_GND_c_16679_n N_noxref_55_M24_noxref_s ) capacitor c=0.00988958f \
 //x=40.045 //y=1.145 //x2=39.425 //y2=0.555
cc_9440 ( N_GND_c_16692_n N_noxref_55_M24_noxref_s ) capacitor c=0.0273693f \
 //x=43.61 //y=0.175 //x2=39.425 //y2=0.555
cc_9441 ( N_GND_c_16706_n N_noxref_55_M24_noxref_s ) capacitor c=0.0634633f \
 //x=38.97 //y=0.175 //x2=39.425 //y2=0.555
cc_9442 ( N_GND_c_16749_n N_noxref_55_M24_noxref_s ) capacitor c=0.00166413f \
 //x=43.78 //y=0.175 //x2=39.425 //y2=0.555
cc_9443 ( N_GND_M24_noxref_d N_noxref_55_M24_noxref_s ) capacitor c=0.0271316f \
 //x=39.855 //y=1.055 //x2=39.425 //y2=0.555
cc_9444 ( N_GND_c_16728_n N_noxref_56_c_18653_n ) capacitor c=0.0011329f \
 //x=44.77 //y=0.175 //x2=45.255 //y2=1.77
cc_9445 ( N_GND_c_16850_n N_noxref_56_c_18653_n ) capacitor c=7.40908e-19 \
 //x=49.58 //y=0.175 //x2=45.255 //y2=1.77
cc_9446 ( N_GND_c_16735_n N_noxref_56_c_18653_n ) capacitor c=0.00350855f \
 //x=44.855 //y=1.145 //x2=45.255 //y2=1.77
cc_9447 ( N_GND_c_16748_n N_noxref_56_c_18653_n ) capacitor c=0.00392231f \
 //x=48.42 //y=0.175 //x2=45.255 //y2=1.77
cc_9448 ( N_GND_M27_noxref_d N_noxref_56_c_18653_n ) capacitor c=0.00578031f \
 //x=44.665 //y=1.055 //x2=45.255 //y2=1.77
cc_9449 ( N_GND_c_16732_n N_noxref_56_c_18682_n ) capacitor c=0.0169052f \
 //x=44.855 //y=1.015 //x2=45.34 //y2=0.805
cc_9450 ( N_GND_c_16850_n N_noxref_56_c_18682_n ) capacitor c=0.00439789f \
 //x=49.58 //y=0.175 //x2=45.34 //y2=0.805
cc_9451 ( N_GND_c_16748_n N_noxref_56_c_18682_n ) capacitor c=0.0141638f \
 //x=48.42 //y=0.175 //x2=45.34 //y2=0.805
cc_9452 ( N_GND_c_16749_n N_noxref_56_c_18682_n ) capacitor c=0.00322478f \
 //x=43.78 //y=0.175 //x2=45.34 //y2=0.805
cc_9453 ( N_GND_c_16850_n N_noxref_56_c_18664_n ) capacitor c=0.0123805f \
 //x=49.58 //y=0.175 //x2=46.225 //y2=0.72
cc_9454 ( N_GND_c_16748_n N_noxref_56_c_18664_n ) capacitor c=0.0361346f \
 //x=48.42 //y=0.175 //x2=46.225 //y2=0.72
cc_9455 ( N_GND_c_16728_n N_noxref_56_M27_noxref_s ) capacitor c=0.00439789f \
 //x=44.77 //y=0.175 //x2=44.235 //y2=0.555
cc_9456 ( N_GND_c_16732_n N_noxref_56_M27_noxref_s ) capacitor c=0.0173062f \
 //x=44.855 //y=1.015 //x2=44.235 //y2=0.555
cc_9457 ( N_GND_c_16850_n N_noxref_56_M27_noxref_s ) capacitor c=0.0044479f \
 //x=49.58 //y=0.175 //x2=44.235 //y2=0.555
cc_9458 ( N_GND_c_16735_n N_noxref_56_M27_noxref_s ) capacitor c=0.00988958f \
 //x=44.855 //y=1.145 //x2=44.235 //y2=0.555
cc_9459 ( N_GND_c_16748_n N_noxref_56_M27_noxref_s ) capacitor c=0.0273693f \
 //x=48.42 //y=0.175 //x2=44.235 //y2=0.555
cc_9460 ( N_GND_c_16749_n N_noxref_56_M27_noxref_s ) capacitor c=0.0634633f \
 //x=43.78 //y=0.175 //x2=44.235 //y2=0.555
cc_9461 ( N_GND_c_16796_n N_noxref_56_M27_noxref_s ) capacitor c=0.00166413f \
 //x=48.59 //y=0.175 //x2=44.235 //y2=0.555
cc_9462 ( N_GND_M27_noxref_d N_noxref_56_M27_noxref_s ) capacitor c=0.0271316f \
 //x=44.665 //y=1.055 //x2=44.235 //y2=0.555
cc_9463 ( N_GND_c_16850_n N_noxref_57_c_18712_n ) capacitor c=0.0011329f \
 //x=49.58 //y=0.175 //x2=50.065 //y2=1.77
cc_9464 ( N_GND_c_16808_n N_noxref_57_c_18712_n ) capacitor c=7.40908e-19 \
 //x=54.39 //y=0.175 //x2=50.065 //y2=1.77
cc_9465 ( N_GND_c_16777_n N_noxref_57_c_18712_n ) capacitor c=0.0036557f \
 //x=49.665 //y=1.145 //x2=50.065 //y2=1.77
cc_9466 ( N_GND_c_16790_n N_noxref_57_c_18712_n ) capacitor c=0.00392232f \
 //x=53.23 //y=0.175 //x2=50.065 //y2=1.77
cc_9467 ( N_GND_M30_noxref_d N_noxref_57_c_18712_n ) capacitor c=0.00578031f \
 //x=49.475 //y=1.055 //x2=50.065 //y2=1.77
cc_9468 ( N_GND_c_16773_n N_noxref_57_c_18740_n ) capacitor c=0.0169052f \
 //x=49.665 //y=1.015 //x2=50.15 //y2=0.805
cc_9469 ( N_GND_c_16808_n N_noxref_57_c_18740_n ) capacitor c=0.00439789f \
 //x=54.39 //y=0.175 //x2=50.15 //y2=0.805
cc_9470 ( N_GND_c_16790_n N_noxref_57_c_18740_n ) capacitor c=0.0141638f \
 //x=53.23 //y=0.175 //x2=50.15 //y2=0.805
cc_9471 ( N_GND_c_16796_n N_noxref_57_c_18740_n ) capacitor c=0.00322478f \
 //x=48.59 //y=0.175 //x2=50.15 //y2=0.805
cc_9472 ( N_GND_c_16808_n N_noxref_57_c_18725_n ) capacitor c=0.0123293f \
 //x=54.39 //y=0.175 //x2=51.035 //y2=0.72
cc_9473 ( N_GND_c_16790_n N_noxref_57_c_18725_n ) capacitor c=0.0361346f \
 //x=53.23 //y=0.175 //x2=51.035 //y2=0.72
cc_9474 ( N_GND_c_16850_n N_noxref_57_M30_noxref_s ) capacitor c=0.00439789f \
 //x=49.58 //y=0.175 //x2=49.045 //y2=0.555
cc_9475 ( N_GND_c_16773_n N_noxref_57_M30_noxref_s ) capacitor c=0.0173062f \
 //x=49.665 //y=1.015 //x2=49.045 //y2=0.555
cc_9476 ( N_GND_c_16808_n N_noxref_57_M30_noxref_s ) capacitor c=0.0044479f \
 //x=54.39 //y=0.175 //x2=49.045 //y2=0.555
cc_9477 ( N_GND_c_16777_n N_noxref_57_M30_noxref_s ) capacitor c=0.00988958f \
 //x=49.665 //y=1.145 //x2=49.045 //y2=0.555
cc_9478 ( N_GND_c_16790_n N_noxref_57_M30_noxref_s ) capacitor c=0.0273693f \
 //x=53.23 //y=0.175 //x2=49.045 //y2=0.555
cc_9479 ( N_GND_c_16796_n N_noxref_57_M30_noxref_s ) capacitor c=0.0634633f \
 //x=48.59 //y=0.175 //x2=49.045 //y2=0.555
cc_9480 ( N_GND_c_16829_n N_noxref_57_M30_noxref_s ) capacitor c=0.00166413f \
 //x=53.4 //y=0.175 //x2=49.045 //y2=0.555
cc_9481 ( N_GND_M30_noxref_d N_noxref_57_M30_noxref_s ) capacitor c=0.0271316f \
 //x=49.475 //y=1.055 //x2=49.045 //y2=0.555
cc_9482 ( N_GND_c_16808_n N_noxref_58_c_18770_n ) capacitor c=0.0011329f \
 //x=54.39 //y=0.175 //x2=54.875 //y2=1.77
cc_9483 ( N_GND_c_16854_n N_noxref_58_c_18770_n ) capacitor c=7.40908e-19 \
 //x=59.2 //y=0.175 //x2=54.875 //y2=1.77
cc_9484 ( N_GND_c_16815_n N_noxref_58_c_18770_n ) capacitor c=0.00349867f \
 //x=54.475 //y=1.145 //x2=54.875 //y2=1.77
cc_9485 ( N_GND_c_16828_n N_noxref_58_c_18770_n ) capacitor c=0.00392232f \
 //x=58.04 //y=0.175 //x2=54.875 //y2=1.77
cc_9486 ( N_GND_M33_noxref_d N_noxref_58_c_18770_n ) capacitor c=0.00578031f \
 //x=54.285 //y=1.055 //x2=54.875 //y2=1.77
cc_9487 ( N_GND_c_16812_n N_noxref_58_c_18799_n ) capacitor c=0.0169052f \
 //x=54.475 //y=1.015 //x2=54.96 //y2=0.805
cc_9488 ( N_GND_c_16854_n N_noxref_58_c_18799_n ) capacitor c=0.00439789f \
 //x=59.2 //y=0.175 //x2=54.96 //y2=0.805
cc_9489 ( N_GND_c_16828_n N_noxref_58_c_18799_n ) capacitor c=0.0141638f \
 //x=58.04 //y=0.175 //x2=54.96 //y2=0.805
cc_9490 ( N_GND_c_16829_n N_noxref_58_c_18799_n ) capacitor c=0.00322478f \
 //x=53.4 //y=0.175 //x2=54.96 //y2=0.805
cc_9491 ( N_GND_c_16854_n N_noxref_58_c_18787_n ) capacitor c=0.0123291f \
 //x=59.2 //y=0.175 //x2=55.845 //y2=0.72
cc_9492 ( N_GND_c_16828_n N_noxref_58_c_18787_n ) capacitor c=0.0361346f \
 //x=58.04 //y=0.175 //x2=55.845 //y2=0.72
cc_9493 ( N_GND_c_16808_n N_noxref_58_M33_noxref_s ) capacitor c=0.00439789f \
 //x=54.39 //y=0.175 //x2=53.855 //y2=0.555
cc_9494 ( N_GND_c_16812_n N_noxref_58_M33_noxref_s ) capacitor c=0.0173062f \
 //x=54.475 //y=1.015 //x2=53.855 //y2=0.555
cc_9495 ( N_GND_c_16854_n N_noxref_58_M33_noxref_s ) capacitor c=0.0044479f \
 //x=59.2 //y=0.175 //x2=53.855 //y2=0.555
cc_9496 ( N_GND_c_16815_n N_noxref_58_M33_noxref_s ) capacitor c=0.00988958f \
 //x=54.475 //y=1.145 //x2=53.855 //y2=0.555
cc_9497 ( N_GND_c_16828_n N_noxref_58_M33_noxref_s ) capacitor c=0.0273693f \
 //x=58.04 //y=0.175 //x2=53.855 //y2=0.555
cc_9498 ( N_GND_c_16829_n N_noxref_58_M33_noxref_s ) capacitor c=0.0634633f \
 //x=53.4 //y=0.175 //x2=53.855 //y2=0.555
cc_9499 ( N_GND_c_16867_n N_noxref_58_M33_noxref_s ) capacitor c=0.00166413f \
 //x=58.21 //y=0.175 //x2=53.855 //y2=0.555
cc_9500 ( N_GND_M33_noxref_d N_noxref_58_M33_noxref_s ) capacitor c=0.0271316f \
 //x=54.285 //y=1.055 //x2=53.855 //y2=0.555
cc_9501 ( N_GND_c_16854_n N_noxref_59_c_18829_n ) capacitor c=0.0011329f \
 //x=59.2 //y=0.175 //x2=59.685 //y2=1.77
cc_9502 ( N_GND_c_16949_n N_noxref_59_c_18829_n ) capacitor c=7.40908e-19 \
 //x=64.01 //y=0.175 //x2=59.685 //y2=1.77
cc_9503 ( N_GND_c_16900_n N_noxref_59_c_18829_n ) capacitor c=0.00375599f \
 //x=59.285 //y=1.145 //x2=59.685 //y2=1.77
cc_9504 ( N_GND_c_16917_n N_noxref_59_c_18829_n ) capacitor c=0.00392232f \
 //x=62.85 //y=0.175 //x2=59.685 //y2=1.77
cc_9505 ( N_GND_M36_noxref_d N_noxref_59_c_18829_n ) capacitor c=0.00578031f \
 //x=59.095 //y=1.055 //x2=59.685 //y2=1.77
cc_9506 ( N_GND_c_16877_n N_noxref_59_c_18855_n ) capacitor c=0.0169052f \
 //x=59.285 //y=1.015 //x2=59.77 //y2=0.805
cc_9507 ( N_GND_c_16949_n N_noxref_59_c_18855_n ) capacitor c=0.00439789f \
 //x=64.01 //y=0.175 //x2=59.77 //y2=0.805
cc_9508 ( N_GND_c_16917_n N_noxref_59_c_18855_n ) capacitor c=0.0141638f \
 //x=62.85 //y=0.175 //x2=59.77 //y2=0.805
cc_9509 ( N_GND_c_16867_n N_noxref_59_c_18855_n ) capacitor c=0.00322478f \
 //x=58.21 //y=0.175 //x2=59.77 //y2=0.805
cc_9510 ( N_GND_c_16949_n N_noxref_59_c_18842_n ) capacitor c=0.012282f \
 //x=64.01 //y=0.175 //x2=60.655 //y2=0.72
cc_9511 ( N_GND_c_16917_n N_noxref_59_c_18842_n ) capacitor c=0.0361346f \
 //x=62.85 //y=0.175 //x2=60.655 //y2=0.72
cc_9512 ( N_GND_c_16854_n N_noxref_59_M36_noxref_s ) capacitor c=0.00439789f \
 //x=59.2 //y=0.175 //x2=58.665 //y2=0.555
cc_9513 ( N_GND_c_16877_n N_noxref_59_M36_noxref_s ) capacitor c=0.0173062f \
 //x=59.285 //y=1.015 //x2=58.665 //y2=0.555
cc_9514 ( N_GND_c_16949_n N_noxref_59_M36_noxref_s ) capacitor c=0.0044479f \
 //x=64.01 //y=0.175 //x2=58.665 //y2=0.555
cc_9515 ( N_GND_c_16900_n N_noxref_59_M36_noxref_s ) capacitor c=0.00988958f \
 //x=59.285 //y=1.145 //x2=58.665 //y2=0.555
cc_9516 ( N_GND_c_16917_n N_noxref_59_M36_noxref_s ) capacitor c=0.0273693f \
 //x=62.85 //y=0.175 //x2=58.665 //y2=0.555
cc_9517 ( N_GND_c_16867_n N_noxref_59_M36_noxref_s ) capacitor c=0.0634633f \
 //x=58.21 //y=0.175 //x2=58.665 //y2=0.555
cc_9518 ( N_GND_c_16984_n N_noxref_59_M36_noxref_s ) capacitor c=0.00166413f \
 //x=63.02 //y=0.175 //x2=58.665 //y2=0.555
cc_9519 ( N_GND_M36_noxref_d N_noxref_59_M36_noxref_s ) capacitor c=0.0271316f \
 //x=59.095 //y=1.055 //x2=58.665 //y2=0.555
cc_9520 ( N_GND_c_16949_n N_noxref_60_c_18885_n ) capacitor c=0.0011329f \
 //x=64.01 //y=0.175 //x2=64.495 //y2=1.77
cc_9521 ( N_GND_c_17063_n N_noxref_60_c_18885_n ) capacitor c=6.52594e-19 \
 //x=68.82 //y=0.175 //x2=64.495 //y2=1.77
cc_9522 ( N_GND_c_16959_n N_noxref_60_c_18885_n ) capacitor c=0.0035977f \
 //x=64.095 //y=1.145 //x2=64.495 //y2=1.77
cc_9523 ( N_GND_c_16982_n N_noxref_60_c_18885_n ) capacitor c=0.00392232f \
 //x=67.66 //y=0.175 //x2=64.495 //y2=1.77
cc_9524 ( N_GND_M39_noxref_d N_noxref_60_c_18885_n ) capacitor c=0.00578031f \
 //x=63.905 //y=1.055 //x2=64.495 //y2=1.77
cc_9525 ( N_GND_c_16953_n N_noxref_60_c_18912_n ) capacitor c=0.0169052f \
 //x=64.095 //y=1.015 //x2=64.58 //y2=0.805
cc_9526 ( N_GND_c_17063_n N_noxref_60_c_18912_n ) capacitor c=0.00439789f \
 //x=68.82 //y=0.175 //x2=64.58 //y2=0.805
cc_9527 ( N_GND_c_16982_n N_noxref_60_c_18912_n ) capacitor c=0.0141638f \
 //x=67.66 //y=0.175 //x2=64.58 //y2=0.805
cc_9528 ( N_GND_c_16984_n N_noxref_60_c_18912_n ) capacitor c=0.00322478f \
 //x=63.02 //y=0.175 //x2=64.58 //y2=0.805
cc_9529 ( N_GND_c_17063_n N_noxref_60_c_18896_n ) capacitor c=0.0124416f \
 //x=68.82 //y=0.175 //x2=65.465 //y2=0.72
cc_9530 ( N_GND_c_16982_n N_noxref_60_c_18896_n ) capacitor c=0.0361346f \
 //x=67.66 //y=0.175 //x2=65.465 //y2=0.72
cc_9531 ( N_GND_c_16949_n N_noxref_60_M39_noxref_s ) capacitor c=0.00439789f \
 //x=64.01 //y=0.175 //x2=63.475 //y2=0.555
cc_9532 ( N_GND_c_16953_n N_noxref_60_M39_noxref_s ) capacitor c=0.0173062f \
 //x=64.095 //y=1.015 //x2=63.475 //y2=0.555
cc_9533 ( N_GND_c_17063_n N_noxref_60_M39_noxref_s ) capacitor c=0.0044479f \
 //x=68.82 //y=0.175 //x2=63.475 //y2=0.555
cc_9534 ( N_GND_c_16959_n N_noxref_60_M39_noxref_s ) capacitor c=0.00988958f \
 //x=64.095 //y=1.145 //x2=63.475 //y2=0.555
cc_9535 ( N_GND_c_16982_n N_noxref_60_M39_noxref_s ) capacitor c=0.0273693f \
 //x=67.66 //y=0.175 //x2=63.475 //y2=0.555
cc_9536 ( N_GND_c_16984_n N_noxref_60_M39_noxref_s ) capacitor c=0.0634633f \
 //x=63.02 //y=0.175 //x2=63.475 //y2=0.555
cc_9537 ( N_GND_c_16997_n N_noxref_60_M39_noxref_s ) capacitor c=0.00166413f \
 //x=67.83 //y=0.175 //x2=63.475 //y2=0.555
cc_9538 ( N_GND_M39_noxref_d N_noxref_60_M39_noxref_s ) capacitor c=0.0271316f \
 //x=63.905 //y=1.055 //x2=63.475 //y2=0.555
cc_9539 ( N_GND_c_17063_n N_noxref_61_c_18942_n ) capacitor c=0.0011329f \
 //x=68.82 //y=0.175 //x2=69.305 //y2=1.77
cc_9540 ( N_GND_c_17019_n N_noxref_61_c_18942_n ) capacitor c=7.40908e-19 \
 //x=73.63 //y=0.175 //x2=69.305 //y2=1.77
cc_9541 ( N_GND_c_16970_n N_noxref_61_c_18942_n ) capacitor c=0.00350793f \
 //x=68.905 //y=1.145 //x2=69.305 //y2=1.77
cc_9542 ( N_GND_c_16983_n N_noxref_61_c_18942_n ) capacitor c=0.00392232f \
 //x=72.47 //y=0.175 //x2=69.305 //y2=1.77
cc_9543 ( N_GND_M42_noxref_d N_noxref_61_c_18942_n ) capacitor c=0.00578031f \
 //x=68.715 //y=1.055 //x2=69.305 //y2=1.77
cc_9544 ( N_GND_c_16956_n N_noxref_61_c_18970_n ) capacitor c=0.0169052f \
 //x=68.905 //y=1.015 //x2=69.39 //y2=0.805
cc_9545 ( N_GND_c_17019_n N_noxref_61_c_18970_n ) capacitor c=0.00439789f \
 //x=73.63 //y=0.175 //x2=69.39 //y2=0.805
cc_9546 ( N_GND_c_16983_n N_noxref_61_c_18970_n ) capacitor c=0.0141638f \
 //x=72.47 //y=0.175 //x2=69.39 //y2=0.805
cc_9547 ( N_GND_c_16997_n N_noxref_61_c_18970_n ) capacitor c=0.00322478f \
 //x=67.83 //y=0.175 //x2=69.39 //y2=0.805
cc_9548 ( N_GND_c_17019_n N_noxref_61_c_18957_n ) capacitor c=0.0118039f \
 //x=73.63 //y=0.175 //x2=70.275 //y2=0.72
cc_9549 ( N_GND_c_16983_n N_noxref_61_c_18957_n ) capacitor c=0.0361346f \
 //x=72.47 //y=0.175 //x2=70.275 //y2=0.72
cc_9550 ( N_GND_c_17063_n N_noxref_61_M42_noxref_s ) capacitor c=0.00439789f \
 //x=68.82 //y=0.175 //x2=68.285 //y2=0.555
cc_9551 ( N_GND_c_16956_n N_noxref_61_M42_noxref_s ) capacitor c=0.0173062f \
 //x=68.905 //y=1.015 //x2=68.285 //y2=0.555
cc_9552 ( N_GND_c_17019_n N_noxref_61_M42_noxref_s ) capacitor c=0.00405325f \
 //x=73.63 //y=0.175 //x2=68.285 //y2=0.555
cc_9553 ( N_GND_c_16970_n N_noxref_61_M42_noxref_s ) capacitor c=0.00988958f \
 //x=68.905 //y=1.145 //x2=68.285 //y2=0.555
cc_9554 ( N_GND_c_16983_n N_noxref_61_M42_noxref_s ) capacitor c=0.0273693f \
 //x=72.47 //y=0.175 //x2=68.285 //y2=0.555
cc_9555 ( N_GND_c_16997_n N_noxref_61_M42_noxref_s ) capacitor c=0.0634633f \
 //x=67.83 //y=0.175 //x2=68.285 //y2=0.555
cc_9556 ( N_GND_c_17040_n N_noxref_61_M42_noxref_s ) capacitor c=0.00166413f \
 //x=72.64 //y=0.175 //x2=68.285 //y2=0.555
cc_9557 ( N_GND_M42_noxref_d N_noxref_61_M42_noxref_s ) capacitor c=0.0271316f \
 //x=68.715 //y=1.055 //x2=68.285 //y2=0.555
cc_9558 ( N_GND_c_17019_n N_noxref_62_c_19000_n ) capacitor c=0.0011329f \
 //x=73.63 //y=0.175 //x2=74.115 //y2=1.77
cc_9559 ( N_GND_c_17064_n N_noxref_62_c_19000_n ) capacitor c=7.40908e-19 \
 //x=78.44 //y=0.175 //x2=74.115 //y2=1.77
cc_9560 ( N_GND_c_17026_n N_noxref_62_c_19000_n ) capacitor c=0.00350855f \
 //x=73.715 //y=1.145 //x2=74.115 //y2=1.77
cc_9561 ( N_GND_c_17039_n N_noxref_62_c_19000_n ) capacitor c=0.00392231f \
 //x=77.28 //y=0.175 //x2=74.115 //y2=1.77
cc_9562 ( N_GND_M45_noxref_d N_noxref_62_c_19000_n ) capacitor c=0.00578031f \
 //x=73.525 //y=1.055 //x2=74.115 //y2=1.77
cc_9563 ( N_GND_c_17023_n N_noxref_62_c_19029_n ) capacitor c=0.0169052f \
 //x=73.715 //y=1.015 //x2=74.2 //y2=0.805
cc_9564 ( N_GND_c_17064_n N_noxref_62_c_19029_n ) capacitor c=0.00439789f \
 //x=78.44 //y=0.175 //x2=74.2 //y2=0.805
cc_9565 ( N_GND_c_17039_n N_noxref_62_c_19029_n ) capacitor c=0.0141638f \
 //x=77.28 //y=0.175 //x2=74.2 //y2=0.805
cc_9566 ( N_GND_c_17040_n N_noxref_62_c_19029_n ) capacitor c=0.00322478f \
 //x=72.64 //y=0.175 //x2=74.2 //y2=0.805
cc_9567 ( N_GND_c_17064_n N_noxref_62_c_19011_n ) capacitor c=0.0123805f \
 //x=78.44 //y=0.175 //x2=75.085 //y2=0.72
cc_9568 ( N_GND_c_17039_n N_noxref_62_c_19011_n ) capacitor c=0.0361346f \
 //x=77.28 //y=0.175 //x2=75.085 //y2=0.72
cc_9569 ( N_GND_c_17019_n N_noxref_62_M45_noxref_s ) capacitor c=0.00439789f \
 //x=73.63 //y=0.175 //x2=73.095 //y2=0.555
cc_9570 ( N_GND_c_17023_n N_noxref_62_M45_noxref_s ) capacitor c=0.0173062f \
 //x=73.715 //y=1.015 //x2=73.095 //y2=0.555
cc_9571 ( N_GND_c_17064_n N_noxref_62_M45_noxref_s ) capacitor c=0.0044479f \
 //x=78.44 //y=0.175 //x2=73.095 //y2=0.555
cc_9572 ( N_GND_c_17026_n N_noxref_62_M45_noxref_s ) capacitor c=0.00988958f \
 //x=73.715 //y=1.145 //x2=73.095 //y2=0.555
cc_9573 ( N_GND_c_17039_n N_noxref_62_M45_noxref_s ) capacitor c=0.0273693f \
 //x=77.28 //y=0.175 //x2=73.095 //y2=0.555
cc_9574 ( N_GND_c_17040_n N_noxref_62_M45_noxref_s ) capacitor c=0.0634633f \
 //x=72.64 //y=0.175 //x2=73.095 //y2=0.555
cc_9575 ( N_GND_c_17093_n N_noxref_62_M45_noxref_s ) capacitor c=0.00166413f \
 //x=77.45 //y=0.175 //x2=73.095 //y2=0.555
cc_9576 ( N_GND_M45_noxref_d N_noxref_62_M45_noxref_s ) capacitor c=0.0271316f \
 //x=73.525 //y=1.055 //x2=73.095 //y2=0.555
cc_9577 ( N_GND_c_17064_n N_noxref_63_c_19059_n ) capacitor c=0.0011329f \
 //x=78.44 //y=0.175 //x2=78.925 //y2=1.77
cc_9578 ( N_GND_c_17141_n N_noxref_63_c_19059_n ) capacitor c=7.40908e-19 \
 //x=83.25 //y=0.175 //x2=78.925 //y2=1.77
cc_9579 ( N_GND_c_17074_n N_noxref_63_c_19059_n ) capacitor c=0.0036557f \
 //x=78.525 //y=1.145 //x2=78.925 //y2=1.77
cc_9580 ( N_GND_c_17087_n N_noxref_63_c_19059_n ) capacitor c=0.00392232f \
 //x=82.09 //y=0.175 //x2=78.925 //y2=1.77
cc_9581 ( N_GND_M48_noxref_d N_noxref_63_c_19059_n ) capacitor c=0.00578031f \
 //x=78.335 //y=1.055 //x2=78.925 //y2=1.77
cc_9582 ( N_GND_c_17070_n N_noxref_63_c_19087_n ) capacitor c=0.0169052f \
 //x=78.525 //y=1.015 //x2=79.01 //y2=0.805
cc_9583 ( N_GND_c_17141_n N_noxref_63_c_19087_n ) capacitor c=0.00439789f \
 //x=83.25 //y=0.175 //x2=79.01 //y2=0.805
cc_9584 ( N_GND_c_17087_n N_noxref_63_c_19087_n ) capacitor c=0.0141638f \
 //x=82.09 //y=0.175 //x2=79.01 //y2=0.805
cc_9585 ( N_GND_c_17093_n N_noxref_63_c_19087_n ) capacitor c=0.00322478f \
 //x=77.45 //y=0.175 //x2=79.01 //y2=0.805
cc_9586 ( N_GND_c_17141_n N_noxref_63_c_19072_n ) capacitor c=0.0123293f \
 //x=83.25 //y=0.175 //x2=79.895 //y2=0.72
cc_9587 ( N_GND_c_17087_n N_noxref_63_c_19072_n ) capacitor c=0.0358997f \
 //x=82.09 //y=0.175 //x2=79.895 //y2=0.72
cc_9588 ( N_GND_c_17064_n N_noxref_63_M48_noxref_s ) capacitor c=0.00439789f \
 //x=78.44 //y=0.175 //x2=77.905 //y2=0.555
cc_9589 ( N_GND_c_17070_n N_noxref_63_M48_noxref_s ) capacitor c=0.0173062f \
 //x=78.525 //y=1.015 //x2=77.905 //y2=0.555
cc_9590 ( N_GND_c_17141_n N_noxref_63_M48_noxref_s ) capacitor c=0.00683407f \
 //x=83.25 //y=0.175 //x2=77.905 //y2=0.555
cc_9591 ( N_GND_c_17074_n N_noxref_63_M48_noxref_s ) capacitor c=0.00988958f \
 //x=78.525 //y=1.145 //x2=77.905 //y2=0.555
cc_9592 ( N_GND_c_17087_n N_noxref_63_M48_noxref_s ) capacitor c=0.027328f \
 //x=82.09 //y=0.175 //x2=77.905 //y2=0.555
cc_9593 ( N_GND_c_17093_n N_noxref_63_M48_noxref_s ) capacitor c=0.0634633f \
 //x=77.45 //y=0.175 //x2=77.905 //y2=0.555
cc_9594 ( N_GND_c_17214_n N_noxref_63_M48_noxref_s ) capacitor c=0.00166413f \
 //x=82.26 //y=0.175 //x2=77.905 //y2=0.555
cc_9595 ( N_GND_M48_noxref_d N_noxref_63_M48_noxref_s ) capacitor c=0.0271316f \
 //x=78.335 //y=1.055 //x2=77.905 //y2=0.555
cc_9596 ( N_GND_c_17141_n N_noxref_64_c_19117_n ) capacitor c=0.0011329f \
 //x=83.25 //y=0.175 //x2=83.735 //y2=1.77
cc_9597 ( N_GND_c_16607_n N_noxref_64_c_19117_n ) capacitor c=7.40908e-19 \
 //x=88.165 //y=0.175 //x2=83.735 //y2=1.77
cc_9598 ( N_GND_c_17200_n N_noxref_64_c_19117_n ) capacitor c=0.00349867f \
 //x=83.335 //y=1.145 //x2=83.735 //y2=1.77
cc_9599 ( N_GND_c_17213_n N_noxref_64_c_19117_n ) capacitor c=0.00392232f \
 //x=86.9 //y=0.175 //x2=83.735 //y2=1.77
cc_9600 ( N_GND_M51_noxref_d N_noxref_64_c_19117_n ) capacitor c=0.00578031f \
 //x=83.145 //y=1.055 //x2=83.735 //y2=1.77
cc_9601 ( N_GND_c_17197_n N_noxref_64_c_19146_n ) capacitor c=0.0169052f \
 //x=83.335 //y=1.015 //x2=83.82 //y2=0.805
cc_9602 ( N_GND_c_16607_n N_noxref_64_c_19146_n ) capacitor c=0.00439789f \
 //x=88.165 //y=0.175 //x2=83.82 //y2=0.805
cc_9603 ( N_GND_c_17213_n N_noxref_64_c_19146_n ) capacitor c=0.0141638f \
 //x=86.9 //y=0.175 //x2=83.82 //y2=0.805
cc_9604 ( N_GND_c_17214_n N_noxref_64_c_19146_n ) capacitor c=0.00322478f \
 //x=82.26 //y=0.175 //x2=83.82 //y2=0.805
cc_9605 ( N_GND_c_16607_n N_noxref_64_c_19128_n ) capacitor c=0.0123291f \
 //x=88.165 //y=0.175 //x2=84.705 //y2=0.72
cc_9606 ( N_GND_c_17213_n N_noxref_64_c_19128_n ) capacitor c=0.0361346f \
 //x=86.9 //y=0.175 //x2=84.705 //y2=0.72
cc_9607 ( N_GND_c_17141_n N_noxref_64_M51_noxref_s ) capacitor c=0.00439789f \
 //x=83.25 //y=0.175 //x2=82.715 //y2=0.555
cc_9608 ( N_GND_c_17197_n N_noxref_64_M51_noxref_s ) capacitor c=0.0173062f \
 //x=83.335 //y=1.015 //x2=82.715 //y2=0.555
cc_9609 ( N_GND_c_16607_n N_noxref_64_M51_noxref_s ) capacitor c=0.0044479f \
 //x=88.165 //y=0.175 //x2=82.715 //y2=0.555
cc_9610 ( N_GND_c_17200_n N_noxref_64_M51_noxref_s ) capacitor c=0.00988958f \
 //x=83.335 //y=1.145 //x2=82.715 //y2=0.555
cc_9611 ( N_GND_c_17213_n N_noxref_64_M51_noxref_s ) capacitor c=0.0273693f \
 //x=86.9 //y=0.175 //x2=82.715 //y2=0.555
cc_9612 ( N_GND_c_17214_n N_noxref_64_M51_noxref_s ) capacitor c=0.0634633f \
 //x=82.26 //y=0.175 //x2=82.715 //y2=0.555
cc_9613 ( N_GND_c_16635_n N_noxref_64_M51_noxref_s ) capacitor c=0.00166451f \
 //x=87.07 //y=0.175 //x2=82.715 //y2=0.555
cc_9614 ( N_GND_M51_noxref_d N_noxref_64_M51_noxref_s ) capacitor c=0.0271316f \
 //x=83.145 //y=1.055 //x2=82.715 //y2=0.555
cc_9615 ( N_GND_c_16607_n N_noxref_65_c_19179_n ) capacitor c=9.536e-19 \
 //x=88.165 //y=0.175 //x2=88.65 //y2=1.76
cc_9616 ( N_GND_c_16608_n N_noxref_65_c_19179_n ) capacitor c=0.0049241f \
 //x=88.25 //y=1.015 //x2=88.65 //y2=1.76
cc_9617 ( N_GND_c_17290_n N_noxref_65_c_19179_n ) capacitor c=7.45647e-19 \
 //x=91.495 //y=0.175 //x2=88.65 //y2=1.76
cc_9618 ( N_GND_c_16628_n N_noxref_65_c_19179_n ) capacitor c=0.00427835f \
 //x=90.23 //y=0.175 //x2=88.65 //y2=1.76
cc_9619 ( N_GND_M54_noxref_d N_noxref_65_c_19179_n ) capacitor c=0.00579662f \
 //x=88.06 //y=1.045 //x2=88.65 //y2=1.76
cc_9620 ( N_GND_c_16608_n N_noxref_65_c_19223_n ) capacitor c=0.0120153f \
 //x=88.25 //y=1.015 //x2=88.735 //y2=0.795
cc_9621 ( N_GND_c_17290_n N_noxref_65_c_19223_n ) capacitor c=0.00395814f \
 //x=91.495 //y=0.175 //x2=88.735 //y2=0.795
cc_9622 ( N_GND_c_16628_n N_noxref_65_c_19223_n ) capacitor c=0.0147555f \
 //x=90.23 //y=0.175 //x2=88.735 //y2=0.795
cc_9623 ( N_GND_c_16635_n N_noxref_65_c_19223_n ) capacitor c=0.00283186f \
 //x=87.07 //y=0.175 //x2=88.735 //y2=0.795
cc_9624 ( N_GND_c_16641_n N_noxref_65_c_19223_n ) capacitor c=2.99356e-19 \
 //x=90.4 //y=0.175 //x2=88.735 //y2=0.795
cc_9625 ( N_GND_c_16635_n N_noxref_65_c_19187_n ) capacitor c=2.89348e-19 \
 //x=87.07 //y=0.175 //x2=88.735 //y2=1.675
cc_9626 ( N_GND_c_17290_n N_noxref_65_c_19194_n ) capacitor c=0.0109835f \
 //x=91.495 //y=0.175 //x2=89.62 //y2=0.71
cc_9627 ( N_GND_c_16628_n N_noxref_65_c_19194_n ) capacitor c=0.0375489f \
 //x=90.23 //y=0.175 //x2=89.62 //y2=0.71
cc_9628 ( N_GND_c_17290_n N_noxref_65_c_19231_n ) capacitor c=0.0045077f \
 //x=91.495 //y=0.175 //x2=89.705 //y2=0.795
cc_9629 ( N_GND_c_16628_n N_noxref_65_c_19231_n ) capacitor c=0.0144994f \
 //x=90.23 //y=0.175 //x2=89.705 //y2=0.795
cc_9630 ( N_GND_c_16641_n N_noxref_65_c_19231_n ) capacitor c=0.054088f \
 //x=90.4 //y=0.175 //x2=89.705 //y2=0.795
cc_9631 ( N_GND_c_16607_n N_noxref_65_M54_noxref_s ) capacitor c=0.00257812f \
 //x=88.165 //y=0.175 //x2=87.63 //y2=0.545
cc_9632 ( N_GND_c_16608_n N_noxref_65_M54_noxref_s ) capacitor c=0.0289775f \
 //x=88.25 //y=1.015 //x2=87.63 //y2=0.545
cc_9633 ( N_GND_c_16628_n N_noxref_65_M54_noxref_s ) capacitor c=0.0146671f \
 //x=90.23 //y=0.175 //x2=87.63 //y2=0.545
cc_9634 ( N_GND_c_16635_n N_noxref_65_M54_noxref_s ) capacitor c=0.0536311f \
 //x=87.07 //y=0.175 //x2=87.63 //y2=0.545
cc_9635 ( N_GND_c_16641_n N_noxref_65_M54_noxref_s ) capacitor c=0.00250794f \
 //x=90.4 //y=0.175 //x2=87.63 //y2=0.545
cc_9636 ( N_GND_M54_noxref_d N_noxref_65_M54_noxref_s ) capacitor c=0.0271433f \
 //x=88.06 //y=1.045 //x2=87.63 //y2=0.545
cc_9637 ( N_GND_c_17290_n N_noxref_66_c_19243_n ) capacitor c=0.0010065f \
 //x=91.495 //y=0.175 //x2=91.98 //y2=1.76
cc_9638 ( N_GND_c_16615_n N_noxref_66_c_19243_n ) capacitor c=0.00444849f \
 //x=91.58 //y=1.015 //x2=91.98 //y2=1.76
cc_9639 ( N_GND_c_17291_n N_noxref_66_c_19243_n ) capacitor c=7.45647e-19 \
 //x=94.825 //y=0.175 //x2=91.98 //y2=1.76
cc_9640 ( N_GND_c_16629_n N_noxref_66_c_19243_n ) capacitor c=0.00356881f \
 //x=93.56 //y=0.175 //x2=91.98 //y2=1.76
cc_9641 ( N_GND_M56_noxref_d N_noxref_66_c_19243_n ) capacitor c=0.00750663f \
 //x=91.39 //y=1.045 //x2=91.98 //y2=1.76
cc_9642 ( N_GND_c_16615_n N_noxref_66_c_19283_n ) capacitor c=0.0120153f \
 //x=91.58 //y=1.015 //x2=92.065 //y2=0.795
cc_9643 ( N_GND_c_17291_n N_noxref_66_c_19283_n ) capacitor c=0.0045077f \
 //x=94.825 //y=0.175 //x2=92.065 //y2=0.795
cc_9644 ( N_GND_c_16629_n N_noxref_66_c_19283_n ) capacitor c=0.0144994f \
 //x=93.56 //y=0.175 //x2=92.065 //y2=0.795
cc_9645 ( N_GND_c_16641_n N_noxref_66_c_19283_n ) capacitor c=0.00226009f \
 //x=90.4 //y=0.175 //x2=92.065 //y2=0.795
cc_9646 ( N_GND_c_17321_n N_noxref_66_c_19283_n ) capacitor c=2.99356e-19 \
 //x=93.73 //y=0.175 //x2=92.065 //y2=0.795
cc_9647 ( N_GND_c_16641_n N_noxref_66_c_19250_n ) capacitor c=2.91423e-19 \
 //x=90.4 //y=0.175 //x2=92.065 //y2=1.675
cc_9648 ( N_GND_c_17291_n N_noxref_66_c_19258_n ) capacitor c=0.0122738f \
 //x=94.825 //y=0.175 //x2=92.95 //y2=0.71
cc_9649 ( N_GND_c_16629_n N_noxref_66_c_19258_n ) capacitor c=0.0374965f \
 //x=93.56 //y=0.175 //x2=92.95 //y2=0.71
cc_9650 ( N_GND_c_17291_n N_noxref_66_c_19291_n ) capacitor c=0.00251499f \
 //x=94.825 //y=0.175 //x2=93.035 //y2=0.795
cc_9651 ( N_GND_c_16629_n N_noxref_66_c_19291_n ) capacitor c=0.0144994f \
 //x=93.56 //y=0.175 //x2=93.035 //y2=0.795
cc_9652 ( N_GND_c_17321_n N_noxref_66_c_19291_n ) capacitor c=0.0528124f \
 //x=93.73 //y=0.175 //x2=93.035 //y2=0.795
cc_9653 ( N_GND_c_17290_n N_noxref_66_M56_noxref_s ) capacitor c=0.0045077f \
 //x=91.495 //y=0.175 //x2=90.96 //y2=0.545
cc_9654 ( N_GND_c_16615_n N_noxref_66_M56_noxref_s ) capacitor c=0.025502f \
 //x=91.58 //y=1.015 //x2=90.96 //y2=0.545
cc_9655 ( N_GND_c_16629_n N_noxref_66_M56_noxref_s ) capacitor c=0.0144994f \
 //x=93.56 //y=0.175 //x2=90.96 //y2=0.545
cc_9656 ( N_GND_c_16641_n N_noxref_66_M56_noxref_s ) capacitor c=0.0536425f \
 //x=90.4 //y=0.175 //x2=90.96 //y2=0.545
cc_9657 ( N_GND_c_17321_n N_noxref_66_M56_noxref_s ) capacitor c=0.00291802f \
 //x=93.73 //y=0.175 //x2=90.96 //y2=0.545
cc_9658 ( N_GND_M56_noxref_d N_noxref_66_M56_noxref_s ) capacitor c=0.0296369f \
 //x=91.39 //y=1.045 //x2=90.96 //y2=0.545
cc_9659 ( N_GND_c_17291_n N_noxref_67_c_19308_n ) capacitor c=9.5216e-19 \
 //x=94.825 //y=0.175 //x2=95.31 //y2=1.76
cc_9660 ( N_GND_c_17294_n N_noxref_67_c_19308_n ) capacitor c=0.0048201f \
 //x=94.91 //y=1.02 //x2=95.31 //y2=1.76
cc_9661 ( N_GND_c_17344_n N_noxref_67_c_19308_n ) capacitor c=0.00204479f \
 //x=98.54 //y=0.18 //x2=95.31 //y2=1.76
cc_9662 ( N_GND_c_17306_n N_noxref_67_c_19308_n ) capacitor c=0.00357558f \
 //x=96.89 //y=0.175 //x2=95.31 //y2=1.76
cc_9663 ( N_GND_M58_noxref_d N_noxref_67_c_19308_n ) capacitor c=0.00579662f \
 //x=94.72 //y=1.045 //x2=95.31 //y2=1.76
cc_9664 ( N_GND_c_17294_n N_noxref_67_c_19352_n ) capacitor c=0.0167642f \
 //x=94.91 //y=1.02 //x2=95.395 //y2=0.795
cc_9665 ( N_GND_c_17344_n N_noxref_67_c_19352_n ) capacitor c=0.00310354f \
 //x=98.54 //y=0.18 //x2=95.395 //y2=0.795
cc_9666 ( N_GND_c_17306_n N_noxref_67_c_19352_n ) capacitor c=0.0144994f \
 //x=96.89 //y=0.175 //x2=95.395 //y2=0.795
cc_9667 ( N_GND_c_17321_n N_noxref_67_c_19352_n ) capacitor c=0.00225073f \
 //x=93.73 //y=0.175 //x2=95.395 //y2=0.795
cc_9668 ( N_GND_c_17332_n N_noxref_67_c_19352_n ) capacitor c=2.21767e-19 \
 //x=97.06 //y=0.175 //x2=95.395 //y2=0.795
cc_9669 ( N_GND_c_17321_n N_noxref_67_c_19315_n ) capacitor c=2.86225e-19 \
 //x=93.73 //y=0.175 //x2=95.395 //y2=1.675
cc_9670 ( N_GND_c_17344_n N_noxref_67_c_19324_n ) capacitor c=0.00939457f \
 //x=98.54 //y=0.18 //x2=96.28 //y2=0.71
cc_9671 ( N_GND_c_17306_n N_noxref_67_c_19324_n ) capacitor c=0.0375173f \
 //x=96.89 //y=0.175 //x2=96.28 //y2=0.71
cc_9672 ( N_GND_c_17344_n N_noxref_67_c_19360_n ) capacitor c=0.00326972f \
 //x=98.54 //y=0.18 //x2=96.365 //y2=0.795
cc_9673 ( N_GND_c_17306_n N_noxref_67_c_19360_n ) capacitor c=0.0144881f \
 //x=96.89 //y=0.175 //x2=96.365 //y2=0.795
cc_9674 ( N_GND_c_18126_p N_noxref_67_c_19360_n ) capacitor c=0.00211385f \
 //x=97.69 //y=0.63 //x2=96.365 //y2=0.795
cc_9675 ( N_GND_c_17332_n N_noxref_67_c_19360_n ) capacitor c=0.0406122f \
 //x=97.06 //y=0.175 //x2=96.365 //y2=0.795
cc_9676 ( N_GND_c_17291_n N_noxref_67_M58_noxref_s ) capacitor c=0.00251499f \
 //x=94.825 //y=0.175 //x2=94.29 //y2=0.545
cc_9677 ( N_GND_c_17294_n N_noxref_67_M58_noxref_s ) capacitor c=0.0250583f \
 //x=94.91 //y=1.02 //x2=94.29 //y2=0.545
cc_9678 ( N_GND_c_17306_n N_noxref_67_M58_noxref_s ) capacitor c=0.0144994f \
 //x=96.89 //y=0.175 //x2=94.29 //y2=0.545
cc_9679 ( N_GND_c_17321_n N_noxref_67_M58_noxref_s ) capacitor c=0.0528916f \
 //x=93.73 //y=0.175 //x2=94.29 //y2=0.545
cc_9680 ( N_GND_c_17332_n N_noxref_67_M58_noxref_s ) capacitor c=0.00580588f \
 //x=97.06 //y=0.175 //x2=94.29 //y2=0.545
cc_9681 ( N_GND_M58_noxref_d N_noxref_67_M58_noxref_s ) capacitor c=0.0272383f \
 //x=94.72 //y=1.045 //x2=94.29 //y2=0.545
cc_9682 ( N_GND_M60_noxref_s N_noxref_67_M58_noxref_s ) capacitor \
 c=0.00317066f //x=97.555 //y=0.55 //x2=94.29 //y2=0.545
cc_9683 ( N_noxref_65_M54_noxref_s N_noxref_66_c_19242_n ) capacitor \
 c=0.00220036f //x=87.63 //y=0.545 //x2=91.095 //y2=1.675
cc_9684 ( N_noxref_65_c_19231_n N_noxref_66_M56_noxref_s ) capacitor \
 c=0.00220036f //x=89.705 //y=0.795 //x2=90.96 //y2=0.545
cc_9685 ( N_noxref_66_M56_noxref_s N_noxref_67_c_19304_n ) capacitor \
 c=0.00244927f //x=90.96 //y=0.545 //x2=94.425 //y2=1.675
cc_9686 ( N_noxref_66_c_19291_n N_noxref_67_M58_noxref_s ) capacitor \
 c=0.00244927f //x=93.035 //y=0.795 //x2=94.29 //y2=0.545
