// File: DFFQX1.spi.DFFQX1.pxi
// Created: Tue Apr 29 10:39:36 2025
//
simulator lang=spectre
x_PM_DFFQX1\%GND ( GND N_GND_c_8_p N_GND_c_121_p N_GND_c_1_p N_GND_c_9_p \
 N_GND_c_10_p N_GND_c_11_p N_GND_c_16_p N_GND_c_30_p N_GND_c_38_p N_GND_c_51_p \
 N_GND_c_75_p N_GND_c_82_p N_GND_c_99_p N_GND_c_2_p N_GND_c_3_p N_GND_c_4_p \
 N_GND_c_5_p N_GND_c_6_p N_GND_c_7_p N_GND_M0_noxref_d N_GND_M3_noxref_d \
 N_GND_M5_noxref_d N_GND_M7_noxref_d N_GND_M9_noxref_d N_GND_M11_noxref_d )  \
 PM_DFFQX1\%GND
x_PM_DFFQX1\%VDD ( VDD N_VDD_c_278_p N_VDD_c_270_n N_VDD_c_378_p N_VDD_c_367_p \
 N_VDD_c_293_p N_VDD_c_345_p N_VDD_c_346_p N_VDD_c_279_p N_VDD_c_280_p \
 N_VDD_c_348_p N_VDD_c_349_p N_VDD_c_291_p N_VDD_c_315_p N_VDD_c_351_p \
 N_VDD_c_352_p N_VDD_c_326_p N_VDD_c_371_p N_VDD_c_471_p N_VDD_c_472_p \
 N_VDD_c_396_p N_VDD_c_425_p N_VDD_c_474_p N_VDD_c_475_p N_VDD_c_454_p \
 N_VDD_c_513_p N_VDD_c_271_n N_VDD_c_272_n N_VDD_c_273_n N_VDD_c_274_n \
 N_VDD_c_275_n N_VDD_c_276_n N_VDD_M13_noxref_s N_VDD_M14_noxref_d \
 N_VDD_M16_noxref_d N_VDD_M18_noxref_d N_VDD_M19_noxref_s N_VDD_M20_noxref_d \
 N_VDD_M22_noxref_d N_VDD_M23_noxref_s N_VDD_M24_noxref_d N_VDD_M26_noxref_d \
 N_VDD_M27_noxref_s N_VDD_M28_noxref_d N_VDD_M30_noxref_d N_VDD_M31_noxref_s \
 N_VDD_M32_noxref_d N_VDD_M34_noxref_d N_VDD_M35_noxref_s N_VDD_M36_noxref_d \
 N_VDD_M38_noxref_d )  PM_DFFQX1\%VDD
x_PM_DFFQX1\%noxref_3 ( N_noxref_3_c_567_n N_noxref_3_c_572_n \
 N_noxref_3_c_573_n N_noxref_3_c_577_n N_noxref_3_c_578_n N_noxref_3_c_596_n \
 N_noxref_3_c_600_n N_noxref_3_c_602_n N_noxref_3_c_579_n N_noxref_3_c_794_p \
 N_noxref_3_c_580_n N_noxref_3_c_581_n N_noxref_3_c_781_p \
 N_noxref_3_M2_noxref_g N_noxref_3_M5_noxref_g N_noxref_3_M17_noxref_g \
 N_noxref_3_M18_noxref_g N_noxref_3_M23_noxref_g N_noxref_3_M24_noxref_g \
 N_noxref_3_c_668_p N_noxref_3_c_669_p N_noxref_3_c_670_p N_noxref_3_c_712_p \
 N_noxref_3_c_689_p N_noxref_3_c_714_p N_noxref_3_c_690_p N_noxref_3_c_582_n \
 N_noxref_3_c_584_n N_noxref_3_c_585_n N_noxref_3_c_586_n N_noxref_3_c_587_n \
 N_noxref_3_c_588_n N_noxref_3_c_589_n N_noxref_3_c_591_n N_noxref_3_c_656_p \
 N_noxref_3_c_673_p N_noxref_3_c_646_p N_noxref_3_c_619_n \
 N_noxref_3_M4_noxref_d N_noxref_3_M19_noxref_d N_noxref_3_M21_noxref_d )  \
 PM_DFFQX1\%noxref_3
x_PM_DFFQX1\%noxref_4 ( N_noxref_4_c_817_n N_noxref_4_c_821_n \
 N_noxref_4_c_838_n N_noxref_4_c_842_n N_noxref_4_c_844_n N_noxref_4_c_822_n \
 N_noxref_4_c_907_p N_noxref_4_c_823_n N_noxref_4_c_824_n N_noxref_4_c_934_p \
 N_noxref_4_M7_noxref_g N_noxref_4_M27_noxref_g N_noxref_4_M28_noxref_g \
 N_noxref_4_c_825_n N_noxref_4_c_827_n N_noxref_4_c_828_n N_noxref_4_c_829_n \
 N_noxref_4_c_830_n N_noxref_4_c_831_n N_noxref_4_c_832_n N_noxref_4_c_834_n \
 N_noxref_4_c_857_n N_noxref_4_M6_noxref_d N_noxref_4_M23_noxref_d \
 N_noxref_4_M25_noxref_d )  PM_DFFQX1\%noxref_4
x_PM_DFFQX1\%CLK ( N_CLK_c_970_n N_CLK_c_988_n CLK CLK CLK CLK CLK \
 N_CLK_c_967_n N_CLK_c_989_n N_CLK_c_1045_n N_CLK_c_968_n N_CLK_c_1022_n \
 N_CLK_c_1023_n N_CLK_c_1025_n N_CLK_c_992_n N_CLK_M1_noxref_g \
 N_CLK_M8_noxref_g N_CLK_M15_noxref_g N_CLK_M16_noxref_g N_CLK_M29_noxref_g \
 N_CLK_M30_noxref_g N_CLK_c_1131_p N_CLK_c_1133_p N_CLK_c_1166_p \
 N_CLK_c_1173_p N_CLK_c_1031_n N_CLK_c_1032_n N_CLK_c_1033_n N_CLK_c_1034_n \
 N_CLK_c_1037_n N_CLK_c_1054_n N_CLK_c_1057_n N_CLK_c_1059_n N_CLK_c_1101_p \
 N_CLK_c_1150_p N_CLK_c_1118_p N_CLK_c_1062_n N_CLK_c_1063_n N_CLK_c_1038_n \
 N_CLK_c_1064_n N_CLK_c_1125_p N_CLK_c_1066_n )  PM_DFFQX1\%CLK
x_PM_DFFQX1\%noxref_6 ( N_noxref_6_c_1263_n N_noxref_6_c_1264_n \
 N_noxref_6_c_1190_n N_noxref_6_c_1271_n N_noxref_6_c_1217_n \
 N_noxref_6_c_1221_n N_noxref_6_c_1223_n N_noxref_6_c_1227_n \
 N_noxref_6_c_1192_n N_noxref_6_c_1277_n N_noxref_6_c_1231_n \
 N_noxref_6_c_1193_n N_noxref_6_c_1194_n N_noxref_6_c_1329_n \
 N_noxref_6_c_1289_n N_noxref_6_M3_noxref_g N_noxref_6_M9_noxref_g \
 N_noxref_6_M19_noxref_g N_noxref_6_M20_noxref_g N_noxref_6_M31_noxref_g \
 N_noxref_6_M32_noxref_g N_noxref_6_c_1195_n N_noxref_6_c_1197_n \
 N_noxref_6_c_1198_n N_noxref_6_c_1199_n N_noxref_6_c_1200_n \
 N_noxref_6_c_1201_n N_noxref_6_c_1202_n N_noxref_6_c_1204_n \
 N_noxref_6_c_1205_n N_noxref_6_c_1207_n N_noxref_6_c_1208_n \
 N_noxref_6_c_1209_n N_noxref_6_c_1210_n N_noxref_6_c_1211_n \
 N_noxref_6_c_1212_n N_noxref_6_c_1214_n N_noxref_6_c_1246_n \
 N_noxref_6_c_1247_n N_noxref_6_M2_noxref_d N_noxref_6_M13_noxref_d \
 N_noxref_6_M15_noxref_d N_noxref_6_M17_noxref_d )  PM_DFFQX1\%noxref_6
x_PM_DFFQX1\%noxref_7 ( N_noxref_7_c_1458_n N_noxref_7_c_1448_n \
 N_noxref_7_c_1450_n N_noxref_7_M10_noxref_g N_noxref_7_M33_noxref_g \
 N_noxref_7_M34_noxref_g N_noxref_7_c_1468_n N_noxref_7_c_1471_n \
 N_noxref_7_c_1473_n N_noxref_7_c_1492_p N_noxref_7_c_1500_p \
 N_noxref_7_c_1486_p N_noxref_7_c_1476_n N_noxref_7_c_1477_n \
 N_noxref_7_c_1478_n N_noxref_7_c_1494_p N_noxref_7_c_1480_n )  \
 PM_DFFQX1\%noxref_7
x_PM_DFFQX1\%noxref_8 ( N_noxref_8_c_1534_n N_noxref_8_c_1538_n \
 N_noxref_8_c_1540_n N_noxref_8_c_1527_n N_noxref_8_c_1569_n \
 N_noxref_8_c_1528_n N_noxref_8_c_1577_n N_noxref_8_M10_noxref_d \
 N_noxref_8_M31_noxref_d N_noxref_8_M33_noxref_d )  PM_DFFQX1\%noxref_8
x_PM_DFFQX1\%noxref_9 ( N_noxref_9_c_1607_n N_noxref_9_c_1608_n \
 N_noxref_9_M11_noxref_g N_noxref_9_M35_noxref_g N_noxref_9_M36_noxref_g \
 N_noxref_9_c_1612_n N_noxref_9_c_1614_n N_noxref_9_c_1615_n \
 N_noxref_9_c_1616_n N_noxref_9_c_1617_n N_noxref_9_c_1618_n \
 N_noxref_9_c_1619_n N_noxref_9_c_1621_n N_noxref_9_c_1629_n )  \
 PM_DFFQX1\%noxref_9
x_PM_DFFQX1\%noxref_10 ( N_noxref_10_c_1678_n N_noxref_10_c_1679_n \
 N_noxref_10_c_1708_n N_noxref_10_c_1778_n N_noxref_10_c_1680_n \
 N_noxref_10_c_1722_n N_noxref_10_c_1681_n N_noxref_10_c_1780_n \
 N_noxref_10_c_1682_n N_noxref_10_c_1730_n N_noxref_10_c_1734_n \
 N_noxref_10_c_1736_n N_noxref_10_c_1684_n N_noxref_10_c_1920_n \
 N_noxref_10_c_1685_n N_noxref_10_c_1942_n N_noxref_10_c_1686_n \
 N_noxref_10_c_1875_n N_noxref_10_M0_noxref_g N_noxref_10_M6_noxref_g \
 N_noxref_10_M12_noxref_g N_noxref_10_M13_noxref_g N_noxref_10_M14_noxref_g \
 N_noxref_10_M25_noxref_g N_noxref_10_M26_noxref_g N_noxref_10_M37_noxref_g \
 N_noxref_10_M38_noxref_g N_noxref_10_c_1688_n N_noxref_10_c_1690_n \
 N_noxref_10_c_1691_n N_noxref_10_c_1692_n N_noxref_10_c_1693_n \
 N_noxref_10_c_1694_n N_noxref_10_c_1695_n N_noxref_10_c_1697_n \
 N_noxref_10_c_1889_n N_noxref_10_c_1758_n N_noxref_10_c_1789_n \
 N_noxref_10_c_1792_n N_noxref_10_c_1794_n N_noxref_10_c_1826_n \
 N_noxref_10_c_1828_n N_noxref_10_c_1829_n N_noxref_10_c_1797_n \
 N_noxref_10_c_1798_n N_noxref_10_c_1950_n N_noxref_10_c_1953_n \
 N_noxref_10_c_1955_n N_noxref_10_c_1967_p N_noxref_10_c_1993_p \
 N_noxref_10_c_1979_p N_noxref_10_c_1958_n N_noxref_10_c_1959_n \
 N_noxref_10_c_1799_n N_noxref_10_c_1835_n N_noxref_10_c_1801_n \
 N_noxref_10_c_1960_n N_noxref_10_c_1984_p N_noxref_10_c_1962_n \
 N_noxref_10_M8_noxref_d N_noxref_10_M27_noxref_d N_noxref_10_M29_noxref_d )  \
 PM_DFFQX1\%noxref_10
x_PM_DFFQX1\%Q ( Q Q Q Q Q Q Q Q N_Q_c_2061_n N_Q_c_2065_n N_Q_c_2067_n \
 N_Q_c_2047_n N_Q_c_2133_p N_Q_c_2070_n N_Q_c_2114_n N_Q_c_2048_n N_Q_c_2049_n \
 N_Q_c_2050_n N_Q_c_2118_n N_Q_c_2071_n N_Q_c_2072_n N_Q_M12_noxref_d \
 N_Q_M35_noxref_d N_Q_M37_noxref_d )  PM_DFFQX1\%Q
x_PM_DFFQX1\%noxref_12 ( N_noxref_12_c_2170_n N_noxref_12_c_2144_n \
 N_noxref_12_c_2148_n N_noxref_12_c_2151_n N_noxref_12_c_2162_n \
 N_noxref_12_M0_noxref_s )  PM_DFFQX1\%noxref_12
x_PM_DFFQX1\%noxref_13 ( N_noxref_13_c_2192_n N_noxref_13_c_2194_n \
 N_noxref_13_c_2197_n N_noxref_13_c_2200_n N_noxref_13_c_2211_n \
 N_noxref_13_M1_noxref_d N_noxref_13_M2_noxref_s )  PM_DFFQX1\%noxref_13
x_PM_DFFQX1\%D ( D D D N_D_c_2246_n N_D_c_2248_n N_D_c_2247_n N_D_c_2266_n \
 N_D_M4_noxref_g N_D_M21_noxref_g N_D_M22_noxref_g N_D_c_2271_n N_D_c_2272_n \
 N_D_c_2273_n N_D_c_2274_n N_D_c_2276_n N_D_c_2277_n N_D_c_2279_n N_D_c_2280_n \
 N_D_c_2282_n N_D_c_2283_n N_D_c_2285_n )  PM_DFFQX1\%D
x_PM_DFFQX1\%noxref_15 ( N_noxref_15_c_2344_n N_noxref_15_c_2325_n \
 N_noxref_15_c_2329_n N_noxref_15_c_2332_n N_noxref_15_c_2333_n \
 N_noxref_15_c_2336_n N_noxref_15_M3_noxref_s )  PM_DFFQX1\%noxref_15
x_PM_DFFQX1\%noxref_16 ( N_noxref_16_c_2397_n N_noxref_16_c_2378_n \
 N_noxref_16_c_2382_n N_noxref_16_c_2385_n N_noxref_16_c_2386_n \
 N_noxref_16_c_2389_n N_noxref_16_M5_noxref_s )  PM_DFFQX1\%noxref_16
x_PM_DFFQX1\%noxref_17 ( N_noxref_17_c_2450_n N_noxref_17_c_2431_n \
 N_noxref_17_c_2435_n N_noxref_17_c_2438_n N_noxref_17_c_2439_n \
 N_noxref_17_c_2442_n N_noxref_17_M7_noxref_s )  PM_DFFQX1\%noxref_17
x_PM_DFFQX1\%noxref_18 ( N_noxref_18_c_2503_n N_noxref_18_c_2484_n \
 N_noxref_18_c_2488_n N_noxref_18_c_2491_n N_noxref_18_c_2492_n \
 N_noxref_18_c_2495_n N_noxref_18_M9_noxref_s )  PM_DFFQX1\%noxref_18
x_PM_DFFQX1\%noxref_19 ( N_noxref_19_c_2555_n N_noxref_19_c_2538_n \
 N_noxref_19_c_2542_n N_noxref_19_c_2545_n N_noxref_19_c_2546_n \
 N_noxref_19_c_2548_n N_noxref_19_M11_noxref_s )  PM_DFFQX1\%noxref_19
cc_1 ( N_GND_c_1_p N_VDD_c_270_n ) capacitor c=0.00989514f //x=1.175 //y=0.18 \
 //x2=1.175 //y2=7.58
cc_2 ( N_GND_c_2_p N_VDD_c_271_n ) capacitor c=0.00989514f //x=21.525 //y=0.18 \
 //x2=21.525 //y2=7.58
cc_3 ( N_GND_c_3_p N_VDD_c_272_n ) capacitor c=0.00500791f //x=5.245 //y=0.175 \
 //x2=5.245 //y2=7.585
cc_4 ( N_GND_c_4_p N_VDD_c_273_n ) capacitor c=0.00500791f //x=8.575 //y=0.175 \
 //x2=8.575 //y2=7.585
cc_5 ( N_GND_c_5_p N_VDD_c_274_n ) capacitor c=0.00500791f //x=11.905 \
 //y=0.175 //x2=11.905 //y2=7.585
cc_6 ( N_GND_c_6_p N_VDD_c_275_n ) capacitor c=0.00524733f //x=15.235 \
 //y=0.175 //x2=15.235 //y2=7.585
cc_7 ( N_GND_c_7_p N_VDD_c_276_n ) capacitor c=0.00500791f //x=18.565 \
 //y=0.175 //x2=18.565 //y2=7.585
cc_8 ( N_GND_c_8_p N_noxref_3_c_567_n ) capacitor c=0.0264725f //x=21.525 \
 //y=0.18 //x2=7.72 //y2=3.51
cc_9 ( N_GND_c_9_p N_noxref_3_c_567_n ) capacitor c=0.00174454f //x=5.075 \
 //y=0.175 //x2=7.72 //y2=3.51
cc_10 ( N_GND_c_10_p N_noxref_3_c_567_n ) capacitor c=0.00192522f //x=6.34 \
 //y=0.175 //x2=7.72 //y2=3.51
cc_11 ( N_GND_c_11_p N_noxref_3_c_567_n ) capacitor c=5.39382e-19 //x=8.405 \
 //y=0.175 //x2=7.72 //y2=3.51
cc_12 ( N_GND_c_3_p N_noxref_3_c_567_n ) capacitor c=0.00820859f //x=5.245 \
 //y=0.175 //x2=7.72 //y2=3.51
cc_13 ( N_GND_c_8_p N_noxref_3_c_572_n ) capacitor c=0.00172486f //x=21.525 \
 //y=0.18 //x2=3.88 //y2=3.51
cc_14 ( N_GND_c_8_p N_noxref_3_c_573_n ) capacitor c=0.0143882f //x=21.525 \
 //y=0.18 //x2=9.57 //y2=3.51
cc_15 ( N_GND_c_11_p N_noxref_3_c_573_n ) capacitor c=0.00157084f //x=8.405 \
 //y=0.175 //x2=9.57 //y2=3.51
cc_16 ( N_GND_c_16_p N_noxref_3_c_573_n ) capacitor c=0.00189777f //x=9.67 \
 //y=0.175 //x2=9.57 //y2=3.51
cc_17 ( N_GND_c_4_p N_noxref_3_c_573_n ) capacitor c=0.00820859f //x=8.575 \
 //y=0.175 //x2=9.57 //y2=3.51
cc_18 ( N_GND_c_8_p N_noxref_3_c_577_n ) capacitor c=0.00153456f //x=21.525 \
 //y=0.18 //x2=7.95 //y2=3.51
cc_19 ( N_GND_c_3_p N_noxref_3_c_578_n ) capacitor c=9.53263e-19 //x=5.245 \
 //y=0.175 //x2=3.765 //y2=2.26
cc_20 ( N_GND_c_4_p N_noxref_3_c_579_n ) capacitor c=0.0462817f //x=8.575 \
 //y=0.175 //x2=7.75 //y2=1.835
cc_21 ( N_GND_c_3_p N_noxref_3_c_580_n ) capacitor c=9.64732e-19 //x=5.245 \
 //y=0.175 //x2=7.835 //y2=3.51
cc_22 ( N_GND_c_4_p N_noxref_3_c_581_n ) capacitor c=0.0179404f //x=8.575 \
 //y=0.175 //x2=9.685 //y2=2.26
cc_23 ( N_GND_c_16_p N_noxref_3_c_582_n ) capacitor c=0.00135783f //x=9.67 \
 //y=0.175 //x2=9.49 //y2=1.045
cc_24 ( N_GND_M5_noxref_d N_noxref_3_c_582_n ) capacitor c=0.00220047f \
 //x=9.565 //y=1.045 //x2=9.49 //y2=1.045
cc_25 ( N_GND_M5_noxref_d N_noxref_3_c_584_n ) capacitor c=0.00255985f \
 //x=9.565 //y=1.045 //x2=9.49 //y2=1.39
cc_26 ( N_GND_c_4_p N_noxref_3_c_585_n ) capacitor c=0.0018059f //x=8.575 \
 //y=0.175 //x2=9.49 //y2=1.7
cc_27 ( N_GND_c_4_p N_noxref_3_c_586_n ) capacitor c=0.0114883f //x=8.575 \
 //y=0.175 //x2=9.49 //y2=2.095
cc_28 ( N_GND_M5_noxref_d N_noxref_3_c_587_n ) capacitor c=0.0131374f \
 //x=9.565 //y=1.045 //x2=9.865 //y2=0.89
cc_29 ( N_GND_M5_noxref_d N_noxref_3_c_588_n ) capacitor c=0.00193146f \
 //x=9.565 //y=1.045 //x2=9.865 //y2=1.545
cc_30 ( N_GND_c_30_p N_noxref_3_c_589_n ) capacitor c=0.00131234f //x=11.735 \
 //y=0.175 //x2=10.02 //y2=1.045
cc_31 ( N_GND_M5_noxref_d N_noxref_3_c_589_n ) capacitor c=0.00257848f \
 //x=9.565 //y=1.045 //x2=10.02 //y2=1.045
cc_32 ( N_GND_M5_noxref_d N_noxref_3_c_591_n ) capacitor c=0.00255985f \
 //x=9.565 //y=1.045 //x2=10.02 //y2=1.39
cc_33 ( N_GND_c_3_p N_noxref_3_M4_noxref_d ) capacitor c=8.58106e-19 //x=5.245 \
 //y=0.175 //x2=7.205 //y2=1.085
cc_34 ( N_GND_c_4_p N_noxref_3_M4_noxref_d ) capacitor c=0.00616547f //x=8.575 \
 //y=0.175 //x2=7.205 //y2=1.085
cc_35 ( N_GND_M3_noxref_d N_noxref_3_M4_noxref_d ) capacitor c=0.00143464f \
 //x=6.235 //y=1.045 //x2=7.205 //y2=1.085
cc_36 ( N_GND_c_8_p N_noxref_4_c_817_n ) capacitor c=0.0143882f //x=21.525 \
 //y=0.18 //x2=12.9 //y2=3.51
cc_37 ( N_GND_c_30_p N_noxref_4_c_817_n ) capacitor c=0.00157084f //x=11.735 \
 //y=0.175 //x2=12.9 //y2=3.51
cc_38 ( N_GND_c_38_p N_noxref_4_c_817_n ) capacitor c=0.00189777f //x=13 \
 //y=0.175 //x2=12.9 //y2=3.51
cc_39 ( N_GND_c_5_p N_noxref_4_c_817_n ) capacitor c=0.00820859f //x=11.905 \
 //y=0.175 //x2=12.9 //y2=3.51
cc_40 ( N_GND_c_8_p N_noxref_4_c_821_n ) capacitor c=0.00174433f //x=21.525 \
 //y=0.18 //x2=11.28 //y2=3.51
cc_41 ( N_GND_c_5_p N_noxref_4_c_822_n ) capacitor c=0.0462817f //x=11.905 \
 //y=0.175 //x2=11.08 //y2=1.835
cc_42 ( N_GND_c_4_p N_noxref_4_c_823_n ) capacitor c=9.64732e-19 //x=8.575 \
 //y=0.175 //x2=11.165 //y2=3.51
cc_43 ( N_GND_c_5_p N_noxref_4_c_824_n ) capacitor c=0.0179404f //x=11.905 \
 //y=0.175 //x2=13.015 //y2=2.26
cc_44 ( N_GND_c_38_p N_noxref_4_c_825_n ) capacitor c=0.00135783f //x=13 \
 //y=0.175 //x2=12.82 //y2=1.045
cc_45 ( N_GND_M7_noxref_d N_noxref_4_c_825_n ) capacitor c=0.00220047f \
 //x=12.895 //y=1.045 //x2=12.82 //y2=1.045
cc_46 ( N_GND_M7_noxref_d N_noxref_4_c_827_n ) capacitor c=0.00255985f \
 //x=12.895 //y=1.045 //x2=12.82 //y2=1.39
cc_47 ( N_GND_c_5_p N_noxref_4_c_828_n ) capacitor c=0.0018059f //x=11.905 \
 //y=0.175 //x2=12.82 //y2=1.7
cc_48 ( N_GND_c_5_p N_noxref_4_c_829_n ) capacitor c=0.0114883f //x=11.905 \
 //y=0.175 //x2=12.82 //y2=2.095
cc_49 ( N_GND_M7_noxref_d N_noxref_4_c_830_n ) capacitor c=0.0131374f \
 //x=12.895 //y=1.045 //x2=13.195 //y2=0.89
cc_50 ( N_GND_M7_noxref_d N_noxref_4_c_831_n ) capacitor c=0.00193146f \
 //x=12.895 //y=1.045 //x2=13.195 //y2=1.545
cc_51 ( N_GND_c_51_p N_noxref_4_c_832_n ) capacitor c=0.00131234f //x=15.065 \
 //y=0.175 //x2=13.35 //y2=1.045
cc_52 ( N_GND_M7_noxref_d N_noxref_4_c_832_n ) capacitor c=0.00257848f \
 //x=12.895 //y=1.045 //x2=13.35 //y2=1.045
cc_53 ( N_GND_M7_noxref_d N_noxref_4_c_834_n ) capacitor c=0.00255985f \
 //x=12.895 //y=1.045 //x2=13.35 //y2=1.39
cc_54 ( N_GND_c_4_p N_noxref_4_M6_noxref_d ) capacitor c=8.58106e-19 //x=8.575 \
 //y=0.175 //x2=10.535 //y2=1.085
cc_55 ( N_GND_c_5_p N_noxref_4_M6_noxref_d ) capacitor c=0.00616547f \
 //x=11.905 //y=0.175 //x2=10.535 //y2=1.085
cc_56 ( N_GND_M5_noxref_d N_noxref_4_M6_noxref_d ) capacitor c=0.00143464f \
 //x=9.565 //y=1.045 //x2=10.535 //y2=1.085
cc_57 ( N_GND_c_1_p N_CLK_c_967_n ) capacitor c=7.65588e-19 //x=1.175 //y=0.18 \
 //x2=2.655 //y2=2.26
cc_58 ( N_GND_c_5_p N_CLK_c_968_n ) capacitor c=9.2064e-19 //x=11.905 \
 //y=0.175 //x2=13.755 //y2=2.26
cc_59 ( N_GND_c_6_p N_CLK_c_968_n ) capacitor c=9.53263e-19 //x=15.235 \
 //y=0.175 //x2=13.755 //y2=2.26
cc_60 ( N_GND_c_8_p N_noxref_6_c_1190_n ) capacitor c=0.0468318f //x=21.525 \
 //y=0.18 //x2=16.23 //y2=3.88
cc_61 ( N_GND_c_6_p N_noxref_6_c_1190_n ) capacitor c=0.00533026f //x=15.235 \
 //y=0.175 //x2=16.23 //y2=3.88
cc_62 ( N_GND_c_3_p N_noxref_6_c_1192_n ) capacitor c=0.0459932f //x=5.245 \
 //y=0.175 //x2=4.42 //y2=1.845
cc_63 ( N_GND_c_3_p N_noxref_6_c_1193_n ) capacitor c=0.0179404f //x=5.245 \
 //y=0.175 //x2=6.355 //y2=2.26
cc_64 ( N_GND_c_6_p N_noxref_6_c_1194_n ) capacitor c=0.0179404f //x=15.235 \
 //y=0.175 //x2=16.345 //y2=2.26
cc_65 ( N_GND_c_10_p N_noxref_6_c_1195_n ) capacitor c=0.00135783f //x=6.34 \
 //y=0.175 //x2=6.16 //y2=1.045
cc_66 ( N_GND_M3_noxref_d N_noxref_6_c_1195_n ) capacitor c=0.00220047f \
 //x=6.235 //y=1.045 //x2=6.16 //y2=1.045
cc_67 ( N_GND_M3_noxref_d N_noxref_6_c_1197_n ) capacitor c=0.00255985f \
 //x=6.235 //y=1.045 //x2=6.16 //y2=1.39
cc_68 ( N_GND_c_3_p N_noxref_6_c_1198_n ) capacitor c=0.00189421f //x=5.245 \
 //y=0.175 //x2=6.16 //y2=1.7
cc_69 ( N_GND_c_3_p N_noxref_6_c_1199_n ) capacitor c=0.0114883f //x=5.245 \
 //y=0.175 //x2=6.16 //y2=2.095
cc_70 ( N_GND_M3_noxref_d N_noxref_6_c_1200_n ) capacitor c=0.0131374f \
 //x=6.235 //y=1.045 //x2=6.535 //y2=0.89
cc_71 ( N_GND_M3_noxref_d N_noxref_6_c_1201_n ) capacitor c=0.00193146f \
 //x=6.235 //y=1.045 //x2=6.535 //y2=1.545
cc_72 ( N_GND_c_11_p N_noxref_6_c_1202_n ) capacitor c=0.00131234f //x=8.405 \
 //y=0.175 //x2=6.69 //y2=1.045
cc_73 ( N_GND_M3_noxref_d N_noxref_6_c_1202_n ) capacitor c=0.00257848f \
 //x=6.235 //y=1.045 //x2=6.69 //y2=1.045
cc_74 ( N_GND_M3_noxref_d N_noxref_6_c_1204_n ) capacitor c=0.00255985f \
 //x=6.235 //y=1.045 //x2=6.69 //y2=1.39
cc_75 ( N_GND_c_75_p N_noxref_6_c_1205_n ) capacitor c=0.00135783f //x=16.33 \
 //y=0.175 //x2=16.15 //y2=1.045
cc_76 ( N_GND_M9_noxref_d N_noxref_6_c_1205_n ) capacitor c=0.00220047f \
 //x=16.225 //y=1.045 //x2=16.15 //y2=1.045
cc_77 ( N_GND_M9_noxref_d N_noxref_6_c_1207_n ) capacitor c=0.00255985f \
 //x=16.225 //y=1.045 //x2=16.15 //y2=1.39
cc_78 ( N_GND_c_6_p N_noxref_6_c_1208_n ) capacitor c=0.0018059f //x=15.235 \
 //y=0.175 //x2=16.15 //y2=1.7
cc_79 ( N_GND_c_6_p N_noxref_6_c_1209_n ) capacitor c=0.0114883f //x=15.235 \
 //y=0.175 //x2=16.15 //y2=2.095
cc_80 ( N_GND_M9_noxref_d N_noxref_6_c_1210_n ) capacitor c=0.0131374f \
 //x=16.225 //y=1.045 //x2=16.525 //y2=0.89
cc_81 ( N_GND_M9_noxref_d N_noxref_6_c_1211_n ) capacitor c=0.00193146f \
 //x=16.225 //y=1.045 //x2=16.525 //y2=1.545
cc_82 ( N_GND_c_82_p N_noxref_6_c_1212_n ) capacitor c=0.00131234f //x=18.395 \
 //y=0.175 //x2=16.68 //y2=1.045
cc_83 ( N_GND_M9_noxref_d N_noxref_6_c_1212_n ) capacitor c=0.00257848f \
 //x=16.225 //y=1.045 //x2=16.68 //y2=1.045
cc_84 ( N_GND_M9_noxref_d N_noxref_6_c_1214_n ) capacitor c=0.00255985f \
 //x=16.225 //y=1.045 //x2=16.68 //y2=1.39
cc_85 ( N_GND_c_3_p N_noxref_6_M2_noxref_d ) capacitor c=0.00591582f //x=5.245 \
 //y=0.175 //x2=3.83 //y2=1.095
cc_86 ( N_GND_c_6_p N_noxref_7_c_1448_n ) capacitor c=9.2064e-19 //x=15.235 \
 //y=0.175 //x2=17.085 //y2=2.26
cc_87 ( N_GND_c_7_p N_noxref_7_c_1448_n ) capacitor c=9.53263e-19 //x=18.565 \
 //y=0.175 //x2=17.085 //y2=2.26
cc_88 ( N_GND_c_8_p N_noxref_7_c_1450_n ) capacitor c=0.00252744f //x=21.525 \
 //y=0.18 //x2=17.085 //y2=3.88
cc_89 ( N_GND_c_7_p N_noxref_8_c_1527_n ) capacitor c=0.0462817f //x=18.565 \
 //y=0.175 //x2=17.74 //y2=1.835
cc_90 ( N_GND_c_8_p N_noxref_8_c_1528_n ) capacitor c=0.00292987f //x=21.525 \
 //y=0.18 //x2=17.825 //y2=3.51
cc_91 ( N_GND_c_82_p N_noxref_8_c_1528_n ) capacitor c=6.84331e-19 //x=18.395 \
 //y=0.175 //x2=17.825 //y2=3.51
cc_92 ( N_GND_c_6_p N_noxref_8_c_1528_n ) capacitor c=9.64732e-19 //x=15.235 \
 //y=0.175 //x2=17.825 //y2=3.51
cc_93 ( N_GND_c_6_p N_noxref_8_M10_noxref_d ) capacitor c=8.58106e-19 \
 //x=15.235 //y=0.175 //x2=17.195 //y2=1.085
cc_94 ( N_GND_c_7_p N_noxref_8_M10_noxref_d ) capacitor c=0.00616547f \
 //x=18.565 //y=0.175 //x2=17.195 //y2=1.085
cc_95 ( N_GND_M9_noxref_d N_noxref_8_M10_noxref_d ) capacitor c=0.00143464f \
 //x=16.225 //y=1.045 //x2=17.195 //y2=1.085
cc_96 ( N_GND_c_7_p N_noxref_9_c_1607_n ) capacitor c=0.0179404f //x=18.565 \
 //y=0.175 //x2=19.675 //y2=2.26
cc_97 ( N_GND_c_8_p N_noxref_9_c_1608_n ) capacitor c=0.012768f //x=21.525 \
 //y=0.18 //x2=19.675 //y2=3.51
cc_98 ( N_GND_c_82_p N_noxref_9_c_1608_n ) capacitor c=8.02089e-19 //x=18.395 \
 //y=0.175 //x2=19.675 //y2=3.51
cc_99 ( N_GND_c_99_p N_noxref_9_c_1608_n ) capacitor c=0.00189777f //x=19.66 \
 //y=0.175 //x2=19.675 //y2=3.51
cc_100 ( N_GND_c_7_p N_noxref_9_c_1608_n ) capacitor c=0.00820859f //x=18.565 \
 //y=0.175 //x2=19.675 //y2=3.51
cc_101 ( N_GND_c_99_p N_noxref_9_c_1612_n ) capacitor c=0.00135783f //x=19.66 \
 //y=0.175 //x2=19.48 //y2=1.045
cc_102 ( N_GND_M11_noxref_d N_noxref_9_c_1612_n ) capacitor c=0.00220047f \
 //x=19.555 //y=1.045 //x2=19.48 //y2=1.045
cc_103 ( N_GND_M11_noxref_d N_noxref_9_c_1614_n ) capacitor c=0.00255985f \
 //x=19.555 //y=1.045 //x2=19.48 //y2=1.39
cc_104 ( N_GND_c_7_p N_noxref_9_c_1615_n ) capacitor c=0.0018059f //x=18.565 \
 //y=0.175 //x2=19.48 //y2=1.7
cc_105 ( N_GND_c_7_p N_noxref_9_c_1616_n ) capacitor c=0.0114883f //x=18.565 \
 //y=0.175 //x2=19.48 //y2=2.095
cc_106 ( N_GND_M11_noxref_d N_noxref_9_c_1617_n ) capacitor c=0.0131374f \
 //x=19.555 //y=1.045 //x2=19.855 //y2=0.89
cc_107 ( N_GND_M11_noxref_d N_noxref_9_c_1618_n ) capacitor c=0.00193146f \
 //x=19.555 //y=1.045 //x2=19.855 //y2=1.545
cc_108 ( N_GND_c_2_p N_noxref_9_c_1619_n ) capacitor c=0.00131234f //x=21.525 \
 //y=0.18 //x2=20.01 //y2=1.045
cc_109 ( N_GND_M11_noxref_d N_noxref_9_c_1619_n ) capacitor c=0.00257848f \
 //x=19.555 //y=1.045 //x2=20.01 //y2=1.045
cc_110 ( N_GND_M11_noxref_d N_noxref_9_c_1621_n ) capacitor c=0.00255985f \
 //x=19.555 //y=1.045 //x2=20.01 //y2=1.39
cc_111 ( N_GND_c_8_p N_noxref_10_c_1678_n ) capacitor c=0.0147352f //x=21.525 \
 //y=0.18 //x2=10.31 //y2=4.25
cc_112 ( N_GND_c_8_p N_noxref_10_c_1679_n ) capacitor c=0.0015897f //x=21.525 \
 //y=0.18 //x2=1.66 //y2=4.25
cc_113 ( N_GND_c_8_p N_noxref_10_c_1680_n ) capacitor c=0.0132783f //x=21.525 \
 //y=0.18 //x2=20.3 //y2=4.25
cc_114 ( N_GND_c_1_p N_noxref_10_c_1681_n ) capacitor c=0.0180363f //x=1.175 \
 //y=0.18 //x2=1.545 //y2=2.26
cc_115 ( N_GND_c_4_p N_noxref_10_c_1682_n ) capacitor c=9.2064e-19 //x=8.575 \
 //y=0.175 //x2=10.425 //y2=2.26
cc_116 ( N_GND_c_5_p N_noxref_10_c_1682_n ) capacitor c=9.53263e-19 //x=11.905 \
 //y=0.175 //x2=10.425 //y2=2.26
cc_117 ( N_GND_c_6_p N_noxref_10_c_1684_n ) capacitor c=0.0462817f //x=15.235 \
 //y=0.175 //x2=14.41 //y2=1.835
cc_118 ( N_GND_c_5_p N_noxref_10_c_1685_n ) capacitor c=9.64732e-19 //x=11.905 \
 //y=0.175 //x2=14.495 //y2=4.25
cc_119 ( N_GND_c_2_p N_noxref_10_c_1686_n ) capacitor c=9.94548e-19 //x=21.525 \
 //y=0.18 //x2=20.415 //y2=2.26
cc_120 ( N_GND_c_7_p N_noxref_10_c_1686_n ) capacitor c=9.2064e-19 //x=18.565 \
 //y=0.175 //x2=20.415 //y2=2.26
cc_121 ( N_GND_c_121_p N_noxref_10_c_1688_n ) capacitor c=0.00133465f \
 //x=1.425 //y=0.175 //x2=1.245 //y2=1.055
cc_122 ( N_GND_M0_noxref_d N_noxref_10_c_1688_n ) capacitor c=0.00211996f \
 //x=1.32 //y=1.055 //x2=1.245 //y2=1.055
cc_123 ( N_GND_M0_noxref_d N_noxref_10_c_1690_n ) capacitor c=0.00255985f \
 //x=1.32 //y=1.055 //x2=1.245 //y2=1.4
cc_124 ( N_GND_c_1_p N_noxref_10_c_1691_n ) capacitor c=0.00295461f //x=1.175 \
 //y=0.18 //x2=1.245 //y2=1.71
cc_125 ( N_GND_c_1_p N_noxref_10_c_1692_n ) capacitor c=0.0134214f //x=1.175 \
 //y=0.18 //x2=1.245 //y2=2.095
cc_126 ( N_GND_M0_noxref_d N_noxref_10_c_1693_n ) capacitor c=0.0131387f \
 //x=1.32 //y=1.055 //x2=1.62 //y2=0.9
cc_127 ( N_GND_M0_noxref_d N_noxref_10_c_1694_n ) capacitor c=0.00193165f \
 //x=1.32 //y=1.055 //x2=1.62 //y2=1.555
cc_128 ( N_GND_c_9_p N_noxref_10_c_1695_n ) capacitor c=0.00129623f //x=5.075 \
 //y=0.175 //x2=1.775 //y2=1.055
cc_129 ( N_GND_M0_noxref_d N_noxref_10_c_1695_n ) capacitor c=0.00257848f \
 //x=1.32 //y=1.055 //x2=1.775 //y2=1.055
cc_130 ( N_GND_M0_noxref_d N_noxref_10_c_1697_n ) capacitor c=0.00255985f \
 //x=1.32 //y=1.055 //x2=1.775 //y2=1.4
cc_131 ( N_GND_c_5_p N_noxref_10_M8_noxref_d ) capacitor c=8.58106e-19 \
 //x=11.905 //y=0.175 //x2=13.865 //y2=1.085
cc_132 ( N_GND_c_6_p N_noxref_10_M8_noxref_d ) capacitor c=0.00616547f \
 //x=15.235 //y=0.175 //x2=13.865 //y2=1.085
cc_133 ( N_GND_M7_noxref_d N_noxref_10_M8_noxref_d ) capacitor c=0.00143464f \
 //x=12.895 //y=1.045 //x2=13.865 //y2=1.085
cc_134 ( N_GND_c_2_p Q ) capacitor c=0.00946859f //x=21.525 //y=0.18 \
 //x2=21.21 //y2=2.4
cc_135 ( N_GND_c_2_p Q ) capacitor c=0.00946859f //x=21.525 //y=0.18 \
 //x2=21.21 //y2=2.77
cc_136 ( N_GND_c_8_p Q ) capacitor c=0.017483f //x=21.525 //y=0.18 //x2=21.21 \
 //y2=3.88
cc_137 ( N_GND_c_2_p N_Q_c_2047_n ) capacitor c=0.0229396f //x=21.525 //y=0.18 \
 //x2=21.07 //y2=1.835
cc_138 ( N_GND_c_7_p N_Q_c_2048_n ) capacitor c=9.64732e-19 //x=18.565 \
 //y=0.175 //x2=21.182 //y2=2.315
cc_139 ( N_GND_c_2_p N_Q_c_2049_n ) capacitor c=0.00778088f //x=21.525 \
 //y=0.18 //x2=21.182 //y2=2.685
cc_140 ( N_GND_c_2_p N_Q_c_2050_n ) capacitor c=0.00173978f //x=21.525 \
 //y=0.18 //x2=21.182 //y2=3.055
cc_141 ( N_GND_c_2_p N_Q_M12_noxref_d ) capacitor c=0.00618259f //x=21.525 \
 //y=0.18 //x2=20.525 //y2=1.085
cc_142 ( N_GND_c_7_p N_Q_M12_noxref_d ) capacitor c=8.58106e-19 //x=18.565 \
 //y=0.175 //x2=20.525 //y2=1.085
cc_143 ( N_GND_M11_noxref_d N_Q_M12_noxref_d ) capacitor c=0.00143464f \
 //x=19.555 //y=1.045 //x2=20.525 //y2=1.085
cc_144 ( N_GND_c_8_p N_noxref_12_c_2144_n ) capacitor c=0.00618966f //x=21.525 \
 //y=0.18 //x2=1.91 //y2=1.77
cc_145 ( N_GND_c_121_p N_noxref_12_c_2144_n ) capacitor c=0.00110148f \
 //x=1.425 //y=0.175 //x2=1.91 //y2=1.77
cc_146 ( N_GND_c_9_p N_noxref_12_c_2144_n ) capacitor c=0.0017942f //x=5.075 \
 //y=0.175 //x2=1.91 //y2=1.77
cc_147 ( N_GND_M0_noxref_d N_noxref_12_c_2144_n ) capacitor c=0.0089491f \
 //x=1.32 //y=1.055 //x2=1.91 //y2=1.77
cc_148 ( N_GND_c_8_p N_noxref_12_c_2148_n ) capacitor c=0.00576803f //x=21.525 \
 //y=0.18 //x2=1.995 //y2=0.805
cc_149 ( N_GND_c_9_p N_noxref_12_c_2148_n ) capacitor c=0.0140604f //x=5.075 \
 //y=0.175 //x2=1.995 //y2=0.805
cc_150 ( N_GND_M0_noxref_d N_noxref_12_c_2148_n ) capacitor c=0.033954f \
 //x=1.32 //y=1.055 //x2=1.995 //y2=0.805
cc_151 ( N_GND_c_8_p N_noxref_12_c_2151_n ) capacitor c=0.0139064f //x=21.525 \
 //y=0.18 //x2=2.88 //y2=0.72
cc_152 ( N_GND_c_9_p N_noxref_12_c_2151_n ) capacitor c=0.0356451f //x=5.075 \
 //y=0.175 //x2=2.88 //y2=0.72
cc_153 ( N_GND_c_2_p N_noxref_12_c_2151_n ) capacitor c=0.00177725f //x=21.525 \
 //y=0.18 //x2=2.88 //y2=0.72
cc_154 ( N_GND_c_8_p N_noxref_12_M0_noxref_s ) capacitor c=0.012556f \
 //x=21.525 //y=0.18 //x2=0.89 //y2=0.555
cc_155 ( N_GND_c_121_p N_noxref_12_M0_noxref_s ) capacitor c=0.0140604f \
 //x=1.425 //y=0.175 //x2=0.89 //y2=0.555
cc_156 ( N_GND_c_1_p N_noxref_12_M0_noxref_s ) capacitor c=0.0712607f \
 //x=1.175 //y=0.18 //x2=0.89 //y2=0.555
cc_157 ( N_GND_c_9_p N_noxref_12_M0_noxref_s ) capacitor c=0.0131642f \
 //x=5.075 //y=0.175 //x2=0.89 //y2=0.555
cc_158 ( N_GND_c_3_p N_noxref_12_M0_noxref_s ) capacitor c=3.31601e-19 \
 //x=5.245 //y=0.175 //x2=0.89 //y2=0.555
cc_159 ( N_GND_M0_noxref_d N_noxref_12_M0_noxref_s ) capacitor c=0.033718f \
 //x=1.32 //y=1.055 //x2=0.89 //y2=0.555
cc_160 ( N_GND_c_8_p N_noxref_13_c_2192_n ) capacitor c=0.00403022f //x=21.525 \
 //y=0.18 //x2=3.45 //y2=1.175
cc_161 ( N_GND_c_9_p N_noxref_13_c_2192_n ) capacitor c=0.00830851f //x=5.075 \
 //y=0.175 //x2=3.45 //y2=1.175
cc_162 ( N_GND_c_8_p N_noxref_13_c_2194_n ) capacitor c=0.00576803f //x=21.525 \
 //y=0.18 //x2=3.535 //y2=0.805
cc_163 ( N_GND_c_9_p N_noxref_13_c_2194_n ) capacitor c=0.0140604f //x=5.075 \
 //y=0.175 //x2=3.535 //y2=0.805
cc_164 ( N_GND_M0_noxref_d N_noxref_13_c_2194_n ) capacitor c=6.21394e-19 \
 //x=1.32 //y=1.055 //x2=3.535 //y2=0.805
cc_165 ( N_GND_c_8_p N_noxref_13_c_2197_n ) capacitor c=0.0118394f //x=21.525 \
 //y=0.18 //x2=4.42 //y2=0.72
cc_166 ( N_GND_c_9_p N_noxref_13_c_2197_n ) capacitor c=0.0365819f //x=5.075 \
 //y=0.175 //x2=4.42 //y2=0.72
cc_167 ( N_GND_c_2_p N_noxref_13_c_2197_n ) capacitor c=0.00189848f //x=21.525 \
 //y=0.18 //x2=4.42 //y2=0.72
cc_168 ( N_GND_c_8_p N_noxref_13_c_2200_n ) capacitor c=0.00287576f //x=21.525 \
 //y=0.18 //x2=4.505 //y2=0.805
cc_169 ( N_GND_c_9_p N_noxref_13_c_2200_n ) capacitor c=0.0142854f //x=5.075 \
 //y=0.175 //x2=4.505 //y2=0.805
cc_170 ( N_GND_c_3_p N_noxref_13_c_2200_n ) capacitor c=0.0404137f //x=5.245 \
 //y=0.175 //x2=4.505 //y2=0.805
cc_171 ( N_GND_M0_noxref_d N_noxref_13_M1_noxref_d ) capacitor c=0.00162435f \
 //x=1.32 //y=1.055 //x2=2.295 //y2=1.09
cc_172 ( N_GND_c_1_p N_noxref_13_M2_noxref_s ) capacitor c=8.16352e-19 \
 //x=1.175 //y=0.18 //x2=3.4 //y2=0.555
cc_173 ( N_GND_c_3_p N_noxref_13_M2_noxref_s ) capacitor c=0.00183576f \
 //x=5.245 //y=0.175 //x2=3.4 //y2=0.555
cc_174 ( N_GND_c_4_p D ) capacitor c=2.6258e-19 //x=8.575 //y=0.175 //x2=7.15 \
 //y2=2.77
cc_175 ( N_GND_c_3_p N_D_c_2246_n ) capacitor c=9.24372e-19 //x=5.245 \
 //y=0.175 //x2=7.095 //y2=2.485
cc_176 ( N_GND_c_4_p N_D_c_2247_n ) capacitor c=2.85898e-19 //x=8.575 \
 //y=0.175 //x2=7.122 //y2=2.685
cc_177 ( N_GND_c_8_p N_noxref_15_c_2325_n ) capacitor c=0.00552743f //x=21.525 \
 //y=0.18 //x2=6.825 //y2=1.76
cc_178 ( N_GND_c_10_p N_noxref_15_c_2325_n ) capacitor c=0.00113126f //x=6.34 \
 //y=0.175 //x2=6.825 //y2=1.76
cc_179 ( N_GND_c_11_p N_noxref_15_c_2325_n ) capacitor c=0.00182654f //x=8.405 \
 //y=0.175 //x2=6.825 //y2=1.76
cc_180 ( N_GND_M3_noxref_d N_noxref_15_c_2325_n ) capacitor c=0.00897333f \
 //x=6.235 //y=1.045 //x2=6.825 //y2=1.76
cc_181 ( N_GND_c_8_p N_noxref_15_c_2329_n ) capacitor c=0.00293362f //x=21.525 \
 //y=0.18 //x2=6.91 //y2=0.795
cc_182 ( N_GND_c_11_p N_noxref_15_c_2329_n ) capacitor c=0.0149577f //x=8.405 \
 //y=0.175 //x2=6.91 //y2=0.795
cc_183 ( N_GND_M3_noxref_d N_noxref_15_c_2329_n ) capacitor c=0.033812f \
 //x=6.235 //y=1.045 //x2=6.91 //y2=0.795
cc_184 ( N_GND_c_3_p N_noxref_15_c_2332_n ) capacitor c=2.91423e-19 //x=5.245 \
 //y=0.175 //x2=6.91 //y2=1.675
cc_185 ( N_GND_c_8_p N_noxref_15_c_2333_n ) capacitor c=0.0120428f //x=21.525 \
 //y=0.18 //x2=7.795 //y2=0.71
cc_186 ( N_GND_c_11_p N_noxref_15_c_2333_n ) capacitor c=0.0375777f //x=8.405 \
 //y=0.175 //x2=7.795 //y2=0.71
cc_187 ( N_GND_c_2_p N_noxref_15_c_2333_n ) capacitor c=0.00198885f //x=21.525 \
 //y=0.18 //x2=7.795 //y2=0.71
cc_188 ( N_GND_c_8_p N_noxref_15_c_2336_n ) capacitor c=0.00292583f //x=21.525 \
 //y=0.18 //x2=7.88 //y2=0.795
cc_189 ( N_GND_c_11_p N_noxref_15_c_2336_n ) capacitor c=0.0148875f //x=8.405 \
 //y=0.175 //x2=7.88 //y2=0.795
cc_190 ( N_GND_c_4_p N_noxref_15_c_2336_n ) capacitor c=0.0431718f //x=8.575 \
 //y=0.175 //x2=7.88 //y2=0.795
cc_191 ( N_GND_c_8_p N_noxref_15_M3_noxref_s ) capacitor c=0.00293362f \
 //x=21.525 //y=0.18 //x2=5.805 //y2=0.545
cc_192 ( N_GND_c_10_p N_noxref_15_M3_noxref_s ) capacitor c=0.0149577f \
 //x=6.34 //y=0.175 //x2=5.805 //y2=0.545
cc_193 ( N_GND_c_3_p N_noxref_15_M3_noxref_s ) capacitor c=0.0583534f \
 //x=5.245 //y=0.175 //x2=5.805 //y2=0.545
cc_194 ( N_GND_c_4_p N_noxref_15_M3_noxref_s ) capacitor c=0.00198043f \
 //x=8.575 //y=0.175 //x2=5.805 //y2=0.545
cc_195 ( N_GND_M3_noxref_d N_noxref_15_M3_noxref_s ) capacitor c=0.0334197f \
 //x=6.235 //y=1.045 //x2=5.805 //y2=0.545
cc_196 ( N_GND_c_8_p N_noxref_16_c_2378_n ) capacitor c=0.00556334f //x=21.525 \
 //y=0.18 //x2=10.155 //y2=1.76
cc_197 ( N_GND_c_16_p N_noxref_16_c_2378_n ) capacitor c=0.00113126f //x=9.67 \
 //y=0.175 //x2=10.155 //y2=1.76
cc_198 ( N_GND_c_30_p N_noxref_16_c_2378_n ) capacitor c=0.00181083f \
 //x=11.735 //y=0.175 //x2=10.155 //y2=1.76
cc_199 ( N_GND_M5_noxref_d N_noxref_16_c_2378_n ) capacitor c=0.00897392f \
 //x=9.565 //y=1.045 //x2=10.155 //y2=1.76
cc_200 ( N_GND_c_8_p N_noxref_16_c_2382_n ) capacitor c=0.00302993f //x=21.525 \
 //y=0.18 //x2=10.24 //y2=0.795
cc_201 ( N_GND_c_30_p N_noxref_16_c_2382_n ) capacitor c=0.014661f //x=11.735 \
 //y=0.175 //x2=10.24 //y2=0.795
cc_202 ( N_GND_M5_noxref_d N_noxref_16_c_2382_n ) capacitor c=0.033812f \
 //x=9.565 //y=1.045 //x2=10.24 //y2=0.795
cc_203 ( N_GND_c_4_p N_noxref_16_c_2385_n ) capacitor c=2.91423e-19 //x=8.575 \
 //y=0.175 //x2=10.24 //y2=1.675
cc_204 ( N_GND_c_8_p N_noxref_16_c_2386_n ) capacitor c=0.0123724f //x=21.525 \
 //y=0.18 //x2=11.125 //y2=0.71
cc_205 ( N_GND_c_30_p N_noxref_16_c_2386_n ) capacitor c=0.0373555f //x=11.735 \
 //y=0.175 //x2=11.125 //y2=0.71
cc_206 ( N_GND_c_2_p N_noxref_16_c_2386_n ) capacitor c=0.00198885f //x=21.525 \
 //y=0.18 //x2=11.125 //y2=0.71
cc_207 ( N_GND_c_8_p N_noxref_16_c_2389_n ) capacitor c=0.00292583f //x=21.525 \
 //y=0.18 //x2=11.21 //y2=0.795
cc_208 ( N_GND_c_30_p N_noxref_16_c_2389_n ) capacitor c=0.0148875f //x=11.735 \
 //y=0.175 //x2=11.21 //y2=0.795
cc_209 ( N_GND_c_5_p N_noxref_16_c_2389_n ) capacitor c=0.0431718f //x=11.905 \
 //y=0.175 //x2=11.21 //y2=0.795
cc_210 ( N_GND_c_8_p N_noxref_16_M5_noxref_s ) capacitor c=0.00293362f \
 //x=21.525 //y=0.18 //x2=9.135 //y2=0.545
cc_211 ( N_GND_c_16_p N_noxref_16_M5_noxref_s ) capacitor c=0.0149577f \
 //x=9.67 //y=0.175 //x2=9.135 //y2=0.545
cc_212 ( N_GND_c_4_p N_noxref_16_M5_noxref_s ) capacitor c=0.058339f //x=8.575 \
 //y=0.175 //x2=9.135 //y2=0.545
cc_213 ( N_GND_c_5_p N_noxref_16_M5_noxref_s ) capacitor c=0.00198043f \
 //x=11.905 //y=0.175 //x2=9.135 //y2=0.545
cc_214 ( N_GND_M5_noxref_d N_noxref_16_M5_noxref_s ) capacitor c=0.0334197f \
 //x=9.565 //y=1.045 //x2=9.135 //y2=0.545
cc_215 ( N_GND_c_8_p N_noxref_17_c_2431_n ) capacitor c=0.00556334f //x=21.525 \
 //y=0.18 //x2=13.485 //y2=1.76
cc_216 ( N_GND_c_38_p N_noxref_17_c_2431_n ) capacitor c=0.00113126f //x=13 \
 //y=0.175 //x2=13.485 //y2=1.76
cc_217 ( N_GND_c_51_p N_noxref_17_c_2431_n ) capacitor c=0.00181083f \
 //x=15.065 //y=0.175 //x2=13.485 //y2=1.76
cc_218 ( N_GND_M7_noxref_d N_noxref_17_c_2431_n ) capacitor c=0.00897392f \
 //x=12.895 //y=1.045 //x2=13.485 //y2=1.76
cc_219 ( N_GND_c_8_p N_noxref_17_c_2435_n ) capacitor c=0.00302993f //x=21.525 \
 //y=0.18 //x2=13.57 //y2=0.795
cc_220 ( N_GND_c_51_p N_noxref_17_c_2435_n ) capacitor c=0.014661f //x=15.065 \
 //y=0.175 //x2=13.57 //y2=0.795
cc_221 ( N_GND_M7_noxref_d N_noxref_17_c_2435_n ) capacitor c=0.033812f \
 //x=12.895 //y=1.045 //x2=13.57 //y2=0.795
cc_222 ( N_GND_c_5_p N_noxref_17_c_2438_n ) capacitor c=2.91423e-19 //x=11.905 \
 //y=0.175 //x2=13.57 //y2=1.675
cc_223 ( N_GND_c_8_p N_noxref_17_c_2439_n ) capacitor c=0.0124252f //x=21.525 \
 //y=0.18 //x2=14.455 //y2=0.71
cc_224 ( N_GND_c_51_p N_noxref_17_c_2439_n ) capacitor c=0.0371502f //x=15.065 \
 //y=0.175 //x2=14.455 //y2=0.71
cc_225 ( N_GND_c_2_p N_noxref_17_c_2439_n ) capacitor c=0.00198885f //x=21.525 \
 //y=0.18 //x2=14.455 //y2=0.71
cc_226 ( N_GND_c_8_p N_noxref_17_c_2442_n ) capacitor c=0.00303004f //x=21.525 \
 //y=0.18 //x2=14.54 //y2=0.795
cc_227 ( N_GND_c_51_p N_noxref_17_c_2442_n ) capacitor c=0.0144635f //x=15.065 \
 //y=0.175 //x2=14.54 //y2=0.795
cc_228 ( N_GND_c_6_p N_noxref_17_c_2442_n ) capacitor c=0.0431718f //x=15.235 \
 //y=0.175 //x2=14.54 //y2=0.795
cc_229 ( N_GND_c_8_p N_noxref_17_M7_noxref_s ) capacitor c=0.00293362f \
 //x=21.525 //y=0.18 //x2=12.465 //y2=0.545
cc_230 ( N_GND_c_38_p N_noxref_17_M7_noxref_s ) capacitor c=0.0149577f //x=13 \
 //y=0.175 //x2=12.465 //y2=0.545
cc_231 ( N_GND_c_5_p N_noxref_17_M7_noxref_s ) capacitor c=0.058339f \
 //x=11.905 //y=0.175 //x2=12.465 //y2=0.545
cc_232 ( N_GND_c_6_p N_noxref_17_M7_noxref_s ) capacitor c=0.00198043f \
 //x=15.235 //y=0.175 //x2=12.465 //y2=0.545
cc_233 ( N_GND_M7_noxref_d N_noxref_17_M7_noxref_s ) capacitor c=0.0334197f \
 //x=12.895 //y=1.045 //x2=12.465 //y2=0.545
cc_234 ( N_GND_c_8_p N_noxref_18_c_2484_n ) capacitor c=0.00565631f //x=21.525 \
 //y=0.18 //x2=16.815 //y2=1.76
cc_235 ( N_GND_c_75_p N_noxref_18_c_2484_n ) capacitor c=0.00111556f //x=16.33 \
 //y=0.175 //x2=16.815 //y2=1.76
cc_236 ( N_GND_c_82_p N_noxref_18_c_2484_n ) capacitor c=0.00181083f \
 //x=18.395 //y=0.175 //x2=16.815 //y2=1.76
cc_237 ( N_GND_M9_noxref_d N_noxref_18_c_2484_n ) capacitor c=0.00901923f \
 //x=16.225 //y=1.045 //x2=16.815 //y2=1.76
cc_238 ( N_GND_c_8_p N_noxref_18_c_2488_n ) capacitor c=0.00511176f //x=21.525 \
 //y=0.18 //x2=16.9 //y2=0.795
cc_239 ( N_GND_c_82_p N_noxref_18_c_2488_n ) capacitor c=0.014661f //x=18.395 \
 //y=0.175 //x2=16.9 //y2=0.795
cc_240 ( N_GND_M9_noxref_d N_noxref_18_c_2488_n ) capacitor c=0.033812f \
 //x=16.225 //y=1.045 //x2=16.9 //y2=0.795
cc_241 ( N_GND_c_6_p N_noxref_18_c_2491_n ) capacitor c=2.91423e-19 //x=15.235 \
 //y=0.175 //x2=16.9 //y2=1.675
cc_242 ( N_GND_c_8_p N_noxref_18_c_2492_n ) capacitor c=0.0123888f //x=21.525 \
 //y=0.18 //x2=17.785 //y2=0.71
cc_243 ( N_GND_c_82_p N_noxref_18_c_2492_n ) capacitor c=0.0373555f //x=18.395 \
 //y=0.175 //x2=17.785 //y2=0.71
cc_244 ( N_GND_c_2_p N_noxref_18_c_2492_n ) capacitor c=0.00198885f //x=21.525 \
 //y=0.18 //x2=17.785 //y2=0.71
cc_245 ( N_GND_c_8_p N_noxref_18_c_2495_n ) capacitor c=0.00292583f //x=21.525 \
 //y=0.18 //x2=17.87 //y2=0.795
cc_246 ( N_GND_c_82_p N_noxref_18_c_2495_n ) capacitor c=0.0148875f //x=18.395 \
 //y=0.175 //x2=17.87 //y2=0.795
cc_247 ( N_GND_c_7_p N_noxref_18_c_2495_n ) capacitor c=0.0431718f //x=18.565 \
 //y=0.175 //x2=17.87 //y2=0.795
cc_248 ( N_GND_c_8_p N_noxref_18_M9_noxref_s ) capacitor c=0.00302993f \
 //x=21.525 //y=0.18 //x2=15.795 //y2=0.545
cc_249 ( N_GND_c_75_p N_noxref_18_M9_noxref_s ) capacitor c=0.014661f \
 //x=16.33 //y=0.175 //x2=15.795 //y2=0.545
cc_250 ( N_GND_c_6_p N_noxref_18_M9_noxref_s ) capacitor c=0.058339f \
 //x=15.235 //y=0.175 //x2=15.795 //y2=0.545
cc_251 ( N_GND_c_7_p N_noxref_18_M9_noxref_s ) capacitor c=0.00198043f \
 //x=18.565 //y=0.175 //x2=15.795 //y2=0.545
cc_252 ( N_GND_M9_noxref_d N_noxref_18_M9_noxref_s ) capacitor c=0.0334197f \
 //x=16.225 //y=1.045 //x2=15.795 //y2=0.545
cc_253 ( N_GND_c_8_p N_noxref_19_c_2538_n ) capacitor c=0.00556334f //x=21.525 \
 //y=0.18 //x2=20.145 //y2=1.76
cc_254 ( N_GND_c_99_p N_noxref_19_c_2538_n ) capacitor c=0.00113126f //x=19.66 \
 //y=0.175 //x2=20.145 //y2=1.76
cc_255 ( N_GND_c_2_p N_noxref_19_c_2538_n ) capacitor c=0.00181083f //x=21.525 \
 //y=0.18 //x2=20.145 //y2=1.76
cc_256 ( N_GND_M11_noxref_d N_noxref_19_c_2538_n ) capacitor c=0.00897392f \
 //x=19.555 //y=1.045 //x2=20.145 //y2=1.76
cc_257 ( N_GND_c_8_p N_noxref_19_c_2542_n ) capacitor c=0.00302993f //x=21.525 \
 //y=0.18 //x2=20.23 //y2=0.795
cc_258 ( N_GND_c_2_p N_noxref_19_c_2542_n ) capacitor c=0.014661f //x=21.525 \
 //y=0.18 //x2=20.23 //y2=0.795
cc_259 ( N_GND_M11_noxref_d N_noxref_19_c_2542_n ) capacitor c=0.033812f \
 //x=19.555 //y=1.045 //x2=20.23 //y2=0.795
cc_260 ( N_GND_c_7_p N_noxref_19_c_2545_n ) capacitor c=2.91423e-19 //x=18.565 \
 //y=0.175 //x2=20.23 //y2=1.675
cc_261 ( N_GND_c_8_p N_noxref_19_c_2546_n ) capacitor c=0.0124224f //x=21.525 \
 //y=0.18 //x2=21.115 //y2=0.71
cc_262 ( N_GND_c_2_p N_noxref_19_c_2546_n ) capacitor c=0.039139f //x=21.525 \
 //y=0.18 //x2=21.115 //y2=0.71
cc_263 ( N_GND_c_8_p N_noxref_19_c_2548_n ) capacitor c=0.00302312f //x=21.525 \
 //y=0.18 //x2=21.2 //y2=0.795
cc_264 ( N_GND_c_2_p N_noxref_19_c_2548_n ) capacitor c=0.0584168f //x=21.525 \
 //y=0.18 //x2=21.2 //y2=0.795
cc_265 ( N_GND_c_8_p N_noxref_19_M11_noxref_s ) capacitor c=0.00293362f \
 //x=21.525 //y=0.18 //x2=19.125 //y2=0.545
cc_266 ( N_GND_c_99_p N_noxref_19_M11_noxref_s ) capacitor c=0.0149577f \
 //x=19.66 //y=0.175 //x2=19.125 //y2=0.545
cc_267 ( N_GND_c_2_p N_noxref_19_M11_noxref_s ) capacitor c=0.00198482f \
 //x=21.525 //y=0.18 //x2=19.125 //y2=0.545
cc_268 ( N_GND_c_7_p N_noxref_19_M11_noxref_s ) capacitor c=0.058339f \
 //x=18.565 //y=0.175 //x2=19.125 //y2=0.545
cc_269 ( N_GND_M11_noxref_d N_noxref_19_M11_noxref_s ) capacitor c=0.0334197f \
 //x=19.555 //y=1.045 //x2=19.125 //y2=0.545
cc_270 ( N_VDD_c_272_n N_noxref_3_c_578_n ) capacitor c=6.58823e-19 //x=5.245 \
 //y=7.585 //x2=3.765 //y2=2.26
cc_271 ( N_VDD_c_278_p N_noxref_3_c_596_n ) capacitor c=0.00453712f //x=21.525 \
 //y=7.58 //x2=7.27 //y2=5.38
cc_272 ( N_VDD_c_279_p N_noxref_3_c_596_n ) capacitor c=4.48891e-19 //x=6.83 \
 //y=7.585 //x2=7.27 //y2=5.38
cc_273 ( N_VDD_c_280_p N_noxref_3_c_596_n ) capacitor c=4.48891e-19 //x=7.71 \
 //y=7.585 //x2=7.27 //y2=5.38
cc_274 ( N_VDD_M20_noxref_d N_noxref_3_c_596_n ) capacitor c=0.012455f \
 //x=6.77 //y=5.2 //x2=7.27 //y2=5.38
cc_275 ( N_VDD_c_272_n N_noxref_3_c_600_n ) capacitor c=0.00985474f //x=5.245 \
 //y=7.585 //x2=6.56 //y2=5.38
cc_276 ( N_VDD_M19_noxref_s N_noxref_3_c_600_n ) capacitor c=0.087833f //x=5.9 \
 //y=5.2 //x2=6.56 //y2=5.38
cc_277 ( N_VDD_c_278_p N_noxref_3_c_602_n ) capacitor c=0.00301812f //x=21.525 \
 //y=7.58 //x2=7.75 //y2=5.38
cc_278 ( N_VDD_c_280_p N_noxref_3_c_602_n ) capacitor c=7.72907e-19 //x=7.71 \
 //y=7.585 //x2=7.75 //y2=5.38
cc_279 ( N_VDD_M22_noxref_d N_noxref_3_c_602_n ) capacitor c=0.0158576f \
 //x=7.65 //y=5.2 //x2=7.75 //y2=5.38
cc_280 ( N_VDD_M23_noxref_s N_noxref_3_c_602_n ) capacitor c=2.44532e-19 \
 //x=9.23 //y=5.2 //x2=7.75 //y2=5.38
cc_281 ( N_VDD_c_272_n N_noxref_3_c_580_n ) capacitor c=0.00151618f //x=5.245 \
 //y=7.585 //x2=7.835 //y2=3.51
cc_282 ( N_VDD_c_273_n N_noxref_3_c_580_n ) capacitor c=0.0429414f //x=8.575 \
 //y=7.585 //x2=7.835 //y2=3.51
cc_283 ( N_VDD_c_278_p N_noxref_3_c_581_n ) capacitor c=0.00125241f //x=21.525 \
 //y=7.58 //x2=9.685 //y2=2.26
cc_284 ( N_VDD_c_291_p N_noxref_3_c_581_n ) capacitor c=2.88017e-19 //x=10.16 \
 //y=7.585 //x2=9.685 //y2=2.26
cc_285 ( N_VDD_c_273_n N_noxref_3_c_581_n ) capacitor c=0.0134208f //x=8.575 \
 //y=7.585 //x2=9.685 //y2=2.26
cc_286 ( N_VDD_c_293_p N_noxref_3_M17_noxref_g ) capacitor c=0.00679791f \
 //x=4.08 //y=7.585 //x2=3.505 //y2=6.2
cc_287 ( N_VDD_M16_noxref_d N_noxref_3_M17_noxref_g ) capacitor c=0.015318f \
 //x=3.14 //y=5.2 //x2=3.505 //y2=6.2
cc_288 ( N_VDD_c_293_p N_noxref_3_M18_noxref_g ) capacitor c=0.00680002f \
 //x=4.08 //y=7.585 //x2=3.945 //y2=6.2
cc_289 ( N_VDD_M18_noxref_d N_noxref_3_M18_noxref_g ) capacitor c=0.0394719f \
 //x=4.02 //y=5.2 //x2=3.945 //y2=6.2
cc_290 ( N_VDD_c_291_p N_noxref_3_M23_noxref_g ) capacitor c=0.00732332f \
 //x=10.16 //y=7.585 //x2=9.585 //y2=6.2
cc_291 ( N_VDD_M23_noxref_s N_noxref_3_M23_noxref_g ) capacitor c=0.054195f \
 //x=9.23 //y=5.2 //x2=9.585 //y2=6.2
cc_292 ( N_VDD_c_291_p N_noxref_3_M24_noxref_g ) capacitor c=0.00677553f \
 //x=10.16 //y=7.585 //x2=10.025 //y2=6.2
cc_293 ( N_VDD_M24_noxref_d N_noxref_3_M24_noxref_g ) capacitor c=0.015318f \
 //x=10.1 //y=5.2 //x2=10.025 //y2=6.2
cc_294 ( N_VDD_c_273_n N_noxref_3_c_619_n ) capacitor c=0.0150435f //x=8.575 \
 //y=7.585 //x2=9.685 //y2=4.88
cc_295 ( N_VDD_c_278_p N_noxref_3_M19_noxref_d ) capacitor c=0.00275298f \
 //x=21.525 //y=7.58 //x2=6.33 //y2=5.2
cc_296 ( N_VDD_c_279_p N_noxref_3_M19_noxref_d ) capacitor c=0.0140544f \
 //x=6.83 //y=7.585 //x2=6.33 //y2=5.2
cc_297 ( N_VDD_c_273_n N_noxref_3_M19_noxref_d ) capacitor c=6.94454e-19 \
 //x=8.575 //y=7.585 //x2=6.33 //y2=5.2
cc_298 ( N_VDD_M20_noxref_d N_noxref_3_M19_noxref_d ) capacitor c=0.0664752f \
 //x=6.77 //y=5.2 //x2=6.33 //y2=5.2
cc_299 ( N_VDD_c_278_p N_noxref_3_M21_noxref_d ) capacitor c=0.00275298f \
 //x=21.525 //y=7.58 //x2=7.21 //y2=5.2
cc_300 ( N_VDD_c_280_p N_noxref_3_M21_noxref_d ) capacitor c=0.0140544f \
 //x=7.71 //y=7.585 //x2=7.21 //y2=5.2
cc_301 ( N_VDD_c_273_n N_noxref_3_M21_noxref_d ) capacitor c=0.0120541f \
 //x=8.575 //y=7.585 //x2=7.21 //y2=5.2
cc_302 ( N_VDD_M19_noxref_s N_noxref_3_M21_noxref_d ) capacitor c=0.00111971f \
 //x=5.9 //y=5.2 //x2=7.21 //y2=5.2
cc_303 ( N_VDD_M20_noxref_d N_noxref_3_M21_noxref_d ) capacitor c=0.0664752f \
 //x=6.77 //y=5.2 //x2=7.21 //y2=5.2
cc_304 ( N_VDD_M22_noxref_d N_noxref_3_M21_noxref_d ) capacitor c=0.0664752f \
 //x=7.65 //y=5.2 //x2=7.21 //y2=5.2
cc_305 ( N_VDD_M23_noxref_s N_noxref_3_M21_noxref_d ) capacitor c=4.54516e-19 \
 //x=9.23 //y=5.2 //x2=7.21 //y2=5.2
cc_306 ( N_VDD_c_278_p N_noxref_4_c_838_n ) capacitor c=0.00453712f //x=21.525 \
 //y=7.58 //x2=10.6 //y2=5.38
cc_307 ( N_VDD_c_291_p N_noxref_4_c_838_n ) capacitor c=4.48891e-19 //x=10.16 \
 //y=7.585 //x2=10.6 //y2=5.38
cc_308 ( N_VDD_c_315_p N_noxref_4_c_838_n ) capacitor c=4.48891e-19 //x=11.04 \
 //y=7.585 //x2=10.6 //y2=5.38
cc_309 ( N_VDD_M24_noxref_d N_noxref_4_c_838_n ) capacitor c=0.012455f \
 //x=10.1 //y=5.2 //x2=10.6 //y2=5.38
cc_310 ( N_VDD_c_273_n N_noxref_4_c_842_n ) capacitor c=0.00985474f //x=8.575 \
 //y=7.585 //x2=9.89 //y2=5.38
cc_311 ( N_VDD_M23_noxref_s N_noxref_4_c_842_n ) capacitor c=0.087833f \
 //x=9.23 //y=5.2 //x2=9.89 //y2=5.38
cc_312 ( N_VDD_c_278_p N_noxref_4_c_844_n ) capacitor c=0.00301812f //x=21.525 \
 //y=7.58 //x2=11.08 //y2=5.38
cc_313 ( N_VDD_c_315_p N_noxref_4_c_844_n ) capacitor c=7.72907e-19 //x=11.04 \
 //y=7.585 //x2=11.08 //y2=5.38
cc_314 ( N_VDD_M26_noxref_d N_noxref_4_c_844_n ) capacitor c=0.0158576f \
 //x=10.98 //y=5.2 //x2=11.08 //y2=5.38
cc_315 ( N_VDD_M27_noxref_s N_noxref_4_c_844_n ) capacitor c=2.44532e-19 \
 //x=12.56 //y=5.2 //x2=11.08 //y2=5.38
cc_316 ( N_VDD_c_273_n N_noxref_4_c_823_n ) capacitor c=0.00151618f //x=8.575 \
 //y=7.585 //x2=11.165 //y2=3.51
cc_317 ( N_VDD_c_274_n N_noxref_4_c_823_n ) capacitor c=0.0427674f //x=11.905 \
 //y=7.585 //x2=11.165 //y2=3.51
cc_318 ( N_VDD_c_278_p N_noxref_4_c_824_n ) capacitor c=0.00125241f //x=21.525 \
 //y=7.58 //x2=13.015 //y2=2.26
cc_319 ( N_VDD_c_326_p N_noxref_4_c_824_n ) capacitor c=2.88017e-19 //x=13.49 \
 //y=7.585 //x2=13.015 //y2=2.26
cc_320 ( N_VDD_c_274_n N_noxref_4_c_824_n ) capacitor c=0.0133228f //x=11.905 \
 //y=7.585 //x2=13.015 //y2=2.26
cc_321 ( N_VDD_c_326_p N_noxref_4_M27_noxref_g ) capacitor c=0.00732332f \
 //x=13.49 //y=7.585 //x2=12.915 //y2=6.2
cc_322 ( N_VDD_M27_noxref_s N_noxref_4_M27_noxref_g ) capacitor c=0.054195f \
 //x=12.56 //y=5.2 //x2=12.915 //y2=6.2
cc_323 ( N_VDD_c_326_p N_noxref_4_M28_noxref_g ) capacitor c=0.00677553f \
 //x=13.49 //y=7.585 //x2=13.355 //y2=6.2
cc_324 ( N_VDD_M28_noxref_d N_noxref_4_M28_noxref_g ) capacitor c=0.015318f \
 //x=13.43 //y=5.2 //x2=13.355 //y2=6.2
cc_325 ( N_VDD_c_274_n N_noxref_4_c_857_n ) capacitor c=0.0149273f //x=11.905 \
 //y=7.585 //x2=13.015 //y2=4.88
cc_326 ( N_VDD_c_278_p N_noxref_4_M23_noxref_d ) capacitor c=0.00275298f \
 //x=21.525 //y=7.58 //x2=9.66 //y2=5.2
cc_327 ( N_VDD_c_291_p N_noxref_4_M23_noxref_d ) capacitor c=0.0140544f \
 //x=10.16 //y=7.585 //x2=9.66 //y2=5.2
cc_328 ( N_VDD_c_274_n N_noxref_4_M23_noxref_d ) capacitor c=6.94454e-19 \
 //x=11.905 //y=7.585 //x2=9.66 //y2=5.2
cc_329 ( N_VDD_M24_noxref_d N_noxref_4_M23_noxref_d ) capacitor c=0.0664752f \
 //x=10.1 //y=5.2 //x2=9.66 //y2=5.2
cc_330 ( N_VDD_c_278_p N_noxref_4_M25_noxref_d ) capacitor c=0.00275298f \
 //x=21.525 //y=7.58 //x2=10.54 //y2=5.2
cc_331 ( N_VDD_c_315_p N_noxref_4_M25_noxref_d ) capacitor c=0.0140544f \
 //x=11.04 //y=7.585 //x2=10.54 //y2=5.2
cc_332 ( N_VDD_c_274_n N_noxref_4_M25_noxref_d ) capacitor c=0.0120541f \
 //x=11.905 //y=7.585 //x2=10.54 //y2=5.2
cc_333 ( N_VDD_M23_noxref_s N_noxref_4_M25_noxref_d ) capacitor c=0.00111971f \
 //x=9.23 //y=5.2 //x2=10.54 //y2=5.2
cc_334 ( N_VDD_M24_noxref_d N_noxref_4_M25_noxref_d ) capacitor c=0.0664752f \
 //x=10.1 //y=5.2 //x2=10.54 //y2=5.2
cc_335 ( N_VDD_M26_noxref_d N_noxref_4_M25_noxref_d ) capacitor c=0.0664752f \
 //x=10.98 //y=5.2 //x2=10.54 //y2=5.2
cc_336 ( N_VDD_M27_noxref_s N_noxref_4_M25_noxref_d ) capacitor c=4.54516e-19 \
 //x=12.56 //y=5.2 //x2=10.54 //y2=5.2
cc_337 ( N_VDD_c_278_p N_CLK_c_970_n ) capacitor c=0.0824158f //x=21.525 \
 //y=7.58 //x2=13.64 //y2=4.62
cc_338 ( N_VDD_c_345_p N_CLK_c_970_n ) capacitor c=0.00258661f //x=5.075 \
 //y=7.585 //x2=13.64 //y2=4.62
cc_339 ( N_VDD_c_346_p N_CLK_c_970_n ) capacitor c=0.0020986f //x=5.95 \
 //y=7.585 //x2=13.64 //y2=4.62
cc_340 ( N_VDD_c_279_p N_CLK_c_970_n ) capacitor c=7.81825e-19 //x=6.83 \
 //y=7.585 //x2=13.64 //y2=4.62
cc_341 ( N_VDD_c_348_p N_CLK_c_970_n ) capacitor c=0.00205644f //x=8.405 \
 //y=7.585 //x2=13.64 //y2=4.62
cc_342 ( N_VDD_c_349_p N_CLK_c_970_n ) capacitor c=0.0020986f //x=9.28 \
 //y=7.585 //x2=13.64 //y2=4.62
cc_343 ( N_VDD_c_291_p N_CLK_c_970_n ) capacitor c=7.81825e-19 //x=10.16 \
 //y=7.585 //x2=13.64 //y2=4.62
cc_344 ( N_VDD_c_351_p N_CLK_c_970_n ) capacitor c=0.00205644f //x=11.735 \
 //y=7.585 //x2=13.64 //y2=4.62
cc_345 ( N_VDD_c_352_p N_CLK_c_970_n ) capacitor c=0.0020986f //x=12.61 \
 //y=7.585 //x2=13.64 //y2=4.62
cc_346 ( N_VDD_c_326_p N_CLK_c_970_n ) capacitor c=7.81825e-19 //x=13.49 \
 //y=7.585 //x2=13.64 //y2=4.62
cc_347 ( N_VDD_c_272_n N_CLK_c_970_n ) capacitor c=0.0389825f //x=5.245 \
 //y=7.585 //x2=13.64 //y2=4.62
cc_348 ( N_VDD_c_273_n N_CLK_c_970_n ) capacitor c=0.0389825f //x=8.575 \
 //y=7.585 //x2=13.64 //y2=4.62
cc_349 ( N_VDD_c_274_n N_CLK_c_970_n ) capacitor c=0.0389825f //x=11.905 \
 //y=7.585 //x2=13.64 //y2=4.62
cc_350 ( N_VDD_M19_noxref_s N_CLK_c_970_n ) capacitor c=0.00541087f //x=5.9 \
 //y=5.2 //x2=13.64 //y2=4.62
cc_351 ( N_VDD_M22_noxref_d N_CLK_c_970_n ) capacitor c=6.71664e-19 //x=7.65 \
 //y=5.2 //x2=13.64 //y2=4.62
cc_352 ( N_VDD_M23_noxref_s N_CLK_c_970_n ) capacitor c=0.00541087f //x=9.23 \
 //y=5.2 //x2=13.64 //y2=4.62
cc_353 ( N_VDD_M26_noxref_d N_CLK_c_970_n ) capacitor c=6.71664e-19 //x=10.98 \
 //y=5.2 //x2=13.64 //y2=4.62
cc_354 ( N_VDD_M27_noxref_s N_CLK_c_970_n ) capacitor c=0.00541087f //x=12.56 \
 //y=5.2 //x2=13.64 //y2=4.62
cc_355 ( N_VDD_c_278_p N_CLK_c_988_n ) capacitor c=0.00146219f //x=21.525 \
 //y=7.58 //x2=2.77 //y2=4.62
cc_356 ( N_VDD_c_278_p N_CLK_c_989_n ) capacitor c=2.03193e-19 //x=21.525 \
 //y=7.58 //x2=2.655 //y2=4.88
cc_357 ( N_VDD_c_274_n N_CLK_c_968_n ) capacitor c=5.27482e-19 //x=11.905 \
 //y=7.585 //x2=13.755 //y2=2.26
cc_358 ( N_VDD_c_275_n N_CLK_c_968_n ) capacitor c=7.54518e-19 //x=15.235 \
 //y=7.585 //x2=13.755 //y2=2.26
cc_359 ( N_VDD_c_270_n N_CLK_c_992_n ) capacitor c=9.53425e-19 //x=1.175 \
 //y=7.58 //x2=2.682 //y2=4.535
cc_360 ( N_VDD_c_367_p N_CLK_M15_noxref_g ) capacitor c=0.00680845f //x=3.2 \
 //y=7.585 //x2=2.625 //y2=6.2
cc_361 ( N_VDD_M14_noxref_d N_CLK_M15_noxref_g ) capacitor c=0.015318f \
 //x=2.26 //y=5.2 //x2=2.625 //y2=6.2
cc_362 ( N_VDD_c_367_p N_CLK_M16_noxref_g ) capacitor c=0.00679791f //x=3.2 \
 //y=7.585 //x2=3.065 //y2=6.2
cc_363 ( N_VDD_M16_noxref_d N_CLK_M16_noxref_g ) capacitor c=0.015318f \
 //x=3.14 //y=5.2 //x2=3.065 //y2=6.2
cc_364 ( N_VDD_c_371_p N_CLK_M29_noxref_g ) capacitor c=0.00678607f //x=14.37 \
 //y=7.585 //x2=13.795 //y2=6.2
cc_365 ( N_VDD_M28_noxref_d N_CLK_M29_noxref_g ) capacitor c=0.015318f \
 //x=13.43 //y=5.2 //x2=13.795 //y2=6.2
cc_366 ( N_VDD_c_371_p N_CLK_M30_noxref_g ) capacitor c=0.00677553f //x=14.37 \
 //y=7.585 //x2=14.235 //y2=6.2
cc_367 ( N_VDD_c_275_n N_CLK_M30_noxref_g ) capacitor c=0.00864163f //x=15.235 \
 //y=7.585 //x2=14.235 //y2=6.2
cc_368 ( N_VDD_M30_noxref_d N_CLK_M30_noxref_g ) capacitor c=0.0430452f \
 //x=14.31 //y=5.2 //x2=14.235 //y2=6.2
cc_369 ( N_VDD_c_275_n N_noxref_6_c_1190_n ) capacitor c=0.00290918f \
 //x=15.235 //y=7.585 //x2=16.23 //y2=3.88
cc_370 ( N_VDD_c_278_p N_noxref_6_c_1217_n ) capacitor c=0.00449361f \
 //x=21.525 //y=7.58 //x2=2.76 //y2=5.335
cc_371 ( N_VDD_c_378_p N_noxref_6_c_1217_n ) capacitor c=4.32713e-19 //x=2.32 \
 //y=7.585 //x2=2.76 //y2=5.335
cc_372 ( N_VDD_c_367_p N_noxref_6_c_1217_n ) capacitor c=4.3239e-19 //x=3.2 \
 //y=7.585 //x2=2.76 //y2=5.335
cc_373 ( N_VDD_M14_noxref_d N_noxref_6_c_1217_n ) capacitor c=0.0115154f \
 //x=2.26 //y=5.2 //x2=2.76 //y2=5.335
cc_374 ( N_VDD_c_270_n N_noxref_6_c_1221_n ) capacitor c=0.00880189f //x=1.175 \
 //y=7.58 //x2=2.05 //y2=5.335
cc_375 ( N_VDD_M13_noxref_s N_noxref_6_c_1221_n ) capacitor c=0.0831083f \
 //x=1.39 //y=5.2 //x2=2.05 //y2=5.335
cc_376 ( N_VDD_c_278_p N_noxref_6_c_1223_n ) capacitor c=0.00442256f \
 //x=21.525 //y=7.58 //x2=3.64 //y2=5.335
cc_377 ( N_VDD_c_367_p N_noxref_6_c_1223_n ) capacitor c=4.32416e-19 //x=3.2 \
 //y=7.585 //x2=3.64 //y2=5.335
cc_378 ( N_VDD_c_293_p N_noxref_6_c_1223_n ) capacitor c=4.32416e-19 //x=4.08 \
 //y=7.585 //x2=3.64 //y2=5.335
cc_379 ( N_VDD_M16_noxref_d N_noxref_6_c_1223_n ) capacitor c=0.0112992f \
 //x=3.14 //y=5.2 //x2=3.64 //y2=5.335
cc_380 ( N_VDD_c_278_p N_noxref_6_c_1227_n ) capacitor c=0.00434594f \
 //x=21.525 //y=7.58 //x2=4.42 //y2=5.335
cc_381 ( N_VDD_c_293_p N_noxref_6_c_1227_n ) capacitor c=7.47443e-19 //x=4.08 \
 //y=7.585 //x2=4.42 //y2=5.335
cc_382 ( N_VDD_c_345_p N_noxref_6_c_1227_n ) capacitor c=0.00199034f //x=5.075 \
 //y=7.585 //x2=4.42 //y2=5.335
cc_383 ( N_VDD_M18_noxref_d N_noxref_6_c_1227_n ) capacitor c=0.0112992f \
 //x=4.02 //y=5.2 //x2=4.42 //y2=5.335
cc_384 ( N_VDD_c_272_n N_noxref_6_c_1231_n ) capacitor c=0.0426341f //x=5.245 \
 //y=7.585 //x2=4.505 //y2=3.88
cc_385 ( N_VDD_c_278_p N_noxref_6_c_1193_n ) capacitor c=0.00125241f \
 //x=21.525 //y=7.58 //x2=6.355 //y2=2.26
cc_386 ( N_VDD_c_279_p N_noxref_6_c_1193_n ) capacitor c=2.88017e-19 //x=6.83 \
 //y=7.585 //x2=6.355 //y2=2.26
cc_387 ( N_VDD_c_272_n N_noxref_6_c_1193_n ) capacitor c=0.0134665f //x=5.245 \
 //y=7.585 //x2=6.355 //y2=2.26
cc_388 ( N_VDD_c_278_p N_noxref_6_c_1194_n ) capacitor c=0.00126176f \
 //x=21.525 //y=7.58 //x2=16.345 //y2=2.26
cc_389 ( N_VDD_c_396_p N_noxref_6_c_1194_n ) capacitor c=2.88573e-19 //x=16.82 \
 //y=7.585 //x2=16.345 //y2=2.26
cc_390 ( N_VDD_c_275_n N_noxref_6_c_1194_n ) capacitor c=0.0157486f //x=15.235 \
 //y=7.585 //x2=16.345 //y2=2.26
cc_391 ( N_VDD_c_279_p N_noxref_6_M19_noxref_g ) capacitor c=0.00732332f \
 //x=6.83 //y=7.585 //x2=6.255 //y2=6.2
cc_392 ( N_VDD_M19_noxref_s N_noxref_6_M19_noxref_g ) capacitor c=0.054195f \
 //x=5.9 //y=5.2 //x2=6.255 //y2=6.2
cc_393 ( N_VDD_c_279_p N_noxref_6_M20_noxref_g ) capacitor c=0.00677553f \
 //x=6.83 //y=7.585 //x2=6.695 //y2=6.2
cc_394 ( N_VDD_M20_noxref_d N_noxref_6_M20_noxref_g ) capacitor c=0.015318f \
 //x=6.77 //y=5.2 //x2=6.695 //y2=6.2
cc_395 ( N_VDD_c_396_p N_noxref_6_M31_noxref_g ) capacitor c=0.00732332f \
 //x=16.82 //y=7.585 //x2=16.245 //y2=6.2
cc_396 ( N_VDD_M31_noxref_s N_noxref_6_M31_noxref_g ) capacitor c=0.054195f \
 //x=15.89 //y=5.2 //x2=16.245 //y2=6.2
cc_397 ( N_VDD_c_396_p N_noxref_6_M32_noxref_g ) capacitor c=0.00677553f \
 //x=16.82 //y=7.585 //x2=16.685 //y2=6.2
cc_398 ( N_VDD_M32_noxref_d N_noxref_6_M32_noxref_g ) capacitor c=0.015318f \
 //x=16.76 //y=5.2 //x2=16.685 //y2=6.2
cc_399 ( N_VDD_c_272_n N_noxref_6_c_1246_n ) capacitor c=0.015293f //x=5.245 \
 //y=7.585 //x2=6.355 //y2=4.88
cc_400 ( N_VDD_c_275_n N_noxref_6_c_1247_n ) capacitor c=0.0149273f //x=15.235 \
 //y=7.585 //x2=16.345 //y2=4.88
cc_401 ( N_VDD_c_278_p N_noxref_6_M13_noxref_d ) capacitor c=0.00285148f \
 //x=21.525 //y=7.58 //x2=1.82 //y2=5.2
cc_402 ( N_VDD_c_378_p N_noxref_6_M13_noxref_d ) capacitor c=0.0141242f \
 //x=2.32 //y=7.585 //x2=1.82 //y2=5.2
cc_403 ( N_VDD_M14_noxref_d N_noxref_6_M13_noxref_d ) capacitor c=0.0664752f \
 //x=2.26 //y=5.2 //x2=1.82 //y2=5.2
cc_404 ( N_VDD_c_278_p N_noxref_6_M15_noxref_d ) capacitor c=0.0027526f \
 //x=21.525 //y=7.58 //x2=2.7 //y2=5.2
cc_405 ( N_VDD_c_367_p N_noxref_6_M15_noxref_d ) capacitor c=0.0140573f \
 //x=3.2 //y=7.585 //x2=2.7 //y2=5.2
cc_406 ( N_VDD_c_272_n N_noxref_6_M15_noxref_d ) capacitor c=4.9285e-19 \
 //x=5.245 //y=7.585 //x2=2.7 //y2=5.2
cc_407 ( N_VDD_M13_noxref_s N_noxref_6_M15_noxref_d ) capacitor c=0.00130656f \
 //x=1.39 //y=5.2 //x2=2.7 //y2=5.2
cc_408 ( N_VDD_M14_noxref_d N_noxref_6_M15_noxref_d ) capacitor c=0.0664752f \
 //x=2.26 //y=5.2 //x2=2.7 //y2=5.2
cc_409 ( N_VDD_M16_noxref_d N_noxref_6_M15_noxref_d ) capacitor c=0.0664752f \
 //x=3.14 //y=5.2 //x2=2.7 //y2=5.2
cc_410 ( N_VDD_c_278_p N_noxref_6_M17_noxref_d ) capacitor c=0.00275309f \
 //x=21.525 //y=7.58 //x2=3.58 //y2=5.2
cc_411 ( N_VDD_c_293_p N_noxref_6_M17_noxref_d ) capacitor c=0.01376f //x=4.08 \
 //y=7.585 //x2=3.58 //y2=5.2
cc_412 ( N_VDD_c_272_n N_noxref_6_M17_noxref_d ) capacitor c=0.00939849f \
 //x=5.245 //y=7.585 //x2=3.58 //y2=5.2
cc_413 ( N_VDD_M16_noxref_d N_noxref_6_M17_noxref_d ) capacitor c=0.0664752f \
 //x=3.14 //y=5.2 //x2=3.58 //y2=5.2
cc_414 ( N_VDD_M18_noxref_d N_noxref_6_M17_noxref_d ) capacitor c=0.0664752f \
 //x=4.02 //y=5.2 //x2=3.58 //y2=5.2
cc_415 ( N_VDD_M19_noxref_s N_noxref_6_M17_noxref_d ) capacitor c=4.52683e-19 \
 //x=5.9 //y=5.2 //x2=3.58 //y2=5.2
cc_416 ( N_VDD_c_275_n N_noxref_7_c_1448_n ) capacitor c=9.06385e-19 \
 //x=15.235 //y=7.585 //x2=17.085 //y2=2.26
cc_417 ( N_VDD_c_276_n N_noxref_7_c_1448_n ) capacitor c=5.81514e-19 \
 //x=18.565 //y=7.585 //x2=17.085 //y2=2.26
cc_418 ( N_VDD_c_425_p N_noxref_7_M33_noxref_g ) capacitor c=0.00678607f \
 //x=17.7 //y=7.585 //x2=17.125 //y2=6.2
cc_419 ( N_VDD_M32_noxref_d N_noxref_7_M33_noxref_g ) capacitor c=0.015318f \
 //x=16.76 //y=5.2 //x2=17.125 //y2=6.2
cc_420 ( N_VDD_c_425_p N_noxref_7_M34_noxref_g ) capacitor c=0.00677553f \
 //x=17.7 //y=7.585 //x2=17.565 //y2=6.2
cc_421 ( N_VDD_c_276_n N_noxref_7_M34_noxref_g ) capacitor c=0.00864163f \
 //x=18.565 //y=7.585 //x2=17.565 //y2=6.2
cc_422 ( N_VDD_M34_noxref_d N_noxref_7_M34_noxref_g ) capacitor c=0.0430452f \
 //x=17.64 //y=5.2 //x2=17.565 //y2=6.2
cc_423 ( N_VDD_c_278_p N_noxref_8_c_1534_n ) capacitor c=0.00460177f \
 //x=21.525 //y=7.58 //x2=17.26 //y2=5.38
cc_424 ( N_VDD_c_396_p N_noxref_8_c_1534_n ) capacitor c=4.49205e-19 //x=16.82 \
 //y=7.585 //x2=17.26 //y2=5.38
cc_425 ( N_VDD_c_425_p N_noxref_8_c_1534_n ) capacitor c=4.49205e-19 //x=17.7 \
 //y=7.585 //x2=17.26 //y2=5.38
cc_426 ( N_VDD_M32_noxref_d N_noxref_8_c_1534_n ) capacitor c=0.0126931f \
 //x=16.76 //y=5.2 //x2=17.26 //y2=5.38
cc_427 ( N_VDD_c_275_n N_noxref_8_c_1538_n ) capacitor c=0.00985474f \
 //x=15.235 //y=7.585 //x2=16.55 //y2=5.38
cc_428 ( N_VDD_M31_noxref_s N_noxref_8_c_1538_n ) capacitor c=0.087833f \
 //x=15.89 //y=5.2 //x2=16.55 //y2=5.38
cc_429 ( N_VDD_c_278_p N_noxref_8_c_1540_n ) capacitor c=0.0030743f //x=21.525 \
 //y=7.58 //x2=17.74 //y2=5.38
cc_430 ( N_VDD_c_425_p N_noxref_8_c_1540_n ) capacitor c=7.74005e-19 //x=17.7 \
 //y=7.585 //x2=17.74 //y2=5.38
cc_431 ( N_VDD_M34_noxref_d N_noxref_8_c_1540_n ) capacitor c=0.016158f \
 //x=17.64 //y=5.2 //x2=17.74 //y2=5.38
cc_432 ( N_VDD_M35_noxref_s N_noxref_8_c_1540_n ) capacitor c=2.44532e-19 \
 //x=19.22 //y=5.2 //x2=17.74 //y2=5.38
cc_433 ( N_VDD_c_275_n N_noxref_8_c_1528_n ) capacitor c=0.00151618f \
 //x=15.235 //y=7.585 //x2=17.825 //y2=3.51
cc_434 ( N_VDD_c_276_n N_noxref_8_c_1528_n ) capacitor c=0.0455537f //x=18.565 \
 //y=7.585 //x2=17.825 //y2=3.51
cc_435 ( N_VDD_c_278_p N_noxref_8_M31_noxref_d ) capacitor c=0.00285139f \
 //x=21.525 //y=7.58 //x2=16.32 //y2=5.2
cc_436 ( N_VDD_c_396_p N_noxref_8_M31_noxref_d ) capacitor c=0.0141209f \
 //x=16.82 //y=7.585 //x2=16.32 //y2=5.2
cc_437 ( N_VDD_c_276_n N_noxref_8_M31_noxref_d ) capacitor c=6.94454e-19 \
 //x=18.565 //y=7.585 //x2=16.32 //y2=5.2
cc_438 ( N_VDD_M32_noxref_d N_noxref_8_M31_noxref_d ) capacitor c=0.0664752f \
 //x=16.76 //y=5.2 //x2=16.32 //y2=5.2
cc_439 ( N_VDD_c_278_p N_noxref_8_M33_noxref_d ) capacitor c=0.00285139f \
 //x=21.525 //y=7.58 //x2=17.2 //y2=5.2
cc_440 ( N_VDD_c_425_p N_noxref_8_M33_noxref_d ) capacitor c=0.0141209f \
 //x=17.7 //y=7.585 //x2=17.2 //y2=5.2
cc_441 ( N_VDD_c_276_n N_noxref_8_M33_noxref_d ) capacitor c=0.0120541f \
 //x=18.565 //y=7.585 //x2=17.2 //y2=5.2
cc_442 ( N_VDD_M31_noxref_s N_noxref_8_M33_noxref_d ) capacitor c=0.00111971f \
 //x=15.89 //y=5.2 //x2=17.2 //y2=5.2
cc_443 ( N_VDD_M32_noxref_d N_noxref_8_M33_noxref_d ) capacitor c=0.0664752f \
 //x=16.76 //y=5.2 //x2=17.2 //y2=5.2
cc_444 ( N_VDD_M34_noxref_d N_noxref_8_M33_noxref_d ) capacitor c=0.0664752f \
 //x=17.64 //y=5.2 //x2=17.2 //y2=5.2
cc_445 ( N_VDD_M35_noxref_s N_noxref_8_M33_noxref_d ) capacitor c=4.54516e-19 \
 //x=19.22 //y=5.2 //x2=17.2 //y2=5.2
cc_446 ( N_VDD_c_278_p N_noxref_9_c_1607_n ) capacitor c=0.00126176f \
 //x=21.525 //y=7.58 //x2=19.675 //y2=2.26
cc_447 ( N_VDD_c_454_p N_noxref_9_c_1607_n ) capacitor c=2.88573e-19 //x=20.15 \
 //y=7.585 //x2=19.675 //y2=2.26
cc_448 ( N_VDD_c_276_n N_noxref_9_c_1607_n ) capacitor c=0.0160121f //x=18.565 \
 //y=7.585 //x2=19.675 //y2=2.26
cc_449 ( N_VDD_c_454_p N_noxref_9_M35_noxref_g ) capacitor c=0.00732332f \
 //x=20.15 //y=7.585 //x2=19.575 //y2=6.2
cc_450 ( N_VDD_M35_noxref_s N_noxref_9_M35_noxref_g ) capacitor c=0.054195f \
 //x=19.22 //y=5.2 //x2=19.575 //y2=6.2
cc_451 ( N_VDD_c_454_p N_noxref_9_M36_noxref_g ) capacitor c=0.00677553f \
 //x=20.15 //y=7.585 //x2=20.015 //y2=6.2
cc_452 ( N_VDD_M36_noxref_d N_noxref_9_M36_noxref_g ) capacitor c=0.015318f \
 //x=20.09 //y=5.2 //x2=20.015 //y2=6.2
cc_453 ( N_VDD_c_276_n N_noxref_9_c_1629_n ) capacitor c=0.0150435f //x=18.565 \
 //y=7.585 //x2=19.675 //y2=4.88
cc_454 ( N_VDD_c_278_p N_noxref_10_c_1678_n ) capacitor c=0.0356138f \
 //x=21.525 //y=7.58 //x2=10.31 //y2=4.25
cc_455 ( N_VDD_c_378_p N_noxref_10_c_1678_n ) capacitor c=0.00113267f //x=2.32 \
 //y=7.585 //x2=10.31 //y2=4.25
cc_456 ( N_VDD_c_272_n N_noxref_10_c_1678_n ) capacitor c=0.0140577f //x=5.245 \
 //y=7.585 //x2=10.31 //y2=4.25
cc_457 ( N_VDD_c_273_n N_noxref_10_c_1678_n ) capacitor c=0.0140577f //x=8.575 \
 //y=7.585 //x2=10.31 //y2=4.25
cc_458 ( N_VDD_c_278_p N_noxref_10_c_1679_n ) capacitor c=0.00189506f \
 //x=21.525 //y=7.58 //x2=1.66 //y2=4.25
cc_459 ( N_VDD_c_270_n N_noxref_10_c_1679_n ) capacitor c=0.0017219f //x=1.175 \
 //y=7.58 //x2=1.66 //y2=4.25
cc_460 ( N_VDD_M13_noxref_s N_noxref_10_c_1679_n ) capacitor c=0.00128247f \
 //x=1.39 //y=5.2 //x2=1.66 //y2=4.25
cc_461 ( N_VDD_c_278_p N_noxref_10_c_1708_n ) capacitor c=0.0158444f \
 //x=21.525 //y=7.58 //x2=14.38 //y2=4.25
cc_462 ( N_VDD_c_274_n N_noxref_10_c_1708_n ) capacitor c=0.0140577f \
 //x=11.905 //y=7.585 //x2=14.38 //y2=4.25
cc_463 ( N_VDD_c_278_p N_noxref_10_c_1680_n ) capacitor c=0.0403694f \
 //x=21.525 //y=7.58 //x2=20.3 //y2=4.25
cc_464 ( N_VDD_c_471_p N_noxref_10_c_1680_n ) capacitor c=0.0016151f \
 //x=15.065 //y=7.585 //x2=20.3 //y2=4.25
cc_465 ( N_VDD_c_472_p N_noxref_10_c_1680_n ) capacitor c=0.00172127f \
 //x=15.94 //y=7.585 //x2=20.3 //y2=4.25
cc_466 ( N_VDD_c_396_p N_noxref_10_c_1680_n ) capacitor c=6.61227e-19 \
 //x=16.82 //y=7.585 //x2=20.3 //y2=4.25
cc_467 ( N_VDD_c_474_p N_noxref_10_c_1680_n ) capacitor c=0.00168633f \
 //x=18.395 //y=7.585 //x2=20.3 //y2=4.25
cc_468 ( N_VDD_c_475_p N_noxref_10_c_1680_n ) capacitor c=0.00172127f \
 //x=19.27 //y=7.585 //x2=20.3 //y2=4.25
cc_469 ( N_VDD_c_454_p N_noxref_10_c_1680_n ) capacitor c=6.61227e-19 \
 //x=20.15 //y=7.585 //x2=20.3 //y2=4.25
cc_470 ( N_VDD_c_275_n N_noxref_10_c_1680_n ) capacitor c=0.0269493f \
 //x=15.235 //y=7.585 //x2=20.3 //y2=4.25
cc_471 ( N_VDD_c_276_n N_noxref_10_c_1680_n ) capacitor c=0.0269493f \
 //x=18.565 //y=7.585 //x2=20.3 //y2=4.25
cc_472 ( N_VDD_M31_noxref_s N_noxref_10_c_1680_n ) capacitor c=0.00363045f \
 //x=15.89 //y=5.2 //x2=20.3 //y2=4.25
cc_473 ( N_VDD_M34_noxref_d N_noxref_10_c_1680_n ) capacitor c=5.05316e-19 \
 //x=17.64 //y=5.2 //x2=20.3 //y2=4.25
cc_474 ( N_VDD_M35_noxref_s N_noxref_10_c_1680_n ) capacitor c=0.00363045f \
 //x=19.22 //y=5.2 //x2=20.3 //y2=4.25
cc_475 ( N_VDD_c_278_p N_noxref_10_c_1722_n ) capacitor c=0.00172719f \
 //x=21.525 //y=7.58 //x2=14.61 //y2=4.25
cc_476 ( N_VDD_c_275_n N_noxref_10_c_1722_n ) capacitor c=0.00104972f \
 //x=15.235 //y=7.585 //x2=14.61 //y2=4.25
cc_477 ( N_VDD_M30_noxref_d N_noxref_10_c_1722_n ) capacitor c=5.1475e-19 \
 //x=14.31 //y=5.2 //x2=14.61 //y2=4.25
cc_478 ( N_VDD_c_278_p N_noxref_10_c_1681_n ) capacitor c=9.2195e-19 \
 //x=21.525 //y=7.58 //x2=1.545 //y2=2.26
cc_479 ( N_VDD_c_270_n N_noxref_10_c_1681_n ) capacitor c=0.0159723f //x=1.175 \
 //y=7.58 //x2=1.545 //y2=2.26
cc_480 ( N_VDD_M13_noxref_s N_noxref_10_c_1681_n ) capacitor c=0.0122994f \
 //x=1.39 //y=5.2 //x2=1.545 //y2=2.26
cc_481 ( N_VDD_c_273_n N_noxref_10_c_1682_n ) capacitor c=4.57806e-19 \
 //x=8.575 //y=7.585 //x2=10.425 //y2=2.26
cc_482 ( N_VDD_c_274_n N_noxref_10_c_1682_n ) capacitor c=3.69525e-19 \
 //x=11.905 //y=7.585 //x2=10.425 //y2=2.26
cc_483 ( N_VDD_c_278_p N_noxref_10_c_1730_n ) capacitor c=0.00453521f \
 //x=21.525 //y=7.58 //x2=13.93 //y2=5.38
cc_484 ( N_VDD_c_326_p N_noxref_10_c_1730_n ) capacitor c=4.48891e-19 \
 //x=13.49 //y=7.585 //x2=13.93 //y2=5.38
cc_485 ( N_VDD_c_371_p N_noxref_10_c_1730_n ) capacitor c=4.48878e-19 \
 //x=14.37 //y=7.585 //x2=13.93 //y2=5.38
cc_486 ( N_VDD_M28_noxref_d N_noxref_10_c_1730_n ) capacitor c=0.0124513f \
 //x=13.43 //y=5.2 //x2=13.93 //y2=5.38
cc_487 ( N_VDD_c_274_n N_noxref_10_c_1734_n ) capacitor c=0.00985474f \
 //x=11.905 //y=7.585 //x2=13.22 //y2=5.38
cc_488 ( N_VDD_M27_noxref_s N_noxref_10_c_1734_n ) capacitor c=0.087833f \
 //x=12.56 //y=5.2 //x2=13.22 //y2=5.38
cc_489 ( N_VDD_c_278_p N_noxref_10_c_1736_n ) capacitor c=0.00307252f \
 //x=21.525 //y=7.58 //x2=14.41 //y2=5.38
cc_490 ( N_VDD_c_371_p N_noxref_10_c_1736_n ) capacitor c=7.74005e-19 \
 //x=14.37 //y=7.585 //x2=14.41 //y2=5.38
cc_491 ( N_VDD_M30_noxref_d N_noxref_10_c_1736_n ) capacitor c=0.0161392f \
 //x=14.31 //y=5.2 //x2=14.41 //y2=5.38
cc_492 ( N_VDD_M31_noxref_s N_noxref_10_c_1736_n ) capacitor c=2.44532e-19 \
 //x=15.89 //y=5.2 //x2=14.41 //y2=5.38
cc_493 ( N_VDD_c_274_n N_noxref_10_c_1685_n ) capacitor c=0.00151618f \
 //x=11.905 //y=7.585 //x2=14.495 //y2=4.25
cc_494 ( N_VDD_c_275_n N_noxref_10_c_1685_n ) capacitor c=0.0451944f \
 //x=15.235 //y=7.585 //x2=14.495 //y2=4.25
cc_495 ( N_VDD_c_271_n N_noxref_10_c_1686_n ) capacitor c=6.91186e-19 \
 //x=21.525 //y=7.58 //x2=20.415 //y2=2.26
cc_496 ( N_VDD_c_276_n N_noxref_10_c_1686_n ) capacitor c=6.2696e-19 \
 //x=18.565 //y=7.585 //x2=20.415 //y2=2.26
cc_497 ( N_VDD_c_378_p N_noxref_10_M13_noxref_g ) capacitor c=0.00755614f \
 //x=2.32 //y=7.585 //x2=1.745 //y2=6.2
cc_498 ( N_VDD_M13_noxref_s N_noxref_10_M13_noxref_g ) capacitor c=0.0477201f \
 //x=1.39 //y=5.2 //x2=1.745 //y2=6.2
cc_499 ( N_VDD_c_378_p N_noxref_10_M14_noxref_g ) capacitor c=0.00679791f \
 //x=2.32 //y=7.585 //x2=2.185 //y2=6.2
cc_500 ( N_VDD_M14_noxref_d N_noxref_10_M14_noxref_g ) capacitor c=0.015318f \
 //x=2.26 //y=5.2 //x2=2.185 //y2=6.2
cc_501 ( N_VDD_c_315_p N_noxref_10_M25_noxref_g ) capacitor c=0.00678607f \
 //x=11.04 //y=7.585 //x2=10.465 //y2=6.2
cc_502 ( N_VDD_M24_noxref_d N_noxref_10_M25_noxref_g ) capacitor c=0.015318f \
 //x=10.1 //y=5.2 //x2=10.465 //y2=6.2
cc_503 ( N_VDD_c_315_p N_noxref_10_M26_noxref_g ) capacitor c=0.00677553f \
 //x=11.04 //y=7.585 //x2=10.905 //y2=6.2
cc_504 ( N_VDD_c_274_n N_noxref_10_M26_noxref_g ) capacitor c=0.00864163f \
 //x=11.905 //y=7.585 //x2=10.905 //y2=6.2
cc_505 ( N_VDD_M26_noxref_d N_noxref_10_M26_noxref_g ) capacitor c=0.0430452f \
 //x=10.98 //y=5.2 //x2=10.905 //y2=6.2
cc_506 ( N_VDD_c_513_p N_noxref_10_M37_noxref_g ) capacitor c=0.00678607f \
 //x=21.03 //y=7.585 //x2=20.455 //y2=6.2
cc_507 ( N_VDD_M36_noxref_d N_noxref_10_M37_noxref_g ) capacitor c=0.015318f \
 //x=20.09 //y=5.2 //x2=20.455 //y2=6.2
cc_508 ( N_VDD_c_513_p N_noxref_10_M38_noxref_g ) capacitor c=0.00677553f \
 //x=21.03 //y=7.585 //x2=20.895 //y2=6.2
cc_509 ( N_VDD_c_271_n N_noxref_10_M38_noxref_g ) capacitor c=0.0242878f \
 //x=21.525 //y=7.58 //x2=20.895 //y2=6.2
cc_510 ( N_VDD_M38_noxref_d N_noxref_10_M38_noxref_g ) capacitor c=0.0430452f \
 //x=20.97 //y=5.2 //x2=20.895 //y2=6.2
cc_511 ( N_VDD_c_270_n N_noxref_10_c_1758_n ) capacitor c=0.00757682f \
 //x=1.175 //y=7.58 //x2=1.82 //y2=4.97
cc_512 ( N_VDD_M13_noxref_s N_noxref_10_c_1758_n ) capacitor c=0.00445143f \
 //x=1.39 //y=5.2 //x2=1.82 //y2=4.97
cc_513 ( N_VDD_c_278_p N_noxref_10_M27_noxref_d ) capacitor c=0.00275298f \
 //x=21.525 //y=7.58 //x2=12.99 //y2=5.2
cc_514 ( N_VDD_c_326_p N_noxref_10_M27_noxref_d ) capacitor c=0.0140544f \
 //x=13.49 //y=7.585 //x2=12.99 //y2=5.2
cc_515 ( N_VDD_c_275_n N_noxref_10_M27_noxref_d ) capacitor c=6.94454e-19 \
 //x=15.235 //y=7.585 //x2=12.99 //y2=5.2
cc_516 ( N_VDD_M28_noxref_d N_noxref_10_M27_noxref_d ) capacitor c=0.0664752f \
 //x=13.43 //y=5.2 //x2=12.99 //y2=5.2
cc_517 ( N_VDD_c_278_p N_noxref_10_M29_noxref_d ) capacitor c=0.00285139f \
 //x=21.525 //y=7.58 //x2=13.87 //y2=5.2
cc_518 ( N_VDD_c_371_p N_noxref_10_M29_noxref_d ) capacitor c=0.0141209f \
 //x=14.37 //y=7.585 //x2=13.87 //y2=5.2
cc_519 ( N_VDD_c_275_n N_noxref_10_M29_noxref_d ) capacitor c=0.0120541f \
 //x=15.235 //y=7.585 //x2=13.87 //y2=5.2
cc_520 ( N_VDD_M27_noxref_s N_noxref_10_M29_noxref_d ) capacitor c=0.00111971f \
 //x=12.56 //y=5.2 //x2=13.87 //y2=5.2
cc_521 ( N_VDD_M28_noxref_d N_noxref_10_M29_noxref_d ) capacitor c=0.0664752f \
 //x=13.43 //y=5.2 //x2=13.87 //y2=5.2
cc_522 ( N_VDD_M30_noxref_d N_noxref_10_M29_noxref_d ) capacitor c=0.0664752f \
 //x=14.31 //y=5.2 //x2=13.87 //y2=5.2
cc_523 ( N_VDD_M31_noxref_s N_noxref_10_M29_noxref_d ) capacitor c=4.54516e-19 \
 //x=15.89 //y=5.2 //x2=13.87 //y2=5.2
cc_524 ( N_VDD_c_278_p Q ) capacitor c=0.0151931f //x=21.525 //y=7.58 \
 //x2=21.21 //y2=3.88
cc_525 ( N_VDD_M38_noxref_d Q ) capacitor c=4.05367e-19 //x=20.97 //y=5.2 \
 //x2=21.21 //y2=3.88
cc_526 ( N_VDD_c_271_n Q ) capacitor c=0.00285659f //x=21.525 //y=7.58 \
 //x2=21.21 //y2=4.25
cc_527 ( N_VDD_c_271_n Q ) capacitor c=0.00946859f //x=21.525 //y=7.58 \
 //x2=21.21 //y2=4.62
cc_528 ( N_VDD_c_278_p Q ) capacitor c=2.28095e-19 //x=21.525 //y=7.58 \
 //x2=21.21 //y2=4.99
cc_529 ( N_VDD_c_271_n Q ) capacitor c=0.0093005f //x=21.525 //y=7.58 \
 //x2=21.21 //y2=4.99
cc_530 ( N_VDD_c_276_n Q ) capacitor c=0.00151558f //x=18.565 //y=7.585 \
 //x2=21.21 //y2=4.99
cc_531 ( N_VDD_c_278_p N_Q_c_2061_n ) capacitor c=0.00459998f //x=21.525 \
 //y=7.58 //x2=20.59 //y2=5.38
cc_532 ( N_VDD_c_454_p N_Q_c_2061_n ) capacitor c=4.49205e-19 //x=20.15 \
 //y=7.585 //x2=20.59 //y2=5.38
cc_533 ( N_VDD_c_513_p N_Q_c_2061_n ) capacitor c=4.49193e-19 //x=21.03 \
 //y=7.585 //x2=20.59 //y2=5.38
cc_534 ( N_VDD_M36_noxref_d N_Q_c_2061_n ) capacitor c=0.0126907f //x=20.09 \
 //y=5.2 //x2=20.59 //y2=5.38
cc_535 ( N_VDD_c_276_n N_Q_c_2065_n ) capacitor c=0.00985474f //x=18.565 \
 //y=7.585 //x2=19.88 //y2=5.38
cc_536 ( N_VDD_M35_noxref_s N_Q_c_2065_n ) capacitor c=0.087833f //x=19.22 \
 //y=5.2 //x2=19.88 //y2=5.38
cc_537 ( N_VDD_c_278_p N_Q_c_2067_n ) capacitor c=0.00312108f //x=21.525 \
 //y=7.58 //x2=21.07 //y2=5.38
cc_538 ( N_VDD_c_513_p N_Q_c_2067_n ) capacitor c=7.22416e-19 //x=21.03 \
 //y=7.585 //x2=21.07 //y2=5.38
cc_539 ( N_VDD_M38_noxref_d N_Q_c_2067_n ) capacitor c=0.0163426f //x=20.97 \
 //y=5.2 //x2=21.07 //y2=5.38
cc_540 ( N_VDD_c_271_n N_Q_c_2070_n ) capacitor c=0.0154944f //x=21.525 \
 //y=7.58 //x2=21.155 //y2=5.295
cc_541 ( N_VDD_c_271_n N_Q_c_2071_n ) capacitor c=0.00770228f //x=21.525 \
 //y=7.58 //x2=21.182 //y2=4.535
cc_542 ( N_VDD_c_271_n N_Q_c_2072_n ) capacitor c=0.00775987f //x=21.525 \
 //y=7.58 //x2=21.182 //y2=4.905
cc_543 ( N_VDD_c_278_p N_Q_M35_noxref_d ) capacitor c=0.00285139f //x=21.525 \
 //y=7.58 //x2=19.65 //y2=5.2
cc_544 ( N_VDD_c_454_p N_Q_M35_noxref_d ) capacitor c=0.0141209f //x=20.15 \
 //y=7.585 //x2=19.65 //y2=5.2
cc_545 ( N_VDD_c_271_n N_Q_M35_noxref_d ) capacitor c=6.94454e-19 //x=21.525 \
 //y=7.58 //x2=19.65 //y2=5.2
cc_546 ( N_VDD_M36_noxref_d N_Q_M35_noxref_d ) capacitor c=0.0664752f \
 //x=20.09 //y=5.2 //x2=19.65 //y2=5.2
cc_547 ( N_VDD_c_278_p N_Q_M37_noxref_d ) capacitor c=0.00294258f //x=21.525 \
 //y=7.58 //x2=20.53 //y2=5.2
cc_548 ( N_VDD_c_513_p N_Q_M37_noxref_d ) capacitor c=0.0138783f //x=21.03 \
 //y=7.585 //x2=20.53 //y2=5.2
cc_549 ( N_VDD_c_271_n N_Q_M37_noxref_d ) capacitor c=0.0123189f //x=21.525 \
 //y=7.58 //x2=20.53 //y2=5.2
cc_550 ( N_VDD_M35_noxref_s N_Q_M37_noxref_d ) capacitor c=0.00111971f \
 //x=19.22 //y=5.2 //x2=20.53 //y2=5.2
cc_551 ( N_VDD_M36_noxref_d N_Q_M37_noxref_d ) capacitor c=0.0664752f \
 //x=20.09 //y=5.2 //x2=20.53 //y2=5.2
cc_552 ( N_VDD_M38_noxref_d N_Q_M37_noxref_d ) capacitor c=0.0664752f \
 //x=20.97 //y=5.2 //x2=20.53 //y2=5.2
cc_553 ( N_VDD_c_272_n N_D_c_2248_n ) capacitor c=4.47073e-19 //x=5.245 \
 //y=7.585 //x2=7.095 //y2=4.715
cc_554 ( N_VDD_c_273_n N_D_c_2248_n ) capacitor c=3.37458e-19 //x=8.575 \
 //y=7.585 //x2=7.095 //y2=4.715
cc_555 ( N_VDD_c_280_p N_D_M21_noxref_g ) capacitor c=0.00678607f //x=7.71 \
 //y=7.585 //x2=7.135 //y2=6.2
cc_556 ( N_VDD_M20_noxref_d N_D_M21_noxref_g ) capacitor c=0.015318f //x=6.77 \
 //y=5.2 //x2=7.135 //y2=6.2
cc_557 ( N_VDD_c_280_p N_D_M22_noxref_g ) capacitor c=0.00677553f //x=7.71 \
 //y=7.585 //x2=7.575 //y2=6.2
cc_558 ( N_VDD_c_273_n N_D_M22_noxref_g ) capacitor c=0.00864163f //x=8.575 \
 //y=7.585 //x2=7.575 //y2=6.2
cc_559 ( N_VDD_M22_noxref_d N_D_M22_noxref_g ) capacitor c=0.0430452f //x=7.65 \
 //y=5.2 //x2=7.575 //y2=6.2
cc_560 ( N_noxref_3_c_573_n N_noxref_4_c_821_n ) capacitor c=0.011463f \
 //x=9.57 //y=3.51 //x2=11.28 //y2=3.51
cc_561 ( N_noxref_3_M24_noxref_g N_noxref_4_c_838_n ) capacitor c=0.0169521f \
 //x=10.025 //y=6.2 //x2=10.6 //y2=5.38
cc_562 ( N_noxref_3_c_581_n N_noxref_4_c_842_n ) capacitor c=0.00539951f \
 //x=9.685 //y=2.26 //x2=9.89 //y2=5.38
cc_563 ( N_noxref_3_M23_noxref_g N_noxref_4_c_842_n ) capacitor c=0.0177326f \
 //x=9.585 //y=6.2 //x2=9.89 //y2=5.38
cc_564 ( N_noxref_3_c_619_n N_noxref_4_c_842_n ) capacitor c=0.00581252f \
 //x=9.685 //y=4.88 //x2=9.89 //y2=5.38
cc_565 ( N_noxref_3_c_580_n N_noxref_4_c_823_n ) capacitor c=3.49822e-19 \
 //x=7.835 //y=3.51 //x2=11.165 //y2=3.51
cc_566 ( N_noxref_3_c_581_n N_noxref_4_c_823_n ) capacitor c=0.00318783f \
 //x=9.685 //y=2.26 //x2=11.165 //y2=3.51
cc_567 ( N_noxref_3_M24_noxref_g N_noxref_4_M23_noxref_d ) capacitor \
 c=0.0173476f //x=10.025 //y=6.2 //x2=9.66 //y2=5.2
cc_568 ( N_noxref_3_c_567_n N_CLK_c_970_n ) capacitor c=0.00360213f //x=7.72 \
 //y=3.51 //x2=13.64 //y2=4.62
cc_569 ( N_noxref_3_c_572_n N_CLK_c_970_n ) capacitor c=4.49102e-19 //x=3.88 \
 //y=3.51 //x2=13.64 //y2=4.62
cc_570 ( N_noxref_3_c_578_n N_CLK_c_970_n ) capacitor c=0.0198958f //x=3.765 \
 //y=2.26 //x2=13.64 //y2=4.62
cc_571 ( N_noxref_3_c_596_n N_CLK_c_970_n ) capacitor c=0.0184237f //x=7.27 \
 //y=5.38 //x2=13.64 //y2=4.62
cc_572 ( N_noxref_3_c_600_n N_CLK_c_970_n ) capacitor c=0.0181237f //x=6.56 \
 //y=5.38 //x2=13.64 //y2=4.62
cc_573 ( N_noxref_3_c_580_n N_CLK_c_970_n ) capacitor c=0.0208321f //x=7.835 \
 //y=3.51 //x2=13.64 //y2=4.62
cc_574 ( N_noxref_3_c_581_n N_CLK_c_970_n ) capacitor c=0.0198304f //x=9.685 \
 //y=2.26 //x2=13.64 //y2=4.62
cc_575 ( N_noxref_3_c_646_p N_CLK_c_970_n ) capacitor c=0.0111881f //x=3.765 \
 //y=4.88 //x2=13.64 //y2=4.62
cc_576 ( N_noxref_3_c_619_n N_CLK_c_970_n ) capacitor c=0.0107057f //x=9.685 \
 //y=4.88 //x2=13.64 //y2=4.62
cc_577 ( N_noxref_3_c_578_n N_CLK_c_988_n ) capacitor c=0.00153281f //x=3.765 \
 //y=2.26 //x2=2.77 //y2=4.62
cc_578 ( N_noxref_3_c_578_n CLK ) capacitor c=0.00493712f //x=3.765 //y=2.26 \
 //x2=2.71 //y2=2.77
cc_579 ( N_noxref_3_c_578_n CLK ) capacitor c=0.00493712f //x=3.765 //y=2.26 \
 //x2=2.71 //y2=3.14
cc_580 ( N_noxref_3_c_572_n CLK ) capacitor c=0.00446435f //x=3.88 //y=3.51 \
 //x2=2.71 //y2=3.51
cc_581 ( N_noxref_3_c_578_n CLK ) capacitor c=0.00329813f //x=3.765 //y=2.26 \
 //x2=2.71 //y2=3.51
cc_582 ( N_noxref_3_c_578_n CLK ) capacitor c=0.00455774f //x=3.765 //y=2.26 \
 //x2=2.71 //y2=3.88
cc_583 ( N_noxref_3_c_578_n CLK ) capacitor c=0.00190929f //x=3.765 //y=2.26 \
 //x2=2.71 //y2=4.62
cc_584 ( N_noxref_3_c_578_n N_CLK_c_967_n ) capacitor c=0.0102353f //x=3.765 \
 //y=2.26 //x2=2.655 //y2=2.26
cc_585 ( N_noxref_3_c_656_p N_CLK_c_967_n ) capacitor c=0.00228632f //x=3.765 \
 //y=2.26 //x2=2.655 //y2=2.26
cc_586 ( N_noxref_3_c_578_n N_CLK_c_989_n ) capacitor c=0.00467264f //x=3.765 \
 //y=2.26 //x2=2.655 //y2=4.88
cc_587 ( N_noxref_3_c_646_p N_CLK_c_989_n ) capacitor c=0.00218014f //x=3.765 \
 //y=4.88 //x2=2.655 //y2=4.88
cc_588 ( N_noxref_3_c_578_n N_CLK_c_1022_n ) capacitor c=0.0042159f //x=3.765 \
 //y=2.26 //x2=2.682 //y2=3.055
cc_589 ( N_noxref_3_c_572_n N_CLK_c_1023_n ) capacitor c=6.33859e-19 //x=3.88 \
 //y=3.51 //x2=2.682 //y2=3.425
cc_590 ( N_noxref_3_c_578_n N_CLK_c_1023_n ) capacitor c=0.00395201f //x=3.765 \
 //y=2.26 //x2=2.682 //y2=3.425
cc_591 ( N_noxref_3_c_572_n N_CLK_c_1025_n ) capacitor c=6.33859e-19 //x=3.88 \
 //y=3.51 //x2=2.682 //y2=3.795
cc_592 ( N_noxref_3_c_578_n N_CLK_c_1025_n ) capacitor c=0.00391381f //x=3.765 \
 //y=2.26 //x2=2.682 //y2=3.795
cc_593 ( N_noxref_3_c_578_n N_CLK_c_992_n ) capacitor c=0.00930728f //x=3.765 \
 //y=2.26 //x2=2.682 //y2=4.535
cc_594 ( N_noxref_3_M17_noxref_g N_CLK_M15_noxref_g ) capacitor c=0.0101598f \
 //x=3.505 //y=6.2 //x2=2.625 //y2=6.2
cc_595 ( N_noxref_3_M17_noxref_g N_CLK_M16_noxref_g ) capacitor c=0.0602553f \
 //x=3.505 //y=6.2 //x2=3.065 //y2=6.2
cc_596 ( N_noxref_3_M18_noxref_g N_CLK_M16_noxref_g ) capacitor c=0.0101598f \
 //x=3.945 //y=6.2 //x2=3.065 //y2=6.2
cc_597 ( N_noxref_3_c_668_p N_CLK_c_1031_n ) capacitor c=0.00456962f //x=3.755 \
 //y=1.095 //x2=2.745 //y2=1.09
cc_598 ( N_noxref_3_c_669_p N_CLK_c_1032_n ) capacitor c=0.00438372f //x=3.755 \
 //y=1.44 //x2=2.745 //y2=1.4
cc_599 ( N_noxref_3_c_670_p N_CLK_c_1033_n ) capacitor c=0.00438372f //x=3.755 \
 //y=1.75 //x2=2.745 //y2=1.63
cc_600 ( N_noxref_3_c_578_n N_CLK_c_1034_n ) capacitor c=0.0023343f //x=3.765 \
 //y=2.26 //x2=2.745 //y2=2.095
cc_601 ( N_noxref_3_c_656_p N_CLK_c_1034_n ) capacitor c=0.00933826f //x=3.765 \
 //y=2.26 //x2=2.745 //y2=2.095
cc_602 ( N_noxref_3_c_673_p N_CLK_c_1034_n ) capacitor c=0.00438372f //x=3.765 \
 //y=2.095 //x2=2.745 //y2=2.095
cc_603 ( N_noxref_3_c_646_p N_CLK_c_1037_n ) capacitor c=0.0611812f //x=3.765 \
 //y=4.88 //x2=2.99 //y2=4.97
cc_604 ( N_noxref_3_c_578_n N_CLK_c_1038_n ) capacitor c=0.00142741f //x=3.765 \
 //y=2.26 //x2=2.655 //y2=4.88
cc_605 ( N_noxref_3_c_646_p N_CLK_c_1038_n ) capacitor c=0.00487508f //x=3.765 \
 //y=4.88 //x2=2.655 //y2=4.88
cc_606 ( N_noxref_3_c_567_n N_noxref_6_c_1263_n ) capacitor c=0.146341f \
 //x=7.72 //y=3.51 //x2=6.24 //y2=3.88
cc_607 ( N_noxref_3_c_567_n N_noxref_6_c_1264_n ) capacitor c=0.0294746f \
 //x=7.72 //y=3.51 //x2=4.62 //y2=3.88
cc_608 ( N_noxref_3_c_578_n N_noxref_6_c_1264_n ) capacitor c=0.00687545f \
 //x=3.765 //y=2.26 //x2=4.62 //y2=3.88
cc_609 ( N_noxref_3_c_567_n N_noxref_6_c_1190_n ) capacitor c=0.108586f \
 //x=7.72 //y=3.51 //x2=16.23 //y2=3.88
cc_610 ( N_noxref_3_c_573_n N_noxref_6_c_1190_n ) capacitor c=0.175696f \
 //x=9.57 //y=3.51 //x2=16.23 //y2=3.88
cc_611 ( N_noxref_3_c_577_n N_noxref_6_c_1190_n ) capacitor c=0.0267668f \
 //x=7.95 //y=3.51 //x2=16.23 //y2=3.88
cc_612 ( N_noxref_3_c_580_n N_noxref_6_c_1190_n ) capacitor c=0.0206034f \
 //x=7.835 //y=3.51 //x2=16.23 //y2=3.88
cc_613 ( N_noxref_3_c_581_n N_noxref_6_c_1190_n ) capacitor c=0.0205831f \
 //x=9.685 //y=2.26 //x2=16.23 //y2=3.88
cc_614 ( N_noxref_3_c_567_n N_noxref_6_c_1271_n ) capacitor c=0.0266674f \
 //x=7.72 //y=3.51 //x2=6.47 //y2=3.88
cc_615 ( N_noxref_3_M17_noxref_g N_noxref_6_c_1223_n ) capacitor c=0.01736f \
 //x=3.505 //y=6.2 //x2=3.64 //y2=5.335
cc_616 ( N_noxref_3_M18_noxref_g N_noxref_6_c_1227_n ) capacitor c=0.0194981f \
 //x=3.945 //y=6.2 //x2=4.42 //y2=5.335
cc_617 ( N_noxref_3_c_646_p N_noxref_6_c_1227_n ) capacitor c=0.00201851f \
 //x=3.765 //y=4.88 //x2=4.42 //y2=5.335
cc_618 ( N_noxref_3_c_689_p N_noxref_6_c_1192_n ) capacitor c=0.00359704f \
 //x=4.13 //y=1.595 //x2=4.42 //y2=1.845
cc_619 ( N_noxref_3_c_690_p N_noxref_6_c_1192_n ) capacitor c=0.00457401f \
 //x=4.285 //y=1.44 //x2=4.42 //y2=1.845
cc_620 ( N_noxref_3_c_567_n N_noxref_6_c_1277_n ) capacitor c=0.00628992f \
 //x=7.72 //y=3.51 //x2=4.105 //y2=1.845
cc_621 ( N_noxref_3_c_567_n N_noxref_6_c_1231_n ) capacitor c=0.0260398f \
 //x=7.72 //y=3.51 //x2=4.505 //y2=3.88
cc_622 ( N_noxref_3_c_572_n N_noxref_6_c_1231_n ) capacitor c=0.00117715f \
 //x=3.88 //y=3.51 //x2=4.505 //y2=3.88
cc_623 ( N_noxref_3_c_578_n N_noxref_6_c_1231_n ) capacitor c=0.0831612f \
 //x=3.765 //y=2.26 //x2=4.505 //y2=3.88
cc_624 ( N_noxref_3_c_580_n N_noxref_6_c_1231_n ) capacitor c=3.52729e-19 \
 //x=7.835 //y=3.51 //x2=4.505 //y2=3.88
cc_625 ( N_noxref_3_c_656_p N_noxref_6_c_1231_n ) capacitor c=0.00877984f \
 //x=3.765 //y=2.26 //x2=4.505 //y2=3.88
cc_626 ( N_noxref_3_c_673_p N_noxref_6_c_1231_n ) capacitor c=0.00283672f \
 //x=3.765 //y=2.095 //x2=4.505 //y2=3.88
cc_627 ( N_noxref_3_c_646_p N_noxref_6_c_1231_n ) capacitor c=0.013693f \
 //x=3.765 //y=4.88 //x2=4.505 //y2=3.88
cc_628 ( N_noxref_3_c_567_n N_noxref_6_c_1193_n ) capacitor c=0.0257693f \
 //x=7.72 //y=3.51 //x2=6.355 //y2=2.26
cc_629 ( N_noxref_3_c_578_n N_noxref_6_c_1193_n ) capacitor c=9.66956e-19 \
 //x=3.765 //y=2.26 //x2=6.355 //y2=2.26
cc_630 ( N_noxref_3_c_600_n N_noxref_6_c_1193_n ) capacitor c=0.00521572f \
 //x=6.56 //y=5.38 //x2=6.355 //y2=2.26
cc_631 ( N_noxref_3_c_580_n N_noxref_6_c_1193_n ) capacitor c=0.00323705f \
 //x=7.835 //y=3.51 //x2=6.355 //y2=2.26
cc_632 ( N_noxref_3_c_578_n N_noxref_6_c_1289_n ) capacitor c=0.0171303f \
 //x=3.765 //y=2.26 //x2=3.725 //y2=5.335
cc_633 ( N_noxref_3_c_646_p N_noxref_6_c_1289_n ) capacitor c=0.00475601f \
 //x=3.765 //y=4.88 //x2=3.725 //y2=5.335
cc_634 ( N_noxref_3_c_600_n N_noxref_6_M19_noxref_g ) capacitor c=0.0177326f \
 //x=6.56 //y=5.38 //x2=6.255 //y2=6.2
cc_635 ( N_noxref_3_c_596_n N_noxref_6_M20_noxref_g ) capacitor c=0.0169521f \
 //x=7.27 //y=5.38 //x2=6.695 //y2=6.2
cc_636 ( N_noxref_3_M19_noxref_d N_noxref_6_M20_noxref_g ) capacitor \
 c=0.0173476f //x=6.33 //y=5.2 //x2=6.695 //y2=6.2
cc_637 ( N_noxref_3_c_600_n N_noxref_6_c_1246_n ) capacitor c=0.00581252f \
 //x=6.56 //y=5.38 //x2=6.355 //y2=4.88
cc_638 ( N_noxref_3_c_668_p N_noxref_6_M2_noxref_d ) capacitor c=0.00217566f \
 //x=3.755 //y=1.095 //x2=3.83 //y2=1.095
cc_639 ( N_noxref_3_c_669_p N_noxref_6_M2_noxref_d ) capacitor c=0.0034598f \
 //x=3.755 //y=1.44 //x2=3.83 //y2=1.095
cc_640 ( N_noxref_3_c_670_p N_noxref_6_M2_noxref_d ) capacitor c=0.00544291f \
 //x=3.755 //y=1.75 //x2=3.83 //y2=1.095
cc_641 ( N_noxref_3_c_712_p N_noxref_6_M2_noxref_d ) capacitor c=0.00241102f \
 //x=4.13 //y=0.94 //x2=3.83 //y2=1.095
cc_642 ( N_noxref_3_c_689_p N_noxref_6_M2_noxref_d ) capacitor c=0.0140297f \
 //x=4.13 //y=1.595 //x2=3.83 //y2=1.095
cc_643 ( N_noxref_3_c_714_p N_noxref_6_M2_noxref_d ) capacitor c=0.00219619f \
 //x=4.285 //y=1.095 //x2=3.83 //y2=1.095
cc_644 ( N_noxref_3_c_690_p N_noxref_6_M2_noxref_d ) capacitor c=0.00603828f \
 //x=4.285 //y=1.44 //x2=3.83 //y2=1.095
cc_645 ( N_noxref_3_c_673_p N_noxref_6_M2_noxref_d ) capacitor c=0.00661782f \
 //x=3.765 //y=2.095 //x2=3.83 //y2=1.095
cc_646 ( N_noxref_3_M17_noxref_g N_noxref_6_M17_noxref_d ) capacitor \
 c=0.0180032f //x=3.505 //y=6.2 //x2=3.58 //y2=5.2
cc_647 ( N_noxref_3_M18_noxref_g N_noxref_6_M17_noxref_d ) capacitor \
 c=0.0194246f //x=3.945 //y=6.2 //x2=3.58 //y2=5.2
cc_648 ( N_noxref_3_c_567_n N_noxref_10_c_1678_n ) capacitor c=0.0430053f \
 //x=7.72 //y=3.51 //x2=10.31 //y2=4.25
cc_649 ( N_noxref_3_c_572_n N_noxref_10_c_1678_n ) capacitor c=0.0135672f \
 //x=3.88 //y=3.51 //x2=10.31 //y2=4.25
cc_650 ( N_noxref_3_c_573_n N_noxref_10_c_1678_n ) capacitor c=0.0110241f \
 //x=9.57 //y=3.51 //x2=10.31 //y2=4.25
cc_651 ( N_noxref_3_c_577_n N_noxref_10_c_1678_n ) capacitor c=5.70661e-19 \
 //x=7.95 //y=3.51 //x2=10.31 //y2=4.25
cc_652 ( N_noxref_3_c_578_n N_noxref_10_c_1678_n ) capacitor c=0.0206302f \
 //x=3.765 //y=2.26 //x2=10.31 //y2=4.25
cc_653 ( N_noxref_3_c_580_n N_noxref_10_c_1678_n ) capacitor c=0.0181936f \
 //x=7.835 //y=3.51 //x2=10.31 //y2=4.25
cc_654 ( N_noxref_3_c_581_n N_noxref_10_c_1678_n ) capacitor c=0.0184765f \
 //x=9.685 //y=2.26 //x2=10.31 //y2=4.25
cc_655 ( N_noxref_3_c_581_n N_noxref_10_c_1778_n ) capacitor c=0.00179385f \
 //x=9.685 //y=2.26 //x2=10.54 //y2=4.25
cc_656 ( N_noxref_3_c_578_n N_noxref_10_c_1681_n ) capacitor c=0.0017677f \
 //x=3.765 //y=2.26 //x2=1.545 //y2=2.26
cc_657 ( N_noxref_3_c_581_n N_noxref_10_c_1780_n ) capacitor c=0.00400249f \
 //x=9.685 //y=2.26 //x2=10.425 //y2=4.715
cc_658 ( N_noxref_3_c_619_n N_noxref_10_c_1780_n ) capacitor c=0.00417994f \
 //x=9.685 //y=4.88 //x2=10.425 //y2=4.715
cc_659 ( N_noxref_3_c_573_n N_noxref_10_c_1682_n ) capacitor c=0.00318578f \
 //x=9.57 //y=3.51 //x2=10.425 //y2=2.26
cc_660 ( N_noxref_3_c_580_n N_noxref_10_c_1682_n ) capacitor c=9.69022e-19 \
 //x=7.835 //y=3.51 //x2=10.425 //y2=2.26
cc_661 ( N_noxref_3_c_581_n N_noxref_10_c_1682_n ) capacitor c=0.0794726f \
 //x=9.685 //y=2.26 //x2=10.425 //y2=2.26
cc_662 ( N_noxref_3_c_586_n N_noxref_10_c_1682_n ) capacitor c=0.00308814f \
 //x=9.49 //y=2.095 //x2=10.425 //y2=2.26
cc_663 ( N_noxref_3_M23_noxref_g N_noxref_10_M25_noxref_g ) capacitor \
 c=0.0104611f //x=9.585 //y=6.2 //x2=10.465 //y2=6.2
cc_664 ( N_noxref_3_M24_noxref_g N_noxref_10_M25_noxref_g ) capacitor \
 c=0.106811f //x=10.025 //y=6.2 //x2=10.465 //y2=6.2
cc_665 ( N_noxref_3_M24_noxref_g N_noxref_10_M26_noxref_g ) capacitor \
 c=0.0100341f //x=10.025 //y=6.2 //x2=10.905 //y2=6.2
cc_666 ( N_noxref_3_c_582_n N_noxref_10_c_1789_n ) capacitor c=4.86506e-19 \
 //x=9.49 //y=1.045 //x2=10.46 //y2=1.085
cc_667 ( N_noxref_3_c_584_n N_noxref_10_c_1789_n ) capacitor c=0.00152104f \
 //x=9.49 //y=1.39 //x2=10.46 //y2=1.085
cc_668 ( N_noxref_3_c_589_n N_noxref_10_c_1789_n ) capacitor c=0.0151475f \
 //x=10.02 //y=1.045 //x2=10.46 //y2=1.085
cc_669 ( N_noxref_3_c_585_n N_noxref_10_c_1792_n ) capacitor c=0.00109982f \
 //x=9.49 //y=1.7 //x2=10.46 //y2=1.43
cc_670 ( N_noxref_3_c_591_n N_noxref_10_c_1792_n ) capacitor c=0.0111064f \
 //x=10.02 //y=1.39 //x2=10.46 //y2=1.43
cc_671 ( N_noxref_3_c_585_n N_noxref_10_c_1794_n ) capacitor c=9.57794e-19 \
 //x=9.49 //y=1.7 //x2=10.46 //y2=1.74
cc_672 ( N_noxref_3_c_586_n N_noxref_10_c_1794_n ) capacitor c=0.00662747f \
 //x=9.49 //y=2.095 //x2=10.46 //y2=1.74
cc_673 ( N_noxref_3_c_591_n N_noxref_10_c_1794_n ) capacitor c=0.00862358f \
 //x=10.02 //y=1.39 //x2=10.46 //y2=1.74
cc_674 ( N_noxref_3_c_589_n N_noxref_10_c_1797_n ) capacitor c=0.00124821f \
 //x=10.02 //y=1.045 //x2=10.99 //y2=1.085
cc_675 ( N_noxref_3_c_591_n N_noxref_10_c_1798_n ) capacitor c=0.00200715f \
 //x=10.02 //y=1.39 //x2=10.99 //y2=1.43
cc_676 ( N_noxref_3_c_581_n N_noxref_10_c_1799_n ) capacitor c=0.00307062f \
 //x=9.685 //y=2.26 //x2=10.425 //y2=2.26
cc_677 ( N_noxref_3_c_586_n N_noxref_10_c_1799_n ) capacitor c=0.0179092f \
 //x=9.49 //y=2.095 //x2=10.425 //y2=2.26
cc_678 ( N_noxref_3_c_581_n N_noxref_10_c_1801_n ) capacitor c=0.00344981f \
 //x=9.685 //y=2.26 //x2=10.455 //y2=4.88
cc_679 ( N_noxref_3_c_619_n N_noxref_10_c_1801_n ) capacitor c=0.0293367f \
 //x=9.685 //y=4.88 //x2=10.455 //y2=4.88
cc_680 ( N_noxref_3_c_567_n N_noxref_13_c_2197_n ) capacitor c=2.45218e-19 \
 //x=7.72 //y=3.51 //x2=4.42 //y2=0.72
cc_681 ( N_noxref_3_c_578_n N_noxref_13_c_2197_n ) capacitor c=0.00208521f \
 //x=3.765 //y=2.26 //x2=4.42 //y2=0.72
cc_682 ( N_noxref_3_c_668_p N_noxref_13_c_2197_n ) capacitor c=0.0194423f \
 //x=3.755 //y=1.095 //x2=4.42 //y2=0.72
cc_683 ( N_noxref_3_c_714_p N_noxref_13_c_2197_n ) capacitor c=0.00656458f \
 //x=4.285 //y=1.095 //x2=4.42 //y2=0.72
cc_684 ( N_noxref_3_c_656_p N_noxref_13_c_2197_n ) capacitor c=2.20712e-19 \
 //x=3.765 //y=2.26 //x2=4.42 //y2=0.72
cc_685 ( N_noxref_3_c_669_p N_noxref_13_c_2211_n ) capacitor c=0.00538829f \
 //x=3.755 //y=1.44 //x2=3.535 //y2=1.175
cc_686 ( N_noxref_3_c_668_p N_noxref_13_M2_noxref_s ) capacitor c=0.00538829f \
 //x=3.755 //y=1.095 //x2=3.4 //y2=0.555
cc_687 ( N_noxref_3_c_670_p N_noxref_13_M2_noxref_s ) capacitor c=0.00538829f \
 //x=3.755 //y=1.75 //x2=3.4 //y2=0.555
cc_688 ( N_noxref_3_c_714_p N_noxref_13_M2_noxref_s ) capacitor c=0.0143002f \
 //x=4.285 //y=1.095 //x2=3.4 //y2=0.555
cc_689 ( N_noxref_3_c_690_p N_noxref_13_M2_noxref_s ) capacitor c=0.00290153f \
 //x=4.285 //y=1.44 //x2=3.4 //y2=0.555
cc_690 ( N_noxref_3_c_580_n D ) capacitor c=0.00777753f //x=7.835 //y=3.51 \
 //x2=7.15 //y2=2.77
cc_691 ( N_noxref_3_c_567_n D ) capacitor c=0.00203703f //x=7.72 //y=3.51 \
 //x2=7.15 //y2=3.14
cc_692 ( N_noxref_3_c_596_n D ) capacitor c=2.01027e-19 //x=7.27 //y=5.38 \
 //x2=7.15 //y2=3.14
cc_693 ( N_noxref_3_c_580_n D ) capacitor c=0.00777753f //x=7.835 //y=3.51 \
 //x2=7.15 //y2=3.14
cc_694 ( N_noxref_3_c_580_n N_D_c_2246_n ) capacitor c=0.0118781f //x=7.835 \
 //y=3.51 //x2=7.095 //y2=2.485
cc_695 ( N_noxref_3_c_567_n N_D_c_2248_n ) capacitor c=0.0222863f //x=7.72 \
 //y=3.51 //x2=7.095 //y2=4.715
cc_696 ( N_noxref_3_c_577_n N_D_c_2248_n ) capacitor c=0.00117715f //x=7.95 \
 //y=3.51 //x2=7.095 //y2=4.715
cc_697 ( N_noxref_3_c_596_n N_D_c_2248_n ) capacitor c=0.0127676f //x=7.27 \
 //y=5.38 //x2=7.095 //y2=4.715
cc_698 ( N_noxref_3_c_580_n N_D_c_2248_n ) capacitor c=0.0483914f //x=7.835 \
 //y=3.51 //x2=7.095 //y2=4.715
cc_699 ( N_noxref_3_c_581_n N_D_c_2248_n ) capacitor c=5.45115e-19 //x=9.685 \
 //y=2.26 //x2=7.095 //y2=4.715
cc_700 ( N_noxref_3_c_580_n N_D_c_2247_n ) capacitor c=0.0065098f //x=7.835 \
 //y=3.51 //x2=7.122 //y2=2.685
cc_701 ( N_noxref_3_c_580_n N_D_c_2266_n ) capacitor c=0.0065098f //x=7.835 \
 //y=3.51 //x2=7.122 //y2=3.055
cc_702 ( N_noxref_3_c_596_n N_D_M21_noxref_g ) capacitor c=0.0166421f //x=7.27 \
 //y=5.38 //x2=7.135 //y2=6.2
cc_703 ( N_noxref_3_M21_noxref_d N_D_M21_noxref_g ) capacitor c=0.0173476f \
 //x=7.21 //y=5.2 //x2=7.135 //y2=6.2
cc_704 ( N_noxref_3_c_602_n N_D_M22_noxref_g ) capacitor c=0.018922f //x=7.75 \
 //y=5.38 //x2=7.575 //y2=6.2
cc_705 ( N_noxref_3_M21_noxref_d N_D_M22_noxref_g ) capacitor c=0.0179769f \
 //x=7.21 //y=5.2 //x2=7.575 //y2=6.2
cc_706 ( N_noxref_3_M4_noxref_d N_D_c_2271_n ) capacitor c=0.00217566f \
 //x=7.205 //y=1.085 //x2=7.13 //y2=1.085
cc_707 ( N_noxref_3_M4_noxref_d N_D_c_2272_n ) capacitor c=0.0034598f \
 //x=7.205 //y=1.085 //x2=7.13 //y2=1.43
cc_708 ( N_noxref_3_M4_noxref_d N_D_c_2273_n ) capacitor c=0.00657067f \
 //x=7.205 //y=1.085 //x2=7.13 //y2=1.74
cc_709 ( N_noxref_3_c_580_n N_D_c_2274_n ) capacitor c=0.0142673f //x=7.835 \
 //y=3.51 //x2=7.5 //y2=4.97
cc_710 ( N_noxref_3_c_781_p N_D_c_2274_n ) capacitor c=0.00407665f //x=7.355 \
 //y=5.38 //x2=7.5 //y2=4.97
cc_711 ( N_noxref_3_M4_noxref_d N_D_c_2276_n ) capacitor c=0.00241102f \
 //x=7.205 //y=1.085 //x2=7.505 //y2=0.93
cc_712 ( N_noxref_3_c_579_n N_D_c_2277_n ) capacitor c=0.00359704f //x=7.75 \
 //y=1.835 //x2=7.505 //y2=1.585
cc_713 ( N_noxref_3_M4_noxref_d N_D_c_2277_n ) capacitor c=0.0138845f \
 //x=7.205 //y=1.085 //x2=7.505 //y2=1.585
cc_714 ( N_noxref_3_M4_noxref_d N_D_c_2279_n ) capacitor c=0.00132245f \
 //x=7.205 //y=1.085 //x2=7.66 //y2=1.085
cc_715 ( N_noxref_3_c_579_n N_D_c_2280_n ) capacitor c=0.00457401f //x=7.75 \
 //y=1.835 //x2=7.66 //y2=1.43
cc_716 ( N_noxref_3_M4_noxref_d N_D_c_2280_n ) capacitor c=0.00566463f \
 //x=7.205 //y=1.085 //x2=7.66 //y2=1.43
cc_717 ( N_noxref_3_c_580_n N_D_c_2282_n ) capacitor c=0.00903754f //x=7.835 \
 //y=3.51 //x2=7.095 //y2=2.26
cc_718 ( N_noxref_3_c_580_n N_D_c_2283_n ) capacitor c=0.00306024f //x=7.835 \
 //y=3.51 //x2=7.095 //y2=2.095
cc_719 ( N_noxref_3_M4_noxref_d N_D_c_2283_n ) capacitor c=0.00660593f \
 //x=7.205 //y=1.085 //x2=7.095 //y2=2.095
cc_720 ( N_noxref_3_c_596_n N_D_c_2285_n ) capacitor c=0.00346527f //x=7.27 \
 //y=5.38 //x2=7.125 //y2=4.88
cc_721 ( N_noxref_3_c_580_n N_D_c_2285_n ) capacitor c=0.00533692f //x=7.835 \
 //y=3.51 //x2=7.125 //y2=4.88
cc_722 ( N_noxref_3_c_567_n N_noxref_15_c_2344_n ) capacitor c=0.00241565f \
 //x=7.72 //y=3.51 //x2=5.94 //y2=1.675
cc_723 ( N_noxref_3_c_794_p N_noxref_15_c_2344_n ) capacitor c=3.15806e-19 \
 //x=7.48 //y=1.835 //x2=5.94 //y2=1.675
cc_724 ( N_noxref_3_c_567_n N_noxref_15_c_2325_n ) capacitor c=0.010299f \
 //x=7.72 //y=3.51 //x2=6.825 //y2=1.76
cc_725 ( N_noxref_3_c_567_n N_noxref_15_c_2332_n ) capacitor c=0.00241565f \
 //x=7.72 //y=3.51 //x2=6.91 //y2=1.675
cc_726 ( N_noxref_3_c_794_p N_noxref_15_c_2332_n ) capacitor c=0.020324f \
 //x=7.48 //y=1.835 //x2=6.91 //y2=1.675
cc_727 ( N_noxref_3_c_567_n N_noxref_15_c_2333_n ) capacitor c=4.34022e-19 \
 //x=7.72 //y=3.51 //x2=7.795 //y2=0.71
cc_728 ( N_noxref_3_c_579_n N_noxref_15_c_2333_n ) capacitor c=0.00465965f \
 //x=7.75 //y=1.835 //x2=7.795 //y2=0.71
cc_729 ( N_noxref_3_M4_noxref_d N_noxref_15_c_2333_n ) capacitor c=0.0117692f \
 //x=7.205 //y=1.085 //x2=7.795 //y2=0.71
cc_730 ( N_noxref_3_c_577_n N_noxref_15_M3_noxref_s ) capacitor c=3.47564e-19 \
 //x=7.95 //y=3.51 //x2=5.805 //y2=0.545
cc_731 ( N_noxref_3_c_579_n N_noxref_15_M3_noxref_s ) capacitor c=0.0141735f \
 //x=7.75 //y=1.835 //x2=5.805 //y2=0.545
cc_732 ( N_noxref_3_M4_noxref_d N_noxref_15_M3_noxref_s ) capacitor \
 c=0.0439476f //x=7.205 //y=1.085 //x2=5.805 //y2=0.545
cc_733 ( N_noxref_3_c_573_n N_noxref_16_c_2397_n ) capacitor c=0.00241565f \
 //x=9.57 //y=3.51 //x2=9.27 //y2=1.675
cc_734 ( N_noxref_3_c_579_n N_noxref_16_c_2397_n ) capacitor c=3.22188e-19 \
 //x=7.75 //y=1.835 //x2=9.27 //y2=1.675
cc_735 ( N_noxref_3_c_586_n N_noxref_16_c_2397_n ) capacitor c=0.0034165f \
 //x=9.49 //y=2.095 //x2=9.27 //y2=1.675
cc_736 ( N_noxref_3_c_573_n N_noxref_16_c_2378_n ) capacitor c=0.00649414f \
 //x=9.57 //y=3.51 //x2=10.155 //y2=1.76
cc_737 ( N_noxref_3_c_581_n N_noxref_16_c_2378_n ) capacitor c=0.011692f \
 //x=9.685 //y=2.26 //x2=10.155 //y2=1.76
cc_738 ( N_noxref_3_c_585_n N_noxref_16_c_2378_n ) capacitor c=0.00703567f \
 //x=9.49 //y=1.7 //x2=10.155 //y2=1.76
cc_739 ( N_noxref_3_c_586_n N_noxref_16_c_2378_n ) capacitor c=0.0203514f \
 //x=9.49 //y=2.095 //x2=10.155 //y2=1.76
cc_740 ( N_noxref_3_c_588_n N_noxref_16_c_2378_n ) capacitor c=0.00780629f \
 //x=9.865 //y=1.545 //x2=10.155 //y2=1.76
cc_741 ( N_noxref_3_c_591_n N_noxref_16_c_2378_n ) capacitor c=0.00339872f \
 //x=10.02 //y=1.39 //x2=10.155 //y2=1.76
cc_742 ( N_noxref_3_c_586_n N_noxref_16_c_2385_n ) capacitor c=6.71402e-19 \
 //x=9.49 //y=2.095 //x2=10.24 //y2=1.675
cc_743 ( N_noxref_3_c_582_n N_noxref_16_M5_noxref_s ) capacitor c=0.0326577f \
 //x=9.49 //y=1.045 //x2=9.135 //y2=0.545
cc_744 ( N_noxref_3_c_585_n N_noxref_16_M5_noxref_s ) capacitor c=3.48408e-19 \
 //x=9.49 //y=1.7 //x2=9.135 //y2=0.545
cc_745 ( N_noxref_3_c_589_n N_noxref_16_M5_noxref_s ) capacitor c=0.0120759f \
 //x=10.02 //y=1.045 //x2=9.135 //y2=0.545
cc_746 ( N_noxref_4_c_838_n N_CLK_c_970_n ) capacitor c=0.0185297f //x=10.6 \
 //y=5.38 //x2=13.64 //y2=4.62
cc_747 ( N_noxref_4_c_842_n N_CLK_c_970_n ) capacitor c=0.018142f //x=9.89 \
 //y=5.38 //x2=13.64 //y2=4.62
cc_748 ( N_noxref_4_c_823_n N_CLK_c_970_n ) capacitor c=0.0208321f //x=11.165 \
 //y=3.51 //x2=13.64 //y2=4.62
cc_749 ( N_noxref_4_c_824_n N_CLK_c_970_n ) capacitor c=0.0215137f //x=13.015 \
 //y=2.26 //x2=13.64 //y2=4.62
cc_750 ( N_noxref_4_c_857_n N_CLK_c_970_n ) capacitor c=0.0109968f //x=13.015 \
 //y=4.88 //x2=13.64 //y2=4.62
cc_751 ( N_noxref_4_c_824_n N_CLK_c_1045_n ) capacitor c=0.00400249f \
 //x=13.015 //y=2.26 //x2=13.755 //y2=4.715
cc_752 ( N_noxref_4_c_857_n N_CLK_c_1045_n ) capacitor c=0.00415951f \
 //x=13.015 //y=4.88 //x2=13.755 //y2=4.715
cc_753 ( N_noxref_4_c_817_n N_CLK_c_968_n ) capacitor c=0.00720056f //x=12.9 \
 //y=3.51 //x2=13.755 //y2=2.26
cc_754 ( N_noxref_4_c_823_n N_CLK_c_968_n ) capacitor c=0.00102338f //x=11.165 \
 //y=3.51 //x2=13.755 //y2=2.26
cc_755 ( N_noxref_4_c_824_n N_CLK_c_968_n ) capacitor c=0.0785565f //x=13.015 \
 //y=2.26 //x2=13.755 //y2=2.26
cc_756 ( N_noxref_4_c_829_n N_CLK_c_968_n ) capacitor c=0.00308814f //x=12.82 \
 //y=2.095 //x2=13.755 //y2=2.26
cc_757 ( N_noxref_4_M27_noxref_g N_CLK_M29_noxref_g ) capacitor c=0.0104611f \
 //x=12.915 //y=6.2 //x2=13.795 //y2=6.2
cc_758 ( N_noxref_4_M28_noxref_g N_CLK_M29_noxref_g ) capacitor c=0.106811f \
 //x=13.355 //y=6.2 //x2=13.795 //y2=6.2
cc_759 ( N_noxref_4_M28_noxref_g N_CLK_M30_noxref_g ) capacitor c=0.0100341f \
 //x=13.355 //y=6.2 //x2=14.235 //y2=6.2
cc_760 ( N_noxref_4_c_825_n N_CLK_c_1054_n ) capacitor c=4.86506e-19 //x=12.82 \
 //y=1.045 //x2=13.79 //y2=1.085
cc_761 ( N_noxref_4_c_827_n N_CLK_c_1054_n ) capacitor c=0.00152104f //x=12.82 \
 //y=1.39 //x2=13.79 //y2=1.085
cc_762 ( N_noxref_4_c_832_n N_CLK_c_1054_n ) capacitor c=0.0151475f //x=13.35 \
 //y=1.045 //x2=13.79 //y2=1.085
cc_763 ( N_noxref_4_c_828_n N_CLK_c_1057_n ) capacitor c=0.00109982f //x=12.82 \
 //y=1.7 //x2=13.79 //y2=1.43
cc_764 ( N_noxref_4_c_834_n N_CLK_c_1057_n ) capacitor c=0.0111064f //x=13.35 \
 //y=1.39 //x2=13.79 //y2=1.43
cc_765 ( N_noxref_4_c_828_n N_CLK_c_1059_n ) capacitor c=9.57794e-19 //x=12.82 \
 //y=1.7 //x2=13.79 //y2=1.74
cc_766 ( N_noxref_4_c_829_n N_CLK_c_1059_n ) capacitor c=0.00662747f //x=12.82 \
 //y=2.095 //x2=13.79 //y2=1.74
cc_767 ( N_noxref_4_c_834_n N_CLK_c_1059_n ) capacitor c=0.00862358f //x=13.35 \
 //y=1.39 //x2=13.79 //y2=1.74
cc_768 ( N_noxref_4_c_832_n N_CLK_c_1062_n ) capacitor c=0.00124821f //x=13.35 \
 //y=1.045 //x2=14.32 //y2=1.085
cc_769 ( N_noxref_4_c_834_n N_CLK_c_1063_n ) capacitor c=0.00200715f //x=13.35 \
 //y=1.39 //x2=14.32 //y2=1.43
cc_770 ( N_noxref_4_c_824_n N_CLK_c_1064_n ) capacitor c=0.00307062f \
 //x=13.015 //y=2.26 //x2=13.755 //y2=2.26
cc_771 ( N_noxref_4_c_829_n N_CLK_c_1064_n ) capacitor c=0.0179092f //x=12.82 \
 //y=2.095 //x2=13.755 //y2=2.26
cc_772 ( N_noxref_4_c_824_n N_CLK_c_1066_n ) capacitor c=0.00342116f \
 //x=13.015 //y=2.26 //x2=13.785 //y2=4.88
cc_773 ( N_noxref_4_c_857_n N_CLK_c_1066_n ) capacitor c=0.0292158f //x=13.015 \
 //y=4.88 //x2=13.785 //y2=4.88
cc_774 ( N_noxref_4_c_817_n N_noxref_6_c_1190_n ) capacitor c=0.175696f \
 //x=12.9 //y=3.51 //x2=16.23 //y2=3.88
cc_775 ( N_noxref_4_c_821_n N_noxref_6_c_1190_n ) capacitor c=0.0293967f \
 //x=11.28 //y=3.51 //x2=16.23 //y2=3.88
cc_776 ( N_noxref_4_c_907_p N_noxref_6_c_1190_n ) capacitor c=0.0037701f \
 //x=10.81 //y=1.835 //x2=16.23 //y2=3.88
cc_777 ( N_noxref_4_c_823_n N_noxref_6_c_1190_n ) capacitor c=0.0206034f \
 //x=11.165 //y=3.51 //x2=16.23 //y2=3.88
cc_778 ( N_noxref_4_c_824_n N_noxref_6_c_1190_n ) capacitor c=0.0205831f \
 //x=13.015 //y=2.26 //x2=16.23 //y2=3.88
cc_779 ( N_noxref_4_c_817_n N_noxref_10_c_1708_n ) capacitor c=0.0110241f \
 //x=12.9 //y=3.51 //x2=14.38 //y2=4.25
cc_780 ( N_noxref_4_c_821_n N_noxref_10_c_1708_n ) capacitor c=8.88358e-19 \
 //x=11.28 //y=3.51 //x2=14.38 //y2=4.25
cc_781 ( N_noxref_4_c_823_n N_noxref_10_c_1708_n ) capacitor c=0.0181936f \
 //x=11.165 //y=3.51 //x2=14.38 //y2=4.25
cc_782 ( N_noxref_4_c_824_n N_noxref_10_c_1708_n ) capacitor c=0.0184765f \
 //x=13.015 //y=2.26 //x2=14.38 //y2=4.25
cc_783 ( N_noxref_4_c_823_n N_noxref_10_c_1778_n ) capacitor c=0.00117715f \
 //x=11.165 //y=3.51 //x2=10.54 //y2=4.25
cc_784 ( N_noxref_4_c_838_n N_noxref_10_c_1780_n ) capacitor c=0.0127164f \
 //x=10.6 //y=5.38 //x2=10.425 //y2=4.715
cc_785 ( N_noxref_4_c_823_n N_noxref_10_c_1780_n ) capacitor c=0.0101319f \
 //x=11.165 //y=3.51 //x2=10.425 //y2=4.715
cc_786 ( N_noxref_4_c_821_n N_noxref_10_c_1682_n ) capacitor c=0.00329059f \
 //x=11.28 //y=3.51 //x2=10.425 //y2=2.26
cc_787 ( N_noxref_4_c_823_n N_noxref_10_c_1682_n ) capacitor c=0.0742673f \
 //x=11.165 //y=3.51 //x2=10.425 //y2=2.26
cc_788 ( N_noxref_4_c_824_n N_noxref_10_c_1682_n ) capacitor c=9.69022e-19 \
 //x=13.015 //y=2.26 //x2=10.425 //y2=2.26
cc_789 ( N_noxref_4_M28_noxref_g N_noxref_10_c_1730_n ) capacitor c=0.0169521f \
 //x=13.355 //y=6.2 //x2=13.93 //y2=5.38
cc_790 ( N_noxref_4_c_824_n N_noxref_10_c_1734_n ) capacitor c=0.00539951f \
 //x=13.015 //y=2.26 //x2=13.22 //y2=5.38
cc_791 ( N_noxref_4_M27_noxref_g N_noxref_10_c_1734_n ) capacitor c=0.0177326f \
 //x=12.915 //y=6.2 //x2=13.22 //y2=5.38
cc_792 ( N_noxref_4_c_857_n N_noxref_10_c_1734_n ) capacitor c=0.00581252f \
 //x=13.015 //y=4.88 //x2=13.22 //y2=5.38
cc_793 ( N_noxref_4_c_823_n N_noxref_10_c_1685_n ) capacitor c=3.49822e-19 \
 //x=11.165 //y=3.51 //x2=14.495 //y2=4.25
cc_794 ( N_noxref_4_c_824_n N_noxref_10_c_1685_n ) capacitor c=0.00389543f \
 //x=13.015 //y=2.26 //x2=14.495 //y2=4.25
cc_795 ( N_noxref_4_c_838_n N_noxref_10_M25_noxref_g ) capacitor c=0.0166421f \
 //x=10.6 //y=5.38 //x2=10.465 //y2=6.2
cc_796 ( N_noxref_4_M25_noxref_d N_noxref_10_M25_noxref_g ) capacitor \
 c=0.0173476f //x=10.54 //y=5.2 //x2=10.465 //y2=6.2
cc_797 ( N_noxref_4_c_844_n N_noxref_10_M26_noxref_g ) capacitor c=0.018922f \
 //x=11.08 //y=5.38 //x2=10.905 //y2=6.2
cc_798 ( N_noxref_4_M25_noxref_d N_noxref_10_M26_noxref_g ) capacitor \
 c=0.0179769f //x=10.54 //y=5.2 //x2=10.905 //y2=6.2
cc_799 ( N_noxref_4_M6_noxref_d N_noxref_10_c_1789_n ) capacitor c=0.00217566f \
 //x=10.535 //y=1.085 //x2=10.46 //y2=1.085
cc_800 ( N_noxref_4_M6_noxref_d N_noxref_10_c_1792_n ) capacitor c=0.0034598f \
 //x=10.535 //y=1.085 //x2=10.46 //y2=1.43
cc_801 ( N_noxref_4_M6_noxref_d N_noxref_10_c_1794_n ) capacitor c=0.0065582f \
 //x=10.535 //y=1.085 //x2=10.46 //y2=1.74
cc_802 ( N_noxref_4_c_823_n N_noxref_10_c_1826_n ) capacitor c=0.0142673f \
 //x=11.165 //y=3.51 //x2=10.83 //y2=4.97
cc_803 ( N_noxref_4_c_934_p N_noxref_10_c_1826_n ) capacitor c=0.00407665f \
 //x=10.685 //y=5.38 //x2=10.83 //y2=4.97
cc_804 ( N_noxref_4_M6_noxref_d N_noxref_10_c_1828_n ) capacitor c=0.00241102f \
 //x=10.535 //y=1.085 //x2=10.835 //y2=0.93
cc_805 ( N_noxref_4_c_822_n N_noxref_10_c_1829_n ) capacitor c=0.00359704f \
 //x=11.08 //y=1.835 //x2=10.835 //y2=1.585
cc_806 ( N_noxref_4_M6_noxref_d N_noxref_10_c_1829_n ) capacitor c=0.0138845f \
 //x=10.535 //y=1.085 //x2=10.835 //y2=1.585
cc_807 ( N_noxref_4_M6_noxref_d N_noxref_10_c_1797_n ) capacitor c=0.00132245f \
 //x=10.535 //y=1.085 //x2=10.99 //y2=1.085
cc_808 ( N_noxref_4_c_822_n N_noxref_10_c_1798_n ) capacitor c=0.00457401f \
 //x=11.08 //y=1.835 //x2=10.99 //y2=1.43
cc_809 ( N_noxref_4_M6_noxref_d N_noxref_10_c_1798_n ) capacitor c=0.00566463f \
 //x=10.535 //y=1.085 //x2=10.99 //y2=1.43
cc_810 ( N_noxref_4_c_823_n N_noxref_10_c_1799_n ) capacitor c=0.00877984f \
 //x=11.165 //y=3.51 //x2=10.425 //y2=2.26
cc_811 ( N_noxref_4_c_823_n N_noxref_10_c_1835_n ) capacitor c=0.00306024f \
 //x=11.165 //y=3.51 //x2=10.425 //y2=2.095
cc_812 ( N_noxref_4_M6_noxref_d N_noxref_10_c_1835_n ) capacitor c=0.00660593f \
 //x=10.535 //y=1.085 //x2=10.425 //y2=2.095
cc_813 ( N_noxref_4_c_838_n N_noxref_10_c_1801_n ) capacitor c=0.00346527f \
 //x=10.6 //y=5.38 //x2=10.455 //y2=4.88
cc_814 ( N_noxref_4_c_823_n N_noxref_10_c_1801_n ) capacitor c=0.00517969f \
 //x=11.165 //y=3.51 //x2=10.455 //y2=4.88
cc_815 ( N_noxref_4_M28_noxref_g N_noxref_10_M27_noxref_d ) capacitor \
 c=0.0173476f //x=13.355 //y=6.2 //x2=12.99 //y2=5.2
cc_816 ( N_noxref_4_c_907_p N_noxref_16_c_2397_n ) capacitor c=3.15806e-19 \
 //x=10.81 //y=1.835 //x2=9.27 //y2=1.675
cc_817 ( N_noxref_4_c_907_p N_noxref_16_c_2385_n ) capacitor c=0.0203424f \
 //x=10.81 //y=1.835 //x2=10.24 //y2=1.675
cc_818 ( N_noxref_4_c_822_n N_noxref_16_c_2386_n ) capacitor c=0.0046686f \
 //x=11.08 //y=1.835 //x2=11.125 //y2=0.71
cc_819 ( N_noxref_4_M6_noxref_d N_noxref_16_c_2386_n ) capacitor c=0.0117932f \
 //x=10.535 //y=1.085 //x2=11.125 //y2=0.71
cc_820 ( N_noxref_4_c_821_n N_noxref_16_M5_noxref_s ) capacitor c=3.47564e-19 \
 //x=11.28 //y=3.51 //x2=9.135 //y2=0.545
cc_821 ( N_noxref_4_c_822_n N_noxref_16_M5_noxref_s ) capacitor c=0.0141735f \
 //x=11.08 //y=1.835 //x2=9.135 //y2=0.545
cc_822 ( N_noxref_4_M6_noxref_d N_noxref_16_M5_noxref_s ) capacitor \
 c=0.043966f //x=10.535 //y=1.085 //x2=9.135 //y2=0.545
cc_823 ( N_noxref_4_c_817_n N_noxref_17_c_2450_n ) capacitor c=0.00241565f \
 //x=12.9 //y=3.51 //x2=12.6 //y2=1.675
cc_824 ( N_noxref_4_c_822_n N_noxref_17_c_2450_n ) capacitor c=3.22188e-19 \
 //x=11.08 //y=1.835 //x2=12.6 //y2=1.675
cc_825 ( N_noxref_4_c_829_n N_noxref_17_c_2450_n ) capacitor c=0.0034165f \
 //x=12.82 //y=2.095 //x2=12.6 //y2=1.675
cc_826 ( N_noxref_4_c_817_n N_noxref_17_c_2431_n ) capacitor c=0.00649414f \
 //x=12.9 //y=3.51 //x2=13.485 //y2=1.76
cc_827 ( N_noxref_4_c_824_n N_noxref_17_c_2431_n ) capacitor c=0.011692f \
 //x=13.015 //y=2.26 //x2=13.485 //y2=1.76
cc_828 ( N_noxref_4_c_828_n N_noxref_17_c_2431_n ) capacitor c=0.00703567f \
 //x=12.82 //y=1.7 //x2=13.485 //y2=1.76
cc_829 ( N_noxref_4_c_829_n N_noxref_17_c_2431_n ) capacitor c=0.0203514f \
 //x=12.82 //y=2.095 //x2=13.485 //y2=1.76
cc_830 ( N_noxref_4_c_831_n N_noxref_17_c_2431_n ) capacitor c=0.00780629f \
 //x=13.195 //y=1.545 //x2=13.485 //y2=1.76
cc_831 ( N_noxref_4_c_834_n N_noxref_17_c_2431_n ) capacitor c=0.00339872f \
 //x=13.35 //y=1.39 //x2=13.485 //y2=1.76
cc_832 ( N_noxref_4_c_829_n N_noxref_17_c_2438_n ) capacitor c=6.71402e-19 \
 //x=12.82 //y=2.095 //x2=13.57 //y2=1.675
cc_833 ( N_noxref_4_c_825_n N_noxref_17_M7_noxref_s ) capacitor c=0.0326577f \
 //x=12.82 //y=1.045 //x2=12.465 //y2=0.545
cc_834 ( N_noxref_4_c_828_n N_noxref_17_M7_noxref_s ) capacitor c=3.48408e-19 \
 //x=12.82 //y=1.7 //x2=12.465 //y2=0.545
cc_835 ( N_noxref_4_c_832_n N_noxref_17_M7_noxref_s ) capacitor c=0.0120759f \
 //x=13.35 //y=1.045 //x2=12.465 //y2=0.545
cc_836 ( N_CLK_c_970_n N_noxref_6_c_1263_n ) capacitor c=0.00940379f //x=13.64 \
 //y=4.62 //x2=6.24 //y2=3.88
cc_837 ( N_CLK_c_970_n N_noxref_6_c_1264_n ) capacitor c=7.95009e-19 //x=13.64 \
 //y=4.62 //x2=4.62 //y2=3.88
cc_838 ( N_CLK_c_970_n N_noxref_6_c_1190_n ) capacitor c=0.0494307f //x=13.64 \
 //y=4.62 //x2=16.23 //y2=3.88
cc_839 ( N_CLK_c_968_n N_noxref_6_c_1190_n ) capacitor c=0.0225527f //x=13.755 \
 //y=2.26 //x2=16.23 //y2=3.88
cc_840 ( N_CLK_c_970_n N_noxref_6_c_1271_n ) capacitor c=6.59192e-19 //x=13.64 \
 //y=4.62 //x2=6.47 //y2=3.88
cc_841 ( N_CLK_c_988_n N_noxref_6_c_1217_n ) capacitor c=0.00283946f //x=2.77 \
 //y=4.62 //x2=2.76 //y2=5.335
cc_842 ( CLK N_noxref_6_c_1217_n ) capacitor c=0.00132827f //x=2.71 //y=4.62 \
 //x2=2.76 //y2=5.335
cc_843 ( N_CLK_c_989_n N_noxref_6_c_1217_n ) capacitor c=0.014564f //x=2.655 \
 //y=4.88 //x2=2.76 //y2=5.335
cc_844 ( N_CLK_M15_noxref_g N_noxref_6_c_1217_n ) capacitor c=0.016514f \
 //x=2.625 //y=6.2 //x2=2.76 //y2=5.335
cc_845 ( N_CLK_c_1038_n N_noxref_6_c_1217_n ) capacitor c=0.00322046f \
 //x=2.655 //y=4.88 //x2=2.76 //y2=5.335
cc_846 ( N_CLK_M16_noxref_g N_noxref_6_c_1223_n ) capacitor c=0.01736f \
 //x=3.065 //y=6.2 //x2=3.64 //y2=5.335
cc_847 ( N_CLK_c_970_n N_noxref_6_c_1227_n ) capacitor c=0.0183122f //x=13.64 \
 //y=4.62 //x2=4.42 //y2=5.335
cc_848 ( N_CLK_c_970_n N_noxref_6_c_1231_n ) capacitor c=0.0210274f //x=13.64 \
 //y=4.62 //x2=4.505 //y2=3.88
cc_849 ( N_CLK_c_967_n N_noxref_6_c_1231_n ) capacitor c=8.06137e-19 //x=2.655 \
 //y=2.26 //x2=4.505 //y2=3.88
cc_850 ( N_CLK_c_1023_n N_noxref_6_c_1231_n ) capacitor c=2.32128e-19 \
 //x=2.682 //y=3.425 //x2=4.505 //y2=3.88
cc_851 ( N_CLK_c_1025_n N_noxref_6_c_1231_n ) capacitor c=2.37933e-19 \
 //x=2.682 //y=3.795 //x2=4.505 //y2=3.88
cc_852 ( N_CLK_c_992_n N_noxref_6_c_1231_n ) capacitor c=4.67028e-19 //x=2.682 \
 //y=4.535 //x2=4.505 //y2=3.88
cc_853 ( N_CLK_c_970_n N_noxref_6_c_1193_n ) capacitor c=0.0198304f //x=13.64 \
 //y=4.62 //x2=6.355 //y2=2.26
cc_854 ( N_CLK_c_968_n N_noxref_6_c_1194_n ) capacitor c=0.00101176f \
 //x=13.755 //y=2.26 //x2=16.345 //y2=2.26
cc_855 ( N_CLK_c_970_n N_noxref_6_c_1329_n ) capacitor c=0.03056f //x=13.64 \
 //y=4.62 //x2=2.845 //y2=5.335
cc_856 ( N_CLK_c_1037_n N_noxref_6_c_1329_n ) capacitor c=0.00419184f //x=2.99 \
 //y=4.97 //x2=2.845 //y2=5.335
cc_857 ( N_CLK_c_970_n N_noxref_6_c_1246_n ) capacitor c=0.0107057f //x=13.64 \
 //y=4.62 //x2=6.355 //y2=4.88
cc_858 ( N_CLK_M15_noxref_g N_noxref_6_M15_noxref_d ) capacitor c=0.0180032f \
 //x=2.625 //y=6.2 //x2=2.7 //y2=5.2
cc_859 ( N_CLK_M16_noxref_g N_noxref_6_M15_noxref_d ) capacitor c=0.0180032f \
 //x=3.065 //y=6.2 //x2=2.7 //y2=5.2
cc_860 ( N_CLK_c_970_n N_noxref_10_c_1678_n ) capacitor c=0.65667f //x=13.64 \
 //y=4.62 //x2=10.31 //y2=4.25
cc_861 ( N_CLK_c_988_n N_noxref_10_c_1678_n ) capacitor c=0.02921f //x=2.77 \
 //y=4.62 //x2=10.31 //y2=4.25
cc_862 ( CLK N_noxref_10_c_1678_n ) capacitor c=0.00161863f //x=2.71 //y=3.88 \
 //x2=10.31 //y2=4.25
cc_863 ( CLK N_noxref_10_c_1678_n ) capacitor c=0.00263824f //x=2.71 //y=4.62 \
 //x2=10.31 //y2=4.25
cc_864 ( N_CLK_c_992_n N_noxref_10_c_1678_n ) capacitor c=0.0245142f //x=2.682 \
 //y=4.535 //x2=10.31 //y2=4.25
cc_865 ( N_CLK_c_1038_n N_noxref_10_c_1678_n ) capacitor c=3.07672e-19 \
 //x=2.655 //y=4.88 //x2=10.31 //y2=4.25
cc_866 ( N_CLK_c_992_n N_noxref_10_c_1679_n ) capacitor c=0.00128547f \
 //x=2.682 //y=4.535 //x2=1.66 //y2=4.25
cc_867 ( N_CLK_c_970_n N_noxref_10_c_1708_n ) capacitor c=0.300301f //x=13.64 \
 //y=4.62 //x2=14.38 //y2=4.25
cc_868 ( N_CLK_c_968_n N_noxref_10_c_1708_n ) capacitor c=0.0187718f \
 //x=13.755 //y=2.26 //x2=14.38 //y2=4.25
cc_869 ( N_CLK_c_1101_p N_noxref_10_c_1708_n ) capacitor c=0.00756255f \
 //x=14.16 //y=4.97 //x2=14.38 //y2=4.25
cc_870 ( N_CLK_c_1066_n N_noxref_10_c_1708_n ) capacitor c=4.6185e-19 \
 //x=13.785 //y=4.88 //x2=14.38 //y2=4.25
cc_871 ( N_CLK_c_970_n N_noxref_10_c_1778_n ) capacitor c=0.0263375f //x=13.64 \
 //y=4.62 //x2=10.54 //y2=4.25
cc_872 ( N_CLK_c_968_n N_noxref_10_c_1722_n ) capacitor c=0.00117715f \
 //x=13.755 //y=2.26 //x2=14.61 //y2=4.25
cc_873 ( N_CLK_c_988_n N_noxref_10_c_1681_n ) capacitor c=0.00551083f //x=2.77 \
 //y=4.62 //x2=1.545 //y2=2.26
cc_874 ( N_CLK_c_967_n N_noxref_10_c_1681_n ) capacitor c=0.0534679f //x=2.655 \
 //y=2.26 //x2=1.545 //y2=2.26
cc_875 ( N_CLK_c_1034_n N_noxref_10_c_1681_n ) capacitor c=0.00231304f \
 //x=2.745 //y=2.095 //x2=1.545 //y2=2.26
cc_876 ( N_CLK_c_1038_n N_noxref_10_c_1681_n ) capacitor c=0.00183762f \
 //x=2.655 //y=4.88 //x2=1.545 //y2=2.26
cc_877 ( N_CLK_c_970_n N_noxref_10_c_1780_n ) capacitor c=0.0016972f //x=13.64 \
 //y=4.62 //x2=10.425 //y2=4.715
cc_878 ( N_CLK_c_970_n N_noxref_10_c_1682_n ) capacitor c=0.0207534f //x=13.64 \
 //y=4.62 //x2=10.425 //y2=2.26
cc_879 ( N_CLK_c_970_n N_noxref_10_c_1730_n ) capacitor c=0.00325337f \
 //x=13.64 //y=4.62 //x2=13.93 //y2=5.38
cc_880 ( N_CLK_c_1045_n N_noxref_10_c_1730_n ) capacitor c=0.0126974f \
 //x=13.755 //y=4.715 //x2=13.93 //y2=5.38
cc_881 ( N_CLK_c_968_n N_noxref_10_c_1730_n ) capacitor c=3.74769e-19 \
 //x=13.755 //y=2.26 //x2=13.93 //y2=5.38
cc_882 ( N_CLK_M29_noxref_g N_noxref_10_c_1730_n ) capacitor c=0.0166421f \
 //x=13.795 //y=6.2 //x2=13.93 //y2=5.38
cc_883 ( N_CLK_c_1066_n N_noxref_10_c_1730_n ) capacitor c=0.00346519f \
 //x=13.785 //y=4.88 //x2=13.93 //y2=5.38
cc_884 ( N_CLK_c_970_n N_noxref_10_c_1734_n ) capacitor c=0.0172877f //x=13.64 \
 //y=4.62 //x2=13.22 //y2=5.38
cc_885 ( N_CLK_M30_noxref_g N_noxref_10_c_1736_n ) capacitor c=0.0199348f \
 //x=14.235 //y=6.2 //x2=14.41 //y2=5.38
cc_886 ( N_CLK_c_1118_p N_noxref_10_c_1684_n ) capacitor c=0.00359704f \
 //x=14.165 //y=1.585 //x2=14.41 //y2=1.835
cc_887 ( N_CLK_c_1063_n N_noxref_10_c_1684_n ) capacitor c=0.00457401f \
 //x=14.32 //y=1.43 //x2=14.41 //y2=1.835
cc_888 ( N_CLK_c_970_n N_noxref_10_c_1685_n ) capacitor c=0.00707546f \
 //x=13.64 //y=4.62 //x2=14.495 //y2=4.25
cc_889 ( N_CLK_c_1045_n N_noxref_10_c_1685_n ) capacitor c=0.00923416f \
 //x=13.755 //y=4.715 //x2=14.495 //y2=4.25
cc_890 ( N_CLK_c_968_n N_noxref_10_c_1685_n ) capacitor c=0.0757812f \
 //x=13.755 //y=2.26 //x2=14.495 //y2=4.25
cc_891 ( N_CLK_c_1101_p N_noxref_10_c_1685_n ) capacitor c=0.0142673f \
 //x=14.16 //y=4.97 //x2=14.495 //y2=4.25
cc_892 ( N_CLK_c_1064_n N_noxref_10_c_1685_n ) capacitor c=0.00877984f \
 //x=13.755 //y=2.26 //x2=14.495 //y2=4.25
cc_893 ( N_CLK_c_1125_p N_noxref_10_c_1685_n ) capacitor c=0.00306024f \
 //x=13.755 //y=2.095 //x2=14.495 //y2=4.25
cc_894 ( N_CLK_c_1066_n N_noxref_10_c_1685_n ) capacitor c=0.00518077f \
 //x=13.785 //y=4.88 //x2=14.495 //y2=4.25
cc_895 ( N_CLK_c_1101_p N_noxref_10_c_1875_n ) capacitor c=0.00408717f \
 //x=14.16 //y=4.97 //x2=14.015 //y2=5.38
cc_896 ( N_CLK_M15_noxref_g N_noxref_10_M13_noxref_g ) capacitor c=0.0105869f \
 //x=2.625 //y=6.2 //x2=1.745 //y2=6.2
cc_897 ( N_CLK_M15_noxref_g N_noxref_10_M14_noxref_g ) capacitor c=0.10632f \
 //x=2.625 //y=6.2 //x2=2.185 //y2=6.2
cc_898 ( N_CLK_M16_noxref_g N_noxref_10_M14_noxref_g ) capacitor c=0.0101598f \
 //x=3.065 //y=6.2 //x2=2.185 //y2=6.2
cc_899 ( N_CLK_c_1131_p N_noxref_10_c_1688_n ) capacitor c=5.72482e-19 \
 //x=2.22 //y=1.09 //x2=1.245 //y2=1.055
cc_900 ( N_CLK_c_1131_p N_noxref_10_c_1690_n ) capacitor c=0.00149976f \
 //x=2.22 //y=1.09 //x2=1.245 //y2=1.4
cc_901 ( N_CLK_c_1133_p N_noxref_10_c_1691_n ) capacitor c=0.00111227f \
 //x=2.22 //y=1.4 //x2=1.245 //y2=1.71
cc_902 ( N_CLK_c_967_n N_noxref_10_c_1692_n ) capacitor c=0.00238338f \
 //x=2.655 //y=2.26 //x2=1.245 //y2=2.095
cc_903 ( N_CLK_c_1034_n N_noxref_10_c_1692_n ) capacitor c=0.00964411f \
 //x=2.745 //y=2.095 //x2=1.245 //y2=2.095
cc_904 ( N_CLK_c_1131_p N_noxref_10_c_1695_n ) capacitor c=0.0160123f //x=2.22 \
 //y=1.09 //x2=1.775 //y2=1.055
cc_905 ( N_CLK_c_1031_n N_noxref_10_c_1695_n ) capacitor c=0.00103227f \
 //x=2.745 //y=1.09 //x2=1.775 //y2=1.055
cc_906 ( N_CLK_c_1133_p N_noxref_10_c_1697_n ) capacitor c=0.0124075f //x=2.22 \
 //y=1.4 //x2=1.775 //y2=1.4
cc_907 ( N_CLK_c_1032_n N_noxref_10_c_1697_n ) capacitor c=0.0010154f \
 //x=2.745 //y=1.4 //x2=1.775 //y2=1.4
cc_908 ( N_CLK_c_1033_n N_noxref_10_c_1697_n ) capacitor c=9.23422e-19 \
 //x=2.745 //y=1.63 //x2=1.775 //y2=1.4
cc_909 ( N_CLK_c_989_n N_noxref_10_c_1889_n ) capacitor c=0.00147352f \
 //x=2.655 //y=4.88 //x2=2.11 //y2=4.97
cc_910 ( N_CLK_c_1038_n N_noxref_10_c_1889_n ) capacitor c=0.0168581f \
 //x=2.655 //y=4.88 //x2=2.11 //y2=4.97
cc_911 ( N_CLK_c_989_n N_noxref_10_c_1758_n ) capacitor c=0.00141297f \
 //x=2.655 //y=4.88 //x2=1.82 //y2=4.97
cc_912 ( N_CLK_c_1038_n N_noxref_10_c_1758_n ) capacitor c=0.00484466f \
 //x=2.655 //y=4.88 //x2=1.82 //y2=4.97
cc_913 ( N_CLK_c_970_n N_noxref_10_c_1826_n ) capacitor c=0.00960248f \
 //x=13.64 //y=4.62 //x2=10.83 //y2=4.97
cc_914 ( N_CLK_c_970_n N_noxref_10_c_1801_n ) capacitor c=0.00203982f \
 //x=13.64 //y=4.62 //x2=10.455 //y2=4.88
cc_915 ( N_CLK_c_1054_n N_noxref_10_M8_noxref_d ) capacitor c=0.00217566f \
 //x=13.79 //y=1.085 //x2=13.865 //y2=1.085
cc_916 ( N_CLK_c_1057_n N_noxref_10_M8_noxref_d ) capacitor c=0.0034598f \
 //x=13.79 //y=1.43 //x2=13.865 //y2=1.085
cc_917 ( N_CLK_c_1059_n N_noxref_10_M8_noxref_d ) capacitor c=0.0065582f \
 //x=13.79 //y=1.74 //x2=13.865 //y2=1.085
cc_918 ( N_CLK_c_1150_p N_noxref_10_M8_noxref_d ) capacitor c=0.00241102f \
 //x=14.165 //y=0.93 //x2=13.865 //y2=1.085
cc_919 ( N_CLK_c_1118_p N_noxref_10_M8_noxref_d ) capacitor c=0.0138845f \
 //x=14.165 //y=1.585 //x2=13.865 //y2=1.085
cc_920 ( N_CLK_c_1062_n N_noxref_10_M8_noxref_d ) capacitor c=0.00132245f \
 //x=14.32 //y=1.085 //x2=13.865 //y2=1.085
cc_921 ( N_CLK_c_1063_n N_noxref_10_M8_noxref_d ) capacitor c=0.00566463f \
 //x=14.32 //y=1.43 //x2=13.865 //y2=1.085
cc_922 ( N_CLK_c_1125_p N_noxref_10_M8_noxref_d ) capacitor c=0.00660593f \
 //x=13.755 //y=2.095 //x2=13.865 //y2=1.085
cc_923 ( N_CLK_M29_noxref_g N_noxref_10_M29_noxref_d ) capacitor c=0.0173476f \
 //x=13.795 //y=6.2 //x2=13.87 //y2=5.2
cc_924 ( N_CLK_M30_noxref_g N_noxref_10_M29_noxref_d ) capacitor c=0.0179769f \
 //x=14.235 //y=6.2 //x2=13.87 //y2=5.2
cc_925 ( N_CLK_c_1131_p N_noxref_12_c_2151_n ) capacitor c=0.0167228f //x=2.22 \
 //y=1.09 //x2=2.88 //y2=0.72
cc_926 ( N_CLK_c_1031_n N_noxref_12_c_2151_n ) capacitor c=0.00534519f \
 //x=2.745 //y=1.09 //x2=2.88 //y2=0.72
cc_927 ( CLK N_noxref_12_c_2162_n ) capacitor c=9.41371e-19 //x=2.71 //y=2.77 \
 //x2=2.88 //y2=1.77
cc_928 ( N_CLK_c_967_n N_noxref_12_c_2162_n ) capacitor c=0.012357f //x=2.655 \
 //y=2.26 //x2=2.88 //y2=1.77
cc_929 ( N_CLK_c_1133_p N_noxref_12_c_2162_n ) capacitor c=0.0153476f //x=2.22 \
 //y=1.4 //x2=2.88 //y2=1.77
cc_930 ( N_CLK_c_1034_n N_noxref_12_c_2162_n ) capacitor c=0.0221865f \
 //x=2.745 //y=2.095 //x2=2.88 //y2=1.77
cc_931 ( N_CLK_c_1131_p N_noxref_12_M0_noxref_s ) capacitor c=0.00798959f \
 //x=2.22 //y=1.09 //x2=0.89 //y2=0.555
cc_932 ( N_CLK_c_1033_n N_noxref_12_M0_noxref_s ) capacitor c=0.00212176f \
 //x=2.745 //y=1.63 //x2=0.89 //y2=0.555
cc_933 ( N_CLK_c_1034_n N_noxref_12_M0_noxref_s ) capacitor c=0.00298115f \
 //x=2.745 //y=2.095 //x2=0.89 //y2=0.555
cc_934 ( N_CLK_c_1166_p N_noxref_13_c_2192_n ) capacitor c=2.14837e-19 \
 //x=2.59 //y=0.935 //x2=3.45 //y2=1.175
cc_935 ( N_CLK_c_1031_n N_noxref_13_c_2192_n ) capacitor c=0.00123426f \
 //x=2.745 //y=1.09 //x2=3.45 //y2=1.175
cc_936 ( N_CLK_c_1032_n N_noxref_13_c_2192_n ) capacitor c=0.0129288f \
 //x=2.745 //y=1.4 //x2=3.45 //y2=1.175
cc_937 ( N_CLK_c_1033_n N_noxref_13_c_2192_n ) capacitor c=0.00142359f \
 //x=2.745 //y=1.63 //x2=3.45 //y2=1.175
cc_938 ( N_CLK_c_1131_p N_noxref_13_M1_noxref_d ) capacitor c=0.00223875f \
 //x=2.22 //y=1.09 //x2=2.295 //y2=1.09
cc_939 ( N_CLK_c_1133_p N_noxref_13_M1_noxref_d ) capacitor c=0.00262485f \
 //x=2.22 //y=1.4 //x2=2.295 //y2=1.09
cc_940 ( N_CLK_c_1166_p N_noxref_13_M1_noxref_d ) capacitor c=0.00220746f \
 //x=2.59 //y=0.935 //x2=2.295 //y2=1.09
cc_941 ( N_CLK_c_1173_p N_noxref_13_M1_noxref_d ) capacitor c=0.00194798f \
 //x=2.59 //y=1.555 //x2=2.295 //y2=1.09
cc_942 ( N_CLK_c_1031_n N_noxref_13_M1_noxref_d ) capacitor c=0.00198465f \
 //x=2.745 //y=1.09 //x2=2.295 //y2=1.09
cc_943 ( N_CLK_c_1032_n N_noxref_13_M1_noxref_d ) capacitor c=0.00128384f \
 //x=2.745 //y=1.4 //x2=2.295 //y2=1.09
cc_944 ( N_CLK_c_1031_n N_noxref_13_M2_noxref_s ) capacitor c=7.21316e-19 \
 //x=2.745 //y=1.09 //x2=3.4 //y2=0.555
cc_945 ( N_CLK_c_1032_n N_noxref_13_M2_noxref_s ) capacitor c=0.00348171f \
 //x=2.745 //y=1.4 //x2=3.4 //y2=0.555
cc_946 ( N_CLK_c_970_n N_D_c_2248_n ) capacitor c=0.0203791f //x=13.64 \
 //y=4.62 //x2=7.095 //y2=4.715
cc_947 ( N_CLK_c_970_n N_D_c_2274_n ) capacitor c=0.00960248f //x=13.64 \
 //y=4.62 //x2=7.5 //y2=4.97
cc_948 ( N_CLK_c_970_n N_D_c_2285_n ) capacitor c=0.00203982f //x=13.64 \
 //y=4.62 //x2=7.125 //y2=4.88
cc_949 ( N_CLK_c_1059_n N_noxref_17_c_2438_n ) capacitor c=0.00623646f \
 //x=13.79 //y=1.74 //x2=13.57 //y2=1.675
cc_950 ( N_CLK_c_1064_n N_noxref_17_c_2438_n ) capacitor c=0.00176439f \
 //x=13.755 //y=2.26 //x2=13.57 //y2=1.675
cc_951 ( N_CLK_c_968_n N_noxref_17_c_2439_n ) capacitor c=0.0016032f \
 //x=13.755 //y=2.26 //x2=14.455 //y2=0.71
cc_952 ( N_CLK_c_1054_n N_noxref_17_c_2439_n ) capacitor c=0.0188655f \
 //x=13.79 //y=1.085 //x2=14.455 //y2=0.71
cc_953 ( N_CLK_c_1062_n N_noxref_17_c_2439_n ) capacitor c=0.00656458f \
 //x=14.32 //y=1.085 //x2=14.455 //y2=0.71
cc_954 ( N_CLK_c_1064_n N_noxref_17_c_2439_n ) capacitor c=2.1838e-19 \
 //x=13.755 //y=2.26 //x2=14.455 //y2=0.71
cc_955 ( N_CLK_c_1054_n N_noxref_17_M7_noxref_s ) capacitor c=0.00623646f \
 //x=13.79 //y=1.085 //x2=12.465 //y2=0.545
cc_956 ( N_CLK_c_1062_n N_noxref_17_M7_noxref_s ) capacitor c=0.0143002f \
 //x=14.32 //y=1.085 //x2=12.465 //y2=0.545
cc_957 ( N_CLK_c_1063_n N_noxref_17_M7_noxref_s ) capacitor c=0.00290153f \
 //x=14.32 //y=1.43 //x2=12.465 //y2=0.545
cc_958 ( N_noxref_6_c_1194_n N_noxref_7_c_1458_n ) capacitor c=0.00400249f \
 //x=16.345 //y=2.26 //x2=17.085 //y2=4.715
cc_959 ( N_noxref_6_c_1247_n N_noxref_7_c_1458_n ) capacitor c=0.00417994f \
 //x=16.345 //y=4.88 //x2=17.085 //y2=4.715
cc_960 ( N_noxref_6_c_1190_n N_noxref_7_c_1448_n ) capacitor c=0.00246068f \
 //x=16.23 //y=3.88 //x2=17.085 //y2=2.26
cc_961 ( N_noxref_6_c_1194_n N_noxref_7_c_1448_n ) capacitor c=0.0837791f \
 //x=16.345 //y=2.26 //x2=17.085 //y2=2.26
cc_962 ( N_noxref_6_c_1209_n N_noxref_7_c_1448_n ) capacitor c=0.00308814f \
 //x=16.15 //y=2.095 //x2=17.085 //y2=2.26
cc_963 ( N_noxref_6_c_1190_n N_noxref_7_c_1450_n ) capacitor c=0.0240607f \
 //x=16.23 //y=3.88 //x2=17.085 //y2=3.88
cc_964 ( N_noxref_6_c_1194_n N_noxref_7_c_1450_n ) capacitor c=0.00103967f \
 //x=16.345 //y=2.26 //x2=17.085 //y2=3.88
cc_965 ( N_noxref_6_M31_noxref_g N_noxref_7_M33_noxref_g ) capacitor \
 c=0.0104611f //x=16.245 //y=6.2 //x2=17.125 //y2=6.2
cc_966 ( N_noxref_6_M32_noxref_g N_noxref_7_M33_noxref_g ) capacitor \
 c=0.106811f //x=16.685 //y=6.2 //x2=17.125 //y2=6.2
cc_967 ( N_noxref_6_M32_noxref_g N_noxref_7_M34_noxref_g ) capacitor \
 c=0.0100341f //x=16.685 //y=6.2 //x2=17.565 //y2=6.2
cc_968 ( N_noxref_6_c_1205_n N_noxref_7_c_1468_n ) capacitor c=4.86506e-19 \
 //x=16.15 //y=1.045 //x2=17.12 //y2=1.085
cc_969 ( N_noxref_6_c_1207_n N_noxref_7_c_1468_n ) capacitor c=0.00152104f \
 //x=16.15 //y=1.39 //x2=17.12 //y2=1.085
cc_970 ( N_noxref_6_c_1212_n N_noxref_7_c_1468_n ) capacitor c=0.0151475f \
 //x=16.68 //y=1.045 //x2=17.12 //y2=1.085
cc_971 ( N_noxref_6_c_1208_n N_noxref_7_c_1471_n ) capacitor c=0.00109982f \
 //x=16.15 //y=1.7 //x2=17.12 //y2=1.43
cc_972 ( N_noxref_6_c_1214_n N_noxref_7_c_1471_n ) capacitor c=0.0111064f \
 //x=16.68 //y=1.39 //x2=17.12 //y2=1.43
cc_973 ( N_noxref_6_c_1208_n N_noxref_7_c_1473_n ) capacitor c=9.57794e-19 \
 //x=16.15 //y=1.7 //x2=17.12 //y2=1.74
cc_974 ( N_noxref_6_c_1209_n N_noxref_7_c_1473_n ) capacitor c=0.00662747f \
 //x=16.15 //y=2.095 //x2=17.12 //y2=1.74
cc_975 ( N_noxref_6_c_1214_n N_noxref_7_c_1473_n ) capacitor c=0.00862358f \
 //x=16.68 //y=1.39 //x2=17.12 //y2=1.74
cc_976 ( N_noxref_6_c_1212_n N_noxref_7_c_1476_n ) capacitor c=0.00124821f \
 //x=16.68 //y=1.045 //x2=17.65 //y2=1.085
cc_977 ( N_noxref_6_c_1214_n N_noxref_7_c_1477_n ) capacitor c=0.00200715f \
 //x=16.68 //y=1.39 //x2=17.65 //y2=1.43
cc_978 ( N_noxref_6_c_1194_n N_noxref_7_c_1478_n ) capacitor c=0.00307062f \
 //x=16.345 //y=2.26 //x2=17.085 //y2=2.26
cc_979 ( N_noxref_6_c_1209_n N_noxref_7_c_1478_n ) capacitor c=0.0179092f \
 //x=16.15 //y=2.095 //x2=17.085 //y2=2.26
cc_980 ( N_noxref_6_c_1194_n N_noxref_7_c_1480_n ) capacitor c=0.00344981f \
 //x=16.345 //y=2.26 //x2=17.115 //y2=4.88
cc_981 ( N_noxref_6_c_1247_n N_noxref_7_c_1480_n ) capacitor c=0.0293367f \
 //x=16.345 //y=4.88 //x2=17.115 //y2=4.88
cc_982 ( N_noxref_6_M32_noxref_g N_noxref_8_c_1534_n ) capacitor c=0.017965f \
 //x=16.685 //y=6.2 //x2=17.26 //y2=5.38
cc_983 ( N_noxref_6_c_1194_n N_noxref_8_c_1538_n ) capacitor c=0.00530485f \
 //x=16.345 //y=2.26 //x2=16.55 //y2=5.38
cc_984 ( N_noxref_6_M31_noxref_g N_noxref_8_c_1538_n ) capacitor c=0.0177326f \
 //x=16.245 //y=6.2 //x2=16.55 //y2=5.38
cc_985 ( N_noxref_6_c_1247_n N_noxref_8_c_1538_n ) capacitor c=0.00582246f \
 //x=16.345 //y=4.88 //x2=16.55 //y2=5.38
cc_986 ( N_noxref_6_c_1194_n N_noxref_8_c_1528_n ) capacitor c=0.00375655f \
 //x=16.345 //y=2.26 //x2=17.825 //y2=3.51
cc_987 ( N_noxref_6_M32_noxref_g N_noxref_8_M31_noxref_d ) capacitor \
 c=0.0173476f //x=16.685 //y=6.2 //x2=16.32 //y2=5.2
cc_988 ( N_noxref_6_c_1263_n N_noxref_10_c_1678_n ) capacitor c=0.147021f \
 //x=6.24 //y=3.88 //x2=10.31 //y2=4.25
cc_989 ( N_noxref_6_c_1264_n N_noxref_10_c_1678_n ) capacitor c=0.0294294f \
 //x=4.62 //y=3.88 //x2=10.31 //y2=4.25
cc_990 ( N_noxref_6_c_1190_n N_noxref_10_c_1678_n ) capacitor c=0.338714f \
 //x=16.23 //y=3.88 //x2=10.31 //y2=4.25
cc_991 ( N_noxref_6_c_1271_n N_noxref_10_c_1678_n ) capacitor c=0.0264478f \
 //x=6.47 //y=3.88 //x2=10.31 //y2=4.25
cc_992 ( N_noxref_6_c_1221_n N_noxref_10_c_1678_n ) capacitor c=0.0154449f \
 //x=2.05 //y=5.335 //x2=10.31 //y2=4.25
cc_993 ( N_noxref_6_c_1231_n N_noxref_10_c_1678_n ) capacitor c=0.0200328f \
 //x=4.505 //y=3.88 //x2=10.31 //y2=4.25
cc_994 ( N_noxref_6_c_1193_n N_noxref_10_c_1678_n ) capacitor c=0.0203111f \
 //x=6.355 //y=2.26 //x2=10.31 //y2=4.25
cc_995 ( N_noxref_6_c_1190_n N_noxref_10_c_1708_n ) capacitor c=0.339146f \
 //x=16.23 //y=3.88 //x2=14.38 //y2=4.25
cc_996 ( N_noxref_6_c_1190_n N_noxref_10_c_1778_n ) capacitor c=0.0267832f \
 //x=16.23 //y=3.88 //x2=10.54 //y2=4.25
cc_997 ( N_noxref_6_c_1190_n N_noxref_10_c_1680_n ) capacitor c=0.176049f \
 //x=16.23 //y=3.88 //x2=20.3 //y2=4.25
cc_998 ( N_noxref_6_c_1194_n N_noxref_10_c_1680_n ) capacitor c=0.0242341f \
 //x=16.345 //y=2.26 //x2=20.3 //y2=4.25
cc_999 ( N_noxref_6_c_1247_n N_noxref_10_c_1680_n ) capacitor c=0.00703556f \
 //x=16.345 //y=4.88 //x2=20.3 //y2=4.25
cc_1000 ( N_noxref_6_c_1190_n N_noxref_10_c_1722_n ) capacitor c=0.0266833f \
 //x=16.23 //y=3.88 //x2=14.61 //y2=4.25
cc_1001 ( N_noxref_6_c_1194_n N_noxref_10_c_1722_n ) capacitor c=3.50683e-19 \
 //x=16.345 //y=2.26 //x2=14.61 //y2=4.25
cc_1002 ( N_noxref_6_c_1190_n N_noxref_10_c_1682_n ) capacitor c=0.0243898f \
 //x=16.23 //y=3.88 //x2=10.425 //y2=2.26
cc_1003 ( N_noxref_6_c_1190_n N_noxref_10_c_1920_n ) capacitor c=0.00433945f \
 //x=16.23 //y=3.88 //x2=14.14 //y2=1.835
cc_1004 ( N_noxref_6_c_1190_n N_noxref_10_c_1685_n ) capacitor c=0.0268509f \
 //x=16.23 //y=3.88 //x2=14.495 //y2=4.25
cc_1005 ( N_noxref_6_c_1194_n N_noxref_10_c_1685_n ) capacitor c=0.0144279f \
 //x=16.345 //y=2.26 //x2=14.495 //y2=4.25
cc_1006 ( N_noxref_6_c_1221_n N_noxref_10_M13_noxref_g ) capacitor \
 c=0.0213876f //x=2.05 //y=5.335 //x2=1.745 //y2=6.2
cc_1007 ( N_noxref_6_c_1217_n N_noxref_10_M14_noxref_g ) capacitor \
 c=0.0178794f //x=2.76 //y=5.335 //x2=2.185 //y2=6.2
cc_1008 ( N_noxref_6_M13_noxref_d N_noxref_10_M14_noxref_g ) capacitor \
 c=0.0180032f //x=1.82 //y=5.2 //x2=2.185 //y2=6.2
cc_1009 ( N_noxref_6_c_1221_n N_noxref_10_c_1889_n ) capacitor c=0.00429591f \
 //x=2.05 //y=5.335 //x2=2.11 //y2=4.97
cc_1010 ( N_noxref_6_c_1190_n Q ) capacitor c=0.00143675f //x=16.23 //y=3.88 \
 //x2=21.21 //y2=3.88
cc_1011 ( N_noxref_6_M2_noxref_d N_noxref_12_M0_noxref_s ) capacitor \
 c=0.00309936f //x=3.83 //y=1.095 //x2=0.89 //y2=0.555
cc_1012 ( N_noxref_6_c_1192_n N_noxref_13_c_2197_n ) capacitor c=0.00466084f \
 //x=4.42 //y=1.845 //x2=4.42 //y2=0.72
cc_1013 ( N_noxref_6_M2_noxref_d N_noxref_13_c_2197_n ) capacitor c=0.0117786f \
 //x=3.83 //y=1.095 //x2=4.42 //y2=0.72
cc_1014 ( N_noxref_6_c_1277_n N_noxref_13_c_2211_n ) capacitor c=0.020048f \
 //x=4.105 //y=1.845 //x2=3.535 //y2=1.175
cc_1015 ( N_noxref_6_M2_noxref_d N_noxref_13_M1_noxref_d ) capacitor \
 c=5.27807e-19 //x=3.83 //y=1.095 //x2=2.295 //y2=1.09
cc_1016 ( N_noxref_6_c_1192_n N_noxref_13_M2_noxref_s ) capacitor c=0.0207678f \
 //x=4.42 //y=1.845 //x2=3.4 //y2=0.555
cc_1017 ( N_noxref_6_M2_noxref_d N_noxref_13_M2_noxref_s ) capacitor \
 c=0.0426444f //x=3.83 //y=1.095 //x2=3.4 //y2=0.555
cc_1018 ( N_noxref_6_c_1193_n N_D_c_2246_n ) capacitor c=0.0778827f //x=6.355 \
 //y=2.26 //x2=7.095 //y2=2.485
cc_1019 ( N_noxref_6_c_1199_n N_D_c_2246_n ) capacitor c=0.00309719f //x=6.16 \
 //y=2.095 //x2=7.095 //y2=2.485
cc_1020 ( N_noxref_6_c_1190_n N_D_c_2248_n ) capacitor c=0.0169594f //x=16.23 \
 //y=3.88 //x2=7.095 //y2=4.715
cc_1021 ( N_noxref_6_c_1271_n N_D_c_2248_n ) capacitor c=0.00131333f //x=6.47 \
 //y=3.88 //x2=7.095 //y2=4.715
cc_1022 ( N_noxref_6_c_1193_n N_D_c_2248_n ) capacitor c=0.00440428f //x=6.355 \
 //y=2.26 //x2=7.095 //y2=4.715
cc_1023 ( N_noxref_6_c_1246_n N_D_c_2248_n ) capacitor c=0.00417994f //x=6.355 \
 //y=4.88 //x2=7.095 //y2=4.715
cc_1024 ( N_noxref_6_c_1231_n N_D_c_2266_n ) capacitor c=8.15307e-19 //x=4.505 \
 //y=3.88 //x2=7.122 //y2=3.055
cc_1025 ( N_noxref_6_M19_noxref_g N_D_M21_noxref_g ) capacitor c=0.0104611f \
 //x=6.255 //y=6.2 //x2=7.135 //y2=6.2
cc_1026 ( N_noxref_6_M20_noxref_g N_D_M21_noxref_g ) capacitor c=0.106811f \
 //x=6.695 //y=6.2 //x2=7.135 //y2=6.2
cc_1027 ( N_noxref_6_M20_noxref_g N_D_M22_noxref_g ) capacitor c=0.0100341f \
 //x=6.695 //y=6.2 //x2=7.575 //y2=6.2
cc_1028 ( N_noxref_6_c_1195_n N_D_c_2271_n ) capacitor c=4.86506e-19 //x=6.16 \
 //y=1.045 //x2=7.13 //y2=1.085
cc_1029 ( N_noxref_6_c_1197_n N_D_c_2271_n ) capacitor c=0.00152104f //x=6.16 \
 //y=1.39 //x2=7.13 //y2=1.085
cc_1030 ( N_noxref_6_c_1202_n N_D_c_2271_n ) capacitor c=0.0151475f //x=6.69 \
 //y=1.045 //x2=7.13 //y2=1.085
cc_1031 ( N_noxref_6_c_1198_n N_D_c_2272_n ) capacitor c=0.00109982f //x=6.16 \
 //y=1.7 //x2=7.13 //y2=1.43
cc_1032 ( N_noxref_6_c_1204_n N_D_c_2272_n ) capacitor c=0.0111064f //x=6.69 \
 //y=1.39 //x2=7.13 //y2=1.43
cc_1033 ( N_noxref_6_c_1198_n N_D_c_2273_n ) capacitor c=9.57794e-19 //x=6.16 \
 //y=1.7 //x2=7.13 //y2=1.74
cc_1034 ( N_noxref_6_c_1199_n N_D_c_2273_n ) capacitor c=0.00662747f //x=6.16 \
 //y=2.095 //x2=7.13 //y2=1.74
cc_1035 ( N_noxref_6_c_1204_n N_D_c_2273_n ) capacitor c=0.00862358f //x=6.69 \
 //y=1.39 //x2=7.13 //y2=1.74
cc_1036 ( N_noxref_6_c_1202_n N_D_c_2279_n ) capacitor c=0.00124821f //x=6.69 \
 //y=1.045 //x2=7.66 //y2=1.085
cc_1037 ( N_noxref_6_c_1204_n N_D_c_2280_n ) capacitor c=0.00200715f //x=6.69 \
 //y=1.39 //x2=7.66 //y2=1.43
cc_1038 ( N_noxref_6_c_1193_n N_D_c_2282_n ) capacitor c=0.00307062f //x=6.355 \
 //y=2.26 //x2=7.095 //y2=2.26
cc_1039 ( N_noxref_6_c_1199_n N_D_c_2282_n ) capacitor c=0.0179092f //x=6.16 \
 //y=2.095 //x2=7.095 //y2=2.26
cc_1040 ( N_noxref_6_c_1193_n N_D_c_2285_n ) capacitor c=0.00344981f //x=6.355 \
 //y=2.26 //x2=7.125 //y2=4.88
cc_1041 ( N_noxref_6_c_1246_n N_D_c_2285_n ) capacitor c=0.0293367f //x=6.355 \
 //y=4.88 //x2=7.125 //y2=4.88
cc_1042 ( N_noxref_6_c_1192_n N_noxref_15_c_2344_n ) capacitor c=3.04182e-19 \
 //x=4.42 //y=1.845 //x2=5.94 //y2=1.675
cc_1043 ( N_noxref_6_c_1199_n N_noxref_15_c_2344_n ) capacitor c=0.0034165f \
 //x=6.16 //y=2.095 //x2=5.94 //y2=1.675
cc_1044 ( N_noxref_6_c_1193_n N_noxref_15_c_2325_n ) capacitor c=0.0116993f \
 //x=6.355 //y=2.26 //x2=6.825 //y2=1.76
cc_1045 ( N_noxref_6_c_1198_n N_noxref_15_c_2325_n ) capacitor c=0.00703567f \
 //x=6.16 //y=1.7 //x2=6.825 //y2=1.76
cc_1046 ( N_noxref_6_c_1199_n N_noxref_15_c_2325_n ) capacitor c=0.0203514f \
 //x=6.16 //y=2.095 //x2=6.825 //y2=1.76
cc_1047 ( N_noxref_6_c_1201_n N_noxref_15_c_2325_n ) capacitor c=0.00780629f \
 //x=6.535 //y=1.545 //x2=6.825 //y2=1.76
cc_1048 ( N_noxref_6_c_1204_n N_noxref_15_c_2325_n ) capacitor c=0.00339872f \
 //x=6.69 //y=1.39 //x2=6.825 //y2=1.76
cc_1049 ( N_noxref_6_c_1199_n N_noxref_15_c_2332_n ) capacitor c=6.71402e-19 \
 //x=6.16 //y=2.095 //x2=6.91 //y2=1.675
cc_1050 ( N_noxref_6_c_1195_n N_noxref_15_M3_noxref_s ) capacitor c=0.0327502f \
 //x=6.16 //y=1.045 //x2=5.805 //y2=0.545
cc_1051 ( N_noxref_6_c_1198_n N_noxref_15_M3_noxref_s ) capacitor \
 c=3.48408e-19 //x=6.16 //y=1.7 //x2=5.805 //y2=0.545
cc_1052 ( N_noxref_6_c_1202_n N_noxref_15_M3_noxref_s ) capacitor c=0.0120759f \
 //x=6.69 //y=1.045 //x2=5.805 //y2=0.545
cc_1053 ( N_noxref_6_c_1190_n N_noxref_16_c_2378_n ) capacitor c=0.00299723f \
 //x=16.23 //y=3.88 //x2=10.155 //y2=1.76
cc_1054 ( N_noxref_6_c_1190_n N_noxref_16_c_2385_n ) capacitor c=0.00187232f \
 //x=16.23 //y=3.88 //x2=10.24 //y2=1.675
cc_1055 ( N_noxref_6_c_1190_n N_noxref_16_c_2386_n ) capacitor c=4.7198e-19 \
 //x=16.23 //y=3.88 //x2=11.125 //y2=0.71
cc_1056 ( N_noxref_6_c_1190_n N_noxref_17_c_2431_n ) capacitor c=0.00299723f \
 //x=16.23 //y=3.88 //x2=13.485 //y2=1.76
cc_1057 ( N_noxref_6_c_1190_n N_noxref_17_c_2438_n ) capacitor c=0.00187232f \
 //x=16.23 //y=3.88 //x2=13.57 //y2=1.675
cc_1058 ( N_noxref_6_c_1190_n N_noxref_17_c_2439_n ) capacitor c=4.7198e-19 \
 //x=16.23 //y=3.88 //x2=14.455 //y2=0.71
cc_1059 ( N_noxref_6_c_1190_n N_noxref_17_M7_noxref_s ) capacitor \
 c=3.97107e-19 //x=16.23 //y=3.88 //x2=12.465 //y2=0.545
cc_1060 ( N_noxref_6_c_1190_n N_noxref_18_c_2503_n ) capacitor c=0.00188872f \
 //x=16.23 //y=3.88 //x2=15.93 //y2=1.675
cc_1061 ( N_noxref_6_c_1209_n N_noxref_18_c_2503_n ) capacitor c=0.0034165f \
 //x=16.15 //y=2.095 //x2=15.93 //y2=1.675
cc_1062 ( N_noxref_6_c_1190_n N_noxref_18_c_2484_n ) capacitor c=0.0056636f \
 //x=16.23 //y=3.88 //x2=16.815 //y2=1.76
cc_1063 ( N_noxref_6_c_1194_n N_noxref_18_c_2484_n ) capacitor c=0.011766f \
 //x=16.345 //y=2.26 //x2=16.815 //y2=1.76
cc_1064 ( N_noxref_6_c_1208_n N_noxref_18_c_2484_n ) capacitor c=0.00703567f \
 //x=16.15 //y=1.7 //x2=16.815 //y2=1.76
cc_1065 ( N_noxref_6_c_1209_n N_noxref_18_c_2484_n ) capacitor c=0.0207598f \
 //x=16.15 //y=2.095 //x2=16.815 //y2=1.76
cc_1066 ( N_noxref_6_c_1211_n N_noxref_18_c_2484_n ) capacitor c=0.00780629f \
 //x=16.525 //y=1.545 //x2=16.815 //y2=1.76
cc_1067 ( N_noxref_6_c_1214_n N_noxref_18_c_2484_n ) capacitor c=0.00339872f \
 //x=16.68 //y=1.39 //x2=16.815 //y2=1.76
cc_1068 ( N_noxref_6_c_1209_n N_noxref_18_c_2491_n ) capacitor c=6.71402e-19 \
 //x=16.15 //y=2.095 //x2=16.9 //y2=1.675
cc_1069 ( N_noxref_6_c_1205_n N_noxref_18_M9_noxref_s ) capacitor c=0.0326577f \
 //x=16.15 //y=1.045 //x2=15.795 //y2=0.545
cc_1070 ( N_noxref_6_c_1208_n N_noxref_18_M9_noxref_s ) capacitor \
 c=3.48408e-19 //x=16.15 //y=1.7 //x2=15.795 //y2=0.545
cc_1071 ( N_noxref_6_c_1212_n N_noxref_18_M9_noxref_s ) capacitor c=0.0120759f \
 //x=16.68 //y=1.045 //x2=15.795 //y2=0.545
cc_1072 ( N_noxref_7_c_1458_n N_noxref_8_c_1534_n ) capacitor c=0.0129336f \
 //x=17.085 //y=4.715 //x2=17.26 //y2=5.38
cc_1073 ( N_noxref_7_M33_noxref_g N_noxref_8_c_1534_n ) capacitor c=0.0166421f \
 //x=17.125 //y=6.2 //x2=17.26 //y2=5.38
cc_1074 ( N_noxref_7_c_1480_n N_noxref_8_c_1534_n ) capacitor c=0.00346635f \
 //x=17.115 //y=4.88 //x2=17.26 //y2=5.38
cc_1075 ( N_noxref_7_M34_noxref_g N_noxref_8_c_1540_n ) capacitor c=0.0199348f \
 //x=17.565 //y=6.2 //x2=17.74 //y2=5.38
cc_1076 ( N_noxref_7_c_1486_p N_noxref_8_c_1527_n ) capacitor c=0.00359704f \
 //x=17.495 //y=1.585 //x2=17.74 //y2=1.835
cc_1077 ( N_noxref_7_c_1477_n N_noxref_8_c_1527_n ) capacitor c=0.00457401f \
 //x=17.65 //y=1.43 //x2=17.74 //y2=1.835
cc_1078 ( N_noxref_7_c_1450_n N_noxref_8_c_1569_n ) capacitor c=5.41587e-19 \
 //x=17.085 //y=3.88 //x2=17.47 //y2=1.835
cc_1079 ( N_noxref_7_c_1458_n N_noxref_8_c_1528_n ) capacitor c=0.0101284f \
 //x=17.085 //y=4.715 //x2=17.825 //y2=3.51
cc_1080 ( N_noxref_7_c_1448_n N_noxref_8_c_1528_n ) capacitor c=0.0816182f \
 //x=17.085 //y=2.26 //x2=17.825 //y2=3.51
cc_1081 ( N_noxref_7_c_1450_n N_noxref_8_c_1528_n ) capacitor c=0.00117715f \
 //x=17.085 //y=3.88 //x2=17.825 //y2=3.51
cc_1082 ( N_noxref_7_c_1492_p N_noxref_8_c_1528_n ) capacitor c=0.0142673f \
 //x=17.49 //y=4.97 //x2=17.825 //y2=3.51
cc_1083 ( N_noxref_7_c_1478_n N_noxref_8_c_1528_n ) capacitor c=0.00877984f \
 //x=17.085 //y=2.26 //x2=17.825 //y2=3.51
cc_1084 ( N_noxref_7_c_1494_p N_noxref_8_c_1528_n ) capacitor c=0.00306024f \
 //x=17.085 //y=2.095 //x2=17.825 //y2=3.51
cc_1085 ( N_noxref_7_c_1480_n N_noxref_8_c_1528_n ) capacitor c=0.00533692f \
 //x=17.115 //y=4.88 //x2=17.825 //y2=3.51
cc_1086 ( N_noxref_7_c_1492_p N_noxref_8_c_1577_n ) capacitor c=0.00408717f \
 //x=17.49 //y=4.97 //x2=17.345 //y2=5.38
cc_1087 ( N_noxref_7_c_1468_n N_noxref_8_M10_noxref_d ) capacitor \
 c=0.00217566f //x=17.12 //y=1.085 //x2=17.195 //y2=1.085
cc_1088 ( N_noxref_7_c_1471_n N_noxref_8_M10_noxref_d ) capacitor c=0.0034598f \
 //x=17.12 //y=1.43 //x2=17.195 //y2=1.085
cc_1089 ( N_noxref_7_c_1473_n N_noxref_8_M10_noxref_d ) capacitor c=0.0065582f \
 //x=17.12 //y=1.74 //x2=17.195 //y2=1.085
cc_1090 ( N_noxref_7_c_1500_p N_noxref_8_M10_noxref_d ) capacitor \
 c=0.00241102f //x=17.495 //y=0.93 //x2=17.195 //y2=1.085
cc_1091 ( N_noxref_7_c_1486_p N_noxref_8_M10_noxref_d ) capacitor c=0.0138845f \
 //x=17.495 //y=1.585 //x2=17.195 //y2=1.085
cc_1092 ( N_noxref_7_c_1476_n N_noxref_8_M10_noxref_d ) capacitor \
 c=0.00132245f //x=17.65 //y=1.085 //x2=17.195 //y2=1.085
cc_1093 ( N_noxref_7_c_1477_n N_noxref_8_M10_noxref_d ) capacitor \
 c=0.00566463f //x=17.65 //y=1.43 //x2=17.195 //y2=1.085
cc_1094 ( N_noxref_7_c_1494_p N_noxref_8_M10_noxref_d ) capacitor \
 c=0.00660593f //x=17.085 //y=2.095 //x2=17.195 //y2=1.085
cc_1095 ( N_noxref_7_M33_noxref_g N_noxref_8_M33_noxref_d ) capacitor \
 c=0.0173476f //x=17.125 //y=6.2 //x2=17.2 //y2=5.2
cc_1096 ( N_noxref_7_M34_noxref_g N_noxref_8_M33_noxref_d ) capacitor \
 c=0.0179769f //x=17.565 //y=6.2 //x2=17.2 //y2=5.2
cc_1097 ( N_noxref_7_c_1448_n N_noxref_9_c_1607_n ) capacitor c=0.001003f \
 //x=17.085 //y=2.26 //x2=19.675 //y2=2.26
cc_1098 ( N_noxref_7_c_1458_n N_noxref_10_c_1680_n ) capacitor c=0.00135863f \
 //x=17.085 //y=4.715 //x2=20.3 //y2=4.25
cc_1099 ( N_noxref_7_c_1448_n N_noxref_10_c_1680_n ) capacitor c=0.022647f \
 //x=17.085 //y=2.26 //x2=20.3 //y2=4.25
cc_1100 ( N_noxref_7_c_1450_n N_noxref_10_c_1680_n ) capacitor c=0.0424445f \
 //x=17.085 //y=3.88 //x2=20.3 //y2=4.25
cc_1101 ( N_noxref_7_c_1492_p N_noxref_10_c_1680_n ) capacitor c=0.00736349f \
 //x=17.49 //y=4.97 //x2=20.3 //y2=4.25
cc_1102 ( N_noxref_7_c_1480_n N_noxref_10_c_1680_n ) capacitor c=0.00160199f \
 //x=17.115 //y=4.88 //x2=20.3 //y2=4.25
cc_1103 ( N_noxref_7_c_1448_n N_noxref_10_c_1685_n ) capacitor c=9.30282e-19 \
 //x=17.085 //y=2.26 //x2=14.495 //y2=4.25
cc_1104 ( N_noxref_7_c_1448_n Q ) capacitor c=0.00339971f //x=17.085 //y=2.26 \
 //x2=21.21 //y2=3.88
cc_1105 ( N_noxref_7_c_1450_n Q ) capacitor c=0.0326546f //x=17.085 //y=3.88 \
 //x2=21.21 //y2=3.88
cc_1106 ( N_noxref_7_c_1450_n N_noxref_18_c_2491_n ) capacitor c=5.09612e-19 \
 //x=17.085 //y=3.88 //x2=16.9 //y2=1.675
cc_1107 ( N_noxref_7_c_1473_n N_noxref_18_c_2491_n ) capacitor c=0.00623646f \
 //x=17.12 //y=1.74 //x2=16.9 //y2=1.675
cc_1108 ( N_noxref_7_c_1478_n N_noxref_18_c_2491_n ) capacitor c=0.00176439f \
 //x=17.085 //y=2.26 //x2=16.9 //y2=1.675
cc_1109 ( N_noxref_7_c_1448_n N_noxref_18_c_2492_n ) capacitor c=0.00160293f \
 //x=17.085 //y=2.26 //x2=17.785 //y2=0.71
cc_1110 ( N_noxref_7_c_1450_n N_noxref_18_c_2492_n ) capacitor c=4.77947e-19 \
 //x=17.085 //y=3.88 //x2=17.785 //y2=0.71
cc_1111 ( N_noxref_7_c_1468_n N_noxref_18_c_2492_n ) capacitor c=0.0188655f \
 //x=17.12 //y=1.085 //x2=17.785 //y2=0.71
cc_1112 ( N_noxref_7_c_1476_n N_noxref_18_c_2492_n ) capacitor c=0.00656458f \
 //x=17.65 //y=1.085 //x2=17.785 //y2=0.71
cc_1113 ( N_noxref_7_c_1478_n N_noxref_18_c_2492_n ) capacitor c=2.1838e-19 \
 //x=17.085 //y=2.26 //x2=17.785 //y2=0.71
cc_1114 ( N_noxref_7_c_1468_n N_noxref_18_M9_noxref_s ) capacitor \
 c=0.00623646f //x=17.12 //y=1.085 //x2=15.795 //y2=0.545
cc_1115 ( N_noxref_7_c_1476_n N_noxref_18_M9_noxref_s ) capacitor c=0.0143002f \
 //x=17.65 //y=1.085 //x2=15.795 //y2=0.545
cc_1116 ( N_noxref_7_c_1477_n N_noxref_18_M9_noxref_s ) capacitor \
 c=0.00290153f //x=17.65 //y=1.43 //x2=15.795 //y2=0.545
cc_1117 ( N_noxref_8_c_1528_n N_noxref_9_c_1607_n ) capacitor c=0.013607f \
 //x=17.825 //y=3.51 //x2=19.675 //y2=2.26
cc_1118 ( N_noxref_8_c_1528_n N_noxref_9_c_1608_n ) capacitor c=0.0401585f \
 //x=17.825 //y=3.51 //x2=19.675 //y2=3.51
cc_1119 ( N_noxref_8_c_1534_n N_noxref_10_c_1680_n ) capacitor c=0.0141384f \
 //x=17.26 //y=5.38 //x2=20.3 //y2=4.25
cc_1120 ( N_noxref_8_c_1538_n N_noxref_10_c_1680_n ) capacitor c=0.0135379f \
 //x=16.55 //y=5.38 //x2=20.3 //y2=4.25
cc_1121 ( N_noxref_8_c_1569_n N_noxref_10_c_1680_n ) capacitor c=5.61261e-19 \
 //x=17.47 //y=1.835 //x2=20.3 //y2=4.25
cc_1122 ( N_noxref_8_c_1528_n N_noxref_10_c_1680_n ) capacitor c=0.0248063f \
 //x=17.825 //y=3.51 //x2=20.3 //y2=4.25
cc_1123 ( N_noxref_8_c_1528_n N_noxref_10_c_1685_n ) capacitor c=3.49822e-19 \
 //x=17.825 //y=3.51 //x2=14.495 //y2=4.25
cc_1124 ( N_noxref_8_c_1528_n N_noxref_10_c_1686_n ) capacitor c=0.00107361f \
 //x=17.825 //y=3.51 //x2=20.415 //y2=2.26
cc_1125 ( N_noxref_8_c_1569_n Q ) capacitor c=0.00268158f //x=17.47 //y=1.835 \
 //x2=21.21 //y2=3.88
cc_1126 ( N_noxref_8_c_1528_n Q ) capacitor c=0.0632139f //x=17.825 //y=3.51 \
 //x2=21.21 //y2=3.88
cc_1127 ( N_noxref_8_c_1528_n N_Q_c_2048_n ) capacitor c=3.4995e-19 //x=17.825 \
 //y=3.51 //x2=21.182 //y2=2.315
cc_1128 ( N_noxref_8_c_1569_n N_noxref_18_c_2503_n ) capacitor c=3.15806e-19 \
 //x=17.47 //y=1.835 //x2=15.93 //y2=1.675
cc_1129 ( N_noxref_8_c_1569_n N_noxref_18_c_2491_n ) capacitor c=0.0203424f \
 //x=17.47 //y=1.835 //x2=16.9 //y2=1.675
cc_1130 ( N_noxref_8_c_1527_n N_noxref_18_c_2492_n ) capacitor c=0.0046686f \
 //x=17.74 //y=1.835 //x2=17.785 //y2=0.71
cc_1131 ( N_noxref_8_M10_noxref_d N_noxref_18_c_2492_n ) capacitor \
 c=0.0118069f //x=17.195 //y=1.085 //x2=17.785 //y2=0.71
cc_1132 ( N_noxref_8_c_1527_n N_noxref_18_M9_noxref_s ) capacitor c=0.0141735f \
 //x=17.74 //y=1.835 //x2=15.795 //y2=0.545
cc_1133 ( N_noxref_8_c_1528_n N_noxref_18_M9_noxref_s ) capacitor \
 c=5.08219e-19 //x=17.825 //y=3.51 //x2=15.795 //y2=0.545
cc_1134 ( N_noxref_8_M10_noxref_d N_noxref_18_M9_noxref_s ) capacitor \
 c=0.043966f //x=17.195 //y=1.085 //x2=15.795 //y2=0.545
cc_1135 ( N_noxref_8_c_1527_n N_noxref_19_c_2555_n ) capacitor c=3.22188e-19 \
 //x=17.74 //y=1.835 //x2=19.26 //y2=1.675
cc_1136 ( N_noxref_9_c_1607_n N_noxref_10_c_1680_n ) capacitor c=0.0241934f \
 //x=19.675 //y=2.26 //x2=20.3 //y2=4.25
cc_1137 ( N_noxref_9_c_1608_n N_noxref_10_c_1680_n ) capacitor c=0.0100303f \
 //x=19.675 //y=3.51 //x2=20.3 //y2=4.25
cc_1138 ( N_noxref_9_c_1629_n N_noxref_10_c_1680_n ) capacitor c=0.00844647f \
 //x=19.675 //y=4.88 //x2=20.3 //y2=4.25
cc_1139 ( N_noxref_9_c_1607_n N_noxref_10_c_1942_n ) capacitor c=0.00400249f \
 //x=19.675 //y=2.26 //x2=20.415 //y2=4.715
cc_1140 ( N_noxref_9_c_1629_n N_noxref_10_c_1942_n ) capacitor c=0.00417994f \
 //x=19.675 //y=4.88 //x2=20.415 //y2=4.715
cc_1141 ( N_noxref_9_c_1607_n N_noxref_10_c_1686_n ) capacitor c=0.0810987f \
 //x=19.675 //y=2.26 //x2=20.415 //y2=2.26
cc_1142 ( N_noxref_9_c_1608_n N_noxref_10_c_1686_n ) capacitor c=0.0055871f \
 //x=19.675 //y=3.51 //x2=20.415 //y2=2.26
cc_1143 ( N_noxref_9_c_1616_n N_noxref_10_c_1686_n ) capacitor c=0.00308814f \
 //x=19.48 //y=2.095 //x2=20.415 //y2=2.26
cc_1144 ( N_noxref_9_M35_noxref_g N_noxref_10_M37_noxref_g ) capacitor \
 c=0.0104611f //x=19.575 //y=6.2 //x2=20.455 //y2=6.2
cc_1145 ( N_noxref_9_M36_noxref_g N_noxref_10_M37_noxref_g ) capacitor \
 c=0.106811f //x=20.015 //y=6.2 //x2=20.455 //y2=6.2
cc_1146 ( N_noxref_9_M36_noxref_g N_noxref_10_M38_noxref_g ) capacitor \
 c=0.0100341f //x=20.015 //y=6.2 //x2=20.895 //y2=6.2
cc_1147 ( N_noxref_9_c_1612_n N_noxref_10_c_1950_n ) capacitor c=4.86506e-19 \
 //x=19.48 //y=1.045 //x2=20.45 //y2=1.085
cc_1148 ( N_noxref_9_c_1614_n N_noxref_10_c_1950_n ) capacitor c=0.00152104f \
 //x=19.48 //y=1.39 //x2=20.45 //y2=1.085
cc_1149 ( N_noxref_9_c_1619_n N_noxref_10_c_1950_n ) capacitor c=0.0151475f \
 //x=20.01 //y=1.045 //x2=20.45 //y2=1.085
cc_1150 ( N_noxref_9_c_1615_n N_noxref_10_c_1953_n ) capacitor c=0.00109982f \
 //x=19.48 //y=1.7 //x2=20.45 //y2=1.43
cc_1151 ( N_noxref_9_c_1621_n N_noxref_10_c_1953_n ) capacitor c=0.0111064f \
 //x=20.01 //y=1.39 //x2=20.45 //y2=1.43
cc_1152 ( N_noxref_9_c_1615_n N_noxref_10_c_1955_n ) capacitor c=9.57794e-19 \
 //x=19.48 //y=1.7 //x2=20.45 //y2=1.74
cc_1153 ( N_noxref_9_c_1616_n N_noxref_10_c_1955_n ) capacitor c=0.00662747f \
 //x=19.48 //y=2.095 //x2=20.45 //y2=1.74
cc_1154 ( N_noxref_9_c_1621_n N_noxref_10_c_1955_n ) capacitor c=0.00862358f \
 //x=20.01 //y=1.39 //x2=20.45 //y2=1.74
cc_1155 ( N_noxref_9_c_1619_n N_noxref_10_c_1958_n ) capacitor c=0.00124821f \
 //x=20.01 //y=1.045 //x2=20.98 //y2=1.085
cc_1156 ( N_noxref_9_c_1621_n N_noxref_10_c_1959_n ) capacitor c=0.00200715f \
 //x=20.01 //y=1.39 //x2=20.98 //y2=1.43
cc_1157 ( N_noxref_9_c_1607_n N_noxref_10_c_1960_n ) capacitor c=0.00307062f \
 //x=19.675 //y=2.26 //x2=20.415 //y2=2.26
cc_1158 ( N_noxref_9_c_1616_n N_noxref_10_c_1960_n ) capacitor c=0.0179092f \
 //x=19.48 //y=2.095 //x2=20.415 //y2=2.26
cc_1159 ( N_noxref_9_c_1607_n N_noxref_10_c_1962_n ) capacitor c=0.00344981f \
 //x=19.675 //y=2.26 //x2=20.445 //y2=4.88
cc_1160 ( N_noxref_9_c_1629_n N_noxref_10_c_1962_n ) capacitor c=0.0293367f \
 //x=19.675 //y=4.88 //x2=20.445 //y2=4.88
cc_1161 ( N_noxref_9_c_1607_n Q ) capacitor c=0.0205569f //x=19.675 //y=2.26 \
 //x2=21.21 //y2=3.88
cc_1162 ( N_noxref_9_c_1608_n Q ) capacitor c=0.156671f //x=19.675 //y=3.51 \
 //x2=21.21 //y2=3.88
cc_1163 ( N_noxref_9_M36_noxref_g N_Q_c_2061_n ) capacitor c=0.017965f \
 //x=20.015 //y=6.2 //x2=20.59 //y2=5.38
cc_1164 ( N_noxref_9_c_1607_n N_Q_c_2065_n ) capacitor c=0.00549854f \
 //x=19.675 //y=2.26 //x2=19.88 //y2=5.38
cc_1165 ( N_noxref_9_M35_noxref_g N_Q_c_2065_n ) capacitor c=0.0177326f \
 //x=19.575 //y=6.2 //x2=19.88 //y2=5.38
cc_1166 ( N_noxref_9_c_1629_n N_Q_c_2065_n ) capacitor c=0.00582246f \
 //x=19.675 //y=4.88 //x2=19.88 //y2=5.38
cc_1167 ( N_noxref_9_c_1607_n N_Q_c_2048_n ) capacitor c=0.00411451f \
 //x=19.675 //y=2.26 //x2=21.182 //y2=2.315
cc_1168 ( N_noxref_9_M36_noxref_g N_Q_M35_noxref_d ) capacitor c=0.0173476f \
 //x=20.015 //y=6.2 //x2=19.65 //y2=5.2
cc_1169 ( N_noxref_9_c_1608_n N_noxref_19_c_2555_n ) capacitor c=0.00241565f \
 //x=19.675 //y=3.51 //x2=19.26 //y2=1.675
cc_1170 ( N_noxref_9_c_1616_n N_noxref_19_c_2555_n ) capacitor c=0.0034165f \
 //x=19.48 //y=2.095 //x2=19.26 //y2=1.675
cc_1171 ( N_noxref_9_c_1607_n N_noxref_19_c_2538_n ) capacitor c=0.011692f \
 //x=19.675 //y=2.26 //x2=20.145 //y2=1.76
cc_1172 ( N_noxref_9_c_1608_n N_noxref_19_c_2538_n ) capacitor c=0.00649414f \
 //x=19.675 //y=3.51 //x2=20.145 //y2=1.76
cc_1173 ( N_noxref_9_c_1615_n N_noxref_19_c_2538_n ) capacitor c=0.00703567f \
 //x=19.48 //y=1.7 //x2=20.145 //y2=1.76
cc_1174 ( N_noxref_9_c_1616_n N_noxref_19_c_2538_n ) capacitor c=0.0203514f \
 //x=19.48 //y=2.095 //x2=20.145 //y2=1.76
cc_1175 ( N_noxref_9_c_1618_n N_noxref_19_c_2538_n ) capacitor c=0.00780629f \
 //x=19.855 //y=1.545 //x2=20.145 //y2=1.76
cc_1176 ( N_noxref_9_c_1621_n N_noxref_19_c_2538_n ) capacitor c=0.00339872f \
 //x=20.01 //y=1.39 //x2=20.145 //y2=1.76
cc_1177 ( N_noxref_9_c_1616_n N_noxref_19_c_2545_n ) capacitor c=6.71402e-19 \
 //x=19.48 //y=2.095 //x2=20.23 //y2=1.675
cc_1178 ( N_noxref_9_c_1612_n N_noxref_19_M11_noxref_s ) capacitor \
 c=0.0326577f //x=19.48 //y=1.045 //x2=19.125 //y2=0.545
cc_1179 ( N_noxref_9_c_1615_n N_noxref_19_M11_noxref_s ) capacitor \
 c=3.48408e-19 //x=19.48 //y=1.7 //x2=19.125 //y2=0.545
cc_1180 ( N_noxref_9_c_1619_n N_noxref_19_M11_noxref_s ) capacitor \
 c=0.0120759f //x=20.01 //y=1.045 //x2=19.125 //y2=0.545
cc_1181 ( N_noxref_10_c_1960_n Q ) capacitor c=7.75607e-19 //x=20.415 //y=2.26 \
 //x2=21.21 //y2=2.4
cc_1182 ( N_noxref_10_c_1680_n Q ) capacitor c=0.286393f //x=20.3 //y=4.25 \
 //x2=21.21 //y2=3.88
cc_1183 ( N_noxref_10_c_1686_n Q ) capacitor c=0.0259687f //x=20.415 //y=2.26 \
 //x2=21.21 //y2=3.88
cc_1184 ( N_noxref_10_c_1967_p Q ) capacitor c=0.00624857f //x=20.82 //y=4.97 \
 //x2=21.21 //y2=3.88
cc_1185 ( N_noxref_10_c_1962_n Q ) capacitor c=3.27069e-19 //x=20.445 //y=4.88 \
 //x2=21.21 //y2=3.88
cc_1186 ( N_noxref_10_c_1680_n Q ) capacitor c=0.00513504f //x=20.3 //y=4.25 \
 //x2=21.21 //y2=4.25
cc_1187 ( N_noxref_10_c_1686_n Q ) capacitor c=4.03999e-19 //x=20.415 //y=2.26 \
 //x2=21.21 //y2=4.25
cc_1188 ( N_noxref_10_M38_noxref_g Q ) capacitor c=0.00728936f //x=20.895 \
 //y=6.2 //x2=21.21 //y2=4.99
cc_1189 ( N_noxref_10_c_1962_n Q ) capacitor c=8.36577e-19 //x=20.445 //y=4.88 \
 //x2=21.21 //y2=4.99
cc_1190 ( N_noxref_10_c_1680_n N_Q_c_2061_n ) capacitor c=0.00208151f //x=20.3 \
 //y=4.25 //x2=20.59 //y2=5.38
cc_1191 ( N_noxref_10_c_1942_n N_Q_c_2061_n ) capacitor c=0.0129205f \
 //x=20.415 //y=4.715 //x2=20.59 //y2=5.38
cc_1192 ( N_noxref_10_M37_noxref_g N_Q_c_2061_n ) capacitor c=0.0166421f \
 //x=20.455 //y=6.2 //x2=20.59 //y2=5.38
cc_1193 ( N_noxref_10_c_1962_n N_Q_c_2061_n ) capacitor c=0.00346627f \
 //x=20.445 //y=4.88 //x2=20.59 //y2=5.38
cc_1194 ( N_noxref_10_c_1680_n N_Q_c_2065_n ) capacitor c=0.01319f //x=20.3 \
 //y=4.25 //x2=19.88 //y2=5.38
cc_1195 ( N_noxref_10_M38_noxref_g N_Q_c_2067_n ) capacitor c=0.0206783f \
 //x=20.895 //y=6.2 //x2=21.07 //y2=5.38
cc_1196 ( N_noxref_10_c_1979_p N_Q_c_2047_n ) capacitor c=0.00359704f \
 //x=20.825 //y=1.585 //x2=21.07 //y2=1.835
cc_1197 ( N_noxref_10_c_1959_n N_Q_c_2047_n ) capacitor c=0.00457401f \
 //x=20.98 //y=1.43 //x2=21.07 //y2=1.835
cc_1198 ( N_noxref_10_c_1967_p N_Q_c_2114_n ) capacitor c=0.00421574f \
 //x=20.82 //y=4.97 //x2=20.675 //y2=5.38
cc_1199 ( N_noxref_10_c_1686_n N_Q_c_2048_n ) capacitor c=0.0780773f \
 //x=20.415 //y=2.26 //x2=21.182 //y2=2.315
cc_1200 ( N_noxref_10_c_1960_n N_Q_c_2048_n ) capacitor c=0.00885723f \
 //x=20.415 //y=2.26 //x2=21.182 //y2=2.315
cc_1201 ( N_noxref_10_c_1984_p N_Q_c_2048_n ) capacitor c=0.00306024f \
 //x=20.415 //y=2.095 //x2=21.182 //y2=2.315
cc_1202 ( N_noxref_10_c_1680_n N_Q_c_2118_n ) capacitor c=7.21907e-19 //x=20.3 \
 //y=4.25 //x2=21.182 //y2=4.165
cc_1203 ( N_noxref_10_c_1680_n N_Q_c_2071_n ) capacitor c=8.84388e-19 //x=20.3 \
 //y=4.25 //x2=21.182 //y2=4.535
cc_1204 ( N_noxref_10_c_1942_n N_Q_c_2072_n ) capacitor c=0.0101588f \
 //x=20.415 //y=4.715 //x2=21.182 //y2=4.905
cc_1205 ( N_noxref_10_c_1967_p N_Q_c_2072_n ) capacitor c=0.00728936f \
 //x=20.82 //y=4.97 //x2=21.182 //y2=4.905
cc_1206 ( N_noxref_10_c_1962_n N_Q_c_2072_n ) capacitor c=0.00533692f \
 //x=20.445 //y=4.88 //x2=21.182 //y2=4.905
cc_1207 ( N_noxref_10_c_1950_n N_Q_M12_noxref_d ) capacitor c=0.00217566f \
 //x=20.45 //y=1.085 //x2=20.525 //y2=1.085
cc_1208 ( N_noxref_10_c_1953_n N_Q_M12_noxref_d ) capacitor c=0.0034598f \
 //x=20.45 //y=1.43 //x2=20.525 //y2=1.085
cc_1209 ( N_noxref_10_c_1955_n N_Q_M12_noxref_d ) capacitor c=0.0065582f \
 //x=20.45 //y=1.74 //x2=20.525 //y2=1.085
cc_1210 ( N_noxref_10_c_1993_p N_Q_M12_noxref_d ) capacitor c=0.00241102f \
 //x=20.825 //y=0.93 //x2=20.525 //y2=1.085
cc_1211 ( N_noxref_10_c_1979_p N_Q_M12_noxref_d ) capacitor c=0.0138845f \
 //x=20.825 //y=1.585 //x2=20.525 //y2=1.085
cc_1212 ( N_noxref_10_c_1958_n N_Q_M12_noxref_d ) capacitor c=0.00132245f \
 //x=20.98 //y=1.085 //x2=20.525 //y2=1.085
cc_1213 ( N_noxref_10_c_1959_n N_Q_M12_noxref_d ) capacitor c=0.00566463f \
 //x=20.98 //y=1.43 //x2=20.525 //y2=1.085
cc_1214 ( N_noxref_10_c_1984_p N_Q_M12_noxref_d ) capacitor c=0.00660593f \
 //x=20.415 //y=2.095 //x2=20.525 //y2=1.085
cc_1215 ( N_noxref_10_M37_noxref_g N_Q_M37_noxref_d ) capacitor c=0.0173476f \
 //x=20.455 //y=6.2 //x2=20.53 //y2=5.2
cc_1216 ( N_noxref_10_M38_noxref_g N_Q_M37_noxref_d ) capacitor c=0.0179769f \
 //x=20.895 //y=6.2 //x2=20.53 //y2=5.2
cc_1217 ( N_noxref_10_c_1692_n N_noxref_12_c_2170_n ) capacitor c=0.0034165f \
 //x=1.245 //y=2.095 //x2=1.025 //y2=1.685
cc_1218 ( N_noxref_10_c_1678_n N_noxref_12_c_2144_n ) capacitor c=0.00179505f \
 //x=10.31 //y=4.25 //x2=1.91 //y2=1.77
cc_1219 ( N_noxref_10_c_1679_n N_noxref_12_c_2144_n ) capacitor c=0.00102628f \
 //x=1.66 //y=4.25 //x2=1.91 //y2=1.77
cc_1220 ( N_noxref_10_c_1681_n N_noxref_12_c_2144_n ) capacitor c=0.0122033f \
 //x=1.545 //y=2.26 //x2=1.91 //y2=1.77
cc_1221 ( N_noxref_10_c_1691_n N_noxref_12_c_2144_n ) capacitor c=0.00703864f \
 //x=1.245 //y=1.71 //x2=1.91 //y2=1.77
cc_1222 ( N_noxref_10_c_1692_n N_noxref_12_c_2144_n ) capacitor c=0.0259045f \
 //x=1.245 //y=2.095 //x2=1.91 //y2=1.77
cc_1223 ( N_noxref_10_c_1694_n N_noxref_12_c_2144_n ) capacitor c=0.00708583f \
 //x=1.62 //y=1.555 //x2=1.91 //y2=1.77
cc_1224 ( N_noxref_10_c_1697_n N_noxref_12_c_2144_n ) capacitor c=0.00698822f \
 //x=1.775 //y=1.4 //x2=1.91 //y2=1.77
cc_1225 ( N_noxref_10_c_1678_n N_noxref_12_c_2162_n ) capacitor c=0.00453743f \
 //x=10.31 //y=4.25 //x2=2.88 //y2=1.77
cc_1226 ( N_noxref_10_c_1678_n N_noxref_12_M0_noxref_s ) capacitor \
 c=0.00262629f //x=10.31 //y=4.25 //x2=0.89 //y2=0.555
cc_1227 ( N_noxref_10_c_1688_n N_noxref_12_M0_noxref_s ) capacitor \
 c=0.0327271f //x=1.245 //y=1.055 //x2=0.89 //y2=0.555
cc_1228 ( N_noxref_10_c_1691_n N_noxref_12_M0_noxref_s ) capacitor \
 c=7.99997e-19 //x=1.245 //y=1.71 //x2=0.89 //y2=0.555
cc_1229 ( N_noxref_10_c_1692_n N_noxref_12_M0_noxref_s ) capacitor \
 c=0.00122123f //x=1.245 //y=2.095 //x2=0.89 //y2=0.555
cc_1230 ( N_noxref_10_c_1695_n N_noxref_12_M0_noxref_s ) capacitor \
 c=0.0121427f //x=1.775 //y=1.055 //x2=0.89 //y2=0.555
cc_1231 ( N_noxref_10_c_1678_n N_noxref_13_c_2192_n ) capacitor c=0.0020922f \
 //x=10.31 //y=4.25 //x2=3.45 //y2=1.175
cc_1232 ( N_noxref_10_c_1678_n N_noxref_13_M2_noxref_s ) capacitor \
 c=0.00143334f //x=10.31 //y=4.25 //x2=3.4 //y2=0.555
cc_1233 ( N_noxref_10_c_1678_n N_D_c_2248_n ) capacitor c=0.0169317f //x=10.31 \
 //y=4.25 //x2=7.095 //y2=4.715
cc_1234 ( N_noxref_10_c_1794_n N_noxref_16_c_2385_n ) capacitor c=0.00623646f \
 //x=10.46 //y=1.74 //x2=10.24 //y2=1.675
cc_1235 ( N_noxref_10_c_1799_n N_noxref_16_c_2385_n ) capacitor c=0.00176439f \
 //x=10.425 //y=2.26 //x2=10.24 //y2=1.675
cc_1236 ( N_noxref_10_c_1682_n N_noxref_16_c_2386_n ) capacitor c=0.0016032f \
 //x=10.425 //y=2.26 //x2=11.125 //y2=0.71
cc_1237 ( N_noxref_10_c_1789_n N_noxref_16_c_2386_n ) capacitor c=0.0188655f \
 //x=10.46 //y=1.085 //x2=11.125 //y2=0.71
cc_1238 ( N_noxref_10_c_1797_n N_noxref_16_c_2386_n ) capacitor c=0.00656458f \
 //x=10.99 //y=1.085 //x2=11.125 //y2=0.71
cc_1239 ( N_noxref_10_c_1799_n N_noxref_16_c_2386_n ) capacitor c=2.1838e-19 \
 //x=10.425 //y=2.26 //x2=11.125 //y2=0.71
cc_1240 ( N_noxref_10_c_1789_n N_noxref_16_M5_noxref_s ) capacitor \
 c=0.00623646f //x=10.46 //y=1.085 //x2=9.135 //y2=0.545
cc_1241 ( N_noxref_10_c_1797_n N_noxref_16_M5_noxref_s ) capacitor \
 c=0.0143002f //x=10.99 //y=1.085 //x2=9.135 //y2=0.545
cc_1242 ( N_noxref_10_c_1798_n N_noxref_16_M5_noxref_s ) capacitor \
 c=0.00290153f //x=10.99 //y=1.43 //x2=9.135 //y2=0.545
cc_1243 ( N_noxref_10_c_1920_n N_noxref_17_c_2450_n ) capacitor c=3.15806e-19 \
 //x=14.14 //y=1.835 //x2=12.6 //y2=1.675
cc_1244 ( N_noxref_10_c_1920_n N_noxref_17_c_2438_n ) capacitor c=0.0203424f \
 //x=14.14 //y=1.835 //x2=13.57 //y2=1.675
cc_1245 ( N_noxref_10_c_1684_n N_noxref_17_c_2439_n ) capacitor c=0.00467111f \
 //x=14.41 //y=1.835 //x2=14.455 //y2=0.71
cc_1246 ( N_noxref_10_M8_noxref_d N_noxref_17_c_2439_n ) capacitor \
 c=0.0117932f //x=13.865 //y=1.085 //x2=14.455 //y2=0.71
cc_1247 ( N_noxref_10_c_1684_n N_noxref_17_M7_noxref_s ) capacitor c=0.014284f \
 //x=14.41 //y=1.835 //x2=12.465 //y2=0.545
cc_1248 ( N_noxref_10_M8_noxref_d N_noxref_17_M7_noxref_s ) capacitor \
 c=0.043966f //x=13.865 //y=1.085 //x2=12.465 //y2=0.545
cc_1249 ( N_noxref_10_c_1684_n N_noxref_18_c_2503_n ) capacitor c=3.22188e-19 \
 //x=14.41 //y=1.835 //x2=15.93 //y2=1.675
cc_1250 ( N_noxref_10_c_1680_n N_noxref_18_c_2484_n ) capacitor c=0.00234538f \
 //x=20.3 //y=4.25 //x2=16.815 //y2=1.76
cc_1251 ( N_noxref_10_c_1680_n N_noxref_18_c_2491_n ) capacitor c=9.02759e-19 \
 //x=20.3 //y=4.25 //x2=16.9 //y2=1.675
cc_1252 ( N_noxref_10_c_1955_n N_noxref_19_c_2545_n ) capacitor c=0.00623646f \
 //x=20.45 //y=1.74 //x2=20.23 //y2=1.675
cc_1253 ( N_noxref_10_c_1960_n N_noxref_19_c_2545_n ) capacitor c=0.00176439f \
 //x=20.415 //y=2.26 //x2=20.23 //y2=1.675
cc_1254 ( N_noxref_10_c_1686_n N_noxref_19_c_2546_n ) capacitor c=0.0016032f \
 //x=20.415 //y=2.26 //x2=21.115 //y2=0.71
cc_1255 ( N_noxref_10_c_1950_n N_noxref_19_c_2546_n ) capacitor c=0.0188655f \
 //x=20.45 //y=1.085 //x2=21.115 //y2=0.71
cc_1256 ( N_noxref_10_c_1958_n N_noxref_19_c_2546_n ) capacitor c=0.00656458f \
 //x=20.98 //y=1.085 //x2=21.115 //y2=0.71
cc_1257 ( N_noxref_10_c_1960_n N_noxref_19_c_2546_n ) capacitor c=2.1838e-19 \
 //x=20.415 //y=2.26 //x2=21.115 //y2=0.71
cc_1258 ( N_noxref_10_c_1950_n N_noxref_19_M11_noxref_s ) capacitor \
 c=0.00623646f //x=20.45 //y=1.085 //x2=19.125 //y2=0.545
cc_1259 ( N_noxref_10_c_1958_n N_noxref_19_M11_noxref_s ) capacitor \
 c=0.0143002f //x=20.98 //y=1.085 //x2=19.125 //y2=0.545
cc_1260 ( N_noxref_10_c_1959_n N_noxref_19_M11_noxref_s ) capacitor \
 c=0.00290153f //x=20.98 //y=1.43 //x2=19.125 //y2=0.545
cc_1261 ( N_Q_c_2133_p N_noxref_19_c_2555_n ) capacitor c=3.15806e-19 //x=20.8 \
 //y=1.835 //x2=19.26 //y2=1.675
cc_1262 ( Q N_noxref_19_c_2538_n ) capacitor c=0.00299723f //x=21.21 //y=3.88 \
 //x2=20.145 //y2=1.76
cc_1263 ( Q N_noxref_19_c_2545_n ) capacitor c=0.00187232f //x=21.21 //y=3.88 \
 //x2=20.23 //y2=1.675
cc_1264 ( N_Q_c_2133_p N_noxref_19_c_2545_n ) capacitor c=0.0203424f //x=20.8 \
 //y=1.835 //x2=20.23 //y2=1.675
cc_1265 ( Q N_noxref_19_c_2546_n ) capacitor c=4.7198e-19 //x=21.21 //y=3.88 \
 //x2=21.115 //y2=0.71
cc_1266 ( N_Q_c_2047_n N_noxref_19_c_2546_n ) capacitor c=0.00467104f \
 //x=21.07 //y=1.835 //x2=21.115 //y2=0.71
cc_1267 ( N_Q_M12_noxref_d N_noxref_19_c_2546_n ) capacitor c=0.0117932f \
 //x=20.525 //y=1.085 //x2=21.115 //y2=0.71
cc_1268 ( Q N_noxref_19_M11_noxref_s ) capacitor c=0.00172479f //x=21.21 \
 //y=2.4 //x2=19.125 //y2=0.545
cc_1269 ( Q N_noxref_19_M11_noxref_s ) capacitor c=2.50009e-19 //x=21.21 \
 //y=2.77 //x2=19.125 //y2=0.545
cc_1270 ( N_Q_c_2047_n N_noxref_19_M11_noxref_s ) capacitor c=0.0142774f \
 //x=21.07 //y=1.835 //x2=19.125 //y2=0.545
cc_1271 ( N_Q_M12_noxref_d N_noxref_19_M11_noxref_s ) capacitor c=0.043966f \
 //x=20.525 //y=1.085 //x2=19.125 //y2=0.545
cc_1272 ( N_noxref_12_c_2151_n N_noxref_13_c_2192_n ) capacitor c=0.0136048f \
 //x=2.88 //y=0.72 //x2=3.45 //y2=1.175
cc_1273 ( N_noxref_12_c_2162_n N_noxref_13_c_2192_n ) capacitor c=0.0102225f \
 //x=2.88 //y=1.77 //x2=3.45 //y2=1.175
cc_1274 ( N_noxref_12_M0_noxref_s N_noxref_13_c_2192_n ) capacitor \
 c=0.0228676f //x=0.89 //y=0.555 //x2=3.45 //y2=1.175
cc_1275 ( N_noxref_12_M0_noxref_s N_noxref_13_c_2194_n ) capacitor \
 c=0.0180035f //x=0.89 //y=0.555 //x2=3.535 //y2=0.805
cc_1276 ( N_noxref_12_c_2151_n N_noxref_13_M1_noxref_d ) capacitor \
 c=0.0129526f //x=2.88 //y=0.72 //x2=2.295 //y2=1.09
cc_1277 ( N_noxref_12_c_2162_n N_noxref_13_M1_noxref_d ) capacitor \
 c=0.00908243f //x=2.88 //y=1.77 //x2=2.295 //y2=1.09
cc_1278 ( N_noxref_12_M0_noxref_s N_noxref_13_M1_noxref_d ) capacitor \
 c=0.0159202f //x=0.89 //y=0.555 //x2=2.295 //y2=1.09
cc_1279 ( N_noxref_12_M0_noxref_s N_noxref_13_M2_noxref_s ) capacitor \
 c=0.0213553f //x=0.89 //y=0.555 //x2=3.4 //y2=0.555
cc_1280 ( N_noxref_13_c_2200_n N_noxref_15_M3_noxref_s ) capacitor \
 c=0.00164795f //x=4.505 //y=0.805 //x2=5.805 //y2=0.545
cc_1281 ( N_D_c_2273_n N_noxref_15_c_2332_n ) capacitor c=0.00623646f //x=7.13 \
 //y=1.74 //x2=6.91 //y2=1.675
cc_1282 ( N_D_c_2282_n N_noxref_15_c_2332_n ) capacitor c=0.00176439f \
 //x=7.095 //y=2.26 //x2=6.91 //y2=1.675
cc_1283 ( D N_noxref_15_c_2333_n ) capacitor c=2.24403e-19 //x=7.15 //y=2.77 \
 //x2=7.795 //y2=0.71
cc_1284 ( N_D_c_2246_n N_noxref_15_c_2333_n ) capacitor c=0.0020358f //x=7.095 \
 //y=2.485 //x2=7.795 //y2=0.71
cc_1285 ( N_D_c_2271_n N_noxref_15_c_2333_n ) capacitor c=0.018512f //x=7.13 \
 //y=1.085 //x2=7.795 //y2=0.71
cc_1286 ( N_D_c_2279_n N_noxref_15_c_2333_n ) capacitor c=0.00656458f //x=7.66 \
 //y=1.085 //x2=7.795 //y2=0.71
cc_1287 ( N_D_c_2282_n N_noxref_15_c_2333_n ) capacitor c=2.1838e-19 //x=7.095 \
 //y=2.26 //x2=7.795 //y2=0.71
cc_1288 ( N_D_c_2271_n N_noxref_15_M3_noxref_s ) capacitor c=0.00623646f \
 //x=7.13 //y=1.085 //x2=5.805 //y2=0.545
cc_1289 ( N_D_c_2279_n N_noxref_15_M3_noxref_s ) capacitor c=0.0143002f \
 //x=7.66 //y=1.085 //x2=5.805 //y2=0.545
cc_1290 ( N_D_c_2280_n N_noxref_15_M3_noxref_s ) capacitor c=0.00290153f \
 //x=7.66 //y=1.43 //x2=5.805 //y2=0.545
cc_1291 ( N_noxref_15_c_2336_n N_noxref_16_M5_noxref_s ) capacitor \
 c=0.00174327f //x=7.88 //y=0.795 //x2=9.135 //y2=0.545
cc_1292 ( N_noxref_16_c_2389_n N_noxref_17_M7_noxref_s ) capacitor \
 c=0.00174327f //x=11.21 //y=0.795 //x2=12.465 //y2=0.545
cc_1293 ( N_noxref_17_c_2442_n N_noxref_18_M9_noxref_s ) capacitor \
 c=0.00174327f //x=14.54 //y=0.795 //x2=15.795 //y2=0.545
cc_1294 ( N_noxref_18_c_2495_n N_noxref_19_M11_noxref_s ) capacitor \
 c=0.00174327f //x=17.87 //y=0.795 //x2=19.125 //y2=0.545
