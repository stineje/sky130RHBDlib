// File: DFFQNX1.spi.DFFQNX1.pxi
// Created: Fri Feb 20 10:09:41 2026
//
simulator lang=spectre
x_PM_DFFQNX1\%noxref_1 ( N_noxref_1_c_31_p N_noxref_1_c_25_p N_noxref_1_c_26_p \
 N_noxref_1_c_27_p N_noxref_1_c_158_p N_noxref_1_c_2_p N_noxref_1_c_8_p \
 N_noxref_1_c_3_p N_noxref_1_c_89_p N_noxref_1_c_4_p N_noxref_1_c_136_p \
 N_noxref_1_c_6_p N_noxref_1_c_5_p N_noxref_1_c_9_p N_noxref_1_c_28_p \
 N_noxref_1_c_39_p N_noxref_1_c_10_p N_noxref_1_c_11_p N_noxref_1_c_17_p \
 N_noxref_1_c_275_p N_noxref_1_c_18_p N_noxref_1_c_187_p N_noxref_1_c_12_p \
 N_noxref_1_c_7_p N_noxref_1_c_43_p N_noxref_1_c_29_p N_noxref_1_c_103_p \
 N_noxref_1_c_115_p N_noxref_1_c_116_p N_noxref_1_c_117_p N_noxref_1_c_19_p \
 N_noxref_1_c_138_p N_noxref_1_c_30_p N_noxref_1_c_35_p N_noxref_1_c_121_p \
 N_noxref_1_c_235_p N_noxref_1_c_179_p N_noxref_1_c_13_p \
 N_noxref_1_M2_noxref_g N_noxref_1_M5_noxref_g N_noxref_1_M17_noxref_g \
 N_noxref_1_M18_noxref_g N_noxref_1_M23_noxref_g N_noxref_1_M24_noxref_g \
 N_noxref_1_c_55_p N_noxref_1_c_56_p N_noxref_1_c_57_p N_noxref_1_c_79_p \
 N_noxref_1_c_80_p N_noxref_1_c_81_p N_noxref_1_c_82_p N_noxref_1_c_211_p \
 N_noxref_1_c_212_p N_noxref_1_c_214_p N_noxref_1_c_189_p N_noxref_1_c_352_p \
 N_noxref_1_c_353_p N_noxref_1_c_213_p N_noxref_1_c_215_p N_noxref_1_c_33_p \
 N_noxref_1_c_61_p N_noxref_1_c_36_p N_noxref_1_c_16_p N_noxref_1_M4_noxref_d \
 N_noxref_1_M19_noxref_d N_noxref_1_M21_noxref_d )  PM_DFFQNX1\%noxref_1
x_PM_DFFQNX1\%noxref_2 ( N_noxref_2_c_412_n N_noxref_2_c_413_n \
 N_noxref_2_c_518_p N_noxref_2_c_482_p N_noxref_2_c_414_n N_noxref_2_c_415_n \
 N_noxref_2_c_484_p N_noxref_2_c_417_n N_noxref_2_c_438_p N_noxref_2_c_439_p \
 N_noxref_2_c_419_n N_noxref_2_c_454_p N_noxref_2_c_521_p N_noxref_2_c_428_n \
 N_noxref_2_c_429_n N_noxref_2_c_440_p N_noxref_2_c_448_p N_noxref_2_c_444_p \
 N_noxref_2_c_441_p N_noxref_2_c_489_p N_noxref_2_c_430_n N_noxref_2_c_442_p \
 N_noxref_2_c_431_n N_noxref_2_c_542_p N_noxref_2_c_443_p N_noxref_2_c_446_p \
 N_noxref_2_M7_noxref_g N_noxref_2_M27_noxref_g N_noxref_2_M28_noxref_g \
 N_noxref_2_c_467_p N_noxref_2_c_468_p N_noxref_2_c_470_p N_noxref_2_c_450_p \
 N_noxref_2_c_636_p N_noxref_2_c_637_p N_noxref_2_c_469_p N_noxref_2_c_471_p \
 N_noxref_2_c_447_p N_noxref_2_M6_noxref_d N_noxref_2_M23_noxref_d \
 N_noxref_2_M25_noxref_d )  PM_DFFQNX1\%noxref_2
x_PM_DFFQNX1\%CLK ( CLK CLK CLK CLK CLK CLK CLK CLK CLK N_CLK_c_694_n \
 N_CLK_c_697_n N_CLK_c_736_n N_CLK_c_740_n N_CLK_c_700_n N_CLK_c_745_n \
 N_CLK_c_707_n N_CLK_c_708_n N_CLK_c_712_n N_CLK_c_749_n N_CLK_c_753_n \
 N_CLK_M1_noxref_g N_CLK_M8_noxref_g N_CLK_M15_noxref_g N_CLK_M16_noxref_g \
 N_CLK_M29_noxref_g N_CLK_M30_noxref_g N_CLK_c_888_p N_CLK_c_890_p \
 N_CLK_c_938_p N_CLK_c_939_p N_CLK_c_718_n N_CLK_c_719_n N_CLK_c_720_n \
 N_CLK_c_721_n N_CLK_c_725_n N_CLK_c_759_n N_CLK_c_762_n N_CLK_c_764_n \
 N_CLK_c_843_p N_CLK_c_856_p N_CLK_c_831_p N_CLK_c_767_n N_CLK_c_768_n \
 N_CLK_c_726_n N_CLK_c_769_n N_CLK_c_833_p N_CLK_c_772_n )  PM_DFFQNX1\%CLK
x_PM_DFFQNX1\%noxref_4 ( N_noxref_4_c_1093_n N_noxref_4_c_975_n \
 N_noxref_4_c_976_n N_noxref_4_c_979_n N_noxref_4_c_984_n N_noxref_4_c_993_n \
 N_noxref_4_c_999_n N_noxref_4_c_1004_n N_noxref_4_c_1006_n \
 N_noxref_4_c_1017_n N_noxref_4_c_1019_n N_noxref_4_c_1023_n \
 N_noxref_4_c_1028_n N_noxref_4_c_1104_n N_noxref_4_c_1131_p \
 N_noxref_4_c_1160_p N_noxref_4_c_1105_n N_noxref_4_c_1032_n \
 N_noxref_4_c_1036_n N_noxref_4_c_1323_p N_noxref_4_c_1037_n \
 N_noxref_4_c_1038_n N_noxref_4_c_1040_n N_noxref_4_c_1199_p \
 N_noxref_4_c_1150_p N_noxref_4_c_1132_p N_noxref_4_c_1112_n \
 N_noxref_4_c_1042_n N_noxref_4_c_1044_n N_noxref_4_c_1046_n \
 N_noxref_4_c_1049_n N_noxref_4_c_1053_n N_noxref_4_c_1057_n \
 N_noxref_4_c_1079_n N_noxref_4_c_1084_n N_noxref_4_c_1087_n \
 N_noxref_4_c_1091_n N_noxref_4_c_1189_p N_noxref_4_c_1124_n \
 N_noxref_4_c_1059_n N_noxref_4_c_1326_p N_noxref_4_c_1064_n \
 N_noxref_4_c_1196_p N_noxref_4_c_1133_p N_noxref_4_M3_noxref_g \
 N_noxref_4_M9_noxref_g N_noxref_4_M19_noxref_g N_noxref_4_M20_noxref_g \
 N_noxref_4_M31_noxref_g N_noxref_4_M32_noxref_g N_noxref_4_c_1345_p \
 N_noxref_4_c_1346_p N_noxref_4_c_1348_p N_noxref_4_c_1334_p \
 N_noxref_4_c_1371_p N_noxref_4_c_1372_p N_noxref_4_c_1347_p \
 N_noxref_4_c_1349_p N_noxref_4_c_1225_p N_noxref_4_c_1226_p \
 N_noxref_4_c_1228_p N_noxref_4_c_1209_p N_noxref_4_c_1383_p \
 N_noxref_4_c_1384_p N_noxref_4_c_1227_p N_noxref_4_c_1229_p \
 N_noxref_4_c_1071_n N_noxref_4_c_1136_p N_noxref_4_M2_noxref_d \
 N_noxref_4_M13_noxref_d N_noxref_4_M15_noxref_d N_noxref_4_M17_noxref_d )  \
 PM_DFFQNX1\%noxref_4
x_PM_DFFQNX1\%QN ( QN QN QN QN QN QN QN QN QN QN N_QN_c_1452_n N_QN_c_1465_p \
 N_QN_c_1548_p N_QN_c_1541_p N_QN_c_1467_p N_QN_c_1528_p N_QN_c_1475_p \
 N_QN_c_1453_n N_QN_c_1495_p N_QN_c_1551_p N_QN_c_1486_p N_QN_c_1488_p \
 N_QN_c_1481_p N_QN_c_1529_p N_QN_c_1476_p N_QN_c_1497_p N_QN_c_1459_n \
 N_QN_c_1535_p N_QN_c_1477_p N_QN_c_1482_p N_QN_M11_noxref_g N_QN_M35_noxref_g \
 N_QN_M36_noxref_g N_QN_c_1508_p N_QN_c_1509_p N_QN_c_1511_p N_QN_c_1490_p \
 N_QN_c_1671_p N_QN_c_1672_p N_QN_c_1510_p N_QN_c_1512_p N_QN_c_1483_p \
 N_QN_M10_noxref_d N_QN_M31_noxref_d N_QN_M33_noxref_d )  PM_DFFQNX1\%QN
x_PM_DFFQNX1\%noxref_6 ( N_noxref_6_c_1857_n N_noxref_6_c_1723_n \
 N_noxref_6_c_1862_n N_noxref_6_c_1725_n N_noxref_6_c_1726_n \
 N_noxref_6_c_1734_n N_noxref_6_c_1735_n N_noxref_6_c_1793_n \
 N_noxref_6_c_1794_n N_noxref_6_c_1882_n N_noxref_6_c_1883_n \
 N_noxref_6_c_1795_n N_noxref_6_c_1796_n N_noxref_6_c_1890_n \
 N_noxref_6_c_1799_n N_noxref_6_c_2016_n N_noxref_6_c_2024_n \
 N_noxref_6_c_2025_n N_noxref_6_c_1897_n N_noxref_6_c_1740_n \
 N_noxref_6_c_1741_n N_noxref_6_c_1803_n N_noxref_6_c_1899_n \
 N_noxref_6_c_2031_n N_noxref_6_c_1812_n N_noxref_6_c_1908_n \
 N_noxref_6_c_2033_n N_noxref_6_c_2034_n N_noxref_6_c_1744_n \
 N_noxref_6_c_1748_n N_noxref_6_c_1749_n N_noxref_6_c_1750_n \
 N_noxref_6_c_1813_n N_noxref_6_c_1751_n N_noxref_6_c_1998_n \
 N_noxref_6_c_1920_n N_noxref_6_c_1921_n N_noxref_6_c_1922_n \
 N_noxref_6_c_1926_n N_noxref_6_c_1755_n N_noxref_6_c_1759_n \
 N_noxref_6_c_1820_n N_noxref_6_c_1929_n N_noxref_6_c_2044_n \
 N_noxref_6_c_2048_n N_noxref_6_M0_noxref_g N_noxref_6_M6_noxref_g \
 N_noxref_6_M12_noxref_g N_noxref_6_M13_noxref_g N_noxref_6_M14_noxref_g \
 N_noxref_6_M25_noxref_g N_noxref_6_M26_noxref_g N_noxref_6_M37_noxref_g \
 N_noxref_6_M38_noxref_g N_noxref_6_c_1936_n N_noxref_6_c_1937_n \
 N_noxref_6_c_1938_n N_noxref_6_c_1939_n N_noxref_6_c_2218_p \
 N_noxref_6_c_2234_p N_noxref_6_c_1942_n N_noxref_6_c_1944_n \
 N_noxref_6_c_1947_n N_noxref_6_c_1950_n N_noxref_6_c_1765_n \
 N_noxref_6_c_1768_n N_noxref_6_c_1770_n N_noxref_6_c_1837_n \
 N_noxref_6_c_1840_n N_noxref_6_c_1842_n N_noxref_6_c_1773_n \
 N_noxref_6_c_1774_n N_noxref_6_c_2054_n N_noxref_6_c_2057_n \
 N_noxref_6_c_2059_n N_noxref_6_c_2094_p N_noxref_6_c_2110_p \
 N_noxref_6_c_2082_p N_noxref_6_c_2062_n N_noxref_6_c_2063_n \
 N_noxref_6_c_1775_n N_noxref_6_c_1853_n N_noxref_6_c_1778_n \
 N_noxref_6_c_2064_n N_noxref_6_c_2084_p N_noxref_6_c_2067_n \
 N_noxref_6_M8_noxref_d N_noxref_6_M27_noxref_d N_noxref_6_M29_noxref_d )  \
 PM_DFFQNX1\%noxref_6
x_PM_DFFQNX1\%noxref_7 ( N_noxref_7_c_2313_n N_noxref_7_c_2315_n \
 N_noxref_7_c_2319_n N_noxref_7_c_2374_n N_noxref_7_c_2375_n \
 N_noxref_7_c_2457_n N_noxref_7_c_2458_n N_noxref_7_c_2376_n \
 N_noxref_7_c_2377_n N_noxref_7_c_2465_n N_noxref_7_c_2379_n \
 N_noxref_7_c_2325_n N_noxref_7_c_2328_n N_noxref_7_c_2383_n \
 N_noxref_7_c_2476_n N_noxref_7_c_2508_p N_noxref_7_c_2392_n \
 N_noxref_7_c_2486_n N_noxref_7_c_2393_n N_noxref_7_c_2490_n \
 N_noxref_7_c_2330_n N_noxref_7_c_2333_n N_noxref_7_c_2337_n \
 N_noxref_7_c_2405_n N_noxref_7_c_2495_n N_noxref_7_M10_noxref_g \
 N_noxref_7_M33_noxref_g N_noxref_7_M34_noxref_g N_noxref_7_c_2343_n \
 N_noxref_7_c_2346_n N_noxref_7_c_2348_n N_noxref_7_c_2422_n \
 N_noxref_7_c_2425_n N_noxref_7_c_2427_n N_noxref_7_c_2351_n \
 N_noxref_7_c_2352_n N_noxref_7_c_2353_n N_noxref_7_c_2438_n \
 N_noxref_7_c_2356_n N_noxref_7_M12_noxref_d N_noxref_7_M35_noxref_d \
 N_noxref_7_M37_noxref_d )  PM_DFFQNX1\%noxref_7
x_PM_DFFQNX1\%VDD ( VDD N_VDD_c_2586_n N_VDD_c_2693_n N_VDD_c_2731_n \
 N_VDD_c_2694_n N_VDD_c_2596_n N_VDD_c_2742_n N_VDD_c_2598_n N_VDD_c_2601_n \
 N_VDD_c_2606_n N_VDD_c_2656_n N_VDD_c_2661_n N_VDD_c_2696_n N_VDD_c_2746_n \
 N_VDD_c_2793_n N_VDD_c_2798_n N_VDD_c_2857_n N_VDD_c_2859_n N_VDD_c_2609_n \
 N_VDD_c_2614_n N_VDD_c_2667_n N_VDD_c_2702_n N_VDD_c_2804_n \
 N_VDD_M13_noxref_s N_VDD_M14_noxref_d N_VDD_M16_noxref_d N_VDD_M18_noxref_d \
 N_VDD_M19_noxref_s N_VDD_M20_noxref_d N_VDD_M22_noxref_d N_VDD_M23_noxref_s \
 N_VDD_M24_noxref_d N_VDD_M26_noxref_d N_VDD_M27_noxref_s N_VDD_M28_noxref_d \
 N_VDD_M30_noxref_d N_VDD_M31_noxref_s N_VDD_M32_noxref_d N_VDD_M34_noxref_d \
 N_VDD_M35_noxref_s N_VDD_M36_noxref_d N_VDD_M38_noxref_d )  PM_DFFQNX1\%VDD
x_PM_DFFQNX1\%noxref_9 ( N_noxref_9_c_2981_n N_noxref_9_c_3008_p \
 N_noxref_9_c_2971_n N_noxref_9_c_3010_p N_noxref_9_c_2976_n \
 N_noxref_9_M1_noxref_d N_noxref_9_M2_noxref_s )  PM_DFFQNX1\%noxref_9
x_PM_DFFQNX1\%D ( D D N_D_c_3042_n N_D_c_3044_n N_D_c_3046_n N_D_c_3047_n \
 N_D_M4_noxref_g N_D_M21_noxref_g N_D_M22_noxref_g N_D_c_3055_n N_D_c_3057_n \
 N_D_c_3060_n N_D_c_3061_n N_D_c_3064_n N_D_c_3066_n N_D_c_3070_n N_D_c_3072_n \
 N_D_c_3076_n N_D_c_3077_n N_D_c_3079_n )  PM_DFFQNX1\%D
x_PM_DFFQNX1\%GND ( GND N_GND_c_3438_p N_GND_c_3343_n N_GND_c_3150_n \
 N_GND_c_3151_n N_GND_c_3195_n N_GND_c_3237_n N_GND_c_3301_n N_GND_c_3351_n \
 N_GND_c_3353_n N_GND_c_3154_n N_GND_c_3256_n N_GND_c_3157_n N_GND_c_3167_n \
 N_GND_c_3202_n N_GND_c_3212_n N_GND_c_3259_n N_GND_c_3268_n N_GND_c_3308_n \
 N_GND_c_3319_n N_GND_c_3170_n N_GND_c_3368_n N_GND_c_3171_n N_GND_c_3172_n \
 N_GND_c_3217_n N_GND_c_3273_n N_GND_c_3173_n N_GND_c_3174_n N_GND_c_3179_n \
 N_GND_c_3220_n N_GND_c_3239_n N_GND_c_3327_n N_GND_M0_noxref_d \
 N_GND_M3_noxref_d N_GND_M5_noxref_d N_GND_M7_noxref_d N_GND_M9_noxref_d \
 N_GND_M11_noxref_d )  PM_DFFQNX1\%GND
x_PM_DFFQNX1\%noxref_12 ( N_noxref_12_c_3584_n N_noxref_12_c_3585_n \
 N_noxref_12_c_3596_n N_noxref_12_c_3574_n N_noxref_12_c_3576_n \
 N_noxref_12_M0_noxref_s )  PM_DFFQNX1\%noxref_12
x_PM_DFFQNX1\%noxref_13 ( N_noxref_13_c_3626_n N_noxref_13_c_3627_n \
 N_noxref_13_c_3670_n N_noxref_13_c_3629_n N_noxref_13_c_3631_n \
 N_noxref_13_c_3679_n N_noxref_13_M3_noxref_s )  PM_DFFQNX1\%noxref_13
x_PM_DFFQNX1\%noxref_14 ( N_noxref_14_c_3692_n N_noxref_14_c_3694_n \
 N_noxref_14_c_3735_n N_noxref_14_c_3702_n N_noxref_14_c_3707_n \
 N_noxref_14_c_3744_n N_noxref_14_M5_noxref_s )  PM_DFFQNX1\%noxref_14
x_PM_DFFQNX1\%noxref_15 ( N_noxref_15_c_3760_n N_noxref_15_c_3762_n \
 N_noxref_15_c_3801_n N_noxref_15_c_3770_n N_noxref_15_c_3777_n \
 N_noxref_15_c_3810_n N_noxref_15_M7_noxref_s )  PM_DFFQNX1\%noxref_15
x_PM_DFFQNX1\%noxref_16 ( N_noxref_16_c_3826_n N_noxref_16_c_3828_n \
 N_noxref_16_c_3867_n N_noxref_16_c_3836_n N_noxref_16_c_3841_n \
 N_noxref_16_c_3876_n N_noxref_16_M9_noxref_s )  PM_DFFQNX1\%noxref_16
x_PM_DFFQNX1\%noxref_17 ( N_noxref_17_c_3892_n N_noxref_17_c_3894_n \
 N_noxref_17_c_3935_n N_noxref_17_c_3902_n N_noxref_17_c_3910_n \
 N_noxref_17_c_3942_n N_noxref_17_M11_noxref_s )  PM_DFFQNX1\%noxref_17
cc_1 ( N_noxref_1_M24_noxref_g N_noxref_2_c_412_n ) capacitor c=0.00889217f \
 //x=10.08 //y=6.2 //x2=10.625 //y2=5.38
cc_2 ( N_noxref_1_c_2_p N_noxref_2_c_413_n ) capacitor c=0.00324213f //x=7.45 \
 //y=1.75 //x2=10.78 //y2=1.75
cc_3 ( N_noxref_1_c_3_p N_noxref_2_c_414_n ) capacitor c=0.00231467f //x=7.805 \
 //y=1.835 //x2=10.865 //y2=1.835
cc_4 ( N_noxref_1_c_4_p N_noxref_2_c_415_n ) capacitor c=0.00204244f //x=7.89 \
 //y=3.35 //x2=11.22 //y2=3.35
cc_5 ( N_noxref_1_c_5_p N_noxref_2_c_415_n ) capacitor c=0.00326312f //x=9.74 \
 //y=3.345 //x2=11.22 //y2=3.35
cc_6 ( N_noxref_1_c_6_p N_noxref_2_c_417_n ) capacitor c=0.00281705f //x=7.89 \
 //y=5.295 //x2=11.22 //y2=5.295
cc_7 ( N_noxref_1_c_7_p N_noxref_2_c_417_n ) capacitor c=0.00193818f //x=9.742 \
 //y=4.74 //x2=11.22 //y2=5.295
cc_8 ( N_noxref_1_c_8_p N_noxref_2_c_419_n ) capacitor c=0.00114153f //x=7.805 \
 //y=5.38 //x2=9.86 //y2=5.56
cc_9 ( N_noxref_1_c_9_p N_noxref_2_c_419_n ) capacitor c=5.6496e-19 //x=9.74 \
 //y=3.665 //x2=9.86 //y2=5.56
cc_10 ( N_noxref_1_c_10_p N_noxref_2_c_419_n ) capacitor c=5.29822e-19 \
 //x=7.41 //y=5.38 //x2=9.86 //y2=5.56
cc_11 ( N_noxref_1_c_11_p N_noxref_2_c_419_n ) capacitor c=0.00147119f \
 //x=7.41 //y=5.56 //x2=9.86 //y2=5.56
cc_12 ( N_noxref_1_c_12_p N_noxref_2_c_419_n ) capacitor c=0.0117744f //x=9.74 \
 //y=4.88 //x2=9.86 //y2=5.56
cc_13 ( N_noxref_1_c_13_p N_noxref_2_c_419_n ) capacitor c=0.00277154f \
 //x=9.74 //y=4.88 //x2=9.86 //y2=5.56
cc_14 ( N_noxref_1_M23_noxref_g N_noxref_2_c_419_n ) capacitor c=0.00201806f \
 //x=9.64 //y=6.2 //x2=9.86 //y2=5.56
cc_15 ( N_noxref_1_M24_noxref_g N_noxref_2_c_419_n ) capacitor c=0.00192712f \
 //x=10.08 //y=6.2 //x2=9.86 //y2=5.56
cc_16 ( N_noxref_1_c_16_p N_noxref_2_c_419_n ) capacitor c=0.00194573f \
 //x=9.74 //y=4.88 //x2=9.86 //y2=5.56
cc_17 ( N_noxref_1_c_17_p N_noxref_2_c_428_n ) capacitor c=6.99317e-19 \
 //x=7.45 //y=1.18 //x2=10.78 //y2=1.18
cc_18 ( N_noxref_1_c_18_p N_noxref_2_c_429_n ) capacitor c=0.00251357f \
 //x=9.74 //y=3.51 //x2=11.22 //y2=3.51
cc_19 ( N_noxref_1_c_19_p N_noxref_2_c_430_n ) capacitor c=0.00518466f \
 //x=9.735 //y=3.505 //x2=11.385 //y2=3.51
cc_20 ( N_noxref_1_c_12_p N_noxref_2_c_431_n ) capacitor c=0.00104426f \
 //x=9.74 //y=4.88 //x2=9.86 //y2=5.56
cc_21 ( N_noxref_1_c_13_p N_noxref_2_c_431_n ) capacitor c=0.00377369f \
 //x=9.74 //y=4.88 //x2=9.86 //y2=5.56
cc_22 ( N_noxref_1_M23_noxref_g N_noxref_2_c_431_n ) capacitor c=0.0158358f \
 //x=9.64 //y=6.2 //x2=9.86 //y2=5.56
cc_23 ( N_noxref_1_M24_noxref_g N_noxref_2_c_431_n ) capacitor c=0.0178987f \
 //x=10.08 //y=6.2 //x2=9.86 //y2=5.56
cc_24 ( N_noxref_1_c_16_p N_noxref_2_c_431_n ) capacitor c=0.0043218f //x=9.74 \
 //y=4.88 //x2=9.86 //y2=5.56
cc_25 ( N_noxref_1_c_25_p CLK ) capacitor c=0.029075f //x=3.82 //y=3.35 \
 //x2=2.71 //y2=2.77
cc_26 ( N_noxref_1_c_26_p CLK ) capacitor c=0.00769355f //x=3.82 //y=3.67 \
 //x2=2.71 //y2=2.77
cc_27 ( N_noxref_1_c_27_p CLK ) capacitor c=0.0251329f //x=3.82 //y=4.75 \
 //x2=2.71 //y2=2.77
cc_28 ( N_noxref_1_c_28_p CLK ) capacitor c=3.35971e-19 //x=3.82 //y=3.51 \
 //x2=2.71 //y2=2.77
cc_29 ( N_noxref_1_c_29_p CLK ) capacitor c=0.00514279f //x=3.985 //y=3.51 \
 //x2=2.71 //y2=2.77
cc_30 ( N_noxref_1_c_30_p CLK ) capacitor c=4.16726e-19 //x=3.82 //y=2.26 \
 //x2=2.71 //y2=2.77
cc_31 ( N_noxref_1_c_31_p N_CLK_c_694_n ) capacitor c=0.0116288f //x=3.82 \
 //y=2.375 //x2=2.71 //y2=2.375
cc_32 ( N_noxref_1_c_30_p N_CLK_c_694_n ) capacitor c=5.42289e-19 //x=3.82 \
 //y=2.26 //x2=2.71 //y2=2.375
cc_33 ( N_noxref_1_c_33_p N_CLK_c_694_n ) capacitor c=0.00139071f //x=3.82 \
 //y=2.26 //x2=2.71 //y2=2.375
cc_34 ( N_noxref_1_c_27_p N_CLK_c_697_n ) capacitor c=0.00713797f //x=3.82 \
 //y=4.75 //x2=2.71 //y2=4.88
cc_35 ( N_noxref_1_c_35_p N_CLK_c_697_n ) capacitor c=6.80672e-19 //x=3.82 \
 //y=4.88 //x2=2.71 //y2=4.88
cc_36 ( N_noxref_1_c_36_p N_CLK_c_697_n ) capacitor c=0.00153715f //x=3.82 \
 //y=4.88 //x2=2.71 //y2=4.88
cc_37 ( N_noxref_1_c_27_p N_CLK_c_700_n ) capacitor c=0.0290946f //x=3.82 \
 //y=4.75 //x2=10.1 //y2=4.62
cc_38 ( N_noxref_1_c_6_p N_CLK_c_700_n ) capacitor c=0.0287614f //x=7.89 \
 //y=5.295 //x2=10.1 //y2=4.62
cc_39 ( N_noxref_1_c_39_p N_CLK_c_700_n ) capacitor c=0.0223096f //x=6.53 \
 //y=5.56 //x2=10.1 //y2=4.62
cc_40 ( N_noxref_1_c_10_p N_CLK_c_700_n ) capacitor c=0.0204096f //x=7.41 \
 //y=5.38 //x2=10.1 //y2=4.62
cc_41 ( N_noxref_1_c_12_p N_CLK_c_700_n ) capacitor c=0.00405241f //x=9.74 \
 //y=4.88 //x2=10.1 //y2=4.62
cc_42 ( N_noxref_1_c_7_p N_CLK_c_700_n ) capacitor c=0.0271167f //x=9.742 \
 //y=4.74 //x2=10.1 //y2=4.62
cc_43 ( N_noxref_1_c_43_p N_CLK_c_700_n ) capacitor c=0.00206462f //x=4.175 \
 //y=3.51 //x2=10.1 //y2=4.62
cc_44 ( N_noxref_1_c_27_p N_CLK_c_707_n ) capacitor c=0.00732998f //x=3.82 \
 //y=4.75 //x2=2.71 //y2=4.62
cc_45 ( N_noxref_1_c_31_p N_CLK_c_708_n ) capacitor c=5.39999e-19 //x=3.82 \
 //y=2.375 //x2=2.71 //y2=2.26
cc_46 ( N_noxref_1_c_25_p N_CLK_c_708_n ) capacitor c=4.16726e-19 //x=3.82 \
 //y=3.35 //x2=2.71 //y2=2.26
cc_47 ( N_noxref_1_c_30_p N_CLK_c_708_n ) capacitor c=0.00125213f //x=3.82 \
 //y=2.26 //x2=2.71 //y2=2.26
cc_48 ( N_noxref_1_c_33_p N_CLK_c_708_n ) capacitor c=0.00204868f //x=3.82 \
 //y=2.26 //x2=2.71 //y2=2.26
cc_49 ( N_noxref_1_c_27_p N_CLK_c_712_n ) capacitor c=2.50728e-19 //x=3.82 \
 //y=4.75 //x2=2.71 //y2=4.88
cc_50 ( N_noxref_1_c_35_p N_CLK_c_712_n ) capacitor c=0.00114249f //x=3.82 \
 //y=4.88 //x2=2.71 //y2=4.88
cc_51 ( N_noxref_1_c_36_p N_CLK_c_712_n ) capacitor c=0.00195911f //x=3.82 \
 //y=4.88 //x2=2.71 //y2=4.88
cc_52 ( N_noxref_1_M17_noxref_g N_CLK_M15_noxref_g ) capacitor c=0.0101598f \
 //x=3.56 //y=6.2 //x2=2.68 //y2=6.2
cc_53 ( N_noxref_1_M17_noxref_g N_CLK_M16_noxref_g ) capacitor c=0.0607232f \
 //x=3.56 //y=6.2 //x2=3.12 //y2=6.2
cc_54 ( N_noxref_1_M18_noxref_g N_CLK_M16_noxref_g ) capacitor c=0.0101598f \
 //x=4 //y=6.2 //x2=3.12 //y2=6.2
cc_55 ( N_noxref_1_c_55_p N_CLK_c_718_n ) capacitor c=0.00456962f //x=3.81 \
 //y=1.095 //x2=2.8 //y2=1.09
cc_56 ( N_noxref_1_c_56_p N_CLK_c_719_n ) capacitor c=0.00438372f //x=3.81 \
 //y=1.44 //x2=2.8 //y2=1.4
cc_57 ( N_noxref_1_c_57_p N_CLK_c_720_n ) capacitor c=0.00438372f //x=3.81 \
 //y=1.75 //x2=2.8 //y2=1.63
cc_58 ( N_noxref_1_c_31_p N_CLK_c_721_n ) capacitor c=0.00141236f //x=3.82 \
 //y=2.375 //x2=2.8 //y2=2.095
cc_59 ( N_noxref_1_c_30_p N_CLK_c_721_n ) capacitor c=0.00209664f //x=3.82 \
 //y=2.26 //x2=2.8 //y2=2.095
cc_60 ( N_noxref_1_c_33_p N_CLK_c_721_n ) capacitor c=0.00933826f //x=3.82 \
 //y=2.26 //x2=2.8 //y2=2.095
cc_61 ( N_noxref_1_c_61_p N_CLK_c_721_n ) capacitor c=0.00438372f //x=3.82 \
 //y=2.095 //x2=2.8 //y2=2.095
cc_62 ( N_noxref_1_c_36_p N_CLK_c_725_n ) capacitor c=0.0616491f //x=3.82 \
 //y=4.88 //x2=3.045 //y2=4.97
cc_63 ( N_noxref_1_c_35_p N_CLK_c_726_n ) capacitor c=9.8646e-19 //x=3.82 \
 //y=4.88 //x2=2.71 //y2=4.88
cc_64 ( N_noxref_1_c_36_p N_CLK_c_726_n ) capacitor c=0.00428612f //x=3.82 \
 //y=4.88 //x2=2.71 //y2=4.88
cc_65 ( N_noxref_1_M17_noxref_g N_noxref_4_c_975_n ) capacitor c=0.00955829f \
 //x=3.56 //y=6.2 //x2=3.665 //y2=5.335
cc_66 ( N_noxref_1_c_39_p N_noxref_4_c_976_n ) capacitor c=5.58535e-19 \
 //x=6.53 //y=5.56 //x2=3.78 //y2=5.56
cc_67 ( N_noxref_1_M17_noxref_g N_noxref_4_c_976_n ) capacitor c=0.00226521f \
 //x=3.56 //y=6.2 //x2=3.78 //y2=5.56
cc_68 ( N_noxref_1_M18_noxref_g N_noxref_4_c_976_n ) capacitor c=0.00368945f \
 //x=4 //y=6.2 //x2=3.78 //y2=5.56
cc_69 ( N_noxref_1_c_26_p N_noxref_4_c_979_n ) capacitor c=0.00109953f \
 //x=3.82 //y=3.67 //x2=4.475 //y2=5.335
cc_70 ( N_noxref_1_c_27_p N_noxref_4_c_979_n ) capacitor c=0.00228791f \
 //x=3.82 //y=4.75 //x2=4.475 //y2=5.335
cc_71 ( N_noxref_1_c_39_p N_noxref_4_c_979_n ) capacitor c=0.00104762f \
 //x=6.53 //y=5.56 //x2=4.475 //y2=5.335
cc_72 ( N_noxref_1_c_35_p N_noxref_4_c_979_n ) capacitor c=0.00130631f \
 //x=3.82 //y=4.88 //x2=4.475 //y2=5.335
cc_73 ( N_noxref_1_M18_noxref_g N_noxref_4_c_979_n ) capacitor c=0.0110523f \
 //x=4 //y=6.2 //x2=4.475 //y2=5.335
cc_74 ( N_noxref_1_c_26_p N_noxref_4_c_984_n ) capacitor c=2.43846e-19 \
 //x=3.82 //y=3.67 //x2=4.075 //y2=1.305
cc_75 ( N_noxref_1_c_17_p N_noxref_4_c_984_n ) capacitor c=6.5615e-19 //x=7.45 \
 //y=1.18 //x2=4.075 //y2=1.305
cc_76 ( N_noxref_1_c_29_p N_noxref_4_c_984_n ) capacitor c=2.14389e-19 \
 //x=3.985 //y=3.51 //x2=4.075 //y2=1.305
cc_77 ( N_noxref_1_c_55_p N_noxref_4_c_984_n ) capacitor c=4.64015e-19 \
 //x=3.81 //y=1.095 //x2=4.075 //y2=1.305
cc_78 ( N_noxref_1_c_56_p N_noxref_4_c_984_n ) capacitor c=0.0026012f //x=3.81 \
 //y=1.44 //x2=4.075 //y2=1.305
cc_79 ( N_noxref_1_c_79_p N_noxref_4_c_984_n ) capacitor c=5.29969e-19 \
 //x=4.185 //y=0.94 //x2=4.075 //y2=1.305
cc_80 ( N_noxref_1_c_80_p N_noxref_4_c_984_n ) capacitor c=5.00648e-19 \
 //x=4.185 //y=1.595 //x2=4.075 //y2=1.305
cc_81 ( N_noxref_1_c_81_p N_noxref_4_c_984_n ) capacitor c=5.28622e-19 \
 //x=4.34 //y=1.095 //x2=4.075 //y2=1.305
cc_82 ( N_noxref_1_c_82_p N_noxref_4_c_984_n ) capacitor c=0.00312156f \
 //x=4.34 //y=1.44 //x2=4.075 //y2=1.305
cc_83 ( N_noxref_1_c_2_p N_noxref_4_c_993_n ) capacitor c=0.00326079f //x=7.45 \
 //y=1.75 //x2=4.075 //y2=1.76
cc_84 ( N_noxref_1_c_56_p N_noxref_4_c_993_n ) capacitor c=0.00127432f \
 //x=3.81 //y=1.44 //x2=4.075 //y2=1.76
cc_85 ( N_noxref_1_c_57_p N_noxref_4_c_993_n ) capacitor c=0.00429966f \
 //x=3.81 //y=1.75 //x2=4.075 //y2=1.76
cc_86 ( N_noxref_1_c_80_p N_noxref_4_c_993_n ) capacitor c=0.00930387f \
 //x=4.185 //y=1.595 //x2=4.075 //y2=1.76
cc_87 ( N_noxref_1_c_82_p N_noxref_4_c_993_n ) capacitor c=0.00347599f \
 //x=4.34 //y=1.44 //x2=4.075 //y2=1.76
cc_88 ( N_noxref_1_c_61_p N_noxref_4_c_993_n ) capacitor c=0.00372124f \
 //x=3.82 //y=2.095 //x2=4.075 //y2=1.76
cc_89 ( N_noxref_1_c_89_p N_noxref_4_c_999_n ) capacitor c=0.00218808f \
 //x=7.535 //y=1.835 //x2=4.475 //y2=1.845
cc_90 ( N_noxref_1_c_4_p N_noxref_4_c_999_n ) capacitor c=0.00203605f //x=7.89 \
 //y=3.35 //x2=4.475 //y2=1.845
cc_91 ( N_noxref_1_c_43_p N_noxref_4_c_999_n ) capacitor c=0.00343082f \
 //x=4.175 //y=3.51 //x2=4.475 //y2=1.845
cc_92 ( N_noxref_1_c_80_p N_noxref_4_c_999_n ) capacitor c=0.00194716f \
 //x=4.185 //y=1.595 //x2=4.475 //y2=1.845
cc_93 ( N_noxref_1_c_82_p N_noxref_4_c_999_n ) capacitor c=0.00323576f \
 //x=4.34 //y=1.44 //x2=4.475 //y2=1.845
cc_94 ( N_noxref_1_c_26_p N_noxref_4_c_1004_n ) capacitor c=0.00112398f \
 //x=3.82 //y=3.67 //x2=4.16 //y2=1.845
cc_95 ( N_noxref_1_c_43_p N_noxref_4_c_1004_n ) capacitor c=0.00420474f \
 //x=4.175 //y=3.51 //x2=4.16 //y2=1.845
cc_96 ( N_noxref_1_c_31_p N_noxref_4_c_1006_n ) capacitor c=0.0154269f \
 //x=3.82 //y=2.375 //x2=4.56 //y2=3.72
cc_97 ( N_noxref_1_c_25_p N_noxref_4_c_1006_n ) capacitor c=0.0445642f \
 //x=3.82 //y=3.35 //x2=4.56 //y2=3.72
cc_98 ( N_noxref_1_c_26_p N_noxref_4_c_1006_n ) capacitor c=0.017329f //x=3.82 \
 //y=3.67 //x2=4.56 //y2=3.72
cc_99 ( N_noxref_1_c_27_p N_noxref_4_c_1006_n ) capacitor c=0.00225898f \
 //x=3.82 //y=4.75 //x2=4.56 //y2=3.72
cc_100 ( N_noxref_1_c_28_p N_noxref_4_c_1006_n ) capacitor c=6.78671e-19 \
 //x=3.82 //y=3.51 //x2=4.56 //y2=3.72
cc_101 ( N_noxref_1_c_43_p N_noxref_4_c_1006_n ) capacitor c=2.75635e-19 \
 //x=4.175 //y=3.51 //x2=4.56 //y2=3.72
cc_102 ( N_noxref_1_c_29_p N_noxref_4_c_1006_n ) capacitor c=0.00308371f \
 //x=3.985 //y=3.51 //x2=4.56 //y2=3.72
cc_103 ( N_noxref_1_c_103_p N_noxref_4_c_1006_n ) capacitor c=0.0277316f \
 //x=4.775 //y=3.495 //x2=4.56 //y2=3.72
cc_104 ( N_noxref_1_c_30_p N_noxref_4_c_1006_n ) capacitor c=0.00163444f \
 //x=3.82 //y=2.26 //x2=4.56 //y2=3.72
cc_105 ( N_noxref_1_c_33_p N_noxref_4_c_1006_n ) capacitor c=0.0025845f \
 //x=3.82 //y=2.26 //x2=4.56 //y2=3.72
cc_106 ( N_noxref_1_c_61_p N_noxref_4_c_1006_n ) capacitor c=0.00282067f \
 //x=3.82 //y=2.095 //x2=4.56 //y2=3.72
cc_107 ( N_noxref_1_c_27_p N_noxref_4_c_1017_n ) capacitor c=0.0148501f \
 //x=3.82 //y=4.75 //x2=4.56 //y2=4.04
cc_108 ( N_noxref_1_c_103_p N_noxref_4_c_1017_n ) capacitor c=0.00899533f \
 //x=4.775 //y=3.495 //x2=4.56 //y2=4.04
cc_109 ( N_noxref_1_c_27_p N_noxref_4_c_1019_n ) capacitor c=0.0416218f \
 //x=3.82 //y=4.75 //x2=4.56 //y2=5.25
cc_110 ( N_noxref_1_c_6_p N_noxref_4_c_1019_n ) capacitor c=0.00283621f \
 //x=7.89 //y=5.295 //x2=4.56 //y2=5.25
cc_111 ( N_noxref_1_c_35_p N_noxref_4_c_1019_n ) capacitor c=0.00131258f \
 //x=3.82 //y=4.88 //x2=4.56 //y2=5.25
cc_112 ( N_noxref_1_c_36_p N_noxref_4_c_1019_n ) capacitor c=0.00737085f \
 //x=3.82 //y=4.88 //x2=4.56 //y2=5.25
cc_113 ( N_noxref_1_c_25_p N_noxref_4_c_1023_n ) capacitor c=0.00210705f \
 //x=3.82 //y=3.35 //x2=6.41 //y2=3.72
cc_114 ( N_noxref_1_c_4_p N_noxref_4_c_1023_n ) capacitor c=0.00327648f \
 //x=7.89 //y=3.35 //x2=6.41 //y2=3.72
cc_115 ( N_noxref_1_c_115_p N_noxref_4_c_1023_n ) capacitor c=4.98743e-19 \
 //x=6.02 //y=3.51 //x2=6.41 //y2=3.72
cc_116 ( N_noxref_1_c_116_p N_noxref_4_c_1023_n ) capacitor c=0.0272333f \
 //x=6.62 //y=3.495 //x2=6.41 //y2=3.72
cc_117 ( N_noxref_1_c_117_p N_noxref_4_c_1023_n ) capacitor c=3.14213e-19 \
 //x=8.045 //y=3.51 //x2=6.41 //y2=3.72
cc_118 ( N_noxref_1_c_39_p N_noxref_4_c_1028_n ) capacitor c=7.23153e-19 \
 //x=6.53 //y=5.56 //x2=6.41 //y2=4.04
cc_119 ( N_noxref_1_c_115_p N_noxref_4_c_1028_n ) capacitor c=0.00229532f \
 //x=6.02 //y=3.51 //x2=6.41 //y2=4.04
cc_120 ( N_noxref_1_c_116_p N_noxref_4_c_1028_n ) capacitor c=0.00505309f \
 //x=6.62 //y=3.495 //x2=6.41 //y2=4.04
cc_121 ( N_noxref_1_c_121_p N_noxref_4_c_1028_n ) capacitor c=2.08455e-19 \
 //x=6.53 //y=5.56 //x2=6.41 //y2=4.04
cc_122 ( N_noxref_1_c_26_p N_noxref_4_c_1032_n ) capacitor c=6.86112e-19 \
 //x=3.82 //y=3.67 //x2=3.78 //y2=5.335
cc_123 ( N_noxref_1_c_27_p N_noxref_4_c_1032_n ) capacitor c=0.0228808f \
 //x=3.82 //y=4.75 //x2=3.78 //y2=5.335
cc_124 ( N_noxref_1_c_35_p N_noxref_4_c_1032_n ) capacitor c=0.00346456f \
 //x=3.82 //y=4.88 //x2=3.78 //y2=5.335
cc_125 ( N_noxref_1_c_36_p N_noxref_4_c_1032_n ) capacitor c=0.00203307f \
 //x=3.82 //y=4.88 //x2=3.78 //y2=5.335
cc_126 ( N_noxref_1_c_27_p N_noxref_4_c_1036_n ) capacitor c=6.03895e-19 \
 //x=3.82 //y=4.75 //x2=4.56 //y2=3.88
cc_127 ( N_noxref_1_c_116_p N_noxref_4_c_1037_n ) capacitor c=0.00211017f \
 //x=6.62 //y=3.495 //x2=6.41 //y2=2.26
cc_128 ( N_noxref_1_c_39_p N_noxref_4_c_1038_n ) capacitor c=0.0117744f \
 //x=6.53 //y=5.56 //x2=6.41 //y2=4.88
cc_129 ( N_noxref_1_c_121_p N_noxref_4_c_1038_n ) capacitor c=0.00104426f \
 //x=6.53 //y=5.56 //x2=6.41 //y2=4.88
cc_130 ( N_noxref_1_c_27_p N_noxref_4_c_1040_n ) capacitor c=8.55722e-19 \
 //x=3.82 //y=4.75 //x2=6.412 //y2=4.74
cc_131 ( N_noxref_1_c_6_p N_noxref_4_c_1040_n ) capacitor c=0.00133619f \
 //x=7.89 //y=5.295 //x2=6.412 //y2=4.74
cc_132 ( N_noxref_1_c_103_p N_noxref_4_c_1042_n ) capacitor c=0.132114f \
 //x=4.775 //y=3.495 //x2=6.245 //y2=3.88
cc_133 ( N_noxref_1_c_115_p N_noxref_4_c_1042_n ) capacitor c=0.01106f \
 //x=6.02 //y=3.51 //x2=6.245 //y2=3.88
cc_134 ( N_noxref_1_c_27_p N_noxref_4_c_1044_n ) capacitor c=0.00686853f \
 //x=3.82 //y=4.75 //x2=4.72 //y2=3.88
cc_135 ( N_noxref_1_c_103_p N_noxref_4_c_1044_n ) capacitor c=0.0365231f \
 //x=4.775 //y=3.495 //x2=4.72 //y2=3.88
cc_136 ( N_noxref_1_c_136_p N_noxref_4_c_1046_n ) capacitor c=0.0040382f \
 //x=7.89 //y=3.67 //x2=8.1 //y2=3.895
cc_137 ( N_noxref_1_c_6_p N_noxref_4_c_1046_n ) capacitor c=0.0226569f \
 //x=7.89 //y=5.295 //x2=8.1 //y2=3.895
cc_138 ( N_noxref_1_c_138_p N_noxref_4_c_1046_n ) capacitor c=0.134732f \
 //x=9.575 //y=3.505 //x2=8.1 //y2=3.895
cc_139 ( N_noxref_1_c_136_p N_noxref_4_c_1049_n ) capacitor c=0.00307263f \
 //x=7.89 //y=3.67 //x2=7.755 //y2=3.895
cc_140 ( N_noxref_1_c_6_p N_noxref_4_c_1049_n ) capacitor c=3.08624e-19 \
 //x=7.89 //y=5.295 //x2=7.755 //y2=3.895
cc_141 ( N_noxref_1_c_116_p N_noxref_4_c_1049_n ) capacitor c=0.0488575f \
 //x=6.62 //y=3.495 //x2=7.755 //y2=3.895
cc_142 ( N_noxref_1_c_117_p N_noxref_4_c_1049_n ) capacitor c=0.126579f \
 //x=8.045 //y=3.51 //x2=7.755 //y2=3.895
cc_143 ( N_noxref_1_c_9_p N_noxref_4_c_1053_n ) capacitor c=0.00342917f \
 //x=9.74 //y=3.665 //x2=9.35 //y2=3.88
cc_144 ( N_noxref_1_c_7_p N_noxref_4_c_1053_n ) capacitor c=3.32529e-19 \
 //x=9.742 //y=4.74 //x2=9.35 //y2=3.88
cc_145 ( N_noxref_1_c_19_p N_noxref_4_c_1053_n ) capacitor c=0.0367952f \
 //x=9.735 //y=3.505 //x2=9.35 //y2=3.88
cc_146 ( N_noxref_1_c_138_p N_noxref_4_c_1053_n ) capacitor c=0.0115365f \
 //x=9.575 //y=3.505 //x2=9.35 //y2=3.88
cc_147 ( N_noxref_1_c_9_p N_noxref_4_c_1057_n ) capacitor c=0.00251313f \
 //x=9.74 //y=3.665 //x2=9.95 //y2=3.89
cc_148 ( N_noxref_1_c_7_p N_noxref_4_c_1057_n ) capacitor c=0.0228115f \
 //x=9.742 //y=4.74 //x2=9.95 //y2=3.89
cc_149 ( N_noxref_1_c_27_p N_noxref_4_c_1059_n ) capacitor c=0.00217653f \
 //x=3.82 //y=4.75 //x2=3.78 //y2=5.56
cc_150 ( N_noxref_1_c_35_p N_noxref_4_c_1059_n ) capacitor c=0.00624059f \
 //x=3.82 //y=4.88 //x2=3.78 //y2=5.56
cc_151 ( N_noxref_1_M17_noxref_g N_noxref_4_c_1059_n ) capacitor c=0.0178885f \
 //x=3.56 //y=6.2 //x2=3.78 //y2=5.56
cc_152 ( N_noxref_1_M18_noxref_g N_noxref_4_c_1059_n ) capacitor c=0.0188608f \
 //x=4 //y=6.2 //x2=3.78 //y2=5.56
cc_153 ( N_noxref_1_c_36_p N_noxref_4_c_1059_n ) capacitor c=0.00375636f \
 //x=3.82 //y=4.88 //x2=3.78 //y2=5.56
cc_154 ( N_noxref_1_c_39_p N_noxref_4_c_1064_n ) capacitor c=0.00277154f \
 //x=6.53 //y=5.56 //x2=6.41 //y2=4.88
cc_155 ( N_noxref_1_c_121_p N_noxref_4_c_1064_n ) capacitor c=0.00377369f \
 //x=6.53 //y=5.56 //x2=6.41 //y2=4.88
cc_156 ( N_noxref_1_c_39_p N_noxref_4_M19_noxref_g ) capacitor c=0.00201806f \
 //x=6.53 //y=5.56 //x2=6.31 //y2=6.2
cc_157 ( N_noxref_1_c_121_p N_noxref_4_M19_noxref_g ) capacitor c=0.0158358f \
 //x=6.53 //y=5.56 //x2=6.31 //y2=6.2
cc_158 ( N_noxref_1_c_158_p N_noxref_4_M20_noxref_g ) capacitor c=0.00889217f \
 //x=7.295 //y=5.38 //x2=6.75 //y2=6.2
cc_159 ( N_noxref_1_c_39_p N_noxref_4_M20_noxref_g ) capacitor c=0.00192712f \
 //x=6.53 //y=5.56 //x2=6.75 //y2=6.2
cc_160 ( N_noxref_1_c_121_p N_noxref_4_M20_noxref_g ) capacitor c=0.0178987f \
 //x=6.53 //y=5.56 //x2=6.75 //y2=6.2
cc_161 ( N_noxref_1_c_39_p N_noxref_4_c_1071_n ) capacitor c=0.00189999f \
 //x=6.53 //y=5.56 //x2=6.41 //y2=4.88
cc_162 ( N_noxref_1_c_121_p N_noxref_4_c_1071_n ) capacitor c=0.0043218f \
 //x=6.53 //y=5.56 //x2=6.41 //y2=4.88
cc_163 ( N_noxref_1_c_55_p N_noxref_4_M2_noxref_d ) capacitor c=0.00137165f \
 //x=3.81 //y=1.095 //x2=3.885 //y2=1.095
cc_164 ( N_noxref_1_c_56_p N_noxref_4_M2_noxref_d ) capacitor c=0.00237422f \
 //x=3.81 //y=1.44 //x2=3.885 //y2=1.095
cc_165 ( N_noxref_1_c_79_p N_noxref_4_M2_noxref_d ) capacitor c=0.0020782f \
 //x=4.185 //y=0.94 //x2=3.885 //y2=1.095
cc_166 ( N_noxref_1_c_80_p N_noxref_4_M2_noxref_d ) capacitor c=0.00356097f \
 //x=4.185 //y=1.595 //x2=3.885 //y2=1.095
cc_167 ( N_noxref_1_c_81_p N_noxref_4_M2_noxref_d ) capacitor c=0.00139206f \
 //x=4.34 //y=1.095 //x2=3.885 //y2=1.095
cc_168 ( N_noxref_1_c_82_p N_noxref_4_M2_noxref_d ) capacitor c=0.00237422f \
 //x=4.34 //y=1.44 //x2=3.885 //y2=1.095
cc_169 ( N_noxref_1_c_25_p N_noxref_6_c_1723_n ) capacitor c=0.00142312f \
 //x=3.82 //y=3.35 //x2=1.6 //y2=4.095
cc_170 ( N_noxref_1_c_27_p N_noxref_6_c_1723_n ) capacitor c=7.99748e-19 \
 //x=3.82 //y=4.75 //x2=1.6 //y2=4.095
cc_171 ( N_noxref_1_c_27_p N_noxref_6_c_1725_n ) capacitor c=5.49831e-19 \
 //x=3.82 //y=4.75 //x2=1.6 //y2=4.755
cc_172 ( N_noxref_1_c_4_p N_noxref_6_c_1726_n ) capacitor c=0.00215025f \
 //x=7.89 //y=3.35 //x2=10.48 //y2=4.095
cc_173 ( N_noxref_1_c_6_p N_noxref_6_c_1726_n ) capacitor c=3.0421e-19 \
 //x=7.89 //y=5.295 //x2=10.48 //y2=4.095
cc_174 ( N_noxref_1_c_5_p N_noxref_6_c_1726_n ) capacitor c=0.0427017f \
 //x=9.74 //y=3.345 //x2=10.48 //y2=4.095
cc_175 ( N_noxref_1_c_9_p N_noxref_6_c_1726_n ) capacitor c=0.0146933f \
 //x=9.74 //y=3.665 //x2=10.48 //y2=4.095
cc_176 ( N_noxref_1_c_18_p N_noxref_6_c_1726_n ) capacitor c=5.57251e-19 \
 //x=9.74 //y=3.51 //x2=10.48 //y2=4.095
cc_177 ( N_noxref_1_c_7_p N_noxref_6_c_1726_n ) capacitor c=0.0172039f \
 //x=9.742 //y=4.74 //x2=10.48 //y2=4.095
cc_178 ( N_noxref_1_c_19_p N_noxref_6_c_1726_n ) capacitor c=0.00364775f \
 //x=9.735 //y=3.505 //x2=10.48 //y2=4.095
cc_179 ( N_noxref_1_c_179_p N_noxref_6_c_1726_n ) capacitor c=3.49899e-19 \
 //x=9.74 //y=2.26 //x2=10.48 //y2=4.095
cc_180 ( N_noxref_1_c_7_p N_noxref_6_c_1734_n ) capacitor c=0.0172847f \
 //x=9.742 //y=4.74 //x2=10.48 //y2=4.415
cc_181 ( N_noxref_1_c_6_p N_noxref_6_c_1735_n ) capacitor c=7.63307e-19 \
 //x=7.89 //y=5.295 //x2=10.48 //y2=4.735
cc_182 ( N_noxref_1_c_12_p N_noxref_6_c_1735_n ) capacitor c=0.0172958f \
 //x=9.74 //y=4.88 //x2=10.48 //y2=4.735
cc_183 ( N_noxref_1_c_7_p N_noxref_6_c_1735_n ) capacitor c=0.0114865f \
 //x=9.742 //y=4.74 //x2=10.48 //y2=4.735
cc_184 ( N_noxref_1_c_13_p N_noxref_6_c_1735_n ) capacitor c=7.25895e-19 \
 //x=9.74 //y=4.88 //x2=10.48 //y2=4.735
cc_185 ( N_noxref_1_c_16_p N_noxref_6_c_1735_n ) capacitor c=0.00200292f \
 //x=9.74 //y=4.88 //x2=10.48 //y2=4.735
cc_186 ( N_noxref_1_c_7_p N_noxref_6_c_1740_n ) capacitor c=6.89957e-19 \
 //x=9.742 //y=4.74 //x2=10.48 //y2=4.25
cc_187 ( N_noxref_1_c_187_p N_noxref_6_c_1741_n ) capacitor c=0.0205342f \
 //x=9.74 //y=2.26 //x2=10.48 //y2=2.26
cc_188 ( N_noxref_1_c_179_p N_noxref_6_c_1741_n ) capacitor c=5.16867e-19 \
 //x=9.74 //y=2.26 //x2=10.48 //y2=2.26
cc_189 ( N_noxref_1_c_189_p N_noxref_6_c_1741_n ) capacitor c=0.00167888f \
 //x=9.545 //y=2.095 //x2=10.48 //y2=2.26
cc_190 ( N_noxref_1_c_26_p N_noxref_6_c_1744_n ) capacitor c=0.0031669f \
 //x=3.82 //y=3.67 //x2=4.175 //y2=4.25
cc_191 ( N_noxref_1_c_27_p N_noxref_6_c_1744_n ) capacitor c=0.0245794f \
 //x=3.82 //y=4.75 //x2=4.175 //y2=4.25
cc_192 ( N_noxref_1_c_43_p N_noxref_6_c_1744_n ) capacitor c=0.0162663f \
 //x=4.175 //y=3.51 //x2=4.175 //y2=4.25
cc_193 ( N_noxref_1_c_29_p N_noxref_6_c_1744_n ) capacitor c=0.0160589f \
 //x=3.985 //y=3.51 //x2=4.175 //y2=4.25
cc_194 ( N_noxref_1_c_103_p N_noxref_6_c_1748_n ) capacitor c=0.00849955f \
 //x=4.775 //y=3.495 //x2=4.775 //y2=4.265
cc_195 ( N_noxref_1_c_115_p N_noxref_6_c_1749_n ) capacitor c=0.00536077f \
 //x=6.02 //y=3.51 //x2=6.02 //y2=4.25
cc_196 ( N_noxref_1_c_116_p N_noxref_6_c_1750_n ) capacitor c=0.00123107f \
 //x=6.62 //y=3.495 //x2=6.62 //y2=4.265
cc_197 ( N_noxref_1_c_6_p N_noxref_6_c_1751_n ) capacitor c=0.0232181f \
 //x=7.89 //y=5.295 //x2=10.645 //y2=4.25
cc_198 ( N_noxref_1_c_7_p N_noxref_6_c_1751_n ) capacitor c=0.0254145f \
 //x=9.742 //y=4.74 //x2=10.645 //y2=4.25
cc_199 ( N_noxref_1_c_117_p N_noxref_6_c_1751_n ) capacitor c=0.00761293f \
 //x=8.045 //y=3.51 //x2=10.645 //y2=4.25
cc_200 ( N_noxref_1_c_138_p N_noxref_6_c_1751_n ) capacitor c=0.00977708f \
 //x=9.575 //y=3.505 //x2=10.645 //y2=4.25
cc_201 ( N_noxref_1_c_5_p N_noxref_6_c_1755_n ) capacitor c=3.49899e-19 \
 //x=9.74 //y=3.345 //x2=10.48 //y2=2.26
cc_202 ( N_noxref_1_c_187_p N_noxref_6_c_1755_n ) capacitor c=5.24723e-19 \
 //x=9.74 //y=2.26 //x2=10.48 //y2=2.26
cc_203 ( N_noxref_1_c_179_p N_noxref_6_c_1755_n ) capacitor c=0.00525888f \
 //x=9.74 //y=2.26 //x2=10.48 //y2=2.26
cc_204 ( N_noxref_1_c_189_p N_noxref_6_c_1755_n ) capacitor c=0.00190888f \
 //x=9.545 //y=2.095 //x2=10.48 //y2=2.26
cc_205 ( N_noxref_1_c_12_p N_noxref_6_c_1759_n ) capacitor c=4.80626e-19 \
 //x=9.74 //y=4.88 //x2=10.51 //y2=4.88
cc_206 ( N_noxref_1_c_13_p N_noxref_6_c_1759_n ) capacitor c=0.00397338f \
 //x=9.74 //y=4.88 //x2=10.51 //y2=4.88
cc_207 ( N_noxref_1_c_16_p N_noxref_6_c_1759_n ) capacitor c=0.00283894f \
 //x=9.74 //y=4.88 //x2=10.51 //y2=4.88
cc_208 ( N_noxref_1_M23_noxref_g N_noxref_6_M25_noxref_g ) capacitor \
 c=0.0104892f //x=9.64 //y=6.2 //x2=10.52 //y2=6.2
cc_209 ( N_noxref_1_M24_noxref_g N_noxref_6_M25_noxref_g ) capacitor \
 c=0.107636f //x=10.08 //y=6.2 //x2=10.52 //y2=6.2
cc_210 ( N_noxref_1_M24_noxref_g N_noxref_6_M26_noxref_g ) capacitor \
 c=0.0100341f //x=10.08 //y=6.2 //x2=10.96 //y2=6.2
cc_211 ( N_noxref_1_c_211_p N_noxref_6_c_1765_n ) capacitor c=4.86545e-19 \
 //x=9.545 //y=1.045 //x2=10.515 //y2=1.085
cc_212 ( N_noxref_1_c_212_p N_noxref_6_c_1765_n ) capacitor c=0.00152405f \
 //x=9.545 //y=1.39 //x2=10.515 //y2=1.085
cc_213 ( N_noxref_1_c_213_p N_noxref_6_c_1765_n ) capacitor c=0.0151475f \
 //x=10.075 //y=1.045 //x2=10.515 //y2=1.085
cc_214 ( N_noxref_1_c_214_p N_noxref_6_c_1768_n ) capacitor c=0.00109982f \
 //x=9.545 //y=1.7 //x2=10.515 //y2=1.43
cc_215 ( N_noxref_1_c_215_p N_noxref_6_c_1768_n ) capacitor c=0.0111064f \
 //x=10.075 //y=1.39 //x2=10.515 //y2=1.43
cc_216 ( N_noxref_1_c_214_p N_noxref_6_c_1770_n ) capacitor c=9.58243e-19 \
 //x=9.545 //y=1.7 //x2=10.515 //y2=1.74
cc_217 ( N_noxref_1_c_189_p N_noxref_6_c_1770_n ) capacitor c=0.00662747f \
 //x=9.545 //y=2.095 //x2=10.515 //y2=1.74
cc_218 ( N_noxref_1_c_215_p N_noxref_6_c_1770_n ) capacitor c=0.00862358f \
 //x=10.075 //y=1.39 //x2=10.515 //y2=1.74
cc_219 ( N_noxref_1_c_213_p N_noxref_6_c_1773_n ) capacitor c=0.00127211f \
 //x=10.075 //y=1.045 //x2=11.045 //y2=1.085
cc_220 ( N_noxref_1_c_215_p N_noxref_6_c_1774_n ) capacitor c=0.00204774f \
 //x=10.075 //y=1.39 //x2=11.045 //y2=1.43
cc_221 ( N_noxref_1_c_187_p N_noxref_6_c_1775_n ) capacitor c=0.00167305f \
 //x=9.74 //y=2.26 //x2=10.48 //y2=2.26
cc_222 ( N_noxref_1_c_179_p N_noxref_6_c_1775_n ) capacitor c=0.0018937f \
 //x=9.74 //y=2.26 //x2=10.48 //y2=2.26
cc_223 ( N_noxref_1_c_189_p N_noxref_6_c_1775_n ) capacitor c=0.0181449f \
 //x=9.545 //y=2.095 //x2=10.48 //y2=2.26
cc_224 ( N_noxref_1_c_12_p N_noxref_6_c_1778_n ) capacitor c=0.00158715f \
 //x=9.74 //y=4.88 //x2=10.51 //y2=4.88
cc_225 ( N_noxref_1_c_13_p N_noxref_6_c_1778_n ) capacitor c=0.00237977f \
 //x=9.74 //y=4.88 //x2=10.51 //y2=4.88
cc_226 ( N_noxref_1_c_16_p N_noxref_6_c_1778_n ) capacitor c=0.0297875f \
 //x=9.74 //y=4.88 //x2=10.51 //y2=4.88
cc_227 ( N_noxref_1_c_158_p N_VDD_c_2586_n ) capacitor c=0.00648307f //x=7.295 \
 //y=5.38 //x2=21.58 //y2=7.58
cc_228 ( N_noxref_1_c_8_p N_VDD_c_2586_n ) capacitor c=0.00492578f //x=7.805 \
 //y=5.38 //x2=21.58 //y2=7.58
cc_229 ( N_noxref_1_c_9_p N_VDD_c_2586_n ) capacitor c=2.0049e-19 //x=9.74 \
 //y=3.665 //x2=21.58 //y2=7.58
cc_230 ( N_noxref_1_c_39_p N_VDD_c_2586_n ) capacitor c=0.00368834f //x=6.53 \
 //y=5.56 //x2=21.58 //y2=7.58
cc_231 ( N_noxref_1_c_10_p N_VDD_c_2586_n ) capacitor c=8.42709e-19 //x=7.41 \
 //y=5.38 //x2=21.58 //y2=7.58
cc_232 ( N_noxref_1_c_11_p N_VDD_c_2586_n ) capacitor c=0.00285853f //x=7.41 \
 //y=5.56 //x2=21.58 //y2=7.58
cc_233 ( N_noxref_1_c_12_p N_VDD_c_2586_n ) capacitor c=9.07241e-19 //x=9.74 \
 //y=4.88 //x2=21.58 //y2=7.58
cc_234 ( N_noxref_1_c_121_p N_VDD_c_2586_n ) capacitor c=0.00224881f //x=6.53 \
 //y=5.56 //x2=21.58 //y2=7.58
cc_235 ( N_noxref_1_c_235_p N_VDD_c_2586_n ) capacitor c=0.00224881f //x=7.41 \
 //y=5.56 //x2=21.58 //y2=7.58
cc_236 ( N_noxref_1_c_13_p N_VDD_c_2586_n ) capacitor c=6.22888e-19 //x=9.74 \
 //y=4.88 //x2=21.58 //y2=7.58
cc_237 ( N_noxref_1_M17_noxref_g N_VDD_c_2596_n ) capacitor c=0.00755544f \
 //x=3.56 //y=6.2 //x2=4.135 //y2=7.585
cc_238 ( N_noxref_1_M18_noxref_g N_VDD_c_2596_n ) capacitor c=0.00755754f \
 //x=4 //y=6.2 //x2=4.135 //y2=7.585
cc_239 ( N_noxref_1_c_158_p N_VDD_c_2598_n ) capacitor c=0.00208087f //x=7.295 \
 //y=5.38 //x2=6.885 //y2=7.585
cc_240 ( N_noxref_1_c_39_p N_VDD_c_2598_n ) capacitor c=9.41185e-19 //x=6.53 \
 //y=5.56 //x2=6.885 //y2=7.585
cc_241 ( N_noxref_1_c_121_p N_VDD_c_2598_n ) capacitor c=0.0136705f //x=6.53 \
 //y=5.56 //x2=6.885 //y2=7.585
cc_242 ( N_noxref_1_c_158_p N_VDD_c_2601_n ) capacitor c=0.00180737f //x=7.295 \
 //y=5.38 //x2=7.765 //y2=7.585
cc_243 ( N_noxref_1_c_8_p N_VDD_c_2601_n ) capacitor c=0.00208087f //x=7.805 \
 //y=5.38 //x2=7.765 //y2=7.585
cc_244 ( N_noxref_1_c_10_p N_VDD_c_2601_n ) capacitor c=4.23719e-19 //x=7.41 \
 //y=5.38 //x2=7.765 //y2=7.585
cc_245 ( N_noxref_1_c_11_p N_VDD_c_2601_n ) capacitor c=5.77976e-19 //x=7.41 \
 //y=5.56 //x2=7.765 //y2=7.585
cc_246 ( N_noxref_1_c_235_p N_VDD_c_2601_n ) capacitor c=0.0136705f //x=7.41 \
 //y=5.56 //x2=7.765 //y2=7.585
cc_247 ( N_noxref_1_c_12_p N_VDD_c_2606_n ) capacitor c=6.28113e-19 //x=9.74 \
 //y=4.88 //x2=10.215 //y2=7.585
cc_248 ( N_noxref_1_M23_noxref_g N_VDD_c_2606_n ) capacitor c=0.00732618f \
 //x=9.64 //y=6.2 //x2=10.215 //y2=7.585
cc_249 ( N_noxref_1_M24_noxref_g N_VDD_c_2606_n ) capacitor c=0.00755544f \
 //x=10.08 //y=6.2 //x2=10.215 //y2=7.585
cc_250 ( N_noxref_1_c_6_p N_VDD_c_2609_n ) capacitor c=0.0013228f //x=7.89 \
 //y=5.295 //x2=5.3 //y2=7.585
cc_251 ( N_noxref_1_c_39_p N_VDD_c_2609_n ) capacitor c=4.91377e-19 //x=6.53 \
 //y=5.56 //x2=5.3 //y2=7.585
cc_252 ( N_noxref_1_c_35_p N_VDD_c_2609_n ) capacitor c=0.00224736f //x=3.82 \
 //y=4.88 //x2=5.3 //y2=7.585
cc_253 ( N_noxref_1_c_121_p N_VDD_c_2609_n ) capacitor c=0.0064135f //x=6.53 \
 //y=5.56 //x2=5.3 //y2=7.585
cc_254 ( N_noxref_1_c_36_p N_VDD_c_2609_n ) capacitor c=2.63786e-19 //x=3.82 \
 //y=4.88 //x2=5.3 //y2=7.585
cc_255 ( N_noxref_1_c_6_p N_VDD_c_2614_n ) capacitor c=0.0291261f //x=7.89 \
 //y=5.295 //x2=8.63 //y2=7.585
cc_256 ( N_noxref_1_c_10_p N_VDD_c_2614_n ) capacitor c=0.00240948f //x=7.41 \
 //y=5.38 //x2=8.63 //y2=7.585
cc_257 ( N_noxref_1_c_11_p N_VDD_c_2614_n ) capacitor c=4.09141e-19 //x=7.41 \
 //y=5.56 //x2=8.63 //y2=7.585
cc_258 ( N_noxref_1_c_12_p N_VDD_c_2614_n ) capacitor c=0.00447349f //x=9.74 \
 //y=4.88 //x2=8.63 //y2=7.585
cc_259 ( N_noxref_1_c_7_p N_VDD_c_2614_n ) capacitor c=0.00564116f //x=9.742 \
 //y=4.74 //x2=8.63 //y2=7.585
cc_260 ( N_noxref_1_c_235_p N_VDD_c_2614_n ) capacitor c=0.0101861f //x=7.41 \
 //y=5.56 //x2=8.63 //y2=7.585
cc_261 ( N_noxref_1_c_13_p N_VDD_c_2614_n ) capacitor c=0.00370494f //x=9.74 \
 //y=4.88 //x2=8.63 //y2=7.585
cc_262 ( N_noxref_1_c_16_p N_VDD_c_2614_n ) capacitor c=0.0129564f //x=9.74 \
 //y=4.88 //x2=8.63 //y2=7.585
cc_263 ( N_noxref_1_M17_noxref_g N_VDD_M16_noxref_d ) capacitor c=0.015318f \
 //x=3.56 //y=6.2 //x2=3.195 //y2=5.2
cc_264 ( N_noxref_1_M18_noxref_g N_VDD_M18_noxref_d ) capacitor c=0.0394719f \
 //x=4 //y=6.2 //x2=4.075 //y2=5.2
cc_265 ( N_noxref_1_c_39_p N_VDD_M19_noxref_s ) capacitor c=0.0611368f \
 //x=6.53 //y=5.56 //x2=5.955 //y2=5.2
cc_266 ( N_noxref_1_c_10_p N_VDD_M19_noxref_s ) capacitor c=6.52457e-19 \
 //x=7.41 //y=5.38 //x2=5.955 //y2=5.2
cc_267 ( N_noxref_1_c_121_p N_VDD_M19_noxref_s ) capacitor c=0.0887533f \
 //x=6.53 //y=5.56 //x2=5.955 //y2=5.2
cc_268 ( N_noxref_1_c_158_p N_VDD_M20_noxref_d ) capacitor c=0.00734094f \
 //x=7.295 //y=5.38 //x2=6.825 //y2=5.2
cc_269 ( N_noxref_1_c_39_p N_VDD_M20_noxref_d ) capacitor c=0.0043528f \
 //x=6.53 //y=5.56 //x2=6.825 //y2=5.2
cc_270 ( N_noxref_1_c_11_p N_VDD_M20_noxref_d ) capacitor c=0.0043528f \
 //x=7.41 //y=5.56 //x2=6.825 //y2=5.2
cc_271 ( N_noxref_1_c_121_p N_VDD_M20_noxref_d ) capacitor c=0.065554f \
 //x=6.53 //y=5.56 //x2=6.825 //y2=5.2
cc_272 ( N_noxref_1_c_235_p N_VDD_M20_noxref_d ) capacitor c=0.065554f \
 //x=7.41 //y=5.56 //x2=6.825 //y2=5.2
cc_273 ( N_noxref_1_c_8_p N_VDD_M22_noxref_d ) capacitor c=0.00934027f \
 //x=7.805 //y=5.38 //x2=7.705 //y2=5.2
cc_274 ( N_noxref_1_c_11_p N_VDD_M22_noxref_d ) capacitor c=0.00587834f \
 //x=7.41 //y=5.56 //x2=7.705 //y2=5.2
cc_275 ( N_noxref_1_c_275_p N_VDD_M22_noxref_d ) capacitor c=9.65951e-19 \
 //x=7.885 //y=3.51 //x2=7.705 //y2=5.2
cc_276 ( N_noxref_1_c_235_p N_VDD_M22_noxref_d ) capacitor c=0.065554f \
 //x=7.41 //y=5.56 //x2=7.705 //y2=5.2
cc_277 ( N_noxref_1_c_8_p N_VDD_M23_noxref_s ) capacitor c=0.00326953f \
 //x=7.805 //y=5.38 //x2=9.285 //y2=5.2
cc_278 ( N_noxref_1_c_9_p N_VDD_M23_noxref_s ) capacitor c=0.00111268f \
 //x=9.74 //y=3.665 //x2=9.285 //y2=5.2
cc_279 ( N_noxref_1_c_10_p N_VDD_M23_noxref_s ) capacitor c=0.00515461f \
 //x=7.41 //y=5.38 //x2=9.285 //y2=5.2
cc_280 ( N_noxref_1_c_11_p N_VDD_M23_noxref_s ) capacitor c=3.28075e-19 \
 //x=7.41 //y=5.56 //x2=9.285 //y2=5.2
cc_281 ( N_noxref_1_M23_noxref_g N_VDD_M23_noxref_s ) capacitor c=0.0567929f \
 //x=9.64 //y=6.2 //x2=9.285 //y2=5.2
cc_282 ( N_noxref_1_M24_noxref_g N_VDD_M24_noxref_d ) capacitor c=0.015318f \
 //x=10.08 //y=6.2 //x2=10.155 //y2=5.2
cc_283 ( N_noxref_1_c_31_p N_noxref_9_c_2971_n ) capacitor c=0.00177186f \
 //x=3.82 //y=2.375 //x2=4.475 //y2=0.72
cc_284 ( N_noxref_1_c_30_p N_noxref_9_c_2971_n ) capacitor c=0.00117306f \
 //x=3.82 //y=2.26 //x2=4.475 //y2=0.72
cc_285 ( N_noxref_1_c_55_p N_noxref_9_c_2971_n ) capacitor c=0.0206349f \
 //x=3.81 //y=1.095 //x2=4.475 //y2=0.72
cc_286 ( N_noxref_1_c_81_p N_noxref_9_c_2971_n ) capacitor c=0.00825432f \
 //x=4.34 //y=1.095 //x2=4.475 //y2=0.72
cc_287 ( N_noxref_1_c_33_p N_noxref_9_c_2971_n ) capacitor c=2.20712e-19 \
 //x=3.82 //y=2.26 //x2=4.475 //y2=0.72
cc_288 ( N_noxref_1_c_56_p N_noxref_9_c_2976_n ) capacitor c=0.0071177f \
 //x=3.81 //y=1.44 //x2=3.59 //y2=1.175
cc_289 ( N_noxref_1_c_55_p N_noxref_9_M2_noxref_s ) capacitor c=0.0071177f \
 //x=3.81 //y=1.095 //x2=3.455 //y2=0.555
cc_290 ( N_noxref_1_c_57_p N_noxref_9_M2_noxref_s ) capacitor c=0.0071177f \
 //x=3.81 //y=1.75 //x2=3.455 //y2=0.555
cc_291 ( N_noxref_1_c_81_p N_noxref_9_M2_noxref_s ) capacitor c=0.015333f \
 //x=4.34 //y=1.095 //x2=3.455 //y2=0.555
cc_292 ( N_noxref_1_c_82_p N_noxref_9_M2_noxref_s ) capacitor c=0.00248746f \
 //x=4.34 //y=1.44 //x2=3.455 //y2=0.555
cc_293 ( N_noxref_1_c_4_p D ) capacitor c=0.0428886f //x=7.89 //y=3.35 \
 //x2=7.15 //y2=2.77
cc_294 ( N_noxref_1_c_136_p D ) capacitor c=0.0174172f //x=7.89 //y=3.67 \
 //x2=7.15 //y2=2.77
cc_295 ( N_noxref_1_c_6_p D ) capacitor c=0.0397921f //x=7.89 //y=5.295 \
 //x2=7.15 //y2=2.77
cc_296 ( N_noxref_1_c_5_p D ) capacitor c=0.00210175f //x=9.74 //y=3.345 \
 //x2=7.15 //y2=2.77
cc_297 ( N_noxref_1_c_275_p D ) capacitor c=6.03895e-19 //x=7.885 //y=3.51 \
 //x2=7.15 //y2=2.77
cc_298 ( N_noxref_1_c_7_p D ) capacitor c=0.00136917f //x=9.742 //y=4.74 \
 //x2=7.15 //y2=2.77
cc_299 ( N_noxref_1_c_117_p D ) capacitor c=0.0277375f //x=8.045 //y=3.51 \
 //x2=7.15 //y2=2.77
cc_300 ( N_noxref_1_c_158_p N_D_c_3042_n ) capacitor c=0.0218552f //x=7.295 \
 //y=5.38 //x2=7.15 //y2=4.735
cc_301 ( N_noxref_1_c_6_p N_D_c_3042_n ) capacitor c=0.016905f //x=7.89 \
 //y=5.295 //x2=7.15 //y2=4.735
cc_302 ( N_noxref_1_c_4_p N_D_c_3044_n ) capacitor c=0.015397f //x=7.89 \
 //y=3.35 //x2=7.15 //y2=2.26
cc_303 ( N_noxref_1_c_117_p N_D_c_3044_n ) capacitor c=0.00255328f //x=8.045 \
 //y=3.51 //x2=7.15 //y2=2.26
cc_304 ( N_noxref_1_c_4_p N_D_c_3046_n ) capacitor c=9.90728e-19 //x=7.89 \
 //y=3.35 //x2=7.15 //y2=2.26
cc_305 ( N_noxref_1_c_158_p N_D_c_3047_n ) capacitor c=0.00469257f //x=7.295 \
 //y=5.38 //x2=7.18 //y2=4.88
cc_306 ( N_noxref_1_c_6_p N_D_c_3047_n ) capacitor c=7.76118e-19 //x=7.89 \
 //y=5.295 //x2=7.18 //y2=4.88
cc_307 ( N_noxref_1_c_158_p N_D_M21_noxref_g ) capacitor c=0.00842859f \
 //x=7.295 //y=5.38 //x2=7.19 //y2=6.2
cc_308 ( N_noxref_1_c_10_p N_D_M21_noxref_g ) capacitor c=0.00192712f //x=7.41 \
 //y=5.38 //x2=7.19 //y2=6.2
cc_309 ( N_noxref_1_c_235_p N_D_M21_noxref_g ) capacitor c=0.0178987f //x=7.41 \
 //y=5.56 //x2=7.19 //y2=6.2
cc_310 ( N_noxref_1_c_8_p N_D_M22_noxref_g ) capacitor c=0.0107429f //x=7.805 \
 //y=5.38 //x2=7.63 //y2=6.2
cc_311 ( N_noxref_1_c_10_p N_D_M22_noxref_g ) capacitor c=0.00298276f //x=7.41 \
 //y=5.38 //x2=7.63 //y2=6.2
cc_312 ( N_noxref_1_c_235_p N_D_M22_noxref_g ) capacitor c=0.0178506f //x=7.41 \
 //y=5.56 //x2=7.63 //y2=6.2
cc_313 ( N_noxref_1_c_17_p N_D_c_3055_n ) capacitor c=0.00120406f //x=7.45 \
 //y=1.18 //x2=7.185 //y2=1.085
cc_314 ( N_noxref_1_M4_noxref_d N_D_c_3055_n ) capacitor c=0.00137165f \
 //x=7.26 //y=1.085 //x2=7.185 //y2=1.085
cc_315 ( N_noxref_1_c_2_p N_D_c_3057_n ) capacitor c=0.00119302f //x=7.45 \
 //y=1.75 //x2=7.185 //y2=1.43
cc_316 ( N_noxref_1_c_17_p N_D_c_3057_n ) capacitor c=0.00218772f //x=7.45 \
 //y=1.18 //x2=7.185 //y2=1.43
cc_317 ( N_noxref_1_M4_noxref_d N_D_c_3057_n ) capacitor c=0.00237422f \
 //x=7.26 //y=1.085 //x2=7.185 //y2=1.43
cc_318 ( N_noxref_1_c_2_p N_D_c_3060_n ) capacitor c=0.00439215f //x=7.45 \
 //y=1.75 //x2=7.185 //y2=1.74
cc_319 ( N_noxref_1_c_6_p N_D_c_3061_n ) capacitor c=0.00845606f //x=7.89 \
 //y=5.295 //x2=7.555 //y2=4.97
cc_320 ( N_noxref_1_c_10_p N_D_c_3061_n ) capacitor c=0.0020909f //x=7.41 \
 //y=5.38 //x2=7.555 //y2=4.97
cc_321 ( N_noxref_1_c_235_p N_D_c_3061_n ) capacitor c=0.00291714f //x=7.41 \
 //y=5.56 //x2=7.555 //y2=4.97
cc_322 ( N_noxref_1_c_17_p N_D_c_3064_n ) capacitor c=5.50523e-19 //x=7.45 \
 //y=1.18 //x2=7.56 //y2=0.93
cc_323 ( N_noxref_1_M4_noxref_d N_D_c_3064_n ) capacitor c=0.0020782f //x=7.26 \
 //y=1.085 //x2=7.56 //y2=0.93
cc_324 ( N_noxref_1_c_2_p N_D_c_3066_n ) capacitor c=0.00917366f //x=7.45 \
 //y=1.75 //x2=7.56 //y2=1.585
cc_325 ( N_noxref_1_c_3_p N_D_c_3066_n ) capacitor c=0.00194324f //x=7.805 \
 //y=1.835 //x2=7.56 //y2=1.585
cc_326 ( N_noxref_1_c_17_p N_D_c_3066_n ) capacitor c=5.67071e-19 //x=7.45 \
 //y=1.18 //x2=7.56 //y2=1.585
cc_327 ( N_noxref_1_M4_noxref_d N_D_c_3066_n ) capacitor c=0.00356097f \
 //x=7.26 //y=1.085 //x2=7.56 //y2=1.585
cc_328 ( N_noxref_1_c_17_p N_D_c_3070_n ) capacitor c=0.00109205f //x=7.45 \
 //y=1.18 //x2=7.715 //y2=1.085
cc_329 ( N_noxref_1_M4_noxref_d N_D_c_3070_n ) capacitor c=8.50095e-19 \
 //x=7.26 //y=1.085 //x2=7.715 //y2=1.085
cc_330 ( N_noxref_1_c_2_p N_D_c_3072_n ) capacitor c=0.003249f //x=7.45 \
 //y=1.75 //x2=7.715 //y2=1.43
cc_331 ( N_noxref_1_c_3_p N_D_c_3072_n ) capacitor c=0.00323005f //x=7.805 \
 //y=1.835 //x2=7.715 //y2=1.43
cc_332 ( N_noxref_1_c_17_p N_D_c_3072_n ) capacitor c=0.00317092f //x=7.45 \
 //y=1.18 //x2=7.715 //y2=1.43
cc_333 ( N_noxref_1_M4_noxref_d N_D_c_3072_n ) capacitor c=0.00237422f \
 //x=7.26 //y=1.085 //x2=7.715 //y2=1.43
cc_334 ( N_noxref_1_c_4_p N_D_c_3076_n ) capacitor c=0.00281392f //x=7.89 \
 //y=3.35 //x2=7.15 //y2=2.26
cc_335 ( N_noxref_1_c_2_p N_D_c_3077_n ) capacitor c=0.00341688f //x=7.45 \
 //y=1.75 //x2=7.15 //y2=2.095
cc_336 ( N_noxref_1_c_4_p N_D_c_3077_n ) capacitor c=0.00309058f //x=7.89 \
 //y=3.35 //x2=7.15 //y2=2.095
cc_337 ( N_noxref_1_c_158_p N_D_c_3079_n ) capacitor c=9.61466e-19 //x=7.295 \
 //y=5.38 //x2=7.18 //y2=4.88
cc_338 ( N_noxref_1_c_6_p N_D_c_3079_n ) capacitor c=0.00142201f //x=7.89 \
 //y=5.295 //x2=7.18 //y2=4.88
cc_339 ( N_noxref_1_c_31_p N_GND_c_3150_n ) capacitor c=0.0021992f //x=3.82 \
 //y=2.375 //x2=6.395 //y2=0.175
cc_340 ( N_noxref_1_c_3_p N_GND_c_3151_n ) capacitor c=0.00654514f //x=7.805 \
 //y=1.835 //x2=9.725 //y2=0.175
cc_341 ( N_noxref_1_c_17_p N_GND_c_3151_n ) capacitor c=0.00964814f //x=7.45 \
 //y=1.18 //x2=9.725 //y2=0.175
cc_342 ( N_noxref_1_M4_noxref_d N_GND_c_3151_n ) capacitor c=3.01769e-19 \
 //x=7.26 //y=1.085 //x2=9.725 //y2=0.175
cc_343 ( N_noxref_1_c_39_p N_GND_c_3154_n ) capacitor c=6.81737e-19 //x=6.53 \
 //y=5.56 //x2=6.48 //y2=1.135
cc_344 ( N_noxref_1_c_17_p N_GND_c_3154_n ) capacitor c=0.0140211f //x=7.45 \
 //y=1.18 //x2=6.48 //y2=1.135
cc_345 ( N_noxref_1_M4_noxref_d N_GND_c_3154_n ) capacitor c=2.93544e-19 \
 //x=7.26 //y=1.085 //x2=6.48 //y2=1.135
cc_346 ( N_noxref_1_c_17_p N_GND_c_3157_n ) capacitor c=0.00549186f //x=7.45 \
 //y=1.18 //x2=9.81 //y2=1.135
cc_347 ( N_noxref_1_c_187_p N_GND_c_3157_n ) capacitor c=0.00709624f //x=9.74 \
 //y=2.26 //x2=9.81 //y2=1.135
cc_348 ( N_noxref_1_c_179_p N_GND_c_3157_n ) capacitor c=2.13705e-19 //x=9.74 \
 //y=2.26 //x2=9.81 //y2=1.135
cc_349 ( N_noxref_1_c_211_p N_GND_c_3157_n ) capacitor c=0.00171023f //x=9.545 \
 //y=1.045 //x2=9.81 //y2=1.135
cc_350 ( N_noxref_1_c_212_p N_GND_c_3157_n ) capacitor c=0.00357815f //x=9.545 \
 //y=1.39 //x2=9.81 //y2=1.135
cc_351 ( N_noxref_1_c_214_p N_GND_c_3157_n ) capacitor c=4.2764e-19 //x=9.545 \
 //y=1.7 //x2=9.81 //y2=1.135
cc_352 ( N_noxref_1_c_352_p N_GND_c_3157_n ) capacitor c=9.36995e-19 //x=9.92 \
 //y=0.89 //x2=9.81 //y2=1.135
cc_353 ( N_noxref_1_c_353_p N_GND_c_3157_n ) capacitor c=6.38426e-19 //x=9.92 \
 //y=1.545 //x2=9.81 //y2=1.135
cc_354 ( N_noxref_1_c_213_p N_GND_c_3157_n ) capacitor c=0.00171721f \
 //x=10.075 //y=1.045 //x2=9.81 //y2=1.135
cc_355 ( N_noxref_1_c_215_p N_GND_c_3157_n ) capacitor c=0.00296337f \
 //x=10.075 //y=1.39 //x2=9.81 //y2=1.135
cc_356 ( N_noxref_1_c_211_p N_GND_c_3167_n ) capacitor c=3.46594e-19 //x=9.545 \
 //y=1.045 //x2=9.807 //y2=1.005
cc_357 ( N_noxref_1_c_352_p N_GND_c_3167_n ) capacitor c=0.00839795f //x=9.92 \
 //y=0.89 //x2=9.807 //y2=1.005
cc_358 ( N_noxref_1_c_213_p N_GND_c_3167_n ) capacitor c=4.40641e-19 \
 //x=10.075 //y=1.045 //x2=9.807 //y2=1.005
cc_359 ( N_noxref_1_c_31_p N_GND_c_3170_n ) capacitor c=2.016e-19 //x=3.82 \
 //y=2.375 //x2=5.13 //y2=0.175
cc_360 ( N_noxref_1_c_3_p N_GND_c_3171_n ) capacitor c=7.75992e-19 //x=7.805 \
 //y=1.835 //x2=8.46 //y2=0.175
cc_361 ( N_noxref_1_c_211_p N_GND_c_3172_n ) capacitor c=0.00688027f //x=9.545 \
 //y=1.045 //x2=11.79 //y2=0.175
cc_362 ( N_noxref_1_c_17_p N_GND_c_3173_n ) capacitor c=2.83275e-19 //x=7.45 \
 //y=1.18 //x2=21.58 //y2=0.18
cc_363 ( N_noxref_1_c_4_p N_GND_c_3174_n ) capacitor c=9.32616e-19 //x=7.89 \
 //y=3.35 //x2=5.3 //y2=0.175
cc_364 ( N_noxref_1_c_115_p N_GND_c_3174_n ) capacitor c=0.00560367f //x=6.02 \
 //y=3.51 //x2=5.3 //y2=0.175
cc_365 ( N_noxref_1_c_30_p N_GND_c_3174_n ) capacitor c=0.00239899f //x=3.82 \
 //y=2.26 //x2=5.3 //y2=0.175
cc_366 ( N_noxref_1_c_82_p N_GND_c_3174_n ) capacitor c=0.00262688f //x=4.34 \
 //y=1.44 //x2=5.3 //y2=0.175
cc_367 ( N_noxref_1_c_33_p N_GND_c_3174_n ) capacitor c=2.63786e-19 //x=3.82 \
 //y=2.26 //x2=5.3 //y2=0.175
cc_368 ( N_noxref_1_c_2_p N_GND_c_3179_n ) capacitor c=0.002973f //x=7.45 \
 //y=1.75 //x2=8.63 //y2=0.175
cc_369 ( N_noxref_1_c_3_p N_GND_c_3179_n ) capacitor c=0.0300121f //x=7.805 \
 //y=1.835 //x2=8.63 //y2=0.175
cc_370 ( N_noxref_1_c_5_p N_GND_c_3179_n ) capacitor c=0.00829739f //x=9.74 \
 //y=3.345 //x2=8.63 //y2=0.175
cc_371 ( N_noxref_1_c_187_p N_GND_c_3179_n ) capacitor c=0.00427323f //x=9.74 \
 //y=2.26 //x2=8.63 //y2=0.175
cc_372 ( N_noxref_1_c_138_p N_GND_c_3179_n ) capacitor c=0.00560367f //x=9.575 \
 //y=3.505 //x2=8.63 //y2=0.175
cc_373 ( N_noxref_1_c_179_p N_GND_c_3179_n ) capacitor c=0.0038607f //x=9.74 \
 //y=2.26 //x2=8.63 //y2=0.175
cc_374 ( N_noxref_1_c_214_p N_GND_c_3179_n ) capacitor c=0.0015404f //x=9.545 \
 //y=1.7 //x2=8.63 //y2=0.175
cc_375 ( N_noxref_1_c_189_p N_GND_c_3179_n ) capacitor c=0.00906518f //x=9.545 \
 //y=2.095 //x2=8.63 //y2=0.175
cc_376 ( N_noxref_1_c_17_p N_GND_M3_noxref_d ) capacitor c=2.82748e-19 \
 //x=7.45 //y=1.18 //x2=6.29 //y2=1.045
cc_377 ( N_noxref_1_c_187_p N_GND_M5_noxref_d ) capacitor c=2.20438e-19 \
 //x=9.74 //y=2.26 //x2=9.62 //y2=1.045
cc_378 ( N_noxref_1_c_211_p N_GND_M5_noxref_d ) capacitor c=0.00192399f \
 //x=9.545 //y=1.045 //x2=9.62 //y2=1.045
cc_379 ( N_noxref_1_c_212_p N_GND_M5_noxref_d ) capacitor c=0.00210798f \
 //x=9.545 //y=1.39 //x2=9.62 //y2=1.045
cc_380 ( N_noxref_1_c_352_p N_GND_M5_noxref_d ) capacitor c=0.00472259f \
 //x=9.92 //y=0.89 //x2=9.62 //y2=1.045
cc_381 ( N_noxref_1_c_353_p N_GND_M5_noxref_d ) capacitor c=0.00166857f \
 //x=9.92 //y=1.545 //x2=9.62 //y2=1.045
cc_382 ( N_noxref_1_c_213_p N_GND_M5_noxref_d ) capacitor c=0.00230174f \
 //x=10.075 //y=1.045 //x2=9.62 //y2=1.045
cc_383 ( N_noxref_1_c_215_p N_GND_M5_noxref_d ) capacitor c=0.00210798f \
 //x=10.075 //y=1.39 //x2=9.62 //y2=1.045
cc_384 ( N_noxref_1_c_115_p N_noxref_13_c_3626_n ) capacitor c=0.00263807f \
 //x=6.02 //y=3.51 //x2=5.995 //y2=1.675
cc_385 ( N_noxref_1_c_115_p N_noxref_13_c_3627_n ) capacitor c=0.00586062f \
 //x=6.02 //y=3.51 //x2=6.88 //y2=1.76
cc_386 ( N_noxref_1_c_117_p N_noxref_13_c_3627_n ) capacitor c=0.00236963f \
 //x=8.045 //y=3.51 //x2=6.88 //y2=1.76
cc_387 ( N_noxref_1_c_89_p N_noxref_13_c_3629_n ) capacitor c=0.00911405f \
 //x=7.535 //y=1.835 //x2=6.965 //y2=1.675
cc_388 ( N_noxref_1_c_117_p N_noxref_13_c_3629_n ) capacitor c=0.0023811f \
 //x=8.045 //y=3.51 //x2=6.965 //y2=1.675
cc_389 ( N_noxref_1_c_3_p N_noxref_13_c_3631_n ) capacitor c=0.00389706f \
 //x=7.805 //y=1.835 //x2=7.85 //y2=0.71
cc_390 ( N_noxref_1_c_17_p N_noxref_13_c_3631_n ) capacitor c=0.00367971f \
 //x=7.45 //y=1.18 //x2=7.85 //y2=0.71
cc_391 ( N_noxref_1_M4_noxref_d N_noxref_13_c_3631_n ) capacitor c=0.00910163f \
 //x=7.26 //y=1.085 //x2=7.85 //y2=0.71
cc_392 ( N_noxref_1_c_2_p N_noxref_13_M3_noxref_s ) capacitor c=0.01625f \
 //x=7.45 //y=1.75 //x2=5.86 //y2=0.545
cc_393 ( N_noxref_1_c_3_p N_noxref_13_M3_noxref_s ) capacitor c=0.00640979f \
 //x=7.805 //y=1.835 //x2=5.86 //y2=0.545
cc_394 ( N_noxref_1_c_136_p N_noxref_13_M3_noxref_s ) capacitor c=4.17069e-19 \
 //x=7.89 //y=3.67 //x2=5.86 //y2=0.545
cc_395 ( N_noxref_1_c_17_p N_noxref_13_M3_noxref_s ) capacitor c=0.00905337f \
 //x=7.45 //y=1.18 //x2=5.86 //y2=0.545
cc_396 ( N_noxref_1_c_275_p N_noxref_13_M3_noxref_s ) capacitor c=0.0010514f \
 //x=7.885 //y=3.51 //x2=5.86 //y2=0.545
cc_397 ( N_noxref_1_M4_noxref_d N_noxref_13_M3_noxref_s ) capacitor \
 c=0.0275552f //x=7.26 //y=1.085 //x2=5.86 //y2=0.545
cc_398 ( N_noxref_1_c_138_p N_noxref_14_c_3692_n ) capacitor c=0.00264481f \
 //x=9.575 //y=3.505 //x2=9.325 //y2=1.675
cc_399 ( N_noxref_1_c_189_p N_noxref_14_c_3692_n ) capacitor c=0.00262672f \
 //x=9.545 //y=2.095 //x2=9.325 //y2=1.675
cc_400 ( N_noxref_1_c_9_p N_noxref_14_c_3694_n ) capacitor c=0.00402488f \
 //x=9.74 //y=3.665 //x2=10.21 //y2=1.76
cc_401 ( N_noxref_1_c_187_p N_noxref_14_c_3694_n ) capacitor c=0.00509504f \
 //x=9.74 //y=2.26 //x2=10.21 //y2=1.76
cc_402 ( N_noxref_1_c_138_p N_noxref_14_c_3694_n ) capacitor c=9.85544e-19 \
 //x=9.575 //y=3.505 //x2=10.21 //y2=1.76
cc_403 ( N_noxref_1_c_179_p N_noxref_14_c_3694_n ) capacitor c=0.00763108f \
 //x=9.74 //y=2.26 //x2=10.21 //y2=1.76
cc_404 ( N_noxref_1_c_214_p N_noxref_14_c_3694_n ) capacitor c=0.00697076f \
 //x=9.545 //y=1.7 //x2=10.21 //y2=1.76
cc_405 ( N_noxref_1_c_189_p N_noxref_14_c_3694_n ) capacitor c=0.0180051f \
 //x=9.545 //y=2.095 //x2=10.21 //y2=1.76
cc_406 ( N_noxref_1_c_353_p N_noxref_14_c_3694_n ) capacitor c=0.00723574f \
 //x=9.92 //y=1.545 //x2=10.21 //y2=1.76
cc_407 ( N_noxref_1_c_215_p N_noxref_14_c_3694_n ) capacitor c=0.00399755f \
 //x=10.075 //y=1.39 //x2=10.21 //y2=1.76
cc_408 ( N_noxref_1_c_189_p N_noxref_14_c_3702_n ) capacitor c=6.71402e-19 \
 //x=9.545 //y=2.095 //x2=10.295 //y2=1.675
cc_409 ( N_noxref_1_c_211_p N_noxref_14_M5_noxref_s ) capacitor c=0.0294925f \
 //x=9.545 //y=1.045 //x2=9.19 //y2=0.545
cc_410 ( N_noxref_1_c_214_p N_noxref_14_M5_noxref_s ) capacitor c=3.48408e-19 \
 //x=9.545 //y=1.7 //x2=9.19 //y2=0.545
cc_411 ( N_noxref_1_c_213_p N_noxref_14_M5_noxref_s ) capacitor c=0.0125442f \
 //x=10.075 //y=1.045 //x2=9.19 //y2=0.545
cc_412 ( N_noxref_2_c_415_n CLK ) capacitor c=0.0021505f //x=11.22 //y=3.35 \
 //x2=13.81 //y2=2.77
cc_413 ( N_noxref_2_c_417_n CLK ) capacitor c=0.00126687f //x=11.22 //y=5.295 \
 //x2=13.81 //y2=2.77
cc_414 ( N_noxref_2_c_438_p CLK ) capacitor c=0.0428988f //x=13.07 //y=3.35 \
 //x2=13.81 //y2=2.77
cc_415 ( N_noxref_2_c_439_p CLK ) capacitor c=0.0146933f //x=13.07 //y=3.67 \
 //x2=13.81 //y2=2.77
cc_416 ( N_noxref_2_c_440_p CLK ) capacitor c=6.03895e-19 //x=13.065 //y=3.51 \
 //x2=13.81 //y2=2.77
cc_417 ( N_noxref_2_c_441_p CLK ) capacitor c=0.0384373f //x=13.072 //y=4.74 \
 //x2=13.81 //y2=2.77
cc_418 ( N_noxref_2_c_442_p CLK ) capacitor c=0.00684103f //x=13.065 //y=3.51 \
 //x2=13.81 //y2=2.77
cc_419 ( N_noxref_2_c_443_p CLK ) capacitor c=3.49899e-19 //x=13.07 //y=2.26 \
 //x2=13.81 //y2=2.77
cc_420 ( N_noxref_2_c_444_p N_CLK_c_736_n ) capacitor c=0.0147952f //x=13.07 \
 //y=4.88 //x2=13.835 //y2=4.865
cc_421 ( N_noxref_2_c_441_p N_CLK_c_736_n ) capacitor c=0.00198309f //x=13.072 \
 //y=4.74 //x2=13.835 //y2=4.865
cc_422 ( N_noxref_2_c_446_p N_CLK_c_736_n ) capacitor c=7.64003e-19 //x=13.07 \
 //y=4.88 //x2=13.835 //y2=4.865
cc_423 ( N_noxref_2_c_447_p N_CLK_c_736_n ) capacitor c=0.00163736f //x=13.07 \
 //y=4.88 //x2=13.835 //y2=4.865
cc_424 ( N_noxref_2_c_448_p N_CLK_c_740_n ) capacitor c=0.0205342f //x=13.07 \
 //y=2.26 //x2=13.81 //y2=2.26
cc_425 ( N_noxref_2_c_443_p N_CLK_c_740_n ) capacitor c=5.16867e-19 //x=13.07 \
 //y=2.26 //x2=13.81 //y2=2.26
cc_426 ( N_noxref_2_c_450_p N_CLK_c_740_n ) capacitor c=0.00167888f //x=12.875 \
 //y=2.095 //x2=13.81 //y2=2.26
cc_427 ( N_noxref_2_c_412_n N_CLK_c_700_n ) capacitor c=0.00611627f //x=10.625 \
 //y=5.38 //x2=10.1 //y2=4.62
cc_428 ( N_noxref_2_c_419_n N_CLK_c_700_n ) capacitor c=0.0154722f //x=9.86 \
 //y=5.56 //x2=10.1 //y2=4.62
cc_429 ( N_noxref_2_c_417_n N_CLK_c_745_n ) capacitor c=0.0291324f //x=11.22 \
 //y=5.295 //x2=10.7 //y2=4.64
cc_430 ( N_noxref_2_c_454_p N_CLK_c_745_n ) capacitor c=0.0211374f //x=10.74 \
 //y=5.38 //x2=10.7 //y2=4.64
cc_431 ( N_noxref_2_c_444_p N_CLK_c_745_n ) capacitor c=0.0114767f //x=13.07 \
 //y=4.88 //x2=10.7 //y2=4.64
cc_432 ( N_noxref_2_c_441_p N_CLK_c_745_n ) capacitor c=0.0274896f //x=13.072 \
 //y=4.74 //x2=10.7 //y2=4.64
cc_433 ( N_noxref_2_c_438_p N_CLK_c_749_n ) capacitor c=3.49899e-19 //x=13.07 \
 //y=3.35 //x2=13.81 //y2=2.26
cc_434 ( N_noxref_2_c_448_p N_CLK_c_749_n ) capacitor c=5.24723e-19 //x=13.07 \
 //y=2.26 //x2=13.81 //y2=2.26
cc_435 ( N_noxref_2_c_443_p N_CLK_c_749_n ) capacitor c=0.00525888f //x=13.07 \
 //y=2.26 //x2=13.81 //y2=2.26
cc_436 ( N_noxref_2_c_450_p N_CLK_c_749_n ) capacitor c=0.00190888f //x=12.875 \
 //y=2.095 //x2=13.81 //y2=2.26
cc_437 ( N_noxref_2_c_444_p N_CLK_c_753_n ) capacitor c=4.80626e-19 //x=13.07 \
 //y=4.88 //x2=13.84 //y2=4.88
cc_438 ( N_noxref_2_c_446_p N_CLK_c_753_n ) capacitor c=0.00396769f //x=13.07 \
 //y=4.88 //x2=13.84 //y2=4.88
cc_439 ( N_noxref_2_c_447_p N_CLK_c_753_n ) capacitor c=0.0028411f //x=13.07 \
 //y=4.88 //x2=13.84 //y2=4.88
cc_440 ( N_noxref_2_M27_noxref_g N_CLK_M29_noxref_g ) capacitor c=0.0104892f \
 //x=12.97 //y=6.2 //x2=13.85 //y2=6.2
cc_441 ( N_noxref_2_M28_noxref_g N_CLK_M29_noxref_g ) capacitor c=0.107636f \
 //x=13.41 //y=6.2 //x2=13.85 //y2=6.2
cc_442 ( N_noxref_2_M28_noxref_g N_CLK_M30_noxref_g ) capacitor c=0.0100341f \
 //x=13.41 //y=6.2 //x2=14.29 //y2=6.2
cc_443 ( N_noxref_2_c_467_p N_CLK_c_759_n ) capacitor c=4.86545e-19 //x=12.875 \
 //y=1.045 //x2=13.845 //y2=1.085
cc_444 ( N_noxref_2_c_468_p N_CLK_c_759_n ) capacitor c=0.00152405f //x=12.875 \
 //y=1.39 //x2=13.845 //y2=1.085
cc_445 ( N_noxref_2_c_469_p N_CLK_c_759_n ) capacitor c=0.0151475f //x=13.405 \
 //y=1.045 //x2=13.845 //y2=1.085
cc_446 ( N_noxref_2_c_470_p N_CLK_c_762_n ) capacitor c=0.00109982f //x=12.875 \
 //y=1.7 //x2=13.845 //y2=1.43
cc_447 ( N_noxref_2_c_471_p N_CLK_c_762_n ) capacitor c=0.0111064f //x=13.405 \
 //y=1.39 //x2=13.845 //y2=1.43
cc_448 ( N_noxref_2_c_470_p N_CLK_c_764_n ) capacitor c=9.58243e-19 //x=12.875 \
 //y=1.7 //x2=13.845 //y2=1.74
cc_449 ( N_noxref_2_c_450_p N_CLK_c_764_n ) capacitor c=0.00662747f //x=12.875 \
 //y=2.095 //x2=13.845 //y2=1.74
cc_450 ( N_noxref_2_c_471_p N_CLK_c_764_n ) capacitor c=0.00862358f //x=13.405 \
 //y=1.39 //x2=13.845 //y2=1.74
cc_451 ( N_noxref_2_c_469_p N_CLK_c_767_n ) capacitor c=0.00127211f //x=13.405 \
 //y=1.045 //x2=14.375 //y2=1.085
cc_452 ( N_noxref_2_c_471_p N_CLK_c_768_n ) capacitor c=0.00204774f //x=13.405 \
 //y=1.39 //x2=14.375 //y2=1.43
cc_453 ( N_noxref_2_c_448_p N_CLK_c_769_n ) capacitor c=0.00167305f //x=13.07 \
 //y=2.26 //x2=13.81 //y2=2.26
cc_454 ( N_noxref_2_c_443_p N_CLK_c_769_n ) capacitor c=0.0018937f //x=13.07 \
 //y=2.26 //x2=13.81 //y2=2.26
cc_455 ( N_noxref_2_c_450_p N_CLK_c_769_n ) capacitor c=0.0181449f //x=12.875 \
 //y=2.095 //x2=13.81 //y2=2.26
cc_456 ( N_noxref_2_c_446_p N_CLK_c_772_n ) capacitor c=0.00202662f //x=13.07 \
 //y=4.88 //x2=13.84 //y2=4.88
cc_457 ( N_noxref_2_c_447_p N_CLK_c_772_n ) capacitor c=0.0288755f //x=13.07 \
 //y=4.88 //x2=13.84 //y2=4.88
cc_458 ( N_noxref_2_c_482_p N_noxref_4_c_1079_n ) capacitor c=0.00188982f \
 //x=11.135 //y=1.835 //x2=10.7 //y2=3.87
cc_459 ( N_noxref_2_c_414_n N_noxref_4_c_1079_n ) capacitor c=0.00322729f \
 //x=10.865 //y=1.835 //x2=10.7 //y2=3.87
cc_460 ( N_noxref_2_c_484_p N_noxref_4_c_1079_n ) capacitor c=0.00129068f \
 //x=11.22 //y=3.67 //x2=10.7 //y2=3.87
cc_461 ( N_noxref_2_c_417_n N_noxref_4_c_1079_n ) capacitor c=7.17731e-19 \
 //x=11.22 //y=5.295 //x2=10.7 //y2=3.87
cc_462 ( N_noxref_2_c_430_n N_noxref_4_c_1079_n ) capacitor c=0.0367952f \
 //x=11.385 //y=3.51 //x2=10.7 //y2=3.87
cc_463 ( N_noxref_2_c_484_p N_noxref_4_c_1084_n ) capacitor c=0.00771097f \
 //x=11.22 //y=3.67 //x2=11.44 //y2=3.895
cc_464 ( N_noxref_2_c_417_n N_noxref_4_c_1084_n ) capacitor c=0.0225064f \
 //x=11.22 //y=5.295 //x2=11.44 //y2=3.895
cc_465 ( N_noxref_2_c_489_p N_noxref_4_c_1084_n ) capacitor c=0.132506f \
 //x=12.905 //y=3.51 //x2=11.44 //y2=3.895
cc_466 ( N_noxref_2_c_439_p N_noxref_4_c_1087_n ) capacitor c=0.00341263f \
 //x=13.07 //y=3.67 //x2=12.68 //y2=3.88
cc_467 ( N_noxref_2_c_441_p N_noxref_4_c_1087_n ) capacitor c=4.98692e-19 \
 //x=13.072 //y=4.74 //x2=12.68 //y2=3.88
cc_468 ( N_noxref_2_c_489_p N_noxref_4_c_1087_n ) capacitor c=0.0114055f \
 //x=12.905 //y=3.51 //x2=12.68 //y2=3.88
cc_469 ( N_noxref_2_c_442_p N_noxref_4_c_1087_n ) capacitor c=0.0367952f \
 //x=13.065 //y=3.51 //x2=12.68 //y2=3.88
cc_470 ( N_noxref_2_c_439_p N_noxref_4_c_1091_n ) capacitor c=0.00251183f \
 //x=13.07 //y=3.67 //x2=13.28 //y2=3.895
cc_471 ( N_noxref_2_c_441_p N_noxref_4_c_1091_n ) capacitor c=0.0224596f \
 //x=13.072 //y=4.74 //x2=13.28 //y2=3.895
cc_472 ( N_noxref_2_c_415_n N_noxref_6_c_1726_n ) capacitor c=0.0428807f \
 //x=11.22 //y=3.35 //x2=10.48 //y2=4.095
cc_473 ( N_noxref_2_c_484_p N_noxref_6_c_1726_n ) capacitor c=0.0146933f \
 //x=11.22 //y=3.67 //x2=10.48 //y2=4.095
cc_474 ( N_noxref_2_c_417_n N_noxref_6_c_1726_n ) capacitor c=0.0169815f \
 //x=11.22 //y=5.295 //x2=10.48 //y2=4.095
cc_475 ( N_noxref_2_c_438_p N_noxref_6_c_1726_n ) capacitor c=0.00211383f \
 //x=13.07 //y=3.35 //x2=10.48 //y2=4.095
cc_476 ( N_noxref_2_c_429_n N_noxref_6_c_1726_n ) capacitor c=5.52402e-19 \
 //x=11.22 //y=3.51 //x2=10.48 //y2=4.095
cc_477 ( N_noxref_2_c_441_p N_noxref_6_c_1726_n ) capacitor c=3.11039e-19 \
 //x=13.072 //y=4.74 //x2=10.48 //y2=4.095
cc_478 ( N_noxref_2_c_430_n N_noxref_6_c_1726_n ) capacitor c=0.00365012f \
 //x=11.385 //y=3.51 //x2=10.48 //y2=4.095
cc_479 ( N_noxref_2_c_412_n N_noxref_6_c_1734_n ) capacitor c=0.0042527f \
 //x=10.625 //y=5.38 //x2=10.48 //y2=4.415
cc_480 ( N_noxref_2_c_417_n N_noxref_6_c_1734_n ) capacitor c=0.0147977f \
 //x=11.22 //y=5.295 //x2=10.48 //y2=4.415
cc_481 ( N_noxref_2_c_412_n N_noxref_6_c_1735_n ) capacitor c=0.0215252f \
 //x=10.625 //y=5.38 //x2=10.48 //y2=4.735
cc_482 ( N_noxref_2_c_417_n N_noxref_6_c_1735_n ) capacitor c=0.0281817f \
 //x=11.22 //y=5.295 //x2=10.48 //y2=4.735
cc_483 ( N_noxref_2_c_441_p N_noxref_6_c_1735_n ) capacitor c=4.6528e-19 \
 //x=13.072 //y=4.74 //x2=10.48 //y2=4.735
cc_484 ( N_noxref_2_M28_noxref_g N_noxref_6_c_1793_n ) capacitor c=0.00889217f \
 //x=13.41 //y=6.2 //x2=13.955 //y2=5.38
cc_485 ( N_noxref_2_c_413_n N_noxref_6_c_1794_n ) capacitor c=0.00324213f \
 //x=10.78 //y=1.75 //x2=14.11 //y2=1.75
cc_486 ( N_noxref_2_c_482_p N_noxref_6_c_1795_n ) capacitor c=0.00231467f \
 //x=11.135 //y=1.835 //x2=14.195 //y2=1.835
cc_487 ( N_noxref_2_c_415_n N_noxref_6_c_1796_n ) capacitor c=0.00204244f \
 //x=11.22 //y=3.35 //x2=14.55 //y2=4.105
cc_488 ( N_noxref_2_c_438_p N_noxref_6_c_1796_n ) capacitor c=0.00327648f \
 //x=13.07 //y=3.35 //x2=14.55 //y2=4.105
cc_489 ( N_noxref_2_c_441_p N_noxref_6_c_1796_n ) capacitor c=7.58839e-19 \
 //x=13.072 //y=4.74 //x2=14.55 //y2=4.105
cc_490 ( N_noxref_2_c_417_n N_noxref_6_c_1799_n ) capacitor c=0.00281705f \
 //x=11.22 //y=5.295 //x2=14.55 //y2=5.295
cc_491 ( N_noxref_2_c_441_p N_noxref_6_c_1799_n ) capacitor c=0.00105238f \
 //x=13.072 //y=4.74 //x2=14.55 //y2=5.295
cc_492 ( N_noxref_2_c_417_n N_noxref_6_c_1740_n ) capacitor c=6.89957e-19 \
 //x=11.22 //y=5.295 //x2=10.48 //y2=4.25
cc_493 ( N_noxref_2_c_415_n N_noxref_6_c_1741_n ) capacitor c=0.015397f \
 //x=11.22 //y=3.35 //x2=10.48 //y2=2.26
cc_494 ( N_noxref_2_c_518_p N_noxref_6_c_1803_n ) capacitor c=0.00114153f \
 //x=11.135 //y=5.38 //x2=13.19 //y2=5.56
cc_495 ( N_noxref_2_c_439_p N_noxref_6_c_1803_n ) capacitor c=5.66772e-19 \
 //x=13.07 //y=3.67 //x2=13.19 //y2=5.56
cc_496 ( N_noxref_2_c_454_p N_noxref_6_c_1803_n ) capacitor c=5.29822e-19 \
 //x=10.74 //y=5.38 //x2=13.19 //y2=5.56
cc_497 ( N_noxref_2_c_521_p N_noxref_6_c_1803_n ) capacitor c=0.00147119f \
 //x=10.74 //y=5.56 //x2=13.19 //y2=5.56
cc_498 ( N_noxref_2_c_444_p N_noxref_6_c_1803_n ) capacitor c=0.0117744f \
 //x=13.07 //y=4.88 //x2=13.19 //y2=5.56
cc_499 ( N_noxref_2_c_446_p N_noxref_6_c_1803_n ) capacitor c=0.00277154f \
 //x=13.07 //y=4.88 //x2=13.19 //y2=5.56
cc_500 ( N_noxref_2_M27_noxref_g N_noxref_6_c_1803_n ) capacitor c=0.00201806f \
 //x=12.97 //y=6.2 //x2=13.19 //y2=5.56
cc_501 ( N_noxref_2_M28_noxref_g N_noxref_6_c_1803_n ) capacitor c=0.00192712f \
 //x=13.41 //y=6.2 //x2=13.19 //y2=5.56
cc_502 ( N_noxref_2_c_447_p N_noxref_6_c_1803_n ) capacitor c=0.00194519f \
 //x=13.07 //y=4.88 //x2=13.19 //y2=5.56
cc_503 ( N_noxref_2_c_428_n N_noxref_6_c_1812_n ) capacitor c=6.99317e-19 \
 //x=10.78 //y=1.18 //x2=14.11 //y2=1.18
cc_504 ( N_noxref_2_c_417_n N_noxref_6_c_1813_n ) capacitor c=0.0227736f \
 //x=11.22 //y=5.295 //x2=14.38 //y2=4.25
cc_505 ( N_noxref_2_c_441_p N_noxref_6_c_1813_n ) capacitor c=0.0232046f \
 //x=13.072 //y=4.74 //x2=14.38 //y2=4.25
cc_506 ( N_noxref_2_c_489_p N_noxref_6_c_1813_n ) capacitor c=0.00973574f \
 //x=12.905 //y=3.51 //x2=14.38 //y2=4.25
cc_507 ( N_noxref_2_c_417_n N_noxref_6_c_1751_n ) capacitor c=0.00328982f \
 //x=11.22 //y=5.295 //x2=10.645 //y2=4.25
cc_508 ( N_noxref_2_c_415_n N_noxref_6_c_1755_n ) capacitor c=9.90728e-19 \
 //x=11.22 //y=3.35 //x2=10.48 //y2=2.26
cc_509 ( N_noxref_2_c_412_n N_noxref_6_c_1759_n ) capacitor c=0.00469257f \
 //x=10.625 //y=5.38 //x2=10.51 //y2=4.88
cc_510 ( N_noxref_2_c_417_n N_noxref_6_c_1759_n ) capacitor c=7.76118e-19 \
 //x=11.22 //y=5.295 //x2=10.51 //y2=4.88
cc_511 ( N_noxref_2_c_444_p N_noxref_6_c_1820_n ) capacitor c=0.00104426f \
 //x=13.07 //y=4.88 //x2=13.19 //y2=5.56
cc_512 ( N_noxref_2_c_446_p N_noxref_6_c_1820_n ) capacitor c=0.00377369f \
 //x=13.07 //y=4.88 //x2=13.19 //y2=5.56
cc_513 ( N_noxref_2_M27_noxref_g N_noxref_6_c_1820_n ) capacitor c=0.0158358f \
 //x=12.97 //y=6.2 //x2=13.19 //y2=5.56
cc_514 ( N_noxref_2_M28_noxref_g N_noxref_6_c_1820_n ) capacitor c=0.0178987f \
 //x=13.41 //y=6.2 //x2=13.19 //y2=5.56
cc_515 ( N_noxref_2_c_447_p N_noxref_6_c_1820_n ) capacitor c=0.0043218f \
 //x=13.07 //y=4.88 //x2=13.19 //y2=5.56
cc_516 ( N_noxref_2_c_412_n N_noxref_6_M25_noxref_g ) capacitor c=0.00842859f \
 //x=10.625 //y=5.38 //x2=10.52 //y2=6.2
cc_517 ( N_noxref_2_c_454_p N_noxref_6_M25_noxref_g ) capacitor c=0.00192712f \
 //x=10.74 //y=5.38 //x2=10.52 //y2=6.2
cc_518 ( N_noxref_2_c_542_p N_noxref_6_M25_noxref_g ) capacitor c=0.0178987f \
 //x=10.74 //y=5.56 //x2=10.52 //y2=6.2
cc_519 ( N_noxref_2_c_518_p N_noxref_6_M26_noxref_g ) capacitor c=0.0106088f \
 //x=11.135 //y=5.38 //x2=10.96 //y2=6.2
cc_520 ( N_noxref_2_c_454_p N_noxref_6_M26_noxref_g ) capacitor c=0.00298276f \
 //x=10.74 //y=5.38 //x2=10.96 //y2=6.2
cc_521 ( N_noxref_2_c_542_p N_noxref_6_M26_noxref_g ) capacitor c=0.0178506f \
 //x=10.74 //y=5.56 //x2=10.96 //y2=6.2
cc_522 ( N_noxref_2_c_428_n N_noxref_6_c_1765_n ) capacitor c=0.00120406f \
 //x=10.78 //y=1.18 //x2=10.515 //y2=1.085
cc_523 ( N_noxref_2_M6_noxref_d N_noxref_6_c_1765_n ) capacitor c=0.00137165f \
 //x=10.59 //y=1.085 //x2=10.515 //y2=1.085
cc_524 ( N_noxref_2_c_413_n N_noxref_6_c_1768_n ) capacitor c=0.00119008f \
 //x=10.78 //y=1.75 //x2=10.515 //y2=1.43
cc_525 ( N_noxref_2_c_428_n N_noxref_6_c_1768_n ) capacitor c=0.00218694f \
 //x=10.78 //y=1.18 //x2=10.515 //y2=1.43
cc_526 ( N_noxref_2_M6_noxref_d N_noxref_6_c_1768_n ) capacitor c=0.00237422f \
 //x=10.59 //y=1.085 //x2=10.515 //y2=1.43
cc_527 ( N_noxref_2_c_413_n N_noxref_6_c_1770_n ) capacitor c=0.00438634f \
 //x=10.78 //y=1.75 //x2=10.515 //y2=1.74
cc_528 ( N_noxref_2_c_417_n N_noxref_6_c_1837_n ) capacitor c=0.00845606f \
 //x=11.22 //y=5.295 //x2=10.885 //y2=4.97
cc_529 ( N_noxref_2_c_454_p N_noxref_6_c_1837_n ) capacitor c=0.0020909f \
 //x=10.74 //y=5.38 //x2=10.885 //y2=4.97
cc_530 ( N_noxref_2_c_542_p N_noxref_6_c_1837_n ) capacitor c=0.00291714f \
 //x=10.74 //y=5.56 //x2=10.885 //y2=4.97
cc_531 ( N_noxref_2_c_428_n N_noxref_6_c_1840_n ) capacitor c=5.50523e-19 \
 //x=10.78 //y=1.18 //x2=10.89 //y2=0.93
cc_532 ( N_noxref_2_M6_noxref_d N_noxref_6_c_1840_n ) capacitor c=0.0020782f \
 //x=10.59 //y=1.085 //x2=10.89 //y2=0.93
cc_533 ( N_noxref_2_c_413_n N_noxref_6_c_1842_n ) capacitor c=0.00916852f \
 //x=10.78 //y=1.75 //x2=10.89 //y2=1.585
cc_534 ( N_noxref_2_c_482_p N_noxref_6_c_1842_n ) capacitor c=0.00194324f \
 //x=11.135 //y=1.835 //x2=10.89 //y2=1.585
cc_535 ( N_noxref_2_c_428_n N_noxref_6_c_1842_n ) capacitor c=5.67071e-19 \
 //x=10.78 //y=1.18 //x2=10.89 //y2=1.585
cc_536 ( N_noxref_2_M6_noxref_d N_noxref_6_c_1842_n ) capacitor c=0.00356097f \
 //x=10.59 //y=1.085 //x2=10.89 //y2=1.585
cc_537 ( N_noxref_2_c_428_n N_noxref_6_c_1773_n ) capacitor c=0.00109205f \
 //x=10.78 //y=1.18 //x2=11.045 //y2=1.085
cc_538 ( N_noxref_2_M6_noxref_d N_noxref_6_c_1773_n ) capacitor c=8.50095e-19 \
 //x=10.59 //y=1.085 //x2=11.045 //y2=1.085
cc_539 ( N_noxref_2_c_413_n N_noxref_6_c_1774_n ) capacitor c=0.003249f \
 //x=10.78 //y=1.75 //x2=11.045 //y2=1.43
cc_540 ( N_noxref_2_c_482_p N_noxref_6_c_1774_n ) capacitor c=0.00323005f \
 //x=11.135 //y=1.835 //x2=11.045 //y2=1.43
cc_541 ( N_noxref_2_c_428_n N_noxref_6_c_1774_n ) capacitor c=0.00317092f \
 //x=10.78 //y=1.18 //x2=11.045 //y2=1.43
cc_542 ( N_noxref_2_M6_noxref_d N_noxref_6_c_1774_n ) capacitor c=0.00237422f \
 //x=10.59 //y=1.085 //x2=11.045 //y2=1.43
cc_543 ( N_noxref_2_c_415_n N_noxref_6_c_1775_n ) capacitor c=0.00281392f \
 //x=11.22 //y=3.35 //x2=10.48 //y2=2.26
cc_544 ( N_noxref_2_c_413_n N_noxref_6_c_1853_n ) capacitor c=0.00341114f \
 //x=10.78 //y=1.75 //x2=10.48 //y2=2.095
cc_545 ( N_noxref_2_c_415_n N_noxref_6_c_1853_n ) capacitor c=0.00309058f \
 //x=11.22 //y=3.35 //x2=10.48 //y2=2.095
cc_546 ( N_noxref_2_c_412_n N_noxref_6_c_1778_n ) capacitor c=8.41897e-19 \
 //x=10.625 //y=5.38 //x2=10.51 //y2=4.88
cc_547 ( N_noxref_2_c_417_n N_noxref_6_c_1778_n ) capacitor c=0.00142201f \
 //x=11.22 //y=5.295 //x2=10.51 //y2=4.88
cc_548 ( N_noxref_2_c_412_n N_VDD_c_2586_n ) capacitor c=0.00648267f \
 //x=10.625 //y=5.38 //x2=21.58 //y2=7.58
cc_549 ( N_noxref_2_c_518_p N_VDD_c_2586_n ) capacitor c=0.00492586f \
 //x=11.135 //y=5.38 //x2=21.58 //y2=7.58
cc_550 ( N_noxref_2_c_484_p N_VDD_c_2586_n ) capacitor c=4.58912e-19 //x=11.22 \
 //y=3.67 //x2=21.58 //y2=7.58
cc_551 ( N_noxref_2_c_439_p N_VDD_c_2586_n ) capacitor c=2.00712e-19 //x=13.07 \
 //y=3.67 //x2=21.58 //y2=7.58
cc_552 ( N_noxref_2_c_419_n N_VDD_c_2586_n ) capacitor c=0.00368834f //x=9.86 \
 //y=5.56 //x2=21.58 //y2=7.58
cc_553 ( N_noxref_2_c_454_p N_VDD_c_2586_n ) capacitor c=8.42594e-19 //x=10.74 \
 //y=5.38 //x2=21.58 //y2=7.58
cc_554 ( N_noxref_2_c_521_p N_VDD_c_2586_n ) capacitor c=0.00285853f //x=10.74 \
 //y=5.56 //x2=21.58 //y2=7.58
cc_555 ( N_noxref_2_c_444_p N_VDD_c_2586_n ) capacitor c=9.07241e-19 //x=13.07 \
 //y=4.88 //x2=21.58 //y2=7.58
cc_556 ( N_noxref_2_c_431_n N_VDD_c_2586_n ) capacitor c=0.00224881f //x=9.86 \
 //y=5.56 //x2=21.58 //y2=7.58
cc_557 ( N_noxref_2_c_542_p N_VDD_c_2586_n ) capacitor c=0.00224881f //x=10.74 \
 //y=5.56 //x2=21.58 //y2=7.58
cc_558 ( N_noxref_2_c_446_p N_VDD_c_2586_n ) capacitor c=6.22888e-19 //x=13.07 \
 //y=4.88 //x2=21.58 //y2=7.58
cc_559 ( N_noxref_2_c_412_n N_VDD_c_2606_n ) capacitor c=0.00208087f \
 //x=10.625 //y=5.38 //x2=10.215 //y2=7.585
cc_560 ( N_noxref_2_c_419_n N_VDD_c_2606_n ) capacitor c=9.41185e-19 //x=9.86 \
 //y=5.56 //x2=10.215 //y2=7.585
cc_561 ( N_noxref_2_c_431_n N_VDD_c_2606_n ) capacitor c=0.0136705f //x=9.86 \
 //y=5.56 //x2=10.215 //y2=7.585
cc_562 ( N_noxref_2_c_412_n N_VDD_c_2656_n ) capacitor c=0.00180737f \
 //x=10.625 //y=5.38 //x2=11.095 //y2=7.585
cc_563 ( N_noxref_2_c_518_p N_VDD_c_2656_n ) capacitor c=0.00208087f \
 //x=11.135 //y=5.38 //x2=11.095 //y2=7.585
cc_564 ( N_noxref_2_c_454_p N_VDD_c_2656_n ) capacitor c=4.23719e-19 //x=10.74 \
 //y=5.38 //x2=11.095 //y2=7.585
cc_565 ( N_noxref_2_c_521_p N_VDD_c_2656_n ) capacitor c=5.77976e-19 //x=10.74 \
 //y=5.56 //x2=11.095 //y2=7.585
cc_566 ( N_noxref_2_c_542_p N_VDD_c_2656_n ) capacitor c=0.0136705f //x=10.74 \
 //y=5.56 //x2=11.095 //y2=7.585
cc_567 ( N_noxref_2_c_444_p N_VDD_c_2661_n ) capacitor c=6.28113e-19 //x=13.07 \
 //y=4.88 //x2=13.545 //y2=7.585
cc_568 ( N_noxref_2_M27_noxref_g N_VDD_c_2661_n ) capacitor c=0.00732618f \
 //x=12.97 //y=6.2 //x2=13.545 //y2=7.585
cc_569 ( N_noxref_2_M28_noxref_g N_VDD_c_2661_n ) capacitor c=0.00755544f \
 //x=13.41 //y=6.2 //x2=13.545 //y2=7.585
cc_570 ( N_noxref_2_c_417_n N_VDD_c_2614_n ) capacitor c=0.0013228f //x=11.22 \
 //y=5.295 //x2=8.63 //y2=7.585
cc_571 ( N_noxref_2_c_419_n N_VDD_c_2614_n ) capacitor c=4.91377e-19 //x=9.86 \
 //y=5.56 //x2=8.63 //y2=7.585
cc_572 ( N_noxref_2_c_431_n N_VDD_c_2614_n ) capacitor c=0.0064135f //x=9.86 \
 //y=5.56 //x2=8.63 //y2=7.585
cc_573 ( N_noxref_2_c_417_n N_VDD_c_2667_n ) capacitor c=0.0285805f //x=11.22 \
 //y=5.295 //x2=11.96 //y2=7.585
cc_574 ( N_noxref_2_c_454_p N_VDD_c_2667_n ) capacitor c=0.00240948f //x=10.74 \
 //y=5.38 //x2=11.96 //y2=7.585
cc_575 ( N_noxref_2_c_521_p N_VDD_c_2667_n ) capacitor c=4.09141e-19 //x=10.74 \
 //y=5.56 //x2=11.96 //y2=7.585
cc_576 ( N_noxref_2_c_444_p N_VDD_c_2667_n ) capacitor c=0.00508547f //x=13.07 \
 //y=4.88 //x2=11.96 //y2=7.585
cc_577 ( N_noxref_2_c_441_p N_VDD_c_2667_n ) capacitor c=0.005822f //x=13.072 \
 //y=4.74 //x2=11.96 //y2=7.585
cc_578 ( N_noxref_2_c_542_p N_VDD_c_2667_n ) capacitor c=0.0101861f //x=10.74 \
 //y=5.56 //x2=11.96 //y2=7.585
cc_579 ( N_noxref_2_c_446_p N_VDD_c_2667_n ) capacitor c=0.00370494f //x=13.07 \
 //y=4.88 //x2=11.96 //y2=7.585
cc_580 ( N_noxref_2_c_447_p N_VDD_c_2667_n ) capacitor c=0.0129564f //x=13.07 \
 //y=4.88 //x2=11.96 //y2=7.585
cc_581 ( N_noxref_2_c_419_n N_VDD_M23_noxref_s ) capacitor c=0.0572211f \
 //x=9.86 //y=5.56 //x2=9.285 //y2=5.2
cc_582 ( N_noxref_2_c_454_p N_VDD_M23_noxref_s ) capacitor c=6.52457e-19 \
 //x=10.74 //y=5.38 //x2=9.285 //y2=5.2
cc_583 ( N_noxref_2_c_431_n N_VDD_M23_noxref_s ) capacitor c=0.0887533f \
 //x=9.86 //y=5.56 //x2=9.285 //y2=5.2
cc_584 ( N_noxref_2_c_412_n N_VDD_M24_noxref_d ) capacitor c=0.00734094f \
 //x=10.625 //y=5.38 //x2=10.155 //y2=5.2
cc_585 ( N_noxref_2_c_419_n N_VDD_M24_noxref_d ) capacitor c=0.0043528f \
 //x=9.86 //y=5.56 //x2=10.155 //y2=5.2
cc_586 ( N_noxref_2_c_521_p N_VDD_M24_noxref_d ) capacitor c=0.0043528f \
 //x=10.74 //y=5.56 //x2=10.155 //y2=5.2
cc_587 ( N_noxref_2_c_431_n N_VDD_M24_noxref_d ) capacitor c=0.065554f \
 //x=9.86 //y=5.56 //x2=10.155 //y2=5.2
cc_588 ( N_noxref_2_c_542_p N_VDD_M24_noxref_d ) capacitor c=0.065554f \
 //x=10.74 //y=5.56 //x2=10.155 //y2=5.2
cc_589 ( N_noxref_2_c_518_p N_VDD_M26_noxref_d ) capacitor c=0.00934027f \
 //x=11.135 //y=5.38 //x2=11.035 //y2=5.2
cc_590 ( N_noxref_2_c_521_p N_VDD_M26_noxref_d ) capacitor c=0.00587834f \
 //x=10.74 //y=5.56 //x2=11.035 //y2=5.2
cc_591 ( N_noxref_2_c_429_n N_VDD_M26_noxref_d ) capacitor c=9.65951e-19 \
 //x=11.22 //y=3.51 //x2=11.035 //y2=5.2
cc_592 ( N_noxref_2_c_542_p N_VDD_M26_noxref_d ) capacitor c=0.065554f \
 //x=10.74 //y=5.56 //x2=11.035 //y2=5.2
cc_593 ( N_noxref_2_c_518_p N_VDD_M27_noxref_s ) capacitor c=0.00326953f \
 //x=11.135 //y=5.38 //x2=12.615 //y2=5.2
cc_594 ( N_noxref_2_c_439_p N_VDD_M27_noxref_s ) capacitor c=0.00111275f \
 //x=13.07 //y=3.67 //x2=12.615 //y2=5.2
cc_595 ( N_noxref_2_c_454_p N_VDD_M27_noxref_s ) capacitor c=0.00515461f \
 //x=10.74 //y=5.38 //x2=12.615 //y2=5.2
cc_596 ( N_noxref_2_c_521_p N_VDD_M27_noxref_s ) capacitor c=3.28075e-19 \
 //x=10.74 //y=5.56 //x2=12.615 //y2=5.2
cc_597 ( N_noxref_2_M27_noxref_g N_VDD_M27_noxref_s ) capacitor c=0.0567929f \
 //x=12.97 //y=6.2 //x2=12.615 //y2=5.2
cc_598 ( N_noxref_2_M28_noxref_g N_VDD_M28_noxref_d ) capacitor c=0.015318f \
 //x=13.41 //y=6.2 //x2=13.485 //y2=5.2
cc_599 ( N_noxref_2_c_482_p N_GND_c_3195_n ) capacitor c=0.00654514f \
 //x=11.135 //y=1.835 //x2=13.055 //y2=0.175
cc_600 ( N_noxref_2_c_484_p N_GND_c_3195_n ) capacitor c=4.53285e-19 //x=11.22 \
 //y=3.67 //x2=13.055 //y2=0.175
cc_601 ( N_noxref_2_c_428_n N_GND_c_3195_n ) capacitor c=0.00964814f //x=10.78 \
 //y=1.18 //x2=13.055 //y2=0.175
cc_602 ( N_noxref_2_M6_noxref_d N_GND_c_3195_n ) capacitor c=3.01769e-19 \
 //x=10.59 //y=1.085 //x2=13.055 //y2=0.175
cc_603 ( N_noxref_2_c_419_n N_GND_c_3157_n ) capacitor c=7.78494e-19 //x=9.86 \
 //y=5.56 //x2=9.81 //y2=1.135
cc_604 ( N_noxref_2_c_428_n N_GND_c_3157_n ) capacitor c=0.0140087f //x=10.78 \
 //y=1.18 //x2=9.81 //y2=1.135
cc_605 ( N_noxref_2_M6_noxref_d N_GND_c_3157_n ) capacitor c=2.93544e-19 \
 //x=10.59 //y=1.085 //x2=9.81 //y2=1.135
cc_606 ( N_noxref_2_c_428_n N_GND_c_3202_n ) capacitor c=0.00549186f //x=10.78 \
 //y=1.18 //x2=13.14 //y2=1.135
cc_607 ( N_noxref_2_c_448_p N_GND_c_3202_n ) capacitor c=0.00709624f //x=13.07 \
 //y=2.26 //x2=13.14 //y2=1.135
cc_608 ( N_noxref_2_c_443_p N_GND_c_3202_n ) capacitor c=2.13705e-19 //x=13.07 \
 //y=2.26 //x2=13.14 //y2=1.135
cc_609 ( N_noxref_2_c_467_p N_GND_c_3202_n ) capacitor c=0.00171023f \
 //x=12.875 //y=1.045 //x2=13.14 //y2=1.135
cc_610 ( N_noxref_2_c_468_p N_GND_c_3202_n ) capacitor c=0.00357815f \
 //x=12.875 //y=1.39 //x2=13.14 //y2=1.135
cc_611 ( N_noxref_2_c_470_p N_GND_c_3202_n ) capacitor c=4.2764e-19 //x=12.875 \
 //y=1.7 //x2=13.14 //y2=1.135
cc_612 ( N_noxref_2_c_636_p N_GND_c_3202_n ) capacitor c=9.36995e-19 //x=13.25 \
 //y=0.89 //x2=13.14 //y2=1.135
cc_613 ( N_noxref_2_c_637_p N_GND_c_3202_n ) capacitor c=6.38426e-19 //x=13.25 \
 //y=1.545 //x2=13.14 //y2=1.135
cc_614 ( N_noxref_2_c_469_p N_GND_c_3202_n ) capacitor c=0.00171721f \
 //x=13.405 //y=1.045 //x2=13.14 //y2=1.135
cc_615 ( N_noxref_2_c_471_p N_GND_c_3202_n ) capacitor c=0.00296337f \
 //x=13.405 //y=1.39 //x2=13.14 //y2=1.135
cc_616 ( N_noxref_2_c_467_p N_GND_c_3212_n ) capacitor c=3.46594e-19 \
 //x=12.875 //y=1.045 //x2=13.137 //y2=1.005
cc_617 ( N_noxref_2_c_636_p N_GND_c_3212_n ) capacitor c=0.00839795f //x=13.25 \
 //y=0.89 //x2=13.137 //y2=1.005
cc_618 ( N_noxref_2_c_469_p N_GND_c_3212_n ) capacitor c=4.40641e-19 \
 //x=13.405 //y=1.045 //x2=13.137 //y2=1.005
cc_619 ( N_noxref_2_c_482_p N_GND_c_3172_n ) capacitor c=7.75992e-19 \
 //x=11.135 //y=1.835 //x2=11.79 //y2=0.175
cc_620 ( N_noxref_2_c_484_p N_GND_c_3172_n ) capacitor c=3.21489e-19 //x=11.22 \
 //y=3.67 //x2=11.79 //y2=0.175
cc_621 ( N_noxref_2_c_467_p N_GND_c_3217_n ) capacitor c=0.00688027f \
 //x=12.875 //y=1.045 //x2=15.12 //y2=0.175
cc_622 ( N_noxref_2_c_428_n N_GND_c_3173_n ) capacitor c=2.83275e-19 //x=10.78 \
 //y=1.18 //x2=21.58 //y2=0.18
cc_623 ( N_noxref_2_c_415_n N_GND_c_3179_n ) capacitor c=9.32616e-19 //x=11.22 \
 //y=3.35 //x2=8.63 //y2=0.175
cc_624 ( N_noxref_2_c_413_n N_GND_c_3220_n ) capacitor c=0.002973f //x=10.78 \
 //y=1.75 //x2=11.96 //y2=0.175
cc_625 ( N_noxref_2_c_482_p N_GND_c_3220_n ) capacitor c=0.0300121f //x=11.135 \
 //y=1.835 //x2=11.96 //y2=0.175
cc_626 ( N_noxref_2_c_438_p N_GND_c_3220_n ) capacitor c=0.00829739f //x=13.07 \
 //y=3.35 //x2=11.96 //y2=0.175
cc_627 ( N_noxref_2_c_448_p N_GND_c_3220_n ) capacitor c=0.00427323f //x=13.07 \
 //y=2.26 //x2=11.96 //y2=0.175
cc_628 ( N_noxref_2_c_489_p N_GND_c_3220_n ) capacitor c=0.00560367f \
 //x=12.905 //y=3.51 //x2=11.96 //y2=0.175
cc_629 ( N_noxref_2_c_443_p N_GND_c_3220_n ) capacitor c=0.0038607f //x=13.07 \
 //y=2.26 //x2=11.96 //y2=0.175
cc_630 ( N_noxref_2_c_470_p N_GND_c_3220_n ) capacitor c=0.0015404f //x=12.875 \
 //y=1.7 //x2=11.96 //y2=0.175
cc_631 ( N_noxref_2_c_450_p N_GND_c_3220_n ) capacitor c=0.00906518f \
 //x=12.875 //y=2.095 //x2=11.96 //y2=0.175
cc_632 ( N_noxref_2_c_428_n N_GND_M5_noxref_d ) capacitor c=2.82748e-19 \
 //x=10.78 //y=1.18 //x2=9.62 //y2=1.045
cc_633 ( N_noxref_2_c_448_p N_GND_M7_noxref_d ) capacitor c=2.20438e-19 \
 //x=13.07 //y=2.26 //x2=12.95 //y2=1.045
cc_634 ( N_noxref_2_c_467_p N_GND_M7_noxref_d ) capacitor c=0.00192399f \
 //x=12.875 //y=1.045 //x2=12.95 //y2=1.045
cc_635 ( N_noxref_2_c_468_p N_GND_M7_noxref_d ) capacitor c=0.00210798f \
 //x=12.875 //y=1.39 //x2=12.95 //y2=1.045
cc_636 ( N_noxref_2_c_636_p N_GND_M7_noxref_d ) capacitor c=0.00472259f \
 //x=13.25 //y=0.89 //x2=12.95 //y2=1.045
cc_637 ( N_noxref_2_c_637_p N_GND_M7_noxref_d ) capacitor c=0.00166857f \
 //x=13.25 //y=1.545 //x2=12.95 //y2=1.045
cc_638 ( N_noxref_2_c_469_p N_GND_M7_noxref_d ) capacitor c=0.00230174f \
 //x=13.405 //y=1.045 //x2=12.95 //y2=1.045
cc_639 ( N_noxref_2_c_471_p N_GND_M7_noxref_d ) capacitor c=0.00210798f \
 //x=13.405 //y=1.39 //x2=12.95 //y2=1.045
cc_640 ( N_noxref_2_c_414_n N_noxref_14_c_3702_n ) capacitor c=0.00911498f \
 //x=10.865 //y=1.835 //x2=10.295 //y2=1.675
cc_641 ( N_noxref_2_c_482_p N_noxref_14_c_3707_n ) capacitor c=0.00372218f \
 //x=11.135 //y=1.835 //x2=11.18 //y2=0.71
cc_642 ( N_noxref_2_c_428_n N_noxref_14_c_3707_n ) capacitor c=0.00367971f \
 //x=10.78 //y=1.18 //x2=11.18 //y2=0.71
cc_643 ( N_noxref_2_M6_noxref_d N_noxref_14_c_3707_n ) capacitor c=0.00910163f \
 //x=10.59 //y=1.085 //x2=11.18 //y2=0.71
cc_644 ( N_noxref_2_c_413_n N_noxref_14_M5_noxref_s ) capacitor c=0.0162484f \
 //x=10.78 //y=1.75 //x2=9.19 //y2=0.545
cc_645 ( N_noxref_2_c_482_p N_noxref_14_M5_noxref_s ) capacitor c=0.00640979f \
 //x=11.135 //y=1.835 //x2=9.19 //y2=0.545
cc_646 ( N_noxref_2_c_484_p N_noxref_14_M5_noxref_s ) capacitor c=4.17069e-19 \
 //x=11.22 //y=3.67 //x2=9.19 //y2=0.545
cc_647 ( N_noxref_2_c_428_n N_noxref_14_M5_noxref_s ) capacitor c=0.00905169f \
 //x=10.78 //y=1.18 //x2=9.19 //y2=0.545
cc_648 ( N_noxref_2_c_429_n N_noxref_14_M5_noxref_s ) capacitor c=0.0010514f \
 //x=11.22 //y=3.51 //x2=9.19 //y2=0.545
cc_649 ( N_noxref_2_M6_noxref_d N_noxref_14_M5_noxref_s ) capacitor \
 c=0.0275552f //x=10.59 //y=1.085 //x2=9.19 //y2=0.545
cc_650 ( N_noxref_2_c_489_p N_noxref_15_c_3760_n ) capacitor c=0.00264481f \
 //x=12.905 //y=3.51 //x2=12.655 //y2=1.675
cc_651 ( N_noxref_2_c_450_p N_noxref_15_c_3760_n ) capacitor c=0.00262672f \
 //x=12.875 //y=2.095 //x2=12.655 //y2=1.675
cc_652 ( N_noxref_2_c_439_p N_noxref_15_c_3762_n ) capacitor c=0.00402188f \
 //x=13.07 //y=3.67 //x2=13.54 //y2=1.76
cc_653 ( N_noxref_2_c_448_p N_noxref_15_c_3762_n ) capacitor c=0.00509504f \
 //x=13.07 //y=2.26 //x2=13.54 //y2=1.76
cc_654 ( N_noxref_2_c_489_p N_noxref_15_c_3762_n ) capacitor c=9.85544e-19 \
 //x=12.905 //y=3.51 //x2=13.54 //y2=1.76
cc_655 ( N_noxref_2_c_443_p N_noxref_15_c_3762_n ) capacitor c=0.00763108f \
 //x=13.07 //y=2.26 //x2=13.54 //y2=1.76
cc_656 ( N_noxref_2_c_470_p N_noxref_15_c_3762_n ) capacitor c=0.00697076f \
 //x=12.875 //y=1.7 //x2=13.54 //y2=1.76
cc_657 ( N_noxref_2_c_450_p N_noxref_15_c_3762_n ) capacitor c=0.0180072f \
 //x=12.875 //y=2.095 //x2=13.54 //y2=1.76
cc_658 ( N_noxref_2_c_637_p N_noxref_15_c_3762_n ) capacitor c=0.00723574f \
 //x=13.25 //y=1.545 //x2=13.54 //y2=1.76
cc_659 ( N_noxref_2_c_471_p N_noxref_15_c_3762_n ) capacitor c=0.00399755f \
 //x=13.405 //y=1.39 //x2=13.54 //y2=1.76
cc_660 ( N_noxref_2_c_450_p N_noxref_15_c_3770_n ) capacitor c=6.71402e-19 \
 //x=12.875 //y=2.095 //x2=13.625 //y2=1.675
cc_661 ( N_noxref_2_c_467_p N_noxref_15_M7_noxref_s ) capacitor c=0.0294925f \
 //x=12.875 //y=1.045 //x2=12.52 //y2=0.545
cc_662 ( N_noxref_2_c_470_p N_noxref_15_M7_noxref_s ) capacitor c=3.48408e-19 \
 //x=12.875 //y=1.7 //x2=12.52 //y2=0.545
cc_663 ( N_noxref_2_c_469_p N_noxref_15_M7_noxref_s ) capacitor c=0.0125442f \
 //x=13.405 //y=1.045 //x2=12.52 //y2=0.545
cc_664 ( N_CLK_c_697_n N_noxref_4_c_1093_n ) capacitor c=0.0292733f //x=2.71 \
 //y=4.88 //x2=2.78 //y2=5.335
cc_665 ( N_CLK_c_707_n N_noxref_4_c_1093_n ) capacitor c=0.0107219f //x=2.71 \
 //y=4.62 //x2=2.78 //y2=5.335
cc_666 ( N_CLK_c_712_n N_noxref_4_c_1093_n ) capacitor c=0.00495283f //x=2.71 \
 //y=4.88 //x2=2.78 //y2=5.335
cc_667 ( N_CLK_M15_noxref_g N_noxref_4_c_1093_n ) capacitor c=0.00853188f \
 //x=2.68 //y=6.2 //x2=2.78 //y2=5.335
cc_668 ( N_CLK_c_726_n N_noxref_4_c_1093_n ) capacitor c=3.4353e-19 //x=2.71 \
 //y=4.88 //x2=2.78 //y2=5.335
cc_669 ( N_CLK_M16_noxref_g N_noxref_4_c_975_n ) capacitor c=0.00955829f \
 //x=3.12 //y=6.2 //x2=3.665 //y2=5.335
cc_670 ( N_CLK_c_700_n N_noxref_4_c_979_n ) capacitor c=0.0205765f //x=10.1 \
 //y=4.62 //x2=4.475 //y2=5.335
cc_671 ( CLK N_noxref_4_c_1006_n ) capacitor c=0.00285669f //x=2.71 //y=2.77 \
 //x2=4.56 //y2=3.72
cc_672 ( CLK N_noxref_4_c_1019_n ) capacitor c=9.69745e-19 //x=2.71 //y=2.77 \
 //x2=4.56 //y2=5.25
cc_673 ( N_CLK_c_697_n N_noxref_4_c_1019_n ) capacitor c=9.02672e-19 //x=2.71 \
 //y=4.88 //x2=4.56 //y2=5.25
cc_674 ( N_CLK_c_700_n N_noxref_4_c_1019_n ) capacitor c=0.0299085f //x=10.1 \
 //y=4.62 //x2=4.56 //y2=5.25
cc_675 ( CLK N_noxref_4_c_1104_n ) capacitor c=0.00278331f //x=13.81 //y=2.77 \
 //x2=16.4 //y2=3.725
cc_676 ( N_CLK_c_700_n N_noxref_4_c_1105_n ) capacitor c=0.0381516f //x=10.1 \
 //y=4.62 //x2=2.9 //y2=5.335
cc_677 ( N_CLK_c_712_n N_noxref_4_c_1105_n ) capacitor c=0.00132214f //x=2.71 \
 //y=4.88 //x2=2.9 //y2=5.335
cc_678 ( N_CLK_M15_noxref_g N_noxref_4_c_1105_n ) capacitor c=0.00229818f \
 //x=2.68 //y=6.2 //x2=2.9 //y2=5.335
cc_679 ( N_CLK_M16_noxref_g N_noxref_4_c_1105_n ) capacitor c=0.00230699f \
 //x=3.12 //y=6.2 //x2=2.9 //y2=5.335
cc_680 ( N_CLK_c_725_n N_noxref_4_c_1105_n ) capacitor c=0.0016987f //x=3.045 \
 //y=4.97 //x2=2.9 //y2=5.335
cc_681 ( N_CLK_c_700_n N_noxref_4_c_1038_n ) capacitor c=0.00354963f //x=10.1 \
 //y=4.62 //x2=6.41 //y2=4.88
cc_682 ( N_CLK_c_700_n N_noxref_4_c_1040_n ) capacitor c=0.0265157f //x=10.1 \
 //y=4.62 //x2=6.412 //y2=4.74
cc_683 ( CLK N_noxref_4_c_1112_n ) capacitor c=0.0011503f //x=13.81 //y=2.77 \
 //x2=16.402 //y2=4.74
cc_684 ( N_CLK_c_700_n N_noxref_4_c_1042_n ) capacitor c=0.00797964f //x=10.1 \
 //y=4.62 //x2=6.245 //y2=3.88
cc_685 ( N_CLK_c_700_n N_noxref_4_c_1046_n ) capacitor c=0.00651104f //x=10.1 \
 //y=4.62 //x2=8.1 //y2=3.895
cc_686 ( N_CLK_c_700_n N_noxref_4_c_1049_n ) capacitor c=0.00977423f //x=10.1 \
 //y=4.62 //x2=7.755 //y2=3.895
cc_687 ( N_CLK_c_700_n N_noxref_4_c_1053_n ) capacitor c=0.0036569f //x=10.1 \
 //y=4.62 //x2=9.35 //y2=3.88
cc_688 ( N_CLK_c_700_n N_noxref_4_c_1057_n ) capacitor c=0.00297965f //x=10.1 \
 //y=4.62 //x2=9.95 //y2=3.89
cc_689 ( N_CLK_c_745_n N_noxref_4_c_1079_n ) capacitor c=0.00625039f //x=10.7 \
 //y=4.64 //x2=10.7 //y2=3.87
cc_690 ( N_CLK_c_745_n N_noxref_4_c_1084_n ) capacitor c=0.00646181f //x=10.7 \
 //y=4.64 //x2=11.44 //y2=3.895
cc_691 ( N_CLK_c_745_n N_noxref_4_c_1087_n ) capacitor c=0.00367719f //x=10.7 \
 //y=4.64 //x2=12.68 //y2=3.88
cc_692 ( CLK N_noxref_4_c_1091_n ) capacitor c=0.0264298f //x=13.81 //y=2.77 \
 //x2=13.28 //y2=3.895
cc_693 ( N_CLK_c_740_n N_noxref_4_c_1091_n ) capacitor c=0.00196738f //x=13.81 \
 //y=2.26 //x2=13.28 //y2=3.895
cc_694 ( N_CLK_c_745_n N_noxref_4_c_1091_n ) capacitor c=0.00287528f //x=10.7 \
 //y=4.64 //x2=13.28 //y2=3.895
cc_695 ( N_CLK_c_697_n N_noxref_4_c_1124_n ) capacitor c=0.00156871f //x=2.71 \
 //y=4.88 //x2=2.9 //y2=5.56
cc_696 ( N_CLK_M15_noxref_g N_noxref_4_c_1124_n ) capacitor c=0.0179041f \
 //x=2.68 //y=6.2 //x2=2.9 //y2=5.56
cc_697 ( N_CLK_M16_noxref_g N_noxref_4_c_1124_n ) capacitor c=0.0179041f \
 //x=3.12 //y=6.2 //x2=2.9 //y2=5.56
cc_698 ( N_CLK_c_725_n N_noxref_4_c_1124_n ) capacitor c=0.00294585f //x=3.045 \
 //y=4.97 //x2=2.9 //y2=5.56
cc_699 ( N_CLK_c_694_n N_noxref_6_c_1857_n ) capacitor c=0.0115546f //x=2.71 \
 //y=2.375 //x2=1.6 //y2=2.375
cc_700 ( N_CLK_c_708_n N_noxref_6_c_1857_n ) capacitor c=0.00375644f //x=2.71 \
 //y=2.26 //x2=1.6 //y2=2.375
cc_701 ( N_CLK_c_721_n N_noxref_6_c_1857_n ) capacitor c=0.00140534f //x=2.8 \
 //y=2.095 //x2=1.6 //y2=2.375
cc_702 ( CLK N_noxref_6_c_1723_n ) capacitor c=0.0542809f //x=2.71 //y=2.77 \
 //x2=1.6 //y2=4.095
cc_703 ( N_CLK_c_708_n N_noxref_6_c_1723_n ) capacitor c=4.16726e-19 //x=2.71 \
 //y=2.26 //x2=1.6 //y2=4.095
cc_704 ( CLK N_noxref_6_c_1862_n ) capacitor c=0.00797621f //x=2.71 //y=2.77 \
 //x2=1.6 //y2=4.415
cc_705 ( CLK N_noxref_6_c_1725_n ) capacitor c=0.00733288f //x=2.71 //y=2.77 \
 //x2=1.6 //y2=4.755
cc_706 ( N_CLK_c_697_n N_noxref_6_c_1725_n ) capacitor c=0.00759719f //x=2.71 \
 //y=4.88 //x2=1.6 //y2=4.755
cc_707 ( N_CLK_c_707_n N_noxref_6_c_1725_n ) capacitor c=0.00978415f //x=2.71 \
 //y=4.62 //x2=1.6 //y2=4.755
cc_708 ( N_CLK_c_712_n N_noxref_6_c_1725_n ) capacitor c=0.00402107f //x=2.71 \
 //y=4.88 //x2=1.6 //y2=4.755
cc_709 ( N_CLK_c_726_n N_noxref_6_c_1725_n ) capacitor c=0.0011347f //x=2.71 \
 //y=4.88 //x2=1.6 //y2=4.755
cc_710 ( N_CLK_c_700_n N_noxref_6_c_1734_n ) capacitor c=0.00260076f //x=10.1 \
 //y=4.62 //x2=10.48 //y2=4.415
cc_711 ( N_CLK_c_745_n N_noxref_6_c_1734_n ) capacitor c=0.00232598f //x=10.7 \
 //y=4.64 //x2=10.48 //y2=4.415
cc_712 ( N_CLK_c_700_n N_noxref_6_c_1735_n ) capacitor c=4.19842e-19 //x=10.1 \
 //y=4.62 //x2=10.48 //y2=4.735
cc_713 ( N_CLK_c_745_n N_noxref_6_c_1735_n ) capacitor c=0.0260326f //x=10.7 \
 //y=4.64 //x2=10.48 //y2=4.735
cc_714 ( N_CLK_c_736_n N_noxref_6_c_1793_n ) capacitor c=0.0247435f //x=13.835 \
 //y=4.865 //x2=13.955 //y2=5.38
cc_715 ( N_CLK_c_745_n N_noxref_6_c_1793_n ) capacitor c=0.00963579f //x=10.7 \
 //y=4.64 //x2=13.955 //y2=5.38
cc_716 ( N_CLK_c_753_n N_noxref_6_c_1793_n ) capacitor c=0.00469232f //x=13.84 \
 //y=4.88 //x2=13.955 //y2=5.38
cc_717 ( N_CLK_M29_noxref_g N_noxref_6_c_1793_n ) capacitor c=0.00842814f \
 //x=13.85 //y=6.2 //x2=13.955 //y2=5.38
cc_718 ( N_CLK_c_772_n N_noxref_6_c_1793_n ) capacitor c=7.7763e-19 //x=13.84 \
 //y=4.88 //x2=13.955 //y2=5.38
cc_719 ( N_CLK_c_762_n N_noxref_6_c_1794_n ) capacitor c=0.00119008f \
 //x=13.845 //y=1.43 //x2=14.11 //y2=1.75
cc_720 ( N_CLK_c_764_n N_noxref_6_c_1794_n ) capacitor c=0.00438634f \
 //x=13.845 //y=1.74 //x2=14.11 //y2=1.75
cc_721 ( N_CLK_c_831_p N_noxref_6_c_1794_n ) capacitor c=0.00916852f //x=14.22 \
 //y=1.585 //x2=14.11 //y2=1.75
cc_722 ( N_CLK_c_768_n N_noxref_6_c_1794_n ) capacitor c=0.003249f //x=14.375 \
 //y=1.43 //x2=14.11 //y2=1.75
cc_723 ( N_CLK_c_833_p N_noxref_6_c_1794_n ) capacitor c=0.00341114f //x=13.81 \
 //y=2.095 //x2=14.11 //y2=1.75
cc_724 ( N_CLK_M30_noxref_g N_noxref_6_c_1882_n ) capacitor c=0.0108037f \
 //x=14.29 //y=6.2 //x2=14.465 //y2=5.38
cc_725 ( N_CLK_c_831_p N_noxref_6_c_1883_n ) capacitor c=0.00194324f //x=14.22 \
 //y=1.585 //x2=14.465 //y2=1.835
cc_726 ( N_CLK_c_768_n N_noxref_6_c_1883_n ) capacitor c=0.00323005f \
 //x=14.375 //y=1.43 //x2=14.465 //y2=1.835
cc_727 ( CLK N_noxref_6_c_1796_n ) capacitor c=0.0741032f //x=13.81 //y=2.77 \
 //x2=14.55 //y2=4.105
cc_728 ( N_CLK_c_740_n N_noxref_6_c_1796_n ) capacitor c=0.015397f //x=13.81 \
 //y=2.26 //x2=14.55 //y2=4.105
cc_729 ( N_CLK_c_749_n N_noxref_6_c_1796_n ) capacitor c=9.90728e-19 //x=13.81 \
 //y=2.26 //x2=14.55 //y2=4.105
cc_730 ( N_CLK_c_769_n N_noxref_6_c_1796_n ) capacitor c=0.00281392f //x=13.81 \
 //y=2.26 //x2=14.55 //y2=4.105
cc_731 ( N_CLK_c_833_p N_noxref_6_c_1796_n ) capacitor c=0.00309058f //x=13.81 \
 //y=2.095 //x2=14.55 //y2=4.105
cc_732 ( CLK N_noxref_6_c_1890_n ) capacitor c=0.01773f //x=13.81 //y=2.77 \
 //x2=14.55 //y2=4.425
cc_733 ( N_CLK_c_843_p N_noxref_6_c_1890_n ) capacitor c=9.17945e-19 \
 //x=14.215 //y=4.97 //x2=14.55 //y2=4.425
cc_734 ( CLK N_noxref_6_c_1799_n ) capacitor c=0.0103877f //x=13.81 //y=2.77 \
 //x2=14.55 //y2=5.295
cc_735 ( N_CLK_c_736_n N_noxref_6_c_1799_n ) capacitor c=0.0154991f //x=13.835 \
 //y=4.865 //x2=14.55 //y2=5.295
cc_736 ( N_CLK_c_745_n N_noxref_6_c_1799_n ) capacitor c=0.0121733f //x=10.7 \
 //y=4.64 //x2=14.55 //y2=5.295
cc_737 ( N_CLK_c_753_n N_noxref_6_c_1799_n ) capacitor c=5.14671e-19 //x=13.84 \
 //y=4.88 //x2=14.55 //y2=5.295
cc_738 ( N_CLK_c_843_p N_noxref_6_c_1799_n ) capacitor c=0.00841383f \
 //x=14.215 //y=4.97 //x2=14.55 //y2=5.295
cc_739 ( CLK N_noxref_6_c_1897_n ) capacitor c=3.43503e-19 //x=2.71 //y=2.77 \
 //x2=1.6 //y2=4.25
cc_740 ( N_CLK_c_745_n N_noxref_6_c_1803_n ) capacitor c=0.0207179f //x=10.7 \
 //y=4.64 //x2=13.19 //y2=5.56
cc_741 ( N_CLK_M29_noxref_g N_noxref_6_c_1899_n ) capacitor c=0.00192712f \
 //x=13.85 //y=6.2 //x2=14.07 //y2=5.38
cc_742 ( N_CLK_M30_noxref_g N_noxref_6_c_1899_n ) capacitor c=0.00298276f \
 //x=14.29 //y=6.2 //x2=14.07 //y2=5.38
cc_743 ( N_CLK_c_843_p N_noxref_6_c_1899_n ) capacitor c=0.0020909f //x=14.215 \
 //y=4.97 //x2=14.07 //y2=5.38
cc_744 ( N_CLK_c_759_n N_noxref_6_c_1812_n ) capacitor c=0.00120406f \
 //x=13.845 //y=1.085 //x2=14.11 //y2=1.18
cc_745 ( N_CLK_c_762_n N_noxref_6_c_1812_n ) capacitor c=0.00218694f \
 //x=13.845 //y=1.43 //x2=14.11 //y2=1.18
cc_746 ( N_CLK_c_856_p N_noxref_6_c_1812_n ) capacitor c=5.50523e-19 //x=14.22 \
 //y=0.93 //x2=14.11 //y2=1.18
cc_747 ( N_CLK_c_831_p N_noxref_6_c_1812_n ) capacitor c=5.67071e-19 //x=14.22 \
 //y=1.585 //x2=14.11 //y2=1.18
cc_748 ( N_CLK_c_767_n N_noxref_6_c_1812_n ) capacitor c=0.00109205f \
 //x=14.375 //y=1.085 //x2=14.11 //y2=1.18
cc_749 ( N_CLK_c_768_n N_noxref_6_c_1812_n ) capacitor c=0.00317092f \
 //x=14.375 //y=1.43 //x2=14.11 //y2=1.18
cc_750 ( CLK N_noxref_6_c_1908_n ) capacitor c=9.19401e-19 //x=13.81 //y=2.77 \
 //x2=14.55 //y2=4.25
cc_751 ( CLK N_noxref_6_c_1744_n ) capacitor c=0.0290324f //x=2.71 //y=2.77 \
 //x2=4.175 //y2=4.25
cc_752 ( N_CLK_c_694_n N_noxref_6_c_1744_n ) capacitor c=0.0015676f //x=2.71 \
 //y=2.375 //x2=4.175 //y2=4.25
cc_753 ( N_CLK_c_697_n N_noxref_6_c_1744_n ) capacitor c=0.00370332f //x=2.71 \
 //y=4.88 //x2=4.175 //y2=4.25
cc_754 ( N_CLK_c_700_n N_noxref_6_c_1744_n ) capacitor c=0.0597544f //x=10.1 \
 //y=4.62 //x2=4.175 //y2=4.25
cc_755 ( N_CLK_c_707_n N_noxref_6_c_1744_n ) capacitor c=0.15521f //x=2.71 \
 //y=4.62 //x2=4.175 //y2=4.25
cc_756 ( N_CLK_c_700_n N_noxref_6_c_1748_n ) capacitor c=0.11637f //x=10.1 \
 //y=4.62 //x2=4.775 //y2=4.265
cc_757 ( N_CLK_c_700_n N_noxref_6_c_1749_n ) capacitor c=0.059022f //x=10.1 \
 //y=4.62 //x2=6.02 //y2=4.25
cc_758 ( CLK N_noxref_6_c_1813_n ) capacitor c=0.0195347f //x=13.81 //y=2.77 \
 //x2=14.38 //y2=4.25
cc_759 ( N_CLK_c_736_n N_noxref_6_c_1813_n ) capacitor c=0.00171763f \
 //x=13.835 //y=4.865 //x2=14.38 //y2=4.25
cc_760 ( N_CLK_c_745_n N_noxref_6_c_1813_n ) capacitor c=0.305221f //x=10.7 \
 //y=4.64 //x2=14.38 //y2=4.25
cc_761 ( N_CLK_c_700_n N_noxref_6_c_1751_n ) capacitor c=0.364548f //x=10.1 \
 //y=4.62 //x2=10.645 //y2=4.25
cc_762 ( CLK N_noxref_6_c_1920_n ) capacitor c=0.00330634f //x=13.81 //y=2.77 \
 //x2=16.27 //y2=4.27
cc_763 ( CLK N_noxref_6_c_1921_n ) capacitor c=0.00243311f //x=2.71 //y=2.77 \
 //x2=1.765 //y2=4.255
cc_764 ( CLK N_noxref_6_c_1922_n ) capacitor c=4.16726e-19 //x=2.71 //y=2.77 \
 //x2=1.6 //y2=2.26
cc_765 ( N_CLK_c_694_n N_noxref_6_c_1922_n ) capacitor c=5.40058e-19 //x=2.71 \
 //y=2.375 //x2=1.6 //y2=2.26
cc_766 ( N_CLK_c_708_n N_noxref_6_c_1922_n ) capacitor c=0.00125213f //x=2.71 \
 //y=2.26 //x2=1.6 //y2=2.26
cc_767 ( N_CLK_c_721_n N_noxref_6_c_1922_n ) capacitor c=0.0020754f //x=2.8 \
 //y=2.095 //x2=1.6 //y2=2.26
cc_768 ( N_CLK_c_697_n N_noxref_6_c_1926_n ) capacitor c=5.84784e-19 //x=2.71 \
 //y=4.88 //x2=1.6 //y2=4.88
cc_769 ( N_CLK_c_712_n N_noxref_6_c_1926_n ) capacitor c=0.00114249f //x=2.71 \
 //y=4.88 //x2=1.6 //y2=4.88
cc_770 ( N_CLK_c_726_n N_noxref_6_c_1926_n ) capacitor c=0.00124807f //x=2.71 \
 //y=4.88 //x2=1.6 //y2=4.88
cc_771 ( N_CLK_c_736_n N_noxref_6_c_1929_n ) capacitor c=8.41381e-19 \
 //x=13.835 //y=4.865 //x2=14.07 //y2=5.56
cc_772 ( N_CLK_M29_noxref_g N_noxref_6_c_1929_n ) capacitor c=0.0178987f \
 //x=13.85 //y=6.2 //x2=14.07 //y2=5.56
cc_773 ( N_CLK_M30_noxref_g N_noxref_6_c_1929_n ) capacitor c=0.0178506f \
 //x=14.29 //y=6.2 //x2=14.07 //y2=5.56
cc_774 ( N_CLK_c_843_p N_noxref_6_c_1929_n ) capacitor c=0.00291714f \
 //x=14.215 //y=4.97 //x2=14.07 //y2=5.56
cc_775 ( N_CLK_M15_noxref_g N_noxref_6_M13_noxref_g ) capacitor c=0.0106276f \
 //x=2.68 //y=6.2 //x2=1.8 //y2=6.2
cc_776 ( N_CLK_M15_noxref_g N_noxref_6_M14_noxref_g ) capacitor c=0.107144f \
 //x=2.68 //y=6.2 //x2=2.24 //y2=6.2
cc_777 ( N_CLK_M16_noxref_g N_noxref_6_M14_noxref_g ) capacitor c=0.0101598f \
 //x=3.12 //y=6.2 //x2=2.24 //y2=6.2
cc_778 ( N_CLK_c_888_p N_noxref_6_c_1936_n ) capacitor c=5.72528e-19 //x=2.275 \
 //y=1.09 //x2=1.3 //y2=1.055
cc_779 ( N_CLK_c_888_p N_noxref_6_c_1937_n ) capacitor c=0.00150277f //x=2.275 \
 //y=1.09 //x2=1.3 //y2=1.4
cc_780 ( N_CLK_c_890_p N_noxref_6_c_1938_n ) capacitor c=0.00111227f //x=2.275 \
 //y=1.4 //x2=1.3 //y2=1.71
cc_781 ( N_CLK_c_694_n N_noxref_6_c_1939_n ) capacitor c=0.00147006f //x=2.71 \
 //y=2.375 //x2=1.3 //y2=2.095
cc_782 ( N_CLK_c_708_n N_noxref_6_c_1939_n ) capacitor c=0.00214573f //x=2.71 \
 //y=2.26 //x2=1.3 //y2=2.095
cc_783 ( N_CLK_c_721_n N_noxref_6_c_1939_n ) capacitor c=0.00964411f //x=2.8 \
 //y=2.095 //x2=1.3 //y2=2.095
cc_784 ( N_CLK_c_888_p N_noxref_6_c_1942_n ) capacitor c=0.0160123f //x=2.275 \
 //y=1.09 //x2=1.83 //y2=1.055
cc_785 ( N_CLK_c_718_n N_noxref_6_c_1942_n ) capacitor c=9.19165e-19 //x=2.8 \
 //y=1.09 //x2=1.83 //y2=1.055
cc_786 ( N_CLK_c_890_p N_noxref_6_c_1944_n ) capacitor c=0.0124075f //x=2.275 \
 //y=1.4 //x2=1.83 //y2=1.4
cc_787 ( N_CLK_c_719_n N_noxref_6_c_1944_n ) capacitor c=0.0010154f //x=2.8 \
 //y=1.4 //x2=1.83 //y2=1.4
cc_788 ( N_CLK_c_720_n N_noxref_6_c_1944_n ) capacitor c=9.23422e-19 //x=2.8 \
 //y=1.63 //x2=1.83 //y2=1.4
cc_789 ( N_CLK_c_697_n N_noxref_6_c_1947_n ) capacitor c=0.00112623f //x=2.71 \
 //y=4.88 //x2=2.165 //y2=4.97
cc_790 ( N_CLK_c_712_n N_noxref_6_c_1947_n ) capacitor c=0.00133699f //x=2.71 \
 //y=4.88 //x2=2.165 //y2=4.97
cc_791 ( N_CLK_c_726_n N_noxref_6_c_1947_n ) capacitor c=0.0163966f //x=2.71 \
 //y=4.88 //x2=2.165 //y2=4.97
cc_792 ( N_CLK_c_697_n N_noxref_6_c_1950_n ) capacitor c=8.39124e-19 //x=2.71 \
 //y=4.88 //x2=1.875 //y2=4.97
cc_793 ( N_CLK_c_712_n N_noxref_6_c_1950_n ) capacitor c=0.00129812f //x=2.71 \
 //y=4.88 //x2=1.875 //y2=4.97
cc_794 ( N_CLK_c_726_n N_noxref_6_c_1950_n ) capacitor c=0.00409733f //x=2.71 \
 //y=4.88 //x2=1.875 //y2=4.97
cc_795 ( N_CLK_c_759_n N_noxref_6_M8_noxref_d ) capacitor c=0.00137165f \
 //x=13.845 //y=1.085 //x2=13.92 //y2=1.085
cc_796 ( N_CLK_c_762_n N_noxref_6_M8_noxref_d ) capacitor c=0.00237422f \
 //x=13.845 //y=1.43 //x2=13.92 //y2=1.085
cc_797 ( N_CLK_c_856_p N_noxref_6_M8_noxref_d ) capacitor c=0.0020782f \
 //x=14.22 //y=0.93 //x2=13.92 //y2=1.085
cc_798 ( N_CLK_c_831_p N_noxref_6_M8_noxref_d ) capacitor c=0.00356097f \
 //x=14.22 //y=1.585 //x2=13.92 //y2=1.085
cc_799 ( N_CLK_c_767_n N_noxref_6_M8_noxref_d ) capacitor c=8.50095e-19 \
 //x=14.375 //y=1.085 //x2=13.92 //y2=1.085
cc_800 ( N_CLK_c_768_n N_noxref_6_M8_noxref_d ) capacitor c=0.00237422f \
 //x=14.375 //y=1.43 //x2=13.92 //y2=1.085
cc_801 ( N_CLK_c_712_n N_VDD_c_2693_n ) capacitor c=4.52718e-19 //x=2.71 \
 //y=4.88 //x2=1.23 //y2=7.58
cc_802 ( N_CLK_M15_noxref_g N_VDD_c_2694_n ) capacitor c=0.00704788f //x=2.68 \
 //y=6.2 //x2=3.255 //y2=7.585
cc_803 ( N_CLK_M16_noxref_g N_VDD_c_2694_n ) capacitor c=0.00755544f //x=3.12 \
 //y=6.2 //x2=3.255 //y2=7.585
cc_804 ( N_CLK_M29_noxref_g N_VDD_c_2696_n ) capacitor c=0.00697352f //x=13.85 \
 //y=6.2 //x2=14.425 //y2=7.585
cc_805 ( N_CLK_M30_noxref_g N_VDD_c_2696_n ) capacitor c=0.00755544f //x=14.29 \
 //y=6.2 //x2=14.425 //y2=7.585
cc_806 ( N_CLK_c_700_n N_VDD_c_2609_n ) capacitor c=0.0263067f //x=10.1 \
 //y=4.62 //x2=5.3 //y2=7.585
cc_807 ( N_CLK_c_712_n N_VDD_c_2609_n ) capacitor c=3.15216e-19 //x=2.71 \
 //y=4.88 //x2=5.3 //y2=7.585
cc_808 ( N_CLK_c_700_n N_VDD_c_2614_n ) capacitor c=0.0264152f //x=10.1 \
 //y=4.62 //x2=8.63 //y2=7.585
cc_809 ( N_CLK_c_745_n N_VDD_c_2667_n ) capacitor c=0.0262144f //x=10.7 \
 //y=4.64 //x2=11.96 //y2=7.585
cc_810 ( N_CLK_c_753_n N_VDD_c_2702_n ) capacitor c=0.00228191f //x=13.84 \
 //y=4.88 //x2=15.29 //y2=7.585
cc_811 ( N_CLK_c_843_p N_VDD_c_2702_n ) capacitor c=0.0129149f //x=14.215 \
 //y=4.97 //x2=15.29 //y2=7.585
cc_812 ( N_CLK_c_772_n N_VDD_c_2702_n ) capacitor c=2.73429e-19 //x=13.84 \
 //y=4.88 //x2=15.29 //y2=7.585
cc_813 ( N_CLK_M15_noxref_g N_VDD_M14_noxref_d ) capacitor c=0.015318f \
 //x=2.68 //y=6.2 //x2=2.315 //y2=5.2
cc_814 ( N_CLK_M16_noxref_g N_VDD_M16_noxref_d ) capacitor c=0.015318f \
 //x=3.12 //y=6.2 //x2=3.195 //y2=5.2
cc_815 ( N_CLK_c_700_n N_VDD_M19_noxref_s ) capacitor c=0.00752361f //x=10.1 \
 //y=4.62 //x2=5.955 //y2=5.2
cc_816 ( N_CLK_c_700_n N_VDD_M23_noxref_s ) capacitor c=0.00765173f //x=10.1 \
 //y=4.62 //x2=9.285 //y2=5.2
cc_817 ( N_CLK_c_745_n N_VDD_M27_noxref_s ) capacitor c=0.00765173f //x=10.7 \
 //y=4.64 //x2=12.615 //y2=5.2
cc_818 ( N_CLK_M29_noxref_g N_VDD_M28_noxref_d ) capacitor c=0.015318f \
 //x=13.85 //y=6.2 //x2=13.485 //y2=5.2
cc_819 ( N_CLK_c_772_n N_VDD_M28_noxref_d ) capacitor c=3.50465e-19 //x=13.84 \
 //y=4.88 //x2=13.485 //y2=5.2
cc_820 ( N_CLK_M30_noxref_g N_VDD_M30_noxref_d ) capacitor c=0.0430452f \
 //x=14.29 //y=6.2 //x2=14.365 //y2=5.2
cc_821 ( N_CLK_c_718_n N_noxref_9_c_2981_n ) capacitor c=0.00123426f //x=2.8 \
 //y=1.09 //x2=3.505 //y2=1.175
cc_822 ( N_CLK_c_719_n N_noxref_9_c_2981_n ) capacitor c=0.0129288f //x=2.8 \
 //y=1.4 //x2=3.505 //y2=1.175
cc_823 ( N_CLK_c_720_n N_noxref_9_c_2981_n ) capacitor c=0.00132209f //x=2.8 \
 //y=1.63 //x2=3.505 //y2=1.175
cc_824 ( N_CLK_c_694_n N_noxref_9_M1_noxref_d ) capacitor c=0.00610765f \
 //x=2.71 //y=2.375 //x2=2.35 //y2=1.09
cc_825 ( N_CLK_c_708_n N_noxref_9_M1_noxref_d ) capacitor c=2.2052e-19 \
 //x=2.71 //y=2.26 //x2=2.35 //y2=1.09
cc_826 ( N_CLK_c_888_p N_noxref_9_M1_noxref_d ) capacitor c=0.00253592f \
 //x=2.275 //y=1.09 //x2=2.35 //y2=1.09
cc_827 ( N_CLK_c_890_p N_noxref_9_M1_noxref_d ) capacitor c=0.00604634f \
 //x=2.275 //y=1.4 //x2=2.35 //y2=1.09
cc_828 ( N_CLK_c_938_p N_noxref_9_M1_noxref_d ) capacitor c=0.002686f \
 //x=2.645 //y=0.935 //x2=2.35 //y2=1.09
cc_829 ( N_CLK_c_939_p N_noxref_9_M1_noxref_d ) capacitor c=0.00251995f \
 //x=2.645 //y=1.555 //x2=2.35 //y2=1.09
cc_830 ( N_CLK_c_718_n N_noxref_9_M1_noxref_d ) capacitor c=0.00314523f \
 //x=2.8 //y=1.09 //x2=2.35 //y2=1.09
cc_831 ( N_CLK_c_719_n N_noxref_9_M1_noxref_d ) capacitor c=0.00168289f \
 //x=2.8 //y=1.4 //x2=2.35 //y2=1.09
cc_832 ( N_CLK_c_720_n N_noxref_9_M1_noxref_d ) capacitor c=0.00111165f \
 //x=2.8 //y=1.63 //x2=2.35 //y2=1.09
cc_833 ( N_CLK_c_718_n N_noxref_9_M2_noxref_s ) capacitor c=7.21316e-19 \
 //x=2.8 //y=1.09 //x2=3.455 //y2=0.555
cc_834 ( N_CLK_c_719_n N_noxref_9_M2_noxref_s ) capacitor c=0.00365271f \
 //x=2.8 //y=1.4 //x2=3.455 //y2=0.555
cc_835 ( N_CLK_c_721_n N_noxref_9_M2_noxref_s ) capacitor c=9.86711e-19 \
 //x=2.8 //y=2.095 //x2=3.455 //y2=0.555
cc_836 ( N_CLK_c_700_n D ) capacitor c=0.023243f //x=10.1 //y=4.62 //x2=7.15 \
 //y2=2.77
cc_837 ( N_CLK_c_700_n N_D_c_3042_n ) capacitor c=0.0042873f //x=10.1 //y=4.62 \
 //x2=7.15 //y2=4.735
cc_838 ( N_CLK_c_694_n N_GND_c_3150_n ) capacitor c=9.16623e-19 //x=2.71 \
 //y=2.375 //x2=6.395 //y2=0.175
cc_839 ( N_CLK_c_740_n N_GND_c_3237_n ) capacitor c=0.00234561f //x=13.81 \
 //y=2.26 //x2=16.385 //y2=0.175
cc_840 ( N_CLK_c_740_n N_GND_c_3217_n ) capacitor c=3.77328e-19 //x=13.81 \
 //y=2.26 //x2=15.12 //y2=0.175
cc_841 ( N_CLK_c_749_n N_GND_c_3239_n ) capacitor c=0.00224736f //x=13.81 \
 //y=2.26 //x2=15.29 //y2=0.175
cc_842 ( N_CLK_c_768_n N_GND_c_3239_n ) capacitor c=0.00275184f //x=14.375 \
 //y=1.43 //x2=15.29 //y2=0.175
cc_843 ( N_CLK_c_769_n N_GND_c_3239_n ) capacitor c=2.63786e-19 //x=13.81 \
 //y=2.26 //x2=15.29 //y2=0.175
cc_844 ( N_CLK_c_888_p N_noxref_12_c_3574_n ) capacitor c=0.0167228f //x=2.275 \
 //y=1.09 //x2=2.935 //y2=0.72
cc_845 ( N_CLK_c_718_n N_noxref_12_c_3574_n ) capacitor c=0.00534519f //x=2.8 \
 //y=1.09 //x2=2.935 //y2=0.72
cc_846 ( N_CLK_c_694_n N_noxref_12_c_3576_n ) capacitor c=0.0048147f //x=2.71 \
 //y=2.375 //x2=2.935 //y2=1.77
cc_847 ( N_CLK_c_697_n N_noxref_12_c_3576_n ) capacitor c=9.34338e-19 //x=2.71 \
 //y=4.88 //x2=2.935 //y2=1.77
cc_848 ( N_CLK_c_708_n N_noxref_12_c_3576_n ) capacitor c=0.0105652f //x=2.71 \
 //y=2.26 //x2=2.935 //y2=1.77
cc_849 ( N_CLK_c_890_p N_noxref_12_c_3576_n ) capacitor c=0.0153476f //x=2.275 \
 //y=1.4 //x2=2.935 //y2=1.77
cc_850 ( N_CLK_c_721_n N_noxref_12_c_3576_n ) capacitor c=0.0205552f //x=2.8 \
 //y=2.095 //x2=2.935 //y2=1.77
cc_851 ( N_CLK_c_888_p N_noxref_12_M0_noxref_s ) capacitor c=0.00798959f \
 //x=2.275 //y=1.09 //x2=0.945 //y2=0.555
cc_852 ( N_CLK_c_720_n N_noxref_12_M0_noxref_s ) capacitor c=0.00212176f \
 //x=2.8 //y=1.63 //x2=0.945 //y2=0.555
cc_853 ( N_CLK_c_721_n N_noxref_12_M0_noxref_s ) capacitor c=0.00298115f \
 //x=2.8 //y=2.095 //x2=0.945 //y2=0.555
cc_854 ( N_CLK_c_740_n N_noxref_15_c_3770_n ) capacitor c=7.50092e-19 \
 //x=13.81 //y=2.26 //x2=13.625 //y2=1.675
cc_855 ( N_CLK_c_764_n N_noxref_15_c_3770_n ) capacitor c=0.00888238f \
 //x=13.845 //y=1.74 //x2=13.625 //y2=1.675
cc_856 ( N_CLK_c_769_n N_noxref_15_c_3770_n ) capacitor c=0.00175171f \
 //x=13.81 //y=2.26 //x2=13.625 //y2=1.675
cc_857 ( N_CLK_c_740_n N_noxref_15_c_3777_n ) capacitor c=0.00141156f \
 //x=13.81 //y=2.26 //x2=14.51 //y2=0.71
cc_858 ( N_CLK_c_749_n N_noxref_15_c_3777_n ) capacitor c=8.82141e-19 \
 //x=13.81 //y=2.26 //x2=14.51 //y2=0.71
cc_859 ( N_CLK_c_759_n N_noxref_15_c_3777_n ) capacitor c=0.0199501f \
 //x=13.845 //y=1.085 //x2=14.51 //y2=0.71
cc_860 ( N_CLK_c_767_n N_noxref_15_c_3777_n ) capacitor c=0.00825432f \
 //x=14.375 //y=1.085 //x2=14.51 //y2=0.71
cc_861 ( N_CLK_c_769_n N_noxref_15_c_3777_n ) capacitor c=2.1838e-19 //x=13.81 \
 //y=2.26 //x2=14.51 //y2=0.71
cc_862 ( N_CLK_c_759_n N_noxref_15_M7_noxref_s ) capacitor c=0.00888238f \
 //x=13.845 //y=1.085 //x2=12.52 //y2=0.545
cc_863 ( N_CLK_c_767_n N_noxref_15_M7_noxref_s ) capacitor c=0.015333f \
 //x=14.375 //y=1.085 //x2=12.52 //y2=0.545
cc_864 ( N_CLK_c_768_n N_noxref_15_M7_noxref_s ) capacitor c=0.00248746f \
 //x=14.375 //y=1.43 //x2=12.52 //y2=0.545
cc_865 ( N_noxref_4_c_1104_n QN ) capacitor c=0.00324628f //x=16.4 //y=3.725 \
 //x2=17.88 //y2=2.4
cc_866 ( N_noxref_4_c_1112_n QN ) capacitor c=0.0023234f //x=16.402 //y=4.74 \
 //x2=17.88 //y2=4.62
cc_867 ( N_noxref_4_M32_noxref_g N_QN_c_1452_n ) capacitor c=0.00966488f \
 //x=16.74 //y=6.2 //x2=17.285 //y2=5.38
cc_868 ( N_noxref_4_c_1131_p N_QN_c_1453_n ) capacitor c=8.193e-19 //x=16.4 \
 //y=4.045 //x2=16.52 //y2=5.56
cc_869 ( N_noxref_4_c_1132_p N_QN_c_1453_n ) capacitor c=0.0118007f //x=16.4 \
 //y=4.88 //x2=16.52 //y2=5.56
cc_870 ( N_noxref_4_c_1133_p N_QN_c_1453_n ) capacitor c=0.00277154f //x=16.4 \
 //y=4.88 //x2=16.52 //y2=5.56
cc_871 ( N_noxref_4_M31_noxref_g N_QN_c_1453_n ) capacitor c=0.00201806f \
 //x=16.3 //y=6.2 //x2=16.52 //y2=5.56
cc_872 ( N_noxref_4_M32_noxref_g N_QN_c_1453_n ) capacitor c=0.00192712f \
 //x=16.74 //y=6.2 //x2=16.52 //y2=5.56
cc_873 ( N_noxref_4_c_1136_p N_QN_c_1453_n ) capacitor c=0.00187457f //x=16.4 \
 //y=4.88 //x2=16.52 //y2=5.56
cc_874 ( N_noxref_4_c_1131_p N_QN_c_1459_n ) capacitor c=2.39213e-19 //x=16.4 \
 //y=4.045 //x2=16.52 //y2=5.56
cc_875 ( N_noxref_4_c_1132_p N_QN_c_1459_n ) capacitor c=0.00104426f //x=16.4 \
 //y=4.88 //x2=16.52 //y2=5.56
cc_876 ( N_noxref_4_c_1133_p N_QN_c_1459_n ) capacitor c=0.00377369f //x=16.4 \
 //y=4.88 //x2=16.52 //y2=5.56
cc_877 ( N_noxref_4_M31_noxref_g N_QN_c_1459_n ) capacitor c=0.0158358f \
 //x=16.3 //y=6.2 //x2=16.52 //y2=5.56
cc_878 ( N_noxref_4_M32_noxref_g N_QN_c_1459_n ) capacitor c=0.0178987f \
 //x=16.74 //y=6.2 //x2=16.52 //y2=5.56
cc_879 ( N_noxref_4_c_1136_p N_QN_c_1459_n ) capacitor c=0.0043218f //x=16.4 \
 //y=4.88 //x2=16.52 //y2=5.56
cc_880 ( N_noxref_4_c_1057_n N_noxref_6_c_1726_n ) capacitor c=4.05935e-19 \
 //x=9.95 //y=3.89 //x2=10.48 //y2=4.095
cc_881 ( N_noxref_4_c_1079_n N_noxref_6_c_1726_n ) capacitor c=0.0258164f \
 //x=10.7 //y=3.87 //x2=10.48 //y2=4.095
cc_882 ( N_noxref_4_c_1057_n N_noxref_6_c_1734_n ) capacitor c=0.00219434f \
 //x=9.95 //y=3.89 //x2=10.48 //y2=4.415
cc_883 ( N_noxref_4_c_1079_n N_noxref_6_c_1734_n ) capacitor c=0.00450788f \
 //x=10.7 //y=3.87 //x2=10.48 //y2=4.415
cc_884 ( N_noxref_4_c_1091_n N_noxref_6_c_1795_n ) capacitor c=0.00551458f \
 //x=13.28 //y=3.895 //x2=14.195 //y2=1.835
cc_885 ( N_noxref_4_c_1104_n N_noxref_6_c_1796_n ) capacitor c=0.0236604f \
 //x=16.4 //y=3.725 //x2=14.55 //y2=4.105
cc_886 ( N_noxref_4_c_1131_p N_noxref_6_c_1796_n ) capacitor c=0.00254581f \
 //x=16.4 //y=4.045 //x2=14.55 //y2=4.105
cc_887 ( N_noxref_4_c_1150_p N_noxref_6_c_1796_n ) capacitor c=0.00457386f \
 //x=16.4 //y=2.26 //x2=14.55 //y2=4.105
cc_888 ( N_noxref_4_c_1112_n N_noxref_6_c_1796_n ) capacitor c=0.00103966f \
 //x=16.402 //y=4.74 //x2=14.55 //y2=4.105
cc_889 ( N_noxref_4_c_1091_n N_noxref_6_c_1796_n ) capacitor c=0.0308123f \
 //x=13.28 //y=3.895 //x2=14.55 //y2=4.105
cc_890 ( N_noxref_4_c_1112_n N_noxref_6_c_1890_n ) capacitor c=0.00233357f \
 //x=16.402 //y=4.74 //x2=14.55 //y2=4.425
cc_891 ( N_noxref_4_c_1091_n N_noxref_6_c_1890_n ) capacitor c=0.00721489f \
 //x=13.28 //y=3.895 //x2=14.55 //y2=4.425
cc_892 ( N_noxref_4_c_1132_p N_noxref_6_c_1799_n ) capacitor c=0.00476843f \
 //x=16.4 //y=4.88 //x2=14.55 //y2=5.295
cc_893 ( N_noxref_4_c_1112_n N_noxref_6_c_1799_n ) capacitor c=0.00494123f \
 //x=16.402 //y=4.74 //x2=14.55 //y2=5.295
cc_894 ( N_noxref_4_c_1079_n N_noxref_6_c_1741_n ) capacitor c=0.00161291f \
 //x=10.7 //y=3.87 //x2=10.48 //y2=2.26
cc_895 ( N_noxref_4_c_1017_n N_noxref_6_c_1744_n ) capacitor c=0.00127339f \
 //x=4.56 //y=4.04 //x2=4.175 //y2=4.25
cc_896 ( N_noxref_4_c_1019_n N_noxref_6_c_1744_n ) capacitor c=3.11164e-19 \
 //x=4.56 //y=5.25 //x2=4.175 //y2=4.25
cc_897 ( N_noxref_4_c_1160_p N_noxref_6_c_1744_n ) capacitor c=0.0220746f \
 //x=2.022 //y=5.335 //x2=4.175 //y2=4.25
cc_898 ( N_noxref_4_c_1044_n N_noxref_6_c_1744_n ) capacitor c=0.0358254f \
 //x=4.72 //y=3.88 //x2=4.175 //y2=4.25
cc_899 ( N_noxref_4_c_1017_n N_noxref_6_c_1748_n ) capacitor c=0.00757046f \
 //x=4.56 //y=4.04 //x2=4.775 //y2=4.265
cc_900 ( N_noxref_4_c_1019_n N_noxref_6_c_1748_n ) capacitor c=0.0226561f \
 //x=4.56 //y=5.25 //x2=4.775 //y2=4.265
cc_901 ( N_noxref_4_c_1042_n N_noxref_6_c_1748_n ) capacitor c=0.127758f \
 //x=6.245 //y=3.88 //x2=4.775 //y2=4.265
cc_902 ( N_noxref_4_c_1028_n N_noxref_6_c_1749_n ) capacitor c=0.00447313f \
 //x=6.41 //y=4.04 //x2=6.02 //y2=4.25
cc_903 ( N_noxref_4_c_1040_n N_noxref_6_c_1749_n ) capacitor c=4.98743e-19 \
 //x=6.412 //y=4.74 //x2=6.02 //y2=4.25
cc_904 ( N_noxref_4_c_1042_n N_noxref_6_c_1749_n ) capacitor c=0.0108816f \
 //x=6.245 //y=3.88 //x2=6.02 //y2=4.25
cc_905 ( N_noxref_4_c_1049_n N_noxref_6_c_1749_n ) capacitor c=0.0358254f \
 //x=7.755 //y=3.895 //x2=6.02 //y2=4.25
cc_906 ( N_noxref_4_c_1028_n N_noxref_6_c_1750_n ) capacitor c=0.00240423f \
 //x=6.41 //y=4.04 //x2=6.62 //y2=4.265
cc_907 ( N_noxref_4_c_1040_n N_noxref_6_c_1750_n ) capacitor c=0.0221402f \
 //x=6.412 //y=4.74 //x2=6.62 //y2=4.265
cc_908 ( N_noxref_4_c_1049_n N_noxref_6_c_1750_n ) capacitor c=0.011929f \
 //x=7.755 //y=3.895 //x2=6.62 //y2=4.265
cc_909 ( N_noxref_4_c_1079_n N_noxref_6_c_1813_n ) capacitor c=0.0834487f \
 //x=10.7 //y=3.87 //x2=14.38 //y2=4.25
cc_910 ( N_noxref_4_c_1084_n N_noxref_6_c_1813_n ) capacitor c=0.110992f \
 //x=11.44 //y=3.895 //x2=14.38 //y2=4.25
cc_911 ( N_noxref_4_c_1087_n N_noxref_6_c_1813_n ) capacitor c=0.0573431f \
 //x=12.68 //y=3.88 //x2=14.38 //y2=4.25
cc_912 ( N_noxref_4_c_1091_n N_noxref_6_c_1813_n ) capacitor c=0.0912005f \
 //x=13.28 //y=3.895 //x2=14.38 //y2=4.25
cc_913 ( N_noxref_4_c_1040_n N_noxref_6_c_1751_n ) capacitor c=3.14882e-19 \
 //x=6.412 //y=4.74 //x2=10.645 //y2=4.25
cc_914 ( N_noxref_4_c_1046_n N_noxref_6_c_1751_n ) capacitor c=0.111913f \
 //x=8.1 //y=3.895 //x2=10.645 //y2=4.25
cc_915 ( N_noxref_4_c_1049_n N_noxref_6_c_1751_n ) capacitor c=0.133647f \
 //x=7.755 //y=3.895 //x2=10.645 //y2=4.25
cc_916 ( N_noxref_4_c_1053_n N_noxref_6_c_1751_n ) capacitor c=0.05672f \
 //x=9.35 //y=3.88 //x2=10.645 //y2=4.25
cc_917 ( N_noxref_4_c_1057_n N_noxref_6_c_1751_n ) capacitor c=0.0248422f \
 //x=9.95 //y=3.89 //x2=10.645 //y2=4.25
cc_918 ( N_noxref_4_c_1079_n N_noxref_6_c_1751_n ) capacitor c=0.0365231f \
 //x=10.7 //y=3.87 //x2=10.645 //y2=4.25
cc_919 ( N_noxref_4_c_1131_p N_noxref_6_c_1998_n ) capacitor c=0.00248847f \
 //x=16.4 //y=4.045 //x2=16.615 //y2=4.27
cc_920 ( N_noxref_4_c_1132_p N_noxref_6_c_1998_n ) capacitor c=0.00242573f \
 //x=16.4 //y=4.88 //x2=16.615 //y2=4.27
cc_921 ( N_noxref_4_c_1112_n N_noxref_6_c_1998_n ) capacitor c=0.0263613f \
 //x=16.402 //y=4.74 //x2=16.615 //y2=4.27
cc_922 ( N_noxref_4_c_1131_p N_noxref_6_c_1920_n ) capacitor c=0.0044381f \
 //x=16.4 //y=4.045 //x2=16.27 //y2=4.27
cc_923 ( N_noxref_4_c_1112_n N_noxref_6_c_1920_n ) capacitor c=0.00208639f \
 //x=16.402 //y=4.74 //x2=16.27 //y2=4.27
cc_924 ( N_noxref_4_c_1091_n N_noxref_6_c_1920_n ) capacitor c=0.222337f \
 //x=13.28 //y=3.895 //x2=16.27 //y2=4.27
cc_925 ( N_noxref_4_c_1160_p N_noxref_6_M13_noxref_g ) capacitor c=0.00501342f \
 //x=2.022 //y=5.335 //x2=1.8 //y2=6.2
cc_926 ( N_noxref_4_c_1189_p N_noxref_6_M13_noxref_g ) capacitor c=0.0162284f \
 //x=2.02 //y=5.56 //x2=1.8 //y2=6.2
cc_927 ( N_noxref_4_c_1093_n N_noxref_6_M14_noxref_g ) capacitor c=0.00973141f \
 //x=2.78 //y=5.335 //x2=2.24 //y2=6.2
cc_928 ( N_noxref_4_c_1160_p N_noxref_6_M14_noxref_g ) capacitor c=0.00229208f \
 //x=2.022 //y=5.335 //x2=2.24 //y2=6.2
cc_929 ( N_noxref_4_c_1189_p N_noxref_6_M14_noxref_g ) capacitor c=0.0179041f \
 //x=2.02 //y=5.56 //x2=2.24 //y2=6.2
cc_930 ( N_noxref_4_c_1160_p N_noxref_6_c_1947_n ) capacitor c=0.00171885f \
 //x=2.022 //y=5.335 //x2=2.165 //y2=4.97
cc_931 ( N_noxref_4_c_1189_p N_noxref_6_c_1947_n ) capacitor c=0.00291477f \
 //x=2.02 //y=5.56 //x2=2.165 //y2=4.97
cc_932 ( N_noxref_4_c_1104_n N_noxref_7_c_2313_n ) capacitor c=0.0585054f \
 //x=16.4 //y=3.725 //x2=17.14 //y2=3.705
cc_933 ( N_noxref_4_c_1196_p N_noxref_7_c_2313_n ) capacitor c=3.49899e-19 \
 //x=16.4 //y=2.26 //x2=17.14 //y2=3.705
cc_934 ( N_noxref_4_c_1104_n N_noxref_7_c_2315_n ) capacitor c=0.00122693f \
 //x=16.4 //y=3.725 //x2=17.14 //y2=4.025
cc_935 ( N_noxref_4_c_1131_p N_noxref_7_c_2315_n ) capacitor c=0.019045f \
 //x=16.4 //y=4.045 //x2=17.14 //y2=4.025
cc_936 ( N_noxref_4_c_1199_p N_noxref_7_c_2315_n ) capacitor c=6.606e-19 \
 //x=16.4 //y=3.88 //x2=17.14 //y2=4.025
cc_937 ( N_noxref_4_c_1091_n N_noxref_7_c_2315_n ) capacitor c=0.00304665f \
 //x=13.28 //y=3.895 //x2=17.14 //y2=4.025
cc_938 ( N_noxref_4_c_1131_p N_noxref_7_c_2319_n ) capacitor c=0.00115845f \
 //x=16.4 //y=4.045 //x2=17.14 //y2=4.735
cc_939 ( N_noxref_4_c_1132_p N_noxref_7_c_2319_n ) capacitor c=0.0172863f \
 //x=16.4 //y=4.88 //x2=17.14 //y2=4.735
cc_940 ( N_noxref_4_c_1112_n N_noxref_7_c_2319_n ) capacitor c=0.027626f \
 //x=16.402 //y=4.74 //x2=17.14 //y2=4.735
cc_941 ( N_noxref_4_c_1091_n N_noxref_7_c_2319_n ) capacitor c=5.0367e-19 \
 //x=13.28 //y=3.895 //x2=17.14 //y2=4.735
cc_942 ( N_noxref_4_c_1133_p N_noxref_7_c_2319_n ) capacitor c=7.76143e-19 \
 //x=16.4 //y=4.88 //x2=17.14 //y2=4.735
cc_943 ( N_noxref_4_c_1136_p N_noxref_7_c_2319_n ) capacitor c=0.00201171f \
 //x=16.4 //y=4.88 //x2=17.14 //y2=4.735
cc_944 ( N_noxref_4_c_1150_p N_noxref_7_c_2325_n ) capacitor c=0.0205342f \
 //x=16.4 //y=2.26 //x2=17.14 //y2=2.26
cc_945 ( N_noxref_4_c_1196_p N_noxref_7_c_2325_n ) capacitor c=5.16867e-19 \
 //x=16.4 //y=2.26 //x2=17.14 //y2=2.26
cc_946 ( N_noxref_4_c_1209_p N_noxref_7_c_2325_n ) capacitor c=0.00167888f \
 //x=16.205 //y=2.095 //x2=17.14 //y2=2.26
cc_947 ( N_noxref_4_c_1131_p N_noxref_7_c_2328_n ) capacitor c=7.27831e-19 \
 //x=16.4 //y=4.045 //x2=17.14 //y2=3.88
cc_948 ( N_noxref_4_c_1199_p N_noxref_7_c_2328_n ) capacitor c=0.0102237f \
 //x=16.4 //y=3.88 //x2=17.14 //y2=3.88
cc_949 ( N_noxref_4_c_1104_n N_noxref_7_c_2330_n ) capacitor c=5.59436e-19 \
 //x=16.4 //y=3.725 //x2=17.3 //y2=3.865
cc_950 ( N_noxref_4_c_1131_p N_noxref_7_c_2330_n ) capacitor c=0.00305846f \
 //x=16.4 //y=4.045 //x2=17.3 //y2=3.865
cc_951 ( N_noxref_4_c_1091_n N_noxref_7_c_2330_n ) capacitor c=0.0214928f \
 //x=13.28 //y=3.895 //x2=17.3 //y2=3.865
cc_952 ( N_noxref_4_c_1104_n N_noxref_7_c_2333_n ) capacitor c=3.49899e-19 \
 //x=16.4 //y=3.725 //x2=17.14 //y2=2.26
cc_953 ( N_noxref_4_c_1150_p N_noxref_7_c_2333_n ) capacitor c=5.24723e-19 \
 //x=16.4 //y=2.26 //x2=17.14 //y2=2.26
cc_954 ( N_noxref_4_c_1196_p N_noxref_7_c_2333_n ) capacitor c=0.00525888f \
 //x=16.4 //y=2.26 //x2=17.14 //y2=2.26
cc_955 ( N_noxref_4_c_1209_p N_noxref_7_c_2333_n ) capacitor c=0.00190888f \
 //x=16.205 //y=2.095 //x2=17.14 //y2=2.26
cc_956 ( N_noxref_4_c_1132_p N_noxref_7_c_2337_n ) capacitor c=4.80626e-19 \
 //x=16.4 //y=4.88 //x2=17.17 //y2=4.88
cc_957 ( N_noxref_4_c_1133_p N_noxref_7_c_2337_n ) capacitor c=0.00397338f \
 //x=16.4 //y=4.88 //x2=17.17 //y2=4.88
cc_958 ( N_noxref_4_c_1136_p N_noxref_7_c_2337_n ) capacitor c=0.00283894f \
 //x=16.4 //y=4.88 //x2=17.17 //y2=4.88
cc_959 ( N_noxref_4_M31_noxref_g N_noxref_7_M33_noxref_g ) capacitor \
 c=0.0104892f //x=16.3 //y=6.2 //x2=17.18 //y2=6.2
cc_960 ( N_noxref_4_M32_noxref_g N_noxref_7_M33_noxref_g ) capacitor \
 c=0.107636f //x=16.74 //y=6.2 //x2=17.18 //y2=6.2
cc_961 ( N_noxref_4_M32_noxref_g N_noxref_7_M34_noxref_g ) capacitor \
 c=0.0100341f //x=16.74 //y=6.2 //x2=17.62 //y2=6.2
cc_962 ( N_noxref_4_c_1225_p N_noxref_7_c_2343_n ) capacitor c=4.86545e-19 \
 //x=16.205 //y=1.045 //x2=17.175 //y2=1.085
cc_963 ( N_noxref_4_c_1226_p N_noxref_7_c_2343_n ) capacitor c=0.00152405f \
 //x=16.205 //y=1.39 //x2=17.175 //y2=1.085
cc_964 ( N_noxref_4_c_1227_p N_noxref_7_c_2343_n ) capacitor c=0.0151475f \
 //x=16.735 //y=1.045 //x2=17.175 //y2=1.085
cc_965 ( N_noxref_4_c_1228_p N_noxref_7_c_2346_n ) capacitor c=0.00109982f \
 //x=16.205 //y=1.7 //x2=17.175 //y2=1.43
cc_966 ( N_noxref_4_c_1229_p N_noxref_7_c_2346_n ) capacitor c=0.0111064f \
 //x=16.735 //y=1.39 //x2=17.175 //y2=1.43
cc_967 ( N_noxref_4_c_1228_p N_noxref_7_c_2348_n ) capacitor c=9.58243e-19 \
 //x=16.205 //y=1.7 //x2=17.175 //y2=1.74
cc_968 ( N_noxref_4_c_1209_p N_noxref_7_c_2348_n ) capacitor c=0.00662747f \
 //x=16.205 //y=2.095 //x2=17.175 //y2=1.74
cc_969 ( N_noxref_4_c_1229_p N_noxref_7_c_2348_n ) capacitor c=0.00862358f \
 //x=16.735 //y=1.39 //x2=17.175 //y2=1.74
cc_970 ( N_noxref_4_c_1227_p N_noxref_7_c_2351_n ) capacitor c=0.00127211f \
 //x=16.735 //y=1.045 //x2=17.705 //y2=1.085
cc_971 ( N_noxref_4_c_1229_p N_noxref_7_c_2352_n ) capacitor c=0.00204774f \
 //x=16.735 //y=1.39 //x2=17.705 //y2=1.43
cc_972 ( N_noxref_4_c_1150_p N_noxref_7_c_2353_n ) capacitor c=0.00167305f \
 //x=16.4 //y=2.26 //x2=17.14 //y2=2.26
cc_973 ( N_noxref_4_c_1196_p N_noxref_7_c_2353_n ) capacitor c=0.0018937f \
 //x=16.4 //y=2.26 //x2=17.14 //y2=2.26
cc_974 ( N_noxref_4_c_1209_p N_noxref_7_c_2353_n ) capacitor c=0.0181449f \
 //x=16.205 //y=2.095 //x2=17.14 //y2=2.26
cc_975 ( N_noxref_4_c_1132_p N_noxref_7_c_2356_n ) capacitor c=0.00158715f \
 //x=16.4 //y=4.88 //x2=17.17 //y2=4.88
cc_976 ( N_noxref_4_c_1133_p N_noxref_7_c_2356_n ) capacitor c=0.00237977f \
 //x=16.4 //y=4.88 //x2=17.17 //y2=4.88
cc_977 ( N_noxref_4_c_1136_p N_noxref_7_c_2356_n ) capacitor c=0.0297875f \
 //x=16.4 //y=4.88 //x2=17.17 //y2=4.88
cc_978 ( N_noxref_4_c_1093_n N_VDD_c_2586_n ) capacitor c=0.00621352f //x=2.78 \
 //y=5.335 //x2=21.58 //y2=7.58
cc_979 ( N_noxref_4_c_975_n N_VDD_c_2586_n ) capacitor c=0.00627192f //x=3.665 \
 //y=5.335 //x2=21.58 //y2=7.58
cc_980 ( N_noxref_4_c_976_n N_VDD_c_2586_n ) capacitor c=0.00256019f //x=3.78 \
 //y=5.56 //x2=21.58 //y2=7.58
cc_981 ( N_noxref_4_c_979_n N_VDD_c_2586_n ) capacitor c=0.00829247f //x=4.475 \
 //y=5.335 //x2=21.58 //y2=7.58
cc_982 ( N_noxref_4_c_1017_n N_VDD_c_2586_n ) capacitor c=5.12643e-19 //x=4.56 \
 //y=4.04 //x2=21.58 //y2=7.58
cc_983 ( N_noxref_4_c_1028_n N_VDD_c_2586_n ) capacitor c=2.12476e-19 //x=6.41 \
 //y=4.04 //x2=21.58 //y2=7.58
cc_984 ( N_noxref_4_c_1131_p N_VDD_c_2586_n ) capacitor c=2.12639e-19 //x=16.4 \
 //y=4.045 //x2=21.58 //y2=7.58
cc_985 ( N_noxref_4_c_1160_p N_VDD_c_2586_n ) capacitor c=0.00261804f \
 //x=2.022 //y=5.335 //x2=21.58 //y2=7.58
cc_986 ( N_noxref_4_c_1105_n N_VDD_c_2586_n ) capacitor c=0.00270108f //x=2.9 \
 //y=5.335 //x2=21.58 //y2=7.58
cc_987 ( N_noxref_4_c_1038_n N_VDD_c_2586_n ) capacitor c=9.07241e-19 //x=6.41 \
 //y=4.88 //x2=21.58 //y2=7.58
cc_988 ( N_noxref_4_c_1132_p N_VDD_c_2586_n ) capacitor c=9.07241e-19 //x=16.4 \
 //y=4.88 //x2=21.58 //y2=7.58
cc_989 ( N_noxref_4_c_1189_p N_VDD_c_2586_n ) capacitor c=0.0024232f //x=2.02 \
 //y=5.56 //x2=21.58 //y2=7.58
cc_990 ( N_noxref_4_c_1124_n N_VDD_c_2586_n ) capacitor c=0.0024232f //x=2.9 \
 //y=5.56 //x2=21.58 //y2=7.58
cc_991 ( N_noxref_4_c_1059_n N_VDD_c_2586_n ) capacitor c=0.0024232f //x=3.78 \
 //y=5.56 //x2=21.58 //y2=7.58
cc_992 ( N_noxref_4_c_1064_n N_VDD_c_2586_n ) capacitor c=6.22888e-19 //x=6.41 \
 //y=4.88 //x2=21.58 //y2=7.58
cc_993 ( N_noxref_4_c_1133_p N_VDD_c_2586_n ) capacitor c=6.22888e-19 //x=16.4 \
 //y=4.88 //x2=21.58 //y2=7.58
cc_994 ( N_noxref_4_c_1160_p N_VDD_c_2693_n ) capacitor c=0.00331944f \
 //x=2.022 //y=5.335 //x2=1.23 //y2=7.58
cc_995 ( N_noxref_4_c_1189_p N_VDD_c_2693_n ) capacitor c=0.00509469f //x=2.02 \
 //y=5.56 //x2=1.23 //y2=7.58
cc_996 ( N_noxref_4_c_1093_n N_VDD_c_2731_n ) capacitor c=0.00202922f //x=2.78 \
 //y=5.335 //x2=2.375 //y2=7.585
cc_997 ( N_noxref_4_c_1160_p N_VDD_c_2731_n ) capacitor c=9.3757e-19 //x=2.022 \
 //y=5.335 //x2=2.375 //y2=7.585
cc_998 ( N_noxref_4_c_1189_p N_VDD_c_2731_n ) capacitor c=0.0138074f //x=2.02 \
 //y=5.56 //x2=2.375 //y2=7.585
cc_999 ( N_noxref_4_c_1093_n N_VDD_c_2694_n ) capacitor c=0.0017701f //x=2.78 \
 //y=5.335 //x2=3.255 //y2=7.585
cc_1000 ( N_noxref_4_c_975_n N_VDD_c_2694_n ) capacitor c=0.00202922f \
 //x=3.665 //y=5.335 //x2=3.255 //y2=7.585
cc_1001 ( N_noxref_4_c_1105_n N_VDD_c_2694_n ) capacitor c=9.48145e-19 //x=2.9 \
 //y=5.335 //x2=3.255 //y2=7.585
cc_1002 ( N_noxref_4_c_1124_n N_VDD_c_2694_n ) capacitor c=0.0138074f //x=2.9 \
 //y=5.56 //x2=3.255 //y2=7.585
cc_1003 ( N_noxref_4_c_975_n N_VDD_c_2596_n ) capacitor c=0.00205906f \
 //x=3.665 //y=5.335 //x2=4.135 //y2=7.585
cc_1004 ( N_noxref_4_c_976_n N_VDD_c_2596_n ) capacitor c=8.49654e-19 //x=3.78 \
 //y=5.56 //x2=4.135 //y2=7.585
cc_1005 ( N_noxref_4_c_979_n N_VDD_c_2596_n ) capacitor c=0.00204238f \
 //x=4.475 //y=5.335 //x2=4.135 //y2=7.585
cc_1006 ( N_noxref_4_c_1059_n N_VDD_c_2596_n ) capacitor c=0.0138074f //x=3.78 \
 //y=5.56 //x2=4.135 //y2=7.585
cc_1007 ( N_noxref_4_c_979_n N_VDD_c_2742_n ) capacitor c=0.00183742f \
 //x=4.475 //y=5.335 //x2=5.13 //y2=7.585
cc_1008 ( N_noxref_4_c_1038_n N_VDD_c_2598_n ) capacitor c=6.28113e-19 \
 //x=6.41 //y=4.88 //x2=6.885 //y2=7.585
cc_1009 ( N_noxref_4_M19_noxref_g N_VDD_c_2598_n ) capacitor c=0.00732618f \
 //x=6.31 //y=6.2 //x2=6.885 //y2=7.585
cc_1010 ( N_noxref_4_M20_noxref_g N_VDD_c_2598_n ) capacitor c=0.00755544f \
 //x=6.75 //y=6.2 //x2=6.885 //y2=7.585
cc_1011 ( N_noxref_4_c_1132_p N_VDD_c_2746_n ) capacitor c=6.28113e-19 \
 //x=16.4 //y=4.88 //x2=16.875 //y2=7.585
cc_1012 ( N_noxref_4_M31_noxref_g N_VDD_c_2746_n ) capacitor c=0.00732618f \
 //x=16.3 //y=6.2 //x2=16.875 //y2=7.585
cc_1013 ( N_noxref_4_M32_noxref_g N_VDD_c_2746_n ) capacitor c=0.00755544f \
 //x=16.74 //y=6.2 //x2=16.875 //y2=7.585
cc_1014 ( N_noxref_4_c_976_n N_VDD_c_2609_n ) capacitor c=0.00269779f //x=3.78 \
 //y=5.56 //x2=5.3 //y2=7.585
cc_1015 ( N_noxref_4_c_1019_n N_VDD_c_2609_n ) capacitor c=0.0311457f //x=4.56 \
 //y=5.25 //x2=5.3 //y2=7.585
cc_1016 ( N_noxref_4_c_1038_n N_VDD_c_2609_n ) capacitor c=0.00447349f \
 //x=6.41 //y=4.88 //x2=5.3 //y2=7.585
cc_1017 ( N_noxref_4_c_1040_n N_VDD_c_2609_n ) capacitor c=0.005882f //x=6.412 \
 //y=4.74 //x2=5.3 //y2=7.585
cc_1018 ( N_noxref_4_c_1059_n N_VDD_c_2609_n ) capacitor c=0.00776541f \
 //x=3.78 //y=5.56 //x2=5.3 //y2=7.585
cc_1019 ( N_noxref_4_c_1064_n N_VDD_c_2609_n ) capacitor c=0.00387138f \
 //x=6.41 //y=4.88 //x2=5.3 //y2=7.585
cc_1020 ( N_noxref_4_c_1071_n N_VDD_c_2609_n ) capacitor c=0.0125313f //x=6.41 \
 //y=4.88 //x2=5.3 //y2=7.585
cc_1021 ( N_noxref_4_c_1132_p N_VDD_c_2702_n ) capacitor c=0.00447349f \
 //x=16.4 //y=4.88 //x2=15.29 //y2=7.585
cc_1022 ( N_noxref_4_c_1112_n N_VDD_c_2702_n ) capacitor c=0.00695635f \
 //x=16.402 //y=4.74 //x2=15.29 //y2=7.585
cc_1023 ( N_noxref_4_c_1091_n N_VDD_c_2702_n ) capacitor c=0.00271717f \
 //x=13.28 //y=3.895 //x2=15.29 //y2=7.585
cc_1024 ( N_noxref_4_c_1133_p N_VDD_c_2702_n ) capacitor c=0.00370494f \
 //x=16.4 //y=4.88 //x2=15.29 //y2=7.585
cc_1025 ( N_noxref_4_c_1136_p N_VDD_c_2702_n ) capacitor c=0.0129564f //x=16.4 \
 //y=4.88 //x2=15.29 //y2=7.585
cc_1026 ( N_noxref_4_c_1160_p N_VDD_M13_noxref_s ) capacitor c=0.0451824f \
 //x=2.022 //y=5.335 //x2=1.445 //y2=5.2
cc_1027 ( N_noxref_4_c_1105_n N_VDD_M13_noxref_s ) capacitor c=7.80122e-19 \
 //x=2.9 //y=5.335 //x2=1.445 //y2=5.2
cc_1028 ( N_noxref_4_c_1189_p N_VDD_M13_noxref_s ) capacitor c=0.09305f \
 //x=2.02 //y=5.56 //x2=1.445 //y2=5.2
cc_1029 ( N_noxref_4_c_1093_n N_VDD_M14_noxref_d ) capacitor c=0.00700141f \
 //x=2.78 //y=5.335 //x2=2.315 //y2=5.2
cc_1030 ( N_noxref_4_c_1189_p N_VDD_M14_noxref_d ) capacitor c=0.0674491f \
 //x=2.02 //y=5.56 //x2=2.315 //y2=5.2
cc_1031 ( N_noxref_4_c_1124_n N_VDD_M14_noxref_d ) capacitor c=0.0674762f \
 //x=2.9 //y=5.56 //x2=2.315 //y2=5.2
cc_1032 ( N_noxref_4_c_975_n N_VDD_M16_noxref_d ) capacitor c=0.00700141f \
 //x=3.665 //y=5.335 //x2=3.195 //y2=5.2
cc_1033 ( N_noxref_4_c_1124_n N_VDD_M16_noxref_d ) capacitor c=0.067493f \
 //x=2.9 //y=5.56 //x2=3.195 //y2=5.2
cc_1034 ( N_noxref_4_c_1059_n N_VDD_M16_noxref_d ) capacitor c=0.0674288f \
 //x=3.78 //y=5.56 //x2=3.195 //y2=5.2
cc_1035 ( N_noxref_4_c_979_n N_VDD_M18_noxref_d ) capacitor c=0.00700141f \
 //x=4.475 //y=5.335 //x2=4.075 //y2=5.2
cc_1036 ( N_noxref_4_c_1059_n N_VDD_M18_noxref_d ) capacitor c=0.0673824f \
 //x=3.78 //y=5.56 //x2=4.075 //y2=5.2
cc_1037 ( N_noxref_4_c_976_n N_VDD_M19_noxref_s ) capacitor c=0.00536022f \
 //x=3.78 //y=5.56 //x2=5.955 //y2=5.2
cc_1038 ( N_noxref_4_c_979_n N_VDD_M19_noxref_s ) capacitor c=0.00211796f \
 //x=4.475 //y=5.335 //x2=5.955 //y2=5.2
cc_1039 ( N_noxref_4_c_1028_n N_VDD_M19_noxref_s ) capacitor c=0.00143547f \
 //x=6.41 //y=4.04 //x2=5.955 //y2=5.2
cc_1040 ( N_noxref_4_M19_noxref_g N_VDD_M19_noxref_s ) capacitor c=0.0567929f \
 //x=6.31 //y=6.2 //x2=5.955 //y2=5.2
cc_1041 ( N_noxref_4_M20_noxref_g N_VDD_M20_noxref_d ) capacitor c=0.015318f \
 //x=6.75 //y=6.2 //x2=6.825 //y2=5.2
cc_1042 ( N_noxref_4_c_1131_p N_VDD_M31_noxref_s ) capacitor c=0.00144559f \
 //x=16.4 //y=4.045 //x2=15.945 //y2=5.2
cc_1043 ( N_noxref_4_M31_noxref_g N_VDD_M31_noxref_s ) capacitor c=0.0567929f \
 //x=16.3 //y=6.2 //x2=15.945 //y2=5.2
cc_1044 ( N_noxref_4_M32_noxref_g N_VDD_M32_noxref_d ) capacitor c=0.015318f \
 //x=16.74 //y=6.2 //x2=16.815 //y2=5.2
cc_1045 ( N_noxref_4_c_984_n N_noxref_9_c_2971_n ) capacitor c=0.0036878f \
 //x=4.075 //y=1.305 //x2=4.475 //y2=0.72
cc_1046 ( N_noxref_4_c_999_n N_noxref_9_c_2971_n ) capacitor c=0.00366757f \
 //x=4.475 //y=1.845 //x2=4.475 //y2=0.72
cc_1047 ( N_noxref_4_M2_noxref_d N_noxref_9_c_2971_n ) capacitor c=0.00949319f \
 //x=3.885 //y=1.095 //x2=4.475 //y2=0.72
cc_1048 ( N_noxref_4_M2_noxref_d N_noxref_9_c_2976_n ) capacitor c=0.00120711f \
 //x=3.885 //y=1.095 //x2=3.59 //y2=1.175
cc_1049 ( N_noxref_4_c_1093_n N_noxref_9_M1_noxref_d ) capacitor c=0.00164346f \
 //x=2.78 //y=5.335 //x2=2.35 //y2=1.09
cc_1050 ( N_noxref_4_c_984_n N_noxref_9_M1_noxref_d ) capacitor c=0.00802836f \
 //x=4.075 //y=1.305 //x2=2.35 //y2=1.09
cc_1051 ( N_noxref_4_c_984_n N_noxref_9_M2_noxref_s ) capacitor c=0.00993092f \
 //x=4.075 //y=1.305 //x2=3.455 //y2=0.555
cc_1052 ( N_noxref_4_c_993_n N_noxref_9_M2_noxref_s ) capacitor c=0.0273402f \
 //x=4.075 //y=1.76 //x2=3.455 //y2=0.555
cc_1053 ( N_noxref_4_c_999_n N_noxref_9_M2_noxref_s ) capacitor c=0.00911719f \
 //x=4.475 //y=1.845 //x2=3.455 //y2=0.555
cc_1054 ( N_noxref_4_c_1036_n N_noxref_9_M2_noxref_s ) capacitor c=0.00129723f \
 //x=4.56 //y=3.88 //x2=3.455 //y2=0.555
cc_1055 ( N_noxref_4_M2_noxref_d N_noxref_9_M2_noxref_s ) capacitor \
 c=0.0279003f //x=3.885 //y=1.095 //x2=3.455 //y2=0.555
cc_1056 ( N_noxref_4_c_1006_n D ) capacitor c=0.00275583f //x=4.56 //y=3.72 \
 //x2=7.15 //y2=2.77
cc_1057 ( N_noxref_4_c_1019_n D ) capacitor c=0.00115385f //x=4.56 //y=5.25 \
 //x2=7.15 //y2=2.77
cc_1058 ( N_noxref_4_c_1023_n D ) capacitor c=0.0565531f //x=6.41 //y=3.72 \
 //x2=7.15 //y2=2.77
cc_1059 ( N_noxref_4_c_1028_n D ) capacitor c=0.0144744f //x=6.41 //y=4.04 \
 //x2=7.15 //y2=2.77
cc_1060 ( N_noxref_4_c_1323_p D ) capacitor c=6.03895e-19 //x=6.405 //y=3.88 \
 //x2=7.15 //y2=2.77
cc_1061 ( N_noxref_4_c_1040_n D ) capacitor c=0.0261735f //x=6.412 //y=4.74 \
 //x2=7.15 //y2=2.77
cc_1062 ( N_noxref_4_c_1049_n D ) capacitor c=0.0234467f //x=7.755 //y=3.895 \
 //x2=7.15 //y2=2.77
cc_1063 ( N_noxref_4_c_1326_p D ) capacitor c=3.49899e-19 //x=6.41 //y=2.26 \
 //x2=7.15 //y2=2.77
cc_1064 ( N_noxref_4_c_1064_n D ) capacitor c=3.02466e-19 //x=6.41 //y=4.88 \
 //x2=7.15 //y2=2.77
cc_1065 ( N_noxref_4_c_1071_n D ) capacitor c=0.00108965f //x=6.41 //y=4.88 \
 //x2=7.15 //y2=2.77
cc_1066 ( N_noxref_4_c_1038_n N_D_c_3042_n ) capacitor c=0.0172863f //x=6.41 \
 //y=4.88 //x2=7.15 //y2=4.735
cc_1067 ( N_noxref_4_c_1064_n N_D_c_3042_n ) capacitor c=4.73677e-19 //x=6.41 \
 //y=4.88 //x2=7.15 //y2=4.735
cc_1068 ( N_noxref_4_c_1071_n N_D_c_3042_n ) capacitor c=9.22067e-19 //x=6.41 \
 //y=4.88 //x2=7.15 //y2=4.735
cc_1069 ( N_noxref_4_c_1037_n N_D_c_3044_n ) capacitor c=0.0205342f //x=6.41 \
 //y=2.26 //x2=7.15 //y2=2.26
cc_1070 ( N_noxref_4_c_1326_p N_D_c_3044_n ) capacitor c=5.16867e-19 //x=6.41 \
 //y=2.26 //x2=7.15 //y2=2.26
cc_1071 ( N_noxref_4_c_1334_p N_D_c_3044_n ) capacitor c=0.00167888f //x=6.215 \
 //y=2.095 //x2=7.15 //y2=2.26
cc_1072 ( N_noxref_4_c_1023_n N_D_c_3046_n ) capacitor c=3.49899e-19 //x=6.41 \
 //y=3.72 //x2=7.15 //y2=2.26
cc_1073 ( N_noxref_4_c_1037_n N_D_c_3046_n ) capacitor c=5.24723e-19 //x=6.41 \
 //y=2.26 //x2=7.15 //y2=2.26
cc_1074 ( N_noxref_4_c_1326_p N_D_c_3046_n ) capacitor c=0.00485709f //x=6.41 \
 //y=2.26 //x2=7.15 //y2=2.26
cc_1075 ( N_noxref_4_c_1334_p N_D_c_3046_n ) capacitor c=0.00190888f //x=6.215 \
 //y=2.095 //x2=7.15 //y2=2.26
cc_1076 ( N_noxref_4_c_1038_n N_D_c_3047_n ) capacitor c=4.80626e-19 //x=6.41 \
 //y=4.88 //x2=7.18 //y2=4.88
cc_1077 ( N_noxref_4_c_1064_n N_D_c_3047_n ) capacitor c=0.00397338f //x=6.41 \
 //y=4.88 //x2=7.18 //y2=4.88
cc_1078 ( N_noxref_4_c_1071_n N_D_c_3047_n ) capacitor c=0.00283894f //x=6.41 \
 //y=4.88 //x2=7.18 //y2=4.88
cc_1079 ( N_noxref_4_M19_noxref_g N_D_M21_noxref_g ) capacitor c=0.0104892f \
 //x=6.31 //y=6.2 //x2=7.19 //y2=6.2
cc_1080 ( N_noxref_4_M20_noxref_g N_D_M21_noxref_g ) capacitor c=0.107636f \
 //x=6.75 //y=6.2 //x2=7.19 //y2=6.2
cc_1081 ( N_noxref_4_M20_noxref_g N_D_M22_noxref_g ) capacitor c=0.0100341f \
 //x=6.75 //y=6.2 //x2=7.63 //y2=6.2
cc_1082 ( N_noxref_4_c_1345_p N_D_c_3055_n ) capacitor c=4.86545e-19 //x=6.215 \
 //y=1.045 //x2=7.185 //y2=1.085
cc_1083 ( N_noxref_4_c_1346_p N_D_c_3055_n ) capacitor c=0.00152405f //x=6.215 \
 //y=1.39 //x2=7.185 //y2=1.085
cc_1084 ( N_noxref_4_c_1347_p N_D_c_3055_n ) capacitor c=0.0151475f //x=6.745 \
 //y=1.045 //x2=7.185 //y2=1.085
cc_1085 ( N_noxref_4_c_1348_p N_D_c_3057_n ) capacitor c=0.00109982f //x=6.215 \
 //y=1.7 //x2=7.185 //y2=1.43
cc_1086 ( N_noxref_4_c_1349_p N_D_c_3057_n ) capacitor c=0.0111064f //x=6.745 \
 //y=1.39 //x2=7.185 //y2=1.43
cc_1087 ( N_noxref_4_c_1348_p N_D_c_3060_n ) capacitor c=9.58243e-19 //x=6.215 \
 //y=1.7 //x2=7.185 //y2=1.74
cc_1088 ( N_noxref_4_c_1334_p N_D_c_3060_n ) capacitor c=0.00662747f //x=6.215 \
 //y=2.095 //x2=7.185 //y2=1.74
cc_1089 ( N_noxref_4_c_1349_p N_D_c_3060_n ) capacitor c=0.00862358f //x=6.745 \
 //y=1.39 //x2=7.185 //y2=1.74
cc_1090 ( N_noxref_4_c_1347_p N_D_c_3070_n ) capacitor c=0.00127211f //x=6.745 \
 //y=1.045 //x2=7.715 //y2=1.085
cc_1091 ( N_noxref_4_c_1349_p N_D_c_3072_n ) capacitor c=0.00204774f //x=6.745 \
 //y=1.39 //x2=7.715 //y2=1.43
cc_1092 ( N_noxref_4_c_1037_n N_D_c_3076_n ) capacitor c=0.00167305f //x=6.41 \
 //y=2.26 //x2=7.15 //y2=2.26
cc_1093 ( N_noxref_4_c_1326_p N_D_c_3076_n ) capacitor c=0.00266443f //x=6.41 \
 //y=2.26 //x2=7.15 //y2=2.26
cc_1094 ( N_noxref_4_c_1334_p N_D_c_3076_n ) capacitor c=0.0181449f //x=6.215 \
 //y=2.095 //x2=7.15 //y2=2.26
cc_1095 ( N_noxref_4_c_1038_n N_D_c_3079_n ) capacitor c=0.00158715f //x=6.41 \
 //y=4.88 //x2=7.18 //y2=4.88
cc_1096 ( N_noxref_4_c_1064_n N_D_c_3079_n ) capacitor c=0.00237977f //x=6.41 \
 //y=4.88 //x2=7.18 //y2=4.88
cc_1097 ( N_noxref_4_c_1071_n N_D_c_3079_n ) capacitor c=0.0297875f //x=6.41 \
 //y=4.88 //x2=7.18 //y2=4.88
cc_1098 ( N_noxref_4_c_984_n N_GND_c_3150_n ) capacitor c=0.00901861f \
 //x=4.075 //y=1.305 //x2=6.395 //y2=0.175
cc_1099 ( N_noxref_4_c_999_n N_GND_c_3150_n ) capacitor c=0.00713708f \
 //x=4.475 //y=1.845 //x2=6.395 //y2=0.175
cc_1100 ( N_noxref_4_c_1017_n N_GND_c_3150_n ) capacitor c=5.12643e-19 \
 //x=4.56 //y=4.04 //x2=6.395 //y2=0.175
cc_1101 ( N_noxref_4_M2_noxref_d N_GND_c_3150_n ) capacitor c=2.9462e-19 \
 //x=3.885 //y=1.095 //x2=6.395 //y2=0.175
cc_1102 ( N_noxref_4_c_984_n N_GND_c_3154_n ) capacitor c=0.00488628f \
 //x=4.075 //y=1.305 //x2=6.48 //y2=1.135
cc_1103 ( N_noxref_4_c_1037_n N_GND_c_3154_n ) capacitor c=0.00709624f \
 //x=6.41 //y=2.26 //x2=6.48 //y2=1.135
cc_1104 ( N_noxref_4_c_1326_p N_GND_c_3154_n ) capacitor c=2.13705e-19 \
 //x=6.41 //y=2.26 //x2=6.48 //y2=1.135
cc_1105 ( N_noxref_4_c_1345_p N_GND_c_3154_n ) capacitor c=0.00176535f \
 //x=6.215 //y=1.045 //x2=6.48 //y2=1.135
cc_1106 ( N_noxref_4_c_1346_p N_GND_c_3154_n ) capacitor c=0.0036005f \
 //x=6.215 //y=1.39 //x2=6.48 //y2=1.135
cc_1107 ( N_noxref_4_c_1348_p N_GND_c_3154_n ) capacitor c=4.2764e-19 \
 //x=6.215 //y=1.7 //x2=6.48 //y2=1.135
cc_1108 ( N_noxref_4_c_1371_p N_GND_c_3154_n ) capacitor c=9.36995e-19 \
 //x=6.59 //y=0.89 //x2=6.48 //y2=1.135
cc_1109 ( N_noxref_4_c_1372_p N_GND_c_3154_n ) capacitor c=6.38426e-19 \
 //x=6.59 //y=1.545 //x2=6.48 //y2=1.135
cc_1110 ( N_noxref_4_c_1347_p N_GND_c_3154_n ) capacitor c=0.00171721f \
 //x=6.745 //y=1.045 //x2=6.48 //y2=1.135
cc_1111 ( N_noxref_4_c_1349_p N_GND_c_3154_n ) capacitor c=0.00296337f \
 //x=6.745 //y=1.39 //x2=6.48 //y2=1.135
cc_1112 ( N_noxref_4_c_1345_p N_GND_c_3256_n ) capacitor c=3.51399e-19 \
 //x=6.215 //y=1.045 //x2=6.477 //y2=1.005
cc_1113 ( N_noxref_4_c_1371_p N_GND_c_3256_n ) capacitor c=0.00852202f \
 //x=6.59 //y=0.89 //x2=6.477 //y2=1.005
cc_1114 ( N_noxref_4_c_1347_p N_GND_c_3256_n ) capacitor c=4.40641e-19 \
 //x=6.745 //y=1.045 //x2=6.477 //y2=1.005
cc_1115 ( N_noxref_4_c_1150_p N_GND_c_3259_n ) capacitor c=0.00709624f \
 //x=16.4 //y=2.26 //x2=16.47 //y2=1.135
cc_1116 ( N_noxref_4_c_1196_p N_GND_c_3259_n ) capacitor c=2.13705e-19 \
 //x=16.4 //y=2.26 //x2=16.47 //y2=1.135
cc_1117 ( N_noxref_4_c_1225_p N_GND_c_3259_n ) capacitor c=0.00171023f \
 //x=16.205 //y=1.045 //x2=16.47 //y2=1.135
cc_1118 ( N_noxref_4_c_1226_p N_GND_c_3259_n ) capacitor c=0.00357815f \
 //x=16.205 //y=1.39 //x2=16.47 //y2=1.135
cc_1119 ( N_noxref_4_c_1228_p N_GND_c_3259_n ) capacitor c=4.2764e-19 \
 //x=16.205 //y=1.7 //x2=16.47 //y2=1.135
cc_1120 ( N_noxref_4_c_1383_p N_GND_c_3259_n ) capacitor c=9.36995e-19 \
 //x=16.58 //y=0.89 //x2=16.47 //y2=1.135
cc_1121 ( N_noxref_4_c_1384_p N_GND_c_3259_n ) capacitor c=6.30911e-19 \
 //x=16.58 //y=1.545 //x2=16.47 //y2=1.135
cc_1122 ( N_noxref_4_c_1227_p N_GND_c_3259_n ) capacitor c=0.00171721f \
 //x=16.735 //y=1.045 //x2=16.47 //y2=1.135
cc_1123 ( N_noxref_4_c_1229_p N_GND_c_3259_n ) capacitor c=0.00296337f \
 //x=16.735 //y=1.39 //x2=16.47 //y2=1.135
cc_1124 ( N_noxref_4_c_1225_p N_GND_c_3268_n ) capacitor c=3.46594e-19 \
 //x=16.205 //y=1.045 //x2=16.467 //y2=1.005
cc_1125 ( N_noxref_4_c_1383_p N_GND_c_3268_n ) capacitor c=0.00839795f \
 //x=16.58 //y=0.89 //x2=16.467 //y2=1.005
cc_1126 ( N_noxref_4_c_1227_p N_GND_c_3268_n ) capacitor c=4.40641e-19 \
 //x=16.735 //y=1.045 //x2=16.467 //y2=1.005
cc_1127 ( N_noxref_4_c_999_n N_GND_c_3170_n ) capacitor c=6.86343e-19 \
 //x=4.475 //y=1.845 //x2=5.13 //y2=0.175
cc_1128 ( N_noxref_4_c_1345_p N_GND_c_3171_n ) capacitor c=0.00688027f \
 //x=6.215 //y=1.045 //x2=8.46 //y2=0.175
cc_1129 ( N_noxref_4_c_1225_p N_GND_c_3273_n ) capacitor c=0.00688027f \
 //x=16.205 //y=1.045 //x2=18.45 //y2=0.175
cc_1130 ( N_noxref_4_c_993_n N_GND_c_3174_n ) capacitor c=0.00285697f \
 //x=4.075 //y=1.76 //x2=5.3 //y2=0.175
cc_1131 ( N_noxref_4_c_999_n N_GND_c_3174_n ) capacitor c=0.0341806f //x=4.475 \
 //y=1.845 //x2=5.3 //y2=0.175
cc_1132 ( N_noxref_4_c_1023_n N_GND_c_3174_n ) capacitor c=0.00829739f \
 //x=6.41 //y=3.72 //x2=5.3 //y2=0.175
cc_1133 ( N_noxref_4_c_1037_n N_GND_c_3174_n ) capacitor c=0.00427323f \
 //x=6.41 //y=2.26 //x2=5.3 //y2=0.175
cc_1134 ( N_noxref_4_c_1326_p N_GND_c_3174_n ) capacitor c=0.00369427f \
 //x=6.41 //y=2.26 //x2=5.3 //y2=0.175
cc_1135 ( N_noxref_4_c_1348_p N_GND_c_3174_n ) capacitor c=0.0015404f \
 //x=6.215 //y=1.7 //x2=5.3 //y2=0.175
cc_1136 ( N_noxref_4_c_1334_p N_GND_c_3174_n ) capacitor c=0.0095324f \
 //x=6.215 //y=2.095 //x2=5.3 //y2=0.175
cc_1137 ( N_noxref_4_c_1104_n N_GND_c_3239_n ) capacitor c=0.00829739f \
 //x=16.4 //y=3.725 //x2=15.29 //y2=0.175
cc_1138 ( N_noxref_4_c_1150_p N_GND_c_3239_n ) capacitor c=0.00427323f \
 //x=16.4 //y=2.26 //x2=15.29 //y2=0.175
cc_1139 ( N_noxref_4_c_1091_n N_GND_c_3239_n ) capacitor c=0.00440673f \
 //x=13.28 //y=3.895 //x2=15.29 //y2=0.175
cc_1140 ( N_noxref_4_c_1196_p N_GND_c_3239_n ) capacitor c=0.0038607f //x=16.4 \
 //y=2.26 //x2=15.29 //y2=0.175
cc_1141 ( N_noxref_4_c_1228_p N_GND_c_3239_n ) capacitor c=0.0015404f \
 //x=16.205 //y=1.7 //x2=15.29 //y2=0.175
cc_1142 ( N_noxref_4_c_1209_p N_GND_c_3239_n ) capacitor c=0.00906518f \
 //x=16.205 //y=2.095 //x2=15.29 //y2=0.175
cc_1143 ( N_noxref_4_c_1037_n N_GND_M3_noxref_d ) capacitor c=2.20438e-19 \
 //x=6.41 //y=2.26 //x2=6.29 //y2=1.045
cc_1144 ( N_noxref_4_c_1345_p N_GND_M3_noxref_d ) capacitor c=0.00192399f \
 //x=6.215 //y=1.045 //x2=6.29 //y2=1.045
cc_1145 ( N_noxref_4_c_1346_p N_GND_M3_noxref_d ) capacitor c=0.00210798f \
 //x=6.215 //y=1.39 //x2=6.29 //y2=1.045
cc_1146 ( N_noxref_4_c_1371_p N_GND_M3_noxref_d ) capacitor c=0.00472259f \
 //x=6.59 //y=0.89 //x2=6.29 //y2=1.045
cc_1147 ( N_noxref_4_c_1372_p N_GND_M3_noxref_d ) capacitor c=0.00166857f \
 //x=6.59 //y=1.545 //x2=6.29 //y2=1.045
cc_1148 ( N_noxref_4_c_1347_p N_GND_M3_noxref_d ) capacitor c=0.00230174f \
 //x=6.745 //y=1.045 //x2=6.29 //y2=1.045
cc_1149 ( N_noxref_4_c_1349_p N_GND_M3_noxref_d ) capacitor c=0.00210798f \
 //x=6.745 //y=1.39 //x2=6.29 //y2=1.045
cc_1150 ( N_noxref_4_c_1150_p N_GND_M9_noxref_d ) capacitor c=2.20438e-19 \
 //x=16.4 //y=2.26 //x2=16.28 //y2=1.045
cc_1151 ( N_noxref_4_c_1225_p N_GND_M9_noxref_d ) capacitor c=0.00192399f \
 //x=16.205 //y=1.045 //x2=16.28 //y2=1.045
cc_1152 ( N_noxref_4_c_1226_p N_GND_M9_noxref_d ) capacitor c=0.00210798f \
 //x=16.205 //y=1.39 //x2=16.28 //y2=1.045
cc_1153 ( N_noxref_4_c_1383_p N_GND_M9_noxref_d ) capacitor c=0.00472259f \
 //x=16.58 //y=0.89 //x2=16.28 //y2=1.045
cc_1154 ( N_noxref_4_c_1384_p N_GND_M9_noxref_d ) capacitor c=0.00166857f \
 //x=16.58 //y=1.545 //x2=16.28 //y2=1.045
cc_1155 ( N_noxref_4_c_1227_p N_GND_M9_noxref_d ) capacitor c=0.00230174f \
 //x=16.735 //y=1.045 //x2=16.28 //y2=1.045
cc_1156 ( N_noxref_4_c_1229_p N_GND_M9_noxref_d ) capacitor c=0.00210798f \
 //x=16.735 //y=1.39 //x2=16.28 //y2=1.045
cc_1157 ( N_noxref_4_c_1334_p N_noxref_13_c_3626_n ) capacitor c=0.00262672f \
 //x=6.215 //y=2.095 //x2=5.995 //y2=1.675
cc_1158 ( N_noxref_4_c_1028_n N_noxref_13_c_3627_n ) capacitor c=0.00361134f \
 //x=6.41 //y=4.04 //x2=6.88 //y2=1.76
cc_1159 ( N_noxref_4_c_1037_n N_noxref_13_c_3627_n ) capacitor c=0.00509504f \
 //x=6.41 //y=2.26 //x2=6.88 //y2=1.76
cc_1160 ( N_noxref_4_c_1326_p N_noxref_13_c_3627_n ) capacitor c=0.00763108f \
 //x=6.41 //y=2.26 //x2=6.88 //y2=1.76
cc_1161 ( N_noxref_4_c_1348_p N_noxref_13_c_3627_n ) capacitor c=0.00697076f \
 //x=6.215 //y=1.7 //x2=6.88 //y2=1.76
cc_1162 ( N_noxref_4_c_1334_p N_noxref_13_c_3627_n ) capacitor c=0.0182994f \
 //x=6.215 //y=2.095 //x2=6.88 //y2=1.76
cc_1163 ( N_noxref_4_c_1372_p N_noxref_13_c_3627_n ) capacitor c=0.00723574f \
 //x=6.59 //y=1.545 //x2=6.88 //y2=1.76
cc_1164 ( N_noxref_4_c_1349_p N_noxref_13_c_3627_n ) capacitor c=0.00339872f \
 //x=6.745 //y=1.39 //x2=6.88 //y2=1.76
cc_1165 ( N_noxref_4_c_1334_p N_noxref_13_c_3629_n ) capacitor c=6.71402e-19 \
 //x=6.215 //y=2.095 //x2=6.965 //y2=1.675
cc_1166 ( N_noxref_4_c_1345_p N_noxref_13_M3_noxref_s ) capacitor c=0.0295366f \
 //x=6.215 //y=1.045 //x2=5.86 //y2=0.545
cc_1167 ( N_noxref_4_c_1348_p N_noxref_13_M3_noxref_s ) capacitor \
 c=3.48408e-19 //x=6.215 //y=1.7 //x2=5.86 //y2=0.545
cc_1168 ( N_noxref_4_c_1347_p N_noxref_13_M3_noxref_s ) capacitor c=0.0125442f \
 //x=6.745 //y=1.045 //x2=5.86 //y2=0.545
cc_1169 ( N_noxref_4_c_1057_n N_noxref_14_c_3694_n ) capacitor c=0.00399388f \
 //x=9.95 //y=3.89 //x2=10.21 //y2=1.76
cc_1170 ( N_noxref_4_c_1057_n N_noxref_14_c_3702_n ) capacitor c=0.00176186f \
 //x=9.95 //y=3.89 //x2=10.295 //y2=1.675
cc_1171 ( N_noxref_4_c_1091_n N_noxref_15_c_3762_n ) capacitor c=0.00398838f \
 //x=13.28 //y=3.895 //x2=13.54 //y2=1.76
cc_1172 ( N_noxref_4_c_1091_n N_noxref_15_c_3770_n ) capacitor c=0.0019353f \
 //x=13.28 //y=3.895 //x2=13.625 //y2=1.675
cc_1173 ( N_noxref_4_c_1091_n N_noxref_16_c_3826_n ) capacitor c=0.00214296f \
 //x=13.28 //y=3.895 //x2=15.985 //y2=1.675
cc_1174 ( N_noxref_4_c_1209_p N_noxref_16_c_3826_n ) capacitor c=0.00262672f \
 //x=16.205 //y=2.095 //x2=15.985 //y2=1.675
cc_1175 ( N_noxref_4_c_1131_p N_noxref_16_c_3828_n ) capacitor c=0.00364314f \
 //x=16.4 //y=4.045 //x2=16.87 //y2=1.76
cc_1176 ( N_noxref_4_c_1150_p N_noxref_16_c_3828_n ) capacitor c=0.00509504f \
 //x=16.4 //y=2.26 //x2=16.87 //y2=1.76
cc_1177 ( N_noxref_4_c_1091_n N_noxref_16_c_3828_n ) capacitor c=0.00120647f \
 //x=13.28 //y=3.895 //x2=16.87 //y2=1.76
cc_1178 ( N_noxref_4_c_1196_p N_noxref_16_c_3828_n ) capacitor c=0.00763108f \
 //x=16.4 //y=2.26 //x2=16.87 //y2=1.76
cc_1179 ( N_noxref_4_c_1228_p N_noxref_16_c_3828_n ) capacitor c=0.00697076f \
 //x=16.205 //y=1.7 //x2=16.87 //y2=1.76
cc_1180 ( N_noxref_4_c_1209_p N_noxref_16_c_3828_n ) capacitor c=0.0184249f \
 //x=16.205 //y=2.095 //x2=16.87 //y2=1.76
cc_1181 ( N_noxref_4_c_1384_p N_noxref_16_c_3828_n ) capacitor c=0.00723574f \
 //x=16.58 //y=1.545 //x2=16.87 //y2=1.76
cc_1182 ( N_noxref_4_c_1229_p N_noxref_16_c_3828_n ) capacitor c=0.00399755f \
 //x=16.735 //y=1.39 //x2=16.87 //y2=1.76
cc_1183 ( N_noxref_4_c_1209_p N_noxref_16_c_3836_n ) capacitor c=6.71402e-19 \
 //x=16.205 //y=2.095 //x2=16.955 //y2=1.675
cc_1184 ( N_noxref_4_c_1225_p N_noxref_16_M9_noxref_s ) capacitor c=0.0294925f \
 //x=16.205 //y=1.045 //x2=15.85 //y2=0.545
cc_1185 ( N_noxref_4_c_1228_p N_noxref_16_M9_noxref_s ) capacitor \
 c=3.48408e-19 //x=16.205 //y=1.7 //x2=15.85 //y2=0.545
cc_1186 ( N_noxref_4_c_1227_p N_noxref_16_M9_noxref_s ) capacitor c=0.0125442f \
 //x=16.735 //y=1.045 //x2=15.85 //y2=0.545
cc_1187 ( N_QN_c_1465_p N_noxref_6_c_1794_n ) capacitor c=0.00324213f \
 //x=17.44 //y=1.75 //x2=14.11 //y2=1.75
cc_1188 ( N_QN_c_1453_n N_noxref_6_c_1882_n ) capacitor c=0.00114153f \
 //x=16.52 //y=5.56 //x2=14.465 //y2=5.38
cc_1189 ( N_QN_c_1467_p N_noxref_6_c_1883_n ) capacitor c=0.00231467f \
 //x=17.525 //y=1.835 //x2=14.465 //y2=1.835
cc_1190 ( QN N_noxref_6_c_1796_n ) capacitor c=0.00204244f //x=17.88 //y=2.4 \
 //x2=14.55 //y2=4.105
cc_1191 ( QN N_noxref_6_c_1799_n ) capacitor c=0.00281705f //x=17.88 //y=4.62 \
 //x2=14.55 //y2=5.295
cc_1192 ( QN N_noxref_6_c_2016_n ) capacitor c=0.0021282f //x=17.88 //y=2.4 \
 //x2=20.47 //y2=4.09
cc_1193 ( QN N_noxref_6_c_2016_n ) capacitor c=7.00667e-19 //x=17.88 //y=4.62 \
 //x2=20.47 //y2=4.09
cc_1194 ( QN N_noxref_6_c_2016_n ) capacitor c=0.0422235f //x=19.73 //y=2.77 \
 //x2=20.47 //y2=4.09
cc_1195 ( QN N_noxref_6_c_2016_n ) capacitor c=0.0164627f //x=19.73 //y=4.62 \
 //x2=20.47 //y2=4.09
cc_1196 ( QN N_noxref_6_c_2016_n ) capacitor c=7.6985e-19 //x=19.73 //y=3.51 \
 //x2=20.47 //y2=4.09
cc_1197 ( N_QN_c_1475_p N_noxref_6_c_2016_n ) capacitor c=0.0151188f //x=19.73 \
 //y=3.655 //x2=20.47 //y2=4.09
cc_1198 ( N_QN_c_1476_p N_noxref_6_c_2016_n ) capacitor c=0.00696905f \
 //x=19.73 //y=3.495 //x2=20.47 //y2=4.09
cc_1199 ( N_QN_c_1477_p N_noxref_6_c_2016_n ) capacitor c=3.49899e-19 \
 //x=19.73 //y=2.26 //x2=20.47 //y2=4.09
cc_1200 ( QN N_noxref_6_c_2024_n ) capacitor c=0.0173413f //x=19.73 //y=4.62 \
 //x2=20.47 //y2=4.41
cc_1201 ( QN N_noxref_6_c_2025_n ) capacitor c=0.00134252f //x=17.88 //y=4.62 \
 //x2=20.47 //y2=4.735
cc_1202 ( QN N_noxref_6_c_2025_n ) capacitor c=0.0138018f //x=19.73 //y=4.62 \
 //x2=20.47 //y2=4.735
cc_1203 ( N_QN_c_1481_p N_noxref_6_c_2025_n ) capacitor c=0.0172958f //x=19.73 \
 //y=4.88 //x2=20.47 //y2=4.735
cc_1204 ( N_QN_c_1482_p N_noxref_6_c_2025_n ) capacitor c=7.76099e-19 \
 //x=19.73 //y=4.88 //x2=20.47 //y2=4.735
cc_1205 ( N_QN_c_1483_p N_noxref_6_c_2025_n ) capacitor c=0.00201171f \
 //x=19.73 //y=4.88 //x2=20.47 //y2=4.735
cc_1206 ( N_QN_c_1453_n N_noxref_6_c_1899_n ) capacitor c=5.29822e-19 \
 //x=16.52 //y=5.56 //x2=14.07 //y2=5.38
cc_1207 ( N_QN_c_1453_n N_noxref_6_c_2031_n ) capacitor c=0.00147119f \
 //x=16.52 //y=5.56 //x2=14.07 //y2=5.56
cc_1208 ( N_QN_c_1486_p N_noxref_6_c_1812_n ) capacitor c=6.99317e-19 \
 //x=17.44 //y=1.18 //x2=14.11 //y2=1.18
cc_1209 ( QN N_noxref_6_c_2033_n ) capacitor c=6.16997e-19 //x=19.73 //y=4.62 \
 //x2=20.47 //y2=4.25
cc_1210 ( N_QN_c_1488_p N_noxref_6_c_2034_n ) capacitor c=0.0205342f //x=19.73 \
 //y=2.26 //x2=20.47 //y2=2.26
cc_1211 ( N_QN_c_1477_p N_noxref_6_c_2034_n ) capacitor c=5.16867e-19 \
 //x=19.73 //y=2.26 //x2=20.47 //y2=2.26
cc_1212 ( N_QN_c_1490_p N_noxref_6_c_2034_n ) capacitor c=0.00167888f \
 //x=19.535 //y=2.095 //x2=20.47 //y2=2.26
cc_1213 ( QN N_noxref_6_c_1998_n ) capacitor c=0.02915f //x=17.88 //y=4.62 \
 //x2=16.615 //y2=4.27
cc_1214 ( QN N_noxref_6_c_1998_n ) capacitor c=0.0295036f //x=19.73 //y=4.62 \
 //x2=16.615 //y2=4.27
cc_1215 ( N_QN_c_1452_n N_noxref_6_c_1998_n ) capacitor c=0.0121187f \
 //x=17.285 //y=5.38 //x2=16.615 //y2=4.27
cc_1216 ( N_QN_c_1453_n N_noxref_6_c_1998_n ) capacitor c=0.00584757f \
 //x=16.52 //y=5.56 //x2=16.615 //y2=4.27
cc_1217 ( N_QN_c_1495_p N_noxref_6_c_1998_n ) capacitor c=0.0151421f //x=17.4 \
 //y=5.38 //x2=16.615 //y2=4.27
cc_1218 ( N_QN_c_1481_p N_noxref_6_c_1998_n ) capacitor c=0.00288386f \
 //x=19.73 //y=4.88 //x2=16.615 //y2=4.27
cc_1219 ( N_QN_c_1497_p N_noxref_6_c_1998_n ) capacitor c=0.00975573f \
 //x=19.57 //y=3.495 //x2=16.615 //y2=4.27
cc_1220 ( QN N_noxref_6_c_2044_n ) capacitor c=3.49899e-19 //x=19.73 //y=2.77 \
 //x2=20.47 //y2=2.26
cc_1221 ( N_QN_c_1488_p N_noxref_6_c_2044_n ) capacitor c=5.24723e-19 \
 //x=19.73 //y=2.26 //x2=20.47 //y2=2.26
cc_1222 ( N_QN_c_1477_p N_noxref_6_c_2044_n ) capacitor c=0.00445529f \
 //x=19.73 //y=2.26 //x2=20.47 //y2=2.26
cc_1223 ( N_QN_c_1490_p N_noxref_6_c_2044_n ) capacitor c=0.00267961f \
 //x=19.535 //y=2.095 //x2=20.47 //y2=2.26
cc_1224 ( N_QN_c_1481_p N_noxref_6_c_2048_n ) capacitor c=4.80626e-19 \
 //x=19.73 //y=4.88 //x2=20.5 //y2=4.88
cc_1225 ( N_QN_c_1482_p N_noxref_6_c_2048_n ) capacitor c=0.00397338f \
 //x=19.73 //y=4.88 //x2=20.5 //y2=4.88
cc_1226 ( N_QN_c_1483_p N_noxref_6_c_2048_n ) capacitor c=0.00283894f \
 //x=19.73 //y=4.88 //x2=20.5 //y2=4.88
cc_1227 ( N_QN_M35_noxref_g N_noxref_6_M37_noxref_g ) capacitor c=0.0104892f \
 //x=19.63 //y=6.2 //x2=20.51 //y2=6.2
cc_1228 ( N_QN_M36_noxref_g N_noxref_6_M37_noxref_g ) capacitor c=0.107636f \
 //x=20.07 //y=6.2 //x2=20.51 //y2=6.2
cc_1229 ( N_QN_M36_noxref_g N_noxref_6_M38_noxref_g ) capacitor c=0.0100341f \
 //x=20.07 //y=6.2 //x2=20.95 //y2=6.2
cc_1230 ( N_QN_c_1508_p N_noxref_6_c_2054_n ) capacitor c=4.86545e-19 \
 //x=19.535 //y=1.045 //x2=20.505 //y2=1.085
cc_1231 ( N_QN_c_1509_p N_noxref_6_c_2054_n ) capacitor c=0.00152405f \
 //x=19.535 //y=1.39 //x2=20.505 //y2=1.085
cc_1232 ( N_QN_c_1510_p N_noxref_6_c_2054_n ) capacitor c=0.0151475f \
 //x=20.065 //y=1.045 //x2=20.505 //y2=1.085
cc_1233 ( N_QN_c_1511_p N_noxref_6_c_2057_n ) capacitor c=0.00109982f \
 //x=19.535 //y=1.7 //x2=20.505 //y2=1.43
cc_1234 ( N_QN_c_1512_p N_noxref_6_c_2057_n ) capacitor c=0.0111064f \
 //x=20.065 //y=1.39 //x2=20.505 //y2=1.43
cc_1235 ( N_QN_c_1511_p N_noxref_6_c_2059_n ) capacitor c=9.58243e-19 \
 //x=19.535 //y=1.7 //x2=20.505 //y2=1.74
cc_1236 ( N_QN_c_1490_p N_noxref_6_c_2059_n ) capacitor c=0.00662747f \
 //x=19.535 //y=2.095 //x2=20.505 //y2=1.74
cc_1237 ( N_QN_c_1512_p N_noxref_6_c_2059_n ) capacitor c=0.00862358f \
 //x=20.065 //y=1.39 //x2=20.505 //y2=1.74
cc_1238 ( N_QN_c_1510_p N_noxref_6_c_2062_n ) capacitor c=0.00127211f \
 //x=20.065 //y=1.045 //x2=21.035 //y2=1.085
cc_1239 ( N_QN_c_1512_p N_noxref_6_c_2063_n ) capacitor c=0.00204774f \
 //x=20.065 //y=1.39 //x2=21.035 //y2=1.43
cc_1240 ( N_QN_c_1488_p N_noxref_6_c_2064_n ) capacitor c=0.00167305f \
 //x=19.73 //y=2.26 //x2=20.47 //y2=2.26
cc_1241 ( N_QN_c_1477_p N_noxref_6_c_2064_n ) capacitor c=0.00266443f \
 //x=19.73 //y=2.26 //x2=20.47 //y2=2.26
cc_1242 ( N_QN_c_1490_p N_noxref_6_c_2064_n ) capacitor c=0.0181449f \
 //x=19.535 //y=2.095 //x2=20.47 //y2=2.26
cc_1243 ( N_QN_c_1481_p N_noxref_6_c_2067_n ) capacitor c=0.00158715f \
 //x=19.73 //y=4.88 //x2=20.5 //y2=4.88
cc_1244 ( N_QN_c_1482_p N_noxref_6_c_2067_n ) capacitor c=0.00237977f \
 //x=19.73 //y=4.88 //x2=20.5 //y2=4.88
cc_1245 ( N_QN_c_1483_p N_noxref_6_c_2067_n ) capacitor c=0.0297875f //x=19.73 \
 //y=4.88 //x2=20.5 //y2=4.88
cc_1246 ( QN N_noxref_7_c_2313_n ) capacitor c=0.0422134f //x=17.88 //y=2.4 \
 //x2=17.14 //y2=3.705
cc_1247 ( QN N_noxref_7_c_2313_n ) capacitor c=0.00215885f //x=17.88 //y=4.62 \
 //x2=17.14 //y2=3.705
cc_1248 ( QN N_noxref_7_c_2313_n ) capacitor c=0.00209153f //x=19.73 //y=2.77 \
 //x2=17.14 //y2=3.705
cc_1249 ( QN N_noxref_7_c_2313_n ) capacitor c=7.6985e-19 //x=17.88 //y=3.51 \
 //x2=17.14 //y2=3.705
cc_1250 ( N_QN_c_1528_p N_noxref_7_c_2313_n ) capacitor c=0.0151188f //x=17.88 \
 //y=3.655 //x2=17.14 //y2=3.705
cc_1251 ( N_QN_c_1529_p N_noxref_7_c_2313_n ) capacitor c=0.00696905f \
 //x=18.04 //y=3.495 //x2=17.14 //y2=3.705
cc_1252 ( QN N_noxref_7_c_2315_n ) capacitor c=0.01761f //x=17.88 //y=4.62 \
 //x2=17.14 //y2=4.025
cc_1253 ( N_QN_c_1452_n N_noxref_7_c_2315_n ) capacitor c=0.00141453f \
 //x=17.285 //y=5.38 //x2=17.14 //y2=4.025
cc_1254 ( N_QN_c_1467_p N_noxref_7_c_2315_n ) capacitor c=4.69451e-19 \
 //x=17.525 //y=1.835 //x2=17.14 //y2=4.025
cc_1255 ( N_QN_c_1495_p N_noxref_7_c_2315_n ) capacitor c=0.00168218f //x=17.4 \
 //y=5.38 //x2=17.14 //y2=4.025
cc_1256 ( N_QN_c_1486_p N_noxref_7_c_2315_n ) capacitor c=2.03e-19 //x=17.44 \
 //y=1.18 //x2=17.14 //y2=4.025
cc_1257 ( N_QN_c_1535_p N_noxref_7_c_2315_n ) capacitor c=4.37971e-19 //x=17.4 \
 //y=5.56 //x2=17.14 //y2=4.025
cc_1258 ( QN N_noxref_7_c_2319_n ) capacitor c=0.0448621f //x=17.88 //y=4.62 \
 //x2=17.14 //y2=4.735
cc_1259 ( QN N_noxref_7_c_2319_n ) capacitor c=0.00159788f //x=19.73 //y=4.62 \
 //x2=17.14 //y2=4.735
cc_1260 ( N_QN_c_1452_n N_noxref_7_c_2319_n ) capacitor c=0.0221293f \
 //x=17.285 //y=5.38 //x2=17.14 //y2=4.735
cc_1261 ( N_QN_M36_noxref_g N_noxref_7_c_2374_n ) capacitor c=0.00967396f \
 //x=20.07 //y=6.2 //x2=20.615 //y2=5.38
cc_1262 ( N_QN_c_1465_p N_noxref_7_c_2375_n ) capacitor c=0.00324213f \
 //x=17.44 //y=1.75 //x2=20.77 //y2=1.75
cc_1263 ( N_QN_c_1541_p N_noxref_7_c_2376_n ) capacitor c=0.00231467f \
 //x=17.795 //y=1.835 //x2=20.855 //y2=1.835
cc_1264 ( QN N_noxref_7_c_2377_n ) capacitor c=0.00204244f //x=17.88 //y=2.4 \
 //x2=21.21 //y2=3.705
cc_1265 ( QN N_noxref_7_c_2377_n ) capacitor c=0.00324628f //x=19.73 //y=2.77 \
 //x2=21.21 //y2=3.705
cc_1266 ( QN N_noxref_7_c_2379_n ) capacitor c=0.00281705f //x=17.88 //y=4.62 \
 //x2=21.21 //y2=5.295
cc_1267 ( QN N_noxref_7_c_2379_n ) capacitor c=0.00286073f //x=19.73 //y=4.62 \
 //x2=21.21 //y2=5.295
cc_1268 ( QN N_noxref_7_c_2325_n ) capacitor c=0.015397f //x=17.88 //y=2.4 \
 //x2=17.14 //y2=2.26
cc_1269 ( QN N_noxref_7_c_2328_n ) capacitor c=7.6985e-19 //x=17.88 //y=4.62 \
 //x2=17.14 //y2=3.88
cc_1270 ( N_QN_c_1548_p N_noxref_7_c_2383_n ) capacitor c=0.00114153f \
 //x=17.795 //y=5.38 //x2=19.85 //y2=5.56
cc_1271 ( N_QN_c_1475_p N_noxref_7_c_2383_n ) capacitor c=6.31487e-19 \
 //x=19.73 //y=3.655 //x2=19.85 //y2=5.56
cc_1272 ( N_QN_c_1495_p N_noxref_7_c_2383_n ) capacitor c=5.29822e-19 //x=17.4 \
 //y=5.38 //x2=19.85 //y2=5.56
cc_1273 ( N_QN_c_1551_p N_noxref_7_c_2383_n ) capacitor c=0.00147119f //x=17.4 \
 //y=5.56 //x2=19.85 //y2=5.56
cc_1274 ( N_QN_c_1481_p N_noxref_7_c_2383_n ) capacitor c=0.0118019f //x=19.73 \
 //y=4.88 //x2=19.85 //y2=5.56
cc_1275 ( N_QN_c_1482_p N_noxref_7_c_2383_n ) capacitor c=0.00277154f \
 //x=19.73 //y=4.88 //x2=19.85 //y2=5.56
cc_1276 ( N_QN_M35_noxref_g N_noxref_7_c_2383_n ) capacitor c=0.00201806f \
 //x=19.63 //y=6.2 //x2=19.85 //y2=5.56
cc_1277 ( N_QN_M36_noxref_g N_noxref_7_c_2383_n ) capacitor c=0.00192712f \
 //x=20.07 //y=6.2 //x2=19.85 //y2=5.56
cc_1278 ( N_QN_c_1483_p N_noxref_7_c_2383_n ) capacitor c=0.00192885f \
 //x=19.73 //y=4.88 //x2=19.85 //y2=5.56
cc_1279 ( N_QN_c_1486_p N_noxref_7_c_2392_n ) capacitor c=6.99317e-19 \
 //x=17.44 //y=1.18 //x2=20.77 //y2=1.18
cc_1280 ( QN N_noxref_7_c_2393_n ) capacitor c=0.0216871f //x=17.88 //y=4.62 \
 //x2=20.085 //y2=3.88
cc_1281 ( QN N_noxref_7_c_2393_n ) capacitor c=0.0229745f //x=19.73 //y=4.62 \
 //x2=20.085 //y2=3.88
cc_1282 ( N_QN_c_1467_p N_noxref_7_c_2393_n ) capacitor c=0.00483671f \
 //x=17.525 //y=1.835 //x2=20.085 //y2=3.88
cc_1283 ( N_QN_c_1528_p N_noxref_7_c_2393_n ) capacitor c=0.00918155f \
 //x=17.88 //y=3.655 //x2=20.085 //y2=3.88
cc_1284 ( N_QN_c_1475_p N_noxref_7_c_2393_n ) capacitor c=0.00606007f \
 //x=19.73 //y=3.655 //x2=20.085 //y2=3.88
cc_1285 ( N_QN_c_1529_p N_noxref_7_c_2393_n ) capacitor c=0.0368432f //x=18.04 \
 //y=3.495 //x2=20.085 //y2=3.88
cc_1286 ( N_QN_c_1476_p N_noxref_7_c_2393_n ) capacitor c=0.0368432f //x=19.73 \
 //y=3.495 //x2=20.085 //y2=3.88
cc_1287 ( N_QN_c_1497_p N_noxref_7_c_2393_n ) capacitor c=0.139965f //x=19.57 \
 //y=3.495 //x2=20.085 //y2=3.88
cc_1288 ( QN N_noxref_7_c_2330_n ) capacitor c=0.00336755f //x=17.88 //y=4.62 \
 //x2=17.3 //y2=3.865
cc_1289 ( QN N_noxref_7_c_2333_n ) capacitor c=9.90728e-19 //x=17.88 //y=2.4 \
 //x2=17.14 //y2=2.26
cc_1290 ( QN N_noxref_7_c_2337_n ) capacitor c=7.76118e-19 //x=17.88 //y=4.62 \
 //x2=17.17 //y2=4.88
cc_1291 ( N_QN_c_1452_n N_noxref_7_c_2337_n ) capacitor c=0.00469257f \
 //x=17.285 //y=5.38 //x2=17.17 //y2=4.88
cc_1292 ( N_QN_c_1481_p N_noxref_7_c_2405_n ) capacitor c=0.00104426f \
 //x=19.73 //y=4.88 //x2=19.85 //y2=5.56
cc_1293 ( N_QN_c_1482_p N_noxref_7_c_2405_n ) capacitor c=0.00377369f \
 //x=19.73 //y=4.88 //x2=19.85 //y2=5.56
cc_1294 ( N_QN_M35_noxref_g N_noxref_7_c_2405_n ) capacitor c=0.0158358f \
 //x=19.63 //y=6.2 //x2=19.85 //y2=5.56
cc_1295 ( N_QN_M36_noxref_g N_noxref_7_c_2405_n ) capacitor c=0.0178987f \
 //x=20.07 //y=6.2 //x2=19.85 //y2=5.56
cc_1296 ( N_QN_c_1483_p N_noxref_7_c_2405_n ) capacitor c=0.0043218f //x=19.73 \
 //y=4.88 //x2=19.85 //y2=5.56
cc_1297 ( N_QN_c_1452_n N_noxref_7_M33_noxref_g ) capacitor c=0.00842859f \
 //x=17.285 //y=5.38 //x2=17.18 //y2=6.2
cc_1298 ( N_QN_c_1495_p N_noxref_7_M33_noxref_g ) capacitor c=0.00192712f \
 //x=17.4 //y=5.38 //x2=17.18 //y2=6.2
cc_1299 ( N_QN_c_1535_p N_noxref_7_M33_noxref_g ) capacitor c=0.0178987f \
 //x=17.4 //y=5.56 //x2=17.18 //y2=6.2
cc_1300 ( N_QN_c_1548_p N_noxref_7_M34_noxref_g ) capacitor c=0.0110279f \
 //x=17.795 //y=5.38 //x2=17.62 //y2=6.2
cc_1301 ( N_QN_c_1495_p N_noxref_7_M34_noxref_g ) capacitor c=0.00298276f \
 //x=17.4 //y=5.38 //x2=17.62 //y2=6.2
cc_1302 ( N_QN_c_1535_p N_noxref_7_M34_noxref_g ) capacitor c=0.0178506f \
 //x=17.4 //y=5.56 //x2=17.62 //y2=6.2
cc_1303 ( N_QN_c_1486_p N_noxref_7_c_2343_n ) capacitor c=0.00120406f \
 //x=17.44 //y=1.18 //x2=17.175 //y2=1.085
cc_1304 ( N_QN_M10_noxref_d N_noxref_7_c_2343_n ) capacitor c=0.00137165f \
 //x=17.25 //y=1.085 //x2=17.175 //y2=1.085
cc_1305 ( N_QN_c_1465_p N_noxref_7_c_2346_n ) capacitor c=0.00119008f \
 //x=17.44 //y=1.75 //x2=17.175 //y2=1.43
cc_1306 ( N_QN_c_1486_p N_noxref_7_c_2346_n ) capacitor c=0.00218694f \
 //x=17.44 //y=1.18 //x2=17.175 //y2=1.43
cc_1307 ( N_QN_M10_noxref_d N_noxref_7_c_2346_n ) capacitor c=0.00237422f \
 //x=17.25 //y=1.085 //x2=17.175 //y2=1.43
cc_1308 ( N_QN_c_1465_p N_noxref_7_c_2348_n ) capacitor c=0.00438634f \
 //x=17.44 //y=1.75 //x2=17.175 //y2=1.74
cc_1309 ( QN N_noxref_7_c_2422_n ) capacitor c=0.00845606f //x=17.88 //y=4.62 \
 //x2=17.545 //y2=4.97
cc_1310 ( N_QN_c_1495_p N_noxref_7_c_2422_n ) capacitor c=0.00183711f //x=17.4 \
 //y=5.38 //x2=17.545 //y2=4.97
cc_1311 ( N_QN_c_1535_p N_noxref_7_c_2422_n ) capacitor c=0.00291714f //x=17.4 \
 //y=5.56 //x2=17.545 //y2=4.97
cc_1312 ( N_QN_c_1486_p N_noxref_7_c_2425_n ) capacitor c=5.50523e-19 \
 //x=17.44 //y=1.18 //x2=17.55 //y2=0.93
cc_1313 ( N_QN_M10_noxref_d N_noxref_7_c_2425_n ) capacitor c=0.0020782f \
 //x=17.25 //y=1.085 //x2=17.55 //y2=0.93
cc_1314 ( N_QN_c_1465_p N_noxref_7_c_2427_n ) capacitor c=0.00916852f \
 //x=17.44 //y=1.75 //x2=17.55 //y2=1.585
cc_1315 ( N_QN_c_1541_p N_noxref_7_c_2427_n ) capacitor c=0.00194324f \
 //x=17.795 //y=1.835 //x2=17.55 //y2=1.585
cc_1316 ( N_QN_c_1486_p N_noxref_7_c_2427_n ) capacitor c=5.31395e-19 \
 //x=17.44 //y=1.18 //x2=17.55 //y2=1.585
cc_1317 ( N_QN_M10_noxref_d N_noxref_7_c_2427_n ) capacitor c=0.00356097f \
 //x=17.25 //y=1.085 //x2=17.55 //y2=1.585
cc_1318 ( N_QN_c_1486_p N_noxref_7_c_2351_n ) capacitor c=0.00109205f \
 //x=17.44 //y=1.18 //x2=17.705 //y2=1.085
cc_1319 ( N_QN_M10_noxref_d N_noxref_7_c_2351_n ) capacitor c=8.50095e-19 \
 //x=17.25 //y=1.085 //x2=17.705 //y2=1.085
cc_1320 ( N_QN_c_1465_p N_noxref_7_c_2352_n ) capacitor c=0.003249f //x=17.44 \
 //y=1.75 //x2=17.705 //y2=1.43
cc_1321 ( N_QN_c_1541_p N_noxref_7_c_2352_n ) capacitor c=0.00323005f \
 //x=17.795 //y=1.835 //x2=17.705 //y2=1.43
cc_1322 ( N_QN_c_1486_p N_noxref_7_c_2352_n ) capacitor c=0.00317092f \
 //x=17.44 //y=1.18 //x2=17.705 //y2=1.43
cc_1323 ( N_QN_M10_noxref_d N_noxref_7_c_2352_n ) capacitor c=0.00237422f \
 //x=17.25 //y=1.085 //x2=17.705 //y2=1.43
cc_1324 ( QN N_noxref_7_c_2353_n ) capacitor c=0.00281392f //x=17.88 //y=2.4 \
 //x2=17.14 //y2=2.26
cc_1325 ( QN N_noxref_7_c_2438_n ) capacitor c=0.00309058f //x=17.88 //y=2.4 \
 //x2=17.14 //y2=2.095
cc_1326 ( N_QN_c_1465_p N_noxref_7_c_2438_n ) capacitor c=0.00341114f \
 //x=17.44 //y=1.75 //x2=17.14 //y2=2.095
cc_1327 ( QN N_noxref_7_c_2356_n ) capacitor c=0.00142201f //x=17.88 //y=4.62 \
 //x2=17.17 //y2=4.88
cc_1328 ( N_QN_c_1452_n N_noxref_7_c_2356_n ) capacitor c=8.87334e-19 \
 //x=17.285 //y=5.38 //x2=17.17 //y2=4.88
cc_1329 ( N_QN_c_1452_n N_VDD_c_2586_n ) capacitor c=0.00648288f //x=17.285 \
 //y=5.38 //x2=21.58 //y2=7.58
cc_1330 ( N_QN_c_1548_p N_VDD_c_2586_n ) capacitor c=0.00492584f //x=17.795 \
 //y=5.38 //x2=21.58 //y2=7.58
cc_1331 ( N_QN_c_1528_p N_VDD_c_2586_n ) capacitor c=4.57419e-19 //x=17.88 \
 //y=3.655 //x2=21.58 //y2=7.58
cc_1332 ( N_QN_c_1453_n N_VDD_c_2586_n ) capacitor c=0.00368834f //x=16.52 \
 //y=5.56 //x2=21.58 //y2=7.58
cc_1333 ( N_QN_c_1495_p N_VDD_c_2586_n ) capacitor c=8.42537e-19 //x=17.4 \
 //y=5.38 //x2=21.58 //y2=7.58
cc_1334 ( N_QN_c_1551_p N_VDD_c_2586_n ) capacitor c=0.00285853f //x=17.4 \
 //y=5.56 //x2=21.58 //y2=7.58
cc_1335 ( N_QN_c_1481_p N_VDD_c_2586_n ) capacitor c=9.07241e-19 //x=19.73 \
 //y=4.88 //x2=21.58 //y2=7.58
cc_1336 ( N_QN_c_1459_n N_VDD_c_2586_n ) capacitor c=0.00224881f //x=16.52 \
 //y=5.56 //x2=21.58 //y2=7.58
cc_1337 ( N_QN_c_1535_p N_VDD_c_2586_n ) capacitor c=0.00224881f //x=17.4 \
 //y=5.56 //x2=21.58 //y2=7.58
cc_1338 ( N_QN_c_1482_p N_VDD_c_2586_n ) capacitor c=6.22888e-19 //x=19.73 \
 //y=4.88 //x2=21.58 //y2=7.58
cc_1339 ( N_QN_c_1452_n N_VDD_c_2746_n ) capacitor c=0.00208087f //x=17.285 \
 //y=5.38 //x2=16.875 //y2=7.585
cc_1340 ( N_QN_c_1453_n N_VDD_c_2746_n ) capacitor c=9.41185e-19 //x=16.52 \
 //y=5.56 //x2=16.875 //y2=7.585
cc_1341 ( N_QN_c_1459_n N_VDD_c_2746_n ) capacitor c=0.0136705f //x=16.52 \
 //y=5.56 //x2=16.875 //y2=7.585
cc_1342 ( N_QN_c_1452_n N_VDD_c_2793_n ) capacitor c=0.00180737f //x=17.285 \
 //y=5.38 //x2=17.755 //y2=7.585
cc_1343 ( N_QN_c_1548_p N_VDD_c_2793_n ) capacitor c=0.00208087f //x=17.795 \
 //y=5.38 //x2=17.755 //y2=7.585
cc_1344 ( N_QN_c_1495_p N_VDD_c_2793_n ) capacitor c=4.23719e-19 //x=17.4 \
 //y=5.38 //x2=17.755 //y2=7.585
cc_1345 ( N_QN_c_1551_p N_VDD_c_2793_n ) capacitor c=5.77976e-19 //x=17.4 \
 //y=5.56 //x2=17.755 //y2=7.585
cc_1346 ( N_QN_c_1535_p N_VDD_c_2793_n ) capacitor c=0.0136705f //x=17.4 \
 //y=5.56 //x2=17.755 //y2=7.585
cc_1347 ( N_QN_c_1481_p N_VDD_c_2798_n ) capacitor c=6.28113e-19 //x=19.73 \
 //y=4.88 //x2=20.205 //y2=7.585
cc_1348 ( N_QN_M35_noxref_g N_VDD_c_2798_n ) capacitor c=0.00732618f //x=19.63 \
 //y=6.2 //x2=20.205 //y2=7.585
cc_1349 ( N_QN_M36_noxref_g N_VDD_c_2798_n ) capacitor c=0.00755544f //x=20.07 \
 //y=6.2 //x2=20.205 //y2=7.585
cc_1350 ( QN N_VDD_c_2702_n ) capacitor c=0.0013228f //x=17.88 //y=4.62 \
 //x2=15.29 //y2=7.585
cc_1351 ( N_QN_c_1453_n N_VDD_c_2702_n ) capacitor c=4.91377e-19 //x=16.52 \
 //y=5.56 //x2=15.29 //y2=7.585
cc_1352 ( N_QN_c_1459_n N_VDD_c_2702_n ) capacitor c=0.0064135f //x=16.52 \
 //y=5.56 //x2=15.29 //y2=7.585
cc_1353 ( QN N_VDD_c_2804_n ) capacitor c=0.0303977f //x=17.88 //y=4.62 \
 //x2=18.62 //y2=7.585
cc_1354 ( QN N_VDD_c_2804_n ) capacitor c=0.00675188f //x=19.73 //y=4.62 \
 //x2=18.62 //y2=7.585
cc_1355 ( N_QN_c_1495_p N_VDD_c_2804_n ) capacitor c=0.00240948f //x=17.4 \
 //y=5.38 //x2=18.62 //y2=7.585
cc_1356 ( N_QN_c_1551_p N_VDD_c_2804_n ) capacitor c=4.09141e-19 //x=17.4 \
 //y=5.56 //x2=18.62 //y2=7.585
cc_1357 ( N_QN_c_1481_p N_VDD_c_2804_n ) capacitor c=0.00447349f //x=19.73 \
 //y=4.88 //x2=18.62 //y2=7.585
cc_1358 ( N_QN_c_1535_p N_VDD_c_2804_n ) capacitor c=0.0101861f //x=17.4 \
 //y=5.56 //x2=18.62 //y2=7.585
cc_1359 ( N_QN_c_1482_p N_VDD_c_2804_n ) capacitor c=0.00370494f //x=19.73 \
 //y=4.88 //x2=18.62 //y2=7.585
cc_1360 ( N_QN_c_1483_p N_VDD_c_2804_n ) capacitor c=0.0129564f //x=19.73 \
 //y=4.88 //x2=18.62 //y2=7.585
cc_1361 ( N_QN_c_1453_n N_VDD_M31_noxref_s ) capacitor c=0.0572211f //x=16.52 \
 //y=5.56 //x2=15.945 //y2=5.2
cc_1362 ( N_QN_c_1495_p N_VDD_M31_noxref_s ) capacitor c=6.52457e-19 //x=17.4 \
 //y=5.38 //x2=15.945 //y2=5.2
cc_1363 ( N_QN_c_1459_n N_VDD_M31_noxref_s ) capacitor c=0.0887533f //x=16.52 \
 //y=5.56 //x2=15.945 //y2=5.2
cc_1364 ( N_QN_c_1452_n N_VDD_M32_noxref_d ) capacitor c=0.00734094f \
 //x=17.285 //y=5.38 //x2=16.815 //y2=5.2
cc_1365 ( N_QN_c_1453_n N_VDD_M32_noxref_d ) capacitor c=0.0043528f //x=16.52 \
 //y=5.56 //x2=16.815 //y2=5.2
cc_1366 ( N_QN_c_1551_p N_VDD_M32_noxref_d ) capacitor c=0.0043528f //x=17.4 \
 //y=5.56 //x2=16.815 //y2=5.2
cc_1367 ( N_QN_c_1459_n N_VDD_M32_noxref_d ) capacitor c=0.065554f //x=16.52 \
 //y=5.56 //x2=16.815 //y2=5.2
cc_1368 ( N_QN_c_1535_p N_VDD_M32_noxref_d ) capacitor c=0.065554f //x=17.4 \
 //y=5.56 //x2=16.815 //y2=5.2
cc_1369 ( QN N_VDD_M34_noxref_d ) capacitor c=9.65951e-19 //x=17.88 //y=3.51 \
 //x2=17.695 //y2=5.2
cc_1370 ( N_QN_c_1548_p N_VDD_M34_noxref_d ) capacitor c=0.00934027f \
 //x=17.795 //y=5.38 //x2=17.695 //y2=5.2
cc_1371 ( N_QN_c_1551_p N_VDD_M34_noxref_d ) capacitor c=0.00587834f //x=17.4 \
 //y=5.56 //x2=17.695 //y2=5.2
cc_1372 ( N_QN_c_1535_p N_VDD_M34_noxref_d ) capacitor c=0.065554f //x=17.4 \
 //y=5.56 //x2=17.695 //y2=5.2
cc_1373 ( N_QN_c_1548_p N_VDD_M35_noxref_s ) capacitor c=0.00326953f \
 //x=17.795 //y=5.38 //x2=19.275 //y2=5.2
cc_1374 ( N_QN_c_1475_p N_VDD_M35_noxref_s ) capacitor c=0.00112123f //x=19.73 \
 //y=3.655 //x2=19.275 //y2=5.2
cc_1375 ( N_QN_c_1495_p N_VDD_M35_noxref_s ) capacitor c=0.00515461f //x=17.4 \
 //y=5.38 //x2=19.275 //y2=5.2
cc_1376 ( N_QN_c_1551_p N_VDD_M35_noxref_s ) capacitor c=3.28075e-19 //x=17.4 \
 //y=5.56 //x2=19.275 //y2=5.2
cc_1377 ( N_QN_M35_noxref_g N_VDD_M35_noxref_s ) capacitor c=0.0567929f \
 //x=19.63 //y=6.2 //x2=19.275 //y2=5.2
cc_1378 ( N_QN_M36_noxref_g N_VDD_M36_noxref_d ) capacitor c=0.015318f \
 //x=20.07 //y=6.2 //x2=20.145 //y2=5.2
cc_1379 ( N_QN_c_1541_p N_GND_c_3301_n ) capacitor c=0.00654514f //x=17.795 \
 //y=1.835 //x2=19.715 //y2=0.175
cc_1380 ( N_QN_c_1528_p N_GND_c_3301_n ) capacitor c=4.5339e-19 //x=17.88 \
 //y=3.655 //x2=19.715 //y2=0.175
cc_1381 ( N_QN_c_1486_p N_GND_c_3301_n ) capacitor c=0.00964814f //x=17.44 \
 //y=1.18 //x2=19.715 //y2=0.175
cc_1382 ( N_QN_M10_noxref_d N_GND_c_3301_n ) capacitor c=3.01769e-19 //x=17.25 \
 //y=1.085 //x2=19.715 //y2=0.175
cc_1383 ( N_QN_c_1453_n N_GND_c_3259_n ) capacitor c=6.12504e-19 //x=16.52 \
 //y=5.56 //x2=16.47 //y2=1.135
cc_1384 ( N_QN_c_1486_p N_GND_c_3259_n ) capacitor c=0.0140087f //x=17.44 \
 //y=1.18 //x2=16.47 //y2=1.135
cc_1385 ( N_QN_M10_noxref_d N_GND_c_3259_n ) capacitor c=2.93544e-19 //x=17.25 \
 //y=1.085 //x2=16.47 //y2=1.135
cc_1386 ( N_QN_c_1486_p N_GND_c_3308_n ) capacitor c=0.00549186f //x=17.44 \
 //y=1.18 //x2=19.8 //y2=1.135
cc_1387 ( N_QN_c_1488_p N_GND_c_3308_n ) capacitor c=0.00689142f //x=19.73 \
 //y=2.26 //x2=19.8 //y2=1.135
cc_1388 ( N_QN_c_1476_p N_GND_c_3308_n ) capacitor c=0.00228578f //x=19.73 \
 //y=3.495 //x2=19.8 //y2=1.135
cc_1389 ( N_QN_c_1477_p N_GND_c_3308_n ) capacitor c=2.13705e-19 //x=19.73 \
 //y=2.26 //x2=19.8 //y2=1.135
cc_1390 ( N_QN_c_1508_p N_GND_c_3308_n ) capacitor c=0.00171023f //x=19.535 \
 //y=1.045 //x2=19.8 //y2=1.135
cc_1391 ( N_QN_c_1509_p N_GND_c_3308_n ) capacitor c=0.00357815f //x=19.535 \
 //y=1.39 //x2=19.8 //y2=1.135
cc_1392 ( N_QN_c_1511_p N_GND_c_3308_n ) capacitor c=4.2764e-19 //x=19.535 \
 //y=1.7 //x2=19.8 //y2=1.135
cc_1393 ( N_QN_c_1671_p N_GND_c_3308_n ) capacitor c=7.35788e-19 //x=19.91 \
 //y=0.89 //x2=19.8 //y2=1.135
cc_1394 ( N_QN_c_1672_p N_GND_c_3308_n ) capacitor c=6.27314e-19 //x=19.91 \
 //y=1.545 //x2=19.8 //y2=1.135
cc_1395 ( N_QN_c_1510_p N_GND_c_3308_n ) capacitor c=0.00158609f //x=20.065 \
 //y=1.045 //x2=19.8 //y2=1.135
cc_1396 ( N_QN_c_1512_p N_GND_c_3308_n ) capacitor c=0.00296337f //x=20.065 \
 //y=1.39 //x2=19.8 //y2=1.135
cc_1397 ( N_QN_c_1508_p N_GND_c_3319_n ) capacitor c=3.46594e-19 //x=19.535 \
 //y=1.045 //x2=19.797 //y2=1.005
cc_1398 ( N_QN_c_1671_p N_GND_c_3319_n ) capacitor c=0.00852202f //x=19.91 \
 //y=0.89 //x2=19.797 //y2=1.005
cc_1399 ( N_QN_c_1510_p N_GND_c_3319_n ) capacitor c=4.45447e-19 //x=20.065 \
 //y=1.045 //x2=19.797 //y2=1.005
cc_1400 ( N_QN_c_1541_p N_GND_c_3273_n ) capacitor c=7.75992e-19 //x=17.795 \
 //y=1.835 //x2=18.45 //y2=0.175
cc_1401 ( N_QN_c_1528_p N_GND_c_3273_n ) capacitor c=3.21953e-19 //x=17.88 \
 //y=3.655 //x2=18.45 //y2=0.175
cc_1402 ( N_QN_c_1486_p N_GND_c_3173_n ) capacitor c=2.83275e-19 //x=17.44 \
 //y=1.18 //x2=21.58 //y2=0.18
cc_1403 ( N_QN_c_1508_p N_GND_c_3173_n ) capacitor c=0.00691994f //x=19.535 \
 //y=1.045 //x2=21.58 //y2=0.18
cc_1404 ( QN N_GND_c_3239_n ) capacitor c=9.32616e-19 //x=17.88 //y=2.4 \
 //x2=15.29 //y2=0.175
cc_1405 ( QN N_GND_c_3327_n ) capacitor c=0.00829739f //x=19.73 //y=2.77 \
 //x2=18.62 //y2=0.175
cc_1406 ( N_QN_c_1465_p N_GND_c_3327_n ) capacitor c=0.002973f //x=17.44 \
 //y=1.75 //x2=18.62 //y2=0.175
cc_1407 ( N_QN_c_1541_p N_GND_c_3327_n ) capacitor c=0.0300121f //x=17.795 \
 //y=1.835 //x2=18.62 //y2=0.175
cc_1408 ( N_QN_c_1488_p N_GND_c_3327_n ) capacitor c=0.00427323f //x=19.73 \
 //y=2.26 //x2=18.62 //y2=0.175
cc_1409 ( N_QN_c_1497_p N_GND_c_3327_n ) capacitor c=0.00560367f //x=19.57 \
 //y=3.495 //x2=18.62 //y2=0.175
cc_1410 ( N_QN_c_1477_p N_GND_c_3327_n ) capacitor c=0.0038607f //x=19.73 \
 //y=2.26 //x2=18.62 //y2=0.175
cc_1411 ( N_QN_c_1511_p N_GND_c_3327_n ) capacitor c=0.0015404f //x=19.535 \
 //y=1.7 //x2=18.62 //y2=0.175
cc_1412 ( N_QN_c_1490_p N_GND_c_3327_n ) capacitor c=0.00906518f //x=19.535 \
 //y=2.095 //x2=18.62 //y2=0.175
cc_1413 ( N_QN_c_1486_p N_GND_M9_noxref_d ) capacitor c=2.82748e-19 //x=17.44 \
 //y=1.18 //x2=16.28 //y2=1.045
cc_1414 ( N_QN_c_1488_p N_GND_M11_noxref_d ) capacitor c=2.20438e-19 //x=19.73 \
 //y=2.26 //x2=19.61 //y2=1.045
cc_1415 ( N_QN_c_1508_p N_GND_M11_noxref_d ) capacitor c=0.00192399f \
 //x=19.535 //y=1.045 //x2=19.61 //y2=1.045
cc_1416 ( N_QN_c_1509_p N_GND_M11_noxref_d ) capacitor c=0.00210798f \
 //x=19.535 //y=1.39 //x2=19.61 //y2=1.045
cc_1417 ( N_QN_c_1671_p N_GND_M11_noxref_d ) capacitor c=0.00472259f //x=19.91 \
 //y=0.89 //x2=19.61 //y2=1.045
cc_1418 ( N_QN_c_1672_p N_GND_M11_noxref_d ) capacitor c=0.00166857f //x=19.91 \
 //y=1.545 //x2=19.61 //y2=1.045
cc_1419 ( N_QN_c_1510_p N_GND_M11_noxref_d ) capacitor c=0.00230174f \
 //x=20.065 //y=1.045 //x2=19.61 //y2=1.045
cc_1420 ( N_QN_c_1512_p N_GND_M11_noxref_d ) capacitor c=0.00210798f \
 //x=20.065 //y=1.39 //x2=19.61 //y2=1.045
cc_1421 ( N_QN_c_1467_p N_noxref_16_c_3836_n ) capacitor c=0.00911498f \
 //x=17.525 //y=1.835 //x2=16.955 //y2=1.675
cc_1422 ( N_QN_c_1541_p N_noxref_16_c_3841_n ) capacitor c=0.00373013f \
 //x=17.795 //y=1.835 //x2=17.84 //y2=0.71
cc_1423 ( N_QN_c_1486_p N_noxref_16_c_3841_n ) capacitor c=0.003751f //x=17.44 \
 //y=1.18 //x2=17.84 //y2=0.71
cc_1424 ( N_QN_M10_noxref_d N_noxref_16_c_3841_n ) capacitor c=0.00910163f \
 //x=17.25 //y=1.085 //x2=17.84 //y2=0.71
cc_1425 ( QN N_noxref_16_M9_noxref_s ) capacitor c=0.0010514f //x=17.88 \
 //y=3.51 //x2=15.85 //y2=0.545
cc_1426 ( N_QN_c_1465_p N_noxref_16_M9_noxref_s ) capacitor c=0.0162484f \
 //x=17.44 //y=1.75 //x2=15.85 //y2=0.545
cc_1427 ( N_QN_c_1541_p N_noxref_16_M9_noxref_s ) capacitor c=0.00640979f \
 //x=17.795 //y=1.835 //x2=15.85 //y2=0.545
cc_1428 ( N_QN_c_1528_p N_noxref_16_M9_noxref_s ) capacitor c=4.21826e-19 \
 //x=17.88 //y=3.655 //x2=15.85 //y2=0.545
cc_1429 ( N_QN_c_1486_p N_noxref_16_M9_noxref_s ) capacitor c=0.00905169f \
 //x=17.44 //y=1.18 //x2=15.85 //y2=0.545
cc_1430 ( N_QN_M10_noxref_d N_noxref_16_M9_noxref_s ) capacitor c=0.0275552f \
 //x=17.25 //y=1.085 //x2=15.85 //y2=0.545
cc_1431 ( N_QN_c_1497_p N_noxref_17_c_3892_n ) capacitor c=0.00264481f \
 //x=19.57 //y=3.495 //x2=19.315 //y2=1.675
cc_1432 ( N_QN_c_1490_p N_noxref_17_c_3892_n ) capacitor c=0.00262672f \
 //x=19.535 //y=2.095 //x2=19.315 //y2=1.675
cc_1433 ( N_QN_c_1475_p N_noxref_17_c_3894_n ) capacitor c=0.00407464f \
 //x=19.73 //y=3.655 //x2=20.2 //y2=1.76
cc_1434 ( N_QN_c_1488_p N_noxref_17_c_3894_n ) capacitor c=0.00509504f \
 //x=19.73 //y=2.26 //x2=20.2 //y2=1.76
cc_1435 ( N_QN_c_1497_p N_noxref_17_c_3894_n ) capacitor c=9.85544e-19 \
 //x=19.57 //y=3.495 //x2=20.2 //y2=1.76
cc_1436 ( N_QN_c_1477_p N_noxref_17_c_3894_n ) capacitor c=0.00763108f \
 //x=19.73 //y=2.26 //x2=20.2 //y2=1.76
cc_1437 ( N_QN_c_1511_p N_noxref_17_c_3894_n ) capacitor c=0.00697076f \
 //x=19.535 //y=1.7 //x2=20.2 //y2=1.76
cc_1438 ( N_QN_c_1490_p N_noxref_17_c_3894_n ) capacitor c=0.0180049f \
 //x=19.535 //y=2.095 //x2=20.2 //y2=1.76
cc_1439 ( N_QN_c_1672_p N_noxref_17_c_3894_n ) capacitor c=0.00723574f \
 //x=19.91 //y=1.545 //x2=20.2 //y2=1.76
cc_1440 ( N_QN_c_1512_p N_noxref_17_c_3894_n ) capacitor c=0.00339872f \
 //x=20.065 //y=1.39 //x2=20.2 //y2=1.76
cc_1441 ( N_QN_c_1490_p N_noxref_17_c_3902_n ) capacitor c=6.71402e-19 \
 //x=19.535 //y=2.095 //x2=20.285 //y2=1.675
cc_1442 ( N_QN_c_1508_p N_noxref_17_M11_noxref_s ) capacitor c=0.0294925f \
 //x=19.535 //y=1.045 //x2=19.18 //y2=0.545
cc_1443 ( N_QN_c_1511_p N_noxref_17_M11_noxref_s ) capacitor c=3.48408e-19 \
 //x=19.535 //y=1.7 //x2=19.18 //y2=0.545
cc_1444 ( N_QN_c_1510_p N_noxref_17_M11_noxref_s ) capacitor c=0.0125442f \
 //x=20.065 //y=1.045 //x2=19.18 //y2=0.545
cc_1445 ( N_noxref_6_c_1796_n N_noxref_7_c_2313_n ) capacitor c=0.00278348f \
 //x=14.55 //y=4.105 //x2=17.14 //y2=3.705
cc_1446 ( N_noxref_6_c_1998_n N_noxref_7_c_2315_n ) capacitor c=0.00533115f \
 //x=16.615 //y=4.27 //x2=17.14 //y2=4.025
cc_1447 ( N_noxref_6_c_1799_n N_noxref_7_c_2319_n ) capacitor c=0.00130218f \
 //x=14.55 //y=5.295 //x2=17.14 //y2=4.735
cc_1448 ( N_noxref_6_c_1998_n N_noxref_7_c_2319_n ) capacitor c=0.0266789f \
 //x=16.615 //y=4.27 //x2=17.14 //y2=4.735
cc_1449 ( N_noxref_6_c_2024_n N_noxref_7_c_2374_n ) capacitor c=0.00425321f \
 //x=20.47 //y=4.41 //x2=20.615 //y2=5.38
cc_1450 ( N_noxref_6_c_2025_n N_noxref_7_c_2374_n ) capacitor c=0.0222527f \
 //x=20.47 //y=4.735 //x2=20.615 //y2=5.38
cc_1451 ( N_noxref_6_c_1998_n N_noxref_7_c_2374_n ) capacitor c=0.00277534f \
 //x=16.615 //y=4.27 //x2=20.615 //y2=5.38
cc_1452 ( N_noxref_6_c_2048_n N_noxref_7_c_2374_n ) capacitor c=0.00469257f \
 //x=20.5 //y=4.88 //x2=20.615 //y2=5.38
cc_1453 ( N_noxref_6_M37_noxref_g N_noxref_7_c_2374_n ) capacitor \
 c=0.00842859f //x=20.51 //y=6.2 //x2=20.615 //y2=5.38
cc_1454 ( N_noxref_6_c_2067_n N_noxref_7_c_2374_n ) capacitor c=8.42507e-19 \
 //x=20.5 //y=4.88 //x2=20.615 //y2=5.38
cc_1455 ( N_noxref_6_c_2057_n N_noxref_7_c_2375_n ) capacitor c=0.00119008f \
 //x=20.505 //y=1.43 //x2=20.77 //y2=1.75
cc_1456 ( N_noxref_6_c_2059_n N_noxref_7_c_2375_n ) capacitor c=0.00438634f \
 //x=20.505 //y=1.74 //x2=20.77 //y2=1.75
cc_1457 ( N_noxref_6_c_2082_p N_noxref_7_c_2375_n ) capacitor c=0.00929259f \
 //x=20.88 //y=1.585 //x2=20.77 //y2=1.75
cc_1458 ( N_noxref_6_c_2063_n N_noxref_7_c_2375_n ) capacitor c=0.00341295f \
 //x=21.035 //y=1.43 //x2=20.77 //y2=1.75
cc_1459 ( N_noxref_6_c_2084_p N_noxref_7_c_2375_n ) capacitor c=0.00341114f \
 //x=20.47 //y=2.095 //x2=20.77 //y2=1.75
cc_1460 ( N_noxref_6_M38_noxref_g N_noxref_7_c_2457_n ) capacitor c=0.0110849f \
 //x=20.95 //y=6.2 //x2=21.125 //y2=5.38
cc_1461 ( N_noxref_6_c_2082_p N_noxref_7_c_2458_n ) capacitor c=0.00194324f \
 //x=20.88 //y=1.585 //x2=21.125 //y2=1.835
cc_1462 ( N_noxref_6_c_2063_n N_noxref_7_c_2458_n ) capacitor c=0.00323005f \
 //x=21.035 //y=1.43 //x2=21.125 //y2=1.835
cc_1463 ( N_noxref_6_c_2016_n N_noxref_7_c_2377_n ) capacitor c=0.060194f \
 //x=20.47 //y=4.09 //x2=21.21 //y2=3.705
cc_1464 ( N_noxref_6_c_2034_n N_noxref_7_c_2377_n ) capacitor c=0.015397f \
 //x=20.47 //y=2.26 //x2=21.21 //y2=3.705
cc_1465 ( N_noxref_6_c_2044_n N_noxref_7_c_2377_n ) capacitor c=0.00440663f \
 //x=20.47 //y=2.26 //x2=21.21 //y2=3.705
cc_1466 ( N_noxref_6_c_2064_n N_noxref_7_c_2377_n ) capacitor c=0.00281392f \
 //x=20.47 //y=2.26 //x2=21.21 //y2=3.705
cc_1467 ( N_noxref_6_c_2084_p N_noxref_7_c_2377_n ) capacitor c=0.00309058f \
 //x=20.47 //y=2.095 //x2=21.21 //y2=3.705
cc_1468 ( N_noxref_6_c_2016_n N_noxref_7_c_2465_n ) capacitor c=0.0178478f \
 //x=20.47 //y=4.09 //x2=21.21 //y2=4.025
cc_1469 ( N_noxref_6_c_2094_p N_noxref_7_c_2465_n ) capacitor c=0.00127572f \
 //x=20.875 //y=4.97 //x2=21.21 //y2=4.025
cc_1470 ( N_noxref_6_c_2016_n N_noxref_7_c_2379_n ) capacitor c=0.00290911f \
 //x=20.47 //y=4.09 //x2=21.21 //y2=5.295
cc_1471 ( N_noxref_6_c_2024_n N_noxref_7_c_2379_n ) capacitor c=0.0149195f \
 //x=20.47 //y=4.41 //x2=21.21 //y2=5.295
cc_1472 ( N_noxref_6_c_2025_n N_noxref_7_c_2379_n ) capacitor c=0.0311001f \
 //x=20.47 //y=4.735 //x2=21.21 //y2=5.295
cc_1473 ( N_noxref_6_c_2033_n N_noxref_7_c_2379_n ) capacitor c=0.00462354f \
 //x=20.47 //y=4.25 //x2=21.21 //y2=5.295
cc_1474 ( N_noxref_6_c_1998_n N_noxref_7_c_2379_n ) capacitor c=0.00686844f \
 //x=16.615 //y=4.27 //x2=21.21 //y2=5.295
cc_1475 ( N_noxref_6_c_2048_n N_noxref_7_c_2379_n ) capacitor c=0.00448306f \
 //x=20.5 //y=4.88 //x2=21.21 //y2=5.295
cc_1476 ( N_noxref_6_c_2094_p N_noxref_7_c_2379_n ) capacitor c=0.00845606f \
 //x=20.875 //y=4.97 //x2=21.21 //y2=5.295
cc_1477 ( N_noxref_6_c_2067_n N_noxref_7_c_2379_n ) capacitor c=0.00142201f \
 //x=20.5 //y=4.88 //x2=21.21 //y2=5.295
cc_1478 ( N_noxref_6_c_1998_n N_noxref_7_c_2383_n ) capacitor c=0.0133502f \
 //x=16.615 //y=4.27 //x2=19.85 //y2=5.56
cc_1479 ( N_noxref_6_c_1998_n N_noxref_7_c_2476_n ) capacitor c=2.42699e-19 \
 //x=16.615 //y=4.27 //x2=20.73 //y2=5.38
cc_1480 ( N_noxref_6_M37_noxref_g N_noxref_7_c_2476_n ) capacitor \
 c=0.00192712f //x=20.51 //y=6.2 //x2=20.73 //y2=5.38
cc_1481 ( N_noxref_6_M38_noxref_g N_noxref_7_c_2476_n ) capacitor \
 c=0.00362563f //x=20.95 //y=6.2 //x2=20.73 //y2=5.38
cc_1482 ( N_noxref_6_c_2094_p N_noxref_7_c_2476_n ) capacitor c=0.0020909f \
 //x=20.875 //y=4.97 //x2=20.73 //y2=5.38
cc_1483 ( N_noxref_6_c_2054_n N_noxref_7_c_2392_n ) capacitor c=0.00120406f \
 //x=20.505 //y=1.085 //x2=20.77 //y2=1.18
cc_1484 ( N_noxref_6_c_2057_n N_noxref_7_c_2392_n ) capacitor c=0.00218694f \
 //x=20.505 //y=1.43 //x2=20.77 //y2=1.18
cc_1485 ( N_noxref_6_c_2110_p N_noxref_7_c_2392_n ) capacitor c=5.50523e-19 \
 //x=20.88 //y=0.93 //x2=20.77 //y2=1.18
cc_1486 ( N_noxref_6_c_2082_p N_noxref_7_c_2392_n ) capacitor c=5.67071e-19 \
 //x=20.88 //y=1.585 //x2=20.77 //y2=1.18
cc_1487 ( N_noxref_6_c_2062_n N_noxref_7_c_2392_n ) capacitor c=0.00121175f \
 //x=21.035 //y=1.085 //x2=20.77 //y2=1.18
cc_1488 ( N_noxref_6_c_2063_n N_noxref_7_c_2392_n ) capacitor c=0.00366282f \
 //x=21.035 //y=1.43 //x2=20.77 //y2=1.18
cc_1489 ( N_noxref_6_c_2016_n N_noxref_7_c_2486_n ) capacitor c=9.19401e-19 \
 //x=20.47 //y=4.09 //x2=21.21 //y2=3.88
cc_1490 ( N_noxref_6_c_2016_n N_noxref_7_c_2393_n ) capacitor c=3.11404e-19 \
 //x=20.47 //y=4.09 //x2=20.085 //y2=3.88
cc_1491 ( N_noxref_6_c_2024_n N_noxref_7_c_2393_n ) capacitor c=0.00207445f \
 //x=20.47 //y=4.41 //x2=20.085 //y2=3.88
cc_1492 ( N_noxref_6_c_1998_n N_noxref_7_c_2393_n ) capacitor c=0.272812f \
 //x=16.615 //y=4.27 //x2=20.085 //y2=3.88
cc_1493 ( N_noxref_6_c_2016_n N_noxref_7_c_2490_n ) capacitor c=0.0274842f \
 //x=20.47 //y=4.09 //x2=20.685 //y2=3.865
cc_1494 ( N_noxref_6_c_2024_n N_noxref_7_c_2490_n ) capacitor c=0.00450608f \
 //x=20.47 //y=4.41 //x2=20.685 //y2=3.865
cc_1495 ( N_noxref_6_c_2034_n N_noxref_7_c_2490_n ) capacitor c=0.00161531f \
 //x=20.47 //y=2.26 //x2=20.685 //y2=3.865
cc_1496 ( N_noxref_6_c_1998_n N_noxref_7_c_2490_n ) capacitor c=0.0374977f \
 //x=16.615 //y=4.27 //x2=20.685 //y2=3.865
cc_1497 ( N_noxref_6_c_1998_n N_noxref_7_c_2330_n ) capacitor c=0.0374977f \
 //x=16.615 //y=4.27 //x2=17.3 //y2=3.865
cc_1498 ( N_noxref_6_M37_noxref_g N_noxref_7_c_2495_n ) capacitor c=0.0178987f \
 //x=20.51 //y=6.2 //x2=20.73 //y2=5.56
cc_1499 ( N_noxref_6_M38_noxref_g N_noxref_7_c_2495_n ) capacitor c=0.0178506f \
 //x=20.95 //y=6.2 //x2=20.73 //y2=5.56
cc_1500 ( N_noxref_6_c_2094_p N_noxref_7_c_2495_n ) capacitor c=0.00291714f \
 //x=20.875 //y=4.97 //x2=20.73 //y2=5.56
cc_1501 ( N_noxref_6_c_2054_n N_noxref_7_M12_noxref_d ) capacitor \
 c=0.00137165f //x=20.505 //y=1.085 //x2=20.58 //y2=1.085
cc_1502 ( N_noxref_6_c_2057_n N_noxref_7_M12_noxref_d ) capacitor \
 c=0.00237422f //x=20.505 //y=1.43 //x2=20.58 //y2=1.085
cc_1503 ( N_noxref_6_c_2110_p N_noxref_7_M12_noxref_d ) capacitor c=0.0020782f \
 //x=20.88 //y=0.93 //x2=20.58 //y2=1.085
cc_1504 ( N_noxref_6_c_2082_p N_noxref_7_M12_noxref_d ) capacitor \
 c=0.00356097f //x=20.88 //y=1.585 //x2=20.58 //y2=1.085
cc_1505 ( N_noxref_6_c_2062_n N_noxref_7_M12_noxref_d ) capacitor \
 c=8.50095e-19 //x=21.035 //y=1.085 //x2=20.58 //y2=1.085
cc_1506 ( N_noxref_6_c_2063_n N_noxref_7_M12_noxref_d ) capacitor \
 c=0.00237422f //x=21.035 //y=1.43 //x2=20.58 //y2=1.085
cc_1507 ( N_noxref_6_c_1862_n N_VDD_c_2586_n ) capacitor c=3.71096e-19 //x=1.6 \
 //y=4.415 //x2=21.58 //y2=7.58
cc_1508 ( N_noxref_6_c_1793_n N_VDD_c_2586_n ) capacitor c=0.00648294f \
 //x=13.955 //y=5.38 //x2=21.58 //y2=7.58
cc_1509 ( N_noxref_6_c_1882_n N_VDD_c_2586_n ) capacitor c=0.00492568f \
 //x=14.465 //y=5.38 //x2=21.58 //y2=7.58
cc_1510 ( N_noxref_6_c_1803_n N_VDD_c_2586_n ) capacitor c=0.00368834f \
 //x=13.19 //y=5.56 //x2=21.58 //y2=7.58
cc_1511 ( N_noxref_6_c_1899_n N_VDD_c_2586_n ) capacitor c=8.42537e-19 \
 //x=14.07 //y=5.38 //x2=21.58 //y2=7.58
cc_1512 ( N_noxref_6_c_2031_n N_VDD_c_2586_n ) capacitor c=0.00285853f \
 //x=14.07 //y=5.56 //x2=21.58 //y2=7.58
cc_1513 ( N_noxref_6_c_1908_n N_VDD_c_2586_n ) capacitor c=3.84946e-19 \
 //x=14.55 //y=4.25 //x2=21.58 //y2=7.58
cc_1514 ( N_noxref_6_c_1820_n N_VDD_c_2586_n ) capacitor c=0.00224881f \
 //x=13.19 //y=5.56 //x2=21.58 //y2=7.58
cc_1515 ( N_noxref_6_c_1929_n N_VDD_c_2586_n ) capacitor c=0.00224881f \
 //x=14.07 //y=5.56 //x2=21.58 //y2=7.58
cc_1516 ( N_noxref_6_c_1862_n N_VDD_c_2693_n ) capacitor c=0.00179679f //x=1.6 \
 //y=4.415 //x2=1.23 //y2=7.58
cc_1517 ( N_noxref_6_c_1725_n N_VDD_c_2693_n ) capacitor c=0.0158335f //x=1.6 \
 //y=4.755 //x2=1.23 //y2=7.58
cc_1518 ( N_noxref_6_c_1897_n N_VDD_c_2693_n ) capacitor c=0.00229699f //x=1.6 \
 //y=4.25 //x2=1.23 //y2=7.58
cc_1519 ( N_noxref_6_c_1926_n N_VDD_c_2693_n ) capacitor c=0.00371026f //x=1.6 \
 //y=4.88 //x2=1.23 //y2=7.58
cc_1520 ( N_noxref_6_c_1950_n N_VDD_c_2693_n ) capacitor c=0.00587308f \
 //x=1.875 //y=4.97 //x2=1.23 //y2=7.58
cc_1521 ( N_noxref_6_c_1862_n N_VDD_c_2731_n ) capacitor c=3.24023e-19 //x=1.6 \
 //y=4.415 //x2=2.375 //y2=7.585
cc_1522 ( N_noxref_6_M13_noxref_g N_VDD_c_2731_n ) capacitor c=0.00755614f \
 //x=1.8 //y=6.2 //x2=2.375 //y2=7.585
cc_1523 ( N_noxref_6_M14_noxref_g N_VDD_c_2731_n ) capacitor c=0.00755544f \
 //x=2.24 //y=6.2 //x2=2.375 //y2=7.585
cc_1524 ( N_noxref_6_M25_noxref_g N_VDD_c_2656_n ) capacitor c=0.00697352f \
 //x=10.52 //y=6.2 //x2=11.095 //y2=7.585
cc_1525 ( N_noxref_6_M26_noxref_g N_VDD_c_2656_n ) capacitor c=0.00755544f \
 //x=10.96 //y=6.2 //x2=11.095 //y2=7.585
cc_1526 ( N_noxref_6_c_1793_n N_VDD_c_2661_n ) capacitor c=0.00208087f \
 //x=13.955 //y=5.38 //x2=13.545 //y2=7.585
cc_1527 ( N_noxref_6_c_1803_n N_VDD_c_2661_n ) capacitor c=9.41185e-19 \
 //x=13.19 //y=5.56 //x2=13.545 //y2=7.585
cc_1528 ( N_noxref_6_c_1820_n N_VDD_c_2661_n ) capacitor c=0.0136705f \
 //x=13.19 //y=5.56 //x2=13.545 //y2=7.585
cc_1529 ( N_noxref_6_c_1793_n N_VDD_c_2696_n ) capacitor c=0.00180737f \
 //x=13.955 //y=5.38 //x2=14.425 //y2=7.585
cc_1530 ( N_noxref_6_c_1882_n N_VDD_c_2696_n ) capacitor c=0.00208087f \
 //x=14.465 //y=5.38 //x2=14.425 //y2=7.585
cc_1531 ( N_noxref_6_c_1899_n N_VDD_c_2696_n ) capacitor c=4.23719e-19 \
 //x=14.07 //y=5.38 //x2=14.425 //y2=7.585
cc_1532 ( N_noxref_6_c_2031_n N_VDD_c_2696_n ) capacitor c=5.77976e-19 \
 //x=14.07 //y=5.56 //x2=14.425 //y2=7.585
cc_1533 ( N_noxref_6_c_1929_n N_VDD_c_2696_n ) capacitor c=0.0136705f \
 //x=14.07 //y=5.56 //x2=14.425 //y2=7.585
cc_1534 ( N_noxref_6_M37_noxref_g N_VDD_c_2857_n ) capacitor c=0.00697352f \
 //x=20.51 //y=6.2 //x2=21.085 //y2=7.585
cc_1535 ( N_noxref_6_M38_noxref_g N_VDD_c_2857_n ) capacitor c=0.00755544f \
 //x=20.95 //y=6.2 //x2=21.085 //y2=7.585
cc_1536 ( N_noxref_6_c_2033_n N_VDD_c_2859_n ) capacitor c=0.00143077f \
 //x=20.47 //y=4.25 //x2=21.58 //y2=7.58
cc_1537 ( N_noxref_6_c_2048_n N_VDD_c_2859_n ) capacitor c=0.00226427f \
 //x=20.5 //y=4.88 //x2=21.58 //y2=7.58
cc_1538 ( N_noxref_6_c_2094_p N_VDD_c_2859_n ) capacitor c=0.0235217f \
 //x=20.875 //y=4.97 //x2=21.58 //y2=7.58
cc_1539 ( N_noxref_6_c_2067_n N_VDD_c_2859_n ) capacitor c=2.73429e-19 \
 //x=20.5 //y=4.88 //x2=21.58 //y2=7.58
cc_1540 ( N_noxref_6_c_1748_n N_VDD_c_2609_n ) capacitor c=3.90041e-19 \
 //x=4.775 //y=4.265 //x2=5.3 //y2=7.585
cc_1541 ( N_noxref_6_c_1749_n N_VDD_c_2609_n ) capacitor c=0.00904116f \
 //x=6.02 //y=4.25 //x2=5.3 //y2=7.585
cc_1542 ( N_noxref_6_c_1740_n N_VDD_c_2614_n ) capacitor c=8.50173e-19 \
 //x=10.48 //y=4.25 //x2=8.63 //y2=7.585
cc_1543 ( N_noxref_6_c_1751_n N_VDD_c_2614_n ) capacitor c=0.0087315f \
 //x=10.645 //y=4.25 //x2=8.63 //y2=7.585
cc_1544 ( N_noxref_6_c_1799_n N_VDD_c_2667_n ) capacitor c=0.0013228f \
 //x=14.55 //y=5.295 //x2=11.96 //y2=7.585
cc_1545 ( N_noxref_6_c_1740_n N_VDD_c_2667_n ) capacitor c=0.00133985f \
 //x=10.48 //y=4.25 //x2=11.96 //y2=7.585
cc_1546 ( N_noxref_6_c_1803_n N_VDD_c_2667_n ) capacitor c=4.91377e-19 \
 //x=13.19 //y=5.56 //x2=11.96 //y2=7.585
cc_1547 ( N_noxref_6_c_1908_n N_VDD_c_2667_n ) capacitor c=4.55587e-19 \
 //x=14.55 //y=4.25 //x2=11.96 //y2=7.585
cc_1548 ( N_noxref_6_c_1813_n N_VDD_c_2667_n ) capacitor c=0.0086272f \
 //x=14.38 //y=4.25 //x2=11.96 //y2=7.585
cc_1549 ( N_noxref_6_c_1759_n N_VDD_c_2667_n ) capacitor c=0.00233202f \
 //x=10.51 //y=4.88 //x2=11.96 //y2=7.585
cc_1550 ( N_noxref_6_c_1820_n N_VDD_c_2667_n ) capacitor c=0.0064135f \
 //x=13.19 //y=5.56 //x2=11.96 //y2=7.585
cc_1551 ( N_noxref_6_c_1837_n N_VDD_c_2667_n ) capacitor c=0.0129149f \
 //x=10.885 //y=4.97 //x2=11.96 //y2=7.585
cc_1552 ( N_noxref_6_c_1890_n N_VDD_c_2702_n ) capacitor c=0.00197635f \
 //x=14.55 //y=4.425 //x2=15.29 //y2=7.585
cc_1553 ( N_noxref_6_c_1799_n N_VDD_c_2702_n ) capacitor c=0.0271117f \
 //x=14.55 //y=5.295 //x2=15.29 //y2=7.585
cc_1554 ( N_noxref_6_c_1899_n N_VDD_c_2702_n ) capacitor c=0.00240948f \
 //x=14.07 //y=5.38 //x2=15.29 //y2=7.585
cc_1555 ( N_noxref_6_c_2031_n N_VDD_c_2702_n ) capacitor c=4.09141e-19 \
 //x=14.07 //y=5.56 //x2=15.29 //y2=7.585
cc_1556 ( N_noxref_6_c_1908_n N_VDD_c_2702_n ) capacitor c=0.00494039f \
 //x=14.55 //y=4.25 //x2=15.29 //y2=7.585
cc_1557 ( N_noxref_6_c_1920_n N_VDD_c_2702_n ) capacitor c=0.0195658f \
 //x=16.27 //y=4.27 //x2=15.29 //y2=7.585
cc_1558 ( N_noxref_6_c_1929_n N_VDD_c_2702_n ) capacitor c=0.0101861f \
 //x=14.07 //y=5.56 //x2=15.29 //y2=7.585
cc_1559 ( N_noxref_6_c_2033_n N_VDD_c_2804_n ) capacitor c=8.4651e-19 \
 //x=20.47 //y=4.25 //x2=18.62 //y2=7.585
cc_1560 ( N_noxref_6_c_1998_n N_VDD_c_2804_n ) capacitor c=0.0196019f \
 //x=16.615 //y=4.27 //x2=18.62 //y2=7.585
cc_1561 ( N_noxref_6_c_1862_n N_VDD_M13_noxref_s ) capacitor c=9.6101e-19 \
 //x=1.6 //y=4.415 //x2=1.445 //y2=5.2
cc_1562 ( N_noxref_6_c_1725_n N_VDD_M13_noxref_s ) capacitor c=0.0223566f \
 //x=1.6 //y=4.755 //x2=1.445 //y2=5.2
cc_1563 ( N_noxref_6_c_1921_n N_VDD_M13_noxref_s ) capacitor c=4.27239e-19 \
 //x=1.765 //y=4.255 //x2=1.445 //y2=5.2
cc_1564 ( N_noxref_6_c_1926_n N_VDD_M13_noxref_s ) capacitor c=0.00911317f \
 //x=1.6 //y=4.88 //x2=1.445 //y2=5.2
cc_1565 ( N_noxref_6_M13_noxref_g N_VDD_M13_noxref_s ) capacitor c=0.053419f \
 //x=1.8 //y=6.2 //x2=1.445 //y2=5.2
cc_1566 ( N_noxref_6_c_1950_n N_VDD_M13_noxref_s ) capacitor c=0.00597659f \
 //x=1.875 //y=4.97 //x2=1.445 //y2=5.2
cc_1567 ( N_noxref_6_M14_noxref_g N_VDD_M14_noxref_d ) capacitor c=0.015318f \
 //x=2.24 //y=6.2 //x2=2.315 //y2=5.2
cc_1568 ( N_noxref_6_M25_noxref_g N_VDD_M24_noxref_d ) capacitor c=0.015318f \
 //x=10.52 //y=6.2 //x2=10.155 //y2=5.2
cc_1569 ( N_noxref_6_c_1778_n N_VDD_M24_noxref_d ) capacitor c=3.50465e-19 \
 //x=10.51 //y=4.88 //x2=10.155 //y2=5.2
cc_1570 ( N_noxref_6_M26_noxref_g N_VDD_M26_noxref_d ) capacitor c=0.0430452f \
 //x=10.96 //y=6.2 //x2=11.035 //y2=5.2
cc_1571 ( N_noxref_6_c_1803_n N_VDD_M27_noxref_s ) capacitor c=0.0572211f \
 //x=13.19 //y=5.56 //x2=12.615 //y2=5.2
cc_1572 ( N_noxref_6_c_1899_n N_VDD_M27_noxref_s ) capacitor c=6.52457e-19 \
 //x=14.07 //y=5.38 //x2=12.615 //y2=5.2
cc_1573 ( N_noxref_6_c_1820_n N_VDD_M27_noxref_s ) capacitor c=0.0887533f \
 //x=13.19 //y=5.56 //x2=12.615 //y2=5.2
cc_1574 ( N_noxref_6_c_1793_n N_VDD_M28_noxref_d ) capacitor c=0.00734094f \
 //x=13.955 //y=5.38 //x2=13.485 //y2=5.2
cc_1575 ( N_noxref_6_c_1803_n N_VDD_M28_noxref_d ) capacitor c=0.0043528f \
 //x=13.19 //y=5.56 //x2=13.485 //y2=5.2
cc_1576 ( N_noxref_6_c_2031_n N_VDD_M28_noxref_d ) capacitor c=0.0043528f \
 //x=14.07 //y=5.56 //x2=13.485 //y2=5.2
cc_1577 ( N_noxref_6_c_1820_n N_VDD_M28_noxref_d ) capacitor c=0.065554f \
 //x=13.19 //y=5.56 //x2=13.485 //y2=5.2
cc_1578 ( N_noxref_6_c_1929_n N_VDD_M28_noxref_d ) capacitor c=0.065554f \
 //x=14.07 //y=5.56 //x2=13.485 //y2=5.2
cc_1579 ( N_noxref_6_c_1882_n N_VDD_M30_noxref_d ) capacitor c=0.00852734f \
 //x=14.465 //y=5.38 //x2=14.365 //y2=5.2
cc_1580 ( N_noxref_6_c_2031_n N_VDD_M30_noxref_d ) capacitor c=0.00587834f \
 //x=14.07 //y=5.56 //x2=14.365 //y2=5.2
cc_1581 ( N_noxref_6_c_1908_n N_VDD_M30_noxref_d ) capacitor c=0.00167175f \
 //x=14.55 //y=4.25 //x2=14.365 //y2=5.2
cc_1582 ( N_noxref_6_c_1929_n N_VDD_M30_noxref_d ) capacitor c=0.065554f \
 //x=14.07 //y=5.56 //x2=14.365 //y2=5.2
cc_1583 ( N_noxref_6_c_1882_n N_VDD_M31_noxref_s ) capacitor c=0.00326953f \
 //x=14.465 //y=5.38 //x2=15.945 //y2=5.2
cc_1584 ( N_noxref_6_c_1899_n N_VDD_M31_noxref_s ) capacitor c=0.00515461f \
 //x=14.07 //y=5.38 //x2=15.945 //y2=5.2
cc_1585 ( N_noxref_6_c_2031_n N_VDD_M31_noxref_s ) capacitor c=3.28075e-19 \
 //x=14.07 //y=5.56 //x2=15.945 //y2=5.2
cc_1586 ( N_noxref_6_c_1920_n N_VDD_M31_noxref_s ) capacitor c=0.00546936f \
 //x=16.27 //y=4.27 //x2=15.945 //y2=5.2
cc_1587 ( N_noxref_6_c_1998_n N_VDD_M35_noxref_s ) capacitor c=0.00556024f \
 //x=16.615 //y=4.27 //x2=19.275 //y2=5.2
cc_1588 ( N_noxref_6_M37_noxref_g N_VDD_M36_noxref_d ) capacitor c=0.015318f \
 //x=20.51 //y=6.2 //x2=20.145 //y2=5.2
cc_1589 ( N_noxref_6_c_2067_n N_VDD_M36_noxref_d ) capacitor c=3.50465e-19 \
 //x=20.5 //y=4.88 //x2=20.145 //y2=5.2
cc_1590 ( N_noxref_6_M38_noxref_g N_VDD_M38_noxref_d ) capacitor c=0.0430452f \
 //x=20.95 //y=6.2 //x2=21.025 //y2=5.2
cc_1591 ( N_noxref_6_c_1751_n D ) capacitor c=0.0209367f //x=10.645 //y=4.25 \
 //x2=7.15 //y2=2.77
cc_1592 ( N_noxref_6_c_1936_n N_GND_c_3343_n ) capacitor c=3.97665e-19 //x=1.3 \
 //y=1.055 //x2=1.565 //y2=1.015
cc_1593 ( N_noxref_6_c_2218_p N_GND_c_3343_n ) capacitor c=0.00864776f \
 //x=1.675 //y=0.9 //x2=1.565 //y2=1.015
cc_1594 ( N_noxref_6_c_1942_n N_GND_c_3343_n ) capacitor c=4.45447e-19 \
 //x=1.83 //y=1.055 //x2=1.565 //y2=1.015
cc_1595 ( N_noxref_6_c_1734_n N_GND_c_3195_n ) capacitor c=2.70712e-19 \
 //x=10.48 //y=4.415 //x2=13.055 //y2=0.175
cc_1596 ( N_noxref_6_c_1741_n N_GND_c_3195_n ) capacitor c=0.00234561f \
 //x=10.48 //y=2.26 //x2=13.055 //y2=0.175
cc_1597 ( N_noxref_6_c_1883_n N_GND_c_3237_n ) capacitor c=0.00654514f \
 //x=14.465 //y=1.835 //x2=16.385 //y2=0.175
cc_1598 ( N_noxref_6_c_1812_n N_GND_c_3237_n ) capacitor c=0.00964814f \
 //x=14.11 //y=1.18 //x2=16.385 //y2=0.175
cc_1599 ( N_noxref_6_M8_noxref_d N_GND_c_3237_n ) capacitor c=3.01769e-19 \
 //x=13.92 //y=1.085 //x2=16.385 //y2=0.175
cc_1600 ( N_noxref_6_c_2024_n N_GND_c_3351_n ) capacitor c=2.6384e-19 \
 //x=20.47 //y=4.41 //x2=21.58 //y2=0.18
cc_1601 ( N_noxref_6_c_2034_n N_GND_c_3351_n ) capacitor c=0.00234561f \
 //x=20.47 //y=2.26 //x2=21.58 //y2=0.18
cc_1602 ( N_noxref_6_c_1857_n N_GND_c_3353_n ) capacitor c=0.00849742f //x=1.6 \
 //y=2.375 //x2=1.565 //y2=1.145
cc_1603 ( N_noxref_6_c_1862_n N_GND_c_3353_n ) capacitor c=4.89021e-19 //x=1.6 \
 //y=4.415 //x2=1.565 //y2=1.145
cc_1604 ( N_noxref_6_c_1922_n N_GND_c_3353_n ) capacitor c=2.22883e-19 //x=1.6 \
 //y=2.26 //x2=1.565 //y2=1.145
cc_1605 ( N_noxref_6_c_1936_n N_GND_c_3353_n ) capacitor c=0.00142616f //x=1.3 \
 //y=1.055 //x2=1.565 //y2=1.145
cc_1606 ( N_noxref_6_c_1937_n N_GND_c_3353_n ) capacitor c=0.00411286f //x=1.3 \
 //y=1.4 //x2=1.565 //y2=1.145
cc_1607 ( N_noxref_6_c_1938_n N_GND_c_3353_n ) capacitor c=4.68816e-19 //x=1.3 \
 //y=1.71 //x2=1.565 //y2=1.145
cc_1608 ( N_noxref_6_c_2218_p N_GND_c_3353_n ) capacitor c=7.3749e-19 \
 //x=1.675 //y=0.9 //x2=1.565 //y2=1.145
cc_1609 ( N_noxref_6_c_2234_p N_GND_c_3353_n ) capacitor c=6.09659e-19 \
 //x=1.675 //y=1.555 //x2=1.565 //y2=1.145
cc_1610 ( N_noxref_6_c_1942_n N_GND_c_3353_n ) capacitor c=0.0017438f //x=1.83 \
 //y=1.055 //x2=1.565 //y2=1.145
cc_1611 ( N_noxref_6_c_1944_n N_GND_c_3353_n ) capacitor c=0.00276804f \
 //x=1.83 //y=1.4 //x2=1.565 //y2=1.145
cc_1612 ( N_noxref_6_c_1803_n N_GND_c_3202_n ) capacitor c=7.78541e-19 \
 //x=13.19 //y=5.56 //x2=13.14 //y2=1.135
cc_1613 ( N_noxref_6_c_1812_n N_GND_c_3202_n ) capacitor c=0.0140087f \
 //x=14.11 //y=1.18 //x2=13.14 //y2=1.135
cc_1614 ( N_noxref_6_M8_noxref_d N_GND_c_3202_n ) capacitor c=2.93544e-19 \
 //x=13.92 //y=1.085 //x2=13.14 //y2=1.135
cc_1615 ( N_noxref_6_c_1812_n N_GND_c_3259_n ) capacitor c=0.00549186f \
 //x=14.11 //y=1.18 //x2=16.47 //y2=1.135
cc_1616 ( N_noxref_6_c_1936_n N_GND_c_3170_n ) capacitor c=0.00680635f //x=1.3 \
 //y=1.055 //x2=5.13 //y2=0.175
cc_1617 ( N_noxref_6_c_1857_n N_GND_c_3368_n ) capacitor c=0.00779049f //x=1.6 \
 //y=2.375 //x2=1.23 //y2=0.18
cc_1618 ( N_noxref_6_c_1723_n N_GND_c_3368_n ) capacitor c=0.0126319f //x=1.6 \
 //y=4.095 //x2=1.23 //y2=0.18
cc_1619 ( N_noxref_6_c_1922_n N_GND_c_3368_n ) capacitor c=0.00394776f //x=1.6 \
 //y=2.26 //x2=1.23 //y2=0.18
cc_1620 ( N_noxref_6_c_1938_n N_GND_c_3368_n ) capacitor c=0.00295461f //x=1.3 \
 //y=1.71 //x2=1.23 //y2=0.18
cc_1621 ( N_noxref_6_c_1939_n N_GND_c_3368_n ) capacitor c=0.0112432f //x=1.3 \
 //y=2.095 //x2=1.23 //y2=0.18
cc_1622 ( N_noxref_6_c_1741_n N_GND_c_3172_n ) capacitor c=3.77328e-19 \
 //x=10.48 //y=2.26 //x2=11.79 //y2=0.175
cc_1623 ( N_noxref_6_c_1883_n N_GND_c_3217_n ) capacitor c=7.77585e-19 \
 //x=14.465 //y=1.835 //x2=15.12 //y2=0.175
cc_1624 ( N_noxref_6_c_1812_n N_GND_c_3173_n ) capacitor c=2.83275e-19 \
 //x=14.11 //y=1.18 //x2=21.58 //y2=0.18
cc_1625 ( N_noxref_6_c_2034_n N_GND_c_3173_n ) capacitor c=3.77328e-19 \
 //x=20.47 //y=2.26 //x2=21.58 //y2=0.18
cc_1626 ( N_noxref_6_c_2044_n N_GND_c_3173_n ) capacitor c=0.00224736f \
 //x=20.47 //y=2.26 //x2=21.58 //y2=0.18
cc_1627 ( N_noxref_6_c_2063_n N_GND_c_3173_n ) capacitor c=0.0028807f \
 //x=21.035 //y=1.43 //x2=21.58 //y2=0.18
cc_1628 ( N_noxref_6_c_2064_n N_GND_c_3173_n ) capacitor c=2.63786e-19 \
 //x=20.47 //y=2.26 //x2=21.58 //y2=0.18
cc_1629 ( N_noxref_6_c_1796_n N_GND_c_3220_n ) capacitor c=9.32616e-19 \
 //x=14.55 //y=4.105 //x2=11.96 //y2=0.175
cc_1630 ( N_noxref_6_c_1755_n N_GND_c_3220_n ) capacitor c=0.00224736f \
 //x=10.48 //y=2.26 //x2=11.96 //y2=0.175
cc_1631 ( N_noxref_6_c_1774_n N_GND_c_3220_n ) capacitor c=0.00275184f \
 //x=11.045 //y=1.43 //x2=11.96 //y2=0.175
cc_1632 ( N_noxref_6_c_1775_n N_GND_c_3220_n ) capacitor c=2.63786e-19 \
 //x=10.48 //y=2.26 //x2=11.96 //y2=0.175
cc_1633 ( N_noxref_6_c_1794_n N_GND_c_3239_n ) capacitor c=0.002973f //x=14.11 \
 //y=1.75 //x2=15.29 //y2=0.175
cc_1634 ( N_noxref_6_c_1883_n N_GND_c_3239_n ) capacitor c=0.0300121f \
 //x=14.465 //y=1.835 //x2=15.29 //y2=0.175
cc_1635 ( N_noxref_6_c_1857_n N_GND_M0_noxref_d ) capacitor c=4.4417e-19 \
 //x=1.6 //y=2.375 //x2=1.375 //y2=1.055
cc_1636 ( N_noxref_6_c_1936_n N_GND_M0_noxref_d ) capacitor c=0.00184354f \
 //x=1.3 //y=1.055 //x2=1.375 //y2=1.055
cc_1637 ( N_noxref_6_c_1937_n N_GND_M0_noxref_d ) capacitor c=0.00210798f \
 //x=1.3 //y=1.4 //x2=1.375 //y2=1.055
cc_1638 ( N_noxref_6_c_2218_p N_GND_M0_noxref_d ) capacitor c=0.00474029f \
 //x=1.675 //y=0.9 //x2=1.375 //y2=1.055
cc_1639 ( N_noxref_6_c_2234_p N_GND_M0_noxref_d ) capacitor c=0.00166857f \
 //x=1.675 //y=1.555 //x2=1.375 //y2=1.055
cc_1640 ( N_noxref_6_c_1942_n N_GND_M0_noxref_d ) capacitor c=0.00230174f \
 //x=1.83 //y=1.055 //x2=1.375 //y2=1.055
cc_1641 ( N_noxref_6_c_1944_n N_GND_M0_noxref_d ) capacitor c=0.00210798f \
 //x=1.83 //y=1.4 //x2=1.375 //y2=1.055
cc_1642 ( N_noxref_6_c_1812_n N_GND_M7_noxref_d ) capacitor c=2.82748e-19 \
 //x=14.11 //y=1.18 //x2=12.95 //y2=1.045
cc_1643 ( N_noxref_6_c_1939_n N_noxref_12_c_3584_n ) capacitor c=0.00267608f \
 //x=1.3 //y=2.095 //x2=1.08 //y2=1.685
cc_1644 ( N_noxref_6_c_1857_n N_noxref_12_c_3585_n ) capacitor c=0.00428451f \
 //x=1.6 //y=2.375 //x2=1.965 //y2=1.77
cc_1645 ( N_noxref_6_c_1862_n N_noxref_12_c_3585_n ) capacitor c=0.0010535f \
 //x=1.6 //y=4.415 //x2=1.965 //y2=1.77
cc_1646 ( N_noxref_6_c_1922_n N_noxref_12_c_3585_n ) capacitor c=0.0104666f \
 //x=1.6 //y=2.26 //x2=1.965 //y2=1.77
cc_1647 ( N_noxref_6_c_1938_n N_noxref_12_c_3585_n ) capacitor c=0.00703864f \
 //x=1.3 //y=1.71 //x2=1.965 //y2=1.77
cc_1648 ( N_noxref_6_c_1939_n N_noxref_12_c_3585_n ) capacitor c=0.0232409f \
 //x=1.3 //y=2.095 //x2=1.965 //y2=1.77
cc_1649 ( N_noxref_6_c_2234_p N_noxref_12_c_3585_n ) capacitor c=0.00588627f \
 //x=1.675 //y=1.555 //x2=1.965 //y2=1.77
cc_1650 ( N_noxref_6_c_1944_n N_noxref_12_c_3585_n ) capacitor c=0.00698822f \
 //x=1.83 //y=1.4 //x2=1.965 //y2=1.77
cc_1651 ( N_noxref_6_c_1936_n N_noxref_12_M0_noxref_s ) capacitor c=0.0295256f \
 //x=1.3 //y=1.055 //x2=0.945 //y2=0.555
cc_1652 ( N_noxref_6_c_1938_n N_noxref_12_M0_noxref_s ) capacitor \
 c=7.99997e-19 //x=1.3 //y=1.71 //x2=0.945 //y2=0.555
cc_1653 ( N_noxref_6_c_1939_n N_noxref_12_M0_noxref_s ) capacitor \
 c=0.00122123f //x=1.3 //y=2.095 //x2=0.945 //y2=0.555
cc_1654 ( N_noxref_6_c_1942_n N_noxref_12_M0_noxref_s ) capacitor c=0.0125924f \
 //x=1.83 //y=1.055 //x2=0.945 //y2=0.555
cc_1655 ( N_noxref_6_c_1734_n N_noxref_14_c_3702_n ) capacitor c=9.48063e-19 \
 //x=10.48 //y=4.415 //x2=10.295 //y2=1.675
cc_1656 ( N_noxref_6_c_1741_n N_noxref_14_c_3702_n ) capacitor c=7.50092e-19 \
 //x=10.48 //y=2.26 //x2=10.295 //y2=1.675
cc_1657 ( N_noxref_6_c_1770_n N_noxref_14_c_3702_n ) capacitor c=0.00888238f \
 //x=10.515 //y=1.74 //x2=10.295 //y2=1.675
cc_1658 ( N_noxref_6_c_1775_n N_noxref_14_c_3702_n ) capacitor c=0.00175171f \
 //x=10.48 //y=2.26 //x2=10.295 //y2=1.675
cc_1659 ( N_noxref_6_c_1741_n N_noxref_14_c_3707_n ) capacitor c=0.001463f \
 //x=10.48 //y=2.26 //x2=11.18 //y2=0.71
cc_1660 ( N_noxref_6_c_1755_n N_noxref_14_c_3707_n ) capacitor c=8.82141e-19 \
 //x=10.48 //y=2.26 //x2=11.18 //y2=0.71
cc_1661 ( N_noxref_6_c_1765_n N_noxref_14_c_3707_n ) capacitor c=0.0200357f \
 //x=10.515 //y=1.085 //x2=11.18 //y2=0.71
cc_1662 ( N_noxref_6_c_1773_n N_noxref_14_c_3707_n ) capacitor c=0.00825432f \
 //x=11.045 //y=1.085 //x2=11.18 //y2=0.71
cc_1663 ( N_noxref_6_c_1775_n N_noxref_14_c_3707_n ) capacitor c=2.1838e-19 \
 //x=10.48 //y=2.26 //x2=11.18 //y2=0.71
cc_1664 ( N_noxref_6_c_1765_n N_noxref_14_M5_noxref_s ) capacitor \
 c=0.00888238f //x=10.515 //y=1.085 //x2=9.19 //y2=0.545
cc_1665 ( N_noxref_6_c_1773_n N_noxref_14_M5_noxref_s ) capacitor c=0.015333f \
 //x=11.045 //y=1.085 //x2=9.19 //y2=0.545
cc_1666 ( N_noxref_6_c_1774_n N_noxref_14_M5_noxref_s ) capacitor \
 c=0.00248746f //x=11.045 //y=1.43 //x2=9.19 //y2=0.545
cc_1667 ( N_noxref_6_c_1795_n N_noxref_15_c_3770_n ) capacitor c=0.00911498f \
 //x=14.195 //y=1.835 //x2=13.625 //y2=1.675
cc_1668 ( N_noxref_6_c_1883_n N_noxref_15_c_3777_n ) capacitor c=0.00361884f \
 //x=14.465 //y=1.835 //x2=14.51 //y2=0.71
cc_1669 ( N_noxref_6_c_1812_n N_noxref_15_c_3777_n ) capacitor c=0.00367971f \
 //x=14.11 //y=1.18 //x2=14.51 //y2=0.71
cc_1670 ( N_noxref_6_M8_noxref_d N_noxref_15_c_3777_n ) capacitor \
 c=0.00910163f //x=13.92 //y=1.085 //x2=14.51 //y2=0.71
cc_1671 ( N_noxref_6_c_1794_n N_noxref_15_M7_noxref_s ) capacitor c=0.0162484f \
 //x=14.11 //y=1.75 //x2=12.52 //y2=0.545
cc_1672 ( N_noxref_6_c_1883_n N_noxref_15_M7_noxref_s ) capacitor \
 c=0.00692219f //x=14.465 //y=1.835 //x2=12.52 //y2=0.545
cc_1673 ( N_noxref_6_c_1812_n N_noxref_15_M7_noxref_s ) capacitor \
 c=0.00905169f //x=14.11 //y=1.18 //x2=12.52 //y2=0.545
cc_1674 ( N_noxref_6_c_1908_n N_noxref_15_M7_noxref_s ) capacitor \
 c=7.05305e-19 //x=14.55 //y=4.25 //x2=12.52 //y2=0.545
cc_1675 ( N_noxref_6_M8_noxref_d N_noxref_15_M7_noxref_s ) capacitor \
 c=0.0275552f //x=13.92 //y=1.085 //x2=12.52 //y2=0.545
cc_1676 ( N_noxref_6_c_2024_n N_noxref_17_c_3902_n ) capacitor c=9.54772e-19 \
 //x=20.47 //y=4.41 //x2=20.285 //y2=1.675
cc_1677 ( N_noxref_6_c_2034_n N_noxref_17_c_3902_n ) capacitor c=7.50092e-19 \
 //x=20.47 //y=2.26 //x2=20.285 //y2=1.675
cc_1678 ( N_noxref_6_c_2059_n N_noxref_17_c_3902_n ) capacitor c=0.00888238f \
 //x=20.505 //y=1.74 //x2=20.285 //y2=1.675
cc_1679 ( N_noxref_6_c_2064_n N_noxref_17_c_3902_n ) capacitor c=0.00175171f \
 //x=20.47 //y=2.26 //x2=20.285 //y2=1.675
cc_1680 ( N_noxref_6_c_2034_n N_noxref_17_c_3910_n ) capacitor c=0.001463f \
 //x=20.47 //y=2.26 //x2=21.17 //y2=0.71
cc_1681 ( N_noxref_6_c_2044_n N_noxref_17_c_3910_n ) capacitor c=8.82141e-19 \
 //x=20.47 //y=2.26 //x2=21.17 //y2=0.71
cc_1682 ( N_noxref_6_c_2054_n N_noxref_17_c_3910_n ) capacitor c=0.0200262f \
 //x=20.505 //y=1.085 //x2=21.17 //y2=0.71
cc_1683 ( N_noxref_6_c_2062_n N_noxref_17_c_3910_n ) capacitor c=0.00825432f \
 //x=21.035 //y=1.085 //x2=21.17 //y2=0.71
cc_1684 ( N_noxref_6_c_2064_n N_noxref_17_c_3910_n ) capacitor c=2.1838e-19 \
 //x=20.47 //y=2.26 //x2=21.17 //y2=0.71
cc_1685 ( N_noxref_6_c_2054_n N_noxref_17_M11_noxref_s ) capacitor \
 c=0.00888238f //x=20.505 //y=1.085 //x2=19.18 //y2=0.545
cc_1686 ( N_noxref_6_c_2062_n N_noxref_17_M11_noxref_s ) capacitor c=0.015333f \
 //x=21.035 //y=1.085 //x2=19.18 //y2=0.545
cc_1687 ( N_noxref_6_c_2063_n N_noxref_17_M11_noxref_s ) capacitor \
 c=0.00248746f //x=21.035 //y=1.43 //x2=19.18 //y2=0.545
cc_1688 ( N_noxref_7_c_2374_n N_VDD_c_2586_n ) capacitor c=0.00648267f \
 //x=20.615 //y=5.38 //x2=21.58 //y2=7.58
cc_1689 ( N_noxref_7_c_2457_n N_VDD_c_2586_n ) capacitor c=0.00492578f \
 //x=21.125 //y=5.38 //x2=21.58 //y2=7.58
cc_1690 ( N_noxref_7_c_2383_n N_VDD_c_2586_n ) capacitor c=0.00368834f \
 //x=19.85 //y=5.56 //x2=21.58 //y2=7.58
cc_1691 ( N_noxref_7_c_2476_n N_VDD_c_2586_n ) capacitor c=8.42623e-19 \
 //x=20.73 //y=5.38 //x2=21.58 //y2=7.58
cc_1692 ( N_noxref_7_c_2508_p N_VDD_c_2586_n ) capacitor c=0.00285853f \
 //x=20.73 //y=5.56 //x2=21.58 //y2=7.58
cc_1693 ( N_noxref_7_c_2405_n N_VDD_c_2586_n ) capacitor c=0.00224881f \
 //x=19.85 //y=5.56 //x2=21.58 //y2=7.58
cc_1694 ( N_noxref_7_c_2495_n N_VDD_c_2586_n ) capacitor c=0.00224881f \
 //x=20.73 //y=5.56 //x2=21.58 //y2=7.58
cc_1695 ( N_noxref_7_M33_noxref_g N_VDD_c_2793_n ) capacitor c=0.00697352f \
 //x=17.18 //y=6.2 //x2=17.755 //y2=7.585
cc_1696 ( N_noxref_7_M34_noxref_g N_VDD_c_2793_n ) capacitor c=0.00755544f \
 //x=17.62 //y=6.2 //x2=17.755 //y2=7.585
cc_1697 ( N_noxref_7_c_2374_n N_VDD_c_2798_n ) capacitor c=0.00208087f \
 //x=20.615 //y=5.38 //x2=20.205 //y2=7.585
cc_1698 ( N_noxref_7_c_2383_n N_VDD_c_2798_n ) capacitor c=9.41185e-19 \
 //x=19.85 //y=5.56 //x2=20.205 //y2=7.585
cc_1699 ( N_noxref_7_c_2405_n N_VDD_c_2798_n ) capacitor c=0.0136705f \
 //x=19.85 //y=5.56 //x2=20.205 //y2=7.585
cc_1700 ( N_noxref_7_c_2374_n N_VDD_c_2857_n ) capacitor c=0.00180737f \
 //x=20.615 //y=5.38 //x2=21.085 //y2=7.585
cc_1701 ( N_noxref_7_c_2457_n N_VDD_c_2857_n ) capacitor c=0.00208087f \
 //x=21.125 //y=5.38 //x2=21.085 //y2=7.585
cc_1702 ( N_noxref_7_c_2476_n N_VDD_c_2857_n ) capacitor c=4.23719e-19 \
 //x=20.73 //y=5.38 //x2=21.085 //y2=7.585
cc_1703 ( N_noxref_7_c_2508_p N_VDD_c_2857_n ) capacitor c=5.77976e-19 \
 //x=20.73 //y=5.56 //x2=21.085 //y2=7.585
cc_1704 ( N_noxref_7_c_2495_n N_VDD_c_2857_n ) capacitor c=0.0136705f \
 //x=20.73 //y=5.56 //x2=21.085 //y2=7.585
cc_1705 ( N_noxref_7_c_2379_n N_VDD_c_2859_n ) capacitor c=0.0374575f \
 //x=21.21 //y=5.295 //x2=21.58 //y2=7.58
cc_1706 ( N_noxref_7_c_2476_n N_VDD_c_2859_n ) capacitor c=0.00379179f \
 //x=20.73 //y=5.38 //x2=21.58 //y2=7.58
cc_1707 ( N_noxref_7_c_2508_p N_VDD_c_2859_n ) capacitor c=0.0016115f \
 //x=20.73 //y=5.56 //x2=21.58 //y2=7.58
cc_1708 ( N_noxref_7_c_2495_n N_VDD_c_2859_n ) capacitor c=0.0101867f \
 //x=20.73 //y=5.56 //x2=21.58 //y2=7.58
cc_1709 ( N_noxref_7_c_2379_n N_VDD_c_2804_n ) capacitor c=0.00150038f \
 //x=21.21 //y=5.295 //x2=18.62 //y2=7.585
cc_1710 ( N_noxref_7_c_2383_n N_VDD_c_2804_n ) capacitor c=4.91377e-19 \
 //x=19.85 //y=5.56 //x2=18.62 //y2=7.585
cc_1711 ( N_noxref_7_c_2337_n N_VDD_c_2804_n ) capacitor c=0.00226427f \
 //x=17.17 //y=4.88 //x2=18.62 //y2=7.585
cc_1712 ( N_noxref_7_c_2405_n N_VDD_c_2804_n ) capacitor c=0.0064135f \
 //x=19.85 //y=5.56 //x2=18.62 //y2=7.585
cc_1713 ( N_noxref_7_c_2422_n N_VDD_c_2804_n ) capacitor c=0.0129149f \
 //x=17.545 //y=4.97 //x2=18.62 //y2=7.585
cc_1714 ( N_noxref_7_c_2356_n N_VDD_c_2804_n ) capacitor c=2.73429e-19 \
 //x=17.17 //y=4.88 //x2=18.62 //y2=7.585
cc_1715 ( N_noxref_7_M33_noxref_g N_VDD_M32_noxref_d ) capacitor c=0.015318f \
 //x=17.18 //y=6.2 //x2=16.815 //y2=5.2
cc_1716 ( N_noxref_7_c_2356_n N_VDD_M32_noxref_d ) capacitor c=3.32552e-19 \
 //x=17.17 //y=4.88 //x2=16.815 //y2=5.2
cc_1717 ( N_noxref_7_M34_noxref_g N_VDD_M34_noxref_d ) capacitor c=0.0430452f \
 //x=17.62 //y=6.2 //x2=17.695 //y2=5.2
cc_1718 ( N_noxref_7_c_2383_n N_VDD_M35_noxref_s ) capacitor c=0.0577058f \
 //x=19.85 //y=5.56 //x2=19.275 //y2=5.2
cc_1719 ( N_noxref_7_c_2476_n N_VDD_M35_noxref_s ) capacitor c=6.52457e-19 \
 //x=20.73 //y=5.38 //x2=19.275 //y2=5.2
cc_1720 ( N_noxref_7_c_2405_n N_VDD_M35_noxref_s ) capacitor c=0.0887533f \
 //x=19.85 //y=5.56 //x2=19.275 //y2=5.2
cc_1721 ( N_noxref_7_c_2374_n N_VDD_M36_noxref_d ) capacitor c=0.00734094f \
 //x=20.615 //y=5.38 //x2=20.145 //y2=5.2
cc_1722 ( N_noxref_7_c_2383_n N_VDD_M36_noxref_d ) capacitor c=0.0043528f \
 //x=19.85 //y=5.56 //x2=20.145 //y2=5.2
cc_1723 ( N_noxref_7_c_2508_p N_VDD_M36_noxref_d ) capacitor c=0.0043528f \
 //x=20.73 //y=5.56 //x2=20.145 //y2=5.2
cc_1724 ( N_noxref_7_c_2405_n N_VDD_M36_noxref_d ) capacitor c=0.065554f \
 //x=19.85 //y=5.56 //x2=20.145 //y2=5.2
cc_1725 ( N_noxref_7_c_2495_n N_VDD_M36_noxref_d ) capacitor c=0.065554f \
 //x=20.73 //y=5.56 //x2=20.145 //y2=5.2
cc_1726 ( N_noxref_7_c_2457_n N_VDD_M38_noxref_d ) capacitor c=0.00898356f \
 //x=21.125 //y=5.38 //x2=21.025 //y2=5.2
cc_1727 ( N_noxref_7_c_2508_p N_VDD_M38_noxref_d ) capacitor c=0.00979407f \
 //x=20.73 //y=5.56 //x2=21.025 //y2=5.2
cc_1728 ( N_noxref_7_c_2486_n N_VDD_M38_noxref_d ) capacitor c=0.00122238f \
 //x=21.21 //y=3.88 //x2=21.025 //y2=5.2
cc_1729 ( N_noxref_7_c_2495_n N_VDD_M38_noxref_d ) capacitor c=0.065554f \
 //x=20.73 //y=5.56 //x2=21.025 //y2=5.2
cc_1730 ( N_noxref_7_c_2325_n N_GND_c_3301_n ) capacitor c=0.00234561f \
 //x=17.14 //y=2.26 //x2=19.715 //y2=0.175
cc_1731 ( N_noxref_7_c_2458_n N_GND_c_3351_n ) capacitor c=0.00654514f \
 //x=21.125 //y=1.835 //x2=21.58 //y2=0.18
cc_1732 ( N_noxref_7_c_2392_n N_GND_c_3351_n ) capacitor c=0.00964814f \
 //x=20.77 //y=1.18 //x2=21.58 //y2=0.18
cc_1733 ( N_noxref_7_M12_noxref_d N_GND_c_3351_n ) capacitor c=3.01769e-19 \
 //x=20.58 //y=1.085 //x2=21.58 //y2=0.18
cc_1734 ( N_noxref_7_c_2383_n N_GND_c_3308_n ) capacitor c=7.09002e-19 \
 //x=19.85 //y=5.56 //x2=19.8 //y2=1.135
cc_1735 ( N_noxref_7_c_2392_n N_GND_c_3308_n ) capacitor c=0.0141824f \
 //x=20.77 //y=1.18 //x2=19.8 //y2=1.135
cc_1736 ( N_noxref_7_M12_noxref_d N_GND_c_3308_n ) capacitor c=2.93544e-19 \
 //x=20.58 //y=1.085 //x2=19.8 //y2=1.135
cc_1737 ( N_noxref_7_c_2325_n N_GND_c_3273_n ) capacitor c=3.77328e-19 \
 //x=17.14 //y=2.26 //x2=18.45 //y2=0.175
cc_1738 ( N_noxref_7_c_2375_n N_GND_c_3173_n ) capacitor c=0.00528499f \
 //x=20.77 //y=1.75 //x2=21.58 //y2=0.18
cc_1739 ( N_noxref_7_c_2458_n N_GND_c_3173_n ) capacitor c=0.0391779f \
 //x=21.125 //y=1.835 //x2=21.58 //y2=0.18
cc_1740 ( N_noxref_7_c_2392_n N_GND_c_3173_n ) capacitor c=2.83275e-19 \
 //x=20.77 //y=1.18 //x2=21.58 //y2=0.18
cc_1741 ( N_noxref_7_c_2377_n N_GND_c_3327_n ) capacitor c=0.0012138f \
 //x=21.21 //y=3.705 //x2=18.62 //y2=0.175
cc_1742 ( N_noxref_7_c_2333_n N_GND_c_3327_n ) capacitor c=0.00224736f \
 //x=17.14 //y=2.26 //x2=18.62 //y2=0.175
cc_1743 ( N_noxref_7_c_2352_n N_GND_c_3327_n ) capacitor c=0.00275184f \
 //x=17.705 //y=1.43 //x2=18.62 //y2=0.175
cc_1744 ( N_noxref_7_c_2353_n N_GND_c_3327_n ) capacitor c=2.63786e-19 \
 //x=17.14 //y=2.26 //x2=18.62 //y2=0.175
cc_1745 ( N_noxref_7_c_2392_n N_GND_M11_noxref_d ) capacitor c=2.82748e-19 \
 //x=20.77 //y=1.18 //x2=19.61 //y2=1.045
cc_1746 ( N_noxref_7_c_2315_n N_noxref_16_c_3836_n ) capacitor c=4.28783e-19 \
 //x=17.14 //y=4.025 //x2=16.955 //y2=1.675
cc_1747 ( N_noxref_7_c_2325_n N_noxref_16_c_3836_n ) capacitor c=7.50092e-19 \
 //x=17.14 //y=2.26 //x2=16.955 //y2=1.675
cc_1748 ( N_noxref_7_c_2348_n N_noxref_16_c_3836_n ) capacitor c=0.00888238f \
 //x=17.175 //y=1.74 //x2=16.955 //y2=1.675
cc_1749 ( N_noxref_7_c_2353_n N_noxref_16_c_3836_n ) capacitor c=0.00175171f \
 //x=17.14 //y=2.26 //x2=16.955 //y2=1.675
cc_1750 ( N_noxref_7_c_2325_n N_noxref_16_c_3841_n ) capacitor c=0.001463f \
 //x=17.14 //y=2.26 //x2=17.84 //y2=0.71
cc_1751 ( N_noxref_7_c_2333_n N_noxref_16_c_3841_n ) capacitor c=8.82141e-19 \
 //x=17.14 //y=2.26 //x2=17.84 //y2=0.71
cc_1752 ( N_noxref_7_c_2343_n N_noxref_16_c_3841_n ) capacitor c=0.0200738f \
 //x=17.175 //y=1.085 //x2=17.84 //y2=0.71
cc_1753 ( N_noxref_7_c_2351_n N_noxref_16_c_3841_n ) capacitor c=0.00825432f \
 //x=17.705 //y=1.085 //x2=17.84 //y2=0.71
cc_1754 ( N_noxref_7_c_2353_n N_noxref_16_c_3841_n ) capacitor c=2.1838e-19 \
 //x=17.14 //y=2.26 //x2=17.84 //y2=0.71
cc_1755 ( N_noxref_7_c_2343_n N_noxref_16_M9_noxref_s ) capacitor \
 c=0.00888238f //x=17.175 //y=1.085 //x2=15.85 //y2=0.545
cc_1756 ( N_noxref_7_c_2351_n N_noxref_16_M9_noxref_s ) capacitor c=0.015333f \
 //x=17.705 //y=1.085 //x2=15.85 //y2=0.545
cc_1757 ( N_noxref_7_c_2352_n N_noxref_16_M9_noxref_s ) capacitor \
 c=0.00248746f //x=17.705 //y=1.43 //x2=15.85 //y2=0.545
cc_1758 ( N_noxref_7_c_2393_n N_noxref_17_c_3894_n ) capacitor c=0.00399187f \
 //x=20.085 //y=3.88 //x2=20.2 //y2=1.76
cc_1759 ( N_noxref_7_c_2376_n N_noxref_17_c_3902_n ) capacitor c=0.00911498f \
 //x=20.855 //y=1.835 //x2=20.285 //y2=1.675
cc_1760 ( N_noxref_7_c_2393_n N_noxref_17_c_3902_n ) capacitor c=0.00176609f \
 //x=20.085 //y=3.88 //x2=20.285 //y2=1.675
cc_1761 ( N_noxref_7_c_2458_n N_noxref_17_c_3910_n ) capacitor c=0.00389706f \
 //x=21.125 //y=1.835 //x2=21.17 //y2=0.71
cc_1762 ( N_noxref_7_c_2392_n N_noxref_17_c_3910_n ) capacitor c=0.00367971f \
 //x=20.77 //y=1.18 //x2=21.17 //y2=0.71
cc_1763 ( N_noxref_7_M12_noxref_d N_noxref_17_c_3910_n ) capacitor \
 c=0.00910163f //x=20.58 //y=1.085 //x2=21.17 //y2=0.71
cc_1764 ( N_noxref_7_c_2375_n N_noxref_17_M11_noxref_s ) capacitor \
 c=0.0175047f //x=20.77 //y=1.75 //x2=19.18 //y2=0.545
cc_1765 ( N_noxref_7_c_2458_n N_noxref_17_M11_noxref_s ) capacitor \
 c=0.00670006f //x=21.125 //y=1.835 //x2=19.18 //y2=0.545
cc_1766 ( N_noxref_7_c_2465_n N_noxref_17_M11_noxref_s ) capacitor \
 c=2.68212e-19 //x=21.21 //y=4.025 //x2=19.18 //y2=0.545
cc_1767 ( N_noxref_7_c_2392_n N_noxref_17_M11_noxref_s ) capacitor \
 c=0.0104658f //x=20.77 //y=1.18 //x2=19.18 //y2=0.545
cc_1768 ( N_noxref_7_c_2486_n N_noxref_17_M11_noxref_s ) capacitor \
 c=8.42257e-19 //x=21.21 //y=3.88 //x2=19.18 //y2=0.545
cc_1769 ( N_noxref_7_M12_noxref_d N_noxref_17_M11_noxref_s ) capacitor \
 c=0.0275552f //x=20.58 //y=1.085 //x2=19.18 //y2=0.545
cc_1770 ( N_VDD_c_2614_n N_D_c_3047_n ) capacitor c=0.00226427f //x=8.63 \
 //y=7.585 //x2=7.18 //y2=4.88
cc_1771 ( N_VDD_c_2601_n N_D_M21_noxref_g ) capacitor c=0.00697352f //x=7.765 \
 //y=7.585 //x2=7.19 //y2=6.2
cc_1772 ( N_VDD_M20_noxref_d N_D_M21_noxref_g ) capacitor c=0.015318f \
 //x=6.825 //y=5.2 //x2=7.19 //y2=6.2
cc_1773 ( N_VDD_c_2601_n N_D_M22_noxref_g ) capacitor c=0.00755544f //x=7.765 \
 //y=7.585 //x2=7.63 //y2=6.2
cc_1774 ( N_VDD_M22_noxref_d N_D_M22_noxref_g ) capacitor c=0.0430452f \
 //x=7.705 //y=5.2 //x2=7.63 //y2=6.2
cc_1775 ( N_VDD_c_2614_n N_D_c_3061_n ) capacitor c=0.0129149f //x=8.63 \
 //y=7.585 //x2=7.555 //y2=4.97
cc_1776 ( N_VDD_c_2614_n N_D_c_3079_n ) capacitor c=2.73429e-19 //x=8.63 \
 //y=7.585 //x2=7.18 //y2=4.88
cc_1777 ( N_VDD_M20_noxref_d N_D_c_3079_n ) capacitor c=3.32552e-19 //x=6.825 \
 //y=5.2 //x2=7.18 //y2=4.88
cc_1778 ( N_VDD_c_2693_n N_GND_c_3368_n ) capacitor c=0.00989514f //x=1.23 \
 //y=7.58 //x2=1.23 //y2=0.18
cc_1779 ( N_VDD_c_2859_n N_GND_c_3173_n ) capacitor c=0.00989514f //x=21.58 \
 //y=7.58 //x2=21.58 //y2=0.18
cc_1780 ( N_VDD_c_2609_n N_GND_c_3174_n ) capacitor c=0.00654453f //x=5.3 \
 //y=7.585 //x2=5.3 //y2=0.175
cc_1781 ( N_VDD_c_2614_n N_GND_c_3179_n ) capacitor c=0.00654453f //x=8.63 \
 //y=7.585 //x2=8.63 //y2=0.175
cc_1782 ( N_VDD_c_2667_n N_GND_c_3220_n ) capacitor c=0.00654453f //x=11.96 \
 //y=7.585 //x2=11.96 //y2=0.175
cc_1783 ( N_VDD_c_2702_n N_GND_c_3239_n ) capacitor c=0.00663779f //x=15.29 \
 //y=7.585 //x2=15.29 //y2=0.175
cc_1784 ( N_VDD_c_2804_n N_GND_c_3327_n ) capacitor c=0.00654453f //x=18.62 \
 //y=7.585 //x2=18.62 //y2=0.175
cc_1785 ( N_noxref_9_c_2981_n N_GND_c_3150_n ) capacitor c=0.0079063f \
 //x=3.505 //y=1.175 //x2=6.395 //y2=0.175
cc_1786 ( N_noxref_9_c_3008_p N_GND_c_3150_n ) capacitor c=0.00685901f \
 //x=3.59 //y=0.805 //x2=6.395 //y2=0.175
cc_1787 ( N_noxref_9_c_2971_n N_GND_c_3150_n ) capacitor c=0.00958276f \
 //x=4.475 //y=0.72 //x2=6.395 //y2=0.175
cc_1788 ( N_noxref_9_c_3010_p N_GND_c_3150_n ) capacitor c=0.00232964f \
 //x=4.56 //y=0.805 //x2=6.395 //y2=0.175
cc_1789 ( N_noxref_9_M1_noxref_d N_GND_c_3150_n ) capacitor c=0.0134285f \
 //x=2.35 //y=1.09 //x2=6.395 //y2=0.175
cc_1790 ( N_noxref_9_M1_noxref_d N_GND_c_3353_n ) capacitor c=0.0156367f \
 //x=2.35 //y=1.09 //x2=1.565 //y2=1.145
cc_1791 ( N_noxref_9_c_2981_n N_GND_c_3170_n ) capacitor c=0.0080792f \
 //x=3.505 //y=1.175 //x2=5.13 //y2=0.175
cc_1792 ( N_noxref_9_c_3008_p N_GND_c_3170_n ) capacitor c=0.0140766f //x=3.59 \
 //y=0.805 //x2=5.13 //y2=0.175
cc_1793 ( N_noxref_9_c_2971_n N_GND_c_3170_n ) capacitor c=0.0364997f \
 //x=4.475 //y=0.72 //x2=5.13 //y2=0.175
cc_1794 ( N_noxref_9_c_3010_p N_GND_c_3170_n ) capacitor c=0.013886f //x=4.56 \
 //y=0.805 //x2=5.13 //y2=0.175
cc_1795 ( N_noxref_9_M2_noxref_s N_GND_c_3368_n ) capacitor c=8.16352e-19 \
 //x=3.455 //y=0.555 //x2=1.23 //y2=0.18
cc_1796 ( N_noxref_9_c_2971_n N_GND_c_3173_n ) capacitor c=0.00189848f \
 //x=4.475 //y=0.72 //x2=21.58 //y2=0.18
cc_1797 ( N_noxref_9_M1_noxref_d N_GND_c_3173_n ) capacitor c=2.7648e-19 \
 //x=2.35 //y=1.09 //x2=21.58 //y2=0.18
cc_1798 ( N_noxref_9_c_3010_p N_GND_c_3174_n ) capacitor c=0.0374312f //x=4.56 \
 //y=0.805 //x2=5.3 //y2=0.175
cc_1799 ( N_noxref_9_M2_noxref_s N_GND_c_3174_n ) capacitor c=0.00519576f \
 //x=3.455 //y=0.555 //x2=5.3 //y2=0.175
cc_1800 ( N_noxref_9_M1_noxref_d N_GND_M0_noxref_d ) capacitor c=3.12752e-19 \
 //x=2.35 //y=1.09 //x2=1.375 //y2=1.055
cc_1801 ( N_noxref_9_c_3008_p N_noxref_12_c_3596_n ) capacitor c=2.15937e-19 \
 //x=3.59 //y=0.805 //x2=2.05 //y2=0.805
cc_1802 ( N_noxref_9_c_2981_n N_noxref_12_c_3574_n ) capacitor c=0.0132582f \
 //x=3.505 //y=1.175 //x2=2.935 //y2=0.72
cc_1803 ( N_noxref_9_M1_noxref_d N_noxref_12_c_3574_n ) capacitor c=0.016458f \
 //x=2.35 //y=1.09 //x2=2.935 //y2=0.72
cc_1804 ( N_noxref_9_c_2981_n N_noxref_12_c_3576_n ) capacitor c=0.00954209f \
 //x=3.505 //y=1.175 //x2=2.935 //y2=1.77
cc_1805 ( N_noxref_9_M1_noxref_d N_noxref_12_c_3576_n ) capacitor c=0.015272f \
 //x=2.35 //y=1.09 //x2=2.935 //y2=1.77
cc_1806 ( N_noxref_9_c_2981_n N_noxref_12_M0_noxref_s ) capacitor c=0.023368f \
 //x=3.505 //y=1.175 //x2=0.945 //y2=0.555
cc_1807 ( N_noxref_9_c_3008_p N_noxref_12_M0_noxref_s ) capacitor c=0.0175532f \
 //x=3.59 //y=0.805 //x2=0.945 //y2=0.555
cc_1808 ( N_noxref_9_c_3010_p N_noxref_12_M0_noxref_s ) capacitor \
 c=2.98721e-19 //x=4.56 //y=0.805 //x2=0.945 //y2=0.555
cc_1809 ( N_noxref_9_M1_noxref_d N_noxref_12_M0_noxref_s ) capacitor \
 c=0.0187969f //x=2.35 //y=1.09 //x2=0.945 //y2=0.555
cc_1810 ( N_noxref_9_M2_noxref_s N_noxref_12_M0_noxref_s ) capacitor \
 c=0.021082f //x=3.455 //y=0.555 //x2=0.945 //y2=0.555
cc_1811 ( N_noxref_9_c_3010_p N_noxref_13_M3_noxref_s ) capacitor \
 c=0.00370912f //x=4.56 //y=0.805 //x2=5.86 //y2=0.545
cc_1812 ( N_noxref_9_M2_noxref_s N_noxref_13_M3_noxref_s ) capacitor \
 c=0.00101401f //x=3.455 //y=0.555 //x2=5.86 //y2=0.545
cc_1813 ( N_D_c_3044_n N_GND_c_3151_n ) capacitor c=0.00234561f //x=7.15 \
 //y=2.26 //x2=9.725 //y2=0.175
cc_1814 ( N_D_c_3044_n N_GND_c_3171_n ) capacitor c=3.77328e-19 //x=7.15 \
 //y=2.26 //x2=8.46 //y2=0.175
cc_1815 ( N_D_c_3046_n N_GND_c_3179_n ) capacitor c=0.00224736f //x=7.15 \
 //y=2.26 //x2=8.63 //y2=0.175
cc_1816 ( N_D_c_3072_n N_GND_c_3179_n ) capacitor c=0.00275184f //x=7.715 \
 //y=1.43 //x2=8.63 //y2=0.175
cc_1817 ( N_D_c_3076_n N_GND_c_3179_n ) capacitor c=2.63786e-19 //x=7.15 \
 //y=2.26 //x2=8.63 //y2=0.175
cc_1818 ( N_D_c_3044_n N_noxref_13_c_3629_n ) capacitor c=7.50092e-19 //x=7.15 \
 //y=2.26 //x2=6.965 //y2=1.675
cc_1819 ( N_D_c_3060_n N_noxref_13_c_3629_n ) capacitor c=0.00888238f \
 //x=7.185 //y=1.74 //x2=6.965 //y2=1.675
cc_1820 ( N_D_c_3076_n N_noxref_13_c_3629_n ) capacitor c=0.00175171f //x=7.15 \
 //y=2.26 //x2=6.965 //y2=1.675
cc_1821 ( N_D_c_3044_n N_noxref_13_c_3631_n ) capacitor c=0.00141156f //x=7.15 \
 //y=2.26 //x2=7.85 //y2=0.71
cc_1822 ( N_D_c_3046_n N_noxref_13_c_3631_n ) capacitor c=8.82141e-19 //x=7.15 \
 //y=2.26 //x2=7.85 //y2=0.71
cc_1823 ( N_D_c_3055_n N_noxref_13_c_3631_n ) capacitor c=0.0199501f //x=7.185 \
 //y=1.085 //x2=7.85 //y2=0.71
cc_1824 ( N_D_c_3070_n N_noxref_13_c_3631_n ) capacitor c=0.00825432f \
 //x=7.715 //y=1.085 //x2=7.85 //y2=0.71
cc_1825 ( N_D_c_3076_n N_noxref_13_c_3631_n ) capacitor c=2.1838e-19 //x=7.15 \
 //y=2.26 //x2=7.85 //y2=0.71
cc_1826 ( N_D_c_3055_n N_noxref_13_M3_noxref_s ) capacitor c=0.00888238f \
 //x=7.185 //y=1.085 //x2=5.86 //y2=0.545
cc_1827 ( N_D_c_3070_n N_noxref_13_M3_noxref_s ) capacitor c=0.015333f \
 //x=7.715 //y=1.085 //x2=5.86 //y2=0.545
cc_1828 ( N_D_c_3072_n N_noxref_13_M3_noxref_s ) capacitor c=0.00248746f \
 //x=7.715 //y=1.43 //x2=5.86 //y2=0.545
cc_1829 ( N_GND_c_3438_p N_noxref_12_c_3585_n ) capacitor c=0.00293992f \
 //x=1.48 //y=0.175 //x2=1.965 //y2=1.77
cc_1830 ( N_GND_c_3150_n N_noxref_12_c_3585_n ) capacitor c=7.0078e-19 \
 //x=6.395 //y=0.175 //x2=1.965 //y2=1.77
cc_1831 ( N_GND_c_3353_n N_noxref_12_c_3585_n ) capacitor c=0.00379381f \
 //x=1.565 //y=1.145 //x2=1.965 //y2=1.77
cc_1832 ( N_GND_c_3170_n N_noxref_12_c_3585_n ) capacitor c=0.00371813f \
 //x=5.13 //y=0.175 //x2=1.965 //y2=1.77
cc_1833 ( N_GND_M0_noxref_d N_noxref_12_c_3585_n ) capacitor c=0.00578031f \
 //x=1.375 //y=1.055 //x2=1.965 //y2=1.77
cc_1834 ( N_GND_c_3343_n N_noxref_12_c_3596_n ) capacitor c=0.0169052f \
 //x=1.565 //y=1.015 //x2=2.05 //y2=0.805
cc_1835 ( N_GND_c_3150_n N_noxref_12_c_3596_n ) capacitor c=0.00710913f \
 //x=6.395 //y=0.175 //x2=2.05 //y2=0.805
cc_1836 ( N_GND_c_3170_n N_noxref_12_c_3596_n ) capacitor c=0.0140604f \
 //x=5.13 //y=0.175 //x2=2.05 //y2=0.805
cc_1837 ( N_GND_c_3368_n N_noxref_12_c_3596_n ) capacitor c=0.00323118f \
 //x=1.23 //y=0.18 //x2=2.05 //y2=0.805
cc_1838 ( N_GND_c_3150_n N_noxref_12_c_3574_n ) capacitor c=0.0138334f \
 //x=6.395 //y=0.175 //x2=2.935 //y2=0.72
cc_1839 ( N_GND_c_3170_n N_noxref_12_c_3574_n ) capacitor c=0.0356451f \
 //x=5.13 //y=0.175 //x2=2.935 //y2=0.72
cc_1840 ( N_GND_c_3173_n N_noxref_12_c_3574_n ) capacitor c=0.00177725f \
 //x=21.58 //y=0.18 //x2=2.935 //y2=0.72
cc_1841 ( N_GND_c_3438_p N_noxref_12_M0_noxref_s ) capacitor c=0.00710913f \
 //x=1.48 //y=0.175 //x2=0.945 //y2=0.555
cc_1842 ( N_GND_c_3343_n N_noxref_12_M0_noxref_s ) capacitor c=0.0173062f \
 //x=1.565 //y=1.015 //x2=0.945 //y2=0.555
cc_1843 ( N_GND_c_3150_n N_noxref_12_M0_noxref_s ) capacitor c=0.00683407f \
 //x=6.395 //y=0.175 //x2=0.945 //y2=0.555
cc_1844 ( N_GND_c_3353_n N_noxref_12_M0_noxref_s ) capacitor c=0.0113024f \
 //x=1.565 //y=1.145 //x2=0.945 //y2=0.555
cc_1845 ( N_GND_c_3170_n N_noxref_12_M0_noxref_s ) capacitor c=0.0272246f \
 //x=5.13 //y=0.175 //x2=0.945 //y2=0.555
cc_1846 ( N_GND_c_3368_n N_noxref_12_M0_noxref_s ) capacitor c=0.0675506f \
 //x=1.23 //y=0.18 //x2=0.945 //y2=0.555
cc_1847 ( N_GND_c_3174_n N_noxref_12_M0_noxref_s ) capacitor c=0.00166451f \
 //x=5.3 //y=0.175 //x2=0.945 //y2=0.555
cc_1848 ( N_GND_M0_noxref_d N_noxref_12_M0_noxref_s ) capacitor c=0.0271316f \
 //x=1.375 //y=1.055 //x2=0.945 //y2=0.555
cc_1849 ( N_GND_c_3150_n N_noxref_13_c_3627_n ) capacitor c=9.8916e-19 \
 //x=6.395 //y=0.175 //x2=6.88 //y2=1.76
cc_1850 ( N_GND_c_3151_n N_noxref_13_c_3627_n ) capacitor c=7.45647e-19 \
 //x=9.725 //y=0.175 //x2=6.88 //y2=1.76
cc_1851 ( N_GND_c_3154_n N_noxref_13_c_3627_n ) capacitor c=0.00402268f \
 //x=6.48 //y=1.135 //x2=6.88 //y2=1.76
cc_1852 ( N_GND_c_3171_n N_noxref_13_c_3627_n ) capacitor c=0.00392838f \
 //x=8.46 //y=0.175 //x2=6.88 //y2=1.76
cc_1853 ( N_GND_M3_noxref_d N_noxref_13_c_3627_n ) capacitor c=0.00578453f \
 //x=6.29 //y=1.045 //x2=6.88 //y2=1.76
cc_1854 ( N_GND_c_3151_n N_noxref_13_c_3670_n ) capacitor c=0.0068323f \
 //x=9.725 //y=0.175 //x2=6.965 //y2=0.795
cc_1855 ( N_GND_c_3256_n N_noxref_13_c_3670_n ) capacitor c=0.0120153f \
 //x=6.477 //y=1.005 //x2=6.965 //y2=0.795
cc_1856 ( N_GND_c_3171_n N_noxref_13_c_3670_n ) capacitor c=0.0146605f \
 //x=8.46 //y=0.175 //x2=6.965 //y2=0.795
cc_1857 ( N_GND_c_3174_n N_noxref_13_c_3670_n ) capacitor c=0.00282583f \
 //x=5.3 //y=0.175 //x2=6.965 //y2=0.795
cc_1858 ( N_GND_c_3179_n N_noxref_13_c_3670_n ) capacitor c=2.99356e-19 \
 //x=8.63 //y=0.175 //x2=6.965 //y2=0.795
cc_1859 ( N_GND_c_3174_n N_noxref_13_c_3629_n ) capacitor c=2.8386e-19 //x=5.3 \
 //y=0.175 //x2=6.965 //y2=1.675
cc_1860 ( N_GND_c_3151_n N_noxref_13_c_3631_n ) capacitor c=0.0100533f \
 //x=9.725 //y=0.175 //x2=7.85 //y2=0.71
cc_1861 ( N_GND_c_3171_n N_noxref_13_c_3631_n ) capacitor c=0.0374802f \
 //x=8.46 //y=0.175 //x2=7.85 //y2=0.71
cc_1862 ( N_GND_c_3173_n N_noxref_13_c_3631_n ) capacitor c=0.00198885f \
 //x=21.58 //y=0.18 //x2=7.85 //y2=0.71
cc_1863 ( N_GND_c_3151_n N_noxref_13_c_3679_n ) capacitor c=0.00250904f \
 //x=9.725 //y=0.175 //x2=7.935 //y2=0.795
cc_1864 ( N_GND_c_3171_n N_noxref_13_c_3679_n ) capacitor c=0.0145784f \
 //x=8.46 //y=0.175 //x2=7.935 //y2=0.795
cc_1865 ( N_GND_c_3179_n N_noxref_13_c_3679_n ) capacitor c=0.0392026f \
 //x=8.63 //y=0.175 //x2=7.935 //y2=0.795
cc_1866 ( N_GND_c_3150_n N_noxref_13_M3_noxref_s ) capacitor c=0.00724992f \
 //x=6.395 //y=0.175 //x2=5.86 //y2=0.545
cc_1867 ( N_GND_c_3154_n N_noxref_13_M3_noxref_s ) capacitor c=0.0100997f \
 //x=6.48 //y=1.135 //x2=5.86 //y2=0.545
cc_1868 ( N_GND_c_3256_n N_noxref_13_M3_noxref_s ) capacitor c=0.0170652f \
 //x=6.477 //y=1.005 //x2=5.86 //y2=0.545
cc_1869 ( N_GND_c_3171_n N_noxref_13_M3_noxref_s ) capacitor c=0.014661f \
 //x=8.46 //y=0.175 //x2=5.86 //y2=0.545
cc_1870 ( N_GND_c_3174_n N_noxref_13_M3_noxref_s ) capacitor c=0.0528206f \
 //x=5.3 //y=0.175 //x2=5.86 //y2=0.545
cc_1871 ( N_GND_c_3179_n N_noxref_13_M3_noxref_s ) capacitor c=0.0064811f \
 //x=8.63 //y=0.175 //x2=5.86 //y2=0.545
cc_1872 ( N_GND_M3_noxref_d N_noxref_13_M3_noxref_s ) capacitor c=0.0271276f \
 //x=6.29 //y=1.045 //x2=5.86 //y2=0.545
cc_1873 ( N_GND_c_3151_n N_noxref_14_c_3694_n ) capacitor c=9.79596e-19 \
 //x=9.725 //y=0.175 //x2=10.21 //y2=1.76
cc_1874 ( N_GND_c_3195_n N_noxref_14_c_3694_n ) capacitor c=7.74325e-19 \
 //x=13.055 //y=0.175 //x2=10.21 //y2=1.76
cc_1875 ( N_GND_c_3157_n N_noxref_14_c_3694_n ) capacitor c=0.00400656f \
 //x=9.81 //y=1.135 //x2=10.21 //y2=1.76
cc_1876 ( N_GND_c_3172_n N_noxref_14_c_3694_n ) capacitor c=0.00392838f \
 //x=11.79 //y=0.175 //x2=10.21 //y2=1.76
cc_1877 ( N_GND_M5_noxref_d N_noxref_14_c_3694_n ) capacitor c=0.00578453f \
 //x=9.62 //y=1.045 //x2=10.21 //y2=1.76
cc_1878 ( N_GND_c_3195_n N_noxref_14_c_3735_n ) capacitor c=0.00560387f \
 //x=13.055 //y=0.175 //x2=10.295 //y2=0.795
cc_1879 ( N_GND_c_3167_n N_noxref_14_c_3735_n ) capacitor c=0.0120153f \
 //x=9.807 //y=1.005 //x2=10.295 //y2=0.795
cc_1880 ( N_GND_c_3172_n N_noxref_14_c_3735_n ) capacitor c=0.0146605f \
 //x=11.79 //y=0.175 //x2=10.295 //y2=0.795
cc_1881 ( N_GND_c_3179_n N_noxref_14_c_3735_n ) capacitor c=0.00282552f \
 //x=8.63 //y=0.175 //x2=10.295 //y2=0.795
cc_1882 ( N_GND_c_3220_n N_noxref_14_c_3735_n ) capacitor c=2.99356e-19 \
 //x=11.96 //y=0.175 //x2=10.295 //y2=0.795
cc_1883 ( N_GND_c_3179_n N_noxref_14_c_3702_n ) capacitor c=2.8386e-19 \
 //x=8.63 //y=0.175 //x2=10.295 //y2=1.675
cc_1884 ( N_GND_c_3195_n N_noxref_14_c_3707_n ) capacitor c=0.00989636f \
 //x=13.055 //y=0.175 //x2=11.18 //y2=0.71
cc_1885 ( N_GND_c_3172_n N_noxref_14_c_3707_n ) capacitor c=0.0374802f \
 //x=11.79 //y=0.175 //x2=11.18 //y2=0.71
cc_1886 ( N_GND_c_3173_n N_noxref_14_c_3707_n ) capacitor c=0.00198885f \
 //x=21.58 //y=0.18 //x2=11.18 //y2=0.71
cc_1887 ( N_GND_c_3195_n N_noxref_14_c_3744_n ) capacitor c=0.00250904f \
 //x=13.055 //y=0.175 //x2=11.265 //y2=0.795
cc_1888 ( N_GND_c_3172_n N_noxref_14_c_3744_n ) capacitor c=0.0145784f \
 //x=11.79 //y=0.175 //x2=11.265 //y2=0.795
cc_1889 ( N_GND_c_3220_n N_noxref_14_c_3744_n ) capacitor c=0.0392026f \
 //x=11.96 //y=0.175 //x2=11.265 //y2=0.795
cc_1890 ( N_GND_c_3151_n N_noxref_14_M5_noxref_s ) capacitor c=0.00724992f \
 //x=9.725 //y=0.175 //x2=9.19 //y2=0.545
cc_1891 ( N_GND_c_3157_n N_noxref_14_M5_noxref_s ) capacitor c=0.0099136f \
 //x=9.81 //y=1.135 //x2=9.19 //y2=0.545
cc_1892 ( N_GND_c_3167_n N_noxref_14_M5_noxref_s ) capacitor c=0.0123761f \
 //x=9.807 //y=1.005 //x2=9.19 //y2=0.545
cc_1893 ( N_GND_c_3172_n N_noxref_14_M5_noxref_s ) capacitor c=0.014661f \
 //x=11.79 //y=0.175 //x2=9.19 //y2=0.545
cc_1894 ( N_GND_c_3179_n N_noxref_14_M5_noxref_s ) capacitor c=0.0518718f \
 //x=8.63 //y=0.175 //x2=9.19 //y2=0.545
cc_1895 ( N_GND_c_3220_n N_noxref_14_M5_noxref_s ) capacitor c=0.0064811f \
 //x=11.96 //y=0.175 //x2=9.19 //y2=0.545
cc_1896 ( N_GND_M5_noxref_d N_noxref_14_M5_noxref_s ) capacitor c=0.0271276f \
 //x=9.62 //y=1.045 //x2=9.19 //y2=0.545
cc_1897 ( N_GND_c_3195_n N_noxref_15_c_3762_n ) capacitor c=9.79596e-19 \
 //x=13.055 //y=0.175 //x2=13.54 //y2=1.76
cc_1898 ( N_GND_c_3237_n N_noxref_15_c_3762_n ) capacitor c=7.74325e-19 \
 //x=16.385 //y=0.175 //x2=13.54 //y2=1.76
cc_1899 ( N_GND_c_3202_n N_noxref_15_c_3762_n ) capacitor c=0.00400678f \
 //x=13.14 //y=1.135 //x2=13.54 //y2=1.76
cc_1900 ( N_GND_c_3217_n N_noxref_15_c_3762_n ) capacitor c=0.00392838f \
 //x=15.12 //y=0.175 //x2=13.54 //y2=1.76
cc_1901 ( N_GND_M7_noxref_d N_noxref_15_c_3762_n ) capacitor c=0.00578453f \
 //x=12.95 //y=1.045 //x2=13.54 //y2=1.76
cc_1902 ( N_GND_c_3237_n N_noxref_15_c_3801_n ) capacitor c=0.00668337f \
 //x=16.385 //y=0.175 //x2=13.625 //y2=0.795
cc_1903 ( N_GND_c_3212_n N_noxref_15_c_3801_n ) capacitor c=0.0120153f \
 //x=13.137 //y=1.005 //x2=13.625 //y2=0.795
cc_1904 ( N_GND_c_3217_n N_noxref_15_c_3801_n ) capacitor c=0.0146605f \
 //x=15.12 //y=0.175 //x2=13.625 //y2=0.795
cc_1905 ( N_GND_c_3220_n N_noxref_15_c_3801_n ) capacitor c=0.00282552f \
 //x=11.96 //y=0.175 //x2=13.625 //y2=0.795
cc_1906 ( N_GND_c_3239_n N_noxref_15_c_3801_n ) capacitor c=2.99356e-19 \
 //x=15.29 //y=0.175 //x2=13.625 //y2=0.795
cc_1907 ( N_GND_c_3220_n N_noxref_15_c_3770_n ) capacitor c=2.8386e-19 \
 //x=11.96 //y=0.175 //x2=13.625 //y2=1.675
cc_1908 ( N_GND_c_3237_n N_noxref_15_c_3777_n ) capacitor c=0.00980233f \
 //x=16.385 //y=0.175 //x2=14.51 //y2=0.71
cc_1909 ( N_GND_c_3217_n N_noxref_15_c_3777_n ) capacitor c=0.0375602f \
 //x=15.12 //y=0.175 //x2=14.51 //y2=0.71
cc_1910 ( N_GND_c_3173_n N_noxref_15_c_3777_n ) capacitor c=0.00198885f \
 //x=21.58 //y=0.18 //x2=14.51 //y2=0.71
cc_1911 ( N_GND_c_3237_n N_noxref_15_c_3810_n ) capacitor c=0.00327337f \
 //x=16.385 //y=0.175 //x2=14.595 //y2=0.795
cc_1912 ( N_GND_c_3217_n N_noxref_15_c_3810_n ) capacitor c=0.0144893f \
 //x=15.12 //y=0.175 //x2=14.595 //y2=0.795
cc_1913 ( N_GND_c_3239_n N_noxref_15_c_3810_n ) capacitor c=0.0392026f \
 //x=15.29 //y=0.175 //x2=14.595 //y2=0.795
cc_1914 ( N_GND_c_3195_n N_noxref_15_M7_noxref_s ) capacitor c=0.00724992f \
 //x=13.055 //y=0.175 //x2=12.52 //y2=0.545
cc_1915 ( N_GND_c_3202_n N_noxref_15_M7_noxref_s ) capacitor c=0.0099136f \
 //x=13.14 //y=1.135 //x2=12.52 //y2=0.545
cc_1916 ( N_GND_c_3212_n N_noxref_15_M7_noxref_s ) capacitor c=0.0123761f \
 //x=13.137 //y=1.005 //x2=12.52 //y2=0.545
cc_1917 ( N_GND_c_3217_n N_noxref_15_M7_noxref_s ) capacitor c=0.014661f \
 //x=15.12 //y=0.175 //x2=12.52 //y2=0.545
cc_1918 ( N_GND_c_3220_n N_noxref_15_M7_noxref_s ) capacitor c=0.0518718f \
 //x=11.96 //y=0.175 //x2=12.52 //y2=0.545
cc_1919 ( N_GND_c_3239_n N_noxref_15_M7_noxref_s ) capacitor c=0.0064811f \
 //x=15.29 //y=0.175 //x2=12.52 //y2=0.545
cc_1920 ( N_GND_M7_noxref_d N_noxref_15_M7_noxref_s ) capacitor c=0.0271276f \
 //x=12.95 //y=1.045 //x2=12.52 //y2=0.545
cc_1921 ( N_GND_c_3237_n N_noxref_16_c_3828_n ) capacitor c=0.00101784f \
 //x=16.385 //y=0.175 //x2=16.87 //y2=1.76
cc_1922 ( N_GND_c_3301_n N_noxref_16_c_3828_n ) capacitor c=7.74325e-19 \
 //x=19.715 //y=0.175 //x2=16.87 //y2=1.76
cc_1923 ( N_GND_c_3259_n N_noxref_16_c_3828_n ) capacitor c=0.00400855f \
 //x=16.47 //y=1.135 //x2=16.87 //y2=1.76
cc_1924 ( N_GND_c_3273_n N_noxref_16_c_3828_n ) capacitor c=0.00392838f \
 //x=18.45 //y=0.175 //x2=16.87 //y2=1.76
cc_1925 ( N_GND_M9_noxref_d N_noxref_16_c_3828_n ) capacitor c=0.00578453f \
 //x=16.28 //y=1.045 //x2=16.87 //y2=1.76
cc_1926 ( N_GND_c_3301_n N_noxref_16_c_3867_n ) capacitor c=0.00570921f \
 //x=19.715 //y=0.175 //x2=16.955 //y2=0.795
cc_1927 ( N_GND_c_3268_n N_noxref_16_c_3867_n ) capacitor c=0.0120153f \
 //x=16.467 //y=1.005 //x2=16.955 //y2=0.795
cc_1928 ( N_GND_c_3273_n N_noxref_16_c_3867_n ) capacitor c=0.0146605f \
 //x=18.45 //y=0.175 //x2=16.955 //y2=0.795
cc_1929 ( N_GND_c_3239_n N_noxref_16_c_3867_n ) capacitor c=0.00282552f \
 //x=15.29 //y=0.175 //x2=16.955 //y2=0.795
cc_1930 ( N_GND_c_3327_n N_noxref_16_c_3867_n ) capacitor c=2.99356e-19 \
 //x=18.62 //y=0.175 //x2=16.955 //y2=0.795
cc_1931 ( N_GND_c_3239_n N_noxref_16_c_3836_n ) capacitor c=2.8386e-19 \
 //x=15.29 //y=0.175 //x2=16.955 //y2=1.675
cc_1932 ( N_GND_c_3301_n N_noxref_16_c_3841_n ) capacitor c=0.00972997f \
 //x=19.715 //y=0.175 //x2=17.84 //y2=0.71
cc_1933 ( N_GND_c_3273_n N_noxref_16_c_3841_n ) capacitor c=0.0374802f \
 //x=18.45 //y=0.175 //x2=17.84 //y2=0.71
cc_1934 ( N_GND_c_3173_n N_noxref_16_c_3841_n ) capacitor c=0.00198885f \
 //x=21.58 //y=0.18 //x2=17.84 //y2=0.71
cc_1935 ( N_GND_c_3301_n N_noxref_16_c_3876_n ) capacitor c=0.00250795f \
 //x=19.715 //y=0.175 //x2=17.925 //y2=0.795
cc_1936 ( N_GND_c_3273_n N_noxref_16_c_3876_n ) capacitor c=0.0145777f \
 //x=18.45 //y=0.175 //x2=17.925 //y2=0.795
cc_1937 ( N_GND_c_3327_n N_noxref_16_c_3876_n ) capacitor c=0.0392026f \
 //x=18.62 //y=0.175 //x2=17.925 //y2=0.795
cc_1938 ( N_GND_c_3237_n N_noxref_16_M9_noxref_s ) capacitor c=0.00724992f \
 //x=16.385 //y=0.175 //x2=15.85 //y2=0.545
cc_1939 ( N_GND_c_3259_n N_noxref_16_M9_noxref_s ) capacitor c=0.0099136f \
 //x=16.47 //y=1.135 //x2=15.85 //y2=0.545
cc_1940 ( N_GND_c_3268_n N_noxref_16_M9_noxref_s ) capacitor c=0.0123761f \
 //x=16.467 //y=1.005 //x2=15.85 //y2=0.545
cc_1941 ( N_GND_c_3273_n N_noxref_16_M9_noxref_s ) capacitor c=0.014661f \
 //x=18.45 //y=0.175 //x2=15.85 //y2=0.545
cc_1942 ( N_GND_c_3239_n N_noxref_16_M9_noxref_s ) capacitor c=0.0518718f \
 //x=15.29 //y=0.175 //x2=15.85 //y2=0.545
cc_1943 ( N_GND_c_3327_n N_noxref_16_M9_noxref_s ) capacitor c=0.0064811f \
 //x=18.62 //y=0.175 //x2=15.85 //y2=0.545
cc_1944 ( N_GND_M9_noxref_d N_noxref_16_M9_noxref_s ) capacitor c=0.0271276f \
 //x=16.28 //y=1.045 //x2=15.85 //y2=0.545
cc_1945 ( N_GND_c_3301_n N_noxref_17_c_3894_n ) capacitor c=9.79596e-19 \
 //x=19.715 //y=0.175 //x2=20.2 //y2=1.76
cc_1946 ( N_GND_c_3351_n N_noxref_17_c_3894_n ) capacitor c=0.00203804f \
 //x=21.58 //y=0.18 //x2=20.2 //y2=1.76
cc_1947 ( N_GND_c_3308_n N_noxref_17_c_3894_n ) capacitor c=0.00398561f \
 //x=19.8 //y=1.135 //x2=20.2 //y2=1.76
cc_1948 ( N_GND_c_3173_n N_noxref_17_c_3894_n ) capacitor c=0.00387051f \
 //x=21.58 //y=0.18 //x2=20.2 //y2=1.76
cc_1949 ( N_GND_M11_noxref_d N_noxref_17_c_3894_n ) capacitor c=0.00578453f \
 //x=19.61 //y=1.045 //x2=20.2 //y2=1.76
cc_1950 ( N_GND_c_3351_n N_noxref_17_c_3935_n ) capacitor c=0.00560307f \
 //x=21.58 //y=0.18 //x2=20.285 //y2=0.795
cc_1951 ( N_GND_c_3319_n N_noxref_17_c_3935_n ) capacitor c=0.0167642f \
 //x=19.797 //y=1.005 //x2=20.285 //y2=0.795
cc_1952 ( N_GND_c_3173_n N_noxref_17_c_3935_n ) capacitor c=0.0148823f \
 //x=21.58 //y=0.18 //x2=20.285 //y2=0.795
cc_1953 ( N_GND_c_3327_n N_noxref_17_c_3935_n ) capacitor c=0.00282552f \
 //x=18.62 //y=0.175 //x2=20.285 //y2=0.795
cc_1954 ( N_GND_c_3327_n N_noxref_17_c_3902_n ) capacitor c=2.8386e-19 \
 //x=18.62 //y=0.175 //x2=20.285 //y2=1.675
cc_1955 ( N_GND_c_3351_n N_noxref_17_c_3910_n ) capacitor c=0.00993072f \
 //x=21.58 //y=0.18 //x2=21.17 //y2=0.71
cc_1956 ( N_GND_c_3173_n N_noxref_17_c_3910_n ) capacitor c=0.0395491f \
 //x=21.58 //y=0.18 //x2=21.17 //y2=0.71
cc_1957 ( N_GND_c_3351_n N_noxref_17_c_3942_n ) capacitor c=0.00253402f \
 //x=21.58 //y=0.18 //x2=21.255 //y2=0.795
cc_1958 ( N_GND_c_3173_n N_noxref_17_c_3942_n ) capacitor c=0.0567734f \
 //x=21.58 //y=0.18 //x2=21.255 //y2=0.795
cc_1959 ( N_GND_c_3301_n N_noxref_17_M11_noxref_s ) capacitor c=0.00724992f \
 //x=19.715 //y=0.175 //x2=19.18 //y2=0.545
cc_1960 ( N_GND_c_3308_n N_noxref_17_M11_noxref_s ) capacitor c=0.0100024f \
 //x=19.8 //y=1.135 //x2=19.18 //y2=0.545
cc_1961 ( N_GND_c_3319_n N_noxref_17_M11_noxref_s ) capacitor c=0.012617f \
 //x=19.797 //y=1.005 //x2=19.18 //y2=0.545
cc_1962 ( N_GND_c_3173_n N_noxref_17_M11_noxref_s ) capacitor c=0.0212998f \
 //x=21.58 //y=0.18 //x2=19.18 //y2=0.545
cc_1963 ( N_GND_c_3327_n N_noxref_17_M11_noxref_s ) capacitor c=0.0518718f \
 //x=18.62 //y=0.175 //x2=19.18 //y2=0.545
cc_1964 ( N_GND_M11_noxref_d N_noxref_17_M11_noxref_s ) capacitor c=0.0271276f \
 //x=19.61 //y=1.045 //x2=19.18 //y2=0.545
cc_1965 ( N_noxref_13_c_3629_n N_noxref_14_c_3692_n ) capacitor c=5.34352e-19 \
 //x=6.965 //y=1.675 //x2=9.325 //y2=1.675
cc_1966 ( N_noxref_13_c_3679_n N_noxref_14_M5_noxref_s ) capacitor \
 c=0.0045327f //x=7.935 //y=0.795 //x2=9.19 //y2=0.545
cc_1967 ( N_noxref_13_M3_noxref_s N_noxref_14_M5_noxref_s ) capacitor \
 c=5.34352e-19 //x=5.86 //y=0.545 //x2=9.19 //y2=0.545
cc_1968 ( N_noxref_14_c_3702_n N_noxref_15_c_3760_n ) capacitor c=5.34352e-19 \
 //x=10.295 //y=1.675 //x2=12.655 //y2=1.675
cc_1969 ( N_noxref_14_c_3744_n N_noxref_15_M7_noxref_s ) capacitor \
 c=0.0045327f //x=11.265 //y=0.795 //x2=12.52 //y2=0.545
cc_1970 ( N_noxref_14_M5_noxref_s N_noxref_15_M7_noxref_s ) capacitor \
 c=5.34352e-19 //x=9.19 //y=0.545 //x2=12.52 //y2=0.545
cc_1971 ( N_noxref_15_c_3770_n N_noxref_16_c_3826_n ) capacitor c=5.34352e-19 \
 //x=13.625 //y=1.675 //x2=15.985 //y2=1.675
cc_1972 ( N_noxref_15_c_3810_n N_noxref_16_M9_noxref_s ) capacitor \
 c=0.0045327f //x=14.595 //y=0.795 //x2=15.85 //y2=0.545
cc_1973 ( N_noxref_15_M7_noxref_s N_noxref_16_M9_noxref_s ) capacitor \
 c=5.34352e-19 //x=12.52 //y=0.545 //x2=15.85 //y2=0.545
cc_1974 ( N_noxref_16_c_3836_n N_noxref_17_c_3892_n ) capacitor c=5.34352e-19 \
 //x=16.955 //y=1.675 //x2=19.315 //y2=1.675
cc_1975 ( N_noxref_16_c_3876_n N_noxref_17_M11_noxref_s ) capacitor \
 c=0.0045327f //x=17.925 //y=0.795 //x2=19.18 //y2=0.545
cc_1976 ( N_noxref_16_M9_noxref_s N_noxref_17_M11_noxref_s ) capacitor \
 c=5.34352e-19 //x=15.85 //y=0.545 //x2=19.18 //y2=0.545
