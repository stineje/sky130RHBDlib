// File: TIELO.spi
// Created: Thu Jan 22 07:08:24 2026
// Program "Calibre xRC"
// Version "v2023.2_27.15"
//
simulator lang=spectre
include "/import/yukari1/lrburle/sky130RHBDlib/sky130_rhbd/pex/TIELO.pex.spice"
subckt TIELO (  VDD YN GND )
//
// GND	GND
// YN	YN
// VDD	VDD
M0_noxref ( N_YN_M0_noxref_d N_noxref_3_M0_noxref_g N_GND_M0_noxref_s \
 noxref_45 ) NMOS l=0.163346 w=2.31104 m=1
M1_noxref ( N_noxref_3_M1_noxref_d N_noxref_3_M1_noxref_g N_VDD_M1_noxref_s \
 noxref_43 ) PMOS l=0.15 w=2 ad=0.57 as=0.57 pd=2.57 ps=2.57 nrd=0 nrs=0 m=1
M2_noxref ( N_VDD_M2_noxref_d N_noxref_3_M2_noxref_g N_noxref_3_M1_noxref_d \
 noxref_43 ) PMOS l=0.15 w=2 ad=0.56 as=0.56 pd=2.56 ps=2.56 nrd=0 nrs=0 m=1
//
include "/import/yukari1/lrburle/sky130RHBDlib/sky130_rhbd/pex/TIELO.pxi.spice"
//
ends TIELO
//
//
