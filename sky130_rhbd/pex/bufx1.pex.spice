// File: bufx1.spi.pex
// Created: Fri Feb 20 10:19:06 2026
// Program "Calibre xRC"
// Version "v2023.2_27.15"
// Nominal Temperature: 30C
// Circuit Temperature: 30C
//
simulator lang=spectre
subckt PM_BUFX1\%noxref_1 ( 2 4 5 6 7 8 10 11 12 14 15 16 18 23 27 31 40 42 43 \
 51 63 72 76 77 78 79 80 81 82 86 87 88 90 96 97 99 107 109 )
c176 ( 107 0 ) capacitor c=0.00869746f //x=0.925 //y=0.91
c177 ( 99 0 ) capacitor c=0.0555104f //x=2.96 //y=2.085
c178 ( 97 0 ) capacitor c=0.0439576f //x=3.6 //y=1.255
c179 ( 96 0 ) capacitor c=0.0201087f //x=3.6 //y=0.91
c180 ( 90 0 ) capacitor c=0.0161986f //x=3.445 //y=1.41
c181 ( 88 0 ) capacitor c=0.0157807f //x=3.445 //y=0.755
c182 ( 87 0 ) capacitor c=0.0557874f //x=3.19 //y=4.79
c183 ( 86 0 ) capacitor c=0.0406047f //x=3.48 //y=4.79
c184 ( 82 0 ) capacitor c=0.0301471f //x=3.07 //y=1.92
c185 ( 81 0 ) capacitor c=0.0255349f //x=3.07 //y=1.565
c186 ( 80 0 ) capacitor c=0.0234346f //x=3.07 //y=1.255
c187 ( 79 0 ) capacitor c=0.02013f //x=3.07 //y=0.91
c188 ( 78 0 ) capacitor c=0.153839f //x=3.555 //y=6.02
c189 ( 77 0 ) capacitor c=0.15434f //x=3.115 //y=6.02
c190 ( 72 0 ) capacitor c=9.45276e-19 //x=2.96 //y=4.7
c191 ( 63 0 ) capacitor c=6.43121e-19 //x=2.96 //y=2.085
c192 ( 51 0 ) capacitor c=0.0263113f //x=1.115 //y=5.38
c193 ( 43 0 ) capacitor c=0.0559047f //x=2.8 //y=2.595
c194 ( 42 0 ) capacitor c=0.00449964f //x=2.96 //y=2.595
c195 ( 40 0 ) capacitor c=0.00515997f //x=1.64 //y=2.595
c196 ( 31 0 ) capacitor c=0.0110654f //x=2.96 //y=2.085
c197 ( 27 0 ) capacitor c=0.0123983f //x=2.96 //y=2.59
c198 ( 23 0 ) capacitor c=0.0143255f //x=1.48 //y=2.59
c199 ( 18 0 ) capacitor c=0.0188628f //x=1.11 //y=1.005
c200 ( 16 0 ) capacitor c=0.0606876f //x=2.96 //y=4.58
c201 ( 15 0 ) capacitor c=0.0116361f //x=2.96 //y=2.755
c202 ( 14 0 ) capacitor c=0.00275838f //x=2.96 //y=2.435
c203 ( 12 0 ) capacitor c=0.0599826f //x=1.48 //y=4.875
c204 ( 11 0 ) capacitor c=0.0118609f //x=1.48 //y=2.755
c205 ( 10 0 ) capacitor c=0.00921769f //x=1.48 //y=2.435
c206 ( 8 0 ) capacitor c=0.00714889f //x=1.2 //y=4.96
c207 ( 7 0 ) capacitor c=0.00753338f //x=1.395 //y=4.96
c208 ( 6 0 ) capacitor c=0.00882254f //x=1.195 //y=1.84
c209 ( 5 0 ) capacitor c=0.0115297f //x=1.395 //y=1.84
c210 ( 4 0 ) capacitor c=0.0119211f //x=1.115 //y=5.24
c211 ( 2 0 ) capacitor c=0.0170679f //x=1.11 //y=1.755
r212 (  99 100 ) resistor r=17.5563 //w=0.302 //l=0.11 //layer=ply \
 //thickness=0.18 //x=2.96 //y=2.085 //x2=3.07 //y2=2.085
r213 (  97 106 ) resistor r=45.1352 //w=0.168 //l=0.173853 //layer=ply \
 //thickness=0.18 //x=3.6 //y=1.255 //x2=3.56 //y2=1.41
r214 (  96 105 ) resistor r=45.1352 //w=0.168 //l=0.173853 //layer=ply \
 //thickness=0.18 //x=3.6 //y=0.91 //x2=3.56 //y2=0.755
r215 (  96 97 ) resistor r=176.904 //w=0.094 //l=0.345 //layer=ply \
 //thickness=0.18 //x=3.6 //y=0.91 //x2=3.6 //y2=1.255
r216 (  91 104 ) resistor r=10.701 //w=0.21 //l=0.115 //layer=ply \
 //thickness=0.18 //x=3.225 //y=1.41 //x2=3.11 //y2=1.41
r217 (  90 106 ) resistor r=5.52526 //w=0.168 //l=0.115 //layer=ply \
 //thickness=0.18 //x=3.445 //y=1.41 //x2=3.56 //y2=1.41
r218 (  89 103 ) resistor r=5.52526 //w=0.168 //l=0.115 //layer=ply \
 //thickness=0.18 //x=3.225 //y=0.755 //x2=3.11 //y2=0.755
r219 (  88 105 ) resistor r=5.52526 //w=0.168 //l=0.115 //layer=ply \
 //thickness=0.18 //x=3.445 //y=0.755 //x2=3.56 //y2=0.755
r220 (  88 89 ) resistor r=112.809 //w=0.094 //l=0.22 //layer=ply \
 //thickness=0.18 //x=3.445 //y=0.755 //x2=3.225 //y2=0.755
r221 (  86 93 ) resistor r=26.9307 //w=0.15 //l=0.106066 //layer=ply \
 //thickness=0.18 //x=3.48 //y=4.79 //x2=3.555 //y2=4.865
r222 (  86 87 ) resistor r=148.702 //w=0.094 //l=0.29 //layer=ply \
 //thickness=0.18 //x=3.48 //y=4.79 //x2=3.19 //y2=4.79
r223 (  83 87 ) resistor r=23.403 //w=0.284 //l=0.106066 //layer=ply \
 //thickness=0.18 //x=3.115 //y=4.865 //x2=3.19 //y2=4.79
r224 (  83 102 ) resistor r=26.3063 //w=0.284 //l=0.229783 //layer=ply \
 //thickness=0.18 //x=3.115 //y=4.865 //x2=2.96 //y2=4.7
r225 (  82 100 ) resistor r=19.1248 //w=0.302 //l=0.165 //layer=ply \
 //thickness=0.18 //x=3.07 //y=1.92 //x2=3.07 //y2=2.085
r226 (  81 104 ) resistor r=39.5823 //w=0.21 //l=0.173853 //layer=ply \
 //thickness=0.18 //x=3.07 //y=1.565 //x2=3.11 //y2=1.41
r227 (  81 82 ) resistor r=182.032 //w=0.094 //l=0.355 //layer=ply \
 //thickness=0.18 //x=3.07 //y=1.565 //x2=3.07 //y2=1.92
r228 (  80 104 ) resistor r=39.5823 //w=0.21 //l=0.173853 //layer=ply \
 //thickness=0.18 //x=3.07 //y=1.255 //x2=3.11 //y2=1.41
r229 (  79 103 ) resistor r=45.1352 //w=0.168 //l=0.173853 //layer=ply \
 //thickness=0.18 //x=3.07 //y=0.91 //x2=3.11 //y2=0.755
r230 (  79 80 ) resistor r=176.904 //w=0.094 //l=0.345 //layer=ply \
 //thickness=0.18 //x=3.07 //y=0.91 //x2=3.07 //y2=1.255
r231 (  78 93 ) resistor r=592.245 //w=0.094 //l=1.155 //layer=ply \
 //thickness=0.18 //x=3.555 //y=6.02 //x2=3.555 //y2=4.865
r232 (  77 83 ) resistor r=592.245 //w=0.094 //l=1.155 //layer=ply \
 //thickness=0.18 //x=3.115 //y=6.02 //x2=3.115 //y2=4.865
r233 (  76 90 ) resistor r=56.4043 //w=0.094 //l=0.11 //layer=ply \
 //thickness=0.18 //x=3.335 //y=1.41 //x2=3.445 //y2=1.41
r234 (  76 91 ) resistor r=56.4043 //w=0.094 //l=0.11 //layer=ply \
 //thickness=0.18 //x=3.335 //y=1.41 //x2=3.225 //y2=1.41
r235 (  72 102 ) resistor r=152 //w=0.17 //l=0.17 //layer=licon //count=1 \
 //x=2.96 //y=4.7 //x2=2.96 //y2=4.7
r236 (  63 99 ) resistor r=152 //w=0.17 //l=0.17 //layer=licon //count=1 \
 //x=2.96 //y=2.085 //x2=2.96 //y2=2.085
r237 (  51 109 ) resistor r=23.615 //w=0.187 //l=0.345 //layer=li \
 //thickness=0.1 //x=1.115 //y=5.38 //x2=1.115 //y2=5.725
r238 (  42 43 ) resistor r=0.10734 //w=0.281 //l=0.16 //layer=m2 \
 //thickness=0.36 //x=2.96 //y=2.595 //x2=2.8 //y2=2.595
r239 (  40 43 ) resistor r=1.10687 //w=0.131 //l=1.16 //layer=m2 \
 //thickness=0.36 //x=1.64 //y=2.59 //x2=2.8 //y2=2.59
r240 (  38 40 ) resistor r=0.10734 //w=0.281 //l=0.16 //layer=m2 \
 //thickness=0.36 //x=1.48 //y=2.595 //x2=1.64 //y2=2.595
r241 (  34 72 ) resistor r=9.3 //w=0.17 //l=0.17 //layer=mcon //count=1 \
 //x=2.96 //y=4.7 //x2=2.96 //y2=4.7
r242 (  31 63 ) resistor r=9.3 //w=0.17 //l=0.17 //layer=mcon //count=1 \
 //x=2.96 //y=2.085 //x2=2.96 //y2=2.085
r243 (  29 42 ) resistor r=4.5 //w=0.15 //l=0.15 //layer=via1 //count=1 \
 //x=2.96 //y=2.595 //x2=2.96 //y2=2.595
r244 (  27 29 ) resistor r=0.00166223 //w=0.376 //l=0.005 //layer=m1 \
 //thickness=0.36 //x=2.907 //y=2.59 //x2=2.907 //y2=2.595
r245 (  25 38 ) resistor r=4.5 //w=0.15 //l=0.15 //layer=via1 //count=1 \
 //x=1.48 //y=2.595 //x2=1.48 //y2=2.595
r246 (  23 25 ) resistor r=0.00166223 //w=0.376 //l=0.005 //layer=m1 \
 //thickness=0.36 //x=1.532 //y=2.59 //x2=1.532 //y2=2.595
r247 (  21 51 ) resistor r=9.3 //w=0.17 //l=0.17 //layer=mcon //count=1 \
 //x=1.115 //y=5.38 //x2=1.115 //y2=5.38
r248 (  18 107 ) resistor r=9.3 //w=0.17 //l=0.17 //layer=mcon //count=1 \
 //x=1.11 //y=1.005 //x2=1.11 //y2=1.005
r249 (  16 34 ) resistor r=0.0732479 //w=0.241 //l=0.122474 //layer=m1 \
 //thickness=0.36 //x=2.96 //y=4.58 //x2=2.965 //y2=4.7
r250 (  15 29 ) resistor r=0.0911593 //w=0.376 //l=0.184608 //layer=m1 \
 //thickness=0.36 //x=2.96 //y=2.755 //x2=2.907 //y2=2.595
r251 (  15 16 ) resistor r=1.74141 //w=0.131 //l=1.825 //layer=m1 \
 //thickness=0.36 //x=2.96 //y=2.755 //x2=2.96 //y2=4.58
r252 (  14 27 ) resistor r=0.0894971 //w=0.376 //l=0.179555 //layer=m1 \
 //thickness=0.36 //x=2.96 //y=2.435 //x2=2.907 //y2=2.59
r253 (  13 31 ) resistor r=0.116051 //w=0.211 //l=0.165 //layer=m1 \
 //thickness=0.36 //x=2.96 //y=2.25 //x2=2.96 //y2=2.085
r254 (  13 14 ) resistor r=0.176527 //w=0.131 //l=0.185 //layer=m1 \
 //thickness=0.36 //x=2.96 //y=2.25 //x2=2.96 //y2=2.435
r255 (  11 25 ) resistor r=0.0911593 //w=0.376 //l=0.184174 //layer=m1 \
 //thickness=0.36 //x=1.48 //y=2.755 //x2=1.532 //y2=2.595
r256 (  11 12 ) resistor r=2.0229 //w=0.131 //l=2.12 //layer=m1 \
 //thickness=0.36 //x=1.48 //y=2.755 //x2=1.48 //y2=4.875
r257 (  10 23 ) resistor r=0.0894971 //w=0.376 //l=0.179123 //layer=m1 \
 //thickness=0.36 //x=1.48 //y=2.435 //x2=1.532 //y2=2.59
r258 (  9 10 ) resistor r=0.486641 //w=0.131 //l=0.51 //layer=m1 \
 //thickness=0.36 //x=1.48 //y=1.925 //x2=1.48 //y2=2.435
r259 (  7 12 ) resistor r=0.0698411 //w=0.17 //l=0.120208 //layer=m1 \
 //thickness=0.36 //x=1.395 //y=4.96 //x2=1.48 //y2=4.875
r260 (  7 8 ) resistor r=0.186069 //w=0.131 //l=0.195 //layer=m1 \
 //thickness=0.36 //x=1.395 //y=4.96 //x2=1.2 //y2=4.96
r261 (  5 9 ) resistor r=0.0698411 //w=0.17 //l=0.120208 //layer=m1 \
 //thickness=0.36 //x=1.395 //y=1.84 //x2=1.48 //y2=1.925
r262 (  5 6 ) resistor r=0.19084 //w=0.131 //l=0.2 //layer=m1 //thickness=0.36 \
 //x=1.395 //y=1.84 //x2=1.195 //y2=1.84
r263 (  4 21 ) resistor r=0.086672 //w=0.218 //l=0.14 //layer=m1 \
 //thickness=0.36 //x=1.115 //y=5.24 //x2=1.115 //y2=5.38
r264 (  3 8 ) resistor r=0.0698411 //w=0.17 //l=0.120208 //layer=m1 \
 //thickness=0.36 //x=1.115 //y=5.045 //x2=1.2 //y2=4.96
r265 (  3 4 ) resistor r=0.186069 //w=0.131 //l=0.195 //layer=m1 \
 //thickness=0.36 //x=1.115 //y=5.045 //x2=1.115 //y2=5.24
r266 (  2 6 ) resistor r=0.0698411 //w=0.17 //l=0.120208 //layer=m1 \
 //thickness=0.36 //x=1.11 //y=1.755 //x2=1.195 //y2=1.84
r267 (  1 18 ) resistor r=0.105739 //w=0.201 //l=0.145 //layer=m1 \
 //thickness=0.36 //x=1.11 //y=1.15 //x2=1.11 //y2=1.005
r268 (  1 2 ) resistor r=0.57729 //w=0.131 //l=0.605 //layer=m1 \
 //thickness=0.36 //x=1.11 //y=1.15 //x2=1.11 //y2=1.755
ends PM_BUFX1\%noxref_1

subckt PM_BUFX1\%noxref_2 ( 9 21 25 47 51 62 65 76 87 88 )
c94 ( 88 0 ) capacitor c=0.0650099f //x=2.715 //y=0.37
c95 ( 87 0 ) capacitor c=0.0633642f //x=0.495 //y=0.37
c96 ( 76 0 ) capacitor c=0.101961f //x=2.22 //y=0
c97 ( 65 0 ) capacitor c=0.196221f //x=0.63 //y=0
c98 ( 62 0 ) capacitor c=0.201424f //x=4.07 //y=0
c99 ( 60 0 ) capacitor c=0.0360826f //x=3.905 //y=0
c100 ( 54 0 ) capacitor c=0.00589014f //x=3.82 //y=0.45
c101 ( 51 0 ) capacitor c=0.00625302f //x=3.735 //y=0.535
c102 ( 50 0 ) capacitor c=0.00479851f //x=3.33 //y=0.45
c103 ( 47 0 ) capacitor c=0.00633284f //x=3.245 //y=0.535
c104 ( 42 0 ) capacitor c=0.00590583f //x=2.85 //y=0.45
c105 ( 39 0 ) capacitor c=0.0189275f //x=2.765 //y=0
c106 ( 34 0 ) capacitor c=0.0360826f //x=1.685 //y=0
c107 ( 33 0 ) capacitor c=0.0184188f //x=2.05 //y=0
c108 ( 28 0 ) capacitor c=0.00589014f //x=1.6 //y=0.45
c109 ( 25 0 ) capacitor c=0.00605867f //x=1.515 //y=0.535
c110 ( 24 0 ) capacitor c=0.00479851f //x=1.11 //y=0.45
c111 ( 21 0 ) capacitor c=0.0064899f //x=1.025 //y=0.535
c112 ( 16 0 ) capacitor c=0.00590583f //x=0.63 //y=0.45
c113 ( 9 0 ) capacitor c=0.188539f //x=4.07 //y=0
r114 (  79 80 ) resistor r=17.5686 //w=0.357 //l=0.49 //layer=li \
 //thickness=0.1 //x=3.33 //y=0 //x2=3.82 //y2=0
r115 (  77 79 ) resistor r=17.2101 //w=0.357 //l=0.48 //layer=li \
 //thickness=0.1 //x=2.85 //y=0 //x2=3.33 //y2=0
r116 (  68 69 ) resistor r=17.5686 //w=0.357 //l=0.49 //layer=li \
 //thickness=0.1 //x=1.11 //y=0 //x2=1.6 //y2=0
r117 (  67 68 ) resistor r=13.2661 //w=0.357 //l=0.37 //layer=li \
 //thickness=0.1 //x=0.74 //y=0 //x2=1.11 //y2=0
r118 (  65 67 ) resistor r=3.94398 //w=0.357 //l=0.11 //layer=li \
 //thickness=0.1 //x=0.63 //y=0 //x2=0.74 //y2=0
r119 (  60 80 ) resistor r=3.04762 //w=0.357 //l=0.085 //layer=li \
 //thickness=0.1 //x=3.905 //y=0 //x2=3.82 //y2=0
r120 (  60 62 ) resistor r=5.91597 //w=0.357 //l=0.165 //layer=li \
 //thickness=0.1 //x=3.905 //y=0 //x2=4.07 //y2=0
r121 (  55 88 ) resistor r=5.4201 //w=0.17 //l=0.085 //layer=li \
 //thickness=0.1 //x=3.82 //y=0.62 //x2=3.82 //y2=0.535
r122 (  55 88 ) resistor r=41.4118 //w=0.187 //l=0.605 //layer=li \
 //thickness=0.1 //x=3.82 //y=0.62 //x2=3.82 //y2=1.225
r123 (  54 88 ) resistor r=5.4201 //w=0.17 //l=0.085 //layer=li \
 //thickness=0.1 //x=3.82 //y=0.45 //x2=3.82 //y2=0.535
r124 (  53 80 ) resistor r=5.03728 //w=0.34 //l=0.17 //layer=li \
 //thickness=0.1 //x=3.82 //y=0.17 //x2=3.82 //y2=0
r125 (  53 54 ) resistor r=19.1658 //w=0.187 //l=0.28 //layer=li \
 //thickness=0.1 //x=3.82 //y=0.17 //x2=3.82 //y2=0.45
r126 (  52 88 ) resistor r=5.4201 //w=0.17 //l=0.085 //layer=li \
 //thickness=0.1 //x=3.415 //y=0.535 //x2=3.33 //y2=0.535
r127 (  51 88 ) resistor r=1.40859 //w=0.34 //l=0.085 //layer=li \
 //thickness=0.1 //x=3.735 //y=0.535 //x2=3.82 //y2=0.535
r128 (  51 52 ) resistor r=21.9037 //w=0.187 //l=0.32 //layer=li \
 //thickness=0.1 //x=3.735 //y=0.535 //x2=3.415 //y2=0.535
r129 (  50 88 ) resistor r=1.40859 //w=0.34 //l=0.085 //layer=li \
 //thickness=0.1 //x=3.33 //y=0.45 //x2=3.33 //y2=0.535
r130 (  49 79 ) resistor r=5.03728 //w=0.34 //l=0.17 //layer=li \
 //thickness=0.1 //x=3.33 //y=0.17 //x2=3.33 //y2=0
r131 (  49 50 ) resistor r=19.1658 //w=0.187 //l=0.28 //layer=li \
 //thickness=0.1 //x=3.33 //y=0.17 //x2=3.33 //y2=0.45
r132 (  48 88 ) resistor r=1.40859 //w=0.34 //l=0.085 //layer=li \
 //thickness=0.1 //x=2.935 //y=0.535 //x2=2.85 //y2=0.535
r133 (  47 88 ) resistor r=5.4201 //w=0.17 //l=0.085 //layer=li \
 //thickness=0.1 //x=3.245 //y=0.535 //x2=3.33 //y2=0.535
r134 (  47 48 ) resistor r=21.2193 //w=0.187 //l=0.31 //layer=li \
 //thickness=0.1 //x=3.245 //y=0.535 //x2=2.935 //y2=0.535
r135 (  43 88 ) resistor r=5.4201 //w=0.17 //l=0.085 //layer=li \
 //thickness=0.1 //x=2.85 //y=0.62 //x2=2.85 //y2=0.535
r136 (  43 88 ) resistor r=41.4118 //w=0.187 //l=0.605 //layer=li \
 //thickness=0.1 //x=2.85 //y=0.62 //x2=2.85 //y2=1.225
r137 (  42 88 ) resistor r=5.4201 //w=0.17 //l=0.085 //layer=li \
 //thickness=0.1 //x=2.85 //y=0.45 //x2=2.85 //y2=0.535
r138 (  41 77 ) resistor r=5.03728 //w=0.34 //l=0.17 //layer=li \
 //thickness=0.1 //x=2.85 //y=0.17 //x2=2.85 //y2=0
r139 (  41 42 ) resistor r=19.1658 //w=0.187 //l=0.28 //layer=li \
 //thickness=0.1 //x=2.85 //y=0.17 //x2=2.85 //y2=0.45
r140 (  40 76 ) resistor r=5.4201 //w=0.34 //l=0.17 //layer=li //thickness=0.1 \
 //x=2.39 //y=0 //x2=2.22 //y2=0
r141 (  39 77 ) resistor r=3.04762 //w=0.357 //l=0.085 //layer=li \
 //thickness=0.1 //x=2.765 //y=0 //x2=2.85 //y2=0
r142 (  39 40 ) resistor r=13.4454 //w=0.357 //l=0.375 //layer=li \
 //thickness=0.1 //x=2.765 //y=0 //x2=2.39 //y2=0
r143 (  34 69 ) resistor r=3.04762 //w=0.357 //l=0.085 //layer=li \
 //thickness=0.1 //x=1.685 //y=0 //x2=1.6 //y2=0
r144 (  34 36 ) resistor r=5.91597 //w=0.357 //l=0.165 //layer=li \
 //thickness=0.1 //x=1.685 //y=0 //x2=1.85 //y2=0
r145 (  33 76 ) resistor r=5.4201 //w=0.34 //l=0.17 //layer=li //thickness=0.1 \
 //x=2.05 //y=0 //x2=2.22 //y2=0
r146 (  33 36 ) resistor r=7.17087 //w=0.357 //l=0.2 //layer=li \
 //thickness=0.1 //x=2.05 //y=0 //x2=1.85 //y2=0
r147 (  29 87 ) resistor r=5.4201 //w=0.17 //l=0.085 //layer=li \
 //thickness=0.1 //x=1.6 //y=0.62 //x2=1.6 //y2=0.535
r148 (  29 87 ) resistor r=41.4118 //w=0.187 //l=0.605 //layer=li \
 //thickness=0.1 //x=1.6 //y=0.62 //x2=1.6 //y2=1.225
r149 (  28 87 ) resistor r=5.4201 //w=0.17 //l=0.085 //layer=li \
 //thickness=0.1 //x=1.6 //y=0.45 //x2=1.6 //y2=0.535
r150 (  27 69 ) resistor r=5.03728 //w=0.34 //l=0.17 //layer=li \
 //thickness=0.1 //x=1.6 //y=0.17 //x2=1.6 //y2=0
r151 (  27 28 ) resistor r=19.1658 //w=0.187 //l=0.28 //layer=li \
 //thickness=0.1 //x=1.6 //y=0.17 //x2=1.6 //y2=0.45
r152 (  26 87 ) resistor r=5.4201 //w=0.17 //l=0.085 //layer=li \
 //thickness=0.1 //x=1.195 //y=0.535 //x2=1.11 //y2=0.535
r153 (  25 87 ) resistor r=1.40859 //w=0.34 //l=0.085 //layer=li \
 //thickness=0.1 //x=1.515 //y=0.535 //x2=1.6 //y2=0.535
r154 (  25 26 ) resistor r=21.9037 //w=0.187 //l=0.32 //layer=li \
 //thickness=0.1 //x=1.515 //y=0.535 //x2=1.195 //y2=0.535
r155 (  24 87 ) resistor r=1.40859 //w=0.34 //l=0.085 //layer=li \
 //thickness=0.1 //x=1.11 //y=0.45 //x2=1.11 //y2=0.535
r156 (  23 68 ) resistor r=5.03728 //w=0.34 //l=0.17 //layer=li \
 //thickness=0.1 //x=1.11 //y=0.17 //x2=1.11 //y2=0
r157 (  23 24 ) resistor r=19.1658 //w=0.187 //l=0.28 //layer=li \
 //thickness=0.1 //x=1.11 //y=0.17 //x2=1.11 //y2=0.45
r158 (  22 87 ) resistor r=1.40859 //w=0.34 //l=0.085 //layer=li \
 //thickness=0.1 //x=0.715 //y=0.535 //x2=0.63 //y2=0.535
r159 (  21 87 ) resistor r=5.4201 //w=0.17 //l=0.085 //layer=li \
 //thickness=0.1 //x=1.025 //y=0.535 //x2=1.11 //y2=0.535
r160 (  21 22 ) resistor r=21.2193 //w=0.187 //l=0.31 //layer=li \
 //thickness=0.1 //x=1.025 //y=0.535 //x2=0.715 //y2=0.535
r161 (  17 87 ) resistor r=5.4201 //w=0.17 //l=0.085 //layer=li \
 //thickness=0.1 //x=0.63 //y=0.62 //x2=0.63 //y2=0.535
r162 (  17 87 ) resistor r=41.4118 //w=0.187 //l=0.605 //layer=li \
 //thickness=0.1 //x=0.63 //y=0.62 //x2=0.63 //y2=1.225
r163 (  16 87 ) resistor r=5.4201 //w=0.17 //l=0.085 //layer=li \
 //thickness=0.1 //x=0.63 //y=0.45 //x2=0.63 //y2=0.535
r164 (  15 65 ) resistor r=5.03728 //w=0.34 //l=0.17 //layer=li \
 //thickness=0.1 //x=0.63 //y=0.17 //x2=0.63 //y2=0
r165 (  15 16 ) resistor r=19.1658 //w=0.187 //l=0.28 //layer=li \
 //thickness=0.1 //x=0.63 //y=0.17 //x2=0.63 //y2=0.45
r166 (  9 62 ) resistor r=9.3 //w=0.17 //l=0.17 //layer=mcon //count=1 \
 //x=4.07 //y=0 //x2=4.07 //y2=0
r167 (  7 79 ) resistor r=3.1 //w=0.17 //l=0.51 //layer=mcon //count=3 \
 //x=3.33 //y=0 //x2=3.33 //y2=0
r168 (  7 9 ) resistor r=0.307309 //w=0.301 //l=0.74 //layer=m1 \
 //thickness=0.36 //x=3.33 //y=0 //x2=4.07 //y2=0
r169 (  5 36 ) resistor r=3.1 //w=0.17 //l=0.51 //layer=mcon //count=3 \
 //x=1.85 //y=0 //x2=1.85 //y2=0
r170 (  5 7 ) resistor r=0.614618 //w=0.301 //l=1.48 //layer=m1 \
 //thickness=0.36 //x=1.85 //y=0 //x2=3.33 //y2=0
r171 (  2 67 ) resistor r=3.1 //w=0.17 //l=0.51 //layer=mcon //count=3 \
 //x=0.74 //y=0 //x2=0.74 //y2=0
r172 (  2 5 ) resistor r=0.460963 //w=0.301 //l=1.11 //layer=m1 \
 //thickness=0.36 //x=0.74 //y=0 //x2=1.85 //y2=0
ends PM_BUFX1\%noxref_2

subckt PM_BUFX1\%noxref_3 ( 9 31 57 72 76 78 81 82 83 84 )
c75 ( 84 0 ) capacitor c=0.0632165f //x=3.63 //y=5.02
c76 ( 83 0 ) capacitor c=0.053454f //x=2.76 //y=5.02
c77 ( 82 0 ) capacitor c=0.0551724f //x=1.41 //y=5.02
c78 ( 81 0 ) capacitor c=0.0616796f //x=0.54 //y=5.02
c79 ( 80 0 ) capacitor c=0.00591168f //x=3.775 //y=7.4
c80 ( 79 0 ) capacitor c=0.00591168f //x=2.895 //y=7.4
c81 ( 78 0 ) capacitor c=0.120967f //x=2.22 //y=7.4
c82 ( 77 0 ) capacitor c=0.00591168f //x=1.555 //y=7.4
c83 ( 76 0 ) capacitor c=0.238972f //x=0.74 //y=7.4
c84 ( 72 0 ) capacitor c=0.23475f //x=4.07 //y=7.4
c85 ( 57 0 ) capacitor c=0.028723f //x=3.69 //y=7.4
c86 ( 47 0 ) capacitor c=0.0216067f //x=2.81 //y=7.4
c87 ( 41 0 ) capacitor c=0.0210379f //x=2.05 //y=7.4
c88 ( 31 0 ) capacitor c=0.028723f //x=1.47 //y=7.4
c89 ( 9 0 ) capacitor c=0.192692f //x=4.07 //y=7.4
r90 (  70 80 ) resistor r=2.94794 //w=0.34 //l=0.085 //layer=li \
 //thickness=0.1 //x=3.86 //y=7.4 //x2=3.775 //y2=7.4
r91 (  70 72 ) resistor r=7.52941 //w=0.357 //l=0.21 //layer=li \
 //thickness=0.1 //x=3.86 //y=7.4 //x2=4.07 //y2=7.4
r92 (  61 80 ) resistor r=4.11603 //w=0.68 //l=0.17 //layer=li //thickness=0.1 \
 //x=3.775 //y=7.23 //x2=3.775 //y2=7.4
r93 (  61 84 ) resistor r=56.4706 //w=0.187 //l=0.825 //layer=li \
 //thickness=0.1 //x=3.775 //y=7.23 //x2=3.775 //y2=6.405
r94 (  58 79 ) resistor r=2.94794 //w=0.34 //l=0.085 //layer=li \
 //thickness=0.1 //x=2.98 //y=7.4 //x2=2.895 //y2=7.4
r95 (  58 60 ) resistor r=12.549 //w=0.357 //l=0.35 //layer=li //thickness=0.1 \
 //x=2.98 //y=7.4 //x2=3.33 //y2=7.4
r96 (  57 80 ) resistor r=2.94794 //w=0.34 //l=0.085 //layer=li \
 //thickness=0.1 //x=3.69 //y=7.4 //x2=3.775 //y2=7.4
r97 (  57 60 ) resistor r=12.9076 //w=0.357 //l=0.36 //layer=li \
 //thickness=0.1 //x=3.69 //y=7.4 //x2=3.33 //y2=7.4
r98 (  49 79 ) resistor r=4.11603 //w=0.68 //l=0.17 //layer=li //thickness=0.1 \
 //x=2.895 //y=7.23 //x2=2.895 //y2=7.4
r99 (  49 83 ) resistor r=56.4706 //w=0.187 //l=0.825 //layer=li \
 //thickness=0.1 //x=2.895 //y=7.23 //x2=2.895 //y2=6.405
r100 (  48 78 ) resistor r=5.4201 //w=0.34 //l=0.17 //layer=li //thickness=0.1 \
 //x=2.39 //y=7.4 //x2=2.22 //y2=7.4
r101 (  47 79 ) resistor r=2.94794 //w=0.34 //l=0.085 //layer=li \
 //thickness=0.1 //x=2.81 //y=7.4 //x2=2.895 //y2=7.4
r102 (  47 48 ) resistor r=15.0588 //w=0.357 //l=0.42 //layer=li \
 //thickness=0.1 //x=2.81 //y=7.4 //x2=2.39 //y2=7.4
r103 (  42 77 ) resistor r=2.94794 //w=0.34 //l=0.085 //layer=li \
 //thickness=0.1 //x=1.64 //y=7.4 //x2=1.555 //y2=7.4
r104 (  42 44 ) resistor r=7.52941 //w=0.357 //l=0.21 //layer=li \
 //thickness=0.1 //x=1.64 //y=7.4 //x2=1.85 //y2=7.4
r105 (  41 78 ) resistor r=5.4201 //w=0.34 //l=0.17 //layer=li //thickness=0.1 \
 //x=2.05 //y=7.4 //x2=2.22 //y2=7.4
r106 (  41 44 ) resistor r=7.17087 //w=0.357 //l=0.2 //layer=li \
 //thickness=0.1 //x=2.05 //y=7.4 //x2=1.85 //y2=7.4
r107 (  33 77 ) resistor r=4.11603 //w=0.68 //l=0.17 //layer=li \
 //thickness=0.1 //x=1.555 //y=7.23 //x2=1.555 //y2=7.4
r108 (  33 82 ) resistor r=56.4706 //w=0.187 //l=0.825 //layer=li \
 //thickness=0.1 //x=1.555 //y=7.23 //x2=1.555 //y2=6.405
r109 (  32 76 ) resistor r=2.94794 //w=0.34 //l=0.085 //layer=li \
 //thickness=0.1 //x=0.76 //y=7.4 //x2=0.675 //y2=7.4
r110 (  31 77 ) resistor r=2.94794 //w=0.34 //l=0.085 //layer=li \
 //thickness=0.1 //x=1.47 //y=7.4 //x2=1.555 //y2=7.4
r111 (  31 32 ) resistor r=25.4566 //w=0.357 //l=0.71 //layer=li \
 //thickness=0.1 //x=1.47 //y=7.4 //x2=0.76 //y2=7.4
r112 (  23 76 ) resistor r=4.11603 //w=0.68 //l=0.17 //layer=li \
 //thickness=0.1 //x=0.675 //y=7.23 //x2=0.675 //y2=7.4
r113 (  23 81 ) resistor r=56.4706 //w=0.187 //l=0.825 //layer=li \
 //thickness=0.1 //x=0.675 //y=7.23 //x2=0.675 //y2=6.405
r114 (  9 72 ) resistor r=9.3 //w=0.17 //l=0.17 //layer=mcon //count=1 \
 //x=4.07 //y=7.4 //x2=4.07 //y2=7.4
r115 (  7 60 ) resistor r=3.1 //w=0.17 //l=0.51 //layer=mcon //count=3 \
 //x=3.33 //y=7.4 //x2=3.33 //y2=7.4
r116 (  7 9 ) resistor r=0.307309 //w=0.301 //l=0.74 //layer=m1 \
 //thickness=0.36 //x=3.33 //y=7.4 //x2=4.07 //y2=7.4
r117 (  5 44 ) resistor r=3.1 //w=0.17 //l=0.51 //layer=mcon //count=3 \
 //x=1.85 //y=7.4 //x2=1.85 //y2=7.4
r118 (  5 7 ) resistor r=0.614618 //w=0.301 //l=1.48 //layer=m1 \
 //thickness=0.36 //x=1.85 //y=7.4 //x2=3.33 //y2=7.4
r119 (  2 76 ) resistor r=3.1 //w=0.17 //l=0.51 //layer=mcon //count=3 \
 //x=0.74 //y=7.4 //x2=0.74 //y2=7.4
r120 (  2 5 ) resistor r=0.460963 //w=0.301 //l=1.11 //layer=m1 \
 //thickness=0.36 //x=0.74 //y=7.4 //x2=1.85 //y2=7.4
ends PM_BUFX1\%noxref_3

subckt PM_BUFX1\%noxref_4 ( 2 4 9 14 18 19 20 21 22 23 24 28 29 30 32 38 39 41 )
c80 ( 41 0 ) capacitor c=0.0564228f //x=0.74 //y=2.085
c81 ( 39 0 ) capacitor c=0.0439576f //x=1.38 //y=1.255
c82 ( 38 0 ) capacitor c=0.0201087f //x=1.38 //y=0.91
c83 ( 32 0 ) capacitor c=0.0161986f //x=1.225 //y=1.41
c84 ( 30 0 ) capacitor c=0.0157807f //x=1.225 //y=0.755
c85 ( 29 0 ) capacitor c=0.0554306f //x=0.97 //y=4.79
c86 ( 28 0 ) capacitor c=0.0407054f //x=1.26 //y=4.79
c87 ( 24 0 ) capacitor c=0.0301471f //x=0.85 //y=1.92
c88 ( 23 0 ) capacitor c=0.0255349f //x=0.85 //y=1.565
c89 ( 22 0 ) capacitor c=0.0234346f //x=0.85 //y=1.255
c90 ( 21 0 ) capacitor c=0.02013f //x=0.85 //y=0.91
c91 ( 20 0 ) capacitor c=0.153944f //x=1.335 //y=6.02
c92 ( 19 0 ) capacitor c=0.154411f //x=0.895 //y=6.02
c93 ( 14 0 ) capacitor c=9.45276e-19 //x=0.74 //y=4.7
c94 ( 9 0 ) capacitor c=9.11699e-19 //x=0.74 //y=2.085
c95 ( 4 0 ) capacitor c=0.0143254f //x=0.74 //y=2.085
c96 ( 2 0 ) capacitor c=0.110899f //x=0.74 //y=4.58
r97 (  41 42 ) resistor r=17.5563 //w=0.302 //l=0.11 //layer=ply \
 //thickness=0.18 //x=0.74 //y=2.085 //x2=0.85 //y2=2.085
r98 (  39 48 ) resistor r=45.1352 //w=0.168 //l=0.173853 //layer=ply \
 //thickness=0.18 //x=1.38 //y=1.255 //x2=1.34 //y2=1.41
r99 (  38 47 ) resistor r=45.1352 //w=0.168 //l=0.173853 //layer=ply \
 //thickness=0.18 //x=1.38 //y=0.91 //x2=1.34 //y2=0.755
r100 (  38 39 ) resistor r=176.904 //w=0.094 //l=0.345 //layer=ply \
 //thickness=0.18 //x=1.38 //y=0.91 //x2=1.38 //y2=1.255
r101 (  33 46 ) resistor r=10.701 //w=0.21 //l=0.115 //layer=ply \
 //thickness=0.18 //x=1.005 //y=1.41 //x2=0.89 //y2=1.41
r102 (  32 48 ) resistor r=5.52526 //w=0.168 //l=0.115 //layer=ply \
 //thickness=0.18 //x=1.225 //y=1.41 //x2=1.34 //y2=1.41
r103 (  31 45 ) resistor r=5.52526 //w=0.168 //l=0.115 //layer=ply \
 //thickness=0.18 //x=1.005 //y=0.755 //x2=0.89 //y2=0.755
r104 (  30 47 ) resistor r=5.52526 //w=0.168 //l=0.115 //layer=ply \
 //thickness=0.18 //x=1.225 //y=0.755 //x2=1.34 //y2=0.755
r105 (  30 31 ) resistor r=112.809 //w=0.094 //l=0.22 //layer=ply \
 //thickness=0.18 //x=1.225 //y=0.755 //x2=1.005 //y2=0.755
r106 (  28 35 ) resistor r=26.9307 //w=0.15 //l=0.106066 //layer=ply \
 //thickness=0.18 //x=1.26 //y=4.79 //x2=1.335 //y2=4.865
r107 (  28 29 ) resistor r=148.702 //w=0.094 //l=0.29 //layer=ply \
 //thickness=0.18 //x=1.26 //y=4.79 //x2=0.97 //y2=4.79
r108 (  25 29 ) resistor r=23.403 //w=0.284 //l=0.106066 //layer=ply \
 //thickness=0.18 //x=0.895 //y=4.865 //x2=0.97 //y2=4.79
r109 (  25 44 ) resistor r=26.3063 //w=0.284 //l=0.229783 //layer=ply \
 //thickness=0.18 //x=0.895 //y=4.865 //x2=0.74 //y2=4.7
r110 (  24 42 ) resistor r=19.1248 //w=0.302 //l=0.165 //layer=ply \
 //thickness=0.18 //x=0.85 //y=1.92 //x2=0.85 //y2=2.085
r111 (  23 46 ) resistor r=39.5823 //w=0.21 //l=0.173853 //layer=ply \
 //thickness=0.18 //x=0.85 //y=1.565 //x2=0.89 //y2=1.41
r112 (  23 24 ) resistor r=182.032 //w=0.094 //l=0.355 //layer=ply \
 //thickness=0.18 //x=0.85 //y=1.565 //x2=0.85 //y2=1.92
r113 (  22 46 ) resistor r=39.5823 //w=0.21 //l=0.173853 //layer=ply \
 //thickness=0.18 //x=0.85 //y=1.255 //x2=0.89 //y2=1.41
r114 (  21 45 ) resistor r=45.1352 //w=0.168 //l=0.173853 //layer=ply \
 //thickness=0.18 //x=0.85 //y=0.91 //x2=0.89 //y2=0.755
r115 (  21 22 ) resistor r=176.904 //w=0.094 //l=0.345 //layer=ply \
 //thickness=0.18 //x=0.85 //y=0.91 //x2=0.85 //y2=1.255
r116 (  20 35 ) resistor r=592.245 //w=0.094 //l=1.155 //layer=ply \
 //thickness=0.18 //x=1.335 //y=6.02 //x2=1.335 //y2=4.865
r117 (  19 25 ) resistor r=592.245 //w=0.094 //l=1.155 //layer=ply \
 //thickness=0.18 //x=0.895 //y=6.02 //x2=0.895 //y2=4.865
r118 (  18 32 ) resistor r=56.4043 //w=0.094 //l=0.11 //layer=ply \
 //thickness=0.18 //x=1.115 //y=1.41 //x2=1.225 //y2=1.41
r119 (  18 33 ) resistor r=56.4043 //w=0.094 //l=0.11 //layer=ply \
 //thickness=0.18 //x=1.115 //y=1.41 //x2=1.005 //y2=1.41
r120 (  14 44 ) resistor r=152 //w=0.17 //l=0.17 //layer=licon //count=1 \
 //x=0.74 //y=4.7 //x2=0.74 //y2=4.7
r121 (  9 41 ) resistor r=152 //w=0.17 //l=0.17 //layer=licon //count=1 \
 //x=0.74 //y=2.085 //x2=0.74 //y2=2.085
r122 (  7 14 ) resistor r=9.3 //w=0.17 //l=0.17 //layer=mcon //count=1 \
 //x=0.74 //y=4.7 //x2=0.74 //y2=4.7
r123 (  4 9 ) resistor r=9.3 //w=0.17 //l=0.17 //layer=mcon //count=1 //x=0.74 \
 //y=2.085 //x2=0.74 //y2=2.085
r124 (  2 7 ) resistor r=0.0732479 //w=0.241 //l=0.122474 //layer=m1 \
 //thickness=0.36 //x=0.74 //y=4.58 //x2=0.745 //y2=4.7
r125 (  1 4 ) resistor r=0.116051 //w=0.211 //l=0.165 //layer=m1 \
 //thickness=0.36 //x=0.74 //y=2.25 //x2=0.74 //y2=2.085
r126 (  1 2 ) resistor r=2.22328 //w=0.131 //l=2.33 //layer=m1 \
 //thickness=0.36 //x=0.74 //y=2.25 //x2=0.74 //y2=4.58
ends PM_BUFX1\%noxref_4

subckt PM_BUFX1\%noxref_5 ( 2 4 5 6 7 8 10 12 22 29 31 )
c77 ( 29 0 ) capacitor c=0.00869746f //x=3.145 //y=0.91
c78 ( 22 0 ) capacitor c=0.0262984f //x=3.335 //y=5.38
c79 ( 12 0 ) capacitor c=0.0188628f //x=3.33 //y=1.005
c80 ( 10 0 ) capacitor c=0.117157f //x=3.7 //y=4.875
c81 ( 8 0 ) capacitor c=0.00557311f //x=3.42 //y=4.96
c82 ( 7 0 ) capacitor c=0.00944012f //x=3.615 //y=4.96
c83 ( 6 0 ) capacitor c=0.00724565f //x=3.415 //y=1.84
c84 ( 5 0 ) capacitor c=0.0145753f //x=3.615 //y=1.84
c85 ( 4 0 ) capacitor c=0.0119211f //x=3.335 //y=5.24
c86 ( 2 0 ) capacitor c=0.0170756f //x=3.33 //y=1.755
r87 (  22 31 ) resistor r=23.615 //w=0.187 //l=0.345 //layer=li \
 //thickness=0.1 //x=3.335 //y=5.38 //x2=3.335 //y2=5.725
r88 (  15 22 ) resistor r=9.3 //w=0.17 //l=0.17 //layer=mcon //count=1 \
 //x=3.335 //y=5.38 //x2=3.335 //y2=5.38
r89 (  12 29 ) resistor r=9.3 //w=0.17 //l=0.17 //layer=mcon //count=1 \
 //x=3.33 //y=1.005 //x2=3.33 //y2=1.005
r90 (  9 10 ) resistor r=2.81489 //w=0.131 //l=2.95 //layer=m1 \
 //thickness=0.36 //x=3.7 //y=1.925 //x2=3.7 //y2=4.875
r91 (  7 10 ) resistor r=0.0698411 //w=0.17 //l=0.120208 //layer=m1 \
 //thickness=0.36 //x=3.615 //y=4.96 //x2=3.7 //y2=4.875
r92 (  7 8 ) resistor r=0.186069 //w=0.131 //l=0.195 //layer=m1 \
 //thickness=0.36 //x=3.615 //y=4.96 //x2=3.42 //y2=4.96
r93 (  5 9 ) resistor r=0.0698411 //w=0.17 //l=0.120208 //layer=m1 \
 //thickness=0.36 //x=3.615 //y=1.84 //x2=3.7 //y2=1.925
r94 (  5 6 ) resistor r=0.19084 //w=0.131 //l=0.2 //layer=m1 //thickness=0.36 \
 //x=3.615 //y=1.84 //x2=3.415 //y2=1.84
r95 (  4 15 ) resistor r=0.086672 //w=0.218 //l=0.14 //layer=m1 \
 //thickness=0.36 //x=3.335 //y=5.24 //x2=3.335 //y2=5.38
r96 (  3 8 ) resistor r=0.0698411 //w=0.17 //l=0.120208 //layer=m1 \
 //thickness=0.36 //x=3.335 //y=5.045 //x2=3.42 //y2=4.96
r97 (  3 4 ) resistor r=0.186069 //w=0.131 //l=0.195 //layer=m1 \
 //thickness=0.36 //x=3.335 //y=5.045 //x2=3.335 //y2=5.24
r98 (  2 6 ) resistor r=0.0698411 //w=0.17 //l=0.120208 //layer=m1 \
 //thickness=0.36 //x=3.33 //y=1.755 //x2=3.415 //y2=1.84
r99 (  1 12 ) resistor r=0.105739 //w=0.201 //l=0.145 //layer=m1 \
 //thickness=0.36 //x=3.33 //y=1.15 //x2=3.33 //y2=1.005
r100 (  1 2 ) resistor r=0.57729 //w=0.131 //l=0.605 //layer=m1 \
 //thickness=0.36 //x=3.33 //y=1.15 //x2=3.33 //y2=1.755
ends PM_BUFX1\%noxref_5
