// File: BUFX1.spi.BUFX1.pxi
// Created: Sun Apr 12 08:30:38 2026
//
simulator lang=spectre
x_PM_BUFX1\%noxref_1 ( N_noxref_1_c_24_p N_noxref_1_c_54_p N_noxref_1_c_1_p \
 N_noxref_1_c_131_p N_noxref_1_c_55_p N_noxref_1_c_68_p N_noxref_1_c_25_p \
 N_noxref_1_c_2_p N_noxref_1_c_69_p N_noxref_1_c_29_p N_noxref_1_c_3_p \
 N_noxref_1_c_56_p N_noxref_1_c_4_p N_noxref_1_c_5_p N_noxref_1_c_20_p \
 N_noxref_1_c_6_p N_noxref_1_c_98_p N_noxref_1_c_140_p N_noxref_1_c_34_p \
 N_noxref_1_c_57_p N_noxref_1_c_7_p N_noxref_1_c_58_p N_noxref_1_M1_noxref_g \
 N_noxref_1_M4_noxref_g N_noxref_1_M5_noxref_g N_noxref_1_c_16_p \
 N_noxref_1_c_147_p N_noxref_1_c_48_p N_noxref_1_c_36_p N_noxref_1_c_67_p \
 N_noxref_1_c_78_p N_noxref_1_c_50_p N_noxref_1_c_150_p N_noxref_1_c_18_p \
 N_noxref_1_c_52_p N_noxref_1_c_17_p N_noxref_1_M0_noxref_d \
 N_noxref_1_M2_noxref_d )  PM_BUFX1\%noxref_1
x_PM_BUFX1\%GND ( GND N_GND_c_178_n N_GND_c_186_n N_GND_c_187_n N_GND_c_190_n \
 N_GND_c_195_n N_GND_c_196_n N_GND_c_201_n N_GND_c_204_n N_GND_M0_noxref_s \
 N_GND_M1_noxref_s )  PM_BUFX1\%GND
x_PM_BUFX1\%VDD ( VDD N_VDD_c_272_n N_VDD_c_277_n N_VDD_c_280_n N_VDD_c_283_n \
 N_VDD_c_286_n N_VDD_c_289_n N_VDD_M2_noxref_s N_VDD_M3_noxref_d \
 N_VDD_M4_noxref_s N_VDD_M5_noxref_d )  PM_BUFX1\%VDD
x_PM_BUFX1\%A ( A A A A A A A N_A_c_355_n N_A_c_356_n N_A_c_357_n N_A_c_358_n \
 N_A_M0_noxref_g N_A_M2_noxref_g N_A_M3_noxref_g N_A_c_365_n N_A_c_367_n \
 N_A_c_370_n N_A_c_371_n N_A_c_372_n N_A_c_375_n N_A_c_376_n N_A_c_378_n \
 N_A_c_382_n N_A_c_384_n N_A_c_387_n )  PM_BUFX1\%A
x_PM_BUFX1\%Y ( Y Y Y Y Y Y Y N_Y_c_443_n N_Y_c_449_n N_Y_c_452_n N_Y_c_453_n \
 N_Y_c_455_n N_Y_c_456_n N_Y_c_459_n N_Y_c_466_n N_Y_M1_noxref_d \
 N_Y_M4_noxref_d )  PM_BUFX1\%Y
cc_1 ( N_noxref_1_c_1_p N_GND_c_178_n ) capacitor c=0.00499594f //x=1.885 \
 //y=2.02 //x2=4.56 //y2=0.18
cc_2 ( N_noxref_1_c_2_p N_GND_c_178_n ) capacitor c=6.42537e-19 //x=1.97 \
 //y=2.935 //x2=4.56 //y2=0.18
cc_3 ( N_noxref_1_c_3_p N_GND_c_178_n ) capacitor c=5.91046e-19 //x=3.45 \
 //y=2.935 //x2=4.56 //y2=0.18
cc_4 ( N_noxref_1_c_4_p N_GND_c_178_n ) capacitor c=0.00998676f //x=1.6 \
 //y=1.185 //x2=4.56 //y2=0.18
cc_5 ( N_noxref_1_c_5_p N_GND_c_178_n ) capacitor c=4.46354e-19 //x=1.97 \
 //y=2.77 //x2=4.56 //y2=0.18
cc_6 ( N_noxref_1_c_6_p N_GND_c_178_n ) capacitor c=0.00249122f //x=3.45 \
 //y=2.265 //x2=4.56 //y2=0.18
cc_7 ( N_noxref_1_c_7_p N_GND_c_178_n ) capacitor c=7.5371e-19 //x=3.45 \
 //y=2.265 //x2=4.56 //y2=0.18
cc_8 ( N_noxref_1_M0_noxref_d N_GND_c_178_n ) capacitor c=0.00119455f \
 //x=1.415 //y=1.09 //x2=4.56 //y2=0.18
cc_9 ( N_noxref_1_c_4_p N_GND_c_186_n ) capacitor c=0.00124813f //x=1.6 \
 //y=1.185 //x2=1.515 //y2=0.715
cc_10 ( N_noxref_1_c_1_p N_GND_c_187_n ) capacitor c=0.0030723f //x=1.885 \
 //y=2.02 //x2=2.005 //y2=0.715
cc_11 ( N_noxref_1_c_4_p N_GND_c_187_n ) capacitor c=0.00130539f //x=1.6 \
 //y=1.185 //x2=2.005 //y2=0.715
cc_12 ( N_noxref_1_c_5_p N_GND_c_187_n ) capacitor c=4.2833e-19 //x=1.97 \
 //y=2.77 //x2=2.005 //y2=0.715
cc_13 ( N_noxref_1_c_3_p N_GND_c_190_n ) capacitor c=2.58644e-19 //x=3.45 \
 //y=2.935 //x2=3.735 //y2=0.715
cc_14 ( N_noxref_1_c_6_p N_GND_c_190_n ) capacitor c=0.00114179f //x=3.45 \
 //y=2.265 //x2=3.735 //y2=0.715
cc_15 ( N_noxref_1_c_7_p N_GND_c_190_n ) capacitor c=3.95714e-19 //x=3.45 \
 //y=2.265 //x2=3.735 //y2=0.715
cc_16 ( N_noxref_1_c_16_p N_GND_c_190_n ) capacitor c=0.0125549f //x=3.56 \
 //y=1.09 //x2=3.735 //y2=0.715
cc_17 ( N_noxref_1_c_17_p N_GND_c_190_n ) capacitor c=2.1838e-19 //x=3.45 \
 //y=2.265 //x2=3.735 //y2=0.715
cc_18 ( N_noxref_1_c_18_p N_GND_c_195_n ) capacitor c=0.0134289f //x=4.09 \
 //y=1.09 //x2=4.225 //y2=0.715
cc_19 ( N_noxref_1_c_4_p N_GND_c_196_n ) capacitor c=2.8029e-19 //x=1.6 \
 //y=1.185 //x2=4.56 //y2=0.18
cc_20 ( N_noxref_1_c_20_p N_GND_c_196_n ) capacitor c=0.00313158f //x=3.45 \
 //y=2.77 //x2=4.56 //y2=0.18
cc_21 ( N_noxref_1_c_7_p N_GND_c_196_n ) capacitor c=0.0022444f //x=3.45 \
 //y=2.265 //x2=4.56 //y2=0.18
cc_22 ( N_noxref_1_c_17_p N_GND_c_196_n ) capacitor c=2.63786e-19 //x=3.45 \
 //y=2.265 //x2=4.56 //y2=0.18
cc_23 ( N_noxref_1_M0_noxref_d N_GND_c_196_n ) capacitor c=2.70835e-19 \
 //x=1.415 //y=1.09 //x2=4.56 //y2=0.18
cc_24 ( N_noxref_1_c_24_p N_GND_c_201_n ) capacitor c=0.00520602f //x=1.6 \
 //y=1.935 //x2=1.12 //y2=0.175
cc_25 ( N_noxref_1_c_25_p N_GND_c_201_n ) capacitor c=2.14154e-19 //x=1.97 \
 //y=2.615 //x2=1.12 //y2=0.175
cc_26 ( N_noxref_1_c_5_p N_GND_c_201_n ) capacitor c=0.00313158f //x=1.97 \
 //y=2.77 //x2=1.12 //y2=0.175
cc_27 ( N_noxref_1_c_1_p N_GND_c_204_n ) capacitor c=0.0147709f //x=1.885 \
 //y=2.02 //x2=2.71 //y2=0.175
cc_28 ( N_noxref_1_c_2_p N_GND_c_204_n ) capacitor c=0.00481459f //x=1.97 \
 //y=2.935 //x2=2.71 //y2=0.175
cc_29 ( N_noxref_1_c_29_p N_GND_c_204_n ) capacitor c=0.00392666f //x=3.45 \
 //y=2.615 //x2=2.71 //y2=0.175
cc_30 ( N_noxref_1_c_3_p N_GND_c_204_n ) capacitor c=0.00481459f //x=3.45 \
 //y=2.935 //x2=2.71 //y2=0.175
cc_31 ( N_noxref_1_c_5_p N_GND_c_204_n ) capacitor c=0.010027f //x=1.97 \
 //y=2.77 //x2=2.71 //y2=0.175
cc_32 ( N_noxref_1_c_20_p N_GND_c_204_n ) capacitor c=0.010027f //x=3.45 \
 //y=2.77 //x2=2.71 //y2=0.175
cc_33 ( N_noxref_1_c_6_p N_GND_c_204_n ) capacitor c=0.00682461f //x=3.45 \
 //y=2.265 //x2=2.71 //y2=0.175
cc_34 ( N_noxref_1_c_34_p N_GND_c_204_n ) capacitor c=0.0228448f //x=3.29 \
 //y=2.775 //x2=2.71 //y2=0.175
cc_35 ( N_noxref_1_c_7_p N_GND_c_204_n ) capacitor c=0.00733227f //x=3.45 \
 //y=2.265 //x2=2.71 //y2=0.175
cc_36 ( N_noxref_1_c_36_p N_GND_c_204_n ) capacitor c=0.00344321f //x=3.56 \
 //y=2.1 //x2=2.71 //y2=0.175
cc_37 ( N_noxref_1_c_17_p N_GND_c_204_n ) capacitor c=0.00786308f //x=3.45 \
 //y=2.265 //x2=2.71 //y2=0.175
cc_38 ( N_noxref_1_c_24_p N_GND_M0_noxref_s ) capacitor c=0.0327121f //x=1.6 \
 //y=1.935 //x2=0.985 //y2=0.55
cc_39 ( N_noxref_1_c_1_p N_GND_M0_noxref_s ) capacitor c=0.00316907f //x=1.885 \
 //y=2.02 //x2=0.985 //y2=0.55
cc_40 ( N_noxref_1_c_2_p N_GND_M0_noxref_s ) capacitor c=0.00295996f //x=1.97 \
 //y=2.935 //x2=0.985 //y2=0.55
cc_41 ( N_noxref_1_c_4_p N_GND_M0_noxref_s ) capacitor c=0.0155288f //x=1.6 \
 //y=1.185 //x2=0.985 //y2=0.55
cc_42 ( N_noxref_1_c_5_p N_GND_M0_noxref_s ) capacitor c=0.00227202f //x=1.97 \
 //y=2.77 //x2=0.985 //y2=0.55
cc_43 ( N_noxref_1_M0_noxref_d N_GND_M0_noxref_s ) capacitor c=0.0377642f \
 //x=1.415 //y=1.09 //x2=0.985 //y2=0.55
cc_44 ( N_noxref_1_c_3_p N_GND_M1_noxref_s ) capacitor c=0.00168601f //x=3.45 \
 //y=2.935 //x2=3.205 //y2=0.55
cc_45 ( N_noxref_1_c_6_p N_GND_M1_noxref_s ) capacitor c=0.00297876f //x=3.45 \
 //y=2.265 //x2=3.205 //y2=0.55
cc_46 ( N_noxref_1_c_7_p N_GND_M1_noxref_s ) capacitor c=0.00651326f //x=3.45 \
 //y=2.265 //x2=3.205 //y2=0.55
cc_47 ( N_noxref_1_c_16_p N_GND_M1_noxref_s ) capacitor c=0.0299684f //x=3.56 \
 //y=1.09 //x2=3.205 //y2=0.55
cc_48 ( N_noxref_1_c_48_p N_GND_M1_noxref_s ) capacitor c=0.002132f //x=3.56 \
 //y=1.745 //x2=3.205 //y2=0.55
cc_49 ( N_noxref_1_c_36_p N_GND_M1_noxref_s ) capacitor c=0.00304786f //x=3.56 \
 //y=2.1 //x2=3.205 //y2=0.55
cc_50 ( N_noxref_1_c_50_p N_GND_M1_noxref_s ) capacitor c=0.00517463f \
 //x=3.935 //y=0.935 //x2=3.205 //y2=0.55
cc_51 ( N_noxref_1_c_18_p N_GND_M1_noxref_s ) capacitor c=0.0153553f //x=4.09 \
 //y=1.09 //x2=3.205 //y2=0.55
cc_52 ( N_noxref_1_c_52_p N_GND_M1_noxref_s ) capacitor c=0.00629878f //x=4.09 \
 //y=1.435 //x2=3.205 //y2=0.55
cc_53 ( N_noxref_1_c_17_p N_GND_M1_noxref_s ) capacitor c=0.00659836f //x=3.45 \
 //y=2.265 //x2=3.205 //y2=0.55
cc_54 ( N_noxref_1_c_54_p N_VDD_c_272_n ) capacitor c=0.00259721f //x=1.605 \
 //y=5.42 //x2=4.56 //y2=7.58
cc_55 ( N_noxref_1_c_55_p N_VDD_c_272_n ) capacitor c=0.00199795f //x=1.885 \
 //y=5.14 //x2=4.56 //y2=7.58
cc_56 ( N_noxref_1_c_56_p N_VDD_c_272_n ) capacitor c=5.73169e-19 //x=3.45 \
 //y=4.76 //x2=4.56 //y2=7.58
cc_57 ( N_noxref_1_c_57_p N_VDD_c_272_n ) capacitor c=0.00241566f //x=1.605 \
 //y=5.56 //x2=4.56 //y2=7.58
cc_58 ( N_noxref_1_c_58_p N_VDD_c_272_n ) capacitor c=3.40755e-19 //x=3.45 \
 //y=4.88 //x2=4.56 //y2=7.58
cc_59 ( N_noxref_1_c_54_p N_VDD_c_277_n ) capacitor c=0.00100699f //x=1.605 \
 //y=5.42 //x2=1.96 //y2=7.585
cc_60 ( N_noxref_1_c_55_p N_VDD_c_277_n ) capacitor c=0.00206008f //x=1.885 \
 //y=5.14 //x2=1.96 //y2=7.585
cc_61 ( N_noxref_1_c_57_p N_VDD_c_277_n ) capacitor c=0.0138017f //x=1.605 \
 //y=5.56 //x2=1.96 //y2=7.585
cc_62 ( N_noxref_1_c_56_p N_VDD_c_280_n ) capacitor c=5.48929e-19 //x=3.45 \
 //y=4.76 //x2=4.18 //y2=7.585
cc_63 ( N_noxref_1_M4_noxref_g N_VDD_c_280_n ) capacitor c=0.00753931f \
 //x=3.605 //y=6.2 //x2=4.18 //y2=7.585
cc_64 ( N_noxref_1_M5_noxref_g N_VDD_c_280_n ) capacitor c=0.00755544f \
 //x=4.045 //y=6.2 //x2=4.18 //y2=7.585
cc_65 ( N_noxref_1_c_57_p N_VDD_c_283_n ) capacitor c=0.00135089f //x=1.605 \
 //y=5.56 //x2=4.56 //y2=7.58
cc_66 ( N_noxref_1_c_58_p N_VDD_c_283_n ) capacitor c=0.00241457f //x=3.45 \
 //y=4.88 //x2=4.56 //y2=7.58
cc_67 ( N_noxref_1_c_67_p N_VDD_c_283_n ) capacitor c=0.0225829f //x=3.97 \
 //y=4.97 //x2=4.56 //y2=7.58
cc_68 ( N_noxref_1_c_68_p N_VDD_c_286_n ) capacitor c=0.00685597f //x=1.69 \
 //y=5.14 //x2=1.23 //y2=7.58
cc_69 ( N_noxref_1_c_69_p N_VDD_c_286_n ) capacitor c=2.43252e-19 //x=1.97 \
 //y=5.055 //x2=1.23 //y2=7.58
cc_70 ( N_noxref_1_c_57_p N_VDD_c_286_n ) capacitor c=0.00824382f //x=1.605 \
 //y=5.56 //x2=1.23 //y2=7.58
cc_71 ( N_noxref_1_c_54_p N_VDD_c_289_n ) capacitor c=0.00217227f //x=1.605 \
 //y=5.42 //x2=2.71 //y2=7.585
cc_72 ( N_noxref_1_c_69_p N_VDD_c_289_n ) capacitor c=0.0205058f //x=1.97 \
 //y=5.055 //x2=2.71 //y2=7.585
cc_73 ( N_noxref_1_c_56_p N_VDD_c_289_n ) capacitor c=0.0155837f //x=3.45 \
 //y=4.76 //x2=2.71 //y2=7.585
cc_74 ( N_noxref_1_c_34_p N_VDD_c_289_n ) capacitor c=0.00259242f //x=3.29 \
 //y=2.775 //x2=2.71 //y2=7.585
cc_75 ( N_noxref_1_c_57_p N_VDD_c_289_n ) capacitor c=0.00827037f //x=1.605 \
 //y=5.56 //x2=2.71 //y2=7.585
cc_76 ( N_noxref_1_c_58_p N_VDD_c_289_n ) capacitor c=0.00795272f //x=3.45 \
 //y=4.88 //x2=2.71 //y2=7.585
cc_77 ( N_noxref_1_M4_noxref_g N_VDD_c_289_n ) capacitor c=0.00635171f \
 //x=3.605 //y=6.2 //x2=2.71 //y2=7.585
cc_78 ( N_noxref_1_c_78_p N_VDD_c_289_n ) capacitor c=0.00799922f //x=3.68 \
 //y=4.97 //x2=2.71 //y2=7.585
cc_79 ( N_noxref_1_c_54_p N_VDD_M2_noxref_s ) capacitor c=0.0480012f //x=1.605 \
 //y=5.42 //x2=1.03 //y2=5.2
cc_80 ( N_noxref_1_c_57_p N_VDD_M2_noxref_s ) capacitor c=0.092379f //x=1.605 \
 //y=5.56 //x2=1.03 //y2=5.2
cc_81 ( N_noxref_1_c_54_p N_VDD_M3_noxref_d ) capacitor c=0.0474638f //x=1.605 \
 //y=5.42 //x2=1.9 //y2=5.2
cc_82 ( N_noxref_1_c_55_p N_VDD_M3_noxref_d ) capacitor c=0.0214667f //x=1.885 \
 //y=5.14 //x2=1.9 //y2=5.2
cc_83 ( N_noxref_1_c_2_p N_VDD_M3_noxref_d ) capacitor c=0.00160673f //x=1.97 \
 //y=2.935 //x2=1.9 //y2=5.2
cc_84 ( N_noxref_1_c_57_p N_VDD_M3_noxref_d ) capacitor c=0.0913728f //x=1.605 \
 //y=5.56 //x2=1.9 //y2=5.2
cc_85 ( N_noxref_1_c_54_p N_VDD_M4_noxref_s ) capacitor c=8.11512e-19 \
 //x=1.605 //y=5.42 //x2=3.25 //y2=5.2
cc_86 ( N_noxref_1_c_3_p N_VDD_M4_noxref_s ) capacitor c=8.64011e-19 //x=3.45 \
 //y=2.935 //x2=3.25 //y2=5.2
cc_87 ( N_noxref_1_c_56_p N_VDD_M4_noxref_s ) capacitor c=0.0211971f //x=3.45 \
 //y=4.76 //x2=3.25 //y2=5.2
cc_88 ( N_noxref_1_c_58_p N_VDD_M4_noxref_s ) capacitor c=0.00914073f //x=3.45 \
 //y=4.88 //x2=3.25 //y2=5.2
cc_89 ( N_noxref_1_M4_noxref_g N_VDD_M4_noxref_s ) capacitor c=0.0573441f \
 //x=3.605 //y=6.2 //x2=3.25 //y2=5.2
cc_90 ( N_noxref_1_c_78_p N_VDD_M4_noxref_s ) capacitor c=0.00527332f //x=3.68 \
 //y=4.97 //x2=3.25 //y2=5.2
cc_91 ( N_noxref_1_M5_noxref_g N_VDD_M5_noxref_d ) capacitor c=0.0572684f \
 //x=4.045 //y=6.2 //x2=4.12 //y2=5.2
cc_92 ( N_noxref_1_c_25_p A ) capacitor c=0.008006f //x=1.97 //y=2.615 \
 //x2=1.23 //y2=2.77
cc_93 ( N_noxref_1_c_2_p A ) capacitor c=0.0149195f //x=1.97 //y=2.935 \
 //x2=1.23 //y2=2.77
cc_94 ( N_noxref_1_c_69_p A ) capacitor c=0.0861997f //x=1.97 //y=5.055 \
 //x2=1.23 //y2=2.77
cc_95 ( N_noxref_1_c_29_p A ) capacitor c=6.61219e-19 //x=3.45 //y=2.615 \
 //x2=1.23 //y2=2.77
cc_96 ( N_noxref_1_c_56_p A ) capacitor c=0.00306936f //x=3.45 //y=4.76 \
 //x2=1.23 //y2=2.77
cc_97 ( N_noxref_1_c_5_p A ) capacitor c=0.00348308f //x=1.97 //y=2.77 \
 //x2=1.23 //y2=2.77
cc_98 ( N_noxref_1_c_98_p A ) capacitor c=0.00687738f //x=2.13 //y=2.775 \
 //x2=1.23 //y2=2.77
cc_99 ( N_noxref_1_c_69_p N_A_c_355_n ) capacitor c=0.0169388f //x=1.97 \
 //y=5.055 //x2=1.23 //y2=4.76
cc_100 ( N_noxref_1_c_25_p N_A_c_356_n ) capacitor c=0.0181783f //x=1.97 \
 //y=2.615 //x2=1.23 //y2=2.265
cc_101 ( N_noxref_1_c_25_p N_A_c_357_n ) capacitor c=4.71798e-19 //x=1.97 \
 //y=2.615 //x2=1.23 //y2=2.265
cc_102 ( N_noxref_1_c_69_p N_A_c_358_n ) capacitor c=0.00160039f //x=1.97 \
 //y=5.055 //x2=1.23 //y2=4.88
cc_103 ( N_noxref_1_c_54_p N_A_M2_noxref_g ) capacitor c=0.00141266f //x=1.605 \
 //y=5.42 //x2=1.385 //y2=6.2
cc_104 ( N_noxref_1_c_68_p N_A_M2_noxref_g ) capacitor c=0.00534267f //x=1.69 \
 //y=5.14 //x2=1.385 //y2=6.2
cc_105 ( N_noxref_1_c_57_p N_A_M2_noxref_g ) capacitor c=0.0162066f //x=1.605 \
 //y=5.56 //x2=1.385 //y2=6.2
cc_106 ( N_noxref_1_c_54_p N_A_M3_noxref_g ) capacitor c=0.00344289f //x=1.605 \
 //y=5.42 //x2=1.825 //y2=6.2
cc_107 ( N_noxref_1_c_55_p N_A_M3_noxref_g ) capacitor c=0.00958393f //x=1.885 \
 //y=5.14 //x2=1.825 //y2=6.2
cc_108 ( N_noxref_1_c_57_p N_A_M3_noxref_g ) capacitor c=0.0162066f //x=1.605 \
 //y=5.56 //x2=1.825 //y2=6.2
cc_109 ( N_noxref_1_c_4_p N_A_c_365_n ) capacitor c=0.00187726f //x=1.6 \
 //y=1.185 //x2=1.34 //y2=1.09
cc_110 ( N_noxref_1_M0_noxref_d N_A_c_365_n ) capacitor c=0.00137914f \
 //x=1.415 //y=1.09 //x2=1.34 //y2=1.09
cc_111 ( N_noxref_1_c_24_p N_A_c_367_n ) capacitor c=0.0012792f //x=1.6 \
 //y=1.935 //x2=1.34 //y2=1.435
cc_112 ( N_noxref_1_c_4_p N_A_c_367_n ) capacitor c=0.00414335f //x=1.6 \
 //y=1.185 //x2=1.34 //y2=1.435
cc_113 ( N_noxref_1_M0_noxref_d N_A_c_367_n ) capacitor c=0.0023891f //x=1.415 \
 //y=1.09 //x2=1.34 //y2=1.435
cc_114 ( N_noxref_1_c_24_p N_A_c_370_n ) capacitor c=0.00561986f //x=1.6 \
 //y=1.935 //x2=1.34 //y2=1.745
cc_115 ( N_noxref_1_c_24_p N_A_c_371_n ) capacitor c=0.00440271f //x=1.6 \
 //y=1.935 //x2=1.34 //y2=2.1
cc_116 ( N_noxref_1_c_68_p N_A_c_372_n ) capacitor c=0.00262283f //x=1.69 \
 //y=5.14 //x2=1.75 //y2=4.97
cc_117 ( N_noxref_1_c_69_p N_A_c_372_n ) capacitor c=0.00208891f //x=1.97 \
 //y=5.055 //x2=1.75 //y2=4.97
cc_118 ( N_noxref_1_c_57_p N_A_c_372_n ) capacitor c=0.00290963f //x=1.605 \
 //y=5.56 //x2=1.75 //y2=4.97
cc_119 ( N_noxref_1_c_69_p N_A_c_375_n ) capacitor c=0.00140024f //x=1.97 \
 //y=5.055 //x2=1.46 //y2=4.97
cc_120 ( N_noxref_1_c_4_p N_A_c_376_n ) capacitor c=5.57924e-19 //x=1.6 \
 //y=1.185 //x2=1.715 //y2=0.935
cc_121 ( N_noxref_1_M0_noxref_d N_A_c_376_n ) capacitor c=0.0020782f //x=1.415 \
 //y=1.09 //x2=1.715 //y2=0.935
cc_122 ( N_noxref_1_c_24_p N_A_c_378_n ) capacitor c=0.00933629f //x=1.6 \
 //y=1.935 //x2=1.715 //y2=1.59
cc_123 ( N_noxref_1_c_1_p N_A_c_378_n ) capacitor c=0.00180253f //x=1.885 \
 //y=2.02 //x2=1.715 //y2=1.59
cc_124 ( N_noxref_1_c_4_p N_A_c_378_n ) capacitor c=5.75878e-19 //x=1.6 \
 //y=1.185 //x2=1.715 //y2=1.59
cc_125 ( N_noxref_1_M0_noxref_d N_A_c_378_n ) capacitor c=0.00356097f \
 //x=1.415 //y=1.09 //x2=1.715 //y2=1.59
cc_126 ( N_noxref_1_c_4_p N_A_c_382_n ) capacitor c=0.0014754f //x=1.6 \
 //y=1.185 //x2=1.87 //y2=1.09
cc_127 ( N_noxref_1_M0_noxref_d N_A_c_382_n ) capacitor c=0.00138452f \
 //x=1.415 //y=1.09 //x2=1.87 //y2=1.09
cc_128 ( N_noxref_1_c_24_p N_A_c_384_n ) capacitor c=0.00321841f //x=1.6 \
 //y=1.935 //x2=1.87 //y2=1.435
cc_129 ( N_noxref_1_c_4_p N_A_c_384_n ) capacitor c=0.0034642f //x=1.6 \
 //y=1.185 //x2=1.87 //y2=1.435
cc_130 ( N_noxref_1_M0_noxref_d N_A_c_384_n ) capacitor c=0.00235934f \
 //x=1.415 //y=1.09 //x2=1.87 //y2=1.435
cc_131 ( N_noxref_1_c_131_p N_A_c_387_n ) capacitor c=0.00440271f //x=1.685 \
 //y=2.02 //x2=1.23 //y2=2.265
cc_132 ( N_noxref_1_c_25_p N_A_c_387_n ) capacitor c=0.00275704f //x=1.97 \
 //y=2.615 //x2=1.23 //y2=2.265
cc_133 ( N_noxref_1_c_25_p Y ) capacitor c=0.00112843f //x=1.97 //y=2.615 \
 //x2=4.19 //y2=2.4
cc_134 ( N_noxref_1_c_69_p Y ) capacitor c=0.00356495f //x=1.97 //y=5.055 \
 //x2=4.19 //y2=2.4
cc_135 ( N_noxref_1_c_29_p Y ) capacitor c=0.0080037f //x=3.45 //y=2.615 \
 //x2=4.19 //y2=2.4
cc_136 ( N_noxref_1_c_3_p Y ) capacitor c=0.0149195f //x=3.45 //y=2.935 \
 //x2=4.19 //y2=2.4
cc_137 ( N_noxref_1_c_56_p Y ) capacitor c=0.093005f //x=3.45 //y=4.76 \
 //x2=4.19 //y2=2.4
cc_138 ( N_noxref_1_c_20_p Y ) capacitor c=0.00348308f //x=3.45 //y=2.77 \
 //x2=4.19 //y2=2.4
cc_139 ( N_noxref_1_c_6_p Y ) capacitor c=0.00825076f //x=3.45 //y=2.265 \
 //x2=4.19 //y2=2.4
cc_140 ( N_noxref_1_c_140_p Y ) capacitor c=0.00687738f //x=3.45 //y=2.775 \
 //x2=4.19 //y2=2.4
cc_141 ( N_noxref_1_c_7_p Y ) capacitor c=0.0023016f //x=3.45 //y=2.265 \
 //x2=4.19 //y2=2.4
cc_142 ( N_noxref_1_c_58_p Y ) capacitor c=0.00250262f //x=3.45 //y=4.88 \
 //x2=4.19 //y2=2.4
cc_143 ( N_noxref_1_c_67_p Y ) capacitor c=4.08297e-19 //x=3.97 //y=4.97 \
 //x2=4.19 //y2=2.4
cc_144 ( N_noxref_1_c_78_p Y ) capacitor c=0.00124564f //x=3.68 //y=4.97 \
 //x2=4.19 //y2=2.4
cc_145 ( N_noxref_1_c_17_p Y ) capacitor c=0.00112403f //x=3.45 //y=2.265 \
 //x2=4.19 //y2=2.4
cc_146 ( N_noxref_1_c_24_p N_Y_c_443_n ) capacitor c=0.00735936f //x=1.6 \
 //y=1.935 //x2=3.82 //y2=1.935
cc_147 ( N_noxref_1_c_147_p N_Y_c_443_n ) capacitor c=0.00107851f //x=3.56 \
 //y=1.435 //x2=3.82 //y2=1.935
cc_148 ( N_noxref_1_c_48_p N_Y_c_443_n ) capacitor c=0.00522452f //x=3.56 \
 //y=1.745 //x2=3.82 //y2=1.935
cc_149 ( N_noxref_1_c_36_p N_Y_c_443_n ) capacitor c=0.00384134f //x=3.56 \
 //y=2.1 //x2=3.82 //y2=1.935
cc_150 ( N_noxref_1_c_150_p N_Y_c_443_n ) capacitor c=0.00932142f //x=3.935 \
 //y=1.59 //x2=3.82 //y2=1.935
cc_151 ( N_noxref_1_c_52_p N_Y_c_443_n ) capacitor c=0.00362207f //x=4.09 \
 //y=1.435 //x2=3.82 //y2=1.935
cc_152 ( N_noxref_1_c_54_p N_Y_c_449_n ) capacitor c=0.00212662f //x=1.605 \
 //y=5.42 //x2=3.825 //y2=5.42
cc_153 ( N_noxref_1_M4_noxref_g N_Y_c_449_n ) capacitor c=0.00141266f \
 //x=3.605 //y=6.2 //x2=3.825 //y2=5.42
cc_154 ( N_noxref_1_M5_noxref_g N_Y_c_449_n ) capacitor c=0.00377331f \
 //x=4.045 //y=6.2 //x2=3.825 //y2=5.42
cc_155 ( N_noxref_1_c_150_p N_Y_c_452_n ) capacitor c=0.00180253f //x=3.935 \
 //y=1.59 //x2=4.105 //y2=2.02
cc_156 ( N_noxref_1_c_1_p N_Y_c_453_n ) capacitor c=0.00350547f //x=1.885 \
 //y=2.02 //x2=3.905 //y2=2.02
cc_157 ( N_noxref_1_c_17_p N_Y_c_453_n ) capacitor c=0.00384134f //x=3.45 \
 //y=2.265 //x2=3.905 //y2=2.02
cc_158 ( N_noxref_1_M5_noxref_g N_Y_c_455_n ) capacitor c=0.00966342f \
 //x=4.045 //y=6.2 //x2=4.105 //y2=5.14
cc_159 ( N_noxref_1_c_55_p N_Y_c_456_n ) capacitor c=0.00349209f //x=1.885 \
 //y=5.14 //x2=3.91 //y2=5.14
cc_160 ( N_noxref_1_M4_noxref_g N_Y_c_456_n ) capacitor c=0.00439203f \
 //x=3.605 //y=6.2 //x2=3.91 //y2=5.14
cc_161 ( N_noxref_1_c_67_p N_Y_c_456_n ) capacitor c=0.00262283f //x=3.97 \
 //y=4.97 //x2=3.91 //y2=5.14
cc_162 ( N_noxref_1_c_4_p N_Y_c_459_n ) capacitor c=0.00708676f //x=1.6 \
 //y=1.185 //x2=3.82 //y2=1.185
cc_163 ( N_noxref_1_c_16_p N_Y_c_459_n ) capacitor c=0.00174488f //x=3.56 \
 //y=1.09 //x2=3.82 //y2=1.185
cc_164 ( N_noxref_1_c_147_p N_Y_c_459_n ) capacitor c=0.00350474f //x=3.56 \
 //y=1.435 //x2=3.82 //y2=1.185
cc_165 ( N_noxref_1_c_50_p N_Y_c_459_n ) capacitor c=5.57924e-19 //x=3.935 \
 //y=0.935 //x2=3.82 //y2=1.185
cc_166 ( N_noxref_1_c_150_p N_Y_c_459_n ) capacitor c=5.75878e-19 //x=3.935 \
 //y=1.59 //x2=3.82 //y2=1.185
cc_167 ( N_noxref_1_c_18_p N_Y_c_459_n ) capacitor c=0.00160969f //x=4.09 \
 //y=1.09 //x2=3.82 //y2=1.185
cc_168 ( N_noxref_1_c_52_p N_Y_c_459_n ) capacitor c=0.00411132f //x=4.09 \
 //y=1.435 //x2=3.82 //y2=1.185
cc_169 ( N_noxref_1_M4_noxref_g N_Y_c_466_n ) capacitor c=0.0162066f //x=3.605 \
 //y=6.2 //x2=3.825 //y2=5.56
cc_170 ( N_noxref_1_M5_noxref_g N_Y_c_466_n ) capacitor c=0.0162066f //x=4.045 \
 //y=6.2 //x2=3.825 //y2=5.56
cc_171 ( N_noxref_1_c_67_p N_Y_c_466_n ) capacitor c=0.00290963f //x=3.97 \
 //y=4.97 //x2=3.825 //y2=5.56
cc_172 ( N_noxref_1_c_16_p N_Y_M1_noxref_d ) capacitor c=0.00137914f //x=3.56 \
 //y=1.09 //x2=3.635 //y2=1.09
cc_173 ( N_noxref_1_c_147_p N_Y_M1_noxref_d ) capacitor c=0.0023891f //x=3.56 \
 //y=1.435 //x2=3.635 //y2=1.09
cc_174 ( N_noxref_1_c_50_p N_Y_M1_noxref_d ) capacitor c=0.0020782f //x=3.935 \
 //y=0.935 //x2=3.635 //y2=1.09
cc_175 ( N_noxref_1_c_150_p N_Y_M1_noxref_d ) capacitor c=0.00356097f \
 //x=3.935 //y=1.59 //x2=3.635 //y2=1.09
cc_176 ( N_noxref_1_c_18_p N_Y_M1_noxref_d ) capacitor c=0.00138452f //x=4.09 \
 //y=1.09 //x2=3.635 //y2=1.09
cc_177 ( N_noxref_1_c_52_p N_Y_M1_noxref_d ) capacitor c=0.00235934f //x=4.09 \
 //y=1.435 //x2=3.635 //y2=1.09
cc_178 ( N_GND_c_196_n N_VDD_c_283_n ) capacitor c=0.00989514f //x=4.56 \
 //y=0.18 //x2=4.56 //y2=7.58
cc_179 ( N_GND_c_201_n N_VDD_c_286_n ) capacitor c=0.00989514f //x=1.12 \
 //y=0.175 //x2=1.23 //y2=7.58
cc_180 ( N_GND_c_204_n N_VDD_c_289_n ) capacitor c=0.00970423f //x=2.71 \
 //y=0.175 //x2=2.71 //y2=7.585
cc_181 ( N_GND_c_201_n A ) capacitor c=0.0137596f //x=1.12 //y=0.175 //x2=1.23 \
 //y2=2.77
cc_182 ( N_GND_c_178_n N_A_c_356_n ) capacitor c=0.00249124f //x=4.56 //y=0.18 \
 //x2=1.23 //y2=2.265
cc_183 ( N_GND_c_186_n N_A_c_356_n ) capacitor c=0.00108343f //x=1.515 \
 //y=0.715 //x2=1.23 //y2=2.265
cc_184 ( N_GND_c_201_n N_A_c_356_n ) capacitor c=0.0100674f //x=1.12 //y=0.175 \
 //x2=1.23 //y2=2.265
cc_185 ( N_GND_M0_noxref_s N_A_c_356_n ) capacitor c=0.00297929f //x=0.985 \
 //y=0.55 //x2=1.23 //y2=2.265
cc_186 ( N_GND_c_178_n N_A_c_357_n ) capacitor c=0.00118266f //x=4.56 //y=0.18 \
 //x2=1.23 //y2=2.265
cc_187 ( N_GND_c_186_n N_A_c_357_n ) capacitor c=3.95714e-19 //x=1.515 \
 //y=0.715 //x2=1.23 //y2=2.265
cc_188 ( N_GND_c_201_n N_A_c_357_n ) capacitor c=0.00733542f //x=1.12 \
 //y=0.175 //x2=1.23 //y2=2.265
cc_189 ( N_GND_c_204_n N_A_c_357_n ) capacitor c=0.0022444f //x=2.71 //y=0.175 \
 //x2=1.23 //y2=2.265
cc_190 ( N_GND_M0_noxref_s N_A_c_357_n ) capacitor c=0.00476545f //x=0.985 \
 //y=0.55 //x2=1.23 //y2=2.265
cc_191 ( N_GND_c_186_n N_A_c_365_n ) capacitor c=0.0124814f //x=1.515 \
 //y=0.715 //x2=1.34 //y2=1.09
cc_192 ( N_GND_M0_noxref_s N_A_c_365_n ) capacitor c=0.0299684f //x=0.985 \
 //y=0.55 //x2=1.34 //y2=1.09
cc_193 ( N_GND_M0_noxref_s N_A_c_370_n ) capacitor c=0.002132f //x=0.985 \
 //y=0.55 //x2=1.34 //y2=1.745
cc_194 ( N_GND_c_201_n N_A_c_371_n ) capacitor c=0.00574171f //x=1.12 \
 //y=0.175 //x2=1.34 //y2=2.1
cc_195 ( N_GND_M0_noxref_s N_A_c_371_n ) capacitor c=0.00304786f //x=0.985 \
 //y=0.55 //x2=1.34 //y2=2.1
cc_196 ( N_GND_M0_noxref_s N_A_c_376_n ) capacitor c=0.00517463f //x=0.985 \
 //y=0.55 //x2=1.715 //y2=0.935
cc_197 ( N_GND_c_187_n N_A_c_382_n ) capacitor c=0.0130753f //x=2.005 \
 //y=0.715 //x2=1.87 //y2=1.09
cc_198 ( N_GND_M0_noxref_s N_A_c_382_n ) capacitor c=0.0153553f //x=0.985 \
 //y=0.55 //x2=1.87 //y2=1.09
cc_199 ( N_GND_M0_noxref_s N_A_c_384_n ) capacitor c=0.00629878f //x=0.985 \
 //y=0.55 //x2=1.87 //y2=1.435
cc_200 ( N_GND_c_186_n N_A_c_387_n ) capacitor c=2.1838e-19 //x=1.515 \
 //y=0.715 //x2=1.23 //y2=2.265
cc_201 ( N_GND_c_201_n N_A_c_387_n ) capacitor c=0.00785621f //x=1.12 \
 //y=0.175 //x2=1.23 //y2=2.265
cc_202 ( N_GND_c_204_n N_A_c_387_n ) capacitor c=2.63786e-19 //x=2.71 \
 //y=0.175 //x2=1.23 //y2=2.265
cc_203 ( N_GND_M0_noxref_s N_A_c_387_n ) capacitor c=0.00659456f //x=0.985 \
 //y=0.55 //x2=1.23 //y2=2.265
cc_204 ( N_GND_c_196_n N_Y_c_443_n ) capacitor c=0.00122336f //x=4.56 //y=0.18 \
 //x2=3.82 //y2=1.935
cc_205 ( N_GND_c_204_n N_Y_c_443_n ) capacitor c=0.00291377f //x=2.71 \
 //y=0.175 //x2=3.82 //y2=1.935
cc_206 ( N_GND_M1_noxref_s N_Y_c_443_n ) capacitor c=0.0327346f //x=3.205 \
 //y=0.55 //x2=3.82 //y2=1.935
cc_207 ( N_GND_c_178_n N_Y_c_452_n ) capacitor c=0.00497604f //x=4.56 //y=0.18 \
 //x2=4.105 //y2=2.02
cc_208 ( N_GND_c_195_n N_Y_c_452_n ) capacitor c=0.00321695f //x=4.225 \
 //y=0.715 //x2=4.105 //y2=2.02
cc_209 ( N_GND_c_196_n N_Y_c_452_n ) capacitor c=0.0298233f //x=4.56 //y=0.18 \
 //x2=4.105 //y2=2.02
cc_210 ( N_GND_M1_noxref_s N_Y_c_452_n ) capacitor c=0.00565821f //x=3.205 \
 //y=0.55 //x2=4.105 //y2=2.02
cc_211 ( N_GND_c_178_n N_Y_c_459_n ) capacitor c=0.00998676f //x=4.56 //y=0.18 \
 //x2=3.82 //y2=1.185
cc_212 ( N_GND_c_190_n N_Y_c_459_n ) capacitor c=0.00124813f //x=3.735 \
 //y=0.715 //x2=3.82 //y2=1.185
cc_213 ( N_GND_c_195_n N_Y_c_459_n ) capacitor c=0.00130539f //x=4.225 \
 //y=0.715 //x2=3.82 //y2=1.185
cc_214 ( N_GND_c_196_n N_Y_c_459_n ) capacitor c=2.8029e-19 //x=4.56 //y=0.18 \
 //x2=3.82 //y2=1.185
cc_215 ( N_GND_M1_noxref_s N_Y_c_459_n ) capacitor c=0.0155332f //x=3.205 \
 //y=0.55 //x2=3.82 //y2=1.185
cc_216 ( N_GND_c_178_n N_Y_M1_noxref_d ) capacitor c=0.00119455f //x=4.56 \
 //y=0.18 //x2=3.635 //y2=1.09
cc_217 ( N_GND_c_196_n N_Y_M1_noxref_d ) capacitor c=2.70835e-19 //x=4.56 \
 //y=0.18 //x2=3.635 //y2=1.09
cc_218 ( N_GND_M1_noxref_s N_Y_M1_noxref_d ) capacitor c=0.0377642f //x=3.205 \
 //y=0.55 //x2=3.635 //y2=1.09
cc_219 ( N_VDD_c_286_n A ) capacitor c=0.0140262f //x=1.23 //y=7.58 //x2=1.23 \
 //y2=2.77
cc_220 ( N_VDD_c_272_n N_A_c_355_n ) capacitor c=5.73169e-19 //x=4.56 //y=7.58 \
 //x2=1.23 //y2=4.76
cc_221 ( N_VDD_c_277_n N_A_c_355_n ) capacitor c=5.48929e-19 //x=1.96 \
 //y=7.585 //x2=1.23 //y2=4.76
cc_222 ( N_VDD_c_286_n N_A_c_355_n ) capacitor c=0.00869686f //x=1.23 //y=7.58 \
 //x2=1.23 //y2=4.76
cc_223 ( N_VDD_M2_noxref_s N_A_c_355_n ) capacitor c=0.0218259f //x=1.03 \
 //y=5.2 //x2=1.23 //y2=4.76
cc_224 ( N_VDD_c_272_n N_A_c_358_n ) capacitor c=3.40755e-19 //x=4.56 //y=7.58 \
 //x2=1.23 //y2=4.88
cc_225 ( N_VDD_c_286_n N_A_c_358_n ) capacitor c=0.00795821f //x=1.23 //y=7.58 \
 //x2=1.23 //y2=4.88
cc_226 ( N_VDD_c_289_n N_A_c_358_n ) capacitor c=0.00235165f //x=2.71 \
 //y=7.585 //x2=1.23 //y2=4.88
cc_227 ( N_VDD_M2_noxref_s N_A_c_358_n ) capacitor c=0.00986169f //x=1.03 \
 //y=5.2 //x2=1.23 //y2=4.88
cc_228 ( N_VDD_c_277_n N_A_M2_noxref_g ) capacitor c=0.00753931f //x=1.96 \
 //y=7.585 //x2=1.385 //y2=6.2
cc_229 ( N_VDD_c_286_n N_A_M2_noxref_g ) capacitor c=0.0210133f //x=1.23 \
 //y=7.58 //x2=1.385 //y2=6.2
cc_230 ( N_VDD_M2_noxref_s N_A_M2_noxref_g ) capacitor c=0.0573441f //x=1.03 \
 //y=5.2 //x2=1.385 //y2=6.2
cc_231 ( N_VDD_c_277_n N_A_M3_noxref_g ) capacitor c=0.00755544f //x=1.96 \
 //y=7.585 //x2=1.825 //y2=6.2
cc_232 ( N_VDD_M3_noxref_d N_A_M3_noxref_g ) capacitor c=0.0572684f //x=1.9 \
 //y=5.2 //x2=1.825 //y2=6.2
cc_233 ( N_VDD_c_289_n N_A_c_372_n ) capacitor c=0.00780996f //x=2.71 \
 //y=7.585 //x2=1.75 //y2=4.97
cc_234 ( N_VDD_c_286_n N_A_c_375_n ) capacitor c=0.00799922f //x=1.23 //y=7.58 \
 //x2=1.46 //y2=4.97
cc_235 ( N_VDD_c_289_n N_A_c_375_n ) capacitor c=2.63786e-19 //x=2.71 \
 //y=7.585 //x2=1.46 //y2=4.97
cc_236 ( N_VDD_M2_noxref_s N_A_c_375_n ) capacitor c=0.00524271f //x=1.03 \
 //y=5.2 //x2=1.46 //y2=4.97
cc_237 ( N_VDD_c_283_n Y ) capacitor c=0.0297606f //x=4.56 //y=7.58 //x2=4.19 \
 //y2=2.4
cc_238 ( N_VDD_c_272_n N_Y_c_449_n ) capacitor c=0.00259721f //x=4.56 //y=7.58 \
 //x2=3.825 //y2=5.42
cc_239 ( N_VDD_c_280_n N_Y_c_449_n ) capacitor c=0.00100699f //x=4.18 \
 //y=7.585 //x2=3.825 //y2=5.42
cc_240 ( N_VDD_c_283_n N_Y_c_449_n ) capacitor c=0.00295945f //x=4.56 //y=7.58 \
 //x2=3.825 //y2=5.42
cc_241 ( N_VDD_M3_noxref_d N_Y_c_449_n ) capacitor c=9.53785e-19 //x=1.9 \
 //y=5.2 //x2=3.825 //y2=5.42
cc_242 ( N_VDD_M4_noxref_s N_Y_c_449_n ) capacitor c=0.0465566f //x=3.25 \
 //y=5.2 //x2=3.825 //y2=5.42
cc_243 ( N_VDD_M5_noxref_d N_Y_c_449_n ) capacitor c=0.0486749f //x=4.12 \
 //y=5.2 //x2=3.825 //y2=5.42
cc_244 ( N_VDD_c_272_n N_Y_c_455_n ) capacitor c=0.00199795f //x=4.56 //y=7.58 \
 //x2=4.105 //y2=5.14
cc_245 ( N_VDD_c_280_n N_Y_c_455_n ) capacitor c=0.00207379f //x=4.18 \
 //y=7.585 //x2=4.105 //y2=5.14
cc_246 ( N_VDD_M5_noxref_d N_Y_c_455_n ) capacitor c=0.0235609f //x=4.12 \
 //y=5.2 //x2=4.105 //y2=5.14
cc_247 ( N_VDD_c_289_n N_Y_c_456_n ) capacitor c=0.0049725f //x=2.71 //y=7.585 \
 //x2=3.91 //y2=5.14
cc_248 ( N_VDD_c_272_n N_Y_c_466_n ) capacitor c=0.00241566f //x=4.56 //y=7.58 \
 //x2=3.825 //y2=5.56
cc_249 ( N_VDD_c_280_n N_Y_c_466_n ) capacitor c=0.0138017f //x=4.18 //y=7.585 \
 //x2=3.825 //y2=5.56
cc_250 ( N_VDD_c_283_n N_Y_c_466_n ) capacitor c=0.00962126f //x=4.56 //y=7.58 \
 //x2=3.825 //y2=5.56
cc_251 ( N_VDD_c_289_n N_Y_c_466_n ) capacitor c=0.00823854f //x=2.71 \
 //y=7.585 //x2=3.825 //y2=5.56
cc_252 ( N_VDD_M4_noxref_s N_Y_c_466_n ) capacitor c=0.0901615f //x=3.25 \
 //y=5.2 //x2=3.825 //y2=5.56
cc_253 ( N_VDD_M5_noxref_d N_Y_c_466_n ) capacitor c=0.0931055f //x=4.12 \
 //y=5.2 //x2=3.825 //y2=5.56
