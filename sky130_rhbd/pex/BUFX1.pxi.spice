// File: BUFX1.spi.BUFX1.pxi
// Created: Tue Apr 29 10:39:11 2025
//
simulator lang=spectre
x_PM_BUFX1\%GND ( GND N_GND_c_10_p N_GND_c_32_p N_GND_c_46_p N_GND_c_4_p \
 N_GND_c_25_p N_GND_c_1_p N_GND_c_2_p N_GND_c_3_p N_GND_M0_noxref_s \
 N_GND_M1_noxref_s )  PM_BUFX1\%GND
x_PM_BUFX1\%VDD ( VDD N_VDD_c_81_p N_VDD_c_65_p N_VDD_c_73_p N_VDD_c_61_n \
 N_VDD_c_62_n N_VDD_c_63_n N_VDD_M2_noxref_s N_VDD_M3_noxref_d \
 N_VDD_M4_noxref_s N_VDD_M5_noxref_d )  PM_BUFX1\%VDD
x_PM_BUFX1\%noxref_3 ( N_noxref_3_c_108_n N_noxref_3_c_112_n \
 N_noxref_3_c_114_n N_noxref_3_c_184_p N_noxref_3_c_142_n N_noxref_3_c_144_n \
 N_noxref_3_c_117_n N_noxref_3_c_120_n N_noxref_3_M1_noxref_g \
 N_noxref_3_M4_noxref_g N_noxref_3_M5_noxref_g N_noxref_3_c_125_n \
 N_noxref_3_c_197_p N_noxref_3_c_198_p N_noxref_3_c_127_n N_noxref_3_c_155_n \
 N_noxref_3_c_156_n N_noxref_3_c_128_n N_noxref_3_c_190_p N_noxref_3_c_129_n \
 N_noxref_3_c_131_n N_noxref_3_c_132_n N_noxref_3_M0_noxref_d \
 N_noxref_3_M2_noxref_d )  PM_BUFX1\%noxref_3
x_PM_BUFX1\%A ( A A A A A A A N_A_c_210_n N_A_M0_noxref_g N_A_M2_noxref_g \
 N_A_M3_noxref_g N_A_c_215_n N_A_c_244_n N_A_c_245_n N_A_c_217_n N_A_c_233_n \
 N_A_c_234_n N_A_c_218_n N_A_c_252_n N_A_c_219_n N_A_c_221_n N_A_c_222_n )  \
 PM_BUFX1\%A
x_PM_BUFX1\%Y ( Y Y Y Y Y Y Y N_Y_c_259_n N_Y_c_282_n N_Y_c_269_n N_Y_c_271_n \
 N_Y_M1_noxref_d N_Y_M4_noxref_d )  PM_BUFX1\%Y
cc_1 ( N_GND_c_1_p N_VDD_c_61_n ) capacitor c=0.00989514f //x=4.56 //y=0.18 \
 //x2=4.56 //y2=7.58
cc_2 ( N_GND_c_2_p N_VDD_c_62_n ) capacitor c=0.00989514f //x=1.12 //y=0.175 \
 //x2=1.23 //y2=7.58
cc_3 ( N_GND_c_3_p N_VDD_c_63_n ) capacitor c=0.00963367f //x=2.71 //y=0.175 \
 //x2=2.71 //y2=7.585
cc_4 ( N_GND_c_4_p N_noxref_3_c_108_n ) capacitor c=2.8021e-19 //x=3.74 \
 //y=0.715 //x2=3.335 //y2=2.77
cc_5 ( N_GND_c_3_p N_noxref_3_c_108_n ) capacitor c=0.0424932f //x=2.71 \
 //y=0.175 //x2=3.335 //y2=2.77
cc_6 ( N_GND_M0_noxref_s N_noxref_3_c_108_n ) capacitor c=0.00261544f \
 //x=0.985 //y=0.55 //x2=3.335 //y2=2.77
cc_7 ( N_GND_M1_noxref_s N_noxref_3_c_108_n ) capacitor c=0.00380507f \
 //x=3.205 //y=0.55 //x2=3.335 //y2=2.77
cc_8 ( N_GND_c_3_p N_noxref_3_c_112_n ) capacitor c=9.11674e-19 //x=2.71 \
 //y=0.175 //x2=2.085 //y2=2.77
cc_9 ( N_GND_M0_noxref_s N_noxref_3_c_112_n ) capacitor c=0.00152344f \
 //x=0.985 //y=0.55 //x2=2.085 //y2=2.77
cc_10 ( N_GND_c_10_p N_noxref_3_c_114_n ) capacitor c=0.00180368f //x=4.56 \
 //y=0.18 //x2=1.885 //y2=2.26
cc_11 ( N_GND_c_3_p N_noxref_3_c_114_n ) capacitor c=0.0266238f //x=2.71 \
 //y=0.175 //x2=1.885 //y2=2.26
cc_12 ( N_GND_M0_noxref_s N_noxref_3_c_114_n ) capacitor c=0.00950499f \
 //x=0.985 //y=0.55 //x2=1.885 //y2=2.26
cc_13 ( N_GND_c_2_p N_noxref_3_c_117_n ) capacitor c=9.71e-19 //x=1.12 \
 //y=0.175 //x2=1.97 //y2=2.77
cc_14 ( N_GND_c_3_p N_noxref_3_c_117_n ) capacitor c=5.56859e-19 //x=2.71 \
 //y=0.175 //x2=1.97 //y2=2.77
cc_15 ( N_GND_M0_noxref_s N_noxref_3_c_117_n ) capacitor c=2.30953e-19 \
 //x=0.985 //y=0.55 //x2=1.97 //y2=2.77
cc_16 ( N_GND_c_10_p N_noxref_3_c_120_n ) capacitor c=0.00203126f //x=4.56 \
 //y=0.18 //x2=3.45 //y2=2.265
cc_17 ( N_GND_c_4_p N_noxref_3_c_120_n ) capacitor c=7.79915e-19 //x=3.74 \
 //y=0.715 //x2=3.45 //y2=2.265
cc_18 ( N_GND_c_1_p N_noxref_3_c_120_n ) capacitor c=0.00135052f //x=4.56 \
 //y=0.18 //x2=3.45 //y2=2.265
cc_19 ( N_GND_c_3_p N_noxref_3_c_120_n ) capacitor c=0.0264037f //x=2.71 \
 //y=0.175 //x2=3.45 //y2=2.265
cc_20 ( N_GND_M1_noxref_s N_noxref_3_c_120_n ) capacitor c=0.0105404f \
 //x=3.205 //y=0.55 //x2=3.45 //y2=2.265
cc_21 ( N_GND_c_4_p N_noxref_3_c_125_n ) capacitor c=0.0121156f //x=3.74 \
 //y=0.715 //x2=3.56 //y2=1.09
cc_22 ( N_GND_M1_noxref_s N_noxref_3_c_125_n ) capacitor c=0.0315727f \
 //x=3.205 //y=0.55 //x2=3.56 //y2=1.09
cc_23 ( N_GND_c_3_p N_noxref_3_c_127_n ) capacitor c=0.0038551f //x=2.71 \
 //y=0.175 //x2=3.56 //y2=2.1
cc_24 ( N_GND_M1_noxref_s N_noxref_3_c_128_n ) capacitor c=0.00483567f \
 //x=3.205 //y=0.55 //x2=3.935 //y2=0.935
cc_25 ( N_GND_c_25_p N_noxref_3_c_129_n ) capacitor c=0.0118631f //x=4.225 \
 //y=0.715 //x2=4.09 //y2=1.09
cc_26 ( N_GND_M1_noxref_s N_noxref_3_c_129_n ) capacitor c=0.0143355f \
 //x=3.205 //y=0.55 //x2=4.09 //y2=1.09
cc_27 ( N_GND_M1_noxref_s N_noxref_3_c_131_n ) capacitor c=0.0074042f \
 //x=3.205 //y=0.55 //x2=4.09 //y2=1.435
cc_28 ( N_GND_c_4_p N_noxref_3_c_132_n ) capacitor c=2.1838e-19 //x=3.74 \
 //y=0.715 //x2=3.45 //y2=2.265
cc_29 ( N_GND_c_3_p N_noxref_3_c_132_n ) capacitor c=0.0108179f //x=2.71 \
 //y=0.175 //x2=3.45 //y2=2.265
cc_30 ( N_GND_M1_noxref_s N_noxref_3_c_132_n ) capacitor c=0.006523f //x=3.205 \
 //y=0.55 //x2=3.45 //y2=2.265
cc_31 ( N_GND_c_10_p N_noxref_3_M0_noxref_d ) capacitor c=0.00194747f //x=4.56 \
 //y=0.18 //x2=1.415 //y2=1.09
cc_32 ( N_GND_c_32_p N_noxref_3_M0_noxref_d ) capacitor c=0.014622f //x=1.52 \
 //y=0.715 //x2=1.415 //y2=1.09
cc_33 ( N_GND_c_1_p N_noxref_3_M0_noxref_d ) capacitor c=2.29264e-19 //x=4.56 \
 //y=0.18 //x2=1.415 //y2=1.09
cc_34 ( N_GND_c_2_p N_noxref_3_M0_noxref_d ) capacitor c=0.0094373f //x=1.12 \
 //y=0.175 //x2=1.415 //y2=1.09
cc_35 ( N_GND_c_3_p N_noxref_3_M0_noxref_d ) capacitor c=0.00945919f //x=2.71 \
 //y=0.175 //x2=1.415 //y2=1.09
cc_36 ( N_GND_M0_noxref_s N_noxref_3_M0_noxref_d ) capacitor c=0.076995f \
 //x=0.985 //y=0.55 //x2=1.415 //y2=1.09
cc_37 ( N_GND_c_10_p N_A_c_210_n ) capacitor c=0.00203126f //x=4.56 //y=0.18 \
 //x2=1.23 //y2=2.265
cc_38 ( N_GND_c_32_p N_A_c_210_n ) capacitor c=8.01092e-19 //x=1.52 //y=0.715 \
 //x2=1.23 //y2=2.265
cc_39 ( N_GND_c_2_p N_A_c_210_n ) capacitor c=0.028767f //x=1.12 //y=0.175 \
 //x2=1.23 //y2=2.265
cc_40 ( N_GND_c_3_p N_A_c_210_n ) capacitor c=0.00133096f //x=2.71 //y=0.175 \
 //x2=1.23 //y2=2.265
cc_41 ( N_GND_M0_noxref_s N_A_c_210_n ) capacitor c=0.0107289f //x=0.985 \
 //y=0.55 //x2=1.23 //y2=2.265
cc_42 ( N_GND_c_32_p N_A_c_215_n ) capacitor c=0.0120525f //x=1.52 //y=0.715 \
 //x2=1.34 //y2=1.09
cc_43 ( N_GND_M0_noxref_s N_A_c_215_n ) capacitor c=0.0315727f //x=0.985 \
 //y=0.55 //x2=1.34 //y2=1.09
cc_44 ( N_GND_c_2_p N_A_c_217_n ) capacitor c=0.0124051f //x=1.12 //y=0.175 \
 //x2=1.34 //y2=2.1
cc_45 ( N_GND_M0_noxref_s N_A_c_218_n ) capacitor c=0.00483567f //x=0.985 \
 //y=0.55 //x2=1.715 //y2=0.935
cc_46 ( N_GND_c_46_p N_A_c_219_n ) capacitor c=0.0118631f //x=2.005 //y=0.715 \
 //x2=1.87 //y2=1.09
cc_47 ( N_GND_M0_noxref_s N_A_c_219_n ) capacitor c=0.0143355f //x=0.985 \
 //y=0.55 //x2=1.87 //y2=1.09
cc_48 ( N_GND_M0_noxref_s N_A_c_221_n ) capacitor c=0.0074042f //x=0.985 \
 //y=0.55 //x2=1.87 //y2=1.435
cc_49 ( N_GND_c_32_p N_A_c_222_n ) capacitor c=2.1838e-19 //x=1.52 //y=0.715 \
 //x2=1.23 //y2=2.265
cc_50 ( N_GND_c_2_p N_A_c_222_n ) capacitor c=0.0108179f //x=1.12 //y=0.175 \
 //x2=1.23 //y2=2.265
cc_51 ( N_GND_M0_noxref_s N_A_c_222_n ) capacitor c=0.00650301f //x=0.985 \
 //y=0.55 //x2=1.23 //y2=2.265
cc_52 ( N_GND_c_3_p Y ) capacitor c=9.57726e-19 //x=2.71 //y=0.175 //x2=4.19 \
 //y2=2.4
cc_53 ( N_GND_c_10_p N_Y_c_259_n ) capacitor c=0.00212303f //x=4.56 //y=0.18 \
 //x2=4.105 //y2=2.26
cc_54 ( N_GND_c_1_p N_Y_c_259_n ) capacitor c=0.029556f //x=4.56 //y=0.18 \
 //x2=4.105 //y2=2.26
cc_55 ( N_GND_M1_noxref_s N_Y_c_259_n ) capacitor c=0.0099963f //x=3.205 \
 //y=0.55 //x2=4.105 //y2=2.26
cc_56 ( N_GND_c_10_p N_Y_M1_noxref_d ) capacitor c=0.00194747f //x=4.56 \
 //y=0.18 //x2=3.635 //y2=1.09
cc_57 ( N_GND_c_4_p N_Y_M1_noxref_d ) capacitor c=0.014622f //x=3.74 //y=0.715 \
 //x2=3.635 //y2=1.09
cc_58 ( N_GND_c_1_p N_Y_M1_noxref_d ) capacitor c=0.00973758f //x=4.56 \
 //y=0.18 //x2=3.635 //y2=1.09
cc_59 ( N_GND_c_3_p N_Y_M1_noxref_d ) capacitor c=0.00924905f //x=2.71 \
 //y=0.175 //x2=3.635 //y2=1.09
cc_60 ( N_GND_M1_noxref_s N_Y_M1_noxref_d ) capacitor c=0.076995f //x=3.205 \
 //y=0.55 //x2=3.635 //y2=1.09
cc_61 ( N_VDD_c_63_n N_noxref_3_c_108_n ) capacitor c=0.00382819f //x=2.71 \
 //y=7.585 //x2=3.335 //y2=2.77
cc_62 ( N_VDD_c_65_p N_noxref_3_c_142_n ) capacitor c=8.94397e-19 //x=1.96 \
 //y=7.585 //x2=1.885 //y2=4.76
cc_63 ( N_VDD_M3_noxref_d N_noxref_3_c_142_n ) capacitor c=0.00645128f //x=1.9 \
 //y=5.2 //x2=1.885 //y2=4.76
cc_64 ( N_VDD_c_62_n N_noxref_3_c_144_n ) capacitor c=0.0179238f //x=1.23 \
 //y=7.58 //x2=1.69 //y2=4.76
cc_65 ( N_VDD_c_62_n N_noxref_3_c_117_n ) capacitor c=4.80934e-19 //x=1.23 \
 //y=7.58 //x2=1.97 //y2=2.77
cc_66 ( N_VDD_c_63_n N_noxref_3_c_117_n ) capacitor c=0.0232484f //x=2.71 \
 //y=7.585 //x2=1.97 //y2=2.77
cc_67 ( N_VDD_c_61_n N_noxref_3_c_120_n ) capacitor c=0.00144809f //x=4.56 \
 //y=7.58 //x2=3.45 //y2=2.265
cc_68 ( N_VDD_c_63_n N_noxref_3_c_120_n ) capacitor c=0.0272885f //x=2.71 \
 //y=7.585 //x2=3.45 //y2=2.265
cc_69 ( N_VDD_M4_noxref_s N_noxref_3_c_120_n ) capacitor c=0.00938354f \
 //x=3.25 //y=5.2 //x2=3.45 //y2=2.265
cc_70 ( N_VDD_c_73_p N_noxref_3_M4_noxref_g ) capacitor c=0.00753931f //x=4.18 \
 //y=7.585 //x2=3.605 //y2=6.2
cc_71 ( N_VDD_c_63_n N_noxref_3_M4_noxref_g ) capacitor c=0.00653241f //x=2.71 \
 //y=7.585 //x2=3.605 //y2=6.2
cc_72 ( N_VDD_M4_noxref_s N_noxref_3_M4_noxref_g ) capacitor c=0.0528676f \
 //x=3.25 //y=5.2 //x2=3.605 //y2=6.2
cc_73 ( N_VDD_c_73_p N_noxref_3_M5_noxref_g ) capacitor c=0.00702238f //x=4.18 \
 //y=7.585 //x2=4.045 //y2=6.2
cc_74 ( N_VDD_M5_noxref_d N_noxref_3_M5_noxref_g ) capacitor c=0.0528676f \
 //x=4.12 //y=5.2 //x2=4.045 //y2=6.2
cc_75 ( N_VDD_c_61_n N_noxref_3_c_155_n ) capacitor c=0.0287802f //x=4.56 \
 //y=7.58 //x2=3.97 //y2=4.97
cc_76 ( N_VDD_c_63_n N_noxref_3_c_156_n ) capacitor c=0.011132f //x=2.71 \
 //y=7.585 //x2=3.68 //y2=4.97
cc_77 ( N_VDD_M4_noxref_s N_noxref_3_c_156_n ) capacitor c=0.00665885f \
 //x=3.25 //y=5.2 //x2=3.68 //y2=4.97
cc_78 ( N_VDD_c_81_p N_noxref_3_M2_noxref_d ) capacitor c=0.00724309f //x=4.56 \
 //y=7.58 //x2=1.46 //y2=5.2
cc_79 ( N_VDD_c_65_p N_noxref_3_M2_noxref_d ) capacitor c=0.0139426f //x=1.96 \
 //y=7.585 //x2=1.46 //y2=5.2
cc_80 ( N_VDD_c_61_n N_noxref_3_M2_noxref_d ) capacitor c=0.00135976f //x=4.56 \
 //y=7.58 //x2=1.46 //y2=5.2
cc_81 ( N_VDD_c_63_n N_noxref_3_M2_noxref_d ) capacitor c=0.0201812f //x=2.71 \
 //y=7.585 //x2=1.46 //y2=5.2
cc_82 ( N_VDD_M2_noxref_s N_noxref_3_M2_noxref_d ) capacitor c=0.0843065f \
 //x=1.03 //y=5.2 //x2=1.46 //y2=5.2
cc_83 ( N_VDD_M3_noxref_d N_noxref_3_M2_noxref_d ) capacitor c=0.0832641f \
 //x=1.9 //y=5.2 //x2=1.46 //y2=5.2
cc_84 ( N_VDD_c_62_n N_A_c_210_n ) capacitor c=0.0276175f //x=1.23 //y=7.58 \
 //x2=1.23 //y2=2.265
cc_85 ( N_VDD_c_63_n N_A_c_210_n ) capacitor c=0.00143749f //x=2.71 //y=7.585 \
 //x2=1.23 //y2=2.265
cc_86 ( N_VDD_M2_noxref_s N_A_c_210_n ) capacitor c=0.00938354f //x=1.03 \
 //y=5.2 //x2=1.23 //y2=2.265
cc_87 ( N_VDD_c_65_p N_A_M2_noxref_g ) capacitor c=0.00753931f //x=1.96 \
 //y=7.585 //x2=1.385 //y2=6.2
cc_88 ( N_VDD_c_62_n N_A_M2_noxref_g ) capacitor c=0.0241676f //x=1.23 \
 //y=7.58 //x2=1.385 //y2=6.2
cc_89 ( N_VDD_M2_noxref_s N_A_M2_noxref_g ) capacitor c=0.0528676f //x=1.03 \
 //y=5.2 //x2=1.385 //y2=6.2
cc_90 ( N_VDD_c_65_p N_A_M3_noxref_g ) capacitor c=0.00702238f //x=1.96 \
 //y=7.585 //x2=1.825 //y2=6.2
cc_91 ( N_VDD_M3_noxref_d N_A_M3_noxref_g ) capacitor c=0.0528676f //x=1.9 \
 //y=5.2 //x2=1.825 //y2=6.2
cc_92 ( N_VDD_c_63_n N_A_c_233_n ) capacitor c=0.0099588f //x=2.71 //y=7.585 \
 //x2=1.75 //y2=4.97
cc_93 ( N_VDD_c_62_n N_A_c_234_n ) capacitor c=0.011132f //x=1.23 //y=7.58 \
 //x2=1.46 //y2=4.97
cc_94 ( N_VDD_M2_noxref_s N_A_c_234_n ) capacitor c=0.00665885f //x=1.03 \
 //y=5.2 //x2=1.46 //y2=4.97
cc_95 ( N_VDD_c_61_n Y ) capacitor c=0.0232778f //x=4.56 //y=7.58 //x2=4.19 \
 //y2=2.4
cc_96 ( N_VDD_c_63_n Y ) capacitor c=4.80934e-19 //x=2.71 //y=7.585 //x2=4.19 \
 //y2=2.4
cc_97 ( N_VDD_c_73_p N_Y_c_269_n ) capacitor c=8.94397e-19 //x=4.18 //y=7.585 \
 //x2=4.105 //y2=4.76
cc_98 ( N_VDD_M5_noxref_d N_Y_c_269_n ) capacitor c=0.00645128f //x=4.12 \
 //y=5.2 //x2=4.105 //y2=4.76
cc_99 ( N_VDD_c_63_n N_Y_c_271_n ) capacitor c=0.017572f //x=2.71 //y=7.585 \
 //x2=3.91 //y2=4.76
cc_100 ( N_VDD_c_81_p N_Y_M4_noxref_d ) capacitor c=0.00724309f //x=4.56 \
 //y=7.58 //x2=3.68 //y2=5.2
cc_101 ( N_VDD_c_73_p N_Y_M4_noxref_d ) capacitor c=0.0139426f //x=4.18 \
 //y=7.585 //x2=3.68 //y2=5.2
cc_102 ( N_VDD_c_61_n N_Y_M4_noxref_d ) capacitor c=0.0219131f //x=4.56 \
 //y=7.58 //x2=3.68 //y2=5.2
cc_103 ( N_VDD_M4_noxref_s N_Y_M4_noxref_d ) capacitor c=0.0843065f //x=3.25 \
 //y=5.2 //x2=3.68 //y2=5.2
cc_104 ( N_VDD_M5_noxref_d N_Y_M4_noxref_d ) capacitor c=0.0832641f //x=4.12 \
 //y=5.2 //x2=3.68 //y2=5.2
cc_105 ( N_noxref_3_c_112_n N_A_c_210_n ) capacitor c=0.00730959f //x=2.085 \
 //y=2.77 //x2=1.23 //y2=2.265
cc_106 ( N_noxref_3_c_144_n N_A_c_210_n ) capacitor c=0.0250789f //x=1.69 \
 //y=4.76 //x2=1.23 //y2=2.265
cc_107 ( N_noxref_3_c_117_n N_A_c_210_n ) capacitor c=0.0712221f //x=1.97 \
 //y=2.77 //x2=1.23 //y2=2.265
cc_108 ( N_noxref_3_c_120_n N_A_c_210_n ) capacitor c=0.00109894f //x=3.45 \
 //y=2.265 //x2=1.23 //y2=2.265
cc_109 ( N_noxref_3_M0_noxref_d N_A_c_210_n ) capacitor c=0.0175773f //x=1.415 \
 //y=1.09 //x2=1.23 //y2=2.265
cc_110 ( N_noxref_3_M2_noxref_d N_A_M2_noxref_g ) capacitor c=0.0219309f \
 //x=1.46 //y=5.2 //x2=1.385 //y2=6.2
cc_111 ( N_noxref_3_M2_noxref_d N_A_M3_noxref_g ) capacitor c=0.021902f \
 //x=1.46 //y=5.2 //x2=1.825 //y2=6.2
cc_112 ( N_noxref_3_M0_noxref_d N_A_c_215_n ) capacitor c=0.00218556f \
 //x=1.415 //y=1.09 //x2=1.34 //y2=1.09
cc_113 ( N_noxref_3_M0_noxref_d N_A_c_244_n ) capacitor c=0.00347355f \
 //x=1.415 //y=1.09 //x2=1.34 //y2=1.435
cc_114 ( N_noxref_3_M0_noxref_d N_A_c_245_n ) capacitor c=0.00742431f \
 //x=1.415 //y=1.09 //x2=1.34 //y2=1.745
cc_115 ( N_noxref_3_M0_noxref_d N_A_c_217_n ) capacitor c=0.00957707f \
 //x=1.415 //y=1.09 //x2=1.34 //y2=2.1
cc_116 ( N_noxref_3_c_142_n N_A_c_233_n ) capacitor c=0.0107726f //x=1.885 \
 //y=4.76 //x2=1.75 //y2=4.97
cc_117 ( N_noxref_3_M2_noxref_d N_A_c_233_n ) capacitor c=0.0148755f //x=1.46 \
 //y=5.2 //x2=1.75 //y2=4.97
cc_118 ( N_noxref_3_c_144_n N_A_c_234_n ) capacitor c=0.00962086f //x=1.69 \
 //y=4.76 //x2=1.46 //y2=4.97
cc_119 ( N_noxref_3_M2_noxref_d N_A_c_234_n ) capacitor c=0.00307344f //x=1.46 \
 //y=5.2 //x2=1.46 //y2=4.97
cc_120 ( N_noxref_3_M0_noxref_d N_A_c_218_n ) capacitor c=0.00220879f \
 //x=1.415 //y=1.09 //x2=1.715 //y2=0.935
cc_121 ( N_noxref_3_c_114_n N_A_c_252_n ) capacitor c=0.0023507f //x=1.885 \
 //y=2.26 //x2=1.715 //y2=1.59
cc_122 ( N_noxref_3_M0_noxref_d N_A_c_252_n ) capacitor c=0.0138447f //x=1.415 \
 //y=1.09 //x2=1.715 //y2=1.59
cc_123 ( N_noxref_3_M0_noxref_d N_A_c_219_n ) capacitor c=0.00218624f \
 //x=1.415 //y=1.09 //x2=1.87 //y2=1.09
cc_124 ( N_noxref_3_M0_noxref_d N_A_c_221_n ) capacitor c=0.00601286f \
 //x=1.415 //y=1.09 //x2=1.87 //y2=1.435
cc_125 ( N_noxref_3_c_184_p N_A_c_222_n ) capacitor c=0.0167852f //x=1.685 \
 //y=2.26 //x2=1.23 //y2=2.265
cc_126 ( N_noxref_3_c_117_n N_A_c_222_n ) capacitor c=8.49451e-19 //x=1.97 \
 //y=2.77 //x2=1.23 //y2=2.265
cc_127 ( N_noxref_3_c_108_n Y ) capacitor c=0.00730959f //x=3.335 //y=2.77 \
 //x2=4.19 //y2=2.4
cc_128 ( N_noxref_3_c_117_n Y ) capacitor c=0.00108914f //x=1.97 //y=2.77 \
 //x2=4.19 //y2=2.4
cc_129 ( N_noxref_3_c_120_n Y ) capacitor c=0.0712221f //x=3.45 //y=2.265 \
 //x2=4.19 //y2=2.4
cc_130 ( N_noxref_3_c_132_n Y ) capacitor c=8.49451e-19 //x=3.45 //y=2.265 \
 //x2=4.19 //y2=2.4
cc_131 ( N_noxref_3_c_190_p N_Y_c_259_n ) capacitor c=0.0023507f //x=3.935 \
 //y=1.59 //x2=4.105 //y2=2.26
cc_132 ( N_noxref_3_c_132_n N_Y_c_282_n ) capacitor c=0.0167852f //x=3.45 \
 //y=2.265 //x2=3.905 //y2=2.26
cc_133 ( N_noxref_3_c_155_n N_Y_c_269_n ) capacitor c=0.0107726f //x=3.97 \
 //y=4.97 //x2=4.105 //y2=4.76
cc_134 ( N_noxref_3_c_120_n N_Y_c_271_n ) capacitor c=0.0253118f //x=3.45 \
 //y=2.265 //x2=3.91 //y2=4.76
cc_135 ( N_noxref_3_c_156_n N_Y_c_271_n ) capacitor c=0.00962086f //x=3.68 \
 //y=4.97 //x2=3.91 //y2=4.76
cc_136 ( N_noxref_3_c_120_n N_Y_M1_noxref_d ) capacitor c=0.0177062f //x=3.45 \
 //y=2.265 //x2=3.635 //y2=1.09
cc_137 ( N_noxref_3_c_125_n N_Y_M1_noxref_d ) capacitor c=0.00218556f //x=3.56 \
 //y=1.09 //x2=3.635 //y2=1.09
cc_138 ( N_noxref_3_c_197_p N_Y_M1_noxref_d ) capacitor c=0.00347355f //x=3.56 \
 //y=1.435 //x2=3.635 //y2=1.09
cc_139 ( N_noxref_3_c_198_p N_Y_M1_noxref_d ) capacitor c=0.00742431f //x=3.56 \
 //y=1.745 //x2=3.635 //y2=1.09
cc_140 ( N_noxref_3_c_127_n N_Y_M1_noxref_d ) capacitor c=0.00957707f //x=3.56 \
 //y=2.1 //x2=3.635 //y2=1.09
cc_141 ( N_noxref_3_c_128_n N_Y_M1_noxref_d ) capacitor c=0.00220879f \
 //x=3.935 //y=0.935 //x2=3.635 //y2=1.09
cc_142 ( N_noxref_3_c_190_p N_Y_M1_noxref_d ) capacitor c=0.0138447f //x=3.935 \
 //y=1.59 //x2=3.635 //y2=1.09
cc_143 ( N_noxref_3_c_129_n N_Y_M1_noxref_d ) capacitor c=0.00218624f //x=4.09 \
 //y=1.09 //x2=3.635 //y2=1.09
cc_144 ( N_noxref_3_c_131_n N_Y_M1_noxref_d ) capacitor c=0.00601286f //x=4.09 \
 //y=1.435 //x2=3.635 //y2=1.09
cc_145 ( N_noxref_3_M0_noxref_d N_Y_M1_noxref_d ) capacitor c=2.55525e-19 \
 //x=1.415 //y=1.09 //x2=3.635 //y2=1.09
cc_146 ( N_noxref_3_M4_noxref_g N_Y_M4_noxref_d ) capacitor c=0.0219309f \
 //x=3.605 //y=6.2 //x2=3.68 //y2=5.2
cc_147 ( N_noxref_3_M5_noxref_g N_Y_M4_noxref_d ) capacitor c=0.021902f \
 //x=4.045 //y=6.2 //x2=3.68 //y2=5.2
cc_148 ( N_noxref_3_c_155_n N_Y_M4_noxref_d ) capacitor c=0.0148755f //x=3.97 \
 //y=4.97 //x2=3.68 //y2=5.2
cc_149 ( N_noxref_3_c_156_n N_Y_M4_noxref_d ) capacitor c=0.00307344f //x=3.68 \
 //y=4.97 //x2=3.68 //y2=5.2
cc_150 ( N_noxref_3_M2_noxref_d N_Y_M4_noxref_d ) capacitor c=7.38512e-19 \
 //x=1.46 //y=5.2 //x2=3.68 //y2=5.2
