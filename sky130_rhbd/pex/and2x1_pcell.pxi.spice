// File: and2x1_pcell.spi.AND2X1_PCELL.pxi
// Created: Fri Feb 20 10:17:53 2026
//
simulator lang=spectre
x_PM_AND2X1_PCELL\%noxref_1 ( N_noxref_1_c_1_p N_noxref_1_c_95_p \
 N_noxref_1_c_2_p N_noxref_1_c_74_p N_noxref_1_c_207_p N_noxref_1_c_63_p \
 N_noxref_1_c_3_p N_noxref_1_c_27_p N_noxref_1_c_97_p N_noxref_1_c_4_p \
 N_noxref_1_c_5_p N_noxref_1_c_6_p N_noxref_1_c_7_p N_noxref_1_c_8_p \
 N_noxref_1_c_77_p N_noxref_1_c_49_p N_noxref_1_c_182_p N_noxref_1_c_78_p \
 N_noxref_1_c_34_p N_noxref_1_c_121_p N_noxref_1_c_56_p N_noxref_1_c_9_p \
 N_noxref_1_c_10_p N_noxref_1_c_79_p N_noxref_1_c_11_p N_noxref_1_M2_noxref_g \
 N_noxref_1_M7_noxref_g N_noxref_1_M8_noxref_g N_noxref_1_c_89_p \
 N_noxref_1_c_161_p N_noxref_1_c_108_p N_noxref_1_c_101_p N_noxref_1_c_26_p \
 N_noxref_1_c_38_p N_noxref_1_c_110_p N_noxref_1_c_164_p N_noxref_1_c_91_p \
 N_noxref_1_c_112_p N_noxref_1_c_90_p N_noxref_1_M1_noxref_d \
 N_noxref_1_M3_noxref_d N_noxref_1_M5_noxref_d )  PM_AND2X1_PCELL\%noxref_1
x_PM_AND2X1_PCELL\%noxref_2 ( N_noxref_2_c_217_n N_noxref_2_c_228_n \
 N_noxref_2_c_231_n N_noxref_2_c_236_n N_noxref_2_c_239_n N_noxref_2_c_243_n \
 N_noxref_2_c_246_n N_noxref_2_M3_noxref_s N_noxref_2_M4_noxref_d \
 N_noxref_2_M6_noxref_d N_noxref_2_M7_noxref_s N_noxref_2_M8_noxref_d )  \
 PM_AND2X1_PCELL\%noxref_2
x_PM_AND2X1_PCELL\%noxref_3 ( N_noxref_3_c_340_p N_noxref_3_c_316_n \
 N_noxref_3_c_318_n N_noxref_3_c_342_p N_noxref_3_c_320_n \
 N_noxref_3_M0_noxref_g N_noxref_3_M3_noxref_g N_noxref_3_M4_noxref_g \
 N_noxref_3_c_343_p N_noxref_3_c_344_p N_noxref_3_c_345_p N_noxref_3_c_358_p \
 N_noxref_3_c_346_p N_noxref_3_c_347_p N_noxref_3_c_348_p N_noxref_3_c_349_p \
 N_noxref_3_c_327_n )  PM_AND2X1_PCELL\%noxref_3
x_PM_AND2X1_PCELL\%noxref_4 ( N_noxref_4_c_455_n N_noxref_4_c_412_n \
 N_noxref_4_c_419_n N_noxref_4_c_465_n N_noxref_4_c_422_n N_noxref_4_c_424_n \
 N_noxref_4_c_518_p N_noxref_4_c_425_n N_noxref_4_c_429_n N_noxref_4_c_430_n \
 N_noxref_4_c_433_n N_noxref_4_M0_noxref_d N_noxref_4_M2_noxref_s )  \
 PM_AND2X1_PCELL\%noxref_4
x_PM_AND2X1_PCELL\%noxref_5 ( N_noxref_5_c_530_n N_noxref_5_c_538_n \
 N_noxref_5_c_540_n N_noxref_5_c_541_n N_noxref_5_M1_noxref_g \
 N_noxref_5_M5_noxref_g N_noxref_5_M6_noxref_g N_noxref_5_c_549_n \
 N_noxref_5_c_551_n N_noxref_5_c_554_n N_noxref_5_c_555_n N_noxref_5_c_558_n \
 N_noxref_5_c_560_n N_noxref_5_c_564_n N_noxref_5_c_566_n N_noxref_5_c_570_n \
 N_noxref_5_c_571_n N_noxref_5_c_573_n )  PM_AND2X1_PCELL\%noxref_5
x_PM_AND2X1_PCELL\%noxref_6 ( N_noxref_6_c_634_n N_noxref_6_c_641_n \
 N_noxref_6_c_645_n N_noxref_6_c_646_n N_noxref_6_c_648_n N_noxref_6_c_649_n \
 N_noxref_6_c_652_n N_noxref_6_c_665_n N_noxref_6_c_673_n \
 N_noxref_6_M2_noxref_d N_noxref_6_M7_noxref_d )  PM_AND2X1_PCELL\%noxref_6
x_PM_AND2X1_PCELL\%noxref_7 ( N_noxref_7_c_724_n N_noxref_7_c_725_n \
 N_noxref_7_c_740_n N_noxref_7_c_714_n N_noxref_7_c_715_n N_noxref_7_c_750_n \
 N_noxref_7_M0_noxref_s )  PM_AND2X1_PCELL\%noxref_7
cc_1 ( N_noxref_1_c_1_p N_noxref_2_c_217_n ) capacitor c=0.00647565f //x=1.995 \
 //y=5.2 //x2=5.18 //y2=7.4
cc_2 ( N_noxref_1_c_2_p N_noxref_2_c_217_n ) capacitor c=0.00491449f //x=2.505 \
 //y=5.2 //x2=5.18 //y2=7.4
cc_3 ( N_noxref_1_c_3_p N_noxref_2_c_217_n ) capacitor c=4.27843e-19 //x=2.59 \
 //y=3.49 //x2=5.18 //y2=7.4
cc_4 ( N_noxref_1_c_4_p N_noxref_2_c_217_n ) capacitor c=2.4719e-19 //x=4.07 \
 //y=3.49 //x2=5.18 //y2=7.4
cc_5 ( N_noxref_1_c_5_p N_noxref_2_c_217_n ) capacitor c=5.72118e-19 //x=4.07 \
 //y=4.58 //x2=5.18 //y2=7.4
cc_6 ( N_noxref_1_c_6_p N_noxref_2_c_217_n ) capacitor c=0.00368144f //x=1.23 \
 //y=5.38 //x2=5.18 //y2=7.4
cc_7 ( N_noxref_1_c_7_p N_noxref_2_c_217_n ) capacitor c=8.41206e-19 //x=2.11 \
 //y=5.2 //x2=5.18 //y2=7.4
cc_8 ( N_noxref_1_c_8_p N_noxref_2_c_217_n ) capacitor c=0.00285294f //x=2.11 \
 //y=5.38 //x2=5.18 //y2=7.4
cc_9 ( N_noxref_1_c_9_p N_noxref_2_c_217_n ) capacitor c=0.00224727f //x=1.23 \
 //y=5.38 //x2=5.18 //y2=7.4
cc_10 ( N_noxref_1_c_10_p N_noxref_2_c_217_n ) capacitor c=0.00224727f \
 //x=2.11 //y=5.38 //x2=5.18 //y2=7.4
cc_11 ( N_noxref_1_c_11_p N_noxref_2_c_217_n ) capacitor c=3.40875e-19 \
 //x=4.07 //y=4.7 //x2=5.18 //y2=7.4
cc_12 ( N_noxref_1_c_1_p N_noxref_2_c_228_n ) capacitor c=0.00213214f \
 //x=1.995 //y=5.2 //x2=1.585 //y2=7.4
cc_13 ( N_noxref_1_c_6_p N_noxref_2_c_228_n ) capacitor c=9.98713e-19 //x=1.23 \
 //y=5.38 //x2=1.585 //y2=7.4
cc_14 ( N_noxref_1_c_9_p N_noxref_2_c_228_n ) capacitor c=0.0136475f //x=1.23 \
 //y=5.38 //x2=1.585 //y2=7.4
cc_15 ( N_noxref_1_c_1_p N_noxref_2_c_231_n ) capacitor c=0.00184538f \
 //x=1.995 //y=5.2 //x2=2.465 //y2=7.4
cc_16 ( N_noxref_1_c_2_p N_noxref_2_c_231_n ) capacitor c=0.00213214f \
 //x=2.505 //y=5.2 //x2=2.465 //y2=7.4
cc_17 ( N_noxref_1_c_7_p N_noxref_2_c_231_n ) capacitor c=5.38567e-19 //x=2.11 \
 //y=5.2 //x2=2.465 //y2=7.4
cc_18 ( N_noxref_1_c_8_p N_noxref_2_c_231_n ) capacitor c=5.78261e-19 //x=2.11 \
 //y=5.38 //x2=2.465 //y2=7.4
cc_19 ( N_noxref_1_c_10_p N_noxref_2_c_231_n ) capacitor c=0.0136475f //x=2.11 \
 //y=5.38 //x2=2.465 //y2=7.4
cc_20 ( N_noxref_1_c_5_p N_noxref_2_c_236_n ) capacitor c=5.4912e-19 //x=4.07 \
 //y=4.58 //x2=4.8 //y2=7.4
cc_21 ( N_noxref_1_M7_noxref_g N_noxref_2_c_236_n ) capacitor c=0.00748034f \
 //x=4.225 //y=6.02 //x2=4.8 //y2=7.4
cc_22 ( N_noxref_1_M8_noxref_g N_noxref_2_c_236_n ) capacitor c=0.00749619f \
 //x=4.665 //y=6.02 //x2=4.8 //y2=7.4
cc_23 ( N_noxref_1_c_9_p N_noxref_2_c_239_n ) capacitor c=0.00135089f //x=1.23 \
 //y=5.38 //x2=5.18 //y2=7.4
cc_24 ( N_noxref_1_c_10_p N_noxref_2_c_239_n ) capacitor c=0.00135089f \
 //x=2.11 //y=5.38 //x2=5.18 //y2=7.4
cc_25 ( N_noxref_1_c_11_p N_noxref_2_c_239_n ) capacitor c=0.00241457f \
 //x=4.07 //y=4.7 //x2=5.18 //y2=7.4
cc_26 ( N_noxref_1_c_26_p N_noxref_2_c_239_n ) capacitor c=0.0201557f //x=4.59 \
 //y=4.79 //x2=5.18 //y2=7.4
cc_27 ( N_noxref_1_c_27_p N_noxref_2_c_243_n ) capacitor c=0.00197052f \
 //x=2.59 //y=5.115 //x2=0.74 //y2=7.4
cc_28 ( N_noxref_1_c_6_p N_noxref_2_c_243_n ) capacitor c=6.39392e-19 //x=1.23 \
 //y=5.38 //x2=0.74 //y2=7.4
cc_29 ( N_noxref_1_c_9_p N_noxref_2_c_243_n ) capacitor c=0.0064135f //x=1.23 \
 //y=5.38 //x2=0.74 //y2=7.4
cc_30 ( N_noxref_1_c_27_p N_noxref_2_c_246_n ) capacitor c=0.0283322f //x=2.59 \
 //y=5.115 //x2=3.33 //y2=7.4
cc_31 ( N_noxref_1_c_5_p N_noxref_2_c_246_n ) capacitor c=0.0155837f //x=4.07 \
 //y=4.58 //x2=3.33 //y2=7.4
cc_32 ( N_noxref_1_c_7_p N_noxref_2_c_246_n ) capacitor c=0.002343f //x=2.11 \
 //y=5.2 //x2=3.33 //y2=7.4
cc_33 ( N_noxref_1_c_8_p N_noxref_2_c_246_n ) capacitor c=4.0348e-19 //x=2.11 \
 //y=5.38 //x2=3.33 //y2=7.4
cc_34 ( N_noxref_1_c_34_p N_noxref_2_c_246_n ) capacitor c=0.00501351f \
 //x=3.905 //y=3.33 //x2=3.33 //y2=7.4
cc_35 ( N_noxref_1_c_10_p N_noxref_2_c_246_n ) capacitor c=0.0101861f //x=2.11 \
 //y=5.38 //x2=3.33 //y2=7.4
cc_36 ( N_noxref_1_c_11_p N_noxref_2_c_246_n ) capacitor c=0.00795305f \
 //x=4.07 //y=4.7 //x2=3.33 //y2=7.4
cc_37 ( N_noxref_1_M7_noxref_g N_noxref_2_c_246_n ) capacitor c=0.00713874f \
 //x=4.225 //y=6.02 //x2=3.33 //y2=7.4
cc_38 ( N_noxref_1_c_38_p N_noxref_2_c_246_n ) capacitor c=0.00799922f //x=4.3 \
 //y=4.79 //x2=3.33 //y2=7.4
cc_39 ( N_noxref_1_c_6_p N_noxref_2_M3_noxref_s ) capacitor c=0.062494f \
 //x=1.23 //y=5.38 //x2=0.655 //y2=5.02
cc_40 ( N_noxref_1_c_7_p N_noxref_2_M3_noxref_s ) capacitor c=6.52457e-19 \
 //x=2.11 //y=5.2 //x2=0.655 //y2=5.02
cc_41 ( N_noxref_1_c_9_p N_noxref_2_M3_noxref_s ) capacitor c=0.0906717f \
 //x=1.23 //y=5.38 //x2=0.655 //y2=5.02
cc_42 ( N_noxref_1_c_1_p N_noxref_2_M4_noxref_d ) capacitor c=0.00810167f \
 //x=1.995 //y=5.2 //x2=1.525 //y2=5.02
cc_43 ( N_noxref_1_c_6_p N_noxref_2_M4_noxref_d ) capacitor c=0.0043528f \
 //x=1.23 //y=5.38 //x2=1.525 //y2=5.02
cc_44 ( N_noxref_1_c_8_p N_noxref_2_M4_noxref_d ) capacitor c=0.0043528f \
 //x=2.11 //y=5.38 //x2=1.525 //y2=5.02
cc_45 ( N_noxref_1_c_9_p N_noxref_2_M4_noxref_d ) capacitor c=0.065554f \
 //x=1.23 //y=5.38 //x2=1.525 //y2=5.02
cc_46 ( N_noxref_1_c_10_p N_noxref_2_M4_noxref_d ) capacitor c=0.065554f \
 //x=2.11 //y=5.38 //x2=1.525 //y2=5.02
cc_47 ( N_noxref_1_c_2_p N_noxref_2_M6_noxref_d ) capacitor c=0.00933287f \
 //x=2.505 //y=5.2 //x2=2.405 //y2=5.02
cc_48 ( N_noxref_1_c_8_p N_noxref_2_M6_noxref_d ) capacitor c=0.00921458f \
 //x=2.11 //y=5.38 //x2=2.405 //y2=5.02
cc_49 ( N_noxref_1_c_49_p N_noxref_2_M6_noxref_d ) capacitor c=9.65858e-19 \
 //x=2.59 //y=3.33 //x2=2.405 //y2=5.02
cc_50 ( N_noxref_1_c_10_p N_noxref_2_M6_noxref_d ) capacitor c=0.065554f \
 //x=2.11 //y=5.38 //x2=2.405 //y2=5.02
cc_51 ( N_noxref_1_c_2_p N_noxref_2_M7_noxref_s ) capacitor c=0.00316782f \
 //x=2.505 //y=5.2 //x2=3.87 //y2=5.02
cc_52 ( N_noxref_1_c_4_p N_noxref_2_M7_noxref_s ) capacitor c=0.00120123f \
 //x=4.07 //y=3.49 //x2=3.87 //y2=5.02
cc_53 ( N_noxref_1_c_5_p N_noxref_2_M7_noxref_s ) capacitor c=0.0211606f \
 //x=4.07 //y=4.58 //x2=3.87 //y2=5.02
cc_54 ( N_noxref_1_c_7_p N_noxref_2_M7_noxref_s ) capacitor c=0.00460957f \
 //x=2.11 //y=5.2 //x2=3.87 //y2=5.02
cc_55 ( N_noxref_1_c_8_p N_noxref_2_M7_noxref_s ) capacitor c=0.00135645f \
 //x=2.11 //y=5.38 //x2=3.87 //y2=5.02
cc_56 ( N_noxref_1_c_56_p N_noxref_2_M7_noxref_s ) capacitor c=4.8313e-19 \
 //x=4.065 //y=3.33 //x2=3.87 //y2=5.02
cc_57 ( N_noxref_1_c_11_p N_noxref_2_M7_noxref_s ) capacitor c=0.00986151f \
 //x=4.07 //y=4.7 //x2=3.87 //y2=5.02
cc_58 ( N_noxref_1_M7_noxref_g N_noxref_2_M7_noxref_s ) capacitor c=0.0573441f \
 //x=4.225 //y=6.02 //x2=3.87 //y2=5.02
cc_59 ( N_noxref_1_c_38_p N_noxref_2_M7_noxref_s ) capacitor c=0.00524547f \
 //x=4.3 //y=4.79 //x2=3.87 //y2=5.02
cc_60 ( N_noxref_1_M8_noxref_g N_noxref_2_M8_noxref_d ) capacitor c=0.0572684f \
 //x=4.665 //y=6.02 //x2=4.74 //y2=5.02
cc_61 ( N_noxref_1_c_6_p N_noxref_3_c_316_n ) capacitor c=0.0118546f //x=1.23 \
 //y=5.38 //x2=1.11 //y2=4.7
cc_62 ( N_noxref_1_c_9_p N_noxref_3_c_316_n ) capacitor c=0.00165549f //x=1.23 \
 //y=5.38 //x2=1.11 //y2=4.7
cc_63 ( N_noxref_1_c_63_p N_noxref_3_c_318_n ) capacitor c=0.00327648f \
 //x=2.59 //y=3.17 //x2=1.112 //y2=4.56
cc_64 ( N_noxref_1_c_27_p N_noxref_3_c_318_n ) capacitor c=0.00327281f \
 //x=2.59 //y=5.115 //x2=1.112 //y2=4.56
cc_65 ( N_noxref_1_c_6_p N_noxref_3_c_320_n ) capacitor c=0.00277154f //x=1.23 \
 //y=5.38 //x2=1.11 //y2=4.7
cc_66 ( N_noxref_1_c_9_p N_noxref_3_c_320_n ) capacitor c=0.00377369f //x=1.23 \
 //y=5.38 //x2=1.11 //y2=4.7
cc_67 ( N_noxref_1_c_6_p N_noxref_3_M3_noxref_g ) capacitor c=0.0020878f \
 //x=1.23 //y=5.38 //x2=1.01 //y2=6.02
cc_68 ( N_noxref_1_c_9_p N_noxref_3_M3_noxref_g ) capacitor c=0.0158358f \
 //x=1.23 //y=5.38 //x2=1.01 //y2=6.02
cc_69 ( N_noxref_1_c_1_p N_noxref_3_M4_noxref_g ) capacitor c=0.0129249f \
 //x=1.995 //y=5.2 //x2=1.45 //y2=6.02
cc_70 ( N_noxref_1_c_6_p N_noxref_3_M4_noxref_g ) capacitor c=0.00192712f \
 //x=1.23 //y=5.38 //x2=1.45 //y2=6.02
cc_71 ( N_noxref_1_c_9_p N_noxref_3_M4_noxref_g ) capacitor c=0.0178987f \
 //x=1.23 //y=5.38 //x2=1.45 //y2=6.02
cc_72 ( N_noxref_1_c_6_p N_noxref_3_c_327_n ) capacitor c=0.00207241f //x=1.23 \
 //y=5.38 //x2=1.11 //y2=4.7
cc_73 ( N_noxref_1_c_9_p N_noxref_3_c_327_n ) capacitor c=0.0043218f //x=1.23 \
 //y=5.38 //x2=1.11 //y2=4.7
cc_74 ( N_noxref_1_c_74_p N_noxref_4_c_412_n ) capacitor c=0.00653239f \
 //x=2.505 //y=1.655 //x2=5.18 //y2=0
cc_75 ( N_noxref_1_c_3_p N_noxref_4_c_412_n ) capacitor c=4.52113e-19 //x=2.59 \
 //y=3.49 //x2=5.18 //y2=0
cc_76 ( N_noxref_1_c_4_p N_noxref_4_c_412_n ) capacitor c=4.40544e-19 //x=4.07 \
 //y=3.49 //x2=5.18 //y2=0
cc_77 ( N_noxref_1_c_77_p N_noxref_4_c_412_n ) capacitor c=0.00963092f \
 //x=2.15 //y=1 //x2=5.18 //y2=0
cc_78 ( N_noxref_1_c_78_p N_noxref_4_c_412_n ) capacitor c=0.00248634f \
 //x=4.07 //y=2.085 //x2=5.18 //y2=0
cc_79 ( N_noxref_1_c_79_p N_noxref_4_c_412_n ) capacitor c=7.53892e-19 \
 //x=4.07 //y=2.085 //x2=5.18 //y2=0
cc_80 ( N_noxref_1_M1_noxref_d N_noxref_4_c_412_n ) capacitor c=3.01654e-19 \
 //x=1.96 //y=0.905 //x2=5.18 //y2=0
cc_81 ( N_noxref_1_c_6_p N_noxref_4_c_419_n ) capacitor c=9.64329e-19 //x=1.23 \
 //y=5.38 //x2=1.18 //y2=0.955
cc_82 ( N_noxref_1_c_77_p N_noxref_4_c_419_n ) capacitor c=0.0141956f //x=2.15 \
 //y=1 //x2=1.18 //y2=0.955
cc_83 ( N_noxref_1_M1_noxref_d N_noxref_4_c_419_n ) capacitor c=2.93544e-19 \
 //x=1.96 //y=0.905 //x2=1.18 //y2=0.955
cc_84 ( N_noxref_1_c_74_p N_noxref_4_c_422_n ) capacitor c=7.76556e-19 \
 //x=2.505 //y=1.655 //x2=3.16 //y2=0
cc_85 ( N_noxref_1_c_3_p N_noxref_4_c_422_n ) capacitor c=3.21617e-19 //x=2.59 \
 //y=3.49 //x2=3.16 //y2=0
cc_86 ( N_noxref_1_c_63_p N_noxref_4_c_424_n ) capacitor c=0.00139243f \
 //x=2.59 //y=3.17 //x2=0.74 //y2=0
cc_87 ( N_noxref_1_c_78_p N_noxref_4_c_425_n ) capacitor c=0.00114179f \
 //x=4.07 //y=2.085 //x2=4.355 //y2=0.535
cc_88 ( N_noxref_1_c_79_p N_noxref_4_c_425_n ) capacitor c=3.95714e-19 \
 //x=4.07 //y=2.085 //x2=4.355 //y2=0.535
cc_89 ( N_noxref_1_c_89_p N_noxref_4_c_425_n ) capacitor c=0.0125414f //x=4.18 \
 //y=0.91 //x2=4.355 //y2=0.535
cc_90 ( N_noxref_1_c_90_p N_noxref_4_c_425_n ) capacitor c=2.1838e-19 //x=4.07 \
 //y=2.085 //x2=4.355 //y2=0.535
cc_91 ( N_noxref_1_c_91_p N_noxref_4_c_429_n ) capacitor c=0.0134259f //x=4.71 \
 //y=0.91 //x2=4.845 //y2=0.535
cc_92 ( N_noxref_1_c_77_p N_noxref_4_c_430_n ) capacitor c=2.83275e-19 \
 //x=2.15 //y=1 //x2=5.18 //y2=0
cc_93 ( N_noxref_1_c_79_p N_noxref_4_c_430_n ) capacitor c=0.0022444f //x=4.07 \
 //y=2.085 //x2=5.18 //y2=0
cc_94 ( N_noxref_1_c_90_p N_noxref_4_c_430_n ) capacitor c=2.63786e-19 \
 //x=4.07 //y=2.085 //x2=5.18 //y2=0
cc_95 ( N_noxref_1_c_95_p N_noxref_4_c_433_n ) capacitor c=0.00269515f \
 //x=2.15 //y=1.57 //x2=3.33 //y2=0
cc_96 ( N_noxref_1_c_74_p N_noxref_4_c_433_n ) capacitor c=0.0271933f \
 //x=2.505 //y=1.655 //x2=3.33 //y2=0
cc_97 ( N_noxref_1_c_97_p N_noxref_4_c_433_n ) capacitor c=0.0103129f //x=4.07 \
 //y=3.17 //x2=3.33 //y2=0
cc_98 ( N_noxref_1_c_78_p N_noxref_4_c_433_n ) capacitor c=0.00682461f \
 //x=4.07 //y=2.085 //x2=3.33 //y2=0
cc_99 ( N_noxref_1_c_34_p N_noxref_4_c_433_n ) capacitor c=0.00560353f \
 //x=3.905 //y=3.33 //x2=3.33 //y2=0
cc_100 ( N_noxref_1_c_79_p N_noxref_4_c_433_n ) capacitor c=0.00733236f \
 //x=4.07 //y=2.085 //x2=3.33 //y2=0
cc_101 ( N_noxref_1_c_101_p N_noxref_4_c_433_n ) capacitor c=0.00427677f \
 //x=4.18 //y=1.92 //x2=3.33 //y2=0
cc_102 ( N_noxref_1_c_90_p N_noxref_4_c_433_n ) capacitor c=0.00786308f \
 //x=4.07 //y=2.085 //x2=3.33 //y2=0
cc_103 ( N_noxref_1_c_77_p N_noxref_4_M0_noxref_d ) capacitor c=2.82748e-19 \
 //x=2.15 //y=1 //x2=0.99 //y2=0.865
cc_104 ( N_noxref_1_c_4_p N_noxref_4_M2_noxref_s ) capacitor c=8.20236e-19 \
 //x=4.07 //y=3.49 //x2=3.825 //y2=0.37
cc_105 ( N_noxref_1_c_78_p N_noxref_4_M2_noxref_s ) capacitor c=0.00297844f \
 //x=4.07 //y=2.085 //x2=3.825 //y2=0.37
cc_106 ( N_noxref_1_c_79_p N_noxref_4_M2_noxref_s ) capacitor c=0.00651272f \
 //x=4.07 //y=2.085 //x2=3.825 //y2=0.37
cc_107 ( N_noxref_1_c_89_p N_noxref_4_M2_noxref_s ) capacitor c=0.0300814f \
 //x=4.18 //y=0.91 //x2=3.825 //y2=0.37
cc_108 ( N_noxref_1_c_108_p N_noxref_4_M2_noxref_s ) capacitor c=0.002132f \
 //x=4.18 //y=1.565 //x2=3.825 //y2=0.37
cc_109 ( N_noxref_1_c_101_p N_noxref_4_M2_noxref_s ) capacitor c=0.00304786f \
 //x=4.18 //y=1.92 //x2=3.825 //y2=0.37
cc_110 ( N_noxref_1_c_110_p N_noxref_4_M2_noxref_s ) capacitor c=0.00517157f \
 //x=4.555 //y=0.755 //x2=3.825 //y2=0.37
cc_111 ( N_noxref_1_c_91_p N_noxref_4_M2_noxref_s ) capacitor c=0.0153553f \
 //x=4.71 //y=0.91 //x2=3.825 //y2=0.37
cc_112 ( N_noxref_1_c_112_p N_noxref_4_M2_noxref_s ) capacitor c=0.00629878f \
 //x=4.71 //y=1.255 //x2=3.825 //y2=0.37
cc_113 ( N_noxref_1_c_90_p N_noxref_4_M2_noxref_s ) capacitor c=0.00660494f \
 //x=4.07 //y=2.085 //x2=3.825 //y2=0.37
cc_114 ( N_noxref_1_c_1_p N_noxref_5_c_530_n ) capacitor c=0.0228479f \
 //x=1.995 //y=5.2 //x2=1.85 //y2=4.555
cc_115 ( N_noxref_1_c_63_p N_noxref_5_c_530_n ) capacitor c=0.0428886f \
 //x=2.59 //y=3.17 //x2=1.85 //y2=4.555
cc_116 ( N_noxref_1_c_3_p N_noxref_5_c_530_n ) capacitor c=0.0148501f //x=2.59 \
 //y=3.49 //x2=1.85 //y2=4.555
cc_117 ( N_noxref_1_c_27_p N_noxref_5_c_530_n ) capacitor c=0.0650546f \
 //x=2.59 //y=5.115 //x2=1.85 //y2=4.555
cc_118 ( N_noxref_1_c_97_p N_noxref_5_c_530_n ) capacitor c=0.00222924f \
 //x=4.07 //y=3.17 //x2=1.85 //y2=4.555
cc_119 ( N_noxref_1_c_5_p N_noxref_5_c_530_n ) capacitor c=0.00225537f \
 //x=4.07 //y=4.58 //x2=1.85 //y2=4.555
cc_120 ( N_noxref_1_c_49_p N_noxref_5_c_530_n ) capacitor c=6.03895e-19 \
 //x=2.59 //y=3.33 //x2=1.85 //y2=4.555
cc_121 ( N_noxref_1_c_121_p N_noxref_5_c_530_n ) capacitor c=0.00687742f \
 //x=2.75 //y=3.33 //x2=1.85 //y2=4.555
cc_122 ( N_noxref_1_c_1_p N_noxref_5_c_538_n ) capacitor c=2.77624e-19 \
 //x=1.995 //y=5.2 //x2=1.85 //y2=2.08
cc_123 ( N_noxref_1_c_63_p N_noxref_5_c_538_n ) capacitor c=0.015397f //x=2.59 \
 //y=3.17 //x2=1.85 //y2=2.08
cc_124 ( N_noxref_1_c_63_p N_noxref_5_c_540_n ) capacitor c=0.00335761f \
 //x=2.59 //y=3.17 //x2=1.85 //y2=2.08
cc_125 ( N_noxref_1_c_1_p N_noxref_5_c_541_n ) capacitor c=0.00469257f \
 //x=1.995 //y=5.2 //x2=1.88 //y2=4.7
cc_126 ( N_noxref_1_c_27_p N_noxref_5_c_541_n ) capacitor c=7.76118e-19 \
 //x=2.59 //y=5.115 //x2=1.88 //y2=4.7
cc_127 ( N_noxref_1_c_1_p N_noxref_5_M5_noxref_g ) capacitor c=0.00842859f \
 //x=1.995 //y=5.2 //x2=1.89 //y2=6.02
cc_128 ( N_noxref_1_c_7_p N_noxref_5_M5_noxref_g ) capacitor c=0.00192712f \
 //x=2.11 //y=5.2 //x2=1.89 //y2=6.02
cc_129 ( N_noxref_1_c_10_p N_noxref_5_M5_noxref_g ) capacitor c=0.0178987f \
 //x=2.11 //y=5.38 //x2=1.89 //y2=6.02
cc_130 ( N_noxref_1_c_2_p N_noxref_5_M6_noxref_g ) capacitor c=0.0115937f \
 //x=2.505 //y=5.2 //x2=2.33 //y2=6.02
cc_131 ( N_noxref_1_c_7_p N_noxref_5_M6_noxref_g ) capacitor c=0.00291595f \
 //x=2.11 //y=5.2 //x2=2.33 //y2=6.02
cc_132 ( N_noxref_1_c_10_p N_noxref_5_M6_noxref_g ) capacitor c=0.0178506f \
 //x=2.11 //y=5.38 //x2=2.33 //y2=6.02
cc_133 ( N_noxref_1_c_77_p N_noxref_5_c_549_n ) capacitor c=0.00120406f \
 //x=2.15 //y=1 //x2=1.885 //y2=0.905
cc_134 ( N_noxref_1_M1_noxref_d N_noxref_5_c_549_n ) capacitor c=0.00137165f \
 //x=1.96 //y=0.905 //x2=1.885 //y2=0.905
cc_135 ( N_noxref_1_c_95_p N_noxref_5_c_551_n ) capacitor c=0.00127432f \
 //x=2.15 //y=1.57 //x2=1.885 //y2=1.25
cc_136 ( N_noxref_1_c_77_p N_noxref_5_c_551_n ) capacitor c=0.00220847f \
 //x=2.15 //y=1 //x2=1.885 //y2=1.25
cc_137 ( N_noxref_1_M1_noxref_d N_noxref_5_c_551_n ) capacitor c=0.00237422f \
 //x=1.96 //y=0.905 //x2=1.885 //y2=1.25
cc_138 ( N_noxref_1_c_95_p N_noxref_5_c_554_n ) capacitor c=0.00454577f \
 //x=2.15 //y=1.57 //x2=1.885 //y2=1.56
cc_139 ( N_noxref_1_c_27_p N_noxref_5_c_555_n ) capacitor c=0.00874009f \
 //x=2.59 //y=5.115 //x2=2.255 //y2=4.79
cc_140 ( N_noxref_1_c_7_p N_noxref_5_c_555_n ) capacitor c=0.0020909f //x=2.11 \
 //y=5.2 //x2=2.255 //y2=4.79
cc_141 ( N_noxref_1_c_10_p N_noxref_5_c_555_n ) capacitor c=0.00291714f \
 //x=2.11 //y=5.38 //x2=2.255 //y2=4.79
cc_142 ( N_noxref_1_c_77_p N_noxref_5_c_558_n ) capacitor c=5.50523e-19 \
 //x=2.15 //y=1 //x2=2.26 //y2=0.75
cc_143 ( N_noxref_1_M1_noxref_d N_noxref_5_c_558_n ) capacitor c=0.0020782f \
 //x=1.96 //y=0.905 //x2=2.26 //y2=0.75
cc_144 ( N_noxref_1_c_95_p N_noxref_5_c_560_n ) capacitor c=0.00910917f \
 //x=2.15 //y=1.57 //x2=2.26 //y2=1.405
cc_145 ( N_noxref_1_c_74_p N_noxref_5_c_560_n ) capacitor c=0.00194324f \
 //x=2.505 //y=1.655 //x2=2.26 //y2=1.405
cc_146 ( N_noxref_1_c_77_p N_noxref_5_c_560_n ) capacitor c=5.67071e-19 \
 //x=2.15 //y=1 //x2=2.26 //y2=1.405
cc_147 ( N_noxref_1_M1_noxref_d N_noxref_5_c_560_n ) capacitor c=0.00356097f \
 //x=1.96 //y=0.905 //x2=2.26 //y2=1.405
cc_148 ( N_noxref_1_c_77_p N_noxref_5_c_564_n ) capacitor c=0.00109893f \
 //x=2.15 //y=1 //x2=2.415 //y2=0.905
cc_149 ( N_noxref_1_M1_noxref_d N_noxref_5_c_564_n ) capacitor c=8.50095e-19 \
 //x=1.96 //y=0.905 //x2=2.415 //y2=0.905
cc_150 ( N_noxref_1_c_95_p N_noxref_5_c_566_n ) capacitor c=0.00303393f \
 //x=2.15 //y=1.57 //x2=2.415 //y2=1.25
cc_151 ( N_noxref_1_c_74_p N_noxref_5_c_566_n ) capacitor c=0.00323005f \
 //x=2.505 //y=1.655 //x2=2.415 //y2=1.25
cc_152 ( N_noxref_1_c_77_p N_noxref_5_c_566_n ) capacitor c=0.00312043f \
 //x=2.15 //y=1 //x2=2.415 //y2=1.25
cc_153 ( N_noxref_1_M1_noxref_d N_noxref_5_c_566_n ) capacitor c=0.00237422f \
 //x=1.96 //y=0.905 //x2=2.415 //y2=1.25
cc_154 ( N_noxref_1_c_63_p N_noxref_5_c_570_n ) capacitor c=0.00285392f \
 //x=2.59 //y=3.17 //x2=1.85 //y2=2.08
cc_155 ( N_noxref_1_c_95_p N_noxref_5_c_571_n ) capacitor c=0.00371023f \
 //x=2.15 //y=1.57 //x2=1.85 //y2=1.915
cc_156 ( N_noxref_1_c_63_p N_noxref_5_c_571_n ) capacitor c=0.00341496f \
 //x=2.59 //y=3.17 //x2=1.85 //y2=1.915
cc_157 ( N_noxref_1_c_1_p N_noxref_5_c_573_n ) capacitor c=9.8107e-19 \
 //x=1.995 //y=5.2 //x2=1.88 //y2=4.7
cc_158 ( N_noxref_1_c_27_p N_noxref_5_c_573_n ) capacitor c=0.00142201f \
 //x=2.59 //y=5.115 //x2=1.88 //y2=4.7
cc_159 ( N_noxref_1_c_95_p N_noxref_6_c_634_n ) capacitor c=0.00466656f \
 //x=2.15 //y=1.57 //x2=4.44 //y2=1.755
cc_160 ( N_noxref_1_c_74_p N_noxref_6_c_634_n ) capacitor c=0.00320561f \
 //x=2.505 //y=1.655 //x2=4.44 //y2=1.755
cc_161 ( N_noxref_1_c_161_p N_noxref_6_c_634_n ) capacitor c=0.00108934f \
 //x=4.18 //y=1.255 //x2=4.44 //y2=1.755
cc_162 ( N_noxref_1_c_108_p N_noxref_6_c_634_n ) capacitor c=0.00524682f \
 //x=4.18 //y=1.565 //x2=4.44 //y2=1.755
cc_163 ( N_noxref_1_c_101_p N_noxref_6_c_634_n ) capacitor c=0.00376309f \
 //x=4.18 //y=1.92 //x2=4.44 //y2=1.755
cc_164 ( N_noxref_1_c_164_p N_noxref_6_c_634_n ) capacitor c=0.00934265f \
 //x=4.555 //y=1.41 //x2=4.44 //y2=1.755
cc_165 ( N_noxref_1_c_112_p N_noxref_6_c_634_n ) capacitor c=0.00362207f \
 //x=4.71 //y=1.255 //x2=4.44 //y2=1.755
cc_166 ( N_noxref_1_c_2_p N_noxref_6_c_641_n ) capacitor c=0.00308961f \
 //x=2.505 //y=5.2 //x2=4.445 //y2=5.24
cc_167 ( N_noxref_1_c_7_p N_noxref_6_c_641_n ) capacitor c=5.44332e-19 \
 //x=2.11 //y=5.2 //x2=4.445 //y2=5.24
cc_168 ( N_noxref_1_M7_noxref_g N_noxref_6_c_641_n ) capacitor c=0.00141266f \
 //x=4.225 //y=6.02 //x2=4.445 //y2=5.24
cc_169 ( N_noxref_1_M8_noxref_g N_noxref_6_c_641_n ) capacitor c=0.00377331f \
 //x=4.665 //y=6.02 //x2=4.445 //y2=5.24
cc_170 ( N_noxref_1_c_164_p N_noxref_6_c_645_n ) capacitor c=0.00180253f \
 //x=4.555 //y=1.41 //x2=4.725 //y2=1.84
cc_171 ( N_noxref_1_c_63_p N_noxref_6_c_646_n ) capacitor c=0.00320561f \
 //x=2.59 //y=3.17 //x2=4.525 //y2=1.84
cc_172 ( N_noxref_1_c_90_p N_noxref_6_c_646_n ) capacitor c=0.00376309f \
 //x=4.07 //y=2.085 //x2=4.525 //y2=1.84
cc_173 ( N_noxref_1_M8_noxref_g N_noxref_6_c_648_n ) capacitor c=0.00966342f \
 //x=4.665 //y=6.02 //x2=4.725 //y2=4.96
cc_174 ( N_noxref_1_c_27_p N_noxref_6_c_649_n ) capacitor c=0.00291366f \
 //x=2.59 //y=5.115 //x2=4.53 //y2=4.96
cc_175 ( N_noxref_1_M7_noxref_g N_noxref_6_c_649_n ) capacitor c=0.00427521f \
 //x=4.225 //y=6.02 //x2=4.53 //y2=4.96
cc_176 ( N_noxref_1_c_26_p N_noxref_6_c_649_n ) capacitor c=0.00262283f \
 //x=4.59 //y=4.79 //x2=4.53 //y2=4.96
cc_177 ( N_noxref_1_c_63_p N_noxref_6_c_652_n ) capacitor c=0.00269396f \
 //x=2.59 //y=3.17 //x2=4.81 //y2=4.875
cc_178 ( N_noxref_1_c_27_p N_noxref_6_c_652_n ) capacitor c=0.00275096f \
 //x=2.59 //y=5.115 //x2=4.81 //y2=4.875
cc_179 ( N_noxref_1_c_97_p N_noxref_6_c_652_n ) capacitor c=0.0423348f \
 //x=4.07 //y=3.17 //x2=4.81 //y2=4.875
cc_180 ( N_noxref_1_c_4_p N_noxref_6_c_652_n ) capacitor c=0.0147607f //x=4.07 \
 //y=3.49 //x2=4.81 //y2=4.875
cc_181 ( N_noxref_1_c_5_p N_noxref_6_c_652_n ) capacitor c=0.0572653f //x=4.07 \
 //y=4.58 //x2=4.81 //y2=4.875
cc_182 ( N_noxref_1_c_182_p N_noxref_6_c_652_n ) capacitor c=0.00540946f \
 //x=4.065 //y=3.33 //x2=4.81 //y2=4.875
cc_183 ( N_noxref_1_c_78_p N_noxref_6_c_652_n ) capacitor c=0.00825076f \
 //x=4.07 //y=2.085 //x2=4.81 //y2=4.875
cc_184 ( N_noxref_1_c_56_p N_noxref_6_c_652_n ) capacitor c=0.00684338f \
 //x=4.065 //y=3.33 //x2=4.81 //y2=4.875
cc_185 ( N_noxref_1_c_79_p N_noxref_6_c_652_n ) capacitor c=0.0023016f \
 //x=4.07 //y=2.085 //x2=4.81 //y2=4.875
cc_186 ( N_noxref_1_c_11_p N_noxref_6_c_652_n ) capacitor c=0.00250262f \
 //x=4.07 //y=4.7 //x2=4.81 //y2=4.875
cc_187 ( N_noxref_1_c_26_p N_noxref_6_c_652_n ) capacitor c=4.08297e-19 \
 //x=4.59 //y=4.79 //x2=4.81 //y2=4.875
cc_188 ( N_noxref_1_c_38_p N_noxref_6_c_652_n ) capacitor c=0.00124564f \
 //x=4.3 //y=4.79 //x2=4.81 //y2=4.875
cc_189 ( N_noxref_1_c_90_p N_noxref_6_c_652_n ) capacitor c=0.00112403f \
 //x=4.07 //y=2.085 //x2=4.81 //y2=4.875
cc_190 ( N_noxref_1_c_95_p N_noxref_6_c_665_n ) capacitor c=6.23317e-19 \
 //x=2.15 //y=1.57 //x2=4.44 //y2=1.005
cc_191 ( N_noxref_1_c_77_p N_noxref_6_c_665_n ) capacitor c=0.00598594f \
 //x=2.15 //y=1 //x2=4.44 //y2=1.005
cc_192 ( N_noxref_1_c_89_p N_noxref_6_c_665_n ) capacitor c=0.00175305f \
 //x=4.18 //y=0.91 //x2=4.44 //y2=1.005
cc_193 ( N_noxref_1_c_161_p N_noxref_6_c_665_n ) capacitor c=0.00354487f \
 //x=4.18 //y=1.255 //x2=4.44 //y2=1.005
cc_194 ( N_noxref_1_c_110_p N_noxref_6_c_665_n ) capacitor c=5.57924e-19 \
 //x=4.555 //y=0.755 //x2=4.44 //y2=1.005
cc_195 ( N_noxref_1_c_164_p N_noxref_6_c_665_n ) capacitor c=5.75878e-19 \
 //x=4.555 //y=1.41 //x2=4.44 //y2=1.005
cc_196 ( N_noxref_1_c_91_p N_noxref_6_c_665_n ) capacitor c=0.00160969f \
 //x=4.71 //y=0.91 //x2=4.44 //y2=1.005
cc_197 ( N_noxref_1_c_112_p N_noxref_6_c_665_n ) capacitor c=0.00411132f \
 //x=4.71 //y=1.255 //x2=4.44 //y2=1.005
cc_198 ( N_noxref_1_M7_noxref_g N_noxref_6_c_673_n ) capacitor c=0.0162066f \
 //x=4.225 //y=6.02 //x2=4.445 //y2=5.38
cc_199 ( N_noxref_1_M8_noxref_g N_noxref_6_c_673_n ) capacitor c=0.0162066f \
 //x=4.665 //y=6.02 //x2=4.445 //y2=5.38
cc_200 ( N_noxref_1_c_26_p N_noxref_6_c_673_n ) capacitor c=0.00290963f \
 //x=4.59 //y=4.79 //x2=4.445 //y2=5.38
cc_201 ( N_noxref_1_c_89_p N_noxref_6_M2_noxref_d ) capacitor c=0.00137914f \
 //x=4.18 //y=0.91 //x2=4.255 //y2=0.91
cc_202 ( N_noxref_1_c_161_p N_noxref_6_M2_noxref_d ) capacitor c=0.0023891f \
 //x=4.18 //y=1.255 //x2=4.255 //y2=0.91
cc_203 ( N_noxref_1_c_110_p N_noxref_6_M2_noxref_d ) capacitor c=0.0020782f \
 //x=4.555 //y=0.755 //x2=4.255 //y2=0.91
cc_204 ( N_noxref_1_c_164_p N_noxref_6_M2_noxref_d ) capacitor c=0.00356097f \
 //x=4.555 //y=1.41 //x2=4.255 //y2=0.91
cc_205 ( N_noxref_1_c_91_p N_noxref_6_M2_noxref_d ) capacitor c=0.00138452f \
 //x=4.71 //y=0.91 //x2=4.255 //y2=0.91
cc_206 ( N_noxref_1_c_112_p N_noxref_6_M2_noxref_d ) capacitor c=0.00235934f \
 //x=4.71 //y=1.255 //x2=4.255 //y2=0.91
cc_207 ( N_noxref_1_c_207_p N_noxref_7_c_714_n ) capacitor c=0.0103386f \
 //x=2.235 //y=1.655 //x2=1.665 //y2=1.495
cc_208 ( N_noxref_1_c_74_p N_noxref_7_c_715_n ) capacitor c=0.00373013f \
 //x=2.505 //y=1.655 //x2=2.55 //y2=0.53
cc_209 ( N_noxref_1_c_77_p N_noxref_7_c_715_n ) capacitor c=0.00367971f \
 //x=2.15 //y=1 //x2=2.55 //y2=0.53
cc_210 ( N_noxref_1_M1_noxref_d N_noxref_7_c_715_n ) capacitor c=0.00910163f \
 //x=1.96 //y=0.905 //x2=2.55 //y2=0.53
cc_211 ( N_noxref_1_c_95_p N_noxref_7_M0_noxref_s ) capacitor c=0.017321f \
 //x=2.15 //y=1.57 //x2=0.56 //y2=0.365
cc_212 ( N_noxref_1_c_74_p N_noxref_7_M0_noxref_s ) capacitor c=0.00640979f \
 //x=2.505 //y=1.655 //x2=0.56 //y2=0.365
cc_213 ( N_noxref_1_c_3_p N_noxref_7_M0_noxref_s ) capacitor c=4.17069e-19 \
 //x=2.59 //y=3.49 //x2=0.56 //y2=0.365
cc_214 ( N_noxref_1_c_77_p N_noxref_7_M0_noxref_s ) capacitor c=0.0090315f \
 //x=2.15 //y=1 //x2=0.56 //y2=0.365
cc_215 ( N_noxref_1_c_49_p N_noxref_7_M0_noxref_s ) capacitor c=0.0010514f \
 //x=2.59 //y=3.33 //x2=0.56 //y2=0.365
cc_216 ( N_noxref_1_M1_noxref_d N_noxref_7_M0_noxref_s ) capacitor \
 c=0.0275552f //x=1.96 //y=0.905 //x2=0.56 //y2=0.365
cc_217 ( N_noxref_2_c_217_n N_noxref_3_c_316_n ) capacitor c=9.05427e-19 \
 //x=5.18 //y=7.4 //x2=1.11 //y2=4.7
cc_218 ( N_noxref_2_c_228_n N_noxref_3_c_316_n ) capacitor c=6.28732e-19 \
 //x=1.585 //y=7.4 //x2=1.11 //y2=4.7
cc_219 ( N_noxref_2_c_243_n N_noxref_3_c_316_n ) capacitor c=0.00867681f \
 //x=0.74 //y=7.4 //x2=1.11 //y2=4.7
cc_220 ( N_noxref_2_c_243_n N_noxref_3_c_318_n ) capacitor c=0.0104242f \
 //x=0.74 //y=7.4 //x2=1.112 //y2=4.56
cc_221 ( N_noxref_2_c_217_n N_noxref_3_c_320_n ) capacitor c=6.23118e-19 \
 //x=5.18 //y=7.4 //x2=1.11 //y2=4.7
cc_222 ( N_noxref_2_c_243_n N_noxref_3_c_320_n ) capacitor c=0.00370735f \
 //x=0.74 //y=7.4 //x2=1.11 //y2=4.7
cc_223 ( N_noxref_2_c_228_n N_noxref_3_M3_noxref_g ) capacitor c=0.0072715f \
 //x=1.585 //y=7.4 //x2=1.01 //y2=6.02
cc_224 ( N_noxref_2_M3_noxref_s N_noxref_3_M3_noxref_g ) capacitor \
 c=0.0567929f //x=0.655 //y=5.02 //x2=1.01 //y2=6.02
cc_225 ( N_noxref_2_c_228_n N_noxref_3_M4_noxref_g ) capacitor c=0.00749619f \
 //x=1.585 //y=7.4 //x2=1.45 //y2=6.02
cc_226 ( N_noxref_2_M4_noxref_d N_noxref_3_M4_noxref_g ) capacitor c=0.015318f \
 //x=1.525 //y=5.02 //x2=1.45 //y2=6.02
cc_227 ( N_noxref_2_c_243_n N_noxref_3_c_327_n ) capacitor c=0.0234764f \
 //x=0.74 //y=7.4 //x2=1.11 //y2=4.7
cc_228 ( N_noxref_2_c_243_n N_noxref_4_c_424_n ) capacitor c=0.00989031f \
 //x=0.74 //y=7.4 //x2=0.74 //y2=0
cc_229 ( N_noxref_2_c_239_n N_noxref_4_c_430_n ) capacitor c=0.00989031f \
 //x=5.18 //y=7.4 //x2=5.18 //y2=0
cc_230 ( N_noxref_2_c_246_n N_noxref_4_c_433_n ) capacitor c=0.00912128f \
 //x=3.33 //y=7.4 //x2=3.33 //y2=0
cc_231 ( N_noxref_2_c_246_n N_noxref_5_c_541_n ) capacitor c=0.00226427f \
 //x=3.33 //y=7.4 //x2=1.88 //y2=4.7
cc_232 ( N_noxref_2_c_231_n N_noxref_5_M5_noxref_g ) capacitor c=0.00692597f \
 //x=2.465 //y=7.4 //x2=1.89 //y2=6.02
cc_233 ( N_noxref_2_M4_noxref_d N_noxref_5_M5_noxref_g ) capacitor c=0.015318f \
 //x=1.525 //y=5.02 //x2=1.89 //y2=6.02
cc_234 ( N_noxref_2_c_231_n N_noxref_5_M6_noxref_g ) capacitor c=0.00749619f \
 //x=2.465 //y=7.4 //x2=2.33 //y2=6.02
cc_235 ( N_noxref_2_M6_noxref_d N_noxref_5_M6_noxref_g ) capacitor \
 c=0.0430452f //x=2.405 //y=5.02 //x2=2.33 //y2=6.02
cc_236 ( N_noxref_2_c_246_n N_noxref_5_c_555_n ) capacitor c=0.0129375f \
 //x=3.33 //y=7.4 //x2=2.255 //y2=4.79
cc_237 ( N_noxref_2_c_246_n N_noxref_5_c_573_n ) capacitor c=2.73429e-19 \
 //x=3.33 //y=7.4 //x2=1.88 //y2=4.7
cc_238 ( N_noxref_2_M4_noxref_d N_noxref_5_c_573_n ) capacitor c=3.32274e-19 \
 //x=1.525 //y=5.02 //x2=1.88 //y2=4.7
cc_239 ( N_noxref_2_c_217_n N_noxref_6_c_641_n ) capacitor c=0.00259275f \
 //x=5.18 //y=7.4 //x2=4.445 //y2=5.24
cc_240 ( N_noxref_2_c_236_n N_noxref_6_c_641_n ) capacitor c=0.0010065f \
 //x=4.8 //y=7.4 //x2=4.445 //y2=5.24
cc_241 ( N_noxref_2_c_239_n N_noxref_6_c_641_n ) capacitor c=0.00295945f \
 //x=5.18 //y=7.4 //x2=4.445 //y2=5.24
cc_242 ( N_noxref_2_M3_noxref_s N_noxref_6_c_641_n ) capacitor c=2.62188e-19 \
 //x=0.655 //y=5.02 //x2=4.445 //y2=5.24
cc_243 ( N_noxref_2_M7_noxref_s N_noxref_6_c_641_n ) capacitor c=0.0465774f \
 //x=3.87 //y=5.02 //x2=4.445 //y2=5.24
cc_244 ( N_noxref_2_M8_noxref_d N_noxref_6_c_641_n ) capacitor c=0.0486749f \
 //x=4.74 //y=5.02 //x2=4.445 //y2=5.24
cc_245 ( N_noxref_2_c_217_n N_noxref_6_c_648_n ) capacitor c=0.00199455f \
 //x=5.18 //y=7.4 //x2=4.725 //y2=4.96
cc_246 ( N_noxref_2_c_236_n N_noxref_6_c_648_n ) capacitor c=0.00207359f \
 //x=4.8 //y=7.4 //x2=4.725 //y2=4.96
cc_247 ( N_noxref_2_M8_noxref_d N_noxref_6_c_648_n ) capacitor c=0.0235605f \
 //x=4.74 //y=5.02 //x2=4.725 //y2=4.96
cc_248 ( N_noxref_2_c_246_n N_noxref_6_c_649_n ) capacitor c=0.00464635f \
 //x=3.33 //y=7.4 //x2=4.53 //y2=4.96
cc_249 ( N_noxref_2_c_239_n N_noxref_6_c_652_n ) capacitor c=0.0297606f \
 //x=5.18 //y=7.4 //x2=4.81 //y2=4.875
cc_250 ( N_noxref_2_c_217_n N_noxref_6_c_673_n ) capacitor c=0.0024144f \
 //x=5.18 //y=7.4 //x2=4.445 //y2=5.38
cc_251 ( N_noxref_2_c_236_n N_noxref_6_c_673_n ) capacitor c=0.0137788f \
 //x=4.8 //y=7.4 //x2=4.445 //y2=5.38
cc_252 ( N_noxref_2_c_239_n N_noxref_6_c_673_n ) capacitor c=0.00961566f \
 //x=5.18 //y=7.4 //x2=4.445 //y2=5.38
cc_253 ( N_noxref_2_c_246_n N_noxref_6_c_673_n ) capacitor c=0.00821941f \
 //x=3.33 //y=7.4 //x2=4.445 //y2=5.38
cc_254 ( N_noxref_2_M7_noxref_s N_noxref_6_c_673_n ) capacitor c=0.0900053f \
 //x=3.87 //y=5.02 //x2=4.445 //y2=5.38
cc_255 ( N_noxref_2_M8_noxref_d N_noxref_6_c_673_n ) capacitor c=0.0930425f \
 //x=4.74 //y=5.02 //x2=4.445 //y2=5.38
cc_256 ( N_noxref_3_c_340_p N_noxref_4_c_455_n ) capacitor c=6.60635e-19 \
 //x=1.11 //y=2.08 //x2=1.095 //y2=0
cc_257 ( N_noxref_3_c_340_p N_noxref_4_c_419_n ) capacitor c=0.00709452f \
 //x=1.11 //y=2.08 //x2=1.18 //y2=0.955
cc_258 ( N_noxref_3_c_342_p N_noxref_4_c_419_n ) capacitor c=2.13705e-19 \
 //x=1.11 //y=2.08 //x2=1.18 //y2=0.955
cc_259 ( N_noxref_3_c_343_p N_noxref_4_c_419_n ) capacitor c=0.00156094f \
 //x=0.915 //y=0.865 //x2=1.18 //y2=0.955
cc_260 ( N_noxref_3_c_344_p N_noxref_4_c_419_n ) capacitor c=0.00413828f \
 //x=0.915 //y=1.21 //x2=1.18 //y2=0.955
cc_261 ( N_noxref_3_c_345_p N_noxref_4_c_419_n ) capacitor c=4.2764e-19 \
 //x=0.915 //y=1.52 //x2=1.18 //y2=0.955
cc_262 ( N_noxref_3_c_346_p N_noxref_4_c_419_n ) capacitor c=5.3458e-19 \
 //x=1.29 //y=0.71 //x2=1.18 //y2=0.955
cc_263 ( N_noxref_3_c_347_p N_noxref_4_c_419_n ) capacitor c=6.38426e-19 \
 //x=1.29 //y=1.365 //x2=1.18 //y2=0.955
cc_264 ( N_noxref_3_c_348_p N_noxref_4_c_419_n ) capacitor c=0.00158609f \
 //x=1.445 //y=0.865 //x2=1.18 //y2=0.955
cc_265 ( N_noxref_3_c_349_p N_noxref_4_c_419_n ) capacitor c=0.00296337f \
 //x=1.445 //y=1.21 //x2=1.18 //y2=0.955
cc_266 ( N_noxref_3_c_343_p N_noxref_4_c_465_n ) capacitor c=3.51399e-19 \
 //x=0.915 //y=0.865 //x2=1.177 //y2=0.825
cc_267 ( N_noxref_3_c_346_p N_noxref_4_c_465_n ) capacitor c=0.00864436f \
 //x=1.29 //y=0.71 //x2=1.177 //y2=0.825
cc_268 ( N_noxref_3_c_348_p N_noxref_4_c_465_n ) capacitor c=4.45447e-19 \
 //x=1.445 //y=0.865 //x2=1.177 //y2=0.825
cc_269 ( N_noxref_3_c_343_p N_noxref_4_c_422_n ) capacitor c=0.0069219f \
 //x=0.915 //y=0.865 //x2=3.16 //y2=0
cc_270 ( N_noxref_3_c_340_p N_noxref_4_c_424_n ) capacitor c=0.0082376f \
 //x=1.11 //y=2.08 //x2=0.74 //y2=0
cc_271 ( N_noxref_3_c_318_n N_noxref_4_c_424_n ) capacitor c=0.0117984f \
 //x=1.112 //y=4.56 //x2=0.74 //y2=0
cc_272 ( N_noxref_3_c_342_p N_noxref_4_c_424_n ) capacitor c=0.00369668f \
 //x=1.11 //y=2.08 //x2=0.74 //y2=0
cc_273 ( N_noxref_3_c_345_p N_noxref_4_c_424_n ) capacitor c=0.0015404f \
 //x=0.915 //y=1.52 //x2=0.74 //y2=0
cc_274 ( N_noxref_3_c_358_p N_noxref_4_c_424_n ) capacitor c=0.00950704f \
 //x=0.915 //y=1.915 //x2=0.74 //y2=0
cc_275 ( N_noxref_3_c_340_p N_noxref_4_M0_noxref_d ) capacitor c=2.20438e-19 \
 //x=1.11 //y=2.08 //x2=0.99 //y2=0.865
cc_276 ( N_noxref_3_c_343_p N_noxref_4_M0_noxref_d ) capacitor c=0.00192399f \
 //x=0.915 //y=0.865 //x2=0.99 //y2=0.865
cc_277 ( N_noxref_3_c_344_p N_noxref_4_M0_noxref_d ) capacitor c=0.00210798f \
 //x=0.915 //y=1.21 //x2=0.99 //y2=0.865
cc_278 ( N_noxref_3_c_346_p N_noxref_4_M0_noxref_d ) capacitor c=0.00472259f \
 //x=1.29 //y=0.71 //x2=0.99 //y2=0.865
cc_279 ( N_noxref_3_c_347_p N_noxref_4_M0_noxref_d ) capacitor c=0.00166857f \
 //x=1.29 //y=1.365 //x2=0.99 //y2=0.865
cc_280 ( N_noxref_3_c_348_p N_noxref_4_M0_noxref_d ) capacitor c=0.00230174f \
 //x=1.445 //y=0.865 //x2=0.99 //y2=0.865
cc_281 ( N_noxref_3_c_349_p N_noxref_4_M0_noxref_d ) capacitor c=0.00210798f \
 //x=1.445 //y=1.21 //x2=0.99 //y2=0.865
cc_282 ( N_noxref_3_c_316_n N_noxref_5_c_530_n ) capacitor c=0.0172958f \
 //x=1.11 //y=4.7 //x2=1.85 //y2=4.555
cc_283 ( N_noxref_3_c_318_n N_noxref_5_c_530_n ) capacitor c=0.108557f \
 //x=1.112 //y=4.56 //x2=1.85 //y2=4.555
cc_284 ( N_noxref_3_c_342_p N_noxref_5_c_530_n ) capacitor c=3.49899e-19 \
 //x=1.11 //y=2.08 //x2=1.85 //y2=4.555
cc_285 ( N_noxref_3_c_320_n N_noxref_5_c_530_n ) capacitor c=7.76143e-19 \
 //x=1.11 //y=4.7 //x2=1.85 //y2=4.555
cc_286 ( N_noxref_3_c_327_n N_noxref_5_c_530_n ) capacitor c=0.00201171f \
 //x=1.11 //y=4.7 //x2=1.85 //y2=4.555
cc_287 ( N_noxref_3_c_340_p N_noxref_5_c_538_n ) capacitor c=0.0205342f \
 //x=1.11 //y=2.08 //x2=1.85 //y2=2.08
cc_288 ( N_noxref_3_c_342_p N_noxref_5_c_538_n ) capacitor c=5.16867e-19 \
 //x=1.11 //y=2.08 //x2=1.85 //y2=2.08
cc_289 ( N_noxref_3_c_358_p N_noxref_5_c_538_n ) capacitor c=0.00167888f \
 //x=0.915 //y=1.915 //x2=1.85 //y2=2.08
cc_290 ( N_noxref_3_c_340_p N_noxref_5_c_540_n ) capacitor c=0.00370824f \
 //x=1.11 //y=2.08 //x2=1.85 //y2=2.08
cc_291 ( N_noxref_3_c_318_n N_noxref_5_c_540_n ) capacitor c=3.49899e-19 \
 //x=1.112 //y=4.56 //x2=1.85 //y2=2.08
cc_292 ( N_noxref_3_c_342_p N_noxref_5_c_540_n ) capacitor c=0.00445529f \
 //x=1.11 //y=2.08 //x2=1.85 //y2=2.08
cc_293 ( N_noxref_3_c_358_p N_noxref_5_c_540_n ) capacitor c=0.00267961f \
 //x=0.915 //y=1.915 //x2=1.85 //y2=2.08
cc_294 ( N_noxref_3_c_316_n N_noxref_5_c_541_n ) capacitor c=0.00389736f \
 //x=1.11 //y=4.7 //x2=1.88 //y2=4.7
cc_295 ( N_noxref_3_c_318_n N_noxref_5_c_541_n ) capacitor c=2.1563e-19 \
 //x=1.112 //y=4.56 //x2=1.88 //y2=4.7
cc_296 ( N_noxref_3_c_320_n N_noxref_5_c_541_n ) capacitor c=0.00397338f \
 //x=1.11 //y=4.7 //x2=1.88 //y2=4.7
cc_297 ( N_noxref_3_c_327_n N_noxref_5_c_541_n ) capacitor c=0.00283894f \
 //x=1.11 //y=4.7 //x2=1.88 //y2=4.7
cc_298 ( N_noxref_3_M3_noxref_g N_noxref_5_M5_noxref_g ) capacitor \
 c=0.0104892f //x=1.01 //y=6.02 //x2=1.89 //y2=6.02
cc_299 ( N_noxref_3_M4_noxref_g N_noxref_5_M5_noxref_g ) capacitor c=0.107636f \
 //x=1.45 //y=6.02 //x2=1.89 //y2=6.02
cc_300 ( N_noxref_3_M4_noxref_g N_noxref_5_M6_noxref_g ) capacitor \
 c=0.0100341f //x=1.45 //y=6.02 //x2=2.33 //y2=6.02
cc_301 ( N_noxref_3_c_343_p N_noxref_5_c_549_n ) capacitor c=4.86545e-19 \
 //x=0.915 //y=0.865 //x2=1.885 //y2=0.905
cc_302 ( N_noxref_3_c_344_p N_noxref_5_c_549_n ) capacitor c=0.00152405f \
 //x=0.915 //y=1.21 //x2=1.885 //y2=0.905
cc_303 ( N_noxref_3_c_348_p N_noxref_5_c_549_n ) capacitor c=0.0151475f \
 //x=1.445 //y=0.865 //x2=1.885 //y2=0.905
cc_304 ( N_noxref_3_c_345_p N_noxref_5_c_551_n ) capacitor c=0.00109982f \
 //x=0.915 //y=1.52 //x2=1.885 //y2=1.25
cc_305 ( N_noxref_3_c_349_p N_noxref_5_c_551_n ) capacitor c=0.0111064f \
 //x=1.445 //y=1.21 //x2=1.885 //y2=1.25
cc_306 ( N_noxref_3_c_345_p N_noxref_5_c_554_n ) capacitor c=9.58243e-19 \
 //x=0.915 //y=1.52 //x2=1.885 //y2=1.56
cc_307 ( N_noxref_3_c_358_p N_noxref_5_c_554_n ) capacitor c=0.00662747f \
 //x=0.915 //y=1.915 //x2=1.885 //y2=1.56
cc_308 ( N_noxref_3_c_349_p N_noxref_5_c_554_n ) capacitor c=0.00862358f \
 //x=1.445 //y=1.21 //x2=1.885 //y2=1.56
cc_309 ( N_noxref_3_c_348_p N_noxref_5_c_564_n ) capacitor c=0.00127211f \
 //x=1.445 //y=0.865 //x2=2.415 //y2=0.905
cc_310 ( N_noxref_3_c_349_p N_noxref_5_c_566_n ) capacitor c=0.00204774f \
 //x=1.445 //y=1.21 //x2=2.415 //y2=1.25
cc_311 ( N_noxref_3_c_340_p N_noxref_5_c_570_n ) capacitor c=0.00167305f \
 //x=1.11 //y=2.08 //x2=1.85 //y2=2.08
cc_312 ( N_noxref_3_c_342_p N_noxref_5_c_570_n ) capacitor c=0.00266443f \
 //x=1.11 //y=2.08 //x2=1.85 //y2=2.08
cc_313 ( N_noxref_3_c_358_p N_noxref_5_c_570_n ) capacitor c=0.0181449f \
 //x=0.915 //y=1.915 //x2=1.85 //y2=2.08
cc_314 ( N_noxref_3_c_316_n N_noxref_5_c_573_n ) capacitor c=0.00158715f \
 //x=1.11 //y=4.7 //x2=1.88 //y2=4.7
cc_315 ( N_noxref_3_c_320_n N_noxref_5_c_573_n ) capacitor c=0.00237977f \
 //x=1.11 //y=4.7 //x2=1.88 //y2=4.7
cc_316 ( N_noxref_3_c_327_n N_noxref_5_c_573_n ) capacitor c=0.0297875f \
 //x=1.11 //y=4.7 //x2=1.88 //y2=4.7
cc_317 ( N_noxref_3_c_358_p N_noxref_7_c_724_n ) capacitor c=0.00262672f \
 //x=0.915 //y=1.915 //x2=0.695 //y2=1.495
cc_318 ( N_noxref_3_c_340_p N_noxref_7_c_725_n ) capacitor c=0.00459552f \
 //x=1.11 //y=2.08 //x2=1.58 //y2=1.58
cc_319 ( N_noxref_3_c_342_p N_noxref_7_c_725_n ) capacitor c=0.00763108f \
 //x=1.11 //y=2.08 //x2=1.58 //y2=1.58
cc_320 ( N_noxref_3_c_345_p N_noxref_7_c_725_n ) capacitor c=0.00695869f \
 //x=0.915 //y=1.52 //x2=1.58 //y2=1.58
cc_321 ( N_noxref_3_c_358_p N_noxref_7_c_725_n ) capacitor c=0.0194861f \
 //x=0.915 //y=1.915 //x2=1.58 //y2=1.58
cc_322 ( N_noxref_3_c_347_p N_noxref_7_c_725_n ) capacitor c=0.00723574f \
 //x=1.29 //y=1.365 //x2=1.58 //y2=1.58
cc_323 ( N_noxref_3_c_349_p N_noxref_7_c_725_n ) capacitor c=0.00339872f \
 //x=1.445 //y=1.21 //x2=1.58 //y2=1.58
cc_324 ( N_noxref_3_c_358_p N_noxref_7_c_714_n ) capacitor c=6.71402e-19 \
 //x=0.915 //y=1.915 //x2=1.665 //y2=1.495
cc_325 ( N_noxref_3_c_343_p N_noxref_7_M0_noxref_s ) capacitor c=0.0294925f \
 //x=0.915 //y=0.865 //x2=0.56 //y2=0.365
cc_326 ( N_noxref_3_c_345_p N_noxref_7_M0_noxref_s ) capacitor c=3.48408e-19 \
 //x=0.915 //y=1.52 //x2=0.56 //y2=0.365
cc_327 ( N_noxref_3_c_348_p N_noxref_7_M0_noxref_s ) capacitor c=0.0125442f \
 //x=1.445 //y=0.865 //x2=0.56 //y2=0.365
cc_328 ( N_noxref_4_c_412_n N_noxref_5_c_538_n ) capacitor c=0.00234099f \
 //x=5.18 //y=0 //x2=1.85 //y2=2.08
cc_329 ( N_noxref_4_c_422_n N_noxref_5_c_538_n ) capacitor c=3.77673e-19 \
 //x=3.16 //y=0 //x2=1.85 //y2=2.08
cc_330 ( N_noxref_4_c_433_n N_noxref_5_c_540_n ) capacitor c=0.00224736f \
 //x=3.33 //y=0 //x2=1.85 //y2=2.08
cc_331 ( N_noxref_4_c_433_n N_noxref_5_c_566_n ) capacitor c=0.00275184f \
 //x=3.33 //y=0 //x2=2.415 //y2=1.25
cc_332 ( N_noxref_4_c_433_n N_noxref_5_c_570_n ) capacitor c=2.63786e-19 \
 //x=3.33 //y=0 //x2=1.85 //y2=2.08
cc_333 ( N_noxref_4_c_430_n N_noxref_6_c_634_n ) capacitor c=0.00122336f \
 //x=5.18 //y=0 //x2=4.44 //y2=1.755
cc_334 ( N_noxref_4_c_433_n N_noxref_6_c_634_n ) capacitor c=0.00272952f \
 //x=3.33 //y=0 //x2=4.44 //y2=1.755
cc_335 ( N_noxref_4_M2_noxref_s N_noxref_6_c_634_n ) capacitor c=0.0325324f \
 //x=3.825 //y=0.37 //x2=4.44 //y2=1.755
cc_336 ( N_noxref_4_c_412_n N_noxref_6_c_645_n ) capacitor c=0.00496359f \
 //x=5.18 //y=0 //x2=4.725 //y2=1.84
cc_337 ( N_noxref_4_c_429_n N_noxref_6_c_645_n ) capacitor c=0.00321677f \
 //x=4.845 //y=0.535 //x2=4.725 //y2=1.84
cc_338 ( N_noxref_4_c_430_n N_noxref_6_c_645_n ) capacitor c=0.030726f \
 //x=5.18 //y=0 //x2=4.725 //y2=1.84
cc_339 ( N_noxref_4_M2_noxref_s N_noxref_6_c_645_n ) capacitor c=0.00565313f \
 //x=3.825 //y=0.37 //x2=4.725 //y2=1.84
cc_340 ( N_noxref_4_c_412_n N_noxref_6_c_665_n ) capacitor c=0.00996824f \
 //x=5.18 //y=0 //x2=4.44 //y2=1.005
cc_341 ( N_noxref_4_c_425_n N_noxref_6_c_665_n ) capacitor c=0.00124697f \
 //x=4.355 //y=0.535 //x2=4.44 //y2=1.005
cc_342 ( N_noxref_4_c_429_n N_noxref_6_c_665_n ) capacitor c=0.00130436f \
 //x=4.845 //y=0.535 //x2=4.44 //y2=1.005
cc_343 ( N_noxref_4_c_430_n N_noxref_6_c_665_n ) capacitor c=2.8029e-19 \
 //x=5.18 //y=0 //x2=4.44 //y2=1.005
cc_344 ( N_noxref_4_M2_noxref_s N_noxref_6_c_665_n ) capacitor c=0.0156205f \
 //x=3.825 //y=0.37 //x2=4.44 //y2=1.005
cc_345 ( N_noxref_4_c_412_n N_noxref_6_M2_noxref_d ) capacitor c=0.00119583f \
 //x=5.18 //y=0 //x2=4.255 //y2=0.91
cc_346 ( N_noxref_4_c_430_n N_noxref_6_M2_noxref_d ) capacitor c=2.70835e-19 \
 //x=5.18 //y=0 //x2=4.255 //y2=0.91
cc_347 ( N_noxref_4_M2_noxref_s N_noxref_6_M2_noxref_d ) capacitor \
 c=0.0377604f //x=3.825 //y=0.37 //x2=4.255 //y2=0.91
cc_348 ( N_noxref_4_c_455_n N_noxref_7_c_725_n ) capacitor c=0.00275882f \
 //x=1.095 //y=0 //x2=1.58 //y2=1.58
cc_349 ( N_noxref_4_c_412_n N_noxref_7_c_725_n ) capacitor c=0.00203715f \
 //x=5.18 //y=0 //x2=1.58 //y2=1.58
cc_350 ( N_noxref_4_c_419_n N_noxref_7_c_725_n ) capacitor c=0.00407704f \
 //x=1.18 //y=0.955 //x2=1.58 //y2=1.58
cc_351 ( N_noxref_4_c_422_n N_noxref_7_c_725_n ) capacitor c=0.00369095f \
 //x=3.16 //y=0 //x2=1.58 //y2=1.58
cc_352 ( N_noxref_4_M0_noxref_d N_noxref_7_c_725_n ) capacitor c=0.00578453f \
 //x=0.99 //y=0.865 //x2=1.58 //y2=1.58
cc_353 ( N_noxref_4_c_412_n N_noxref_7_c_740_n ) capacitor c=0.00681952f \
 //x=5.18 //y=0 //x2=1.665 //y2=0.615
cc_354 ( N_noxref_4_c_465_n N_noxref_7_c_740_n ) capacitor c=0.0167642f \
 //x=1.177 //y=0.825 //x2=1.665 //y2=0.615
cc_355 ( N_noxref_4_c_422_n N_noxref_7_c_740_n ) capacitor c=0.0146219f \
 //x=3.16 //y=0 //x2=1.665 //y2=0.615
cc_356 ( N_noxref_4_c_424_n N_noxref_7_c_740_n ) capacitor c=0.00283128f \
 //x=0.74 //y=0 //x2=1.665 //y2=0.615
cc_357 ( N_noxref_4_c_430_n N_noxref_7_c_740_n ) capacitor c=0.00145873f \
 //x=5.18 //y=0 //x2=1.665 //y2=0.615
cc_358 ( N_noxref_4_c_433_n N_noxref_7_c_740_n ) capacitor c=2.21767e-19 \
 //x=3.33 //y=0 //x2=1.665 //y2=0.615
cc_359 ( N_noxref_4_c_424_n N_noxref_7_c_714_n ) capacitor c=2.85935e-19 \
 //x=0.74 //y=0 //x2=1.665 //y2=1.495
cc_360 ( N_noxref_4_c_412_n N_noxref_7_c_715_n ) capacitor c=0.0100493f \
 //x=5.18 //y=0 //x2=2.55 //y2=0.53
cc_361 ( N_noxref_4_c_422_n N_noxref_7_c_715_n ) capacitor c=0.0374392f \
 //x=3.16 //y=0 //x2=2.55 //y2=0.53
cc_362 ( N_noxref_4_c_430_n N_noxref_7_c_715_n ) capacitor c=0.00198448f \
 //x=5.18 //y=0 //x2=2.55 //y2=0.53
cc_363 ( N_noxref_4_c_412_n N_noxref_7_c_750_n ) capacitor c=0.00250835f \
 //x=5.18 //y=0 //x2=2.635 //y2=0.615
cc_364 ( N_noxref_4_c_422_n N_noxref_7_c_750_n ) capacitor c=0.0145577f \
 //x=3.16 //y=0 //x2=2.635 //y2=0.615
cc_365 ( N_noxref_4_c_518_p N_noxref_7_c_750_n ) capacitor c=0.00209572f \
 //x=3.96 //y=0.45 //x2=2.635 //y2=0.615
cc_366 ( N_noxref_4_c_430_n N_noxref_7_c_750_n ) capacitor c=0.00145015f \
 //x=5.18 //y=0 //x2=2.635 //y2=0.615
cc_367 ( N_noxref_4_c_433_n N_noxref_7_c_750_n ) capacitor c=0.0402083f \
 //x=3.33 //y=0 //x2=2.635 //y2=0.615
cc_368 ( N_noxref_4_c_455_n N_noxref_7_M0_noxref_s ) capacitor c=0.00723598f \
 //x=1.095 //y=0 //x2=0.56 //y2=0.365
cc_369 ( N_noxref_4_c_419_n N_noxref_7_M0_noxref_s ) capacitor c=0.011456f \
 //x=1.18 //y=0.955 //x2=0.56 //y2=0.365
cc_370 ( N_noxref_4_c_465_n N_noxref_7_M0_noxref_s ) capacitor c=0.0173062f \
 //x=1.177 //y=0.825 //x2=0.56 //y2=0.365
cc_371 ( N_noxref_4_c_422_n N_noxref_7_M0_noxref_s ) capacitor c=0.0146208f \
 //x=3.16 //y=0 //x2=0.56 //y2=0.365
cc_372 ( N_noxref_4_c_424_n N_noxref_7_M0_noxref_s ) capacitor c=0.0559891f \
 //x=0.74 //y=0 //x2=0.56 //y2=0.365
cc_373 ( N_noxref_4_c_430_n N_noxref_7_M0_noxref_s ) capacitor c=0.00145873f \
 //x=5.18 //y=0 //x2=0.56 //y2=0.365
cc_374 ( N_noxref_4_c_433_n N_noxref_7_M0_noxref_s ) capacitor c=0.00642652f \
 //x=3.33 //y=0 //x2=0.56 //y2=0.365
cc_375 ( N_noxref_4_M0_noxref_d N_noxref_7_M0_noxref_s ) capacitor \
 c=0.0271276f //x=0.99 //y=0.865 //x2=0.56 //y2=0.365
cc_376 ( N_noxref_4_M2_noxref_s N_noxref_7_M0_noxref_s ) capacitor \
 c=0.0031675f //x=3.825 //y=0.37 //x2=0.56 //y2=0.365
cc_377 ( N_noxref_5_c_538_n N_noxref_7_c_714_n ) capacitor c=7.471e-19 \
 //x=1.85 //y=2.08 //x2=1.665 //y2=1.495
cc_378 ( N_noxref_5_c_554_n N_noxref_7_c_714_n ) capacitor c=0.00888238f \
 //x=1.885 //y=1.56 //x2=1.665 //y2=1.495
cc_379 ( N_noxref_5_c_570_n N_noxref_7_c_714_n ) capacitor c=0.00173073f \
 //x=1.85 //y=2.08 //x2=1.665 //y2=1.495
cc_380 ( N_noxref_5_c_538_n N_noxref_7_c_715_n ) capacitor c=0.00141156f \
 //x=1.85 //y=2.08 //x2=2.55 //y2=0.53
cc_381 ( N_noxref_5_c_540_n N_noxref_7_c_715_n ) capacitor c=8.82141e-19 \
 //x=1.85 //y=2.08 //x2=2.55 //y2=0.53
cc_382 ( N_noxref_5_c_549_n N_noxref_7_c_715_n ) capacitor c=0.0199501f \
 //x=1.885 //y=0.905 //x2=2.55 //y2=0.53
cc_383 ( N_noxref_5_c_564_n N_noxref_7_c_715_n ) capacitor c=0.00825432f \
 //x=2.415 //y=0.905 //x2=2.55 //y2=0.53
cc_384 ( N_noxref_5_c_570_n N_noxref_7_c_715_n ) capacitor c=2.1838e-19 \
 //x=1.85 //y=2.08 //x2=2.55 //y2=0.53
cc_385 ( N_noxref_5_c_549_n N_noxref_7_M0_noxref_s ) capacitor c=0.00888238f \
 //x=1.885 //y=0.905 //x2=0.56 //y2=0.365
cc_386 ( N_noxref_5_c_564_n N_noxref_7_M0_noxref_s ) capacitor c=0.015333f \
 //x=2.415 //y=0.905 //x2=0.56 //y2=0.365
cc_387 ( N_noxref_5_c_566_n N_noxref_7_M0_noxref_s ) capacitor c=0.00248746f \
 //x=2.415 //y=1.25 //x2=0.56 //y2=0.365
