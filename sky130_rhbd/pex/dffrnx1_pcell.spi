// File: dffrnx1_pcell.spi
// Created: Fri Feb 20 10:19:18 2026
// Program "Calibre xRC"
// Version "v2023.2_27.15"
//
simulator lang=spectre
include "/import/yukari1/lrburle/sky130RHBDlib/calibre/sky130_rhbd_output/spice/dffrnx1_pcell.pex.spice"
subckt dffrnx1_pcell (  )
//
M0_noxref ( N_noxref_16_M0_noxref_d N_noxref_6_M0_noxref_g \
 N_noxref_18_M0_noxref_s noxref_252 ) NMOS l=0.163119 w=2.35104 m=1
M1_noxref ( N_noxref_8_M1_noxref_d N_noxref_3_M1_noxref_g \
 N_noxref_18_M0_noxref_s noxref_252 ) NMOS l=0.160516 w=2.29447 m=1
M2_noxref ( N_noxref_4_M2_noxref_d N_noxref_1_M2_noxref_g \
 N_noxref_8_M2_noxref_s noxref_252 ) NMOS l=0.163346 w=2.31104 m=1
M3_noxref ( N_noxref_16_M3_noxref_d N_noxref_4_M3_noxref_g \
 N_noxref_19_M3_noxref_s noxref_252 ) NMOS l=0.163119 w=2.35104 m=1
M4_noxref ( N_noxref_9_M4_noxref_d N_noxref_10_M4_noxref_g \
 N_noxref_19_M3_noxref_s noxref_252 ) NMOS l=0.160516 w=2.29447 m=1
M5_noxref ( N_noxref_1_M5_noxref_d N_noxref_5_M5_noxref_g \
 N_noxref_9_M5_noxref_s noxref_252 ) NMOS l=0.163346 w=2.31104 m=1
M6_noxref ( N_noxref_16_M6_noxref_d N_noxref_1_M6_noxref_g \
 N_noxref_20_M6_noxref_s noxref_252 ) NMOS l=0.163119 w=2.35104 m=1
M7_noxref ( N_noxref_2_M7_noxref_d N_noxref_6_M7_noxref_g \
 N_noxref_20_M6_noxref_s noxref_252 ) NMOS l=0.163346 w=2.31104 m=1
M8_noxref ( N_noxref_16_M8_noxref_d N_noxref_2_M8_noxref_g \
 N_noxref_21_M8_noxref_s noxref_252 ) NMOS l=0.163119 w=2.35104 m=1
M9_noxref ( N_noxref_11_M9_noxref_d N_noxref_3_M9_noxref_g \
 N_noxref_21_M8_noxref_s noxref_252 ) NMOS l=0.160516 w=2.29447 m=1
M10_noxref ( N_noxref_6_M10_noxref_d N_noxref_5_M10_noxref_g \
 N_noxref_11_M10_noxref_s noxref_252 ) NMOS l=0.163346 w=2.31104 m=1
M11_noxref ( N_noxref_16_M11_noxref_d N_noxref_4_M11_noxref_g \
 N_noxref_22_M11_noxref_s noxref_252 ) NMOS l=0.163119 w=2.35104 m=1
M12_noxref ( N_noxref_12_M12_noxref_d N_noxref_5_M12_noxref_g \
 N_noxref_22_M11_noxref_s noxref_252 ) NMOS l=0.160516 w=2.29447 m=1
M13_noxref ( N_noxref_14_M13_noxref_d N_noxref_13_M13_noxref_g \
 N_noxref_12_M13_noxref_s noxref_252 ) NMOS l=0.163346 w=2.31104 m=1
M14_noxref ( N_noxref_16_M14_noxref_d N_noxref_15_M14_noxref_g \
 N_noxref_23_M14_noxref_s noxref_252 ) NMOS l=0.163119 w=2.35104 m=1
M15_noxref ( N_noxref_17_M15_noxref_d N_noxref_6_M15_noxref_g \
 N_noxref_23_M14_noxref_s noxref_252 ) NMOS l=0.163346 w=2.31104 m=1
M16_noxref ( N_noxref_4_M16_noxref_d N_noxref_6_M16_noxref_g \
 N_noxref_7_M16_noxref_s noxref_250 ) PMOS l=0.15 w=2 ad=0.57 as=0.57 pd=2.57 \
 ps=2.57 nrd=0 nrs=0 m=1
M17_noxref ( N_noxref_7_M17_noxref_d N_noxref_6_M17_noxref_g \
 N_noxref_4_M16_noxref_d noxref_250 ) PMOS l=0.15 w=2 ad=0.58 as=0.58 pd=2.58 \
 ps=2.58 nrd=0 nrs=0 m=1
M18_noxref ( N_noxref_4_M18_noxref_d N_noxref_3_M18_noxref_g \
 N_noxref_7_M17_noxref_d noxref_250 ) PMOS l=0.15 w=2 ad=0.58 as=0.58 pd=2.58 \
 ps=2.58 nrd=0 nrs=0 m=1
M19_noxref ( N_noxref_7_M19_noxref_d N_noxref_3_M19_noxref_g \
 N_noxref_4_M18_noxref_d noxref_250 ) PMOS l=0.15 w=2 ad=0.58 as=0.58 pd=2.58 \
 ps=2.58 nrd=0 nrs=0 m=1
M20_noxref ( N_noxref_4_M20_noxref_d N_noxref_1_M20_noxref_g \
 N_noxref_7_M19_noxref_d noxref_250 ) PMOS l=0.15 w=2 ad=0.58 as=0.58 pd=2.58 \
 ps=2.58 nrd=0 nrs=0 m=1
M21_noxref ( N_noxref_7_M21_noxref_d N_noxref_1_M21_noxref_g \
 N_noxref_4_M20_noxref_d noxref_250 ) PMOS l=0.15 w=2 ad=0.56 as=0.56 pd=2.56 \
 ps=2.56 nrd=0 nrs=0 m=1
M22_noxref ( N_noxref_1_M22_noxref_d N_noxref_4_M22_noxref_g \
 N_noxref_7_M22_noxref_s noxref_250 ) PMOS l=0.15 w=2 ad=0.57 as=0.57 pd=2.57 \
 ps=2.57 nrd=0 nrs=0 m=1
M23_noxref ( N_noxref_7_M23_noxref_d N_noxref_4_M23_noxref_g \
 N_noxref_1_M22_noxref_d noxref_250 ) PMOS l=0.15 w=2 ad=0.58 as=0.58 pd=2.58 \
 ps=2.58 nrd=0 nrs=0 m=1
M24_noxref ( N_noxref_1_M24_noxref_d N_noxref_10_M24_noxref_g \
 N_noxref_7_M23_noxref_d noxref_250 ) PMOS l=0.15 w=2 ad=0.58 as=0.58 pd=2.58 \
 ps=2.58 nrd=0 nrs=0 m=1
M25_noxref ( N_noxref_7_M25_noxref_d N_noxref_10_M25_noxref_g \
 N_noxref_1_M24_noxref_d noxref_250 ) PMOS l=0.15 w=2 ad=0.58 as=0.58 pd=2.58 \
 ps=2.58 nrd=0 nrs=0 m=1
M26_noxref ( N_noxref_1_M26_noxref_d N_noxref_5_M26_noxref_g \
 N_noxref_7_M25_noxref_d noxref_250 ) PMOS l=0.15 w=2 ad=0.58 as=0.58 pd=2.58 \
 ps=2.58 nrd=0 nrs=0 m=1
M27_noxref ( N_noxref_7_M27_noxref_d N_noxref_5_M27_noxref_g \
 N_noxref_1_M26_noxref_d noxref_250 ) PMOS l=0.15 w=2 ad=0.56 as=0.56 pd=2.56 \
 ps=2.56 nrd=0 nrs=0 m=1
M28_noxref ( N_noxref_2_M28_noxref_d N_noxref_1_M28_noxref_g \
 N_noxref_7_M28_noxref_s noxref_250 ) PMOS l=0.15 w=2 ad=0.57 as=0.57 pd=2.57 \
 ps=2.57 nrd=0 nrs=0 m=1
M29_noxref ( N_noxref_7_M29_noxref_d N_noxref_1_M29_noxref_g \
 N_noxref_2_M28_noxref_d noxref_250 ) PMOS l=0.15 w=2 ad=0.58 as=0.58 pd=2.58 \
 ps=2.58 nrd=0 nrs=0 m=1
M30_noxref ( N_noxref_2_M30_noxref_d N_noxref_6_M30_noxref_g \
 N_noxref_7_M29_noxref_d noxref_250 ) PMOS l=0.15 w=2 ad=0.58 as=0.58 pd=2.58 \
 ps=2.58 nrd=0 nrs=0 m=1
M31_noxref ( N_noxref_7_M31_noxref_d N_noxref_6_M31_noxref_g \
 N_noxref_2_M30_noxref_d noxref_250 ) PMOS l=0.15 w=2 ad=0.56 as=0.56 pd=2.56 \
 ps=2.56 nrd=0 nrs=0 m=1
M32_noxref ( N_noxref_6_M32_noxref_d N_noxref_2_M32_noxref_g \
 N_noxref_7_M32_noxref_s noxref_250 ) PMOS l=0.15 w=2 ad=0.57 as=0.57 pd=2.57 \
 ps=2.57 nrd=0 nrs=0 m=1
M33_noxref ( N_noxref_7_M33_noxref_d N_noxref_2_M33_noxref_g \
 N_noxref_6_M32_noxref_d noxref_250 ) PMOS l=0.15 w=2 ad=0.58 as=0.58 pd=2.58 \
 ps=2.58 nrd=0 nrs=0 m=1
M34_noxref ( N_noxref_6_M34_noxref_d N_noxref_3_M34_noxref_g \
 N_noxref_7_M33_noxref_d noxref_250 ) PMOS l=0.15 w=2 ad=0.58 as=0.58 pd=2.58 \
 ps=2.58 nrd=0 nrs=0 m=1
M35_noxref ( N_noxref_7_M35_noxref_d N_noxref_3_M35_noxref_g \
 N_noxref_6_M34_noxref_d noxref_250 ) PMOS l=0.15 w=2 ad=0.58 as=0.58 pd=2.58 \
 ps=2.58 nrd=0 nrs=0 m=1
M36_noxref ( N_noxref_6_M36_noxref_d N_noxref_5_M36_noxref_g \
 N_noxref_7_M35_noxref_d noxref_250 ) PMOS l=0.15 w=2 ad=0.58 as=0.58 pd=2.58 \
 ps=2.58 nrd=0 nrs=0 m=1
M37_noxref ( N_noxref_7_M37_noxref_d N_noxref_5_M37_noxref_g \
 N_noxref_6_M36_noxref_d noxref_250 ) PMOS l=0.15 w=2 ad=0.56 as=0.56 pd=2.56 \
 ps=2.56 nrd=0 nrs=0 m=1
M38_noxref ( N_noxref_14_M38_noxref_d N_noxref_4_M38_noxref_g \
 N_noxref_7_M38_noxref_s noxref_250 ) PMOS l=0.15 w=2 ad=0.57 as=0.57 pd=2.57 \
 ps=2.57 nrd=0 nrs=0 m=1
M39_noxref ( N_noxref_7_M39_noxref_d N_noxref_4_M39_noxref_g \
 N_noxref_14_M38_noxref_d noxref_250 ) PMOS l=0.15 w=2 ad=0.58 as=0.58 pd=2.58 \
 ps=2.58 nrd=0 nrs=0 m=1
M40_noxref ( N_noxref_14_M40_noxref_d N_noxref_5_M40_noxref_g \
 N_noxref_7_M39_noxref_d noxref_250 ) PMOS l=0.15 w=2 ad=0.58 as=0.58 pd=2.58 \
 ps=2.58 nrd=0 nrs=0 m=1
M41_noxref ( N_noxref_7_M41_noxref_d N_noxref_5_M41_noxref_g \
 N_noxref_14_M40_noxref_d noxref_250 ) PMOS l=0.15 w=2 ad=0.58 as=0.58 pd=2.58 \
 ps=2.58 nrd=0 nrs=0 m=1
M42_noxref ( N_noxref_14_M42_noxref_d N_noxref_13_M42_noxref_g \
 N_noxref_7_M41_noxref_d noxref_250 ) PMOS l=0.15 w=2 ad=0.58 as=0.58 pd=2.58 \
 ps=2.58 nrd=0 nrs=0 m=1
M43_noxref ( N_noxref_7_M43_noxref_d N_noxref_13_M43_noxref_g \
 N_noxref_14_M42_noxref_d noxref_250 ) PMOS l=0.15 w=2 ad=0.56 as=0.56 pd=2.56 \
 ps=2.56 nrd=0 nrs=0 m=1
M44_noxref ( N_noxref_17_M44_noxref_d N_noxref_15_M44_noxref_g \
 N_noxref_7_M44_noxref_s noxref_250 ) PMOS l=0.15 w=2 ad=0.57 as=0.57 pd=2.57 \
 ps=2.57 nrd=0 nrs=0 m=1
M45_noxref ( N_noxref_7_M45_noxref_d N_noxref_15_M45_noxref_g \
 N_noxref_17_M44_noxref_d noxref_250 ) PMOS l=0.15 w=2 ad=0.58 as=0.58 pd=2.58 \
 ps=2.58 nrd=0 nrs=0 m=1
M46_noxref ( N_noxref_17_M46_noxref_d N_noxref_6_M46_noxref_g \
 N_noxref_7_M45_noxref_d noxref_250 ) PMOS l=0.15 w=2 ad=0.58 as=0.58 pd=2.58 \
 ps=2.58 nrd=0 nrs=0 m=1
M47_noxref ( N_noxref_7_M47_noxref_d N_noxref_6_M47_noxref_g \
 N_noxref_17_M46_noxref_d noxref_250 ) PMOS l=0.15 w=2 ad=0.56 as=0.56 pd=2.56 \
 ps=2.56 nrd=0 nrs=0 m=1
//
include "/import/yukari1/lrburle/sky130RHBDlib/calibre/sky130_rhbd_output/spice/dffrnx1_pcell.pxi.spice"
//
ends DFFRNX1_PCELL
//
//
