// File: nor3x1_pcell.spi.NOR3X1_PCELL.pxi
// Created: Sun Mar 15 12:51:53 2026
//
simulator lang=spectre
x_PM_NOR3X1_PCELL\%noxref_1 ( N_noxref_1_c_1_p N_noxref_1_c_2_p \
 N_noxref_1_c_16_p N_noxref_1_c_27_p N_noxref_1_c_15_p N_noxref_1_c_3_p \
 N_noxref_1_M0_noxref_s )  PM_NOR3X1_PCELL\%noxref_1
x_PM_NOR3X1_PCELL\%noxref_2 ( N_noxref_2_c_73_p N_noxref_2_c_114_p \
 N_noxref_2_c_75_p N_noxref_2_c_85_p N_noxref_2_c_86_p N_noxref_2_c_97_p \
 N_noxref_2_c_76_p N_noxref_2_c_87_p N_noxref_2_M3_noxref_s \
 N_noxref_2_M4_noxref_d N_noxref_2_M6_noxref_d )  PM_NOR3X1_PCELL\%noxref_2
x_PM_NOR3X1_PCELL\%noxref_3 ( N_noxref_3_c_163_n N_noxref_3_c_166_n \
 N_noxref_3_c_177_n N_noxref_3_c_180_n N_noxref_3_c_167_n \
 N_noxref_3_M0_noxref_g N_noxref_3_M3_noxref_g N_noxref_3_M4_noxref_g \
 N_noxref_3_c_169_n N_noxref_3_c_229_p N_noxref_3_c_230_p N_noxref_3_c_171_n \
 N_noxref_3_c_252_p N_noxref_3_c_253_p N_noxref_3_c_191_n N_noxref_3_c_173_n \
 N_noxref_3_c_175_n N_noxref_3_c_192_n )  PM_NOR3X1_PCELL\%noxref_3
x_PM_NOR3X1_PCELL\%noxref_4 ( N_noxref_4_c_277_n N_noxref_4_c_281_n \
 N_noxref_4_c_287_n N_noxref_4_c_291_n N_noxref_4_c_275_n N_noxref_4_c_276_n \
 N_noxref_4_M3_noxref_d )  PM_NOR3X1_PCELL\%noxref_4
x_PM_NOR3X1_PCELL\%noxref_5 ( N_noxref_5_c_349_n N_noxref_5_c_361_n \
 N_noxref_5_c_350_n N_noxref_5_c_363_n N_noxref_5_M1_noxref_g \
 N_noxref_5_M5_noxref_g N_noxref_5_M6_noxref_g N_noxref_5_c_353_n \
 N_noxref_5_c_393_n N_noxref_5_c_396_n N_noxref_5_c_439_p N_noxref_5_c_459_p \
 N_noxref_5_c_355_n N_noxref_5_c_356_n N_noxref_5_c_400_n N_noxref_5_c_358_n \
 N_noxref_5_c_404_n N_noxref_5_c_371_n )  PM_NOR3X1_PCELL\%noxref_5
x_PM_NOR3X1_PCELL\%noxref_6 ( N_noxref_6_c_477_n N_noxref_6_c_486_n \
 N_noxref_6_c_478_n N_noxref_6_c_488_n N_noxref_6_M2_noxref_g \
 N_noxref_6_M7_noxref_g N_noxref_6_M8_noxref_g N_noxref_6_c_480_n \
 N_noxref_6_c_506_n N_noxref_6_c_508_n N_noxref_6_c_510_n N_noxref_6_c_544_p \
 N_noxref_6_c_482_n N_noxref_6_c_527_p N_noxref_6_c_483_n N_noxref_6_c_513_n \
 N_noxref_6_c_491_n N_noxref_6_c_485_n N_noxref_6_c_517_n )  \
 PM_NOR3X1_PCELL\%noxref_6
x_PM_NOR3X1_PCELL\%noxref_7 ( N_noxref_7_c_581_n N_noxref_7_c_584_n \
 N_noxref_7_c_602_n N_noxref_7_c_586_n N_noxref_7_c_590_n N_noxref_7_c_593_n \
 N_noxref_7_c_594_n N_noxref_7_c_598_n N_noxref_7_M5_noxref_d \
 N_noxref_7_M7_noxref_s N_noxref_7_M8_noxref_d )  PM_NOR3X1_PCELL\%noxref_7
x_PM_NOR3X1_PCELL\%noxref_8 ( N_noxref_8_c_657_n N_noxref_8_c_661_n \
 N_noxref_8_c_662_n N_noxref_8_c_696_n N_noxref_8_c_666_n N_noxref_8_c_670_n \
 N_noxref_8_c_671_n N_noxref_8_c_675_n N_noxref_8_c_679_n N_noxref_8_c_681_n \
 N_noxref_8_c_726_n N_noxref_8_c_727_n N_noxref_8_c_784_n N_noxref_8_c_697_n \
 N_noxref_8_c_698_n N_noxref_8_M0_noxref_d N_noxref_8_M1_noxref_d \
 N_noxref_8_M2_noxref_d N_noxref_8_M7_noxref_d )  PM_NOR3X1_PCELL\%noxref_8
cc_1 ( N_noxref_1_c_1_p N_noxref_3_c_163_n ) capacitor c=6.99281e-19 //x=4.07 \
 //y=0 //x2=1.11 //y2=2.245
cc_2 ( N_noxref_1_c_2_p N_noxref_3_c_163_n ) capacitor c=9.81943e-19 //x=1.58 \
 //y=0.53 //x2=1.11 //y2=2.245
cc_3 ( N_noxref_1_c_3_p N_noxref_3_c_163_n ) capacitor c=0.00920582f //x=0.74 \
 //y=0 //x2=1.11 //y2=2.245
cc_4 ( N_noxref_1_c_3_p N_noxref_3_c_166_n ) capacitor c=0.0119787f //x=0.74 \
 //y=0 //x2=1.11 //y2=4.585
cc_5 ( N_noxref_1_c_2_p N_noxref_3_c_167_n ) capacitor c=4.19546e-19 //x=1.58 \
 //y=0.53 //x2=1.11 //y2=2.08
cc_6 ( N_noxref_1_c_3_p N_noxref_3_c_167_n ) capacitor c=0.00368165f //x=0.74 \
 //y=0 //x2=1.11 //y2=2.08
cc_7 ( N_noxref_1_c_2_p N_noxref_3_c_169_n ) capacitor c=0.0209625f //x=1.58 \
 //y=0.53 //x2=0.915 //y2=0.905
cc_8 ( N_noxref_1_M0_noxref_s N_noxref_3_c_169_n ) capacitor c=0.033078f \
 //x=0.56 //y=0.365 //x2=0.915 //y2=0.905
cc_9 ( N_noxref_1_c_2_p N_noxref_3_c_171_n ) capacitor c=2.1838e-19 //x=1.58 \
 //y=0.53 //x2=0.915 //y2=1.915
cc_10 ( N_noxref_1_c_3_p N_noxref_3_c_171_n ) capacitor c=0.0121558f //x=0.74 \
 //y=0 //x2=0.915 //y2=1.915
cc_11 ( N_noxref_1_c_2_p N_noxref_3_c_173_n ) capacitor c=0.00805599f //x=1.58 \
 //y=0.53 //x2=1.445 //y2=0.905
cc_12 ( N_noxref_1_M0_noxref_s N_noxref_3_c_173_n ) capacitor c=0.00617417f \
 //x=0.56 //y=0.365 //x2=1.445 //y2=0.905
cc_13 ( N_noxref_1_M0_noxref_s N_noxref_3_c_175_n ) capacitor c=0.00120103f \
 //x=0.56 //y=0.365 //x2=1.445 //y2=1.25
cc_14 ( N_noxref_1_c_3_p N_noxref_4_c_275_n ) capacitor c=0.00989031f //x=0.74 \
 //y=0 //x2=0.74 //y2=7.4
cc_15 ( N_noxref_1_c_15_p N_noxref_4_c_276_n ) capacitor c=0.00989031f \
 //x=4.07 //y=0 //x2=4.07 //y2=7.4
cc_16 ( N_noxref_1_c_16_p N_noxref_5_c_349_n ) capacitor c=6.15173e-19 \
 //x=2.55 //y=0.53 //x2=1.85 //y2=2.21
cc_17 ( N_noxref_1_c_16_p N_noxref_5_c_350_n ) capacitor c=9.05712e-19 \
 //x=2.55 //y=0.53 //x2=1.85 //y2=2.08
cc_18 ( N_noxref_1_c_15_p N_noxref_5_c_350_n ) capacitor c=2.74946e-19 \
 //x=4.07 //y=0 //x2=1.85 //y2=2.08
cc_19 ( N_noxref_1_c_3_p N_noxref_5_c_350_n ) capacitor c=5.03552e-19 //x=0.74 \
 //y=0 //x2=1.85 //y2=2.08
cc_20 ( N_noxref_1_c_16_p N_noxref_5_c_353_n ) capacitor c=0.0207598f //x=2.55 \
 //y=0.53 //x2=1.885 //y2=0.905
cc_21 ( N_noxref_1_M0_noxref_s N_noxref_5_c_353_n ) capacitor c=0.00732593f \
 //x=0.56 //y=0.365 //x2=1.885 //y2=0.905
cc_22 ( N_noxref_1_M0_noxref_s N_noxref_5_c_355_n ) capacitor c=0.00120679f \
 //x=0.56 //y=0.365 //x2=2.26 //y2=1.405
cc_23 ( N_noxref_1_c_16_p N_noxref_5_c_356_n ) capacitor c=0.00805599f \
 //x=2.55 //y=0.53 //x2=2.415 //y2=0.905
cc_24 ( N_noxref_1_M0_noxref_s N_noxref_5_c_356_n ) capacitor c=0.00617003f \
 //x=0.56 //y=0.365 //x2=2.415 //y2=0.905
cc_25 ( N_noxref_1_c_16_p N_noxref_5_c_358_n ) capacitor c=2.1838e-19 //x=2.55 \
 //y=0.53 //x2=1.85 //y2=2.08
cc_26 ( N_noxref_1_M0_noxref_s N_noxref_5_c_358_n ) capacitor c=0.00118102f \
 //x=0.56 //y=0.365 //x2=1.85 //y2=2.08
cc_27 ( N_noxref_1_c_27_p N_noxref_6_c_477_n ) capacitor c=7.66217e-19 \
 //x=3.52 //y=0.53 //x2=2.96 //y2=2.225
cc_28 ( N_noxref_1_c_27_p N_noxref_6_c_478_n ) capacitor c=0.00100208f \
 //x=3.52 //y=0.53 //x2=2.96 //y2=2.08
cc_29 ( N_noxref_1_c_15_p N_noxref_6_c_478_n ) capacitor c=0.00172597f \
 //x=4.07 //y=0 //x2=2.96 //y2=2.08
cc_30 ( N_noxref_1_c_27_p N_noxref_6_c_480_n ) capacitor c=0.0208435f //x=3.52 \
 //y=0.53 //x2=2.855 //y2=0.905
cc_31 ( N_noxref_1_M0_noxref_s N_noxref_6_c_480_n ) capacitor c=0.00732593f \
 //x=0.56 //y=0.365 //x2=2.855 //y2=0.905
cc_32 ( N_noxref_1_M0_noxref_s N_noxref_6_c_482_n ) capacitor c=0.00271091f \
 //x=0.56 //y=0.365 //x2=3.23 //y2=1.405
cc_33 ( N_noxref_1_c_27_p N_noxref_6_c_483_n ) capacitor c=0.00825432f \
 //x=3.52 //y=0.53 //x2=3.385 //y2=0.905
cc_34 ( N_noxref_1_M0_noxref_s N_noxref_6_c_483_n ) capacitor c=0.0143707f \
 //x=0.56 //y=0.365 //x2=3.385 //y2=0.905
cc_35 ( N_noxref_1_c_27_p N_noxref_6_c_485_n ) capacitor c=2.1838e-19 //x=3.52 \
 //y=0.53 //x2=2.855 //y2=2.08
cc_36 ( N_noxref_1_c_1_p N_noxref_8_c_657_n ) capacitor c=0.0100127f //x=4.07 \
 //y=0 //x2=1.18 //y2=1.13
cc_37 ( N_noxref_1_c_2_p N_noxref_8_c_657_n ) capacitor c=0.00400023f //x=1.58 \
 //y=0.53 //x2=1.18 //y2=1.13
cc_38 ( N_noxref_1_c_15_p N_noxref_8_c_657_n ) capacitor c=2.87802e-19 \
 //x=4.07 //y=0 //x2=1.18 //y2=1.13
cc_39 ( N_noxref_1_M0_noxref_s N_noxref_8_c_657_n ) capacitor c=0.0106681f \
 //x=0.56 //y=0.365 //x2=1.18 //y2=1.13
cc_40 ( N_noxref_1_M0_noxref_s N_noxref_8_c_661_n ) capacitor c=0.0281176f \
 //x=0.56 //y=0.365 //x2=1.18 //y2=1.57
cc_41 ( N_noxref_1_c_1_p N_noxref_8_c_662_n ) capacitor c=0.00677167f //x=4.07 \
 //y=0 //x2=2.065 //y2=1.655
cc_42 ( N_noxref_1_c_2_p N_noxref_8_c_662_n ) capacitor c=0.00128856f //x=1.58 \
 //y=0.53 //x2=2.065 //y2=1.655
cc_43 ( N_noxref_1_c_16_p N_noxref_8_c_662_n ) capacitor c=0.0010475f //x=2.55 \
 //y=0.53 //x2=2.065 //y2=1.655
cc_44 ( N_noxref_1_M0_noxref_s N_noxref_8_c_662_n ) capacitor c=0.00856975f \
 //x=0.56 //y=0.365 //x2=2.065 //y2=1.655
cc_45 ( N_noxref_1_c_1_p N_noxref_8_c_666_n ) capacitor c=0.0100522f //x=4.07 \
 //y=0 //x2=2.15 //y2=1.13
cc_46 ( N_noxref_1_c_16_p N_noxref_8_c_666_n ) capacitor c=0.00431488f \
 //x=2.55 //y=0.53 //x2=2.15 //y2=1.13
cc_47 ( N_noxref_1_c_15_p N_noxref_8_c_666_n ) capacitor c=2.87802e-19 \
 //x=4.07 //y=0 //x2=2.15 //y2=1.13
cc_48 ( N_noxref_1_M0_noxref_s N_noxref_8_c_666_n ) capacitor c=0.00695238f \
 //x=0.56 //y=0.365 //x2=2.15 //y2=1.13
cc_49 ( N_noxref_1_M0_noxref_s N_noxref_8_c_670_n ) capacitor c=0.00901608f \
 //x=0.56 //y=0.365 //x2=2.15 //y2=1.57
cc_50 ( N_noxref_1_c_1_p N_noxref_8_c_671_n ) capacitor c=0.00677234f //x=4.07 \
 //y=0 //x2=3.035 //y2=1.655
cc_51 ( N_noxref_1_c_16_p N_noxref_8_c_671_n ) capacitor c=0.00128856f \
 //x=2.55 //y=0.53 //x2=3.035 //y2=1.655
cc_52 ( N_noxref_1_c_27_p N_noxref_8_c_671_n ) capacitor c=0.00176314f \
 //x=3.52 //y=0.53 //x2=3.035 //y2=1.655
cc_53 ( N_noxref_1_M0_noxref_s N_noxref_8_c_671_n ) capacitor c=0.00884125f \
 //x=0.56 //y=0.365 //x2=3.035 //y2=1.655
cc_54 ( N_noxref_1_c_1_p N_noxref_8_c_675_n ) capacitor c=0.00982429f //x=4.07 \
 //y=0 //x2=3.12 //y2=1.145
cc_55 ( N_noxref_1_c_27_p N_noxref_8_c_675_n ) capacitor c=0.00398909f \
 //x=3.52 //y=0.53 //x2=3.12 //y2=1.145
cc_56 ( N_noxref_1_c_15_p N_noxref_8_c_675_n ) capacitor c=2.87802e-19 \
 //x=4.07 //y=0 //x2=3.12 //y2=1.145
cc_57 ( N_noxref_1_M0_noxref_s N_noxref_8_c_675_n ) capacitor c=0.0113255f \
 //x=0.56 //y=0.365 //x2=3.12 //y2=1.145
cc_58 ( N_noxref_1_c_15_p N_noxref_8_c_679_n ) capacitor c=0.00484928f \
 //x=4.07 //y=0 //x2=3.12 //y2=1.57
cc_59 ( N_noxref_1_M0_noxref_s N_noxref_8_c_679_n ) capacitor c=0.0117003f \
 //x=0.56 //y=0.365 //x2=3.12 //y2=1.57
cc_60 ( N_noxref_1_c_1_p N_noxref_8_c_681_n ) capacitor c=0.00902316f //x=4.07 \
 //y=0 //x2=3.615 //y2=1.655
cc_61 ( N_noxref_1_c_27_p N_noxref_8_c_681_n ) capacitor c=0.00348283f \
 //x=3.52 //y=0.53 //x2=3.615 //y2=1.655
cc_62 ( N_noxref_1_c_15_p N_noxref_8_c_681_n ) capacitor c=0.0292329f //x=4.07 \
 //y=0 //x2=3.615 //y2=1.655
cc_63 ( N_noxref_1_M0_noxref_s N_noxref_8_c_681_n ) capacitor c=0.0108131f \
 //x=0.56 //y=0.365 //x2=3.615 //y2=1.655
cc_64 ( N_noxref_1_c_1_p N_noxref_8_M0_noxref_d ) capacitor c=3.01654e-19 \
 //x=4.07 //y=0 //x2=0.99 //y2=0.905
cc_65 ( N_noxref_1_c_2_p N_noxref_8_M0_noxref_d ) capacitor c=0.00910163f \
 //x=1.58 //y=0.53 //x2=0.99 //y2=0.905
cc_66 ( N_noxref_1_M0_noxref_s N_noxref_8_M0_noxref_d ) capacitor c=0.0275007f \
 //x=0.56 //y=0.365 //x2=0.99 //y2=0.905
cc_67 ( N_noxref_1_c_1_p N_noxref_8_M1_noxref_d ) capacitor c=3.01654e-19 \
 //x=4.07 //y=0 //x2=1.96 //y2=0.905
cc_68 ( N_noxref_1_c_16_p N_noxref_8_M1_noxref_d ) capacitor c=0.00910163f \
 //x=2.55 //y=0.53 //x2=1.96 //y2=0.905
cc_69 ( N_noxref_1_M0_noxref_s N_noxref_8_M1_noxref_d ) capacitor c=0.0274981f \
 //x=0.56 //y=0.365 //x2=1.96 //y2=0.905
cc_70 ( N_noxref_1_c_1_p N_noxref_8_M2_noxref_d ) capacitor c=3.01654e-19 \
 //x=4.07 //y=0 //x2=2.93 //y2=0.905
cc_71 ( N_noxref_1_c_27_p N_noxref_8_M2_noxref_d ) capacitor c=0.00910163f \
 //x=3.52 //y=0.53 //x2=2.93 //y2=0.905
cc_72 ( N_noxref_1_M0_noxref_s N_noxref_8_M2_noxref_d ) capacitor c=0.0274983f \
 //x=0.56 //y=0.365 //x2=2.93 //y2=0.905
cc_73 ( N_noxref_2_c_73_p N_noxref_3_c_163_n ) capacitor c=3.49728e-19 \
 //x=1.555 //y=5.21 //x2=1.11 //y2=2.245
cc_74 ( N_noxref_2_c_73_p N_noxref_3_c_177_n ) capacitor c=0.00780885f \
 //x=1.555 //y=5.21 //x2=0.955 //y2=4.705
cc_75 ( N_noxref_2_c_75_p N_noxref_3_c_177_n ) capacitor c=0.0239345f \
 //x=0.792 //y=5.21 //x2=0.955 //y2=4.705
cc_76 ( N_noxref_2_c_76_p N_noxref_3_c_177_n ) capacitor c=0.0022154f //x=0.79 \
 //y=5.38 //x2=0.955 //y2=4.705
cc_77 ( N_noxref_2_c_73_p N_noxref_3_c_180_n ) capacitor c=0.00104675f \
 //x=1.555 //y=5.21 //x2=0.955 //y2=4.705
cc_78 ( N_noxref_2_c_75_p N_noxref_3_c_180_n ) capacitor c=0.00565893f \
 //x=0.792 //y=5.21 //x2=0.955 //y2=4.705
cc_79 ( N_noxref_2_c_76_p N_noxref_3_c_180_n ) capacitor c=0.00126834f \
 //x=0.79 //y=5.38 //x2=0.955 //y2=4.705
cc_80 ( N_noxref_2_c_73_p N_noxref_3_M3_noxref_g ) capacitor c=0.00997309f \
 //x=1.555 //y=5.21 //x2=1.01 //y2=6.025
cc_81 ( N_noxref_2_c_75_p N_noxref_3_M3_noxref_g ) capacitor c=0.00429908f \
 //x=0.792 //y=5.21 //x2=1.01 //y2=6.025
cc_82 ( N_noxref_2_c_76_p N_noxref_3_M3_noxref_g ) capacitor c=0.0483843f \
 //x=0.79 //y=5.38 //x2=1.01 //y2=6.025
cc_83 ( N_noxref_2_M3_noxref_s N_noxref_3_M3_noxref_g ) capacitor \
 c=0.00370227f //x=0.655 //y=5.025 //x2=1.01 //y2=6.025
cc_84 ( N_noxref_2_c_73_p N_noxref_3_M4_noxref_g ) capacitor c=0.00967464f \
 //x=1.555 //y=5.21 //x2=1.45 //y2=6.025
cc_85 ( N_noxref_2_c_85_p N_noxref_3_M4_noxref_g ) capacitor c=0.00182852f \
 //x=1.672 //y=5.21 //x2=1.45 //y2=6.025
cc_86 ( N_noxref_2_c_86_p N_noxref_3_M4_noxref_g ) capacitor c=0.00175452f \
 //x=1.67 //y=6.74 //x2=1.45 //y2=6.025
cc_87 ( N_noxref_2_c_87_p N_noxref_3_M4_noxref_g ) capacitor c=0.0170175f \
 //x=1.67 //y=5.38 //x2=1.45 //y2=6.025
cc_88 ( N_noxref_2_c_73_p N_noxref_3_c_191_n ) capacitor c=0.00196455f \
 //x=1.555 //y=5.21 //x2=1.375 //y2=4.795
cc_89 ( N_noxref_2_c_75_p N_noxref_3_c_192_n ) capacitor c=9.17057e-19 \
 //x=0.792 //y=5.21 //x2=0.955 //y2=4.705
cc_90 ( N_noxref_2_c_76_p N_noxref_3_c_192_n ) capacitor c=0.00297041f \
 //x=0.79 //y=5.38 //x2=0.955 //y2=4.705
cc_91 ( N_noxref_2_c_73_p N_noxref_4_c_277_n ) capacitor c=0.00186634f \
 //x=1.555 //y=5.21 //x2=1.145 //y2=7.4
cc_92 ( N_noxref_2_c_75_p N_noxref_4_c_277_n ) capacitor c=3.01893e-19 \
 //x=0.792 //y=5.21 //x2=1.145 //y2=7.4
cc_93 ( N_noxref_2_c_76_p N_noxref_4_c_277_n ) capacitor c=0.00240599f \
 //x=0.79 //y=5.38 //x2=1.145 //y2=7.4
cc_94 ( N_noxref_2_M3_noxref_s N_noxref_4_c_277_n ) capacitor c=0.0245152f \
 //x=0.655 //y=5.025 //x2=1.145 //y2=7.4
cc_95 ( N_noxref_2_c_73_p N_noxref_4_c_281_n ) capacitor c=0.00495979f \
 //x=1.555 //y=5.21 //x2=1.23 //y2=6.855
cc_96 ( N_noxref_2_c_86_p N_noxref_4_c_281_n ) capacitor c=0.0375632f //x=1.67 \
 //y=6.74 //x2=1.23 //y2=6.855
cc_97 ( N_noxref_2_c_97_p N_noxref_4_c_281_n ) capacitor c=6.22236e-19 \
 //x=2.55 //y=6.74 //x2=1.23 //y2=6.855
cc_98 ( N_noxref_2_c_76_p N_noxref_4_c_281_n ) capacitor c=0.00220362f \
 //x=0.79 //y=5.38 //x2=1.23 //y2=6.855
cc_99 ( N_noxref_2_c_87_p N_noxref_4_c_281_n ) capacitor c=0.00220362f \
 //x=1.67 //y=5.38 //x2=1.23 //y2=6.855
cc_100 ( N_noxref_2_M3_noxref_s N_noxref_4_c_281_n ) capacitor c=0.0381427f \
 //x=0.655 //y=5.025 //x2=1.23 //y2=6.855
cc_101 ( N_noxref_2_c_86_p N_noxref_4_c_287_n ) capacitor c=0.0104314f \
 //x=1.67 //y=6.74 //x2=1.23 //y2=7.23
cc_102 ( N_noxref_2_c_76_p N_noxref_4_c_287_n ) capacitor c=0.00158506f \
 //x=0.79 //y=5.38 //x2=1.23 //y2=7.23
cc_103 ( N_noxref_2_c_87_p N_noxref_4_c_287_n ) capacitor c=4.62894e-19 \
 //x=1.67 //y=5.38 //x2=1.23 //y2=7.23
cc_104 ( N_noxref_2_M3_noxref_s N_noxref_4_c_287_n ) capacitor c=0.0121524f \
 //x=0.655 //y=5.025 //x2=1.23 //y2=7.23
cc_105 ( N_noxref_2_c_73_p N_noxref_4_c_291_n ) capacitor c=0.00198579f \
 //x=1.555 //y=5.21 //x2=4.07 //y2=7.4
cc_106 ( N_noxref_2_c_86_p N_noxref_4_c_291_n ) capacitor c=0.0973825f \
 //x=1.67 //y=6.74 //x2=4.07 //y2=7.4
cc_107 ( N_noxref_2_c_97_p N_noxref_4_c_291_n ) capacitor c=0.00214718f \
 //x=2.55 //y=6.74 //x2=4.07 //y2=7.4
cc_108 ( N_noxref_2_c_87_p N_noxref_4_c_291_n ) capacitor c=0.0020548f \
 //x=1.67 //y=5.38 //x2=4.07 //y2=7.4
cc_109 ( N_noxref_2_M6_noxref_d N_noxref_4_c_291_n ) capacitor c=0.00206634f \
 //x=2.405 //y=5.025 //x2=4.07 //y2=7.4
cc_110 ( N_noxref_2_c_75_p N_noxref_4_c_275_n ) capacitor c=0.0100761f \
 //x=0.792 //y=5.21 //x2=0.74 //y2=7.4
cc_111 ( N_noxref_2_c_76_p N_noxref_4_c_275_n ) capacitor c=0.0554809f \
 //x=0.79 //y=5.38 //x2=0.74 //y2=7.4
cc_112 ( N_noxref_2_M3_noxref_s N_noxref_4_c_275_n ) capacitor c=0.00790985f \
 //x=0.655 //y=5.025 //x2=0.74 //y2=7.4
cc_113 ( N_noxref_2_c_73_p N_noxref_4_c_276_n ) capacitor c=0.00432797f \
 //x=1.555 //y=5.21 //x2=4.07 //y2=7.4
cc_114 ( N_noxref_2_c_114_p N_noxref_4_c_276_n ) capacitor c=0.00219567f \
 //x=2.435 //y=6.91 //x2=4.07 //y2=7.4
cc_115 ( N_noxref_2_c_75_p N_noxref_4_c_276_n ) capacitor c=2.30791e-19 \
 //x=0.792 //y=5.21 //x2=4.07 //y2=7.4
cc_116 ( N_noxref_2_c_86_p N_noxref_4_c_276_n ) capacitor c=0.0215794f \
 //x=1.67 //y=6.74 //x2=4.07 //y2=7.4
cc_117 ( N_noxref_2_c_97_p N_noxref_4_c_276_n ) capacitor c=0.00218666f \
 //x=2.55 //y=6.74 //x2=4.07 //y2=7.4
cc_118 ( N_noxref_2_c_76_p N_noxref_4_c_276_n ) capacitor c=0.0142846f \
 //x=0.79 //y=5.38 //x2=4.07 //y2=7.4
cc_119 ( N_noxref_2_c_87_p N_noxref_4_c_276_n ) capacitor c=0.0095667f \
 //x=1.67 //y=5.38 //x2=4.07 //y2=7.4
cc_120 ( N_noxref_2_M3_noxref_s N_noxref_4_c_276_n ) capacitor c=0.00421486f \
 //x=0.655 //y=5.025 //x2=4.07 //y2=7.4
cc_121 ( N_noxref_2_M6_noxref_d N_noxref_4_c_276_n ) capacitor c=0.00958662f \
 //x=2.405 //y=5.025 //x2=4.07 //y2=7.4
cc_122 ( N_noxref_2_c_73_p N_noxref_4_M3_noxref_d ) capacitor c=0.00667051f \
 //x=1.555 //y=5.21 //x2=1.085 //y2=5.025
cc_123 ( N_noxref_2_c_86_p N_noxref_4_M3_noxref_d ) capacitor c=0.00466156f \
 //x=1.67 //y=6.74 //x2=1.085 //y2=5.025
cc_124 ( N_noxref_2_c_76_p N_noxref_4_M3_noxref_d ) capacitor c=0.0736776f \
 //x=0.79 //y=5.38 //x2=1.085 //y2=5.025
cc_125 ( N_noxref_2_c_87_p N_noxref_4_M3_noxref_d ) capacitor c=0.0670838f \
 //x=1.67 //y=5.38 //x2=1.085 //y2=5.025
cc_126 ( N_noxref_2_M3_noxref_s N_noxref_4_M3_noxref_d ) capacitor \
 c=0.00566948f //x=0.655 //y=5.025 //x2=1.085 //y2=5.025
cc_127 ( N_noxref_2_c_85_p N_noxref_5_c_349_n ) capacitor c=6.32666e-19 \
 //x=1.672 //y=5.21 //x2=1.85 //y2=2.21
cc_128 ( N_noxref_2_c_114_p N_noxref_5_c_361_n ) capacitor c=0.00230547f \
 //x=2.435 //y=6.91 //x2=1.85 //y2=4.56
cc_129 ( N_noxref_2_c_85_p N_noxref_5_c_361_n ) capacitor c=0.00148837f \
 //x=1.672 //y=5.21 //x2=1.85 //y2=4.56
cc_130 ( N_noxref_2_c_114_p N_noxref_5_c_363_n ) capacitor c=0.00233465f \
 //x=2.435 //y=6.91 //x2=1.885 //y2=4.705
cc_131 ( N_noxref_2_c_114_p N_noxref_5_M5_noxref_g ) capacitor c=0.00778083f \
 //x=2.435 //y=6.91 //x2=1.89 //y2=6.025
cc_132 ( N_noxref_2_c_85_p N_noxref_5_M5_noxref_g ) capacitor c=0.0018192f \
 //x=1.672 //y=5.21 //x2=1.89 //y2=6.025
cc_133 ( N_noxref_2_c_86_p N_noxref_5_M5_noxref_g ) capacitor c=0.0018046f \
 //x=1.67 //y=6.74 //x2=1.89 //y2=6.025
cc_134 ( N_noxref_2_c_87_p N_noxref_5_M5_noxref_g ) capacitor c=0.0170175f \
 //x=1.67 //y=5.38 //x2=1.89 //y2=6.025
cc_135 ( N_noxref_2_c_114_p N_noxref_5_M6_noxref_g ) capacitor c=0.00843033f \
 //x=2.435 //y=6.91 //x2=2.33 //y2=6.025
cc_136 ( N_noxref_2_c_97_p N_noxref_5_M6_noxref_g ) capacitor c=0.00272866f \
 //x=2.55 //y=6.74 //x2=2.33 //y2=6.025
cc_137 ( N_noxref_2_M6_noxref_d N_noxref_5_M6_noxref_g ) capacitor \
 c=0.0231499f //x=2.405 //y=5.025 //x2=2.33 //y2=6.025
cc_138 ( N_noxref_2_c_85_p N_noxref_5_c_371_n ) capacitor c=6.56606e-19 \
 //x=1.672 //y=5.21 //x2=1.885 //y2=4.705
cc_139 ( N_noxref_2_c_114_p N_noxref_7_c_581_n ) capacitor c=0.00321697f \
 //x=2.435 //y=6.91 //x2=3.065 //y2=5.21
cc_140 ( N_noxref_2_c_97_p N_noxref_7_c_581_n ) capacitor c=0.00503384f \
 //x=2.55 //y=6.74 //x2=3.065 //y2=5.21
cc_141 ( N_noxref_2_M6_noxref_d N_noxref_7_c_581_n ) capacitor c=0.00659996f \
 //x=2.405 //y=5.025 //x2=3.065 //y2=5.21
cc_142 ( N_noxref_2_c_85_p N_noxref_7_c_584_n ) capacitor c=8.51609e-19 \
 //x=1.672 //y=5.21 //x2=3.15 //y2=5.59
cc_143 ( N_noxref_2_M6_noxref_d N_noxref_7_c_584_n ) capacitor c=0.00726094f \
 //x=2.405 //y=5.025 //x2=3.15 //y2=5.59
cc_144 ( N_noxref_2_c_114_p N_noxref_7_c_586_n ) capacitor c=0.00515028f \
 //x=2.435 //y=6.91 //x2=2.11 //y2=5.21
cc_145 ( N_noxref_2_c_75_p N_noxref_7_c_586_n ) capacitor c=6.44186e-19 \
 //x=0.792 //y=5.21 //x2=2.11 //y2=5.21
cc_146 ( N_noxref_2_c_85_p N_noxref_7_c_586_n ) capacitor c=0.0526233f \
 //x=1.672 //y=5.21 //x2=2.11 //y2=5.21
cc_147 ( N_noxref_2_c_87_p N_noxref_7_c_586_n ) capacitor c=0.00261162f \
 //x=1.67 //y=5.38 //x2=2.11 //y2=5.21
cc_148 ( N_noxref_2_c_86_p N_noxref_7_c_590_n ) capacitor c=4.26669e-19 \
 //x=1.67 //y=6.74 //x2=3.15 //y2=6.74
cc_149 ( N_noxref_2_c_97_p N_noxref_7_c_590_n ) capacitor c=0.036549f //x=2.55 \
 //y=6.74 //x2=3.15 //y2=6.74
cc_150 ( N_noxref_2_M6_noxref_d N_noxref_7_c_590_n ) capacitor c=0.00418103f \
 //x=2.405 //y=5.025 //x2=3.15 //y2=6.74
cc_151 ( N_noxref_2_c_97_p N_noxref_7_c_593_n ) capacitor c=4.2596e-19 \
 //x=2.55 //y=6.74 //x2=4.03 //y2=6.74
cc_152 ( N_noxref_2_c_114_p N_noxref_7_c_594_n ) capacitor c=0.00406191f \
 //x=2.435 //y=6.91 //x2=2.11 //y2=5.38
cc_153 ( N_noxref_2_c_85_p N_noxref_7_c_594_n ) capacitor c=0.00396335f \
 //x=1.672 //y=5.21 //x2=2.11 //y2=5.38
cc_154 ( N_noxref_2_c_87_p N_noxref_7_c_594_n ) capacitor c=0.0679433f \
 //x=1.67 //y=5.38 //x2=2.11 //y2=5.38
cc_155 ( N_noxref_2_M6_noxref_d N_noxref_7_c_594_n ) capacitor c=0.0468918f \
 //x=2.405 //y=5.025 //x2=2.11 //y2=5.38
cc_156 ( N_noxref_2_c_97_p N_noxref_7_c_598_n ) capacitor c=0.00161703f \
 //x=2.55 //y=6.74 //x2=3.15 //y2=5.72
cc_157 ( N_noxref_2_M6_noxref_d N_noxref_7_c_598_n ) capacitor c=0.0468546f \
 //x=2.405 //y=5.025 //x2=3.15 //y2=5.72
cc_158 ( N_noxref_2_c_73_p N_noxref_8_c_657_n ) capacitor c=2.38306e-19 \
 //x=1.555 //y=5.21 //x2=1.18 //y2=1.13
cc_159 ( N_noxref_2_c_85_p N_noxref_8_c_662_n ) capacitor c=0.00318142f \
 //x=1.672 //y=5.21 //x2=2.065 //y2=1.655
cc_160 ( N_noxref_2_c_73_p N_noxref_8_c_696_n ) capacitor c=0.00292631f \
 //x=1.555 //y=5.21 //x2=1.265 //y2=1.655
cc_161 ( N_noxref_2_c_85_p N_noxref_8_c_697_n ) capacitor c=0.00134451f \
 //x=1.672 //y=5.21 //x2=3.7 //y2=5.21
cc_162 ( N_noxref_2_M6_noxref_d N_noxref_8_c_698_n ) capacitor c=0.00395323f \
 //x=2.405 //y=5.025 //x2=3.59 //y2=5.72
cc_163 ( N_noxref_3_M3_noxref_g N_noxref_4_c_281_n ) capacitor c=0.0012542f \
 //x=1.01 //y=6.025 //x2=1.23 //y2=6.855
cc_164 ( N_noxref_3_M4_noxref_g N_noxref_4_c_281_n ) capacitor c=0.0012542f \
 //x=1.45 //y=6.025 //x2=1.23 //y2=6.855
cc_165 ( N_noxref_3_M3_noxref_g N_noxref_4_c_287_n ) capacitor c=0.00205385f \
 //x=1.01 //y=6.025 //x2=1.23 //y2=7.23
cc_166 ( N_noxref_3_M4_noxref_g N_noxref_4_c_287_n ) capacitor c=0.00294739f \
 //x=1.45 //y=6.025 //x2=1.23 //y2=7.23
cc_167 ( N_noxref_3_c_166_n N_noxref_4_c_275_n ) capacitor c=0.0113632f \
 //x=1.11 //y=4.585 //x2=0.74 //y2=7.4
cc_168 ( N_noxref_3_c_177_n N_noxref_4_c_275_n ) capacitor c=0.00509436f \
 //x=0.955 //y=4.705 //x2=0.74 //y2=7.4
cc_169 ( N_noxref_3_c_180_n N_noxref_4_c_275_n ) capacitor c=0.00639333f \
 //x=0.955 //y=4.705 //x2=0.74 //y2=7.4
cc_170 ( N_noxref_3_M3_noxref_g N_noxref_4_c_275_n ) capacitor c=0.0165754f \
 //x=1.01 //y=6.025 //x2=0.74 //y2=7.4
cc_171 ( N_noxref_3_c_192_n N_noxref_4_c_275_n ) capacitor c=0.00542539f \
 //x=0.955 //y=4.705 //x2=0.74 //y2=7.4
cc_172 ( N_noxref_3_M3_noxref_g N_noxref_4_c_276_n ) capacitor c=0.00715024f \
 //x=1.01 //y=6.025 //x2=4.07 //y2=7.4
cc_173 ( N_noxref_3_M4_noxref_g N_noxref_4_c_276_n ) capacitor c=0.00754867f \
 //x=1.45 //y=6.025 //x2=4.07 //y2=7.4
cc_174 ( N_noxref_3_M3_noxref_g N_noxref_4_M3_noxref_d ) capacitor \
 c=0.0130453f //x=1.01 //y=6.025 //x2=1.085 //y2=5.025
cc_175 ( N_noxref_3_M4_noxref_g N_noxref_4_M3_noxref_d ) capacitor \
 c=0.0146888f //x=1.45 //y=6.025 //x2=1.085 //y2=5.025
cc_176 ( N_noxref_3_c_191_n N_noxref_4_M3_noxref_d ) capacitor c=0.00248632f \
 //x=1.375 //y=4.795 //x2=1.085 //y2=5.025
cc_177 ( N_noxref_3_c_163_n N_noxref_5_c_349_n ) capacitor c=0.0198635f \
 //x=1.11 //y=2.245 //x2=1.85 //y2=2.21
cc_178 ( N_noxref_3_c_167_n N_noxref_5_c_349_n ) capacitor c=6.64673e-19 \
 //x=1.11 //y=2.08 //x2=1.85 //y2=2.21
cc_179 ( N_noxref_3_c_171_n N_noxref_5_c_349_n ) capacitor c=0.00160374f \
 //x=0.915 //y=1.915 //x2=1.85 //y2=2.21
cc_180 ( N_noxref_3_c_163_n N_noxref_5_c_361_n ) capacitor c=0.00271206f \
 //x=1.11 //y=2.245 //x2=1.85 //y2=4.56
cc_181 ( N_noxref_3_c_166_n N_noxref_5_c_361_n ) capacitor c=0.120243f \
 //x=1.11 //y=4.585 //x2=1.85 //y2=4.56
cc_182 ( N_noxref_3_c_177_n N_noxref_5_c_361_n ) capacitor c=0.00245109f \
 //x=0.955 //y=4.705 //x2=1.85 //y2=4.56
cc_183 ( N_noxref_3_c_180_n N_noxref_5_c_361_n ) capacitor c=8.14108e-19 \
 //x=0.955 //y=4.705 //x2=1.85 //y2=4.56
cc_184 ( N_noxref_3_c_191_n N_noxref_5_c_361_n ) capacitor c=7.4344e-19 \
 //x=1.375 //y=4.795 //x2=1.85 //y2=4.56
cc_185 ( N_noxref_3_c_163_n N_noxref_5_c_350_n ) capacitor c=0.00412829f \
 //x=1.11 //y=2.245 //x2=1.85 //y2=2.08
cc_186 ( N_noxref_3_c_167_n N_noxref_5_c_350_n ) capacitor c=0.00444996f \
 //x=1.11 //y=2.08 //x2=1.85 //y2=2.08
cc_187 ( N_noxref_3_c_171_n N_noxref_5_c_350_n ) capacitor c=0.00284386f \
 //x=0.915 //y=1.915 //x2=1.85 //y2=2.08
cc_188 ( N_noxref_3_c_166_n N_noxref_5_c_363_n ) capacitor c=0.0023775f \
 //x=1.11 //y=4.585 //x2=1.885 //y2=4.705
cc_189 ( N_noxref_3_c_177_n N_noxref_5_c_363_n ) capacitor c=0.00153582f \
 //x=0.955 //y=4.705 //x2=1.885 //y2=4.705
cc_190 ( N_noxref_3_c_180_n N_noxref_5_c_363_n ) capacitor c=0.00234902f \
 //x=0.955 //y=4.705 //x2=1.885 //y2=4.705
cc_191 ( N_noxref_3_c_191_n N_noxref_5_c_363_n ) capacitor c=0.00112509f \
 //x=1.375 //y=4.795 //x2=1.885 //y2=4.705
cc_192 ( N_noxref_3_c_192_n N_noxref_5_c_363_n ) capacitor c=0.00121814f \
 //x=0.955 //y=4.705 //x2=1.885 //y2=4.705
cc_193 ( N_noxref_3_M3_noxref_g N_noxref_5_M5_noxref_g ) capacitor \
 c=0.0101077f //x=1.01 //y=6.025 //x2=1.89 //y2=6.025
cc_194 ( N_noxref_3_M4_noxref_g N_noxref_5_M5_noxref_g ) capacitor c=0.109254f \
 //x=1.45 //y=6.025 //x2=1.89 //y2=6.025
cc_195 ( N_noxref_3_M4_noxref_g N_noxref_5_M6_noxref_g ) capacitor \
 c=0.00945018f //x=1.45 //y=6.025 //x2=2.33 //y2=6.025
cc_196 ( N_noxref_3_c_169_n N_noxref_5_c_353_n ) capacitor c=0.00128177f \
 //x=0.915 //y=0.905 //x2=1.885 //y2=0.905
cc_197 ( N_noxref_3_c_173_n N_noxref_5_c_353_n ) capacitor c=0.0126654f \
 //x=1.445 //y=0.905 //x2=1.885 //y2=0.905
cc_198 ( N_noxref_3_c_229_p N_noxref_5_c_393_n ) capacitor c=0.00149727f \
 //x=0.915 //y=1.25 //x2=1.885 //y2=1.255
cc_199 ( N_noxref_3_c_230_p N_noxref_5_c_393_n ) capacitor c=0.00111802f \
 //x=0.915 //y=1.56 //x2=1.885 //y2=1.255
cc_200 ( N_noxref_3_c_175_n N_noxref_5_c_393_n ) capacitor c=0.0126654f \
 //x=1.445 //y=1.25 //x2=1.885 //y2=1.255
cc_201 ( N_noxref_3_c_230_p N_noxref_5_c_396_n ) capacitor c=0.00116305f \
 //x=0.915 //y=1.56 //x2=1.885 //y2=1.56
cc_202 ( N_noxref_3_c_175_n N_noxref_5_c_396_n ) capacitor c=0.00938322f \
 //x=1.445 //y=1.25 //x2=1.885 //y2=1.56
cc_203 ( N_noxref_3_c_175_n N_noxref_5_c_355_n ) capacitor c=0.00131492f \
 //x=1.445 //y=1.25 //x2=2.26 //y2=1.405
cc_204 ( N_noxref_3_c_173_n N_noxref_5_c_356_n ) capacitor c=0.00135327f \
 //x=1.445 //y=0.905 //x2=2.415 //y2=0.905
cc_205 ( N_noxref_3_c_175_n N_noxref_5_c_400_n ) capacitor c=0.00151998f \
 //x=1.445 //y=1.25 //x2=2.415 //y2=1.255
cc_206 ( N_noxref_3_c_163_n N_noxref_5_c_358_n ) capacitor c=0.00184232f \
 //x=1.11 //y=2.245 //x2=1.85 //y2=2.08
cc_207 ( N_noxref_3_c_167_n N_noxref_5_c_358_n ) capacitor c=0.00266357f \
 //x=1.11 //y=2.08 //x2=1.85 //y2=2.08
cc_208 ( N_noxref_3_c_171_n N_noxref_5_c_358_n ) capacitor c=0.0177224f \
 //x=0.915 //y=1.915 //x2=1.85 //y2=2.08
cc_209 ( N_noxref_3_c_171_n N_noxref_5_c_404_n ) capacitor c=0.00636965f \
 //x=0.915 //y=1.915 //x2=1.85 //y2=1.915
cc_210 ( N_noxref_3_c_166_n N_noxref_5_c_371_n ) capacitor c=0.00117002f \
 //x=1.11 //y=4.585 //x2=1.885 //y2=4.705
cc_211 ( N_noxref_3_c_177_n N_noxref_5_c_371_n ) capacitor c=4.66993e-19 \
 //x=0.955 //y=4.705 //x2=1.885 //y2=4.705
cc_212 ( N_noxref_3_c_180_n N_noxref_5_c_371_n ) capacitor c=0.0022472f \
 //x=0.955 //y=4.705 //x2=1.885 //y2=4.705
cc_213 ( N_noxref_3_c_191_n N_noxref_5_c_371_n ) capacitor c=0.019933f \
 //x=1.375 //y=4.795 //x2=1.885 //y2=4.705
cc_214 ( N_noxref_3_c_192_n N_noxref_5_c_371_n ) capacitor c=0.00590438f \
 //x=0.955 //y=4.705 //x2=1.885 //y2=4.705
cc_215 ( N_noxref_3_c_166_n N_noxref_6_c_486_n ) capacitor c=0.00418084f \
 //x=1.11 //y=4.585 //x2=2.96 //y2=4.585
cc_216 ( N_noxref_3_c_180_n N_noxref_6_c_486_n ) capacitor c=2.52182e-19 \
 //x=0.955 //y=4.705 //x2=2.96 //y2=4.585
cc_217 ( N_noxref_3_c_163_n N_noxref_8_c_657_n ) capacitor c=0.00147045f \
 //x=1.11 //y=2.245 //x2=1.18 //y2=1.13
cc_218 ( N_noxref_3_c_167_n N_noxref_8_c_657_n ) capacitor c=7.07025e-19 \
 //x=1.11 //y=2.08 //x2=1.18 //y2=1.13
cc_219 ( N_noxref_3_c_169_n N_noxref_8_c_657_n ) capacitor c=7.80351e-19 \
 //x=0.915 //y=0.905 //x2=1.18 //y2=1.13
cc_220 ( N_noxref_3_c_229_p N_noxref_8_c_657_n ) capacitor c=0.00391325f \
 //x=0.915 //y=1.25 //x2=1.18 //y2=1.13
cc_221 ( N_noxref_3_c_252_p N_noxref_8_c_657_n ) capacitor c=5.34749e-19 \
 //x=1.29 //y=0.75 //x2=1.18 //y2=1.13
cc_222 ( N_noxref_3_c_253_p N_noxref_8_c_657_n ) capacitor c=6.20502e-19 \
 //x=1.29 //y=1.405 //x2=1.18 //y2=1.13
cc_223 ( N_noxref_3_c_173_n N_noxref_8_c_657_n ) capacitor c=9.60468e-19 \
 //x=1.445 //y=0.905 //x2=1.18 //y2=1.13
cc_224 ( N_noxref_3_c_175_n N_noxref_8_c_657_n ) capacitor c=0.00221072f \
 //x=1.445 //y=1.25 //x2=1.18 //y2=1.13
cc_225 ( N_noxref_3_c_229_p N_noxref_8_c_661_n ) capacitor c=0.00127432f \
 //x=0.915 //y=1.25 //x2=1.18 //y2=1.57
cc_226 ( N_noxref_3_c_230_p N_noxref_8_c_661_n ) capacitor c=0.00350316f \
 //x=0.915 //y=1.56 //x2=1.18 //y2=1.57
cc_227 ( N_noxref_3_c_171_n N_noxref_8_c_661_n ) capacitor c=0.00379925f \
 //x=0.915 //y=1.915 //x2=1.18 //y2=1.57
cc_228 ( N_noxref_3_c_253_p N_noxref_8_c_661_n ) capacitor c=0.00702073f \
 //x=1.29 //y=1.405 //x2=1.18 //y2=1.57
cc_229 ( N_noxref_3_c_175_n N_noxref_8_c_661_n ) capacitor c=0.00253555f \
 //x=1.445 //y=1.25 //x2=1.18 //y2=1.57
cc_230 ( N_noxref_3_c_175_n N_noxref_8_c_662_n ) capacitor c=7.25274e-19 \
 //x=1.445 //y=1.25 //x2=2.065 //y2=1.655
cc_231 ( N_noxref_3_c_163_n N_noxref_8_c_696_n ) capacitor c=0.0171527f \
 //x=1.11 //y=2.245 //x2=1.265 //y2=1.655
cc_232 ( N_noxref_3_c_167_n N_noxref_8_c_696_n ) capacitor c=0.00293491f \
 //x=1.11 //y=2.08 //x2=1.265 //y2=1.655
cc_233 ( N_noxref_3_c_171_n N_noxref_8_c_696_n ) capacitor c=0.00113924f \
 //x=0.915 //y=1.915 //x2=1.265 //y2=1.655
cc_234 ( N_noxref_3_c_175_n N_noxref_8_c_670_n ) capacitor c=6.29838e-19 \
 //x=1.445 //y=1.25 //x2=2.15 //y2=1.57
cc_235 ( N_noxref_3_c_163_n N_noxref_8_M0_noxref_d ) capacitor c=0.00138074f \
 //x=1.11 //y=2.245 //x2=0.99 //y2=0.905
cc_236 ( N_noxref_3_c_167_n N_noxref_8_M0_noxref_d ) capacitor c=0.00150031f \
 //x=1.11 //y=2.08 //x2=0.99 //y2=0.905
cc_237 ( N_noxref_3_c_169_n N_noxref_8_M0_noxref_d ) capacitor c=8.46111e-19 \
 //x=0.915 //y=0.905 //x2=0.99 //y2=0.905
cc_238 ( N_noxref_3_c_229_p N_noxref_8_M0_noxref_d ) capacitor c=0.00237422f \
 //x=0.915 //y=1.25 //x2=0.99 //y2=0.905
cc_239 ( N_noxref_3_c_171_n N_noxref_8_M0_noxref_d ) capacitor c=4.64071e-19 \
 //x=0.915 //y=1.915 //x2=0.99 //y2=0.905
cc_240 ( N_noxref_3_c_252_p N_noxref_8_M0_noxref_d ) capacitor c=0.0020782f \
 //x=1.29 //y=0.75 //x2=0.99 //y2=0.905
cc_241 ( N_noxref_3_c_253_p N_noxref_8_M0_noxref_d ) capacitor c=0.00344131f \
 //x=1.29 //y=1.405 //x2=0.99 //y2=0.905
cc_242 ( N_noxref_3_c_173_n N_noxref_8_M0_noxref_d ) capacitor c=0.00139206f \
 //x=1.445 //y=0.905 //x2=0.99 //y2=0.905
cc_243 ( N_noxref_3_c_175_n N_noxref_8_M0_noxref_d ) capacitor c=0.00237422f \
 //x=1.445 //y=1.25 //x2=0.99 //y2=0.905
cc_244 ( N_noxref_4_c_276_n N_noxref_5_M5_noxref_g ) capacitor c=0.00720241f \
 //x=4.07 //y=7.4 //x2=1.89 //y2=6.025
cc_245 ( N_noxref_4_c_276_n N_noxref_5_M6_noxref_g ) capacitor c=0.00776897f \
 //x=4.07 //y=7.4 //x2=2.33 //y2=6.025
cc_246 ( N_noxref_4_c_276_n N_noxref_6_c_488_n ) capacitor c=0.0018189f \
 //x=4.07 //y=7.4 //x2=2.96 //y2=4.705
cc_247 ( N_noxref_4_c_276_n N_noxref_6_M7_noxref_g ) capacitor c=0.00776897f \
 //x=4.07 //y=7.4 //x2=3.37 //y2=6.025
cc_248 ( N_noxref_4_c_276_n N_noxref_6_M8_noxref_g ) capacitor c=0.00776897f \
 //x=4.07 //y=7.4 //x2=3.81 //y2=6.025
cc_249 ( N_noxref_4_c_276_n N_noxref_6_c_491_n ) capacitor c=0.0265828f \
 //x=4.07 //y=7.4 //x2=3.735 //y2=4.795
cc_250 ( N_noxref_4_c_291_n N_noxref_7_c_581_n ) capacitor c=0.00445638f \
 //x=4.07 //y=7.4 //x2=3.065 //y2=5.21
cc_251 ( N_noxref_4_c_276_n N_noxref_7_c_581_n ) capacitor c=0.00365337f \
 //x=4.07 //y=7.4 //x2=3.065 //y2=5.21
cc_252 ( N_noxref_4_c_276_n N_noxref_7_c_602_n ) capacitor c=0.00219567f \
 //x=4.07 //y=7.4 //x2=3.915 //y2=6.91
cc_253 ( N_noxref_4_c_291_n N_noxref_7_c_590_n ) capacitor c=0.097658f \
 //x=4.07 //y=7.4 //x2=3.15 //y2=6.74
cc_254 ( N_noxref_4_c_276_n N_noxref_7_c_590_n ) capacitor c=0.023347f \
 //x=4.07 //y=7.4 //x2=3.15 //y2=6.74
cc_255 ( N_noxref_4_c_291_n N_noxref_7_c_593_n ) capacitor c=0.00187652f \
 //x=4.07 //y=7.4 //x2=4.03 //y2=6.74
cc_256 ( N_noxref_4_c_276_n N_noxref_7_c_593_n ) capacitor c=0.0134255f \
 //x=4.07 //y=7.4 //x2=4.03 //y2=6.74
cc_257 ( N_noxref_4_c_276_n N_noxref_7_c_594_n ) capacitor c=0.00663439f \
 //x=4.07 //y=7.4 //x2=2.11 //y2=5.38
cc_258 ( N_noxref_4_M3_noxref_d N_noxref_7_c_594_n ) capacitor c=0.00557191f \
 //x=1.085 //y=5.025 //x2=2.11 //y2=5.38
cc_259 ( N_noxref_4_c_291_n N_noxref_7_c_598_n ) capacitor c=0.00206634f \
 //x=4.07 //y=7.4 //x2=3.15 //y2=5.72
cc_260 ( N_noxref_4_c_276_n N_noxref_7_c_598_n ) capacitor c=0.00958662f \
 //x=4.07 //y=7.4 //x2=3.15 //y2=5.72
cc_261 ( N_noxref_4_c_291_n N_noxref_7_M8_noxref_d ) capacitor c=0.00206634f \
 //x=4.07 //y=7.4 //x2=3.885 //y2=5.025
cc_262 ( N_noxref_4_c_276_n N_noxref_7_M8_noxref_d ) capacitor c=0.0535064f \
 //x=4.07 //y=7.4 //x2=3.885 //y2=5.025
cc_263 ( N_noxref_4_c_276_n N_noxref_8_c_726_n ) capacitor c=0.0052314f \
 //x=4.07 //y=7.4 //x2=3.59 //y2=5.59
cc_264 ( N_noxref_4_c_276_n N_noxref_8_c_727_n ) capacitor c=0.0354f //x=4.07 \
 //y=7.4 //x2=3.7 //y2=5.125
cc_265 ( N_noxref_4_c_276_n N_noxref_8_c_698_n ) capacitor c=0.00924393f \
 //x=4.07 //y=7.4 //x2=3.59 //y2=5.72
cc_266 ( N_noxref_5_c_349_n N_noxref_6_c_477_n ) capacitor c=0.0115855f \
 //x=1.85 //y=2.21 //x2=2.96 //y2=2.225
cc_267 ( N_noxref_5_c_361_n N_noxref_6_c_477_n ) capacitor c=6.43877e-19 \
 //x=1.85 //y=4.56 //x2=2.96 //y2=2.225
cc_268 ( N_noxref_5_c_350_n N_noxref_6_c_477_n ) capacitor c=5.84901e-19 \
 //x=1.85 //y=2.08 //x2=2.96 //y2=2.225
cc_269 ( N_noxref_5_c_361_n N_noxref_6_c_486_n ) capacitor c=0.0846712f \
 //x=1.85 //y=4.56 //x2=2.96 //y2=4.585
cc_270 ( N_noxref_5_c_363_n N_noxref_6_c_486_n ) capacitor c=9.78721e-19 \
 //x=1.885 //y=4.705 //x2=2.96 //y2=4.585
cc_271 ( N_noxref_5_c_349_n N_noxref_6_c_478_n ) capacitor c=4.43682e-19 \
 //x=1.85 //y=2.21 //x2=2.96 //y2=2.08
cc_272 ( N_noxref_5_c_350_n N_noxref_6_c_478_n ) capacitor c=0.00114266f \
 //x=1.85 //y=2.08 //x2=2.96 //y2=2.08
cc_273 ( N_noxref_5_c_358_n N_noxref_6_c_478_n ) capacitor c=3.80079e-19 \
 //x=1.85 //y=2.08 //x2=2.96 //y2=2.08
cc_274 ( N_noxref_5_c_361_n N_noxref_6_c_488_n ) capacitor c=8.51262e-19 \
 //x=1.85 //y=4.56 //x2=2.96 //y2=4.705
cc_275 ( N_noxref_5_c_363_n N_noxref_6_c_488_n ) capacitor c=0.00124702f \
 //x=1.885 //y=4.705 //x2=2.96 //y2=4.705
cc_276 ( N_noxref_5_c_371_n N_noxref_6_c_488_n ) capacitor c=4.01223e-19 \
 //x=1.885 //y=4.705 //x2=2.96 //y2=4.705
cc_277 ( N_noxref_5_M6_noxref_g N_noxref_6_M7_noxref_g ) capacitor \
 c=0.0359752f //x=2.33 //y=6.025 //x2=3.37 //y2=6.025
cc_278 ( N_noxref_5_c_353_n N_noxref_6_c_480_n ) capacitor c=0.00133966f \
 //x=1.885 //y=0.905 //x2=2.855 //y2=0.905
cc_279 ( N_noxref_5_c_356_n N_noxref_6_c_480_n ) capacitor c=0.00886682f \
 //x=2.415 //y=0.905 //x2=2.855 //y2=0.905
cc_280 ( N_noxref_5_c_393_n N_noxref_6_c_506_n ) capacitor c=0.0015172f \
 //x=1.885 //y=1.255 //x2=2.855 //y2=1.255
cc_281 ( N_noxref_5_c_400_n N_noxref_6_c_506_n ) capacitor c=0.00886682f \
 //x=2.415 //y=1.255 //x2=2.855 //y2=1.255
cc_282 ( N_noxref_5_c_396_n N_noxref_6_c_508_n ) capacitor c=0.00296957f \
 //x=1.885 //y=1.56 //x2=2.855 //y2=1.56
cc_283 ( N_noxref_5_c_355_n N_noxref_6_c_508_n ) capacitor c=0.0182761f \
 //x=2.26 //y=1.405 //x2=2.855 //y2=1.56
cc_284 ( N_noxref_5_c_404_n N_noxref_6_c_510_n ) capacitor c=0.00581071f \
 //x=1.85 //y=1.915 //x2=2.855 //y2=1.915
cc_285 ( N_noxref_5_c_355_n N_noxref_6_c_482_n ) capacitor c=0.00131492f \
 //x=2.26 //y=1.405 //x2=3.23 //y2=1.405
cc_286 ( N_noxref_5_c_356_n N_noxref_6_c_483_n ) capacitor c=0.00135327f \
 //x=2.415 //y=0.905 //x2=3.385 //y2=0.905
cc_287 ( N_noxref_5_c_400_n N_noxref_6_c_513_n ) capacitor c=0.0015172f \
 //x=2.415 //y=1.255 //x2=3.385 //y2=1.255
cc_288 ( N_noxref_5_c_349_n N_noxref_6_c_485_n ) capacitor c=0.00151737f \
 //x=1.85 //y=2.21 //x2=2.855 //y2=2.08
cc_289 ( N_noxref_5_c_350_n N_noxref_6_c_485_n ) capacitor c=0.0021413f \
 //x=1.85 //y=2.08 //x2=2.855 //y2=2.08
cc_290 ( N_noxref_5_c_358_n N_noxref_6_c_485_n ) capacitor c=0.00926648f \
 //x=1.85 //y=2.08 //x2=2.855 //y2=2.08
cc_291 ( N_noxref_5_c_361_n N_noxref_6_c_517_n ) capacitor c=0.00135035f \
 //x=1.85 //y=4.56 //x2=2.96 //y2=4.705
cc_292 ( N_noxref_5_c_363_n N_noxref_6_c_517_n ) capacitor c=0.00193614f \
 //x=1.885 //y=4.705 //x2=2.96 //y2=4.705
cc_293 ( N_noxref_5_c_439_p N_noxref_6_c_517_n ) capacitor c=0.0107159f \
 //x=2.255 //y=4.795 //x2=2.96 //y2=4.705
cc_294 ( N_noxref_5_c_371_n N_noxref_6_c_517_n ) capacitor c=0.0051116f \
 //x=1.885 //y=4.705 //x2=2.96 //y2=4.705
cc_295 ( N_noxref_5_M6_noxref_g N_noxref_7_c_581_n ) capacitor c=0.0108199f \
 //x=2.33 //y=6.025 //x2=3.065 //y2=5.21
cc_296 ( N_noxref_5_M6_noxref_g N_noxref_7_c_584_n ) capacitor c=0.00165119f \
 //x=2.33 //y=6.025 //x2=3.15 //y2=5.59
cc_297 ( N_noxref_5_c_361_n N_noxref_7_c_586_n ) capacitor c=9.00765e-19 \
 //x=1.85 //y=4.56 //x2=2.11 //y2=5.21
cc_298 ( N_noxref_5_M5_noxref_g N_noxref_7_c_586_n ) capacitor c=0.00186001f \
 //x=1.89 //y=6.025 //x2=2.11 //y2=5.21
cc_299 ( N_noxref_5_M6_noxref_g N_noxref_7_c_586_n ) capacitor c=0.00210236f \
 //x=2.33 //y=6.025 //x2=2.11 //y2=5.21
cc_300 ( N_noxref_5_c_439_p N_noxref_7_c_586_n ) capacitor c=0.00213157f \
 //x=2.255 //y=4.795 //x2=2.11 //y2=5.21
cc_301 ( N_noxref_5_M6_noxref_g N_noxref_7_c_590_n ) capacitor c=4.79118e-19 \
 //x=2.33 //y=6.025 //x2=3.15 //y2=6.74
cc_302 ( N_noxref_5_M5_noxref_g N_noxref_7_c_594_n ) capacitor c=0.0120591f \
 //x=1.89 //y=6.025 //x2=2.11 //y2=5.38
cc_303 ( N_noxref_5_M6_noxref_g N_noxref_7_c_594_n ) capacitor c=0.0159649f \
 //x=2.33 //y=6.025 //x2=2.11 //y2=5.38
cc_304 ( N_noxref_5_c_439_p N_noxref_7_c_594_n ) capacitor c=0.00293135f \
 //x=2.255 //y=4.795 //x2=2.11 //y2=5.38
cc_305 ( N_noxref_5_c_396_n N_noxref_8_c_661_n ) capacitor c=6.83023e-19 \
 //x=1.885 //y=1.56 //x2=1.18 //y2=1.57
cc_306 ( N_noxref_5_c_349_n N_noxref_8_c_662_n ) capacitor c=0.0308091f \
 //x=1.85 //y=2.21 //x2=2.065 //y2=1.655
cc_307 ( N_noxref_5_c_361_n N_noxref_8_c_662_n ) capacitor c=3.68612e-19 \
 //x=1.85 //y=4.56 //x2=2.065 //y2=1.655
cc_308 ( N_noxref_5_c_350_n N_noxref_8_c_662_n ) capacitor c=0.00494853f \
 //x=1.85 //y=2.08 //x2=2.065 //y2=1.655
cc_309 ( N_noxref_5_c_358_n N_noxref_8_c_662_n ) capacitor c=0.00139093f \
 //x=1.85 //y=2.08 //x2=2.065 //y2=1.655
cc_310 ( N_noxref_5_c_404_n N_noxref_8_c_662_n ) capacitor c=0.00778097f \
 //x=1.85 //y=1.915 //x2=2.065 //y2=1.655
cc_311 ( N_noxref_5_c_353_n N_noxref_8_c_666_n ) capacitor c=8.454e-19 \
 //x=1.885 //y=0.905 //x2=2.15 //y2=1.13
cc_312 ( N_noxref_5_c_393_n N_noxref_8_c_666_n ) capacitor c=0.00221072f \
 //x=1.885 //y=1.255 //x2=2.15 //y2=1.13
cc_313 ( N_noxref_5_c_459_p N_noxref_8_c_666_n ) capacitor c=5.42035e-19 \
 //x=2.26 //y=0.75 //x2=2.15 //y2=1.13
cc_314 ( N_noxref_5_c_355_n N_noxref_8_c_666_n ) capacitor c=7.84428e-19 \
 //x=2.26 //y=1.405 //x2=2.15 //y2=1.13
cc_315 ( N_noxref_5_c_356_n N_noxref_8_c_666_n ) capacitor c=7.61925e-19 \
 //x=2.415 //y=0.905 //x2=2.15 //y2=1.13
cc_316 ( N_noxref_5_c_400_n N_noxref_8_c_666_n ) capacitor c=0.00220852f \
 //x=2.415 //y=1.255 //x2=2.15 //y2=1.13
cc_317 ( N_noxref_5_c_393_n N_noxref_8_c_670_n ) capacitor c=7.7986e-19 \
 //x=1.885 //y=1.255 //x2=2.15 //y2=1.57
cc_318 ( N_noxref_5_c_396_n N_noxref_8_c_670_n ) capacitor c=0.00253868f \
 //x=1.885 //y=1.56 //x2=2.15 //y2=1.57
cc_319 ( N_noxref_5_c_355_n N_noxref_8_c_670_n ) capacitor c=0.00845712f \
 //x=2.26 //y=1.405 //x2=2.15 //y2=1.57
cc_320 ( N_noxref_5_c_400_n N_noxref_8_c_670_n ) capacitor c=7.7986e-19 \
 //x=2.415 //y=1.255 //x2=2.15 //y2=1.57
cc_321 ( N_noxref_5_c_355_n N_noxref_8_c_671_n ) capacitor c=7.25274e-19 \
 //x=2.26 //y=1.405 //x2=3.035 //y2=1.655
cc_322 ( N_noxref_5_c_355_n N_noxref_8_c_679_n ) capacitor c=6.29838e-19 \
 //x=2.26 //y=1.405 //x2=3.12 //y2=1.57
cc_323 ( N_noxref_5_c_349_n N_noxref_8_c_727_n ) capacitor c=3.05675e-19 \
 //x=1.85 //y=2.21 //x2=3.7 //y2=5.125
cc_324 ( N_noxref_5_c_361_n N_noxref_8_c_727_n ) capacitor c=0.00421067f \
 //x=1.85 //y=4.56 //x2=3.7 //y2=5.125
cc_325 ( N_noxref_5_c_353_n N_noxref_8_M1_noxref_d ) capacitor c=8.51904e-19 \
 //x=1.885 //y=0.905 //x2=1.96 //y2=0.905
cc_326 ( N_noxref_5_c_393_n N_noxref_8_M1_noxref_d ) capacitor c=0.00237422f \
 //x=1.885 //y=1.255 //x2=1.96 //y2=0.905
cc_327 ( N_noxref_5_c_459_p N_noxref_8_M1_noxref_d ) capacitor c=0.0020782f \
 //x=2.26 //y=0.75 //x2=1.96 //y2=0.905
cc_328 ( N_noxref_5_c_355_n N_noxref_8_M1_noxref_d ) capacitor c=0.00356097f \
 //x=2.26 //y=1.405 //x2=1.96 //y2=0.905
cc_329 ( N_noxref_5_c_356_n N_noxref_8_M1_noxref_d ) capacitor c=8.55887e-19 \
 //x=2.415 //y=0.905 //x2=1.96 //y2=0.905
cc_330 ( N_noxref_5_c_400_n N_noxref_8_M1_noxref_d ) capacitor c=0.00237422f \
 //x=2.415 //y=1.255 //x2=1.96 //y2=0.905
cc_331 ( N_noxref_6_c_477_n N_noxref_7_c_581_n ) capacitor c=3.89231e-19 \
 //x=2.96 //y=2.225 //x2=3.065 //y2=5.21
cc_332 ( N_noxref_6_c_486_n N_noxref_7_c_581_n ) capacitor c=0.02207f //x=2.96 \
 //y=4.585 //x2=3.065 //y2=5.21
cc_333 ( N_noxref_6_c_488_n N_noxref_7_c_581_n ) capacitor c=0.00449448f \
 //x=2.96 //y=4.705 //x2=3.065 //y2=5.21
cc_334 ( N_noxref_6_M7_noxref_g N_noxref_7_c_581_n ) capacitor c=0.00412344f \
 //x=3.37 //y=6.025 //x2=3.065 //y2=5.21
cc_335 ( N_noxref_6_c_517_n N_noxref_7_c_581_n ) capacitor c=0.00462848f \
 //x=2.96 //y=4.705 //x2=3.065 //y2=5.21
cc_336 ( N_noxref_6_M7_noxref_g N_noxref_7_c_584_n ) capacitor c=0.0025714f \
 //x=3.37 //y=6.025 //x2=3.15 //y2=5.59
cc_337 ( N_noxref_6_c_527_p N_noxref_7_c_584_n ) capacitor c=6.67396e-19 \
 //x=3.295 //y=4.795 //x2=3.15 //y2=5.59
cc_338 ( N_noxref_6_M7_noxref_g N_noxref_7_c_602_n ) capacitor c=0.00998354f \
 //x=3.37 //y=6.025 //x2=3.915 //y2=6.91
cc_339 ( N_noxref_6_M8_noxref_g N_noxref_7_c_602_n ) capacitor c=0.0104174f \
 //x=3.81 //y=6.025 //x2=3.915 //y2=6.91
cc_340 ( N_noxref_6_M7_noxref_g N_noxref_7_c_590_n ) capacitor c=0.00266045f \
 //x=3.37 //y=6.025 //x2=3.15 //y2=6.74
cc_341 ( N_noxref_6_M8_noxref_g N_noxref_7_c_593_n ) capacitor c=0.00394587f \
 //x=3.81 //y=6.025 //x2=4.03 //y2=6.74
cc_342 ( N_noxref_6_c_486_n N_noxref_7_c_598_n ) capacitor c=3.85234e-19 \
 //x=2.96 //y=4.585 //x2=3.15 //y2=5.72
cc_343 ( N_noxref_6_M7_noxref_g N_noxref_7_c_598_n ) capacitor c=0.0227892f \
 //x=3.37 //y=6.025 //x2=3.15 //y2=5.72
cc_344 ( N_noxref_6_c_517_n N_noxref_7_c_598_n ) capacitor c=0.00281079f \
 //x=2.96 //y=4.705 //x2=3.15 //y2=5.72
cc_345 ( N_noxref_6_M8_noxref_g N_noxref_7_M8_noxref_d ) capacitor \
 c=0.0365206f //x=3.81 //y=6.025 //x2=3.885 //y2=5.025
cc_346 ( N_noxref_6_c_508_n N_noxref_8_c_670_n ) capacitor c=0.00120307f \
 //x=2.855 //y=1.56 //x2=2.15 //y2=1.57
cc_347 ( N_noxref_6_c_477_n N_noxref_8_c_671_n ) capacitor c=0.0286668f \
 //x=2.96 //y=2.225 //x2=3.035 //y2=1.655
cc_348 ( N_noxref_6_c_478_n N_noxref_8_c_671_n ) capacitor c=0.00451548f \
 //x=2.96 //y=2.08 //x2=3.035 //y2=1.655
cc_349 ( N_noxref_6_c_510_n N_noxref_8_c_671_n ) capacitor c=0.00915686f \
 //x=2.855 //y=1.915 //x2=3.035 //y2=1.655
cc_350 ( N_noxref_6_c_485_n N_noxref_8_c_671_n ) capacitor c=0.00129562f \
 //x=2.855 //y=2.08 //x2=3.035 //y2=1.655
cc_351 ( N_noxref_6_c_478_n N_noxref_8_c_675_n ) capacitor c=2.35917e-19 \
 //x=2.96 //y=2.08 //x2=3.12 //y2=1.145
cc_352 ( N_noxref_6_c_480_n N_noxref_8_c_675_n ) capacitor c=0.00114203f \
 //x=2.855 //y=0.905 //x2=3.12 //y2=1.145
cc_353 ( N_noxref_6_c_506_n N_noxref_8_c_675_n ) capacitor c=0.00235402f \
 //x=2.855 //y=1.255 //x2=3.12 //y2=1.145
cc_354 ( N_noxref_6_c_544_p N_noxref_8_c_675_n ) capacitor c=5.45609e-19 \
 //x=3.23 //y=0.75 //x2=3.12 //y2=1.145
cc_355 ( N_noxref_6_c_482_n N_noxref_8_c_675_n ) capacitor c=4.1601e-19 \
 //x=3.23 //y=1.405 //x2=3.12 //y2=1.145
cc_356 ( N_noxref_6_c_483_n N_noxref_8_c_675_n ) capacitor c=0.00103216f \
 //x=3.385 //y=0.905 //x2=3.12 //y2=1.145
cc_357 ( N_noxref_6_c_513_n N_noxref_8_c_675_n ) capacitor c=0.00416435f \
 //x=3.385 //y=1.255 //x2=3.12 //y2=1.145
cc_358 ( N_noxref_6_c_506_n N_noxref_8_c_679_n ) capacitor c=7.7986e-19 \
 //x=2.855 //y=1.255 //x2=3.12 //y2=1.57
cc_359 ( N_noxref_6_c_508_n N_noxref_8_c_679_n ) capacitor c=0.0030633f \
 //x=2.855 //y=1.56 //x2=3.12 //y2=1.57
cc_360 ( N_noxref_6_c_482_n N_noxref_8_c_679_n ) capacitor c=0.00944764f \
 //x=3.23 //y=1.405 //x2=3.12 //y2=1.57
cc_361 ( N_noxref_6_c_513_n N_noxref_8_c_679_n ) capacitor c=0.00135417f \
 //x=3.385 //y=1.255 //x2=3.12 //y2=1.57
cc_362 ( N_noxref_6_c_482_n N_noxref_8_c_681_n ) capacitor c=0.0045388f \
 //x=3.23 //y=1.405 //x2=3.615 //y2=1.655
cc_363 ( N_noxref_6_M7_noxref_g N_noxref_8_c_726_n ) capacitor c=0.00140876f \
 //x=3.37 //y=6.025 //x2=3.59 //y2=5.59
cc_364 ( N_noxref_6_M8_noxref_g N_noxref_8_c_726_n ) capacitor c=0.00854816f \
 //x=3.81 //y=6.025 //x2=3.59 //y2=5.59
cc_365 ( N_noxref_6_c_477_n N_noxref_8_c_727_n ) capacitor c=0.0161611f \
 //x=2.96 //y=2.225 //x2=3.7 //y2=5.125
cc_366 ( N_noxref_6_c_486_n N_noxref_8_c_727_n ) capacitor c=0.128969f \
 //x=2.96 //y=4.585 //x2=3.7 //y2=5.125
cc_367 ( N_noxref_6_c_478_n N_noxref_8_c_727_n ) capacitor c=0.0048697f \
 //x=2.96 //y=2.08 //x2=3.7 //y2=5.125
cc_368 ( N_noxref_6_c_488_n N_noxref_8_c_727_n ) capacitor c=0.0055568f \
 //x=2.96 //y=4.705 //x2=3.7 //y2=5.125
cc_369 ( N_noxref_6_M7_noxref_g N_noxref_8_c_727_n ) capacitor c=0.00478791f \
 //x=3.37 //y=6.025 //x2=3.7 //y2=5.125
cc_370 ( N_noxref_6_M8_noxref_g N_noxref_8_c_727_n ) capacitor c=0.00450478f \
 //x=3.81 //y=6.025 //x2=3.7 //y2=5.125
cc_371 ( N_noxref_6_c_510_n N_noxref_8_c_727_n ) capacitor c=0.00300603f \
 //x=2.855 //y=1.915 //x2=3.7 //y2=5.125
cc_372 ( N_noxref_6_c_491_n N_noxref_8_c_727_n ) capacitor c=0.00872849f \
 //x=3.735 //y=4.795 //x2=3.7 //y2=5.125
cc_373 ( N_noxref_6_c_485_n N_noxref_8_c_727_n ) capacitor c=0.00278769f \
 //x=2.855 //y=2.08 //x2=3.7 //y2=5.125
cc_374 ( N_noxref_6_c_517_n N_noxref_8_c_727_n ) capacitor c=0.00140919f \
 //x=2.96 //y=4.705 //x2=3.7 //y2=5.125
cc_375 ( N_noxref_6_c_477_n N_noxref_8_c_784_n ) capacitor c=0.00327478f \
 //x=2.96 //y=2.225 //x2=3.12 //y2=1.655
cc_376 ( N_noxref_6_c_478_n N_noxref_8_c_784_n ) capacitor c=0.00154812f \
 //x=2.96 //y=2.08 //x2=3.12 //y2=1.655
cc_377 ( N_noxref_6_M7_noxref_g N_noxref_8_c_697_n ) capacitor c=0.00234737f \
 //x=3.37 //y=6.025 //x2=3.7 //y2=5.21
cc_378 ( N_noxref_6_M8_noxref_g N_noxref_8_c_697_n ) capacitor c=0.00478286f \
 //x=3.81 //y=6.025 //x2=3.7 //y2=5.21
cc_379 ( N_noxref_6_c_491_n N_noxref_8_c_697_n ) capacitor c=0.00162779f \
 //x=3.735 //y=4.795 //x2=3.7 //y2=5.21
cc_380 ( N_noxref_6_M7_noxref_g N_noxref_8_c_698_n ) capacitor c=0.00896756f \
 //x=3.37 //y=6.025 //x2=3.59 //y2=5.72
cc_381 ( N_noxref_6_M8_noxref_g N_noxref_8_c_698_n ) capacitor c=0.00896756f \
 //x=3.81 //y=6.025 //x2=3.59 //y2=5.72
cc_382 ( N_noxref_6_c_491_n N_noxref_8_c_698_n ) capacitor c=0.00165738f \
 //x=3.735 //y=4.795 //x2=3.59 //y2=5.72
cc_383 ( N_noxref_6_c_477_n N_noxref_8_M2_noxref_d ) capacitor c=8.91766e-19 \
 //x=2.96 //y=2.225 //x2=2.93 //y2=0.905
cc_384 ( N_noxref_6_c_478_n N_noxref_8_M2_noxref_d ) capacitor c=5.40451e-19 \
 //x=2.96 //y=2.08 //x2=2.93 //y2=0.905
cc_385 ( N_noxref_6_c_480_n N_noxref_8_M2_noxref_d ) capacitor c=0.00145956f \
 //x=2.855 //y=0.905 //x2=2.93 //y2=0.905
cc_386 ( N_noxref_6_c_506_n N_noxref_8_M2_noxref_d ) capacitor c=0.00237422f \
 //x=2.855 //y=1.255 //x2=2.93 //y2=0.905
cc_387 ( N_noxref_6_c_544_p N_noxref_8_M2_noxref_d ) capacitor c=0.0020782f \
 //x=3.23 //y=0.75 //x2=2.93 //y2=0.905
cc_388 ( N_noxref_6_c_482_n N_noxref_8_M2_noxref_d ) capacitor c=0.003549f \
 //x=3.23 //y=1.405 //x2=2.93 //y2=0.905
cc_389 ( N_noxref_6_c_483_n N_noxref_8_M2_noxref_d ) capacitor c=8.55887e-19 \
 //x=3.385 //y=0.905 //x2=2.93 //y2=0.905
cc_390 ( N_noxref_6_c_513_n N_noxref_8_M2_noxref_d ) capacitor c=0.00237422f \
 //x=3.385 //y=1.255 //x2=2.93 //y2=0.905
cc_391 ( N_noxref_7_c_586_n N_noxref_8_c_662_n ) capacitor c=0.00522451f \
 //x=2.11 //y=5.21 //x2=2.065 //y2=1.655
cc_392 ( N_noxref_7_c_581_n N_noxref_8_c_666_n ) capacitor c=2.03695e-19 \
 //x=3.065 //y=5.21 //x2=2.15 //y2=1.13
cc_393 ( N_noxref_7_c_586_n N_noxref_8_c_666_n ) capacitor c=2.29432e-19 \
 //x=2.11 //y=5.21 //x2=2.15 //y2=1.13
cc_394 ( N_noxref_7_c_581_n N_noxref_8_c_671_n ) capacitor c=0.00500529f \
 //x=3.065 //y=5.21 //x2=3.035 //y2=1.655
cc_395 ( N_noxref_7_c_584_n N_noxref_8_c_681_n ) capacitor c=3.49767e-19 \
 //x=3.15 //y=5.59 //x2=3.615 //y2=1.655
cc_396 ( N_noxref_7_c_584_n N_noxref_8_c_726_n ) capacitor c=0.0589193f \
 //x=3.15 //y=5.59 //x2=3.59 //y2=5.59
cc_397 ( N_noxref_7_c_602_n N_noxref_8_c_726_n ) capacitor c=0.00729607f \
 //x=3.915 //y=6.91 //x2=3.59 //y2=5.59
cc_398 ( N_noxref_7_c_586_n N_noxref_8_c_726_n ) capacitor c=0.00100155f \
 //x=2.11 //y=5.21 //x2=3.59 //y2=5.59
cc_399 ( N_noxref_7_c_598_n N_noxref_8_c_726_n ) capacitor c=0.00425215f \
 //x=3.15 //y=5.72 //x2=3.59 //y2=5.59
cc_400 ( N_noxref_7_M8_noxref_d N_noxref_8_c_726_n ) capacitor c=0.00826418f \
 //x=3.885 //y=5.025 //x2=3.59 //y2=5.59
cc_401 ( N_noxref_7_c_581_n N_noxref_8_c_697_n ) capacitor c=0.0184026f \
 //x=3.065 //y=5.21 //x2=3.7 //y2=5.21
cc_402 ( N_noxref_7_c_602_n N_noxref_8_c_697_n ) capacitor c=0.00145412f \
 //x=3.915 //y=6.91 //x2=3.7 //y2=5.21
cc_403 ( N_noxref_7_c_594_n N_noxref_8_c_697_n ) capacitor c=4.62901e-19 \
 //x=2.11 //y=5.38 //x2=3.7 //y2=5.21
cc_404 ( N_noxref_7_c_584_n N_noxref_8_c_698_n ) capacitor c=0.00432732f \
 //x=3.15 //y=5.59 //x2=3.59 //y2=5.72
cc_405 ( N_noxref_7_c_602_n N_noxref_8_c_698_n ) capacitor c=0.00368853f \
 //x=3.915 //y=6.91 //x2=3.59 //y2=5.72
cc_406 ( N_noxref_7_c_590_n N_noxref_8_c_698_n ) capacitor c=8.19351e-19 \
 //x=3.15 //y=6.74 //x2=3.59 //y2=5.72
cc_407 ( N_noxref_7_c_593_n N_noxref_8_c_698_n ) capacitor c=8.19351e-19 \
 //x=4.03 //y=6.74 //x2=3.59 //y2=5.72
cc_408 ( N_noxref_7_c_598_n N_noxref_8_c_698_n ) capacitor c=0.0524362f \
 //x=3.15 //y=5.72 //x2=3.59 //y2=5.72
cc_409 ( N_noxref_7_M8_noxref_d N_noxref_8_c_698_n ) capacitor c=0.0481518f \
 //x=3.885 //y=5.025 //x2=3.59 //y2=5.72
