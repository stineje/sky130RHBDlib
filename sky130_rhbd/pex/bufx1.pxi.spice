// File: bufx1.spi.BUFX1.pxi
// Created: Sun Mar 15 12:48:37 2026
//
simulator lang=spectre
x_PM_BUFX1\%noxref_1 ( N_noxref_1_c_24_p N_noxref_1_c_54_p N_noxref_1_c_1_p \
 N_noxref_1_c_130_p N_noxref_1_c_55_p N_noxref_1_c_68_p N_noxref_1_c_25_p \
 N_noxref_1_c_2_p N_noxref_1_c_69_p N_noxref_1_c_29_p N_noxref_1_c_3_p \
 N_noxref_1_c_56_p N_noxref_1_c_4_p N_noxref_1_c_5_p N_noxref_1_c_20_p \
 N_noxref_1_c_6_p N_noxref_1_c_98_p N_noxref_1_c_155_p N_noxref_1_c_34_p \
 N_noxref_1_c_57_p N_noxref_1_c_7_p N_noxref_1_c_58_p N_noxref_1_M1_noxref_g \
 N_noxref_1_M4_noxref_g N_noxref_1_M5_noxref_g N_noxref_1_c_16_p \
 N_noxref_1_c_133_p N_noxref_1_c_48_p N_noxref_1_c_36_p N_noxref_1_c_67_p \
 N_noxref_1_c_78_p N_noxref_1_c_50_p N_noxref_1_c_136_p N_noxref_1_c_18_p \
 N_noxref_1_c_52_p N_noxref_1_c_17_p N_noxref_1_M0_noxref_d \
 N_noxref_1_M2_noxref_d )  PM_BUFX1\%noxref_1
x_PM_BUFX1\%noxref_2 ( N_noxref_2_c_177_n N_noxref_2_c_185_n \
 N_noxref_2_c_186_n N_noxref_2_c_189_n N_noxref_2_c_194_n N_noxref_2_c_195_n \
 N_noxref_2_c_200_n N_noxref_2_c_203_n N_noxref_2_M0_noxref_s \
 N_noxref_2_M1_noxref_s )  PM_BUFX1\%noxref_2
x_PM_BUFX1\%noxref_3 ( N_noxref_3_c_271_n N_noxref_3_c_276_n \
 N_noxref_3_c_279_n N_noxref_3_c_282_n N_noxref_3_c_285_n N_noxref_3_c_288_n \
 N_noxref_3_M2_noxref_s N_noxref_3_M3_noxref_d N_noxref_3_M4_noxref_s \
 N_noxref_3_M5_noxref_d )  PM_BUFX1\%noxref_3
x_PM_BUFX1\%noxref_4 ( N_noxref_4_c_346_n N_noxref_4_c_353_n \
 N_noxref_4_c_354_n N_noxref_4_c_355_n N_noxref_4_M0_noxref_g \
 N_noxref_4_M2_noxref_g N_noxref_4_M3_noxref_g N_noxref_4_c_362_n \
 N_noxref_4_c_364_n N_noxref_4_c_367_n N_noxref_4_c_368_n N_noxref_4_c_369_n \
 N_noxref_4_c_372_n N_noxref_4_c_373_n N_noxref_4_c_375_n N_noxref_4_c_379_n \
 N_noxref_4_c_381_n N_noxref_4_c_384_n )  PM_BUFX1\%noxref_4
x_PM_BUFX1\%noxref_5 ( N_noxref_5_c_426_n N_noxref_5_c_432_n \
 N_noxref_5_c_435_n N_noxref_5_c_436_n N_noxref_5_c_438_n N_noxref_5_c_439_n \
 N_noxref_5_c_442_n N_noxref_5_c_455_n N_noxref_5_c_462_n \
 N_noxref_5_M1_noxref_d N_noxref_5_M4_noxref_d )  PM_BUFX1\%noxref_5
cc_1 ( N_noxref_1_c_1_p N_noxref_2_c_177_n ) capacitor c=0.00498313f //x=1.395 \
 //y=1.84 //x2=4.07 //y2=0
cc_2 ( N_noxref_1_c_2_p N_noxref_2_c_177_n ) capacitor c=6.41891e-19 //x=1.48 \
 //y=2.755 //x2=4.07 //y2=0
cc_3 ( N_noxref_1_c_3_p N_noxref_2_c_177_n ) capacitor c=5.90466e-19 //x=2.96 \
 //y=2.755 //x2=4.07 //y2=0
cc_4 ( N_noxref_1_c_4_p N_noxref_2_c_177_n ) capacitor c=0.00996824f //x=1.11 \
 //y=1.005 //x2=4.07 //y2=0
cc_5 ( N_noxref_1_c_5_p N_noxref_2_c_177_n ) capacitor c=4.4656e-19 //x=1.48 \
 //y=2.59 //x2=4.07 //y2=0
cc_6 ( N_noxref_1_c_6_p N_noxref_2_c_177_n ) capacitor c=0.00248634f //x=2.96 \
 //y=2.085 //x2=4.07 //y2=0
cc_7 ( N_noxref_1_c_7_p N_noxref_2_c_177_n ) capacitor c=7.53892e-19 //x=2.96 \
 //y=2.085 //x2=4.07 //y2=0
cc_8 ( N_noxref_1_M0_noxref_d N_noxref_2_c_177_n ) capacitor c=0.00119583f \
 //x=0.925 //y=0.91 //x2=4.07 //y2=0
cc_9 ( N_noxref_1_c_4_p N_noxref_2_c_185_n ) capacitor c=0.00124697f //x=1.11 \
 //y=1.005 //x2=1.025 //y2=0.535
cc_10 ( N_noxref_1_c_1_p N_noxref_2_c_186_n ) capacitor c=0.00307212f \
 //x=1.395 //y=1.84 //x2=1.515 //y2=0.535
cc_11 ( N_noxref_1_c_4_p N_noxref_2_c_186_n ) capacitor c=0.00130436f //x=1.11 \
 //y=1.005 //x2=1.515 //y2=0.535
cc_12 ( N_noxref_1_c_5_p N_noxref_2_c_186_n ) capacitor c=4.2833e-19 //x=1.48 \
 //y=2.59 //x2=1.515 //y2=0.535
cc_13 ( N_noxref_1_c_3_p N_noxref_2_c_189_n ) capacitor c=2.58644e-19 //x=2.96 \
 //y=2.755 //x2=3.245 //y2=0.535
cc_14 ( N_noxref_1_c_6_p N_noxref_2_c_189_n ) capacitor c=0.00114179f //x=2.96 \
 //y=2.085 //x2=3.245 //y2=0.535
cc_15 ( N_noxref_1_c_7_p N_noxref_2_c_189_n ) capacitor c=3.95714e-19 //x=2.96 \
 //y=2.085 //x2=3.245 //y2=0.535
cc_16 ( N_noxref_1_c_16_p N_noxref_2_c_189_n ) capacitor c=0.0125519f //x=3.07 \
 //y=0.91 //x2=3.245 //y2=0.535
cc_17 ( N_noxref_1_c_17_p N_noxref_2_c_189_n ) capacitor c=2.1838e-19 //x=2.96 \
 //y=2.085 //x2=3.245 //y2=0.535
cc_18 ( N_noxref_1_c_18_p N_noxref_2_c_194_n ) capacitor c=0.0134259f //x=3.6 \
 //y=0.91 //x2=3.735 //y2=0.535
cc_19 ( N_noxref_1_c_4_p N_noxref_2_c_195_n ) capacitor c=2.8029e-19 //x=1.11 \
 //y=1.005 //x2=4.07 //y2=0
cc_20 ( N_noxref_1_c_20_p N_noxref_2_c_195_n ) capacitor c=0.00313158f \
 //x=2.96 //y=2.59 //x2=4.07 //y2=0
cc_21 ( N_noxref_1_c_7_p N_noxref_2_c_195_n ) capacitor c=0.0022444f //x=2.96 \
 //y=2.085 //x2=4.07 //y2=0
cc_22 ( N_noxref_1_c_17_p N_noxref_2_c_195_n ) capacitor c=2.63786e-19 \
 //x=2.96 //y=2.085 //x2=4.07 //y2=0
cc_23 ( N_noxref_1_M0_noxref_d N_noxref_2_c_195_n ) capacitor c=2.70835e-19 \
 //x=0.925 //y=0.91 //x2=4.07 //y2=0
cc_24 ( N_noxref_1_c_24_p N_noxref_2_c_200_n ) capacitor c=0.00520602f \
 //x=1.11 //y=1.755 //x2=0.63 //y2=0
cc_25 ( N_noxref_1_c_25_p N_noxref_2_c_200_n ) capacitor c=2.14154e-19 \
 //x=1.48 //y=2.435 //x2=0.63 //y2=0
cc_26 ( N_noxref_1_c_5_p N_noxref_2_c_200_n ) capacitor c=0.00313158f //x=1.48 \
 //y=2.59 //x2=0.63 //y2=0
cc_27 ( N_noxref_1_c_1_p N_noxref_2_c_203_n ) capacitor c=0.0147709f //x=1.395 \
 //y=1.84 //x2=2.22 //y2=0
cc_28 ( N_noxref_1_c_2_p N_noxref_2_c_203_n ) capacitor c=0.00481459f //x=1.48 \
 //y=2.755 //x2=2.22 //y2=0
cc_29 ( N_noxref_1_c_29_p N_noxref_2_c_203_n ) capacitor c=0.00392666f \
 //x=2.96 //y=2.435 //x2=2.22 //y2=0
cc_30 ( N_noxref_1_c_3_p N_noxref_2_c_203_n ) capacitor c=0.00481459f //x=2.96 \
 //y=2.755 //x2=2.22 //y2=0
cc_31 ( N_noxref_1_c_5_p N_noxref_2_c_203_n ) capacitor c=0.010027f //x=1.48 \
 //y=2.59 //x2=2.22 //y2=0
cc_32 ( N_noxref_1_c_20_p N_noxref_2_c_203_n ) capacitor c=0.010027f //x=2.96 \
 //y=2.59 //x2=2.22 //y2=0
cc_33 ( N_noxref_1_c_6_p N_noxref_2_c_203_n ) capacitor c=0.00682461f //x=2.96 \
 //y=2.085 //x2=2.22 //y2=0
cc_34 ( N_noxref_1_c_34_p N_noxref_2_c_203_n ) capacitor c=0.0228448f //x=2.8 \
 //y=2.595 //x2=2.22 //y2=0
cc_35 ( N_noxref_1_c_7_p N_noxref_2_c_203_n ) capacitor c=0.00733227f //x=2.96 \
 //y=2.085 //x2=2.22 //y2=0
cc_36 ( N_noxref_1_c_36_p N_noxref_2_c_203_n ) capacitor c=0.00344321f \
 //x=3.07 //y=1.92 //x2=2.22 //y2=0
cc_37 ( N_noxref_1_c_17_p N_noxref_2_c_203_n ) capacitor c=0.00786308f \
 //x=2.96 //y=2.085 //x2=2.22 //y2=0
cc_38 ( N_noxref_1_c_24_p N_noxref_2_M0_noxref_s ) capacitor c=0.0327121f \
 //x=1.11 //y=1.755 //x2=0.495 //y2=0.37
cc_39 ( N_noxref_1_c_1_p N_noxref_2_M0_noxref_s ) capacitor c=0.00316664f \
 //x=1.395 //y=1.84 //x2=0.495 //y2=0.37
cc_40 ( N_noxref_1_c_2_p N_noxref_2_M0_noxref_s ) capacitor c=0.00295953f \
 //x=1.48 //y=2.755 //x2=0.495 //y2=0.37
cc_41 ( N_noxref_1_c_4_p N_noxref_2_M0_noxref_s ) capacitor c=0.0155279f \
 //x=1.11 //y=1.005 //x2=0.495 //y2=0.37
cc_42 ( N_noxref_1_c_5_p N_noxref_2_M0_noxref_s ) capacitor c=0.00227181f \
 //x=1.48 //y=2.59 //x2=0.495 //y2=0.37
cc_43 ( N_noxref_1_M0_noxref_d N_noxref_2_M0_noxref_s ) capacitor c=0.0377604f \
 //x=0.925 //y=0.91 //x2=0.495 //y2=0.37
cc_44 ( N_noxref_1_c_3_p N_noxref_2_M1_noxref_s ) capacitor c=0.00168578f \
 //x=2.96 //y=2.755 //x2=2.715 //y2=0.37
cc_45 ( N_noxref_1_c_6_p N_noxref_2_M1_noxref_s ) capacitor c=0.00297844f \
 //x=2.96 //y=2.085 //x2=2.715 //y2=0.37
cc_46 ( N_noxref_1_c_7_p N_noxref_2_M1_noxref_s ) capacitor c=0.00651272f \
 //x=2.96 //y=2.085 //x2=2.715 //y2=0.37
cc_47 ( N_noxref_1_c_16_p N_noxref_2_M1_noxref_s ) capacitor c=0.0299684f \
 //x=3.07 //y=0.91 //x2=2.715 //y2=0.37
cc_48 ( N_noxref_1_c_48_p N_noxref_2_M1_noxref_s ) capacitor c=0.002132f \
 //x=3.07 //y=1.565 //x2=2.715 //y2=0.37
cc_49 ( N_noxref_1_c_36_p N_noxref_2_M1_noxref_s ) capacitor c=0.00304786f \
 //x=3.07 //y=1.92 //x2=2.715 //y2=0.37
cc_50 ( N_noxref_1_c_50_p N_noxref_2_M1_noxref_s ) capacitor c=0.00517157f \
 //x=3.445 //y=0.755 //x2=2.715 //y2=0.37
cc_51 ( N_noxref_1_c_18_p N_noxref_2_M1_noxref_s ) capacitor c=0.0153553f \
 //x=3.6 //y=0.91 //x2=2.715 //y2=0.37
cc_52 ( N_noxref_1_c_52_p N_noxref_2_M1_noxref_s ) capacitor c=0.00629878f \
 //x=3.6 //y=1.255 //x2=2.715 //y2=0.37
cc_53 ( N_noxref_1_c_17_p N_noxref_2_M1_noxref_s ) capacitor c=0.00659775f \
 //x=2.96 //y=2.085 //x2=2.715 //y2=0.37
cc_54 ( N_noxref_1_c_54_p N_noxref_3_c_271_n ) capacitor c=0.00259275f \
 //x=1.115 //y=5.24 //x2=4.07 //y2=7.4
cc_55 ( N_noxref_1_c_55_p N_noxref_3_c_271_n ) capacitor c=0.00199455f \
 //x=1.395 //y=4.96 //x2=4.07 //y2=7.4
cc_56 ( N_noxref_1_c_56_p N_noxref_3_c_271_n ) capacitor c=5.72118e-19 \
 //x=2.96 //y=4.58 //x2=4.07 //y2=7.4
cc_57 ( N_noxref_1_c_57_p N_noxref_3_c_271_n ) capacitor c=0.0024144f \
 //x=1.115 //y=5.38 //x2=4.07 //y2=7.4
cc_58 ( N_noxref_1_c_58_p N_noxref_3_c_271_n ) capacitor c=3.40875e-19 \
 //x=2.96 //y=4.7 //x2=4.07 //y2=7.4
cc_59 ( N_noxref_1_c_54_p N_noxref_3_c_276_n ) capacitor c=0.0010065f \
 //x=1.115 //y=5.24 //x2=1.47 //y2=7.4
cc_60 ( N_noxref_1_c_55_p N_noxref_3_c_276_n ) capacitor c=0.00205998f \
 //x=1.395 //y=4.96 //x2=1.47 //y2=7.4
cc_61 ( N_noxref_1_c_57_p N_noxref_3_c_276_n ) capacitor c=0.0137788f \
 //x=1.115 //y=5.38 //x2=1.47 //y2=7.4
cc_62 ( N_noxref_1_c_56_p N_noxref_3_c_279_n ) capacitor c=5.4912e-19 //x=2.96 \
 //y=4.58 //x2=3.69 //y2=7.4
cc_63 ( N_noxref_1_M4_noxref_g N_noxref_3_c_279_n ) capacitor c=0.00748034f \
 //x=3.115 //y=6.02 //x2=3.69 //y2=7.4
cc_64 ( N_noxref_1_M5_noxref_g N_noxref_3_c_279_n ) capacitor c=0.00749619f \
 //x=3.555 //y=6.02 //x2=3.69 //y2=7.4
cc_65 ( N_noxref_1_c_57_p N_noxref_3_c_282_n ) capacitor c=0.00135089f \
 //x=1.115 //y=5.38 //x2=4.07 //y2=7.4
cc_66 ( N_noxref_1_c_58_p N_noxref_3_c_282_n ) capacitor c=0.00241457f \
 //x=2.96 //y=4.7 //x2=4.07 //y2=7.4
cc_67 ( N_noxref_1_c_67_p N_noxref_3_c_282_n ) capacitor c=0.0225829f //x=3.48 \
 //y=4.79 //x2=4.07 //y2=7.4
cc_68 ( N_noxref_1_c_68_p N_noxref_3_c_285_n ) capacitor c=0.00685597f //x=1.2 \
 //y=4.96 //x2=0.74 //y2=7.4
cc_69 ( N_noxref_1_c_69_p N_noxref_3_c_285_n ) capacitor c=2.43252e-19 \
 //x=1.48 //y=4.875 //x2=0.74 //y2=7.4
cc_70 ( N_noxref_1_c_57_p N_noxref_3_c_285_n ) capacitor c=0.00824382f \
 //x=1.115 //y=5.38 //x2=0.74 //y2=7.4
cc_71 ( N_noxref_1_c_54_p N_noxref_3_c_288_n ) capacitor c=0.00217227f \
 //x=1.115 //y=5.24 //x2=2.22 //y2=7.4
cc_72 ( N_noxref_1_c_69_p N_noxref_3_c_288_n ) capacitor c=0.0205058f //x=1.48 \
 //y=4.875 //x2=2.22 //y2=7.4
cc_73 ( N_noxref_1_c_56_p N_noxref_3_c_288_n ) capacitor c=0.0155837f //x=2.96 \
 //y=4.58 //x2=2.22 //y2=7.4
cc_74 ( N_noxref_1_c_34_p N_noxref_3_c_288_n ) capacitor c=0.00259238f //x=2.8 \
 //y=2.595 //x2=2.22 //y2=7.4
cc_75 ( N_noxref_1_c_57_p N_noxref_3_c_288_n ) capacitor c=0.00827037f \
 //x=1.115 //y=5.38 //x2=2.22 //y2=7.4
cc_76 ( N_noxref_1_c_58_p N_noxref_3_c_288_n ) capacitor c=0.00795272f \
 //x=2.96 //y=4.7 //x2=2.22 //y2=7.4
cc_77 ( N_noxref_1_M4_noxref_g N_noxref_3_c_288_n ) capacitor c=0.00635171f \
 //x=3.115 //y=6.02 //x2=2.22 //y2=7.4
cc_78 ( N_noxref_1_c_78_p N_noxref_3_c_288_n ) capacitor c=0.00799922f \
 //x=3.19 //y=4.79 //x2=2.22 //y2=7.4
cc_79 ( N_noxref_1_c_54_p N_noxref_3_M2_noxref_s ) capacitor c=0.0480012f \
 //x=1.115 //y=5.24 //x2=0.54 //y2=5.02
cc_80 ( N_noxref_1_c_57_p N_noxref_3_M2_noxref_s ) capacitor c=0.092379f \
 //x=1.115 //y=5.38 //x2=0.54 //y2=5.02
cc_81 ( N_noxref_1_c_54_p N_noxref_3_M3_noxref_d ) capacitor c=0.0474638f \
 //x=1.115 //y=5.24 //x2=1.41 //y2=5.02
cc_82 ( N_noxref_1_c_55_p N_noxref_3_M3_noxref_d ) capacitor c=0.0214668f \
 //x=1.395 //y=4.96 //x2=1.41 //y2=5.02
cc_83 ( N_noxref_1_c_2_p N_noxref_3_M3_noxref_d ) capacitor c=0.00160678f \
 //x=1.48 //y=2.755 //x2=1.41 //y2=5.02
cc_84 ( N_noxref_1_c_57_p N_noxref_3_M3_noxref_d ) capacitor c=0.0913728f \
 //x=1.115 //y=5.38 //x2=1.41 //y2=5.02
cc_85 ( N_noxref_1_c_54_p N_noxref_3_M4_noxref_s ) capacitor c=8.11512e-19 \
 //x=1.115 //y=5.24 //x2=2.76 //y2=5.02
cc_86 ( N_noxref_1_c_3_p N_noxref_3_M4_noxref_s ) capacitor c=8.64011e-19 \
 //x=2.96 //y=2.755 //x2=2.76 //y2=5.02
cc_87 ( N_noxref_1_c_56_p N_noxref_3_M4_noxref_s ) capacitor c=0.0211972f \
 //x=2.96 //y=4.58 //x2=2.76 //y2=5.02
cc_88 ( N_noxref_1_c_58_p N_noxref_3_M4_noxref_s ) capacitor c=0.00914062f \
 //x=2.96 //y=4.7 //x2=2.76 //y2=5.02
cc_89 ( N_noxref_1_M4_noxref_g N_noxref_3_M4_noxref_s ) capacitor c=0.0573441f \
 //x=3.115 //y=6.02 //x2=2.76 //y2=5.02
cc_90 ( N_noxref_1_c_78_p N_noxref_3_M4_noxref_s ) capacitor c=0.00527312f \
 //x=3.19 //y=4.79 //x2=2.76 //y2=5.02
cc_91 ( N_noxref_1_M5_noxref_g N_noxref_3_M5_noxref_d ) capacitor c=0.0572684f \
 //x=3.555 //y=6.02 //x2=3.63 //y2=5.02
cc_92 ( N_noxref_1_c_25_p N_noxref_4_c_346_n ) capacitor c=0.008006f //x=1.48 \
 //y=2.435 //x2=0.74 //y2=4.58
cc_93 ( N_noxref_1_c_2_p N_noxref_4_c_346_n ) capacitor c=0.0149195f //x=1.48 \
 //y=2.755 //x2=0.74 //y2=4.58
cc_94 ( N_noxref_1_c_69_p N_noxref_4_c_346_n ) capacitor c=0.103139f //x=1.48 \
 //y=4.875 //x2=0.74 //y2=4.58
cc_95 ( N_noxref_1_c_29_p N_noxref_4_c_346_n ) capacitor c=6.61219e-19 \
 //x=2.96 //y=2.435 //x2=0.74 //y2=4.58
cc_96 ( N_noxref_1_c_56_p N_noxref_4_c_346_n ) capacitor c=0.00306936f \
 //x=2.96 //y=4.58 //x2=0.74 //y2=4.58
cc_97 ( N_noxref_1_c_5_p N_noxref_4_c_346_n ) capacitor c=0.00348308f //x=1.48 \
 //y=2.59 //x2=0.74 //y2=4.58
cc_98 ( N_noxref_1_c_98_p N_noxref_4_c_346_n ) capacitor c=0.00687738f \
 //x=1.64 //y=2.595 //x2=0.74 //y2=4.58
cc_99 ( N_noxref_1_c_25_p N_noxref_4_c_353_n ) capacitor c=0.0181783f //x=1.48 \
 //y=2.435 //x2=0.74 //y2=2.085
cc_100 ( N_noxref_1_c_25_p N_noxref_4_c_354_n ) capacitor c=4.71798e-19 \
 //x=1.48 //y=2.435 //x2=0.74 //y2=2.085
cc_101 ( N_noxref_1_c_69_p N_noxref_4_c_355_n ) capacitor c=0.00160039f \
 //x=1.48 //y=4.875 //x2=0.74 //y2=4.7
cc_102 ( N_noxref_1_c_54_p N_noxref_4_M2_noxref_g ) capacitor c=0.00141266f \
 //x=1.115 //y=5.24 //x2=0.895 //y2=6.02
cc_103 ( N_noxref_1_c_68_p N_noxref_4_M2_noxref_g ) capacitor c=0.00534267f \
 //x=1.2 //y=4.96 //x2=0.895 //y2=6.02
cc_104 ( N_noxref_1_c_57_p N_noxref_4_M2_noxref_g ) capacitor c=0.0162066f \
 //x=1.115 //y=5.38 //x2=0.895 //y2=6.02
cc_105 ( N_noxref_1_c_54_p N_noxref_4_M3_noxref_g ) capacitor c=0.00344289f \
 //x=1.115 //y=5.24 //x2=1.335 //y2=6.02
cc_106 ( N_noxref_1_c_55_p N_noxref_4_M3_noxref_g ) capacitor c=0.00958393f \
 //x=1.395 //y=4.96 //x2=1.335 //y2=6.02
cc_107 ( N_noxref_1_c_57_p N_noxref_4_M3_noxref_g ) capacitor c=0.0162066f \
 //x=1.115 //y=5.38 //x2=1.335 //y2=6.02
cc_108 ( N_noxref_1_c_4_p N_noxref_4_c_362_n ) capacitor c=0.00187726f \
 //x=1.11 //y=1.005 //x2=0.85 //y2=0.91
cc_109 ( N_noxref_1_M0_noxref_d N_noxref_4_c_362_n ) capacitor c=0.00137914f \
 //x=0.925 //y=0.91 //x2=0.85 //y2=0.91
cc_110 ( N_noxref_1_c_24_p N_noxref_4_c_364_n ) capacitor c=0.0012792f \
 //x=1.11 //y=1.755 //x2=0.85 //y2=1.255
cc_111 ( N_noxref_1_c_4_p N_noxref_4_c_364_n ) capacitor c=0.00414335f \
 //x=1.11 //y=1.005 //x2=0.85 //y2=1.255
cc_112 ( N_noxref_1_M0_noxref_d N_noxref_4_c_364_n ) capacitor c=0.0023891f \
 //x=0.925 //y=0.91 //x2=0.85 //y2=1.255
cc_113 ( N_noxref_1_c_24_p N_noxref_4_c_367_n ) capacitor c=0.00561986f \
 //x=1.11 //y=1.755 //x2=0.85 //y2=1.565
cc_114 ( N_noxref_1_c_24_p N_noxref_4_c_368_n ) capacitor c=0.00440271f \
 //x=1.11 //y=1.755 //x2=0.85 //y2=1.92
cc_115 ( N_noxref_1_c_68_p N_noxref_4_c_369_n ) capacitor c=0.00262283f \
 //x=1.2 //y=4.96 //x2=1.26 //y2=4.79
cc_116 ( N_noxref_1_c_69_p N_noxref_4_c_369_n ) capacitor c=0.00208891f \
 //x=1.48 //y=4.875 //x2=1.26 //y2=4.79
cc_117 ( N_noxref_1_c_57_p N_noxref_4_c_369_n ) capacitor c=0.00290963f \
 //x=1.115 //y=5.38 //x2=1.26 //y2=4.79
cc_118 ( N_noxref_1_c_69_p N_noxref_4_c_372_n ) capacitor c=0.00140024f \
 //x=1.48 //y=4.875 //x2=0.97 //y2=4.79
cc_119 ( N_noxref_1_c_4_p N_noxref_4_c_373_n ) capacitor c=5.57924e-19 \
 //x=1.11 //y=1.005 //x2=1.225 //y2=0.755
cc_120 ( N_noxref_1_M0_noxref_d N_noxref_4_c_373_n ) capacitor c=0.0020782f \
 //x=0.925 //y=0.91 //x2=1.225 //y2=0.755
cc_121 ( N_noxref_1_c_24_p N_noxref_4_c_375_n ) capacitor c=0.00933629f \
 //x=1.11 //y=1.755 //x2=1.225 //y2=1.41
cc_122 ( N_noxref_1_c_1_p N_noxref_4_c_375_n ) capacitor c=0.00180253f \
 //x=1.395 //y=1.84 //x2=1.225 //y2=1.41
cc_123 ( N_noxref_1_c_4_p N_noxref_4_c_375_n ) capacitor c=5.75878e-19 \
 //x=1.11 //y=1.005 //x2=1.225 //y2=1.41
cc_124 ( N_noxref_1_M0_noxref_d N_noxref_4_c_375_n ) capacitor c=0.00356097f \
 //x=0.925 //y=0.91 //x2=1.225 //y2=1.41
cc_125 ( N_noxref_1_c_4_p N_noxref_4_c_379_n ) capacitor c=0.0014754f //x=1.11 \
 //y=1.005 //x2=1.38 //y2=0.91
cc_126 ( N_noxref_1_M0_noxref_d N_noxref_4_c_379_n ) capacitor c=0.00138452f \
 //x=0.925 //y=0.91 //x2=1.38 //y2=0.91
cc_127 ( N_noxref_1_c_24_p N_noxref_4_c_381_n ) capacitor c=0.00321841f \
 //x=1.11 //y=1.755 //x2=1.38 //y2=1.255
cc_128 ( N_noxref_1_c_4_p N_noxref_4_c_381_n ) capacitor c=0.0034642f //x=1.11 \
 //y=1.005 //x2=1.38 //y2=1.255
cc_129 ( N_noxref_1_M0_noxref_d N_noxref_4_c_381_n ) capacitor c=0.00235934f \
 //x=0.925 //y=0.91 //x2=1.38 //y2=1.255
cc_130 ( N_noxref_1_c_130_p N_noxref_4_c_384_n ) capacitor c=0.00440271f \
 //x=1.195 //y=1.84 //x2=0.74 //y2=2.085
cc_131 ( N_noxref_1_c_25_p N_noxref_4_c_384_n ) capacitor c=0.00275704f \
 //x=1.48 //y=2.435 //x2=0.74 //y2=2.085
cc_132 ( N_noxref_1_c_24_p N_noxref_5_c_426_n ) capacitor c=0.00735936f \
 //x=1.11 //y=1.755 //x2=3.33 //y2=1.755
cc_133 ( N_noxref_1_c_133_p N_noxref_5_c_426_n ) capacitor c=0.00107851f \
 //x=3.07 //y=1.255 //x2=3.33 //y2=1.755
cc_134 ( N_noxref_1_c_48_p N_noxref_5_c_426_n ) capacitor c=0.00522452f \
 //x=3.07 //y=1.565 //x2=3.33 //y2=1.755
cc_135 ( N_noxref_1_c_36_p N_noxref_5_c_426_n ) capacitor c=0.00384134f \
 //x=3.07 //y=1.92 //x2=3.33 //y2=1.755
cc_136 ( N_noxref_1_c_136_p N_noxref_5_c_426_n ) capacitor c=0.00932142f \
 //x=3.445 //y=1.41 //x2=3.33 //y2=1.755
cc_137 ( N_noxref_1_c_52_p N_noxref_5_c_426_n ) capacitor c=0.00362207f \
 //x=3.6 //y=1.255 //x2=3.33 //y2=1.755
cc_138 ( N_noxref_1_c_54_p N_noxref_5_c_432_n ) capacitor c=0.00212662f \
 //x=1.115 //y=5.24 //x2=3.335 //y2=5.24
cc_139 ( N_noxref_1_M4_noxref_g N_noxref_5_c_432_n ) capacitor c=0.00141266f \
 //x=3.115 //y=6.02 //x2=3.335 //y2=5.24
cc_140 ( N_noxref_1_M5_noxref_g N_noxref_5_c_432_n ) capacitor c=0.00377331f \
 //x=3.555 //y=6.02 //x2=3.335 //y2=5.24
cc_141 ( N_noxref_1_c_136_p N_noxref_5_c_435_n ) capacitor c=0.00180253f \
 //x=3.445 //y=1.41 //x2=3.615 //y2=1.84
cc_142 ( N_noxref_1_c_1_p N_noxref_5_c_436_n ) capacitor c=0.00350547f \
 //x=1.395 //y=1.84 //x2=3.415 //y2=1.84
cc_143 ( N_noxref_1_c_17_p N_noxref_5_c_436_n ) capacitor c=0.00384134f \
 //x=2.96 //y=2.085 //x2=3.415 //y2=1.84
cc_144 ( N_noxref_1_M5_noxref_g N_noxref_5_c_438_n ) capacitor c=0.00966342f \
 //x=3.555 //y=6.02 //x2=3.615 //y2=4.96
cc_145 ( N_noxref_1_c_55_p N_noxref_5_c_439_n ) capacitor c=0.00349209f \
 //x=1.395 //y=4.96 //x2=3.42 //y2=4.96
cc_146 ( N_noxref_1_M4_noxref_g N_noxref_5_c_439_n ) capacitor c=0.00439203f \
 //x=3.115 //y=6.02 //x2=3.42 //y2=4.96
cc_147 ( N_noxref_1_c_67_p N_noxref_5_c_439_n ) capacitor c=0.00262283f \
 //x=3.48 //y=4.79 //x2=3.42 //y2=4.96
cc_148 ( N_noxref_1_c_25_p N_noxref_5_c_442_n ) capacitor c=0.00112843f \
 //x=1.48 //y=2.435 //x2=3.7 //y2=4.875
cc_149 ( N_noxref_1_c_69_p N_noxref_5_c_442_n ) capacitor c=0.00356495f \
 //x=1.48 //y=4.875 //x2=3.7 //y2=4.875
cc_150 ( N_noxref_1_c_29_p N_noxref_5_c_442_n ) capacitor c=0.0080037f \
 //x=2.96 //y=2.435 //x2=3.7 //y2=4.875
cc_151 ( N_noxref_1_c_3_p N_noxref_5_c_442_n ) capacitor c=0.0149195f //x=2.96 \
 //y=2.755 //x2=3.7 //y2=4.875
cc_152 ( N_noxref_1_c_56_p N_noxref_5_c_442_n ) capacitor c=0.093005f //x=2.96 \
 //y=4.58 //x2=3.7 //y2=4.875
cc_153 ( N_noxref_1_c_20_p N_noxref_5_c_442_n ) capacitor c=0.00348308f \
 //x=2.96 //y=2.59 //x2=3.7 //y2=4.875
cc_154 ( N_noxref_1_c_6_p N_noxref_5_c_442_n ) capacitor c=0.00825076f \
 //x=2.96 //y=2.085 //x2=3.7 //y2=4.875
cc_155 ( N_noxref_1_c_155_p N_noxref_5_c_442_n ) capacitor c=0.00687738f \
 //x=2.96 //y=2.595 //x2=3.7 //y2=4.875
cc_156 ( N_noxref_1_c_7_p N_noxref_5_c_442_n ) capacitor c=0.0023016f //x=2.96 \
 //y=2.085 //x2=3.7 //y2=4.875
cc_157 ( N_noxref_1_c_58_p N_noxref_5_c_442_n ) capacitor c=0.00250262f \
 //x=2.96 //y=4.7 //x2=3.7 //y2=4.875
cc_158 ( N_noxref_1_c_67_p N_noxref_5_c_442_n ) capacitor c=4.08297e-19 \
 //x=3.48 //y=4.79 //x2=3.7 //y2=4.875
cc_159 ( N_noxref_1_c_78_p N_noxref_5_c_442_n ) capacitor c=0.00124564f \
 //x=3.19 //y=4.79 //x2=3.7 //y2=4.875
cc_160 ( N_noxref_1_c_17_p N_noxref_5_c_442_n ) capacitor c=0.00112403f \
 //x=2.96 //y=2.085 //x2=3.7 //y2=4.875
cc_161 ( N_noxref_1_c_4_p N_noxref_5_c_455_n ) capacitor c=0.00708676f \
 //x=1.11 //y=1.005 //x2=3.33 //y2=1.005
cc_162 ( N_noxref_1_c_16_p N_noxref_5_c_455_n ) capacitor c=0.00174488f \
 //x=3.07 //y=0.91 //x2=3.33 //y2=1.005
cc_163 ( N_noxref_1_c_133_p N_noxref_5_c_455_n ) capacitor c=0.00350474f \
 //x=3.07 //y=1.255 //x2=3.33 //y2=1.005
cc_164 ( N_noxref_1_c_50_p N_noxref_5_c_455_n ) capacitor c=5.57924e-19 \
 //x=3.445 //y=0.755 //x2=3.33 //y2=1.005
cc_165 ( N_noxref_1_c_136_p N_noxref_5_c_455_n ) capacitor c=5.75878e-19 \
 //x=3.445 //y=1.41 //x2=3.33 //y2=1.005
cc_166 ( N_noxref_1_c_18_p N_noxref_5_c_455_n ) capacitor c=0.00160969f \
 //x=3.6 //y=0.91 //x2=3.33 //y2=1.005
cc_167 ( N_noxref_1_c_52_p N_noxref_5_c_455_n ) capacitor c=0.00411132f \
 //x=3.6 //y=1.255 //x2=3.33 //y2=1.005
cc_168 ( N_noxref_1_M4_noxref_g N_noxref_5_c_462_n ) capacitor c=0.0162066f \
 //x=3.115 //y=6.02 //x2=3.335 //y2=5.38
cc_169 ( N_noxref_1_M5_noxref_g N_noxref_5_c_462_n ) capacitor c=0.0162066f \
 //x=3.555 //y=6.02 //x2=3.335 //y2=5.38
cc_170 ( N_noxref_1_c_67_p N_noxref_5_c_462_n ) capacitor c=0.00290963f \
 //x=3.48 //y=4.79 //x2=3.335 //y2=5.38
cc_171 ( N_noxref_1_c_16_p N_noxref_5_M1_noxref_d ) capacitor c=0.00137914f \
 //x=3.07 //y=0.91 //x2=3.145 //y2=0.91
cc_172 ( N_noxref_1_c_133_p N_noxref_5_M1_noxref_d ) capacitor c=0.0023891f \
 //x=3.07 //y=1.255 //x2=3.145 //y2=0.91
cc_173 ( N_noxref_1_c_50_p N_noxref_5_M1_noxref_d ) capacitor c=0.0020782f \
 //x=3.445 //y=0.755 //x2=3.145 //y2=0.91
cc_174 ( N_noxref_1_c_136_p N_noxref_5_M1_noxref_d ) capacitor c=0.00356097f \
 //x=3.445 //y=1.41 //x2=3.145 //y2=0.91
cc_175 ( N_noxref_1_c_18_p N_noxref_5_M1_noxref_d ) capacitor c=0.00138452f \
 //x=3.6 //y=0.91 //x2=3.145 //y2=0.91
cc_176 ( N_noxref_1_c_52_p N_noxref_5_M1_noxref_d ) capacitor c=0.00235934f \
 //x=3.6 //y=1.255 //x2=3.145 //y2=0.91
cc_177 ( N_noxref_2_c_195_n N_noxref_3_c_282_n ) capacitor c=0.00989031f \
 //x=4.07 //y=0 //x2=4.07 //y2=7.4
cc_178 ( N_noxref_2_c_200_n N_noxref_3_c_285_n ) capacitor c=0.00989031f \
 //x=0.63 //y=0 //x2=0.74 //y2=7.4
cc_179 ( N_noxref_2_c_203_n N_noxref_3_c_288_n ) capacitor c=0.00969948f \
 //x=2.22 //y=0 //x2=2.22 //y2=7.4
cc_180 ( N_noxref_2_c_200_n N_noxref_4_c_346_n ) capacitor c=0.0137596f \
 //x=0.63 //y=0 //x2=0.74 //y2=4.58
cc_181 ( N_noxref_2_c_177_n N_noxref_4_c_353_n ) capacitor c=0.00248636f \
 //x=4.07 //y=0 //x2=0.74 //y2=2.085
cc_182 ( N_noxref_2_c_185_n N_noxref_4_c_353_n ) capacitor c=0.00108343f \
 //x=1.025 //y=0.535 //x2=0.74 //y2=2.085
cc_183 ( N_noxref_2_c_200_n N_noxref_4_c_353_n ) capacitor c=0.0100674f \
 //x=0.63 //y=0 //x2=0.74 //y2=2.085
cc_184 ( N_noxref_2_M0_noxref_s N_noxref_4_c_353_n ) capacitor c=0.00297897f \
 //x=0.495 //y=0.37 //x2=0.74 //y2=2.085
cc_185 ( N_noxref_2_c_177_n N_noxref_4_c_354_n ) capacitor c=0.00118314f \
 //x=4.07 //y=0 //x2=0.74 //y2=2.085
cc_186 ( N_noxref_2_c_185_n N_noxref_4_c_354_n ) capacitor c=3.95714e-19 \
 //x=1.025 //y=0.535 //x2=0.74 //y2=2.085
cc_187 ( N_noxref_2_c_200_n N_noxref_4_c_354_n ) capacitor c=0.00733542f \
 //x=0.63 //y=0 //x2=0.74 //y2=2.085
cc_188 ( N_noxref_2_c_203_n N_noxref_4_c_354_n ) capacitor c=0.0022444f \
 //x=2.22 //y=0 //x2=0.74 //y2=2.085
cc_189 ( N_noxref_2_M0_noxref_s N_noxref_4_c_354_n ) capacitor c=0.00476509f \
 //x=0.495 //y=0.37 //x2=0.74 //y2=2.085
cc_190 ( N_noxref_2_c_185_n N_noxref_4_c_362_n ) capacitor c=0.0124783f \
 //x=1.025 //y=0.535 //x2=0.85 //y2=0.91
cc_191 ( N_noxref_2_M0_noxref_s N_noxref_4_c_362_n ) capacitor c=0.0299684f \
 //x=0.495 //y=0.37 //x2=0.85 //y2=0.91
cc_192 ( N_noxref_2_M0_noxref_s N_noxref_4_c_367_n ) capacitor c=0.002132f \
 //x=0.495 //y=0.37 //x2=0.85 //y2=1.565
cc_193 ( N_noxref_2_c_200_n N_noxref_4_c_368_n ) capacitor c=0.00574171f \
 //x=0.63 //y=0 //x2=0.85 //y2=1.92
cc_194 ( N_noxref_2_M0_noxref_s N_noxref_4_c_368_n ) capacitor c=0.00304786f \
 //x=0.495 //y=0.37 //x2=0.85 //y2=1.92
cc_195 ( N_noxref_2_M0_noxref_s N_noxref_4_c_373_n ) capacitor c=0.00517157f \
 //x=0.495 //y=0.37 //x2=1.225 //y2=0.755
cc_196 ( N_noxref_2_c_186_n N_noxref_4_c_379_n ) capacitor c=0.0130723f \
 //x=1.515 //y=0.535 //x2=1.38 //y2=0.91
cc_197 ( N_noxref_2_M0_noxref_s N_noxref_4_c_379_n ) capacitor c=0.0153553f \
 //x=0.495 //y=0.37 //x2=1.38 //y2=0.91
cc_198 ( N_noxref_2_M0_noxref_s N_noxref_4_c_381_n ) capacitor c=0.00629878f \
 //x=0.495 //y=0.37 //x2=1.38 //y2=1.255
cc_199 ( N_noxref_2_c_185_n N_noxref_4_c_384_n ) capacitor c=2.1838e-19 \
 //x=1.025 //y=0.535 //x2=0.74 //y2=2.085
cc_200 ( N_noxref_2_c_200_n N_noxref_4_c_384_n ) capacitor c=0.00785621f \
 //x=0.63 //y=0 //x2=0.74 //y2=2.085
cc_201 ( N_noxref_2_c_203_n N_noxref_4_c_384_n ) capacitor c=2.63786e-19 \
 //x=2.22 //y=0 //x2=0.74 //y2=2.085
cc_202 ( N_noxref_2_M0_noxref_s N_noxref_4_c_384_n ) capacitor c=0.00659395f \
 //x=0.495 //y=0.37 //x2=0.74 //y2=2.085
cc_203 ( N_noxref_2_c_195_n N_noxref_5_c_426_n ) capacitor c=0.00122336f \
 //x=4.07 //y=0 //x2=3.33 //y2=1.755
cc_204 ( N_noxref_2_c_203_n N_noxref_5_c_426_n ) capacitor c=0.00291377f \
 //x=2.22 //y=0 //x2=3.33 //y2=1.755
cc_205 ( N_noxref_2_M1_noxref_s N_noxref_5_c_426_n ) capacitor c=0.0327346f \
 //x=2.715 //y=0.37 //x2=3.33 //y2=1.755
cc_206 ( N_noxref_2_c_177_n N_noxref_5_c_435_n ) capacitor c=0.00496359f \
 //x=4.07 //y=0 //x2=3.615 //y2=1.84
cc_207 ( N_noxref_2_c_194_n N_noxref_5_c_435_n ) capacitor c=0.00321677f \
 //x=3.735 //y=0.535 //x2=3.615 //y2=1.84
cc_208 ( N_noxref_2_c_195_n N_noxref_5_c_435_n ) capacitor c=0.0298233f \
 //x=4.07 //y=0 //x2=3.615 //y2=1.84
cc_209 ( N_noxref_2_M1_noxref_s N_noxref_5_c_435_n ) capacitor c=0.00565313f \
 //x=2.715 //y=0.37 //x2=3.615 //y2=1.84
cc_210 ( N_noxref_2_c_177_n N_noxref_5_c_455_n ) capacitor c=0.00996824f \
 //x=4.07 //y=0 //x2=3.33 //y2=1.005
cc_211 ( N_noxref_2_c_189_n N_noxref_5_c_455_n ) capacitor c=0.00124697f \
 //x=3.245 //y=0.535 //x2=3.33 //y2=1.005
cc_212 ( N_noxref_2_c_194_n N_noxref_5_c_455_n ) capacitor c=0.00130436f \
 //x=3.735 //y=0.535 //x2=3.33 //y2=1.005
cc_213 ( N_noxref_2_c_195_n N_noxref_5_c_455_n ) capacitor c=2.8029e-19 \
 //x=4.07 //y=0 //x2=3.33 //y2=1.005
cc_214 ( N_noxref_2_M1_noxref_s N_noxref_5_c_455_n ) capacitor c=0.0155323f \
 //x=2.715 //y=0.37 //x2=3.33 //y2=1.005
cc_215 ( N_noxref_2_c_177_n N_noxref_5_M1_noxref_d ) capacitor c=0.00119583f \
 //x=4.07 //y=0 //x2=3.145 //y2=0.91
cc_216 ( N_noxref_2_c_195_n N_noxref_5_M1_noxref_d ) capacitor c=2.70835e-19 \
 //x=4.07 //y=0 //x2=3.145 //y2=0.91
cc_217 ( N_noxref_2_M1_noxref_s N_noxref_5_M1_noxref_d ) capacitor \
 c=0.0377604f //x=2.715 //y=0.37 //x2=3.145 //y2=0.91
cc_218 ( N_noxref_3_c_271_n N_noxref_4_c_346_n ) capacitor c=5.72118e-19 \
 //x=4.07 //y=7.4 //x2=0.74 //y2=4.58
cc_219 ( N_noxref_3_c_276_n N_noxref_4_c_346_n ) capacitor c=5.4912e-19 \
 //x=1.47 //y=7.4 //x2=0.74 //y2=4.58
cc_220 ( N_noxref_3_c_285_n N_noxref_4_c_346_n ) capacitor c=0.022723f \
 //x=0.74 //y=7.4 //x2=0.74 //y2=4.58
cc_221 ( N_noxref_3_M2_noxref_s N_noxref_4_c_346_n ) capacitor c=0.0218261f \
 //x=0.54 //y=5.02 //x2=0.74 //y2=4.58
cc_222 ( N_noxref_3_c_271_n N_noxref_4_c_355_n ) capacitor c=3.40875e-19 \
 //x=4.07 //y=7.4 //x2=0.74 //y2=4.7
cc_223 ( N_noxref_3_c_285_n N_noxref_4_c_355_n ) capacitor c=0.00795821f \
 //x=0.74 //y=7.4 //x2=0.74 //y2=4.7
cc_224 ( N_noxref_3_c_288_n N_noxref_4_c_355_n ) capacitor c=0.00235165f \
 //x=2.22 //y=7.4 //x2=0.74 //y2=4.7
cc_225 ( N_noxref_3_M2_noxref_s N_noxref_4_c_355_n ) capacitor c=0.00986151f \
 //x=0.54 //y=5.02 //x2=0.74 //y2=4.7
cc_226 ( N_noxref_3_c_276_n N_noxref_4_M2_noxref_g ) capacitor c=0.00748034f \
 //x=1.47 //y=7.4 //x2=0.895 //y2=6.02
cc_227 ( N_noxref_3_c_285_n N_noxref_4_M2_noxref_g ) capacitor c=0.0210133f \
 //x=0.74 //y=7.4 //x2=0.895 //y2=6.02
cc_228 ( N_noxref_3_M2_noxref_s N_noxref_4_M2_noxref_g ) capacitor \
 c=0.0573441f //x=0.54 //y=5.02 //x2=0.895 //y2=6.02
cc_229 ( N_noxref_3_c_276_n N_noxref_4_M3_noxref_g ) capacitor c=0.00749619f \
 //x=1.47 //y=7.4 //x2=1.335 //y2=6.02
cc_230 ( N_noxref_3_M3_noxref_d N_noxref_4_M3_noxref_g ) capacitor \
 c=0.0572684f //x=1.41 //y=5.02 //x2=1.335 //y2=6.02
cc_231 ( N_noxref_3_c_288_n N_noxref_4_c_369_n ) capacitor c=0.00780996f \
 //x=2.22 //y=7.4 //x2=1.26 //y2=4.79
cc_232 ( N_noxref_3_c_285_n N_noxref_4_c_372_n ) capacitor c=0.00799922f \
 //x=0.74 //y=7.4 //x2=0.97 //y2=4.79
cc_233 ( N_noxref_3_c_288_n N_noxref_4_c_372_n ) capacitor c=2.63786e-19 \
 //x=2.22 //y=7.4 //x2=0.97 //y2=4.79
cc_234 ( N_noxref_3_M2_noxref_s N_noxref_4_c_372_n ) capacitor c=0.00524251f \
 //x=0.54 //y=5.02 //x2=0.97 //y2=4.79
cc_235 ( N_noxref_3_c_271_n N_noxref_5_c_432_n ) capacitor c=0.00259275f \
 //x=4.07 //y=7.4 //x2=3.335 //y2=5.24
cc_236 ( N_noxref_3_c_279_n N_noxref_5_c_432_n ) capacitor c=0.0010065f \
 //x=3.69 //y=7.4 //x2=3.335 //y2=5.24
cc_237 ( N_noxref_3_c_282_n N_noxref_5_c_432_n ) capacitor c=0.00295945f \
 //x=4.07 //y=7.4 //x2=3.335 //y2=5.24
cc_238 ( N_noxref_3_M3_noxref_d N_noxref_5_c_432_n ) capacitor c=9.53785e-19 \
 //x=1.41 //y=5.02 //x2=3.335 //y2=5.24
cc_239 ( N_noxref_3_M4_noxref_s N_noxref_5_c_432_n ) capacitor c=0.0465566f \
 //x=2.76 //y=5.02 //x2=3.335 //y2=5.24
cc_240 ( N_noxref_3_M5_noxref_d N_noxref_5_c_432_n ) capacitor c=0.0486749f \
 //x=3.63 //y=5.02 //x2=3.335 //y2=5.24
cc_241 ( N_noxref_3_c_271_n N_noxref_5_c_438_n ) capacitor c=0.00199455f \
 //x=4.07 //y=7.4 //x2=3.615 //y2=4.96
cc_242 ( N_noxref_3_c_279_n N_noxref_5_c_438_n ) capacitor c=0.00207359f \
 //x=3.69 //y=7.4 //x2=3.615 //y2=4.96
cc_243 ( N_noxref_3_M5_noxref_d N_noxref_5_c_438_n ) capacitor c=0.0235605f \
 //x=3.63 //y=5.02 //x2=3.615 //y2=4.96
cc_244 ( N_noxref_3_c_288_n N_noxref_5_c_439_n ) capacitor c=0.0049725f \
 //x=2.22 //y=7.4 //x2=3.42 //y2=4.96
cc_245 ( N_noxref_3_c_282_n N_noxref_5_c_442_n ) capacitor c=0.0297606f \
 //x=4.07 //y=7.4 //x2=3.7 //y2=4.875
cc_246 ( N_noxref_3_c_271_n N_noxref_5_c_462_n ) capacitor c=0.0024144f \
 //x=4.07 //y=7.4 //x2=3.335 //y2=5.38
cc_247 ( N_noxref_3_c_279_n N_noxref_5_c_462_n ) capacitor c=0.0137788f \
 //x=3.69 //y=7.4 //x2=3.335 //y2=5.38
cc_248 ( N_noxref_3_c_282_n N_noxref_5_c_462_n ) capacitor c=0.00962126f \
 //x=4.07 //y=7.4 //x2=3.335 //y2=5.38
cc_249 ( N_noxref_3_c_288_n N_noxref_5_c_462_n ) capacitor c=0.00823854f \
 //x=2.22 //y=7.4 //x2=3.335 //y2=5.38
cc_250 ( N_noxref_3_M4_noxref_s N_noxref_5_c_462_n ) capacitor c=0.0901615f \
 //x=2.76 //y=5.02 //x2=3.335 //y2=5.38
cc_251 ( N_noxref_3_M5_noxref_d N_noxref_5_c_462_n ) capacitor c=0.0931055f \
 //x=3.63 //y=5.02 //x2=3.335 //y2=5.38
