// File: TIEHI.spi.TIEHI.pxi
// Created: Fri Feb 20 10:14:46 2026
//
simulator lang=spectre
x_PM_TIEHI\%VDD ( VDD N_VDD_c_1_p N_VDD_c_2_p N_VDD_c_3_p N_VDD_c_7_p \
 N_VDD_M1_noxref_s N_VDD_M2_noxref_d )  PM_TIEHI\%VDD
x_PM_TIEHI\%noxref_2 ( N_noxref_2_c_36_n N_noxref_2_c_61_p N_noxref_2_c_76_p \
 N_noxref_2_c_54_p N_noxref_2_c_69_p N_noxref_2_c_40_n N_noxref_2_M0_noxref_g \
 N_noxref_2_M1_noxref_g N_noxref_2_M2_noxref_g N_noxref_2_c_73_p \
 N_noxref_2_c_96_p N_noxref_2_c_79_p N_noxref_2_c_49_n N_noxref_2_c_50_n \
 N_noxref_2_c_88_p N_noxref_2_c_99_p N_noxref_2_c_80_p N_noxref_2_M0_noxref_d ) \
 PM_TIEHI\%noxref_2
x_PM_TIEHI\%Y ( Y Y Y N_Y_c_106_n N_Y_c_110_n N_Y_M1_noxref_d )  PM_TIEHI\%Y
x_PM_TIEHI\%GND ( GND N_GND_c_132_n N_GND_c_138_n N_GND_c_140_n N_GND_c_133_n \
 N_GND_c_134_n N_GND_c_135_n N_GND_c_153_n N_GND_M0_noxref_s )  PM_TIEHI\%GND
cc_1 ( N_VDD_c_1_p N_noxref_2_c_36_n ) capacitor c=5.48838e-19 //x=1.97 \
 //y=7.58 //x2=1.23 //y2=4.765
cc_2 ( N_VDD_c_2_p N_noxref_2_c_36_n ) capacitor c=4.51103e-19 //x=1.955 \
 //y=7.585 //x2=1.23 //y2=4.765
cc_3 ( N_VDD_c_3_p N_noxref_2_c_36_n ) capacitor c=0.0221278f //x=1.23 \
 //y=7.58 //x2=1.23 //y2=4.765
cc_4 ( N_VDD_M1_noxref_s N_noxref_2_c_36_n ) capacitor c=0.0222951f //x=1.025 \
 //y=5.2 //x2=1.23 //y2=4.765
cc_5 ( N_VDD_c_1_p N_noxref_2_c_40_n ) capacitor c=3.72238e-19 //x=1.97 \
 //y=7.58 //x2=1.23 //y2=4.88
cc_6 ( N_VDD_c_3_p N_noxref_2_c_40_n ) capacitor c=0.0079128f //x=1.23 \
 //y=7.58 //x2=1.23 //y2=4.88
cc_7 ( N_VDD_c_7_p N_noxref_2_c_40_n ) capacitor c=0.0023228f //x=1.97 \
 //y=7.58 //x2=1.23 //y2=4.88
cc_8 ( N_VDD_M1_noxref_s N_noxref_2_c_40_n ) capacitor c=0.010793f //x=1.025 \
 //y=5.2 //x2=1.23 //y2=4.88
cc_9 ( N_VDD_c_2_p N_noxref_2_M1_noxref_g ) capacitor c=0.00752015f //x=1.955 \
 //y=7.585 //x2=1.38 //y2=6.2
cc_10 ( N_VDD_c_3_p N_noxref_2_M1_noxref_g ) capacitor c=0.0193697f //x=1.23 \
 //y=7.58 //x2=1.38 //y2=6.2
cc_11 ( N_VDD_M1_noxref_s N_noxref_2_M1_noxref_g ) capacitor c=0.0601516f \
 //x=1.025 //y=5.2 //x2=1.38 //y2=6.2
cc_12 ( N_VDD_c_2_p N_noxref_2_M2_noxref_g ) capacitor c=0.00755544f //x=1.955 \
 //y=7.585 //x2=1.82 //y2=6.2
cc_13 ( N_VDD_M2_noxref_d N_noxref_2_M2_noxref_g ) capacitor c=0.0576266f \
 //x=1.895 //y=5.2 //x2=1.82 //y2=6.2
cc_14 ( N_VDD_c_7_p N_noxref_2_c_49_n ) capacitor c=0.0251394f //x=1.97 \
 //y=7.58 //x2=1.745 //y2=4.97
cc_15 ( N_VDD_c_3_p N_noxref_2_c_50_n ) capacitor c=0.00718224f //x=1.23 \
 //y=7.58 //x2=1.455 //y2=4.97
cc_16 ( N_VDD_c_7_p N_noxref_2_c_50_n ) capacitor c=2.63786e-19 //x=1.97 \
 //y=7.58 //x2=1.455 //y2=4.97
cc_17 ( N_VDD_M1_noxref_s N_noxref_2_c_50_n ) capacitor c=0.00687108f \
 //x=1.025 //y=5.2 //x2=1.455 //y2=4.97
cc_18 ( N_VDD_c_3_p Y ) capacitor c=0.00568389f //x=1.23 //y=7.58 //x2=1.6 \
 //y2=3.88
cc_19 ( N_VDD_c_7_p Y ) capacitor c=0.0213166f //x=1.97 //y=7.58 //x2=1.6 \
 //y2=3.88
cc_20 ( N_VDD_M1_noxref_s Y ) capacitor c=0.0160231f //x=1.025 //y=5.2 \
 //x2=1.6 //y2=3.88
cc_21 ( N_VDD_M2_noxref_d Y ) capacitor c=0.0146345f //x=1.895 //y=5.2 \
 //x2=1.6 //y2=3.88
cc_22 ( N_VDD_c_1_p N_Y_c_106_n ) capacitor c=0.00266544f //x=1.97 //y=7.58 \
 //x2=1.6 //y2=5.45
cc_23 ( N_VDD_c_2_p N_Y_c_106_n ) capacitor c=0.00102429f //x=1.955 //y=7.585 \
 //x2=1.6 //y2=5.45
cc_24 ( N_VDD_M1_noxref_s N_Y_c_106_n ) capacitor c=0.0404878f //x=1.025 \
 //y=5.2 //x2=1.6 //y2=5.45
cc_25 ( N_VDD_M2_noxref_d N_Y_c_106_n ) capacitor c=0.040935f //x=1.895 \
 //y=5.2 //x2=1.6 //y2=5.45
cc_26 ( N_VDD_c_1_p N_Y_c_110_n ) capacitor c=0.00242317f //x=1.97 //y=7.58 \
 //x2=1.6 //y2=5.565
cc_27 ( N_VDD_c_2_p N_Y_c_110_n ) capacitor c=0.013807f //x=1.955 //y=7.585 \
 //x2=1.6 //y2=5.565
cc_28 ( N_VDD_c_3_p N_Y_c_110_n ) capacitor c=0.00833402f //x=1.23 //y=7.58 \
 //x2=1.6 //y2=5.565
cc_29 ( N_VDD_c_7_p N_Y_c_110_n ) capacitor c=0.00968483f //x=1.97 //y=7.58 \
 //x2=1.6 //y2=5.565
cc_30 ( N_VDD_M1_noxref_s N_Y_c_110_n ) capacitor c=0.0924216f //x=1.025 \
 //y=5.2 //x2=1.6 //y2=5.565
cc_31 ( N_VDD_M2_noxref_d N_Y_c_110_n ) capacitor c=0.0924052f //x=1.895 \
 //y=5.2 //x2=1.6 //y2=5.565
cc_32 ( N_VDD_M1_noxref_s N_GND_c_132_n ) capacitor c=2.22637e-19 //x=1.025 \
 //y=5.2 //x2=1.12 //y2=0.59
cc_33 ( N_VDD_M2_noxref_d N_GND_c_133_n ) capacitor c=0.00107454f //x=1.895 \
 //y=5.2 //x2=2.09 //y2=0.59
cc_34 ( N_VDD_c_3_p N_GND_c_134_n ) capacitor c=0.00989514f //x=1.23 //y=7.58 \
 //x2=1.23 //y2=0.18
cc_35 ( N_VDD_c_7_p N_GND_c_135_n ) capacitor c=0.00989514f //x=1.97 //y=7.58 \
 //x2=1.97 //y2=0.18
cc_36 ( N_noxref_2_c_36_n Y ) capacitor c=0.12543f //x=1.23 //y=4.765 //x2=1.6 \
 //y2=3.88
cc_37 ( N_noxref_2_c_54_p Y ) capacitor c=0.00600246f //x=1.23 //y=2.26 \
 //x2=1.6 //y2=3.88
cc_38 ( N_noxref_2_c_40_n Y ) capacitor c=0.00714031f //x=1.23 //y=4.88 \
 //x2=1.6 //y2=3.88
cc_39 ( N_noxref_2_M1_noxref_g Y ) capacitor c=0.00414917f //x=1.38 //y=6.2 \
 //x2=1.6 //y2=3.88
cc_40 ( N_noxref_2_M2_noxref_g Y ) capacitor c=0.00414917f //x=1.82 //y=6.2 \
 //x2=1.6 //y2=3.88
cc_41 ( N_noxref_2_c_49_n Y ) capacitor c=0.00949429f //x=1.745 //y=4.97 \
 //x2=1.6 //y2=3.88
cc_42 ( N_noxref_2_c_50_n Y ) capacitor c=0.00147568f //x=1.455 //y=4.97 \
 //x2=1.6 //y2=3.88
cc_43 ( N_noxref_2_M0_noxref_d Y ) capacitor c=7.36288e-19 //x=1.415 //y=1.085 \
 //x2=1.6 //y2=3.88
cc_44 ( N_noxref_2_c_61_p N_Y_c_106_n ) capacitor c=3.41178e-19 //x=1.6 \
 //y=1.3 //x2=1.6 //y2=5.45
cc_45 ( N_noxref_2_c_54_p N_Y_c_106_n ) capacitor c=3.1905e-19 //x=1.23 \
 //y=2.26 //x2=1.6 //y2=5.45
cc_46 ( N_noxref_2_M1_noxref_g N_Y_c_106_n ) capacitor c=0.00125619f //x=1.38 \
 //y=6.2 //x2=1.6 //y2=5.45
cc_47 ( N_noxref_2_M2_noxref_g N_Y_c_106_n ) capacitor c=0.00126667f //x=1.82 \
 //y=6.2 //x2=1.6 //y2=5.45
cc_48 ( N_noxref_2_M1_noxref_g N_Y_c_110_n ) capacitor c=0.0161837f //x=1.38 \
 //y=6.2 //x2=1.6 //y2=5.565
cc_49 ( N_noxref_2_M2_noxref_g N_Y_c_110_n ) capacitor c=0.0161837f //x=1.82 \
 //y=6.2 //x2=1.6 //y2=5.565
cc_50 ( N_noxref_2_c_49_n N_Y_c_110_n ) capacitor c=0.00259313f //x=1.745 \
 //y=4.97 //x2=1.6 //y2=5.565
cc_51 ( N_noxref_2_c_54_p N_GND_c_132_n ) capacitor c=0.00260482f //x=1.23 \
 //y=2.26 //x2=1.12 //y2=0.59
cc_52 ( N_noxref_2_c_69_p N_GND_c_132_n ) capacitor c=7.55036e-19 //x=1.23 \
 //y=2.26 //x2=1.12 //y2=0.59
cc_53 ( N_noxref_2_c_54_p N_GND_c_138_n ) capacitor c=0.00360187f //x=1.23 \
 //y=2.26 //x2=1.485 //y2=0.71
cc_54 ( N_noxref_2_c_69_p N_GND_c_138_n ) capacitor c=6.00824e-19 //x=1.23 \
 //y=2.26 //x2=1.485 //y2=0.71
cc_55 ( N_noxref_2_c_61_p N_GND_c_140_n ) capacitor c=0.0344593f //x=1.6 \
 //y=1.3 //x2=1.725 //y2=0.71
cc_56 ( N_noxref_2_c_73_p N_GND_c_140_n ) capacitor c=0.00429072f //x=1.34 \
 //y=1.085 //x2=1.725 //y2=0.71
cc_57 ( N_noxref_2_M0_noxref_d N_GND_c_140_n ) capacitor c=0.00300031f \
 //x=1.415 //y=1.085 //x2=1.725 //y2=0.71
cc_58 ( N_noxref_2_c_36_n N_GND_c_134_n ) capacitor c=0.0177023f //x=1.23 \
 //y=4.765 //x2=1.23 //y2=0.18
cc_59 ( N_noxref_2_c_76_p N_GND_c_134_n ) capacitor c=0.005176f //x=1.6 \
 //y=2.155 //x2=1.23 //y2=0.18
cc_60 ( N_noxref_2_c_54_p N_GND_c_134_n ) capacitor c=0.00794726f //x=1.23 \
 //y=2.26 //x2=1.23 //y2=0.18
cc_61 ( N_noxref_2_c_69_p N_GND_c_134_n ) capacitor c=0.00735633f //x=1.23 \
 //y=2.26 //x2=1.23 //y2=0.18
cc_62 ( N_noxref_2_c_79_p N_GND_c_134_n ) capacitor c=0.00574455f //x=1.34 \
 //y=2.095 //x2=1.23 //y2=0.18
cc_63 ( N_noxref_2_c_80_p N_GND_c_134_n ) capacitor c=0.00785703f //x=1.23 \
 //y=2.26 //x2=1.23 //y2=0.18
cc_64 ( N_noxref_2_c_36_n N_GND_c_135_n ) capacitor c=0.00850867f //x=1.23 \
 //y=4.765 //x2=1.97 //y2=0.18
cc_65 ( N_noxref_2_c_76_p N_GND_c_135_n ) capacitor c=0.0122417f //x=1.6 \
 //y=2.155 //x2=1.97 //y2=0.18
cc_66 ( N_noxref_2_c_54_p N_GND_c_135_n ) capacitor c=0.00159001f //x=1.23 \
 //y=2.26 //x2=1.97 //y2=0.18
cc_67 ( N_noxref_2_c_69_p N_GND_c_135_n ) capacitor c=0.00246074f //x=1.23 \
 //y=2.26 //x2=1.97 //y2=0.18
cc_68 ( N_noxref_2_c_61_p N_GND_c_153_n ) capacitor c=0.00405613f //x=1.6 \
 //y=1.3 //x2=2.005 //y2=0.71
cc_69 ( N_noxref_2_c_54_p N_GND_c_153_n ) capacitor c=0.00226503f //x=1.23 \
 //y=2.26 //x2=2.005 //y2=0.71
cc_70 ( N_noxref_2_c_73_p N_GND_c_153_n ) capacitor c=0.0196609f //x=1.34 \
 //y=1.085 //x2=2.005 //y2=0.71
cc_71 ( N_noxref_2_c_88_p N_GND_c_153_n ) capacitor c=0.00747944f //x=1.87 \
 //y=1.085 //x2=2.005 //y2=0.71
cc_72 ( N_noxref_2_c_80_p N_GND_c_153_n ) capacitor c=2.1838e-19 //x=1.23 \
 //y=2.26 //x2=2.005 //y2=0.71
cc_73 ( N_noxref_2_M0_noxref_d N_GND_c_153_n ) capacitor c=0.0127526f \
 //x=1.415 //y=1.085 //x2=2.005 //y2=0.71
cc_74 ( N_noxref_2_c_61_p N_GND_M0_noxref_s ) capacitor c=0.0136501f //x=1.6 \
 //y=1.3 //x2=0.985 //y2=0.545
cc_75 ( N_noxref_2_c_76_p N_GND_M0_noxref_s ) capacitor c=0.0376852f //x=1.6 \
 //y=2.155 //x2=0.985 //y2=0.545
cc_76 ( N_noxref_2_c_54_p N_GND_M0_noxref_s ) capacitor c=0.00218887f //x=1.23 \
 //y=2.26 //x2=0.985 //y2=0.545
cc_77 ( N_noxref_2_c_69_p N_GND_M0_noxref_s ) capacitor c=0.00646196f //x=1.23 \
 //y=2.26 //x2=0.985 //y2=0.545
cc_78 ( N_noxref_2_c_73_p N_GND_M0_noxref_s ) capacitor c=0.0299684f //x=1.34 \
 //y=1.085 //x2=0.985 //y2=0.545
cc_79 ( N_noxref_2_c_96_p N_GND_M0_noxref_s ) capacitor c=0.002132f //x=1.34 \
 //y=1.74 //x2=0.985 //y2=0.545
cc_80 ( N_noxref_2_c_79_p N_GND_M0_noxref_s ) capacitor c=0.00304786f //x=1.34 \
 //y=2.095 //x2=0.985 //y2=0.545
cc_81 ( N_noxref_2_c_88_p N_GND_M0_noxref_s ) capacitor c=0.0153553f //x=1.87 \
 //y=1.085 //x2=0.985 //y2=0.545
cc_82 ( N_noxref_2_c_99_p N_GND_M0_noxref_s ) capacitor c=0.00629878f //x=1.87 \
 //y=1.43 //x2=0.985 //y2=0.545
cc_83 ( N_noxref_2_c_80_p N_GND_M0_noxref_s ) capacitor c=0.00653896f //x=1.23 \
 //y=2.26 //x2=0.985 //y2=0.545
cc_84 ( N_noxref_2_M0_noxref_d N_GND_M0_noxref_s ) capacitor c=0.0275629f \
 //x=1.415 //y=1.085 //x2=0.985 //y2=0.545
cc_85 ( Y N_GND_c_140_n ) capacitor c=2.8224e-19 //x=1.6 //y=3.88 //x2=1.725 \
 //y2=0.71
