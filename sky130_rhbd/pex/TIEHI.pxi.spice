// File: TIEHI.spi.TIEHI.pxi
// Created: Tue Apr 29 10:44:27 2025
//
simulator lang=spectre
x_PM_TIEHI\%GND ( GND N_GND_c_3_p N_GND_c_4_p N_GND_c_12_p N_GND_c_1_p \
 N_GND_c_2_p N_GND_M0_noxref_s )  PM_TIEHI\%GND
x_PM_TIEHI\%VDD ( VDD N_VDD_c_37_p N_VDD_c_29_p N_VDD_c_24_n N_VDD_c_25_n \
 N_VDD_M1_noxref_s N_VDD_M2_noxref_d )  PM_TIEHI\%VDD
x_PM_TIEHI\%noxref_3 ( N_noxref_3_c_43_n N_noxref_3_c_47_n N_noxref_3_c_75_p \
 N_noxref_3_M0_noxref_g N_noxref_3_M1_noxref_g N_noxref_3_M2_noxref_g \
 N_noxref_3_c_48_n N_noxref_3_c_50_n N_noxref_3_c_71_n N_noxref_3_c_72_n \
 N_noxref_3_c_51_n N_noxref_3_c_52_n N_noxref_3_c_54_n N_noxref_3_c_55_n \
 N_noxref_3_M0_noxref_d )  PM_TIEHI\%noxref_3
x_PM_TIEHI\%Y ( Y Y Y N_Y_M1_noxref_d )  PM_TIEHI\%Y
cc_1 ( N_GND_c_1_p N_VDD_c_24_n ) capacitor c=0.00989514f //x=1.12 //y=0.175 \
 //x2=1.23 //y2=7.58
cc_2 ( N_GND_c_2_p N_VDD_c_25_n ) capacitor c=0.00989514f //x=2.09 //y=0.175 \
 //x2=1.97 //y2=7.58
cc_3 ( N_GND_c_3_p N_noxref_3_c_43_n ) capacitor c=0.003105f //x=1.97 //y=0.18 \
 //x2=1.23 //y2=2.265
cc_4 ( N_GND_c_4_p N_noxref_3_c_43_n ) capacitor c=0.00306364f //x=1.515 \
 //y=0.71 //x2=1.23 //y2=2.265
cc_5 ( N_GND_c_1_p N_noxref_3_c_43_n ) capacitor c=0.0301214f //x=1.12 \
 //y=0.175 //x2=1.23 //y2=2.265
cc_6 ( N_GND_M0_noxref_s N_noxref_3_c_43_n ) capacitor c=0.00834276f //x=0.985 \
 //y=0.545 //x2=1.23 //y2=2.265
cc_7 ( N_GND_c_2_p N_noxref_3_c_47_n ) capacitor c=0.0103271f //x=2.09 \
 //y=0.175 //x2=1.23 //y2=4.88
cc_8 ( N_GND_c_4_p N_noxref_3_c_48_n ) capacitor c=0.0114956f //x=1.515 \
 //y=0.71 //x2=1.34 //y2=1.085
cc_9 ( N_GND_M0_noxref_s N_noxref_3_c_48_n ) capacitor c=0.0315727f //x=0.985 \
 //y=0.545 //x2=1.34 //y2=1.085
cc_10 ( N_GND_c_1_p N_noxref_3_c_50_n ) capacitor c=0.0124051f //x=1.12 \
 //y=0.175 //x2=1.34 //y2=2.095
cc_11 ( N_GND_M0_noxref_s N_noxref_3_c_51_n ) capacitor c=0.00483644f \
 //x=0.985 //y=0.545 //x2=1.715 //y2=0.93
cc_12 ( N_GND_c_12_p N_noxref_3_c_52_n ) capacitor c=0.0126941f //x=2.005 \
 //y=0.71 //x2=1.87 //y2=1.085
cc_13 ( N_GND_M0_noxref_s N_noxref_3_c_52_n ) capacitor c=0.0143355f //x=0.985 \
 //y=0.545 //x2=1.87 //y2=1.085
cc_14 ( N_GND_M0_noxref_s N_noxref_3_c_54_n ) capacitor c=0.0074042f //x=0.985 \
 //y=0.545 //x2=1.87 //y2=1.43
cc_15 ( N_GND_c_4_p N_noxref_3_c_55_n ) capacitor c=2.1838e-19 //x=1.515 \
 //y=0.71 //x2=1.23 //y2=2.26
cc_16 ( N_GND_c_1_p N_noxref_3_c_55_n ) capacitor c=0.0118013f //x=1.12 \
 //y=0.175 //x2=1.23 //y2=2.26
cc_17 ( N_GND_c_2_p N_noxref_3_c_55_n ) capacitor c=5.27572e-19 //x=2.09 \
 //y=0.175 //x2=1.23 //y2=2.26
cc_18 ( N_GND_M0_noxref_s N_noxref_3_c_55_n ) capacitor c=0.00650255f \
 //x=0.985 //y=0.545 //x2=1.23 //y2=2.26
cc_19 ( N_GND_c_3_p N_noxref_3_M0_noxref_d ) capacitor c=0.00195867f //x=1.97 \
 //y=0.18 //x2=1.415 //y2=1.085
cc_20 ( N_GND_c_1_p N_noxref_3_M0_noxref_d ) capacitor c=0.00795703f //x=1.12 \
 //y=0.175 //x2=1.415 //y2=1.085
cc_21 ( N_GND_c_2_p N_noxref_3_M0_noxref_d ) capacitor c=0.0129914f //x=2.09 \
 //y=0.175 //x2=1.415 //y2=1.085
cc_22 ( N_GND_M0_noxref_s N_noxref_3_M0_noxref_d ) capacitor c=0.0914914f \
 //x=0.985 //y=0.545 //x2=1.415 //y2=1.085
cc_23 ( N_GND_M0_noxref_s Y ) capacitor c=6.59536e-19 //x=0.985 //y=0.545 \
 //x2=1.6 //y2=3.88
cc_24 ( N_VDD_c_24_n N_noxref_3_c_47_n ) capacitor c=0.0276175f //x=1.23 \
 //y=7.58 //x2=1.23 //y2=4.88
cc_25 ( N_VDD_c_25_n N_noxref_3_c_47_n ) capacitor c=0.00120599f //x=1.97 \
 //y=7.58 //x2=1.23 //y2=4.88
cc_26 ( N_VDD_M1_noxref_s N_noxref_3_c_47_n ) capacitor c=0.0123296f //x=1.025 \
 //y=5.2 //x2=1.23 //y2=4.88
cc_27 ( N_VDD_c_29_p N_noxref_3_M1_noxref_g ) capacitor c=0.00751968f \
 //x=1.955 //y=7.585 //x2=1.38 //y2=6.2
cc_28 ( N_VDD_c_24_n N_noxref_3_M1_noxref_g ) capacitor c=0.0230612f //x=1.23 \
 //y=7.58 //x2=1.38 //y2=6.2
cc_29 ( N_VDD_M1_noxref_s N_noxref_3_M1_noxref_g ) capacitor c=0.0556551f \
 //x=1.025 //y=5.2 //x2=1.38 //y2=6.2
cc_30 ( N_VDD_c_29_p N_noxref_3_M2_noxref_g ) capacitor c=0.00755544f \
 //x=1.955 //y=7.585 //x2=1.82 //y2=6.2
cc_31 ( N_VDD_M2_noxref_d N_noxref_3_M2_noxref_g ) capacitor c=0.0556551f \
 //x=1.895 //y=5.2 //x2=1.82 //y2=6.2
cc_32 ( N_VDD_c_25_n N_noxref_3_c_71_n ) capacitor c=0.0274323f //x=1.97 \
 //y=7.58 //x2=1.745 //y2=4.97
cc_33 ( N_VDD_c_24_n N_noxref_3_c_72_n ) capacitor c=0.0111304f //x=1.23 \
 //y=7.58 //x2=1.455 //y2=4.97
cc_34 ( N_VDD_M1_noxref_s N_noxref_3_c_72_n ) capacitor c=0.00804139f \
 //x=1.025 //y=5.2 //x2=1.455 //y2=4.97
cc_35 ( N_VDD_c_37_p Y ) capacitor c=0.00727134f //x=1.97 //y=7.58 //x2=1.6 \
 //y2=3.88
cc_36 ( N_VDD_c_29_p Y ) capacitor c=0.0139926f //x=1.955 //y=7.585 //x2=1.6 \
 //y2=3.88
cc_37 ( N_VDD_c_24_n Y ) capacitor c=0.0172244f //x=1.23 //y=7.58 //x2=1.6 \
 //y2=3.88
cc_38 ( N_VDD_c_25_n Y ) capacitor c=0.0336531f //x=1.97 //y=7.58 //x2=1.6 \
 //y2=3.88
cc_39 ( N_VDD_M1_noxref_s Y ) capacitor c=0.089071f //x=1.025 //y=5.2 //x2=1.6 \
 //y2=3.88
cc_40 ( N_VDD_M2_noxref_d Y ) capacitor c=0.089071f //x=1.895 //y=5.2 //x2=1.6 \
 //y2=3.88
cc_41 ( N_noxref_3_c_47_n Y ) capacitor c=0.0835236f //x=1.23 //y=4.88 \
 //x2=1.6 //y2=3.88
cc_42 ( N_noxref_3_c_75_p Y ) capacitor c=0.00405488f //x=1.515 //y=2.18 \
 //x2=1.6 //y2=3.88
cc_43 ( N_noxref_3_M1_noxref_g Y ) capacitor c=0.0212031f //x=1.38 //y=6.2 \
 //x2=1.6 //y2=3.88
cc_44 ( N_noxref_3_M2_noxref_g Y ) capacitor c=0.0212031f //x=1.82 //y=6.2 \
 //x2=1.6 //y2=3.88
cc_45 ( N_noxref_3_c_71_n Y ) capacitor c=0.0158262f //x=1.745 //y=4.97 \
 //x2=1.6 //y2=3.88
cc_46 ( N_noxref_3_c_72_n Y ) capacitor c=0.00927197f //x=1.455 //y=4.97 \
 //x2=1.6 //y2=3.88
