// File: aoa4x1_pcell.spi.AOA4X1_PCELL.pxi
// Created: Fri Feb 20 10:18:29 2026
//
simulator lang=spectre
x_PM_AOA4X1_PCELL\%noxref_1 ( N_noxref_1_c_43_p N_noxref_1_c_10_p \
 N_noxref_1_c_30_p N_noxref_1_c_17_p N_noxref_1_c_255_p N_noxref_1_c_25_p \
 N_noxref_1_c_111_p N_noxref_1_c_27_p N_noxref_1_c_26_p N_noxref_1_c_18_p \
 N_noxref_1_c_28_p N_noxref_1_c_45_p N_noxref_1_c_46_p N_noxref_1_c_47_p \
 N_noxref_1_c_1_p N_noxref_1_c_90_p N_noxref_1_c_31_p N_noxref_1_c_2_p \
 N_noxref_1_c_71_p N_noxref_1_c_116_p N_noxref_1_c_20_p N_noxref_1_c_72_p \
 N_noxref_1_c_48_p N_noxref_1_c_49_p N_noxref_1_c_29_p N_noxref_1_c_3_p \
 N_noxref_1_M2_noxref_g N_noxref_1_M11_noxref_g N_noxref_1_M12_noxref_g \
 N_noxref_1_c_4_p N_noxref_1_c_5_p N_noxref_1_c_12_p N_noxref_1_c_13_p \
 N_noxref_1_c_6_p N_noxref_1_c_7_p N_noxref_1_c_95_p N_noxref_1_c_8_p \
 N_noxref_1_c_9_p N_noxref_1_c_76_p N_noxref_1_M1_noxref_d \
 N_noxref_1_M7_noxref_d N_noxref_1_M9_noxref_d )  PM_AOA4X1_PCELL\%noxref_1
x_PM_AOA4X1_PCELL\%noxref_2 ( N_noxref_2_c_265_n N_noxref_2_c_274_n \
 N_noxref_2_c_280_n N_noxref_2_c_281_n N_noxref_2_c_323_p N_noxref_2_c_287_n \
 N_noxref_2_c_331_p N_noxref_2_c_310_p N_noxref_2_c_289_n N_noxref_2_c_376_p \
 N_noxref_2_c_291_n N_noxref_2_c_312_p N_noxref_2_c_316_p N_noxref_2_c_294_n \
 N_noxref_2_c_295_n N_noxref_2_c_324_p N_noxref_2_c_427_p N_noxref_2_c_318_p \
 N_noxref_2_c_314_p N_noxref_2_c_296_n N_noxref_2_c_325_p N_noxref_2_c_344_p \
 N_noxref_2_c_335_p N_noxref_2_c_429_p N_noxref_2_c_319_p \
 N_noxref_2_M4_noxref_g N_noxref_2_M15_noxref_g N_noxref_2_M16_noxref_g \
 N_noxref_2_c_430_p N_noxref_2_c_431_p N_noxref_2_c_432_p N_noxref_2_c_461_p \
 N_noxref_2_c_433_p N_noxref_2_c_434_p N_noxref_2_c_435_p N_noxref_2_c_436_p \
 N_noxref_2_c_322_p N_noxref_2_M2_noxref_d N_noxref_2_M3_noxref_d \
 N_noxref_2_M13_noxref_d )  PM_AOA4X1_PCELL\%noxref_2
x_PM_AOA4X1_PCELL\%noxref_3 ( N_noxref_3_c_535_n N_noxref_3_c_536_n \
 N_noxref_3_c_560_p N_noxref_3_c_616_p N_noxref_3_c_538_n N_noxref_3_c_539_n \
 N_noxref_3_c_617_p N_noxref_3_c_541_n N_noxref_3_c_638_p N_noxref_3_c_608_p \
 N_noxref_3_c_561_p N_noxref_3_c_543_n N_noxref_3_c_563_p N_noxref_3_c_564_p \
 N_noxref_3_c_551_n N_noxref_3_c_552_n N_noxref_3_c_641_p N_noxref_3_c_620_p \
 N_noxref_3_c_553_n N_noxref_3_c_732_p N_noxref_3_c_586_p N_noxref_3_c_554_n \
 N_noxref_3_c_566_p N_noxref_3_c_621_p N_noxref_3_c_567_p \
 N_noxref_3_M6_noxref_g N_noxref_3_M19_noxref_g N_noxref_3_M20_noxref_g \
 N_noxref_3_c_631_p N_noxref_3_c_709_p N_noxref_3_c_656_p N_noxref_3_c_645_p \
 N_noxref_3_c_594_p N_noxref_3_c_590_p N_noxref_3_c_658_p N_noxref_3_c_712_p \
 N_noxref_3_c_633_p N_noxref_3_c_660_p N_noxref_3_c_632_p \
 N_noxref_3_M5_noxref_d N_noxref_3_M15_noxref_d N_noxref_3_M17_noxref_d )  \
 PM_AOA4X1_PCELL\%noxref_3
x_PM_AOA4X1_PCELL\%noxref_4 ( N_noxref_4_c_765_n N_noxref_4_c_772_n \
 N_noxref_4_c_774_n N_noxref_4_c_818_n N_noxref_4_c_776_n N_noxref_4_c_779_n \
 N_noxref_4_c_784_n N_noxref_4_c_823_n N_noxref_4_c_854_n N_noxref_4_c_859_n \
 N_noxref_4_c_786_n N_noxref_4_c_789_n N_noxref_4_c_799_n N_noxref_4_c_865_n \
 N_noxref_4_c_800_n N_noxref_4_M7_noxref_s N_noxref_4_M8_noxref_d \
 N_noxref_4_M10_noxref_d N_noxref_4_M11_noxref_d N_noxref_4_M15_noxref_s \
 N_noxref_4_M16_noxref_d N_noxref_4_M18_noxref_d N_noxref_4_M19_noxref_s \
 N_noxref_4_M20_noxref_d )  PM_AOA4X1_PCELL\%noxref_4
x_PM_AOA4X1_PCELL\%noxref_5 ( N_noxref_5_c_1028_p N_noxref_5_c_999_n \
 N_noxref_5_c_1001_n N_noxref_5_c_1025_p N_noxref_5_c_1003_n \
 N_noxref_5_M0_noxref_g N_noxref_5_M7_noxref_g N_noxref_5_M8_noxref_g \
 N_noxref_5_c_1042_p N_noxref_5_c_1043_p N_noxref_5_c_1045_p \
 N_noxref_5_c_1030_p N_noxref_5_c_1064_p N_noxref_5_c_1065_p \
 N_noxref_5_c_1044_p N_noxref_5_c_1046_p N_noxref_5_c_1010_n )  \
 PM_AOA4X1_PCELL\%noxref_5
x_PM_AOA4X1_PCELL\%noxref_6 ( N_noxref_6_c_1095_n N_noxref_6_c_1103_n \
 N_noxref_6_c_1105_n N_noxref_6_c_1106_n N_noxref_6_M1_noxref_g \
 N_noxref_6_M9_noxref_g N_noxref_6_M10_noxref_g N_noxref_6_c_1114_n \
 N_noxref_6_c_1116_n N_noxref_6_c_1119_n N_noxref_6_c_1120_n \
 N_noxref_6_c_1123_n N_noxref_6_c_1125_n N_noxref_6_c_1129_n \
 N_noxref_6_c_1131_n N_noxref_6_c_1135_n N_noxref_6_c_1136_n \
 N_noxref_6_c_1138_n )  PM_AOA4X1_PCELL\%noxref_6
x_PM_AOA4X1_PCELL\%noxref_7 ( N_noxref_7_c_1199_n N_noxref_7_c_1222_n \
 N_noxref_7_c_1205_n N_noxref_7_c_1212_n N_noxref_7_c_1213_n \
 N_noxref_7_c_1229_n N_noxref_7_c_1214_n N_noxref_7_c_1218_n \
 N_noxref_7_M11_noxref_s N_noxref_7_M12_noxref_d N_noxref_7_M14_noxref_d )  \
 PM_AOA4X1_PCELL\%noxref_7
x_PM_AOA4X1_PCELL\%noxref_8 ( N_noxref_8_c_1293_n N_noxref_8_c_1296_n \
 N_noxref_8_c_1299_n N_noxref_8_c_1307_n N_noxref_8_c_1311_n \
 N_noxref_8_M3_noxref_g N_noxref_8_M13_noxref_g N_noxref_8_M14_noxref_g \
 N_noxref_8_c_1318_n N_noxref_8_c_1320_n N_noxref_8_c_1323_n \
 N_noxref_8_c_1364_n N_noxref_8_c_1367_n N_noxref_8_c_1325_n \
 N_noxref_8_c_1326_n N_noxref_8_c_1327_n N_noxref_8_c_1328_n \
 N_noxref_8_c_1331_n N_noxref_8_c_1332_n )  PM_AOA4X1_PCELL\%noxref_8
x_PM_AOA4X1_PCELL\%noxref_9 ( N_noxref_9_c_1564_n N_noxref_9_c_1412_n \
 N_noxref_9_c_1513_n N_noxref_9_c_1418_n N_noxref_9_c_1574_n \
 N_noxref_9_c_1458_n N_noxref_9_c_1469_n N_noxref_9_c_1421_n \
 N_noxref_9_c_1423_n N_noxref_9_c_1644_p N_noxref_9_c_1425_n \
 N_noxref_9_c_1475_n N_noxref_9_c_1679_p N_noxref_9_c_1479_n \
 N_noxref_9_c_1480_n N_noxref_9_c_1673_p N_noxref_9_c_1525_n \
 N_noxref_9_c_1530_n N_noxref_9_c_1431_n N_noxref_9_c_1482_n \
 N_noxref_9_c_1532_n N_noxref_9_c_1442_n N_noxref_9_M0_noxref_d \
 N_noxref_9_M2_noxref_s N_noxref_9_M4_noxref_d N_noxref_9_M6_noxref_s )  \
 PM_AOA4X1_PCELL\%noxref_9
x_PM_AOA4X1_PCELL\%noxref_10 ( N_noxref_10_c_1687_n N_noxref_10_c_1698_n \
 N_noxref_10_c_1701_n N_noxref_10_c_1705_n N_noxref_10_M5_noxref_g \
 N_noxref_10_M17_noxref_g N_noxref_10_M18_noxref_g N_noxref_10_c_1711_n \
 N_noxref_10_c_1714_n N_noxref_10_c_1716_n N_noxref_10_c_1752_n \
 N_noxref_10_c_1755_n N_noxref_10_c_1757_n N_noxref_10_c_1719_n \
 N_noxref_10_c_1720_n N_noxref_10_c_1721_n N_noxref_10_c_1768_n \
 N_noxref_10_c_1724_n )  PM_AOA4X1_PCELL\%noxref_10
x_PM_AOA4X1_PCELL\%noxref_11 ( N_noxref_11_c_1796_n N_noxref_11_c_1803_n \
 N_noxref_11_c_1807_n N_noxref_11_c_1808_n N_noxref_11_c_1810_n \
 N_noxref_11_c_1811_n N_noxref_11_c_1814_n N_noxref_11_c_1827_n \
 N_noxref_11_c_1835_n N_noxref_11_M6_noxref_d N_noxref_11_M19_noxref_d )  \
 PM_AOA4X1_PCELL\%noxref_11
x_PM_AOA4X1_PCELL\%noxref_12 ( N_noxref_12_c_1886_n N_noxref_12_c_1887_n \
 N_noxref_12_c_1913_n N_noxref_12_c_1876_n N_noxref_12_c_1877_n \
 N_noxref_12_c_1923_n N_noxref_12_M0_noxref_s )  PM_AOA4X1_PCELL\%noxref_12
x_PM_AOA4X1_PCELL\%noxref_13 ( N_noxref_13_c_1937_n N_noxref_13_c_1939_n \
 N_noxref_13_c_1966_n N_noxref_13_c_1947_n N_noxref_13_c_1952_n \
 N_noxref_13_c_1976_n N_noxref_13_M4_noxref_s )  PM_AOA4X1_PCELL\%noxref_13
cc_1 ( N_noxref_1_c_1_p N_noxref_2_c_265_n ) capacitor c=0.00604284f //x=2.15 \
 //y=1 //x2=4.51 //y2=1.125
cc_2 ( N_noxref_1_c_2_p N_noxref_2_c_265_n ) capacitor c=0.00116613f //x=4.44 \
 //y=2.08 //x2=4.51 //y2=1.125
cc_3 ( N_noxref_1_c_3_p N_noxref_2_c_265_n ) capacitor c=7.02188e-19 //x=4.44 \
 //y=2.08 //x2=4.51 //y2=1.125
cc_4 ( N_noxref_1_c_4_p N_noxref_2_c_265_n ) capacitor c=6.06305e-19 //x=4.245 \
 //y=0.905 //x2=4.51 //y2=1.125
cc_5 ( N_noxref_1_c_5_p N_noxref_2_c_265_n ) capacitor c=0.00328491f //x=4.245 \
 //y=1.25 //x2=4.51 //y2=1.125
cc_6 ( N_noxref_1_c_6_p N_noxref_2_c_265_n ) capacitor c=5.29726e-19 //x=4.62 \
 //y=0.75 //x2=4.51 //y2=1.125
cc_7 ( N_noxref_1_c_7_p N_noxref_2_c_265_n ) capacitor c=6.14781e-19 //x=4.62 \
 //y=1.405 //x2=4.51 //y2=1.125
cc_8 ( N_noxref_1_c_8_p N_noxref_2_c_265_n ) capacitor c=5.57259e-19 //x=4.775 \
 //y=0.905 //x2=4.51 //y2=1.125
cc_9 ( N_noxref_1_c_9_p N_noxref_2_c_265_n ) capacitor c=0.00212774f //x=4.775 \
 //y=1.25 //x2=4.51 //y2=1.125
cc_10 ( N_noxref_1_c_10_p N_noxref_2_c_274_n ) capacitor c=0.00445584f \
 //x=2.15 //y=1.57 //x2=4.51 //y2=1.57
cc_11 ( N_noxref_1_c_5_p N_noxref_2_c_274_n ) capacitor c=0.00109347f \
 //x=4.245 //y=1.25 //x2=4.51 //y2=1.57
cc_12 ( N_noxref_1_c_12_p N_noxref_2_c_274_n ) capacitor c=0.00314841f \
 //x=4.245 //y=1.56 //x2=4.51 //y2=1.57
cc_13 ( N_noxref_1_c_13_p N_noxref_2_c_274_n ) capacitor c=0.00309965f \
 //x=4.245 //y=1.915 //x2=4.51 //y2=1.57
cc_14 ( N_noxref_1_c_7_p N_noxref_2_c_274_n ) capacitor c=0.00674367f //x=4.62 \
 //y=1.405 //x2=4.51 //y2=1.57
cc_15 ( N_noxref_1_c_9_p N_noxref_2_c_274_n ) capacitor c=0.00253555f \
 //x=4.775 //y=1.25 //x2=4.51 //y2=1.57
cc_16 ( N_noxref_1_c_9_p N_noxref_2_c_280_n ) capacitor c=7.25274e-19 \
 //x=4.775 //y=1.25 //x2=5.395 //y2=1.655
cc_17 ( N_noxref_1_c_17_p N_noxref_2_c_281_n ) capacitor c=0.00351497f \
 //x=2.505 //y=1.655 //x2=4.595 //y2=1.655
cc_18 ( N_noxref_1_c_18_p N_noxref_2_c_281_n ) capacitor c=0.00127002f \
 //x=4.44 //y=2.745 //x2=4.595 //y2=1.655
cc_19 ( N_noxref_1_c_2_p N_noxref_2_c_281_n ) capacitor c=0.0161272f //x=4.44 \
 //y=2.08 //x2=4.595 //y2=1.655
cc_20 ( N_noxref_1_c_20_p N_noxref_2_c_281_n ) capacitor c=6.59793e-19 \
 //x=4.435 //y=2.585 //x2=4.595 //y2=1.655
cc_21 ( N_noxref_1_c_3_p N_noxref_2_c_281_n ) capacitor c=0.00293572f //x=4.44 \
 //y=2.08 //x2=4.595 //y2=1.655
cc_22 ( N_noxref_1_c_13_p N_noxref_2_c_281_n ) capacitor c=0.00107086f \
 //x=4.245 //y=1.915 //x2=4.595 //y2=1.655
cc_23 ( N_noxref_1_c_10_p N_noxref_2_c_287_n ) capacitor c=6.26628e-19 \
 //x=2.15 //y=1.57 //x2=5.48 //y2=1.57
cc_24 ( N_noxref_1_c_9_p N_noxref_2_c_287_n ) capacitor c=6.29838e-19 \
 //x=4.775 //y=1.25 //x2=5.48 //y2=1.57
cc_25 ( N_noxref_1_c_25_p N_noxref_2_c_289_n ) capacitor c=0.00204276f \
 //x=2.59 //y=2.425 //x2=5.92 //y2=2.425
cc_26 ( N_noxref_1_c_26_p N_noxref_2_c_289_n ) capacitor c=9.83329e-19 \
 //x=4.44 //y=2.425 //x2=5.92 //y2=2.425
cc_27 ( N_noxref_1_c_27_p N_noxref_2_c_291_n ) capacitor c=0.00294086f \
 //x=2.59 //y=5.115 //x2=5.92 //y2=5.125
cc_28 ( N_noxref_1_c_28_p N_noxref_2_c_291_n ) capacitor c=0.00558958f \
 //x=4.44 //y=4.585 //x2=5.92 //y2=5.125
cc_29 ( N_noxref_1_c_29_p N_noxref_2_c_291_n ) capacitor c=2.44646e-19 \
 //x=4.285 //y=4.705 //x2=5.92 //y2=5.125
cc_30 ( N_noxref_1_c_30_p N_noxref_2_c_294_n ) capacitor c=7.34073e-19 \
 //x=2.505 //y=5.2 //x2=5.435 //y2=5.21
cc_31 ( N_noxref_1_c_31_p N_noxref_2_c_295_n ) capacitor c=0.00251935f \
 //x=4.44 //y=2.59 //x2=5.92 //y2=2.59
cc_32 ( N_noxref_1_c_20_p N_noxref_2_c_296_n ) capacitor c=0.00542346f \
 //x=4.435 //y=2.585 //x2=6.075 //y2=2.585
cc_33 ( N_noxref_1_c_18_p N_noxref_2_M2_noxref_d ) capacitor c=3.25483e-19 \
 //x=4.44 //y=2.745 //x2=4.32 //y2=0.905
cc_34 ( N_noxref_1_c_2_p N_noxref_2_M2_noxref_d ) capacitor c=7.18966e-19 \
 //x=4.44 //y=2.08 //x2=4.32 //y2=0.905
cc_35 ( N_noxref_1_c_3_p N_noxref_2_M2_noxref_d ) capacitor c=0.00150225f \
 //x=4.44 //y=2.08 //x2=4.32 //y2=0.905
cc_36 ( N_noxref_1_c_4_p N_noxref_2_M2_noxref_d ) capacitor c=0.00124139f \
 //x=4.245 //y=0.905 //x2=4.32 //y2=0.905
cc_37 ( N_noxref_1_c_5_p N_noxref_2_M2_noxref_d ) capacitor c=0.00237422f \
 //x=4.245 //y=1.25 //x2=4.32 //y2=0.905
cc_38 ( N_noxref_1_c_13_p N_noxref_2_M2_noxref_d ) capacitor c=4.64713e-19 \
 //x=4.245 //y=1.915 //x2=4.32 //y2=0.905
cc_39 ( N_noxref_1_c_6_p N_noxref_2_M2_noxref_d ) capacitor c=0.00213893f \
 //x=4.62 //y=0.75 //x2=4.32 //y2=0.905
cc_40 ( N_noxref_1_c_7_p N_noxref_2_M2_noxref_d ) capacitor c=0.00345753f \
 //x=4.62 //y=1.405 //x2=4.32 //y2=0.905
cc_41 ( N_noxref_1_c_8_p N_noxref_2_M2_noxref_d ) capacitor c=0.00211919f \
 //x=4.775 //y=0.905 //x2=4.32 //y2=0.905
cc_42 ( N_noxref_1_c_9_p N_noxref_2_M2_noxref_d ) capacitor c=0.00237422f \
 //x=4.775 //y=1.25 //x2=4.32 //y2=0.905
cc_43 ( N_noxref_1_c_43_p N_noxref_4_c_765_n ) capacitor c=0.00647565f \
 //x=1.995 //y=5.2 //x2=4.475 //y2=7.4
cc_44 ( N_noxref_1_c_30_p N_noxref_4_c_765_n ) capacitor c=0.0048744f \
 //x=2.505 //y=5.2 //x2=4.475 //y2=7.4
cc_45 ( N_noxref_1_c_45_p N_noxref_4_c_765_n ) capacitor c=0.00368144f \
 //x=1.23 //y=5.38 //x2=4.475 //y2=7.4
cc_46 ( N_noxref_1_c_46_p N_noxref_4_c_765_n ) capacitor c=8.41206e-19 \
 //x=2.11 //y=5.2 //x2=4.475 //y2=7.4
cc_47 ( N_noxref_1_c_47_p N_noxref_4_c_765_n ) capacitor c=0.00285294f \
 //x=2.11 //y=5.38 //x2=4.475 //y2=7.4
cc_48 ( N_noxref_1_c_48_p N_noxref_4_c_765_n ) capacitor c=0.00224727f \
 //x=1.23 //y=5.38 //x2=4.475 //y2=7.4
cc_49 ( N_noxref_1_c_49_p N_noxref_4_c_765_n ) capacitor c=0.00224727f \
 //x=2.11 //y=5.38 //x2=4.475 //y2=7.4
cc_50 ( N_noxref_1_M11_noxref_g N_noxref_4_c_772_n ) capacitor c=0.00122608f \
 //x=4.34 //y=6.025 //x2=4.56 //y2=6.855
cc_51 ( N_noxref_1_M12_noxref_g N_noxref_4_c_772_n ) capacitor c=0.00122608f \
 //x=4.78 //y=6.025 //x2=4.56 //y2=6.855
cc_52 ( N_noxref_1_M11_noxref_g N_noxref_4_c_774_n ) capacitor c=0.00205385f \
 //x=4.34 //y=6.025 //x2=4.56 //y2=7.23
cc_53 ( N_noxref_1_M12_noxref_g N_noxref_4_c_774_n ) capacitor c=0.00294739f \
 //x=4.78 //y=6.025 //x2=4.56 //y2=7.23
cc_54 ( N_noxref_1_c_43_p N_noxref_4_c_776_n ) capacitor c=0.00213214f \
 //x=1.995 //y=5.2 //x2=1.585 //y2=7.4
cc_55 ( N_noxref_1_c_45_p N_noxref_4_c_776_n ) capacitor c=9.98713e-19 \
 //x=1.23 //y=5.38 //x2=1.585 //y2=7.4
cc_56 ( N_noxref_1_c_48_p N_noxref_4_c_776_n ) capacitor c=0.0136475f //x=1.23 \
 //y=5.38 //x2=1.585 //y2=7.4
cc_57 ( N_noxref_1_c_43_p N_noxref_4_c_779_n ) capacitor c=0.00184538f \
 //x=1.995 //y=5.2 //x2=2.465 //y2=7.4
cc_58 ( N_noxref_1_c_30_p N_noxref_4_c_779_n ) capacitor c=0.00213214f \
 //x=2.505 //y=5.2 //x2=2.465 //y2=7.4
cc_59 ( N_noxref_1_c_46_p N_noxref_4_c_779_n ) capacitor c=5.38567e-19 \
 //x=2.11 //y=5.2 //x2=2.465 //y2=7.4
cc_60 ( N_noxref_1_c_47_p N_noxref_4_c_779_n ) capacitor c=5.78261e-19 \
 //x=2.11 //y=5.38 //x2=2.465 //y2=7.4
cc_61 ( N_noxref_1_c_49_p N_noxref_4_c_779_n ) capacitor c=0.0136475f //x=2.11 \
 //y=5.38 //x2=2.465 //y2=7.4
cc_62 ( N_noxref_1_M11_noxref_g N_noxref_4_c_784_n ) capacitor c=0.00715024f \
 //x=4.34 //y=6.025 //x2=6.49 //y2=7.4
cc_63 ( N_noxref_1_M12_noxref_g N_noxref_4_c_784_n ) capacitor c=0.00754867f \
 //x=4.78 //y=6.025 //x2=6.49 //y2=7.4
cc_64 ( N_noxref_1_c_27_p N_noxref_4_c_786_n ) capacitor c=0.00197052f \
 //x=2.59 //y=5.115 //x2=0.74 //y2=7.4
cc_65 ( N_noxref_1_c_45_p N_noxref_4_c_786_n ) capacitor c=6.39392e-19 \
 //x=1.23 //y=5.38 //x2=0.74 //y2=7.4
cc_66 ( N_noxref_1_c_48_p N_noxref_4_c_786_n ) capacitor c=0.0064135f //x=1.23 \
 //y=5.38 //x2=0.74 //y2=7.4
cc_67 ( N_noxref_1_c_27_p N_noxref_4_c_789_n ) capacitor c=0.0305833f //x=2.59 \
 //y=5.115 //x2=3.33 //y2=7.4
cc_68 ( N_noxref_1_c_28_p N_noxref_4_c_789_n ) capacitor c=0.00722719f \
 //x=4.44 //y=4.585 //x2=3.33 //y2=7.4
cc_69 ( N_noxref_1_c_46_p N_noxref_4_c_789_n ) capacitor c=0.00240948f \
 //x=2.11 //y=5.2 //x2=3.33 //y2=7.4
cc_70 ( N_noxref_1_c_47_p N_noxref_4_c_789_n ) capacitor c=4.09141e-19 \
 //x=2.11 //y=5.38 //x2=3.33 //y2=7.4
cc_71 ( N_noxref_1_c_71_p N_noxref_4_c_789_n ) capacitor c=0.00344941f \
 //x=4.285 //y=4.705 //x2=3.33 //y2=7.4
cc_72 ( N_noxref_1_c_72_p N_noxref_4_c_789_n ) capacitor c=0.00259238f \
 //x=4.275 //y=2.585 //x2=3.33 //y2=7.4
cc_73 ( N_noxref_1_c_49_p N_noxref_4_c_789_n ) capacitor c=0.0101448f //x=2.11 \
 //y=5.38 //x2=3.33 //y2=7.4
cc_74 ( N_noxref_1_c_29_p N_noxref_4_c_789_n ) capacitor c=0.00643194f \
 //x=4.285 //y=4.705 //x2=3.33 //y2=7.4
cc_75 ( N_noxref_1_M11_noxref_g N_noxref_4_c_789_n ) capacitor c=0.00898416f \
 //x=4.34 //y=6.025 //x2=3.33 //y2=7.4
cc_76 ( N_noxref_1_c_76_p N_noxref_4_c_789_n ) capacitor c=0.00438848f \
 //x=4.285 //y=4.705 //x2=3.33 //y2=7.4
cc_77 ( N_noxref_1_c_29_p N_noxref_4_c_799_n ) capacitor c=3.49022e-19 \
 //x=4.285 //y=4.705 //x2=6.66 //y2=7.4
cc_78 ( N_noxref_1_c_48_p N_noxref_4_c_800_n ) capacitor c=0.00135089f \
 //x=1.23 //y=5.38 //x2=11.47 //y2=7.4
cc_79 ( N_noxref_1_c_49_p N_noxref_4_c_800_n ) capacitor c=0.00135089f \
 //x=2.11 //y=5.38 //x2=11.47 //y2=7.4
cc_80 ( N_noxref_1_c_45_p N_noxref_4_M7_noxref_s ) capacitor c=0.062494f \
 //x=1.23 //y=5.38 //x2=0.655 //y2=5.02
cc_81 ( N_noxref_1_c_46_p N_noxref_4_M7_noxref_s ) capacitor c=6.52457e-19 \
 //x=2.11 //y=5.2 //x2=0.655 //y2=5.02
cc_82 ( N_noxref_1_c_48_p N_noxref_4_M7_noxref_s ) capacitor c=0.0906034f \
 //x=1.23 //y=5.38 //x2=0.655 //y2=5.02
cc_83 ( N_noxref_1_c_43_p N_noxref_4_M8_noxref_d ) capacitor c=0.00810167f \
 //x=1.995 //y=5.2 //x2=1.525 //y2=5.02
cc_84 ( N_noxref_1_c_45_p N_noxref_4_M8_noxref_d ) capacitor c=0.0043528f \
 //x=1.23 //y=5.38 //x2=1.525 //y2=5.02
cc_85 ( N_noxref_1_c_47_p N_noxref_4_M8_noxref_d ) capacitor c=0.0043528f \
 //x=2.11 //y=5.38 //x2=1.525 //y2=5.02
cc_86 ( N_noxref_1_c_48_p N_noxref_4_M8_noxref_d ) capacitor c=0.0654258f \
 //x=1.23 //y=5.38 //x2=1.525 //y2=5.02
cc_87 ( N_noxref_1_c_49_p N_noxref_4_M8_noxref_d ) capacitor c=0.0653553f \
 //x=2.11 //y=5.38 //x2=1.525 //y2=5.02
cc_88 ( N_noxref_1_c_30_p N_noxref_4_M10_noxref_d ) capacitor c=0.0100422f \
 //x=2.505 //y=5.2 //x2=2.405 //y2=5.02
cc_89 ( N_noxref_1_c_47_p N_noxref_4_M10_noxref_d ) capacitor c=0.00979407f \
 //x=2.11 //y=5.38 //x2=2.405 //y2=5.02
cc_90 ( N_noxref_1_c_90_p N_noxref_4_M10_noxref_d ) capacitor c=6.87188e-19 \
 //x=2.59 //y=2.59 //x2=2.405 //y2=5.02
cc_91 ( N_noxref_1_c_49_p N_noxref_4_M10_noxref_d ) capacitor c=0.0651828f \
 //x=2.11 //y=5.38 //x2=2.405 //y2=5.02
cc_92 ( N_noxref_1_c_31_p N_noxref_4_M11_noxref_d ) capacitor c=3.55297e-19 \
 //x=4.44 //y=2.59 //x2=4.415 //y2=5.025
cc_93 ( N_noxref_1_M11_noxref_g N_noxref_4_M11_noxref_d ) capacitor \
 c=0.0130453f //x=4.34 //y=6.025 //x2=4.415 //y2=5.025
cc_94 ( N_noxref_1_M12_noxref_g N_noxref_4_M11_noxref_d ) capacitor \
 c=0.0142727f //x=4.78 //y=6.025 //x2=4.415 //y2=5.025
cc_95 ( N_noxref_1_c_95_p N_noxref_4_M11_noxref_d ) capacitor c=0.00241874f \
 //x=4.705 //y=4.795 //x2=4.415 //y2=5.025
cc_96 ( N_noxref_1_c_45_p N_noxref_5_c_999_n ) capacitor c=0.0118546f //x=1.23 \
 //y=5.38 //x2=1.11 //y2=4.7
cc_97 ( N_noxref_1_c_48_p N_noxref_5_c_999_n ) capacitor c=0.00165549f \
 //x=1.23 //y=5.38 //x2=1.11 //y2=4.7
cc_98 ( N_noxref_1_c_25_p N_noxref_5_c_1001_n ) capacitor c=0.00100975f \
 //x=2.59 //y=2.425 //x2=1.112 //y2=4.56
cc_99 ( N_noxref_1_c_27_p N_noxref_5_c_1001_n ) capacitor c=0.00453113f \
 //x=2.59 //y=5.115 //x2=1.112 //y2=4.56
cc_100 ( N_noxref_1_c_45_p N_noxref_5_c_1003_n ) capacitor c=0.00277154f \
 //x=1.23 //y=5.38 //x2=1.11 //y2=4.7
cc_101 ( N_noxref_1_c_48_p N_noxref_5_c_1003_n ) capacitor c=0.00377369f \
 //x=1.23 //y=5.38 //x2=1.11 //y2=4.7
cc_102 ( N_noxref_1_c_45_p N_noxref_5_M7_noxref_g ) capacitor c=0.0020878f \
 //x=1.23 //y=5.38 //x2=1.01 //y2=6.02
cc_103 ( N_noxref_1_c_48_p N_noxref_5_M7_noxref_g ) capacitor c=0.0158358f \
 //x=1.23 //y=5.38 //x2=1.01 //y2=6.02
cc_104 ( N_noxref_1_c_43_p N_noxref_5_M8_noxref_g ) capacitor c=0.0129249f \
 //x=1.995 //y=5.2 //x2=1.45 //y2=6.02
cc_105 ( N_noxref_1_c_45_p N_noxref_5_M8_noxref_g ) capacitor c=0.00192712f \
 //x=1.23 //y=5.38 //x2=1.45 //y2=6.02
cc_106 ( N_noxref_1_c_48_p N_noxref_5_M8_noxref_g ) capacitor c=0.0178987f \
 //x=1.23 //y=5.38 //x2=1.45 //y2=6.02
cc_107 ( N_noxref_1_c_45_p N_noxref_5_c_1010_n ) capacitor c=0.00207241f \
 //x=1.23 //y=5.38 //x2=1.11 //y2=4.7
cc_108 ( N_noxref_1_c_48_p N_noxref_5_c_1010_n ) capacitor c=0.0043218f \
 //x=1.23 //y=5.38 //x2=1.11 //y2=4.7
cc_109 ( N_noxref_1_c_43_p N_noxref_6_c_1095_n ) capacitor c=0.0228479f \
 //x=1.995 //y=5.2 //x2=1.85 //y2=4.555
cc_110 ( N_noxref_1_c_25_p N_noxref_6_c_1095_n ) capacitor c=0.009049f \
 //x=2.59 //y=2.425 //x2=1.85 //y2=4.555
cc_111 ( N_noxref_1_c_111_p N_noxref_6_c_1095_n ) capacitor c=0.0148501f \
 //x=2.59 //y=2.745 //x2=1.85 //y2=4.555
cc_112 ( N_noxref_1_c_27_p N_noxref_6_c_1095_n ) capacitor c=0.100629f \
 //x=2.59 //y=5.115 //x2=1.85 //y2=4.555
cc_113 ( N_noxref_1_c_26_p N_noxref_6_c_1095_n ) capacitor c=6.23212e-19 \
 //x=4.44 //y=2.425 //x2=1.85 //y2=4.555
cc_114 ( N_noxref_1_c_28_p N_noxref_6_c_1095_n ) capacitor c=0.00288721f \
 //x=4.44 //y=4.585 //x2=1.85 //y2=4.555
cc_115 ( N_noxref_1_c_90_p N_noxref_6_c_1095_n ) capacitor c=6.15181e-19 \
 //x=2.59 //y=2.59 //x2=1.85 //y2=4.555
cc_116 ( N_noxref_1_c_116_p N_noxref_6_c_1095_n ) capacitor c=0.00687503f \
 //x=2.75 //y=2.585 //x2=1.85 //y2=4.555
cc_117 ( N_noxref_1_c_43_p N_noxref_6_c_1103_n ) capacitor c=2.77624e-19 \
 //x=1.995 //y=5.2 //x2=1.85 //y2=2.08
cc_118 ( N_noxref_1_c_25_p N_noxref_6_c_1103_n ) capacitor c=0.015397f \
 //x=2.59 //y=2.425 //x2=1.85 //y2=2.08
cc_119 ( N_noxref_1_c_25_p N_noxref_6_c_1105_n ) capacitor c=9.90728e-19 \
 //x=2.59 //y=2.425 //x2=1.85 //y2=2.08
cc_120 ( N_noxref_1_c_43_p N_noxref_6_c_1106_n ) capacitor c=0.00469257f \
 //x=1.995 //y=5.2 //x2=1.88 //y2=4.7
cc_121 ( N_noxref_1_c_27_p N_noxref_6_c_1106_n ) capacitor c=0.00342433f \
 //x=2.59 //y=5.115 //x2=1.88 //y2=4.7
cc_122 ( N_noxref_1_c_43_p N_noxref_6_M9_noxref_g ) capacitor c=0.00842859f \
 //x=1.995 //y=5.2 //x2=1.89 //y2=6.02
cc_123 ( N_noxref_1_c_46_p N_noxref_6_M9_noxref_g ) capacitor c=0.00192712f \
 //x=2.11 //y=5.2 //x2=1.89 //y2=6.02
cc_124 ( N_noxref_1_c_49_p N_noxref_6_M9_noxref_g ) capacitor c=0.0178987f \
 //x=2.11 //y=5.38 //x2=1.89 //y2=6.02
cc_125 ( N_noxref_1_c_30_p N_noxref_6_M10_noxref_g ) capacitor c=0.0115937f \
 //x=2.505 //y=5.2 //x2=2.33 //y2=6.02
cc_126 ( N_noxref_1_c_46_p N_noxref_6_M10_noxref_g ) capacitor c=0.00298276f \
 //x=2.11 //y=5.2 //x2=2.33 //y2=6.02
cc_127 ( N_noxref_1_c_49_p N_noxref_6_M10_noxref_g ) capacitor c=0.0178506f \
 //x=2.11 //y=5.38 //x2=2.33 //y2=6.02
cc_128 ( N_noxref_1_c_1_p N_noxref_6_c_1114_n ) capacitor c=0.00120406f \
 //x=2.15 //y=1 //x2=1.885 //y2=0.905
cc_129 ( N_noxref_1_M1_noxref_d N_noxref_6_c_1114_n ) capacitor c=0.00137165f \
 //x=1.96 //y=0.905 //x2=1.885 //y2=0.905
cc_130 ( N_noxref_1_c_10_p N_noxref_6_c_1116_n ) capacitor c=0.00127432f \
 //x=2.15 //y=1.57 //x2=1.885 //y2=1.25
cc_131 ( N_noxref_1_c_1_p N_noxref_6_c_1116_n ) capacitor c=0.00220847f \
 //x=2.15 //y=1 //x2=1.885 //y2=1.25
cc_132 ( N_noxref_1_M1_noxref_d N_noxref_6_c_1116_n ) capacitor c=0.00237422f \
 //x=1.96 //y=0.905 //x2=1.885 //y2=1.25
cc_133 ( N_noxref_1_c_10_p N_noxref_6_c_1119_n ) capacitor c=0.00454577f \
 //x=2.15 //y=1.57 //x2=1.885 //y2=1.56
cc_134 ( N_noxref_1_c_27_p N_noxref_6_c_1120_n ) capacitor c=0.00874009f \
 //x=2.59 //y=5.115 //x2=2.255 //y2=4.79
cc_135 ( N_noxref_1_c_46_p N_noxref_6_c_1120_n ) capacitor c=0.0020909f \
 //x=2.11 //y=5.2 //x2=2.255 //y2=4.79
cc_136 ( N_noxref_1_c_49_p N_noxref_6_c_1120_n ) capacitor c=0.00291714f \
 //x=2.11 //y=5.38 //x2=2.255 //y2=4.79
cc_137 ( N_noxref_1_c_1_p N_noxref_6_c_1123_n ) capacitor c=5.50523e-19 \
 //x=2.15 //y=1 //x2=2.26 //y2=0.75
cc_138 ( N_noxref_1_M1_noxref_d N_noxref_6_c_1123_n ) capacitor c=0.0020782f \
 //x=1.96 //y=0.905 //x2=2.26 //y2=0.75
cc_139 ( N_noxref_1_c_10_p N_noxref_6_c_1125_n ) capacitor c=0.00912818f \
 //x=2.15 //y=1.57 //x2=2.26 //y2=1.405
cc_140 ( N_noxref_1_c_17_p N_noxref_6_c_1125_n ) capacitor c=0.00194324f \
 //x=2.505 //y=1.655 //x2=2.26 //y2=1.405
cc_141 ( N_noxref_1_c_1_p N_noxref_6_c_1125_n ) capacitor c=5.67071e-19 \
 //x=2.15 //y=1 //x2=2.26 //y2=1.405
cc_142 ( N_noxref_1_M1_noxref_d N_noxref_6_c_1125_n ) capacitor c=0.00356097f \
 //x=1.96 //y=0.905 //x2=2.26 //y2=1.405
cc_143 ( N_noxref_1_c_1_p N_noxref_6_c_1129_n ) capacitor c=0.0010954f \
 //x=2.15 //y=1 //x2=2.415 //y2=0.905
cc_144 ( N_noxref_1_M1_noxref_d N_noxref_6_c_1129_n ) capacitor c=8.50095e-19 \
 //x=1.96 //y=0.905 //x2=2.415 //y2=0.905
cc_145 ( N_noxref_1_c_10_p N_noxref_6_c_1131_n ) capacitor c=0.00305472f \
 //x=2.15 //y=1.57 //x2=2.415 //y2=1.25
cc_146 ( N_noxref_1_c_17_p N_noxref_6_c_1131_n ) capacitor c=0.00323005f \
 //x=2.505 //y=1.655 //x2=2.415 //y2=1.25
cc_147 ( N_noxref_1_c_1_p N_noxref_6_c_1131_n ) capacitor c=0.00314842f \
 //x=2.15 //y=1 //x2=2.415 //y2=1.25
cc_148 ( N_noxref_1_M1_noxref_d N_noxref_6_c_1131_n ) capacitor c=0.00237422f \
 //x=1.96 //y=0.905 //x2=2.415 //y2=1.25
cc_149 ( N_noxref_1_c_25_p N_noxref_6_c_1135_n ) capacitor c=0.00285392f \
 //x=2.59 //y=2.425 //x2=1.85 //y2=2.08
cc_150 ( N_noxref_1_c_10_p N_noxref_6_c_1136_n ) capacitor c=0.00371023f \
 //x=2.15 //y=1.57 //x2=1.85 //y2=1.915
cc_151 ( N_noxref_1_c_25_p N_noxref_6_c_1136_n ) capacitor c=0.00341496f \
 //x=2.59 //y=2.425 //x2=1.85 //y2=1.915
cc_152 ( N_noxref_1_c_43_p N_noxref_6_c_1138_n ) capacitor c=9.8107e-19 \
 //x=1.995 //y=5.2 //x2=1.88 //y2=4.7
cc_153 ( N_noxref_1_c_27_p N_noxref_6_c_1138_n ) capacitor c=0.00142201f \
 //x=2.59 //y=5.115 //x2=1.88 //y2=4.7
cc_154 ( N_noxref_1_c_18_p N_noxref_7_c_1199_n ) capacitor c=4.98604e-19 \
 //x=4.44 //y=2.745 //x2=4.88 //y2=5.21
cc_155 ( N_noxref_1_c_71_p N_noxref_7_c_1199_n ) capacitor c=0.0078395f \
 //x=4.285 //y=4.705 //x2=4.88 //y2=5.21
cc_156 ( N_noxref_1_c_29_p N_noxref_7_c_1199_n ) capacitor c=0.00104675f \
 //x=4.285 //y=4.705 //x2=4.88 //y2=5.21
cc_157 ( N_noxref_1_M11_noxref_g N_noxref_7_c_1199_n ) capacitor c=0.00996264f \
 //x=4.34 //y=6.025 //x2=4.88 //y2=5.21
cc_158 ( N_noxref_1_M12_noxref_g N_noxref_7_c_1199_n ) capacitor c=0.00967241f \
 //x=4.78 //y=6.025 //x2=4.88 //y2=5.21
cc_159 ( N_noxref_1_c_95_p N_noxref_7_c_1199_n ) capacitor c=0.00189947f \
 //x=4.705 //y=4.795 //x2=4.88 //y2=5.21
cc_160 ( N_noxref_1_c_30_p N_noxref_7_c_1205_n ) capacitor c=0.00408808f \
 //x=2.505 //y=5.2 //x2=4.12 //y2=5.21
cc_161 ( N_noxref_1_c_46_p N_noxref_7_c_1205_n ) capacitor c=0.00518363f \
 //x=2.11 //y=5.2 //x2=4.12 //y2=5.21
cc_162 ( N_noxref_1_c_47_p N_noxref_7_c_1205_n ) capacitor c=3.28075e-19 \
 //x=2.11 //y=5.38 //x2=4.12 //y2=5.21
cc_163 ( N_noxref_1_c_71_p N_noxref_7_c_1205_n ) capacitor c=0.0243045f \
 //x=4.285 //y=4.705 //x2=4.12 //y2=5.21
cc_164 ( N_noxref_1_c_29_p N_noxref_7_c_1205_n ) capacitor c=0.00565356f \
 //x=4.285 //y=4.705 //x2=4.12 //y2=5.21
cc_165 ( N_noxref_1_M11_noxref_g N_noxref_7_c_1205_n ) capacitor c=0.00403872f \
 //x=4.34 //y=6.025 //x2=4.12 //y2=5.21
cc_166 ( N_noxref_1_c_76_p N_noxref_7_c_1205_n ) capacitor c=9.12041e-19 \
 //x=4.285 //y=4.705 //x2=4.12 //y2=5.21
cc_167 ( N_noxref_1_M12_noxref_g N_noxref_7_c_1212_n ) capacitor c=0.0018094f \
 //x=4.78 //y=6.025 //x2=5 //y2=5.21
cc_168 ( N_noxref_1_M12_noxref_g N_noxref_7_c_1213_n ) capacitor c=0.00180782f \
 //x=4.78 //y=6.025 //x2=5 //y2=6.74
cc_169 ( N_noxref_1_c_71_p N_noxref_7_c_1214_n ) capacitor c=0.00154424f \
 //x=4.285 //y=4.705 //x2=4.12 //y2=5.38
cc_170 ( N_noxref_1_c_29_p N_noxref_7_c_1214_n ) capacitor c=0.00126834f \
 //x=4.285 //y=4.705 //x2=4.12 //y2=5.38
cc_171 ( N_noxref_1_M11_noxref_g N_noxref_7_c_1214_n ) capacitor c=0.0483843f \
 //x=4.34 //y=6.025 //x2=4.12 //y2=5.38
cc_172 ( N_noxref_1_c_76_p N_noxref_7_c_1214_n ) capacitor c=0.00297041f \
 //x=4.285 //y=4.705 //x2=4.12 //y2=5.38
cc_173 ( N_noxref_1_M12_noxref_g N_noxref_7_c_1218_n ) capacitor c=0.0170175f \
 //x=4.78 //y=6.025 //x2=5 //y2=5.38
cc_174 ( N_noxref_1_M11_noxref_g N_noxref_7_M11_noxref_s ) capacitor \
 c=0.00378422f //x=4.34 //y=6.025 //x2=3.985 //y2=5.025
cc_175 ( N_noxref_1_c_2_p N_noxref_8_c_1293_n ) capacitor c=0.0217252f \
 //x=4.44 //y=2.08 //x2=5.18 //y2=2.08
cc_176 ( N_noxref_1_c_3_p N_noxref_8_c_1293_n ) capacitor c=5.41079e-19 \
 //x=4.44 //y=2.08 //x2=5.18 //y2=2.08
cc_177 ( N_noxref_1_c_13_p N_noxref_8_c_1293_n ) capacitor c=0.00178181f \
 //x=4.245 //y=1.915 //x2=5.18 //y2=2.08
cc_178 ( N_noxref_1_c_71_p N_noxref_8_c_1296_n ) capacitor c=0.0486063f \
 //x=4.285 //y=4.705 //x2=5.215 //y2=4.705
cc_179 ( N_noxref_1_c_29_p N_noxref_8_c_1296_n ) capacitor c=0.00105182f \
 //x=4.285 //y=4.705 //x2=5.215 //y2=4.705
cc_180 ( N_noxref_1_c_95_p N_noxref_8_c_1296_n ) capacitor c=0.00107587f \
 //x=4.705 //y=4.795 //x2=5.215 //y2=4.705
cc_181 ( N_noxref_1_c_25_p N_noxref_8_c_1299_n ) capacitor c=6.5122e-19 \
 //x=2.59 //y=2.425 //x2=5.215 //y2=4.56
cc_182 ( N_noxref_1_c_27_p N_noxref_8_c_1299_n ) capacitor c=0.00351523f \
 //x=2.59 //y=5.115 //x2=5.215 //y2=4.56
cc_183 ( N_noxref_1_c_26_p N_noxref_8_c_1299_n ) capacitor c=0.00863767f \
 //x=4.44 //y=2.425 //x2=5.215 //y2=4.56
cc_184 ( N_noxref_1_c_18_p N_noxref_8_c_1299_n ) capacitor c=0.0146933f \
 //x=4.44 //y=2.745 //x2=5.215 //y2=4.56
cc_185 ( N_noxref_1_c_28_p N_noxref_8_c_1299_n ) capacitor c=0.0473875f \
 //x=4.44 //y=4.585 //x2=5.215 //y2=4.56
cc_186 ( N_noxref_1_c_31_p N_noxref_8_c_1299_n ) capacitor c=5.57251e-19 \
 //x=4.44 //y=2.59 //x2=5.215 //y2=4.56
cc_187 ( N_noxref_1_c_20_p N_noxref_8_c_1299_n ) capacitor c=0.00359337f \
 //x=4.435 //y=2.585 //x2=5.215 //y2=4.56
cc_188 ( N_noxref_1_c_3_p N_noxref_8_c_1299_n ) capacitor c=2.61947e-19 \
 //x=4.44 //y=2.08 //x2=5.215 //y2=4.56
cc_189 ( N_noxref_1_c_26_p N_noxref_8_c_1307_n ) capacitor c=2.61947e-19 \
 //x=4.44 //y=2.425 //x2=5.18 //y2=2.08
cc_190 ( N_noxref_1_c_2_p N_noxref_8_c_1307_n ) capacitor c=5.24865e-19 \
 //x=4.44 //y=2.08 //x2=5.18 //y2=2.08
cc_191 ( N_noxref_1_c_3_p N_noxref_8_c_1307_n ) capacitor c=0.00525888f \
 //x=4.44 //y=2.08 //x2=5.18 //y2=2.08
cc_192 ( N_noxref_1_c_13_p N_noxref_8_c_1307_n ) capacitor c=0.00190888f \
 //x=4.245 //y=1.915 //x2=5.18 //y2=2.08
cc_193 ( N_noxref_1_c_71_p N_noxref_8_c_1311_n ) capacitor c=4.32488e-19 \
 //x=4.285 //y=4.705 //x2=5.215 //y2=4.705
cc_194 ( N_noxref_1_c_29_p N_noxref_8_c_1311_n ) capacitor c=0.00242589f \
 //x=4.285 //y=4.705 //x2=5.215 //y2=4.705
cc_195 ( N_noxref_1_c_95_p N_noxref_8_c_1311_n ) capacitor c=0.00116837f \
 //x=4.705 //y=4.795 //x2=5.215 //y2=4.705
cc_196 ( N_noxref_1_c_76_p N_noxref_8_c_1311_n ) capacitor c=0.00121814f \
 //x=4.285 //y=4.705 //x2=5.215 //y2=4.705
cc_197 ( N_noxref_1_M11_noxref_g N_noxref_8_M13_noxref_g ) capacitor \
 c=0.0101077f //x=4.34 //y=6.025 //x2=5.22 //y2=6.025
cc_198 ( N_noxref_1_M12_noxref_g N_noxref_8_M13_noxref_g ) capacitor \
 c=0.109254f //x=4.78 //y=6.025 //x2=5.22 //y2=6.025
cc_199 ( N_noxref_1_M12_noxref_g N_noxref_8_M14_noxref_g ) capacitor \
 c=0.00945018f //x=4.78 //y=6.025 //x2=5.66 //y2=6.025
cc_200 ( N_noxref_1_c_4_p N_noxref_8_c_1318_n ) capacitor c=0.00125788f \
 //x=4.245 //y=0.905 //x2=5.215 //y2=0.905
cc_201 ( N_noxref_1_c_8_p N_noxref_8_c_1318_n ) capacitor c=0.0126654f \
 //x=4.775 //y=0.905 //x2=5.215 //y2=0.905
cc_202 ( N_noxref_1_c_5_p N_noxref_8_c_1320_n ) capacitor c=0.00149727f \
 //x=4.245 //y=1.25 //x2=5.215 //y2=1.255
cc_203 ( N_noxref_1_c_12_p N_noxref_8_c_1320_n ) capacitor c=0.00111802f \
 //x=4.245 //y=1.56 //x2=5.215 //y2=1.255
cc_204 ( N_noxref_1_c_9_p N_noxref_8_c_1320_n ) capacitor c=0.0126654f \
 //x=4.775 //y=1.25 //x2=5.215 //y2=1.255
cc_205 ( N_noxref_1_c_12_p N_noxref_8_c_1323_n ) capacitor c=0.00116305f \
 //x=4.245 //y=1.56 //x2=5.215 //y2=1.56
cc_206 ( N_noxref_1_c_9_p N_noxref_8_c_1323_n ) capacitor c=0.00938322f \
 //x=4.775 //y=1.25 //x2=5.215 //y2=1.56
cc_207 ( N_noxref_1_c_9_p N_noxref_8_c_1325_n ) capacitor c=0.00131492f \
 //x=4.775 //y=1.25 //x2=5.59 //y2=1.405
cc_208 ( N_noxref_1_c_8_p N_noxref_8_c_1326_n ) capacitor c=0.00132934f \
 //x=4.775 //y=0.905 //x2=5.745 //y2=0.905
cc_209 ( N_noxref_1_c_9_p N_noxref_8_c_1327_n ) capacitor c=0.00151998f \
 //x=4.775 //y=1.25 //x2=5.745 //y2=1.255
cc_210 ( N_noxref_1_c_2_p N_noxref_8_c_1328_n ) capacitor c=0.00173144f \
 //x=4.44 //y=2.08 //x2=5.18 //y2=2.08
cc_211 ( N_noxref_1_c_3_p N_noxref_8_c_1328_n ) capacitor c=0.0018937f \
 //x=4.44 //y=2.08 //x2=5.18 //y2=2.08
cc_212 ( N_noxref_1_c_13_p N_noxref_8_c_1328_n ) capacitor c=0.0181449f \
 //x=4.245 //y=1.915 //x2=5.18 //y2=2.08
cc_213 ( N_noxref_1_c_13_p N_noxref_8_c_1331_n ) capacitor c=0.00636965f \
 //x=4.245 //y=1.915 //x2=5.18 //y2=1.915
cc_214 ( N_noxref_1_c_28_p N_noxref_8_c_1332_n ) capacitor c=0.00117265f \
 //x=4.44 //y=4.585 //x2=5.215 //y2=4.705
cc_215 ( N_noxref_1_c_71_p N_noxref_8_c_1332_n ) capacitor c=4.8456e-19 \
 //x=4.285 //y=4.705 //x2=5.215 //y2=4.705
cc_216 ( N_noxref_1_c_29_p N_noxref_8_c_1332_n ) capacitor c=0.00211373f \
 //x=4.285 //y=4.705 //x2=5.215 //y2=4.705
cc_217 ( N_noxref_1_c_95_p N_noxref_8_c_1332_n ) capacitor c=0.0203928f \
 //x=4.705 //y=4.795 //x2=5.215 //y2=4.705
cc_218 ( N_noxref_1_c_76_p N_noxref_8_c_1332_n ) capacitor c=0.00590438f \
 //x=4.285 //y=4.705 //x2=5.215 //y2=4.705
cc_219 ( N_noxref_1_c_17_p N_noxref_9_c_1412_n ) capacitor c=0.00653239f \
 //x=2.505 //y=1.655 //x2=7.755 //y2=0
cc_220 ( N_noxref_1_c_111_p N_noxref_9_c_1412_n ) capacitor c=5.98346e-19 \
 //x=2.59 //y=2.745 //x2=7.755 //y2=0
cc_221 ( N_noxref_1_c_18_p N_noxref_9_c_1412_n ) capacitor c=3.68467e-19 \
 //x=4.44 //y=2.745 //x2=7.755 //y2=0
cc_222 ( N_noxref_1_c_1_p N_noxref_9_c_1412_n ) capacitor c=0.00963092f \
 //x=2.15 //y=1 //x2=7.755 //y2=0
cc_223 ( N_noxref_1_c_2_p N_noxref_9_c_1412_n ) capacitor c=8.82978e-19 \
 //x=4.44 //y=2.08 //x2=7.755 //y2=0
cc_224 ( N_noxref_1_M1_noxref_d N_noxref_9_c_1412_n ) capacitor c=3.01654e-19 \
 //x=1.96 //y=0.905 //x2=7.755 //y2=0
cc_225 ( N_noxref_1_c_45_p N_noxref_9_c_1418_n ) capacitor c=9.64329e-19 \
 //x=1.23 //y=5.38 //x2=1.18 //y2=0.955
cc_226 ( N_noxref_1_c_1_p N_noxref_9_c_1418_n ) capacitor c=0.0141894f \
 //x=2.15 //y=1 //x2=1.18 //y2=0.955
cc_227 ( N_noxref_1_M1_noxref_d N_noxref_9_c_1418_n ) capacitor c=2.93544e-19 \
 //x=1.96 //y=0.905 //x2=1.18 //y2=0.955
cc_228 ( N_noxref_1_c_17_p N_noxref_9_c_1421_n ) capacitor c=7.76556e-19 \
 //x=2.505 //y=1.655 //x2=3.16 //y2=0
cc_229 ( N_noxref_1_c_111_p N_noxref_9_c_1421_n ) capacitor c=4.78945e-19 \
 //x=2.59 //y=2.745 //x2=3.16 //y2=0
cc_230 ( N_noxref_1_c_25_p N_noxref_9_c_1423_n ) capacitor c=0.00139243f \
 //x=2.59 //y=2.425 //x2=0.74 //y2=0
cc_231 ( N_noxref_1_c_90_p N_noxref_9_c_1423_n ) capacitor c=0.00133432f \
 //x=2.59 //y=2.59 //x2=0.74 //y2=0
cc_232 ( N_noxref_1_c_18_p N_noxref_9_c_1425_n ) capacitor c=9.54331e-19 \
 //x=4.44 //y=2.745 //x2=4.91 //y2=0.53
cc_233 ( N_noxref_1_c_2_p N_noxref_9_c_1425_n ) capacitor c=0.0010437f \
 //x=4.44 //y=2.08 //x2=4.91 //y2=0.53
cc_234 ( N_noxref_1_c_3_p N_noxref_9_c_1425_n ) capacitor c=6.77674e-19 \
 //x=4.44 //y=2.08 //x2=4.91 //y2=0.53
cc_235 ( N_noxref_1_c_4_p N_noxref_9_c_1425_n ) capacitor c=0.0211758f \
 //x=4.245 //y=0.905 //x2=4.91 //y2=0.53
cc_236 ( N_noxref_1_c_13_p N_noxref_9_c_1425_n ) capacitor c=2.1838e-19 \
 //x=4.245 //y=1.915 //x2=4.91 //y2=0.53
cc_237 ( N_noxref_1_c_8_p N_noxref_9_c_1425_n ) capacitor c=0.00805599f \
 //x=4.775 //y=0.905 //x2=4.91 //y2=0.53
cc_238 ( N_noxref_1_c_10_p N_noxref_9_c_1431_n ) capacitor c=0.00271975f \
 //x=2.15 //y=1.57 //x2=3.33 //y2=0
cc_239 ( N_noxref_1_c_17_p N_noxref_9_c_1431_n ) capacitor c=0.021518f \
 //x=2.505 //y=1.655 //x2=3.33 //y2=0
cc_240 ( N_noxref_1_c_111_p N_noxref_9_c_1431_n ) capacitor c=0.00429364f \
 //x=2.59 //y=2.745 //x2=3.33 //y2=0
cc_241 ( N_noxref_1_c_26_p N_noxref_9_c_1431_n ) capacitor c=0.00325281f \
 //x=4.44 //y=2.425 //x2=3.33 //y2=0
cc_242 ( N_noxref_1_c_18_p N_noxref_9_c_1431_n ) capacitor c=0.00311747f \
 //x=4.44 //y=2.745 //x2=3.33 //y2=0
cc_243 ( N_noxref_1_c_90_p N_noxref_9_c_1431_n ) capacitor c=0.0101726f \
 //x=2.59 //y=2.59 //x2=3.33 //y2=0
cc_244 ( N_noxref_1_c_31_p N_noxref_9_c_1431_n ) capacitor c=0.00513832f \
 //x=4.44 //y=2.59 //x2=3.33 //y2=0
cc_245 ( N_noxref_1_c_2_p N_noxref_9_c_1431_n ) capacitor c=0.00446799f \
 //x=4.44 //y=2.08 //x2=3.33 //y2=0
cc_246 ( N_noxref_1_c_72_p N_noxref_9_c_1431_n ) capacitor c=0.0239533f \
 //x=4.275 //y=2.585 //x2=3.33 //y2=0
cc_247 ( N_noxref_1_c_3_p N_noxref_9_c_1431_n ) capacitor c=0.00369203f \
 //x=4.44 //y=2.08 //x2=3.33 //y2=0
cc_248 ( N_noxref_1_c_13_p N_noxref_9_c_1431_n ) capacitor c=0.0101725f \
 //x=4.245 //y=1.915 //x2=3.33 //y2=0
cc_249 ( N_noxref_1_c_1_p N_noxref_9_c_1442_n ) capacitor c=2.83275e-19 \
 //x=2.15 //y=1 //x2=11.59 //y2=0
cc_250 ( N_noxref_1_c_1_p N_noxref_9_M0_noxref_d ) capacitor c=2.82748e-19 \
 //x=2.15 //y=1 //x2=0.99 //y2=0.865
cc_251 ( N_noxref_1_c_72_p N_noxref_9_M2_noxref_s ) capacitor c=0.00355145f \
 //x=4.275 //y=2.585 //x2=3.89 //y2=0.365
cc_252 ( N_noxref_1_c_4_p N_noxref_9_M2_noxref_s ) capacitor c=0.0329097f \
 //x=4.245 //y=0.905 //x2=3.89 //y2=0.365
cc_253 ( N_noxref_1_c_8_p N_noxref_9_M2_noxref_s ) capacitor c=0.00605785f \
 //x=4.775 //y=0.905 //x2=3.89 //y2=0.365
cc_254 ( N_noxref_1_c_9_p N_noxref_9_M2_noxref_s ) capacitor c=0.00120103f \
 //x=4.775 //y=1.25 //x2=3.89 //y2=0.365
cc_255 ( N_noxref_1_c_255_p N_noxref_12_c_1876_n ) capacitor c=0.0103386f \
 //x=2.235 //y=1.655 //x2=1.665 //y2=1.495
cc_256 ( N_noxref_1_c_17_p N_noxref_12_c_1877_n ) capacitor c=0.00373013f \
 //x=2.505 //y=1.655 //x2=2.55 //y2=0.53
cc_257 ( N_noxref_1_c_1_p N_noxref_12_c_1877_n ) capacitor c=0.00367971f \
 //x=2.15 //y=1 //x2=2.55 //y2=0.53
cc_258 ( N_noxref_1_M1_noxref_d N_noxref_12_c_1877_n ) capacitor c=0.00910163f \
 //x=1.96 //y=0.905 //x2=2.55 //y2=0.53
cc_259 ( N_noxref_1_c_10_p N_noxref_12_M0_noxref_s ) capacitor c=0.0173667f \
 //x=2.15 //y=1.57 //x2=0.56 //y2=0.365
cc_260 ( N_noxref_1_c_17_p N_noxref_12_M0_noxref_s ) capacitor c=0.0055349f \
 //x=2.505 //y=1.655 //x2=0.56 //y2=0.365
cc_261 ( N_noxref_1_c_111_p N_noxref_12_M0_noxref_s ) capacitor c=7.90116e-19 \
 //x=2.59 //y=2.745 //x2=0.56 //y2=0.365
cc_262 ( N_noxref_1_c_1_p N_noxref_12_M0_noxref_s ) capacitor c=0.00907053f \
 //x=2.15 //y=1 //x2=0.56 //y2=0.365
cc_263 ( N_noxref_1_c_90_p N_noxref_12_M0_noxref_s ) capacitor c=0.00202552f \
 //x=2.59 //y=2.59 //x2=0.56 //y2=0.365
cc_264 ( N_noxref_1_M1_noxref_d N_noxref_12_M0_noxref_s ) capacitor \
 c=0.0275552f //x=1.96 //y=0.905 //x2=0.56 //y2=0.365
cc_265 ( N_noxref_2_M16_noxref_g N_noxref_3_c_535_n ) capacitor c=0.0129249f \
 //x=8.11 //y=6.02 //x2=8.655 //y2=5.2
cc_266 ( N_noxref_2_c_274_n N_noxref_3_c_536_n ) capacitor c=5.51079e-19 \
 //x=4.51 //y=1.57 //x2=8.81 //y2=1.57
cc_267 ( N_noxref_2_c_287_n N_noxref_3_c_536_n ) capacitor c=0.00311198f \
 //x=5.48 //y=1.57 //x2=8.81 //y2=1.57
cc_268 ( N_noxref_2_c_310_p N_noxref_3_c_538_n ) capacitor c=0.00242359f \
 //x=5.835 //y=1.655 //x2=8.895 //y2=1.655
cc_269 ( N_noxref_2_c_289_n N_noxref_3_c_539_n ) capacitor c=0.00204244f \
 //x=5.92 //y=2.425 //x2=9.25 //y2=2.425
cc_270 ( N_noxref_2_c_312_p N_noxref_3_c_539_n ) capacitor c=0.00100721f \
 //x=7.77 //y=2.425 //x2=9.25 //y2=2.425
cc_271 ( N_noxref_2_c_291_n N_noxref_3_c_541_n ) capacitor c=0.0028169f \
 //x=5.92 //y=5.125 //x2=9.25 //y2=5.115
cc_272 ( N_noxref_2_c_314_p N_noxref_3_c_541_n ) capacitor c=0.00450609f \
 //x=7.772 //y=4.56 //x2=9.25 //y2=5.115
cc_273 ( N_noxref_2_c_291_n N_noxref_3_c_543_n ) capacitor c=9.75602e-19 \
 //x=5.92 //y=5.125 //x2=7.89 //y2=5.38
cc_274 ( N_noxref_2_c_316_p N_noxref_3_c_543_n ) capacitor c=3.53224e-19 \
 //x=7.77 //y=2.745 //x2=7.89 //y2=5.38
cc_275 ( N_noxref_2_c_294_n N_noxref_3_c_543_n ) capacitor c=4.93096e-19 \
 //x=5.435 //y=5.21 //x2=7.89 //y2=5.38
cc_276 ( N_noxref_2_c_318_p N_noxref_3_c_543_n ) capacitor c=0.0118546f \
 //x=7.77 //y=4.7 //x2=7.89 //y2=5.38
cc_277 ( N_noxref_2_c_319_p N_noxref_3_c_543_n ) capacitor c=0.00277154f \
 //x=7.77 //y=4.7 //x2=7.89 //y2=5.38
cc_278 ( N_noxref_2_M15_noxref_g N_noxref_3_c_543_n ) capacitor c=0.00201806f \
 //x=7.67 //y=6.02 //x2=7.89 //y2=5.38
cc_279 ( N_noxref_2_M16_noxref_g N_noxref_3_c_543_n ) capacitor c=0.00192712f \
 //x=8.11 //y=6.02 //x2=7.89 //y2=5.38
cc_280 ( N_noxref_2_c_322_p N_noxref_3_c_543_n ) capacitor c=0.00201727f \
 //x=7.77 //y=4.7 //x2=7.89 //y2=5.38
cc_281 ( N_noxref_2_c_323_p N_noxref_3_c_551_n ) capacitor c=6.90042e-19 \
 //x=5.48 //y=1.12 //x2=8.81 //y2=1
cc_282 ( N_noxref_2_c_324_p N_noxref_3_c_552_n ) capacitor c=0.00251935f \
 //x=7.77 //y=2.59 //x2=9.25 //y2=2.59
cc_283 ( N_noxref_2_c_325_p N_noxref_3_c_553_n ) capacitor c=0.00532714f \
 //x=7.76 //y=2.585 //x2=9.41 //y2=2.585
cc_284 ( N_noxref_2_c_318_p N_noxref_3_c_554_n ) capacitor c=0.00104426f \
 //x=7.77 //y=4.7 //x2=7.89 //y2=5.38
cc_285 ( N_noxref_2_c_319_p N_noxref_3_c_554_n ) capacitor c=0.00377369f \
 //x=7.77 //y=4.7 //x2=7.89 //y2=5.38
cc_286 ( N_noxref_2_M15_noxref_g N_noxref_3_c_554_n ) capacitor c=0.0158358f \
 //x=7.67 //y=6.02 //x2=7.89 //y2=5.38
cc_287 ( N_noxref_2_M16_noxref_g N_noxref_3_c_554_n ) capacitor c=0.0178987f \
 //x=8.11 //y=6.02 //x2=7.89 //y2=5.38
cc_288 ( N_noxref_2_c_322_p N_noxref_3_c_554_n ) capacitor c=0.0043218f \
 //x=7.77 //y=4.7 //x2=7.89 //y2=5.38
cc_289 ( N_noxref_2_c_331_p N_noxref_4_c_818_n ) capacitor c=2.8973e-19 \
 //x=5.835 //y=5.21 //x2=11.47 //y2=7.4
cc_290 ( N_noxref_2_c_318_p N_noxref_4_c_818_n ) capacitor c=9.05427e-19 \
 //x=7.77 //y=4.7 //x2=11.47 //y2=7.4
cc_291 ( N_noxref_2_c_319_p N_noxref_4_c_818_n ) capacitor c=6.23118e-19 \
 //x=7.77 //y=4.7 //x2=11.47 //y2=7.4
cc_292 ( N_noxref_2_c_331_p N_noxref_4_c_784_n ) capacitor c=0.00153048f \
 //x=5.835 //y=5.21 //x2=6.49 //y2=7.4
cc_293 ( N_noxref_2_c_335_p N_noxref_4_c_784_n ) capacitor c=0.00512314f \
 //x=5.44 //y=5.38 //x2=6.49 //y2=7.4
cc_294 ( N_noxref_2_c_318_p N_noxref_4_c_823_n ) capacitor c=6.28732e-19 \
 //x=7.77 //y=4.7 //x2=8.245 //y2=7.4
cc_295 ( N_noxref_2_M15_noxref_g N_noxref_4_c_823_n ) capacitor c=0.0072715f \
 //x=7.67 //y=6.02 //x2=8.245 //y2=7.4
cc_296 ( N_noxref_2_M16_noxref_g N_noxref_4_c_823_n ) capacitor c=0.00749619f \
 //x=8.11 //y=6.02 //x2=8.245 //y2=7.4
cc_297 ( N_noxref_2_c_291_n N_noxref_4_c_789_n ) capacitor c=0.00125992f \
 //x=5.92 //y=5.125 //x2=3.33 //y2=7.4
cc_298 ( N_noxref_2_c_291_n N_noxref_4_c_799_n ) capacitor c=0.030593f \
 //x=5.92 //y=5.125 //x2=6.66 //y2=7.4
cc_299 ( N_noxref_2_c_294_n N_noxref_4_c_799_n ) capacitor c=0.00270468f \
 //x=5.435 //y=5.21 //x2=6.66 //y2=7.4
cc_300 ( N_noxref_2_c_318_p N_noxref_4_c_799_n ) capacitor c=0.00447349f \
 //x=7.77 //y=4.7 //x2=6.66 //y2=7.4
cc_301 ( N_noxref_2_c_314_p N_noxref_4_c_799_n ) capacitor c=0.00733791f \
 //x=7.772 //y=4.56 //x2=6.66 //y2=7.4
cc_302 ( N_noxref_2_c_344_p N_noxref_4_c_799_n ) capacitor c=0.00260414f \
 //x=7.6 //y=2.585 //x2=6.66 //y2=7.4
cc_303 ( N_noxref_2_c_335_p N_noxref_4_c_799_n ) capacitor c=0.0092106f \
 //x=5.44 //y=5.38 //x2=6.66 //y2=7.4
cc_304 ( N_noxref_2_c_319_p N_noxref_4_c_799_n ) capacitor c=0.00370495f \
 //x=7.77 //y=4.7 //x2=6.66 //y2=7.4
cc_305 ( N_noxref_2_c_322_p N_noxref_4_c_799_n ) capacitor c=0.01355f //x=7.77 \
 //y=4.7 //x2=6.66 //y2=7.4
cc_306 ( N_noxref_2_c_335_p N_noxref_4_c_800_n ) capacitor c=2.32853e-19 \
 //x=5.44 //y=5.38 //x2=11.47 //y2=7.4
cc_307 ( N_noxref_2_c_335_p N_noxref_4_M11_noxref_d ) capacitor c=0.00559643f \
 //x=5.44 //y=5.38 //x2=4.415 //y2=5.025
cc_308 ( N_noxref_2_c_331_p N_noxref_4_M15_noxref_s ) capacitor c=0.00364f \
 //x=5.835 //y=5.21 //x2=7.315 //y2=5.02
cc_309 ( N_noxref_2_c_316_p N_noxref_4_M15_noxref_s ) capacitor c=7.58516e-19 \
 //x=7.77 //y=2.745 //x2=7.315 //y2=5.02
cc_310 ( N_noxref_2_c_294_n N_noxref_4_M15_noxref_s ) capacitor c=0.00513745f \
 //x=5.435 //y=5.21 //x2=7.315 //y2=5.02
cc_311 ( N_noxref_2_M15_noxref_g N_noxref_4_M15_noxref_s ) capacitor \
 c=0.0567929f //x=7.67 //y=6.02 //x2=7.315 //y2=5.02
cc_312 ( N_noxref_2_M16_noxref_g N_noxref_4_M16_noxref_d ) capacitor \
 c=0.015318f //x=8.11 //y=6.02 //x2=8.185 //y2=5.02
cc_313 ( N_noxref_2_c_265_n N_noxref_7_c_1199_n ) capacitor c=2.9249e-19 \
 //x=4.51 //y=1.125 //x2=4.88 //y2=5.21
cc_314 ( N_noxref_2_c_281_n N_noxref_7_c_1199_n ) capacitor c=0.00265501f \
 //x=4.595 //y=1.655 //x2=4.88 //y2=5.21
cc_315 ( N_noxref_2_c_331_p N_noxref_7_c_1222_n ) capacitor c=0.00301289f \
 //x=5.835 //y=5.21 //x2=5.75 //y2=6.91
cc_316 ( N_noxref_2_c_294_n N_noxref_7_c_1222_n ) capacitor c=0.00513934f \
 //x=5.435 //y=5.21 //x2=5.75 //y2=6.91
cc_317 ( N_noxref_2_c_335_p N_noxref_7_c_1222_n ) capacitor c=0.00406191f \
 //x=5.44 //y=5.38 //x2=5.75 //y2=6.91
cc_318 ( N_noxref_2_c_294_n N_noxref_7_c_1205_n ) capacitor c=6.34305e-19 \
 //x=5.435 //y=5.21 //x2=4.12 //y2=5.21
cc_319 ( N_noxref_2_c_280_n N_noxref_7_c_1212_n ) capacitor c=0.00291215f \
 //x=5.395 //y=1.655 //x2=5 //y2=5.21
cc_320 ( N_noxref_2_c_294_n N_noxref_7_c_1212_n ) capacitor c=0.0514662f \
 //x=5.435 //y=5.21 //x2=5 //y2=5.21
cc_321 ( N_noxref_2_c_335_p N_noxref_7_c_1212_n ) capacitor c=0.00398527f \
 //x=5.44 //y=5.38 //x2=5 //y2=5.21
cc_322 ( N_noxref_2_c_331_p N_noxref_7_c_1229_n ) capacitor c=0.0056963f \
 //x=5.835 //y=5.21 //x2=5.88 //y2=6.74
cc_323 ( N_noxref_2_c_294_n N_noxref_7_c_1218_n ) capacitor c=0.00275395f \
 //x=5.435 //y=5.21 //x2=5 //y2=5.38
cc_324 ( N_noxref_2_c_335_p N_noxref_7_c_1218_n ) capacitor c=0.0683237f \
 //x=5.44 //y=5.38 //x2=5 //y2=5.38
cc_325 ( N_noxref_2_c_331_p N_noxref_7_M14_noxref_d ) capacitor c=0.00855426f \
 //x=5.835 //y=5.21 //x2=5.735 //y2=5.025
cc_326 ( N_noxref_2_c_295_n N_noxref_7_M14_noxref_d ) capacitor c=6.7951e-19 \
 //x=5.92 //y=2.59 //x2=5.735 //y2=5.025
cc_327 ( N_noxref_2_c_335_p N_noxref_7_M14_noxref_d ) capacitor c=0.047732f \
 //x=5.44 //y=5.38 //x2=5.735 //y2=5.025
cc_328 ( N_noxref_2_c_280_n N_noxref_8_c_1293_n ) capacitor c=0.0306206f \
 //x=5.395 //y=1.655 //x2=5.18 //y2=2.08
cc_329 ( N_noxref_2_c_289_n N_noxref_8_c_1293_n ) capacitor c=0.0160491f \
 //x=5.92 //y=2.425 //x2=5.18 //y2=2.08
cc_330 ( N_noxref_2_c_280_n N_noxref_8_c_1296_n ) capacitor c=4.30382e-19 \
 //x=5.395 //y=1.655 //x2=5.215 //y2=4.705
cc_331 ( N_noxref_2_c_291_n N_noxref_8_c_1296_n ) capacitor c=0.0175188f \
 //x=5.92 //y=5.125 //x2=5.215 //y2=4.705
cc_332 ( N_noxref_2_c_294_n N_noxref_8_c_1296_n ) capacitor c=0.00207961f \
 //x=5.435 //y=5.21 //x2=5.215 //y2=4.705
cc_333 ( N_noxref_2_c_289_n N_noxref_8_c_1299_n ) capacitor c=0.00866339f \
 //x=5.92 //y=2.425 //x2=5.215 //y2=4.56
cc_334 ( N_noxref_2_c_376_p N_noxref_8_c_1299_n ) capacitor c=0.0150092f \
 //x=5.92 //y=2.745 //x2=5.215 //y2=4.56
cc_335 ( N_noxref_2_c_291_n N_noxref_8_c_1299_n ) capacitor c=0.0839355f \
 //x=5.92 //y=5.125 //x2=5.215 //y2=4.56
cc_336 ( N_noxref_2_c_312_p N_noxref_8_c_1299_n ) capacitor c=6.23212e-19 \
 //x=7.77 //y=2.425 //x2=5.215 //y2=4.56
cc_337 ( N_noxref_2_c_295_n N_noxref_8_c_1299_n ) capacitor c=5.57251e-19 \
 //x=5.92 //y=2.59 //x2=5.215 //y2=4.56
cc_338 ( N_noxref_2_c_314_p N_noxref_8_c_1299_n ) capacitor c=0.00289475f \
 //x=7.772 //y=4.56 //x2=5.215 //y2=4.56
cc_339 ( N_noxref_2_c_296_n N_noxref_8_c_1299_n ) capacitor c=0.00361658f \
 //x=6.075 //y=2.585 //x2=5.215 //y2=4.56
cc_340 ( N_noxref_2_c_280_n N_noxref_8_c_1307_n ) capacitor c=0.00491852f \
 //x=5.395 //y=1.655 //x2=5.18 //y2=2.08
cc_341 ( N_noxref_2_c_289_n N_noxref_8_c_1307_n ) capacitor c=8.61986e-19 \
 //x=5.92 //y=2.425 //x2=5.18 //y2=2.08
cc_342 ( N_noxref_2_c_291_n N_noxref_8_c_1311_n ) capacitor c=0.00342077f \
 //x=5.92 //y=5.125 //x2=5.215 //y2=4.705
cc_343 ( N_noxref_2_c_294_n N_noxref_8_M13_noxref_g ) capacitor c=0.00184899f \
 //x=5.435 //y=5.21 //x2=5.22 //y2=6.025
cc_344 ( N_noxref_2_c_335_p N_noxref_8_M13_noxref_g ) capacitor c=0.0120591f \
 //x=5.44 //y=5.38 //x2=5.22 //y2=6.025
cc_345 ( N_noxref_2_c_331_p N_noxref_8_M14_noxref_g ) capacitor c=0.0110031f \
 //x=5.835 //y=5.21 //x2=5.66 //y2=6.025
cc_346 ( N_noxref_2_c_294_n N_noxref_8_M14_noxref_g ) capacitor c=0.0027897f \
 //x=5.435 //y=5.21 //x2=5.66 //y2=6.025
cc_347 ( N_noxref_2_c_335_p N_noxref_8_M14_noxref_g ) capacitor c=0.0140704f \
 //x=5.44 //y=5.38 //x2=5.66 //y2=6.025
cc_348 ( N_noxref_2_c_323_p N_noxref_8_c_1318_n ) capacitor c=0.00112851f \
 //x=5.48 //y=1.12 //x2=5.215 //y2=0.905
cc_349 ( N_noxref_2_M3_noxref_d N_noxref_8_c_1318_n ) capacitor c=0.00218694f \
 //x=5.29 //y=0.905 //x2=5.215 //y2=0.905
cc_350 ( N_noxref_2_c_323_p N_noxref_8_c_1320_n ) capacitor c=0.0021447f \
 //x=5.48 //y=1.12 //x2=5.215 //y2=1.255
cc_351 ( N_noxref_2_c_287_n N_noxref_8_c_1320_n ) capacitor c=7.7986e-19 \
 //x=5.48 //y=1.57 //x2=5.215 //y2=1.255
cc_352 ( N_noxref_2_M3_noxref_d N_noxref_8_c_1320_n ) capacitor c=0.00237422f \
 //x=5.29 //y=0.905 //x2=5.215 //y2=1.255
cc_353 ( N_noxref_2_c_274_n N_noxref_8_c_1323_n ) capacitor c=0.00120307f \
 //x=4.51 //y=1.57 //x2=5.215 //y2=1.56
cc_354 ( N_noxref_2_c_287_n N_noxref_8_c_1323_n ) capacitor c=0.00364979f \
 //x=5.48 //y=1.57 //x2=5.215 //y2=1.56
cc_355 ( N_noxref_2_c_291_n N_noxref_8_c_1364_n ) capacitor c=0.00852293f \
 //x=5.92 //y=5.125 //x2=5.585 //y2=4.795
cc_356 ( N_noxref_2_c_294_n N_noxref_8_c_1364_n ) capacitor c=0.00213157f \
 //x=5.435 //y=5.21 //x2=5.585 //y2=4.795
cc_357 ( N_noxref_2_c_335_p N_noxref_8_c_1364_n ) capacitor c=0.00293135f \
 //x=5.44 //y=5.38 //x2=5.585 //y2=4.795
cc_358 ( N_noxref_2_c_323_p N_noxref_8_c_1367_n ) capacitor c=5.32053e-19 \
 //x=5.48 //y=1.12 //x2=5.59 //y2=0.75
cc_359 ( N_noxref_2_M3_noxref_d N_noxref_8_c_1367_n ) capacitor c=0.00213893f \
 //x=5.29 //y=0.905 //x2=5.59 //y2=0.75
cc_360 ( N_noxref_2_c_323_p N_noxref_8_c_1325_n ) capacitor c=5.60411e-19 \
 //x=5.48 //y=1.12 //x2=5.59 //y2=1.405
cc_361 ( N_noxref_2_c_287_n N_noxref_8_c_1325_n ) capacitor c=0.00983535f \
 //x=5.48 //y=1.57 //x2=5.59 //y2=1.405
cc_362 ( N_noxref_2_c_310_p N_noxref_8_c_1325_n ) capacitor c=0.00500113f \
 //x=5.835 //y=1.655 //x2=5.59 //y2=1.405
cc_363 ( N_noxref_2_M3_noxref_d N_noxref_8_c_1325_n ) capacitor c=0.00357974f \
 //x=5.29 //y=0.905 //x2=5.59 //y2=1.405
cc_364 ( N_noxref_2_c_323_p N_noxref_8_c_1326_n ) capacitor c=8.06279e-19 \
 //x=5.48 //y=1.12 //x2=5.745 //y2=0.905
cc_365 ( N_noxref_2_M3_noxref_d N_noxref_8_c_1326_n ) capacitor c=0.0012513f \
 //x=5.29 //y=0.905 //x2=5.745 //y2=0.905
cc_366 ( N_noxref_2_c_323_p N_noxref_8_c_1327_n ) capacitor c=0.00327546f \
 //x=5.48 //y=1.12 //x2=5.745 //y2=1.255
cc_367 ( N_noxref_2_c_287_n N_noxref_8_c_1327_n ) capacitor c=0.00126467f \
 //x=5.48 //y=1.57 //x2=5.745 //y2=1.255
cc_368 ( N_noxref_2_M3_noxref_d N_noxref_8_c_1327_n ) capacitor c=0.00237422f \
 //x=5.29 //y=0.905 //x2=5.745 //y2=1.255
cc_369 ( N_noxref_2_c_280_n N_noxref_8_c_1328_n ) capacitor c=0.00161541f \
 //x=5.395 //y=1.655 //x2=5.18 //y2=2.08
cc_370 ( N_noxref_2_c_289_n N_noxref_8_c_1328_n ) capacitor c=0.0028062f \
 //x=5.92 //y=2.425 //x2=5.18 //y2=2.08
cc_371 ( N_noxref_2_c_280_n N_noxref_8_c_1331_n ) capacitor c=0.00817459f \
 //x=5.395 //y=1.655 //x2=5.18 //y2=1.915
cc_372 ( N_noxref_2_c_289_n N_noxref_8_c_1331_n ) capacitor c=0.00311553f \
 //x=5.92 //y=2.425 //x2=5.18 //y2=1.915
cc_373 ( N_noxref_2_c_291_n N_noxref_8_c_1332_n ) capacitor c=0.00141757f \
 //x=5.92 //y=5.125 //x2=5.215 //y2=4.705
cc_374 ( N_noxref_2_c_265_n N_noxref_9_c_1412_n ) capacitor c=0.00994852f \
 //x=4.51 //y=1.125 //x2=7.755 //y2=0
cc_375 ( N_noxref_2_c_280_n N_noxref_9_c_1412_n ) capacitor c=0.00677162f \
 //x=5.395 //y=1.655 //x2=7.755 //y2=0
cc_376 ( N_noxref_2_c_323_p N_noxref_9_c_1412_n ) capacitor c=0.0106127f \
 //x=5.48 //y=1.12 //x2=7.755 //y2=0
cc_377 ( N_noxref_2_c_310_p N_noxref_9_c_1412_n ) capacitor c=0.00665572f \
 //x=5.835 //y=1.655 //x2=7.755 //y2=0
cc_378 ( N_noxref_2_c_376_p N_noxref_9_c_1412_n ) capacitor c=6.41825e-19 \
 //x=5.92 //y=2.745 //x2=7.755 //y2=0
cc_379 ( N_noxref_2_c_316_p N_noxref_9_c_1412_n ) capacitor c=2.29259e-19 \
 //x=7.77 //y=2.745 //x2=7.755 //y2=0
cc_380 ( N_noxref_2_c_295_n N_noxref_9_c_1412_n ) capacitor c=5.12996e-19 \
 //x=5.92 //y=2.59 //x2=7.755 //y2=0
cc_381 ( N_noxref_2_M2_noxref_d N_noxref_9_c_1412_n ) capacitor c=3.01654e-19 \
 //x=4.32 //y=0.905 //x2=7.755 //y2=0
cc_382 ( N_noxref_2_M3_noxref_d N_noxref_9_c_1412_n ) capacitor c=3.01654e-19 \
 //x=5.29 //y=0.905 //x2=7.755 //y2=0
cc_383 ( N_noxref_2_c_265_n N_noxref_9_c_1418_n ) capacitor c=4.59693e-19 \
 //x=4.51 //y=1.125 //x2=1.18 //y2=0.955
cc_384 ( N_noxref_2_c_323_p N_noxref_9_c_1458_n ) capacitor c=0.00581397f \
 //x=5.48 //y=1.12 //x2=7.84 //y2=0.955
cc_385 ( N_noxref_2_c_427_p N_noxref_9_c_1458_n ) capacitor c=0.00662308f \
 //x=7.77 //y=2.08 //x2=7.84 //y2=0.955
cc_386 ( N_noxref_2_c_325_p N_noxref_9_c_1458_n ) capacitor c=0.00303385f \
 //x=7.76 //y=2.585 //x2=7.84 //y2=0.955
cc_387 ( N_noxref_2_c_429_p N_noxref_9_c_1458_n ) capacitor c=2.13705e-19 \
 //x=7.77 //y=2.08 //x2=7.84 //y2=0.955
cc_388 ( N_noxref_2_c_430_p N_noxref_9_c_1458_n ) capacitor c=0.00169607f \
 //x=7.575 //y=0.865 //x2=7.84 //y2=0.955
cc_389 ( N_noxref_2_c_431_p N_noxref_9_c_1458_n ) capacitor c=0.00357243f \
 //x=7.575 //y=1.21 //x2=7.84 //y2=0.955
cc_390 ( N_noxref_2_c_432_p N_noxref_9_c_1458_n ) capacitor c=4.2764e-19 \
 //x=7.575 //y=1.52 //x2=7.84 //y2=0.955
cc_391 ( N_noxref_2_c_433_p N_noxref_9_c_1458_n ) capacitor c=7.35788e-19 \
 //x=7.95 //y=0.71 //x2=7.84 //y2=0.955
cc_392 ( N_noxref_2_c_434_p N_noxref_9_c_1458_n ) capacitor c=6.38426e-19 \
 //x=7.95 //y=1.365 //x2=7.84 //y2=0.955
cc_393 ( N_noxref_2_c_435_p N_noxref_9_c_1458_n ) capacitor c=0.00158609f \
 //x=8.105 //y=0.865 //x2=7.84 //y2=0.955
cc_394 ( N_noxref_2_c_436_p N_noxref_9_c_1458_n ) capacitor c=0.00296337f \
 //x=8.105 //y=1.21 //x2=7.84 //y2=0.955
cc_395 ( N_noxref_2_c_430_p N_noxref_9_c_1469_n ) capacitor c=3.51399e-19 \
 //x=7.575 //y=0.865 //x2=7.837 //y2=0.825
cc_396 ( N_noxref_2_c_433_p N_noxref_9_c_1469_n ) capacitor c=0.00864436f \
 //x=7.95 //y=0.71 //x2=7.837 //y2=0.825
cc_397 ( N_noxref_2_c_435_p N_noxref_9_c_1469_n ) capacitor c=4.45447e-19 \
 //x=8.105 //y=0.865 //x2=7.837 //y2=0.825
cc_398 ( N_noxref_2_c_265_n N_noxref_9_c_1425_n ) capacitor c=0.00372564f \
 //x=4.51 //y=1.125 //x2=4.91 //y2=0.53
cc_399 ( N_noxref_2_c_280_n N_noxref_9_c_1425_n ) capacitor c=0.00128856f \
 //x=5.395 //y=1.655 //x2=4.91 //y2=0.53
cc_400 ( N_noxref_2_M2_noxref_d N_noxref_9_c_1425_n ) capacitor c=0.0124264f \
 //x=4.32 //y=0.905 //x2=4.91 //y2=0.53
cc_401 ( N_noxref_2_c_280_n N_noxref_9_c_1475_n ) capacitor c=0.00105223f \
 //x=5.395 //y=1.655 //x2=5.88 //y2=0.53
cc_402 ( N_noxref_2_c_323_p N_noxref_9_c_1475_n ) capacitor c=0.00469733f \
 //x=5.48 //y=1.12 //x2=5.88 //y2=0.53
cc_403 ( N_noxref_2_c_310_p N_noxref_9_c_1475_n ) capacitor c=0.00353984f \
 //x=5.835 //y=1.655 //x2=5.88 //y2=0.53
cc_404 ( N_noxref_2_M3_noxref_d N_noxref_9_c_1475_n ) capacitor c=0.0122548f \
 //x=5.29 //y=0.905 //x2=5.88 //y2=0.53
cc_405 ( N_noxref_2_c_376_p N_noxref_9_c_1479_n ) capacitor c=2.8128e-19 \
 //x=5.92 //y=2.745 //x2=6.49 //y2=0
cc_406 ( N_noxref_2_c_430_p N_noxref_9_c_1480_n ) capacitor c=0.00689257f \
 //x=7.575 //y=0.865 //x2=9.82 //y2=0
cc_407 ( N_noxref_2_c_289_n N_noxref_9_c_1431_n ) capacitor c=9.32616e-19 \
 //x=5.92 //y=2.425 //x2=3.33 //y2=0
cc_408 ( N_noxref_2_c_287_n N_noxref_9_c_1482_n ) capacitor c=0.00331216f \
 //x=5.48 //y=1.57 //x2=6.66 //y2=0
cc_409 ( N_noxref_2_c_310_p N_noxref_9_c_1482_n ) capacitor c=0.0231857f \
 //x=5.835 //y=1.655 //x2=6.66 //y2=0
cc_410 ( N_noxref_2_c_376_p N_noxref_9_c_1482_n ) capacitor c=0.00427064f \
 //x=5.92 //y=2.745 //x2=6.66 //y2=0
cc_411 ( N_noxref_2_c_312_p N_noxref_9_c_1482_n ) capacitor c=0.00333222f \
 //x=7.77 //y=2.425 //x2=6.66 //y2=0
cc_412 ( N_noxref_2_c_316_p N_noxref_9_c_1482_n ) capacitor c=0.00312614f \
 //x=7.77 //y=2.745 //x2=6.66 //y2=0
cc_413 ( N_noxref_2_c_295_n N_noxref_9_c_1482_n ) capacitor c=0.0101754f \
 //x=5.92 //y=2.59 //x2=6.66 //y2=0
cc_414 ( N_noxref_2_c_324_p N_noxref_9_c_1482_n ) capacitor c=0.00512799f \
 //x=7.77 //y=2.59 //x2=6.66 //y2=0
cc_415 ( N_noxref_2_c_427_p N_noxref_9_c_1482_n ) capacitor c=0.00427323f \
 //x=7.77 //y=2.08 //x2=6.66 //y2=0
cc_416 ( N_noxref_2_c_344_p N_noxref_9_c_1482_n ) capacitor c=0.0241255f \
 //x=7.6 //y=2.585 //x2=6.66 //y2=0
cc_417 ( N_noxref_2_c_429_p N_noxref_9_c_1482_n ) capacitor c=0.00369427f \
 //x=7.77 //y=2.08 //x2=6.66 //y2=0
cc_418 ( N_noxref_2_c_432_p N_noxref_9_c_1482_n ) capacitor c=0.0015404f \
 //x=7.575 //y=1.52 //x2=6.66 //y2=0
cc_419 ( N_noxref_2_c_461_p N_noxref_9_c_1482_n ) capacitor c=0.00950704f \
 //x=7.575 //y=1.915 //x2=6.66 //y2=0
cc_420 ( N_noxref_2_c_265_n N_noxref_9_c_1442_n ) capacitor c=3.01913e-19 \
 //x=4.51 //y=1.125 //x2=11.59 //y2=0
cc_421 ( N_noxref_2_c_323_p N_noxref_9_c_1442_n ) capacitor c=3.01913e-19 \
 //x=5.48 //y=1.12 //x2=11.59 //y2=0
cc_422 ( N_noxref_2_c_265_n N_noxref_9_M2_noxref_s ) capacitor c=0.00926082f \
 //x=4.51 //y=1.125 //x2=3.89 //y2=0.365
cc_423 ( N_noxref_2_c_274_n N_noxref_9_M2_noxref_s ) capacitor c=0.0225586f \
 //x=4.51 //y=1.57 //x2=3.89 //y2=0.365
cc_424 ( N_noxref_2_c_280_n N_noxref_9_M2_noxref_s ) capacitor c=0.00857479f \
 //x=5.395 //y=1.655 //x2=3.89 //y2=0.365
cc_425 ( N_noxref_2_c_323_p N_noxref_9_M2_noxref_s ) capacitor c=0.00932895f \
 //x=5.48 //y=1.12 //x2=3.89 //y2=0.365
cc_426 ( N_noxref_2_c_287_n N_noxref_9_M2_noxref_s ) capacitor c=0.0111835f \
 //x=5.48 //y=1.57 //x2=3.89 //y2=0.365
cc_427 ( N_noxref_2_c_310_p N_noxref_9_M2_noxref_s ) capacitor c=0.00606707f \
 //x=5.835 //y=1.655 //x2=3.89 //y2=0.365
cc_428 ( N_noxref_2_c_376_p N_noxref_9_M2_noxref_s ) capacitor c=8.10031e-19 \
 //x=5.92 //y=2.745 //x2=3.89 //y2=0.365
cc_429 ( N_noxref_2_c_295_n N_noxref_9_M2_noxref_s ) capacitor c=0.00206158f \
 //x=5.92 //y=2.59 //x2=3.89 //y2=0.365
cc_430 ( N_noxref_2_M2_noxref_d N_noxref_9_M2_noxref_s ) capacitor \
 c=0.0297221f //x=4.32 //y=0.905 //x2=3.89 //y2=0.365
cc_431 ( N_noxref_2_M3_noxref_d N_noxref_9_M2_noxref_s ) capacitor c=0.029747f \
 //x=5.29 //y=0.905 //x2=3.89 //y2=0.365
cc_432 ( N_noxref_2_c_427_p N_noxref_9_M4_noxref_d ) capacitor c=2.20438e-19 \
 //x=7.77 //y=2.08 //x2=7.65 //y2=0.865
cc_433 ( N_noxref_2_c_430_p N_noxref_9_M4_noxref_d ) capacitor c=0.00192399f \
 //x=7.575 //y=0.865 //x2=7.65 //y2=0.865
cc_434 ( N_noxref_2_c_431_p N_noxref_9_M4_noxref_d ) capacitor c=0.00210798f \
 //x=7.575 //y=1.21 //x2=7.65 //y2=0.865
cc_435 ( N_noxref_2_c_433_p N_noxref_9_M4_noxref_d ) capacitor c=0.00472259f \
 //x=7.95 //y=0.71 //x2=7.65 //y2=0.865
cc_436 ( N_noxref_2_c_434_p N_noxref_9_M4_noxref_d ) capacitor c=0.00166857f \
 //x=7.95 //y=1.365 //x2=7.65 //y2=0.865
cc_437 ( N_noxref_2_c_435_p N_noxref_9_M4_noxref_d ) capacitor c=0.00230174f \
 //x=8.105 //y=0.865 //x2=7.65 //y2=0.865
cc_438 ( N_noxref_2_c_436_p N_noxref_9_M4_noxref_d ) capacitor c=0.00210798f \
 //x=8.105 //y=1.21 //x2=7.65 //y2=0.865
cc_439 ( N_noxref_2_c_289_n N_noxref_10_c_1687_n ) capacitor c=6.60708e-19 \
 //x=5.92 //y=2.425 //x2=8.51 //y2=4.555
cc_440 ( N_noxref_2_c_291_n N_noxref_10_c_1687_n ) capacitor c=0.00317943f \
 //x=5.92 //y=5.125 //x2=8.51 //y2=4.555
cc_441 ( N_noxref_2_c_312_p N_noxref_10_c_1687_n ) capacitor c=0.0090111f \
 //x=7.77 //y=2.425 //x2=8.51 //y2=4.555
cc_442 ( N_noxref_2_c_316_p N_noxref_10_c_1687_n ) capacitor c=0.0145387f \
 //x=7.77 //y=2.745 //x2=8.51 //y2=4.555
cc_443 ( N_noxref_2_c_324_p N_noxref_10_c_1687_n ) capacitor c=5.57251e-19 \
 //x=7.77 //y=2.59 //x2=8.51 //y2=4.555
cc_444 ( N_noxref_2_c_318_p N_noxref_10_c_1687_n ) capacitor c=0.0172958f \
 //x=7.77 //y=4.7 //x2=8.51 //y2=4.555
cc_445 ( N_noxref_2_c_314_p N_noxref_10_c_1687_n ) capacitor c=0.0840435f \
 //x=7.772 //y=4.56 //x2=8.51 //y2=4.555
cc_446 ( N_noxref_2_c_325_p N_noxref_10_c_1687_n ) capacitor c=0.00358737f \
 //x=7.76 //y=2.585 //x2=8.51 //y2=4.555
cc_447 ( N_noxref_2_c_429_p N_noxref_10_c_1687_n ) capacitor c=3.49899e-19 \
 //x=7.77 //y=2.08 //x2=8.51 //y2=4.555
cc_448 ( N_noxref_2_c_319_p N_noxref_10_c_1687_n ) capacitor c=7.76143e-19 \
 //x=7.77 //y=4.7 //x2=8.51 //y2=4.555
cc_449 ( N_noxref_2_c_322_p N_noxref_10_c_1687_n ) capacitor c=0.00201171f \
 //x=7.77 //y=4.7 //x2=8.51 //y2=4.555
cc_450 ( N_noxref_2_c_427_p N_noxref_10_c_1698_n ) capacitor c=0.0205342f \
 //x=7.77 //y=2.08 //x2=8.51 //y2=2.08
cc_451 ( N_noxref_2_c_429_p N_noxref_10_c_1698_n ) capacitor c=5.16867e-19 \
 //x=7.77 //y=2.08 //x2=8.51 //y2=2.08
cc_452 ( N_noxref_2_c_461_p N_noxref_10_c_1698_n ) capacitor c=0.00167888f \
 //x=7.575 //y=1.915 //x2=8.51 //y2=2.08
cc_453 ( N_noxref_2_c_312_p N_noxref_10_c_1701_n ) capacitor c=3.49899e-19 \
 //x=7.77 //y=2.425 //x2=8.51 //y2=2.08
cc_454 ( N_noxref_2_c_427_p N_noxref_10_c_1701_n ) capacitor c=5.24723e-19 \
 //x=7.77 //y=2.08 //x2=8.51 //y2=2.08
cc_455 ( N_noxref_2_c_429_p N_noxref_10_c_1701_n ) capacitor c=0.00445529f \
 //x=7.77 //y=2.08 //x2=8.51 //y2=2.08
cc_456 ( N_noxref_2_c_461_p N_noxref_10_c_1701_n ) capacitor c=0.00267961f \
 //x=7.575 //y=1.915 //x2=8.51 //y2=2.08
cc_457 ( N_noxref_2_c_318_p N_noxref_10_c_1705_n ) capacitor c=4.80626e-19 \
 //x=7.77 //y=4.7 //x2=8.54 //y2=4.7
cc_458 ( N_noxref_2_c_319_p N_noxref_10_c_1705_n ) capacitor c=0.00397338f \
 //x=7.77 //y=4.7 //x2=8.54 //y2=4.7
cc_459 ( N_noxref_2_c_322_p N_noxref_10_c_1705_n ) capacitor c=0.00283894f \
 //x=7.77 //y=4.7 //x2=8.54 //y2=4.7
cc_460 ( N_noxref_2_M15_noxref_g N_noxref_10_M17_noxref_g ) capacitor \
 c=0.0104892f //x=7.67 //y=6.02 //x2=8.55 //y2=6.02
cc_461 ( N_noxref_2_M16_noxref_g N_noxref_10_M17_noxref_g ) capacitor \
 c=0.107636f //x=8.11 //y=6.02 //x2=8.55 //y2=6.02
cc_462 ( N_noxref_2_M16_noxref_g N_noxref_10_M18_noxref_g ) capacitor \
 c=0.0100341f //x=8.11 //y=6.02 //x2=8.99 //y2=6.02
cc_463 ( N_noxref_2_c_430_p N_noxref_10_c_1711_n ) capacitor c=4.86545e-19 \
 //x=7.575 //y=0.865 //x2=8.545 //y2=0.905
cc_464 ( N_noxref_2_c_431_p N_noxref_10_c_1711_n ) capacitor c=0.00152405f \
 //x=7.575 //y=1.21 //x2=8.545 //y2=0.905
cc_465 ( N_noxref_2_c_435_p N_noxref_10_c_1711_n ) capacitor c=0.0151475f \
 //x=8.105 //y=0.865 //x2=8.545 //y2=0.905
cc_466 ( N_noxref_2_c_432_p N_noxref_10_c_1714_n ) capacitor c=0.00109982f \
 //x=7.575 //y=1.52 //x2=8.545 //y2=1.25
cc_467 ( N_noxref_2_c_436_p N_noxref_10_c_1714_n ) capacitor c=0.0111064f \
 //x=8.105 //y=1.21 //x2=8.545 //y2=1.25
cc_468 ( N_noxref_2_c_432_p N_noxref_10_c_1716_n ) capacitor c=9.58243e-19 \
 //x=7.575 //y=1.52 //x2=8.545 //y2=1.56
cc_469 ( N_noxref_2_c_461_p N_noxref_10_c_1716_n ) capacitor c=0.00662747f \
 //x=7.575 //y=1.915 //x2=8.545 //y2=1.56
cc_470 ( N_noxref_2_c_436_p N_noxref_10_c_1716_n ) capacitor c=0.00862358f \
 //x=8.105 //y=1.21 //x2=8.545 //y2=1.56
cc_471 ( N_noxref_2_c_435_p N_noxref_10_c_1719_n ) capacitor c=0.00127211f \
 //x=8.105 //y=0.865 //x2=9.075 //y2=0.905
cc_472 ( N_noxref_2_c_436_p N_noxref_10_c_1720_n ) capacitor c=0.00204774f \
 //x=8.105 //y=1.21 //x2=9.075 //y2=1.25
cc_473 ( N_noxref_2_c_427_p N_noxref_10_c_1721_n ) capacitor c=0.00167305f \
 //x=7.77 //y=2.08 //x2=8.51 //y2=2.08
cc_474 ( N_noxref_2_c_429_p N_noxref_10_c_1721_n ) capacitor c=0.00266443f \
 //x=7.77 //y=2.08 //x2=8.51 //y2=2.08
cc_475 ( N_noxref_2_c_461_p N_noxref_10_c_1721_n ) capacitor c=0.0181449f \
 //x=7.575 //y=1.915 //x2=8.51 //y2=2.08
cc_476 ( N_noxref_2_c_318_p N_noxref_10_c_1724_n ) capacitor c=0.00158715f \
 //x=7.77 //y=4.7 //x2=8.54 //y2=4.7
cc_477 ( N_noxref_2_c_319_p N_noxref_10_c_1724_n ) capacitor c=0.00237977f \
 //x=7.77 //y=4.7 //x2=8.54 //y2=4.7
cc_478 ( N_noxref_2_c_322_p N_noxref_10_c_1724_n ) capacitor c=0.0297875f \
 //x=7.77 //y=4.7 //x2=8.54 //y2=4.7
cc_479 ( N_noxref_2_c_344_p N_noxref_13_c_1937_n ) capacitor c=0.00357165f \
 //x=7.6 //y=2.585 //x2=7.355 //y2=1.495
cc_480 ( N_noxref_2_c_461_p N_noxref_13_c_1937_n ) capacitor c=0.00262672f \
 //x=7.575 //y=1.915 //x2=7.355 //y2=1.495
cc_481 ( N_noxref_2_c_316_p N_noxref_13_c_1939_n ) capacitor c=0.00524385f \
 //x=7.77 //y=2.745 //x2=8.24 //y2=1.58
cc_482 ( N_noxref_2_c_427_p N_noxref_13_c_1939_n ) capacitor c=0.00509504f \
 //x=7.77 //y=2.08 //x2=8.24 //y2=1.58
cc_483 ( N_noxref_2_c_344_p N_noxref_13_c_1939_n ) capacitor c=0.00132102f \
 //x=7.6 //y=2.585 //x2=8.24 //y2=1.58
cc_484 ( N_noxref_2_c_429_p N_noxref_13_c_1939_n ) capacitor c=0.00763108f \
 //x=7.77 //y=2.08 //x2=8.24 //y2=1.58
cc_485 ( N_noxref_2_c_432_p N_noxref_13_c_1939_n ) capacitor c=0.00697076f \
 //x=7.575 //y=1.52 //x2=8.24 //y2=1.58
cc_486 ( N_noxref_2_c_461_p N_noxref_13_c_1939_n ) capacitor c=0.0165705f \
 //x=7.575 //y=1.915 //x2=8.24 //y2=1.58
cc_487 ( N_noxref_2_c_434_p N_noxref_13_c_1939_n ) capacitor c=0.00723574f \
 //x=7.95 //y=1.365 //x2=8.24 //y2=1.58
cc_488 ( N_noxref_2_c_436_p N_noxref_13_c_1939_n ) capacitor c=0.00339872f \
 //x=8.105 //y=1.21 //x2=8.24 //y2=1.58
cc_489 ( N_noxref_2_c_461_p N_noxref_13_c_1947_n ) capacitor c=6.71402e-19 \
 //x=7.575 //y=1.915 //x2=8.325 //y2=1.495
cc_490 ( N_noxref_2_c_430_p N_noxref_13_M4_noxref_s ) capacitor c=0.029498f \
 //x=7.575 //y=0.865 //x2=7.22 //y2=0.365
cc_491 ( N_noxref_2_c_432_p N_noxref_13_M4_noxref_s ) capacitor c=3.48408e-19 \
 //x=7.575 //y=1.52 //x2=7.22 //y2=0.365
cc_492 ( N_noxref_2_c_435_p N_noxref_13_M4_noxref_s ) capacitor c=0.0125442f \
 //x=8.105 //y=0.865 //x2=7.22 //y2=0.365
cc_493 ( N_noxref_3_c_535_n N_noxref_4_c_818_n ) capacitor c=0.00647565f \
 //x=8.655 //y=5.2 //x2=11.47 //y2=7.4
cc_494 ( N_noxref_3_c_560_p N_noxref_4_c_818_n ) capacitor c=0.0048744f \
 //x=9.165 //y=5.2 //x2=11.47 //y2=7.4
cc_495 ( N_noxref_3_c_561_p N_noxref_4_c_818_n ) capacitor c=5.72118e-19 \
 //x=10.73 //y=4.58 //x2=11.47 //y2=7.4
cc_496 ( N_noxref_3_c_543_n N_noxref_4_c_818_n ) capacitor c=0.00368144f \
 //x=7.89 //y=5.38 //x2=11.47 //y2=7.4
cc_497 ( N_noxref_3_c_563_p N_noxref_4_c_818_n ) capacitor c=8.41206e-19 \
 //x=8.77 //y=5.2 //x2=11.47 //y2=7.4
cc_498 ( N_noxref_3_c_564_p N_noxref_4_c_818_n ) capacitor c=0.00285294f \
 //x=8.77 //y=5.38 //x2=11.47 //y2=7.4
cc_499 ( N_noxref_3_c_554_n N_noxref_4_c_818_n ) capacitor c=0.00224727f \
 //x=7.89 //y=5.38 //x2=11.47 //y2=7.4
cc_500 ( N_noxref_3_c_566_p N_noxref_4_c_818_n ) capacitor c=0.00224727f \
 //x=8.77 //y=5.38 //x2=11.47 //y2=7.4
cc_501 ( N_noxref_3_c_567_p N_noxref_4_c_818_n ) capacitor c=3.40875e-19 \
 //x=10.73 //y=4.7 //x2=11.47 //y2=7.4
cc_502 ( N_noxref_3_c_535_n N_noxref_4_c_823_n ) capacitor c=0.00213214f \
 //x=8.655 //y=5.2 //x2=8.245 //y2=7.4
cc_503 ( N_noxref_3_c_543_n N_noxref_4_c_823_n ) capacitor c=9.98713e-19 \
 //x=7.89 //y=5.38 //x2=8.245 //y2=7.4
cc_504 ( N_noxref_3_c_554_n N_noxref_4_c_823_n ) capacitor c=0.0136475f \
 //x=7.89 //y=5.38 //x2=8.245 //y2=7.4
cc_505 ( N_noxref_3_c_535_n N_noxref_4_c_854_n ) capacitor c=0.00184538f \
 //x=8.655 //y=5.2 //x2=9.125 //y2=7.4
cc_506 ( N_noxref_3_c_560_p N_noxref_4_c_854_n ) capacitor c=0.00213214f \
 //x=9.165 //y=5.2 //x2=9.125 //y2=7.4
cc_507 ( N_noxref_3_c_563_p N_noxref_4_c_854_n ) capacitor c=5.38567e-19 \
 //x=8.77 //y=5.2 //x2=9.125 //y2=7.4
cc_508 ( N_noxref_3_c_564_p N_noxref_4_c_854_n ) capacitor c=5.78261e-19 \
 //x=8.77 //y=5.38 //x2=9.125 //y2=7.4
cc_509 ( N_noxref_3_c_566_p N_noxref_4_c_854_n ) capacitor c=0.0136475f \
 //x=8.77 //y=5.38 //x2=9.125 //y2=7.4
cc_510 ( N_noxref_3_c_561_p N_noxref_4_c_859_n ) capacitor c=5.4912e-19 \
 //x=10.73 //y=4.58 //x2=11.46 //y2=7.4
cc_511 ( N_noxref_3_M19_noxref_g N_noxref_4_c_859_n ) capacitor c=0.00748034f \
 //x=10.885 //y=6.02 //x2=11.46 //y2=7.4
cc_512 ( N_noxref_3_M20_noxref_g N_noxref_4_c_859_n ) capacitor c=0.00749619f \
 //x=11.325 //y=6.02 //x2=11.46 //y2=7.4
cc_513 ( N_noxref_3_c_541_n N_noxref_4_c_799_n ) capacitor c=0.0013228f \
 //x=9.25 //y=5.115 //x2=6.66 //y2=7.4
cc_514 ( N_noxref_3_c_543_n N_noxref_4_c_799_n ) capacitor c=4.91377e-19 \
 //x=7.89 //y=5.38 //x2=6.66 //y2=7.4
cc_515 ( N_noxref_3_c_554_n N_noxref_4_c_799_n ) capacitor c=0.00637389f \
 //x=7.89 //y=5.38 //x2=6.66 //y2=7.4
cc_516 ( N_noxref_3_c_541_n N_noxref_4_c_865_n ) capacitor c=0.0283322f \
 //x=9.25 //y=5.115 //x2=9.99 //y2=7.4
cc_517 ( N_noxref_3_c_561_p N_noxref_4_c_865_n ) capacitor c=0.0155837f \
 //x=10.73 //y=4.58 //x2=9.99 //y2=7.4
cc_518 ( N_noxref_3_c_563_p N_noxref_4_c_865_n ) capacitor c=0.002343f \
 //x=8.77 //y=5.2 //x2=9.99 //y2=7.4
cc_519 ( N_noxref_3_c_564_p N_noxref_4_c_865_n ) capacitor c=4.0348e-19 \
 //x=8.77 //y=5.38 //x2=9.99 //y2=7.4
cc_520 ( N_noxref_3_c_586_p N_noxref_4_c_865_n ) capacitor c=0.00259238f \
 //x=10.57 //y=2.585 //x2=9.99 //y2=7.4
cc_521 ( N_noxref_3_c_566_p N_noxref_4_c_865_n ) capacitor c=0.0101861f \
 //x=8.77 //y=5.38 //x2=9.99 //y2=7.4
cc_522 ( N_noxref_3_c_567_p N_noxref_4_c_865_n ) capacitor c=0.00795305f \
 //x=10.73 //y=4.7 //x2=9.99 //y2=7.4
cc_523 ( N_noxref_3_M19_noxref_g N_noxref_4_c_865_n ) capacitor c=0.00713874f \
 //x=10.885 //y=6.02 //x2=9.99 //y2=7.4
cc_524 ( N_noxref_3_c_590_p N_noxref_4_c_865_n ) capacitor c=0.00799922f \
 //x=10.96 //y=4.79 //x2=9.99 //y2=7.4
cc_525 ( N_noxref_3_c_554_n N_noxref_4_c_800_n ) capacitor c=0.00135089f \
 //x=7.89 //y=5.38 //x2=11.47 //y2=7.4
cc_526 ( N_noxref_3_c_566_p N_noxref_4_c_800_n ) capacitor c=0.00135089f \
 //x=8.77 //y=5.38 //x2=11.47 //y2=7.4
cc_527 ( N_noxref_3_c_567_p N_noxref_4_c_800_n ) capacitor c=0.00241457f \
 //x=10.73 //y=4.7 //x2=11.47 //y2=7.4
cc_528 ( N_noxref_3_c_594_p N_noxref_4_c_800_n ) capacitor c=0.0201557f \
 //x=11.25 //y=4.79 //x2=11.47 //y2=7.4
cc_529 ( N_noxref_3_c_543_n N_noxref_4_M15_noxref_s ) capacitor c=0.0611368f \
 //x=7.89 //y=5.38 //x2=7.315 //y2=5.02
cc_530 ( N_noxref_3_c_563_p N_noxref_4_M15_noxref_s ) capacitor c=6.52457e-19 \
 //x=8.77 //y=5.2 //x2=7.315 //y2=5.02
cc_531 ( N_noxref_3_c_554_n N_noxref_4_M15_noxref_s ) capacitor c=0.0884109f \
 //x=7.89 //y=5.38 //x2=7.315 //y2=5.02
cc_532 ( N_noxref_3_c_535_n N_noxref_4_M16_noxref_d ) capacitor c=0.00810167f \
 //x=8.655 //y=5.2 //x2=8.185 //y2=5.02
cc_533 ( N_noxref_3_c_543_n N_noxref_4_M16_noxref_d ) capacitor c=0.0043528f \
 //x=7.89 //y=5.38 //x2=8.185 //y2=5.02
cc_534 ( N_noxref_3_c_564_p N_noxref_4_M16_noxref_d ) capacitor c=0.0043528f \
 //x=8.77 //y=5.38 //x2=8.185 //y2=5.02
cc_535 ( N_noxref_3_c_554_n N_noxref_4_M16_noxref_d ) capacitor c=0.0653657f \
 //x=7.89 //y=5.38 //x2=8.185 //y2=5.02
cc_536 ( N_noxref_3_c_566_p N_noxref_4_M16_noxref_d ) capacitor c=0.0654383f \
 //x=8.77 //y=5.38 //x2=8.185 //y2=5.02
cc_537 ( N_noxref_3_c_560_p N_noxref_4_M18_noxref_d ) capacitor c=0.0100422f \
 //x=9.165 //y=5.2 //x2=9.065 //y2=5.02
cc_538 ( N_noxref_3_c_564_p N_noxref_4_M18_noxref_d ) capacitor c=0.00921458f \
 //x=8.77 //y=5.38 //x2=9.065 //y2=5.02
cc_539 ( N_noxref_3_c_552_n N_noxref_4_M18_noxref_d ) capacitor c=6.87188e-19 \
 //x=9.25 //y=2.59 //x2=9.065 //y2=5.02
cc_540 ( N_noxref_3_c_566_p N_noxref_4_M18_noxref_d ) capacitor c=0.0654892f \
 //x=8.77 //y=5.38 //x2=9.065 //y2=5.02
cc_541 ( N_noxref_3_c_560_p N_noxref_4_M19_noxref_s ) capacitor c=0.00316782f \
 //x=9.165 //y=5.2 //x2=10.53 //y2=5.02
cc_542 ( N_noxref_3_c_608_p N_noxref_4_M19_noxref_s ) capacitor c=8.61504e-19 \
 //x=10.73 //y=2.745 //x2=10.53 //y2=5.02
cc_543 ( N_noxref_3_c_561_p N_noxref_4_M19_noxref_s ) capacitor c=0.0211972f \
 //x=10.73 //y=4.58 //x2=10.53 //y2=5.02
cc_544 ( N_noxref_3_c_563_p N_noxref_4_M19_noxref_s ) capacitor c=0.00460957f \
 //x=8.77 //y=5.2 //x2=10.53 //y2=5.02
cc_545 ( N_noxref_3_c_564_p N_noxref_4_M19_noxref_s ) capacitor c=0.00135645f \
 //x=8.77 //y=5.38 //x2=10.53 //y2=5.02
cc_546 ( N_noxref_3_c_567_p N_noxref_4_M19_noxref_s ) capacitor c=0.00914062f \
 //x=10.73 //y=4.7 //x2=10.53 //y2=5.02
cc_547 ( N_noxref_3_M19_noxref_g N_noxref_4_M19_noxref_s ) capacitor \
 c=0.0573441f //x=10.885 //y=6.02 //x2=10.53 //y2=5.02
cc_548 ( N_noxref_3_c_590_p N_noxref_4_M19_noxref_s ) capacitor c=0.00527341f \
 //x=10.96 //y=4.79 //x2=10.53 //y2=5.02
cc_549 ( N_noxref_3_M20_noxref_g N_noxref_4_M20_noxref_d ) capacitor \
 c=0.0572684f //x=11.325 //y=6.02 //x2=11.4 //y2=5.02
cc_550 ( N_noxref_3_c_616_p N_noxref_9_c_1513_n ) capacitor c=0.00653239f \
 //x=9.165 //y=1.655 //x2=11.47 //y2=0
cc_551 ( N_noxref_3_c_617_p N_noxref_9_c_1513_n ) capacitor c=5.98346e-19 \
 //x=9.25 //y=2.745 //x2=11.47 //y2=0
cc_552 ( N_noxref_3_c_608_p N_noxref_9_c_1513_n ) capacitor c=5.91805e-19 \
 //x=10.73 //y=2.745 //x2=11.47 //y2=0
cc_553 ( N_noxref_3_c_551_n N_noxref_9_c_1513_n ) capacitor c=0.00963092f \
 //x=8.81 //y=1 //x2=11.47 //y2=0
cc_554 ( N_noxref_3_c_620_p N_noxref_9_c_1513_n ) capacitor c=0.00248634f \
 //x=10.73 //y=2.085 //x2=11.47 //y2=0
cc_555 ( N_noxref_3_c_621_p N_noxref_9_c_1513_n ) capacitor c=7.53892e-19 \
 //x=10.73 //y=2.085 //x2=11.47 //y2=0
cc_556 ( N_noxref_3_M5_noxref_d N_noxref_9_c_1513_n ) capacitor c=3.01654e-19 \
 //x=8.62 //y=0.905 //x2=11.47 //y2=0
cc_557 ( N_noxref_3_c_543_n N_noxref_9_c_1458_n ) capacitor c=7.01036e-19 \
 //x=7.89 //y=5.38 //x2=7.84 //y2=0.955
cc_558 ( N_noxref_3_c_551_n N_noxref_9_c_1458_n ) capacitor c=0.0140149f \
 //x=8.81 //y=1 //x2=7.84 //y2=0.955
cc_559 ( N_noxref_3_M5_noxref_d N_noxref_9_c_1458_n ) capacitor c=2.93544e-19 \
 //x=8.62 //y=0.905 //x2=7.84 //y2=0.955
cc_560 ( N_noxref_3_c_616_p N_noxref_9_c_1480_n ) capacitor c=7.76556e-19 \
 //x=9.165 //y=1.655 //x2=9.82 //y2=0
cc_561 ( N_noxref_3_c_617_p N_noxref_9_c_1480_n ) capacitor c=4.78945e-19 \
 //x=9.25 //y=2.745 //x2=9.82 //y2=0
cc_562 ( N_noxref_3_c_608_p N_noxref_9_c_1525_n ) capacitor c=2.60522e-19 \
 //x=10.73 //y=2.745 //x2=11.015 //y2=0.535
cc_563 ( N_noxref_3_c_620_p N_noxref_9_c_1525_n ) capacitor c=0.00114179f \
 //x=10.73 //y=2.085 //x2=11.015 //y2=0.535
cc_564 ( N_noxref_3_c_621_p N_noxref_9_c_1525_n ) capacitor c=3.95714e-19 \
 //x=10.73 //y=2.085 //x2=11.015 //y2=0.535
cc_565 ( N_noxref_3_c_631_p N_noxref_9_c_1525_n ) capacitor c=0.0125519f \
 //x=10.84 //y=0.91 //x2=11.015 //y2=0.535
cc_566 ( N_noxref_3_c_632_p N_noxref_9_c_1525_n ) capacitor c=2.1838e-19 \
 //x=10.73 //y=2.085 //x2=11.015 //y2=0.535
cc_567 ( N_noxref_3_c_633_p N_noxref_9_c_1530_n ) capacitor c=0.0134259f \
 //x=11.37 //y=0.91 //x2=11.505 //y2=0.535
cc_568 ( N_noxref_3_c_539_n N_noxref_9_c_1482_n ) capacitor c=9.34934e-19 \
 //x=9.25 //y=2.425 //x2=6.66 //y2=0
cc_569 ( N_noxref_3_c_536_n N_noxref_9_c_1532_n ) capacitor c=0.00269515f \
 //x=8.81 //y=1.57 //x2=9.99 //y2=0
cc_570 ( N_noxref_3_c_616_p N_noxref_9_c_1532_n ) capacitor c=0.0197995f \
 //x=9.165 //y=1.655 //x2=9.99 //y2=0
cc_571 ( N_noxref_3_c_617_p N_noxref_9_c_1532_n ) capacitor c=0.00494191f \
 //x=9.25 //y=2.745 //x2=9.99 //y2=0
cc_572 ( N_noxref_3_c_638_p N_noxref_9_c_1532_n ) capacitor c=0.00382407f \
 //x=10.73 //y=2.425 //x2=9.99 //y2=0
cc_573 ( N_noxref_3_c_608_p N_noxref_9_c_1532_n ) capacitor c=0.00494191f \
 //x=10.73 //y=2.745 //x2=9.99 //y2=0
cc_574 ( N_noxref_3_c_552_n N_noxref_9_c_1532_n ) capacitor c=0.010052f \
 //x=9.25 //y=2.59 //x2=9.99 //y2=0
cc_575 ( N_noxref_3_c_641_p N_noxref_9_c_1532_n ) capacitor c=0.010052f \
 //x=10.73 //y=2.59 //x2=9.99 //y2=0
cc_576 ( N_noxref_3_c_620_p N_noxref_9_c_1532_n ) capacitor c=0.00682461f \
 //x=10.73 //y=2.085 //x2=9.99 //y2=0
cc_577 ( N_noxref_3_c_586_p N_noxref_9_c_1532_n ) capacitor c=0.0228448f \
 //x=10.57 //y=2.585 //x2=9.99 //y2=0
cc_578 ( N_noxref_3_c_621_p N_noxref_9_c_1532_n ) capacitor c=0.00733236f \
 //x=10.73 //y=2.085 //x2=9.99 //y2=0
cc_579 ( N_noxref_3_c_645_p N_noxref_9_c_1532_n ) capacitor c=0.00427783f \
 //x=10.84 //y=1.92 //x2=9.99 //y2=0
cc_580 ( N_noxref_3_c_632_p N_noxref_9_c_1532_n ) capacitor c=0.00786308f \
 //x=10.73 //y=2.085 //x2=9.99 //y2=0
cc_581 ( N_noxref_3_c_551_n N_noxref_9_c_1442_n ) capacitor c=2.83275e-19 \
 //x=8.81 //y=1 //x2=11.59 //y2=0
cc_582 ( N_noxref_3_c_641_p N_noxref_9_c_1442_n ) capacitor c=0.00313809f \
 //x=10.73 //y=2.59 //x2=11.59 //y2=0
cc_583 ( N_noxref_3_c_621_p N_noxref_9_c_1442_n ) capacitor c=0.0022444f \
 //x=10.73 //y=2.085 //x2=11.59 //y2=0
cc_584 ( N_noxref_3_c_632_p N_noxref_9_c_1442_n ) capacitor c=2.63786e-19 \
 //x=10.73 //y=2.085 //x2=11.59 //y2=0
cc_585 ( N_noxref_3_c_551_n N_noxref_9_M4_noxref_d ) capacitor c=2.82748e-19 \
 //x=8.81 //y=1 //x2=7.65 //y2=0.865
cc_586 ( N_noxref_3_c_608_p N_noxref_9_M6_noxref_s ) capacitor c=0.0016958f \
 //x=10.73 //y=2.745 //x2=10.485 //y2=0.37
cc_587 ( N_noxref_3_c_620_p N_noxref_9_M6_noxref_s ) capacitor c=0.00297844f \
 //x=10.73 //y=2.085 //x2=10.485 //y2=0.37
cc_588 ( N_noxref_3_c_621_p N_noxref_9_M6_noxref_s ) capacitor c=0.00651272f \
 //x=10.73 //y=2.085 //x2=10.485 //y2=0.37
cc_589 ( N_noxref_3_c_631_p N_noxref_9_M6_noxref_s ) capacitor c=0.0300873f \
 //x=10.84 //y=0.91 //x2=10.485 //y2=0.37
cc_590 ( N_noxref_3_c_656_p N_noxref_9_M6_noxref_s ) capacitor c=0.002132f \
 //x=10.84 //y=1.565 //x2=10.485 //y2=0.37
cc_591 ( N_noxref_3_c_645_p N_noxref_9_M6_noxref_s ) capacitor c=0.00304786f \
 //x=10.84 //y=1.92 //x2=10.485 //y2=0.37
cc_592 ( N_noxref_3_c_658_p N_noxref_9_M6_noxref_s ) capacitor c=0.00517157f \
 //x=11.215 //y=0.755 //x2=10.485 //y2=0.37
cc_593 ( N_noxref_3_c_633_p N_noxref_9_M6_noxref_s ) capacitor c=0.0153553f \
 //x=11.37 //y=0.91 //x2=10.485 //y2=0.37
cc_594 ( N_noxref_3_c_660_p N_noxref_9_M6_noxref_s ) capacitor c=0.00629878f \
 //x=11.37 //y=1.255 //x2=10.485 //y2=0.37
cc_595 ( N_noxref_3_c_632_p N_noxref_9_M6_noxref_s ) capacitor c=0.00659771f \
 //x=10.73 //y=2.085 //x2=10.485 //y2=0.37
cc_596 ( N_noxref_3_c_535_n N_noxref_10_c_1687_n ) capacitor c=0.0228479f \
 //x=8.655 //y=5.2 //x2=8.51 //y2=4.555
cc_597 ( N_noxref_3_c_539_n N_noxref_10_c_1687_n ) capacitor c=0.009049f \
 //x=9.25 //y=2.425 //x2=8.51 //y2=4.555
cc_598 ( N_noxref_3_c_617_p N_noxref_10_c_1687_n ) capacitor c=0.0148501f \
 //x=9.25 //y=2.745 //x2=8.51 //y2=4.555
cc_599 ( N_noxref_3_c_541_n N_noxref_10_c_1687_n ) capacitor c=0.100631f \
 //x=9.25 //y=5.115 //x2=8.51 //y2=4.555
cc_600 ( N_noxref_3_c_638_p N_noxref_10_c_1687_n ) capacitor c=6.38703e-19 \
 //x=10.73 //y=2.425 //x2=8.51 //y2=4.555
cc_601 ( N_noxref_3_c_561_p N_noxref_10_c_1687_n ) capacitor c=0.00309347f \
 //x=10.73 //y=4.58 //x2=8.51 //y2=4.555
cc_602 ( N_noxref_3_c_552_n N_noxref_10_c_1687_n ) capacitor c=5.57251e-19 \
 //x=9.25 //y=2.59 //x2=8.51 //y2=4.555
cc_603 ( N_noxref_3_c_553_n N_noxref_10_c_1687_n ) capacitor c=0.00361136f \
 //x=9.41 //y=2.585 //x2=8.51 //y2=4.555
cc_604 ( N_noxref_3_c_535_n N_noxref_10_c_1698_n ) capacitor c=2.77624e-19 \
 //x=8.655 //y=5.2 //x2=8.51 //y2=2.08
cc_605 ( N_noxref_3_c_539_n N_noxref_10_c_1698_n ) capacitor c=0.015397f \
 //x=9.25 //y=2.425 //x2=8.51 //y2=2.08
cc_606 ( N_noxref_3_c_539_n N_noxref_10_c_1701_n ) capacitor c=0.00335761f \
 //x=9.25 //y=2.425 //x2=8.51 //y2=2.08
cc_607 ( N_noxref_3_c_535_n N_noxref_10_c_1705_n ) capacitor c=0.00469257f \
 //x=8.655 //y=5.2 //x2=8.54 //y2=4.7
cc_608 ( N_noxref_3_c_541_n N_noxref_10_c_1705_n ) capacitor c=7.76118e-19 \
 //x=9.25 //y=5.115 //x2=8.54 //y2=4.7
cc_609 ( N_noxref_3_c_535_n N_noxref_10_M17_noxref_g ) capacitor c=0.00842859f \
 //x=8.655 //y=5.2 //x2=8.55 //y2=6.02
cc_610 ( N_noxref_3_c_563_p N_noxref_10_M17_noxref_g ) capacitor c=0.00192712f \
 //x=8.77 //y=5.2 //x2=8.55 //y2=6.02
cc_611 ( N_noxref_3_c_566_p N_noxref_10_M17_noxref_g ) capacitor c=0.0178987f \
 //x=8.77 //y=5.38 //x2=8.55 //y2=6.02
cc_612 ( N_noxref_3_c_560_p N_noxref_10_M18_noxref_g ) capacitor c=0.0115937f \
 //x=9.165 //y=5.2 //x2=8.99 //y2=6.02
cc_613 ( N_noxref_3_c_563_p N_noxref_10_M18_noxref_g ) capacitor c=0.00291595f \
 //x=8.77 //y=5.2 //x2=8.99 //y2=6.02
cc_614 ( N_noxref_3_c_566_p N_noxref_10_M18_noxref_g ) capacitor c=0.0178506f \
 //x=8.77 //y=5.38 //x2=8.99 //y2=6.02
cc_615 ( N_noxref_3_c_551_n N_noxref_10_c_1711_n ) capacitor c=0.00120406f \
 //x=8.81 //y=1 //x2=8.545 //y2=0.905
cc_616 ( N_noxref_3_M5_noxref_d N_noxref_10_c_1711_n ) capacitor c=0.00137165f \
 //x=8.62 //y=0.905 //x2=8.545 //y2=0.905
cc_617 ( N_noxref_3_c_536_n N_noxref_10_c_1714_n ) capacitor c=0.00119008f \
 //x=8.81 //y=1.57 //x2=8.545 //y2=1.25
cc_618 ( N_noxref_3_c_551_n N_noxref_10_c_1714_n ) capacitor c=0.00218668f \
 //x=8.81 //y=1 //x2=8.545 //y2=1.25
cc_619 ( N_noxref_3_M5_noxref_d N_noxref_10_c_1714_n ) capacitor c=0.00237422f \
 //x=8.62 //y=0.905 //x2=8.545 //y2=1.25
cc_620 ( N_noxref_3_c_536_n N_noxref_10_c_1716_n ) capacitor c=0.00438634f \
 //x=8.81 //y=1.57 //x2=8.545 //y2=1.56
cc_621 ( N_noxref_3_c_541_n N_noxref_10_c_1752_n ) capacitor c=0.00845606f \
 //x=9.25 //y=5.115 //x2=8.915 //y2=4.79
cc_622 ( N_noxref_3_c_563_p N_noxref_10_c_1752_n ) capacitor c=0.0020909f \
 //x=8.77 //y=5.2 //x2=8.915 //y2=4.79
cc_623 ( N_noxref_3_c_566_p N_noxref_10_c_1752_n ) capacitor c=0.00291714f \
 //x=8.77 //y=5.38 //x2=8.915 //y2=4.79
cc_624 ( N_noxref_3_c_551_n N_noxref_10_c_1755_n ) capacitor c=5.50523e-19 \
 //x=8.81 //y=1 //x2=8.92 //y2=0.75
cc_625 ( N_noxref_3_M5_noxref_d N_noxref_10_c_1755_n ) capacitor c=0.0020782f \
 //x=8.62 //y=0.905 //x2=8.92 //y2=0.75
cc_626 ( N_noxref_3_c_536_n N_noxref_10_c_1757_n ) capacitor c=0.0089787f \
 //x=8.81 //y=1.57 //x2=8.92 //y2=1.405
cc_627 ( N_noxref_3_c_616_p N_noxref_10_c_1757_n ) capacitor c=0.00194324f \
 //x=9.165 //y=1.655 //x2=8.92 //y2=1.405
cc_628 ( N_noxref_3_c_551_n N_noxref_10_c_1757_n ) capacitor c=5.67071e-19 \
 //x=8.81 //y=1 //x2=8.92 //y2=1.405
cc_629 ( N_noxref_3_M5_noxref_d N_noxref_10_c_1757_n ) capacitor c=0.00356097f \
 //x=8.62 //y=0.905 //x2=8.92 //y2=1.405
cc_630 ( N_noxref_3_c_551_n N_noxref_10_c_1719_n ) capacitor c=0.00109893f \
 //x=8.81 //y=1 //x2=9.075 //y2=0.905
cc_631 ( N_noxref_3_M5_noxref_d N_noxref_10_c_1719_n ) capacitor c=8.50095e-19 \
 //x=8.62 //y=0.905 //x2=9.075 //y2=0.905
cc_632 ( N_noxref_3_c_536_n N_noxref_10_c_1720_n ) capacitor c=0.00303393f \
 //x=8.81 //y=1.57 //x2=9.075 //y2=1.25
cc_633 ( N_noxref_3_c_616_p N_noxref_10_c_1720_n ) capacitor c=0.00323005f \
 //x=9.165 //y=1.655 //x2=9.075 //y2=1.25
cc_634 ( N_noxref_3_c_551_n N_noxref_10_c_1720_n ) capacitor c=0.00312043f \
 //x=8.81 //y=1 //x2=9.075 //y2=1.25
cc_635 ( N_noxref_3_M5_noxref_d N_noxref_10_c_1720_n ) capacitor c=0.00237422f \
 //x=8.62 //y=0.905 //x2=9.075 //y2=1.25
cc_636 ( N_noxref_3_c_539_n N_noxref_10_c_1721_n ) capacitor c=0.00281392f \
 //x=9.25 //y=2.425 //x2=8.51 //y2=2.08
cc_637 ( N_noxref_3_c_536_n N_noxref_10_c_1768_n ) capacitor c=0.00341114f \
 //x=8.81 //y=1.57 //x2=8.51 //y2=1.915
cc_638 ( N_noxref_3_c_539_n N_noxref_10_c_1768_n ) capacitor c=0.00309058f \
 //x=9.25 //y=2.425 //x2=8.51 //y2=1.915
cc_639 ( N_noxref_3_c_535_n N_noxref_10_c_1724_n ) capacitor c=9.8107e-19 \
 //x=8.655 //y=5.2 //x2=8.54 //y2=4.7
cc_640 ( N_noxref_3_c_541_n N_noxref_10_c_1724_n ) capacitor c=0.00142201f \
 //x=9.25 //y=5.115 //x2=8.54 //y2=4.7
cc_641 ( N_noxref_3_c_536_n N_noxref_11_c_1796_n ) capacitor c=0.00466656f \
 //x=8.81 //y=1.57 //x2=11.1 //y2=1.755
cc_642 ( N_noxref_3_c_616_p N_noxref_11_c_1796_n ) capacitor c=0.00320561f \
 //x=9.165 //y=1.655 //x2=11.1 //y2=1.755
cc_643 ( N_noxref_3_c_709_p N_noxref_11_c_1796_n ) capacitor c=0.00108934f \
 //x=10.84 //y=1.255 //x2=11.1 //y2=1.755
cc_644 ( N_noxref_3_c_656_p N_noxref_11_c_1796_n ) capacitor c=0.00524682f \
 //x=10.84 //y=1.565 //x2=11.1 //y2=1.755
cc_645 ( N_noxref_3_c_645_p N_noxref_11_c_1796_n ) capacitor c=0.00376309f \
 //x=10.84 //y=1.92 //x2=11.1 //y2=1.755
cc_646 ( N_noxref_3_c_712_p N_noxref_11_c_1796_n ) capacitor c=0.00934265f \
 //x=11.215 //y=1.41 //x2=11.1 //y2=1.755
cc_647 ( N_noxref_3_c_660_p N_noxref_11_c_1796_n ) capacitor c=0.00362207f \
 //x=11.37 //y=1.255 //x2=11.1 //y2=1.755
cc_648 ( N_noxref_3_c_560_p N_noxref_11_c_1803_n ) capacitor c=0.00308961f \
 //x=9.165 //y=5.2 //x2=11.105 //y2=5.24
cc_649 ( N_noxref_3_c_563_p N_noxref_11_c_1803_n ) capacitor c=5.44332e-19 \
 //x=8.77 //y=5.2 //x2=11.105 //y2=5.24
cc_650 ( N_noxref_3_M19_noxref_g N_noxref_11_c_1803_n ) capacitor \
 c=0.00141266f //x=10.885 //y=6.02 //x2=11.105 //y2=5.24
cc_651 ( N_noxref_3_M20_noxref_g N_noxref_11_c_1803_n ) capacitor \
 c=0.00377331f //x=11.325 //y=6.02 //x2=11.105 //y2=5.24
cc_652 ( N_noxref_3_c_712_p N_noxref_11_c_1807_n ) capacitor c=0.00180253f \
 //x=11.215 //y=1.41 //x2=11.385 //y2=1.84
cc_653 ( N_noxref_3_c_539_n N_noxref_11_c_1808_n ) capacitor c=0.00320561f \
 //x=9.25 //y=2.425 //x2=11.185 //y2=1.84
cc_654 ( N_noxref_3_c_632_p N_noxref_11_c_1808_n ) capacitor c=0.00376309f \
 //x=10.73 //y=2.085 //x2=11.185 //y2=1.84
cc_655 ( N_noxref_3_M20_noxref_g N_noxref_11_c_1810_n ) capacitor \
 c=0.00966342f //x=11.325 //y=6.02 //x2=11.385 //y2=4.96
cc_656 ( N_noxref_3_c_541_n N_noxref_11_c_1811_n ) capacitor c=0.00291366f \
 //x=9.25 //y=5.115 //x2=11.19 //y2=4.96
cc_657 ( N_noxref_3_M19_noxref_g N_noxref_11_c_1811_n ) capacitor \
 c=0.00427521f //x=10.885 //y=6.02 //x2=11.19 //y2=4.96
cc_658 ( N_noxref_3_c_594_p N_noxref_11_c_1811_n ) capacitor c=0.00262283f \
 //x=11.25 //y=4.79 //x2=11.19 //y2=4.96
cc_659 ( N_noxref_3_c_539_n N_noxref_11_c_1814_n ) capacitor c=0.00110342f \
 //x=9.25 //y=2.425 //x2=11.47 //y2=4.875
cc_660 ( N_noxref_3_c_541_n N_noxref_11_c_1814_n ) capacitor c=0.00358906f \
 //x=9.25 //y=5.115 //x2=11.47 //y2=4.875
cc_661 ( N_noxref_3_c_638_p N_noxref_11_c_1814_n ) capacitor c=0.00761377f \
 //x=10.73 //y=2.425 //x2=11.47 //y2=4.875
cc_662 ( N_noxref_3_c_608_p N_noxref_11_c_1814_n ) capacitor c=0.0149195f \
 //x=10.73 //y=2.745 //x2=11.47 //y2=4.875
cc_663 ( N_noxref_3_c_561_p N_noxref_11_c_1814_n ) capacitor c=0.0933965f \
 //x=10.73 //y=4.58 //x2=11.47 //y2=4.875
cc_664 ( N_noxref_3_c_641_p N_noxref_11_c_1814_n ) capacitor c=0.00347652f \
 //x=10.73 //y=2.59 //x2=11.47 //y2=4.875
cc_665 ( N_noxref_3_c_620_p N_noxref_11_c_1814_n ) capacitor c=0.00825076f \
 //x=10.73 //y=2.085 //x2=11.47 //y2=4.875
cc_666 ( N_noxref_3_c_732_p N_noxref_11_c_1814_n ) capacitor c=0.00687738f \
 //x=10.73 //y=2.585 //x2=11.47 //y2=4.875
cc_667 ( N_noxref_3_c_621_p N_noxref_11_c_1814_n ) capacitor c=0.0023016f \
 //x=10.73 //y=2.085 //x2=11.47 //y2=4.875
cc_668 ( N_noxref_3_c_567_p N_noxref_11_c_1814_n ) capacitor c=0.00250262f \
 //x=10.73 //y=4.7 //x2=11.47 //y2=4.875
cc_669 ( N_noxref_3_c_594_p N_noxref_11_c_1814_n ) capacitor c=4.08297e-19 \
 //x=11.25 //y=4.79 //x2=11.47 //y2=4.875
cc_670 ( N_noxref_3_c_590_p N_noxref_11_c_1814_n ) capacitor c=0.00124564f \
 //x=10.96 //y=4.79 //x2=11.47 //y2=4.875
cc_671 ( N_noxref_3_c_632_p N_noxref_11_c_1814_n ) capacitor c=0.00112403f \
 //x=10.73 //y=2.085 //x2=11.47 //y2=4.875
cc_672 ( N_noxref_3_c_536_n N_noxref_11_c_1827_n ) capacitor c=6.23317e-19 \
 //x=8.81 //y=1.57 //x2=11.1 //y2=1.005
cc_673 ( N_noxref_3_c_551_n N_noxref_11_c_1827_n ) capacitor c=0.00598594f \
 //x=8.81 //y=1 //x2=11.1 //y2=1.005
cc_674 ( N_noxref_3_c_631_p N_noxref_11_c_1827_n ) capacitor c=0.00175305f \
 //x=10.84 //y=0.91 //x2=11.1 //y2=1.005
cc_675 ( N_noxref_3_c_709_p N_noxref_11_c_1827_n ) capacitor c=0.00354487f \
 //x=10.84 //y=1.255 //x2=11.1 //y2=1.005
cc_676 ( N_noxref_3_c_658_p N_noxref_11_c_1827_n ) capacitor c=5.57924e-19 \
 //x=11.215 //y=0.755 //x2=11.1 //y2=1.005
cc_677 ( N_noxref_3_c_712_p N_noxref_11_c_1827_n ) capacitor c=5.75878e-19 \
 //x=11.215 //y=1.41 //x2=11.1 //y2=1.005
cc_678 ( N_noxref_3_c_633_p N_noxref_11_c_1827_n ) capacitor c=0.00160969f \
 //x=11.37 //y=0.91 //x2=11.1 //y2=1.005
cc_679 ( N_noxref_3_c_660_p N_noxref_11_c_1827_n ) capacitor c=0.00411132f \
 //x=11.37 //y=1.255 //x2=11.1 //y2=1.005
cc_680 ( N_noxref_3_M19_noxref_g N_noxref_11_c_1835_n ) capacitor c=0.0162066f \
 //x=10.885 //y=6.02 //x2=11.105 //y2=5.38
cc_681 ( N_noxref_3_M20_noxref_g N_noxref_11_c_1835_n ) capacitor c=0.0162066f \
 //x=11.325 //y=6.02 //x2=11.105 //y2=5.38
cc_682 ( N_noxref_3_c_594_p N_noxref_11_c_1835_n ) capacitor c=0.00290963f \
 //x=11.25 //y=4.79 //x2=11.105 //y2=5.38
cc_683 ( N_noxref_3_c_631_p N_noxref_11_M6_noxref_d ) capacitor c=0.00137914f \
 //x=10.84 //y=0.91 //x2=10.915 //y2=0.91
cc_684 ( N_noxref_3_c_709_p N_noxref_11_M6_noxref_d ) capacitor c=0.0023891f \
 //x=10.84 //y=1.255 //x2=10.915 //y2=0.91
cc_685 ( N_noxref_3_c_658_p N_noxref_11_M6_noxref_d ) capacitor c=0.0020782f \
 //x=11.215 //y=0.755 //x2=10.915 //y2=0.91
cc_686 ( N_noxref_3_c_712_p N_noxref_11_M6_noxref_d ) capacitor c=0.00356097f \
 //x=11.215 //y=1.41 //x2=10.915 //y2=0.91
cc_687 ( N_noxref_3_c_633_p N_noxref_11_M6_noxref_d ) capacitor c=0.00138452f \
 //x=11.37 //y=0.91 //x2=10.915 //y2=0.91
cc_688 ( N_noxref_3_c_660_p N_noxref_11_M6_noxref_d ) capacitor c=0.00235934f \
 //x=11.37 //y=1.255 //x2=10.915 //y2=0.91
cc_689 ( N_noxref_3_c_538_n N_noxref_13_c_1947_n ) capacitor c=0.00911498f \
 //x=8.895 //y=1.655 //x2=8.325 //y2=1.495
cc_690 ( N_noxref_3_c_616_p N_noxref_13_c_1952_n ) capacitor c=0.00373013f \
 //x=9.165 //y=1.655 //x2=9.21 //y2=0.53
cc_691 ( N_noxref_3_c_551_n N_noxref_13_c_1952_n ) capacitor c=0.00367971f \
 //x=8.81 //y=1 //x2=9.21 //y2=0.53
cc_692 ( N_noxref_3_M5_noxref_d N_noxref_13_c_1952_n ) capacitor c=0.00910163f \
 //x=8.62 //y=0.905 //x2=9.21 //y2=0.53
cc_693 ( N_noxref_3_c_536_n N_noxref_13_M4_noxref_s ) capacitor c=0.0157502f \
 //x=8.81 //y=1.57 //x2=7.22 //y2=0.365
cc_694 ( N_noxref_3_c_616_p N_noxref_13_M4_noxref_s ) capacitor c=0.0055349f \
 //x=9.165 //y=1.655 //x2=7.22 //y2=0.365
cc_695 ( N_noxref_3_c_617_p N_noxref_13_M4_noxref_s ) capacitor c=7.90116e-19 \
 //x=9.25 //y=2.745 //x2=7.22 //y2=0.365
cc_696 ( N_noxref_3_c_551_n N_noxref_13_M4_noxref_s ) capacitor c=0.00897308f \
 //x=8.81 //y=1 //x2=7.22 //y2=0.365
cc_697 ( N_noxref_3_c_552_n N_noxref_13_M4_noxref_s ) capacitor c=0.00202552f \
 //x=9.25 //y=2.59 //x2=7.22 //y2=0.365
cc_698 ( N_noxref_3_M5_noxref_d N_noxref_13_M4_noxref_s ) capacitor \
 c=0.0275552f //x=8.62 //y=0.905 //x2=7.22 //y2=0.365
cc_699 ( N_noxref_4_c_765_n N_noxref_5_c_999_n ) capacitor c=9.05427e-19 \
 //x=4.475 //y=7.4 //x2=1.11 //y2=4.7
cc_700 ( N_noxref_4_c_776_n N_noxref_5_c_999_n ) capacitor c=6.28732e-19 \
 //x=1.585 //y=7.4 //x2=1.11 //y2=4.7
cc_701 ( N_noxref_4_c_786_n N_noxref_5_c_999_n ) capacitor c=0.00867681f \
 //x=0.74 //y=7.4 //x2=1.11 //y2=4.7
cc_702 ( N_noxref_4_c_786_n N_noxref_5_c_1001_n ) capacitor c=0.0104242f \
 //x=0.74 //y=7.4 //x2=1.112 //y2=4.56
cc_703 ( N_noxref_4_c_765_n N_noxref_5_c_1003_n ) capacitor c=6.23118e-19 \
 //x=4.475 //y=7.4 //x2=1.11 //y2=4.7
cc_704 ( N_noxref_4_c_786_n N_noxref_5_c_1003_n ) capacitor c=0.00370735f \
 //x=0.74 //y=7.4 //x2=1.11 //y2=4.7
cc_705 ( N_noxref_4_c_776_n N_noxref_5_M7_noxref_g ) capacitor c=0.0072715f \
 //x=1.585 //y=7.4 //x2=1.01 //y2=6.02
cc_706 ( N_noxref_4_M7_noxref_s N_noxref_5_M7_noxref_g ) capacitor \
 c=0.0567929f //x=0.655 //y=5.02 //x2=1.01 //y2=6.02
cc_707 ( N_noxref_4_c_776_n N_noxref_5_M8_noxref_g ) capacitor c=0.00749619f \
 //x=1.585 //y=7.4 //x2=1.45 //y2=6.02
cc_708 ( N_noxref_4_M8_noxref_d N_noxref_5_M8_noxref_g ) capacitor c=0.015318f \
 //x=1.525 //y=5.02 //x2=1.45 //y2=6.02
cc_709 ( N_noxref_4_c_786_n N_noxref_5_c_1010_n ) capacitor c=0.0234764f \
 //x=0.74 //y=7.4 //x2=1.11 //y2=4.7
cc_710 ( N_noxref_4_c_789_n N_noxref_6_c_1106_n ) capacitor c=0.00226427f \
 //x=3.33 //y=7.4 //x2=1.88 //y2=4.7
cc_711 ( N_noxref_4_c_779_n N_noxref_6_M9_noxref_g ) capacitor c=0.00692597f \
 //x=2.465 //y=7.4 //x2=1.89 //y2=6.02
cc_712 ( N_noxref_4_M8_noxref_d N_noxref_6_M9_noxref_g ) capacitor c=0.015318f \
 //x=1.525 //y=5.02 //x2=1.89 //y2=6.02
cc_713 ( N_noxref_4_c_779_n N_noxref_6_M10_noxref_g ) capacitor c=0.00749619f \
 //x=2.465 //y=7.4 //x2=2.33 //y2=6.02
cc_714 ( N_noxref_4_M10_noxref_d N_noxref_6_M10_noxref_g ) capacitor \
 c=0.0430452f //x=2.405 //y=5.02 //x2=2.33 //y2=6.02
cc_715 ( N_noxref_4_c_789_n N_noxref_6_c_1120_n ) capacitor c=0.0132232f \
 //x=3.33 //y=7.4 //x2=2.255 //y2=4.79
cc_716 ( N_noxref_4_c_789_n N_noxref_6_c_1138_n ) capacitor c=2.73429e-19 \
 //x=3.33 //y=7.4 //x2=1.88 //y2=4.7
cc_717 ( N_noxref_4_M8_noxref_d N_noxref_6_c_1138_n ) capacitor c=3.32274e-19 \
 //x=1.525 //y=5.02 //x2=1.88 //y2=4.7
cc_718 ( N_noxref_4_c_765_n N_noxref_7_c_1199_n ) capacitor c=0.0019855f \
 //x=4.475 //y=7.4 //x2=4.88 //y2=5.21
cc_719 ( N_noxref_4_c_772_n N_noxref_7_c_1199_n ) capacitor c=0.00495337f \
 //x=4.56 //y=6.855 //x2=4.88 //y2=5.21
cc_720 ( N_noxref_4_c_818_n N_noxref_7_c_1199_n ) capacitor c=0.00192602f \
 //x=11.47 //y=7.4 //x2=4.88 //y2=5.21
cc_721 ( N_noxref_4_c_784_n N_noxref_7_c_1199_n ) capacitor c=0.00433483f \
 //x=6.49 //y=7.4 //x2=4.88 //y2=5.21
cc_722 ( N_noxref_4_M11_noxref_d N_noxref_7_c_1199_n ) capacitor c=0.00655495f \
 //x=4.415 //y=5.025 //x2=4.88 //y2=5.21
cc_723 ( N_noxref_4_c_800_n N_noxref_7_c_1222_n ) capacitor c=0.00223213f \
 //x=11.47 //y=7.4 //x2=5.75 //y2=6.91
cc_724 ( N_noxref_4_c_789_n N_noxref_7_c_1205_n ) capacitor c=0.00766391f \
 //x=3.33 //y=7.4 //x2=4.12 //y2=5.21
cc_725 ( N_noxref_4_M7_noxref_s N_noxref_7_c_1205_n ) capacitor c=5.03296e-19 \
 //x=0.655 //y=5.02 //x2=4.12 //y2=5.21
cc_726 ( N_noxref_4_M15_noxref_s N_noxref_7_c_1212_n ) capacitor c=0.00111428f \
 //x=7.315 //y=5.02 //x2=5 //y2=5.21
cc_727 ( N_noxref_4_c_772_n N_noxref_7_c_1213_n ) capacitor c=0.0377581f \
 //x=4.56 //y=6.855 //x2=5 //y2=6.74
cc_728 ( N_noxref_4_c_774_n N_noxref_7_c_1213_n ) capacitor c=0.0104317f \
 //x=4.56 //y=7.23 //x2=5 //y2=6.74
cc_729 ( N_noxref_4_c_818_n N_noxref_7_c_1213_n ) capacitor c=0.0973955f \
 //x=11.47 //y=7.4 //x2=5 //y2=6.74
cc_730 ( N_noxref_4_c_784_n N_noxref_7_c_1213_n ) capacitor c=0.0204874f \
 //x=6.49 //y=7.4 //x2=5 //y2=6.74
cc_731 ( N_noxref_4_c_800_n N_noxref_7_c_1213_n ) capacitor c=0.00112916f \
 //x=11.47 //y=7.4 //x2=5 //y2=6.74
cc_732 ( N_noxref_4_M11_noxref_d N_noxref_7_c_1213_n ) capacitor c=0.00510287f \
 //x=4.415 //y=5.025 //x2=5 //y2=6.74
cc_733 ( N_noxref_4_c_772_n N_noxref_7_c_1229_n ) capacitor c=6.1128e-19 \
 //x=4.56 //y=6.855 //x2=5.88 //y2=6.74
cc_734 ( N_noxref_4_c_818_n N_noxref_7_c_1229_n ) capacitor c=0.00192921f \
 //x=11.47 //y=7.4 //x2=5.88 //y2=6.74
cc_735 ( N_noxref_4_c_784_n N_noxref_7_c_1229_n ) capacitor c=9.36527e-19 \
 //x=6.49 //y=7.4 //x2=5.88 //y2=6.74
cc_736 ( N_noxref_4_c_799_n N_noxref_7_c_1229_n ) capacitor c=0.0111101f \
 //x=6.66 //y=7.4 //x2=5.88 //y2=6.74
cc_737 ( N_noxref_4_c_800_n N_noxref_7_c_1229_n ) capacitor c=0.00112713f \
 //x=11.47 //y=7.4 //x2=5.88 //y2=6.74
cc_738 ( N_noxref_4_c_765_n N_noxref_7_c_1214_n ) capacitor c=0.00240599f \
 //x=4.475 //y=7.4 //x2=4.12 //y2=5.38
cc_739 ( N_noxref_4_c_772_n N_noxref_7_c_1214_n ) capacitor c=0.00220777f \
 //x=4.56 //y=6.855 //x2=4.12 //y2=5.38
cc_740 ( N_noxref_4_c_774_n N_noxref_7_c_1214_n ) capacitor c=0.00154298f \
 //x=4.56 //y=7.23 //x2=4.12 //y2=5.38
cc_741 ( N_noxref_4_c_784_n N_noxref_7_c_1214_n ) capacitor c=0.0126678f \
 //x=6.49 //y=7.4 //x2=4.12 //y2=5.38
cc_742 ( N_noxref_4_c_789_n N_noxref_7_c_1214_n ) capacitor c=0.0552885f \
 //x=3.33 //y=7.4 //x2=4.12 //y2=5.38
cc_743 ( N_noxref_4_c_800_n N_noxref_7_c_1214_n ) capacitor c=0.00161681f \
 //x=11.47 //y=7.4 //x2=4.12 //y2=5.38
cc_744 ( N_noxref_4_M10_noxref_d N_noxref_7_c_1214_n ) capacitor c=0.00271974f \
 //x=2.405 //y=5.02 //x2=4.12 //y2=5.38
cc_745 ( N_noxref_4_M11_noxref_d N_noxref_7_c_1214_n ) capacitor c=0.0736177f \
 //x=4.415 //y=5.025 //x2=4.12 //y2=5.38
cc_746 ( N_noxref_4_c_772_n N_noxref_7_c_1218_n ) capacitor c=0.00211426f \
 //x=4.56 //y=6.855 //x2=5 //y2=5.38
cc_747 ( N_noxref_4_c_774_n N_noxref_7_c_1218_n ) capacitor c=4.62894e-19 \
 //x=4.56 //y=7.23 //x2=5 //y2=5.38
cc_748 ( N_noxref_4_c_818_n N_noxref_7_c_1218_n ) capacitor c=0.0020548f \
 //x=11.47 //y=7.4 //x2=5 //y2=5.38
cc_749 ( N_noxref_4_c_784_n N_noxref_7_c_1218_n ) capacitor c=0.00855842f \
 //x=6.49 //y=7.4 //x2=5 //y2=5.38
cc_750 ( N_noxref_4_c_800_n N_noxref_7_c_1218_n ) capacitor c=0.00100828f \
 //x=11.47 //y=7.4 //x2=5 //y2=5.38
cc_751 ( N_noxref_4_M11_noxref_d N_noxref_7_c_1218_n ) capacitor c=0.0672707f \
 //x=4.415 //y=5.025 //x2=5 //y2=5.38
cc_752 ( N_noxref_4_c_765_n N_noxref_7_M11_noxref_s ) capacitor c=0.0245587f \
 //x=4.475 //y=7.4 //x2=3.985 //y2=5.025
cc_753 ( N_noxref_4_c_772_n N_noxref_7_M11_noxref_s ) capacitor c=0.0378001f \
 //x=4.56 //y=6.855 //x2=3.985 //y2=5.025
cc_754 ( N_noxref_4_c_774_n N_noxref_7_M11_noxref_s ) capacitor c=0.0124823f \
 //x=4.56 //y=7.23 //x2=3.985 //y2=5.025
cc_755 ( N_noxref_4_c_784_n N_noxref_7_M11_noxref_s ) capacitor c=0.00293113f \
 //x=6.49 //y=7.4 //x2=3.985 //y2=5.025
cc_756 ( N_noxref_4_c_789_n N_noxref_7_M11_noxref_s ) capacitor c=0.00933367f \
 //x=3.33 //y=7.4 //x2=3.985 //y2=5.025
cc_757 ( N_noxref_4_c_800_n N_noxref_7_M11_noxref_s ) capacitor c=0.00129282f \
 //x=11.47 //y=7.4 //x2=3.985 //y2=5.025
cc_758 ( N_noxref_4_M11_noxref_d N_noxref_7_M11_noxref_s ) capacitor \
 c=0.00566597f //x=4.415 //y=5.025 //x2=3.985 //y2=5.025
cc_759 ( N_noxref_4_c_818_n N_noxref_7_M14_noxref_d ) capacitor c=0.00206634f \
 //x=11.47 //y=7.4 //x2=5.735 //y2=5.025
cc_760 ( N_noxref_4_c_784_n N_noxref_7_M14_noxref_d ) capacitor c=0.00858175f \
 //x=6.49 //y=7.4 //x2=5.735 //y2=5.025
cc_761 ( N_noxref_4_c_799_n N_noxref_7_M14_noxref_d ) capacitor c=0.0437918f \
 //x=6.66 //y=7.4 //x2=5.735 //y2=5.025
cc_762 ( N_noxref_4_c_800_n N_noxref_7_M14_noxref_d ) capacitor c=0.00100487f \
 //x=11.47 //y=7.4 //x2=5.735 //y2=5.025
cc_763 ( N_noxref_4_M15_noxref_s N_noxref_7_M14_noxref_d ) capacitor \
 c=0.00249213f //x=7.315 //y=5.02 //x2=5.735 //y2=5.025
cc_764 ( N_noxref_4_c_799_n N_noxref_8_c_1311_n ) capacitor c=0.00231379f \
 //x=6.66 //y=7.4 //x2=5.215 //y2=4.705
cc_765 ( N_noxref_4_c_784_n N_noxref_8_M13_noxref_g ) capacitor c=0.00720064f \
 //x=6.49 //y=7.4 //x2=5.22 //y2=6.025
cc_766 ( N_noxref_4_c_784_n N_noxref_8_M14_noxref_g ) capacitor c=0.00776897f \
 //x=6.49 //y=7.4 //x2=5.66 //y2=6.025
cc_767 ( N_noxref_4_c_799_n N_noxref_8_c_1364_n ) capacitor c=0.016784f \
 //x=6.66 //y=7.4 //x2=5.585 //y2=4.795
cc_768 ( N_noxref_4_c_799_n N_noxref_8_c_1332_n ) capacitor c=2.75092e-19 \
 //x=6.66 //y=7.4 //x2=5.215 //y2=4.705
cc_769 ( N_noxref_4_c_786_n N_noxref_9_c_1423_n ) capacitor c=0.00989031f \
 //x=0.74 //y=7.4 //x2=0.74 //y2=0
cc_770 ( N_noxref_4_c_789_n N_noxref_9_c_1431_n ) capacitor c=0.00969948f \
 //x=3.33 //y=7.4 //x2=3.33 //y2=0
cc_771 ( N_noxref_4_c_799_n N_noxref_9_c_1482_n ) capacitor c=0.00969948f \
 //x=6.66 //y=7.4 //x2=6.66 //y2=0
cc_772 ( N_noxref_4_c_865_n N_noxref_9_c_1532_n ) capacitor c=0.00969948f \
 //x=9.99 //y=7.4 //x2=9.99 //y2=0
cc_773 ( N_noxref_4_c_800_n N_noxref_9_c_1442_n ) capacitor c=0.00989031f \
 //x=11.47 //y=7.4 //x2=11.59 //y2=0
cc_774 ( N_noxref_4_c_865_n N_noxref_10_c_1705_n ) capacitor c=0.00226427f \
 //x=9.99 //y=7.4 //x2=8.54 //y2=4.7
cc_775 ( N_noxref_4_c_854_n N_noxref_10_M17_noxref_g ) capacitor c=0.00692597f \
 //x=9.125 //y=7.4 //x2=8.55 //y2=6.02
cc_776 ( N_noxref_4_M16_noxref_d N_noxref_10_M17_noxref_g ) capacitor \
 c=0.015318f //x=8.185 //y=5.02 //x2=8.55 //y2=6.02
cc_777 ( N_noxref_4_c_854_n N_noxref_10_M18_noxref_g ) capacitor c=0.00749619f \
 //x=9.125 //y=7.4 //x2=8.99 //y2=6.02
cc_778 ( N_noxref_4_M18_noxref_d N_noxref_10_M18_noxref_g ) capacitor \
 c=0.0430452f //x=9.065 //y=5.02 //x2=8.99 //y2=6.02
cc_779 ( N_noxref_4_c_865_n N_noxref_10_c_1752_n ) capacitor c=0.0129375f \
 //x=9.99 //y=7.4 //x2=8.915 //y2=4.79
cc_780 ( N_noxref_4_c_865_n N_noxref_10_c_1724_n ) capacitor c=2.73429e-19 \
 //x=9.99 //y=7.4 //x2=8.54 //y2=4.7
cc_781 ( N_noxref_4_M16_noxref_d N_noxref_10_c_1724_n ) capacitor \
 c=3.32274e-19 //x=8.185 //y=5.02 //x2=8.54 //y2=4.7
cc_782 ( N_noxref_4_c_818_n N_noxref_11_c_1803_n ) capacitor c=0.00259275f \
 //x=11.47 //y=7.4 //x2=11.105 //y2=5.24
cc_783 ( N_noxref_4_c_859_n N_noxref_11_c_1803_n ) capacitor c=0.0010065f \
 //x=11.46 //y=7.4 //x2=11.105 //y2=5.24
cc_784 ( N_noxref_4_c_800_n N_noxref_11_c_1803_n ) capacitor c=0.00295945f \
 //x=11.47 //y=7.4 //x2=11.105 //y2=5.24
cc_785 ( N_noxref_4_M15_noxref_s N_noxref_11_c_1803_n ) capacitor \
 c=2.62188e-19 //x=7.315 //y=5.02 //x2=11.105 //y2=5.24
cc_786 ( N_noxref_4_M19_noxref_s N_noxref_11_c_1803_n ) capacitor c=0.0465774f \
 //x=10.53 //y=5.02 //x2=11.105 //y2=5.24
cc_787 ( N_noxref_4_M20_noxref_d N_noxref_11_c_1803_n ) capacitor c=0.0486749f \
 //x=11.4 //y=5.02 //x2=11.105 //y2=5.24
cc_788 ( N_noxref_4_c_818_n N_noxref_11_c_1810_n ) capacitor c=0.00199455f \
 //x=11.47 //y=7.4 //x2=11.385 //y2=4.96
cc_789 ( N_noxref_4_c_859_n N_noxref_11_c_1810_n ) capacitor c=0.00207359f \
 //x=11.46 //y=7.4 //x2=11.385 //y2=4.96
cc_790 ( N_noxref_4_M20_noxref_d N_noxref_11_c_1810_n ) capacitor c=0.0235605f \
 //x=11.4 //y=5.02 //x2=11.385 //y2=4.96
cc_791 ( N_noxref_4_c_865_n N_noxref_11_c_1811_n ) capacitor c=0.00464635f \
 //x=9.99 //y=7.4 //x2=11.19 //y2=4.96
cc_792 ( N_noxref_4_c_800_n N_noxref_11_c_1814_n ) capacitor c=0.0297606f \
 //x=11.47 //y=7.4 //x2=11.47 //y2=4.875
cc_793 ( N_noxref_4_c_818_n N_noxref_11_c_1835_n ) capacitor c=0.0024144f \
 //x=11.47 //y=7.4 //x2=11.105 //y2=5.38
cc_794 ( N_noxref_4_c_859_n N_noxref_11_c_1835_n ) capacitor c=0.0137788f \
 //x=11.46 //y=7.4 //x2=11.105 //y2=5.38
cc_795 ( N_noxref_4_c_865_n N_noxref_11_c_1835_n ) capacitor c=0.00821941f \
 //x=9.99 //y=7.4 //x2=11.105 //y2=5.38
cc_796 ( N_noxref_4_c_800_n N_noxref_11_c_1835_n ) capacitor c=0.00961566f \
 //x=11.47 //y=7.4 //x2=11.105 //y2=5.38
cc_797 ( N_noxref_4_M19_noxref_s N_noxref_11_c_1835_n ) capacitor c=0.0900053f \
 //x=10.53 //y=5.02 //x2=11.105 //y2=5.38
cc_798 ( N_noxref_4_M20_noxref_d N_noxref_11_c_1835_n ) capacitor c=0.0930425f \
 //x=11.4 //y=5.02 //x2=11.105 //y2=5.38
cc_799 ( N_noxref_5_c_999_n N_noxref_6_c_1095_n ) capacitor c=0.0172939f \
 //x=1.11 //y=4.7 //x2=1.85 //y2=4.555
cc_800 ( N_noxref_5_c_1001_n N_noxref_6_c_1095_n ) capacitor c=0.109381f \
 //x=1.112 //y=4.56 //x2=1.85 //y2=4.555
cc_801 ( N_noxref_5_c_1025_p N_noxref_6_c_1095_n ) capacitor c=3.49899e-19 \
 //x=1.11 //y=2.08 //x2=1.85 //y2=4.555
cc_802 ( N_noxref_5_c_1003_n N_noxref_6_c_1095_n ) capacitor c=7.76143e-19 \
 //x=1.11 //y=4.7 //x2=1.85 //y2=4.555
cc_803 ( N_noxref_5_c_1010_n N_noxref_6_c_1095_n ) capacitor c=0.00201171f \
 //x=1.11 //y=4.7 //x2=1.85 //y2=4.555
cc_804 ( N_noxref_5_c_1028_p N_noxref_6_c_1103_n ) capacitor c=0.0205342f \
 //x=1.11 //y=2.08 //x2=1.85 //y2=2.08
cc_805 ( N_noxref_5_c_1025_p N_noxref_6_c_1103_n ) capacitor c=5.16867e-19 \
 //x=1.11 //y=2.08 //x2=1.85 //y2=2.08
cc_806 ( N_noxref_5_c_1030_p N_noxref_6_c_1103_n ) capacitor c=0.00167888f \
 //x=0.915 //y=1.915 //x2=1.85 //y2=2.08
cc_807 ( N_noxref_5_c_1028_p N_noxref_6_c_1105_n ) capacitor c=0.00370824f \
 //x=1.11 //y=2.08 //x2=1.85 //y2=2.08
cc_808 ( N_noxref_5_c_1001_n N_noxref_6_c_1105_n ) capacitor c=3.49899e-19 \
 //x=1.112 //y=4.56 //x2=1.85 //y2=2.08
cc_809 ( N_noxref_5_c_1025_p N_noxref_6_c_1105_n ) capacitor c=0.00445529f \
 //x=1.11 //y=2.08 //x2=1.85 //y2=2.08
cc_810 ( N_noxref_5_c_1030_p N_noxref_6_c_1105_n ) capacitor c=0.00267961f \
 //x=0.915 //y=1.915 //x2=1.85 //y2=2.08
cc_811 ( N_noxref_5_c_999_n N_noxref_6_c_1106_n ) capacitor c=0.00389735f \
 //x=1.11 //y=4.7 //x2=1.88 //y2=4.7
cc_812 ( N_noxref_5_c_1001_n N_noxref_6_c_1106_n ) capacitor c=2.1563e-19 \
 //x=1.112 //y=4.56 //x2=1.88 //y2=4.7
cc_813 ( N_noxref_5_c_1003_n N_noxref_6_c_1106_n ) capacitor c=0.00397338f \
 //x=1.11 //y=4.7 //x2=1.88 //y2=4.7
cc_814 ( N_noxref_5_c_1010_n N_noxref_6_c_1106_n ) capacitor c=0.00283894f \
 //x=1.11 //y=4.7 //x2=1.88 //y2=4.7
cc_815 ( N_noxref_5_M7_noxref_g N_noxref_6_M9_noxref_g ) capacitor \
 c=0.0104892f //x=1.01 //y=6.02 //x2=1.89 //y2=6.02
cc_816 ( N_noxref_5_M8_noxref_g N_noxref_6_M9_noxref_g ) capacitor c=0.107636f \
 //x=1.45 //y=6.02 //x2=1.89 //y2=6.02
cc_817 ( N_noxref_5_M8_noxref_g N_noxref_6_M10_noxref_g ) capacitor \
 c=0.0100341f //x=1.45 //y=6.02 //x2=2.33 //y2=6.02
cc_818 ( N_noxref_5_c_1042_p N_noxref_6_c_1114_n ) capacitor c=4.86545e-19 \
 //x=0.915 //y=0.865 //x2=1.885 //y2=0.905
cc_819 ( N_noxref_5_c_1043_p N_noxref_6_c_1114_n ) capacitor c=0.00152405f \
 //x=0.915 //y=1.21 //x2=1.885 //y2=0.905
cc_820 ( N_noxref_5_c_1044_p N_noxref_6_c_1114_n ) capacitor c=0.0151475f \
 //x=1.445 //y=0.865 //x2=1.885 //y2=0.905
cc_821 ( N_noxref_5_c_1045_p N_noxref_6_c_1116_n ) capacitor c=0.00109982f \
 //x=0.915 //y=1.52 //x2=1.885 //y2=1.25
cc_822 ( N_noxref_5_c_1046_p N_noxref_6_c_1116_n ) capacitor c=0.0111064f \
 //x=1.445 //y=1.21 //x2=1.885 //y2=1.25
cc_823 ( N_noxref_5_c_1045_p N_noxref_6_c_1119_n ) capacitor c=9.58243e-19 \
 //x=0.915 //y=1.52 //x2=1.885 //y2=1.56
cc_824 ( N_noxref_5_c_1030_p N_noxref_6_c_1119_n ) capacitor c=0.00662747f \
 //x=0.915 //y=1.915 //x2=1.885 //y2=1.56
cc_825 ( N_noxref_5_c_1046_p N_noxref_6_c_1119_n ) capacitor c=0.00862358f \
 //x=1.445 //y=1.21 //x2=1.885 //y2=1.56
cc_826 ( N_noxref_5_c_1044_p N_noxref_6_c_1129_n ) capacitor c=0.00127211f \
 //x=1.445 //y=0.865 //x2=2.415 //y2=0.905
cc_827 ( N_noxref_5_c_1046_p N_noxref_6_c_1131_n ) capacitor c=0.00204774f \
 //x=1.445 //y=1.21 //x2=2.415 //y2=1.25
cc_828 ( N_noxref_5_c_1028_p N_noxref_6_c_1135_n ) capacitor c=0.00167305f \
 //x=1.11 //y=2.08 //x2=1.85 //y2=2.08
cc_829 ( N_noxref_5_c_1025_p N_noxref_6_c_1135_n ) capacitor c=0.00266443f \
 //x=1.11 //y=2.08 //x2=1.85 //y2=2.08
cc_830 ( N_noxref_5_c_1030_p N_noxref_6_c_1135_n ) capacitor c=0.0181449f \
 //x=0.915 //y=1.915 //x2=1.85 //y2=2.08
cc_831 ( N_noxref_5_c_999_n N_noxref_6_c_1138_n ) capacitor c=0.00158715f \
 //x=1.11 //y=4.7 //x2=1.88 //y2=4.7
cc_832 ( N_noxref_5_c_1003_n N_noxref_6_c_1138_n ) capacitor c=0.00237977f \
 //x=1.11 //y=4.7 //x2=1.88 //y2=4.7
cc_833 ( N_noxref_5_c_1010_n N_noxref_6_c_1138_n ) capacitor c=0.0297875f \
 //x=1.11 //y=4.7 //x2=1.88 //y2=4.7
cc_834 ( N_noxref_5_c_1028_p N_noxref_9_c_1564_n ) capacitor c=6.60635e-19 \
 //x=1.11 //y=2.08 //x2=1.095 //y2=0
cc_835 ( N_noxref_5_c_1028_p N_noxref_9_c_1418_n ) capacitor c=0.00709452f \
 //x=1.11 //y=2.08 //x2=1.18 //y2=0.955
cc_836 ( N_noxref_5_c_1025_p N_noxref_9_c_1418_n ) capacitor c=2.13705e-19 \
 //x=1.11 //y=2.08 //x2=1.18 //y2=0.955
cc_837 ( N_noxref_5_c_1042_p N_noxref_9_c_1418_n ) capacitor c=0.00156094f \
 //x=0.915 //y=0.865 //x2=1.18 //y2=0.955
cc_838 ( N_noxref_5_c_1043_p N_noxref_9_c_1418_n ) capacitor c=0.00413828f \
 //x=0.915 //y=1.21 //x2=1.18 //y2=0.955
cc_839 ( N_noxref_5_c_1045_p N_noxref_9_c_1418_n ) capacitor c=4.2764e-19 \
 //x=0.915 //y=1.52 //x2=1.18 //y2=0.955
cc_840 ( N_noxref_5_c_1064_p N_noxref_9_c_1418_n ) capacitor c=7.35788e-19 \
 //x=1.29 //y=0.71 //x2=1.18 //y2=0.955
cc_841 ( N_noxref_5_c_1065_p N_noxref_9_c_1418_n ) capacitor c=6.38426e-19 \
 //x=1.29 //y=1.365 //x2=1.18 //y2=0.955
cc_842 ( N_noxref_5_c_1044_p N_noxref_9_c_1418_n ) capacitor c=0.00172871f \
 //x=1.445 //y=0.865 //x2=1.18 //y2=0.955
cc_843 ( N_noxref_5_c_1046_p N_noxref_9_c_1418_n ) capacitor c=0.00296337f \
 //x=1.445 //y=1.21 //x2=1.18 //y2=0.955
cc_844 ( N_noxref_5_c_1042_p N_noxref_9_c_1574_n ) capacitor c=3.51399e-19 \
 //x=0.915 //y=0.865 //x2=1.177 //y2=0.825
cc_845 ( N_noxref_5_c_1064_p N_noxref_9_c_1574_n ) capacitor c=0.00864436f \
 //x=1.29 //y=0.71 //x2=1.177 //y2=0.825
cc_846 ( N_noxref_5_c_1044_p N_noxref_9_c_1574_n ) capacitor c=4.45447e-19 \
 //x=1.445 //y=0.865 //x2=1.177 //y2=0.825
cc_847 ( N_noxref_5_c_1042_p N_noxref_9_c_1421_n ) capacitor c=0.00688065f \
 //x=0.915 //y=0.865 //x2=3.16 //y2=0
cc_848 ( N_noxref_5_c_1028_p N_noxref_9_c_1423_n ) capacitor c=0.0082376f \
 //x=1.11 //y=2.08 //x2=0.74 //y2=0
cc_849 ( N_noxref_5_c_1001_n N_noxref_9_c_1423_n ) capacitor c=0.0113199f \
 //x=1.112 //y=4.56 //x2=0.74 //y2=0
cc_850 ( N_noxref_5_c_1025_p N_noxref_9_c_1423_n ) capacitor c=0.00369668f \
 //x=1.11 //y=2.08 //x2=0.74 //y2=0
cc_851 ( N_noxref_5_c_1045_p N_noxref_9_c_1423_n ) capacitor c=0.0015404f \
 //x=0.915 //y=1.52 //x2=0.74 //y2=0
cc_852 ( N_noxref_5_c_1030_p N_noxref_9_c_1423_n ) capacitor c=0.00950704f \
 //x=0.915 //y=1.915 //x2=0.74 //y2=0
cc_853 ( N_noxref_5_c_1028_p N_noxref_9_M0_noxref_d ) capacitor c=2.20438e-19 \
 //x=1.11 //y=2.08 //x2=0.99 //y2=0.865
cc_854 ( N_noxref_5_c_1042_p N_noxref_9_M0_noxref_d ) capacitor c=0.00192399f \
 //x=0.915 //y=0.865 //x2=0.99 //y2=0.865
cc_855 ( N_noxref_5_c_1043_p N_noxref_9_M0_noxref_d ) capacitor c=0.00210798f \
 //x=0.915 //y=1.21 //x2=0.99 //y2=0.865
cc_856 ( N_noxref_5_c_1064_p N_noxref_9_M0_noxref_d ) capacitor c=0.00472259f \
 //x=1.29 //y=0.71 //x2=0.99 //y2=0.865
cc_857 ( N_noxref_5_c_1065_p N_noxref_9_M0_noxref_d ) capacitor c=0.00166857f \
 //x=1.29 //y=1.365 //x2=0.99 //y2=0.865
cc_858 ( N_noxref_5_c_1044_p N_noxref_9_M0_noxref_d ) capacitor c=0.00230174f \
 //x=1.445 //y=0.865 //x2=0.99 //y2=0.865
cc_859 ( N_noxref_5_c_1046_p N_noxref_9_M0_noxref_d ) capacitor c=0.00210798f \
 //x=1.445 //y=1.21 //x2=0.99 //y2=0.865
cc_860 ( N_noxref_5_c_1030_p N_noxref_12_c_1886_n ) capacitor c=0.00262672f \
 //x=0.915 //y=1.915 //x2=0.695 //y2=1.495
cc_861 ( N_noxref_5_c_1028_p N_noxref_12_c_1887_n ) capacitor c=0.00459552f \
 //x=1.11 //y=2.08 //x2=1.58 //y2=1.58
cc_862 ( N_noxref_5_c_1025_p N_noxref_12_c_1887_n ) capacitor c=0.00763108f \
 //x=1.11 //y=2.08 //x2=1.58 //y2=1.58
cc_863 ( N_noxref_5_c_1045_p N_noxref_12_c_1887_n ) capacitor c=0.00695869f \
 //x=0.915 //y=1.52 //x2=1.58 //y2=1.58
cc_864 ( N_noxref_5_c_1030_p N_noxref_12_c_1887_n ) capacitor c=0.0194861f \
 //x=0.915 //y=1.915 //x2=1.58 //y2=1.58
cc_865 ( N_noxref_5_c_1065_p N_noxref_12_c_1887_n ) capacitor c=0.00723574f \
 //x=1.29 //y=1.365 //x2=1.58 //y2=1.58
cc_866 ( N_noxref_5_c_1046_p N_noxref_12_c_1887_n ) capacitor c=0.00399755f \
 //x=1.445 //y=1.21 //x2=1.58 //y2=1.58
cc_867 ( N_noxref_5_c_1030_p N_noxref_12_c_1876_n ) capacitor c=6.71402e-19 \
 //x=0.915 //y=1.915 //x2=1.665 //y2=1.495
cc_868 ( N_noxref_5_c_1042_p N_noxref_12_M0_noxref_s ) capacitor c=0.0294925f \
 //x=0.915 //y=0.865 //x2=0.56 //y2=0.365
cc_869 ( N_noxref_5_c_1045_p N_noxref_12_M0_noxref_s ) capacitor c=3.48408e-19 \
 //x=0.915 //y=1.52 //x2=0.56 //y2=0.365
cc_870 ( N_noxref_5_c_1044_p N_noxref_12_M0_noxref_s ) capacitor c=0.0125442f \
 //x=1.445 //y=0.865 //x2=0.56 //y2=0.365
cc_871 ( N_noxref_6_c_1103_n N_noxref_9_c_1412_n ) capacitor c=0.00234099f \
 //x=1.85 //y=2.08 //x2=7.755 //y2=0
cc_872 ( N_noxref_6_c_1103_n N_noxref_9_c_1421_n ) capacitor c=3.77673e-19 \
 //x=1.85 //y=2.08 //x2=3.16 //y2=0
cc_873 ( N_noxref_6_c_1105_n N_noxref_9_c_1431_n ) capacitor c=0.00224736f \
 //x=1.85 //y=2.08 //x2=3.33 //y2=0
cc_874 ( N_noxref_6_c_1131_n N_noxref_9_c_1431_n ) capacitor c=0.00275184f \
 //x=2.415 //y=1.25 //x2=3.33 //y2=0
cc_875 ( N_noxref_6_c_1135_n N_noxref_9_c_1431_n ) capacitor c=2.63786e-19 \
 //x=1.85 //y=2.08 //x2=3.33 //y2=0
cc_876 ( N_noxref_6_c_1103_n N_noxref_12_c_1876_n ) capacitor c=7.471e-19 \
 //x=1.85 //y=2.08 //x2=1.665 //y2=1.495
cc_877 ( N_noxref_6_c_1119_n N_noxref_12_c_1876_n ) capacitor c=0.00888238f \
 //x=1.885 //y=1.56 //x2=1.665 //y2=1.495
cc_878 ( N_noxref_6_c_1135_n N_noxref_12_c_1876_n ) capacitor c=0.00173073f \
 //x=1.85 //y=2.08 //x2=1.665 //y2=1.495
cc_879 ( N_noxref_6_c_1103_n N_noxref_12_c_1877_n ) capacitor c=0.00141156f \
 //x=1.85 //y=2.08 //x2=2.55 //y2=0.53
cc_880 ( N_noxref_6_c_1105_n N_noxref_12_c_1877_n ) capacitor c=8.82141e-19 \
 //x=1.85 //y=2.08 //x2=2.55 //y2=0.53
cc_881 ( N_noxref_6_c_1114_n N_noxref_12_c_1877_n ) capacitor c=0.0199501f \
 //x=1.885 //y=0.905 //x2=2.55 //y2=0.53
cc_882 ( N_noxref_6_c_1129_n N_noxref_12_c_1877_n ) capacitor c=0.00825432f \
 //x=2.415 //y=0.905 //x2=2.55 //y2=0.53
cc_883 ( N_noxref_6_c_1135_n N_noxref_12_c_1877_n ) capacitor c=2.1838e-19 \
 //x=1.85 //y=2.08 //x2=2.55 //y2=0.53
cc_884 ( N_noxref_6_c_1114_n N_noxref_12_M0_noxref_s ) capacitor c=0.00888238f \
 //x=1.885 //y=0.905 //x2=0.56 //y2=0.365
cc_885 ( N_noxref_6_c_1129_n N_noxref_12_M0_noxref_s ) capacitor c=0.015333f \
 //x=2.415 //y=0.905 //x2=0.56 //y2=0.365
cc_886 ( N_noxref_6_c_1131_n N_noxref_12_M0_noxref_s ) capacitor c=0.00248746f \
 //x=2.415 //y=1.25 //x2=0.56 //y2=0.365
cc_887 ( N_noxref_7_c_1212_n N_noxref_8_c_1293_n ) capacitor c=7.31659e-19 \
 //x=5 //y=5.21 //x2=5.18 //y2=2.08
cc_888 ( N_noxref_7_c_1222_n N_noxref_8_c_1296_n ) capacitor c=0.00213985f \
 //x=5.75 //y=6.91 //x2=5.215 //y2=4.705
cc_889 ( N_noxref_7_c_1212_n N_noxref_8_c_1296_n ) capacitor c=0.00262304f \
 //x=5 //y=5.21 //x2=5.215 //y2=4.705
cc_890 ( N_noxref_7_c_1222_n N_noxref_8_c_1311_n ) capacitor c=0.00233585f \
 //x=5.75 //y=6.91 //x2=5.215 //y2=4.705
cc_891 ( N_noxref_7_c_1222_n N_noxref_8_M13_noxref_g ) capacitor c=0.00777443f \
 //x=5.75 //y=6.91 //x2=5.22 //y2=6.025
cc_892 ( N_noxref_7_c_1212_n N_noxref_8_M13_noxref_g ) capacitor c=0.00176767f \
 //x=5 //y=5.21 //x2=5.22 //y2=6.025
cc_893 ( N_noxref_7_c_1213_n N_noxref_8_M13_noxref_g ) capacitor c=0.00186228f \
 //x=5 //y=6.74 //x2=5.22 //y2=6.025
cc_894 ( N_noxref_7_c_1218_n N_noxref_8_M13_noxref_g ) capacitor c=0.0170175f \
 //x=5 //y=5.38 //x2=5.22 //y2=6.025
cc_895 ( N_noxref_7_c_1222_n N_noxref_8_M14_noxref_g ) capacitor c=0.0093887f \
 //x=5.75 //y=6.91 //x2=5.66 //y2=6.025
cc_896 ( N_noxref_7_c_1229_n N_noxref_8_M14_noxref_g ) capacitor c=0.00410728f \
 //x=5.88 //y=6.74 //x2=5.66 //y2=6.025
cc_897 ( N_noxref_7_M14_noxref_d N_noxref_8_M14_noxref_g ) capacitor \
 c=0.0365939f //x=5.735 //y=5.025 //x2=5.66 //y2=6.025
cc_898 ( N_noxref_7_c_1212_n N_noxref_8_c_1332_n ) capacitor c=6.45633e-19 \
 //x=5 //y=5.21 //x2=5.215 //y2=4.705
cc_899 ( N_noxref_8_c_1293_n N_noxref_9_c_1475_n ) capacitor c=6.61292e-19 \
 //x=5.18 //y=2.08 //x2=5.88 //y2=0.53
cc_900 ( N_noxref_8_c_1307_n N_noxref_9_c_1475_n ) capacitor c=8.64363e-19 \
 //x=5.18 //y=2.08 //x2=5.88 //y2=0.53
cc_901 ( N_noxref_8_c_1318_n N_noxref_9_c_1475_n ) capacitor c=0.0210318f \
 //x=5.215 //y=0.905 //x2=5.88 //y2=0.53
cc_902 ( N_noxref_8_c_1326_n N_noxref_9_c_1475_n ) capacitor c=0.00825432f \
 //x=5.745 //y=0.905 //x2=5.88 //y2=0.53
cc_903 ( N_noxref_8_c_1328_n N_noxref_9_c_1475_n ) capacitor c=2.1838e-19 \
 //x=5.18 //y=2.08 //x2=5.88 //y2=0.53
cc_904 ( N_noxref_8_c_1307_n N_noxref_9_c_1482_n ) capacitor c=0.00224736f \
 //x=5.18 //y=2.08 //x2=6.66 //y2=0
cc_905 ( N_noxref_8_c_1325_n N_noxref_9_c_1482_n ) capacitor c=0.0028635f \
 //x=5.59 //y=1.405 //x2=6.66 //y2=0
cc_906 ( N_noxref_8_c_1328_n N_noxref_9_c_1482_n ) capacitor c=2.63786e-19 \
 //x=5.18 //y=2.08 //x2=6.66 //y2=0
cc_907 ( N_noxref_8_c_1318_n N_noxref_9_M2_noxref_s ) capacitor c=0.00720961f \
 //x=5.215 //y=0.905 //x2=3.89 //y2=0.365
cc_908 ( N_noxref_8_c_1325_n N_noxref_9_M2_noxref_s ) capacitor c=0.00271091f \
 //x=5.59 //y=1.405 //x2=3.89 //y2=0.365
cc_909 ( N_noxref_8_c_1326_n N_noxref_9_M2_noxref_s ) capacitor c=0.0151996f \
 //x=5.745 //y=0.905 //x2=3.89 //y2=0.365
cc_910 ( N_noxref_8_c_1328_n N_noxref_9_M2_noxref_s ) capacitor c=0.00119118f \
 //x=5.18 //y=2.08 //x2=3.89 //y2=0.365
cc_911 ( N_noxref_9_c_1513_n N_noxref_10_c_1698_n ) capacitor c=0.00234099f \
 //x=11.47 //y=0 //x2=8.51 //y2=2.08
cc_912 ( N_noxref_9_c_1480_n N_noxref_10_c_1698_n ) capacitor c=3.77673e-19 \
 //x=9.82 //y=0 //x2=8.51 //y2=2.08
cc_913 ( N_noxref_9_c_1532_n N_noxref_10_c_1701_n ) capacitor c=0.00224736f \
 //x=9.99 //y=0 //x2=8.51 //y2=2.08
cc_914 ( N_noxref_9_c_1532_n N_noxref_10_c_1720_n ) capacitor c=0.00275184f \
 //x=9.99 //y=0 //x2=9.075 //y2=1.25
cc_915 ( N_noxref_9_c_1532_n N_noxref_10_c_1721_n ) capacitor c=2.63786e-19 \
 //x=9.99 //y=0 //x2=8.51 //y2=2.08
cc_916 ( N_noxref_9_c_1532_n N_noxref_11_c_1796_n ) capacitor c=0.00272952f \
 //x=9.99 //y=0 //x2=11.1 //y2=1.755
cc_917 ( N_noxref_9_c_1442_n N_noxref_11_c_1796_n ) capacitor c=0.00122336f \
 //x=11.59 //y=0 //x2=11.1 //y2=1.755
cc_918 ( N_noxref_9_M6_noxref_s N_noxref_11_c_1796_n ) capacitor c=0.0325324f \
 //x=10.485 //y=0.37 //x2=11.1 //y2=1.755
cc_919 ( N_noxref_9_c_1513_n N_noxref_11_c_1807_n ) capacitor c=0.00496359f \
 //x=11.47 //y=0 //x2=11.385 //y2=1.84
cc_920 ( N_noxref_9_c_1530_n N_noxref_11_c_1807_n ) capacitor c=0.00321677f \
 //x=11.505 //y=0.535 //x2=11.385 //y2=1.84
cc_921 ( N_noxref_9_c_1442_n N_noxref_11_c_1807_n ) capacitor c=0.0298335f \
 //x=11.59 //y=0 //x2=11.385 //y2=1.84
cc_922 ( N_noxref_9_M6_noxref_s N_noxref_11_c_1807_n ) capacitor c=0.00565313f \
 //x=10.485 //y=0.37 //x2=11.385 //y2=1.84
cc_923 ( N_noxref_9_c_1513_n N_noxref_11_c_1827_n ) capacitor c=0.00996824f \
 //x=11.47 //y=0 //x2=11.1 //y2=1.005
cc_924 ( N_noxref_9_c_1525_n N_noxref_11_c_1827_n ) capacitor c=0.00124697f \
 //x=11.015 //y=0.535 //x2=11.1 //y2=1.005
cc_925 ( N_noxref_9_c_1530_n N_noxref_11_c_1827_n ) capacitor c=0.00130436f \
 //x=11.505 //y=0.535 //x2=11.1 //y2=1.005
cc_926 ( N_noxref_9_c_1442_n N_noxref_11_c_1827_n ) capacitor c=2.8029e-19 \
 //x=11.59 //y=0 //x2=11.1 //y2=1.005
cc_927 ( N_noxref_9_M6_noxref_s N_noxref_11_c_1827_n ) capacitor c=0.0156205f \
 //x=10.485 //y=0.37 //x2=11.1 //y2=1.005
cc_928 ( N_noxref_9_c_1513_n N_noxref_11_M6_noxref_d ) capacitor c=0.00119583f \
 //x=11.47 //y=0 //x2=10.915 //y2=0.91
cc_929 ( N_noxref_9_c_1442_n N_noxref_11_M6_noxref_d ) capacitor c=2.70835e-19 \
 //x=11.59 //y=0 //x2=10.915 //y2=0.91
cc_930 ( N_noxref_9_M6_noxref_s N_noxref_11_M6_noxref_d ) capacitor \
 c=0.0377604f //x=10.485 //y=0.37 //x2=10.915 //y2=0.91
cc_931 ( N_noxref_9_c_1564_n N_noxref_12_c_1887_n ) capacitor c=0.00275882f \
 //x=1.095 //y=0 //x2=1.58 //y2=1.58
cc_932 ( N_noxref_9_c_1412_n N_noxref_12_c_1887_n ) capacitor c=7.73914e-19 \
 //x=7.755 //y=0 //x2=1.58 //y2=1.58
cc_933 ( N_noxref_9_c_1418_n N_noxref_12_c_1887_n ) capacitor c=0.00407704f \
 //x=1.18 //y=0.955 //x2=1.58 //y2=1.58
cc_934 ( N_noxref_9_c_1421_n N_noxref_12_c_1887_n ) capacitor c=0.00374872f \
 //x=3.16 //y=0 //x2=1.58 //y2=1.58
cc_935 ( N_noxref_9_M0_noxref_d N_noxref_12_c_1887_n ) capacitor c=0.00578453f \
 //x=0.99 //y=0.865 //x2=1.58 //y2=1.58
cc_936 ( N_noxref_9_c_1412_n N_noxref_12_c_1913_n ) capacitor c=0.00681952f \
 //x=7.755 //y=0 //x2=1.665 //y2=0.615
cc_937 ( N_noxref_9_c_1574_n N_noxref_12_c_1913_n ) capacitor c=0.0167642f \
 //x=1.177 //y=0.825 //x2=1.665 //y2=0.615
cc_938 ( N_noxref_9_c_1421_n N_noxref_12_c_1913_n ) capacitor c=0.0146219f \
 //x=3.16 //y=0 //x2=1.665 //y2=0.615
cc_939 ( N_noxref_9_c_1423_n N_noxref_12_c_1913_n ) capacitor c=0.00283128f \
 //x=0.74 //y=0 //x2=1.665 //y2=0.615
cc_940 ( N_noxref_9_c_1431_n N_noxref_12_c_1913_n ) capacitor c=2.21767e-19 \
 //x=3.33 //y=0 //x2=1.665 //y2=0.615
cc_941 ( N_noxref_9_c_1442_n N_noxref_12_c_1913_n ) capacitor c=0.00145873f \
 //x=11.59 //y=0 //x2=1.665 //y2=0.615
cc_942 ( N_noxref_9_c_1423_n N_noxref_12_c_1876_n ) capacitor c=2.85935e-19 \
 //x=0.74 //y=0 //x2=1.665 //y2=1.495
cc_943 ( N_noxref_9_c_1412_n N_noxref_12_c_1877_n ) capacitor c=0.0100359f \
 //x=7.755 //y=0 //x2=2.55 //y2=0.53
cc_944 ( N_noxref_9_c_1421_n N_noxref_12_c_1877_n ) capacitor c=0.0374415f \
 //x=3.16 //y=0 //x2=2.55 //y2=0.53
cc_945 ( N_noxref_9_c_1442_n N_noxref_12_c_1877_n ) capacitor c=0.00199095f \
 //x=11.59 //y=0 //x2=2.55 //y2=0.53
cc_946 ( N_noxref_9_c_1412_n N_noxref_12_c_1923_n ) capacitor c=0.002449f \
 //x=7.755 //y=0 //x2=2.635 //y2=0.615
cc_947 ( N_noxref_9_c_1421_n N_noxref_12_c_1923_n ) capacitor c=0.0145157f \
 //x=3.16 //y=0 //x2=2.635 //y2=0.615
cc_948 ( N_noxref_9_c_1644_p N_noxref_12_c_1923_n ) capacitor c=0.0019997f \
 //x=4.025 //y=0.445 //x2=2.635 //y2=0.615
cc_949 ( N_noxref_9_c_1431_n N_noxref_12_c_1923_n ) capacitor c=0.0401922f \
 //x=3.33 //y=0 //x2=2.635 //y2=0.615
cc_950 ( N_noxref_9_c_1442_n N_noxref_12_c_1923_n ) capacitor c=0.00145015f \
 //x=11.59 //y=0 //x2=2.635 //y2=0.615
cc_951 ( N_noxref_9_c_1564_n N_noxref_12_M0_noxref_s ) capacitor c=0.00723598f \
 //x=1.095 //y=0 //x2=0.56 //y2=0.365
cc_952 ( N_noxref_9_c_1418_n N_noxref_12_M0_noxref_s ) capacitor c=0.0113988f \
 //x=1.18 //y=0.955 //x2=0.56 //y2=0.365
cc_953 ( N_noxref_9_c_1574_n N_noxref_12_M0_noxref_s ) capacitor c=0.0173062f \
 //x=1.177 //y=0.825 //x2=0.56 //y2=0.365
cc_954 ( N_noxref_9_c_1421_n N_noxref_12_M0_noxref_s ) capacitor c=0.0146208f \
 //x=3.16 //y=0 //x2=0.56 //y2=0.365
cc_955 ( N_noxref_9_c_1423_n N_noxref_12_M0_noxref_s ) capacitor c=0.0559891f \
 //x=0.74 //y=0 //x2=0.56 //y2=0.365
cc_956 ( N_noxref_9_c_1431_n N_noxref_12_M0_noxref_s ) capacitor c=0.00642623f \
 //x=3.33 //y=0 //x2=0.56 //y2=0.365
cc_957 ( N_noxref_9_c_1442_n N_noxref_12_M0_noxref_s ) capacitor c=0.00145873f \
 //x=11.59 //y=0 //x2=0.56 //y2=0.365
cc_958 ( N_noxref_9_M0_noxref_d N_noxref_12_M0_noxref_s ) capacitor \
 c=0.0271276f //x=0.99 //y=0.865 //x2=0.56 //y2=0.365
cc_959 ( N_noxref_9_M2_noxref_s N_noxref_12_M0_noxref_s ) capacitor \
 c=0.00298769f //x=3.89 //y=0.365 //x2=0.56 //y2=0.365
cc_960 ( N_noxref_9_c_1412_n N_noxref_13_c_1939_n ) capacitor c=9.58128e-19 \
 //x=7.755 //y=0 //x2=8.24 //y2=1.58
cc_961 ( N_noxref_9_c_1513_n N_noxref_13_c_1939_n ) capacitor c=0.00203715f \
 //x=11.47 //y=0 //x2=8.24 //y2=1.58
cc_962 ( N_noxref_9_c_1458_n N_noxref_13_c_1939_n ) capacitor c=0.00398366f \
 //x=7.84 //y=0.955 //x2=8.24 //y2=1.58
cc_963 ( N_noxref_9_c_1480_n N_noxref_13_c_1939_n ) capacitor c=0.00386563f \
 //x=9.82 //y=0 //x2=8.24 //y2=1.58
cc_964 ( N_noxref_9_M4_noxref_d N_noxref_13_c_1939_n ) capacitor c=0.00578453f \
 //x=7.65 //y=0.865 //x2=8.24 //y2=1.58
cc_965 ( N_noxref_9_c_1513_n N_noxref_13_c_1966_n ) capacitor c=0.00681952f \
 //x=11.47 //y=0 //x2=8.325 //y2=0.615
cc_966 ( N_noxref_9_c_1469_n N_noxref_13_c_1966_n ) capacitor c=0.0167642f \
 //x=7.837 //y=0.825 //x2=8.325 //y2=0.615
cc_967 ( N_noxref_9_c_1480_n N_noxref_13_c_1966_n ) capacitor c=0.0146219f \
 //x=9.82 //y=0 //x2=8.325 //y2=0.615
cc_968 ( N_noxref_9_c_1482_n N_noxref_13_c_1966_n ) capacitor c=0.00282552f \
 //x=6.66 //y=0 //x2=8.325 //y2=0.615
cc_969 ( N_noxref_9_c_1532_n N_noxref_13_c_1966_n ) capacitor c=2.21767e-19 \
 //x=9.99 //y=0 //x2=8.325 //y2=0.615
cc_970 ( N_noxref_9_c_1442_n N_noxref_13_c_1966_n ) capacitor c=0.00145873f \
 //x=11.59 //y=0 //x2=8.325 //y2=0.615
cc_971 ( N_noxref_9_c_1482_n N_noxref_13_c_1947_n ) capacitor c=2.8386e-19 \
 //x=6.66 //y=0 //x2=8.325 //y2=1.495
cc_972 ( N_noxref_9_c_1513_n N_noxref_13_c_1952_n ) capacitor c=0.0100359f \
 //x=11.47 //y=0 //x2=9.21 //y2=0.53
cc_973 ( N_noxref_9_c_1480_n N_noxref_13_c_1952_n ) capacitor c=0.0374415f \
 //x=9.82 //y=0 //x2=9.21 //y2=0.53
cc_974 ( N_noxref_9_c_1442_n N_noxref_13_c_1952_n ) capacitor c=0.00199095f \
 //x=11.59 //y=0 //x2=9.21 //y2=0.53
cc_975 ( N_noxref_9_c_1513_n N_noxref_13_c_1976_n ) capacitor c=0.002449f \
 //x=11.47 //y=0 //x2=9.295 //y2=0.615
cc_976 ( N_noxref_9_c_1480_n N_noxref_13_c_1976_n ) capacitor c=0.0145157f \
 //x=9.82 //y=0 //x2=9.295 //y2=0.615
cc_977 ( N_noxref_9_c_1673_p N_noxref_13_c_1976_n ) capacitor c=0.00209572f \
 //x=10.62 //y=0.45 //x2=9.295 //y2=0.615
cc_978 ( N_noxref_9_c_1532_n N_noxref_13_c_1976_n ) capacitor c=0.0402083f \
 //x=9.99 //y=0 //x2=9.295 //y2=0.615
cc_979 ( N_noxref_9_c_1442_n N_noxref_13_c_1976_n ) capacitor c=0.00145015f \
 //x=11.59 //y=0 //x2=9.295 //y2=0.615
cc_980 ( N_noxref_9_c_1412_n N_noxref_13_M4_noxref_s ) capacitor c=0.00723598f \
 //x=7.755 //y=0 //x2=7.22 //y2=0.365
cc_981 ( N_noxref_9_c_1458_n N_noxref_13_M4_noxref_s ) capacitor c=0.00997186f \
 //x=7.84 //y=0.955 //x2=7.22 //y2=0.365
cc_982 ( N_noxref_9_c_1469_n N_noxref_13_M4_noxref_s ) capacitor c=0.0173062f \
 //x=7.837 //y=0.825 //x2=7.22 //y2=0.365
cc_983 ( N_noxref_9_c_1679_p N_noxref_13_M4_noxref_s ) capacitor c=0.00396688f \
 //x=5.965 //y=0.445 //x2=7.22 //y2=0.365
cc_984 ( N_noxref_9_c_1480_n N_noxref_13_M4_noxref_s ) capacitor c=0.0146208f \
 //x=9.82 //y=0 //x2=7.22 //y2=0.365
cc_985 ( N_noxref_9_c_1482_n N_noxref_13_M4_noxref_s ) capacitor c=0.052705f \
 //x=6.66 //y=0 //x2=7.22 //y2=0.365
cc_986 ( N_noxref_9_c_1532_n N_noxref_13_M4_noxref_s ) capacitor c=0.00642652f \
 //x=9.99 //y=0 //x2=7.22 //y2=0.365
cc_987 ( N_noxref_9_c_1442_n N_noxref_13_M4_noxref_s ) capacitor c=0.00145873f \
 //x=11.59 //y=0 //x2=7.22 //y2=0.365
cc_988 ( N_noxref_9_M2_noxref_s N_noxref_13_M4_noxref_s ) capacitor \
 c=9.07604e-19 //x=3.89 //y=0.365 //x2=7.22 //y2=0.365
cc_989 ( N_noxref_9_M4_noxref_d N_noxref_13_M4_noxref_s ) capacitor \
 c=0.0271276f //x=7.65 //y=0.865 //x2=7.22 //y2=0.365
cc_990 ( N_noxref_9_M6_noxref_s N_noxref_13_M4_noxref_s ) capacitor \
 c=0.0031675f //x=10.485 //y=0.37 //x2=7.22 //y2=0.365
cc_991 ( N_noxref_10_c_1698_n N_noxref_13_c_1947_n ) capacitor c=7.471e-19 \
 //x=8.51 //y=2.08 //x2=8.325 //y2=1.495
cc_992 ( N_noxref_10_c_1716_n N_noxref_13_c_1947_n ) capacitor c=0.00888238f \
 //x=8.545 //y=1.56 //x2=8.325 //y2=1.495
cc_993 ( N_noxref_10_c_1721_n N_noxref_13_c_1947_n ) capacitor c=0.00173073f \
 //x=8.51 //y=2.08 //x2=8.325 //y2=1.495
cc_994 ( N_noxref_10_c_1698_n N_noxref_13_c_1952_n ) capacitor c=0.00141156f \
 //x=8.51 //y=2.08 //x2=9.21 //y2=0.53
cc_995 ( N_noxref_10_c_1701_n N_noxref_13_c_1952_n ) capacitor c=8.82141e-19 \
 //x=8.51 //y=2.08 //x2=9.21 //y2=0.53
cc_996 ( N_noxref_10_c_1711_n N_noxref_13_c_1952_n ) capacitor c=0.0199501f \
 //x=8.545 //y=0.905 //x2=9.21 //y2=0.53
cc_997 ( N_noxref_10_c_1719_n N_noxref_13_c_1952_n ) capacitor c=0.00825432f \
 //x=9.075 //y=0.905 //x2=9.21 //y2=0.53
cc_998 ( N_noxref_10_c_1721_n N_noxref_13_c_1952_n ) capacitor c=2.1838e-19 \
 //x=8.51 //y=2.08 //x2=9.21 //y2=0.53
cc_999 ( N_noxref_10_c_1711_n N_noxref_13_M4_noxref_s ) capacitor \
 c=0.00888238f //x=8.545 //y=0.905 //x2=7.22 //y2=0.365
cc_1000 ( N_noxref_10_c_1719_n N_noxref_13_M4_noxref_s ) capacitor c=0.015333f \
 //x=9.075 //y=0.905 //x2=7.22 //y2=0.365
cc_1001 ( N_noxref_10_c_1720_n N_noxref_13_M4_noxref_s ) capacitor \
 c=0.00248746f //x=9.075 //y=1.25 //x2=7.22 //y2=0.365
