// File: TMRDFFQX1.spi.pex
// Created: Fri Feb 20 10:15:26 2026
// Program "Calibre xRC"
// Version "v2023.2_27.15"
// Nominal Temperature: 30C
// Circuit Temperature: 30C
//
simulator lang=spectre
subckt PM_TMRDFFQX1\%noxref_1 ( 1 2 3 4 7 12 13 15 16 18 19 20 22 23 30 34 35 \
 38 40 43 48 50 53 54 56 57 58 60 62 65 72 73 76 85 90 98 115 124 128 129 130 \
 131 132 133 137 138 139 144 146 149 150 151 152 153 154 158 160 163 164 169 \
 170 175 184 187 189 190 )
c431 ( 187 0 ) capacitor c=0.00878249f //x=7.26 //y=1.085
c432 ( 184 0 ) capacitor c=0.0682508f //x=9.74 //y=4.88
c433 ( 175 0 ) capacitor c=0.0710066f //x=3.82 //y=4.88
c434 ( 170 0 ) capacitor c=0.0278202f //x=3.82 //y=2.095
c435 ( 169 0 ) capacitor c=0.0479324f //x=3.82 //y=2.26
c436 ( 164 0 ) capacitor c=0.0318956f //x=10.075 //y=1.39
c437 ( 163 0 ) capacitor c=0.0186809f //x=10.075 //y=1.045
c438 ( 160 0 ) capacitor c=0.0141821f //x=9.92 //y=1.545
c439 ( 158 0 ) capacitor c=0.0158553f //x=9.92 //y=0.89
c440 ( 154 0 ) capacitor c=0.0854171f //x=9.545 //y=2.095
c441 ( 153 0 ) capacitor c=0.0229235f //x=9.545 //y=1.7
c442 ( 152 0 ) capacitor c=0.0234359f //x=9.545 //y=1.39
c443 ( 151 0 ) capacitor c=0.0198759f //x=9.545 //y=1.045
c444 ( 150 0 ) capacitor c=0.0443175f //x=4.34 //y=1.44
c445 ( 149 0 ) capacitor c=0.0199703f //x=4.34 //y=1.095
c446 ( 146 0 ) capacitor c=0.0162526f //x=4.185 //y=1.595
c447 ( 144 0 ) capacitor c=0.0157807f //x=4.185 //y=0.94
c448 ( 139 0 ) capacitor c=0.0220935f //x=3.81 //y=1.75
c449 ( 138 0 ) capacitor c=0.0207489f //x=3.81 //y=1.44
c450 ( 137 0 ) capacitor c=0.0194091f //x=3.81 //y=1.095
c451 ( 133 0 ) capacitor c=0.110369f //x=10.08 //y=6.2
c452 ( 132 0 ) capacitor c=0.154619f //x=9.64 //y=6.2
c453 ( 131 0 ) capacitor c=0.159671f //x=4 //y=6.2
c454 ( 130 0 ) capacitor c=0.110208f //x=3.56 //y=6.2
c455 ( 124 0 ) capacitor c=8.13425e-19 //x=9.74 //y=4.88
c456 ( 115 0 ) capacitor c=7.85889e-19 //x=9.74 //y=2.26
c457 ( 98 0 ) capacitor c=0.0322017f //x=7.41 //y=5.56
c458 ( 90 0 ) capacitor c=0.0290186f //x=6.53 //y=5.56
c459 ( 85 0 ) capacitor c=8.10944e-19 //x=3.82 //y=4.88
c460 ( 76 0 ) capacitor c=0.00101179f //x=3.82 //y=2.26
c461 ( 73 0 ) capacitor c=0.0244175f //x=9.575 //y=3.505
c462 ( 72 0 ) capacitor c=5.48521e-19 //x=9.735 //y=3.505
c463 ( 65 0 ) capacitor c=0.0150474f //x=8.045 //y=3.51
c464 ( 62 0 ) capacitor c=0.00684519f //x=6.62 //y=3.495
c465 ( 60 0 ) capacitor c=0.0382613f //x=6.02 //y=3.51
c466 ( 58 0 ) capacitor c=0.018822f //x=4.775 //y=3.495
c467 ( 57 0 ) capacitor c=0.00325528f //x=3.985 //y=3.51
c468 ( 56 0 ) capacitor c=0.00673568f //x=4.175 //y=3.51
c469 ( 54 0 ) capacitor c=0.0267491f //x=9.742 //y=4.74
c470 ( 53 0 ) capacitor c=0.00611287f //x=9.74 //y=4.88
c471 ( 50 0 ) capacitor c=0.0064096f //x=9.74 //y=2.26
c472 ( 48 0 ) capacitor c=0.0163473f //x=9.74 //y=3.51
c473 ( 43 0 ) capacitor c=0.0170489f //x=7.885 //y=3.51
c474 ( 40 0 ) capacitor c=0.0111664f //x=7.45 //y=1.18
c475 ( 38 0 ) capacitor c=5.78613e-19 //x=7.41 //y=5.56
c476 ( 35 0 ) capacitor c=0.011586f //x=7.41 //y=5.38
c477 ( 34 0 ) capacitor c=0.00923791f //x=6.53 //y=5.56
c478 ( 30 0 ) capacitor c=0.0148558f //x=3.82 //y=3.51
c479 ( 23 0 ) capacitor c=0.0131975f //x=9.74 //y=3.665
c480 ( 22 0 ) capacitor c=0.028193f //x=9.74 //y=3.345
c481 ( 20 0 ) capacitor c=0.0405845f //x=7.89 //y=5.295
c482 ( 19 0 ) capacitor c=0.0134427f //x=7.89 //y=3.67
c483 ( 18 0 ) capacitor c=0.0380334f //x=7.89 //y=3.35
c484 ( 16 0 ) capacitor c=0.00504728f //x=7.535 //y=1.835
c485 ( 15 0 ) capacitor c=0.0126369f //x=7.805 //y=1.835
c486 ( 13 0 ) capacitor c=0.0108105f //x=7.805 //y=5.38
c487 ( 12 0 ) capacitor c=0.0102514f //x=7.45 //y=1.75
c488 ( 7 0 ) capacitor c=0.0147072f //x=7.295 //y=5.38
c489 ( 4 0 ) capacitor c=0.0286377f //x=3.82 //y=4.75
c490 ( 3 0 ) capacitor c=0.0126137f //x=3.82 //y=3.67
c491 ( 2 0 ) capacitor c=0.0274183f //x=3.82 //y=3.35
c492 ( 1 0 ) capacitor c=0.00685053f //x=3.82 //y=2.375
r493 (  182 184 ) resistor r=20.6867 //w=0.233 //l=0.1 //layer=ply \
 //thickness=0.18 //x=9.64 //y=4.88 //x2=9.74 //y2=4.88
r494 (  169 170 ) resistor r=52.7279 //w=0.214 //l=0.165 //layer=ply \
 //thickness=0.18 //x=3.82 //y=2.26 //x2=3.82 //y2=2.095
r495 (  165 184 ) resistor r=70.3348 //w=0.233 //l=0.414367 //layer=ply \
 //thickness=0.18 //x=10.08 //y=5.045 //x2=9.74 //y2=4.88
r496 (  164 186 ) resistor r=45.1352 //w=0.168 //l=0.173853 //layer=ply \
 //thickness=0.18 //x=10.075 //y=1.39 //x2=10.035 //y2=1.545
r497 (  163 185 ) resistor r=45.1352 //w=0.168 //l=0.173853 //layer=ply \
 //thickness=0.18 //x=10.075 //y=1.045 //x2=10.035 //y2=0.89
r498 (  163 164 ) resistor r=176.904 //w=0.094 //l=0.345 //layer=ply \
 //thickness=0.18 //x=10.075 //y=1.045 //x2=10.075 //y2=1.39
r499 (  161 181 ) resistor r=10.701 //w=0.21 //l=0.115 //layer=ply \
 //thickness=0.18 //x=9.7 //y=1.545 //x2=9.585 //y2=1.545
r500 (  160 186 ) resistor r=5.52526 //w=0.168 //l=0.115 //layer=ply \
 //thickness=0.18 //x=9.92 //y=1.545 //x2=10.035 //y2=1.545
r501 (  159 180 ) resistor r=5.52526 //w=0.168 //l=0.115 //layer=ply \
 //thickness=0.18 //x=9.7 //y=0.89 //x2=9.585 //y2=0.89
r502 (  158 185 ) resistor r=5.52526 //w=0.168 //l=0.115 //layer=ply \
 //thickness=0.18 //x=9.92 //y=0.89 //x2=10.035 //y2=0.89
r503 (  158 159 ) resistor r=112.809 //w=0.094 //l=0.22 //layer=ply \
 //thickness=0.18 //x=9.92 //y=0.89 //x2=9.7 //y2=0.89
r504 (  155 182 ) resistor r=13.0941 //w=0.233 //l=0.165 //layer=ply \
 //thickness=0.18 //x=9.64 //y=5.045 //x2=9.64 //y2=4.88
r505 (  154 179 ) resistor r=34.8111 //w=0.27 //l=0.264953 //layer=ply \
 //thickness=0.18 //x=9.545 //y=2.095 //x2=9.74 //y2=2.26
r506 (  153 181 ) resistor r=39.5823 //w=0.21 //l=0.173853 //layer=ply \
 //thickness=0.18 //x=9.545 //y=1.7 //x2=9.585 //y2=1.545
r507 (  153 154 ) resistor r=202.543 //w=0.094 //l=0.395 //layer=ply \
 //thickness=0.18 //x=9.545 //y=1.7 //x2=9.545 //y2=2.095
r508 (  152 181 ) resistor r=39.5823 //w=0.21 //l=0.173853 //layer=ply \
 //thickness=0.18 //x=9.545 //y=1.39 //x2=9.585 //y2=1.545
r509 (  151 180 ) resistor r=45.1352 //w=0.168 //l=0.173853 //layer=ply \
 //thickness=0.18 //x=9.545 //y=1.045 //x2=9.585 //y2=0.89
r510 (  151 152 ) resistor r=176.904 //w=0.094 //l=0.345 //layer=ply \
 //thickness=0.18 //x=9.545 //y=1.045 //x2=9.545 //y2=1.39
r511 (  150 177 ) resistor r=45.1352 //w=0.168 //l=0.173853 //layer=ply \
 //thickness=0.18 //x=4.34 //y=1.44 //x2=4.3 //y2=1.595
r512 (  149 176 ) resistor r=45.1352 //w=0.168 //l=0.173853 //layer=ply \
 //thickness=0.18 //x=4.34 //y=1.095 //x2=4.3 //y2=0.94
r513 (  149 150 ) resistor r=176.904 //w=0.094 //l=0.345 //layer=ply \
 //thickness=0.18 //x=4.34 //y=1.095 //x2=4.34 //y2=1.44
r514 (  147 173 ) resistor r=10.701 //w=0.21 //l=0.115 //layer=ply \
 //thickness=0.18 //x=3.965 //y=1.595 //x2=3.85 //y2=1.595
r515 (  146 177 ) resistor r=5.52526 //w=0.168 //l=0.115 //layer=ply \
 //thickness=0.18 //x=4.185 //y=1.595 //x2=4.3 //y2=1.595
r516 (  145 172 ) resistor r=5.52526 //w=0.168 //l=0.115 //layer=ply \
 //thickness=0.18 //x=3.965 //y=0.94 //x2=3.85 //y2=0.94
r517 (  144 176 ) resistor r=5.52526 //w=0.168 //l=0.115 //layer=ply \
 //thickness=0.18 //x=4.185 //y=0.94 //x2=4.3 //y2=0.94
r518 (  144 145 ) resistor r=112.809 //w=0.094 //l=0.22 //layer=ply \
 //thickness=0.18 //x=4.185 //y=0.94 //x2=3.965 //y2=0.94
r519 (  141 175 ) resistor r=37.236 //w=0.233 //l=0.249199 //layer=ply \
 //thickness=0.18 //x=4 //y=5.045 //x2=3.82 //y2=4.88
r520 (  139 173 ) resistor r=39.5823 //w=0.21 //l=0.173853 //layer=ply \
 //thickness=0.18 //x=3.81 //y=1.75 //x2=3.85 //y2=1.595
r521 (  139 170 ) resistor r=176.904 //w=0.094 //l=0.345 //layer=ply \
 //thickness=0.18 //x=3.81 //y=1.75 //x2=3.81 //y2=2.095
r522 (  138 173 ) resistor r=39.5823 //w=0.21 //l=0.173853 //layer=ply \
 //thickness=0.18 //x=3.81 //y=1.44 //x2=3.85 //y2=1.595
r523 (  137 172 ) resistor r=45.1352 //w=0.168 //l=0.173853 //layer=ply \
 //thickness=0.18 //x=3.81 //y=1.095 //x2=3.85 //y2=0.94
r524 (  137 138 ) resistor r=176.904 //w=0.094 //l=0.345 //layer=ply \
 //thickness=0.18 //x=3.81 //y=1.095 //x2=3.81 //y2=1.44
r525 (  134 175 ) resistor r=53.7854 //w=0.233 //l=0.332415 //layer=ply \
 //thickness=0.18 //x=3.56 //y=5.045 //x2=3.82 //y2=4.88
r526 (  133 165 ) resistor r=592.245 //w=0.094 //l=1.155 //layer=ply \
 //thickness=0.18 //x=10.08 //y=6.2 //x2=10.08 //y2=5.045
r527 (  132 155 ) resistor r=592.245 //w=0.094 //l=1.155 //layer=ply \
 //thickness=0.18 //x=9.64 //y=6.2 //x2=9.64 //y2=5.045
r528 (  131 141 ) resistor r=592.245 //w=0.094 //l=1.155 //layer=ply \
 //thickness=0.18 //x=4 //y=6.2 //x2=4 //y2=5.045
r529 (  130 134 ) resistor r=592.245 //w=0.094 //l=1.155 //layer=ply \
 //thickness=0.18 //x=3.56 //y=6.2 //x2=3.56 //y2=5.045
r530 (  129 160 ) resistor r=56.4043 //w=0.094 //l=0.11 //layer=ply \
 //thickness=0.18 //x=9.81 //y=1.545 //x2=9.92 //y2=1.545
r531 (  129 161 ) resistor r=56.4043 //w=0.094 //l=0.11 //layer=ply \
 //thickness=0.18 //x=9.81 //y=1.545 //x2=9.7 //y2=1.545
r532 (  128 146 ) resistor r=56.4043 //w=0.094 //l=0.11 //layer=ply \
 //thickness=0.18 //x=4.075 //y=1.595 //x2=4.185 //y2=1.595
r533 (  128 147 ) resistor r=56.4043 //w=0.094 //l=0.11 //layer=ply \
 //thickness=0.18 //x=4.075 //y=1.595 //x2=3.965 //y2=1.595
r534 (  124 184 ) resistor r=152 //w=0.17 //l=0.17 //layer=licon //count=1 \
 //x=9.74 //y=4.88 //x2=9.74 //y2=4.88
r535 (  115 179 ) resistor r=152 //w=0.17 //l=0.17 //layer=licon //count=1 \
 //x=9.74 //y=2.26 //x2=9.74 //y2=2.26
r536 (  98 190 ) resistor r=23.615 //w=0.187 //l=0.345 //layer=li \
 //thickness=0.1 //x=7.41 //y=5.56 //x2=7.41 //y2=5.905
r537 (  90 189 ) resistor r=23.615 //w=0.187 //l=0.345 //layer=li \
 //thickness=0.1 //x=6.53 //y=5.56 //x2=6.53 //y2=5.905
r538 (  85 175 ) resistor r=152 //w=0.17 //l=0.17 //layer=licon //count=1 \
 //x=3.82 //y=4.88 //x2=3.82 //y2=4.88
r539 (  76 169 ) resistor r=152 //w=0.17 //l=0.17 //layer=licon //count=1 \
 //x=3.82 //y=2.26 //x2=3.82 //y2=2.26
r540 (  72 73 ) resistor r=0.10734 //w=0.281 //l=0.16 //layer=m2 \
 //thickness=0.36 //x=9.735 //y=3.505 //x2=9.575 //y2=3.505
r541 (  65 70 ) resistor r=0.10188 //w=0.204 //l=0.16 //layer=m2 \
 //thickness=0.36 //x=8.045 //y=3.51 //x2=7.885 //y2=3.51
r542 (  65 73 ) resistor r=1.45992 //w=0.131 //l=1.53 //layer=m2 \
 //thickness=0.36 //x=8.045 //y=3.51 //x2=9.575 //y2=3.51
r543 (  62 70 ) resistor r=0.778963 //w=0.204 //l=1.27248 //layer=m2 \
 //thickness=0.36 //x=6.62 //y=3.495 //x2=7.885 //y2=3.51
r544 (  62 63 ) resistor r=0.410305 //w=0.131 //l=0.43 //layer=m2 \
 //thickness=0.36 //x=6.62 //y=3.495 //x2=6.19 //y2=3.495
r545 (  60 63 ) resistor r=0.125 //w=0.17 //l=0.177341 //layer=m2 \
 //thickness=0.36 //x=6.02 //y=3.51 //x2=6.19 //y2=3.495
r546 (  60 61 ) resistor r=0.944656 //w=0.131 //l=0.99 //layer=m2 \
 //thickness=0.36 //x=6.02 //y=3.51 //x2=5.03 //y2=3.51
r547 (  58 61 ) resistor r=0.1875 //w=0.17 //l=0.262393 //layer=m2 \
 //thickness=0.36 //x=4.775 //y=3.495 //x2=5.03 //y2=3.51
r548 (  58 59 ) resistor r=0.410305 //w=0.131 //l=0.43 //layer=m2 \
 //thickness=0.36 //x=4.775 //y=3.495 //x2=4.345 //y2=3.495
r549 (  57 67 ) resistor r=0.10734 //w=0.281 //l=0.16 //layer=m2 \
 //thickness=0.36 //x=3.985 //y=3.51 //x2=3.825 //y2=3.51
r550 (  56 59 ) resistor r=0.125 //w=0.17 //l=0.177341 //layer=m2 \
 //thickness=0.36 //x=4.175 //y=3.51 //x2=4.345 //y2=3.495
r551 (  56 57 ) resistor r=0.181298 //w=0.131 //l=0.19 //layer=m2 \
 //thickness=0.36 //x=4.175 //y=3.51 //x2=3.985 //y2=3.51
r552 (  53 124 ) resistor r=9.3 //w=0.17 //l=0.17 //layer=mcon //count=1 \
 //x=9.74 //y=4.88 //x2=9.74 //y2=4.88
r553 (  53 54 ) resistor r=0.103207 //w=0.196 //l=0.14 //layer=m1 \
 //thickness=0.36 //x=9.742 //y=4.88 //x2=9.742 //y2=4.74
r554 (  50 115 ) resistor r=9.3 //w=0.17 //l=0.17 //layer=mcon //count=1 \
 //x=9.74 //y=2.26 //x2=9.74 //y2=2.26
r555 (  46 72 ) resistor r=4.5 //w=0.15 //l=0.15 //layer=via1 //count=1 \
 //x=9.735 //y=3.505 //x2=9.735 //y2=3.505
r556 (  46 48 ) resistor r=0.00167112 //w=0.374 //l=0.005 //layer=m1 \
 //thickness=0.36 //x=9.685 //y=3.505 //x2=9.685 //y2=3.51
r557 (  43 70 ) resistor r=4.5 //w=0.15 //l=0.15 //layer=via1 //count=1 \
 //x=7.885 //y=3.51 //x2=7.885 //y2=3.51
r558 (  40 187 ) resistor r=9.3 //w=0.17 //l=0.17 //layer=mcon //count=1 \
 //x=7.45 //y=1.18 //x2=7.45 //y2=1.18
r559 (  38 98 ) resistor r=9.3 //w=0.17 //l=0.17 //layer=mcon //count=1 \
 //x=7.41 //y=5.56 //x2=7.41 //y2=5.56
r560 (  35 38 ) resistor r=0.117801 //w=0.191 //l=0.18 //layer=m1 \
 //thickness=0.36 //x=7.41 //y=5.38 //x2=7.41 //y2=5.56
r561 (  34 90 ) resistor r=9.3 //w=0.17 //l=0.17 //layer=mcon //count=1 \
 //x=6.53 //y=5.56 //x2=6.53 //y2=5.56
r562 (  32 34 ) resistor r=0.10274 //w=0.219 //l=0.18 //layer=m1 \
 //thickness=0.36 //x=6.53 //y=5.38 //x2=6.53 //y2=5.56
r563 (  30 67 ) resistor r=4.5 //w=0.15 //l=0.15 //layer=via1 //count=1 \
 //x=3.825 //y=3.51 //x2=3.825 //y2=3.51
r564 (  28 85 ) resistor r=9.3 //w=0.17 //l=0.17 //layer=mcon //count=1 \
 //x=3.82 //y=4.88 //x2=3.82 //y2=4.88
r565 (  26 76 ) resistor r=9.3 //w=0.17 //l=0.17 //layer=mcon //count=1 \
 //x=3.82 //y=2.26 //x2=3.82 //y2=2.26
r566 (  23 48 ) resistor r=0.089409 //w=0.374 //l=0.180416 //layer=m1 \
 //thickness=0.36 //x=9.74 //y=3.665 //x2=9.685 //y2=3.51
r567 (  23 54 ) resistor r=1.02576 //w=0.131 //l=1.075 //layer=m1 \
 //thickness=0.36 //x=9.74 //y=3.665 //x2=9.74 //y2=4.74
r568 (  22 46 ) resistor r=0.0910802 //w=0.374 //l=0.185472 //layer=m1 \
 //thickness=0.36 //x=9.74 //y=3.345 //x2=9.685 //y2=3.505
r569 (  21 50 ) resistor r=0.0933015 //w=0.201 //l=0.125 //layer=m1 \
 //thickness=0.36 //x=9.74 //y=2.385 //x2=9.74 //y2=2.26
r570 (  21 22 ) resistor r=0.916031 //w=0.131 //l=0.96 //layer=m1 \
 //thickness=0.36 //x=9.74 //y=2.385 //x2=9.74 //y2=3.345
r571 (  19 43 ) resistor r=0.0910802 //w=0.374 //l=0.185472 //layer=m1 \
 //thickness=0.36 //x=7.89 //y=3.67 //x2=7.835 //y2=3.51
r572 (  19 20 ) resistor r=1.55057 //w=0.131 //l=1.625 //layer=m1 \
 //thickness=0.36 //x=7.89 //y=3.67 //x2=7.89 //y2=5.295
r573 (  18 43 ) resistor r=0.0910802 //w=0.374 //l=0.185472 //layer=m1 \
 //thickness=0.36 //x=7.89 //y=3.35 //x2=7.835 //y2=3.51
r574 (  17 18 ) resistor r=1.3645 //w=0.131 //l=1.43 //layer=m1 \
 //thickness=0.36 //x=7.89 //y=1.92 //x2=7.89 //y2=3.35
r575 (  15 17 ) resistor r=0.0698411 //w=0.17 //l=0.120208 //layer=m1 \
 //thickness=0.36 //x=7.805 //y=1.835 //x2=7.89 //y2=1.92
r576 (  15 16 ) resistor r=0.257634 //w=0.131 //l=0.27 //layer=m1 \
 //thickness=0.36 //x=7.805 //y=1.835 //x2=7.535 //y2=1.835
r577 (  14 35 ) resistor r=0.0257089 //w=0.23 //l=0.115 //layer=m1 \
 //thickness=0.36 //x=7.525 //y=5.38 //x2=7.41 //y2=5.38
r578 (  13 20 ) resistor r=0.0698411 //w=0.17 //l=0.120208 //layer=m1 \
 //thickness=0.36 //x=7.805 //y=5.38 //x2=7.89 //y2=5.295
r579 (  13 14 ) resistor r=0.267176 //w=0.131 //l=0.28 //layer=m1 \
 //thickness=0.36 //x=7.805 //y=5.38 //x2=7.525 //y2=5.38
r580 (  12 16 ) resistor r=0.0698411 //w=0.17 //l=0.120208 //layer=m1 \
 //thickness=0.36 //x=7.45 //y=1.75 //x2=7.535 //y2=1.835
r581 (  11 40 ) resistor r=0.0913624 //w=0.191 //l=0.12 //layer=m1 \
 //thickness=0.36 //x=7.45 //y=1.3 //x2=7.45 //y2=1.18
r582 (  11 12 ) resistor r=0.429389 //w=0.131 //l=0.45 //layer=m1 \
 //thickness=0.36 //x=7.45 //y=1.3 //x2=7.45 //y2=1.75
r583 (  8 32 ) resistor r=0.0227762 //w=0.219 //l=0.115 //layer=m1 \
 //thickness=0.36 //x=6.645 //y=5.38 //x2=6.53 //y2=5.38
r584 (  7 35 ) resistor r=0.0257089 //w=0.23 //l=0.115 //layer=m1 \
 //thickness=0.36 //x=7.295 //y=5.38 //x2=7.41 //y2=5.38
r585 (  7 8 ) resistor r=0.620229 //w=0.131 //l=0.65 //layer=m1 \
 //thickness=0.36 //x=7.295 //y=5.38 //x2=6.645 //y2=5.38
r586 (  4 28 ) resistor r=0.0801089 //w=0.224 //l=0.13 //layer=m1 \
 //thickness=0.36 //x=3.82 //y=4.75 //x2=3.82 //y2=4.88
r587 (  3 30 ) resistor r=0.0910802 //w=0.374 //l=0.185472 //layer=m1 \
 //thickness=0.36 //x=3.82 //y=3.67 //x2=3.875 //y2=3.51
r588 (  3 4 ) resistor r=1.03053 //w=0.131 //l=1.08 //layer=m1 \
 //thickness=0.36 //x=3.82 //y=3.67 //x2=3.82 //y2=4.75
r589 (  2 30 ) resistor r=0.0910802 //w=0.374 //l=0.185472 //layer=m1 \
 //thickness=0.36 //x=3.82 //y=3.35 //x2=3.875 //y2=3.51
r590 (  1 26 ) resistor r=0.0719237 //w=0.222 //l=0.115 //layer=m1 \
 //thickness=0.36 //x=3.82 //y=2.375 //x2=3.82 //y2=2.26
r591 (  1 2 ) resistor r=0.930344 //w=0.131 //l=0.975 //layer=m1 \
 //thickness=0.36 //x=3.82 //y=2.375 //x2=3.82 //y2=3.35
ends PM_TMRDFFQX1\%noxref_1

subckt PM_TMRDFFQX1\%noxref_2 ( 3 8 9 11 12 14 15 16 18 19 23 24 27 29 32 35 \
 38 41 42 44 45 50 53 61 78 87 91 92 93 94 95 96 97 101 103 106 107 117 120 \
 122 123 )
c282 ( 120 0 ) capacitor c=0.00878249f //x=10.59 //y=1.085
c283 ( 117 0 ) capacitor c=0.0682508f //x=13.07 //y=4.88
c284 ( 107 0 ) capacitor c=0.0318956f //x=13.405 //y=1.39
c285 ( 106 0 ) capacitor c=0.0186809f //x=13.405 //y=1.045
c286 ( 103 0 ) capacitor c=0.0141821f //x=13.25 //y=1.545
c287 ( 101 0 ) capacitor c=0.0158553f //x=13.25 //y=0.89
c288 ( 97 0 ) capacitor c=0.0854195f //x=12.875 //y=2.095
c289 ( 96 0 ) capacitor c=0.0229235f //x=12.875 //y=1.7
c290 ( 95 0 ) capacitor c=0.0234359f //x=12.875 //y=1.39
c291 ( 94 0 ) capacitor c=0.0198759f //x=12.875 //y=1.045
c292 ( 93 0 ) capacitor c=0.110369f //x=13.41 //y=6.2
c293 ( 92 0 ) capacitor c=0.154619f //x=12.97 //y=6.2
c294 ( 87 0 ) capacitor c=8.13425e-19 //x=13.07 //y=4.88
c295 ( 78 0 ) capacitor c=7.85889e-19 //x=13.07 //y=2.26
c296 ( 61 0 ) capacitor c=0.0322017f //x=10.74 //y=5.56
c297 ( 53 0 ) capacitor c=0.0291714f //x=9.86 //y=5.56
c298 ( 50 0 ) capacitor c=5.49021e-19 //x=13.065 //y=3.51
c299 ( 45 0 ) capacitor c=8.73927e-19 //x=11.385 //y=3.51
c300 ( 44 0 ) capacitor c=0.0228166f //x=12.905 //y=3.51
c301 ( 42 0 ) capacitor c=0.0270852f //x=13.072 //y=4.74
c302 ( 41 0 ) capacitor c=0.0060492f //x=13.07 //y=4.88
c303 ( 38 0 ) capacitor c=0.00641145f //x=13.07 //y=2.26
c304 ( 35 0 ) capacitor c=0.0164425f //x=13.065 //y=3.51
c305 ( 32 0 ) capacitor c=0.0167895f //x=11.22 //y=3.51
c306 ( 29 0 ) capacitor c=0.0113735f //x=10.78 //y=1.18
c307 ( 27 0 ) capacitor c=5.78613e-19 //x=10.74 //y=5.56
c308 ( 24 0 ) capacitor c=0.0103127f //x=10.74 //y=5.38
c309 ( 23 0 ) capacitor c=0.00933334f //x=9.86 //y=5.56
c310 ( 19 0 ) capacitor c=0.0131458f //x=13.07 //y=3.67
c311 ( 18 0 ) capacitor c=0.0282897f //x=13.07 //y=3.35
c312 ( 16 0 ) capacitor c=0.0402141f //x=11.22 //y=5.295
c313 ( 15 0 ) capacitor c=0.0132742f //x=11.22 //y=3.67
c314 ( 14 0 ) capacitor c=0.0395638f //x=11.22 //y=3.35
c315 ( 12 0 ) capacitor c=0.00560492f //x=10.865 //y=1.835
c316 ( 11 0 ) capacitor c=0.0129728f //x=11.135 //y=1.835
c317 ( 9 0 ) capacitor c=0.0112475f //x=11.135 //y=5.38
c318 ( 8 0 ) capacitor c=0.0101547f //x=10.78 //y=1.75
c319 ( 3 0 ) capacitor c=0.0134484f //x=10.625 //y=5.38
r320 (  115 117 ) resistor r=20.6867 //w=0.233 //l=0.1 //layer=ply \
 //thickness=0.18 //x=12.97 //y=4.88 //x2=13.07 //y2=4.88
r321 (  108 117 ) resistor r=70.3348 //w=0.233 //l=0.414367 //layer=ply \
 //thickness=0.18 //x=13.41 //y=5.045 //x2=13.07 //y2=4.88
r322 (  107 119 ) resistor r=45.1352 //w=0.168 //l=0.173853 //layer=ply \
 //thickness=0.18 //x=13.405 //y=1.39 //x2=13.365 //y2=1.545
r323 (  106 118 ) resistor r=45.1352 //w=0.168 //l=0.173853 //layer=ply \
 //thickness=0.18 //x=13.405 //y=1.045 //x2=13.365 //y2=0.89
r324 (  106 107 ) resistor r=176.904 //w=0.094 //l=0.345 //layer=ply \
 //thickness=0.18 //x=13.405 //y=1.045 //x2=13.405 //y2=1.39
r325 (  104 114 ) resistor r=10.701 //w=0.21 //l=0.115 //layer=ply \
 //thickness=0.18 //x=13.03 //y=1.545 //x2=12.915 //y2=1.545
r326 (  103 119 ) resistor r=5.52526 //w=0.168 //l=0.115 //layer=ply \
 //thickness=0.18 //x=13.25 //y=1.545 //x2=13.365 //y2=1.545
r327 (  102 113 ) resistor r=5.52526 //w=0.168 //l=0.115 //layer=ply \
 //thickness=0.18 //x=13.03 //y=0.89 //x2=12.915 //y2=0.89
r328 (  101 118 ) resistor r=5.52526 //w=0.168 //l=0.115 //layer=ply \
 //thickness=0.18 //x=13.25 //y=0.89 //x2=13.365 //y2=0.89
r329 (  101 102 ) resistor r=112.809 //w=0.094 //l=0.22 //layer=ply \
 //thickness=0.18 //x=13.25 //y=0.89 //x2=13.03 //y2=0.89
r330 (  98 115 ) resistor r=13.0941 //w=0.233 //l=0.165 //layer=ply \
 //thickness=0.18 //x=12.97 //y=5.045 //x2=12.97 //y2=4.88
r331 (  97 112 ) resistor r=34.8111 //w=0.27 //l=0.264953 //layer=ply \
 //thickness=0.18 //x=12.875 //y=2.095 //x2=13.07 //y2=2.26
r332 (  96 114 ) resistor r=39.5823 //w=0.21 //l=0.173853 //layer=ply \
 //thickness=0.18 //x=12.875 //y=1.7 //x2=12.915 //y2=1.545
r333 (  96 97 ) resistor r=202.543 //w=0.094 //l=0.395 //layer=ply \
 //thickness=0.18 //x=12.875 //y=1.7 //x2=12.875 //y2=2.095
r334 (  95 114 ) resistor r=39.5823 //w=0.21 //l=0.173853 //layer=ply \
 //thickness=0.18 //x=12.875 //y=1.39 //x2=12.915 //y2=1.545
r335 (  94 113 ) resistor r=45.1352 //w=0.168 //l=0.173853 //layer=ply \
 //thickness=0.18 //x=12.875 //y=1.045 //x2=12.915 //y2=0.89
r336 (  94 95 ) resistor r=176.904 //w=0.094 //l=0.345 //layer=ply \
 //thickness=0.18 //x=12.875 //y=1.045 //x2=12.875 //y2=1.39
r337 (  93 108 ) resistor r=592.245 //w=0.094 //l=1.155 //layer=ply \
 //thickness=0.18 //x=13.41 //y=6.2 //x2=13.41 //y2=5.045
r338 (  92 98 ) resistor r=592.245 //w=0.094 //l=1.155 //layer=ply \
 //thickness=0.18 //x=12.97 //y=6.2 //x2=12.97 //y2=5.045
r339 (  91 103 ) resistor r=56.4043 //w=0.094 //l=0.11 //layer=ply \
 //thickness=0.18 //x=13.14 //y=1.545 //x2=13.25 //y2=1.545
r340 (  91 104 ) resistor r=56.4043 //w=0.094 //l=0.11 //layer=ply \
 //thickness=0.18 //x=13.14 //y=1.545 //x2=13.03 //y2=1.545
r341 (  87 117 ) resistor r=152 //w=0.17 //l=0.17 //layer=licon //count=1 \
 //x=13.07 //y=4.88 //x2=13.07 //y2=4.88
r342 (  78 112 ) resistor r=152 //w=0.17 //l=0.17 //layer=licon //count=1 \
 //x=13.07 //y=2.26 //x2=13.07 //y2=2.26
r343 (  61 123 ) resistor r=23.615 //w=0.187 //l=0.345 //layer=li \
 //thickness=0.1 //x=10.74 //y=5.56 //x2=10.74 //y2=5.905
r344 (  53 122 ) resistor r=23.615 //w=0.187 //l=0.345 //layer=li \
 //thickness=0.1 //x=9.86 //y=5.56 //x2=9.86 //y2=5.905
r345 (  45 47 ) resistor r=0.10734 //w=0.281 //l=0.16 //layer=m2 \
 //thickness=0.36 //x=11.385 //y=3.51 //x2=11.225 //y2=3.51
r346 (  44 50 ) resistor r=0.10734 //w=0.281 //l=0.16 //layer=m2 \
 //thickness=0.36 //x=12.905 //y=3.51 //x2=13.065 //y2=3.51
r347 (  44 45 ) resistor r=1.45038 //w=0.131 //l=1.52 //layer=m2 \
 //thickness=0.36 //x=12.905 //y=3.51 //x2=11.385 //y2=3.51
r348 (  41 87 ) resistor r=9.3 //w=0.17 //l=0.17 //layer=mcon //count=1 \
 //x=13.07 //y=4.88 //x2=13.07 //y2=4.88
r349 (  41 42 ) resistor r=0.103207 //w=0.196 //l=0.14 //layer=m1 \
 //thickness=0.36 //x=13.072 //y=4.88 //x2=13.072 //y2=4.74
r350 (  38 78 ) resistor r=9.3 //w=0.17 //l=0.17 //layer=mcon //count=1 \
 //x=13.07 //y=2.26 //x2=13.07 //y2=2.26
r351 (  35 50 ) resistor r=4.5 //w=0.15 //l=0.15 //layer=via1 //count=1 \
 //x=13.065 //y=3.51 //x2=13.065 //y2=3.51
r352 (  32 47 ) resistor r=4.5 //w=0.15 //l=0.15 //layer=via1 //count=1 \
 //x=11.225 //y=3.51 //x2=11.225 //y2=3.51
r353 (  29 120 ) resistor r=9.3 //w=0.17 //l=0.17 //layer=mcon //count=1 \
 //x=10.78 //y=1.18 //x2=10.78 //y2=1.18
r354 (  27 61 ) resistor r=9.3 //w=0.17 //l=0.17 //layer=mcon //count=1 \
 //x=10.74 //y=5.56 //x2=10.74 //y2=5.56
r355 (  24 27 ) resistor r=0.117801 //w=0.191 //l=0.18 //layer=m1 \
 //thickness=0.36 //x=10.74 //y=5.38 //x2=10.74 //y2=5.56
r356 (  23 53 ) resistor r=9.3 //w=0.17 //l=0.17 //layer=mcon //count=1 \
 //x=9.86 //y=5.56 //x2=9.86 //y2=5.56
r357 (  21 23 ) resistor r=0.10274 //w=0.219 //l=0.18 //layer=m1 \
 //thickness=0.36 //x=9.86 //y=5.38 //x2=9.86 //y2=5.56
r358 (  19 35 ) resistor r=0.0910802 //w=0.374 //l=0.185472 //layer=m1 \
 //thickness=0.36 //x=13.07 //y=3.67 //x2=13.015 //y2=3.51
r359 (  19 42 ) resistor r=1.02099 //w=0.131 //l=1.07 //layer=m1 \
 //thickness=0.36 //x=13.07 //y=3.67 //x2=13.07 //y2=4.74
r360 (  18 35 ) resistor r=0.0910802 //w=0.374 //l=0.185472 //layer=m1 \
 //thickness=0.36 //x=13.07 //y=3.35 //x2=13.015 //y2=3.51
r361 (  17 38 ) resistor r=0.0933015 //w=0.201 //l=0.125 //layer=m1 \
 //thickness=0.36 //x=13.07 //y=2.385 //x2=13.07 //y2=2.26
r362 (  17 18 ) resistor r=0.920802 //w=0.131 //l=0.965 //layer=m1 \
 //thickness=0.36 //x=13.07 //y=2.385 //x2=13.07 //y2=3.35
r363 (  15 32 ) resistor r=0.0910802 //w=0.374 //l=0.185472 //layer=m1 \
 //thickness=0.36 //x=11.22 //y=3.67 //x2=11.275 //y2=3.51
r364 (  15 16 ) resistor r=1.55057 //w=0.131 //l=1.625 //layer=m1 \
 //thickness=0.36 //x=11.22 //y=3.67 //x2=11.22 //y2=5.295
r365 (  14 32 ) resistor r=0.0910802 //w=0.374 //l=0.185472 //layer=m1 \
 //thickness=0.36 //x=11.22 //y=3.35 //x2=11.275 //y2=3.51
r366 (  13 14 ) resistor r=1.3645 //w=0.131 //l=1.43 //layer=m1 \
 //thickness=0.36 //x=11.22 //y=1.92 //x2=11.22 //y2=3.35
r367 (  11 13 ) resistor r=0.0698411 //w=0.17 //l=0.120208 //layer=m1 \
 //thickness=0.36 //x=11.135 //y=1.835 //x2=11.22 //y2=1.92
r368 (  11 12 ) resistor r=0.257634 //w=0.131 //l=0.27 //layer=m1 \
 //thickness=0.36 //x=11.135 //y=1.835 //x2=10.865 //y2=1.835
r369 (  10 24 ) resistor r=0.0257089 //w=0.23 //l=0.115 //layer=m1 \
 //thickness=0.36 //x=10.855 //y=5.38 //x2=10.74 //y2=5.38
r370 (  9 16 ) resistor r=0.0698411 //w=0.17 //l=0.120208 //layer=m1 \
 //thickness=0.36 //x=11.135 //y=5.38 //x2=11.22 //y2=5.295
r371 (  9 10 ) resistor r=0.267176 //w=0.131 //l=0.28 //layer=m1 \
 //thickness=0.36 //x=11.135 //y=5.38 //x2=10.855 //y2=5.38
r372 (  8 12 ) resistor r=0.0698411 //w=0.17 //l=0.120208 //layer=m1 \
 //thickness=0.36 //x=10.78 //y=1.75 //x2=10.865 //y2=1.835
r373 (  7 29 ) resistor r=0.0913624 //w=0.191 //l=0.12 //layer=m1 \
 //thickness=0.36 //x=10.78 //y=1.3 //x2=10.78 //y2=1.18
r374 (  7 8 ) resistor r=0.429389 //w=0.131 //l=0.45 //layer=m1 \
 //thickness=0.36 //x=10.78 //y=1.3 //x2=10.78 //y2=1.75
r375 (  4 21 ) resistor r=0.0227762 //w=0.219 //l=0.115 //layer=m1 \
 //thickness=0.36 //x=9.975 //y=5.38 //x2=9.86 //y2=5.38
r376 (  3 24 ) resistor r=0.0257089 //w=0.23 //l=0.115 //layer=m1 \
 //thickness=0.36 //x=10.625 //y=5.38 //x2=10.74 //y2=5.38
r377 (  3 4 ) resistor r=0.620229 //w=0.131 //l=0.65 //layer=m1 \
 //thickness=0.36 //x=10.625 //y=5.38 //x2=9.975 //y2=5.38
ends PM_TMRDFFQX1\%noxref_2

subckt PM_TMRDFFQX1\%noxref_3 ( 1 3 6 7 9 10 11 12 14 15 16 18 19 22 23 25 28 \
 31 37 40 43 46 47 50 54 57 58 60 61 62 63 64 66 68 70 72 74 84 92 100 117 126 \
 131 140 144 145 146 147 148 149 150 151 152 153 157 159 162 163 167 168 169 \
 170 174 176 179 180 190 199 202 204 205 206 )
c481 ( 202 0 ) capacitor c=0.00885916f //x=3.885 //y=1.095
c482 ( 199 0 ) capacitor c=0.0645411f //x=16.4 //y=4.88
c483 ( 190 0 ) capacitor c=0.0645923f //x=6.41 //y=4.88
c484 ( 180 0 ) capacitor c=0.0318956f //x=16.735 //y=1.39
c485 ( 179 0 ) capacitor c=0.0186809f //x=16.735 //y=1.045
c486 ( 176 0 ) capacitor c=0.0141821f //x=16.58 //y=1.545
c487 ( 174 0 ) capacitor c=0.0158553f //x=16.58 //y=0.89
c488 ( 170 0 ) capacitor c=0.088055f //x=16.205 //y=2.095
c489 ( 169 0 ) capacitor c=0.0229235f //x=16.205 //y=1.7
c490 ( 168 0 ) capacitor c=0.0234359f //x=16.205 //y=1.39
c491 ( 167 0 ) capacitor c=0.0198759f //x=16.205 //y=1.045
c492 ( 163 0 ) capacitor c=0.0318956f //x=6.745 //y=1.39
c493 ( 162 0 ) capacitor c=0.0186809f //x=6.745 //y=1.045
c494 ( 159 0 ) capacitor c=0.0141821f //x=6.59 //y=1.545
c495 ( 157 0 ) capacitor c=0.0158553f //x=6.59 //y=0.89
c496 ( 153 0 ) capacitor c=0.088055f //x=6.215 //y=2.095
c497 ( 152 0 ) capacitor c=0.0229235f //x=6.215 //y=1.7
c498 ( 151 0 ) capacitor c=0.0234359f //x=6.215 //y=1.39
c499 ( 150 0 ) capacitor c=0.0198759f //x=6.215 //y=1.045
c500 ( 149 0 ) capacitor c=0.110369f //x=16.74 //y=6.2
c501 ( 148 0 ) capacitor c=0.154619f //x=16.3 //y=6.2
c502 ( 147 0 ) capacitor c=0.110369f //x=6.75 //y=6.2
c503 ( 146 0 ) capacitor c=0.154619f //x=6.31 //y=6.2
c504 ( 140 0 ) capacitor c=8.13425e-19 //x=16.4 //y=4.88
c505 ( 131 0 ) capacitor c=7.85889e-19 //x=16.4 //y=2.26
c506 ( 126 0 ) capacitor c=8.13425e-19 //x=6.41 //y=4.88
c507 ( 117 0 ) capacitor c=7.85889e-19 //x=6.41 //y=2.26
c508 ( 100 0 ) capacitor c=0.0293071f //x=3.78 //y=5.56
c509 ( 92 0 ) capacitor c=0.029137f //x=2.9 //y=5.56
c510 ( 84 0 ) capacitor c=0.0278099f //x=2.02 //y=5.56
c511 ( 74 0 ) capacitor c=0.0461327f //x=13.28 //y=3.895
c512 ( 72 0 ) capacitor c=0.0175525f //x=12.68 //y=3.88
c513 ( 70 0 ) capacitor c=0.00418974f //x=11.44 //y=3.895
c514 ( 68 0 ) capacitor c=0.00891578f //x=10.7 //y=3.87
c515 ( 66 0 ) capacitor c=0.00615582f //x=9.95 //y=3.89
c516 ( 64 0 ) capacitor c=0.0178779f //x=9.35 //y=3.88
c517 ( 63 0 ) capacitor c=0.00992601f //x=7.755 //y=3.895
c518 ( 62 0 ) capacitor c=0.00477746f //x=8.1 //y=3.895
c519 ( 61 0 ) capacitor c=7.05145e-19 //x=4.72 //y=3.88
c520 ( 60 0 ) capacitor c=0.0193144f //x=6.245 //y=3.88
c521 ( 58 0 ) capacitor c=0.0161339f //x=16.402 //y=4.74
c522 ( 57 0 ) capacitor c=0.00598189f //x=16.4 //y=4.88
c523 ( 54 0 ) capacitor c=0.00654828f //x=16.4 //y=2.26
c524 ( 50 0 ) capacitor c=0.0159231f //x=16.4 //y=3.88
c525 ( 47 0 ) capacitor c=0.0172769f //x=6.412 //y=4.74
c526 ( 46 0 ) capacitor c=0.00598357f //x=6.41 //y=4.88
c527 ( 43 0 ) capacitor c=0.00654649f //x=6.41 //y=2.26
c528 ( 40 0 ) capacitor c=0.0163193f //x=6.405 //y=3.88
c529 ( 37 0 ) capacitor c=0.0170864f //x=4.56 //y=3.88
c530 ( 31 0 ) capacitor c=9.55882e-19 //x=3.78 //y=5.335
c531 ( 28 0 ) capacitor c=0.00753245f //x=2.9 //y=5.335
c532 ( 25 0 ) capacitor c=0.0123281f //x=2.022 //y=5.335
c533 ( 23 0 ) capacitor c=0.012588f //x=16.4 //y=4.045
c534 ( 22 0 ) capacitor c=0.0391037f //x=16.4 //y=3.725
c535 ( 19 0 ) capacitor c=0.0124546f //x=6.41 //y=4.04
c536 ( 18 0 ) capacitor c=0.0366503f //x=6.41 //y=3.72
c537 ( 16 0 ) capacitor c=0.0309857f //x=4.56 //y=5.25
c538 ( 15 0 ) capacitor c=0.0132732f //x=4.56 //y=4.04
c539 ( 14 0 ) capacitor c=0.0506888f //x=4.56 //y=3.72
c540 ( 12 0 ) capacitor c=0.00686157f //x=4.16 //y=1.845
c541 ( 11 0 ) capacitor c=0.0159771f //x=4.475 //y=1.845
c542 ( 10 0 ) capacitor c=0.0136149f //x=4.075 //y=1.76
c543 ( 9 0 ) capacitor c=0.011255f //x=4.075 //y=1.305
c544 ( 7 0 ) capacitor c=0.0228253f //x=4.475 //y=5.335
c545 ( 6 0 ) capacitor c=0.00906713f //x=3.78 //y=5.56
c546 ( 3 0 ) capacitor c=0.019596f //x=3.665 //y=5.335
c547 ( 1 0 ) capacitor c=0.0150747f //x=2.78 //y=5.335
r548 (  197 199 ) resistor r=20.6867 //w=0.233 //l=0.1 //layer=ply \
 //thickness=0.18 //x=16.3 //y=4.88 //x2=16.4 //y2=4.88
r549 (  188 190 ) resistor r=20.6867 //w=0.233 //l=0.1 //layer=ply \
 //thickness=0.18 //x=6.31 //y=4.88 //x2=6.41 //y2=4.88
r550 (  181 199 ) resistor r=70.3348 //w=0.233 //l=0.414367 //layer=ply \
 //thickness=0.18 //x=16.74 //y=5.045 //x2=16.4 //y2=4.88
r551 (  180 201 ) resistor r=45.1352 //w=0.168 //l=0.173853 //layer=ply \
 //thickness=0.18 //x=16.735 //y=1.39 //x2=16.695 //y2=1.545
r552 (  179 200 ) resistor r=45.1352 //w=0.168 //l=0.173853 //layer=ply \
 //thickness=0.18 //x=16.735 //y=1.045 //x2=16.695 //y2=0.89
r553 (  179 180 ) resistor r=176.904 //w=0.094 //l=0.345 //layer=ply \
 //thickness=0.18 //x=16.735 //y=1.045 //x2=16.735 //y2=1.39
r554 (  177 196 ) resistor r=10.701 //w=0.21 //l=0.115 //layer=ply \
 //thickness=0.18 //x=16.36 //y=1.545 //x2=16.245 //y2=1.545
r555 (  176 201 ) resistor r=5.52526 //w=0.168 //l=0.115 //layer=ply \
 //thickness=0.18 //x=16.58 //y=1.545 //x2=16.695 //y2=1.545
r556 (  175 195 ) resistor r=5.52526 //w=0.168 //l=0.115 //layer=ply \
 //thickness=0.18 //x=16.36 //y=0.89 //x2=16.245 //y2=0.89
r557 (  174 200 ) resistor r=5.52526 //w=0.168 //l=0.115 //layer=ply \
 //thickness=0.18 //x=16.58 //y=0.89 //x2=16.695 //y2=0.89
r558 (  174 175 ) resistor r=112.809 //w=0.094 //l=0.22 //layer=ply \
 //thickness=0.18 //x=16.58 //y=0.89 //x2=16.36 //y2=0.89
r559 (  171 197 ) resistor r=13.0941 //w=0.233 //l=0.165 //layer=ply \
 //thickness=0.18 //x=16.3 //y=5.045 //x2=16.3 //y2=4.88
r560 (  170 194 ) resistor r=34.8111 //w=0.27 //l=0.264953 //layer=ply \
 //thickness=0.18 //x=16.205 //y=2.095 //x2=16.4 //y2=2.26
r561 (  169 196 ) resistor r=39.5823 //w=0.21 //l=0.173853 //layer=ply \
 //thickness=0.18 //x=16.205 //y=1.7 //x2=16.245 //y2=1.545
r562 (  169 170 ) resistor r=202.543 //w=0.094 //l=0.395 //layer=ply \
 //thickness=0.18 //x=16.205 //y=1.7 //x2=16.205 //y2=2.095
r563 (  168 196 ) resistor r=39.5823 //w=0.21 //l=0.173853 //layer=ply \
 //thickness=0.18 //x=16.205 //y=1.39 //x2=16.245 //y2=1.545
r564 (  167 195 ) resistor r=45.1352 //w=0.168 //l=0.173853 //layer=ply \
 //thickness=0.18 //x=16.205 //y=1.045 //x2=16.245 //y2=0.89
r565 (  167 168 ) resistor r=176.904 //w=0.094 //l=0.345 //layer=ply \
 //thickness=0.18 //x=16.205 //y=1.045 //x2=16.205 //y2=1.39
r566 (  164 190 ) resistor r=70.3348 //w=0.233 //l=0.414367 //layer=ply \
 //thickness=0.18 //x=6.75 //y=5.045 //x2=6.41 //y2=4.88
r567 (  163 192 ) resistor r=45.1352 //w=0.168 //l=0.173853 //layer=ply \
 //thickness=0.18 //x=6.745 //y=1.39 //x2=6.705 //y2=1.545
r568 (  162 191 ) resistor r=45.1352 //w=0.168 //l=0.173853 //layer=ply \
 //thickness=0.18 //x=6.745 //y=1.045 //x2=6.705 //y2=0.89
r569 (  162 163 ) resistor r=176.904 //w=0.094 //l=0.345 //layer=ply \
 //thickness=0.18 //x=6.745 //y=1.045 //x2=6.745 //y2=1.39
r570 (  160 187 ) resistor r=10.701 //w=0.21 //l=0.115 //layer=ply \
 //thickness=0.18 //x=6.37 //y=1.545 //x2=6.255 //y2=1.545
r571 (  159 192 ) resistor r=5.52526 //w=0.168 //l=0.115 //layer=ply \
 //thickness=0.18 //x=6.59 //y=1.545 //x2=6.705 //y2=1.545
r572 (  158 186 ) resistor r=5.52526 //w=0.168 //l=0.115 //layer=ply \
 //thickness=0.18 //x=6.37 //y=0.89 //x2=6.255 //y2=0.89
r573 (  157 191 ) resistor r=5.52526 //w=0.168 //l=0.115 //layer=ply \
 //thickness=0.18 //x=6.59 //y=0.89 //x2=6.705 //y2=0.89
r574 (  157 158 ) resistor r=112.809 //w=0.094 //l=0.22 //layer=ply \
 //thickness=0.18 //x=6.59 //y=0.89 //x2=6.37 //y2=0.89
r575 (  154 188 ) resistor r=13.0941 //w=0.233 //l=0.165 //layer=ply \
 //thickness=0.18 //x=6.31 //y=5.045 //x2=6.31 //y2=4.88
r576 (  153 185 ) resistor r=34.8111 //w=0.27 //l=0.264953 //layer=ply \
 //thickness=0.18 //x=6.215 //y=2.095 //x2=6.41 //y2=2.26
r577 (  152 187 ) resistor r=39.5823 //w=0.21 //l=0.173853 //layer=ply \
 //thickness=0.18 //x=6.215 //y=1.7 //x2=6.255 //y2=1.545
r578 (  152 153 ) resistor r=202.543 //w=0.094 //l=0.395 //layer=ply \
 //thickness=0.18 //x=6.215 //y=1.7 //x2=6.215 //y2=2.095
r579 (  151 187 ) resistor r=39.5823 //w=0.21 //l=0.173853 //layer=ply \
 //thickness=0.18 //x=6.215 //y=1.39 //x2=6.255 //y2=1.545
r580 (  150 186 ) resistor r=45.1352 //w=0.168 //l=0.173853 //layer=ply \
 //thickness=0.18 //x=6.215 //y=1.045 //x2=6.255 //y2=0.89
r581 (  150 151 ) resistor r=176.904 //w=0.094 //l=0.345 //layer=ply \
 //thickness=0.18 //x=6.215 //y=1.045 //x2=6.215 //y2=1.39
r582 (  149 181 ) resistor r=592.245 //w=0.094 //l=1.155 //layer=ply \
 //thickness=0.18 //x=16.74 //y=6.2 //x2=16.74 //y2=5.045
r583 (  148 171 ) resistor r=592.245 //w=0.094 //l=1.155 //layer=ply \
 //thickness=0.18 //x=16.3 //y=6.2 //x2=16.3 //y2=5.045
r584 (  147 164 ) resistor r=592.245 //w=0.094 //l=1.155 //layer=ply \
 //thickness=0.18 //x=6.75 //y=6.2 //x2=6.75 //y2=5.045
r585 (  146 154 ) resistor r=592.245 //w=0.094 //l=1.155 //layer=ply \
 //thickness=0.18 //x=6.31 //y=6.2 //x2=6.31 //y2=5.045
r586 (  145 176 ) resistor r=56.4043 //w=0.094 //l=0.11 //layer=ply \
 //thickness=0.18 //x=16.47 //y=1.545 //x2=16.58 //y2=1.545
r587 (  145 177 ) resistor r=56.4043 //w=0.094 //l=0.11 //layer=ply \
 //thickness=0.18 //x=16.47 //y=1.545 //x2=16.36 //y2=1.545
r588 (  144 159 ) resistor r=56.4043 //w=0.094 //l=0.11 //layer=ply \
 //thickness=0.18 //x=6.48 //y=1.545 //x2=6.59 //y2=1.545
r589 (  144 160 ) resistor r=56.4043 //w=0.094 //l=0.11 //layer=ply \
 //thickness=0.18 //x=6.48 //y=1.545 //x2=6.37 //y2=1.545
r590 (  140 199 ) resistor r=152 //w=0.17 //l=0.17 //layer=licon //count=1 \
 //x=16.4 //y=4.88 //x2=16.4 //y2=4.88
r591 (  131 194 ) resistor r=152 //w=0.17 //l=0.17 //layer=licon //count=1 \
 //x=16.4 //y=2.26 //x2=16.4 //y2=2.26
r592 (  126 190 ) resistor r=152 //w=0.17 //l=0.17 //layer=licon //count=1 \
 //x=6.41 //y=4.88 //x2=6.41 //y2=4.88
r593 (  117 185 ) resistor r=152 //w=0.17 //l=0.17 //layer=licon //count=1 \
 //x=6.41 //y=2.26 //x2=6.41 //y2=2.26
r594 (  100 206 ) resistor r=23.615 //w=0.187 //l=0.345 //layer=li \
 //thickness=0.1 //x=3.78 //y=5.56 //x2=3.78 //y2=5.905
r595 (  92 205 ) resistor r=23.615 //w=0.187 //l=0.345 //layer=li \
 //thickness=0.1 //x=2.9 //y=5.56 //x2=2.9 //y2=5.905
r596 (  84 204 ) resistor r=23.615 //w=0.187 //l=0.345 //layer=li \
 //thickness=0.1 //x=2.02 //y=5.56 //x2=2.02 //y2=5.905
r597 (  74 82 ) resistor r=2.10915 //w=0.185 //l=3.125 //layer=m2 \
 //thickness=0.36 //x=13.28 //y=3.895 //x2=16.4 //y2=3.885
r598 (  74 75 ) resistor r=0.329198 //w=0.131 //l=0.345 //layer=m2 \
 //thickness=0.36 //x=13.28 //y=3.895 //x2=12.935 //y2=3.895
r599 (  72 75 ) resistor r=0.1875 //w=0.17 //l=0.262393 //layer=m2 \
 //thickness=0.36 //x=12.68 //y=3.88 //x2=12.935 //y2=3.895
r600 (  72 73 ) resistor r=1.02099 //w=0.131 //l=1.07 //layer=m2 \
 //thickness=0.36 //x=12.68 //y=3.88 //x2=11.61 //y2=3.88
r601 (  70 73 ) resistor r=0.125 //w=0.17 //l=0.177341 //layer=m2 \
 //thickness=0.36 //x=11.44 //y=3.895 //x2=11.61 //y2=3.88
r602 (  70 71 ) resistor r=0.329198 //w=0.131 //l=0.345 //layer=m2 \
 //thickness=0.36 //x=11.44 //y=3.895 //x2=11.095 //y2=3.895
r603 (  68 71 ) resistor r=0.290441 //w=0.17 //l=0.407308 //layer=m2 \
 //thickness=0.36 //x=10.7 //y=3.87 //x2=11.095 //y2=3.895
r604 (  68 69 ) resistor r=0.410305 //w=0.131 //l=0.43 //layer=m2 \
 //thickness=0.36 //x=10.7 //y=3.87 //x2=10.27 //y2=3.87
r605 (  66 69 ) resistor r=0.235294 //w=0.17 //l=0.329848 //layer=m2 \
 //thickness=0.36 //x=9.95 //y=3.89 //x2=10.27 //y2=3.87
r606 (  66 67 ) resistor r=0.329198 //w=0.131 //l=0.345 //layer=m2 \
 //thickness=0.36 //x=9.95 //y=3.89 //x2=9.605 //y2=3.89
r607 (  64 67 ) resistor r=0.1875 //w=0.17 //l=0.259952 //layer=m2 \
 //thickness=0.36 //x=9.35 //y=3.88 //x2=9.605 //y2=3.89
r608 (  64 65 ) resistor r=1.03053 //w=0.131 //l=1.08 //layer=m2 \
 //thickness=0.36 //x=9.35 //y=3.88 //x2=8.27 //y2=3.88
r609 (  63 80 ) resistor r=0.838898 //w=0.202 //l=1.35748 //layer=m2 \
 //thickness=0.36 //x=7.755 //y=3.895 //x2=6.405 //y2=3.88
r610 (  62 65 ) resistor r=0.125 //w=0.17 //l=0.177341 //layer=m2 \
 //thickness=0.36 //x=8.1 //y=3.895 //x2=8.27 //y2=3.88
r611 (  62 63 ) resistor r=0.329198 //w=0.131 //l=0.345 //layer=m2 \
 //thickness=0.36 //x=8.1 //y=3.895 //x2=7.755 //y2=3.895
r612 (  61 77 ) resistor r=0.10734 //w=0.281 //l=0.16 //layer=m2 \
 //thickness=0.36 //x=4.72 //y=3.88 //x2=4.56 //y2=3.88
r613 (  60 80 ) resistor r=0.102512 //w=0.202 //l=0.16 //layer=m2 \
 //thickness=0.36 //x=6.245 //y=3.88 //x2=6.405 //y2=3.88
r614 (  60 61 ) resistor r=1.45515 //w=0.131 //l=1.525 //layer=m2 \
 //thickness=0.36 //x=6.245 //y=3.88 //x2=4.72 //y2=3.88
r615 (  57 140 ) resistor r=9.3 //w=0.17 //l=0.17 //layer=mcon //count=1 \
 //x=16.4 //y=4.88 //x2=16.4 //y2=4.88
r616 (  57 58 ) resistor r=0.103207 //w=0.196 //l=0.14 //layer=m1 \
 //thickness=0.36 //x=16.402 //y=4.88 //x2=16.402 //y2=4.74
r617 (  54 131 ) resistor r=9.3 //w=0.17 //l=0.17 //layer=mcon //count=1 \
 //x=16.4 //y=2.26 //x2=16.4 //y2=2.26
r618 (  52 82 ) resistor r=4.5 //w=0.15 //l=0.15 //layer=via1 //count=1 \
 //x=16.4 //y=3.885 //x2=16.4 //y2=3.885
r619 (  50 52 ) resistor r=0.00166223 //w=0.376 //l=0.005 //layer=m1 \
 //thickness=0.36 //x=16.347 //y=3.88 //x2=16.347 //y2=3.885
r620 (  46 126 ) resistor r=9.3 //w=0.17 //l=0.17 //layer=mcon //count=1 \
 //x=6.41 //y=4.88 //x2=6.41 //y2=4.88
r621 (  46 47 ) resistor r=0.103207 //w=0.196 //l=0.14 //layer=m1 \
 //thickness=0.36 //x=6.412 //y=4.88 //x2=6.412 //y2=4.74
r622 (  43 117 ) resistor r=9.3 //w=0.17 //l=0.17 //layer=mcon //count=1 \
 //x=6.41 //y=2.26 //x2=6.41 //y2=2.26
r623 (  40 80 ) resistor r=4.5 //w=0.15 //l=0.15 //layer=via1 //count=1 \
 //x=6.405 //y=3.88 //x2=6.405 //y2=3.88
r624 (  37 77 ) resistor r=4.5 //w=0.15 //l=0.15 //layer=via1 //count=1 \
 //x=4.56 //y=3.88 //x2=4.56 //y2=3.88
r625 (  35 202 ) resistor r=9.3 //w=0.17 //l=0.17 //layer=mcon //count=1 \
 //x=4.075 //y=1.19 //x2=4.075 //y2=1.19
r626 (  33 100 ) resistor r=9.3 //w=0.17 //l=0.17 //layer=mcon //count=1 \
 //x=3.78 //y=5.56 //x2=3.78 //y2=5.56
r627 (  30 92 ) resistor r=9.3 //w=0.17 //l=0.17 //layer=mcon //count=1 \
 //x=2.9 //y=5.56 //x2=2.9 //y2=5.56
r628 (  28 30 ) resistor r=0.121228 //w=0.232 //l=0.225 //layer=m1 \
 //thickness=0.36 //x=2.9 //y=5.335 //x2=2.9 //y2=5.56
r629 (  27 84 ) resistor r=9.3 //w=0.17 //l=0.17 //layer=mcon //count=1 \
 //x=2.02 //y=5.56 //x2=2.02 //y2=5.56
r630 (  25 27 ) resistor r=0.129608 //w=0.217 //l=0.225 //layer=m1 \
 //thickness=0.36 //x=2.022 //y=5.335 //x2=2.022 //y2=5.56
r631 (  23 52 ) resistor r=0.0911593 //w=0.376 //l=0.184608 //layer=m1 \
 //thickness=0.36 //x=16.4 //y=4.045 //x2=16.347 //y2=3.885
r632 (  23 58 ) resistor r=0.663168 //w=0.131 //l=0.695 //layer=m1 \
 //thickness=0.36 //x=16.4 //y=4.045 //x2=16.4 //y2=4.74
r633 (  22 50 ) resistor r=0.0894971 //w=0.376 //l=0.179555 //layer=m1 \
 //thickness=0.36 //x=16.4 //y=3.725 //x2=16.347 //y2=3.88
r634 (  21 54 ) resistor r=0.0933015 //w=0.201 //l=0.125 //layer=m1 \
 //thickness=0.36 //x=16.4 //y=2.385 //x2=16.4 //y2=2.26
r635 (  21 22 ) resistor r=1.27863 //w=0.131 //l=1.34 //layer=m1 \
 //thickness=0.36 //x=16.4 //y=2.385 //x2=16.4 //y2=3.725
r636 (  19 40 ) resistor r=0.0910802 //w=0.374 //l=0.185472 //layer=m1 \
 //thickness=0.36 //x=6.41 //y=4.04 //x2=6.355 //y2=3.88
r637 (  19 47 ) resistor r=0.667939 //w=0.131 //l=0.7 //layer=m1 \
 //thickness=0.36 //x=6.41 //y=4.04 //x2=6.41 //y2=4.74
r638 (  18 40 ) resistor r=0.0910802 //w=0.374 //l=0.185472 //layer=m1 \
 //thickness=0.36 //x=6.41 //y=3.72 //x2=6.355 //y2=3.88
r639 (  17 43 ) resistor r=0.0933015 //w=0.201 //l=0.125 //layer=m1 \
 //thickness=0.36 //x=6.41 //y=2.385 //x2=6.41 //y2=2.26
r640 (  17 18 ) resistor r=1.27385 //w=0.131 //l=1.335 //layer=m1 \
 //thickness=0.36 //x=6.41 //y=2.385 //x2=6.41 //y2=3.72
r641 (  15 37 ) resistor r=0.0911593 //w=0.376 //l=0.184174 //layer=m1 \
 //thickness=0.36 //x=4.56 //y=4.04 //x2=4.612 //y2=3.88
r642 (  15 16 ) resistor r=1.15458 //w=0.131 //l=1.21 //layer=m1 \
 //thickness=0.36 //x=4.56 //y=4.04 //x2=4.56 //y2=5.25
r643 (  14 37 ) resistor r=0.0911593 //w=0.376 //l=0.184174 //layer=m1 \
 //thickness=0.36 //x=4.56 //y=3.72 //x2=4.612 //y2=3.88
r644 (  13 14 ) resistor r=1.70802 //w=0.131 //l=1.79 //layer=m1 \
 //thickness=0.36 //x=4.56 //y=1.93 //x2=4.56 //y2=3.72
r645 (  11 13 ) resistor r=0.0698411 //w=0.17 //l=0.120208 //layer=m1 \
 //thickness=0.36 //x=4.475 //y=1.845 //x2=4.56 //y2=1.93
r646 (  11 12 ) resistor r=0.300573 //w=0.131 //l=0.315 //layer=m1 \
 //thickness=0.36 //x=4.475 //y=1.845 //x2=4.16 //y2=1.845
r647 (  10 12 ) resistor r=0.0698411 //w=0.17 //l=0.120208 //layer=m1 \
 //thickness=0.36 //x=4.075 //y=1.76 //x2=4.16 //y2=1.845
r648 (  9 35 ) resistor r=0.0717383 //w=0.224 //l=0.115 //layer=m1 \
 //thickness=0.36 //x=4.075 //y=1.305 //x2=4.075 //y2=1.19
r649 (  9 10 ) resistor r=0.43416 //w=0.131 //l=0.455 //layer=m1 \
 //thickness=0.36 //x=4.075 //y=1.305 //x2=4.075 //y2=1.76
r650 (  8 31 ) resistor r=0.0675342 //w=0.23 //l=0.115 //layer=m1 \
 //thickness=0.36 //x=3.895 //y=5.335 //x2=3.78 //y2=5.335
r651 (  7 16 ) resistor r=0.0698411 //w=0.17 //l=0.120208 //layer=m1 \
 //thickness=0.36 //x=4.475 //y=5.335 //x2=4.56 //y2=5.25
r652 (  7 8 ) resistor r=0.553435 //w=0.131 //l=0.58 //layer=m1 \
 //thickness=0.36 //x=4.475 //y=5.335 //x2=3.895 //y2=5.335
r653 (  6 33 ) resistor r=0.00118313 //w=0.23 //layer=m1 //thickness=0.36 \
 //x=3.78 //y=5.56 //x2=3.78 //y2=5.56
r654 (  5 31 ) resistor r=0.002872 //w=0.34 //l=0.085 //layer=m1 \
 //thickness=0.36 //x=3.78 //y=5.42 //x2=3.78 //y2=5.335
r655 (  5 6 ) resistor r=0.091623 //w=0.191 //l=0.14 //layer=m1 \
 //thickness=0.36 //x=3.78 //y=5.42 //x2=3.78 //y2=5.56
r656 (  4 28 ) resistor r=0.0262263 //w=0.232 //l=0.12 //layer=m1 \
 //thickness=0.36 //x=3.02 //y=5.335 //x2=2.9 //y2=5.335
r657 (  3 31 ) resistor r=0.0675342 //w=0.23 //l=0.115 //layer=m1 \
 //thickness=0.36 //x=3.665 //y=5.335 //x2=3.78 //y2=5.335
r658 (  3 4 ) resistor r=0.615458 //w=0.131 //l=0.645 //layer=m1 \
 //thickness=0.36 //x=3.665 //y=5.335 //x2=3.02 //y2=5.335
r659 (  2 25 ) resistor r=0.0222262 //w=0.217 //l=0.118 //layer=m1 \
 //thickness=0.36 //x=2.14 //y=5.335 //x2=2.022 //y2=5.335
r660 (  1 28 ) resistor r=0.0262263 //w=0.232 //l=0.12 //layer=m1 \
 //thickness=0.36 //x=2.78 //y=5.335 //x2=2.9 //y2=5.335
r661 (  1 2 ) resistor r=0.610687 //w=0.131 //l=0.64 //layer=m1 \
 //thickness=0.36 //x=2.78 //y=5.335 //x2=2.14 //y2=5.335
ends PM_TMRDFFQX1\%noxref_3

subckt PM_TMRDFFQX1\%noxref_4 ( 3 8 9 11 12 14 15 16 18 19 23 24 27 29 34 38 \
 40 43 44 51 53 54 57 65 82 91 95 96 97 98 99 100 101 105 107 110 111 121 124 \
 126 127 )
c284 ( 124 0 ) capacitor c=0.00878249f //x=17.25 //y=1.085
c285 ( 121 0 ) capacitor c=0.0646027f //x=19.73 //y=4.88
c286 ( 111 0 ) capacitor c=0.0318956f //x=20.065 //y=1.39
c287 ( 110 0 ) capacitor c=0.0186809f //x=20.065 //y=1.045
c288 ( 107 0 ) capacitor c=0.0141821f //x=19.91 //y=1.545
c289 ( 105 0 ) capacitor c=0.0158553f //x=19.91 //y=0.89
c290 ( 101 0 ) capacitor c=0.088055f //x=19.535 //y=2.095
c291 ( 100 0 ) capacitor c=0.0229235f //x=19.535 //y=1.7
c292 ( 99 0 ) capacitor c=0.0234359f //x=19.535 //y=1.39
c293 ( 98 0 ) capacitor c=0.0198759f //x=19.535 //y=1.045
c294 ( 97 0 ) capacitor c=0.110369f //x=20.07 //y=6.2
c295 ( 96 0 ) capacitor c=0.154619f //x=19.63 //y=6.2
c296 ( 91 0 ) capacitor c=8.13425e-19 //x=19.73 //y=4.88
c297 ( 82 0 ) capacitor c=7.85889e-19 //x=19.73 //y=2.26
c298 ( 65 0 ) capacitor c=0.0322017f //x=17.4 //y=5.56
c299 ( 57 0 ) capacitor c=0.0290186f //x=16.52 //y=5.56
c300 ( 54 0 ) capacitor c=0.0234059f //x=19.565 //y=3.865
c301 ( 53 0 ) capacitor c=8.85755e-19 //x=19.725 //y=3.865
c302 ( 51 0 ) capacitor c=8.2295e-19 //x=18.04 //y=3.865
c303 ( 44 0 ) capacitor c=0.0158653f //x=19.732 //y=4.74
c304 ( 43 0 ) capacitor c=0.00598864f //x=19.73 //y=4.88
c305 ( 40 0 ) capacitor c=0.00654113f //x=19.73 //y=2.26
c306 ( 38 0 ) capacitor c=0.0165926f //x=19.73 //y=3.88
c307 ( 34 0 ) capacitor c=0.0170475f //x=17.88 //y=3.88
c308 ( 29 0 ) capacitor c=0.0111921f //x=17.44 //y=1.18
c309 ( 27 0 ) capacitor c=5.78613e-19 //x=17.4 //y=5.56
c310 ( 24 0 ) capacitor c=0.0114042f //x=17.4 //y=5.38
c311 ( 23 0 ) capacitor c=0.00917153f //x=16.52 //y=5.56
c312 ( 19 0 ) capacitor c=0.0123305f //x=19.73 //y=4.025
c313 ( 18 0 ) capacitor c=0.0378818f //x=19.73 //y=3.705
c314 ( 16 0 ) capacitor c=0.0304799f //x=17.88 //y=5.295
c315 ( 15 0 ) capacitor c=0.0135873f //x=17.88 //y=4.025
c316 ( 14 0 ) capacitor c=0.0486199f //x=17.88 //y=3.705
c317 ( 12 0 ) capacitor c=0.00515315f //x=17.525 //y=1.835
c318 ( 11 0 ) capacitor c=0.0130757f //x=17.795 //y=1.835
c319 ( 9 0 ) capacitor c=0.0111209f //x=17.795 //y=5.38
c320 ( 8 0 ) capacitor c=0.0101547f //x=17.44 //y=1.75
c321 ( 3 0 ) capacitor c=0.0145347f //x=17.285 //y=5.38
r322 (  119 121 ) resistor r=20.6867 //w=0.233 //l=0.1 //layer=ply \
 //thickness=0.18 //x=19.63 //y=4.88 //x2=19.73 //y2=4.88
r323 (  112 121 ) resistor r=70.3348 //w=0.233 //l=0.414367 //layer=ply \
 //thickness=0.18 //x=20.07 //y=5.045 //x2=19.73 //y2=4.88
r324 (  111 123 ) resistor r=45.1352 //w=0.168 //l=0.173853 //layer=ply \
 //thickness=0.18 //x=20.065 //y=1.39 //x2=20.025 //y2=1.545
r325 (  110 122 ) resistor r=45.1352 //w=0.168 //l=0.173853 //layer=ply \
 //thickness=0.18 //x=20.065 //y=1.045 //x2=20.025 //y2=0.89
r326 (  110 111 ) resistor r=176.904 //w=0.094 //l=0.345 //layer=ply \
 //thickness=0.18 //x=20.065 //y=1.045 //x2=20.065 //y2=1.39
r327 (  108 118 ) resistor r=10.701 //w=0.21 //l=0.115 //layer=ply \
 //thickness=0.18 //x=19.69 //y=1.545 //x2=19.575 //y2=1.545
r328 (  107 123 ) resistor r=5.52526 //w=0.168 //l=0.115 //layer=ply \
 //thickness=0.18 //x=19.91 //y=1.545 //x2=20.025 //y2=1.545
r329 (  106 117 ) resistor r=5.52526 //w=0.168 //l=0.115 //layer=ply \
 //thickness=0.18 //x=19.69 //y=0.89 //x2=19.575 //y2=0.89
r330 (  105 122 ) resistor r=5.52526 //w=0.168 //l=0.115 //layer=ply \
 //thickness=0.18 //x=19.91 //y=0.89 //x2=20.025 //y2=0.89
r331 (  105 106 ) resistor r=112.809 //w=0.094 //l=0.22 //layer=ply \
 //thickness=0.18 //x=19.91 //y=0.89 //x2=19.69 //y2=0.89
r332 (  102 119 ) resistor r=13.0941 //w=0.233 //l=0.165 //layer=ply \
 //thickness=0.18 //x=19.63 //y=5.045 //x2=19.63 //y2=4.88
r333 (  101 116 ) resistor r=34.8111 //w=0.27 //l=0.264953 //layer=ply \
 //thickness=0.18 //x=19.535 //y=2.095 //x2=19.73 //y2=2.26
r334 (  100 118 ) resistor r=39.5823 //w=0.21 //l=0.173853 //layer=ply \
 //thickness=0.18 //x=19.535 //y=1.7 //x2=19.575 //y2=1.545
r335 (  100 101 ) resistor r=202.543 //w=0.094 //l=0.395 //layer=ply \
 //thickness=0.18 //x=19.535 //y=1.7 //x2=19.535 //y2=2.095
r336 (  99 118 ) resistor r=39.5823 //w=0.21 //l=0.173853 //layer=ply \
 //thickness=0.18 //x=19.535 //y=1.39 //x2=19.575 //y2=1.545
r337 (  98 117 ) resistor r=45.1352 //w=0.168 //l=0.173853 //layer=ply \
 //thickness=0.18 //x=19.535 //y=1.045 //x2=19.575 //y2=0.89
r338 (  98 99 ) resistor r=176.904 //w=0.094 //l=0.345 //layer=ply \
 //thickness=0.18 //x=19.535 //y=1.045 //x2=19.535 //y2=1.39
r339 (  97 112 ) resistor r=592.245 //w=0.094 //l=1.155 //layer=ply \
 //thickness=0.18 //x=20.07 //y=6.2 //x2=20.07 //y2=5.045
r340 (  96 102 ) resistor r=592.245 //w=0.094 //l=1.155 //layer=ply \
 //thickness=0.18 //x=19.63 //y=6.2 //x2=19.63 //y2=5.045
r341 (  95 107 ) resistor r=56.4043 //w=0.094 //l=0.11 //layer=ply \
 //thickness=0.18 //x=19.8 //y=1.545 //x2=19.91 //y2=1.545
r342 (  95 108 ) resistor r=56.4043 //w=0.094 //l=0.11 //layer=ply \
 //thickness=0.18 //x=19.8 //y=1.545 //x2=19.69 //y2=1.545
r343 (  91 121 ) resistor r=152 //w=0.17 //l=0.17 //layer=licon //count=1 \
 //x=19.73 //y=4.88 //x2=19.73 //y2=4.88
r344 (  82 116 ) resistor r=152 //w=0.17 //l=0.17 //layer=licon //count=1 \
 //x=19.73 //y=2.26 //x2=19.73 //y2=2.26
r345 (  65 127 ) resistor r=23.615 //w=0.187 //l=0.345 //layer=li \
 //thickness=0.1 //x=17.4 //y=5.56 //x2=17.4 //y2=5.905
r346 (  57 126 ) resistor r=23.615 //w=0.187 //l=0.345 //layer=li \
 //thickness=0.1 //x=16.52 //y=5.56 //x2=16.52 //y2=5.905
r347 (  53 54 ) resistor r=0.10734 //w=0.281 //l=0.16 //layer=m2 \
 //thickness=0.36 //x=19.725 //y=3.865 //x2=19.565 //y2=3.865
r348 (  51 54 ) resistor r=1.45515 //w=0.131 //l=1.525 //layer=m2 \
 //thickness=0.36 //x=18.04 //y=3.88 //x2=19.565 //y2=3.88
r349 (  49 51 ) resistor r=0.10734 //w=0.281 //l=0.16 //layer=m2 \
 //thickness=0.36 //x=17.88 //y=3.865 //x2=18.04 //y2=3.865
r350 (  43 91 ) resistor r=9.3 //w=0.17 //l=0.17 //layer=mcon //count=1 \
 //x=19.73 //y=4.88 //x2=19.73 //y2=4.88
r351 (  43 44 ) resistor r=0.103207 //w=0.196 //l=0.14 //layer=m1 \
 //thickness=0.36 //x=19.732 //y=4.88 //x2=19.732 //y2=4.74
r352 (  40 82 ) resistor r=9.3 //w=0.17 //l=0.17 //layer=mcon //count=1 \
 //x=19.73 //y=2.26 //x2=19.73 //y2=2.26
r353 (  36 53 ) resistor r=4.5 //w=0.15 //l=0.15 //layer=via1 //count=1 \
 //x=19.725 //y=3.865 //x2=19.725 //y2=3.865
r354 (  36 38 ) resistor r=0.00501337 //w=0.374 //l=0.015 //layer=m1 \
 //thickness=0.36 //x=19.675 //y=3.865 //x2=19.675 //y2=3.88
r355 (  32 49 ) resistor r=4.5 //w=0.15 //l=0.15 //layer=via1 //count=1 \
 //x=17.88 //y=3.865 //x2=17.88 //y2=3.865
r356 (  32 34 ) resistor r=0.0049867 //w=0.376 //l=0.015 //layer=m1 \
 //thickness=0.36 //x=17.932 //y=3.865 //x2=17.932 //y2=3.88
r357 (  29 124 ) resistor r=9.3 //w=0.17 //l=0.17 //layer=mcon //count=1 \
 //x=17.44 //y=1.18 //x2=17.44 //y2=1.18
r358 (  27 65 ) resistor r=9.3 //w=0.17 //l=0.17 //layer=mcon //count=1 \
 //x=17.4 //y=5.56 //x2=17.4 //y2=5.56
r359 (  24 27 ) resistor r=0.117801 //w=0.191 //l=0.18 //layer=m1 \
 //thickness=0.36 //x=17.4 //y=5.38 //x2=17.4 //y2=5.56
r360 (  23 57 ) resistor r=9.3 //w=0.17 //l=0.17 //layer=mcon //count=1 \
 //x=16.52 //y=5.56 //x2=16.52 //y2=5.56
r361 (  21 23 ) resistor r=0.10274 //w=0.219 //l=0.18 //layer=m1 \
 //thickness=0.36 //x=16.52 //y=5.38 //x2=16.52 //y2=5.56
r362 (  19 38 ) resistor r=0.0860668 //w=0.374 //l=0.170294 //layer=m1 \
 //thickness=0.36 //x=19.73 //y=4.025 //x2=19.675 //y2=3.88
r363 (  19 44 ) resistor r=0.682252 //w=0.131 //l=0.715 //layer=m1 \
 //thickness=0.36 //x=19.73 //y=4.025 //x2=19.73 //y2=4.74
r364 (  18 36 ) resistor r=0.0910802 //w=0.374 //l=0.185472 //layer=m1 \
 //thickness=0.36 //x=19.73 //y=3.705 //x2=19.675 //y2=3.865
r365 (  17 40 ) resistor r=0.0933015 //w=0.201 //l=0.125 //layer=m1 \
 //thickness=0.36 //x=19.73 //y=2.385 //x2=19.73 //y2=2.26
r366 (  17 18 ) resistor r=1.25954 //w=0.131 //l=1.32 //layer=m1 \
 //thickness=0.36 //x=19.73 //y=2.385 //x2=19.73 //y2=3.705
r367 (  15 34 ) resistor r=0.0861726 //w=0.376 //l=0.169012 //layer=m1 \
 //thickness=0.36 //x=17.88 //y=4.025 //x2=17.932 //y2=3.88
r368 (  15 16 ) resistor r=1.21183 //w=0.131 //l=1.27 //layer=m1 \
 //thickness=0.36 //x=17.88 //y=4.025 //x2=17.88 //y2=5.295
r369 (  14 32 ) resistor r=0.0911593 //w=0.376 //l=0.184174 //layer=m1 \
 //thickness=0.36 //x=17.88 //y=3.705 //x2=17.932 //y2=3.865
r370 (  13 14 ) resistor r=1.70324 //w=0.131 //l=1.785 //layer=m1 \
 //thickness=0.36 //x=17.88 //y=1.92 //x2=17.88 //y2=3.705
r371 (  11 13 ) resistor r=0.0698411 //w=0.17 //l=0.120208 //layer=m1 \
 //thickness=0.36 //x=17.795 //y=1.835 //x2=17.88 //y2=1.92
r372 (  11 12 ) resistor r=0.257634 //w=0.131 //l=0.27 //layer=m1 \
 //thickness=0.36 //x=17.795 //y=1.835 //x2=17.525 //y2=1.835
r373 (  10 24 ) resistor r=0.0257089 //w=0.23 //l=0.115 //layer=m1 \
 //thickness=0.36 //x=17.515 //y=5.38 //x2=17.4 //y2=5.38
r374 (  9 16 ) resistor r=0.0698411 //w=0.17 //l=0.120208 //layer=m1 \
 //thickness=0.36 //x=17.795 //y=5.38 //x2=17.88 //y2=5.295
r375 (  9 10 ) resistor r=0.267176 //w=0.131 //l=0.28 //layer=m1 \
 //thickness=0.36 //x=17.795 //y=5.38 //x2=17.515 //y2=5.38
r376 (  8 12 ) resistor r=0.0698411 //w=0.17 //l=0.120208 //layer=m1 \
 //thickness=0.36 //x=17.44 //y=1.75 //x2=17.525 //y2=1.835
r377 (  7 29 ) resistor r=0.0913624 //w=0.191 //l=0.12 //layer=m1 \
 //thickness=0.36 //x=17.44 //y=1.3 //x2=17.44 //y2=1.18
r378 (  7 8 ) resistor r=0.429389 //w=0.131 //l=0.45 //layer=m1 \
 //thickness=0.36 //x=17.44 //y=1.3 //x2=17.44 //y2=1.75
r379 (  4 21 ) resistor r=0.0227762 //w=0.219 //l=0.115 //layer=m1 \
 //thickness=0.36 //x=16.635 //y=5.38 //x2=16.52 //y2=5.38
r380 (  3 24 ) resistor r=0.0257089 //w=0.23 //l=0.115 //layer=m1 \
 //thickness=0.36 //x=17.285 //y=5.38 //x2=17.4 //y2=5.38
r381 (  3 4 ) resistor r=0.620229 //w=0.131 //l=0.65 //layer=m1 \
 //thickness=0.36 //x=17.285 //y=5.38 //x2=16.635 //y2=5.38
ends PM_TMRDFFQX1\%noxref_4

subckt PM_TMRDFFQX1\%noxref_5 ( 1 2 3 4 6 7 8 11 16 17 19 20 22 23 24 26 27 28 \
 34 38 42 49 50 53 55 58 62 65 70 72 74 76 78 79 80 81 85 93 102 107 116 121 \
 129 146 155 159 160 161 162 163 164 165 166 167 168 169 170 171 172 174 180 \
 181 182 183 187 188 189 194 196 198 204 205 206 207 208 213 215 217 223 224 \
 234 235 238 247 248 251 259 261 262 )
c614 ( 259 0 ) capacitor c=0.00878249f //x=13.92 //y=1.085
c615 ( 251 0 ) capacitor c=0.0356006f //x=20.5 //y=4.88
c616 ( 248 0 ) capacitor c=0.0284095f //x=20.47 //y=2.095
c617 ( 247 0 ) capacitor c=0.0476356f //x=20.47 //y=2.26
c618 ( 238 0 ) capacitor c=0.0354915f //x=10.51 //y=4.88
c619 ( 235 0 ) capacitor c=0.0284095f //x=10.48 //y=2.095
c620 ( 234 0 ) capacitor c=0.0476356f //x=10.48 //y=2.26
c621 ( 224 0 ) capacitor c=0.0439708f //x=21.035 //y=1.43
c622 ( 223 0 ) capacitor c=0.0192582f //x=21.035 //y=1.085
c623 ( 217 0 ) capacitor c=0.0162526f //x=20.88 //y=1.585
c624 ( 215 0 ) capacitor c=0.0157807f //x=20.88 //y=0.93
c625 ( 213 0 ) capacitor c=0.0372668f //x=20.875 //y=4.97
c626 ( 208 0 ) capacitor c=0.0210762f //x=20.505 //y=1.74
c627 ( 207 0 ) capacitor c=0.0168511f //x=20.505 //y=1.43
c628 ( 206 0 ) capacitor c=0.0175485f //x=20.505 //y=1.085
c629 ( 205 0 ) capacitor c=0.0439708f //x=11.045 //y=1.43
c630 ( 204 0 ) capacitor c=0.0192582f //x=11.045 //y=1.085
c631 ( 198 0 ) capacitor c=0.0162526f //x=10.89 //y=1.585
c632 ( 196 0 ) capacitor c=0.0157807f //x=10.89 //y=0.93
c633 ( 194 0 ) capacitor c=0.0372668f //x=10.885 //y=4.97
c634 ( 189 0 ) capacitor c=0.0210762f //x=10.515 //y=1.74
c635 ( 188 0 ) capacitor c=0.0168511f //x=10.515 //y=1.43
c636 ( 187 0 ) capacitor c=0.0175485f //x=10.515 //y=1.085
c637 ( 183 0 ) capacitor c=0.0551643f //x=1.875 //y=4.97
c638 ( 182 0 ) capacitor c=0.0376038f //x=2.165 //y=4.97
c639 ( 181 0 ) capacitor c=0.0346489f //x=1.83 //y=1.4
c640 ( 180 0 ) capacitor c=0.018692f //x=1.83 //y=1.055
c641 ( 174 0 ) capacitor c=0.0137077f //x=1.675 //y=1.555
c642 ( 172 0 ) capacitor c=0.0158585f //x=1.675 //y=0.9
c643 ( 171 0 ) capacitor c=0.103534f //x=1.3 //y=2.095
c644 ( 170 0 ) capacitor c=0.0229444f //x=1.3 //y=1.71
c645 ( 169 0 ) capacitor c=0.0234359f //x=1.3 //y=1.4
c646 ( 168 0 ) capacitor c=0.019815f //x=1.3 //y=1.055
c647 ( 167 0 ) capacitor c=0.155269f //x=20.95 //y=6.2
c648 ( 166 0 ) capacitor c=0.110375f //x=20.51 //y=6.2
c649 ( 165 0 ) capacitor c=0.155269f //x=10.96 //y=6.2
c650 ( 164 0 ) capacitor c=0.110375f //x=10.52 //y=6.2
c651 ( 163 0 ) capacitor c=0.110208f //x=2.24 //y=6.2
c652 ( 162 0 ) capacitor c=0.158957f //x=1.8 //y=6.2
c653 ( 155 0 ) capacitor c=5.80994e-19 //x=20.5 //y=4.88
c654 ( 146 0 ) capacitor c=5.78095e-19 //x=20.47 //y=2.26
c655 ( 129 0 ) capacitor c=0.0319332f //x=14.07 //y=5.56
c656 ( 121 0 ) capacitor c=0.0291719f //x=13.19 //y=5.56
c657 ( 116 0 ) capacitor c=5.80994e-19 //x=10.51 //y=4.88
c658 ( 107 0 ) capacitor c=5.78095e-19 //x=10.48 //y=2.26
c659 ( 102 0 ) capacitor c=0.0012433f //x=1.6 //y=4.88
c660 ( 93 0 ) capacitor c=0.0012618f //x=1.6 //y=2.26
c661 ( 85 0 ) capacitor c=0.0110688f //x=1.765 //y=4.255
c662 ( 81 0 ) capacitor c=0.0200835f //x=16.27 //y=4.27
c663 ( 80 0 ) capacitor c=0.0408507f //x=16.615 //y=4.27
c664 ( 79 0 ) capacitor c=0.0344756f //x=10.645 //y=4.25
c665 ( 78 0 ) capacitor c=0.0338306f //x=14.38 //y=4.25
c666 ( 76 0 ) capacitor c=0.00147451f //x=6.62 //y=4.265
c667 ( 74 0 ) capacitor c=0.0153988f //x=6.02 //y=4.25
c668 ( 72 0 ) capacitor c=0.00416722f //x=4.775 //y=4.265
c669 ( 70 0 ) capacitor c=0.0677407f //x=4.175 //y=4.25
c670 ( 65 0 ) capacitor c=0.0066236f //x=20.47 //y=2.26
c671 ( 62 0 ) capacitor c=0.0150367f //x=20.47 //y=4.25
c672 ( 58 0 ) capacitor c=0.015184f //x=14.55 //y=4.25
c673 ( 55 0 ) capacitor c=0.0113735f //x=14.11 //y=1.18
c674 ( 53 0 ) capacitor c=5.78613e-19 //x=14.07 //y=5.56
c675 ( 50 0 ) capacitor c=0.00999937f //x=14.07 //y=5.38
c676 ( 49 0 ) capacitor c=0.00933207f //x=13.19 //y=5.56
c677 ( 42 0 ) capacitor c=0.00662515f //x=10.48 //y=2.26
c678 ( 38 0 ) capacitor c=0.0143744f //x=10.48 //y=4.25
c679 ( 34 0 ) capacitor c=0.0160407f //x=1.6 //y=4.25
c680 ( 28 0 ) capacitor c=0.00917813f //x=20.47 //y=4.735
c681 ( 27 0 ) capacitor c=0.00984584f //x=20.47 //y=4.41
c682 ( 26 0 ) capacitor c=0.0376132f //x=20.47 //y=4.09
c683 ( 24 0 ) capacitor c=0.0190547f //x=14.55 //y=5.295
c684 ( 23 0 ) capacitor c=0.012741f //x=14.55 //y=4.425
c685 ( 22 0 ) capacitor c=0.0596729f //x=14.55 //y=4.105
c686 ( 20 0 ) capacitor c=0.00560492f //x=14.195 //y=1.835
c687 ( 19 0 ) capacitor c=0.0131084f //x=14.465 //y=1.835
c688 ( 17 0 ) capacitor c=0.0101176f //x=14.465 //y=5.38
c689 ( 16 0 ) capacitor c=0.0101547f //x=14.11 //y=1.75
c690 ( 11 0 ) capacitor c=0.0142466f //x=13.955 //y=5.38
c691 ( 8 0 ) capacitor c=0.00908133f //x=10.48 //y=4.735
c692 ( 7 0 ) capacitor c=0.00995231f //x=10.48 //y=4.415
c693 ( 6 0 ) capacitor c=0.0361105f //x=10.48 //y=4.095
c694 ( 4 0 ) capacitor c=0.0228118f //x=1.6 //y=4.755
c695 ( 3 0 ) capacitor c=0.0128906f //x=1.6 //y=4.415
c696 ( 2 0 ) capacitor c=0.0862595f //x=1.6 //y=4.095
c697 ( 1 0 ) capacitor c=0.0113406f //x=1.6 //y=2.375
r698 (  253 254 ) resistor r=32.4568 //w=0.214 //l=0.075 //layer=ply \
 //thickness=0.18 //x=20.5 //y=4.97 //x2=20.5 //y2=5.045
r699 (  251 253 ) resistor r=20.271 //w=0.214 //l=0.09 //layer=ply \
 //thickness=0.18 //x=20.5 //y=4.88 //x2=20.5 //y2=4.97
r700 (  247 248 ) resistor r=52.7279 //w=0.214 //l=0.165 //layer=ply \
 //thickness=0.18 //x=20.47 //y=2.26 //x2=20.47 //y2=2.095
r701 (  240 241 ) resistor r=32.4568 //w=0.214 //l=0.075 //layer=ply \
 //thickness=0.18 //x=10.51 //y=4.97 //x2=10.51 //y2=5.045
r702 (  238 240 ) resistor r=20.271 //w=0.214 //l=0.09 //layer=ply \
 //thickness=0.18 //x=10.51 //y=4.88 //x2=10.51 //y2=4.97
r703 (  234 235 ) resistor r=52.7279 //w=0.214 //l=0.165 //layer=ply \
 //thickness=0.18 //x=10.48 //y=2.26 //x2=10.48 //y2=2.095
r704 (  224 258 ) resistor r=45.1352 //w=0.168 //l=0.173853 //layer=ply \
 //thickness=0.18 //x=21.035 //y=1.43 //x2=20.995 //y2=1.585
r705 (  223 257 ) resistor r=45.1352 //w=0.168 //l=0.173853 //layer=ply \
 //thickness=0.18 //x=21.035 //y=1.085 //x2=20.995 //y2=0.93
r706 (  223 224 ) resistor r=176.904 //w=0.094 //l=0.345 //layer=ply \
 //thickness=0.18 //x=21.035 //y=1.085 //x2=21.035 //y2=1.43
r707 (  218 256 ) resistor r=10.701 //w=0.21 //l=0.115 //layer=ply \
 //thickness=0.18 //x=20.66 //y=1.585 //x2=20.545 //y2=1.585
r708 (  217 258 ) resistor r=5.52526 //w=0.168 //l=0.115 //layer=ply \
 //thickness=0.18 //x=20.88 //y=1.585 //x2=20.995 //y2=1.585
r709 (  216 255 ) resistor r=5.52526 //w=0.168 //l=0.115 //layer=ply \
 //thickness=0.18 //x=20.66 //y=0.93 //x2=20.545 //y2=0.93
r710 (  215 257 ) resistor r=5.52526 //w=0.168 //l=0.115 //layer=ply \
 //thickness=0.18 //x=20.88 //y=0.93 //x2=20.995 //y2=0.93
r711 (  215 216 ) resistor r=112.809 //w=0.094 //l=0.22 //layer=ply \
 //thickness=0.18 //x=20.88 //y=0.93 //x2=20.66 //y2=0.93
r712 (  214 253 ) resistor r=16.5046 //w=0.27 //l=0.135 //layer=ply \
 //thickness=0.18 //x=20.635 //y=4.97 //x2=20.5 //y2=4.97
r713 (  213 220 ) resistor r=26.9307 //w=0.15 //l=0.106066 //layer=ply \
 //thickness=0.18 //x=20.875 //y=4.97 //x2=20.95 //y2=5.045
r714 (  213 214 ) resistor r=123.064 //w=0.094 //l=0.24 //layer=ply \
 //thickness=0.18 //x=20.875 //y=4.97 //x2=20.635 //y2=4.97
r715 (  208 256 ) resistor r=39.5823 //w=0.21 //l=0.173853 //layer=ply \
 //thickness=0.18 //x=20.505 //y=1.74 //x2=20.545 //y2=1.585
r716 (  208 248 ) resistor r=182.032 //w=0.094 //l=0.355 //layer=ply \
 //thickness=0.18 //x=20.505 //y=1.74 //x2=20.505 //y2=2.095
r717 (  207 256 ) resistor r=39.5823 //w=0.21 //l=0.173853 //layer=ply \
 //thickness=0.18 //x=20.505 //y=1.43 //x2=20.545 //y2=1.585
r718 (  206 255 ) resistor r=45.1352 //w=0.168 //l=0.173853 //layer=ply \
 //thickness=0.18 //x=20.505 //y=1.085 //x2=20.545 //y2=0.93
r719 (  206 207 ) resistor r=176.904 //w=0.094 //l=0.345 //layer=ply \
 //thickness=0.18 //x=20.505 //y=1.085 //x2=20.505 //y2=1.43
r720 (  205 245 ) resistor r=45.1352 //w=0.168 //l=0.173853 //layer=ply \
 //thickness=0.18 //x=11.045 //y=1.43 //x2=11.005 //y2=1.585
r721 (  204 244 ) resistor r=45.1352 //w=0.168 //l=0.173853 //layer=ply \
 //thickness=0.18 //x=11.045 //y=1.085 //x2=11.005 //y2=0.93
r722 (  204 205 ) resistor r=176.904 //w=0.094 //l=0.345 //layer=ply \
 //thickness=0.18 //x=11.045 //y=1.085 //x2=11.045 //y2=1.43
r723 (  199 243 ) resistor r=10.701 //w=0.21 //l=0.115 //layer=ply \
 //thickness=0.18 //x=10.67 //y=1.585 //x2=10.555 //y2=1.585
r724 (  198 245 ) resistor r=5.52526 //w=0.168 //l=0.115 //layer=ply \
 //thickness=0.18 //x=10.89 //y=1.585 //x2=11.005 //y2=1.585
r725 (  197 242 ) resistor r=5.52526 //w=0.168 //l=0.115 //layer=ply \
 //thickness=0.18 //x=10.67 //y=0.93 //x2=10.555 //y2=0.93
r726 (  196 244 ) resistor r=5.52526 //w=0.168 //l=0.115 //layer=ply \
 //thickness=0.18 //x=10.89 //y=0.93 //x2=11.005 //y2=0.93
r727 (  196 197 ) resistor r=112.809 //w=0.094 //l=0.22 //layer=ply \
 //thickness=0.18 //x=10.89 //y=0.93 //x2=10.67 //y2=0.93
r728 (  195 240 ) resistor r=16.5046 //w=0.27 //l=0.135 //layer=ply \
 //thickness=0.18 //x=10.645 //y=4.97 //x2=10.51 //y2=4.97
r729 (  194 201 ) resistor r=26.9307 //w=0.15 //l=0.106066 //layer=ply \
 //thickness=0.18 //x=10.885 //y=4.97 //x2=10.96 //y2=5.045
r730 (  194 195 ) resistor r=123.064 //w=0.094 //l=0.24 //layer=ply \
 //thickness=0.18 //x=10.885 //y=4.97 //x2=10.645 //y2=4.97
r731 (  189 243 ) resistor r=39.5823 //w=0.21 //l=0.173853 //layer=ply \
 //thickness=0.18 //x=10.515 //y=1.74 //x2=10.555 //y2=1.585
r732 (  189 235 ) resistor r=182.032 //w=0.094 //l=0.355 //layer=ply \
 //thickness=0.18 //x=10.515 //y=1.74 //x2=10.515 //y2=2.095
r733 (  188 243 ) resistor r=39.5823 //w=0.21 //l=0.173853 //layer=ply \
 //thickness=0.18 //x=10.515 //y=1.43 //x2=10.555 //y2=1.585
r734 (  187 242 ) resistor r=45.1352 //w=0.168 //l=0.173853 //layer=ply \
 //thickness=0.18 //x=10.515 //y=1.085 //x2=10.555 //y2=0.93
r735 (  187 188 ) resistor r=176.904 //w=0.094 //l=0.345 //layer=ply \
 //thickness=0.18 //x=10.515 //y=1.085 //x2=10.515 //y2=1.43
r736 (  182 184 ) resistor r=26.9307 //w=0.15 //l=0.106066 //layer=ply \
 //thickness=0.18 //x=2.165 //y=4.97 //x2=2.24 //y2=5.045
r737 (  182 183 ) resistor r=148.702 //w=0.094 //l=0.29 //layer=ply \
 //thickness=0.18 //x=2.165 //y=4.97 //x2=1.875 //y2=4.97
r738 (  181 232 ) resistor r=45.1352 //w=0.168 //l=0.173853 //layer=ply \
 //thickness=0.18 //x=1.83 //y=1.4 //x2=1.79 //y2=1.555
r739 (  180 231 ) resistor r=45.1352 //w=0.168 //l=0.173853 //layer=ply \
 //thickness=0.18 //x=1.83 //y=1.055 //x2=1.79 //y2=0.9
r740 (  180 181 ) resistor r=176.904 //w=0.094 //l=0.345 //layer=ply \
 //thickness=0.18 //x=1.83 //y=1.055 //x2=1.83 //y2=1.4
r741 (  177 183 ) resistor r=22.7971 //w=0.269 //l=0.106066 //layer=ply \
 //thickness=0.18 //x=1.8 //y=5.045 //x2=1.875 //y2=4.97
r742 (  177 230 ) resistor r=35.8364 //w=0.269 //l=0.270185 //layer=ply \
 //thickness=0.18 //x=1.8 //y=5.045 //x2=1.6 //y2=4.88
r743 (  175 226 ) resistor r=10.701 //w=0.21 //l=0.115 //layer=ply \
 //thickness=0.18 //x=1.455 //y=1.555 //x2=1.34 //y2=1.555
r744 (  174 232 ) resistor r=5.52526 //w=0.168 //l=0.115 //layer=ply \
 //thickness=0.18 //x=1.675 //y=1.555 //x2=1.79 //y2=1.555
r745 (  173 225 ) resistor r=5.52526 //w=0.168 //l=0.115 //layer=ply \
 //thickness=0.18 //x=1.455 //y=0.9 //x2=1.34 //y2=0.9
r746 (  172 231 ) resistor r=5.52526 //w=0.168 //l=0.115 //layer=ply \
 //thickness=0.18 //x=1.675 //y=0.9 //x2=1.79 //y2=0.9
r747 (  172 173 ) resistor r=112.809 //w=0.094 //l=0.22 //layer=ply \
 //thickness=0.18 //x=1.675 //y=0.9 //x2=1.455 //y2=0.9
r748 (  171 228 ) resistor r=58.7805 //w=0.246 //l=0.373497 //layer=ply \
 //thickness=0.18 //x=1.3 //y=2.095 //x2=1.6 //y2=2.26
r749 (  170 226 ) resistor r=39.5823 //w=0.21 //l=0.173853 //layer=ply \
 //thickness=0.18 //x=1.3 //y=1.71 //x2=1.34 //y2=1.555
r750 (  170 171 ) resistor r=197.415 //w=0.094 //l=0.385 //layer=ply \
 //thickness=0.18 //x=1.3 //y=1.71 //x2=1.3 //y2=2.095
r751 (  169 226 ) resistor r=39.5823 //w=0.21 //l=0.173853 //layer=ply \
 //thickness=0.18 //x=1.3 //y=1.4 //x2=1.34 //y2=1.555
r752 (  168 225 ) resistor r=45.1352 //w=0.168 //l=0.173853 //layer=ply \
 //thickness=0.18 //x=1.3 //y=1.055 //x2=1.34 //y2=0.9
r753 (  168 169 ) resistor r=176.904 //w=0.094 //l=0.345 //layer=ply \
 //thickness=0.18 //x=1.3 //y=1.055 //x2=1.3 //y2=1.4
r754 (  167 220 ) resistor r=592.245 //w=0.094 //l=1.155 //layer=ply \
 //thickness=0.18 //x=20.95 //y=6.2 //x2=20.95 //y2=5.045
r755 (  166 254 ) resistor r=592.245 //w=0.094 //l=1.155 //layer=ply \
 //thickness=0.18 //x=20.51 //y=6.2 //x2=20.51 //y2=5.045
r756 (  165 201 ) resistor r=592.245 //w=0.094 //l=1.155 //layer=ply \
 //thickness=0.18 //x=10.96 //y=6.2 //x2=10.96 //y2=5.045
r757 (  164 241 ) resistor r=592.245 //w=0.094 //l=1.155 //layer=ply \
 //thickness=0.18 //x=10.52 //y=6.2 //x2=10.52 //y2=5.045
r758 (  163 184 ) resistor r=592.245 //w=0.094 //l=1.155 //layer=ply \
 //thickness=0.18 //x=2.24 //y=6.2 //x2=2.24 //y2=5.045
r759 (  162 177 ) resistor r=592.245 //w=0.094 //l=1.155 //layer=ply \
 //thickness=0.18 //x=1.8 //y=6.2 //x2=1.8 //y2=5.045
r760 (  161 217 ) resistor r=56.4043 //w=0.094 //l=0.11 //layer=ply \
 //thickness=0.18 //x=20.77 //y=1.585 //x2=20.88 //y2=1.585
r761 (  161 218 ) resistor r=56.4043 //w=0.094 //l=0.11 //layer=ply \
 //thickness=0.18 //x=20.77 //y=1.585 //x2=20.66 //y2=1.585
r762 (  160 198 ) resistor r=56.4043 //w=0.094 //l=0.11 //layer=ply \
 //thickness=0.18 //x=10.78 //y=1.585 //x2=10.89 //y2=1.585
r763 (  160 199 ) resistor r=56.4043 //w=0.094 //l=0.11 //layer=ply \
 //thickness=0.18 //x=10.78 //y=1.585 //x2=10.67 //y2=1.585
r764 (  159 174 ) resistor r=56.4043 //w=0.094 //l=0.11 //layer=ply \
 //thickness=0.18 //x=1.565 //y=1.555 //x2=1.675 //y2=1.555
r765 (  159 175 ) resistor r=56.4043 //w=0.094 //l=0.11 //layer=ply \
 //thickness=0.18 //x=1.565 //y=1.555 //x2=1.455 //y2=1.555
r766 (  155 251 ) resistor r=152 //w=0.17 //l=0.17 //layer=licon //count=1 \
 //x=20.5 //y=4.88 //x2=20.5 //y2=4.88
r767 (  146 247 ) resistor r=152 //w=0.17 //l=0.17 //layer=licon //count=1 \
 //x=20.47 //y=2.26 //x2=20.47 //y2=2.26
r768 (  129 262 ) resistor r=23.615 //w=0.187 //l=0.345 //layer=li \
 //thickness=0.1 //x=14.07 //y=5.56 //x2=14.07 //y2=5.905
r769 (  121 261 ) resistor r=23.615 //w=0.187 //l=0.345 //layer=li \
 //thickness=0.1 //x=13.19 //y=5.56 //x2=13.19 //y2=5.905
r770 (  116 238 ) resistor r=152 //w=0.17 //l=0.17 //layer=licon //count=1 \
 //x=10.51 //y=4.88 //x2=10.51 //y2=4.88
r771 (  107 234 ) resistor r=152 //w=0.17 //l=0.17 //layer=licon //count=1 \
 //x=10.48 //y=2.26 //x2=10.48 //y2=2.26
r772 (  102 230 ) resistor r=152 //w=0.17 //l=0.17 //layer=licon //count=1 \
 //x=1.6 //y=4.88 //x2=1.6 //y2=4.88
r773 (  93 228 ) resistor r=152 //w=0.17 //l=0.17 //layer=licon //count=1 \
 //x=1.6 //y=2.26 //x2=1.6 //y2=2.26
r774 (  83 85 ) resistor r=0.10734 //w=0.281 //l=0.16 //layer=m2 \
 //thickness=0.36 //x=1.605 //y=4.255 //x2=1.765 //y2=4.255
r775 (  81 89 ) resistor r=1.10585 //w=0.196 //l=1.7325 //layer=m2 \
 //thickness=0.36 //x=16.27 //y=4.27 //x2=14.54 //y2=4.265
r776 (  80 91 ) resistor r=2.64838 //w=0.182 //l=3.86499 //layer=m2 \
 //thickness=0.36 //x=16.615 //y=4.27 //x2=20.47 //y2=4.25
r777 (  80 81 ) resistor r=0.329198 //w=0.131 //l=0.345 //layer=m2 \
 //thickness=0.36 //x=16.615 //y=4.27 //x2=16.27 //y2=4.27
r778 (  79 87 ) resistor r=0.110608 //w=0.182 //l=0.162481 //layer=m2 \
 //thickness=0.36 //x=10.645 //y=4.25 //x2=10.485 //y2=4.255
r779 (  78 89 ) resistor r=0.104578 //w=0.196 //l=0.167332 //layer=m2 \
 //thickness=0.36 //x=14.38 //y=4.25 //x2=14.54 //y2=4.265
r780 (  78 79 ) resistor r=3.56393 //w=0.131 //l=3.735 //layer=m2 \
 //thickness=0.36 //x=14.38 //y=4.25 //x2=10.645 //y2=4.25
r781 (  76 87 ) resistor r=2.65525 //w=0.182 //l=3.87 //layer=m2 \
 //thickness=0.36 //x=6.62 //y=4.265 //x2=10.485 //y2=4.255
r782 (  76 77 ) resistor r=0.329198 //w=0.131 //l=0.345 //layer=m2 \
 //thickness=0.36 //x=6.62 //y=4.265 //x2=6.275 //y2=4.265
r783 (  74 77 ) resistor r=0.1875 //w=0.17 //l=0.262393 //layer=m2 \
 //thickness=0.36 //x=6.02 //y=4.25 //x2=6.275 //y2=4.265
r784 (  74 75 ) resistor r=1.02576 //w=0.131 //l=1.075 //layer=m2 \
 //thickness=0.36 //x=6.02 //y=4.25 //x2=4.945 //y2=4.25
r785 (  72 75 ) resistor r=0.125 //w=0.17 //l=0.177341 //layer=m2 \
 //thickness=0.36 //x=4.775 //y=4.265 //x2=4.945 //y2=4.25
r786 (  72 73 ) resistor r=0.329198 //w=0.131 //l=0.345 //layer=m2 \
 //thickness=0.36 //x=4.775 //y=4.265 //x2=4.43 //y2=4.265
r787 (  70 73 ) resistor r=0.1875 //w=0.17 //l=0.262393 //layer=m2 \
 //thickness=0.36 //x=4.175 //y=4.25 //x2=4.43 //y2=4.265
r788 (  70 85 ) resistor r=2.29962 //w=0.131 //l=2.41 //layer=m2 \
 //thickness=0.36 //x=4.175 //y=4.25 //x2=1.765 //y2=4.25
r789 (  69 155 ) resistor r=9.3 //w=0.17 //l=0.17 //layer=mcon //count=1 \
 //x=20.5 //y=4.88 //x2=20.5 //y2=4.88
r790 (  65 146 ) resistor r=9.3 //w=0.17 //l=0.17 //layer=mcon //count=1 \
 //x=20.47 //y=2.26 //x2=20.47 //y2=2.26
r791 (  65 67 ) resistor r=0.0936408 //w=0.196 //l=0.125 //layer=m1 \
 //thickness=0.36 //x=20.472 //y=2.26 //x2=20.472 //y2=2.385
r792 (  62 91 ) resistor r=4.5 //w=0.15 //l=0.15 //layer=via1 //count=1 \
 //x=20.47 //y=4.25 //x2=20.47 //y2=4.25
r793 (  60 89 ) resistor r=4.5 //w=0.15 //l=0.15 //layer=via1 //count=1 \
 //x=14.54 //y=4.265 //x2=14.54 //y2=4.265
r794 (  58 60 ) resistor r=0.00505391 //w=0.371 //l=0.015 //layer=m1 \
 //thickness=0.36 //x=14.492 //y=4.25 //x2=14.492 //y2=4.265
r795 (  55 259 ) resistor r=9.3 //w=0.17 //l=0.17 //layer=mcon //count=1 \
 //x=14.11 //y=1.18 //x2=14.11 //y2=1.18
r796 (  53 129 ) resistor r=9.3 //w=0.17 //l=0.17 //layer=mcon //count=1 \
 //x=14.07 //y=5.56 //x2=14.07 //y2=5.56
r797 (  50 53 ) resistor r=0.117801 //w=0.191 //l=0.18 //layer=m1 \
 //thickness=0.36 //x=14.07 //y=5.38 //x2=14.07 //y2=5.56
r798 (  49 121 ) resistor r=9.3 //w=0.17 //l=0.17 //layer=mcon //count=1 \
 //x=13.19 //y=5.56 //x2=13.19 //y2=5.56
r799 (  47 49 ) resistor r=0.10274 //w=0.219 //l=0.18 //layer=m1 \
 //thickness=0.36 //x=13.19 //y=5.38 //x2=13.19 //y2=5.56
r800 (  46 116 ) resistor r=9.3 //w=0.17 //l=0.17 //layer=mcon //count=1 \
 //x=10.51 //y=4.88 //x2=10.51 //y2=4.88
r801 (  42 107 ) resistor r=9.3 //w=0.17 //l=0.17 //layer=mcon //count=1 \
 //x=10.48 //y=2.26 //x2=10.48 //y2=2.26
r802 (  42 44 ) resistor r=0.0936408 //w=0.196 //l=0.125 //layer=m1 \
 //thickness=0.36 //x=10.482 //y=2.26 //x2=10.482 //y2=2.385
r803 (  40 87 ) resistor r=4.5 //w=0.15 //l=0.15 //layer=via1 //count=1 \
 //x=10.485 //y=4.255 //x2=10.485 //y2=4.255
r804 (  38 40 ) resistor r=0.00164908 //w=0.379 //l=0.005 //layer=m1 \
 //thickness=0.36 //x=10.43 //y=4.25 //x2=10.43 //y2=4.255
r805 (  36 83 ) resistor r=4.5 //w=0.15 //l=0.15 //layer=via1 //count=1 \
 //x=1.605 //y=4.255 //x2=1.605 //y2=4.255
r806 (  34 36 ) resistor r=0.00167112 //w=0.374 //l=0.005 //layer=m1 \
 //thickness=0.36 //x=1.655 //y=4.25 //x2=1.655 //y2=4.255
r807 (  32 102 ) resistor r=9.3 //w=0.17 //l=0.17 //layer=mcon //count=1 \
 //x=1.6 //y=4.88 //x2=1.6 //y2=4.88
r808 (  30 93 ) resistor r=9.3 //w=0.17 //l=0.17 //layer=mcon //count=1 \
 //x=1.6 //y=2.26 //x2=1.6 //y2=2.26
r809 (  28 69 ) resistor r=0.0878548 //w=0.228 //l=0.159295 //layer=m1 \
 //thickness=0.36 //x=20.47 //y=4.735 //x2=20.5 //y2=4.88
r810 (  27 62 ) resistor r=0.0911593 //w=0.376 //l=0.184608 //layer=m1 \
 //thickness=0.36 //x=20.47 //y=4.41 //x2=20.417 //y2=4.25
r811 (  27 28 ) resistor r=0.310115 //w=0.131 //l=0.325 //layer=m1 \
 //thickness=0.36 //x=20.47 //y=4.41 //x2=20.47 //y2=4.735
r812 (  26 62 ) resistor r=0.0911593 //w=0.376 //l=0.184608 //layer=m1 \
 //thickness=0.36 //x=20.47 //y=4.09 //x2=20.417 //y2=4.25
r813 (  26 67 ) resistor r=1.62691 //w=0.131 //l=1.705 //layer=m1 \
 //thickness=0.36 //x=20.47 //y=4.09 //x2=20.47 //y2=2.385
r814 (  23 60 ) resistor r=0.0909648 //w=0.371 //l=0.186762 //layer=m1 \
 //thickness=0.36 //x=14.55 //y=4.425 //x2=14.492 //y2=4.265
r815 (  23 24 ) resistor r=0.830153 //w=0.131 //l=0.87 //layer=m1 \
 //thickness=0.36 //x=14.55 //y=4.425 //x2=14.55 //y2=5.295
r816 (  22 58 ) resistor r=0.0859108 //w=0.371 //l=0.171566 //layer=m1 \
 //thickness=0.36 //x=14.55 //y=4.105 //x2=14.492 //y2=4.25
r817 (  21 22 ) resistor r=2.08492 //w=0.131 //l=2.185 //layer=m1 \
 //thickness=0.36 //x=14.55 //y=1.92 //x2=14.55 //y2=4.105
r818 (  19 21 ) resistor r=0.0698411 //w=0.17 //l=0.120208 //layer=m1 \
 //thickness=0.36 //x=14.465 //y=1.835 //x2=14.55 //y2=1.92
r819 (  19 20 ) resistor r=0.257634 //w=0.131 //l=0.27 //layer=m1 \
 //thickness=0.36 //x=14.465 //y=1.835 //x2=14.195 //y2=1.835
r820 (  18 50 ) resistor r=0.0257089 //w=0.23 //l=0.115 //layer=m1 \
 //thickness=0.36 //x=14.185 //y=5.38 //x2=14.07 //y2=5.38
r821 (  17 24 ) resistor r=0.0698411 //w=0.17 //l=0.120208 //layer=m1 \
 //thickness=0.36 //x=14.465 //y=5.38 //x2=14.55 //y2=5.295
r822 (  17 18 ) resistor r=0.267176 //w=0.131 //l=0.28 //layer=m1 \
 //thickness=0.36 //x=14.465 //y=5.38 //x2=14.185 //y2=5.38
r823 (  16 20 ) resistor r=0.0698411 //w=0.17 //l=0.120208 //layer=m1 \
 //thickness=0.36 //x=14.11 //y=1.75 //x2=14.195 //y2=1.835
r824 (  15 55 ) resistor r=0.0913624 //w=0.191 //l=0.12 //layer=m1 \
 //thickness=0.36 //x=14.11 //y=1.3 //x2=14.11 //y2=1.18
r825 (  15 16 ) resistor r=0.429389 //w=0.131 //l=0.45 //layer=m1 \
 //thickness=0.36 //x=14.11 //y=1.3 //x2=14.11 //y2=1.75
r826 (  12 47 ) resistor r=0.0227762 //w=0.219 //l=0.115 //layer=m1 \
 //thickness=0.36 //x=13.305 //y=5.38 //x2=13.19 //y2=5.38
r827 (  11 50 ) resistor r=0.0257089 //w=0.23 //l=0.115 //layer=m1 \
 //thickness=0.36 //x=13.955 //y=5.38 //x2=14.07 //y2=5.38
r828 (  11 12 ) resistor r=0.620229 //w=0.131 //l=0.65 //layer=m1 \
 //thickness=0.36 //x=13.955 //y=5.38 //x2=13.305 //y2=5.38
r829 (  8 46 ) resistor r=0.0878548 //w=0.228 //l=0.159295 //layer=m1 \
 //thickness=0.36 //x=10.48 //y=4.735 //x2=10.51 //y2=4.88
r830 (  7 40 ) resistor r=0.0912814 //w=0.379 //l=0.183303 //layer=m1 \
 //thickness=0.36 //x=10.48 //y=4.415 //x2=10.43 //y2=4.255
r831 (  7 8 ) resistor r=0.305344 //w=0.131 //l=0.32 //layer=m1 \
 //thickness=0.36 //x=10.48 //y=4.415 //x2=10.48 //y2=4.735
r832 (  6 38 ) resistor r=0.0896323 //w=0.379 //l=0.178255 //layer=m1 \
 //thickness=0.36 //x=10.48 //y=4.095 //x2=10.43 //y2=4.25
r833 (  6 44 ) resistor r=1.63168 //w=0.131 //l=1.71 //layer=m1 \
 //thickness=0.36 //x=10.48 //y=4.095 //x2=10.48 //y2=2.385
r834 (  4 32 ) resistor r=0.0760407 //w=0.238 //l=0.125 //layer=m1 \
 //thickness=0.36 //x=1.6 //y=4.755 //x2=1.6 //y2=4.88
r835 (  3 36 ) resistor r=0.0910802 //w=0.374 //l=0.185472 //layer=m1 \
 //thickness=0.36 //x=1.6 //y=4.415 //x2=1.655 //y2=4.255
r836 (  3 4 ) resistor r=0.324427 //w=0.131 //l=0.34 //layer=m1 \
 //thickness=0.36 //x=1.6 //y=4.415 //x2=1.6 //y2=4.755
r837 (  2 34 ) resistor r=0.089409 //w=0.374 //l=0.180416 //layer=m1 \
 //thickness=0.36 //x=1.6 //y=4.095 //x2=1.655 //y2=4.25
r838 (  1 30 ) resistor r=0.0719237 //w=0.222 //l=0.115 //layer=m1 \
 //thickness=0.36 //x=1.6 //y=2.375 //x2=1.6 //y2=2.26
r839 (  1 2 ) resistor r=1.64122 //w=0.131 //l=1.72 //layer=m1 \
 //thickness=0.36 //x=1.6 //y=2.375 //x2=1.6 //y2=4.095
ends PM_TMRDFFQX1\%noxref_5

subckt PM_TMRDFFQX1\%noxref_6 ( 1 2 3 4 7 12 13 15 16 18 19 20 22 23 30 34 35 \
 38 40 43 48 50 53 54 56 57 58 60 62 65 72 73 76 85 90 98 115 124 128 129 130 \
 131 132 133 137 138 139 144 146 149 150 151 152 153 154 158 160 163 164 169 \
 170 175 184 187 189 190 )
c441 ( 187 0 ) capacitor c=0.00878249f //x=28.72 //y=1.085
c442 ( 184 0 ) capacitor c=0.0682508f //x=31.2 //y=4.88
c443 ( 175 0 ) capacitor c=0.0710066f //x=25.28 //y=4.88
c444 ( 170 0 ) capacitor c=0.0278202f //x=25.28 //y=2.095
c445 ( 169 0 ) capacitor c=0.0479324f //x=25.28 //y=2.26
c446 ( 164 0 ) capacitor c=0.0318956f //x=31.535 //y=1.39
c447 ( 163 0 ) capacitor c=0.0186809f //x=31.535 //y=1.045
c448 ( 160 0 ) capacitor c=0.0141821f //x=31.38 //y=1.545
c449 ( 158 0 ) capacitor c=0.0158553f //x=31.38 //y=0.89
c450 ( 154 0 ) capacitor c=0.0854171f //x=31.005 //y=2.095
c451 ( 153 0 ) capacitor c=0.0229235f //x=31.005 //y=1.7
c452 ( 152 0 ) capacitor c=0.0234359f //x=31.005 //y=1.39
c453 ( 151 0 ) capacitor c=0.0198759f //x=31.005 //y=1.045
c454 ( 150 0 ) capacitor c=0.0443175f //x=25.8 //y=1.44
c455 ( 149 0 ) capacitor c=0.0199703f //x=25.8 //y=1.095
c456 ( 146 0 ) capacitor c=0.0162526f //x=25.645 //y=1.595
c457 ( 144 0 ) capacitor c=0.0157807f //x=25.645 //y=0.94
c458 ( 139 0 ) capacitor c=0.0220935f //x=25.27 //y=1.75
c459 ( 138 0 ) capacitor c=0.0207489f //x=25.27 //y=1.44
c460 ( 137 0 ) capacitor c=0.0194091f //x=25.27 //y=1.095
c461 ( 133 0 ) capacitor c=0.110369f //x=31.54 //y=6.2
c462 ( 132 0 ) capacitor c=0.154619f //x=31.1 //y=6.2
c463 ( 131 0 ) capacitor c=0.159671f //x=25.46 //y=6.2
c464 ( 130 0 ) capacitor c=0.110208f //x=25.02 //y=6.2
c465 ( 124 0 ) capacitor c=8.13425e-19 //x=31.2 //y=4.88
c466 ( 115 0 ) capacitor c=7.85889e-19 //x=31.2 //y=2.26
c467 ( 98 0 ) capacitor c=0.0322017f //x=28.87 //y=5.56
c468 ( 90 0 ) capacitor c=0.0290186f //x=27.99 //y=5.56
c469 ( 85 0 ) capacitor c=8.10944e-19 //x=25.28 //y=4.88
c470 ( 76 0 ) capacitor c=0.00101179f //x=25.28 //y=2.26
c471 ( 73 0 ) capacitor c=0.0202533f //x=31.035 //y=3.505
c472 ( 72 0 ) capacitor c=4.79889e-19 //x=31.195 //y=3.505
c473 ( 65 0 ) capacitor c=0.00841868f //x=29.505 //y=3.51
c474 ( 62 0 ) capacitor c=0.00209252f //x=28.08 //y=3.495
c475 ( 60 0 ) capacitor c=0.0155233f //x=27.48 //y=3.51
c476 ( 58 0 ) capacitor c=0.00615643f //x=26.235 //y=3.495
c477 ( 57 0 ) capacitor c=6.32236e-19 //x=25.445 //y=3.51
c478 ( 56 0 ) capacitor c=0.00294384f //x=25.635 //y=3.51
c479 ( 54 0 ) capacitor c=0.0267491f //x=31.202 //y=4.74
c480 ( 53 0 ) capacitor c=0.00611287f //x=31.2 //y=4.88
c481 ( 50 0 ) capacitor c=0.0064096f //x=31.2 //y=2.26
c482 ( 48 0 ) capacitor c=0.0163473f //x=31.2 //y=3.51
c483 ( 43 0 ) capacitor c=0.0170489f //x=29.345 //y=3.51
c484 ( 40 0 ) capacitor c=0.0111664f //x=28.91 //y=1.18
c485 ( 38 0 ) capacitor c=5.78613e-19 //x=28.87 //y=5.56
c486 ( 35 0 ) capacitor c=0.0115917f //x=28.87 //y=5.38
c487 ( 34 0 ) capacitor c=0.00923791f //x=27.99 //y=5.56
c488 ( 30 0 ) capacitor c=0.0148558f //x=25.28 //y=3.51
c489 ( 23 0 ) capacitor c=0.0131975f //x=31.2 //y=3.665
c490 ( 22 0 ) capacitor c=0.025486f //x=31.2 //y=3.345
c491 ( 20 0 ) capacitor c=0.0405845f //x=29.35 //y=5.295
c492 ( 19 0 ) capacitor c=0.0134427f //x=29.35 //y=3.67
c493 ( 18 0 ) capacitor c=0.0352651f //x=29.35 //y=3.35
c494 ( 16 0 ) capacitor c=0.00504728f //x=28.995 //y=1.835
c495 ( 15 0 ) capacitor c=0.0126369f //x=29.265 //y=1.835
c496 ( 13 0 ) capacitor c=0.0108105f //x=29.265 //y=5.38
c497 ( 12 0 ) capacitor c=0.0102514f //x=28.91 //y=1.75
c498 ( 7 0 ) capacitor c=0.0146317f //x=28.755 //y=5.38
c499 ( 4 0 ) capacitor c=0.0286377f //x=25.28 //y=4.75
c500 ( 3 0 ) capacitor c=0.0126097f //x=25.28 //y=3.67
c501 ( 2 0 ) capacitor c=0.023917f //x=25.28 //y=3.35
c502 ( 1 0 ) capacitor c=0.00685053f //x=25.28 //y=2.375
r503 (  182 184 ) resistor r=20.6867 //w=0.233 //l=0.1 //layer=ply \
 //thickness=0.18 //x=31.1 //y=4.88 //x2=31.2 //y2=4.88
r504 (  169 170 ) resistor r=52.7279 //w=0.214 //l=0.165 //layer=ply \
 //thickness=0.18 //x=25.28 //y=2.26 //x2=25.28 //y2=2.095
r505 (  165 184 ) resistor r=70.3348 //w=0.233 //l=0.414367 //layer=ply \
 //thickness=0.18 //x=31.54 //y=5.045 //x2=31.2 //y2=4.88
r506 (  164 186 ) resistor r=45.1352 //w=0.168 //l=0.173853 //layer=ply \
 //thickness=0.18 //x=31.535 //y=1.39 //x2=31.495 //y2=1.545
r507 (  163 185 ) resistor r=45.1352 //w=0.168 //l=0.173853 //layer=ply \
 //thickness=0.18 //x=31.535 //y=1.045 //x2=31.495 //y2=0.89
r508 (  163 164 ) resistor r=176.904 //w=0.094 //l=0.345 //layer=ply \
 //thickness=0.18 //x=31.535 //y=1.045 //x2=31.535 //y2=1.39
r509 (  161 181 ) resistor r=10.701 //w=0.21 //l=0.115 //layer=ply \
 //thickness=0.18 //x=31.16 //y=1.545 //x2=31.045 //y2=1.545
r510 (  160 186 ) resistor r=5.52526 //w=0.168 //l=0.115 //layer=ply \
 //thickness=0.18 //x=31.38 //y=1.545 //x2=31.495 //y2=1.545
r511 (  159 180 ) resistor r=5.52526 //w=0.168 //l=0.115 //layer=ply \
 //thickness=0.18 //x=31.16 //y=0.89 //x2=31.045 //y2=0.89
r512 (  158 185 ) resistor r=5.52526 //w=0.168 //l=0.115 //layer=ply \
 //thickness=0.18 //x=31.38 //y=0.89 //x2=31.495 //y2=0.89
r513 (  158 159 ) resistor r=112.809 //w=0.094 //l=0.22 //layer=ply \
 //thickness=0.18 //x=31.38 //y=0.89 //x2=31.16 //y2=0.89
r514 (  155 182 ) resistor r=13.0941 //w=0.233 //l=0.165 //layer=ply \
 //thickness=0.18 //x=31.1 //y=5.045 //x2=31.1 //y2=4.88
r515 (  154 179 ) resistor r=34.8111 //w=0.27 //l=0.264953 //layer=ply \
 //thickness=0.18 //x=31.005 //y=2.095 //x2=31.2 //y2=2.26
r516 (  153 181 ) resistor r=39.5823 //w=0.21 //l=0.173853 //layer=ply \
 //thickness=0.18 //x=31.005 //y=1.7 //x2=31.045 //y2=1.545
r517 (  153 154 ) resistor r=202.543 //w=0.094 //l=0.395 //layer=ply \
 //thickness=0.18 //x=31.005 //y=1.7 //x2=31.005 //y2=2.095
r518 (  152 181 ) resistor r=39.5823 //w=0.21 //l=0.173853 //layer=ply \
 //thickness=0.18 //x=31.005 //y=1.39 //x2=31.045 //y2=1.545
r519 (  151 180 ) resistor r=45.1352 //w=0.168 //l=0.173853 //layer=ply \
 //thickness=0.18 //x=31.005 //y=1.045 //x2=31.045 //y2=0.89
r520 (  151 152 ) resistor r=176.904 //w=0.094 //l=0.345 //layer=ply \
 //thickness=0.18 //x=31.005 //y=1.045 //x2=31.005 //y2=1.39
r521 (  150 177 ) resistor r=45.1352 //w=0.168 //l=0.173853 //layer=ply \
 //thickness=0.18 //x=25.8 //y=1.44 //x2=25.76 //y2=1.595
r522 (  149 176 ) resistor r=45.1352 //w=0.168 //l=0.173853 //layer=ply \
 //thickness=0.18 //x=25.8 //y=1.095 //x2=25.76 //y2=0.94
r523 (  149 150 ) resistor r=176.904 //w=0.094 //l=0.345 //layer=ply \
 //thickness=0.18 //x=25.8 //y=1.095 //x2=25.8 //y2=1.44
r524 (  147 173 ) resistor r=10.701 //w=0.21 //l=0.115 //layer=ply \
 //thickness=0.18 //x=25.425 //y=1.595 //x2=25.31 //y2=1.595
r525 (  146 177 ) resistor r=5.52526 //w=0.168 //l=0.115 //layer=ply \
 //thickness=0.18 //x=25.645 //y=1.595 //x2=25.76 //y2=1.595
r526 (  145 172 ) resistor r=5.52526 //w=0.168 //l=0.115 //layer=ply \
 //thickness=0.18 //x=25.425 //y=0.94 //x2=25.31 //y2=0.94
r527 (  144 176 ) resistor r=5.52526 //w=0.168 //l=0.115 //layer=ply \
 //thickness=0.18 //x=25.645 //y=0.94 //x2=25.76 //y2=0.94
r528 (  144 145 ) resistor r=112.809 //w=0.094 //l=0.22 //layer=ply \
 //thickness=0.18 //x=25.645 //y=0.94 //x2=25.425 //y2=0.94
r529 (  141 175 ) resistor r=37.236 //w=0.233 //l=0.249199 //layer=ply \
 //thickness=0.18 //x=25.46 //y=5.045 //x2=25.28 //y2=4.88
r530 (  139 173 ) resistor r=39.5823 //w=0.21 //l=0.173853 //layer=ply \
 //thickness=0.18 //x=25.27 //y=1.75 //x2=25.31 //y2=1.595
r531 (  139 170 ) resistor r=176.904 //w=0.094 //l=0.345 //layer=ply \
 //thickness=0.18 //x=25.27 //y=1.75 //x2=25.27 //y2=2.095
r532 (  138 173 ) resistor r=39.5823 //w=0.21 //l=0.173853 //layer=ply \
 //thickness=0.18 //x=25.27 //y=1.44 //x2=25.31 //y2=1.595
r533 (  137 172 ) resistor r=45.1352 //w=0.168 //l=0.173853 //layer=ply \
 //thickness=0.18 //x=25.27 //y=1.095 //x2=25.31 //y2=0.94
r534 (  137 138 ) resistor r=176.904 //w=0.094 //l=0.345 //layer=ply \
 //thickness=0.18 //x=25.27 //y=1.095 //x2=25.27 //y2=1.44
r535 (  134 175 ) resistor r=53.7854 //w=0.233 //l=0.332415 //layer=ply \
 //thickness=0.18 //x=25.02 //y=5.045 //x2=25.28 //y2=4.88
r536 (  133 165 ) resistor r=592.245 //w=0.094 //l=1.155 //layer=ply \
 //thickness=0.18 //x=31.54 //y=6.2 //x2=31.54 //y2=5.045
r537 (  132 155 ) resistor r=592.245 //w=0.094 //l=1.155 //layer=ply \
 //thickness=0.18 //x=31.1 //y=6.2 //x2=31.1 //y2=5.045
r538 (  131 141 ) resistor r=592.245 //w=0.094 //l=1.155 //layer=ply \
 //thickness=0.18 //x=25.46 //y=6.2 //x2=25.46 //y2=5.045
r539 (  130 134 ) resistor r=592.245 //w=0.094 //l=1.155 //layer=ply \
 //thickness=0.18 //x=25.02 //y=6.2 //x2=25.02 //y2=5.045
r540 (  129 160 ) resistor r=56.4043 //w=0.094 //l=0.11 //layer=ply \
 //thickness=0.18 //x=31.27 //y=1.545 //x2=31.38 //y2=1.545
r541 (  129 161 ) resistor r=56.4043 //w=0.094 //l=0.11 //layer=ply \
 //thickness=0.18 //x=31.27 //y=1.545 //x2=31.16 //y2=1.545
r542 (  128 146 ) resistor r=56.4043 //w=0.094 //l=0.11 //layer=ply \
 //thickness=0.18 //x=25.535 //y=1.595 //x2=25.645 //y2=1.595
r543 (  128 147 ) resistor r=56.4043 //w=0.094 //l=0.11 //layer=ply \
 //thickness=0.18 //x=25.535 //y=1.595 //x2=25.425 //y2=1.595
r544 (  124 184 ) resistor r=152 //w=0.17 //l=0.17 //layer=licon //count=1 \
 //x=31.2 //y=4.88 //x2=31.2 //y2=4.88
r545 (  115 179 ) resistor r=152 //w=0.17 //l=0.17 //layer=licon //count=1 \
 //x=31.2 //y=2.26 //x2=31.2 //y2=2.26
r546 (  98 190 ) resistor r=23.615 //w=0.187 //l=0.345 //layer=li \
 //thickness=0.1 //x=28.87 //y=5.56 //x2=28.87 //y2=5.905
r547 (  90 189 ) resistor r=23.615 //w=0.187 //l=0.345 //layer=li \
 //thickness=0.1 //x=27.99 //y=5.56 //x2=27.99 //y2=5.905
r548 (  85 175 ) resistor r=152 //w=0.17 //l=0.17 //layer=licon //count=1 \
 //x=25.28 //y=4.88 //x2=25.28 //y2=4.88
r549 (  76 169 ) resistor r=152 //w=0.17 //l=0.17 //layer=licon //count=1 \
 //x=25.28 //y=2.26 //x2=25.28 //y2=2.26
r550 (  72 73 ) resistor r=0.10734 //w=0.281 //l=0.16 //layer=m2 \
 //thickness=0.36 //x=31.195 //y=3.505 //x2=31.035 //y2=3.505
r551 (  65 70 ) resistor r=0.10188 //w=0.204 //l=0.16 //layer=m2 \
 //thickness=0.36 //x=29.505 //y=3.51 //x2=29.345 //y2=3.51
r552 (  65 73 ) resistor r=1.45992 //w=0.131 //l=1.53 //layer=m2 \
 //thickness=0.36 //x=29.505 //y=3.51 //x2=31.035 //y2=3.51
r553 (  62 70 ) resistor r=0.778963 //w=0.204 //l=1.27248 //layer=m2 \
 //thickness=0.36 //x=28.08 //y=3.495 //x2=29.345 //y2=3.51
r554 (  62 63 ) resistor r=0.410305 //w=0.131 //l=0.43 //layer=m2 \
 //thickness=0.36 //x=28.08 //y=3.495 //x2=27.65 //y2=3.495
r555 (  60 63 ) resistor r=0.125 //w=0.17 //l=0.177341 //layer=m2 \
 //thickness=0.36 //x=27.48 //y=3.51 //x2=27.65 //y2=3.495
r556 (  60 61 ) resistor r=0.944656 //w=0.131 //l=0.99 //layer=m2 \
 //thickness=0.36 //x=27.48 //y=3.51 //x2=26.49 //y2=3.51
r557 (  58 61 ) resistor r=0.1875 //w=0.17 //l=0.262393 //layer=m2 \
 //thickness=0.36 //x=26.235 //y=3.495 //x2=26.49 //y2=3.51
r558 (  58 59 ) resistor r=0.410305 //w=0.131 //l=0.43 //layer=m2 \
 //thickness=0.36 //x=26.235 //y=3.495 //x2=25.805 //y2=3.495
r559 (  57 67 ) resistor r=0.10734 //w=0.281 //l=0.16 //layer=m2 \
 //thickness=0.36 //x=25.445 //y=3.51 //x2=25.285 //y2=3.51
r560 (  56 59 ) resistor r=0.125 //w=0.17 //l=0.177341 //layer=m2 \
 //thickness=0.36 //x=25.635 //y=3.51 //x2=25.805 //y2=3.495
r561 (  56 57 ) resistor r=0.181298 //w=0.131 //l=0.19 //layer=m2 \
 //thickness=0.36 //x=25.635 //y=3.51 //x2=25.445 //y2=3.51
r562 (  53 124 ) resistor r=9.3 //w=0.17 //l=0.17 //layer=mcon //count=1 \
 //x=31.2 //y=4.88 //x2=31.2 //y2=4.88
r563 (  53 54 ) resistor r=0.103207 //w=0.196 //l=0.14 //layer=m1 \
 //thickness=0.36 //x=31.202 //y=4.88 //x2=31.202 //y2=4.74
r564 (  50 115 ) resistor r=9.3 //w=0.17 //l=0.17 //layer=mcon //count=1 \
 //x=31.2 //y=2.26 //x2=31.2 //y2=2.26
r565 (  46 72 ) resistor r=4.5 //w=0.15 //l=0.15 //layer=via1 //count=1 \
 //x=31.195 //y=3.505 //x2=31.195 //y2=3.505
r566 (  46 48 ) resistor r=0.00167112 //w=0.374 //l=0.005 //layer=m1 \
 //thickness=0.36 //x=31.145 //y=3.505 //x2=31.145 //y2=3.51
r567 (  43 70 ) resistor r=4.5 //w=0.15 //l=0.15 //layer=via1 //count=1 \
 //x=29.345 //y=3.51 //x2=29.345 //y2=3.51
r568 (  40 187 ) resistor r=9.3 //w=0.17 //l=0.17 //layer=mcon //count=1 \
 //x=28.91 //y=1.18 //x2=28.91 //y2=1.18
r569 (  38 98 ) resistor r=9.3 //w=0.17 //l=0.17 //layer=mcon //count=1 \
 //x=28.87 //y=5.56 //x2=28.87 //y2=5.56
r570 (  35 38 ) resistor r=0.117801 //w=0.191 //l=0.18 //layer=m1 \
 //thickness=0.36 //x=28.87 //y=5.38 //x2=28.87 //y2=5.56
r571 (  34 90 ) resistor r=9.3 //w=0.17 //l=0.17 //layer=mcon //count=1 \
 //x=27.99 //y=5.56 //x2=27.99 //y2=5.56
r572 (  32 34 ) resistor r=0.10274 //w=0.219 //l=0.18 //layer=m1 \
 //thickness=0.36 //x=27.99 //y=5.38 //x2=27.99 //y2=5.56
r573 (  30 67 ) resistor r=4.5 //w=0.15 //l=0.15 //layer=via1 //count=1 \
 //x=25.285 //y=3.51 //x2=25.285 //y2=3.51
r574 (  28 85 ) resistor r=9.3 //w=0.17 //l=0.17 //layer=mcon //count=1 \
 //x=25.28 //y=4.88 //x2=25.28 //y2=4.88
r575 (  26 76 ) resistor r=9.3 //w=0.17 //l=0.17 //layer=mcon //count=1 \
 //x=25.28 //y=2.26 //x2=25.28 //y2=2.26
r576 (  23 48 ) resistor r=0.089409 //w=0.374 //l=0.180416 //layer=m1 \
 //thickness=0.36 //x=31.2 //y=3.665 //x2=31.145 //y2=3.51
r577 (  23 54 ) resistor r=1.02576 //w=0.131 //l=1.075 //layer=m1 \
 //thickness=0.36 //x=31.2 //y=3.665 //x2=31.2 //y2=4.74
r578 (  22 46 ) resistor r=0.0910802 //w=0.374 //l=0.185472 //layer=m1 \
 //thickness=0.36 //x=31.2 //y=3.345 //x2=31.145 //y2=3.505
r579 (  21 50 ) resistor r=0.0933015 //w=0.201 //l=0.125 //layer=m1 \
 //thickness=0.36 //x=31.2 //y=2.385 //x2=31.2 //y2=2.26
r580 (  21 22 ) resistor r=0.916031 //w=0.131 //l=0.96 //layer=m1 \
 //thickness=0.36 //x=31.2 //y=2.385 //x2=31.2 //y2=3.345
r581 (  19 43 ) resistor r=0.0910802 //w=0.374 //l=0.185472 //layer=m1 \
 //thickness=0.36 //x=29.35 //y=3.67 //x2=29.295 //y2=3.51
r582 (  19 20 ) resistor r=1.55057 //w=0.131 //l=1.625 //layer=m1 \
 //thickness=0.36 //x=29.35 //y=3.67 //x2=29.35 //y2=5.295
r583 (  18 43 ) resistor r=0.0910802 //w=0.374 //l=0.185472 //layer=m1 \
 //thickness=0.36 //x=29.35 //y=3.35 //x2=29.295 //y2=3.51
r584 (  17 18 ) resistor r=1.3645 //w=0.131 //l=1.43 //layer=m1 \
 //thickness=0.36 //x=29.35 //y=1.92 //x2=29.35 //y2=3.35
r585 (  15 17 ) resistor r=0.0698411 //w=0.17 //l=0.120208 //layer=m1 \
 //thickness=0.36 //x=29.265 //y=1.835 //x2=29.35 //y2=1.92
r586 (  15 16 ) resistor r=0.257634 //w=0.131 //l=0.27 //layer=m1 \
 //thickness=0.36 //x=29.265 //y=1.835 //x2=28.995 //y2=1.835
r587 (  14 35 ) resistor r=0.0257089 //w=0.23 //l=0.115 //layer=m1 \
 //thickness=0.36 //x=28.985 //y=5.38 //x2=28.87 //y2=5.38
r588 (  13 20 ) resistor r=0.0698411 //w=0.17 //l=0.120208 //layer=m1 \
 //thickness=0.36 //x=29.265 //y=5.38 //x2=29.35 //y2=5.295
r589 (  13 14 ) resistor r=0.267176 //w=0.131 //l=0.28 //layer=m1 \
 //thickness=0.36 //x=29.265 //y=5.38 //x2=28.985 //y2=5.38
r590 (  12 16 ) resistor r=0.0698411 //w=0.17 //l=0.120208 //layer=m1 \
 //thickness=0.36 //x=28.91 //y=1.75 //x2=28.995 //y2=1.835
r591 (  11 40 ) resistor r=0.0913624 //w=0.191 //l=0.12 //layer=m1 \
 //thickness=0.36 //x=28.91 //y=1.3 //x2=28.91 //y2=1.18
r592 (  11 12 ) resistor r=0.429389 //w=0.131 //l=0.45 //layer=m1 \
 //thickness=0.36 //x=28.91 //y=1.3 //x2=28.91 //y2=1.75
r593 (  8 32 ) resistor r=0.0227762 //w=0.219 //l=0.115 //layer=m1 \
 //thickness=0.36 //x=28.105 //y=5.38 //x2=27.99 //y2=5.38
r594 (  7 35 ) resistor r=0.0257089 //w=0.23 //l=0.115 //layer=m1 \
 //thickness=0.36 //x=28.755 //y=5.38 //x2=28.87 //y2=5.38
r595 (  7 8 ) resistor r=0.620229 //w=0.131 //l=0.65 //layer=m1 \
 //thickness=0.36 //x=28.755 //y=5.38 //x2=28.105 //y2=5.38
r596 (  4 28 ) resistor r=0.0801089 //w=0.224 //l=0.13 //layer=m1 \
 //thickness=0.36 //x=25.28 //y=4.75 //x2=25.28 //y2=4.88
r597 (  3 30 ) resistor r=0.0910802 //w=0.374 //l=0.185472 //layer=m1 \
 //thickness=0.36 //x=25.28 //y=3.67 //x2=25.335 //y2=3.51
r598 (  3 4 ) resistor r=1.03053 //w=0.131 //l=1.08 //layer=m1 \
 //thickness=0.36 //x=25.28 //y=3.67 //x2=25.28 //y2=4.75
r599 (  2 30 ) resistor r=0.0910802 //w=0.374 //l=0.185472 //layer=m1 \
 //thickness=0.36 //x=25.28 //y=3.35 //x2=25.335 //y2=3.51
r600 (  1 26 ) resistor r=0.0719237 //w=0.222 //l=0.115 //layer=m1 \
 //thickness=0.36 //x=25.28 //y=2.375 //x2=25.28 //y2=2.26
r601 (  1 2 ) resistor r=0.930344 //w=0.131 //l=0.975 //layer=m1 \
 //thickness=0.36 //x=25.28 //y=2.375 //x2=25.28 //y2=3.35
ends PM_TMRDFFQX1\%noxref_6

subckt PM_TMRDFFQX1\%noxref_7 ( 3 8 9 11 12 14 15 16 18 19 23 24 27 29 32 35 \
 38 41 42 44 45 50 53 61 78 87 91 92 93 94 95 96 97 101 103 106 107 117 120 \
 122 123 )
c288 ( 120 0 ) capacitor c=0.00878249f //x=32.05 //y=1.085
c289 ( 117 0 ) capacitor c=0.0682508f //x=34.53 //y=4.88
c290 ( 107 0 ) capacitor c=0.0318956f //x=34.865 //y=1.39
c291 ( 106 0 ) capacitor c=0.0186809f //x=34.865 //y=1.045
c292 ( 103 0 ) capacitor c=0.0141821f //x=34.71 //y=1.545
c293 ( 101 0 ) capacitor c=0.0158553f //x=34.71 //y=0.89
c294 ( 97 0 ) capacitor c=0.0854195f //x=34.335 //y=2.095
c295 ( 96 0 ) capacitor c=0.0229235f //x=34.335 //y=1.7
c296 ( 95 0 ) capacitor c=0.0234359f //x=34.335 //y=1.39
c297 ( 94 0 ) capacitor c=0.0198759f //x=34.335 //y=1.045
c298 ( 93 0 ) capacitor c=0.110369f //x=34.87 //y=6.2
c299 ( 92 0 ) capacitor c=0.154619f //x=34.43 //y=6.2
c300 ( 87 0 ) capacitor c=8.13425e-19 //x=34.53 //y=4.88
c301 ( 78 0 ) capacitor c=7.85889e-19 //x=34.53 //y=2.26
c302 ( 61 0 ) capacitor c=0.0322017f //x=32.2 //y=5.56
c303 ( 53 0 ) capacitor c=0.0291714f //x=31.32 //y=5.56
c304 ( 50 0 ) capacitor c=4.79804e-19 //x=34.525 //y=3.51
c305 ( 45 0 ) capacitor c=7.23354e-19 //x=32.845 //y=3.51
c306 ( 44 0 ) capacitor c=0.018923f //x=34.365 //y=3.51
c307 ( 42 0 ) capacitor c=0.0270852f //x=34.532 //y=4.74
c308 ( 41 0 ) capacitor c=0.0060492f //x=34.53 //y=4.88
c309 ( 38 0 ) capacitor c=0.00641145f //x=34.53 //y=2.26
c310 ( 35 0 ) capacitor c=0.0164425f //x=34.525 //y=3.51
c311 ( 32 0 ) capacitor c=0.0167895f //x=32.68 //y=3.51
c312 ( 29 0 ) capacitor c=0.0113735f //x=32.24 //y=1.18
c313 ( 27 0 ) capacitor c=5.78613e-19 //x=32.2 //y=5.56
c314 ( 24 0 ) capacitor c=0.0103127f //x=32.2 //y=5.38
c315 ( 23 0 ) capacitor c=0.00933334f //x=31.32 //y=5.56
c316 ( 19 0 ) capacitor c=0.0131458f //x=34.53 //y=3.67
c317 ( 18 0 ) capacitor c=0.0255439f //x=34.53 //y=3.35
c318 ( 16 0 ) capacitor c=0.0402141f //x=32.68 //y=5.295
c319 ( 15 0 ) capacitor c=0.0132742f //x=32.68 //y=3.67
c320 ( 14 0 ) capacitor c=0.0368956f //x=32.68 //y=3.35
c321 ( 12 0 ) capacitor c=0.00560492f //x=32.325 //y=1.835
c322 ( 11 0 ) capacitor c=0.0129728f //x=32.595 //y=1.835
c323 ( 9 0 ) capacitor c=0.0112475f //x=32.595 //y=5.38
c324 ( 8 0 ) capacitor c=0.0101547f //x=32.24 //y=1.75
c325 ( 3 0 ) capacitor c=0.0134484f //x=32.085 //y=5.38
r326 (  115 117 ) resistor r=20.6867 //w=0.233 //l=0.1 //layer=ply \
 //thickness=0.18 //x=34.43 //y=4.88 //x2=34.53 //y2=4.88
r327 (  108 117 ) resistor r=70.3348 //w=0.233 //l=0.414367 //layer=ply \
 //thickness=0.18 //x=34.87 //y=5.045 //x2=34.53 //y2=4.88
r328 (  107 119 ) resistor r=45.1352 //w=0.168 //l=0.173853 //layer=ply \
 //thickness=0.18 //x=34.865 //y=1.39 //x2=34.825 //y2=1.545
r329 (  106 118 ) resistor r=45.1352 //w=0.168 //l=0.173853 //layer=ply \
 //thickness=0.18 //x=34.865 //y=1.045 //x2=34.825 //y2=0.89
r330 (  106 107 ) resistor r=176.904 //w=0.094 //l=0.345 //layer=ply \
 //thickness=0.18 //x=34.865 //y=1.045 //x2=34.865 //y2=1.39
r331 (  104 114 ) resistor r=10.701 //w=0.21 //l=0.115 //layer=ply \
 //thickness=0.18 //x=34.49 //y=1.545 //x2=34.375 //y2=1.545
r332 (  103 119 ) resistor r=5.52526 //w=0.168 //l=0.115 //layer=ply \
 //thickness=0.18 //x=34.71 //y=1.545 //x2=34.825 //y2=1.545
r333 (  102 113 ) resistor r=5.52526 //w=0.168 //l=0.115 //layer=ply \
 //thickness=0.18 //x=34.49 //y=0.89 //x2=34.375 //y2=0.89
r334 (  101 118 ) resistor r=5.52526 //w=0.168 //l=0.115 //layer=ply \
 //thickness=0.18 //x=34.71 //y=0.89 //x2=34.825 //y2=0.89
r335 (  101 102 ) resistor r=112.809 //w=0.094 //l=0.22 //layer=ply \
 //thickness=0.18 //x=34.71 //y=0.89 //x2=34.49 //y2=0.89
r336 (  98 115 ) resistor r=13.0941 //w=0.233 //l=0.165 //layer=ply \
 //thickness=0.18 //x=34.43 //y=5.045 //x2=34.43 //y2=4.88
r337 (  97 112 ) resistor r=34.8111 //w=0.27 //l=0.264953 //layer=ply \
 //thickness=0.18 //x=34.335 //y=2.095 //x2=34.53 //y2=2.26
r338 (  96 114 ) resistor r=39.5823 //w=0.21 //l=0.173853 //layer=ply \
 //thickness=0.18 //x=34.335 //y=1.7 //x2=34.375 //y2=1.545
r339 (  96 97 ) resistor r=202.543 //w=0.094 //l=0.395 //layer=ply \
 //thickness=0.18 //x=34.335 //y=1.7 //x2=34.335 //y2=2.095
r340 (  95 114 ) resistor r=39.5823 //w=0.21 //l=0.173853 //layer=ply \
 //thickness=0.18 //x=34.335 //y=1.39 //x2=34.375 //y2=1.545
r341 (  94 113 ) resistor r=45.1352 //w=0.168 //l=0.173853 //layer=ply \
 //thickness=0.18 //x=34.335 //y=1.045 //x2=34.375 //y2=0.89
r342 (  94 95 ) resistor r=176.904 //w=0.094 //l=0.345 //layer=ply \
 //thickness=0.18 //x=34.335 //y=1.045 //x2=34.335 //y2=1.39
r343 (  93 108 ) resistor r=592.245 //w=0.094 //l=1.155 //layer=ply \
 //thickness=0.18 //x=34.87 //y=6.2 //x2=34.87 //y2=5.045
r344 (  92 98 ) resistor r=592.245 //w=0.094 //l=1.155 //layer=ply \
 //thickness=0.18 //x=34.43 //y=6.2 //x2=34.43 //y2=5.045
r345 (  91 103 ) resistor r=56.4043 //w=0.094 //l=0.11 //layer=ply \
 //thickness=0.18 //x=34.6 //y=1.545 //x2=34.71 //y2=1.545
r346 (  91 104 ) resistor r=56.4043 //w=0.094 //l=0.11 //layer=ply \
 //thickness=0.18 //x=34.6 //y=1.545 //x2=34.49 //y2=1.545
r347 (  87 117 ) resistor r=152 //w=0.17 //l=0.17 //layer=licon //count=1 \
 //x=34.53 //y=4.88 //x2=34.53 //y2=4.88
r348 (  78 112 ) resistor r=152 //w=0.17 //l=0.17 //layer=licon //count=1 \
 //x=34.53 //y=2.26 //x2=34.53 //y2=2.26
r349 (  61 123 ) resistor r=23.615 //w=0.187 //l=0.345 //layer=li \
 //thickness=0.1 //x=32.2 //y=5.56 //x2=32.2 //y2=5.905
r350 (  53 122 ) resistor r=23.615 //w=0.187 //l=0.345 //layer=li \
 //thickness=0.1 //x=31.32 //y=5.56 //x2=31.32 //y2=5.905
r351 (  45 47 ) resistor r=0.10734 //w=0.281 //l=0.16 //layer=m2 \
 //thickness=0.36 //x=32.845 //y=3.51 //x2=32.685 //y2=3.51
r352 (  44 50 ) resistor r=0.10734 //w=0.281 //l=0.16 //layer=m2 \
 //thickness=0.36 //x=34.365 //y=3.51 //x2=34.525 //y2=3.51
r353 (  44 45 ) resistor r=1.45038 //w=0.131 //l=1.52 //layer=m2 \
 //thickness=0.36 //x=34.365 //y=3.51 //x2=32.845 //y2=3.51
r354 (  41 87 ) resistor r=9.3 //w=0.17 //l=0.17 //layer=mcon //count=1 \
 //x=34.53 //y=4.88 //x2=34.53 //y2=4.88
r355 (  41 42 ) resistor r=0.103207 //w=0.196 //l=0.14 //layer=m1 \
 //thickness=0.36 //x=34.532 //y=4.88 //x2=34.532 //y2=4.74
r356 (  38 78 ) resistor r=9.3 //w=0.17 //l=0.17 //layer=mcon //count=1 \
 //x=34.53 //y=2.26 //x2=34.53 //y2=2.26
r357 (  35 50 ) resistor r=4.5 //w=0.15 //l=0.15 //layer=via1 //count=1 \
 //x=34.525 //y=3.51 //x2=34.525 //y2=3.51
r358 (  32 47 ) resistor r=4.5 //w=0.15 //l=0.15 //layer=via1 //count=1 \
 //x=32.685 //y=3.51 //x2=32.685 //y2=3.51
r359 (  29 120 ) resistor r=9.3 //w=0.17 //l=0.17 //layer=mcon //count=1 \
 //x=32.24 //y=1.18 //x2=32.24 //y2=1.18
r360 (  27 61 ) resistor r=9.3 //w=0.17 //l=0.17 //layer=mcon //count=1 \
 //x=32.2 //y=5.56 //x2=32.2 //y2=5.56
r361 (  24 27 ) resistor r=0.117801 //w=0.191 //l=0.18 //layer=m1 \
 //thickness=0.36 //x=32.2 //y=5.38 //x2=32.2 //y2=5.56
r362 (  23 53 ) resistor r=9.3 //w=0.17 //l=0.17 //layer=mcon //count=1 \
 //x=31.32 //y=5.56 //x2=31.32 //y2=5.56
r363 (  21 23 ) resistor r=0.10274 //w=0.219 //l=0.18 //layer=m1 \
 //thickness=0.36 //x=31.32 //y=5.38 //x2=31.32 //y2=5.56
r364 (  19 35 ) resistor r=0.0910802 //w=0.374 //l=0.185472 //layer=m1 \
 //thickness=0.36 //x=34.53 //y=3.67 //x2=34.475 //y2=3.51
r365 (  19 42 ) resistor r=1.02099 //w=0.131 //l=1.07 //layer=m1 \
 //thickness=0.36 //x=34.53 //y=3.67 //x2=34.53 //y2=4.74
r366 (  18 35 ) resistor r=0.0910802 //w=0.374 //l=0.185472 //layer=m1 \
 //thickness=0.36 //x=34.53 //y=3.35 //x2=34.475 //y2=3.51
r367 (  17 38 ) resistor r=0.0933015 //w=0.201 //l=0.125 //layer=m1 \
 //thickness=0.36 //x=34.53 //y=2.385 //x2=34.53 //y2=2.26
r368 (  17 18 ) resistor r=0.920802 //w=0.131 //l=0.965 //layer=m1 \
 //thickness=0.36 //x=34.53 //y=2.385 //x2=34.53 //y2=3.35
r369 (  15 32 ) resistor r=0.0910802 //w=0.374 //l=0.185472 //layer=m1 \
 //thickness=0.36 //x=32.68 //y=3.67 //x2=32.735 //y2=3.51
r370 (  15 16 ) resistor r=1.55057 //w=0.131 //l=1.625 //layer=m1 \
 //thickness=0.36 //x=32.68 //y=3.67 //x2=32.68 //y2=5.295
r371 (  14 32 ) resistor r=0.0910802 //w=0.374 //l=0.185472 //layer=m1 \
 //thickness=0.36 //x=32.68 //y=3.35 //x2=32.735 //y2=3.51
r372 (  13 14 ) resistor r=1.3645 //w=0.131 //l=1.43 //layer=m1 \
 //thickness=0.36 //x=32.68 //y=1.92 //x2=32.68 //y2=3.35
r373 (  11 13 ) resistor r=0.0698411 //w=0.17 //l=0.120208 //layer=m1 \
 //thickness=0.36 //x=32.595 //y=1.835 //x2=32.68 //y2=1.92
r374 (  11 12 ) resistor r=0.257634 //w=0.131 //l=0.27 //layer=m1 \
 //thickness=0.36 //x=32.595 //y=1.835 //x2=32.325 //y2=1.835
r375 (  10 24 ) resistor r=0.0257089 //w=0.23 //l=0.115 //layer=m1 \
 //thickness=0.36 //x=32.315 //y=5.38 //x2=32.2 //y2=5.38
r376 (  9 16 ) resistor r=0.0698411 //w=0.17 //l=0.120208 //layer=m1 \
 //thickness=0.36 //x=32.595 //y=5.38 //x2=32.68 //y2=5.295
r377 (  9 10 ) resistor r=0.267176 //w=0.131 //l=0.28 //layer=m1 \
 //thickness=0.36 //x=32.595 //y=5.38 //x2=32.315 //y2=5.38
r378 (  8 12 ) resistor r=0.0698411 //w=0.17 //l=0.120208 //layer=m1 \
 //thickness=0.36 //x=32.24 //y=1.75 //x2=32.325 //y2=1.835
r379 (  7 29 ) resistor r=0.0913624 //w=0.191 //l=0.12 //layer=m1 \
 //thickness=0.36 //x=32.24 //y=1.3 //x2=32.24 //y2=1.18
r380 (  7 8 ) resistor r=0.429389 //w=0.131 //l=0.45 //layer=m1 \
 //thickness=0.36 //x=32.24 //y=1.3 //x2=32.24 //y2=1.75
r381 (  4 21 ) resistor r=0.0227762 //w=0.219 //l=0.115 //layer=m1 \
 //thickness=0.36 //x=31.435 //y=5.38 //x2=31.32 //y2=5.38
r382 (  3 24 ) resistor r=0.0257089 //w=0.23 //l=0.115 //layer=m1 \
 //thickness=0.36 //x=32.085 //y=5.38 //x2=32.2 //y2=5.38
r383 (  3 4 ) resistor r=0.620229 //w=0.131 //l=0.65 //layer=m1 \
 //thickness=0.36 //x=32.085 //y=5.38 //x2=31.435 //y2=5.38
ends PM_TMRDFFQX1\%noxref_7

subckt PM_TMRDFFQX1\%noxref_8 ( 1 3 6 7 9 10 11 12 14 15 16 18 19 22 23 25 28 \
 31 37 40 43 46 47 50 54 57 58 60 61 62 63 64 66 68 70 72 74 84 92 100 117 126 \
 131 140 144 145 146 147 148 149 150 151 152 153 157 159 162 163 167 168 169 \
 170 174 176 179 180 190 199 202 204 205 206 )
c491 ( 202 0 ) capacitor c=0.00885916f //x=25.345 //y=1.095
c492 ( 199 0 ) capacitor c=0.0645411f //x=37.86 //y=4.88
c493 ( 190 0 ) capacitor c=0.0645923f //x=27.87 //y=4.88
c494 ( 180 0 ) capacitor c=0.0318956f //x=38.195 //y=1.39
c495 ( 179 0 ) capacitor c=0.0186809f //x=38.195 //y=1.045
c496 ( 176 0 ) capacitor c=0.0141821f //x=38.04 //y=1.545
c497 ( 174 0 ) capacitor c=0.0158553f //x=38.04 //y=0.89
c498 ( 170 0 ) capacitor c=0.088055f //x=37.665 //y=2.095
c499 ( 169 0 ) capacitor c=0.0229235f //x=37.665 //y=1.7
c500 ( 168 0 ) capacitor c=0.0234359f //x=37.665 //y=1.39
c501 ( 167 0 ) capacitor c=0.0198759f //x=37.665 //y=1.045
c502 ( 163 0 ) capacitor c=0.0318956f //x=28.205 //y=1.39
c503 ( 162 0 ) capacitor c=0.0186809f //x=28.205 //y=1.045
c504 ( 159 0 ) capacitor c=0.0141821f //x=28.05 //y=1.545
c505 ( 157 0 ) capacitor c=0.0158553f //x=28.05 //y=0.89
c506 ( 153 0 ) capacitor c=0.088055f //x=27.675 //y=2.095
c507 ( 152 0 ) capacitor c=0.0229235f //x=27.675 //y=1.7
c508 ( 151 0 ) capacitor c=0.0234359f //x=27.675 //y=1.39
c509 ( 150 0 ) capacitor c=0.0198759f //x=27.675 //y=1.045
c510 ( 149 0 ) capacitor c=0.110369f //x=38.2 //y=6.2
c511 ( 148 0 ) capacitor c=0.154619f //x=37.76 //y=6.2
c512 ( 147 0 ) capacitor c=0.110369f //x=28.21 //y=6.2
c513 ( 146 0 ) capacitor c=0.154619f //x=27.77 //y=6.2
c514 ( 140 0 ) capacitor c=8.13425e-19 //x=37.86 //y=4.88
c515 ( 131 0 ) capacitor c=7.85889e-19 //x=37.86 //y=2.26
c516 ( 126 0 ) capacitor c=8.13425e-19 //x=27.87 //y=4.88
c517 ( 117 0 ) capacitor c=7.85889e-19 //x=27.87 //y=2.26
c518 ( 100 0 ) capacitor c=0.0293071f //x=25.24 //y=5.56
c519 ( 92 0 ) capacitor c=0.029137f //x=24.36 //y=5.56
c520 ( 84 0 ) capacitor c=0.0277605f //x=23.48 //y=5.56
c521 ( 74 0 ) capacitor c=0.0403878f //x=34.74 //y=3.895
c522 ( 72 0 ) capacitor c=0.0175525f //x=34.14 //y=3.88
c523 ( 70 0 ) capacitor c=0.00418974f //x=32.9 //y=3.895
c524 ( 68 0 ) capacitor c=0.00769994f //x=32.16 //y=3.87
c525 ( 66 0 ) capacitor c=0.005471f //x=31.41 //y=3.89
c526 ( 64 0 ) capacitor c=0.0178779f //x=30.81 //y=3.88
c527 ( 63 0 ) capacitor c=0.00989324f //x=29.215 //y=3.895
c528 ( 62 0 ) capacitor c=0.00477746f //x=29.56 //y=3.895
c529 ( 61 0 ) capacitor c=7.05145e-19 //x=26.18 //y=3.88
c530 ( 60 0 ) capacitor c=0.0193144f //x=27.705 //y=3.88
c531 ( 58 0 ) capacitor c=0.0161369f //x=37.862 //y=4.74
c532 ( 57 0 ) capacitor c=0.00598189f //x=37.86 //y=4.88
c533 ( 54 0 ) capacitor c=0.00648848f //x=37.86 //y=2.26
c534 ( 50 0 ) capacitor c=0.0159231f //x=37.86 //y=3.88
c535 ( 47 0 ) capacitor c=0.0172769f //x=27.872 //y=4.74
c536 ( 46 0 ) capacitor c=0.00598357f //x=27.87 //y=4.88
c537 ( 43 0 ) capacitor c=0.00654649f //x=27.87 //y=2.26
c538 ( 40 0 ) capacitor c=0.0163193f //x=27.865 //y=3.88
c539 ( 37 0 ) capacitor c=0.0170864f //x=26.02 //y=3.88
c540 ( 31 0 ) capacitor c=9.55882e-19 //x=25.24 //y=5.335
c541 ( 28 0 ) capacitor c=0.00753245f //x=24.36 //y=5.335
c542 ( 25 0 ) capacitor c=0.0112819f //x=23.482 //y=5.335
c543 ( 23 0 ) capacitor c=0.0125875f //x=37.86 //y=4.045
c544 ( 22 0 ) capacitor c=0.0393416f //x=37.86 //y=3.725
c545 ( 19 0 ) capacitor c=0.0123877f //x=27.87 //y=4.04
c546 ( 18 0 ) capacitor c=0.0342447f //x=27.87 //y=3.72
c547 ( 16 0 ) capacitor c=0.0309857f //x=26.02 //y=5.25
c548 ( 15 0 ) capacitor c=0.0132732f //x=26.02 //y=4.04
c549 ( 14 0 ) capacitor c=0.0474064f //x=26.02 //y=3.72
c550 ( 12 0 ) capacitor c=0.00521328f //x=25.62 //y=1.845
c551 ( 11 0 ) capacitor c=0.0145678f //x=25.935 //y=1.845
c552 ( 10 0 ) capacitor c=0.013549f //x=25.535 //y=1.76
c553 ( 9 0 ) capacitor c=0.0111993f //x=25.535 //y=1.305
c554 ( 7 0 ) capacitor c=0.0228253f //x=25.935 //y=5.335
c555 ( 6 0 ) capacitor c=0.00906713f //x=25.24 //y=5.56
c556 ( 3 0 ) capacitor c=0.019596f //x=25.125 //y=5.335
c557 ( 1 0 ) capacitor c=0.014788f //x=24.24 //y=5.335
r558 (  197 199 ) resistor r=20.6867 //w=0.233 //l=0.1 //layer=ply \
 //thickness=0.18 //x=37.76 //y=4.88 //x2=37.86 //y2=4.88
r559 (  188 190 ) resistor r=20.6867 //w=0.233 //l=0.1 //layer=ply \
 //thickness=0.18 //x=27.77 //y=4.88 //x2=27.87 //y2=4.88
r560 (  181 199 ) resistor r=70.3348 //w=0.233 //l=0.414367 //layer=ply \
 //thickness=0.18 //x=38.2 //y=5.045 //x2=37.86 //y2=4.88
r561 (  180 201 ) resistor r=45.1352 //w=0.168 //l=0.173853 //layer=ply \
 //thickness=0.18 //x=38.195 //y=1.39 //x2=38.155 //y2=1.545
r562 (  179 200 ) resistor r=45.1352 //w=0.168 //l=0.173853 //layer=ply \
 //thickness=0.18 //x=38.195 //y=1.045 //x2=38.155 //y2=0.89
r563 (  179 180 ) resistor r=176.904 //w=0.094 //l=0.345 //layer=ply \
 //thickness=0.18 //x=38.195 //y=1.045 //x2=38.195 //y2=1.39
r564 (  177 196 ) resistor r=10.701 //w=0.21 //l=0.115 //layer=ply \
 //thickness=0.18 //x=37.82 //y=1.545 //x2=37.705 //y2=1.545
r565 (  176 201 ) resistor r=5.52526 //w=0.168 //l=0.115 //layer=ply \
 //thickness=0.18 //x=38.04 //y=1.545 //x2=38.155 //y2=1.545
r566 (  175 195 ) resistor r=5.52526 //w=0.168 //l=0.115 //layer=ply \
 //thickness=0.18 //x=37.82 //y=0.89 //x2=37.705 //y2=0.89
r567 (  174 200 ) resistor r=5.52526 //w=0.168 //l=0.115 //layer=ply \
 //thickness=0.18 //x=38.04 //y=0.89 //x2=38.155 //y2=0.89
r568 (  174 175 ) resistor r=112.809 //w=0.094 //l=0.22 //layer=ply \
 //thickness=0.18 //x=38.04 //y=0.89 //x2=37.82 //y2=0.89
r569 (  171 197 ) resistor r=13.0941 //w=0.233 //l=0.165 //layer=ply \
 //thickness=0.18 //x=37.76 //y=5.045 //x2=37.76 //y2=4.88
r570 (  170 194 ) resistor r=34.8111 //w=0.27 //l=0.264953 //layer=ply \
 //thickness=0.18 //x=37.665 //y=2.095 //x2=37.86 //y2=2.26
r571 (  169 196 ) resistor r=39.5823 //w=0.21 //l=0.173853 //layer=ply \
 //thickness=0.18 //x=37.665 //y=1.7 //x2=37.705 //y2=1.545
r572 (  169 170 ) resistor r=202.543 //w=0.094 //l=0.395 //layer=ply \
 //thickness=0.18 //x=37.665 //y=1.7 //x2=37.665 //y2=2.095
r573 (  168 196 ) resistor r=39.5823 //w=0.21 //l=0.173853 //layer=ply \
 //thickness=0.18 //x=37.665 //y=1.39 //x2=37.705 //y2=1.545
r574 (  167 195 ) resistor r=45.1352 //w=0.168 //l=0.173853 //layer=ply \
 //thickness=0.18 //x=37.665 //y=1.045 //x2=37.705 //y2=0.89
r575 (  167 168 ) resistor r=176.904 //w=0.094 //l=0.345 //layer=ply \
 //thickness=0.18 //x=37.665 //y=1.045 //x2=37.665 //y2=1.39
r576 (  164 190 ) resistor r=70.3348 //w=0.233 //l=0.414367 //layer=ply \
 //thickness=0.18 //x=28.21 //y=5.045 //x2=27.87 //y2=4.88
r577 (  163 192 ) resistor r=45.1352 //w=0.168 //l=0.173853 //layer=ply \
 //thickness=0.18 //x=28.205 //y=1.39 //x2=28.165 //y2=1.545
r578 (  162 191 ) resistor r=45.1352 //w=0.168 //l=0.173853 //layer=ply \
 //thickness=0.18 //x=28.205 //y=1.045 //x2=28.165 //y2=0.89
r579 (  162 163 ) resistor r=176.904 //w=0.094 //l=0.345 //layer=ply \
 //thickness=0.18 //x=28.205 //y=1.045 //x2=28.205 //y2=1.39
r580 (  160 187 ) resistor r=10.701 //w=0.21 //l=0.115 //layer=ply \
 //thickness=0.18 //x=27.83 //y=1.545 //x2=27.715 //y2=1.545
r581 (  159 192 ) resistor r=5.52526 //w=0.168 //l=0.115 //layer=ply \
 //thickness=0.18 //x=28.05 //y=1.545 //x2=28.165 //y2=1.545
r582 (  158 186 ) resistor r=5.52526 //w=0.168 //l=0.115 //layer=ply \
 //thickness=0.18 //x=27.83 //y=0.89 //x2=27.715 //y2=0.89
r583 (  157 191 ) resistor r=5.52526 //w=0.168 //l=0.115 //layer=ply \
 //thickness=0.18 //x=28.05 //y=0.89 //x2=28.165 //y2=0.89
r584 (  157 158 ) resistor r=112.809 //w=0.094 //l=0.22 //layer=ply \
 //thickness=0.18 //x=28.05 //y=0.89 //x2=27.83 //y2=0.89
r585 (  154 188 ) resistor r=13.0941 //w=0.233 //l=0.165 //layer=ply \
 //thickness=0.18 //x=27.77 //y=5.045 //x2=27.77 //y2=4.88
r586 (  153 185 ) resistor r=34.8111 //w=0.27 //l=0.264953 //layer=ply \
 //thickness=0.18 //x=27.675 //y=2.095 //x2=27.87 //y2=2.26
r587 (  152 187 ) resistor r=39.5823 //w=0.21 //l=0.173853 //layer=ply \
 //thickness=0.18 //x=27.675 //y=1.7 //x2=27.715 //y2=1.545
r588 (  152 153 ) resistor r=202.543 //w=0.094 //l=0.395 //layer=ply \
 //thickness=0.18 //x=27.675 //y=1.7 //x2=27.675 //y2=2.095
r589 (  151 187 ) resistor r=39.5823 //w=0.21 //l=0.173853 //layer=ply \
 //thickness=0.18 //x=27.675 //y=1.39 //x2=27.715 //y2=1.545
r590 (  150 186 ) resistor r=45.1352 //w=0.168 //l=0.173853 //layer=ply \
 //thickness=0.18 //x=27.675 //y=1.045 //x2=27.715 //y2=0.89
r591 (  150 151 ) resistor r=176.904 //w=0.094 //l=0.345 //layer=ply \
 //thickness=0.18 //x=27.675 //y=1.045 //x2=27.675 //y2=1.39
r592 (  149 181 ) resistor r=592.245 //w=0.094 //l=1.155 //layer=ply \
 //thickness=0.18 //x=38.2 //y=6.2 //x2=38.2 //y2=5.045
r593 (  148 171 ) resistor r=592.245 //w=0.094 //l=1.155 //layer=ply \
 //thickness=0.18 //x=37.76 //y=6.2 //x2=37.76 //y2=5.045
r594 (  147 164 ) resistor r=592.245 //w=0.094 //l=1.155 //layer=ply \
 //thickness=0.18 //x=28.21 //y=6.2 //x2=28.21 //y2=5.045
r595 (  146 154 ) resistor r=592.245 //w=0.094 //l=1.155 //layer=ply \
 //thickness=0.18 //x=27.77 //y=6.2 //x2=27.77 //y2=5.045
r596 (  145 176 ) resistor r=56.4043 //w=0.094 //l=0.11 //layer=ply \
 //thickness=0.18 //x=37.93 //y=1.545 //x2=38.04 //y2=1.545
r597 (  145 177 ) resistor r=56.4043 //w=0.094 //l=0.11 //layer=ply \
 //thickness=0.18 //x=37.93 //y=1.545 //x2=37.82 //y2=1.545
r598 (  144 159 ) resistor r=56.4043 //w=0.094 //l=0.11 //layer=ply \
 //thickness=0.18 //x=27.94 //y=1.545 //x2=28.05 //y2=1.545
r599 (  144 160 ) resistor r=56.4043 //w=0.094 //l=0.11 //layer=ply \
 //thickness=0.18 //x=27.94 //y=1.545 //x2=27.83 //y2=1.545
r600 (  140 199 ) resistor r=152 //w=0.17 //l=0.17 //layer=licon //count=1 \
 //x=37.86 //y=4.88 //x2=37.86 //y2=4.88
r601 (  131 194 ) resistor r=152 //w=0.17 //l=0.17 //layer=licon //count=1 \
 //x=37.86 //y=2.26 //x2=37.86 //y2=2.26
r602 (  126 190 ) resistor r=152 //w=0.17 //l=0.17 //layer=licon //count=1 \
 //x=27.87 //y=4.88 //x2=27.87 //y2=4.88
r603 (  117 185 ) resistor r=152 //w=0.17 //l=0.17 //layer=licon //count=1 \
 //x=27.87 //y=2.26 //x2=27.87 //y2=2.26
r604 (  100 206 ) resistor r=23.615 //w=0.187 //l=0.345 //layer=li \
 //thickness=0.1 //x=25.24 //y=5.56 //x2=25.24 //y2=5.905
r605 (  92 205 ) resistor r=23.615 //w=0.187 //l=0.345 //layer=li \
 //thickness=0.1 //x=24.36 //y=5.56 //x2=24.36 //y2=5.905
r606 (  84 204 ) resistor r=23.615 //w=0.187 //l=0.345 //layer=li \
 //thickness=0.1 //x=23.48 //y=5.56 //x2=23.48 //y2=5.905
r607 (  74 82 ) resistor r=2.10915 //w=0.185 //l=3.125 //layer=m2 \
 //thickness=0.36 //x=34.74 //y=3.895 //x2=37.86 //y2=3.885
r608 (  74 75 ) resistor r=0.329198 //w=0.131 //l=0.345 //layer=m2 \
 //thickness=0.36 //x=34.74 //y=3.895 //x2=34.395 //y2=3.895
r609 (  72 75 ) resistor r=0.1875 //w=0.17 //l=0.262393 //layer=m2 \
 //thickness=0.36 //x=34.14 //y=3.88 //x2=34.395 //y2=3.895
r610 (  72 73 ) resistor r=1.02099 //w=0.131 //l=1.07 //layer=m2 \
 //thickness=0.36 //x=34.14 //y=3.88 //x2=33.07 //y2=3.88
r611 (  70 73 ) resistor r=0.125 //w=0.17 //l=0.177341 //layer=m2 \
 //thickness=0.36 //x=32.9 //y=3.895 //x2=33.07 //y2=3.88
r612 (  70 71 ) resistor r=0.329198 //w=0.131 //l=0.345 //layer=m2 \
 //thickness=0.36 //x=32.9 //y=3.895 //x2=32.555 //y2=3.895
r613 (  68 71 ) resistor r=0.290441 //w=0.17 //l=0.407308 //layer=m2 \
 //thickness=0.36 //x=32.16 //y=3.87 //x2=32.555 //y2=3.895
r614 (  68 69 ) resistor r=0.410305 //w=0.131 //l=0.43 //layer=m2 \
 //thickness=0.36 //x=32.16 //y=3.87 //x2=31.73 //y2=3.87
r615 (  66 69 ) resistor r=0.235294 //w=0.17 //l=0.329848 //layer=m2 \
 //thickness=0.36 //x=31.41 //y=3.89 //x2=31.73 //y2=3.87
r616 (  66 67 ) resistor r=0.329198 //w=0.131 //l=0.345 //layer=m2 \
 //thickness=0.36 //x=31.41 //y=3.89 //x2=31.065 //y2=3.89
r617 (  64 67 ) resistor r=0.1875 //w=0.17 //l=0.259952 //layer=m2 \
 //thickness=0.36 //x=30.81 //y=3.88 //x2=31.065 //y2=3.89
r618 (  64 65 ) resistor r=1.03053 //w=0.131 //l=1.08 //layer=m2 \
 //thickness=0.36 //x=30.81 //y=3.88 //x2=29.73 //y2=3.88
r619 (  63 80 ) resistor r=0.838898 //w=0.202 //l=1.35748 //layer=m2 \
 //thickness=0.36 //x=29.215 //y=3.895 //x2=27.865 //y2=3.88
r620 (  62 65 ) resistor r=0.125 //w=0.17 //l=0.177341 //layer=m2 \
 //thickness=0.36 //x=29.56 //y=3.895 //x2=29.73 //y2=3.88
r621 (  62 63 ) resistor r=0.329198 //w=0.131 //l=0.345 //layer=m2 \
 //thickness=0.36 //x=29.56 //y=3.895 //x2=29.215 //y2=3.895
r622 (  61 77 ) resistor r=0.10734 //w=0.281 //l=0.16 //layer=m2 \
 //thickness=0.36 //x=26.18 //y=3.88 //x2=26.02 //y2=3.88
r623 (  60 80 ) resistor r=0.102512 //w=0.202 //l=0.16 //layer=m2 \
 //thickness=0.36 //x=27.705 //y=3.88 //x2=27.865 //y2=3.88
r624 (  60 61 ) resistor r=1.45515 //w=0.131 //l=1.525 //layer=m2 \
 //thickness=0.36 //x=27.705 //y=3.88 //x2=26.18 //y2=3.88
r625 (  57 140 ) resistor r=9.3 //w=0.17 //l=0.17 //layer=mcon //count=1 \
 //x=37.86 //y=4.88 //x2=37.86 //y2=4.88
r626 (  57 58 ) resistor r=0.103207 //w=0.196 //l=0.14 //layer=m1 \
 //thickness=0.36 //x=37.862 //y=4.88 //x2=37.862 //y2=4.74
r627 (  54 131 ) resistor r=9.3 //w=0.17 //l=0.17 //layer=mcon //count=1 \
 //x=37.86 //y=2.26 //x2=37.86 //y2=2.26
r628 (  52 82 ) resistor r=4.5 //w=0.15 //l=0.15 //layer=via1 //count=1 \
 //x=37.86 //y=3.885 //x2=37.86 //y2=3.885
r629 (  50 52 ) resistor r=0.00166223 //w=0.376 //l=0.005 //layer=m1 \
 //thickness=0.36 //x=37.807 //y=3.88 //x2=37.807 //y2=3.885
r630 (  46 126 ) resistor r=9.3 //w=0.17 //l=0.17 //layer=mcon //count=1 \
 //x=27.87 //y=4.88 //x2=27.87 //y2=4.88
r631 (  46 47 ) resistor r=0.103207 //w=0.196 //l=0.14 //layer=m1 \
 //thickness=0.36 //x=27.872 //y=4.88 //x2=27.872 //y2=4.74
r632 (  43 117 ) resistor r=9.3 //w=0.17 //l=0.17 //layer=mcon //count=1 \
 //x=27.87 //y=2.26 //x2=27.87 //y2=2.26
r633 (  40 80 ) resistor r=4.5 //w=0.15 //l=0.15 //layer=via1 //count=1 \
 //x=27.865 //y=3.88 //x2=27.865 //y2=3.88
r634 (  37 77 ) resistor r=4.5 //w=0.15 //l=0.15 //layer=via1 //count=1 \
 //x=26.02 //y=3.88 //x2=26.02 //y2=3.88
r635 (  35 202 ) resistor r=9.3 //w=0.17 //l=0.17 //layer=mcon //count=1 \
 //x=25.535 //y=1.19 //x2=25.535 //y2=1.19
r636 (  33 100 ) resistor r=9.3 //w=0.17 //l=0.17 //layer=mcon //count=1 \
 //x=25.24 //y=5.56 //x2=25.24 //y2=5.56
r637 (  30 92 ) resistor r=9.3 //w=0.17 //l=0.17 //layer=mcon //count=1 \
 //x=24.36 //y=5.56 //x2=24.36 //y2=5.56
r638 (  28 30 ) resistor r=0.121228 //w=0.232 //l=0.225 //layer=m1 \
 //thickness=0.36 //x=24.36 //y=5.335 //x2=24.36 //y2=5.56
r639 (  27 84 ) resistor r=9.3 //w=0.17 //l=0.17 //layer=mcon //count=1 \
 //x=23.48 //y=5.56 //x2=23.48 //y2=5.56
r640 (  25 27 ) resistor r=0.129608 //w=0.217 //l=0.225 //layer=m1 \
 //thickness=0.36 //x=23.482 //y=5.335 //x2=23.482 //y2=5.56
r641 (  23 52 ) resistor r=0.0911593 //w=0.376 //l=0.184608 //layer=m1 \
 //thickness=0.36 //x=37.86 //y=4.045 //x2=37.807 //y2=3.885
r642 (  23 58 ) resistor r=0.663168 //w=0.131 //l=0.695 //layer=m1 \
 //thickness=0.36 //x=37.86 //y=4.045 //x2=37.86 //y2=4.74
r643 (  22 50 ) resistor r=0.0894971 //w=0.376 //l=0.179555 //layer=m1 \
 //thickness=0.36 //x=37.86 //y=3.725 //x2=37.807 //y2=3.88
r644 (  21 54 ) resistor r=0.0933015 //w=0.201 //l=0.125 //layer=m1 \
 //thickness=0.36 //x=37.86 //y=2.385 //x2=37.86 //y2=2.26
r645 (  21 22 ) resistor r=1.27863 //w=0.131 //l=1.34 //layer=m1 \
 //thickness=0.36 //x=37.86 //y=2.385 //x2=37.86 //y2=3.725
r646 (  19 40 ) resistor r=0.0910802 //w=0.374 //l=0.185472 //layer=m1 \
 //thickness=0.36 //x=27.87 //y=4.04 //x2=27.815 //y2=3.88
r647 (  19 47 ) resistor r=0.667939 //w=0.131 //l=0.7 //layer=m1 \
 //thickness=0.36 //x=27.87 //y=4.04 //x2=27.87 //y2=4.74
r648 (  18 40 ) resistor r=0.0910802 //w=0.374 //l=0.185472 //layer=m1 \
 //thickness=0.36 //x=27.87 //y=3.72 //x2=27.815 //y2=3.88
r649 (  17 43 ) resistor r=0.0933015 //w=0.201 //l=0.125 //layer=m1 \
 //thickness=0.36 //x=27.87 //y=2.385 //x2=27.87 //y2=2.26
r650 (  17 18 ) resistor r=1.27385 //w=0.131 //l=1.335 //layer=m1 \
 //thickness=0.36 //x=27.87 //y=2.385 //x2=27.87 //y2=3.72
r651 (  15 37 ) resistor r=0.0911593 //w=0.376 //l=0.184174 //layer=m1 \
 //thickness=0.36 //x=26.02 //y=4.04 //x2=26.072 //y2=3.88
r652 (  15 16 ) resistor r=1.15458 //w=0.131 //l=1.21 //layer=m1 \
 //thickness=0.36 //x=26.02 //y=4.04 //x2=26.02 //y2=5.25
r653 (  14 37 ) resistor r=0.0911593 //w=0.376 //l=0.184174 //layer=m1 \
 //thickness=0.36 //x=26.02 //y=3.72 //x2=26.072 //y2=3.88
r654 (  13 14 ) resistor r=1.70802 //w=0.131 //l=1.79 //layer=m1 \
 //thickness=0.36 //x=26.02 //y=1.93 //x2=26.02 //y2=3.72
r655 (  11 13 ) resistor r=0.0698411 //w=0.17 //l=0.120208 //layer=m1 \
 //thickness=0.36 //x=25.935 //y=1.845 //x2=26.02 //y2=1.93
r656 (  11 12 ) resistor r=0.300573 //w=0.131 //l=0.315 //layer=m1 \
 //thickness=0.36 //x=25.935 //y=1.845 //x2=25.62 //y2=1.845
r657 (  10 12 ) resistor r=0.0698411 //w=0.17 //l=0.120208 //layer=m1 \
 //thickness=0.36 //x=25.535 //y=1.76 //x2=25.62 //y2=1.845
r658 (  9 35 ) resistor r=0.0717383 //w=0.224 //l=0.115 //layer=m1 \
 //thickness=0.36 //x=25.535 //y=1.305 //x2=25.535 //y2=1.19
r659 (  9 10 ) resistor r=0.43416 //w=0.131 //l=0.455 //layer=m1 \
 //thickness=0.36 //x=25.535 //y=1.305 //x2=25.535 //y2=1.76
r660 (  8 31 ) resistor r=0.0675342 //w=0.23 //l=0.115 //layer=m1 \
 //thickness=0.36 //x=25.355 //y=5.335 //x2=25.24 //y2=5.335
r661 (  7 16 ) resistor r=0.0698411 //w=0.17 //l=0.120208 //layer=m1 \
 //thickness=0.36 //x=25.935 //y=5.335 //x2=26.02 //y2=5.25
r662 (  7 8 ) resistor r=0.553435 //w=0.131 //l=0.58 //layer=m1 \
 //thickness=0.36 //x=25.935 //y=5.335 //x2=25.355 //y2=5.335
r663 (  6 33 ) resistor r=0.00118313 //w=0.23 //layer=m1 //thickness=0.36 \
 //x=25.24 //y=5.56 //x2=25.24 //y2=5.56
r664 (  5 31 ) resistor r=0.002872 //w=0.34 //l=0.085 //layer=m1 \
 //thickness=0.36 //x=25.24 //y=5.42 //x2=25.24 //y2=5.335
r665 (  5 6 ) resistor r=0.091623 //w=0.191 //l=0.14 //layer=m1 \
 //thickness=0.36 //x=25.24 //y=5.42 //x2=25.24 //y2=5.56
r666 (  4 28 ) resistor r=0.0262263 //w=0.232 //l=0.12 //layer=m1 \
 //thickness=0.36 //x=24.48 //y=5.335 //x2=24.36 //y2=5.335
r667 (  3 31 ) resistor r=0.0675342 //w=0.23 //l=0.115 //layer=m1 \
 //thickness=0.36 //x=25.125 //y=5.335 //x2=25.24 //y2=5.335
r668 (  3 4 ) resistor r=0.615458 //w=0.131 //l=0.645 //layer=m1 \
 //thickness=0.36 //x=25.125 //y=5.335 //x2=24.48 //y2=5.335
r669 (  2 25 ) resistor r=0.0222262 //w=0.217 //l=0.118 //layer=m1 \
 //thickness=0.36 //x=23.6 //y=5.335 //x2=23.482 //y2=5.335
r670 (  1 28 ) resistor r=0.0262263 //w=0.232 //l=0.12 //layer=m1 \
 //thickness=0.36 //x=24.24 //y=5.335 //x2=24.36 //y2=5.335
r671 (  1 2 ) resistor r=0.610687 //w=0.131 //l=0.64 //layer=m1 \
 //thickness=0.36 //x=24.24 //y=5.335 //x2=23.6 //y2=5.335
ends PM_TMRDFFQX1\%noxref_8

subckt PM_TMRDFFQX1\%noxref_9 ( 3 8 9 11 12 14 15 16 18 19 23 24 27 29 34 38 \
 40 43 44 51 53 54 57 65 82 91 95 96 97 98 99 100 101 105 107 110 111 121 124 \
 126 127 )
c278 ( 124 0 ) capacitor c=0.00878249f //x=38.71 //y=1.085
c279 ( 121 0 ) capacitor c=0.0646027f //x=41.19 //y=4.88
c280 ( 111 0 ) capacitor c=0.0318956f //x=41.525 //y=1.39
c281 ( 110 0 ) capacitor c=0.0186809f //x=41.525 //y=1.045
c282 ( 107 0 ) capacitor c=0.0141821f //x=41.37 //y=1.545
c283 ( 105 0 ) capacitor c=0.0158553f //x=41.37 //y=0.89
c284 ( 101 0 ) capacitor c=0.088055f //x=40.995 //y=2.095
c285 ( 100 0 ) capacitor c=0.0229235f //x=40.995 //y=1.7
c286 ( 99 0 ) capacitor c=0.0234359f //x=40.995 //y=1.39
c287 ( 98 0 ) capacitor c=0.0198759f //x=40.995 //y=1.045
c288 ( 97 0 ) capacitor c=0.110369f //x=41.53 //y=6.2
c289 ( 96 0 ) capacitor c=0.154619f //x=41.09 //y=6.2
c290 ( 91 0 ) capacitor c=8.13425e-19 //x=41.19 //y=4.88
c291 ( 82 0 ) capacitor c=8.01091e-19 //x=41.19 //y=2.26
c292 ( 65 0 ) capacitor c=0.0322017f //x=38.86 //y=5.56
c293 ( 57 0 ) capacitor c=0.0290186f //x=37.98 //y=5.56
c294 ( 54 0 ) capacitor c=0.0234059f //x=41.025 //y=3.865
c295 ( 53 0 ) capacitor c=8.85755e-19 //x=41.185 //y=3.865
c296 ( 51 0 ) capacitor c=8.2295e-19 //x=39.5 //y=3.865
c297 ( 44 0 ) capacitor c=0.0158653f //x=41.192 //y=4.74
c298 ( 43 0 ) capacitor c=0.00598864f //x=41.19 //y=4.88
c299 ( 40 0 ) capacitor c=0.00463527f //x=41.19 //y=2.26
c300 ( 38 0 ) capacitor c=0.0165926f //x=41.19 //y=3.88
c301 ( 34 0 ) capacitor c=0.0170475f //x=39.34 //y=3.88
c302 ( 29 0 ) capacitor c=0.0113259f //x=38.9 //y=1.18
c303 ( 27 0 ) capacitor c=5.78613e-19 //x=38.86 //y=5.56
c304 ( 24 0 ) capacitor c=0.0105334f //x=38.86 //y=5.38
c305 ( 23 0 ) capacitor c=0.00917086f //x=37.98 //y=5.56
c306 ( 19 0 ) capacitor c=0.0123184f //x=41.19 //y=4.025
c307 ( 18 0 ) capacitor c=0.03862f //x=41.19 //y=3.705
c308 ( 16 0 ) capacitor c=0.0304799f //x=39.34 //y=5.295
c309 ( 15 0 ) capacitor c=0.0135873f //x=39.34 //y=4.025
c310 ( 14 0 ) capacitor c=0.0505785f //x=39.34 //y=3.705
c311 ( 12 0 ) capacitor c=0.00465779f //x=38.985 //y=1.835
c312 ( 11 0 ) capacitor c=0.0117728f //x=39.255 //y=1.835
c313 ( 9 0 ) capacitor c=0.0111209f //x=39.255 //y=5.38
c314 ( 8 0 ) capacitor c=0.0101547f //x=38.9 //y=1.75
c315 ( 3 0 ) capacitor c=0.0147352f //x=38.745 //y=5.38
r316 (  119 121 ) resistor r=20.6867 //w=0.233 //l=0.1 //layer=ply \
 //thickness=0.18 //x=41.09 //y=4.88 //x2=41.19 //y2=4.88
r317 (  112 121 ) resistor r=70.3348 //w=0.233 //l=0.414367 //layer=ply \
 //thickness=0.18 //x=41.53 //y=5.045 //x2=41.19 //y2=4.88
r318 (  111 123 ) resistor r=45.1352 //w=0.168 //l=0.173853 //layer=ply \
 //thickness=0.18 //x=41.525 //y=1.39 //x2=41.485 //y2=1.545
r319 (  110 122 ) resistor r=45.1352 //w=0.168 //l=0.173853 //layer=ply \
 //thickness=0.18 //x=41.525 //y=1.045 //x2=41.485 //y2=0.89
r320 (  110 111 ) resistor r=176.904 //w=0.094 //l=0.345 //layer=ply \
 //thickness=0.18 //x=41.525 //y=1.045 //x2=41.525 //y2=1.39
r321 (  108 118 ) resistor r=10.701 //w=0.21 //l=0.115 //layer=ply \
 //thickness=0.18 //x=41.15 //y=1.545 //x2=41.035 //y2=1.545
r322 (  107 123 ) resistor r=5.52526 //w=0.168 //l=0.115 //layer=ply \
 //thickness=0.18 //x=41.37 //y=1.545 //x2=41.485 //y2=1.545
r323 (  106 117 ) resistor r=5.52526 //w=0.168 //l=0.115 //layer=ply \
 //thickness=0.18 //x=41.15 //y=0.89 //x2=41.035 //y2=0.89
r324 (  105 122 ) resistor r=5.52526 //w=0.168 //l=0.115 //layer=ply \
 //thickness=0.18 //x=41.37 //y=0.89 //x2=41.485 //y2=0.89
r325 (  105 106 ) resistor r=112.809 //w=0.094 //l=0.22 //layer=ply \
 //thickness=0.18 //x=41.37 //y=0.89 //x2=41.15 //y2=0.89
r326 (  102 119 ) resistor r=13.0941 //w=0.233 //l=0.165 //layer=ply \
 //thickness=0.18 //x=41.09 //y=5.045 //x2=41.09 //y2=4.88
r327 (  101 116 ) resistor r=34.8111 //w=0.27 //l=0.264953 //layer=ply \
 //thickness=0.18 //x=40.995 //y=2.095 //x2=41.19 //y2=2.26
r328 (  100 118 ) resistor r=39.5823 //w=0.21 //l=0.173853 //layer=ply \
 //thickness=0.18 //x=40.995 //y=1.7 //x2=41.035 //y2=1.545
r329 (  100 101 ) resistor r=202.543 //w=0.094 //l=0.395 //layer=ply \
 //thickness=0.18 //x=40.995 //y=1.7 //x2=40.995 //y2=2.095
r330 (  99 118 ) resistor r=39.5823 //w=0.21 //l=0.173853 //layer=ply \
 //thickness=0.18 //x=40.995 //y=1.39 //x2=41.035 //y2=1.545
r331 (  98 117 ) resistor r=45.1352 //w=0.168 //l=0.173853 //layer=ply \
 //thickness=0.18 //x=40.995 //y=1.045 //x2=41.035 //y2=0.89
r332 (  98 99 ) resistor r=176.904 //w=0.094 //l=0.345 //layer=ply \
 //thickness=0.18 //x=40.995 //y=1.045 //x2=40.995 //y2=1.39
r333 (  97 112 ) resistor r=592.245 //w=0.094 //l=1.155 //layer=ply \
 //thickness=0.18 //x=41.53 //y=6.2 //x2=41.53 //y2=5.045
r334 (  96 102 ) resistor r=592.245 //w=0.094 //l=1.155 //layer=ply \
 //thickness=0.18 //x=41.09 //y=6.2 //x2=41.09 //y2=5.045
r335 (  95 107 ) resistor r=56.4043 //w=0.094 //l=0.11 //layer=ply \
 //thickness=0.18 //x=41.26 //y=1.545 //x2=41.37 //y2=1.545
r336 (  95 108 ) resistor r=56.4043 //w=0.094 //l=0.11 //layer=ply \
 //thickness=0.18 //x=41.26 //y=1.545 //x2=41.15 //y2=1.545
r337 (  91 121 ) resistor r=152 //w=0.17 //l=0.17 //layer=licon //count=1 \
 //x=41.19 //y=4.88 //x2=41.19 //y2=4.88
r338 (  82 116 ) resistor r=152 //w=0.17 //l=0.17 //layer=licon //count=1 \
 //x=41.19 //y=2.26 //x2=41.19 //y2=2.26
r339 (  65 127 ) resistor r=23.615 //w=0.187 //l=0.345 //layer=li \
 //thickness=0.1 //x=38.86 //y=5.56 //x2=38.86 //y2=5.905
r340 (  57 126 ) resistor r=23.615 //w=0.187 //l=0.345 //layer=li \
 //thickness=0.1 //x=37.98 //y=5.56 //x2=37.98 //y2=5.905
r341 (  53 54 ) resistor r=0.10734 //w=0.281 //l=0.16 //layer=m2 \
 //thickness=0.36 //x=41.185 //y=3.865 //x2=41.025 //y2=3.865
r342 (  51 54 ) resistor r=1.45515 //w=0.131 //l=1.525 //layer=m2 \
 //thickness=0.36 //x=39.5 //y=3.88 //x2=41.025 //y2=3.88
r343 (  49 51 ) resistor r=0.10734 //w=0.281 //l=0.16 //layer=m2 \
 //thickness=0.36 //x=39.34 //y=3.865 //x2=39.5 //y2=3.865
r344 (  43 91 ) resistor r=9.3 //w=0.17 //l=0.17 //layer=mcon //count=1 \
 //x=41.19 //y=4.88 //x2=41.19 //y2=4.88
r345 (  43 44 ) resistor r=0.103207 //w=0.196 //l=0.14 //layer=m1 \
 //thickness=0.36 //x=41.192 //y=4.88 //x2=41.192 //y2=4.74
r346 (  40 82 ) resistor r=9.3 //w=0.17 //l=0.17 //layer=mcon //count=1 \
 //x=41.19 //y=2.26 //x2=41.19 //y2=2.26
r347 (  36 53 ) resistor r=4.5 //w=0.15 //l=0.15 //layer=via1 //count=1 \
 //x=41.185 //y=3.865 //x2=41.185 //y2=3.865
r348 (  36 38 ) resistor r=0.00501337 //w=0.374 //l=0.015 //layer=m1 \
 //thickness=0.36 //x=41.135 //y=3.865 //x2=41.135 //y2=3.88
r349 (  32 49 ) resistor r=4.5 //w=0.15 //l=0.15 //layer=via1 //count=1 \
 //x=39.34 //y=3.865 //x2=39.34 //y2=3.865
r350 (  32 34 ) resistor r=0.0049867 //w=0.376 //l=0.015 //layer=m1 \
 //thickness=0.36 //x=39.392 //y=3.865 //x2=39.392 //y2=3.88
r351 (  29 124 ) resistor r=9.3 //w=0.17 //l=0.17 //layer=mcon //count=1 \
 //x=38.9 //y=1.18 //x2=38.9 //y2=1.18
r352 (  27 65 ) resistor r=9.3 //w=0.17 //l=0.17 //layer=mcon //count=1 \
 //x=38.86 //y=5.56 //x2=38.86 //y2=5.56
r353 (  24 27 ) resistor r=0.117801 //w=0.191 //l=0.18 //layer=m1 \
 //thickness=0.36 //x=38.86 //y=5.38 //x2=38.86 //y2=5.56
r354 (  23 57 ) resistor r=9.3 //w=0.17 //l=0.17 //layer=mcon //count=1 \
 //x=37.98 //y=5.56 //x2=37.98 //y2=5.56
r355 (  21 23 ) resistor r=0.10274 //w=0.219 //l=0.18 //layer=m1 \
 //thickness=0.36 //x=37.98 //y=5.38 //x2=37.98 //y2=5.56
r356 (  19 38 ) resistor r=0.0860668 //w=0.374 //l=0.170294 //layer=m1 \
 //thickness=0.36 //x=41.19 //y=4.025 //x2=41.135 //y2=3.88
r357 (  19 44 ) resistor r=0.682252 //w=0.131 //l=0.715 //layer=m1 \
 //thickness=0.36 //x=41.19 //y=4.025 //x2=41.19 //y2=4.74
r358 (  18 36 ) resistor r=0.0910802 //w=0.374 //l=0.185472 //layer=m1 \
 //thickness=0.36 //x=41.19 //y=3.705 //x2=41.135 //y2=3.865
r359 (  17 40 ) resistor r=0.0933015 //w=0.201 //l=0.125 //layer=m1 \
 //thickness=0.36 //x=41.19 //y=2.385 //x2=41.19 //y2=2.26
r360 (  17 18 ) resistor r=1.25954 //w=0.131 //l=1.32 //layer=m1 \
 //thickness=0.36 //x=41.19 //y=2.385 //x2=41.19 //y2=3.705
r361 (  15 34 ) resistor r=0.0861726 //w=0.376 //l=0.169012 //layer=m1 \
 //thickness=0.36 //x=39.34 //y=4.025 //x2=39.392 //y2=3.88
r362 (  15 16 ) resistor r=1.21183 //w=0.131 //l=1.27 //layer=m1 \
 //thickness=0.36 //x=39.34 //y=4.025 //x2=39.34 //y2=5.295
r363 (  14 32 ) resistor r=0.0911593 //w=0.376 //l=0.184174 //layer=m1 \
 //thickness=0.36 //x=39.34 //y=3.705 //x2=39.392 //y2=3.865
r364 (  13 14 ) resistor r=1.70324 //w=0.131 //l=1.785 //layer=m1 \
 //thickness=0.36 //x=39.34 //y=1.92 //x2=39.34 //y2=3.705
r365 (  11 13 ) resistor r=0.0698411 //w=0.17 //l=0.120208 //layer=m1 \
 //thickness=0.36 //x=39.255 //y=1.835 //x2=39.34 //y2=1.92
r366 (  11 12 ) resistor r=0.257634 //w=0.131 //l=0.27 //layer=m1 \
 //thickness=0.36 //x=39.255 //y=1.835 //x2=38.985 //y2=1.835
r367 (  10 24 ) resistor r=0.0257089 //w=0.23 //l=0.115 //layer=m1 \
 //thickness=0.36 //x=38.975 //y=5.38 //x2=38.86 //y2=5.38
r368 (  9 16 ) resistor r=0.0698411 //w=0.17 //l=0.120208 //layer=m1 \
 //thickness=0.36 //x=39.255 //y=5.38 //x2=39.34 //y2=5.295
r369 (  9 10 ) resistor r=0.267176 //w=0.131 //l=0.28 //layer=m1 \
 //thickness=0.36 //x=39.255 //y=5.38 //x2=38.975 //y2=5.38
r370 (  8 12 ) resistor r=0.0698411 //w=0.17 //l=0.120208 //layer=m1 \
 //thickness=0.36 //x=38.9 //y=1.75 //x2=38.985 //y2=1.835
r371 (  7 29 ) resistor r=0.0913624 //w=0.191 //l=0.12 //layer=m1 \
 //thickness=0.36 //x=38.9 //y=1.3 //x2=38.9 //y2=1.18
r372 (  7 8 ) resistor r=0.429389 //w=0.131 //l=0.45 //layer=m1 \
 //thickness=0.36 //x=38.9 //y=1.3 //x2=38.9 //y2=1.75
r373 (  4 21 ) resistor r=0.0227762 //w=0.219 //l=0.115 //layer=m1 \
 //thickness=0.36 //x=38.095 //y=5.38 //x2=37.98 //y2=5.38
r374 (  3 24 ) resistor r=0.0257089 //w=0.23 //l=0.115 //layer=m1 \
 //thickness=0.36 //x=38.745 //y=5.38 //x2=38.86 //y2=5.38
r375 (  3 4 ) resistor r=0.620229 //w=0.131 //l=0.65 //layer=m1 \
 //thickness=0.36 //x=38.745 //y=5.38 //x2=38.095 //y2=5.38
ends PM_TMRDFFQX1\%noxref_9

subckt PM_TMRDFFQX1\%noxref_10 ( 1 2 3 4 6 7 8 11 16 17 19 20 22 23 24 26 27 \
 28 34 38 42 49 50 53 55 58 62 65 70 72 74 76 78 79 80 81 85 93 102 107 116 \
 121 129 146 155 159 160 161 162 163 164 165 166 167 168 169 170 171 172 174 \
 180 181 182 183 187 188 189 194 196 198 204 205 206 207 208 213 215 217 223 \
 224 234 235 238 247 248 251 259 261 262 )
c637 ( 259 0 ) capacitor c=0.00878249f //x=35.38 //y=1.085
c638 ( 251 0 ) capacitor c=0.0356006f //x=41.96 //y=4.88
c639 ( 248 0 ) capacitor c=0.0284095f //x=41.93 //y=2.095
c640 ( 247 0 ) capacitor c=0.046061f //x=41.93 //y=2.26
c641 ( 238 0 ) capacitor c=0.0354915f //x=31.97 //y=4.88
c642 ( 235 0 ) capacitor c=0.0284095f //x=31.94 //y=2.095
c643 ( 234 0 ) capacitor c=0.0476356f //x=31.94 //y=2.26
c644 ( 224 0 ) capacitor c=0.0439015f //x=42.495 //y=1.43
c645 ( 223 0 ) capacitor c=0.0192582f //x=42.495 //y=1.085
c646 ( 217 0 ) capacitor c=0.0162526f //x=42.34 //y=1.585
c647 ( 215 0 ) capacitor c=0.0157807f //x=42.34 //y=0.93
c648 ( 213 0 ) capacitor c=0.0372668f //x=42.335 //y=4.97
c649 ( 208 0 ) capacitor c=0.0210762f //x=41.965 //y=1.74
c650 ( 207 0 ) capacitor c=0.0168511f //x=41.965 //y=1.43
c651 ( 206 0 ) capacitor c=0.0175485f //x=41.965 //y=1.085
c652 ( 205 0 ) capacitor c=0.0439708f //x=32.505 //y=1.43
c653 ( 204 0 ) capacitor c=0.0192582f //x=32.505 //y=1.085
c654 ( 198 0 ) capacitor c=0.0162526f //x=32.35 //y=1.585
c655 ( 196 0 ) capacitor c=0.0157807f //x=32.35 //y=0.93
c656 ( 194 0 ) capacitor c=0.0372668f //x=32.345 //y=4.97
c657 ( 189 0 ) capacitor c=0.0210762f //x=31.975 //y=1.74
c658 ( 188 0 ) capacitor c=0.0168511f //x=31.975 //y=1.43
c659 ( 187 0 ) capacitor c=0.0175485f //x=31.975 //y=1.085
c660 ( 183 0 ) capacitor c=0.0552496f //x=23.335 //y=4.97
c661 ( 182 0 ) capacitor c=0.0376038f //x=23.625 //y=4.97
c662 ( 181 0 ) capacitor c=0.0346489f //x=23.29 //y=1.4
c663 ( 180 0 ) capacitor c=0.018692f //x=23.29 //y=1.055
c664 ( 174 0 ) capacitor c=0.0137077f //x=23.135 //y=1.555
c665 ( 172 0 ) capacitor c=0.0158585f //x=23.135 //y=0.9
c666 ( 171 0 ) capacitor c=0.103534f //x=22.76 //y=2.095
c667 ( 170 0 ) capacitor c=0.0229444f //x=22.76 //y=1.71
c668 ( 169 0 ) capacitor c=0.0234359f //x=22.76 //y=1.4
c669 ( 168 0 ) capacitor c=0.019815f //x=22.76 //y=1.055
c670 ( 167 0 ) capacitor c=0.155269f //x=42.41 //y=6.2
c671 ( 166 0 ) capacitor c=0.110375f //x=41.97 //y=6.2
c672 ( 165 0 ) capacitor c=0.155269f //x=32.42 //y=6.2
c673 ( 164 0 ) capacitor c=0.110375f //x=31.98 //y=6.2
c674 ( 163 0 ) capacitor c=0.110208f //x=23.7 //y=6.2
c675 ( 162 0 ) capacitor c=0.158957f //x=23.26 //y=6.2
c676 ( 155 0 ) capacitor c=5.80994e-19 //x=41.96 //y=4.88
c677 ( 146 0 ) capacitor c=5.78095e-19 //x=41.93 //y=2.26
c678 ( 129 0 ) capacitor c=0.0319332f //x=35.53 //y=5.56
c679 ( 121 0 ) capacitor c=0.0291719f //x=34.65 //y=5.56
c680 ( 116 0 ) capacitor c=5.80994e-19 //x=31.97 //y=4.88
c681 ( 107 0 ) capacitor c=5.78095e-19 //x=31.94 //y=2.26
c682 ( 102 0 ) capacitor c=0.00129098f //x=23.06 //y=4.88
c683 ( 93 0 ) capacitor c=0.0012618f //x=23.06 //y=2.26
c684 ( 85 0 ) capacitor c=0.00112471f //x=23.225 //y=4.255
c685 ( 81 0 ) capacitor c=0.0199655f //x=37.73 //y=4.27
c686 ( 80 0 ) capacitor c=0.0412164f //x=38.075 //y=4.27
c687 ( 79 0 ) capacitor c=0.034449f //x=32.105 //y=4.25
c688 ( 78 0 ) capacitor c=0.0338287f //x=35.84 //y=4.25
c689 ( 76 0 ) capacitor c=0.00147451f //x=28.08 //y=4.265
c690 ( 74 0 ) capacitor c=0.0153988f //x=27.48 //y=4.25
c691 ( 72 0 ) capacitor c=0.00416722f //x=26.235 //y=4.265
c692 ( 70 0 ) capacitor c=0.0313219f //x=25.635 //y=4.25
c693 ( 65 0 ) capacitor c=0.00504418f //x=41.93 //y=2.26
c694 ( 62 0 ) capacitor c=0.0150367f //x=41.93 //y=4.25
c695 ( 58 0 ) capacitor c=0.015184f //x=36.01 //y=4.25
c696 ( 55 0 ) capacitor c=0.0113735f //x=35.57 //y=1.18
c697 ( 53 0 ) capacitor c=5.78613e-19 //x=35.53 //y=5.56
c698 ( 50 0 ) capacitor c=0.00999937f //x=35.53 //y=5.38
c699 ( 49 0 ) capacitor c=0.00933207f //x=34.65 //y=5.56
c700 ( 42 0 ) capacitor c=0.00662515f //x=31.94 //y=2.26
c701 ( 38 0 ) capacitor c=0.0143744f //x=31.94 //y=4.25
c702 ( 34 0 ) capacitor c=0.0159434f //x=23.06 //y=4.25
c703 ( 28 0 ) capacitor c=0.00917813f //x=41.93 //y=4.735
c704 ( 27 0 ) capacitor c=0.00983725f //x=41.93 //y=4.41
c705 ( 26 0 ) capacitor c=0.0388777f //x=41.93 //y=4.09
c706 ( 24 0 ) capacitor c=0.0191047f //x=36.01 //y=5.295
c707 ( 23 0 ) capacitor c=0.012741f //x=36.01 //y=4.425
c708 ( 22 0 ) capacitor c=0.058651f //x=36.01 //y=4.105
c709 ( 20 0 ) capacitor c=0.00560492f //x=35.655 //y=1.835
c710 ( 19 0 ) capacitor c=0.0131084f //x=35.925 //y=1.835
c711 ( 17 0 ) capacitor c=0.0101152f //x=35.925 //y=5.38
c712 ( 16 0 ) capacitor c=0.0101547f //x=35.57 //y=1.75
c713 ( 11 0 ) capacitor c=0.0142466f //x=35.415 //y=5.38
c714 ( 8 0 ) capacitor c=0.00908133f //x=31.94 //y=4.735
c715 ( 7 0 ) capacitor c=0.00995231f //x=31.94 //y=4.415
c716 ( 6 0 ) capacitor c=0.033867f //x=31.94 //y=4.095
c717 ( 4 0 ) capacitor c=0.0140142f //x=23.06 //y=4.755
c718 ( 3 0 ) capacitor c=0.0125872f //x=23.06 //y=4.415
c719 ( 2 0 ) capacitor c=0.0562682f //x=23.06 //y=4.095
c720 ( 1 0 ) capacitor c=0.00681376f //x=23.06 //y=2.375
r721 (  253 254 ) resistor r=32.4568 //w=0.214 //l=0.075 //layer=ply \
 //thickness=0.18 //x=41.96 //y=4.97 //x2=41.96 //y2=5.045
r722 (  251 253 ) resistor r=20.271 //w=0.214 //l=0.09 //layer=ply \
 //thickness=0.18 //x=41.96 //y=4.88 //x2=41.96 //y2=4.97
r723 (  247 248 ) resistor r=52.7279 //w=0.214 //l=0.165 //layer=ply \
 //thickness=0.18 //x=41.93 //y=2.26 //x2=41.93 //y2=2.095
r724 (  240 241 ) resistor r=32.4568 //w=0.214 //l=0.075 //layer=ply \
 //thickness=0.18 //x=31.97 //y=4.97 //x2=31.97 //y2=5.045
r725 (  238 240 ) resistor r=20.271 //w=0.214 //l=0.09 //layer=ply \
 //thickness=0.18 //x=31.97 //y=4.88 //x2=31.97 //y2=4.97
r726 (  234 235 ) resistor r=52.7279 //w=0.214 //l=0.165 //layer=ply \
 //thickness=0.18 //x=31.94 //y=2.26 //x2=31.94 //y2=2.095
r727 (  224 258 ) resistor r=45.1352 //w=0.168 //l=0.173853 //layer=ply \
 //thickness=0.18 //x=42.495 //y=1.43 //x2=42.455 //y2=1.585
r728 (  223 257 ) resistor r=45.1352 //w=0.168 //l=0.173853 //layer=ply \
 //thickness=0.18 //x=42.495 //y=1.085 //x2=42.455 //y2=0.93
r729 (  223 224 ) resistor r=176.904 //w=0.094 //l=0.345 //layer=ply \
 //thickness=0.18 //x=42.495 //y=1.085 //x2=42.495 //y2=1.43
r730 (  218 256 ) resistor r=10.701 //w=0.21 //l=0.115 //layer=ply \
 //thickness=0.18 //x=42.12 //y=1.585 //x2=42.005 //y2=1.585
r731 (  217 258 ) resistor r=5.52526 //w=0.168 //l=0.115 //layer=ply \
 //thickness=0.18 //x=42.34 //y=1.585 //x2=42.455 //y2=1.585
r732 (  216 255 ) resistor r=5.52526 //w=0.168 //l=0.115 //layer=ply \
 //thickness=0.18 //x=42.12 //y=0.93 //x2=42.005 //y2=0.93
r733 (  215 257 ) resistor r=5.52526 //w=0.168 //l=0.115 //layer=ply \
 //thickness=0.18 //x=42.34 //y=0.93 //x2=42.455 //y2=0.93
r734 (  215 216 ) resistor r=112.809 //w=0.094 //l=0.22 //layer=ply \
 //thickness=0.18 //x=42.34 //y=0.93 //x2=42.12 //y2=0.93
r735 (  214 253 ) resistor r=16.5046 //w=0.27 //l=0.135 //layer=ply \
 //thickness=0.18 //x=42.095 //y=4.97 //x2=41.96 //y2=4.97
r736 (  213 220 ) resistor r=26.9307 //w=0.15 //l=0.106066 //layer=ply \
 //thickness=0.18 //x=42.335 //y=4.97 //x2=42.41 //y2=5.045
r737 (  213 214 ) resistor r=123.064 //w=0.094 //l=0.24 //layer=ply \
 //thickness=0.18 //x=42.335 //y=4.97 //x2=42.095 //y2=4.97
r738 (  208 256 ) resistor r=39.5823 //w=0.21 //l=0.173853 //layer=ply \
 //thickness=0.18 //x=41.965 //y=1.74 //x2=42.005 //y2=1.585
r739 (  208 248 ) resistor r=182.032 //w=0.094 //l=0.355 //layer=ply \
 //thickness=0.18 //x=41.965 //y=1.74 //x2=41.965 //y2=2.095
r740 (  207 256 ) resistor r=39.5823 //w=0.21 //l=0.173853 //layer=ply \
 //thickness=0.18 //x=41.965 //y=1.43 //x2=42.005 //y2=1.585
r741 (  206 255 ) resistor r=45.1352 //w=0.168 //l=0.173853 //layer=ply \
 //thickness=0.18 //x=41.965 //y=1.085 //x2=42.005 //y2=0.93
r742 (  206 207 ) resistor r=176.904 //w=0.094 //l=0.345 //layer=ply \
 //thickness=0.18 //x=41.965 //y=1.085 //x2=41.965 //y2=1.43
r743 (  205 245 ) resistor r=45.1352 //w=0.168 //l=0.173853 //layer=ply \
 //thickness=0.18 //x=32.505 //y=1.43 //x2=32.465 //y2=1.585
r744 (  204 244 ) resistor r=45.1352 //w=0.168 //l=0.173853 //layer=ply \
 //thickness=0.18 //x=32.505 //y=1.085 //x2=32.465 //y2=0.93
r745 (  204 205 ) resistor r=176.904 //w=0.094 //l=0.345 //layer=ply \
 //thickness=0.18 //x=32.505 //y=1.085 //x2=32.505 //y2=1.43
r746 (  199 243 ) resistor r=10.701 //w=0.21 //l=0.115 //layer=ply \
 //thickness=0.18 //x=32.13 //y=1.585 //x2=32.015 //y2=1.585
r747 (  198 245 ) resistor r=5.52526 //w=0.168 //l=0.115 //layer=ply \
 //thickness=0.18 //x=32.35 //y=1.585 //x2=32.465 //y2=1.585
r748 (  197 242 ) resistor r=5.52526 //w=0.168 //l=0.115 //layer=ply \
 //thickness=0.18 //x=32.13 //y=0.93 //x2=32.015 //y2=0.93
r749 (  196 244 ) resistor r=5.52526 //w=0.168 //l=0.115 //layer=ply \
 //thickness=0.18 //x=32.35 //y=0.93 //x2=32.465 //y2=0.93
r750 (  196 197 ) resistor r=112.809 //w=0.094 //l=0.22 //layer=ply \
 //thickness=0.18 //x=32.35 //y=0.93 //x2=32.13 //y2=0.93
r751 (  195 240 ) resistor r=16.5046 //w=0.27 //l=0.135 //layer=ply \
 //thickness=0.18 //x=32.105 //y=4.97 //x2=31.97 //y2=4.97
r752 (  194 201 ) resistor r=26.9307 //w=0.15 //l=0.106066 //layer=ply \
 //thickness=0.18 //x=32.345 //y=4.97 //x2=32.42 //y2=5.045
r753 (  194 195 ) resistor r=123.064 //w=0.094 //l=0.24 //layer=ply \
 //thickness=0.18 //x=32.345 //y=4.97 //x2=32.105 //y2=4.97
r754 (  189 243 ) resistor r=39.5823 //w=0.21 //l=0.173853 //layer=ply \
 //thickness=0.18 //x=31.975 //y=1.74 //x2=32.015 //y2=1.585
r755 (  189 235 ) resistor r=182.032 //w=0.094 //l=0.355 //layer=ply \
 //thickness=0.18 //x=31.975 //y=1.74 //x2=31.975 //y2=2.095
r756 (  188 243 ) resistor r=39.5823 //w=0.21 //l=0.173853 //layer=ply \
 //thickness=0.18 //x=31.975 //y=1.43 //x2=32.015 //y2=1.585
r757 (  187 242 ) resistor r=45.1352 //w=0.168 //l=0.173853 //layer=ply \
 //thickness=0.18 //x=31.975 //y=1.085 //x2=32.015 //y2=0.93
r758 (  187 188 ) resistor r=176.904 //w=0.094 //l=0.345 //layer=ply \
 //thickness=0.18 //x=31.975 //y=1.085 //x2=31.975 //y2=1.43
r759 (  182 184 ) resistor r=26.9307 //w=0.15 //l=0.106066 //layer=ply \
 //thickness=0.18 //x=23.625 //y=4.97 //x2=23.7 //y2=5.045
r760 (  182 183 ) resistor r=148.702 //w=0.094 //l=0.29 //layer=ply \
 //thickness=0.18 //x=23.625 //y=4.97 //x2=23.335 //y2=4.97
r761 (  181 232 ) resistor r=45.1352 //w=0.168 //l=0.173853 //layer=ply \
 //thickness=0.18 //x=23.29 //y=1.4 //x2=23.25 //y2=1.555
r762 (  180 231 ) resistor r=45.1352 //w=0.168 //l=0.173853 //layer=ply \
 //thickness=0.18 //x=23.29 //y=1.055 //x2=23.25 //y2=0.9
r763 (  180 181 ) resistor r=176.904 //w=0.094 //l=0.345 //layer=ply \
 //thickness=0.18 //x=23.29 //y=1.055 //x2=23.29 //y2=1.4
r764 (  177 183 ) resistor r=22.7971 //w=0.269 //l=0.106066 //layer=ply \
 //thickness=0.18 //x=23.26 //y=5.045 //x2=23.335 //y2=4.97
r765 (  177 230 ) resistor r=35.8364 //w=0.269 //l=0.270185 //layer=ply \
 //thickness=0.18 //x=23.26 //y=5.045 //x2=23.06 //y2=4.88
r766 (  175 226 ) resistor r=10.701 //w=0.21 //l=0.115 //layer=ply \
 //thickness=0.18 //x=22.915 //y=1.555 //x2=22.8 //y2=1.555
r767 (  174 232 ) resistor r=5.52526 //w=0.168 //l=0.115 //layer=ply \
 //thickness=0.18 //x=23.135 //y=1.555 //x2=23.25 //y2=1.555
r768 (  173 225 ) resistor r=5.52526 //w=0.168 //l=0.115 //layer=ply \
 //thickness=0.18 //x=22.915 //y=0.9 //x2=22.8 //y2=0.9
r769 (  172 231 ) resistor r=5.52526 //w=0.168 //l=0.115 //layer=ply \
 //thickness=0.18 //x=23.135 //y=0.9 //x2=23.25 //y2=0.9
r770 (  172 173 ) resistor r=112.809 //w=0.094 //l=0.22 //layer=ply \
 //thickness=0.18 //x=23.135 //y=0.9 //x2=22.915 //y2=0.9
r771 (  171 228 ) resistor r=58.7805 //w=0.246 //l=0.373497 //layer=ply \
 //thickness=0.18 //x=22.76 //y=2.095 //x2=23.06 //y2=2.26
r772 (  170 226 ) resistor r=39.5823 //w=0.21 //l=0.173853 //layer=ply \
 //thickness=0.18 //x=22.76 //y=1.71 //x2=22.8 //y2=1.555
r773 (  170 171 ) resistor r=197.415 //w=0.094 //l=0.385 //layer=ply \
 //thickness=0.18 //x=22.76 //y=1.71 //x2=22.76 //y2=2.095
r774 (  169 226 ) resistor r=39.5823 //w=0.21 //l=0.173853 //layer=ply \
 //thickness=0.18 //x=22.76 //y=1.4 //x2=22.8 //y2=1.555
r775 (  168 225 ) resistor r=45.1352 //w=0.168 //l=0.173853 //layer=ply \
 //thickness=0.18 //x=22.76 //y=1.055 //x2=22.8 //y2=0.9
r776 (  168 169 ) resistor r=176.904 //w=0.094 //l=0.345 //layer=ply \
 //thickness=0.18 //x=22.76 //y=1.055 //x2=22.76 //y2=1.4
r777 (  167 220 ) resistor r=592.245 //w=0.094 //l=1.155 //layer=ply \
 //thickness=0.18 //x=42.41 //y=6.2 //x2=42.41 //y2=5.045
r778 (  166 254 ) resistor r=592.245 //w=0.094 //l=1.155 //layer=ply \
 //thickness=0.18 //x=41.97 //y=6.2 //x2=41.97 //y2=5.045
r779 (  165 201 ) resistor r=592.245 //w=0.094 //l=1.155 //layer=ply \
 //thickness=0.18 //x=32.42 //y=6.2 //x2=32.42 //y2=5.045
r780 (  164 241 ) resistor r=592.245 //w=0.094 //l=1.155 //layer=ply \
 //thickness=0.18 //x=31.98 //y=6.2 //x2=31.98 //y2=5.045
r781 (  163 184 ) resistor r=592.245 //w=0.094 //l=1.155 //layer=ply \
 //thickness=0.18 //x=23.7 //y=6.2 //x2=23.7 //y2=5.045
r782 (  162 177 ) resistor r=592.245 //w=0.094 //l=1.155 //layer=ply \
 //thickness=0.18 //x=23.26 //y=6.2 //x2=23.26 //y2=5.045
r783 (  161 217 ) resistor r=56.4043 //w=0.094 //l=0.11 //layer=ply \
 //thickness=0.18 //x=42.23 //y=1.585 //x2=42.34 //y2=1.585
r784 (  161 218 ) resistor r=56.4043 //w=0.094 //l=0.11 //layer=ply \
 //thickness=0.18 //x=42.23 //y=1.585 //x2=42.12 //y2=1.585
r785 (  160 198 ) resistor r=56.4043 //w=0.094 //l=0.11 //layer=ply \
 //thickness=0.18 //x=32.24 //y=1.585 //x2=32.35 //y2=1.585
r786 (  160 199 ) resistor r=56.4043 //w=0.094 //l=0.11 //layer=ply \
 //thickness=0.18 //x=32.24 //y=1.585 //x2=32.13 //y2=1.585
r787 (  159 174 ) resistor r=56.4043 //w=0.094 //l=0.11 //layer=ply \
 //thickness=0.18 //x=23.025 //y=1.555 //x2=23.135 //y2=1.555
r788 (  159 175 ) resistor r=56.4043 //w=0.094 //l=0.11 //layer=ply \
 //thickness=0.18 //x=23.025 //y=1.555 //x2=22.915 //y2=1.555
r789 (  155 251 ) resistor r=152 //w=0.17 //l=0.17 //layer=licon //count=1 \
 //x=41.96 //y=4.88 //x2=41.96 //y2=4.88
r790 (  146 247 ) resistor r=152 //w=0.17 //l=0.17 //layer=licon //count=1 \
 //x=41.93 //y=2.26 //x2=41.93 //y2=2.26
r791 (  129 262 ) resistor r=23.615 //w=0.187 //l=0.345 //layer=li \
 //thickness=0.1 //x=35.53 //y=5.56 //x2=35.53 //y2=5.905
r792 (  121 261 ) resistor r=23.615 //w=0.187 //l=0.345 //layer=li \
 //thickness=0.1 //x=34.65 //y=5.56 //x2=34.65 //y2=5.905
r793 (  116 238 ) resistor r=152 //w=0.17 //l=0.17 //layer=licon //count=1 \
 //x=31.97 //y=4.88 //x2=31.97 //y2=4.88
r794 (  107 234 ) resistor r=152 //w=0.17 //l=0.17 //layer=licon //count=1 \
 //x=31.94 //y=2.26 //x2=31.94 //y2=2.26
r795 (  102 230 ) resistor r=152 //w=0.17 //l=0.17 //layer=licon //count=1 \
 //x=23.06 //y=4.88 //x2=23.06 //y2=4.88
r796 (  93 228 ) resistor r=152 //w=0.17 //l=0.17 //layer=licon //count=1 \
 //x=23.06 //y=2.26 //x2=23.06 //y2=2.26
r797 (  83 85 ) resistor r=0.10734 //w=0.281 //l=0.16 //layer=m2 \
 //thickness=0.36 //x=23.065 //y=4.255 //x2=23.225 //y2=4.255
r798 (  81 89 ) resistor r=1.10585 //w=0.196 //l=1.7325 //layer=m2 \
 //thickness=0.36 //x=37.73 //y=4.27 //x2=36 //y2=4.265
r799 (  80 91 ) resistor r=2.64838 //w=0.182 //l=3.86499 //layer=m2 \
 //thickness=0.36 //x=38.075 //y=4.27 //x2=41.93 //y2=4.25
r800 (  80 81 ) resistor r=0.329198 //w=0.131 //l=0.345 //layer=m2 \
 //thickness=0.36 //x=38.075 //y=4.27 //x2=37.73 //y2=4.27
r801 (  79 87 ) resistor r=0.110608 //w=0.182 //l=0.162481 //layer=m2 \
 //thickness=0.36 //x=32.105 //y=4.25 //x2=31.945 //y2=4.255
r802 (  78 89 ) resistor r=0.104578 //w=0.196 //l=0.167332 //layer=m2 \
 //thickness=0.36 //x=35.84 //y=4.25 //x2=36 //y2=4.265
r803 (  78 79 ) resistor r=3.56393 //w=0.131 //l=3.735 //layer=m2 \
 //thickness=0.36 //x=35.84 //y=4.25 //x2=32.105 //y2=4.25
r804 (  76 87 ) resistor r=2.65525 //w=0.182 //l=3.87 //layer=m2 \
 //thickness=0.36 //x=28.08 //y=4.265 //x2=31.945 //y2=4.255
r805 (  76 77 ) resistor r=0.329198 //w=0.131 //l=0.345 //layer=m2 \
 //thickness=0.36 //x=28.08 //y=4.265 //x2=27.735 //y2=4.265
r806 (  74 77 ) resistor r=0.1875 //w=0.17 //l=0.262393 //layer=m2 \
 //thickness=0.36 //x=27.48 //y=4.25 //x2=27.735 //y2=4.265
r807 (  74 75 ) resistor r=1.02576 //w=0.131 //l=1.075 //layer=m2 \
 //thickness=0.36 //x=27.48 //y=4.25 //x2=26.405 //y2=4.25
r808 (  72 75 ) resistor r=0.125 //w=0.17 //l=0.177341 //layer=m2 \
 //thickness=0.36 //x=26.235 //y=4.265 //x2=26.405 //y2=4.25
r809 (  72 73 ) resistor r=0.329198 //w=0.131 //l=0.345 //layer=m2 \
 //thickness=0.36 //x=26.235 //y=4.265 //x2=25.89 //y2=4.265
r810 (  70 73 ) resistor r=0.1875 //w=0.17 //l=0.262393 //layer=m2 \
 //thickness=0.36 //x=25.635 //y=4.25 //x2=25.89 //y2=4.265
r811 (  70 85 ) resistor r=2.29962 //w=0.131 //l=2.41 //layer=m2 \
 //thickness=0.36 //x=25.635 //y=4.25 //x2=23.225 //y2=4.25
r812 (  69 155 ) resistor r=9.3 //w=0.17 //l=0.17 //layer=mcon //count=1 \
 //x=41.96 //y=4.88 //x2=41.96 //y2=4.88
r813 (  65 146 ) resistor r=9.3 //w=0.17 //l=0.17 //layer=mcon //count=1 \
 //x=41.93 //y=2.26 //x2=41.93 //y2=2.26
r814 (  65 67 ) resistor r=0.0936408 //w=0.196 //l=0.125 //layer=m1 \
 //thickness=0.36 //x=41.932 //y=2.26 //x2=41.932 //y2=2.385
r815 (  62 91 ) resistor r=4.5 //w=0.15 //l=0.15 //layer=via1 //count=1 \
 //x=41.93 //y=4.25 //x2=41.93 //y2=4.25
r816 (  60 89 ) resistor r=4.5 //w=0.15 //l=0.15 //layer=via1 //count=1 //x=36 \
 //y=4.265 //x2=36 //y2=4.265
r817 (  58 60 ) resistor r=0.00505391 //w=0.371 //l=0.015 //layer=m1 \
 //thickness=0.36 //x=35.952 //y=4.25 //x2=35.952 //y2=4.265
r818 (  55 259 ) resistor r=9.3 //w=0.17 //l=0.17 //layer=mcon //count=1 \
 //x=35.57 //y=1.18 //x2=35.57 //y2=1.18
r819 (  53 129 ) resistor r=9.3 //w=0.17 //l=0.17 //layer=mcon //count=1 \
 //x=35.53 //y=5.56 //x2=35.53 //y2=5.56
r820 (  50 53 ) resistor r=0.117801 //w=0.191 //l=0.18 //layer=m1 \
 //thickness=0.36 //x=35.53 //y=5.38 //x2=35.53 //y2=5.56
r821 (  49 121 ) resistor r=9.3 //w=0.17 //l=0.17 //layer=mcon //count=1 \
 //x=34.65 //y=5.56 //x2=34.65 //y2=5.56
r822 (  47 49 ) resistor r=0.10274 //w=0.219 //l=0.18 //layer=m1 \
 //thickness=0.36 //x=34.65 //y=5.38 //x2=34.65 //y2=5.56
r823 (  46 116 ) resistor r=9.3 //w=0.17 //l=0.17 //layer=mcon //count=1 \
 //x=31.97 //y=4.88 //x2=31.97 //y2=4.88
r824 (  42 107 ) resistor r=9.3 //w=0.17 //l=0.17 //layer=mcon //count=1 \
 //x=31.94 //y=2.26 //x2=31.94 //y2=2.26
r825 (  42 44 ) resistor r=0.0936408 //w=0.196 //l=0.125 //layer=m1 \
 //thickness=0.36 //x=31.942 //y=2.26 //x2=31.942 //y2=2.385
r826 (  40 87 ) resistor r=4.5 //w=0.15 //l=0.15 //layer=via1 //count=1 \
 //x=31.945 //y=4.255 //x2=31.945 //y2=4.255
r827 (  38 40 ) resistor r=0.00164908 //w=0.379 //l=0.005 //layer=m1 \
 //thickness=0.36 //x=31.89 //y=4.25 //x2=31.89 //y2=4.255
r828 (  36 83 ) resistor r=4.5 //w=0.15 //l=0.15 //layer=via1 //count=1 \
 //x=23.065 //y=4.255 //x2=23.065 //y2=4.255
r829 (  34 36 ) resistor r=0.00167112 //w=0.374 //l=0.005 //layer=m1 \
 //thickness=0.36 //x=23.115 //y=4.25 //x2=23.115 //y2=4.255
r830 (  32 102 ) resistor r=9.3 //w=0.17 //l=0.17 //layer=mcon //count=1 \
 //x=23.06 //y=4.88 //x2=23.06 //y2=4.88
r831 (  30 93 ) resistor r=9.3 //w=0.17 //l=0.17 //layer=mcon //count=1 \
 //x=23.06 //y=2.26 //x2=23.06 //y2=2.26
r832 (  28 69 ) resistor r=0.0878548 //w=0.228 //l=0.159295 //layer=m1 \
 //thickness=0.36 //x=41.93 //y=4.735 //x2=41.96 //y2=4.88
r833 (  27 62 ) resistor r=0.0911593 //w=0.376 //l=0.184608 //layer=m1 \
 //thickness=0.36 //x=41.93 //y=4.41 //x2=41.877 //y2=4.25
r834 (  27 28 ) resistor r=0.310115 //w=0.131 //l=0.325 //layer=m1 \
 //thickness=0.36 //x=41.93 //y=4.41 //x2=41.93 //y2=4.735
r835 (  26 62 ) resistor r=0.0911593 //w=0.376 //l=0.184608 //layer=m1 \
 //thickness=0.36 //x=41.93 //y=4.09 //x2=41.877 //y2=4.25
r836 (  26 67 ) resistor r=1.62691 //w=0.131 //l=1.705 //layer=m1 \
 //thickness=0.36 //x=41.93 //y=4.09 //x2=41.93 //y2=2.385
r837 (  23 60 ) resistor r=0.0909648 //w=0.371 //l=0.186762 //layer=m1 \
 //thickness=0.36 //x=36.01 //y=4.425 //x2=35.952 //y2=4.265
r838 (  23 24 ) resistor r=0.830153 //w=0.131 //l=0.87 //layer=m1 \
 //thickness=0.36 //x=36.01 //y=4.425 //x2=36.01 //y2=5.295
r839 (  22 58 ) resistor r=0.0859108 //w=0.371 //l=0.171566 //layer=m1 \
 //thickness=0.36 //x=36.01 //y=4.105 //x2=35.952 //y2=4.25
r840 (  21 22 ) resistor r=2.08492 //w=0.131 //l=2.185 //layer=m1 \
 //thickness=0.36 //x=36.01 //y=1.92 //x2=36.01 //y2=4.105
r841 (  19 21 ) resistor r=0.0698411 //w=0.17 //l=0.120208 //layer=m1 \
 //thickness=0.36 //x=35.925 //y=1.835 //x2=36.01 //y2=1.92
r842 (  19 20 ) resistor r=0.257634 //w=0.131 //l=0.27 //layer=m1 \
 //thickness=0.36 //x=35.925 //y=1.835 //x2=35.655 //y2=1.835
r843 (  18 50 ) resistor r=0.0257089 //w=0.23 //l=0.115 //layer=m1 \
 //thickness=0.36 //x=35.645 //y=5.38 //x2=35.53 //y2=5.38
r844 (  17 24 ) resistor r=0.0698411 //w=0.17 //l=0.120208 //layer=m1 \
 //thickness=0.36 //x=35.925 //y=5.38 //x2=36.01 //y2=5.295
r845 (  17 18 ) resistor r=0.267176 //w=0.131 //l=0.28 //layer=m1 \
 //thickness=0.36 //x=35.925 //y=5.38 //x2=35.645 //y2=5.38
r846 (  16 20 ) resistor r=0.0698411 //w=0.17 //l=0.120208 //layer=m1 \
 //thickness=0.36 //x=35.57 //y=1.75 //x2=35.655 //y2=1.835
r847 (  15 55 ) resistor r=0.0913624 //w=0.191 //l=0.12 //layer=m1 \
 //thickness=0.36 //x=35.57 //y=1.3 //x2=35.57 //y2=1.18
r848 (  15 16 ) resistor r=0.429389 //w=0.131 //l=0.45 //layer=m1 \
 //thickness=0.36 //x=35.57 //y=1.3 //x2=35.57 //y2=1.75
r849 (  12 47 ) resistor r=0.0227762 //w=0.219 //l=0.115 //layer=m1 \
 //thickness=0.36 //x=34.765 //y=5.38 //x2=34.65 //y2=5.38
r850 (  11 50 ) resistor r=0.0257089 //w=0.23 //l=0.115 //layer=m1 \
 //thickness=0.36 //x=35.415 //y=5.38 //x2=35.53 //y2=5.38
r851 (  11 12 ) resistor r=0.620229 //w=0.131 //l=0.65 //layer=m1 \
 //thickness=0.36 //x=35.415 //y=5.38 //x2=34.765 //y2=5.38
r852 (  8 46 ) resistor r=0.0878548 //w=0.228 //l=0.159295 //layer=m1 \
 //thickness=0.36 //x=31.94 //y=4.735 //x2=31.97 //y2=4.88
r853 (  7 40 ) resistor r=0.0912814 //w=0.379 //l=0.183303 //layer=m1 \
 //thickness=0.36 //x=31.94 //y=4.415 //x2=31.89 //y2=4.255
r854 (  7 8 ) resistor r=0.305344 //w=0.131 //l=0.32 //layer=m1 \
 //thickness=0.36 //x=31.94 //y=4.415 //x2=31.94 //y2=4.735
r855 (  6 38 ) resistor r=0.0896323 //w=0.379 //l=0.178255 //layer=m1 \
 //thickness=0.36 //x=31.94 //y=4.095 //x2=31.89 //y2=4.25
r856 (  6 44 ) resistor r=1.63168 //w=0.131 //l=1.71 //layer=m1 \
 //thickness=0.36 //x=31.94 //y=4.095 //x2=31.94 //y2=2.385
r857 (  4 32 ) resistor r=0.0760407 //w=0.238 //l=0.125 //layer=m1 \
 //thickness=0.36 //x=23.06 //y=4.755 //x2=23.06 //y2=4.88
r858 (  3 36 ) resistor r=0.0910802 //w=0.374 //l=0.185472 //layer=m1 \
 //thickness=0.36 //x=23.06 //y=4.415 //x2=23.115 //y2=4.255
r859 (  3 4 ) resistor r=0.324427 //w=0.131 //l=0.34 //layer=m1 \
 //thickness=0.36 //x=23.06 //y=4.415 //x2=23.06 //y2=4.755
r860 (  2 34 ) resistor r=0.089409 //w=0.374 //l=0.180416 //layer=m1 \
 //thickness=0.36 //x=23.06 //y=4.095 //x2=23.115 //y2=4.25
r861 (  1 30 ) resistor r=0.0719237 //w=0.222 //l=0.115 //layer=m1 \
 //thickness=0.36 //x=23.06 //y=2.375 //x2=23.06 //y2=2.26
r862 (  1 2 ) resistor r=1.64122 //w=0.131 //l=1.72 //layer=m1 \
 //thickness=0.36 //x=23.06 //y=2.375 //x2=23.06 //y2=4.095
ends PM_TMRDFFQX1\%noxref_10

subckt PM_TMRDFFQX1\%D ( 1 2 3 4 6 7 8 11 12 13 15 16 17 19 29 43 55 58 59 61 \
 62 65 74 79 88 93 102 106 107 108 109 110 111 112 113 114 115 116 117 122 124 \
 126 132 133 134 135 136 141 143 145 151 152 153 154 155 160 162 164 170 171 \
 173 174 177 186 187 190 199 200 203 )
c628 ( 203 0 ) capacitor c=0.0393541f //x=50.1 //y=4.88
c629 ( 200 0 ) capacitor c=0.0284095f //x=50.07 //y=2.095
c630 ( 199 0 ) capacitor c=0.0438885f //x=50.07 //y=2.26
c631 ( 190 0 ) capacitor c=0.0393541f //x=28.64 //y=4.88
c632 ( 187 0 ) capacitor c=0.0284095f //x=28.61 //y=2.095
c633 ( 186 0 ) capacitor c=0.0438926f //x=28.61 //y=2.26
c634 ( 177 0 ) capacitor c=0.0393541f //x=7.18 //y=4.88
c635 ( 174 0 ) capacitor c=0.0284095f //x=7.15 //y=2.095
c636 ( 173 0 ) capacitor c=0.0438935f //x=7.15 //y=2.26
c637 ( 171 0 ) capacitor c=0.0439708f //x=50.635 //y=1.43
c638 ( 170 0 ) capacitor c=0.0192582f //x=50.635 //y=1.085
c639 ( 164 0 ) capacitor c=0.0162526f //x=50.48 //y=1.585
c640 ( 162 0 ) capacitor c=0.0157807f //x=50.48 //y=0.93
c641 ( 160 0 ) capacitor c=0.0372668f //x=50.475 //y=4.97
c642 ( 155 0 ) capacitor c=0.0210762f //x=50.105 //y=1.74
c643 ( 154 0 ) capacitor c=0.0168511f //x=50.105 //y=1.43
c644 ( 153 0 ) capacitor c=0.0175485f //x=50.105 //y=1.085
c645 ( 152 0 ) capacitor c=0.0439708f //x=29.175 //y=1.43
c646 ( 151 0 ) capacitor c=0.0192582f //x=29.175 //y=1.085
c647 ( 145 0 ) capacitor c=0.0162526f //x=29.02 //y=1.585
c648 ( 143 0 ) capacitor c=0.0157807f //x=29.02 //y=0.93
c649 ( 141 0 ) capacitor c=0.0372668f //x=29.015 //y=4.97
c650 ( 136 0 ) capacitor c=0.0210762f //x=28.645 //y=1.74
c651 ( 135 0 ) capacitor c=0.0168511f //x=28.645 //y=1.43
c652 ( 134 0 ) capacitor c=0.0175485f //x=28.645 //y=1.085
c653 ( 133 0 ) capacitor c=0.0439708f //x=7.715 //y=1.43
c654 ( 132 0 ) capacitor c=0.0192582f //x=7.715 //y=1.085
c655 ( 126 0 ) capacitor c=0.0162526f //x=7.56 //y=1.585
c656 ( 124 0 ) capacitor c=0.0157807f //x=7.56 //y=0.93
c657 ( 122 0 ) capacitor c=0.0372668f //x=7.555 //y=4.97
c658 ( 117 0 ) capacitor c=0.0210762f //x=7.185 //y=1.74
c659 ( 116 0 ) capacitor c=0.0168511f //x=7.185 //y=1.43
c660 ( 115 0 ) capacitor c=0.0175485f //x=7.185 //y=1.085
c661 ( 114 0 ) capacitor c=0.155269f //x=50.55 //y=6.2
c662 ( 113 0 ) capacitor c=0.110375f //x=50.11 //y=6.2
c663 ( 112 0 ) capacitor c=0.155269f //x=29.09 //y=6.2
c664 ( 111 0 ) capacitor c=0.110375f //x=28.65 //y=6.2
c665 ( 110 0 ) capacitor c=0.155269f //x=7.63 //y=6.2
c666 ( 109 0 ) capacitor c=0.110375f //x=7.19 //y=6.2
c667 ( 102 0 ) capacitor c=8.90417e-19 //x=50.1 //y=4.88
c668 ( 93 0 ) capacitor c=3.09518e-19 //x=50.07 //y=2.26
c669 ( 88 0 ) capacitor c=8.90417e-19 //x=28.64 //y=4.88
c670 ( 79 0 ) capacitor c=3.09518e-19 //x=28.61 //y=2.26
c671 ( 74 0 ) capacitor c=8.90417e-19 //x=7.18 //y=4.88
c672 ( 65 0 ) capacitor c=3.09518e-19 //x=7.15 //y=2.26
c673 ( 62 0 ) capacitor c=0.309909f //x=49.91 //y=2.755
c674 ( 61 0 ) capacitor c=8.23247e-19 //x=50.07 //y=2.755
c675 ( 59 0 ) capacitor c=0.00310379f //x=28.755 //y=2.78
c676 ( 58 0 ) capacitor c=0.483534f //x=28.435 //y=2.78
c677 ( 55 0 ) capacitor c=0.00366833f //x=7.315 //y=2.785
c678 ( 43 0 ) capacitor c=0.00470059f //x=50.07 //y=2.26
c679 ( 29 0 ) capacitor c=0.00616544f //x=28.61 //y=2.26
c680 ( 19 0 ) capacitor c=0.00616596f //x=7.15 //y=2.26
c681 ( 17 0 ) capacitor c=0.0416626f //x=50.07 //y=4.735
c682 ( 16 0 ) capacitor c=0.010195f //x=50.07 //y=2.915
c683 ( 15 0 ) capacitor c=0.00256101f //x=50.07 //y=2.595
c684 ( 13 0 ) capacitor c=0.040991f //x=28.61 //y=4.735
c685 ( 12 0 ) capacitor c=0.0104409f //x=28.61 //y=2.94
c686 ( 11 0 ) capacitor c=0.00336328f //x=28.61 //y=2.62
c687 ( 8 0 ) capacitor c=0.00454964f //x=7.15 //y=4.735
c688 ( 7 0 ) capacitor c=0.00999458f //x=7.15 //y=2.945
c689 ( 6 0 ) capacitor c=0.00339252f //x=7.15 //y=2.625
c690 ( 4 0 ) capacitor c=0.0140837f //x=50.07 //y=2.77
c691 ( 3 0 ) capacitor c=0.0140812f //x=28.61 //y=2.77
c692 ( 2 0 ) capacitor c=0.0140812f //x=7.15 //y=2.77
c693 ( 1 0 ) capacitor c=0.0387487f //x=7.15 //y=3.14
r694 (  205 206 ) resistor r=32.4568 //w=0.214 //l=0.075 //layer=ply \
 //thickness=0.18 //x=50.1 //y=4.97 //x2=50.1 //y2=5.045
r695 (  203 205 ) resistor r=20.271 //w=0.214 //l=0.09 //layer=ply \
 //thickness=0.18 //x=50.1 //y=4.88 //x2=50.1 //y2=4.97
r696 (  199 200 ) resistor r=52.7279 //w=0.214 //l=0.165 //layer=ply \
 //thickness=0.18 //x=50.07 //y=2.26 //x2=50.07 //y2=2.095
r697 (  192 193 ) resistor r=32.4568 //w=0.214 //l=0.075 //layer=ply \
 //thickness=0.18 //x=28.64 //y=4.97 //x2=28.64 //y2=5.045
r698 (  190 192 ) resistor r=20.271 //w=0.214 //l=0.09 //layer=ply \
 //thickness=0.18 //x=28.64 //y=4.88 //x2=28.64 //y2=4.97
r699 (  186 187 ) resistor r=52.7279 //w=0.214 //l=0.165 //layer=ply \
 //thickness=0.18 //x=28.61 //y=2.26 //x2=28.61 //y2=2.095
r700 (  179 180 ) resistor r=32.4568 //w=0.214 //l=0.075 //layer=ply \
 //thickness=0.18 //x=7.18 //y=4.97 //x2=7.18 //y2=5.045
r701 (  177 179 ) resistor r=20.271 //w=0.214 //l=0.09 //layer=ply \
 //thickness=0.18 //x=7.18 //y=4.88 //x2=7.18 //y2=4.97
r702 (  173 174 ) resistor r=52.7279 //w=0.214 //l=0.165 //layer=ply \
 //thickness=0.18 //x=7.15 //y=2.26 //x2=7.15 //y2=2.095
r703 (  171 210 ) resistor r=45.1352 //w=0.168 //l=0.173853 //layer=ply \
 //thickness=0.18 //x=50.635 //y=1.43 //x2=50.595 //y2=1.585
r704 (  170 209 ) resistor r=45.1352 //w=0.168 //l=0.173853 //layer=ply \
 //thickness=0.18 //x=50.635 //y=1.085 //x2=50.595 //y2=0.93
r705 (  170 171 ) resistor r=176.904 //w=0.094 //l=0.345 //layer=ply \
 //thickness=0.18 //x=50.635 //y=1.085 //x2=50.635 //y2=1.43
r706 (  165 208 ) resistor r=10.701 //w=0.21 //l=0.115 //layer=ply \
 //thickness=0.18 //x=50.26 //y=1.585 //x2=50.145 //y2=1.585
r707 (  164 210 ) resistor r=5.52526 //w=0.168 //l=0.115 //layer=ply \
 //thickness=0.18 //x=50.48 //y=1.585 //x2=50.595 //y2=1.585
r708 (  163 207 ) resistor r=5.52526 //w=0.168 //l=0.115 //layer=ply \
 //thickness=0.18 //x=50.26 //y=0.93 //x2=50.145 //y2=0.93
r709 (  162 209 ) resistor r=5.52526 //w=0.168 //l=0.115 //layer=ply \
 //thickness=0.18 //x=50.48 //y=0.93 //x2=50.595 //y2=0.93
r710 (  162 163 ) resistor r=112.809 //w=0.094 //l=0.22 //layer=ply \
 //thickness=0.18 //x=50.48 //y=0.93 //x2=50.26 //y2=0.93
r711 (  161 205 ) resistor r=16.5046 //w=0.27 //l=0.135 //layer=ply \
 //thickness=0.18 //x=50.235 //y=4.97 //x2=50.1 //y2=4.97
r712 (  160 167 ) resistor r=26.9307 //w=0.15 //l=0.106066 //layer=ply \
 //thickness=0.18 //x=50.475 //y=4.97 //x2=50.55 //y2=5.045
r713 (  160 161 ) resistor r=123.064 //w=0.094 //l=0.24 //layer=ply \
 //thickness=0.18 //x=50.475 //y=4.97 //x2=50.235 //y2=4.97
r714 (  155 208 ) resistor r=39.5823 //w=0.21 //l=0.173853 //layer=ply \
 //thickness=0.18 //x=50.105 //y=1.74 //x2=50.145 //y2=1.585
r715 (  155 200 ) resistor r=182.032 //w=0.094 //l=0.355 //layer=ply \
 //thickness=0.18 //x=50.105 //y=1.74 //x2=50.105 //y2=2.095
r716 (  154 208 ) resistor r=39.5823 //w=0.21 //l=0.173853 //layer=ply \
 //thickness=0.18 //x=50.105 //y=1.43 //x2=50.145 //y2=1.585
r717 (  153 207 ) resistor r=45.1352 //w=0.168 //l=0.173853 //layer=ply \
 //thickness=0.18 //x=50.105 //y=1.085 //x2=50.145 //y2=0.93
r718 (  153 154 ) resistor r=176.904 //w=0.094 //l=0.345 //layer=ply \
 //thickness=0.18 //x=50.105 //y=1.085 //x2=50.105 //y2=1.43
r719 (  152 197 ) resistor r=45.1352 //w=0.168 //l=0.173853 //layer=ply \
 //thickness=0.18 //x=29.175 //y=1.43 //x2=29.135 //y2=1.585
r720 (  151 196 ) resistor r=45.1352 //w=0.168 //l=0.173853 //layer=ply \
 //thickness=0.18 //x=29.175 //y=1.085 //x2=29.135 //y2=0.93
r721 (  151 152 ) resistor r=176.904 //w=0.094 //l=0.345 //layer=ply \
 //thickness=0.18 //x=29.175 //y=1.085 //x2=29.175 //y2=1.43
r722 (  146 195 ) resistor r=10.701 //w=0.21 //l=0.115 //layer=ply \
 //thickness=0.18 //x=28.8 //y=1.585 //x2=28.685 //y2=1.585
r723 (  145 197 ) resistor r=5.52526 //w=0.168 //l=0.115 //layer=ply \
 //thickness=0.18 //x=29.02 //y=1.585 //x2=29.135 //y2=1.585
r724 (  144 194 ) resistor r=5.52526 //w=0.168 //l=0.115 //layer=ply \
 //thickness=0.18 //x=28.8 //y=0.93 //x2=28.685 //y2=0.93
r725 (  143 196 ) resistor r=5.52526 //w=0.168 //l=0.115 //layer=ply \
 //thickness=0.18 //x=29.02 //y=0.93 //x2=29.135 //y2=0.93
r726 (  143 144 ) resistor r=112.809 //w=0.094 //l=0.22 //layer=ply \
 //thickness=0.18 //x=29.02 //y=0.93 //x2=28.8 //y2=0.93
r727 (  142 192 ) resistor r=16.5046 //w=0.27 //l=0.135 //layer=ply \
 //thickness=0.18 //x=28.775 //y=4.97 //x2=28.64 //y2=4.97
r728 (  141 148 ) resistor r=26.9307 //w=0.15 //l=0.106066 //layer=ply \
 //thickness=0.18 //x=29.015 //y=4.97 //x2=29.09 //y2=5.045
r729 (  141 142 ) resistor r=123.064 //w=0.094 //l=0.24 //layer=ply \
 //thickness=0.18 //x=29.015 //y=4.97 //x2=28.775 //y2=4.97
r730 (  136 195 ) resistor r=39.5823 //w=0.21 //l=0.173853 //layer=ply \
 //thickness=0.18 //x=28.645 //y=1.74 //x2=28.685 //y2=1.585
r731 (  136 187 ) resistor r=182.032 //w=0.094 //l=0.355 //layer=ply \
 //thickness=0.18 //x=28.645 //y=1.74 //x2=28.645 //y2=2.095
r732 (  135 195 ) resistor r=39.5823 //w=0.21 //l=0.173853 //layer=ply \
 //thickness=0.18 //x=28.645 //y=1.43 //x2=28.685 //y2=1.585
r733 (  134 194 ) resistor r=45.1352 //w=0.168 //l=0.173853 //layer=ply \
 //thickness=0.18 //x=28.645 //y=1.085 //x2=28.685 //y2=0.93
r734 (  134 135 ) resistor r=176.904 //w=0.094 //l=0.345 //layer=ply \
 //thickness=0.18 //x=28.645 //y=1.085 //x2=28.645 //y2=1.43
r735 (  133 184 ) resistor r=45.1352 //w=0.168 //l=0.173853 //layer=ply \
 //thickness=0.18 //x=7.715 //y=1.43 //x2=7.675 //y2=1.585
r736 (  132 183 ) resistor r=45.1352 //w=0.168 //l=0.173853 //layer=ply \
 //thickness=0.18 //x=7.715 //y=1.085 //x2=7.675 //y2=0.93
r737 (  132 133 ) resistor r=176.904 //w=0.094 //l=0.345 //layer=ply \
 //thickness=0.18 //x=7.715 //y=1.085 //x2=7.715 //y2=1.43
r738 (  127 182 ) resistor r=10.701 //w=0.21 //l=0.115 //layer=ply \
 //thickness=0.18 //x=7.34 //y=1.585 //x2=7.225 //y2=1.585
r739 (  126 184 ) resistor r=5.52526 //w=0.168 //l=0.115 //layer=ply \
 //thickness=0.18 //x=7.56 //y=1.585 //x2=7.675 //y2=1.585
r740 (  125 181 ) resistor r=5.52526 //w=0.168 //l=0.115 //layer=ply \
 //thickness=0.18 //x=7.34 //y=0.93 //x2=7.225 //y2=0.93
r741 (  124 183 ) resistor r=5.52526 //w=0.168 //l=0.115 //layer=ply \
 //thickness=0.18 //x=7.56 //y=0.93 //x2=7.675 //y2=0.93
r742 (  124 125 ) resistor r=112.809 //w=0.094 //l=0.22 //layer=ply \
 //thickness=0.18 //x=7.56 //y=0.93 //x2=7.34 //y2=0.93
r743 (  123 179 ) resistor r=16.5046 //w=0.27 //l=0.135 //layer=ply \
 //thickness=0.18 //x=7.315 //y=4.97 //x2=7.18 //y2=4.97
r744 (  122 129 ) resistor r=26.9307 //w=0.15 //l=0.106066 //layer=ply \
 //thickness=0.18 //x=7.555 //y=4.97 //x2=7.63 //y2=5.045
r745 (  122 123 ) resistor r=123.064 //w=0.094 //l=0.24 //layer=ply \
 //thickness=0.18 //x=7.555 //y=4.97 //x2=7.315 //y2=4.97
r746 (  117 182 ) resistor r=39.5823 //w=0.21 //l=0.173853 //layer=ply \
 //thickness=0.18 //x=7.185 //y=1.74 //x2=7.225 //y2=1.585
r747 (  117 174 ) resistor r=182.032 //w=0.094 //l=0.355 //layer=ply \
 //thickness=0.18 //x=7.185 //y=1.74 //x2=7.185 //y2=2.095
r748 (  116 182 ) resistor r=39.5823 //w=0.21 //l=0.173853 //layer=ply \
 //thickness=0.18 //x=7.185 //y=1.43 //x2=7.225 //y2=1.585
r749 (  115 181 ) resistor r=45.1352 //w=0.168 //l=0.173853 //layer=ply \
 //thickness=0.18 //x=7.185 //y=1.085 //x2=7.225 //y2=0.93
r750 (  115 116 ) resistor r=176.904 //w=0.094 //l=0.345 //layer=ply \
 //thickness=0.18 //x=7.185 //y=1.085 //x2=7.185 //y2=1.43
r751 (  114 167 ) resistor r=592.245 //w=0.094 //l=1.155 //layer=ply \
 //thickness=0.18 //x=50.55 //y=6.2 //x2=50.55 //y2=5.045
r752 (  113 206 ) resistor r=592.245 //w=0.094 //l=1.155 //layer=ply \
 //thickness=0.18 //x=50.11 //y=6.2 //x2=50.11 //y2=5.045
r753 (  112 148 ) resistor r=592.245 //w=0.094 //l=1.155 //layer=ply \
 //thickness=0.18 //x=29.09 //y=6.2 //x2=29.09 //y2=5.045
r754 (  111 193 ) resistor r=592.245 //w=0.094 //l=1.155 //layer=ply \
 //thickness=0.18 //x=28.65 //y=6.2 //x2=28.65 //y2=5.045
r755 (  110 129 ) resistor r=592.245 //w=0.094 //l=1.155 //layer=ply \
 //thickness=0.18 //x=7.63 //y=6.2 //x2=7.63 //y2=5.045
r756 (  109 180 ) resistor r=592.245 //w=0.094 //l=1.155 //layer=ply \
 //thickness=0.18 //x=7.19 //y=6.2 //x2=7.19 //y2=5.045
r757 (  108 164 ) resistor r=56.4043 //w=0.094 //l=0.11 //layer=ply \
 //thickness=0.18 //x=50.37 //y=1.585 //x2=50.48 //y2=1.585
r758 (  108 165 ) resistor r=56.4043 //w=0.094 //l=0.11 //layer=ply \
 //thickness=0.18 //x=50.37 //y=1.585 //x2=50.26 //y2=1.585
r759 (  107 145 ) resistor r=56.4043 //w=0.094 //l=0.11 //layer=ply \
 //thickness=0.18 //x=28.91 //y=1.585 //x2=29.02 //y2=1.585
r760 (  107 146 ) resistor r=56.4043 //w=0.094 //l=0.11 //layer=ply \
 //thickness=0.18 //x=28.91 //y=1.585 //x2=28.8 //y2=1.585
r761 (  106 126 ) resistor r=56.4043 //w=0.094 //l=0.11 //layer=ply \
 //thickness=0.18 //x=7.45 //y=1.585 //x2=7.56 //y2=1.585
r762 (  106 127 ) resistor r=56.4043 //w=0.094 //l=0.11 //layer=ply \
 //thickness=0.18 //x=7.45 //y=1.585 //x2=7.34 //y2=1.585
r763 (  102 203 ) resistor r=152 //w=0.17 //l=0.17 //layer=licon //count=1 \
 //x=50.1 //y=4.88 //x2=50.1 //y2=4.88
r764 (  93 199 ) resistor r=152 //w=0.17 //l=0.17 //layer=licon //count=1 \
 //x=50.07 //y=2.26 //x2=50.07 //y2=2.26
r765 (  88 190 ) resistor r=152 //w=0.17 //l=0.17 //layer=licon //count=1 \
 //x=28.64 //y=4.88 //x2=28.64 //y2=4.88
r766 (  79 186 ) resistor r=152 //w=0.17 //l=0.17 //layer=licon //count=1 \
 //x=28.61 //y=2.26 //x2=28.61 //y2=2.26
r767 (  74 177 ) resistor r=152 //w=0.17 //l=0.17 //layer=licon //count=1 \
 //x=7.18 //y=4.88 //x2=7.18 //y2=4.88
r768 (  65 173 ) resistor r=152 //w=0.17 //l=0.17 //layer=licon //count=1 \
 //x=7.15 //y=2.26 //x2=7.15 //y2=2.26
r769 (  61 62 ) resistor r=0.10734 //w=0.281 //l=0.16 //layer=m2 \
 //thickness=0.36 //x=50.07 //y=2.755 //x2=49.91 //y2=2.755
r770 (  59 62 ) resistor r=20.1861 //w=0.131 //l=21.155 //layer=m2 \
 //thickness=0.36 //x=28.755 //y=2.77 //x2=49.91 //y2=2.77
r771 (  57 59 ) resistor r=0.10734 //w=0.281 //l=0.16 //layer=m2 \
 //thickness=0.36 //x=28.595 //y=2.78 //x2=28.755 //y2=2.78
r772 (  57 58 ) resistor r=0.10734 //w=0.281 //l=0.16 //layer=m2 \
 //thickness=0.36 //x=28.595 //y=2.78 //x2=28.435 //y2=2.78
r773 (  55 58 ) resistor r=20.1527 //w=0.131 //l=21.12 //layer=m2 \
 //thickness=0.36 //x=7.315 //y=2.77 //x2=28.435 //y2=2.77
r774 (  53 55 ) resistor r=0.10734 //w=0.281 //l=0.16 //layer=m2 \
 //thickness=0.36 //x=7.155 //y=2.785 //x2=7.315 //y2=2.785
r775 (  47 102 ) resistor r=9.3 //w=0.17 //l=0.17 //layer=mcon //count=1 \
 //x=50.1 //y=4.88 //x2=50.1 //y2=4.88
r776 (  43 93 ) resistor r=9.3 //w=0.17 //l=0.17 //layer=mcon //count=1 \
 //x=50.07 //y=2.26 //x2=50.07 //y2=2.26
r777 (  43 45 ) resistor r=0.0936408 //w=0.196 //l=0.125 //layer=m1 \
 //thickness=0.36 //x=50.072 //y=2.26 //x2=50.072 //y2=2.385
r778 (  39 61 ) resistor r=4.5 //w=0.15 //l=0.15 //layer=via1 //count=1 \
 //x=50.07 //y=2.755 //x2=50.07 //y2=2.755
r779 (  37 57 ) resistor r=4.5 //w=0.15 //l=0.15 //layer=via1 //count=1 \
 //x=28.595 //y=2.78 //x2=28.595 //y2=2.78
r780 (  33 88 ) resistor r=9.3 //w=0.17 //l=0.17 //layer=mcon //count=1 \
 //x=28.64 //y=4.88 //x2=28.64 //y2=4.88
r781 (  29 79 ) resistor r=9.3 //w=0.17 //l=0.17 //layer=mcon //count=1 \
 //x=28.61 //y=2.26 //x2=28.61 //y2=2.26
r782 (  29 31 ) resistor r=0.0936408 //w=0.196 //l=0.125 //layer=m1 \
 //thickness=0.36 //x=28.612 //y=2.26 //x2=28.612 //y2=2.385
r783 (  27 53 ) resistor r=4.5 //w=0.15 //l=0.15 //layer=via1 //count=1 \
 //x=7.155 //y=2.785 //x2=7.155 //y2=2.785
r784 (  23 74 ) resistor r=9.3 //w=0.17 //l=0.17 //layer=mcon //count=1 \
 //x=7.18 //y=4.88 //x2=7.18 //y2=4.88
r785 (  19 65 ) resistor r=9.3 //w=0.17 //l=0.17 //layer=mcon //count=1 \
 //x=7.15 //y=2.26 //x2=7.15 //y2=2.26
r786 (  19 21 ) resistor r=0.0936408 //w=0.196 //l=0.125 //layer=m1 \
 //thickness=0.36 //x=7.152 //y=2.26 //x2=7.152 //y2=2.385
r787 (  17 47 ) resistor r=0.0878548 //w=0.228 //l=0.159295 //layer=m1 \
 //thickness=0.36 //x=50.07 //y=4.735 //x2=50.1 //y2=4.88
r788 (  16 17 ) resistor r=1.73664 //w=0.131 //l=1.82 //layer=m1 \
 //thickness=0.36 //x=50.07 //y=2.915 //x2=50.07 //y2=4.735
r789 (  15 39 ) resistor r=0.0911593 //w=0.376 //l=0.184608 //layer=m1 \
 //thickness=0.36 //x=50.07 //y=2.595 //x2=50.017 //y2=2.755
r790 (  15 45 ) resistor r=0.200382 //w=0.131 //l=0.21 //layer=m1 \
 //thickness=0.36 //x=50.07 //y=2.595 //x2=50.07 //y2=2.385
r791 (  13 33 ) resistor r=0.0878548 //w=0.228 //l=0.159295 //layer=m1 \
 //thickness=0.36 //x=28.61 //y=4.735 //x2=28.64 //y2=4.88
r792 (  12 37 ) resistor r=0.0914932 //w=0.384 //l=0.181108 //layer=m1 \
 //thickness=0.36 //x=28.61 //y=2.94 //x2=28.655 //y2=2.78
r793 (  12 13 ) resistor r=1.71279 //w=0.131 //l=1.795 //layer=m1 \
 //thickness=0.36 //x=28.61 //y=2.94 //x2=28.61 //y2=4.735
r794 (  11 31 ) resistor r=0.224237 //w=0.131 //l=0.235 //layer=m1 \
 //thickness=0.36 //x=28.61 //y=2.62 //x2=28.61 //y2=2.385
r795 (  8 23 ) resistor r=0.0878548 //w=0.228 //l=0.159295 //layer=m1 \
 //thickness=0.36 //x=7.15 //y=4.735 //x2=7.18 //y2=4.88
r796 (  7 27 ) resistor r=0.0910802 //w=0.374 //l=0.185472 //layer=m1 \
 //thickness=0.36 //x=7.15 //y=2.945 //x2=7.205 //y2=2.785
r797 (  6 21 ) resistor r=0.229008 //w=0.131 //l=0.24 //layer=m1 \
 //thickness=0.36 //x=7.15 //y=2.625 //x2=7.15 //y2=2.385
r798 (  4 16 ) resistor r=0.0861726 //w=0.376 //l=0.16944 //layer=m1 \
 //thickness=0.36 //x=50.017 //y=2.77 //x2=50.07 //y2=2.915
r799 (  4 39 ) resistor r=0.0049867 //w=0.376 //l=0.015 //layer=m1 \
 //thickness=0.36 //x=50.017 //y=2.77 //x2=50.017 //y2=2.755
r800 (  3 37 ) resistor r=0.00325521 //w=0.384 //l=0.01 //layer=m1 \
 //thickness=0.36 //x=28.655 //y=2.77 //x2=28.655 //y2=2.78
r801 (  3 11 ) resistor r=0.088238 //w=0.384 //l=0.171026 //layer=m1 \
 //thickness=0.36 //x=28.655 //y=2.77 //x2=28.61 //y2=2.62
r802 (  2 27 ) resistor r=0.00501337 //w=0.374 //l=0.015 //layer=m1 \
 //thickness=0.36 //x=7.205 //y=2.77 //x2=7.205 //y2=2.785
r803 (  2 6 ) resistor r=0.0860668 //w=0.374 //l=0.170294 //layer=m1 \
 //thickness=0.36 //x=7.205 //y=2.77 //x2=7.15 //y2=2.625
r804 (  1 8 ) resistor r=1.52195 //w=0.131 //l=1.595 //layer=m1 \
 //thickness=0.36 //x=7.15 //y=3.14 //x2=7.15 //y2=4.735
r805 (  1 7 ) resistor r=0.186069 //w=0.131 //l=0.195 //layer=m1 \
 //thickness=0.36 //x=7.15 //y=3.14 //x2=7.15 //y2=2.945
ends PM_TMRDFFQX1\%D

subckt PM_TMRDFFQX1\%noxref_12 ( 1 2 3 4 7 12 13 15 16 18 19 20 22 23 30 34 35 \
 38 40 43 48 50 53 54 56 57 58 60 62 65 72 73 76 85 90 98 115 124 128 129 130 \
 131 132 133 137 138 139 144 146 149 150 151 152 153 154 158 160 163 164 169 \
 170 175 184 187 189 190 )
c440 ( 187 0 ) capacitor c=0.00878249f //x=50.18 //y=1.085
c441 ( 184 0 ) capacitor c=0.0682508f //x=52.66 //y=4.88
c442 ( 175 0 ) capacitor c=0.0710066f //x=46.74 //y=4.88
c443 ( 170 0 ) capacitor c=0.0278202f //x=46.74 //y=2.095
c444 ( 169 0 ) capacitor c=0.0479324f //x=46.74 //y=2.26
c445 ( 164 0 ) capacitor c=0.0318956f //x=52.995 //y=1.39
c446 ( 163 0 ) capacitor c=0.0186809f //x=52.995 //y=1.045
c447 ( 160 0 ) capacitor c=0.0141821f //x=52.84 //y=1.545
c448 ( 158 0 ) capacitor c=0.0158553f //x=52.84 //y=0.89
c449 ( 154 0 ) capacitor c=0.0854171f //x=52.465 //y=2.095
c450 ( 153 0 ) capacitor c=0.0229235f //x=52.465 //y=1.7
c451 ( 152 0 ) capacitor c=0.0234359f //x=52.465 //y=1.39
c452 ( 151 0 ) capacitor c=0.0198759f //x=52.465 //y=1.045
c453 ( 150 0 ) capacitor c=0.0443175f //x=47.26 //y=1.44
c454 ( 149 0 ) capacitor c=0.0199703f //x=47.26 //y=1.095
c455 ( 146 0 ) capacitor c=0.0162526f //x=47.105 //y=1.595
c456 ( 144 0 ) capacitor c=0.0157807f //x=47.105 //y=0.94
c457 ( 139 0 ) capacitor c=0.0220935f //x=46.73 //y=1.75
c458 ( 138 0 ) capacitor c=0.0207489f //x=46.73 //y=1.44
c459 ( 137 0 ) capacitor c=0.0194091f //x=46.73 //y=1.095
c460 ( 133 0 ) capacitor c=0.110369f //x=53 //y=6.2
c461 ( 132 0 ) capacitor c=0.154619f //x=52.56 //y=6.2
c462 ( 131 0 ) capacitor c=0.159671f //x=46.92 //y=6.2
c463 ( 130 0 ) capacitor c=0.110208f //x=46.48 //y=6.2
c464 ( 124 0 ) capacitor c=8.13425e-19 //x=52.66 //y=4.88
c465 ( 115 0 ) capacitor c=7.85889e-19 //x=52.66 //y=2.26
c466 ( 98 0 ) capacitor c=0.0322017f //x=50.33 //y=5.56
c467 ( 90 0 ) capacitor c=0.0290186f //x=49.45 //y=5.56
c468 ( 85 0 ) capacitor c=8.10944e-19 //x=46.74 //y=4.88
c469 ( 76 0 ) capacitor c=0.00101179f //x=46.74 //y=2.26
c470 ( 73 0 ) capacitor c=0.0202533f //x=52.495 //y=3.505
c471 ( 72 0 ) capacitor c=4.79889e-19 //x=52.655 //y=3.505
c472 ( 65 0 ) capacitor c=0.00856521f //x=50.965 //y=3.51
c473 ( 62 0 ) capacitor c=0.00209252f //x=49.54 //y=3.495
c474 ( 60 0 ) capacitor c=0.0155233f //x=48.94 //y=3.51
c475 ( 58 0 ) capacitor c=0.00615643f //x=47.695 //y=3.495
c476 ( 57 0 ) capacitor c=6.32236e-19 //x=46.905 //y=3.51
c477 ( 56 0 ) capacitor c=0.00294384f //x=47.095 //y=3.51
c478 ( 54 0 ) capacitor c=0.0267491f //x=52.662 //y=4.74
c479 ( 53 0 ) capacitor c=0.00611287f //x=52.66 //y=4.88
c480 ( 50 0 ) capacitor c=0.00463527f //x=52.66 //y=2.26
c481 ( 48 0 ) capacitor c=0.0163473f //x=52.66 //y=3.51
c482 ( 43 0 ) capacitor c=0.0170489f //x=50.805 //y=3.51
c483 ( 40 0 ) capacitor c=0.0113244f //x=50.37 //y=1.18
c484 ( 38 0 ) capacitor c=5.78613e-19 //x=50.33 //y=5.56
c485 ( 35 0 ) capacitor c=0.0104855f //x=50.33 //y=5.38
c486 ( 34 0 ) capacitor c=0.00923791f //x=49.45 //y=5.56
c487 ( 30 0 ) capacitor c=0.0148558f //x=46.74 //y=3.51
c488 ( 23 0 ) capacitor c=0.0131821f //x=52.66 //y=3.665
c489 ( 22 0 ) capacitor c=0.0254304f //x=52.66 //y=3.345
c490 ( 20 0 ) capacitor c=0.0405845f //x=50.81 //y=5.295
c491 ( 19 0 ) capacitor c=0.0134364f //x=50.81 //y=3.67
c492 ( 18 0 ) capacitor c=0.0349248f //x=50.81 //y=3.35
c493 ( 16 0 ) capacitor c=0.00461898f //x=50.455 //y=1.835
c494 ( 15 0 ) capacitor c=0.0117367f //x=50.725 //y=1.835
c495 ( 13 0 ) capacitor c=0.0108105f //x=50.725 //y=5.38
c496 ( 12 0 ) capacitor c=0.0102514f //x=50.37 //y=1.75
c497 ( 7 0 ) capacitor c=0.0143198f //x=50.215 //y=5.38
c498 ( 4 0 ) capacitor c=0.0286377f //x=46.74 //y=4.75
c499 ( 3 0 ) capacitor c=0.012605f //x=46.74 //y=3.67
c500 ( 2 0 ) capacitor c=0.0228533f //x=46.74 //y=3.35
c501 ( 1 0 ) capacitor c=0.00556102f //x=46.74 //y=2.375
r502 (  182 184 ) resistor r=20.6867 //w=0.233 //l=0.1 //layer=ply \
 //thickness=0.18 //x=52.56 //y=4.88 //x2=52.66 //y2=4.88
r503 (  169 170 ) resistor r=52.7279 //w=0.214 //l=0.165 //layer=ply \
 //thickness=0.18 //x=46.74 //y=2.26 //x2=46.74 //y2=2.095
r504 (  165 184 ) resistor r=70.3348 //w=0.233 //l=0.414367 //layer=ply \
 //thickness=0.18 //x=53 //y=5.045 //x2=52.66 //y2=4.88
r505 (  164 186 ) resistor r=45.1352 //w=0.168 //l=0.173853 //layer=ply \
 //thickness=0.18 //x=52.995 //y=1.39 //x2=52.955 //y2=1.545
r506 (  163 185 ) resistor r=45.1352 //w=0.168 //l=0.173853 //layer=ply \
 //thickness=0.18 //x=52.995 //y=1.045 //x2=52.955 //y2=0.89
r507 (  163 164 ) resistor r=176.904 //w=0.094 //l=0.345 //layer=ply \
 //thickness=0.18 //x=52.995 //y=1.045 //x2=52.995 //y2=1.39
r508 (  161 181 ) resistor r=10.701 //w=0.21 //l=0.115 //layer=ply \
 //thickness=0.18 //x=52.62 //y=1.545 //x2=52.505 //y2=1.545
r509 (  160 186 ) resistor r=5.52526 //w=0.168 //l=0.115 //layer=ply \
 //thickness=0.18 //x=52.84 //y=1.545 //x2=52.955 //y2=1.545
r510 (  159 180 ) resistor r=5.52526 //w=0.168 //l=0.115 //layer=ply \
 //thickness=0.18 //x=52.62 //y=0.89 //x2=52.505 //y2=0.89
r511 (  158 185 ) resistor r=5.52526 //w=0.168 //l=0.115 //layer=ply \
 //thickness=0.18 //x=52.84 //y=0.89 //x2=52.955 //y2=0.89
r512 (  158 159 ) resistor r=112.809 //w=0.094 //l=0.22 //layer=ply \
 //thickness=0.18 //x=52.84 //y=0.89 //x2=52.62 //y2=0.89
r513 (  155 182 ) resistor r=13.0941 //w=0.233 //l=0.165 //layer=ply \
 //thickness=0.18 //x=52.56 //y=5.045 //x2=52.56 //y2=4.88
r514 (  154 179 ) resistor r=34.8111 //w=0.27 //l=0.264953 //layer=ply \
 //thickness=0.18 //x=52.465 //y=2.095 //x2=52.66 //y2=2.26
r515 (  153 181 ) resistor r=39.5823 //w=0.21 //l=0.173853 //layer=ply \
 //thickness=0.18 //x=52.465 //y=1.7 //x2=52.505 //y2=1.545
r516 (  153 154 ) resistor r=202.543 //w=0.094 //l=0.395 //layer=ply \
 //thickness=0.18 //x=52.465 //y=1.7 //x2=52.465 //y2=2.095
r517 (  152 181 ) resistor r=39.5823 //w=0.21 //l=0.173853 //layer=ply \
 //thickness=0.18 //x=52.465 //y=1.39 //x2=52.505 //y2=1.545
r518 (  151 180 ) resistor r=45.1352 //w=0.168 //l=0.173853 //layer=ply \
 //thickness=0.18 //x=52.465 //y=1.045 //x2=52.505 //y2=0.89
r519 (  151 152 ) resistor r=176.904 //w=0.094 //l=0.345 //layer=ply \
 //thickness=0.18 //x=52.465 //y=1.045 //x2=52.465 //y2=1.39
r520 (  150 177 ) resistor r=45.1352 //w=0.168 //l=0.173853 //layer=ply \
 //thickness=0.18 //x=47.26 //y=1.44 //x2=47.22 //y2=1.595
r521 (  149 176 ) resistor r=45.1352 //w=0.168 //l=0.173853 //layer=ply \
 //thickness=0.18 //x=47.26 //y=1.095 //x2=47.22 //y2=0.94
r522 (  149 150 ) resistor r=176.904 //w=0.094 //l=0.345 //layer=ply \
 //thickness=0.18 //x=47.26 //y=1.095 //x2=47.26 //y2=1.44
r523 (  147 173 ) resistor r=10.701 //w=0.21 //l=0.115 //layer=ply \
 //thickness=0.18 //x=46.885 //y=1.595 //x2=46.77 //y2=1.595
r524 (  146 177 ) resistor r=5.52526 //w=0.168 //l=0.115 //layer=ply \
 //thickness=0.18 //x=47.105 //y=1.595 //x2=47.22 //y2=1.595
r525 (  145 172 ) resistor r=5.52526 //w=0.168 //l=0.115 //layer=ply \
 //thickness=0.18 //x=46.885 //y=0.94 //x2=46.77 //y2=0.94
r526 (  144 176 ) resistor r=5.52526 //w=0.168 //l=0.115 //layer=ply \
 //thickness=0.18 //x=47.105 //y=0.94 //x2=47.22 //y2=0.94
r527 (  144 145 ) resistor r=112.809 //w=0.094 //l=0.22 //layer=ply \
 //thickness=0.18 //x=47.105 //y=0.94 //x2=46.885 //y2=0.94
r528 (  141 175 ) resistor r=37.236 //w=0.233 //l=0.249199 //layer=ply \
 //thickness=0.18 //x=46.92 //y=5.045 //x2=46.74 //y2=4.88
r529 (  139 173 ) resistor r=39.5823 //w=0.21 //l=0.173853 //layer=ply \
 //thickness=0.18 //x=46.73 //y=1.75 //x2=46.77 //y2=1.595
r530 (  139 170 ) resistor r=176.904 //w=0.094 //l=0.345 //layer=ply \
 //thickness=0.18 //x=46.73 //y=1.75 //x2=46.73 //y2=2.095
r531 (  138 173 ) resistor r=39.5823 //w=0.21 //l=0.173853 //layer=ply \
 //thickness=0.18 //x=46.73 //y=1.44 //x2=46.77 //y2=1.595
r532 (  137 172 ) resistor r=45.1352 //w=0.168 //l=0.173853 //layer=ply \
 //thickness=0.18 //x=46.73 //y=1.095 //x2=46.77 //y2=0.94
r533 (  137 138 ) resistor r=176.904 //w=0.094 //l=0.345 //layer=ply \
 //thickness=0.18 //x=46.73 //y=1.095 //x2=46.73 //y2=1.44
r534 (  134 175 ) resistor r=53.7854 //w=0.233 //l=0.332415 //layer=ply \
 //thickness=0.18 //x=46.48 //y=5.045 //x2=46.74 //y2=4.88
r535 (  133 165 ) resistor r=592.245 //w=0.094 //l=1.155 //layer=ply \
 //thickness=0.18 //x=53 //y=6.2 //x2=53 //y2=5.045
r536 (  132 155 ) resistor r=592.245 //w=0.094 //l=1.155 //layer=ply \
 //thickness=0.18 //x=52.56 //y=6.2 //x2=52.56 //y2=5.045
r537 (  131 141 ) resistor r=592.245 //w=0.094 //l=1.155 //layer=ply \
 //thickness=0.18 //x=46.92 //y=6.2 //x2=46.92 //y2=5.045
r538 (  130 134 ) resistor r=592.245 //w=0.094 //l=1.155 //layer=ply \
 //thickness=0.18 //x=46.48 //y=6.2 //x2=46.48 //y2=5.045
r539 (  129 160 ) resistor r=56.4043 //w=0.094 //l=0.11 //layer=ply \
 //thickness=0.18 //x=52.73 //y=1.545 //x2=52.84 //y2=1.545
r540 (  129 161 ) resistor r=56.4043 //w=0.094 //l=0.11 //layer=ply \
 //thickness=0.18 //x=52.73 //y=1.545 //x2=52.62 //y2=1.545
r541 (  128 146 ) resistor r=56.4043 //w=0.094 //l=0.11 //layer=ply \
 //thickness=0.18 //x=46.995 //y=1.595 //x2=47.105 //y2=1.595
r542 (  128 147 ) resistor r=56.4043 //w=0.094 //l=0.11 //layer=ply \
 //thickness=0.18 //x=46.995 //y=1.595 //x2=46.885 //y2=1.595
r543 (  124 184 ) resistor r=152 //w=0.17 //l=0.17 //layer=licon //count=1 \
 //x=52.66 //y=4.88 //x2=52.66 //y2=4.88
r544 (  115 179 ) resistor r=152 //w=0.17 //l=0.17 //layer=licon //count=1 \
 //x=52.66 //y=2.26 //x2=52.66 //y2=2.26
r545 (  98 190 ) resistor r=23.615 //w=0.187 //l=0.345 //layer=li \
 //thickness=0.1 //x=50.33 //y=5.56 //x2=50.33 //y2=5.905
r546 (  90 189 ) resistor r=23.615 //w=0.187 //l=0.345 //layer=li \
 //thickness=0.1 //x=49.45 //y=5.56 //x2=49.45 //y2=5.905
r547 (  85 175 ) resistor r=152 //w=0.17 //l=0.17 //layer=licon //count=1 \
 //x=46.74 //y=4.88 //x2=46.74 //y2=4.88
r548 (  76 169 ) resistor r=152 //w=0.17 //l=0.17 //layer=licon //count=1 \
 //x=46.74 //y=2.26 //x2=46.74 //y2=2.26
r549 (  72 73 ) resistor r=0.10734 //w=0.281 //l=0.16 //layer=m2 \
 //thickness=0.36 //x=52.655 //y=3.505 //x2=52.495 //y2=3.505
r550 (  65 70 ) resistor r=0.10188 //w=0.204 //l=0.16 //layer=m2 \
 //thickness=0.36 //x=50.965 //y=3.51 //x2=50.805 //y2=3.51
r551 (  65 73 ) resistor r=1.45992 //w=0.131 //l=1.53 //layer=m2 \
 //thickness=0.36 //x=50.965 //y=3.51 //x2=52.495 //y2=3.51
r552 (  62 70 ) resistor r=0.778963 //w=0.204 //l=1.27248 //layer=m2 \
 //thickness=0.36 //x=49.54 //y=3.495 //x2=50.805 //y2=3.51
r553 (  62 63 ) resistor r=0.410305 //w=0.131 //l=0.43 //layer=m2 \
 //thickness=0.36 //x=49.54 //y=3.495 //x2=49.11 //y2=3.495
r554 (  60 63 ) resistor r=0.125 //w=0.17 //l=0.177341 //layer=m2 \
 //thickness=0.36 //x=48.94 //y=3.51 //x2=49.11 //y2=3.495
r555 (  60 61 ) resistor r=0.944656 //w=0.131 //l=0.99 //layer=m2 \
 //thickness=0.36 //x=48.94 //y=3.51 //x2=47.95 //y2=3.51
r556 (  58 61 ) resistor r=0.1875 //w=0.17 //l=0.262393 //layer=m2 \
 //thickness=0.36 //x=47.695 //y=3.495 //x2=47.95 //y2=3.51
r557 (  58 59 ) resistor r=0.410305 //w=0.131 //l=0.43 //layer=m2 \
 //thickness=0.36 //x=47.695 //y=3.495 //x2=47.265 //y2=3.495
r558 (  57 67 ) resistor r=0.10734 //w=0.281 //l=0.16 //layer=m2 \
 //thickness=0.36 //x=46.905 //y=3.51 //x2=46.745 //y2=3.51
r559 (  56 59 ) resistor r=0.125 //w=0.17 //l=0.177341 //layer=m2 \
 //thickness=0.36 //x=47.095 //y=3.51 //x2=47.265 //y2=3.495
r560 (  56 57 ) resistor r=0.181298 //w=0.131 //l=0.19 //layer=m2 \
 //thickness=0.36 //x=47.095 //y=3.51 //x2=46.905 //y2=3.51
r561 (  53 124 ) resistor r=9.3 //w=0.17 //l=0.17 //layer=mcon //count=1 \
 //x=52.66 //y=4.88 //x2=52.66 //y2=4.88
r562 (  53 54 ) resistor r=0.103207 //w=0.196 //l=0.14 //layer=m1 \
 //thickness=0.36 //x=52.662 //y=4.88 //x2=52.662 //y2=4.74
r563 (  50 115 ) resistor r=9.3 //w=0.17 //l=0.17 //layer=mcon //count=1 \
 //x=52.66 //y=2.26 //x2=52.66 //y2=2.26
r564 (  46 72 ) resistor r=4.5 //w=0.15 //l=0.15 //layer=via1 //count=1 \
 //x=52.655 //y=3.505 //x2=52.655 //y2=3.505
r565 (  46 48 ) resistor r=0.00167112 //w=0.374 //l=0.005 //layer=m1 \
 //thickness=0.36 //x=52.605 //y=3.505 //x2=52.605 //y2=3.51
r566 (  43 70 ) resistor r=4.5 //w=0.15 //l=0.15 //layer=via1 //count=1 \
 //x=50.805 //y=3.51 //x2=50.805 //y2=3.51
r567 (  40 187 ) resistor r=9.3 //w=0.17 //l=0.17 //layer=mcon //count=1 \
 //x=50.37 //y=1.18 //x2=50.37 //y2=1.18
r568 (  38 98 ) resistor r=9.3 //w=0.17 //l=0.17 //layer=mcon //count=1 \
 //x=50.33 //y=5.56 //x2=50.33 //y2=5.56
r569 (  35 38 ) resistor r=0.117801 //w=0.191 //l=0.18 //layer=m1 \
 //thickness=0.36 //x=50.33 //y=5.38 //x2=50.33 //y2=5.56
r570 (  34 90 ) resistor r=9.3 //w=0.17 //l=0.17 //layer=mcon //count=1 \
 //x=49.45 //y=5.56 //x2=49.45 //y2=5.56
r571 (  32 34 ) resistor r=0.10274 //w=0.219 //l=0.18 //layer=m1 \
 //thickness=0.36 //x=49.45 //y=5.38 //x2=49.45 //y2=5.56
r572 (  30 67 ) resistor r=4.5 //w=0.15 //l=0.15 //layer=via1 //count=1 \
 //x=46.745 //y=3.51 //x2=46.745 //y2=3.51
r573 (  28 85 ) resistor r=9.3 //w=0.17 //l=0.17 //layer=mcon //count=1 \
 //x=46.74 //y=4.88 //x2=46.74 //y2=4.88
r574 (  26 76 ) resistor r=9.3 //w=0.17 //l=0.17 //layer=mcon //count=1 \
 //x=46.74 //y=2.26 //x2=46.74 //y2=2.26
r575 (  23 48 ) resistor r=0.089409 //w=0.374 //l=0.180416 //layer=m1 \
 //thickness=0.36 //x=52.66 //y=3.665 //x2=52.605 //y2=3.51
r576 (  23 54 ) resistor r=1.02576 //w=0.131 //l=1.075 //layer=m1 \
 //thickness=0.36 //x=52.66 //y=3.665 //x2=52.66 //y2=4.74
r577 (  22 46 ) resistor r=0.0910802 //w=0.374 //l=0.185472 //layer=m1 \
 //thickness=0.36 //x=52.66 //y=3.345 //x2=52.605 //y2=3.505
r578 (  21 50 ) resistor r=0.0933015 //w=0.201 //l=0.125 //layer=m1 \
 //thickness=0.36 //x=52.66 //y=2.385 //x2=52.66 //y2=2.26
r579 (  21 22 ) resistor r=0.916031 //w=0.131 //l=0.96 //layer=m1 \
 //thickness=0.36 //x=52.66 //y=2.385 //x2=52.66 //y2=3.345
r580 (  19 43 ) resistor r=0.0910802 //w=0.374 //l=0.185472 //layer=m1 \
 //thickness=0.36 //x=50.81 //y=3.67 //x2=50.755 //y2=3.51
r581 (  19 20 ) resistor r=1.55057 //w=0.131 //l=1.625 //layer=m1 \
 //thickness=0.36 //x=50.81 //y=3.67 //x2=50.81 //y2=5.295
r582 (  18 43 ) resistor r=0.0910802 //w=0.374 //l=0.185472 //layer=m1 \
 //thickness=0.36 //x=50.81 //y=3.35 //x2=50.755 //y2=3.51
r583 (  17 18 ) resistor r=1.3645 //w=0.131 //l=1.43 //layer=m1 \
 //thickness=0.36 //x=50.81 //y=1.92 //x2=50.81 //y2=3.35
r584 (  15 17 ) resistor r=0.0698411 //w=0.17 //l=0.120208 //layer=m1 \
 //thickness=0.36 //x=50.725 //y=1.835 //x2=50.81 //y2=1.92
r585 (  15 16 ) resistor r=0.257634 //w=0.131 //l=0.27 //layer=m1 \
 //thickness=0.36 //x=50.725 //y=1.835 //x2=50.455 //y2=1.835
r586 (  14 35 ) resistor r=0.0257089 //w=0.23 //l=0.115 //layer=m1 \
 //thickness=0.36 //x=50.445 //y=5.38 //x2=50.33 //y2=5.38
r587 (  13 20 ) resistor r=0.0698411 //w=0.17 //l=0.120208 //layer=m1 \
 //thickness=0.36 //x=50.725 //y=5.38 //x2=50.81 //y2=5.295
r588 (  13 14 ) resistor r=0.267176 //w=0.131 //l=0.28 //layer=m1 \
 //thickness=0.36 //x=50.725 //y=5.38 //x2=50.445 //y2=5.38
r589 (  12 16 ) resistor r=0.0698411 //w=0.17 //l=0.120208 //layer=m1 \
 //thickness=0.36 //x=50.37 //y=1.75 //x2=50.455 //y2=1.835
r590 (  11 40 ) resistor r=0.0913624 //w=0.191 //l=0.12 //layer=m1 \
 //thickness=0.36 //x=50.37 //y=1.3 //x2=50.37 //y2=1.18
r591 (  11 12 ) resistor r=0.429389 //w=0.131 //l=0.45 //layer=m1 \
 //thickness=0.36 //x=50.37 //y=1.3 //x2=50.37 //y2=1.75
r592 (  8 32 ) resistor r=0.0227762 //w=0.219 //l=0.115 //layer=m1 \
 //thickness=0.36 //x=49.565 //y=5.38 //x2=49.45 //y2=5.38
r593 (  7 35 ) resistor r=0.0257089 //w=0.23 //l=0.115 //layer=m1 \
 //thickness=0.36 //x=50.215 //y=5.38 //x2=50.33 //y2=5.38
r594 (  7 8 ) resistor r=0.620229 //w=0.131 //l=0.65 //layer=m1 \
 //thickness=0.36 //x=50.215 //y=5.38 //x2=49.565 //y2=5.38
r595 (  4 28 ) resistor r=0.0801089 //w=0.224 //l=0.13 //layer=m1 \
 //thickness=0.36 //x=46.74 //y=4.75 //x2=46.74 //y2=4.88
r596 (  3 30 ) resistor r=0.0910802 //w=0.374 //l=0.185472 //layer=m1 \
 //thickness=0.36 //x=46.74 //y=3.67 //x2=46.795 //y2=3.51
r597 (  3 4 ) resistor r=1.03053 //w=0.131 //l=1.08 //layer=m1 \
 //thickness=0.36 //x=46.74 //y=3.67 //x2=46.74 //y2=4.75
r598 (  2 30 ) resistor r=0.0910802 //w=0.374 //l=0.185472 //layer=m1 \
 //thickness=0.36 //x=46.74 //y=3.35 //x2=46.795 //y2=3.51
r599 (  1 26 ) resistor r=0.0719237 //w=0.222 //l=0.115 //layer=m1 \
 //thickness=0.36 //x=46.74 //y=2.375 //x2=46.74 //y2=2.26
r600 (  1 2 ) resistor r=0.930344 //w=0.131 //l=0.975 //layer=m1 \
 //thickness=0.36 //x=46.74 //y=2.375 //x2=46.74 //y2=3.35
ends PM_TMRDFFQX1\%noxref_12

subckt PM_TMRDFFQX1\%noxref_13 ( 3 8 9 11 12 14 15 16 18 19 23 24 27 29 32 35 \
 38 41 42 44 45 50 53 61 78 87 91 92 93 94 95 96 97 101 103 106 107 117 120 \
 122 123 )
c289 ( 120 0 ) capacitor c=0.00878249f //x=53.51 //y=1.085
c290 ( 117 0 ) capacitor c=0.0682508f //x=55.99 //y=4.88
c291 ( 107 0 ) capacitor c=0.0318956f //x=56.325 //y=1.39
c292 ( 106 0 ) capacitor c=0.0186809f //x=56.325 //y=1.045
c293 ( 103 0 ) capacitor c=0.0141821f //x=56.17 //y=1.545
c294 ( 101 0 ) capacitor c=0.0158553f //x=56.17 //y=0.89
c295 ( 97 0 ) capacitor c=0.0854195f //x=55.795 //y=2.095
c296 ( 96 0 ) capacitor c=0.0229235f //x=55.795 //y=1.7
c297 ( 95 0 ) capacitor c=0.0234359f //x=55.795 //y=1.39
c298 ( 94 0 ) capacitor c=0.0198759f //x=55.795 //y=1.045
c299 ( 93 0 ) capacitor c=0.110369f //x=56.33 //y=6.2
c300 ( 92 0 ) capacitor c=0.154619f //x=55.89 //y=6.2
c301 ( 87 0 ) capacitor c=8.13425e-19 //x=55.99 //y=4.88
c302 ( 78 0 ) capacitor c=7.85889e-19 //x=55.99 //y=2.26
c303 ( 61 0 ) capacitor c=0.0322017f //x=53.66 //y=5.56
c304 ( 53 0 ) capacitor c=0.0291714f //x=52.78 //y=5.56
c305 ( 50 0 ) capacitor c=4.79804e-19 //x=55.985 //y=3.51
c306 ( 45 0 ) capacitor c=7.23354e-19 //x=54.305 //y=3.51
c307 ( 44 0 ) capacitor c=0.018923f //x=55.825 //y=3.51
c308 ( 42 0 ) capacitor c=0.0270852f //x=55.992 //y=4.74
c309 ( 41 0 ) capacitor c=0.0060492f //x=55.99 //y=4.88
c310 ( 38 0 ) capacitor c=0.00463527f //x=55.99 //y=2.26
c311 ( 35 0 ) capacitor c=0.0164425f //x=55.985 //y=3.51
c312 ( 32 0 ) capacitor c=0.0167895f //x=54.14 //y=3.51
c313 ( 29 0 ) capacitor c=0.0113259f //x=53.7 //y=1.18
c314 ( 27 0 ) capacitor c=5.78613e-19 //x=53.66 //y=5.56
c315 ( 24 0 ) capacitor c=0.0103127f //x=53.66 //y=5.38
c316 ( 23 0 ) capacitor c=0.00933334f //x=52.78 //y=5.56
c317 ( 19 0 ) capacitor c=0.0131304f //x=55.99 //y=3.67
c318 ( 18 0 ) capacitor c=0.0254889f //x=55.99 //y=3.35
c319 ( 16 0 ) capacitor c=0.0402141f //x=54.14 //y=5.295
c320 ( 15 0 ) capacitor c=0.0132742f //x=54.14 //y=3.67
c321 ( 14 0 ) capacitor c=0.0374345f //x=54.14 //y=3.35
c322 ( 12 0 ) capacitor c=0.00465779f //x=53.785 //y=1.835
c323 ( 11 0 ) capacitor c=0.0117221f //x=54.055 //y=1.835
c324 ( 9 0 ) capacitor c=0.0112475f //x=54.055 //y=5.38
c325 ( 8 0 ) capacitor c=0.0101547f //x=53.7 //y=1.75
c326 ( 3 0 ) capacitor c=0.0134484f //x=53.545 //y=5.38
r327 (  115 117 ) resistor r=20.6867 //w=0.233 //l=0.1 //layer=ply \
 //thickness=0.18 //x=55.89 //y=4.88 //x2=55.99 //y2=4.88
r328 (  108 117 ) resistor r=70.3348 //w=0.233 //l=0.414367 //layer=ply \
 //thickness=0.18 //x=56.33 //y=5.045 //x2=55.99 //y2=4.88
r329 (  107 119 ) resistor r=45.1352 //w=0.168 //l=0.173853 //layer=ply \
 //thickness=0.18 //x=56.325 //y=1.39 //x2=56.285 //y2=1.545
r330 (  106 118 ) resistor r=45.1352 //w=0.168 //l=0.173853 //layer=ply \
 //thickness=0.18 //x=56.325 //y=1.045 //x2=56.285 //y2=0.89
r331 (  106 107 ) resistor r=176.904 //w=0.094 //l=0.345 //layer=ply \
 //thickness=0.18 //x=56.325 //y=1.045 //x2=56.325 //y2=1.39
r332 (  104 114 ) resistor r=10.701 //w=0.21 //l=0.115 //layer=ply \
 //thickness=0.18 //x=55.95 //y=1.545 //x2=55.835 //y2=1.545
r333 (  103 119 ) resistor r=5.52526 //w=0.168 //l=0.115 //layer=ply \
 //thickness=0.18 //x=56.17 //y=1.545 //x2=56.285 //y2=1.545
r334 (  102 113 ) resistor r=5.52526 //w=0.168 //l=0.115 //layer=ply \
 //thickness=0.18 //x=55.95 //y=0.89 //x2=55.835 //y2=0.89
r335 (  101 118 ) resistor r=5.52526 //w=0.168 //l=0.115 //layer=ply \
 //thickness=0.18 //x=56.17 //y=0.89 //x2=56.285 //y2=0.89
r336 (  101 102 ) resistor r=112.809 //w=0.094 //l=0.22 //layer=ply \
 //thickness=0.18 //x=56.17 //y=0.89 //x2=55.95 //y2=0.89
r337 (  98 115 ) resistor r=13.0941 //w=0.233 //l=0.165 //layer=ply \
 //thickness=0.18 //x=55.89 //y=5.045 //x2=55.89 //y2=4.88
r338 (  97 112 ) resistor r=34.8111 //w=0.27 //l=0.264953 //layer=ply \
 //thickness=0.18 //x=55.795 //y=2.095 //x2=55.99 //y2=2.26
r339 (  96 114 ) resistor r=39.5823 //w=0.21 //l=0.173853 //layer=ply \
 //thickness=0.18 //x=55.795 //y=1.7 //x2=55.835 //y2=1.545
r340 (  96 97 ) resistor r=202.543 //w=0.094 //l=0.395 //layer=ply \
 //thickness=0.18 //x=55.795 //y=1.7 //x2=55.795 //y2=2.095
r341 (  95 114 ) resistor r=39.5823 //w=0.21 //l=0.173853 //layer=ply \
 //thickness=0.18 //x=55.795 //y=1.39 //x2=55.835 //y2=1.545
r342 (  94 113 ) resistor r=45.1352 //w=0.168 //l=0.173853 //layer=ply \
 //thickness=0.18 //x=55.795 //y=1.045 //x2=55.835 //y2=0.89
r343 (  94 95 ) resistor r=176.904 //w=0.094 //l=0.345 //layer=ply \
 //thickness=0.18 //x=55.795 //y=1.045 //x2=55.795 //y2=1.39
r344 (  93 108 ) resistor r=592.245 //w=0.094 //l=1.155 //layer=ply \
 //thickness=0.18 //x=56.33 //y=6.2 //x2=56.33 //y2=5.045
r345 (  92 98 ) resistor r=592.245 //w=0.094 //l=1.155 //layer=ply \
 //thickness=0.18 //x=55.89 //y=6.2 //x2=55.89 //y2=5.045
r346 (  91 103 ) resistor r=56.4043 //w=0.094 //l=0.11 //layer=ply \
 //thickness=0.18 //x=56.06 //y=1.545 //x2=56.17 //y2=1.545
r347 (  91 104 ) resistor r=56.4043 //w=0.094 //l=0.11 //layer=ply \
 //thickness=0.18 //x=56.06 //y=1.545 //x2=55.95 //y2=1.545
r348 (  87 117 ) resistor r=152 //w=0.17 //l=0.17 //layer=licon //count=1 \
 //x=55.99 //y=4.88 //x2=55.99 //y2=4.88
r349 (  78 112 ) resistor r=152 //w=0.17 //l=0.17 //layer=licon //count=1 \
 //x=55.99 //y=2.26 //x2=55.99 //y2=2.26
r350 (  61 123 ) resistor r=23.615 //w=0.187 //l=0.345 //layer=li \
 //thickness=0.1 //x=53.66 //y=5.56 //x2=53.66 //y2=5.905
r351 (  53 122 ) resistor r=23.615 //w=0.187 //l=0.345 //layer=li \
 //thickness=0.1 //x=52.78 //y=5.56 //x2=52.78 //y2=5.905
r352 (  45 47 ) resistor r=0.10734 //w=0.281 //l=0.16 //layer=m2 \
 //thickness=0.36 //x=54.305 //y=3.51 //x2=54.145 //y2=3.51
r353 (  44 50 ) resistor r=0.10734 //w=0.281 //l=0.16 //layer=m2 \
 //thickness=0.36 //x=55.825 //y=3.51 //x2=55.985 //y2=3.51
r354 (  44 45 ) resistor r=1.45038 //w=0.131 //l=1.52 //layer=m2 \
 //thickness=0.36 //x=55.825 //y=3.51 //x2=54.305 //y2=3.51
r355 (  41 87 ) resistor r=9.3 //w=0.17 //l=0.17 //layer=mcon //count=1 \
 //x=55.99 //y=4.88 //x2=55.99 //y2=4.88
r356 (  41 42 ) resistor r=0.103207 //w=0.196 //l=0.14 //layer=m1 \
 //thickness=0.36 //x=55.992 //y=4.88 //x2=55.992 //y2=4.74
r357 (  38 78 ) resistor r=9.3 //w=0.17 //l=0.17 //layer=mcon //count=1 \
 //x=55.99 //y=2.26 //x2=55.99 //y2=2.26
r358 (  35 50 ) resistor r=4.5 //w=0.15 //l=0.15 //layer=via1 //count=1 \
 //x=55.985 //y=3.51 //x2=55.985 //y2=3.51
r359 (  32 47 ) resistor r=4.5 //w=0.15 //l=0.15 //layer=via1 //count=1 \
 //x=54.145 //y=3.51 //x2=54.145 //y2=3.51
r360 (  29 120 ) resistor r=9.3 //w=0.17 //l=0.17 //layer=mcon //count=1 \
 //x=53.7 //y=1.18 //x2=53.7 //y2=1.18
r361 (  27 61 ) resistor r=9.3 //w=0.17 //l=0.17 //layer=mcon //count=1 \
 //x=53.66 //y=5.56 //x2=53.66 //y2=5.56
r362 (  24 27 ) resistor r=0.117801 //w=0.191 //l=0.18 //layer=m1 \
 //thickness=0.36 //x=53.66 //y=5.38 //x2=53.66 //y2=5.56
r363 (  23 53 ) resistor r=9.3 //w=0.17 //l=0.17 //layer=mcon //count=1 \
 //x=52.78 //y=5.56 //x2=52.78 //y2=5.56
r364 (  21 23 ) resistor r=0.10274 //w=0.219 //l=0.18 //layer=m1 \
 //thickness=0.36 //x=52.78 //y=5.38 //x2=52.78 //y2=5.56
r365 (  19 35 ) resistor r=0.0910802 //w=0.374 //l=0.185472 //layer=m1 \
 //thickness=0.36 //x=55.99 //y=3.67 //x2=55.935 //y2=3.51
r366 (  19 42 ) resistor r=1.02099 //w=0.131 //l=1.07 //layer=m1 \
 //thickness=0.36 //x=55.99 //y=3.67 //x2=55.99 //y2=4.74
r367 (  18 35 ) resistor r=0.0910802 //w=0.374 //l=0.185472 //layer=m1 \
 //thickness=0.36 //x=55.99 //y=3.35 //x2=55.935 //y2=3.51
r368 (  17 38 ) resistor r=0.0933015 //w=0.201 //l=0.125 //layer=m1 \
 //thickness=0.36 //x=55.99 //y=2.385 //x2=55.99 //y2=2.26
r369 (  17 18 ) resistor r=0.920802 //w=0.131 //l=0.965 //layer=m1 \
 //thickness=0.36 //x=55.99 //y=2.385 //x2=55.99 //y2=3.35
r370 (  15 32 ) resistor r=0.0910802 //w=0.374 //l=0.185472 //layer=m1 \
 //thickness=0.36 //x=54.14 //y=3.67 //x2=54.195 //y2=3.51
r371 (  15 16 ) resistor r=1.55057 //w=0.131 //l=1.625 //layer=m1 \
 //thickness=0.36 //x=54.14 //y=3.67 //x2=54.14 //y2=5.295
r372 (  14 32 ) resistor r=0.0910802 //w=0.374 //l=0.185472 //layer=m1 \
 //thickness=0.36 //x=54.14 //y=3.35 //x2=54.195 //y2=3.51
r373 (  13 14 ) resistor r=1.3645 //w=0.131 //l=1.43 //layer=m1 \
 //thickness=0.36 //x=54.14 //y=1.92 //x2=54.14 //y2=3.35
r374 (  11 13 ) resistor r=0.0698411 //w=0.17 //l=0.120208 //layer=m1 \
 //thickness=0.36 //x=54.055 //y=1.835 //x2=54.14 //y2=1.92
r375 (  11 12 ) resistor r=0.257634 //w=0.131 //l=0.27 //layer=m1 \
 //thickness=0.36 //x=54.055 //y=1.835 //x2=53.785 //y2=1.835
r376 (  10 24 ) resistor r=0.0257089 //w=0.23 //l=0.115 //layer=m1 \
 //thickness=0.36 //x=53.775 //y=5.38 //x2=53.66 //y2=5.38
r377 (  9 16 ) resistor r=0.0698411 //w=0.17 //l=0.120208 //layer=m1 \
 //thickness=0.36 //x=54.055 //y=5.38 //x2=54.14 //y2=5.295
r378 (  9 10 ) resistor r=0.267176 //w=0.131 //l=0.28 //layer=m1 \
 //thickness=0.36 //x=54.055 //y=5.38 //x2=53.775 //y2=5.38
r379 (  8 12 ) resistor r=0.0698411 //w=0.17 //l=0.120208 //layer=m1 \
 //thickness=0.36 //x=53.7 //y=1.75 //x2=53.785 //y2=1.835
r380 (  7 29 ) resistor r=0.0913624 //w=0.191 //l=0.12 //layer=m1 \
 //thickness=0.36 //x=53.7 //y=1.3 //x2=53.7 //y2=1.18
r381 (  7 8 ) resistor r=0.429389 //w=0.131 //l=0.45 //layer=m1 \
 //thickness=0.36 //x=53.7 //y=1.3 //x2=53.7 //y2=1.75
r382 (  4 21 ) resistor r=0.0227762 //w=0.219 //l=0.115 //layer=m1 \
 //thickness=0.36 //x=52.895 //y=5.38 //x2=52.78 //y2=5.38
r383 (  3 24 ) resistor r=0.0257089 //w=0.23 //l=0.115 //layer=m1 \
 //thickness=0.36 //x=53.545 //y=5.38 //x2=53.66 //y2=5.38
r384 (  3 4 ) resistor r=0.620229 //w=0.131 //l=0.65 //layer=m1 \
 //thickness=0.36 //x=53.545 //y=5.38 //x2=52.895 //y2=5.38
ends PM_TMRDFFQX1\%noxref_13

subckt PM_TMRDFFQX1\%CLK ( 1 2 3 4 5 6 7 8 9 10 11 12 13 14 15 16 17 18 19 31 \
 40 50 56 62 66 72 78 82 88 94 97 99 101 102 105 106 107 109 111 115 117 118 \
 119 120 121 123 125 127 131 133 134 135 140 148 153 158 163 168 173 178 183 \
 188 193 198 203 207 208 209 210 211 212 213 214 215 216 217 218 219 220 221 \
 222 223 224 225 226 227 229 235 236 237 238 239 244 245 246 251 253 255 261 \
 262 263 264 265 267 273 274 275 276 277 282 283 284 289 291 293 299 300 301 \
 302 303 305 311 312 313 314 315 320 321 322 327 329 331 337 338 342 351 352 \
 355 366 375 376 379 390 399 400 403 )
c998 ( 403 0 ) capacitor c=0.0366322f //x=56.76 //y=4.88
c999 ( 400 0 ) capacitor c=0.0284095f //x=56.73 //y=2.095
c1000 ( 399 0 ) capacitor c=0.0476356f //x=56.73 //y=2.26
c1001 ( 390 0 ) capacitor c=0.0372825f //x=45.63 //y=4.88
c1002 ( 379 0 ) capacitor c=0.0366322f //x=35.3 //y=4.88
c1003 ( 376 0 ) capacitor c=0.0284095f //x=35.27 //y=2.095
c1004 ( 375 0 ) capacitor c=0.0476356f //x=35.27 //y=2.26
c1005 ( 366 0 ) capacitor c=0.0372825f //x=24.17 //y=4.88
c1006 ( 355 0 ) capacitor c=0.0366322f //x=13.84 //y=4.88
c1007 ( 352 0 ) capacitor c=0.0284095f //x=13.81 //y=2.095
c1008 ( 351 0 ) capacitor c=0.0476356f //x=13.81 //y=2.26
c1009 ( 342 0 ) capacitor c=0.0372825f //x=2.71 //y=4.88
c1010 ( 338 0 ) capacitor c=0.0439708f //x=57.295 //y=1.43
c1011 ( 337 0 ) capacitor c=0.0192582f //x=57.295 //y=1.085
c1012 ( 331 0 ) capacitor c=0.0162526f //x=57.14 //y=1.585
c1013 ( 329 0 ) capacitor c=0.0157807f //x=57.14 //y=0.93
c1014 ( 327 0 ) capacitor c=0.0353784f //x=57.135 //y=4.97
c1015 ( 322 0 ) capacitor c=0.0210762f //x=56.765 //y=1.74
c1016 ( 321 0 ) capacitor c=0.0168511f //x=56.765 //y=1.43
c1017 ( 320 0 ) capacitor c=0.0175485f //x=56.765 //y=1.085
c1018 ( 315 0 ) capacitor c=0.0305913f //x=45.965 //y=4.97
c1019 ( 314 0 ) capacitor c=0.0863671f //x=45.72 //y=2.095
c1020 ( 313 0 ) capacitor c=0.0170266f //x=45.72 //y=1.63
c1021 ( 312 0 ) capacitor c=0.018609f //x=45.72 //y=1.4
c1022 ( 311 0 ) capacitor c=0.0186599f //x=45.72 //y=1.09
c1023 ( 305 0 ) capacitor c=0.0146988f //x=45.565 //y=1.555
c1024 ( 303 0 ) capacitor c=0.0148531f //x=45.565 //y=0.935
c1025 ( 302 0 ) capacitor c=0.0334406f //x=45.195 //y=1.4
c1026 ( 301 0 ) capacitor c=0.0173191f //x=45.195 //y=1.09
c1027 ( 300 0 ) capacitor c=0.0439708f //x=35.835 //y=1.43
c1028 ( 299 0 ) capacitor c=0.0192582f //x=35.835 //y=1.085
c1029 ( 293 0 ) capacitor c=0.0162526f //x=35.68 //y=1.585
c1030 ( 291 0 ) capacitor c=0.0157807f //x=35.68 //y=0.93
c1031 ( 289 0 ) capacitor c=0.0353784f //x=35.675 //y=4.97
c1032 ( 284 0 ) capacitor c=0.0210762f //x=35.305 //y=1.74
c1033 ( 283 0 ) capacitor c=0.0168511f //x=35.305 //y=1.43
c1034 ( 282 0 ) capacitor c=0.0175485f //x=35.305 //y=1.085
c1035 ( 277 0 ) capacitor c=0.0305913f //x=24.505 //y=4.97
c1036 ( 276 0 ) capacitor c=0.0863671f //x=24.26 //y=2.095
c1037 ( 275 0 ) capacitor c=0.0170266f //x=24.26 //y=1.63
c1038 ( 274 0 ) capacitor c=0.018609f //x=24.26 //y=1.4
c1039 ( 273 0 ) capacitor c=0.0186599f //x=24.26 //y=1.09
c1040 ( 267 0 ) capacitor c=0.0146988f //x=24.105 //y=1.555
c1041 ( 265 0 ) capacitor c=0.0148531f //x=24.105 //y=0.935
c1042 ( 264 0 ) capacitor c=0.0334406f //x=23.735 //y=1.4
c1043 ( 263 0 ) capacitor c=0.0173191f //x=23.735 //y=1.09
c1044 ( 262 0 ) capacitor c=0.0439708f //x=14.375 //y=1.43
c1045 ( 261 0 ) capacitor c=0.0192582f //x=14.375 //y=1.085
c1046 ( 255 0 ) capacitor c=0.0162526f //x=14.22 //y=1.585
c1047 ( 253 0 ) capacitor c=0.0157807f //x=14.22 //y=0.93
c1048 ( 251 0 ) capacitor c=0.0353784f //x=14.215 //y=4.97
c1049 ( 246 0 ) capacitor c=0.0210762f //x=13.845 //y=1.74
c1050 ( 245 0 ) capacitor c=0.0168511f //x=13.845 //y=1.43
c1051 ( 244 0 ) capacitor c=0.0175485f //x=13.845 //y=1.085
c1052 ( 239 0 ) capacitor c=0.0305913f //x=3.045 //y=4.97
c1053 ( 238 0 ) capacitor c=0.0863671f //x=2.8 //y=2.095
c1054 ( 237 0 ) capacitor c=0.0170266f //x=2.8 //y=1.63
c1055 ( 236 0 ) capacitor c=0.018609f //x=2.8 //y=1.4
c1056 ( 235 0 ) capacitor c=0.0186599f //x=2.8 //y=1.09
c1057 ( 229 0 ) capacitor c=0.0146988f //x=2.645 //y=1.555
c1058 ( 227 0 ) capacitor c=0.0148531f //x=2.645 //y=0.935
c1059 ( 226 0 ) capacitor c=0.0334406f //x=2.275 //y=1.4
c1060 ( 225 0 ) capacitor c=0.0173191f //x=2.275 //y=1.09
c1061 ( 224 0 ) capacitor c=0.155269f //x=57.21 //y=6.2
c1062 ( 223 0 ) capacitor c=0.110375f //x=56.77 //y=6.2
c1063 ( 222 0 ) capacitor c=0.110208f //x=46.04 //y=6.2
c1064 ( 221 0 ) capacitor c=0.110214f //x=45.6 //y=6.2
c1065 ( 220 0 ) capacitor c=0.155269f //x=35.75 //y=6.2
c1066 ( 219 0 ) capacitor c=0.110375f //x=35.31 //y=6.2
c1067 ( 218 0 ) capacitor c=0.110208f //x=24.58 //y=6.2
c1068 ( 217 0 ) capacitor c=0.110214f //x=24.14 //y=6.2
c1069 ( 216 0 ) capacitor c=0.155269f //x=14.29 //y=6.2
c1070 ( 215 0 ) capacitor c=0.110375f //x=13.85 //y=6.2
c1071 ( 214 0 ) capacitor c=0.110208f //x=3.12 //y=6.2
c1072 ( 213 0 ) capacitor c=0.110214f //x=2.68 //y=6.2
c1073 ( 203 0 ) capacitor c=8.63406e-19 //x=56.76 //y=4.88
c1074 ( 198 0 ) capacitor c=7.72439e-19 //x=56.73 //y=2.26
c1075 ( 193 0 ) capacitor c=0.00143828f //x=45.63 //y=4.88
c1076 ( 188 0 ) capacitor c=0.00121786f //x=45.63 //y=2.26
c1077 ( 183 0 ) capacitor c=8.63406e-19 //x=35.3 //y=4.88
c1078 ( 178 0 ) capacitor c=7.72439e-19 //x=35.27 //y=2.26
c1079 ( 173 0 ) capacitor c=0.00143828f //x=24.17 //y=4.88
c1080 ( 168 0 ) capacitor c=0.00121786f //x=24.17 //y=2.26
c1081 ( 163 0 ) capacitor c=8.63406e-19 //x=13.84 //y=4.88
c1082 ( 158 0 ) capacitor c=7.72439e-19 //x=13.81 //y=2.26
c1083 ( 153 0 ) capacitor c=0.00143828f //x=2.71 //y=4.88
c1084 ( 148 0 ) capacitor c=0.00121786f //x=2.71 //y=2.26
c1085 ( 140 0 ) capacitor c=0.0529879f //x=17.235 //y=4.62
c1086 ( 135 0 ) capacitor c=0.00230753f //x=2.71 //y=4.62
c1087 ( 134 0 ) capacitor c=0.197144f //x=53.275 //y=4.64
c1088 ( 133 0 ) capacitor c=0.0877785f //x=53.62 //y=4.64
c1089 ( 131 0 ) capacitor c=0.00147048f //x=45.63 //y=4.88
c1090 ( 127 0 ) capacitor c=0.00744552f //x=44.74 //y=4.64
c1091 ( 125 0 ) capacitor c=0.0761212f //x=44.14 //y=4.62
c1092 ( 123 0 ) capacitor c=0.0105203f //x=42.145 //y=4.635
c1093 ( 121 0 ) capacitor c=0.132089f //x=41.545 //y=4.62
c1094 ( 120 0 ) capacitor c=0.0847646f //x=35.87 //y=4.65
c1095 ( 119 0 ) capacitor c=0.0146011f //x=36.215 //y=4.65
c1096 ( 118 0 ) capacitor c=0.197099f //x=31.815 //y=4.64
c1097 ( 117 0 ) capacitor c=0.00468492f //x=32.16 //y=4.64
c1098 ( 115 0 ) capacitor c=0.00147048f //x=24.17 //y=4.88
c1099 ( 111 0 ) capacitor c=0.00744552f //x=23.28 //y=4.64
c1100 ( 109 0 ) capacitor c=0.0753491f //x=22.68 //y=4.62
c1101 ( 107 0 ) capacitor c=0.0105203f //x=20.685 //y=4.635
c1102 ( 106 0 ) capacitor c=0.00167146f //x=17.32 //y=4.62
c1103 ( 105 0 ) capacitor c=0.0744572f //x=20.085 //y=4.62
c1104 ( 102 0 ) capacitor c=0.0846315f //x=14.395 //y=4.642
c1105 ( 101 0 ) capacitor c=0.016784f //x=14.763 //y=4.642
c1106 ( 99 0 ) capacitor c=0.00468492f //x=10.7 //y=4.64
c1107 ( 97 0 ) capacitor c=0.178406f //x=10.1 //y=4.62
c1108 ( 94 0 ) capacitor c=0.00504845f //x=56.73 //y=2.26
c1109 ( 88 0 ) capacitor c=0.00618093f //x=56.755 //y=4.865
c1110 ( 82 0 ) capacitor c=0.00543381f //x=45.63 //y=4.88
c1111 ( 78 0 ) capacitor c=0.00680024f //x=35.27 //y=2.26
c1112 ( 72 0 ) capacitor c=0.00618409f //x=35.295 //y=4.865
c1113 ( 66 0 ) capacitor c=0.00543901f //x=24.17 //y=4.88
c1114 ( 62 0 ) capacitor c=0.00680024f //x=13.81 //y=2.26
c1115 ( 56 0 ) capacitor c=0.00618409f //x=13.835 //y=4.865
c1116 ( 50 0 ) capacitor c=0.00551512f //x=2.71 //y=4.88
c1117 ( 40 0 ) capacitor c=0.00380207f //x=45.63 //y=2.375
c1118 ( 31 0 ) capacitor c=0.00565957f //x=24.17 //y=2.375
c1119 ( 19 0 ) capacitor c=0.00565957f //x=2.71 //y=2.375
c1120 ( 17 0 ) capacitor c=0.0480079f //x=56.73 //y=3.51
c1121 ( 14 0 ) capacitor c=0.062747f //x=45.63 //y=3.51
c1122 ( 12 0 ) capacitor c=0.0479032f //x=35.27 //y=3.51
c1123 ( 9 0 ) capacitor c=0.0635391f //x=24.17 //y=3.51
c1124 ( 6 0 ) capacitor c=0.0494096f //x=13.81 //y=3.14
c1125 ( 1 0 ) capacitor c=0.0678123f //x=2.71 //y=2.77
r1126 (  405 406 ) resistor r=32.4568 //w=0.214 //l=0.075 //layer=ply \
 //thickness=0.18 //x=56.76 //y=4.97 //x2=56.76 //y2=5.045
r1127 (  403 405 ) resistor r=20.271 //w=0.214 //l=0.09 //layer=ply \
 //thickness=0.18 //x=56.76 //y=4.88 //x2=56.76 //y2=4.97
r1128 (  399 400 ) resistor r=52.7279 //w=0.214 //l=0.165 //layer=ply \
 //thickness=0.18 //x=56.73 //y=2.26 //x2=56.73 //y2=2.095
r1129 (  392 393 ) resistor r=32.4568 //w=0.214 //l=0.075 //layer=ply \
 //thickness=0.18 //x=45.63 //y=4.97 //x2=45.63 //y2=5.045
r1130 (  390 392 ) resistor r=20.271 //w=0.214 //l=0.09 //layer=ply \
 //thickness=0.18 //x=45.63 //y=4.88 //x2=45.63 //y2=4.97
r1131 (  381 382 ) resistor r=32.4568 //w=0.214 //l=0.075 //layer=ply \
 //thickness=0.18 //x=35.3 //y=4.97 //x2=35.3 //y2=5.045
r1132 (  379 381 ) resistor r=20.271 //w=0.214 //l=0.09 //layer=ply \
 //thickness=0.18 //x=35.3 //y=4.88 //x2=35.3 //y2=4.97
r1133 (  375 376 ) resistor r=52.7279 //w=0.214 //l=0.165 //layer=ply \
 //thickness=0.18 //x=35.27 //y=2.26 //x2=35.27 //y2=2.095
r1134 (  368 369 ) resistor r=32.4568 //w=0.214 //l=0.075 //layer=ply \
 //thickness=0.18 //x=24.17 //y=4.97 //x2=24.17 //y2=5.045
r1135 (  366 368 ) resistor r=20.271 //w=0.214 //l=0.09 //layer=ply \
 //thickness=0.18 //x=24.17 //y=4.88 //x2=24.17 //y2=4.97
r1136 (  357 358 ) resistor r=32.4568 //w=0.214 //l=0.075 //layer=ply \
 //thickness=0.18 //x=13.84 //y=4.97 //x2=13.84 //y2=5.045
r1137 (  355 357 ) resistor r=20.271 //w=0.214 //l=0.09 //layer=ply \
 //thickness=0.18 //x=13.84 //y=4.88 //x2=13.84 //y2=4.97
r1138 (  351 352 ) resistor r=52.7279 //w=0.214 //l=0.165 //layer=ply \
 //thickness=0.18 //x=13.81 //y=2.26 //x2=13.81 //y2=2.095
r1139 (  344 345 ) resistor r=32.4568 //w=0.214 //l=0.075 //layer=ply \
 //thickness=0.18 //x=2.71 //y=4.97 //x2=2.71 //y2=5.045
r1140 (  342 344 ) resistor r=20.271 //w=0.214 //l=0.09 //layer=ply \
 //thickness=0.18 //x=2.71 //y=4.88 //x2=2.71 //y2=4.97
r1141 (  338 410 ) resistor r=45.1352 //w=0.168 //l=0.173853 //layer=ply \
 //thickness=0.18 //x=57.295 //y=1.43 //x2=57.255 //y2=1.585
r1142 (  337 409 ) resistor r=45.1352 //w=0.168 //l=0.173853 //layer=ply \
 //thickness=0.18 //x=57.295 //y=1.085 //x2=57.255 //y2=0.93
r1143 (  337 338 ) resistor r=176.904 //w=0.094 //l=0.345 //layer=ply \
 //thickness=0.18 //x=57.295 //y=1.085 //x2=57.295 //y2=1.43
r1144 (  332 408 ) resistor r=10.701 //w=0.21 //l=0.115 //layer=ply \
 //thickness=0.18 //x=56.92 //y=1.585 //x2=56.805 //y2=1.585
r1145 (  331 410 ) resistor r=5.52526 //w=0.168 //l=0.115 //layer=ply \
 //thickness=0.18 //x=57.14 //y=1.585 //x2=57.255 //y2=1.585
r1146 (  330 407 ) resistor r=5.52526 //w=0.168 //l=0.115 //layer=ply \
 //thickness=0.18 //x=56.92 //y=0.93 //x2=56.805 //y2=0.93
r1147 (  329 409 ) resistor r=5.52526 //w=0.168 //l=0.115 //layer=ply \
 //thickness=0.18 //x=57.14 //y=0.93 //x2=57.255 //y2=0.93
r1148 (  329 330 ) resistor r=112.809 //w=0.094 //l=0.22 //layer=ply \
 //thickness=0.18 //x=57.14 //y=0.93 //x2=56.92 //y2=0.93
r1149 (  328 405 ) resistor r=16.5046 //w=0.27 //l=0.135 //layer=ply \
 //thickness=0.18 //x=56.895 //y=4.97 //x2=56.76 //y2=4.97
r1150 (  327 334 ) resistor r=26.9307 //w=0.15 //l=0.106066 //layer=ply \
 //thickness=0.18 //x=57.135 //y=4.97 //x2=57.21 //y2=5.045
r1151 (  327 328 ) resistor r=123.064 //w=0.094 //l=0.24 //layer=ply \
 //thickness=0.18 //x=57.135 //y=4.97 //x2=56.895 //y2=4.97
r1152 (  322 408 ) resistor r=39.5823 //w=0.21 //l=0.173853 //layer=ply \
 //thickness=0.18 //x=56.765 //y=1.74 //x2=56.805 //y2=1.585
r1153 (  322 400 ) resistor r=182.032 //w=0.094 //l=0.355 //layer=ply \
 //thickness=0.18 //x=56.765 //y=1.74 //x2=56.765 //y2=2.095
r1154 (  321 408 ) resistor r=39.5823 //w=0.21 //l=0.173853 //layer=ply \
 //thickness=0.18 //x=56.765 //y=1.43 //x2=56.805 //y2=1.585
r1155 (  320 407 ) resistor r=45.1352 //w=0.168 //l=0.173853 //layer=ply \
 //thickness=0.18 //x=56.765 //y=1.085 //x2=56.805 //y2=0.93
r1156 (  320 321 ) resistor r=176.904 //w=0.094 //l=0.345 //layer=ply \
 //thickness=0.18 //x=56.765 //y=1.085 //x2=56.765 //y2=1.43
r1157 (  316 392 ) resistor r=16.5046 //w=0.27 //l=0.135 //layer=ply \
 //thickness=0.18 //x=45.765 //y=4.97 //x2=45.63 //y2=4.97
r1158 (  315 317 ) resistor r=26.9307 //w=0.15 //l=0.106066 //layer=ply \
 //thickness=0.18 //x=45.965 //y=4.97 //x2=46.04 //y2=5.045
r1159 (  315 316 ) resistor r=102.553 //w=0.094 //l=0.2 //layer=ply \
 //thickness=0.18 //x=45.965 //y=4.97 //x2=45.765 //y2=4.97
r1160 (  314 397 ) resistor r=38.6777 //w=0.284 //l=0.198997 //layer=ply \
 //thickness=0.18 //x=45.72 //y=2.095 //x2=45.645 //y2=2.26
r1161 (  313 395 ) resistor r=21.2976 //w=0.217 //l=0.0928709 //layer=ply \
 //thickness=0.18 //x=45.72 //y=1.63 //x2=45.68 //y2=1.555
r1162 (  313 314 ) resistor r=238.436 //w=0.094 //l=0.465 //layer=ply \
 //thickness=0.18 //x=45.72 //y=1.63 //x2=45.72 //y2=2.095
r1163 (  312 395 ) resistor r=39.0671 //w=0.217 //l=0.173853 //layer=ply \
 //thickness=0.18 //x=45.72 //y=1.4 //x2=45.68 //y2=1.555
r1164 (  311 394 ) resistor r=45.1352 //w=0.168 //l=0.173853 //layer=ply \
 //thickness=0.18 //x=45.72 //y=1.09 //x2=45.68 //y2=0.935
r1165 (  311 312 ) resistor r=158.957 //w=0.094 //l=0.31 //layer=ply \
 //thickness=0.18 //x=45.72 //y=1.09 //x2=45.72 //y2=1.4
r1166 (  306 388 ) resistor r=5.52526 //w=0.168 //l=0.115 //layer=ply \
 //thickness=0.18 //x=45.35 //y=1.555 //x2=45.235 //y2=1.555
r1167 (  305 395 ) resistor r=11.4558 //w=0.217 //l=0.115 //layer=ply \
 //thickness=0.18 //x=45.565 //y=1.555 //x2=45.68 //y2=1.555
r1168 (  304 387 ) resistor r=5.52526 //w=0.168 //l=0.115 //layer=ply \
 //thickness=0.18 //x=45.35 //y=0.935 //x2=45.235 //y2=0.935
r1169 (  303 394 ) resistor r=5.52526 //w=0.168 //l=0.115 //layer=ply \
 //thickness=0.18 //x=45.565 //y=0.935 //x2=45.68 //y2=0.935
r1170 (  303 304 ) resistor r=110.245 //w=0.094 //l=0.215 //layer=ply \
 //thickness=0.18 //x=45.565 //y=0.935 //x2=45.35 //y2=0.935
r1171 (  302 388 ) resistor r=45.1352 //w=0.168 //l=0.173853 //layer=ply \
 //thickness=0.18 //x=45.195 //y=1.4 //x2=45.235 //y2=1.555
r1172 (  301 387 ) resistor r=45.1352 //w=0.168 //l=0.173853 //layer=ply \
 //thickness=0.18 //x=45.195 //y=1.09 //x2=45.235 //y2=0.935
r1173 (  301 302 ) resistor r=158.957 //w=0.094 //l=0.31 //layer=ply \
 //thickness=0.18 //x=45.195 //y=1.09 //x2=45.195 //y2=1.4
r1174 (  300 386 ) resistor r=45.1352 //w=0.168 //l=0.173853 //layer=ply \
 //thickness=0.18 //x=35.835 //y=1.43 //x2=35.795 //y2=1.585
r1175 (  299 385 ) resistor r=45.1352 //w=0.168 //l=0.173853 //layer=ply \
 //thickness=0.18 //x=35.835 //y=1.085 //x2=35.795 //y2=0.93
r1176 (  299 300 ) resistor r=176.904 //w=0.094 //l=0.345 //layer=ply \
 //thickness=0.18 //x=35.835 //y=1.085 //x2=35.835 //y2=1.43
r1177 (  294 384 ) resistor r=10.701 //w=0.21 //l=0.115 //layer=ply \
 //thickness=0.18 //x=35.46 //y=1.585 //x2=35.345 //y2=1.585
r1178 (  293 386 ) resistor r=5.52526 //w=0.168 //l=0.115 //layer=ply \
 //thickness=0.18 //x=35.68 //y=1.585 //x2=35.795 //y2=1.585
r1179 (  292 383 ) resistor r=5.52526 //w=0.168 //l=0.115 //layer=ply \
 //thickness=0.18 //x=35.46 //y=0.93 //x2=35.345 //y2=0.93
r1180 (  291 385 ) resistor r=5.52526 //w=0.168 //l=0.115 //layer=ply \
 //thickness=0.18 //x=35.68 //y=0.93 //x2=35.795 //y2=0.93
r1181 (  291 292 ) resistor r=112.809 //w=0.094 //l=0.22 //layer=ply \
 //thickness=0.18 //x=35.68 //y=0.93 //x2=35.46 //y2=0.93
r1182 (  290 381 ) resistor r=16.5046 //w=0.27 //l=0.135 //layer=ply \
 //thickness=0.18 //x=35.435 //y=4.97 //x2=35.3 //y2=4.97
r1183 (  289 296 ) resistor r=26.9307 //w=0.15 //l=0.106066 //layer=ply \
 //thickness=0.18 //x=35.675 //y=4.97 //x2=35.75 //y2=5.045
r1184 (  289 290 ) resistor r=123.064 //w=0.094 //l=0.24 //layer=ply \
 //thickness=0.18 //x=35.675 //y=4.97 //x2=35.435 //y2=4.97
r1185 (  284 384 ) resistor r=39.5823 //w=0.21 //l=0.173853 //layer=ply \
 //thickness=0.18 //x=35.305 //y=1.74 //x2=35.345 //y2=1.585
r1186 (  284 376 ) resistor r=182.032 //w=0.094 //l=0.355 //layer=ply \
 //thickness=0.18 //x=35.305 //y=1.74 //x2=35.305 //y2=2.095
r1187 (  283 384 ) resistor r=39.5823 //w=0.21 //l=0.173853 //layer=ply \
 //thickness=0.18 //x=35.305 //y=1.43 //x2=35.345 //y2=1.585
r1188 (  282 383 ) resistor r=45.1352 //w=0.168 //l=0.173853 //layer=ply \
 //thickness=0.18 //x=35.305 //y=1.085 //x2=35.345 //y2=0.93
r1189 (  282 283 ) resistor r=176.904 //w=0.094 //l=0.345 //layer=ply \
 //thickness=0.18 //x=35.305 //y=1.085 //x2=35.305 //y2=1.43
r1190 (  278 368 ) resistor r=16.5046 //w=0.27 //l=0.135 //layer=ply \
 //thickness=0.18 //x=24.305 //y=4.97 //x2=24.17 //y2=4.97
r1191 (  277 279 ) resistor r=26.9307 //w=0.15 //l=0.106066 //layer=ply \
 //thickness=0.18 //x=24.505 //y=4.97 //x2=24.58 //y2=5.045
r1192 (  277 278 ) resistor r=102.553 //w=0.094 //l=0.2 //layer=ply \
 //thickness=0.18 //x=24.505 //y=4.97 //x2=24.305 //y2=4.97
r1193 (  276 373 ) resistor r=38.6777 //w=0.284 //l=0.198997 //layer=ply \
 //thickness=0.18 //x=24.26 //y=2.095 //x2=24.185 //y2=2.26
r1194 (  275 371 ) resistor r=21.2976 //w=0.217 //l=0.0928709 //layer=ply \
 //thickness=0.18 //x=24.26 //y=1.63 //x2=24.22 //y2=1.555
r1195 (  275 276 ) resistor r=238.436 //w=0.094 //l=0.465 //layer=ply \
 //thickness=0.18 //x=24.26 //y=1.63 //x2=24.26 //y2=2.095
r1196 (  274 371 ) resistor r=39.0671 //w=0.217 //l=0.173853 //layer=ply \
 //thickness=0.18 //x=24.26 //y=1.4 //x2=24.22 //y2=1.555
r1197 (  273 370 ) resistor r=45.1352 //w=0.168 //l=0.173853 //layer=ply \
 //thickness=0.18 //x=24.26 //y=1.09 //x2=24.22 //y2=0.935
r1198 (  273 274 ) resistor r=158.957 //w=0.094 //l=0.31 //layer=ply \
 //thickness=0.18 //x=24.26 //y=1.09 //x2=24.26 //y2=1.4
r1199 (  268 364 ) resistor r=5.52526 //w=0.168 //l=0.115 //layer=ply \
 //thickness=0.18 //x=23.89 //y=1.555 //x2=23.775 //y2=1.555
r1200 (  267 371 ) resistor r=11.4558 //w=0.217 //l=0.115 //layer=ply \
 //thickness=0.18 //x=24.105 //y=1.555 //x2=24.22 //y2=1.555
r1201 (  266 363 ) resistor r=5.52526 //w=0.168 //l=0.115 //layer=ply \
 //thickness=0.18 //x=23.89 //y=0.935 //x2=23.775 //y2=0.935
r1202 (  265 370 ) resistor r=5.52526 //w=0.168 //l=0.115 //layer=ply \
 //thickness=0.18 //x=24.105 //y=0.935 //x2=24.22 //y2=0.935
r1203 (  265 266 ) resistor r=110.245 //w=0.094 //l=0.215 //layer=ply \
 //thickness=0.18 //x=24.105 //y=0.935 //x2=23.89 //y2=0.935
r1204 (  264 364 ) resistor r=45.1352 //w=0.168 //l=0.173853 //layer=ply \
 //thickness=0.18 //x=23.735 //y=1.4 //x2=23.775 //y2=1.555
r1205 (  263 363 ) resistor r=45.1352 //w=0.168 //l=0.173853 //layer=ply \
 //thickness=0.18 //x=23.735 //y=1.09 //x2=23.775 //y2=0.935
r1206 (  263 264 ) resistor r=158.957 //w=0.094 //l=0.31 //layer=ply \
 //thickness=0.18 //x=23.735 //y=1.09 //x2=23.735 //y2=1.4
r1207 (  262 362 ) resistor r=45.1352 //w=0.168 //l=0.173853 //layer=ply \
 //thickness=0.18 //x=14.375 //y=1.43 //x2=14.335 //y2=1.585
r1208 (  261 361 ) resistor r=45.1352 //w=0.168 //l=0.173853 //layer=ply \
 //thickness=0.18 //x=14.375 //y=1.085 //x2=14.335 //y2=0.93
r1209 (  261 262 ) resistor r=176.904 //w=0.094 //l=0.345 //layer=ply \
 //thickness=0.18 //x=14.375 //y=1.085 //x2=14.375 //y2=1.43
r1210 (  256 360 ) resistor r=10.701 //w=0.21 //l=0.115 //layer=ply \
 //thickness=0.18 //x=14 //y=1.585 //x2=13.885 //y2=1.585
r1211 (  255 362 ) resistor r=5.52526 //w=0.168 //l=0.115 //layer=ply \
 //thickness=0.18 //x=14.22 //y=1.585 //x2=14.335 //y2=1.585
r1212 (  254 359 ) resistor r=5.52526 //w=0.168 //l=0.115 //layer=ply \
 //thickness=0.18 //x=14 //y=0.93 //x2=13.885 //y2=0.93
r1213 (  253 361 ) resistor r=5.52526 //w=0.168 //l=0.115 //layer=ply \
 //thickness=0.18 //x=14.22 //y=0.93 //x2=14.335 //y2=0.93
r1214 (  253 254 ) resistor r=112.809 //w=0.094 //l=0.22 //layer=ply \
 //thickness=0.18 //x=14.22 //y=0.93 //x2=14 //y2=0.93
r1215 (  252 357 ) resistor r=16.5046 //w=0.27 //l=0.135 //layer=ply \
 //thickness=0.18 //x=13.975 //y=4.97 //x2=13.84 //y2=4.97
r1216 (  251 258 ) resistor r=26.9307 //w=0.15 //l=0.106066 //layer=ply \
 //thickness=0.18 //x=14.215 //y=4.97 //x2=14.29 //y2=5.045
r1217 (  251 252 ) resistor r=123.064 //w=0.094 //l=0.24 //layer=ply \
 //thickness=0.18 //x=14.215 //y=4.97 //x2=13.975 //y2=4.97
r1218 (  246 360 ) resistor r=39.5823 //w=0.21 //l=0.173853 //layer=ply \
 //thickness=0.18 //x=13.845 //y=1.74 //x2=13.885 //y2=1.585
r1219 (  246 352 ) resistor r=182.032 //w=0.094 //l=0.355 //layer=ply \
 //thickness=0.18 //x=13.845 //y=1.74 //x2=13.845 //y2=2.095
r1220 (  245 360 ) resistor r=39.5823 //w=0.21 //l=0.173853 //layer=ply \
 //thickness=0.18 //x=13.845 //y=1.43 //x2=13.885 //y2=1.585
r1221 (  244 359 ) resistor r=45.1352 //w=0.168 //l=0.173853 //layer=ply \
 //thickness=0.18 //x=13.845 //y=1.085 //x2=13.885 //y2=0.93
r1222 (  244 245 ) resistor r=176.904 //w=0.094 //l=0.345 //layer=ply \
 //thickness=0.18 //x=13.845 //y=1.085 //x2=13.845 //y2=1.43
r1223 (  240 344 ) resistor r=16.5046 //w=0.27 //l=0.135 //layer=ply \
 //thickness=0.18 //x=2.845 //y=4.97 //x2=2.71 //y2=4.97
r1224 (  239 241 ) resistor r=26.9307 //w=0.15 //l=0.106066 //layer=ply \
 //thickness=0.18 //x=3.045 //y=4.97 //x2=3.12 //y2=5.045
r1225 (  239 240 ) resistor r=102.553 //w=0.094 //l=0.2 //layer=ply \
 //thickness=0.18 //x=3.045 //y=4.97 //x2=2.845 //y2=4.97
r1226 (  238 349 ) resistor r=38.6777 //w=0.284 //l=0.198997 //layer=ply \
 //thickness=0.18 //x=2.8 //y=2.095 //x2=2.725 //y2=2.26
r1227 (  237 347 ) resistor r=21.2976 //w=0.217 //l=0.0928709 //layer=ply \
 //thickness=0.18 //x=2.8 //y=1.63 //x2=2.76 //y2=1.555
r1228 (  237 238 ) resistor r=238.436 //w=0.094 //l=0.465 //layer=ply \
 //thickness=0.18 //x=2.8 //y=1.63 //x2=2.8 //y2=2.095
r1229 (  236 347 ) resistor r=39.0671 //w=0.217 //l=0.173853 //layer=ply \
 //thickness=0.18 //x=2.8 //y=1.4 //x2=2.76 //y2=1.555
r1230 (  235 346 ) resistor r=45.1352 //w=0.168 //l=0.173853 //layer=ply \
 //thickness=0.18 //x=2.8 //y=1.09 //x2=2.76 //y2=0.935
r1231 (  235 236 ) resistor r=158.957 //w=0.094 //l=0.31 //layer=ply \
 //thickness=0.18 //x=2.8 //y=1.09 //x2=2.8 //y2=1.4
r1232 (  230 340 ) resistor r=5.52526 //w=0.168 //l=0.115 //layer=ply \
 //thickness=0.18 //x=2.43 //y=1.555 //x2=2.315 //y2=1.555
r1233 (  229 347 ) resistor r=11.4558 //w=0.217 //l=0.115 //layer=ply \
 //thickness=0.18 //x=2.645 //y=1.555 //x2=2.76 //y2=1.555
r1234 (  228 339 ) resistor r=5.52526 //w=0.168 //l=0.115 //layer=ply \
 //thickness=0.18 //x=2.43 //y=0.935 //x2=2.315 //y2=0.935
r1235 (  227 346 ) resistor r=5.52526 //w=0.168 //l=0.115 //layer=ply \
 //thickness=0.18 //x=2.645 //y=0.935 //x2=2.76 //y2=0.935
r1236 (  227 228 ) resistor r=110.245 //w=0.094 //l=0.215 //layer=ply \
 //thickness=0.18 //x=2.645 //y=0.935 //x2=2.43 //y2=0.935
r1237 (  226 340 ) resistor r=45.1352 //w=0.168 //l=0.173853 //layer=ply \
 //thickness=0.18 //x=2.275 //y=1.4 //x2=2.315 //y2=1.555
r1238 (  225 339 ) resistor r=45.1352 //w=0.168 //l=0.173853 //layer=ply \
 //thickness=0.18 //x=2.275 //y=1.09 //x2=2.315 //y2=0.935
r1239 (  225 226 ) resistor r=158.957 //w=0.094 //l=0.31 //layer=ply \
 //thickness=0.18 //x=2.275 //y=1.09 //x2=2.275 //y2=1.4
r1240 (  224 334 ) resistor r=592.245 //w=0.094 //l=1.155 //layer=ply \
 //thickness=0.18 //x=57.21 //y=6.2 //x2=57.21 //y2=5.045
r1241 (  223 406 ) resistor r=592.245 //w=0.094 //l=1.155 //layer=ply \
 //thickness=0.18 //x=56.77 //y=6.2 //x2=56.77 //y2=5.045
r1242 (  222 317 ) resistor r=592.245 //w=0.094 //l=1.155 //layer=ply \
 //thickness=0.18 //x=46.04 //y=6.2 //x2=46.04 //y2=5.045
r1243 (  221 393 ) resistor r=592.245 //w=0.094 //l=1.155 //layer=ply \
 //thickness=0.18 //x=45.6 //y=6.2 //x2=45.6 //y2=5.045
r1244 (  220 296 ) resistor r=592.245 //w=0.094 //l=1.155 //layer=ply \
 //thickness=0.18 //x=35.75 //y=6.2 //x2=35.75 //y2=5.045
r1245 (  219 382 ) resistor r=592.245 //w=0.094 //l=1.155 //layer=ply \
 //thickness=0.18 //x=35.31 //y=6.2 //x2=35.31 //y2=5.045
r1246 (  218 279 ) resistor r=592.245 //w=0.094 //l=1.155 //layer=ply \
 //thickness=0.18 //x=24.58 //y=6.2 //x2=24.58 //y2=5.045
r1247 (  217 369 ) resistor r=592.245 //w=0.094 //l=1.155 //layer=ply \
 //thickness=0.18 //x=24.14 //y=6.2 //x2=24.14 //y2=5.045
r1248 (  216 258 ) resistor r=592.245 //w=0.094 //l=1.155 //layer=ply \
 //thickness=0.18 //x=14.29 //y=6.2 //x2=14.29 //y2=5.045
r1249 (  215 358 ) resistor r=592.245 //w=0.094 //l=1.155 //layer=ply \
 //thickness=0.18 //x=13.85 //y=6.2 //x2=13.85 //y2=5.045
r1250 (  214 241 ) resistor r=592.245 //w=0.094 //l=1.155 //layer=ply \
 //thickness=0.18 //x=3.12 //y=6.2 //x2=3.12 //y2=5.045
r1251 (  213 345 ) resistor r=592.245 //w=0.094 //l=1.155 //layer=ply \
 //thickness=0.18 //x=2.68 //y=6.2 //x2=2.68 //y2=5.045
r1252 (  212 331 ) resistor r=56.4043 //w=0.094 //l=0.11 //layer=ply \
 //thickness=0.18 //x=57.03 //y=1.585 //x2=57.14 //y2=1.585
r1253 (  212 332 ) resistor r=56.4043 //w=0.094 //l=0.11 //layer=ply \
 //thickness=0.18 //x=57.03 //y=1.585 //x2=56.92 //y2=1.585
r1254 (  211 305 ) resistor r=55.3787 //w=0.094 //l=0.108 //layer=ply \
 //thickness=0.18 //x=45.457 //y=1.555 //x2=45.565 //y2=1.555
r1255 (  211 306 ) resistor r=54.866 //w=0.094 //l=0.107 //layer=ply \
 //thickness=0.18 //x=45.457 //y=1.555 //x2=45.35 //y2=1.555
r1256 (  210 293 ) resistor r=56.4043 //w=0.094 //l=0.11 //layer=ply \
 //thickness=0.18 //x=35.57 //y=1.585 //x2=35.68 //y2=1.585
r1257 (  210 294 ) resistor r=56.4043 //w=0.094 //l=0.11 //layer=ply \
 //thickness=0.18 //x=35.57 //y=1.585 //x2=35.46 //y2=1.585
r1258 (  209 267 ) resistor r=55.3787 //w=0.094 //l=0.108 //layer=ply \
 //thickness=0.18 //x=23.997 //y=1.555 //x2=24.105 //y2=1.555
r1259 (  209 268 ) resistor r=54.866 //w=0.094 //l=0.107 //layer=ply \
 //thickness=0.18 //x=23.997 //y=1.555 //x2=23.89 //y2=1.555
r1260 (  208 255 ) resistor r=56.4043 //w=0.094 //l=0.11 //layer=ply \
 //thickness=0.18 //x=14.11 //y=1.585 //x2=14.22 //y2=1.585
r1261 (  208 256 ) resistor r=56.4043 //w=0.094 //l=0.11 //layer=ply \
 //thickness=0.18 //x=14.11 //y=1.585 //x2=14 //y2=1.585
r1262 (  207 229 ) resistor r=55.3787 //w=0.094 //l=0.108 //layer=ply \
 //thickness=0.18 //x=2.537 //y=1.555 //x2=2.645 //y2=1.555
r1263 (  207 230 ) resistor r=54.866 //w=0.094 //l=0.107 //layer=ply \
 //thickness=0.18 //x=2.537 //y=1.555 //x2=2.43 //y2=1.555
r1264 (  203 403 ) resistor r=152 //w=0.17 //l=0.17 //layer=licon //count=1 \
 //x=56.76 //y=4.88 //x2=56.76 //y2=4.88
r1265 (  198 399 ) resistor r=152 //w=0.17 //l=0.17 //layer=licon //count=1 \
 //x=56.73 //y=2.26 //x2=56.73 //y2=2.26
r1266 (  193 390 ) resistor r=152 //w=0.17 //l=0.17 //layer=licon //count=1 \
 //x=45.63 //y=4.88 //x2=45.63 //y2=4.88
r1267 (  188 397 ) resistor r=152 //w=0.17 //l=0.17 //layer=licon //count=1 \
 //x=45.63 //y=2.26 //x2=45.63 //y2=2.26
r1268 (  183 379 ) resistor r=152 //w=0.17 //l=0.17 //layer=licon //count=1 \
 //x=35.3 //y=4.88 //x2=35.3 //y2=4.88
r1269 (  178 375 ) resistor r=152 //w=0.17 //l=0.17 //layer=licon //count=1 \
 //x=35.27 //y=2.26 //x2=35.27 //y2=2.26
r1270 (  173 366 ) resistor r=152 //w=0.17 //l=0.17 //layer=licon //count=1 \
 //x=24.17 //y=4.88 //x2=24.17 //y2=4.88
r1271 (  168 373 ) resistor r=152 //w=0.17 //l=0.17 //layer=licon //count=1 \
 //x=24.17 //y=2.26 //x2=24.17 //y2=2.26
r1272 (  163 355 ) resistor r=152 //w=0.17 //l=0.17 //layer=licon //count=1 \
 //x=13.84 //y=4.88 //x2=13.84 //y2=4.88
r1273 (  158 351 ) resistor r=152 //w=0.17 //l=0.17 //layer=licon //count=1 \
 //x=13.81 //y=2.26 //x2=13.81 //y2=2.26
r1274 (  153 342 ) resistor r=152 //w=0.17 //l=0.17 //layer=licon //count=1 \
 //x=2.71 //y=4.88 //x2=2.71 //y2=4.88
r1275 (  148 349 ) resistor r=152 //w=0.17 //l=0.17 //layer=licon //count=1 \
 //x=2.71 //y=2.26 //x2=2.71 //y2=2.26
r1276 (  135 137 ) resistor r=0.110922 //w=0.293 //l=0.26 //layer=m2 \
 //thickness=0.36 //x=2.71 //y=4.62 //x2=2.71 //y2=4.88
r1277 (  133 146 ) resistor r=1.98202 //w=0.198 //l=3.16733 //layer=m2 \
 //thickness=0.36 //x=53.62 //y=4.64 //x2=56.755 //y2=4.705
r1278 (  133 134 ) resistor r=0.329198 //w=0.131 //l=0.345 //layer=m2 \
 //thickness=0.36 //x=53.62 //y=4.64 //x2=53.275 //y2=4.64
r1279 (  129 134 ) resistor r=5.62132 //w=0.17 //l=7.65 //layer=m2 \
 //thickness=0.36 //x=45.63 //y=4.63 //x2=53.275 //y2=4.64
r1280 (  129 131 ) resistor r=0.077847 //w=0.281 //l=0.175 //layer=m2 \
 //thickness=0.36 //x=45.63 //y=4.705 //x2=45.63 //y2=4.88
r1281 (  127 129 ) resistor r=0.654412 //w=0.17 //l=0.894986 //layer=m2 \
 //thickness=0.36 //x=44.74 //y=4.64 //x2=45.63 //y2=4.63
r1282 (  127 128 ) resistor r=0.329198 //w=0.131 //l=0.345 //layer=m2 \
 //thickness=0.36 //x=44.74 //y=4.64 //x2=44.395 //y2=4.64
r1283 (  125 128 ) resistor r=0.1875 //w=0.17 //l=0.264811 //layer=m2 \
 //thickness=0.36 //x=44.14 //y=4.62 //x2=44.395 //y2=4.64
r1284 (  125 126 ) resistor r=1.74141 //w=0.131 //l=1.825 //layer=m2 \
 //thickness=0.36 //x=44.14 //y=4.62 //x2=42.315 //y2=4.62
r1285 (  123 126 ) resistor r=0.125 //w=0.17 //l=0.177341 //layer=m2 \
 //thickness=0.36 //x=42.145 //y=4.635 //x2=42.315 //y2=4.62
r1286 (  123 124 ) resistor r=0.329198 //w=0.131 //l=0.345 //layer=m2 \
 //thickness=0.36 //x=42.145 //y=4.635 //x2=41.8 //y2=4.635
r1287 (  121 124 ) resistor r=0.1875 //w=0.17 //l=0.262393 //layer=m2 \
 //thickness=0.36 //x=41.545 //y=4.62 //x2=41.8 //y2=4.635
r1288 (  121 122 ) resistor r=4.92366 //w=0.131 //l=5.16 //layer=m2 \
 //thickness=0.36 //x=41.545 //y=4.62 //x2=36.385 //y2=4.62
r1289 (  120 143 ) resistor r=0.365854 //w=0.198 //l=0.601872 //layer=m2 \
 //thickness=0.36 //x=35.87 //y=4.65 //x2=35.295 //y2=4.705
r1290 (  119 122 ) resistor r=0.125 //w=0.17 //l=0.184391 //layer=m2 \
 //thickness=0.36 //x=36.215 //y=4.65 //x2=36.385 //y2=4.62
r1291 (  119 120 ) resistor r=0.329198 //w=0.131 //l=0.345 //layer=m2 \
 //thickness=0.36 //x=36.215 //y=4.65 //x2=35.87 //y2=4.65
r1292 (  117 143 ) resistor r=1.98202 //w=0.198 //l=3.16733 //layer=m2 \
 //thickness=0.36 //x=32.16 //y=4.64 //x2=35.295 //y2=4.705
r1293 (  117 118 ) resistor r=0.329198 //w=0.131 //l=0.345 //layer=m2 \
 //thickness=0.36 //x=32.16 //y=4.64 //x2=31.815 //y2=4.64
r1294 (  113 118 ) resistor r=5.62132 //w=0.17 //l=7.65 //layer=m2 \
 //thickness=0.36 //x=24.17 //y=4.63 //x2=31.815 //y2=4.64
r1295 (  113 115 ) resistor r=0.077847 //w=0.281 //l=0.175 //layer=m2 \
 //thickness=0.36 //x=24.17 //y=4.705 //x2=24.17 //y2=4.88
r1296 (  111 113 ) resistor r=0.654412 //w=0.17 //l=0.894986 //layer=m2 \
 //thickness=0.36 //x=23.28 //y=4.64 //x2=24.17 //y2=4.63
r1297 (  111 112 ) resistor r=0.329198 //w=0.131 //l=0.345 //layer=m2 \
 //thickness=0.36 //x=23.28 //y=4.64 //x2=22.935 //y2=4.64
r1298 (  109 112 ) resistor r=0.1875 //w=0.17 //l=0.264811 //layer=m2 \
 //thickness=0.36 //x=22.68 //y=4.62 //x2=22.935 //y2=4.64
r1299 (  109 110 ) resistor r=1.74141 //w=0.131 //l=1.825 //layer=m2 \
 //thickness=0.36 //x=22.68 //y=4.62 //x2=20.855 //y2=4.62
r1300 (  107 110 ) resistor r=0.125 //w=0.17 //l=0.177341 //layer=m2 \
 //thickness=0.36 //x=20.685 //y=4.635 //x2=20.855 //y2=4.62
r1301 (  107 108 ) resistor r=0.329198 //w=0.131 //l=0.345 //layer=m2 \
 //thickness=0.36 //x=20.685 //y=4.635 //x2=20.34 //y2=4.635
r1302 (  106 140 ) resistor r=0.0821511 //w=0.131 //l=0.085 //layer=m2 \
 //thickness=0.36 //x=17.32 //y=4.62 //x2=17.235 //y2=4.62
r1303 (  105 108 ) resistor r=0.1875 //w=0.17 //l=0.262393 //layer=m2 \
 //thickness=0.36 //x=20.085 //y=4.62 //x2=20.34 //y2=4.635
r1304 (  105 106 ) resistor r=2.63836 //w=0.131 //l=2.765 //layer=m2 \
 //thickness=0.36 //x=20.085 //y=4.62 //x2=17.32 //y2=4.62
r1305 (  104 140 ) resistor r=2.42996 //w=0.116 //l=2.255 //layer=m2 \
 //thickness=0.36 //x=14.98 //y=4.622 //x2=17.235 //y2=4.622
r1306 (  102 139 ) resistor r=0.361358 //w=0.197 //l=0.590661 //layer=m2 \
 //thickness=0.36 //x=14.395 //y=4.642 //x2=13.835 //y2=4.705
r1307 (  101 104 ) resistor r=0.170597 //w=0.159 //l=0.22678 //layer=m2 \
 //thickness=0.36 //x=14.763 //y=4.642 //x2=14.98 //y2=4.622
r1308 (  101 102 ) resistor r=0.396552 //w=0.116 //l=0.368 //layer=m2 \
 //thickness=0.36 //x=14.763 //y=4.642 //x2=14.395 //y2=4.642
r1309 (  99 139 ) resistor r=1.99191 //w=0.197 //l=3.16733 //layer=m2 \
 //thickness=0.36 //x=10.7 //y=4.64 //x2=13.835 //y2=4.705
r1310 (  99 100 ) resistor r=0.329198 //w=0.131 //l=0.345 //layer=m2 \
 //thickness=0.36 //x=10.7 //y=4.64 //x2=10.355 //y2=4.64
r1311 (  98 135 ) resistor r=0.040188 //w=0.293 //l=0.16 //layer=m2 \
 //thickness=0.36 //x=2.87 //y=4.62 //x2=2.71 //y2=4.62
r1312 (  97 100 ) resistor r=0.1875 //w=0.17 //l=0.264811 //layer=m2 \
 //thickness=0.36 //x=10.1 //y=4.62 //x2=10.355 //y2=4.64
r1313 (  97 98 ) resistor r=6.89885 //w=0.131 //l=7.23 //layer=m2 \
 //thickness=0.36 //x=10.1 //y=4.62 //x2=2.87 //y2=4.62
r1314 (  94 198 ) resistor r=9.3 //w=0.17 //l=0.17 //layer=mcon //count=1 \
 //x=56.73 //y=2.26 //x2=56.73 //y2=2.26
r1315 (  94 96 ) resistor r=0.0936408 //w=0.196 //l=0.125 //layer=m1 \
 //thickness=0.36 //x=56.732 //y=2.26 //x2=56.732 //y2=2.385
r1316 (  91 203 ) resistor r=9.3 //w=0.17 //l=0.17 //layer=mcon //count=1 \
 //x=56.76 //y=4.88 //x2=56.76 //y2=4.88
r1317 (  88 146 ) resistor r=4.5 //w=0.15 //l=0.15 //layer=via1 //count=1 \
 //x=56.755 //y=4.865 //x2=56.755 //y2=4.865
r1318 (  88 91 ) resistor r=0.0066726 //w=0.281 //l=0.015 //layer=m1 \
 //thickness=0.36 //x=56.755 //y=4.865 //x2=56.755 //y2=4.88
r1319 (  88 89 ) resistor r=0.10734 //w=0.281 //l=0.16 //layer=m1 \
 //thickness=0.36 //x=56.755 //y=4.865 //x2=56.755 //y2=4.705
r1320 (  86 188 ) resistor r=9.3 //w=0.17 //l=0.17 //layer=mcon //count=1 \
 //x=45.63 //y=2.26 //x2=45.63 //y2=2.26
r1321 (  82 193 ) resistor r=9.3 //w=0.17 //l=0.17 //layer=mcon //count=1 \
 //x=45.63 //y=4.88 //x2=45.63 //y2=4.88
r1322 (  82 131 ) resistor r=4.5 //w=0.15 //l=0.15 //layer=via1 //count=1 \
 //x=45.63 //y=4.88 //x2=45.63 //y2=4.88
r1323 (  78 178 ) resistor r=9.3 //w=0.17 //l=0.17 //layer=mcon //count=1 \
 //x=35.27 //y=2.26 //x2=35.27 //y2=2.26
r1324 (  78 80 ) resistor r=0.0936408 //w=0.196 //l=0.125 //layer=m1 \
 //thickness=0.36 //x=35.272 //y=2.26 //x2=35.272 //y2=2.385
r1325 (  75 183 ) resistor r=9.3 //w=0.17 //l=0.17 //layer=mcon //count=1 \
 //x=35.3 //y=4.88 //x2=35.3 //y2=4.88
r1326 (  72 143 ) resistor r=4.5 //w=0.15 //l=0.15 //layer=via1 //count=1 \
 //x=35.295 //y=4.865 //x2=35.295 //y2=4.865
r1327 (  72 75 ) resistor r=0.0066726 //w=0.281 //l=0.015 //layer=m1 \
 //thickness=0.36 //x=35.295 //y=4.865 //x2=35.295 //y2=4.88
r1328 (  72 73 ) resistor r=0.10734 //w=0.281 //l=0.16 //layer=m1 \
 //thickness=0.36 //x=35.295 //y=4.865 //x2=35.295 //y2=4.705
r1329 (  70 168 ) resistor r=9.3 //w=0.17 //l=0.17 //layer=mcon //count=1 \
 //x=24.17 //y=2.26 //x2=24.17 //y2=2.26
r1330 (  66 173 ) resistor r=9.3 //w=0.17 //l=0.17 //layer=mcon //count=1 \
 //x=24.17 //y=4.88 //x2=24.17 //y2=4.88
r1331 (  66 115 ) resistor r=4.5 //w=0.15 //l=0.15 //layer=via1 //count=1 \
 //x=24.17 //y=4.88 //x2=24.17 //y2=4.88
r1332 (  62 158 ) resistor r=9.3 //w=0.17 //l=0.17 //layer=mcon //count=1 \
 //x=13.81 //y=2.26 //x2=13.81 //y2=2.26
r1333 (  62 64 ) resistor r=0.0936408 //w=0.196 //l=0.125 //layer=m1 \
 //thickness=0.36 //x=13.812 //y=2.26 //x2=13.812 //y2=2.385
r1334 (  59 163 ) resistor r=9.3 //w=0.17 //l=0.17 //layer=mcon //count=1 \
 //x=13.84 //y=4.88 //x2=13.84 //y2=4.88
r1335 (  56 139 ) resistor r=4.5 //w=0.15 //l=0.15 //layer=via1 //count=1 \
 //x=13.835 //y=4.865 //x2=13.835 //y2=4.865
r1336 (  56 59 ) resistor r=0.0066726 //w=0.281 //l=0.015 //layer=m1 \
 //thickness=0.36 //x=13.835 //y=4.865 //x2=13.835 //y2=4.88
r1337 (  56 57 ) resistor r=0.10734 //w=0.281 //l=0.16 //layer=m1 \
 //thickness=0.36 //x=13.835 //y=4.865 //x2=13.835 //y2=4.705
r1338 (  54 148 ) resistor r=9.3 //w=0.17 //l=0.17 //layer=mcon //count=1 \
 //x=2.71 //y=2.26 //x2=2.71 //y2=2.26
r1339 (  50 153 ) resistor r=9.3 //w=0.17 //l=0.17 //layer=mcon //count=1 \
 //x=2.71 //y=4.88 //x2=2.71 //y2=4.88
r1340 (  50 137 ) resistor r=4.5 //w=0.15 //l=0.15 //layer=via1 //count=1 \
 //x=2.71 //y=4.88 //x2=2.71 //y2=4.88
r1341 (  41 82 ) resistor r=0.10734 //w=0.281 //l=0.16 //layer=m1 \
 //thickness=0.36 //x=45.63 //y=4.72 //x2=45.63 //y2=4.88
r1342 (  40 86 ) resistor r=0.0715665 //w=0.226 //l=0.115996 //layer=m1 \
 //thickness=0.36 //x=45.63 //y=2.375 //x2=45.632 //y2=2.26
r1343 (  32 66 ) resistor r=0.10734 //w=0.281 //l=0.16 //layer=m1 \
 //thickness=0.36 //x=24.17 //y=4.72 //x2=24.17 //y2=4.88
r1344 (  31 70 ) resistor r=0.0715665 //w=0.226 //l=0.115996 //layer=m1 \
 //thickness=0.36 //x=24.17 //y=2.375 //x2=24.172 //y2=2.26
r1345 (  20 50 ) resistor r=0.10734 //w=0.281 //l=0.16 //layer=m1 \
 //thickness=0.36 //x=2.71 //y=4.72 //x2=2.71 //y2=4.88
r1346 (  19 54 ) resistor r=0.0715665 //w=0.226 //l=0.115996 //layer=m1 \
 //thickness=0.36 //x=2.71 //y=2.375 //x2=2.712 //y2=2.26
r1347 (  18 89 ) resistor r=0.0811069 //w=0.131 //l=0.085 //layer=m1 \
 //thickness=0.36 //x=56.73 //y=4.62 //x2=56.73 //y2=4.705
r1348 (  17 18 ) resistor r=1.05916 //w=0.131 //l=1.11 //layer=m1 \
 //thickness=0.36 //x=56.73 //y=3.51 //x2=56.73 //y2=4.62
r1349 (  17 96 ) resistor r=1.07347 //w=0.131 //l=1.125 //layer=m1 \
 //thickness=0.36 //x=56.73 //y=3.51 //x2=56.73 //y2=2.385
r1350 (  16 41 ) resistor r=0.0954198 //w=0.131 //l=0.1 //layer=m1 \
 //thickness=0.36 //x=45.63 //y=4.62 //x2=45.63 //y2=4.72
r1351 (  15 16 ) resistor r=0.706107 //w=0.131 //l=0.74 //layer=m1 \
 //thickness=0.36 //x=45.63 //y=3.88 //x2=45.63 //y2=4.62
r1352 (  14 15 ) resistor r=0.353053 //w=0.131 //l=0.37 //layer=m1 \
 //thickness=0.36 //x=45.63 //y=3.51 //x2=45.63 //y2=3.88
r1353 (  14 40 ) resistor r=1.08302 //w=0.131 //l=1.135 //layer=m1 \
 //thickness=0.36 //x=45.63 //y=3.51 //x2=45.63 //y2=2.375
r1354 (  13 73 ) resistor r=0.0811069 //w=0.131 //l=0.085 //layer=m1 \
 //thickness=0.36 //x=35.27 //y=4.62 //x2=35.27 //y2=4.705
r1355 (  12 13 ) resistor r=1.05916 //w=0.131 //l=1.11 //layer=m1 \
 //thickness=0.36 //x=35.27 //y=3.51 //x2=35.27 //y2=4.62
r1356 (  12 80 ) resistor r=1.07347 //w=0.131 //l=1.125 //layer=m1 \
 //thickness=0.36 //x=35.27 //y=3.51 //x2=35.27 //y2=2.385
r1357 (  11 32 ) resistor r=0.0954198 //w=0.131 //l=0.1 //layer=m1 \
 //thickness=0.36 //x=24.17 //y=4.62 //x2=24.17 //y2=4.72
r1358 (  10 11 ) resistor r=0.706107 //w=0.131 //l=0.74 //layer=m1 \
 //thickness=0.36 //x=24.17 //y=3.88 //x2=24.17 //y2=4.62
r1359 (  9 10 ) resistor r=0.353053 //w=0.131 //l=0.37 //layer=m1 \
 //thickness=0.36 //x=24.17 //y=3.51 //x2=24.17 //y2=3.88
r1360 (  9 31 ) resistor r=1.08302 //w=0.131 //l=1.135 //layer=m1 \
 //thickness=0.36 //x=24.17 //y=3.51 //x2=24.17 //y2=2.375
r1361 (  8 57 ) resistor r=0.0811069 //w=0.131 //l=0.085 //layer=m1 \
 //thickness=0.36 //x=13.81 //y=4.62 //x2=13.81 //y2=4.705
r1362 (  7 8 ) resistor r=1.05916 //w=0.131 //l=1.11 //layer=m1 \
 //thickness=0.36 //x=13.81 //y=3.51 //x2=13.81 //y2=4.62
r1363 (  6 7 ) resistor r=0.353053 //w=0.131 //l=0.37 //layer=m1 \
 //thickness=0.36 //x=13.81 //y=3.14 //x2=13.81 //y2=3.51
r1364 (  6 64 ) resistor r=0.72042 //w=0.131 //l=0.755 //layer=m1 \
 //thickness=0.36 //x=13.81 //y=3.14 //x2=13.81 //y2=2.385
r1365 (  5 20 ) resistor r=0.0954198 //w=0.131 //l=0.1 //layer=m1 \
 //thickness=0.36 //x=2.71 //y=4.62 //x2=2.71 //y2=4.72
r1366 (  4 5 ) resistor r=0.706107 //w=0.131 //l=0.74 //layer=m1 \
 //thickness=0.36 //x=2.71 //y=3.88 //x2=2.71 //y2=4.62
r1367 (  3 4 ) resistor r=0.353053 //w=0.131 //l=0.37 //layer=m1 \
 //thickness=0.36 //x=2.71 //y=3.51 //x2=2.71 //y2=3.88
r1368 (  2 3 ) resistor r=0.353053 //w=0.131 //l=0.37 //layer=m1 \
 //thickness=0.36 //x=2.71 //y=3.14 //x2=2.71 //y2=3.51
r1369 (  1 2 ) resistor r=0.353053 //w=0.131 //l=0.37 //layer=m1 \
 //thickness=0.36 //x=2.71 //y=2.77 //x2=2.71 //y2=3.14
r1370 (  1 19 ) resistor r=0.376908 //w=0.131 //l=0.395 //layer=m1 \
 //thickness=0.36 //x=2.71 //y=2.77 //x2=2.71 //y2=2.375
ends PM_TMRDFFQX1\%CLK

subckt PM_TMRDFFQX1\%noxref_15 ( 1 3 6 7 9 10 11 12 14 15 16 18 19 22 23 25 28 \
 31 37 40 43 46 47 50 54 57 58 60 61 62 63 64 66 68 70 72 74 84 92 100 117 126 \
 131 140 144 145 146 147 148 149 150 151 152 153 157 159 162 163 167 168 169 \
 170 174 176 179 180 190 199 202 204 205 206 )
c496 ( 202 0 ) capacitor c=0.00885916f //x=46.805 //y=1.095
c497 ( 199 0 ) capacitor c=0.0645411f //x=59.32 //y=4.88
c498 ( 190 0 ) capacitor c=0.0645923f //x=49.33 //y=4.88
c499 ( 180 0 ) capacitor c=0.0318956f //x=59.655 //y=1.39
c500 ( 179 0 ) capacitor c=0.0186809f //x=59.655 //y=1.045
c501 ( 176 0 ) capacitor c=0.0141821f //x=59.5 //y=1.545
c502 ( 174 0 ) capacitor c=0.0158553f //x=59.5 //y=0.89
c503 ( 170 0 ) capacitor c=0.088055f //x=59.125 //y=2.095
c504 ( 169 0 ) capacitor c=0.0229235f //x=59.125 //y=1.7
c505 ( 168 0 ) capacitor c=0.0234359f //x=59.125 //y=1.39
c506 ( 167 0 ) capacitor c=0.0198759f //x=59.125 //y=1.045
c507 ( 163 0 ) capacitor c=0.0318956f //x=49.665 //y=1.39
c508 ( 162 0 ) capacitor c=0.0186809f //x=49.665 //y=1.045
c509 ( 159 0 ) capacitor c=0.0141821f //x=49.51 //y=1.545
c510 ( 157 0 ) capacitor c=0.0158553f //x=49.51 //y=0.89
c511 ( 153 0 ) capacitor c=0.088055f //x=49.135 //y=2.095
c512 ( 152 0 ) capacitor c=0.0229235f //x=49.135 //y=1.7
c513 ( 151 0 ) capacitor c=0.0234359f //x=49.135 //y=1.39
c514 ( 150 0 ) capacitor c=0.0198759f //x=49.135 //y=1.045
c515 ( 149 0 ) capacitor c=0.110369f //x=59.66 //y=6.2
c516 ( 148 0 ) capacitor c=0.154619f //x=59.22 //y=6.2
c517 ( 147 0 ) capacitor c=0.110369f //x=49.67 //y=6.2
c518 ( 146 0 ) capacitor c=0.154619f //x=49.23 //y=6.2
c519 ( 140 0 ) capacitor c=8.13425e-19 //x=59.32 //y=4.88
c520 ( 131 0 ) capacitor c=7.85889e-19 //x=59.32 //y=2.26
c521 ( 126 0 ) capacitor c=8.13425e-19 //x=49.33 //y=4.88
c522 ( 117 0 ) capacitor c=7.85889e-19 //x=49.33 //y=2.26
c523 ( 100 0 ) capacitor c=0.0293071f //x=46.7 //y=5.56
c524 ( 92 0 ) capacitor c=0.029137f //x=45.82 //y=5.56
c525 ( 84 0 ) capacitor c=0.0277605f //x=44.94 //y=5.56
c526 ( 74 0 ) capacitor c=0.0403878f //x=56.2 //y=3.895
c527 ( 72 0 ) capacitor c=0.0175525f //x=55.6 //y=3.88
c528 ( 70 0 ) capacitor c=0.00418974f //x=54.36 //y=3.895
c529 ( 68 0 ) capacitor c=0.00769994f //x=53.62 //y=3.87
c530 ( 66 0 ) capacitor c=0.005471f //x=52.87 //y=3.89
c531 ( 64 0 ) capacitor c=0.0178779f //x=52.27 //y=3.88
c532 ( 63 0 ) capacitor c=0.0100334f //x=50.675 //y=3.895
c533 ( 62 0 ) capacitor c=0.00477746f //x=51.02 //y=3.895
c534 ( 61 0 ) capacitor c=7.05145e-19 //x=47.64 //y=3.88
c535 ( 60 0 ) capacitor c=0.0193144f //x=49.165 //y=3.88
c536 ( 58 0 ) capacitor c=0.0152615f //x=59.322 //y=4.74
c537 ( 57 0 ) capacitor c=0.00598189f //x=59.32 //y=4.88
c538 ( 54 0 ) capacitor c=0.00463527f //x=59.32 //y=2.26
c539 ( 50 0 ) capacitor c=0.0142994f //x=59.32 //y=3.88
c540 ( 47 0 ) capacitor c=0.0172769f //x=49.332 //y=4.74
c541 ( 46 0 ) capacitor c=0.00598357f //x=49.33 //y=4.88
c542 ( 43 0 ) capacitor c=0.00463527f //x=49.33 //y=2.26
c543 ( 40 0 ) capacitor c=0.0163193f //x=49.325 //y=3.88
c544 ( 37 0 ) capacitor c=0.0170864f //x=47.48 //y=3.88
c545 ( 31 0 ) capacitor c=9.55882e-19 //x=46.7 //y=5.335
c546 ( 28 0 ) capacitor c=0.00753245f //x=45.82 //y=5.335
c547 ( 25 0 ) capacitor c=0.0112819f //x=44.942 //y=5.335
c548 ( 23 0 ) capacitor c=0.0123638f //x=59.32 //y=4.045
c549 ( 22 0 ) capacitor c=0.039459f //x=59.32 //y=3.725
c550 ( 19 0 ) capacitor c=0.0123756f //x=49.33 //y=4.04
c551 ( 18 0 ) capacitor c=0.0335599f //x=49.33 //y=3.72
c552 ( 16 0 ) capacitor c=0.0309857f //x=47.48 //y=5.25
c553 ( 15 0 ) capacitor c=0.0132732f //x=47.48 //y=4.04
c554 ( 14 0 ) capacitor c=0.0475959f //x=47.48 //y=3.72
c555 ( 12 0 ) capacitor c=0.0047266f //x=47.08 //y=1.845
c556 ( 11 0 ) capacitor c=0.01299f //x=47.395 //y=1.845
c557 ( 10 0 ) capacitor c=0.013549f //x=46.995 //y=1.76
c558 ( 9 0 ) capacitor c=0.0111876f //x=46.995 //y=1.305
c559 ( 7 0 ) capacitor c=0.0228253f //x=47.395 //y=5.335
c560 ( 6 0 ) capacitor c=0.00906713f //x=46.7 //y=5.56
c561 ( 3 0 ) capacitor c=0.019596f //x=46.585 //y=5.335
c562 ( 1 0 ) capacitor c=0.014788f //x=45.7 //y=5.335
r563 (  197 199 ) resistor r=20.6867 //w=0.233 //l=0.1 //layer=ply \
 //thickness=0.18 //x=59.22 //y=4.88 //x2=59.32 //y2=4.88
r564 (  188 190 ) resistor r=20.6867 //w=0.233 //l=0.1 //layer=ply \
 //thickness=0.18 //x=49.23 //y=4.88 //x2=49.33 //y2=4.88
r565 (  181 199 ) resistor r=70.3348 //w=0.233 //l=0.414367 //layer=ply \
 //thickness=0.18 //x=59.66 //y=5.045 //x2=59.32 //y2=4.88
r566 (  180 201 ) resistor r=45.1352 //w=0.168 //l=0.173853 //layer=ply \
 //thickness=0.18 //x=59.655 //y=1.39 //x2=59.615 //y2=1.545
r567 (  179 200 ) resistor r=45.1352 //w=0.168 //l=0.173853 //layer=ply \
 //thickness=0.18 //x=59.655 //y=1.045 //x2=59.615 //y2=0.89
r568 (  179 180 ) resistor r=176.904 //w=0.094 //l=0.345 //layer=ply \
 //thickness=0.18 //x=59.655 //y=1.045 //x2=59.655 //y2=1.39
r569 (  177 196 ) resistor r=10.701 //w=0.21 //l=0.115 //layer=ply \
 //thickness=0.18 //x=59.28 //y=1.545 //x2=59.165 //y2=1.545
r570 (  176 201 ) resistor r=5.52526 //w=0.168 //l=0.115 //layer=ply \
 //thickness=0.18 //x=59.5 //y=1.545 //x2=59.615 //y2=1.545
r571 (  175 195 ) resistor r=5.52526 //w=0.168 //l=0.115 //layer=ply \
 //thickness=0.18 //x=59.28 //y=0.89 //x2=59.165 //y2=0.89
r572 (  174 200 ) resistor r=5.52526 //w=0.168 //l=0.115 //layer=ply \
 //thickness=0.18 //x=59.5 //y=0.89 //x2=59.615 //y2=0.89
r573 (  174 175 ) resistor r=112.809 //w=0.094 //l=0.22 //layer=ply \
 //thickness=0.18 //x=59.5 //y=0.89 //x2=59.28 //y2=0.89
r574 (  171 197 ) resistor r=13.0941 //w=0.233 //l=0.165 //layer=ply \
 //thickness=0.18 //x=59.22 //y=5.045 //x2=59.22 //y2=4.88
r575 (  170 194 ) resistor r=34.8111 //w=0.27 //l=0.264953 //layer=ply \
 //thickness=0.18 //x=59.125 //y=2.095 //x2=59.32 //y2=2.26
r576 (  169 196 ) resistor r=39.5823 //w=0.21 //l=0.173853 //layer=ply \
 //thickness=0.18 //x=59.125 //y=1.7 //x2=59.165 //y2=1.545
r577 (  169 170 ) resistor r=202.543 //w=0.094 //l=0.395 //layer=ply \
 //thickness=0.18 //x=59.125 //y=1.7 //x2=59.125 //y2=2.095
r578 (  168 196 ) resistor r=39.5823 //w=0.21 //l=0.173853 //layer=ply \
 //thickness=0.18 //x=59.125 //y=1.39 //x2=59.165 //y2=1.545
r579 (  167 195 ) resistor r=45.1352 //w=0.168 //l=0.173853 //layer=ply \
 //thickness=0.18 //x=59.125 //y=1.045 //x2=59.165 //y2=0.89
r580 (  167 168 ) resistor r=176.904 //w=0.094 //l=0.345 //layer=ply \
 //thickness=0.18 //x=59.125 //y=1.045 //x2=59.125 //y2=1.39
r581 (  164 190 ) resistor r=70.3348 //w=0.233 //l=0.414367 //layer=ply \
 //thickness=0.18 //x=49.67 //y=5.045 //x2=49.33 //y2=4.88
r582 (  163 192 ) resistor r=45.1352 //w=0.168 //l=0.173853 //layer=ply \
 //thickness=0.18 //x=49.665 //y=1.39 //x2=49.625 //y2=1.545
r583 (  162 191 ) resistor r=45.1352 //w=0.168 //l=0.173853 //layer=ply \
 //thickness=0.18 //x=49.665 //y=1.045 //x2=49.625 //y2=0.89
r584 (  162 163 ) resistor r=176.904 //w=0.094 //l=0.345 //layer=ply \
 //thickness=0.18 //x=49.665 //y=1.045 //x2=49.665 //y2=1.39
r585 (  160 187 ) resistor r=10.701 //w=0.21 //l=0.115 //layer=ply \
 //thickness=0.18 //x=49.29 //y=1.545 //x2=49.175 //y2=1.545
r586 (  159 192 ) resistor r=5.52526 //w=0.168 //l=0.115 //layer=ply \
 //thickness=0.18 //x=49.51 //y=1.545 //x2=49.625 //y2=1.545
r587 (  158 186 ) resistor r=5.52526 //w=0.168 //l=0.115 //layer=ply \
 //thickness=0.18 //x=49.29 //y=0.89 //x2=49.175 //y2=0.89
r588 (  157 191 ) resistor r=5.52526 //w=0.168 //l=0.115 //layer=ply \
 //thickness=0.18 //x=49.51 //y=0.89 //x2=49.625 //y2=0.89
r589 (  157 158 ) resistor r=112.809 //w=0.094 //l=0.22 //layer=ply \
 //thickness=0.18 //x=49.51 //y=0.89 //x2=49.29 //y2=0.89
r590 (  154 188 ) resistor r=13.0941 //w=0.233 //l=0.165 //layer=ply \
 //thickness=0.18 //x=49.23 //y=5.045 //x2=49.23 //y2=4.88
r591 (  153 185 ) resistor r=34.8111 //w=0.27 //l=0.264953 //layer=ply \
 //thickness=0.18 //x=49.135 //y=2.095 //x2=49.33 //y2=2.26
r592 (  152 187 ) resistor r=39.5823 //w=0.21 //l=0.173853 //layer=ply \
 //thickness=0.18 //x=49.135 //y=1.7 //x2=49.175 //y2=1.545
r593 (  152 153 ) resistor r=202.543 //w=0.094 //l=0.395 //layer=ply \
 //thickness=0.18 //x=49.135 //y=1.7 //x2=49.135 //y2=2.095
r594 (  151 187 ) resistor r=39.5823 //w=0.21 //l=0.173853 //layer=ply \
 //thickness=0.18 //x=49.135 //y=1.39 //x2=49.175 //y2=1.545
r595 (  150 186 ) resistor r=45.1352 //w=0.168 //l=0.173853 //layer=ply \
 //thickness=0.18 //x=49.135 //y=1.045 //x2=49.175 //y2=0.89
r596 (  150 151 ) resistor r=176.904 //w=0.094 //l=0.345 //layer=ply \
 //thickness=0.18 //x=49.135 //y=1.045 //x2=49.135 //y2=1.39
r597 (  149 181 ) resistor r=592.245 //w=0.094 //l=1.155 //layer=ply \
 //thickness=0.18 //x=59.66 //y=6.2 //x2=59.66 //y2=5.045
r598 (  148 171 ) resistor r=592.245 //w=0.094 //l=1.155 //layer=ply \
 //thickness=0.18 //x=59.22 //y=6.2 //x2=59.22 //y2=5.045
r599 (  147 164 ) resistor r=592.245 //w=0.094 //l=1.155 //layer=ply \
 //thickness=0.18 //x=49.67 //y=6.2 //x2=49.67 //y2=5.045
r600 (  146 154 ) resistor r=592.245 //w=0.094 //l=1.155 //layer=ply \
 //thickness=0.18 //x=49.23 //y=6.2 //x2=49.23 //y2=5.045
r601 (  145 176 ) resistor r=56.4043 //w=0.094 //l=0.11 //layer=ply \
 //thickness=0.18 //x=59.39 //y=1.545 //x2=59.5 //y2=1.545
r602 (  145 177 ) resistor r=56.4043 //w=0.094 //l=0.11 //layer=ply \
 //thickness=0.18 //x=59.39 //y=1.545 //x2=59.28 //y2=1.545
r603 (  144 159 ) resistor r=56.4043 //w=0.094 //l=0.11 //layer=ply \
 //thickness=0.18 //x=49.4 //y=1.545 //x2=49.51 //y2=1.545
r604 (  144 160 ) resistor r=56.4043 //w=0.094 //l=0.11 //layer=ply \
 //thickness=0.18 //x=49.4 //y=1.545 //x2=49.29 //y2=1.545
r605 (  140 199 ) resistor r=152 //w=0.17 //l=0.17 //layer=licon //count=1 \
 //x=59.32 //y=4.88 //x2=59.32 //y2=4.88
r606 (  131 194 ) resistor r=152 //w=0.17 //l=0.17 //layer=licon //count=1 \
 //x=59.32 //y=2.26 //x2=59.32 //y2=2.26
r607 (  126 190 ) resistor r=152 //w=0.17 //l=0.17 //layer=licon //count=1 \
 //x=49.33 //y=4.88 //x2=49.33 //y2=4.88
r608 (  117 185 ) resistor r=152 //w=0.17 //l=0.17 //layer=licon //count=1 \
 //x=49.33 //y=2.26 //x2=49.33 //y2=2.26
r609 (  100 206 ) resistor r=23.615 //w=0.187 //l=0.345 //layer=li \
 //thickness=0.1 //x=46.7 //y=5.56 //x2=46.7 //y2=5.905
r610 (  92 205 ) resistor r=23.615 //w=0.187 //l=0.345 //layer=li \
 //thickness=0.1 //x=45.82 //y=5.56 //x2=45.82 //y2=5.905
r611 (  84 204 ) resistor r=23.615 //w=0.187 //l=0.345 //layer=li \
 //thickness=0.1 //x=44.94 //y=5.56 //x2=44.94 //y2=5.905
r612 (  74 82 ) resistor r=2.10915 //w=0.185 //l=3.125 //layer=m2 \
 //thickness=0.36 //x=56.2 //y=3.895 //x2=59.32 //y2=3.885
r613 (  74 75 ) resistor r=0.329198 //w=0.131 //l=0.345 //layer=m2 \
 //thickness=0.36 //x=56.2 //y=3.895 //x2=55.855 //y2=3.895
r614 (  72 75 ) resistor r=0.1875 //w=0.17 //l=0.262393 //layer=m2 \
 //thickness=0.36 //x=55.6 //y=3.88 //x2=55.855 //y2=3.895
r615 (  72 73 ) resistor r=1.02099 //w=0.131 //l=1.07 //layer=m2 \
 //thickness=0.36 //x=55.6 //y=3.88 //x2=54.53 //y2=3.88
r616 (  70 73 ) resistor r=0.125 //w=0.17 //l=0.177341 //layer=m2 \
 //thickness=0.36 //x=54.36 //y=3.895 //x2=54.53 //y2=3.88
r617 (  70 71 ) resistor r=0.329198 //w=0.131 //l=0.345 //layer=m2 \
 //thickness=0.36 //x=54.36 //y=3.895 //x2=54.015 //y2=3.895
r618 (  68 71 ) resistor r=0.290441 //w=0.17 //l=0.407308 //layer=m2 \
 //thickness=0.36 //x=53.62 //y=3.87 //x2=54.015 //y2=3.895
r619 (  68 69 ) resistor r=0.410305 //w=0.131 //l=0.43 //layer=m2 \
 //thickness=0.36 //x=53.62 //y=3.87 //x2=53.19 //y2=3.87
r620 (  66 69 ) resistor r=0.235294 //w=0.17 //l=0.329848 //layer=m2 \
 //thickness=0.36 //x=52.87 //y=3.89 //x2=53.19 //y2=3.87
r621 (  66 67 ) resistor r=0.329198 //w=0.131 //l=0.345 //layer=m2 \
 //thickness=0.36 //x=52.87 //y=3.89 //x2=52.525 //y2=3.89
r622 (  64 67 ) resistor r=0.1875 //w=0.17 //l=0.259952 //layer=m2 \
 //thickness=0.36 //x=52.27 //y=3.88 //x2=52.525 //y2=3.89
r623 (  64 65 ) resistor r=1.03053 //w=0.131 //l=1.08 //layer=m2 \
 //thickness=0.36 //x=52.27 //y=3.88 //x2=51.19 //y2=3.88
r624 (  63 80 ) resistor r=0.838898 //w=0.202 //l=1.35748 //layer=m2 \
 //thickness=0.36 //x=50.675 //y=3.895 //x2=49.325 //y2=3.88
r625 (  62 65 ) resistor r=0.125 //w=0.17 //l=0.177341 //layer=m2 \
 //thickness=0.36 //x=51.02 //y=3.895 //x2=51.19 //y2=3.88
r626 (  62 63 ) resistor r=0.329198 //w=0.131 //l=0.345 //layer=m2 \
 //thickness=0.36 //x=51.02 //y=3.895 //x2=50.675 //y2=3.895
r627 (  61 77 ) resistor r=0.10734 //w=0.281 //l=0.16 //layer=m2 \
 //thickness=0.36 //x=47.64 //y=3.88 //x2=47.48 //y2=3.88
r628 (  60 80 ) resistor r=0.102512 //w=0.202 //l=0.16 //layer=m2 \
 //thickness=0.36 //x=49.165 //y=3.88 //x2=49.325 //y2=3.88
r629 (  60 61 ) resistor r=1.45515 //w=0.131 //l=1.525 //layer=m2 \
 //thickness=0.36 //x=49.165 //y=3.88 //x2=47.64 //y2=3.88
r630 (  57 140 ) resistor r=9.3 //w=0.17 //l=0.17 //layer=mcon //count=1 \
 //x=59.32 //y=4.88 //x2=59.32 //y2=4.88
r631 (  57 58 ) resistor r=0.103207 //w=0.196 //l=0.14 //layer=m1 \
 //thickness=0.36 //x=59.322 //y=4.88 //x2=59.322 //y2=4.74
r632 (  54 131 ) resistor r=9.3 //w=0.17 //l=0.17 //layer=mcon //count=1 \
 //x=59.32 //y=2.26 //x2=59.32 //y2=2.26
r633 (  52 82 ) resistor r=4.5 //w=0.15 //l=0.15 //layer=via1 //count=1 \
 //x=59.32 //y=3.885 //x2=59.32 //y2=3.885
r634 (  50 52 ) resistor r=0.00166223 //w=0.376 //l=0.005 //layer=m1 \
 //thickness=0.36 //x=59.267 //y=3.88 //x2=59.267 //y2=3.885
r635 (  46 126 ) resistor r=9.3 //w=0.17 //l=0.17 //layer=mcon //count=1 \
 //x=49.33 //y=4.88 //x2=49.33 //y2=4.88
r636 (  46 47 ) resistor r=0.103207 //w=0.196 //l=0.14 //layer=m1 \
 //thickness=0.36 //x=49.332 //y=4.88 //x2=49.332 //y2=4.74
r637 (  43 117 ) resistor r=9.3 //w=0.17 //l=0.17 //layer=mcon //count=1 \
 //x=49.33 //y=2.26 //x2=49.33 //y2=2.26
r638 (  40 80 ) resistor r=4.5 //w=0.15 //l=0.15 //layer=via1 //count=1 \
 //x=49.325 //y=3.88 //x2=49.325 //y2=3.88
r639 (  37 77 ) resistor r=4.5 //w=0.15 //l=0.15 //layer=via1 //count=1 \
 //x=47.48 //y=3.88 //x2=47.48 //y2=3.88
r640 (  35 202 ) resistor r=9.3 //w=0.17 //l=0.17 //layer=mcon //count=1 \
 //x=46.995 //y=1.19 //x2=46.995 //y2=1.19
r641 (  33 100 ) resistor r=9.3 //w=0.17 //l=0.17 //layer=mcon //count=1 \
 //x=46.7 //y=5.56 //x2=46.7 //y2=5.56
r642 (  30 92 ) resistor r=9.3 //w=0.17 //l=0.17 //layer=mcon //count=1 \
 //x=45.82 //y=5.56 //x2=45.82 //y2=5.56
r643 (  28 30 ) resistor r=0.121228 //w=0.232 //l=0.225 //layer=m1 \
 //thickness=0.36 //x=45.82 //y=5.335 //x2=45.82 //y2=5.56
r644 (  27 84 ) resistor r=9.3 //w=0.17 //l=0.17 //layer=mcon //count=1 \
 //x=44.94 //y=5.56 //x2=44.94 //y2=5.56
r645 (  25 27 ) resistor r=0.129608 //w=0.217 //l=0.225 //layer=m1 \
 //thickness=0.36 //x=44.942 //y=5.335 //x2=44.942 //y2=5.56
r646 (  23 52 ) resistor r=0.0911593 //w=0.376 //l=0.184608 //layer=m1 \
 //thickness=0.36 //x=59.32 //y=4.045 //x2=59.267 //y2=3.885
r647 (  23 58 ) resistor r=0.663168 //w=0.131 //l=0.695 //layer=m1 \
 //thickness=0.36 //x=59.32 //y=4.045 //x2=59.32 //y2=4.74
r648 (  22 50 ) resistor r=0.0894971 //w=0.376 //l=0.179555 //layer=m1 \
 //thickness=0.36 //x=59.32 //y=3.725 //x2=59.267 //y2=3.88
r649 (  21 54 ) resistor r=0.0933015 //w=0.201 //l=0.125 //layer=m1 \
 //thickness=0.36 //x=59.32 //y=2.385 //x2=59.32 //y2=2.26
r650 (  21 22 ) resistor r=1.27863 //w=0.131 //l=1.34 //layer=m1 \
 //thickness=0.36 //x=59.32 //y=2.385 //x2=59.32 //y2=3.725
r651 (  19 40 ) resistor r=0.0910802 //w=0.374 //l=0.185472 //layer=m1 \
 //thickness=0.36 //x=49.33 //y=4.04 //x2=49.275 //y2=3.88
r652 (  19 47 ) resistor r=0.667939 //w=0.131 //l=0.7 //layer=m1 \
 //thickness=0.36 //x=49.33 //y=4.04 //x2=49.33 //y2=4.74
r653 (  18 40 ) resistor r=0.0910802 //w=0.374 //l=0.185472 //layer=m1 \
 //thickness=0.36 //x=49.33 //y=3.72 //x2=49.275 //y2=3.88
r654 (  17 43 ) resistor r=0.0933015 //w=0.201 //l=0.125 //layer=m1 \
 //thickness=0.36 //x=49.33 //y=2.385 //x2=49.33 //y2=2.26
r655 (  17 18 ) resistor r=1.27385 //w=0.131 //l=1.335 //layer=m1 \
 //thickness=0.36 //x=49.33 //y=2.385 //x2=49.33 //y2=3.72
r656 (  15 37 ) resistor r=0.0911593 //w=0.376 //l=0.184174 //layer=m1 \
 //thickness=0.36 //x=47.48 //y=4.04 //x2=47.532 //y2=3.88
r657 (  15 16 ) resistor r=1.15458 //w=0.131 //l=1.21 //layer=m1 \
 //thickness=0.36 //x=47.48 //y=4.04 //x2=47.48 //y2=5.25
r658 (  14 37 ) resistor r=0.0911593 //w=0.376 //l=0.184174 //layer=m1 \
 //thickness=0.36 //x=47.48 //y=3.72 //x2=47.532 //y2=3.88
r659 (  13 14 ) resistor r=1.70802 //w=0.131 //l=1.79 //layer=m1 \
 //thickness=0.36 //x=47.48 //y=1.93 //x2=47.48 //y2=3.72
r660 (  11 13 ) resistor r=0.0698411 //w=0.17 //l=0.120208 //layer=m1 \
 //thickness=0.36 //x=47.395 //y=1.845 //x2=47.48 //y2=1.93
r661 (  11 12 ) resistor r=0.300573 //w=0.131 //l=0.315 //layer=m1 \
 //thickness=0.36 //x=47.395 //y=1.845 //x2=47.08 //y2=1.845
r662 (  10 12 ) resistor r=0.0698411 //w=0.17 //l=0.120208 //layer=m1 \
 //thickness=0.36 //x=46.995 //y=1.76 //x2=47.08 //y2=1.845
r663 (  9 35 ) resistor r=0.0717383 //w=0.224 //l=0.115 //layer=m1 \
 //thickness=0.36 //x=46.995 //y=1.305 //x2=46.995 //y2=1.19
r664 (  9 10 ) resistor r=0.43416 //w=0.131 //l=0.455 //layer=m1 \
 //thickness=0.36 //x=46.995 //y=1.305 //x2=46.995 //y2=1.76
r665 (  8 31 ) resistor r=0.0675342 //w=0.23 //l=0.115 //layer=m1 \
 //thickness=0.36 //x=46.815 //y=5.335 //x2=46.7 //y2=5.335
r666 (  7 16 ) resistor r=0.0698411 //w=0.17 //l=0.120208 //layer=m1 \
 //thickness=0.36 //x=47.395 //y=5.335 //x2=47.48 //y2=5.25
r667 (  7 8 ) resistor r=0.553435 //w=0.131 //l=0.58 //layer=m1 \
 //thickness=0.36 //x=47.395 //y=5.335 //x2=46.815 //y2=5.335
r668 (  6 33 ) resistor r=0.00118313 //w=0.23 //layer=m1 //thickness=0.36 \
 //x=46.7 //y=5.56 //x2=46.7 //y2=5.56
r669 (  5 31 ) resistor r=0.002872 //w=0.34 //l=0.085 //layer=m1 \
 //thickness=0.36 //x=46.7 //y=5.42 //x2=46.7 //y2=5.335
r670 (  5 6 ) resistor r=0.091623 //w=0.191 //l=0.14 //layer=m1 \
 //thickness=0.36 //x=46.7 //y=5.42 //x2=46.7 //y2=5.56
r671 (  4 28 ) resistor r=0.0262263 //w=0.232 //l=0.12 //layer=m1 \
 //thickness=0.36 //x=45.94 //y=5.335 //x2=45.82 //y2=5.335
r672 (  3 31 ) resistor r=0.0675342 //w=0.23 //l=0.115 //layer=m1 \
 //thickness=0.36 //x=46.585 //y=5.335 //x2=46.7 //y2=5.335
r673 (  3 4 ) resistor r=0.615458 //w=0.131 //l=0.645 //layer=m1 \
 //thickness=0.36 //x=46.585 //y=5.335 //x2=45.94 //y2=5.335
r674 (  2 25 ) resistor r=0.0222262 //w=0.217 //l=0.118 //layer=m1 \
 //thickness=0.36 //x=45.06 //y=5.335 //x2=44.942 //y2=5.335
r675 (  1 28 ) resistor r=0.0262263 //w=0.232 //l=0.12 //layer=m1 \
 //thickness=0.36 //x=45.7 //y=5.335 //x2=45.82 //y2=5.335
r676 (  1 2 ) resistor r=0.610687 //w=0.131 //l=0.64 //layer=m1 \
 //thickness=0.36 //x=45.7 //y=5.335 //x2=45.06 //y2=5.335
ends PM_TMRDFFQX1\%noxref_15

subckt PM_TMRDFFQX1\%noxref_16 ( 3 8 9 11 12 14 15 16 18 21 22 25 27 30 34 39 \
 41 46 47 51 59 76 81 85 86 87 88 89 90 91 95 97 100 101 111 114 116 117 )
c279 ( 114 0 ) capacitor c=0.00878249f //x=60.17 //y=1.085
c280 ( 111 0 ) capacitor c=0.0653681f //x=62.65 //y=4.88
c281 ( 101 0 ) capacitor c=0.0318956f //x=62.985 //y=1.39
c282 ( 100 0 ) capacitor c=0.0186809f //x=62.985 //y=1.045
c283 ( 97 0 ) capacitor c=0.0141821f //x=62.83 //y=1.545
c284 ( 95 0 ) capacitor c=0.0158553f //x=62.83 //y=0.89
c285 ( 91 0 ) capacitor c=0.088055f //x=62.455 //y=2.095
c286 ( 90 0 ) capacitor c=0.0229235f //x=62.455 //y=1.7
c287 ( 89 0 ) capacitor c=0.0234359f //x=62.455 //y=1.39
c288 ( 88 0 ) capacitor c=0.0198759f //x=62.455 //y=1.045
c289 ( 87 0 ) capacitor c=0.110369f //x=62.99 //y=6.2
c290 ( 86 0 ) capacitor c=0.154619f //x=62.55 //y=6.2
c291 ( 81 0 ) capacitor c=8.13425e-19 //x=62.65 //y=4.88
c292 ( 76 0 ) capacitor c=7.85889e-19 //x=62.65 //y=2.26
c293 ( 59 0 ) capacitor c=0.0322017f //x=60.32 //y=5.56
c294 ( 51 0 ) capacitor c=0.0290186f //x=59.44 //y=5.56
c295 ( 47 0 ) capacitor c=0.00289812f //x=62.65 //y=4.62
c296 ( 46 0 ) capacitor c=0.00390716f //x=60.955 //y=4.635
c297 ( 41 0 ) capacitor c=0.0436041f //x=62.49 //y=4.62
c298 ( 39 0 ) capacitor c=0.00463527f //x=62.65 //y=2.26
c299 ( 34 0 ) capacitor c=0.00537728f //x=62.65 //y=4.865
c300 ( 30 0 ) capacitor c=0.0146108f //x=60.8 //y=4.62
c301 ( 27 0 ) capacitor c=0.0114161f //x=60.36 //y=1.18
c302 ( 25 0 ) capacitor c=5.78613e-19 //x=60.32 //y=5.56
c303 ( 22 0 ) capacitor c=0.0112577f //x=60.32 //y=5.38
c304 ( 21 0 ) capacitor c=0.00921781f //x=59.44 //y=5.56
c305 ( 18 0 ) capacitor c=0.0640013f //x=62.65 //y=4.705
c306 ( 16 0 ) capacitor c=0.0117892f //x=60.8 //y=5.295
c307 ( 15 0 ) capacitor c=0.0133928f //x=60.8 //y=4.795
c308 ( 14 0 ) capacitor c=0.0705749f //x=60.8 //y=4.475
c309 ( 12 0 ) capacitor c=0.00462494f //x=60.445 //y=1.835
c310 ( 11 0 ) capacitor c=0.0117867f //x=60.715 //y=1.835
c311 ( 9 0 ) capacitor c=0.0107674f //x=60.715 //y=5.38
c312 ( 8 0 ) capacitor c=0.0101547f //x=60.36 //y=1.75
c313 ( 3 0 ) capacitor c=0.0148064f //x=60.205 //y=5.38
r314 (  109 111 ) resistor r=20.6867 //w=0.233 //l=0.1 //layer=ply \
 //thickness=0.18 //x=62.55 //y=4.88 //x2=62.65 //y2=4.88
r315 (  102 111 ) resistor r=70.3348 //w=0.233 //l=0.414367 //layer=ply \
 //thickness=0.18 //x=62.99 //y=5.045 //x2=62.65 //y2=4.88
r316 (  101 113 ) resistor r=45.1352 //w=0.168 //l=0.173853 //layer=ply \
 //thickness=0.18 //x=62.985 //y=1.39 //x2=62.945 //y2=1.545
r317 (  100 112 ) resistor r=45.1352 //w=0.168 //l=0.173853 //layer=ply \
 //thickness=0.18 //x=62.985 //y=1.045 //x2=62.945 //y2=0.89
r318 (  100 101 ) resistor r=176.904 //w=0.094 //l=0.345 //layer=ply \
 //thickness=0.18 //x=62.985 //y=1.045 //x2=62.985 //y2=1.39
r319 (  98 108 ) resistor r=10.701 //w=0.21 //l=0.115 //layer=ply \
 //thickness=0.18 //x=62.61 //y=1.545 //x2=62.495 //y2=1.545
r320 (  97 113 ) resistor r=5.52526 //w=0.168 //l=0.115 //layer=ply \
 //thickness=0.18 //x=62.83 //y=1.545 //x2=62.945 //y2=1.545
r321 (  96 107 ) resistor r=5.52526 //w=0.168 //l=0.115 //layer=ply \
 //thickness=0.18 //x=62.61 //y=0.89 //x2=62.495 //y2=0.89
r322 (  95 112 ) resistor r=5.52526 //w=0.168 //l=0.115 //layer=ply \
 //thickness=0.18 //x=62.83 //y=0.89 //x2=62.945 //y2=0.89
r323 (  95 96 ) resistor r=112.809 //w=0.094 //l=0.22 //layer=ply \
 //thickness=0.18 //x=62.83 //y=0.89 //x2=62.61 //y2=0.89
r324 (  92 109 ) resistor r=13.0941 //w=0.233 //l=0.165 //layer=ply \
 //thickness=0.18 //x=62.55 //y=5.045 //x2=62.55 //y2=4.88
r325 (  91 106 ) resistor r=34.8111 //w=0.27 //l=0.264953 //layer=ply \
 //thickness=0.18 //x=62.455 //y=2.095 //x2=62.65 //y2=2.26
r326 (  90 108 ) resistor r=39.5823 //w=0.21 //l=0.173853 //layer=ply \
 //thickness=0.18 //x=62.455 //y=1.7 //x2=62.495 //y2=1.545
r327 (  90 91 ) resistor r=202.543 //w=0.094 //l=0.395 //layer=ply \
 //thickness=0.18 //x=62.455 //y=1.7 //x2=62.455 //y2=2.095
r328 (  89 108 ) resistor r=39.5823 //w=0.21 //l=0.173853 //layer=ply \
 //thickness=0.18 //x=62.455 //y=1.39 //x2=62.495 //y2=1.545
r329 (  88 107 ) resistor r=45.1352 //w=0.168 //l=0.173853 //layer=ply \
 //thickness=0.18 //x=62.455 //y=1.045 //x2=62.495 //y2=0.89
r330 (  88 89 ) resistor r=176.904 //w=0.094 //l=0.345 //layer=ply \
 //thickness=0.18 //x=62.455 //y=1.045 //x2=62.455 //y2=1.39
r331 (  87 102 ) resistor r=592.245 //w=0.094 //l=1.155 //layer=ply \
 //thickness=0.18 //x=62.99 //y=6.2 //x2=62.99 //y2=5.045
r332 (  86 92 ) resistor r=592.245 //w=0.094 //l=1.155 //layer=ply \
 //thickness=0.18 //x=62.55 //y=6.2 //x2=62.55 //y2=5.045
r333 (  85 97 ) resistor r=56.4043 //w=0.094 //l=0.11 //layer=ply \
 //thickness=0.18 //x=62.72 //y=1.545 //x2=62.83 //y2=1.545
r334 (  85 98 ) resistor r=56.4043 //w=0.094 //l=0.11 //layer=ply \
 //thickness=0.18 //x=62.72 //y=1.545 //x2=62.61 //y2=1.545
r335 (  81 111 ) resistor r=152 //w=0.17 //l=0.17 //layer=licon //count=1 \
 //x=62.65 //y=4.88 //x2=62.65 //y2=4.88
r336 (  76 106 ) resistor r=152 //w=0.17 //l=0.17 //layer=licon //count=1 \
 //x=62.65 //y=2.26 //x2=62.65 //y2=2.26
r337 (  59 117 ) resistor r=23.615 //w=0.187 //l=0.345 //layer=li \
 //thickness=0.1 //x=60.32 //y=5.56 //x2=60.32 //y2=5.905
r338 (  51 116 ) resistor r=23.615 //w=0.187 //l=0.345 //layer=li \
 //thickness=0.1 //x=59.44 //y=5.56 //x2=59.44 //y2=5.905
r339 (  47 49 ) resistor r=0.103463 //w=0.296 //l=0.245 //layer=m2 \
 //thickness=0.36 //x=62.65 //y=4.62 //x2=62.65 //y2=4.865
r340 (  44 46 ) resistor r=0.10734 //w=0.281 //l=0.16 //layer=m2 \
 //thickness=0.36 //x=60.795 //y=4.635 //x2=60.955 //y2=4.635
r341 (  41 47 ) resistor r=0.0408006 //w=0.296 //l=0.16 //layer=m2 \
 //thickness=0.36 //x=62.49 //y=4.62 //x2=62.65 //y2=4.62
r342 (  41 46 ) resistor r=1.46469 //w=0.131 //l=1.535 //layer=m2 \
 //thickness=0.36 //x=62.49 //y=4.62 //x2=60.955 //y2=4.62
r343 (  39 76 ) resistor r=9.3 //w=0.17 //l=0.17 //layer=mcon //count=1 \
 //x=62.65 //y=2.26 //x2=62.65 //y2=2.26
r344 (  36 81 ) resistor r=9.3 //w=0.17 //l=0.17 //layer=mcon //count=1 \
 //x=62.65 //y=4.88 //x2=62.65 //y2=4.88
r345 (  34 49 ) resistor r=4.5 //w=0.15 //l=0.15 //layer=via1 //count=1 \
 //x=62.65 //y=4.865 //x2=62.65 //y2=4.865
r346 (  34 36 ) resistor r=0.0066726 //w=0.281 //l=0.015 //layer=m1 \
 //thickness=0.36 //x=62.65 //y=4.865 //x2=62.65 //y2=4.88
r347 (  32 44 ) resistor r=4.5 //w=0.15 //l=0.15 //layer=via1 //count=1 \
 //x=60.795 //y=4.635 //x2=60.795 //y2=4.635
r348 (  30 32 ) resistor r=0.00494723 //w=0.379 //l=0.015 //layer=m1 \
 //thickness=0.36 //x=60.85 //y=4.62 //x2=60.85 //y2=4.635
r349 (  27 114 ) resistor r=9.3 //w=0.17 //l=0.17 //layer=mcon //count=1 \
 //x=60.36 //y=1.18 //x2=60.36 //y2=1.18
r350 (  25 59 ) resistor r=9.3 //w=0.17 //l=0.17 //layer=mcon //count=1 \
 //x=60.32 //y=5.56 //x2=60.32 //y2=5.56
r351 (  22 25 ) resistor r=0.117801 //w=0.191 //l=0.18 //layer=m1 \
 //thickness=0.36 //x=60.32 //y=5.38 //x2=60.32 //y2=5.56
r352 (  21 51 ) resistor r=9.3 //w=0.17 //l=0.17 //layer=mcon //count=1 \
 //x=59.44 //y=5.56 //x2=59.44 //y2=5.56
r353 (  19 21 ) resistor r=0.10274 //w=0.219 //l=0.18 //layer=m1 \
 //thickness=0.36 //x=59.44 //y=5.38 //x2=59.44 //y2=5.56
r354 (  18 34 ) resistor r=0.10734 //w=0.281 //l=0.16 //layer=m1 \
 //thickness=0.36 //x=62.65 //y=4.705 //x2=62.65 //y2=4.865
r355 (  17 39 ) resistor r=0.0933015 //w=0.201 //l=0.125 //layer=m1 \
 //thickness=0.36 //x=62.65 //y=2.385 //x2=62.65 //y2=2.26
r356 (  17 18 ) resistor r=2.21374 //w=0.131 //l=2.32 //layer=m1 \
 //thickness=0.36 //x=62.65 //y=2.385 //x2=62.65 //y2=4.705
r357 (  15 32 ) resistor r=0.0912814 //w=0.379 //l=0.183303 //layer=m1 \
 //thickness=0.36 //x=60.8 //y=4.795 //x2=60.85 //y2=4.635
r358 (  15 16 ) resistor r=0.477099 //w=0.131 //l=0.5 //layer=m1 \
 //thickness=0.36 //x=60.8 //y=4.795 //x2=60.8 //y2=5.295
r359 (  14 30 ) resistor r=0.0863342 //w=0.379 //l=0.168152 //layer=m1 \
 //thickness=0.36 //x=60.8 //y=4.475 //x2=60.85 //y2=4.62
r360 (  13 14 ) resistor r=2.43798 //w=0.131 //l=2.555 //layer=m1 \
 //thickness=0.36 //x=60.8 //y=1.92 //x2=60.8 //y2=4.475
r361 (  11 13 ) resistor r=0.0698411 //w=0.17 //l=0.120208 //layer=m1 \
 //thickness=0.36 //x=60.715 //y=1.835 //x2=60.8 //y2=1.92
r362 (  11 12 ) resistor r=0.257634 //w=0.131 //l=0.27 //layer=m1 \
 //thickness=0.36 //x=60.715 //y=1.835 //x2=60.445 //y2=1.835
r363 (  10 22 ) resistor r=0.0257089 //w=0.23 //l=0.115 //layer=m1 \
 //thickness=0.36 //x=60.435 //y=5.38 //x2=60.32 //y2=5.38
r364 (  9 16 ) resistor r=0.0698411 //w=0.17 //l=0.120208 //layer=m1 \
 //thickness=0.36 //x=60.715 //y=5.38 //x2=60.8 //y2=5.295
r365 (  9 10 ) resistor r=0.267176 //w=0.131 //l=0.28 //layer=m1 \
 //thickness=0.36 //x=60.715 //y=5.38 //x2=60.435 //y2=5.38
r366 (  8 12 ) resistor r=0.0698411 //w=0.17 //l=0.120208 //layer=m1 \
 //thickness=0.36 //x=60.36 //y=1.75 //x2=60.445 //y2=1.835
r367 (  7 27 ) resistor r=0.0913624 //w=0.191 //l=0.12 //layer=m1 \
 //thickness=0.36 //x=60.36 //y=1.3 //x2=60.36 //y2=1.18
r368 (  7 8 ) resistor r=0.429389 //w=0.131 //l=0.45 //layer=m1 \
 //thickness=0.36 //x=60.36 //y=1.3 //x2=60.36 //y2=1.75
r369 (  4 19 ) resistor r=0.0227762 //w=0.219 //l=0.115 //layer=m1 \
 //thickness=0.36 //x=59.555 //y=5.38 //x2=59.44 //y2=5.38
r370 (  3 22 ) resistor r=0.0257089 //w=0.23 //l=0.115 //layer=m1 \
 //thickness=0.36 //x=60.205 //y=5.38 //x2=60.32 //y2=5.38
r371 (  3 4 ) resistor r=0.620229 //w=0.131 //l=0.65 //layer=m1 \
 //thickness=0.36 //x=60.205 //y=5.38 //x2=59.555 //y2=5.38
ends PM_TMRDFFQX1\%noxref_16

subckt PM_TMRDFFQX1\%noxref_17 ( 1 2 3 4 6 7 8 11 16 17 19 20 22 23 24 26 27 \
 28 34 38 42 49 50 53 55 58 62 65 70 72 74 76 78 79 80 81 85 93 102 107 116 \
 121 129 146 155 159 160 161 162 163 164 165 166 167 168 169 170 171 172 174 \
 180 181 182 183 187 188 189 194 196 198 204 205 206 207 208 213 215 217 223 \
 224 234 235 238 247 248 251 259 261 262 )
c628 ( 259 0 ) capacitor c=0.00878249f //x=56.84 //y=1.085
c629 ( 251 0 ) capacitor c=0.0356006f //x=63.42 //y=4.88
c630 ( 248 0 ) capacitor c=0.0284095f //x=63.39 //y=2.095
c631 ( 247 0 ) capacitor c=0.0476356f //x=63.39 //y=2.26
c632 ( 238 0 ) capacitor c=0.0354915f //x=53.43 //y=4.88
c633 ( 235 0 ) capacitor c=0.0284095f //x=53.4 //y=2.095
c634 ( 234 0 ) capacitor c=0.0476356f //x=53.4 //y=2.26
c635 ( 224 0 ) capacitor c=0.0439708f //x=63.955 //y=1.43
c636 ( 223 0 ) capacitor c=0.0192582f //x=63.955 //y=1.085
c637 ( 217 0 ) capacitor c=0.0162526f //x=63.8 //y=1.585
c638 ( 215 0 ) capacitor c=0.0157807f //x=63.8 //y=0.93
c639 ( 213 0 ) capacitor c=0.0373491f //x=63.795 //y=4.97
c640 ( 208 0 ) capacitor c=0.0210762f //x=63.425 //y=1.74
c641 ( 207 0 ) capacitor c=0.0168511f //x=63.425 //y=1.43
c642 ( 206 0 ) capacitor c=0.0175485f //x=63.425 //y=1.085
c643 ( 205 0 ) capacitor c=0.0439708f //x=53.965 //y=1.43
c644 ( 204 0 ) capacitor c=0.0192582f //x=53.965 //y=1.085
c645 ( 198 0 ) capacitor c=0.0162526f //x=53.81 //y=1.585
c646 ( 196 0 ) capacitor c=0.0157807f //x=53.81 //y=0.93
c647 ( 194 0 ) capacitor c=0.0372668f //x=53.805 //y=4.97
c648 ( 189 0 ) capacitor c=0.0210762f //x=53.435 //y=1.74
c649 ( 188 0 ) capacitor c=0.0168511f //x=53.435 //y=1.43
c650 ( 187 0 ) capacitor c=0.0175485f //x=53.435 //y=1.085
c651 ( 183 0 ) capacitor c=0.0552496f //x=44.795 //y=4.97
c652 ( 182 0 ) capacitor c=0.0376038f //x=45.085 //y=4.97
c653 ( 181 0 ) capacitor c=0.0346489f //x=44.75 //y=1.4
c654 ( 180 0 ) capacitor c=0.018692f //x=44.75 //y=1.055
c655 ( 174 0 ) capacitor c=0.0137077f //x=44.595 //y=1.555
c656 ( 172 0 ) capacitor c=0.0158585f //x=44.595 //y=0.9
c657 ( 171 0 ) capacitor c=0.103534f //x=44.22 //y=2.095
c658 ( 170 0 ) capacitor c=0.0229444f //x=44.22 //y=1.71
c659 ( 169 0 ) capacitor c=0.0234359f //x=44.22 //y=1.4
c660 ( 168 0 ) capacitor c=0.019815f //x=44.22 //y=1.055
c661 ( 167 0 ) capacitor c=0.155269f //x=63.87 //y=6.2
c662 ( 166 0 ) capacitor c=0.110375f //x=63.43 //y=6.2
c663 ( 165 0 ) capacitor c=0.155269f //x=53.88 //y=6.2
c664 ( 164 0 ) capacitor c=0.110375f //x=53.44 //y=6.2
c665 ( 163 0 ) capacitor c=0.110208f //x=45.16 //y=6.2
c666 ( 162 0 ) capacitor c=0.158957f //x=44.72 //y=6.2
c667 ( 155 0 ) capacitor c=5.80994e-19 //x=63.42 //y=4.88
c668 ( 146 0 ) capacitor c=5.78095e-19 //x=63.39 //y=2.26
c669 ( 129 0 ) capacitor c=0.0319332f //x=56.99 //y=5.56
c670 ( 121 0 ) capacitor c=0.0291719f //x=56.11 //y=5.56
c671 ( 116 0 ) capacitor c=5.80994e-19 //x=53.43 //y=4.88
c672 ( 107 0 ) capacitor c=5.78095e-19 //x=53.4 //y=2.26
c673 ( 102 0 ) capacitor c=0.00129098f //x=44.52 //y=4.88
c674 ( 93 0 ) capacitor c=0.0012618f //x=44.52 //y=2.26
c675 ( 85 0 ) capacitor c=0.00112471f //x=44.685 //y=4.255
c676 ( 81 0 ) capacitor c=0.0512985f //x=59.19 //y=4.27
c677 ( 80 0 ) capacitor c=0.0601433f //x=59.535 //y=4.27
c678 ( 79 0 ) capacitor c=0.0345682f //x=53.565 //y=4.25
c679 ( 78 0 ) capacitor c=0.0376575f //x=57.3 //y=4.25
c680 ( 76 0 ) capacitor c=0.00147451f //x=49.54 //y=4.265
c681 ( 74 0 ) capacitor c=0.0153988f //x=48.94 //y=4.25
c682 ( 72 0 ) capacitor c=0.00416722f //x=47.695 //y=4.265
c683 ( 70 0 ) capacitor c=0.0313219f //x=47.095 //y=4.25
c684 ( 65 0 ) capacitor c=0.00504845f //x=63.39 //y=2.26
c685 ( 62 0 ) capacitor c=0.0152588f //x=63.39 //y=4.25
c686 ( 58 0 ) capacitor c=0.015184f //x=57.47 //y=4.25
c687 ( 55 0 ) capacitor c=0.0113259f //x=57.03 //y=1.18
c688 ( 53 0 ) capacitor c=5.78613e-19 //x=56.99 //y=5.56
c689 ( 50 0 ) capacitor c=0.0106343f //x=56.99 //y=5.38
c690 ( 49 0 ) capacitor c=0.00933207f //x=56.11 //y=5.56
c691 ( 42 0 ) capacitor c=0.00504845f //x=53.4 //y=2.26
c692 ( 38 0 ) capacitor c=0.0143744f //x=53.4 //y=4.25
c693 ( 34 0 ) capacitor c=0.0159434f //x=44.52 //y=4.25
c694 ( 28 0 ) capacitor c=0.00890551f //x=63.39 //y=4.735
c695 ( 27 0 ) capacitor c=0.00982913f //x=63.39 //y=4.41
c696 ( 26 0 ) capacitor c=0.038814f //x=63.39 //y=4.09
c697 ( 24 0 ) capacitor c=0.0186547f //x=57.47 //y=5.295
c698 ( 23 0 ) capacitor c=0.0126302f //x=57.47 //y=4.425
c699 ( 22 0 ) capacitor c=0.0598541f //x=57.47 //y=4.105
c700 ( 20 0 ) capacitor c=0.00465779f //x=57.115 //y=1.835
c701 ( 19 0 ) capacitor c=0.0118867f //x=57.385 //y=1.835
c702 ( 17 0 ) capacitor c=0.0102685f //x=57.385 //y=5.38
c703 ( 16 0 ) capacitor c=0.0101547f //x=57.03 //y=1.75
c704 ( 11 0 ) capacitor c=0.0142466f //x=56.875 //y=5.38
c705 ( 8 0 ) capacitor c=0.00908133f //x=53.4 //y=4.735
c706 ( 7 0 ) capacitor c=0.0099435f //x=53.4 //y=4.415
c707 ( 6 0 ) capacitor c=0.0339717f //x=53.4 //y=4.095
c708 ( 4 0 ) capacitor c=0.0140142f //x=44.52 //y=4.755
c709 ( 3 0 ) capacitor c=0.0125845f //x=44.52 //y=4.415
c710 ( 2 0 ) capacitor c=0.0563317f //x=44.52 //y=4.095
c711 ( 1 0 ) capacitor c=0.00494847f //x=44.52 //y=2.375
r712 (  253 254 ) resistor r=32.4568 //w=0.214 //l=0.075 //layer=ply \
 //thickness=0.18 //x=63.42 //y=4.97 //x2=63.42 //y2=5.045
r713 (  251 253 ) resistor r=20.271 //w=0.214 //l=0.09 //layer=ply \
 //thickness=0.18 //x=63.42 //y=4.88 //x2=63.42 //y2=4.97
r714 (  247 248 ) resistor r=52.7279 //w=0.214 //l=0.165 //layer=ply \
 //thickness=0.18 //x=63.39 //y=2.26 //x2=63.39 //y2=2.095
r715 (  240 241 ) resistor r=32.4568 //w=0.214 //l=0.075 //layer=ply \
 //thickness=0.18 //x=53.43 //y=4.97 //x2=53.43 //y2=5.045
r716 (  238 240 ) resistor r=20.271 //w=0.214 //l=0.09 //layer=ply \
 //thickness=0.18 //x=53.43 //y=4.88 //x2=53.43 //y2=4.97
r717 (  234 235 ) resistor r=52.7279 //w=0.214 //l=0.165 //layer=ply \
 //thickness=0.18 //x=53.4 //y=2.26 //x2=53.4 //y2=2.095
r718 (  224 258 ) resistor r=45.1352 //w=0.168 //l=0.173853 //layer=ply \
 //thickness=0.18 //x=63.955 //y=1.43 //x2=63.915 //y2=1.585
r719 (  223 257 ) resistor r=45.1352 //w=0.168 //l=0.173853 //layer=ply \
 //thickness=0.18 //x=63.955 //y=1.085 //x2=63.915 //y2=0.93
r720 (  223 224 ) resistor r=176.904 //w=0.094 //l=0.345 //layer=ply \
 //thickness=0.18 //x=63.955 //y=1.085 //x2=63.955 //y2=1.43
r721 (  218 256 ) resistor r=10.701 //w=0.21 //l=0.115 //layer=ply \
 //thickness=0.18 //x=63.58 //y=1.585 //x2=63.465 //y2=1.585
r722 (  217 258 ) resistor r=5.52526 //w=0.168 //l=0.115 //layer=ply \
 //thickness=0.18 //x=63.8 //y=1.585 //x2=63.915 //y2=1.585
r723 (  216 255 ) resistor r=5.52526 //w=0.168 //l=0.115 //layer=ply \
 //thickness=0.18 //x=63.58 //y=0.93 //x2=63.465 //y2=0.93
r724 (  215 257 ) resistor r=5.52526 //w=0.168 //l=0.115 //layer=ply \
 //thickness=0.18 //x=63.8 //y=0.93 //x2=63.915 //y2=0.93
r725 (  215 216 ) resistor r=112.809 //w=0.094 //l=0.22 //layer=ply \
 //thickness=0.18 //x=63.8 //y=0.93 //x2=63.58 //y2=0.93
r726 (  214 253 ) resistor r=16.5046 //w=0.27 //l=0.135 //layer=ply \
 //thickness=0.18 //x=63.555 //y=4.97 //x2=63.42 //y2=4.97
r727 (  213 220 ) resistor r=26.9307 //w=0.15 //l=0.106066 //layer=ply \
 //thickness=0.18 //x=63.795 //y=4.97 //x2=63.87 //y2=5.045
r728 (  213 214 ) resistor r=123.064 //w=0.094 //l=0.24 //layer=ply \
 //thickness=0.18 //x=63.795 //y=4.97 //x2=63.555 //y2=4.97
r729 (  208 256 ) resistor r=39.5823 //w=0.21 //l=0.173853 //layer=ply \
 //thickness=0.18 //x=63.425 //y=1.74 //x2=63.465 //y2=1.585
r730 (  208 248 ) resistor r=182.032 //w=0.094 //l=0.355 //layer=ply \
 //thickness=0.18 //x=63.425 //y=1.74 //x2=63.425 //y2=2.095
r731 (  207 256 ) resistor r=39.5823 //w=0.21 //l=0.173853 //layer=ply \
 //thickness=0.18 //x=63.425 //y=1.43 //x2=63.465 //y2=1.585
r732 (  206 255 ) resistor r=45.1352 //w=0.168 //l=0.173853 //layer=ply \
 //thickness=0.18 //x=63.425 //y=1.085 //x2=63.465 //y2=0.93
r733 (  206 207 ) resistor r=176.904 //w=0.094 //l=0.345 //layer=ply \
 //thickness=0.18 //x=63.425 //y=1.085 //x2=63.425 //y2=1.43
r734 (  205 245 ) resistor r=45.1352 //w=0.168 //l=0.173853 //layer=ply \
 //thickness=0.18 //x=53.965 //y=1.43 //x2=53.925 //y2=1.585
r735 (  204 244 ) resistor r=45.1352 //w=0.168 //l=0.173853 //layer=ply \
 //thickness=0.18 //x=53.965 //y=1.085 //x2=53.925 //y2=0.93
r736 (  204 205 ) resistor r=176.904 //w=0.094 //l=0.345 //layer=ply \
 //thickness=0.18 //x=53.965 //y=1.085 //x2=53.965 //y2=1.43
r737 (  199 243 ) resistor r=10.701 //w=0.21 //l=0.115 //layer=ply \
 //thickness=0.18 //x=53.59 //y=1.585 //x2=53.475 //y2=1.585
r738 (  198 245 ) resistor r=5.52526 //w=0.168 //l=0.115 //layer=ply \
 //thickness=0.18 //x=53.81 //y=1.585 //x2=53.925 //y2=1.585
r739 (  197 242 ) resistor r=5.52526 //w=0.168 //l=0.115 //layer=ply \
 //thickness=0.18 //x=53.59 //y=0.93 //x2=53.475 //y2=0.93
r740 (  196 244 ) resistor r=5.52526 //w=0.168 //l=0.115 //layer=ply \
 //thickness=0.18 //x=53.81 //y=0.93 //x2=53.925 //y2=0.93
r741 (  196 197 ) resistor r=112.809 //w=0.094 //l=0.22 //layer=ply \
 //thickness=0.18 //x=53.81 //y=0.93 //x2=53.59 //y2=0.93
r742 (  195 240 ) resistor r=16.5046 //w=0.27 //l=0.135 //layer=ply \
 //thickness=0.18 //x=53.565 //y=4.97 //x2=53.43 //y2=4.97
r743 (  194 201 ) resistor r=26.9307 //w=0.15 //l=0.106066 //layer=ply \
 //thickness=0.18 //x=53.805 //y=4.97 //x2=53.88 //y2=5.045
r744 (  194 195 ) resistor r=123.064 //w=0.094 //l=0.24 //layer=ply \
 //thickness=0.18 //x=53.805 //y=4.97 //x2=53.565 //y2=4.97
r745 (  189 243 ) resistor r=39.5823 //w=0.21 //l=0.173853 //layer=ply \
 //thickness=0.18 //x=53.435 //y=1.74 //x2=53.475 //y2=1.585
r746 (  189 235 ) resistor r=182.032 //w=0.094 //l=0.355 //layer=ply \
 //thickness=0.18 //x=53.435 //y=1.74 //x2=53.435 //y2=2.095
r747 (  188 243 ) resistor r=39.5823 //w=0.21 //l=0.173853 //layer=ply \
 //thickness=0.18 //x=53.435 //y=1.43 //x2=53.475 //y2=1.585
r748 (  187 242 ) resistor r=45.1352 //w=0.168 //l=0.173853 //layer=ply \
 //thickness=0.18 //x=53.435 //y=1.085 //x2=53.475 //y2=0.93
r749 (  187 188 ) resistor r=176.904 //w=0.094 //l=0.345 //layer=ply \
 //thickness=0.18 //x=53.435 //y=1.085 //x2=53.435 //y2=1.43
r750 (  182 184 ) resistor r=26.9307 //w=0.15 //l=0.106066 //layer=ply \
 //thickness=0.18 //x=45.085 //y=4.97 //x2=45.16 //y2=5.045
r751 (  182 183 ) resistor r=148.702 //w=0.094 //l=0.29 //layer=ply \
 //thickness=0.18 //x=45.085 //y=4.97 //x2=44.795 //y2=4.97
r752 (  181 232 ) resistor r=45.1352 //w=0.168 //l=0.173853 //layer=ply \
 //thickness=0.18 //x=44.75 //y=1.4 //x2=44.71 //y2=1.555
r753 (  180 231 ) resistor r=45.1352 //w=0.168 //l=0.173853 //layer=ply \
 //thickness=0.18 //x=44.75 //y=1.055 //x2=44.71 //y2=0.9
r754 (  180 181 ) resistor r=176.904 //w=0.094 //l=0.345 //layer=ply \
 //thickness=0.18 //x=44.75 //y=1.055 //x2=44.75 //y2=1.4
r755 (  177 183 ) resistor r=22.7971 //w=0.269 //l=0.106066 //layer=ply \
 //thickness=0.18 //x=44.72 //y=5.045 //x2=44.795 //y2=4.97
r756 (  177 230 ) resistor r=35.8364 //w=0.269 //l=0.270185 //layer=ply \
 //thickness=0.18 //x=44.72 //y=5.045 //x2=44.52 //y2=4.88
r757 (  175 226 ) resistor r=10.701 //w=0.21 //l=0.115 //layer=ply \
 //thickness=0.18 //x=44.375 //y=1.555 //x2=44.26 //y2=1.555
r758 (  174 232 ) resistor r=5.52526 //w=0.168 //l=0.115 //layer=ply \
 //thickness=0.18 //x=44.595 //y=1.555 //x2=44.71 //y2=1.555
r759 (  173 225 ) resistor r=5.52526 //w=0.168 //l=0.115 //layer=ply \
 //thickness=0.18 //x=44.375 //y=0.9 //x2=44.26 //y2=0.9
r760 (  172 231 ) resistor r=5.52526 //w=0.168 //l=0.115 //layer=ply \
 //thickness=0.18 //x=44.595 //y=0.9 //x2=44.71 //y2=0.9
r761 (  172 173 ) resistor r=112.809 //w=0.094 //l=0.22 //layer=ply \
 //thickness=0.18 //x=44.595 //y=0.9 //x2=44.375 //y2=0.9
r762 (  171 228 ) resistor r=58.7805 //w=0.246 //l=0.373497 //layer=ply \
 //thickness=0.18 //x=44.22 //y=2.095 //x2=44.52 //y2=2.26
r763 (  170 226 ) resistor r=39.5823 //w=0.21 //l=0.173853 //layer=ply \
 //thickness=0.18 //x=44.22 //y=1.71 //x2=44.26 //y2=1.555
r764 (  170 171 ) resistor r=197.415 //w=0.094 //l=0.385 //layer=ply \
 //thickness=0.18 //x=44.22 //y=1.71 //x2=44.22 //y2=2.095
r765 (  169 226 ) resistor r=39.5823 //w=0.21 //l=0.173853 //layer=ply \
 //thickness=0.18 //x=44.22 //y=1.4 //x2=44.26 //y2=1.555
r766 (  168 225 ) resistor r=45.1352 //w=0.168 //l=0.173853 //layer=ply \
 //thickness=0.18 //x=44.22 //y=1.055 //x2=44.26 //y2=0.9
r767 (  168 169 ) resistor r=176.904 //w=0.094 //l=0.345 //layer=ply \
 //thickness=0.18 //x=44.22 //y=1.055 //x2=44.22 //y2=1.4
r768 (  167 220 ) resistor r=592.245 //w=0.094 //l=1.155 //layer=ply \
 //thickness=0.18 //x=63.87 //y=6.2 //x2=63.87 //y2=5.045
r769 (  166 254 ) resistor r=592.245 //w=0.094 //l=1.155 //layer=ply \
 //thickness=0.18 //x=63.43 //y=6.2 //x2=63.43 //y2=5.045
r770 (  165 201 ) resistor r=592.245 //w=0.094 //l=1.155 //layer=ply \
 //thickness=0.18 //x=53.88 //y=6.2 //x2=53.88 //y2=5.045
r771 (  164 241 ) resistor r=592.245 //w=0.094 //l=1.155 //layer=ply \
 //thickness=0.18 //x=53.44 //y=6.2 //x2=53.44 //y2=5.045
r772 (  163 184 ) resistor r=592.245 //w=0.094 //l=1.155 //layer=ply \
 //thickness=0.18 //x=45.16 //y=6.2 //x2=45.16 //y2=5.045
r773 (  162 177 ) resistor r=592.245 //w=0.094 //l=1.155 //layer=ply \
 //thickness=0.18 //x=44.72 //y=6.2 //x2=44.72 //y2=5.045
r774 (  161 217 ) resistor r=56.4043 //w=0.094 //l=0.11 //layer=ply \
 //thickness=0.18 //x=63.69 //y=1.585 //x2=63.8 //y2=1.585
r775 (  161 218 ) resistor r=56.4043 //w=0.094 //l=0.11 //layer=ply \
 //thickness=0.18 //x=63.69 //y=1.585 //x2=63.58 //y2=1.585
r776 (  160 198 ) resistor r=56.4043 //w=0.094 //l=0.11 //layer=ply \
 //thickness=0.18 //x=53.7 //y=1.585 //x2=53.81 //y2=1.585
r777 (  160 199 ) resistor r=56.4043 //w=0.094 //l=0.11 //layer=ply \
 //thickness=0.18 //x=53.7 //y=1.585 //x2=53.59 //y2=1.585
r778 (  159 174 ) resistor r=56.4043 //w=0.094 //l=0.11 //layer=ply \
 //thickness=0.18 //x=44.485 //y=1.555 //x2=44.595 //y2=1.555
r779 (  159 175 ) resistor r=56.4043 //w=0.094 //l=0.11 //layer=ply \
 //thickness=0.18 //x=44.485 //y=1.555 //x2=44.375 //y2=1.555
r780 (  155 251 ) resistor r=152 //w=0.17 //l=0.17 //layer=licon //count=1 \
 //x=63.42 //y=4.88 //x2=63.42 //y2=4.88
r781 (  146 247 ) resistor r=152 //w=0.17 //l=0.17 //layer=licon //count=1 \
 //x=63.39 //y=2.26 //x2=63.39 //y2=2.26
r782 (  129 262 ) resistor r=23.615 //w=0.187 //l=0.345 //layer=li \
 //thickness=0.1 //x=56.99 //y=5.56 //x2=56.99 //y2=5.905
r783 (  121 261 ) resistor r=23.615 //w=0.187 //l=0.345 //layer=li \
 //thickness=0.1 //x=56.11 //y=5.56 //x2=56.11 //y2=5.905
r784 (  116 238 ) resistor r=152 //w=0.17 //l=0.17 //layer=licon //count=1 \
 //x=53.43 //y=4.88 //x2=53.43 //y2=4.88
r785 (  107 234 ) resistor r=152 //w=0.17 //l=0.17 //layer=licon //count=1 \
 //x=53.4 //y=2.26 //x2=53.4 //y2=2.26
r786 (  102 230 ) resistor r=152 //w=0.17 //l=0.17 //layer=licon //count=1 \
 //x=44.52 //y=4.88 //x2=44.52 //y2=4.88
r787 (  93 228 ) resistor r=152 //w=0.17 //l=0.17 //layer=licon //count=1 \
 //x=44.52 //y=2.26 //x2=44.52 //y2=2.26
r788 (  83 85 ) resistor r=0.10734 //w=0.281 //l=0.16 //layer=m2 \
 //thickness=0.36 //x=44.525 //y=4.255 //x2=44.685 //y2=4.255
r789 (  81 89 ) resistor r=1.10585 //w=0.196 //l=1.7325 //layer=m2 \
 //thickness=0.36 //x=59.19 //y=4.27 //x2=57.46 //y2=4.265
r790 (  80 91 ) resistor r=2.64838 //w=0.182 //l=3.86499 //layer=m2 \
 //thickness=0.36 //x=59.535 //y=4.27 //x2=63.39 //y2=4.25
r791 (  80 81 ) resistor r=0.329198 //w=0.131 //l=0.345 //layer=m2 \
 //thickness=0.36 //x=59.535 //y=4.27 //x2=59.19 //y2=4.27
r792 (  79 87 ) resistor r=0.110608 //w=0.182 //l=0.162481 //layer=m2 \
 //thickness=0.36 //x=53.565 //y=4.25 //x2=53.405 //y2=4.255
r793 (  78 89 ) resistor r=0.104578 //w=0.196 //l=0.167332 //layer=m2 \
 //thickness=0.36 //x=57.3 //y=4.25 //x2=57.46 //y2=4.265
r794 (  78 79 ) resistor r=3.56393 //w=0.131 //l=3.735 //layer=m2 \
 //thickness=0.36 //x=57.3 //y=4.25 //x2=53.565 //y2=4.25
r795 (  76 87 ) resistor r=2.65525 //w=0.182 //l=3.87 //layer=m2 \
 //thickness=0.36 //x=49.54 //y=4.265 //x2=53.405 //y2=4.255
r796 (  76 77 ) resistor r=0.329198 //w=0.131 //l=0.345 //layer=m2 \
 //thickness=0.36 //x=49.54 //y=4.265 //x2=49.195 //y2=4.265
r797 (  74 77 ) resistor r=0.1875 //w=0.17 //l=0.262393 //layer=m2 \
 //thickness=0.36 //x=48.94 //y=4.25 //x2=49.195 //y2=4.265
r798 (  74 75 ) resistor r=1.02576 //w=0.131 //l=1.075 //layer=m2 \
 //thickness=0.36 //x=48.94 //y=4.25 //x2=47.865 //y2=4.25
r799 (  72 75 ) resistor r=0.125 //w=0.17 //l=0.177341 //layer=m2 \
 //thickness=0.36 //x=47.695 //y=4.265 //x2=47.865 //y2=4.25
r800 (  72 73 ) resistor r=0.329198 //w=0.131 //l=0.345 //layer=m2 \
 //thickness=0.36 //x=47.695 //y=4.265 //x2=47.35 //y2=4.265
r801 (  70 73 ) resistor r=0.1875 //w=0.17 //l=0.262393 //layer=m2 \
 //thickness=0.36 //x=47.095 //y=4.25 //x2=47.35 //y2=4.265
r802 (  70 85 ) resistor r=2.29962 //w=0.131 //l=2.41 //layer=m2 \
 //thickness=0.36 //x=47.095 //y=4.25 //x2=44.685 //y2=4.25
r803 (  69 155 ) resistor r=9.3 //w=0.17 //l=0.17 //layer=mcon //count=1 \
 //x=63.42 //y=4.88 //x2=63.42 //y2=4.88
r804 (  65 146 ) resistor r=9.3 //w=0.17 //l=0.17 //layer=mcon //count=1 \
 //x=63.39 //y=2.26 //x2=63.39 //y2=2.26
r805 (  65 67 ) resistor r=0.0936408 //w=0.196 //l=0.125 //layer=m1 \
 //thickness=0.36 //x=63.392 //y=2.26 //x2=63.392 //y2=2.385
r806 (  62 91 ) resistor r=4.5 //w=0.15 //l=0.15 //layer=via1 //count=1 \
 //x=63.39 //y=4.25 //x2=63.39 //y2=4.25
r807 (  60 89 ) resistor r=4.5 //w=0.15 //l=0.15 //layer=via1 //count=1 \
 //x=57.46 //y=4.265 //x2=57.46 //y2=4.265
r808 (  58 60 ) resistor r=0.00505391 //w=0.371 //l=0.015 //layer=m1 \
 //thickness=0.36 //x=57.412 //y=4.25 //x2=57.412 //y2=4.265
r809 (  55 259 ) resistor r=9.3 //w=0.17 //l=0.17 //layer=mcon //count=1 \
 //x=57.03 //y=1.18 //x2=57.03 //y2=1.18
r810 (  53 129 ) resistor r=9.3 //w=0.17 //l=0.17 //layer=mcon //count=1 \
 //x=56.99 //y=5.56 //x2=56.99 //y2=5.56
r811 (  50 53 ) resistor r=0.117801 //w=0.191 //l=0.18 //layer=m1 \
 //thickness=0.36 //x=56.99 //y=5.38 //x2=56.99 //y2=5.56
r812 (  49 121 ) resistor r=9.3 //w=0.17 //l=0.17 //layer=mcon //count=1 \
 //x=56.11 //y=5.56 //x2=56.11 //y2=5.56
r813 (  47 49 ) resistor r=0.10274 //w=0.219 //l=0.18 //layer=m1 \
 //thickness=0.36 //x=56.11 //y=5.38 //x2=56.11 //y2=5.56
r814 (  46 116 ) resistor r=9.3 //w=0.17 //l=0.17 //layer=mcon //count=1 \
 //x=53.43 //y=4.88 //x2=53.43 //y2=4.88
r815 (  42 107 ) resistor r=9.3 //w=0.17 //l=0.17 //layer=mcon //count=1 \
 //x=53.4 //y=2.26 //x2=53.4 //y2=2.26
r816 (  42 44 ) resistor r=0.0936408 //w=0.196 //l=0.125 //layer=m1 \
 //thickness=0.36 //x=53.402 //y=2.26 //x2=53.402 //y2=2.385
r817 (  40 87 ) resistor r=4.5 //w=0.15 //l=0.15 //layer=via1 //count=1 \
 //x=53.405 //y=4.255 //x2=53.405 //y2=4.255
r818 (  38 40 ) resistor r=0.00164908 //w=0.379 //l=0.005 //layer=m1 \
 //thickness=0.36 //x=53.35 //y=4.25 //x2=53.35 //y2=4.255
r819 (  36 83 ) resistor r=4.5 //w=0.15 //l=0.15 //layer=via1 //count=1 \
 //x=44.525 //y=4.255 //x2=44.525 //y2=4.255
r820 (  34 36 ) resistor r=0.00167112 //w=0.374 //l=0.005 //layer=m1 \
 //thickness=0.36 //x=44.575 //y=4.25 //x2=44.575 //y2=4.255
r821 (  32 102 ) resistor r=9.3 //w=0.17 //l=0.17 //layer=mcon //count=1 \
 //x=44.52 //y=4.88 //x2=44.52 //y2=4.88
r822 (  30 93 ) resistor r=9.3 //w=0.17 //l=0.17 //layer=mcon //count=1 \
 //x=44.52 //y=2.26 //x2=44.52 //y2=2.26
r823 (  28 69 ) resistor r=0.0878548 //w=0.228 //l=0.159295 //layer=m1 \
 //thickness=0.36 //x=63.39 //y=4.735 //x2=63.42 //y2=4.88
r824 (  27 62 ) resistor r=0.0911593 //w=0.376 //l=0.184608 //layer=m1 \
 //thickness=0.36 //x=63.39 //y=4.41 //x2=63.337 //y2=4.25
r825 (  27 28 ) resistor r=0.310115 //w=0.131 //l=0.325 //layer=m1 \
 //thickness=0.36 //x=63.39 //y=4.41 //x2=63.39 //y2=4.735
r826 (  26 62 ) resistor r=0.0911593 //w=0.376 //l=0.184608 //layer=m1 \
 //thickness=0.36 //x=63.39 //y=4.09 //x2=63.337 //y2=4.25
r827 (  26 67 ) resistor r=1.62691 //w=0.131 //l=1.705 //layer=m1 \
 //thickness=0.36 //x=63.39 //y=4.09 //x2=63.39 //y2=2.385
r828 (  23 60 ) resistor r=0.0909648 //w=0.371 //l=0.186762 //layer=m1 \
 //thickness=0.36 //x=57.47 //y=4.425 //x2=57.412 //y2=4.265
r829 (  23 24 ) resistor r=0.830153 //w=0.131 //l=0.87 //layer=m1 \
 //thickness=0.36 //x=57.47 //y=4.425 //x2=57.47 //y2=5.295
r830 (  22 58 ) resistor r=0.0859108 //w=0.371 //l=0.171566 //layer=m1 \
 //thickness=0.36 //x=57.47 //y=4.105 //x2=57.412 //y2=4.25
r831 (  21 22 ) resistor r=2.08492 //w=0.131 //l=2.185 //layer=m1 \
 //thickness=0.36 //x=57.47 //y=1.92 //x2=57.47 //y2=4.105
r832 (  19 21 ) resistor r=0.0698411 //w=0.17 //l=0.120208 //layer=m1 \
 //thickness=0.36 //x=57.385 //y=1.835 //x2=57.47 //y2=1.92
r833 (  19 20 ) resistor r=0.257634 //w=0.131 //l=0.27 //layer=m1 \
 //thickness=0.36 //x=57.385 //y=1.835 //x2=57.115 //y2=1.835
r834 (  18 50 ) resistor r=0.0257089 //w=0.23 //l=0.115 //layer=m1 \
 //thickness=0.36 //x=57.105 //y=5.38 //x2=56.99 //y2=5.38
r835 (  17 24 ) resistor r=0.0698411 //w=0.17 //l=0.120208 //layer=m1 \
 //thickness=0.36 //x=57.385 //y=5.38 //x2=57.47 //y2=5.295
r836 (  17 18 ) resistor r=0.267176 //w=0.131 //l=0.28 //layer=m1 \
 //thickness=0.36 //x=57.385 //y=5.38 //x2=57.105 //y2=5.38
r837 (  16 20 ) resistor r=0.0698411 //w=0.17 //l=0.120208 //layer=m1 \
 //thickness=0.36 //x=57.03 //y=1.75 //x2=57.115 //y2=1.835
r838 (  15 55 ) resistor r=0.0913624 //w=0.191 //l=0.12 //layer=m1 \
 //thickness=0.36 //x=57.03 //y=1.3 //x2=57.03 //y2=1.18
r839 (  15 16 ) resistor r=0.429389 //w=0.131 //l=0.45 //layer=m1 \
 //thickness=0.36 //x=57.03 //y=1.3 //x2=57.03 //y2=1.75
r840 (  12 47 ) resistor r=0.0227762 //w=0.219 //l=0.115 //layer=m1 \
 //thickness=0.36 //x=56.225 //y=5.38 //x2=56.11 //y2=5.38
r841 (  11 50 ) resistor r=0.0257089 //w=0.23 //l=0.115 //layer=m1 \
 //thickness=0.36 //x=56.875 //y=5.38 //x2=56.99 //y2=5.38
r842 (  11 12 ) resistor r=0.620229 //w=0.131 //l=0.65 //layer=m1 \
 //thickness=0.36 //x=56.875 //y=5.38 //x2=56.225 //y2=5.38
r843 (  8 46 ) resistor r=0.0878548 //w=0.228 //l=0.159295 //layer=m1 \
 //thickness=0.36 //x=53.4 //y=4.735 //x2=53.43 //y2=4.88
r844 (  7 40 ) resistor r=0.0912814 //w=0.379 //l=0.183303 //layer=m1 \
 //thickness=0.36 //x=53.4 //y=4.415 //x2=53.35 //y2=4.255
r845 (  7 8 ) resistor r=0.305344 //w=0.131 //l=0.32 //layer=m1 \
 //thickness=0.36 //x=53.4 //y=4.415 //x2=53.4 //y2=4.735
r846 (  6 38 ) resistor r=0.0896323 //w=0.379 //l=0.178255 //layer=m1 \
 //thickness=0.36 //x=53.4 //y=4.095 //x2=53.35 //y2=4.25
r847 (  6 44 ) resistor r=1.63168 //w=0.131 //l=1.71 //layer=m1 \
 //thickness=0.36 //x=53.4 //y=4.095 //x2=53.4 //y2=2.385
r848 (  4 32 ) resistor r=0.0760407 //w=0.238 //l=0.125 //layer=m1 \
 //thickness=0.36 //x=44.52 //y=4.755 //x2=44.52 //y2=4.88
r849 (  3 36 ) resistor r=0.0910802 //w=0.374 //l=0.185472 //layer=m1 \
 //thickness=0.36 //x=44.52 //y=4.415 //x2=44.575 //y2=4.255
r850 (  3 4 ) resistor r=0.324427 //w=0.131 //l=0.34 //layer=m1 \
 //thickness=0.36 //x=44.52 //y=4.415 //x2=44.52 //y2=4.755
r851 (  2 34 ) resistor r=0.089409 //w=0.374 //l=0.180416 //layer=m1 \
 //thickness=0.36 //x=44.52 //y=4.095 //x2=44.575 //y2=4.25
r852 (  1 30 ) resistor r=0.0719237 //w=0.222 //l=0.115 //layer=m1 \
 //thickness=0.36 //x=44.52 //y=2.375 //x2=44.52 //y2=2.26
r853 (  1 2 ) resistor r=1.64122 //w=0.131 //l=1.72 //layer=m1 \
 //thickness=0.36 //x=44.52 //y=2.375 //x2=44.52 //y2=4.095
ends PM_TMRDFFQX1\%noxref_17

subckt PM_TMRDFFQX1\%noxref_18 ( 2 3 4 7 12 13 15 16 18 19 20 21 22 23 24 25 \
 26 28 36 39 40 43 45 48 52 58 61 66 68 71 73 77 81 82 88 89 92 101 106 114 \
 131 140 146 151 156 157 158 159 160 161 162 163 164 165 166 167 172 174 176 \
 182 183 184 185 186 187 191 193 196 197 198 199 203 204 205 206 210 212 218 \
 219 221 222 225 234 247 250 252 253 )
c556 ( 250 0 ) capacitor c=0.00878249f //x=63.5 //y=1.085
c557 ( 247 0 ) capacitor c=0.0692896f //x=69.31 //y=4.885
c558 ( 234 0 ) capacitor c=0.0603371f //x=65.61 //y=2.26
c559 ( 225 0 ) capacitor c=0.0363183f //x=60.09 //y=4.88
c560 ( 222 0 ) capacitor c=0.0284095f //x=60.06 //y=2.095
c561 ( 221 0 ) capacitor c=0.0476356f //x=60.06 //y=2.26
c562 ( 219 0 ) capacitor c=0.0344584f //x=69.645 //y=1.39
c563 ( 218 0 ) capacitor c=0.0186809f //x=69.645 //y=1.045
c564 ( 212 0 ) capacitor c=0.0141797f //x=69.49 //y=1.545
c565 ( 210 0 ) capacitor c=0.0158553f //x=69.49 //y=0.89
c566 ( 206 0 ) capacitor c=0.103881f //x=69.115 //y=2.095
c567 ( 205 0 ) capacitor c=0.0227978f //x=69.115 //y=1.7
c568 ( 204 0 ) capacitor c=0.0234352f //x=69.115 //y=1.39
c569 ( 203 0 ) capacitor c=0.0198759f //x=69.115 //y=1.045
c570 ( 199 0 ) capacitor c=0.0318956f //x=66.315 //y=1.39
c571 ( 198 0 ) capacitor c=0.0186809f //x=66.315 //y=1.045
c572 ( 197 0 ) capacitor c=0.061583f //x=65.955 //y=4.975
c573 ( 196 0 ) capacitor c=0.0375163f //x=66.245 //y=4.975
c574 ( 193 0 ) capacitor c=0.0157936f //x=66.16 //y=1.545
c575 ( 191 0 ) capacitor c=0.0158553f //x=66.16 //y=0.89
c576 ( 187 0 ) capacitor c=0.0302441f //x=65.785 //y=2.095
c577 ( 186 0 ) capacitor c=0.0238107f //x=65.785 //y=1.7
c578 ( 185 0 ) capacitor c=0.0234359f //x=65.785 //y=1.39
c579 ( 184 0 ) capacitor c=0.0199332f //x=65.785 //y=1.045
c580 ( 183 0 ) capacitor c=0.0439708f //x=60.625 //y=1.43
c581 ( 182 0 ) capacitor c=0.0192582f //x=60.625 //y=1.085
c582 ( 176 0 ) capacitor c=0.0162526f //x=60.47 //y=1.585
c583 ( 174 0 ) capacitor c=0.0157807f //x=60.47 //y=0.93
c584 ( 172 0 ) capacitor c=0.0359568f //x=60.465 //y=4.97
c585 ( 167 0 ) capacitor c=0.0210762f //x=60.095 //y=1.74
c586 ( 166 0 ) capacitor c=0.0168511f //x=60.095 //y=1.43
c587 ( 165 0 ) capacitor c=0.0175485f //x=60.095 //y=1.085
c588 ( 164 0 ) capacitor c=0.111167f //x=69.64 //y=6.205
c589 ( 163 0 ) capacitor c=0.154978f //x=69.2 //y=6.205
c590 ( 162 0 ) capacitor c=0.110282f //x=66.32 //y=6.205
c591 ( 161 0 ) capacitor c=0.155219f //x=65.88 //y=6.205
c592 ( 160 0 ) capacitor c=0.155269f //x=60.54 //y=6.2
c593 ( 159 0 ) capacitor c=0.110375f //x=60.1 //y=6.2
c594 ( 151 0 ) capacitor c=0.0156727f //x=69.31 //y=4.62
c595 ( 146 0 ) capacitor c=0.00126053f //x=69.31 //y=2.26
c596 ( 140 0 ) capacitor c=0.0117308f //x=65.61 //y=4.62
c597 ( 131 0 ) capacitor c=9.32025e-19 //x=65.61 //y=2.26
c598 ( 114 0 ) capacitor c=0.0320929f //x=63.65 //y=5.56
c599 ( 106 0 ) capacitor c=0.028968f //x=62.77 //y=5.56
c600 ( 101 0 ) capacitor c=0.00106022f //x=60.09 //y=4.88
c601 ( 92 0 ) capacitor c=5.78095e-19 //x=60.06 //y=2.26
c602 ( 89 0 ) capacitor c=0.0745476f //x=69.155 //y=4.64
c603 ( 88 0 ) capacitor c=0.00642399f //x=69.315 //y=4.64
c604 ( 82 0 ) capacitor c=0.0409269f //x=65.445 //y=3.89
c605 ( 81 0 ) capacitor c=0.00114404f //x=65.605 //y=3.89
c606 ( 77 0 ) capacitor c=7.51531e-19 //x=60.22 //y=3.865
c607 ( 73 0 ) capacitor c=0.00530163f //x=65.775 //y=4.62
c608 ( 71 0 ) capacitor c=0.0120646f //x=64.28 //y=3.88
c609 ( 68 0 ) capacitor c=0.00389639f //x=63.605 //y=3.865
c610 ( 66 0 ) capacitor c=0.0377205f //x=63.005 //y=3.88
c611 ( 61 0 ) capacitor c=0.0127992f //x=69.31 //y=4.62
c612 ( 58 0 ) capacitor c=0.0126133f //x=65.61 //y=4.62
c613 ( 52 0 ) capacitor c=0.0159232f //x=65.61 //y=3.88
c614 ( 48 0 ) capacitor c=0.0168651f //x=64.13 //y=3.88
c615 ( 45 0 ) capacitor c=0.0113351f //x=63.69 //y=1.18
c616 ( 43 0 ) capacitor c=5.78613e-19 //x=63.65 //y=5.56
c617 ( 40 0 ) capacitor c=0.0114734f //x=63.65 //y=5.38
c618 ( 39 0 ) capacitor c=0.00880986f //x=62.77 //y=5.56
c619 ( 36 0 ) capacitor c=0.0139575f //x=60.06 //y=3.88
c620 ( 28 0 ) capacitor c=0.00504845f //x=60.06 //y=2.26
c621 ( 26 0 ) capacitor c=0.0794622f //x=69.31 //y=4.475
c622 ( 25 0 ) capacitor c=0.00874893f //x=69.31 //y=2.385
c623 ( 24 0 ) capacitor c=0.0090702f //x=65.61 //y=4.46
c624 ( 23 0 ) capacitor c=0.0122102f //x=65.61 //y=4.05
c625 ( 22 0 ) capacitor c=0.0400972f //x=65.61 //y=3.73
c626 ( 21 0 ) capacitor c=0.00384805f //x=65.61 //y=2.375
c627 ( 20 0 ) capacitor c=0.0287298f //x=64.13 //y=5.295
c628 ( 19 0 ) capacitor c=0.0124868f //x=64.13 //y=4.05
c629 ( 18 0 ) capacitor c=0.0501009f //x=64.13 //y=3.73
c630 ( 16 0 ) capacitor c=0.00465779f //x=63.775 //y=1.835
c631 ( 15 0 ) capacitor c=0.013052f //x=64.045 //y=1.835
c632 ( 13 0 ) capacitor c=0.0114761f //x=64.045 //y=5.38
c633 ( 12 0 ) capacitor c=0.0115202f //x=63.69 //y=1.75
c634 ( 7 0 ) capacitor c=0.0136628f //x=63.535 //y=5.38
c635 ( 4 0 ) capacitor c=0.0165616f //x=60.06 //y=4.735
c636 ( 3 0 ) capacitor c=0.00983135f //x=60.06 //y=4.025
c637 ( 2 0 ) capacitor c=0.0313844f //x=60.06 //y=3.705
r638 (  245 247 ) resistor r=22.7554 //w=0.233 //l=0.11 //layer=ply \
 //thickness=0.18 //x=69.2 //y=4.885 //x2=69.31 //y2=4.885
r639 (  227 228 ) resistor r=32.4568 //w=0.214 //l=0.075 //layer=ply \
 //thickness=0.18 //x=60.09 //y=4.97 //x2=60.09 //y2=5.045
r640 (  225 227 ) resistor r=20.271 //w=0.214 //l=0.09 //layer=ply \
 //thickness=0.18 //x=60.09 //y=4.88 //x2=60.09 //y2=4.97
r641 (  221 222 ) resistor r=52.7279 //w=0.214 //l=0.165 //layer=ply \
 //thickness=0.18 //x=60.06 //y=2.26 //x2=60.06 //y2=2.095
r642 (  219 249 ) resistor r=45.1352 //w=0.168 //l=0.173853 //layer=ply \
 //thickness=0.18 //x=69.645 //y=1.39 //x2=69.605 //y2=1.545
r643 (  218 248 ) resistor r=45.1352 //w=0.168 //l=0.173853 //layer=ply \
 //thickness=0.18 //x=69.645 //y=1.045 //x2=69.605 //y2=0.89
r644 (  218 219 ) resistor r=176.904 //w=0.094 //l=0.345 //layer=ply \
 //thickness=0.18 //x=69.645 //y=1.045 //x2=69.645 //y2=1.39
r645 (  215 247 ) resistor r=68.2661 //w=0.233 //l=0.404166 //layer=ply \
 //thickness=0.18 //x=69.64 //y=5.05 //x2=69.31 //y2=4.885
r646 (  213 244 ) resistor r=10.701 //w=0.21 //l=0.115 //layer=ply \
 //thickness=0.18 //x=69.27 //y=1.545 //x2=69.155 //y2=1.545
r647 (  212 249 ) resistor r=5.52526 //w=0.168 //l=0.115 //layer=ply \
 //thickness=0.18 //x=69.49 //y=1.545 //x2=69.605 //y2=1.545
r648 (  211 243 ) resistor r=5.52526 //w=0.168 //l=0.115 //layer=ply \
 //thickness=0.18 //x=69.27 //y=0.89 //x2=69.155 //y2=0.89
r649 (  210 248 ) resistor r=5.52526 //w=0.168 //l=0.115 //layer=ply \
 //thickness=0.18 //x=69.49 //y=0.89 //x2=69.605 //y2=0.89
r650 (  210 211 ) resistor r=112.809 //w=0.094 //l=0.22 //layer=ply \
 //thickness=0.18 //x=69.49 //y=0.89 //x2=69.27 //y2=0.89
r651 (  207 245 ) resistor r=13.0941 //w=0.233 //l=0.165 //layer=ply \
 //thickness=0.18 //x=69.2 //y=5.05 //x2=69.2 //y2=4.885
r652 (  206 242 ) resistor r=34.8111 //w=0.27 //l=0.264953 //layer=ply \
 //thickness=0.18 //x=69.115 //y=2.095 //x2=69.31 //y2=2.26
r653 (  205 244 ) resistor r=39.5823 //w=0.21 //l=0.173853 //layer=ply \
 //thickness=0.18 //x=69.115 //y=1.7 //x2=69.155 //y2=1.545
r654 (  205 206 ) resistor r=202.543 //w=0.094 //l=0.395 //layer=ply \
 //thickness=0.18 //x=69.115 //y=1.7 //x2=69.115 //y2=2.095
r655 (  204 244 ) resistor r=39.5823 //w=0.21 //l=0.173853 //layer=ply \
 //thickness=0.18 //x=69.115 //y=1.39 //x2=69.155 //y2=1.545
r656 (  203 243 ) resistor r=45.1352 //w=0.168 //l=0.173853 //layer=ply \
 //thickness=0.18 //x=69.115 //y=1.045 //x2=69.155 //y2=0.89
r657 (  203 204 ) resistor r=176.904 //w=0.094 //l=0.345 //layer=ply \
 //thickness=0.18 //x=69.115 //y=1.045 //x2=69.115 //y2=1.39
r658 (  199 240 ) resistor r=45.1352 //w=0.168 //l=0.173853 //layer=ply \
 //thickness=0.18 //x=66.315 //y=1.39 //x2=66.275 //y2=1.545
r659 (  198 239 ) resistor r=45.1352 //w=0.168 //l=0.173853 //layer=ply \
 //thickness=0.18 //x=66.315 //y=1.045 //x2=66.275 //y2=0.89
r660 (  198 199 ) resistor r=176.904 //w=0.094 //l=0.345 //layer=ply \
 //thickness=0.18 //x=66.315 //y=1.045 //x2=66.315 //y2=1.39
r661 (  196 200 ) resistor r=26.9307 //w=0.15 //l=0.106066 //layer=ply \
 //thickness=0.18 //x=66.245 //y=4.975 //x2=66.32 //y2=5.05
r662 (  196 197 ) resistor r=148.702 //w=0.094 //l=0.29 //layer=ply \
 //thickness=0.18 //x=66.245 //y=4.975 //x2=65.955 //y2=4.975
r663 (  194 238 ) resistor r=10.701 //w=0.21 //l=0.115 //layer=ply \
 //thickness=0.18 //x=65.94 //y=1.545 //x2=65.825 //y2=1.545
r664 (  193 240 ) resistor r=5.52526 //w=0.168 //l=0.115 //layer=ply \
 //thickness=0.18 //x=66.16 //y=1.545 //x2=66.275 //y2=1.545
r665 (  192 237 ) resistor r=5.52526 //w=0.168 //l=0.115 //layer=ply \
 //thickness=0.18 //x=65.94 //y=0.89 //x2=65.825 //y2=0.89
r666 (  191 239 ) resistor r=5.52526 //w=0.168 //l=0.115 //layer=ply \
 //thickness=0.18 //x=66.16 //y=0.89 //x2=66.275 //y2=0.89
r667 (  191 192 ) resistor r=112.809 //w=0.094 //l=0.22 //layer=ply \
 //thickness=0.18 //x=66.16 //y=0.89 //x2=65.94 //y2=0.89
r668 (  188 197 ) resistor r=22.1787 //w=0.252 //l=0.106066 //layer=ply \
 //thickness=0.18 //x=65.88 //y=5.05 //x2=65.955 //y2=4.975
r669 (  188 236 ) resistor r=51.6429 //w=0.252 //l=0.34271 //layer=ply \
 //thickness=0.18 //x=65.88 //y=5.05 //x2=65.61 //y2=4.885
r670 (  187 234 ) resistor r=30.4513 //w=0.277 //l=0.243926 //layer=ply \
 //thickness=0.18 //x=65.785 //y=2.095 //x2=65.61 //y2=2.26
r671 (  186 238 ) resistor r=39.5823 //w=0.21 //l=0.173853 //layer=ply \
 //thickness=0.18 //x=65.785 //y=1.7 //x2=65.825 //y2=1.545
r672 (  186 187 ) resistor r=202.543 //w=0.094 //l=0.395 //layer=ply \
 //thickness=0.18 //x=65.785 //y=1.7 //x2=65.785 //y2=2.095
r673 (  185 238 ) resistor r=39.5823 //w=0.21 //l=0.173853 //layer=ply \
 //thickness=0.18 //x=65.785 //y=1.39 //x2=65.825 //y2=1.545
r674 (  184 237 ) resistor r=45.1352 //w=0.168 //l=0.173853 //layer=ply \
 //thickness=0.18 //x=65.785 //y=1.045 //x2=65.825 //y2=0.89
r675 (  184 185 ) resistor r=176.904 //w=0.094 //l=0.345 //layer=ply \
 //thickness=0.18 //x=65.785 //y=1.045 //x2=65.785 //y2=1.39
r676 (  183 232 ) resistor r=45.1352 //w=0.168 //l=0.173853 //layer=ply \
 //thickness=0.18 //x=60.625 //y=1.43 //x2=60.585 //y2=1.585
r677 (  182 231 ) resistor r=45.1352 //w=0.168 //l=0.173853 //layer=ply \
 //thickness=0.18 //x=60.625 //y=1.085 //x2=60.585 //y2=0.93
r678 (  182 183 ) resistor r=176.904 //w=0.094 //l=0.345 //layer=ply \
 //thickness=0.18 //x=60.625 //y=1.085 //x2=60.625 //y2=1.43
r679 (  177 230 ) resistor r=10.701 //w=0.21 //l=0.115 //layer=ply \
 //thickness=0.18 //x=60.25 //y=1.585 //x2=60.135 //y2=1.585
r680 (  176 232 ) resistor r=5.52526 //w=0.168 //l=0.115 //layer=ply \
 //thickness=0.18 //x=60.47 //y=1.585 //x2=60.585 //y2=1.585
r681 (  175 229 ) resistor r=5.52526 //w=0.168 //l=0.115 //layer=ply \
 //thickness=0.18 //x=60.25 //y=0.93 //x2=60.135 //y2=0.93
r682 (  174 231 ) resistor r=5.52526 //w=0.168 //l=0.115 //layer=ply \
 //thickness=0.18 //x=60.47 //y=0.93 //x2=60.585 //y2=0.93
r683 (  174 175 ) resistor r=112.809 //w=0.094 //l=0.22 //layer=ply \
 //thickness=0.18 //x=60.47 //y=0.93 //x2=60.25 //y2=0.93
r684 (  173 227 ) resistor r=16.5046 //w=0.27 //l=0.135 //layer=ply \
 //thickness=0.18 //x=60.225 //y=4.97 //x2=60.09 //y2=4.97
r685 (  172 179 ) resistor r=26.9307 //w=0.15 //l=0.106066 //layer=ply \
 //thickness=0.18 //x=60.465 //y=4.97 //x2=60.54 //y2=5.045
r686 (  172 173 ) resistor r=123.064 //w=0.094 //l=0.24 //layer=ply \
 //thickness=0.18 //x=60.465 //y=4.97 //x2=60.225 //y2=4.97
r687 (  167 230 ) resistor r=39.5823 //w=0.21 //l=0.173853 //layer=ply \
 //thickness=0.18 //x=60.095 //y=1.74 //x2=60.135 //y2=1.585
r688 (  167 222 ) resistor r=182.032 //w=0.094 //l=0.355 //layer=ply \
 //thickness=0.18 //x=60.095 //y=1.74 //x2=60.095 //y2=2.095
r689 (  166 230 ) resistor r=39.5823 //w=0.21 //l=0.173853 //layer=ply \
 //thickness=0.18 //x=60.095 //y=1.43 //x2=60.135 //y2=1.585
r690 (  165 229 ) resistor r=45.1352 //w=0.168 //l=0.173853 //layer=ply \
 //thickness=0.18 //x=60.095 //y=1.085 //x2=60.135 //y2=0.93
r691 (  165 166 ) resistor r=176.904 //w=0.094 //l=0.345 //layer=ply \
 //thickness=0.18 //x=60.095 //y=1.085 //x2=60.095 //y2=1.43
r692 (  164 215 ) resistor r=592.245 //w=0.094 //l=1.155 //layer=ply \
 //thickness=0.18 //x=69.64 //y=6.205 //x2=69.64 //y2=5.05
r693 (  163 207 ) resistor r=592.245 //w=0.094 //l=1.155 //layer=ply \
 //thickness=0.18 //x=69.2 //y=6.205 //x2=69.2 //y2=5.05
r694 (  162 200 ) resistor r=592.245 //w=0.094 //l=1.155 //layer=ply \
 //thickness=0.18 //x=66.32 //y=6.205 //x2=66.32 //y2=5.05
r695 (  161 188 ) resistor r=592.245 //w=0.094 //l=1.155 //layer=ply \
 //thickness=0.18 //x=65.88 //y=6.205 //x2=65.88 //y2=5.05
r696 (  160 179 ) resistor r=592.245 //w=0.094 //l=1.155 //layer=ply \
 //thickness=0.18 //x=60.54 //y=6.2 //x2=60.54 //y2=5.045
r697 (  159 228 ) resistor r=592.245 //w=0.094 //l=1.155 //layer=ply \
 //thickness=0.18 //x=60.1 //y=6.2 //x2=60.1 //y2=5.045
r698 (  158 212 ) resistor r=56.4043 //w=0.094 //l=0.11 //layer=ply \
 //thickness=0.18 //x=69.38 //y=1.545 //x2=69.49 //y2=1.545
r699 (  158 213 ) resistor r=56.4043 //w=0.094 //l=0.11 //layer=ply \
 //thickness=0.18 //x=69.38 //y=1.545 //x2=69.27 //y2=1.545
r700 (  157 193 ) resistor r=56.4043 //w=0.094 //l=0.11 //layer=ply \
 //thickness=0.18 //x=66.05 //y=1.545 //x2=66.16 //y2=1.545
r701 (  157 194 ) resistor r=56.4043 //w=0.094 //l=0.11 //layer=ply \
 //thickness=0.18 //x=66.05 //y=1.545 //x2=65.94 //y2=1.545
r702 (  156 176 ) resistor r=56.4043 //w=0.094 //l=0.11 //layer=ply \
 //thickness=0.18 //x=60.36 //y=1.585 //x2=60.47 //y2=1.585
r703 (  156 177 ) resistor r=56.4043 //w=0.094 //l=0.11 //layer=ply \
 //thickness=0.18 //x=60.36 //y=1.585 //x2=60.25 //y2=1.585
r704 (  154 247 ) resistor r=152 //w=0.17 //l=0.17 //layer=licon //count=1 \
 //x=69.31 //y=4.885 //x2=69.31 //y2=4.885
r705 (  151 154 ) resistor r=18.139 //w=0.187 //l=0.265 //layer=li \
 //thickness=0.1 //x=69.31 //y=4.62 //x2=69.31 //y2=4.885
r706 (  146 242 ) resistor r=152 //w=0.17 //l=0.17 //layer=licon //count=1 \
 //x=69.31 //y=2.26 //x2=69.31 //y2=2.26
r707 (  143 236 ) resistor r=152 //w=0.17 //l=0.17 //layer=licon //count=1 \
 //x=65.61 //y=4.885 //x2=65.61 //y2=4.885
r708 (  140 143 ) resistor r=18.139 //w=0.187 //l=0.265 //layer=li \
 //thickness=0.1 //x=65.61 //y=4.62 //x2=65.61 //y2=4.885
r709 (  131 234 ) resistor r=152 //w=0.17 //l=0.17 //layer=licon //count=1 \
 //x=65.61 //y=2.26 //x2=65.61 //y2=2.26
r710 (  114 253 ) resistor r=23.615 //w=0.187 //l=0.345 //layer=li \
 //thickness=0.1 //x=63.65 //y=5.56 //x2=63.65 //y2=5.905
r711 (  106 252 ) resistor r=23.615 //w=0.187 //l=0.345 //layer=li \
 //thickness=0.1 //x=62.77 //y=5.56 //x2=62.77 //y2=5.905
r712 (  101 225 ) resistor r=152 //w=0.17 //l=0.17 //layer=licon //count=1 \
 //x=60.09 //y=4.88 //x2=60.09 //y2=4.88
r713 (  92 221 ) resistor r=152 //w=0.17 //l=0.17 //layer=licon //count=1 \
 //x=60.06 //y=2.26 //x2=60.06 //y2=2.26
r714 (  88 89 ) resistor r=0.10734 //w=0.281 //l=0.16 //layer=m2 \
 //thickness=0.36 //x=69.315 //y=4.64 //x2=69.155 //y2=4.64
r715 (  81 82 ) resistor r=0.10734 //w=0.281 //l=0.16 //layer=m2 \
 //thickness=0.36 //x=65.605 //y=3.89 //x2=65.445 //y2=3.89
r716 (  75 77 ) resistor r=0.10734 //w=0.281 //l=0.16 //layer=m2 \
 //thickness=0.36 //x=60.06 //y=3.865 //x2=60.22 //y2=3.865
r717 (  73 85 ) resistor r=0.10734 //w=0.281 //l=0.16 //layer=m2 \
 //thickness=0.36 //x=65.775 //y=4.62 //x2=65.615 //y2=4.62
r718 (  73 89 ) resistor r=3.22519 //w=0.131 //l=3.38 //layer=m2 \
 //thickness=0.36 //x=65.775 //y=4.62 //x2=69.155 //y2=4.62
r719 (  71 79 ) resistor r=0.0938585 //w=0.242 //l=0.164924 //layer=m2 \
 //thickness=0.36 //x=64.28 //y=3.88 //x2=64.12 //y2=3.89
r720 (  71 82 ) resistor r=1.11164 //w=0.131 //l=1.165 //layer=m2 \
 //thickness=0.36 //x=64.28 //y=3.88 //x2=65.445 //y2=3.88
r721 (  68 79 ) resistor r=0.277226 //w=0.242 //l=0.527352 //layer=m2 \
 //thickness=0.36 //x=63.605 //y=3.865 //x2=64.12 //y2=3.89
r722 (  68 69 ) resistor r=0.410305 //w=0.131 //l=0.43 //layer=m2 \
 //thickness=0.36 //x=63.605 //y=3.865 //x2=63.175 //y2=3.865
r723 (  66 69 ) resistor r=0.125 //w=0.17 //l=0.177341 //layer=m2 \
 //thickness=0.36 //x=63.005 //y=3.88 //x2=63.175 //y2=3.865
r724 (  66 77 ) resistor r=2.65744 //w=0.131 //l=2.785 //layer=m2 \
 //thickness=0.36 //x=63.005 //y=3.88 //x2=60.22 //y2=3.88
r725 (  65 146 ) resistor r=9.3 //w=0.17 //l=0.17 //layer=mcon //count=1 \
 //x=69.31 //y=2.26 //x2=69.31 //y2=2.26
r726 (  63 88 ) resistor r=4.5 //w=0.15 //l=0.15 //layer=via1 //count=1 \
 //x=69.315 //y=4.64 //x2=69.315 //y2=4.64
r727 (  61 151 ) resistor r=9.3 //w=0.17 //l=0.17 //layer=mcon //count=1 \
 //x=69.31 //y=4.62 //x2=69.31 //y2=4.62
r728 (  61 63 ) resistor r=0.00659631 //w=0.379 //l=0.02 //layer=m1 \
 //thickness=0.36 //x=69.26 //y=4.62 //x2=69.26 //y2=4.64
r729 (  58 140 ) resistor r=9.3 //w=0.17 //l=0.17 //layer=mcon //count=1 \
 //x=65.61 //y=4.62 //x2=65.61 //y2=4.62
r730 (  58 85 ) resistor r=4.5 //w=0.15 //l=0.15 //layer=via1 //count=1 \
 //x=65.615 //y=4.62 //x2=65.615 //y2=4.62
r731 (  56 131 ) resistor r=9.3 //w=0.17 //l=0.17 //layer=mcon //count=1 \
 //x=65.61 //y=2.26 //x2=65.61 //y2=2.26
r732 (  54 81 ) resistor r=4.5 //w=0.15 //l=0.15 //layer=via1 //count=1 \
 //x=65.605 //y=3.89 //x2=65.605 //y2=3.89
r733 (  52 54 ) resistor r=0.00334225 //w=0.374 //l=0.01 //layer=m1 \
 //thickness=0.36 //x=65.555 //y=3.88 //x2=65.555 //y2=3.89
r734 (  50 79 ) resistor r=4.5 //w=0.15 //l=0.15 //layer=via1 //count=1 \
 //x=64.12 //y=3.89 //x2=64.12 //y2=3.89
r735 (  48 50 ) resistor r=0.00327225 //w=0.382 //l=0.01 //layer=m1 \
 //thickness=0.36 //x=64.177 //y=3.88 //x2=64.177 //y2=3.89
r736 (  45 250 ) resistor r=9.3 //w=0.17 //l=0.17 //layer=mcon //count=1 \
 //x=63.69 //y=1.18 //x2=63.69 //y2=1.18
r737 (  43 114 ) resistor r=9.3 //w=0.17 //l=0.17 //layer=mcon //count=1 \
 //x=63.65 //y=5.56 //x2=63.65 //y2=5.56
r738 (  40 43 ) resistor r=0.117801 //w=0.191 //l=0.18 //layer=m1 \
 //thickness=0.36 //x=63.65 //y=5.38 //x2=63.65 //y2=5.56
r739 (  39 106 ) resistor r=9.3 //w=0.17 //l=0.17 //layer=mcon //count=1 \
 //x=62.77 //y=5.56 //x2=62.77 //y2=5.56
r740 (  37 39 ) resistor r=0.10274 //w=0.219 //l=0.18 //layer=m1 \
 //thickness=0.36 //x=62.77 //y=5.38 //x2=62.77 //y2=5.56
r741 (  34 75 ) resistor r=4.5 //w=0.15 //l=0.15 //layer=via1 //count=1 \
 //x=60.06 //y=3.865 //x2=60.06 //y2=3.865
r742 (  34 36 ) resistor r=0.0049867 //w=0.376 //l=0.015 //layer=m1 \
 //thickness=0.36 //x=60.112 //y=3.865 //x2=60.112 //y2=3.88
r743 (  32 101 ) resistor r=9.3 //w=0.17 //l=0.17 //layer=mcon //count=1 \
 //x=60.09 //y=4.88 //x2=60.09 //y2=4.88
r744 (  28 92 ) resistor r=9.3 //w=0.17 //l=0.17 //layer=mcon //count=1 \
 //x=60.06 //y=2.26 //x2=60.06 //y2=2.26
r745 (  28 30 ) resistor r=0.0936408 //w=0.196 //l=0.125 //layer=m1 \
 //thickness=0.36 //x=60.062 //y=2.26 //x2=60.062 //y2=2.385
r746 (  26 61 ) resistor r=0.0863342 //w=0.379 //l=0.168152 //layer=m1 \
 //thickness=0.36 //x=69.31 //y=4.475 //x2=69.26 //y2=4.62
r747 (  25 65 ) resistor r=0.0761125 //w=0.237 //l=0.126491 //layer=m1 \
 //thickness=0.36 //x=69.31 //y=2.385 //x2=69.307 //y2=2.26
r748 (  25 26 ) resistor r=1.99427 //w=0.131 //l=2.09 //layer=m1 \
 //thickness=0.36 //x=69.31 //y=2.385 //x2=69.31 //y2=4.475
r749 (  24 58 ) resistor r=0.0898201 //w=0.322 //l=0.185472 //layer=m1 \
 //thickness=0.36 //x=65.61 //y=4.46 //x2=65.665 //y2=4.62
r750 (  23 54 ) resistor r=0.0910802 //w=0.374 //l=0.185472 //layer=m1 \
 //thickness=0.36 //x=65.61 //y=4.05 //x2=65.555 //y2=3.89
r751 (  23 24 ) resistor r=0.391221 //w=0.131 //l=0.41 //layer=m1 \
 //thickness=0.36 //x=65.61 //y=4.05 //x2=65.61 //y2=4.46
r752 (  22 52 ) resistor r=0.0877379 //w=0.374 //l=0.175357 //layer=m1 \
 //thickness=0.36 //x=65.61 //y=3.73 //x2=65.555 //y2=3.88
r753 (  21 56 ) resistor r=0.0717383 //w=0.224 //l=0.115 //layer=m1 \
 //thickness=0.36 //x=65.61 //y=2.375 //x2=65.61 //y2=2.26
r754 (  21 22 ) resistor r=1.29294 //w=0.131 //l=1.355 //layer=m1 \
 //thickness=0.36 //x=65.61 //y=2.375 //x2=65.61 //y2=3.73
r755 (  19 50 ) resistor r=0.0914072 //w=0.382 //l=0.181989 //layer=m1 \
 //thickness=0.36 //x=64.13 //y=4.05 //x2=64.177 //y2=3.89
r756 (  19 20 ) resistor r=1.18798 //w=0.131 //l=1.245 //layer=m1 \
 //thickness=0.36 //x=64.13 //y=4.05 //x2=64.13 //y2=5.295
r757 (  18 48 ) resistor r=0.088135 //w=0.382 //l=0.171901 //layer=m1 \
 //thickness=0.36 //x=64.13 //y=3.73 //x2=64.177 //y2=3.88
r758 (  17 18 ) resistor r=1.7271 //w=0.131 //l=1.81 //layer=m1 \
 //thickness=0.36 //x=64.13 //y=1.92 //x2=64.13 //y2=3.73
r759 (  15 17 ) resistor r=0.0698411 //w=0.17 //l=0.120208 //layer=m1 \
 //thickness=0.36 //x=64.045 //y=1.835 //x2=64.13 //y2=1.92
r760 (  15 16 ) resistor r=0.257634 //w=0.131 //l=0.27 //layer=m1 \
 //thickness=0.36 //x=64.045 //y=1.835 //x2=63.775 //y2=1.835
r761 (  14 40 ) resistor r=0.0257089 //w=0.23 //l=0.115 //layer=m1 \
 //thickness=0.36 //x=63.765 //y=5.38 //x2=63.65 //y2=5.38
r762 (  13 20 ) resistor r=0.0698411 //w=0.17 //l=0.120208 //layer=m1 \
 //thickness=0.36 //x=64.045 //y=5.38 //x2=64.13 //y2=5.295
r763 (  13 14 ) resistor r=0.267176 //w=0.131 //l=0.28 //layer=m1 \
 //thickness=0.36 //x=64.045 //y=5.38 //x2=63.765 //y2=5.38
r764 (  12 16 ) resistor r=0.0698411 //w=0.17 //l=0.120208 //layer=m1 \
 //thickness=0.36 //x=63.69 //y=1.75 //x2=63.775 //y2=1.835
r765 (  11 45 ) resistor r=0.0913624 //w=0.191 //l=0.12 //layer=m1 \
 //thickness=0.36 //x=63.69 //y=1.3 //x2=63.69 //y2=1.18
r766 (  11 12 ) resistor r=0.429389 //w=0.131 //l=0.45 //layer=m1 \
 //thickness=0.36 //x=63.69 //y=1.3 //x2=63.69 //y2=1.75
r767 (  8 37 ) resistor r=0.0227762 //w=0.219 //l=0.115 //layer=m1 \
 //thickness=0.36 //x=62.885 //y=5.38 //x2=62.77 //y2=5.38
r768 (  7 40 ) resistor r=0.0257089 //w=0.23 //l=0.115 //layer=m1 \
 //thickness=0.36 //x=63.535 //y=5.38 //x2=63.65 //y2=5.38
r769 (  7 8 ) resistor r=0.620229 //w=0.131 //l=0.65 //layer=m1 \
 //thickness=0.36 //x=63.535 //y=5.38 //x2=62.885 //y2=5.38
r770 (  4 32 ) resistor r=0.0878548 //w=0.228 //l=0.159295 //layer=m1 \
 //thickness=0.36 //x=60.06 //y=4.735 //x2=60.09 //y2=4.88
r771 (  3 36 ) resistor r=0.0861726 //w=0.376 //l=0.169012 //layer=m1 \
 //thickness=0.36 //x=60.06 //y=4.025 //x2=60.112 //y2=3.88
r772 (  3 4 ) resistor r=0.677481 //w=0.131 //l=0.71 //layer=m1 \
 //thickness=0.36 //x=60.06 //y=4.025 //x2=60.06 //y2=4.735
r773 (  2 34 ) resistor r=0.0911593 //w=0.376 //l=0.184174 //layer=m1 \
 //thickness=0.36 //x=60.06 //y=3.705 //x2=60.112 //y2=3.865
r774 (  2 30 ) resistor r=1.25954 //w=0.131 //l=1.32 //layer=m1 \
 //thickness=0.36 //x=60.06 //y=3.705 //x2=60.06 //y2=2.385
ends PM_TMRDFFQX1\%noxref_18

subckt PM_TMRDFFQX1\%noxref_19 ( 1 2 3 4 5 6 7 8 9 10 26 30 35 37 42 51 53 54 \
 57 62 67 76 81 90 94 95 96 97 98 99 100 101 102 103 104 105 110 112 114 120 \
 121 122 123 124 129 131 133 139 140 141 142 143 148 150 152 158 159 161 162 \
 165 174 175 178 186 187 190 )
c591 ( 190 0 ) capacitor c=0.0370698f //x=73.4 //y=4.885
c592 ( 187 0 ) capacitor c=0.028421f //x=73.38 //y=2.095
c593 ( 186 0 ) capacitor c=0.0512002f //x=73.38 //y=2.26
c594 ( 178 0 ) capacitor c=0.0387879f //x=66.76 //y=4.885
c595 ( 175 0 ) capacitor c=0.0300885f //x=66.72 //y=2.095
c596 ( 174 0 ) capacitor c=0.0506604f //x=66.72 //y=2.26
c597 ( 165 0 ) capacitor c=0.0393541f //x=38.63 //y=4.88
c598 ( 162 0 ) capacitor c=0.0284095f //x=38.6 //y=2.095
c599 ( 161 0 ) capacitor c=0.0451185f //x=38.6 //y=2.26
c600 ( 159 0 ) capacitor c=0.0237734f //x=73.945 //y=1.435
c601 ( 158 0 ) capacitor c=0.0191782f //x=73.945 //y=1.085
c602 ( 152 0 ) capacitor c=0.0361171f //x=73.79 //y=1.585
c603 ( 150 0 ) capacitor c=0.0157803f //x=73.79 //y=0.93
c604 ( 148 0 ) capacitor c=0.0377178f //x=73.785 //y=4.975
c605 ( 143 0 ) capacitor c=0.020493f //x=73.415 //y=1.74
c606 ( 142 0 ) capacitor c=0.0167049f //x=73.415 //y=1.435
c607 ( 141 0 ) capacitor c=0.0174993f //x=73.415 //y=1.085
c608 ( 140 0 ) capacitor c=0.0443648f //x=67.285 //y=1.43
c609 ( 139 0 ) capacitor c=0.0192211f //x=67.285 //y=1.085
c610 ( 133 0 ) capacitor c=0.0186579f //x=67.13 //y=1.585
c611 ( 131 0 ) capacitor c=0.0157795f //x=67.13 //y=0.93
c612 ( 129 0 ) capacitor c=0.0351351f //x=67.125 //y=4.975
c613 ( 124 0 ) capacitor c=0.0209124f //x=66.755 //y=1.74
c614 ( 123 0 ) capacitor c=0.016848f //x=66.755 //y=1.43
c615 ( 122 0 ) capacitor c=0.0174777f //x=66.755 //y=1.085
c616 ( 121 0 ) capacitor c=0.0439708f //x=39.165 //y=1.43
c617 ( 120 0 ) capacitor c=0.0192582f //x=39.165 //y=1.085
c618 ( 114 0 ) capacitor c=0.0162526f //x=39.01 //y=1.585
c619 ( 112 0 ) capacitor c=0.0157807f //x=39.01 //y=0.93
c620 ( 110 0 ) capacitor c=0.0372668f //x=39.005 //y=4.97
c621 ( 105 0 ) capacitor c=0.0210762f //x=38.635 //y=1.74
c622 ( 104 0 ) capacitor c=0.0168511f //x=38.635 //y=1.43
c623 ( 103 0 ) capacitor c=0.0175485f //x=38.635 //y=1.085
c624 ( 102 0 ) capacitor c=0.155887f //x=73.86 //y=6.205
c625 ( 101 0 ) capacitor c=0.1106f //x=73.42 //y=6.205
c626 ( 100 0 ) capacitor c=0.154859f //x=67.2 //y=6.205
c627 ( 99 0 ) capacitor c=0.110573f //x=66.76 //y=6.205
c628 ( 98 0 ) capacitor c=0.155269f //x=39.08 //y=6.2
c629 ( 97 0 ) capacitor c=0.110375f //x=38.64 //y=6.2
c630 ( 90 0 ) capacitor c=8.10734e-19 //x=73.4 //y=4.885
c631 ( 81 0 ) capacitor c=0.00105273f //x=73.38 //y=2.26
c632 ( 76 0 ) capacitor c=0.00173056f //x=66.76 //y=4.885
c633 ( 67 0 ) capacitor c=0.00152737f //x=66.72 //y=2.26
c634 ( 62 0 ) capacitor c=8.90417e-19 //x=38.63 //y=4.88
c635 ( 57 0 ) capacitor c=7.72439e-19 //x=38.6 //y=2.26
c636 ( 54 0 ) capacitor c=0.147325f //x=73.235 //y=4.21
c637 ( 53 0 ) capacitor c=0.00479868f //x=73.395 //y=4.21
c638 ( 51 0 ) capacitor c=0.00315008f //x=66.88 //y=4.205
c639 ( 42 0 ) capacitor c=0.0057541f //x=38.585 //y=2.325
c640 ( 37 0 ) capacitor c=0.417451f //x=50.285 //y=2.37
c641 ( 35 0 ) capacitor c=0.24779f //x=49.685 //y=2.4
c642 ( 30 0 ) capacitor c=0.0138506f //x=73.38 //y=4.25
c643 ( 26 0 ) capacitor c=0.0166522f //x=66.72 //y=4.25
c644 ( 10 0 ) capacitor c=0.0124358f //x=73.38 //y=4.74
c645 ( 9 0 ) capacitor c=0.0108569f //x=73.38 //y=4.37
c646 ( 8 0 ) capacitor c=0.0479874f //x=73.38 //y=4.05
c647 ( 7 0 ) capacitor c=0.00651439f //x=73.38 //y=2.38
c648 ( 6 0 ) capacitor c=0.0169891f //x=66.72 //y=4.71
c649 ( 5 0 ) capacitor c=0.0128756f //x=66.72 //y=4.365
c650 ( 4 0 ) capacitor c=0.0586305f //x=66.72 //y=4.045
c651 ( 3 0 ) capacitor c=0.0129582f //x=66.72 //y=2.485
c652 ( 2 0 ) capacitor c=0.0522997f //x=38.6 //y=4.735
c653 ( 1 0 ) capacitor c=0.010091f //x=38.6 //y=2.485
r654 (  192 193 ) resistor r=32.4568 //w=0.214 //l=0.075 //layer=ply \
 //thickness=0.18 //x=73.4 //y=4.975 //x2=73.4 //y2=5.05
r655 (  190 192 ) resistor r=20.271 //w=0.214 //l=0.09 //layer=ply \
 //thickness=0.18 //x=73.4 //y=4.885 //x2=73.4 //y2=4.975
r656 (  186 187 ) resistor r=52.7279 //w=0.214 //l=0.165 //layer=ply \
 //thickness=0.18 //x=73.38 //y=2.26 //x2=73.38 //y2=2.095
r657 (  178 180 ) resistor r=20.271 //w=0.214 //l=0.09 //layer=ply \
 //thickness=0.18 //x=66.76 //y=4.885 //x2=66.76 //y2=4.975
r658 (  174 175 ) resistor r=52.7279 //w=0.214 //l=0.165 //layer=ply \
 //thickness=0.18 //x=66.72 //y=2.26 //x2=66.72 //y2=2.095
r659 (  167 168 ) resistor r=32.4568 //w=0.214 //l=0.075 //layer=ply \
 //thickness=0.18 //x=38.63 //y=4.97 //x2=38.63 //y2=5.045
r660 (  165 167 ) resistor r=20.271 //w=0.214 //l=0.09 //layer=ply \
 //thickness=0.18 //x=38.63 //y=4.88 //x2=38.63 //y2=4.97
r661 (  161 162 ) resistor r=52.7279 //w=0.214 //l=0.165 //layer=ply \
 //thickness=0.18 //x=38.6 //y=2.26 //x2=38.6 //y2=2.095
r662 (  159 197 ) resistor r=4.95774 //w=0.164 //l=0.112 //layer=ply \
 //thickness=0.18 //x=73.945 //y=1.435 //x2=73.945 //y2=1.547
r663 (  158 196 ) resistor r=45.1352 //w=0.168 //l=0.173853 //layer=ply \
 //thickness=0.18 //x=73.945 //y=1.085 //x2=73.905 //y2=0.93
r664 (  158 159 ) resistor r=179.468 //w=0.094 //l=0.35 //layer=ply \
 //thickness=0.18 //x=73.945 //y=1.085 //x2=73.945 //y2=1.435
r665 (  153 195 ) resistor r=10.8103 //w=0.211 //l=0.115 //layer=ply \
 //thickness=0.18 //x=73.57 //y=1.585 //x2=73.455 //y2=1.585
r666 (  152 197 ) resistor r=45.9962 //w=0.164 //l=0.17296 //layer=ply \
 //thickness=0.18 //x=73.79 //y=1.585 //x2=73.945 //y2=1.547
r667 (  151 194 ) resistor r=5.52526 //w=0.168 //l=0.115 //layer=ply \
 //thickness=0.18 //x=73.57 //y=0.93 //x2=73.455 //y2=0.93
r668 (  150 196 ) resistor r=5.52526 //w=0.168 //l=0.115 //layer=ply \
 //thickness=0.18 //x=73.79 //y=0.93 //x2=73.905 //y2=0.93
r669 (  150 151 ) resistor r=112.809 //w=0.094 //l=0.22 //layer=ply \
 //thickness=0.18 //x=73.79 //y=0.93 //x2=73.57 //y2=0.93
r670 (  149 192 ) resistor r=16.5046 //w=0.27 //l=0.135 //layer=ply \
 //thickness=0.18 //x=73.535 //y=4.975 //x2=73.4 //y2=4.975
r671 (  148 155 ) resistor r=26.9307 //w=0.15 //l=0.106066 //layer=ply \
 //thickness=0.18 //x=73.785 //y=4.975 //x2=73.86 //y2=5.05
r672 (  148 149 ) resistor r=128.191 //w=0.094 //l=0.25 //layer=ply \
 //thickness=0.18 //x=73.785 //y=4.975 //x2=73.535 //y2=4.975
r673 (  143 195 ) resistor r=39.5036 //w=0.211 //l=0.173853 //layer=ply \
 //thickness=0.18 //x=73.415 //y=1.74 //x2=73.455 //y2=1.585
r674 (  143 187 ) resistor r=182.032 //w=0.094 //l=0.355 //layer=ply \
 //thickness=0.18 //x=73.415 //y=1.74 //x2=73.415 //y2=2.095
r675 (  142 195 ) resistor r=38.3614 //w=0.211 //l=0.168819 //layer=ply \
 //thickness=0.18 //x=73.415 //y=1.435 //x2=73.455 //y2=1.585
r676 (  141 194 ) resistor r=45.1352 //w=0.168 //l=0.173853 //layer=ply \
 //thickness=0.18 //x=73.415 //y=1.085 //x2=73.455 //y2=0.93
r677 (  141 142 ) resistor r=179.468 //w=0.094 //l=0.35 //layer=ply \
 //thickness=0.18 //x=73.415 //y=1.085 //x2=73.415 //y2=1.435
r678 (  140 184 ) resistor r=45.1352 //w=0.168 //l=0.173853 //layer=ply \
 //thickness=0.18 //x=67.285 //y=1.43 //x2=67.245 //y2=1.585
r679 (  139 183 ) resistor r=45.1352 //w=0.168 //l=0.173853 //layer=ply \
 //thickness=0.18 //x=67.285 //y=1.085 //x2=67.245 //y2=0.93
r680 (  139 140 ) resistor r=176.904 //w=0.094 //l=0.345 //layer=ply \
 //thickness=0.18 //x=67.285 //y=1.085 //x2=67.285 //y2=1.43
r681 (  134 182 ) resistor r=10.701 //w=0.21 //l=0.115 //layer=ply \
 //thickness=0.18 //x=66.91 //y=1.585 //x2=66.795 //y2=1.585
r682 (  133 184 ) resistor r=5.52526 //w=0.168 //l=0.115 //layer=ply \
 //thickness=0.18 //x=67.13 //y=1.585 //x2=67.245 //y2=1.585
r683 (  132 181 ) resistor r=5.52526 //w=0.168 //l=0.115 //layer=ply \
 //thickness=0.18 //x=66.91 //y=0.93 //x2=66.795 //y2=0.93
r684 (  131 183 ) resistor r=5.52526 //w=0.168 //l=0.115 //layer=ply \
 //thickness=0.18 //x=67.13 //y=0.93 //x2=67.245 //y2=0.93
r685 (  131 132 ) resistor r=112.809 //w=0.094 //l=0.22 //layer=ply \
 //thickness=0.18 //x=67.13 //y=0.93 //x2=66.91 //y2=0.93
r686 (  130 180 ) resistor r=16.5046 //w=0.27 //l=0.135 //layer=ply \
 //thickness=0.18 //x=66.895 //y=4.975 //x2=66.76 //y2=4.975
r687 (  129 136 ) resistor r=26.9307 //w=0.15 //l=0.106066 //layer=ply \
 //thickness=0.18 //x=67.125 //y=4.975 //x2=67.2 //y2=5.05
r688 (  129 130 ) resistor r=117.936 //w=0.094 //l=0.23 //layer=ply \
 //thickness=0.18 //x=67.125 //y=4.975 //x2=66.895 //y2=4.975
r689 (  126 180 ) resistor r=32.4568 //w=0.214 //l=0.075 //layer=ply \
 //thickness=0.18 //x=66.76 //y=5.05 //x2=66.76 //y2=4.975
r690 (  124 182 ) resistor r=39.5823 //w=0.21 //l=0.173853 //layer=ply \
 //thickness=0.18 //x=66.755 //y=1.74 //x2=66.795 //y2=1.585
r691 (  124 175 ) resistor r=182.032 //w=0.094 //l=0.355 //layer=ply \
 //thickness=0.18 //x=66.755 //y=1.74 //x2=66.755 //y2=2.095
r692 (  123 182 ) resistor r=39.5823 //w=0.21 //l=0.173853 //layer=ply \
 //thickness=0.18 //x=66.755 //y=1.43 //x2=66.795 //y2=1.585
r693 (  122 181 ) resistor r=45.1352 //w=0.168 //l=0.173853 //layer=ply \
 //thickness=0.18 //x=66.755 //y=1.085 //x2=66.795 //y2=0.93
r694 (  122 123 ) resistor r=176.904 //w=0.094 //l=0.345 //layer=ply \
 //thickness=0.18 //x=66.755 //y=1.085 //x2=66.755 //y2=1.43
r695 (  121 172 ) resistor r=45.1352 //w=0.168 //l=0.173853 //layer=ply \
 //thickness=0.18 //x=39.165 //y=1.43 //x2=39.125 //y2=1.585
r696 (  120 171 ) resistor r=45.1352 //w=0.168 //l=0.173853 //layer=ply \
 //thickness=0.18 //x=39.165 //y=1.085 //x2=39.125 //y2=0.93
r697 (  120 121 ) resistor r=176.904 //w=0.094 //l=0.345 //layer=ply \
 //thickness=0.18 //x=39.165 //y=1.085 //x2=39.165 //y2=1.43
r698 (  115 170 ) resistor r=10.701 //w=0.21 //l=0.115 //layer=ply \
 //thickness=0.18 //x=38.79 //y=1.585 //x2=38.675 //y2=1.585
r699 (  114 172 ) resistor r=5.52526 //w=0.168 //l=0.115 //layer=ply \
 //thickness=0.18 //x=39.01 //y=1.585 //x2=39.125 //y2=1.585
r700 (  113 169 ) resistor r=5.52526 //w=0.168 //l=0.115 //layer=ply \
 //thickness=0.18 //x=38.79 //y=0.93 //x2=38.675 //y2=0.93
r701 (  112 171 ) resistor r=5.52526 //w=0.168 //l=0.115 //layer=ply \
 //thickness=0.18 //x=39.01 //y=0.93 //x2=39.125 //y2=0.93
r702 (  112 113 ) resistor r=112.809 //w=0.094 //l=0.22 //layer=ply \
 //thickness=0.18 //x=39.01 //y=0.93 //x2=38.79 //y2=0.93
r703 (  111 167 ) resistor r=16.5046 //w=0.27 //l=0.135 //layer=ply \
 //thickness=0.18 //x=38.765 //y=4.97 //x2=38.63 //y2=4.97
r704 (  110 117 ) resistor r=26.9307 //w=0.15 //l=0.106066 //layer=ply \
 //thickness=0.18 //x=39.005 //y=4.97 //x2=39.08 //y2=5.045
r705 (  110 111 ) resistor r=123.064 //w=0.094 //l=0.24 //layer=ply \
 //thickness=0.18 //x=39.005 //y=4.97 //x2=38.765 //y2=4.97
r706 (  105 170 ) resistor r=39.5823 //w=0.21 //l=0.173853 //layer=ply \
 //thickness=0.18 //x=38.635 //y=1.74 //x2=38.675 //y2=1.585
r707 (  105 162 ) resistor r=182.032 //w=0.094 //l=0.355 //layer=ply \
 //thickness=0.18 //x=38.635 //y=1.74 //x2=38.635 //y2=2.095
r708 (  104 170 ) resistor r=39.5823 //w=0.21 //l=0.173853 //layer=ply \
 //thickness=0.18 //x=38.635 //y=1.43 //x2=38.675 //y2=1.585
r709 (  103 169 ) resistor r=45.1352 //w=0.168 //l=0.173853 //layer=ply \
 //thickness=0.18 //x=38.635 //y=1.085 //x2=38.675 //y2=0.93
r710 (  103 104 ) resistor r=176.904 //w=0.094 //l=0.345 //layer=ply \
 //thickness=0.18 //x=38.635 //y=1.085 //x2=38.635 //y2=1.43
r711 (  102 155 ) resistor r=592.245 //w=0.094 //l=1.155 //layer=ply \
 //thickness=0.18 //x=73.86 //y=6.205 //x2=73.86 //y2=5.05
r712 (  101 193 ) resistor r=592.245 //w=0.094 //l=1.155 //layer=ply \
 //thickness=0.18 //x=73.42 //y=6.205 //x2=73.42 //y2=5.05
r713 (  100 136 ) resistor r=592.245 //w=0.094 //l=1.155 //layer=ply \
 //thickness=0.18 //x=67.2 //y=6.205 //x2=67.2 //y2=5.05
r714 (  99 126 ) resistor r=592.245 //w=0.094 //l=1.155 //layer=ply \
 //thickness=0.18 //x=66.76 //y=6.205 //x2=66.76 //y2=5.05
r715 (  98 117 ) resistor r=592.245 //w=0.094 //l=1.155 //layer=ply \
 //thickness=0.18 //x=39.08 //y=6.2 //x2=39.08 //y2=5.045
r716 (  97 168 ) resistor r=592.245 //w=0.094 //l=1.155 //layer=ply \
 //thickness=0.18 //x=38.64 //y=6.2 //x2=38.64 //y2=5.045
r717 (  96 152 ) resistor r=56.4043 //w=0.094 //l=0.11 //layer=ply \
 //thickness=0.18 //x=73.68 //y=1.585 //x2=73.79 //y2=1.585
r718 (  96 153 ) resistor r=56.4043 //w=0.094 //l=0.11 //layer=ply \
 //thickness=0.18 //x=73.68 //y=1.585 //x2=73.57 //y2=1.585
r719 (  95 133 ) resistor r=56.4043 //w=0.094 //l=0.11 //layer=ply \
 //thickness=0.18 //x=67.02 //y=1.585 //x2=67.13 //y2=1.585
r720 (  95 134 ) resistor r=56.4043 //w=0.094 //l=0.11 //layer=ply \
 //thickness=0.18 //x=67.02 //y=1.585 //x2=66.91 //y2=1.585
r721 (  94 114 ) resistor r=56.4043 //w=0.094 //l=0.11 //layer=ply \
 //thickness=0.18 //x=38.9 //y=1.585 //x2=39.01 //y2=1.585
r722 (  94 115 ) resistor r=56.4043 //w=0.094 //l=0.11 //layer=ply \
 //thickness=0.18 //x=38.9 //y=1.585 //x2=38.79 //y2=1.585
r723 (  90 190 ) resistor r=152 //w=0.17 //l=0.17 //layer=licon //count=1 \
 //x=73.4 //y=4.885 //x2=73.4 //y2=4.885
r724 (  81 186 ) resistor r=152 //w=0.17 //l=0.17 //layer=licon //count=1 \
 //x=73.38 //y=2.26 //x2=73.38 //y2=2.26
r725 (  76 178 ) resistor r=152 //w=0.17 //l=0.17 //layer=licon //count=1 \
 //x=66.76 //y=4.885 //x2=66.76 //y2=4.885
r726 (  67 174 ) resistor r=152 //w=0.17 //l=0.17 //layer=licon //count=1 \
 //x=66.72 //y=2.26 //x2=66.72 //y2=2.26
r727 (  62 165 ) resistor r=152 //w=0.17 //l=0.17 //layer=licon //count=1 \
 //x=38.63 //y=4.88 //x2=38.63 //y2=4.88
r728 (  57 161 ) resistor r=152 //w=0.17 //l=0.17 //layer=licon //count=1 \
 //x=38.6 //y=2.26 //x2=38.6 //y2=2.26
r729 (  53 54 ) resistor r=0.104807 //w=0.281 //l=0.16 //layer=m2 \
 //thickness=0.36 //x=73.395 //y=4.21 //x2=73.235 //y2=4.21
r730 (  51 54 ) resistor r=5.84099 //w=0.136 //l=6.355 //layer=m2 \
 //thickness=0.36 //x=66.88 //y=4.252 //x2=73.235 //y2=4.252
r731 (  49 51 ) resistor r=0.104807 //w=0.281 //l=0.16 //layer=m2 \
 //thickness=0.36 //x=66.72 //y=4.205 //x2=66.88 //y2=4.205
r732 (  42 44 ) resistor r=0.033363 //w=0.281 //l=0.075 //layer=m2 \
 //thickness=0.36 //x=38.585 //y=2.325 //x2=38.585 //y2=2.4
r733 (  37 47 ) resistor r=11.8678 //w=0.173 //l=16.4475 //layer=m2 \
 //thickness=0.36 //x=50.285 //y=2.37 //x2=66.71 //y2=2.325
r734 (  37 38 ) resistor r=0.410305 //w=0.131 //l=0.43 //layer=m2 \
 //thickness=0.36 //x=50.285 //y=2.37 //x2=49.855 //y2=2.37
r735 (  36 44 ) resistor r=0.0455071 //w=0.32 //l=0.16 //layer=m2 \
 //thickness=0.36 //x=38.745 //y=2.4 //x2=38.585 //y2=2.4
r736 (  35 38 ) resistor r=0.125 //w=0.17 //l=0.184391 //layer=m2 \
 //thickness=0.36 //x=49.685 //y=2.4 //x2=49.855 //y2=2.37
r737 (  35 36 ) resistor r=10.4389 //w=0.131 //l=10.94 //layer=m2 \
 //thickness=0.36 //x=49.685 //y=2.4 //x2=38.745 //y2=2.4
r738 (  34 90 ) resistor r=9.3 //w=0.17 //l=0.17 //layer=mcon //count=1 \
 //x=73.4 //y=4.885 //x2=73.4 //y2=4.885
r739 (  32 81 ) resistor r=9.3 //w=0.17 //l=0.17 //layer=mcon //count=1 \
 //x=73.38 //y=2.26 //x2=73.38 //y2=2.26
r740 (  28 53 ) resistor r=4.5 //w=0.15 //l=0.15 //layer=via1 //count=1 \
 //x=73.395 //y=4.21 //x2=73.395 //y2=4.21
r741 (  28 30 ) resistor r=0.0130208 //w=0.384 //l=0.04 //layer=m1 \
 //thickness=0.36 //x=73.335 //y=4.21 //x2=73.335 //y2=4.25
r742 (  24 49 ) resistor r=4.5 //w=0.15 //l=0.15 //layer=via1 //count=1 \
 //x=66.72 //y=4.205 //x2=66.72 //y2=4.205
r743 (  24 26 ) resistor r=0.0149601 //w=0.376 //l=0.045 //layer=m1 \
 //thickness=0.36 //x=66.772 //y=4.205 //x2=66.772 //y2=4.25
r744 (  22 76 ) resistor r=9.3 //w=0.17 //l=0.17 //layer=mcon //count=1 \
 //x=66.76 //y=4.885 //x2=66.76 //y2=4.885
r745 (  20 47 ) resistor r=4.5 //w=0.15 //l=0.15 //layer=via1 //count=1 \
 //x=66.71 //y=2.325 //x2=66.71 //y2=2.325
r746 (  18 67 ) resistor r=9.3 //w=0.17 //l=0.17 //layer=mcon //count=1 \
 //x=66.72 //y=2.26 //x2=66.72 //y2=2.26
r747 (  18 20 ) resistor r=0.0268152 //w=0.303 //l=0.065 //layer=m1 \
 //thickness=0.36 //x=66.71 //y=2.26 //x2=66.71 //y2=2.325
r748 (  16 62 ) resistor r=9.3 //w=0.17 //l=0.17 //layer=mcon //count=1 \
 //x=38.63 //y=4.88 //x2=38.63 //y2=4.88
r749 (  14 42 ) resistor r=4.5 //w=0.15 //l=0.15 //layer=via1 //count=1 \
 //x=38.585 //y=2.325 //x2=38.585 //y2=2.325
r750 (  12 57 ) resistor r=9.3 //w=0.17 //l=0.17 //layer=mcon //count=1 \
 //x=38.6 //y=2.26 //x2=38.6 //y2=2.26
r751 (  12 14 ) resistor r=0.0262945 //w=0.309 //l=0.065 //layer=m1 \
 //thickness=0.36 //x=38.585 //y=2.26 //x2=38.585 //y2=2.325
r752 (  10 34 ) resistor r=0.0893515 //w=0.219 //l=0.154677 //layer=m1 \
 //thickness=0.36 //x=73.38 //y=4.74 //x2=73.4 //y2=4.885
r753 (  9 30 ) resistor r=0.0784723 //w=0.384 //l=0.140712 //layer=m1 \
 //thickness=0.36 //x=73.38 //y=4.37 //x2=73.335 //y2=4.25
r754 (  9 10 ) resistor r=0.353053 //w=0.131 //l=0.37 //layer=m1 \
 //thickness=0.36 //x=73.38 //y=4.37 //x2=73.38 //y2=4.74
r755 (  8 28 ) resistor r=0.0914932 //w=0.384 //l=0.181108 //layer=m1 \
 //thickness=0.36 //x=73.38 //y=4.05 //x2=73.335 //y2=4.21
r756 (  7 32 ) resistor r=0.0744285 //w=0.225 //l=0.12 //layer=m1 \
 //thickness=0.36 //x=73.38 //y=2.38 //x2=73.38 //y2=2.26
r757 (  7 8 ) resistor r=1.59351 //w=0.131 //l=1.67 //layer=m1 \
 //thickness=0.36 //x=73.38 //y=2.38 //x2=73.38 //y2=4.05
r758 (  6 22 ) resistor r=0.100665 //w=0.248 //l=0.193972 //layer=m1 \
 //thickness=0.36 //x=66.72 //y=4.71 //x2=66.76 //y2=4.885
r759 (  5 26 ) resistor r=0.0761992 //w=0.376 //l=0.138582 //layer=m1 \
 //thickness=0.36 //x=66.72 //y=4.365 //x2=66.772 //y2=4.25
r760 (  5 6 ) resistor r=0.329198 //w=0.131 //l=0.345 //layer=m1 \
 //thickness=0.36 //x=66.72 //y=4.365 //x2=66.72 //y2=4.71
r761 (  4 24 ) resistor r=0.0911593 //w=0.376 //l=0.184174 //layer=m1 \
 //thickness=0.36 //x=66.72 //y=4.045 //x2=66.772 //y2=4.205
r762 (  3 20 ) resistor r=0.0898969 //w=0.303 //l=0.164924 //layer=m1 \
 //thickness=0.36 //x=66.72 //y=2.485 //x2=66.71 //y2=2.325
r763 (  3 4 ) resistor r=1.48855 //w=0.131 //l=1.56 //layer=m1 \
 //thickness=0.36 //x=66.72 //y=2.485 //x2=66.72 //y2=4.045
r764 (  2 16 ) resistor r=0.0878548 //w=0.228 //l=0.159295 //layer=m1 \
 //thickness=0.36 //x=38.6 //y=4.735 //x2=38.63 //y2=4.88
r765 (  1 14 ) resistor r=0.0898315 //w=0.309 //l=0.167332 //layer=m1 \
 //thickness=0.36 //x=38.6 //y=2.485 //x2=38.585 //y2=2.325
r766 (  1 2 ) resistor r=2.14695 //w=0.131 //l=2.25 //layer=m1 \
 //thickness=0.36 //x=38.6 //y=2.485 //x2=38.6 //y2=4.735
ends PM_TMRDFFQX1\%noxref_19

subckt PM_TMRDFFQX1\%noxref_20 ( 2 3 4 7 12 13 15 16 18 19 20 21 22 23 24 25 \
 26 28 34 39 40 43 45 48 52 66 68 69 70 72 74 76 78 80 82 84 86 88 90 92 94 96 \
 98 100 102 104 106 113 121 123 124 127 136 141 149 166 175 180 185 189 190 \
 191 192 193 194 195 196 197 198 199 200 205 207 209 215 216 220 221 222 223 \
 224 226 229 232 233 234 235 236 237 238 239 243 245 248 249 250 251 256 257 \
 260 277 284 286 287 )
c767 ( 284 0 ) capacitor c=0.00878249f //x=20.58 //y=1.085
c768 ( 277 0 ) capacitor c=0.0586737f //x=72.27 //y=2.26
c769 ( 260 0 ) capacitor c=0.0393541f //x=17.17 //y=4.88
c770 ( 257 0 ) capacitor c=0.0284095f //x=17.14 //y=2.095
c771 ( 256 0 ) capacitor c=0.0440089f //x=17.14 //y=2.26
c772 ( 251 0 ) capacitor c=0.0318956f //x=72.975 //y=1.39
c773 ( 250 0 ) capacitor c=0.0186809f //x=72.975 //y=1.045
c774 ( 249 0 ) capacitor c=0.0659968f //x=72.615 //y=4.975
c775 ( 248 0 ) capacitor c=0.0373387f //x=72.905 //y=4.975
c776 ( 245 0 ) capacitor c=0.0157936f //x=72.82 //y=1.545
c777 ( 243 0 ) capacitor c=0.0158553f //x=72.82 //y=0.89
c778 ( 239 0 ) capacitor c=0.0302441f //x=72.445 //y=2.095
c779 ( 238 0 ) capacitor c=0.0238107f //x=72.445 //y=1.7
c780 ( 237 0 ) capacitor c=0.0234359f //x=72.445 //y=1.39
c781 ( 236 0 ) capacitor c=0.0199332f //x=72.445 //y=1.045
c782 ( 235 0 ) capacitor c=0.0927661f //x=70.615 //y=2.095
c783 ( 234 0 ) capacitor c=0.0251353f //x=70.615 //y=1.74
c784 ( 233 0 ) capacitor c=0.0234318f //x=70.615 //y=1.43
c785 ( 232 0 ) capacitor c=0.0192547f //x=70.615 //y=1.085
c786 ( 229 0 ) capacitor c=0.0714656f //x=70.52 //y=5.05
c787 ( 226 0 ) capacitor c=0.0186579f //x=70.46 //y=1.585
c788 ( 224 0 ) capacitor c=0.0157803f //x=70.46 //y=0.93
c789 ( 223 0 ) capacitor c=0.0134011f //x=70.155 //y=4.975
c790 ( 222 0 ) capacitor c=0.0243282f //x=70.445 //y=4.975
c791 ( 221 0 ) capacitor c=0.0364928f //x=70.085 //y=1.43
c792 ( 220 0 ) capacitor c=0.0174823f //x=70.085 //y=1.085
c793 ( 216 0 ) capacitor c=0.0439708f //x=17.705 //y=1.43
c794 ( 215 0 ) capacitor c=0.0192582f //x=17.705 //y=1.085
c795 ( 209 0 ) capacitor c=0.0162526f //x=17.55 //y=1.585
c796 ( 207 0 ) capacitor c=0.0157807f //x=17.55 //y=0.93
c797 ( 205 0 ) capacitor c=0.0372668f //x=17.545 //y=4.97
c798 ( 200 0 ) capacitor c=0.0210762f //x=17.175 //y=1.74
c799 ( 199 0 ) capacitor c=0.0168511f //x=17.175 //y=1.43
c800 ( 198 0 ) capacitor c=0.0175485f //x=17.175 //y=1.085
c801 ( 197 0 ) capacitor c=0.11081f //x=72.98 //y=6.205
c802 ( 196 0 ) capacitor c=0.154997f //x=72.54 //y=6.205
c803 ( 195 0 ) capacitor c=0.155934f //x=70.52 //y=6.205
c804 ( 194 0 ) capacitor c=0.110594f //x=70.08 //y=6.205
c805 ( 193 0 ) capacitor c=0.155269f //x=17.62 //y=6.2
c806 ( 192 0 ) capacitor c=0.110375f //x=17.18 //y=6.2
c807 ( 185 0 ) capacitor c=7.7962e-19 //x=72.27 //y=4.885
c808 ( 180 0 ) capacitor c=7.89145e-19 //x=72.27 //y=2.26
c809 ( 175 0 ) capacitor c=7.79163e-19 //x=70.79 //y=4.885
c810 ( 166 0 ) capacitor c=4.74639e-19 //x=70.79 //y=2.26
c811 ( 149 0 ) capacitor c=0.0322017f //x=20.73 //y=5.56
c812 ( 141 0 ) capacitor c=0.0290186f //x=19.85 //y=5.56
c813 ( 136 0 ) capacitor c=8.90417e-19 //x=17.17 //y=4.88
c814 ( 127 0 ) capacitor c=3.09518e-19 //x=17.14 //y=2.26
c815 ( 124 0 ) capacitor c=0.0208859f //x=72.105 //y=2.27
c816 ( 123 0 ) capacitor c=0.00247225f //x=72.265 //y=2.27
c817 ( 121 0 ) capacitor c=0.00126294f //x=70.955 //y=2.27
c818 ( 113 0 ) capacitor c=5.09159e-19 //x=17.285 //y=3.155
c819 ( 106 0 ) capacitor c=0.236576f //x=56.2 //y=3.125
c820 ( 104 0 ) capacitor c=0.0185676f //x=55.6 //y=3.14
c821 ( 102 0 ) capacitor c=0.00772414f //x=54.36 //y=3.125
c822 ( 100 0 ) capacitor c=0.00821162f //x=53.76 //y=3.14
c823 ( 98 0 ) capacitor c=0.00628936f //x=52.87 //y=3.12
c824 ( 96 0 ) capacitor c=0.0191737f //x=52.27 //y=3.14
c825 ( 94 0 ) capacitor c=0.008025f //x=51.02 //y=3.125
c826 ( 92 0 ) capacitor c=0.0340565f //x=50.42 //y=3.14
c827 ( 90 0 ) capacitor c=0.00477105f //x=46.96 //y=3.125
c828 ( 88 0 ) capacitor c=0.155804f //x=46.36 //y=3.14
c829 ( 86 0 ) capacitor c=0.00540847f //x=34.74 //y=3.125
c830 ( 84 0 ) capacitor c=0.0155693f //x=34.14 //y=3.14
c831 ( 82 0 ) capacitor c=0.00607094f //x=32.9 //y=3.125
c832 ( 80 0 ) capacitor c=0.00706942f //x=32.3 //y=3.14
c833 ( 78 0 ) capacitor c=0.00531214f //x=31.41 //y=3.12
c834 ( 76 0 ) capacitor c=0.0161377f //x=30.81 //y=3.14
c835 ( 74 0 ) capacitor c=0.00639434f //x=29.56 //y=3.125
c836 ( 72 0 ) capacitor c=0.00478627f //x=28.81 //y=3.165
c837 ( 70 0 ) capacitor c=0.0293811f //x=28.21 //y=3.14
c838 ( 69 0 ) capacitor c=0.0594065f //x=25.07 //y=3.125
c839 ( 68 0 ) capacitor c=0.00477105f //x=25.5 //y=3.125
c840 ( 66 0 ) capacitor c=0.0468142f //x=21.04 //y=3.14
c841 ( 52 0 ) capacitor c=0.0148135f //x=70.79 //y=3.14
c842 ( 48 0 ) capacitor c=0.0158166f //x=21.21 //y=3.14
c843 ( 45 0 ) capacitor c=0.0112857f //x=20.77 //y=1.18
c844 ( 43 0 ) capacitor c=5.78613e-19 //x=20.73 //y=5.56
c845 ( 40 0 ) capacitor c=0.0107082f //x=20.73 //y=5.38
c846 ( 39 0 ) capacitor c=0.00923159f //x=19.85 //y=5.56
c847 ( 34 0 ) capacitor c=0.0141141f //x=17.14 //y=3.14
c848 ( 28 0 ) capacitor c=0.00625975f //x=17.14 //y=2.26
c849 ( 26 0 ) capacitor c=0.076695f //x=72.27 //y=4.755
c850 ( 25 0 ) capacitor c=0.00995077f //x=72.27 //y=2.43
c851 ( 24 0 ) capacitor c=0.0562407f //x=70.79 //y=4.76
c852 ( 23 0 ) capacitor c=0.0140008f //x=70.79 //y=3.3
c853 ( 22 0 ) capacitor c=0.0154555f //x=70.79 //y=2.98
c854 ( 21 0 ) capacitor c=0.0100503f //x=70.79 //y=2.43
c855 ( 20 0 ) capacitor c=0.0547013f //x=21.21 //y=5.295
c856 ( 19 0 ) capacitor c=0.0141904f //x=21.21 //y=3.315
c857 ( 18 0 ) capacitor c=0.0269376f //x=21.21 //y=2.995
c858 ( 16 0 ) capacitor c=0.00560492f //x=20.855 //y=1.835
c859 ( 15 0 ) capacitor c=0.0130605f //x=21.125 //y=1.835
c860 ( 13 0 ) capacitor c=0.0117187f //x=21.125 //y=5.38
c861 ( 12 0 ) capacitor c=0.0133876f //x=20.77 //y=1.75
c862 ( 7 0 ) capacitor c=0.0134497f //x=20.615 //y=5.38
c863 ( 4 0 ) capacitor c=0.0330661f //x=17.14 //y=4.735
c864 ( 3 0 ) capacitor c=0.0110134f //x=17.14 //y=3.315
c865 ( 2 0 ) capacitor c=0.0114462f //x=17.14 //y=2.995
r866 (  262 263 ) resistor r=32.4568 //w=0.214 //l=0.075 //layer=ply \
 //thickness=0.18 //x=17.17 //y=4.97 //x2=17.17 //y2=5.045
r867 (  260 262 ) resistor r=20.271 //w=0.214 //l=0.09 //layer=ply \
 //thickness=0.18 //x=17.17 //y=4.88 //x2=17.17 //y2=4.97
r868 (  256 257 ) resistor r=52.7279 //w=0.214 //l=0.165 //layer=ply \
 //thickness=0.18 //x=17.14 //y=2.26 //x2=17.14 //y2=2.095
r869 (  251 283 ) resistor r=45.1352 //w=0.168 //l=0.173853 //layer=ply \
 //thickness=0.18 //x=72.975 //y=1.39 //x2=72.935 //y2=1.545
r870 (  250 282 ) resistor r=45.1352 //w=0.168 //l=0.173853 //layer=ply \
 //thickness=0.18 //x=72.975 //y=1.045 //x2=72.935 //y2=0.89
r871 (  250 251 ) resistor r=176.904 //w=0.094 //l=0.345 //layer=ply \
 //thickness=0.18 //x=72.975 //y=1.045 //x2=72.975 //y2=1.39
r872 (  248 252 ) resistor r=26.9307 //w=0.15 //l=0.106066 //layer=ply \
 //thickness=0.18 //x=72.905 //y=4.975 //x2=72.98 //y2=5.05
r873 (  248 249 ) resistor r=148.702 //w=0.094 //l=0.29 //layer=ply \
 //thickness=0.18 //x=72.905 //y=4.975 //x2=72.615 //y2=4.975
r874 (  246 281 ) resistor r=10.701 //w=0.21 //l=0.115 //layer=ply \
 //thickness=0.18 //x=72.6 //y=1.545 //x2=72.485 //y2=1.545
r875 (  245 283 ) resistor r=5.52526 //w=0.168 //l=0.115 //layer=ply \
 //thickness=0.18 //x=72.82 //y=1.545 //x2=72.935 //y2=1.545
r876 (  244 280 ) resistor r=5.52526 //w=0.168 //l=0.115 //layer=ply \
 //thickness=0.18 //x=72.6 //y=0.89 //x2=72.485 //y2=0.89
r877 (  243 282 ) resistor r=5.52526 //w=0.168 //l=0.115 //layer=ply \
 //thickness=0.18 //x=72.82 //y=0.89 //x2=72.935 //y2=0.89
r878 (  243 244 ) resistor r=112.809 //w=0.094 //l=0.22 //layer=ply \
 //thickness=0.18 //x=72.82 //y=0.89 //x2=72.6 //y2=0.89
r879 (  240 249 ) resistor r=22.1787 //w=0.252 //l=0.106066 //layer=ply \
 //thickness=0.18 //x=72.54 //y=5.05 //x2=72.615 //y2=4.975
r880 (  240 279 ) resistor r=51.6429 //w=0.252 //l=0.34271 //layer=ply \
 //thickness=0.18 //x=72.54 //y=5.05 //x2=72.27 //y2=4.885
r881 (  239 277 ) resistor r=30.4513 //w=0.277 //l=0.243926 //layer=ply \
 //thickness=0.18 //x=72.445 //y=2.095 //x2=72.27 //y2=2.26
r882 (  238 281 ) resistor r=39.5823 //w=0.21 //l=0.173853 //layer=ply \
 //thickness=0.18 //x=72.445 //y=1.7 //x2=72.485 //y2=1.545
r883 (  238 239 ) resistor r=202.543 //w=0.094 //l=0.395 //layer=ply \
 //thickness=0.18 //x=72.445 //y=1.7 //x2=72.445 //y2=2.095
r884 (  237 281 ) resistor r=39.5823 //w=0.21 //l=0.173853 //layer=ply \
 //thickness=0.18 //x=72.445 //y=1.39 //x2=72.485 //y2=1.545
r885 (  236 280 ) resistor r=45.1352 //w=0.168 //l=0.173853 //layer=ply \
 //thickness=0.18 //x=72.445 //y=1.045 //x2=72.485 //y2=0.89
r886 (  236 237 ) resistor r=176.904 //w=0.094 //l=0.345 //layer=ply \
 //thickness=0.18 //x=72.445 //y=1.045 //x2=72.445 //y2=1.39
r887 (  235 273 ) resistor r=30.4513 //w=0.277 //l=0.243926 //layer=ply \
 //thickness=0.18 //x=70.615 //y=2.095 //x2=70.79 //y2=2.26
r888 (  234 271 ) resistor r=39.5823 //w=0.21 //l=0.173853 //layer=ply \
 //thickness=0.18 //x=70.615 //y=1.74 //x2=70.575 //y2=1.585
r889 (  234 235 ) resistor r=182.032 //w=0.094 //l=0.355 //layer=ply \
 //thickness=0.18 //x=70.615 //y=1.74 //x2=70.615 //y2=2.095
r890 (  233 271 ) resistor r=39.5823 //w=0.21 //l=0.173853 //layer=ply \
 //thickness=0.18 //x=70.615 //y=1.43 //x2=70.575 //y2=1.585
r891 (  232 270 ) resistor r=45.1352 //w=0.168 //l=0.173853 //layer=ply \
 //thickness=0.18 //x=70.615 //y=1.085 //x2=70.575 //y2=0.93
r892 (  232 233 ) resistor r=176.904 //w=0.094 //l=0.345 //layer=ply \
 //thickness=0.18 //x=70.615 //y=1.085 //x2=70.615 //y2=1.43
r893 (  229 275 ) resistor r=51.6429 //w=0.252 //l=0.34271 //layer=ply \
 //thickness=0.18 //x=70.52 //y=5.05 //x2=70.79 //y2=4.885
r894 (  227 269 ) resistor r=5.52526 //w=0.168 //l=0.115 //layer=ply \
 //thickness=0.18 //x=70.24 //y=1.585 //x2=70.125 //y2=1.585
r895 (  226 271 ) resistor r=10.701 //w=0.21 //l=0.115 //layer=ply \
 //thickness=0.18 //x=70.46 //y=1.585 //x2=70.575 //y2=1.585
r896 (  225 268 ) resistor r=5.52526 //w=0.168 //l=0.115 //layer=ply \
 //thickness=0.18 //x=70.24 //y=0.93 //x2=70.125 //y2=0.93
r897 (  224 270 ) resistor r=5.52526 //w=0.168 //l=0.115 //layer=ply \
 //thickness=0.18 //x=70.46 //y=0.93 //x2=70.575 //y2=0.93
r898 (  224 225 ) resistor r=112.809 //w=0.094 //l=0.22 //layer=ply \
 //thickness=0.18 //x=70.46 //y=0.93 //x2=70.24 //y2=0.93
r899 (  222 229 ) resistor r=22.1787 //w=0.252 //l=0.106066 //layer=ply \
 //thickness=0.18 //x=70.445 //y=4.975 //x2=70.52 //y2=5.05
r900 (  222 223 ) resistor r=148.702 //w=0.094 //l=0.29 //layer=ply \
 //thickness=0.18 //x=70.445 //y=4.975 //x2=70.155 //y2=4.975
r901 (  221 269 ) resistor r=45.1352 //w=0.168 //l=0.173853 //layer=ply \
 //thickness=0.18 //x=70.085 //y=1.43 //x2=70.125 //y2=1.585
r902 (  220 268 ) resistor r=45.1352 //w=0.168 //l=0.173853 //layer=ply \
 //thickness=0.18 //x=70.085 //y=1.085 //x2=70.125 //y2=0.93
r903 (  220 221 ) resistor r=176.904 //w=0.094 //l=0.345 //layer=ply \
 //thickness=0.18 //x=70.085 //y=1.085 //x2=70.085 //y2=1.43
r904 (  217 223 ) resistor r=26.9307 //w=0.15 //l=0.106066 //layer=ply \
 //thickness=0.18 //x=70.08 //y=5.05 //x2=70.155 //y2=4.975
r905 (  216 267 ) resistor r=45.1352 //w=0.168 //l=0.173853 //layer=ply \
 //thickness=0.18 //x=17.705 //y=1.43 //x2=17.665 //y2=1.585
r906 (  215 266 ) resistor r=45.1352 //w=0.168 //l=0.173853 //layer=ply \
 //thickness=0.18 //x=17.705 //y=1.085 //x2=17.665 //y2=0.93
r907 (  215 216 ) resistor r=176.904 //w=0.094 //l=0.345 //layer=ply \
 //thickness=0.18 //x=17.705 //y=1.085 //x2=17.705 //y2=1.43
r908 (  210 265 ) resistor r=10.701 //w=0.21 //l=0.115 //layer=ply \
 //thickness=0.18 //x=17.33 //y=1.585 //x2=17.215 //y2=1.585
r909 (  209 267 ) resistor r=5.52526 //w=0.168 //l=0.115 //layer=ply \
 //thickness=0.18 //x=17.55 //y=1.585 //x2=17.665 //y2=1.585
r910 (  208 264 ) resistor r=5.52526 //w=0.168 //l=0.115 //layer=ply \
 //thickness=0.18 //x=17.33 //y=0.93 //x2=17.215 //y2=0.93
r911 (  207 266 ) resistor r=5.52526 //w=0.168 //l=0.115 //layer=ply \
 //thickness=0.18 //x=17.55 //y=0.93 //x2=17.665 //y2=0.93
r912 (  207 208 ) resistor r=112.809 //w=0.094 //l=0.22 //layer=ply \
 //thickness=0.18 //x=17.55 //y=0.93 //x2=17.33 //y2=0.93
r913 (  206 262 ) resistor r=16.5046 //w=0.27 //l=0.135 //layer=ply \
 //thickness=0.18 //x=17.305 //y=4.97 //x2=17.17 //y2=4.97
r914 (  205 212 ) resistor r=26.9307 //w=0.15 //l=0.106066 //layer=ply \
 //thickness=0.18 //x=17.545 //y=4.97 //x2=17.62 //y2=5.045
r915 (  205 206 ) resistor r=123.064 //w=0.094 //l=0.24 //layer=ply \
 //thickness=0.18 //x=17.545 //y=4.97 //x2=17.305 //y2=4.97
r916 (  200 265 ) resistor r=39.5823 //w=0.21 //l=0.173853 //layer=ply \
 //thickness=0.18 //x=17.175 //y=1.74 //x2=17.215 //y2=1.585
r917 (  200 257 ) resistor r=182.032 //w=0.094 //l=0.355 //layer=ply \
 //thickness=0.18 //x=17.175 //y=1.74 //x2=17.175 //y2=2.095
r918 (  199 265 ) resistor r=39.5823 //w=0.21 //l=0.173853 //layer=ply \
 //thickness=0.18 //x=17.175 //y=1.43 //x2=17.215 //y2=1.585
r919 (  198 264 ) resistor r=45.1352 //w=0.168 //l=0.173853 //layer=ply \
 //thickness=0.18 //x=17.175 //y=1.085 //x2=17.215 //y2=0.93
r920 (  198 199 ) resistor r=176.904 //w=0.094 //l=0.345 //layer=ply \
 //thickness=0.18 //x=17.175 //y=1.085 //x2=17.175 //y2=1.43
r921 (  197 252 ) resistor r=592.245 //w=0.094 //l=1.155 //layer=ply \
 //thickness=0.18 //x=72.98 //y=6.205 //x2=72.98 //y2=5.05
r922 (  196 240 ) resistor r=592.245 //w=0.094 //l=1.155 //layer=ply \
 //thickness=0.18 //x=72.54 //y=6.205 //x2=72.54 //y2=5.05
r923 (  195 229 ) resistor r=592.245 //w=0.094 //l=1.155 //layer=ply \
 //thickness=0.18 //x=70.52 //y=6.205 //x2=70.52 //y2=5.05
r924 (  194 217 ) resistor r=592.245 //w=0.094 //l=1.155 //layer=ply \
 //thickness=0.18 //x=70.08 //y=6.205 //x2=70.08 //y2=5.05
r925 (  193 212 ) resistor r=592.245 //w=0.094 //l=1.155 //layer=ply \
 //thickness=0.18 //x=17.62 //y=6.2 //x2=17.62 //y2=5.045
r926 (  192 263 ) resistor r=592.245 //w=0.094 //l=1.155 //layer=ply \
 //thickness=0.18 //x=17.18 //y=6.2 //x2=17.18 //y2=5.045
r927 (  191 245 ) resistor r=56.4043 //w=0.094 //l=0.11 //layer=ply \
 //thickness=0.18 //x=72.71 //y=1.545 //x2=72.82 //y2=1.545
r928 (  191 246 ) resistor r=56.4043 //w=0.094 //l=0.11 //layer=ply \
 //thickness=0.18 //x=72.71 //y=1.545 //x2=72.6 //y2=1.545
r929 (  190 226 ) resistor r=56.4043 //w=0.094 //l=0.11 //layer=ply \
 //thickness=0.18 //x=70.35 //y=1.585 //x2=70.46 //y2=1.585
r930 (  190 227 ) resistor r=56.4043 //w=0.094 //l=0.11 //layer=ply \
 //thickness=0.18 //x=70.35 //y=1.585 //x2=70.24 //y2=1.585
r931 (  189 209 ) resistor r=56.4043 //w=0.094 //l=0.11 //layer=ply \
 //thickness=0.18 //x=17.44 //y=1.585 //x2=17.55 //y2=1.585
r932 (  189 210 ) resistor r=56.4043 //w=0.094 //l=0.11 //layer=ply \
 //thickness=0.18 //x=17.44 //y=1.585 //x2=17.33 //y2=1.585
r933 (  185 279 ) resistor r=152 //w=0.17 //l=0.17 //layer=licon //count=1 \
 //x=72.27 //y=4.885 //x2=72.27 //y2=4.885
r934 (  180 277 ) resistor r=152 //w=0.17 //l=0.17 //layer=licon //count=1 \
 //x=72.27 //y=2.26 //x2=72.27 //y2=2.26
r935 (  175 275 ) resistor r=152 //w=0.17 //l=0.17 //layer=licon //count=1 \
 //x=70.79 //y=4.885 //x2=70.79 //y2=4.885
r936 (  166 273 ) resistor r=152 //w=0.17 //l=0.17 //layer=licon //count=1 \
 //x=70.79 //y=2.26 //x2=70.79 //y2=2.26
r937 (  149 287 ) resistor r=23.615 //w=0.187 //l=0.345 //layer=li \
 //thickness=0.1 //x=20.73 //y=5.56 //x2=20.73 //y2=5.905
r938 (  141 286 ) resistor r=23.615 //w=0.187 //l=0.345 //layer=li \
 //thickness=0.1 //x=19.85 //y=5.56 //x2=19.85 //y2=5.905
r939 (  136 260 ) resistor r=152 //w=0.17 //l=0.17 //layer=licon //count=1 \
 //x=17.17 //y=4.88 //x2=17.17 //y2=4.88
r940 (  127 256 ) resistor r=152 //w=0.17 //l=0.17 //layer=licon //count=1 \
 //x=17.14 //y=2.26 //x2=17.14 //y2=2.26
r941 (  123 124 ) resistor r=0.10734 //w=0.281 //l=0.16 //layer=m2 \
 //thickness=0.36 //x=72.265 //y=2.27 //x2=72.105 //y2=2.27
r942 (  121 124 ) resistor r=1.09733 //w=0.131 //l=1.15 //layer=m2 \
 //thickness=0.36 //x=70.955 //y=2.26 //x2=72.105 //y2=2.26
r943 (  119 121 ) resistor r=0.10734 //w=0.281 //l=0.16 //layer=m2 \
 //thickness=0.36 //x=70.795 //y=2.27 //x2=70.955 //y2=2.27
r944 (  111 113 ) resistor r=0.10734 //w=0.281 //l=0.16 //layer=m2 \
 //thickness=0.36 //x=17.125 //y=3.155 //x2=17.285 //y2=3.155
r945 (  106 117 ) resistor r=10.4813 //w=0.174 //l=14.5975 //layer=m2 \
 //thickness=0.36 //x=56.2 //y=3.125 //x2=70.79 //y2=3.14
r946 (  106 107 ) resistor r=0.410305 //w=0.131 //l=0.43 //layer=m2 \
 //thickness=0.36 //x=56.2 //y=3.125 //x2=55.77 //y2=3.125
r947 (  104 107 ) resistor r=0.125 //w=0.17 //l=0.177341 //layer=m2 \
 //thickness=0.36 //x=55.6 //y=3.14 //x2=55.77 //y2=3.125
r948 (  104 105 ) resistor r=0.939885 //w=0.131 //l=0.985 //layer=m2 \
 //thickness=0.36 //x=55.6 //y=3.14 //x2=54.615 //y2=3.14
r949 (  102 105 ) resistor r=0.1875 //w=0.17 //l=0.262393 //layer=m2 \
 //thickness=0.36 //x=54.36 //y=3.125 //x2=54.615 //y2=3.14
r950 (  102 103 ) resistor r=0.410305 //w=0.131 //l=0.43 //layer=m2 \
 //thickness=0.36 //x=54.36 //y=3.125 //x2=53.93 //y2=3.125
r951 (  100 103 ) resistor r=0.125 //w=0.17 //l=0.177341 //layer=m2 \
 //thickness=0.36 //x=53.76 //y=3.14 //x2=53.93 //y2=3.125
r952 (  100 101 ) resistor r=0.605916 //w=0.131 //l=0.635 //layer=m2 \
 //thickness=0.36 //x=53.76 //y=3.14 //x2=53.125 //y2=3.14
r953 (  98 101 ) resistor r=0.1875 //w=0.17 //l=0.264811 //layer=m2 \
 //thickness=0.36 //x=52.87 //y=3.12 //x2=53.125 //y2=3.14
r954 (  98 99 ) resistor r=0.410305 //w=0.131 //l=0.43 //layer=m2 \
 //thickness=0.36 //x=52.87 //y=3.12 //x2=52.44 //y2=3.12
r955 (  96 99 ) resistor r=0.125 //w=0.17 //l=0.179722 //layer=m2 \
 //thickness=0.36 //x=52.27 //y=3.14 //x2=52.44 //y2=3.12
r956 (  96 97 ) resistor r=0.949427 //w=0.131 //l=0.995 //layer=m2 \
 //thickness=0.36 //x=52.27 //y=3.14 //x2=51.275 //y2=3.14
r957 (  94 97 ) resistor r=0.1875 //w=0.17 //l=0.262393 //layer=m2 \
 //thickness=0.36 //x=51.02 //y=3.125 //x2=51.275 //y2=3.14
r958 (  94 95 ) resistor r=0.410305 //w=0.131 //l=0.43 //layer=m2 \
 //thickness=0.36 //x=51.02 //y=3.125 //x2=50.59 //y2=3.125
r959 (  92 95 ) resistor r=0.125 //w=0.17 //l=0.177341 //layer=m2 \
 //thickness=0.36 //x=50.42 //y=3.14 //x2=50.59 //y2=3.125
r960 (  92 93 ) resistor r=3.05821 //w=0.131 //l=3.205 //layer=m2 \
 //thickness=0.36 //x=50.42 //y=3.14 //x2=47.215 //y2=3.14
r961 (  90 93 ) resistor r=0.1875 //w=0.17 //l=0.262393 //layer=m2 \
 //thickness=0.36 //x=46.96 //y=3.125 //x2=47.215 //y2=3.14
r962 (  90 91 ) resistor r=0.410305 //w=0.131 //l=0.43 //layer=m2 \
 //thickness=0.36 //x=46.96 //y=3.125 //x2=46.53 //y2=3.125
r963 (  88 91 ) resistor r=0.125 //w=0.17 //l=0.177341 //layer=m2 \
 //thickness=0.36 //x=46.36 //y=3.14 //x2=46.53 //y2=3.125
r964 (  88 89 ) resistor r=10.8445 //w=0.131 //l=11.365 //layer=m2 \
 //thickness=0.36 //x=46.36 //y=3.14 //x2=34.995 //y2=3.14
r965 (  86 89 ) resistor r=0.1875 //w=0.17 //l=0.262393 //layer=m2 \
 //thickness=0.36 //x=34.74 //y=3.125 //x2=34.995 //y2=3.14
r966 (  86 87 ) resistor r=0.410305 //w=0.131 //l=0.43 //layer=m2 \
 //thickness=0.36 //x=34.74 //y=3.125 //x2=34.31 //y2=3.125
r967 (  84 87 ) resistor r=0.125 //w=0.17 //l=0.177341 //layer=m2 \
 //thickness=0.36 //x=34.14 //y=3.14 //x2=34.31 //y2=3.125
r968 (  84 85 ) resistor r=0.939885 //w=0.131 //l=0.985 //layer=m2 \
 //thickness=0.36 //x=34.14 //y=3.14 //x2=33.155 //y2=3.14
r969 (  82 85 ) resistor r=0.1875 //w=0.17 //l=0.262393 //layer=m2 \
 //thickness=0.36 //x=32.9 //y=3.125 //x2=33.155 //y2=3.14
r970 (  82 83 ) resistor r=0.410305 //w=0.131 //l=0.43 //layer=m2 \
 //thickness=0.36 //x=32.9 //y=3.125 //x2=32.47 //y2=3.125
r971 (  80 83 ) resistor r=0.125 //w=0.17 //l=0.177341 //layer=m2 \
 //thickness=0.36 //x=32.3 //y=3.14 //x2=32.47 //y2=3.125
r972 (  80 81 ) resistor r=0.605916 //w=0.131 //l=0.635 //layer=m2 \
 //thickness=0.36 //x=32.3 //y=3.14 //x2=31.665 //y2=3.14
r973 (  78 81 ) resistor r=0.1875 //w=0.17 //l=0.264811 //layer=m2 \
 //thickness=0.36 //x=31.41 //y=3.12 //x2=31.665 //y2=3.14
r974 (  78 79 ) resistor r=0.410305 //w=0.131 //l=0.43 //layer=m2 \
 //thickness=0.36 //x=31.41 //y=3.12 //x2=30.98 //y2=3.12
r975 (  76 79 ) resistor r=0.125 //w=0.17 //l=0.179722 //layer=m2 \
 //thickness=0.36 //x=30.81 //y=3.14 //x2=30.98 //y2=3.12
r976 (  76 77 ) resistor r=0.949427 //w=0.131 //l=0.995 //layer=m2 \
 //thickness=0.36 //x=30.81 //y=3.14 //x2=29.815 //y2=3.14
r977 (  74 77 ) resistor r=0.1875 //w=0.17 //l=0.262393 //layer=m2 \
 //thickness=0.36 //x=29.56 //y=3.125 //x2=29.815 //y2=3.14
r978 (  74 75 ) resistor r=0.410305 //w=0.131 //l=0.43 //layer=m2 \
 //thickness=0.36 //x=29.56 //y=3.125 //x2=29.13 //y2=3.125
r979 (  72 75 ) resistor r=0.235294 //w=0.17 //l=0.339411 //layer=m2 \
 //thickness=0.36 //x=28.81 //y=3.165 //x2=29.13 //y2=3.125
r980 (  72 73 ) resistor r=0.329198 //w=0.131 //l=0.345 //layer=m2 \
 //thickness=0.36 //x=28.81 //y=3.165 //x2=28.465 //y2=3.165
r981 (  70 73 ) resistor r=0.1875 //w=0.17 //l=0.267208 //layer=m2 \
 //thickness=0.36 //x=28.21 //y=3.14 //x2=28.465 //y2=3.165
r982 (  70 71 ) resistor r=2.34256 //w=0.131 //l=2.455 //layer=m2 \
 //thickness=0.36 //x=28.21 //y=3.14 //x2=25.755 //y2=3.14
r983 (  69 115 ) resistor r=2.65869 //w=0.182 //l=3.88497 //layer=m2 \
 //thickness=0.36 //x=25.07 //y=3.125 //x2=21.2 //y2=3.155
r984 (  68 71 ) resistor r=0.1875 //w=0.17 //l=0.262393 //layer=m2 \
 //thickness=0.36 //x=25.5 //y=3.125 //x2=25.755 //y2=3.14
r985 (  68 69 ) resistor r=0.410305 //w=0.131 //l=0.43 //layer=m2 \
 //thickness=0.36 //x=25.5 //y=3.125 //x2=25.07 //y2=3.125
r986 (  66 115 ) resistor r=0.110608 //w=0.182 //l=0.167332 //layer=m2 \
 //thickness=0.36 //x=21.04 //y=3.14 //x2=21.2 //y2=3.155
r987 (  66 113 ) resistor r=3.58302 //w=0.131 //l=3.755 //layer=m2 \
 //thickness=0.36 //x=21.04 //y=3.14 //x2=17.285 //y2=3.14
r988 (  65 185 ) resistor r=9.3 //w=0.17 //l=0.17 //layer=mcon //count=1 \
 //x=72.27 //y=4.885 //x2=72.27 //y2=4.885
r989 (  63 123 ) resistor r=4.5 //w=0.15 //l=0.15 //layer=via1 //count=1 \
 //x=72.265 //y=2.27 //x2=72.265 //y2=2.27
r990 (  61 180 ) resistor r=9.3 //w=0.17 //l=0.17 //layer=mcon //count=1 \
 //x=72.27 //y=2.26 //x2=72.27 //y2=2.26
r991 (  61 63 ) resistor r=0.00334225 //w=0.374 //l=0.01 //layer=m1 \
 //thickness=0.36 //x=72.215 //y=2.26 //x2=72.215 //y2=2.27
r992 (  59 119 ) resistor r=4.5 //w=0.15 //l=0.15 //layer=via1 //count=1 \
 //x=70.795 //y=2.27 //x2=70.795 //y2=2.27
r993 (  57 166 ) resistor r=9.3 //w=0.17 //l=0.17 //layer=mcon //count=1 \
 //x=70.79 //y=2.26 //x2=70.79 //y2=2.26
r994 (  57 59 ) resistor r=0.00334225 //w=0.374 //l=0.01 //layer=m1 \
 //thickness=0.36 //x=70.845 //y=2.26 //x2=70.845 //y2=2.27
r995 (  55 175 ) resistor r=9.3 //w=0.17 //l=0.17 //layer=mcon //count=1 \
 //x=70.79 //y=4.885 //x2=70.79 //y2=4.885
r996 (  52 117 ) resistor r=4.5 //w=0.15 //l=0.15 //layer=via1 //count=1 \
 //x=70.79 //y=3.14 //x2=70.79 //y2=3.14
r997 (  50 115 ) resistor r=4.5 //w=0.15 //l=0.15 //layer=via1 //count=1 \
 //x=21.2 //y=3.155 //x2=21.2 //y2=3.155
r998 (  48 50 ) resistor r=0.00490838 //w=0.382 //l=0.015 //layer=m1 \
 //thickness=0.36 //x=21.257 //y=3.14 //x2=21.257 //y2=3.155
r999 (  45 284 ) resistor r=9.3 //w=0.17 //l=0.17 //layer=mcon //count=1 \
 //x=20.77 //y=1.18 //x2=20.77 //y2=1.18
r1000 (  43 149 ) resistor r=9.3 //w=0.17 //l=0.17 //layer=mcon //count=1 \
 //x=20.73 //y=5.56 //x2=20.73 //y2=5.56
r1001 (  40 43 ) resistor r=0.117801 //w=0.191 //l=0.18 //layer=m1 \
 //thickness=0.36 //x=20.73 //y=5.38 //x2=20.73 //y2=5.56
r1002 (  39 141 ) resistor r=9.3 //w=0.17 //l=0.17 //layer=mcon //count=1 \
 //x=19.85 //y=5.56 //x2=19.85 //y2=5.56
r1003 (  37 39 ) resistor r=0.10274 //w=0.219 //l=0.18 //layer=m1 \
 //thickness=0.36 //x=19.85 //y=5.38 //x2=19.85 //y2=5.56
r1004 (  36 111 ) resistor r=4.5 //w=0.15 //l=0.15 //layer=via1 //count=1 \
 //x=17.125 //y=3.155 //x2=17.125 //y2=3.155
r1005 (  34 36 ) resistor r=0.00488281 //w=0.384 //l=0.015 //layer=m1 \
 //thickness=0.36 //x=17.185 //y=3.14 //x2=17.185 //y2=3.155
r1006 (  32 136 ) resistor r=9.3 //w=0.17 //l=0.17 //layer=mcon //count=1 \
 //x=17.17 //y=4.88 //x2=17.17 //y2=4.88
r1007 (  28 127 ) resistor r=9.3 //w=0.17 //l=0.17 //layer=mcon //count=1 \
 //x=17.14 //y=2.26 //x2=17.14 //y2=2.26
r1008 (  28 30 ) resistor r=0.0936408 //w=0.196 //l=0.125 //layer=m1 \
 //thickness=0.36 //x=17.142 //y=2.26 //x2=17.142 //y2=2.385
r1009 (  26 65 ) resistor r=0.0777782 //w=0.252 //l=0.131491 //layer=m1 \
 //thickness=0.36 //x=72.27 //y=4.755 //x2=72.267 //y2=4.885
r1010 (  25 63 ) resistor r=0.0910802 //w=0.374 //l=0.185472 //layer=m1 \
 //thickness=0.36 //x=72.27 //y=2.43 //x2=72.215 //y2=2.27
r1011 (  25 26 ) resistor r=2.21851 //w=0.131 //l=2.325 //layer=m1 \
 //thickness=0.36 //x=72.27 //y=2.43 //x2=72.27 //y2=4.755
r1012 (  24 55 ) resistor r=0.075298 //w=0.252 //l=0.125 //layer=m1 \
 //thickness=0.36 //x=70.79 //y=4.76 //x2=70.79 //y2=4.885
r1013 (  23 52 ) resistor r=0.0911593 //w=0.376 //l=0.184608 //layer=m1 \
 //thickness=0.36 //x=70.79 //y=3.3 //x2=70.737 //y2=3.14
r1014 (  23 24 ) resistor r=1.39313 //w=0.131 //l=1.46 //layer=m1 \
 //thickness=0.36 //x=70.79 //y=3.3 //x2=70.79 //y2=4.76
r1015 (  22 52 ) resistor r=0.0911593 //w=0.376 //l=0.184608 //layer=m1 \
 //thickness=0.36 //x=70.79 //y=2.98 //x2=70.737 //y2=3.14
r1016 (  21 59 ) resistor r=0.0910802 //w=0.374 //l=0.185472 //layer=m1 \
 //thickness=0.36 //x=70.79 //y=2.43 //x2=70.845 //y2=2.27
r1017 (  21 22 ) resistor r=0.524809 //w=0.131 //l=0.55 //layer=m1 \
 //thickness=0.36 //x=70.79 //y=2.43 //x2=70.79 //y2=2.98
r1018 (  19 50 ) resistor r=0.0914072 //w=0.382 //l=0.181989 //layer=m1 \
 //thickness=0.36 //x=21.21 //y=3.315 //x2=21.257 //y2=3.155
r1019 (  19 20 ) resistor r=1.88931 //w=0.131 //l=1.98 //layer=m1 \
 //thickness=0.36 //x=21.21 //y=3.315 //x2=21.21 //y2=5.295
r1020 (  18 48 ) resistor r=0.0864989 //w=0.382 //l=0.166853 //layer=m1 \
 //thickness=0.36 //x=21.21 //y=2.995 //x2=21.257 //y2=3.14
r1021 (  17 18 ) resistor r=1.02576 //w=0.131 //l=1.075 //layer=m1 \
 //thickness=0.36 //x=21.21 //y=1.92 //x2=21.21 //y2=2.995
r1022 (  15 17 ) resistor r=0.0698411 //w=0.17 //l=0.120208 //layer=m1 \
 //thickness=0.36 //x=21.125 //y=1.835 //x2=21.21 //y2=1.92
r1023 (  15 16 ) resistor r=0.257634 //w=0.131 //l=0.27 //layer=m1 \
 //thickness=0.36 //x=21.125 //y=1.835 //x2=20.855 //y2=1.835
r1024 (  14 40 ) resistor r=0.0257089 //w=0.23 //l=0.115 //layer=m1 \
 //thickness=0.36 //x=20.845 //y=5.38 //x2=20.73 //y2=5.38
r1025 (  13 20 ) resistor r=0.0698411 //w=0.17 //l=0.120208 //layer=m1 \
 //thickness=0.36 //x=21.125 //y=5.38 //x2=21.21 //y2=5.295
r1026 (  13 14 ) resistor r=0.267176 //w=0.131 //l=0.28 //layer=m1 \
 //thickness=0.36 //x=21.125 //y=5.38 //x2=20.845 //y2=5.38
r1027 (  12 16 ) resistor r=0.0698411 //w=0.17 //l=0.120208 //layer=m1 \
 //thickness=0.36 //x=20.77 //y=1.75 //x2=20.855 //y2=1.835
r1028 (  11 45 ) resistor r=0.0913624 //w=0.191 //l=0.12 //layer=m1 \
 //thickness=0.36 //x=20.77 //y=1.3 //x2=20.77 //y2=1.18
r1029 (  11 12 ) resistor r=0.429389 //w=0.131 //l=0.45 //layer=m1 \
 //thickness=0.36 //x=20.77 //y=1.3 //x2=20.77 //y2=1.75
r1030 (  8 37 ) resistor r=0.0227762 //w=0.219 //l=0.115 //layer=m1 \
 //thickness=0.36 //x=19.965 //y=5.38 //x2=19.85 //y2=5.38
r1031 (  7 40 ) resistor r=0.0257089 //w=0.23 //l=0.115 //layer=m1 \
 //thickness=0.36 //x=20.615 //y=5.38 //x2=20.73 //y2=5.38
r1032 (  7 8 ) resistor r=0.620229 //w=0.131 //l=0.65 //layer=m1 \
 //thickness=0.36 //x=20.615 //y=5.38 //x2=19.965 //y2=5.38
r1033 (  4 32 ) resistor r=0.0878548 //w=0.228 //l=0.159295 //layer=m1 \
 //thickness=0.36 //x=17.14 //y=4.735 //x2=17.17 //y2=4.88
r1034 (  3 36 ) resistor r=0.0914932 //w=0.384 //l=0.181108 //layer=m1 \
 //thickness=0.36 //x=17.14 //y=3.315 //x2=17.185 //y2=3.155
r1035 (  3 4 ) resistor r=1.35496 //w=0.131 //l=1.42 //layer=m1 \
 //thickness=0.36 //x=17.14 //y=3.315 //x2=17.14 //y2=4.735
r1036 (  2 34 ) resistor r=0.0866104 //w=0.384 //l=0.165982 //layer=m1 \
 //thickness=0.36 //x=17.14 //y=2.995 //x2=17.185 //y2=3.14
r1037 (  2 30 ) resistor r=0.582061 //w=0.131 //l=0.61 //layer=m1 \
 //thickness=0.36 //x=17.14 //y=2.995 //x2=17.14 //y2=2.385
ends PM_TMRDFFQX1\%noxref_20

subckt PM_TMRDFFQX1\%noxref_21 ( 1 3 4 5 7 8 10 11 12 14 15 16 18 22 25 28 36 \
 40 44 57 60 61 63 64 69 71 72 81 89 107 116 124 125 126 127 128 129 130 134 \
 135 136 138 144 145 147 155 156 157 161 162 )
c341 ( 157 0 ) capacitor c=0.00985497f //x=73.49 //y=1.085
c342 ( 156 0 ) capacitor c=0.0108938f //x=70.16 //y=1.085
c343 ( 155 0 ) capacitor c=0.0110396f //x=66.83 //y=1.085
c344 ( 147 0 ) capacitor c=0.0588117f //x=75.6 //y=2.265
c345 ( 145 0 ) capacitor c=0.0439576f //x=76.24 //y=1.435
c346 ( 144 0 ) capacitor c=0.0201087f //x=76.24 //y=1.09
c347 ( 138 0 ) capacitor c=0.0161986f //x=76.085 //y=1.59
c348 ( 136 0 ) capacitor c=0.0157807f //x=76.085 //y=0.935
c349 ( 135 0 ) capacitor c=0.051364f //x=75.83 //y=4.97
c350 ( 134 0 ) capacitor c=0.0406047f //x=76.12 //y=4.97
c351 ( 130 0 ) capacitor c=0.0301471f //x=75.71 //y=2.1
c352 ( 129 0 ) capacitor c=0.0255349f //x=75.71 //y=1.745
c353 ( 128 0 ) capacitor c=0.0234346f //x=75.71 //y=1.435
c354 ( 127 0 ) capacitor c=0.02013f //x=75.71 //y=1.09
c355 ( 126 0 ) capacitor c=0.153839f //x=76.195 //y=6.2
c356 ( 125 0 ) capacitor c=0.15434f //x=75.755 //y=6.2
c357 ( 116 0 ) capacitor c=6.76693e-19 //x=75.6 //y=4.88
c358 ( 107 0 ) capacitor c=9.11699e-19 //x=75.6 //y=2.265
c359 ( 89 0 ) capacitor c=0.0265472f //x=73.64 //y=5.56
c360 ( 81 0 ) capacitor c=0.0232072f //x=72.76 //y=5.56
c361 ( 72 0 ) capacitor c=0.0554023f //x=75.44 //y=4.255
c362 ( 71 0 ) capacitor c=0.00507699f //x=75.6 //y=4.255
c363 ( 69 0 ) capacitor c=0.00713729f //x=74.28 //y=4.255
c364 ( 64 0 ) capacitor c=0.0846646f //x=73.515 //y=1.405
c365 ( 63 0 ) capacitor c=0.0257508f //x=73.675 //y=1.405
c366 ( 61 0 ) capacitor c=0.00731967f //x=70.48 //y=1.405
c367 ( 60 0 ) capacitor c=0.0837058f //x=70.22 //y=1.405
c368 ( 57 0 ) capacitor c=0.00315207f //x=67.185 //y=1.405
c369 ( 44 0 ) capacitor c=0.0116317f //x=75.6 //y=2.265
c370 ( 40 0 ) capacitor c=0.0139687f //x=75.6 //y=4.25
c371 ( 36 0 ) capacitor c=0.0138558f //x=74.12 //y=4.25
c372 ( 28 0 ) capacitor c=0.0126021f //x=73.637 //y=5.39
c373 ( 25 0 ) capacitor c=0.0156957f //x=72.76 //y=5.39
c374 ( 22 0 ) capacitor c=0.00904974f //x=70.35 //y=1.36
c375 ( 18 0 ) capacitor c=0.00594737f //x=67.02 //y=1.36
c376 ( 16 0 ) capacitor c=0.010406f //x=75.6 //y=4.76
c377 ( 15 0 ) capacitor c=0.0112315f //x=75.6 //y=4.415
c378 ( 14 0 ) capacitor c=0.0499188f //x=75.6 //y=4.095
c379 ( 12 0 ) capacitor c=0.0203608f //x=74.12 //y=5.305
c380 ( 11 0 ) capacitor c=0.0114995f //x=74.12 //y=4.415
c381 ( 10 0 ) capacitor c=0.0630549f //x=74.12 //y=4.095
c382 ( 8 0 ) capacitor c=0.00834076f //x=73.765 //y=1.825
c383 ( 7 0 ) capacitor c=0.014154f //x=74.035 //y=1.825
c384 ( 5 0 ) capacitor c=0.00996583f //x=74.035 //y=5.39
c385 ( 4 0 ) capacitor c=0.00638645f //x=73.68 //y=1.74
c386 ( 3 0 ) capacitor c=0.00623208f //x=73.68 //y=1.535
c387 ( 1 0 ) capacitor c=0.0116295f //x=73.515 //y=5.39
r388 (  147 148 ) resistor r=17.5563 //w=0.302 //l=0.11 //layer=ply \
 //thickness=0.18 //x=75.6 //y=2.265 //x2=75.71 //y2=2.265
r389 (  145 154 ) resistor r=45.1352 //w=0.168 //l=0.173853 //layer=ply \
 //thickness=0.18 //x=76.24 //y=1.435 //x2=76.2 //y2=1.59
r390 (  144 153 ) resistor r=45.1352 //w=0.168 //l=0.173853 //layer=ply \
 //thickness=0.18 //x=76.24 //y=1.09 //x2=76.2 //y2=0.935
r391 (  144 145 ) resistor r=176.904 //w=0.094 //l=0.345 //layer=ply \
 //thickness=0.18 //x=76.24 //y=1.09 //x2=76.24 //y2=1.435
r392 (  139 152 ) resistor r=10.701 //w=0.21 //l=0.115 //layer=ply \
 //thickness=0.18 //x=75.865 //y=1.59 //x2=75.75 //y2=1.59
r393 (  138 154 ) resistor r=5.52526 //w=0.168 //l=0.115 //layer=ply \
 //thickness=0.18 //x=76.085 //y=1.59 //x2=76.2 //y2=1.59
r394 (  137 151 ) resistor r=5.52526 //w=0.168 //l=0.115 //layer=ply \
 //thickness=0.18 //x=75.865 //y=0.935 //x2=75.75 //y2=0.935
r395 (  136 153 ) resistor r=5.52526 //w=0.168 //l=0.115 //layer=ply \
 //thickness=0.18 //x=76.085 //y=0.935 //x2=76.2 //y2=0.935
r396 (  136 137 ) resistor r=112.809 //w=0.094 //l=0.22 //layer=ply \
 //thickness=0.18 //x=76.085 //y=0.935 //x2=75.865 //y2=0.935
r397 (  134 141 ) resistor r=26.9307 //w=0.15 //l=0.106066 //layer=ply \
 //thickness=0.18 //x=76.12 //y=4.97 //x2=76.195 //y2=5.045
r398 (  134 135 ) resistor r=148.702 //w=0.094 //l=0.29 //layer=ply \
 //thickness=0.18 //x=76.12 //y=4.97 //x2=75.83 //y2=4.97
r399 (  131 135 ) resistor r=23.403 //w=0.284 //l=0.106066 //layer=ply \
 //thickness=0.18 //x=75.755 //y=5.045 //x2=75.83 //y2=4.97
r400 (  131 150 ) resistor r=26.3063 //w=0.284 //l=0.229783 //layer=ply \
 //thickness=0.18 //x=75.755 //y=5.045 //x2=75.6 //y2=4.88
r401 (  130 148 ) resistor r=19.1248 //w=0.302 //l=0.165 //layer=ply \
 //thickness=0.18 //x=75.71 //y=2.1 //x2=75.71 //y2=2.265
r402 (  129 152 ) resistor r=39.5823 //w=0.21 //l=0.173853 //layer=ply \
 //thickness=0.18 //x=75.71 //y=1.745 //x2=75.75 //y2=1.59
r403 (  129 130 ) resistor r=182.032 //w=0.094 //l=0.355 //layer=ply \
 //thickness=0.18 //x=75.71 //y=1.745 //x2=75.71 //y2=2.1
r404 (  128 152 ) resistor r=39.5823 //w=0.21 //l=0.173853 //layer=ply \
 //thickness=0.18 //x=75.71 //y=1.435 //x2=75.75 //y2=1.59
r405 (  127 151 ) resistor r=45.1352 //w=0.168 //l=0.173853 //layer=ply \
 //thickness=0.18 //x=75.71 //y=1.09 //x2=75.75 //y2=0.935
r406 (  127 128 ) resistor r=176.904 //w=0.094 //l=0.345 //layer=ply \
 //thickness=0.18 //x=75.71 //y=1.09 //x2=75.71 //y2=1.435
r407 (  126 141 ) resistor r=592.245 //w=0.094 //l=1.155 //layer=ply \
 //thickness=0.18 //x=76.195 //y=6.2 //x2=76.195 //y2=5.045
r408 (  125 131 ) resistor r=592.245 //w=0.094 //l=1.155 //layer=ply \
 //thickness=0.18 //x=75.755 //y=6.2 //x2=75.755 //y2=5.045
r409 (  124 138 ) resistor r=56.4043 //w=0.094 //l=0.11 //layer=ply \
 //thickness=0.18 //x=75.975 //y=1.59 //x2=76.085 //y2=1.59
r410 (  124 139 ) resistor r=56.4043 //w=0.094 //l=0.11 //layer=ply \
 //thickness=0.18 //x=75.975 //y=1.59 //x2=75.865 //y2=1.59
r411 (  123 155 ) resistor r=13.3953 //w=0.172 //l=0.18 //layer=li \
 //thickness=0.1 //x=67.017 //y=1.36 //x2=67.017 //y2=1.18
r412 (  116 150 ) resistor r=152 //w=0.17 //l=0.17 //layer=licon //count=1 \
 //x=75.6 //y=4.88 //x2=75.6 //y2=4.88
r413 (  107 147 ) resistor r=152 //w=0.17 //l=0.17 //layer=licon //count=1 \
 //x=75.6 //y=2.265 //x2=75.6 //y2=2.265
r414 (  100 157 ) resistor r=12.3209 //w=0.187 //l=0.18 //layer=li \
 //thickness=0.1 //x=73.68 //y=1.36 //x2=73.68 //y2=1.18
r415 (  89 162 ) resistor r=23.2727 //w=0.187 //l=0.34 //layer=li \
 //thickness=0.1 //x=73.64 //y=5.56 //x2=73.64 //y2=5.9
r416 (  81 161 ) resistor r=23.2727 //w=0.187 //l=0.34 //layer=li \
 //thickness=0.1 //x=72.76 //y=5.56 //x2=72.76 //y2=5.9
r417 (  78 156 ) resistor r=12.3209 //w=0.187 //l=0.18 //layer=li \
 //thickness=0.1 //x=70.35 //y=1.36 //x2=70.35 //y2=1.18
r418 (  71 72 ) resistor r=0.10734 //w=0.281 //l=0.16 //layer=m2 \
 //thickness=0.36 //x=75.6 //y=4.255 //x2=75.44 //y2=4.255
r419 (  69 72 ) resistor r=1.10687 //w=0.131 //l=1.16 //layer=m2 \
 //thickness=0.36 //x=74.28 //y=4.25 //x2=75.44 //y2=4.25
r420 (  67 69 ) resistor r=0.10734 //w=0.281 //l=0.16 //layer=m2 \
 //thickness=0.36 //x=74.12 //y=4.255 //x2=74.28 //y2=4.255
r421 (  63 64 ) resistor r=0.10734 //w=0.281 //l=0.16 //layer=m2 \
 //thickness=0.36 //x=73.675 //y=1.405 //x2=73.515 //y2=1.405
r422 (  61 64 ) resistor r=2.89599 //w=0.131 //l=3.035 //layer=m2 \
 //thickness=0.36 //x=70.48 //y=1.36 //x2=73.515 //y2=1.36
r423 (  59 61 ) resistor r=0.0942778 //w=0.221 //l=0.13 //layer=m2 \
 //thickness=0.36 //x=70.35 //y=1.405 //x2=70.48 //y2=1.405
r424 (  59 60 ) resistor r=0.0942778 //w=0.221 //l=0.13 //layer=m2 \
 //thickness=0.36 //x=70.35 //y=1.405 //x2=70.22 //y2=1.405
r425 (  57 60 ) resistor r=2.89599 //w=0.131 //l=3.035 //layer=m2 \
 //thickness=0.36 //x=67.185 //y=1.36 //x2=70.22 //y2=1.36
r426 (  55 57 ) resistor r=0.10734 //w=0.281 //l=0.16 //layer=m2 \
 //thickness=0.36 //x=67.025 //y=1.405 //x2=67.185 //y2=1.405
r427 (  47 116 ) resistor r=9.3 //w=0.17 //l=0.17 //layer=mcon //count=1 \
 //x=75.6 //y=4.88 //x2=75.6 //y2=4.88
r428 (  44 107 ) resistor r=9.3 //w=0.17 //l=0.17 //layer=mcon //count=1 \
 //x=75.6 //y=2.265 //x2=75.6 //y2=2.265
r429 (  42 71 ) resistor r=4.5 //w=0.15 //l=0.15 //layer=via1 //count=1 \
 //x=75.6 //y=4.255 //x2=75.6 //y2=4.255
r430 (  40 42 ) resistor r=0.00166223 //w=0.376 //l=0.005 //layer=m1 \
 //thickness=0.36 //x=75.547 //y=4.25 //x2=75.547 //y2=4.255
r431 (  38 67 ) resistor r=4.5 //w=0.15 //l=0.15 //layer=via1 //count=1 \
 //x=74.12 //y=4.255 //x2=74.12 //y2=4.255
r432 (  36 38 ) resistor r=0.00166223 //w=0.376 //l=0.005 //layer=m1 \
 //thickness=0.36 //x=74.172 //y=4.25 //x2=74.172 //y2=4.255
r433 (  34 63 ) resistor r=4.5 //w=0.15 //l=0.15 //layer=via1 //count=1 \
 //x=73.675 //y=1.405 //x2=73.675 //y2=1.405
r434 (  32 100 ) resistor r=9.3 //w=0.17 //l=0.17 //layer=mcon //count=1 \
 //x=73.68 //y=1.36 //x2=73.68 //y2=1.36
r435 (  32 34 ) resistor r=0.0163043 //w=0.345 //l=0.045 //layer=m1 \
 //thickness=0.36 //x=73.62 //y=1.36 //x2=73.62 //y2=1.405
r436 (  30 89 ) resistor r=9.3 //w=0.17 //l=0.17 //layer=mcon //count=1 \
 //x=73.64 //y=5.56 //x2=73.64 //y2=5.56
r437 (  28 30 ) resistor r=0.0944444 //w=0.225 //l=0.17 //layer=m1 \
 //thickness=0.36 //x=73.637 //y=5.39 //x2=73.637 //y2=5.56
r438 (  27 81 ) resistor r=9.3 //w=0.17 //l=0.17 //layer=mcon //count=1 \
 //x=72.76 //y=5.56 //x2=72.76 //y2=5.56
r439 (  25 27 ) resistor r=0.0936123 //w=0.227 //l=0.17 //layer=m1 \
 //thickness=0.36 //x=72.76 //y=5.39 //x2=72.76 //y2=5.56
r440 (  24 59 ) resistor r=4.5 //w=0.15 //l=0.15 //layer=via1 //count=1 \
 //x=70.35 //y=1.405 //x2=70.35 //y2=1.405
r441 (  22 78 ) resistor r=9.3 //w=0.17 //l=0.17 //layer=mcon //count=1 \
 //x=70.35 //y=1.36 //x2=70.35 //y2=1.36
r442 (  22 24 ) resistor r=0.0163043 //w=0.345 //l=0.045 //layer=m1 \
 //thickness=0.36 //x=70.29 //y=1.36 //x2=70.29 //y2=1.405
r443 (  20 55 ) resistor r=4.5 //w=0.15 //l=0.15 //layer=via1 //count=1 \
 //x=67.025 //y=1.405 //x2=67.025 //y2=1.405
r444 (  18 123 ) resistor r=9.3 //w=0.17 //l=0.17 //layer=mcon //count=1 \
 //x=67.02 //y=1.36 //x2=67.02 //y2=1.36
r445 (  18 20 ) resistor r=0.0150401 //w=0.374 //l=0.045 //layer=m1 \
 //thickness=0.36 //x=67.075 //y=1.36 //x2=67.075 //y2=1.405
r446 (  16 47 ) resistor r=0.0732479 //w=0.241 //l=0.122474 //layer=m1 \
 //thickness=0.36 //x=75.6 //y=4.76 //x2=75.605 //y2=4.88
r447 (  15 42 ) resistor r=0.0911593 //w=0.376 //l=0.184608 //layer=m1 \
 //thickness=0.36 //x=75.6 //y=4.415 //x2=75.547 //y2=4.255
r448 (  15 16 ) resistor r=0.329198 //w=0.131 //l=0.345 //layer=m1 \
 //thickness=0.36 //x=75.6 //y=4.415 //x2=75.6 //y2=4.76
r449 (  14 40 ) resistor r=0.0894971 //w=0.376 //l=0.179555 //layer=m1 \
 //thickness=0.36 //x=75.6 //y=4.095 //x2=75.547 //y2=4.25
r450 (  13 44 ) resistor r=0.116051 //w=0.211 //l=0.165 //layer=m1 \
 //thickness=0.36 //x=75.6 //y=2.43 //x2=75.6 //y2=2.265
r451 (  13 14 ) resistor r=1.58874 //w=0.131 //l=1.665 //layer=m1 \
 //thickness=0.36 //x=75.6 //y=2.43 //x2=75.6 //y2=4.095
r452 (  11 38 ) resistor r=0.0911593 //w=0.376 //l=0.184174 //layer=m1 \
 //thickness=0.36 //x=74.12 //y=4.415 //x2=74.172 //y2=4.255
r453 (  11 12 ) resistor r=0.849237 //w=0.131 //l=0.89 //layer=m1 \
 //thickness=0.36 //x=74.12 //y=4.415 //x2=74.12 //y2=5.305
r454 (  10 36 ) resistor r=0.0894971 //w=0.376 //l=0.179123 //layer=m1 \
 //thickness=0.36 //x=74.12 //y=4.095 //x2=74.172 //y2=4.25
r455 (  9 10 ) resistor r=2.08492 //w=0.131 //l=2.185 //layer=m1 \
 //thickness=0.36 //x=74.12 //y=1.91 //x2=74.12 //y2=4.095
r456 (  7 9 ) resistor r=0.0698411 //w=0.17 //l=0.120208 //layer=m1 \
 //thickness=0.36 //x=74.035 //y=1.825 //x2=74.12 //y2=1.91
r457 (  7 8 ) resistor r=0.257634 //w=0.131 //l=0.27 //layer=m1 \
 //thickness=0.36 //x=74.035 //y=1.825 //x2=73.765 //y2=1.825
r458 (  6 28 ) resistor r=0.0243946 //w=0.225 //l=0.123 //layer=m1 \
 //thickness=0.36 //x=73.76 //y=5.39 //x2=73.637 //y2=5.39
r459 (  5 12 ) resistor r=0.0698411 //w=0.17 //l=0.120208 //layer=m1 \
 //thickness=0.36 //x=74.035 //y=5.39 //x2=74.12 //y2=5.305
r460 (  5 6 ) resistor r=0.262405 //w=0.131 //l=0.275 //layer=m1 \
 //thickness=0.36 //x=74.035 //y=5.39 //x2=73.76 //y2=5.39
r461 (  4 8 ) resistor r=0.0698411 //w=0.17 //l=0.120208 //layer=m1 \
 //thickness=0.36 //x=73.68 //y=1.74 //x2=73.765 //y2=1.825
r462 (  3 34 ) resistor r=0.0792909 //w=0.345 //l=0.157162 //layer=m1 \
 //thickness=0.36 //x=73.68 //y=1.535 //x2=73.62 //y2=1.405
r463 (  3 4 ) resistor r=0.195611 //w=0.131 //l=0.205 //layer=m1 \
 //thickness=0.36 //x=73.68 //y=1.535 //x2=73.68 //y2=1.74
r464 (  2 25 ) resistor r=0.0249239 //w=0.227 //l=0.125 //layer=m1 \
 //thickness=0.36 //x=72.885 //y=5.39 //x2=72.76 //y2=5.39
r465 (  1 28 ) resistor r=0.0243946 //w=0.225 //l=0.122 //layer=m1 \
 //thickness=0.36 //x=73.515 //y=5.39 //x2=73.637 //y2=5.39
r466 (  1 2 ) resistor r=0.601145 //w=0.131 //l=0.63 //layer=m1 \
 //thickness=0.36 //x=73.515 //y=5.39 //x2=72.885 //y2=5.39
ends PM_TMRDFFQX1\%noxref_21

subckt PM_TMRDFFQX1\%VDD ( 1 2 109 110 111 113 114 115 119 120 137 196 205 215 \
 223 233 249 257 283 293 319 329 351 359 385 395 421 431 441 449 465 475 497 \
 505 531 541 567 577 599 607 633 641 651 661 677 687 713 723 745 753 779 789 \
 799 815 825 837 872 880 900 918 923 927 932 937 941 947 952 957 961 966 971 \
 977 981 986 991 995 1000 1001 1002 1003 1007 1008 1009 1010 1011 1012 1013 \
 1014 1015 1016 1017 1018 1019 1020 1021 1022 1023 1024 1025 1026 1027 1028 \
 1029 1030 1031 1032 1033 1034 1035 1036 1037 1038 1039 1040 1041 1042 1043 \
 1044 1045 1046 1047 1048 1049 1050 1051 1052 1053 1054 1055 1056 1057 1058 \
 1059 1060 1061 1062 1063 1064 1065 1066 1067 1068 1069 )
c1415 ( 1069 0 ) capacitor c=0.0632648f //x=76.27 //y=5.2
c1416 ( 1068 0 ) capacitor c=0.0575062f //x=75.4 //y=5.2
c1417 ( 1067 0 ) capacitor c=0.0424825f //x=67.275 //y=5.205
c1418 ( 1066 0 ) capacitor c=0.0223606f //x=66.395 //y=5.205
c1419 ( 1065 0 ) capacitor c=0.050992f //x=65.525 //y=5.205
c1420 ( 1064 0 ) capacitor c=0.0393089f //x=63.945 //y=5.2
c1421 ( 1063 0 ) capacitor c=0.0247431f //x=63.065 //y=5.2
c1422 ( 1062 0 ) capacitor c=0.0622781f //x=62.195 //y=5.2
c1423 ( 1061 0 ) capacitor c=0.0386927f //x=60.615 //y=5.2
c1424 ( 1060 0 ) capacitor c=0.0248174f //x=59.735 //y=5.2
c1425 ( 1059 0 ) capacitor c=0.062487f //x=58.865 //y=5.2
c1426 ( 1058 0 ) capacitor c=0.0390282f //x=57.285 //y=5.2
c1427 ( 1057 0 ) capacitor c=0.0248174f //x=56.405 //y=5.2
c1428 ( 1056 0 ) capacitor c=0.0623361f //x=55.535 //y=5.2
c1429 ( 1055 0 ) capacitor c=0.039544f //x=53.955 //y=5.2
c1430 ( 1054 0 ) capacitor c=0.0248174f //x=53.075 //y=5.2
c1431 ( 1053 0 ) capacitor c=0.0623361f //x=52.205 //y=5.2
c1432 ( 1052 0 ) capacitor c=0.039544f //x=50.625 //y=5.2
c1433 ( 1051 0 ) capacitor c=0.0248174f //x=49.745 //y=5.2
c1434 ( 1050 0 ) capacitor c=0.0627254f //x=48.875 //y=5.2
c1435 ( 1049 0 ) capacitor c=0.0466891f //x=46.995 //y=5.2
c1436 ( 1048 0 ) capacitor c=0.0255836f //x=46.115 //y=5.2
c1437 ( 1047 0 ) capacitor c=0.0255777f //x=45.235 //y=5.2
c1438 ( 1046 0 ) capacitor c=0.0674366f //x=44.365 //y=5.2
c1439 ( 1045 0 ) capacitor c=0.0400462f //x=42.485 //y=5.2
c1440 ( 1044 0 ) capacitor c=0.0248174f //x=41.605 //y=5.2
c1441 ( 1043 0 ) capacitor c=0.0622502f //x=40.735 //y=5.2
c1442 ( 1042 0 ) capacitor c=0.0393089f //x=39.155 //y=5.2
c1443 ( 1041 0 ) capacitor c=0.0248174f //x=38.275 //y=5.2
c1444 ( 1040 0 ) capacitor c=0.0622502f //x=37.405 //y=5.2
c1445 ( 1039 0 ) capacitor c=0.0390282f //x=35.825 //y=5.2
c1446 ( 1038 0 ) capacitor c=0.0248174f //x=34.945 //y=5.2
c1447 ( 1037 0 ) capacitor c=0.0623361f //x=34.075 //y=5.2
c1448 ( 1036 0 ) capacitor c=0.039544f //x=32.495 //y=5.2
c1449 ( 1035 0 ) capacitor c=0.0248174f //x=31.615 //y=5.2
c1450 ( 1034 0 ) capacitor c=0.0623361f //x=30.745 //y=5.2
c1451 ( 1033 0 ) capacitor c=0.039544f //x=29.165 //y=5.2
c1452 ( 1032 0 ) capacitor c=0.0248174f //x=28.285 //y=5.2
c1453 ( 1031 0 ) capacitor c=0.0627254f //x=27.415 //y=5.2
c1454 ( 1030 0 ) capacitor c=0.0466891f //x=25.535 //y=5.2
c1455 ( 1029 0 ) capacitor c=0.0255836f //x=24.655 //y=5.2
c1456 ( 1028 0 ) capacitor c=0.0255777f //x=23.775 //y=5.2
c1457 ( 1027 0 ) capacitor c=0.067437f //x=22.905 //y=5.2
c1458 ( 1026 0 ) capacitor c=0.0397412f //x=21.025 //y=5.2
c1459 ( 1025 0 ) capacitor c=0.0248174f //x=20.145 //y=5.2
c1460 ( 1024 0 ) capacitor c=0.0622502f //x=19.275 //y=5.2
c1461 ( 1023 0 ) capacitor c=0.0393089f //x=17.695 //y=5.2
c1462 ( 1022 0 ) capacitor c=0.0248174f //x=16.815 //y=5.2
c1463 ( 1021 0 ) capacitor c=0.0622535f //x=15.945 //y=5.2
c1464 ( 1020 0 ) capacitor c=0.0390282f //x=14.365 //y=5.2
c1465 ( 1019 0 ) capacitor c=0.0248174f //x=13.485 //y=5.2
c1466 ( 1018 0 ) capacitor c=0.0623361f //x=12.615 //y=5.2
c1467 ( 1017 0 ) capacitor c=0.039544f //x=11.035 //y=5.2
c1468 ( 1016 0 ) capacitor c=0.0248174f //x=10.155 //y=5.2
c1469 ( 1015 0 ) capacitor c=0.0623361f //x=9.285 //y=5.2
c1470 ( 1014 0 ) capacitor c=0.039544f //x=7.705 //y=5.2
c1471 ( 1013 0 ) capacitor c=0.0248174f //x=6.825 //y=5.2
c1472 ( 1012 0 ) capacitor c=0.0627254f //x=5.955 //y=5.2
c1473 ( 1011 0 ) capacitor c=0.0466891f //x=4.075 //y=5.2
c1474 ( 1010 0 ) capacitor c=0.0255836f //x=3.195 //y=5.2
c1475 ( 1009 0 ) capacitor c=0.0256114f //x=2.315 //y=5.2
c1476 ( 1008 0 ) capacitor c=0.0693239f //x=1.445 //y=5.2
c1477 ( 1007 0 ) capacitor c=0.258867f //x=76.34 //y=7.58
c1478 ( 1005 0 ) capacitor c=0.00597439f //x=75.6 //y=7.58
c1479 ( 1003 0 ) capacitor c=0.117824f //x=74.86 //y=7.585
c1480 ( 1002 0 ) capacitor c=0.121201f //x=71.53 //y=7.585
c1481 ( 1001 0 ) capacitor c=0.125864f //x=68.2 //y=7.585
c1482 ( 1000 0 ) capacitor c=0.123835f //x=64.87 //y=7.585
c1483 ( 999 0 ) capacitor c=0.00597439f //x=64.13 //y=7.58
c1484 ( 997 0 ) capacitor c=0.00597439f //x=63.21 //y=7.585
c1485 ( 996 0 ) capacitor c=0.00597439f //x=62.33 //y=7.585
c1486 ( 995 0 ) capacitor c=0.123628f //x=61.54 //y=7.585
c1487 ( 994 0 ) capacitor c=0.00597439f //x=60.76 //y=7.585
c1488 ( 993 0 ) capacitor c=0.00597439f //x=59.88 //y=7.585
c1489 ( 992 0 ) capacitor c=0.00597439f //x=59 //y=7.585
c1490 ( 991 0 ) capacitor c=0.126753f //x=58.21 //y=7.585
c1491 ( 990 0 ) capacitor c=0.00597439f //x=57.43 //y=7.585
c1492 ( 989 0 ) capacitor c=0.00597439f //x=56.55 //y=7.585
c1493 ( 988 0 ) capacitor c=0.00597439f //x=55.62 //y=7.58
c1494 ( 986 0 ) capacitor c=0.126609f //x=54.88 //y=7.585
c1495 ( 985 0 ) capacitor c=0.00597439f //x=54.14 //y=7.58
c1496 ( 983 0 ) capacitor c=0.00597439f //x=53.22 //y=7.585
c1497 ( 982 0 ) capacitor c=0.00597439f //x=52.34 //y=7.585
c1498 ( 981 0 ) capacitor c=0.126767f //x=51.55 //y=7.585
c1499 ( 980 0 ) capacitor c=0.00597439f //x=50.77 //y=7.585
c1500 ( 979 0 ) capacitor c=0.00597439f //x=49.89 //y=7.585
c1501 ( 978 0 ) capacitor c=0.00597439f //x=49.01 //y=7.585
c1502 ( 977 0 ) capacitor c=0.145722f //x=48.22 //y=7.585
c1503 ( 976 0 ) capacitor c=0.00597439f //x=47.14 //y=7.585
c1504 ( 975 0 ) capacitor c=0.00597439f //x=46.26 //y=7.585
c1505 ( 974 0 ) capacitor c=0.00597439f //x=45.38 //y=7.585
c1506 ( 973 0 ) capacitor c=0.00597439f //x=44.52 //y=7.58
c1507 ( 971 0 ) capacitor c=0.145674f //x=43.41 //y=7.585
c1508 ( 970 0 ) capacitor c=0.00597439f //x=42.63 //y=7.585
c1509 ( 969 0 ) capacitor c=0.00597439f //x=41.75 //y=7.585
c1510 ( 968 0 ) capacitor c=0.00597439f //x=40.82 //y=7.58
c1511 ( 966 0 ) capacitor c=0.126767f //x=40.08 //y=7.585
c1512 ( 965 0 ) capacitor c=0.00597439f //x=39.34 //y=7.58
c1513 ( 963 0 ) capacitor c=0.00597439f //x=38.42 //y=7.585
c1514 ( 962 0 ) capacitor c=0.00597439f //x=37.54 //y=7.585
c1515 ( 961 0 ) capacitor c=0.125969f //x=36.75 //y=7.585
c1516 ( 960 0 ) capacitor c=0.00597439f //x=35.97 //y=7.585
c1517 ( 959 0 ) capacitor c=0.00597439f //x=35.09 //y=7.585
c1518 ( 958 0 ) capacitor c=0.00597439f //x=34.21 //y=7.585
c1519 ( 957 0 ) capacitor c=0.126609f //x=33.42 //y=7.585
c1520 ( 956 0 ) capacitor c=0.00597439f //x=32.64 //y=7.585
c1521 ( 955 0 ) capacitor c=0.00597439f //x=31.76 //y=7.585
c1522 ( 954 0 ) capacitor c=0.00597439f //x=30.83 //y=7.58
c1523 ( 952 0 ) capacitor c=0.126767f //x=30.09 //y=7.585
c1524 ( 951 0 ) capacitor c=0.00597439f //x=29.35 //y=7.58
c1525 ( 949 0 ) capacitor c=0.00597439f //x=28.43 //y=7.585
c1526 ( 948 0 ) capacitor c=0.00597439f //x=27.55 //y=7.585
c1527 ( 947 0 ) capacitor c=0.145722f //x=26.76 //y=7.585
c1528 ( 946 0 ) capacitor c=0.00597439f //x=25.65 //y=7.58
c1529 ( 944 0 ) capacitor c=0.00597439f //x=24.8 //y=7.585
c1530 ( 943 0 ) capacitor c=0.00597439f //x=23.92 //y=7.585
c1531 ( 942 0 ) capacitor c=0.00597439f //x=23.04 //y=7.585
c1532 ( 941 0 ) capacitor c=0.145674f //x=21.95 //y=7.585
c1533 ( 940 0 ) capacitor c=0.00597439f //x=21.17 //y=7.585
c1534 ( 939 0 ) capacitor c=0.00597439f //x=20.29 //y=7.585
c1535 ( 938 0 ) capacitor c=0.00597439f //x=19.41 //y=7.585
c1536 ( 937 0 ) capacitor c=0.126767f //x=18.62 //y=7.585
c1537 ( 936 0 ) capacitor c=0.00597439f //x=17.84 //y=7.585
c1538 ( 935 0 ) capacitor c=0.00597439f //x=16.96 //y=7.585
c1539 ( 934 0 ) capacitor c=0.00597439f //x=16.03 //y=7.58
c1540 ( 932 0 ) capacitor c=0.126076f //x=15.29 //y=7.585
c1541 ( 931 0 ) capacitor c=0.00597439f //x=14.55 //y=7.58
c1542 ( 929 0 ) capacitor c=0.00597439f //x=13.63 //y=7.585
c1543 ( 928 0 ) capacitor c=0.00597439f //x=12.75 //y=7.585
c1544 ( 927 0 ) capacitor c=0.126609f //x=11.96 //y=7.585
c1545 ( 926 0 ) capacitor c=0.00597439f //x=11.18 //y=7.585
c1546 ( 925 0 ) capacitor c=0.00597439f //x=10.3 //y=7.585
c1547 ( 924 0 ) capacitor c=0.00597439f //x=9.42 //y=7.585
c1548 ( 923 0 ) capacitor c=0.126767f //x=8.63 //y=7.585
c1549 ( 922 0 ) capacitor c=0.00597439f //x=7.85 //y=7.585
c1550 ( 921 0 ) capacitor c=0.00597439f //x=6.97 //y=7.585
c1551 ( 920 0 ) capacitor c=0.00597439f //x=6.04 //y=7.58
c1552 ( 918 0 ) capacitor c=0.145722f //x=5.3 //y=7.585
c1553 ( 917 0 ) capacitor c=0.00597439f //x=4.22 //y=7.585
c1554 ( 916 0 ) capacitor c=0.00597439f //x=3.34 //y=7.585
c1555 ( 915 0 ) capacitor c=0.00597439f //x=2.46 //y=7.585
c1556 ( 914 0 ) capacitor c=0.00597439f //x=1.58 //y=7.585
c1557 ( 900 0 ) capacitor c=0.0290604f //x=76.33 //y=7.585
c1558 ( 890 0 ) capacitor c=0.021306f //x=75.45 //y=7.585
c1559 ( 880 0 ) capacitor c=0.134506f //x=74.69 //y=7.585
c1560 ( 872 0 ) capacitor c=0.131873f //x=71.36 //y=7.585
c1561 ( 837 0 ) capacitor c=0.133054f //x=68.03 //y=7.585
c1562 ( 833 0 ) capacitor c=0.0277785f //x=64.7 //y=7.585
c1563 ( 825 0 ) capacitor c=0.0287376f //x=64.005 //y=7.585
c1564 ( 815 0 ) capacitor c=0.0291078f //x=63.125 //y=7.585
c1565 ( 803 0 ) capacitor c=0.0283511f //x=62.245 //y=7.585
c1566 ( 799 0 ) capacitor c=0.0261965f //x=61.37 //y=7.585
c1567 ( 789 0 ) capacitor c=0.0287375f //x=60.675 //y=7.585
c1568 ( 779 0 ) capacitor c=0.0291078f //x=59.795 //y=7.585
c1569 ( 769 0 ) capacitor c=0.0283511f //x=58.915 //y=7.585
c1570 ( 763 0 ) capacitor c=0.0273918f //x=58.04 //y=7.585
c1571 ( 753 0 ) capacitor c=0.0287377f //x=57.345 //y=7.585
c1572 ( 745 0 ) capacitor c=0.0291078f //x=56.465 //y=7.585
c1573 ( 735 0 ) capacitor c=0.0283511f //x=55.585 //y=7.585
c1574 ( 731 0 ) capacitor c=0.0277785f //x=54.71 //y=7.585
c1575 ( 723 0 ) capacitor c=0.0287376f //x=54.015 //y=7.585
c1576 ( 713 0 ) capacitor c=0.0291078f //x=53.135 //y=7.585
c1577 ( 701 0 ) capacitor c=0.0283511f //x=52.255 //y=7.585
c1578 ( 697 0 ) capacitor c=0.0277785f //x=51.38 //y=7.585
c1579 ( 687 0 ) capacitor c=0.0287375f //x=50.685 //y=7.585
c1580 ( 677 0 ) capacitor c=0.0291078f //x=49.805 //y=7.585
c1581 ( 667 0 ) capacitor c=0.0283511f //x=48.925 //y=7.585
c1582 ( 661 0 ) capacitor c=0.042257f //x=48.05 //y=7.585
c1583 ( 651 0 ) capacitor c=0.0288858f //x=47.055 //y=7.585
c1584 ( 641 0 ) capacitor c=0.0288441f //x=46.175 //y=7.585
c1585 ( 633 0 ) capacitor c=0.0289834f //x=45.295 //y=7.585
c1586 ( 623 0 ) capacitor c=0.0455283f //x=44.415 //y=7.585
c1587 ( 617 0 ) capacitor c=0.0277785f //x=43.24 //y=7.585
c1588 ( 607 0 ) capacitor c=0.0287376f //x=42.545 //y=7.585
c1589 ( 599 0 ) capacitor c=0.0291078f //x=41.665 //y=7.585
c1590 ( 589 0 ) capacitor c=0.0283511f //x=40.785 //y=7.585
c1591 ( 585 0 ) capacitor c=0.0277785f //x=39.91 //y=7.585
c1592 ( 577 0 ) capacitor c=0.0287375f //x=39.215 //y=7.585
c1593 ( 567 0 ) capacitor c=0.0291078f //x=38.335 //y=7.585
c1594 ( 555 0 ) capacitor c=0.0283511f //x=37.455 //y=7.585
c1595 ( 551 0 ) capacitor c=0.0273918f //x=36.58 //y=7.585
c1596 ( 541 0 ) capacitor c=0.0287377f //x=35.885 //y=7.585
c1597 ( 531 0 ) capacitor c=0.0291078f //x=35.005 //y=7.585
c1598 ( 521 0 ) capacitor c=0.0283511f //x=34.125 //y=7.585
c1599 ( 515 0 ) capacitor c=0.0277785f //x=33.25 //y=7.585
c1600 ( 505 0 ) capacitor c=0.0287376f //x=32.555 //y=7.585
c1601 ( 497 0 ) capacitor c=0.0291078f //x=31.675 //y=7.585
c1602 ( 487 0 ) capacitor c=0.0283511f //x=30.795 //y=7.585
c1603 ( 483 0 ) capacitor c=0.0277785f //x=29.92 //y=7.585
c1604 ( 475 0 ) capacitor c=0.0287375f //x=29.225 //y=7.585
c1605 ( 465 0 ) capacitor c=0.0291078f //x=28.345 //y=7.585
c1606 ( 453 0 ) capacitor c=0.0283511f //x=27.465 //y=7.585
c1607 ( 449 0 ) capacitor c=0.042257f //x=26.59 //y=7.585
c1608 ( 441 0 ) capacitor c=0.0288858f //x=25.595 //y=7.585
c1609 ( 431 0 ) capacitor c=0.0288441f //x=24.715 //y=7.585
c1610 ( 421 0 ) capacitor c=0.0289834f //x=23.835 //y=7.585
c1611 ( 409 0 ) capacitor c=0.0455283f //x=22.955 //y=7.585
c1612 ( 405 0 ) capacitor c=0.0277785f //x=21.78 //y=7.585
c1613 ( 395 0 ) capacitor c=0.0287376f //x=21.085 //y=7.585
c1614 ( 385 0 ) capacitor c=0.0291078f //x=20.205 //y=7.585
c1615 ( 375 0 ) capacitor c=0.0283511f //x=19.325 //y=7.585
c1616 ( 369 0 ) capacitor c=0.0277785f //x=18.45 //y=7.585
c1617 ( 359 0 ) capacitor c=0.0287375f //x=17.755 //y=7.585
c1618 ( 351 0 ) capacitor c=0.0291078f //x=16.875 //y=7.585
c1619 ( 341 0 ) capacitor c=0.0283511f //x=15.995 //y=7.585
c1620 ( 337 0 ) capacitor c=0.0273918f //x=15.12 //y=7.585
c1621 ( 329 0 ) capacitor c=0.0287377f //x=14.425 //y=7.585
c1622 ( 319 0 ) capacitor c=0.0291078f //x=13.545 //y=7.585
c1623 ( 307 0 ) capacitor c=0.0283511f //x=12.665 //y=7.585
c1624 ( 303 0 ) capacitor c=0.0277785f //x=11.79 //y=7.585
c1625 ( 293 0 ) capacitor c=0.0287376f //x=11.095 //y=7.585
c1626 ( 283 0 ) capacitor c=0.0291078f //x=10.215 //y=7.585
c1627 ( 273 0 ) capacitor c=0.0283511f //x=9.335 //y=7.585
c1628 ( 267 0 ) capacitor c=0.0277785f //x=8.46 //y=7.585
c1629 ( 257 0 ) capacitor c=0.0287375f //x=7.765 //y=7.585
c1630 ( 249 0 ) capacitor c=0.0291078f //x=6.885 //y=7.585
c1631 ( 239 0 ) capacitor c=0.0283511f //x=6.005 //y=7.585
c1632 ( 233 0 ) capacitor c=0.042257f //x=5.13 //y=7.585
c1633 ( 223 0 ) capacitor c=0.0288858f //x=4.135 //y=7.585
c1634 ( 215 0 ) capacitor c=0.0288441f //x=3.255 //y=7.585
c1635 ( 205 0 ) capacitor c=0.0289834f //x=2.375 //y=7.585
c1636 ( 196 0 ) capacitor c=0.253472f //x=1.23 //y=7.58
c1637 ( 193 0 ) capacitor c=0.0455283f //x=1.495 //y=7.585
c1638 ( 184 0 ) capacitor c=0.00499323f //x=67.42 //y=7.585
c1639 ( 181 0 ) capacitor c=0.00499323f //x=66.54 //y=7.585
c1640 ( 176 0 ) capacitor c=0.00499323f //x=65.61 //y=7.58
c1641 ( 137 0 ) capacitor c=0.348083f //x=76.34 //y=7.58
c1642 ( 120 0 ) capacitor c=0.00657976f //x=67.42 //y=7.41
c1643 ( 119 0 ) capacitor c=0.00827249f //x=67.42 //y=7.035
c1644 ( 115 0 ) capacitor c=0.0220779f //x=67.335 //y=7.585
c1645 ( 114 0 ) capacitor c=0.00369726f //x=66.54 //y=7.41
c1646 ( 113 0 ) capacitor c=0.00650208f //x=66.54 //y=7.035
c1647 ( 111 0 ) capacitor c=0.02242f //x=66.455 //y=7.585
c1648 ( 110 0 ) capacitor c=0.0090067f //x=65.66 //y=7.41
c1649 ( 109 0 ) capacitor c=0.0125184f //x=65.66 //y=7.035
c1650 ( 2 0 ) capacitor c=2.32864f //x=65.575 //y=7.585
r1651 (  902 1007 ) resistor r=4.23183 //w=0.7 //l=0.175 //layer=li \
 //thickness=0.1 //x=76.415 //y=7.41 //x2=76.415 //y2=7.585
r1652 (  902 1069 ) resistor r=56.4706 //w=0.187 //l=0.825 //layer=li \
 //thickness=0.1 //x=76.415 //y=7.41 //x2=76.415 //y2=6.585
r1653 (  901 1005 ) resistor r=2.87058 //w=0.35 //l=0.085 //layer=li \
 //thickness=0.1 //x=75.62 //y=7.585 //x2=75.535 //y2=7.585
r1654 (  900 1007 ) resistor r=2.87058 //w=0.35 //l=0.085 //layer=li \
 //thickness=0.1 //x=76.33 //y=7.585 //x2=76.415 //y2=7.585
r1655 (  900 901 ) resistor r=24.7629 //w=0.367 //l=0.71 //layer=li \
 //thickness=0.1 //x=76.33 //y=7.585 //x2=75.62 //y2=7.585
r1656 (  892 1005 ) resistor r=4.23183 //w=0.7 //l=0.175 //layer=li \
 //thickness=0.1 //x=75.535 //y=7.41 //x2=75.535 //y2=7.585
r1657 (  892 1068 ) resistor r=56.4706 //w=0.187 //l=0.825 //layer=li \
 //thickness=0.1 //x=75.535 //y=7.41 //x2=75.535 //y2=6.585
r1658 (  891 1003 ) resistor r=5.29055 //w=0.35 //l=0.17 //layer=li \
 //thickness=0.1 //x=75.03 //y=7.585 //x2=74.86 //y2=7.585
r1659 (  890 1005 ) resistor r=2.87058 //w=0.35 //l=0.085 //layer=li \
 //thickness=0.1 //x=75.45 //y=7.585 //x2=75.535 //y2=7.585
r1660 (  890 891 ) resistor r=14.6485 //w=0.367 //l=0.42 //layer=li \
 //thickness=0.1 //x=75.45 //y=7.585 //x2=75.03 //y2=7.585
r1661 (  885 887 ) resistor r=38.7139 //w=0.367 //l=1.11 //layer=li \
 //thickness=0.1 //x=73.01 //y=7.585 //x2=74.12 //y2=7.585
r1662 (  883 885 ) resistor r=38.7139 //w=0.367 //l=1.11 //layer=li \
 //thickness=0.1 //x=71.9 //y=7.585 //x2=73.01 //y2=7.585
r1663 (  881 1002 ) resistor r=5.29055 //w=0.35 //l=0.17 //layer=li \
 //thickness=0.1 //x=71.7 //y=7.585 //x2=71.53 //y2=7.585
r1664 (  881 883 ) resistor r=6.97548 //w=0.367 //l=0.2 //layer=li \
 //thickness=0.1 //x=71.7 //y=7.585 //x2=71.9 //y2=7.585
r1665 (  880 1003 ) resistor r=5.29055 //w=0.35 //l=0.17 //layer=li \
 //thickness=0.1 //x=74.69 //y=7.585 //x2=74.86 //y2=7.585
r1666 (  880 887 ) resistor r=19.8801 //w=0.367 //l=0.57 //layer=li \
 //thickness=0.1 //x=74.69 //y=7.585 //x2=74.12 //y2=7.585
r1667 (  875 877 ) resistor r=38.7139 //w=0.367 //l=1.11 //layer=li \
 //thickness=0.1 //x=69.31 //y=7.585 //x2=70.42 //y2=7.585
r1668 (  873 1001 ) resistor r=5.29055 //w=0.35 //l=0.17 //layer=li \
 //thickness=0.1 //x=68.37 //y=7.585 //x2=68.2 //y2=7.585
r1669 (  873 875 ) resistor r=32.7847 //w=0.367 //l=0.94 //layer=li \
 //thickness=0.1 //x=68.37 //y=7.585 //x2=69.31 //y2=7.585
r1670 (  872 1002 ) resistor r=5.29055 //w=0.35 //l=0.17 //layer=li \
 //thickness=0.1 //x=71.36 //y=7.585 //x2=71.53 //y2=7.585
r1671 (  872 877 ) resistor r=32.7847 //w=0.367 //l=0.94 //layer=li \
 //thickness=0.1 //x=71.36 //y=7.585 //x2=70.42 //y2=7.585
r1672 (  868 1067 ) resistor r=23.2727 //w=0.187 //l=0.34 //layer=li \
 //thickness=0.1 //x=67.42 //y=6.92 //x2=67.42 //y2=6.58
r1673 (  853 1065 ) resistor r=23.2727 //w=0.187 //l=0.34 //layer=li \
 //thickness=0.1 //x=65.66 //y=6.92 //x2=65.66 //y2=6.58
r1674 (  842 844 ) resistor r=38.7139 //w=0.367 //l=1.11 //layer=li \
 //thickness=0.1 //x=66.72 //y=7.585 //x2=67.83 //y2=7.585
r1675 (  840 842 ) resistor r=38.7139 //w=0.367 //l=1.11 //layer=li \
 //thickness=0.1 //x=65.61 //y=7.585 //x2=66.72 //y2=7.585
r1676 (  838 1000 ) resistor r=5.29055 //w=0.35 //l=0.17 //layer=li \
 //thickness=0.1 //x=65.04 //y=7.585 //x2=64.87 //y2=7.585
r1677 (  838 840 ) resistor r=19.8801 //w=0.367 //l=0.57 //layer=li \
 //thickness=0.1 //x=65.04 //y=7.585 //x2=65.61 //y2=7.585
r1678 (  837 1001 ) resistor r=5.29055 //w=0.35 //l=0.17 //layer=li \
 //thickness=0.1 //x=68.03 //y=7.585 //x2=68.2 //y2=7.585
r1679 (  837 844 ) resistor r=6.97548 //w=0.367 //l=0.2 //layer=li \
 //thickness=0.1 //x=68.03 //y=7.585 //x2=67.83 //y2=7.585
r1680 (  834 999 ) resistor r=2.87058 //w=0.35 //l=0.085 //layer=li \
 //thickness=0.1 //x=64.175 //y=7.585 //x2=64.09 //y2=7.585
r1681 (  833 1000 ) resistor r=5.29055 //w=0.35 //l=0.17 //layer=li \
 //thickness=0.1 //x=64.7 //y=7.585 //x2=64.87 //y2=7.585
r1682 (  833 834 ) resistor r=18.3106 //w=0.367 //l=0.525 //layer=li \
 //thickness=0.1 //x=64.7 //y=7.585 //x2=64.175 //y2=7.585
r1683 (  827 999 ) resistor r=4.23183 //w=0.7 //l=0.175 //layer=li \
 //thickness=0.1 //x=64.09 //y=7.41 //x2=64.09 //y2=7.585
r1684 (  827 1064 ) resistor r=33.1979 //w=0.187 //l=0.485 //layer=li \
 //thickness=0.1 //x=64.09 //y=7.41 //x2=64.09 //y2=6.925
r1685 (  826 997 ) resistor r=2.87058 //w=0.35 //l=0.085 //layer=li \
 //thickness=0.1 //x=63.295 //y=7.585 //x2=63.21 //y2=7.585
r1686 (  825 999 ) resistor r=2.87058 //w=0.35 //l=0.085 //layer=li \
 //thickness=0.1 //x=64.005 //y=7.585 //x2=64.09 //y2=7.585
r1687 (  825 826 ) resistor r=24.7629 //w=0.367 //l=0.71 //layer=li \
 //thickness=0.1 //x=64.005 //y=7.585 //x2=63.295 //y2=7.585
r1688 (  819 997 ) resistor r=4.23183 //w=0.7 //l=0.175 //layer=li \
 //thickness=0.1 //x=63.21 //y=7.41 //x2=63.21 //y2=7.585
r1689 (  819 1063 ) resistor r=33.1979 //w=0.187 //l=0.485 //layer=li \
 //thickness=0.1 //x=63.21 //y=7.41 //x2=63.21 //y2=6.925
r1690 (  816 996 ) resistor r=2.87058 //w=0.35 //l=0.085 //layer=li \
 //thickness=0.1 //x=62.415 //y=7.585 //x2=62.33 //y2=7.585
r1691 (  816 818 ) resistor r=21.1008 //w=0.367 //l=0.605 //layer=li \
 //thickness=0.1 //x=62.415 //y=7.585 //x2=63.02 //y2=7.585
r1692 (  815 997 ) resistor r=2.87058 //w=0.35 //l=0.085 //layer=li \
 //thickness=0.1 //x=63.125 //y=7.585 //x2=63.21 //y2=7.585
r1693 (  815 818 ) resistor r=3.66213 //w=0.367 //l=0.105 //layer=li \
 //thickness=0.1 //x=63.125 //y=7.585 //x2=63.02 //y2=7.585
r1694 (  807 996 ) resistor r=4.23183 //w=0.7 //l=0.175 //layer=li \
 //thickness=0.1 //x=62.33 //y=7.41 //x2=62.33 //y2=7.585
r1695 (  807 1062 ) resistor r=56.4706 //w=0.187 //l=0.825 //layer=li \
 //thickness=0.1 //x=62.33 //y=7.41 //x2=62.33 //y2=6.585
r1696 (  804 995 ) resistor r=5.29055 //w=0.35 //l=0.17 //layer=li \
 //thickness=0.1 //x=61.71 //y=7.585 //x2=61.54 //y2=7.585
r1697 (  804 806 ) resistor r=6.97548 //w=0.367 //l=0.2 //layer=li \
 //thickness=0.1 //x=61.71 //y=7.585 //x2=61.91 //y2=7.585
r1698 (  803 996 ) resistor r=2.87058 //w=0.35 //l=0.085 //layer=li \
 //thickness=0.1 //x=62.245 //y=7.585 //x2=62.33 //y2=7.585
r1699 (  803 806 ) resistor r=11.6839 //w=0.367 //l=0.335 //layer=li \
 //thickness=0.1 //x=62.245 //y=7.585 //x2=61.91 //y2=7.585
r1700 (  800 994 ) resistor r=2.87058 //w=0.35 //l=0.085 //layer=li \
 //thickness=0.1 //x=60.845 //y=7.585 //x2=60.76 //y2=7.585
r1701 (  799 995 ) resistor r=5.29055 //w=0.35 //l=0.17 //layer=li \
 //thickness=0.1 //x=61.37 //y=7.585 //x2=61.54 //y2=7.585
r1702 (  799 800 ) resistor r=18.3106 //w=0.367 //l=0.525 //layer=li \
 //thickness=0.1 //x=61.37 //y=7.585 //x2=60.845 //y2=7.585
r1703 (  793 994 ) resistor r=4.23183 //w=0.7 //l=0.175 //layer=li \
 //thickness=0.1 //x=60.76 //y=7.41 //x2=60.76 //y2=7.585
r1704 (  793 1061 ) resistor r=33.1979 //w=0.187 //l=0.485 //layer=li \
 //thickness=0.1 //x=60.76 //y=7.41 //x2=60.76 //y2=6.925
r1705 (  790 993 ) resistor r=2.87058 //w=0.35 //l=0.085 //layer=li \
 //thickness=0.1 //x=59.965 //y=7.585 //x2=59.88 //y2=7.585
r1706 (  790 792 ) resistor r=16.218 //w=0.367 //l=0.465 //layer=li \
 //thickness=0.1 //x=59.965 //y=7.585 //x2=60.43 //y2=7.585
r1707 (  789 994 ) resistor r=2.87058 //w=0.35 //l=0.085 //layer=li \
 //thickness=0.1 //x=60.675 //y=7.585 //x2=60.76 //y2=7.585
r1708 (  789 792 ) resistor r=8.54496 //w=0.367 //l=0.245 //layer=li \
 //thickness=0.1 //x=60.675 //y=7.585 //x2=60.43 //y2=7.585
r1709 (  783 993 ) resistor r=4.23183 //w=0.7 //l=0.175 //layer=li \
 //thickness=0.1 //x=59.88 //y=7.41 //x2=59.88 //y2=7.585
r1710 (  783 1060 ) resistor r=33.1979 //w=0.187 //l=0.485 //layer=li \
 //thickness=0.1 //x=59.88 //y=7.41 //x2=59.88 //y2=6.925
r1711 (  780 992 ) resistor r=2.87058 //w=0.35 //l=0.085 //layer=li \
 //thickness=0.1 //x=59.085 //y=7.585 //x2=59 //y2=7.585
r1712 (  780 782 ) resistor r=8.19619 //w=0.367 //l=0.235 //layer=li \
 //thickness=0.1 //x=59.085 //y=7.585 //x2=59.32 //y2=7.585
r1713 (  779 993 ) resistor r=2.87058 //w=0.35 //l=0.085 //layer=li \
 //thickness=0.1 //x=59.795 //y=7.585 //x2=59.88 //y2=7.585
r1714 (  779 782 ) resistor r=16.5668 //w=0.367 //l=0.475 //layer=li \
 //thickness=0.1 //x=59.795 //y=7.585 //x2=59.32 //y2=7.585
r1715 (  771 992 ) resistor r=4.23183 //w=0.7 //l=0.175 //layer=li \
 //thickness=0.1 //x=59 //y=7.41 //x2=59 //y2=7.585
r1716 (  771 1059 ) resistor r=56.4706 //w=0.187 //l=0.825 //layer=li \
 //thickness=0.1 //x=59 //y=7.41 //x2=59 //y2=6.585
r1717 (  770 991 ) resistor r=5.29055 //w=0.35 //l=0.17 //layer=li \
 //thickness=0.1 //x=58.38 //y=7.585 //x2=58.21 //y2=7.585
r1718 (  769 992 ) resistor r=2.87058 //w=0.35 //l=0.085 //layer=li \
 //thickness=0.1 //x=58.915 //y=7.585 //x2=59 //y2=7.585
r1719 (  769 770 ) resistor r=18.6594 //w=0.367 //l=0.535 //layer=li \
 //thickness=0.1 //x=58.915 //y=7.585 //x2=58.38 //y2=7.585
r1720 (  764 990 ) resistor r=2.87058 //w=0.35 //l=0.085 //layer=li \
 //thickness=0.1 //x=57.515 //y=7.585 //x2=57.43 //y2=7.585
r1721 (  764 766 ) resistor r=11.3351 //w=0.367 //l=0.325 //layer=li \
 //thickness=0.1 //x=57.515 //y=7.585 //x2=57.84 //y2=7.585
r1722 (  763 991 ) resistor r=5.29055 //w=0.35 //l=0.17 //layer=li \
 //thickness=0.1 //x=58.04 //y=7.585 //x2=58.21 //y2=7.585
r1723 (  763 766 ) resistor r=6.97548 //w=0.367 //l=0.2 //layer=li \
 //thickness=0.1 //x=58.04 //y=7.585 //x2=57.84 //y2=7.585
r1724 (  757 990 ) resistor r=4.23183 //w=0.7 //l=0.175 //layer=li \
 //thickness=0.1 //x=57.43 //y=7.41 //x2=57.43 //y2=7.585
r1725 (  757 1058 ) resistor r=33.1979 //w=0.187 //l=0.485 //layer=li \
 //thickness=0.1 //x=57.43 //y=7.41 //x2=57.43 //y2=6.925
r1726 (  754 989 ) resistor r=2.87058 //w=0.35 //l=0.085 //layer=li \
 //thickness=0.1 //x=56.635 //y=7.585 //x2=56.55 //y2=7.585
r1727 (  754 756 ) resistor r=3.31335 //w=0.367 //l=0.095 //layer=li \
 //thickness=0.1 //x=56.635 //y=7.585 //x2=56.73 //y2=7.585
r1728 (  753 990 ) resistor r=2.87058 //w=0.35 //l=0.085 //layer=li \
 //thickness=0.1 //x=57.345 //y=7.585 //x2=57.43 //y2=7.585
r1729 (  753 756 ) resistor r=21.4496 //w=0.367 //l=0.615 //layer=li \
 //thickness=0.1 //x=57.345 //y=7.585 //x2=56.73 //y2=7.585
r1730 (  747 989 ) resistor r=4.23183 //w=0.7 //l=0.175 //layer=li \
 //thickness=0.1 //x=56.55 //y=7.41 //x2=56.55 //y2=7.585
r1731 (  747 1057 ) resistor r=33.1979 //w=0.187 //l=0.485 //layer=li \
 //thickness=0.1 //x=56.55 //y=7.41 //x2=56.55 //y2=6.925
r1732 (  746 988 ) resistor r=2.87058 //w=0.35 //l=0.085 //layer=li \
 //thickness=0.1 //x=55.755 //y=7.585 //x2=55.67 //y2=7.585
r1733 (  745 989 ) resistor r=2.87058 //w=0.35 //l=0.085 //layer=li \
 //thickness=0.1 //x=56.465 //y=7.585 //x2=56.55 //y2=7.585
r1734 (  745 746 ) resistor r=24.7629 //w=0.367 //l=0.71 //layer=li \
 //thickness=0.1 //x=56.465 //y=7.585 //x2=55.755 //y2=7.585
r1735 (  737 988 ) resistor r=4.23183 //w=0.7 //l=0.175 //layer=li \
 //thickness=0.1 //x=55.67 //y=7.41 //x2=55.67 //y2=7.585
r1736 (  737 1056 ) resistor r=56.4706 //w=0.187 //l=0.825 //layer=li \
 //thickness=0.1 //x=55.67 //y=7.41 //x2=55.67 //y2=6.585
r1737 (  736 986 ) resistor r=5.29055 //w=0.35 //l=0.17 //layer=li \
 //thickness=0.1 //x=55.05 //y=7.585 //x2=54.88 //y2=7.585
r1738 (  735 988 ) resistor r=2.87058 //w=0.35 //l=0.085 //layer=li \
 //thickness=0.1 //x=55.585 //y=7.585 //x2=55.67 //y2=7.585
r1739 (  735 736 ) resistor r=18.6594 //w=0.367 //l=0.535 //layer=li \
 //thickness=0.1 //x=55.585 //y=7.585 //x2=55.05 //y2=7.585
r1740 (  732 985 ) resistor r=2.87058 //w=0.35 //l=0.085 //layer=li \
 //thickness=0.1 //x=54.185 //y=7.585 //x2=54.1 //y2=7.585
r1741 (  731 986 ) resistor r=5.29055 //w=0.35 //l=0.17 //layer=li \
 //thickness=0.1 //x=54.71 //y=7.585 //x2=54.88 //y2=7.585
r1742 (  731 732 ) resistor r=18.3106 //w=0.367 //l=0.525 //layer=li \
 //thickness=0.1 //x=54.71 //y=7.585 //x2=54.185 //y2=7.585
r1743 (  725 985 ) resistor r=4.23183 //w=0.7 //l=0.175 //layer=li \
 //thickness=0.1 //x=54.1 //y=7.41 //x2=54.1 //y2=7.585
r1744 (  725 1055 ) resistor r=33.1979 //w=0.187 //l=0.485 //layer=li \
 //thickness=0.1 //x=54.1 //y=7.41 //x2=54.1 //y2=6.925
r1745 (  724 983 ) resistor r=2.87058 //w=0.35 //l=0.085 //layer=li \
 //thickness=0.1 //x=53.305 //y=7.585 //x2=53.22 //y2=7.585
r1746 (  723 985 ) resistor r=2.87058 //w=0.35 //l=0.085 //layer=li \
 //thickness=0.1 //x=54.015 //y=7.585 //x2=54.1 //y2=7.585
r1747 (  723 724 ) resistor r=24.7629 //w=0.367 //l=0.71 //layer=li \
 //thickness=0.1 //x=54.015 //y=7.585 //x2=53.305 //y2=7.585
r1748 (  717 983 ) resistor r=4.23183 //w=0.7 //l=0.175 //layer=li \
 //thickness=0.1 //x=53.22 //y=7.41 //x2=53.22 //y2=7.585
r1749 (  717 1054 ) resistor r=33.1979 //w=0.187 //l=0.485 //layer=li \
 //thickness=0.1 //x=53.22 //y=7.41 //x2=53.22 //y2=6.925
r1750 (  714 982 ) resistor r=2.87058 //w=0.35 //l=0.085 //layer=li \
 //thickness=0.1 //x=52.425 //y=7.585 //x2=52.34 //y2=7.585
r1751 (  714 716 ) resistor r=21.1008 //w=0.367 //l=0.605 //layer=li \
 //thickness=0.1 //x=52.425 //y=7.585 //x2=53.03 //y2=7.585
r1752 (  713 983 ) resistor r=2.87058 //w=0.35 //l=0.085 //layer=li \
 //thickness=0.1 //x=53.135 //y=7.585 //x2=53.22 //y2=7.585
r1753 (  713 716 ) resistor r=3.66213 //w=0.367 //l=0.105 //layer=li \
 //thickness=0.1 //x=53.135 //y=7.585 //x2=53.03 //y2=7.585
r1754 (  705 982 ) resistor r=4.23183 //w=0.7 //l=0.175 //layer=li \
 //thickness=0.1 //x=52.34 //y=7.41 //x2=52.34 //y2=7.585
r1755 (  705 1053 ) resistor r=56.4706 //w=0.187 //l=0.825 //layer=li \
 //thickness=0.1 //x=52.34 //y=7.41 //x2=52.34 //y2=6.585
r1756 (  702 981 ) resistor r=5.29055 //w=0.35 //l=0.17 //layer=li \
 //thickness=0.1 //x=51.72 //y=7.585 //x2=51.55 //y2=7.585
r1757 (  702 704 ) resistor r=6.97548 //w=0.367 //l=0.2 //layer=li \
 //thickness=0.1 //x=51.72 //y=7.585 //x2=51.92 //y2=7.585
r1758 (  701 982 ) resistor r=2.87058 //w=0.35 //l=0.085 //layer=li \
 //thickness=0.1 //x=52.255 //y=7.585 //x2=52.34 //y2=7.585
r1759 (  701 704 ) resistor r=11.6839 //w=0.367 //l=0.335 //layer=li \
 //thickness=0.1 //x=52.255 //y=7.585 //x2=51.92 //y2=7.585
r1760 (  698 980 ) resistor r=2.87058 //w=0.35 //l=0.085 //layer=li \
 //thickness=0.1 //x=50.855 //y=7.585 //x2=50.77 //y2=7.585
r1761 (  697 981 ) resistor r=5.29055 //w=0.35 //l=0.17 //layer=li \
 //thickness=0.1 //x=51.38 //y=7.585 //x2=51.55 //y2=7.585
r1762 (  697 698 ) resistor r=18.3106 //w=0.367 //l=0.525 //layer=li \
 //thickness=0.1 //x=51.38 //y=7.585 //x2=50.855 //y2=7.585
r1763 (  691 980 ) resistor r=4.23183 //w=0.7 //l=0.175 //layer=li \
 //thickness=0.1 //x=50.77 //y=7.41 //x2=50.77 //y2=7.585
r1764 (  691 1052 ) resistor r=33.1979 //w=0.187 //l=0.485 //layer=li \
 //thickness=0.1 //x=50.77 //y=7.41 //x2=50.77 //y2=6.925
r1765 (  688 979 ) resistor r=2.87058 //w=0.35 //l=0.085 //layer=li \
 //thickness=0.1 //x=49.975 //y=7.585 //x2=49.89 //y2=7.585
r1766 (  688 690 ) resistor r=16.218 //w=0.367 //l=0.465 //layer=li \
 //thickness=0.1 //x=49.975 //y=7.585 //x2=50.44 //y2=7.585
r1767 (  687 980 ) resistor r=2.87058 //w=0.35 //l=0.085 //layer=li \
 //thickness=0.1 //x=50.685 //y=7.585 //x2=50.77 //y2=7.585
r1768 (  687 690 ) resistor r=8.54496 //w=0.367 //l=0.245 //layer=li \
 //thickness=0.1 //x=50.685 //y=7.585 //x2=50.44 //y2=7.585
r1769 (  681 979 ) resistor r=4.23183 //w=0.7 //l=0.175 //layer=li \
 //thickness=0.1 //x=49.89 //y=7.41 //x2=49.89 //y2=7.585
r1770 (  681 1051 ) resistor r=33.1979 //w=0.187 //l=0.485 //layer=li \
 //thickness=0.1 //x=49.89 //y=7.41 //x2=49.89 //y2=6.925
r1771 (  678 978 ) resistor r=2.87058 //w=0.35 //l=0.085 //layer=li \
 //thickness=0.1 //x=49.095 //y=7.585 //x2=49.01 //y2=7.585
r1772 (  678 680 ) resistor r=8.19619 //w=0.367 //l=0.235 //layer=li \
 //thickness=0.1 //x=49.095 //y=7.585 //x2=49.33 //y2=7.585
r1773 (  677 979 ) resistor r=2.87058 //w=0.35 //l=0.085 //layer=li \
 //thickness=0.1 //x=49.805 //y=7.585 //x2=49.89 //y2=7.585
r1774 (  677 680 ) resistor r=16.5668 //w=0.367 //l=0.475 //layer=li \
 //thickness=0.1 //x=49.805 //y=7.585 //x2=49.33 //y2=7.585
r1775 (  669 978 ) resistor r=4.23183 //w=0.7 //l=0.175 //layer=li \
 //thickness=0.1 //x=49.01 //y=7.41 //x2=49.01 //y2=7.585
r1776 (  669 1050 ) resistor r=56.4706 //w=0.187 //l=0.825 //layer=li \
 //thickness=0.1 //x=49.01 //y=7.41 //x2=49.01 //y2=6.585
r1777 (  668 977 ) resistor r=5.29055 //w=0.35 //l=0.17 //layer=li \
 //thickness=0.1 //x=48.39 //y=7.585 //x2=48.22 //y2=7.585
r1778 (  667 978 ) resistor r=2.87058 //w=0.35 //l=0.085 //layer=li \
 //thickness=0.1 //x=48.925 //y=7.585 //x2=49.01 //y2=7.585
r1779 (  667 668 ) resistor r=18.6594 //w=0.367 //l=0.535 //layer=li \
 //thickness=0.1 //x=48.925 //y=7.585 //x2=48.39 //y2=7.585
r1780 (  662 976 ) resistor r=2.87058 //w=0.35 //l=0.085 //layer=li \
 //thickness=0.1 //x=47.225 //y=7.585 //x2=47.14 //y2=7.585
r1781 (  662 664 ) resistor r=21.7984 //w=0.367 //l=0.625 //layer=li \
 //thickness=0.1 //x=47.225 //y=7.585 //x2=47.85 //y2=7.585
r1782 (  661 977 ) resistor r=5.29055 //w=0.35 //l=0.17 //layer=li \
 //thickness=0.1 //x=48.05 //y=7.585 //x2=48.22 //y2=7.585
r1783 (  661 664 ) resistor r=6.97548 //w=0.367 //l=0.2 //layer=li \
 //thickness=0.1 //x=48.05 //y=7.585 //x2=47.85 //y2=7.585
r1784 (  655 976 ) resistor r=4.23183 //w=0.7 //l=0.175 //layer=li \
 //thickness=0.1 //x=47.14 //y=7.41 //x2=47.14 //y2=7.585
r1785 (  655 1049 ) resistor r=33.1979 //w=0.187 //l=0.485 //layer=li \
 //thickness=0.1 //x=47.14 //y=7.41 //x2=47.14 //y2=6.925
r1786 (  652 975 ) resistor r=2.87058 //w=0.35 //l=0.085 //layer=li \
 //thickness=0.1 //x=46.345 //y=7.585 //x2=46.26 //y2=7.585
r1787 (  652 654 ) resistor r=13.7766 //w=0.367 //l=0.395 //layer=li \
 //thickness=0.1 //x=46.345 //y=7.585 //x2=46.74 //y2=7.585
r1788 (  651 976 ) resistor r=2.87058 //w=0.35 //l=0.085 //layer=li \
 //thickness=0.1 //x=47.055 //y=7.585 //x2=47.14 //y2=7.585
r1789 (  651 654 ) resistor r=10.9864 //w=0.367 //l=0.315 //layer=li \
 //thickness=0.1 //x=47.055 //y=7.585 //x2=46.74 //y2=7.585
r1790 (  645 975 ) resistor r=4.23183 //w=0.7 //l=0.175 //layer=li \
 //thickness=0.1 //x=46.26 //y=7.41 //x2=46.26 //y2=7.585
r1791 (  645 1048 ) resistor r=33.1979 //w=0.187 //l=0.485 //layer=li \
 //thickness=0.1 //x=46.26 //y=7.41 //x2=46.26 //y2=6.925
r1792 (  642 974 ) resistor r=2.87058 //w=0.35 //l=0.085 //layer=li \
 //thickness=0.1 //x=45.465 //y=7.585 //x2=45.38 //y2=7.585
r1793 (  642 644 ) resistor r=5.75477 //w=0.367 //l=0.165 //layer=li \
 //thickness=0.1 //x=45.465 //y=7.585 //x2=45.63 //y2=7.585
r1794 (  641 975 ) resistor r=2.87058 //w=0.35 //l=0.085 //layer=li \
 //thickness=0.1 //x=46.175 //y=7.585 //x2=46.26 //y2=7.585
r1795 (  641 644 ) resistor r=19.0082 //w=0.367 //l=0.545 //layer=li \
 //thickness=0.1 //x=46.175 //y=7.585 //x2=45.63 //y2=7.585
r1796 (  635 974 ) resistor r=4.23183 //w=0.7 //l=0.175 //layer=li \
 //thickness=0.1 //x=45.38 //y=7.41 //x2=45.38 //y2=7.585
r1797 (  635 1047 ) resistor r=33.1979 //w=0.187 //l=0.485 //layer=li \
 //thickness=0.1 //x=45.38 //y=7.41 //x2=45.38 //y2=6.925
r1798 (  634 973 ) resistor r=2.87058 //w=0.35 //l=0.085 //layer=li \
 //thickness=0.1 //x=44.585 //y=7.585 //x2=44.5 //y2=7.585
r1799 (  633 974 ) resistor r=2.87058 //w=0.35 //l=0.085 //layer=li \
 //thickness=0.1 //x=45.295 //y=7.585 //x2=45.38 //y2=7.585
r1800 (  633 634 ) resistor r=24.7629 //w=0.367 //l=0.71 //layer=li \
 //thickness=0.1 //x=45.295 //y=7.585 //x2=44.585 //y2=7.585
r1801 (  625 973 ) resistor r=4.23183 //w=0.7 //l=0.175 //layer=li \
 //thickness=0.1 //x=44.5 //y=7.41 //x2=44.5 //y2=7.585
r1802 (  625 1046 ) resistor r=56.4706 //w=0.187 //l=0.825 //layer=li \
 //thickness=0.1 //x=44.5 //y=7.41 //x2=44.5 //y2=6.585
r1803 (  624 971 ) resistor r=5.29055 //w=0.35 //l=0.17 //layer=li \
 //thickness=0.1 //x=43.58 //y=7.585 //x2=43.41 //y2=7.585
r1804 (  623 973 ) resistor r=2.87058 //w=0.35 //l=0.085 //layer=li \
 //thickness=0.1 //x=44.415 //y=7.585 //x2=44.5 //y2=7.585
r1805 (  623 624 ) resistor r=29.1226 //w=0.367 //l=0.835 //layer=li \
 //thickness=0.1 //x=44.415 //y=7.585 //x2=43.58 //y2=7.585
r1806 (  618 970 ) resistor r=2.87058 //w=0.35 //l=0.085 //layer=li \
 //thickness=0.1 //x=42.715 //y=7.585 //x2=42.63 //y2=7.585
r1807 (  618 620 ) resistor r=11.3351 //w=0.367 //l=0.325 //layer=li \
 //thickness=0.1 //x=42.715 //y=7.585 //x2=43.04 //y2=7.585
r1808 (  617 971 ) resistor r=5.29055 //w=0.35 //l=0.17 //layer=li \
 //thickness=0.1 //x=43.24 //y=7.585 //x2=43.41 //y2=7.585
r1809 (  617 620 ) resistor r=6.97548 //w=0.367 //l=0.2 //layer=li \
 //thickness=0.1 //x=43.24 //y=7.585 //x2=43.04 //y2=7.585
r1810 (  611 970 ) resistor r=4.23183 //w=0.7 //l=0.175 //layer=li \
 //thickness=0.1 //x=42.63 //y=7.41 //x2=42.63 //y2=7.585
r1811 (  611 1045 ) resistor r=33.1979 //w=0.187 //l=0.485 //layer=li \
 //thickness=0.1 //x=42.63 //y=7.41 //x2=42.63 //y2=6.925
r1812 (  608 969 ) resistor r=2.87058 //w=0.35 //l=0.085 //layer=li \
 //thickness=0.1 //x=41.835 //y=7.585 //x2=41.75 //y2=7.585
r1813 (  608 610 ) resistor r=3.31335 //w=0.367 //l=0.095 //layer=li \
 //thickness=0.1 //x=41.835 //y=7.585 //x2=41.93 //y2=7.585
r1814 (  607 970 ) resistor r=2.87058 //w=0.35 //l=0.085 //layer=li \
 //thickness=0.1 //x=42.545 //y=7.585 //x2=42.63 //y2=7.585
r1815 (  607 610 ) resistor r=21.4496 //w=0.367 //l=0.615 //layer=li \
 //thickness=0.1 //x=42.545 //y=7.585 //x2=41.93 //y2=7.585
r1816 (  601 969 ) resistor r=4.23183 //w=0.7 //l=0.175 //layer=li \
 //thickness=0.1 //x=41.75 //y=7.41 //x2=41.75 //y2=7.585
r1817 (  601 1044 ) resistor r=33.1979 //w=0.187 //l=0.485 //layer=li \
 //thickness=0.1 //x=41.75 //y=7.41 //x2=41.75 //y2=6.925
r1818 (  600 968 ) resistor r=2.87058 //w=0.35 //l=0.085 //layer=li \
 //thickness=0.1 //x=40.955 //y=7.585 //x2=40.87 //y2=7.585
r1819 (  599 969 ) resistor r=2.87058 //w=0.35 //l=0.085 //layer=li \
 //thickness=0.1 //x=41.665 //y=7.585 //x2=41.75 //y2=7.585
r1820 (  599 600 ) resistor r=24.7629 //w=0.367 //l=0.71 //layer=li \
 //thickness=0.1 //x=41.665 //y=7.585 //x2=40.955 //y2=7.585
r1821 (  591 968 ) resistor r=4.23183 //w=0.7 //l=0.175 //layer=li \
 //thickness=0.1 //x=40.87 //y=7.41 //x2=40.87 //y2=7.585
r1822 (  591 1043 ) resistor r=56.4706 //w=0.187 //l=0.825 //layer=li \
 //thickness=0.1 //x=40.87 //y=7.41 //x2=40.87 //y2=6.585
r1823 (  590 966 ) resistor r=5.29055 //w=0.35 //l=0.17 //layer=li \
 //thickness=0.1 //x=40.25 //y=7.585 //x2=40.08 //y2=7.585
r1824 (  589 968 ) resistor r=2.87058 //w=0.35 //l=0.085 //layer=li \
 //thickness=0.1 //x=40.785 //y=7.585 //x2=40.87 //y2=7.585
r1825 (  589 590 ) resistor r=18.6594 //w=0.367 //l=0.535 //layer=li \
 //thickness=0.1 //x=40.785 //y=7.585 //x2=40.25 //y2=7.585
r1826 (  586 965 ) resistor r=2.87058 //w=0.35 //l=0.085 //layer=li \
 //thickness=0.1 //x=39.385 //y=7.585 //x2=39.3 //y2=7.585
r1827 (  585 966 ) resistor r=5.29055 //w=0.35 //l=0.17 //layer=li \
 //thickness=0.1 //x=39.91 //y=7.585 //x2=40.08 //y2=7.585
r1828 (  585 586 ) resistor r=18.3106 //w=0.367 //l=0.525 //layer=li \
 //thickness=0.1 //x=39.91 //y=7.585 //x2=39.385 //y2=7.585
r1829 (  579 965 ) resistor r=4.23183 //w=0.7 //l=0.175 //layer=li \
 //thickness=0.1 //x=39.3 //y=7.41 //x2=39.3 //y2=7.585
r1830 (  579 1042 ) resistor r=33.1979 //w=0.187 //l=0.485 //layer=li \
 //thickness=0.1 //x=39.3 //y=7.41 //x2=39.3 //y2=6.925
r1831 (  578 963 ) resistor r=2.87058 //w=0.35 //l=0.085 //layer=li \
 //thickness=0.1 //x=38.505 //y=7.585 //x2=38.42 //y2=7.585
r1832 (  577 965 ) resistor r=2.87058 //w=0.35 //l=0.085 //layer=li \
 //thickness=0.1 //x=39.215 //y=7.585 //x2=39.3 //y2=7.585
r1833 (  577 578 ) resistor r=24.7629 //w=0.367 //l=0.71 //layer=li \
 //thickness=0.1 //x=39.215 //y=7.585 //x2=38.505 //y2=7.585
r1834 (  571 963 ) resistor r=4.23183 //w=0.7 //l=0.175 //layer=li \
 //thickness=0.1 //x=38.42 //y=7.41 //x2=38.42 //y2=7.585
r1835 (  571 1041 ) resistor r=33.1979 //w=0.187 //l=0.485 //layer=li \
 //thickness=0.1 //x=38.42 //y=7.41 //x2=38.42 //y2=6.925
r1836 (  568 962 ) resistor r=2.87058 //w=0.35 //l=0.085 //layer=li \
 //thickness=0.1 //x=37.625 //y=7.585 //x2=37.54 //y2=7.585
r1837 (  568 570 ) resistor r=21.1008 //w=0.367 //l=0.605 //layer=li \
 //thickness=0.1 //x=37.625 //y=7.585 //x2=38.23 //y2=7.585
r1838 (  567 963 ) resistor r=2.87058 //w=0.35 //l=0.085 //layer=li \
 //thickness=0.1 //x=38.335 //y=7.585 //x2=38.42 //y2=7.585
r1839 (  567 570 ) resistor r=3.66213 //w=0.367 //l=0.105 //layer=li \
 //thickness=0.1 //x=38.335 //y=7.585 //x2=38.23 //y2=7.585
r1840 (  559 962 ) resistor r=4.23183 //w=0.7 //l=0.175 //layer=li \
 //thickness=0.1 //x=37.54 //y=7.41 //x2=37.54 //y2=7.585
r1841 (  559 1040 ) resistor r=56.4706 //w=0.187 //l=0.825 //layer=li \
 //thickness=0.1 //x=37.54 //y=7.41 //x2=37.54 //y2=6.585
r1842 (  556 961 ) resistor r=5.29055 //w=0.35 //l=0.17 //layer=li \
 //thickness=0.1 //x=36.92 //y=7.585 //x2=36.75 //y2=7.585
r1843 (  556 558 ) resistor r=6.97548 //w=0.367 //l=0.2 //layer=li \
 //thickness=0.1 //x=36.92 //y=7.585 //x2=37.12 //y2=7.585
r1844 (  555 962 ) resistor r=2.87058 //w=0.35 //l=0.085 //layer=li \
 //thickness=0.1 //x=37.455 //y=7.585 //x2=37.54 //y2=7.585
r1845 (  555 558 ) resistor r=11.6839 //w=0.367 //l=0.335 //layer=li \
 //thickness=0.1 //x=37.455 //y=7.585 //x2=37.12 //y2=7.585
r1846 (  552 960 ) resistor r=2.87058 //w=0.35 //l=0.085 //layer=li \
 //thickness=0.1 //x=36.055 //y=7.585 //x2=35.97 //y2=7.585
r1847 (  551 961 ) resistor r=5.29055 //w=0.35 //l=0.17 //layer=li \
 //thickness=0.1 //x=36.58 //y=7.585 //x2=36.75 //y2=7.585
r1848 (  551 552 ) resistor r=18.3106 //w=0.367 //l=0.525 //layer=li \
 //thickness=0.1 //x=36.58 //y=7.585 //x2=36.055 //y2=7.585
r1849 (  545 960 ) resistor r=4.23183 //w=0.7 //l=0.175 //layer=li \
 //thickness=0.1 //x=35.97 //y=7.41 //x2=35.97 //y2=7.585
r1850 (  545 1039 ) resistor r=33.1979 //w=0.187 //l=0.485 //layer=li \
 //thickness=0.1 //x=35.97 //y=7.41 //x2=35.97 //y2=6.925
r1851 (  542 959 ) resistor r=2.87058 //w=0.35 //l=0.085 //layer=li \
 //thickness=0.1 //x=35.175 //y=7.585 //x2=35.09 //y2=7.585
r1852 (  542 544 ) resistor r=16.218 //w=0.367 //l=0.465 //layer=li \
 //thickness=0.1 //x=35.175 //y=7.585 //x2=35.64 //y2=7.585
r1853 (  541 960 ) resistor r=2.87058 //w=0.35 //l=0.085 //layer=li \
 //thickness=0.1 //x=35.885 //y=7.585 //x2=35.97 //y2=7.585
r1854 (  541 544 ) resistor r=8.54496 //w=0.367 //l=0.245 //layer=li \
 //thickness=0.1 //x=35.885 //y=7.585 //x2=35.64 //y2=7.585
r1855 (  535 959 ) resistor r=4.23183 //w=0.7 //l=0.175 //layer=li \
 //thickness=0.1 //x=35.09 //y=7.41 //x2=35.09 //y2=7.585
r1856 (  535 1038 ) resistor r=33.1979 //w=0.187 //l=0.485 //layer=li \
 //thickness=0.1 //x=35.09 //y=7.41 //x2=35.09 //y2=6.925
r1857 (  532 958 ) resistor r=2.87058 //w=0.35 //l=0.085 //layer=li \
 //thickness=0.1 //x=34.295 //y=7.585 //x2=34.21 //y2=7.585
r1858 (  532 534 ) resistor r=8.19619 //w=0.367 //l=0.235 //layer=li \
 //thickness=0.1 //x=34.295 //y=7.585 //x2=34.53 //y2=7.585
r1859 (  531 959 ) resistor r=2.87058 //w=0.35 //l=0.085 //layer=li \
 //thickness=0.1 //x=35.005 //y=7.585 //x2=35.09 //y2=7.585
r1860 (  531 534 ) resistor r=16.5668 //w=0.367 //l=0.475 //layer=li \
 //thickness=0.1 //x=35.005 //y=7.585 //x2=34.53 //y2=7.585
r1861 (  523 958 ) resistor r=4.23183 //w=0.7 //l=0.175 //layer=li \
 //thickness=0.1 //x=34.21 //y=7.41 //x2=34.21 //y2=7.585
r1862 (  523 1037 ) resistor r=56.4706 //w=0.187 //l=0.825 //layer=li \
 //thickness=0.1 //x=34.21 //y=7.41 //x2=34.21 //y2=6.585
r1863 (  522 957 ) resistor r=5.29055 //w=0.35 //l=0.17 //layer=li \
 //thickness=0.1 //x=33.59 //y=7.585 //x2=33.42 //y2=7.585
r1864 (  521 958 ) resistor r=2.87058 //w=0.35 //l=0.085 //layer=li \
 //thickness=0.1 //x=34.125 //y=7.585 //x2=34.21 //y2=7.585
r1865 (  521 522 ) resistor r=18.6594 //w=0.367 //l=0.535 //layer=li \
 //thickness=0.1 //x=34.125 //y=7.585 //x2=33.59 //y2=7.585
r1866 (  516 956 ) resistor r=2.87058 //w=0.35 //l=0.085 //layer=li \
 //thickness=0.1 //x=32.725 //y=7.585 //x2=32.64 //y2=7.585
r1867 (  516 518 ) resistor r=11.3351 //w=0.367 //l=0.325 //layer=li \
 //thickness=0.1 //x=32.725 //y=7.585 //x2=33.05 //y2=7.585
r1868 (  515 957 ) resistor r=5.29055 //w=0.35 //l=0.17 //layer=li \
 //thickness=0.1 //x=33.25 //y=7.585 //x2=33.42 //y2=7.585
r1869 (  515 518 ) resistor r=6.97548 //w=0.367 //l=0.2 //layer=li \
 //thickness=0.1 //x=33.25 //y=7.585 //x2=33.05 //y2=7.585
r1870 (  509 956 ) resistor r=4.23183 //w=0.7 //l=0.175 //layer=li \
 //thickness=0.1 //x=32.64 //y=7.41 //x2=32.64 //y2=7.585
r1871 (  509 1036 ) resistor r=33.1979 //w=0.187 //l=0.485 //layer=li \
 //thickness=0.1 //x=32.64 //y=7.41 //x2=32.64 //y2=6.925
r1872 (  506 955 ) resistor r=2.87058 //w=0.35 //l=0.085 //layer=li \
 //thickness=0.1 //x=31.845 //y=7.585 //x2=31.76 //y2=7.585
r1873 (  506 508 ) resistor r=3.31335 //w=0.367 //l=0.095 //layer=li \
 //thickness=0.1 //x=31.845 //y=7.585 //x2=31.94 //y2=7.585
r1874 (  505 956 ) resistor r=2.87058 //w=0.35 //l=0.085 //layer=li \
 //thickness=0.1 //x=32.555 //y=7.585 //x2=32.64 //y2=7.585
r1875 (  505 508 ) resistor r=21.4496 //w=0.367 //l=0.615 //layer=li \
 //thickness=0.1 //x=32.555 //y=7.585 //x2=31.94 //y2=7.585
r1876 (  499 955 ) resistor r=4.23183 //w=0.7 //l=0.175 //layer=li \
 //thickness=0.1 //x=31.76 //y=7.41 //x2=31.76 //y2=7.585
r1877 (  499 1035 ) resistor r=33.1979 //w=0.187 //l=0.485 //layer=li \
 //thickness=0.1 //x=31.76 //y=7.41 //x2=31.76 //y2=6.925
r1878 (  498 954 ) resistor r=2.87058 //w=0.35 //l=0.085 //layer=li \
 //thickness=0.1 //x=30.965 //y=7.585 //x2=30.88 //y2=7.585
r1879 (  497 955 ) resistor r=2.87058 //w=0.35 //l=0.085 //layer=li \
 //thickness=0.1 //x=31.675 //y=7.585 //x2=31.76 //y2=7.585
r1880 (  497 498 ) resistor r=24.7629 //w=0.367 //l=0.71 //layer=li \
 //thickness=0.1 //x=31.675 //y=7.585 //x2=30.965 //y2=7.585
r1881 (  489 954 ) resistor r=4.23183 //w=0.7 //l=0.175 //layer=li \
 //thickness=0.1 //x=30.88 //y=7.41 //x2=30.88 //y2=7.585
r1882 (  489 1034 ) resistor r=56.4706 //w=0.187 //l=0.825 //layer=li \
 //thickness=0.1 //x=30.88 //y=7.41 //x2=30.88 //y2=6.585
r1883 (  488 952 ) resistor r=5.29055 //w=0.35 //l=0.17 //layer=li \
 //thickness=0.1 //x=30.26 //y=7.585 //x2=30.09 //y2=7.585
r1884 (  487 954 ) resistor r=2.87058 //w=0.35 //l=0.085 //layer=li \
 //thickness=0.1 //x=30.795 //y=7.585 //x2=30.88 //y2=7.585
r1885 (  487 488 ) resistor r=18.6594 //w=0.367 //l=0.535 //layer=li \
 //thickness=0.1 //x=30.795 //y=7.585 //x2=30.26 //y2=7.585
r1886 (  484 951 ) resistor r=2.87058 //w=0.35 //l=0.085 //layer=li \
 //thickness=0.1 //x=29.395 //y=7.585 //x2=29.31 //y2=7.585
r1887 (  483 952 ) resistor r=5.29055 //w=0.35 //l=0.17 //layer=li \
 //thickness=0.1 //x=29.92 //y=7.585 //x2=30.09 //y2=7.585
r1888 (  483 484 ) resistor r=18.3106 //w=0.367 //l=0.525 //layer=li \
 //thickness=0.1 //x=29.92 //y=7.585 //x2=29.395 //y2=7.585
r1889 (  477 951 ) resistor r=4.23183 //w=0.7 //l=0.175 //layer=li \
 //thickness=0.1 //x=29.31 //y=7.41 //x2=29.31 //y2=7.585
r1890 (  477 1033 ) resistor r=33.1979 //w=0.187 //l=0.485 //layer=li \
 //thickness=0.1 //x=29.31 //y=7.41 //x2=29.31 //y2=6.925
r1891 (  476 949 ) resistor r=2.87058 //w=0.35 //l=0.085 //layer=li \
 //thickness=0.1 //x=28.515 //y=7.585 //x2=28.43 //y2=7.585
r1892 (  475 951 ) resistor r=2.87058 //w=0.35 //l=0.085 //layer=li \
 //thickness=0.1 //x=29.225 //y=7.585 //x2=29.31 //y2=7.585
r1893 (  475 476 ) resistor r=24.7629 //w=0.367 //l=0.71 //layer=li \
 //thickness=0.1 //x=29.225 //y=7.585 //x2=28.515 //y2=7.585
r1894 (  469 949 ) resistor r=4.23183 //w=0.7 //l=0.175 //layer=li \
 //thickness=0.1 //x=28.43 //y=7.41 //x2=28.43 //y2=7.585
r1895 (  469 1032 ) resistor r=33.1979 //w=0.187 //l=0.485 //layer=li \
 //thickness=0.1 //x=28.43 //y=7.41 //x2=28.43 //y2=6.925
r1896 (  466 948 ) resistor r=2.87058 //w=0.35 //l=0.085 //layer=li \
 //thickness=0.1 //x=27.635 //y=7.585 //x2=27.55 //y2=7.585
r1897 (  466 468 ) resistor r=21.1008 //w=0.367 //l=0.605 //layer=li \
 //thickness=0.1 //x=27.635 //y=7.585 //x2=28.24 //y2=7.585
r1898 (  465 949 ) resistor r=2.87058 //w=0.35 //l=0.085 //layer=li \
 //thickness=0.1 //x=28.345 //y=7.585 //x2=28.43 //y2=7.585
r1899 (  465 468 ) resistor r=3.66213 //w=0.367 //l=0.105 //layer=li \
 //thickness=0.1 //x=28.345 //y=7.585 //x2=28.24 //y2=7.585
r1900 (  457 948 ) resistor r=4.23183 //w=0.7 //l=0.175 //layer=li \
 //thickness=0.1 //x=27.55 //y=7.41 //x2=27.55 //y2=7.585
r1901 (  457 1031 ) resistor r=56.4706 //w=0.187 //l=0.825 //layer=li \
 //thickness=0.1 //x=27.55 //y=7.41 //x2=27.55 //y2=6.585
r1902 (  454 947 ) resistor r=5.29055 //w=0.35 //l=0.17 //layer=li \
 //thickness=0.1 //x=26.93 //y=7.585 //x2=26.76 //y2=7.585
r1903 (  454 456 ) resistor r=6.97548 //w=0.367 //l=0.2 //layer=li \
 //thickness=0.1 //x=26.93 //y=7.585 //x2=27.13 //y2=7.585
r1904 (  453 948 ) resistor r=2.87058 //w=0.35 //l=0.085 //layer=li \
 //thickness=0.1 //x=27.465 //y=7.585 //x2=27.55 //y2=7.585
r1905 (  453 456 ) resistor r=11.6839 //w=0.367 //l=0.335 //layer=li \
 //thickness=0.1 //x=27.465 //y=7.585 //x2=27.13 //y2=7.585
r1906 (  450 946 ) resistor r=2.87058 //w=0.35 //l=0.085 //layer=li \
 //thickness=0.1 //x=25.765 //y=7.585 //x2=25.68 //y2=7.585
r1907 (  449 947 ) resistor r=5.29055 //w=0.35 //l=0.17 //layer=li \
 //thickness=0.1 //x=26.59 //y=7.585 //x2=26.76 //y2=7.585
r1908 (  449 450 ) resistor r=28.7738 //w=0.367 //l=0.825 //layer=li \
 //thickness=0.1 //x=26.59 //y=7.585 //x2=25.765 //y2=7.585
r1909 (  443 946 ) resistor r=4.23183 //w=0.7 //l=0.175 //layer=li \
 //thickness=0.1 //x=25.68 //y=7.41 //x2=25.68 //y2=7.585
r1910 (  443 1030 ) resistor r=33.1979 //w=0.187 //l=0.485 //layer=li \
 //thickness=0.1 //x=25.68 //y=7.41 //x2=25.68 //y2=6.925
r1911 (  442 944 ) resistor r=2.87058 //w=0.35 //l=0.085 //layer=li \
 //thickness=0.1 //x=24.885 //y=7.585 //x2=24.8 //y2=7.585
r1912 (  441 946 ) resistor r=2.87058 //w=0.35 //l=0.085 //layer=li \
 //thickness=0.1 //x=25.595 //y=7.585 //x2=25.68 //y2=7.585
r1913 (  441 442 ) resistor r=24.7629 //w=0.367 //l=0.71 //layer=li \
 //thickness=0.1 //x=25.595 //y=7.585 //x2=24.885 //y2=7.585
r1914 (  435 944 ) resistor r=4.23183 //w=0.7 //l=0.175 //layer=li \
 //thickness=0.1 //x=24.8 //y=7.41 //x2=24.8 //y2=7.585
r1915 (  435 1029 ) resistor r=33.1979 //w=0.187 //l=0.485 //layer=li \
 //thickness=0.1 //x=24.8 //y=7.41 //x2=24.8 //y2=6.925
r1916 (  432 943 ) resistor r=2.87058 //w=0.35 //l=0.085 //layer=li \
 //thickness=0.1 //x=24.005 //y=7.585 //x2=23.92 //y2=7.585
r1917 (  432 434 ) resistor r=18.6594 //w=0.367 //l=0.535 //layer=li \
 //thickness=0.1 //x=24.005 //y=7.585 //x2=24.54 //y2=7.585
r1918 (  431 944 ) resistor r=2.87058 //w=0.35 //l=0.085 //layer=li \
 //thickness=0.1 //x=24.715 //y=7.585 //x2=24.8 //y2=7.585
r1919 (  431 434 ) resistor r=6.10354 //w=0.367 //l=0.175 //layer=li \
 //thickness=0.1 //x=24.715 //y=7.585 //x2=24.54 //y2=7.585
r1920 (  425 943 ) resistor r=4.23183 //w=0.7 //l=0.175 //layer=li \
 //thickness=0.1 //x=23.92 //y=7.41 //x2=23.92 //y2=7.585
r1921 (  425 1028 ) resistor r=33.1979 //w=0.187 //l=0.485 //layer=li \
 //thickness=0.1 //x=23.92 //y=7.41 //x2=23.92 //y2=6.925
r1922 (  422 942 ) resistor r=2.87058 //w=0.35 //l=0.085 //layer=li \
 //thickness=0.1 //x=23.125 //y=7.585 //x2=23.04 //y2=7.585
r1923 (  422 424 ) resistor r=10.6376 //w=0.367 //l=0.305 //layer=li \
 //thickness=0.1 //x=23.125 //y=7.585 //x2=23.43 //y2=7.585
r1924 (  421 943 ) resistor r=2.87058 //w=0.35 //l=0.085 //layer=li \
 //thickness=0.1 //x=23.835 //y=7.585 //x2=23.92 //y2=7.585
r1925 (  421 424 ) resistor r=14.1253 //w=0.367 //l=0.405 //layer=li \
 //thickness=0.1 //x=23.835 //y=7.585 //x2=23.43 //y2=7.585
r1926 (  413 942 ) resistor r=4.23183 //w=0.7 //l=0.175 //layer=li \
 //thickness=0.1 //x=23.04 //y=7.41 //x2=23.04 //y2=7.585
r1927 (  413 1027 ) resistor r=56.4706 //w=0.187 //l=0.825 //layer=li \
 //thickness=0.1 //x=23.04 //y=7.41 //x2=23.04 //y2=6.585
r1928 (  410 941 ) resistor r=5.29055 //w=0.35 //l=0.17 //layer=li \
 //thickness=0.1 //x=22.12 //y=7.585 //x2=21.95 //y2=7.585
r1929 (  410 412 ) resistor r=6.97548 //w=0.367 //l=0.2 //layer=li \
 //thickness=0.1 //x=22.12 //y=7.585 //x2=22.32 //y2=7.585
r1930 (  409 942 ) resistor r=2.87058 //w=0.35 //l=0.085 //layer=li \
 //thickness=0.1 //x=22.955 //y=7.585 //x2=23.04 //y2=7.585
r1931 (  409 412 ) resistor r=22.1471 //w=0.367 //l=0.635 //layer=li \
 //thickness=0.1 //x=22.955 //y=7.585 //x2=22.32 //y2=7.585
r1932 (  406 940 ) resistor r=2.87058 //w=0.35 //l=0.085 //layer=li \
 //thickness=0.1 //x=21.255 //y=7.585 //x2=21.17 //y2=7.585
r1933 (  405 941 ) resistor r=5.29055 //w=0.35 //l=0.17 //layer=li \
 //thickness=0.1 //x=21.78 //y=7.585 //x2=21.95 //y2=7.585
r1934 (  405 406 ) resistor r=18.3106 //w=0.367 //l=0.525 //layer=li \
 //thickness=0.1 //x=21.78 //y=7.585 //x2=21.255 //y2=7.585
r1935 (  399 940 ) resistor r=4.23183 //w=0.7 //l=0.175 //layer=li \
 //thickness=0.1 //x=21.17 //y=7.41 //x2=21.17 //y2=7.585
r1936 (  399 1026 ) resistor r=33.1979 //w=0.187 //l=0.485 //layer=li \
 //thickness=0.1 //x=21.17 //y=7.41 //x2=21.17 //y2=6.925
r1937 (  396 939 ) resistor r=2.87058 //w=0.35 //l=0.085 //layer=li \
 //thickness=0.1 //x=20.375 //y=7.585 //x2=20.29 //y2=7.585
r1938 (  396 398 ) resistor r=16.218 //w=0.367 //l=0.465 //layer=li \
 //thickness=0.1 //x=20.375 //y=7.585 //x2=20.84 //y2=7.585
r1939 (  395 940 ) resistor r=2.87058 //w=0.35 //l=0.085 //layer=li \
 //thickness=0.1 //x=21.085 //y=7.585 //x2=21.17 //y2=7.585
r1940 (  395 398 ) resistor r=8.54496 //w=0.367 //l=0.245 //layer=li \
 //thickness=0.1 //x=21.085 //y=7.585 //x2=20.84 //y2=7.585
r1941 (  389 939 ) resistor r=4.23183 //w=0.7 //l=0.175 //layer=li \
 //thickness=0.1 //x=20.29 //y=7.41 //x2=20.29 //y2=7.585
r1942 (  389 1025 ) resistor r=33.1979 //w=0.187 //l=0.485 //layer=li \
 //thickness=0.1 //x=20.29 //y=7.41 //x2=20.29 //y2=6.925
r1943 (  386 938 ) resistor r=2.87058 //w=0.35 //l=0.085 //layer=li \
 //thickness=0.1 //x=19.495 //y=7.585 //x2=19.41 //y2=7.585
r1944 (  386 388 ) resistor r=8.19619 //w=0.367 //l=0.235 //layer=li \
 //thickness=0.1 //x=19.495 //y=7.585 //x2=19.73 //y2=7.585
r1945 (  385 939 ) resistor r=2.87058 //w=0.35 //l=0.085 //layer=li \
 //thickness=0.1 //x=20.205 //y=7.585 //x2=20.29 //y2=7.585
r1946 (  385 388 ) resistor r=16.5668 //w=0.367 //l=0.475 //layer=li \
 //thickness=0.1 //x=20.205 //y=7.585 //x2=19.73 //y2=7.585
r1947 (  377 938 ) resistor r=4.23183 //w=0.7 //l=0.175 //layer=li \
 //thickness=0.1 //x=19.41 //y=7.41 //x2=19.41 //y2=7.585
r1948 (  377 1024 ) resistor r=56.4706 //w=0.187 //l=0.825 //layer=li \
 //thickness=0.1 //x=19.41 //y=7.41 //x2=19.41 //y2=6.585
r1949 (  376 937 ) resistor r=5.29055 //w=0.35 //l=0.17 //layer=li \
 //thickness=0.1 //x=18.79 //y=7.585 //x2=18.62 //y2=7.585
r1950 (  375 938 ) resistor r=2.87058 //w=0.35 //l=0.085 //layer=li \
 //thickness=0.1 //x=19.325 //y=7.585 //x2=19.41 //y2=7.585
r1951 (  375 376 ) resistor r=18.6594 //w=0.367 //l=0.535 //layer=li \
 //thickness=0.1 //x=19.325 //y=7.585 //x2=18.79 //y2=7.585
r1952 (  370 936 ) resistor r=2.87058 //w=0.35 //l=0.085 //layer=li \
 //thickness=0.1 //x=17.925 //y=7.585 //x2=17.84 //y2=7.585
r1953 (  370 372 ) resistor r=11.3351 //w=0.367 //l=0.325 //layer=li \
 //thickness=0.1 //x=17.925 //y=7.585 //x2=18.25 //y2=7.585
r1954 (  369 937 ) resistor r=5.29055 //w=0.35 //l=0.17 //layer=li \
 //thickness=0.1 //x=18.45 //y=7.585 //x2=18.62 //y2=7.585
r1955 (  369 372 ) resistor r=6.97548 //w=0.367 //l=0.2 //layer=li \
 //thickness=0.1 //x=18.45 //y=7.585 //x2=18.25 //y2=7.585
r1956 (  363 936 ) resistor r=4.23183 //w=0.7 //l=0.175 //layer=li \
 //thickness=0.1 //x=17.84 //y=7.41 //x2=17.84 //y2=7.585
r1957 (  363 1023 ) resistor r=33.1979 //w=0.187 //l=0.485 //layer=li \
 //thickness=0.1 //x=17.84 //y=7.41 //x2=17.84 //y2=6.925
r1958 (  360 935 ) resistor r=2.87058 //w=0.35 //l=0.085 //layer=li \
 //thickness=0.1 //x=17.045 //y=7.585 //x2=16.96 //y2=7.585
r1959 (  360 362 ) resistor r=3.31335 //w=0.367 //l=0.095 //layer=li \
 //thickness=0.1 //x=17.045 //y=7.585 //x2=17.14 //y2=7.585
r1960 (  359 936 ) resistor r=2.87058 //w=0.35 //l=0.085 //layer=li \
 //thickness=0.1 //x=17.755 //y=7.585 //x2=17.84 //y2=7.585
r1961 (  359 362 ) resistor r=21.4496 //w=0.367 //l=0.615 //layer=li \
 //thickness=0.1 //x=17.755 //y=7.585 //x2=17.14 //y2=7.585
r1962 (  353 935 ) resistor r=4.23183 //w=0.7 //l=0.175 //layer=li \
 //thickness=0.1 //x=16.96 //y=7.41 //x2=16.96 //y2=7.585
r1963 (  353 1022 ) resistor r=33.1979 //w=0.187 //l=0.485 //layer=li \
 //thickness=0.1 //x=16.96 //y=7.41 //x2=16.96 //y2=6.925
r1964 (  352 934 ) resistor r=2.87058 //w=0.35 //l=0.085 //layer=li \
 //thickness=0.1 //x=16.165 //y=7.585 //x2=16.08 //y2=7.585
r1965 (  351 935 ) resistor r=2.87058 //w=0.35 //l=0.085 //layer=li \
 //thickness=0.1 //x=16.875 //y=7.585 //x2=16.96 //y2=7.585
r1966 (  351 352 ) resistor r=24.7629 //w=0.367 //l=0.71 //layer=li \
 //thickness=0.1 //x=16.875 //y=7.585 //x2=16.165 //y2=7.585
r1967 (  343 934 ) resistor r=4.23183 //w=0.7 //l=0.175 //layer=li \
 //thickness=0.1 //x=16.08 //y=7.41 //x2=16.08 //y2=7.585
r1968 (  343 1021 ) resistor r=56.4706 //w=0.187 //l=0.825 //layer=li \
 //thickness=0.1 //x=16.08 //y=7.41 //x2=16.08 //y2=6.585
r1969 (  342 932 ) resistor r=5.29055 //w=0.35 //l=0.17 //layer=li \
 //thickness=0.1 //x=15.46 //y=7.585 //x2=15.29 //y2=7.585
r1970 (  341 934 ) resistor r=2.87058 //w=0.35 //l=0.085 //layer=li \
 //thickness=0.1 //x=15.995 //y=7.585 //x2=16.08 //y2=7.585
r1971 (  341 342 ) resistor r=18.6594 //w=0.367 //l=0.535 //layer=li \
 //thickness=0.1 //x=15.995 //y=7.585 //x2=15.46 //y2=7.585
r1972 (  338 931 ) resistor r=2.87058 //w=0.35 //l=0.085 //layer=li \
 //thickness=0.1 //x=14.595 //y=7.585 //x2=14.51 //y2=7.585
r1973 (  337 932 ) resistor r=5.29055 //w=0.35 //l=0.17 //layer=li \
 //thickness=0.1 //x=15.12 //y=7.585 //x2=15.29 //y2=7.585
r1974 (  337 338 ) resistor r=18.3106 //w=0.367 //l=0.525 //layer=li \
 //thickness=0.1 //x=15.12 //y=7.585 //x2=14.595 //y2=7.585
r1975 (  331 931 ) resistor r=4.23183 //w=0.7 //l=0.175 //layer=li \
 //thickness=0.1 //x=14.51 //y=7.41 //x2=14.51 //y2=7.585
r1976 (  331 1020 ) resistor r=33.1979 //w=0.187 //l=0.485 //layer=li \
 //thickness=0.1 //x=14.51 //y=7.41 //x2=14.51 //y2=6.925
r1977 (  330 929 ) resistor r=2.87058 //w=0.35 //l=0.085 //layer=li \
 //thickness=0.1 //x=13.715 //y=7.585 //x2=13.63 //y2=7.585
r1978 (  329 931 ) resistor r=2.87058 //w=0.35 //l=0.085 //layer=li \
 //thickness=0.1 //x=14.425 //y=7.585 //x2=14.51 //y2=7.585
r1979 (  329 330 ) resistor r=24.7629 //w=0.367 //l=0.71 //layer=li \
 //thickness=0.1 //x=14.425 //y=7.585 //x2=13.715 //y2=7.585
r1980 (  323 929 ) resistor r=4.23183 //w=0.7 //l=0.175 //layer=li \
 //thickness=0.1 //x=13.63 //y=7.41 //x2=13.63 //y2=7.585
r1981 (  323 1019 ) resistor r=33.1979 //w=0.187 //l=0.485 //layer=li \
 //thickness=0.1 //x=13.63 //y=7.41 //x2=13.63 //y2=6.925
r1982 (  320 928 ) resistor r=2.87058 //w=0.35 //l=0.085 //layer=li \
 //thickness=0.1 //x=12.835 //y=7.585 //x2=12.75 //y2=7.585
r1983 (  320 322 ) resistor r=21.1008 //w=0.367 //l=0.605 //layer=li \
 //thickness=0.1 //x=12.835 //y=7.585 //x2=13.44 //y2=7.585
r1984 (  319 929 ) resistor r=2.87058 //w=0.35 //l=0.085 //layer=li \
 //thickness=0.1 //x=13.545 //y=7.585 //x2=13.63 //y2=7.585
r1985 (  319 322 ) resistor r=3.66213 //w=0.367 //l=0.105 //layer=li \
 //thickness=0.1 //x=13.545 //y=7.585 //x2=13.44 //y2=7.585
r1986 (  311 928 ) resistor r=4.23183 //w=0.7 //l=0.175 //layer=li \
 //thickness=0.1 //x=12.75 //y=7.41 //x2=12.75 //y2=7.585
r1987 (  311 1018 ) resistor r=56.4706 //w=0.187 //l=0.825 //layer=li \
 //thickness=0.1 //x=12.75 //y=7.41 //x2=12.75 //y2=6.585
r1988 (  308 927 ) resistor r=5.29055 //w=0.35 //l=0.17 //layer=li \
 //thickness=0.1 //x=12.13 //y=7.585 //x2=11.96 //y2=7.585
r1989 (  308 310 ) resistor r=6.97548 //w=0.367 //l=0.2 //layer=li \
 //thickness=0.1 //x=12.13 //y=7.585 //x2=12.33 //y2=7.585
r1990 (  307 928 ) resistor r=2.87058 //w=0.35 //l=0.085 //layer=li \
 //thickness=0.1 //x=12.665 //y=7.585 //x2=12.75 //y2=7.585
r1991 (  307 310 ) resistor r=11.6839 //w=0.367 //l=0.335 //layer=li \
 //thickness=0.1 //x=12.665 //y=7.585 //x2=12.33 //y2=7.585
r1992 (  304 926 ) resistor r=2.87058 //w=0.35 //l=0.085 //layer=li \
 //thickness=0.1 //x=11.265 //y=7.585 //x2=11.18 //y2=7.585
r1993 (  303 927 ) resistor r=5.29055 //w=0.35 //l=0.17 //layer=li \
 //thickness=0.1 //x=11.79 //y=7.585 //x2=11.96 //y2=7.585
r1994 (  303 304 ) resistor r=18.3106 //w=0.367 //l=0.525 //layer=li \
 //thickness=0.1 //x=11.79 //y=7.585 //x2=11.265 //y2=7.585
r1995 (  297 926 ) resistor r=4.23183 //w=0.7 //l=0.175 //layer=li \
 //thickness=0.1 //x=11.18 //y=7.41 //x2=11.18 //y2=7.585
r1996 (  297 1017 ) resistor r=33.1979 //w=0.187 //l=0.485 //layer=li \
 //thickness=0.1 //x=11.18 //y=7.41 //x2=11.18 //y2=6.925
r1997 (  294 925 ) resistor r=2.87058 //w=0.35 //l=0.085 //layer=li \
 //thickness=0.1 //x=10.385 //y=7.585 //x2=10.3 //y2=7.585
r1998 (  294 296 ) resistor r=16.218 //w=0.367 //l=0.465 //layer=li \
 //thickness=0.1 //x=10.385 //y=7.585 //x2=10.85 //y2=7.585
r1999 (  293 926 ) resistor r=2.87058 //w=0.35 //l=0.085 //layer=li \
 //thickness=0.1 //x=11.095 //y=7.585 //x2=11.18 //y2=7.585
r2000 (  293 296 ) resistor r=8.54496 //w=0.367 //l=0.245 //layer=li \
 //thickness=0.1 //x=11.095 //y=7.585 //x2=10.85 //y2=7.585
r2001 (  287 925 ) resistor r=4.23183 //w=0.7 //l=0.175 //layer=li \
 //thickness=0.1 //x=10.3 //y=7.41 //x2=10.3 //y2=7.585
r2002 (  287 1016 ) resistor r=33.1979 //w=0.187 //l=0.485 //layer=li \
 //thickness=0.1 //x=10.3 //y=7.41 //x2=10.3 //y2=6.925
r2003 (  284 924 ) resistor r=2.87058 //w=0.35 //l=0.085 //layer=li \
 //thickness=0.1 //x=9.505 //y=7.585 //x2=9.42 //y2=7.585
r2004 (  284 286 ) resistor r=8.19619 //w=0.367 //l=0.235 //layer=li \
 //thickness=0.1 //x=9.505 //y=7.585 //x2=9.74 //y2=7.585
r2005 (  283 925 ) resistor r=2.87058 //w=0.35 //l=0.085 //layer=li \
 //thickness=0.1 //x=10.215 //y=7.585 //x2=10.3 //y2=7.585
r2006 (  283 286 ) resistor r=16.5668 //w=0.367 //l=0.475 //layer=li \
 //thickness=0.1 //x=10.215 //y=7.585 //x2=9.74 //y2=7.585
r2007 (  275 924 ) resistor r=4.23183 //w=0.7 //l=0.175 //layer=li \
 //thickness=0.1 //x=9.42 //y=7.41 //x2=9.42 //y2=7.585
r2008 (  275 1015 ) resistor r=56.4706 //w=0.187 //l=0.825 //layer=li \
 //thickness=0.1 //x=9.42 //y=7.41 //x2=9.42 //y2=6.585
r2009 (  274 923 ) resistor r=5.29055 //w=0.35 //l=0.17 //layer=li \
 //thickness=0.1 //x=8.8 //y=7.585 //x2=8.63 //y2=7.585
r2010 (  273 924 ) resistor r=2.87058 //w=0.35 //l=0.085 //layer=li \
 //thickness=0.1 //x=9.335 //y=7.585 //x2=9.42 //y2=7.585
r2011 (  273 274 ) resistor r=18.6594 //w=0.367 //l=0.535 //layer=li \
 //thickness=0.1 //x=9.335 //y=7.585 //x2=8.8 //y2=7.585
r2012 (  268 922 ) resistor r=2.87058 //w=0.35 //l=0.085 //layer=li \
 //thickness=0.1 //x=7.935 //y=7.585 //x2=7.85 //y2=7.585
r2013 (  268 270 ) resistor r=11.3351 //w=0.367 //l=0.325 //layer=li \
 //thickness=0.1 //x=7.935 //y=7.585 //x2=8.26 //y2=7.585
r2014 (  267 923 ) resistor r=5.29055 //w=0.35 //l=0.17 //layer=li \
 //thickness=0.1 //x=8.46 //y=7.585 //x2=8.63 //y2=7.585
r2015 (  267 270 ) resistor r=6.97548 //w=0.367 //l=0.2 //layer=li \
 //thickness=0.1 //x=8.46 //y=7.585 //x2=8.26 //y2=7.585
r2016 (  261 922 ) resistor r=4.23183 //w=0.7 //l=0.175 //layer=li \
 //thickness=0.1 //x=7.85 //y=7.41 //x2=7.85 //y2=7.585
r2017 (  261 1014 ) resistor r=33.1979 //w=0.187 //l=0.485 //layer=li \
 //thickness=0.1 //x=7.85 //y=7.41 //x2=7.85 //y2=6.925
r2018 (  258 921 ) resistor r=2.87058 //w=0.35 //l=0.085 //layer=li \
 //thickness=0.1 //x=7.055 //y=7.585 //x2=6.97 //y2=7.585
r2019 (  258 260 ) resistor r=3.31335 //w=0.367 //l=0.095 //layer=li \
 //thickness=0.1 //x=7.055 //y=7.585 //x2=7.15 //y2=7.585
r2020 (  257 922 ) resistor r=2.87058 //w=0.35 //l=0.085 //layer=li \
 //thickness=0.1 //x=7.765 //y=7.585 //x2=7.85 //y2=7.585
r2021 (  257 260 ) resistor r=21.4496 //w=0.367 //l=0.615 //layer=li \
 //thickness=0.1 //x=7.765 //y=7.585 //x2=7.15 //y2=7.585
r2022 (  251 921 ) resistor r=4.23183 //w=0.7 //l=0.175 //layer=li \
 //thickness=0.1 //x=6.97 //y=7.41 //x2=6.97 //y2=7.585
r2023 (  251 1013 ) resistor r=33.1979 //w=0.187 //l=0.485 //layer=li \
 //thickness=0.1 //x=6.97 //y=7.41 //x2=6.97 //y2=6.925
r2024 (  250 920 ) resistor r=2.87058 //w=0.35 //l=0.085 //layer=li \
 //thickness=0.1 //x=6.175 //y=7.585 //x2=6.09 //y2=7.585
r2025 (  249 921 ) resistor r=2.87058 //w=0.35 //l=0.085 //layer=li \
 //thickness=0.1 //x=6.885 //y=7.585 //x2=6.97 //y2=7.585
r2026 (  249 250 ) resistor r=24.7629 //w=0.367 //l=0.71 //layer=li \
 //thickness=0.1 //x=6.885 //y=7.585 //x2=6.175 //y2=7.585
r2027 (  241 920 ) resistor r=4.23183 //w=0.7 //l=0.175 //layer=li \
 //thickness=0.1 //x=6.09 //y=7.41 //x2=6.09 //y2=7.585
r2028 (  241 1012 ) resistor r=56.4706 //w=0.187 //l=0.825 //layer=li \
 //thickness=0.1 //x=6.09 //y=7.41 //x2=6.09 //y2=6.585
r2029 (  240 918 ) resistor r=5.29055 //w=0.35 //l=0.17 //layer=li \
 //thickness=0.1 //x=5.47 //y=7.585 //x2=5.3 //y2=7.585
r2030 (  239 920 ) resistor r=2.87058 //w=0.35 //l=0.085 //layer=li \
 //thickness=0.1 //x=6.005 //y=7.585 //x2=6.09 //y2=7.585
r2031 (  239 240 ) resistor r=18.6594 //w=0.367 //l=0.535 //layer=li \
 //thickness=0.1 //x=6.005 //y=7.585 //x2=5.47 //y2=7.585
r2032 (  234 917 ) resistor r=2.87058 //w=0.35 //l=0.085 //layer=li \
 //thickness=0.1 //x=4.305 //y=7.585 //x2=4.22 //y2=7.585
r2033 (  234 236 ) resistor r=8.89373 //w=0.367 //l=0.255 //layer=li \
 //thickness=0.1 //x=4.305 //y=7.585 //x2=4.56 //y2=7.585
r2034 (  233 918 ) resistor r=5.29055 //w=0.35 //l=0.17 //layer=li \
 //thickness=0.1 //x=5.13 //y=7.585 //x2=5.3 //y2=7.585
r2035 (  233 236 ) resistor r=19.8801 //w=0.367 //l=0.57 //layer=li \
 //thickness=0.1 //x=5.13 //y=7.585 //x2=4.56 //y2=7.585
r2036 (  227 917 ) resistor r=4.23183 //w=0.7 //l=0.175 //layer=li \
 //thickness=0.1 //x=4.22 //y=7.41 //x2=4.22 //y2=7.585
r2037 (  227 1011 ) resistor r=33.1979 //w=0.187 //l=0.485 //layer=li \
 //thickness=0.1 //x=4.22 //y=7.41 //x2=4.22 //y2=6.925
r2038 (  224 916 ) resistor r=2.87058 //w=0.35 //l=0.085 //layer=li \
 //thickness=0.1 //x=3.425 //y=7.585 //x2=3.34 //y2=7.585
r2039 (  224 226 ) resistor r=0.871935 //w=0.367 //l=0.025 //layer=li \
 //thickness=0.1 //x=3.425 //y=7.585 //x2=3.45 //y2=7.585
r2040 (  223 917 ) resistor r=2.87058 //w=0.35 //l=0.085 //layer=li \
 //thickness=0.1 //x=4.135 //y=7.585 //x2=4.22 //y2=7.585
r2041 (  223 226 ) resistor r=23.891 //w=0.367 //l=0.685 //layer=li \
 //thickness=0.1 //x=4.135 //y=7.585 //x2=3.45 //y2=7.585
r2042 (  217 916 ) resistor r=4.23183 //w=0.7 //l=0.175 //layer=li \
 //thickness=0.1 //x=3.34 //y=7.41 //x2=3.34 //y2=7.585
r2043 (  217 1010 ) resistor r=33.1979 //w=0.187 //l=0.485 //layer=li \
 //thickness=0.1 //x=3.34 //y=7.41 //x2=3.34 //y2=6.925
r2044 (  216 915 ) resistor r=2.87058 //w=0.35 //l=0.085 //layer=li \
 //thickness=0.1 //x=2.545 //y=7.585 //x2=2.46 //y2=7.585
r2045 (  215 916 ) resistor r=2.87058 //w=0.35 //l=0.085 //layer=li \
 //thickness=0.1 //x=3.255 //y=7.585 //x2=3.34 //y2=7.585
r2046 (  215 216 ) resistor r=24.7629 //w=0.367 //l=0.71 //layer=li \
 //thickness=0.1 //x=3.255 //y=7.585 //x2=2.545 //y2=7.585
r2047 (  209 915 ) resistor r=4.23183 //w=0.7 //l=0.175 //layer=li \
 //thickness=0.1 //x=2.46 //y=7.41 //x2=2.46 //y2=7.585
r2048 (  209 1009 ) resistor r=33.1979 //w=0.187 //l=0.485 //layer=li \
 //thickness=0.1 //x=2.46 //y=7.41 //x2=2.46 //y2=6.925
r2049 (  206 914 ) resistor r=2.87058 //w=0.35 //l=0.085 //layer=li \
 //thickness=0.1 //x=1.665 //y=7.585 //x2=1.58 //y2=7.585
r2050 (  206 208 ) resistor r=23.5422 //w=0.367 //l=0.675 //layer=li \
 //thickness=0.1 //x=1.665 //y=7.585 //x2=2.34 //y2=7.585
r2051 (  205 915 ) resistor r=2.87058 //w=0.35 //l=0.085 //layer=li \
 //thickness=0.1 //x=2.375 //y=7.585 //x2=2.46 //y2=7.585
r2052 (  205 208 ) resistor r=1.22071 //w=0.367 //l=0.035 //layer=li \
 //thickness=0.1 //x=2.375 //y=7.585 //x2=2.34 //y2=7.585
r2053 (  197 914 ) resistor r=4.23183 //w=0.7 //l=0.175 //layer=li \
 //thickness=0.1 //x=1.58 //y=7.41 //x2=1.58 //y2=7.585
r2054 (  197 1008 ) resistor r=56.4706 //w=0.187 //l=0.825 //layer=li \
 //thickness=0.1 //x=1.58 //y=7.41 //x2=1.58 //y2=6.585
r2055 (  193 914 ) resistor r=2.87058 //w=0.35 //l=0.085 //layer=li \
 //thickness=0.1 //x=1.495 //y=7.585 //x2=1.58 //y2=7.585
r2056 (  193 196 ) resistor r=9.24251 //w=0.367 //l=0.265 //layer=li \
 //thickness=0.1 //x=1.495 //y=7.585 //x2=1.23 //y2=7.585
r2057 (  186 868 ) resistor r=9.3 //w=0.17 //l=0.17 //layer=mcon //count=1 \
 //x=67.42 //y=6.92 //x2=67.42 //y2=6.92
r2058 (  183 1066 ) resistor r=9.3 //w=0.17 //l=0.17 //layer=mcon //count=1 \
 //x=66.54 //y=6.92 //x2=66.54 //y2=6.92
r2059 (  180 853 ) resistor r=9.3 //w=0.17 //l=0.17 //layer=mcon //count=1 \
 //x=65.66 //y=6.92 //x2=65.66 //y2=6.92
r2060 (  176 840 ) resistor r=3.1 //w=0.17 //l=0.51 //layer=mcon //count=3 \
 //x=65.61 //y=7.58 //x2=65.61 //y2=7.58
r2061 (  137 1007 ) resistor r=4.65 //w=0.17 //l=0.34 //layer=mcon //count=2 \
 //x=76.34 //y=7.58 //x2=76.34 //y2=7.58
r2062 (  135 1005 ) resistor r=3.1 //w=0.17 //l=0.51 //layer=mcon //count=3 \
 //x=75.6 //y=7.58 //x2=75.6 //y2=7.58
r2063 (  135 137 ) resistor r=0.297428 //w=0.311 //l=0.74 //layer=m1 \
 //thickness=0.36 //x=75.6 //y=7.585 //x2=76.34 //y2=7.585
r2064 (  133 887 ) resistor r=3.1 //w=0.17 //l=0.51 //layer=mcon //count=3 \
 //x=74.12 //y=7.58 //x2=74.12 //y2=7.58
r2065 (  133 135 ) resistor r=0.594855 //w=0.311 //l=1.48 //layer=m1 \
 //thickness=0.36 //x=74.12 //y=7.585 //x2=75.6 //y2=7.585
r2066 (  131 885 ) resistor r=3.1 //w=0.17 //l=0.51 //layer=mcon //count=3 \
 //x=73.01 //y=7.58 //x2=73.01 //y2=7.58
r2067 (  131 133 ) resistor r=0.446141 //w=0.311 //l=1.11 //layer=m1 \
 //thickness=0.36 //x=73.01 //y=7.585 //x2=74.12 //y2=7.585
r2068 (  129 883 ) resistor r=3.1 //w=0.17 //l=0.51 //layer=mcon //count=3 \
 //x=71.9 //y=7.58 //x2=71.9 //y2=7.58
r2069 (  129 131 ) resistor r=0.446141 //w=0.311 //l=1.11 //layer=m1 \
 //thickness=0.36 //x=71.9 //y=7.585 //x2=73.01 //y2=7.585
r2070 (  127 877 ) resistor r=3.1 //w=0.17 //l=0.51 //layer=mcon //count=3 \
 //x=70.42 //y=7.58 //x2=70.42 //y2=7.58
r2071 (  127 129 ) resistor r=0.594855 //w=0.311 //l=1.48 //layer=m1 \
 //thickness=0.36 //x=70.42 //y=7.585 //x2=71.9 //y2=7.585
r2072 (  125 875 ) resistor r=3.1 //w=0.17 //l=0.51 //layer=mcon //count=3 \
 //x=69.31 //y=7.58 //x2=69.31 //y2=7.58
r2073 (  125 127 ) resistor r=0.446141 //w=0.311 //l=1.11 //layer=m1 \
 //thickness=0.36 //x=69.31 //y=7.585 //x2=70.42 //y2=7.585
r2074 (  123 844 ) resistor r=3.1 //w=0.17 //l=0.51 //layer=mcon //count=3 \
 //x=67.83 //y=7.58 //x2=67.83 //y2=7.58
r2075 (  123 125 ) resistor r=0.594855 //w=0.311 //l=1.48 //layer=m1 \
 //thickness=0.36 //x=67.83 //y=7.585 //x2=69.31 //y2=7.585
r2076 (  121 184 ) resistor r=0.028033 //w=0.35 //l=0.085 //layer=m1 \
 //thickness=0.36 //x=67.505 //y=7.585 //x2=67.42 //y2=7.585
r2077 (  121 123 ) resistor r=0.130627 //w=0.311 //l=0.325 //layer=m1 \
 //thickness=0.36 //x=67.505 //y=7.585 //x2=67.83 //y2=7.585
r2078 (  120 184 ) resistor r=0.0413265 //w=0.7 //l=0.175 //layer=m1 \
 //thickness=0.36 //x=67.42 //y=7.41 //x2=67.42 //y2=7.585
r2079 (  119 186 ) resistor r=0.0715665 //w=0.226 //l=0.115 //layer=m1 \
 //thickness=0.36 //x=67.42 //y=7.035 //x2=67.42 //y2=6.92
r2080 (  119 120 ) resistor r=0.357824 //w=0.131 //l=0.375 //layer=m1 \
 //thickness=0.36 //x=67.42 //y=7.035 //x2=67.42 //y2=7.41
r2081 (  118 842 ) resistor r=3.1 //w=0.17 //l=0.51 //layer=mcon //count=3 \
 //x=66.72 //y=7.58 //x2=66.72 //y2=7.58
r2082 (  116 181 ) resistor r=0.028033 //w=0.35 //l=0.085 //layer=m1 \
 //thickness=0.36 //x=66.625 //y=7.585 //x2=66.54 //y2=7.585
r2083 (  116 118 ) resistor r=0.0381833 //w=0.311 //l=0.095 //layer=m1 \
 //thickness=0.36 //x=66.625 //y=7.585 //x2=66.72 //y2=7.585
r2084 (  115 184 ) resistor r=0.028033 //w=0.35 //l=0.085 //layer=m1 \
 //thickness=0.36 //x=67.335 //y=7.585 //x2=67.42 //y2=7.585
r2085 (  115 118 ) resistor r=0.247186 //w=0.311 //l=0.615 //layer=m1 \
 //thickness=0.36 //x=67.335 //y=7.585 //x2=66.72 //y2=7.585
r2086 (  114 181 ) resistor r=0.0413265 //w=0.7 //l=0.175 //layer=m1 \
 //thickness=0.36 //x=66.54 //y=7.41 //x2=66.54 //y2=7.585
r2087 (  113 183 ) resistor r=0.0715665 //w=0.226 //l=0.117473 //layer=m1 \
 //thickness=0.36 //x=66.54 //y=7.035 //x2=66.545 //y2=6.92
r2088 (  113 114 ) resistor r=0.357824 //w=0.131 //l=0.375 //layer=m1 \
 //thickness=0.36 //x=66.54 //y=7.035 //x2=66.54 //y2=7.41
r2089 (  112 176 ) resistor r=0.028033 //w=0.35 //l=0.085 //layer=m1 \
 //thickness=0.36 //x=65.745 //y=7.585 //x2=65.66 //y2=7.585
r2090 (  111 181 ) resistor r=0.028033 //w=0.35 //l=0.085 //layer=m1 \
 //thickness=0.36 //x=66.455 //y=7.585 //x2=66.54 //y2=7.585
r2091 (  111 112 ) resistor r=0.28537 //w=0.311 //l=0.71 //layer=m1 \
 //thickness=0.36 //x=66.455 //y=7.585 //x2=65.745 //y2=7.585
r2092 (  110 176 ) resistor r=0.0413265 //w=0.7 //l=0.175 //layer=m1 \
 //thickness=0.36 //x=65.66 //y=7.41 //x2=65.66 //y2=7.585
r2093 (  109 180 ) resistor r=0.0712609 //w=0.23 //l=0.11649 //layer=m1 \
 //thickness=0.36 //x=65.66 //y=7.035 //x2=65.657 //y2=6.92
r2094 (  109 110 ) resistor r=0.357824 //w=0.131 //l=0.375 //layer=m1 \
 //thickness=0.36 //x=65.66 //y=7.035 //x2=65.66 //y2=7.41
r2095 (  108 999 ) resistor r=3.1 //w=0.17 //l=0.51 //layer=mcon //count=3 \
 //x=64.13 //y=7.58 //x2=64.13 //y2=7.58
r2096 (  106 818 ) resistor r=3.1 //w=0.17 //l=0.51 //layer=mcon //count=3 \
 //x=63.02 //y=7.58 //x2=63.02 //y2=7.58
r2097 (  106 108 ) resistor r=0.446141 //w=0.311 //l=1.11 //layer=m1 \
 //thickness=0.36 //x=63.02 //y=7.585 //x2=64.13 //y2=7.585
r2098 (  104 806 ) resistor r=3.1 //w=0.17 //l=0.51 //layer=mcon //count=3 \
 //x=61.91 //y=7.58 //x2=61.91 //y2=7.58
r2099 (  104 106 ) resistor r=0.446141 //w=0.311 //l=1.11 //layer=m1 \
 //thickness=0.36 //x=61.91 //y=7.585 //x2=63.02 //y2=7.585
r2100 (  102 792 ) resistor r=3.1 //w=0.17 //l=0.51 //layer=mcon //count=3 \
 //x=60.43 //y=7.58 //x2=60.43 //y2=7.58
r2101 (  102 104 ) resistor r=0.594855 //w=0.311 //l=1.48 //layer=m1 \
 //thickness=0.36 //x=60.43 //y=7.585 //x2=61.91 //y2=7.585
r2102 (  100 782 ) resistor r=3.1 //w=0.17 //l=0.51 //layer=mcon //count=3 \
 //x=59.32 //y=7.58 //x2=59.32 //y2=7.58
r2103 (  100 102 ) resistor r=0.446141 //w=0.311 //l=1.11 //layer=m1 \
 //thickness=0.36 //x=59.32 //y=7.585 //x2=60.43 //y2=7.585
r2104 (  98 766 ) resistor r=3.1 //w=0.17 //l=0.51 //layer=mcon //count=3 \
 //x=57.84 //y=7.58 //x2=57.84 //y2=7.58
r2105 (  98 100 ) resistor r=0.594855 //w=0.311 //l=1.48 //layer=m1 \
 //thickness=0.36 //x=57.84 //y=7.585 //x2=59.32 //y2=7.585
r2106 (  96 756 ) resistor r=3.1 //w=0.17 //l=0.51 //layer=mcon //count=3 \
 //x=56.73 //y=7.58 //x2=56.73 //y2=7.58
r2107 (  96 98 ) resistor r=0.446141 //w=0.311 //l=1.11 //layer=m1 \
 //thickness=0.36 //x=56.73 //y=7.585 //x2=57.84 //y2=7.585
r2108 (  94 988 ) resistor r=3.1 //w=0.17 //l=0.51 //layer=mcon //count=3 \
 //x=55.62 //y=7.58 //x2=55.62 //y2=7.58
r2109 (  94 96 ) resistor r=0.446141 //w=0.311 //l=1.11 //layer=m1 \
 //thickness=0.36 //x=55.62 //y=7.585 //x2=56.73 //y2=7.585
r2110 (  92 985 ) resistor r=3.1 //w=0.17 //l=0.51 //layer=mcon //count=3 \
 //x=54.14 //y=7.58 //x2=54.14 //y2=7.58
r2111 (  92 94 ) resistor r=0.594855 //w=0.311 //l=1.48 //layer=m1 \
 //thickness=0.36 //x=54.14 //y=7.585 //x2=55.62 //y2=7.585
r2112 (  90 716 ) resistor r=3.1 //w=0.17 //l=0.51 //layer=mcon //count=3 \
 //x=53.03 //y=7.58 //x2=53.03 //y2=7.58
r2113 (  90 92 ) resistor r=0.446141 //w=0.311 //l=1.11 //layer=m1 \
 //thickness=0.36 //x=53.03 //y=7.585 //x2=54.14 //y2=7.585
r2114 (  88 704 ) resistor r=3.1 //w=0.17 //l=0.51 //layer=mcon //count=3 \
 //x=51.92 //y=7.58 //x2=51.92 //y2=7.58
r2115 (  88 90 ) resistor r=0.446141 //w=0.311 //l=1.11 //layer=m1 \
 //thickness=0.36 //x=51.92 //y=7.585 //x2=53.03 //y2=7.585
r2116 (  86 690 ) resistor r=3.1 //w=0.17 //l=0.51 //layer=mcon //count=3 \
 //x=50.44 //y=7.58 //x2=50.44 //y2=7.58
r2117 (  86 88 ) resistor r=0.594855 //w=0.311 //l=1.48 //layer=m1 \
 //thickness=0.36 //x=50.44 //y=7.585 //x2=51.92 //y2=7.585
r2118 (  84 680 ) resistor r=3.1 //w=0.17 //l=0.51 //layer=mcon //count=3 \
 //x=49.33 //y=7.58 //x2=49.33 //y2=7.58
r2119 (  84 86 ) resistor r=0.446141 //w=0.311 //l=1.11 //layer=m1 \
 //thickness=0.36 //x=49.33 //y=7.585 //x2=50.44 //y2=7.585
r2120 (  82 664 ) resistor r=3.1 //w=0.17 //l=0.51 //layer=mcon //count=3 \
 //x=47.85 //y=7.58 //x2=47.85 //y2=7.58
r2121 (  82 84 ) resistor r=0.594855 //w=0.311 //l=1.48 //layer=m1 \
 //thickness=0.36 //x=47.85 //y=7.585 //x2=49.33 //y2=7.585
r2122 (  80 654 ) resistor r=3.1 //w=0.17 //l=0.51 //layer=mcon //count=3 \
 //x=46.74 //y=7.58 //x2=46.74 //y2=7.58
r2123 (  80 82 ) resistor r=0.446141 //w=0.311 //l=1.11 //layer=m1 \
 //thickness=0.36 //x=46.74 //y=7.585 //x2=47.85 //y2=7.585
r2124 (  78 644 ) resistor r=3.1 //w=0.17 //l=0.51 //layer=mcon //count=3 \
 //x=45.63 //y=7.58 //x2=45.63 //y2=7.58
r2125 (  78 80 ) resistor r=0.446141 //w=0.311 //l=1.11 //layer=m1 \
 //thickness=0.36 //x=45.63 //y=7.585 //x2=46.74 //y2=7.585
r2126 (  76 973 ) resistor r=3.1 //w=0.17 //l=0.51 //layer=mcon //count=3 \
 //x=44.52 //y=7.58 //x2=44.52 //y2=7.58
r2127 (  76 78 ) resistor r=0.446141 //w=0.311 //l=1.11 //layer=m1 \
 //thickness=0.36 //x=44.52 //y=7.585 //x2=45.63 //y2=7.585
r2128 (  74 620 ) resistor r=3.1 //w=0.17 //l=0.51 //layer=mcon //count=3 \
 //x=43.04 //y=7.58 //x2=43.04 //y2=7.58
r2129 (  74 76 ) resistor r=0.594855 //w=0.311 //l=1.48 //layer=m1 \
 //thickness=0.36 //x=43.04 //y=7.585 //x2=44.52 //y2=7.585
r2130 (  72 610 ) resistor r=3.1 //w=0.17 //l=0.51 //layer=mcon //count=3 \
 //x=41.93 //y=7.58 //x2=41.93 //y2=7.58
r2131 (  72 74 ) resistor r=0.446141 //w=0.311 //l=1.11 //layer=m1 \
 //thickness=0.36 //x=41.93 //y=7.585 //x2=43.04 //y2=7.585
r2132 (  70 968 ) resistor r=3.1 //w=0.17 //l=0.51 //layer=mcon //count=3 \
 //x=40.82 //y=7.58 //x2=40.82 //y2=7.58
r2133 (  70 72 ) resistor r=0.446141 //w=0.311 //l=1.11 //layer=m1 \
 //thickness=0.36 //x=40.82 //y=7.585 //x2=41.93 //y2=7.585
r2134 (  68 965 ) resistor r=3.1 //w=0.17 //l=0.51 //layer=mcon //count=3 \
 //x=39.34 //y=7.58 //x2=39.34 //y2=7.58
r2135 (  68 70 ) resistor r=0.594855 //w=0.311 //l=1.48 //layer=m1 \
 //thickness=0.36 //x=39.34 //y=7.585 //x2=40.82 //y2=7.585
r2136 (  65 570 ) resistor r=3.1 //w=0.17 //l=0.51 //layer=mcon //count=3 \
 //x=38.23 //y=7.58 //x2=38.23 //y2=7.58
r2137 (  63 558 ) resistor r=3.1 //w=0.17 //l=0.51 //layer=mcon //count=3 \
 //x=37.12 //y=7.58 //x2=37.12 //y2=7.58
r2138 (  63 65 ) resistor r=0.446141 //w=0.311 //l=1.11 //layer=m1 \
 //thickness=0.36 //x=37.12 //y=7.585 //x2=38.23 //y2=7.585
r2139 (  61 544 ) resistor r=3.1 //w=0.17 //l=0.51 //layer=mcon //count=3 \
 //x=35.64 //y=7.58 //x2=35.64 //y2=7.58
r2140 (  61 63 ) resistor r=0.594855 //w=0.311 //l=1.48 //layer=m1 \
 //thickness=0.36 //x=35.64 //y=7.585 //x2=37.12 //y2=7.585
r2141 (  59 534 ) resistor r=3.1 //w=0.17 //l=0.51 //layer=mcon //count=3 \
 //x=34.53 //y=7.58 //x2=34.53 //y2=7.58
r2142 (  59 61 ) resistor r=0.446141 //w=0.311 //l=1.11 //layer=m1 \
 //thickness=0.36 //x=34.53 //y=7.585 //x2=35.64 //y2=7.585
r2143 (  57 518 ) resistor r=3.1 //w=0.17 //l=0.51 //layer=mcon //count=3 \
 //x=33.05 //y=7.58 //x2=33.05 //y2=7.58
r2144 (  57 59 ) resistor r=0.594855 //w=0.311 //l=1.48 //layer=m1 \
 //thickness=0.36 //x=33.05 //y=7.585 //x2=34.53 //y2=7.585
r2145 (  55 508 ) resistor r=3.1 //w=0.17 //l=0.51 //layer=mcon //count=3 \
 //x=31.94 //y=7.58 //x2=31.94 //y2=7.58
r2146 (  55 57 ) resistor r=0.446141 //w=0.311 //l=1.11 //layer=m1 \
 //thickness=0.36 //x=31.94 //y=7.585 //x2=33.05 //y2=7.585
r2147 (  53 954 ) resistor r=3.1 //w=0.17 //l=0.51 //layer=mcon //count=3 \
 //x=30.83 //y=7.58 //x2=30.83 //y2=7.58
r2148 (  53 55 ) resistor r=0.446141 //w=0.311 //l=1.11 //layer=m1 \
 //thickness=0.36 //x=30.83 //y=7.585 //x2=31.94 //y2=7.585
r2149 (  51 951 ) resistor r=3.1 //w=0.17 //l=0.51 //layer=mcon //count=3 \
 //x=29.35 //y=7.58 //x2=29.35 //y2=7.58
r2150 (  51 53 ) resistor r=0.594855 //w=0.311 //l=1.48 //layer=m1 \
 //thickness=0.36 //x=29.35 //y=7.585 //x2=30.83 //y2=7.585
r2151 (  49 468 ) resistor r=3.1 //w=0.17 //l=0.51 //layer=mcon //count=3 \
 //x=28.24 //y=7.58 //x2=28.24 //y2=7.58
r2152 (  49 51 ) resistor r=0.446141 //w=0.311 //l=1.11 //layer=m1 \
 //thickness=0.36 //x=28.24 //y=7.585 //x2=29.35 //y2=7.585
r2153 (  47 456 ) resistor r=3.1 //w=0.17 //l=0.51 //layer=mcon //count=3 \
 //x=27.13 //y=7.58 //x2=27.13 //y2=7.58
r2154 (  47 49 ) resistor r=0.446141 //w=0.311 //l=1.11 //layer=m1 \
 //thickness=0.36 //x=27.13 //y=7.585 //x2=28.24 //y2=7.585
r2155 (  45 946 ) resistor r=3.1 //w=0.17 //l=0.51 //layer=mcon //count=3 \
 //x=25.65 //y=7.58 //x2=25.65 //y2=7.58
r2156 (  45 47 ) resistor r=0.594855 //w=0.311 //l=1.48 //layer=m1 \
 //thickness=0.36 //x=25.65 //y=7.585 //x2=27.13 //y2=7.585
r2157 (  43 434 ) resistor r=3.1 //w=0.17 //l=0.51 //layer=mcon //count=3 \
 //x=24.54 //y=7.58 //x2=24.54 //y2=7.58
r2158 (  43 45 ) resistor r=0.446141 //w=0.311 //l=1.11 //layer=m1 \
 //thickness=0.36 //x=24.54 //y=7.585 //x2=25.65 //y2=7.585
r2159 (  41 424 ) resistor r=3.1 //w=0.17 //l=0.51 //layer=mcon //count=3 \
 //x=23.43 //y=7.58 //x2=23.43 //y2=7.58
r2160 (  41 43 ) resistor r=0.446141 //w=0.311 //l=1.11 //layer=m1 \
 //thickness=0.36 //x=23.43 //y=7.585 //x2=24.54 //y2=7.585
r2161 (  39 412 ) resistor r=3.1 //w=0.17 //l=0.51 //layer=mcon //count=3 \
 //x=22.32 //y=7.58 //x2=22.32 //y2=7.58
r2162 (  39 41 ) resistor r=0.446141 //w=0.311 //l=1.11 //layer=m1 \
 //thickness=0.36 //x=22.32 //y=7.585 //x2=23.43 //y2=7.585
r2163 (  37 398 ) resistor r=3.1 //w=0.17 //l=0.51 //layer=mcon //count=3 \
 //x=20.84 //y=7.58 //x2=20.84 //y2=7.58
r2164 (  37 39 ) resistor r=0.594855 //w=0.311 //l=1.48 //layer=m1 \
 //thickness=0.36 //x=20.84 //y=7.585 //x2=22.32 //y2=7.585
r2165 (  35 388 ) resistor r=3.1 //w=0.17 //l=0.51 //layer=mcon //count=3 \
 //x=19.73 //y=7.58 //x2=19.73 //y2=7.58
r2166 (  35 37 ) resistor r=0.446141 //w=0.311 //l=1.11 //layer=m1 \
 //thickness=0.36 //x=19.73 //y=7.585 //x2=20.84 //y2=7.585
r2167 (  33 372 ) resistor r=3.1 //w=0.17 //l=0.51 //layer=mcon //count=3 \
 //x=18.25 //y=7.58 //x2=18.25 //y2=7.58
r2168 (  33 35 ) resistor r=0.594855 //w=0.311 //l=1.48 //layer=m1 \
 //thickness=0.36 //x=18.25 //y=7.585 //x2=19.73 //y2=7.585
r2169 (  31 362 ) resistor r=3.1 //w=0.17 //l=0.51 //layer=mcon //count=3 \
 //x=17.14 //y=7.58 //x2=17.14 //y2=7.58
r2170 (  31 33 ) resistor r=0.446141 //w=0.311 //l=1.11 //layer=m1 \
 //thickness=0.36 //x=17.14 //y=7.585 //x2=18.25 //y2=7.585
r2171 (  29 934 ) resistor r=3.1 //w=0.17 //l=0.51 //layer=mcon //count=3 \
 //x=16.03 //y=7.58 //x2=16.03 //y2=7.58
r2172 (  29 31 ) resistor r=0.446141 //w=0.311 //l=1.11 //layer=m1 \
 //thickness=0.36 //x=16.03 //y=7.585 //x2=17.14 //y2=7.585
r2173 (  27 931 ) resistor r=3.1 //w=0.17 //l=0.51 //layer=mcon //count=3 \
 //x=14.55 //y=7.58 //x2=14.55 //y2=7.58
r2174 (  27 29 ) resistor r=0.594855 //w=0.311 //l=1.48 //layer=m1 \
 //thickness=0.36 //x=14.55 //y=7.585 //x2=16.03 //y2=7.585
r2175 (  25 322 ) resistor r=3.1 //w=0.17 //l=0.51 //layer=mcon //count=3 \
 //x=13.44 //y=7.58 //x2=13.44 //y2=7.58
r2176 (  25 27 ) resistor r=0.446141 //w=0.311 //l=1.11 //layer=m1 \
 //thickness=0.36 //x=13.44 //y=7.585 //x2=14.55 //y2=7.585
r2177 (  23 310 ) resistor r=3.1 //w=0.17 //l=0.51 //layer=mcon //count=3 \
 //x=12.33 //y=7.58 //x2=12.33 //y2=7.58
r2178 (  23 25 ) resistor r=0.446141 //w=0.311 //l=1.11 //layer=m1 \
 //thickness=0.36 //x=12.33 //y=7.585 //x2=13.44 //y2=7.585
r2179 (  21 296 ) resistor r=3.1 //w=0.17 //l=0.51 //layer=mcon //count=3 \
 //x=10.85 //y=7.58 //x2=10.85 //y2=7.58
r2180 (  21 23 ) resistor r=0.594855 //w=0.311 //l=1.48 //layer=m1 \
 //thickness=0.36 //x=10.85 //y=7.585 //x2=12.33 //y2=7.585
r2181 (  19 286 ) resistor r=3.1 //w=0.17 //l=0.51 //layer=mcon //count=3 \
 //x=9.74 //y=7.58 //x2=9.74 //y2=7.58
r2182 (  19 21 ) resistor r=0.446141 //w=0.311 //l=1.11 //layer=m1 \
 //thickness=0.36 //x=9.74 //y=7.585 //x2=10.85 //y2=7.585
r2183 (  17 270 ) resistor r=3.1 //w=0.17 //l=0.51 //layer=mcon //count=3 \
 //x=8.26 //y=7.58 //x2=8.26 //y2=7.58
r2184 (  17 19 ) resistor r=0.594855 //w=0.311 //l=1.48 //layer=m1 \
 //thickness=0.36 //x=8.26 //y=7.585 //x2=9.74 //y2=7.585
r2185 (  15 260 ) resistor r=3.1 //w=0.17 //l=0.51 //layer=mcon //count=3 \
 //x=7.15 //y=7.58 //x2=7.15 //y2=7.58
r2186 (  15 17 ) resistor r=0.446141 //w=0.311 //l=1.11 //layer=m1 \
 //thickness=0.36 //x=7.15 //y=7.585 //x2=8.26 //y2=7.585
r2187 (  13 920 ) resistor r=3.1 //w=0.17 //l=0.51 //layer=mcon //count=3 \
 //x=6.04 //y=7.58 //x2=6.04 //y2=7.58
r2188 (  13 15 ) resistor r=0.446141 //w=0.311 //l=1.11 //layer=m1 \
 //thickness=0.36 //x=6.04 //y=7.585 //x2=7.15 //y2=7.585
r2189 (  11 236 ) resistor r=3.1 //w=0.17 //l=0.51 //layer=mcon //count=3 \
 //x=4.56 //y=7.58 //x2=4.56 //y2=7.58
r2190 (  11 13 ) resistor r=0.594855 //w=0.311 //l=1.48 //layer=m1 \
 //thickness=0.36 //x=4.56 //y=7.585 //x2=6.04 //y2=7.585
r2191 (  9 226 ) resistor r=3.1 //w=0.17 //l=0.51 //layer=mcon //count=3 \
 //x=3.45 //y=7.58 //x2=3.45 //y2=7.58
r2192 (  9 11 ) resistor r=0.446141 //w=0.311 //l=1.11 //layer=m1 \
 //thickness=0.36 //x=3.45 //y=7.585 //x2=4.56 //y2=7.585
r2193 (  7 208 ) resistor r=3.1 //w=0.17 //l=0.51 //layer=mcon //count=3 \
 //x=2.34 //y=7.58 //x2=2.34 //y2=7.58
r2194 (  7 9 ) resistor r=0.446141 //w=0.311 //l=1.11 //layer=m1 \
 //thickness=0.36 //x=2.34 //y=7.585 //x2=3.45 //y2=7.585
r2195 (  4 196 ) resistor r=3.1 //w=0.17 //l=0.51 //layer=mcon //count=3 \
 //x=1.23 //y=7.58 //x2=1.23 //y2=7.58
r2196 (  4 7 ) resistor r=0.446141 //w=0.311 //l=1.11 //layer=m1 \
 //thickness=0.36 //x=1.23 //y=7.585 //x2=2.34 //y2=7.585
r2197 (  2 176 ) resistor r=0.028033 //w=0.35 //l=0.085 //layer=m1 \
 //thickness=0.36 //x=65.575 //y=7.585 //x2=65.66 //y2=7.585
r2198 (  2 108 ) resistor r=0.580788 //w=0.311 //l=1.445 //layer=m1 \
 //thickness=0.36 //x=65.575 //y=7.585 //x2=64.13 //y2=7.585
r2199 (  1 68 ) resistor r=0.223071 //w=0.311 //l=0.555 //layer=m1 \
 //thickness=0.36 //x=38.785 //y=7.585 //x2=39.34 //y2=7.585
r2200 (  1 65 ) resistor r=0.223071 //w=0.311 //l=0.555 //layer=m1 \
 //thickness=0.36 //x=38.785 //y=7.585 //x2=38.23 //y2=7.585
ends PM_TMRDFFQX1\%VDD

subckt PM_TMRDFFQX1\%noxref_23 ( 5 7 15 19 30 33 34 )
c64 ( 34 0 ) capacitor c=0.0463677f //x=3.455 //y=0.555
c65 ( 33 0 ) capacitor c=0.0198746f //x=2.35 //y=1.09
c66 ( 30 0 ) capacitor c=0.00141302f //x=3.59 //y=1.175
c67 ( 19 0 ) capacitor c=0.00695768f //x=4.56 //y=0.805
c68 ( 15 0 ) capacitor c=0.0154966f //x=4.475 //y=0.72
c69 ( 7 0 ) capacitor c=0.00689476f //x=3.59 //y=0.805
c70 ( 5 0 ) capacitor c=0.0288646f //x=3.505 //y=1.175
r71 (  19 34 ) resistor r=3.57586 //w=0.17 //l=0.125 //layer=li \
 //thickness=0.1 //x=4.56 //y=0.805 //x2=4.56 //y2=0.68
r72 (  19 34 ) resistor r=18.139 //w=0.187 //l=0.265 //layer=li \
 //thickness=0.1 //x=4.56 //y=0.805 //x2=4.56 //y2=1.07
r73 (  16 34 ) resistor r=3.57586 //w=0.17 //l=0.103078 //layer=li \
 //thickness=0.1 //x=3.675 //y=0.72 //x2=3.59 //y2=0.68
r74 (  16 34 ) resistor r=27.3797 //w=0.187 //l=0.4 //layer=li //thickness=0.1 \
 //x=3.675 //y=0.72 //x2=4.075 //y2=0.72
r75 (  15 34 ) resistor r=3.57586 //w=0.17 //l=0.103078 //layer=li \
 //thickness=0.1 //x=4.475 //y=0.72 //x2=4.56 //y2=0.68
r76 (  15 34 ) resistor r=27.3797 //w=0.187 //l=0.4 //layer=li //thickness=0.1 \
 //x=4.475 //y=0.72 //x2=4.075 //y2=0.72
r77 (  11 30 ) resistor r=5.4201 //w=0.17 //l=0.085 //layer=li //thickness=0.1 \
 //x=3.59 //y=1.26 //x2=3.59 //y2=1.175
r78 (  11 34 ) resistor r=10.2674 //w=0.187 //l=0.15 //layer=li \
 //thickness=0.1 //x=3.59 //y=1.26 //x2=3.59 //y2=1.41
r79 (  8 30 ) resistor r=5.4201 //w=0.17 //l=0.085 //layer=li //thickness=0.1 \
 //x=3.59 //y=1.09 //x2=3.59 //y2=1.175
r80 (  8 34 ) resistor r=1.36898 //w=0.187 //l=0.02 //layer=li //thickness=0.1 \
 //x=3.59 //y=1.09 //x2=3.59 //y2=1.07
r81 (  7 34 ) resistor r=3.57586 //w=0.17 //l=0.125 //layer=li //thickness=0.1 \
 //x=3.59 //y=0.805 //x2=3.59 //y2=0.68
r82 (  7 34 ) resistor r=18.139 //w=0.187 //l=0.265 //layer=li //thickness=0.1 \
 //x=3.59 //y=0.805 //x2=3.59 //y2=1.07
r83 (  6 33 ) resistor r=0.751729 //w=0.17 //l=0.085 //layer=li \
 //thickness=0.1 //x=2.625 //y=1.175 //x2=2.54 //y2=1.175
r84 (  5 30 ) resistor r=1.40859 //w=0.34 //l=0.085 //layer=li //thickness=0.1 \
 //x=3.505 //y=1.175 //x2=3.59 //y2=1.175
r85 (  5 6 ) resistor r=60.2353 //w=0.187 //l=0.88 //layer=li //thickness=0.1 \
 //x=3.505 //y=1.175 //x2=2.625 //y2=1.175
ends PM_TMRDFFQX1\%noxref_23

subckt PM_TMRDFFQX1\%noxref_24 ( 5 7 15 19 30 33 34 )
c68 ( 34 0 ) capacitor c=0.0455191f //x=24.915 //y=0.555
c69 ( 33 0 ) capacitor c=0.0195173f //x=23.81 //y=1.09
c70 ( 30 0 ) capacitor c=0.00141302f //x=25.05 //y=1.175
c71 ( 19 0 ) capacitor c=0.00695768f //x=26.02 //y=0.805
c72 ( 15 0 ) capacitor c=0.0155183f //x=25.935 //y=0.72
c73 ( 7 0 ) capacitor c=0.00689476f //x=25.05 //y=0.805
c74 ( 5 0 ) capacitor c=0.0241875f //x=24.965 //y=1.175
r75 (  19 34 ) resistor r=3.57586 //w=0.17 //l=0.125 //layer=li \
 //thickness=0.1 //x=26.02 //y=0.805 //x2=26.02 //y2=0.68
r76 (  19 34 ) resistor r=18.139 //w=0.187 //l=0.265 //layer=li \
 //thickness=0.1 //x=26.02 //y=0.805 //x2=26.02 //y2=1.07
r77 (  16 34 ) resistor r=3.57586 //w=0.17 //l=0.103078 //layer=li \
 //thickness=0.1 //x=25.135 //y=0.72 //x2=25.05 //y2=0.68
r78 (  16 34 ) resistor r=27.3797 //w=0.187 //l=0.4 //layer=li //thickness=0.1 \
 //x=25.135 //y=0.72 //x2=25.535 //y2=0.72
r79 (  15 34 ) resistor r=3.57586 //w=0.17 //l=0.103078 //layer=li \
 //thickness=0.1 //x=25.935 //y=0.72 //x2=26.02 //y2=0.68
r80 (  15 34 ) resistor r=27.3797 //w=0.187 //l=0.4 //layer=li //thickness=0.1 \
 //x=25.935 //y=0.72 //x2=25.535 //y2=0.72
r81 (  11 30 ) resistor r=5.4201 //w=0.17 //l=0.085 //layer=li //thickness=0.1 \
 //x=25.05 //y=1.26 //x2=25.05 //y2=1.175
r82 (  11 34 ) resistor r=10.2674 //w=0.187 //l=0.15 //layer=li \
 //thickness=0.1 //x=25.05 //y=1.26 //x2=25.05 //y2=1.41
r83 (  8 30 ) resistor r=5.4201 //w=0.17 //l=0.085 //layer=li //thickness=0.1 \
 //x=25.05 //y=1.09 //x2=25.05 //y2=1.175
r84 (  8 34 ) resistor r=1.36898 //w=0.187 //l=0.02 //layer=li //thickness=0.1 \
 //x=25.05 //y=1.09 //x2=25.05 //y2=1.07
r85 (  7 34 ) resistor r=3.57586 //w=0.17 //l=0.125 //layer=li //thickness=0.1 \
 //x=25.05 //y=0.805 //x2=25.05 //y2=0.68
r86 (  7 34 ) resistor r=18.139 //w=0.187 //l=0.265 //layer=li //thickness=0.1 \
 //x=25.05 //y=0.805 //x2=25.05 //y2=1.07
r87 (  6 33 ) resistor r=0.751729 //w=0.17 //l=0.085 //layer=li \
 //thickness=0.1 //x=24.085 //y=1.175 //x2=24 //y2=1.175
r88 (  5 30 ) resistor r=1.40859 //w=0.34 //l=0.085 //layer=li //thickness=0.1 \
 //x=24.965 //y=1.175 //x2=25.05 //y2=1.175
r89 (  5 6 ) resistor r=60.2353 //w=0.187 //l=0.88 //layer=li //thickness=0.1 \
 //x=24.965 //y=1.175 //x2=24.085 //y2=1.175
ends PM_TMRDFFQX1\%noxref_24

subckt PM_TMRDFFQX1\%noxref_25 ( 3 8 9 11 12 14 15 16 19 20 23 25 28 30 38 54 \
 56 57 )
c166 ( 54 0 ) capacitor c=0.00878249f //x=42.04 //y=1.085
c167 ( 38 0 ) capacitor c=0.0322017f //x=42.19 //y=5.56
c168 ( 30 0 ) capacitor c=0.0290186f //x=41.31 //y=5.56
c169 ( 28 0 ) capacitor c=0.0141761f //x=42.67 //y=2.4
c170 ( 25 0 ) capacitor c=0.0112381f //x=42.23 //y=1.18
c171 ( 23 0 ) capacitor c=5.78613e-19 //x=42.19 //y=5.56
c172 ( 20 0 ) capacitor c=0.0107082f //x=42.19 //y=5.38
c173 ( 19 0 ) capacitor c=0.00923159f //x=41.31 //y=5.56
c174 ( 16 0 ) capacitor c=0.0760679f //x=42.67 //y=5.295
c175 ( 15 0 ) capacitor c=0.0115456f //x=42.67 //y=2.515
c176 ( 14 0 ) capacitor c=0.00923189f //x=42.67 //y=2.285
c177 ( 12 0 ) capacitor c=0.00465779f //x=42.315 //y=1.835
c178 ( 11 0 ) capacitor c=0.0106899f //x=42.585 //y=1.835
c179 ( 9 0 ) capacitor c=0.0116477f //x=42.585 //y=5.38
c180 ( 8 0 ) capacitor c=0.0133876f //x=42.23 //y=1.75
c181 ( 3 0 ) capacitor c=0.0134497f //x=42.075 //y=5.38
r182 (  38 57 ) resistor r=23.615 //w=0.187 //l=0.345 //layer=li \
 //thickness=0.1 //x=42.19 //y=5.56 //x2=42.19 //y2=5.905
r183 (  30 56 ) resistor r=23.615 //w=0.187 //l=0.345 //layer=li \
 //thickness=0.1 //x=41.31 //y=5.56 //x2=41.31 //y2=5.905
r184 (  25 54 ) resistor r=9.3 //w=0.17 //l=0.17 //layer=mcon //count=1 \
 //x=42.23 //y=1.18 //x2=42.23 //y2=1.18
r185 (  23 38 ) resistor r=9.3 //w=0.17 //l=0.17 //layer=mcon //count=1 \
 //x=42.19 //y=5.56 //x2=42.19 //y2=5.56
r186 (  20 23 ) resistor r=0.117801 //w=0.191 //l=0.18 //layer=m1 \
 //thickness=0.36 //x=42.19 //y=5.38 //x2=42.19 //y2=5.56
r187 (  19 30 ) resistor r=9.3 //w=0.17 //l=0.17 //layer=mcon //count=1 \
 //x=41.31 //y=5.56 //x2=41.31 //y2=5.56
r188 (  17 19 ) resistor r=0.10274 //w=0.219 //l=0.18 //layer=m1 \
 //thickness=0.36 //x=41.31 //y=5.38 //x2=41.31 //y2=5.56
r189 (  15 28 ) resistor r=0.0752589 //w=0.364 //l=0.141863 //layer=m1 \
 //thickness=0.36 //x=42.67 //y=2.515 //x2=42.61 //y2=2.4
r190 (  15 16 ) resistor r=2.65267 //w=0.131 //l=2.78 //layer=m1 \
 //thickness=0.36 //x=42.67 //y=2.515 //x2=42.67 //y2=5.295
r191 (  14 28 ) resistor r=0.0752589 //w=0.364 //l=0.141863 //layer=m1 \
 //thickness=0.36 //x=42.67 //y=2.285 //x2=42.61 //y2=2.4
r192 (  13 14 ) resistor r=0.348282 //w=0.131 //l=0.365 //layer=m1 \
 //thickness=0.36 //x=42.67 //y=1.92 //x2=42.67 //y2=2.285
r193 (  11 13 ) resistor r=0.0698411 //w=0.17 //l=0.120208 //layer=m1 \
 //thickness=0.36 //x=42.585 //y=1.835 //x2=42.67 //y2=1.92
r194 (  11 12 ) resistor r=0.257634 //w=0.131 //l=0.27 //layer=m1 \
 //thickness=0.36 //x=42.585 //y=1.835 //x2=42.315 //y2=1.835
r195 (  10 20 ) resistor r=0.0257089 //w=0.23 //l=0.115 //layer=m1 \
 //thickness=0.36 //x=42.305 //y=5.38 //x2=42.19 //y2=5.38
r196 (  9 16 ) resistor r=0.0698411 //w=0.17 //l=0.120208 //layer=m1 \
 //thickness=0.36 //x=42.585 //y=5.38 //x2=42.67 //y2=5.295
r197 (  9 10 ) resistor r=0.267176 //w=0.131 //l=0.28 //layer=m1 \
 //thickness=0.36 //x=42.585 //y=5.38 //x2=42.305 //y2=5.38
r198 (  8 12 ) resistor r=0.0698411 //w=0.17 //l=0.120208 //layer=m1 \
 //thickness=0.36 //x=42.23 //y=1.75 //x2=42.315 //y2=1.835
r199 (  7 25 ) resistor r=0.0913624 //w=0.191 //l=0.12 //layer=m1 \
 //thickness=0.36 //x=42.23 //y=1.3 //x2=42.23 //y2=1.18
r200 (  7 8 ) resistor r=0.429389 //w=0.131 //l=0.45 //layer=m1 \
 //thickness=0.36 //x=42.23 //y=1.3 //x2=42.23 //y2=1.75
r201 (  4 17 ) resistor r=0.0227762 //w=0.219 //l=0.115 //layer=m1 \
 //thickness=0.36 //x=41.425 //y=5.38 //x2=41.31 //y2=5.38
r202 (  3 20 ) resistor r=0.0257089 //w=0.23 //l=0.115 //layer=m1 \
 //thickness=0.36 //x=42.075 //y=5.38 //x2=42.19 //y2=5.38
r203 (  3 4 ) resistor r=0.620229 //w=0.131 //l=0.65 //layer=m1 \
 //thickness=0.36 //x=42.075 //y=5.38 //x2=41.425 //y2=5.38
ends PM_TMRDFFQX1\%noxref_25

subckt PM_TMRDFFQX1\%noxref_26 ( 5 7 15 19 30 33 34 )
c68 ( 34 0 ) capacitor c=0.0453527f //x=46.375 //y=0.555
c69 ( 33 0 ) capacitor c=0.0194867f //x=45.27 //y=1.09
c70 ( 30 0 ) capacitor c=0.00141302f //x=46.51 //y=1.175
c71 ( 19 0 ) capacitor c=0.00695768f //x=47.48 //y=0.805
c72 ( 15 0 ) capacitor c=0.0155081f //x=47.395 //y=0.72
c73 ( 7 0 ) capacitor c=0.00689476f //x=46.51 //y=0.805
c74 ( 5 0 ) capacitor c=0.0235962f //x=46.425 //y=1.175
r75 (  19 34 ) resistor r=3.57586 //w=0.17 //l=0.125 //layer=li \
 //thickness=0.1 //x=47.48 //y=0.805 //x2=47.48 //y2=0.68
r76 (  19 34 ) resistor r=18.139 //w=0.187 //l=0.265 //layer=li \
 //thickness=0.1 //x=47.48 //y=0.805 //x2=47.48 //y2=1.07
r77 (  16 34 ) resistor r=3.57586 //w=0.17 //l=0.103078 //layer=li \
 //thickness=0.1 //x=46.595 //y=0.72 //x2=46.51 //y2=0.68
r78 (  16 34 ) resistor r=27.3797 //w=0.187 //l=0.4 //layer=li //thickness=0.1 \
 //x=46.595 //y=0.72 //x2=46.995 //y2=0.72
r79 (  15 34 ) resistor r=3.57586 //w=0.17 //l=0.103078 //layer=li \
 //thickness=0.1 //x=47.395 //y=0.72 //x2=47.48 //y2=0.68
r80 (  15 34 ) resistor r=27.3797 //w=0.187 //l=0.4 //layer=li //thickness=0.1 \
 //x=47.395 //y=0.72 //x2=46.995 //y2=0.72
r81 (  11 30 ) resistor r=5.4201 //w=0.17 //l=0.085 //layer=li //thickness=0.1 \
 //x=46.51 //y=1.26 //x2=46.51 //y2=1.175
r82 (  11 34 ) resistor r=10.2674 //w=0.187 //l=0.15 //layer=li \
 //thickness=0.1 //x=46.51 //y=1.26 //x2=46.51 //y2=1.41
r83 (  8 30 ) resistor r=5.4201 //w=0.17 //l=0.085 //layer=li //thickness=0.1 \
 //x=46.51 //y=1.09 //x2=46.51 //y2=1.175
r84 (  8 34 ) resistor r=1.36898 //w=0.187 //l=0.02 //layer=li //thickness=0.1 \
 //x=46.51 //y=1.09 //x2=46.51 //y2=1.07
r85 (  7 34 ) resistor r=3.57586 //w=0.17 //l=0.125 //layer=li //thickness=0.1 \
 //x=46.51 //y=0.805 //x2=46.51 //y2=0.68
r86 (  7 34 ) resistor r=18.139 //w=0.187 //l=0.265 //layer=li //thickness=0.1 \
 //x=46.51 //y=0.805 //x2=46.51 //y2=1.07
r87 (  6 33 ) resistor r=0.751729 //w=0.17 //l=0.085 //layer=li \
 //thickness=0.1 //x=45.545 //y=1.175 //x2=45.46 //y2=1.175
r88 (  5 30 ) resistor r=1.40859 //w=0.34 //l=0.085 //layer=li //thickness=0.1 \
 //x=46.425 //y=1.175 //x2=46.51 //y2=1.175
r89 (  5 6 ) resistor r=60.2353 //w=0.187 //l=0.88 //layer=li //thickness=0.1 \
 //x=46.425 //y=1.175 //x2=45.545 //y2=1.175
ends PM_TMRDFFQX1\%noxref_26

subckt PM_TMRDFFQX1\%noxref_27 ( 1 3 4 5 7 9 19 25 27 30 40 49 71 72 73 74 75 )
c161 ( 75 0 ) capacitor c=0.0354016f //x=70.595 //y=5.205
c162 ( 74 0 ) capacitor c=0.0241107f //x=69.715 //y=5.205
c163 ( 72 0 ) capacitor c=0.00544792f //x=66.835 //y=5.205
c164 ( 71 0 ) capacitor c=0.00516996f //x=65.955 //y=5.205
c165 ( 49 0 ) capacitor c=0.0508454f //x=68.98 //y=5.39
c166 ( 40 0 ) capacitor c=0.0362911f //x=66.98 //y=5.39
c167 ( 30 0 ) capacitor c=0.0293961f //x=66.1 //y=5.56
c168 ( 27 0 ) capacitor c=0.00984489f //x=70.74 //y=6.92
c169 ( 25 0 ) capacitor c=0.0059844f //x=69.857 //y=7.09
c170 ( 19 0 ) capacitor c=0.00975753f //x=68.98 //y=6.92
c171 ( 9 0 ) capacitor c=0.014892f //x=66.102 //y=5.39
c172 ( 7 0 ) capacitor c=0.00787288f //x=70.625 //y=7.09
c173 ( 5 0 ) capacitor c=0.00659042f //x=69.74 //y=7.09
c174 ( 4 0 ) capacitor c=0.00558326f //x=67.095 //y=5.39
c175 ( 3 0 ) capacitor c=0.0636102f //x=68.865 //y=5.39
c176 ( 1 0 ) capacitor c=0.0147486f //x=66.865 //y=5.39
r177 (  49 73 ) resistor r=58.1818 //w=0.187 //l=0.85 //layer=li \
 //thickness=0.1 //x=68.98 //y=5.39 //x2=68.98 //y2=6.24
r178 (  40 72 ) resistor r=58.1818 //w=0.187 //l=0.85 //layer=li \
 //thickness=0.1 //x=66.98 //y=5.39 //x2=66.98 //y2=6.24
r179 (  30 71 ) resistor r=23.2727 //w=0.187 //l=0.34 //layer=li \
 //thickness=0.1 //x=66.1 //y=5.56 //x2=66.1 //y2=5.9
r180 (  27 75 ) resistor r=9.3 //w=0.17 //l=0.17 //layer=mcon //count=1 \
 //x=70.74 //y=6.92 //x2=70.74 //y2=6.92
r181 (  27 28 ) resistor r=0.0988372 //w=0.215 //l=0.17 //layer=m1 \
 //thickness=0.36 //x=70.742 //y=6.92 //x2=70.742 //y2=7.09
r182 (  24 74 ) resistor r=9.3 //w=0.17 //l=0.17 //layer=mcon //count=1 \
 //x=69.86 //y=6.92 //x2=69.86 //y2=6.92
r183 (  24 25 ) resistor r=0.0940266 //w=0.226 //l=0.17 //layer=m1 \
 //thickness=0.36 //x=69.857 //y=6.92 //x2=69.857 //y2=7.09
r184 (  22 49 ) resistor r=9.3 //w=0.17 //l=0.17 //layer=mcon //count=1 \
 //x=68.98 //y=5.39 //x2=68.98 //y2=5.39
r185 (  19 73 ) resistor r=9.3 //w=0.17 //l=0.17 //layer=mcon //count=1 \
 //x=68.98 //y=6.92 //x2=68.98 //y2=6.92
r186 (  19 20 ) resistor r=0.0979263 //w=0.217 //l=0.17 //layer=m1 \
 //thickness=0.36 //x=68.982 //y=6.92 //x2=68.982 //y2=7.09
r187 (  15 40 ) resistor r=9.3 //w=0.17 //l=0.17 //layer=mcon //count=1 \
 //x=66.98 //y=5.39 //x2=66.98 //y2=5.39
r188 (  11 30 ) resistor r=9.3 //w=0.17 //l=0.17 //layer=mcon //count=1 \
 //x=66.1 //y=5.56 //x2=66.1 //y2=5.56
r189 (  9 11 ) resistor r=0.0944444 //w=0.225 //l=0.17 //layer=m1 \
 //thickness=0.36 //x=66.102 //y=5.39 //x2=66.102 //y2=5.56
r190 (  8 25 ) resistor r=0.0246599 //w=0.226 //l=0.118 //layer=m1 \
 //thickness=0.36 //x=69.975 //y=7.09 //x2=69.857 //y2=7.09
r191 (  7 28 ) resistor r=0.0216707 //w=0.215 //l=0.117 //layer=m1 \
 //thickness=0.36 //x=70.625 //y=7.09 //x2=70.742 //y2=7.09
r192 (  7 8 ) resistor r=0.620229 //w=0.131 //l=0.65 //layer=m1 \
 //thickness=0.36 //x=70.625 //y=7.09 //x2=69.975 //y2=7.09
r193 (  6 20 ) resistor r=0.0222262 //w=0.217 //l=0.118 //layer=m1 \
 //thickness=0.36 //x=69.1 //y=7.09 //x2=68.982 //y2=7.09
r194 (  5 25 ) resistor r=0.0246599 //w=0.226 //l=0.117 //layer=m1 \
 //thickness=0.36 //x=69.74 //y=7.09 //x2=69.857 //y2=7.09
r195 (  5 6 ) resistor r=0.610687 //w=0.131 //l=0.64 //layer=m1 \
 //thickness=0.36 //x=69.74 //y=7.09 //x2=69.1 //y2=7.09
r196 (  4 15 ) resistor r=0.0880901 //w=0.191 //l=0.115 //layer=m1 \
 //thickness=0.36 //x=67.095 //y=5.39 //x2=66.98 //y2=5.39
r197 (  3 22 ) resistor r=0.0717383 //w=0.224 //l=0.115 //layer=m1 \
 //thickness=0.36 //x=68.865 //y=5.39 //x2=68.98 //y2=5.39
r198 (  3 4 ) resistor r=1.68893 //w=0.131 //l=1.77 //layer=m1 \
 //thickness=0.36 //x=68.865 //y=5.39 //x2=67.095 //y2=5.39
r199 (  2 9 ) resistor r=0.0243946 //w=0.225 //l=0.123 //layer=m1 \
 //thickness=0.36 //x=66.225 //y=5.39 //x2=66.102 //y2=5.39
r200 (  1 15 ) resistor r=0.0880901 //w=0.191 //l=0.115 //layer=m1 \
 //thickness=0.36 //x=66.865 //y=5.39 //x2=66.98 //y2=5.39
r201 (  1 2 ) resistor r=0.610687 //w=0.131 //l=0.64 //layer=m1 \
 //thickness=0.36 //x=66.865 //y=5.39 //x2=66.225 //y2=5.39
ends PM_TMRDFFQX1\%noxref_27

subckt PM_TMRDFFQX1\%noxref_28 ( 1 3 4 5 7 9 13 15 21 23 26 38 60 61 62 63 )
c133 ( 63 0 ) capacitor c=0.0343252f //x=73.935 //y=5.205
c134 ( 62 0 ) capacitor c=0.0239063f //x=73.055 //y=5.205
c135 ( 38 0 ) capacitor c=0.0496553f //x=72.32 //y=5.39
c136 ( 26 0 ) capacitor c=0.0229521f //x=69.42 //y=5.56
c137 ( 23 0 ) capacitor c=0.0155899f //x=74.08 //y=6.92
c138 ( 21 0 ) capacitor c=0.00566376f //x=73.2 //y=7.09
c139 ( 15 0 ) capacitor c=0.00945187f //x=72.32 //y=6.92
c140 ( 13 0 ) capacitor c=0.0163615f //x=70.3 //y=5.39
c141 ( 9 0 ) capacitor c=0.0153365f //x=69.42 //y=5.39
c142 ( 7 0 ) capacitor c=0.0068287f //x=73.95 //y=7.09
c143 ( 5 0 ) capacitor c=0.00878908f //x=73.085 //y=7.09
c144 ( 4 0 ) capacitor c=0.00826388f //x=70.415 //y=5.39
c145 ( 3 0 ) capacitor c=0.0560955f //x=72.205 //y=5.39
c146 ( 1 0 ) capacitor c=0.0183136f //x=70.185 //y=5.39
r147 (  38 61 ) resistor r=58.1818 //w=0.187 //l=0.85 //layer=li \
 //thickness=0.1 //x=72.32 //y=5.39 //x2=72.32 //y2=6.24
r148 (  26 60 ) resistor r=23.2727 //w=0.187 //l=0.34 //layer=li \
 //thickness=0.1 //x=69.42 //y=5.56 //x2=69.42 //y2=5.9
r149 (  23 63 ) resistor r=9.3 //w=0.17 //l=0.17 //layer=mcon //count=1 \
 //x=74.08 //y=6.92 //x2=74.08 //y2=6.92
r150 (  23 24 ) resistor r=0.0923913 //w=0.23 //l=0.17 //layer=m1 \
 //thickness=0.36 //x=74.075 //y=6.92 //x2=74.075 //y2=7.09
r151 (  20 62 ) resistor r=9.3 //w=0.17 //l=0.17 //layer=mcon //count=1 \
 //x=73.2 //y=6.92 //x2=73.2 //y2=6.92
r152 (  20 21 ) resistor r=0.0957207 //w=0.222 //l=0.17 //layer=m1 \
 //thickness=0.36 //x=73.2 //y=6.92 //x2=73.2 //y2=7.09
r153 (  18 38 ) resistor r=9.3 //w=0.17 //l=0.17 //layer=mcon //count=1 \
 //x=72.32 //y=5.39 //x2=72.32 //y2=5.39
r154 (  15 61 ) resistor r=9.3 //w=0.17 //l=0.17 //layer=mcon //count=1 \
 //x=72.32 //y=6.92 //x2=72.32 //y2=6.92
r155 (  15 16 ) resistor r=0.100236 //w=0.212 //l=0.17 //layer=m1 \
 //thickness=0.36 //x=72.32 //y=6.92 //x2=72.32 //y2=7.09
r156 (  11 26 ) resistor r=9.3 //w=0.17 //l=0.17 //layer=mcon //count=1 \
 //x=69.42 //y=5.56 //x2=69.42 //y2=5.56
r157 (  9 11 ) resistor r=0.100236 //w=0.212 //l=0.17 //layer=m1 \
 //thickness=0.36 //x=69.42 //y=5.39 //x2=69.42 //y2=5.56
r158 (  8 21 ) resistor r=0.0235912 //w=0.222 //l=0.115 //layer=m1 \
 //thickness=0.36 //x=73.315 //y=7.09 //x2=73.2 //y2=7.09
r159 (  7 24 ) resistor r=0.0257089 //w=0.23 //l=0.125 //layer=m1 \
 //thickness=0.36 //x=73.95 //y=7.09 //x2=74.075 //y2=7.09
r160 (  7 8 ) resistor r=0.605916 //w=0.131 //l=0.635 //layer=m1 \
 //thickness=0.36 //x=73.95 //y=7.09 //x2=73.315 //y2=7.09
r161 (  6 16 ) resistor r=0.0208269 //w=0.212 //l=0.115 //layer=m1 \
 //thickness=0.36 //x=72.435 //y=7.09 //x2=72.32 //y2=7.09
r162 (  5 21 ) resistor r=0.0235912 //w=0.222 //l=0.115 //layer=m1 \
 //thickness=0.36 //x=73.085 //y=7.09 //x2=73.2 //y2=7.09
r163 (  5 6 ) resistor r=0.620229 //w=0.131 //l=0.65 //layer=m1 \
 //thickness=0.36 //x=73.085 //y=7.09 //x2=72.435 //y2=7.09
r164 (  4 13 ) resistor r=0.0880901 //w=0.191 //l=0.115 //layer=m1 \
 //thickness=0.36 //x=70.415 //y=5.39 //x2=70.3 //y2=5.39
r165 (  3 18 ) resistor r=0.0717383 //w=0.224 //l=0.115 //layer=m1 \
 //thickness=0.36 //x=72.205 //y=5.39 //x2=72.32 //y2=5.39
r166 (  3 4 ) resistor r=1.70802 //w=0.131 //l=1.79 //layer=m1 \
 //thickness=0.36 //x=72.205 //y=5.39 //x2=70.415 //y2=5.39
r167 (  2 9 ) resistor r=0.0208269 //w=0.212 //l=0.115 //layer=m1 \
 //thickness=0.36 //x=69.535 //y=5.39 //x2=69.42 //y2=5.39
r168 (  1 13 ) resistor r=0.0880901 //w=0.191 //l=0.115 //layer=m1 \
 //thickness=0.36 //x=70.185 //y=5.39 //x2=70.3 //y2=5.39
r169 (  1 2 ) resistor r=0.620229 //w=0.131 //l=0.65 //layer=m1 \
 //thickness=0.36 //x=70.185 //y=5.39 //x2=69.535 //y2=5.39
ends PM_TMRDFFQX1\%noxref_28

subckt PM_TMRDFFQX1\%GND ( 1 2 6 7 19 27 35 45 53 60 61 73 83 91 99 110 117 \
 118 128 136 146 154 162 171 172 179 180 187 196 199 203 204 208 209 214 215 \
 219 220 224 225 230 234 235 239 240 244 245 250 251 255 256 260 265 266 271 \
 272 276 277 281 282 287 288 303 306 320 335 348 363 378 391 408 423 438 451 \
 466 481 498 511 526 541 554 569 584 597 615 620 624 636 637 638 639 640 641 \
 642 643 644 645 646 647 648 649 650 651 652 653 654 655 656 663 670 671 672 \
 673 674 675 676 677 678 679 680 681 682 683 684 685 686 687 688 689 690 691 )
c1584 ( 691 0 ) capacitor c=0.0654471f //x=75.355 //y=0.55
c1585 ( 690 0 ) capacitor c=0.00828027f //x=72.52 //y=1.045
c1586 ( 689 0 ) capacitor c=0.00867576f //x=69.19 //y=1.045
c1587 ( 688 0 ) capacitor c=0.0083251f //x=65.86 //y=1.045
c1588 ( 687 0 ) capacitor c=0.00843555f //x=62.53 //y=1.045
c1589 ( 686 0 ) capacitor c=0.00843555f //x=59.2 //y=1.045
c1590 ( 685 0 ) capacitor c=0.00843555f //x=55.87 //y=1.045
c1591 ( 684 0 ) capacitor c=0.00843555f //x=52.54 //y=1.045
c1592 ( 683 0 ) capacitor c=0.00843555f //x=49.21 //y=1.045
c1593 ( 682 0 ) capacitor c=0.00840423f //x=44.295 //y=1.055
c1594 ( 681 0 ) capacitor c=0.00843555f //x=41.07 //y=1.045
c1595 ( 680 0 ) capacitor c=0.00843555f //x=37.74 //y=1.045
c1596 ( 679 0 ) capacitor c=0.00843555f //x=34.41 //y=1.045
c1597 ( 678 0 ) capacitor c=0.00843555f //x=31.08 //y=1.045
c1598 ( 677 0 ) capacitor c=0.00843555f //x=27.75 //y=1.045
c1599 ( 676 0 ) capacitor c=0.00840423f //x=22.835 //y=1.055
c1600 ( 675 0 ) capacitor c=0.00843555f //x=19.61 //y=1.045
c1601 ( 674 0 ) capacitor c=0.00843555f //x=16.28 //y=1.045
c1602 ( 673 0 ) capacitor c=0.00843555f //x=12.95 //y=1.045
c1603 ( 672 0 ) capacitor c=0.00843555f //x=9.62 //y=1.045
c1604 ( 671 0 ) capacitor c=0.00843555f //x=6.29 //y=1.045
c1605 ( 670 0 ) capacitor c=0.00840423f //x=1.375 //y=1.055
c1606 ( 663 0 ) capacitor c=0.259948f //x=76.46 //y=0.175
c1607 ( 656 0 ) capacitor c=0.11347f //x=74.86 //y=0.175
c1608 ( 655 0 ) capacitor c=0.110242f //x=71.53 //y=0.175
c1609 ( 654 0 ) capacitor c=0.123597f //x=68.2 //y=0.175
c1610 ( 653 0 ) capacitor c=0.114864f //x=64.87 //y=0.175
c1611 ( 652 0 ) capacitor c=0.117679f //x=61.54 //y=0.175
c1612 ( 651 0 ) capacitor c=0.117679f //x=58.21 //y=0.175
c1613 ( 650 0 ) capacitor c=0.117679f //x=54.88 //y=0.175
c1614 ( 649 0 ) capacitor c=0.116385f //x=51.55 //y=0.175
c1615 ( 648 0 ) capacitor c=0.117187f //x=48.22 //y=0.175
c1616 ( 647 0 ) capacitor c=0.109921f //x=43.41 //y=0.175
c1617 ( 646 0 ) capacitor c=0.116305f //x=40.08 //y=0.175
c1618 ( 645 0 ) capacitor c=0.116325f //x=36.75 //y=0.175
c1619 ( 644 0 ) capacitor c=0.116325f //x=33.42 //y=0.175
c1620 ( 643 0 ) capacitor c=0.115127f //x=30.09 //y=0.175
c1621 ( 642 0 ) capacitor c=0.116893f //x=26.76 //y=0.175
c1622 ( 641 0 ) capacitor c=0.112091f //x=21.95 //y=0.175
c1623 ( 640 0 ) capacitor c=0.116325f //x=18.62 //y=0.175
c1624 ( 639 0 ) capacitor c=0.116718f //x=15.29 //y=0.175
c1625 ( 638 0 ) capacitor c=0.116479f //x=11.96 //y=0.175
c1626 ( 637 0 ) capacitor c=0.115281f //x=8.63 //y=0.175
c1627 ( 636 0 ) capacitor c=0.117311f //x=5.3 //y=0.175
c1628 ( 627 0 ) capacitor c=0.00585268f //x=76.46 //y=0.63
c1629 ( 624 0 ) capacitor c=0.00625302f //x=76.375 //y=0.715
c1630 ( 623 0 ) capacitor c=0.00479851f //x=75.97 //y=0.63
c1631 ( 620 0 ) capacitor c=0.00645299f //x=75.885 //y=0.715
c1632 ( 615 0 ) capacitor c=0.00586769f //x=75.49 //y=0.63
c1633 ( 612 0 ) capacitor c=0.0191899f //x=75.405 //y=0.175
c1634 ( 597 0 ) capacitor c=0.122563f //x=74.69 //y=0.175
c1635 ( 584 0 ) capacitor c=0.118812f //x=71.36 //y=0.175
c1636 ( 569 0 ) capacitor c=0.119085f //x=68.03 //y=0.175
c1637 ( 554 0 ) capacitor c=0.118923f //x=64.7 //y=0.175
c1638 ( 541 0 ) capacitor c=0.118923f //x=61.37 //y=0.175
c1639 ( 526 0 ) capacitor c=0.118923f //x=58.04 //y=0.175
c1640 ( 511 0 ) capacitor c=0.118923f //x=54.71 //y=0.175
c1641 ( 498 0 ) capacitor c=0.119029f //x=51.38 //y=0.175
c1642 ( 481 0 ) capacitor c=0.176412f //x=48.05 //y=0.175
c1643 ( 466 0 ) capacitor c=0.118995f //x=43.24 //y=0.175
c1644 ( 451 0 ) capacitor c=0.118939f //x=39.91 //y=0.175
c1645 ( 438 0 ) capacitor c=0.11895f //x=36.58 //y=0.175
c1646 ( 423 0 ) capacitor c=0.11895f //x=33.25 //y=0.175
c1647 ( 408 0 ) capacitor c=0.119064f //x=29.92 //y=0.175
c1648 ( 391 0 ) capacitor c=0.176537f //x=26.59 //y=0.175
c1649 ( 378 0 ) capacitor c=0.11895f //x=21.78 //y=0.175
c1650 ( 363 0 ) capacitor c=0.11895f //x=18.45 //y=0.175
c1651 ( 348 0 ) capacitor c=0.11895f //x=15.12 //y=0.175
c1652 ( 335 0 ) capacitor c=0.11895f //x=11.79 //y=0.175
c1653 ( 320 0 ) capacitor c=0.123047f //x=8.46 //y=0.175
c1654 ( 306 0 ) capacitor c=0.197064f //x=1.23 //y=0.18
c1655 ( 303 0 ) capacitor c=0.181445f //x=5.13 //y=0.175
c1656 ( 298 0 ) capacitor c=0.00509083f //x=72.71 //y=0.175
c1657 ( 295 0 ) capacitor c=0.00510068f //x=69.31 //y=0.18
c1658 ( 291 0 ) capacitor c=0.00509083f //x=66.05 //y=0.175
c1659 ( 290 0 ) capacitor c=0.00509083f //x=62.72 //y=0.175
c1660 ( 288 0 ) capacitor c=0.0188922f //x=62.717 //y=1.005
c1661 ( 287 0 ) capacitor c=0.0124054f //x=62.72 //y=1.135
c1662 ( 285 0 ) capacitor c=0.00509083f //x=59.32 //y=0.18
c1663 ( 282 0 ) capacitor c=0.0188922f //x=59.387 //y=1.005
c1664 ( 281 0 ) capacitor c=0.0124377f //x=59.39 //y=1.135
c1665 ( 279 0 ) capacitor c=0.00509083f //x=56.06 //y=0.175
c1666 ( 277 0 ) capacitor c=0.0188922f //x=56.057 //y=1.005
c1667 ( 276 0 ) capacitor c=0.0124753f //x=56.06 //y=1.135
c1668 ( 274 0 ) capacitor c=0.00509083f //x=52.73 //y=0.175
c1669 ( 272 0 ) capacitor c=0.0188922f //x=52.727 //y=1.005
c1670 ( 271 0 ) capacitor c=0.0124757f //x=52.73 //y=1.135
c1671 ( 269 0 ) capacitor c=0.00509083f //x=49.33 //y=0.18
c1672 ( 266 0 ) capacitor c=0.0235363f //x=49.397 //y=1.005
c1673 ( 265 0 ) capacitor c=0.0135231f //x=49.4 //y=1.135
c1674 ( 263 0 ) capacitor c=0.00509414f //x=44.52 //y=0.18
c1675 ( 260 0 ) capacitor c=0.0131977f //x=44.485 //y=1.145
c1676 ( 258 0 ) capacitor c=0.00509083f //x=41.26 //y=0.175
c1677 ( 256 0 ) capacitor c=0.0187613f //x=41.257 //y=1.005
c1678 ( 255 0 ) capacitor c=0.0124543f //x=41.26 //y=1.135
c1679 ( 253 0 ) capacitor c=0.00509083f //x=37.93 //y=0.175
c1680 ( 251 0 ) capacitor c=0.0188922f //x=37.927 //y=1.005
c1681 ( 250 0 ) capacitor c=0.0124697f //x=37.93 //y=1.135
c1682 ( 248 0 ) capacitor c=0.00509083f //x=34.53 //y=0.18
c1683 ( 245 0 ) capacitor c=0.0188922f //x=34.597 //y=1.005
c1684 ( 244 0 ) capacitor c=0.0125083f //x=34.6 //y=1.135
c1685 ( 242 0 ) capacitor c=0.00509083f //x=31.27 //y=0.175
c1686 ( 240 0 ) capacitor c=0.0188922f //x=31.267 //y=1.005
c1687 ( 239 0 ) capacitor c=0.0125087f //x=31.27 //y=1.135
c1688 ( 237 0 ) capacitor c=0.00509083f //x=27.94 //y=0.175
c1689 ( 235 0 ) capacitor c=0.0235363f //x=27.937 //y=1.005
c1690 ( 234 0 ) capacitor c=0.0135538f //x=27.94 //y=1.135
c1691 ( 232 0 ) capacitor c=0.00509414f //x=23.025 //y=0.175
c1692 ( 230 0 ) capacitor c=0.0132217f //x=23.025 //y=1.145
c1693 ( 228 0 ) capacitor c=0.00509083f //x=19.73 //y=0.18
c1694 ( 225 0 ) capacitor c=0.0187613f //x=19.797 //y=1.005
c1695 ( 224 0 ) capacitor c=0.0124851f //x=19.8 //y=1.135
c1696 ( 222 0 ) capacitor c=0.00509083f //x=16.47 //y=0.175
c1697 ( 220 0 ) capacitor c=0.0188922f //x=16.467 //y=1.005
c1698 ( 219 0 ) capacitor c=0.0124697f //x=16.47 //y=1.135
c1699 ( 217 0 ) capacitor c=0.00509083f //x=13.14 //y=0.175
c1700 ( 215 0 ) capacitor c=0.0188922f //x=13.137 //y=1.005
c1701 ( 214 0 ) capacitor c=0.0125083f //x=13.14 //y=1.135
c1702 ( 212 0 ) capacitor c=0.00509083f //x=9.74 //y=0.18
c1703 ( 209 0 ) capacitor c=0.0188922f //x=9.807 //y=1.005
c1704 ( 208 0 ) capacitor c=0.0125087f //x=9.81 //y=1.135
c1705 ( 206 0 ) capacitor c=0.00509083f //x=6.48 //y=0.175
c1706 ( 204 0 ) capacitor c=0.0235363f //x=6.477 //y=1.005
c1707 ( 203 0 ) capacitor c=0.013606f //x=6.48 //y=1.135
c1708 ( 201 0 ) capacitor c=0.00509414f //x=1.565 //y=0.175
c1709 ( 199 0 ) capacitor c=0.017081f //x=1.565 //y=1.145
c1710 ( 196 0 ) capacitor c=0.179237f //x=76.34 //y=0.18
c1711 ( 187 0 ) capacitor c=0.0350921f //x=72.71 //y=1.02
c1712 ( 180 0 ) capacitor c=0.10747f //x=72.625 //y=0.175
c1713 ( 179 0 ) capacitor c=0.0275448f //x=69.38 //y=1.015
c1714 ( 172 0 ) capacitor c=0.112314f //x=69.295 //y=0.175
c1715 ( 171 0 ) capacitor c=0.029369f //x=66.05 //y=1.015
c1716 ( 162 0 ) capacitor c=0.108946f //x=65.965 //y=0.175
c1717 ( 154 0 ) capacitor c=0.111091f //x=62.635 //y=0.175
c1718 ( 146 0 ) capacitor c=0.112269f //x=59.305 //y=0.175
c1719 ( 136 0 ) capacitor c=0.111001f //x=55.975 //y=0.175
c1720 ( 128 0 ) capacitor c=0.112145f //x=52.645 //y=0.175
c1721 ( 118 0 ) capacitor c=0.15471f //x=49.315 //y=0.175
c1722 ( 117 0 ) capacitor c=0.0253397f //x=44.485 //y=1.015
c1723 ( 110 0 ) capacitor c=0.106819f //x=44.4 //y=0.175
c1724 ( 99 0 ) capacitor c=0.110829f //x=41.175 //y=0.175
c1725 ( 91 0 ) capacitor c=0.112282f //x=37.845 //y=0.175
c1726 ( 83 0 ) capacitor c=0.111017f //x=34.515 //y=0.175
c1727 ( 73 0 ) capacitor c=0.112159f //x=31.185 //y=0.175
c1728 ( 61 0 ) capacitor c=0.154725f //x=27.855 //y=0.175
c1729 ( 60 0 ) capacitor c=0.0253397f //x=23.025 //y=1.015
c1730 ( 53 0 ) capacitor c=0.105402f //x=22.94 //y=0.175
c1731 ( 45 0 ) capacitor c=0.111028f //x=19.715 //y=0.175
c1732 ( 35 0 ) capacitor c=0.112282f //x=16.385 //y=0.175
c1733 ( 27 0 ) capacitor c=0.111017f //x=13.055 //y=0.175
c1734 ( 19 0 ) capacitor c=0.112159f //x=9.725 //y=0.175
c1735 ( 7 0 ) capacitor c=0.154867f //x=6.395 //y=0.175
c1736 ( 6 0 ) capacitor c=0.0302305f //x=1.565 //y=1.015
c1737 ( 2 0 ) capacitor c=0.0710427f //x=1.48 //y=0.175
r1738 (  662 663 ) resistor r=4.18529 //w=0.367 //l=0.12 //layer=li \
 //thickness=0.1 //x=76.34 //y=0.175 //x2=76.46 //y2=0.175
r1739 (  660 662 ) resistor r=12.9046 //w=0.367 //l=0.37 //layer=li \
 //thickness=0.1 //x=75.97 //y=0.175 //x2=76.34 //y2=0.175
r1740 (  659 660 ) resistor r=12.9046 //w=0.367 //l=0.37 //layer=li \
 //thickness=0.1 //x=75.6 //y=0.175 //x2=75.97 //y2=0.175
r1741 (  657 659 ) resistor r=3.83651 //w=0.367 //l=0.11 //layer=li \
 //thickness=0.1 //x=75.49 //y=0.175 //x2=75.6 //y2=0.175
r1742 (  628 691 ) resistor r=5.4201 //w=0.17 //l=0.085 //layer=li \
 //thickness=0.1 //x=76.46 //y=0.8 //x2=76.46 //y2=0.715
r1743 (  628 691 ) resistor r=41.4118 //w=0.187 //l=0.605 //layer=li \
 //thickness=0.1 //x=76.46 //y=0.8 //x2=76.46 //y2=1.405
r1744 (  627 691 ) resistor r=5.4201 //w=0.17 //l=0.085 //layer=li \
 //thickness=0.1 //x=76.46 //y=0.63 //x2=76.46 //y2=0.715
r1745 (  626 663 ) resistor r=5.21862 //w=0.35 //l=0.175 //layer=li \
 //thickness=0.1 //x=76.46 //y=0.35 //x2=76.46 //y2=0.175
r1746 (  626 627 ) resistor r=19.1658 //w=0.187 //l=0.28 //layer=li \
 //thickness=0.1 //x=76.46 //y=0.35 //x2=76.46 //y2=0.63
r1747 (  625 691 ) resistor r=5.4201 //w=0.17 //l=0.085 //layer=li \
 //thickness=0.1 //x=76.055 //y=0.715 //x2=75.97 //y2=0.715
r1748 (  624 691 ) resistor r=1.40859 //w=0.34 //l=0.085 //layer=li \
 //thickness=0.1 //x=76.375 //y=0.715 //x2=76.46 //y2=0.715
r1749 (  624 625 ) resistor r=21.9037 //w=0.187 //l=0.32 //layer=li \
 //thickness=0.1 //x=76.375 //y=0.715 //x2=76.055 //y2=0.715
r1750 (  623 691 ) resistor r=1.40859 //w=0.34 //l=0.085 //layer=li \
 //thickness=0.1 //x=75.97 //y=0.63 //x2=75.97 //y2=0.715
r1751 (  622 660 ) resistor r=5.21862 //w=0.35 //l=0.175 //layer=li \
 //thickness=0.1 //x=75.97 //y=0.35 //x2=75.97 //y2=0.175
r1752 (  622 623 ) resistor r=19.1658 //w=0.187 //l=0.28 //layer=li \
 //thickness=0.1 //x=75.97 //y=0.35 //x2=75.97 //y2=0.63
r1753 (  621 691 ) resistor r=1.40859 //w=0.34 //l=0.085 //layer=li \
 //thickness=0.1 //x=75.575 //y=0.715 //x2=75.49 //y2=0.715
r1754 (  620 691 ) resistor r=5.4201 //w=0.17 //l=0.085 //layer=li \
 //thickness=0.1 //x=75.885 //y=0.715 //x2=75.97 //y2=0.715
r1755 (  620 621 ) resistor r=21.2193 //w=0.187 //l=0.31 //layer=li \
 //thickness=0.1 //x=75.885 //y=0.715 //x2=75.575 //y2=0.715
r1756 (  616 691 ) resistor r=5.4201 //w=0.17 //l=0.085 //layer=li \
 //thickness=0.1 //x=75.49 //y=0.8 //x2=75.49 //y2=0.715
r1757 (  616 691 ) resistor r=41.4118 //w=0.187 //l=0.605 //layer=li \
 //thickness=0.1 //x=75.49 //y=0.8 //x2=75.49 //y2=1.405
r1758 (  615 691 ) resistor r=5.4201 //w=0.17 //l=0.085 //layer=li \
 //thickness=0.1 //x=75.49 //y=0.63 //x2=75.49 //y2=0.715
r1759 (  614 657 ) resistor r=5.21862 //w=0.35 //l=0.175 //layer=li \
 //thickness=0.1 //x=75.49 //y=0.35 //x2=75.49 //y2=0.175
r1760 (  614 615 ) resistor r=19.1658 //w=0.187 //l=0.28 //layer=li \
 //thickness=0.1 //x=75.49 //y=0.35 //x2=75.49 //y2=0.63
r1761 (  613 656 ) resistor r=5.29055 //w=0.35 //l=0.17 //layer=li \
 //thickness=0.1 //x=75.03 //y=0.175 //x2=74.86 //y2=0.175
r1762 (  612 657 ) resistor r=2.96458 //w=0.367 //l=0.085 //layer=li \
 //thickness=0.1 //x=75.405 //y=0.175 //x2=75.49 //y2=0.175
r1763 (  612 613 ) resistor r=13.079 //w=0.367 //l=0.375 //layer=li \
 //thickness=0.1 //x=75.405 //y=0.175 //x2=75.03 //y2=0.175
r1764 (  602 604 ) resistor r=38.7139 //w=0.367 //l=1.11 //layer=li \
 //thickness=0.1 //x=73.01 //y=0.175 //x2=74.12 //y2=0.175
r1765 (  600 602 ) resistor r=38.7139 //w=0.367 //l=1.11 //layer=li \
 //thickness=0.1 //x=71.9 //y=0.175 //x2=73.01 //y2=0.175
r1766 (  598 655 ) resistor r=5.29055 //w=0.35 //l=0.17 //layer=li \
 //thickness=0.1 //x=71.7 //y=0.175 //x2=71.53 //y2=0.175
r1767 (  598 600 ) resistor r=6.97548 //w=0.367 //l=0.2 //layer=li \
 //thickness=0.1 //x=71.7 //y=0.175 //x2=71.9 //y2=0.175
r1768 (  597 656 ) resistor r=5.29055 //w=0.35 //l=0.17 //layer=li \
 //thickness=0.1 //x=74.69 //y=0.175 //x2=74.86 //y2=0.175
r1769 (  597 604 ) resistor r=19.8801 //w=0.367 //l=0.57 //layer=li \
 //thickness=0.1 //x=74.69 //y=0.175 //x2=74.12 //y2=0.175
r1770 (  587 589 ) resistor r=38.7139 //w=0.367 //l=1.11 //layer=li \
 //thickness=0.1 //x=69.31 //y=0.175 //x2=70.42 //y2=0.175
r1771 (  585 654 ) resistor r=5.29055 //w=0.35 //l=0.17 //layer=li \
 //thickness=0.1 //x=68.37 //y=0.175 //x2=68.2 //y2=0.175
r1772 (  585 587 ) resistor r=32.7847 //w=0.367 //l=0.94 //layer=li \
 //thickness=0.1 //x=68.37 //y=0.175 //x2=69.31 //y2=0.175
r1773 (  584 655 ) resistor r=5.29055 //w=0.35 //l=0.17 //layer=li \
 //thickness=0.1 //x=71.36 //y=0.175 //x2=71.53 //y2=0.175
r1774 (  584 589 ) resistor r=32.7847 //w=0.367 //l=0.94 //layer=li \
 //thickness=0.1 //x=71.36 //y=0.175 //x2=70.42 //y2=0.175
r1775 (  574 576 ) resistor r=38.7139 //w=0.367 //l=1.11 //layer=li \
 //thickness=0.1 //x=66.72 //y=0.175 //x2=67.83 //y2=0.175
r1776 (  572 574 ) resistor r=38.7139 //w=0.367 //l=1.11 //layer=li \
 //thickness=0.1 //x=65.61 //y=0.175 //x2=66.72 //y2=0.175
r1777 (  570 653 ) resistor r=5.29055 //w=0.35 //l=0.17 //layer=li \
 //thickness=0.1 //x=65.04 //y=0.175 //x2=64.87 //y2=0.175
r1778 (  570 572 ) resistor r=19.8801 //w=0.367 //l=0.57 //layer=li \
 //thickness=0.1 //x=65.04 //y=0.175 //x2=65.61 //y2=0.175
r1779 (  569 654 ) resistor r=5.29055 //w=0.35 //l=0.17 //layer=li \
 //thickness=0.1 //x=68.03 //y=0.175 //x2=68.2 //y2=0.175
r1780 (  569 576 ) resistor r=6.97548 //w=0.367 //l=0.2 //layer=li \
 //thickness=0.1 //x=68.03 //y=0.175 //x2=67.83 //y2=0.175
r1781 (  559 561 ) resistor r=38.7139 //w=0.367 //l=1.11 //layer=li \
 //thickness=0.1 //x=63.02 //y=0.175 //x2=64.13 //y2=0.175
r1782 (  557 559 ) resistor r=38.7139 //w=0.367 //l=1.11 //layer=li \
 //thickness=0.1 //x=61.91 //y=0.175 //x2=63.02 //y2=0.175
r1783 (  555 652 ) resistor r=5.29055 //w=0.35 //l=0.17 //layer=li \
 //thickness=0.1 //x=61.71 //y=0.175 //x2=61.54 //y2=0.175
r1784 (  555 557 ) resistor r=6.97548 //w=0.367 //l=0.2 //layer=li \
 //thickness=0.1 //x=61.71 //y=0.175 //x2=61.91 //y2=0.175
r1785 (  554 653 ) resistor r=5.29055 //w=0.35 //l=0.17 //layer=li \
 //thickness=0.1 //x=64.7 //y=0.175 //x2=64.87 //y2=0.175
r1786 (  554 561 ) resistor r=19.8801 //w=0.367 //l=0.57 //layer=li \
 //thickness=0.1 //x=64.7 //y=0.175 //x2=64.13 //y2=0.175
r1787 (  544 546 ) resistor r=38.7139 //w=0.367 //l=1.11 //layer=li \
 //thickness=0.1 //x=59.32 //y=0.175 //x2=60.43 //y2=0.175
r1788 (  542 651 ) resistor r=5.29055 //w=0.35 //l=0.17 //layer=li \
 //thickness=0.1 //x=58.38 //y=0.175 //x2=58.21 //y2=0.175
r1789 (  542 544 ) resistor r=32.7847 //w=0.367 //l=0.94 //layer=li \
 //thickness=0.1 //x=58.38 //y=0.175 //x2=59.32 //y2=0.175
r1790 (  541 652 ) resistor r=5.29055 //w=0.35 //l=0.17 //layer=li \
 //thickness=0.1 //x=61.37 //y=0.175 //x2=61.54 //y2=0.175
r1791 (  541 546 ) resistor r=32.7847 //w=0.367 //l=0.94 //layer=li \
 //thickness=0.1 //x=61.37 //y=0.175 //x2=60.43 //y2=0.175
r1792 (  531 533 ) resistor r=38.7139 //w=0.367 //l=1.11 //layer=li \
 //thickness=0.1 //x=56.73 //y=0.175 //x2=57.84 //y2=0.175
r1793 (  529 531 ) resistor r=38.7139 //w=0.367 //l=1.11 //layer=li \
 //thickness=0.1 //x=55.62 //y=0.175 //x2=56.73 //y2=0.175
r1794 (  527 650 ) resistor r=5.29055 //w=0.35 //l=0.17 //layer=li \
 //thickness=0.1 //x=55.05 //y=0.175 //x2=54.88 //y2=0.175
r1795 (  527 529 ) resistor r=19.8801 //w=0.367 //l=0.57 //layer=li \
 //thickness=0.1 //x=55.05 //y=0.175 //x2=55.62 //y2=0.175
r1796 (  526 651 ) resistor r=5.29055 //w=0.35 //l=0.17 //layer=li \
 //thickness=0.1 //x=58.04 //y=0.175 //x2=58.21 //y2=0.175
r1797 (  526 533 ) resistor r=6.97548 //w=0.367 //l=0.2 //layer=li \
 //thickness=0.1 //x=58.04 //y=0.175 //x2=57.84 //y2=0.175
r1798 (  516 518 ) resistor r=38.7139 //w=0.367 //l=1.11 //layer=li \
 //thickness=0.1 //x=53.03 //y=0.175 //x2=54.14 //y2=0.175
r1799 (  514 516 ) resistor r=38.7139 //w=0.367 //l=1.11 //layer=li \
 //thickness=0.1 //x=51.92 //y=0.175 //x2=53.03 //y2=0.175
r1800 (  512 649 ) resistor r=5.29055 //w=0.35 //l=0.17 //layer=li \
 //thickness=0.1 //x=51.72 //y=0.175 //x2=51.55 //y2=0.175
r1801 (  512 514 ) resistor r=6.97548 //w=0.367 //l=0.2 //layer=li \
 //thickness=0.1 //x=51.72 //y=0.175 //x2=51.92 //y2=0.175
r1802 (  511 650 ) resistor r=5.29055 //w=0.35 //l=0.17 //layer=li \
 //thickness=0.1 //x=54.71 //y=0.175 //x2=54.88 //y2=0.175
r1803 (  511 518 ) resistor r=19.8801 //w=0.367 //l=0.57 //layer=li \
 //thickness=0.1 //x=54.71 //y=0.175 //x2=54.14 //y2=0.175
r1804 (  501 503 ) resistor r=38.7139 //w=0.367 //l=1.11 //layer=li \
 //thickness=0.1 //x=49.33 //y=0.175 //x2=50.44 //y2=0.175
r1805 (  499 648 ) resistor r=5.29055 //w=0.35 //l=0.17 //layer=li \
 //thickness=0.1 //x=48.39 //y=0.175 //x2=48.22 //y2=0.175
r1806 (  499 501 ) resistor r=32.7847 //w=0.367 //l=0.94 //layer=li \
 //thickness=0.1 //x=48.39 //y=0.175 //x2=49.33 //y2=0.175
r1807 (  498 649 ) resistor r=5.29055 //w=0.35 //l=0.17 //layer=li \
 //thickness=0.1 //x=51.38 //y=0.175 //x2=51.55 //y2=0.175
r1808 (  498 503 ) resistor r=32.7847 //w=0.367 //l=0.94 //layer=li \
 //thickness=0.1 //x=51.38 //y=0.175 //x2=50.44 //y2=0.175
r1809 (  488 490 ) resistor r=38.7139 //w=0.367 //l=1.11 //layer=li \
 //thickness=0.1 //x=46.74 //y=0.175 //x2=47.85 //y2=0.175
r1810 (  486 488 ) resistor r=38.7139 //w=0.367 //l=1.11 //layer=li \
 //thickness=0.1 //x=45.63 //y=0.175 //x2=46.74 //y2=0.175
r1811 (  484 486 ) resistor r=38.7139 //w=0.367 //l=1.11 //layer=li \
 //thickness=0.1 //x=44.52 //y=0.175 //x2=45.63 //y2=0.175
r1812 (  482 647 ) resistor r=5.29055 //w=0.35 //l=0.17 //layer=li \
 //thickness=0.1 //x=43.58 //y=0.175 //x2=43.41 //y2=0.175
r1813 (  482 484 ) resistor r=32.7847 //w=0.367 //l=0.94 //layer=li \
 //thickness=0.1 //x=43.58 //y=0.175 //x2=44.52 //y2=0.175
r1814 (  481 648 ) resistor r=5.29055 //w=0.35 //l=0.17 //layer=li \
 //thickness=0.1 //x=48.05 //y=0.175 //x2=48.22 //y2=0.175
r1815 (  481 490 ) resistor r=6.97548 //w=0.367 //l=0.2 //layer=li \
 //thickness=0.1 //x=48.05 //y=0.175 //x2=47.85 //y2=0.175
r1816 (  471 473 ) resistor r=38.7139 //w=0.367 //l=1.11 //layer=li \
 //thickness=0.1 //x=41.93 //y=0.175 //x2=43.04 //y2=0.175
r1817 (  469 471 ) resistor r=38.7139 //w=0.367 //l=1.11 //layer=li \
 //thickness=0.1 //x=40.82 //y=0.175 //x2=41.93 //y2=0.175
r1818 (  467 646 ) resistor r=5.29055 //w=0.35 //l=0.17 //layer=li \
 //thickness=0.1 //x=40.25 //y=0.175 //x2=40.08 //y2=0.175
r1819 (  467 469 ) resistor r=19.8801 //w=0.367 //l=0.57 //layer=li \
 //thickness=0.1 //x=40.25 //y=0.175 //x2=40.82 //y2=0.175
r1820 (  466 647 ) resistor r=5.29055 //w=0.35 //l=0.17 //layer=li \
 //thickness=0.1 //x=43.24 //y=0.175 //x2=43.41 //y2=0.175
r1821 (  466 473 ) resistor r=6.97548 //w=0.367 //l=0.2 //layer=li \
 //thickness=0.1 //x=43.24 //y=0.175 //x2=43.04 //y2=0.175
r1822 (  456 458 ) resistor r=38.7139 //w=0.367 //l=1.11 //layer=li \
 //thickness=0.1 //x=38.23 //y=0.175 //x2=39.34 //y2=0.175
r1823 (  454 456 ) resistor r=38.7139 //w=0.367 //l=1.11 //layer=li \
 //thickness=0.1 //x=37.12 //y=0.175 //x2=38.23 //y2=0.175
r1824 (  452 645 ) resistor r=5.29055 //w=0.35 //l=0.17 //layer=li \
 //thickness=0.1 //x=36.92 //y=0.175 //x2=36.75 //y2=0.175
r1825 (  452 454 ) resistor r=6.97548 //w=0.367 //l=0.2 //layer=li \
 //thickness=0.1 //x=36.92 //y=0.175 //x2=37.12 //y2=0.175
r1826 (  451 646 ) resistor r=5.29055 //w=0.35 //l=0.17 //layer=li \
 //thickness=0.1 //x=39.91 //y=0.175 //x2=40.08 //y2=0.175
r1827 (  451 458 ) resistor r=19.8801 //w=0.367 //l=0.57 //layer=li \
 //thickness=0.1 //x=39.91 //y=0.175 //x2=39.34 //y2=0.175
r1828 (  441 443 ) resistor r=38.7139 //w=0.367 //l=1.11 //layer=li \
 //thickness=0.1 //x=34.53 //y=0.175 //x2=35.64 //y2=0.175
r1829 (  439 644 ) resistor r=5.29055 //w=0.35 //l=0.17 //layer=li \
 //thickness=0.1 //x=33.59 //y=0.175 //x2=33.42 //y2=0.175
r1830 (  439 441 ) resistor r=32.7847 //w=0.367 //l=0.94 //layer=li \
 //thickness=0.1 //x=33.59 //y=0.175 //x2=34.53 //y2=0.175
r1831 (  438 645 ) resistor r=5.29055 //w=0.35 //l=0.17 //layer=li \
 //thickness=0.1 //x=36.58 //y=0.175 //x2=36.75 //y2=0.175
r1832 (  438 443 ) resistor r=32.7847 //w=0.367 //l=0.94 //layer=li \
 //thickness=0.1 //x=36.58 //y=0.175 //x2=35.64 //y2=0.175
r1833 (  428 430 ) resistor r=38.7139 //w=0.367 //l=1.11 //layer=li \
 //thickness=0.1 //x=31.94 //y=0.175 //x2=33.05 //y2=0.175
r1834 (  426 428 ) resistor r=38.7139 //w=0.367 //l=1.11 //layer=li \
 //thickness=0.1 //x=30.83 //y=0.175 //x2=31.94 //y2=0.175
r1835 (  424 643 ) resistor r=5.29055 //w=0.35 //l=0.17 //layer=li \
 //thickness=0.1 //x=30.26 //y=0.175 //x2=30.09 //y2=0.175
r1836 (  424 426 ) resistor r=19.8801 //w=0.367 //l=0.57 //layer=li \
 //thickness=0.1 //x=30.26 //y=0.175 //x2=30.83 //y2=0.175
r1837 (  423 644 ) resistor r=5.29055 //w=0.35 //l=0.17 //layer=li \
 //thickness=0.1 //x=33.25 //y=0.175 //x2=33.42 //y2=0.175
r1838 (  423 430 ) resistor r=6.97548 //w=0.367 //l=0.2 //layer=li \
 //thickness=0.1 //x=33.25 //y=0.175 //x2=33.05 //y2=0.175
r1839 (  413 415 ) resistor r=38.7139 //w=0.367 //l=1.11 //layer=li \
 //thickness=0.1 //x=28.24 //y=0.175 //x2=29.35 //y2=0.175
r1840 (  411 413 ) resistor r=38.7139 //w=0.367 //l=1.11 //layer=li \
 //thickness=0.1 //x=27.13 //y=0.175 //x2=28.24 //y2=0.175
r1841 (  409 642 ) resistor r=5.29055 //w=0.35 //l=0.17 //layer=li \
 //thickness=0.1 //x=26.93 //y=0.175 //x2=26.76 //y2=0.175
r1842 (  409 411 ) resistor r=6.97548 //w=0.367 //l=0.2 //layer=li \
 //thickness=0.1 //x=26.93 //y=0.175 //x2=27.13 //y2=0.175
r1843 (  408 643 ) resistor r=5.29055 //w=0.35 //l=0.17 //layer=li \
 //thickness=0.1 //x=29.92 //y=0.175 //x2=30.09 //y2=0.175
r1844 (  408 415 ) resistor r=19.8801 //w=0.367 //l=0.57 //layer=li \
 //thickness=0.1 //x=29.92 //y=0.175 //x2=29.35 //y2=0.175
r1845 (  398 400 ) resistor r=38.7139 //w=0.367 //l=1.11 //layer=li \
 //thickness=0.1 //x=24.54 //y=0.175 //x2=25.65 //y2=0.175
r1846 (  396 398 ) resistor r=38.7139 //w=0.367 //l=1.11 //layer=li \
 //thickness=0.1 //x=23.43 //y=0.175 //x2=24.54 //y2=0.175
r1847 (  394 396 ) resistor r=38.7139 //w=0.367 //l=1.11 //layer=li \
 //thickness=0.1 //x=22.32 //y=0.175 //x2=23.43 //y2=0.175
r1848 (  392 641 ) resistor r=5.29055 //w=0.35 //l=0.17 //layer=li \
 //thickness=0.1 //x=22.12 //y=0.175 //x2=21.95 //y2=0.175
r1849 (  392 394 ) resistor r=6.97548 //w=0.367 //l=0.2 //layer=li \
 //thickness=0.1 //x=22.12 //y=0.175 //x2=22.32 //y2=0.175
r1850 (  391 642 ) resistor r=5.29055 //w=0.35 //l=0.17 //layer=li \
 //thickness=0.1 //x=26.59 //y=0.175 //x2=26.76 //y2=0.175
r1851 (  391 400 ) resistor r=32.7847 //w=0.367 //l=0.94 //layer=li \
 //thickness=0.1 //x=26.59 //y=0.175 //x2=25.65 //y2=0.175
r1852 (  381 383 ) resistor r=38.7139 //w=0.367 //l=1.11 //layer=li \
 //thickness=0.1 //x=19.73 //y=0.175 //x2=20.84 //y2=0.175
r1853 (  379 640 ) resistor r=5.29055 //w=0.35 //l=0.17 //layer=li \
 //thickness=0.1 //x=18.79 //y=0.175 //x2=18.62 //y2=0.175
r1854 (  379 381 ) resistor r=32.7847 //w=0.367 //l=0.94 //layer=li \
 //thickness=0.1 //x=18.79 //y=0.175 //x2=19.73 //y2=0.175
r1855 (  378 641 ) resistor r=5.29055 //w=0.35 //l=0.17 //layer=li \
 //thickness=0.1 //x=21.78 //y=0.175 //x2=21.95 //y2=0.175
r1856 (  378 383 ) resistor r=32.7847 //w=0.367 //l=0.94 //layer=li \
 //thickness=0.1 //x=21.78 //y=0.175 //x2=20.84 //y2=0.175
r1857 (  368 370 ) resistor r=38.7139 //w=0.367 //l=1.11 //layer=li \
 //thickness=0.1 //x=17.14 //y=0.175 //x2=18.25 //y2=0.175
r1858 (  366 368 ) resistor r=38.7139 //w=0.367 //l=1.11 //layer=li \
 //thickness=0.1 //x=16.03 //y=0.175 //x2=17.14 //y2=0.175
r1859 (  364 639 ) resistor r=5.29055 //w=0.35 //l=0.17 //layer=li \
 //thickness=0.1 //x=15.46 //y=0.175 //x2=15.29 //y2=0.175
r1860 (  364 366 ) resistor r=19.8801 //w=0.367 //l=0.57 //layer=li \
 //thickness=0.1 //x=15.46 //y=0.175 //x2=16.03 //y2=0.175
r1861 (  363 640 ) resistor r=5.29055 //w=0.35 //l=0.17 //layer=li \
 //thickness=0.1 //x=18.45 //y=0.175 //x2=18.62 //y2=0.175
r1862 (  363 370 ) resistor r=6.97548 //w=0.367 //l=0.2 //layer=li \
 //thickness=0.1 //x=18.45 //y=0.175 //x2=18.25 //y2=0.175
r1863 (  353 355 ) resistor r=38.7139 //w=0.367 //l=1.11 //layer=li \
 //thickness=0.1 //x=13.44 //y=0.175 //x2=14.55 //y2=0.175
r1864 (  351 353 ) resistor r=38.7139 //w=0.367 //l=1.11 //layer=li \
 //thickness=0.1 //x=12.33 //y=0.175 //x2=13.44 //y2=0.175
r1865 (  349 638 ) resistor r=5.29055 //w=0.35 //l=0.17 //layer=li \
 //thickness=0.1 //x=12.13 //y=0.175 //x2=11.96 //y2=0.175
r1866 (  349 351 ) resistor r=6.97548 //w=0.367 //l=0.2 //layer=li \
 //thickness=0.1 //x=12.13 //y=0.175 //x2=12.33 //y2=0.175
r1867 (  348 639 ) resistor r=5.29055 //w=0.35 //l=0.17 //layer=li \
 //thickness=0.1 //x=15.12 //y=0.175 //x2=15.29 //y2=0.175
r1868 (  348 355 ) resistor r=19.8801 //w=0.367 //l=0.57 //layer=li \
 //thickness=0.1 //x=15.12 //y=0.175 //x2=14.55 //y2=0.175
r1869 (  338 340 ) resistor r=38.7139 //w=0.367 //l=1.11 //layer=li \
 //thickness=0.1 //x=9.74 //y=0.175 //x2=10.85 //y2=0.175
r1870 (  336 637 ) resistor r=5.29055 //w=0.35 //l=0.17 //layer=li \
 //thickness=0.1 //x=8.8 //y=0.175 //x2=8.63 //y2=0.175
r1871 (  336 338 ) resistor r=32.7847 //w=0.367 //l=0.94 //layer=li \
 //thickness=0.1 //x=8.8 //y=0.175 //x2=9.74 //y2=0.175
r1872 (  335 638 ) resistor r=5.29055 //w=0.35 //l=0.17 //layer=li \
 //thickness=0.1 //x=11.79 //y=0.175 //x2=11.96 //y2=0.175
r1873 (  335 340 ) resistor r=32.7847 //w=0.367 //l=0.94 //layer=li \
 //thickness=0.1 //x=11.79 //y=0.175 //x2=10.85 //y2=0.175
r1874 (  325 327 ) resistor r=38.7139 //w=0.367 //l=1.11 //layer=li \
 //thickness=0.1 //x=7.15 //y=0.175 //x2=8.26 //y2=0.175
r1875 (  323 325 ) resistor r=38.7139 //w=0.367 //l=1.11 //layer=li \
 //thickness=0.1 //x=6.04 //y=0.175 //x2=7.15 //y2=0.175
r1876 (  321 636 ) resistor r=5.29055 //w=0.35 //l=0.17 //layer=li \
 //thickness=0.1 //x=5.47 //y=0.175 //x2=5.3 //y2=0.175
r1877 (  321 323 ) resistor r=19.8801 //w=0.367 //l=0.57 //layer=li \
 //thickness=0.1 //x=5.47 //y=0.175 //x2=6.04 //y2=0.175
r1878 (  320 637 ) resistor r=5.29055 //w=0.35 //l=0.17 //layer=li \
 //thickness=0.1 //x=8.46 //y=0.175 //x2=8.63 //y2=0.175
r1879 (  320 327 ) resistor r=6.97548 //w=0.367 //l=0.2 //layer=li \
 //thickness=0.1 //x=8.46 //y=0.175 //x2=8.26 //y2=0.175
r1880 (  310 312 ) resistor r=38.7139 //w=0.367 //l=1.11 //layer=li \
 //thickness=0.1 //x=3.45 //y=0.175 //x2=4.56 //y2=0.175
r1881 (  308 310 ) resistor r=38.7139 //w=0.367 //l=1.11 //layer=li \
 //thickness=0.1 //x=2.34 //y=0.175 //x2=3.45 //y2=0.175
r1882 (  306 308 ) resistor r=38.7139 //w=0.367 //l=1.11 //layer=li \
 //thickness=0.1 //x=1.23 //y=0.175 //x2=2.34 //y2=0.175
r1883 (  303 636 ) resistor r=5.29055 //w=0.35 //l=0.17 //layer=li \
 //thickness=0.1 //x=5.13 //y=0.175 //x2=5.3 //y2=0.175
r1884 (  303 312 ) resistor r=19.8801 //w=0.367 //l=0.57 //layer=li \
 //thickness=0.1 //x=5.13 //y=0.175 //x2=4.56 //y2=0.175
r1885 (  300 690 ) resistor r=9.3 //w=0.17 //l=0.17 //layer=mcon //count=1 \
 //x=72.71 //y=1.135 //x2=72.71 //y2=1.135
r1886 (  297 689 ) resistor r=9.3 //w=0.17 //l=0.17 //layer=mcon //count=1 \
 //x=69.38 //y=1.135 //x2=69.38 //y2=1.135
r1887 (  295 587 ) resistor r=3.1 //w=0.17 //l=0.51 //layer=mcon //count=3 \
 //x=69.31 //y=0.18 //x2=69.31 //y2=0.18
r1888 (  293 688 ) resistor r=9.3 //w=0.17 //l=0.17 //layer=mcon //count=1 \
 //x=66.05 //y=1.135 //x2=66.05 //y2=1.135
r1889 (  287 687 ) resistor r=9.3 //w=0.17 //l=0.17 //layer=mcon //count=1 \
 //x=62.72 //y=1.135 //x2=62.72 //y2=1.135
r1890 (  287 288 ) resistor r=0.0939994 //w=0.226 //l=0.13 //layer=m1 \
 //thickness=0.36 //x=62.717 //y=1.135 //x2=62.717 //y2=1.005
r1891 (  285 544 ) resistor r=3.1 //w=0.17 //l=0.51 //layer=mcon //count=3 \
 //x=59.32 //y=0.18 //x2=59.32 //y2=0.18
r1892 (  281 686 ) resistor r=9.3 //w=0.17 //l=0.17 //layer=mcon //count=1 \
 //x=59.39 //y=1.135 //x2=59.39 //y2=1.135
r1893 (  281 282 ) resistor r=0.0939994 //w=0.226 //l=0.13 //layer=m1 \
 //thickness=0.36 //x=59.387 //y=1.135 //x2=59.387 //y2=1.005
r1894 (  276 685 ) resistor r=9.3 //w=0.17 //l=0.17 //layer=mcon //count=1 \
 //x=56.06 //y=1.135 //x2=56.06 //y2=1.135
r1895 (  276 277 ) resistor r=0.0939994 //w=0.226 //l=0.13 //layer=m1 \
 //thickness=0.36 //x=56.057 //y=1.135 //x2=56.057 //y2=1.005
r1896 (  271 684 ) resistor r=9.3 //w=0.17 //l=0.17 //layer=mcon //count=1 \
 //x=52.73 //y=1.135 //x2=52.73 //y2=1.135
r1897 (  271 272 ) resistor r=0.0939994 //w=0.226 //l=0.13 //layer=m1 \
 //thickness=0.36 //x=52.727 //y=1.135 //x2=52.727 //y2=1.005
r1898 (  269 501 ) resistor r=3.1 //w=0.17 //l=0.51 //layer=mcon //count=3 \
 //x=49.33 //y=0.18 //x2=49.33 //y2=0.18
r1899 (  265 683 ) resistor r=9.3 //w=0.17 //l=0.17 //layer=mcon //count=1 \
 //x=49.4 //y=1.135 //x2=49.4 //y2=1.135
r1900 (  265 266 ) resistor r=0.0939994 //w=0.226 //l=0.13 //layer=m1 \
 //thickness=0.36 //x=49.397 //y=1.135 //x2=49.397 //y2=1.005
r1901 (  263 484 ) resistor r=3.1 //w=0.17 //l=0.51 //layer=mcon //count=3 \
 //x=44.52 //y=0.18 //x2=44.52 //y2=0.18
r1902 (  260 682 ) resistor r=9.3 //w=0.17 //l=0.17 //layer=mcon //count=1 \
 //x=44.485 //y=1.145 //x2=44.485 //y2=1.145
r1903 (  255 681 ) resistor r=9.3 //w=0.17 //l=0.17 //layer=mcon //count=1 \
 //x=41.26 //y=1.135 //x2=41.26 //y2=1.135
r1904 (  255 256 ) resistor r=0.0939994 //w=0.226 //l=0.13 //layer=m1 \
 //thickness=0.36 //x=41.257 //y=1.135 //x2=41.257 //y2=1.005
r1905 (  250 680 ) resistor r=9.3 //w=0.17 //l=0.17 //layer=mcon //count=1 \
 //x=37.93 //y=1.135 //x2=37.93 //y2=1.135
r1906 (  250 251 ) resistor r=0.0939994 //w=0.226 //l=0.13 //layer=m1 \
 //thickness=0.36 //x=37.927 //y=1.135 //x2=37.927 //y2=1.005
r1907 (  248 441 ) resistor r=3.1 //w=0.17 //l=0.51 //layer=mcon //count=3 \
 //x=34.53 //y=0.18 //x2=34.53 //y2=0.18
r1908 (  244 679 ) resistor r=9.3 //w=0.17 //l=0.17 //layer=mcon //count=1 \
 //x=34.6 //y=1.135 //x2=34.6 //y2=1.135
r1909 (  244 245 ) resistor r=0.0939994 //w=0.226 //l=0.13 //layer=m1 \
 //thickness=0.36 //x=34.597 //y=1.135 //x2=34.597 //y2=1.005
r1910 (  239 678 ) resistor r=9.3 //w=0.17 //l=0.17 //layer=mcon //count=1 \
 //x=31.27 //y=1.135 //x2=31.27 //y2=1.135
r1911 (  239 240 ) resistor r=0.0939994 //w=0.226 //l=0.13 //layer=m1 \
 //thickness=0.36 //x=31.267 //y=1.135 //x2=31.267 //y2=1.005
r1912 (  234 677 ) resistor r=9.3 //w=0.17 //l=0.17 //layer=mcon //count=1 \
 //x=27.94 //y=1.135 //x2=27.94 //y2=1.135
r1913 (  234 235 ) resistor r=0.0939994 //w=0.226 //l=0.13 //layer=m1 \
 //thickness=0.36 //x=27.937 //y=1.135 //x2=27.937 //y2=1.005
r1914 (  230 676 ) resistor r=9.3 //w=0.17 //l=0.17 //layer=mcon //count=1 \
 //x=23.025 //y=1.145 //x2=23.025 //y2=1.145
r1915 (  228 381 ) resistor r=3.1 //w=0.17 //l=0.51 //layer=mcon //count=3 \
 //x=19.73 //y=0.18 //x2=19.73 //y2=0.18
r1916 (  224 675 ) resistor r=9.3 //w=0.17 //l=0.17 //layer=mcon //count=1 \
 //x=19.8 //y=1.135 //x2=19.8 //y2=1.135
r1917 (  224 225 ) resistor r=0.0939994 //w=0.226 //l=0.13 //layer=m1 \
 //thickness=0.36 //x=19.797 //y=1.135 //x2=19.797 //y2=1.005
r1918 (  219 674 ) resistor r=9.3 //w=0.17 //l=0.17 //layer=mcon //count=1 \
 //x=16.47 //y=1.135 //x2=16.47 //y2=1.135
r1919 (  219 220 ) resistor r=0.0939994 //w=0.226 //l=0.13 //layer=m1 \
 //thickness=0.36 //x=16.467 //y=1.135 //x2=16.467 //y2=1.005
r1920 (  214 673 ) resistor r=9.3 //w=0.17 //l=0.17 //layer=mcon //count=1 \
 //x=13.14 //y=1.135 //x2=13.14 //y2=1.135
r1921 (  214 215 ) resistor r=0.0939994 //w=0.226 //l=0.13 //layer=m1 \
 //thickness=0.36 //x=13.137 //y=1.135 //x2=13.137 //y2=1.005
r1922 (  212 338 ) resistor r=3.1 //w=0.17 //l=0.51 //layer=mcon //count=3 \
 //x=9.74 //y=0.18 //x2=9.74 //y2=0.18
r1923 (  208 672 ) resistor r=9.3 //w=0.17 //l=0.17 //layer=mcon //count=1 \
 //x=9.81 //y=1.135 //x2=9.81 //y2=1.135
r1924 (  208 209 ) resistor r=0.0939994 //w=0.226 //l=0.13 //layer=m1 \
 //thickness=0.36 //x=9.807 //y=1.135 //x2=9.807 //y2=1.005
r1925 (  203 671 ) resistor r=9.3 //w=0.17 //l=0.17 //layer=mcon //count=1 \
 //x=6.48 //y=1.135 //x2=6.48 //y2=1.135
r1926 (  203 204 ) resistor r=0.0939994 //w=0.226 //l=0.13 //layer=m1 \
 //thickness=0.36 //x=6.477 //y=1.135 //x2=6.477 //y2=1.005
r1927 (  199 670 ) resistor r=9.3 //w=0.17 //l=0.17 //layer=mcon //count=1 \
 //x=1.565 //y=1.145 //x2=1.565 //y2=1.145
r1928 (  196 662 ) resistor r=4.65 //w=0.17 //l=0.34 //layer=mcon //count=2 \
 //x=76.34 //y=0.18 //x2=76.34 //y2=0.18
r1929 (  194 659 ) resistor r=3.1 //w=0.17 //l=0.51 //layer=mcon //count=3 \
 //x=75.6 //y=0.18 //x2=75.6 //y2=0.18
r1930 (  194 196 ) resistor r=0.297428 //w=0.311 //l=0.74 //layer=m1 \
 //thickness=0.36 //x=75.6 //y=0.175 //x2=76.34 //y2=0.175
r1931 (  192 604 ) resistor r=3.1 //w=0.17 //l=0.51 //layer=mcon //count=3 \
 //x=74.12 //y=0.18 //x2=74.12 //y2=0.18
r1932 (  192 194 ) resistor r=0.594855 //w=0.311 //l=1.48 //layer=m1 \
 //thickness=0.36 //x=74.12 //y=0.175 //x2=75.6 //y2=0.175
r1933 (  190 602 ) resistor r=3.1 //w=0.17 //l=0.51 //layer=mcon //count=3 \
 //x=73.01 //y=0.18 //x2=73.01 //y2=0.18
r1934 (  190 192 ) resistor r=0.446141 //w=0.311 //l=1.11 //layer=m1 \
 //thickness=0.36 //x=73.01 //y=0.175 //x2=74.12 //y2=0.175
r1935 (  188 298 ) resistor r=0.028033 //w=0.35 //l=0.085 //layer=m1 \
 //thickness=0.36 //x=72.795 //y=0.175 //x2=72.71 //y2=0.175
r1936 (  188 190 ) resistor r=0.0864148 //w=0.311 //l=0.215 //layer=m1 \
 //thickness=0.36 //x=72.795 //y=0.175 //x2=73.01 //y2=0.175
r1937 (  187 300 ) resistor r=0.0703067 //w=0.254 //l=0.11649 //layer=m1 \
 //thickness=0.36 //x=72.71 //y=1.02 //x2=72.707 //y2=1.135
r1938 (  186 298 ) resistor r=0.0413265 //w=0.7 //l=0.175 //layer=m1 \
 //thickness=0.36 //x=72.71 //y=0.35 //x2=72.71 //y2=0.175
r1939 (  186 187 ) resistor r=0.639313 //w=0.131 //l=0.67 //layer=m1 \
 //thickness=0.36 //x=72.71 //y=0.35 //x2=72.71 //y2=1.02
r1940 (  185 600 ) resistor r=3.1 //w=0.17 //l=0.51 //layer=mcon //count=3 \
 //x=71.9 //y=0.18 //x2=71.9 //y2=0.18
r1941 (  183 589 ) resistor r=3.1 //w=0.17 //l=0.51 //layer=mcon //count=3 \
 //x=70.42 //y=0.18 //x2=70.42 //y2=0.18
r1942 (  183 185 ) resistor r=0.594855 //w=0.311 //l=1.48 //layer=m1 \
 //thickness=0.36 //x=70.42 //y=0.175 //x2=71.9 //y2=0.175
r1943 (  181 295 ) resistor r=0.028033 //w=0.35 //l=0.085 //layer=m1 \
 //thickness=0.36 //x=69.465 //y=0.175 //x2=69.38 //y2=0.175
r1944 (  181 183 ) resistor r=0.383842 //w=0.311 //l=0.955 //layer=m1 \
 //thickness=0.36 //x=69.465 //y=0.175 //x2=70.42 //y2=0.175
r1945 (  180 298 ) resistor r=0.028033 //w=0.35 //l=0.085 //layer=m1 \
 //thickness=0.36 //x=72.625 //y=0.175 //x2=72.71 //y2=0.175
r1946 (  180 185 ) resistor r=0.291399 //w=0.311 //l=0.725 //layer=m1 \
 //thickness=0.36 //x=72.625 //y=0.175 //x2=71.9 //y2=0.175
r1947 (  179 297 ) resistor r=0.0736049 //w=0.235 //l=0.12 //layer=m1 \
 //thickness=0.36 //x=69.38 //y=1.015 //x2=69.38 //y2=1.135
r1948 (  178 295 ) resistor r=0.0413265 //w=0.7 //l=0.175 //layer=m1 \
 //thickness=0.36 //x=69.38 //y=0.35 //x2=69.38 //y2=0.175
r1949 (  178 179 ) resistor r=0.634542 //w=0.131 //l=0.665 //layer=m1 \
 //thickness=0.36 //x=69.38 //y=0.35 //x2=69.38 //y2=1.015
r1950 (  177 576 ) resistor r=3.1 //w=0.17 //l=0.51 //layer=mcon //count=3 \
 //x=67.83 //y=0.18 //x2=67.83 //y2=0.18
r1951 (  175 574 ) resistor r=3.1 //w=0.17 //l=0.51 //layer=mcon //count=3 \
 //x=66.72 //y=0.18 //x2=66.72 //y2=0.18
r1952 (  175 177 ) resistor r=0.446141 //w=0.311 //l=1.11 //layer=m1 \
 //thickness=0.36 //x=66.72 //y=0.175 //x2=67.83 //y2=0.175
r1953 (  173 291 ) resistor r=0.028033 //w=0.35 //l=0.085 //layer=m1 \
 //thickness=0.36 //x=66.135 //y=0.175 //x2=66.05 //y2=0.175
r1954 (  173 175 ) resistor r=0.235129 //w=0.311 //l=0.585 //layer=m1 \
 //thickness=0.36 //x=66.135 //y=0.175 //x2=66.72 //y2=0.175
r1955 (  172 295 ) resistor r=0.028033 //w=0.35 //l=0.085 //layer=m1 \
 //thickness=0.36 //x=69.295 //y=0.175 //x2=69.38 //y2=0.175
r1956 (  172 177 ) resistor r=0.588826 //w=0.311 //l=1.465 //layer=m1 \
 //thickness=0.36 //x=69.295 //y=0.175 //x2=67.83 //y2=0.175
r1957 (  171 293 ) resistor r=0.0729089 //w=0.249 //l=0.120996 //layer=m1 \
 //thickness=0.36 //x=66.05 //y=1.015 //x2=66.052 //y2=1.135
r1958 (  170 291 ) resistor r=0.0413265 //w=0.7 //l=0.175 //layer=m1 \
 //thickness=0.36 //x=66.05 //y=0.35 //x2=66.05 //y2=0.175
r1959 (  170 171 ) resistor r=0.634542 //w=0.131 //l=0.665 //layer=m1 \
 //thickness=0.36 //x=66.05 //y=0.35 //x2=66.05 //y2=1.015
r1960 (  169 572 ) resistor r=3.1 //w=0.17 //l=0.51 //layer=mcon //count=3 \
 //x=65.61 //y=0.18 //x2=65.61 //y2=0.18
r1961 (  167 561 ) resistor r=3.1 //w=0.17 //l=0.51 //layer=mcon //count=3 \
 //x=64.13 //y=0.18 //x2=64.13 //y2=0.18
r1962 (  167 169 ) resistor r=0.594855 //w=0.311 //l=1.48 //layer=m1 \
 //thickness=0.36 //x=64.13 //y=0.175 //x2=65.61 //y2=0.175
r1963 (  165 559 ) resistor r=3.1 //w=0.17 //l=0.51 //layer=mcon //count=3 \
 //x=63.02 //y=0.18 //x2=63.02 //y2=0.18
r1964 (  165 167 ) resistor r=0.446141 //w=0.311 //l=1.11 //layer=m1 \
 //thickness=0.36 //x=63.02 //y=0.175 //x2=64.13 //y2=0.175
r1965 (  163 290 ) resistor r=0.028033 //w=0.35 //l=0.085 //layer=m1 \
 //thickness=0.36 //x=62.805 //y=0.175 //x2=62.72 //y2=0.175
r1966 (  163 165 ) resistor r=0.0864148 //w=0.311 //l=0.215 //layer=m1 \
 //thickness=0.36 //x=62.805 //y=0.175 //x2=63.02 //y2=0.175
r1967 (  162 291 ) resistor r=0.028033 //w=0.35 //l=0.085 //layer=m1 \
 //thickness=0.36 //x=65.965 //y=0.175 //x2=66.05 //y2=0.175
r1968 (  162 169 ) resistor r=0.142685 //w=0.311 //l=0.355 //layer=m1 \
 //thickness=0.36 //x=65.965 //y=0.175 //x2=65.61 //y2=0.175
r1969 (  160 290 ) resistor r=0.0413265 //w=0.7 //l=0.175 //layer=m1 \
 //thickness=0.36 //x=62.72 //y=0.35 //x2=62.72 //y2=0.175
r1970 (  160 288 ) resistor r=0.625 //w=0.131 //l=0.655 //layer=m1 \
 //thickness=0.36 //x=62.72 //y=0.35 //x2=62.72 //y2=1.005
r1971 (  159 557 ) resistor r=3.1 //w=0.17 //l=0.51 //layer=mcon //count=3 \
 //x=61.91 //y=0.18 //x2=61.91 //y2=0.18
r1972 (  157 546 ) resistor r=3.1 //w=0.17 //l=0.51 //layer=mcon //count=3 \
 //x=60.43 //y=0.18 //x2=60.43 //y2=0.18
r1973 (  157 159 ) resistor r=0.594855 //w=0.311 //l=1.48 //layer=m1 \
 //thickness=0.36 //x=60.43 //y=0.175 //x2=61.91 //y2=0.175
r1974 (  155 285 ) resistor r=0.028033 //w=0.35 //l=0.085 //layer=m1 \
 //thickness=0.36 //x=59.475 //y=0.175 //x2=59.39 //y2=0.175
r1975 (  155 157 ) resistor r=0.383842 //w=0.311 //l=0.955 //layer=m1 \
 //thickness=0.36 //x=59.475 //y=0.175 //x2=60.43 //y2=0.175
r1976 (  154 290 ) resistor r=0.028033 //w=0.35 //l=0.085 //layer=m1 \
 //thickness=0.36 //x=62.635 //y=0.175 //x2=62.72 //y2=0.175
r1977 (  154 159 ) resistor r=0.291399 //w=0.311 //l=0.725 //layer=m1 \
 //thickness=0.36 //x=62.635 //y=0.175 //x2=61.91 //y2=0.175
r1978 (  152 285 ) resistor r=0.0413265 //w=0.7 //l=0.175 //layer=m1 \
 //thickness=0.36 //x=59.39 //y=0.35 //x2=59.39 //y2=0.175
r1979 (  152 282 ) resistor r=0.625 //w=0.131 //l=0.655 //layer=m1 \
 //thickness=0.36 //x=59.39 //y=0.35 //x2=59.39 //y2=1.005
r1980 (  151 533 ) resistor r=3.1 //w=0.17 //l=0.51 //layer=mcon //count=3 \
 //x=57.84 //y=0.18 //x2=57.84 //y2=0.18
r1981 (  149 531 ) resistor r=3.1 //w=0.17 //l=0.51 //layer=mcon //count=3 \
 //x=56.73 //y=0.18 //x2=56.73 //y2=0.18
r1982 (  149 151 ) resistor r=0.446141 //w=0.311 //l=1.11 //layer=m1 \
 //thickness=0.36 //x=56.73 //y=0.175 //x2=57.84 //y2=0.175
r1983 (  147 279 ) resistor r=0.028033 //w=0.35 //l=0.085 //layer=m1 \
 //thickness=0.36 //x=56.145 //y=0.175 //x2=56.06 //y2=0.175
r1984 (  147 149 ) resistor r=0.235129 //w=0.311 //l=0.585 //layer=m1 \
 //thickness=0.36 //x=56.145 //y=0.175 //x2=56.73 //y2=0.175
r1985 (  146 285 ) resistor r=0.028033 //w=0.35 //l=0.085 //layer=m1 \
 //thickness=0.36 //x=59.305 //y=0.175 //x2=59.39 //y2=0.175
r1986 (  146 151 ) resistor r=0.588826 //w=0.311 //l=1.465 //layer=m1 \
 //thickness=0.36 //x=59.305 //y=0.175 //x2=57.84 //y2=0.175
r1987 (  144 279 ) resistor r=0.0413265 //w=0.7 //l=0.175 //layer=m1 \
 //thickness=0.36 //x=56.06 //y=0.35 //x2=56.06 //y2=0.175
r1988 (  144 277 ) resistor r=0.625 //w=0.131 //l=0.655 //layer=m1 \
 //thickness=0.36 //x=56.06 //y=0.35 //x2=56.06 //y2=1.005
r1989 (  143 529 ) resistor r=3.1 //w=0.17 //l=0.51 //layer=mcon //count=3 \
 //x=55.62 //y=0.18 //x2=55.62 //y2=0.18
r1990 (  141 518 ) resistor r=3.1 //w=0.17 //l=0.51 //layer=mcon //count=3 \
 //x=54.14 //y=0.18 //x2=54.14 //y2=0.18
r1991 (  141 143 ) resistor r=0.594855 //w=0.311 //l=1.48 //layer=m1 \
 //thickness=0.36 //x=54.14 //y=0.175 //x2=55.62 //y2=0.175
r1992 (  139 516 ) resistor r=3.1 //w=0.17 //l=0.51 //layer=mcon //count=3 \
 //x=53.03 //y=0.18 //x2=53.03 //y2=0.18
r1993 (  139 141 ) resistor r=0.446141 //w=0.311 //l=1.11 //layer=m1 \
 //thickness=0.36 //x=53.03 //y=0.175 //x2=54.14 //y2=0.175
r1994 (  137 274 ) resistor r=0.028033 //w=0.35 //l=0.085 //layer=m1 \
 //thickness=0.36 //x=52.815 //y=0.175 //x2=52.73 //y2=0.175
r1995 (  137 139 ) resistor r=0.0864148 //w=0.311 //l=0.215 //layer=m1 \
 //thickness=0.36 //x=52.815 //y=0.175 //x2=53.03 //y2=0.175
r1996 (  136 279 ) resistor r=0.028033 //w=0.35 //l=0.085 //layer=m1 \
 //thickness=0.36 //x=55.975 //y=0.175 //x2=56.06 //y2=0.175
r1997 (  136 143 ) resistor r=0.142685 //w=0.311 //l=0.355 //layer=m1 \
 //thickness=0.36 //x=55.975 //y=0.175 //x2=55.62 //y2=0.175
r1998 (  134 274 ) resistor r=0.0413265 //w=0.7 //l=0.175 //layer=m1 \
 //thickness=0.36 //x=52.73 //y=0.35 //x2=52.73 //y2=0.175
r1999 (  134 272 ) resistor r=0.625 //w=0.131 //l=0.655 //layer=m1 \
 //thickness=0.36 //x=52.73 //y=0.35 //x2=52.73 //y2=1.005
r2000 (  133 514 ) resistor r=3.1 //w=0.17 //l=0.51 //layer=mcon //count=3 \
 //x=51.92 //y=0.18 //x2=51.92 //y2=0.18
r2001 (  131 503 ) resistor r=3.1 //w=0.17 //l=0.51 //layer=mcon //count=3 \
 //x=50.44 //y=0.18 //x2=50.44 //y2=0.18
r2002 (  131 133 ) resistor r=0.594855 //w=0.311 //l=1.48 //layer=m1 \
 //thickness=0.36 //x=50.44 //y=0.175 //x2=51.92 //y2=0.175
r2003 (  129 269 ) resistor r=0.028033 //w=0.35 //l=0.085 //layer=m1 \
 //thickness=0.36 //x=49.485 //y=0.175 //x2=49.4 //y2=0.175
r2004 (  129 131 ) resistor r=0.383842 //w=0.311 //l=0.955 //layer=m1 \
 //thickness=0.36 //x=49.485 //y=0.175 //x2=50.44 //y2=0.175
r2005 (  128 274 ) resistor r=0.028033 //w=0.35 //l=0.085 //layer=m1 \
 //thickness=0.36 //x=52.645 //y=0.175 //x2=52.73 //y2=0.175
r2006 (  128 133 ) resistor r=0.291399 //w=0.311 //l=0.725 //layer=m1 \
 //thickness=0.36 //x=52.645 //y=0.175 //x2=51.92 //y2=0.175
r2007 (  126 269 ) resistor r=0.0413265 //w=0.7 //l=0.175 //layer=m1 \
 //thickness=0.36 //x=49.4 //y=0.35 //x2=49.4 //y2=0.175
r2008 (  126 266 ) resistor r=0.625 //w=0.131 //l=0.655 //layer=m1 \
 //thickness=0.36 //x=49.4 //y=0.35 //x2=49.4 //y2=1.005
r2009 (  125 490 ) resistor r=3.1 //w=0.17 //l=0.51 //layer=mcon //count=3 \
 //x=47.85 //y=0.18 //x2=47.85 //y2=0.18
r2010 (  123 488 ) resistor r=3.1 //w=0.17 //l=0.51 //layer=mcon //count=3 \
 //x=46.74 //y=0.18 //x2=46.74 //y2=0.18
r2011 (  123 125 ) resistor r=0.446141 //w=0.311 //l=1.11 //layer=m1 \
 //thickness=0.36 //x=46.74 //y=0.175 //x2=47.85 //y2=0.175
r2012 (  121 486 ) resistor r=3.1 //w=0.17 //l=0.51 //layer=mcon //count=3 \
 //x=45.63 //y=0.18 //x2=45.63 //y2=0.18
r2013 (  121 123 ) resistor r=0.446141 //w=0.311 //l=1.11 //layer=m1 \
 //thickness=0.36 //x=45.63 //y=0.175 //x2=46.74 //y2=0.175
r2014 (  119 263 ) resistor r=0.028033 //w=0.35 //l=0.085 //layer=m1 \
 //thickness=0.36 //x=44.57 //y=0.175 //x2=44.485 //y2=0.175
r2015 (  119 121 ) resistor r=0.426045 //w=0.311 //l=1.06 //layer=m1 \
 //thickness=0.36 //x=44.57 //y=0.175 //x2=45.63 //y2=0.175
r2016 (  118 269 ) resistor r=0.028033 //w=0.35 //l=0.085 //layer=m1 \
 //thickness=0.36 //x=49.315 //y=0.175 //x2=49.4 //y2=0.175
r2017 (  118 125 ) resistor r=0.588826 //w=0.311 //l=1.465 //layer=m1 \
 //thickness=0.36 //x=49.315 //y=0.175 //x2=47.85 //y2=0.175
r2018 (  117 260 ) resistor r=0.0942778 //w=0.221 //l=0.13 //layer=m1 \
 //thickness=0.36 //x=44.485 //y=1.015 //x2=44.485 //y2=1.145
r2019 (  116 263 ) resistor r=0.0413265 //w=0.7 //l=0.175 //layer=m1 \
 //thickness=0.36 //x=44.485 //y=0.35 //x2=44.485 //y2=0.175
r2020 (  116 117 ) resistor r=0.634542 //w=0.131 //l=0.665 //layer=m1 \
 //thickness=0.36 //x=44.485 //y=0.35 //x2=44.485 //y2=1.015
r2021 (  115 473 ) resistor r=3.1 //w=0.17 //l=0.51 //layer=mcon //count=3 \
 //x=43.04 //y=0.18 //x2=43.04 //y2=0.18
r2022 (  113 471 ) resistor r=3.1 //w=0.17 //l=0.51 //layer=mcon //count=3 \
 //x=41.93 //y=0.18 //x2=41.93 //y2=0.18
r2023 (  113 115 ) resistor r=0.446141 //w=0.311 //l=1.11 //layer=m1 \
 //thickness=0.36 //x=41.93 //y=0.175 //x2=43.04 //y2=0.175
r2024 (  111 258 ) resistor r=0.028033 //w=0.35 //l=0.085 //layer=m1 \
 //thickness=0.36 //x=41.345 //y=0.175 //x2=41.26 //y2=0.175
r2025 (  111 113 ) resistor r=0.235129 //w=0.311 //l=0.585 //layer=m1 \
 //thickness=0.36 //x=41.345 //y=0.175 //x2=41.93 //y2=0.175
r2026 (  110 263 ) resistor r=0.028033 //w=0.35 //l=0.085 //layer=m1 \
 //thickness=0.36 //x=44.4 //y=0.175 //x2=44.485 //y2=0.175
r2027 (  110 115 ) resistor r=0.546624 //w=0.311 //l=1.36 //layer=m1 \
 //thickness=0.36 //x=44.4 //y=0.175 //x2=43.04 //y2=0.175
r2028 (  108 258 ) resistor r=0.0413265 //w=0.7 //l=0.175 //layer=m1 \
 //thickness=0.36 //x=41.26 //y=0.35 //x2=41.26 //y2=0.175
r2029 (  108 256 ) resistor r=0.625 //w=0.131 //l=0.655 //layer=m1 \
 //thickness=0.36 //x=41.26 //y=0.35 //x2=41.26 //y2=1.005
r2030 (  107 469 ) resistor r=3.1 //w=0.17 //l=0.51 //layer=mcon //count=3 \
 //x=40.82 //y=0.18 //x2=40.82 //y2=0.18
r2031 (  105 458 ) resistor r=3.1 //w=0.17 //l=0.51 //layer=mcon //count=3 \
 //x=39.34 //y=0.18 //x2=39.34 //y2=0.18
r2032 (  105 107 ) resistor r=0.594855 //w=0.311 //l=1.48 //layer=m1 \
 //thickness=0.36 //x=39.34 //y=0.175 //x2=40.82 //y2=0.175
r2033 (  102 456 ) resistor r=3.1 //w=0.17 //l=0.51 //layer=mcon //count=3 \
 //x=38.23 //y=0.18 //x2=38.23 //y2=0.18
r2034 (  100 253 ) resistor r=0.028033 //w=0.35 //l=0.085 //layer=m1 \
 //thickness=0.36 //x=38.015 //y=0.175 //x2=37.93 //y2=0.175
r2035 (  100 102 ) resistor r=0.0864148 //w=0.311 //l=0.215 //layer=m1 \
 //thickness=0.36 //x=38.015 //y=0.175 //x2=38.23 //y2=0.175
r2036 (  99 258 ) resistor r=0.028033 //w=0.35 //l=0.085 //layer=m1 \
 //thickness=0.36 //x=41.175 //y=0.175 //x2=41.26 //y2=0.175
r2037 (  99 107 ) resistor r=0.142685 //w=0.311 //l=0.355 //layer=m1 \
 //thickness=0.36 //x=41.175 //y=0.175 //x2=40.82 //y2=0.175
r2038 (  97 253 ) resistor r=0.0413265 //w=0.7 //l=0.175 //layer=m1 \
 //thickness=0.36 //x=37.93 //y=0.35 //x2=37.93 //y2=0.175
r2039 (  97 251 ) resistor r=0.625 //w=0.131 //l=0.655 //layer=m1 \
 //thickness=0.36 //x=37.93 //y=0.35 //x2=37.93 //y2=1.005
r2040 (  96 454 ) resistor r=3.1 //w=0.17 //l=0.51 //layer=mcon //count=3 \
 //x=37.12 //y=0.18 //x2=37.12 //y2=0.18
r2041 (  94 443 ) resistor r=3.1 //w=0.17 //l=0.51 //layer=mcon //count=3 \
 //x=35.64 //y=0.18 //x2=35.64 //y2=0.18
r2042 (  94 96 ) resistor r=0.594855 //w=0.311 //l=1.48 //layer=m1 \
 //thickness=0.36 //x=35.64 //y=0.175 //x2=37.12 //y2=0.175
r2043 (  92 248 ) resistor r=0.028033 //w=0.35 //l=0.085 //layer=m1 \
 //thickness=0.36 //x=34.685 //y=0.175 //x2=34.6 //y2=0.175
r2044 (  92 94 ) resistor r=0.383842 //w=0.311 //l=0.955 //layer=m1 \
 //thickness=0.36 //x=34.685 //y=0.175 //x2=35.64 //y2=0.175
r2045 (  91 253 ) resistor r=0.028033 //w=0.35 //l=0.085 //layer=m1 \
 //thickness=0.36 //x=37.845 //y=0.175 //x2=37.93 //y2=0.175
r2046 (  91 96 ) resistor r=0.291399 //w=0.311 //l=0.725 //layer=m1 \
 //thickness=0.36 //x=37.845 //y=0.175 //x2=37.12 //y2=0.175
r2047 (  89 248 ) resistor r=0.0413265 //w=0.7 //l=0.175 //layer=m1 \
 //thickness=0.36 //x=34.6 //y=0.35 //x2=34.6 //y2=0.175
r2048 (  89 245 ) resistor r=0.625 //w=0.131 //l=0.655 //layer=m1 \
 //thickness=0.36 //x=34.6 //y=0.35 //x2=34.6 //y2=1.005
r2049 (  88 430 ) resistor r=3.1 //w=0.17 //l=0.51 //layer=mcon //count=3 \
 //x=33.05 //y=0.18 //x2=33.05 //y2=0.18
r2050 (  86 428 ) resistor r=3.1 //w=0.17 //l=0.51 //layer=mcon //count=3 \
 //x=31.94 //y=0.18 //x2=31.94 //y2=0.18
r2051 (  86 88 ) resistor r=0.446141 //w=0.311 //l=1.11 //layer=m1 \
 //thickness=0.36 //x=31.94 //y=0.175 //x2=33.05 //y2=0.175
r2052 (  84 242 ) resistor r=0.028033 //w=0.35 //l=0.085 //layer=m1 \
 //thickness=0.36 //x=31.355 //y=0.175 //x2=31.27 //y2=0.175
r2053 (  84 86 ) resistor r=0.235129 //w=0.311 //l=0.585 //layer=m1 \
 //thickness=0.36 //x=31.355 //y=0.175 //x2=31.94 //y2=0.175
r2054 (  83 248 ) resistor r=0.028033 //w=0.35 //l=0.085 //layer=m1 \
 //thickness=0.36 //x=34.515 //y=0.175 //x2=34.6 //y2=0.175
r2055 (  83 88 ) resistor r=0.588826 //w=0.311 //l=1.465 //layer=m1 \
 //thickness=0.36 //x=34.515 //y=0.175 //x2=33.05 //y2=0.175
r2056 (  81 242 ) resistor r=0.0413265 //w=0.7 //l=0.175 //layer=m1 \
 //thickness=0.36 //x=31.27 //y=0.35 //x2=31.27 //y2=0.175
r2057 (  81 240 ) resistor r=0.625 //w=0.131 //l=0.655 //layer=m1 \
 //thickness=0.36 //x=31.27 //y=0.35 //x2=31.27 //y2=1.005
r2058 (  80 426 ) resistor r=3.1 //w=0.17 //l=0.51 //layer=mcon //count=3 \
 //x=30.83 //y=0.18 //x2=30.83 //y2=0.18
r2059 (  78 415 ) resistor r=3.1 //w=0.17 //l=0.51 //layer=mcon //count=3 \
 //x=29.35 //y=0.18 //x2=29.35 //y2=0.18
r2060 (  78 80 ) resistor r=0.594855 //w=0.311 //l=1.48 //layer=m1 \
 //thickness=0.36 //x=29.35 //y=0.175 //x2=30.83 //y2=0.175
r2061 (  76 413 ) resistor r=3.1 //w=0.17 //l=0.51 //layer=mcon //count=3 \
 //x=28.24 //y=0.18 //x2=28.24 //y2=0.18
r2062 (  76 78 ) resistor r=0.446141 //w=0.311 //l=1.11 //layer=m1 \
 //thickness=0.36 //x=28.24 //y=0.175 //x2=29.35 //y2=0.175
r2063 (  74 237 ) resistor r=0.028033 //w=0.35 //l=0.085 //layer=m1 \
 //thickness=0.36 //x=28.025 //y=0.175 //x2=27.94 //y2=0.175
r2064 (  74 76 ) resistor r=0.0864148 //w=0.311 //l=0.215 //layer=m1 \
 //thickness=0.36 //x=28.025 //y=0.175 //x2=28.24 //y2=0.175
r2065 (  73 242 ) resistor r=0.028033 //w=0.35 //l=0.085 //layer=m1 \
 //thickness=0.36 //x=31.185 //y=0.175 //x2=31.27 //y2=0.175
r2066 (  73 80 ) resistor r=0.142685 //w=0.311 //l=0.355 //layer=m1 \
 //thickness=0.36 //x=31.185 //y=0.175 //x2=30.83 //y2=0.175
r2067 (  71 237 ) resistor r=0.0413265 //w=0.7 //l=0.175 //layer=m1 \
 //thickness=0.36 //x=27.94 //y=0.35 //x2=27.94 //y2=0.175
r2068 (  71 235 ) resistor r=0.625 //w=0.131 //l=0.655 //layer=m1 \
 //thickness=0.36 //x=27.94 //y=0.35 //x2=27.94 //y2=1.005
r2069 (  70 411 ) resistor r=3.1 //w=0.17 //l=0.51 //layer=mcon //count=3 \
 //x=27.13 //y=0.18 //x2=27.13 //y2=0.18
r2070 (  68 400 ) resistor r=3.1 //w=0.17 //l=0.51 //layer=mcon //count=3 \
 //x=25.65 //y=0.18 //x2=25.65 //y2=0.18
r2071 (  68 70 ) resistor r=0.594855 //w=0.311 //l=1.48 //layer=m1 \
 //thickness=0.36 //x=25.65 //y=0.175 //x2=27.13 //y2=0.175
r2072 (  66 398 ) resistor r=3.1 //w=0.17 //l=0.51 //layer=mcon //count=3 \
 //x=24.54 //y=0.18 //x2=24.54 //y2=0.18
r2073 (  66 68 ) resistor r=0.446141 //w=0.311 //l=1.11 //layer=m1 \
 //thickness=0.36 //x=24.54 //y=0.175 //x2=25.65 //y2=0.175
r2074 (  64 396 ) resistor r=3.1 //w=0.17 //l=0.51 //layer=mcon //count=3 \
 //x=23.43 //y=0.18 //x2=23.43 //y2=0.18
r2075 (  64 66 ) resistor r=0.446141 //w=0.311 //l=1.11 //layer=m1 \
 //thickness=0.36 //x=23.43 //y=0.175 //x2=24.54 //y2=0.175
r2076 (  62 232 ) resistor r=0.028033 //w=0.35 //l=0.085 //layer=m1 \
 //thickness=0.36 //x=23.11 //y=0.175 //x2=23.025 //y2=0.175
r2077 (  62 64 ) resistor r=0.128617 //w=0.311 //l=0.32 //layer=m1 \
 //thickness=0.36 //x=23.11 //y=0.175 //x2=23.43 //y2=0.175
r2078 (  61 237 ) resistor r=0.028033 //w=0.35 //l=0.085 //layer=m1 \
 //thickness=0.36 //x=27.855 //y=0.175 //x2=27.94 //y2=0.175
r2079 (  61 70 ) resistor r=0.291399 //w=0.311 //l=0.725 //layer=m1 \
 //thickness=0.36 //x=27.855 //y=0.175 //x2=27.13 //y2=0.175
r2080 (  60 230 ) resistor r=0.0942778 //w=0.221 //l=0.13 //layer=m1 \
 //thickness=0.36 //x=23.025 //y=1.015 //x2=23.025 //y2=1.145
r2081 (  59 232 ) resistor r=0.0413265 //w=0.7 //l=0.175 //layer=m1 \
 //thickness=0.36 //x=23.025 //y=0.35 //x2=23.025 //y2=0.175
r2082 (  59 60 ) resistor r=0.634542 //w=0.131 //l=0.665 //layer=m1 \
 //thickness=0.36 //x=23.025 //y=0.35 //x2=23.025 //y2=1.015
r2083 (  58 394 ) resistor r=3.1 //w=0.17 //l=0.51 //layer=mcon //count=3 \
 //x=22.32 //y=0.18 //x2=22.32 //y2=0.18
r2084 (  56 383 ) resistor r=3.1 //w=0.17 //l=0.51 //layer=mcon //count=3 \
 //x=20.84 //y=0.18 //x2=20.84 //y2=0.18
r2085 (  56 58 ) resistor r=0.594855 //w=0.311 //l=1.48 //layer=m1 \
 //thickness=0.36 //x=20.84 //y=0.175 //x2=22.32 //y2=0.175
r2086 (  54 228 ) resistor r=0.028033 //w=0.35 //l=0.085 //layer=m1 \
 //thickness=0.36 //x=19.885 //y=0.175 //x2=19.8 //y2=0.175
r2087 (  54 56 ) resistor r=0.383842 //w=0.311 //l=0.955 //layer=m1 \
 //thickness=0.36 //x=19.885 //y=0.175 //x2=20.84 //y2=0.175
r2088 (  53 232 ) resistor r=0.028033 //w=0.35 //l=0.085 //layer=m1 \
 //thickness=0.36 //x=22.94 //y=0.175 //x2=23.025 //y2=0.175
r2089 (  53 58 ) resistor r=0.249196 //w=0.311 //l=0.62 //layer=m1 \
 //thickness=0.36 //x=22.94 //y=0.175 //x2=22.32 //y2=0.175
r2090 (  51 228 ) resistor r=0.0413265 //w=0.7 //l=0.175 //layer=m1 \
 //thickness=0.36 //x=19.8 //y=0.35 //x2=19.8 //y2=0.175
r2091 (  51 225 ) resistor r=0.625 //w=0.131 //l=0.655 //layer=m1 \
 //thickness=0.36 //x=19.8 //y=0.35 //x2=19.8 //y2=1.005
r2092 (  50 370 ) resistor r=3.1 //w=0.17 //l=0.51 //layer=mcon //count=3 \
 //x=18.25 //y=0.18 //x2=18.25 //y2=0.18
r2093 (  48 368 ) resistor r=3.1 //w=0.17 //l=0.51 //layer=mcon //count=3 \
 //x=17.14 //y=0.18 //x2=17.14 //y2=0.18
r2094 (  48 50 ) resistor r=0.446141 //w=0.311 //l=1.11 //layer=m1 \
 //thickness=0.36 //x=17.14 //y=0.175 //x2=18.25 //y2=0.175
r2095 (  46 222 ) resistor r=0.028033 //w=0.35 //l=0.085 //layer=m1 \
 //thickness=0.36 //x=16.555 //y=0.175 //x2=16.47 //y2=0.175
r2096 (  46 48 ) resistor r=0.235129 //w=0.311 //l=0.585 //layer=m1 \
 //thickness=0.36 //x=16.555 //y=0.175 //x2=17.14 //y2=0.175
r2097 (  45 228 ) resistor r=0.028033 //w=0.35 //l=0.085 //layer=m1 \
 //thickness=0.36 //x=19.715 //y=0.175 //x2=19.8 //y2=0.175
r2098 (  45 50 ) resistor r=0.588826 //w=0.311 //l=1.465 //layer=m1 \
 //thickness=0.36 //x=19.715 //y=0.175 //x2=18.25 //y2=0.175
r2099 (  43 222 ) resistor r=0.0413265 //w=0.7 //l=0.175 //layer=m1 \
 //thickness=0.36 //x=16.47 //y=0.35 //x2=16.47 //y2=0.175
r2100 (  43 220 ) resistor r=0.625 //w=0.131 //l=0.655 //layer=m1 \
 //thickness=0.36 //x=16.47 //y=0.35 //x2=16.47 //y2=1.005
r2101 (  42 366 ) resistor r=3.1 //w=0.17 //l=0.51 //layer=mcon //count=3 \
 //x=16.03 //y=0.18 //x2=16.03 //y2=0.18
r2102 (  40 355 ) resistor r=3.1 //w=0.17 //l=0.51 //layer=mcon //count=3 \
 //x=14.55 //y=0.18 //x2=14.55 //y2=0.18
r2103 (  40 42 ) resistor r=0.594855 //w=0.311 //l=1.48 //layer=m1 \
 //thickness=0.36 //x=14.55 //y=0.175 //x2=16.03 //y2=0.175
r2104 (  38 353 ) resistor r=3.1 //w=0.17 //l=0.51 //layer=mcon //count=3 \
 //x=13.44 //y=0.18 //x2=13.44 //y2=0.18
r2105 (  38 40 ) resistor r=0.446141 //w=0.311 //l=1.11 //layer=m1 \
 //thickness=0.36 //x=13.44 //y=0.175 //x2=14.55 //y2=0.175
r2106 (  36 217 ) resistor r=0.028033 //w=0.35 //l=0.085 //layer=m1 \
 //thickness=0.36 //x=13.225 //y=0.175 //x2=13.14 //y2=0.175
r2107 (  36 38 ) resistor r=0.0864148 //w=0.311 //l=0.215 //layer=m1 \
 //thickness=0.36 //x=13.225 //y=0.175 //x2=13.44 //y2=0.175
r2108 (  35 222 ) resistor r=0.028033 //w=0.35 //l=0.085 //layer=m1 \
 //thickness=0.36 //x=16.385 //y=0.175 //x2=16.47 //y2=0.175
r2109 (  35 42 ) resistor r=0.142685 //w=0.311 //l=0.355 //layer=m1 \
 //thickness=0.36 //x=16.385 //y=0.175 //x2=16.03 //y2=0.175
r2110 (  33 217 ) resistor r=0.0413265 //w=0.7 //l=0.175 //layer=m1 \
 //thickness=0.36 //x=13.14 //y=0.35 //x2=13.14 //y2=0.175
r2111 (  33 215 ) resistor r=0.625 //w=0.131 //l=0.655 //layer=m1 \
 //thickness=0.36 //x=13.14 //y=0.35 //x2=13.14 //y2=1.005
r2112 (  32 351 ) resistor r=3.1 //w=0.17 //l=0.51 //layer=mcon //count=3 \
 //x=12.33 //y=0.18 //x2=12.33 //y2=0.18
r2113 (  30 340 ) resistor r=3.1 //w=0.17 //l=0.51 //layer=mcon //count=3 \
 //x=10.85 //y=0.18 //x2=10.85 //y2=0.18
r2114 (  30 32 ) resistor r=0.594855 //w=0.311 //l=1.48 //layer=m1 \
 //thickness=0.36 //x=10.85 //y=0.175 //x2=12.33 //y2=0.175
r2115 (  28 212 ) resistor r=0.028033 //w=0.35 //l=0.085 //layer=m1 \
 //thickness=0.36 //x=9.895 //y=0.175 //x2=9.81 //y2=0.175
r2116 (  28 30 ) resistor r=0.383842 //w=0.311 //l=0.955 //layer=m1 \
 //thickness=0.36 //x=9.895 //y=0.175 //x2=10.85 //y2=0.175
r2117 (  27 217 ) resistor r=0.028033 //w=0.35 //l=0.085 //layer=m1 \
 //thickness=0.36 //x=13.055 //y=0.175 //x2=13.14 //y2=0.175
r2118 (  27 32 ) resistor r=0.291399 //w=0.311 //l=0.725 //layer=m1 \
 //thickness=0.36 //x=13.055 //y=0.175 //x2=12.33 //y2=0.175
r2119 (  25 212 ) resistor r=0.0413265 //w=0.7 //l=0.175 //layer=m1 \
 //thickness=0.36 //x=9.81 //y=0.35 //x2=9.81 //y2=0.175
r2120 (  25 209 ) resistor r=0.625 //w=0.131 //l=0.655 //layer=m1 \
 //thickness=0.36 //x=9.81 //y=0.35 //x2=9.81 //y2=1.005
r2121 (  24 327 ) resistor r=3.1 //w=0.17 //l=0.51 //layer=mcon //count=3 \
 //x=8.26 //y=0.18 //x2=8.26 //y2=0.18
r2122 (  22 325 ) resistor r=3.1 //w=0.17 //l=0.51 //layer=mcon //count=3 \
 //x=7.15 //y=0.18 //x2=7.15 //y2=0.18
r2123 (  22 24 ) resistor r=0.446141 //w=0.311 //l=1.11 //layer=m1 \
 //thickness=0.36 //x=7.15 //y=0.175 //x2=8.26 //y2=0.175
r2124 (  20 206 ) resistor r=0.028033 //w=0.35 //l=0.085 //layer=m1 \
 //thickness=0.36 //x=6.565 //y=0.175 //x2=6.48 //y2=0.175
r2125 (  20 22 ) resistor r=0.235129 //w=0.311 //l=0.585 //layer=m1 \
 //thickness=0.36 //x=6.565 //y=0.175 //x2=7.15 //y2=0.175
r2126 (  19 212 ) resistor r=0.028033 //w=0.35 //l=0.085 //layer=m1 \
 //thickness=0.36 //x=9.725 //y=0.175 //x2=9.81 //y2=0.175
r2127 (  19 24 ) resistor r=0.588826 //w=0.311 //l=1.465 //layer=m1 \
 //thickness=0.36 //x=9.725 //y=0.175 //x2=8.26 //y2=0.175
r2128 (  17 206 ) resistor r=0.0413265 //w=0.7 //l=0.175 //layer=m1 \
 //thickness=0.36 //x=6.48 //y=0.35 //x2=6.48 //y2=0.175
r2129 (  17 204 ) resistor r=0.625 //w=0.131 //l=0.655 //layer=m1 \
 //thickness=0.36 //x=6.48 //y=0.35 //x2=6.48 //y2=1.005
r2130 (  16 323 ) resistor r=3.1 //w=0.17 //l=0.51 //layer=mcon //count=3 \
 //x=6.04 //y=0.18 //x2=6.04 //y2=0.18
r2131 (  14 312 ) resistor r=3.1 //w=0.17 //l=0.51 //layer=mcon //count=3 \
 //x=4.56 //y=0.18 //x2=4.56 //y2=0.18
r2132 (  14 16 ) resistor r=0.594855 //w=0.311 //l=1.48 //layer=m1 \
 //thickness=0.36 //x=4.56 //y=0.175 //x2=6.04 //y2=0.175
r2133 (  12 310 ) resistor r=3.1 //w=0.17 //l=0.51 //layer=mcon //count=3 \
 //x=3.45 //y=0.18 //x2=3.45 //y2=0.18
r2134 (  12 14 ) resistor r=0.446141 //w=0.311 //l=1.11 //layer=m1 \
 //thickness=0.36 //x=3.45 //y=0.175 //x2=4.56 //y2=0.175
r2135 (  10 308 ) resistor r=3.1 //w=0.17 //l=0.51 //layer=mcon //count=3 \
 //x=2.34 //y=0.18 //x2=2.34 //y2=0.18
r2136 (  10 12 ) resistor r=0.446141 //w=0.311 //l=1.11 //layer=m1 \
 //thickness=0.36 //x=2.34 //y=0.175 //x2=3.45 //y2=0.175
r2137 (  8 201 ) resistor r=0.028033 //w=0.35 //l=0.085 //layer=m1 \
 //thickness=0.36 //x=1.65 //y=0.175 //x2=1.565 //y2=0.175
r2138 (  8 10 ) resistor r=0.277331 //w=0.311 //l=0.69 //layer=m1 \
 //thickness=0.36 //x=1.65 //y=0.175 //x2=2.34 //y2=0.175
r2139 (  7 206 ) resistor r=0.028033 //w=0.35 //l=0.085 //layer=m1 \
 //thickness=0.36 //x=6.395 //y=0.175 //x2=6.48 //y2=0.175
r2140 (  7 16 ) resistor r=0.142685 //w=0.311 //l=0.355 //layer=m1 \
 //thickness=0.36 //x=6.395 //y=0.175 //x2=6.04 //y2=0.175
r2141 (  6 199 ) resistor r=0.0942778 //w=0.221 //l=0.13 //layer=m1 \
 //thickness=0.36 //x=1.565 //y=1.015 //x2=1.565 //y2=1.145
r2142 (  5 201 ) resistor r=0.0413265 //w=0.7 //l=0.175 //layer=m1 \
 //thickness=0.36 //x=1.565 //y=0.35 //x2=1.565 //y2=0.175
r2143 (  5 6 ) resistor r=0.634542 //w=0.131 //l=0.665 //layer=m1 \
 //thickness=0.36 //x=1.565 //y=0.35 //x2=1.565 //y2=1.015
r2144 (  4 306 ) resistor r=3.1 //w=0.17 //l=0.51 //layer=mcon //count=3 \
 //x=1.23 //y=0.18 //x2=1.23 //y2=0.18
r2145 (  2 201 ) resistor r=0.028033 //w=0.35 //l=0.085 //layer=m1 \
 //thickness=0.36 //x=1.48 //y=0.175 //x2=1.565 //y2=0.175
r2146 (  2 4 ) resistor r=0.0892857 //w=0.35 //l=0.25 //layer=m1 \
 //thickness=0.36 //x=1.48 //y=0.175 //x2=1.23 //y2=0.175
r2147 (  1 105 ) resistor r=0.223071 //w=0.311 //l=0.555 //layer=m1 \
 //thickness=0.36 //x=38.785 //y=0.175 //x2=39.34 //y2=0.175
r2148 (  1 102 ) resistor r=0.223071 //w=0.311 //l=0.555 //layer=m1 \
 //thickness=0.36 //x=38.785 //y=0.175 //x2=38.23 //y2=0.175
ends PM_TMRDFFQX1\%GND

subckt PM_TMRDFFQX1\%Q ( 1 2 3 4 5 6 8 10 11 12 13 14 24 34 41 43 )
c80 ( 41 0 ) capacitor c=0.00875839f //x=75.785 //y=1.09
c81 ( 34 0 ) capacitor c=0.0261871f //x=75.975 //y=5.56
c82 ( 24 0 ) capacitor c=0.0196817f //x=75.97 //y=1.185
c83 ( 14 0 ) capacitor c=0.00557311f //x=76.06 //y=5.14
c84 ( 13 0 ) capacitor c=0.00944012f //x=76.255 //y=5.14
c85 ( 12 0 ) capacitor c=0.00724565f //x=76.055 //y=2.02
c86 ( 11 0 ) capacitor c=0.0145753f //x=76.255 //y=2.02
c87 ( 10 0 ) capacitor c=0.0117946f //x=75.975 //y=5.42
c88 ( 8 0 ) capacitor c=0.0166561f //x=75.97 //y=1.935
c89 ( 1 0 ) capacitor c=0.116158f //x=76.34 //y=2.4
r90 (  34 43 ) resistor r=23.615 //w=0.187 //l=0.345 //layer=li \
 //thickness=0.1 //x=75.975 //y=5.56 //x2=75.975 //y2=5.905
r91 (  27 34 ) resistor r=9.3 //w=0.17 //l=0.17 //layer=mcon //count=1 \
 //x=75.975 //y=5.56 //x2=75.975 //y2=5.56
r92 (  24 41 ) resistor r=9.3 //w=0.17 //l=0.17 //layer=mcon //count=1 \
 //x=75.97 //y=1.185 //x2=75.97 //y2=1.185
r93 (  13 16 ) resistor r=0.0698411 //w=0.17 //l=0.120208 //layer=m1 \
 //thickness=0.36 //x=76.255 //y=5.14 //x2=76.34 //y2=5.055
r94 (  13 14 ) resistor r=0.186069 //w=0.131 //l=0.195 //layer=m1 \
 //thickness=0.36 //x=76.255 //y=5.14 //x2=76.06 //y2=5.14
r95 (  11 15 ) resistor r=0.0698411 //w=0.17 //l=0.120208 //layer=m1 \
 //thickness=0.36 //x=76.255 //y=2.02 //x2=76.34 //y2=2.105
r96 (  11 12 ) resistor r=0.19084 //w=0.131 //l=0.2 //layer=m1 \
 //thickness=0.36 //x=76.255 //y=2.02 //x2=76.055 //y2=2.02
r97 (  10 27 ) resistor r=0.086672 //w=0.218 //l=0.14 //layer=m1 \
 //thickness=0.36 //x=75.975 //y=5.42 //x2=75.975 //y2=5.56
r98 (  9 14 ) resistor r=0.0698411 //w=0.17 //l=0.120208 //layer=m1 \
 //thickness=0.36 //x=75.975 //y=5.225 //x2=76.06 //y2=5.14
r99 (  9 10 ) resistor r=0.186069 //w=0.131 //l=0.195 //layer=m1 \
 //thickness=0.36 //x=75.975 //y=5.225 //x2=75.975 //y2=5.42
r100 (  8 12 ) resistor r=0.0698411 //w=0.17 //l=0.120208 //layer=m1 \
 //thickness=0.36 //x=75.97 //y=1.935 //x2=76.055 //y2=2.02
r101 (  7 24 ) resistor r=0.105739 //w=0.201 //l=0.145 //layer=m1 \
 //thickness=0.36 //x=75.97 //y=1.33 //x2=75.97 //y2=1.185
r102 (  7 8 ) resistor r=0.57729 //w=0.131 //l=0.605 //layer=m1 \
 //thickness=0.36 //x=75.97 //y=1.33 //x2=75.97 //y2=1.935
r103 (  6 16 ) resistor r=0.76813 //w=0.131 //l=0.805 //layer=m1 \
 //thickness=0.36 //x=76.34 //y=4.25 //x2=76.34 //y2=5.055
r104 (  5 6 ) resistor r=0.353053 //w=0.131 //l=0.37 //layer=m1 \
 //thickness=0.36 //x=76.34 //y=3.88 //x2=76.34 //y2=4.25
r105 (  4 5 ) resistor r=0.353053 //w=0.131 //l=0.37 //layer=m1 \
 //thickness=0.36 //x=76.34 //y=3.51 //x2=76.34 //y2=3.88
r106 (  3 4 ) resistor r=0.353053 //w=0.131 //l=0.37 //layer=m1 \
 //thickness=0.36 //x=76.34 //y=3.14 //x2=76.34 //y2=3.51
r107 (  2 3 ) resistor r=0.353053 //w=0.131 //l=0.37 //layer=m1 \
 //thickness=0.36 //x=76.34 //y=2.77 //x2=76.34 //y2=3.14
r108 (  1 2 ) resistor r=0.353053 //w=0.131 //l=0.37 //layer=m1 \
 //thickness=0.36 //x=76.34 //y=2.4 //x2=76.34 //y2=2.77
r109 (  1 15 ) resistor r=0.281489 //w=0.131 //l=0.295 //layer=m1 \
 //thickness=0.36 //x=76.34 //y=2.4 //x2=76.34 //y2=2.105
ends PM_TMRDFFQX1\%Q

subckt PM_TMRDFFQX1\%noxref_31 ( 1 5 9 13 17 35 )
c55 ( 35 0 ) capacitor c=0.0721035f //x=0.945 //y=0.555
c56 ( 17 0 ) capacitor c=0.0221074f //x=2.935 //y=1.77
c57 ( 13 0 ) capacitor c=0.0153941f //x=2.935 //y=0.72
c58 ( 9 0 ) capacitor c=0.00772076f //x=2.05 //y=0.805
c59 ( 5 0 ) capacitor c=0.0198571f //x=1.965 //y=1.77
c60 ( 1 0 ) capacitor c=0.0109947f //x=1.08 //y=1.685
r61 (  18 35 ) resistor r=5.4201 //w=0.17 //l=0.103078 //layer=li \
 //thickness=0.1 //x=2.135 //y=1.77 //x2=2.05 //y2=1.81
r62 (  18 35 ) resistor r=27.3797 //w=0.187 //l=0.4 //layer=li //thickness=0.1 \
 //x=2.135 //y=1.77 //x2=2.535 //y2=1.77
r63 (  17 35 ) resistor r=0.751729 //w=0.17 //l=0.085 //layer=li \
 //thickness=0.1 //x=2.935 //y=1.77 //x2=3.02 //y2=1.77
r64 (  17 35 ) resistor r=27.3797 //w=0.187 //l=0.4 //layer=li //thickness=0.1 \
 //x=2.935 //y=1.77 //x2=2.535 //y2=1.77
r65 (  14 35 ) resistor r=3.57586 //w=0.17 //l=0.103078 //layer=li \
 //thickness=0.1 //x=2.135 //y=0.72 //x2=2.05 //y2=0.68
r66 (  14 35 ) resistor r=27.3797 //w=0.187 //l=0.4 //layer=li //thickness=0.1 \
 //x=2.135 //y=0.72 //x2=2.535 //y2=0.72
r67 (  13 35 ) resistor r=0.751729 //w=0.17 //l=0.085 //layer=li \
 //thickness=0.1 //x=2.935 //y=0.72 //x2=3.02 //y2=0.72
r68 (  13 35 ) resistor r=27.3797 //w=0.187 //l=0.4 //layer=li //thickness=0.1 \
 //x=2.935 //y=0.72 //x2=2.535 //y2=0.72
r69 (  10 35 ) resistor r=1.40859 //w=0.34 //l=0.125 //layer=li \
 //thickness=0.1 //x=2.05 //y=1.685 //x2=2.05 //y2=1.81
r70 (  10 35 ) resistor r=42.0963 //w=0.187 //l=0.615 //layer=li \
 //thickness=0.1 //x=2.05 //y=1.685 //x2=2.05 //y2=1.07
r71 (  9 35 ) resistor r=3.57586 //w=0.17 //l=0.125 //layer=li //thickness=0.1 \
 //x=2.05 //y=0.805 //x2=2.05 //y2=0.68
r72 (  9 35 ) resistor r=18.139 //w=0.187 //l=0.265 //layer=li //thickness=0.1 \
 //x=2.05 //y=0.805 //x2=2.05 //y2=1.07
r73 (  6 35 ) resistor r=3.57586 //w=0.17 //l=0.103078 //layer=li \
 //thickness=0.1 //x=1.165 //y=1.77 //x2=1.08 //y2=1.81
r74 (  6 35 ) resistor r=27.3797 //w=0.187 //l=0.4 //layer=li //thickness=0.1 \
 //x=1.165 //y=1.77 //x2=1.565 //y2=1.77
r75 (  5 35 ) resistor r=5.4201 //w=0.17 //l=0.103078 //layer=li \
 //thickness=0.1 //x=1.965 //y=1.77 //x2=2.05 //y2=1.81
r76 (  5 35 ) resistor r=27.3797 //w=0.187 //l=0.4 //layer=li //thickness=0.1 \
 //x=1.965 //y=1.77 //x2=1.565 //y2=1.77
r77 (  1 35 ) resistor r=3.57586 //w=0.17 //l=0.125 //layer=li //thickness=0.1 \
 //x=1.08 //y=1.685 //x2=1.08 //y2=1.81
r78 (  1 35 ) resistor r=42.0963 //w=0.187 //l=0.615 //layer=li \
 //thickness=0.1 //x=1.08 //y=1.685 //x2=1.08 //y2=1.07
ends PM_TMRDFFQX1\%noxref_31

subckt PM_TMRDFFQX1\%noxref_32 ( 1 5 9 10 13 17 29 )
c69 ( 29 0 ) capacitor c=0.0670401f //x=5.86 //y=0.545
c70 ( 17 0 ) capacitor c=0.0067865f //x=7.935 //y=0.795
c71 ( 13 0 ) capacitor c=0.0155043f //x=7.85 //y=0.71
c72 ( 10 0 ) capacitor c=0.0071105f //x=6.965 //y=1.675
c73 ( 9 0 ) capacitor c=0.00770028f //x=6.965 //y=0.795
c74 ( 5 0 ) capacitor c=0.0193892f //x=6.88 //y=1.76
c75 ( 1 0 ) capacitor c=0.00822695f //x=5.995 //y=1.675
r76 (  17 29 ) resistor r=3.57586 //w=0.17 //l=0.125 //layer=li \
 //thickness=0.1 //x=7.935 //y=0.795 //x2=7.935 //y2=0.67
r77 (  17 29 ) resistor r=18.139 //w=0.187 //l=0.265 //layer=li \
 //thickness=0.1 //x=7.935 //y=0.795 //x2=7.935 //y2=1.06
r78 (  14 29 ) resistor r=3.57586 //w=0.17 //l=0.103078 //layer=li \
 //thickness=0.1 //x=7.05 //y=0.71 //x2=6.965 //y2=0.67
r79 (  14 29 ) resistor r=27.3797 //w=0.187 //l=0.4 //layer=li //thickness=0.1 \
 //x=7.05 //y=0.71 //x2=7.45 //y2=0.71
r80 (  13 29 ) resistor r=3.57586 //w=0.17 //l=0.103078 //layer=li \
 //thickness=0.1 //x=7.85 //y=0.71 //x2=7.935 //y2=0.67
r81 (  13 29 ) resistor r=27.3797 //w=0.187 //l=0.4 //layer=li //thickness=0.1 \
 //x=7.85 //y=0.71 //x2=7.45 //y2=0.71
r82 (  10 29 ) resistor r=3.57586 //w=0.17 //l=0.125 //layer=li \
 //thickness=0.1 //x=6.965 //y=1.675 //x2=6.965 //y2=1.8
r83 (  10 29 ) resistor r=42.0963 //w=0.187 //l=0.615 //layer=li \
 //thickness=0.1 //x=6.965 //y=1.675 //x2=6.965 //y2=1.06
r84 (  9 29 ) resistor r=3.57586 //w=0.17 //l=0.125 //layer=li //thickness=0.1 \
 //x=6.965 //y=0.795 //x2=6.965 //y2=0.67
r85 (  9 29 ) resistor r=18.139 //w=0.187 //l=0.265 //layer=li //thickness=0.1 \
 //x=6.965 //y=0.795 //x2=6.965 //y2=1.06
r86 (  6 29 ) resistor r=3.57586 //w=0.17 //l=0.103078 //layer=li \
 //thickness=0.1 //x=6.08 //y=1.76 //x2=5.995 //y2=1.8
r87 (  6 29 ) resistor r=27.3797 //w=0.187 //l=0.4 //layer=li //thickness=0.1 \
 //x=6.08 //y=1.76 //x2=6.48 //y2=1.76
r88 (  5 29 ) resistor r=3.57586 //w=0.17 //l=0.103078 //layer=li \
 //thickness=0.1 //x=6.88 //y=1.76 //x2=6.965 //y2=1.8
r89 (  5 29 ) resistor r=27.3797 //w=0.187 //l=0.4 //layer=li //thickness=0.1 \
 //x=6.88 //y=1.76 //x2=6.48 //y2=1.76
r90 (  1 29 ) resistor r=3.57586 //w=0.17 //l=0.125 //layer=li //thickness=0.1 \
 //x=5.995 //y=1.675 //x2=5.995 //y2=1.8
r91 (  1 29 ) resistor r=42.0963 //w=0.187 //l=0.615 //layer=li \
 //thickness=0.1 //x=5.995 //y=1.675 //x2=5.995 //y2=1.06
ends PM_TMRDFFQX1\%noxref_32

subckt PM_TMRDFFQX1\%noxref_33 ( 1 5 9 10 13 17 29 )
c69 ( 29 0 ) capacitor c=0.0667368f //x=9.19 //y=0.545
c70 ( 17 0 ) capacitor c=0.0067865f //x=11.265 //y=0.795
c71 ( 13 0 ) capacitor c=0.0156591f //x=11.18 //y=0.71
c72 ( 10 0 ) capacitor c=0.00687366f //x=10.295 //y=1.675
c73 ( 9 0 ) capacitor c=0.00770028f //x=10.295 //y=0.795
c74 ( 5 0 ) capacitor c=0.0183675f //x=10.21 //y=1.76
c75 ( 1 0 ) capacitor c=0.00776954f //x=9.325 //y=1.675
r76 (  17 29 ) resistor r=3.57586 //w=0.17 //l=0.125 //layer=li \
 //thickness=0.1 //x=11.265 //y=0.795 //x2=11.265 //y2=0.67
r77 (  17 29 ) resistor r=18.139 //w=0.187 //l=0.265 //layer=li \
 //thickness=0.1 //x=11.265 //y=0.795 //x2=11.265 //y2=1.06
r78 (  14 29 ) resistor r=3.57586 //w=0.17 //l=0.103078 //layer=li \
 //thickness=0.1 //x=10.38 //y=0.71 //x2=10.295 //y2=0.67
r79 (  14 29 ) resistor r=27.3797 //w=0.187 //l=0.4 //layer=li //thickness=0.1 \
 //x=10.38 //y=0.71 //x2=10.78 //y2=0.71
r80 (  13 29 ) resistor r=3.57586 //w=0.17 //l=0.103078 //layer=li \
 //thickness=0.1 //x=11.18 //y=0.71 //x2=11.265 //y2=0.67
r81 (  13 29 ) resistor r=27.3797 //w=0.187 //l=0.4 //layer=li //thickness=0.1 \
 //x=11.18 //y=0.71 //x2=10.78 //y2=0.71
r82 (  10 29 ) resistor r=3.57586 //w=0.17 //l=0.125 //layer=li \
 //thickness=0.1 //x=10.295 //y=1.675 //x2=10.295 //y2=1.8
r83 (  10 29 ) resistor r=42.0963 //w=0.187 //l=0.615 //layer=li \
 //thickness=0.1 //x=10.295 //y=1.675 //x2=10.295 //y2=1.06
r84 (  9 29 ) resistor r=3.57586 //w=0.17 //l=0.125 //layer=li //thickness=0.1 \
 //x=10.295 //y=0.795 //x2=10.295 //y2=0.67
r85 (  9 29 ) resistor r=18.139 //w=0.187 //l=0.265 //layer=li //thickness=0.1 \
 //x=10.295 //y=0.795 //x2=10.295 //y2=1.06
r86 (  6 29 ) resistor r=3.57586 //w=0.17 //l=0.103078 //layer=li \
 //thickness=0.1 //x=9.41 //y=1.76 //x2=9.325 //y2=1.8
r87 (  6 29 ) resistor r=27.3797 //w=0.187 //l=0.4 //layer=li //thickness=0.1 \
 //x=9.41 //y=1.76 //x2=9.81 //y2=1.76
r88 (  5 29 ) resistor r=3.57586 //w=0.17 //l=0.103078 //layer=li \
 //thickness=0.1 //x=10.21 //y=1.76 //x2=10.295 //y2=1.8
r89 (  5 29 ) resistor r=27.3797 //w=0.187 //l=0.4 //layer=li //thickness=0.1 \
 //x=10.21 //y=1.76 //x2=9.81 //y2=1.76
r90 (  1 29 ) resistor r=3.57586 //w=0.17 //l=0.125 //layer=li //thickness=0.1 \
 //x=9.325 //y=1.675 //x2=9.325 //y2=1.8
r91 (  1 29 ) resistor r=42.0963 //w=0.187 //l=0.615 //layer=li \
 //thickness=0.1 //x=9.325 //y=1.675 //x2=9.325 //y2=1.06
ends PM_TMRDFFQX1\%noxref_33

subckt PM_TMRDFFQX1\%noxref_34 ( 1 5 9 10 13 17 29 )
c68 ( 29 0 ) capacitor c=0.0671104f //x=12.52 //y=0.545
c69 ( 17 0 ) capacitor c=0.0067865f //x=14.595 //y=0.795
c70 ( 13 0 ) capacitor c=0.0155242f //x=14.51 //y=0.71
c71 ( 10 0 ) capacitor c=0.0069736f //x=13.625 //y=1.675
c72 ( 9 0 ) capacitor c=0.00770028f //x=13.625 //y=0.795
c73 ( 5 0 ) capacitor c=0.0183675f //x=13.54 //y=1.76
c74 ( 1 0 ) capacitor c=0.00776954f //x=12.655 //y=1.675
r75 (  17 29 ) resistor r=3.57586 //w=0.17 //l=0.125 //layer=li \
 //thickness=0.1 //x=14.595 //y=0.795 //x2=14.595 //y2=0.67
r76 (  17 29 ) resistor r=18.139 //w=0.187 //l=0.265 //layer=li \
 //thickness=0.1 //x=14.595 //y=0.795 //x2=14.595 //y2=1.06
r77 (  14 29 ) resistor r=3.57586 //w=0.17 //l=0.103078 //layer=li \
 //thickness=0.1 //x=13.71 //y=0.71 //x2=13.625 //y2=0.67
r78 (  14 29 ) resistor r=27.3797 //w=0.187 //l=0.4 //layer=li //thickness=0.1 \
 //x=13.71 //y=0.71 //x2=14.11 //y2=0.71
r79 (  13 29 ) resistor r=3.57586 //w=0.17 //l=0.103078 //layer=li \
 //thickness=0.1 //x=14.51 //y=0.71 //x2=14.595 //y2=0.67
r80 (  13 29 ) resistor r=27.3797 //w=0.187 //l=0.4 //layer=li //thickness=0.1 \
 //x=14.51 //y=0.71 //x2=14.11 //y2=0.71
r81 (  10 29 ) resistor r=3.57586 //w=0.17 //l=0.125 //layer=li \
 //thickness=0.1 //x=13.625 //y=1.675 //x2=13.625 //y2=1.8
r82 (  10 29 ) resistor r=42.0963 //w=0.187 //l=0.615 //layer=li \
 //thickness=0.1 //x=13.625 //y=1.675 //x2=13.625 //y2=1.06
r83 (  9 29 ) resistor r=3.57586 //w=0.17 //l=0.125 //layer=li //thickness=0.1 \
 //x=13.625 //y=0.795 //x2=13.625 //y2=0.67
r84 (  9 29 ) resistor r=18.139 //w=0.187 //l=0.265 //layer=li //thickness=0.1 \
 //x=13.625 //y=0.795 //x2=13.625 //y2=1.06
r85 (  6 29 ) resistor r=3.57586 //w=0.17 //l=0.103078 //layer=li \
 //thickness=0.1 //x=12.74 //y=1.76 //x2=12.655 //y2=1.8
r86 (  6 29 ) resistor r=27.3797 //w=0.187 //l=0.4 //layer=li //thickness=0.1 \
 //x=12.74 //y=1.76 //x2=13.14 //y2=1.76
r87 (  5 29 ) resistor r=3.57586 //w=0.17 //l=0.103078 //layer=li \
 //thickness=0.1 //x=13.54 //y=1.76 //x2=13.625 //y2=1.8
r88 (  5 29 ) resistor r=27.3797 //w=0.187 //l=0.4 //layer=li //thickness=0.1 \
 //x=13.54 //y=1.76 //x2=13.14 //y2=1.76
r89 (  1 29 ) resistor r=3.57586 //w=0.17 //l=0.125 //layer=li //thickness=0.1 \
 //x=12.655 //y=1.675 //x2=12.655 //y2=1.8
r90 (  1 29 ) resistor r=42.0963 //w=0.187 //l=0.615 //layer=li \
 //thickness=0.1 //x=12.655 //y=1.675 //x2=12.655 //y2=1.06
ends PM_TMRDFFQX1\%noxref_34

subckt PM_TMRDFFQX1\%noxref_35 ( 1 5 9 10 13 17 29 )
c70 ( 29 0 ) capacitor c=0.0669409f //x=15.85 //y=0.545
c71 ( 17 0 ) capacitor c=0.0067865f //x=17.925 //y=0.795
c72 ( 13 0 ) capacitor c=0.0155242f //x=17.84 //y=0.71
c73 ( 10 0 ) capacitor c=0.00684707f //x=16.955 //y=1.675
c74 ( 9 0 ) capacitor c=0.00770028f //x=16.955 //y=0.795
c75 ( 5 0 ) capacitor c=0.0183675f //x=16.87 //y=1.76
c76 ( 1 0 ) capacitor c=0.00776954f //x=15.985 //y=1.675
r77 (  17 29 ) resistor r=3.57586 //w=0.17 //l=0.125 //layer=li \
 //thickness=0.1 //x=17.925 //y=0.795 //x2=17.925 //y2=0.67
r78 (  17 29 ) resistor r=18.139 //w=0.187 //l=0.265 //layer=li \
 //thickness=0.1 //x=17.925 //y=0.795 //x2=17.925 //y2=1.06
r79 (  14 29 ) resistor r=3.57586 //w=0.17 //l=0.103078 //layer=li \
 //thickness=0.1 //x=17.04 //y=0.71 //x2=16.955 //y2=0.67
r80 (  14 29 ) resistor r=27.3797 //w=0.187 //l=0.4 //layer=li //thickness=0.1 \
 //x=17.04 //y=0.71 //x2=17.44 //y2=0.71
r81 (  13 29 ) resistor r=3.57586 //w=0.17 //l=0.103078 //layer=li \
 //thickness=0.1 //x=17.84 //y=0.71 //x2=17.925 //y2=0.67
r82 (  13 29 ) resistor r=27.3797 //w=0.187 //l=0.4 //layer=li //thickness=0.1 \
 //x=17.84 //y=0.71 //x2=17.44 //y2=0.71
r83 (  10 29 ) resistor r=3.57586 //w=0.17 //l=0.125 //layer=li \
 //thickness=0.1 //x=16.955 //y=1.675 //x2=16.955 //y2=1.8
r84 (  10 29 ) resistor r=42.0963 //w=0.187 //l=0.615 //layer=li \
 //thickness=0.1 //x=16.955 //y=1.675 //x2=16.955 //y2=1.06
r85 (  9 29 ) resistor r=3.57586 //w=0.17 //l=0.125 //layer=li //thickness=0.1 \
 //x=16.955 //y=0.795 //x2=16.955 //y2=0.67
r86 (  9 29 ) resistor r=18.139 //w=0.187 //l=0.265 //layer=li //thickness=0.1 \
 //x=16.955 //y=0.795 //x2=16.955 //y2=1.06
r87 (  6 29 ) resistor r=3.57586 //w=0.17 //l=0.103078 //layer=li \
 //thickness=0.1 //x=16.07 //y=1.76 //x2=15.985 //y2=1.8
r88 (  6 29 ) resistor r=27.3797 //w=0.187 //l=0.4 //layer=li //thickness=0.1 \
 //x=16.07 //y=1.76 //x2=16.47 //y2=1.76
r89 (  5 29 ) resistor r=3.57586 //w=0.17 //l=0.103078 //layer=li \
 //thickness=0.1 //x=16.87 //y=1.76 //x2=16.955 //y2=1.8
r90 (  5 29 ) resistor r=27.3797 //w=0.187 //l=0.4 //layer=li //thickness=0.1 \
 //x=16.87 //y=1.76 //x2=16.47 //y2=1.76
r91 (  1 29 ) resistor r=3.57586 //w=0.17 //l=0.125 //layer=li //thickness=0.1 \
 //x=15.985 //y=1.675 //x2=15.985 //y2=1.8
r92 (  1 29 ) resistor r=42.0963 //w=0.187 //l=0.615 //layer=li \
 //thickness=0.1 //x=15.985 //y=1.675 //x2=15.985 //y2=1.06
ends PM_TMRDFFQX1\%noxref_35

subckt PM_TMRDFFQX1\%noxref_36 ( 1 5 9 10 13 17 29 )
c69 ( 29 0 ) capacitor c=0.0665675f //x=19.18 //y=0.545
c70 ( 17 0 ) capacitor c=0.00675704f //x=21.255 //y=0.795
c71 ( 13 0 ) capacitor c=0.0156444f //x=21.17 //y=0.71
c72 ( 10 0 ) capacitor c=0.00687366f //x=20.285 //y=1.675
c73 ( 9 0 ) capacitor c=0.00770028f //x=20.285 //y=0.795
c74 ( 5 0 ) capacitor c=0.0183675f //x=20.2 //y=1.76
c75 ( 1 0 ) capacitor c=0.00776954f //x=19.315 //y=1.675
r76 (  17 29 ) resistor r=3.57586 //w=0.17 //l=0.125 //layer=li \
 //thickness=0.1 //x=21.255 //y=0.795 //x2=21.255 //y2=0.67
r77 (  17 29 ) resistor r=18.139 //w=0.187 //l=0.265 //layer=li \
 //thickness=0.1 //x=21.255 //y=0.795 //x2=21.255 //y2=1.06
r78 (  14 29 ) resistor r=3.57586 //w=0.17 //l=0.103078 //layer=li \
 //thickness=0.1 //x=20.37 //y=0.71 //x2=20.285 //y2=0.67
r79 (  14 29 ) resistor r=27.3797 //w=0.187 //l=0.4 //layer=li //thickness=0.1 \
 //x=20.37 //y=0.71 //x2=20.77 //y2=0.71
r80 (  13 29 ) resistor r=3.57586 //w=0.17 //l=0.103078 //layer=li \
 //thickness=0.1 //x=21.17 //y=0.71 //x2=21.255 //y2=0.67
r81 (  13 29 ) resistor r=27.3797 //w=0.187 //l=0.4 //layer=li //thickness=0.1 \
 //x=21.17 //y=0.71 //x2=20.77 //y2=0.71
r82 (  10 29 ) resistor r=3.57586 //w=0.17 //l=0.125 //layer=li \
 //thickness=0.1 //x=20.285 //y=1.675 //x2=20.285 //y2=1.8
r83 (  10 29 ) resistor r=42.0963 //w=0.187 //l=0.615 //layer=li \
 //thickness=0.1 //x=20.285 //y=1.675 //x2=20.285 //y2=1.06
r84 (  9 29 ) resistor r=3.57586 //w=0.17 //l=0.125 //layer=li //thickness=0.1 \
 //x=20.285 //y=0.795 //x2=20.285 //y2=0.67
r85 (  9 29 ) resistor r=18.139 //w=0.187 //l=0.265 //layer=li //thickness=0.1 \
 //x=20.285 //y=0.795 //x2=20.285 //y2=1.06
r86 (  6 29 ) resistor r=3.57586 //w=0.17 //l=0.103078 //layer=li \
 //thickness=0.1 //x=19.4 //y=1.76 //x2=19.315 //y2=1.8
r87 (  6 29 ) resistor r=27.3797 //w=0.187 //l=0.4 //layer=li //thickness=0.1 \
 //x=19.4 //y=1.76 //x2=19.8 //y2=1.76
r88 (  5 29 ) resistor r=3.57586 //w=0.17 //l=0.103078 //layer=li \
 //thickness=0.1 //x=20.2 //y=1.76 //x2=20.285 //y2=1.8
r89 (  5 29 ) resistor r=27.3797 //w=0.187 //l=0.4 //layer=li //thickness=0.1 \
 //x=20.2 //y=1.76 //x2=19.8 //y2=1.76
r90 (  1 29 ) resistor r=3.57586 //w=0.17 //l=0.125 //layer=li //thickness=0.1 \
 //x=19.315 //y=1.675 //x2=19.315 //y2=1.8
r91 (  1 29 ) resistor r=42.0963 //w=0.187 //l=0.615 //layer=li \
 //thickness=0.1 //x=19.315 //y=1.675 //x2=19.315 //y2=1.06
ends PM_TMRDFFQX1\%noxref_36

subckt PM_TMRDFFQX1\%noxref_37 ( 1 5 9 13 17 35 )
c59 ( 35 0 ) capacitor c=0.0692064f //x=22.405 //y=0.555
c60 ( 17 0 ) capacitor c=0.0195855f //x=24.395 //y=1.77
c61 ( 13 0 ) capacitor c=0.015342f //x=24.395 //y=0.72
c62 ( 9 0 ) capacitor c=0.00772076f //x=23.51 //y=0.805
c63 ( 5 0 ) capacitor c=0.0171871f //x=23.425 //y=1.77
c64 ( 1 0 ) capacitor c=0.00726193f //x=22.54 //y=1.685
r65 (  18 35 ) resistor r=5.4201 //w=0.17 //l=0.103078 //layer=li \
 //thickness=0.1 //x=23.595 //y=1.77 //x2=23.51 //y2=1.81
r66 (  18 35 ) resistor r=27.3797 //w=0.187 //l=0.4 //layer=li //thickness=0.1 \
 //x=23.595 //y=1.77 //x2=23.995 //y2=1.77
r67 (  17 35 ) resistor r=0.751729 //w=0.17 //l=0.085 //layer=li \
 //thickness=0.1 //x=24.395 //y=1.77 //x2=24.48 //y2=1.77
r68 (  17 35 ) resistor r=27.3797 //w=0.187 //l=0.4 //layer=li //thickness=0.1 \
 //x=24.395 //y=1.77 //x2=23.995 //y2=1.77
r69 (  14 35 ) resistor r=3.57586 //w=0.17 //l=0.103078 //layer=li \
 //thickness=0.1 //x=23.595 //y=0.72 //x2=23.51 //y2=0.68
r70 (  14 35 ) resistor r=27.3797 //w=0.187 //l=0.4 //layer=li //thickness=0.1 \
 //x=23.595 //y=0.72 //x2=23.995 //y2=0.72
r71 (  13 35 ) resistor r=0.751729 //w=0.17 //l=0.085 //layer=li \
 //thickness=0.1 //x=24.395 //y=0.72 //x2=24.48 //y2=0.72
r72 (  13 35 ) resistor r=27.3797 //w=0.187 //l=0.4 //layer=li //thickness=0.1 \
 //x=24.395 //y=0.72 //x2=23.995 //y2=0.72
r73 (  10 35 ) resistor r=1.40859 //w=0.34 //l=0.125 //layer=li \
 //thickness=0.1 //x=23.51 //y=1.685 //x2=23.51 //y2=1.81
r74 (  10 35 ) resistor r=42.0963 //w=0.187 //l=0.615 //layer=li \
 //thickness=0.1 //x=23.51 //y=1.685 //x2=23.51 //y2=1.07
r75 (  9 35 ) resistor r=3.57586 //w=0.17 //l=0.125 //layer=li //thickness=0.1 \
 //x=23.51 //y=0.805 //x2=23.51 //y2=0.68
r76 (  9 35 ) resistor r=18.139 //w=0.187 //l=0.265 //layer=li //thickness=0.1 \
 //x=23.51 //y=0.805 //x2=23.51 //y2=1.07
r77 (  6 35 ) resistor r=3.57586 //w=0.17 //l=0.103078 //layer=li \
 //thickness=0.1 //x=22.625 //y=1.77 //x2=22.54 //y2=1.81
r78 (  6 35 ) resistor r=27.3797 //w=0.187 //l=0.4 //layer=li //thickness=0.1 \
 //x=22.625 //y=1.77 //x2=23.025 //y2=1.77
r79 (  5 35 ) resistor r=5.4201 //w=0.17 //l=0.103078 //layer=li \
 //thickness=0.1 //x=23.425 //y=1.77 //x2=23.51 //y2=1.81
r80 (  5 35 ) resistor r=27.3797 //w=0.187 //l=0.4 //layer=li //thickness=0.1 \
 //x=23.425 //y=1.77 //x2=23.025 //y2=1.77
r81 (  1 35 ) resistor r=3.57586 //w=0.17 //l=0.125 //layer=li //thickness=0.1 \
 //x=22.54 //y=1.685 //x2=22.54 //y2=1.81
r82 (  1 35 ) resistor r=42.0963 //w=0.187 //l=0.615 //layer=li \
 //thickness=0.1 //x=22.54 //y=1.685 //x2=22.54 //y2=1.07
ends PM_TMRDFFQX1\%noxref_37

subckt PM_TMRDFFQX1\%noxref_38 ( 1 5 9 10 13 17 29 )
c68 ( 29 0 ) capacitor c=0.0670401f //x=27.32 //y=0.545
c69 ( 17 0 ) capacitor c=0.0067865f //x=29.395 //y=0.795
c70 ( 13 0 ) capacitor c=0.0155056f //x=29.31 //y=0.71
c71 ( 10 0 ) capacitor c=0.00675634f //x=28.425 //y=1.675
c72 ( 9 0 ) capacitor c=0.00770028f //x=28.425 //y=0.795
c73 ( 5 0 ) capacitor c=0.0183675f //x=28.34 //y=1.76
c74 ( 1 0 ) capacitor c=0.00777933f //x=27.455 //y=1.675
r75 (  17 29 ) resistor r=3.57586 //w=0.17 //l=0.125 //layer=li \
 //thickness=0.1 //x=29.395 //y=0.795 //x2=29.395 //y2=0.67
r76 (  17 29 ) resistor r=18.139 //w=0.187 //l=0.265 //layer=li \
 //thickness=0.1 //x=29.395 //y=0.795 //x2=29.395 //y2=1.06
r77 (  14 29 ) resistor r=3.57586 //w=0.17 //l=0.103078 //layer=li \
 //thickness=0.1 //x=28.51 //y=0.71 //x2=28.425 //y2=0.67
r78 (  14 29 ) resistor r=27.3797 //w=0.187 //l=0.4 //layer=li //thickness=0.1 \
 //x=28.51 //y=0.71 //x2=28.91 //y2=0.71
r79 (  13 29 ) resistor r=3.57586 //w=0.17 //l=0.103078 //layer=li \
 //thickness=0.1 //x=29.31 //y=0.71 //x2=29.395 //y2=0.67
r80 (  13 29 ) resistor r=27.3797 //w=0.187 //l=0.4 //layer=li //thickness=0.1 \
 //x=29.31 //y=0.71 //x2=28.91 //y2=0.71
r81 (  10 29 ) resistor r=3.57586 //w=0.17 //l=0.125 //layer=li \
 //thickness=0.1 //x=28.425 //y=1.675 //x2=28.425 //y2=1.8
r82 (  10 29 ) resistor r=42.0963 //w=0.187 //l=0.615 //layer=li \
 //thickness=0.1 //x=28.425 //y=1.675 //x2=28.425 //y2=1.06
r83 (  9 29 ) resistor r=3.57586 //w=0.17 //l=0.125 //layer=li //thickness=0.1 \
 //x=28.425 //y=0.795 //x2=28.425 //y2=0.67
r84 (  9 29 ) resistor r=18.139 //w=0.187 //l=0.265 //layer=li //thickness=0.1 \
 //x=28.425 //y=0.795 //x2=28.425 //y2=1.06
r85 (  6 29 ) resistor r=3.57586 //w=0.17 //l=0.103078 //layer=li \
 //thickness=0.1 //x=27.54 //y=1.76 //x2=27.455 //y2=1.8
r86 (  6 29 ) resistor r=27.3797 //w=0.187 //l=0.4 //layer=li //thickness=0.1 \
 //x=27.54 //y=1.76 //x2=27.94 //y2=1.76
r87 (  5 29 ) resistor r=3.57586 //w=0.17 //l=0.103078 //layer=li \
 //thickness=0.1 //x=28.34 //y=1.76 //x2=28.425 //y2=1.8
r88 (  5 29 ) resistor r=27.3797 //w=0.187 //l=0.4 //layer=li //thickness=0.1 \
 //x=28.34 //y=1.76 //x2=27.94 //y2=1.76
r89 (  1 29 ) resistor r=3.57586 //w=0.17 //l=0.125 //layer=li //thickness=0.1 \
 //x=27.455 //y=1.675 //x2=27.455 //y2=1.8
r90 (  1 29 ) resistor r=42.0963 //w=0.187 //l=0.615 //layer=li \
 //thickness=0.1 //x=27.455 //y=1.675 //x2=27.455 //y2=1.06
ends PM_TMRDFFQX1\%noxref_38

subckt PM_TMRDFFQX1\%noxref_39 ( 1 5 9 10 13 17 29 )
c69 ( 29 0 ) capacitor c=0.0667368f //x=30.65 //y=0.545
c70 ( 17 0 ) capacitor c=0.0067865f //x=32.725 //y=0.795
c71 ( 13 0 ) capacitor c=0.0156591f //x=32.64 //y=0.71
c72 ( 10 0 ) capacitor c=0.00687366f //x=31.755 //y=1.675
c73 ( 9 0 ) capacitor c=0.00770028f //x=31.755 //y=0.795
c74 ( 5 0 ) capacitor c=0.0183675f //x=31.67 //y=1.76
c75 ( 1 0 ) capacitor c=0.00776954f //x=30.785 //y=1.675
r76 (  17 29 ) resistor r=3.57586 //w=0.17 //l=0.125 //layer=li \
 //thickness=0.1 //x=32.725 //y=0.795 //x2=32.725 //y2=0.67
r77 (  17 29 ) resistor r=18.139 //w=0.187 //l=0.265 //layer=li \
 //thickness=0.1 //x=32.725 //y=0.795 //x2=32.725 //y2=1.06
r78 (  14 29 ) resistor r=3.57586 //w=0.17 //l=0.103078 //layer=li \
 //thickness=0.1 //x=31.84 //y=0.71 //x2=31.755 //y2=0.67
r79 (  14 29 ) resistor r=27.3797 //w=0.187 //l=0.4 //layer=li //thickness=0.1 \
 //x=31.84 //y=0.71 //x2=32.24 //y2=0.71
r80 (  13 29 ) resistor r=3.57586 //w=0.17 //l=0.103078 //layer=li \
 //thickness=0.1 //x=32.64 //y=0.71 //x2=32.725 //y2=0.67
r81 (  13 29 ) resistor r=27.3797 //w=0.187 //l=0.4 //layer=li //thickness=0.1 \
 //x=32.64 //y=0.71 //x2=32.24 //y2=0.71
r82 (  10 29 ) resistor r=3.57586 //w=0.17 //l=0.125 //layer=li \
 //thickness=0.1 //x=31.755 //y=1.675 //x2=31.755 //y2=1.8
r83 (  10 29 ) resistor r=42.0963 //w=0.187 //l=0.615 //layer=li \
 //thickness=0.1 //x=31.755 //y=1.675 //x2=31.755 //y2=1.06
r84 (  9 29 ) resistor r=3.57586 //w=0.17 //l=0.125 //layer=li //thickness=0.1 \
 //x=31.755 //y=0.795 //x2=31.755 //y2=0.67
r85 (  9 29 ) resistor r=18.139 //w=0.187 //l=0.265 //layer=li //thickness=0.1 \
 //x=31.755 //y=0.795 //x2=31.755 //y2=1.06
r86 (  6 29 ) resistor r=3.57586 //w=0.17 //l=0.103078 //layer=li \
 //thickness=0.1 //x=30.87 //y=1.76 //x2=30.785 //y2=1.8
r87 (  6 29 ) resistor r=27.3797 //w=0.187 //l=0.4 //layer=li //thickness=0.1 \
 //x=30.87 //y=1.76 //x2=31.27 //y2=1.76
r88 (  5 29 ) resistor r=3.57586 //w=0.17 //l=0.103078 //layer=li \
 //thickness=0.1 //x=31.67 //y=1.76 //x2=31.755 //y2=1.8
r89 (  5 29 ) resistor r=27.3797 //w=0.187 //l=0.4 //layer=li //thickness=0.1 \
 //x=31.67 //y=1.76 //x2=31.27 //y2=1.76
r90 (  1 29 ) resistor r=3.57586 //w=0.17 //l=0.125 //layer=li //thickness=0.1 \
 //x=30.785 //y=1.675 //x2=30.785 //y2=1.8
r91 (  1 29 ) resistor r=42.0963 //w=0.187 //l=0.615 //layer=li \
 //thickness=0.1 //x=30.785 //y=1.675 //x2=30.785 //y2=1.06
ends PM_TMRDFFQX1\%noxref_39

subckt PM_TMRDFFQX1\%noxref_40 ( 1 5 9 10 13 17 29 )
c68 ( 29 0 ) capacitor c=0.0671104f //x=33.98 //y=0.545
c69 ( 17 0 ) capacitor c=0.0067865f //x=36.055 //y=0.795
c70 ( 13 0 ) capacitor c=0.0155242f //x=35.97 //y=0.71
c71 ( 10 0 ) capacitor c=0.0069736f //x=35.085 //y=1.675
c72 ( 9 0 ) capacitor c=0.00770028f //x=35.085 //y=0.795
c73 ( 5 0 ) capacitor c=0.0183675f //x=35 //y=1.76
c74 ( 1 0 ) capacitor c=0.00776954f //x=34.115 //y=1.675
r75 (  17 29 ) resistor r=3.57586 //w=0.17 //l=0.125 //layer=li \
 //thickness=0.1 //x=36.055 //y=0.795 //x2=36.055 //y2=0.67
r76 (  17 29 ) resistor r=18.139 //w=0.187 //l=0.265 //layer=li \
 //thickness=0.1 //x=36.055 //y=0.795 //x2=36.055 //y2=1.06
r77 (  14 29 ) resistor r=3.57586 //w=0.17 //l=0.103078 //layer=li \
 //thickness=0.1 //x=35.17 //y=0.71 //x2=35.085 //y2=0.67
r78 (  14 29 ) resistor r=27.3797 //w=0.187 //l=0.4 //layer=li //thickness=0.1 \
 //x=35.17 //y=0.71 //x2=35.57 //y2=0.71
r79 (  13 29 ) resistor r=3.57586 //w=0.17 //l=0.103078 //layer=li \
 //thickness=0.1 //x=35.97 //y=0.71 //x2=36.055 //y2=0.67
r80 (  13 29 ) resistor r=27.3797 //w=0.187 //l=0.4 //layer=li //thickness=0.1 \
 //x=35.97 //y=0.71 //x2=35.57 //y2=0.71
r81 (  10 29 ) resistor r=3.57586 //w=0.17 //l=0.125 //layer=li \
 //thickness=0.1 //x=35.085 //y=1.675 //x2=35.085 //y2=1.8
r82 (  10 29 ) resistor r=42.0963 //w=0.187 //l=0.615 //layer=li \
 //thickness=0.1 //x=35.085 //y=1.675 //x2=35.085 //y2=1.06
r83 (  9 29 ) resistor r=3.57586 //w=0.17 //l=0.125 //layer=li //thickness=0.1 \
 //x=35.085 //y=0.795 //x2=35.085 //y2=0.67
r84 (  9 29 ) resistor r=18.139 //w=0.187 //l=0.265 //layer=li //thickness=0.1 \
 //x=35.085 //y=0.795 //x2=35.085 //y2=1.06
r85 (  6 29 ) resistor r=3.57586 //w=0.17 //l=0.103078 //layer=li \
 //thickness=0.1 //x=34.2 //y=1.76 //x2=34.115 //y2=1.8
r86 (  6 29 ) resistor r=27.3797 //w=0.187 //l=0.4 //layer=li //thickness=0.1 \
 //x=34.2 //y=1.76 //x2=34.6 //y2=1.76
r87 (  5 29 ) resistor r=3.57586 //w=0.17 //l=0.103078 //layer=li \
 //thickness=0.1 //x=35 //y=1.76 //x2=35.085 //y2=1.8
r88 (  5 29 ) resistor r=27.3797 //w=0.187 //l=0.4 //layer=li //thickness=0.1 \
 //x=35 //y=1.76 //x2=34.6 //y2=1.76
r89 (  1 29 ) resistor r=3.57586 //w=0.17 //l=0.125 //layer=li //thickness=0.1 \
 //x=34.115 //y=1.675 //x2=34.115 //y2=1.8
r90 (  1 29 ) resistor r=42.0963 //w=0.187 //l=0.615 //layer=li \
 //thickness=0.1 //x=34.115 //y=1.675 //x2=34.115 //y2=1.06
ends PM_TMRDFFQX1\%noxref_40

subckt PM_TMRDFFQX1\%noxref_41 ( 1 5 9 10 13 17 29 )
c68 ( 29 0 ) capacitor c=0.0668841f //x=37.31 //y=0.545
c69 ( 17 0 ) capacitor c=0.0067865f //x=39.385 //y=0.795
c70 ( 13 0 ) capacitor c=0.0154839f //x=39.3 //y=0.71
c71 ( 10 0 ) capacitor c=0.00665309f //x=38.415 //y=1.675
c72 ( 9 0 ) capacitor c=0.00770028f //x=38.415 //y=0.795
c73 ( 5 0 ) capacitor c=0.0183675f //x=38.33 //y=1.76
c74 ( 1 0 ) capacitor c=0.00776954f //x=37.445 //y=1.675
r75 (  17 29 ) resistor r=3.57586 //w=0.17 //l=0.125 //layer=li \
 //thickness=0.1 //x=39.385 //y=0.795 //x2=39.385 //y2=0.67
r76 (  17 29 ) resistor r=18.139 //w=0.187 //l=0.265 //layer=li \
 //thickness=0.1 //x=39.385 //y=0.795 //x2=39.385 //y2=1.06
r77 (  14 29 ) resistor r=3.57586 //w=0.17 //l=0.103078 //layer=li \
 //thickness=0.1 //x=38.5 //y=0.71 //x2=38.415 //y2=0.67
r78 (  14 29 ) resistor r=27.3797 //w=0.187 //l=0.4 //layer=li //thickness=0.1 \
 //x=38.5 //y=0.71 //x2=38.9 //y2=0.71
r79 (  13 29 ) resistor r=3.57586 //w=0.17 //l=0.103078 //layer=li \
 //thickness=0.1 //x=39.3 //y=0.71 //x2=39.385 //y2=0.67
r80 (  13 29 ) resistor r=27.3797 //w=0.187 //l=0.4 //layer=li //thickness=0.1 \
 //x=39.3 //y=0.71 //x2=38.9 //y2=0.71
r81 (  10 29 ) resistor r=3.57586 //w=0.17 //l=0.125 //layer=li \
 //thickness=0.1 //x=38.415 //y=1.675 //x2=38.415 //y2=1.8
r82 (  10 29 ) resistor r=42.0963 //w=0.187 //l=0.615 //layer=li \
 //thickness=0.1 //x=38.415 //y=1.675 //x2=38.415 //y2=1.06
r83 (  9 29 ) resistor r=3.57586 //w=0.17 //l=0.125 //layer=li //thickness=0.1 \
 //x=38.415 //y=0.795 //x2=38.415 //y2=0.67
r84 (  9 29 ) resistor r=18.139 //w=0.187 //l=0.265 //layer=li //thickness=0.1 \
 //x=38.415 //y=0.795 //x2=38.415 //y2=1.06
r85 (  6 29 ) resistor r=3.57586 //w=0.17 //l=0.103078 //layer=li \
 //thickness=0.1 //x=37.53 //y=1.76 //x2=37.445 //y2=1.8
r86 (  6 29 ) resistor r=27.3797 //w=0.187 //l=0.4 //layer=li //thickness=0.1 \
 //x=37.53 //y=1.76 //x2=37.93 //y2=1.76
r87 (  5 29 ) resistor r=3.57586 //w=0.17 //l=0.103078 //layer=li \
 //thickness=0.1 //x=38.33 //y=1.76 //x2=38.415 //y2=1.8
r88 (  5 29 ) resistor r=27.3797 //w=0.187 //l=0.4 //layer=li //thickness=0.1 \
 //x=38.33 //y=1.76 //x2=37.93 //y2=1.76
r89 (  1 29 ) resistor r=3.57586 //w=0.17 //l=0.125 //layer=li //thickness=0.1 \
 //x=37.445 //y=1.675 //x2=37.445 //y2=1.8
r90 (  1 29 ) resistor r=42.0963 //w=0.187 //l=0.615 //layer=li \
 //thickness=0.1 //x=37.445 //y=1.675 //x2=37.445 //y2=1.06
ends PM_TMRDFFQX1\%noxref_41

subckt PM_TMRDFFQX1\%noxref_42 ( 1 5 9 10 13 17 29 )
c68 ( 29 0 ) capacitor c=0.0657587f //x=40.64 //y=0.545
c69 ( 17 0 ) capacitor c=0.00675704f //x=42.715 //y=0.795
c70 ( 13 0 ) capacitor c=0.0156179f //x=42.63 //y=0.71
c71 ( 10 0 ) capacitor c=0.00673372f //x=41.745 //y=1.675
c72 ( 9 0 ) capacitor c=0.00770028f //x=41.745 //y=0.795
c73 ( 5 0 ) capacitor c=0.0179513f //x=41.66 //y=1.76
c74 ( 1 0 ) capacitor c=0.0076012f //x=40.775 //y=1.675
r75 (  17 29 ) resistor r=3.57586 //w=0.17 //l=0.125 //layer=li \
 //thickness=0.1 //x=42.715 //y=0.795 //x2=42.715 //y2=0.67
r76 (  17 29 ) resistor r=18.139 //w=0.187 //l=0.265 //layer=li \
 //thickness=0.1 //x=42.715 //y=0.795 //x2=42.715 //y2=1.06
r77 (  14 29 ) resistor r=3.57586 //w=0.17 //l=0.103078 //layer=li \
 //thickness=0.1 //x=41.83 //y=0.71 //x2=41.745 //y2=0.67
r78 (  14 29 ) resistor r=27.3797 //w=0.187 //l=0.4 //layer=li //thickness=0.1 \
 //x=41.83 //y=0.71 //x2=42.23 //y2=0.71
r79 (  13 29 ) resistor r=3.57586 //w=0.17 //l=0.103078 //layer=li \
 //thickness=0.1 //x=42.63 //y=0.71 //x2=42.715 //y2=0.67
r80 (  13 29 ) resistor r=27.3797 //w=0.187 //l=0.4 //layer=li //thickness=0.1 \
 //x=42.63 //y=0.71 //x2=42.23 //y2=0.71
r81 (  10 29 ) resistor r=3.57586 //w=0.17 //l=0.125 //layer=li \
 //thickness=0.1 //x=41.745 //y=1.675 //x2=41.745 //y2=1.8
r82 (  10 29 ) resistor r=42.0963 //w=0.187 //l=0.615 //layer=li \
 //thickness=0.1 //x=41.745 //y=1.675 //x2=41.745 //y2=1.06
r83 (  9 29 ) resistor r=3.57586 //w=0.17 //l=0.125 //layer=li //thickness=0.1 \
 //x=41.745 //y=0.795 //x2=41.745 //y2=0.67
r84 (  9 29 ) resistor r=18.139 //w=0.187 //l=0.265 //layer=li //thickness=0.1 \
 //x=41.745 //y=0.795 //x2=41.745 //y2=1.06
r85 (  6 29 ) resistor r=3.57586 //w=0.17 //l=0.103078 //layer=li \
 //thickness=0.1 //x=40.86 //y=1.76 //x2=40.775 //y2=1.8
r86 (  6 29 ) resistor r=27.3797 //w=0.187 //l=0.4 //layer=li //thickness=0.1 \
 //x=40.86 //y=1.76 //x2=41.26 //y2=1.76
r87 (  5 29 ) resistor r=3.57586 //w=0.17 //l=0.103078 //layer=li \
 //thickness=0.1 //x=41.66 //y=1.76 //x2=41.745 //y2=1.8
r88 (  5 29 ) resistor r=27.3797 //w=0.187 //l=0.4 //layer=li //thickness=0.1 \
 //x=41.66 //y=1.76 //x2=41.26 //y2=1.76
r89 (  1 29 ) resistor r=3.57586 //w=0.17 //l=0.125 //layer=li //thickness=0.1 \
 //x=40.775 //y=1.675 //x2=40.775 //y2=1.8
r90 (  1 29 ) resistor r=42.0963 //w=0.187 //l=0.615 //layer=li \
 //thickness=0.1 //x=40.775 //y=1.675 //x2=40.775 //y2=1.06
ends PM_TMRDFFQX1\%noxref_42

subckt PM_TMRDFFQX1\%noxref_43 ( 1 5 9 13 17 35 )
c59 ( 35 0 ) capacitor c=0.0688411f //x=43.865 //y=0.555
c60 ( 17 0 ) capacitor c=0.0190725f //x=45.855 //y=1.77
c61 ( 13 0 ) capacitor c=0.015325f //x=45.855 //y=0.72
c62 ( 9 0 ) capacitor c=0.00772076f //x=44.97 //y=0.805
c63 ( 5 0 ) capacitor c=0.0168501f //x=44.885 //y=1.77
c64 ( 1 0 ) capacitor c=0.00709556f //x=44 //y=1.685
r65 (  18 35 ) resistor r=5.4201 //w=0.17 //l=0.103078 //layer=li \
 //thickness=0.1 //x=45.055 //y=1.77 //x2=44.97 //y2=1.81
r66 (  18 35 ) resistor r=27.3797 //w=0.187 //l=0.4 //layer=li //thickness=0.1 \
 //x=45.055 //y=1.77 //x2=45.455 //y2=1.77
r67 (  17 35 ) resistor r=0.751729 //w=0.17 //l=0.085 //layer=li \
 //thickness=0.1 //x=45.855 //y=1.77 //x2=45.94 //y2=1.77
r68 (  17 35 ) resistor r=27.3797 //w=0.187 //l=0.4 //layer=li //thickness=0.1 \
 //x=45.855 //y=1.77 //x2=45.455 //y2=1.77
r69 (  14 35 ) resistor r=3.57586 //w=0.17 //l=0.103078 //layer=li \
 //thickness=0.1 //x=45.055 //y=0.72 //x2=44.97 //y2=0.68
r70 (  14 35 ) resistor r=27.3797 //w=0.187 //l=0.4 //layer=li //thickness=0.1 \
 //x=45.055 //y=0.72 //x2=45.455 //y2=0.72
r71 (  13 35 ) resistor r=0.751729 //w=0.17 //l=0.085 //layer=li \
 //thickness=0.1 //x=45.855 //y=0.72 //x2=45.94 //y2=0.72
r72 (  13 35 ) resistor r=27.3797 //w=0.187 //l=0.4 //layer=li //thickness=0.1 \
 //x=45.855 //y=0.72 //x2=45.455 //y2=0.72
r73 (  10 35 ) resistor r=1.40859 //w=0.34 //l=0.125 //layer=li \
 //thickness=0.1 //x=44.97 //y=1.685 //x2=44.97 //y2=1.81
r74 (  10 35 ) resistor r=42.0963 //w=0.187 //l=0.615 //layer=li \
 //thickness=0.1 //x=44.97 //y=1.685 //x2=44.97 //y2=1.07
r75 (  9 35 ) resistor r=3.57586 //w=0.17 //l=0.125 //layer=li //thickness=0.1 \
 //x=44.97 //y=0.805 //x2=44.97 //y2=0.68
r76 (  9 35 ) resistor r=18.139 //w=0.187 //l=0.265 //layer=li //thickness=0.1 \
 //x=44.97 //y=0.805 //x2=44.97 //y2=1.07
r77 (  6 35 ) resistor r=3.57586 //w=0.17 //l=0.103078 //layer=li \
 //thickness=0.1 //x=44.085 //y=1.77 //x2=44 //y2=1.81
r78 (  6 35 ) resistor r=27.3797 //w=0.187 //l=0.4 //layer=li //thickness=0.1 \
 //x=44.085 //y=1.77 //x2=44.485 //y2=1.77
r79 (  5 35 ) resistor r=5.4201 //w=0.17 //l=0.103078 //layer=li \
 //thickness=0.1 //x=44.885 //y=1.77 //x2=44.97 //y2=1.81
r80 (  5 35 ) resistor r=27.3797 //w=0.187 //l=0.4 //layer=li //thickness=0.1 \
 //x=44.885 //y=1.77 //x2=44.485 //y2=1.77
r81 (  1 35 ) resistor r=3.57586 //w=0.17 //l=0.125 //layer=li //thickness=0.1 \
 //x=44 //y=1.685 //x2=44 //y2=1.81
r82 (  1 35 ) resistor r=42.0963 //w=0.187 //l=0.615 //layer=li \
 //thickness=0.1 //x=44 //y=1.685 //x2=44 //y2=1.07
ends PM_TMRDFFQX1\%noxref_43

subckt PM_TMRDFFQX1\%noxref_44 ( 1 5 9 10 13 17 29 )
c69 ( 29 0 ) capacitor c=0.0669833f //x=48.78 //y=0.545
c70 ( 17 0 ) capacitor c=0.0067865f //x=50.855 //y=0.795
c71 ( 13 0 ) capacitor c=0.0154955f //x=50.77 //y=0.71
c72 ( 10 0 ) capacitor c=0.0065552f //x=49.885 //y=1.675
c73 ( 9 0 ) capacitor c=0.00770028f //x=49.885 //y=0.795
c74 ( 5 0 ) capacitor c=0.0179492f //x=49.8 //y=1.76
c75 ( 1 0 ) capacitor c=0.00761099f //x=48.915 //y=1.675
r76 (  17 29 ) resistor r=3.57586 //w=0.17 //l=0.125 //layer=li \
 //thickness=0.1 //x=50.855 //y=0.795 //x2=50.855 //y2=0.67
r77 (  17 29 ) resistor r=18.139 //w=0.187 //l=0.265 //layer=li \
 //thickness=0.1 //x=50.855 //y=0.795 //x2=50.855 //y2=1.06
r78 (  14 29 ) resistor r=3.57586 //w=0.17 //l=0.103078 //layer=li \
 //thickness=0.1 //x=49.97 //y=0.71 //x2=49.885 //y2=0.67
r79 (  14 29 ) resistor r=27.3797 //w=0.187 //l=0.4 //layer=li //thickness=0.1 \
 //x=49.97 //y=0.71 //x2=50.37 //y2=0.71
r80 (  13 29 ) resistor r=3.57586 //w=0.17 //l=0.103078 //layer=li \
 //thickness=0.1 //x=50.77 //y=0.71 //x2=50.855 //y2=0.67
r81 (  13 29 ) resistor r=27.3797 //w=0.187 //l=0.4 //layer=li //thickness=0.1 \
 //x=50.77 //y=0.71 //x2=50.37 //y2=0.71
r82 (  10 29 ) resistor r=3.57586 //w=0.17 //l=0.125 //layer=li \
 //thickness=0.1 //x=49.885 //y=1.675 //x2=49.885 //y2=1.8
r83 (  10 29 ) resistor r=42.0963 //w=0.187 //l=0.615 //layer=li \
 //thickness=0.1 //x=49.885 //y=1.675 //x2=49.885 //y2=1.06
r84 (  9 29 ) resistor r=3.57586 //w=0.17 //l=0.125 //layer=li //thickness=0.1 \
 //x=49.885 //y=0.795 //x2=49.885 //y2=0.67
r85 (  9 29 ) resistor r=18.139 //w=0.187 //l=0.265 //layer=li //thickness=0.1 \
 //x=49.885 //y=0.795 //x2=49.885 //y2=1.06
r86 (  6 29 ) resistor r=3.57586 //w=0.17 //l=0.103078 //layer=li \
 //thickness=0.1 //x=49 //y=1.76 //x2=48.915 //y2=1.8
r87 (  6 29 ) resistor r=27.3797 //w=0.187 //l=0.4 //layer=li //thickness=0.1 \
 //x=49 //y=1.76 //x2=49.4 //y2=1.76
r88 (  5 29 ) resistor r=3.57586 //w=0.17 //l=0.103078 //layer=li \
 //thickness=0.1 //x=49.8 //y=1.76 //x2=49.885 //y2=1.8
r89 (  5 29 ) resistor r=27.3797 //w=0.187 //l=0.4 //layer=li //thickness=0.1 \
 //x=49.8 //y=1.76 //x2=49.4 //y2=1.76
r90 (  1 29 ) resistor r=3.57586 //w=0.17 //l=0.125 //layer=li //thickness=0.1 \
 //x=48.915 //y=1.675 //x2=48.915 //y2=1.8
r91 (  1 29 ) resistor r=42.0963 //w=0.187 //l=0.615 //layer=li \
 //thickness=0.1 //x=48.915 //y=1.675 //x2=48.915 //y2=1.06
ends PM_TMRDFFQX1\%noxref_44

subckt PM_TMRDFFQX1\%noxref_45 ( 1 5 9 10 13 17 29 )
c69 ( 29 0 ) capacitor c=0.06668f //x=52.11 //y=0.545
c70 ( 17 0 ) capacitor c=0.0067865f //x=54.185 //y=0.795
c71 ( 13 0 ) capacitor c=0.0156326f //x=54.1 //y=0.71
c72 ( 10 0 ) capacitor c=0.00673372f //x=53.215 //y=1.675
c73 ( 9 0 ) capacitor c=0.00770028f //x=53.215 //y=0.795
c74 ( 5 0 ) capacitor c=0.0179513f //x=53.13 //y=1.76
c75 ( 1 0 ) capacitor c=0.0076012f //x=52.245 //y=1.675
r76 (  17 29 ) resistor r=3.57586 //w=0.17 //l=0.125 //layer=li \
 //thickness=0.1 //x=54.185 //y=0.795 //x2=54.185 //y2=0.67
r77 (  17 29 ) resistor r=18.139 //w=0.187 //l=0.265 //layer=li \
 //thickness=0.1 //x=54.185 //y=0.795 //x2=54.185 //y2=1.06
r78 (  14 29 ) resistor r=3.57586 //w=0.17 //l=0.103078 //layer=li \
 //thickness=0.1 //x=53.3 //y=0.71 //x2=53.215 //y2=0.67
r79 (  14 29 ) resistor r=27.3797 //w=0.187 //l=0.4 //layer=li //thickness=0.1 \
 //x=53.3 //y=0.71 //x2=53.7 //y2=0.71
r80 (  13 29 ) resistor r=3.57586 //w=0.17 //l=0.103078 //layer=li \
 //thickness=0.1 //x=54.1 //y=0.71 //x2=54.185 //y2=0.67
r81 (  13 29 ) resistor r=27.3797 //w=0.187 //l=0.4 //layer=li //thickness=0.1 \
 //x=54.1 //y=0.71 //x2=53.7 //y2=0.71
r82 (  10 29 ) resistor r=3.57586 //w=0.17 //l=0.125 //layer=li \
 //thickness=0.1 //x=53.215 //y=1.675 //x2=53.215 //y2=1.8
r83 (  10 29 ) resistor r=42.0963 //w=0.187 //l=0.615 //layer=li \
 //thickness=0.1 //x=53.215 //y=1.675 //x2=53.215 //y2=1.06
r84 (  9 29 ) resistor r=3.57586 //w=0.17 //l=0.125 //layer=li //thickness=0.1 \
 //x=53.215 //y=0.795 //x2=53.215 //y2=0.67
r85 (  9 29 ) resistor r=18.139 //w=0.187 //l=0.265 //layer=li //thickness=0.1 \
 //x=53.215 //y=0.795 //x2=53.215 //y2=1.06
r86 (  6 29 ) resistor r=3.57586 //w=0.17 //l=0.103078 //layer=li \
 //thickness=0.1 //x=52.33 //y=1.76 //x2=52.245 //y2=1.8
r87 (  6 29 ) resistor r=27.3797 //w=0.187 //l=0.4 //layer=li //thickness=0.1 \
 //x=52.33 //y=1.76 //x2=52.73 //y2=1.76
r88 (  5 29 ) resistor r=3.57586 //w=0.17 //l=0.103078 //layer=li \
 //thickness=0.1 //x=53.13 //y=1.76 //x2=53.215 //y2=1.8
r89 (  5 29 ) resistor r=27.3797 //w=0.187 //l=0.4 //layer=li //thickness=0.1 \
 //x=53.13 //y=1.76 //x2=52.73 //y2=1.76
r90 (  1 29 ) resistor r=3.57586 //w=0.17 //l=0.125 //layer=li //thickness=0.1 \
 //x=52.245 //y=1.675 //x2=52.245 //y2=1.8
r91 (  1 29 ) resistor r=42.0963 //w=0.187 //l=0.615 //layer=li \
 //thickness=0.1 //x=52.245 //y=1.675 //x2=52.245 //y2=1.06
ends PM_TMRDFFQX1\%noxref_45

subckt PM_TMRDFFQX1\%noxref_46 ( 1 5 9 10 13 17 29 )
c68 ( 29 0 ) capacitor c=0.0670536f //x=55.44 //y=0.545
c69 ( 17 0 ) capacitor c=0.0067865f //x=57.515 //y=0.795
c70 ( 13 0 ) capacitor c=0.0154977f //x=57.43 //y=0.71
c71 ( 10 0 ) capacitor c=0.00683366f //x=56.545 //y=1.675
c72 ( 9 0 ) capacitor c=0.00770028f //x=56.545 //y=0.795
c73 ( 5 0 ) capacitor c=0.0179513f //x=56.46 //y=1.76
c74 ( 1 0 ) capacitor c=0.0076012f //x=55.575 //y=1.675
r75 (  17 29 ) resistor r=3.57586 //w=0.17 //l=0.125 //layer=li \
 //thickness=0.1 //x=57.515 //y=0.795 //x2=57.515 //y2=0.67
r76 (  17 29 ) resistor r=18.139 //w=0.187 //l=0.265 //layer=li \
 //thickness=0.1 //x=57.515 //y=0.795 //x2=57.515 //y2=1.06
r77 (  14 29 ) resistor r=3.57586 //w=0.17 //l=0.103078 //layer=li \
 //thickness=0.1 //x=56.63 //y=0.71 //x2=56.545 //y2=0.67
r78 (  14 29 ) resistor r=27.3797 //w=0.187 //l=0.4 //layer=li //thickness=0.1 \
 //x=56.63 //y=0.71 //x2=57.03 //y2=0.71
r79 (  13 29 ) resistor r=3.57586 //w=0.17 //l=0.103078 //layer=li \
 //thickness=0.1 //x=57.43 //y=0.71 //x2=57.515 //y2=0.67
r80 (  13 29 ) resistor r=27.3797 //w=0.187 //l=0.4 //layer=li //thickness=0.1 \
 //x=57.43 //y=0.71 //x2=57.03 //y2=0.71
r81 (  10 29 ) resistor r=3.57586 //w=0.17 //l=0.125 //layer=li \
 //thickness=0.1 //x=56.545 //y=1.675 //x2=56.545 //y2=1.8
r82 (  10 29 ) resistor r=42.0963 //w=0.187 //l=0.615 //layer=li \
 //thickness=0.1 //x=56.545 //y=1.675 //x2=56.545 //y2=1.06
r83 (  9 29 ) resistor r=3.57586 //w=0.17 //l=0.125 //layer=li //thickness=0.1 \
 //x=56.545 //y=0.795 //x2=56.545 //y2=0.67
r84 (  9 29 ) resistor r=18.139 //w=0.187 //l=0.265 //layer=li //thickness=0.1 \
 //x=56.545 //y=0.795 //x2=56.545 //y2=1.06
r85 (  6 29 ) resistor r=3.57586 //w=0.17 //l=0.103078 //layer=li \
 //thickness=0.1 //x=55.66 //y=1.76 //x2=55.575 //y2=1.8
r86 (  6 29 ) resistor r=27.3797 //w=0.187 //l=0.4 //layer=li //thickness=0.1 \
 //x=55.66 //y=1.76 //x2=56.06 //y2=1.76
r87 (  5 29 ) resistor r=3.57586 //w=0.17 //l=0.103078 //layer=li \
 //thickness=0.1 //x=56.46 //y=1.76 //x2=56.545 //y2=1.8
r88 (  5 29 ) resistor r=27.3797 //w=0.187 //l=0.4 //layer=li //thickness=0.1 \
 //x=56.46 //y=1.76 //x2=56.06 //y2=1.76
r89 (  1 29 ) resistor r=3.57586 //w=0.17 //l=0.125 //layer=li //thickness=0.1 \
 //x=55.575 //y=1.675 //x2=55.575 //y2=1.8
r90 (  1 29 ) resistor r=42.0963 //w=0.187 //l=0.615 //layer=li \
 //thickness=0.1 //x=55.575 //y=1.675 //x2=55.575 //y2=1.06
ends PM_TMRDFFQX1\%noxref_46

subckt PM_TMRDFFQX1\%noxref_47 ( 1 5 9 10 13 17 29 )
c70 ( 29 0 ) capacitor c=0.0671946f //x=58.77 //y=0.545
c71 ( 17 0 ) capacitor c=0.0067865f //x=60.845 //y=0.795
c72 ( 13 0 ) capacitor c=0.0154977f //x=60.76 //y=0.71
c73 ( 10 0 ) capacitor c=0.00673372f //x=59.875 //y=1.675
c74 ( 9 0 ) capacitor c=0.00770028f //x=59.875 //y=0.795
c75 ( 5 0 ) capacitor c=0.0179513f //x=59.79 //y=1.76
c76 ( 1 0 ) capacitor c=0.0076012f //x=58.905 //y=1.675
r77 (  17 29 ) resistor r=3.57586 //w=0.17 //l=0.125 //layer=li \
 //thickness=0.1 //x=60.845 //y=0.795 //x2=60.845 //y2=0.67
r78 (  17 29 ) resistor r=18.139 //w=0.187 //l=0.265 //layer=li \
 //thickness=0.1 //x=60.845 //y=0.795 //x2=60.845 //y2=1.06
r79 (  14 29 ) resistor r=3.57586 //w=0.17 //l=0.103078 //layer=li \
 //thickness=0.1 //x=59.96 //y=0.71 //x2=59.875 //y2=0.67
r80 (  14 29 ) resistor r=27.3797 //w=0.187 //l=0.4 //layer=li //thickness=0.1 \
 //x=59.96 //y=0.71 //x2=60.36 //y2=0.71
r81 (  13 29 ) resistor r=3.57586 //w=0.17 //l=0.103078 //layer=li \
 //thickness=0.1 //x=60.76 //y=0.71 //x2=60.845 //y2=0.67
r82 (  13 29 ) resistor r=27.3797 //w=0.187 //l=0.4 //layer=li //thickness=0.1 \
 //x=60.76 //y=0.71 //x2=60.36 //y2=0.71
r83 (  10 29 ) resistor r=3.57586 //w=0.17 //l=0.125 //layer=li \
 //thickness=0.1 //x=59.875 //y=1.675 //x2=59.875 //y2=1.8
r84 (  10 29 ) resistor r=42.0963 //w=0.187 //l=0.615 //layer=li \
 //thickness=0.1 //x=59.875 //y=1.675 //x2=59.875 //y2=1.06
r85 (  9 29 ) resistor r=3.57586 //w=0.17 //l=0.125 //layer=li //thickness=0.1 \
 //x=59.875 //y=0.795 //x2=59.875 //y2=0.67
r86 (  9 29 ) resistor r=18.139 //w=0.187 //l=0.265 //layer=li //thickness=0.1 \
 //x=59.875 //y=0.795 //x2=59.875 //y2=1.06
r87 (  6 29 ) resistor r=3.57586 //w=0.17 //l=0.103078 //layer=li \
 //thickness=0.1 //x=58.99 //y=1.76 //x2=58.905 //y2=1.8
r88 (  6 29 ) resistor r=27.3797 //w=0.187 //l=0.4 //layer=li //thickness=0.1 \
 //x=58.99 //y=1.76 //x2=59.39 //y2=1.76
r89 (  5 29 ) resistor r=3.57586 //w=0.17 //l=0.103078 //layer=li \
 //thickness=0.1 //x=59.79 //y=1.76 //x2=59.875 //y2=1.8
r90 (  5 29 ) resistor r=27.3797 //w=0.187 //l=0.4 //layer=li //thickness=0.1 \
 //x=59.79 //y=1.76 //x2=59.39 //y2=1.76
r91 (  1 29 ) resistor r=3.57586 //w=0.17 //l=0.125 //layer=li //thickness=0.1 \
 //x=58.905 //y=1.675 //x2=58.905 //y2=1.8
r92 (  1 29 ) resistor r=42.0963 //w=0.187 //l=0.615 //layer=li \
 //thickness=0.1 //x=58.905 //y=1.675 //x2=58.905 //y2=1.06
ends PM_TMRDFFQX1\%noxref_47

subckt PM_TMRDFFQX1\%noxref_48 ( 1 5 9 10 13 17 29 )
c69 ( 29 0 ) capacitor c=0.0668792f //x=62.1 //y=0.545
c70 ( 17 0 ) capacitor c=0.0067865f //x=64.175 //y=0.795
c71 ( 13 0 ) capacitor c=0.0156179f //x=64.09 //y=0.71
c72 ( 10 0 ) capacitor c=0.00673372f //x=63.205 //y=1.675
c73 ( 9 0 ) capacitor c=0.00770028f //x=63.205 //y=0.795
c74 ( 5 0 ) capacitor c=0.0179513f //x=63.12 //y=1.76
c75 ( 1 0 ) capacitor c=0.0076012f //x=62.235 //y=1.675
r76 (  17 29 ) resistor r=3.57586 //w=0.17 //l=0.125 //layer=li \
 //thickness=0.1 //x=64.175 //y=0.795 //x2=64.175 //y2=0.67
r77 (  17 29 ) resistor r=18.139 //w=0.187 //l=0.265 //layer=li \
 //thickness=0.1 //x=64.175 //y=0.795 //x2=64.175 //y2=1.06
r78 (  14 29 ) resistor r=3.57586 //w=0.17 //l=0.103078 //layer=li \
 //thickness=0.1 //x=63.29 //y=0.71 //x2=63.205 //y2=0.67
r79 (  14 29 ) resistor r=27.3797 //w=0.187 //l=0.4 //layer=li //thickness=0.1 \
 //x=63.29 //y=0.71 //x2=63.69 //y2=0.71
r80 (  13 29 ) resistor r=3.57586 //w=0.17 //l=0.103078 //layer=li \
 //thickness=0.1 //x=64.09 //y=0.71 //x2=64.175 //y2=0.67
r81 (  13 29 ) resistor r=27.3797 //w=0.187 //l=0.4 //layer=li //thickness=0.1 \
 //x=64.09 //y=0.71 //x2=63.69 //y2=0.71
r82 (  10 29 ) resistor r=3.57586 //w=0.17 //l=0.125 //layer=li \
 //thickness=0.1 //x=63.205 //y=1.675 //x2=63.205 //y2=1.8
r83 (  10 29 ) resistor r=42.0963 //w=0.187 //l=0.615 //layer=li \
 //thickness=0.1 //x=63.205 //y=1.675 //x2=63.205 //y2=1.06
r84 (  9 29 ) resistor r=3.57586 //w=0.17 //l=0.125 //layer=li //thickness=0.1 \
 //x=63.205 //y=0.795 //x2=63.205 //y2=0.67
r85 (  9 29 ) resistor r=18.139 //w=0.187 //l=0.265 //layer=li //thickness=0.1 \
 //x=63.205 //y=0.795 //x2=63.205 //y2=1.06
r86 (  6 29 ) resistor r=3.57586 //w=0.17 //l=0.103078 //layer=li \
 //thickness=0.1 //x=62.32 //y=1.76 //x2=62.235 //y2=1.8
r87 (  6 29 ) resistor r=27.3797 //w=0.187 //l=0.4 //layer=li //thickness=0.1 \
 //x=62.32 //y=1.76 //x2=62.72 //y2=1.76
r88 (  5 29 ) resistor r=3.57586 //w=0.17 //l=0.103078 //layer=li \
 //thickness=0.1 //x=63.12 //y=1.76 //x2=63.205 //y2=1.8
r89 (  5 29 ) resistor r=27.3797 //w=0.187 //l=0.4 //layer=li //thickness=0.1 \
 //x=63.12 //y=1.76 //x2=62.72 //y2=1.76
r90 (  1 29 ) resistor r=3.57586 //w=0.17 //l=0.125 //layer=li //thickness=0.1 \
 //x=62.235 //y=1.675 //x2=62.235 //y2=1.8
r91 (  1 29 ) resistor r=42.0963 //w=0.187 //l=0.615 //layer=li \
 //thickness=0.1 //x=62.235 //y=1.675 //x2=62.235 //y2=1.06
ends PM_TMRDFFQX1\%noxref_48

subckt PM_TMRDFFQX1\%noxref_49 ( 1 5 9 10 13 17 29 )
c68 ( 29 0 ) capacitor c=0.0765053f //x=65.43 //y=0.545
c69 ( 17 0 ) capacitor c=0.00678917f //x=67.505 //y=0.795
c70 ( 13 0 ) capacitor c=0.0152971f //x=67.42 //y=0.71
c71 ( 10 0 ) capacitor c=0.00732519f //x=66.535 //y=1.675
c72 ( 9 0 ) capacitor c=0.00770028f //x=66.535 //y=0.795
c73 ( 5 0 ) capacitor c=0.0203276f //x=66.45 //y=1.76
c74 ( 1 0 ) capacitor c=0.00458439f //x=65.565 //y=1.675
r75 (  17 29 ) resistor r=3.57586 //w=0.17 //l=0.125 //layer=li \
 //thickness=0.1 //x=67.505 //y=0.795 //x2=67.505 //y2=0.67
r76 (  17 29 ) resistor r=41.4118 //w=0.187 //l=0.605 //layer=li \
 //thickness=0.1 //x=67.505 //y=0.795 //x2=67.505 //y2=1.4
r77 (  14 29 ) resistor r=3.57586 //w=0.17 //l=0.103078 //layer=li \
 //thickness=0.1 //x=66.62 //y=0.71 //x2=66.535 //y2=0.67
r78 (  14 29 ) resistor r=27.0374 //w=0.187 //l=0.395 //layer=li \
 //thickness=0.1 //x=66.62 //y=0.71 //x2=67.015 //y2=0.71
r79 (  13 29 ) resistor r=3.57586 //w=0.17 //l=0.103078 //layer=li \
 //thickness=0.1 //x=67.42 //y=0.71 //x2=67.505 //y2=0.67
r80 (  13 29 ) resistor r=27.7219 //w=0.187 //l=0.405 //layer=li \
 //thickness=0.1 //x=67.42 //y=0.71 //x2=67.015 //y2=0.71
r81 (  10 29 ) resistor r=3.57586 //w=0.17 //l=0.125 //layer=li \
 //thickness=0.1 //x=66.535 //y=1.675 //x2=66.535 //y2=1.8
r82 (  10 29 ) resistor r=42.0963 //w=0.187 //l=0.615 //layer=li \
 //thickness=0.1 //x=66.535 //y=1.675 //x2=66.535 //y2=1.06
r83 (  9 29 ) resistor r=3.57586 //w=0.17 //l=0.125 //layer=li //thickness=0.1 \
 //x=66.535 //y=0.795 //x2=66.535 //y2=0.67
r84 (  9 29 ) resistor r=18.139 //w=0.187 //l=0.265 //layer=li //thickness=0.1 \
 //x=66.535 //y=0.795 //x2=66.535 //y2=1.06
r85 (  6 29 ) resistor r=3.57586 //w=0.17 //l=0.103078 //layer=li \
 //thickness=0.1 //x=65.65 //y=1.76 //x2=65.565 //y2=1.8
r86 (  6 29 ) resistor r=27.3797 //w=0.187 //l=0.4 //layer=li //thickness=0.1 \
 //x=65.65 //y=1.76 //x2=66.05 //y2=1.76
r87 (  5 29 ) resistor r=3.57586 //w=0.17 //l=0.103078 //layer=li \
 //thickness=0.1 //x=66.45 //y=1.76 //x2=66.535 //y2=1.8
r88 (  5 29 ) resistor r=27.3797 //w=0.187 //l=0.4 //layer=li //thickness=0.1 \
 //x=66.45 //y=1.76 //x2=66.05 //y2=1.76
r89 (  1 29 ) resistor r=3.57586 //w=0.17 //l=0.125 //layer=li //thickness=0.1 \
 //x=65.565 //y=1.675 //x2=65.565 //y2=1.8
r90 (  1 29 ) resistor r=42.0963 //w=0.187 //l=0.615 //layer=li \
 //thickness=0.1 //x=65.565 //y=1.675 //x2=65.565 //y2=1.06
ends PM_TMRDFFQX1\%noxref_49

subckt PM_TMRDFFQX1\%noxref_51 ( 1 5 9 10 13 17 29 )
c64 ( 29 0 ) capacitor c=0.0738221f //x=68.76 //y=0.545
c65 ( 17 0 ) capacitor c=0.00678917f //x=70.835 //y=0.795
c66 ( 13 0 ) capacitor c=0.0158009f //x=70.75 //y=0.71
c67 ( 10 0 ) capacitor c=0.00903204f //x=69.865 //y=1.675
c68 ( 9 0 ) capacitor c=0.00770028f //x=69.865 //y=0.795
c69 ( 5 0 ) capacitor c=0.0186275f //x=69.78 //y=1.76
c70 ( 1 0 ) capacitor c=0.00881929f //x=68.895 //y=1.675
r71 (  17 29 ) resistor r=3.57586 //w=0.17 //l=0.125 //layer=li \
 //thickness=0.1 //x=70.835 //y=0.795 //x2=70.835 //y2=0.67
r72 (  17 29 ) resistor r=41.4118 //w=0.187 //l=0.605 //layer=li \
 //thickness=0.1 //x=70.835 //y=0.795 //x2=70.835 //y2=1.4
r73 (  14 29 ) resistor r=3.57586 //w=0.17 //l=0.103078 //layer=li \
 //thickness=0.1 //x=69.95 //y=0.71 //x2=69.865 //y2=0.67
r74 (  14 29 ) resistor r=27.3797 //w=0.187 //l=0.4 //layer=li //thickness=0.1 \
 //x=69.95 //y=0.71 //x2=70.35 //y2=0.71
r75 (  13 29 ) resistor r=3.57586 //w=0.17 //l=0.103078 //layer=li \
 //thickness=0.1 //x=70.75 //y=0.71 //x2=70.835 //y2=0.67
r76 (  13 29 ) resistor r=27.3797 //w=0.187 //l=0.4 //layer=li //thickness=0.1 \
 //x=70.75 //y=0.71 //x2=70.35 //y2=0.71
r77 (  10 29 ) resistor r=3.57586 //w=0.17 //l=0.125 //layer=li \
 //thickness=0.1 //x=69.865 //y=1.675 //x2=69.865 //y2=1.8
r78 (  10 29 ) resistor r=42.0963 //w=0.187 //l=0.615 //layer=li \
 //thickness=0.1 //x=69.865 //y=1.675 //x2=69.865 //y2=1.06
r79 (  9 29 ) resistor r=3.57586 //w=0.17 //l=0.125 //layer=li //thickness=0.1 \
 //x=69.865 //y=0.795 //x2=69.865 //y2=0.67
r80 (  9 29 ) resistor r=18.139 //w=0.187 //l=0.265 //layer=li //thickness=0.1 \
 //x=69.865 //y=0.795 //x2=69.865 //y2=1.06
r81 (  6 29 ) resistor r=3.57586 //w=0.17 //l=0.103078 //layer=li \
 //thickness=0.1 //x=68.98 //y=1.76 //x2=68.895 //y2=1.8
r82 (  6 29 ) resistor r=27.3797 //w=0.187 //l=0.4 //layer=li //thickness=0.1 \
 //x=68.98 //y=1.76 //x2=69.38 //y2=1.76
r83 (  5 29 ) resistor r=3.57586 //w=0.17 //l=0.103078 //layer=li \
 //thickness=0.1 //x=69.78 //y=1.76 //x2=69.865 //y2=1.8
r84 (  5 29 ) resistor r=27.3797 //w=0.187 //l=0.4 //layer=li //thickness=0.1 \
 //x=69.78 //y=1.76 //x2=69.38 //y2=1.76
r85 (  1 29 ) resistor r=3.57586 //w=0.17 //l=0.125 //layer=li //thickness=0.1 \
 //x=68.895 //y=1.675 //x2=68.895 //y2=1.8
r86 (  1 29 ) resistor r=42.0963 //w=0.187 //l=0.615 //layer=li \
 //thickness=0.1 //x=68.895 //y=1.675 //x2=68.895 //y2=1.06
ends PM_TMRDFFQX1\%noxref_51

subckt PM_TMRDFFQX1\%noxref_52 ( 1 5 9 10 13 17 29 )
c70 ( 29 0 ) capacitor c=0.067718f //x=72.09 //y=0.545
c71 ( 17 0 ) capacitor c=0.00709795f //x=74.165 //y=0.795
c72 ( 13 0 ) capacitor c=0.0152565f //x=74.08 //y=0.71
c73 ( 10 0 ) capacitor c=0.00749806f //x=73.195 //y=1.675
c74 ( 9 0 ) capacitor c=0.00770028f //x=73.195 //y=0.795
c75 ( 5 0 ) capacitor c=0.0236235f //x=73.11 //y=1.76
c76 ( 1 0 ) capacitor c=0.00498238f //x=72.225 //y=1.675
r77 (  17 29 ) resistor r=3.57586 //w=0.17 //l=0.125 //layer=li \
 //thickness=0.1 //x=74.165 //y=0.795 //x2=74.165 //y2=0.67
r78 (  17 29 ) resistor r=18.139 //w=0.187 //l=0.265 //layer=li \
 //thickness=0.1 //x=74.165 //y=0.795 //x2=74.165 //y2=1.06
r79 (  14 29 ) resistor r=3.57586 //w=0.17 //l=0.103078 //layer=li \
 //thickness=0.1 //x=73.28 //y=0.71 //x2=73.195 //y2=0.67
r80 (  14 29 ) resistor r=27.3797 //w=0.187 //l=0.4 //layer=li //thickness=0.1 \
 //x=73.28 //y=0.71 //x2=73.68 //y2=0.71
r81 (  13 29 ) resistor r=3.57586 //w=0.17 //l=0.103078 //layer=li \
 //thickness=0.1 //x=74.08 //y=0.71 //x2=74.165 //y2=0.67
r82 (  13 29 ) resistor r=27.3797 //w=0.187 //l=0.4 //layer=li //thickness=0.1 \
 //x=74.08 //y=0.71 //x2=73.68 //y2=0.71
r83 (  10 29 ) resistor r=3.57586 //w=0.17 //l=0.125 //layer=li \
 //thickness=0.1 //x=73.195 //y=1.675 //x2=73.195 //y2=1.8
r84 (  10 29 ) resistor r=42.0963 //w=0.187 //l=0.615 //layer=li \
 //thickness=0.1 //x=73.195 //y=1.675 //x2=73.195 //y2=1.06
r85 (  9 29 ) resistor r=3.57586 //w=0.17 //l=0.125 //layer=li //thickness=0.1 \
 //x=73.195 //y=0.795 //x2=73.195 //y2=0.67
r86 (  9 29 ) resistor r=18.139 //w=0.187 //l=0.265 //layer=li //thickness=0.1 \
 //x=73.195 //y=0.795 //x2=73.195 //y2=1.06
r87 (  6 29 ) resistor r=3.57586 //w=0.17 //l=0.103078 //layer=li \
 //thickness=0.1 //x=72.31 //y=1.76 //x2=72.225 //y2=1.8
r88 (  6 29 ) resistor r=27.3797 //w=0.187 //l=0.4 //layer=li //thickness=0.1 \
 //x=72.31 //y=1.76 //x2=72.71 //y2=1.76
r89 (  5 29 ) resistor r=3.57586 //w=0.17 //l=0.103078 //layer=li \
 //thickness=0.1 //x=73.11 //y=1.76 //x2=73.195 //y2=1.8
r90 (  5 29 ) resistor r=27.3797 //w=0.187 //l=0.4 //layer=li //thickness=0.1 \
 //x=73.11 //y=1.76 //x2=72.71 //y2=1.76
r91 (  1 29 ) resistor r=3.57586 //w=0.17 //l=0.125 //layer=li //thickness=0.1 \
 //x=72.225 //y=1.675 //x2=72.225 //y2=1.8
r92 (  1 29 ) resistor r=42.0963 //w=0.187 //l=0.615 //layer=li \
 //thickness=0.1 //x=72.225 //y=1.675 //x2=72.225 //y2=1.06
ends PM_TMRDFFQX1\%noxref_52
