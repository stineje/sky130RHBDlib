// File: TMRDFFQX1.spi.pex
// Created: Tue Apr 29 10:45:06 2025
// Program "Calibre xRC"
// Version "v2023.2_27.15"
// Nominal Temperature: 30C
// Circuit Temperature: 30C
//
simulator lang=spectre
subckt PM_TMRDFFQX1\%GND ( 1 127 131 134 139 149 157 165 171 177 185 193 201 \
 209 215 221 229 239 247 255 263 271 277 283 291 299 307 315 321 331 337 343 \
 351 359 367 375 381 387 395 403 411 419 425 431 439 450 455 459 472 474 477 \
 479 481 484 486 488 490 493 495 497 500 503 505 507 510 512 514 517 519 526 \
 533 534 535 536 537 538 539 540 541 542 543 544 545 546 547 548 549 550 551 \
 552 553 554 )
c971 ( 554 0 ) capacitor c=0.0604394f //x=75.355 //y=0.55
c972 ( 553 0 ) capacitor c=0.0215013f //x=72.52 //y=1.045
c973 ( 552 0 ) capacitor c=0.0215013f //x=69.19 //y=1.045
c974 ( 551 0 ) capacitor c=0.0207058f //x=65.86 //y=1.045
c975 ( 550 0 ) capacitor c=0.0207408f //x=62.53 //y=1.045
c976 ( 549 0 ) capacitor c=0.0207408f //x=59.2 //y=1.045
c977 ( 548 0 ) capacitor c=0.0207408f //x=55.87 //y=1.045
c978 ( 547 0 ) capacitor c=0.0207408f //x=52.54 //y=1.045
c979 ( 546 0 ) capacitor c=0.0207408f //x=49.21 //y=1.045
c980 ( 545 0 ) capacitor c=0.0226075f //x=44.295 //y=1.055
c981 ( 544 0 ) capacitor c=0.0207408f //x=41.07 //y=1.045
c982 ( 543 0 ) capacitor c=0.0207675f //x=37.74 //y=1.045
c983 ( 542 0 ) capacitor c=0.0207675f //x=34.41 //y=1.045
c984 ( 541 0 ) capacitor c=0.0207675f //x=31.08 //y=1.045
c985 ( 540 0 ) capacitor c=0.0207675f //x=27.75 //y=1.045
c986 ( 539 0 ) capacitor c=0.0226345f //x=22.835 //y=1.055
c987 ( 538 0 ) capacitor c=0.0207675f //x=19.61 //y=1.045
c988 ( 537 0 ) capacitor c=0.0207675f //x=16.28 //y=1.045
c989 ( 536 0 ) capacitor c=0.0207675f //x=12.95 //y=1.045
c990 ( 535 0 ) capacitor c=0.0207675f //x=9.62 //y=1.045
c991 ( 534 0 ) capacitor c=0.0208019f //x=6.29 //y=1.045
c992 ( 533 0 ) capacitor c=0.022675f //x=1.375 //y=1.055
c993 ( 526 0 ) capacitor c=0.253772f //x=76.46 //y=0.175
c994 ( 519 0 ) capacitor c=0.102069f //x=74.86 //y=0.175
c995 ( 518 0 ) capacitor c=0.00446416f //x=72.71 //y=0.175
c996 ( 517 0 ) capacitor c=0.101602f //x=71.53 //y=0.175
c997 ( 516 0 ) capacitor c=0.00446416f //x=69.31 //y=0.18
c998 ( 514 0 ) capacitor c=0.115842f //x=68.2 //y=0.175
c999 ( 513 0 ) capacitor c=0.00446416f //x=66.05 //y=0.175
c1000 ( 512 0 ) capacitor c=0.103196f //x=64.87 //y=0.175
c1001 ( 511 0 ) capacitor c=0.00446416f //x=62.72 //y=0.175
c1002 ( 510 0 ) capacitor c=0.105498f //x=61.54 //y=0.175
c1003 ( 509 0 ) capacitor c=0.00446416f //x=59.32 //y=0.18
c1004 ( 507 0 ) capacitor c=0.105498f //x=58.21 //y=0.175
c1005 ( 506 0 ) capacitor c=0.00446416f //x=56.06 //y=0.175
c1006 ( 505 0 ) capacitor c=0.105498f //x=54.88 //y=0.175
c1007 ( 504 0 ) capacitor c=0.00446416f //x=52.73 //y=0.175
c1008 ( 503 0 ) capacitor c=0.105028f //x=51.55 //y=0.175
c1009 ( 502 0 ) capacitor c=0.00446416f //x=49.33 //y=0.18
c1010 ( 500 0 ) capacitor c=0.10874f //x=48.22 //y=0.175
c1011 ( 499 0 ) capacitor c=0.00446464f //x=44.52 //y=0.18
c1012 ( 497 0 ) capacitor c=0.104488f //x=43.41 //y=0.175
c1013 ( 496 0 ) capacitor c=0.00446416f //x=41.26 //y=0.175
c1014 ( 495 0 ) capacitor c=0.105758f //x=40.08 //y=0.175
c1015 ( 494 0 ) capacitor c=0.00446416f //x=37.93 //y=0.175
c1016 ( 493 0 ) capacitor c=0.106782f //x=36.75 //y=0.175
c1017 ( 492 0 ) capacitor c=0.00446416f //x=34.53 //y=0.18
c1018 ( 490 0 ) capacitor c=0.107095f //x=33.42 //y=0.175
c1019 ( 489 0 ) capacitor c=0.00446416f //x=31.27 //y=0.175
c1020 ( 488 0 ) capacitor c=0.106974f //x=30.09 //y=0.175
c1021 ( 487 0 ) capacitor c=0.00446416f //x=27.94 //y=0.175
c1022 ( 486 0 ) capacitor c=0.10991f //x=26.76 //y=0.175
c1023 ( 485 0 ) capacitor c=0.00446464f //x=23.025 //y=0.175
c1024 ( 484 0 ) capacitor c=0.105876f //x=21.95 //y=0.175
c1025 ( 483 0 ) capacitor c=0.00446416f //x=19.73 //y=0.18
c1026 ( 481 0 ) capacitor c=0.107095f //x=18.62 //y=0.175
c1027 ( 480 0 ) capacitor c=0.00446416f //x=16.47 //y=0.175
c1028 ( 479 0 ) capacitor c=0.107095f //x=15.29 //y=0.175
c1029 ( 478 0 ) capacitor c=0.00446416f //x=13.14 //y=0.175
c1030 ( 477 0 ) capacitor c=0.107095f //x=11.96 //y=0.175
c1031 ( 476 0 ) capacitor c=0.00446416f //x=9.74 //y=0.18
c1032 ( 474 0 ) capacitor c=0.106974f //x=8.63 //y=0.175
c1033 ( 473 0 ) capacitor c=0.00446416f //x=6.48 //y=0.175
c1034 ( 472 0 ) capacitor c=0.109663f //x=5.3 //y=0.175
c1035 ( 471 0 ) capacitor c=0.00446464f //x=1.565 //y=0.175
c1036 ( 462 0 ) capacitor c=0.00583665f //x=76.46 //y=0.63
c1037 ( 459 0 ) capacitor c=0.00542565f //x=76.375 //y=0.715
c1038 ( 458 0 ) capacitor c=0.00479856f //x=75.975 //y=0.63
c1039 ( 455 0 ) capacitor c=0.00707849f //x=75.89 //y=0.715
c1040 ( 450 0 ) capacitor c=0.00588377f //x=75.49 //y=0.63
c1041 ( 447 0 ) capacitor c=0.0191899f //x=75.405 //y=0.175
c1042 ( 439 0 ) capacitor c=0.0758845f //x=74.69 //y=0.175
c1043 ( 431 0 ) capacitor c=0.0393378f //x=72.625 //y=0.175
c1044 ( 425 0 ) capacitor c=0.0725462f //x=71.36 //y=0.175
c1045 ( 419 0 ) capacitor c=0.0391794f //x=69.295 //y=0.175
c1046 ( 411 0 ) capacitor c=0.0726301f //x=68.03 //y=0.175
c1047 ( 403 0 ) capacitor c=0.039444f //x=65.965 //y=0.175
c1048 ( 395 0 ) capacitor c=0.0727058f //x=64.7 //y=0.175
c1049 ( 387 0 ) capacitor c=0.0392405f //x=62.635 //y=0.175
c1050 ( 381 0 ) capacitor c=0.0727058f //x=61.37 //y=0.175
c1051 ( 375 0 ) capacitor c=0.0392405f //x=59.305 //y=0.175
c1052 ( 367 0 ) capacitor c=0.0727058f //x=58.04 //y=0.175
c1053 ( 359 0 ) capacitor c=0.0392405f //x=55.975 //y=0.175
c1054 ( 351 0 ) capacitor c=0.0727058f //x=54.71 //y=0.175
c1055 ( 343 0 ) capacitor c=0.0392405f //x=52.645 //y=0.175
c1056 ( 337 0 ) capacitor c=0.0727058f //x=51.38 //y=0.175
c1057 ( 331 0 ) capacitor c=0.0392405f //x=49.315 //y=0.175
c1058 ( 321 0 ) capacitor c=0.135066f //x=48.05 //y=0.175
c1059 ( 315 0 ) capacitor c=0.0342713f //x=44.4 //y=0.175
c1060 ( 307 0 ) capacitor c=0.0727042f //x=43.24 //y=0.175
c1061 ( 299 0 ) capacitor c=0.0392405f //x=41.175 //y=0.175
c1062 ( 291 0 ) capacitor c=0.0727169f //x=39.91 //y=0.175
c1063 ( 283 0 ) capacitor c=0.0392556f //x=37.845 //y=0.175
c1064 ( 277 0 ) capacitor c=0.0727453f //x=36.58 //y=0.175
c1065 ( 271 0 ) capacitor c=0.0392556f //x=34.515 //y=0.175
c1066 ( 263 0 ) capacitor c=0.0727453f //x=33.25 //y=0.175
c1067 ( 255 0 ) capacitor c=0.0392556f //x=31.185 //y=0.175
c1068 ( 247 0 ) capacitor c=0.0727448f //x=29.92 //y=0.175
c1069 ( 239 0 ) capacitor c=0.0392556f //x=27.855 //y=0.175
c1070 ( 229 0 ) capacitor c=0.135219f //x=26.59 //y=0.175
c1071 ( 221 0 ) capacitor c=0.0342869f //x=22.94 //y=0.175
c1072 ( 215 0 ) capacitor c=0.0727453f //x=21.78 //y=0.175
c1073 ( 209 0 ) capacitor c=0.0392556f //x=19.715 //y=0.175
c1074 ( 201 0 ) capacitor c=0.0727453f //x=18.45 //y=0.175
c1075 ( 193 0 ) capacitor c=0.0392556f //x=16.385 //y=0.175
c1076 ( 185 0 ) capacitor c=0.0727453f //x=15.12 //y=0.175
c1077 ( 177 0 ) capacitor c=0.0392556f //x=13.055 //y=0.175
c1078 ( 171 0 ) capacitor c=0.0727453f //x=11.79 //y=0.175
c1079 ( 165 0 ) capacitor c=0.0392556f //x=9.725 //y=0.175
c1080 ( 157 0 ) capacitor c=0.072764f //x=8.46 //y=0.175
c1081 ( 149 0 ) capacitor c=0.0392803f //x=6.395 //y=0.175
c1082 ( 139 0 ) capacitor c=0.133468f //x=5.13 //y=0.175
c1083 ( 134 0 ) capacitor c=0.196955f //x=1.23 //y=0.18
c1084 ( 131 0 ) capacitor c=0.0370791f //x=1.48 //y=0.175
c1085 ( 127 0 ) capacitor c=2.4053f //x=76.34 //y=0.18
r1086 (  525 526 ) resistor r=4.18529 //w=0.367 //l=0.12 //layer=li \
 //thickness=0.1 //x=76.34 //y=0.175 //x2=76.46 //y2=0.175
r1087 (  523 525 ) resistor r=12.7302 //w=0.367 //l=0.365 //layer=li \
 //thickness=0.1 //x=75.975 //y=0.175 //x2=76.34 //y2=0.175
r1088 (  522 523 ) resistor r=13.079 //w=0.367 //l=0.375 //layer=li \
 //thickness=0.1 //x=75.6 //y=0.175 //x2=75.975 //y2=0.175
r1089 (  520 522 ) resistor r=3.83651 //w=0.367 //l=0.11 //layer=li \
 //thickness=0.1 //x=75.49 //y=0.175 //x2=75.6 //y2=0.175
r1090 (  463 554 ) resistor r=5.4201 //w=0.17 //l=0.085 //layer=li \
 //thickness=0.1 //x=76.46 //y=0.8 //x2=76.46 //y2=0.715
r1091 (  463 554 ) resistor r=41.4118 //w=0.187 //l=0.605 //layer=li \
 //thickness=0.1 //x=76.46 //y=0.8 //x2=76.46 //y2=1.405
r1092 (  462 554 ) resistor r=5.4201 //w=0.17 //l=0.085 //layer=li \
 //thickness=0.1 //x=76.46 //y=0.63 //x2=76.46 //y2=0.715
r1093 (  461 526 ) resistor r=5.21862 //w=0.35 //l=0.175 //layer=li \
 //thickness=0.1 //x=76.46 //y=0.35 //x2=76.46 //y2=0.175
r1094 (  461 462 ) resistor r=19.1658 //w=0.187 //l=0.28 //layer=li \
 //thickness=0.1 //x=76.46 //y=0.35 //x2=76.46 //y2=0.63
r1095 (  460 554 ) resistor r=5.4201 //w=0.17 //l=0.085 //layer=li \
 //thickness=0.1 //x=76.06 //y=0.715 //x2=75.975 //y2=0.715
r1096 (  459 554 ) resistor r=1.40859 //w=0.34 //l=0.085 //layer=li \
 //thickness=0.1 //x=76.375 //y=0.715 //x2=76.46 //y2=0.715
r1097 (  459 460 ) resistor r=21.5615 //w=0.187 //l=0.315 //layer=li \
 //thickness=0.1 //x=76.375 //y=0.715 //x2=76.06 //y2=0.715
r1098 (  458 554 ) resistor r=1.40859 //w=0.34 //l=0.085 //layer=li \
 //thickness=0.1 //x=75.975 //y=0.63 //x2=75.975 //y2=0.715
r1099 (  457 523 ) resistor r=5.21862 //w=0.35 //l=0.175 //layer=li \
 //thickness=0.1 //x=75.975 //y=0.35 //x2=75.975 //y2=0.175
r1100 (  457 458 ) resistor r=19.1658 //w=0.187 //l=0.28 //layer=li \
 //thickness=0.1 //x=75.975 //y=0.35 //x2=75.975 //y2=0.63
r1101 (  456 554 ) resistor r=1.40859 //w=0.34 //l=0.085 //layer=li \
 //thickness=0.1 //x=75.575 //y=0.715 //x2=75.49 //y2=0.715
r1102 (  455 554 ) resistor r=5.4201 //w=0.17 //l=0.085 //layer=li \
 //thickness=0.1 //x=75.89 //y=0.715 //x2=75.975 //y2=0.715
r1103 (  455 456 ) resistor r=21.5615 //w=0.187 //l=0.315 //layer=li \
 //thickness=0.1 //x=75.89 //y=0.715 //x2=75.575 //y2=0.715
r1104 (  451 554 ) resistor r=5.4201 //w=0.17 //l=0.085 //layer=li \
 //thickness=0.1 //x=75.49 //y=0.8 //x2=75.49 //y2=0.715
r1105 (  451 554 ) resistor r=41.4118 //w=0.187 //l=0.605 //layer=li \
 //thickness=0.1 //x=75.49 //y=0.8 //x2=75.49 //y2=1.405
r1106 (  450 554 ) resistor r=5.4201 //w=0.17 //l=0.085 //layer=li \
 //thickness=0.1 //x=75.49 //y=0.63 //x2=75.49 //y2=0.715
r1107 (  449 520 ) resistor r=5.21862 //w=0.35 //l=0.175 //layer=li \
 //thickness=0.1 //x=75.49 //y=0.35 //x2=75.49 //y2=0.175
r1108 (  449 450 ) resistor r=19.1658 //w=0.187 //l=0.28 //layer=li \
 //thickness=0.1 //x=75.49 //y=0.35 //x2=75.49 //y2=0.63
r1109 (  448 519 ) resistor r=5.29055 //w=0.35 //l=0.17 //layer=li \
 //thickness=0.1 //x=75.03 //y=0.175 //x2=74.86 //y2=0.175
r1110 (  447 520 ) resistor r=2.96458 //w=0.367 //l=0.085 //layer=li \
 //thickness=0.1 //x=75.405 //y=0.175 //x2=75.49 //y2=0.175
r1111 (  447 448 ) resistor r=13.079 //w=0.367 //l=0.375 //layer=li \
 //thickness=0.1 //x=75.405 //y=0.175 //x2=75.03 //y2=0.175
r1112 (  442 444 ) resistor r=38.7139 //w=0.367 //l=1.11 //layer=li \
 //thickness=0.1 //x=73.01 //y=0.175 //x2=74.12 //y2=0.175
r1113 (  440 518 ) resistor r=2.87058 //w=0.35 //l=0.085 //layer=li \
 //thickness=0.1 //x=72.795 //y=0.175 //x2=72.71 //y2=0.175
r1114 (  440 442 ) resistor r=7.49864 //w=0.367 //l=0.215 //layer=li \
 //thickness=0.1 //x=72.795 //y=0.175 //x2=73.01 //y2=0.175
r1115 (  439 519 ) resistor r=5.29055 //w=0.35 //l=0.17 //layer=li \
 //thickness=0.1 //x=74.69 //y=0.175 //x2=74.86 //y2=0.175
r1116 (  439 444 ) resistor r=19.8801 //w=0.367 //l=0.57 //layer=li \
 //thickness=0.1 //x=74.69 //y=0.175 //x2=74.12 //y2=0.175
r1117 (  435 518 ) resistor r=4.23183 //w=0.7 //l=0.175 //layer=li \
 //thickness=0.1 //x=72.71 //y=0.35 //x2=72.71 //y2=0.175
r1118 (  435 553 ) resistor r=53.7326 //w=0.187 //l=0.785 //layer=li \
 //thickness=0.1 //x=72.71 //y=0.35 //x2=72.71 //y2=1.135
r1119 (  432 517 ) resistor r=5.29055 //w=0.35 //l=0.17 //layer=li \
 //thickness=0.1 //x=71.7 //y=0.175 //x2=71.53 //y2=0.175
r1120 (  432 434 ) resistor r=6.97548 //w=0.367 //l=0.2 //layer=li \
 //thickness=0.1 //x=71.7 //y=0.175 //x2=71.9 //y2=0.175
r1121 (  431 518 ) resistor r=2.87058 //w=0.35 //l=0.085 //layer=li \
 //thickness=0.1 //x=72.625 //y=0.175 //x2=72.71 //y2=0.175
r1122 (  431 434 ) resistor r=25.2861 //w=0.367 //l=0.725 //layer=li \
 //thickness=0.1 //x=72.625 //y=0.175 //x2=71.9 //y2=0.175
r1123 (  426 516 ) resistor r=2.87058 //w=0.35 //l=0.085 //layer=li \
 //thickness=0.1 //x=69.465 //y=0.175 //x2=69.38 //y2=0.175
r1124 (  426 428 ) resistor r=33.3079 //w=0.367 //l=0.955 //layer=li \
 //thickness=0.1 //x=69.465 //y=0.175 //x2=70.42 //y2=0.175
r1125 (  425 517 ) resistor r=5.29055 //w=0.35 //l=0.17 //layer=li \
 //thickness=0.1 //x=71.36 //y=0.175 //x2=71.53 //y2=0.175
r1126 (  425 428 ) resistor r=32.7847 //w=0.367 //l=0.94 //layer=li \
 //thickness=0.1 //x=71.36 //y=0.175 //x2=70.42 //y2=0.175
r1127 (  421 516 ) resistor r=4.23183 //w=0.7 //l=0.175 //layer=li \
 //thickness=0.1 //x=69.38 //y=0.35 //x2=69.38 //y2=0.175
r1128 (  421 552 ) resistor r=53.7326 //w=0.187 //l=0.785 //layer=li \
 //thickness=0.1 //x=69.38 //y=0.35 //x2=69.38 //y2=1.135
r1129 (  420 514 ) resistor r=5.29055 //w=0.35 //l=0.17 //layer=li \
 //thickness=0.1 //x=68.37 //y=0.175 //x2=68.2 //y2=0.175
r1130 (  419 516 ) resistor r=2.87058 //w=0.35 //l=0.085 //layer=li \
 //thickness=0.1 //x=69.295 //y=0.175 //x2=69.38 //y2=0.175
r1131 (  419 420 ) resistor r=32.2616 //w=0.367 //l=0.925 //layer=li \
 //thickness=0.1 //x=69.295 //y=0.175 //x2=68.37 //y2=0.175
r1132 (  414 416 ) resistor r=38.7139 //w=0.367 //l=1.11 //layer=li \
 //thickness=0.1 //x=66.72 //y=0.175 //x2=67.83 //y2=0.175
r1133 (  412 513 ) resistor r=2.87058 //w=0.35 //l=0.085 //layer=li \
 //thickness=0.1 //x=66.135 //y=0.175 //x2=66.05 //y2=0.175
r1134 (  412 414 ) resistor r=20.4033 //w=0.367 //l=0.585 //layer=li \
 //thickness=0.1 //x=66.135 //y=0.175 //x2=66.72 //y2=0.175
r1135 (  411 514 ) resistor r=5.29055 //w=0.35 //l=0.17 //layer=li \
 //thickness=0.1 //x=68.03 //y=0.175 //x2=68.2 //y2=0.175
r1136 (  411 416 ) resistor r=6.97548 //w=0.367 //l=0.2 //layer=li \
 //thickness=0.1 //x=68.03 //y=0.175 //x2=67.83 //y2=0.175
r1137 (  407 513 ) resistor r=4.23183 //w=0.7 //l=0.175 //layer=li \
 //thickness=0.1 //x=66.05 //y=0.35 //x2=66.05 //y2=0.175
r1138 (  407 551 ) resistor r=53.7326 //w=0.187 //l=0.785 //layer=li \
 //thickness=0.1 //x=66.05 //y=0.35 //x2=66.05 //y2=1.135
r1139 (  404 512 ) resistor r=5.29055 //w=0.35 //l=0.17 //layer=li \
 //thickness=0.1 //x=65.04 //y=0.175 //x2=64.87 //y2=0.175
r1140 (  404 406 ) resistor r=19.8801 //w=0.367 //l=0.57 //layer=li \
 //thickness=0.1 //x=65.04 //y=0.175 //x2=65.61 //y2=0.175
r1141 (  403 513 ) resistor r=2.87058 //w=0.35 //l=0.085 //layer=li \
 //thickness=0.1 //x=65.965 //y=0.175 //x2=66.05 //y2=0.175
r1142 (  403 406 ) resistor r=12.3815 //w=0.367 //l=0.355 //layer=li \
 //thickness=0.1 //x=65.965 //y=0.175 //x2=65.61 //y2=0.175
r1143 (  398 400 ) resistor r=38.7139 //w=0.367 //l=1.11 //layer=li \
 //thickness=0.1 //x=63.02 //y=0.175 //x2=64.13 //y2=0.175
r1144 (  396 511 ) resistor r=2.87058 //w=0.35 //l=0.085 //layer=li \
 //thickness=0.1 //x=62.805 //y=0.175 //x2=62.72 //y2=0.175
r1145 (  396 398 ) resistor r=7.49864 //w=0.367 //l=0.215 //layer=li \
 //thickness=0.1 //x=62.805 //y=0.175 //x2=63.02 //y2=0.175
r1146 (  395 512 ) resistor r=5.29055 //w=0.35 //l=0.17 //layer=li \
 //thickness=0.1 //x=64.7 //y=0.175 //x2=64.87 //y2=0.175
r1147 (  395 400 ) resistor r=19.8801 //w=0.367 //l=0.57 //layer=li \
 //thickness=0.1 //x=64.7 //y=0.175 //x2=64.13 //y2=0.175
r1148 (  391 511 ) resistor r=4.23183 //w=0.7 //l=0.175 //layer=li \
 //thickness=0.1 //x=62.72 //y=0.35 //x2=62.72 //y2=0.175
r1149 (  391 550 ) resistor r=53.7326 //w=0.187 //l=0.785 //layer=li \
 //thickness=0.1 //x=62.72 //y=0.35 //x2=62.72 //y2=1.135
r1150 (  388 510 ) resistor r=5.29055 //w=0.35 //l=0.17 //layer=li \
 //thickness=0.1 //x=61.71 //y=0.175 //x2=61.54 //y2=0.175
r1151 (  388 390 ) resistor r=6.97548 //w=0.367 //l=0.2 //layer=li \
 //thickness=0.1 //x=61.71 //y=0.175 //x2=61.91 //y2=0.175
r1152 (  387 511 ) resistor r=2.87058 //w=0.35 //l=0.085 //layer=li \
 //thickness=0.1 //x=62.635 //y=0.175 //x2=62.72 //y2=0.175
r1153 (  387 390 ) resistor r=25.2861 //w=0.367 //l=0.725 //layer=li \
 //thickness=0.1 //x=62.635 //y=0.175 //x2=61.91 //y2=0.175
r1154 (  382 509 ) resistor r=2.87058 //w=0.35 //l=0.085 //layer=li \
 //thickness=0.1 //x=59.475 //y=0.175 //x2=59.39 //y2=0.175
r1155 (  382 384 ) resistor r=33.3079 //w=0.367 //l=0.955 //layer=li \
 //thickness=0.1 //x=59.475 //y=0.175 //x2=60.43 //y2=0.175
r1156 (  381 510 ) resistor r=5.29055 //w=0.35 //l=0.17 //layer=li \
 //thickness=0.1 //x=61.37 //y=0.175 //x2=61.54 //y2=0.175
r1157 (  381 384 ) resistor r=32.7847 //w=0.367 //l=0.94 //layer=li \
 //thickness=0.1 //x=61.37 //y=0.175 //x2=60.43 //y2=0.175
r1158 (  377 509 ) resistor r=4.23183 //w=0.7 //l=0.175 //layer=li \
 //thickness=0.1 //x=59.39 //y=0.35 //x2=59.39 //y2=0.175
r1159 (  377 549 ) resistor r=53.7326 //w=0.187 //l=0.785 //layer=li \
 //thickness=0.1 //x=59.39 //y=0.35 //x2=59.39 //y2=1.135
r1160 (  376 507 ) resistor r=5.29055 //w=0.35 //l=0.17 //layer=li \
 //thickness=0.1 //x=58.38 //y=0.175 //x2=58.21 //y2=0.175
r1161 (  375 509 ) resistor r=2.87058 //w=0.35 //l=0.085 //layer=li \
 //thickness=0.1 //x=59.305 //y=0.175 //x2=59.39 //y2=0.175
r1162 (  375 376 ) resistor r=32.2616 //w=0.367 //l=0.925 //layer=li \
 //thickness=0.1 //x=59.305 //y=0.175 //x2=58.38 //y2=0.175
r1163 (  370 372 ) resistor r=38.7139 //w=0.367 //l=1.11 //layer=li \
 //thickness=0.1 //x=56.73 //y=0.175 //x2=57.84 //y2=0.175
r1164 (  368 506 ) resistor r=2.87058 //w=0.35 //l=0.085 //layer=li \
 //thickness=0.1 //x=56.145 //y=0.175 //x2=56.06 //y2=0.175
r1165 (  368 370 ) resistor r=20.4033 //w=0.367 //l=0.585 //layer=li \
 //thickness=0.1 //x=56.145 //y=0.175 //x2=56.73 //y2=0.175
r1166 (  367 507 ) resistor r=5.29055 //w=0.35 //l=0.17 //layer=li \
 //thickness=0.1 //x=58.04 //y=0.175 //x2=58.21 //y2=0.175
r1167 (  367 372 ) resistor r=6.97548 //w=0.367 //l=0.2 //layer=li \
 //thickness=0.1 //x=58.04 //y=0.175 //x2=57.84 //y2=0.175
r1168 (  363 506 ) resistor r=4.23183 //w=0.7 //l=0.175 //layer=li \
 //thickness=0.1 //x=56.06 //y=0.35 //x2=56.06 //y2=0.175
r1169 (  363 548 ) resistor r=53.7326 //w=0.187 //l=0.785 //layer=li \
 //thickness=0.1 //x=56.06 //y=0.35 //x2=56.06 //y2=1.135
r1170 (  360 505 ) resistor r=5.29055 //w=0.35 //l=0.17 //layer=li \
 //thickness=0.1 //x=55.05 //y=0.175 //x2=54.88 //y2=0.175
r1171 (  360 362 ) resistor r=19.8801 //w=0.367 //l=0.57 //layer=li \
 //thickness=0.1 //x=55.05 //y=0.175 //x2=55.62 //y2=0.175
r1172 (  359 506 ) resistor r=2.87058 //w=0.35 //l=0.085 //layer=li \
 //thickness=0.1 //x=55.975 //y=0.175 //x2=56.06 //y2=0.175
r1173 (  359 362 ) resistor r=12.3815 //w=0.367 //l=0.355 //layer=li \
 //thickness=0.1 //x=55.975 //y=0.175 //x2=55.62 //y2=0.175
r1174 (  354 356 ) resistor r=38.7139 //w=0.367 //l=1.11 //layer=li \
 //thickness=0.1 //x=53.03 //y=0.175 //x2=54.14 //y2=0.175
r1175 (  352 504 ) resistor r=2.87058 //w=0.35 //l=0.085 //layer=li \
 //thickness=0.1 //x=52.815 //y=0.175 //x2=52.73 //y2=0.175
r1176 (  352 354 ) resistor r=7.49864 //w=0.367 //l=0.215 //layer=li \
 //thickness=0.1 //x=52.815 //y=0.175 //x2=53.03 //y2=0.175
r1177 (  351 505 ) resistor r=5.29055 //w=0.35 //l=0.17 //layer=li \
 //thickness=0.1 //x=54.71 //y=0.175 //x2=54.88 //y2=0.175
r1178 (  351 356 ) resistor r=19.8801 //w=0.367 //l=0.57 //layer=li \
 //thickness=0.1 //x=54.71 //y=0.175 //x2=54.14 //y2=0.175
r1179 (  347 504 ) resistor r=4.23183 //w=0.7 //l=0.175 //layer=li \
 //thickness=0.1 //x=52.73 //y=0.35 //x2=52.73 //y2=0.175
r1180 (  347 547 ) resistor r=53.7326 //w=0.187 //l=0.785 //layer=li \
 //thickness=0.1 //x=52.73 //y=0.35 //x2=52.73 //y2=1.135
r1181 (  344 503 ) resistor r=5.29055 //w=0.35 //l=0.17 //layer=li \
 //thickness=0.1 //x=51.72 //y=0.175 //x2=51.55 //y2=0.175
r1182 (  344 346 ) resistor r=6.97548 //w=0.367 //l=0.2 //layer=li \
 //thickness=0.1 //x=51.72 //y=0.175 //x2=51.92 //y2=0.175
r1183 (  343 504 ) resistor r=2.87058 //w=0.35 //l=0.085 //layer=li \
 //thickness=0.1 //x=52.645 //y=0.175 //x2=52.73 //y2=0.175
r1184 (  343 346 ) resistor r=25.2861 //w=0.367 //l=0.725 //layer=li \
 //thickness=0.1 //x=52.645 //y=0.175 //x2=51.92 //y2=0.175
r1185 (  338 502 ) resistor r=2.87058 //w=0.35 //l=0.085 //layer=li \
 //thickness=0.1 //x=49.485 //y=0.175 //x2=49.4 //y2=0.175
r1186 (  338 340 ) resistor r=33.3079 //w=0.367 //l=0.955 //layer=li \
 //thickness=0.1 //x=49.485 //y=0.175 //x2=50.44 //y2=0.175
r1187 (  337 503 ) resistor r=5.29055 //w=0.35 //l=0.17 //layer=li \
 //thickness=0.1 //x=51.38 //y=0.175 //x2=51.55 //y2=0.175
r1188 (  337 340 ) resistor r=32.7847 //w=0.367 //l=0.94 //layer=li \
 //thickness=0.1 //x=51.38 //y=0.175 //x2=50.44 //y2=0.175
r1189 (  333 502 ) resistor r=4.23183 //w=0.7 //l=0.175 //layer=li \
 //thickness=0.1 //x=49.4 //y=0.35 //x2=49.4 //y2=0.175
r1190 (  333 546 ) resistor r=53.7326 //w=0.187 //l=0.785 //layer=li \
 //thickness=0.1 //x=49.4 //y=0.35 //x2=49.4 //y2=1.135
r1191 (  332 500 ) resistor r=5.29055 //w=0.35 //l=0.17 //layer=li \
 //thickness=0.1 //x=48.39 //y=0.175 //x2=48.22 //y2=0.175
r1192 (  331 502 ) resistor r=2.87058 //w=0.35 //l=0.085 //layer=li \
 //thickness=0.1 //x=49.315 //y=0.175 //x2=49.4 //y2=0.175
r1193 (  331 332 ) resistor r=32.2616 //w=0.367 //l=0.925 //layer=li \
 //thickness=0.1 //x=49.315 //y=0.175 //x2=48.39 //y2=0.175
r1194 (  326 328 ) resistor r=38.7139 //w=0.367 //l=1.11 //layer=li \
 //thickness=0.1 //x=46.74 //y=0.175 //x2=47.85 //y2=0.175
r1195 (  324 326 ) resistor r=38.7139 //w=0.367 //l=1.11 //layer=li \
 //thickness=0.1 //x=45.63 //y=0.175 //x2=46.74 //y2=0.175
r1196 (  322 499 ) resistor r=2.87058 //w=0.35 //l=0.085 //layer=li \
 //thickness=0.1 //x=44.57 //y=0.175 //x2=44.485 //y2=0.175
r1197 (  322 324 ) resistor r=36.97 //w=0.367 //l=1.06 //layer=li \
 //thickness=0.1 //x=44.57 //y=0.175 //x2=45.63 //y2=0.175
r1198 (  321 500 ) resistor r=5.29055 //w=0.35 //l=0.17 //layer=li \
 //thickness=0.1 //x=48.05 //y=0.175 //x2=48.22 //y2=0.175
r1199 (  321 328 ) resistor r=6.97548 //w=0.367 //l=0.2 //layer=li \
 //thickness=0.1 //x=48.05 //y=0.175 //x2=47.85 //y2=0.175
r1200 (  317 499 ) resistor r=4.23183 //w=0.7 //l=0.175 //layer=li \
 //thickness=0.1 //x=44.485 //y=0.35 //x2=44.485 //y2=0.175
r1201 (  317 545 ) resistor r=54.4171 //w=0.187 //l=0.795 //layer=li \
 //thickness=0.1 //x=44.485 //y=0.35 //x2=44.485 //y2=1.145
r1202 (  316 497 ) resistor r=5.29055 //w=0.35 //l=0.17 //layer=li \
 //thickness=0.1 //x=43.58 //y=0.175 //x2=43.41 //y2=0.175
r1203 (  315 499 ) resistor r=2.87058 //w=0.35 //l=0.085 //layer=li \
 //thickness=0.1 //x=44.4 //y=0.175 //x2=44.485 //y2=0.175
r1204 (  315 316 ) resistor r=28.5995 //w=0.367 //l=0.82 //layer=li \
 //thickness=0.1 //x=44.4 //y=0.175 //x2=43.58 //y2=0.175
r1205 (  310 312 ) resistor r=38.7139 //w=0.367 //l=1.11 //layer=li \
 //thickness=0.1 //x=41.93 //y=0.175 //x2=43.04 //y2=0.175
r1206 (  308 496 ) resistor r=2.87058 //w=0.35 //l=0.085 //layer=li \
 //thickness=0.1 //x=41.345 //y=0.175 //x2=41.26 //y2=0.175
r1207 (  308 310 ) resistor r=20.4033 //w=0.367 //l=0.585 //layer=li \
 //thickness=0.1 //x=41.345 //y=0.175 //x2=41.93 //y2=0.175
r1208 (  307 497 ) resistor r=5.29055 //w=0.35 //l=0.17 //layer=li \
 //thickness=0.1 //x=43.24 //y=0.175 //x2=43.41 //y2=0.175
r1209 (  307 312 ) resistor r=6.97548 //w=0.367 //l=0.2 //layer=li \
 //thickness=0.1 //x=43.24 //y=0.175 //x2=43.04 //y2=0.175
r1210 (  303 496 ) resistor r=4.23183 //w=0.7 //l=0.175 //layer=li \
 //thickness=0.1 //x=41.26 //y=0.35 //x2=41.26 //y2=0.175
r1211 (  303 544 ) resistor r=53.7326 //w=0.187 //l=0.785 //layer=li \
 //thickness=0.1 //x=41.26 //y=0.35 //x2=41.26 //y2=1.135
r1212 (  300 495 ) resistor r=5.29055 //w=0.35 //l=0.17 //layer=li \
 //thickness=0.1 //x=40.25 //y=0.175 //x2=40.08 //y2=0.175
r1213 (  300 302 ) resistor r=19.8801 //w=0.367 //l=0.57 //layer=li \
 //thickness=0.1 //x=40.25 //y=0.175 //x2=40.82 //y2=0.175
r1214 (  299 496 ) resistor r=2.87058 //w=0.35 //l=0.085 //layer=li \
 //thickness=0.1 //x=41.175 //y=0.175 //x2=41.26 //y2=0.175
r1215 (  299 302 ) resistor r=12.3815 //w=0.367 //l=0.355 //layer=li \
 //thickness=0.1 //x=41.175 //y=0.175 //x2=40.82 //y2=0.175
r1216 (  294 296 ) resistor r=38.7139 //w=0.367 //l=1.11 //layer=li \
 //thickness=0.1 //x=38.23 //y=0.175 //x2=39.34 //y2=0.175
r1217 (  292 494 ) resistor r=2.87058 //w=0.35 //l=0.085 //layer=li \
 //thickness=0.1 //x=38.015 //y=0.175 //x2=37.93 //y2=0.175
r1218 (  292 294 ) resistor r=7.49864 //w=0.367 //l=0.215 //layer=li \
 //thickness=0.1 //x=38.015 //y=0.175 //x2=38.23 //y2=0.175
r1219 (  291 495 ) resistor r=5.29055 //w=0.35 //l=0.17 //layer=li \
 //thickness=0.1 //x=39.91 //y=0.175 //x2=40.08 //y2=0.175
r1220 (  291 296 ) resistor r=19.8801 //w=0.367 //l=0.57 //layer=li \
 //thickness=0.1 //x=39.91 //y=0.175 //x2=39.34 //y2=0.175
r1221 (  287 494 ) resistor r=4.23183 //w=0.7 //l=0.175 //layer=li \
 //thickness=0.1 //x=37.93 //y=0.35 //x2=37.93 //y2=0.175
r1222 (  287 543 ) resistor r=53.7326 //w=0.187 //l=0.785 //layer=li \
 //thickness=0.1 //x=37.93 //y=0.35 //x2=37.93 //y2=1.135
r1223 (  284 493 ) resistor r=5.29055 //w=0.35 //l=0.17 //layer=li \
 //thickness=0.1 //x=36.92 //y=0.175 //x2=36.75 //y2=0.175
r1224 (  284 286 ) resistor r=6.97548 //w=0.367 //l=0.2 //layer=li \
 //thickness=0.1 //x=36.92 //y=0.175 //x2=37.12 //y2=0.175
r1225 (  283 494 ) resistor r=2.87058 //w=0.35 //l=0.085 //layer=li \
 //thickness=0.1 //x=37.845 //y=0.175 //x2=37.93 //y2=0.175
r1226 (  283 286 ) resistor r=25.2861 //w=0.367 //l=0.725 //layer=li \
 //thickness=0.1 //x=37.845 //y=0.175 //x2=37.12 //y2=0.175
r1227 (  278 492 ) resistor r=2.87058 //w=0.35 //l=0.085 //layer=li \
 //thickness=0.1 //x=34.685 //y=0.175 //x2=34.6 //y2=0.175
r1228 (  278 280 ) resistor r=33.3079 //w=0.367 //l=0.955 //layer=li \
 //thickness=0.1 //x=34.685 //y=0.175 //x2=35.64 //y2=0.175
r1229 (  277 493 ) resistor r=5.29055 //w=0.35 //l=0.17 //layer=li \
 //thickness=0.1 //x=36.58 //y=0.175 //x2=36.75 //y2=0.175
r1230 (  277 280 ) resistor r=32.7847 //w=0.367 //l=0.94 //layer=li \
 //thickness=0.1 //x=36.58 //y=0.175 //x2=35.64 //y2=0.175
r1231 (  273 492 ) resistor r=4.23183 //w=0.7 //l=0.175 //layer=li \
 //thickness=0.1 //x=34.6 //y=0.35 //x2=34.6 //y2=0.175
r1232 (  273 542 ) resistor r=53.7326 //w=0.187 //l=0.785 //layer=li \
 //thickness=0.1 //x=34.6 //y=0.35 //x2=34.6 //y2=1.135
r1233 (  272 490 ) resistor r=5.29055 //w=0.35 //l=0.17 //layer=li \
 //thickness=0.1 //x=33.59 //y=0.175 //x2=33.42 //y2=0.175
r1234 (  271 492 ) resistor r=2.87058 //w=0.35 //l=0.085 //layer=li \
 //thickness=0.1 //x=34.515 //y=0.175 //x2=34.6 //y2=0.175
r1235 (  271 272 ) resistor r=32.2616 //w=0.367 //l=0.925 //layer=li \
 //thickness=0.1 //x=34.515 //y=0.175 //x2=33.59 //y2=0.175
r1236 (  266 268 ) resistor r=38.7139 //w=0.367 //l=1.11 //layer=li \
 //thickness=0.1 //x=31.94 //y=0.175 //x2=33.05 //y2=0.175
r1237 (  264 489 ) resistor r=2.87058 //w=0.35 //l=0.085 //layer=li \
 //thickness=0.1 //x=31.355 //y=0.175 //x2=31.27 //y2=0.175
r1238 (  264 266 ) resistor r=20.4033 //w=0.367 //l=0.585 //layer=li \
 //thickness=0.1 //x=31.355 //y=0.175 //x2=31.94 //y2=0.175
r1239 (  263 490 ) resistor r=5.29055 //w=0.35 //l=0.17 //layer=li \
 //thickness=0.1 //x=33.25 //y=0.175 //x2=33.42 //y2=0.175
r1240 (  263 268 ) resistor r=6.97548 //w=0.367 //l=0.2 //layer=li \
 //thickness=0.1 //x=33.25 //y=0.175 //x2=33.05 //y2=0.175
r1241 (  259 489 ) resistor r=4.23183 //w=0.7 //l=0.175 //layer=li \
 //thickness=0.1 //x=31.27 //y=0.35 //x2=31.27 //y2=0.175
r1242 (  259 541 ) resistor r=53.7326 //w=0.187 //l=0.785 //layer=li \
 //thickness=0.1 //x=31.27 //y=0.35 //x2=31.27 //y2=1.135
r1243 (  256 488 ) resistor r=5.29055 //w=0.35 //l=0.17 //layer=li \
 //thickness=0.1 //x=30.26 //y=0.175 //x2=30.09 //y2=0.175
r1244 (  256 258 ) resistor r=19.8801 //w=0.367 //l=0.57 //layer=li \
 //thickness=0.1 //x=30.26 //y=0.175 //x2=30.83 //y2=0.175
r1245 (  255 489 ) resistor r=2.87058 //w=0.35 //l=0.085 //layer=li \
 //thickness=0.1 //x=31.185 //y=0.175 //x2=31.27 //y2=0.175
r1246 (  255 258 ) resistor r=12.3815 //w=0.367 //l=0.355 //layer=li \
 //thickness=0.1 //x=31.185 //y=0.175 //x2=30.83 //y2=0.175
r1247 (  250 252 ) resistor r=38.7139 //w=0.367 //l=1.11 //layer=li \
 //thickness=0.1 //x=28.24 //y=0.175 //x2=29.35 //y2=0.175
r1248 (  248 487 ) resistor r=2.87058 //w=0.35 //l=0.085 //layer=li \
 //thickness=0.1 //x=28.025 //y=0.175 //x2=27.94 //y2=0.175
r1249 (  248 250 ) resistor r=7.49864 //w=0.367 //l=0.215 //layer=li \
 //thickness=0.1 //x=28.025 //y=0.175 //x2=28.24 //y2=0.175
r1250 (  247 488 ) resistor r=5.29055 //w=0.35 //l=0.17 //layer=li \
 //thickness=0.1 //x=29.92 //y=0.175 //x2=30.09 //y2=0.175
r1251 (  247 252 ) resistor r=19.8801 //w=0.367 //l=0.57 //layer=li \
 //thickness=0.1 //x=29.92 //y=0.175 //x2=29.35 //y2=0.175
r1252 (  243 487 ) resistor r=4.23183 //w=0.7 //l=0.175 //layer=li \
 //thickness=0.1 //x=27.94 //y=0.35 //x2=27.94 //y2=0.175
r1253 (  243 540 ) resistor r=53.7326 //w=0.187 //l=0.785 //layer=li \
 //thickness=0.1 //x=27.94 //y=0.35 //x2=27.94 //y2=1.135
r1254 (  240 486 ) resistor r=5.29055 //w=0.35 //l=0.17 //layer=li \
 //thickness=0.1 //x=26.93 //y=0.175 //x2=26.76 //y2=0.175
r1255 (  240 242 ) resistor r=6.97548 //w=0.367 //l=0.2 //layer=li \
 //thickness=0.1 //x=26.93 //y=0.175 //x2=27.13 //y2=0.175
r1256 (  239 487 ) resistor r=2.87058 //w=0.35 //l=0.085 //layer=li \
 //thickness=0.1 //x=27.855 //y=0.175 //x2=27.94 //y2=0.175
r1257 (  239 242 ) resistor r=25.2861 //w=0.367 //l=0.725 //layer=li \
 //thickness=0.1 //x=27.855 //y=0.175 //x2=27.13 //y2=0.175
r1258 (  234 236 ) resistor r=38.7139 //w=0.367 //l=1.11 //layer=li \
 //thickness=0.1 //x=24.54 //y=0.175 //x2=25.65 //y2=0.175
r1259 (  232 234 ) resistor r=38.7139 //w=0.367 //l=1.11 //layer=li \
 //thickness=0.1 //x=23.43 //y=0.175 //x2=24.54 //y2=0.175
r1260 (  230 485 ) resistor r=2.87058 //w=0.35 //l=0.085 //layer=li \
 //thickness=0.1 //x=23.11 //y=0.175 //x2=23.025 //y2=0.175
r1261 (  230 232 ) resistor r=11.1608 //w=0.367 //l=0.32 //layer=li \
 //thickness=0.1 //x=23.11 //y=0.175 //x2=23.43 //y2=0.175
r1262 (  229 486 ) resistor r=5.29055 //w=0.35 //l=0.17 //layer=li \
 //thickness=0.1 //x=26.59 //y=0.175 //x2=26.76 //y2=0.175
r1263 (  229 236 ) resistor r=32.7847 //w=0.367 //l=0.94 //layer=li \
 //thickness=0.1 //x=26.59 //y=0.175 //x2=25.65 //y2=0.175
r1264 (  225 485 ) resistor r=4.23183 //w=0.7 //l=0.175 //layer=li \
 //thickness=0.1 //x=23.025 //y=0.35 //x2=23.025 //y2=0.175
r1265 (  225 539 ) resistor r=54.4171 //w=0.187 //l=0.795 //layer=li \
 //thickness=0.1 //x=23.025 //y=0.35 //x2=23.025 //y2=1.145
r1266 (  222 484 ) resistor r=5.29055 //w=0.35 //l=0.17 //layer=li \
 //thickness=0.1 //x=22.12 //y=0.175 //x2=21.95 //y2=0.175
r1267 (  222 224 ) resistor r=6.97548 //w=0.367 //l=0.2 //layer=li \
 //thickness=0.1 //x=22.12 //y=0.175 //x2=22.32 //y2=0.175
r1268 (  221 485 ) resistor r=2.87058 //w=0.35 //l=0.085 //layer=li \
 //thickness=0.1 //x=22.94 //y=0.175 //x2=23.025 //y2=0.175
r1269 (  221 224 ) resistor r=21.624 //w=0.367 //l=0.62 //layer=li \
 //thickness=0.1 //x=22.94 //y=0.175 //x2=22.32 //y2=0.175
r1270 (  216 483 ) resistor r=2.87058 //w=0.35 //l=0.085 //layer=li \
 //thickness=0.1 //x=19.885 //y=0.175 //x2=19.8 //y2=0.175
r1271 (  216 218 ) resistor r=33.3079 //w=0.367 //l=0.955 //layer=li \
 //thickness=0.1 //x=19.885 //y=0.175 //x2=20.84 //y2=0.175
r1272 (  215 484 ) resistor r=5.29055 //w=0.35 //l=0.17 //layer=li \
 //thickness=0.1 //x=21.78 //y=0.175 //x2=21.95 //y2=0.175
r1273 (  215 218 ) resistor r=32.7847 //w=0.367 //l=0.94 //layer=li \
 //thickness=0.1 //x=21.78 //y=0.175 //x2=20.84 //y2=0.175
r1274 (  211 483 ) resistor r=4.23183 //w=0.7 //l=0.175 //layer=li \
 //thickness=0.1 //x=19.8 //y=0.35 //x2=19.8 //y2=0.175
r1275 (  211 538 ) resistor r=53.7326 //w=0.187 //l=0.785 //layer=li \
 //thickness=0.1 //x=19.8 //y=0.35 //x2=19.8 //y2=1.135
r1276 (  210 481 ) resistor r=5.29055 //w=0.35 //l=0.17 //layer=li \
 //thickness=0.1 //x=18.79 //y=0.175 //x2=18.62 //y2=0.175
r1277 (  209 483 ) resistor r=2.87058 //w=0.35 //l=0.085 //layer=li \
 //thickness=0.1 //x=19.715 //y=0.175 //x2=19.8 //y2=0.175
r1278 (  209 210 ) resistor r=32.2616 //w=0.367 //l=0.925 //layer=li \
 //thickness=0.1 //x=19.715 //y=0.175 //x2=18.79 //y2=0.175
r1279 (  204 206 ) resistor r=38.7139 //w=0.367 //l=1.11 //layer=li \
 //thickness=0.1 //x=17.14 //y=0.175 //x2=18.25 //y2=0.175
r1280 (  202 480 ) resistor r=2.87058 //w=0.35 //l=0.085 //layer=li \
 //thickness=0.1 //x=16.555 //y=0.175 //x2=16.47 //y2=0.175
r1281 (  202 204 ) resistor r=20.4033 //w=0.367 //l=0.585 //layer=li \
 //thickness=0.1 //x=16.555 //y=0.175 //x2=17.14 //y2=0.175
r1282 (  201 481 ) resistor r=5.29055 //w=0.35 //l=0.17 //layer=li \
 //thickness=0.1 //x=18.45 //y=0.175 //x2=18.62 //y2=0.175
r1283 (  201 206 ) resistor r=6.97548 //w=0.367 //l=0.2 //layer=li \
 //thickness=0.1 //x=18.45 //y=0.175 //x2=18.25 //y2=0.175
r1284 (  197 480 ) resistor r=4.23183 //w=0.7 //l=0.175 //layer=li \
 //thickness=0.1 //x=16.47 //y=0.35 //x2=16.47 //y2=0.175
r1285 (  197 537 ) resistor r=53.7326 //w=0.187 //l=0.785 //layer=li \
 //thickness=0.1 //x=16.47 //y=0.35 //x2=16.47 //y2=1.135
r1286 (  194 479 ) resistor r=5.29055 //w=0.35 //l=0.17 //layer=li \
 //thickness=0.1 //x=15.46 //y=0.175 //x2=15.29 //y2=0.175
r1287 (  194 196 ) resistor r=19.8801 //w=0.367 //l=0.57 //layer=li \
 //thickness=0.1 //x=15.46 //y=0.175 //x2=16.03 //y2=0.175
r1288 (  193 480 ) resistor r=2.87058 //w=0.35 //l=0.085 //layer=li \
 //thickness=0.1 //x=16.385 //y=0.175 //x2=16.47 //y2=0.175
r1289 (  193 196 ) resistor r=12.3815 //w=0.367 //l=0.355 //layer=li \
 //thickness=0.1 //x=16.385 //y=0.175 //x2=16.03 //y2=0.175
r1290 (  188 190 ) resistor r=38.7139 //w=0.367 //l=1.11 //layer=li \
 //thickness=0.1 //x=13.44 //y=0.175 //x2=14.55 //y2=0.175
r1291 (  186 478 ) resistor r=2.87058 //w=0.35 //l=0.085 //layer=li \
 //thickness=0.1 //x=13.225 //y=0.175 //x2=13.14 //y2=0.175
r1292 (  186 188 ) resistor r=7.49864 //w=0.367 //l=0.215 //layer=li \
 //thickness=0.1 //x=13.225 //y=0.175 //x2=13.44 //y2=0.175
r1293 (  185 479 ) resistor r=5.29055 //w=0.35 //l=0.17 //layer=li \
 //thickness=0.1 //x=15.12 //y=0.175 //x2=15.29 //y2=0.175
r1294 (  185 190 ) resistor r=19.8801 //w=0.367 //l=0.57 //layer=li \
 //thickness=0.1 //x=15.12 //y=0.175 //x2=14.55 //y2=0.175
r1295 (  181 478 ) resistor r=4.23183 //w=0.7 //l=0.175 //layer=li \
 //thickness=0.1 //x=13.14 //y=0.35 //x2=13.14 //y2=0.175
r1296 (  181 536 ) resistor r=53.7326 //w=0.187 //l=0.785 //layer=li \
 //thickness=0.1 //x=13.14 //y=0.35 //x2=13.14 //y2=1.135
r1297 (  178 477 ) resistor r=5.29055 //w=0.35 //l=0.17 //layer=li \
 //thickness=0.1 //x=12.13 //y=0.175 //x2=11.96 //y2=0.175
r1298 (  178 180 ) resistor r=6.97548 //w=0.367 //l=0.2 //layer=li \
 //thickness=0.1 //x=12.13 //y=0.175 //x2=12.33 //y2=0.175
r1299 (  177 478 ) resistor r=2.87058 //w=0.35 //l=0.085 //layer=li \
 //thickness=0.1 //x=13.055 //y=0.175 //x2=13.14 //y2=0.175
r1300 (  177 180 ) resistor r=25.2861 //w=0.367 //l=0.725 //layer=li \
 //thickness=0.1 //x=13.055 //y=0.175 //x2=12.33 //y2=0.175
r1301 (  172 476 ) resistor r=2.87058 //w=0.35 //l=0.085 //layer=li \
 //thickness=0.1 //x=9.895 //y=0.175 //x2=9.81 //y2=0.175
r1302 (  172 174 ) resistor r=33.3079 //w=0.367 //l=0.955 //layer=li \
 //thickness=0.1 //x=9.895 //y=0.175 //x2=10.85 //y2=0.175
r1303 (  171 477 ) resistor r=5.29055 //w=0.35 //l=0.17 //layer=li \
 //thickness=0.1 //x=11.79 //y=0.175 //x2=11.96 //y2=0.175
r1304 (  171 174 ) resistor r=32.7847 //w=0.367 //l=0.94 //layer=li \
 //thickness=0.1 //x=11.79 //y=0.175 //x2=10.85 //y2=0.175
r1305 (  167 476 ) resistor r=4.23183 //w=0.7 //l=0.175 //layer=li \
 //thickness=0.1 //x=9.81 //y=0.35 //x2=9.81 //y2=0.175
r1306 (  167 535 ) resistor r=53.7326 //w=0.187 //l=0.785 //layer=li \
 //thickness=0.1 //x=9.81 //y=0.35 //x2=9.81 //y2=1.135
r1307 (  166 474 ) resistor r=5.29055 //w=0.35 //l=0.17 //layer=li \
 //thickness=0.1 //x=8.8 //y=0.175 //x2=8.63 //y2=0.175
r1308 (  165 476 ) resistor r=2.87058 //w=0.35 //l=0.085 //layer=li \
 //thickness=0.1 //x=9.725 //y=0.175 //x2=9.81 //y2=0.175
r1309 (  165 166 ) resistor r=32.2616 //w=0.367 //l=0.925 //layer=li \
 //thickness=0.1 //x=9.725 //y=0.175 //x2=8.8 //y2=0.175
r1310 (  160 162 ) resistor r=38.7139 //w=0.367 //l=1.11 //layer=li \
 //thickness=0.1 //x=7.15 //y=0.175 //x2=8.26 //y2=0.175
r1311 (  158 473 ) resistor r=2.87058 //w=0.35 //l=0.085 //layer=li \
 //thickness=0.1 //x=6.565 //y=0.175 //x2=6.48 //y2=0.175
r1312 (  158 160 ) resistor r=20.4033 //w=0.367 //l=0.585 //layer=li \
 //thickness=0.1 //x=6.565 //y=0.175 //x2=7.15 //y2=0.175
r1313 (  157 474 ) resistor r=5.29055 //w=0.35 //l=0.17 //layer=li \
 //thickness=0.1 //x=8.46 //y=0.175 //x2=8.63 //y2=0.175
r1314 (  157 162 ) resistor r=6.97548 //w=0.367 //l=0.2 //layer=li \
 //thickness=0.1 //x=8.46 //y=0.175 //x2=8.26 //y2=0.175
r1315 (  153 473 ) resistor r=4.23183 //w=0.7 //l=0.175 //layer=li \
 //thickness=0.1 //x=6.48 //y=0.35 //x2=6.48 //y2=0.175
r1316 (  153 534 ) resistor r=53.7326 //w=0.187 //l=0.785 //layer=li \
 //thickness=0.1 //x=6.48 //y=0.35 //x2=6.48 //y2=1.135
r1317 (  150 472 ) resistor r=5.29055 //w=0.35 //l=0.17 //layer=li \
 //thickness=0.1 //x=5.47 //y=0.175 //x2=5.3 //y2=0.175
r1318 (  150 152 ) resistor r=19.8801 //w=0.367 //l=0.57 //layer=li \
 //thickness=0.1 //x=5.47 //y=0.175 //x2=6.04 //y2=0.175
r1319 (  149 473 ) resistor r=2.87058 //w=0.35 //l=0.085 //layer=li \
 //thickness=0.1 //x=6.395 //y=0.175 //x2=6.48 //y2=0.175
r1320 (  149 152 ) resistor r=12.3815 //w=0.367 //l=0.355 //layer=li \
 //thickness=0.1 //x=6.395 //y=0.175 //x2=6.04 //y2=0.175
r1321 (  144 146 ) resistor r=38.7139 //w=0.367 //l=1.11 //layer=li \
 //thickness=0.1 //x=3.45 //y=0.175 //x2=4.56 //y2=0.175
r1322 (  142 144 ) resistor r=38.7139 //w=0.367 //l=1.11 //layer=li \
 //thickness=0.1 //x=2.34 //y=0.175 //x2=3.45 //y2=0.175
r1323 (  140 471 ) resistor r=2.87058 //w=0.35 //l=0.085 //layer=li \
 //thickness=0.1 //x=1.65 //y=0.175 //x2=1.565 //y2=0.175
r1324 (  140 142 ) resistor r=24.0654 //w=0.367 //l=0.69 //layer=li \
 //thickness=0.1 //x=1.65 //y=0.175 //x2=2.34 //y2=0.175
r1325 (  139 472 ) resistor r=5.29055 //w=0.35 //l=0.17 //layer=li \
 //thickness=0.1 //x=5.13 //y=0.175 //x2=5.3 //y2=0.175
r1326 (  139 146 ) resistor r=19.8801 //w=0.367 //l=0.57 //layer=li \
 //thickness=0.1 //x=5.13 //y=0.175 //x2=4.56 //y2=0.175
r1327 (  135 471 ) resistor r=4.23183 //w=0.7 //l=0.175 //layer=li \
 //thickness=0.1 //x=1.565 //y=0.35 //x2=1.565 //y2=0.175
r1328 (  135 533 ) resistor r=54.4171 //w=0.187 //l=0.795 //layer=li \
 //thickness=0.1 //x=1.565 //y=0.35 //x2=1.565 //y2=1.145
r1329 (  131 471 ) resistor r=2.87058 //w=0.35 //l=0.085 //layer=li \
 //thickness=0.1 //x=1.48 //y=0.175 //x2=1.565 //y2=0.175
r1330 (  131 134 ) resistor r=8.71935 //w=0.367 //l=0.25 //layer=li \
 //thickness=0.1 //x=1.48 //y=0.175 //x2=1.23 //y2=0.175
r1331 (  127 525 ) resistor r=4.65 //w=0.17 //l=0.34 //layer=mcon //count=2 \
 //x=76.34 //y=0.18 //x2=76.34 //y2=0.18
r1332 (  125 522 ) resistor r=3.1 //w=0.17 //l=0.51 //layer=mcon //count=3 \
 //x=75.6 //y=0.18 //x2=75.6 //y2=0.18
r1333 (  125 127 ) resistor r=0.297428 //w=0.311 //l=0.74 //layer=m1 \
 //thickness=0.36 //x=75.6 //y=0.175 //x2=76.34 //y2=0.175
r1334 (  123 444 ) resistor r=3.1 //w=0.17 //l=0.51 //layer=mcon //count=3 \
 //x=74.12 //y=0.18 //x2=74.12 //y2=0.18
r1335 (  123 125 ) resistor r=0.594855 //w=0.311 //l=1.48 //layer=m1 \
 //thickness=0.36 //x=74.12 //y=0.175 //x2=75.6 //y2=0.175
r1336 (  121 442 ) resistor r=3.1 //w=0.17 //l=0.51 //layer=mcon //count=3 \
 //x=73.01 //y=0.18 //x2=73.01 //y2=0.18
r1337 (  121 123 ) resistor r=0.446141 //w=0.311 //l=1.11 //layer=m1 \
 //thickness=0.36 //x=73.01 //y=0.175 //x2=74.12 //y2=0.175
r1338 (  119 434 ) resistor r=3.1 //w=0.17 //l=0.51 //layer=mcon //count=3 \
 //x=71.9 //y=0.18 //x2=71.9 //y2=0.18
r1339 (  119 121 ) resistor r=0.446141 //w=0.311 //l=1.11 //layer=m1 \
 //thickness=0.36 //x=71.9 //y=0.175 //x2=73.01 //y2=0.175
r1340 (  117 428 ) resistor r=3.1 //w=0.17 //l=0.51 //layer=mcon //count=3 \
 //x=70.42 //y=0.18 //x2=70.42 //y2=0.18
r1341 (  117 119 ) resistor r=0.594855 //w=0.311 //l=1.48 //layer=m1 \
 //thickness=0.36 //x=70.42 //y=0.175 //x2=71.9 //y2=0.175
r1342 (  115 516 ) resistor r=3.1 //w=0.17 //l=0.51 //layer=mcon //count=3 \
 //x=69.31 //y=0.18 //x2=69.31 //y2=0.18
r1343 (  115 117 ) resistor r=0.446141 //w=0.311 //l=1.11 //layer=m1 \
 //thickness=0.36 //x=69.31 //y=0.175 //x2=70.42 //y2=0.175
r1344 (  113 416 ) resistor r=3.1 //w=0.17 //l=0.51 //layer=mcon //count=3 \
 //x=67.83 //y=0.18 //x2=67.83 //y2=0.18
r1345 (  113 115 ) resistor r=0.594855 //w=0.311 //l=1.48 //layer=m1 \
 //thickness=0.36 //x=67.83 //y=0.175 //x2=69.31 //y2=0.175
r1346 (  111 414 ) resistor r=3.1 //w=0.17 //l=0.51 //layer=mcon //count=3 \
 //x=66.72 //y=0.18 //x2=66.72 //y2=0.18
r1347 (  111 113 ) resistor r=0.446141 //w=0.311 //l=1.11 //layer=m1 \
 //thickness=0.36 //x=66.72 //y=0.175 //x2=67.83 //y2=0.175
r1348 (  109 406 ) resistor r=3.1 //w=0.17 //l=0.51 //layer=mcon //count=3 \
 //x=65.61 //y=0.18 //x2=65.61 //y2=0.18
r1349 (  109 111 ) resistor r=0.446141 //w=0.311 //l=1.11 //layer=m1 \
 //thickness=0.36 //x=65.61 //y=0.175 //x2=66.72 //y2=0.175
r1350 (  107 400 ) resistor r=3.1 //w=0.17 //l=0.51 //layer=mcon //count=3 \
 //x=64.13 //y=0.18 //x2=64.13 //y2=0.18
r1351 (  107 109 ) resistor r=0.594855 //w=0.311 //l=1.48 //layer=m1 \
 //thickness=0.36 //x=64.13 //y=0.175 //x2=65.61 //y2=0.175
r1352 (  105 398 ) resistor r=3.1 //w=0.17 //l=0.51 //layer=mcon //count=3 \
 //x=63.02 //y=0.18 //x2=63.02 //y2=0.18
r1353 (  105 107 ) resistor r=0.446141 //w=0.311 //l=1.11 //layer=m1 \
 //thickness=0.36 //x=63.02 //y=0.175 //x2=64.13 //y2=0.175
r1354 (  103 390 ) resistor r=3.1 //w=0.17 //l=0.51 //layer=mcon //count=3 \
 //x=61.91 //y=0.18 //x2=61.91 //y2=0.18
r1355 (  103 105 ) resistor r=0.446141 //w=0.311 //l=1.11 //layer=m1 \
 //thickness=0.36 //x=61.91 //y=0.175 //x2=63.02 //y2=0.175
r1356 (  101 384 ) resistor r=3.1 //w=0.17 //l=0.51 //layer=mcon //count=3 \
 //x=60.43 //y=0.18 //x2=60.43 //y2=0.18
r1357 (  101 103 ) resistor r=0.594855 //w=0.311 //l=1.48 //layer=m1 \
 //thickness=0.36 //x=60.43 //y=0.175 //x2=61.91 //y2=0.175
r1358 (  99 509 ) resistor r=3.1 //w=0.17 //l=0.51 //layer=mcon //count=3 \
 //x=59.32 //y=0.18 //x2=59.32 //y2=0.18
r1359 (  99 101 ) resistor r=0.446141 //w=0.311 //l=1.11 //layer=m1 \
 //thickness=0.36 //x=59.32 //y=0.175 //x2=60.43 //y2=0.175
r1360 (  97 372 ) resistor r=3.1 //w=0.17 //l=0.51 //layer=mcon //count=3 \
 //x=57.84 //y=0.18 //x2=57.84 //y2=0.18
r1361 (  97 99 ) resistor r=0.594855 //w=0.311 //l=1.48 //layer=m1 \
 //thickness=0.36 //x=57.84 //y=0.175 //x2=59.32 //y2=0.175
r1362 (  95 370 ) resistor r=3.1 //w=0.17 //l=0.51 //layer=mcon //count=3 \
 //x=56.73 //y=0.18 //x2=56.73 //y2=0.18
r1363 (  95 97 ) resistor r=0.446141 //w=0.311 //l=1.11 //layer=m1 \
 //thickness=0.36 //x=56.73 //y=0.175 //x2=57.84 //y2=0.175
r1364 (  93 362 ) resistor r=3.1 //w=0.17 //l=0.51 //layer=mcon //count=3 \
 //x=55.62 //y=0.18 //x2=55.62 //y2=0.18
r1365 (  93 95 ) resistor r=0.446141 //w=0.311 //l=1.11 //layer=m1 \
 //thickness=0.36 //x=55.62 //y=0.175 //x2=56.73 //y2=0.175
r1366 (  91 356 ) resistor r=3.1 //w=0.17 //l=0.51 //layer=mcon //count=3 \
 //x=54.14 //y=0.18 //x2=54.14 //y2=0.18
r1367 (  91 93 ) resistor r=0.594855 //w=0.311 //l=1.48 //layer=m1 \
 //thickness=0.36 //x=54.14 //y=0.175 //x2=55.62 //y2=0.175
r1368 (  89 354 ) resistor r=3.1 //w=0.17 //l=0.51 //layer=mcon //count=3 \
 //x=53.03 //y=0.18 //x2=53.03 //y2=0.18
r1369 (  89 91 ) resistor r=0.446141 //w=0.311 //l=1.11 //layer=m1 \
 //thickness=0.36 //x=53.03 //y=0.175 //x2=54.14 //y2=0.175
r1370 (  87 346 ) resistor r=3.1 //w=0.17 //l=0.51 //layer=mcon //count=3 \
 //x=51.92 //y=0.18 //x2=51.92 //y2=0.18
r1371 (  87 89 ) resistor r=0.446141 //w=0.311 //l=1.11 //layer=m1 \
 //thickness=0.36 //x=51.92 //y=0.175 //x2=53.03 //y2=0.175
r1372 (  85 340 ) resistor r=3.1 //w=0.17 //l=0.51 //layer=mcon //count=3 \
 //x=50.44 //y=0.18 //x2=50.44 //y2=0.18
r1373 (  85 87 ) resistor r=0.594855 //w=0.311 //l=1.48 //layer=m1 \
 //thickness=0.36 //x=50.44 //y=0.175 //x2=51.92 //y2=0.175
r1374 (  83 502 ) resistor r=3.1 //w=0.17 //l=0.51 //layer=mcon //count=3 \
 //x=49.33 //y=0.18 //x2=49.33 //y2=0.18
r1375 (  83 85 ) resistor r=0.446141 //w=0.311 //l=1.11 //layer=m1 \
 //thickness=0.36 //x=49.33 //y=0.175 //x2=50.44 //y2=0.175
r1376 (  81 328 ) resistor r=3.1 //w=0.17 //l=0.51 //layer=mcon //count=3 \
 //x=47.85 //y=0.18 //x2=47.85 //y2=0.18
r1377 (  81 83 ) resistor r=0.594855 //w=0.311 //l=1.48 //layer=m1 \
 //thickness=0.36 //x=47.85 //y=0.175 //x2=49.33 //y2=0.175
r1378 (  79 326 ) resistor r=3.1 //w=0.17 //l=0.51 //layer=mcon //count=3 \
 //x=46.74 //y=0.18 //x2=46.74 //y2=0.18
r1379 (  79 81 ) resistor r=0.446141 //w=0.311 //l=1.11 //layer=m1 \
 //thickness=0.36 //x=46.74 //y=0.175 //x2=47.85 //y2=0.175
r1380 (  77 324 ) resistor r=3.1 //w=0.17 //l=0.51 //layer=mcon //count=3 \
 //x=45.63 //y=0.18 //x2=45.63 //y2=0.18
r1381 (  77 79 ) resistor r=0.446141 //w=0.311 //l=1.11 //layer=m1 \
 //thickness=0.36 //x=45.63 //y=0.175 //x2=46.74 //y2=0.175
r1382 (  75 499 ) resistor r=3.1 //w=0.17 //l=0.51 //layer=mcon //count=3 \
 //x=44.52 //y=0.18 //x2=44.52 //y2=0.18
r1383 (  75 77 ) resistor r=0.446141 //w=0.311 //l=1.11 //layer=m1 \
 //thickness=0.36 //x=44.52 //y=0.175 //x2=45.63 //y2=0.175
r1384 (  73 312 ) resistor r=3.1 //w=0.17 //l=0.51 //layer=mcon //count=3 \
 //x=43.04 //y=0.18 //x2=43.04 //y2=0.18
r1385 (  73 75 ) resistor r=0.594855 //w=0.311 //l=1.48 //layer=m1 \
 //thickness=0.36 //x=43.04 //y=0.175 //x2=44.52 //y2=0.175
r1386 (  71 310 ) resistor r=3.1 //w=0.17 //l=0.51 //layer=mcon //count=3 \
 //x=41.93 //y=0.18 //x2=41.93 //y2=0.18
r1387 (  71 73 ) resistor r=0.446141 //w=0.311 //l=1.11 //layer=m1 \
 //thickness=0.36 //x=41.93 //y=0.175 //x2=43.04 //y2=0.175
r1388 (  69 302 ) resistor r=3.1 //w=0.17 //l=0.51 //layer=mcon //count=3 \
 //x=40.82 //y=0.18 //x2=40.82 //y2=0.18
r1389 (  69 71 ) resistor r=0.446141 //w=0.311 //l=1.11 //layer=m1 \
 //thickness=0.36 //x=40.82 //y=0.175 //x2=41.93 //y2=0.175
r1390 (  67 296 ) resistor r=3.1 //w=0.17 //l=0.51 //layer=mcon //count=3 \
 //x=39.34 //y=0.18 //x2=39.34 //y2=0.18
r1391 (  67 69 ) resistor r=0.594855 //w=0.311 //l=1.48 //layer=m1 \
 //thickness=0.36 //x=39.34 //y=0.175 //x2=40.82 //y2=0.175
r1392 (  64 294 ) resistor r=3.1 //w=0.17 //l=0.51 //layer=mcon //count=3 \
 //x=38.23 //y=0.18 //x2=38.23 //y2=0.18
r1393 (  62 286 ) resistor r=3.1 //w=0.17 //l=0.51 //layer=mcon //count=3 \
 //x=37.12 //y=0.18 //x2=37.12 //y2=0.18
r1394 (  62 64 ) resistor r=0.446141 //w=0.311 //l=1.11 //layer=m1 \
 //thickness=0.36 //x=37.12 //y=0.175 //x2=38.23 //y2=0.175
r1395 (  60 280 ) resistor r=3.1 //w=0.17 //l=0.51 //layer=mcon //count=3 \
 //x=35.64 //y=0.18 //x2=35.64 //y2=0.18
r1396 (  60 62 ) resistor r=0.594855 //w=0.311 //l=1.48 //layer=m1 \
 //thickness=0.36 //x=35.64 //y=0.175 //x2=37.12 //y2=0.175
r1397 (  58 492 ) resistor r=3.1 //w=0.17 //l=0.51 //layer=mcon //count=3 \
 //x=34.53 //y=0.18 //x2=34.53 //y2=0.18
r1398 (  58 60 ) resistor r=0.446141 //w=0.311 //l=1.11 //layer=m1 \
 //thickness=0.36 //x=34.53 //y=0.175 //x2=35.64 //y2=0.175
r1399 (  56 268 ) resistor r=3.1 //w=0.17 //l=0.51 //layer=mcon //count=3 \
 //x=33.05 //y=0.18 //x2=33.05 //y2=0.18
r1400 (  56 58 ) resistor r=0.594855 //w=0.311 //l=1.48 //layer=m1 \
 //thickness=0.36 //x=33.05 //y=0.175 //x2=34.53 //y2=0.175
r1401 (  54 266 ) resistor r=3.1 //w=0.17 //l=0.51 //layer=mcon //count=3 \
 //x=31.94 //y=0.18 //x2=31.94 //y2=0.18
r1402 (  54 56 ) resistor r=0.446141 //w=0.311 //l=1.11 //layer=m1 \
 //thickness=0.36 //x=31.94 //y=0.175 //x2=33.05 //y2=0.175
r1403 (  52 258 ) resistor r=3.1 //w=0.17 //l=0.51 //layer=mcon //count=3 \
 //x=30.83 //y=0.18 //x2=30.83 //y2=0.18
r1404 (  52 54 ) resistor r=0.446141 //w=0.311 //l=1.11 //layer=m1 \
 //thickness=0.36 //x=30.83 //y=0.175 //x2=31.94 //y2=0.175
r1405 (  50 252 ) resistor r=3.1 //w=0.17 //l=0.51 //layer=mcon //count=3 \
 //x=29.35 //y=0.18 //x2=29.35 //y2=0.18
r1406 (  50 52 ) resistor r=0.594855 //w=0.311 //l=1.48 //layer=m1 \
 //thickness=0.36 //x=29.35 //y=0.175 //x2=30.83 //y2=0.175
r1407 (  48 250 ) resistor r=3.1 //w=0.17 //l=0.51 //layer=mcon //count=3 \
 //x=28.24 //y=0.18 //x2=28.24 //y2=0.18
r1408 (  48 50 ) resistor r=0.446141 //w=0.311 //l=1.11 //layer=m1 \
 //thickness=0.36 //x=28.24 //y=0.175 //x2=29.35 //y2=0.175
r1409 (  46 242 ) resistor r=3.1 //w=0.17 //l=0.51 //layer=mcon //count=3 \
 //x=27.13 //y=0.18 //x2=27.13 //y2=0.18
r1410 (  46 48 ) resistor r=0.446141 //w=0.311 //l=1.11 //layer=m1 \
 //thickness=0.36 //x=27.13 //y=0.175 //x2=28.24 //y2=0.175
r1411 (  44 236 ) resistor r=3.1 //w=0.17 //l=0.51 //layer=mcon //count=3 \
 //x=25.65 //y=0.18 //x2=25.65 //y2=0.18
r1412 (  44 46 ) resistor r=0.594855 //w=0.311 //l=1.48 //layer=m1 \
 //thickness=0.36 //x=25.65 //y=0.175 //x2=27.13 //y2=0.175
r1413 (  42 234 ) resistor r=3.1 //w=0.17 //l=0.51 //layer=mcon //count=3 \
 //x=24.54 //y=0.18 //x2=24.54 //y2=0.18
r1414 (  42 44 ) resistor r=0.446141 //w=0.311 //l=1.11 //layer=m1 \
 //thickness=0.36 //x=24.54 //y=0.175 //x2=25.65 //y2=0.175
r1415 (  40 232 ) resistor r=3.1 //w=0.17 //l=0.51 //layer=mcon //count=3 \
 //x=23.43 //y=0.18 //x2=23.43 //y2=0.18
r1416 (  40 42 ) resistor r=0.446141 //w=0.311 //l=1.11 //layer=m1 \
 //thickness=0.36 //x=23.43 //y=0.175 //x2=24.54 //y2=0.175
r1417 (  38 224 ) resistor r=3.1 //w=0.17 //l=0.51 //layer=mcon //count=3 \
 //x=22.32 //y=0.18 //x2=22.32 //y2=0.18
r1418 (  38 40 ) resistor r=0.446141 //w=0.311 //l=1.11 //layer=m1 \
 //thickness=0.36 //x=22.32 //y=0.175 //x2=23.43 //y2=0.175
r1419 (  36 218 ) resistor r=3.1 //w=0.17 //l=0.51 //layer=mcon //count=3 \
 //x=20.84 //y=0.18 //x2=20.84 //y2=0.18
r1420 (  36 38 ) resistor r=0.594855 //w=0.311 //l=1.48 //layer=m1 \
 //thickness=0.36 //x=20.84 //y=0.175 //x2=22.32 //y2=0.175
r1421 (  34 483 ) resistor r=3.1 //w=0.17 //l=0.51 //layer=mcon //count=3 \
 //x=19.73 //y=0.18 //x2=19.73 //y2=0.18
r1422 (  34 36 ) resistor r=0.446141 //w=0.311 //l=1.11 //layer=m1 \
 //thickness=0.36 //x=19.73 //y=0.175 //x2=20.84 //y2=0.175
r1423 (  32 206 ) resistor r=3.1 //w=0.17 //l=0.51 //layer=mcon //count=3 \
 //x=18.25 //y=0.18 //x2=18.25 //y2=0.18
r1424 (  32 34 ) resistor r=0.594855 //w=0.311 //l=1.48 //layer=m1 \
 //thickness=0.36 //x=18.25 //y=0.175 //x2=19.73 //y2=0.175
r1425 (  30 204 ) resistor r=3.1 //w=0.17 //l=0.51 //layer=mcon //count=3 \
 //x=17.14 //y=0.18 //x2=17.14 //y2=0.18
r1426 (  30 32 ) resistor r=0.446141 //w=0.311 //l=1.11 //layer=m1 \
 //thickness=0.36 //x=17.14 //y=0.175 //x2=18.25 //y2=0.175
r1427 (  28 196 ) resistor r=3.1 //w=0.17 //l=0.51 //layer=mcon //count=3 \
 //x=16.03 //y=0.18 //x2=16.03 //y2=0.18
r1428 (  28 30 ) resistor r=0.446141 //w=0.311 //l=1.11 //layer=m1 \
 //thickness=0.36 //x=16.03 //y=0.175 //x2=17.14 //y2=0.175
r1429 (  26 190 ) resistor r=3.1 //w=0.17 //l=0.51 //layer=mcon //count=3 \
 //x=14.55 //y=0.18 //x2=14.55 //y2=0.18
r1430 (  26 28 ) resistor r=0.594855 //w=0.311 //l=1.48 //layer=m1 \
 //thickness=0.36 //x=14.55 //y=0.175 //x2=16.03 //y2=0.175
r1431 (  24 188 ) resistor r=3.1 //w=0.17 //l=0.51 //layer=mcon //count=3 \
 //x=13.44 //y=0.18 //x2=13.44 //y2=0.18
r1432 (  24 26 ) resistor r=0.446141 //w=0.311 //l=1.11 //layer=m1 \
 //thickness=0.36 //x=13.44 //y=0.175 //x2=14.55 //y2=0.175
r1433 (  22 180 ) resistor r=3.1 //w=0.17 //l=0.51 //layer=mcon //count=3 \
 //x=12.33 //y=0.18 //x2=12.33 //y2=0.18
r1434 (  22 24 ) resistor r=0.446141 //w=0.311 //l=1.11 //layer=m1 \
 //thickness=0.36 //x=12.33 //y=0.175 //x2=13.44 //y2=0.175
r1435 (  20 174 ) resistor r=3.1 //w=0.17 //l=0.51 //layer=mcon //count=3 \
 //x=10.85 //y=0.18 //x2=10.85 //y2=0.18
r1436 (  20 22 ) resistor r=0.594855 //w=0.311 //l=1.48 //layer=m1 \
 //thickness=0.36 //x=10.85 //y=0.175 //x2=12.33 //y2=0.175
r1437 (  18 476 ) resistor r=3.1 //w=0.17 //l=0.51 //layer=mcon //count=3 \
 //x=9.74 //y=0.18 //x2=9.74 //y2=0.18
r1438 (  18 20 ) resistor r=0.446141 //w=0.311 //l=1.11 //layer=m1 \
 //thickness=0.36 //x=9.74 //y=0.175 //x2=10.85 //y2=0.175
r1439 (  16 162 ) resistor r=3.1 //w=0.17 //l=0.51 //layer=mcon //count=3 \
 //x=8.26 //y=0.18 //x2=8.26 //y2=0.18
r1440 (  16 18 ) resistor r=0.594855 //w=0.311 //l=1.48 //layer=m1 \
 //thickness=0.36 //x=8.26 //y=0.175 //x2=9.74 //y2=0.175
r1441 (  14 160 ) resistor r=3.1 //w=0.17 //l=0.51 //layer=mcon //count=3 \
 //x=7.15 //y=0.18 //x2=7.15 //y2=0.18
r1442 (  14 16 ) resistor r=0.446141 //w=0.311 //l=1.11 //layer=m1 \
 //thickness=0.36 //x=7.15 //y=0.175 //x2=8.26 //y2=0.175
r1443 (  12 152 ) resistor r=3.1 //w=0.17 //l=0.51 //layer=mcon //count=3 \
 //x=6.04 //y=0.18 //x2=6.04 //y2=0.18
r1444 (  12 14 ) resistor r=0.446141 //w=0.311 //l=1.11 //layer=m1 \
 //thickness=0.36 //x=6.04 //y=0.175 //x2=7.15 //y2=0.175
r1445 (  10 146 ) resistor r=3.1 //w=0.17 //l=0.51 //layer=mcon //count=3 \
 //x=4.56 //y=0.18 //x2=4.56 //y2=0.18
r1446 (  10 12 ) resistor r=0.594855 //w=0.311 //l=1.48 //layer=m1 \
 //thickness=0.36 //x=4.56 //y=0.175 //x2=6.04 //y2=0.175
r1447 (  8 144 ) resistor r=3.1 //w=0.17 //l=0.51 //layer=mcon //count=3 \
 //x=3.45 //y=0.18 //x2=3.45 //y2=0.18
r1448 (  8 10 ) resistor r=0.446141 //w=0.311 //l=1.11 //layer=m1 \
 //thickness=0.36 //x=3.45 //y=0.175 //x2=4.56 //y2=0.175
r1449 (  6 142 ) resistor r=3.1 //w=0.17 //l=0.51 //layer=mcon //count=3 \
 //x=2.34 //y=0.18 //x2=2.34 //y2=0.18
r1450 (  6 8 ) resistor r=0.446141 //w=0.311 //l=1.11 //layer=m1 \
 //thickness=0.36 //x=2.34 //y=0.175 //x2=3.45 //y2=0.175
r1451 (  3 134 ) resistor r=3.1 //w=0.17 //l=0.51 //layer=mcon //count=3 \
 //x=1.23 //y=0.18 //x2=1.23 //y2=0.18
r1452 (  3 6 ) resistor r=0.446141 //w=0.311 //l=1.11 //layer=m1 \
 //thickness=0.36 //x=1.23 //y=0.175 //x2=2.34 //y2=0.175
r1453 (  1 67 ) resistor r=0.223071 //w=0.311 //l=0.555 //layer=m1 \
 //thickness=0.36 //x=38.785 //y=0.175 //x2=39.34 //y2=0.175
r1454 (  1 64 ) resistor r=0.223071 //w=0.311 //l=0.555 //layer=m1 \
 //thickness=0.36 //x=38.785 //y=0.175 //x2=38.23 //y2=0.175
ends PM_TMRDFFQX1\%GND

subckt PM_TMRDFFQX1\%VDD ( 1 127 134 141 151 159 169 175 183 191 201 207 215 \
 225 235 239 249 259 267 271 279 287 297 303 311 321 331 335 345 355 365 373 \
 377 387 397 405 409 417 425 435 441 449 459 469 473 483 493 501 505 513 521 \
 531 537 545 553 563 573 579 587 597 607 611 621 631 639 643 651 659 669 675 \
 683 693 703 707 717 727 739 747 755 765 771 779 789 797 813 818 822 827 832 \
 836 842 847 852 856 861 866 872 876 881 886 890 895 900 901 902 906 907 908 \
 909 910 911 912 913 914 915 916 917 918 919 920 921 922 923 924 925 926 927 \
 928 929 930 931 932 933 934 935 936 937 938 939 940 941 942 943 944 945 946 \
 947 948 949 950 951 952 953 954 955 956 957 958 959 960 961 962 963 964 965 \
 966 967 968 )
c1035 ( 968 0 ) capacitor c=0.0451938f //x=76.27 //y=5.2
c1036 ( 967 0 ) capacitor c=0.0420334f //x=75.4 //y=5.2
c1037 ( 966 0 ) capacitor c=0.0476809f //x=67.275 //y=5.205
c1038 ( 965 0 ) capacitor c=0.0241715f //x=66.395 //y=5.205
c1039 ( 964 0 ) capacitor c=0.0467094f //x=65.525 //y=5.205
c1040 ( 963 0 ) capacitor c=0.0382077f //x=63.945 //y=5.2
c1041 ( 962 0 ) capacitor c=0.0240874f //x=63.065 //y=5.2
c1042 ( 961 0 ) capacitor c=0.0490306f //x=62.195 //y=5.2
c1043 ( 960 0 ) capacitor c=0.0381675f //x=60.615 //y=5.2
c1044 ( 959 0 ) capacitor c=0.0240879f //x=59.735 //y=5.2
c1045 ( 958 0 ) capacitor c=0.0493661f //x=58.865 //y=5.2
c1046 ( 957 0 ) capacitor c=0.0381451f //x=57.285 //y=5.2
c1047 ( 956 0 ) capacitor c=0.0240074f //x=56.405 //y=5.2
c1048 ( 955 0 ) capacitor c=0.0490306f //x=55.535 //y=5.2
c1049 ( 954 0 ) capacitor c=0.038068f //x=53.955 //y=5.2
c1050 ( 953 0 ) capacitor c=0.0240081f //x=53.075 //y=5.2
c1051 ( 952 0 ) capacitor c=0.0490306f //x=52.205 //y=5.2
c1052 ( 951 0 ) capacitor c=0.038068f //x=50.625 //y=5.2
c1053 ( 950 0 ) capacitor c=0.0240081f //x=49.745 //y=5.2
c1054 ( 949 0 ) capacitor c=0.0492093f //x=48.875 //y=5.2
c1055 ( 948 0 ) capacitor c=0.045218f //x=46.995 //y=5.2
c1056 ( 947 0 ) capacitor c=0.0241521f //x=46.115 //y=5.2
c1057 ( 946 0 ) capacitor c=0.0241521f //x=45.235 //y=5.2
c1058 ( 945 0 ) capacitor c=0.0531894f //x=44.365 //y=5.2
c1059 ( 944 0 ) capacitor c=0.038068f //x=42.485 //y=5.2
c1060 ( 943 0 ) capacitor c=0.0240081f //x=41.605 //y=5.2
c1061 ( 942 0 ) capacitor c=0.0490306f //x=40.735 //y=5.2
c1062 ( 941 0 ) capacitor c=0.038068f //x=39.155 //y=5.2
c1063 ( 940 0 ) capacitor c=0.0240081f //x=38.275 //y=5.2
c1064 ( 939 0 ) capacitor c=0.0490306f //x=37.405 //y=5.2
c1065 ( 938 0 ) capacitor c=0.038068f //x=35.825 //y=5.2
c1066 ( 937 0 ) capacitor c=0.0240074f //x=34.945 //y=5.2
c1067 ( 936 0 ) capacitor c=0.0490306f //x=34.075 //y=5.2
c1068 ( 935 0 ) capacitor c=0.038068f //x=32.495 //y=5.2
c1069 ( 934 0 ) capacitor c=0.0240081f //x=31.615 //y=5.2
c1070 ( 933 0 ) capacitor c=0.0490306f //x=30.745 //y=5.2
c1071 ( 932 0 ) capacitor c=0.038068f //x=29.165 //y=5.2
c1072 ( 931 0 ) capacitor c=0.0240081f //x=28.285 //y=5.2
c1073 ( 930 0 ) capacitor c=0.0492093f //x=27.415 //y=5.2
c1074 ( 929 0 ) capacitor c=0.045218f //x=25.535 //y=5.2
c1075 ( 928 0 ) capacitor c=0.0241521f //x=24.655 //y=5.2
c1076 ( 927 0 ) capacitor c=0.0241521f //x=23.775 //y=5.2
c1077 ( 926 0 ) capacitor c=0.0531894f //x=22.905 //y=5.2
c1078 ( 925 0 ) capacitor c=0.038068f //x=21.025 //y=5.2
c1079 ( 924 0 ) capacitor c=0.0240081f //x=20.145 //y=5.2
c1080 ( 923 0 ) capacitor c=0.0490306f //x=19.275 //y=5.2
c1081 ( 922 0 ) capacitor c=0.038068f //x=17.695 //y=5.2
c1082 ( 921 0 ) capacitor c=0.0240093f //x=16.815 //y=5.2
c1083 ( 920 0 ) capacitor c=0.0490352f //x=15.945 //y=5.2
c1084 ( 919 0 ) capacitor c=0.0380693f //x=14.365 //y=5.2
c1085 ( 918 0 ) capacitor c=0.0240074f //x=13.485 //y=5.2
c1086 ( 917 0 ) capacitor c=0.0490306f //x=12.615 //y=5.2
c1087 ( 916 0 ) capacitor c=0.038068f //x=11.035 //y=5.2
c1088 ( 915 0 ) capacitor c=0.0240081f //x=10.155 //y=5.2
c1089 ( 914 0 ) capacitor c=0.0490306f //x=9.285 //y=5.2
c1090 ( 913 0 ) capacitor c=0.038068f //x=7.705 //y=5.2
c1091 ( 912 0 ) capacitor c=0.0240081f //x=6.825 //y=5.2
c1092 ( 911 0 ) capacitor c=0.0492093f //x=5.955 //y=5.2
c1093 ( 910 0 ) capacitor c=0.045218f //x=4.075 //y=5.2
c1094 ( 909 0 ) capacitor c=0.0241521f //x=3.195 //y=5.2
c1095 ( 908 0 ) capacitor c=0.0242401f //x=2.315 //y=5.2
c1096 ( 907 0 ) capacitor c=0.0531407f //x=1.445 //y=5.2
c1097 ( 906 0 ) capacitor c=0.253514f //x=76.34 //y=7.58
c1098 ( 904 0 ) capacitor c=0.00597439f //x=75.6 //y=7.58
c1099 ( 902 0 ) capacitor c=0.107782f //x=74.86 //y=7.585
c1100 ( 901 0 ) capacitor c=0.113453f //x=71.53 //y=7.585
c1101 ( 900 0 ) capacitor c=0.121322f //x=68.2 //y=7.585
c1102 ( 899 0 ) capacitor c=0.00597439f //x=67.42 //y=7.585
c1103 ( 898 0 ) capacitor c=0.00597439f //x=66.54 //y=7.585
c1104 ( 897 0 ) capacitor c=0.00597439f //x=65.61 //y=7.58
c1105 ( 895 0 ) capacitor c=0.115382f //x=64.87 //y=7.585
c1106 ( 894 0 ) capacitor c=0.00597439f //x=64.13 //y=7.58
c1107 ( 892 0 ) capacitor c=0.00597439f //x=63.21 //y=7.585
c1108 ( 891 0 ) capacitor c=0.00597439f //x=62.33 //y=7.585
c1109 ( 890 0 ) capacitor c=0.114216f //x=61.54 //y=7.585
c1110 ( 889 0 ) capacitor c=0.00597439f //x=60.76 //y=7.585
c1111 ( 888 0 ) capacitor c=0.00597439f //x=59.88 //y=7.585
c1112 ( 887 0 ) capacitor c=0.00597439f //x=59 //y=7.585
c1113 ( 886 0 ) capacitor c=0.116056f //x=58.21 //y=7.585
c1114 ( 885 0 ) capacitor c=0.00597439f //x=57.43 //y=7.585
c1115 ( 884 0 ) capacitor c=0.00597439f //x=56.55 //y=7.585
c1116 ( 883 0 ) capacitor c=0.00597439f //x=55.62 //y=7.58
c1117 ( 881 0 ) capacitor c=0.114485f //x=54.88 //y=7.585
c1118 ( 880 0 ) capacitor c=0.00597439f //x=54.14 //y=7.58
c1119 ( 878 0 ) capacitor c=0.00597439f //x=53.22 //y=7.585
c1120 ( 877 0 ) capacitor c=0.00597439f //x=52.34 //y=7.585
c1121 ( 876 0 ) capacitor c=0.114614f //x=51.55 //y=7.585
c1122 ( 875 0 ) capacitor c=0.00597439f //x=50.77 //y=7.585
c1123 ( 874 0 ) capacitor c=0.00597439f //x=49.89 //y=7.585
c1124 ( 873 0 ) capacitor c=0.00597439f //x=49.01 //y=7.585
c1125 ( 872 0 ) capacitor c=0.134694f //x=48.22 //y=7.585
c1126 ( 871 0 ) capacitor c=0.00597439f //x=47.14 //y=7.585
c1127 ( 870 0 ) capacitor c=0.00597439f //x=46.26 //y=7.585
c1128 ( 869 0 ) capacitor c=0.00597439f //x=45.38 //y=7.585
c1129 ( 868 0 ) capacitor c=0.00597439f //x=44.52 //y=7.58
c1130 ( 866 0 ) capacitor c=0.139349f //x=43.41 //y=7.585
c1131 ( 865 0 ) capacitor c=0.00597439f //x=42.63 //y=7.585
c1132 ( 864 0 ) capacitor c=0.00597439f //x=41.75 //y=7.585
c1133 ( 863 0 ) capacitor c=0.00597439f //x=40.82 //y=7.58
c1134 ( 861 0 ) capacitor c=0.114614f //x=40.08 //y=7.585
c1135 ( 860 0 ) capacitor c=0.00597439f //x=39.34 //y=7.58
c1136 ( 858 0 ) capacitor c=0.00597439f //x=38.42 //y=7.585
c1137 ( 857 0 ) capacitor c=0.00597439f //x=37.54 //y=7.585
c1138 ( 856 0 ) capacitor c=0.114444f //x=36.75 //y=7.585
c1139 ( 855 0 ) capacitor c=0.00597439f //x=35.97 //y=7.585
c1140 ( 854 0 ) capacitor c=0.00597439f //x=35.09 //y=7.585
c1141 ( 853 0 ) capacitor c=0.00597439f //x=34.21 //y=7.585
c1142 ( 852 0 ) capacitor c=0.114485f //x=33.42 //y=7.585
c1143 ( 851 0 ) capacitor c=0.00597439f //x=32.64 //y=7.585
c1144 ( 850 0 ) capacitor c=0.00597439f //x=31.76 //y=7.585
c1145 ( 849 0 ) capacitor c=0.00597439f //x=30.83 //y=7.58
c1146 ( 847 0 ) capacitor c=0.114614f //x=30.09 //y=7.585
c1147 ( 846 0 ) capacitor c=0.00597439f //x=29.35 //y=7.58
c1148 ( 844 0 ) capacitor c=0.00597439f //x=28.43 //y=7.585
c1149 ( 843 0 ) capacitor c=0.00597439f //x=27.55 //y=7.585
c1150 ( 842 0 ) capacitor c=0.134694f //x=26.76 //y=7.585
c1151 ( 841 0 ) capacitor c=0.00597439f //x=25.65 //y=7.58
c1152 ( 839 0 ) capacitor c=0.00597439f //x=24.8 //y=7.585
c1153 ( 838 0 ) capacitor c=0.00597439f //x=23.92 //y=7.585
c1154 ( 837 0 ) capacitor c=0.00597439f //x=23.04 //y=7.585
c1155 ( 836 0 ) capacitor c=0.139349f //x=21.95 //y=7.585
c1156 ( 835 0 ) capacitor c=0.00597439f //x=21.17 //y=7.585
c1157 ( 834 0 ) capacitor c=0.00597439f //x=20.29 //y=7.585
c1158 ( 833 0 ) capacitor c=0.00597439f //x=19.41 //y=7.585
c1159 ( 832 0 ) capacitor c=0.114614f //x=18.62 //y=7.585
c1160 ( 831 0 ) capacitor c=0.00597439f //x=17.84 //y=7.585
c1161 ( 830 0 ) capacitor c=0.00597439f //x=16.96 //y=7.585
c1162 ( 829 0 ) capacitor c=0.00597439f //x=16.03 //y=7.58
c1163 ( 827 0 ) capacitor c=0.114582f //x=15.29 //y=7.585
c1164 ( 826 0 ) capacitor c=0.00597439f //x=14.55 //y=7.58
c1165 ( 824 0 ) capacitor c=0.00597439f //x=13.63 //y=7.585
c1166 ( 823 0 ) capacitor c=0.00597439f //x=12.75 //y=7.585
c1167 ( 822 0 ) capacitor c=0.114485f //x=11.96 //y=7.585
c1168 ( 821 0 ) capacitor c=0.00597439f //x=11.18 //y=7.585
c1169 ( 820 0 ) capacitor c=0.00597439f //x=10.3 //y=7.585
c1170 ( 819 0 ) capacitor c=0.00597439f //x=9.42 //y=7.585
c1171 ( 818 0 ) capacitor c=0.114614f //x=8.63 //y=7.585
c1172 ( 817 0 ) capacitor c=0.00597439f //x=7.85 //y=7.585
c1173 ( 816 0 ) capacitor c=0.00597439f //x=6.97 //y=7.585
c1174 ( 815 0 ) capacitor c=0.00597439f //x=6.04 //y=7.58
c1175 ( 813 0 ) capacitor c=0.134694f //x=5.3 //y=7.585
c1176 ( 812 0 ) capacitor c=0.00597439f //x=4.22 //y=7.585
c1177 ( 811 0 ) capacitor c=0.00597439f //x=3.34 //y=7.585
c1178 ( 810 0 ) capacitor c=0.00597439f //x=2.46 //y=7.585
c1179 ( 809 0 ) capacitor c=0.00597439f //x=1.58 //y=7.585
c1180 ( 797 0 ) capacitor c=0.0290557f //x=76.33 //y=7.585
c1181 ( 789 0 ) capacitor c=0.0187886f //x=75.45 //y=7.585
c1182 ( 779 0 ) capacitor c=0.122205f //x=74.69 //y=7.585
c1183 ( 771 0 ) capacitor c=0.122102f //x=71.36 //y=7.585
c1184 ( 765 0 ) capacitor c=0.0238235f //x=68.03 //y=7.585
c1185 ( 755 0 ) capacitor c=0.0288071f //x=67.335 //y=7.585
c1186 ( 747 0 ) capacitor c=0.0287754f //x=66.455 //y=7.585
c1187 ( 739 0 ) capacitor c=0.0277927f //x=65.575 //y=7.585
c1188 ( 735 0 ) capacitor c=0.0277785f //x=64.7 //y=7.585
c1189 ( 727 0 ) capacitor c=0.028702f //x=64.005 //y=7.585
c1190 ( 717 0 ) capacitor c=0.0291089f //x=63.125 //y=7.585
c1191 ( 707 0 ) capacitor c=0.024303f //x=62.245 //y=7.585
c1192 ( 703 0 ) capacitor c=0.0239099f //x=61.37 //y=7.585
c1193 ( 693 0 ) capacitor c=0.0291288f //x=60.675 //y=7.585
c1194 ( 683 0 ) capacitor c=0.0291291f //x=59.795 //y=7.585
c1195 ( 675 0 ) capacitor c=0.024303f //x=58.915 //y=7.585
c1196 ( 669 0 ) capacitor c=0.0238958f //x=58.04 //y=7.585
c1197 ( 659 0 ) capacitor c=0.0291247f //x=57.345 //y=7.585
c1198 ( 651 0 ) capacitor c=0.0291028f //x=56.465 //y=7.585
c1199 ( 643 0 ) capacitor c=0.024303f //x=55.585 //y=7.585
c1200 ( 639 0 ) capacitor c=0.0238235f //x=54.71 //y=7.585
c1201 ( 631 0 ) capacitor c=0.0291008f //x=54.015 //y=7.585
c1202 ( 621 0 ) capacitor c=0.0291028f //x=53.135 //y=7.585
c1203 ( 611 0 ) capacitor c=0.024303f //x=52.255 //y=7.585
c1204 ( 607 0 ) capacitor c=0.0238235f //x=51.38 //y=7.585
c1205 ( 597 0 ) capacitor c=0.0291008f //x=50.685 //y=7.585
c1206 ( 587 0 ) capacitor c=0.0291028f //x=49.805 //y=7.585
c1207 ( 579 0 ) capacitor c=0.024303f //x=48.925 //y=7.585
c1208 ( 573 0 ) capacitor c=0.0397734f //x=48.05 //y=7.585
c1209 ( 563 0 ) capacitor c=0.0291138f //x=47.055 //y=7.585
c1210 ( 553 0 ) capacitor c=0.0290163f //x=46.175 //y=7.585
c1211 ( 545 0 ) capacitor c=0.0287649f //x=45.295 //y=7.585
c1212 ( 537 0 ) capacitor c=0.0386886f //x=44.415 //y=7.585
c1213 ( 531 0 ) capacitor c=0.0238235f //x=43.24 //y=7.585
c1214 ( 521 0 ) capacitor c=0.0291008f //x=42.545 //y=7.585
c1215 ( 513 0 ) capacitor c=0.0291028f //x=41.665 //y=7.585
c1216 ( 505 0 ) capacitor c=0.024303f //x=40.785 //y=7.585
c1217 ( 501 0 ) capacitor c=0.0238235f //x=39.91 //y=7.585
c1218 ( 493 0 ) capacitor c=0.0291008f //x=39.215 //y=7.585
c1219 ( 483 0 ) capacitor c=0.0291028f //x=38.335 //y=7.585
c1220 ( 473 0 ) capacitor c=0.024303f //x=37.455 //y=7.585
c1221 ( 469 0 ) capacitor c=0.0238235f //x=36.58 //y=7.585
c1222 ( 459 0 ) capacitor c=0.0291007f //x=35.885 //y=7.585
c1223 ( 449 0 ) capacitor c=0.0291028f //x=35.005 //y=7.585
c1224 ( 441 0 ) capacitor c=0.024303f //x=34.125 //y=7.585
c1225 ( 435 0 ) capacitor c=0.0238235f //x=33.25 //y=7.585
c1226 ( 425 0 ) capacitor c=0.0291008f //x=32.555 //y=7.585
c1227 ( 417 0 ) capacitor c=0.0291028f //x=31.675 //y=7.585
c1228 ( 409 0 ) capacitor c=0.024303f //x=30.795 //y=7.585
c1229 ( 405 0 ) capacitor c=0.0238235f //x=29.92 //y=7.585
c1230 ( 397 0 ) capacitor c=0.0291008f //x=29.225 //y=7.585
c1231 ( 387 0 ) capacitor c=0.0291028f //x=28.345 //y=7.585
c1232 ( 377 0 ) capacitor c=0.024303f //x=27.465 //y=7.585
c1233 ( 373 0 ) capacitor c=0.0397734f //x=26.59 //y=7.585
c1234 ( 365 0 ) capacitor c=0.0291138f //x=25.595 //y=7.585
c1235 ( 355 0 ) capacitor c=0.0290163f //x=24.715 //y=7.585
c1236 ( 345 0 ) capacitor c=0.0287649f //x=23.835 //y=7.585
c1237 ( 335 0 ) capacitor c=0.0386886f //x=22.955 //y=7.585
c1238 ( 331 0 ) capacitor c=0.0238235f //x=21.78 //y=7.585
c1239 ( 321 0 ) capacitor c=0.0291008f //x=21.085 //y=7.585
c1240 ( 311 0 ) capacitor c=0.0291028f //x=20.205 //y=7.585
c1241 ( 303 0 ) capacitor c=0.024303f //x=19.325 //y=7.585
c1242 ( 297 0 ) capacitor c=0.0238235f //x=18.45 //y=7.585
c1243 ( 287 0 ) capacitor c=0.0291009f //x=17.755 //y=7.585
c1244 ( 279 0 ) capacitor c=0.0291032f //x=16.875 //y=7.585
c1245 ( 271 0 ) capacitor c=0.024303f //x=15.995 //y=7.585
c1246 ( 267 0 ) capacitor c=0.0238235f //x=15.12 //y=7.585
c1247 ( 259 0 ) capacitor c=0.029101f //x=14.425 //y=7.585
c1248 ( 249 0 ) capacitor c=0.0291028f //x=13.545 //y=7.585
c1249 ( 239 0 ) capacitor c=0.024303f //x=12.665 //y=7.585
c1250 ( 235 0 ) capacitor c=0.0238235f //x=11.79 //y=7.585
c1251 ( 225 0 ) capacitor c=0.0291008f //x=11.095 //y=7.585
c1252 ( 215 0 ) capacitor c=0.0291028f //x=10.215 //y=7.585
c1253 ( 207 0 ) capacitor c=0.024303f //x=9.335 //y=7.585
c1254 ( 201 0 ) capacitor c=0.0238235f //x=8.46 //y=7.585
c1255 ( 191 0 ) capacitor c=0.0291008f //x=7.765 //y=7.585
c1256 ( 183 0 ) capacitor c=0.0291028f //x=6.885 //y=7.585
c1257 ( 175 0 ) capacitor c=0.024303f //x=6.005 //y=7.585
c1258 ( 169 0 ) capacitor c=0.0397734f //x=5.13 //y=7.585
c1259 ( 159 0 ) capacitor c=0.0291138f //x=4.135 //y=7.585
c1260 ( 151 0 ) capacitor c=0.0290163f //x=3.255 //y=7.585
c1261 ( 141 0 ) capacitor c=0.0287792f //x=2.375 //y=7.585
c1262 ( 134 0 ) capacitor c=0.253096f //x=1.23 //y=7.58
c1263 ( 131 0 ) capacitor c=0.0455283f //x=1.495 //y=7.585
c1264 ( 127 0 ) capacitor c=2.55676f //x=76.34 //y=7.58
r1265 (  799 906 ) resistor r=4.23183 //w=0.7 //l=0.175 //layer=li \
 //thickness=0.1 //x=76.415 //y=7.41 //x2=76.415 //y2=7.585
r1266 (  799 968 ) resistor r=56.4706 //w=0.187 //l=0.825 //layer=li \
 //thickness=0.1 //x=76.415 //y=7.41 //x2=76.415 //y2=6.585
r1267 (  798 904 ) resistor r=2.87058 //w=0.35 //l=0.085 //layer=li \
 //thickness=0.1 //x=75.62 //y=7.585 //x2=75.535 //y2=7.585
r1268 (  797 906 ) resistor r=2.87058 //w=0.35 //l=0.085 //layer=li \
 //thickness=0.1 //x=76.33 //y=7.585 //x2=76.415 //y2=7.585
r1269 (  797 798 ) resistor r=24.7629 //w=0.367 //l=0.71 //layer=li \
 //thickness=0.1 //x=76.33 //y=7.585 //x2=75.62 //y2=7.585
r1270 (  791 904 ) resistor r=4.23183 //w=0.7 //l=0.175 //layer=li \
 //thickness=0.1 //x=75.535 //y=7.41 //x2=75.535 //y2=7.585
r1271 (  791 967 ) resistor r=56.4706 //w=0.187 //l=0.825 //layer=li \
 //thickness=0.1 //x=75.535 //y=7.41 //x2=75.535 //y2=6.585
r1272 (  790 902 ) resistor r=5.29055 //w=0.35 //l=0.17 //layer=li \
 //thickness=0.1 //x=75.03 //y=7.585 //x2=74.86 //y2=7.585
r1273 (  789 904 ) resistor r=2.87058 //w=0.35 //l=0.085 //layer=li \
 //thickness=0.1 //x=75.45 //y=7.585 //x2=75.535 //y2=7.585
r1274 (  789 790 ) resistor r=14.6485 //w=0.367 //l=0.42 //layer=li \
 //thickness=0.1 //x=75.45 //y=7.585 //x2=75.03 //y2=7.585
r1275 (  784 786 ) resistor r=38.7139 //w=0.367 //l=1.11 //layer=li \
 //thickness=0.1 //x=73.01 //y=7.585 //x2=74.12 //y2=7.585
r1276 (  782 784 ) resistor r=38.7139 //w=0.367 //l=1.11 //layer=li \
 //thickness=0.1 //x=71.9 //y=7.585 //x2=73.01 //y2=7.585
r1277 (  780 901 ) resistor r=5.29055 //w=0.35 //l=0.17 //layer=li \
 //thickness=0.1 //x=71.7 //y=7.585 //x2=71.53 //y2=7.585
r1278 (  780 782 ) resistor r=6.97548 //w=0.367 //l=0.2 //layer=li \
 //thickness=0.1 //x=71.7 //y=7.585 //x2=71.9 //y2=7.585
r1279 (  779 902 ) resistor r=5.29055 //w=0.35 //l=0.17 //layer=li \
 //thickness=0.1 //x=74.69 //y=7.585 //x2=74.86 //y2=7.585
r1280 (  779 786 ) resistor r=19.8801 //w=0.367 //l=0.57 //layer=li \
 //thickness=0.1 //x=74.69 //y=7.585 //x2=74.12 //y2=7.585
r1281 (  774 776 ) resistor r=38.7139 //w=0.367 //l=1.11 //layer=li \
 //thickness=0.1 //x=69.31 //y=7.585 //x2=70.42 //y2=7.585
r1282 (  772 900 ) resistor r=5.29055 //w=0.35 //l=0.17 //layer=li \
 //thickness=0.1 //x=68.37 //y=7.585 //x2=68.2 //y2=7.585
r1283 (  772 774 ) resistor r=32.7847 //w=0.367 //l=0.94 //layer=li \
 //thickness=0.1 //x=68.37 //y=7.585 //x2=69.31 //y2=7.585
r1284 (  771 901 ) resistor r=5.29055 //w=0.35 //l=0.17 //layer=li \
 //thickness=0.1 //x=71.36 //y=7.585 //x2=71.53 //y2=7.585
r1285 (  771 776 ) resistor r=32.7847 //w=0.367 //l=0.94 //layer=li \
 //thickness=0.1 //x=71.36 //y=7.585 //x2=70.42 //y2=7.585
r1286 (  766 899 ) resistor r=2.87058 //w=0.35 //l=0.085 //layer=li \
 //thickness=0.1 //x=67.505 //y=7.585 //x2=67.42 //y2=7.585
r1287 (  766 768 ) resistor r=11.3351 //w=0.367 //l=0.325 //layer=li \
 //thickness=0.1 //x=67.505 //y=7.585 //x2=67.83 //y2=7.585
r1288 (  765 900 ) resistor r=5.29055 //w=0.35 //l=0.17 //layer=li \
 //thickness=0.1 //x=68.03 //y=7.585 //x2=68.2 //y2=7.585
r1289 (  765 768 ) resistor r=6.97548 //w=0.367 //l=0.2 //layer=li \
 //thickness=0.1 //x=68.03 //y=7.585 //x2=67.83 //y2=7.585
r1290 (  759 899 ) resistor r=4.23183 //w=0.7 //l=0.175 //layer=li \
 //thickness=0.1 //x=67.42 //y=7.41 //x2=67.42 //y2=7.585
r1291 (  759 966 ) resistor r=56.8128 //w=0.187 //l=0.83 //layer=li \
 //thickness=0.1 //x=67.42 //y=7.41 //x2=67.42 //y2=6.58
r1292 (  756 898 ) resistor r=2.87058 //w=0.35 //l=0.085 //layer=li \
 //thickness=0.1 //x=66.625 //y=7.585 //x2=66.54 //y2=7.585
r1293 (  756 758 ) resistor r=3.31335 //w=0.367 //l=0.095 //layer=li \
 //thickness=0.1 //x=66.625 //y=7.585 //x2=66.72 //y2=7.585
r1294 (  755 899 ) resistor r=2.87058 //w=0.35 //l=0.085 //layer=li \
 //thickness=0.1 //x=67.335 //y=7.585 //x2=67.42 //y2=7.585
r1295 (  755 758 ) resistor r=21.4496 //w=0.367 //l=0.615 //layer=li \
 //thickness=0.1 //x=67.335 //y=7.585 //x2=66.72 //y2=7.585
r1296 (  749 898 ) resistor r=4.23183 //w=0.7 //l=0.175 //layer=li \
 //thickness=0.1 //x=66.54 //y=7.41 //x2=66.54 //y2=7.585
r1297 (  749 965 ) resistor r=33.5401 //w=0.187 //l=0.49 //layer=li \
 //thickness=0.1 //x=66.54 //y=7.41 //x2=66.54 //y2=6.92
r1298 (  748 897 ) resistor r=2.87058 //w=0.35 //l=0.085 //layer=li \
 //thickness=0.1 //x=65.745 //y=7.585 //x2=65.66 //y2=7.585
r1299 (  747 898 ) resistor r=2.87058 //w=0.35 //l=0.085 //layer=li \
 //thickness=0.1 //x=66.455 //y=7.585 //x2=66.54 //y2=7.585
r1300 (  747 748 ) resistor r=24.7629 //w=0.367 //l=0.71 //layer=li \
 //thickness=0.1 //x=66.455 //y=7.585 //x2=65.745 //y2=7.585
r1301 (  741 897 ) resistor r=4.23183 //w=0.7 //l=0.175 //layer=li \
 //thickness=0.1 //x=65.66 //y=7.41 //x2=65.66 //y2=7.585
r1302 (  741 964 ) resistor r=56.8128 //w=0.187 //l=0.83 //layer=li \
 //thickness=0.1 //x=65.66 //y=7.41 //x2=65.66 //y2=6.58
r1303 (  740 895 ) resistor r=5.29055 //w=0.35 //l=0.17 //layer=li \
 //thickness=0.1 //x=65.04 //y=7.585 //x2=64.87 //y2=7.585
r1304 (  739 897 ) resistor r=2.87058 //w=0.35 //l=0.085 //layer=li \
 //thickness=0.1 //x=65.575 //y=7.585 //x2=65.66 //y2=7.585
r1305 (  739 740 ) resistor r=18.6594 //w=0.367 //l=0.535 //layer=li \
 //thickness=0.1 //x=65.575 //y=7.585 //x2=65.04 //y2=7.585
r1306 (  736 894 ) resistor r=2.87058 //w=0.35 //l=0.085 //layer=li \
 //thickness=0.1 //x=64.175 //y=7.585 //x2=64.09 //y2=7.585
r1307 (  735 895 ) resistor r=5.29055 //w=0.35 //l=0.17 //layer=li \
 //thickness=0.1 //x=64.7 //y=7.585 //x2=64.87 //y2=7.585
r1308 (  735 736 ) resistor r=18.3106 //w=0.367 //l=0.525 //layer=li \
 //thickness=0.1 //x=64.7 //y=7.585 //x2=64.175 //y2=7.585
r1309 (  729 894 ) resistor r=4.23183 //w=0.7 //l=0.175 //layer=li \
 //thickness=0.1 //x=64.09 //y=7.41 //x2=64.09 //y2=7.585
r1310 (  729 963 ) resistor r=33.1979 //w=0.187 //l=0.485 //layer=li \
 //thickness=0.1 //x=64.09 //y=7.41 //x2=64.09 //y2=6.925
r1311 (  728 892 ) resistor r=2.87058 //w=0.35 //l=0.085 //layer=li \
 //thickness=0.1 //x=63.295 //y=7.585 //x2=63.21 //y2=7.585
r1312 (  727 894 ) resistor r=2.87058 //w=0.35 //l=0.085 //layer=li \
 //thickness=0.1 //x=64.005 //y=7.585 //x2=64.09 //y2=7.585
r1313 (  727 728 ) resistor r=24.7629 //w=0.367 //l=0.71 //layer=li \
 //thickness=0.1 //x=64.005 //y=7.585 //x2=63.295 //y2=7.585
r1314 (  721 892 ) resistor r=4.23183 //w=0.7 //l=0.175 //layer=li \
 //thickness=0.1 //x=63.21 //y=7.41 //x2=63.21 //y2=7.585
r1315 (  721 962 ) resistor r=33.1979 //w=0.187 //l=0.485 //layer=li \
 //thickness=0.1 //x=63.21 //y=7.41 //x2=63.21 //y2=6.925
r1316 (  718 891 ) resistor r=2.87058 //w=0.35 //l=0.085 //layer=li \
 //thickness=0.1 //x=62.415 //y=7.585 //x2=62.33 //y2=7.585
r1317 (  718 720 ) resistor r=21.1008 //w=0.367 //l=0.605 //layer=li \
 //thickness=0.1 //x=62.415 //y=7.585 //x2=63.02 //y2=7.585
r1318 (  717 892 ) resistor r=2.87058 //w=0.35 //l=0.085 //layer=li \
 //thickness=0.1 //x=63.125 //y=7.585 //x2=63.21 //y2=7.585
r1319 (  717 720 ) resistor r=3.66213 //w=0.367 //l=0.105 //layer=li \
 //thickness=0.1 //x=63.125 //y=7.585 //x2=63.02 //y2=7.585
r1320 (  711 891 ) resistor r=4.23183 //w=0.7 //l=0.175 //layer=li \
 //thickness=0.1 //x=62.33 //y=7.41 //x2=62.33 //y2=7.585
r1321 (  711 961 ) resistor r=56.4706 //w=0.187 //l=0.825 //layer=li \
 //thickness=0.1 //x=62.33 //y=7.41 //x2=62.33 //y2=6.585
r1322 (  708 890 ) resistor r=5.29055 //w=0.35 //l=0.17 //layer=li \
 //thickness=0.1 //x=61.71 //y=7.585 //x2=61.54 //y2=7.585
r1323 (  708 710 ) resistor r=6.97548 //w=0.367 //l=0.2 //layer=li \
 //thickness=0.1 //x=61.71 //y=7.585 //x2=61.91 //y2=7.585
r1324 (  707 891 ) resistor r=2.87058 //w=0.35 //l=0.085 //layer=li \
 //thickness=0.1 //x=62.245 //y=7.585 //x2=62.33 //y2=7.585
r1325 (  707 710 ) resistor r=11.6839 //w=0.367 //l=0.335 //layer=li \
 //thickness=0.1 //x=62.245 //y=7.585 //x2=61.91 //y2=7.585
r1326 (  704 889 ) resistor r=2.87058 //w=0.35 //l=0.085 //layer=li \
 //thickness=0.1 //x=60.845 //y=7.585 //x2=60.76 //y2=7.585
r1327 (  703 890 ) resistor r=5.29055 //w=0.35 //l=0.17 //layer=li \
 //thickness=0.1 //x=61.37 //y=7.585 //x2=61.54 //y2=7.585
r1328 (  703 704 ) resistor r=18.3106 //w=0.367 //l=0.525 //layer=li \
 //thickness=0.1 //x=61.37 //y=7.585 //x2=60.845 //y2=7.585
r1329 (  697 889 ) resistor r=4.23183 //w=0.7 //l=0.175 //layer=li \
 //thickness=0.1 //x=60.76 //y=7.41 //x2=60.76 //y2=7.585
r1330 (  697 960 ) resistor r=33.1979 //w=0.187 //l=0.485 //layer=li \
 //thickness=0.1 //x=60.76 //y=7.41 //x2=60.76 //y2=6.925
r1331 (  694 888 ) resistor r=2.87058 //w=0.35 //l=0.085 //layer=li \
 //thickness=0.1 //x=59.965 //y=7.585 //x2=59.88 //y2=7.585
r1332 (  694 696 ) resistor r=16.218 //w=0.367 //l=0.465 //layer=li \
 //thickness=0.1 //x=59.965 //y=7.585 //x2=60.43 //y2=7.585
r1333 (  693 889 ) resistor r=2.87058 //w=0.35 //l=0.085 //layer=li \
 //thickness=0.1 //x=60.675 //y=7.585 //x2=60.76 //y2=7.585
r1334 (  693 696 ) resistor r=8.54496 //w=0.367 //l=0.245 //layer=li \
 //thickness=0.1 //x=60.675 //y=7.585 //x2=60.43 //y2=7.585
r1335 (  687 888 ) resistor r=4.23183 //w=0.7 //l=0.175 //layer=li \
 //thickness=0.1 //x=59.88 //y=7.41 //x2=59.88 //y2=7.585
r1336 (  687 959 ) resistor r=33.1979 //w=0.187 //l=0.485 //layer=li \
 //thickness=0.1 //x=59.88 //y=7.41 //x2=59.88 //y2=6.925
r1337 (  684 887 ) resistor r=2.87058 //w=0.35 //l=0.085 //layer=li \
 //thickness=0.1 //x=59.085 //y=7.585 //x2=59 //y2=7.585
r1338 (  684 686 ) resistor r=8.19619 //w=0.367 //l=0.235 //layer=li \
 //thickness=0.1 //x=59.085 //y=7.585 //x2=59.32 //y2=7.585
r1339 (  683 888 ) resistor r=2.87058 //w=0.35 //l=0.085 //layer=li \
 //thickness=0.1 //x=59.795 //y=7.585 //x2=59.88 //y2=7.585
r1340 (  683 686 ) resistor r=16.5668 //w=0.367 //l=0.475 //layer=li \
 //thickness=0.1 //x=59.795 //y=7.585 //x2=59.32 //y2=7.585
r1341 (  677 887 ) resistor r=4.23183 //w=0.7 //l=0.175 //layer=li \
 //thickness=0.1 //x=59 //y=7.41 //x2=59 //y2=7.585
r1342 (  677 958 ) resistor r=56.4706 //w=0.187 //l=0.825 //layer=li \
 //thickness=0.1 //x=59 //y=7.41 //x2=59 //y2=6.585
r1343 (  676 886 ) resistor r=5.29055 //w=0.35 //l=0.17 //layer=li \
 //thickness=0.1 //x=58.38 //y=7.585 //x2=58.21 //y2=7.585
r1344 (  675 887 ) resistor r=2.87058 //w=0.35 //l=0.085 //layer=li \
 //thickness=0.1 //x=58.915 //y=7.585 //x2=59 //y2=7.585
r1345 (  675 676 ) resistor r=18.6594 //w=0.367 //l=0.535 //layer=li \
 //thickness=0.1 //x=58.915 //y=7.585 //x2=58.38 //y2=7.585
r1346 (  670 885 ) resistor r=2.87058 //w=0.35 //l=0.085 //layer=li \
 //thickness=0.1 //x=57.515 //y=7.585 //x2=57.43 //y2=7.585
r1347 (  670 672 ) resistor r=11.3351 //w=0.367 //l=0.325 //layer=li \
 //thickness=0.1 //x=57.515 //y=7.585 //x2=57.84 //y2=7.585
r1348 (  669 886 ) resistor r=5.29055 //w=0.35 //l=0.17 //layer=li \
 //thickness=0.1 //x=58.04 //y=7.585 //x2=58.21 //y2=7.585
r1349 (  669 672 ) resistor r=6.97548 //w=0.367 //l=0.2 //layer=li \
 //thickness=0.1 //x=58.04 //y=7.585 //x2=57.84 //y2=7.585
r1350 (  663 885 ) resistor r=4.23183 //w=0.7 //l=0.175 //layer=li \
 //thickness=0.1 //x=57.43 //y=7.41 //x2=57.43 //y2=7.585
r1351 (  663 957 ) resistor r=33.1979 //w=0.187 //l=0.485 //layer=li \
 //thickness=0.1 //x=57.43 //y=7.41 //x2=57.43 //y2=6.925
r1352 (  660 884 ) resistor r=2.87058 //w=0.35 //l=0.085 //layer=li \
 //thickness=0.1 //x=56.635 //y=7.585 //x2=56.55 //y2=7.585
r1353 (  660 662 ) resistor r=3.31335 //w=0.367 //l=0.095 //layer=li \
 //thickness=0.1 //x=56.635 //y=7.585 //x2=56.73 //y2=7.585
r1354 (  659 885 ) resistor r=2.87058 //w=0.35 //l=0.085 //layer=li \
 //thickness=0.1 //x=57.345 //y=7.585 //x2=57.43 //y2=7.585
r1355 (  659 662 ) resistor r=21.4496 //w=0.367 //l=0.615 //layer=li \
 //thickness=0.1 //x=57.345 //y=7.585 //x2=56.73 //y2=7.585
r1356 (  653 884 ) resistor r=4.23183 //w=0.7 //l=0.175 //layer=li \
 //thickness=0.1 //x=56.55 //y=7.41 //x2=56.55 //y2=7.585
r1357 (  653 956 ) resistor r=33.1979 //w=0.187 //l=0.485 //layer=li \
 //thickness=0.1 //x=56.55 //y=7.41 //x2=56.55 //y2=6.925
r1358 (  652 883 ) resistor r=2.87058 //w=0.35 //l=0.085 //layer=li \
 //thickness=0.1 //x=55.755 //y=7.585 //x2=55.67 //y2=7.585
r1359 (  651 884 ) resistor r=2.87058 //w=0.35 //l=0.085 //layer=li \
 //thickness=0.1 //x=56.465 //y=7.585 //x2=56.55 //y2=7.585
r1360 (  651 652 ) resistor r=24.7629 //w=0.367 //l=0.71 //layer=li \
 //thickness=0.1 //x=56.465 //y=7.585 //x2=55.755 //y2=7.585
r1361 (  645 883 ) resistor r=4.23183 //w=0.7 //l=0.175 //layer=li \
 //thickness=0.1 //x=55.67 //y=7.41 //x2=55.67 //y2=7.585
r1362 (  645 955 ) resistor r=56.4706 //w=0.187 //l=0.825 //layer=li \
 //thickness=0.1 //x=55.67 //y=7.41 //x2=55.67 //y2=6.585
r1363 (  644 881 ) resistor r=5.29055 //w=0.35 //l=0.17 //layer=li \
 //thickness=0.1 //x=55.05 //y=7.585 //x2=54.88 //y2=7.585
r1364 (  643 883 ) resistor r=2.87058 //w=0.35 //l=0.085 //layer=li \
 //thickness=0.1 //x=55.585 //y=7.585 //x2=55.67 //y2=7.585
r1365 (  643 644 ) resistor r=18.6594 //w=0.367 //l=0.535 //layer=li \
 //thickness=0.1 //x=55.585 //y=7.585 //x2=55.05 //y2=7.585
r1366 (  640 880 ) resistor r=2.87058 //w=0.35 //l=0.085 //layer=li \
 //thickness=0.1 //x=54.185 //y=7.585 //x2=54.1 //y2=7.585
r1367 (  639 881 ) resistor r=5.29055 //w=0.35 //l=0.17 //layer=li \
 //thickness=0.1 //x=54.71 //y=7.585 //x2=54.88 //y2=7.585
r1368 (  639 640 ) resistor r=18.3106 //w=0.367 //l=0.525 //layer=li \
 //thickness=0.1 //x=54.71 //y=7.585 //x2=54.185 //y2=7.585
r1369 (  633 880 ) resistor r=4.23183 //w=0.7 //l=0.175 //layer=li \
 //thickness=0.1 //x=54.1 //y=7.41 //x2=54.1 //y2=7.585
r1370 (  633 954 ) resistor r=33.1979 //w=0.187 //l=0.485 //layer=li \
 //thickness=0.1 //x=54.1 //y=7.41 //x2=54.1 //y2=6.925
r1371 (  632 878 ) resistor r=2.87058 //w=0.35 //l=0.085 //layer=li \
 //thickness=0.1 //x=53.305 //y=7.585 //x2=53.22 //y2=7.585
r1372 (  631 880 ) resistor r=2.87058 //w=0.35 //l=0.085 //layer=li \
 //thickness=0.1 //x=54.015 //y=7.585 //x2=54.1 //y2=7.585
r1373 (  631 632 ) resistor r=24.7629 //w=0.367 //l=0.71 //layer=li \
 //thickness=0.1 //x=54.015 //y=7.585 //x2=53.305 //y2=7.585
r1374 (  625 878 ) resistor r=4.23183 //w=0.7 //l=0.175 //layer=li \
 //thickness=0.1 //x=53.22 //y=7.41 //x2=53.22 //y2=7.585
r1375 (  625 953 ) resistor r=33.1979 //w=0.187 //l=0.485 //layer=li \
 //thickness=0.1 //x=53.22 //y=7.41 //x2=53.22 //y2=6.925
r1376 (  622 877 ) resistor r=2.87058 //w=0.35 //l=0.085 //layer=li \
 //thickness=0.1 //x=52.425 //y=7.585 //x2=52.34 //y2=7.585
r1377 (  622 624 ) resistor r=21.1008 //w=0.367 //l=0.605 //layer=li \
 //thickness=0.1 //x=52.425 //y=7.585 //x2=53.03 //y2=7.585
r1378 (  621 878 ) resistor r=2.87058 //w=0.35 //l=0.085 //layer=li \
 //thickness=0.1 //x=53.135 //y=7.585 //x2=53.22 //y2=7.585
r1379 (  621 624 ) resistor r=3.66213 //w=0.367 //l=0.105 //layer=li \
 //thickness=0.1 //x=53.135 //y=7.585 //x2=53.03 //y2=7.585
r1380 (  615 877 ) resistor r=4.23183 //w=0.7 //l=0.175 //layer=li \
 //thickness=0.1 //x=52.34 //y=7.41 //x2=52.34 //y2=7.585
r1381 (  615 952 ) resistor r=56.4706 //w=0.187 //l=0.825 //layer=li \
 //thickness=0.1 //x=52.34 //y=7.41 //x2=52.34 //y2=6.585
r1382 (  612 876 ) resistor r=5.29055 //w=0.35 //l=0.17 //layer=li \
 //thickness=0.1 //x=51.72 //y=7.585 //x2=51.55 //y2=7.585
r1383 (  612 614 ) resistor r=6.97548 //w=0.367 //l=0.2 //layer=li \
 //thickness=0.1 //x=51.72 //y=7.585 //x2=51.92 //y2=7.585
r1384 (  611 877 ) resistor r=2.87058 //w=0.35 //l=0.085 //layer=li \
 //thickness=0.1 //x=52.255 //y=7.585 //x2=52.34 //y2=7.585
r1385 (  611 614 ) resistor r=11.6839 //w=0.367 //l=0.335 //layer=li \
 //thickness=0.1 //x=52.255 //y=7.585 //x2=51.92 //y2=7.585
r1386 (  608 875 ) resistor r=2.87058 //w=0.35 //l=0.085 //layer=li \
 //thickness=0.1 //x=50.855 //y=7.585 //x2=50.77 //y2=7.585
r1387 (  607 876 ) resistor r=5.29055 //w=0.35 //l=0.17 //layer=li \
 //thickness=0.1 //x=51.38 //y=7.585 //x2=51.55 //y2=7.585
r1388 (  607 608 ) resistor r=18.3106 //w=0.367 //l=0.525 //layer=li \
 //thickness=0.1 //x=51.38 //y=7.585 //x2=50.855 //y2=7.585
r1389 (  601 875 ) resistor r=4.23183 //w=0.7 //l=0.175 //layer=li \
 //thickness=0.1 //x=50.77 //y=7.41 //x2=50.77 //y2=7.585
r1390 (  601 951 ) resistor r=33.1979 //w=0.187 //l=0.485 //layer=li \
 //thickness=0.1 //x=50.77 //y=7.41 //x2=50.77 //y2=6.925
r1391 (  598 874 ) resistor r=2.87058 //w=0.35 //l=0.085 //layer=li \
 //thickness=0.1 //x=49.975 //y=7.585 //x2=49.89 //y2=7.585
r1392 (  598 600 ) resistor r=16.218 //w=0.367 //l=0.465 //layer=li \
 //thickness=0.1 //x=49.975 //y=7.585 //x2=50.44 //y2=7.585
r1393 (  597 875 ) resistor r=2.87058 //w=0.35 //l=0.085 //layer=li \
 //thickness=0.1 //x=50.685 //y=7.585 //x2=50.77 //y2=7.585
r1394 (  597 600 ) resistor r=8.54496 //w=0.367 //l=0.245 //layer=li \
 //thickness=0.1 //x=50.685 //y=7.585 //x2=50.44 //y2=7.585
r1395 (  591 874 ) resistor r=4.23183 //w=0.7 //l=0.175 //layer=li \
 //thickness=0.1 //x=49.89 //y=7.41 //x2=49.89 //y2=7.585
r1396 (  591 950 ) resistor r=33.1979 //w=0.187 //l=0.485 //layer=li \
 //thickness=0.1 //x=49.89 //y=7.41 //x2=49.89 //y2=6.925
r1397 (  588 873 ) resistor r=2.87058 //w=0.35 //l=0.085 //layer=li \
 //thickness=0.1 //x=49.095 //y=7.585 //x2=49.01 //y2=7.585
r1398 (  588 590 ) resistor r=8.19619 //w=0.367 //l=0.235 //layer=li \
 //thickness=0.1 //x=49.095 //y=7.585 //x2=49.33 //y2=7.585
r1399 (  587 874 ) resistor r=2.87058 //w=0.35 //l=0.085 //layer=li \
 //thickness=0.1 //x=49.805 //y=7.585 //x2=49.89 //y2=7.585
r1400 (  587 590 ) resistor r=16.5668 //w=0.367 //l=0.475 //layer=li \
 //thickness=0.1 //x=49.805 //y=7.585 //x2=49.33 //y2=7.585
r1401 (  581 873 ) resistor r=4.23183 //w=0.7 //l=0.175 //layer=li \
 //thickness=0.1 //x=49.01 //y=7.41 //x2=49.01 //y2=7.585
r1402 (  581 949 ) resistor r=56.4706 //w=0.187 //l=0.825 //layer=li \
 //thickness=0.1 //x=49.01 //y=7.41 //x2=49.01 //y2=6.585
r1403 (  580 872 ) resistor r=5.29055 //w=0.35 //l=0.17 //layer=li \
 //thickness=0.1 //x=48.39 //y=7.585 //x2=48.22 //y2=7.585
r1404 (  579 873 ) resistor r=2.87058 //w=0.35 //l=0.085 //layer=li \
 //thickness=0.1 //x=48.925 //y=7.585 //x2=49.01 //y2=7.585
r1405 (  579 580 ) resistor r=18.6594 //w=0.367 //l=0.535 //layer=li \
 //thickness=0.1 //x=48.925 //y=7.585 //x2=48.39 //y2=7.585
r1406 (  574 871 ) resistor r=2.87058 //w=0.35 //l=0.085 //layer=li \
 //thickness=0.1 //x=47.225 //y=7.585 //x2=47.14 //y2=7.585
r1407 (  574 576 ) resistor r=21.7984 //w=0.367 //l=0.625 //layer=li \
 //thickness=0.1 //x=47.225 //y=7.585 //x2=47.85 //y2=7.585
r1408 (  573 872 ) resistor r=5.29055 //w=0.35 //l=0.17 //layer=li \
 //thickness=0.1 //x=48.05 //y=7.585 //x2=48.22 //y2=7.585
r1409 (  573 576 ) resistor r=6.97548 //w=0.367 //l=0.2 //layer=li \
 //thickness=0.1 //x=48.05 //y=7.585 //x2=47.85 //y2=7.585
r1410 (  567 871 ) resistor r=4.23183 //w=0.7 //l=0.175 //layer=li \
 //thickness=0.1 //x=47.14 //y=7.41 //x2=47.14 //y2=7.585
r1411 (  567 948 ) resistor r=33.1979 //w=0.187 //l=0.485 //layer=li \
 //thickness=0.1 //x=47.14 //y=7.41 //x2=47.14 //y2=6.925
r1412 (  564 870 ) resistor r=2.87058 //w=0.35 //l=0.085 //layer=li \
 //thickness=0.1 //x=46.345 //y=7.585 //x2=46.26 //y2=7.585
r1413 (  564 566 ) resistor r=13.7766 //w=0.367 //l=0.395 //layer=li \
 //thickness=0.1 //x=46.345 //y=7.585 //x2=46.74 //y2=7.585
r1414 (  563 871 ) resistor r=2.87058 //w=0.35 //l=0.085 //layer=li \
 //thickness=0.1 //x=47.055 //y=7.585 //x2=47.14 //y2=7.585
r1415 (  563 566 ) resistor r=10.9864 //w=0.367 //l=0.315 //layer=li \
 //thickness=0.1 //x=47.055 //y=7.585 //x2=46.74 //y2=7.585
r1416 (  557 870 ) resistor r=4.23183 //w=0.7 //l=0.175 //layer=li \
 //thickness=0.1 //x=46.26 //y=7.41 //x2=46.26 //y2=7.585
r1417 (  557 947 ) resistor r=33.1979 //w=0.187 //l=0.485 //layer=li \
 //thickness=0.1 //x=46.26 //y=7.41 //x2=46.26 //y2=6.925
r1418 (  554 869 ) resistor r=2.87058 //w=0.35 //l=0.085 //layer=li \
 //thickness=0.1 //x=45.465 //y=7.585 //x2=45.38 //y2=7.585
r1419 (  554 556 ) resistor r=5.75477 //w=0.367 //l=0.165 //layer=li \
 //thickness=0.1 //x=45.465 //y=7.585 //x2=45.63 //y2=7.585
r1420 (  553 870 ) resistor r=2.87058 //w=0.35 //l=0.085 //layer=li \
 //thickness=0.1 //x=46.175 //y=7.585 //x2=46.26 //y2=7.585
r1421 (  553 556 ) resistor r=19.0082 //w=0.367 //l=0.545 //layer=li \
 //thickness=0.1 //x=46.175 //y=7.585 //x2=45.63 //y2=7.585
r1422 (  547 869 ) resistor r=4.23183 //w=0.7 //l=0.175 //layer=li \
 //thickness=0.1 //x=45.38 //y=7.41 //x2=45.38 //y2=7.585
r1423 (  547 946 ) resistor r=33.1979 //w=0.187 //l=0.485 //layer=li \
 //thickness=0.1 //x=45.38 //y=7.41 //x2=45.38 //y2=6.925
r1424 (  546 868 ) resistor r=2.87058 //w=0.35 //l=0.085 //layer=li \
 //thickness=0.1 //x=44.585 //y=7.585 //x2=44.5 //y2=7.585
r1425 (  545 869 ) resistor r=2.87058 //w=0.35 //l=0.085 //layer=li \
 //thickness=0.1 //x=45.295 //y=7.585 //x2=45.38 //y2=7.585
r1426 (  545 546 ) resistor r=24.7629 //w=0.367 //l=0.71 //layer=li \
 //thickness=0.1 //x=45.295 //y=7.585 //x2=44.585 //y2=7.585
r1427 (  539 868 ) resistor r=4.23183 //w=0.7 //l=0.175 //layer=li \
 //thickness=0.1 //x=44.5 //y=7.41 //x2=44.5 //y2=7.585
r1428 (  539 945 ) resistor r=56.4706 //w=0.187 //l=0.825 //layer=li \
 //thickness=0.1 //x=44.5 //y=7.41 //x2=44.5 //y2=6.585
r1429 (  538 866 ) resistor r=5.29055 //w=0.35 //l=0.17 //layer=li \
 //thickness=0.1 //x=43.58 //y=7.585 //x2=43.41 //y2=7.585
r1430 (  537 868 ) resistor r=2.87058 //w=0.35 //l=0.085 //layer=li \
 //thickness=0.1 //x=44.415 //y=7.585 //x2=44.5 //y2=7.585
r1431 (  537 538 ) resistor r=29.1226 //w=0.367 //l=0.835 //layer=li \
 //thickness=0.1 //x=44.415 //y=7.585 //x2=43.58 //y2=7.585
r1432 (  532 865 ) resistor r=2.87058 //w=0.35 //l=0.085 //layer=li \
 //thickness=0.1 //x=42.715 //y=7.585 //x2=42.63 //y2=7.585
r1433 (  532 534 ) resistor r=11.3351 //w=0.367 //l=0.325 //layer=li \
 //thickness=0.1 //x=42.715 //y=7.585 //x2=43.04 //y2=7.585
r1434 (  531 866 ) resistor r=5.29055 //w=0.35 //l=0.17 //layer=li \
 //thickness=0.1 //x=43.24 //y=7.585 //x2=43.41 //y2=7.585
r1435 (  531 534 ) resistor r=6.97548 //w=0.367 //l=0.2 //layer=li \
 //thickness=0.1 //x=43.24 //y=7.585 //x2=43.04 //y2=7.585
r1436 (  525 865 ) resistor r=4.23183 //w=0.7 //l=0.175 //layer=li \
 //thickness=0.1 //x=42.63 //y=7.41 //x2=42.63 //y2=7.585
r1437 (  525 944 ) resistor r=33.1979 //w=0.187 //l=0.485 //layer=li \
 //thickness=0.1 //x=42.63 //y=7.41 //x2=42.63 //y2=6.925
r1438 (  522 864 ) resistor r=2.87058 //w=0.35 //l=0.085 //layer=li \
 //thickness=0.1 //x=41.835 //y=7.585 //x2=41.75 //y2=7.585
r1439 (  522 524 ) resistor r=3.31335 //w=0.367 //l=0.095 //layer=li \
 //thickness=0.1 //x=41.835 //y=7.585 //x2=41.93 //y2=7.585
r1440 (  521 865 ) resistor r=2.87058 //w=0.35 //l=0.085 //layer=li \
 //thickness=0.1 //x=42.545 //y=7.585 //x2=42.63 //y2=7.585
r1441 (  521 524 ) resistor r=21.4496 //w=0.367 //l=0.615 //layer=li \
 //thickness=0.1 //x=42.545 //y=7.585 //x2=41.93 //y2=7.585
r1442 (  515 864 ) resistor r=4.23183 //w=0.7 //l=0.175 //layer=li \
 //thickness=0.1 //x=41.75 //y=7.41 //x2=41.75 //y2=7.585
r1443 (  515 943 ) resistor r=33.1979 //w=0.187 //l=0.485 //layer=li \
 //thickness=0.1 //x=41.75 //y=7.41 //x2=41.75 //y2=6.925
r1444 (  514 863 ) resistor r=2.87058 //w=0.35 //l=0.085 //layer=li \
 //thickness=0.1 //x=40.955 //y=7.585 //x2=40.87 //y2=7.585
r1445 (  513 864 ) resistor r=2.87058 //w=0.35 //l=0.085 //layer=li \
 //thickness=0.1 //x=41.665 //y=7.585 //x2=41.75 //y2=7.585
r1446 (  513 514 ) resistor r=24.7629 //w=0.367 //l=0.71 //layer=li \
 //thickness=0.1 //x=41.665 //y=7.585 //x2=40.955 //y2=7.585
r1447 (  507 863 ) resistor r=4.23183 //w=0.7 //l=0.175 //layer=li \
 //thickness=0.1 //x=40.87 //y=7.41 //x2=40.87 //y2=7.585
r1448 (  507 942 ) resistor r=56.4706 //w=0.187 //l=0.825 //layer=li \
 //thickness=0.1 //x=40.87 //y=7.41 //x2=40.87 //y2=6.585
r1449 (  506 861 ) resistor r=5.29055 //w=0.35 //l=0.17 //layer=li \
 //thickness=0.1 //x=40.25 //y=7.585 //x2=40.08 //y2=7.585
r1450 (  505 863 ) resistor r=2.87058 //w=0.35 //l=0.085 //layer=li \
 //thickness=0.1 //x=40.785 //y=7.585 //x2=40.87 //y2=7.585
r1451 (  505 506 ) resistor r=18.6594 //w=0.367 //l=0.535 //layer=li \
 //thickness=0.1 //x=40.785 //y=7.585 //x2=40.25 //y2=7.585
r1452 (  502 860 ) resistor r=2.87058 //w=0.35 //l=0.085 //layer=li \
 //thickness=0.1 //x=39.385 //y=7.585 //x2=39.3 //y2=7.585
r1453 (  501 861 ) resistor r=5.29055 //w=0.35 //l=0.17 //layer=li \
 //thickness=0.1 //x=39.91 //y=7.585 //x2=40.08 //y2=7.585
r1454 (  501 502 ) resistor r=18.3106 //w=0.367 //l=0.525 //layer=li \
 //thickness=0.1 //x=39.91 //y=7.585 //x2=39.385 //y2=7.585
r1455 (  495 860 ) resistor r=4.23183 //w=0.7 //l=0.175 //layer=li \
 //thickness=0.1 //x=39.3 //y=7.41 //x2=39.3 //y2=7.585
r1456 (  495 941 ) resistor r=33.1979 //w=0.187 //l=0.485 //layer=li \
 //thickness=0.1 //x=39.3 //y=7.41 //x2=39.3 //y2=6.925
r1457 (  494 858 ) resistor r=2.87058 //w=0.35 //l=0.085 //layer=li \
 //thickness=0.1 //x=38.505 //y=7.585 //x2=38.42 //y2=7.585
r1458 (  493 860 ) resistor r=2.87058 //w=0.35 //l=0.085 //layer=li \
 //thickness=0.1 //x=39.215 //y=7.585 //x2=39.3 //y2=7.585
r1459 (  493 494 ) resistor r=24.7629 //w=0.367 //l=0.71 //layer=li \
 //thickness=0.1 //x=39.215 //y=7.585 //x2=38.505 //y2=7.585
r1460 (  487 858 ) resistor r=4.23183 //w=0.7 //l=0.175 //layer=li \
 //thickness=0.1 //x=38.42 //y=7.41 //x2=38.42 //y2=7.585
r1461 (  487 940 ) resistor r=33.1979 //w=0.187 //l=0.485 //layer=li \
 //thickness=0.1 //x=38.42 //y=7.41 //x2=38.42 //y2=6.925
r1462 (  484 857 ) resistor r=2.87058 //w=0.35 //l=0.085 //layer=li \
 //thickness=0.1 //x=37.625 //y=7.585 //x2=37.54 //y2=7.585
r1463 (  484 486 ) resistor r=21.1008 //w=0.367 //l=0.605 //layer=li \
 //thickness=0.1 //x=37.625 //y=7.585 //x2=38.23 //y2=7.585
r1464 (  483 858 ) resistor r=2.87058 //w=0.35 //l=0.085 //layer=li \
 //thickness=0.1 //x=38.335 //y=7.585 //x2=38.42 //y2=7.585
r1465 (  483 486 ) resistor r=3.66213 //w=0.367 //l=0.105 //layer=li \
 //thickness=0.1 //x=38.335 //y=7.585 //x2=38.23 //y2=7.585
r1466 (  477 857 ) resistor r=4.23183 //w=0.7 //l=0.175 //layer=li \
 //thickness=0.1 //x=37.54 //y=7.41 //x2=37.54 //y2=7.585
r1467 (  477 939 ) resistor r=56.4706 //w=0.187 //l=0.825 //layer=li \
 //thickness=0.1 //x=37.54 //y=7.41 //x2=37.54 //y2=6.585
r1468 (  474 856 ) resistor r=5.29055 //w=0.35 //l=0.17 //layer=li \
 //thickness=0.1 //x=36.92 //y=7.585 //x2=36.75 //y2=7.585
r1469 (  474 476 ) resistor r=6.97548 //w=0.367 //l=0.2 //layer=li \
 //thickness=0.1 //x=36.92 //y=7.585 //x2=37.12 //y2=7.585
r1470 (  473 857 ) resistor r=2.87058 //w=0.35 //l=0.085 //layer=li \
 //thickness=0.1 //x=37.455 //y=7.585 //x2=37.54 //y2=7.585
r1471 (  473 476 ) resistor r=11.6839 //w=0.367 //l=0.335 //layer=li \
 //thickness=0.1 //x=37.455 //y=7.585 //x2=37.12 //y2=7.585
r1472 (  470 855 ) resistor r=2.87058 //w=0.35 //l=0.085 //layer=li \
 //thickness=0.1 //x=36.055 //y=7.585 //x2=35.97 //y2=7.585
r1473 (  469 856 ) resistor r=5.29055 //w=0.35 //l=0.17 //layer=li \
 //thickness=0.1 //x=36.58 //y=7.585 //x2=36.75 //y2=7.585
r1474 (  469 470 ) resistor r=18.3106 //w=0.367 //l=0.525 //layer=li \
 //thickness=0.1 //x=36.58 //y=7.585 //x2=36.055 //y2=7.585
r1475 (  463 855 ) resistor r=4.23183 //w=0.7 //l=0.175 //layer=li \
 //thickness=0.1 //x=35.97 //y=7.41 //x2=35.97 //y2=7.585
r1476 (  463 938 ) resistor r=33.1979 //w=0.187 //l=0.485 //layer=li \
 //thickness=0.1 //x=35.97 //y=7.41 //x2=35.97 //y2=6.925
r1477 (  460 854 ) resistor r=2.87058 //w=0.35 //l=0.085 //layer=li \
 //thickness=0.1 //x=35.175 //y=7.585 //x2=35.09 //y2=7.585
r1478 (  460 462 ) resistor r=16.218 //w=0.367 //l=0.465 //layer=li \
 //thickness=0.1 //x=35.175 //y=7.585 //x2=35.64 //y2=7.585
r1479 (  459 855 ) resistor r=2.87058 //w=0.35 //l=0.085 //layer=li \
 //thickness=0.1 //x=35.885 //y=7.585 //x2=35.97 //y2=7.585
r1480 (  459 462 ) resistor r=8.54496 //w=0.367 //l=0.245 //layer=li \
 //thickness=0.1 //x=35.885 //y=7.585 //x2=35.64 //y2=7.585
r1481 (  453 854 ) resistor r=4.23183 //w=0.7 //l=0.175 //layer=li \
 //thickness=0.1 //x=35.09 //y=7.41 //x2=35.09 //y2=7.585
r1482 (  453 937 ) resistor r=33.1979 //w=0.187 //l=0.485 //layer=li \
 //thickness=0.1 //x=35.09 //y=7.41 //x2=35.09 //y2=6.925
r1483 (  450 853 ) resistor r=2.87058 //w=0.35 //l=0.085 //layer=li \
 //thickness=0.1 //x=34.295 //y=7.585 //x2=34.21 //y2=7.585
r1484 (  450 452 ) resistor r=8.19619 //w=0.367 //l=0.235 //layer=li \
 //thickness=0.1 //x=34.295 //y=7.585 //x2=34.53 //y2=7.585
r1485 (  449 854 ) resistor r=2.87058 //w=0.35 //l=0.085 //layer=li \
 //thickness=0.1 //x=35.005 //y=7.585 //x2=35.09 //y2=7.585
r1486 (  449 452 ) resistor r=16.5668 //w=0.367 //l=0.475 //layer=li \
 //thickness=0.1 //x=35.005 //y=7.585 //x2=34.53 //y2=7.585
r1487 (  443 853 ) resistor r=4.23183 //w=0.7 //l=0.175 //layer=li \
 //thickness=0.1 //x=34.21 //y=7.41 //x2=34.21 //y2=7.585
r1488 (  443 936 ) resistor r=56.4706 //w=0.187 //l=0.825 //layer=li \
 //thickness=0.1 //x=34.21 //y=7.41 //x2=34.21 //y2=6.585
r1489 (  442 852 ) resistor r=5.29055 //w=0.35 //l=0.17 //layer=li \
 //thickness=0.1 //x=33.59 //y=7.585 //x2=33.42 //y2=7.585
r1490 (  441 853 ) resistor r=2.87058 //w=0.35 //l=0.085 //layer=li \
 //thickness=0.1 //x=34.125 //y=7.585 //x2=34.21 //y2=7.585
r1491 (  441 442 ) resistor r=18.6594 //w=0.367 //l=0.535 //layer=li \
 //thickness=0.1 //x=34.125 //y=7.585 //x2=33.59 //y2=7.585
r1492 (  436 851 ) resistor r=2.87058 //w=0.35 //l=0.085 //layer=li \
 //thickness=0.1 //x=32.725 //y=7.585 //x2=32.64 //y2=7.585
r1493 (  436 438 ) resistor r=11.3351 //w=0.367 //l=0.325 //layer=li \
 //thickness=0.1 //x=32.725 //y=7.585 //x2=33.05 //y2=7.585
r1494 (  435 852 ) resistor r=5.29055 //w=0.35 //l=0.17 //layer=li \
 //thickness=0.1 //x=33.25 //y=7.585 //x2=33.42 //y2=7.585
r1495 (  435 438 ) resistor r=6.97548 //w=0.367 //l=0.2 //layer=li \
 //thickness=0.1 //x=33.25 //y=7.585 //x2=33.05 //y2=7.585
r1496 (  429 851 ) resistor r=4.23183 //w=0.7 //l=0.175 //layer=li \
 //thickness=0.1 //x=32.64 //y=7.41 //x2=32.64 //y2=7.585
r1497 (  429 935 ) resistor r=33.1979 //w=0.187 //l=0.485 //layer=li \
 //thickness=0.1 //x=32.64 //y=7.41 //x2=32.64 //y2=6.925
r1498 (  426 850 ) resistor r=2.87058 //w=0.35 //l=0.085 //layer=li \
 //thickness=0.1 //x=31.845 //y=7.585 //x2=31.76 //y2=7.585
r1499 (  426 428 ) resistor r=3.31335 //w=0.367 //l=0.095 //layer=li \
 //thickness=0.1 //x=31.845 //y=7.585 //x2=31.94 //y2=7.585
r1500 (  425 851 ) resistor r=2.87058 //w=0.35 //l=0.085 //layer=li \
 //thickness=0.1 //x=32.555 //y=7.585 //x2=32.64 //y2=7.585
r1501 (  425 428 ) resistor r=21.4496 //w=0.367 //l=0.615 //layer=li \
 //thickness=0.1 //x=32.555 //y=7.585 //x2=31.94 //y2=7.585
r1502 (  419 850 ) resistor r=4.23183 //w=0.7 //l=0.175 //layer=li \
 //thickness=0.1 //x=31.76 //y=7.41 //x2=31.76 //y2=7.585
r1503 (  419 934 ) resistor r=33.1979 //w=0.187 //l=0.485 //layer=li \
 //thickness=0.1 //x=31.76 //y=7.41 //x2=31.76 //y2=6.925
r1504 (  418 849 ) resistor r=2.87058 //w=0.35 //l=0.085 //layer=li \
 //thickness=0.1 //x=30.965 //y=7.585 //x2=30.88 //y2=7.585
r1505 (  417 850 ) resistor r=2.87058 //w=0.35 //l=0.085 //layer=li \
 //thickness=0.1 //x=31.675 //y=7.585 //x2=31.76 //y2=7.585
r1506 (  417 418 ) resistor r=24.7629 //w=0.367 //l=0.71 //layer=li \
 //thickness=0.1 //x=31.675 //y=7.585 //x2=30.965 //y2=7.585
r1507 (  411 849 ) resistor r=4.23183 //w=0.7 //l=0.175 //layer=li \
 //thickness=0.1 //x=30.88 //y=7.41 //x2=30.88 //y2=7.585
r1508 (  411 933 ) resistor r=56.4706 //w=0.187 //l=0.825 //layer=li \
 //thickness=0.1 //x=30.88 //y=7.41 //x2=30.88 //y2=6.585
r1509 (  410 847 ) resistor r=5.29055 //w=0.35 //l=0.17 //layer=li \
 //thickness=0.1 //x=30.26 //y=7.585 //x2=30.09 //y2=7.585
r1510 (  409 849 ) resistor r=2.87058 //w=0.35 //l=0.085 //layer=li \
 //thickness=0.1 //x=30.795 //y=7.585 //x2=30.88 //y2=7.585
r1511 (  409 410 ) resistor r=18.6594 //w=0.367 //l=0.535 //layer=li \
 //thickness=0.1 //x=30.795 //y=7.585 //x2=30.26 //y2=7.585
r1512 (  406 846 ) resistor r=2.87058 //w=0.35 //l=0.085 //layer=li \
 //thickness=0.1 //x=29.395 //y=7.585 //x2=29.31 //y2=7.585
r1513 (  405 847 ) resistor r=5.29055 //w=0.35 //l=0.17 //layer=li \
 //thickness=0.1 //x=29.92 //y=7.585 //x2=30.09 //y2=7.585
r1514 (  405 406 ) resistor r=18.3106 //w=0.367 //l=0.525 //layer=li \
 //thickness=0.1 //x=29.92 //y=7.585 //x2=29.395 //y2=7.585
r1515 (  399 846 ) resistor r=4.23183 //w=0.7 //l=0.175 //layer=li \
 //thickness=0.1 //x=29.31 //y=7.41 //x2=29.31 //y2=7.585
r1516 (  399 932 ) resistor r=33.1979 //w=0.187 //l=0.485 //layer=li \
 //thickness=0.1 //x=29.31 //y=7.41 //x2=29.31 //y2=6.925
r1517 (  398 844 ) resistor r=2.87058 //w=0.35 //l=0.085 //layer=li \
 //thickness=0.1 //x=28.515 //y=7.585 //x2=28.43 //y2=7.585
r1518 (  397 846 ) resistor r=2.87058 //w=0.35 //l=0.085 //layer=li \
 //thickness=0.1 //x=29.225 //y=7.585 //x2=29.31 //y2=7.585
r1519 (  397 398 ) resistor r=24.7629 //w=0.367 //l=0.71 //layer=li \
 //thickness=0.1 //x=29.225 //y=7.585 //x2=28.515 //y2=7.585
r1520 (  391 844 ) resistor r=4.23183 //w=0.7 //l=0.175 //layer=li \
 //thickness=0.1 //x=28.43 //y=7.41 //x2=28.43 //y2=7.585
r1521 (  391 931 ) resistor r=33.1979 //w=0.187 //l=0.485 //layer=li \
 //thickness=0.1 //x=28.43 //y=7.41 //x2=28.43 //y2=6.925
r1522 (  388 843 ) resistor r=2.87058 //w=0.35 //l=0.085 //layer=li \
 //thickness=0.1 //x=27.635 //y=7.585 //x2=27.55 //y2=7.585
r1523 (  388 390 ) resistor r=21.1008 //w=0.367 //l=0.605 //layer=li \
 //thickness=0.1 //x=27.635 //y=7.585 //x2=28.24 //y2=7.585
r1524 (  387 844 ) resistor r=2.87058 //w=0.35 //l=0.085 //layer=li \
 //thickness=0.1 //x=28.345 //y=7.585 //x2=28.43 //y2=7.585
r1525 (  387 390 ) resistor r=3.66213 //w=0.367 //l=0.105 //layer=li \
 //thickness=0.1 //x=28.345 //y=7.585 //x2=28.24 //y2=7.585
r1526 (  381 843 ) resistor r=4.23183 //w=0.7 //l=0.175 //layer=li \
 //thickness=0.1 //x=27.55 //y=7.41 //x2=27.55 //y2=7.585
r1527 (  381 930 ) resistor r=56.4706 //w=0.187 //l=0.825 //layer=li \
 //thickness=0.1 //x=27.55 //y=7.41 //x2=27.55 //y2=6.585
r1528 (  378 842 ) resistor r=5.29055 //w=0.35 //l=0.17 //layer=li \
 //thickness=0.1 //x=26.93 //y=7.585 //x2=26.76 //y2=7.585
r1529 (  378 380 ) resistor r=6.97548 //w=0.367 //l=0.2 //layer=li \
 //thickness=0.1 //x=26.93 //y=7.585 //x2=27.13 //y2=7.585
r1530 (  377 843 ) resistor r=2.87058 //w=0.35 //l=0.085 //layer=li \
 //thickness=0.1 //x=27.465 //y=7.585 //x2=27.55 //y2=7.585
r1531 (  377 380 ) resistor r=11.6839 //w=0.367 //l=0.335 //layer=li \
 //thickness=0.1 //x=27.465 //y=7.585 //x2=27.13 //y2=7.585
r1532 (  374 841 ) resistor r=2.87058 //w=0.35 //l=0.085 //layer=li \
 //thickness=0.1 //x=25.765 //y=7.585 //x2=25.68 //y2=7.585
r1533 (  373 842 ) resistor r=5.29055 //w=0.35 //l=0.17 //layer=li \
 //thickness=0.1 //x=26.59 //y=7.585 //x2=26.76 //y2=7.585
r1534 (  373 374 ) resistor r=28.7738 //w=0.367 //l=0.825 //layer=li \
 //thickness=0.1 //x=26.59 //y=7.585 //x2=25.765 //y2=7.585
r1535 (  367 841 ) resistor r=4.23183 //w=0.7 //l=0.175 //layer=li \
 //thickness=0.1 //x=25.68 //y=7.41 //x2=25.68 //y2=7.585
r1536 (  367 929 ) resistor r=33.1979 //w=0.187 //l=0.485 //layer=li \
 //thickness=0.1 //x=25.68 //y=7.41 //x2=25.68 //y2=6.925
r1537 (  366 839 ) resistor r=2.87058 //w=0.35 //l=0.085 //layer=li \
 //thickness=0.1 //x=24.885 //y=7.585 //x2=24.8 //y2=7.585
r1538 (  365 841 ) resistor r=2.87058 //w=0.35 //l=0.085 //layer=li \
 //thickness=0.1 //x=25.595 //y=7.585 //x2=25.68 //y2=7.585
r1539 (  365 366 ) resistor r=24.7629 //w=0.367 //l=0.71 //layer=li \
 //thickness=0.1 //x=25.595 //y=7.585 //x2=24.885 //y2=7.585
r1540 (  359 839 ) resistor r=4.23183 //w=0.7 //l=0.175 //layer=li \
 //thickness=0.1 //x=24.8 //y=7.41 //x2=24.8 //y2=7.585
r1541 (  359 928 ) resistor r=33.1979 //w=0.187 //l=0.485 //layer=li \
 //thickness=0.1 //x=24.8 //y=7.41 //x2=24.8 //y2=6.925
r1542 (  356 838 ) resistor r=2.87058 //w=0.35 //l=0.085 //layer=li \
 //thickness=0.1 //x=24.005 //y=7.585 //x2=23.92 //y2=7.585
r1543 (  356 358 ) resistor r=18.6594 //w=0.367 //l=0.535 //layer=li \
 //thickness=0.1 //x=24.005 //y=7.585 //x2=24.54 //y2=7.585
r1544 (  355 839 ) resistor r=2.87058 //w=0.35 //l=0.085 //layer=li \
 //thickness=0.1 //x=24.715 //y=7.585 //x2=24.8 //y2=7.585
r1545 (  355 358 ) resistor r=6.10354 //w=0.367 //l=0.175 //layer=li \
 //thickness=0.1 //x=24.715 //y=7.585 //x2=24.54 //y2=7.585
r1546 (  349 838 ) resistor r=4.23183 //w=0.7 //l=0.175 //layer=li \
 //thickness=0.1 //x=23.92 //y=7.41 //x2=23.92 //y2=7.585
r1547 (  349 927 ) resistor r=33.1979 //w=0.187 //l=0.485 //layer=li \
 //thickness=0.1 //x=23.92 //y=7.41 //x2=23.92 //y2=6.925
r1548 (  346 837 ) resistor r=2.87058 //w=0.35 //l=0.085 //layer=li \
 //thickness=0.1 //x=23.125 //y=7.585 //x2=23.04 //y2=7.585
r1549 (  346 348 ) resistor r=10.6376 //w=0.367 //l=0.305 //layer=li \
 //thickness=0.1 //x=23.125 //y=7.585 //x2=23.43 //y2=7.585
r1550 (  345 838 ) resistor r=2.87058 //w=0.35 //l=0.085 //layer=li \
 //thickness=0.1 //x=23.835 //y=7.585 //x2=23.92 //y2=7.585
r1551 (  345 348 ) resistor r=14.1253 //w=0.367 //l=0.405 //layer=li \
 //thickness=0.1 //x=23.835 //y=7.585 //x2=23.43 //y2=7.585
r1552 (  339 837 ) resistor r=4.23183 //w=0.7 //l=0.175 //layer=li \
 //thickness=0.1 //x=23.04 //y=7.41 //x2=23.04 //y2=7.585
r1553 (  339 926 ) resistor r=56.4706 //w=0.187 //l=0.825 //layer=li \
 //thickness=0.1 //x=23.04 //y=7.41 //x2=23.04 //y2=6.585
r1554 (  336 836 ) resistor r=5.29055 //w=0.35 //l=0.17 //layer=li \
 //thickness=0.1 //x=22.12 //y=7.585 //x2=21.95 //y2=7.585
r1555 (  336 338 ) resistor r=6.97548 //w=0.367 //l=0.2 //layer=li \
 //thickness=0.1 //x=22.12 //y=7.585 //x2=22.32 //y2=7.585
r1556 (  335 837 ) resistor r=2.87058 //w=0.35 //l=0.085 //layer=li \
 //thickness=0.1 //x=22.955 //y=7.585 //x2=23.04 //y2=7.585
r1557 (  335 338 ) resistor r=22.1471 //w=0.367 //l=0.635 //layer=li \
 //thickness=0.1 //x=22.955 //y=7.585 //x2=22.32 //y2=7.585
r1558 (  332 835 ) resistor r=2.87058 //w=0.35 //l=0.085 //layer=li \
 //thickness=0.1 //x=21.255 //y=7.585 //x2=21.17 //y2=7.585
r1559 (  331 836 ) resistor r=5.29055 //w=0.35 //l=0.17 //layer=li \
 //thickness=0.1 //x=21.78 //y=7.585 //x2=21.95 //y2=7.585
r1560 (  331 332 ) resistor r=18.3106 //w=0.367 //l=0.525 //layer=li \
 //thickness=0.1 //x=21.78 //y=7.585 //x2=21.255 //y2=7.585
r1561 (  325 835 ) resistor r=4.23183 //w=0.7 //l=0.175 //layer=li \
 //thickness=0.1 //x=21.17 //y=7.41 //x2=21.17 //y2=7.585
r1562 (  325 925 ) resistor r=33.1979 //w=0.187 //l=0.485 //layer=li \
 //thickness=0.1 //x=21.17 //y=7.41 //x2=21.17 //y2=6.925
r1563 (  322 834 ) resistor r=2.87058 //w=0.35 //l=0.085 //layer=li \
 //thickness=0.1 //x=20.375 //y=7.585 //x2=20.29 //y2=7.585
r1564 (  322 324 ) resistor r=16.218 //w=0.367 //l=0.465 //layer=li \
 //thickness=0.1 //x=20.375 //y=7.585 //x2=20.84 //y2=7.585
r1565 (  321 835 ) resistor r=2.87058 //w=0.35 //l=0.085 //layer=li \
 //thickness=0.1 //x=21.085 //y=7.585 //x2=21.17 //y2=7.585
r1566 (  321 324 ) resistor r=8.54496 //w=0.367 //l=0.245 //layer=li \
 //thickness=0.1 //x=21.085 //y=7.585 //x2=20.84 //y2=7.585
r1567 (  315 834 ) resistor r=4.23183 //w=0.7 //l=0.175 //layer=li \
 //thickness=0.1 //x=20.29 //y=7.41 //x2=20.29 //y2=7.585
r1568 (  315 924 ) resistor r=33.1979 //w=0.187 //l=0.485 //layer=li \
 //thickness=0.1 //x=20.29 //y=7.41 //x2=20.29 //y2=6.925
r1569 (  312 833 ) resistor r=2.87058 //w=0.35 //l=0.085 //layer=li \
 //thickness=0.1 //x=19.495 //y=7.585 //x2=19.41 //y2=7.585
r1570 (  312 314 ) resistor r=8.19619 //w=0.367 //l=0.235 //layer=li \
 //thickness=0.1 //x=19.495 //y=7.585 //x2=19.73 //y2=7.585
r1571 (  311 834 ) resistor r=2.87058 //w=0.35 //l=0.085 //layer=li \
 //thickness=0.1 //x=20.205 //y=7.585 //x2=20.29 //y2=7.585
r1572 (  311 314 ) resistor r=16.5668 //w=0.367 //l=0.475 //layer=li \
 //thickness=0.1 //x=20.205 //y=7.585 //x2=19.73 //y2=7.585
r1573 (  305 833 ) resistor r=4.23183 //w=0.7 //l=0.175 //layer=li \
 //thickness=0.1 //x=19.41 //y=7.41 //x2=19.41 //y2=7.585
r1574 (  305 923 ) resistor r=56.4706 //w=0.187 //l=0.825 //layer=li \
 //thickness=0.1 //x=19.41 //y=7.41 //x2=19.41 //y2=6.585
r1575 (  304 832 ) resistor r=5.29055 //w=0.35 //l=0.17 //layer=li \
 //thickness=0.1 //x=18.79 //y=7.585 //x2=18.62 //y2=7.585
r1576 (  303 833 ) resistor r=2.87058 //w=0.35 //l=0.085 //layer=li \
 //thickness=0.1 //x=19.325 //y=7.585 //x2=19.41 //y2=7.585
r1577 (  303 304 ) resistor r=18.6594 //w=0.367 //l=0.535 //layer=li \
 //thickness=0.1 //x=19.325 //y=7.585 //x2=18.79 //y2=7.585
r1578 (  298 831 ) resistor r=2.87058 //w=0.35 //l=0.085 //layer=li \
 //thickness=0.1 //x=17.925 //y=7.585 //x2=17.84 //y2=7.585
r1579 (  298 300 ) resistor r=11.3351 //w=0.367 //l=0.325 //layer=li \
 //thickness=0.1 //x=17.925 //y=7.585 //x2=18.25 //y2=7.585
r1580 (  297 832 ) resistor r=5.29055 //w=0.35 //l=0.17 //layer=li \
 //thickness=0.1 //x=18.45 //y=7.585 //x2=18.62 //y2=7.585
r1581 (  297 300 ) resistor r=6.97548 //w=0.367 //l=0.2 //layer=li \
 //thickness=0.1 //x=18.45 //y=7.585 //x2=18.25 //y2=7.585
r1582 (  291 831 ) resistor r=4.23183 //w=0.7 //l=0.175 //layer=li \
 //thickness=0.1 //x=17.84 //y=7.41 //x2=17.84 //y2=7.585
r1583 (  291 922 ) resistor r=33.1979 //w=0.187 //l=0.485 //layer=li \
 //thickness=0.1 //x=17.84 //y=7.41 //x2=17.84 //y2=6.925
r1584 (  288 830 ) resistor r=2.87058 //w=0.35 //l=0.085 //layer=li \
 //thickness=0.1 //x=17.045 //y=7.585 //x2=16.96 //y2=7.585
r1585 (  288 290 ) resistor r=3.31335 //w=0.367 //l=0.095 //layer=li \
 //thickness=0.1 //x=17.045 //y=7.585 //x2=17.14 //y2=7.585
r1586 (  287 831 ) resistor r=2.87058 //w=0.35 //l=0.085 //layer=li \
 //thickness=0.1 //x=17.755 //y=7.585 //x2=17.84 //y2=7.585
r1587 (  287 290 ) resistor r=21.4496 //w=0.367 //l=0.615 //layer=li \
 //thickness=0.1 //x=17.755 //y=7.585 //x2=17.14 //y2=7.585
r1588 (  281 830 ) resistor r=4.23183 //w=0.7 //l=0.175 //layer=li \
 //thickness=0.1 //x=16.96 //y=7.41 //x2=16.96 //y2=7.585
r1589 (  281 921 ) resistor r=33.1979 //w=0.187 //l=0.485 //layer=li \
 //thickness=0.1 //x=16.96 //y=7.41 //x2=16.96 //y2=6.925
r1590 (  280 829 ) resistor r=2.87058 //w=0.35 //l=0.085 //layer=li \
 //thickness=0.1 //x=16.165 //y=7.585 //x2=16.08 //y2=7.585
r1591 (  279 830 ) resistor r=2.87058 //w=0.35 //l=0.085 //layer=li \
 //thickness=0.1 //x=16.875 //y=7.585 //x2=16.96 //y2=7.585
r1592 (  279 280 ) resistor r=24.7629 //w=0.367 //l=0.71 //layer=li \
 //thickness=0.1 //x=16.875 //y=7.585 //x2=16.165 //y2=7.585
r1593 (  273 829 ) resistor r=4.23183 //w=0.7 //l=0.175 //layer=li \
 //thickness=0.1 //x=16.08 //y=7.41 //x2=16.08 //y2=7.585
r1594 (  273 920 ) resistor r=56.4706 //w=0.187 //l=0.825 //layer=li \
 //thickness=0.1 //x=16.08 //y=7.41 //x2=16.08 //y2=6.585
r1595 (  272 827 ) resistor r=5.29055 //w=0.35 //l=0.17 //layer=li \
 //thickness=0.1 //x=15.46 //y=7.585 //x2=15.29 //y2=7.585
r1596 (  271 829 ) resistor r=2.87058 //w=0.35 //l=0.085 //layer=li \
 //thickness=0.1 //x=15.995 //y=7.585 //x2=16.08 //y2=7.585
r1597 (  271 272 ) resistor r=18.6594 //w=0.367 //l=0.535 //layer=li \
 //thickness=0.1 //x=15.995 //y=7.585 //x2=15.46 //y2=7.585
r1598 (  268 826 ) resistor r=2.87058 //w=0.35 //l=0.085 //layer=li \
 //thickness=0.1 //x=14.595 //y=7.585 //x2=14.51 //y2=7.585
r1599 (  267 827 ) resistor r=5.29055 //w=0.35 //l=0.17 //layer=li \
 //thickness=0.1 //x=15.12 //y=7.585 //x2=15.29 //y2=7.585
r1600 (  267 268 ) resistor r=18.3106 //w=0.367 //l=0.525 //layer=li \
 //thickness=0.1 //x=15.12 //y=7.585 //x2=14.595 //y2=7.585
r1601 (  261 826 ) resistor r=4.23183 //w=0.7 //l=0.175 //layer=li \
 //thickness=0.1 //x=14.51 //y=7.41 //x2=14.51 //y2=7.585
r1602 (  261 919 ) resistor r=33.1979 //w=0.187 //l=0.485 //layer=li \
 //thickness=0.1 //x=14.51 //y=7.41 //x2=14.51 //y2=6.925
r1603 (  260 824 ) resistor r=2.87058 //w=0.35 //l=0.085 //layer=li \
 //thickness=0.1 //x=13.715 //y=7.585 //x2=13.63 //y2=7.585
r1604 (  259 826 ) resistor r=2.87058 //w=0.35 //l=0.085 //layer=li \
 //thickness=0.1 //x=14.425 //y=7.585 //x2=14.51 //y2=7.585
r1605 (  259 260 ) resistor r=24.7629 //w=0.367 //l=0.71 //layer=li \
 //thickness=0.1 //x=14.425 //y=7.585 //x2=13.715 //y2=7.585
r1606 (  253 824 ) resistor r=4.23183 //w=0.7 //l=0.175 //layer=li \
 //thickness=0.1 //x=13.63 //y=7.41 //x2=13.63 //y2=7.585
r1607 (  253 918 ) resistor r=33.1979 //w=0.187 //l=0.485 //layer=li \
 //thickness=0.1 //x=13.63 //y=7.41 //x2=13.63 //y2=6.925
r1608 (  250 823 ) resistor r=2.87058 //w=0.35 //l=0.085 //layer=li \
 //thickness=0.1 //x=12.835 //y=7.585 //x2=12.75 //y2=7.585
r1609 (  250 252 ) resistor r=21.1008 //w=0.367 //l=0.605 //layer=li \
 //thickness=0.1 //x=12.835 //y=7.585 //x2=13.44 //y2=7.585
r1610 (  249 824 ) resistor r=2.87058 //w=0.35 //l=0.085 //layer=li \
 //thickness=0.1 //x=13.545 //y=7.585 //x2=13.63 //y2=7.585
r1611 (  249 252 ) resistor r=3.66213 //w=0.367 //l=0.105 //layer=li \
 //thickness=0.1 //x=13.545 //y=7.585 //x2=13.44 //y2=7.585
r1612 (  243 823 ) resistor r=4.23183 //w=0.7 //l=0.175 //layer=li \
 //thickness=0.1 //x=12.75 //y=7.41 //x2=12.75 //y2=7.585
r1613 (  243 917 ) resistor r=56.4706 //w=0.187 //l=0.825 //layer=li \
 //thickness=0.1 //x=12.75 //y=7.41 //x2=12.75 //y2=6.585
r1614 (  240 822 ) resistor r=5.29055 //w=0.35 //l=0.17 //layer=li \
 //thickness=0.1 //x=12.13 //y=7.585 //x2=11.96 //y2=7.585
r1615 (  240 242 ) resistor r=6.97548 //w=0.367 //l=0.2 //layer=li \
 //thickness=0.1 //x=12.13 //y=7.585 //x2=12.33 //y2=7.585
r1616 (  239 823 ) resistor r=2.87058 //w=0.35 //l=0.085 //layer=li \
 //thickness=0.1 //x=12.665 //y=7.585 //x2=12.75 //y2=7.585
r1617 (  239 242 ) resistor r=11.6839 //w=0.367 //l=0.335 //layer=li \
 //thickness=0.1 //x=12.665 //y=7.585 //x2=12.33 //y2=7.585
r1618 (  236 821 ) resistor r=2.87058 //w=0.35 //l=0.085 //layer=li \
 //thickness=0.1 //x=11.265 //y=7.585 //x2=11.18 //y2=7.585
r1619 (  235 822 ) resistor r=5.29055 //w=0.35 //l=0.17 //layer=li \
 //thickness=0.1 //x=11.79 //y=7.585 //x2=11.96 //y2=7.585
r1620 (  235 236 ) resistor r=18.3106 //w=0.367 //l=0.525 //layer=li \
 //thickness=0.1 //x=11.79 //y=7.585 //x2=11.265 //y2=7.585
r1621 (  229 821 ) resistor r=4.23183 //w=0.7 //l=0.175 //layer=li \
 //thickness=0.1 //x=11.18 //y=7.41 //x2=11.18 //y2=7.585
r1622 (  229 916 ) resistor r=33.1979 //w=0.187 //l=0.485 //layer=li \
 //thickness=0.1 //x=11.18 //y=7.41 //x2=11.18 //y2=6.925
r1623 (  226 820 ) resistor r=2.87058 //w=0.35 //l=0.085 //layer=li \
 //thickness=0.1 //x=10.385 //y=7.585 //x2=10.3 //y2=7.585
r1624 (  226 228 ) resistor r=16.218 //w=0.367 //l=0.465 //layer=li \
 //thickness=0.1 //x=10.385 //y=7.585 //x2=10.85 //y2=7.585
r1625 (  225 821 ) resistor r=2.87058 //w=0.35 //l=0.085 //layer=li \
 //thickness=0.1 //x=11.095 //y=7.585 //x2=11.18 //y2=7.585
r1626 (  225 228 ) resistor r=8.54496 //w=0.367 //l=0.245 //layer=li \
 //thickness=0.1 //x=11.095 //y=7.585 //x2=10.85 //y2=7.585
r1627 (  219 820 ) resistor r=4.23183 //w=0.7 //l=0.175 //layer=li \
 //thickness=0.1 //x=10.3 //y=7.41 //x2=10.3 //y2=7.585
r1628 (  219 915 ) resistor r=33.1979 //w=0.187 //l=0.485 //layer=li \
 //thickness=0.1 //x=10.3 //y=7.41 //x2=10.3 //y2=6.925
r1629 (  216 819 ) resistor r=2.87058 //w=0.35 //l=0.085 //layer=li \
 //thickness=0.1 //x=9.505 //y=7.585 //x2=9.42 //y2=7.585
r1630 (  216 218 ) resistor r=8.19619 //w=0.367 //l=0.235 //layer=li \
 //thickness=0.1 //x=9.505 //y=7.585 //x2=9.74 //y2=7.585
r1631 (  215 820 ) resistor r=2.87058 //w=0.35 //l=0.085 //layer=li \
 //thickness=0.1 //x=10.215 //y=7.585 //x2=10.3 //y2=7.585
r1632 (  215 218 ) resistor r=16.5668 //w=0.367 //l=0.475 //layer=li \
 //thickness=0.1 //x=10.215 //y=7.585 //x2=9.74 //y2=7.585
r1633 (  209 819 ) resistor r=4.23183 //w=0.7 //l=0.175 //layer=li \
 //thickness=0.1 //x=9.42 //y=7.41 //x2=9.42 //y2=7.585
r1634 (  209 914 ) resistor r=56.4706 //w=0.187 //l=0.825 //layer=li \
 //thickness=0.1 //x=9.42 //y=7.41 //x2=9.42 //y2=6.585
r1635 (  208 818 ) resistor r=5.29055 //w=0.35 //l=0.17 //layer=li \
 //thickness=0.1 //x=8.8 //y=7.585 //x2=8.63 //y2=7.585
r1636 (  207 819 ) resistor r=2.87058 //w=0.35 //l=0.085 //layer=li \
 //thickness=0.1 //x=9.335 //y=7.585 //x2=9.42 //y2=7.585
r1637 (  207 208 ) resistor r=18.6594 //w=0.367 //l=0.535 //layer=li \
 //thickness=0.1 //x=9.335 //y=7.585 //x2=8.8 //y2=7.585
r1638 (  202 817 ) resistor r=2.87058 //w=0.35 //l=0.085 //layer=li \
 //thickness=0.1 //x=7.935 //y=7.585 //x2=7.85 //y2=7.585
r1639 (  202 204 ) resistor r=11.3351 //w=0.367 //l=0.325 //layer=li \
 //thickness=0.1 //x=7.935 //y=7.585 //x2=8.26 //y2=7.585
r1640 (  201 818 ) resistor r=5.29055 //w=0.35 //l=0.17 //layer=li \
 //thickness=0.1 //x=8.46 //y=7.585 //x2=8.63 //y2=7.585
r1641 (  201 204 ) resistor r=6.97548 //w=0.367 //l=0.2 //layer=li \
 //thickness=0.1 //x=8.46 //y=7.585 //x2=8.26 //y2=7.585
r1642 (  195 817 ) resistor r=4.23183 //w=0.7 //l=0.175 //layer=li \
 //thickness=0.1 //x=7.85 //y=7.41 //x2=7.85 //y2=7.585
r1643 (  195 913 ) resistor r=33.1979 //w=0.187 //l=0.485 //layer=li \
 //thickness=0.1 //x=7.85 //y=7.41 //x2=7.85 //y2=6.925
r1644 (  192 816 ) resistor r=2.87058 //w=0.35 //l=0.085 //layer=li \
 //thickness=0.1 //x=7.055 //y=7.585 //x2=6.97 //y2=7.585
r1645 (  192 194 ) resistor r=3.31335 //w=0.367 //l=0.095 //layer=li \
 //thickness=0.1 //x=7.055 //y=7.585 //x2=7.15 //y2=7.585
r1646 (  191 817 ) resistor r=2.87058 //w=0.35 //l=0.085 //layer=li \
 //thickness=0.1 //x=7.765 //y=7.585 //x2=7.85 //y2=7.585
r1647 (  191 194 ) resistor r=21.4496 //w=0.367 //l=0.615 //layer=li \
 //thickness=0.1 //x=7.765 //y=7.585 //x2=7.15 //y2=7.585
r1648 (  185 816 ) resistor r=4.23183 //w=0.7 //l=0.175 //layer=li \
 //thickness=0.1 //x=6.97 //y=7.41 //x2=6.97 //y2=7.585
r1649 (  185 912 ) resistor r=33.1979 //w=0.187 //l=0.485 //layer=li \
 //thickness=0.1 //x=6.97 //y=7.41 //x2=6.97 //y2=6.925
r1650 (  184 815 ) resistor r=2.87058 //w=0.35 //l=0.085 //layer=li \
 //thickness=0.1 //x=6.175 //y=7.585 //x2=6.09 //y2=7.585
r1651 (  183 816 ) resistor r=2.87058 //w=0.35 //l=0.085 //layer=li \
 //thickness=0.1 //x=6.885 //y=7.585 //x2=6.97 //y2=7.585
r1652 (  183 184 ) resistor r=24.7629 //w=0.367 //l=0.71 //layer=li \
 //thickness=0.1 //x=6.885 //y=7.585 //x2=6.175 //y2=7.585
r1653 (  177 815 ) resistor r=4.23183 //w=0.7 //l=0.175 //layer=li \
 //thickness=0.1 //x=6.09 //y=7.41 //x2=6.09 //y2=7.585
r1654 (  177 911 ) resistor r=56.4706 //w=0.187 //l=0.825 //layer=li \
 //thickness=0.1 //x=6.09 //y=7.41 //x2=6.09 //y2=6.585
r1655 (  176 813 ) resistor r=5.29055 //w=0.35 //l=0.17 //layer=li \
 //thickness=0.1 //x=5.47 //y=7.585 //x2=5.3 //y2=7.585
r1656 (  175 815 ) resistor r=2.87058 //w=0.35 //l=0.085 //layer=li \
 //thickness=0.1 //x=6.005 //y=7.585 //x2=6.09 //y2=7.585
r1657 (  175 176 ) resistor r=18.6594 //w=0.367 //l=0.535 //layer=li \
 //thickness=0.1 //x=6.005 //y=7.585 //x2=5.47 //y2=7.585
r1658 (  170 812 ) resistor r=2.87058 //w=0.35 //l=0.085 //layer=li \
 //thickness=0.1 //x=4.305 //y=7.585 //x2=4.22 //y2=7.585
r1659 (  170 172 ) resistor r=8.89373 //w=0.367 //l=0.255 //layer=li \
 //thickness=0.1 //x=4.305 //y=7.585 //x2=4.56 //y2=7.585
r1660 (  169 813 ) resistor r=5.29055 //w=0.35 //l=0.17 //layer=li \
 //thickness=0.1 //x=5.13 //y=7.585 //x2=5.3 //y2=7.585
r1661 (  169 172 ) resistor r=19.8801 //w=0.367 //l=0.57 //layer=li \
 //thickness=0.1 //x=5.13 //y=7.585 //x2=4.56 //y2=7.585
r1662 (  163 812 ) resistor r=4.23183 //w=0.7 //l=0.175 //layer=li \
 //thickness=0.1 //x=4.22 //y=7.41 //x2=4.22 //y2=7.585
r1663 (  163 910 ) resistor r=33.1979 //w=0.187 //l=0.485 //layer=li \
 //thickness=0.1 //x=4.22 //y=7.41 //x2=4.22 //y2=6.925
r1664 (  160 811 ) resistor r=2.87058 //w=0.35 //l=0.085 //layer=li \
 //thickness=0.1 //x=3.425 //y=7.585 //x2=3.34 //y2=7.585
r1665 (  160 162 ) resistor r=0.871935 //w=0.367 //l=0.025 //layer=li \
 //thickness=0.1 //x=3.425 //y=7.585 //x2=3.45 //y2=7.585
r1666 (  159 812 ) resistor r=2.87058 //w=0.35 //l=0.085 //layer=li \
 //thickness=0.1 //x=4.135 //y=7.585 //x2=4.22 //y2=7.585
r1667 (  159 162 ) resistor r=23.891 //w=0.367 //l=0.685 //layer=li \
 //thickness=0.1 //x=4.135 //y=7.585 //x2=3.45 //y2=7.585
r1668 (  153 811 ) resistor r=4.23183 //w=0.7 //l=0.175 //layer=li \
 //thickness=0.1 //x=3.34 //y=7.41 //x2=3.34 //y2=7.585
r1669 (  153 909 ) resistor r=33.1979 //w=0.187 //l=0.485 //layer=li \
 //thickness=0.1 //x=3.34 //y=7.41 //x2=3.34 //y2=6.925
r1670 (  152 810 ) resistor r=2.87058 //w=0.35 //l=0.085 //layer=li \
 //thickness=0.1 //x=2.545 //y=7.585 //x2=2.46 //y2=7.585
r1671 (  151 811 ) resistor r=2.87058 //w=0.35 //l=0.085 //layer=li \
 //thickness=0.1 //x=3.255 //y=7.585 //x2=3.34 //y2=7.585
r1672 (  151 152 ) resistor r=24.7629 //w=0.367 //l=0.71 //layer=li \
 //thickness=0.1 //x=3.255 //y=7.585 //x2=2.545 //y2=7.585
r1673 (  145 810 ) resistor r=4.23183 //w=0.7 //l=0.175 //layer=li \
 //thickness=0.1 //x=2.46 //y=7.41 //x2=2.46 //y2=7.585
r1674 (  145 908 ) resistor r=33.1979 //w=0.187 //l=0.485 //layer=li \
 //thickness=0.1 //x=2.46 //y=7.41 //x2=2.46 //y2=6.925
r1675 (  142 809 ) resistor r=2.87058 //w=0.35 //l=0.085 //layer=li \
 //thickness=0.1 //x=1.665 //y=7.585 //x2=1.58 //y2=7.585
r1676 (  142 144 ) resistor r=23.5422 //w=0.367 //l=0.675 //layer=li \
 //thickness=0.1 //x=1.665 //y=7.585 //x2=2.34 //y2=7.585
r1677 (  141 810 ) resistor r=2.87058 //w=0.35 //l=0.085 //layer=li \
 //thickness=0.1 //x=2.375 //y=7.585 //x2=2.46 //y2=7.585
r1678 (  141 144 ) resistor r=1.22071 //w=0.367 //l=0.035 //layer=li \
 //thickness=0.1 //x=2.375 //y=7.585 //x2=2.34 //y2=7.585
r1679 (  135 809 ) resistor r=4.23183 //w=0.7 //l=0.175 //layer=li \
 //thickness=0.1 //x=1.58 //y=7.41 //x2=1.58 //y2=7.585
r1680 (  135 907 ) resistor r=56.4706 //w=0.187 //l=0.825 //layer=li \
 //thickness=0.1 //x=1.58 //y=7.41 //x2=1.58 //y2=6.585
r1681 (  131 809 ) resistor r=2.87058 //w=0.35 //l=0.085 //layer=li \
 //thickness=0.1 //x=1.495 //y=7.585 //x2=1.58 //y2=7.585
r1682 (  131 134 ) resistor r=9.24251 //w=0.367 //l=0.265 //layer=li \
 //thickness=0.1 //x=1.495 //y=7.585 //x2=1.23 //y2=7.585
r1683 (  127 906 ) resistor r=4.65 //w=0.17 //l=0.34 //layer=mcon //count=2 \
 //x=76.34 //y=7.58 //x2=76.34 //y2=7.58
r1684 (  125 904 ) resistor r=3.1 //w=0.17 //l=0.51 //layer=mcon //count=3 \
 //x=75.6 //y=7.58 //x2=75.6 //y2=7.58
r1685 (  125 127 ) resistor r=0.297428 //w=0.311 //l=0.74 //layer=m1 \
 //thickness=0.36 //x=75.6 //y=7.585 //x2=76.34 //y2=7.585
r1686 (  123 786 ) resistor r=3.1 //w=0.17 //l=0.51 //layer=mcon //count=3 \
 //x=74.12 //y=7.58 //x2=74.12 //y2=7.58
r1687 (  123 125 ) resistor r=0.594855 //w=0.311 //l=1.48 //layer=m1 \
 //thickness=0.36 //x=74.12 //y=7.585 //x2=75.6 //y2=7.585
r1688 (  121 784 ) resistor r=3.1 //w=0.17 //l=0.51 //layer=mcon //count=3 \
 //x=73.01 //y=7.58 //x2=73.01 //y2=7.58
r1689 (  121 123 ) resistor r=0.446141 //w=0.311 //l=1.11 //layer=m1 \
 //thickness=0.36 //x=73.01 //y=7.585 //x2=74.12 //y2=7.585
r1690 (  119 782 ) resistor r=3.1 //w=0.17 //l=0.51 //layer=mcon //count=3 \
 //x=71.9 //y=7.58 //x2=71.9 //y2=7.58
r1691 (  119 121 ) resistor r=0.446141 //w=0.311 //l=1.11 //layer=m1 \
 //thickness=0.36 //x=71.9 //y=7.585 //x2=73.01 //y2=7.585
r1692 (  117 776 ) resistor r=3.1 //w=0.17 //l=0.51 //layer=mcon //count=3 \
 //x=70.42 //y=7.58 //x2=70.42 //y2=7.58
r1693 (  117 119 ) resistor r=0.594855 //w=0.311 //l=1.48 //layer=m1 \
 //thickness=0.36 //x=70.42 //y=7.585 //x2=71.9 //y2=7.585
r1694 (  115 774 ) resistor r=3.1 //w=0.17 //l=0.51 //layer=mcon //count=3 \
 //x=69.31 //y=7.58 //x2=69.31 //y2=7.58
r1695 (  115 117 ) resistor r=0.446141 //w=0.311 //l=1.11 //layer=m1 \
 //thickness=0.36 //x=69.31 //y=7.585 //x2=70.42 //y2=7.585
r1696 (  113 768 ) resistor r=3.1 //w=0.17 //l=0.51 //layer=mcon //count=3 \
 //x=67.83 //y=7.58 //x2=67.83 //y2=7.58
r1697 (  113 115 ) resistor r=0.594855 //w=0.311 //l=1.48 //layer=m1 \
 //thickness=0.36 //x=67.83 //y=7.585 //x2=69.31 //y2=7.585
r1698 (  111 758 ) resistor r=3.1 //w=0.17 //l=0.51 //layer=mcon //count=3 \
 //x=66.72 //y=7.58 //x2=66.72 //y2=7.58
r1699 (  111 113 ) resistor r=0.446141 //w=0.311 //l=1.11 //layer=m1 \
 //thickness=0.36 //x=66.72 //y=7.585 //x2=67.83 //y2=7.585
r1700 (  109 897 ) resistor r=3.1 //w=0.17 //l=0.51 //layer=mcon //count=3 \
 //x=65.61 //y=7.58 //x2=65.61 //y2=7.58
r1701 (  109 111 ) resistor r=0.446141 //w=0.311 //l=1.11 //layer=m1 \
 //thickness=0.36 //x=65.61 //y=7.585 //x2=66.72 //y2=7.585
r1702 (  107 894 ) resistor r=3.1 //w=0.17 //l=0.51 //layer=mcon //count=3 \
 //x=64.13 //y=7.58 //x2=64.13 //y2=7.58
r1703 (  107 109 ) resistor r=0.594855 //w=0.311 //l=1.48 //layer=m1 \
 //thickness=0.36 //x=64.13 //y=7.585 //x2=65.61 //y2=7.585
r1704 (  105 720 ) resistor r=3.1 //w=0.17 //l=0.51 //layer=mcon //count=3 \
 //x=63.02 //y=7.58 //x2=63.02 //y2=7.58
r1705 (  105 107 ) resistor r=0.446141 //w=0.311 //l=1.11 //layer=m1 \
 //thickness=0.36 //x=63.02 //y=7.585 //x2=64.13 //y2=7.585
r1706 (  103 710 ) resistor r=3.1 //w=0.17 //l=0.51 //layer=mcon //count=3 \
 //x=61.91 //y=7.58 //x2=61.91 //y2=7.58
r1707 (  103 105 ) resistor r=0.446141 //w=0.311 //l=1.11 //layer=m1 \
 //thickness=0.36 //x=61.91 //y=7.585 //x2=63.02 //y2=7.585
r1708 (  101 696 ) resistor r=3.1 //w=0.17 //l=0.51 //layer=mcon //count=3 \
 //x=60.43 //y=7.58 //x2=60.43 //y2=7.58
r1709 (  101 103 ) resistor r=0.594855 //w=0.311 //l=1.48 //layer=m1 \
 //thickness=0.36 //x=60.43 //y=7.585 //x2=61.91 //y2=7.585
r1710 (  99 686 ) resistor r=3.1 //w=0.17 //l=0.51 //layer=mcon //count=3 \
 //x=59.32 //y=7.58 //x2=59.32 //y2=7.58
r1711 (  99 101 ) resistor r=0.446141 //w=0.311 //l=1.11 //layer=m1 \
 //thickness=0.36 //x=59.32 //y=7.585 //x2=60.43 //y2=7.585
r1712 (  97 672 ) resistor r=3.1 //w=0.17 //l=0.51 //layer=mcon //count=3 \
 //x=57.84 //y=7.58 //x2=57.84 //y2=7.58
r1713 (  97 99 ) resistor r=0.594855 //w=0.311 //l=1.48 //layer=m1 \
 //thickness=0.36 //x=57.84 //y=7.585 //x2=59.32 //y2=7.585
r1714 (  95 662 ) resistor r=3.1 //w=0.17 //l=0.51 //layer=mcon //count=3 \
 //x=56.73 //y=7.58 //x2=56.73 //y2=7.58
r1715 (  95 97 ) resistor r=0.446141 //w=0.311 //l=1.11 //layer=m1 \
 //thickness=0.36 //x=56.73 //y=7.585 //x2=57.84 //y2=7.585
r1716 (  93 883 ) resistor r=3.1 //w=0.17 //l=0.51 //layer=mcon //count=3 \
 //x=55.62 //y=7.58 //x2=55.62 //y2=7.58
r1717 (  93 95 ) resistor r=0.446141 //w=0.311 //l=1.11 //layer=m1 \
 //thickness=0.36 //x=55.62 //y=7.585 //x2=56.73 //y2=7.585
r1718 (  91 880 ) resistor r=3.1 //w=0.17 //l=0.51 //layer=mcon //count=3 \
 //x=54.14 //y=7.58 //x2=54.14 //y2=7.58
r1719 (  91 93 ) resistor r=0.594855 //w=0.311 //l=1.48 //layer=m1 \
 //thickness=0.36 //x=54.14 //y=7.585 //x2=55.62 //y2=7.585
r1720 (  89 624 ) resistor r=3.1 //w=0.17 //l=0.51 //layer=mcon //count=3 \
 //x=53.03 //y=7.58 //x2=53.03 //y2=7.58
r1721 (  89 91 ) resistor r=0.446141 //w=0.311 //l=1.11 //layer=m1 \
 //thickness=0.36 //x=53.03 //y=7.585 //x2=54.14 //y2=7.585
r1722 (  87 614 ) resistor r=3.1 //w=0.17 //l=0.51 //layer=mcon //count=3 \
 //x=51.92 //y=7.58 //x2=51.92 //y2=7.58
r1723 (  87 89 ) resistor r=0.446141 //w=0.311 //l=1.11 //layer=m1 \
 //thickness=0.36 //x=51.92 //y=7.585 //x2=53.03 //y2=7.585
r1724 (  85 600 ) resistor r=3.1 //w=0.17 //l=0.51 //layer=mcon //count=3 \
 //x=50.44 //y=7.58 //x2=50.44 //y2=7.58
r1725 (  85 87 ) resistor r=0.594855 //w=0.311 //l=1.48 //layer=m1 \
 //thickness=0.36 //x=50.44 //y=7.585 //x2=51.92 //y2=7.585
r1726 (  83 590 ) resistor r=3.1 //w=0.17 //l=0.51 //layer=mcon //count=3 \
 //x=49.33 //y=7.58 //x2=49.33 //y2=7.58
r1727 (  83 85 ) resistor r=0.446141 //w=0.311 //l=1.11 //layer=m1 \
 //thickness=0.36 //x=49.33 //y=7.585 //x2=50.44 //y2=7.585
r1728 (  81 576 ) resistor r=3.1 //w=0.17 //l=0.51 //layer=mcon //count=3 \
 //x=47.85 //y=7.58 //x2=47.85 //y2=7.58
r1729 (  81 83 ) resistor r=0.594855 //w=0.311 //l=1.48 //layer=m1 \
 //thickness=0.36 //x=47.85 //y=7.585 //x2=49.33 //y2=7.585
r1730 (  79 566 ) resistor r=3.1 //w=0.17 //l=0.51 //layer=mcon //count=3 \
 //x=46.74 //y=7.58 //x2=46.74 //y2=7.58
r1731 (  79 81 ) resistor r=0.446141 //w=0.311 //l=1.11 //layer=m1 \
 //thickness=0.36 //x=46.74 //y=7.585 //x2=47.85 //y2=7.585
r1732 (  77 556 ) resistor r=3.1 //w=0.17 //l=0.51 //layer=mcon //count=3 \
 //x=45.63 //y=7.58 //x2=45.63 //y2=7.58
r1733 (  77 79 ) resistor r=0.446141 //w=0.311 //l=1.11 //layer=m1 \
 //thickness=0.36 //x=45.63 //y=7.585 //x2=46.74 //y2=7.585
r1734 (  75 868 ) resistor r=3.1 //w=0.17 //l=0.51 //layer=mcon //count=3 \
 //x=44.52 //y=7.58 //x2=44.52 //y2=7.58
r1735 (  75 77 ) resistor r=0.446141 //w=0.311 //l=1.11 //layer=m1 \
 //thickness=0.36 //x=44.52 //y=7.585 //x2=45.63 //y2=7.585
r1736 (  73 534 ) resistor r=3.1 //w=0.17 //l=0.51 //layer=mcon //count=3 \
 //x=43.04 //y=7.58 //x2=43.04 //y2=7.58
r1737 (  73 75 ) resistor r=0.594855 //w=0.311 //l=1.48 //layer=m1 \
 //thickness=0.36 //x=43.04 //y=7.585 //x2=44.52 //y2=7.585
r1738 (  71 524 ) resistor r=3.1 //w=0.17 //l=0.51 //layer=mcon //count=3 \
 //x=41.93 //y=7.58 //x2=41.93 //y2=7.58
r1739 (  71 73 ) resistor r=0.446141 //w=0.311 //l=1.11 //layer=m1 \
 //thickness=0.36 //x=41.93 //y=7.585 //x2=43.04 //y2=7.585
r1740 (  69 863 ) resistor r=3.1 //w=0.17 //l=0.51 //layer=mcon //count=3 \
 //x=40.82 //y=7.58 //x2=40.82 //y2=7.58
r1741 (  69 71 ) resistor r=0.446141 //w=0.311 //l=1.11 //layer=m1 \
 //thickness=0.36 //x=40.82 //y=7.585 //x2=41.93 //y2=7.585
r1742 (  67 860 ) resistor r=3.1 //w=0.17 //l=0.51 //layer=mcon //count=3 \
 //x=39.34 //y=7.58 //x2=39.34 //y2=7.58
r1743 (  67 69 ) resistor r=0.594855 //w=0.311 //l=1.48 //layer=m1 \
 //thickness=0.36 //x=39.34 //y=7.585 //x2=40.82 //y2=7.585
r1744 (  64 486 ) resistor r=3.1 //w=0.17 //l=0.51 //layer=mcon //count=3 \
 //x=38.23 //y=7.58 //x2=38.23 //y2=7.58
r1745 (  62 476 ) resistor r=3.1 //w=0.17 //l=0.51 //layer=mcon //count=3 \
 //x=37.12 //y=7.58 //x2=37.12 //y2=7.58
r1746 (  62 64 ) resistor r=0.446141 //w=0.311 //l=1.11 //layer=m1 \
 //thickness=0.36 //x=37.12 //y=7.585 //x2=38.23 //y2=7.585
r1747 (  60 462 ) resistor r=3.1 //w=0.17 //l=0.51 //layer=mcon //count=3 \
 //x=35.64 //y=7.58 //x2=35.64 //y2=7.58
r1748 (  60 62 ) resistor r=0.594855 //w=0.311 //l=1.48 //layer=m1 \
 //thickness=0.36 //x=35.64 //y=7.585 //x2=37.12 //y2=7.585
r1749 (  58 452 ) resistor r=3.1 //w=0.17 //l=0.51 //layer=mcon //count=3 \
 //x=34.53 //y=7.58 //x2=34.53 //y2=7.58
r1750 (  58 60 ) resistor r=0.446141 //w=0.311 //l=1.11 //layer=m1 \
 //thickness=0.36 //x=34.53 //y=7.585 //x2=35.64 //y2=7.585
r1751 (  56 438 ) resistor r=3.1 //w=0.17 //l=0.51 //layer=mcon //count=3 \
 //x=33.05 //y=7.58 //x2=33.05 //y2=7.58
r1752 (  56 58 ) resistor r=0.594855 //w=0.311 //l=1.48 //layer=m1 \
 //thickness=0.36 //x=33.05 //y=7.585 //x2=34.53 //y2=7.585
r1753 (  54 428 ) resistor r=3.1 //w=0.17 //l=0.51 //layer=mcon //count=3 \
 //x=31.94 //y=7.58 //x2=31.94 //y2=7.58
r1754 (  54 56 ) resistor r=0.446141 //w=0.311 //l=1.11 //layer=m1 \
 //thickness=0.36 //x=31.94 //y=7.585 //x2=33.05 //y2=7.585
r1755 (  52 849 ) resistor r=3.1 //w=0.17 //l=0.51 //layer=mcon //count=3 \
 //x=30.83 //y=7.58 //x2=30.83 //y2=7.58
r1756 (  52 54 ) resistor r=0.446141 //w=0.311 //l=1.11 //layer=m1 \
 //thickness=0.36 //x=30.83 //y=7.585 //x2=31.94 //y2=7.585
r1757 (  50 846 ) resistor r=3.1 //w=0.17 //l=0.51 //layer=mcon //count=3 \
 //x=29.35 //y=7.58 //x2=29.35 //y2=7.58
r1758 (  50 52 ) resistor r=0.594855 //w=0.311 //l=1.48 //layer=m1 \
 //thickness=0.36 //x=29.35 //y=7.585 //x2=30.83 //y2=7.585
r1759 (  48 390 ) resistor r=3.1 //w=0.17 //l=0.51 //layer=mcon //count=3 \
 //x=28.24 //y=7.58 //x2=28.24 //y2=7.58
r1760 (  48 50 ) resistor r=0.446141 //w=0.311 //l=1.11 //layer=m1 \
 //thickness=0.36 //x=28.24 //y=7.585 //x2=29.35 //y2=7.585
r1761 (  46 380 ) resistor r=3.1 //w=0.17 //l=0.51 //layer=mcon //count=3 \
 //x=27.13 //y=7.58 //x2=27.13 //y2=7.58
r1762 (  46 48 ) resistor r=0.446141 //w=0.311 //l=1.11 //layer=m1 \
 //thickness=0.36 //x=27.13 //y=7.585 //x2=28.24 //y2=7.585
r1763 (  44 841 ) resistor r=3.1 //w=0.17 //l=0.51 //layer=mcon //count=3 \
 //x=25.65 //y=7.58 //x2=25.65 //y2=7.58
r1764 (  44 46 ) resistor r=0.594855 //w=0.311 //l=1.48 //layer=m1 \
 //thickness=0.36 //x=25.65 //y=7.585 //x2=27.13 //y2=7.585
r1765 (  42 358 ) resistor r=3.1 //w=0.17 //l=0.51 //layer=mcon //count=3 \
 //x=24.54 //y=7.58 //x2=24.54 //y2=7.58
r1766 (  42 44 ) resistor r=0.446141 //w=0.311 //l=1.11 //layer=m1 \
 //thickness=0.36 //x=24.54 //y=7.585 //x2=25.65 //y2=7.585
r1767 (  40 348 ) resistor r=3.1 //w=0.17 //l=0.51 //layer=mcon //count=3 \
 //x=23.43 //y=7.58 //x2=23.43 //y2=7.58
r1768 (  40 42 ) resistor r=0.446141 //w=0.311 //l=1.11 //layer=m1 \
 //thickness=0.36 //x=23.43 //y=7.585 //x2=24.54 //y2=7.585
r1769 (  38 338 ) resistor r=3.1 //w=0.17 //l=0.51 //layer=mcon //count=3 \
 //x=22.32 //y=7.58 //x2=22.32 //y2=7.58
r1770 (  38 40 ) resistor r=0.446141 //w=0.311 //l=1.11 //layer=m1 \
 //thickness=0.36 //x=22.32 //y=7.585 //x2=23.43 //y2=7.585
r1771 (  36 324 ) resistor r=3.1 //w=0.17 //l=0.51 //layer=mcon //count=3 \
 //x=20.84 //y=7.58 //x2=20.84 //y2=7.58
r1772 (  36 38 ) resistor r=0.594855 //w=0.311 //l=1.48 //layer=m1 \
 //thickness=0.36 //x=20.84 //y=7.585 //x2=22.32 //y2=7.585
r1773 (  34 314 ) resistor r=3.1 //w=0.17 //l=0.51 //layer=mcon //count=3 \
 //x=19.73 //y=7.58 //x2=19.73 //y2=7.58
r1774 (  34 36 ) resistor r=0.446141 //w=0.311 //l=1.11 //layer=m1 \
 //thickness=0.36 //x=19.73 //y=7.585 //x2=20.84 //y2=7.585
r1775 (  32 300 ) resistor r=3.1 //w=0.17 //l=0.51 //layer=mcon //count=3 \
 //x=18.25 //y=7.58 //x2=18.25 //y2=7.58
r1776 (  32 34 ) resistor r=0.594855 //w=0.311 //l=1.48 //layer=m1 \
 //thickness=0.36 //x=18.25 //y=7.585 //x2=19.73 //y2=7.585
r1777 (  30 290 ) resistor r=3.1 //w=0.17 //l=0.51 //layer=mcon //count=3 \
 //x=17.14 //y=7.58 //x2=17.14 //y2=7.58
r1778 (  30 32 ) resistor r=0.446141 //w=0.311 //l=1.11 //layer=m1 \
 //thickness=0.36 //x=17.14 //y=7.585 //x2=18.25 //y2=7.585
r1779 (  28 829 ) resistor r=3.1 //w=0.17 //l=0.51 //layer=mcon //count=3 \
 //x=16.03 //y=7.58 //x2=16.03 //y2=7.58
r1780 (  28 30 ) resistor r=0.446141 //w=0.311 //l=1.11 //layer=m1 \
 //thickness=0.36 //x=16.03 //y=7.585 //x2=17.14 //y2=7.585
r1781 (  26 826 ) resistor r=3.1 //w=0.17 //l=0.51 //layer=mcon //count=3 \
 //x=14.55 //y=7.58 //x2=14.55 //y2=7.58
r1782 (  26 28 ) resistor r=0.594855 //w=0.311 //l=1.48 //layer=m1 \
 //thickness=0.36 //x=14.55 //y=7.585 //x2=16.03 //y2=7.585
r1783 (  24 252 ) resistor r=3.1 //w=0.17 //l=0.51 //layer=mcon //count=3 \
 //x=13.44 //y=7.58 //x2=13.44 //y2=7.58
r1784 (  24 26 ) resistor r=0.446141 //w=0.311 //l=1.11 //layer=m1 \
 //thickness=0.36 //x=13.44 //y=7.585 //x2=14.55 //y2=7.585
r1785 (  22 242 ) resistor r=3.1 //w=0.17 //l=0.51 //layer=mcon //count=3 \
 //x=12.33 //y=7.58 //x2=12.33 //y2=7.58
r1786 (  22 24 ) resistor r=0.446141 //w=0.311 //l=1.11 //layer=m1 \
 //thickness=0.36 //x=12.33 //y=7.585 //x2=13.44 //y2=7.585
r1787 (  20 228 ) resistor r=3.1 //w=0.17 //l=0.51 //layer=mcon //count=3 \
 //x=10.85 //y=7.58 //x2=10.85 //y2=7.58
r1788 (  20 22 ) resistor r=0.594855 //w=0.311 //l=1.48 //layer=m1 \
 //thickness=0.36 //x=10.85 //y=7.585 //x2=12.33 //y2=7.585
r1789 (  18 218 ) resistor r=3.1 //w=0.17 //l=0.51 //layer=mcon //count=3 \
 //x=9.74 //y=7.58 //x2=9.74 //y2=7.58
r1790 (  18 20 ) resistor r=0.446141 //w=0.311 //l=1.11 //layer=m1 \
 //thickness=0.36 //x=9.74 //y=7.585 //x2=10.85 //y2=7.585
r1791 (  16 204 ) resistor r=3.1 //w=0.17 //l=0.51 //layer=mcon //count=3 \
 //x=8.26 //y=7.58 //x2=8.26 //y2=7.58
r1792 (  16 18 ) resistor r=0.594855 //w=0.311 //l=1.48 //layer=m1 \
 //thickness=0.36 //x=8.26 //y=7.585 //x2=9.74 //y2=7.585
r1793 (  14 194 ) resistor r=3.1 //w=0.17 //l=0.51 //layer=mcon //count=3 \
 //x=7.15 //y=7.58 //x2=7.15 //y2=7.58
r1794 (  14 16 ) resistor r=0.446141 //w=0.311 //l=1.11 //layer=m1 \
 //thickness=0.36 //x=7.15 //y=7.585 //x2=8.26 //y2=7.585
r1795 (  12 815 ) resistor r=3.1 //w=0.17 //l=0.51 //layer=mcon //count=3 \
 //x=6.04 //y=7.58 //x2=6.04 //y2=7.58
r1796 (  12 14 ) resistor r=0.446141 //w=0.311 //l=1.11 //layer=m1 \
 //thickness=0.36 //x=6.04 //y=7.585 //x2=7.15 //y2=7.585
r1797 (  10 172 ) resistor r=3.1 //w=0.17 //l=0.51 //layer=mcon //count=3 \
 //x=4.56 //y=7.58 //x2=4.56 //y2=7.58
r1798 (  10 12 ) resistor r=0.594855 //w=0.311 //l=1.48 //layer=m1 \
 //thickness=0.36 //x=4.56 //y=7.585 //x2=6.04 //y2=7.585
r1799 (  8 162 ) resistor r=3.1 //w=0.17 //l=0.51 //layer=mcon //count=3 \
 //x=3.45 //y=7.58 //x2=3.45 //y2=7.58
r1800 (  8 10 ) resistor r=0.446141 //w=0.311 //l=1.11 //layer=m1 \
 //thickness=0.36 //x=3.45 //y=7.585 //x2=4.56 //y2=7.585
r1801 (  6 144 ) resistor r=3.1 //w=0.17 //l=0.51 //layer=mcon //count=3 \
 //x=2.34 //y=7.58 //x2=2.34 //y2=7.58
r1802 (  6 8 ) resistor r=0.446141 //w=0.311 //l=1.11 //layer=m1 \
 //thickness=0.36 //x=2.34 //y=7.585 //x2=3.45 //y2=7.585
r1803 (  3 134 ) resistor r=3.1 //w=0.17 //l=0.51 //layer=mcon //count=3 \
 //x=1.23 //y=7.58 //x2=1.23 //y2=7.58
r1804 (  3 6 ) resistor r=0.446141 //w=0.311 //l=1.11 //layer=m1 \
 //thickness=0.36 //x=1.23 //y=7.585 //x2=2.34 //y2=7.585
r1805 (  1 67 ) resistor r=0.223071 //w=0.311 //l=0.555 //layer=m1 \
 //thickness=0.36 //x=38.785 //y=7.585 //x2=39.34 //y2=7.585
r1806 (  1 64 ) resistor r=0.223071 //w=0.311 //l=0.555 //layer=m1 \
 //thickness=0.36 //x=38.785 //y=7.585 //x2=38.23 //y2=7.585
ends PM_TMRDFFQX1\%VDD

subckt PM_TMRDFFQX1\%noxref_3 ( 1 2 3 4 12 25 26 37 39 40 44 46 53 54 55 56 57 \
 58 59 63 64 65 70 72 75 76 77 78 79 80 84 86 89 90 95 96 101 110 113 115 116 )
c232 ( 116 0 ) capacitor c=0.0220291f //x=7.265 //y=5.2
c233 ( 115 0 ) capacitor c=0.0217503f //x=6.385 //y=5.2
c234 ( 113 0 ) capacitor c=0.00866655f //x=7.26 //y=1.085
c235 ( 110 0 ) capacitor c=0.0588816f //x=9.74 //y=4.88
c236 ( 101 0 ) capacitor c=0.058931f //x=3.82 //y=4.88
c237 ( 96 0 ) capacitor c=0.0273931f //x=3.82 //y=2.095
c238 ( 95 0 ) capacitor c=0.0464411f //x=3.82 //y=2.26
c239 ( 90 0 ) capacitor c=0.0318948f //x=10.075 //y=1.39
c240 ( 89 0 ) capacitor c=0.0187384f //x=10.075 //y=1.045
c241 ( 86 0 ) capacitor c=0.0141798f //x=9.92 //y=1.545
c242 ( 84 0 ) capacitor c=0.0149844f //x=9.92 //y=0.89
c243 ( 80 0 ) capacitor c=0.0816311f //x=9.545 //y=2.095
c244 ( 79 0 ) capacitor c=0.0229722f //x=9.545 //y=1.7
c245 ( 78 0 ) capacitor c=0.0234352f //x=9.545 //y=1.39
c246 ( 77 0 ) capacitor c=0.0199343f //x=9.545 //y=1.045
c247 ( 76 0 ) capacitor c=0.0432517f //x=4.34 //y=1.44
c248 ( 75 0 ) capacitor c=0.0200379f //x=4.34 //y=1.095
c249 ( 72 0 ) capacitor c=0.0158629f //x=4.185 //y=1.595
c250 ( 70 0 ) capacitor c=0.0157803f //x=4.185 //y=0.94
c251 ( 65 0 ) capacitor c=0.0218028f //x=3.81 //y=1.75
c252 ( 64 0 ) capacitor c=0.0207459f //x=3.81 //y=1.44
c253 ( 63 0 ) capacitor c=0.0194308f //x=3.81 //y=1.095
c254 ( 59 0 ) capacitor c=0.110275f //x=10.08 //y=6.2
c255 ( 58 0 ) capacitor c=0.154305f //x=9.64 //y=6.2
c256 ( 57 0 ) capacitor c=0.158794f //x=4 //y=6.2
c257 ( 56 0 ) capacitor c=0.110114f //x=3.56 //y=6.2
c258 ( 53 0 ) capacitor c=0.00211606f //x=7.41 //y=5.38
c259 ( 46 0 ) capacitor c=0.0894554f //x=9.74 //y=2.26
c260 ( 44 0 ) capacitor c=0.106205f //x=7.89 //y=3.51
c261 ( 40 0 ) capacitor c=0.00436419f //x=7.535 //y=1.835
c262 ( 39 0 ) capacitor c=0.0127039f //x=7.805 //y=1.835
c263 ( 37 0 ) capacitor c=0.0137522f //x=7.805 //y=5.38
c264 ( 26 0 ) capacitor c=0.00251635f //x=6.615 //y=5.38
c265 ( 25 0 ) capacitor c=0.0142423f //x=7.325 //y=5.38
c266 ( 12 0 ) capacitor c=0.0882402f //x=3.82 //y=2.26
c267 ( 4 0 ) capacitor c=0.00305824f //x=8.005 //y=3.51
c268 ( 3 0 ) capacitor c=0.0402189f //x=9.625 //y=3.51
c269 ( 2 0 ) capacitor c=0.0149801f //x=3.935 //y=3.51
c270 ( 1 0 ) capacitor c=0.100545f //x=7.775 //y=3.51
r271 (  108 110 ) resistor r=20.6867 //w=0.233 //l=0.1 //layer=ply \
 //thickness=0.18 //x=9.64 //y=4.88 //x2=9.74 //y2=4.88
r272 (  95 96 ) resistor r=52.7279 //w=0.214 //l=0.165 //layer=ply \
 //thickness=0.18 //x=3.82 //y=2.26 //x2=3.82 //y2=2.095
r273 (  91 110 ) resistor r=70.3348 //w=0.233 //l=0.414367 //layer=ply \
 //thickness=0.18 //x=10.08 //y=5.045 //x2=9.74 //y2=4.88
r274 (  90 112 ) resistor r=45.1352 //w=0.168 //l=0.173853 //layer=ply \
 //thickness=0.18 //x=10.075 //y=1.39 //x2=10.035 //y2=1.545
r275 (  89 111 ) resistor r=45.1352 //w=0.168 //l=0.173853 //layer=ply \
 //thickness=0.18 //x=10.075 //y=1.045 //x2=10.035 //y2=0.89
r276 (  89 90 ) resistor r=176.904 //w=0.094 //l=0.345 //layer=ply \
 //thickness=0.18 //x=10.075 //y=1.045 //x2=10.075 //y2=1.39
r277 (  87 107 ) resistor r=10.701 //w=0.21 //l=0.115 //layer=ply \
 //thickness=0.18 //x=9.7 //y=1.545 //x2=9.585 //y2=1.545
r278 (  86 112 ) resistor r=5.52526 //w=0.168 //l=0.115 //layer=ply \
 //thickness=0.18 //x=9.92 //y=1.545 //x2=10.035 //y2=1.545
r279 (  85 106 ) resistor r=5.52526 //w=0.168 //l=0.115 //layer=ply \
 //thickness=0.18 //x=9.7 //y=0.89 //x2=9.585 //y2=0.89
r280 (  84 111 ) resistor r=5.52526 //w=0.168 //l=0.115 //layer=ply \
 //thickness=0.18 //x=9.92 //y=0.89 //x2=10.035 //y2=0.89
r281 (  84 85 ) resistor r=112.809 //w=0.094 //l=0.22 //layer=ply \
 //thickness=0.18 //x=9.92 //y=0.89 //x2=9.7 //y2=0.89
r282 (  81 108 ) resistor r=13.0941 //w=0.233 //l=0.165 //layer=ply \
 //thickness=0.18 //x=9.64 //y=5.045 //x2=9.64 //y2=4.88
r283 (  80 105 ) resistor r=34.8111 //w=0.27 //l=0.264953 //layer=ply \
 //thickness=0.18 //x=9.545 //y=2.095 //x2=9.74 //y2=2.26
r284 (  79 107 ) resistor r=39.5823 //w=0.21 //l=0.173853 //layer=ply \
 //thickness=0.18 //x=9.545 //y=1.7 //x2=9.585 //y2=1.545
r285 (  79 80 ) resistor r=202.543 //w=0.094 //l=0.395 //layer=ply \
 //thickness=0.18 //x=9.545 //y=1.7 //x2=9.545 //y2=2.095
r286 (  78 107 ) resistor r=39.5823 //w=0.21 //l=0.173853 //layer=ply \
 //thickness=0.18 //x=9.545 //y=1.39 //x2=9.585 //y2=1.545
r287 (  77 106 ) resistor r=45.1352 //w=0.168 //l=0.173853 //layer=ply \
 //thickness=0.18 //x=9.545 //y=1.045 //x2=9.585 //y2=0.89
r288 (  77 78 ) resistor r=176.904 //w=0.094 //l=0.345 //layer=ply \
 //thickness=0.18 //x=9.545 //y=1.045 //x2=9.545 //y2=1.39
r289 (  76 103 ) resistor r=45.1352 //w=0.168 //l=0.173853 //layer=ply \
 //thickness=0.18 //x=4.34 //y=1.44 //x2=4.3 //y2=1.595
r290 (  75 102 ) resistor r=45.1352 //w=0.168 //l=0.173853 //layer=ply \
 //thickness=0.18 //x=4.34 //y=1.095 //x2=4.3 //y2=0.94
r291 (  75 76 ) resistor r=176.904 //w=0.094 //l=0.345 //layer=ply \
 //thickness=0.18 //x=4.34 //y=1.095 //x2=4.34 //y2=1.44
r292 (  73 99 ) resistor r=10.701 //w=0.21 //l=0.115 //layer=ply \
 //thickness=0.18 //x=3.965 //y=1.595 //x2=3.85 //y2=1.595
r293 (  72 103 ) resistor r=5.52526 //w=0.168 //l=0.115 //layer=ply \
 //thickness=0.18 //x=4.185 //y=1.595 //x2=4.3 //y2=1.595
r294 (  71 98 ) resistor r=5.52526 //w=0.168 //l=0.115 //layer=ply \
 //thickness=0.18 //x=3.965 //y=0.94 //x2=3.85 //y2=0.94
r295 (  70 102 ) resistor r=5.52526 //w=0.168 //l=0.115 //layer=ply \
 //thickness=0.18 //x=4.185 //y=0.94 //x2=4.3 //y2=0.94
r296 (  70 71 ) resistor r=112.809 //w=0.094 //l=0.22 //layer=ply \
 //thickness=0.18 //x=4.185 //y=0.94 //x2=3.965 //y2=0.94
r297 (  67 101 ) resistor r=37.236 //w=0.233 //l=0.249199 //layer=ply \
 //thickness=0.18 //x=4 //y=5.045 //x2=3.82 //y2=4.88
r298 (  65 99 ) resistor r=39.5823 //w=0.21 //l=0.173853 //layer=ply \
 //thickness=0.18 //x=3.81 //y=1.75 //x2=3.85 //y2=1.595
r299 (  65 96 ) resistor r=176.904 //w=0.094 //l=0.345 //layer=ply \
 //thickness=0.18 //x=3.81 //y=1.75 //x2=3.81 //y2=2.095
r300 (  64 99 ) resistor r=39.5823 //w=0.21 //l=0.173853 //layer=ply \
 //thickness=0.18 //x=3.81 //y=1.44 //x2=3.85 //y2=1.595
r301 (  63 98 ) resistor r=45.1352 //w=0.168 //l=0.173853 //layer=ply \
 //thickness=0.18 //x=3.81 //y=1.095 //x2=3.85 //y2=0.94
r302 (  63 64 ) resistor r=176.904 //w=0.094 //l=0.345 //layer=ply \
 //thickness=0.18 //x=3.81 //y=1.095 //x2=3.81 //y2=1.44
r303 (  60 101 ) resistor r=53.7854 //w=0.233 //l=0.332415 //layer=ply \
 //thickness=0.18 //x=3.56 //y=5.045 //x2=3.82 //y2=4.88
r304 (  59 91 ) resistor r=592.245 //w=0.094 //l=1.155 //layer=ply \
 //thickness=0.18 //x=10.08 //y=6.2 //x2=10.08 //y2=5.045
r305 (  58 81 ) resistor r=592.245 //w=0.094 //l=1.155 //layer=ply \
 //thickness=0.18 //x=9.64 //y=6.2 //x2=9.64 //y2=5.045
r306 (  57 67 ) resistor r=592.245 //w=0.094 //l=1.155 //layer=ply \
 //thickness=0.18 //x=4 //y=6.2 //x2=4 //y2=5.045
r307 (  56 60 ) resistor r=592.245 //w=0.094 //l=1.155 //layer=ply \
 //thickness=0.18 //x=3.56 //y=6.2 //x2=3.56 //y2=5.045
r308 (  55 86 ) resistor r=56.4043 //w=0.094 //l=0.11 //layer=ply \
 //thickness=0.18 //x=9.81 //y=1.545 //x2=9.92 //y2=1.545
r309 (  55 87 ) resistor r=56.4043 //w=0.094 //l=0.11 //layer=ply \
 //thickness=0.18 //x=9.81 //y=1.545 //x2=9.7 //y2=1.545
r310 (  54 72 ) resistor r=56.4043 //w=0.094 //l=0.11 //layer=ply \
 //thickness=0.18 //x=4.075 //y=1.595 //x2=4.185 //y2=1.595
r311 (  54 73 ) resistor r=56.4043 //w=0.094 //l=0.11 //layer=ply \
 //thickness=0.18 //x=4.075 //y=1.595 //x2=3.965 //y2=1.595
r312 (  51 110 ) resistor r=152 //w=0.17 //l=0.17 //layer=licon //count=1 \
 //x=9.74 //y=4.88 //x2=9.74 //y2=4.88
r313 (  49 51 ) resistor r=93.7754 //w=0.187 //l=1.37 //layer=li \
 //thickness=0.1 //x=9.74 //y=3.51 //x2=9.74 //y2=4.88
r314 (  46 105 ) resistor r=152 //w=0.17 //l=0.17 //layer=licon //count=1 \
 //x=9.74 //y=2.26 //x2=9.74 //y2=2.26
r315 (  46 49 ) resistor r=85.5615 //w=0.187 //l=1.25 //layer=li \
 //thickness=0.1 //x=9.74 //y=2.26 //x2=9.74 //y2=3.51
r316 (  42 44 ) resistor r=122.182 //w=0.187 //l=1.785 //layer=li \
 //thickness=0.1 //x=7.89 //y=5.295 //x2=7.89 //y2=3.51
r317 (  41 44 ) resistor r=108.834 //w=0.187 //l=1.59 //layer=li \
 //thickness=0.1 //x=7.89 //y=1.92 //x2=7.89 //y2=3.51
r318 (  39 41 ) resistor r=7.15173 //w=0.17 //l=0.120208 //layer=li \
 //thickness=0.1 //x=7.805 //y=1.835 //x2=7.89 //y2=1.92
r319 (  39 40 ) resistor r=18.4813 //w=0.187 //l=0.27 //layer=li \
 //thickness=0.1 //x=7.805 //y=1.835 //x2=7.535 //y2=1.835
r320 (  38 53 ) resistor r=5.4201 //w=0.17 //l=0.085 //layer=li \
 //thickness=0.1 //x=7.495 //y=5.38 //x2=7.41 //y2=5.38
r321 (  37 42 ) resistor r=7.15173 //w=0.17 //l=0.120208 //layer=li \
 //thickness=0.1 //x=7.805 //y=5.38 //x2=7.89 //y2=5.295
r322 (  37 38 ) resistor r=21.2193 //w=0.187 //l=0.31 //layer=li \
 //thickness=0.1 //x=7.805 //y=5.38 //x2=7.495 //y2=5.38
r323 (  33 40 ) resistor r=7.15173 //w=0.17 //l=0.120208 //layer=li \
 //thickness=0.1 //x=7.45 //y=1.75 //x2=7.535 //y2=1.835
r324 (  33 113 ) resistor r=39.016 //w=0.187 //l=0.57 //layer=li \
 //thickness=0.1 //x=7.45 //y=1.75 //x2=7.45 //y2=1.18
r325 (  27 53 ) resistor r=1.40859 //w=0.34 //l=0.085 //layer=li \
 //thickness=0.1 //x=7.41 //y=5.465 //x2=7.41 //y2=5.38
r326 (  27 116 ) resistor r=30.1176 //w=0.187 //l=0.44 //layer=li \
 //thickness=0.1 //x=7.41 //y=5.465 //x2=7.41 //y2=5.905
r327 (  25 53 ) resistor r=5.4201 //w=0.17 //l=0.085 //layer=li \
 //thickness=0.1 //x=7.325 //y=5.38 //x2=7.41 //y2=5.38
r328 (  25 26 ) resistor r=48.5989 //w=0.187 //l=0.71 //layer=li \
 //thickness=0.1 //x=7.325 //y=5.38 //x2=6.615 //y2=5.38
r329 (  19 26 ) resistor r=7.15173 //w=0.17 //l=0.120208 //layer=li \
 //thickness=0.1 //x=6.53 //y=5.465 //x2=6.615 //y2=5.38
r330 (  19 115 ) resistor r=30.1176 //w=0.187 //l=0.44 //layer=li \
 //thickness=0.1 //x=6.53 //y=5.465 //x2=6.53 //y2=5.905
r331 (  17 101 ) resistor r=152 //w=0.17 //l=0.17 //layer=licon //count=1 \
 //x=3.82 //y=4.88 //x2=3.82 //y2=4.88
r332 (  15 17 ) resistor r=93.7754 //w=0.187 //l=1.37 //layer=li \
 //thickness=0.1 //x=3.82 //y=3.51 //x2=3.82 //y2=4.88
r333 (  12 95 ) resistor r=152 //w=0.17 //l=0.17 //layer=licon //count=1 \
 //x=3.82 //y=2.26 //x2=3.82 //y2=2.26
r334 (  12 15 ) resistor r=85.5615 //w=0.187 //l=1.25 //layer=li \
 //thickness=0.1 //x=3.82 //y=2.26 //x2=3.82 //y2=3.51
r335 (  10 49 ) resistor r=9.3 //w=0.17 //l=0.17 //layer=mcon //count=1 \
 //x=9.74 //y=3.51 //x2=9.74 //y2=3.51
r336 (  8 44 ) resistor r=9.3 //w=0.17 //l=0.17 //layer=mcon //count=1 \
 //x=7.89 //y=3.51 //x2=7.89 //y2=3.51
r337 (  6 15 ) resistor r=9.3 //w=0.17 //l=0.17 //layer=mcon //count=1 \
 //x=3.82 //y=3.51 //x2=3.82 //y2=3.51
r338 (  4 8 ) resistor r=0.0880901 //w=0.191 //l=0.115 //layer=m1 \
 //thickness=0.36 //x=8.005 //y=3.51 //x2=7.89 //y2=3.51
r339 (  3 10 ) resistor r=0.0717383 //w=0.224 //l=0.115 //layer=m1 \
 //thickness=0.36 //x=9.625 //y=3.51 //x2=9.74 //y2=3.51
r340 (  3 4 ) resistor r=1.5458 //w=0.131 //l=1.62 //layer=m1 //thickness=0.36 \
 //x=9.625 //y=3.51 //x2=8.005 //y2=3.51
r341 (  2 6 ) resistor r=0.0717383 //w=0.224 //l=0.115 //layer=m1 \
 //thickness=0.36 //x=3.935 //y=3.51 //x2=3.82 //y2=3.51
r342 (  1 8 ) resistor r=0.0880901 //w=0.191 //l=0.115 //layer=m1 \
 //thickness=0.36 //x=7.775 //y=3.51 //x2=7.89 //y2=3.51
r343 (  1 2 ) resistor r=3.66412 //w=0.131 //l=3.84 //layer=m1 \
 //thickness=0.36 //x=7.775 //y=3.51 //x2=3.935 //y2=3.51
ends PM_TMRDFFQX1\%noxref_3

subckt PM_TMRDFFQX1\%noxref_4 ( 1 2 13 14 25 27 28 32 34 41 42 43 44 45 46 47 \
 48 52 54 57 58 68 71 73 74 )
c150 ( 74 0 ) capacitor c=0.0220291f //x=10.595 //y=5.2
c151 ( 73 0 ) capacitor c=0.0217503f //x=9.715 //y=5.2
c152 ( 71 0 ) capacitor c=0.00866655f //x=10.59 //y=1.085
c153 ( 68 0 ) capacitor c=0.0588816f //x=13.07 //y=4.88
c154 ( 58 0 ) capacitor c=0.0318948f //x=13.405 //y=1.39
c155 ( 57 0 ) capacitor c=0.0187384f //x=13.405 //y=1.045
c156 ( 54 0 ) capacitor c=0.0141798f //x=13.25 //y=1.545
c157 ( 52 0 ) capacitor c=0.0149844f //x=13.25 //y=0.89
c158 ( 48 0 ) capacitor c=0.0816311f //x=12.875 //y=2.095
c159 ( 47 0 ) capacitor c=0.0229722f //x=12.875 //y=1.7
c160 ( 46 0 ) capacitor c=0.0234352f //x=12.875 //y=1.39
c161 ( 45 0 ) capacitor c=0.0199343f //x=12.875 //y=1.045
c162 ( 44 0 ) capacitor c=0.110275f //x=13.41 //y=6.2
c163 ( 43 0 ) capacitor c=0.154305f //x=12.97 //y=6.2
c164 ( 41 0 ) capacitor c=0.00211606f //x=10.74 //y=5.38
c165 ( 34 0 ) capacitor c=0.0889544f //x=13.07 //y=2.26
c166 ( 32 0 ) capacitor c=0.106752f //x=11.22 //y=3.51
c167 ( 28 0 ) capacitor c=0.00436419f //x=10.865 //y=1.835
c168 ( 27 0 ) capacitor c=0.0127039f //x=11.135 //y=1.835
c169 ( 25 0 ) capacitor c=0.0137522f //x=11.135 //y=5.38
c170 ( 14 0 ) capacitor c=0.00251459f //x=9.945 //y=5.38
c171 ( 13 0 ) capacitor c=0.0143649f //x=10.655 //y=5.38
c172 ( 2 0 ) capacitor c=0.00703116f //x=11.335 //y=3.51
c173 ( 1 0 ) capacitor c=0.0455801f //x=12.955 //y=3.51
r174 (  66 68 ) resistor r=20.6867 //w=0.233 //l=0.1 //layer=ply \
 //thickness=0.18 //x=12.97 //y=4.88 //x2=13.07 //y2=4.88
r175 (  59 68 ) resistor r=70.3348 //w=0.233 //l=0.414367 //layer=ply \
 //thickness=0.18 //x=13.41 //y=5.045 //x2=13.07 //y2=4.88
r176 (  58 70 ) resistor r=45.1352 //w=0.168 //l=0.173853 //layer=ply \
 //thickness=0.18 //x=13.405 //y=1.39 //x2=13.365 //y2=1.545
r177 (  57 69 ) resistor r=45.1352 //w=0.168 //l=0.173853 //layer=ply \
 //thickness=0.18 //x=13.405 //y=1.045 //x2=13.365 //y2=0.89
r178 (  57 58 ) resistor r=176.904 //w=0.094 //l=0.345 //layer=ply \
 //thickness=0.18 //x=13.405 //y=1.045 //x2=13.405 //y2=1.39
r179 (  55 65 ) resistor r=10.701 //w=0.21 //l=0.115 //layer=ply \
 //thickness=0.18 //x=13.03 //y=1.545 //x2=12.915 //y2=1.545
r180 (  54 70 ) resistor r=5.52526 //w=0.168 //l=0.115 //layer=ply \
 //thickness=0.18 //x=13.25 //y=1.545 //x2=13.365 //y2=1.545
r181 (  53 64 ) resistor r=5.52526 //w=0.168 //l=0.115 //layer=ply \
 //thickness=0.18 //x=13.03 //y=0.89 //x2=12.915 //y2=0.89
r182 (  52 69 ) resistor r=5.52526 //w=0.168 //l=0.115 //layer=ply \
 //thickness=0.18 //x=13.25 //y=0.89 //x2=13.365 //y2=0.89
r183 (  52 53 ) resistor r=112.809 //w=0.094 //l=0.22 //layer=ply \
 //thickness=0.18 //x=13.25 //y=0.89 //x2=13.03 //y2=0.89
r184 (  49 66 ) resistor r=13.0941 //w=0.233 //l=0.165 //layer=ply \
 //thickness=0.18 //x=12.97 //y=5.045 //x2=12.97 //y2=4.88
r185 (  48 63 ) resistor r=34.8111 //w=0.27 //l=0.264953 //layer=ply \
 //thickness=0.18 //x=12.875 //y=2.095 //x2=13.07 //y2=2.26
r186 (  47 65 ) resistor r=39.5823 //w=0.21 //l=0.173853 //layer=ply \
 //thickness=0.18 //x=12.875 //y=1.7 //x2=12.915 //y2=1.545
r187 (  47 48 ) resistor r=202.543 //w=0.094 //l=0.395 //layer=ply \
 //thickness=0.18 //x=12.875 //y=1.7 //x2=12.875 //y2=2.095
r188 (  46 65 ) resistor r=39.5823 //w=0.21 //l=0.173853 //layer=ply \
 //thickness=0.18 //x=12.875 //y=1.39 //x2=12.915 //y2=1.545
r189 (  45 64 ) resistor r=45.1352 //w=0.168 //l=0.173853 //layer=ply \
 //thickness=0.18 //x=12.875 //y=1.045 //x2=12.915 //y2=0.89
r190 (  45 46 ) resistor r=176.904 //w=0.094 //l=0.345 //layer=ply \
 //thickness=0.18 //x=12.875 //y=1.045 //x2=12.875 //y2=1.39
r191 (  44 59 ) resistor r=592.245 //w=0.094 //l=1.155 //layer=ply \
 //thickness=0.18 //x=13.41 //y=6.2 //x2=13.41 //y2=5.045
r192 (  43 49 ) resistor r=592.245 //w=0.094 //l=1.155 //layer=ply \
 //thickness=0.18 //x=12.97 //y=6.2 //x2=12.97 //y2=5.045
r193 (  42 54 ) resistor r=56.4043 //w=0.094 //l=0.11 //layer=ply \
 //thickness=0.18 //x=13.14 //y=1.545 //x2=13.25 //y2=1.545
r194 (  42 55 ) resistor r=56.4043 //w=0.094 //l=0.11 //layer=ply \
 //thickness=0.18 //x=13.14 //y=1.545 //x2=13.03 //y2=1.545
r195 (  39 68 ) resistor r=152 //w=0.17 //l=0.17 //layer=licon //count=1 \
 //x=13.07 //y=4.88 //x2=13.07 //y2=4.88
r196 (  37 39 ) resistor r=93.7754 //w=0.187 //l=1.37 //layer=li \
 //thickness=0.1 //x=13.07 //y=3.51 //x2=13.07 //y2=4.88
r197 (  34 63 ) resistor r=152 //w=0.17 //l=0.17 //layer=licon //count=1 \
 //x=13.07 //y=2.26 //x2=13.07 //y2=2.26
r198 (  34 37 ) resistor r=85.5615 //w=0.187 //l=1.25 //layer=li \
 //thickness=0.1 //x=13.07 //y=2.26 //x2=13.07 //y2=3.51
r199 (  30 32 ) resistor r=122.182 //w=0.187 //l=1.785 //layer=li \
 //thickness=0.1 //x=11.22 //y=5.295 //x2=11.22 //y2=3.51
r200 (  29 32 ) resistor r=108.834 //w=0.187 //l=1.59 //layer=li \
 //thickness=0.1 //x=11.22 //y=1.92 //x2=11.22 //y2=3.51
r201 (  27 29 ) resistor r=7.15173 //w=0.17 //l=0.120208 //layer=li \
 //thickness=0.1 //x=11.135 //y=1.835 //x2=11.22 //y2=1.92
r202 (  27 28 ) resistor r=18.4813 //w=0.187 //l=0.27 //layer=li \
 //thickness=0.1 //x=11.135 //y=1.835 //x2=10.865 //y2=1.835
r203 (  26 41 ) resistor r=5.4201 //w=0.17 //l=0.085 //layer=li \
 //thickness=0.1 //x=10.825 //y=5.38 //x2=10.74 //y2=5.38
r204 (  25 30 ) resistor r=7.15173 //w=0.17 //l=0.120208 //layer=li \
 //thickness=0.1 //x=11.135 //y=5.38 //x2=11.22 //y2=5.295
r205 (  25 26 ) resistor r=21.2193 //w=0.187 //l=0.31 //layer=li \
 //thickness=0.1 //x=11.135 //y=5.38 //x2=10.825 //y2=5.38
r206 (  21 28 ) resistor r=7.15173 //w=0.17 //l=0.120208 //layer=li \
 //thickness=0.1 //x=10.78 //y=1.75 //x2=10.865 //y2=1.835
r207 (  21 71 ) resistor r=39.016 //w=0.187 //l=0.57 //layer=li \
 //thickness=0.1 //x=10.78 //y=1.75 //x2=10.78 //y2=1.18
r208 (  15 41 ) resistor r=1.40859 //w=0.34 //l=0.085 //layer=li \
 //thickness=0.1 //x=10.74 //y=5.465 //x2=10.74 //y2=5.38
r209 (  15 74 ) resistor r=30.1176 //w=0.187 //l=0.44 //layer=li \
 //thickness=0.1 //x=10.74 //y=5.465 //x2=10.74 //y2=5.905
r210 (  13 41 ) resistor r=5.4201 //w=0.17 //l=0.085 //layer=li \
 //thickness=0.1 //x=10.655 //y=5.38 //x2=10.74 //y2=5.38
r211 (  13 14 ) resistor r=48.5989 //w=0.187 //l=0.71 //layer=li \
 //thickness=0.1 //x=10.655 //y=5.38 //x2=9.945 //y2=5.38
r212 (  7 14 ) resistor r=7.15173 //w=0.17 //l=0.120208 //layer=li \
 //thickness=0.1 //x=9.86 //y=5.465 //x2=9.945 //y2=5.38
r213 (  7 73 ) resistor r=30.1176 //w=0.187 //l=0.44 //layer=li \
 //thickness=0.1 //x=9.86 //y=5.465 //x2=9.86 //y2=5.905
r214 (  6 37 ) resistor r=9.3 //w=0.17 //l=0.17 //layer=mcon //count=1 \
 //x=13.07 //y=3.51 //x2=13.07 //y2=3.51
r215 (  4 32 ) resistor r=9.3 //w=0.17 //l=0.17 //layer=mcon //count=1 \
 //x=11.22 //y=3.51 //x2=11.22 //y2=3.51
r216 (  2 4 ) resistor r=0.0717383 //w=0.224 //l=0.115 //layer=m1 \
 //thickness=0.36 //x=11.335 //y=3.51 //x2=11.22 //y2=3.51
r217 (  1 6 ) resistor r=0.0717383 //w=0.224 //l=0.115 //layer=m1 \
 //thickness=0.36 //x=12.955 //y=3.51 //x2=13.07 //y2=3.51
r218 (  1 2 ) resistor r=1.5458 //w=0.131 //l=1.62 //layer=m1 //thickness=0.36 \
 //x=12.955 //y=3.51 //x2=11.335 //y2=3.51
ends PM_TMRDFFQX1\%noxref_4

subckt PM_TMRDFFQX1\%noxref_5 ( 1 2 3 4 17 18 25 33 39 40 44 46 54 61 62 63 64 \
 65 66 67 68 69 70 71 72 76 78 81 82 86 87 88 89 93 95 98 99 109 118 121 123 \
 124 125 )
c248 ( 125 0 ) capacitor c=0.023087f //x=3.635 //y=5.2
c249 ( 124 0 ) capacitor c=0.023519f //x=2.755 //y=5.2
c250 ( 123 0 ) capacitor c=0.0224735f //x=1.875 //y=5.2
c251 ( 121 0 ) capacitor c=0.00872971f //x=3.885 //y=1.095
c252 ( 118 0 ) capacitor c=0.0588845f //x=16.4 //y=4.88
c253 ( 109 0 ) capacitor c=0.0588816f //x=6.41 //y=4.88
c254 ( 99 0 ) capacitor c=0.0318948f //x=16.735 //y=1.39
c255 ( 98 0 ) capacitor c=0.0187384f //x=16.735 //y=1.045
c256 ( 95 0 ) capacitor c=0.0141798f //x=16.58 //y=1.545
c257 ( 93 0 ) capacitor c=0.0149844f //x=16.58 //y=0.89
c258 ( 89 0 ) capacitor c=0.0816311f //x=16.205 //y=2.095
c259 ( 88 0 ) capacitor c=0.0229722f //x=16.205 //y=1.7
c260 ( 87 0 ) capacitor c=0.0234352f //x=16.205 //y=1.39
c261 ( 86 0 ) capacitor c=0.0199343f //x=16.205 //y=1.045
c262 ( 82 0 ) capacitor c=0.0318948f //x=6.745 //y=1.39
c263 ( 81 0 ) capacitor c=0.0187384f //x=6.745 //y=1.045
c264 ( 78 0 ) capacitor c=0.0141798f //x=6.59 //y=1.545
c265 ( 76 0 ) capacitor c=0.0149844f //x=6.59 //y=0.89
c266 ( 72 0 ) capacitor c=0.0860049f //x=6.215 //y=2.095
c267 ( 71 0 ) capacitor c=0.0229722f //x=6.215 //y=1.7
c268 ( 70 0 ) capacitor c=0.0234352f //x=6.215 //y=1.39
c269 ( 69 0 ) capacitor c=0.0199343f //x=6.215 //y=1.045
c270 ( 68 0 ) capacitor c=0.110275f //x=16.74 //y=6.2
c271 ( 67 0 ) capacitor c=0.154305f //x=16.3 //y=6.2
c272 ( 66 0 ) capacitor c=0.110275f //x=6.75 //y=6.2
c273 ( 65 0 ) capacitor c=0.154305f //x=6.31 //y=6.2
c274 ( 62 0 ) capacitor c=0.00106608f //x=3.78 //y=5.335
c275 ( 61 0 ) capacitor c=0.00207162f //x=2.9 //y=5.335
c276 ( 54 0 ) capacitor c=0.0918023f //x=16.4 //y=2.26
c277 ( 46 0 ) capacitor c=0.0905231f //x=6.41 //y=2.26
c278 ( 44 0 ) capacitor c=0.109488f //x=4.56 //y=3.88
c279 ( 40 0 ) capacitor c=0.00493499f //x=4.16 //y=1.845
c280 ( 39 0 ) capacitor c=0.0154052f //x=4.475 //y=1.845
c281 ( 33 0 ) capacitor c=0.0284988f //x=4.475 //y=5.335
c282 ( 25 0 ) capacitor c=0.0176454f //x=3.695 //y=5.335
c283 ( 18 0 ) capacitor c=0.00351598f //x=2.105 //y=5.335
c284 ( 17 0 ) capacitor c=0.0154196f //x=2.815 //y=5.335
c285 ( 4 0 ) capacitor c=0.00424317f //x=6.525 //y=3.88
c286 ( 3 0 ) capacitor c=0.173045f //x=16.285 //y=3.88
c287 ( 2 0 ) capacitor c=0.0125346f //x=4.675 //y=3.88
c288 ( 1 0 ) capacitor c=0.0285004f //x=6.295 //y=3.88
r289 (  116 118 ) resistor r=20.6867 //w=0.233 //l=0.1 //layer=ply \
 //thickness=0.18 //x=16.3 //y=4.88 //x2=16.4 //y2=4.88
r290 (  107 109 ) resistor r=20.6867 //w=0.233 //l=0.1 //layer=ply \
 //thickness=0.18 //x=6.31 //y=4.88 //x2=6.41 //y2=4.88
r291 (  100 118 ) resistor r=70.3348 //w=0.233 //l=0.414367 //layer=ply \
 //thickness=0.18 //x=16.74 //y=5.045 //x2=16.4 //y2=4.88
r292 (  99 120 ) resistor r=45.1352 //w=0.168 //l=0.173853 //layer=ply \
 //thickness=0.18 //x=16.735 //y=1.39 //x2=16.695 //y2=1.545
r293 (  98 119 ) resistor r=45.1352 //w=0.168 //l=0.173853 //layer=ply \
 //thickness=0.18 //x=16.735 //y=1.045 //x2=16.695 //y2=0.89
r294 (  98 99 ) resistor r=176.904 //w=0.094 //l=0.345 //layer=ply \
 //thickness=0.18 //x=16.735 //y=1.045 //x2=16.735 //y2=1.39
r295 (  96 115 ) resistor r=10.701 //w=0.21 //l=0.115 //layer=ply \
 //thickness=0.18 //x=16.36 //y=1.545 //x2=16.245 //y2=1.545
r296 (  95 120 ) resistor r=5.52526 //w=0.168 //l=0.115 //layer=ply \
 //thickness=0.18 //x=16.58 //y=1.545 //x2=16.695 //y2=1.545
r297 (  94 114 ) resistor r=5.52526 //w=0.168 //l=0.115 //layer=ply \
 //thickness=0.18 //x=16.36 //y=0.89 //x2=16.245 //y2=0.89
r298 (  93 119 ) resistor r=5.52526 //w=0.168 //l=0.115 //layer=ply \
 //thickness=0.18 //x=16.58 //y=0.89 //x2=16.695 //y2=0.89
r299 (  93 94 ) resistor r=112.809 //w=0.094 //l=0.22 //layer=ply \
 //thickness=0.18 //x=16.58 //y=0.89 //x2=16.36 //y2=0.89
r300 (  90 116 ) resistor r=13.0941 //w=0.233 //l=0.165 //layer=ply \
 //thickness=0.18 //x=16.3 //y=5.045 //x2=16.3 //y2=4.88
r301 (  89 113 ) resistor r=34.8111 //w=0.27 //l=0.264953 //layer=ply \
 //thickness=0.18 //x=16.205 //y=2.095 //x2=16.4 //y2=2.26
r302 (  88 115 ) resistor r=39.5823 //w=0.21 //l=0.173853 //layer=ply \
 //thickness=0.18 //x=16.205 //y=1.7 //x2=16.245 //y2=1.545
r303 (  88 89 ) resistor r=202.543 //w=0.094 //l=0.395 //layer=ply \
 //thickness=0.18 //x=16.205 //y=1.7 //x2=16.205 //y2=2.095
r304 (  87 115 ) resistor r=39.5823 //w=0.21 //l=0.173853 //layer=ply \
 //thickness=0.18 //x=16.205 //y=1.39 //x2=16.245 //y2=1.545
r305 (  86 114 ) resistor r=45.1352 //w=0.168 //l=0.173853 //layer=ply \
 //thickness=0.18 //x=16.205 //y=1.045 //x2=16.245 //y2=0.89
r306 (  86 87 ) resistor r=176.904 //w=0.094 //l=0.345 //layer=ply \
 //thickness=0.18 //x=16.205 //y=1.045 //x2=16.205 //y2=1.39
r307 (  83 109 ) resistor r=70.3348 //w=0.233 //l=0.414367 //layer=ply \
 //thickness=0.18 //x=6.75 //y=5.045 //x2=6.41 //y2=4.88
r308 (  82 111 ) resistor r=45.1352 //w=0.168 //l=0.173853 //layer=ply \
 //thickness=0.18 //x=6.745 //y=1.39 //x2=6.705 //y2=1.545
r309 (  81 110 ) resistor r=45.1352 //w=0.168 //l=0.173853 //layer=ply \
 //thickness=0.18 //x=6.745 //y=1.045 //x2=6.705 //y2=0.89
r310 (  81 82 ) resistor r=176.904 //w=0.094 //l=0.345 //layer=ply \
 //thickness=0.18 //x=6.745 //y=1.045 //x2=6.745 //y2=1.39
r311 (  79 106 ) resistor r=10.701 //w=0.21 //l=0.115 //layer=ply \
 //thickness=0.18 //x=6.37 //y=1.545 //x2=6.255 //y2=1.545
r312 (  78 111 ) resistor r=5.52526 //w=0.168 //l=0.115 //layer=ply \
 //thickness=0.18 //x=6.59 //y=1.545 //x2=6.705 //y2=1.545
r313 (  77 105 ) resistor r=5.52526 //w=0.168 //l=0.115 //layer=ply \
 //thickness=0.18 //x=6.37 //y=0.89 //x2=6.255 //y2=0.89
r314 (  76 110 ) resistor r=5.52526 //w=0.168 //l=0.115 //layer=ply \
 //thickness=0.18 //x=6.59 //y=0.89 //x2=6.705 //y2=0.89
r315 (  76 77 ) resistor r=112.809 //w=0.094 //l=0.22 //layer=ply \
 //thickness=0.18 //x=6.59 //y=0.89 //x2=6.37 //y2=0.89
r316 (  73 107 ) resistor r=13.0941 //w=0.233 //l=0.165 //layer=ply \
 //thickness=0.18 //x=6.31 //y=5.045 //x2=6.31 //y2=4.88
r317 (  72 104 ) resistor r=34.8111 //w=0.27 //l=0.264953 //layer=ply \
 //thickness=0.18 //x=6.215 //y=2.095 //x2=6.41 //y2=2.26
r318 (  71 106 ) resistor r=39.5823 //w=0.21 //l=0.173853 //layer=ply \
 //thickness=0.18 //x=6.215 //y=1.7 //x2=6.255 //y2=1.545
r319 (  71 72 ) resistor r=202.543 //w=0.094 //l=0.395 //layer=ply \
 //thickness=0.18 //x=6.215 //y=1.7 //x2=6.215 //y2=2.095
r320 (  70 106 ) resistor r=39.5823 //w=0.21 //l=0.173853 //layer=ply \
 //thickness=0.18 //x=6.215 //y=1.39 //x2=6.255 //y2=1.545
r321 (  69 105 ) resistor r=45.1352 //w=0.168 //l=0.173853 //layer=ply \
 //thickness=0.18 //x=6.215 //y=1.045 //x2=6.255 //y2=0.89
r322 (  69 70 ) resistor r=176.904 //w=0.094 //l=0.345 //layer=ply \
 //thickness=0.18 //x=6.215 //y=1.045 //x2=6.215 //y2=1.39
r323 (  68 100 ) resistor r=592.245 //w=0.094 //l=1.155 //layer=ply \
 //thickness=0.18 //x=16.74 //y=6.2 //x2=16.74 //y2=5.045
r324 (  67 90 ) resistor r=592.245 //w=0.094 //l=1.155 //layer=ply \
 //thickness=0.18 //x=16.3 //y=6.2 //x2=16.3 //y2=5.045
r325 (  66 83 ) resistor r=592.245 //w=0.094 //l=1.155 //layer=ply \
 //thickness=0.18 //x=6.75 //y=6.2 //x2=6.75 //y2=5.045
r326 (  65 73 ) resistor r=592.245 //w=0.094 //l=1.155 //layer=ply \
 //thickness=0.18 //x=6.31 //y=6.2 //x2=6.31 //y2=5.045
r327 (  64 95 ) resistor r=56.4043 //w=0.094 //l=0.11 //layer=ply \
 //thickness=0.18 //x=16.47 //y=1.545 //x2=16.58 //y2=1.545
r328 (  64 96 ) resistor r=56.4043 //w=0.094 //l=0.11 //layer=ply \
 //thickness=0.18 //x=16.47 //y=1.545 //x2=16.36 //y2=1.545
r329 (  63 78 ) resistor r=56.4043 //w=0.094 //l=0.11 //layer=ply \
 //thickness=0.18 //x=6.48 //y=1.545 //x2=6.59 //y2=1.545
r330 (  63 79 ) resistor r=56.4043 //w=0.094 //l=0.11 //layer=ply \
 //thickness=0.18 //x=6.48 //y=1.545 //x2=6.37 //y2=1.545
r331 (  59 118 ) resistor r=152 //w=0.17 //l=0.17 //layer=licon //count=1 \
 //x=16.4 //y=4.88 //x2=16.4 //y2=4.88
r332 (  57 59 ) resistor r=68.4492 //w=0.187 //l=1 //layer=li //thickness=0.1 \
 //x=16.4 //y=3.88 //x2=16.4 //y2=4.88
r333 (  54 113 ) resistor r=152 //w=0.17 //l=0.17 //layer=licon //count=1 \
 //x=16.4 //y=2.26 //x2=16.4 //y2=2.26
r334 (  54 57 ) resistor r=110.888 //w=0.187 //l=1.62 //layer=li \
 //thickness=0.1 //x=16.4 //y=2.26 //x2=16.4 //y2=3.88
r335 (  51 109 ) resistor r=152 //w=0.17 //l=0.17 //layer=licon //count=1 \
 //x=6.41 //y=4.88 //x2=6.41 //y2=4.88
r336 (  49 51 ) resistor r=68.4492 //w=0.187 //l=1 //layer=li //thickness=0.1 \
 //x=6.41 //y=3.88 //x2=6.41 //y2=4.88
r337 (  46 104 ) resistor r=152 //w=0.17 //l=0.17 //layer=licon //count=1 \
 //x=6.41 //y=2.26 //x2=6.41 //y2=2.26
r338 (  46 49 ) resistor r=110.888 //w=0.187 //l=1.62 //layer=li \
 //thickness=0.1 //x=6.41 //y=2.26 //x2=6.41 //y2=3.88
r339 (  42 44 ) resistor r=93.7754 //w=0.187 //l=1.37 //layer=li \
 //thickness=0.1 //x=4.56 //y=5.25 //x2=4.56 //y2=3.88
r340 (  41 44 ) resistor r=133.476 //w=0.187 //l=1.95 //layer=li \
 //thickness=0.1 //x=4.56 //y=1.93 //x2=4.56 //y2=3.88
r341 (  39 41 ) resistor r=7.15173 //w=0.17 //l=0.120208 //layer=li \
 //thickness=0.1 //x=4.475 //y=1.845 //x2=4.56 //y2=1.93
r342 (  39 40 ) resistor r=21.5615 //w=0.187 //l=0.315 //layer=li \
 //thickness=0.1 //x=4.475 //y=1.845 //x2=4.16 //y2=1.845
r343 (  35 40 ) resistor r=7.15173 //w=0.17 //l=0.120208 //layer=li \
 //thickness=0.1 //x=4.075 //y=1.76 //x2=4.16 //y2=1.845
r344 (  35 121 ) resistor r=39.016 //w=0.187 //l=0.57 //layer=li \
 //thickness=0.1 //x=4.075 //y=1.76 //x2=4.075 //y2=1.19
r345 (  34 62 ) resistor r=5.4201 //w=0.17 //l=0.085 //layer=li \
 //thickness=0.1 //x=3.865 //y=5.335 //x2=3.78 //y2=5.335
r346 (  33 42 ) resistor r=7.15173 //w=0.17 //l=0.120208 //layer=li \
 //thickness=0.1 //x=4.475 //y=5.335 //x2=4.56 //y2=5.25
r347 (  33 34 ) resistor r=41.754 //w=0.187 //l=0.61 //layer=li \
 //thickness=0.1 //x=4.475 //y=5.335 //x2=3.865 //y2=5.335
r348 (  27 62 ) resistor r=1.40859 //w=0.34 //l=0.085 //layer=li \
 //thickness=0.1 //x=3.78 //y=5.42 //x2=3.78 //y2=5.335
r349 (  27 125 ) resistor r=33.1979 //w=0.187 //l=0.485 //layer=li \
 //thickness=0.1 //x=3.78 //y=5.42 //x2=3.78 //y2=5.905
r350 (  26 61 ) resistor r=5.4201 //w=0.17 //l=0.085 //layer=li \
 //thickness=0.1 //x=2.985 //y=5.335 //x2=2.9 //y2=5.335
r351 (  25 62 ) resistor r=5.4201 //w=0.17 //l=0.085 //layer=li \
 //thickness=0.1 //x=3.695 //y=5.335 //x2=3.78 //y2=5.335
r352 (  25 26 ) resistor r=48.5989 //w=0.187 //l=0.71 //layer=li \
 //thickness=0.1 //x=3.695 //y=5.335 //x2=2.985 //y2=5.335
r353 (  19 61 ) resistor r=1.40859 //w=0.34 //l=0.085 //layer=li \
 //thickness=0.1 //x=2.9 //y=5.42 //x2=2.9 //y2=5.335
r354 (  19 124 ) resistor r=33.1979 //w=0.187 //l=0.485 //layer=li \
 //thickness=0.1 //x=2.9 //y=5.42 //x2=2.9 //y2=5.905
r355 (  17 61 ) resistor r=5.4201 //w=0.17 //l=0.085 //layer=li \
 //thickness=0.1 //x=2.815 //y=5.335 //x2=2.9 //y2=5.335
r356 (  17 18 ) resistor r=48.5989 //w=0.187 //l=0.71 //layer=li \
 //thickness=0.1 //x=2.815 //y=5.335 //x2=2.105 //y2=5.335
r357 (  11 18 ) resistor r=7.15173 //w=0.17 //l=0.120208 //layer=li \
 //thickness=0.1 //x=2.02 //y=5.42 //x2=2.105 //y2=5.335
r358 (  11 123 ) resistor r=33.1979 //w=0.187 //l=0.485 //layer=li \
 //thickness=0.1 //x=2.02 //y=5.42 //x2=2.02 //y2=5.905
r359 (  10 57 ) resistor r=9.3 //w=0.17 //l=0.17 //layer=mcon //count=1 \
 //x=16.4 //y=3.88 //x2=16.4 //y2=3.88
r360 (  8 49 ) resistor r=9.3 //w=0.17 //l=0.17 //layer=mcon //count=1 \
 //x=6.41 //y=3.88 //x2=6.41 //y2=3.88
r361 (  6 44 ) resistor r=9.3 //w=0.17 //l=0.17 //layer=mcon //count=1 \
 //x=4.56 //y=3.88 //x2=4.56 //y2=3.88
r362 (  4 8 ) resistor r=0.0880901 //w=0.191 //l=0.115 //layer=m1 \
 //thickness=0.36 //x=6.525 //y=3.88 //x2=6.41 //y2=3.88
r363 (  3 10 ) resistor r=0.0717383 //w=0.224 //l=0.115 //layer=m1 \
 //thickness=0.36 //x=16.285 //y=3.88 //x2=16.4 //y2=3.88
r364 (  3 4 ) resistor r=9.31298 //w=0.131 //l=9.76 //layer=m1 \
 //thickness=0.36 //x=16.285 //y=3.88 //x2=6.525 //y2=3.88
r365 (  2 6 ) resistor r=0.0717383 //w=0.224 //l=0.115 //layer=m1 \
 //thickness=0.36 //x=4.675 //y=3.88 //x2=4.56 //y2=3.88
r366 (  1 8 ) resistor r=0.0880901 //w=0.191 //l=0.115 //layer=m1 \
 //thickness=0.36 //x=6.295 //y=3.88 //x2=6.41 //y2=3.88
r367 (  1 2 ) resistor r=1.5458 //w=0.131 //l=1.62 //layer=m1 //thickness=0.36 \
 //x=6.295 //y=3.88 //x2=4.675 //y2=3.88
ends PM_TMRDFFQX1\%noxref_5

subckt PM_TMRDFFQX1\%noxref_6 ( 1 2 13 14 25 27 28 32 34 41 42 43 44 45 46 47 \
 48 52 54 57 58 68 71 73 74 )
c150 ( 74 0 ) capacitor c=0.0220291f //x=17.255 //y=5.2
c151 ( 73 0 ) capacitor c=0.0217503f //x=16.375 //y=5.2
c152 ( 71 0 ) capacitor c=0.00866655f //x=17.25 //y=1.085
c153 ( 68 0 ) capacitor c=0.0588816f //x=19.73 //y=4.88
c154 ( 58 0 ) capacitor c=0.0318948f //x=20.065 //y=1.39
c155 ( 57 0 ) capacitor c=0.0187384f //x=20.065 //y=1.045
c156 ( 54 0 ) capacitor c=0.0141798f //x=19.91 //y=1.545
c157 ( 52 0 ) capacitor c=0.0149844f //x=19.91 //y=0.89
c158 ( 48 0 ) capacitor c=0.0816311f //x=19.535 //y=2.095
c159 ( 47 0 ) capacitor c=0.0229722f //x=19.535 //y=1.7
c160 ( 46 0 ) capacitor c=0.0234352f //x=19.535 //y=1.39
c161 ( 45 0 ) capacitor c=0.0199343f //x=19.535 //y=1.045
c162 ( 44 0 ) capacitor c=0.110275f //x=20.07 //y=6.2
c163 ( 43 0 ) capacitor c=0.154305f //x=19.63 //y=6.2
c164 ( 41 0 ) capacitor c=0.00211606f //x=17.4 //y=5.38
c165 ( 34 0 ) capacitor c=0.0889334f //x=19.73 //y=2.26
c166 ( 32 0 ) capacitor c=0.10676f //x=17.88 //y=3.88
c167 ( 28 0 ) capacitor c=0.00436419f //x=17.525 //y=1.835
c168 ( 27 0 ) capacitor c=0.0127039f //x=17.795 //y=1.835
c169 ( 25 0 ) capacitor c=0.0137522f //x=17.795 //y=5.38
c170 ( 14 0 ) capacitor c=0.0025165f //x=16.605 //y=5.38
c171 ( 13 0 ) capacitor c=0.0142497f //x=17.315 //y=5.38
c172 ( 2 0 ) capacitor c=0.00701934f //x=17.995 //y=3.88
c173 ( 1 0 ) capacitor c=0.0472012f //x=19.615 //y=3.88
r174 (  66 68 ) resistor r=20.6867 //w=0.233 //l=0.1 //layer=ply \
 //thickness=0.18 //x=19.63 //y=4.88 //x2=19.73 //y2=4.88
r175 (  59 68 ) resistor r=70.3348 //w=0.233 //l=0.414367 //layer=ply \
 //thickness=0.18 //x=20.07 //y=5.045 //x2=19.73 //y2=4.88
r176 (  58 70 ) resistor r=45.1352 //w=0.168 //l=0.173853 //layer=ply \
 //thickness=0.18 //x=20.065 //y=1.39 //x2=20.025 //y2=1.545
r177 (  57 69 ) resistor r=45.1352 //w=0.168 //l=0.173853 //layer=ply \
 //thickness=0.18 //x=20.065 //y=1.045 //x2=20.025 //y2=0.89
r178 (  57 58 ) resistor r=176.904 //w=0.094 //l=0.345 //layer=ply \
 //thickness=0.18 //x=20.065 //y=1.045 //x2=20.065 //y2=1.39
r179 (  55 65 ) resistor r=10.701 //w=0.21 //l=0.115 //layer=ply \
 //thickness=0.18 //x=19.69 //y=1.545 //x2=19.575 //y2=1.545
r180 (  54 70 ) resistor r=5.52526 //w=0.168 //l=0.115 //layer=ply \
 //thickness=0.18 //x=19.91 //y=1.545 //x2=20.025 //y2=1.545
r181 (  53 64 ) resistor r=5.52526 //w=0.168 //l=0.115 //layer=ply \
 //thickness=0.18 //x=19.69 //y=0.89 //x2=19.575 //y2=0.89
r182 (  52 69 ) resistor r=5.52526 //w=0.168 //l=0.115 //layer=ply \
 //thickness=0.18 //x=19.91 //y=0.89 //x2=20.025 //y2=0.89
r183 (  52 53 ) resistor r=112.809 //w=0.094 //l=0.22 //layer=ply \
 //thickness=0.18 //x=19.91 //y=0.89 //x2=19.69 //y2=0.89
r184 (  49 66 ) resistor r=13.0941 //w=0.233 //l=0.165 //layer=ply \
 //thickness=0.18 //x=19.63 //y=5.045 //x2=19.63 //y2=4.88
r185 (  48 63 ) resistor r=34.8111 //w=0.27 //l=0.264953 //layer=ply \
 //thickness=0.18 //x=19.535 //y=2.095 //x2=19.73 //y2=2.26
r186 (  47 65 ) resistor r=39.5823 //w=0.21 //l=0.173853 //layer=ply \
 //thickness=0.18 //x=19.535 //y=1.7 //x2=19.575 //y2=1.545
r187 (  47 48 ) resistor r=202.543 //w=0.094 //l=0.395 //layer=ply \
 //thickness=0.18 //x=19.535 //y=1.7 //x2=19.535 //y2=2.095
r188 (  46 65 ) resistor r=39.5823 //w=0.21 //l=0.173853 //layer=ply \
 //thickness=0.18 //x=19.535 //y=1.39 //x2=19.575 //y2=1.545
r189 (  45 64 ) resistor r=45.1352 //w=0.168 //l=0.173853 //layer=ply \
 //thickness=0.18 //x=19.535 //y=1.045 //x2=19.575 //y2=0.89
r190 (  45 46 ) resistor r=176.904 //w=0.094 //l=0.345 //layer=ply \
 //thickness=0.18 //x=19.535 //y=1.045 //x2=19.535 //y2=1.39
r191 (  44 59 ) resistor r=592.245 //w=0.094 //l=1.155 //layer=ply \
 //thickness=0.18 //x=20.07 //y=6.2 //x2=20.07 //y2=5.045
r192 (  43 49 ) resistor r=592.245 //w=0.094 //l=1.155 //layer=ply \
 //thickness=0.18 //x=19.63 //y=6.2 //x2=19.63 //y2=5.045
r193 (  42 54 ) resistor r=56.4043 //w=0.094 //l=0.11 //layer=ply \
 //thickness=0.18 //x=19.8 //y=1.545 //x2=19.91 //y2=1.545
r194 (  42 55 ) resistor r=56.4043 //w=0.094 //l=0.11 //layer=ply \
 //thickness=0.18 //x=19.8 //y=1.545 //x2=19.69 //y2=1.545
r195 (  39 68 ) resistor r=152 //w=0.17 //l=0.17 //layer=licon //count=1 \
 //x=19.73 //y=4.88 //x2=19.73 //y2=4.88
r196 (  37 39 ) resistor r=68.4492 //w=0.187 //l=1 //layer=li //thickness=0.1 \
 //x=19.73 //y=3.88 //x2=19.73 //y2=4.88
r197 (  34 63 ) resistor r=152 //w=0.17 //l=0.17 //layer=licon //count=1 \
 //x=19.73 //y=2.26 //x2=19.73 //y2=2.26
r198 (  34 37 ) resistor r=110.888 //w=0.187 //l=1.62 //layer=li \
 //thickness=0.1 //x=19.73 //y=2.26 //x2=19.73 //y2=3.88
r199 (  30 32 ) resistor r=96.8556 //w=0.187 //l=1.415 //layer=li \
 //thickness=0.1 //x=17.88 //y=5.295 //x2=17.88 //y2=3.88
r200 (  29 32 ) resistor r=134.16 //w=0.187 //l=1.96 //layer=li \
 //thickness=0.1 //x=17.88 //y=1.92 //x2=17.88 //y2=3.88
r201 (  27 29 ) resistor r=7.15173 //w=0.17 //l=0.120208 //layer=li \
 //thickness=0.1 //x=17.795 //y=1.835 //x2=17.88 //y2=1.92
r202 (  27 28 ) resistor r=18.4813 //w=0.187 //l=0.27 //layer=li \
 //thickness=0.1 //x=17.795 //y=1.835 //x2=17.525 //y2=1.835
r203 (  26 41 ) resistor r=5.4201 //w=0.17 //l=0.085 //layer=li \
 //thickness=0.1 //x=17.485 //y=5.38 //x2=17.4 //y2=5.38
r204 (  25 30 ) resistor r=7.15173 //w=0.17 //l=0.120208 //layer=li \
 //thickness=0.1 //x=17.795 //y=5.38 //x2=17.88 //y2=5.295
r205 (  25 26 ) resistor r=21.2193 //w=0.187 //l=0.31 //layer=li \
 //thickness=0.1 //x=17.795 //y=5.38 //x2=17.485 //y2=5.38
r206 (  21 28 ) resistor r=7.15173 //w=0.17 //l=0.120208 //layer=li \
 //thickness=0.1 //x=17.44 //y=1.75 //x2=17.525 //y2=1.835
r207 (  21 71 ) resistor r=39.016 //w=0.187 //l=0.57 //layer=li \
 //thickness=0.1 //x=17.44 //y=1.75 //x2=17.44 //y2=1.18
r208 (  15 41 ) resistor r=1.40859 //w=0.34 //l=0.085 //layer=li \
 //thickness=0.1 //x=17.4 //y=5.465 //x2=17.4 //y2=5.38
r209 (  15 74 ) resistor r=30.1176 //w=0.187 //l=0.44 //layer=li \
 //thickness=0.1 //x=17.4 //y=5.465 //x2=17.4 //y2=5.905
r210 (  13 41 ) resistor r=5.4201 //w=0.17 //l=0.085 //layer=li \
 //thickness=0.1 //x=17.315 //y=5.38 //x2=17.4 //y2=5.38
r211 (  13 14 ) resistor r=48.5989 //w=0.187 //l=0.71 //layer=li \
 //thickness=0.1 //x=17.315 //y=5.38 //x2=16.605 //y2=5.38
r212 (  7 14 ) resistor r=7.15173 //w=0.17 //l=0.120208 //layer=li \
 //thickness=0.1 //x=16.52 //y=5.465 //x2=16.605 //y2=5.38
r213 (  7 73 ) resistor r=30.1176 //w=0.187 //l=0.44 //layer=li \
 //thickness=0.1 //x=16.52 //y=5.465 //x2=16.52 //y2=5.905
r214 (  6 37 ) resistor r=9.3 //w=0.17 //l=0.17 //layer=mcon //count=1 \
 //x=19.73 //y=3.88 //x2=19.73 //y2=3.88
r215 (  4 32 ) resistor r=9.3 //w=0.17 //l=0.17 //layer=mcon //count=1 \
 //x=17.88 //y=3.88 //x2=17.88 //y2=3.88
r216 (  2 4 ) resistor r=0.0717383 //w=0.224 //l=0.115 //layer=m1 \
 //thickness=0.36 //x=17.995 //y=3.88 //x2=17.88 //y2=3.88
r217 (  1 6 ) resistor r=0.0717383 //w=0.224 //l=0.115 //layer=m1 \
 //thickness=0.36 //x=19.615 //y=3.88 //x2=19.73 //y2=3.88
r218 (  1 2 ) resistor r=1.5458 //w=0.131 //l=1.62 //layer=m1 //thickness=0.36 \
 //x=19.615 //y=3.88 //x2=17.995 //y2=3.88
ends PM_TMRDFFQX1\%noxref_6

subckt PM_TMRDFFQX1\%noxref_7 ( 1 2 3 4 5 6 16 23 25 35 36 47 49 50 54 55 57 \
 63 66 67 68 69 70 71 72 73 74 75 76 77 78 79 81 87 88 89 90 94 95 96 101 103 \
 105 111 112 113 114 115 120 122 124 130 131 141 142 145 154 155 158 166 168 \
 169 )
c353 ( 169 0 ) capacitor c=0.0220291f //x=13.925 //y=5.2
c354 ( 168 0 ) capacitor c=0.0217503f //x=13.045 //y=5.2
c355 ( 166 0 ) capacitor c=0.00866655f //x=13.92 //y=1.085
c356 ( 158 0 ) capacitor c=0.0331095f //x=20.5 //y=4.88
c357 ( 155 0 ) capacitor c=0.0279499f //x=20.47 //y=2.095
c358 ( 154 0 ) capacitor c=0.0421302f //x=20.47 //y=2.26
c359 ( 145 0 ) capacitor c=0.0331095f //x=10.51 //y=4.88
c360 ( 142 0 ) capacitor c=0.0279499f //x=10.48 //y=2.095
c361 ( 141 0 ) capacitor c=0.0421302f //x=10.48 //y=2.26
c362 ( 131 0 ) capacitor c=0.0429696f //x=21.035 //y=1.43
c363 ( 130 0 ) capacitor c=0.0192208f //x=21.035 //y=1.085
c364 ( 124 0 ) capacitor c=0.0158629f //x=20.88 //y=1.585
c365 ( 122 0 ) capacitor c=0.0157803f //x=20.88 //y=0.93
c366 ( 120 0 ) capacitor c=0.0295235f //x=20.875 //y=4.97
c367 ( 115 0 ) capacitor c=0.0204188f //x=20.505 //y=1.74
c368 ( 114 0 ) capacitor c=0.0168481f //x=20.505 //y=1.43
c369 ( 113 0 ) capacitor c=0.0174783f //x=20.505 //y=1.085
c370 ( 112 0 ) capacitor c=0.0429696f //x=11.045 //y=1.43
c371 ( 111 0 ) capacitor c=0.0192208f //x=11.045 //y=1.085
c372 ( 105 0 ) capacitor c=0.0158629f //x=10.89 //y=1.585
c373 ( 103 0 ) capacitor c=0.0157803f //x=10.89 //y=0.93
c374 ( 101 0 ) capacitor c=0.0295235f //x=10.885 //y=4.97
c375 ( 96 0 ) capacitor c=0.0204188f //x=10.515 //y=1.74
c376 ( 95 0 ) capacitor c=0.0168481f //x=10.515 //y=1.43
c377 ( 94 0 ) capacitor c=0.0174783f //x=10.515 //y=1.085
c378 ( 90 0 ) capacitor c=0.0559896f //x=1.875 //y=4.97
c379 ( 89 0 ) capacitor c=0.0298189f //x=2.165 //y=4.97
c380 ( 88 0 ) capacitor c=0.0347816f //x=1.83 //y=1.4
c381 ( 87 0 ) capacitor c=0.0187487f //x=1.83 //y=1.055
c382 ( 81 0 ) capacitor c=0.0137055f //x=1.675 //y=1.555
c383 ( 79 0 ) capacitor c=0.0149861f //x=1.675 //y=0.9
c384 ( 78 0 ) capacitor c=0.102158f //x=1.3 //y=2.095
c385 ( 77 0 ) capacitor c=0.0229444f //x=1.3 //y=1.71
c386 ( 76 0 ) capacitor c=0.0234352f //x=1.3 //y=1.4
c387 ( 75 0 ) capacitor c=0.0198724f //x=1.3 //y=1.055
c388 ( 74 0 ) capacitor c=0.15358f //x=20.95 //y=6.2
c389 ( 73 0 ) capacitor c=0.110281f //x=20.51 //y=6.2
c390 ( 72 0 ) capacitor c=0.15358f //x=10.96 //y=6.2
c391 ( 71 0 ) capacitor c=0.110281f //x=10.52 //y=6.2
c392 ( 70 0 ) capacitor c=0.110114f //x=2.24 //y=6.2
c393 ( 69 0 ) capacitor c=0.158956f //x=1.8 //y=6.2
c394 ( 63 0 ) capacitor c=0.0021186f //x=14.07 //y=5.38
c395 ( 57 0 ) capacitor c=0.0729826f //x=20.47 //y=2.26
c396 ( 55 0 ) capacitor c=0.00453889f //x=20.47 //y=4.715
c397 ( 54 0 ) capacitor c=0.108418f //x=14.55 //y=4.25
c398 ( 50 0 ) capacitor c=0.00436419f //x=14.195 //y=1.835
c399 ( 49 0 ) capacitor c=0.0127039f //x=14.465 //y=1.835
c400 ( 47 0 ) capacitor c=0.0137562f //x=14.465 //y=5.38
c401 ( 36 0 ) capacitor c=0.00251459f //x=13.275 //y=5.38
c402 ( 35 0 ) capacitor c=0.0142537f //x=13.985 //y=5.38
c403 ( 25 0 ) capacitor c=0.0719497f //x=10.48 //y=2.26
c404 ( 23 0 ) capacitor c=0.00453889f //x=10.48 //y=4.715
c405 ( 16 0 ) capacitor c=0.124161f //x=1.6 //y=2.26
c406 ( 6 0 ) capacitor c=0.00408661f //x=14.665 //y=4.25
c407 ( 5 0 ) capacitor c=0.100584f //x=20.355 //y=4.25
c408 ( 4 0 ) capacitor c=0.00412846f //x=10.595 //y=4.25
c409 ( 3 0 ) capacitor c=0.0519595f //x=14.435 //y=4.25
c410 ( 2 0 ) capacitor c=0.0160831f //x=1.715 //y=4.25
c411 ( 1 0 ) capacitor c=0.163286f //x=10.365 //y=4.25
r412 (  160 161 ) resistor r=32.4568 //w=0.214 //l=0.075 //layer=ply \
 //thickness=0.18 //x=20.5 //y=4.97 //x2=20.5 //y2=5.045
r413 (  158 160 ) resistor r=20.271 //w=0.214 //l=0.09 //layer=ply \
 //thickness=0.18 //x=20.5 //y=4.88 //x2=20.5 //y2=4.97
r414 (  154 155 ) resistor r=52.7279 //w=0.214 //l=0.165 //layer=ply \
 //thickness=0.18 //x=20.47 //y=2.26 //x2=20.47 //y2=2.095
r415 (  147 148 ) resistor r=32.4568 //w=0.214 //l=0.075 //layer=ply \
 //thickness=0.18 //x=10.51 //y=4.97 //x2=10.51 //y2=5.045
r416 (  145 147 ) resistor r=20.271 //w=0.214 //l=0.09 //layer=ply \
 //thickness=0.18 //x=10.51 //y=4.88 //x2=10.51 //y2=4.97
r417 (  141 142 ) resistor r=52.7279 //w=0.214 //l=0.165 //layer=ply \
 //thickness=0.18 //x=10.48 //y=2.26 //x2=10.48 //y2=2.095
r418 (  131 165 ) resistor r=45.1352 //w=0.168 //l=0.173853 //layer=ply \
 //thickness=0.18 //x=21.035 //y=1.43 //x2=20.995 //y2=1.585
r419 (  130 164 ) resistor r=45.1352 //w=0.168 //l=0.173853 //layer=ply \
 //thickness=0.18 //x=21.035 //y=1.085 //x2=20.995 //y2=0.93
r420 (  130 131 ) resistor r=176.904 //w=0.094 //l=0.345 //layer=ply \
 //thickness=0.18 //x=21.035 //y=1.085 //x2=21.035 //y2=1.43
r421 (  125 163 ) resistor r=10.701 //w=0.21 //l=0.115 //layer=ply \
 //thickness=0.18 //x=20.66 //y=1.585 //x2=20.545 //y2=1.585
r422 (  124 165 ) resistor r=5.52526 //w=0.168 //l=0.115 //layer=ply \
 //thickness=0.18 //x=20.88 //y=1.585 //x2=20.995 //y2=1.585
r423 (  123 162 ) resistor r=5.52526 //w=0.168 //l=0.115 //layer=ply \
 //thickness=0.18 //x=20.66 //y=0.93 //x2=20.545 //y2=0.93
r424 (  122 164 ) resistor r=5.52526 //w=0.168 //l=0.115 //layer=ply \
 //thickness=0.18 //x=20.88 //y=0.93 //x2=20.995 //y2=0.93
r425 (  122 123 ) resistor r=112.809 //w=0.094 //l=0.22 //layer=ply \
 //thickness=0.18 //x=20.88 //y=0.93 //x2=20.66 //y2=0.93
r426 (  121 160 ) resistor r=16.5046 //w=0.27 //l=0.135 //layer=ply \
 //thickness=0.18 //x=20.635 //y=4.97 //x2=20.5 //y2=4.97
r427 (  120 127 ) resistor r=26.9307 //w=0.15 //l=0.106066 //layer=ply \
 //thickness=0.18 //x=20.875 //y=4.97 //x2=20.95 //y2=5.045
r428 (  120 121 ) resistor r=123.064 //w=0.094 //l=0.24 //layer=ply \
 //thickness=0.18 //x=20.875 //y=4.97 //x2=20.635 //y2=4.97
r429 (  115 163 ) resistor r=39.5823 //w=0.21 //l=0.173853 //layer=ply \
 //thickness=0.18 //x=20.505 //y=1.74 //x2=20.545 //y2=1.585
r430 (  115 155 ) resistor r=182.032 //w=0.094 //l=0.355 //layer=ply \
 //thickness=0.18 //x=20.505 //y=1.74 //x2=20.505 //y2=2.095
r431 (  114 163 ) resistor r=39.5823 //w=0.21 //l=0.173853 //layer=ply \
 //thickness=0.18 //x=20.505 //y=1.43 //x2=20.545 //y2=1.585
r432 (  113 162 ) resistor r=45.1352 //w=0.168 //l=0.173853 //layer=ply \
 //thickness=0.18 //x=20.505 //y=1.085 //x2=20.545 //y2=0.93
r433 (  113 114 ) resistor r=176.904 //w=0.094 //l=0.345 //layer=ply \
 //thickness=0.18 //x=20.505 //y=1.085 //x2=20.505 //y2=1.43
r434 (  112 152 ) resistor r=45.1352 //w=0.168 //l=0.173853 //layer=ply \
 //thickness=0.18 //x=11.045 //y=1.43 //x2=11.005 //y2=1.585
r435 (  111 151 ) resistor r=45.1352 //w=0.168 //l=0.173853 //layer=ply \
 //thickness=0.18 //x=11.045 //y=1.085 //x2=11.005 //y2=0.93
r436 (  111 112 ) resistor r=176.904 //w=0.094 //l=0.345 //layer=ply \
 //thickness=0.18 //x=11.045 //y=1.085 //x2=11.045 //y2=1.43
r437 (  106 150 ) resistor r=10.701 //w=0.21 //l=0.115 //layer=ply \
 //thickness=0.18 //x=10.67 //y=1.585 //x2=10.555 //y2=1.585
r438 (  105 152 ) resistor r=5.52526 //w=0.168 //l=0.115 //layer=ply \
 //thickness=0.18 //x=10.89 //y=1.585 //x2=11.005 //y2=1.585
r439 (  104 149 ) resistor r=5.52526 //w=0.168 //l=0.115 //layer=ply \
 //thickness=0.18 //x=10.67 //y=0.93 //x2=10.555 //y2=0.93
r440 (  103 151 ) resistor r=5.52526 //w=0.168 //l=0.115 //layer=ply \
 //thickness=0.18 //x=10.89 //y=0.93 //x2=11.005 //y2=0.93
r441 (  103 104 ) resistor r=112.809 //w=0.094 //l=0.22 //layer=ply \
 //thickness=0.18 //x=10.89 //y=0.93 //x2=10.67 //y2=0.93
r442 (  102 147 ) resistor r=16.5046 //w=0.27 //l=0.135 //layer=ply \
 //thickness=0.18 //x=10.645 //y=4.97 //x2=10.51 //y2=4.97
r443 (  101 108 ) resistor r=26.9307 //w=0.15 //l=0.106066 //layer=ply \
 //thickness=0.18 //x=10.885 //y=4.97 //x2=10.96 //y2=5.045
r444 (  101 102 ) resistor r=123.064 //w=0.094 //l=0.24 //layer=ply \
 //thickness=0.18 //x=10.885 //y=4.97 //x2=10.645 //y2=4.97
r445 (  96 150 ) resistor r=39.5823 //w=0.21 //l=0.173853 //layer=ply \
 //thickness=0.18 //x=10.515 //y=1.74 //x2=10.555 //y2=1.585
r446 (  96 142 ) resistor r=182.032 //w=0.094 //l=0.355 //layer=ply \
 //thickness=0.18 //x=10.515 //y=1.74 //x2=10.515 //y2=2.095
r447 (  95 150 ) resistor r=39.5823 //w=0.21 //l=0.173853 //layer=ply \
 //thickness=0.18 //x=10.515 //y=1.43 //x2=10.555 //y2=1.585
r448 (  94 149 ) resistor r=45.1352 //w=0.168 //l=0.173853 //layer=ply \
 //thickness=0.18 //x=10.515 //y=1.085 //x2=10.555 //y2=0.93
r449 (  94 95 ) resistor r=176.904 //w=0.094 //l=0.345 //layer=ply \
 //thickness=0.18 //x=10.515 //y=1.085 //x2=10.515 //y2=1.43
r450 (  89 91 ) resistor r=26.9307 //w=0.15 //l=0.106066 //layer=ply \
 //thickness=0.18 //x=2.165 //y=4.97 //x2=2.24 //y2=5.045
r451 (  89 90 ) resistor r=148.702 //w=0.094 //l=0.29 //layer=ply \
 //thickness=0.18 //x=2.165 //y=4.97 //x2=1.875 //y2=4.97
r452 (  88 139 ) resistor r=45.1352 //w=0.168 //l=0.173853 //layer=ply \
 //thickness=0.18 //x=1.83 //y=1.4 //x2=1.79 //y2=1.555
r453 (  87 138 ) resistor r=45.1352 //w=0.168 //l=0.173853 //layer=ply \
 //thickness=0.18 //x=1.83 //y=1.055 //x2=1.79 //y2=0.9
r454 (  87 88 ) resistor r=176.904 //w=0.094 //l=0.345 //layer=ply \
 //thickness=0.18 //x=1.83 //y=1.055 //x2=1.83 //y2=1.4
r455 (  84 90 ) resistor r=22.7971 //w=0.269 //l=0.106066 //layer=ply \
 //thickness=0.18 //x=1.8 //y=5.045 //x2=1.875 //y2=4.97
r456 (  84 137 ) resistor r=35.8364 //w=0.269 //l=0.270185 //layer=ply \
 //thickness=0.18 //x=1.8 //y=5.045 //x2=1.6 //y2=4.88
r457 (  82 133 ) resistor r=10.701 //w=0.21 //l=0.115 //layer=ply \
 //thickness=0.18 //x=1.455 //y=1.555 //x2=1.34 //y2=1.555
r458 (  81 139 ) resistor r=5.52526 //w=0.168 //l=0.115 //layer=ply \
 //thickness=0.18 //x=1.675 //y=1.555 //x2=1.79 //y2=1.555
r459 (  80 132 ) resistor r=5.52526 //w=0.168 //l=0.115 //layer=ply \
 //thickness=0.18 //x=1.455 //y=0.9 //x2=1.34 //y2=0.9
r460 (  79 138 ) resistor r=5.52526 //w=0.168 //l=0.115 //layer=ply \
 //thickness=0.18 //x=1.675 //y=0.9 //x2=1.79 //y2=0.9
r461 (  79 80 ) resistor r=112.809 //w=0.094 //l=0.22 //layer=ply \
 //thickness=0.18 //x=1.675 //y=0.9 //x2=1.455 //y2=0.9
r462 (  78 135 ) resistor r=58.7805 //w=0.246 //l=0.373497 //layer=ply \
 //thickness=0.18 //x=1.3 //y=2.095 //x2=1.6 //y2=2.26
r463 (  77 133 ) resistor r=39.5823 //w=0.21 //l=0.173853 //layer=ply \
 //thickness=0.18 //x=1.3 //y=1.71 //x2=1.34 //y2=1.555
r464 (  77 78 ) resistor r=197.415 //w=0.094 //l=0.385 //layer=ply \
 //thickness=0.18 //x=1.3 //y=1.71 //x2=1.3 //y2=2.095
r465 (  76 133 ) resistor r=39.5823 //w=0.21 //l=0.173853 //layer=ply \
 //thickness=0.18 //x=1.3 //y=1.4 //x2=1.34 //y2=1.555
r466 (  75 132 ) resistor r=45.1352 //w=0.168 //l=0.173853 //layer=ply \
 //thickness=0.18 //x=1.3 //y=1.055 //x2=1.34 //y2=0.9
r467 (  75 76 ) resistor r=176.904 //w=0.094 //l=0.345 //layer=ply \
 //thickness=0.18 //x=1.3 //y=1.055 //x2=1.3 //y2=1.4
r468 (  74 127 ) resistor r=592.245 //w=0.094 //l=1.155 //layer=ply \
 //thickness=0.18 //x=20.95 //y=6.2 //x2=20.95 //y2=5.045
r469 (  73 161 ) resistor r=592.245 //w=0.094 //l=1.155 //layer=ply \
 //thickness=0.18 //x=20.51 //y=6.2 //x2=20.51 //y2=5.045
r470 (  72 108 ) resistor r=592.245 //w=0.094 //l=1.155 //layer=ply \
 //thickness=0.18 //x=10.96 //y=6.2 //x2=10.96 //y2=5.045
r471 (  71 148 ) resistor r=592.245 //w=0.094 //l=1.155 //layer=ply \
 //thickness=0.18 //x=10.52 //y=6.2 //x2=10.52 //y2=5.045
r472 (  70 91 ) resistor r=592.245 //w=0.094 //l=1.155 //layer=ply \
 //thickness=0.18 //x=2.24 //y=6.2 //x2=2.24 //y2=5.045
r473 (  69 84 ) resistor r=592.245 //w=0.094 //l=1.155 //layer=ply \
 //thickness=0.18 //x=1.8 //y=6.2 //x2=1.8 //y2=5.045
r474 (  68 124 ) resistor r=56.4043 //w=0.094 //l=0.11 //layer=ply \
 //thickness=0.18 //x=20.77 //y=1.585 //x2=20.88 //y2=1.585
r475 (  68 125 ) resistor r=56.4043 //w=0.094 //l=0.11 //layer=ply \
 //thickness=0.18 //x=20.77 //y=1.585 //x2=20.66 //y2=1.585
r476 (  67 105 ) resistor r=56.4043 //w=0.094 //l=0.11 //layer=ply \
 //thickness=0.18 //x=10.78 //y=1.585 //x2=10.89 //y2=1.585
r477 (  67 106 ) resistor r=56.4043 //w=0.094 //l=0.11 //layer=ply \
 //thickness=0.18 //x=10.78 //y=1.585 //x2=10.67 //y2=1.585
r478 (  66 81 ) resistor r=56.4043 //w=0.094 //l=0.11 //layer=ply \
 //thickness=0.18 //x=1.565 //y=1.555 //x2=1.675 //y2=1.555
r479 (  66 82 ) resistor r=56.4043 //w=0.094 //l=0.11 //layer=ply \
 //thickness=0.18 //x=1.565 //y=1.555 //x2=1.455 //y2=1.555
r480 (  65 158 ) resistor r=152 //w=0.17 //l=0.17 //layer=licon //count=1 \
 //x=20.5 //y=4.88 //x2=20.5 //y2=4.88
r481 (  62 145 ) resistor r=152 //w=0.17 //l=0.17 //layer=licon //count=1 \
 //x=10.51 //y=4.88 //x2=10.51 //y2=4.88
r482 (  57 154 ) resistor r=152 //w=0.17 //l=0.17 //layer=licon //count=1 \
 //x=20.47 //y=2.26 //x2=20.47 //y2=2.26
r483 (  57 60 ) resistor r=136.214 //w=0.187 //l=1.99 //layer=li \
 //thickness=0.1 //x=20.47 //y=2.26 //x2=20.47 //y2=4.25
r484 (  55 65 ) resistor r=11.4737 //w=0.186 //l=0.172337 //layer=li \
 //thickness=0.1 //x=20.47 //y=4.715 //x2=20.485 //y2=4.88
r485 (  55 60 ) resistor r=31.8289 //w=0.187 //l=0.465 //layer=li \
 //thickness=0.1 //x=20.47 //y=4.715 //x2=20.47 //y2=4.25
r486 (  52 54 ) resistor r=71.5294 //w=0.187 //l=1.045 //layer=li \
 //thickness=0.1 //x=14.55 //y=5.295 //x2=14.55 //y2=4.25
r487 (  51 54 ) resistor r=159.487 //w=0.187 //l=2.33 //layer=li \
 //thickness=0.1 //x=14.55 //y=1.92 //x2=14.55 //y2=4.25
r488 (  49 51 ) resistor r=7.15173 //w=0.17 //l=0.120208 //layer=li \
 //thickness=0.1 //x=14.465 //y=1.835 //x2=14.55 //y2=1.92
r489 (  49 50 ) resistor r=18.4813 //w=0.187 //l=0.27 //layer=li \
 //thickness=0.1 //x=14.465 //y=1.835 //x2=14.195 //y2=1.835
r490 (  48 63 ) resistor r=5.4201 //w=0.17 //l=0.085 //layer=li \
 //thickness=0.1 //x=14.155 //y=5.38 //x2=14.07 //y2=5.38
r491 (  47 52 ) resistor r=7.15173 //w=0.17 //l=0.120208 //layer=li \
 //thickness=0.1 //x=14.465 //y=5.38 //x2=14.55 //y2=5.295
r492 (  47 48 ) resistor r=21.2193 //w=0.187 //l=0.31 //layer=li \
 //thickness=0.1 //x=14.465 //y=5.38 //x2=14.155 //y2=5.38
r493 (  43 50 ) resistor r=7.15173 //w=0.17 //l=0.120208 //layer=li \
 //thickness=0.1 //x=14.11 //y=1.75 //x2=14.195 //y2=1.835
r494 (  43 166 ) resistor r=39.016 //w=0.187 //l=0.57 //layer=li \
 //thickness=0.1 //x=14.11 //y=1.75 //x2=14.11 //y2=1.18
r495 (  37 63 ) resistor r=1.40859 //w=0.34 //l=0.085 //layer=li \
 //thickness=0.1 //x=14.07 //y=5.465 //x2=14.07 //y2=5.38
r496 (  37 169 ) resistor r=30.1176 //w=0.187 //l=0.44 //layer=li \
 //thickness=0.1 //x=14.07 //y=5.465 //x2=14.07 //y2=5.905
r497 (  35 63 ) resistor r=5.4201 //w=0.17 //l=0.085 //layer=li \
 //thickness=0.1 //x=13.985 //y=5.38 //x2=14.07 //y2=5.38
r498 (  35 36 ) resistor r=48.5989 //w=0.187 //l=0.71 //layer=li \
 //thickness=0.1 //x=13.985 //y=5.38 //x2=13.275 //y2=5.38
r499 (  29 36 ) resistor r=7.15173 //w=0.17 //l=0.120208 //layer=li \
 //thickness=0.1 //x=13.19 //y=5.465 //x2=13.275 //y2=5.38
r500 (  29 168 ) resistor r=30.1176 //w=0.187 //l=0.44 //layer=li \
 //thickness=0.1 //x=13.19 //y=5.465 //x2=13.19 //y2=5.905
r501 (  25 141 ) resistor r=152 //w=0.17 //l=0.17 //layer=licon //count=1 \
 //x=10.48 //y=2.26 //x2=10.48 //y2=2.26
r502 (  25 28 ) resistor r=136.214 //w=0.187 //l=1.99 //layer=li \
 //thickness=0.1 //x=10.48 //y=2.26 //x2=10.48 //y2=4.25
r503 (  23 62 ) resistor r=11.4737 //w=0.186 //l=0.172337 //layer=li \
 //thickness=0.1 //x=10.48 //y=4.715 //x2=10.495 //y2=4.88
r504 (  23 28 ) resistor r=31.8289 //w=0.187 //l=0.465 //layer=li \
 //thickness=0.1 //x=10.48 //y=4.715 //x2=10.48 //y2=4.25
r505 (  21 137 ) resistor r=152 //w=0.17 //l=0.17 //layer=licon //count=1 \
 //x=1.6 //y=4.88 //x2=1.6 //y2=4.88
r506 (  19 21 ) resistor r=43.123 //w=0.187 //l=0.63 //layer=li \
 //thickness=0.1 //x=1.6 //y=4.25 //x2=1.6 //y2=4.88
r507 (  16 135 ) resistor r=152 //w=0.17 //l=0.17 //layer=licon //count=1 \
 //x=1.6 //y=2.26 //x2=1.6 //y2=2.26
r508 (  16 19 ) resistor r=136.214 //w=0.187 //l=1.99 //layer=li \
 //thickness=0.1 //x=1.6 //y=2.26 //x2=1.6 //y2=4.25
r509 (  14 60 ) resistor r=9.3 //w=0.17 //l=0.17 //layer=mcon //count=1 \
 //x=20.47 //y=4.25 //x2=20.47 //y2=4.25
r510 (  12 54 ) resistor r=9.3 //w=0.17 //l=0.17 //layer=mcon //count=1 \
 //x=14.55 //y=4.25 //x2=14.55 //y2=4.25
r511 (  10 28 ) resistor r=9.3 //w=0.17 //l=0.17 //layer=mcon //count=1 \
 //x=10.48 //y=4.25 //x2=10.48 //y2=4.25
r512 (  8 19 ) resistor r=9.3 //w=0.17 //l=0.17 //layer=mcon //count=1 //x=1.6 \
 //y=4.25 //x2=1.6 //y2=4.25
r513 (  6 12 ) resistor r=0.0880901 //w=0.191 //l=0.115 //layer=m1 \
 //thickness=0.36 //x=14.665 //y=4.25 //x2=14.55 //y2=4.25
r514 (  5 14 ) resistor r=0.0717383 //w=0.224 //l=0.115 //layer=m1 \
 //thickness=0.36 //x=20.355 //y=4.25 //x2=20.47 //y2=4.25
r515 (  5 6 ) resistor r=5.42939 //w=0.131 //l=5.69 //layer=m1 \
 //thickness=0.36 //x=20.355 //y=4.25 //x2=14.665 //y2=4.25
r516 (  4 10 ) resistor r=0.0880901 //w=0.191 //l=0.115 //layer=m1 \
 //thickness=0.36 //x=10.595 //y=4.25 //x2=10.48 //y2=4.25
r517 (  3 12 ) resistor r=0.0880901 //w=0.191 //l=0.115 //layer=m1 \
 //thickness=0.36 //x=14.435 //y=4.25 //x2=14.55 //y2=4.25
r518 (  3 4 ) resistor r=3.66412 //w=0.131 //l=3.84 //layer=m1 \
 //thickness=0.36 //x=14.435 //y=4.25 //x2=10.595 //y2=4.25
r519 (  2 8 ) resistor r=0.0717383 //w=0.224 //l=0.115 //layer=m1 \
 //thickness=0.36 //x=1.715 //y=4.25 //x2=1.6 //y2=4.25
r520 (  1 10 ) resistor r=0.0880901 //w=0.191 //l=0.115 //layer=m1 \
 //thickness=0.36 //x=10.365 //y=4.25 //x2=10.48 //y2=4.25
r521 (  1 2 ) resistor r=8.25382 //w=0.131 //l=8.65 //layer=m1 \
 //thickness=0.36 //x=10.365 //y=4.25 //x2=1.715 //y2=4.25
ends PM_TMRDFFQX1\%noxref_7

subckt PM_TMRDFFQX1\%noxref_8 ( 1 2 3 4 12 25 26 37 39 40 44 46 53 54 55 56 57 \
 58 59 63 64 65 70 72 75 76 77 78 79 80 84 86 89 90 95 96 101 110 113 115 116 )
c232 ( 116 0 ) capacitor c=0.0220291f //x=28.725 //y=5.2
c233 ( 115 0 ) capacitor c=0.0217503f //x=27.845 //y=5.2
c234 ( 113 0 ) capacitor c=0.00866655f //x=28.72 //y=1.085
c235 ( 110 0 ) capacitor c=0.0588816f //x=31.2 //y=4.88
c236 ( 101 0 ) capacitor c=0.058931f //x=25.28 //y=4.88
c237 ( 96 0 ) capacitor c=0.0273931f //x=25.28 //y=2.095
c238 ( 95 0 ) capacitor c=0.0457054f //x=25.28 //y=2.26
c239 ( 90 0 ) capacitor c=0.0318948f //x=31.535 //y=1.39
c240 ( 89 0 ) capacitor c=0.0187384f //x=31.535 //y=1.045
c241 ( 86 0 ) capacitor c=0.0141798f //x=31.38 //y=1.545
c242 ( 84 0 ) capacitor c=0.0149844f //x=31.38 //y=0.89
c243 ( 80 0 ) capacitor c=0.0816311f //x=31.005 //y=2.095
c244 ( 79 0 ) capacitor c=0.0229722f //x=31.005 //y=1.7
c245 ( 78 0 ) capacitor c=0.0234352f //x=31.005 //y=1.39
c246 ( 77 0 ) capacitor c=0.0199343f //x=31.005 //y=1.045
c247 ( 76 0 ) capacitor c=0.0432517f //x=25.8 //y=1.44
c248 ( 75 0 ) capacitor c=0.0200379f //x=25.8 //y=1.095
c249 ( 72 0 ) capacitor c=0.0158629f //x=25.645 //y=1.595
c250 ( 70 0 ) capacitor c=0.0157803f //x=25.645 //y=0.94
c251 ( 65 0 ) capacitor c=0.0218028f //x=25.27 //y=1.75
c252 ( 64 0 ) capacitor c=0.0207459f //x=25.27 //y=1.44
c253 ( 63 0 ) capacitor c=0.0194308f //x=25.27 //y=1.095
c254 ( 59 0 ) capacitor c=0.110275f //x=31.54 //y=6.2
c255 ( 58 0 ) capacitor c=0.154305f //x=31.1 //y=6.2
c256 ( 57 0 ) capacitor c=0.158794f //x=25.46 //y=6.2
c257 ( 56 0 ) capacitor c=0.110114f //x=25.02 //y=6.2
c258 ( 53 0 ) capacitor c=0.00211606f //x=28.87 //y=5.38
c259 ( 46 0 ) capacitor c=0.0864117f //x=31.2 //y=2.26
c260 ( 44 0 ) capacitor c=0.103161f //x=29.35 //y=3.51
c261 ( 40 0 ) capacitor c=0.00436419f //x=28.995 //y=1.835
c262 ( 39 0 ) capacitor c=0.0127039f //x=29.265 //y=1.835
c263 ( 37 0 ) capacitor c=0.0137522f //x=29.265 //y=5.38
c264 ( 26 0 ) capacitor c=0.00251635f //x=28.075 //y=5.38
c265 ( 25 0 ) capacitor c=0.0142423f //x=28.785 //y=5.38
c266 ( 12 0 ) capacitor c=0.0836809f //x=25.28 //y=2.26
c267 ( 4 0 ) capacitor c=0.00280195f //x=29.465 //y=3.51
c268 ( 3 0 ) capacitor c=0.0346903f //x=31.085 //y=3.51
c269 ( 2 0 ) capacitor c=0.0127233f //x=25.395 //y=3.51
c270 ( 1 0 ) capacitor c=0.0559579f //x=29.235 //y=3.51
r271 (  108 110 ) resistor r=20.6867 //w=0.233 //l=0.1 //layer=ply \
 //thickness=0.18 //x=31.1 //y=4.88 //x2=31.2 //y2=4.88
r272 (  95 96 ) resistor r=52.7279 //w=0.214 //l=0.165 //layer=ply \
 //thickness=0.18 //x=25.28 //y=2.26 //x2=25.28 //y2=2.095
r273 (  91 110 ) resistor r=70.3348 //w=0.233 //l=0.414367 //layer=ply \
 //thickness=0.18 //x=31.54 //y=5.045 //x2=31.2 //y2=4.88
r274 (  90 112 ) resistor r=45.1352 //w=0.168 //l=0.173853 //layer=ply \
 //thickness=0.18 //x=31.535 //y=1.39 //x2=31.495 //y2=1.545
r275 (  89 111 ) resistor r=45.1352 //w=0.168 //l=0.173853 //layer=ply \
 //thickness=0.18 //x=31.535 //y=1.045 //x2=31.495 //y2=0.89
r276 (  89 90 ) resistor r=176.904 //w=0.094 //l=0.345 //layer=ply \
 //thickness=0.18 //x=31.535 //y=1.045 //x2=31.535 //y2=1.39
r277 (  87 107 ) resistor r=10.701 //w=0.21 //l=0.115 //layer=ply \
 //thickness=0.18 //x=31.16 //y=1.545 //x2=31.045 //y2=1.545
r278 (  86 112 ) resistor r=5.52526 //w=0.168 //l=0.115 //layer=ply \
 //thickness=0.18 //x=31.38 //y=1.545 //x2=31.495 //y2=1.545
r279 (  85 106 ) resistor r=5.52526 //w=0.168 //l=0.115 //layer=ply \
 //thickness=0.18 //x=31.16 //y=0.89 //x2=31.045 //y2=0.89
r280 (  84 111 ) resistor r=5.52526 //w=0.168 //l=0.115 //layer=ply \
 //thickness=0.18 //x=31.38 //y=0.89 //x2=31.495 //y2=0.89
r281 (  84 85 ) resistor r=112.809 //w=0.094 //l=0.22 //layer=ply \
 //thickness=0.18 //x=31.38 //y=0.89 //x2=31.16 //y2=0.89
r282 (  81 108 ) resistor r=13.0941 //w=0.233 //l=0.165 //layer=ply \
 //thickness=0.18 //x=31.1 //y=5.045 //x2=31.1 //y2=4.88
r283 (  80 105 ) resistor r=34.8111 //w=0.27 //l=0.264953 //layer=ply \
 //thickness=0.18 //x=31.005 //y=2.095 //x2=31.2 //y2=2.26
r284 (  79 107 ) resistor r=39.5823 //w=0.21 //l=0.173853 //layer=ply \
 //thickness=0.18 //x=31.005 //y=1.7 //x2=31.045 //y2=1.545
r285 (  79 80 ) resistor r=202.543 //w=0.094 //l=0.395 //layer=ply \
 //thickness=0.18 //x=31.005 //y=1.7 //x2=31.005 //y2=2.095
r286 (  78 107 ) resistor r=39.5823 //w=0.21 //l=0.173853 //layer=ply \
 //thickness=0.18 //x=31.005 //y=1.39 //x2=31.045 //y2=1.545
r287 (  77 106 ) resistor r=45.1352 //w=0.168 //l=0.173853 //layer=ply \
 //thickness=0.18 //x=31.005 //y=1.045 //x2=31.045 //y2=0.89
r288 (  77 78 ) resistor r=176.904 //w=0.094 //l=0.345 //layer=ply \
 //thickness=0.18 //x=31.005 //y=1.045 //x2=31.005 //y2=1.39
r289 (  76 103 ) resistor r=45.1352 //w=0.168 //l=0.173853 //layer=ply \
 //thickness=0.18 //x=25.8 //y=1.44 //x2=25.76 //y2=1.595
r290 (  75 102 ) resistor r=45.1352 //w=0.168 //l=0.173853 //layer=ply \
 //thickness=0.18 //x=25.8 //y=1.095 //x2=25.76 //y2=0.94
r291 (  75 76 ) resistor r=176.904 //w=0.094 //l=0.345 //layer=ply \
 //thickness=0.18 //x=25.8 //y=1.095 //x2=25.8 //y2=1.44
r292 (  73 99 ) resistor r=10.701 //w=0.21 //l=0.115 //layer=ply \
 //thickness=0.18 //x=25.425 //y=1.595 //x2=25.31 //y2=1.595
r293 (  72 103 ) resistor r=5.52526 //w=0.168 //l=0.115 //layer=ply \
 //thickness=0.18 //x=25.645 //y=1.595 //x2=25.76 //y2=1.595
r294 (  71 98 ) resistor r=5.52526 //w=0.168 //l=0.115 //layer=ply \
 //thickness=0.18 //x=25.425 //y=0.94 //x2=25.31 //y2=0.94
r295 (  70 102 ) resistor r=5.52526 //w=0.168 //l=0.115 //layer=ply \
 //thickness=0.18 //x=25.645 //y=0.94 //x2=25.76 //y2=0.94
r296 (  70 71 ) resistor r=112.809 //w=0.094 //l=0.22 //layer=ply \
 //thickness=0.18 //x=25.645 //y=0.94 //x2=25.425 //y2=0.94
r297 (  67 101 ) resistor r=37.236 //w=0.233 //l=0.249199 //layer=ply \
 //thickness=0.18 //x=25.46 //y=5.045 //x2=25.28 //y2=4.88
r298 (  65 99 ) resistor r=39.5823 //w=0.21 //l=0.173853 //layer=ply \
 //thickness=0.18 //x=25.27 //y=1.75 //x2=25.31 //y2=1.595
r299 (  65 96 ) resistor r=176.904 //w=0.094 //l=0.345 //layer=ply \
 //thickness=0.18 //x=25.27 //y=1.75 //x2=25.27 //y2=2.095
r300 (  64 99 ) resistor r=39.5823 //w=0.21 //l=0.173853 //layer=ply \
 //thickness=0.18 //x=25.27 //y=1.44 //x2=25.31 //y2=1.595
r301 (  63 98 ) resistor r=45.1352 //w=0.168 //l=0.173853 //layer=ply \
 //thickness=0.18 //x=25.27 //y=1.095 //x2=25.31 //y2=0.94
r302 (  63 64 ) resistor r=176.904 //w=0.094 //l=0.345 //layer=ply \
 //thickness=0.18 //x=25.27 //y=1.095 //x2=25.27 //y2=1.44
r303 (  60 101 ) resistor r=53.7854 //w=0.233 //l=0.332415 //layer=ply \
 //thickness=0.18 //x=25.02 //y=5.045 //x2=25.28 //y2=4.88
r304 (  59 91 ) resistor r=592.245 //w=0.094 //l=1.155 //layer=ply \
 //thickness=0.18 //x=31.54 //y=6.2 //x2=31.54 //y2=5.045
r305 (  58 81 ) resistor r=592.245 //w=0.094 //l=1.155 //layer=ply \
 //thickness=0.18 //x=31.1 //y=6.2 //x2=31.1 //y2=5.045
r306 (  57 67 ) resistor r=592.245 //w=0.094 //l=1.155 //layer=ply \
 //thickness=0.18 //x=25.46 //y=6.2 //x2=25.46 //y2=5.045
r307 (  56 60 ) resistor r=592.245 //w=0.094 //l=1.155 //layer=ply \
 //thickness=0.18 //x=25.02 //y=6.2 //x2=25.02 //y2=5.045
r308 (  55 86 ) resistor r=56.4043 //w=0.094 //l=0.11 //layer=ply \
 //thickness=0.18 //x=31.27 //y=1.545 //x2=31.38 //y2=1.545
r309 (  55 87 ) resistor r=56.4043 //w=0.094 //l=0.11 //layer=ply \
 //thickness=0.18 //x=31.27 //y=1.545 //x2=31.16 //y2=1.545
r310 (  54 72 ) resistor r=56.4043 //w=0.094 //l=0.11 //layer=ply \
 //thickness=0.18 //x=25.535 //y=1.595 //x2=25.645 //y2=1.595
r311 (  54 73 ) resistor r=56.4043 //w=0.094 //l=0.11 //layer=ply \
 //thickness=0.18 //x=25.535 //y=1.595 //x2=25.425 //y2=1.595
r312 (  51 110 ) resistor r=152 //w=0.17 //l=0.17 //layer=licon //count=1 \
 //x=31.2 //y=4.88 //x2=31.2 //y2=4.88
r313 (  49 51 ) resistor r=93.7754 //w=0.187 //l=1.37 //layer=li \
 //thickness=0.1 //x=31.2 //y=3.51 //x2=31.2 //y2=4.88
r314 (  46 105 ) resistor r=152 //w=0.17 //l=0.17 //layer=licon //count=1 \
 //x=31.2 //y=2.26 //x2=31.2 //y2=2.26
r315 (  46 49 ) resistor r=85.5615 //w=0.187 //l=1.25 //layer=li \
 //thickness=0.1 //x=31.2 //y=2.26 //x2=31.2 //y2=3.51
r316 (  42 44 ) resistor r=122.182 //w=0.187 //l=1.785 //layer=li \
 //thickness=0.1 //x=29.35 //y=5.295 //x2=29.35 //y2=3.51
r317 (  41 44 ) resistor r=108.834 //w=0.187 //l=1.59 //layer=li \
 //thickness=0.1 //x=29.35 //y=1.92 //x2=29.35 //y2=3.51
r318 (  39 41 ) resistor r=7.15173 //w=0.17 //l=0.120208 //layer=li \
 //thickness=0.1 //x=29.265 //y=1.835 //x2=29.35 //y2=1.92
r319 (  39 40 ) resistor r=18.4813 //w=0.187 //l=0.27 //layer=li \
 //thickness=0.1 //x=29.265 //y=1.835 //x2=28.995 //y2=1.835
r320 (  38 53 ) resistor r=5.4201 //w=0.17 //l=0.085 //layer=li \
 //thickness=0.1 //x=28.955 //y=5.38 //x2=28.87 //y2=5.38
r321 (  37 42 ) resistor r=7.15173 //w=0.17 //l=0.120208 //layer=li \
 //thickness=0.1 //x=29.265 //y=5.38 //x2=29.35 //y2=5.295
r322 (  37 38 ) resistor r=21.2193 //w=0.187 //l=0.31 //layer=li \
 //thickness=0.1 //x=29.265 //y=5.38 //x2=28.955 //y2=5.38
r323 (  33 40 ) resistor r=7.15173 //w=0.17 //l=0.120208 //layer=li \
 //thickness=0.1 //x=28.91 //y=1.75 //x2=28.995 //y2=1.835
r324 (  33 113 ) resistor r=39.016 //w=0.187 //l=0.57 //layer=li \
 //thickness=0.1 //x=28.91 //y=1.75 //x2=28.91 //y2=1.18
r325 (  27 53 ) resistor r=1.40859 //w=0.34 //l=0.085 //layer=li \
 //thickness=0.1 //x=28.87 //y=5.465 //x2=28.87 //y2=5.38
r326 (  27 116 ) resistor r=30.1176 //w=0.187 //l=0.44 //layer=li \
 //thickness=0.1 //x=28.87 //y=5.465 //x2=28.87 //y2=5.905
r327 (  25 53 ) resistor r=5.4201 //w=0.17 //l=0.085 //layer=li \
 //thickness=0.1 //x=28.785 //y=5.38 //x2=28.87 //y2=5.38
r328 (  25 26 ) resistor r=48.5989 //w=0.187 //l=0.71 //layer=li \
 //thickness=0.1 //x=28.785 //y=5.38 //x2=28.075 //y2=5.38
r329 (  19 26 ) resistor r=7.15173 //w=0.17 //l=0.120208 //layer=li \
 //thickness=0.1 //x=27.99 //y=5.465 //x2=28.075 //y2=5.38
r330 (  19 115 ) resistor r=30.1176 //w=0.187 //l=0.44 //layer=li \
 //thickness=0.1 //x=27.99 //y=5.465 //x2=27.99 //y2=5.905
r331 (  17 101 ) resistor r=152 //w=0.17 //l=0.17 //layer=licon //count=1 \
 //x=25.28 //y=4.88 //x2=25.28 //y2=4.88
r332 (  15 17 ) resistor r=93.7754 //w=0.187 //l=1.37 //layer=li \
 //thickness=0.1 //x=25.28 //y=3.51 //x2=25.28 //y2=4.88
r333 (  12 95 ) resistor r=152 //w=0.17 //l=0.17 //layer=licon //count=1 \
 //x=25.28 //y=2.26 //x2=25.28 //y2=2.26
r334 (  12 15 ) resistor r=85.5615 //w=0.187 //l=1.25 //layer=li \
 //thickness=0.1 //x=25.28 //y=2.26 //x2=25.28 //y2=3.51
r335 (  10 49 ) resistor r=9.3 //w=0.17 //l=0.17 //layer=mcon //count=1 \
 //x=31.2 //y=3.51 //x2=31.2 //y2=3.51
r336 (  8 44 ) resistor r=9.3 //w=0.17 //l=0.17 //layer=mcon //count=1 \
 //x=29.35 //y=3.51 //x2=29.35 //y2=3.51
r337 (  6 15 ) resistor r=9.3 //w=0.17 //l=0.17 //layer=mcon //count=1 \
 //x=25.28 //y=3.51 //x2=25.28 //y2=3.51
r338 (  4 8 ) resistor r=0.0880901 //w=0.191 //l=0.115 //layer=m1 \
 //thickness=0.36 //x=29.465 //y=3.51 //x2=29.35 //y2=3.51
r339 (  3 10 ) resistor r=0.0717383 //w=0.224 //l=0.115 //layer=m1 \
 //thickness=0.36 //x=31.085 //y=3.51 //x2=31.2 //y2=3.51
r340 (  3 4 ) resistor r=1.5458 //w=0.131 //l=1.62 //layer=m1 //thickness=0.36 \
 //x=31.085 //y=3.51 //x2=29.465 //y2=3.51
r341 (  2 6 ) resistor r=0.0717383 //w=0.224 //l=0.115 //layer=m1 \
 //thickness=0.36 //x=25.395 //y=3.51 //x2=25.28 //y2=3.51
r342 (  1 8 ) resistor r=0.0880901 //w=0.191 //l=0.115 //layer=m1 \
 //thickness=0.36 //x=29.235 //y=3.51 //x2=29.35 //y2=3.51
r343 (  1 2 ) resistor r=3.66412 //w=0.131 //l=3.84 //layer=m1 \
 //thickness=0.36 //x=29.235 //y=3.51 //x2=25.395 //y2=3.51
ends PM_TMRDFFQX1\%noxref_8

subckt PM_TMRDFFQX1\%noxref_9 ( 1 2 13 14 25 27 28 32 34 41 42 43 44 45 46 47 \
 48 52 54 57 58 68 71 73 74 )
c153 ( 74 0 ) capacitor c=0.0220291f //x=32.055 //y=5.2
c154 ( 73 0 ) capacitor c=0.0217503f //x=31.175 //y=5.2
c155 ( 71 0 ) capacitor c=0.00866655f //x=32.05 //y=1.085
c156 ( 68 0 ) capacitor c=0.0588816f //x=34.53 //y=4.88
c157 ( 58 0 ) capacitor c=0.0318948f //x=34.865 //y=1.39
c158 ( 57 0 ) capacitor c=0.0187384f //x=34.865 //y=1.045
c159 ( 54 0 ) capacitor c=0.0141798f //x=34.71 //y=1.545
c160 ( 52 0 ) capacitor c=0.0149844f //x=34.71 //y=0.89
c161 ( 48 0 ) capacitor c=0.0816311f //x=34.335 //y=2.095
c162 ( 47 0 ) capacitor c=0.0229722f //x=34.335 //y=1.7
c163 ( 46 0 ) capacitor c=0.0234352f //x=34.335 //y=1.39
c164 ( 45 0 ) capacitor c=0.0199343f //x=34.335 //y=1.045
c165 ( 44 0 ) capacitor c=0.110275f //x=34.87 //y=6.2
c166 ( 43 0 ) capacitor c=0.154305f //x=34.43 //y=6.2
c167 ( 41 0 ) capacitor c=0.00211606f //x=32.2 //y=5.38
c168 ( 34 0 ) capacitor c=0.0859106f //x=34.53 //y=2.26
c169 ( 32 0 ) capacitor c=0.103708f //x=32.68 //y=3.51
c170 ( 28 0 ) capacitor c=0.00436419f //x=32.325 //y=1.835
c171 ( 27 0 ) capacitor c=0.0127039f //x=32.595 //y=1.835
c172 ( 25 0 ) capacitor c=0.0137522f //x=32.595 //y=5.38
c173 ( 14 0 ) capacitor c=0.00251459f //x=31.405 //y=5.38
c174 ( 13 0 ) capacitor c=0.0143649f //x=32.115 //y=5.38
c175 ( 2 0 ) capacitor c=0.00668619f //x=32.795 //y=3.51
c176 ( 1 0 ) capacitor c=0.0400514f //x=34.415 //y=3.51
r177 (  66 68 ) resistor r=20.6867 //w=0.233 //l=0.1 //layer=ply \
 //thickness=0.18 //x=34.43 //y=4.88 //x2=34.53 //y2=4.88
r178 (  59 68 ) resistor r=70.3348 //w=0.233 //l=0.414367 //layer=ply \
 //thickness=0.18 //x=34.87 //y=5.045 //x2=34.53 //y2=4.88
r179 (  58 70 ) resistor r=45.1352 //w=0.168 //l=0.173853 //layer=ply \
 //thickness=0.18 //x=34.865 //y=1.39 //x2=34.825 //y2=1.545
r180 (  57 69 ) resistor r=45.1352 //w=0.168 //l=0.173853 //layer=ply \
 //thickness=0.18 //x=34.865 //y=1.045 //x2=34.825 //y2=0.89
r181 (  57 58 ) resistor r=176.904 //w=0.094 //l=0.345 //layer=ply \
 //thickness=0.18 //x=34.865 //y=1.045 //x2=34.865 //y2=1.39
r182 (  55 65 ) resistor r=10.701 //w=0.21 //l=0.115 //layer=ply \
 //thickness=0.18 //x=34.49 //y=1.545 //x2=34.375 //y2=1.545
r183 (  54 70 ) resistor r=5.52526 //w=0.168 //l=0.115 //layer=ply \
 //thickness=0.18 //x=34.71 //y=1.545 //x2=34.825 //y2=1.545
r184 (  53 64 ) resistor r=5.52526 //w=0.168 //l=0.115 //layer=ply \
 //thickness=0.18 //x=34.49 //y=0.89 //x2=34.375 //y2=0.89
r185 (  52 69 ) resistor r=5.52526 //w=0.168 //l=0.115 //layer=ply \
 //thickness=0.18 //x=34.71 //y=0.89 //x2=34.825 //y2=0.89
r186 (  52 53 ) resistor r=112.809 //w=0.094 //l=0.22 //layer=ply \
 //thickness=0.18 //x=34.71 //y=0.89 //x2=34.49 //y2=0.89
r187 (  49 66 ) resistor r=13.0941 //w=0.233 //l=0.165 //layer=ply \
 //thickness=0.18 //x=34.43 //y=5.045 //x2=34.43 //y2=4.88
r188 (  48 63 ) resistor r=34.8111 //w=0.27 //l=0.264953 //layer=ply \
 //thickness=0.18 //x=34.335 //y=2.095 //x2=34.53 //y2=2.26
r189 (  47 65 ) resistor r=39.5823 //w=0.21 //l=0.173853 //layer=ply \
 //thickness=0.18 //x=34.335 //y=1.7 //x2=34.375 //y2=1.545
r190 (  47 48 ) resistor r=202.543 //w=0.094 //l=0.395 //layer=ply \
 //thickness=0.18 //x=34.335 //y=1.7 //x2=34.335 //y2=2.095
r191 (  46 65 ) resistor r=39.5823 //w=0.21 //l=0.173853 //layer=ply \
 //thickness=0.18 //x=34.335 //y=1.39 //x2=34.375 //y2=1.545
r192 (  45 64 ) resistor r=45.1352 //w=0.168 //l=0.173853 //layer=ply \
 //thickness=0.18 //x=34.335 //y=1.045 //x2=34.375 //y2=0.89
r193 (  45 46 ) resistor r=176.904 //w=0.094 //l=0.345 //layer=ply \
 //thickness=0.18 //x=34.335 //y=1.045 //x2=34.335 //y2=1.39
r194 (  44 59 ) resistor r=592.245 //w=0.094 //l=1.155 //layer=ply \
 //thickness=0.18 //x=34.87 //y=6.2 //x2=34.87 //y2=5.045
r195 (  43 49 ) resistor r=592.245 //w=0.094 //l=1.155 //layer=ply \
 //thickness=0.18 //x=34.43 //y=6.2 //x2=34.43 //y2=5.045
r196 (  42 54 ) resistor r=56.4043 //w=0.094 //l=0.11 //layer=ply \
 //thickness=0.18 //x=34.6 //y=1.545 //x2=34.71 //y2=1.545
r197 (  42 55 ) resistor r=56.4043 //w=0.094 //l=0.11 //layer=ply \
 //thickness=0.18 //x=34.6 //y=1.545 //x2=34.49 //y2=1.545
r198 (  39 68 ) resistor r=152 //w=0.17 //l=0.17 //layer=licon //count=1 \
 //x=34.53 //y=4.88 //x2=34.53 //y2=4.88
r199 (  37 39 ) resistor r=93.7754 //w=0.187 //l=1.37 //layer=li \
 //thickness=0.1 //x=34.53 //y=3.51 //x2=34.53 //y2=4.88
r200 (  34 63 ) resistor r=152 //w=0.17 //l=0.17 //layer=licon //count=1 \
 //x=34.53 //y=2.26 //x2=34.53 //y2=2.26
r201 (  34 37 ) resistor r=85.5615 //w=0.187 //l=1.25 //layer=li \
 //thickness=0.1 //x=34.53 //y=2.26 //x2=34.53 //y2=3.51
r202 (  30 32 ) resistor r=122.182 //w=0.187 //l=1.785 //layer=li \
 //thickness=0.1 //x=32.68 //y=5.295 //x2=32.68 //y2=3.51
r203 (  29 32 ) resistor r=108.834 //w=0.187 //l=1.59 //layer=li \
 //thickness=0.1 //x=32.68 //y=1.92 //x2=32.68 //y2=3.51
r204 (  27 29 ) resistor r=7.15173 //w=0.17 //l=0.120208 //layer=li \
 //thickness=0.1 //x=32.595 //y=1.835 //x2=32.68 //y2=1.92
r205 (  27 28 ) resistor r=18.4813 //w=0.187 //l=0.27 //layer=li \
 //thickness=0.1 //x=32.595 //y=1.835 //x2=32.325 //y2=1.835
r206 (  26 41 ) resistor r=5.4201 //w=0.17 //l=0.085 //layer=li \
 //thickness=0.1 //x=32.285 //y=5.38 //x2=32.2 //y2=5.38
r207 (  25 30 ) resistor r=7.15173 //w=0.17 //l=0.120208 //layer=li \
 //thickness=0.1 //x=32.595 //y=5.38 //x2=32.68 //y2=5.295
r208 (  25 26 ) resistor r=21.2193 //w=0.187 //l=0.31 //layer=li \
 //thickness=0.1 //x=32.595 //y=5.38 //x2=32.285 //y2=5.38
r209 (  21 28 ) resistor r=7.15173 //w=0.17 //l=0.120208 //layer=li \
 //thickness=0.1 //x=32.24 //y=1.75 //x2=32.325 //y2=1.835
r210 (  21 71 ) resistor r=39.016 //w=0.187 //l=0.57 //layer=li \
 //thickness=0.1 //x=32.24 //y=1.75 //x2=32.24 //y2=1.18
r211 (  15 41 ) resistor r=1.40859 //w=0.34 //l=0.085 //layer=li \
 //thickness=0.1 //x=32.2 //y=5.465 //x2=32.2 //y2=5.38
r212 (  15 74 ) resistor r=30.1176 //w=0.187 //l=0.44 //layer=li \
 //thickness=0.1 //x=32.2 //y=5.465 //x2=32.2 //y2=5.905
r213 (  13 41 ) resistor r=5.4201 //w=0.17 //l=0.085 //layer=li \
 //thickness=0.1 //x=32.115 //y=5.38 //x2=32.2 //y2=5.38
r214 (  13 14 ) resistor r=48.5989 //w=0.187 //l=0.71 //layer=li \
 //thickness=0.1 //x=32.115 //y=5.38 //x2=31.405 //y2=5.38
r215 (  7 14 ) resistor r=7.15173 //w=0.17 //l=0.120208 //layer=li \
 //thickness=0.1 //x=31.32 //y=5.465 //x2=31.405 //y2=5.38
r216 (  7 73 ) resistor r=30.1176 //w=0.187 //l=0.44 //layer=li \
 //thickness=0.1 //x=31.32 //y=5.465 //x2=31.32 //y2=5.905
r217 (  6 37 ) resistor r=9.3 //w=0.17 //l=0.17 //layer=mcon //count=1 \
 //x=34.53 //y=3.51 //x2=34.53 //y2=3.51
r218 (  4 32 ) resistor r=9.3 //w=0.17 //l=0.17 //layer=mcon //count=1 \
 //x=32.68 //y=3.51 //x2=32.68 //y2=3.51
r219 (  2 4 ) resistor r=0.0717383 //w=0.224 //l=0.115 //layer=m1 \
 //thickness=0.36 //x=32.795 //y=3.51 //x2=32.68 //y2=3.51
r220 (  1 6 ) resistor r=0.0717383 //w=0.224 //l=0.115 //layer=m1 \
 //thickness=0.36 //x=34.415 //y=3.51 //x2=34.53 //y2=3.51
r221 (  1 2 ) resistor r=1.5458 //w=0.131 //l=1.62 //layer=m1 //thickness=0.36 \
 //x=34.415 //y=3.51 //x2=32.795 //y2=3.51
ends PM_TMRDFFQX1\%noxref_9

subckt PM_TMRDFFQX1\%noxref_10 ( 1 2 3 4 17 18 25 33 39 40 44 46 54 61 62 63 \
 64 65 66 67 68 69 70 71 72 76 78 81 82 86 87 88 89 93 95 98 99 109 118 121 \
 123 124 125 )
c258 ( 125 0 ) capacitor c=0.023087f //x=25.095 //y=5.2
c259 ( 124 0 ) capacitor c=0.023519f //x=24.215 //y=5.2
c260 ( 123 0 ) capacitor c=0.0224735f //x=23.335 //y=5.2
c261 ( 121 0 ) capacitor c=0.00872971f //x=25.345 //y=1.095
c262 ( 118 0 ) capacitor c=0.0588816f //x=37.86 //y=4.88
c263 ( 109 0 ) capacitor c=0.0588816f //x=27.87 //y=4.88
c264 ( 99 0 ) capacitor c=0.0318948f //x=38.195 //y=1.39
c265 ( 98 0 ) capacitor c=0.0187384f //x=38.195 //y=1.045
c266 ( 95 0 ) capacitor c=0.0141798f //x=38.04 //y=1.545
c267 ( 93 0 ) capacitor c=0.0149844f //x=38.04 //y=0.89
c268 ( 89 0 ) capacitor c=0.0816311f //x=37.665 //y=2.095
c269 ( 88 0 ) capacitor c=0.0229722f //x=37.665 //y=1.7
c270 ( 87 0 ) capacitor c=0.0234352f //x=37.665 //y=1.39
c271 ( 86 0 ) capacitor c=0.0199343f //x=37.665 //y=1.045
c272 ( 82 0 ) capacitor c=0.0318948f //x=28.205 //y=1.39
c273 ( 81 0 ) capacitor c=0.0187384f //x=28.205 //y=1.045
c274 ( 78 0 ) capacitor c=0.0141798f //x=28.05 //y=1.545
c275 ( 76 0 ) capacitor c=0.0149844f //x=28.05 //y=0.89
c276 ( 72 0 ) capacitor c=0.0816311f //x=27.675 //y=2.095
c277 ( 71 0 ) capacitor c=0.0229722f //x=27.675 //y=1.7
c278 ( 70 0 ) capacitor c=0.0234352f //x=27.675 //y=1.39
c279 ( 69 0 ) capacitor c=0.0199343f //x=27.675 //y=1.045
c280 ( 68 0 ) capacitor c=0.110275f //x=38.2 //y=6.2
c281 ( 67 0 ) capacitor c=0.154305f //x=37.76 //y=6.2
c282 ( 66 0 ) capacitor c=0.110275f //x=28.21 //y=6.2
c283 ( 65 0 ) capacitor c=0.154305f //x=27.77 //y=6.2
c284 ( 62 0 ) capacitor c=0.00106608f //x=25.24 //y=5.335
c285 ( 61 0 ) capacitor c=0.00207162f //x=24.36 //y=5.335
c286 ( 54 0 ) capacitor c=0.0890863f //x=37.86 //y=2.26
c287 ( 46 0 ) capacitor c=0.0858897f //x=27.87 //y=2.26
c288 ( 44 0 ) capacitor c=0.104635f //x=26.02 //y=3.88
c289 ( 40 0 ) capacitor c=0.00431225f //x=25.62 //y=1.845
c290 ( 39 0 ) capacitor c=0.0143009f //x=25.935 //y=1.845
c291 ( 33 0 ) capacitor c=0.0284988f //x=25.935 //y=5.335
c292 ( 25 0 ) capacitor c=0.0176454f //x=25.155 //y=5.335
c293 ( 18 0 ) capacitor c=0.00332903f //x=23.565 //y=5.335
c294 ( 17 0 ) capacitor c=0.014837f //x=24.275 //y=5.335
c295 ( 4 0 ) capacitor c=0.00424317f //x=27.985 //y=3.88
c296 ( 3 0 ) capacitor c=0.161586f //x=37.745 //y=3.88
c297 ( 2 0 ) capacitor c=0.0125346f //x=26.135 //y=3.88
c298 ( 1 0 ) capacitor c=0.0285004f //x=27.755 //y=3.88
r299 (  116 118 ) resistor r=20.6867 //w=0.233 //l=0.1 //layer=ply \
 //thickness=0.18 //x=37.76 //y=4.88 //x2=37.86 //y2=4.88
r300 (  107 109 ) resistor r=20.6867 //w=0.233 //l=0.1 //layer=ply \
 //thickness=0.18 //x=27.77 //y=4.88 //x2=27.87 //y2=4.88
r301 (  100 118 ) resistor r=70.3348 //w=0.233 //l=0.414367 //layer=ply \
 //thickness=0.18 //x=38.2 //y=5.045 //x2=37.86 //y2=4.88
r302 (  99 120 ) resistor r=45.1352 //w=0.168 //l=0.173853 //layer=ply \
 //thickness=0.18 //x=38.195 //y=1.39 //x2=38.155 //y2=1.545
r303 (  98 119 ) resistor r=45.1352 //w=0.168 //l=0.173853 //layer=ply \
 //thickness=0.18 //x=38.195 //y=1.045 //x2=38.155 //y2=0.89
r304 (  98 99 ) resistor r=176.904 //w=0.094 //l=0.345 //layer=ply \
 //thickness=0.18 //x=38.195 //y=1.045 //x2=38.195 //y2=1.39
r305 (  96 115 ) resistor r=10.701 //w=0.21 //l=0.115 //layer=ply \
 //thickness=0.18 //x=37.82 //y=1.545 //x2=37.705 //y2=1.545
r306 (  95 120 ) resistor r=5.52526 //w=0.168 //l=0.115 //layer=ply \
 //thickness=0.18 //x=38.04 //y=1.545 //x2=38.155 //y2=1.545
r307 (  94 114 ) resistor r=5.52526 //w=0.168 //l=0.115 //layer=ply \
 //thickness=0.18 //x=37.82 //y=0.89 //x2=37.705 //y2=0.89
r308 (  93 119 ) resistor r=5.52526 //w=0.168 //l=0.115 //layer=ply \
 //thickness=0.18 //x=38.04 //y=0.89 //x2=38.155 //y2=0.89
r309 (  93 94 ) resistor r=112.809 //w=0.094 //l=0.22 //layer=ply \
 //thickness=0.18 //x=38.04 //y=0.89 //x2=37.82 //y2=0.89
r310 (  90 116 ) resistor r=13.0941 //w=0.233 //l=0.165 //layer=ply \
 //thickness=0.18 //x=37.76 //y=5.045 //x2=37.76 //y2=4.88
r311 (  89 113 ) resistor r=34.8111 //w=0.27 //l=0.264953 //layer=ply \
 //thickness=0.18 //x=37.665 //y=2.095 //x2=37.86 //y2=2.26
r312 (  88 115 ) resistor r=39.5823 //w=0.21 //l=0.173853 //layer=ply \
 //thickness=0.18 //x=37.665 //y=1.7 //x2=37.705 //y2=1.545
r313 (  88 89 ) resistor r=202.543 //w=0.094 //l=0.395 //layer=ply \
 //thickness=0.18 //x=37.665 //y=1.7 //x2=37.665 //y2=2.095
r314 (  87 115 ) resistor r=39.5823 //w=0.21 //l=0.173853 //layer=ply \
 //thickness=0.18 //x=37.665 //y=1.39 //x2=37.705 //y2=1.545
r315 (  86 114 ) resistor r=45.1352 //w=0.168 //l=0.173853 //layer=ply \
 //thickness=0.18 //x=37.665 //y=1.045 //x2=37.705 //y2=0.89
r316 (  86 87 ) resistor r=176.904 //w=0.094 //l=0.345 //layer=ply \
 //thickness=0.18 //x=37.665 //y=1.045 //x2=37.665 //y2=1.39
r317 (  83 109 ) resistor r=70.3348 //w=0.233 //l=0.414367 //layer=ply \
 //thickness=0.18 //x=28.21 //y=5.045 //x2=27.87 //y2=4.88
r318 (  82 111 ) resistor r=45.1352 //w=0.168 //l=0.173853 //layer=ply \
 //thickness=0.18 //x=28.205 //y=1.39 //x2=28.165 //y2=1.545
r319 (  81 110 ) resistor r=45.1352 //w=0.168 //l=0.173853 //layer=ply \
 //thickness=0.18 //x=28.205 //y=1.045 //x2=28.165 //y2=0.89
r320 (  81 82 ) resistor r=176.904 //w=0.094 //l=0.345 //layer=ply \
 //thickness=0.18 //x=28.205 //y=1.045 //x2=28.205 //y2=1.39
r321 (  79 106 ) resistor r=10.701 //w=0.21 //l=0.115 //layer=ply \
 //thickness=0.18 //x=27.83 //y=1.545 //x2=27.715 //y2=1.545
r322 (  78 111 ) resistor r=5.52526 //w=0.168 //l=0.115 //layer=ply \
 //thickness=0.18 //x=28.05 //y=1.545 //x2=28.165 //y2=1.545
r323 (  77 105 ) resistor r=5.52526 //w=0.168 //l=0.115 //layer=ply \
 //thickness=0.18 //x=27.83 //y=0.89 //x2=27.715 //y2=0.89
r324 (  76 110 ) resistor r=5.52526 //w=0.168 //l=0.115 //layer=ply \
 //thickness=0.18 //x=28.05 //y=0.89 //x2=28.165 //y2=0.89
r325 (  76 77 ) resistor r=112.809 //w=0.094 //l=0.22 //layer=ply \
 //thickness=0.18 //x=28.05 //y=0.89 //x2=27.83 //y2=0.89
r326 (  73 107 ) resistor r=13.0941 //w=0.233 //l=0.165 //layer=ply \
 //thickness=0.18 //x=27.77 //y=5.045 //x2=27.77 //y2=4.88
r327 (  72 104 ) resistor r=34.8111 //w=0.27 //l=0.264953 //layer=ply \
 //thickness=0.18 //x=27.675 //y=2.095 //x2=27.87 //y2=2.26
r328 (  71 106 ) resistor r=39.5823 //w=0.21 //l=0.173853 //layer=ply \
 //thickness=0.18 //x=27.675 //y=1.7 //x2=27.715 //y2=1.545
r329 (  71 72 ) resistor r=202.543 //w=0.094 //l=0.395 //layer=ply \
 //thickness=0.18 //x=27.675 //y=1.7 //x2=27.675 //y2=2.095
r330 (  70 106 ) resistor r=39.5823 //w=0.21 //l=0.173853 //layer=ply \
 //thickness=0.18 //x=27.675 //y=1.39 //x2=27.715 //y2=1.545
r331 (  69 105 ) resistor r=45.1352 //w=0.168 //l=0.173853 //layer=ply \
 //thickness=0.18 //x=27.675 //y=1.045 //x2=27.715 //y2=0.89
r332 (  69 70 ) resistor r=176.904 //w=0.094 //l=0.345 //layer=ply \
 //thickness=0.18 //x=27.675 //y=1.045 //x2=27.675 //y2=1.39
r333 (  68 100 ) resistor r=592.245 //w=0.094 //l=1.155 //layer=ply \
 //thickness=0.18 //x=38.2 //y=6.2 //x2=38.2 //y2=5.045
r334 (  67 90 ) resistor r=592.245 //w=0.094 //l=1.155 //layer=ply \
 //thickness=0.18 //x=37.76 //y=6.2 //x2=37.76 //y2=5.045
r335 (  66 83 ) resistor r=592.245 //w=0.094 //l=1.155 //layer=ply \
 //thickness=0.18 //x=28.21 //y=6.2 //x2=28.21 //y2=5.045
r336 (  65 73 ) resistor r=592.245 //w=0.094 //l=1.155 //layer=ply \
 //thickness=0.18 //x=27.77 //y=6.2 //x2=27.77 //y2=5.045
r337 (  64 95 ) resistor r=56.4043 //w=0.094 //l=0.11 //layer=ply \
 //thickness=0.18 //x=37.93 //y=1.545 //x2=38.04 //y2=1.545
r338 (  64 96 ) resistor r=56.4043 //w=0.094 //l=0.11 //layer=ply \
 //thickness=0.18 //x=37.93 //y=1.545 //x2=37.82 //y2=1.545
r339 (  63 78 ) resistor r=56.4043 //w=0.094 //l=0.11 //layer=ply \
 //thickness=0.18 //x=27.94 //y=1.545 //x2=28.05 //y2=1.545
r340 (  63 79 ) resistor r=56.4043 //w=0.094 //l=0.11 //layer=ply \
 //thickness=0.18 //x=27.94 //y=1.545 //x2=27.83 //y2=1.545
r341 (  59 118 ) resistor r=152 //w=0.17 //l=0.17 //layer=licon //count=1 \
 //x=37.86 //y=4.88 //x2=37.86 //y2=4.88
r342 (  57 59 ) resistor r=68.4492 //w=0.187 //l=1 //layer=li //thickness=0.1 \
 //x=37.86 //y=3.88 //x2=37.86 //y2=4.88
r343 (  54 113 ) resistor r=152 //w=0.17 //l=0.17 //layer=licon //count=1 \
 //x=37.86 //y=2.26 //x2=37.86 //y2=2.26
r344 (  54 57 ) resistor r=110.888 //w=0.187 //l=1.62 //layer=li \
 //thickness=0.1 //x=37.86 //y=2.26 //x2=37.86 //y2=3.88
r345 (  51 109 ) resistor r=152 //w=0.17 //l=0.17 //layer=licon //count=1 \
 //x=27.87 //y=4.88 //x2=27.87 //y2=4.88
r346 (  49 51 ) resistor r=68.4492 //w=0.187 //l=1 //layer=li //thickness=0.1 \
 //x=27.87 //y=3.88 //x2=27.87 //y2=4.88
r347 (  46 104 ) resistor r=152 //w=0.17 //l=0.17 //layer=licon //count=1 \
 //x=27.87 //y=2.26 //x2=27.87 //y2=2.26
r348 (  46 49 ) resistor r=110.888 //w=0.187 //l=1.62 //layer=li \
 //thickness=0.1 //x=27.87 //y=2.26 //x2=27.87 //y2=3.88
r349 (  42 44 ) resistor r=93.7754 //w=0.187 //l=1.37 //layer=li \
 //thickness=0.1 //x=26.02 //y=5.25 //x2=26.02 //y2=3.88
r350 (  41 44 ) resistor r=133.476 //w=0.187 //l=1.95 //layer=li \
 //thickness=0.1 //x=26.02 //y=1.93 //x2=26.02 //y2=3.88
r351 (  39 41 ) resistor r=7.15173 //w=0.17 //l=0.120208 //layer=li \
 //thickness=0.1 //x=25.935 //y=1.845 //x2=26.02 //y2=1.93
r352 (  39 40 ) resistor r=21.5615 //w=0.187 //l=0.315 //layer=li \
 //thickness=0.1 //x=25.935 //y=1.845 //x2=25.62 //y2=1.845
r353 (  35 40 ) resistor r=7.15173 //w=0.17 //l=0.120208 //layer=li \
 //thickness=0.1 //x=25.535 //y=1.76 //x2=25.62 //y2=1.845
r354 (  35 121 ) resistor r=39.016 //w=0.187 //l=0.57 //layer=li \
 //thickness=0.1 //x=25.535 //y=1.76 //x2=25.535 //y2=1.19
r355 (  34 62 ) resistor r=5.4201 //w=0.17 //l=0.085 //layer=li \
 //thickness=0.1 //x=25.325 //y=5.335 //x2=25.24 //y2=5.335
r356 (  33 42 ) resistor r=7.15173 //w=0.17 //l=0.120208 //layer=li \
 //thickness=0.1 //x=25.935 //y=5.335 //x2=26.02 //y2=5.25
r357 (  33 34 ) resistor r=41.754 //w=0.187 //l=0.61 //layer=li \
 //thickness=0.1 //x=25.935 //y=5.335 //x2=25.325 //y2=5.335
r358 (  27 62 ) resistor r=1.40859 //w=0.34 //l=0.085 //layer=li \
 //thickness=0.1 //x=25.24 //y=5.42 //x2=25.24 //y2=5.335
r359 (  27 125 ) resistor r=33.1979 //w=0.187 //l=0.485 //layer=li \
 //thickness=0.1 //x=25.24 //y=5.42 //x2=25.24 //y2=5.905
r360 (  26 61 ) resistor r=5.4201 //w=0.17 //l=0.085 //layer=li \
 //thickness=0.1 //x=24.445 //y=5.335 //x2=24.36 //y2=5.335
r361 (  25 62 ) resistor r=5.4201 //w=0.17 //l=0.085 //layer=li \
 //thickness=0.1 //x=25.155 //y=5.335 //x2=25.24 //y2=5.335
r362 (  25 26 ) resistor r=48.5989 //w=0.187 //l=0.71 //layer=li \
 //thickness=0.1 //x=25.155 //y=5.335 //x2=24.445 //y2=5.335
r363 (  19 61 ) resistor r=1.40859 //w=0.34 //l=0.085 //layer=li \
 //thickness=0.1 //x=24.36 //y=5.42 //x2=24.36 //y2=5.335
r364 (  19 124 ) resistor r=33.1979 //w=0.187 //l=0.485 //layer=li \
 //thickness=0.1 //x=24.36 //y=5.42 //x2=24.36 //y2=5.905
r365 (  17 61 ) resistor r=5.4201 //w=0.17 //l=0.085 //layer=li \
 //thickness=0.1 //x=24.275 //y=5.335 //x2=24.36 //y2=5.335
r366 (  17 18 ) resistor r=48.5989 //w=0.187 //l=0.71 //layer=li \
 //thickness=0.1 //x=24.275 //y=5.335 //x2=23.565 //y2=5.335
r367 (  11 18 ) resistor r=7.15173 //w=0.17 //l=0.120208 //layer=li \
 //thickness=0.1 //x=23.48 //y=5.42 //x2=23.565 //y2=5.335
r368 (  11 123 ) resistor r=33.1979 //w=0.187 //l=0.485 //layer=li \
 //thickness=0.1 //x=23.48 //y=5.42 //x2=23.48 //y2=5.905
r369 (  10 57 ) resistor r=9.3 //w=0.17 //l=0.17 //layer=mcon //count=1 \
 //x=37.86 //y=3.88 //x2=37.86 //y2=3.88
r370 (  8 49 ) resistor r=9.3 //w=0.17 //l=0.17 //layer=mcon //count=1 \
 //x=27.87 //y=3.88 //x2=27.87 //y2=3.88
r371 (  6 44 ) resistor r=9.3 //w=0.17 //l=0.17 //layer=mcon //count=1 \
 //x=26.02 //y=3.88 //x2=26.02 //y2=3.88
r372 (  4 8 ) resistor r=0.0880901 //w=0.191 //l=0.115 //layer=m1 \
 //thickness=0.36 //x=27.985 //y=3.88 //x2=27.87 //y2=3.88
r373 (  3 10 ) resistor r=0.0717383 //w=0.224 //l=0.115 //layer=m1 \
 //thickness=0.36 //x=37.745 //y=3.88 //x2=37.86 //y2=3.88
r374 (  3 4 ) resistor r=9.31298 //w=0.131 //l=9.76 //layer=m1 \
 //thickness=0.36 //x=37.745 //y=3.88 //x2=27.985 //y2=3.88
r375 (  2 6 ) resistor r=0.0717383 //w=0.224 //l=0.115 //layer=m1 \
 //thickness=0.36 //x=26.135 //y=3.88 //x2=26.02 //y2=3.88
r376 (  1 8 ) resistor r=0.0880901 //w=0.191 //l=0.115 //layer=m1 \
 //thickness=0.36 //x=27.755 //y=3.88 //x2=27.87 //y2=3.88
r377 (  1 2 ) resistor r=1.5458 //w=0.131 //l=1.62 //layer=m1 //thickness=0.36 \
 //x=27.755 //y=3.88 //x2=26.135 //y2=3.88
ends PM_TMRDFFQX1\%noxref_10

subckt PM_TMRDFFQX1\%noxref_11 ( 1 2 13 14 25 27 28 32 34 41 42 43 44 45 46 47 \
 48 52 54 57 58 68 71 73 74 )
c151 ( 74 0 ) capacitor c=0.0220291f //x=38.715 //y=5.2
c152 ( 73 0 ) capacitor c=0.0217503f //x=37.835 //y=5.2
c153 ( 71 0 ) capacitor c=0.00866655f //x=38.71 //y=1.085
c154 ( 68 0 ) capacitor c=0.0588816f //x=41.19 //y=4.88
c155 ( 58 0 ) capacitor c=0.0318948f //x=41.525 //y=1.39
c156 ( 57 0 ) capacitor c=0.0187384f //x=41.525 //y=1.045
c157 ( 54 0 ) capacitor c=0.0141798f //x=41.37 //y=1.545
c158 ( 52 0 ) capacitor c=0.0149844f //x=41.37 //y=0.89
c159 ( 48 0 ) capacitor c=0.0813322f //x=40.995 //y=2.095
c160 ( 47 0 ) capacitor c=0.0229267f //x=40.995 //y=1.7
c161 ( 46 0 ) capacitor c=0.0234352f //x=40.995 //y=1.39
c162 ( 45 0 ) capacitor c=0.0199343f //x=40.995 //y=1.045
c163 ( 44 0 ) capacitor c=0.110275f //x=41.53 //y=6.2
c164 ( 43 0 ) capacitor c=0.154305f //x=41.09 //y=6.2
c165 ( 41 0 ) capacitor c=0.00211606f //x=38.86 //y=5.38
c166 ( 34 0 ) capacitor c=0.0867306f //x=41.19 //y=2.26
c167 ( 32 0 ) capacitor c=0.105846f //x=39.34 //y=3.88
c168 ( 28 0 ) capacitor c=0.00404073f //x=38.985 //y=1.835
c169 ( 27 0 ) capacitor c=0.0122201f //x=39.255 //y=1.835
c170 ( 25 0 ) capacitor c=0.0137522f //x=39.255 //y=5.38
c171 ( 14 0 ) capacitor c=0.00251459f //x=38.065 //y=5.38
c172 ( 13 0 ) capacitor c=0.0142423f //x=38.775 //y=5.38
c173 ( 2 0 ) capacitor c=0.00701934f //x=39.455 //y=3.88
c174 ( 1 0 ) capacitor c=0.0472012f //x=41.075 //y=3.88
r175 (  66 68 ) resistor r=20.6867 //w=0.233 //l=0.1 //layer=ply \
 //thickness=0.18 //x=41.09 //y=4.88 //x2=41.19 //y2=4.88
r176 (  59 68 ) resistor r=70.3348 //w=0.233 //l=0.414367 //layer=ply \
 //thickness=0.18 //x=41.53 //y=5.045 //x2=41.19 //y2=4.88
r177 (  58 70 ) resistor r=45.1352 //w=0.168 //l=0.173853 //layer=ply \
 //thickness=0.18 //x=41.525 //y=1.39 //x2=41.485 //y2=1.545
r178 (  57 69 ) resistor r=45.1352 //w=0.168 //l=0.173853 //layer=ply \
 //thickness=0.18 //x=41.525 //y=1.045 //x2=41.485 //y2=0.89
r179 (  57 58 ) resistor r=176.904 //w=0.094 //l=0.345 //layer=ply \
 //thickness=0.18 //x=41.525 //y=1.045 //x2=41.525 //y2=1.39
r180 (  55 65 ) resistor r=10.701 //w=0.21 //l=0.115 //layer=ply \
 //thickness=0.18 //x=41.15 //y=1.545 //x2=41.035 //y2=1.545
r181 (  54 70 ) resistor r=5.52526 //w=0.168 //l=0.115 //layer=ply \
 //thickness=0.18 //x=41.37 //y=1.545 //x2=41.485 //y2=1.545
r182 (  53 64 ) resistor r=5.52526 //w=0.168 //l=0.115 //layer=ply \
 //thickness=0.18 //x=41.15 //y=0.89 //x2=41.035 //y2=0.89
r183 (  52 69 ) resistor r=5.52526 //w=0.168 //l=0.115 //layer=ply \
 //thickness=0.18 //x=41.37 //y=0.89 //x2=41.485 //y2=0.89
r184 (  52 53 ) resistor r=112.809 //w=0.094 //l=0.22 //layer=ply \
 //thickness=0.18 //x=41.37 //y=0.89 //x2=41.15 //y2=0.89
r185 (  49 66 ) resistor r=13.0941 //w=0.233 //l=0.165 //layer=ply \
 //thickness=0.18 //x=41.09 //y=5.045 //x2=41.09 //y2=4.88
r186 (  48 63 ) resistor r=34.8111 //w=0.27 //l=0.264953 //layer=ply \
 //thickness=0.18 //x=40.995 //y=2.095 //x2=41.19 //y2=2.26
r187 (  47 65 ) resistor r=39.5823 //w=0.21 //l=0.173853 //layer=ply \
 //thickness=0.18 //x=40.995 //y=1.7 //x2=41.035 //y2=1.545
r188 (  47 48 ) resistor r=202.543 //w=0.094 //l=0.395 //layer=ply \
 //thickness=0.18 //x=40.995 //y=1.7 //x2=40.995 //y2=2.095
r189 (  46 65 ) resistor r=39.5823 //w=0.21 //l=0.173853 //layer=ply \
 //thickness=0.18 //x=40.995 //y=1.39 //x2=41.035 //y2=1.545
r190 (  45 64 ) resistor r=45.1352 //w=0.168 //l=0.173853 //layer=ply \
 //thickness=0.18 //x=40.995 //y=1.045 //x2=41.035 //y2=0.89
r191 (  45 46 ) resistor r=176.904 //w=0.094 //l=0.345 //layer=ply \
 //thickness=0.18 //x=40.995 //y=1.045 //x2=40.995 //y2=1.39
r192 (  44 59 ) resistor r=592.245 //w=0.094 //l=1.155 //layer=ply \
 //thickness=0.18 //x=41.53 //y=6.2 //x2=41.53 //y2=5.045
r193 (  43 49 ) resistor r=592.245 //w=0.094 //l=1.155 //layer=ply \
 //thickness=0.18 //x=41.09 //y=6.2 //x2=41.09 //y2=5.045
r194 (  42 54 ) resistor r=56.4043 //w=0.094 //l=0.11 //layer=ply \
 //thickness=0.18 //x=41.26 //y=1.545 //x2=41.37 //y2=1.545
r195 (  42 55 ) resistor r=56.4043 //w=0.094 //l=0.11 //layer=ply \
 //thickness=0.18 //x=41.26 //y=1.545 //x2=41.15 //y2=1.545
r196 (  39 68 ) resistor r=152 //w=0.17 //l=0.17 //layer=licon //count=1 \
 //x=41.19 //y=4.88 //x2=41.19 //y2=4.88
r197 (  37 39 ) resistor r=68.4492 //w=0.187 //l=1 //layer=li //thickness=0.1 \
 //x=41.19 //y=3.88 //x2=41.19 //y2=4.88
r198 (  34 63 ) resistor r=152 //w=0.17 //l=0.17 //layer=licon //count=1 \
 //x=41.19 //y=2.26 //x2=41.19 //y2=2.26
r199 (  34 37 ) resistor r=110.888 //w=0.187 //l=1.62 //layer=li \
 //thickness=0.1 //x=41.19 //y=2.26 //x2=41.19 //y2=3.88
r200 (  30 32 ) resistor r=96.8556 //w=0.187 //l=1.415 //layer=li \
 //thickness=0.1 //x=39.34 //y=5.295 //x2=39.34 //y2=3.88
r201 (  29 32 ) resistor r=134.16 //w=0.187 //l=1.96 //layer=li \
 //thickness=0.1 //x=39.34 //y=1.92 //x2=39.34 //y2=3.88
r202 (  27 29 ) resistor r=7.15173 //w=0.17 //l=0.120208 //layer=li \
 //thickness=0.1 //x=39.255 //y=1.835 //x2=39.34 //y2=1.92
r203 (  27 28 ) resistor r=18.4813 //w=0.187 //l=0.27 //layer=li \
 //thickness=0.1 //x=39.255 //y=1.835 //x2=38.985 //y2=1.835
r204 (  26 41 ) resistor r=5.4201 //w=0.17 //l=0.085 //layer=li \
 //thickness=0.1 //x=38.945 //y=5.38 //x2=38.86 //y2=5.38
r205 (  25 30 ) resistor r=7.15173 //w=0.17 //l=0.120208 //layer=li \
 //thickness=0.1 //x=39.255 //y=5.38 //x2=39.34 //y2=5.295
r206 (  25 26 ) resistor r=21.2193 //w=0.187 //l=0.31 //layer=li \
 //thickness=0.1 //x=39.255 //y=5.38 //x2=38.945 //y2=5.38
r207 (  21 28 ) resistor r=7.15173 //w=0.17 //l=0.120208 //layer=li \
 //thickness=0.1 //x=38.9 //y=1.75 //x2=38.985 //y2=1.835
r208 (  21 71 ) resistor r=39.016 //w=0.187 //l=0.57 //layer=li \
 //thickness=0.1 //x=38.9 //y=1.75 //x2=38.9 //y2=1.18
r209 (  15 41 ) resistor r=1.40859 //w=0.34 //l=0.085 //layer=li \
 //thickness=0.1 //x=38.86 //y=5.465 //x2=38.86 //y2=5.38
r210 (  15 74 ) resistor r=30.1176 //w=0.187 //l=0.44 //layer=li \
 //thickness=0.1 //x=38.86 //y=5.465 //x2=38.86 //y2=5.905
r211 (  13 41 ) resistor r=5.4201 //w=0.17 //l=0.085 //layer=li \
 //thickness=0.1 //x=38.775 //y=5.38 //x2=38.86 //y2=5.38
r212 (  13 14 ) resistor r=48.5989 //w=0.187 //l=0.71 //layer=li \
 //thickness=0.1 //x=38.775 //y=5.38 //x2=38.065 //y2=5.38
r213 (  7 14 ) resistor r=7.15173 //w=0.17 //l=0.120208 //layer=li \
 //thickness=0.1 //x=37.98 //y=5.465 //x2=38.065 //y2=5.38
r214 (  7 73 ) resistor r=30.1176 //w=0.187 //l=0.44 //layer=li \
 //thickness=0.1 //x=37.98 //y=5.465 //x2=37.98 //y2=5.905
r215 (  6 37 ) resistor r=9.3 //w=0.17 //l=0.17 //layer=mcon //count=1 \
 //x=41.19 //y=3.88 //x2=41.19 //y2=3.88
r216 (  4 32 ) resistor r=9.3 //w=0.17 //l=0.17 //layer=mcon //count=1 \
 //x=39.34 //y=3.88 //x2=39.34 //y2=3.88
r217 (  2 4 ) resistor r=0.0717383 //w=0.224 //l=0.115 //layer=m1 \
 //thickness=0.36 //x=39.455 //y=3.88 //x2=39.34 //y2=3.88
r218 (  1 6 ) resistor r=0.0717383 //w=0.224 //l=0.115 //layer=m1 \
 //thickness=0.36 //x=41.075 //y=3.88 //x2=41.19 //y2=3.88
r219 (  1 2 ) resistor r=1.5458 //w=0.131 //l=1.62 //layer=m1 //thickness=0.36 \
 //x=41.075 //y=3.88 //x2=39.455 //y2=3.88
ends PM_TMRDFFQX1\%noxref_11

subckt PM_TMRDFFQX1\%noxref_12 ( 1 2 3 4 5 6 16 23 25 35 36 47 49 50 54 55 57 \
 63 66 67 68 69 70 71 72 73 74 75 76 77 78 79 81 87 88 89 90 94 95 96 101 103 \
 105 111 112 113 114 115 120 122 124 130 131 141 142 145 154 155 158 166 168 \
 169 )
c355 ( 169 0 ) capacitor c=0.0220291f //x=35.385 //y=5.2
c356 ( 168 0 ) capacitor c=0.0217503f //x=34.505 //y=5.2
c357 ( 166 0 ) capacitor c=0.00866655f //x=35.38 //y=1.085
c358 ( 158 0 ) capacitor c=0.0331095f //x=41.96 //y=4.88
c359 ( 155 0 ) capacitor c=0.0279499f //x=41.93 //y=2.095
c360 ( 154 0 ) capacitor c=0.0421676f //x=41.93 //y=2.26
c361 ( 145 0 ) capacitor c=0.0331095f //x=31.97 //y=4.88
c362 ( 142 0 ) capacitor c=0.0279499f //x=31.94 //y=2.095
c363 ( 141 0 ) capacitor c=0.0421302f //x=31.94 //y=2.26
c364 ( 131 0 ) capacitor c=0.0429696f //x=42.495 //y=1.43
c365 ( 130 0 ) capacitor c=0.0192208f //x=42.495 //y=1.085
c366 ( 124 0 ) capacitor c=0.0148884f //x=42.34 //y=1.585
c367 ( 122 0 ) capacitor c=0.0157803f //x=42.34 //y=0.93
c368 ( 120 0 ) capacitor c=0.0295235f //x=42.335 //y=4.97
c369 ( 115 0 ) capacitor c=0.0204188f //x=41.965 //y=1.74
c370 ( 114 0 ) capacitor c=0.0168481f //x=41.965 //y=1.43
c371 ( 113 0 ) capacitor c=0.0174783f //x=41.965 //y=1.085
c372 ( 112 0 ) capacitor c=0.0429696f //x=32.505 //y=1.43
c373 ( 111 0 ) capacitor c=0.0192208f //x=32.505 //y=1.085
c374 ( 105 0 ) capacitor c=0.0158629f //x=32.35 //y=1.585
c375 ( 103 0 ) capacitor c=0.0157803f //x=32.35 //y=0.93
c376 ( 101 0 ) capacitor c=0.0295235f //x=32.345 //y=4.97
c377 ( 96 0 ) capacitor c=0.0204188f //x=31.975 //y=1.74
c378 ( 95 0 ) capacitor c=0.0168481f //x=31.975 //y=1.43
c379 ( 94 0 ) capacitor c=0.0174783f //x=31.975 //y=1.085
c380 ( 90 0 ) capacitor c=0.0556143f //x=23.335 //y=4.97
c381 ( 89 0 ) capacitor c=0.0293157f //x=23.625 //y=4.97
c382 ( 88 0 ) capacitor c=0.0347816f //x=23.29 //y=1.4
c383 ( 87 0 ) capacitor c=0.0187487f //x=23.29 //y=1.055
c384 ( 81 0 ) capacitor c=0.0137055f //x=23.135 //y=1.555
c385 ( 79 0 ) capacitor c=0.0149861f //x=23.135 //y=0.9
c386 ( 78 0 ) capacitor c=0.0965296f //x=22.76 //y=2.095
c387 ( 77 0 ) capacitor c=0.0229444f //x=22.76 //y=1.71
c388 ( 76 0 ) capacitor c=0.0234352f //x=22.76 //y=1.4
c389 ( 75 0 ) capacitor c=0.0198724f //x=22.76 //y=1.055
c390 ( 74 0 ) capacitor c=0.15358f //x=42.41 //y=6.2
c391 ( 73 0 ) capacitor c=0.110281f //x=41.97 //y=6.2
c392 ( 72 0 ) capacitor c=0.15358f //x=32.42 //y=6.2
c393 ( 71 0 ) capacitor c=0.110281f //x=31.98 //y=6.2
c394 ( 70 0 ) capacitor c=0.110114f //x=23.7 //y=6.2
c395 ( 69 0 ) capacitor c=0.158956f //x=23.26 //y=6.2
c396 ( 63 0 ) capacitor c=0.00211606f //x=35.53 //y=5.38
c397 ( 57 0 ) capacitor c=0.0711385f //x=41.93 //y=2.26
c398 ( 55 0 ) capacitor c=0.00453889f //x=41.93 //y=4.715
c399 ( 54 0 ) capacitor c=0.105358f //x=36.01 //y=4.25
c400 ( 50 0 ) capacitor c=0.00436419f //x=35.655 //y=1.835
c401 ( 49 0 ) capacitor c=0.0127039f //x=35.925 //y=1.835
c402 ( 47 0 ) capacitor c=0.0137522f //x=35.925 //y=5.38
c403 ( 36 0 ) capacitor c=0.00251459f //x=34.735 //y=5.38
c404 ( 35 0 ) capacitor c=0.0142529f //x=35.445 //y=5.38
c405 ( 25 0 ) capacitor c=0.0699667f //x=31.94 //y=2.26
c406 ( 23 0 ) capacitor c=0.00453889f //x=31.94 //y=4.715
c407 ( 16 0 ) capacitor c=0.103259f //x=23.06 //y=2.26
c408 ( 6 0 ) capacitor c=0.00407792f //x=36.125 //y=4.25
c409 ( 5 0 ) capacitor c=0.0992605f //x=41.815 //y=4.25
c410 ( 4 0 ) capacitor c=0.00412846f //x=32.055 //y=4.25
c411 ( 3 0 ) capacitor c=0.0519266f //x=35.895 //y=4.25
c412 ( 2 0 ) capacitor c=0.0101712f //x=23.175 //y=4.25
c413 ( 1 0 ) capacitor c=0.130427f //x=31.825 //y=4.25
r414 (  160 161 ) resistor r=32.4568 //w=0.214 //l=0.075 //layer=ply \
 //thickness=0.18 //x=41.96 //y=4.97 //x2=41.96 //y2=5.045
r415 (  158 160 ) resistor r=20.271 //w=0.214 //l=0.09 //layer=ply \
 //thickness=0.18 //x=41.96 //y=4.88 //x2=41.96 //y2=4.97
r416 (  154 155 ) resistor r=52.7279 //w=0.214 //l=0.165 //layer=ply \
 //thickness=0.18 //x=41.93 //y=2.26 //x2=41.93 //y2=2.095
r417 (  147 148 ) resistor r=32.4568 //w=0.214 //l=0.075 //layer=ply \
 //thickness=0.18 //x=31.97 //y=4.97 //x2=31.97 //y2=5.045
r418 (  145 147 ) resistor r=20.271 //w=0.214 //l=0.09 //layer=ply \
 //thickness=0.18 //x=31.97 //y=4.88 //x2=31.97 //y2=4.97
r419 (  141 142 ) resistor r=52.7279 //w=0.214 //l=0.165 //layer=ply \
 //thickness=0.18 //x=31.94 //y=2.26 //x2=31.94 //y2=2.095
r420 (  131 165 ) resistor r=45.1352 //w=0.168 //l=0.173853 //layer=ply \
 //thickness=0.18 //x=42.495 //y=1.43 //x2=42.455 //y2=1.585
r421 (  130 164 ) resistor r=45.1352 //w=0.168 //l=0.173853 //layer=ply \
 //thickness=0.18 //x=42.495 //y=1.085 //x2=42.455 //y2=0.93
r422 (  130 131 ) resistor r=176.904 //w=0.094 //l=0.345 //layer=ply \
 //thickness=0.18 //x=42.495 //y=1.085 //x2=42.495 //y2=1.43
r423 (  125 163 ) resistor r=10.701 //w=0.21 //l=0.115 //layer=ply \
 //thickness=0.18 //x=42.12 //y=1.585 //x2=42.005 //y2=1.585
r424 (  124 165 ) resistor r=5.52526 //w=0.168 //l=0.115 //layer=ply \
 //thickness=0.18 //x=42.34 //y=1.585 //x2=42.455 //y2=1.585
r425 (  123 162 ) resistor r=5.52526 //w=0.168 //l=0.115 //layer=ply \
 //thickness=0.18 //x=42.12 //y=0.93 //x2=42.005 //y2=0.93
r426 (  122 164 ) resistor r=5.52526 //w=0.168 //l=0.115 //layer=ply \
 //thickness=0.18 //x=42.34 //y=0.93 //x2=42.455 //y2=0.93
r427 (  122 123 ) resistor r=112.809 //w=0.094 //l=0.22 //layer=ply \
 //thickness=0.18 //x=42.34 //y=0.93 //x2=42.12 //y2=0.93
r428 (  121 160 ) resistor r=16.5046 //w=0.27 //l=0.135 //layer=ply \
 //thickness=0.18 //x=42.095 //y=4.97 //x2=41.96 //y2=4.97
r429 (  120 127 ) resistor r=26.9307 //w=0.15 //l=0.106066 //layer=ply \
 //thickness=0.18 //x=42.335 //y=4.97 //x2=42.41 //y2=5.045
r430 (  120 121 ) resistor r=123.064 //w=0.094 //l=0.24 //layer=ply \
 //thickness=0.18 //x=42.335 //y=4.97 //x2=42.095 //y2=4.97
r431 (  115 163 ) resistor r=39.5823 //w=0.21 //l=0.173853 //layer=ply \
 //thickness=0.18 //x=41.965 //y=1.74 //x2=42.005 //y2=1.585
r432 (  115 155 ) resistor r=182.032 //w=0.094 //l=0.355 //layer=ply \
 //thickness=0.18 //x=41.965 //y=1.74 //x2=41.965 //y2=2.095
r433 (  114 163 ) resistor r=39.5823 //w=0.21 //l=0.173853 //layer=ply \
 //thickness=0.18 //x=41.965 //y=1.43 //x2=42.005 //y2=1.585
r434 (  113 162 ) resistor r=45.1352 //w=0.168 //l=0.173853 //layer=ply \
 //thickness=0.18 //x=41.965 //y=1.085 //x2=42.005 //y2=0.93
r435 (  113 114 ) resistor r=176.904 //w=0.094 //l=0.345 //layer=ply \
 //thickness=0.18 //x=41.965 //y=1.085 //x2=41.965 //y2=1.43
r436 (  112 152 ) resistor r=45.1352 //w=0.168 //l=0.173853 //layer=ply \
 //thickness=0.18 //x=32.505 //y=1.43 //x2=32.465 //y2=1.585
r437 (  111 151 ) resistor r=45.1352 //w=0.168 //l=0.173853 //layer=ply \
 //thickness=0.18 //x=32.505 //y=1.085 //x2=32.465 //y2=0.93
r438 (  111 112 ) resistor r=176.904 //w=0.094 //l=0.345 //layer=ply \
 //thickness=0.18 //x=32.505 //y=1.085 //x2=32.505 //y2=1.43
r439 (  106 150 ) resistor r=10.701 //w=0.21 //l=0.115 //layer=ply \
 //thickness=0.18 //x=32.13 //y=1.585 //x2=32.015 //y2=1.585
r440 (  105 152 ) resistor r=5.52526 //w=0.168 //l=0.115 //layer=ply \
 //thickness=0.18 //x=32.35 //y=1.585 //x2=32.465 //y2=1.585
r441 (  104 149 ) resistor r=5.52526 //w=0.168 //l=0.115 //layer=ply \
 //thickness=0.18 //x=32.13 //y=0.93 //x2=32.015 //y2=0.93
r442 (  103 151 ) resistor r=5.52526 //w=0.168 //l=0.115 //layer=ply \
 //thickness=0.18 //x=32.35 //y=0.93 //x2=32.465 //y2=0.93
r443 (  103 104 ) resistor r=112.809 //w=0.094 //l=0.22 //layer=ply \
 //thickness=0.18 //x=32.35 //y=0.93 //x2=32.13 //y2=0.93
r444 (  102 147 ) resistor r=16.5046 //w=0.27 //l=0.135 //layer=ply \
 //thickness=0.18 //x=32.105 //y=4.97 //x2=31.97 //y2=4.97
r445 (  101 108 ) resistor r=26.9307 //w=0.15 //l=0.106066 //layer=ply \
 //thickness=0.18 //x=32.345 //y=4.97 //x2=32.42 //y2=5.045
r446 (  101 102 ) resistor r=123.064 //w=0.094 //l=0.24 //layer=ply \
 //thickness=0.18 //x=32.345 //y=4.97 //x2=32.105 //y2=4.97
r447 (  96 150 ) resistor r=39.5823 //w=0.21 //l=0.173853 //layer=ply \
 //thickness=0.18 //x=31.975 //y=1.74 //x2=32.015 //y2=1.585
r448 (  96 142 ) resistor r=182.032 //w=0.094 //l=0.355 //layer=ply \
 //thickness=0.18 //x=31.975 //y=1.74 //x2=31.975 //y2=2.095
r449 (  95 150 ) resistor r=39.5823 //w=0.21 //l=0.173853 //layer=ply \
 //thickness=0.18 //x=31.975 //y=1.43 //x2=32.015 //y2=1.585
r450 (  94 149 ) resistor r=45.1352 //w=0.168 //l=0.173853 //layer=ply \
 //thickness=0.18 //x=31.975 //y=1.085 //x2=32.015 //y2=0.93
r451 (  94 95 ) resistor r=176.904 //w=0.094 //l=0.345 //layer=ply \
 //thickness=0.18 //x=31.975 //y=1.085 //x2=31.975 //y2=1.43
r452 (  89 91 ) resistor r=26.9307 //w=0.15 //l=0.106066 //layer=ply \
 //thickness=0.18 //x=23.625 //y=4.97 //x2=23.7 //y2=5.045
r453 (  89 90 ) resistor r=148.702 //w=0.094 //l=0.29 //layer=ply \
 //thickness=0.18 //x=23.625 //y=4.97 //x2=23.335 //y2=4.97
r454 (  88 139 ) resistor r=45.1352 //w=0.168 //l=0.173853 //layer=ply \
 //thickness=0.18 //x=23.29 //y=1.4 //x2=23.25 //y2=1.555
r455 (  87 138 ) resistor r=45.1352 //w=0.168 //l=0.173853 //layer=ply \
 //thickness=0.18 //x=23.29 //y=1.055 //x2=23.25 //y2=0.9
r456 (  87 88 ) resistor r=176.904 //w=0.094 //l=0.345 //layer=ply \
 //thickness=0.18 //x=23.29 //y=1.055 //x2=23.29 //y2=1.4
r457 (  84 90 ) resistor r=22.7971 //w=0.269 //l=0.106066 //layer=ply \
 //thickness=0.18 //x=23.26 //y=5.045 //x2=23.335 //y2=4.97
r458 (  84 137 ) resistor r=35.8364 //w=0.269 //l=0.270185 //layer=ply \
 //thickness=0.18 //x=23.26 //y=5.045 //x2=23.06 //y2=4.88
r459 (  82 133 ) resistor r=10.701 //w=0.21 //l=0.115 //layer=ply \
 //thickness=0.18 //x=22.915 //y=1.555 //x2=22.8 //y2=1.555
r460 (  81 139 ) resistor r=5.52526 //w=0.168 //l=0.115 //layer=ply \
 //thickness=0.18 //x=23.135 //y=1.555 //x2=23.25 //y2=1.555
r461 (  80 132 ) resistor r=5.52526 //w=0.168 //l=0.115 //layer=ply \
 //thickness=0.18 //x=22.915 //y=0.9 //x2=22.8 //y2=0.9
r462 (  79 138 ) resistor r=5.52526 //w=0.168 //l=0.115 //layer=ply \
 //thickness=0.18 //x=23.135 //y=0.9 //x2=23.25 //y2=0.9
r463 (  79 80 ) resistor r=112.809 //w=0.094 //l=0.22 //layer=ply \
 //thickness=0.18 //x=23.135 //y=0.9 //x2=22.915 //y2=0.9
r464 (  78 135 ) resistor r=58.7805 //w=0.246 //l=0.373497 //layer=ply \
 //thickness=0.18 //x=22.76 //y=2.095 //x2=23.06 //y2=2.26
r465 (  77 133 ) resistor r=39.5823 //w=0.21 //l=0.173853 //layer=ply \
 //thickness=0.18 //x=22.76 //y=1.71 //x2=22.8 //y2=1.555
r466 (  77 78 ) resistor r=197.415 //w=0.094 //l=0.385 //layer=ply \
 //thickness=0.18 //x=22.76 //y=1.71 //x2=22.76 //y2=2.095
r467 (  76 133 ) resistor r=39.5823 //w=0.21 //l=0.173853 //layer=ply \
 //thickness=0.18 //x=22.76 //y=1.4 //x2=22.8 //y2=1.555
r468 (  75 132 ) resistor r=45.1352 //w=0.168 //l=0.173853 //layer=ply \
 //thickness=0.18 //x=22.76 //y=1.055 //x2=22.8 //y2=0.9
r469 (  75 76 ) resistor r=176.904 //w=0.094 //l=0.345 //layer=ply \
 //thickness=0.18 //x=22.76 //y=1.055 //x2=22.76 //y2=1.4
r470 (  74 127 ) resistor r=592.245 //w=0.094 //l=1.155 //layer=ply \
 //thickness=0.18 //x=42.41 //y=6.2 //x2=42.41 //y2=5.045
r471 (  73 161 ) resistor r=592.245 //w=0.094 //l=1.155 //layer=ply \
 //thickness=0.18 //x=41.97 //y=6.2 //x2=41.97 //y2=5.045
r472 (  72 108 ) resistor r=592.245 //w=0.094 //l=1.155 //layer=ply \
 //thickness=0.18 //x=32.42 //y=6.2 //x2=32.42 //y2=5.045
r473 (  71 148 ) resistor r=592.245 //w=0.094 //l=1.155 //layer=ply \
 //thickness=0.18 //x=31.98 //y=6.2 //x2=31.98 //y2=5.045
r474 (  70 91 ) resistor r=592.245 //w=0.094 //l=1.155 //layer=ply \
 //thickness=0.18 //x=23.7 //y=6.2 //x2=23.7 //y2=5.045
r475 (  69 84 ) resistor r=592.245 //w=0.094 //l=1.155 //layer=ply \
 //thickness=0.18 //x=23.26 //y=6.2 //x2=23.26 //y2=5.045
r476 (  68 124 ) resistor r=56.4043 //w=0.094 //l=0.11 //layer=ply \
 //thickness=0.18 //x=42.23 //y=1.585 //x2=42.34 //y2=1.585
r477 (  68 125 ) resistor r=56.4043 //w=0.094 //l=0.11 //layer=ply \
 //thickness=0.18 //x=42.23 //y=1.585 //x2=42.12 //y2=1.585
r478 (  67 105 ) resistor r=56.4043 //w=0.094 //l=0.11 //layer=ply \
 //thickness=0.18 //x=32.24 //y=1.585 //x2=32.35 //y2=1.585
r479 (  67 106 ) resistor r=56.4043 //w=0.094 //l=0.11 //layer=ply \
 //thickness=0.18 //x=32.24 //y=1.585 //x2=32.13 //y2=1.585
r480 (  66 81 ) resistor r=56.4043 //w=0.094 //l=0.11 //layer=ply \
 //thickness=0.18 //x=23.025 //y=1.555 //x2=23.135 //y2=1.555
r481 (  66 82 ) resistor r=56.4043 //w=0.094 //l=0.11 //layer=ply \
 //thickness=0.18 //x=23.025 //y=1.555 //x2=22.915 //y2=1.555
r482 (  65 158 ) resistor r=152 //w=0.17 //l=0.17 //layer=licon //count=1 \
 //x=41.96 //y=4.88 //x2=41.96 //y2=4.88
r483 (  62 145 ) resistor r=152 //w=0.17 //l=0.17 //layer=licon //count=1 \
 //x=31.97 //y=4.88 //x2=31.97 //y2=4.88
r484 (  57 154 ) resistor r=152 //w=0.17 //l=0.17 //layer=licon //count=1 \
 //x=41.93 //y=2.26 //x2=41.93 //y2=2.26
r485 (  57 60 ) resistor r=136.214 //w=0.187 //l=1.99 //layer=li \
 //thickness=0.1 //x=41.93 //y=2.26 //x2=41.93 //y2=4.25
r486 (  55 65 ) resistor r=11.4737 //w=0.186 //l=0.172337 //layer=li \
 //thickness=0.1 //x=41.93 //y=4.715 //x2=41.945 //y2=4.88
r487 (  55 60 ) resistor r=31.8289 //w=0.187 //l=0.465 //layer=li \
 //thickness=0.1 //x=41.93 //y=4.715 //x2=41.93 //y2=4.25
r488 (  52 54 ) resistor r=71.5294 //w=0.187 //l=1.045 //layer=li \
 //thickness=0.1 //x=36.01 //y=5.295 //x2=36.01 //y2=4.25
r489 (  51 54 ) resistor r=159.487 //w=0.187 //l=2.33 //layer=li \
 //thickness=0.1 //x=36.01 //y=1.92 //x2=36.01 //y2=4.25
r490 (  49 51 ) resistor r=7.15173 //w=0.17 //l=0.120208 //layer=li \
 //thickness=0.1 //x=35.925 //y=1.835 //x2=36.01 //y2=1.92
r491 (  49 50 ) resistor r=18.4813 //w=0.187 //l=0.27 //layer=li \
 //thickness=0.1 //x=35.925 //y=1.835 //x2=35.655 //y2=1.835
r492 (  48 63 ) resistor r=5.4201 //w=0.17 //l=0.085 //layer=li \
 //thickness=0.1 //x=35.615 //y=5.38 //x2=35.53 //y2=5.38
r493 (  47 52 ) resistor r=7.15173 //w=0.17 //l=0.120208 //layer=li \
 //thickness=0.1 //x=35.925 //y=5.38 //x2=36.01 //y2=5.295
r494 (  47 48 ) resistor r=21.2193 //w=0.187 //l=0.31 //layer=li \
 //thickness=0.1 //x=35.925 //y=5.38 //x2=35.615 //y2=5.38
r495 (  43 50 ) resistor r=7.15173 //w=0.17 //l=0.120208 //layer=li \
 //thickness=0.1 //x=35.57 //y=1.75 //x2=35.655 //y2=1.835
r496 (  43 166 ) resistor r=39.016 //w=0.187 //l=0.57 //layer=li \
 //thickness=0.1 //x=35.57 //y=1.75 //x2=35.57 //y2=1.18
r497 (  37 63 ) resistor r=1.40859 //w=0.34 //l=0.085 //layer=li \
 //thickness=0.1 //x=35.53 //y=5.465 //x2=35.53 //y2=5.38
r498 (  37 169 ) resistor r=30.1176 //w=0.187 //l=0.44 //layer=li \
 //thickness=0.1 //x=35.53 //y=5.465 //x2=35.53 //y2=5.905
r499 (  35 63 ) resistor r=5.4201 //w=0.17 //l=0.085 //layer=li \
 //thickness=0.1 //x=35.445 //y=5.38 //x2=35.53 //y2=5.38
r500 (  35 36 ) resistor r=48.5989 //w=0.187 //l=0.71 //layer=li \
 //thickness=0.1 //x=35.445 //y=5.38 //x2=34.735 //y2=5.38
r501 (  29 36 ) resistor r=7.15173 //w=0.17 //l=0.120208 //layer=li \
 //thickness=0.1 //x=34.65 //y=5.465 //x2=34.735 //y2=5.38
r502 (  29 168 ) resistor r=30.1176 //w=0.187 //l=0.44 //layer=li \
 //thickness=0.1 //x=34.65 //y=5.465 //x2=34.65 //y2=5.905
r503 (  25 141 ) resistor r=152 //w=0.17 //l=0.17 //layer=licon //count=1 \
 //x=31.94 //y=2.26 //x2=31.94 //y2=2.26
r504 (  25 28 ) resistor r=136.214 //w=0.187 //l=1.99 //layer=li \
 //thickness=0.1 //x=31.94 //y=2.26 //x2=31.94 //y2=4.25
r505 (  23 62 ) resistor r=11.4737 //w=0.186 //l=0.172337 //layer=li \
 //thickness=0.1 //x=31.94 //y=4.715 //x2=31.955 //y2=4.88
r506 (  23 28 ) resistor r=31.8289 //w=0.187 //l=0.465 //layer=li \
 //thickness=0.1 //x=31.94 //y=4.715 //x2=31.94 //y2=4.25
r507 (  21 137 ) resistor r=152 //w=0.17 //l=0.17 //layer=licon //count=1 \
 //x=23.06 //y=4.88 //x2=23.06 //y2=4.88
r508 (  19 21 ) resistor r=43.123 //w=0.187 //l=0.63 //layer=li \
 //thickness=0.1 //x=23.06 //y=4.25 //x2=23.06 //y2=4.88
r509 (  16 135 ) resistor r=152 //w=0.17 //l=0.17 //layer=licon //count=1 \
 //x=23.06 //y=2.26 //x2=23.06 //y2=2.26
r510 (  16 19 ) resistor r=136.214 //w=0.187 //l=1.99 //layer=li \
 //thickness=0.1 //x=23.06 //y=2.26 //x2=23.06 //y2=4.25
r511 (  14 60 ) resistor r=9.3 //w=0.17 //l=0.17 //layer=mcon //count=1 \
 //x=41.93 //y=4.25 //x2=41.93 //y2=4.25
r512 (  12 54 ) resistor r=9.3 //w=0.17 //l=0.17 //layer=mcon //count=1 \
 //x=36.01 //y=4.25 //x2=36.01 //y2=4.25
r513 (  10 28 ) resistor r=9.3 //w=0.17 //l=0.17 //layer=mcon //count=1 \
 //x=31.94 //y=4.25 //x2=31.94 //y2=4.25
r514 (  8 19 ) resistor r=9.3 //w=0.17 //l=0.17 //layer=mcon //count=1 \
 //x=23.06 //y=4.25 //x2=23.06 //y2=4.25
r515 (  6 12 ) resistor r=0.0880901 //w=0.191 //l=0.115 //layer=m1 \
 //thickness=0.36 //x=36.125 //y=4.25 //x2=36.01 //y2=4.25
r516 (  5 14 ) resistor r=0.0717383 //w=0.224 //l=0.115 //layer=m1 \
 //thickness=0.36 //x=41.815 //y=4.25 //x2=41.93 //y2=4.25
r517 (  5 6 ) resistor r=5.42939 //w=0.131 //l=5.69 //layer=m1 \
 //thickness=0.36 //x=41.815 //y=4.25 //x2=36.125 //y2=4.25
r518 (  4 10 ) resistor r=0.0880901 //w=0.191 //l=0.115 //layer=m1 \
 //thickness=0.36 //x=32.055 //y=4.25 //x2=31.94 //y2=4.25
r519 (  3 12 ) resistor r=0.0880901 //w=0.191 //l=0.115 //layer=m1 \
 //thickness=0.36 //x=35.895 //y=4.25 //x2=36.01 //y2=4.25
r520 (  3 4 ) resistor r=3.66412 //w=0.131 //l=3.84 //layer=m1 \
 //thickness=0.36 //x=35.895 //y=4.25 //x2=32.055 //y2=4.25
r521 (  2 8 ) resistor r=0.0717383 //w=0.224 //l=0.115 //layer=m1 \
 //thickness=0.36 //x=23.175 //y=4.25 //x2=23.06 //y2=4.25
r522 (  1 10 ) resistor r=0.0880901 //w=0.191 //l=0.115 //layer=m1 \
 //thickness=0.36 //x=31.825 //y=4.25 //x2=31.94 //y2=4.25
r523 (  1 2 ) resistor r=8.25382 //w=0.131 //l=8.65 //layer=m1 \
 //thickness=0.36 //x=31.825 //y=4.25 //x2=23.175 //y2=4.25
ends PM_TMRDFFQX1\%noxref_12

subckt PM_TMRDFFQX1\%D ( 1 2 3 4 11 12 13 14 15 17 22 24 28 30 40 41 42 43 44 \
 45 46 47 48 49 50 51 56 58 60 66 67 68 69 70 75 77 79 85 86 87 88 89 94 96 98 \
 104 105 107 108 111 120 121 124 133 134 137 )
c424 ( 137 0 ) capacitor c=0.0331095f //x=50.1 //y=4.88
c425 ( 134 0 ) capacitor c=0.0279499f //x=50.07 //y=2.095
c426 ( 133 0 ) capacitor c=0.0421676f //x=50.07 //y=2.26
c427 ( 124 0 ) capacitor c=0.0331095f //x=28.64 //y=4.88
c428 ( 121 0 ) capacitor c=0.0279499f //x=28.61 //y=2.095
c429 ( 120 0 ) capacitor c=0.0421262f //x=28.61 //y=2.26
c430 ( 111 0 ) capacitor c=0.0331095f //x=7.18 //y=4.88
c431 ( 108 0 ) capacitor c=0.0279499f //x=7.15 //y=2.095
c432 ( 107 0 ) capacitor c=0.0421262f //x=7.15 //y=2.26
c433 ( 105 0 ) capacitor c=0.0429696f //x=50.635 //y=1.43
c434 ( 104 0 ) capacitor c=0.0192208f //x=50.635 //y=1.085
c435 ( 98 0 ) capacitor c=0.0148884f //x=50.48 //y=1.585
c436 ( 96 0 ) capacitor c=0.0157803f //x=50.48 //y=0.93
c437 ( 94 0 ) capacitor c=0.0295235f //x=50.475 //y=4.97
c438 ( 89 0 ) capacitor c=0.0204188f //x=50.105 //y=1.74
c439 ( 88 0 ) capacitor c=0.0168481f //x=50.105 //y=1.43
c440 ( 87 0 ) capacitor c=0.0174783f //x=50.105 //y=1.085
c441 ( 86 0 ) capacitor c=0.0429696f //x=29.175 //y=1.43
c442 ( 85 0 ) capacitor c=0.0192208f //x=29.175 //y=1.085
c443 ( 79 0 ) capacitor c=0.0158629f //x=29.02 //y=1.585
c444 ( 77 0 ) capacitor c=0.0157803f //x=29.02 //y=0.93
c445 ( 75 0 ) capacitor c=0.0295235f //x=29.015 //y=4.97
c446 ( 70 0 ) capacitor c=0.0204188f //x=28.645 //y=1.74
c447 ( 69 0 ) capacitor c=0.0168481f //x=28.645 //y=1.43
c448 ( 68 0 ) capacitor c=0.0174783f //x=28.645 //y=1.085
c449 ( 67 0 ) capacitor c=0.0429696f //x=7.715 //y=1.43
c450 ( 66 0 ) capacitor c=0.0192208f //x=7.715 //y=1.085
c451 ( 60 0 ) capacitor c=0.0158629f //x=7.56 //y=1.585
c452 ( 58 0 ) capacitor c=0.0157803f //x=7.56 //y=0.93
c453 ( 56 0 ) capacitor c=0.0295235f //x=7.555 //y=4.97
c454 ( 51 0 ) capacitor c=0.0204188f //x=7.185 //y=1.74
c455 ( 50 0 ) capacitor c=0.0168481f //x=7.185 //y=1.43
c456 ( 49 0 ) capacitor c=0.0174783f //x=7.185 //y=1.085
c457 ( 48 0 ) capacitor c=0.15358f //x=50.55 //y=6.2
c458 ( 47 0 ) capacitor c=0.110281f //x=50.11 //y=6.2
c459 ( 46 0 ) capacitor c=0.15358f //x=29.09 //y=6.2
c460 ( 45 0 ) capacitor c=0.110281f //x=28.65 //y=6.2
c461 ( 44 0 ) capacitor c=0.15358f //x=7.63 //y=6.2
c462 ( 43 0 ) capacitor c=0.110281f //x=7.19 //y=6.2
c463 ( 30 0 ) capacitor c=0.0671606f //x=50.07 //y=2.26
c464 ( 28 0 ) capacitor c=0.00453889f //x=50.07 //y=4.715
c465 ( 24 0 ) capacitor c=0.069138f //x=28.61 //y=2.26
c466 ( 22 0 ) capacitor c=0.00453889f //x=28.61 //y=4.715
c467 ( 17 0 ) capacitor c=0.0711209f //x=7.15 //y=2.26
c468 ( 15 0 ) capacitor c=0.00453889f //x=7.15 //y=4.715
c469 ( 4 0 ) capacitor c=0.0070827f //x=28.725 //y=2.77
c470 ( 3 0 ) capacitor c=0.371601f //x=49.955 //y=2.77
c471 ( 2 0 ) capacitor c=0.0159421f //x=7.265 //y=2.77
c472 ( 1 0 ) capacitor c=0.508623f //x=28.495 //y=2.77
r473 (  139 140 ) resistor r=32.4568 //w=0.214 //l=0.075 //layer=ply \
 //thickness=0.18 //x=50.1 //y=4.97 //x2=50.1 //y2=5.045
r474 (  137 139 ) resistor r=20.271 //w=0.214 //l=0.09 //layer=ply \
 //thickness=0.18 //x=50.1 //y=4.88 //x2=50.1 //y2=4.97
r475 (  133 134 ) resistor r=52.7279 //w=0.214 //l=0.165 //layer=ply \
 //thickness=0.18 //x=50.07 //y=2.26 //x2=50.07 //y2=2.095
r476 (  126 127 ) resistor r=32.4568 //w=0.214 //l=0.075 //layer=ply \
 //thickness=0.18 //x=28.64 //y=4.97 //x2=28.64 //y2=5.045
r477 (  124 126 ) resistor r=20.271 //w=0.214 //l=0.09 //layer=ply \
 //thickness=0.18 //x=28.64 //y=4.88 //x2=28.64 //y2=4.97
r478 (  120 121 ) resistor r=52.7279 //w=0.214 //l=0.165 //layer=ply \
 //thickness=0.18 //x=28.61 //y=2.26 //x2=28.61 //y2=2.095
r479 (  113 114 ) resistor r=32.4568 //w=0.214 //l=0.075 //layer=ply \
 //thickness=0.18 //x=7.18 //y=4.97 //x2=7.18 //y2=5.045
r480 (  111 113 ) resistor r=20.271 //w=0.214 //l=0.09 //layer=ply \
 //thickness=0.18 //x=7.18 //y=4.88 //x2=7.18 //y2=4.97
r481 (  107 108 ) resistor r=52.7279 //w=0.214 //l=0.165 //layer=ply \
 //thickness=0.18 //x=7.15 //y=2.26 //x2=7.15 //y2=2.095
r482 (  105 144 ) resistor r=45.1352 //w=0.168 //l=0.173853 //layer=ply \
 //thickness=0.18 //x=50.635 //y=1.43 //x2=50.595 //y2=1.585
r483 (  104 143 ) resistor r=45.1352 //w=0.168 //l=0.173853 //layer=ply \
 //thickness=0.18 //x=50.635 //y=1.085 //x2=50.595 //y2=0.93
r484 (  104 105 ) resistor r=176.904 //w=0.094 //l=0.345 //layer=ply \
 //thickness=0.18 //x=50.635 //y=1.085 //x2=50.635 //y2=1.43
r485 (  99 142 ) resistor r=10.701 //w=0.21 //l=0.115 //layer=ply \
 //thickness=0.18 //x=50.26 //y=1.585 //x2=50.145 //y2=1.585
r486 (  98 144 ) resistor r=5.52526 //w=0.168 //l=0.115 //layer=ply \
 //thickness=0.18 //x=50.48 //y=1.585 //x2=50.595 //y2=1.585
r487 (  97 141 ) resistor r=5.52526 //w=0.168 //l=0.115 //layer=ply \
 //thickness=0.18 //x=50.26 //y=0.93 //x2=50.145 //y2=0.93
r488 (  96 143 ) resistor r=5.52526 //w=0.168 //l=0.115 //layer=ply \
 //thickness=0.18 //x=50.48 //y=0.93 //x2=50.595 //y2=0.93
r489 (  96 97 ) resistor r=112.809 //w=0.094 //l=0.22 //layer=ply \
 //thickness=0.18 //x=50.48 //y=0.93 //x2=50.26 //y2=0.93
r490 (  95 139 ) resistor r=16.5046 //w=0.27 //l=0.135 //layer=ply \
 //thickness=0.18 //x=50.235 //y=4.97 //x2=50.1 //y2=4.97
r491 (  94 101 ) resistor r=26.9307 //w=0.15 //l=0.106066 //layer=ply \
 //thickness=0.18 //x=50.475 //y=4.97 //x2=50.55 //y2=5.045
r492 (  94 95 ) resistor r=123.064 //w=0.094 //l=0.24 //layer=ply \
 //thickness=0.18 //x=50.475 //y=4.97 //x2=50.235 //y2=4.97
r493 (  89 142 ) resistor r=39.5823 //w=0.21 //l=0.173853 //layer=ply \
 //thickness=0.18 //x=50.105 //y=1.74 //x2=50.145 //y2=1.585
r494 (  89 134 ) resistor r=182.032 //w=0.094 //l=0.355 //layer=ply \
 //thickness=0.18 //x=50.105 //y=1.74 //x2=50.105 //y2=2.095
r495 (  88 142 ) resistor r=39.5823 //w=0.21 //l=0.173853 //layer=ply \
 //thickness=0.18 //x=50.105 //y=1.43 //x2=50.145 //y2=1.585
r496 (  87 141 ) resistor r=45.1352 //w=0.168 //l=0.173853 //layer=ply \
 //thickness=0.18 //x=50.105 //y=1.085 //x2=50.145 //y2=0.93
r497 (  87 88 ) resistor r=176.904 //w=0.094 //l=0.345 //layer=ply \
 //thickness=0.18 //x=50.105 //y=1.085 //x2=50.105 //y2=1.43
r498 (  86 131 ) resistor r=45.1352 //w=0.168 //l=0.173853 //layer=ply \
 //thickness=0.18 //x=29.175 //y=1.43 //x2=29.135 //y2=1.585
r499 (  85 130 ) resistor r=45.1352 //w=0.168 //l=0.173853 //layer=ply \
 //thickness=0.18 //x=29.175 //y=1.085 //x2=29.135 //y2=0.93
r500 (  85 86 ) resistor r=176.904 //w=0.094 //l=0.345 //layer=ply \
 //thickness=0.18 //x=29.175 //y=1.085 //x2=29.175 //y2=1.43
r501 (  80 129 ) resistor r=10.701 //w=0.21 //l=0.115 //layer=ply \
 //thickness=0.18 //x=28.8 //y=1.585 //x2=28.685 //y2=1.585
r502 (  79 131 ) resistor r=5.52526 //w=0.168 //l=0.115 //layer=ply \
 //thickness=0.18 //x=29.02 //y=1.585 //x2=29.135 //y2=1.585
r503 (  78 128 ) resistor r=5.52526 //w=0.168 //l=0.115 //layer=ply \
 //thickness=0.18 //x=28.8 //y=0.93 //x2=28.685 //y2=0.93
r504 (  77 130 ) resistor r=5.52526 //w=0.168 //l=0.115 //layer=ply \
 //thickness=0.18 //x=29.02 //y=0.93 //x2=29.135 //y2=0.93
r505 (  77 78 ) resistor r=112.809 //w=0.094 //l=0.22 //layer=ply \
 //thickness=0.18 //x=29.02 //y=0.93 //x2=28.8 //y2=0.93
r506 (  76 126 ) resistor r=16.5046 //w=0.27 //l=0.135 //layer=ply \
 //thickness=0.18 //x=28.775 //y=4.97 //x2=28.64 //y2=4.97
r507 (  75 82 ) resistor r=26.9307 //w=0.15 //l=0.106066 //layer=ply \
 //thickness=0.18 //x=29.015 //y=4.97 //x2=29.09 //y2=5.045
r508 (  75 76 ) resistor r=123.064 //w=0.094 //l=0.24 //layer=ply \
 //thickness=0.18 //x=29.015 //y=4.97 //x2=28.775 //y2=4.97
r509 (  70 129 ) resistor r=39.5823 //w=0.21 //l=0.173853 //layer=ply \
 //thickness=0.18 //x=28.645 //y=1.74 //x2=28.685 //y2=1.585
r510 (  70 121 ) resistor r=182.032 //w=0.094 //l=0.355 //layer=ply \
 //thickness=0.18 //x=28.645 //y=1.74 //x2=28.645 //y2=2.095
r511 (  69 129 ) resistor r=39.5823 //w=0.21 //l=0.173853 //layer=ply \
 //thickness=0.18 //x=28.645 //y=1.43 //x2=28.685 //y2=1.585
r512 (  68 128 ) resistor r=45.1352 //w=0.168 //l=0.173853 //layer=ply \
 //thickness=0.18 //x=28.645 //y=1.085 //x2=28.685 //y2=0.93
r513 (  68 69 ) resistor r=176.904 //w=0.094 //l=0.345 //layer=ply \
 //thickness=0.18 //x=28.645 //y=1.085 //x2=28.645 //y2=1.43
r514 (  67 118 ) resistor r=45.1352 //w=0.168 //l=0.173853 //layer=ply \
 //thickness=0.18 //x=7.715 //y=1.43 //x2=7.675 //y2=1.585
r515 (  66 117 ) resistor r=45.1352 //w=0.168 //l=0.173853 //layer=ply \
 //thickness=0.18 //x=7.715 //y=1.085 //x2=7.675 //y2=0.93
r516 (  66 67 ) resistor r=176.904 //w=0.094 //l=0.345 //layer=ply \
 //thickness=0.18 //x=7.715 //y=1.085 //x2=7.715 //y2=1.43
r517 (  61 116 ) resistor r=10.701 //w=0.21 //l=0.115 //layer=ply \
 //thickness=0.18 //x=7.34 //y=1.585 //x2=7.225 //y2=1.585
r518 (  60 118 ) resistor r=5.52526 //w=0.168 //l=0.115 //layer=ply \
 //thickness=0.18 //x=7.56 //y=1.585 //x2=7.675 //y2=1.585
r519 (  59 115 ) resistor r=5.52526 //w=0.168 //l=0.115 //layer=ply \
 //thickness=0.18 //x=7.34 //y=0.93 //x2=7.225 //y2=0.93
r520 (  58 117 ) resistor r=5.52526 //w=0.168 //l=0.115 //layer=ply \
 //thickness=0.18 //x=7.56 //y=0.93 //x2=7.675 //y2=0.93
r521 (  58 59 ) resistor r=112.809 //w=0.094 //l=0.22 //layer=ply \
 //thickness=0.18 //x=7.56 //y=0.93 //x2=7.34 //y2=0.93
r522 (  57 113 ) resistor r=16.5046 //w=0.27 //l=0.135 //layer=ply \
 //thickness=0.18 //x=7.315 //y=4.97 //x2=7.18 //y2=4.97
r523 (  56 63 ) resistor r=26.9307 //w=0.15 //l=0.106066 //layer=ply \
 //thickness=0.18 //x=7.555 //y=4.97 //x2=7.63 //y2=5.045
r524 (  56 57 ) resistor r=123.064 //w=0.094 //l=0.24 //layer=ply \
 //thickness=0.18 //x=7.555 //y=4.97 //x2=7.315 //y2=4.97
r525 (  51 116 ) resistor r=39.5823 //w=0.21 //l=0.173853 //layer=ply \
 //thickness=0.18 //x=7.185 //y=1.74 //x2=7.225 //y2=1.585
r526 (  51 108 ) resistor r=182.032 //w=0.094 //l=0.355 //layer=ply \
 //thickness=0.18 //x=7.185 //y=1.74 //x2=7.185 //y2=2.095
r527 (  50 116 ) resistor r=39.5823 //w=0.21 //l=0.173853 //layer=ply \
 //thickness=0.18 //x=7.185 //y=1.43 //x2=7.225 //y2=1.585
r528 (  49 115 ) resistor r=45.1352 //w=0.168 //l=0.173853 //layer=ply \
 //thickness=0.18 //x=7.185 //y=1.085 //x2=7.225 //y2=0.93
r529 (  49 50 ) resistor r=176.904 //w=0.094 //l=0.345 //layer=ply \
 //thickness=0.18 //x=7.185 //y=1.085 //x2=7.185 //y2=1.43
r530 (  48 101 ) resistor r=592.245 //w=0.094 //l=1.155 //layer=ply \
 //thickness=0.18 //x=50.55 //y=6.2 //x2=50.55 //y2=5.045
r531 (  47 140 ) resistor r=592.245 //w=0.094 //l=1.155 //layer=ply \
 //thickness=0.18 //x=50.11 //y=6.2 //x2=50.11 //y2=5.045
r532 (  46 82 ) resistor r=592.245 //w=0.094 //l=1.155 //layer=ply \
 //thickness=0.18 //x=29.09 //y=6.2 //x2=29.09 //y2=5.045
r533 (  45 127 ) resistor r=592.245 //w=0.094 //l=1.155 //layer=ply \
 //thickness=0.18 //x=28.65 //y=6.2 //x2=28.65 //y2=5.045
r534 (  44 63 ) resistor r=592.245 //w=0.094 //l=1.155 //layer=ply \
 //thickness=0.18 //x=7.63 //y=6.2 //x2=7.63 //y2=5.045
r535 (  43 114 ) resistor r=592.245 //w=0.094 //l=1.155 //layer=ply \
 //thickness=0.18 //x=7.19 //y=6.2 //x2=7.19 //y2=5.045
r536 (  42 98 ) resistor r=56.4043 //w=0.094 //l=0.11 //layer=ply \
 //thickness=0.18 //x=50.37 //y=1.585 //x2=50.48 //y2=1.585
r537 (  42 99 ) resistor r=56.4043 //w=0.094 //l=0.11 //layer=ply \
 //thickness=0.18 //x=50.37 //y=1.585 //x2=50.26 //y2=1.585
r538 (  41 79 ) resistor r=56.4043 //w=0.094 //l=0.11 //layer=ply \
 //thickness=0.18 //x=28.91 //y=1.585 //x2=29.02 //y2=1.585
r539 (  41 80 ) resistor r=56.4043 //w=0.094 //l=0.11 //layer=ply \
 //thickness=0.18 //x=28.91 //y=1.585 //x2=28.8 //y2=1.585
r540 (  40 60 ) resistor r=56.4043 //w=0.094 //l=0.11 //layer=ply \
 //thickness=0.18 //x=7.45 //y=1.585 //x2=7.56 //y2=1.585
r541 (  40 61 ) resistor r=56.4043 //w=0.094 //l=0.11 //layer=ply \
 //thickness=0.18 //x=7.45 //y=1.585 //x2=7.34 //y2=1.585
r542 (  39 137 ) resistor r=152 //w=0.17 //l=0.17 //layer=licon //count=1 \
 //x=50.1 //y=4.88 //x2=50.1 //y2=4.88
r543 (  37 124 ) resistor r=152 //w=0.17 //l=0.17 //layer=licon //count=1 \
 //x=28.64 //y=4.88 //x2=28.64 //y2=4.88
r544 (  35 111 ) resistor r=152 //w=0.17 //l=0.17 //layer=licon //count=1 \
 //x=7.18 //y=4.88 //x2=7.18 //y2=4.88
r545 (  30 133 ) resistor r=152 //w=0.17 //l=0.17 //layer=licon //count=1 \
 //x=50.07 //y=2.26 //x2=50.07 //y2=2.26
r546 (  28 39 ) resistor r=11.4737 //w=0.186 //l=0.172337 //layer=li \
 //thickness=0.1 //x=50.07 //y=4.715 //x2=50.085 //y2=4.88
r547 (  24 120 ) resistor r=152 //w=0.17 //l=0.17 //layer=licon //count=1 \
 //x=28.61 //y=2.26 //x2=28.61 //y2=2.26
r548 (  22 37 ) resistor r=11.4737 //w=0.186 //l=0.172337 //layer=li \
 //thickness=0.1 //x=28.61 //y=4.715 //x2=28.625 //y2=4.88
r549 (  17 107 ) resistor r=152 //w=0.17 //l=0.17 //layer=licon //count=1 \
 //x=7.15 //y=2.26 //x2=7.15 //y2=2.26
r550 (  15 35 ) resistor r=11.4737 //w=0.186 //l=0.172337 //layer=li \
 //thickness=0.1 //x=7.15 //y=4.715 //x2=7.165 //y2=4.88
r551 (  14 28 ) resistor r=133.134 //w=0.187 //l=1.945 //layer=li \
 //thickness=0.1 //x=50.07 //y=2.77 //x2=50.07 //y2=4.715
r552 (  14 30 ) resistor r=34.9091 //w=0.187 //l=0.51 //layer=li \
 //thickness=0.1 //x=50.07 //y=2.77 //x2=50.07 //y2=2.26
r553 (  13 22 ) resistor r=133.134 //w=0.187 //l=1.945 //layer=li \
 //thickness=0.1 //x=28.61 //y=2.77 //x2=28.61 //y2=4.715
r554 (  13 24 ) resistor r=34.9091 //w=0.187 //l=0.51 //layer=li \
 //thickness=0.1 //x=28.61 //y=2.77 //x2=28.61 //y2=2.26
r555 (  12 15 ) resistor r=107.807 //w=0.187 //l=1.575 //layer=li \
 //thickness=0.1 //x=7.15 //y=3.14 //x2=7.15 //y2=4.715
r556 (  11 12 ) resistor r=25.3262 //w=0.187 //l=0.37 //layer=li \
 //thickness=0.1 //x=7.15 //y=2.77 //x2=7.15 //y2=3.14
r557 (  11 17 ) resistor r=34.9091 //w=0.187 //l=0.51 //layer=li \
 //thickness=0.1 //x=7.15 //y=2.77 //x2=7.15 //y2=2.26
r558 (  10 14 ) resistor r=9.3 //w=0.17 //l=0.17 //layer=mcon //count=1 \
 //x=50.07 //y=2.77 //x2=50.07 //y2=2.77
r559 (  8 13 ) resistor r=9.3 //w=0.17 //l=0.17 //layer=mcon //count=1 \
 //x=28.61 //y=2.77 //x2=28.61 //y2=2.77
r560 (  6 11 ) resistor r=9.3 //w=0.17 //l=0.17 //layer=mcon //count=1 \
 //x=7.15 //y=2.77 //x2=7.15 //y2=2.77
r561 (  4 8 ) resistor r=0.0880901 //w=0.191 //l=0.115 //layer=m1 \
 //thickness=0.36 //x=28.725 //y=2.77 //x2=28.61 //y2=2.77
r562 (  3 10 ) resistor r=0.0717383 //w=0.224 //l=0.115 //layer=m1 \
 //thickness=0.36 //x=49.955 //y=2.77 //x2=50.07 //y2=2.77
r563 (  3 4 ) resistor r=20.2576 //w=0.131 //l=21.23 //layer=m1 \
 //thickness=0.36 //x=49.955 //y=2.77 //x2=28.725 //y2=2.77
r564 (  2 6 ) resistor r=0.0717383 //w=0.224 //l=0.115 //layer=m1 \
 //thickness=0.36 //x=7.265 //y=2.77 //x2=7.15 //y2=2.77
r565 (  1 8 ) resistor r=0.0880901 //w=0.191 //l=0.115 //layer=m1 \
 //thickness=0.36 //x=28.495 //y=2.77 //x2=28.61 //y2=2.77
r566 (  1 2 ) resistor r=20.2576 //w=0.131 //l=21.23 //layer=m1 \
 //thickness=0.36 //x=28.495 //y=2.77 //x2=7.265 //y2=2.77
ends PM_TMRDFFQX1\%D

subckt PM_TMRDFFQX1\%noxref_14 ( 1 2 3 4 12 25 26 37 39 40 44 46 53 54 55 56 \
 57 58 59 63 64 65 70 72 75 76 77 78 79 80 84 86 89 90 95 96 101 110 113 115 \
 116 )
c233 ( 116 0 ) capacitor c=0.0220291f //x=50.185 //y=5.2
c234 ( 115 0 ) capacitor c=0.0217503f //x=49.305 //y=5.2
c235 ( 113 0 ) capacitor c=0.00866655f //x=50.18 //y=1.085
c236 ( 110 0 ) capacitor c=0.0588816f //x=52.66 //y=4.88
c237 ( 101 0 ) capacitor c=0.058931f //x=46.74 //y=4.88
c238 ( 96 0 ) capacitor c=0.0273931f //x=46.74 //y=2.095
c239 ( 95 0 ) capacitor c=0.0456313f //x=46.74 //y=2.26
c240 ( 90 0 ) capacitor c=0.0318948f //x=52.995 //y=1.39
c241 ( 89 0 ) capacitor c=0.0187384f //x=52.995 //y=1.045
c242 ( 86 0 ) capacitor c=0.0141798f //x=52.84 //y=1.545
c243 ( 84 0 ) capacitor c=0.0149844f //x=52.84 //y=0.89
c244 ( 80 0 ) capacitor c=0.0813322f //x=52.465 //y=2.095
c245 ( 79 0 ) capacitor c=0.0229267f //x=52.465 //y=1.7
c246 ( 78 0 ) capacitor c=0.0234352f //x=52.465 //y=1.39
c247 ( 77 0 ) capacitor c=0.0199343f //x=52.465 //y=1.045
c248 ( 76 0 ) capacitor c=0.0432517f //x=47.26 //y=1.44
c249 ( 75 0 ) capacitor c=0.0200379f //x=47.26 //y=1.095
c250 ( 72 0 ) capacitor c=0.0148873f //x=47.105 //y=1.595
c251 ( 70 0 ) capacitor c=0.0157803f //x=47.105 //y=0.94
c252 ( 65 0 ) capacitor c=0.0218028f //x=46.73 //y=1.75
c253 ( 64 0 ) capacitor c=0.0207459f //x=46.73 //y=1.44
c254 ( 63 0 ) capacitor c=0.0194308f //x=46.73 //y=1.095
c255 ( 59 0 ) capacitor c=0.110275f //x=53 //y=6.2
c256 ( 58 0 ) capacitor c=0.154305f //x=52.56 //y=6.2
c257 ( 57 0 ) capacitor c=0.158794f //x=46.92 //y=6.2
c258 ( 56 0 ) capacitor c=0.110114f //x=46.48 //y=6.2
c259 ( 53 0 ) capacitor c=0.00211606f //x=50.33 //y=5.38
c260 ( 46 0 ) capacitor c=0.0862378f //x=52.66 //y=2.26
c261 ( 44 0 ) capacitor c=0.103497f //x=50.81 //y=3.51
c262 ( 40 0 ) capacitor c=0.00404073f //x=50.455 //y=1.835
c263 ( 39 0 ) capacitor c=0.0122201f //x=50.725 //y=1.835
c264 ( 37 0 ) capacitor c=0.0137522f //x=50.725 //y=5.38
c265 ( 26 0 ) capacitor c=0.00251635f //x=49.535 //y=5.38
c266 ( 25 0 ) capacitor c=0.0142423f //x=50.245 //y=5.38
c267 ( 12 0 ) capacitor c=0.0813598f //x=46.74 //y=2.26
c268 ( 4 0 ) capacitor c=0.00280195f //x=50.925 //y=3.51
c269 ( 3 0 ) capacitor c=0.0346903f //x=52.545 //y=3.51
c270 ( 2 0 ) capacitor c=0.0127233f //x=46.855 //y=3.51
c271 ( 1 0 ) capacitor c=0.0559579f //x=50.695 //y=3.51
r272 (  108 110 ) resistor r=20.6867 //w=0.233 //l=0.1 //layer=ply \
 //thickness=0.18 //x=52.56 //y=4.88 //x2=52.66 //y2=4.88
r273 (  95 96 ) resistor r=52.7279 //w=0.214 //l=0.165 //layer=ply \
 //thickness=0.18 //x=46.74 //y=2.26 //x2=46.74 //y2=2.095
r274 (  91 110 ) resistor r=70.3348 //w=0.233 //l=0.414367 //layer=ply \
 //thickness=0.18 //x=53 //y=5.045 //x2=52.66 //y2=4.88
r275 (  90 112 ) resistor r=45.1352 //w=0.168 //l=0.173853 //layer=ply \
 //thickness=0.18 //x=52.995 //y=1.39 //x2=52.955 //y2=1.545
r276 (  89 111 ) resistor r=45.1352 //w=0.168 //l=0.173853 //layer=ply \
 //thickness=0.18 //x=52.995 //y=1.045 //x2=52.955 //y2=0.89
r277 (  89 90 ) resistor r=176.904 //w=0.094 //l=0.345 //layer=ply \
 //thickness=0.18 //x=52.995 //y=1.045 //x2=52.995 //y2=1.39
r278 (  87 107 ) resistor r=10.701 //w=0.21 //l=0.115 //layer=ply \
 //thickness=0.18 //x=52.62 //y=1.545 //x2=52.505 //y2=1.545
r279 (  86 112 ) resistor r=5.52526 //w=0.168 //l=0.115 //layer=ply \
 //thickness=0.18 //x=52.84 //y=1.545 //x2=52.955 //y2=1.545
r280 (  85 106 ) resistor r=5.52526 //w=0.168 //l=0.115 //layer=ply \
 //thickness=0.18 //x=52.62 //y=0.89 //x2=52.505 //y2=0.89
r281 (  84 111 ) resistor r=5.52526 //w=0.168 //l=0.115 //layer=ply \
 //thickness=0.18 //x=52.84 //y=0.89 //x2=52.955 //y2=0.89
r282 (  84 85 ) resistor r=112.809 //w=0.094 //l=0.22 //layer=ply \
 //thickness=0.18 //x=52.84 //y=0.89 //x2=52.62 //y2=0.89
r283 (  81 108 ) resistor r=13.0941 //w=0.233 //l=0.165 //layer=ply \
 //thickness=0.18 //x=52.56 //y=5.045 //x2=52.56 //y2=4.88
r284 (  80 105 ) resistor r=34.8111 //w=0.27 //l=0.264953 //layer=ply \
 //thickness=0.18 //x=52.465 //y=2.095 //x2=52.66 //y2=2.26
r285 (  79 107 ) resistor r=39.5823 //w=0.21 //l=0.173853 //layer=ply \
 //thickness=0.18 //x=52.465 //y=1.7 //x2=52.505 //y2=1.545
r286 (  79 80 ) resistor r=202.543 //w=0.094 //l=0.395 //layer=ply \
 //thickness=0.18 //x=52.465 //y=1.7 //x2=52.465 //y2=2.095
r287 (  78 107 ) resistor r=39.5823 //w=0.21 //l=0.173853 //layer=ply \
 //thickness=0.18 //x=52.465 //y=1.39 //x2=52.505 //y2=1.545
r288 (  77 106 ) resistor r=45.1352 //w=0.168 //l=0.173853 //layer=ply \
 //thickness=0.18 //x=52.465 //y=1.045 //x2=52.505 //y2=0.89
r289 (  77 78 ) resistor r=176.904 //w=0.094 //l=0.345 //layer=ply \
 //thickness=0.18 //x=52.465 //y=1.045 //x2=52.465 //y2=1.39
r290 (  76 103 ) resistor r=45.1352 //w=0.168 //l=0.173853 //layer=ply \
 //thickness=0.18 //x=47.26 //y=1.44 //x2=47.22 //y2=1.595
r291 (  75 102 ) resistor r=45.1352 //w=0.168 //l=0.173853 //layer=ply \
 //thickness=0.18 //x=47.26 //y=1.095 //x2=47.22 //y2=0.94
r292 (  75 76 ) resistor r=176.904 //w=0.094 //l=0.345 //layer=ply \
 //thickness=0.18 //x=47.26 //y=1.095 //x2=47.26 //y2=1.44
r293 (  73 99 ) resistor r=10.701 //w=0.21 //l=0.115 //layer=ply \
 //thickness=0.18 //x=46.885 //y=1.595 //x2=46.77 //y2=1.595
r294 (  72 103 ) resistor r=5.52526 //w=0.168 //l=0.115 //layer=ply \
 //thickness=0.18 //x=47.105 //y=1.595 //x2=47.22 //y2=1.595
r295 (  71 98 ) resistor r=5.52526 //w=0.168 //l=0.115 //layer=ply \
 //thickness=0.18 //x=46.885 //y=0.94 //x2=46.77 //y2=0.94
r296 (  70 102 ) resistor r=5.52526 //w=0.168 //l=0.115 //layer=ply \
 //thickness=0.18 //x=47.105 //y=0.94 //x2=47.22 //y2=0.94
r297 (  70 71 ) resistor r=112.809 //w=0.094 //l=0.22 //layer=ply \
 //thickness=0.18 //x=47.105 //y=0.94 //x2=46.885 //y2=0.94
r298 (  67 101 ) resistor r=37.236 //w=0.233 //l=0.249199 //layer=ply \
 //thickness=0.18 //x=46.92 //y=5.045 //x2=46.74 //y2=4.88
r299 (  65 99 ) resistor r=39.5823 //w=0.21 //l=0.173853 //layer=ply \
 //thickness=0.18 //x=46.73 //y=1.75 //x2=46.77 //y2=1.595
r300 (  65 96 ) resistor r=176.904 //w=0.094 //l=0.345 //layer=ply \
 //thickness=0.18 //x=46.73 //y=1.75 //x2=46.73 //y2=2.095
r301 (  64 99 ) resistor r=39.5823 //w=0.21 //l=0.173853 //layer=ply \
 //thickness=0.18 //x=46.73 //y=1.44 //x2=46.77 //y2=1.595
r302 (  63 98 ) resistor r=45.1352 //w=0.168 //l=0.173853 //layer=ply \
 //thickness=0.18 //x=46.73 //y=1.095 //x2=46.77 //y2=0.94
r303 (  63 64 ) resistor r=176.904 //w=0.094 //l=0.345 //layer=ply \
 //thickness=0.18 //x=46.73 //y=1.095 //x2=46.73 //y2=1.44
r304 (  60 101 ) resistor r=53.7854 //w=0.233 //l=0.332415 //layer=ply \
 //thickness=0.18 //x=46.48 //y=5.045 //x2=46.74 //y2=4.88
r305 (  59 91 ) resistor r=592.245 //w=0.094 //l=1.155 //layer=ply \
 //thickness=0.18 //x=53 //y=6.2 //x2=53 //y2=5.045
r306 (  58 81 ) resistor r=592.245 //w=0.094 //l=1.155 //layer=ply \
 //thickness=0.18 //x=52.56 //y=6.2 //x2=52.56 //y2=5.045
r307 (  57 67 ) resistor r=592.245 //w=0.094 //l=1.155 //layer=ply \
 //thickness=0.18 //x=46.92 //y=6.2 //x2=46.92 //y2=5.045
r308 (  56 60 ) resistor r=592.245 //w=0.094 //l=1.155 //layer=ply \
 //thickness=0.18 //x=46.48 //y=6.2 //x2=46.48 //y2=5.045
r309 (  55 86 ) resistor r=56.4043 //w=0.094 //l=0.11 //layer=ply \
 //thickness=0.18 //x=52.73 //y=1.545 //x2=52.84 //y2=1.545
r310 (  55 87 ) resistor r=56.4043 //w=0.094 //l=0.11 //layer=ply \
 //thickness=0.18 //x=52.73 //y=1.545 //x2=52.62 //y2=1.545
r311 (  54 72 ) resistor r=56.4043 //w=0.094 //l=0.11 //layer=ply \
 //thickness=0.18 //x=46.995 //y=1.595 //x2=47.105 //y2=1.595
r312 (  54 73 ) resistor r=56.4043 //w=0.094 //l=0.11 //layer=ply \
 //thickness=0.18 //x=46.995 //y=1.595 //x2=46.885 //y2=1.595
r313 (  51 110 ) resistor r=152 //w=0.17 //l=0.17 //layer=licon //count=1 \
 //x=52.66 //y=4.88 //x2=52.66 //y2=4.88
r314 (  49 51 ) resistor r=93.7754 //w=0.187 //l=1.37 //layer=li \
 //thickness=0.1 //x=52.66 //y=3.51 //x2=52.66 //y2=4.88
r315 (  46 105 ) resistor r=152 //w=0.17 //l=0.17 //layer=licon //count=1 \
 //x=52.66 //y=2.26 //x2=52.66 //y2=2.26
r316 (  46 49 ) resistor r=85.5615 //w=0.187 //l=1.25 //layer=li \
 //thickness=0.1 //x=52.66 //y=2.26 //x2=52.66 //y2=3.51
r317 (  42 44 ) resistor r=122.182 //w=0.187 //l=1.785 //layer=li \
 //thickness=0.1 //x=50.81 //y=5.295 //x2=50.81 //y2=3.51
r318 (  41 44 ) resistor r=108.834 //w=0.187 //l=1.59 //layer=li \
 //thickness=0.1 //x=50.81 //y=1.92 //x2=50.81 //y2=3.51
r319 (  39 41 ) resistor r=7.15173 //w=0.17 //l=0.120208 //layer=li \
 //thickness=0.1 //x=50.725 //y=1.835 //x2=50.81 //y2=1.92
r320 (  39 40 ) resistor r=18.4813 //w=0.187 //l=0.27 //layer=li \
 //thickness=0.1 //x=50.725 //y=1.835 //x2=50.455 //y2=1.835
r321 (  38 53 ) resistor r=5.4201 //w=0.17 //l=0.085 //layer=li \
 //thickness=0.1 //x=50.415 //y=5.38 //x2=50.33 //y2=5.38
r322 (  37 42 ) resistor r=7.15173 //w=0.17 //l=0.120208 //layer=li \
 //thickness=0.1 //x=50.725 //y=5.38 //x2=50.81 //y2=5.295
r323 (  37 38 ) resistor r=21.2193 //w=0.187 //l=0.31 //layer=li \
 //thickness=0.1 //x=50.725 //y=5.38 //x2=50.415 //y2=5.38
r324 (  33 40 ) resistor r=7.15173 //w=0.17 //l=0.120208 //layer=li \
 //thickness=0.1 //x=50.37 //y=1.75 //x2=50.455 //y2=1.835
r325 (  33 113 ) resistor r=39.016 //w=0.187 //l=0.57 //layer=li \
 //thickness=0.1 //x=50.37 //y=1.75 //x2=50.37 //y2=1.18
r326 (  27 53 ) resistor r=1.40859 //w=0.34 //l=0.085 //layer=li \
 //thickness=0.1 //x=50.33 //y=5.465 //x2=50.33 //y2=5.38
r327 (  27 116 ) resistor r=30.1176 //w=0.187 //l=0.44 //layer=li \
 //thickness=0.1 //x=50.33 //y=5.465 //x2=50.33 //y2=5.905
r328 (  25 53 ) resistor r=5.4201 //w=0.17 //l=0.085 //layer=li \
 //thickness=0.1 //x=50.245 //y=5.38 //x2=50.33 //y2=5.38
r329 (  25 26 ) resistor r=48.5989 //w=0.187 //l=0.71 //layer=li \
 //thickness=0.1 //x=50.245 //y=5.38 //x2=49.535 //y2=5.38
r330 (  19 26 ) resistor r=7.15173 //w=0.17 //l=0.120208 //layer=li \
 //thickness=0.1 //x=49.45 //y=5.465 //x2=49.535 //y2=5.38
r331 (  19 115 ) resistor r=30.1176 //w=0.187 //l=0.44 //layer=li \
 //thickness=0.1 //x=49.45 //y=5.465 //x2=49.45 //y2=5.905
r332 (  17 101 ) resistor r=152 //w=0.17 //l=0.17 //layer=licon //count=1 \
 //x=46.74 //y=4.88 //x2=46.74 //y2=4.88
r333 (  15 17 ) resistor r=93.7754 //w=0.187 //l=1.37 //layer=li \
 //thickness=0.1 //x=46.74 //y=3.51 //x2=46.74 //y2=4.88
r334 (  12 95 ) resistor r=152 //w=0.17 //l=0.17 //layer=licon //count=1 \
 //x=46.74 //y=2.26 //x2=46.74 //y2=2.26
r335 (  12 15 ) resistor r=85.5615 //w=0.187 //l=1.25 //layer=li \
 //thickness=0.1 //x=46.74 //y=2.26 //x2=46.74 //y2=3.51
r336 (  10 49 ) resistor r=9.3 //w=0.17 //l=0.17 //layer=mcon //count=1 \
 //x=52.66 //y=3.51 //x2=52.66 //y2=3.51
r337 (  8 44 ) resistor r=9.3 //w=0.17 //l=0.17 //layer=mcon //count=1 \
 //x=50.81 //y=3.51 //x2=50.81 //y2=3.51
r338 (  6 15 ) resistor r=9.3 //w=0.17 //l=0.17 //layer=mcon //count=1 \
 //x=46.74 //y=3.51 //x2=46.74 //y2=3.51
r339 (  4 8 ) resistor r=0.0880901 //w=0.191 //l=0.115 //layer=m1 \
 //thickness=0.36 //x=50.925 //y=3.51 //x2=50.81 //y2=3.51
r340 (  3 10 ) resistor r=0.0717383 //w=0.224 //l=0.115 //layer=m1 \
 //thickness=0.36 //x=52.545 //y=3.51 //x2=52.66 //y2=3.51
r341 (  3 4 ) resistor r=1.5458 //w=0.131 //l=1.62 //layer=m1 //thickness=0.36 \
 //x=52.545 //y=3.51 //x2=50.925 //y2=3.51
r342 (  2 6 ) resistor r=0.0717383 //w=0.224 //l=0.115 //layer=m1 \
 //thickness=0.36 //x=46.855 //y=3.51 //x2=46.74 //y2=3.51
r343 (  1 8 ) resistor r=0.0880901 //w=0.191 //l=0.115 //layer=m1 \
 //thickness=0.36 //x=50.695 //y=3.51 //x2=50.81 //y2=3.51
r344 (  1 2 ) resistor r=3.66412 //w=0.131 //l=3.84 //layer=m1 \
 //thickness=0.36 //x=50.695 //y=3.51 //x2=46.855 //y2=3.51
ends PM_TMRDFFQX1\%noxref_14

subckt PM_TMRDFFQX1\%noxref_15 ( 1 2 13 14 25 27 28 32 34 41 42 43 44 45 46 47 \
 48 52 54 57 58 68 71 73 74 )
c151 ( 74 0 ) capacitor c=0.0220291f //x=53.515 //y=5.2
c152 ( 73 0 ) capacitor c=0.0217503f //x=52.635 //y=5.2
c153 ( 71 0 ) capacitor c=0.00866655f //x=53.51 //y=1.085
c154 ( 68 0 ) capacitor c=0.0588816f //x=55.99 //y=4.88
c155 ( 58 0 ) capacitor c=0.0318948f //x=56.325 //y=1.39
c156 ( 57 0 ) capacitor c=0.0187384f //x=56.325 //y=1.045
c157 ( 54 0 ) capacitor c=0.0141798f //x=56.17 //y=1.545
c158 ( 52 0 ) capacitor c=0.0149844f //x=56.17 //y=0.89
c159 ( 48 0 ) capacitor c=0.0813322f //x=55.795 //y=2.095
c160 ( 47 0 ) capacitor c=0.0229267f //x=55.795 //y=1.7
c161 ( 46 0 ) capacitor c=0.0234352f //x=55.795 //y=1.39
c162 ( 45 0 ) capacitor c=0.0199343f //x=55.795 //y=1.045
c163 ( 44 0 ) capacitor c=0.110275f //x=56.33 //y=6.2
c164 ( 43 0 ) capacitor c=0.154305f //x=55.89 //y=6.2
c165 ( 41 0 ) capacitor c=0.00211606f //x=53.66 //y=5.38
c166 ( 34 0 ) capacitor c=0.0859022f //x=55.99 //y=2.26
c167 ( 32 0 ) capacitor c=0.104682f //x=54.14 //y=3.51
c168 ( 28 0 ) capacitor c=0.00404073f //x=53.785 //y=1.835
c169 ( 27 0 ) capacitor c=0.0122201f //x=54.055 //y=1.835
c170 ( 25 0 ) capacitor c=0.0137522f //x=54.055 //y=5.38
c171 ( 14 0 ) capacitor c=0.00251459f //x=52.865 //y=5.38
c172 ( 13 0 ) capacitor c=0.0143649f //x=53.575 //y=5.38
c173 ( 2 0 ) capacitor c=0.00668619f //x=54.255 //y=3.51
c174 ( 1 0 ) capacitor c=0.0400514f //x=55.875 //y=3.51
r175 (  66 68 ) resistor r=20.6867 //w=0.233 //l=0.1 //layer=ply \
 //thickness=0.18 //x=55.89 //y=4.88 //x2=55.99 //y2=4.88
r176 (  59 68 ) resistor r=70.3348 //w=0.233 //l=0.414367 //layer=ply \
 //thickness=0.18 //x=56.33 //y=5.045 //x2=55.99 //y2=4.88
r177 (  58 70 ) resistor r=45.1352 //w=0.168 //l=0.173853 //layer=ply \
 //thickness=0.18 //x=56.325 //y=1.39 //x2=56.285 //y2=1.545
r178 (  57 69 ) resistor r=45.1352 //w=0.168 //l=0.173853 //layer=ply \
 //thickness=0.18 //x=56.325 //y=1.045 //x2=56.285 //y2=0.89
r179 (  57 58 ) resistor r=176.904 //w=0.094 //l=0.345 //layer=ply \
 //thickness=0.18 //x=56.325 //y=1.045 //x2=56.325 //y2=1.39
r180 (  55 65 ) resistor r=10.701 //w=0.21 //l=0.115 //layer=ply \
 //thickness=0.18 //x=55.95 //y=1.545 //x2=55.835 //y2=1.545
r181 (  54 70 ) resistor r=5.52526 //w=0.168 //l=0.115 //layer=ply \
 //thickness=0.18 //x=56.17 //y=1.545 //x2=56.285 //y2=1.545
r182 (  53 64 ) resistor r=5.52526 //w=0.168 //l=0.115 //layer=ply \
 //thickness=0.18 //x=55.95 //y=0.89 //x2=55.835 //y2=0.89
r183 (  52 69 ) resistor r=5.52526 //w=0.168 //l=0.115 //layer=ply \
 //thickness=0.18 //x=56.17 //y=0.89 //x2=56.285 //y2=0.89
r184 (  52 53 ) resistor r=112.809 //w=0.094 //l=0.22 //layer=ply \
 //thickness=0.18 //x=56.17 //y=0.89 //x2=55.95 //y2=0.89
r185 (  49 66 ) resistor r=13.0941 //w=0.233 //l=0.165 //layer=ply \
 //thickness=0.18 //x=55.89 //y=5.045 //x2=55.89 //y2=4.88
r186 (  48 63 ) resistor r=34.8111 //w=0.27 //l=0.264953 //layer=ply \
 //thickness=0.18 //x=55.795 //y=2.095 //x2=55.99 //y2=2.26
r187 (  47 65 ) resistor r=39.5823 //w=0.21 //l=0.173853 //layer=ply \
 //thickness=0.18 //x=55.795 //y=1.7 //x2=55.835 //y2=1.545
r188 (  47 48 ) resistor r=202.543 //w=0.094 //l=0.395 //layer=ply \
 //thickness=0.18 //x=55.795 //y=1.7 //x2=55.795 //y2=2.095
r189 (  46 65 ) resistor r=39.5823 //w=0.21 //l=0.173853 //layer=ply \
 //thickness=0.18 //x=55.795 //y=1.39 //x2=55.835 //y2=1.545
r190 (  45 64 ) resistor r=45.1352 //w=0.168 //l=0.173853 //layer=ply \
 //thickness=0.18 //x=55.795 //y=1.045 //x2=55.835 //y2=0.89
r191 (  45 46 ) resistor r=176.904 //w=0.094 //l=0.345 //layer=ply \
 //thickness=0.18 //x=55.795 //y=1.045 //x2=55.795 //y2=1.39
r192 (  44 59 ) resistor r=592.245 //w=0.094 //l=1.155 //layer=ply \
 //thickness=0.18 //x=56.33 //y=6.2 //x2=56.33 //y2=5.045
r193 (  43 49 ) resistor r=592.245 //w=0.094 //l=1.155 //layer=ply \
 //thickness=0.18 //x=55.89 //y=6.2 //x2=55.89 //y2=5.045
r194 (  42 54 ) resistor r=56.4043 //w=0.094 //l=0.11 //layer=ply \
 //thickness=0.18 //x=56.06 //y=1.545 //x2=56.17 //y2=1.545
r195 (  42 55 ) resistor r=56.4043 //w=0.094 //l=0.11 //layer=ply \
 //thickness=0.18 //x=56.06 //y=1.545 //x2=55.95 //y2=1.545
r196 (  39 68 ) resistor r=152 //w=0.17 //l=0.17 //layer=licon //count=1 \
 //x=55.99 //y=4.88 //x2=55.99 //y2=4.88
r197 (  37 39 ) resistor r=93.7754 //w=0.187 //l=1.37 //layer=li \
 //thickness=0.1 //x=55.99 //y=3.51 //x2=55.99 //y2=4.88
r198 (  34 63 ) resistor r=152 //w=0.17 //l=0.17 //layer=licon //count=1 \
 //x=55.99 //y=2.26 //x2=55.99 //y2=2.26
r199 (  34 37 ) resistor r=85.5615 //w=0.187 //l=1.25 //layer=li \
 //thickness=0.1 //x=55.99 //y=2.26 //x2=55.99 //y2=3.51
r200 (  30 32 ) resistor r=122.182 //w=0.187 //l=1.785 //layer=li \
 //thickness=0.1 //x=54.14 //y=5.295 //x2=54.14 //y2=3.51
r201 (  29 32 ) resistor r=108.834 //w=0.187 //l=1.59 //layer=li \
 //thickness=0.1 //x=54.14 //y=1.92 //x2=54.14 //y2=3.51
r202 (  27 29 ) resistor r=7.15173 //w=0.17 //l=0.120208 //layer=li \
 //thickness=0.1 //x=54.055 //y=1.835 //x2=54.14 //y2=1.92
r203 (  27 28 ) resistor r=18.4813 //w=0.187 //l=0.27 //layer=li \
 //thickness=0.1 //x=54.055 //y=1.835 //x2=53.785 //y2=1.835
r204 (  26 41 ) resistor r=5.4201 //w=0.17 //l=0.085 //layer=li \
 //thickness=0.1 //x=53.745 //y=5.38 //x2=53.66 //y2=5.38
r205 (  25 30 ) resistor r=7.15173 //w=0.17 //l=0.120208 //layer=li \
 //thickness=0.1 //x=54.055 //y=5.38 //x2=54.14 //y2=5.295
r206 (  25 26 ) resistor r=21.2193 //w=0.187 //l=0.31 //layer=li \
 //thickness=0.1 //x=54.055 //y=5.38 //x2=53.745 //y2=5.38
r207 (  21 28 ) resistor r=7.15173 //w=0.17 //l=0.120208 //layer=li \
 //thickness=0.1 //x=53.7 //y=1.75 //x2=53.785 //y2=1.835
r208 (  21 71 ) resistor r=39.016 //w=0.187 //l=0.57 //layer=li \
 //thickness=0.1 //x=53.7 //y=1.75 //x2=53.7 //y2=1.18
r209 (  15 41 ) resistor r=1.40859 //w=0.34 //l=0.085 //layer=li \
 //thickness=0.1 //x=53.66 //y=5.465 //x2=53.66 //y2=5.38
r210 (  15 74 ) resistor r=30.1176 //w=0.187 //l=0.44 //layer=li \
 //thickness=0.1 //x=53.66 //y=5.465 //x2=53.66 //y2=5.905
r211 (  13 41 ) resistor r=5.4201 //w=0.17 //l=0.085 //layer=li \
 //thickness=0.1 //x=53.575 //y=5.38 //x2=53.66 //y2=5.38
r212 (  13 14 ) resistor r=48.5989 //w=0.187 //l=0.71 //layer=li \
 //thickness=0.1 //x=53.575 //y=5.38 //x2=52.865 //y2=5.38
r213 (  7 14 ) resistor r=7.15173 //w=0.17 //l=0.120208 //layer=li \
 //thickness=0.1 //x=52.78 //y=5.465 //x2=52.865 //y2=5.38
r214 (  7 73 ) resistor r=30.1176 //w=0.187 //l=0.44 //layer=li \
 //thickness=0.1 //x=52.78 //y=5.465 //x2=52.78 //y2=5.905
r215 (  6 37 ) resistor r=9.3 //w=0.17 //l=0.17 //layer=mcon //count=1 \
 //x=55.99 //y=3.51 //x2=55.99 //y2=3.51
r216 (  4 32 ) resistor r=9.3 //w=0.17 //l=0.17 //layer=mcon //count=1 \
 //x=54.14 //y=3.51 //x2=54.14 //y2=3.51
r217 (  2 4 ) resistor r=0.0717383 //w=0.224 //l=0.115 //layer=m1 \
 //thickness=0.36 //x=54.255 //y=3.51 //x2=54.14 //y2=3.51
r218 (  1 6 ) resistor r=0.0717383 //w=0.224 //l=0.115 //layer=m1 \
 //thickness=0.36 //x=55.875 //y=3.51 //x2=55.99 //y2=3.51
r219 (  1 2 ) resistor r=1.5458 //w=0.131 //l=1.62 //layer=m1 //thickness=0.36 \
 //x=55.875 //y=3.51 //x2=54.255 //y2=3.51
ends PM_TMRDFFQX1\%noxref_15

subckt PM_TMRDFFQX1\%CLK ( 1 2 3 4 5 6 7 8 9 10 23 24 25 26 27 28 29 30 31 32 \
 33 34 35 36 37 38 39 40 42 53 55 62 71 73 79 88 90 101 102 103 104 105 106 \
 107 108 109 110 111 112 113 114 115 116 117 118 119 120 121 123 129 130 131 \
 132 133 138 139 140 145 147 149 155 156 157 158 159 161 167 168 169 170 171 \
 176 177 178 183 185 187 193 194 195 196 197 199 205 206 207 208 209 214 215 \
 216 221 223 225 231 232 236 245 246 249 260 269 270 273 284 293 294 297 )
c752 ( 297 0 ) capacitor c=0.0331838f //x=56.76 //y=4.88
c753 ( 294 0 ) capacitor c=0.0279499f //x=56.73 //y=2.095
c754 ( 293 0 ) capacitor c=0.0421676f //x=56.73 //y=2.26
c755 ( 284 0 ) capacitor c=0.0334842f //x=45.63 //y=4.88
c756 ( 273 0 ) capacitor c=0.0331706f //x=35.3 //y=4.88
c757 ( 270 0 ) capacitor c=0.0279499f //x=35.27 //y=2.095
c758 ( 269 0 ) capacitor c=0.0421302f //x=35.27 //y=2.26
c759 ( 260 0 ) capacitor c=0.0334842f //x=24.17 //y=4.88
c760 ( 249 0 ) capacitor c=0.0331706f //x=13.84 //y=4.88
c761 ( 246 0 ) capacitor c=0.0279499f //x=13.81 //y=2.095
c762 ( 245 0 ) capacitor c=0.0421302f //x=13.81 //y=2.26
c763 ( 236 0 ) capacitor c=0.0334842f //x=2.71 //y=4.88
c764 ( 232 0 ) capacitor c=0.0429696f //x=57.295 //y=1.43
c765 ( 231 0 ) capacitor c=0.0192208f //x=57.295 //y=1.085
c766 ( 225 0 ) capacitor c=0.0148884f //x=57.14 //y=1.585
c767 ( 223 0 ) capacitor c=0.0157803f //x=57.14 //y=0.93
c768 ( 221 0 ) capacitor c=0.0299681f //x=57.135 //y=4.97
c769 ( 216 0 ) capacitor c=0.0205163f //x=56.765 //y=1.74
c770 ( 215 0 ) capacitor c=0.0168481f //x=56.765 //y=1.43
c771 ( 214 0 ) capacitor c=0.0174783f //x=56.765 //y=1.085
c772 ( 209 0 ) capacitor c=0.0245352f //x=45.965 //y=4.97
c773 ( 208 0 ) capacitor c=0.0825763f //x=45.72 //y=2.095
c774 ( 207 0 ) capacitor c=0.0170266f //x=45.72 //y=1.63
c775 ( 206 0 ) capacitor c=0.018609f //x=45.72 //y=1.4
c776 ( 205 0 ) capacitor c=0.0187309f //x=45.72 //y=1.09
c777 ( 199 0 ) capacitor c=0.014725f //x=45.565 //y=1.555
c778 ( 197 0 ) capacitor c=0.0146567f //x=45.565 //y=0.935
c779 ( 196 0 ) capacitor c=0.0335408f //x=45.195 //y=1.4
c780 ( 195 0 ) capacitor c=0.0173761f //x=45.195 //y=1.09
c781 ( 194 0 ) capacitor c=0.0429696f //x=35.835 //y=1.43
c782 ( 193 0 ) capacitor c=0.0192208f //x=35.835 //y=1.085
c783 ( 187 0 ) capacitor c=0.0158629f //x=35.68 //y=1.585
c784 ( 185 0 ) capacitor c=0.0157803f //x=35.68 //y=0.93
c785 ( 183 0 ) capacitor c=0.0295235f //x=35.675 //y=4.97
c786 ( 178 0 ) capacitor c=0.0204188f //x=35.305 //y=1.74
c787 ( 177 0 ) capacitor c=0.0168481f //x=35.305 //y=1.43
c788 ( 176 0 ) capacitor c=0.0174783f //x=35.305 //y=1.085
c789 ( 171 0 ) capacitor c=0.0245352f //x=24.505 //y=4.97
c790 ( 170 0 ) capacitor c=0.0826403f //x=24.26 //y=2.095
c791 ( 169 0 ) capacitor c=0.0170266f //x=24.26 //y=1.63
c792 ( 168 0 ) capacitor c=0.018609f //x=24.26 //y=1.4
c793 ( 167 0 ) capacitor c=0.0187309f //x=24.26 //y=1.09
c794 ( 161 0 ) capacitor c=0.014725f //x=24.105 //y=1.555
c795 ( 159 0 ) capacitor c=0.0146567f //x=24.105 //y=0.935
c796 ( 158 0 ) capacitor c=0.0335408f //x=23.735 //y=1.4
c797 ( 157 0 ) capacitor c=0.0173761f //x=23.735 //y=1.09
c798 ( 156 0 ) capacitor c=0.0429696f //x=14.375 //y=1.43
c799 ( 155 0 ) capacitor c=0.0192208f //x=14.375 //y=1.085
c800 ( 149 0 ) capacitor c=0.0158629f //x=14.22 //y=1.585
c801 ( 147 0 ) capacitor c=0.0157803f //x=14.22 //y=0.93
c802 ( 145 0 ) capacitor c=0.0295269f //x=14.215 //y=4.97
c803 ( 140 0 ) capacitor c=0.0204188f //x=13.845 //y=1.74
c804 ( 139 0 ) capacitor c=0.0168481f //x=13.845 //y=1.43
c805 ( 138 0 ) capacitor c=0.0174783f //x=13.845 //y=1.085
c806 ( 133 0 ) capacitor c=0.0245352f //x=3.045 //y=4.97
c807 ( 132 0 ) capacitor c=0.0850619f //x=2.8 //y=2.095
c808 ( 131 0 ) capacitor c=0.0170266f //x=2.8 //y=1.63
c809 ( 130 0 ) capacitor c=0.018609f //x=2.8 //y=1.4
c810 ( 129 0 ) capacitor c=0.0187309f //x=2.8 //y=1.09
c811 ( 123 0 ) capacitor c=0.014725f //x=2.645 //y=1.555
c812 ( 121 0 ) capacitor c=0.0146567f //x=2.645 //y=0.935
c813 ( 120 0 ) capacitor c=0.0335408f //x=2.275 //y=1.4
c814 ( 119 0 ) capacitor c=0.0173761f //x=2.275 //y=1.09
c815 ( 118 0 ) capacitor c=0.15358f //x=57.21 //y=6.2
c816 ( 117 0 ) capacitor c=0.110281f //x=56.77 //y=6.2
c817 ( 116 0 ) capacitor c=0.110114f //x=46.04 //y=6.2
c818 ( 115 0 ) capacitor c=0.11012f //x=45.6 //y=6.2
c819 ( 114 0 ) capacitor c=0.15358f //x=35.75 //y=6.2
c820 ( 113 0 ) capacitor c=0.110281f //x=35.31 //y=6.2
c821 ( 112 0 ) capacitor c=0.110114f //x=24.58 //y=6.2
c822 ( 111 0 ) capacitor c=0.11012f //x=24.14 //y=6.2
c823 ( 110 0 ) capacitor c=0.15358f //x=14.29 //y=6.2
c824 ( 109 0 ) capacitor c=0.110281f //x=13.85 //y=6.2
c825 ( 108 0 ) capacitor c=0.110114f //x=3.12 //y=6.2
c826 ( 107 0 ) capacitor c=0.11012f //x=2.68 //y=6.2
c827 ( 90 0 ) capacitor c=0.0707124f //x=56.73 //y=2.26
c828 ( 88 0 ) capacitor c=0.00369614f //x=56.73 //y=4.715
c829 ( 79 0 ) capacitor c=0.0921731f //x=45.63 //y=2.26
c830 ( 73 0 ) capacitor c=0.0706586f //x=35.27 //y=2.26
c831 ( 71 0 ) capacitor c=0.00369614f //x=35.27 //y=4.715
c832 ( 62 0 ) capacitor c=0.0948276f //x=24.17 //y=2.26
c833 ( 55 0 ) capacitor c=0.0725839f //x=13.81 //y=2.26
c834 ( 53 0 ) capacitor c=0.00369614f //x=13.81 //y=4.715
c835 ( 42 0 ) capacitor c=0.100158f //x=2.71 //y=2.26
c836 ( 10 0 ) capacitor c=0.00697397f //x=45.745 //y=4.62
c837 ( 9 0 ) capacitor c=0.25424f //x=56.615 //y=4.62
c838 ( 8 0 ) capacitor c=0.00680508f //x=35.385 //y=4.62
c839 ( 7 0 ) capacitor c=0.250892f //x=45.515 //y=4.62
c840 ( 6 0 ) capacitor c=0.184244f //x=24.285 //y=4.62
c841 ( 5 0 ) capacitor c=0.241824f //x=35.155 //y=4.62
c842 ( 4 0 ) capacitor c=0.00759515f //x=13.955 //y=4.622
c843 ( 3 0 ) capacitor c=0.0725822f //x=17.235 //y=4.622
c844 ( 2 0 ) capacitor c=0.0154455f //x=2.825 //y=4.62
c845 ( 1 0 ) capacitor c=0.241824f //x=13.695 //y=4.62
r846 (  299 300 ) resistor r=32.4568 //w=0.214 //l=0.075 //layer=ply \
 //thickness=0.18 //x=56.76 //y=4.97 //x2=56.76 //y2=5.045
r847 (  297 299 ) resistor r=20.271 //w=0.214 //l=0.09 //layer=ply \
 //thickness=0.18 //x=56.76 //y=4.88 //x2=56.76 //y2=4.97
r848 (  293 294 ) resistor r=52.7279 //w=0.214 //l=0.165 //layer=ply \
 //thickness=0.18 //x=56.73 //y=2.26 //x2=56.73 //y2=2.095
r849 (  286 287 ) resistor r=32.4568 //w=0.214 //l=0.075 //layer=ply \
 //thickness=0.18 //x=45.63 //y=4.97 //x2=45.63 //y2=5.045
r850 (  284 286 ) resistor r=20.271 //w=0.214 //l=0.09 //layer=ply \
 //thickness=0.18 //x=45.63 //y=4.88 //x2=45.63 //y2=4.97
r851 (  275 276 ) resistor r=32.4568 //w=0.214 //l=0.075 //layer=ply \
 //thickness=0.18 //x=35.3 //y=4.97 //x2=35.3 //y2=5.045
r852 (  273 275 ) resistor r=20.271 //w=0.214 //l=0.09 //layer=ply \
 //thickness=0.18 //x=35.3 //y=4.88 //x2=35.3 //y2=4.97
r853 (  269 270 ) resistor r=52.7279 //w=0.214 //l=0.165 //layer=ply \
 //thickness=0.18 //x=35.27 //y=2.26 //x2=35.27 //y2=2.095
r854 (  262 263 ) resistor r=32.4568 //w=0.214 //l=0.075 //layer=ply \
 //thickness=0.18 //x=24.17 //y=4.97 //x2=24.17 //y2=5.045
r855 (  260 262 ) resistor r=20.271 //w=0.214 //l=0.09 //layer=ply \
 //thickness=0.18 //x=24.17 //y=4.88 //x2=24.17 //y2=4.97
r856 (  251 252 ) resistor r=32.4568 //w=0.214 //l=0.075 //layer=ply \
 //thickness=0.18 //x=13.84 //y=4.97 //x2=13.84 //y2=5.045
r857 (  249 251 ) resistor r=20.271 //w=0.214 //l=0.09 //layer=ply \
 //thickness=0.18 //x=13.84 //y=4.88 //x2=13.84 //y2=4.97
r858 (  245 246 ) resistor r=52.7279 //w=0.214 //l=0.165 //layer=ply \
 //thickness=0.18 //x=13.81 //y=2.26 //x2=13.81 //y2=2.095
r859 (  238 239 ) resistor r=32.4568 //w=0.214 //l=0.075 //layer=ply \
 //thickness=0.18 //x=2.71 //y=4.97 //x2=2.71 //y2=5.045
r860 (  236 238 ) resistor r=20.271 //w=0.214 //l=0.09 //layer=ply \
 //thickness=0.18 //x=2.71 //y=4.88 //x2=2.71 //y2=4.97
r861 (  232 304 ) resistor r=45.1352 //w=0.168 //l=0.173853 //layer=ply \
 //thickness=0.18 //x=57.295 //y=1.43 //x2=57.255 //y2=1.585
r862 (  231 303 ) resistor r=45.1352 //w=0.168 //l=0.173853 //layer=ply \
 //thickness=0.18 //x=57.295 //y=1.085 //x2=57.255 //y2=0.93
r863 (  231 232 ) resistor r=176.904 //w=0.094 //l=0.345 //layer=ply \
 //thickness=0.18 //x=57.295 //y=1.085 //x2=57.295 //y2=1.43
r864 (  226 302 ) resistor r=10.701 //w=0.21 //l=0.115 //layer=ply \
 //thickness=0.18 //x=56.92 //y=1.585 //x2=56.805 //y2=1.585
r865 (  225 304 ) resistor r=5.52526 //w=0.168 //l=0.115 //layer=ply \
 //thickness=0.18 //x=57.14 //y=1.585 //x2=57.255 //y2=1.585
r866 (  224 301 ) resistor r=5.52526 //w=0.168 //l=0.115 //layer=ply \
 //thickness=0.18 //x=56.92 //y=0.93 //x2=56.805 //y2=0.93
r867 (  223 303 ) resistor r=5.52526 //w=0.168 //l=0.115 //layer=ply \
 //thickness=0.18 //x=57.14 //y=0.93 //x2=57.255 //y2=0.93
r868 (  223 224 ) resistor r=112.809 //w=0.094 //l=0.22 //layer=ply \
 //thickness=0.18 //x=57.14 //y=0.93 //x2=56.92 //y2=0.93
r869 (  222 299 ) resistor r=16.5046 //w=0.27 //l=0.135 //layer=ply \
 //thickness=0.18 //x=56.895 //y=4.97 //x2=56.76 //y2=4.97
r870 (  221 228 ) resistor r=26.9307 //w=0.15 //l=0.106066 //layer=ply \
 //thickness=0.18 //x=57.135 //y=4.97 //x2=57.21 //y2=5.045
r871 (  221 222 ) resistor r=123.064 //w=0.094 //l=0.24 //layer=ply \
 //thickness=0.18 //x=57.135 //y=4.97 //x2=56.895 //y2=4.97
r872 (  216 302 ) resistor r=39.5823 //w=0.21 //l=0.173853 //layer=ply \
 //thickness=0.18 //x=56.765 //y=1.74 //x2=56.805 //y2=1.585
r873 (  216 294 ) resistor r=182.032 //w=0.094 //l=0.355 //layer=ply \
 //thickness=0.18 //x=56.765 //y=1.74 //x2=56.765 //y2=2.095
r874 (  215 302 ) resistor r=39.5823 //w=0.21 //l=0.173853 //layer=ply \
 //thickness=0.18 //x=56.765 //y=1.43 //x2=56.805 //y2=1.585
r875 (  214 301 ) resistor r=45.1352 //w=0.168 //l=0.173853 //layer=ply \
 //thickness=0.18 //x=56.765 //y=1.085 //x2=56.805 //y2=0.93
r876 (  214 215 ) resistor r=176.904 //w=0.094 //l=0.345 //layer=ply \
 //thickness=0.18 //x=56.765 //y=1.085 //x2=56.765 //y2=1.43
r877 (  210 286 ) resistor r=16.5046 //w=0.27 //l=0.135 //layer=ply \
 //thickness=0.18 //x=45.765 //y=4.97 //x2=45.63 //y2=4.97
r878 (  209 211 ) resistor r=26.9307 //w=0.15 //l=0.106066 //layer=ply \
 //thickness=0.18 //x=45.965 //y=4.97 //x2=46.04 //y2=5.045
r879 (  209 210 ) resistor r=102.553 //w=0.094 //l=0.2 //layer=ply \
 //thickness=0.18 //x=45.965 //y=4.97 //x2=45.765 //y2=4.97
r880 (  208 291 ) resistor r=38.6777 //w=0.284 //l=0.198997 //layer=ply \
 //thickness=0.18 //x=45.72 //y=2.095 //x2=45.645 //y2=2.26
r881 (  207 289 ) resistor r=21.2976 //w=0.217 //l=0.0928709 //layer=ply \
 //thickness=0.18 //x=45.72 //y=1.63 //x2=45.68 //y2=1.555
r882 (  207 208 ) resistor r=238.436 //w=0.094 //l=0.465 //layer=ply \
 //thickness=0.18 //x=45.72 //y=1.63 //x2=45.72 //y2=2.095
r883 (  206 289 ) resistor r=39.0671 //w=0.217 //l=0.173853 //layer=ply \
 //thickness=0.18 //x=45.72 //y=1.4 //x2=45.68 //y2=1.555
r884 (  205 288 ) resistor r=45.1352 //w=0.168 //l=0.173853 //layer=ply \
 //thickness=0.18 //x=45.72 //y=1.09 //x2=45.68 //y2=0.935
r885 (  205 206 ) resistor r=158.957 //w=0.094 //l=0.31 //layer=ply \
 //thickness=0.18 //x=45.72 //y=1.09 //x2=45.72 //y2=1.4
r886 (  200 282 ) resistor r=5.52526 //w=0.168 //l=0.115 //layer=ply \
 //thickness=0.18 //x=45.35 //y=1.555 //x2=45.235 //y2=1.555
r887 (  199 289 ) resistor r=11.4558 //w=0.217 //l=0.115 //layer=ply \
 //thickness=0.18 //x=45.565 //y=1.555 //x2=45.68 //y2=1.555
r888 (  198 281 ) resistor r=5.52526 //w=0.168 //l=0.115 //layer=ply \
 //thickness=0.18 //x=45.35 //y=0.935 //x2=45.235 //y2=0.935
r889 (  197 288 ) resistor r=5.52526 //w=0.168 //l=0.115 //layer=ply \
 //thickness=0.18 //x=45.565 //y=0.935 //x2=45.68 //y2=0.935
r890 (  197 198 ) resistor r=110.245 //w=0.094 //l=0.215 //layer=ply \
 //thickness=0.18 //x=45.565 //y=0.935 //x2=45.35 //y2=0.935
r891 (  196 282 ) resistor r=45.1352 //w=0.168 //l=0.173853 //layer=ply \
 //thickness=0.18 //x=45.195 //y=1.4 //x2=45.235 //y2=1.555
r892 (  195 281 ) resistor r=45.1352 //w=0.168 //l=0.173853 //layer=ply \
 //thickness=0.18 //x=45.195 //y=1.09 //x2=45.235 //y2=0.935
r893 (  195 196 ) resistor r=158.957 //w=0.094 //l=0.31 //layer=ply \
 //thickness=0.18 //x=45.195 //y=1.09 //x2=45.195 //y2=1.4
r894 (  194 280 ) resistor r=45.1352 //w=0.168 //l=0.173853 //layer=ply \
 //thickness=0.18 //x=35.835 //y=1.43 //x2=35.795 //y2=1.585
r895 (  193 279 ) resistor r=45.1352 //w=0.168 //l=0.173853 //layer=ply \
 //thickness=0.18 //x=35.835 //y=1.085 //x2=35.795 //y2=0.93
r896 (  193 194 ) resistor r=176.904 //w=0.094 //l=0.345 //layer=ply \
 //thickness=0.18 //x=35.835 //y=1.085 //x2=35.835 //y2=1.43
r897 (  188 278 ) resistor r=10.701 //w=0.21 //l=0.115 //layer=ply \
 //thickness=0.18 //x=35.46 //y=1.585 //x2=35.345 //y2=1.585
r898 (  187 280 ) resistor r=5.52526 //w=0.168 //l=0.115 //layer=ply \
 //thickness=0.18 //x=35.68 //y=1.585 //x2=35.795 //y2=1.585
r899 (  186 277 ) resistor r=5.52526 //w=0.168 //l=0.115 //layer=ply \
 //thickness=0.18 //x=35.46 //y=0.93 //x2=35.345 //y2=0.93
r900 (  185 279 ) resistor r=5.52526 //w=0.168 //l=0.115 //layer=ply \
 //thickness=0.18 //x=35.68 //y=0.93 //x2=35.795 //y2=0.93
r901 (  185 186 ) resistor r=112.809 //w=0.094 //l=0.22 //layer=ply \
 //thickness=0.18 //x=35.68 //y=0.93 //x2=35.46 //y2=0.93
r902 (  184 275 ) resistor r=16.5046 //w=0.27 //l=0.135 //layer=ply \
 //thickness=0.18 //x=35.435 //y=4.97 //x2=35.3 //y2=4.97
r903 (  183 190 ) resistor r=26.9307 //w=0.15 //l=0.106066 //layer=ply \
 //thickness=0.18 //x=35.675 //y=4.97 //x2=35.75 //y2=5.045
r904 (  183 184 ) resistor r=123.064 //w=0.094 //l=0.24 //layer=ply \
 //thickness=0.18 //x=35.675 //y=4.97 //x2=35.435 //y2=4.97
r905 (  178 278 ) resistor r=39.5823 //w=0.21 //l=0.173853 //layer=ply \
 //thickness=0.18 //x=35.305 //y=1.74 //x2=35.345 //y2=1.585
r906 (  178 270 ) resistor r=182.032 //w=0.094 //l=0.355 //layer=ply \
 //thickness=0.18 //x=35.305 //y=1.74 //x2=35.305 //y2=2.095
r907 (  177 278 ) resistor r=39.5823 //w=0.21 //l=0.173853 //layer=ply \
 //thickness=0.18 //x=35.305 //y=1.43 //x2=35.345 //y2=1.585
r908 (  176 277 ) resistor r=45.1352 //w=0.168 //l=0.173853 //layer=ply \
 //thickness=0.18 //x=35.305 //y=1.085 //x2=35.345 //y2=0.93
r909 (  176 177 ) resistor r=176.904 //w=0.094 //l=0.345 //layer=ply \
 //thickness=0.18 //x=35.305 //y=1.085 //x2=35.305 //y2=1.43
r910 (  172 262 ) resistor r=16.5046 //w=0.27 //l=0.135 //layer=ply \
 //thickness=0.18 //x=24.305 //y=4.97 //x2=24.17 //y2=4.97
r911 (  171 173 ) resistor r=26.9307 //w=0.15 //l=0.106066 //layer=ply \
 //thickness=0.18 //x=24.505 //y=4.97 //x2=24.58 //y2=5.045
r912 (  171 172 ) resistor r=102.553 //w=0.094 //l=0.2 //layer=ply \
 //thickness=0.18 //x=24.505 //y=4.97 //x2=24.305 //y2=4.97
r913 (  170 267 ) resistor r=38.6777 //w=0.284 //l=0.198997 //layer=ply \
 //thickness=0.18 //x=24.26 //y=2.095 //x2=24.185 //y2=2.26
r914 (  169 265 ) resistor r=21.2976 //w=0.217 //l=0.0928709 //layer=ply \
 //thickness=0.18 //x=24.26 //y=1.63 //x2=24.22 //y2=1.555
r915 (  169 170 ) resistor r=238.436 //w=0.094 //l=0.465 //layer=ply \
 //thickness=0.18 //x=24.26 //y=1.63 //x2=24.26 //y2=2.095
r916 (  168 265 ) resistor r=39.0671 //w=0.217 //l=0.173853 //layer=ply \
 //thickness=0.18 //x=24.26 //y=1.4 //x2=24.22 //y2=1.555
r917 (  167 264 ) resistor r=45.1352 //w=0.168 //l=0.173853 //layer=ply \
 //thickness=0.18 //x=24.26 //y=1.09 //x2=24.22 //y2=0.935
r918 (  167 168 ) resistor r=158.957 //w=0.094 //l=0.31 //layer=ply \
 //thickness=0.18 //x=24.26 //y=1.09 //x2=24.26 //y2=1.4
r919 (  162 258 ) resistor r=5.52526 //w=0.168 //l=0.115 //layer=ply \
 //thickness=0.18 //x=23.89 //y=1.555 //x2=23.775 //y2=1.555
r920 (  161 265 ) resistor r=11.4558 //w=0.217 //l=0.115 //layer=ply \
 //thickness=0.18 //x=24.105 //y=1.555 //x2=24.22 //y2=1.555
r921 (  160 257 ) resistor r=5.52526 //w=0.168 //l=0.115 //layer=ply \
 //thickness=0.18 //x=23.89 //y=0.935 //x2=23.775 //y2=0.935
r922 (  159 264 ) resistor r=5.52526 //w=0.168 //l=0.115 //layer=ply \
 //thickness=0.18 //x=24.105 //y=0.935 //x2=24.22 //y2=0.935
r923 (  159 160 ) resistor r=110.245 //w=0.094 //l=0.215 //layer=ply \
 //thickness=0.18 //x=24.105 //y=0.935 //x2=23.89 //y2=0.935
r924 (  158 258 ) resistor r=45.1352 //w=0.168 //l=0.173853 //layer=ply \
 //thickness=0.18 //x=23.735 //y=1.4 //x2=23.775 //y2=1.555
r925 (  157 257 ) resistor r=45.1352 //w=0.168 //l=0.173853 //layer=ply \
 //thickness=0.18 //x=23.735 //y=1.09 //x2=23.775 //y2=0.935
r926 (  157 158 ) resistor r=158.957 //w=0.094 //l=0.31 //layer=ply \
 //thickness=0.18 //x=23.735 //y=1.09 //x2=23.735 //y2=1.4
r927 (  156 256 ) resistor r=45.1352 //w=0.168 //l=0.173853 //layer=ply \
 //thickness=0.18 //x=14.375 //y=1.43 //x2=14.335 //y2=1.585
r928 (  155 255 ) resistor r=45.1352 //w=0.168 //l=0.173853 //layer=ply \
 //thickness=0.18 //x=14.375 //y=1.085 //x2=14.335 //y2=0.93
r929 (  155 156 ) resistor r=176.904 //w=0.094 //l=0.345 //layer=ply \
 //thickness=0.18 //x=14.375 //y=1.085 //x2=14.375 //y2=1.43
r930 (  150 254 ) resistor r=10.701 //w=0.21 //l=0.115 //layer=ply \
 //thickness=0.18 //x=14 //y=1.585 //x2=13.885 //y2=1.585
r931 (  149 256 ) resistor r=5.52526 //w=0.168 //l=0.115 //layer=ply \
 //thickness=0.18 //x=14.22 //y=1.585 //x2=14.335 //y2=1.585
r932 (  148 253 ) resistor r=5.52526 //w=0.168 //l=0.115 //layer=ply \
 //thickness=0.18 //x=14 //y=0.93 //x2=13.885 //y2=0.93
r933 (  147 255 ) resistor r=5.52526 //w=0.168 //l=0.115 //layer=ply \
 //thickness=0.18 //x=14.22 //y=0.93 //x2=14.335 //y2=0.93
r934 (  147 148 ) resistor r=112.809 //w=0.094 //l=0.22 //layer=ply \
 //thickness=0.18 //x=14.22 //y=0.93 //x2=14 //y2=0.93
r935 (  146 251 ) resistor r=16.5046 //w=0.27 //l=0.135 //layer=ply \
 //thickness=0.18 //x=13.975 //y=4.97 //x2=13.84 //y2=4.97
r936 (  145 152 ) resistor r=26.9307 //w=0.15 //l=0.106066 //layer=ply \
 //thickness=0.18 //x=14.215 //y=4.97 //x2=14.29 //y2=5.045
r937 (  145 146 ) resistor r=123.064 //w=0.094 //l=0.24 //layer=ply \
 //thickness=0.18 //x=14.215 //y=4.97 //x2=13.975 //y2=4.97
r938 (  140 254 ) resistor r=39.5823 //w=0.21 //l=0.173853 //layer=ply \
 //thickness=0.18 //x=13.845 //y=1.74 //x2=13.885 //y2=1.585
r939 (  140 246 ) resistor r=182.032 //w=0.094 //l=0.355 //layer=ply \
 //thickness=0.18 //x=13.845 //y=1.74 //x2=13.845 //y2=2.095
r940 (  139 254 ) resistor r=39.5823 //w=0.21 //l=0.173853 //layer=ply \
 //thickness=0.18 //x=13.845 //y=1.43 //x2=13.885 //y2=1.585
r941 (  138 253 ) resistor r=45.1352 //w=0.168 //l=0.173853 //layer=ply \
 //thickness=0.18 //x=13.845 //y=1.085 //x2=13.885 //y2=0.93
r942 (  138 139 ) resistor r=176.904 //w=0.094 //l=0.345 //layer=ply \
 //thickness=0.18 //x=13.845 //y=1.085 //x2=13.845 //y2=1.43
r943 (  134 238 ) resistor r=16.5046 //w=0.27 //l=0.135 //layer=ply \
 //thickness=0.18 //x=2.845 //y=4.97 //x2=2.71 //y2=4.97
r944 (  133 135 ) resistor r=26.9307 //w=0.15 //l=0.106066 //layer=ply \
 //thickness=0.18 //x=3.045 //y=4.97 //x2=3.12 //y2=5.045
r945 (  133 134 ) resistor r=102.553 //w=0.094 //l=0.2 //layer=ply \
 //thickness=0.18 //x=3.045 //y=4.97 //x2=2.845 //y2=4.97
r946 (  132 243 ) resistor r=38.6777 //w=0.284 //l=0.198997 //layer=ply \
 //thickness=0.18 //x=2.8 //y=2.095 //x2=2.725 //y2=2.26
r947 (  131 241 ) resistor r=21.2976 //w=0.217 //l=0.0928709 //layer=ply \
 //thickness=0.18 //x=2.8 //y=1.63 //x2=2.76 //y2=1.555
r948 (  131 132 ) resistor r=238.436 //w=0.094 //l=0.465 //layer=ply \
 //thickness=0.18 //x=2.8 //y=1.63 //x2=2.8 //y2=2.095
r949 (  130 241 ) resistor r=39.0671 //w=0.217 //l=0.173853 //layer=ply \
 //thickness=0.18 //x=2.8 //y=1.4 //x2=2.76 //y2=1.555
r950 (  129 240 ) resistor r=45.1352 //w=0.168 //l=0.173853 //layer=ply \
 //thickness=0.18 //x=2.8 //y=1.09 //x2=2.76 //y2=0.935
r951 (  129 130 ) resistor r=158.957 //w=0.094 //l=0.31 //layer=ply \
 //thickness=0.18 //x=2.8 //y=1.09 //x2=2.8 //y2=1.4
r952 (  124 234 ) resistor r=5.52526 //w=0.168 //l=0.115 //layer=ply \
 //thickness=0.18 //x=2.43 //y=1.555 //x2=2.315 //y2=1.555
r953 (  123 241 ) resistor r=11.4558 //w=0.217 //l=0.115 //layer=ply \
 //thickness=0.18 //x=2.645 //y=1.555 //x2=2.76 //y2=1.555
r954 (  122 233 ) resistor r=5.52526 //w=0.168 //l=0.115 //layer=ply \
 //thickness=0.18 //x=2.43 //y=0.935 //x2=2.315 //y2=0.935
r955 (  121 240 ) resistor r=5.52526 //w=0.168 //l=0.115 //layer=ply \
 //thickness=0.18 //x=2.645 //y=0.935 //x2=2.76 //y2=0.935
r956 (  121 122 ) resistor r=110.245 //w=0.094 //l=0.215 //layer=ply \
 //thickness=0.18 //x=2.645 //y=0.935 //x2=2.43 //y2=0.935
r957 (  120 234 ) resistor r=45.1352 //w=0.168 //l=0.173853 //layer=ply \
 //thickness=0.18 //x=2.275 //y=1.4 //x2=2.315 //y2=1.555
r958 (  119 233 ) resistor r=45.1352 //w=0.168 //l=0.173853 //layer=ply \
 //thickness=0.18 //x=2.275 //y=1.09 //x2=2.315 //y2=0.935
r959 (  119 120 ) resistor r=158.957 //w=0.094 //l=0.31 //layer=ply \
 //thickness=0.18 //x=2.275 //y=1.09 //x2=2.275 //y2=1.4
r960 (  118 228 ) resistor r=592.245 //w=0.094 //l=1.155 //layer=ply \
 //thickness=0.18 //x=57.21 //y=6.2 //x2=57.21 //y2=5.045
r961 (  117 300 ) resistor r=592.245 //w=0.094 //l=1.155 //layer=ply \
 //thickness=0.18 //x=56.77 //y=6.2 //x2=56.77 //y2=5.045
r962 (  116 211 ) resistor r=592.245 //w=0.094 //l=1.155 //layer=ply \
 //thickness=0.18 //x=46.04 //y=6.2 //x2=46.04 //y2=5.045
r963 (  115 287 ) resistor r=592.245 //w=0.094 //l=1.155 //layer=ply \
 //thickness=0.18 //x=45.6 //y=6.2 //x2=45.6 //y2=5.045
r964 (  114 190 ) resistor r=592.245 //w=0.094 //l=1.155 //layer=ply \
 //thickness=0.18 //x=35.75 //y=6.2 //x2=35.75 //y2=5.045
r965 (  113 276 ) resistor r=592.245 //w=0.094 //l=1.155 //layer=ply \
 //thickness=0.18 //x=35.31 //y=6.2 //x2=35.31 //y2=5.045
r966 (  112 173 ) resistor r=592.245 //w=0.094 //l=1.155 //layer=ply \
 //thickness=0.18 //x=24.58 //y=6.2 //x2=24.58 //y2=5.045
r967 (  111 263 ) resistor r=592.245 //w=0.094 //l=1.155 //layer=ply \
 //thickness=0.18 //x=24.14 //y=6.2 //x2=24.14 //y2=5.045
r968 (  110 152 ) resistor r=592.245 //w=0.094 //l=1.155 //layer=ply \
 //thickness=0.18 //x=14.29 //y=6.2 //x2=14.29 //y2=5.045
r969 (  109 252 ) resistor r=592.245 //w=0.094 //l=1.155 //layer=ply \
 //thickness=0.18 //x=13.85 //y=6.2 //x2=13.85 //y2=5.045
r970 (  108 135 ) resistor r=592.245 //w=0.094 //l=1.155 //layer=ply \
 //thickness=0.18 //x=3.12 //y=6.2 //x2=3.12 //y2=5.045
r971 (  107 239 ) resistor r=592.245 //w=0.094 //l=1.155 //layer=ply \
 //thickness=0.18 //x=2.68 //y=6.2 //x2=2.68 //y2=5.045
r972 (  106 225 ) resistor r=56.4043 //w=0.094 //l=0.11 //layer=ply \
 //thickness=0.18 //x=57.03 //y=1.585 //x2=57.14 //y2=1.585
r973 (  106 226 ) resistor r=56.4043 //w=0.094 //l=0.11 //layer=ply \
 //thickness=0.18 //x=57.03 //y=1.585 //x2=56.92 //y2=1.585
r974 (  105 199 ) resistor r=55.3787 //w=0.094 //l=0.108 //layer=ply \
 //thickness=0.18 //x=45.457 //y=1.555 //x2=45.565 //y2=1.555
r975 (  105 200 ) resistor r=54.866 //w=0.094 //l=0.107 //layer=ply \
 //thickness=0.18 //x=45.457 //y=1.555 //x2=45.35 //y2=1.555
r976 (  104 187 ) resistor r=56.4043 //w=0.094 //l=0.11 //layer=ply \
 //thickness=0.18 //x=35.57 //y=1.585 //x2=35.68 //y2=1.585
r977 (  104 188 ) resistor r=56.4043 //w=0.094 //l=0.11 //layer=ply \
 //thickness=0.18 //x=35.57 //y=1.585 //x2=35.46 //y2=1.585
r978 (  103 161 ) resistor r=55.3787 //w=0.094 //l=0.108 //layer=ply \
 //thickness=0.18 //x=23.997 //y=1.555 //x2=24.105 //y2=1.555
r979 (  103 162 ) resistor r=54.866 //w=0.094 //l=0.107 //layer=ply \
 //thickness=0.18 //x=23.997 //y=1.555 //x2=23.89 //y2=1.555
r980 (  102 149 ) resistor r=56.4043 //w=0.094 //l=0.11 //layer=ply \
 //thickness=0.18 //x=14.11 //y=1.585 //x2=14.22 //y2=1.585
r981 (  102 150 ) resistor r=56.4043 //w=0.094 //l=0.11 //layer=ply \
 //thickness=0.18 //x=14.11 //y=1.585 //x2=14 //y2=1.585
r982 (  101 123 ) resistor r=55.3787 //w=0.094 //l=0.108 //layer=ply \
 //thickness=0.18 //x=2.537 //y=1.555 //x2=2.645 //y2=1.555
r983 (  101 124 ) resistor r=54.866 //w=0.094 //l=0.107 //layer=ply \
 //thickness=0.18 //x=2.537 //y=1.555 //x2=2.43 //y2=1.555
r984 (  100 297 ) resistor r=152 //w=0.17 //l=0.17 //layer=licon //count=1 \
 //x=56.76 //y=4.88 //x2=56.76 //y2=4.88
r985 (  98 273 ) resistor r=152 //w=0.17 //l=0.17 //layer=licon //count=1 \
 //x=35.3 //y=4.88 //x2=35.3 //y2=4.88
r986 (  96 249 ) resistor r=152 //w=0.17 //l=0.17 //layer=licon //count=1 \
 //x=13.84 //y=4.88 //x2=13.84 //y2=4.88
r987 (  90 293 ) resistor r=152 //w=0.17 //l=0.17 //layer=licon //count=1 \
 //x=56.73 //y=2.26 //x2=56.73 //y2=2.26
r988 (  88 100 ) resistor r=11.4737 //w=0.186 //l=0.172337 //layer=li \
 //thickness=0.1 //x=56.73 //y=4.715 //x2=56.745 //y2=4.88
r989 (  86 284 ) resistor r=152 //w=0.17 //l=0.17 //layer=licon //count=1 \
 //x=45.63 //y=4.88 //x2=45.63 //y2=4.88
r990 (  79 291 ) resistor r=152 //w=0.17 //l=0.17 //layer=licon //count=1 \
 //x=45.63 //y=2.26 //x2=45.63 //y2=2.26
r991 (  73 269 ) resistor r=152 //w=0.17 //l=0.17 //layer=licon //count=1 \
 //x=35.27 //y=2.26 //x2=35.27 //y2=2.26
r992 (  71 98 ) resistor r=11.4737 //w=0.186 //l=0.172337 //layer=li \
 //thickness=0.1 //x=35.27 //y=4.715 //x2=35.285 //y2=4.88
r993 (  69 260 ) resistor r=152 //w=0.17 //l=0.17 //layer=licon //count=1 \
 //x=24.17 //y=4.88 //x2=24.17 //y2=4.88
r994 (  62 267 ) resistor r=152 //w=0.17 //l=0.17 //layer=licon //count=1 \
 //x=24.17 //y=2.26 //x2=24.17 //y2=2.26
r995 (  55 245 ) resistor r=152 //w=0.17 //l=0.17 //layer=licon //count=1 \
 //x=13.81 //y=2.26 //x2=13.81 //y2=2.26
r996 (  53 96 ) resistor r=11.4737 //w=0.186 //l=0.172337 //layer=li \
 //thickness=0.1 //x=13.81 //y=4.715 //x2=13.825 //y2=4.88
r997 (  51 236 ) resistor r=152 //w=0.17 //l=0.17 //layer=licon //count=1 \
 //x=2.71 //y=4.88 //x2=2.71 //y2=4.88
r998 (  42 243 ) resistor r=152 //w=0.17 //l=0.17 //layer=licon //count=1 \
 //x=2.71 //y=2.26 //x2=2.71 //y2=2.26
r999 (  40 88 ) resistor r=6.50267 //w=0.187 //l=0.095 //layer=li \
 //thickness=0.1 //x=56.73 //y=4.62 //x2=56.73 //y2=4.715
r1000 (  39 40 ) resistor r=75.9786 //w=0.187 //l=1.11 //layer=li \
 //thickness=0.1 //x=56.73 //y=3.51 //x2=56.73 //y2=4.62
r1001 (  39 90 ) resistor r=85.5615 //w=0.187 //l=1.25 //layer=li \
 //thickness=0.1 //x=56.73 //y=3.51 //x2=56.73 //y2=2.26
r1002 (  38 86 ) resistor r=17.7968 //w=0.187 //l=0.26 //layer=li \
 //thickness=0.1 //x=45.63 //y=4.62 //x2=45.63 //y2=4.88
r1003 (  37 38 ) resistor r=50.6524 //w=0.187 //l=0.74 //layer=li \
 //thickness=0.1 //x=45.63 //y=3.88 //x2=45.63 //y2=4.62
r1004 (  36 37 ) resistor r=25.3262 //w=0.187 //l=0.37 //layer=li \
 //thickness=0.1 //x=45.63 //y=3.51 //x2=45.63 //y2=3.88
r1005 (  36 79 ) resistor r=85.5615 //w=0.187 //l=1.25 //layer=li \
 //thickness=0.1 //x=45.63 //y=3.51 //x2=45.63 //y2=2.26
r1006 (  35 71 ) resistor r=6.50267 //w=0.187 //l=0.095 //layer=li \
 //thickness=0.1 //x=35.27 //y=4.62 //x2=35.27 //y2=4.715
r1007 (  34 35 ) resistor r=75.9786 //w=0.187 //l=1.11 //layer=li \
 //thickness=0.1 //x=35.27 //y=3.51 //x2=35.27 //y2=4.62
r1008 (  34 73 ) resistor r=85.5615 //w=0.187 //l=1.25 //layer=li \
 //thickness=0.1 //x=35.27 //y=3.51 //x2=35.27 //y2=2.26
r1009 (  33 69 ) resistor r=17.7968 //w=0.187 //l=0.26 //layer=li \
 //thickness=0.1 //x=24.17 //y=4.62 //x2=24.17 //y2=4.88
r1010 (  32 33 ) resistor r=50.6524 //w=0.187 //l=0.74 //layer=li \
 //thickness=0.1 //x=24.17 //y=3.88 //x2=24.17 //y2=4.62
r1011 (  31 32 ) resistor r=25.3262 //w=0.187 //l=0.37 //layer=li \
 //thickness=0.1 //x=24.17 //y=3.51 //x2=24.17 //y2=3.88
r1012 (  31 62 ) resistor r=85.5615 //w=0.187 //l=1.25 //layer=li \
 //thickness=0.1 //x=24.17 //y=3.51 //x2=24.17 //y2=2.26
r1013 (  30 53 ) resistor r=6.50267 //w=0.187 //l=0.095 //layer=li \
 //thickness=0.1 //x=13.81 //y=4.62 //x2=13.81 //y2=4.715
r1014 (  29 30 ) resistor r=75.9786 //w=0.187 //l=1.11 //layer=li \
 //thickness=0.1 //x=13.81 //y=3.51 //x2=13.81 //y2=4.62
r1015 (  28 29 ) resistor r=25.3262 //w=0.187 //l=0.37 //layer=li \
 //thickness=0.1 //x=13.81 //y=3.14 //x2=13.81 //y2=3.51
r1016 (  28 55 ) resistor r=60.2353 //w=0.187 //l=0.88 //layer=li \
 //thickness=0.1 //x=13.81 //y=3.14 //x2=13.81 //y2=2.26
r1017 (  27 51 ) resistor r=17.7968 //w=0.187 //l=0.26 //layer=li \
 //thickness=0.1 //x=2.71 //y=4.62 //x2=2.71 //y2=4.88
r1018 (  26 27 ) resistor r=50.6524 //w=0.187 //l=0.74 //layer=li \
 //thickness=0.1 //x=2.71 //y=3.88 //x2=2.71 //y2=4.62
r1019 (  25 26 ) resistor r=25.3262 //w=0.187 //l=0.37 //layer=li \
 //thickness=0.1 //x=2.71 //y=3.51 //x2=2.71 //y2=3.88
r1020 (  24 25 ) resistor r=25.3262 //w=0.187 //l=0.37 //layer=li \
 //thickness=0.1 //x=2.71 //y=3.14 //x2=2.71 //y2=3.51
r1021 (  23 24 ) resistor r=25.3262 //w=0.187 //l=0.37 //layer=li \
 //thickness=0.1 //x=2.71 //y=2.77 //x2=2.71 //y2=3.14
r1022 (  23 42 ) resistor r=34.9091 //w=0.187 //l=0.51 //layer=li \
 //thickness=0.1 //x=2.71 //y=2.77 //x2=2.71 //y2=2.26
r1023 (  22 40 ) resistor r=9.3 //w=0.17 //l=0.17 //layer=mcon //count=1 \
 //x=56.73 //y=4.62 //x2=56.73 //y2=4.62
r1024 (  20 38 ) resistor r=9.3 //w=0.17 //l=0.17 //layer=mcon //count=1 \
 //x=45.63 //y=4.62 //x2=45.63 //y2=4.62
r1025 (  18 35 ) resistor r=9.3 //w=0.17 //l=0.17 //layer=mcon //count=1 \
 //x=35.27 //y=4.62 //x2=35.27 //y2=4.62
r1026 (  16 33 ) resistor r=9.3 //w=0.17 //l=0.17 //layer=mcon //count=1 \
 //x=24.17 //y=4.62 //x2=24.17 //y2=4.62
r1027 (  14 30 ) resistor r=9.3 //w=0.17 //l=0.17 //layer=mcon //count=1 \
 //x=13.81 //y=4.62 //x2=13.81 //y2=4.62
r1028 (  12 27 ) resistor r=9.3 //w=0.17 //l=0.17 //layer=mcon //count=1 \
 //x=2.71 //y=4.62 //x2=2.71 //y2=4.62
r1029 (  10 20 ) resistor r=0.0880901 //w=0.191 //l=0.115 //layer=m1 \
 //thickness=0.36 //x=45.745 //y=4.62 //x2=45.63 //y2=4.62
r1030 (  9 22 ) resistor r=0.0717383 //w=0.224 //l=0.115 //layer=m1 \
 //thickness=0.36 //x=56.615 //y=4.62 //x2=56.73 //y2=4.62
r1031 (  9 10 ) resistor r=10.3721 //w=0.131 //l=10.87 //layer=m1 \
 //thickness=0.36 //x=56.615 //y=4.62 //x2=45.745 //y2=4.62
r1032 (  8 18 ) resistor r=0.0880901 //w=0.191 //l=0.115 //layer=m1 \
 //thickness=0.36 //x=35.385 //y=4.62 //x2=35.27 //y2=4.62
r1033 (  7 20 ) resistor r=0.0880901 //w=0.191 //l=0.115 //layer=m1 \
 //thickness=0.36 //x=45.515 //y=4.62 //x2=45.63 //y2=4.62
r1034 (  7 8 ) resistor r=9.66603 //w=0.131 //l=10.13 //layer=m1 \
 //thickness=0.36 //x=45.515 //y=4.62 //x2=35.385 //y2=4.62
r1035 (  6 16 ) resistor r=0.0835756 //w=0.172 //l=0.115 //layer=m1 \
 //thickness=0.36 //x=24.285 //y=4.62 //x2=24.17 //y2=4.62
r1036 (  5 18 ) resistor r=0.0880901 //w=0.191 //l=0.115 //layer=m1 \
 //thickness=0.36 //x=35.155 //y=4.62 //x2=35.27 //y2=4.62
r1037 (  5 6 ) resistor r=10.3721 //w=0.131 //l=10.87 //layer=m1 \
 //thickness=0.36 //x=35.155 //y=4.62 //x2=24.285 //y2=4.62
r1038 (  4 14 ) resistor r=0.0928915 //w=0.224 //l=0.145997 //layer=m1 \
 //thickness=0.36 //x=13.955 //y=4.622 //x2=13.81 //y2=4.62
r1039 (  3 16 ) resistor r=5.04146 //w=0.172 //l=6.936 //layer=m1 \
 //thickness=0.36 //x=17.235 //y=4.622 //x2=24.17 //y2=4.62
r1040 (  3 4 ) resistor r=3.53448 //w=0.116 //l=3.28 //layer=m1 \
 //thickness=0.36 //x=17.235 //y=4.622 //x2=13.955 //y2=4.622
r1041 (  2 12 ) resistor r=0.0717383 //w=0.224 //l=0.115 //layer=m1 \
 //thickness=0.36 //x=2.825 //y=4.62 //x2=2.71 //y2=4.62
r1042 (  1 14 ) resistor r=0.0717383 //w=0.224 //l=0.115 //layer=m1 \
 //thickness=0.36 //x=13.695 //y=4.62 //x2=13.81 //y2=4.62
r1043 (  1 2 ) resistor r=10.3721 //w=0.131 //l=10.87 //layer=m1 \
 //thickness=0.36 //x=13.695 //y=4.62 //x2=2.825 //y2=4.62
ends PM_TMRDFFQX1\%CLK

subckt PM_TMRDFFQX1\%noxref_17 ( 1 2 3 4 17 18 25 33 39 40 44 46 54 61 62 63 \
 64 65 66 67 68 69 70 71 72 76 78 81 82 86 87 88 89 93 95 98 99 109 118 121 \
 123 124 125 )
c255 ( 125 0 ) capacitor c=0.023087f //x=46.555 //y=5.2
c256 ( 124 0 ) capacitor c=0.023519f //x=45.675 //y=5.2
c257 ( 123 0 ) capacitor c=0.0224735f //x=44.795 //y=5.2
c258 ( 121 0 ) capacitor c=0.00872971f //x=46.805 //y=1.095
c259 ( 118 0 ) capacitor c=0.0593152f //x=59.32 //y=4.88
c260 ( 109 0 ) capacitor c=0.0588816f //x=49.33 //y=4.88
c261 ( 99 0 ) capacitor c=0.0318948f //x=59.655 //y=1.39
c262 ( 98 0 ) capacitor c=0.0187384f //x=59.655 //y=1.045
c263 ( 95 0 ) capacitor c=0.0141798f //x=59.5 //y=1.545
c264 ( 93 0 ) capacitor c=0.0149844f //x=59.5 //y=0.89
c265 ( 89 0 ) capacitor c=0.0813322f //x=59.125 //y=2.095
c266 ( 88 0 ) capacitor c=0.0229267f //x=59.125 //y=1.7
c267 ( 87 0 ) capacitor c=0.0234352f //x=59.125 //y=1.39
c268 ( 86 0 ) capacitor c=0.0199343f //x=59.125 //y=1.045
c269 ( 82 0 ) capacitor c=0.0318948f //x=49.665 //y=1.39
c270 ( 81 0 ) capacitor c=0.0187384f //x=49.665 //y=1.045
c271 ( 78 0 ) capacitor c=0.0141798f //x=49.51 //y=1.545
c272 ( 76 0 ) capacitor c=0.0149844f //x=49.51 //y=0.89
c273 ( 72 0 ) capacitor c=0.0813322f //x=49.135 //y=2.095
c274 ( 71 0 ) capacitor c=0.0229267f //x=49.135 //y=1.7
c275 ( 70 0 ) capacitor c=0.0234352f //x=49.135 //y=1.39
c276 ( 69 0 ) capacitor c=0.0199343f //x=49.135 //y=1.045
c277 ( 68 0 ) capacitor c=0.110275f //x=59.66 //y=6.2
c278 ( 67 0 ) capacitor c=0.154305f //x=59.22 //y=6.2
c279 ( 66 0 ) capacitor c=0.110275f //x=49.67 //y=6.2
c280 ( 65 0 ) capacitor c=0.154305f //x=49.23 //y=6.2
c281 ( 62 0 ) capacitor c=0.00106608f //x=46.7 //y=5.335
c282 ( 61 0 ) capacitor c=0.00207162f //x=45.82 //y=5.335
c283 ( 54 0 ) capacitor c=0.0907958f //x=59.32 //y=2.26
c284 ( 46 0 ) capacitor c=0.0836545f //x=49.33 //y=2.26
c285 ( 44 0 ) capacitor c=0.103675f //x=47.48 //y=3.88
c286 ( 40 0 ) capacitor c=0.00398962f //x=47.08 //y=1.845
c287 ( 39 0 ) capacitor c=0.0137288f //x=47.395 //y=1.845
c288 ( 33 0 ) capacitor c=0.0284988f //x=47.395 //y=5.335
c289 ( 25 0 ) capacitor c=0.0176454f //x=46.615 //y=5.335
c290 ( 18 0 ) capacitor c=0.00332903f //x=45.025 //y=5.335
c291 ( 17 0 ) capacitor c=0.014837f //x=45.735 //y=5.335
c292 ( 4 0 ) capacitor c=0.00424317f //x=49.445 //y=3.88
c293 ( 3 0 ) capacitor c=0.159775f //x=59.205 //y=3.88
c294 ( 2 0 ) capacitor c=0.0125346f //x=47.595 //y=3.88
c295 ( 1 0 ) capacitor c=0.0285004f //x=49.215 //y=3.88
r296 (  116 118 ) resistor r=20.6867 //w=0.233 //l=0.1 //layer=ply \
 //thickness=0.18 //x=59.22 //y=4.88 //x2=59.32 //y2=4.88
r297 (  107 109 ) resistor r=20.6867 //w=0.233 //l=0.1 //layer=ply \
 //thickness=0.18 //x=49.23 //y=4.88 //x2=49.33 //y2=4.88
r298 (  100 118 ) resistor r=70.3348 //w=0.233 //l=0.414367 //layer=ply \
 //thickness=0.18 //x=59.66 //y=5.045 //x2=59.32 //y2=4.88
r299 (  99 120 ) resistor r=45.1352 //w=0.168 //l=0.173853 //layer=ply \
 //thickness=0.18 //x=59.655 //y=1.39 //x2=59.615 //y2=1.545
r300 (  98 119 ) resistor r=45.1352 //w=0.168 //l=0.173853 //layer=ply \
 //thickness=0.18 //x=59.655 //y=1.045 //x2=59.615 //y2=0.89
r301 (  98 99 ) resistor r=176.904 //w=0.094 //l=0.345 //layer=ply \
 //thickness=0.18 //x=59.655 //y=1.045 //x2=59.655 //y2=1.39
r302 (  96 115 ) resistor r=10.701 //w=0.21 //l=0.115 //layer=ply \
 //thickness=0.18 //x=59.28 //y=1.545 //x2=59.165 //y2=1.545
r303 (  95 120 ) resistor r=5.52526 //w=0.168 //l=0.115 //layer=ply \
 //thickness=0.18 //x=59.5 //y=1.545 //x2=59.615 //y2=1.545
r304 (  94 114 ) resistor r=5.52526 //w=0.168 //l=0.115 //layer=ply \
 //thickness=0.18 //x=59.28 //y=0.89 //x2=59.165 //y2=0.89
r305 (  93 119 ) resistor r=5.52526 //w=0.168 //l=0.115 //layer=ply \
 //thickness=0.18 //x=59.5 //y=0.89 //x2=59.615 //y2=0.89
r306 (  93 94 ) resistor r=112.809 //w=0.094 //l=0.22 //layer=ply \
 //thickness=0.18 //x=59.5 //y=0.89 //x2=59.28 //y2=0.89
r307 (  90 116 ) resistor r=13.0941 //w=0.233 //l=0.165 //layer=ply \
 //thickness=0.18 //x=59.22 //y=5.045 //x2=59.22 //y2=4.88
r308 (  89 113 ) resistor r=34.8111 //w=0.27 //l=0.264953 //layer=ply \
 //thickness=0.18 //x=59.125 //y=2.095 //x2=59.32 //y2=2.26
r309 (  88 115 ) resistor r=39.5823 //w=0.21 //l=0.173853 //layer=ply \
 //thickness=0.18 //x=59.125 //y=1.7 //x2=59.165 //y2=1.545
r310 (  88 89 ) resistor r=202.543 //w=0.094 //l=0.395 //layer=ply \
 //thickness=0.18 //x=59.125 //y=1.7 //x2=59.125 //y2=2.095
r311 (  87 115 ) resistor r=39.5823 //w=0.21 //l=0.173853 //layer=ply \
 //thickness=0.18 //x=59.125 //y=1.39 //x2=59.165 //y2=1.545
r312 (  86 114 ) resistor r=45.1352 //w=0.168 //l=0.173853 //layer=ply \
 //thickness=0.18 //x=59.125 //y=1.045 //x2=59.165 //y2=0.89
r313 (  86 87 ) resistor r=176.904 //w=0.094 //l=0.345 //layer=ply \
 //thickness=0.18 //x=59.125 //y=1.045 //x2=59.125 //y2=1.39
r314 (  83 109 ) resistor r=70.3348 //w=0.233 //l=0.414367 //layer=ply \
 //thickness=0.18 //x=49.67 //y=5.045 //x2=49.33 //y2=4.88
r315 (  82 111 ) resistor r=45.1352 //w=0.168 //l=0.173853 //layer=ply \
 //thickness=0.18 //x=49.665 //y=1.39 //x2=49.625 //y2=1.545
r316 (  81 110 ) resistor r=45.1352 //w=0.168 //l=0.173853 //layer=ply \
 //thickness=0.18 //x=49.665 //y=1.045 //x2=49.625 //y2=0.89
r317 (  81 82 ) resistor r=176.904 //w=0.094 //l=0.345 //layer=ply \
 //thickness=0.18 //x=49.665 //y=1.045 //x2=49.665 //y2=1.39
r318 (  79 106 ) resistor r=10.701 //w=0.21 //l=0.115 //layer=ply \
 //thickness=0.18 //x=49.29 //y=1.545 //x2=49.175 //y2=1.545
r319 (  78 111 ) resistor r=5.52526 //w=0.168 //l=0.115 //layer=ply \
 //thickness=0.18 //x=49.51 //y=1.545 //x2=49.625 //y2=1.545
r320 (  77 105 ) resistor r=5.52526 //w=0.168 //l=0.115 //layer=ply \
 //thickness=0.18 //x=49.29 //y=0.89 //x2=49.175 //y2=0.89
r321 (  76 110 ) resistor r=5.52526 //w=0.168 //l=0.115 //layer=ply \
 //thickness=0.18 //x=49.51 //y=0.89 //x2=49.625 //y2=0.89
r322 (  76 77 ) resistor r=112.809 //w=0.094 //l=0.22 //layer=ply \
 //thickness=0.18 //x=49.51 //y=0.89 //x2=49.29 //y2=0.89
r323 (  73 107 ) resistor r=13.0941 //w=0.233 //l=0.165 //layer=ply \
 //thickness=0.18 //x=49.23 //y=5.045 //x2=49.23 //y2=4.88
r324 (  72 104 ) resistor r=34.8111 //w=0.27 //l=0.264953 //layer=ply \
 //thickness=0.18 //x=49.135 //y=2.095 //x2=49.33 //y2=2.26
r325 (  71 106 ) resistor r=39.5823 //w=0.21 //l=0.173853 //layer=ply \
 //thickness=0.18 //x=49.135 //y=1.7 //x2=49.175 //y2=1.545
r326 (  71 72 ) resistor r=202.543 //w=0.094 //l=0.395 //layer=ply \
 //thickness=0.18 //x=49.135 //y=1.7 //x2=49.135 //y2=2.095
r327 (  70 106 ) resistor r=39.5823 //w=0.21 //l=0.173853 //layer=ply \
 //thickness=0.18 //x=49.135 //y=1.39 //x2=49.175 //y2=1.545
r328 (  69 105 ) resistor r=45.1352 //w=0.168 //l=0.173853 //layer=ply \
 //thickness=0.18 //x=49.135 //y=1.045 //x2=49.175 //y2=0.89
r329 (  69 70 ) resistor r=176.904 //w=0.094 //l=0.345 //layer=ply \
 //thickness=0.18 //x=49.135 //y=1.045 //x2=49.135 //y2=1.39
r330 (  68 100 ) resistor r=592.245 //w=0.094 //l=1.155 //layer=ply \
 //thickness=0.18 //x=59.66 //y=6.2 //x2=59.66 //y2=5.045
r331 (  67 90 ) resistor r=592.245 //w=0.094 //l=1.155 //layer=ply \
 //thickness=0.18 //x=59.22 //y=6.2 //x2=59.22 //y2=5.045
r332 (  66 83 ) resistor r=592.245 //w=0.094 //l=1.155 //layer=ply \
 //thickness=0.18 //x=49.67 //y=6.2 //x2=49.67 //y2=5.045
r333 (  65 73 ) resistor r=592.245 //w=0.094 //l=1.155 //layer=ply \
 //thickness=0.18 //x=49.23 //y=6.2 //x2=49.23 //y2=5.045
r334 (  64 95 ) resistor r=56.4043 //w=0.094 //l=0.11 //layer=ply \
 //thickness=0.18 //x=59.39 //y=1.545 //x2=59.5 //y2=1.545
r335 (  64 96 ) resistor r=56.4043 //w=0.094 //l=0.11 //layer=ply \
 //thickness=0.18 //x=59.39 //y=1.545 //x2=59.28 //y2=1.545
r336 (  63 78 ) resistor r=56.4043 //w=0.094 //l=0.11 //layer=ply \
 //thickness=0.18 //x=49.4 //y=1.545 //x2=49.51 //y2=1.545
r337 (  63 79 ) resistor r=56.4043 //w=0.094 //l=0.11 //layer=ply \
 //thickness=0.18 //x=49.4 //y=1.545 //x2=49.29 //y2=1.545
r338 (  59 118 ) resistor r=152 //w=0.17 //l=0.17 //layer=licon //count=1 \
 //x=59.32 //y=4.88 //x2=59.32 //y2=4.88
r339 (  57 59 ) resistor r=68.4492 //w=0.187 //l=1 //layer=li //thickness=0.1 \
 //x=59.32 //y=3.88 //x2=59.32 //y2=4.88
r340 (  54 113 ) resistor r=152 //w=0.17 //l=0.17 //layer=licon //count=1 \
 //x=59.32 //y=2.26 //x2=59.32 //y2=2.26
r341 (  54 57 ) resistor r=110.888 //w=0.187 //l=1.62 //layer=li \
 //thickness=0.1 //x=59.32 //y=2.26 //x2=59.32 //y2=3.88
r342 (  51 109 ) resistor r=152 //w=0.17 //l=0.17 //layer=licon //count=1 \
 //x=49.33 //y=4.88 //x2=49.33 //y2=4.88
r343 (  49 51 ) resistor r=68.4492 //w=0.187 //l=1 //layer=li //thickness=0.1 \
 //x=49.33 //y=3.88 //x2=49.33 //y2=4.88
r344 (  46 104 ) resistor r=152 //w=0.17 //l=0.17 //layer=licon //count=1 \
 //x=49.33 //y=2.26 //x2=49.33 //y2=2.26
r345 (  46 49 ) resistor r=110.888 //w=0.187 //l=1.62 //layer=li \
 //thickness=0.1 //x=49.33 //y=2.26 //x2=49.33 //y2=3.88
r346 (  42 44 ) resistor r=93.7754 //w=0.187 //l=1.37 //layer=li \
 //thickness=0.1 //x=47.48 //y=5.25 //x2=47.48 //y2=3.88
r347 (  41 44 ) resistor r=133.476 //w=0.187 //l=1.95 //layer=li \
 //thickness=0.1 //x=47.48 //y=1.93 //x2=47.48 //y2=3.88
r348 (  39 41 ) resistor r=7.15173 //w=0.17 //l=0.120208 //layer=li \
 //thickness=0.1 //x=47.395 //y=1.845 //x2=47.48 //y2=1.93
r349 (  39 40 ) resistor r=21.5615 //w=0.187 //l=0.315 //layer=li \
 //thickness=0.1 //x=47.395 //y=1.845 //x2=47.08 //y2=1.845
r350 (  35 40 ) resistor r=7.15173 //w=0.17 //l=0.120208 //layer=li \
 //thickness=0.1 //x=46.995 //y=1.76 //x2=47.08 //y2=1.845
r351 (  35 121 ) resistor r=39.016 //w=0.187 //l=0.57 //layer=li \
 //thickness=0.1 //x=46.995 //y=1.76 //x2=46.995 //y2=1.19
r352 (  34 62 ) resistor r=5.4201 //w=0.17 //l=0.085 //layer=li \
 //thickness=0.1 //x=46.785 //y=5.335 //x2=46.7 //y2=5.335
r353 (  33 42 ) resistor r=7.15173 //w=0.17 //l=0.120208 //layer=li \
 //thickness=0.1 //x=47.395 //y=5.335 //x2=47.48 //y2=5.25
r354 (  33 34 ) resistor r=41.754 //w=0.187 //l=0.61 //layer=li \
 //thickness=0.1 //x=47.395 //y=5.335 //x2=46.785 //y2=5.335
r355 (  27 62 ) resistor r=1.40859 //w=0.34 //l=0.085 //layer=li \
 //thickness=0.1 //x=46.7 //y=5.42 //x2=46.7 //y2=5.335
r356 (  27 125 ) resistor r=33.1979 //w=0.187 //l=0.485 //layer=li \
 //thickness=0.1 //x=46.7 //y=5.42 //x2=46.7 //y2=5.905
r357 (  26 61 ) resistor r=5.4201 //w=0.17 //l=0.085 //layer=li \
 //thickness=0.1 //x=45.905 //y=5.335 //x2=45.82 //y2=5.335
r358 (  25 62 ) resistor r=5.4201 //w=0.17 //l=0.085 //layer=li \
 //thickness=0.1 //x=46.615 //y=5.335 //x2=46.7 //y2=5.335
r359 (  25 26 ) resistor r=48.5989 //w=0.187 //l=0.71 //layer=li \
 //thickness=0.1 //x=46.615 //y=5.335 //x2=45.905 //y2=5.335
r360 (  19 61 ) resistor r=1.40859 //w=0.34 //l=0.085 //layer=li \
 //thickness=0.1 //x=45.82 //y=5.42 //x2=45.82 //y2=5.335
r361 (  19 124 ) resistor r=33.1979 //w=0.187 //l=0.485 //layer=li \
 //thickness=0.1 //x=45.82 //y=5.42 //x2=45.82 //y2=5.905
r362 (  17 61 ) resistor r=5.4201 //w=0.17 //l=0.085 //layer=li \
 //thickness=0.1 //x=45.735 //y=5.335 //x2=45.82 //y2=5.335
r363 (  17 18 ) resistor r=48.5989 //w=0.187 //l=0.71 //layer=li \
 //thickness=0.1 //x=45.735 //y=5.335 //x2=45.025 //y2=5.335
r364 (  11 18 ) resistor r=7.15173 //w=0.17 //l=0.120208 //layer=li \
 //thickness=0.1 //x=44.94 //y=5.42 //x2=45.025 //y2=5.335
r365 (  11 123 ) resistor r=33.1979 //w=0.187 //l=0.485 //layer=li \
 //thickness=0.1 //x=44.94 //y=5.42 //x2=44.94 //y2=5.905
r366 (  10 57 ) resistor r=9.3 //w=0.17 //l=0.17 //layer=mcon //count=1 \
 //x=59.32 //y=3.88 //x2=59.32 //y2=3.88
r367 (  8 49 ) resistor r=9.3 //w=0.17 //l=0.17 //layer=mcon //count=1 \
 //x=49.33 //y=3.88 //x2=49.33 //y2=3.88
r368 (  6 44 ) resistor r=9.3 //w=0.17 //l=0.17 //layer=mcon //count=1 \
 //x=47.48 //y=3.88 //x2=47.48 //y2=3.88
r369 (  4 8 ) resistor r=0.0880901 //w=0.191 //l=0.115 //layer=m1 \
 //thickness=0.36 //x=49.445 //y=3.88 //x2=49.33 //y2=3.88
r370 (  3 10 ) resistor r=0.0717383 //w=0.224 //l=0.115 //layer=m1 \
 //thickness=0.36 //x=59.205 //y=3.88 //x2=59.32 //y2=3.88
r371 (  3 4 ) resistor r=9.31298 //w=0.131 //l=9.76 //layer=m1 \
 //thickness=0.36 //x=59.205 //y=3.88 //x2=49.445 //y2=3.88
r372 (  2 6 ) resistor r=0.0717383 //w=0.224 //l=0.115 //layer=m1 \
 //thickness=0.36 //x=47.595 //y=3.88 //x2=47.48 //y2=3.88
r373 (  1 8 ) resistor r=0.0880901 //w=0.191 //l=0.115 //layer=m1 \
 //thickness=0.36 //x=49.215 //y=3.88 //x2=49.33 //y2=3.88
r374 (  1 2 ) resistor r=1.5458 //w=0.131 //l=1.62 //layer=m1 //thickness=0.36 \
 //x=49.215 //y=3.88 //x2=47.595 //y2=3.88
ends PM_TMRDFFQX1\%noxref_17

subckt PM_TMRDFFQX1\%noxref_18 ( 1 2 13 14 25 27 28 32 34 41 42 43 44 45 46 47 \
 48 52 54 57 58 68 71 73 74 )
c158 ( 74 0 ) capacitor c=0.0220291f //x=60.175 //y=5.2
c159 ( 73 0 ) capacitor c=0.0217503f //x=59.295 //y=5.2
c160 ( 71 0 ) capacitor c=0.00866655f //x=60.17 //y=1.085
c161 ( 68 0 ) capacitor c=0.0591178f //x=62.65 //y=4.88
c162 ( 58 0 ) capacitor c=0.0318948f //x=62.985 //y=1.39
c163 ( 57 0 ) capacitor c=0.0187384f //x=62.985 //y=1.045
c164 ( 54 0 ) capacitor c=0.0141798f //x=62.83 //y=1.545
c165 ( 52 0 ) capacitor c=0.0149844f //x=62.83 //y=0.89
c166 ( 48 0 ) capacitor c=0.0813322f //x=62.455 //y=2.095
c167 ( 47 0 ) capacitor c=0.0229267f //x=62.455 //y=1.7
c168 ( 46 0 ) capacitor c=0.0234352f //x=62.455 //y=1.39
c169 ( 45 0 ) capacitor c=0.0199343f //x=62.455 //y=1.045
c170 ( 44 0 ) capacitor c=0.110275f //x=62.99 //y=6.2
c171 ( 43 0 ) capacitor c=0.154305f //x=62.55 //y=6.2
c172 ( 41 0 ) capacitor c=0.0023043f //x=60.32 //y=5.38
c173 ( 34 0 ) capacitor c=0.0895062f //x=62.65 //y=2.26
c174 ( 32 0 ) capacitor c=0.107504f //x=60.8 //y=4.62
c175 ( 28 0 ) capacitor c=0.00404073f //x=60.445 //y=1.835
c176 ( 27 0 ) capacitor c=0.0122201f //x=60.715 //y=1.835
c177 ( 25 0 ) capacitor c=0.013932f //x=60.715 //y=5.38
c178 ( 14 0 ) capacitor c=0.00265417f //x=59.525 //y=5.38
c179 ( 13 0 ) capacitor c=0.0149571f //x=60.235 //y=5.38
c180 ( 2 0 ) capacitor c=0.0110676f //x=60.915 //y=4.62
c181 ( 1 0 ) capacitor c=0.0525534f //x=62.535 //y=4.62
r182 (  66 68 ) resistor r=20.6867 //w=0.233 //l=0.1 //layer=ply \
 //thickness=0.18 //x=62.55 //y=4.88 //x2=62.65 //y2=4.88
r183 (  59 68 ) resistor r=70.3348 //w=0.233 //l=0.414367 //layer=ply \
 //thickness=0.18 //x=62.99 //y=5.045 //x2=62.65 //y2=4.88
r184 (  58 70 ) resistor r=45.1352 //w=0.168 //l=0.173853 //layer=ply \
 //thickness=0.18 //x=62.985 //y=1.39 //x2=62.945 //y2=1.545
r185 (  57 69 ) resistor r=45.1352 //w=0.168 //l=0.173853 //layer=ply \
 //thickness=0.18 //x=62.985 //y=1.045 //x2=62.945 //y2=0.89
r186 (  57 58 ) resistor r=176.904 //w=0.094 //l=0.345 //layer=ply \
 //thickness=0.18 //x=62.985 //y=1.045 //x2=62.985 //y2=1.39
r187 (  55 65 ) resistor r=10.701 //w=0.21 //l=0.115 //layer=ply \
 //thickness=0.18 //x=62.61 //y=1.545 //x2=62.495 //y2=1.545
r188 (  54 70 ) resistor r=5.52526 //w=0.168 //l=0.115 //layer=ply \
 //thickness=0.18 //x=62.83 //y=1.545 //x2=62.945 //y2=1.545
r189 (  53 64 ) resistor r=5.52526 //w=0.168 //l=0.115 //layer=ply \
 //thickness=0.18 //x=62.61 //y=0.89 //x2=62.495 //y2=0.89
r190 (  52 69 ) resistor r=5.52526 //w=0.168 //l=0.115 //layer=ply \
 //thickness=0.18 //x=62.83 //y=0.89 //x2=62.945 //y2=0.89
r191 (  52 53 ) resistor r=112.809 //w=0.094 //l=0.22 //layer=ply \
 //thickness=0.18 //x=62.83 //y=0.89 //x2=62.61 //y2=0.89
r192 (  49 66 ) resistor r=13.0941 //w=0.233 //l=0.165 //layer=ply \
 //thickness=0.18 //x=62.55 //y=5.045 //x2=62.55 //y2=4.88
r193 (  48 63 ) resistor r=34.8111 //w=0.27 //l=0.264953 //layer=ply \
 //thickness=0.18 //x=62.455 //y=2.095 //x2=62.65 //y2=2.26
r194 (  47 65 ) resistor r=39.5823 //w=0.21 //l=0.173853 //layer=ply \
 //thickness=0.18 //x=62.455 //y=1.7 //x2=62.495 //y2=1.545
r195 (  47 48 ) resistor r=202.543 //w=0.094 //l=0.395 //layer=ply \
 //thickness=0.18 //x=62.455 //y=1.7 //x2=62.455 //y2=2.095
r196 (  46 65 ) resistor r=39.5823 //w=0.21 //l=0.173853 //layer=ply \
 //thickness=0.18 //x=62.455 //y=1.39 //x2=62.495 //y2=1.545
r197 (  45 64 ) resistor r=45.1352 //w=0.168 //l=0.173853 //layer=ply \
 //thickness=0.18 //x=62.455 //y=1.045 //x2=62.495 //y2=0.89
r198 (  45 46 ) resistor r=176.904 //w=0.094 //l=0.345 //layer=ply \
 //thickness=0.18 //x=62.455 //y=1.045 //x2=62.455 //y2=1.39
r199 (  44 59 ) resistor r=592.245 //w=0.094 //l=1.155 //layer=ply \
 //thickness=0.18 //x=62.99 //y=6.2 //x2=62.99 //y2=5.045
r200 (  43 49 ) resistor r=592.245 //w=0.094 //l=1.155 //layer=ply \
 //thickness=0.18 //x=62.55 //y=6.2 //x2=62.55 //y2=5.045
r201 (  42 54 ) resistor r=56.4043 //w=0.094 //l=0.11 //layer=ply \
 //thickness=0.18 //x=62.72 //y=1.545 //x2=62.83 //y2=1.545
r202 (  42 55 ) resistor r=56.4043 //w=0.094 //l=0.11 //layer=ply \
 //thickness=0.18 //x=62.72 //y=1.545 //x2=62.61 //y2=1.545
r203 (  39 68 ) resistor r=152 //w=0.17 //l=0.17 //layer=licon //count=1 \
 //x=62.65 //y=4.88 //x2=62.65 //y2=4.88
r204 (  37 39 ) resistor r=17.7968 //w=0.187 //l=0.26 //layer=li \
 //thickness=0.1 //x=62.65 //y=4.62 //x2=62.65 //y2=4.88
r205 (  34 63 ) resistor r=152 //w=0.17 //l=0.17 //layer=licon //count=1 \
 //x=62.65 //y=2.26 //x2=62.65 //y2=2.26
r206 (  34 37 ) resistor r=161.54 //w=0.187 //l=2.36 //layer=li \
 //thickness=0.1 //x=62.65 //y=2.26 //x2=62.65 //y2=4.62
r207 (  30 32 ) resistor r=46.2032 //w=0.187 //l=0.675 //layer=li \
 //thickness=0.1 //x=60.8 //y=5.295 //x2=60.8 //y2=4.62
r208 (  29 32 ) resistor r=184.813 //w=0.187 //l=2.7 //layer=li \
 //thickness=0.1 //x=60.8 //y=1.92 //x2=60.8 //y2=4.62
r209 (  27 29 ) resistor r=7.15173 //w=0.17 //l=0.120208 //layer=li \
 //thickness=0.1 //x=60.715 //y=1.835 //x2=60.8 //y2=1.92
r210 (  27 28 ) resistor r=18.4813 //w=0.187 //l=0.27 //layer=li \
 //thickness=0.1 //x=60.715 //y=1.835 //x2=60.445 //y2=1.835
r211 (  26 41 ) resistor r=5.4201 //w=0.17 //l=0.085 //layer=li \
 //thickness=0.1 //x=60.405 //y=5.38 //x2=60.32 //y2=5.38
r212 (  25 30 ) resistor r=7.15173 //w=0.17 //l=0.120208 //layer=li \
 //thickness=0.1 //x=60.715 //y=5.38 //x2=60.8 //y2=5.295
r213 (  25 26 ) resistor r=21.2193 //w=0.187 //l=0.31 //layer=li \
 //thickness=0.1 //x=60.715 //y=5.38 //x2=60.405 //y2=5.38
r214 (  21 28 ) resistor r=7.15173 //w=0.17 //l=0.120208 //layer=li \
 //thickness=0.1 //x=60.36 //y=1.75 //x2=60.445 //y2=1.835
r215 (  21 71 ) resistor r=39.016 //w=0.187 //l=0.57 //layer=li \
 //thickness=0.1 //x=60.36 //y=1.75 //x2=60.36 //y2=1.18
r216 (  15 41 ) resistor r=1.40859 //w=0.34 //l=0.085 //layer=li \
 //thickness=0.1 //x=60.32 //y=5.465 //x2=60.32 //y2=5.38
r217 (  15 74 ) resistor r=30.1176 //w=0.187 //l=0.44 //layer=li \
 //thickness=0.1 //x=60.32 //y=5.465 //x2=60.32 //y2=5.905
r218 (  13 41 ) resistor r=5.4201 //w=0.17 //l=0.085 //layer=li \
 //thickness=0.1 //x=60.235 //y=5.38 //x2=60.32 //y2=5.38
r219 (  13 14 ) resistor r=48.5989 //w=0.187 //l=0.71 //layer=li \
 //thickness=0.1 //x=60.235 //y=5.38 //x2=59.525 //y2=5.38
r220 (  7 14 ) resistor r=7.15173 //w=0.17 //l=0.120208 //layer=li \
 //thickness=0.1 //x=59.44 //y=5.465 //x2=59.525 //y2=5.38
r221 (  7 73 ) resistor r=30.1176 //w=0.187 //l=0.44 //layer=li \
 //thickness=0.1 //x=59.44 //y=5.465 //x2=59.44 //y2=5.905
r222 (  6 37 ) resistor r=9.3 //w=0.17 //l=0.17 //layer=mcon //count=1 \
 //x=62.65 //y=4.62 //x2=62.65 //y2=4.62
r223 (  4 32 ) resistor r=9.3 //w=0.17 //l=0.17 //layer=mcon //count=1 \
 //x=60.8 //y=4.62 //x2=60.8 //y2=4.62
r224 (  2 4 ) resistor r=0.0717383 //w=0.224 //l=0.115 //layer=m1 \
 //thickness=0.36 //x=60.915 //y=4.62 //x2=60.8 //y2=4.62
r225 (  1 6 ) resistor r=0.0717383 //w=0.224 //l=0.115 //layer=m1 \
 //thickness=0.36 //x=62.535 //y=4.62 //x2=62.65 //y2=4.62
r226 (  1 2 ) resistor r=1.5458 //w=0.131 //l=1.62 //layer=m1 //thickness=0.36 \
 //x=62.535 //y=4.62 //x2=60.915 //y2=4.62
ends PM_TMRDFFQX1\%noxref_18

subckt PM_TMRDFFQX1\%noxref_19 ( 1 2 3 4 5 6 16 23 25 35 36 47 49 50 54 55 57 \
 63 66 67 68 69 70 71 72 73 74 75 76 77 78 79 81 87 88 89 90 94 95 96 101 103 \
 105 111 112 113 114 115 120 122 124 130 131 141 142 145 154 155 158 166 168 \
 169 )
c370 ( 169 0 ) capacitor c=0.0220291f //x=56.845 //y=5.2
c371 ( 168 0 ) capacitor c=0.0217503f //x=55.965 //y=5.2
c372 ( 166 0 ) capacitor c=0.00866655f //x=56.84 //y=1.085
c373 ( 158 0 ) capacitor c=0.0333434f //x=63.42 //y=4.88
c374 ( 155 0 ) capacitor c=0.0279499f //x=63.39 //y=2.095
c375 ( 154 0 ) capacitor c=0.0421676f //x=63.39 //y=2.26
c376 ( 145 0 ) capacitor c=0.0331095f //x=53.43 //y=4.88
c377 ( 142 0 ) capacitor c=0.0279499f //x=53.4 //y=2.095
c378 ( 141 0 ) capacitor c=0.0421676f //x=53.4 //y=2.26
c379 ( 131 0 ) capacitor c=0.0429696f //x=63.955 //y=1.43
c380 ( 130 0 ) capacitor c=0.0192208f //x=63.955 //y=1.085
c381 ( 124 0 ) capacitor c=0.0148884f //x=63.8 //y=1.585
c382 ( 122 0 ) capacitor c=0.0157803f //x=63.8 //y=0.93
c383 ( 120 0 ) capacitor c=0.0307199f //x=63.795 //y=4.97
c384 ( 115 0 ) capacitor c=0.0205163f //x=63.425 //y=1.74
c385 ( 114 0 ) capacitor c=0.0168481f //x=63.425 //y=1.43
c386 ( 113 0 ) capacitor c=0.0174783f //x=63.425 //y=1.085
c387 ( 112 0 ) capacitor c=0.0429696f //x=53.965 //y=1.43
c388 ( 111 0 ) capacitor c=0.0192208f //x=53.965 //y=1.085
c389 ( 105 0 ) capacitor c=0.0148884f //x=53.81 //y=1.585
c390 ( 103 0 ) capacitor c=0.0157803f //x=53.81 //y=0.93
c391 ( 101 0 ) capacitor c=0.0295235f //x=53.805 //y=4.97
c392 ( 96 0 ) capacitor c=0.0205163f //x=53.435 //y=1.74
c393 ( 95 0 ) capacitor c=0.0168481f //x=53.435 //y=1.43
c394 ( 94 0 ) capacitor c=0.0174783f //x=53.435 //y=1.085
c395 ( 90 0 ) capacitor c=0.0557698f //x=44.795 //y=4.97
c396 ( 89 0 ) capacitor c=0.0293157f //x=45.085 //y=4.97
c397 ( 88 0 ) capacitor c=0.0347816f //x=44.75 //y=1.4
c398 ( 87 0 ) capacitor c=0.0187487f //x=44.75 //y=1.055
c399 ( 81 0 ) capacitor c=0.0137055f //x=44.595 //y=1.555
c400 ( 79 0 ) capacitor c=0.0149861f //x=44.595 //y=0.9
c401 ( 78 0 ) capacitor c=0.096037f //x=44.22 //y=2.095
c402 ( 77 0 ) capacitor c=0.0228993f //x=44.22 //y=1.71
c403 ( 76 0 ) capacitor c=0.0234352f //x=44.22 //y=1.4
c404 ( 75 0 ) capacitor c=0.0198724f //x=44.22 //y=1.055
c405 ( 74 0 ) capacitor c=0.15358f //x=63.87 //y=6.2
c406 ( 73 0 ) capacitor c=0.110281f //x=63.43 //y=6.2
c407 ( 72 0 ) capacitor c=0.15358f //x=53.88 //y=6.2
c408 ( 71 0 ) capacitor c=0.110281f //x=53.44 //y=6.2
c409 ( 70 0 ) capacitor c=0.110114f //x=45.16 //y=6.2
c410 ( 69 0 ) capacitor c=0.158956f //x=44.72 //y=6.2
c411 ( 63 0 ) capacitor c=0.0023043f //x=56.99 //y=5.38
c412 ( 57 0 ) capacitor c=0.0728897f //x=63.39 //y=2.26
c413 ( 55 0 ) capacitor c=0.00453889f //x=63.39 //y=4.715
c414 ( 54 0 ) capacitor c=0.107708f //x=57.47 //y=4.25
c415 ( 50 0 ) capacitor c=0.00404073f //x=57.115 //y=1.835
c416 ( 49 0 ) capacitor c=0.0122201f //x=57.385 //y=1.835
c417 ( 47 0 ) capacitor c=0.0140419f //x=57.385 //y=5.38
c418 ( 36 0 ) capacitor c=0.00251459f //x=56.195 //y=5.38
c419 ( 35 0 ) capacitor c=0.0143111f //x=56.905 //y=5.38
c420 ( 25 0 ) capacitor c=0.0699131f //x=53.4 //y=2.26
c421 ( 23 0 ) capacitor c=0.00453889f //x=53.4 //y=4.715
c422 ( 16 0 ) capacitor c=0.100766f //x=44.52 //y=2.26
c423 ( 6 0 ) capacitor c=0.00579155f //x=57.585 //y=4.25
c424 ( 5 0 ) capacitor c=0.136665f //x=63.275 //y=4.25
c425 ( 4 0 ) capacitor c=0.00412846f //x=53.515 //y=4.25
c426 ( 3 0 ) capacitor c=0.0575173f //x=57.355 //y=4.25
c427 ( 2 0 ) capacitor c=0.0101712f //x=44.635 //y=4.25
c428 ( 1 0 ) capacitor c=0.130427f //x=53.285 //y=4.25
r429 (  160 161 ) resistor r=32.4568 //w=0.214 //l=0.075 //layer=ply \
 //thickness=0.18 //x=63.42 //y=4.97 //x2=63.42 //y2=5.045
r430 (  158 160 ) resistor r=20.271 //w=0.214 //l=0.09 //layer=ply \
 //thickness=0.18 //x=63.42 //y=4.88 //x2=63.42 //y2=4.97
r431 (  154 155 ) resistor r=52.7279 //w=0.214 //l=0.165 //layer=ply \
 //thickness=0.18 //x=63.39 //y=2.26 //x2=63.39 //y2=2.095
r432 (  147 148 ) resistor r=32.4568 //w=0.214 //l=0.075 //layer=ply \
 //thickness=0.18 //x=53.43 //y=4.97 //x2=53.43 //y2=5.045
r433 (  145 147 ) resistor r=20.271 //w=0.214 //l=0.09 //layer=ply \
 //thickness=0.18 //x=53.43 //y=4.88 //x2=53.43 //y2=4.97
r434 (  141 142 ) resistor r=52.7279 //w=0.214 //l=0.165 //layer=ply \
 //thickness=0.18 //x=53.4 //y=2.26 //x2=53.4 //y2=2.095
r435 (  131 165 ) resistor r=45.1352 //w=0.168 //l=0.173853 //layer=ply \
 //thickness=0.18 //x=63.955 //y=1.43 //x2=63.915 //y2=1.585
r436 (  130 164 ) resistor r=45.1352 //w=0.168 //l=0.173853 //layer=ply \
 //thickness=0.18 //x=63.955 //y=1.085 //x2=63.915 //y2=0.93
r437 (  130 131 ) resistor r=176.904 //w=0.094 //l=0.345 //layer=ply \
 //thickness=0.18 //x=63.955 //y=1.085 //x2=63.955 //y2=1.43
r438 (  125 163 ) resistor r=10.701 //w=0.21 //l=0.115 //layer=ply \
 //thickness=0.18 //x=63.58 //y=1.585 //x2=63.465 //y2=1.585
r439 (  124 165 ) resistor r=5.52526 //w=0.168 //l=0.115 //layer=ply \
 //thickness=0.18 //x=63.8 //y=1.585 //x2=63.915 //y2=1.585
r440 (  123 162 ) resistor r=5.52526 //w=0.168 //l=0.115 //layer=ply \
 //thickness=0.18 //x=63.58 //y=0.93 //x2=63.465 //y2=0.93
r441 (  122 164 ) resistor r=5.52526 //w=0.168 //l=0.115 //layer=ply \
 //thickness=0.18 //x=63.8 //y=0.93 //x2=63.915 //y2=0.93
r442 (  122 123 ) resistor r=112.809 //w=0.094 //l=0.22 //layer=ply \
 //thickness=0.18 //x=63.8 //y=0.93 //x2=63.58 //y2=0.93
r443 (  121 160 ) resistor r=16.5046 //w=0.27 //l=0.135 //layer=ply \
 //thickness=0.18 //x=63.555 //y=4.97 //x2=63.42 //y2=4.97
r444 (  120 127 ) resistor r=26.9307 //w=0.15 //l=0.106066 //layer=ply \
 //thickness=0.18 //x=63.795 //y=4.97 //x2=63.87 //y2=5.045
r445 (  120 121 ) resistor r=123.064 //w=0.094 //l=0.24 //layer=ply \
 //thickness=0.18 //x=63.795 //y=4.97 //x2=63.555 //y2=4.97
r446 (  115 163 ) resistor r=39.5823 //w=0.21 //l=0.173853 //layer=ply \
 //thickness=0.18 //x=63.425 //y=1.74 //x2=63.465 //y2=1.585
r447 (  115 155 ) resistor r=182.032 //w=0.094 //l=0.355 //layer=ply \
 //thickness=0.18 //x=63.425 //y=1.74 //x2=63.425 //y2=2.095
r448 (  114 163 ) resistor r=39.5823 //w=0.21 //l=0.173853 //layer=ply \
 //thickness=0.18 //x=63.425 //y=1.43 //x2=63.465 //y2=1.585
r449 (  113 162 ) resistor r=45.1352 //w=0.168 //l=0.173853 //layer=ply \
 //thickness=0.18 //x=63.425 //y=1.085 //x2=63.465 //y2=0.93
r450 (  113 114 ) resistor r=176.904 //w=0.094 //l=0.345 //layer=ply \
 //thickness=0.18 //x=63.425 //y=1.085 //x2=63.425 //y2=1.43
r451 (  112 152 ) resistor r=45.1352 //w=0.168 //l=0.173853 //layer=ply \
 //thickness=0.18 //x=53.965 //y=1.43 //x2=53.925 //y2=1.585
r452 (  111 151 ) resistor r=45.1352 //w=0.168 //l=0.173853 //layer=ply \
 //thickness=0.18 //x=53.965 //y=1.085 //x2=53.925 //y2=0.93
r453 (  111 112 ) resistor r=176.904 //w=0.094 //l=0.345 //layer=ply \
 //thickness=0.18 //x=53.965 //y=1.085 //x2=53.965 //y2=1.43
r454 (  106 150 ) resistor r=10.701 //w=0.21 //l=0.115 //layer=ply \
 //thickness=0.18 //x=53.59 //y=1.585 //x2=53.475 //y2=1.585
r455 (  105 152 ) resistor r=5.52526 //w=0.168 //l=0.115 //layer=ply \
 //thickness=0.18 //x=53.81 //y=1.585 //x2=53.925 //y2=1.585
r456 (  104 149 ) resistor r=5.52526 //w=0.168 //l=0.115 //layer=ply \
 //thickness=0.18 //x=53.59 //y=0.93 //x2=53.475 //y2=0.93
r457 (  103 151 ) resistor r=5.52526 //w=0.168 //l=0.115 //layer=ply \
 //thickness=0.18 //x=53.81 //y=0.93 //x2=53.925 //y2=0.93
r458 (  103 104 ) resistor r=112.809 //w=0.094 //l=0.22 //layer=ply \
 //thickness=0.18 //x=53.81 //y=0.93 //x2=53.59 //y2=0.93
r459 (  102 147 ) resistor r=16.5046 //w=0.27 //l=0.135 //layer=ply \
 //thickness=0.18 //x=53.565 //y=4.97 //x2=53.43 //y2=4.97
r460 (  101 108 ) resistor r=26.9307 //w=0.15 //l=0.106066 //layer=ply \
 //thickness=0.18 //x=53.805 //y=4.97 //x2=53.88 //y2=5.045
r461 (  101 102 ) resistor r=123.064 //w=0.094 //l=0.24 //layer=ply \
 //thickness=0.18 //x=53.805 //y=4.97 //x2=53.565 //y2=4.97
r462 (  96 150 ) resistor r=39.5823 //w=0.21 //l=0.173853 //layer=ply \
 //thickness=0.18 //x=53.435 //y=1.74 //x2=53.475 //y2=1.585
r463 (  96 142 ) resistor r=182.032 //w=0.094 //l=0.355 //layer=ply \
 //thickness=0.18 //x=53.435 //y=1.74 //x2=53.435 //y2=2.095
r464 (  95 150 ) resistor r=39.5823 //w=0.21 //l=0.173853 //layer=ply \
 //thickness=0.18 //x=53.435 //y=1.43 //x2=53.475 //y2=1.585
r465 (  94 149 ) resistor r=45.1352 //w=0.168 //l=0.173853 //layer=ply \
 //thickness=0.18 //x=53.435 //y=1.085 //x2=53.475 //y2=0.93
r466 (  94 95 ) resistor r=176.904 //w=0.094 //l=0.345 //layer=ply \
 //thickness=0.18 //x=53.435 //y=1.085 //x2=53.435 //y2=1.43
r467 (  89 91 ) resistor r=26.9307 //w=0.15 //l=0.106066 //layer=ply \
 //thickness=0.18 //x=45.085 //y=4.97 //x2=45.16 //y2=5.045
r468 (  89 90 ) resistor r=148.702 //w=0.094 //l=0.29 //layer=ply \
 //thickness=0.18 //x=45.085 //y=4.97 //x2=44.795 //y2=4.97
r469 (  88 139 ) resistor r=45.1352 //w=0.168 //l=0.173853 //layer=ply \
 //thickness=0.18 //x=44.75 //y=1.4 //x2=44.71 //y2=1.555
r470 (  87 138 ) resistor r=45.1352 //w=0.168 //l=0.173853 //layer=ply \
 //thickness=0.18 //x=44.75 //y=1.055 //x2=44.71 //y2=0.9
r471 (  87 88 ) resistor r=176.904 //w=0.094 //l=0.345 //layer=ply \
 //thickness=0.18 //x=44.75 //y=1.055 //x2=44.75 //y2=1.4
r472 (  84 90 ) resistor r=22.7971 //w=0.269 //l=0.106066 //layer=ply \
 //thickness=0.18 //x=44.72 //y=5.045 //x2=44.795 //y2=4.97
r473 (  84 137 ) resistor r=35.8364 //w=0.269 //l=0.270185 //layer=ply \
 //thickness=0.18 //x=44.72 //y=5.045 //x2=44.52 //y2=4.88
r474 (  82 133 ) resistor r=10.701 //w=0.21 //l=0.115 //layer=ply \
 //thickness=0.18 //x=44.375 //y=1.555 //x2=44.26 //y2=1.555
r475 (  81 139 ) resistor r=5.52526 //w=0.168 //l=0.115 //layer=ply \
 //thickness=0.18 //x=44.595 //y=1.555 //x2=44.71 //y2=1.555
r476 (  80 132 ) resistor r=5.52526 //w=0.168 //l=0.115 //layer=ply \
 //thickness=0.18 //x=44.375 //y=0.9 //x2=44.26 //y2=0.9
r477 (  79 138 ) resistor r=5.52526 //w=0.168 //l=0.115 //layer=ply \
 //thickness=0.18 //x=44.595 //y=0.9 //x2=44.71 //y2=0.9
r478 (  79 80 ) resistor r=112.809 //w=0.094 //l=0.22 //layer=ply \
 //thickness=0.18 //x=44.595 //y=0.9 //x2=44.375 //y2=0.9
r479 (  78 135 ) resistor r=58.7805 //w=0.246 //l=0.373497 //layer=ply \
 //thickness=0.18 //x=44.22 //y=2.095 //x2=44.52 //y2=2.26
r480 (  77 133 ) resistor r=39.5823 //w=0.21 //l=0.173853 //layer=ply \
 //thickness=0.18 //x=44.22 //y=1.71 //x2=44.26 //y2=1.555
r481 (  77 78 ) resistor r=197.415 //w=0.094 //l=0.385 //layer=ply \
 //thickness=0.18 //x=44.22 //y=1.71 //x2=44.22 //y2=2.095
r482 (  76 133 ) resistor r=39.5823 //w=0.21 //l=0.173853 //layer=ply \
 //thickness=0.18 //x=44.22 //y=1.4 //x2=44.26 //y2=1.555
r483 (  75 132 ) resistor r=45.1352 //w=0.168 //l=0.173853 //layer=ply \
 //thickness=0.18 //x=44.22 //y=1.055 //x2=44.26 //y2=0.9
r484 (  75 76 ) resistor r=176.904 //w=0.094 //l=0.345 //layer=ply \
 //thickness=0.18 //x=44.22 //y=1.055 //x2=44.22 //y2=1.4
r485 (  74 127 ) resistor r=592.245 //w=0.094 //l=1.155 //layer=ply \
 //thickness=0.18 //x=63.87 //y=6.2 //x2=63.87 //y2=5.045
r486 (  73 161 ) resistor r=592.245 //w=0.094 //l=1.155 //layer=ply \
 //thickness=0.18 //x=63.43 //y=6.2 //x2=63.43 //y2=5.045
r487 (  72 108 ) resistor r=592.245 //w=0.094 //l=1.155 //layer=ply \
 //thickness=0.18 //x=53.88 //y=6.2 //x2=53.88 //y2=5.045
r488 (  71 148 ) resistor r=592.245 //w=0.094 //l=1.155 //layer=ply \
 //thickness=0.18 //x=53.44 //y=6.2 //x2=53.44 //y2=5.045
r489 (  70 91 ) resistor r=592.245 //w=0.094 //l=1.155 //layer=ply \
 //thickness=0.18 //x=45.16 //y=6.2 //x2=45.16 //y2=5.045
r490 (  69 84 ) resistor r=592.245 //w=0.094 //l=1.155 //layer=ply \
 //thickness=0.18 //x=44.72 //y=6.2 //x2=44.72 //y2=5.045
r491 (  68 124 ) resistor r=56.4043 //w=0.094 //l=0.11 //layer=ply \
 //thickness=0.18 //x=63.69 //y=1.585 //x2=63.8 //y2=1.585
r492 (  68 125 ) resistor r=56.4043 //w=0.094 //l=0.11 //layer=ply \
 //thickness=0.18 //x=63.69 //y=1.585 //x2=63.58 //y2=1.585
r493 (  67 105 ) resistor r=56.4043 //w=0.094 //l=0.11 //layer=ply \
 //thickness=0.18 //x=53.7 //y=1.585 //x2=53.81 //y2=1.585
r494 (  67 106 ) resistor r=56.4043 //w=0.094 //l=0.11 //layer=ply \
 //thickness=0.18 //x=53.7 //y=1.585 //x2=53.59 //y2=1.585
r495 (  66 81 ) resistor r=56.4043 //w=0.094 //l=0.11 //layer=ply \
 //thickness=0.18 //x=44.485 //y=1.555 //x2=44.595 //y2=1.555
r496 (  66 82 ) resistor r=56.4043 //w=0.094 //l=0.11 //layer=ply \
 //thickness=0.18 //x=44.485 //y=1.555 //x2=44.375 //y2=1.555
r497 (  65 158 ) resistor r=152 //w=0.17 //l=0.17 //layer=licon //count=1 \
 //x=63.42 //y=4.88 //x2=63.42 //y2=4.88
r498 (  62 145 ) resistor r=152 //w=0.17 //l=0.17 //layer=licon //count=1 \
 //x=53.43 //y=4.88 //x2=53.43 //y2=4.88
r499 (  57 154 ) resistor r=152 //w=0.17 //l=0.17 //layer=licon //count=1 \
 //x=63.39 //y=2.26 //x2=63.39 //y2=2.26
r500 (  57 60 ) resistor r=136.214 //w=0.187 //l=1.99 //layer=li \
 //thickness=0.1 //x=63.39 //y=2.26 //x2=63.39 //y2=4.25
r501 (  55 65 ) resistor r=11.4737 //w=0.186 //l=0.172337 //layer=li \
 //thickness=0.1 //x=63.39 //y=4.715 //x2=63.405 //y2=4.88
r502 (  55 60 ) resistor r=31.8289 //w=0.187 //l=0.465 //layer=li \
 //thickness=0.1 //x=63.39 //y=4.715 //x2=63.39 //y2=4.25
r503 (  52 54 ) resistor r=71.5294 //w=0.187 //l=1.045 //layer=li \
 //thickness=0.1 //x=57.47 //y=5.295 //x2=57.47 //y2=4.25
r504 (  51 54 ) resistor r=159.487 //w=0.187 //l=2.33 //layer=li \
 //thickness=0.1 //x=57.47 //y=1.92 //x2=57.47 //y2=4.25
r505 (  49 51 ) resistor r=7.15173 //w=0.17 //l=0.120208 //layer=li \
 //thickness=0.1 //x=57.385 //y=1.835 //x2=57.47 //y2=1.92
r506 (  49 50 ) resistor r=18.4813 //w=0.187 //l=0.27 //layer=li \
 //thickness=0.1 //x=57.385 //y=1.835 //x2=57.115 //y2=1.835
r507 (  48 63 ) resistor r=5.4201 //w=0.17 //l=0.085 //layer=li \
 //thickness=0.1 //x=57.075 //y=5.38 //x2=56.99 //y2=5.38
r508 (  47 52 ) resistor r=7.15173 //w=0.17 //l=0.120208 //layer=li \
 //thickness=0.1 //x=57.385 //y=5.38 //x2=57.47 //y2=5.295
r509 (  47 48 ) resistor r=21.2193 //w=0.187 //l=0.31 //layer=li \
 //thickness=0.1 //x=57.385 //y=5.38 //x2=57.075 //y2=5.38
r510 (  43 50 ) resistor r=7.15173 //w=0.17 //l=0.120208 //layer=li \
 //thickness=0.1 //x=57.03 //y=1.75 //x2=57.115 //y2=1.835
r511 (  43 166 ) resistor r=39.016 //w=0.187 //l=0.57 //layer=li \
 //thickness=0.1 //x=57.03 //y=1.75 //x2=57.03 //y2=1.18
r512 (  37 63 ) resistor r=1.40859 //w=0.34 //l=0.085 //layer=li \
 //thickness=0.1 //x=56.99 //y=5.465 //x2=56.99 //y2=5.38
r513 (  37 169 ) resistor r=30.1176 //w=0.187 //l=0.44 //layer=li \
 //thickness=0.1 //x=56.99 //y=5.465 //x2=56.99 //y2=5.905
r514 (  35 63 ) resistor r=5.4201 //w=0.17 //l=0.085 //layer=li \
 //thickness=0.1 //x=56.905 //y=5.38 //x2=56.99 //y2=5.38
r515 (  35 36 ) resistor r=48.5989 //w=0.187 //l=0.71 //layer=li \
 //thickness=0.1 //x=56.905 //y=5.38 //x2=56.195 //y2=5.38
r516 (  29 36 ) resistor r=7.15173 //w=0.17 //l=0.120208 //layer=li \
 //thickness=0.1 //x=56.11 //y=5.465 //x2=56.195 //y2=5.38
r517 (  29 168 ) resistor r=30.1176 //w=0.187 //l=0.44 //layer=li \
 //thickness=0.1 //x=56.11 //y=5.465 //x2=56.11 //y2=5.905
r518 (  25 141 ) resistor r=152 //w=0.17 //l=0.17 //layer=licon //count=1 \
 //x=53.4 //y=2.26 //x2=53.4 //y2=2.26
r519 (  25 28 ) resistor r=136.214 //w=0.187 //l=1.99 //layer=li \
 //thickness=0.1 //x=53.4 //y=2.26 //x2=53.4 //y2=4.25
r520 (  23 62 ) resistor r=11.4737 //w=0.186 //l=0.172337 //layer=li \
 //thickness=0.1 //x=53.4 //y=4.715 //x2=53.415 //y2=4.88
r521 (  23 28 ) resistor r=31.8289 //w=0.187 //l=0.465 //layer=li \
 //thickness=0.1 //x=53.4 //y=4.715 //x2=53.4 //y2=4.25
r522 (  21 137 ) resistor r=152 //w=0.17 //l=0.17 //layer=licon //count=1 \
 //x=44.52 //y=4.88 //x2=44.52 //y2=4.88
r523 (  19 21 ) resistor r=43.123 //w=0.187 //l=0.63 //layer=li \
 //thickness=0.1 //x=44.52 //y=4.25 //x2=44.52 //y2=4.88
r524 (  16 135 ) resistor r=152 //w=0.17 //l=0.17 //layer=licon //count=1 \
 //x=44.52 //y=2.26 //x2=44.52 //y2=2.26
r525 (  16 19 ) resistor r=136.214 //w=0.187 //l=1.99 //layer=li \
 //thickness=0.1 //x=44.52 //y=2.26 //x2=44.52 //y2=4.25
r526 (  14 60 ) resistor r=9.3 //w=0.17 //l=0.17 //layer=mcon //count=1 \
 //x=63.39 //y=4.25 //x2=63.39 //y2=4.25
r527 (  12 54 ) resistor r=9.3 //w=0.17 //l=0.17 //layer=mcon //count=1 \
 //x=57.47 //y=4.25 //x2=57.47 //y2=4.25
r528 (  10 28 ) resistor r=9.3 //w=0.17 //l=0.17 //layer=mcon //count=1 \
 //x=53.4 //y=4.25 //x2=53.4 //y2=4.25
r529 (  8 19 ) resistor r=9.3 //w=0.17 //l=0.17 //layer=mcon //count=1 \
 //x=44.52 //y=4.25 //x2=44.52 //y2=4.25
r530 (  6 12 ) resistor r=0.0880901 //w=0.191 //l=0.115 //layer=m1 \
 //thickness=0.36 //x=57.585 //y=4.25 //x2=57.47 //y2=4.25
r531 (  5 14 ) resistor r=0.0717383 //w=0.224 //l=0.115 //layer=m1 \
 //thickness=0.36 //x=63.275 //y=4.25 //x2=63.39 //y2=4.25
r532 (  5 6 ) resistor r=5.42939 //w=0.131 //l=5.69 //layer=m1 \
 //thickness=0.36 //x=63.275 //y=4.25 //x2=57.585 //y2=4.25
r533 (  4 10 ) resistor r=0.0880901 //w=0.191 //l=0.115 //layer=m1 \
 //thickness=0.36 //x=53.515 //y=4.25 //x2=53.4 //y2=4.25
r534 (  3 12 ) resistor r=0.0880901 //w=0.191 //l=0.115 //layer=m1 \
 //thickness=0.36 //x=57.355 //y=4.25 //x2=57.47 //y2=4.25
r535 (  3 4 ) resistor r=3.66412 //w=0.131 //l=3.84 //layer=m1 \
 //thickness=0.36 //x=57.355 //y=4.25 //x2=53.515 //y2=4.25
r536 (  2 8 ) resistor r=0.0717383 //w=0.224 //l=0.115 //layer=m1 \
 //thickness=0.36 //x=44.635 //y=4.25 //x2=44.52 //y2=4.25
r537 (  1 10 ) resistor r=0.0880901 //w=0.191 //l=0.115 //layer=m1 \
 //thickness=0.36 //x=53.285 //y=4.25 //x2=53.4 //y2=4.25
r538 (  1 2 ) resistor r=8.25382 //w=0.131 //l=8.65 //layer=m1 \
 //thickness=0.36 //x=53.285 //y=4.25 //x2=44.635 //y2=4.25
ends PM_TMRDFFQX1\%noxref_19

subckt PM_TMRDFFQX1\%noxref_20 ( 1 2 3 4 5 6 17 19 29 30 41 43 44 48 50 60 69 \
 70 71 72 73 74 75 76 77 78 79 80 81 86 88 90 96 97 98 99 100 101 105 107 110 \
 111 112 113 117 118 119 120 124 126 132 133 135 136 139 148 161 164 166 167 )
c344 ( 167 0 ) capacitor c=0.0220235f //x=63.505 //y=5.2
c345 ( 166 0 ) capacitor c=0.0217503f //x=62.625 //y=5.2
c346 ( 164 0 ) capacitor c=0.00864721f //x=63.5 //y=1.085
c347 ( 161 0 ) capacitor c=0.0655948f //x=69.31 //y=4.885
c348 ( 148 0 ) capacitor c=0.0540823f //x=65.61 //y=2.26
c349 ( 139 0 ) capacitor c=0.0331552f //x=60.09 //y=4.88
c350 ( 136 0 ) capacitor c=0.0279499f //x=60.06 //y=2.095
c351 ( 135 0 ) capacitor c=0.0421676f //x=60.06 //y=2.26
c352 ( 133 0 ) capacitor c=0.0342409f //x=69.645 //y=1.39
c353 ( 132 0 ) capacitor c=0.0187384f //x=69.645 //y=1.045
c354 ( 126 0 ) capacitor c=0.0141797f //x=69.49 //y=1.545
c355 ( 124 0 ) capacitor c=0.0149844f //x=69.49 //y=0.89
c356 ( 120 0 ) capacitor c=0.0979048f //x=69.115 //y=2.095
c357 ( 119 0 ) capacitor c=0.0225105f //x=69.115 //y=1.7
c358 ( 118 0 ) capacitor c=0.0234376f //x=69.115 //y=1.39
c359 ( 117 0 ) capacitor c=0.0199343f //x=69.115 //y=1.045
c360 ( 113 0 ) capacitor c=0.0318948f //x=66.315 //y=1.39
c361 ( 112 0 ) capacitor c=0.0187384f //x=66.315 //y=1.045
c362 ( 111 0 ) capacitor c=0.0606536f //x=65.955 //y=4.975
c363 ( 110 0 ) capacitor c=0.0292043f //x=66.245 //y=4.975
c364 ( 107 0 ) capacitor c=0.0157913f //x=66.16 //y=1.545
c365 ( 105 0 ) capacitor c=0.0149844f //x=66.16 //y=0.89
c366 ( 101 0 ) capacitor c=0.0302441f //x=65.785 //y=2.095
c367 ( 100 0 ) capacitor c=0.0237559f //x=65.785 //y=1.7
c368 ( 99 0 ) capacitor c=0.0234352f //x=65.785 //y=1.39
c369 ( 98 0 ) capacitor c=0.0199931f //x=65.785 //y=1.045
c370 ( 97 0 ) capacitor c=0.0429696f //x=60.625 //y=1.43
c371 ( 96 0 ) capacitor c=0.0192208f //x=60.625 //y=1.085
c372 ( 90 0 ) capacitor c=0.0148884f //x=60.47 //y=1.585
c373 ( 88 0 ) capacitor c=0.0157803f //x=60.47 //y=0.93
c374 ( 86 0 ) capacitor c=0.0299681f //x=60.465 //y=4.97
c375 ( 81 0 ) capacitor c=0.0205163f //x=60.095 //y=1.74
c376 ( 80 0 ) capacitor c=0.0168481f //x=60.095 //y=1.43
c377 ( 79 0 ) capacitor c=0.0174783f //x=60.095 //y=1.085
c378 ( 78 0 ) capacitor c=0.110336f //x=69.64 //y=6.205
c379 ( 77 0 ) capacitor c=0.154049f //x=69.2 //y=6.205
c380 ( 76 0 ) capacitor c=0.110003f //x=66.32 //y=6.205
c381 ( 75 0 ) capacitor c=0.15424f //x=65.88 //y=6.205
c382 ( 74 0 ) capacitor c=0.15358f //x=60.54 //y=6.2
c383 ( 73 0 ) capacitor c=0.110281f //x=60.1 //y=6.2
c384 ( 69 0 ) capacitor c=0.0024826f //x=63.65 //y=5.38
c385 ( 60 0 ) capacitor c=0.117774f //x=69.31 //y=2.26
c386 ( 50 0 ) capacitor c=0.0959619f //x=65.61 //y=2.26
c387 ( 48 0 ) capacitor c=0.107292f //x=64.13 //y=3.88
c388 ( 44 0 ) capacitor c=0.00404073f //x=63.775 //y=1.835
c389 ( 43 0 ) capacitor c=0.0122201f //x=64.045 //y=1.835
c390 ( 41 0 ) capacitor c=0.0141743f //x=64.045 //y=5.38
c391 ( 30 0 ) capacitor c=0.0025891f //x=62.855 //y=5.38
c392 ( 29 0 ) capacitor c=0.0150834f //x=63.565 //y=5.38
c393 ( 19 0 ) capacitor c=0.0728369f //x=60.06 //y=2.26
c394 ( 17 0 ) capacitor c=0.00453889f //x=60.06 //y=4.715
c395 ( 6 0 ) capacitor c=0.0112191f //x=65.725 //y=4.62
c396 ( 5 0 ) capacitor c=0.0875589f //x=69.195 //y=4.62
c397 ( 4 0 ) capacitor c=0.00444525f //x=64.245 //y=3.88
c398 ( 3 0 ) capacitor c=0.0607201f //x=65.495 //y=3.88
c399 ( 2 0 ) capacitor c=0.00514884f //x=60.175 //y=3.88
c400 ( 1 0 ) capacitor c=0.0734822f //x=64.015 //y=3.88
r401 (  159 161 ) resistor r=22.7554 //w=0.233 //l=0.11 //layer=ply \
 //thickness=0.18 //x=69.2 //y=4.885 //x2=69.31 //y2=4.885
r402 (  141 142 ) resistor r=32.4568 //w=0.214 //l=0.075 //layer=ply \
 //thickness=0.18 //x=60.09 //y=4.97 //x2=60.09 //y2=5.045
r403 (  139 141 ) resistor r=20.271 //w=0.214 //l=0.09 //layer=ply \
 //thickness=0.18 //x=60.09 //y=4.88 //x2=60.09 //y2=4.97
r404 (  135 136 ) resistor r=52.7279 //w=0.214 //l=0.165 //layer=ply \
 //thickness=0.18 //x=60.06 //y=2.26 //x2=60.06 //y2=2.095
r405 (  133 163 ) resistor r=45.1352 //w=0.168 //l=0.173853 //layer=ply \
 //thickness=0.18 //x=69.645 //y=1.39 //x2=69.605 //y2=1.545
r406 (  132 162 ) resistor r=45.1352 //w=0.168 //l=0.173853 //layer=ply \
 //thickness=0.18 //x=69.645 //y=1.045 //x2=69.605 //y2=0.89
r407 (  132 133 ) resistor r=176.904 //w=0.094 //l=0.345 //layer=ply \
 //thickness=0.18 //x=69.645 //y=1.045 //x2=69.645 //y2=1.39
r408 (  129 161 ) resistor r=68.2661 //w=0.233 //l=0.404166 //layer=ply \
 //thickness=0.18 //x=69.64 //y=5.05 //x2=69.31 //y2=4.885
r409 (  127 158 ) resistor r=10.701 //w=0.21 //l=0.115 //layer=ply \
 //thickness=0.18 //x=69.27 //y=1.545 //x2=69.155 //y2=1.545
r410 (  126 163 ) resistor r=5.52526 //w=0.168 //l=0.115 //layer=ply \
 //thickness=0.18 //x=69.49 //y=1.545 //x2=69.605 //y2=1.545
r411 (  125 157 ) resistor r=5.52526 //w=0.168 //l=0.115 //layer=ply \
 //thickness=0.18 //x=69.27 //y=0.89 //x2=69.155 //y2=0.89
r412 (  124 162 ) resistor r=5.52526 //w=0.168 //l=0.115 //layer=ply \
 //thickness=0.18 //x=69.49 //y=0.89 //x2=69.605 //y2=0.89
r413 (  124 125 ) resistor r=112.809 //w=0.094 //l=0.22 //layer=ply \
 //thickness=0.18 //x=69.49 //y=0.89 //x2=69.27 //y2=0.89
r414 (  121 159 ) resistor r=13.0941 //w=0.233 //l=0.165 //layer=ply \
 //thickness=0.18 //x=69.2 //y=5.05 //x2=69.2 //y2=4.885
r415 (  120 156 ) resistor r=34.8111 //w=0.27 //l=0.264953 //layer=ply \
 //thickness=0.18 //x=69.115 //y=2.095 //x2=69.31 //y2=2.26
r416 (  119 158 ) resistor r=39.5823 //w=0.21 //l=0.173853 //layer=ply \
 //thickness=0.18 //x=69.115 //y=1.7 //x2=69.155 //y2=1.545
r417 (  119 120 ) resistor r=202.543 //w=0.094 //l=0.395 //layer=ply \
 //thickness=0.18 //x=69.115 //y=1.7 //x2=69.115 //y2=2.095
r418 (  118 158 ) resistor r=39.5823 //w=0.21 //l=0.173853 //layer=ply \
 //thickness=0.18 //x=69.115 //y=1.39 //x2=69.155 //y2=1.545
r419 (  117 157 ) resistor r=45.1352 //w=0.168 //l=0.173853 //layer=ply \
 //thickness=0.18 //x=69.115 //y=1.045 //x2=69.155 //y2=0.89
r420 (  117 118 ) resistor r=176.904 //w=0.094 //l=0.345 //layer=ply \
 //thickness=0.18 //x=69.115 //y=1.045 //x2=69.115 //y2=1.39
r421 (  113 154 ) resistor r=45.1352 //w=0.168 //l=0.173853 //layer=ply \
 //thickness=0.18 //x=66.315 //y=1.39 //x2=66.275 //y2=1.545
r422 (  112 153 ) resistor r=45.1352 //w=0.168 //l=0.173853 //layer=ply \
 //thickness=0.18 //x=66.315 //y=1.045 //x2=66.275 //y2=0.89
r423 (  112 113 ) resistor r=176.904 //w=0.094 //l=0.345 //layer=ply \
 //thickness=0.18 //x=66.315 //y=1.045 //x2=66.315 //y2=1.39
r424 (  110 114 ) resistor r=26.9307 //w=0.15 //l=0.106066 //layer=ply \
 //thickness=0.18 //x=66.245 //y=4.975 //x2=66.32 //y2=5.05
r425 (  110 111 ) resistor r=148.702 //w=0.094 //l=0.29 //layer=ply \
 //thickness=0.18 //x=66.245 //y=4.975 //x2=65.955 //y2=4.975
r426 (  108 152 ) resistor r=10.701 //w=0.21 //l=0.115 //layer=ply \
 //thickness=0.18 //x=65.94 //y=1.545 //x2=65.825 //y2=1.545
r427 (  107 154 ) resistor r=5.52526 //w=0.168 //l=0.115 //layer=ply \
 //thickness=0.18 //x=66.16 //y=1.545 //x2=66.275 //y2=1.545
r428 (  106 151 ) resistor r=5.52526 //w=0.168 //l=0.115 //layer=ply \
 //thickness=0.18 //x=65.94 //y=0.89 //x2=65.825 //y2=0.89
r429 (  105 153 ) resistor r=5.52526 //w=0.168 //l=0.115 //layer=ply \
 //thickness=0.18 //x=66.16 //y=0.89 //x2=66.275 //y2=0.89
r430 (  105 106 ) resistor r=112.809 //w=0.094 //l=0.22 //layer=ply \
 //thickness=0.18 //x=66.16 //y=0.89 //x2=65.94 //y2=0.89
r431 (  102 111 ) resistor r=22.1787 //w=0.252 //l=0.106066 //layer=ply \
 //thickness=0.18 //x=65.88 //y=5.05 //x2=65.955 //y2=4.975
r432 (  102 150 ) resistor r=51.6429 //w=0.252 //l=0.34271 //layer=ply \
 //thickness=0.18 //x=65.88 //y=5.05 //x2=65.61 //y2=4.885
r433 (  101 148 ) resistor r=30.4513 //w=0.277 //l=0.243926 //layer=ply \
 //thickness=0.18 //x=65.785 //y=2.095 //x2=65.61 //y2=2.26
r434 (  100 152 ) resistor r=39.5823 //w=0.21 //l=0.173853 //layer=ply \
 //thickness=0.18 //x=65.785 //y=1.7 //x2=65.825 //y2=1.545
r435 (  100 101 ) resistor r=202.543 //w=0.094 //l=0.395 //layer=ply \
 //thickness=0.18 //x=65.785 //y=1.7 //x2=65.785 //y2=2.095
r436 (  99 152 ) resistor r=39.5823 //w=0.21 //l=0.173853 //layer=ply \
 //thickness=0.18 //x=65.785 //y=1.39 //x2=65.825 //y2=1.545
r437 (  98 151 ) resistor r=45.1352 //w=0.168 //l=0.173853 //layer=ply \
 //thickness=0.18 //x=65.785 //y=1.045 //x2=65.825 //y2=0.89
r438 (  98 99 ) resistor r=176.904 //w=0.094 //l=0.345 //layer=ply \
 //thickness=0.18 //x=65.785 //y=1.045 //x2=65.785 //y2=1.39
r439 (  97 146 ) resistor r=45.1352 //w=0.168 //l=0.173853 //layer=ply \
 //thickness=0.18 //x=60.625 //y=1.43 //x2=60.585 //y2=1.585
r440 (  96 145 ) resistor r=45.1352 //w=0.168 //l=0.173853 //layer=ply \
 //thickness=0.18 //x=60.625 //y=1.085 //x2=60.585 //y2=0.93
r441 (  96 97 ) resistor r=176.904 //w=0.094 //l=0.345 //layer=ply \
 //thickness=0.18 //x=60.625 //y=1.085 //x2=60.625 //y2=1.43
r442 (  91 144 ) resistor r=10.701 //w=0.21 //l=0.115 //layer=ply \
 //thickness=0.18 //x=60.25 //y=1.585 //x2=60.135 //y2=1.585
r443 (  90 146 ) resistor r=5.52526 //w=0.168 //l=0.115 //layer=ply \
 //thickness=0.18 //x=60.47 //y=1.585 //x2=60.585 //y2=1.585
r444 (  89 143 ) resistor r=5.52526 //w=0.168 //l=0.115 //layer=ply \
 //thickness=0.18 //x=60.25 //y=0.93 //x2=60.135 //y2=0.93
r445 (  88 145 ) resistor r=5.52526 //w=0.168 //l=0.115 //layer=ply \
 //thickness=0.18 //x=60.47 //y=0.93 //x2=60.585 //y2=0.93
r446 (  88 89 ) resistor r=112.809 //w=0.094 //l=0.22 //layer=ply \
 //thickness=0.18 //x=60.47 //y=0.93 //x2=60.25 //y2=0.93
r447 (  87 141 ) resistor r=16.5046 //w=0.27 //l=0.135 //layer=ply \
 //thickness=0.18 //x=60.225 //y=4.97 //x2=60.09 //y2=4.97
r448 (  86 93 ) resistor r=26.9307 //w=0.15 //l=0.106066 //layer=ply \
 //thickness=0.18 //x=60.465 //y=4.97 //x2=60.54 //y2=5.045
r449 (  86 87 ) resistor r=123.064 //w=0.094 //l=0.24 //layer=ply \
 //thickness=0.18 //x=60.465 //y=4.97 //x2=60.225 //y2=4.97
r450 (  81 144 ) resistor r=39.5823 //w=0.21 //l=0.173853 //layer=ply \
 //thickness=0.18 //x=60.095 //y=1.74 //x2=60.135 //y2=1.585
r451 (  81 136 ) resistor r=182.032 //w=0.094 //l=0.355 //layer=ply \
 //thickness=0.18 //x=60.095 //y=1.74 //x2=60.095 //y2=2.095
r452 (  80 144 ) resistor r=39.5823 //w=0.21 //l=0.173853 //layer=ply \
 //thickness=0.18 //x=60.095 //y=1.43 //x2=60.135 //y2=1.585
r453 (  79 143 ) resistor r=45.1352 //w=0.168 //l=0.173853 //layer=ply \
 //thickness=0.18 //x=60.095 //y=1.085 //x2=60.135 //y2=0.93
r454 (  79 80 ) resistor r=176.904 //w=0.094 //l=0.345 //layer=ply \
 //thickness=0.18 //x=60.095 //y=1.085 //x2=60.095 //y2=1.43
r455 (  78 129 ) resistor r=592.245 //w=0.094 //l=1.155 //layer=ply \
 //thickness=0.18 //x=69.64 //y=6.205 //x2=69.64 //y2=5.05
r456 (  77 121 ) resistor r=592.245 //w=0.094 //l=1.155 //layer=ply \
 //thickness=0.18 //x=69.2 //y=6.205 //x2=69.2 //y2=5.05
r457 (  76 114 ) resistor r=592.245 //w=0.094 //l=1.155 //layer=ply \
 //thickness=0.18 //x=66.32 //y=6.205 //x2=66.32 //y2=5.05
r458 (  75 102 ) resistor r=592.245 //w=0.094 //l=1.155 //layer=ply \
 //thickness=0.18 //x=65.88 //y=6.205 //x2=65.88 //y2=5.05
r459 (  74 93 ) resistor r=592.245 //w=0.094 //l=1.155 //layer=ply \
 //thickness=0.18 //x=60.54 //y=6.2 //x2=60.54 //y2=5.045
r460 (  73 142 ) resistor r=592.245 //w=0.094 //l=1.155 //layer=ply \
 //thickness=0.18 //x=60.1 //y=6.2 //x2=60.1 //y2=5.045
r461 (  72 126 ) resistor r=56.4043 //w=0.094 //l=0.11 //layer=ply \
 //thickness=0.18 //x=69.38 //y=1.545 //x2=69.49 //y2=1.545
r462 (  72 127 ) resistor r=56.4043 //w=0.094 //l=0.11 //layer=ply \
 //thickness=0.18 //x=69.38 //y=1.545 //x2=69.27 //y2=1.545
r463 (  71 107 ) resistor r=56.4043 //w=0.094 //l=0.11 //layer=ply \
 //thickness=0.18 //x=66.05 //y=1.545 //x2=66.16 //y2=1.545
r464 (  71 108 ) resistor r=56.4043 //w=0.094 //l=0.11 //layer=ply \
 //thickness=0.18 //x=66.05 //y=1.545 //x2=65.94 //y2=1.545
r465 (  70 90 ) resistor r=56.4043 //w=0.094 //l=0.11 //layer=ply \
 //thickness=0.18 //x=60.36 //y=1.585 //x2=60.47 //y2=1.585
r466 (  70 91 ) resistor r=56.4043 //w=0.094 //l=0.11 //layer=ply \
 //thickness=0.18 //x=60.36 //y=1.585 //x2=60.25 //y2=1.585
r467 (  68 139 ) resistor r=152 //w=0.17 //l=0.17 //layer=licon //count=1 \
 //x=60.09 //y=4.88 //x2=60.09 //y2=4.88
r468 (  65 161 ) resistor r=152 //w=0.17 //l=0.17 //layer=licon //count=1 \
 //x=69.31 //y=4.885 //x2=69.31 //y2=4.885
r469 (  63 65 ) resistor r=18.139 //w=0.187 //l=0.265 //layer=li \
 //thickness=0.1 //x=69.31 //y=4.62 //x2=69.31 //y2=4.885
r470 (  60 156 ) resistor r=152 //w=0.17 //l=0.17 //layer=licon //count=1 \
 //x=69.31 //y=2.26 //x2=69.31 //y2=2.26
r471 (  60 63 ) resistor r=161.54 //w=0.187 //l=2.36 //layer=li \
 //thickness=0.1 //x=69.31 //y=2.26 //x2=69.31 //y2=4.62
r472 (  57 150 ) resistor r=152 //w=0.17 //l=0.17 //layer=licon //count=1 \
 //x=65.61 //y=4.885 //x2=65.61 //y2=4.885
r473 (  55 57 ) resistor r=18.139 //w=0.187 //l=0.265 //layer=li \
 //thickness=0.1 //x=65.61 //y=4.62 //x2=65.61 //y2=4.885
r474 (  53 55 ) resistor r=50.6524 //w=0.187 //l=0.74 //layer=li \
 //thickness=0.1 //x=65.61 //y=3.88 //x2=65.61 //y2=4.62
r475 (  50 148 ) resistor r=152 //w=0.17 //l=0.17 //layer=licon //count=1 \
 //x=65.61 //y=2.26 //x2=65.61 //y2=2.26
r476 (  50 53 ) resistor r=110.888 //w=0.187 //l=1.62 //layer=li \
 //thickness=0.1 //x=65.61 //y=2.26 //x2=65.61 //y2=3.88
r477 (  46 48 ) resistor r=96.8556 //w=0.187 //l=1.415 //layer=li \
 //thickness=0.1 //x=64.13 //y=5.295 //x2=64.13 //y2=3.88
r478 (  45 48 ) resistor r=134.16 //w=0.187 //l=1.96 //layer=li \
 //thickness=0.1 //x=64.13 //y=1.92 //x2=64.13 //y2=3.88
r479 (  43 45 ) resistor r=7.15173 //w=0.17 //l=0.120208 //layer=li \
 //thickness=0.1 //x=64.045 //y=1.835 //x2=64.13 //y2=1.92
r480 (  43 44 ) resistor r=18.4813 //w=0.187 //l=0.27 //layer=li \
 //thickness=0.1 //x=64.045 //y=1.835 //x2=63.775 //y2=1.835
r481 (  42 69 ) resistor r=5.4201 //w=0.17 //l=0.085 //layer=li \
 //thickness=0.1 //x=63.735 //y=5.38 //x2=63.65 //y2=5.38
r482 (  41 46 ) resistor r=7.15173 //w=0.17 //l=0.120208 //layer=li \
 //thickness=0.1 //x=64.045 //y=5.38 //x2=64.13 //y2=5.295
r483 (  41 42 ) resistor r=21.2193 //w=0.187 //l=0.31 //layer=li \
 //thickness=0.1 //x=64.045 //y=5.38 //x2=63.735 //y2=5.38
r484 (  37 44 ) resistor r=7.15173 //w=0.17 //l=0.120208 //layer=li \
 //thickness=0.1 //x=63.69 //y=1.75 //x2=63.775 //y2=1.835
r485 (  37 164 ) resistor r=39.016 //w=0.187 //l=0.57 //layer=li \
 //thickness=0.1 //x=63.69 //y=1.75 //x2=63.69 //y2=1.18
r486 (  31 69 ) resistor r=1.40859 //w=0.34 //l=0.085 //layer=li \
 //thickness=0.1 //x=63.65 //y=5.465 //x2=63.65 //y2=5.38
r487 (  31 167 ) resistor r=30.1176 //w=0.187 //l=0.44 //layer=li \
 //thickness=0.1 //x=63.65 //y=5.465 //x2=63.65 //y2=5.905
r488 (  29 69 ) resistor r=5.4201 //w=0.17 //l=0.085 //layer=li \
 //thickness=0.1 //x=63.565 //y=5.38 //x2=63.65 //y2=5.38
r489 (  29 30 ) resistor r=48.5989 //w=0.187 //l=0.71 //layer=li \
 //thickness=0.1 //x=63.565 //y=5.38 //x2=62.855 //y2=5.38
r490 (  23 30 ) resistor r=7.15173 //w=0.17 //l=0.120208 //layer=li \
 //thickness=0.1 //x=62.77 //y=5.465 //x2=62.855 //y2=5.38
r491 (  23 166 ) resistor r=30.1176 //w=0.187 //l=0.44 //layer=li \
 //thickness=0.1 //x=62.77 //y=5.465 //x2=62.77 //y2=5.905
r492 (  19 135 ) resistor r=152 //w=0.17 //l=0.17 //layer=licon //count=1 \
 //x=60.06 //y=2.26 //x2=60.06 //y2=2.26
r493 (  19 22 ) resistor r=110.888 //w=0.187 //l=1.62 //layer=li \
 //thickness=0.1 //x=60.06 //y=2.26 //x2=60.06 //y2=3.88
r494 (  17 68 ) resistor r=11.4737 //w=0.186 //l=0.172337 //layer=li \
 //thickness=0.1 //x=60.06 //y=4.715 //x2=60.075 //y2=4.88
r495 (  17 22 ) resistor r=57.1551 //w=0.187 //l=0.835 //layer=li \
 //thickness=0.1 //x=60.06 //y=4.715 //x2=60.06 //y2=3.88
r496 (  16 63 ) resistor r=9.3 //w=0.17 //l=0.17 //layer=mcon //count=1 \
 //x=69.31 //y=4.62 //x2=69.31 //y2=4.62
r497 (  14 53 ) resistor r=9.3 //w=0.17 //l=0.17 //layer=mcon //count=1 \
 //x=65.61 //y=3.88 //x2=65.61 //y2=3.88
r498 (  12 55 ) resistor r=9.3 //w=0.17 //l=0.17 //layer=mcon //count=1 \
 //x=65.61 //y=4.62 //x2=65.61 //y2=4.62
r499 (  10 48 ) resistor r=9.3 //w=0.17 //l=0.17 //layer=mcon //count=1 \
 //x=64.13 //y=3.88 //x2=64.13 //y2=3.88
r500 (  8 22 ) resistor r=9.3 //w=0.17 //l=0.17 //layer=mcon //count=1 \
 //x=60.06 //y=3.88 //x2=60.06 //y2=3.88
r501 (  6 12 ) resistor r=0.0717383 //w=0.224 //l=0.115 //layer=m1 \
 //thickness=0.36 //x=65.725 //y=4.62 //x2=65.61 //y2=4.62
r502 (  5 16 ) resistor r=0.0717383 //w=0.224 //l=0.115 //layer=m1 \
 //thickness=0.36 //x=69.195 //y=4.62 //x2=69.31 //y2=4.62
r503 (  5 6 ) resistor r=3.31107 //w=0.131 //l=3.47 //layer=m1 \
 //thickness=0.36 //x=69.195 //y=4.62 //x2=65.725 //y2=4.62
r504 (  4 10 ) resistor r=0.0880901 //w=0.191 //l=0.115 //layer=m1 \
 //thickness=0.36 //x=64.245 //y=3.88 //x2=64.13 //y2=3.88
r505 (  3 14 ) resistor r=0.0717383 //w=0.224 //l=0.115 //layer=m1 \
 //thickness=0.36 //x=65.495 //y=3.88 //x2=65.61 //y2=3.88
r506 (  3 4 ) resistor r=1.19275 //w=0.131 //l=1.25 //layer=m1 \
 //thickness=0.36 //x=65.495 //y=3.88 //x2=64.245 //y2=3.88
r507 (  2 8 ) resistor r=0.0717383 //w=0.224 //l=0.115 //layer=m1 \
 //thickness=0.36 //x=60.175 //y=3.88 //x2=60.06 //y2=3.88
r508 (  1 10 ) resistor r=0.0880901 //w=0.191 //l=0.115 //layer=m1 \
 //thickness=0.36 //x=64.015 //y=3.88 //x2=64.13 //y2=3.88
r509 (  1 2 ) resistor r=3.66412 //w=0.131 //l=3.84 //layer=m1 \
 //thickness=0.36 //x=64.015 //y=3.88 //x2=60.175 //y2=3.88
ends PM_TMRDFFQX1\%noxref_20

subckt PM_TMRDFFQX1\%noxref_21 ( 1 2 3 4 5 6 17 19 29 30 41 43 44 48 49 51 59 \
 65 69 72 73 74 75 76 77 78 79 80 81 82 83 88 90 92 98 99 100 101 102 107 109 \
 111 117 118 119 120 121 126 128 130 136 137 139 140 143 152 153 156 164 165 \
 168 176 178 179 )
c506 ( 179 0 ) capacitor c=0.0220291f //x=42.045 //y=5.2
c507 ( 178 0 ) capacitor c=0.0217503f //x=41.165 //y=5.2
c508 ( 176 0 ) capacitor c=0.0084702f //x=42.04 //y=1.085
c509 ( 168 0 ) capacitor c=0.0352016f //x=73.4 //y=4.885
c510 ( 165 0 ) capacitor c=0.0279733f //x=73.38 //y=2.095
c511 ( 164 0 ) capacitor c=0.0467621f //x=73.38 //y=2.26
c512 ( 156 0 ) capacitor c=0.03845f //x=66.76 //y=4.885
c513 ( 153 0 ) capacitor c=0.0300885f //x=66.72 //y=2.095
c514 ( 152 0 ) capacitor c=0.050087f //x=66.72 //y=2.26
c515 ( 143 0 ) capacitor c=0.0331095f //x=38.63 //y=4.88
c516 ( 140 0 ) capacitor c=0.0279499f //x=38.6 //y=2.095
c517 ( 139 0 ) capacitor c=0.0420383f //x=38.6 //y=2.26
c518 ( 137 0 ) capacitor c=0.0237734f //x=73.945 //y=1.435
c519 ( 136 0 ) capacitor c=0.0191782f //x=73.945 //y=1.085
c520 ( 130 0 ) capacitor c=0.0351663f //x=73.79 //y=1.585
c521 ( 128 0 ) capacitor c=0.0157803f //x=73.79 //y=0.93
c522 ( 126 0 ) capacitor c=0.0374703f //x=73.785 //y=4.975
c523 ( 121 0 ) capacitor c=0.0200628f //x=73.415 //y=1.74
c524 ( 120 0 ) capacitor c=0.0168575f //x=73.415 //y=1.435
c525 ( 119 0 ) capacitor c=0.0174993f //x=73.415 //y=1.085
c526 ( 118 0 ) capacitor c=0.0447087f //x=67.285 //y=1.43
c527 ( 117 0 ) capacitor c=0.019286f //x=67.285 //y=1.085
c528 ( 111 0 ) capacitor c=0.0187932f //x=67.13 //y=1.585
c529 ( 109 0 ) capacitor c=0.0157795f //x=67.13 //y=0.93
c530 ( 107 0 ) capacitor c=0.029531f //x=67.125 //y=4.975
c531 ( 102 0 ) capacitor c=0.0206178f //x=66.755 //y=1.74
c532 ( 101 0 ) capacitor c=0.016848f //x=66.755 //y=1.43
c533 ( 100 0 ) capacitor c=0.0174777f //x=66.755 //y=1.085
c534 ( 99 0 ) capacitor c=0.0429696f //x=39.165 //y=1.43
c535 ( 98 0 ) capacitor c=0.0192208f //x=39.165 //y=1.085
c536 ( 92 0 ) capacitor c=0.0148884f //x=39.01 //y=1.585
c537 ( 90 0 ) capacitor c=0.0157803f //x=39.01 //y=0.93
c538 ( 88 0 ) capacitor c=0.0295235f //x=39.005 //y=4.97
c539 ( 83 0 ) capacitor c=0.0204188f //x=38.635 //y=1.74
c540 ( 82 0 ) capacitor c=0.0168481f //x=38.635 //y=1.43
c541 ( 81 0 ) capacitor c=0.0174783f //x=38.635 //y=1.085
c542 ( 80 0 ) capacitor c=0.15325f //x=73.86 //y=6.205
c543 ( 79 0 ) capacitor c=0.110411f //x=73.42 //y=6.205
c544 ( 78 0 ) capacitor c=0.154236f //x=67.2 //y=6.205
c545 ( 77 0 ) capacitor c=0.110294f //x=66.76 //y=6.205
c546 ( 76 0 ) capacitor c=0.15358f //x=39.08 //y=6.2
c547 ( 75 0 ) capacitor c=0.110281f //x=38.64 //y=6.2
c548 ( 69 0 ) capacitor c=0.00501304f //x=73.4 //y=4.885
c549 ( 65 0 ) capacitor c=0.00211606f //x=42.19 //y=5.38
c550 ( 59 0 ) capacitor c=0.0901308f //x=73.38 //y=2.26
c551 ( 51 0 ) capacitor c=0.106138f //x=66.72 //y=2.26
c552 ( 49 0 ) capacitor c=0.00669947f //x=66.72 //y=4.72
c553 ( 48 0 ) capacitor c=0.109862f //x=42.67 //y=2.4
c554 ( 44 0 ) capacitor c=0.00404073f //x=42.315 //y=1.835
c555 ( 43 0 ) capacitor c=0.0122167f //x=42.585 //y=1.835
c556 ( 41 0 ) capacitor c=0.0137995f //x=42.585 //y=5.38
c557 ( 30 0 ) capacitor c=0.00251459f //x=41.395 //y=5.38
c558 ( 29 0 ) capacitor c=0.0143649f //x=42.105 //y=5.38
c559 ( 19 0 ) capacitor c=0.0699202f //x=38.6 //y=2.26
c560 ( 17 0 ) capacitor c=0.00453889f //x=38.6 //y=4.715
c561 ( 6 0 ) capacitor c=0.0111493f //x=66.835 //y=4.25
c562 ( 5 0 ) capacitor c=0.194021f //x=73.265 //y=4.25
c563 ( 4 0 ) capacitor c=0.0053389f //x=42.785 //y=2.4
c564 ( 3 0 ) capacitor c=0.528702f //x=66.605 //y=2.4
c565 ( 2 0 ) capacitor c=0.0141371f //x=38.715 //y=2.4
c566 ( 1 0 ) capacitor c=0.0738364f //x=42.555 //y=2.4
r567 (  170 171 ) resistor r=32.4568 //w=0.214 //l=0.075 //layer=ply \
 //thickness=0.18 //x=73.4 //y=4.975 //x2=73.4 //y2=5.05
r568 (  168 170 ) resistor r=20.271 //w=0.214 //l=0.09 //layer=ply \
 //thickness=0.18 //x=73.4 //y=4.885 //x2=73.4 //y2=4.975
r569 (  164 165 ) resistor r=52.7279 //w=0.214 //l=0.165 //layer=ply \
 //thickness=0.18 //x=73.38 //y=2.26 //x2=73.38 //y2=2.095
r570 (  156 158 ) resistor r=20.271 //w=0.214 //l=0.09 //layer=ply \
 //thickness=0.18 //x=66.76 //y=4.885 //x2=66.76 //y2=4.975
r571 (  152 153 ) resistor r=52.7279 //w=0.214 //l=0.165 //layer=ply \
 //thickness=0.18 //x=66.72 //y=2.26 //x2=66.72 //y2=2.095
r572 (  145 146 ) resistor r=32.4568 //w=0.214 //l=0.075 //layer=ply \
 //thickness=0.18 //x=38.63 //y=4.97 //x2=38.63 //y2=5.045
r573 (  143 145 ) resistor r=20.271 //w=0.214 //l=0.09 //layer=ply \
 //thickness=0.18 //x=38.63 //y=4.88 //x2=38.63 //y2=4.97
r574 (  139 140 ) resistor r=52.7279 //w=0.214 //l=0.165 //layer=ply \
 //thickness=0.18 //x=38.6 //y=2.26 //x2=38.6 //y2=2.095
r575 (  137 175 ) resistor r=4.95774 //w=0.164 //l=0.112 //layer=ply \
 //thickness=0.18 //x=73.945 //y=1.435 //x2=73.945 //y2=1.547
r576 (  136 174 ) resistor r=45.1352 //w=0.168 //l=0.173853 //layer=ply \
 //thickness=0.18 //x=73.945 //y=1.085 //x2=73.905 //y2=0.93
r577 (  136 137 ) resistor r=179.468 //w=0.094 //l=0.35 //layer=ply \
 //thickness=0.18 //x=73.945 //y=1.085 //x2=73.945 //y2=1.435
r578 (  131 173 ) resistor r=10.8103 //w=0.211 //l=0.115 //layer=ply \
 //thickness=0.18 //x=73.57 //y=1.585 //x2=73.455 //y2=1.585
r579 (  130 175 ) resistor r=45.9962 //w=0.164 //l=0.17296 //layer=ply \
 //thickness=0.18 //x=73.79 //y=1.585 //x2=73.945 //y2=1.547
r580 (  129 172 ) resistor r=5.52526 //w=0.168 //l=0.115 //layer=ply \
 //thickness=0.18 //x=73.57 //y=0.93 //x2=73.455 //y2=0.93
r581 (  128 174 ) resistor r=5.52526 //w=0.168 //l=0.115 //layer=ply \
 //thickness=0.18 //x=73.79 //y=0.93 //x2=73.905 //y2=0.93
r582 (  128 129 ) resistor r=112.809 //w=0.094 //l=0.22 //layer=ply \
 //thickness=0.18 //x=73.79 //y=0.93 //x2=73.57 //y2=0.93
r583 (  127 170 ) resistor r=16.5046 //w=0.27 //l=0.135 //layer=ply \
 //thickness=0.18 //x=73.535 //y=4.975 //x2=73.4 //y2=4.975
r584 (  126 133 ) resistor r=26.9307 //w=0.15 //l=0.106066 //layer=ply \
 //thickness=0.18 //x=73.785 //y=4.975 //x2=73.86 //y2=5.05
r585 (  126 127 ) resistor r=128.191 //w=0.094 //l=0.25 //layer=ply \
 //thickness=0.18 //x=73.785 //y=4.975 //x2=73.535 //y2=4.975
r586 (  121 173 ) resistor r=39.5036 //w=0.211 //l=0.173853 //layer=ply \
 //thickness=0.18 //x=73.415 //y=1.74 //x2=73.455 //y2=1.585
r587 (  121 165 ) resistor r=182.032 //w=0.094 //l=0.355 //layer=ply \
 //thickness=0.18 //x=73.415 //y=1.74 //x2=73.415 //y2=2.095
r588 (  120 173 ) resistor r=38.3614 //w=0.211 //l=0.168819 //layer=ply \
 //thickness=0.18 //x=73.415 //y=1.435 //x2=73.455 //y2=1.585
r589 (  119 172 ) resistor r=45.1352 //w=0.168 //l=0.173853 //layer=ply \
 //thickness=0.18 //x=73.415 //y=1.085 //x2=73.455 //y2=0.93
r590 (  119 120 ) resistor r=179.468 //w=0.094 //l=0.35 //layer=ply \
 //thickness=0.18 //x=73.415 //y=1.085 //x2=73.415 //y2=1.435
r591 (  118 162 ) resistor r=45.1352 //w=0.168 //l=0.173853 //layer=ply \
 //thickness=0.18 //x=67.285 //y=1.43 //x2=67.245 //y2=1.585
r592 (  117 161 ) resistor r=45.1352 //w=0.168 //l=0.173853 //layer=ply \
 //thickness=0.18 //x=67.285 //y=1.085 //x2=67.245 //y2=0.93
r593 (  117 118 ) resistor r=176.904 //w=0.094 //l=0.345 //layer=ply \
 //thickness=0.18 //x=67.285 //y=1.085 //x2=67.285 //y2=1.43
r594 (  112 160 ) resistor r=10.701 //w=0.21 //l=0.115 //layer=ply \
 //thickness=0.18 //x=66.91 //y=1.585 //x2=66.795 //y2=1.585
r595 (  111 162 ) resistor r=5.52526 //w=0.168 //l=0.115 //layer=ply \
 //thickness=0.18 //x=67.13 //y=1.585 //x2=67.245 //y2=1.585
r596 (  110 159 ) resistor r=5.52526 //w=0.168 //l=0.115 //layer=ply \
 //thickness=0.18 //x=66.91 //y=0.93 //x2=66.795 //y2=0.93
r597 (  109 161 ) resistor r=5.52526 //w=0.168 //l=0.115 //layer=ply \
 //thickness=0.18 //x=67.13 //y=0.93 //x2=67.245 //y2=0.93
r598 (  109 110 ) resistor r=112.809 //w=0.094 //l=0.22 //layer=ply \
 //thickness=0.18 //x=67.13 //y=0.93 //x2=66.91 //y2=0.93
r599 (  108 158 ) resistor r=16.5046 //w=0.27 //l=0.135 //layer=ply \
 //thickness=0.18 //x=66.895 //y=4.975 //x2=66.76 //y2=4.975
r600 (  107 114 ) resistor r=26.9307 //w=0.15 //l=0.106066 //layer=ply \
 //thickness=0.18 //x=67.125 //y=4.975 //x2=67.2 //y2=5.05
r601 (  107 108 ) resistor r=117.936 //w=0.094 //l=0.23 //layer=ply \
 //thickness=0.18 //x=67.125 //y=4.975 //x2=66.895 //y2=4.975
r602 (  104 158 ) resistor r=32.4568 //w=0.214 //l=0.075 //layer=ply \
 //thickness=0.18 //x=66.76 //y=5.05 //x2=66.76 //y2=4.975
r603 (  102 160 ) resistor r=39.5823 //w=0.21 //l=0.173853 //layer=ply \
 //thickness=0.18 //x=66.755 //y=1.74 //x2=66.795 //y2=1.585
r604 (  102 153 ) resistor r=182.032 //w=0.094 //l=0.355 //layer=ply \
 //thickness=0.18 //x=66.755 //y=1.74 //x2=66.755 //y2=2.095
r605 (  101 160 ) resistor r=39.5823 //w=0.21 //l=0.173853 //layer=ply \
 //thickness=0.18 //x=66.755 //y=1.43 //x2=66.795 //y2=1.585
r606 (  100 159 ) resistor r=45.1352 //w=0.168 //l=0.173853 //layer=ply \
 //thickness=0.18 //x=66.755 //y=1.085 //x2=66.795 //y2=0.93
r607 (  100 101 ) resistor r=176.904 //w=0.094 //l=0.345 //layer=ply \
 //thickness=0.18 //x=66.755 //y=1.085 //x2=66.755 //y2=1.43
r608 (  99 150 ) resistor r=45.1352 //w=0.168 //l=0.173853 //layer=ply \
 //thickness=0.18 //x=39.165 //y=1.43 //x2=39.125 //y2=1.585
r609 (  98 149 ) resistor r=45.1352 //w=0.168 //l=0.173853 //layer=ply \
 //thickness=0.18 //x=39.165 //y=1.085 //x2=39.125 //y2=0.93
r610 (  98 99 ) resistor r=176.904 //w=0.094 //l=0.345 //layer=ply \
 //thickness=0.18 //x=39.165 //y=1.085 //x2=39.165 //y2=1.43
r611 (  93 148 ) resistor r=10.701 //w=0.21 //l=0.115 //layer=ply \
 //thickness=0.18 //x=38.79 //y=1.585 //x2=38.675 //y2=1.585
r612 (  92 150 ) resistor r=5.52526 //w=0.168 //l=0.115 //layer=ply \
 //thickness=0.18 //x=39.01 //y=1.585 //x2=39.125 //y2=1.585
r613 (  91 147 ) resistor r=5.52526 //w=0.168 //l=0.115 //layer=ply \
 //thickness=0.18 //x=38.79 //y=0.93 //x2=38.675 //y2=0.93
r614 (  90 149 ) resistor r=5.52526 //w=0.168 //l=0.115 //layer=ply \
 //thickness=0.18 //x=39.01 //y=0.93 //x2=39.125 //y2=0.93
r615 (  90 91 ) resistor r=112.809 //w=0.094 //l=0.22 //layer=ply \
 //thickness=0.18 //x=39.01 //y=0.93 //x2=38.79 //y2=0.93
r616 (  89 145 ) resistor r=16.5046 //w=0.27 //l=0.135 //layer=ply \
 //thickness=0.18 //x=38.765 //y=4.97 //x2=38.63 //y2=4.97
r617 (  88 95 ) resistor r=26.9307 //w=0.15 //l=0.106066 //layer=ply \
 //thickness=0.18 //x=39.005 //y=4.97 //x2=39.08 //y2=5.045
r618 (  88 89 ) resistor r=123.064 //w=0.094 //l=0.24 //layer=ply \
 //thickness=0.18 //x=39.005 //y=4.97 //x2=38.765 //y2=4.97
r619 (  83 148 ) resistor r=39.5823 //w=0.21 //l=0.173853 //layer=ply \
 //thickness=0.18 //x=38.635 //y=1.74 //x2=38.675 //y2=1.585
r620 (  83 140 ) resistor r=182.032 //w=0.094 //l=0.355 //layer=ply \
 //thickness=0.18 //x=38.635 //y=1.74 //x2=38.635 //y2=2.095
r621 (  82 148 ) resistor r=39.5823 //w=0.21 //l=0.173853 //layer=ply \
 //thickness=0.18 //x=38.635 //y=1.43 //x2=38.675 //y2=1.585
r622 (  81 147 ) resistor r=45.1352 //w=0.168 //l=0.173853 //layer=ply \
 //thickness=0.18 //x=38.635 //y=1.085 //x2=38.675 //y2=0.93
r623 (  81 82 ) resistor r=176.904 //w=0.094 //l=0.345 //layer=ply \
 //thickness=0.18 //x=38.635 //y=1.085 //x2=38.635 //y2=1.43
r624 (  80 133 ) resistor r=592.245 //w=0.094 //l=1.155 //layer=ply \
 //thickness=0.18 //x=73.86 //y=6.205 //x2=73.86 //y2=5.05
r625 (  79 171 ) resistor r=592.245 //w=0.094 //l=1.155 //layer=ply \
 //thickness=0.18 //x=73.42 //y=6.205 //x2=73.42 //y2=5.05
r626 (  78 114 ) resistor r=592.245 //w=0.094 //l=1.155 //layer=ply \
 //thickness=0.18 //x=67.2 //y=6.205 //x2=67.2 //y2=5.05
r627 (  77 104 ) resistor r=592.245 //w=0.094 //l=1.155 //layer=ply \
 //thickness=0.18 //x=66.76 //y=6.205 //x2=66.76 //y2=5.05
r628 (  76 95 ) resistor r=592.245 //w=0.094 //l=1.155 //layer=ply \
 //thickness=0.18 //x=39.08 //y=6.2 //x2=39.08 //y2=5.045
r629 (  75 146 ) resistor r=592.245 //w=0.094 //l=1.155 //layer=ply \
 //thickness=0.18 //x=38.64 //y=6.2 //x2=38.64 //y2=5.045
r630 (  74 130 ) resistor r=56.4043 //w=0.094 //l=0.11 //layer=ply \
 //thickness=0.18 //x=73.68 //y=1.585 //x2=73.79 //y2=1.585
r631 (  74 131 ) resistor r=56.4043 //w=0.094 //l=0.11 //layer=ply \
 //thickness=0.18 //x=73.68 //y=1.585 //x2=73.57 //y2=1.585
r632 (  73 111 ) resistor r=56.4043 //w=0.094 //l=0.11 //layer=ply \
 //thickness=0.18 //x=67.02 //y=1.585 //x2=67.13 //y2=1.585
r633 (  73 112 ) resistor r=56.4043 //w=0.094 //l=0.11 //layer=ply \
 //thickness=0.18 //x=67.02 //y=1.585 //x2=66.91 //y2=1.585
r634 (  72 92 ) resistor r=56.4043 //w=0.094 //l=0.11 //layer=ply \
 //thickness=0.18 //x=38.9 //y=1.585 //x2=39.01 //y2=1.585
r635 (  72 93 ) resistor r=56.4043 //w=0.094 //l=0.11 //layer=ply \
 //thickness=0.18 //x=38.9 //y=1.585 //x2=38.79 //y2=1.585
r636 (  69 168 ) resistor r=152 //w=0.17 //l=0.17 //layer=licon //count=1 \
 //x=73.4 //y=4.885 //x2=73.4 //y2=4.885
r637 (  69 70 ) resistor r=10.3507 //w=0.207 //l=0.165 //layer=li \
 //thickness=0.1 //x=73.39 //y=4.885 //x2=73.39 //y2=4.72
r638 (  67 156 ) resistor r=152 //w=0.17 //l=0.17 //layer=licon //count=1 \
 //x=66.76 //y=4.885 //x2=66.76 //y2=4.885
r639 (  64 143 ) resistor r=152 //w=0.17 //l=0.17 //layer=licon //count=1 \
 //x=38.63 //y=4.88 //x2=38.63 //y2=4.88
r640 (  62 70 ) resistor r=32.1711 //w=0.187 //l=0.47 //layer=li \
 //thickness=0.1 //x=73.38 //y=4.25 //x2=73.38 //y2=4.72
r641 (  59 164 ) resistor r=152 //w=0.17 //l=0.17 //layer=licon //count=1 \
 //x=73.38 //y=2.26 //x2=73.38 //y2=2.26
r642 (  59 62 ) resistor r=136.214 //w=0.187 //l=1.99 //layer=li \
 //thickness=0.1 //x=73.38 //y=2.26 //x2=73.38 //y2=4.25
r643 (  54 56 ) resistor r=126.631 //w=0.187 //l=1.85 //layer=li \
 //thickness=0.1 //x=66.72 //y=2.4 //x2=66.72 //y2=4.25
r644 (  51 152 ) resistor r=152 //w=0.17 //l=0.17 //layer=licon //count=1 \
 //x=66.72 //y=2.26 //x2=66.72 //y2=2.26
r645 (  51 54 ) resistor r=9.58289 //w=0.187 //l=0.14 //layer=li \
 //thickness=0.1 //x=66.72 //y=2.26 //x2=66.72 //y2=2.4
r646 (  49 67 ) resistor r=11.2426 //w=0.191 //l=0.174714 //layer=li \
 //thickness=0.1 //x=66.72 //y=4.72 //x2=66.74 //y2=4.885
r647 (  49 56 ) resistor r=32.1711 //w=0.187 //l=0.47 //layer=li \
 //thickness=0.1 //x=66.72 //y=4.72 //x2=66.72 //y2=4.25
r648 (  46 48 ) resistor r=198.16 //w=0.187 //l=2.895 //layer=li \
 //thickness=0.1 //x=42.67 //y=5.295 //x2=42.67 //y2=2.4
r649 (  45 48 ) resistor r=32.8556 //w=0.187 //l=0.48 //layer=li \
 //thickness=0.1 //x=42.67 //y=1.92 //x2=42.67 //y2=2.4
r650 (  43 45 ) resistor r=7.15173 //w=0.17 //l=0.120208 //layer=li \
 //thickness=0.1 //x=42.585 //y=1.835 //x2=42.67 //y2=1.92
r651 (  43 44 ) resistor r=18.4813 //w=0.187 //l=0.27 //layer=li \
 //thickness=0.1 //x=42.585 //y=1.835 //x2=42.315 //y2=1.835
r652 (  42 65 ) resistor r=5.4201 //w=0.17 //l=0.085 //layer=li \
 //thickness=0.1 //x=42.275 //y=5.38 //x2=42.19 //y2=5.38
r653 (  41 46 ) resistor r=7.15173 //w=0.17 //l=0.120208 //layer=li \
 //thickness=0.1 //x=42.585 //y=5.38 //x2=42.67 //y2=5.295
r654 (  41 42 ) resistor r=21.2193 //w=0.187 //l=0.31 //layer=li \
 //thickness=0.1 //x=42.585 //y=5.38 //x2=42.275 //y2=5.38
r655 (  37 44 ) resistor r=7.15173 //w=0.17 //l=0.120208 //layer=li \
 //thickness=0.1 //x=42.23 //y=1.75 //x2=42.315 //y2=1.835
r656 (  37 176 ) resistor r=39.016 //w=0.187 //l=0.57 //layer=li \
 //thickness=0.1 //x=42.23 //y=1.75 //x2=42.23 //y2=1.18
r657 (  31 65 ) resistor r=1.40859 //w=0.34 //l=0.085 //layer=li \
 //thickness=0.1 //x=42.19 //y=5.465 //x2=42.19 //y2=5.38
r658 (  31 179 ) resistor r=30.1176 //w=0.187 //l=0.44 //layer=li \
 //thickness=0.1 //x=42.19 //y=5.465 //x2=42.19 //y2=5.905
r659 (  29 65 ) resistor r=5.4201 //w=0.17 //l=0.085 //layer=li \
 //thickness=0.1 //x=42.105 //y=5.38 //x2=42.19 //y2=5.38
r660 (  29 30 ) resistor r=48.5989 //w=0.187 //l=0.71 //layer=li \
 //thickness=0.1 //x=42.105 //y=5.38 //x2=41.395 //y2=5.38
r661 (  23 30 ) resistor r=7.15173 //w=0.17 //l=0.120208 //layer=li \
 //thickness=0.1 //x=41.31 //y=5.465 //x2=41.395 //y2=5.38
r662 (  23 178 ) resistor r=30.1176 //w=0.187 //l=0.44 //layer=li \
 //thickness=0.1 //x=41.31 //y=5.465 //x2=41.31 //y2=5.905
r663 (  19 139 ) resistor r=152 //w=0.17 //l=0.17 //layer=licon //count=1 \
 //x=38.6 //y=2.26 //x2=38.6 //y2=2.26
r664 (  19 22 ) resistor r=9.58289 //w=0.187 //l=0.14 //layer=li \
 //thickness=0.1 //x=38.6 //y=2.26 //x2=38.6 //y2=2.4
r665 (  17 64 ) resistor r=11.4737 //w=0.186 //l=0.172337 //layer=li \
 //thickness=0.1 //x=38.6 //y=4.715 //x2=38.615 //y2=4.88
r666 (  17 22 ) resistor r=158.46 //w=0.187 //l=2.315 //layer=li \
 //thickness=0.1 //x=38.6 //y=4.715 //x2=38.6 //y2=2.4
r667 (  16 62 ) resistor r=9.3 //w=0.17 //l=0.17 //layer=mcon //count=1 \
 //x=73.38 //y=4.25 //x2=73.38 //y2=4.25
r668 (  14 54 ) resistor r=9.3 //w=0.17 //l=0.17 //layer=mcon //count=1 \
 //x=66.72 //y=2.4 //x2=66.72 //y2=2.4
r669 (  12 56 ) resistor r=9.3 //w=0.17 //l=0.17 //layer=mcon //count=1 \
 //x=66.72 //y=4.25 //x2=66.72 //y2=4.25
r670 (  10 48 ) resistor r=9.3 //w=0.17 //l=0.17 //layer=mcon //count=1 \
 //x=42.67 //y=2.4 //x2=42.67 //y2=2.4
r671 (  8 22 ) resistor r=9.3 //w=0.17 //l=0.17 //layer=mcon //count=1 \
 //x=38.6 //y=2.4 //x2=38.6 //y2=2.4
r672 (  6 12 ) resistor r=0.0717383 //w=0.224 //l=0.115 //layer=m1 \
 //thickness=0.36 //x=66.835 //y=4.25 //x2=66.72 //y2=4.25
r673 (  5 16 ) resistor r=0.0717383 //w=0.224 //l=0.115 //layer=m1 \
 //thickness=0.36 //x=73.265 //y=4.25 //x2=73.38 //y2=4.25
r674 (  5 6 ) resistor r=6.1355 //w=0.131 //l=6.43 //layer=m1 //thickness=0.36 \
 //x=73.265 //y=4.25 //x2=66.835 //y2=4.25
r675 (  4 10 ) resistor r=0.0880901 //w=0.191 //l=0.115 //layer=m1 \
 //thickness=0.36 //x=42.785 //y=2.4 //x2=42.67 //y2=2.4
r676 (  3 14 ) resistor r=0.0717383 //w=0.224 //l=0.115 //layer=m1 \
 //thickness=0.36 //x=66.605 //y=2.4 //x2=66.72 //y2=2.4
r677 (  3 4 ) resistor r=22.729 //w=0.131 //l=23.82 //layer=m1 \
 //thickness=0.36 //x=66.605 //y=2.4 //x2=42.785 //y2=2.4
r678 (  2 8 ) resistor r=0.0717383 //w=0.224 //l=0.115 //layer=m1 \
 //thickness=0.36 //x=38.715 //y=2.4 //x2=38.6 //y2=2.4
r679 (  1 10 ) resistor r=0.0880901 //w=0.191 //l=0.115 //layer=m1 \
 //thickness=0.36 //x=42.555 //y=2.4 //x2=42.67 //y2=2.4
r680 (  1 2 ) resistor r=3.66412 //w=0.131 //l=3.84 //layer=m1 \
 //thickness=0.36 //x=42.555 //y=2.4 //x2=38.715 //y2=2.4
ends PM_TMRDFFQX1\%noxref_21

subckt PM_TMRDFFQX1\%noxref_22 ( 1 2 13 14 15 23 29 30 37 50 51 52 53 54 )
c91 ( 54 0 ) capacitor c=0.034295f //x=70.595 //y=5.205
c92 ( 53 0 ) capacitor c=0.0174957f //x=69.715 //y=5.205
c93 ( 51 0 ) capacitor c=0.0214849f //x=66.835 //y=5.205
c94 ( 50 0 ) capacitor c=0.0217161f //x=65.955 //y=5.205
c95 ( 49 0 ) capacitor c=0.00115294f //x=69.86 //y=7.09
c96 ( 37 0 ) capacitor c=0.0131238f //x=70.655 //y=7.09
c97 ( 30 0 ) capacitor c=0.00386507f //x=69.065 //y=7.09
c98 ( 29 0 ) capacitor c=0.00951687f //x=69.775 //y=7.09
c99 ( 23 0 ) capacitor c=0.0455351f //x=68.98 //y=5.39
c100 ( 15 0 ) capacitor c=0.00869404f //x=66.98 //y=5.475
c101 ( 14 0 ) capacitor c=0.00290434f //x=66.185 //y=5.39
c102 ( 13 0 ) capacitor c=0.0139202f //x=66.895 //y=5.39
c103 ( 2 0 ) capacitor c=0.0091252f //x=67.095 //y=5.39
c104 ( 1 0 ) capacitor c=0.0484159f //x=68.865 //y=5.39
r105 (  39 54 ) resistor r=5.81818 //w=0.187 //l=0.085 //layer=li \
 //thickness=0.1 //x=70.74 //y=7.005 //x2=70.74 //y2=6.92
r106 (  38 49 ) resistor r=5.4201 //w=0.17 //l=0.085 //layer=li \
 //thickness=0.1 //x=69.945 //y=7.09 //x2=69.86 //y2=7.09
r107 (  37 39 ) resistor r=7.15173 //w=0.17 //l=0.120208 //layer=li \
 //thickness=0.1 //x=70.655 //y=7.09 //x2=70.74 //y2=7.005
r108 (  37 38 ) resistor r=48.5989 //w=0.187 //l=0.71 //layer=li \
 //thickness=0.1 //x=70.655 //y=7.09 //x2=69.945 //y2=7.09
r109 (  31 49 ) resistor r=1.40859 //w=0.34 //l=0.085 //layer=li \
 //thickness=0.1 //x=69.86 //y=7.005 //x2=69.86 //y2=7.09
r110 (  31 53 ) resistor r=5.81818 //w=0.187 //l=0.085 //layer=li \
 //thickness=0.1 //x=69.86 //y=7.005 //x2=69.86 //y2=6.92
r111 (  29 49 ) resistor r=5.4201 //w=0.17 //l=0.085 //layer=li \
 //thickness=0.1 //x=69.775 //y=7.09 //x2=69.86 //y2=7.09
r112 (  29 30 ) resistor r=48.5989 //w=0.187 //l=0.71 //layer=li \
 //thickness=0.1 //x=69.775 //y=7.09 //x2=69.065 //y2=7.09
r113 (  23 52 ) resistor r=58.1818 //w=0.187 //l=0.85 //layer=li \
 //thickness=0.1 //x=68.98 //y=5.39 //x2=68.98 //y2=6.24
r114 (  21 30 ) resistor r=7.15173 //w=0.17 //l=0.120208 //layer=li \
 //thickness=0.1 //x=68.98 //y=7.005 //x2=69.065 //y2=7.09
r115 (  21 52 ) resistor r=5.81818 //w=0.187 //l=0.085 //layer=li \
 //thickness=0.1 //x=68.98 //y=7.005 //x2=68.98 //y2=6.92
r116 (  15 48 ) resistor r=3.57586 //w=0.17 //l=0.125 //layer=li \
 //thickness=0.1 //x=66.98 //y=5.475 //x2=66.98 //y2=5.35
r117 (  15 51 ) resistor r=52.3636 //w=0.187 //l=0.765 //layer=li \
 //thickness=0.1 //x=66.98 //y=5.475 //x2=66.98 //y2=6.24
r118 (  13 48 ) resistor r=3.57586 //w=0.17 //l=0.103078 //layer=li \
 //thickness=0.1 //x=66.895 //y=5.39 //x2=66.98 //y2=5.35
r119 (  13 14 ) resistor r=48.5989 //w=0.187 //l=0.71 //layer=li \
 //thickness=0.1 //x=66.895 //y=5.39 //x2=66.185 //y2=5.39
r120 (  7 14 ) resistor r=7.15173 //w=0.17 //l=0.120208 //layer=li \
 //thickness=0.1 //x=66.1 //y=5.475 //x2=66.185 //y2=5.39
r121 (  7 50 ) resistor r=29.0909 //w=0.187 //l=0.425 //layer=li \
 //thickness=0.1 //x=66.1 //y=5.475 //x2=66.1 //y2=5.9
r122 (  6 23 ) resistor r=9.3 //w=0.17 //l=0.17 //layer=mcon //count=1 \
 //x=68.98 //y=5.39 //x2=68.98 //y2=5.39
r123 (  4 48 ) resistor r=9.3 //w=0.17 //l=0.17 //layer=mcon //count=1 \
 //x=66.98 //y=5.39 //x2=66.98 //y2=5.39
r124 (  2 4 ) resistor r=0.0717383 //w=0.224 //l=0.115 //layer=m1 \
 //thickness=0.36 //x=67.095 //y=5.39 //x2=66.98 //y2=5.39
r125 (  1 6 ) resistor r=0.0717383 //w=0.224 //l=0.115 //layer=m1 \
 //thickness=0.36 //x=68.865 //y=5.39 //x2=68.98 //y2=5.39
r126 (  1 2 ) resistor r=1.68893 //w=0.131 //l=1.77 //layer=m1 \
 //thickness=0.36 //x=68.865 //y=5.39 //x2=67.095 //y2=5.39
ends PM_TMRDFFQX1\%noxref_22

subckt PM_TMRDFFQX1\%noxref_23 ( 1 2 3 4 5 6 17 19 29 30 41 43 44 48 50 59 67 \
 68 69 70 71 72 73 74 75 76 77 78 79 84 86 88 94 95 99 100 101 102 103 105 108 \
 111 112 113 114 115 116 117 118 122 124 127 128 129 130 135 136 139 156 163 \
 165 166 )
c459 ( 166 0 ) capacitor c=0.0220291f //x=20.585 //y=5.2
c460 ( 165 0 ) capacitor c=0.0217503f //x=19.705 //y=5.2
c461 ( 163 0 ) capacitor c=0.0084702f //x=20.58 //y=1.085
c462 ( 156 0 ) capacitor c=0.0583848f //x=72.27 //y=2.26
c463 ( 139 0 ) capacitor c=0.0331095f //x=17.17 //y=4.88
c464 ( 136 0 ) capacitor c=0.0279499f //x=17.14 //y=2.095
c465 ( 135 0 ) capacitor c=0.0421302f //x=17.14 //y=2.26
c466 ( 130 0 ) capacitor c=0.0316774f //x=72.975 //y=1.39
c467 ( 129 0 ) capacitor c=0.0187384f //x=72.975 //y=1.045
c468 ( 128 0 ) capacitor c=0.0590362f //x=72.615 //y=4.975
c469 ( 127 0 ) capacitor c=0.0296075f //x=72.905 //y=4.975
c470 ( 124 0 ) capacitor c=0.0157912f //x=72.82 //y=1.545
c471 ( 122 0 ) capacitor c=0.0149844f //x=72.82 //y=0.89
c472 ( 118 0 ) capacitor c=0.0302441f //x=72.445 //y=2.095
c473 ( 117 0 ) capacitor c=0.0234157f //x=72.445 //y=1.7
c474 ( 116 0 ) capacitor c=0.0234376f //x=72.445 //y=1.39
c475 ( 115 0 ) capacitor c=0.0199931f //x=72.445 //y=1.045
c476 ( 114 0 ) capacitor c=0.093437f //x=70.615 //y=2.095
c477 ( 113 0 ) capacitor c=0.0249466f //x=70.615 //y=1.74
c478 ( 112 0 ) capacitor c=0.0234397f //x=70.615 //y=1.43
c479 ( 111 0 ) capacitor c=0.0193195f //x=70.615 //y=1.085
c480 ( 108 0 ) capacitor c=0.0631944f //x=70.52 //y=5.05
c481 ( 105 0 ) capacitor c=0.0187941f //x=70.46 //y=1.585
c482 ( 103 0 ) capacitor c=0.0157803f //x=70.46 //y=0.93
c483 ( 102 0 ) capacitor c=0.010629f //x=70.155 //y=4.975
c484 ( 101 0 ) capacitor c=0.0194269f //x=70.445 //y=4.975
c485 ( 100 0 ) capacitor c=0.0365717f //x=70.085 //y=1.43
c486 ( 99 0 ) capacitor c=0.0175988f //x=70.085 //y=1.085
c487 ( 95 0 ) capacitor c=0.0429696f //x=17.705 //y=1.43
c488 ( 94 0 ) capacitor c=0.0192208f //x=17.705 //y=1.085
c489 ( 88 0 ) capacitor c=0.0158629f //x=17.55 //y=1.585
c490 ( 86 0 ) capacitor c=0.0157803f //x=17.55 //y=0.93
c491 ( 84 0 ) capacitor c=0.0295235f //x=17.545 //y=4.97
c492 ( 79 0 ) capacitor c=0.0204188f //x=17.175 //y=1.74
c493 ( 78 0 ) capacitor c=0.0168481f //x=17.175 //y=1.43
c494 ( 77 0 ) capacitor c=0.0174783f //x=17.175 //y=1.085
c495 ( 76 0 ) capacitor c=0.110622f //x=72.98 //y=6.205
c496 ( 75 0 ) capacitor c=0.154068f //x=72.54 //y=6.205
c497 ( 74 0 ) capacitor c=0.154291f //x=70.52 //y=6.205
c498 ( 73 0 ) capacitor c=0.110404f //x=70.08 //y=6.205
c499 ( 72 0 ) capacitor c=0.15358f //x=17.62 //y=6.2
c500 ( 71 0 ) capacitor c=0.110281f //x=17.18 //y=6.2
c501 ( 67 0 ) capacitor c=0.00211606f //x=20.73 //y=5.38
c502 ( 59 0 ) capacitor c=0.100881f //x=72.27 //y=2.26
c503 ( 50 0 ) capacitor c=0.105664f //x=70.79 //y=2.26
c504 ( 48 0 ) capacitor c=0.110619f //x=21.21 //y=3.14
c505 ( 44 0 ) capacitor c=0.00436419f //x=20.855 //y=1.835
c506 ( 43 0 ) capacitor c=0.0127039f //x=21.125 //y=1.835
c507 ( 41 0 ) capacitor c=0.0137995f //x=21.125 //y=5.38
c508 ( 30 0 ) capacitor c=0.00251459f //x=19.935 //y=5.38
c509 ( 29 0 ) capacitor c=0.0143649f //x=20.645 //y=5.38
c510 ( 19 0 ) capacitor c=0.0718857f //x=17.14 //y=2.26
c511 ( 17 0 ) capacitor c=0.00453889f //x=17.14 //y=4.715
c512 ( 6 0 ) capacitor c=0.0100496f //x=70.905 //y=2.26
c513 ( 5 0 ) capacitor c=0.0462526f //x=72.155 //y=2.26
c514 ( 4 0 ) capacitor c=0.00475948f //x=21.325 //y=3.14
c515 ( 3 0 ) capacitor c=0.950065f //x=70.675 //y=3.14
c516 ( 2 0 ) capacitor c=0.0130562f //x=17.255 //y=3.14
c517 ( 1 0 ) capacitor c=0.0719815f //x=21.095 //y=3.14
r518 (  141 142 ) resistor r=32.4568 //w=0.214 //l=0.075 //layer=ply \
 //thickness=0.18 //x=17.17 //y=4.97 //x2=17.17 //y2=5.045
r519 (  139 141 ) resistor r=20.271 //w=0.214 //l=0.09 //layer=ply \
 //thickness=0.18 //x=17.17 //y=4.88 //x2=17.17 //y2=4.97
r520 (  135 136 ) resistor r=52.7279 //w=0.214 //l=0.165 //layer=ply \
 //thickness=0.18 //x=17.14 //y=2.26 //x2=17.14 //y2=2.095
r521 (  130 162 ) resistor r=45.1352 //w=0.168 //l=0.173853 //layer=ply \
 //thickness=0.18 //x=72.975 //y=1.39 //x2=72.935 //y2=1.545
r522 (  129 161 ) resistor r=45.1352 //w=0.168 //l=0.173853 //layer=ply \
 //thickness=0.18 //x=72.975 //y=1.045 //x2=72.935 //y2=0.89
r523 (  129 130 ) resistor r=176.904 //w=0.094 //l=0.345 //layer=ply \
 //thickness=0.18 //x=72.975 //y=1.045 //x2=72.975 //y2=1.39
r524 (  127 131 ) resistor r=26.9307 //w=0.15 //l=0.106066 //layer=ply \
 //thickness=0.18 //x=72.905 //y=4.975 //x2=72.98 //y2=5.05
r525 (  127 128 ) resistor r=148.702 //w=0.094 //l=0.29 //layer=ply \
 //thickness=0.18 //x=72.905 //y=4.975 //x2=72.615 //y2=4.975
r526 (  125 160 ) resistor r=10.701 //w=0.21 //l=0.115 //layer=ply \
 //thickness=0.18 //x=72.6 //y=1.545 //x2=72.485 //y2=1.545
r527 (  124 162 ) resistor r=5.52526 //w=0.168 //l=0.115 //layer=ply \
 //thickness=0.18 //x=72.82 //y=1.545 //x2=72.935 //y2=1.545
r528 (  123 159 ) resistor r=5.52526 //w=0.168 //l=0.115 //layer=ply \
 //thickness=0.18 //x=72.6 //y=0.89 //x2=72.485 //y2=0.89
r529 (  122 161 ) resistor r=5.52526 //w=0.168 //l=0.115 //layer=ply \
 //thickness=0.18 //x=72.82 //y=0.89 //x2=72.935 //y2=0.89
r530 (  122 123 ) resistor r=112.809 //w=0.094 //l=0.22 //layer=ply \
 //thickness=0.18 //x=72.82 //y=0.89 //x2=72.6 //y2=0.89
r531 (  119 128 ) resistor r=22.1787 //w=0.252 //l=0.106066 //layer=ply \
 //thickness=0.18 //x=72.54 //y=5.05 //x2=72.615 //y2=4.975
r532 (  119 158 ) resistor r=51.6429 //w=0.252 //l=0.34271 //layer=ply \
 //thickness=0.18 //x=72.54 //y=5.05 //x2=72.27 //y2=4.885
r533 (  118 156 ) resistor r=30.4513 //w=0.277 //l=0.243926 //layer=ply \
 //thickness=0.18 //x=72.445 //y=2.095 //x2=72.27 //y2=2.26
r534 (  117 160 ) resistor r=39.5823 //w=0.21 //l=0.173853 //layer=ply \
 //thickness=0.18 //x=72.445 //y=1.7 //x2=72.485 //y2=1.545
r535 (  117 118 ) resistor r=202.543 //w=0.094 //l=0.395 //layer=ply \
 //thickness=0.18 //x=72.445 //y=1.7 //x2=72.445 //y2=2.095
r536 (  116 160 ) resistor r=39.5823 //w=0.21 //l=0.173853 //layer=ply \
 //thickness=0.18 //x=72.445 //y=1.39 //x2=72.485 //y2=1.545
r537 (  115 159 ) resistor r=45.1352 //w=0.168 //l=0.173853 //layer=ply \
 //thickness=0.18 //x=72.445 //y=1.045 //x2=72.485 //y2=0.89
r538 (  115 116 ) resistor r=176.904 //w=0.094 //l=0.345 //layer=ply \
 //thickness=0.18 //x=72.445 //y=1.045 //x2=72.445 //y2=1.39
r539 (  114 152 ) resistor r=30.4513 //w=0.277 //l=0.243926 //layer=ply \
 //thickness=0.18 //x=70.615 //y=2.095 //x2=70.79 //y2=2.26
r540 (  113 150 ) resistor r=39.5823 //w=0.21 //l=0.173853 //layer=ply \
 //thickness=0.18 //x=70.615 //y=1.74 //x2=70.575 //y2=1.585
r541 (  113 114 ) resistor r=182.032 //w=0.094 //l=0.355 //layer=ply \
 //thickness=0.18 //x=70.615 //y=1.74 //x2=70.615 //y2=2.095
r542 (  112 150 ) resistor r=39.5823 //w=0.21 //l=0.173853 //layer=ply \
 //thickness=0.18 //x=70.615 //y=1.43 //x2=70.575 //y2=1.585
r543 (  111 149 ) resistor r=45.1352 //w=0.168 //l=0.173853 //layer=ply \
 //thickness=0.18 //x=70.615 //y=1.085 //x2=70.575 //y2=0.93
r544 (  111 112 ) resistor r=176.904 //w=0.094 //l=0.345 //layer=ply \
 //thickness=0.18 //x=70.615 //y=1.085 //x2=70.615 //y2=1.43
r545 (  108 154 ) resistor r=51.6429 //w=0.252 //l=0.34271 //layer=ply \
 //thickness=0.18 //x=70.52 //y=5.05 //x2=70.79 //y2=4.885
r546 (  106 148 ) resistor r=5.52526 //w=0.168 //l=0.115 //layer=ply \
 //thickness=0.18 //x=70.24 //y=1.585 //x2=70.125 //y2=1.585
r547 (  105 150 ) resistor r=10.701 //w=0.21 //l=0.115 //layer=ply \
 //thickness=0.18 //x=70.46 //y=1.585 //x2=70.575 //y2=1.585
r548 (  104 147 ) resistor r=5.52526 //w=0.168 //l=0.115 //layer=ply \
 //thickness=0.18 //x=70.24 //y=0.93 //x2=70.125 //y2=0.93
r549 (  103 149 ) resistor r=5.52526 //w=0.168 //l=0.115 //layer=ply \
 //thickness=0.18 //x=70.46 //y=0.93 //x2=70.575 //y2=0.93
r550 (  103 104 ) resistor r=112.809 //w=0.094 //l=0.22 //layer=ply \
 //thickness=0.18 //x=70.46 //y=0.93 //x2=70.24 //y2=0.93
r551 (  101 108 ) resistor r=22.1787 //w=0.252 //l=0.106066 //layer=ply \
 //thickness=0.18 //x=70.445 //y=4.975 //x2=70.52 //y2=5.05
r552 (  101 102 ) resistor r=148.702 //w=0.094 //l=0.29 //layer=ply \
 //thickness=0.18 //x=70.445 //y=4.975 //x2=70.155 //y2=4.975
r553 (  100 148 ) resistor r=45.1352 //w=0.168 //l=0.173853 //layer=ply \
 //thickness=0.18 //x=70.085 //y=1.43 //x2=70.125 //y2=1.585
r554 (  99 147 ) resistor r=45.1352 //w=0.168 //l=0.173853 //layer=ply \
 //thickness=0.18 //x=70.085 //y=1.085 //x2=70.125 //y2=0.93
r555 (  99 100 ) resistor r=176.904 //w=0.094 //l=0.345 //layer=ply \
 //thickness=0.18 //x=70.085 //y=1.085 //x2=70.085 //y2=1.43
r556 (  96 102 ) resistor r=26.9307 //w=0.15 //l=0.106066 //layer=ply \
 //thickness=0.18 //x=70.08 //y=5.05 //x2=70.155 //y2=4.975
r557 (  95 146 ) resistor r=45.1352 //w=0.168 //l=0.173853 //layer=ply \
 //thickness=0.18 //x=17.705 //y=1.43 //x2=17.665 //y2=1.585
r558 (  94 145 ) resistor r=45.1352 //w=0.168 //l=0.173853 //layer=ply \
 //thickness=0.18 //x=17.705 //y=1.085 //x2=17.665 //y2=0.93
r559 (  94 95 ) resistor r=176.904 //w=0.094 //l=0.345 //layer=ply \
 //thickness=0.18 //x=17.705 //y=1.085 //x2=17.705 //y2=1.43
r560 (  89 144 ) resistor r=10.701 //w=0.21 //l=0.115 //layer=ply \
 //thickness=0.18 //x=17.33 //y=1.585 //x2=17.215 //y2=1.585
r561 (  88 146 ) resistor r=5.52526 //w=0.168 //l=0.115 //layer=ply \
 //thickness=0.18 //x=17.55 //y=1.585 //x2=17.665 //y2=1.585
r562 (  87 143 ) resistor r=5.52526 //w=0.168 //l=0.115 //layer=ply \
 //thickness=0.18 //x=17.33 //y=0.93 //x2=17.215 //y2=0.93
r563 (  86 145 ) resistor r=5.52526 //w=0.168 //l=0.115 //layer=ply \
 //thickness=0.18 //x=17.55 //y=0.93 //x2=17.665 //y2=0.93
r564 (  86 87 ) resistor r=112.809 //w=0.094 //l=0.22 //layer=ply \
 //thickness=0.18 //x=17.55 //y=0.93 //x2=17.33 //y2=0.93
r565 (  85 141 ) resistor r=16.5046 //w=0.27 //l=0.135 //layer=ply \
 //thickness=0.18 //x=17.305 //y=4.97 //x2=17.17 //y2=4.97
r566 (  84 91 ) resistor r=26.9307 //w=0.15 //l=0.106066 //layer=ply \
 //thickness=0.18 //x=17.545 //y=4.97 //x2=17.62 //y2=5.045
r567 (  84 85 ) resistor r=123.064 //w=0.094 //l=0.24 //layer=ply \
 //thickness=0.18 //x=17.545 //y=4.97 //x2=17.305 //y2=4.97
r568 (  79 144 ) resistor r=39.5823 //w=0.21 //l=0.173853 //layer=ply \
 //thickness=0.18 //x=17.175 //y=1.74 //x2=17.215 //y2=1.585
r569 (  79 136 ) resistor r=182.032 //w=0.094 //l=0.355 //layer=ply \
 //thickness=0.18 //x=17.175 //y=1.74 //x2=17.175 //y2=2.095
r570 (  78 144 ) resistor r=39.5823 //w=0.21 //l=0.173853 //layer=ply \
 //thickness=0.18 //x=17.175 //y=1.43 //x2=17.215 //y2=1.585
r571 (  77 143 ) resistor r=45.1352 //w=0.168 //l=0.173853 //layer=ply \
 //thickness=0.18 //x=17.175 //y=1.085 //x2=17.215 //y2=0.93
r572 (  77 78 ) resistor r=176.904 //w=0.094 //l=0.345 //layer=ply \
 //thickness=0.18 //x=17.175 //y=1.085 //x2=17.175 //y2=1.43
r573 (  76 131 ) resistor r=592.245 //w=0.094 //l=1.155 //layer=ply \
 //thickness=0.18 //x=72.98 //y=6.205 //x2=72.98 //y2=5.05
r574 (  75 119 ) resistor r=592.245 //w=0.094 //l=1.155 //layer=ply \
 //thickness=0.18 //x=72.54 //y=6.205 //x2=72.54 //y2=5.05
r575 (  74 108 ) resistor r=592.245 //w=0.094 //l=1.155 //layer=ply \
 //thickness=0.18 //x=70.52 //y=6.205 //x2=70.52 //y2=5.05
r576 (  73 96 ) resistor r=592.245 //w=0.094 //l=1.155 //layer=ply \
 //thickness=0.18 //x=70.08 //y=6.205 //x2=70.08 //y2=5.05
r577 (  72 91 ) resistor r=592.245 //w=0.094 //l=1.155 //layer=ply \
 //thickness=0.18 //x=17.62 //y=6.2 //x2=17.62 //y2=5.045
r578 (  71 142 ) resistor r=592.245 //w=0.094 //l=1.155 //layer=ply \
 //thickness=0.18 //x=17.18 //y=6.2 //x2=17.18 //y2=5.045
r579 (  70 124 ) resistor r=56.4043 //w=0.094 //l=0.11 //layer=ply \
 //thickness=0.18 //x=72.71 //y=1.545 //x2=72.82 //y2=1.545
r580 (  70 125 ) resistor r=56.4043 //w=0.094 //l=0.11 //layer=ply \
 //thickness=0.18 //x=72.71 //y=1.545 //x2=72.6 //y2=1.545
r581 (  69 105 ) resistor r=56.4043 //w=0.094 //l=0.11 //layer=ply \
 //thickness=0.18 //x=70.35 //y=1.585 //x2=70.46 //y2=1.585
r582 (  69 106 ) resistor r=56.4043 //w=0.094 //l=0.11 //layer=ply \
 //thickness=0.18 //x=70.35 //y=1.585 //x2=70.24 //y2=1.585
r583 (  68 88 ) resistor r=56.4043 //w=0.094 //l=0.11 //layer=ply \
 //thickness=0.18 //x=17.44 //y=1.585 //x2=17.55 //y2=1.585
r584 (  68 89 ) resistor r=56.4043 //w=0.094 //l=0.11 //layer=ply \
 //thickness=0.18 //x=17.44 //y=1.585 //x2=17.33 //y2=1.585
r585 (  66 139 ) resistor r=152 //w=0.17 //l=0.17 //layer=licon //count=1 \
 //x=17.17 //y=4.88 //x2=17.17 //y2=4.88
r586 (  63 158 ) resistor r=152 //w=0.17 //l=0.17 //layer=licon //count=1 \
 //x=72.27 //y=4.885 //x2=72.27 //y2=4.885
r587 (  59 156 ) resistor r=152 //w=0.17 //l=0.17 //layer=licon //count=1 \
 //x=72.27 //y=2.26 //x2=72.27 //y2=2.26
r588 (  59 63 ) resistor r=179.679 //w=0.187 //l=2.625 //layer=li \
 //thickness=0.1 //x=72.27 //y=2.26 //x2=72.27 //y2=4.885
r589 (  56 154 ) resistor r=152 //w=0.17 //l=0.17 //layer=licon //count=1 \
 //x=70.79 //y=4.885 //x2=70.79 //y2=4.885
r590 (  54 56 ) resistor r=119.444 //w=0.187 //l=1.745 //layer=li \
 //thickness=0.1 //x=70.79 //y=3.14 //x2=70.79 //y2=4.885
r591 (  50 152 ) resistor r=152 //w=0.17 //l=0.17 //layer=licon //count=1 \
 //x=70.79 //y=2.26 //x2=70.79 //y2=2.26
r592 (  50 54 ) resistor r=60.2353 //w=0.187 //l=0.88 //layer=li \
 //thickness=0.1 //x=70.79 //y=2.26 //x2=70.79 //y2=3.14
r593 (  46 48 ) resistor r=147.508 //w=0.187 //l=2.155 //layer=li \
 //thickness=0.1 //x=21.21 //y=5.295 //x2=21.21 //y2=3.14
r594 (  45 48 ) resistor r=83.508 //w=0.187 //l=1.22 //layer=li \
 //thickness=0.1 //x=21.21 //y=1.92 //x2=21.21 //y2=3.14
r595 (  43 45 ) resistor r=7.15173 //w=0.17 //l=0.120208 //layer=li \
 //thickness=0.1 //x=21.125 //y=1.835 //x2=21.21 //y2=1.92
r596 (  43 44 ) resistor r=18.4813 //w=0.187 //l=0.27 //layer=li \
 //thickness=0.1 //x=21.125 //y=1.835 //x2=20.855 //y2=1.835
r597 (  42 67 ) resistor r=5.4201 //w=0.17 //l=0.085 //layer=li \
 //thickness=0.1 //x=20.815 //y=5.38 //x2=20.73 //y2=5.38
r598 (  41 46 ) resistor r=7.15173 //w=0.17 //l=0.120208 //layer=li \
 //thickness=0.1 //x=21.125 //y=5.38 //x2=21.21 //y2=5.295
r599 (  41 42 ) resistor r=21.2193 //w=0.187 //l=0.31 //layer=li \
 //thickness=0.1 //x=21.125 //y=5.38 //x2=20.815 //y2=5.38
r600 (  37 44 ) resistor r=7.15173 //w=0.17 //l=0.120208 //layer=li \
 //thickness=0.1 //x=20.77 //y=1.75 //x2=20.855 //y2=1.835
r601 (  37 163 ) resistor r=39.016 //w=0.187 //l=0.57 //layer=li \
 //thickness=0.1 //x=20.77 //y=1.75 //x2=20.77 //y2=1.18
r602 (  31 67 ) resistor r=1.40859 //w=0.34 //l=0.085 //layer=li \
 //thickness=0.1 //x=20.73 //y=5.465 //x2=20.73 //y2=5.38
r603 (  31 166 ) resistor r=30.1176 //w=0.187 //l=0.44 //layer=li \
 //thickness=0.1 //x=20.73 //y=5.465 //x2=20.73 //y2=5.905
r604 (  29 67 ) resistor r=5.4201 //w=0.17 //l=0.085 //layer=li \
 //thickness=0.1 //x=20.645 //y=5.38 //x2=20.73 //y2=5.38
r605 (  29 30 ) resistor r=48.5989 //w=0.187 //l=0.71 //layer=li \
 //thickness=0.1 //x=20.645 //y=5.38 //x2=19.935 //y2=5.38
r606 (  23 30 ) resistor r=7.15173 //w=0.17 //l=0.120208 //layer=li \
 //thickness=0.1 //x=19.85 //y=5.465 //x2=19.935 //y2=5.38
r607 (  23 165 ) resistor r=30.1176 //w=0.187 //l=0.44 //layer=li \
 //thickness=0.1 //x=19.85 //y=5.465 //x2=19.85 //y2=5.905
r608 (  19 135 ) resistor r=152 //w=0.17 //l=0.17 //layer=licon //count=1 \
 //x=17.14 //y=2.26 //x2=17.14 //y2=2.26
r609 (  19 22 ) resistor r=60.2353 //w=0.187 //l=0.88 //layer=li \
 //thickness=0.1 //x=17.14 //y=2.26 //x2=17.14 //y2=3.14
r610 (  17 66 ) resistor r=11.4737 //w=0.186 //l=0.172337 //layer=li \
 //thickness=0.1 //x=17.14 //y=4.715 //x2=17.155 //y2=4.88
r611 (  17 22 ) resistor r=107.807 //w=0.187 //l=1.575 //layer=li \
 //thickness=0.1 //x=17.14 //y=4.715 //x2=17.14 //y2=3.14
r612 (  16 59 ) resistor r=9.3 //w=0.17 //l=0.17 //layer=mcon //count=1 \
 //x=72.27 //y=2.26 //x2=72.27 //y2=2.26
r613 (  14 54 ) resistor r=9.3 //w=0.17 //l=0.17 //layer=mcon //count=1 \
 //x=70.79 //y=3.14 //x2=70.79 //y2=3.14
r614 (  12 50 ) resistor r=9.3 //w=0.17 //l=0.17 //layer=mcon //count=1 \
 //x=70.79 //y=2.26 //x2=70.79 //y2=2.26
r615 (  10 48 ) resistor r=9.3 //w=0.17 //l=0.17 //layer=mcon //count=1 \
 //x=21.21 //y=3.14 //x2=21.21 //y2=3.14
r616 (  8 22 ) resistor r=9.3 //w=0.17 //l=0.17 //layer=mcon //count=1 \
 //x=17.14 //y=3.14 //x2=17.14 //y2=3.14
r617 (  6 12 ) resistor r=0.0717383 //w=0.224 //l=0.115 //layer=m1 \
 //thickness=0.36 //x=70.905 //y=2.26 //x2=70.79 //y2=2.26
r618 (  5 16 ) resistor r=0.0717383 //w=0.224 //l=0.115 //layer=m1 \
 //thickness=0.36 //x=72.155 //y=2.26 //x2=72.27 //y2=2.26
r619 (  5 6 ) resistor r=1.19275 //w=0.131 //l=1.25 //layer=m1 \
 //thickness=0.36 //x=72.155 //y=2.26 //x2=70.905 //y2=2.26
r620 (  4 10 ) resistor r=0.0880901 //w=0.191 //l=0.115 //layer=m1 \
 //thickness=0.36 //x=21.325 //y=3.14 //x2=21.21 //y2=3.14
r621 (  3 14 ) resistor r=0.0717383 //w=0.224 //l=0.115 //layer=m1 \
 //thickness=0.36 //x=70.675 //y=3.14 //x2=70.79 //y2=3.14
r622 (  3 4 ) resistor r=47.0897 //w=0.131 //l=49.35 //layer=m1 \
 //thickness=0.36 //x=70.675 //y=3.14 //x2=21.325 //y2=3.14
r623 (  2 8 ) resistor r=0.0717383 //w=0.224 //l=0.115 //layer=m1 \
 //thickness=0.36 //x=17.255 //y=3.14 //x2=17.14 //y2=3.14
r624 (  1 10 ) resistor r=0.0880901 //w=0.191 //l=0.115 //layer=m1 \
 //thickness=0.36 //x=21.095 //y=3.14 //x2=21.21 //y2=3.14
r625 (  1 2 ) resistor r=3.66412 //w=0.131 //l=3.84 //layer=m1 \
 //thickness=0.36 //x=21.095 //y=3.14 //x2=17.255 //y2=3.14
ends PM_TMRDFFQX1\%noxref_23

subckt PM_TMRDFFQX1\%noxref_24 ( 1 2 13 14 15 21 27 28 35 46 47 48 49 50 )
c90 ( 50 0 ) capacitor c=0.0306574f //x=73.935 //y=5.205
c91 ( 49 0 ) capacitor c=0.0173945f //x=73.055 //y=5.205
c92 ( 47 0 ) capacitor c=0.0169278f //x=70.155 //y=5.205
c93 ( 46 0 ) capacitor c=0.0166762f //x=69.275 //y=5.205
c94 ( 45 0 ) capacitor c=0.00115294f //x=73.2 //y=7.09
c95 ( 35 0 ) capacitor c=0.0132983f //x=73.995 //y=7.09
c96 ( 28 0 ) capacitor c=0.00388794f //x=72.405 //y=7.09
c97 ( 27 0 ) capacitor c=0.00985708f //x=73.115 //y=7.09
c98 ( 21 0 ) capacitor c=0.0442221f //x=72.32 //y=5.39
c99 ( 15 0 ) capacitor c=0.0105083f //x=70.3 //y=5.475
c100 ( 14 0 ) capacitor c=0.00227812f //x=69.505 //y=5.39
c101 ( 13 0 ) capacitor c=0.0174384f //x=70.215 //y=5.39
c102 ( 2 0 ) capacitor c=0.00682032f //x=70.415 //y=5.39
c103 ( 1 0 ) capacitor c=0.0573196f //x=72.205 //y=5.39
r104 (  37 50 ) resistor r=5.81818 //w=0.187 //l=0.085 //layer=li \
 //thickness=0.1 //x=74.08 //y=7.005 //x2=74.08 //y2=6.92
r105 (  36 45 ) resistor r=5.4201 //w=0.17 //l=0.085 //layer=li \
 //thickness=0.1 //x=73.285 //y=7.09 //x2=73.2 //y2=7.09
r106 (  35 37 ) resistor r=7.15173 //w=0.17 //l=0.120208 //layer=li \
 //thickness=0.1 //x=73.995 //y=7.09 //x2=74.08 //y2=7.005
r107 (  35 36 ) resistor r=48.5989 //w=0.187 //l=0.71 //layer=li \
 //thickness=0.1 //x=73.995 //y=7.09 //x2=73.285 //y2=7.09
r108 (  29 45 ) resistor r=1.40859 //w=0.34 //l=0.085 //layer=li \
 //thickness=0.1 //x=73.2 //y=7.005 //x2=73.2 //y2=7.09
r109 (  29 49 ) resistor r=5.81818 //w=0.187 //l=0.085 //layer=li \
 //thickness=0.1 //x=73.2 //y=7.005 //x2=73.2 //y2=6.92
r110 (  27 45 ) resistor r=5.4201 //w=0.17 //l=0.085 //layer=li \
 //thickness=0.1 //x=73.115 //y=7.09 //x2=73.2 //y2=7.09
r111 (  27 28 ) resistor r=48.5989 //w=0.187 //l=0.71 //layer=li \
 //thickness=0.1 //x=73.115 //y=7.09 //x2=72.405 //y2=7.09
r112 (  21 48 ) resistor r=58.1818 //w=0.187 //l=0.85 //layer=li \
 //thickness=0.1 //x=72.32 //y=5.39 //x2=72.32 //y2=6.24
r113 (  19 28 ) resistor r=7.15173 //w=0.17 //l=0.120208 //layer=li \
 //thickness=0.1 //x=72.32 //y=7.005 //x2=72.405 //y2=7.09
r114 (  19 48 ) resistor r=5.81818 //w=0.187 //l=0.085 //layer=li \
 //thickness=0.1 //x=72.32 //y=7.005 //x2=72.32 //y2=6.92
r115 (  15 44 ) resistor r=3.57586 //w=0.17 //l=0.125 //layer=li \
 //thickness=0.1 //x=70.3 //y=5.475 //x2=70.3 //y2=5.35
r116 (  15 47 ) resistor r=52.3636 //w=0.187 //l=0.765 //layer=li \
 //thickness=0.1 //x=70.3 //y=5.475 //x2=70.3 //y2=6.24
r117 (  13 44 ) resistor r=3.57586 //w=0.17 //l=0.103078 //layer=li \
 //thickness=0.1 //x=70.215 //y=5.39 //x2=70.3 //y2=5.35
r118 (  13 14 ) resistor r=48.5989 //w=0.187 //l=0.71 //layer=li \
 //thickness=0.1 //x=70.215 //y=5.39 //x2=69.505 //y2=5.39
r119 (  7 14 ) resistor r=7.15173 //w=0.17 //l=0.120208 //layer=li \
 //thickness=0.1 //x=69.42 //y=5.475 //x2=69.505 //y2=5.39
r120 (  7 46 ) resistor r=29.0909 //w=0.187 //l=0.425 //layer=li \
 //thickness=0.1 //x=69.42 //y=5.475 //x2=69.42 //y2=5.9
r121 (  6 21 ) resistor r=9.3 //w=0.17 //l=0.17 //layer=mcon //count=1 \
 //x=72.32 //y=5.39 //x2=72.32 //y2=5.39
r122 (  4 44 ) resistor r=9.3 //w=0.17 //l=0.17 //layer=mcon //count=1 \
 //x=70.3 //y=5.39 //x2=70.3 //y2=5.39
r123 (  2 4 ) resistor r=0.0717383 //w=0.224 //l=0.115 //layer=m1 \
 //thickness=0.36 //x=70.415 //y=5.39 //x2=70.3 //y2=5.39
r124 (  1 6 ) resistor r=0.0717383 //w=0.224 //l=0.115 //layer=m1 \
 //thickness=0.36 //x=72.205 //y=5.39 //x2=72.32 //y2=5.39
r125 (  1 2 ) resistor r=1.70802 //w=0.131 //l=1.79 //layer=m1 \
 //thickness=0.36 //x=72.205 //y=5.39 //x2=70.415 //y2=5.39
ends PM_TMRDFFQX1\%noxref_24

subckt PM_TMRDFFQX1\%noxref_25 ( 1 2 3 4 5 6 29 30 43 45 46 50 52 63 64 65 66 \
 67 68 69 70 74 75 76 78 84 85 87 95 96 97 101 102 )
c240 ( 102 0 ) capacitor c=0.0167617f //x=73.495 //y=5.205
c241 ( 101 0 ) capacitor c=0.0164812f //x=72.615 //y=5.205
c242 ( 97 0 ) capacitor c=0.0110092f //x=73.49 //y=1.085
c243 ( 96 0 ) capacitor c=0.0131637f //x=70.16 //y=1.085
c244 ( 95 0 ) capacitor c=0.0131367f //x=66.83 //y=1.085
c245 ( 87 0 ) capacitor c=0.0537799f //x=75.6 //y=2.265
c246 ( 85 0 ) capacitor c=0.0435629f //x=76.24 //y=1.435
c247 ( 84 0 ) capacitor c=0.0200386f //x=76.24 //y=1.09
c248 ( 78 0 ) capacitor c=0.0152946f //x=76.085 //y=1.59
c249 ( 76 0 ) capacitor c=0.0157804f //x=76.085 //y=0.935
c250 ( 75 0 ) capacitor c=0.05065f //x=75.83 //y=4.97
c251 ( 74 0 ) capacitor c=0.0322983f //x=76.12 //y=4.97
c252 ( 70 0 ) capacitor c=0.0290017f //x=75.71 //y=2.1
c253 ( 69 0 ) capacitor c=0.0250027f //x=75.71 //y=1.745
c254 ( 68 0 ) capacitor c=0.0234316f //x=75.71 //y=1.435
c255 ( 67 0 ) capacitor c=0.0200596f //x=75.71 //y=1.09
c256 ( 66 0 ) capacitor c=0.154218f //x=76.195 //y=6.2
c257 ( 65 0 ) capacitor c=0.154243f //x=75.755 //y=6.2
c258 ( 63 0 ) capacitor c=0.00421476f //x=73.64 //y=5.39
c259 ( 52 0 ) capacitor c=0.094257f //x=75.6 //y=2.265
c260 ( 50 0 ) capacitor c=0.112965f //x=74.12 //y=4.25
c261 ( 46 0 ) capacitor c=0.00775877f //x=73.765 //y=1.825
c262 ( 45 0 ) capacitor c=0.0161066f //x=74.035 //y=1.825
c263 ( 43 0 ) capacitor c=0.0151634f //x=74.035 //y=5.39
c264 ( 30 0 ) capacitor c=0.0029383f //x=72.845 //y=5.39
c265 ( 29 0 ) capacitor c=0.0155464f //x=73.555 //y=5.39
c266 ( 6 0 ) capacitor c=0.00867855f //x=74.235 //y=4.25
c267 ( 5 0 ) capacitor c=0.0786471f //x=75.485 //y=4.25
c268 ( 4 0 ) capacitor c=0.00511584f //x=70.465 //y=1.36
c269 ( 3 0 ) capacitor c=0.0702096f //x=73.565 //y=1.36
c270 ( 2 0 ) capacitor c=0.0150174f //x=67.135 //y=1.36
c271 ( 1 0 ) capacitor c=0.0604206f //x=70.235 //y=1.36
r272 (  87 88 ) resistor r=17.5563 //w=0.302 //l=0.11 //layer=ply \
 //thickness=0.18 //x=75.6 //y=2.265 //x2=75.71 //y2=2.265
r273 (  85 94 ) resistor r=45.1352 //w=0.168 //l=0.173853 //layer=ply \
 //thickness=0.18 //x=76.24 //y=1.435 //x2=76.2 //y2=1.59
r274 (  84 93 ) resistor r=45.1352 //w=0.168 //l=0.173853 //layer=ply \
 //thickness=0.18 //x=76.24 //y=1.09 //x2=76.2 //y2=0.935
r275 (  84 85 ) resistor r=176.904 //w=0.094 //l=0.345 //layer=ply \
 //thickness=0.18 //x=76.24 //y=1.09 //x2=76.24 //y2=1.435
r276 (  79 92 ) resistor r=10.701 //w=0.21 //l=0.115 //layer=ply \
 //thickness=0.18 //x=75.865 //y=1.59 //x2=75.75 //y2=1.59
r277 (  78 94 ) resistor r=5.52526 //w=0.168 //l=0.115 //layer=ply \
 //thickness=0.18 //x=76.085 //y=1.59 //x2=76.2 //y2=1.59
r278 (  77 91 ) resistor r=5.52526 //w=0.168 //l=0.115 //layer=ply \
 //thickness=0.18 //x=75.865 //y=0.935 //x2=75.75 //y2=0.935
r279 (  76 93 ) resistor r=5.52526 //w=0.168 //l=0.115 //layer=ply \
 //thickness=0.18 //x=76.085 //y=0.935 //x2=76.2 //y2=0.935
r280 (  76 77 ) resistor r=112.809 //w=0.094 //l=0.22 //layer=ply \
 //thickness=0.18 //x=76.085 //y=0.935 //x2=75.865 //y2=0.935
r281 (  74 81 ) resistor r=26.9307 //w=0.15 //l=0.106066 //layer=ply \
 //thickness=0.18 //x=76.12 //y=4.97 //x2=76.195 //y2=5.045
r282 (  74 75 ) resistor r=148.702 //w=0.094 //l=0.29 //layer=ply \
 //thickness=0.18 //x=76.12 //y=4.97 //x2=75.83 //y2=4.97
r283 (  71 75 ) resistor r=23.403 //w=0.284 //l=0.106066 //layer=ply \
 //thickness=0.18 //x=75.755 //y=5.045 //x2=75.83 //y2=4.97
r284 (  71 90 ) resistor r=26.3063 //w=0.284 //l=0.229783 //layer=ply \
 //thickness=0.18 //x=75.755 //y=5.045 //x2=75.6 //y2=4.88
r285 (  70 88 ) resistor r=19.1248 //w=0.302 //l=0.165 //layer=ply \
 //thickness=0.18 //x=75.71 //y=2.1 //x2=75.71 //y2=2.265
r286 (  69 92 ) resistor r=39.5823 //w=0.21 //l=0.173853 //layer=ply \
 //thickness=0.18 //x=75.71 //y=1.745 //x2=75.75 //y2=1.59
r287 (  69 70 ) resistor r=182.032 //w=0.094 //l=0.355 //layer=ply \
 //thickness=0.18 //x=75.71 //y=1.745 //x2=75.71 //y2=2.1
r288 (  68 92 ) resistor r=39.5823 //w=0.21 //l=0.173853 //layer=ply \
 //thickness=0.18 //x=75.71 //y=1.435 //x2=75.75 //y2=1.59
r289 (  67 91 ) resistor r=45.1352 //w=0.168 //l=0.173853 //layer=ply \
 //thickness=0.18 //x=75.71 //y=1.09 //x2=75.75 //y2=0.935
r290 (  67 68 ) resistor r=176.904 //w=0.094 //l=0.345 //layer=ply \
 //thickness=0.18 //x=75.71 //y=1.09 //x2=75.71 //y2=1.435
r291 (  66 81 ) resistor r=592.245 //w=0.094 //l=1.155 //layer=ply \
 //thickness=0.18 //x=76.195 //y=6.2 //x2=76.195 //y2=5.045
r292 (  65 71 ) resistor r=592.245 //w=0.094 //l=1.155 //layer=ply \
 //thickness=0.18 //x=75.755 //y=6.2 //x2=75.755 //y2=5.045
r293 (  64 78 ) resistor r=56.4043 //w=0.094 //l=0.11 //layer=ply \
 //thickness=0.18 //x=75.975 //y=1.59 //x2=76.085 //y2=1.59
r294 (  64 79 ) resistor r=56.4043 //w=0.094 //l=0.11 //layer=ply \
 //thickness=0.18 //x=75.975 //y=1.59 //x2=75.865 //y2=1.59
r295 (  62 95 ) resistor r=13.3953 //w=0.172 //l=0.18 //layer=li \
 //thickness=0.1 //x=67.017 //y=1.36 //x2=67.017 //y2=1.18
r296 (  57 90 ) resistor r=152 //w=0.17 //l=0.17 //layer=licon //count=1 \
 //x=75.6 //y=4.88 //x2=75.6 //y2=4.88
r297 (  55 57 ) resistor r=43.123 //w=0.187 //l=0.63 //layer=li \
 //thickness=0.1 //x=75.6 //y=4.25 //x2=75.6 //y2=4.88
r298 (  52 87 ) resistor r=152 //w=0.17 //l=0.17 //layer=licon //count=1 \
 //x=75.6 //y=2.265 //x2=75.6 //y2=2.265
r299 (  52 55 ) resistor r=135.872 //w=0.187 //l=1.985 //layer=li \
 //thickness=0.1 //x=75.6 //y=2.265 //x2=75.6 //y2=4.25
r300 (  48 50 ) resistor r=72.2139 //w=0.187 //l=1.055 //layer=li \
 //thickness=0.1 //x=74.12 //y=5.305 //x2=74.12 //y2=4.25
r301 (  47 50 ) resistor r=160.171 //w=0.187 //l=2.34 //layer=li \
 //thickness=0.1 //x=74.12 //y=1.91 //x2=74.12 //y2=4.25
r302 (  45 47 ) resistor r=7.15173 //w=0.17 //l=0.120208 //layer=li \
 //thickness=0.1 //x=74.035 //y=1.825 //x2=74.12 //y2=1.91
r303 (  45 46 ) resistor r=18.4813 //w=0.187 //l=0.27 //layer=li \
 //thickness=0.1 //x=74.035 //y=1.825 //x2=73.765 //y2=1.825
r304 (  44 63 ) resistor r=5.4201 //w=0.17 //l=0.085 //layer=li \
 //thickness=0.1 //x=73.725 //y=5.39 //x2=73.64 //y2=5.39
r305 (  43 48 ) resistor r=7.15173 //w=0.17 //l=0.120208 //layer=li \
 //thickness=0.1 //x=74.035 //y=5.39 //x2=74.12 //y2=5.305
r306 (  43 44 ) resistor r=21.2193 //w=0.187 //l=0.31 //layer=li \
 //thickness=0.1 //x=74.035 //y=5.39 //x2=73.725 //y2=5.39
r307 (  42 97 ) resistor r=12.3209 //w=0.187 //l=0.18 //layer=li \
 //thickness=0.1 //x=73.68 //y=1.36 //x2=73.68 //y2=1.18
r308 (  37 46 ) resistor r=7.15173 //w=0.17 //l=0.120208 //layer=li \
 //thickness=0.1 //x=73.68 //y=1.74 //x2=73.765 //y2=1.825
r309 (  37 42 ) resistor r=26.0107 //w=0.187 //l=0.38 //layer=li \
 //thickness=0.1 //x=73.68 //y=1.74 //x2=73.68 //y2=1.36
r310 (  31 63 ) resistor r=1.40859 //w=0.34 //l=0.085 //layer=li \
 //thickness=0.1 //x=73.64 //y=5.475 //x2=73.64 //y2=5.39
r311 (  31 102 ) resistor r=29.0909 //w=0.187 //l=0.425 //layer=li \
 //thickness=0.1 //x=73.64 //y=5.475 //x2=73.64 //y2=5.9
r312 (  29 63 ) resistor r=5.4201 //w=0.17 //l=0.085 //layer=li \
 //thickness=0.1 //x=73.555 //y=5.39 //x2=73.64 //y2=5.39
r313 (  29 30 ) resistor r=48.5989 //w=0.187 //l=0.71 //layer=li \
 //thickness=0.1 //x=73.555 //y=5.39 //x2=72.845 //y2=5.39
r314 (  23 30 ) resistor r=7.15173 //w=0.17 //l=0.120208 //layer=li \
 //thickness=0.1 //x=72.76 //y=5.475 //x2=72.845 //y2=5.39
r315 (  23 101 ) resistor r=29.0909 //w=0.187 //l=0.425 //layer=li \
 //thickness=0.1 //x=72.76 //y=5.475 //x2=72.76 //y2=5.9
r316 (  21 96 ) resistor r=12.3209 //w=0.187 //l=0.18 //layer=li \
 //thickness=0.1 //x=70.35 //y=1.36 //x2=70.35 //y2=1.18
r317 (  16 55 ) resistor r=9.3 //w=0.17 //l=0.17 //layer=mcon //count=1 \
 //x=75.6 //y=4.25 //x2=75.6 //y2=4.25
r318 (  14 50 ) resistor r=9.3 //w=0.17 //l=0.17 //layer=mcon //count=1 \
 //x=74.12 //y=4.25 //x2=74.12 //y2=4.25
r319 (  12 42 ) resistor r=9.3 //w=0.17 //l=0.17 //layer=mcon //count=1 \
 //x=73.68 //y=1.36 //x2=73.68 //y2=1.36
r320 (  10 21 ) resistor r=9.3 //w=0.17 //l=0.17 //layer=mcon //count=1 \
 //x=70.35 //y=1.36 //x2=70.35 //y2=1.36
r321 (  8 62 ) resistor r=9.3 //w=0.17 //l=0.17 //layer=mcon //count=1 \
 //x=67.02 //y=1.36 //x2=67.02 //y2=1.36
r322 (  6 14 ) resistor r=0.0717383 //w=0.224 //l=0.115 //layer=m1 \
 //thickness=0.36 //x=74.235 //y=4.25 //x2=74.12 //y2=4.25
r323 (  5 16 ) resistor r=0.0717383 //w=0.224 //l=0.115 //layer=m1 \
 //thickness=0.36 //x=75.485 //y=4.25 //x2=75.6 //y2=4.25
r324 (  5 6 ) resistor r=1.19275 //w=0.131 //l=1.25 //layer=m1 \
 //thickness=0.36 //x=75.485 //y=4.25 //x2=74.235 //y2=4.25
r325 (  4 10 ) resistor r=0.0880901 //w=0.191 //l=0.115 //layer=m1 \
 //thickness=0.36 //x=70.465 //y=1.36 //x2=70.35 //y2=1.36
r326 (  3 12 ) resistor r=0.0717383 //w=0.224 //l=0.115 //layer=m1 \
 //thickness=0.36 //x=73.565 //y=1.36 //x2=73.68 //y2=1.36
r327 (  3 4 ) resistor r=2.95802 //w=0.131 //l=3.1 //layer=m1 //thickness=0.36 \
 //x=73.565 //y=1.36 //x2=70.465 //y2=1.36
r328 (  2 8 ) resistor r=0.0717383 //w=0.224 //l=0.115 //layer=m1 \
 //thickness=0.36 //x=67.135 //y=1.36 //x2=67.02 //y2=1.36
r329 (  1 10 ) resistor r=0.0880901 //w=0.191 //l=0.115 //layer=m1 \
 //thickness=0.36 //x=70.235 //y=1.36 //x2=70.35 //y2=1.36
r330 (  1 2 ) resistor r=2.95802 //w=0.131 //l=3.1 //layer=m1 //thickness=0.36 \
 //x=70.235 //y=1.36 //x2=67.135 //y2=1.36
ends PM_TMRDFFQX1\%noxref_25

subckt PM_TMRDFFQX1\%noxref_26 ( 1 5 9 13 17 35 )
c47 ( 35 0 ) capacitor c=0.0703709f //x=0.945 //y=0.555
c48 ( 17 0 ) capacitor c=0.0221229f //x=2.935 //y=1.77
c49 ( 13 0 ) capacitor c=0.0156939f //x=2.935 //y=0.72
c50 ( 9 0 ) capacitor c=0.00678203f //x=2.05 //y=0.805
c51 ( 5 0 ) capacitor c=0.0206412f //x=1.965 //y=1.77
c52 ( 1 0 ) capacitor c=0.0109947f //x=1.08 //y=1.685
r53 (  18 35 ) resistor r=5.4201 //w=0.17 //l=0.103078 //layer=li \
 //thickness=0.1 //x=2.135 //y=1.77 //x2=2.05 //y2=1.81
r54 (  18 35 ) resistor r=27.3797 //w=0.187 //l=0.4 //layer=li //thickness=0.1 \
 //x=2.135 //y=1.77 //x2=2.535 //y2=1.77
r55 (  17 35 ) resistor r=0.751729 //w=0.17 //l=0.085 //layer=li \
 //thickness=0.1 //x=2.935 //y=1.77 //x2=3.02 //y2=1.77
r56 (  17 35 ) resistor r=27.3797 //w=0.187 //l=0.4 //layer=li //thickness=0.1 \
 //x=2.935 //y=1.77 //x2=2.535 //y2=1.77
r57 (  14 35 ) resistor r=3.57586 //w=0.17 //l=0.103078 //layer=li \
 //thickness=0.1 //x=2.135 //y=0.72 //x2=2.05 //y2=0.68
r58 (  14 35 ) resistor r=27.3797 //w=0.187 //l=0.4 //layer=li //thickness=0.1 \
 //x=2.135 //y=0.72 //x2=2.535 //y2=0.72
r59 (  13 35 ) resistor r=0.751729 //w=0.17 //l=0.085 //layer=li \
 //thickness=0.1 //x=2.935 //y=0.72 //x2=3.02 //y2=0.72
r60 (  13 35 ) resistor r=27.3797 //w=0.187 //l=0.4 //layer=li //thickness=0.1 \
 //x=2.935 //y=0.72 //x2=2.535 //y2=0.72
r61 (  10 35 ) resistor r=1.40859 //w=0.34 //l=0.125 //layer=li \
 //thickness=0.1 //x=2.05 //y=1.685 //x2=2.05 //y2=1.81
r62 (  10 35 ) resistor r=42.0963 //w=0.187 //l=0.615 //layer=li \
 //thickness=0.1 //x=2.05 //y=1.685 //x2=2.05 //y2=1.07
r63 (  9 35 ) resistor r=3.57586 //w=0.17 //l=0.125 //layer=li //thickness=0.1 \
 //x=2.05 //y=0.805 //x2=2.05 //y2=0.68
r64 (  9 35 ) resistor r=18.139 //w=0.187 //l=0.265 //layer=li //thickness=0.1 \
 //x=2.05 //y=0.805 //x2=2.05 //y2=1.07
r65 (  6 35 ) resistor r=3.57586 //w=0.17 //l=0.103078 //layer=li \
 //thickness=0.1 //x=1.165 //y=1.77 //x2=1.08 //y2=1.81
r66 (  6 35 ) resistor r=27.3797 //w=0.187 //l=0.4 //layer=li //thickness=0.1 \
 //x=1.165 //y=1.77 //x2=1.565 //y2=1.77
r67 (  5 35 ) resistor r=5.4201 //w=0.17 //l=0.103078 //layer=li \
 //thickness=0.1 //x=1.965 //y=1.77 //x2=2.05 //y2=1.81
r68 (  5 35 ) resistor r=27.3797 //w=0.187 //l=0.4 //layer=li //thickness=0.1 \
 //x=1.965 //y=1.77 //x2=1.565 //y2=1.77
r69 (  1 35 ) resistor r=3.57586 //w=0.17 //l=0.125 //layer=li //thickness=0.1 \
 //x=1.08 //y=1.685 //x2=1.08 //y2=1.81
r70 (  1 35 ) resistor r=42.0963 //w=0.187 //l=0.615 //layer=li \
 //thickness=0.1 //x=1.08 //y=1.685 //x2=1.08 //y2=1.07
ends PM_TMRDFFQX1\%noxref_26

subckt PM_TMRDFFQX1\%noxref_27 ( 1 3 11 15 25 28 29 )
c53 ( 29 0 ) capacitor c=0.043074f //x=3.455 //y=0.555
c54 ( 28 0 ) capacitor c=0.00465142f //x=2.35 //y=1.09
c55 ( 25 0 ) capacitor c=0.00156479f //x=3.59 //y=1.175
c56 ( 15 0 ) capacitor c=0.00737666f //x=4.56 //y=0.805
c57 ( 11 0 ) capacitor c=0.0149771f //x=4.475 //y=0.72
c58 ( 3 0 ) capacitor c=0.00718386f //x=3.59 //y=0.805
c59 ( 1 0 ) capacitor c=0.0251532f //x=3.505 //y=1.175
r60 (  15 29 ) resistor r=3.57586 //w=0.17 //l=0.125 //layer=li \
 //thickness=0.1 //x=4.56 //y=0.805 //x2=4.56 //y2=0.68
r61 (  15 29 ) resistor r=18.139 //w=0.187 //l=0.265 //layer=li \
 //thickness=0.1 //x=4.56 //y=0.805 //x2=4.56 //y2=1.07
r62 (  12 29 ) resistor r=3.57586 //w=0.17 //l=0.103078 //layer=li \
 //thickness=0.1 //x=3.675 //y=0.72 //x2=3.59 //y2=0.68
r63 (  12 29 ) resistor r=27.3797 //w=0.187 //l=0.4 //layer=li //thickness=0.1 \
 //x=3.675 //y=0.72 //x2=4.075 //y2=0.72
r64 (  11 29 ) resistor r=3.57586 //w=0.17 //l=0.103078 //layer=li \
 //thickness=0.1 //x=4.475 //y=0.72 //x2=4.56 //y2=0.68
r65 (  11 29 ) resistor r=27.3797 //w=0.187 //l=0.4 //layer=li //thickness=0.1 \
 //x=4.475 //y=0.72 //x2=4.075 //y2=0.72
r66 (  7 25 ) resistor r=5.4201 //w=0.17 //l=0.085 //layer=li //thickness=0.1 \
 //x=3.59 //y=1.26 //x2=3.59 //y2=1.175
r67 (  7 29 ) resistor r=10.2674 //w=0.187 //l=0.15 //layer=li //thickness=0.1 \
 //x=3.59 //y=1.26 //x2=3.59 //y2=1.41
r68 (  4 25 ) resistor r=5.4201 //w=0.17 //l=0.085 //layer=li //thickness=0.1 \
 //x=3.59 //y=1.09 //x2=3.59 //y2=1.175
r69 (  4 29 ) resistor r=1.36898 //w=0.187 //l=0.02 //layer=li //thickness=0.1 \
 //x=3.59 //y=1.09 //x2=3.59 //y2=1.07
r70 (  3 29 ) resistor r=3.57586 //w=0.17 //l=0.125 //layer=li //thickness=0.1 \
 //x=3.59 //y=0.805 //x2=3.59 //y2=0.68
r71 (  3 29 ) resistor r=18.139 //w=0.187 //l=0.265 //layer=li //thickness=0.1 \
 //x=3.59 //y=0.805 //x2=3.59 //y2=1.07
r72 (  2 28 ) resistor r=0.751729 //w=0.17 //l=0.085 //layer=li \
 //thickness=0.1 //x=2.625 //y=1.175 //x2=2.54 //y2=1.175
r73 (  1 25 ) resistor r=1.40859 //w=0.34 //l=0.085 //layer=li //thickness=0.1 \
 //x=3.505 //y=1.175 //x2=3.59 //y2=1.175
r74 (  1 2 ) resistor r=60.2353 //w=0.187 //l=0.88 //layer=li //thickness=0.1 \
 //x=3.505 //y=1.175 //x2=2.625 //y2=1.175
ends PM_TMRDFFQX1\%noxref_27

subckt PM_TMRDFFQX1\%noxref_28 ( 1 5 9 10 13 17 29 )
c54 ( 29 0 ) capacitor c=0.0634189f //x=5.86 //y=0.545
c55 ( 17 0 ) capacitor c=0.00722223f //x=7.935 //y=0.795
c56 ( 13 0 ) capacitor c=0.0146588f //x=7.85 //y=0.71
c57 ( 10 0 ) capacitor c=0.00656209f //x=6.965 //y=1.675
c58 ( 9 0 ) capacitor c=0.006761f //x=6.965 //y=0.795
c59 ( 5 0 ) capacitor c=0.0196287f //x=6.88 //y=1.76
c60 ( 1 0 ) capacitor c=0.00828748f //x=5.995 //y=1.675
r61 (  17 29 ) resistor r=3.57586 //w=0.17 //l=0.125 //layer=li \
 //thickness=0.1 //x=7.935 //y=0.795 //x2=7.935 //y2=0.67
r62 (  17 29 ) resistor r=18.139 //w=0.187 //l=0.265 //layer=li \
 //thickness=0.1 //x=7.935 //y=0.795 //x2=7.935 //y2=1.06
r63 (  14 29 ) resistor r=3.57586 //w=0.17 //l=0.103078 //layer=li \
 //thickness=0.1 //x=7.05 //y=0.71 //x2=6.965 //y2=0.67
r64 (  14 29 ) resistor r=27.3797 //w=0.187 //l=0.4 //layer=li //thickness=0.1 \
 //x=7.05 //y=0.71 //x2=7.45 //y2=0.71
r65 (  13 29 ) resistor r=3.57586 //w=0.17 //l=0.103078 //layer=li \
 //thickness=0.1 //x=7.85 //y=0.71 //x2=7.935 //y2=0.67
r66 (  13 29 ) resistor r=27.3797 //w=0.187 //l=0.4 //layer=li //thickness=0.1 \
 //x=7.85 //y=0.71 //x2=7.45 //y2=0.71
r67 (  10 29 ) resistor r=3.57586 //w=0.17 //l=0.125 //layer=li \
 //thickness=0.1 //x=6.965 //y=1.675 //x2=6.965 //y2=1.8
r68 (  10 29 ) resistor r=42.0963 //w=0.187 //l=0.615 //layer=li \
 //thickness=0.1 //x=6.965 //y=1.675 //x2=6.965 //y2=1.06
r69 (  9 29 ) resistor r=3.57586 //w=0.17 //l=0.125 //layer=li //thickness=0.1 \
 //x=6.965 //y=0.795 //x2=6.965 //y2=0.67
r70 (  9 29 ) resistor r=18.139 //w=0.187 //l=0.265 //layer=li //thickness=0.1 \
 //x=6.965 //y=0.795 //x2=6.965 //y2=1.06
r71 (  6 29 ) resistor r=3.57586 //w=0.17 //l=0.103078 //layer=li \
 //thickness=0.1 //x=6.08 //y=1.76 //x2=5.995 //y2=1.8
r72 (  6 29 ) resistor r=27.3797 //w=0.187 //l=0.4 //layer=li //thickness=0.1 \
 //x=6.08 //y=1.76 //x2=6.48 //y2=1.76
r73 (  5 29 ) resistor r=3.57586 //w=0.17 //l=0.103078 //layer=li \
 //thickness=0.1 //x=6.88 //y=1.76 //x2=6.965 //y2=1.8
r74 (  5 29 ) resistor r=27.3797 //w=0.187 //l=0.4 //layer=li //thickness=0.1 \
 //x=6.88 //y=1.76 //x2=6.48 //y2=1.76
r75 (  1 29 ) resistor r=3.57586 //w=0.17 //l=0.125 //layer=li //thickness=0.1 \
 //x=5.995 //y=1.675 //x2=5.995 //y2=1.8
r76 (  1 29 ) resistor r=42.0963 //w=0.187 //l=0.615 //layer=li \
 //thickness=0.1 //x=5.995 //y=1.675 //x2=5.995 //y2=1.06
ends PM_TMRDFFQX1\%noxref_28

subckt PM_TMRDFFQX1\%noxref_29 ( 1 5 9 10 13 17 29 )
c52 ( 29 0 ) capacitor c=0.0634191f //x=9.19 //y=0.545
c53 ( 17 0 ) capacitor c=0.00722223f //x=11.265 //y=0.795
c54 ( 13 0 ) capacitor c=0.014662f //x=11.18 //y=0.71
c55 ( 10 0 ) capacitor c=0.00610102f //x=10.295 //y=1.675
c56 ( 9 0 ) capacitor c=0.006761f //x=10.295 //y=0.795
c57 ( 5 0 ) capacitor c=0.0181202f //x=10.21 //y=1.76
c58 ( 1 0 ) capacitor c=0.00765941f //x=9.325 //y=1.675
r59 (  17 29 ) resistor r=3.57586 //w=0.17 //l=0.125 //layer=li \
 //thickness=0.1 //x=11.265 //y=0.795 //x2=11.265 //y2=0.67
r60 (  17 29 ) resistor r=18.139 //w=0.187 //l=0.265 //layer=li \
 //thickness=0.1 //x=11.265 //y=0.795 //x2=11.265 //y2=1.06
r61 (  14 29 ) resistor r=3.57586 //w=0.17 //l=0.103078 //layer=li \
 //thickness=0.1 //x=10.38 //y=0.71 //x2=10.295 //y2=0.67
r62 (  14 29 ) resistor r=27.3797 //w=0.187 //l=0.4 //layer=li //thickness=0.1 \
 //x=10.38 //y=0.71 //x2=10.78 //y2=0.71
r63 (  13 29 ) resistor r=3.57586 //w=0.17 //l=0.103078 //layer=li \
 //thickness=0.1 //x=11.18 //y=0.71 //x2=11.265 //y2=0.67
r64 (  13 29 ) resistor r=27.3797 //w=0.187 //l=0.4 //layer=li //thickness=0.1 \
 //x=11.18 //y=0.71 //x2=10.78 //y2=0.71
r65 (  10 29 ) resistor r=3.57586 //w=0.17 //l=0.125 //layer=li \
 //thickness=0.1 //x=10.295 //y=1.675 //x2=10.295 //y2=1.8
r66 (  10 29 ) resistor r=42.0963 //w=0.187 //l=0.615 //layer=li \
 //thickness=0.1 //x=10.295 //y=1.675 //x2=10.295 //y2=1.06
r67 (  9 29 ) resistor r=3.57586 //w=0.17 //l=0.125 //layer=li //thickness=0.1 \
 //x=10.295 //y=0.795 //x2=10.295 //y2=0.67
r68 (  9 29 ) resistor r=18.139 //w=0.187 //l=0.265 //layer=li //thickness=0.1 \
 //x=10.295 //y=0.795 //x2=10.295 //y2=1.06
r69 (  6 29 ) resistor r=3.57586 //w=0.17 //l=0.103078 //layer=li \
 //thickness=0.1 //x=9.41 //y=1.76 //x2=9.325 //y2=1.8
r70 (  6 29 ) resistor r=27.3797 //w=0.187 //l=0.4 //layer=li //thickness=0.1 \
 //x=9.41 //y=1.76 //x2=9.81 //y2=1.76
r71 (  5 29 ) resistor r=3.57586 //w=0.17 //l=0.103078 //layer=li \
 //thickness=0.1 //x=10.21 //y=1.76 //x2=10.295 //y2=1.8
r72 (  5 29 ) resistor r=27.3797 //w=0.187 //l=0.4 //layer=li //thickness=0.1 \
 //x=10.21 //y=1.76 //x2=9.81 //y2=1.76
r73 (  1 29 ) resistor r=3.57586 //w=0.17 //l=0.125 //layer=li //thickness=0.1 \
 //x=9.325 //y=1.675 //x2=9.325 //y2=1.8
r74 (  1 29 ) resistor r=42.0963 //w=0.187 //l=0.615 //layer=li \
 //thickness=0.1 //x=9.325 //y=1.675 //x2=9.325 //y2=1.06
ends PM_TMRDFFQX1\%noxref_29

subckt PM_TMRDFFQX1\%noxref_30 ( 1 5 9 10 13 17 29 )
c52 ( 29 0 ) capacitor c=0.0634191f //x=12.52 //y=0.545
c53 ( 17 0 ) capacitor c=0.00722223f //x=14.595 //y=0.795
c54 ( 13 0 ) capacitor c=0.014662f //x=14.51 //y=0.71
c55 ( 10 0 ) capacitor c=0.00610102f //x=13.625 //y=1.675
c56 ( 9 0 ) capacitor c=0.006761f //x=13.625 //y=0.795
c57 ( 5 0 ) capacitor c=0.0181202f //x=13.54 //y=1.76
c58 ( 1 0 ) capacitor c=0.00765941f //x=12.655 //y=1.675
r59 (  17 29 ) resistor r=3.57586 //w=0.17 //l=0.125 //layer=li \
 //thickness=0.1 //x=14.595 //y=0.795 //x2=14.595 //y2=0.67
r60 (  17 29 ) resistor r=18.139 //w=0.187 //l=0.265 //layer=li \
 //thickness=0.1 //x=14.595 //y=0.795 //x2=14.595 //y2=1.06
r61 (  14 29 ) resistor r=3.57586 //w=0.17 //l=0.103078 //layer=li \
 //thickness=0.1 //x=13.71 //y=0.71 //x2=13.625 //y2=0.67
r62 (  14 29 ) resistor r=27.3797 //w=0.187 //l=0.4 //layer=li //thickness=0.1 \
 //x=13.71 //y=0.71 //x2=14.11 //y2=0.71
r63 (  13 29 ) resistor r=3.57586 //w=0.17 //l=0.103078 //layer=li \
 //thickness=0.1 //x=14.51 //y=0.71 //x2=14.595 //y2=0.67
r64 (  13 29 ) resistor r=27.3797 //w=0.187 //l=0.4 //layer=li //thickness=0.1 \
 //x=14.51 //y=0.71 //x2=14.11 //y2=0.71
r65 (  10 29 ) resistor r=3.57586 //w=0.17 //l=0.125 //layer=li \
 //thickness=0.1 //x=13.625 //y=1.675 //x2=13.625 //y2=1.8
r66 (  10 29 ) resistor r=42.0963 //w=0.187 //l=0.615 //layer=li \
 //thickness=0.1 //x=13.625 //y=1.675 //x2=13.625 //y2=1.06
r67 (  9 29 ) resistor r=3.57586 //w=0.17 //l=0.125 //layer=li //thickness=0.1 \
 //x=13.625 //y=0.795 //x2=13.625 //y2=0.67
r68 (  9 29 ) resistor r=18.139 //w=0.187 //l=0.265 //layer=li //thickness=0.1 \
 //x=13.625 //y=0.795 //x2=13.625 //y2=1.06
r69 (  6 29 ) resistor r=3.57586 //w=0.17 //l=0.103078 //layer=li \
 //thickness=0.1 //x=12.74 //y=1.76 //x2=12.655 //y2=1.8
r70 (  6 29 ) resistor r=27.3797 //w=0.187 //l=0.4 //layer=li //thickness=0.1 \
 //x=12.74 //y=1.76 //x2=13.14 //y2=1.76
r71 (  5 29 ) resistor r=3.57586 //w=0.17 //l=0.103078 //layer=li \
 //thickness=0.1 //x=13.54 //y=1.76 //x2=13.625 //y2=1.8
r72 (  5 29 ) resistor r=27.3797 //w=0.187 //l=0.4 //layer=li //thickness=0.1 \
 //x=13.54 //y=1.76 //x2=13.14 //y2=1.76
r73 (  1 29 ) resistor r=3.57586 //w=0.17 //l=0.125 //layer=li //thickness=0.1 \
 //x=12.655 //y=1.675 //x2=12.655 //y2=1.8
r74 (  1 29 ) resistor r=42.0963 //w=0.187 //l=0.615 //layer=li \
 //thickness=0.1 //x=12.655 //y=1.675 //x2=12.655 //y2=1.06
ends PM_TMRDFFQX1\%noxref_30

subckt PM_TMRDFFQX1\%noxref_31 ( 1 5 9 10 13 17 29 )
c52 ( 29 0 ) capacitor c=0.0634191f //x=15.85 //y=0.545
c53 ( 17 0 ) capacitor c=0.00722223f //x=17.925 //y=0.795
c54 ( 13 0 ) capacitor c=0.014662f //x=17.84 //y=0.71
c55 ( 10 0 ) capacitor c=0.00610102f //x=16.955 //y=1.675
c56 ( 9 0 ) capacitor c=0.006761f //x=16.955 //y=0.795
c57 ( 5 0 ) capacitor c=0.0181202f //x=16.87 //y=1.76
c58 ( 1 0 ) capacitor c=0.00765941f //x=15.985 //y=1.675
r59 (  17 29 ) resistor r=3.57586 //w=0.17 //l=0.125 //layer=li \
 //thickness=0.1 //x=17.925 //y=0.795 //x2=17.925 //y2=0.67
r60 (  17 29 ) resistor r=18.139 //w=0.187 //l=0.265 //layer=li \
 //thickness=0.1 //x=17.925 //y=0.795 //x2=17.925 //y2=1.06
r61 (  14 29 ) resistor r=3.57586 //w=0.17 //l=0.103078 //layer=li \
 //thickness=0.1 //x=17.04 //y=0.71 //x2=16.955 //y2=0.67
r62 (  14 29 ) resistor r=27.3797 //w=0.187 //l=0.4 //layer=li //thickness=0.1 \
 //x=17.04 //y=0.71 //x2=17.44 //y2=0.71
r63 (  13 29 ) resistor r=3.57586 //w=0.17 //l=0.103078 //layer=li \
 //thickness=0.1 //x=17.84 //y=0.71 //x2=17.925 //y2=0.67
r64 (  13 29 ) resistor r=27.3797 //w=0.187 //l=0.4 //layer=li //thickness=0.1 \
 //x=17.84 //y=0.71 //x2=17.44 //y2=0.71
r65 (  10 29 ) resistor r=3.57586 //w=0.17 //l=0.125 //layer=li \
 //thickness=0.1 //x=16.955 //y=1.675 //x2=16.955 //y2=1.8
r66 (  10 29 ) resistor r=42.0963 //w=0.187 //l=0.615 //layer=li \
 //thickness=0.1 //x=16.955 //y=1.675 //x2=16.955 //y2=1.06
r67 (  9 29 ) resistor r=3.57586 //w=0.17 //l=0.125 //layer=li //thickness=0.1 \
 //x=16.955 //y=0.795 //x2=16.955 //y2=0.67
r68 (  9 29 ) resistor r=18.139 //w=0.187 //l=0.265 //layer=li //thickness=0.1 \
 //x=16.955 //y=0.795 //x2=16.955 //y2=1.06
r69 (  6 29 ) resistor r=3.57586 //w=0.17 //l=0.103078 //layer=li \
 //thickness=0.1 //x=16.07 //y=1.76 //x2=15.985 //y2=1.8
r70 (  6 29 ) resistor r=27.3797 //w=0.187 //l=0.4 //layer=li //thickness=0.1 \
 //x=16.07 //y=1.76 //x2=16.47 //y2=1.76
r71 (  5 29 ) resistor r=3.57586 //w=0.17 //l=0.103078 //layer=li \
 //thickness=0.1 //x=16.87 //y=1.76 //x2=16.955 //y2=1.8
r72 (  5 29 ) resistor r=27.3797 //w=0.187 //l=0.4 //layer=li //thickness=0.1 \
 //x=16.87 //y=1.76 //x2=16.47 //y2=1.76
r73 (  1 29 ) resistor r=3.57586 //w=0.17 //l=0.125 //layer=li //thickness=0.1 \
 //x=15.985 //y=1.675 //x2=15.985 //y2=1.8
r74 (  1 29 ) resistor r=42.0963 //w=0.187 //l=0.615 //layer=li \
 //thickness=0.1 //x=15.985 //y=1.675 //x2=15.985 //y2=1.06
ends PM_TMRDFFQX1\%noxref_31

subckt PM_TMRDFFQX1\%noxref_32 ( 1 5 9 10 13 17 29 )
c52 ( 29 0 ) capacitor c=0.0634191f //x=19.18 //y=0.545
c53 ( 17 0 ) capacitor c=0.0072343f //x=21.255 //y=0.795
c54 ( 13 0 ) capacitor c=0.014662f //x=21.17 //y=0.71
c55 ( 10 0 ) capacitor c=0.00610102f //x=20.285 //y=1.675
c56 ( 9 0 ) capacitor c=0.006761f //x=20.285 //y=0.795
c57 ( 5 0 ) capacitor c=0.0181202f //x=20.2 //y=1.76
c58 ( 1 0 ) capacitor c=0.00765941f //x=19.315 //y=1.675
r59 (  17 29 ) resistor r=3.57586 //w=0.17 //l=0.125 //layer=li \
 //thickness=0.1 //x=21.255 //y=0.795 //x2=21.255 //y2=0.67
r60 (  17 29 ) resistor r=18.139 //w=0.187 //l=0.265 //layer=li \
 //thickness=0.1 //x=21.255 //y=0.795 //x2=21.255 //y2=1.06
r61 (  14 29 ) resistor r=3.57586 //w=0.17 //l=0.103078 //layer=li \
 //thickness=0.1 //x=20.37 //y=0.71 //x2=20.285 //y2=0.67
r62 (  14 29 ) resistor r=27.3797 //w=0.187 //l=0.4 //layer=li //thickness=0.1 \
 //x=20.37 //y=0.71 //x2=20.77 //y2=0.71
r63 (  13 29 ) resistor r=3.57586 //w=0.17 //l=0.103078 //layer=li \
 //thickness=0.1 //x=21.17 //y=0.71 //x2=21.255 //y2=0.67
r64 (  13 29 ) resistor r=27.3797 //w=0.187 //l=0.4 //layer=li //thickness=0.1 \
 //x=21.17 //y=0.71 //x2=20.77 //y2=0.71
r65 (  10 29 ) resistor r=3.57586 //w=0.17 //l=0.125 //layer=li \
 //thickness=0.1 //x=20.285 //y=1.675 //x2=20.285 //y2=1.8
r66 (  10 29 ) resistor r=42.0963 //w=0.187 //l=0.615 //layer=li \
 //thickness=0.1 //x=20.285 //y=1.675 //x2=20.285 //y2=1.06
r67 (  9 29 ) resistor r=3.57586 //w=0.17 //l=0.125 //layer=li //thickness=0.1 \
 //x=20.285 //y=0.795 //x2=20.285 //y2=0.67
r68 (  9 29 ) resistor r=18.139 //w=0.187 //l=0.265 //layer=li //thickness=0.1 \
 //x=20.285 //y=0.795 //x2=20.285 //y2=1.06
r69 (  6 29 ) resistor r=3.57586 //w=0.17 //l=0.103078 //layer=li \
 //thickness=0.1 //x=19.4 //y=1.76 //x2=19.315 //y2=1.8
r70 (  6 29 ) resistor r=27.3797 //w=0.187 //l=0.4 //layer=li //thickness=0.1 \
 //x=19.4 //y=1.76 //x2=19.8 //y2=1.76
r71 (  5 29 ) resistor r=3.57586 //w=0.17 //l=0.103078 //layer=li \
 //thickness=0.1 //x=20.2 //y=1.76 //x2=20.285 //y2=1.8
r72 (  5 29 ) resistor r=27.3797 //w=0.187 //l=0.4 //layer=li //thickness=0.1 \
 //x=20.2 //y=1.76 //x2=19.8 //y2=1.76
r73 (  1 29 ) resistor r=3.57586 //w=0.17 //l=0.125 //layer=li //thickness=0.1 \
 //x=19.315 //y=1.675 //x2=19.315 //y2=1.8
r74 (  1 29 ) resistor r=42.0963 //w=0.187 //l=0.615 //layer=li \
 //thickness=0.1 //x=19.315 //y=1.675 //x2=19.315 //y2=1.06
ends PM_TMRDFFQX1\%noxref_32

subckt PM_TMRDFFQX1\%noxref_33 ( 1 5 9 13 17 35 )
c50 ( 35 0 ) capacitor c=0.0679963f //x=22.405 //y=0.555
c51 ( 17 0 ) capacitor c=0.018806f //x=24.395 //y=1.77
c52 ( 13 0 ) capacitor c=0.0155484f //x=24.395 //y=0.72
c53 ( 9 0 ) capacitor c=0.00678203f //x=23.51 //y=0.805
c54 ( 5 0 ) capacitor c=0.0170872f //x=23.425 //y=1.77
c55 ( 1 0 ) capacitor c=0.00729042f //x=22.54 //y=1.685
r56 (  18 35 ) resistor r=5.4201 //w=0.17 //l=0.103078 //layer=li \
 //thickness=0.1 //x=23.595 //y=1.77 //x2=23.51 //y2=1.81
r57 (  18 35 ) resistor r=27.3797 //w=0.187 //l=0.4 //layer=li //thickness=0.1 \
 //x=23.595 //y=1.77 //x2=23.995 //y2=1.77
r58 (  17 35 ) resistor r=0.751729 //w=0.17 //l=0.085 //layer=li \
 //thickness=0.1 //x=24.395 //y=1.77 //x2=24.48 //y2=1.77
r59 (  17 35 ) resistor r=27.3797 //w=0.187 //l=0.4 //layer=li //thickness=0.1 \
 //x=24.395 //y=1.77 //x2=23.995 //y2=1.77
r60 (  14 35 ) resistor r=3.57586 //w=0.17 //l=0.103078 //layer=li \
 //thickness=0.1 //x=23.595 //y=0.72 //x2=23.51 //y2=0.68
r61 (  14 35 ) resistor r=27.3797 //w=0.187 //l=0.4 //layer=li //thickness=0.1 \
 //x=23.595 //y=0.72 //x2=23.995 //y2=0.72
r62 (  13 35 ) resistor r=0.751729 //w=0.17 //l=0.085 //layer=li \
 //thickness=0.1 //x=24.395 //y=0.72 //x2=24.48 //y2=0.72
r63 (  13 35 ) resistor r=27.3797 //w=0.187 //l=0.4 //layer=li //thickness=0.1 \
 //x=24.395 //y=0.72 //x2=23.995 //y2=0.72
r64 (  10 35 ) resistor r=1.40859 //w=0.34 //l=0.125 //layer=li \
 //thickness=0.1 //x=23.51 //y=1.685 //x2=23.51 //y2=1.81
r65 (  10 35 ) resistor r=42.0963 //w=0.187 //l=0.615 //layer=li \
 //thickness=0.1 //x=23.51 //y=1.685 //x2=23.51 //y2=1.07
r66 (  9 35 ) resistor r=3.57586 //w=0.17 //l=0.125 //layer=li //thickness=0.1 \
 //x=23.51 //y=0.805 //x2=23.51 //y2=0.68
r67 (  9 35 ) resistor r=18.139 //w=0.187 //l=0.265 //layer=li //thickness=0.1 \
 //x=23.51 //y=0.805 //x2=23.51 //y2=1.07
r68 (  6 35 ) resistor r=3.57586 //w=0.17 //l=0.103078 //layer=li \
 //thickness=0.1 //x=22.625 //y=1.77 //x2=22.54 //y2=1.81
r69 (  6 35 ) resistor r=27.3797 //w=0.187 //l=0.4 //layer=li //thickness=0.1 \
 //x=22.625 //y=1.77 //x2=23.025 //y2=1.77
r70 (  5 35 ) resistor r=5.4201 //w=0.17 //l=0.103078 //layer=li \
 //thickness=0.1 //x=23.425 //y=1.77 //x2=23.51 //y2=1.81
r71 (  5 35 ) resistor r=27.3797 //w=0.187 //l=0.4 //layer=li //thickness=0.1 \
 //x=23.425 //y=1.77 //x2=23.025 //y2=1.77
r72 (  1 35 ) resistor r=3.57586 //w=0.17 //l=0.125 //layer=li //thickness=0.1 \
 //x=22.54 //y=1.685 //x2=22.54 //y2=1.81
r73 (  1 35 ) resistor r=42.0963 //w=0.187 //l=0.615 //layer=li \
 //thickness=0.1 //x=22.54 //y=1.685 //x2=22.54 //y2=1.07
ends PM_TMRDFFQX1\%noxref_33

subckt PM_TMRDFFQX1\%noxref_34 ( 1 3 11 15 25 28 29 )
c53 ( 29 0 ) capacitor c=0.0418028f //x=24.915 //y=0.555
c54 ( 28 0 ) capacitor c=0.00460056f //x=23.81 //y=1.09
c55 ( 25 0 ) capacitor c=0.00156479f //x=25.05 //y=1.175
c56 ( 15 0 ) capacitor c=0.00737666f //x=26.02 //y=0.805
c57 ( 11 0 ) capacitor c=0.0145763f //x=25.935 //y=0.72
c58 ( 3 0 ) capacitor c=0.00718386f //x=25.05 //y=0.805
c59 ( 1 0 ) capacitor c=0.022715f //x=24.965 //y=1.175
r60 (  15 29 ) resistor r=3.57586 //w=0.17 //l=0.125 //layer=li \
 //thickness=0.1 //x=26.02 //y=0.805 //x2=26.02 //y2=0.68
r61 (  15 29 ) resistor r=18.139 //w=0.187 //l=0.265 //layer=li \
 //thickness=0.1 //x=26.02 //y=0.805 //x2=26.02 //y2=1.07
r62 (  12 29 ) resistor r=3.57586 //w=0.17 //l=0.103078 //layer=li \
 //thickness=0.1 //x=25.135 //y=0.72 //x2=25.05 //y2=0.68
r63 (  12 29 ) resistor r=27.3797 //w=0.187 //l=0.4 //layer=li //thickness=0.1 \
 //x=25.135 //y=0.72 //x2=25.535 //y2=0.72
r64 (  11 29 ) resistor r=3.57586 //w=0.17 //l=0.103078 //layer=li \
 //thickness=0.1 //x=25.935 //y=0.72 //x2=26.02 //y2=0.68
r65 (  11 29 ) resistor r=27.3797 //w=0.187 //l=0.4 //layer=li //thickness=0.1 \
 //x=25.935 //y=0.72 //x2=25.535 //y2=0.72
r66 (  7 25 ) resistor r=5.4201 //w=0.17 //l=0.085 //layer=li //thickness=0.1 \
 //x=25.05 //y=1.26 //x2=25.05 //y2=1.175
r67 (  7 29 ) resistor r=10.2674 //w=0.187 //l=0.15 //layer=li //thickness=0.1 \
 //x=25.05 //y=1.26 //x2=25.05 //y2=1.41
r68 (  4 25 ) resistor r=5.4201 //w=0.17 //l=0.085 //layer=li //thickness=0.1 \
 //x=25.05 //y=1.09 //x2=25.05 //y2=1.175
r69 (  4 29 ) resistor r=1.36898 //w=0.187 //l=0.02 //layer=li //thickness=0.1 \
 //x=25.05 //y=1.09 //x2=25.05 //y2=1.07
r70 (  3 29 ) resistor r=3.57586 //w=0.17 //l=0.125 //layer=li //thickness=0.1 \
 //x=25.05 //y=0.805 //x2=25.05 //y2=0.68
r71 (  3 29 ) resistor r=18.139 //w=0.187 //l=0.265 //layer=li //thickness=0.1 \
 //x=25.05 //y=0.805 //x2=25.05 //y2=1.07
r72 (  2 28 ) resistor r=0.751729 //w=0.17 //l=0.085 //layer=li \
 //thickness=0.1 //x=24.085 //y=1.175 //x2=24 //y2=1.175
r73 (  1 25 ) resistor r=1.40859 //w=0.34 //l=0.085 //layer=li //thickness=0.1 \
 //x=24.965 //y=1.175 //x2=25.05 //y2=1.175
r74 (  1 2 ) resistor r=60.2353 //w=0.187 //l=0.88 //layer=li //thickness=0.1 \
 //x=24.965 //y=1.175 //x2=24.085 //y2=1.175
ends PM_TMRDFFQX1\%noxref_34

subckt PM_TMRDFFQX1\%noxref_35 ( 1 5 9 10 13 17 29 )
c54 ( 29 0 ) capacitor c=0.0634189f //x=27.32 //y=0.545
c55 ( 17 0 ) capacitor c=0.00722223f //x=29.395 //y=0.795
c56 ( 13 0 ) capacitor c=0.0146588f //x=29.31 //y=0.71
c57 ( 10 0 ) capacitor c=0.00610027f //x=28.425 //y=1.675
c58 ( 9 0 ) capacitor c=0.006761f //x=28.425 //y=0.795
c59 ( 5 0 ) capacitor c=0.0181202f //x=28.34 //y=1.76
c60 ( 1 0 ) capacitor c=0.00765941f //x=27.455 //y=1.675
r61 (  17 29 ) resistor r=3.57586 //w=0.17 //l=0.125 //layer=li \
 //thickness=0.1 //x=29.395 //y=0.795 //x2=29.395 //y2=0.67
r62 (  17 29 ) resistor r=18.139 //w=0.187 //l=0.265 //layer=li \
 //thickness=0.1 //x=29.395 //y=0.795 //x2=29.395 //y2=1.06
r63 (  14 29 ) resistor r=3.57586 //w=0.17 //l=0.103078 //layer=li \
 //thickness=0.1 //x=28.51 //y=0.71 //x2=28.425 //y2=0.67
r64 (  14 29 ) resistor r=27.3797 //w=0.187 //l=0.4 //layer=li //thickness=0.1 \
 //x=28.51 //y=0.71 //x2=28.91 //y2=0.71
r65 (  13 29 ) resistor r=3.57586 //w=0.17 //l=0.103078 //layer=li \
 //thickness=0.1 //x=29.31 //y=0.71 //x2=29.395 //y2=0.67
r66 (  13 29 ) resistor r=27.3797 //w=0.187 //l=0.4 //layer=li //thickness=0.1 \
 //x=29.31 //y=0.71 //x2=28.91 //y2=0.71
r67 (  10 29 ) resistor r=3.57586 //w=0.17 //l=0.125 //layer=li \
 //thickness=0.1 //x=28.425 //y=1.675 //x2=28.425 //y2=1.8
r68 (  10 29 ) resistor r=42.0963 //w=0.187 //l=0.615 //layer=li \
 //thickness=0.1 //x=28.425 //y=1.675 //x2=28.425 //y2=1.06
r69 (  9 29 ) resistor r=3.57586 //w=0.17 //l=0.125 //layer=li //thickness=0.1 \
 //x=28.425 //y=0.795 //x2=28.425 //y2=0.67
r70 (  9 29 ) resistor r=18.139 //w=0.187 //l=0.265 //layer=li //thickness=0.1 \
 //x=28.425 //y=0.795 //x2=28.425 //y2=1.06
r71 (  6 29 ) resistor r=3.57586 //w=0.17 //l=0.103078 //layer=li \
 //thickness=0.1 //x=27.54 //y=1.76 //x2=27.455 //y2=1.8
r72 (  6 29 ) resistor r=27.3797 //w=0.187 //l=0.4 //layer=li //thickness=0.1 \
 //x=27.54 //y=1.76 //x2=27.94 //y2=1.76
r73 (  5 29 ) resistor r=3.57586 //w=0.17 //l=0.103078 //layer=li \
 //thickness=0.1 //x=28.34 //y=1.76 //x2=28.425 //y2=1.8
r74 (  5 29 ) resistor r=27.3797 //w=0.187 //l=0.4 //layer=li //thickness=0.1 \
 //x=28.34 //y=1.76 //x2=27.94 //y2=1.76
r75 (  1 29 ) resistor r=3.57586 //w=0.17 //l=0.125 //layer=li //thickness=0.1 \
 //x=27.455 //y=1.675 //x2=27.455 //y2=1.8
r76 (  1 29 ) resistor r=42.0963 //w=0.187 //l=0.615 //layer=li \
 //thickness=0.1 //x=27.455 //y=1.675 //x2=27.455 //y2=1.06
ends PM_TMRDFFQX1\%noxref_35

subckt PM_TMRDFFQX1\%noxref_36 ( 1 5 9 10 13 17 29 )
c52 ( 29 0 ) capacitor c=0.0634191f //x=30.65 //y=0.545
c53 ( 17 0 ) capacitor c=0.00722223f //x=32.725 //y=0.795
c54 ( 13 0 ) capacitor c=0.014662f //x=32.64 //y=0.71
c55 ( 10 0 ) capacitor c=0.00610102f //x=31.755 //y=1.675
c56 ( 9 0 ) capacitor c=0.006761f //x=31.755 //y=0.795
c57 ( 5 0 ) capacitor c=0.0181202f //x=31.67 //y=1.76
c58 ( 1 0 ) capacitor c=0.00765941f //x=30.785 //y=1.675
r59 (  17 29 ) resistor r=3.57586 //w=0.17 //l=0.125 //layer=li \
 //thickness=0.1 //x=32.725 //y=0.795 //x2=32.725 //y2=0.67
r60 (  17 29 ) resistor r=18.139 //w=0.187 //l=0.265 //layer=li \
 //thickness=0.1 //x=32.725 //y=0.795 //x2=32.725 //y2=1.06
r61 (  14 29 ) resistor r=3.57586 //w=0.17 //l=0.103078 //layer=li \
 //thickness=0.1 //x=31.84 //y=0.71 //x2=31.755 //y2=0.67
r62 (  14 29 ) resistor r=27.3797 //w=0.187 //l=0.4 //layer=li //thickness=0.1 \
 //x=31.84 //y=0.71 //x2=32.24 //y2=0.71
r63 (  13 29 ) resistor r=3.57586 //w=0.17 //l=0.103078 //layer=li \
 //thickness=0.1 //x=32.64 //y=0.71 //x2=32.725 //y2=0.67
r64 (  13 29 ) resistor r=27.3797 //w=0.187 //l=0.4 //layer=li //thickness=0.1 \
 //x=32.64 //y=0.71 //x2=32.24 //y2=0.71
r65 (  10 29 ) resistor r=3.57586 //w=0.17 //l=0.125 //layer=li \
 //thickness=0.1 //x=31.755 //y=1.675 //x2=31.755 //y2=1.8
r66 (  10 29 ) resistor r=42.0963 //w=0.187 //l=0.615 //layer=li \
 //thickness=0.1 //x=31.755 //y=1.675 //x2=31.755 //y2=1.06
r67 (  9 29 ) resistor r=3.57586 //w=0.17 //l=0.125 //layer=li //thickness=0.1 \
 //x=31.755 //y=0.795 //x2=31.755 //y2=0.67
r68 (  9 29 ) resistor r=18.139 //w=0.187 //l=0.265 //layer=li //thickness=0.1 \
 //x=31.755 //y=0.795 //x2=31.755 //y2=1.06
r69 (  6 29 ) resistor r=3.57586 //w=0.17 //l=0.103078 //layer=li \
 //thickness=0.1 //x=30.87 //y=1.76 //x2=30.785 //y2=1.8
r70 (  6 29 ) resistor r=27.3797 //w=0.187 //l=0.4 //layer=li //thickness=0.1 \
 //x=30.87 //y=1.76 //x2=31.27 //y2=1.76
r71 (  5 29 ) resistor r=3.57586 //w=0.17 //l=0.103078 //layer=li \
 //thickness=0.1 //x=31.67 //y=1.76 //x2=31.755 //y2=1.8
r72 (  5 29 ) resistor r=27.3797 //w=0.187 //l=0.4 //layer=li //thickness=0.1 \
 //x=31.67 //y=1.76 //x2=31.27 //y2=1.76
r73 (  1 29 ) resistor r=3.57586 //w=0.17 //l=0.125 //layer=li //thickness=0.1 \
 //x=30.785 //y=1.675 //x2=30.785 //y2=1.8
r74 (  1 29 ) resistor r=42.0963 //w=0.187 //l=0.615 //layer=li \
 //thickness=0.1 //x=30.785 //y=1.675 //x2=30.785 //y2=1.06
ends PM_TMRDFFQX1\%noxref_36

subckt PM_TMRDFFQX1\%noxref_37 ( 1 5 9 10 13 17 29 )
c52 ( 29 0 ) capacitor c=0.0634191f //x=33.98 //y=0.545
c53 ( 17 0 ) capacitor c=0.00722223f //x=36.055 //y=0.795
c54 ( 13 0 ) capacitor c=0.014662f //x=35.97 //y=0.71
c55 ( 10 0 ) capacitor c=0.00610102f //x=35.085 //y=1.675
c56 ( 9 0 ) capacitor c=0.006761f //x=35.085 //y=0.795
c57 ( 5 0 ) capacitor c=0.0181202f //x=35 //y=1.76
c58 ( 1 0 ) capacitor c=0.00765941f //x=34.115 //y=1.675
r59 (  17 29 ) resistor r=3.57586 //w=0.17 //l=0.125 //layer=li \
 //thickness=0.1 //x=36.055 //y=0.795 //x2=36.055 //y2=0.67
r60 (  17 29 ) resistor r=18.139 //w=0.187 //l=0.265 //layer=li \
 //thickness=0.1 //x=36.055 //y=0.795 //x2=36.055 //y2=1.06
r61 (  14 29 ) resistor r=3.57586 //w=0.17 //l=0.103078 //layer=li \
 //thickness=0.1 //x=35.17 //y=0.71 //x2=35.085 //y2=0.67
r62 (  14 29 ) resistor r=27.3797 //w=0.187 //l=0.4 //layer=li //thickness=0.1 \
 //x=35.17 //y=0.71 //x2=35.57 //y2=0.71
r63 (  13 29 ) resistor r=3.57586 //w=0.17 //l=0.103078 //layer=li \
 //thickness=0.1 //x=35.97 //y=0.71 //x2=36.055 //y2=0.67
r64 (  13 29 ) resistor r=27.3797 //w=0.187 //l=0.4 //layer=li //thickness=0.1 \
 //x=35.97 //y=0.71 //x2=35.57 //y2=0.71
r65 (  10 29 ) resistor r=3.57586 //w=0.17 //l=0.125 //layer=li \
 //thickness=0.1 //x=35.085 //y=1.675 //x2=35.085 //y2=1.8
r66 (  10 29 ) resistor r=42.0963 //w=0.187 //l=0.615 //layer=li \
 //thickness=0.1 //x=35.085 //y=1.675 //x2=35.085 //y2=1.06
r67 (  9 29 ) resistor r=3.57586 //w=0.17 //l=0.125 //layer=li //thickness=0.1 \
 //x=35.085 //y=0.795 //x2=35.085 //y2=0.67
r68 (  9 29 ) resistor r=18.139 //w=0.187 //l=0.265 //layer=li //thickness=0.1 \
 //x=35.085 //y=0.795 //x2=35.085 //y2=1.06
r69 (  6 29 ) resistor r=3.57586 //w=0.17 //l=0.103078 //layer=li \
 //thickness=0.1 //x=34.2 //y=1.76 //x2=34.115 //y2=1.8
r70 (  6 29 ) resistor r=27.3797 //w=0.187 //l=0.4 //layer=li //thickness=0.1 \
 //x=34.2 //y=1.76 //x2=34.6 //y2=1.76
r71 (  5 29 ) resistor r=3.57586 //w=0.17 //l=0.103078 //layer=li \
 //thickness=0.1 //x=35 //y=1.76 //x2=35.085 //y2=1.8
r72 (  5 29 ) resistor r=27.3797 //w=0.187 //l=0.4 //layer=li //thickness=0.1 \
 //x=35 //y=1.76 //x2=34.6 //y2=1.76
r73 (  1 29 ) resistor r=3.57586 //w=0.17 //l=0.125 //layer=li //thickness=0.1 \
 //x=34.115 //y=1.675 //x2=34.115 //y2=1.8
r74 (  1 29 ) resistor r=42.0963 //w=0.187 //l=0.615 //layer=li \
 //thickness=0.1 //x=34.115 //y=1.675 //x2=34.115 //y2=1.06
ends PM_TMRDFFQX1\%noxref_37

subckt PM_TMRDFFQX1\%noxref_38 ( 1 5 9 10 13 17 29 )
c54 ( 29 0 ) capacitor c=0.0632684f //x=37.31 //y=0.545
c55 ( 17 0 ) capacitor c=0.00722223f //x=39.385 //y=0.795
c56 ( 13 0 ) capacitor c=0.0145042f //x=39.3 //y=0.71
c57 ( 10 0 ) capacitor c=0.00605993f //x=38.415 //y=1.675
c58 ( 9 0 ) capacitor c=0.006761f //x=38.415 //y=0.795
c59 ( 5 0 ) capacitor c=0.0181202f //x=38.33 //y=1.76
c60 ( 1 0 ) capacitor c=0.00765941f //x=37.445 //y=1.675
r61 (  17 29 ) resistor r=3.57586 //w=0.17 //l=0.125 //layer=li \
 //thickness=0.1 //x=39.385 //y=0.795 //x2=39.385 //y2=0.67
r62 (  17 29 ) resistor r=18.139 //w=0.187 //l=0.265 //layer=li \
 //thickness=0.1 //x=39.385 //y=0.795 //x2=39.385 //y2=1.06
r63 (  14 29 ) resistor r=3.57586 //w=0.17 //l=0.103078 //layer=li \
 //thickness=0.1 //x=38.5 //y=0.71 //x2=38.415 //y2=0.67
r64 (  14 29 ) resistor r=27.3797 //w=0.187 //l=0.4 //layer=li //thickness=0.1 \
 //x=38.5 //y=0.71 //x2=38.9 //y2=0.71
r65 (  13 29 ) resistor r=3.57586 //w=0.17 //l=0.103078 //layer=li \
 //thickness=0.1 //x=39.3 //y=0.71 //x2=39.385 //y2=0.67
r66 (  13 29 ) resistor r=27.3797 //w=0.187 //l=0.4 //layer=li //thickness=0.1 \
 //x=39.3 //y=0.71 //x2=38.9 //y2=0.71
r67 (  10 29 ) resistor r=3.57586 //w=0.17 //l=0.125 //layer=li \
 //thickness=0.1 //x=38.415 //y=1.675 //x2=38.415 //y2=1.8
r68 (  10 29 ) resistor r=42.0963 //w=0.187 //l=0.615 //layer=li \
 //thickness=0.1 //x=38.415 //y=1.675 //x2=38.415 //y2=1.06
r69 (  9 29 ) resistor r=3.57586 //w=0.17 //l=0.125 //layer=li //thickness=0.1 \
 //x=38.415 //y=0.795 //x2=38.415 //y2=0.67
r70 (  9 29 ) resistor r=18.139 //w=0.187 //l=0.265 //layer=li //thickness=0.1 \
 //x=38.415 //y=0.795 //x2=38.415 //y2=1.06
r71 (  6 29 ) resistor r=3.57586 //w=0.17 //l=0.103078 //layer=li \
 //thickness=0.1 //x=37.53 //y=1.76 //x2=37.445 //y2=1.8
r72 (  6 29 ) resistor r=27.3797 //w=0.187 //l=0.4 //layer=li //thickness=0.1 \
 //x=37.53 //y=1.76 //x2=37.93 //y2=1.76
r73 (  5 29 ) resistor r=3.57586 //w=0.17 //l=0.103078 //layer=li \
 //thickness=0.1 //x=38.33 //y=1.76 //x2=38.415 //y2=1.8
r74 (  5 29 ) resistor r=27.3797 //w=0.187 //l=0.4 //layer=li //thickness=0.1 \
 //x=38.33 //y=1.76 //x2=37.93 //y2=1.76
r75 (  1 29 ) resistor r=3.57586 //w=0.17 //l=0.125 //layer=li //thickness=0.1 \
 //x=37.445 //y=1.675 //x2=37.445 //y2=1.8
r76 (  1 29 ) resistor r=42.0963 //w=0.187 //l=0.615 //layer=li \
 //thickness=0.1 //x=37.445 //y=1.675 //x2=37.445 //y2=1.06
ends PM_TMRDFFQX1\%noxref_38

subckt PM_TMRDFFQX1\%noxref_39 ( 1 5 9 10 13 17 29 )
c54 ( 29 0 ) capacitor c=0.0632577f //x=40.64 //y=0.545
c55 ( 17 0 ) capacitor c=0.0072343f //x=42.715 //y=0.795
c56 ( 13 0 ) capacitor c=0.0145076f //x=42.63 //y=0.71
c57 ( 10 0 ) capacitor c=0.00582081f //x=41.745 //y=1.675
c58 ( 9 0 ) capacitor c=0.006761f //x=41.745 //y=0.795
c59 ( 5 0 ) capacitor c=0.0173046f //x=41.66 //y=1.76
c60 ( 1 0 ) capacitor c=0.00733328f //x=40.775 //y=1.675
r61 (  17 29 ) resistor r=3.57586 //w=0.17 //l=0.125 //layer=li \
 //thickness=0.1 //x=42.715 //y=0.795 //x2=42.715 //y2=0.67
r62 (  17 29 ) resistor r=18.139 //w=0.187 //l=0.265 //layer=li \
 //thickness=0.1 //x=42.715 //y=0.795 //x2=42.715 //y2=1.06
r63 (  14 29 ) resistor r=3.57586 //w=0.17 //l=0.103078 //layer=li \
 //thickness=0.1 //x=41.83 //y=0.71 //x2=41.745 //y2=0.67
r64 (  14 29 ) resistor r=27.3797 //w=0.187 //l=0.4 //layer=li //thickness=0.1 \
 //x=41.83 //y=0.71 //x2=42.23 //y2=0.71
r65 (  13 29 ) resistor r=3.57586 //w=0.17 //l=0.103078 //layer=li \
 //thickness=0.1 //x=42.63 //y=0.71 //x2=42.715 //y2=0.67
r66 (  13 29 ) resistor r=27.3797 //w=0.187 //l=0.4 //layer=li //thickness=0.1 \
 //x=42.63 //y=0.71 //x2=42.23 //y2=0.71
r67 (  10 29 ) resistor r=3.57586 //w=0.17 //l=0.125 //layer=li \
 //thickness=0.1 //x=41.745 //y=1.675 //x2=41.745 //y2=1.8
r68 (  10 29 ) resistor r=42.0963 //w=0.187 //l=0.615 //layer=li \
 //thickness=0.1 //x=41.745 //y=1.675 //x2=41.745 //y2=1.06
r69 (  9 29 ) resistor r=3.57586 //w=0.17 //l=0.125 //layer=li //thickness=0.1 \
 //x=41.745 //y=0.795 //x2=41.745 //y2=0.67
r70 (  9 29 ) resistor r=18.139 //w=0.187 //l=0.265 //layer=li //thickness=0.1 \
 //x=41.745 //y=0.795 //x2=41.745 //y2=1.06
r71 (  6 29 ) resistor r=3.57586 //w=0.17 //l=0.103078 //layer=li \
 //thickness=0.1 //x=40.86 //y=1.76 //x2=40.775 //y2=1.8
r72 (  6 29 ) resistor r=27.3797 //w=0.187 //l=0.4 //layer=li //thickness=0.1 \
 //x=40.86 //y=1.76 //x2=41.26 //y2=1.76
r73 (  5 29 ) resistor r=3.57586 //w=0.17 //l=0.103078 //layer=li \
 //thickness=0.1 //x=41.66 //y=1.76 //x2=41.745 //y2=1.8
r74 (  5 29 ) resistor r=27.3797 //w=0.187 //l=0.4 //layer=li //thickness=0.1 \
 //x=41.66 //y=1.76 //x2=41.26 //y2=1.76
r75 (  1 29 ) resistor r=3.57586 //w=0.17 //l=0.125 //layer=li //thickness=0.1 \
 //x=40.775 //y=1.675 //x2=40.775 //y2=1.8
r76 (  1 29 ) resistor r=42.0963 //w=0.187 //l=0.615 //layer=li \
 //thickness=0.1 //x=40.775 //y=1.675 //x2=40.775 //y2=1.06
ends PM_TMRDFFQX1\%noxref_39

subckt PM_TMRDFFQX1\%noxref_40 ( 1 5 9 13 17 35 )
c50 ( 35 0 ) capacitor c=0.0673029f //x=43.865 //y=0.555
c51 ( 17 0 ) capacitor c=0.0178317f //x=45.855 //y=1.77
c52 ( 13 0 ) capacitor c=0.0154936f //x=45.855 //y=0.72
c53 ( 9 0 ) capacitor c=0.00678203f //x=44.97 //y=0.805
c54 ( 5 0 ) capacitor c=0.0164013f //x=44.885 //y=1.77
c55 ( 1 0 ) capacitor c=0.00696517f //x=44 //y=1.685
r56 (  18 35 ) resistor r=5.4201 //w=0.17 //l=0.103078 //layer=li \
 //thickness=0.1 //x=45.055 //y=1.77 //x2=44.97 //y2=1.81
r57 (  18 35 ) resistor r=27.3797 //w=0.187 //l=0.4 //layer=li //thickness=0.1 \
 //x=45.055 //y=1.77 //x2=45.455 //y2=1.77
r58 (  17 35 ) resistor r=0.751729 //w=0.17 //l=0.085 //layer=li \
 //thickness=0.1 //x=45.855 //y=1.77 //x2=45.94 //y2=1.77
r59 (  17 35 ) resistor r=27.3797 //w=0.187 //l=0.4 //layer=li //thickness=0.1 \
 //x=45.855 //y=1.77 //x2=45.455 //y2=1.77
r60 (  14 35 ) resistor r=3.57586 //w=0.17 //l=0.103078 //layer=li \
 //thickness=0.1 //x=45.055 //y=0.72 //x2=44.97 //y2=0.68
r61 (  14 35 ) resistor r=27.3797 //w=0.187 //l=0.4 //layer=li //thickness=0.1 \
 //x=45.055 //y=0.72 //x2=45.455 //y2=0.72
r62 (  13 35 ) resistor r=0.751729 //w=0.17 //l=0.085 //layer=li \
 //thickness=0.1 //x=45.855 //y=0.72 //x2=45.94 //y2=0.72
r63 (  13 35 ) resistor r=27.3797 //w=0.187 //l=0.4 //layer=li //thickness=0.1 \
 //x=45.855 //y=0.72 //x2=45.455 //y2=0.72
r64 (  10 35 ) resistor r=1.40859 //w=0.34 //l=0.125 //layer=li \
 //thickness=0.1 //x=44.97 //y=1.685 //x2=44.97 //y2=1.81
r65 (  10 35 ) resistor r=42.0963 //w=0.187 //l=0.615 //layer=li \
 //thickness=0.1 //x=44.97 //y=1.685 //x2=44.97 //y2=1.07
r66 (  9 35 ) resistor r=3.57586 //w=0.17 //l=0.125 //layer=li //thickness=0.1 \
 //x=44.97 //y=0.805 //x2=44.97 //y2=0.68
r67 (  9 35 ) resistor r=18.139 //w=0.187 //l=0.265 //layer=li //thickness=0.1 \
 //x=44.97 //y=0.805 //x2=44.97 //y2=1.07
r68 (  6 35 ) resistor r=3.57586 //w=0.17 //l=0.103078 //layer=li \
 //thickness=0.1 //x=44.085 //y=1.77 //x2=44 //y2=1.81
r69 (  6 35 ) resistor r=27.3797 //w=0.187 //l=0.4 //layer=li //thickness=0.1 \
 //x=44.085 //y=1.77 //x2=44.485 //y2=1.77
r70 (  5 35 ) resistor r=5.4201 //w=0.17 //l=0.103078 //layer=li \
 //thickness=0.1 //x=44.885 //y=1.77 //x2=44.97 //y2=1.81
r71 (  5 35 ) resistor r=27.3797 //w=0.187 //l=0.4 //layer=li //thickness=0.1 \
 //x=44.885 //y=1.77 //x2=44.485 //y2=1.77
r72 (  1 35 ) resistor r=3.57586 //w=0.17 //l=0.125 //layer=li //thickness=0.1 \
 //x=44 //y=1.685 //x2=44 //y2=1.81
r73 (  1 35 ) resistor r=42.0963 //w=0.187 //l=0.615 //layer=li \
 //thickness=0.1 //x=44 //y=1.685 //x2=44 //y2=1.07
ends PM_TMRDFFQX1\%noxref_40

subckt PM_TMRDFFQX1\%noxref_41 ( 1 3 11 15 25 28 29 )
c53 ( 29 0 ) capacitor c=0.0413887f //x=46.375 //y=0.555
c54 ( 28 0 ) capacitor c=0.0045748f //x=45.27 //y=1.09
c55 ( 25 0 ) capacitor c=0.00156479f //x=46.51 //y=1.175
c56 ( 15 0 ) capacitor c=0.00737666f //x=47.48 //y=0.805
c57 ( 11 0 ) capacitor c=0.0144274f //x=47.395 //y=0.72
c58 ( 3 0 ) capacitor c=0.00718386f //x=46.51 //y=0.805
c59 ( 1 0 ) capacitor c=0.0218888f //x=46.425 //y=1.175
r60 (  15 29 ) resistor r=3.57586 //w=0.17 //l=0.125 //layer=li \
 //thickness=0.1 //x=47.48 //y=0.805 //x2=47.48 //y2=0.68
r61 (  15 29 ) resistor r=18.139 //w=0.187 //l=0.265 //layer=li \
 //thickness=0.1 //x=47.48 //y=0.805 //x2=47.48 //y2=1.07
r62 (  12 29 ) resistor r=3.57586 //w=0.17 //l=0.103078 //layer=li \
 //thickness=0.1 //x=46.595 //y=0.72 //x2=46.51 //y2=0.68
r63 (  12 29 ) resistor r=27.3797 //w=0.187 //l=0.4 //layer=li //thickness=0.1 \
 //x=46.595 //y=0.72 //x2=46.995 //y2=0.72
r64 (  11 29 ) resistor r=3.57586 //w=0.17 //l=0.103078 //layer=li \
 //thickness=0.1 //x=47.395 //y=0.72 //x2=47.48 //y2=0.68
r65 (  11 29 ) resistor r=27.3797 //w=0.187 //l=0.4 //layer=li //thickness=0.1 \
 //x=47.395 //y=0.72 //x2=46.995 //y2=0.72
r66 (  7 25 ) resistor r=5.4201 //w=0.17 //l=0.085 //layer=li //thickness=0.1 \
 //x=46.51 //y=1.26 //x2=46.51 //y2=1.175
r67 (  7 29 ) resistor r=10.2674 //w=0.187 //l=0.15 //layer=li //thickness=0.1 \
 //x=46.51 //y=1.26 //x2=46.51 //y2=1.41
r68 (  4 25 ) resistor r=5.4201 //w=0.17 //l=0.085 //layer=li //thickness=0.1 \
 //x=46.51 //y=1.09 //x2=46.51 //y2=1.175
r69 (  4 29 ) resistor r=1.36898 //w=0.187 //l=0.02 //layer=li //thickness=0.1 \
 //x=46.51 //y=1.09 //x2=46.51 //y2=1.07
r70 (  3 29 ) resistor r=3.57586 //w=0.17 //l=0.125 //layer=li //thickness=0.1 \
 //x=46.51 //y=0.805 //x2=46.51 //y2=0.68
r71 (  3 29 ) resistor r=18.139 //w=0.187 //l=0.265 //layer=li //thickness=0.1 \
 //x=46.51 //y=0.805 //x2=46.51 //y2=1.07
r72 (  2 28 ) resistor r=0.751729 //w=0.17 //l=0.085 //layer=li \
 //thickness=0.1 //x=45.545 //y=1.175 //x2=45.46 //y2=1.175
r73 (  1 25 ) resistor r=1.40859 //w=0.34 //l=0.085 //layer=li //thickness=0.1 \
 //x=46.425 //y=1.175 //x2=46.51 //y2=1.175
r74 (  1 2 ) resistor r=60.2353 //w=0.187 //l=0.88 //layer=li //thickness=0.1 \
 //x=46.425 //y=1.175 //x2=45.545 //y2=1.175
ends PM_TMRDFFQX1\%noxref_41

subckt PM_TMRDFFQX1\%noxref_42 ( 1 5 9 10 13 17 29 )
c52 ( 29 0 ) capacitor c=0.0632682f //x=48.78 //y=0.545
c53 ( 17 0 ) capacitor c=0.00722223f //x=50.855 //y=0.795
c54 ( 13 0 ) capacitor c=0.0145084f //x=50.77 //y=0.71
c55 ( 10 0 ) capacitor c=0.00582081f //x=49.885 //y=1.675
c56 ( 9 0 ) capacitor c=0.006761f //x=49.885 //y=0.795
c57 ( 5 0 ) capacitor c=0.0173046f //x=49.8 //y=1.76
c58 ( 1 0 ) capacitor c=0.00733328f //x=48.915 //y=1.675
r59 (  17 29 ) resistor r=3.57586 //w=0.17 //l=0.125 //layer=li \
 //thickness=0.1 //x=50.855 //y=0.795 //x2=50.855 //y2=0.67
r60 (  17 29 ) resistor r=18.139 //w=0.187 //l=0.265 //layer=li \
 //thickness=0.1 //x=50.855 //y=0.795 //x2=50.855 //y2=1.06
r61 (  14 29 ) resistor r=3.57586 //w=0.17 //l=0.103078 //layer=li \
 //thickness=0.1 //x=49.97 //y=0.71 //x2=49.885 //y2=0.67
r62 (  14 29 ) resistor r=27.3797 //w=0.187 //l=0.4 //layer=li //thickness=0.1 \
 //x=49.97 //y=0.71 //x2=50.37 //y2=0.71
r63 (  13 29 ) resistor r=3.57586 //w=0.17 //l=0.103078 //layer=li \
 //thickness=0.1 //x=50.77 //y=0.71 //x2=50.855 //y2=0.67
r64 (  13 29 ) resistor r=27.3797 //w=0.187 //l=0.4 //layer=li //thickness=0.1 \
 //x=50.77 //y=0.71 //x2=50.37 //y2=0.71
r65 (  10 29 ) resistor r=3.57586 //w=0.17 //l=0.125 //layer=li \
 //thickness=0.1 //x=49.885 //y=1.675 //x2=49.885 //y2=1.8
r66 (  10 29 ) resistor r=42.0963 //w=0.187 //l=0.615 //layer=li \
 //thickness=0.1 //x=49.885 //y=1.675 //x2=49.885 //y2=1.06
r67 (  9 29 ) resistor r=3.57586 //w=0.17 //l=0.125 //layer=li //thickness=0.1 \
 //x=49.885 //y=0.795 //x2=49.885 //y2=0.67
r68 (  9 29 ) resistor r=18.139 //w=0.187 //l=0.265 //layer=li //thickness=0.1 \
 //x=49.885 //y=0.795 //x2=49.885 //y2=1.06
r69 (  6 29 ) resistor r=3.57586 //w=0.17 //l=0.103078 //layer=li \
 //thickness=0.1 //x=49 //y=1.76 //x2=48.915 //y2=1.8
r70 (  6 29 ) resistor r=27.3797 //w=0.187 //l=0.4 //layer=li //thickness=0.1 \
 //x=49 //y=1.76 //x2=49.4 //y2=1.76
r71 (  5 29 ) resistor r=3.57586 //w=0.17 //l=0.103078 //layer=li \
 //thickness=0.1 //x=49.8 //y=1.76 //x2=49.885 //y2=1.8
r72 (  5 29 ) resistor r=27.3797 //w=0.187 //l=0.4 //layer=li //thickness=0.1 \
 //x=49.8 //y=1.76 //x2=49.4 //y2=1.76
r73 (  1 29 ) resistor r=3.57586 //w=0.17 //l=0.125 //layer=li //thickness=0.1 \
 //x=48.915 //y=1.675 //x2=48.915 //y2=1.8
r74 (  1 29 ) resistor r=42.0963 //w=0.187 //l=0.615 //layer=li \
 //thickness=0.1 //x=48.915 //y=1.675 //x2=48.915 //y2=1.06
ends PM_TMRDFFQX1\%noxref_42

subckt PM_TMRDFFQX1\%noxref_43 ( 1 5 9 10 13 17 29 )
c52 ( 29 0 ) capacitor c=0.0632684f //x=52.11 //y=0.545
c53 ( 17 0 ) capacitor c=0.00722223f //x=54.185 //y=0.795
c54 ( 13 0 ) capacitor c=0.0145084f //x=54.1 //y=0.71
c55 ( 10 0 ) capacitor c=0.00582081f //x=53.215 //y=1.675
c56 ( 9 0 ) capacitor c=0.006761f //x=53.215 //y=0.795
c57 ( 5 0 ) capacitor c=0.0173046f //x=53.13 //y=1.76
c58 ( 1 0 ) capacitor c=0.00733328f //x=52.245 //y=1.675
r59 (  17 29 ) resistor r=3.57586 //w=0.17 //l=0.125 //layer=li \
 //thickness=0.1 //x=54.185 //y=0.795 //x2=54.185 //y2=0.67
r60 (  17 29 ) resistor r=18.139 //w=0.187 //l=0.265 //layer=li \
 //thickness=0.1 //x=54.185 //y=0.795 //x2=54.185 //y2=1.06
r61 (  14 29 ) resistor r=3.57586 //w=0.17 //l=0.103078 //layer=li \
 //thickness=0.1 //x=53.3 //y=0.71 //x2=53.215 //y2=0.67
r62 (  14 29 ) resistor r=27.3797 //w=0.187 //l=0.4 //layer=li //thickness=0.1 \
 //x=53.3 //y=0.71 //x2=53.7 //y2=0.71
r63 (  13 29 ) resistor r=3.57586 //w=0.17 //l=0.103078 //layer=li \
 //thickness=0.1 //x=54.1 //y=0.71 //x2=54.185 //y2=0.67
r64 (  13 29 ) resistor r=27.3797 //w=0.187 //l=0.4 //layer=li //thickness=0.1 \
 //x=54.1 //y=0.71 //x2=53.7 //y2=0.71
r65 (  10 29 ) resistor r=3.57586 //w=0.17 //l=0.125 //layer=li \
 //thickness=0.1 //x=53.215 //y=1.675 //x2=53.215 //y2=1.8
r66 (  10 29 ) resistor r=42.0963 //w=0.187 //l=0.615 //layer=li \
 //thickness=0.1 //x=53.215 //y=1.675 //x2=53.215 //y2=1.06
r67 (  9 29 ) resistor r=3.57586 //w=0.17 //l=0.125 //layer=li //thickness=0.1 \
 //x=53.215 //y=0.795 //x2=53.215 //y2=0.67
r68 (  9 29 ) resistor r=18.139 //w=0.187 //l=0.265 //layer=li //thickness=0.1 \
 //x=53.215 //y=0.795 //x2=53.215 //y2=1.06
r69 (  6 29 ) resistor r=3.57586 //w=0.17 //l=0.103078 //layer=li \
 //thickness=0.1 //x=52.33 //y=1.76 //x2=52.245 //y2=1.8
r70 (  6 29 ) resistor r=27.3797 //w=0.187 //l=0.4 //layer=li //thickness=0.1 \
 //x=52.33 //y=1.76 //x2=52.73 //y2=1.76
r71 (  5 29 ) resistor r=3.57586 //w=0.17 //l=0.103078 //layer=li \
 //thickness=0.1 //x=53.13 //y=1.76 //x2=53.215 //y2=1.8
r72 (  5 29 ) resistor r=27.3797 //w=0.187 //l=0.4 //layer=li //thickness=0.1 \
 //x=53.13 //y=1.76 //x2=52.73 //y2=1.76
r73 (  1 29 ) resistor r=3.57586 //w=0.17 //l=0.125 //layer=li //thickness=0.1 \
 //x=52.245 //y=1.675 //x2=52.245 //y2=1.8
r74 (  1 29 ) resistor r=42.0963 //w=0.187 //l=0.615 //layer=li \
 //thickness=0.1 //x=52.245 //y=1.675 //x2=52.245 //y2=1.06
ends PM_TMRDFFQX1\%noxref_43

subckt PM_TMRDFFQX1\%noxref_44 ( 1 5 9 10 13 17 29 )
c52 ( 29 0 ) capacitor c=0.0632684f //x=55.44 //y=0.545
c53 ( 17 0 ) capacitor c=0.00722223f //x=57.515 //y=0.795
c54 ( 13 0 ) capacitor c=0.0145084f //x=57.43 //y=0.71
c55 ( 10 0 ) capacitor c=0.00582081f //x=56.545 //y=1.675
c56 ( 9 0 ) capacitor c=0.006761f //x=56.545 //y=0.795
c57 ( 5 0 ) capacitor c=0.0173046f //x=56.46 //y=1.76
c58 ( 1 0 ) capacitor c=0.00733328f //x=55.575 //y=1.675
r59 (  17 29 ) resistor r=3.57586 //w=0.17 //l=0.125 //layer=li \
 //thickness=0.1 //x=57.515 //y=0.795 //x2=57.515 //y2=0.67
r60 (  17 29 ) resistor r=18.139 //w=0.187 //l=0.265 //layer=li \
 //thickness=0.1 //x=57.515 //y=0.795 //x2=57.515 //y2=1.06
r61 (  14 29 ) resistor r=3.57586 //w=0.17 //l=0.103078 //layer=li \
 //thickness=0.1 //x=56.63 //y=0.71 //x2=56.545 //y2=0.67
r62 (  14 29 ) resistor r=27.3797 //w=0.187 //l=0.4 //layer=li //thickness=0.1 \
 //x=56.63 //y=0.71 //x2=57.03 //y2=0.71
r63 (  13 29 ) resistor r=3.57586 //w=0.17 //l=0.103078 //layer=li \
 //thickness=0.1 //x=57.43 //y=0.71 //x2=57.515 //y2=0.67
r64 (  13 29 ) resistor r=27.3797 //w=0.187 //l=0.4 //layer=li //thickness=0.1 \
 //x=57.43 //y=0.71 //x2=57.03 //y2=0.71
r65 (  10 29 ) resistor r=3.57586 //w=0.17 //l=0.125 //layer=li \
 //thickness=0.1 //x=56.545 //y=1.675 //x2=56.545 //y2=1.8
r66 (  10 29 ) resistor r=42.0963 //w=0.187 //l=0.615 //layer=li \
 //thickness=0.1 //x=56.545 //y=1.675 //x2=56.545 //y2=1.06
r67 (  9 29 ) resistor r=3.57586 //w=0.17 //l=0.125 //layer=li //thickness=0.1 \
 //x=56.545 //y=0.795 //x2=56.545 //y2=0.67
r68 (  9 29 ) resistor r=18.139 //w=0.187 //l=0.265 //layer=li //thickness=0.1 \
 //x=56.545 //y=0.795 //x2=56.545 //y2=1.06
r69 (  6 29 ) resistor r=3.57586 //w=0.17 //l=0.103078 //layer=li \
 //thickness=0.1 //x=55.66 //y=1.76 //x2=55.575 //y2=1.8
r70 (  6 29 ) resistor r=27.3797 //w=0.187 //l=0.4 //layer=li //thickness=0.1 \
 //x=55.66 //y=1.76 //x2=56.06 //y2=1.76
r71 (  5 29 ) resistor r=3.57586 //w=0.17 //l=0.103078 //layer=li \
 //thickness=0.1 //x=56.46 //y=1.76 //x2=56.545 //y2=1.8
r72 (  5 29 ) resistor r=27.3797 //w=0.187 //l=0.4 //layer=li //thickness=0.1 \
 //x=56.46 //y=1.76 //x2=56.06 //y2=1.76
r73 (  1 29 ) resistor r=3.57586 //w=0.17 //l=0.125 //layer=li //thickness=0.1 \
 //x=55.575 //y=1.675 //x2=55.575 //y2=1.8
r74 (  1 29 ) resistor r=42.0963 //w=0.187 //l=0.615 //layer=li \
 //thickness=0.1 //x=55.575 //y=1.675 //x2=55.575 //y2=1.06
ends PM_TMRDFFQX1\%noxref_44

subckt PM_TMRDFFQX1\%noxref_45 ( 1 5 9 10 13 17 29 )
c52 ( 29 0 ) capacitor c=0.0632684f //x=58.77 //y=0.545
c53 ( 17 0 ) capacitor c=0.00722223f //x=60.845 //y=0.795
c54 ( 13 0 ) capacitor c=0.0145084f //x=60.76 //y=0.71
c55 ( 10 0 ) capacitor c=0.00582081f //x=59.875 //y=1.675
c56 ( 9 0 ) capacitor c=0.006761f //x=59.875 //y=0.795
c57 ( 5 0 ) capacitor c=0.0173046f //x=59.79 //y=1.76
c58 ( 1 0 ) capacitor c=0.00733328f //x=58.905 //y=1.675
r59 (  17 29 ) resistor r=3.57586 //w=0.17 //l=0.125 //layer=li \
 //thickness=0.1 //x=60.845 //y=0.795 //x2=60.845 //y2=0.67
r60 (  17 29 ) resistor r=18.139 //w=0.187 //l=0.265 //layer=li \
 //thickness=0.1 //x=60.845 //y=0.795 //x2=60.845 //y2=1.06
r61 (  14 29 ) resistor r=3.57586 //w=0.17 //l=0.103078 //layer=li \
 //thickness=0.1 //x=59.96 //y=0.71 //x2=59.875 //y2=0.67
r62 (  14 29 ) resistor r=27.3797 //w=0.187 //l=0.4 //layer=li //thickness=0.1 \
 //x=59.96 //y=0.71 //x2=60.36 //y2=0.71
r63 (  13 29 ) resistor r=3.57586 //w=0.17 //l=0.103078 //layer=li \
 //thickness=0.1 //x=60.76 //y=0.71 //x2=60.845 //y2=0.67
r64 (  13 29 ) resistor r=27.3797 //w=0.187 //l=0.4 //layer=li //thickness=0.1 \
 //x=60.76 //y=0.71 //x2=60.36 //y2=0.71
r65 (  10 29 ) resistor r=3.57586 //w=0.17 //l=0.125 //layer=li \
 //thickness=0.1 //x=59.875 //y=1.675 //x2=59.875 //y2=1.8
r66 (  10 29 ) resistor r=42.0963 //w=0.187 //l=0.615 //layer=li \
 //thickness=0.1 //x=59.875 //y=1.675 //x2=59.875 //y2=1.06
r67 (  9 29 ) resistor r=3.57586 //w=0.17 //l=0.125 //layer=li //thickness=0.1 \
 //x=59.875 //y=0.795 //x2=59.875 //y2=0.67
r68 (  9 29 ) resistor r=18.139 //w=0.187 //l=0.265 //layer=li //thickness=0.1 \
 //x=59.875 //y=0.795 //x2=59.875 //y2=1.06
r69 (  6 29 ) resistor r=3.57586 //w=0.17 //l=0.103078 //layer=li \
 //thickness=0.1 //x=58.99 //y=1.76 //x2=58.905 //y2=1.8
r70 (  6 29 ) resistor r=27.3797 //w=0.187 //l=0.4 //layer=li //thickness=0.1 \
 //x=58.99 //y=1.76 //x2=59.39 //y2=1.76
r71 (  5 29 ) resistor r=3.57586 //w=0.17 //l=0.103078 //layer=li \
 //thickness=0.1 //x=59.79 //y=1.76 //x2=59.875 //y2=1.8
r72 (  5 29 ) resistor r=27.3797 //w=0.187 //l=0.4 //layer=li //thickness=0.1 \
 //x=59.79 //y=1.76 //x2=59.39 //y2=1.76
r73 (  1 29 ) resistor r=3.57586 //w=0.17 //l=0.125 //layer=li //thickness=0.1 \
 //x=58.905 //y=1.675 //x2=58.905 //y2=1.8
r74 (  1 29 ) resistor r=42.0963 //w=0.187 //l=0.615 //layer=li \
 //thickness=0.1 //x=58.905 //y=1.675 //x2=58.905 //y2=1.06
ends PM_TMRDFFQX1\%noxref_45

subckt PM_TMRDFFQX1\%noxref_46 ( 1 5 9 10 13 17 29 )
c52 ( 29 0 ) capacitor c=0.0631409f //x=62.1 //y=0.545
c53 ( 17 0 ) capacitor c=0.00722223f //x=64.175 //y=0.795
c54 ( 13 0 ) capacitor c=0.0145084f //x=64.09 //y=0.71
c55 ( 10 0 ) capacitor c=0.00582081f //x=63.205 //y=1.675
c56 ( 9 0 ) capacitor c=0.006761f //x=63.205 //y=0.795
c57 ( 5 0 ) capacitor c=0.0173046f //x=63.12 //y=1.76
c58 ( 1 0 ) capacitor c=0.00733328f //x=62.235 //y=1.675
r59 (  17 29 ) resistor r=3.57586 //w=0.17 //l=0.125 //layer=li \
 //thickness=0.1 //x=64.175 //y=0.795 //x2=64.175 //y2=0.67
r60 (  17 29 ) resistor r=18.139 //w=0.187 //l=0.265 //layer=li \
 //thickness=0.1 //x=64.175 //y=0.795 //x2=64.175 //y2=1.06
r61 (  14 29 ) resistor r=3.57586 //w=0.17 //l=0.103078 //layer=li \
 //thickness=0.1 //x=63.29 //y=0.71 //x2=63.205 //y2=0.67
r62 (  14 29 ) resistor r=27.3797 //w=0.187 //l=0.4 //layer=li //thickness=0.1 \
 //x=63.29 //y=0.71 //x2=63.69 //y2=0.71
r63 (  13 29 ) resistor r=3.57586 //w=0.17 //l=0.103078 //layer=li \
 //thickness=0.1 //x=64.09 //y=0.71 //x2=64.175 //y2=0.67
r64 (  13 29 ) resistor r=27.3797 //w=0.187 //l=0.4 //layer=li //thickness=0.1 \
 //x=64.09 //y=0.71 //x2=63.69 //y2=0.71
r65 (  10 29 ) resistor r=3.57586 //w=0.17 //l=0.125 //layer=li \
 //thickness=0.1 //x=63.205 //y=1.675 //x2=63.205 //y2=1.8
r66 (  10 29 ) resistor r=42.0963 //w=0.187 //l=0.615 //layer=li \
 //thickness=0.1 //x=63.205 //y=1.675 //x2=63.205 //y2=1.06
r67 (  9 29 ) resistor r=3.57586 //w=0.17 //l=0.125 //layer=li //thickness=0.1 \
 //x=63.205 //y=0.795 //x2=63.205 //y2=0.67
r68 (  9 29 ) resistor r=18.139 //w=0.187 //l=0.265 //layer=li //thickness=0.1 \
 //x=63.205 //y=0.795 //x2=63.205 //y2=1.06
r69 (  6 29 ) resistor r=3.57586 //w=0.17 //l=0.103078 //layer=li \
 //thickness=0.1 //x=62.32 //y=1.76 //x2=62.235 //y2=1.8
r70 (  6 29 ) resistor r=27.3797 //w=0.187 //l=0.4 //layer=li //thickness=0.1 \
 //x=62.32 //y=1.76 //x2=62.72 //y2=1.76
r71 (  5 29 ) resistor r=3.57586 //w=0.17 //l=0.103078 //layer=li \
 //thickness=0.1 //x=63.12 //y=1.76 //x2=63.205 //y2=1.8
r72 (  5 29 ) resistor r=27.3797 //w=0.187 //l=0.4 //layer=li //thickness=0.1 \
 //x=63.12 //y=1.76 //x2=62.72 //y2=1.76
r73 (  1 29 ) resistor r=3.57586 //w=0.17 //l=0.125 //layer=li //thickness=0.1 \
 //x=62.235 //y=1.675 //x2=62.235 //y2=1.8
r74 (  1 29 ) resistor r=42.0963 //w=0.187 //l=0.615 //layer=li \
 //thickness=0.1 //x=62.235 //y=1.675 //x2=62.235 //y2=1.06
ends PM_TMRDFFQX1\%noxref_46

subckt PM_TMRDFFQX1\%noxref_47 ( 1 5 9 10 13 17 29 )
c58 ( 29 0 ) capacitor c=0.0758145f //x=65.43 //y=0.545
c59 ( 17 0 ) capacitor c=0.0072249f //x=67.505 //y=0.795
c60 ( 13 0 ) capacitor c=0.0153113f //x=67.42 //y=0.71
c61 ( 10 0 ) capacitor c=0.00698223f //x=66.535 //y=1.675
c62 ( 9 0 ) capacitor c=0.006761f //x=66.535 //y=0.795
c63 ( 5 0 ) capacitor c=0.0191191f //x=66.45 //y=1.76
c64 ( 1 0 ) capacitor c=0.00483164f //x=65.565 //y=1.675
r65 (  17 29 ) resistor r=3.57586 //w=0.17 //l=0.125 //layer=li \
 //thickness=0.1 //x=67.505 //y=0.795 //x2=67.505 //y2=0.67
r66 (  17 29 ) resistor r=41.4118 //w=0.187 //l=0.605 //layer=li \
 //thickness=0.1 //x=67.505 //y=0.795 //x2=67.505 //y2=1.4
r67 (  14 29 ) resistor r=3.57586 //w=0.17 //l=0.103078 //layer=li \
 //thickness=0.1 //x=66.62 //y=0.71 //x2=66.535 //y2=0.67
r68 (  14 29 ) resistor r=27.0374 //w=0.187 //l=0.395 //layer=li \
 //thickness=0.1 //x=66.62 //y=0.71 //x2=67.015 //y2=0.71
r69 (  13 29 ) resistor r=3.57586 //w=0.17 //l=0.103078 //layer=li \
 //thickness=0.1 //x=67.42 //y=0.71 //x2=67.505 //y2=0.67
r70 (  13 29 ) resistor r=27.7219 //w=0.187 //l=0.405 //layer=li \
 //thickness=0.1 //x=67.42 //y=0.71 //x2=67.015 //y2=0.71
r71 (  10 29 ) resistor r=3.57586 //w=0.17 //l=0.125 //layer=li \
 //thickness=0.1 //x=66.535 //y=1.675 //x2=66.535 //y2=1.8
r72 (  10 29 ) resistor r=42.0963 //w=0.187 //l=0.615 //layer=li \
 //thickness=0.1 //x=66.535 //y=1.675 //x2=66.535 //y2=1.06
r73 (  9 29 ) resistor r=3.57586 //w=0.17 //l=0.125 //layer=li //thickness=0.1 \
 //x=66.535 //y=0.795 //x2=66.535 //y2=0.67
r74 (  9 29 ) resistor r=18.139 //w=0.187 //l=0.265 //layer=li //thickness=0.1 \
 //x=66.535 //y=0.795 //x2=66.535 //y2=1.06
r75 (  6 29 ) resistor r=3.57586 //w=0.17 //l=0.103078 //layer=li \
 //thickness=0.1 //x=65.65 //y=1.76 //x2=65.565 //y2=1.8
r76 (  6 29 ) resistor r=27.3797 //w=0.187 //l=0.4 //layer=li //thickness=0.1 \
 //x=65.65 //y=1.76 //x2=66.05 //y2=1.76
r77 (  5 29 ) resistor r=3.57586 //w=0.17 //l=0.103078 //layer=li \
 //thickness=0.1 //x=66.45 //y=1.76 //x2=66.535 //y2=1.8
r78 (  5 29 ) resistor r=27.3797 //w=0.187 //l=0.4 //layer=li //thickness=0.1 \
 //x=66.45 //y=1.76 //x2=66.05 //y2=1.76
r79 (  1 29 ) resistor r=3.57586 //w=0.17 //l=0.125 //layer=li //thickness=0.1 \
 //x=65.565 //y=1.675 //x2=65.565 //y2=1.8
r80 (  1 29 ) resistor r=42.0963 //w=0.187 //l=0.615 //layer=li \
 //thickness=0.1 //x=65.565 //y=1.675 //x2=65.565 //y2=1.06
ends PM_TMRDFFQX1\%noxref_47

subckt PM_TMRDFFQX1\%noxref_48 ( 1 5 9 10 13 17 29 )
c56 ( 29 0 ) capacitor c=0.0723103f //x=68.76 //y=0.545
c57 ( 17 0 ) capacitor c=0.0072249f //x=70.835 //y=0.795
c58 ( 13 0 ) capacitor c=0.0155051f //x=70.75 //y=0.71
c59 ( 10 0 ) capacitor c=0.00876912f //x=69.865 //y=1.675
c60 ( 9 0 ) capacitor c=0.006761f //x=69.865 //y=0.795
c61 ( 5 0 ) capacitor c=0.0182818f //x=69.78 //y=1.76
c62 ( 1 0 ) capacitor c=0.00857722f //x=68.895 //y=1.675
r63 (  17 29 ) resistor r=3.57586 //w=0.17 //l=0.125 //layer=li \
 //thickness=0.1 //x=70.835 //y=0.795 //x2=70.835 //y2=0.67
r64 (  17 29 ) resistor r=41.4118 //w=0.187 //l=0.605 //layer=li \
 //thickness=0.1 //x=70.835 //y=0.795 //x2=70.835 //y2=1.4
r65 (  14 29 ) resistor r=3.57586 //w=0.17 //l=0.103078 //layer=li \
 //thickness=0.1 //x=69.95 //y=0.71 //x2=69.865 //y2=0.67
r66 (  14 29 ) resistor r=27.3797 //w=0.187 //l=0.4 //layer=li //thickness=0.1 \
 //x=69.95 //y=0.71 //x2=70.35 //y2=0.71
r67 (  13 29 ) resistor r=3.57586 //w=0.17 //l=0.103078 //layer=li \
 //thickness=0.1 //x=70.75 //y=0.71 //x2=70.835 //y2=0.67
r68 (  13 29 ) resistor r=27.3797 //w=0.187 //l=0.4 //layer=li //thickness=0.1 \
 //x=70.75 //y=0.71 //x2=70.35 //y2=0.71
r69 (  10 29 ) resistor r=3.57586 //w=0.17 //l=0.125 //layer=li \
 //thickness=0.1 //x=69.865 //y=1.675 //x2=69.865 //y2=1.8
r70 (  10 29 ) resistor r=42.0963 //w=0.187 //l=0.615 //layer=li \
 //thickness=0.1 //x=69.865 //y=1.675 //x2=69.865 //y2=1.06
r71 (  9 29 ) resistor r=3.57586 //w=0.17 //l=0.125 //layer=li //thickness=0.1 \
 //x=69.865 //y=0.795 //x2=69.865 //y2=0.67
r72 (  9 29 ) resistor r=18.139 //w=0.187 //l=0.265 //layer=li //thickness=0.1 \
 //x=69.865 //y=0.795 //x2=69.865 //y2=1.06
r73 (  6 29 ) resistor r=3.57586 //w=0.17 //l=0.103078 //layer=li \
 //thickness=0.1 //x=68.98 //y=1.76 //x2=68.895 //y2=1.8
r74 (  6 29 ) resistor r=27.3797 //w=0.187 //l=0.4 //layer=li //thickness=0.1 \
 //x=68.98 //y=1.76 //x2=69.38 //y2=1.76
r75 (  5 29 ) resistor r=3.57586 //w=0.17 //l=0.103078 //layer=li \
 //thickness=0.1 //x=69.78 //y=1.76 //x2=69.865 //y2=1.8
r76 (  5 29 ) resistor r=27.3797 //w=0.187 //l=0.4 //layer=li //thickness=0.1 \
 //x=69.78 //y=1.76 //x2=69.38 //y2=1.76
r77 (  1 29 ) resistor r=3.57586 //w=0.17 //l=0.125 //layer=li //thickness=0.1 \
 //x=68.895 //y=1.675 //x2=68.895 //y2=1.8
r78 (  1 29 ) resistor r=42.0963 //w=0.187 //l=0.615 //layer=li \
 //thickness=0.1 //x=68.895 //y=1.675 //x2=68.895 //y2=1.06
ends PM_TMRDFFQX1\%noxref_48

subckt PM_TMRDFFQX1\%noxref_49 ( 1 5 9 10 13 17 29 )
c57 ( 29 0 ) capacitor c=0.0637832f //x=72.09 //y=0.545
c58 ( 17 0 ) capacitor c=0.00722228f //x=74.165 //y=0.795
c59 ( 13 0 ) capacitor c=0.0141607f //x=74.08 //y=0.71
c60 ( 10 0 ) capacitor c=0.00712138f //x=73.195 //y=1.675
c61 ( 9 0 ) capacitor c=0.006761f //x=73.195 //y=0.795
c62 ( 5 0 ) capacitor c=0.0233454f //x=73.11 //y=1.76
c63 ( 1 0 ) capacitor c=0.00481264f //x=72.225 //y=1.675
r64 (  17 29 ) resistor r=3.57586 //w=0.17 //l=0.125 //layer=li \
 //thickness=0.1 //x=74.165 //y=0.795 //x2=74.165 //y2=0.67
r65 (  17 29 ) resistor r=18.139 //w=0.187 //l=0.265 //layer=li \
 //thickness=0.1 //x=74.165 //y=0.795 //x2=74.165 //y2=1.06
r66 (  14 29 ) resistor r=3.57586 //w=0.17 //l=0.103078 //layer=li \
 //thickness=0.1 //x=73.28 //y=0.71 //x2=73.195 //y2=0.67
r67 (  14 29 ) resistor r=27.3797 //w=0.187 //l=0.4 //layer=li //thickness=0.1 \
 //x=73.28 //y=0.71 //x2=73.68 //y2=0.71
r68 (  13 29 ) resistor r=3.57586 //w=0.17 //l=0.103078 //layer=li \
 //thickness=0.1 //x=74.08 //y=0.71 //x2=74.165 //y2=0.67
r69 (  13 29 ) resistor r=27.3797 //w=0.187 //l=0.4 //layer=li //thickness=0.1 \
 //x=74.08 //y=0.71 //x2=73.68 //y2=0.71
r70 (  10 29 ) resistor r=3.57586 //w=0.17 //l=0.125 //layer=li \
 //thickness=0.1 //x=73.195 //y=1.675 //x2=73.195 //y2=1.8
r71 (  10 29 ) resistor r=42.0963 //w=0.187 //l=0.615 //layer=li \
 //thickness=0.1 //x=73.195 //y=1.675 //x2=73.195 //y2=1.06
r72 (  9 29 ) resistor r=3.57586 //w=0.17 //l=0.125 //layer=li //thickness=0.1 \
 //x=73.195 //y=0.795 //x2=73.195 //y2=0.67
r73 (  9 29 ) resistor r=18.139 //w=0.187 //l=0.265 //layer=li //thickness=0.1 \
 //x=73.195 //y=0.795 //x2=73.195 //y2=1.06
r74 (  6 29 ) resistor r=3.57586 //w=0.17 //l=0.103078 //layer=li \
 //thickness=0.1 //x=72.31 //y=1.76 //x2=72.225 //y2=1.8
r75 (  6 29 ) resistor r=27.3797 //w=0.187 //l=0.4 //layer=li //thickness=0.1 \
 //x=72.31 //y=1.76 //x2=72.71 //y2=1.76
r76 (  5 29 ) resistor r=3.57586 //w=0.17 //l=0.103078 //layer=li \
 //thickness=0.1 //x=73.11 //y=1.76 //x2=73.195 //y2=1.8
r77 (  5 29 ) resistor r=27.3797 //w=0.187 //l=0.4 //layer=li //thickness=0.1 \
 //x=73.11 //y=1.76 //x2=72.71 //y2=1.76
r78 (  1 29 ) resistor r=3.57586 //w=0.17 //l=0.125 //layer=li //thickness=0.1 \
 //x=72.225 //y=1.675 //x2=72.225 //y2=1.8
r79 (  1 29 ) resistor r=42.0963 //w=0.187 //l=0.615 //layer=li \
 //thickness=0.1 //x=72.225 //y=1.675 //x2=72.225 //y2=1.06
ends PM_TMRDFFQX1\%noxref_49

subckt PM_TMRDFFQX1\%Q ( 1 2 3 4 5 6 17 18 19 20 29 31 )
c44 ( 31 0 ) capacitor c=0.028734f //x=75.83 //y=5.2
c45 ( 29 0 ) capacitor c=0.0172744f //x=75.785 //y=1.09
c46 ( 20 0 ) capacitor c=0.00575887f //x=76.06 //y=4.76
c47 ( 19 0 ) capacitor c=0.0136889f //x=76.255 //y=4.76
c48 ( 18 0 ) capacitor c=0.00636159f //x=76.055 //y=2.26
c49 ( 17 0 ) capacitor c=0.0140707f //x=76.255 //y=2.26
c50 ( 1 0 ) capacitor c=0.105613f //x=76.34 //y=2.4
r51 (  19 22 ) resistor r=7.15173 //w=0.17 //l=0.120208 //layer=li \
 //thickness=0.1 //x=76.255 //y=4.76 //x2=76.34 //y2=4.675
r52 (  19 20 ) resistor r=13.3476 //w=0.187 //l=0.195 //layer=li \
 //thickness=0.1 //x=76.255 //y=4.76 //x2=76.06 //y2=4.76
r53 (  17 21 ) resistor r=7.15173 //w=0.17 //l=0.120208 //layer=li \
 //thickness=0.1 //x=76.255 //y=2.26 //x2=76.34 //y2=2.345
r54 (  17 18 ) resistor r=13.6898 //w=0.187 //l=0.2 //layer=li //thickness=0.1 \
 //x=76.255 //y=2.26 //x2=76.055 //y2=2.26
r55 (  11 20 ) resistor r=7.15173 //w=0.17 //l=0.120208 //layer=li \
 //thickness=0.1 //x=75.975 //y=4.845 //x2=76.06 //y2=4.76
r56 (  11 31 ) resistor r=72.5562 //w=0.187 //l=1.06 //layer=li \
 //thickness=0.1 //x=75.975 //y=4.845 //x2=75.975 //y2=5.905
r57 (  7 18 ) resistor r=7.15173 //w=0.17 //l=0.120208 //layer=li \
 //thickness=0.1 //x=75.97 //y=2.175 //x2=76.055 //y2=2.26
r58 (  7 29 ) resistor r=67.7647 //w=0.187 //l=0.99 //layer=li //thickness=0.1 \
 //x=75.97 //y=2.175 //x2=75.97 //y2=1.185
r59 (  6 22 ) resistor r=29.0909 //w=0.187 //l=0.425 //layer=li \
 //thickness=0.1 //x=76.34 //y=4.25 //x2=76.34 //y2=4.675
r60 (  5 6 ) resistor r=25.3262 //w=0.187 //l=0.37 //layer=li //thickness=0.1 \
 //x=76.34 //y=3.88 //x2=76.34 //y2=4.25
r61 (  4 5 ) resistor r=25.3262 //w=0.187 //l=0.37 //layer=li //thickness=0.1 \
 //x=76.34 //y=3.51 //x2=76.34 //y2=3.88
r62 (  3 4 ) resistor r=25.3262 //w=0.187 //l=0.37 //layer=li //thickness=0.1 \
 //x=76.34 //y=3.14 //x2=76.34 //y2=3.51
r63 (  2 3 ) resistor r=25.3262 //w=0.187 //l=0.37 //layer=li //thickness=0.1 \
 //x=76.34 //y=2.77 //x2=76.34 //y2=3.14
r64 (  1 2 ) resistor r=25.3262 //w=0.187 //l=0.37 //layer=li //thickness=0.1 \
 //x=76.34 //y=2.4 //x2=76.34 //y2=2.77
r65 (  1 21 ) resistor r=3.76471 //w=0.187 //l=0.055 //layer=li \
 //thickness=0.1 //x=76.34 //y=2.4 //x2=76.34 //y2=2.345
ends PM_TMRDFFQX1\%Q
