// File: BUFX1.spi.pex
// Created: Tue Apr 29 10:39:11 2025
// Program "Calibre xRC"
// Version "v2023.2_27.15"
// Nominal Temperature: 30C
// Circuit Temperature: 30C
//
simulator lang=spectre
subckt PM_BUFX1\%GND ( 1 11 23 27 49 53 64 67 78 90 91 )
c60 ( 91 0 ) capacitor c=0.0597376f //x=3.205 //y=0.55
c61 ( 90 0 ) capacitor c=0.0585891f //x=0.985 //y=0.55
c62 ( 78 0 ) capacitor c=0.0970752f //x=2.71 //y=0.175
c63 ( 67 0 ) capacitor c=0.211321f //x=1.12 //y=0.175
c64 ( 64 0 ) capacitor c=0.216532f //x=4.56 //y=0.18
c65 ( 62 0 ) capacitor c=0.0366606f //x=4.395 //y=0.175
c66 ( 56 0 ) capacitor c=0.00587411f //x=4.31 //y=0.63
c67 ( 53 0 ) capacitor c=0.00542565f //x=4.225 //y=0.715
c68 ( 52 0 ) capacitor c=0.00479856f //x=3.825 //y=0.63
c69 ( 49 0 ) capacitor c=0.00690112f //x=3.74 //y=0.715
c70 ( 44 0 ) capacitor c=0.00592191f //x=3.34 //y=0.63
c71 ( 41 0 ) capacitor c=0.0191899f //x=3.255 //y=0.175
c72 ( 36 0 ) capacitor c=0.0366606f //x=2.175 //y=0.175
c73 ( 35 0 ) capacitor c=0.0186173f //x=2.54 //y=0.175
c74 ( 30 0 ) capacitor c=0.00587411f //x=2.09 //y=0.63
c75 ( 27 0 ) capacitor c=0.00535899f //x=2.005 //y=0.715
c76 ( 26 0 ) capacitor c=0.00479856f //x=1.605 //y=0.63
c77 ( 23 0 ) capacitor c=0.00707849f //x=1.52 //y=0.715
c78 ( 18 0 ) capacitor c=0.00592191f //x=1.12 //y=0.63
c79 ( 11 0 ) capacitor c=0.2263f //x=4.56 //y=0.18
r80 (  82 83 ) resistor r=16.9155 //w=0.367 //l=0.485 //layer=li \
 //thickness=0.1 //x=3.825 //y=0.175 //x2=4.31 //y2=0.175
r81 (  81 82 ) resistor r=0.174387 //w=0.367 //l=0.005 //layer=li \
 //thickness=0.1 //x=3.82 //y=0.175 //x2=3.825 //y2=0.175
r82 (  79 81 ) resistor r=16.7411 //w=0.367 //l=0.48 //layer=li \
 //thickness=0.1 //x=3.34 //y=0.175 //x2=3.82 //y2=0.175
r83 (  70 71 ) resistor r=16.9155 //w=0.367 //l=0.485 //layer=li \
 //thickness=0.1 //x=1.605 //y=0.175 //x2=2.09 //y2=0.175
r84 (  69 70 ) resistor r=13.079 //w=0.367 //l=0.375 //layer=li \
 //thickness=0.1 //x=1.23 //y=0.175 //x2=1.605 //y2=0.175
r85 (  67 69 ) resistor r=3.83651 //w=0.367 //l=0.11 //layer=li \
 //thickness=0.1 //x=1.12 //y=0.175 //x2=1.23 //y2=0.175
r86 (  62 83 ) resistor r=2.96458 //w=0.367 //l=0.085 //layer=li \
 //thickness=0.1 //x=4.395 //y=0.175 //x2=4.31 //y2=0.175
r87 (  62 64 ) resistor r=5.75477 //w=0.367 //l=0.165 //layer=li \
 //thickness=0.1 //x=4.395 //y=0.175 //x2=4.56 //y2=0.175
r88 (  57 91 ) resistor r=5.4201 //w=0.17 //l=0.085 //layer=li //thickness=0.1 \
 //x=4.31 //y=0.8 //x2=4.31 //y2=0.715
r89 (  57 91 ) resistor r=41.4118 //w=0.187 //l=0.605 //layer=li \
 //thickness=0.1 //x=4.31 //y=0.8 //x2=4.31 //y2=1.405
r90 (  56 91 ) resistor r=5.4201 //w=0.17 //l=0.085 //layer=li //thickness=0.1 \
 //x=4.31 //y=0.63 //x2=4.31 //y2=0.715
r91 (  55 83 ) resistor r=5.21862 //w=0.35 //l=0.175 //layer=li \
 //thickness=0.1 //x=4.31 //y=0.35 //x2=4.31 //y2=0.175
r92 (  55 56 ) resistor r=19.1658 //w=0.187 //l=0.28 //layer=li \
 //thickness=0.1 //x=4.31 //y=0.35 //x2=4.31 //y2=0.63
r93 (  54 91 ) resistor r=5.4201 //w=0.17 //l=0.085 //layer=li //thickness=0.1 \
 //x=3.91 //y=0.715 //x2=3.825 //y2=0.715
r94 (  53 91 ) resistor r=1.40859 //w=0.34 //l=0.085 //layer=li \
 //thickness=0.1 //x=4.225 //y=0.715 //x2=4.31 //y2=0.715
r95 (  53 54 ) resistor r=21.5615 //w=0.187 //l=0.315 //layer=li \
 //thickness=0.1 //x=4.225 //y=0.715 //x2=3.91 //y2=0.715
r96 (  52 91 ) resistor r=1.40859 //w=0.34 //l=0.085 //layer=li \
 //thickness=0.1 //x=3.825 //y=0.63 //x2=3.825 //y2=0.715
r97 (  51 82 ) resistor r=5.21862 //w=0.35 //l=0.175 //layer=li \
 //thickness=0.1 //x=3.825 //y=0.35 //x2=3.825 //y2=0.175
r98 (  51 52 ) resistor r=19.1658 //w=0.187 //l=0.28 //layer=li \
 //thickness=0.1 //x=3.825 //y=0.35 //x2=3.825 //y2=0.63
r99 (  50 91 ) resistor r=1.40859 //w=0.34 //l=0.085 //layer=li \
 //thickness=0.1 //x=3.425 //y=0.715 //x2=3.34 //y2=0.715
r100 (  49 91 ) resistor r=5.4201 //w=0.17 //l=0.085 //layer=li \
 //thickness=0.1 //x=3.74 //y=0.715 //x2=3.825 //y2=0.715
r101 (  49 50 ) resistor r=21.5615 //w=0.187 //l=0.315 //layer=li \
 //thickness=0.1 //x=3.74 //y=0.715 //x2=3.425 //y2=0.715
r102 (  45 91 ) resistor r=5.4201 //w=0.17 //l=0.085 //layer=li \
 //thickness=0.1 //x=3.34 //y=0.8 //x2=3.34 //y2=0.715
r103 (  45 91 ) resistor r=41.4118 //w=0.187 //l=0.605 //layer=li \
 //thickness=0.1 //x=3.34 //y=0.8 //x2=3.34 //y2=1.405
r104 (  44 91 ) resistor r=5.4201 //w=0.17 //l=0.085 //layer=li \
 //thickness=0.1 //x=3.34 //y=0.63 //x2=3.34 //y2=0.715
r105 (  43 79 ) resistor r=5.21862 //w=0.35 //l=0.175 //layer=li \
 //thickness=0.1 //x=3.34 //y=0.35 //x2=3.34 //y2=0.175
r106 (  43 44 ) resistor r=19.1658 //w=0.187 //l=0.28 //layer=li \
 //thickness=0.1 //x=3.34 //y=0.35 //x2=3.34 //y2=0.63
r107 (  42 78 ) resistor r=5.29055 //w=0.35 //l=0.17 //layer=li \
 //thickness=0.1 //x=2.88 //y=0.175 //x2=2.71 //y2=0.175
r108 (  41 79 ) resistor r=2.96458 //w=0.367 //l=0.085 //layer=li \
 //thickness=0.1 //x=3.255 //y=0.175 //x2=3.34 //y2=0.175
r109 (  41 42 ) resistor r=13.079 //w=0.367 //l=0.375 //layer=li \
 //thickness=0.1 //x=3.255 //y=0.175 //x2=2.88 //y2=0.175
r110 (  36 71 ) resistor r=2.96458 //w=0.367 //l=0.085 //layer=li \
 //thickness=0.1 //x=2.175 //y=0.175 //x2=2.09 //y2=0.175
r111 (  36 38 ) resistor r=5.75477 //w=0.367 //l=0.165 //layer=li \
 //thickness=0.1 //x=2.175 //y=0.175 //x2=2.34 //y2=0.175
r112 (  35 78 ) resistor r=5.29055 //w=0.35 //l=0.17 //layer=li \
 //thickness=0.1 //x=2.54 //y=0.175 //x2=2.71 //y2=0.175
r113 (  35 38 ) resistor r=6.97548 //w=0.367 //l=0.2 //layer=li \
 //thickness=0.1 //x=2.54 //y=0.175 //x2=2.34 //y2=0.175
r114 (  31 90 ) resistor r=5.4201 //w=0.17 //l=0.085 //layer=li \
 //thickness=0.1 //x=2.09 //y=0.8 //x2=2.09 //y2=0.715
r115 (  31 90 ) resistor r=41.4118 //w=0.187 //l=0.605 //layer=li \
 //thickness=0.1 //x=2.09 //y=0.8 //x2=2.09 //y2=1.405
r116 (  30 90 ) resistor r=5.4201 //w=0.17 //l=0.085 //layer=li \
 //thickness=0.1 //x=2.09 //y=0.63 //x2=2.09 //y2=0.715
r117 (  29 71 ) resistor r=5.21862 //w=0.35 //l=0.175 //layer=li \
 //thickness=0.1 //x=2.09 //y=0.35 //x2=2.09 //y2=0.175
r118 (  29 30 ) resistor r=19.1658 //w=0.187 //l=0.28 //layer=li \
 //thickness=0.1 //x=2.09 //y=0.35 //x2=2.09 //y2=0.63
r119 (  28 90 ) resistor r=5.4201 //w=0.17 //l=0.085 //layer=li \
 //thickness=0.1 //x=1.69 //y=0.715 //x2=1.605 //y2=0.715
r120 (  27 90 ) resistor r=1.40859 //w=0.34 //l=0.085 //layer=li \
 //thickness=0.1 //x=2.005 //y=0.715 //x2=2.09 //y2=0.715
r121 (  27 28 ) resistor r=21.5615 //w=0.187 //l=0.315 //layer=li \
 //thickness=0.1 //x=2.005 //y=0.715 //x2=1.69 //y2=0.715
r122 (  26 90 ) resistor r=1.40859 //w=0.34 //l=0.085 //layer=li \
 //thickness=0.1 //x=1.605 //y=0.63 //x2=1.605 //y2=0.715
r123 (  25 70 ) resistor r=5.21862 //w=0.35 //l=0.175 //layer=li \
 //thickness=0.1 //x=1.605 //y=0.35 //x2=1.605 //y2=0.175
r124 (  25 26 ) resistor r=19.1658 //w=0.187 //l=0.28 //layer=li \
 //thickness=0.1 //x=1.605 //y=0.35 //x2=1.605 //y2=0.63
r125 (  24 90 ) resistor r=1.40859 //w=0.34 //l=0.085 //layer=li \
 //thickness=0.1 //x=1.205 //y=0.715 //x2=1.12 //y2=0.715
r126 (  23 90 ) resistor r=5.4201 //w=0.17 //l=0.085 //layer=li \
 //thickness=0.1 //x=1.52 //y=0.715 //x2=1.605 //y2=0.715
r127 (  23 24 ) resistor r=21.5615 //w=0.187 //l=0.315 //layer=li \
 //thickness=0.1 //x=1.52 //y=0.715 //x2=1.205 //y2=0.715
r128 (  19 90 ) resistor r=5.4201 //w=0.17 //l=0.085 //layer=li \
 //thickness=0.1 //x=1.12 //y=0.8 //x2=1.12 //y2=0.715
r129 (  19 90 ) resistor r=41.4118 //w=0.187 //l=0.605 //layer=li \
 //thickness=0.1 //x=1.12 //y=0.8 //x2=1.12 //y2=1.405
r130 (  18 90 ) resistor r=5.4201 //w=0.17 //l=0.085 //layer=li \
 //thickness=0.1 //x=1.12 //y=0.63 //x2=1.12 //y2=0.715
r131 (  17 67 ) resistor r=5.21862 //w=0.35 //l=0.175 //layer=li \
 //thickness=0.1 //x=1.12 //y=0.35 //x2=1.12 //y2=0.175
r132 (  17 18 ) resistor r=19.1658 //w=0.187 //l=0.28 //layer=li \
 //thickness=0.1 //x=1.12 //y=0.35 //x2=1.12 //y2=0.63
r133 (  11 64 ) resistor r=9.3 //w=0.17 //l=0.17 //layer=mcon //count=1 \
 //x=4.56 //y=0.18 //x2=4.56 //y2=0.18
r134 (  9 81 ) resistor r=3.1 //w=0.17 //l=0.51 //layer=mcon //count=3 \
 //x=3.82 //y=0.18 //x2=3.82 //y2=0.18
r135 (  9 11 ) resistor r=0.297428 //w=0.311 //l=0.74 //layer=m1 \
 //thickness=0.36 //x=3.82 //y=0.175 //x2=4.56 //y2=0.175
r136 (  6 38 ) resistor r=3.1 //w=0.17 //l=0.51 //layer=mcon //count=3 \
 //x=2.34 //y=0.18 //x2=2.34 //y2=0.18
r137 (  3 69 ) resistor r=3.1 //w=0.17 //l=0.51 //layer=mcon //count=3 \
 //x=1.23 //y=0.18 //x2=1.23 //y2=0.18
r138 (  3 6 ) resistor r=0.446141 //w=0.311 //l=1.11 //layer=m1 \
 //thickness=0.36 //x=1.23 //y=0.175 //x2=2.34 //y2=0.175
r139 (  1 9 ) resistor r=0.446141 //w=0.311 //l=1.11 //layer=m1 \
 //thickness=0.36 //x=2.71 //y=0.175 //x2=3.82 //y2=0.175
r140 (  1 6 ) resistor r=0.148714 //w=0.311 //l=0.37 //layer=m1 \
 //thickness=0.36 //x=2.71 //y=0.175 //x2=2.34 //y2=0.175
ends PM_BUFX1\%GND

subckt PM_BUFX1\%VDD ( 1 11 23 45 58 62 64 67 68 69 70 )
c47 ( 70 0 ) capacitor c=0.0451938f //x=4.12 //y=5.2
c48 ( 69 0 ) capacitor c=0.0427418f //x=3.25 //y=5.2
c49 ( 68 0 ) capacitor c=0.0451938f //x=1.9 //y=5.2
c50 ( 67 0 ) capacitor c=0.0427418f //x=1.03 //y=5.2
c51 ( 66 0 ) capacitor c=0.00597439f //x=4.265 //y=7.585
c52 ( 65 0 ) capacitor c=0.00597439f //x=3.385 //y=7.585
c53 ( 64 0 ) capacitor c=0.109311f //x=2.71 //y=7.585
c54 ( 63 0 ) capacitor c=0.00597439f //x=2.045 //y=7.585
c55 ( 62 0 ) capacitor c=0.252156f //x=1.23 //y=7.58
c56 ( 58 0 ) capacitor c=0.247693f //x=4.56 //y=7.58
c57 ( 45 0 ) capacitor c=0.029016f //x=4.18 //y=7.585
c58 ( 37 0 ) capacitor c=0.0217664f //x=3.3 //y=7.585
c59 ( 31 0 ) capacitor c=0.0211939f //x=2.54 //y=7.585
c60 ( 23 0 ) capacitor c=0.029016f //x=1.96 //y=7.585
c61 ( 11 0 ) capacitor c=0.227414f //x=4.56 //y=7.58
r62 (  56 66 ) resistor r=2.87058 //w=0.35 //l=0.085 //layer=li \
 //thickness=0.1 //x=4.35 //y=7.585 //x2=4.265 //y2=7.585
r63 (  56 58 ) resistor r=7.32425 //w=0.367 //l=0.21 //layer=li \
 //thickness=0.1 //x=4.35 //y=7.585 //x2=4.56 //y2=7.585
r64 (  49 66 ) resistor r=4.23183 //w=0.7 //l=0.175 //layer=li //thickness=0.1 \
 //x=4.265 //y=7.41 //x2=4.265 //y2=7.585
r65 (  49 70 ) resistor r=56.4706 //w=0.187 //l=0.825 //layer=li \
 //thickness=0.1 //x=4.265 //y=7.41 //x2=4.265 //y2=6.585
r66 (  46 65 ) resistor r=2.87058 //w=0.35 //l=0.085 //layer=li \
 //thickness=0.1 //x=3.47 //y=7.585 //x2=3.385 //y2=7.585
r67 (  46 48 ) resistor r=12.2071 //w=0.367 //l=0.35 //layer=li \
 //thickness=0.1 //x=3.47 //y=7.585 //x2=3.82 //y2=7.585
r68 (  45 66 ) resistor r=2.87058 //w=0.35 //l=0.085 //layer=li \
 //thickness=0.1 //x=4.18 //y=7.585 //x2=4.265 //y2=7.585
r69 (  45 48 ) resistor r=12.5559 //w=0.367 //l=0.36 //layer=li \
 //thickness=0.1 //x=4.18 //y=7.585 //x2=3.82 //y2=7.585
r70 (  39 65 ) resistor r=4.23183 //w=0.7 //l=0.175 //layer=li //thickness=0.1 \
 //x=3.385 //y=7.41 //x2=3.385 //y2=7.585
r71 (  39 69 ) resistor r=56.4706 //w=0.187 //l=0.825 //layer=li \
 //thickness=0.1 //x=3.385 //y=7.41 //x2=3.385 //y2=6.585
r72 (  38 64 ) resistor r=5.29055 //w=0.35 //l=0.17 //layer=li //thickness=0.1 \
 //x=2.88 //y=7.585 //x2=2.71 //y2=7.585
r73 (  37 65 ) resistor r=2.87058 //w=0.35 //l=0.085 //layer=li \
 //thickness=0.1 //x=3.3 //y=7.585 //x2=3.385 //y2=7.585
r74 (  37 38 ) resistor r=14.6485 //w=0.367 //l=0.42 //layer=li \
 //thickness=0.1 //x=3.3 //y=7.585 //x2=2.88 //y2=7.585
r75 (  32 63 ) resistor r=2.87058 //w=0.35 //l=0.085 //layer=li \
 //thickness=0.1 //x=2.13 //y=7.585 //x2=2.045 //y2=7.585
r76 (  32 34 ) resistor r=7.32425 //w=0.367 //l=0.21 //layer=li \
 //thickness=0.1 //x=2.13 //y=7.585 //x2=2.34 //y2=7.585
r77 (  31 64 ) resistor r=5.29055 //w=0.35 //l=0.17 //layer=li //thickness=0.1 \
 //x=2.54 //y=7.585 //x2=2.71 //y2=7.585
r78 (  31 34 ) resistor r=6.97548 //w=0.367 //l=0.2 //layer=li //thickness=0.1 \
 //x=2.54 //y=7.585 //x2=2.34 //y2=7.585
r79 (  25 63 ) resistor r=4.23183 //w=0.7 //l=0.175 //layer=li //thickness=0.1 \
 //x=2.045 //y=7.41 //x2=2.045 //y2=7.585
r80 (  25 68 ) resistor r=56.4706 //w=0.187 //l=0.825 //layer=li \
 //thickness=0.1 //x=2.045 //y=7.41 //x2=2.045 //y2=6.585
r81 (  24 62 ) resistor r=2.87058 //w=0.35 //l=0.085 //layer=li \
 //thickness=0.1 //x=1.25 //y=7.585 //x2=1.165 //y2=7.585
r82 (  23 63 ) resistor r=2.87058 //w=0.35 //l=0.085 //layer=li \
 //thickness=0.1 //x=1.96 //y=7.585 //x2=2.045 //y2=7.585
r83 (  23 24 ) resistor r=24.7629 //w=0.367 //l=0.71 //layer=li \
 //thickness=0.1 //x=1.96 //y=7.585 //x2=1.25 //y2=7.585
r84 (  17 62 ) resistor r=4.23183 //w=0.7 //l=0.175 //layer=li //thickness=0.1 \
 //x=1.165 //y=7.41 //x2=1.165 //y2=7.585
r85 (  17 67 ) resistor r=56.4706 //w=0.187 //l=0.825 //layer=li \
 //thickness=0.1 //x=1.165 //y=7.41 //x2=1.165 //y2=6.585
r86 (  11 58 ) resistor r=9.3 //w=0.17 //l=0.17 //layer=mcon //count=1 \
 //x=4.56 //y=7.58 //x2=4.56 //y2=7.58
r87 (  9 48 ) resistor r=3.1 //w=0.17 //l=0.51 //layer=mcon //count=3 //x=3.82 \
 //y=7.58 //x2=3.82 //y2=7.58
r88 (  9 11 ) resistor r=0.297428 //w=0.311 //l=0.74 //layer=m1 \
 //thickness=0.36 //x=3.82 //y=7.585 //x2=4.56 //y2=7.585
r89 (  6 34 ) resistor r=3.1 //w=0.17 //l=0.51 //layer=mcon //count=3 //x=2.34 \
 //y=7.58 //x2=2.34 //y2=7.58
r90 (  3 62 ) resistor r=3.1 //w=0.17 //l=0.51 //layer=mcon //count=3 //x=1.23 \
 //y=7.58 //x2=1.23 //y2=7.58
r91 (  3 6 ) resistor r=0.446141 //w=0.311 //l=1.11 //layer=m1 \
 //thickness=0.36 //x=1.23 //y=7.585 //x2=2.34 //y2=7.585
r92 (  1 9 ) resistor r=0.446141 //w=0.311 //l=1.11 //layer=m1 \
 //thickness=0.36 //x=2.71 //y=7.585 //x2=3.82 //y2=7.585
r93 (  1 6 ) resistor r=0.148714 //w=0.311 //l=0.37 //layer=m1 \
 //thickness=0.36 //x=2.71 //y=7.585 //x2=2.34 //y2=7.585
ends PM_BUFX1\%VDD

subckt PM_BUFX1\%noxref_3 ( 1 2 17 18 19 20 24 26 33 34 35 36 37 38 39 43 44 \
 45 47 53 54 56 64 66 )
c102 ( 66 0 ) capacitor c=0.028734f //x=1.46 //y=5.2
c103 ( 64 0 ) capacitor c=0.0173218f //x=1.415 //y=1.09
c104 ( 56 0 ) capacitor c=0.0517753f //x=3.45 //y=2.265
c105 ( 54 0 ) capacitor c=0.0435629f //x=4.09 //y=1.435
c106 ( 53 0 ) capacitor c=0.0200386f //x=4.09 //y=1.09
c107 ( 47 0 ) capacitor c=0.0152946f //x=3.935 //y=1.59
c108 ( 45 0 ) capacitor c=0.0157804f //x=3.935 //y=0.935
c109 ( 44 0 ) capacitor c=0.0525175f //x=3.68 //y=4.97
c110 ( 43 0 ) capacitor c=0.0322983f //x=3.97 //y=4.97
c111 ( 39 0 ) capacitor c=0.0290017f //x=3.56 //y=2.1
c112 ( 38 0 ) capacitor c=0.0250027f //x=3.56 //y=1.745
c113 ( 37 0 ) capacitor c=0.0234316f //x=3.56 //y=1.435
c114 ( 36 0 ) capacitor c=0.0200596f //x=3.56 //y=1.09
c115 ( 35 0 ) capacitor c=0.154218f //x=4.045 //y=6.2
c116 ( 34 0 ) capacitor c=0.154243f //x=3.605 //y=6.2
c117 ( 26 0 ) capacitor c=0.0948756f //x=3.45 //y=2.265
c118 ( 24 0 ) capacitor c=0.0858431f //x=1.97 //y=2.77
c119 ( 20 0 ) capacitor c=0.00575887f //x=1.69 //y=4.76
c120 ( 19 0 ) capacitor c=0.0146153f //x=1.885 //y=4.76
c121 ( 18 0 ) capacitor c=0.00636159f //x=1.685 //y=2.26
c122 ( 17 0 ) capacitor c=0.0136204f //x=1.885 //y=2.26
c123 ( 2 0 ) capacitor c=0.0171827f //x=2.085 //y=2.77
c124 ( 1 0 ) capacitor c=0.0922367f //x=3.335 //y=2.77
r125 (  56 57 ) resistor r=17.5563 //w=0.302 //l=0.11 //layer=ply \
 //thickness=0.18 //x=3.45 //y=2.265 //x2=3.56 //y2=2.265
r126 (  54 63 ) resistor r=45.1352 //w=0.168 //l=0.173853 //layer=ply \
 //thickness=0.18 //x=4.09 //y=1.435 //x2=4.05 //y2=1.59
r127 (  53 62 ) resistor r=45.1352 //w=0.168 //l=0.173853 //layer=ply \
 //thickness=0.18 //x=4.09 //y=1.09 //x2=4.05 //y2=0.935
r128 (  53 54 ) resistor r=176.904 //w=0.094 //l=0.345 //layer=ply \
 //thickness=0.18 //x=4.09 //y=1.09 //x2=4.09 //y2=1.435
r129 (  48 61 ) resistor r=10.701 //w=0.21 //l=0.115 //layer=ply \
 //thickness=0.18 //x=3.715 //y=1.59 //x2=3.6 //y2=1.59
r130 (  47 63 ) resistor r=5.52526 //w=0.168 //l=0.115 //layer=ply \
 //thickness=0.18 //x=3.935 //y=1.59 //x2=4.05 //y2=1.59
r131 (  46 60 ) resistor r=5.52526 //w=0.168 //l=0.115 //layer=ply \
 //thickness=0.18 //x=3.715 //y=0.935 //x2=3.6 //y2=0.935
r132 (  45 62 ) resistor r=5.52526 //w=0.168 //l=0.115 //layer=ply \
 //thickness=0.18 //x=3.935 //y=0.935 //x2=4.05 //y2=0.935
r133 (  45 46 ) resistor r=112.809 //w=0.094 //l=0.22 //layer=ply \
 //thickness=0.18 //x=3.935 //y=0.935 //x2=3.715 //y2=0.935
r134 (  43 50 ) resistor r=26.9307 //w=0.15 //l=0.106066 //layer=ply \
 //thickness=0.18 //x=3.97 //y=4.97 //x2=4.045 //y2=5.045
r135 (  43 44 ) resistor r=148.702 //w=0.094 //l=0.29 //layer=ply \
 //thickness=0.18 //x=3.97 //y=4.97 //x2=3.68 //y2=4.97
r136 (  40 44 ) resistor r=23.403 //w=0.284 //l=0.106066 //layer=ply \
 //thickness=0.18 //x=3.605 //y=5.045 //x2=3.68 //y2=4.97
r137 (  40 59 ) resistor r=26.3063 //w=0.284 //l=0.229783 //layer=ply \
 //thickness=0.18 //x=3.605 //y=5.045 //x2=3.45 //y2=4.88
r138 (  39 57 ) resistor r=19.1248 //w=0.302 //l=0.165 //layer=ply \
 //thickness=0.18 //x=3.56 //y=2.1 //x2=3.56 //y2=2.265
r139 (  38 61 ) resistor r=39.5823 //w=0.21 //l=0.173853 //layer=ply \
 //thickness=0.18 //x=3.56 //y=1.745 //x2=3.6 //y2=1.59
r140 (  38 39 ) resistor r=182.032 //w=0.094 //l=0.355 //layer=ply \
 //thickness=0.18 //x=3.56 //y=1.745 //x2=3.56 //y2=2.1
r141 (  37 61 ) resistor r=39.5823 //w=0.21 //l=0.173853 //layer=ply \
 //thickness=0.18 //x=3.56 //y=1.435 //x2=3.6 //y2=1.59
r142 (  36 60 ) resistor r=45.1352 //w=0.168 //l=0.173853 //layer=ply \
 //thickness=0.18 //x=3.56 //y=1.09 //x2=3.6 //y2=0.935
r143 (  36 37 ) resistor r=176.904 //w=0.094 //l=0.345 //layer=ply \
 //thickness=0.18 //x=3.56 //y=1.09 //x2=3.56 //y2=1.435
r144 (  35 50 ) resistor r=592.245 //w=0.094 //l=1.155 //layer=ply \
 //thickness=0.18 //x=4.045 //y=6.2 //x2=4.045 //y2=5.045
r145 (  34 40 ) resistor r=592.245 //w=0.094 //l=1.155 //layer=ply \
 //thickness=0.18 //x=3.605 //y=6.2 //x2=3.605 //y2=5.045
r146 (  33 47 ) resistor r=56.4043 //w=0.094 //l=0.11 //layer=ply \
 //thickness=0.18 //x=3.825 //y=1.59 //x2=3.935 //y2=1.59
r147 (  33 48 ) resistor r=56.4043 //w=0.094 //l=0.11 //layer=ply \
 //thickness=0.18 //x=3.825 //y=1.59 //x2=3.715 //y2=1.59
r148 (  31 59 ) resistor r=152 //w=0.17 //l=0.17 //layer=licon //count=1 \
 //x=3.45 //y=4.88 //x2=3.45 //y2=4.88
r149 (  29 31 ) resistor r=144.428 //w=0.187 //l=2.11 //layer=li \
 //thickness=0.1 //x=3.45 //y=2.77 //x2=3.45 //y2=4.88
r150 (  26 56 ) resistor r=152 //w=0.17 //l=0.17 //layer=licon //count=1 \
 //x=3.45 //y=2.265 //x2=3.45 //y2=2.265
r151 (  26 29 ) resistor r=34.5668 //w=0.187 //l=0.505 //layer=li \
 //thickness=0.1 //x=3.45 //y=2.265 //x2=3.45 //y2=2.77
r152 (  22 24 ) resistor r=130.396 //w=0.187 //l=1.905 //layer=li \
 //thickness=0.1 //x=1.97 //y=4.675 //x2=1.97 //y2=2.77
r153 (  21 24 ) resistor r=29.0909 //w=0.187 //l=0.425 //layer=li \
 //thickness=0.1 //x=1.97 //y=2.345 //x2=1.97 //y2=2.77
r154 (  19 22 ) resistor r=7.15173 //w=0.17 //l=0.120208 //layer=li \
 //thickness=0.1 //x=1.885 //y=4.76 //x2=1.97 //y2=4.675
r155 (  19 20 ) resistor r=13.3476 //w=0.187 //l=0.195 //layer=li \
 //thickness=0.1 //x=1.885 //y=4.76 //x2=1.69 //y2=4.76
r156 (  17 21 ) resistor r=7.15173 //w=0.17 //l=0.120208 //layer=li \
 //thickness=0.1 //x=1.885 //y=2.26 //x2=1.97 //y2=2.345
r157 (  17 18 ) resistor r=13.6898 //w=0.187 //l=0.2 //layer=li \
 //thickness=0.1 //x=1.885 //y=2.26 //x2=1.685 //y2=2.26
r158 (  11 20 ) resistor r=7.15173 //w=0.17 //l=0.120208 //layer=li \
 //thickness=0.1 //x=1.605 //y=4.845 //x2=1.69 //y2=4.76
r159 (  11 66 ) resistor r=72.5562 //w=0.187 //l=1.06 //layer=li \
 //thickness=0.1 //x=1.605 //y=4.845 //x2=1.605 //y2=5.905
r160 (  7 18 ) resistor r=7.15173 //w=0.17 //l=0.120208 //layer=li \
 //thickness=0.1 //x=1.6 //y=2.175 //x2=1.685 //y2=2.26
r161 (  7 64 ) resistor r=67.7647 //w=0.187 //l=0.99 //layer=li \
 //thickness=0.1 //x=1.6 //y=2.175 //x2=1.6 //y2=1.185
r162 (  6 29 ) resistor r=9.3 //w=0.17 //l=0.17 //layer=mcon //count=1 \
 //x=3.45 //y=2.77 //x2=3.45 //y2=2.77
r163 (  4 24 ) resistor r=9.3 //w=0.17 //l=0.17 //layer=mcon //count=1 \
 //x=1.97 //y=2.77 //x2=1.97 //y2=2.77
r164 (  2 4 ) resistor r=0.0717383 //w=0.224 //l=0.115 //layer=m1 \
 //thickness=0.36 //x=2.085 //y=2.77 //x2=1.97 //y2=2.77
r165 (  1 6 ) resistor r=0.0717383 //w=0.224 //l=0.115 //layer=m1 \
 //thickness=0.36 //x=3.335 //y=2.77 //x2=3.45 //y2=2.77
r166 (  1 2 ) resistor r=1.19275 //w=0.131 //l=1.25 //layer=m1 \
 //thickness=0.36 //x=3.335 //y=2.77 //x2=2.085 //y2=2.77
ends PM_BUFX1\%noxref_3

subckt PM_BUFX1\%A ( 1 2 3 4 5 6 7 9 21 22 23 24 25 26 27 31 32 33 35 41 42 44 )
c48 ( 44 0 ) capacitor c=0.0537799f //x=1.23 //y=2.265
c49 ( 42 0 ) capacitor c=0.0435629f //x=1.87 //y=1.435
c50 ( 41 0 ) capacitor c=0.0200386f //x=1.87 //y=1.09
c51 ( 35 0 ) capacitor c=0.0152946f //x=1.715 //y=1.59
c52 ( 33 0 ) capacitor c=0.0157804f //x=1.715 //y=0.935
c53 ( 32 0 ) capacitor c=0.0524167f //x=1.46 //y=4.97
c54 ( 31 0 ) capacitor c=0.0323991f //x=1.75 //y=4.97
c55 ( 27 0 ) capacitor c=0.0290017f //x=1.34 //y=2.1
c56 ( 26 0 ) capacitor c=0.0250027f //x=1.34 //y=1.745
c57 ( 25 0 ) capacitor c=0.0234316f //x=1.34 //y=1.435
c58 ( 24 0 ) capacitor c=0.0200596f //x=1.34 //y=1.09
c59 ( 23 0 ) capacitor c=0.154218f //x=1.825 //y=6.2
c60 ( 22 0 ) capacitor c=0.154243f //x=1.385 //y=6.2
c61 ( 9 0 ) capacitor c=0.114635f //x=1.23 //y=2.265
r62 (  44 45 ) resistor r=17.5563 //w=0.302 //l=0.11 //layer=ply \
 //thickness=0.18 //x=1.23 //y=2.265 //x2=1.34 //y2=2.265
r63 (  42 51 ) resistor r=45.1352 //w=0.168 //l=0.173853 //layer=ply \
 //thickness=0.18 //x=1.87 //y=1.435 //x2=1.83 //y2=1.59
r64 (  41 50 ) resistor r=45.1352 //w=0.168 //l=0.173853 //layer=ply \
 //thickness=0.18 //x=1.87 //y=1.09 //x2=1.83 //y2=0.935
r65 (  41 42 ) resistor r=176.904 //w=0.094 //l=0.345 //layer=ply \
 //thickness=0.18 //x=1.87 //y=1.09 //x2=1.87 //y2=1.435
r66 (  36 49 ) resistor r=10.701 //w=0.21 //l=0.115 //layer=ply \
 //thickness=0.18 //x=1.495 //y=1.59 //x2=1.38 //y2=1.59
r67 (  35 51 ) resistor r=5.52526 //w=0.168 //l=0.115 //layer=ply \
 //thickness=0.18 //x=1.715 //y=1.59 //x2=1.83 //y2=1.59
r68 (  34 48 ) resistor r=5.52526 //w=0.168 //l=0.115 //layer=ply \
 //thickness=0.18 //x=1.495 //y=0.935 //x2=1.38 //y2=0.935
r69 (  33 50 ) resistor r=5.52526 //w=0.168 //l=0.115 //layer=ply \
 //thickness=0.18 //x=1.715 //y=0.935 //x2=1.83 //y2=0.935
r70 (  33 34 ) resistor r=112.809 //w=0.094 //l=0.22 //layer=ply \
 //thickness=0.18 //x=1.715 //y=0.935 //x2=1.495 //y2=0.935
r71 (  31 38 ) resistor r=26.9307 //w=0.15 //l=0.106066 //layer=ply \
 //thickness=0.18 //x=1.75 //y=4.97 //x2=1.825 //y2=5.045
r72 (  31 32 ) resistor r=148.702 //w=0.094 //l=0.29 //layer=ply \
 //thickness=0.18 //x=1.75 //y=4.97 //x2=1.46 //y2=4.97
r73 (  28 32 ) resistor r=23.403 //w=0.284 //l=0.106066 //layer=ply \
 //thickness=0.18 //x=1.385 //y=5.045 //x2=1.46 //y2=4.97
r74 (  28 47 ) resistor r=26.3063 //w=0.284 //l=0.229783 //layer=ply \
 //thickness=0.18 //x=1.385 //y=5.045 //x2=1.23 //y2=4.88
r75 (  27 45 ) resistor r=19.1248 //w=0.302 //l=0.165 //layer=ply \
 //thickness=0.18 //x=1.34 //y=2.1 //x2=1.34 //y2=2.265
r76 (  26 49 ) resistor r=39.5823 //w=0.21 //l=0.173853 //layer=ply \
 //thickness=0.18 //x=1.34 //y=1.745 //x2=1.38 //y2=1.59
r77 (  26 27 ) resistor r=182.032 //w=0.094 //l=0.355 //layer=ply \
 //thickness=0.18 //x=1.34 //y=1.745 //x2=1.34 //y2=2.1
r78 (  25 49 ) resistor r=39.5823 //w=0.21 //l=0.173853 //layer=ply \
 //thickness=0.18 //x=1.34 //y=1.435 //x2=1.38 //y2=1.59
r79 (  24 48 ) resistor r=45.1352 //w=0.168 //l=0.173853 //layer=ply \
 //thickness=0.18 //x=1.34 //y=1.09 //x2=1.38 //y2=0.935
r80 (  24 25 ) resistor r=176.904 //w=0.094 //l=0.345 //layer=ply \
 //thickness=0.18 //x=1.34 //y=1.09 //x2=1.34 //y2=1.435
r81 (  23 38 ) resistor r=592.245 //w=0.094 //l=1.155 //layer=ply \
 //thickness=0.18 //x=1.825 //y=6.2 //x2=1.825 //y2=5.045
r82 (  22 28 ) resistor r=592.245 //w=0.094 //l=1.155 //layer=ply \
 //thickness=0.18 //x=1.385 //y=6.2 //x2=1.385 //y2=5.045
r83 (  21 35 ) resistor r=56.4043 //w=0.094 //l=0.11 //layer=ply \
 //thickness=0.18 //x=1.605 //y=1.59 //x2=1.715 //y2=1.59
r84 (  21 36 ) resistor r=56.4043 //w=0.094 //l=0.11 //layer=ply \
 //thickness=0.18 //x=1.605 //y=1.59 //x2=1.495 //y2=1.59
r85 (  19 47 ) resistor r=152 //w=0.17 //l=0.17 //layer=licon //count=1 \
 //x=1.23 //y=4.88 //x2=1.23 //y2=4.88
r86 (  9 44 ) resistor r=152 //w=0.17 //l=0.17 //layer=licon //count=1 \
 //x=1.23 //y=2.265 //x2=1.23 //y2=2.265
r87 (  7 19 ) resistor r=17.7968 //w=0.187 //l=0.26 //layer=li //thickness=0.1 \
 //x=1.23 //y=4.62 //x2=1.23 //y2=4.88
r88 (  6 7 ) resistor r=25.3262 //w=0.187 //l=0.37 //layer=li //thickness=0.1 \
 //x=1.23 //y=4.25 //x2=1.23 //y2=4.62
r89 (  5 6 ) resistor r=25.3262 //w=0.187 //l=0.37 //layer=li //thickness=0.1 \
 //x=1.23 //y=3.88 //x2=1.23 //y2=4.25
r90 (  4 5 ) resistor r=25.3262 //w=0.187 //l=0.37 //layer=li //thickness=0.1 \
 //x=1.23 //y=3.51 //x2=1.23 //y2=3.88
r91 (  3 4 ) resistor r=25.3262 //w=0.187 //l=0.37 //layer=li //thickness=0.1 \
 //x=1.23 //y=3.14 //x2=1.23 //y2=3.51
r92 (  2 3 ) resistor r=25.3262 //w=0.187 //l=0.37 //layer=li //thickness=0.1 \
 //x=1.23 //y=2.77 //x2=1.23 //y2=3.14
r93 (  1 2 ) resistor r=25.3262 //w=0.187 //l=0.37 //layer=li //thickness=0.1 \
 //x=1.23 //y=2.4 //x2=1.23 //y2=2.77
r94 (  1 9 ) resistor r=9.24064 //w=0.187 //l=0.135 //layer=li //thickness=0.1 \
 //x=1.23 //y=2.4 //x2=1.23 //y2=2.265
ends PM_BUFX1\%A

subckt PM_BUFX1\%Y ( 1 2 3 4 5 6 7 18 19 20 21 31 33 )
c43 ( 33 0 ) capacitor c=0.028734f //x=3.68 //y=5.2
c44 ( 31 0 ) capacitor c=0.0173218f //x=3.635 //y=1.09
c45 ( 21 0 ) capacitor c=0.00575887f //x=3.91 //y=4.76
c46 ( 20 0 ) capacitor c=0.0146395f //x=4.105 //y=4.76
c47 ( 19 0 ) capacitor c=0.00636159f //x=3.905 //y=2.26
c48 ( 18 0 ) capacitor c=0.0141837f //x=4.105 //y=2.26
c49 ( 1 0 ) capacitor c=0.105613f //x=4.19 //y=2.4
r50 (  20 23 ) resistor r=7.15173 //w=0.17 //l=0.120208 //layer=li \
 //thickness=0.1 //x=4.105 //y=4.76 //x2=4.19 //y2=4.675
r51 (  20 21 ) resistor r=13.3476 //w=0.187 //l=0.195 //layer=li \
 //thickness=0.1 //x=4.105 //y=4.76 //x2=3.91 //y2=4.76
r52 (  18 22 ) resistor r=7.15173 //w=0.17 //l=0.120208 //layer=li \
 //thickness=0.1 //x=4.105 //y=2.26 //x2=4.19 //y2=2.345
r53 (  18 19 ) resistor r=13.6898 //w=0.187 //l=0.2 //layer=li //thickness=0.1 \
 //x=4.105 //y=2.26 //x2=3.905 //y2=2.26
r54 (  12 21 ) resistor r=7.15173 //w=0.17 //l=0.120208 //layer=li \
 //thickness=0.1 //x=3.825 //y=4.845 //x2=3.91 //y2=4.76
r55 (  12 33 ) resistor r=72.5562 //w=0.187 //l=1.06 //layer=li \
 //thickness=0.1 //x=3.825 //y=4.845 //x2=3.825 //y2=5.905
r56 (  8 19 ) resistor r=7.15173 //w=0.17 //l=0.120208 //layer=li \
 //thickness=0.1 //x=3.82 //y=2.175 //x2=3.905 //y2=2.26
r57 (  8 31 ) resistor r=67.7647 //w=0.187 //l=0.99 //layer=li //thickness=0.1 \
 //x=3.82 //y=2.175 //x2=3.82 //y2=1.185
r58 (  7 23 ) resistor r=3.76471 //w=0.187 //l=0.055 //layer=li \
 //thickness=0.1 //x=4.19 //y=4.62 //x2=4.19 //y2=4.675
r59 (  6 7 ) resistor r=25.3262 //w=0.187 //l=0.37 //layer=li //thickness=0.1 \
 //x=4.19 //y=4.25 //x2=4.19 //y2=4.62
r60 (  5 6 ) resistor r=25.3262 //w=0.187 //l=0.37 //layer=li //thickness=0.1 \
 //x=4.19 //y=3.88 //x2=4.19 //y2=4.25
r61 (  4 5 ) resistor r=25.3262 //w=0.187 //l=0.37 //layer=li //thickness=0.1 \
 //x=4.19 //y=3.51 //x2=4.19 //y2=3.88
r62 (  3 4 ) resistor r=25.3262 //w=0.187 //l=0.37 //layer=li //thickness=0.1 \
 //x=4.19 //y=3.14 //x2=4.19 //y2=3.51
r63 (  2 3 ) resistor r=25.3262 //w=0.187 //l=0.37 //layer=li //thickness=0.1 \
 //x=4.19 //y=2.77 //x2=4.19 //y2=3.14
r64 (  1 2 ) resistor r=25.3262 //w=0.187 //l=0.37 //layer=li //thickness=0.1 \
 //x=4.19 //y=2.4 //x2=4.19 //y2=2.77
r65 (  1 22 ) resistor r=3.76471 //w=0.187 //l=0.055 //layer=li \
 //thickness=0.1 //x=4.19 //y=2.4 //x2=4.19 //y2=2.345
ends PM_BUFX1\%Y
