// File: BUFX1.spi.pex
// Created: Sun Mar 15 12:39:35 2026
// Program "Calibre xRC"
// Version "v2023.2_27.15"
// Nominal Temperature: 30C
// Circuit Temperature: 30C
//
simulator lang=spectre
subckt PM_BUFX1\%noxref_1 ( 2 4 5 6 7 8 10 11 12 14 15 16 18 23 27 31 40 42 43 \
 51 63 72 76 77 78 79 80 81 82 86 87 88 90 96 97 99 107 109 )
c177 ( 107 0 ) capacitor c=0.00869746f //x=1.415 //y=1.09
c178 ( 99 0 ) capacitor c=0.0555104f //x=3.45 //y=2.265
c179 ( 97 0 ) capacitor c=0.0439576f //x=4.09 //y=1.435
c180 ( 96 0 ) capacitor c=0.0201087f //x=4.09 //y=1.09
c181 ( 90 0 ) capacitor c=0.0161986f //x=3.935 //y=1.59
c182 ( 88 0 ) capacitor c=0.0157807f //x=3.935 //y=0.935
c183 ( 87 0 ) capacitor c=0.0557874f //x=3.68 //y=4.97
c184 ( 86 0 ) capacitor c=0.0406047f //x=3.97 //y=4.97
c185 ( 82 0 ) capacitor c=0.0301471f //x=3.56 //y=2.1
c186 ( 81 0 ) capacitor c=0.0255349f //x=3.56 //y=1.745
c187 ( 80 0 ) capacitor c=0.0234346f //x=3.56 //y=1.435
c188 ( 79 0 ) capacitor c=0.02013f //x=3.56 //y=1.09
c189 ( 78 0 ) capacitor c=0.153839f //x=4.045 //y=6.2
c190 ( 77 0 ) capacitor c=0.15434f //x=3.605 //y=6.2
c191 ( 72 0 ) capacitor c=9.4527e-19 //x=3.45 //y=4.88
c192 ( 63 0 ) capacitor c=6.43121e-19 //x=3.45 //y=2.265
c193 ( 51 0 ) capacitor c=0.0263113f //x=1.605 //y=5.56
c194 ( 43 0 ) capacitor c=0.0559047f //x=3.29 //y=2.775
c195 ( 42 0 ) capacitor c=0.00449964f //x=3.45 //y=2.775
c196 ( 40 0 ) capacitor c=0.00515997f //x=2.13 //y=2.775
c197 ( 31 0 ) capacitor c=0.0110654f //x=3.45 //y=2.265
c198 ( 27 0 ) capacitor c=0.0123983f //x=3.45 //y=2.77
c199 ( 23 0 ) capacitor c=0.0143255f //x=1.97 //y=2.77
c200 ( 18 0 ) capacitor c=0.0188628f //x=1.6 //y=1.185
c201 ( 16 0 ) capacitor c=0.0606876f //x=3.45 //y=4.76
c202 ( 15 0 ) capacitor c=0.0116361f //x=3.45 //y=2.935
c203 ( 14 0 ) capacitor c=0.00275838f //x=3.45 //y=2.615
c204 ( 12 0 ) capacitor c=0.0599826f //x=1.97 //y=5.055
c205 ( 11 0 ) capacitor c=0.0118609f //x=1.97 //y=2.935
c206 ( 10 0 ) capacitor c=0.00921769f //x=1.97 //y=2.615
c207 ( 8 0 ) capacitor c=0.00714889f //x=1.69 //y=5.14
c208 ( 7 0 ) capacitor c=0.00753338f //x=1.885 //y=5.14
c209 ( 6 0 ) capacitor c=0.00882254f //x=1.685 //y=2.02
c210 ( 5 0 ) capacitor c=0.0115297f //x=1.885 //y=2.02
c211 ( 4 0 ) capacitor c=0.0119211f //x=1.605 //y=5.42
c212 ( 2 0 ) capacitor c=0.0170679f //x=1.6 //y=1.935
r213 (  99 100 ) resistor r=17.5563 //w=0.302 //l=0.11 //layer=ply \
 //thickness=0.18 //x=3.45 //y=2.265 //x2=3.56 //y2=2.265
r214 (  97 106 ) resistor r=45.1352 //w=0.168 //l=0.173853 //layer=ply \
 //thickness=0.18 //x=4.09 //y=1.435 //x2=4.05 //y2=1.59
r215 (  96 105 ) resistor r=45.1352 //w=0.168 //l=0.173853 //layer=ply \
 //thickness=0.18 //x=4.09 //y=1.09 //x2=4.05 //y2=0.935
r216 (  96 97 ) resistor r=176.904 //w=0.094 //l=0.345 //layer=ply \
 //thickness=0.18 //x=4.09 //y=1.09 //x2=4.09 //y2=1.435
r217 (  91 104 ) resistor r=10.701 //w=0.21 //l=0.115 //layer=ply \
 //thickness=0.18 //x=3.715 //y=1.59 //x2=3.6 //y2=1.59
r218 (  90 106 ) resistor r=5.52526 //w=0.168 //l=0.115 //layer=ply \
 //thickness=0.18 //x=3.935 //y=1.59 //x2=4.05 //y2=1.59
r219 (  89 103 ) resistor r=5.52526 //w=0.168 //l=0.115 //layer=ply \
 //thickness=0.18 //x=3.715 //y=0.935 //x2=3.6 //y2=0.935
r220 (  88 105 ) resistor r=5.52526 //w=0.168 //l=0.115 //layer=ply \
 //thickness=0.18 //x=3.935 //y=0.935 //x2=4.05 //y2=0.935
r221 (  88 89 ) resistor r=112.809 //w=0.094 //l=0.22 //layer=ply \
 //thickness=0.18 //x=3.935 //y=0.935 //x2=3.715 //y2=0.935
r222 (  86 93 ) resistor r=26.9307 //w=0.15 //l=0.106066 //layer=ply \
 //thickness=0.18 //x=3.97 //y=4.97 //x2=4.045 //y2=5.045
r223 (  86 87 ) resistor r=148.702 //w=0.094 //l=0.29 //layer=ply \
 //thickness=0.18 //x=3.97 //y=4.97 //x2=3.68 //y2=4.97
r224 (  83 87 ) resistor r=23.403 //w=0.284 //l=0.106066 //layer=ply \
 //thickness=0.18 //x=3.605 //y=5.045 //x2=3.68 //y2=4.97
r225 (  83 102 ) resistor r=26.3063 //w=0.284 //l=0.229783 //layer=ply \
 //thickness=0.18 //x=3.605 //y=5.045 //x2=3.45 //y2=4.88
r226 (  82 100 ) resistor r=19.1248 //w=0.302 //l=0.165 //layer=ply \
 //thickness=0.18 //x=3.56 //y=2.1 //x2=3.56 //y2=2.265
r227 (  81 104 ) resistor r=39.5823 //w=0.21 //l=0.173853 //layer=ply \
 //thickness=0.18 //x=3.56 //y=1.745 //x2=3.6 //y2=1.59
r228 (  81 82 ) resistor r=182.032 //w=0.094 //l=0.355 //layer=ply \
 //thickness=0.18 //x=3.56 //y=1.745 //x2=3.56 //y2=2.1
r229 (  80 104 ) resistor r=39.5823 //w=0.21 //l=0.173853 //layer=ply \
 //thickness=0.18 //x=3.56 //y=1.435 //x2=3.6 //y2=1.59
r230 (  79 103 ) resistor r=45.1352 //w=0.168 //l=0.173853 //layer=ply \
 //thickness=0.18 //x=3.56 //y=1.09 //x2=3.6 //y2=0.935
r231 (  79 80 ) resistor r=176.904 //w=0.094 //l=0.345 //layer=ply \
 //thickness=0.18 //x=3.56 //y=1.09 //x2=3.56 //y2=1.435
r232 (  78 93 ) resistor r=592.245 //w=0.094 //l=1.155 //layer=ply \
 //thickness=0.18 //x=4.045 //y=6.2 //x2=4.045 //y2=5.045
r233 (  77 83 ) resistor r=592.245 //w=0.094 //l=1.155 //layer=ply \
 //thickness=0.18 //x=3.605 //y=6.2 //x2=3.605 //y2=5.045
r234 (  76 90 ) resistor r=56.4043 //w=0.094 //l=0.11 //layer=ply \
 //thickness=0.18 //x=3.825 //y=1.59 //x2=3.935 //y2=1.59
r235 (  76 91 ) resistor r=56.4043 //w=0.094 //l=0.11 //layer=ply \
 //thickness=0.18 //x=3.825 //y=1.59 //x2=3.715 //y2=1.59
r236 (  72 102 ) resistor r=152 //w=0.17 //l=0.17 //layer=licon //count=1 \
 //x=3.45 //y=4.88 //x2=3.45 //y2=4.88
r237 (  63 99 ) resistor r=152 //w=0.17 //l=0.17 //layer=licon //count=1 \
 //x=3.45 //y=2.265 //x2=3.45 //y2=2.265
r238 (  51 109 ) resistor r=23.615 //w=0.187 //l=0.345 //layer=li \
 //thickness=0.1 //x=1.605 //y=5.56 //x2=1.605 //y2=5.905
r239 (  42 43 ) resistor r=0.10734 //w=0.281 //l=0.16 //layer=m2 \
 //thickness=0.36 //x=3.45 //y=2.775 //x2=3.29 //y2=2.775
r240 (  40 43 ) resistor r=1.10687 //w=0.131 //l=1.16 //layer=m2 \
 //thickness=0.36 //x=2.13 //y=2.77 //x2=3.29 //y2=2.77
r241 (  38 40 ) resistor r=0.10734 //w=0.281 //l=0.16 //layer=m2 \
 //thickness=0.36 //x=1.97 //y=2.775 //x2=2.13 //y2=2.775
r242 (  34 72 ) resistor r=9.3 //w=0.17 //l=0.17 //layer=mcon //count=1 \
 //x=3.45 //y=4.88 //x2=3.45 //y2=4.88
r243 (  31 63 ) resistor r=9.3 //w=0.17 //l=0.17 //layer=mcon //count=1 \
 //x=3.45 //y=2.265 //x2=3.45 //y2=2.265
r244 (  29 42 ) resistor r=4.5 //w=0.15 //l=0.15 //layer=via1 //count=1 \
 //x=3.45 //y=2.775 //x2=3.45 //y2=2.775
r245 (  27 29 ) resistor r=0.00166223 //w=0.376 //l=0.005 //layer=m1 \
 //thickness=0.36 //x=3.397 //y=2.77 //x2=3.397 //y2=2.775
r246 (  25 38 ) resistor r=4.5 //w=0.15 //l=0.15 //layer=via1 //count=1 \
 //x=1.97 //y=2.775 //x2=1.97 //y2=2.775
r247 (  23 25 ) resistor r=0.00166223 //w=0.376 //l=0.005 //layer=m1 \
 //thickness=0.36 //x=2.022 //y=2.77 //x2=2.022 //y2=2.775
r248 (  21 51 ) resistor r=9.3 //w=0.17 //l=0.17 //layer=mcon //count=1 \
 //x=1.605 //y=5.56 //x2=1.605 //y2=5.56
r249 (  18 107 ) resistor r=9.3 //w=0.17 //l=0.17 //layer=mcon //count=1 \
 //x=1.6 //y=1.185 //x2=1.6 //y2=1.185
r250 (  16 34 ) resistor r=0.0732479 //w=0.241 //l=0.122474 //layer=m1 \
 //thickness=0.36 //x=3.45 //y=4.76 //x2=3.455 //y2=4.88
r251 (  15 29 ) resistor r=0.0911593 //w=0.376 //l=0.184608 //layer=m1 \
 //thickness=0.36 //x=3.45 //y=2.935 //x2=3.397 //y2=2.775
r252 (  15 16 ) resistor r=1.74141 //w=0.131 //l=1.825 //layer=m1 \
 //thickness=0.36 //x=3.45 //y=2.935 //x2=3.45 //y2=4.76
r253 (  14 27 ) resistor r=0.0894971 //w=0.376 //l=0.179555 //layer=m1 \
 //thickness=0.36 //x=3.45 //y=2.615 //x2=3.397 //y2=2.77
r254 (  13 31 ) resistor r=0.116051 //w=0.211 //l=0.165 //layer=m1 \
 //thickness=0.36 //x=3.45 //y=2.43 //x2=3.45 //y2=2.265
r255 (  13 14 ) resistor r=0.176527 //w=0.131 //l=0.185 //layer=m1 \
 //thickness=0.36 //x=3.45 //y=2.43 //x2=3.45 //y2=2.615
r256 (  11 25 ) resistor r=0.0911593 //w=0.376 //l=0.184174 //layer=m1 \
 //thickness=0.36 //x=1.97 //y=2.935 //x2=2.022 //y2=2.775
r257 (  11 12 ) resistor r=2.0229 //w=0.131 //l=2.12 //layer=m1 \
 //thickness=0.36 //x=1.97 //y=2.935 //x2=1.97 //y2=5.055
r258 (  10 23 ) resistor r=0.0894971 //w=0.376 //l=0.179123 //layer=m1 \
 //thickness=0.36 //x=1.97 //y=2.615 //x2=2.022 //y2=2.77
r259 (  9 10 ) resistor r=0.486641 //w=0.131 //l=0.51 //layer=m1 \
 //thickness=0.36 //x=1.97 //y=2.105 //x2=1.97 //y2=2.615
r260 (  7 12 ) resistor r=0.0698411 //w=0.17 //l=0.120208 //layer=m1 \
 //thickness=0.36 //x=1.885 //y=5.14 //x2=1.97 //y2=5.055
r261 (  7 8 ) resistor r=0.186069 //w=0.131 //l=0.195 //layer=m1 \
 //thickness=0.36 //x=1.885 //y=5.14 //x2=1.69 //y2=5.14
r262 (  5 9 ) resistor r=0.0698411 //w=0.17 //l=0.120208 //layer=m1 \
 //thickness=0.36 //x=1.885 //y=2.02 //x2=1.97 //y2=2.105
r263 (  5 6 ) resistor r=0.19084 //w=0.131 //l=0.2 //layer=m1 //thickness=0.36 \
 //x=1.885 //y=2.02 //x2=1.685 //y2=2.02
r264 (  4 21 ) resistor r=0.086672 //w=0.218 //l=0.14 //layer=m1 \
 //thickness=0.36 //x=1.605 //y=5.42 //x2=1.605 //y2=5.56
r265 (  3 8 ) resistor r=0.0698411 //w=0.17 //l=0.120208 //layer=m1 \
 //thickness=0.36 //x=1.605 //y=5.225 //x2=1.69 //y2=5.14
r266 (  3 4 ) resistor r=0.186069 //w=0.131 //l=0.195 //layer=m1 \
 //thickness=0.36 //x=1.605 //y=5.225 //x2=1.605 //y2=5.42
r267 (  2 6 ) resistor r=0.0698411 //w=0.17 //l=0.120208 //layer=m1 \
 //thickness=0.36 //x=1.6 //y=1.935 //x2=1.685 //y2=2.02
r268 (  1 18 ) resistor r=0.105739 //w=0.201 //l=0.145 //layer=m1 \
 //thickness=0.36 //x=1.6 //y=1.33 //x2=1.6 //y2=1.185
r269 (  1 2 ) resistor r=0.57729 //w=0.131 //l=0.605 //layer=m1 \
 //thickness=0.36 //x=1.6 //y=1.33 //x2=1.6 //y2=1.935
ends PM_BUFX1\%noxref_1

subckt PM_BUFX1\%GND ( 1 11 23 27 49 53 64 67 78 89 90 )
c94 ( 90 0 ) capacitor c=0.0650127f //x=3.205 //y=0.55
c95 ( 89 0 ) capacitor c=0.0633658f //x=0.985 //y=0.55
c96 ( 78 0 ) capacitor c=0.102087f //x=2.71 //y=0.175
c97 ( 67 0 ) capacitor c=0.215034f //x=1.12 //y=0.175
c98 ( 64 0 ) capacitor c=0.220216f //x=4.56 //y=0.18
c99 ( 62 0 ) capacitor c=0.0366946f //x=4.395 //y=0.175
c100 ( 56 0 ) capacitor c=0.00589014f //x=4.31 //y=0.63
c101 ( 53 0 ) capacitor c=0.00625302f //x=4.225 //y=0.715
c102 ( 52 0 ) capacitor c=0.00479851f //x=3.82 //y=0.63
c103 ( 49 0 ) capacitor c=0.00633284f //x=3.735 //y=0.715
c104 ( 44 0 ) capacitor c=0.00590583f //x=3.34 //y=0.63
c105 ( 41 0 ) capacitor c=0.0190699f //x=3.255 //y=0.175
c106 ( 36 0 ) capacitor c=0.0366946f //x=2.175 //y=0.175
c107 ( 35 0 ) capacitor c=0.0185573f //x=2.54 //y=0.175
c108 ( 30 0 ) capacitor c=0.00589014f //x=2.09 //y=0.63
c109 ( 27 0 ) capacitor c=0.00605867f //x=2.005 //y=0.715
c110 ( 26 0 ) capacitor c=0.00479851f //x=1.6 //y=0.63
c111 ( 23 0 ) capacitor c=0.0064899f //x=1.515 //y=0.715
c112 ( 18 0 ) capacitor c=0.00590583f //x=1.12 //y=0.63
c113 ( 11 0 ) capacitor c=0.22411f //x=4.56 //y=0.18
r114 (  81 82 ) resistor r=17.0899 //w=0.367 //l=0.49 //layer=li \
 //thickness=0.1 //x=3.82 //y=0.175 //x2=4.31 //y2=0.175
r115 (  79 81 ) resistor r=16.7411 //w=0.367 //l=0.48 //layer=li \
 //thickness=0.1 //x=3.34 //y=0.175 //x2=3.82 //y2=0.175
r116 (  70 71 ) resistor r=17.0899 //w=0.367 //l=0.49 //layer=li \
 //thickness=0.1 //x=1.6 //y=0.175 //x2=2.09 //y2=0.175
r117 (  69 70 ) resistor r=12.9046 //w=0.367 //l=0.37 //layer=li \
 //thickness=0.1 //x=1.23 //y=0.175 //x2=1.6 //y2=0.175
r118 (  67 69 ) resistor r=3.83651 //w=0.367 //l=0.11 //layer=li \
 //thickness=0.1 //x=1.12 //y=0.175 //x2=1.23 //y2=0.175
r119 (  62 82 ) resistor r=2.96458 //w=0.367 //l=0.085 //layer=li \
 //thickness=0.1 //x=4.395 //y=0.175 //x2=4.31 //y2=0.175
r120 (  62 64 ) resistor r=5.75477 //w=0.367 //l=0.165 //layer=li \
 //thickness=0.1 //x=4.395 //y=0.175 //x2=4.56 //y2=0.175
r121 (  57 90 ) resistor r=5.4201 //w=0.17 //l=0.085 //layer=li \
 //thickness=0.1 //x=4.31 //y=0.8 //x2=4.31 //y2=0.715
r122 (  57 90 ) resistor r=41.4118 //w=0.187 //l=0.605 //layer=li \
 //thickness=0.1 //x=4.31 //y=0.8 //x2=4.31 //y2=1.405
r123 (  56 90 ) resistor r=5.4201 //w=0.17 //l=0.085 //layer=li \
 //thickness=0.1 //x=4.31 //y=0.63 //x2=4.31 //y2=0.715
r124 (  55 82 ) resistor r=5.21862 //w=0.35 //l=0.175 //layer=li \
 //thickness=0.1 //x=4.31 //y=0.35 //x2=4.31 //y2=0.175
r125 (  55 56 ) resistor r=19.1658 //w=0.187 //l=0.28 //layer=li \
 //thickness=0.1 //x=4.31 //y=0.35 //x2=4.31 //y2=0.63
r126 (  54 90 ) resistor r=5.4201 //w=0.17 //l=0.085 //layer=li \
 //thickness=0.1 //x=3.905 //y=0.715 //x2=3.82 //y2=0.715
r127 (  53 90 ) resistor r=1.40859 //w=0.34 //l=0.085 //layer=li \
 //thickness=0.1 //x=4.225 //y=0.715 //x2=4.31 //y2=0.715
r128 (  53 54 ) resistor r=21.9037 //w=0.187 //l=0.32 //layer=li \
 //thickness=0.1 //x=4.225 //y=0.715 //x2=3.905 //y2=0.715
r129 (  52 90 ) resistor r=1.40859 //w=0.34 //l=0.085 //layer=li \
 //thickness=0.1 //x=3.82 //y=0.63 //x2=3.82 //y2=0.715
r130 (  51 81 ) resistor r=5.21862 //w=0.35 //l=0.175 //layer=li \
 //thickness=0.1 //x=3.82 //y=0.35 //x2=3.82 //y2=0.175
r131 (  51 52 ) resistor r=19.1658 //w=0.187 //l=0.28 //layer=li \
 //thickness=0.1 //x=3.82 //y=0.35 //x2=3.82 //y2=0.63
r132 (  50 90 ) resistor r=1.40859 //w=0.34 //l=0.085 //layer=li \
 //thickness=0.1 //x=3.425 //y=0.715 //x2=3.34 //y2=0.715
r133 (  49 90 ) resistor r=5.4201 //w=0.17 //l=0.085 //layer=li \
 //thickness=0.1 //x=3.735 //y=0.715 //x2=3.82 //y2=0.715
r134 (  49 50 ) resistor r=21.2193 //w=0.187 //l=0.31 //layer=li \
 //thickness=0.1 //x=3.735 //y=0.715 //x2=3.425 //y2=0.715
r135 (  45 90 ) resistor r=5.4201 //w=0.17 //l=0.085 //layer=li \
 //thickness=0.1 //x=3.34 //y=0.8 //x2=3.34 //y2=0.715
r136 (  45 90 ) resistor r=41.4118 //w=0.187 //l=0.605 //layer=li \
 //thickness=0.1 //x=3.34 //y=0.8 //x2=3.34 //y2=1.405
r137 (  44 90 ) resistor r=5.4201 //w=0.17 //l=0.085 //layer=li \
 //thickness=0.1 //x=3.34 //y=0.63 //x2=3.34 //y2=0.715
r138 (  43 79 ) resistor r=5.21862 //w=0.35 //l=0.175 //layer=li \
 //thickness=0.1 //x=3.34 //y=0.35 //x2=3.34 //y2=0.175
r139 (  43 44 ) resistor r=19.1658 //w=0.187 //l=0.28 //layer=li \
 //thickness=0.1 //x=3.34 //y=0.35 //x2=3.34 //y2=0.63
r140 (  42 78 ) resistor r=5.29055 //w=0.35 //l=0.17 //layer=li \
 //thickness=0.1 //x=2.88 //y=0.175 //x2=2.71 //y2=0.175
r141 (  41 79 ) resistor r=2.96458 //w=0.367 //l=0.085 //layer=li \
 //thickness=0.1 //x=3.255 //y=0.175 //x2=3.34 //y2=0.175
r142 (  41 42 ) resistor r=13.079 //w=0.367 //l=0.375 //layer=li \
 //thickness=0.1 //x=3.255 //y=0.175 //x2=2.88 //y2=0.175
r143 (  36 71 ) resistor r=2.96458 //w=0.367 //l=0.085 //layer=li \
 //thickness=0.1 //x=2.175 //y=0.175 //x2=2.09 //y2=0.175
r144 (  36 38 ) resistor r=5.75477 //w=0.367 //l=0.165 //layer=li \
 //thickness=0.1 //x=2.175 //y=0.175 //x2=2.34 //y2=0.175
r145 (  35 78 ) resistor r=5.29055 //w=0.35 //l=0.17 //layer=li \
 //thickness=0.1 //x=2.54 //y=0.175 //x2=2.71 //y2=0.175
r146 (  35 38 ) resistor r=6.97548 //w=0.367 //l=0.2 //layer=li \
 //thickness=0.1 //x=2.54 //y=0.175 //x2=2.34 //y2=0.175
r147 (  31 89 ) resistor r=5.4201 //w=0.17 //l=0.085 //layer=li \
 //thickness=0.1 //x=2.09 //y=0.8 //x2=2.09 //y2=0.715
r148 (  31 89 ) resistor r=41.4118 //w=0.187 //l=0.605 //layer=li \
 //thickness=0.1 //x=2.09 //y=0.8 //x2=2.09 //y2=1.405
r149 (  30 89 ) resistor r=5.4201 //w=0.17 //l=0.085 //layer=li \
 //thickness=0.1 //x=2.09 //y=0.63 //x2=2.09 //y2=0.715
r150 (  29 71 ) resistor r=5.21862 //w=0.35 //l=0.175 //layer=li \
 //thickness=0.1 //x=2.09 //y=0.35 //x2=2.09 //y2=0.175
r151 (  29 30 ) resistor r=19.1658 //w=0.187 //l=0.28 //layer=li \
 //thickness=0.1 //x=2.09 //y=0.35 //x2=2.09 //y2=0.63
r152 (  28 89 ) resistor r=5.4201 //w=0.17 //l=0.085 //layer=li \
 //thickness=0.1 //x=1.685 //y=0.715 //x2=1.6 //y2=0.715
r153 (  27 89 ) resistor r=1.40859 //w=0.34 //l=0.085 //layer=li \
 //thickness=0.1 //x=2.005 //y=0.715 //x2=2.09 //y2=0.715
r154 (  27 28 ) resistor r=21.9037 //w=0.187 //l=0.32 //layer=li \
 //thickness=0.1 //x=2.005 //y=0.715 //x2=1.685 //y2=0.715
r155 (  26 89 ) resistor r=1.40859 //w=0.34 //l=0.085 //layer=li \
 //thickness=0.1 //x=1.6 //y=0.63 //x2=1.6 //y2=0.715
r156 (  25 70 ) resistor r=5.21862 //w=0.35 //l=0.175 //layer=li \
 //thickness=0.1 //x=1.6 //y=0.35 //x2=1.6 //y2=0.175
r157 (  25 26 ) resistor r=19.1658 //w=0.187 //l=0.28 //layer=li \
 //thickness=0.1 //x=1.6 //y=0.35 //x2=1.6 //y2=0.63
r158 (  24 89 ) resistor r=1.40859 //w=0.34 //l=0.085 //layer=li \
 //thickness=0.1 //x=1.205 //y=0.715 //x2=1.12 //y2=0.715
r159 (  23 89 ) resistor r=5.4201 //w=0.17 //l=0.085 //layer=li \
 //thickness=0.1 //x=1.515 //y=0.715 //x2=1.6 //y2=0.715
r160 (  23 24 ) resistor r=21.2193 //w=0.187 //l=0.31 //layer=li \
 //thickness=0.1 //x=1.515 //y=0.715 //x2=1.205 //y2=0.715
r161 (  19 89 ) resistor r=5.4201 //w=0.17 //l=0.085 //layer=li \
 //thickness=0.1 //x=1.12 //y=0.8 //x2=1.12 //y2=0.715
r162 (  19 89 ) resistor r=41.4118 //w=0.187 //l=0.605 //layer=li \
 //thickness=0.1 //x=1.12 //y=0.8 //x2=1.12 //y2=1.405
r163 (  18 89 ) resistor r=5.4201 //w=0.17 //l=0.085 //layer=li \
 //thickness=0.1 //x=1.12 //y=0.63 //x2=1.12 //y2=0.715
r164 (  17 67 ) resistor r=5.21862 //w=0.35 //l=0.175 //layer=li \
 //thickness=0.1 //x=1.12 //y=0.35 //x2=1.12 //y2=0.175
r165 (  17 18 ) resistor r=19.1658 //w=0.187 //l=0.28 //layer=li \
 //thickness=0.1 //x=1.12 //y=0.35 //x2=1.12 //y2=0.63
r166 (  11 64 ) resistor r=9.3 //w=0.17 //l=0.17 //layer=mcon //count=1 \
 //x=4.56 //y=0.18 //x2=4.56 //y2=0.18
r167 (  9 81 ) resistor r=3.1 //w=0.17 //l=0.51 //layer=mcon //count=3 \
 //x=3.82 //y=0.18 //x2=3.82 //y2=0.18
r168 (  9 11 ) resistor r=0.297428 //w=0.311 //l=0.74 //layer=m1 \
 //thickness=0.36 //x=3.82 //y=0.175 //x2=4.56 //y2=0.175
r169 (  6 38 ) resistor r=3.1 //w=0.17 //l=0.51 //layer=mcon //count=3 \
 //x=2.34 //y=0.18 //x2=2.34 //y2=0.18
r170 (  3 69 ) resistor r=3.1 //w=0.17 //l=0.51 //layer=mcon //count=3 \
 //x=1.23 //y=0.18 //x2=1.23 //y2=0.18
r171 (  3 6 ) resistor r=0.446141 //w=0.311 //l=1.11 //layer=m1 \
 //thickness=0.36 //x=1.23 //y=0.175 //x2=2.34 //y2=0.175
r172 (  1 9 ) resistor r=0.446141 //w=0.311 //l=1.11 //layer=m1 \
 //thickness=0.36 //x=2.71 //y=0.175 //x2=3.82 //y2=0.175
r173 (  1 6 ) resistor r=0.148714 //w=0.311 //l=0.37 //layer=m1 \
 //thickness=0.36 //x=2.71 //y=0.175 //x2=2.34 //y2=0.175
ends PM_BUFX1\%GND

subckt PM_BUFX1\%VDD ( 1 11 33 59 74 78 80 83 84 85 86 )
c76 ( 86 0 ) capacitor c=0.0632166f //x=4.12 //y=5.2
c77 ( 85 0 ) capacitor c=0.0534541f //x=3.25 //y=5.2
c78 ( 84 0 ) capacitor c=0.055172f //x=1.9 //y=5.2
c79 ( 83 0 ) capacitor c=0.0616797f //x=1.03 //y=5.2
c80 ( 82 0 ) capacitor c=0.00597439f //x=4.265 //y=7.585
c81 ( 81 0 ) capacitor c=0.00597439f //x=3.385 //y=7.585
c82 ( 80 0 ) capacitor c=0.121093f //x=2.71 //y=7.585
c83 ( 79 0 ) capacitor c=0.00597439f //x=2.045 //y=7.585
c84 ( 78 0 ) capacitor c=0.257865f //x=1.23 //y=7.58
c85 ( 74 0 ) capacitor c=0.253559f //x=4.56 //y=7.58
c86 ( 59 0 ) capacitor c=0.0289924f //x=4.18 //y=7.585
c87 ( 49 0 ) capacitor c=0.0217664f //x=3.3 //y=7.585
c88 ( 43 0 ) capacitor c=0.0211939f //x=2.54 //y=7.585
c89 ( 33 0 ) capacitor c=0.0289924f //x=1.96 //y=7.585
c90 ( 11 0 ) capacitor c=0.228271f //x=4.56 //y=7.58
r91 (  72 82 ) resistor r=2.87058 //w=0.35 //l=0.085 //layer=li \
 //thickness=0.1 //x=4.35 //y=7.585 //x2=4.265 //y2=7.585
r92 (  72 74 ) resistor r=7.32425 //w=0.367 //l=0.21 //layer=li \
 //thickness=0.1 //x=4.35 //y=7.585 //x2=4.56 //y2=7.585
r93 (  63 82 ) resistor r=4.23183 //w=0.7 //l=0.175 //layer=li //thickness=0.1 \
 //x=4.265 //y=7.41 //x2=4.265 //y2=7.585
r94 (  63 86 ) resistor r=56.4706 //w=0.187 //l=0.825 //layer=li \
 //thickness=0.1 //x=4.265 //y=7.41 //x2=4.265 //y2=6.585
r95 (  60 81 ) resistor r=2.87058 //w=0.35 //l=0.085 //layer=li \
 //thickness=0.1 //x=3.47 //y=7.585 //x2=3.385 //y2=7.585
r96 (  60 62 ) resistor r=12.2071 //w=0.367 //l=0.35 //layer=li \
 //thickness=0.1 //x=3.47 //y=7.585 //x2=3.82 //y2=7.585
r97 (  59 82 ) resistor r=2.87058 //w=0.35 //l=0.085 //layer=li \
 //thickness=0.1 //x=4.18 //y=7.585 //x2=4.265 //y2=7.585
r98 (  59 62 ) resistor r=12.5559 //w=0.367 //l=0.36 //layer=li \
 //thickness=0.1 //x=4.18 //y=7.585 //x2=3.82 //y2=7.585
r99 (  51 81 ) resistor r=4.23183 //w=0.7 //l=0.175 //layer=li //thickness=0.1 \
 //x=3.385 //y=7.41 //x2=3.385 //y2=7.585
r100 (  51 85 ) resistor r=56.4706 //w=0.187 //l=0.825 //layer=li \
 //thickness=0.1 //x=3.385 //y=7.41 //x2=3.385 //y2=6.585
r101 (  50 80 ) resistor r=5.29055 //w=0.35 //l=0.17 //layer=li \
 //thickness=0.1 //x=2.88 //y=7.585 //x2=2.71 //y2=7.585
r102 (  49 81 ) resistor r=2.87058 //w=0.35 //l=0.085 //layer=li \
 //thickness=0.1 //x=3.3 //y=7.585 //x2=3.385 //y2=7.585
r103 (  49 50 ) resistor r=14.6485 //w=0.367 //l=0.42 //layer=li \
 //thickness=0.1 //x=3.3 //y=7.585 //x2=2.88 //y2=7.585
r104 (  44 79 ) resistor r=2.87058 //w=0.35 //l=0.085 //layer=li \
 //thickness=0.1 //x=2.13 //y=7.585 //x2=2.045 //y2=7.585
r105 (  44 46 ) resistor r=7.32425 //w=0.367 //l=0.21 //layer=li \
 //thickness=0.1 //x=2.13 //y=7.585 //x2=2.34 //y2=7.585
r106 (  43 80 ) resistor r=5.29055 //w=0.35 //l=0.17 //layer=li \
 //thickness=0.1 //x=2.54 //y=7.585 //x2=2.71 //y2=7.585
r107 (  43 46 ) resistor r=6.97548 //w=0.367 //l=0.2 //layer=li \
 //thickness=0.1 //x=2.54 //y=7.585 //x2=2.34 //y2=7.585
r108 (  35 79 ) resistor r=4.23183 //w=0.7 //l=0.175 //layer=li \
 //thickness=0.1 //x=2.045 //y=7.41 //x2=2.045 //y2=7.585
r109 (  35 84 ) resistor r=56.4706 //w=0.187 //l=0.825 //layer=li \
 //thickness=0.1 //x=2.045 //y=7.41 //x2=2.045 //y2=6.585
r110 (  34 78 ) resistor r=2.87058 //w=0.35 //l=0.085 //layer=li \
 //thickness=0.1 //x=1.25 //y=7.585 //x2=1.165 //y2=7.585
r111 (  33 79 ) resistor r=2.87058 //w=0.35 //l=0.085 //layer=li \
 //thickness=0.1 //x=1.96 //y=7.585 //x2=2.045 //y2=7.585
r112 (  33 34 ) resistor r=24.7629 //w=0.367 //l=0.71 //layer=li \
 //thickness=0.1 //x=1.96 //y=7.585 //x2=1.25 //y2=7.585
r113 (  25 78 ) resistor r=4.23183 //w=0.7 //l=0.175 //layer=li \
 //thickness=0.1 //x=1.165 //y=7.41 //x2=1.165 //y2=7.585
r114 (  25 83 ) resistor r=56.4706 //w=0.187 //l=0.825 //layer=li \
 //thickness=0.1 //x=1.165 //y=7.41 //x2=1.165 //y2=6.585
r115 (  11 74 ) resistor r=9.3 //w=0.17 //l=0.17 //layer=mcon //count=1 \
 //x=4.56 //y=7.58 //x2=4.56 //y2=7.58
r116 (  9 62 ) resistor r=3.1 //w=0.17 //l=0.51 //layer=mcon //count=3 \
 //x=3.82 //y=7.58 //x2=3.82 //y2=7.58
r117 (  9 11 ) resistor r=0.297428 //w=0.311 //l=0.74 //layer=m1 \
 //thickness=0.36 //x=3.82 //y=7.585 //x2=4.56 //y2=7.585
r118 (  6 46 ) resistor r=3.1 //w=0.17 //l=0.51 //layer=mcon //count=3 \
 //x=2.34 //y=7.58 //x2=2.34 //y2=7.58
r119 (  3 78 ) resistor r=3.1 //w=0.17 //l=0.51 //layer=mcon //count=3 \
 //x=1.23 //y=7.58 //x2=1.23 //y2=7.58
r120 (  3 6 ) resistor r=0.446141 //w=0.311 //l=1.11 //layer=m1 \
 //thickness=0.36 //x=1.23 //y=7.585 //x2=2.34 //y2=7.585
r121 (  1 9 ) resistor r=0.446141 //w=0.311 //l=1.11 //layer=m1 \
 //thickness=0.36 //x=2.71 //y=7.585 //x2=3.82 //y2=7.585
r122 (  1 6 ) resistor r=0.148714 //w=0.311 //l=0.37 //layer=m1 \
 //thickness=0.36 //x=2.71 //y=7.585 //x2=2.34 //y2=7.585
ends PM_BUFX1\%VDD

subckt PM_BUFX1\%A ( 1 2 3 4 5 6 7 9 17 23 28 32 33 34 35 36 37 38 42 43 44 46 \
 52 53 55 )
c82 ( 55 0 ) capacitor c=0.0564228f //x=1.23 //y=2.265
c83 ( 53 0 ) capacitor c=0.0439576f //x=1.87 //y=1.435
c84 ( 52 0 ) capacitor c=0.0201087f //x=1.87 //y=1.09
c85 ( 46 0 ) capacitor c=0.0161986f //x=1.715 //y=1.59
c86 ( 44 0 ) capacitor c=0.0157807f //x=1.715 //y=0.935
c87 ( 43 0 ) capacitor c=0.0554306f //x=1.46 //y=4.97
c88 ( 42 0 ) capacitor c=0.0407054f //x=1.75 //y=4.97
c89 ( 38 0 ) capacitor c=0.0301471f //x=1.34 //y=2.1
c90 ( 37 0 ) capacitor c=0.0255349f //x=1.34 //y=1.745
c91 ( 36 0 ) capacitor c=0.0234346f //x=1.34 //y=1.435
c92 ( 35 0 ) capacitor c=0.02013f //x=1.34 //y=1.09
c93 ( 34 0 ) capacitor c=0.153944f //x=1.825 //y=6.2
c94 ( 33 0 ) capacitor c=0.154411f //x=1.385 //y=6.2
c95 ( 28 0 ) capacitor c=9.4527e-19 //x=1.23 //y=4.88
c96 ( 23 0 ) capacitor c=9.11699e-19 //x=1.23 //y=2.265
c97 ( 17 0 ) capacitor c=0.0143254f //x=1.23 //y=2.265
c98 ( 9 0 ) capacitor c=0.0101842f //x=1.23 //y=4.76
c99 ( 1 0 ) capacitor c=0.100715f //x=1.23 //y=2.77
r100 (  55 56 ) resistor r=17.5563 //w=0.302 //l=0.11 //layer=ply \
 //thickness=0.18 //x=1.23 //y=2.265 //x2=1.34 //y2=2.265
r101 (  53 62 ) resistor r=45.1352 //w=0.168 //l=0.173853 //layer=ply \
 //thickness=0.18 //x=1.87 //y=1.435 //x2=1.83 //y2=1.59
r102 (  52 61 ) resistor r=45.1352 //w=0.168 //l=0.173853 //layer=ply \
 //thickness=0.18 //x=1.87 //y=1.09 //x2=1.83 //y2=0.935
r103 (  52 53 ) resistor r=176.904 //w=0.094 //l=0.345 //layer=ply \
 //thickness=0.18 //x=1.87 //y=1.09 //x2=1.87 //y2=1.435
r104 (  47 60 ) resistor r=10.701 //w=0.21 //l=0.115 //layer=ply \
 //thickness=0.18 //x=1.495 //y=1.59 //x2=1.38 //y2=1.59
r105 (  46 62 ) resistor r=5.52526 //w=0.168 //l=0.115 //layer=ply \
 //thickness=0.18 //x=1.715 //y=1.59 //x2=1.83 //y2=1.59
r106 (  45 59 ) resistor r=5.52526 //w=0.168 //l=0.115 //layer=ply \
 //thickness=0.18 //x=1.495 //y=0.935 //x2=1.38 //y2=0.935
r107 (  44 61 ) resistor r=5.52526 //w=0.168 //l=0.115 //layer=ply \
 //thickness=0.18 //x=1.715 //y=0.935 //x2=1.83 //y2=0.935
r108 (  44 45 ) resistor r=112.809 //w=0.094 //l=0.22 //layer=ply \
 //thickness=0.18 //x=1.715 //y=0.935 //x2=1.495 //y2=0.935
r109 (  42 49 ) resistor r=26.9307 //w=0.15 //l=0.106066 //layer=ply \
 //thickness=0.18 //x=1.75 //y=4.97 //x2=1.825 //y2=5.045
r110 (  42 43 ) resistor r=148.702 //w=0.094 //l=0.29 //layer=ply \
 //thickness=0.18 //x=1.75 //y=4.97 //x2=1.46 //y2=4.97
r111 (  39 43 ) resistor r=23.403 //w=0.284 //l=0.106066 //layer=ply \
 //thickness=0.18 //x=1.385 //y=5.045 //x2=1.46 //y2=4.97
r112 (  39 58 ) resistor r=26.3063 //w=0.284 //l=0.229783 //layer=ply \
 //thickness=0.18 //x=1.385 //y=5.045 //x2=1.23 //y2=4.88
r113 (  38 56 ) resistor r=19.1248 //w=0.302 //l=0.165 //layer=ply \
 //thickness=0.18 //x=1.34 //y=2.1 //x2=1.34 //y2=2.265
r114 (  37 60 ) resistor r=39.5823 //w=0.21 //l=0.173853 //layer=ply \
 //thickness=0.18 //x=1.34 //y=1.745 //x2=1.38 //y2=1.59
r115 (  37 38 ) resistor r=182.032 //w=0.094 //l=0.355 //layer=ply \
 //thickness=0.18 //x=1.34 //y=1.745 //x2=1.34 //y2=2.1
r116 (  36 60 ) resistor r=39.5823 //w=0.21 //l=0.173853 //layer=ply \
 //thickness=0.18 //x=1.34 //y=1.435 //x2=1.38 //y2=1.59
r117 (  35 59 ) resistor r=45.1352 //w=0.168 //l=0.173853 //layer=ply \
 //thickness=0.18 //x=1.34 //y=1.09 //x2=1.38 //y2=0.935
r118 (  35 36 ) resistor r=176.904 //w=0.094 //l=0.345 //layer=ply \
 //thickness=0.18 //x=1.34 //y=1.09 //x2=1.34 //y2=1.435
r119 (  34 49 ) resistor r=592.245 //w=0.094 //l=1.155 //layer=ply \
 //thickness=0.18 //x=1.825 //y=6.2 //x2=1.825 //y2=5.045
r120 (  33 39 ) resistor r=592.245 //w=0.094 //l=1.155 //layer=ply \
 //thickness=0.18 //x=1.385 //y=6.2 //x2=1.385 //y2=5.045
r121 (  32 46 ) resistor r=56.4043 //w=0.094 //l=0.11 //layer=ply \
 //thickness=0.18 //x=1.605 //y=1.59 //x2=1.715 //y2=1.59
r122 (  32 47 ) resistor r=56.4043 //w=0.094 //l=0.11 //layer=ply \
 //thickness=0.18 //x=1.605 //y=1.59 //x2=1.495 //y2=1.59
r123 (  28 58 ) resistor r=152 //w=0.17 //l=0.17 //layer=licon //count=1 \
 //x=1.23 //y=4.88 //x2=1.23 //y2=4.88
r124 (  23 55 ) resistor r=152 //w=0.17 //l=0.17 //layer=licon //count=1 \
 //x=1.23 //y=2.265 //x2=1.23 //y2=2.265
r125 (  21 28 ) resistor r=9.3 //w=0.17 //l=0.17 //layer=mcon //count=1 \
 //x=1.23 //y=4.88 //x2=1.23 //y2=4.88
r126 (  17 23 ) resistor r=9.3 //w=0.17 //l=0.17 //layer=mcon //count=1 \
 //x=1.23 //y=2.265 //x2=1.23 //y2=2.265
r127 (  9 21 ) resistor r=0.0732479 //w=0.241 //l=0.122474 //layer=m1 \
 //thickness=0.36 //x=1.23 //y=4.76 //x2=1.235 //y2=4.88
r128 (  7 8 ) resistor r=0.0360744 //w=0.211 //l=0.03 //layer=m1 \
 //thickness=0.36 //x=1.23 //y=2.4 //x2=1.23 //y2=2.43
r129 (  7 17 ) resistor r=0.0799763 //w=0.211 //l=0.135 //layer=m1 \
 //thickness=0.36 //x=1.23 //y=2.4 //x2=1.23 //y2=2.265
r130 (  6 9 ) resistor r=0.133588 //w=0.131 //l=0.14 //layer=m1 \
 //thickness=0.36 //x=1.23 //y=4.62 //x2=1.23 //y2=4.76
r131 (  5 6 ) resistor r=0.353053 //w=0.131 //l=0.37 //layer=m1 \
 //thickness=0.36 //x=1.23 //y=4.25 //x2=1.23 //y2=4.62
r132 (  4 5 ) resistor r=0.353053 //w=0.131 //l=0.37 //layer=m1 \
 //thickness=0.36 //x=1.23 //y=3.88 //x2=1.23 //y2=4.25
r133 (  3 4 ) resistor r=0.353053 //w=0.131 //l=0.37 //layer=m1 \
 //thickness=0.36 //x=1.23 //y=3.51 //x2=1.23 //y2=3.88
r134 (  2 3 ) resistor r=0.353053 //w=0.131 //l=0.37 //layer=m1 \
 //thickness=0.36 //x=1.23 //y=3.14 //x2=1.23 //y2=3.51
r135 (  1 2 ) resistor r=0.353053 //w=0.131 //l=0.37 //layer=m1 \
 //thickness=0.36 //x=1.23 //y=2.77 //x2=1.23 //y2=3.14
r136 (  1 8 ) resistor r=0.324427 //w=0.131 //l=0.34 //layer=m1 \
 //thickness=0.36 //x=1.23 //y=2.77 //x2=1.23 //y2=2.43
ends PM_BUFX1\%A

subckt PM_BUFX1\%Y ( 1 2 3 4 5 6 7 9 11 12 13 14 15 26 36 43 45 )
c77 ( 43 0 ) capacitor c=0.00869746f //x=3.635 //y=1.09
c78 ( 36 0 ) capacitor c=0.0262984f //x=3.825 //y=5.56
c79 ( 26 0 ) capacitor c=0.0188628f //x=3.82 //y=1.185
c80 ( 15 0 ) capacitor c=0.00557311f //x=3.91 //y=5.14
c81 ( 14 0 ) capacitor c=0.00944012f //x=4.105 //y=5.14
c82 ( 13 0 ) capacitor c=0.00724565f //x=3.905 //y=2.02
c83 ( 12 0 ) capacitor c=0.0145753f //x=4.105 //y=2.02
c84 ( 11 0 ) capacitor c=0.0119211f //x=3.825 //y=5.42
c85 ( 9 0 ) capacitor c=0.0170756f //x=3.82 //y=1.935
c86 ( 1 0 ) capacitor c=0.117157f //x=4.19 //y=2.4
r87 (  36 45 ) resistor r=23.615 //w=0.187 //l=0.345 //layer=li \
 //thickness=0.1 //x=3.825 //y=5.56 //x2=3.825 //y2=5.905
r88 (  29 36 ) resistor r=9.3 //w=0.17 //l=0.17 //layer=mcon //count=1 \
 //x=3.825 //y=5.56 //x2=3.825 //y2=5.56
r89 (  26 43 ) resistor r=9.3 //w=0.17 //l=0.17 //layer=mcon //count=1 \
 //x=3.82 //y=1.185 //x2=3.82 //y2=1.185
r90 (  14 17 ) resistor r=0.0698411 //w=0.17 //l=0.120208 //layer=m1 \
 //thickness=0.36 //x=4.105 //y=5.14 //x2=4.19 //y2=5.055
r91 (  14 15 ) resistor r=0.186069 //w=0.131 //l=0.195 //layer=m1 \
 //thickness=0.36 //x=4.105 //y=5.14 //x2=3.91 //y2=5.14
r92 (  12 16 ) resistor r=0.0698411 //w=0.17 //l=0.120208 //layer=m1 \
 //thickness=0.36 //x=4.105 //y=2.02 //x2=4.19 //y2=2.105
r93 (  12 13 ) resistor r=0.19084 //w=0.131 //l=0.2 //layer=m1 \
 //thickness=0.36 //x=4.105 //y=2.02 //x2=3.905 //y2=2.02
r94 (  11 29 ) resistor r=0.086672 //w=0.218 //l=0.14 //layer=m1 \
 //thickness=0.36 //x=3.825 //y=5.42 //x2=3.825 //y2=5.56
r95 (  10 15 ) resistor r=0.0698411 //w=0.17 //l=0.120208 //layer=m1 \
 //thickness=0.36 //x=3.825 //y=5.225 //x2=3.91 //y2=5.14
r96 (  10 11 ) resistor r=0.186069 //w=0.131 //l=0.195 //layer=m1 \
 //thickness=0.36 //x=3.825 //y=5.225 //x2=3.825 //y2=5.42
r97 (  9 13 ) resistor r=0.0698411 //w=0.17 //l=0.120208 //layer=m1 \
 //thickness=0.36 //x=3.82 //y=1.935 //x2=3.905 //y2=2.02
r98 (  8 26 ) resistor r=0.105739 //w=0.201 //l=0.145 //layer=m1 \
 //thickness=0.36 //x=3.82 //y=1.33 //x2=3.82 //y2=1.185
r99 (  8 9 ) resistor r=0.57729 //w=0.131 //l=0.605 //layer=m1 \
 //thickness=0.36 //x=3.82 //y=1.33 //x2=3.82 //y2=1.935
r100 (  7 17 ) resistor r=0.415076 //w=0.131 //l=0.435 //layer=m1 \
 //thickness=0.36 //x=4.19 //y=4.62 //x2=4.19 //y2=5.055
r101 (  6 7 ) resistor r=0.353053 //w=0.131 //l=0.37 //layer=m1 \
 //thickness=0.36 //x=4.19 //y=4.25 //x2=4.19 //y2=4.62
r102 (  5 6 ) resistor r=0.353053 //w=0.131 //l=0.37 //layer=m1 \
 //thickness=0.36 //x=4.19 //y=3.88 //x2=4.19 //y2=4.25
r103 (  4 5 ) resistor r=0.353053 //w=0.131 //l=0.37 //layer=m1 \
 //thickness=0.36 //x=4.19 //y=3.51 //x2=4.19 //y2=3.88
r104 (  3 4 ) resistor r=0.353053 //w=0.131 //l=0.37 //layer=m1 \
 //thickness=0.36 //x=4.19 //y=3.14 //x2=4.19 //y2=3.51
r105 (  2 3 ) resistor r=0.353053 //w=0.131 //l=0.37 //layer=m1 \
 //thickness=0.36 //x=4.19 //y=2.77 //x2=4.19 //y2=3.14
r106 (  1 2 ) resistor r=0.353053 //w=0.131 //l=0.37 //layer=m1 \
 //thickness=0.36 //x=4.19 //y=2.4 //x2=4.19 //y2=2.77
r107 (  1 16 ) resistor r=0.281489 //w=0.131 //l=0.295 //layer=m1 \
 //thickness=0.36 //x=4.19 //y=2.4 //x2=4.19 //y2=2.105
ends PM_BUFX1\%Y
