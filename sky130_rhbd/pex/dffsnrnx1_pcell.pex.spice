// File: dffsnrnx1_pcell.spi.pex
// Created: Sun Apr 12 08:40:08 2026
// Program "Calibre xRC"
// Version "v2023.2_27.15"
// Nominal Temperature: 30C
// Circuit Temperature: 30C
//
simulator lang=spectre
subckt PM_DFFSNRNX1_PCELL\%noxref_1 ( 1 3 6 7 9 10 11 12 14 15 16 17 18 19 20 \
 21 22 23 24 25 28 31 37 45 49 63 66 67 69 70 73 81 89 106 115 120 129 133 134 \
 135 136 137 138 139 140 141 142 143 145 151 152 153 154 158 159 160 161 162 \
 164 170 171 172 173 193 195 196 197 )
c406 ( 193 0 ) capacitor c=0.00885916f //x=3.395 //y=0.915
c407 ( 173 0 ) capacitor c=0.0612936f //x=11.005 //y=4.79
c408 ( 172 0 ) capacitor c=0.0376642f //x=11.295 //y=4.79
c409 ( 171 0 ) capacitor c=0.0346489f //x=10.96 //y=1.22
c410 ( 170 0 ) capacitor c=0.018692f //x=10.96 //y=0.875
c411 ( 164 0 ) capacitor c=0.0137077f //x=10.805 //y=1.375
c412 ( 162 0 ) capacitor c=0.0158585f //x=10.805 //y=0.72
c413 ( 161 0 ) capacitor c=0.0979536f //x=10.43 //y=1.915
c414 ( 160 0 ) capacitor c=0.0229444f //x=10.43 //y=1.53
c415 ( 159 0 ) capacitor c=0.0234359f //x=10.43 //y=1.22
c416 ( 158 0 ) capacitor c=0.019815f //x=10.43 //y=0.875
c417 ( 154 0 ) capacitor c=0.0612936f //x=6.195 //y=4.79
c418 ( 153 0 ) capacitor c=0.0376642f //x=6.485 //y=4.79
c419 ( 152 0 ) capacitor c=0.0346489f //x=6.15 //y=1.22
c420 ( 151 0 ) capacitor c=0.018692f //x=6.15 //y=0.875
c421 ( 145 0 ) capacitor c=0.0137077f //x=5.995 //y=1.375
c422 ( 143 0 ) capacitor c=0.0158585f //x=5.995 //y=0.72
c423 ( 142 0 ) capacitor c=0.0996161f //x=5.62 //y=1.915
c424 ( 141 0 ) capacitor c=0.0229444f //x=5.62 //y=1.53
c425 ( 140 0 ) capacitor c=0.0234359f //x=5.62 //y=1.22
c426 ( 139 0 ) capacitor c=0.019815f //x=5.62 //y=0.875
c427 ( 138 0 ) capacitor c=0.110208f //x=11.37 //y=6.02
c428 ( 137 0 ) capacitor c=0.158957f //x=10.93 //y=6.02
c429 ( 136 0 ) capacitor c=0.110208f //x=6.56 //y=6.02
c430 ( 135 0 ) capacitor c=0.158957f //x=6.12 //y=6.02
c431 ( 129 0 ) capacitor c=0.0014751f //x=10.73 //y=4.7
c432 ( 120 0 ) capacitor c=9.93222e-19 //x=10.73 //y=2.08
c433 ( 115 0 ) capacitor c=0.0014751f //x=5.92 //y=4.7
c434 ( 106 0 ) capacitor c=9.93222e-19 //x=5.92 //y=2.08
c435 ( 89 0 ) capacitor c=0.0293562f //x=3.29 //y=5.38
c436 ( 81 0 ) capacitor c=0.029341f //x=2.41 //y=5.38
c437 ( 73 0 ) capacitor c=0.0282179f //x=1.53 //y=5.38
c438 ( 70 0 ) capacitor c=0.0559596f //x=10.57 //y=2.605
c439 ( 69 0 ) capacitor c=6.72555e-19 //x=10.73 //y=2.605
c440 ( 67 0 ) capacitor c=6.72555e-19 //x=6.085 //y=2.605
c441 ( 66 0 ) capacitor c=0.0224706f //x=5.765 //y=2.605
c442 ( 63 0 ) capacitor c=0.00113895f //x=4.235 //y=2.605
c443 ( 49 0 ) capacitor c=0.0154699f //x=10.73 //y=2.59
c444 ( 45 0 ) capacitor c=0.0148628f //x=5.92 //y=2.59
c445 ( 37 0 ) capacitor c=0.0144706f //x=4.07 //y=2.59
c446 ( 31 0 ) capacitor c=0.00120661f //x=3.29 //y=5.155
c447 ( 28 0 ) capacitor c=0.0102486f //x=2.41 //y=5.155
c448 ( 25 0 ) capacitor c=0.0155037f //x=1.532 //y=5.155
c449 ( 24 0 ) capacitor c=0.0634506f //x=10.73 //y=4.575
c450 ( 23 0 ) capacitor c=0.0130987f //x=10.73 //y=2.765
c451 ( 22 0 ) capacitor c=0.00473602f //x=10.73 //y=2.445
c452 ( 21 0 ) capacitor c=0.00495287f //x=10.73 //y=2.195
c453 ( 20 0 ) capacitor c=0.0691569f //x=5.92 //y=4.575
c454 ( 19 0 ) capacitor c=0.0129701f //x=5.92 //y=2.765
c455 ( 18 0 ) capacitor c=0.00482124f //x=5.92 //y=2.445
c456 ( 17 0 ) capacitor c=0.00495287f //x=5.92 //y=2.195
c457 ( 16 0 ) capacitor c=0.0731396f //x=4.07 //y=5.07
c458 ( 15 0 ) capacitor c=0.0123217f //x=4.07 //y=2.765
c459 ( 14 0 ) capacitor c=0.0179579f //x=4.07 //y=2.445
c460 ( 12 0 ) capacitor c=0.00584263f //x=3.67 //y=1.665
c461 ( 11 0 ) capacitor c=0.0129788f //x=3.985 //y=1.665
c462 ( 10 0 ) capacitor c=0.0167992f //x=3.585 //y=1.58
c463 ( 9 0 ) capacitor c=0.0110957f //x=3.585 //y=1.125
c464 ( 7 0 ) capacitor c=0.0264064f //x=3.985 //y=5.155
c465 ( 6 0 ) capacitor c=0.00933983f //x=3.29 //y=5.38
c466 ( 3 0 ) capacitor c=0.0255081f //x=3.175 //y=5.155
c467 ( 1 0 ) capacitor c=0.0189204f //x=2.29 //y=5.155
r468 (  172 174 ) resistor r=26.9307 //w=0.15 //l=0.106066 //layer=ply \
 //thickness=0.18 //x=11.295 //y=4.79 //x2=11.37 //y2=4.865
r469 (  172 173 ) resistor r=148.702 //w=0.094 //l=0.29 //layer=ply \
 //thickness=0.18 //x=11.295 //y=4.79 //x2=11.005 //y2=4.79
r470 (  171 192 ) resistor r=45.1352 //w=0.168 //l=0.173853 //layer=ply \
 //thickness=0.18 //x=10.96 //y=1.22 //x2=10.92 //y2=1.375
r471 (  170 191 ) resistor r=45.1352 //w=0.168 //l=0.173853 //layer=ply \
 //thickness=0.18 //x=10.96 //y=0.875 //x2=10.92 //y2=0.72
r472 (  170 171 ) resistor r=176.904 //w=0.094 //l=0.345 //layer=ply \
 //thickness=0.18 //x=10.96 //y=0.875 //x2=10.96 //y2=1.22
r473 (  167 173 ) resistor r=22.7971 //w=0.269 //l=0.106066 //layer=ply \
 //thickness=0.18 //x=10.93 //y=4.865 //x2=11.005 //y2=4.79
r474 (  167 190 ) resistor r=35.8364 //w=0.269 //l=0.270185 //layer=ply \
 //thickness=0.18 //x=10.93 //y=4.865 //x2=10.73 //y2=4.7
r475 (  165 186 ) resistor r=10.701 //w=0.21 //l=0.115 //layer=ply \
 //thickness=0.18 //x=10.585 //y=1.375 //x2=10.47 //y2=1.375
r476 (  164 192 ) resistor r=5.52526 //w=0.168 //l=0.115 //layer=ply \
 //thickness=0.18 //x=10.805 //y=1.375 //x2=10.92 //y2=1.375
r477 (  163 185 ) resistor r=5.52526 //w=0.168 //l=0.115 //layer=ply \
 //thickness=0.18 //x=10.585 //y=0.72 //x2=10.47 //y2=0.72
r478 (  162 191 ) resistor r=5.52526 //w=0.168 //l=0.115 //layer=ply \
 //thickness=0.18 //x=10.805 //y=0.72 //x2=10.92 //y2=0.72
r479 (  162 163 ) resistor r=112.809 //w=0.094 //l=0.22 //layer=ply \
 //thickness=0.18 //x=10.805 //y=0.72 //x2=10.585 //y2=0.72
r480 (  161 188 ) resistor r=58.7805 //w=0.246 //l=0.373497 //layer=ply \
 //thickness=0.18 //x=10.43 //y=1.915 //x2=10.73 //y2=2.08
r481 (  160 186 ) resistor r=39.5823 //w=0.21 //l=0.173853 //layer=ply \
 //thickness=0.18 //x=10.43 //y=1.53 //x2=10.47 //y2=1.375
r482 (  160 161 ) resistor r=197.415 //w=0.094 //l=0.385 //layer=ply \
 //thickness=0.18 //x=10.43 //y=1.53 //x2=10.43 //y2=1.915
r483 (  159 186 ) resistor r=39.5823 //w=0.21 //l=0.173853 //layer=ply \
 //thickness=0.18 //x=10.43 //y=1.22 //x2=10.47 //y2=1.375
r484 (  158 185 ) resistor r=45.1352 //w=0.168 //l=0.173853 //layer=ply \
 //thickness=0.18 //x=10.43 //y=0.875 //x2=10.47 //y2=0.72
r485 (  158 159 ) resistor r=176.904 //w=0.094 //l=0.345 //layer=ply \
 //thickness=0.18 //x=10.43 //y=0.875 //x2=10.43 //y2=1.22
r486 (  153 155 ) resistor r=26.9307 //w=0.15 //l=0.106066 //layer=ply \
 //thickness=0.18 //x=6.485 //y=4.79 //x2=6.56 //y2=4.865
r487 (  153 154 ) resistor r=148.702 //w=0.094 //l=0.29 //layer=ply \
 //thickness=0.18 //x=6.485 //y=4.79 //x2=6.195 //y2=4.79
r488 (  152 184 ) resistor r=45.1352 //w=0.168 //l=0.173853 //layer=ply \
 //thickness=0.18 //x=6.15 //y=1.22 //x2=6.11 //y2=1.375
r489 (  151 183 ) resistor r=45.1352 //w=0.168 //l=0.173853 //layer=ply \
 //thickness=0.18 //x=6.15 //y=0.875 //x2=6.11 //y2=0.72
r490 (  151 152 ) resistor r=176.904 //w=0.094 //l=0.345 //layer=ply \
 //thickness=0.18 //x=6.15 //y=0.875 //x2=6.15 //y2=1.22
r491 (  148 154 ) resistor r=22.7971 //w=0.269 //l=0.106066 //layer=ply \
 //thickness=0.18 //x=6.12 //y=4.865 //x2=6.195 //y2=4.79
r492 (  148 182 ) resistor r=35.8364 //w=0.269 //l=0.270185 //layer=ply \
 //thickness=0.18 //x=6.12 //y=4.865 //x2=5.92 //y2=4.7
r493 (  146 178 ) resistor r=10.701 //w=0.21 //l=0.115 //layer=ply \
 //thickness=0.18 //x=5.775 //y=1.375 //x2=5.66 //y2=1.375
r494 (  145 184 ) resistor r=5.52526 //w=0.168 //l=0.115 //layer=ply \
 //thickness=0.18 //x=5.995 //y=1.375 //x2=6.11 //y2=1.375
r495 (  144 177 ) resistor r=5.52526 //w=0.168 //l=0.115 //layer=ply \
 //thickness=0.18 //x=5.775 //y=0.72 //x2=5.66 //y2=0.72
r496 (  143 183 ) resistor r=5.52526 //w=0.168 //l=0.115 //layer=ply \
 //thickness=0.18 //x=5.995 //y=0.72 //x2=6.11 //y2=0.72
r497 (  143 144 ) resistor r=112.809 //w=0.094 //l=0.22 //layer=ply \
 //thickness=0.18 //x=5.995 //y=0.72 //x2=5.775 //y2=0.72
r498 (  142 180 ) resistor r=58.7805 //w=0.246 //l=0.373497 //layer=ply \
 //thickness=0.18 //x=5.62 //y=1.915 //x2=5.92 //y2=2.08
r499 (  141 178 ) resistor r=39.5823 //w=0.21 //l=0.173853 //layer=ply \
 //thickness=0.18 //x=5.62 //y=1.53 //x2=5.66 //y2=1.375
r500 (  141 142 ) resistor r=197.415 //w=0.094 //l=0.385 //layer=ply \
 //thickness=0.18 //x=5.62 //y=1.53 //x2=5.62 //y2=1.915
r501 (  140 178 ) resistor r=39.5823 //w=0.21 //l=0.173853 //layer=ply \
 //thickness=0.18 //x=5.62 //y=1.22 //x2=5.66 //y2=1.375
r502 (  139 177 ) resistor r=45.1352 //w=0.168 //l=0.173853 //layer=ply \
 //thickness=0.18 //x=5.62 //y=0.875 //x2=5.66 //y2=0.72
r503 (  139 140 ) resistor r=176.904 //w=0.094 //l=0.345 //layer=ply \
 //thickness=0.18 //x=5.62 //y=0.875 //x2=5.62 //y2=1.22
r504 (  138 174 ) resistor r=592.245 //w=0.094 //l=1.155 //layer=ply \
 //thickness=0.18 //x=11.37 //y=6.02 //x2=11.37 //y2=4.865
r505 (  137 167 ) resistor r=592.245 //w=0.094 //l=1.155 //layer=ply \
 //thickness=0.18 //x=10.93 //y=6.02 //x2=10.93 //y2=4.865
r506 (  136 155 ) resistor r=592.245 //w=0.094 //l=1.155 //layer=ply \
 //thickness=0.18 //x=6.56 //y=6.02 //x2=6.56 //y2=4.865
r507 (  135 148 ) resistor r=592.245 //w=0.094 //l=1.155 //layer=ply \
 //thickness=0.18 //x=6.12 //y=6.02 //x2=6.12 //y2=4.865
r508 (  134 164 ) resistor r=56.4043 //w=0.094 //l=0.11 //layer=ply \
 //thickness=0.18 //x=10.695 //y=1.375 //x2=10.805 //y2=1.375
r509 (  134 165 ) resistor r=56.4043 //w=0.094 //l=0.11 //layer=ply \
 //thickness=0.18 //x=10.695 //y=1.375 //x2=10.585 //y2=1.375
r510 (  133 145 ) resistor r=56.4043 //w=0.094 //l=0.11 //layer=ply \
 //thickness=0.18 //x=5.885 //y=1.375 //x2=5.995 //y2=1.375
r511 (  133 146 ) resistor r=56.4043 //w=0.094 //l=0.11 //layer=ply \
 //thickness=0.18 //x=5.885 //y=1.375 //x2=5.775 //y2=1.375
r512 (  129 190 ) resistor r=152 //w=0.17 //l=0.17 //layer=licon //count=1 \
 //x=10.73 //y=4.7 //x2=10.73 //y2=4.7
r513 (  120 188 ) resistor r=152 //w=0.17 //l=0.17 //layer=licon //count=1 \
 //x=10.73 //y=2.08 //x2=10.73 //y2=2.08
r514 (  115 182 ) resistor r=152 //w=0.17 //l=0.17 //layer=licon //count=1 \
 //x=5.92 //y=4.7 //x2=5.92 //y2=4.7
r515 (  106 180 ) resistor r=152 //w=0.17 //l=0.17 //layer=licon //count=1 \
 //x=5.92 //y=2.08 //x2=5.92 //y2=2.08
r516 (  89 197 ) resistor r=23.615 //w=0.187 //l=0.345 //layer=li \
 //thickness=0.1 //x=3.29 //y=5.38 //x2=3.29 //y2=5.725
r517 (  81 196 ) resistor r=23.615 //w=0.187 //l=0.345 //layer=li \
 //thickness=0.1 //x=2.41 //y=5.38 //x2=2.41 //y2=5.725
r518 (  73 195 ) resistor r=23.615 //w=0.187 //l=0.345 //layer=li \
 //thickness=0.1 //x=1.53 //y=5.38 //x2=1.53 //y2=5.725
r519 (  69 70 ) resistor r=0.10734 //w=0.281 //l=0.16 //layer=m2 \
 //thickness=0.36 //x=10.73 //y=2.605 //x2=10.57 //y2=2.605
r520 (  67 70 ) resistor r=4.27958 //w=0.131 //l=4.485 //layer=m2 \
 //thickness=0.36 //x=6.085 //y=2.59 //x2=10.57 //y2=2.59
r521 (  65 67 ) resistor r=0.10734 //w=0.281 //l=0.16 //layer=m2 \
 //thickness=0.36 //x=5.925 //y=2.605 //x2=6.085 //y2=2.605
r522 (  65 66 ) resistor r=0.10734 //w=0.281 //l=0.16 //layer=m2 \
 //thickness=0.36 //x=5.925 //y=2.605 //x2=5.765 //y2=2.605
r523 (  63 66 ) resistor r=1.45992 //w=0.131 //l=1.53 //layer=m2 \
 //thickness=0.36 //x=4.235 //y=2.59 //x2=5.765 //y2=2.59
r524 (  61 63 ) resistor r=0.10734 //w=0.281 //l=0.16 //layer=m2 \
 //thickness=0.36 //x=4.075 //y=2.605 //x2=4.235 //y2=2.605
r525 (  55 129 ) resistor r=9.3 //w=0.17 //l=0.17 //layer=mcon //count=1 \
 //x=10.73 //y=4.7 //x2=10.73 //y2=4.7
r526 (  53 120 ) resistor r=9.3 //w=0.17 //l=0.17 //layer=mcon //count=1 \
 //x=10.73 //y=2.08 //x2=10.73 //y2=2.08
r527 (  51 69 ) resistor r=4.5 //w=0.15 //l=0.15 //layer=via1 //count=1 \
 //x=10.73 //y=2.605 //x2=10.73 //y2=2.605
r528 (  49 51 ) resistor r=0.0049867 //w=0.376 //l=0.015 //layer=m1 \
 //thickness=0.36 //x=10.677 //y=2.59 //x2=10.677 //y2=2.605
r529 (  47 65 ) resistor r=4.5 //w=0.15 //l=0.15 //layer=via1 //count=1 \
 //x=5.925 //y=2.605 //x2=5.925 //y2=2.605
r530 (  45 47 ) resistor r=0.00501337 //w=0.374 //l=0.015 //layer=m1 \
 //thickness=0.36 //x=5.975 //y=2.59 //x2=5.975 //y2=2.605
r531 (  43 115 ) resistor r=9.3 //w=0.17 //l=0.17 //layer=mcon //count=1 \
 //x=5.92 //y=4.7 //x2=5.92 //y2=4.7
r532 (  41 106 ) resistor r=9.3 //w=0.17 //l=0.17 //layer=mcon //count=1 \
 //x=5.92 //y=2.08 //x2=5.92 //y2=2.08
r533 (  39 61 ) resistor r=4.5 //w=0.15 //l=0.15 //layer=via1 //count=1 \
 //x=4.075 //y=2.605 //x2=4.075 //y2=2.605
r534 (  37 39 ) resistor r=0.00501337 //w=0.374 //l=0.015 //layer=m1 \
 //thickness=0.36 //x=4.125 //y=2.59 //x2=4.125 //y2=2.605
r535 (  35 193 ) resistor r=9.3 //w=0.17 //l=0.17 //layer=mcon //count=1 \
 //x=3.585 //y=1.01 //x2=3.585 //y2=1.01
r536 (  33 89 ) resistor r=9.3 //w=0.17 //l=0.17 //layer=mcon //count=1 \
 //x=3.29 //y=5.38 //x2=3.29 //y2=5.38
r537 (  30 81 ) resistor r=9.3 //w=0.17 //l=0.17 //layer=mcon //count=1 \
 //x=2.41 //y=5.38 //x2=2.41 //y2=5.38
r538 (  28 30 ) resistor r=0.121228 //w=0.232 //l=0.225 //layer=m1 \
 //thickness=0.36 //x=2.41 //y=5.155 //x2=2.41 //y2=5.38
r539 (  27 73 ) resistor r=9.3 //w=0.17 //l=0.17 //layer=mcon //count=1 \
 //x=1.53 //y=5.38 //x2=1.53 //y2=5.38
r540 (  25 27 ) resistor r=0.129608 //w=0.217 //l=0.225 //layer=m1 \
 //thickness=0.36 //x=1.532 //y=5.155 //x2=1.532 //y2=5.38
r541 (  24 55 ) resistor r=0.0760407 //w=0.238 //l=0.125 //layer=m1 \
 //thickness=0.36 //x=10.73 //y=4.575 //x2=10.73 //y2=4.7
r542 (  23 51 ) resistor r=0.0911593 //w=0.376 //l=0.184608 //layer=m1 \
 //thickness=0.36 //x=10.73 //y=2.765 //x2=10.677 //y2=2.605
r543 (  23 24 ) resistor r=1.7271 //w=0.131 //l=1.81 //layer=m1 \
 //thickness=0.36 //x=10.73 //y=2.765 //x2=10.73 //y2=4.575
r544 (  22 49 ) resistor r=0.0861726 //w=0.376 //l=0.16944 //layer=m1 \
 //thickness=0.36 //x=10.73 //y=2.445 //x2=10.677 //y2=2.59
r545 (  21 53 ) resistor r=0.0719237 //w=0.222 //l=0.115 //layer=m1 \
 //thickness=0.36 //x=10.73 //y=2.195 //x2=10.73 //y2=2.08
r546 (  21 22 ) resistor r=0.23855 //w=0.131 //l=0.25 //layer=m1 \
 //thickness=0.36 //x=10.73 //y=2.195 //x2=10.73 //y2=2.445
r547 (  20 43 ) resistor r=0.0760407 //w=0.238 //l=0.125 //layer=m1 \
 //thickness=0.36 //x=5.92 //y=4.575 //x2=5.92 //y2=4.7
r548 (  19 47 ) resistor r=0.0910802 //w=0.374 //l=0.185472 //layer=m1 \
 //thickness=0.36 //x=5.92 //y=2.765 //x2=5.975 //y2=2.605
r549 (  19 20 ) resistor r=1.7271 //w=0.131 //l=1.81 //layer=m1 \
 //thickness=0.36 //x=5.92 //y=2.765 //x2=5.92 //y2=4.575
r550 (  18 45 ) resistor r=0.0860668 //w=0.374 //l=0.170294 //layer=m1 \
 //thickness=0.36 //x=5.92 //y=2.445 //x2=5.975 //y2=2.59
r551 (  17 41 ) resistor r=0.0719237 //w=0.222 //l=0.115 //layer=m1 \
 //thickness=0.36 //x=5.92 //y=2.195 //x2=5.92 //y2=2.08
r552 (  17 18 ) resistor r=0.23855 //w=0.131 //l=0.25 //layer=m1 \
 //thickness=0.36 //x=5.92 //y=2.195 //x2=5.92 //y2=2.445
r553 (  15 39 ) resistor r=0.0910802 //w=0.374 //l=0.185472 //layer=m1 \
 //thickness=0.36 //x=4.07 //y=2.765 //x2=4.125 //y2=2.605
r554 (  15 16 ) resistor r=2.19943 //w=0.131 //l=2.305 //layer=m1 \
 //thickness=0.36 //x=4.07 //y=2.765 //x2=4.07 //y2=5.07
r555 (  14 37 ) resistor r=0.0860668 //w=0.374 //l=0.170294 //layer=m1 \
 //thickness=0.36 //x=4.07 //y=2.445 //x2=4.125 //y2=2.59
r556 (  13 14 ) resistor r=0.663168 //w=0.131 //l=0.695 //layer=m1 \
 //thickness=0.36 //x=4.07 //y=1.75 //x2=4.07 //y2=2.445
r557 (  11 13 ) resistor r=0.0698411 //w=0.17 //l=0.120208 //layer=m1 \
 //thickness=0.36 //x=3.985 //y=1.665 //x2=4.07 //y2=1.75
r558 (  11 12 ) resistor r=0.300573 //w=0.131 //l=0.315 //layer=m1 \
 //thickness=0.36 //x=3.985 //y=1.665 //x2=3.67 //y2=1.665
r559 (  10 12 ) resistor r=0.0698411 //w=0.17 //l=0.120208 //layer=m1 \
 //thickness=0.36 //x=3.585 //y=1.58 //x2=3.67 //y2=1.665
r560 (  9 35 ) resistor r=0.0717383 //w=0.224 //l=0.115 //layer=m1 \
 //thickness=0.36 //x=3.585 //y=1.125 //x2=3.585 //y2=1.01
r561 (  9 10 ) resistor r=0.43416 //w=0.131 //l=0.455 //layer=m1 \
 //thickness=0.36 //x=3.585 //y=1.125 //x2=3.585 //y2=1.58
r562 (  8 31 ) resistor r=0.0675342 //w=0.23 //l=0.115 //layer=m1 \
 //thickness=0.36 //x=3.405 //y=5.155 //x2=3.29 //y2=5.155
r563 (  7 16 ) resistor r=0.0698411 //w=0.17 //l=0.120208 //layer=m1 \
 //thickness=0.36 //x=3.985 //y=5.155 //x2=4.07 //y2=5.07
r564 (  7 8 ) resistor r=0.553435 //w=0.131 //l=0.58 //layer=m1 \
 //thickness=0.36 //x=3.985 //y=5.155 //x2=3.405 //y2=5.155
r565 (  6 33 ) resistor r=0.00118313 //w=0.23 //layer=m1 //thickness=0.36 \
 //x=3.29 //y=5.38 //x2=3.29 //y2=5.38
r566 (  5 31 ) resistor r=0.002872 //w=0.34 //l=0.085 //layer=m1 \
 //thickness=0.36 //x=3.29 //y=5.24 //x2=3.29 //y2=5.155
r567 (  5 6 ) resistor r=0.091623 //w=0.191 //l=0.14 //layer=m1 \
 //thickness=0.36 //x=3.29 //y=5.24 //x2=3.29 //y2=5.38
r568 (  4 28 ) resistor r=0.0262263 //w=0.232 //l=0.12 //layer=m1 \
 //thickness=0.36 //x=2.53 //y=5.155 //x2=2.41 //y2=5.155
r569 (  3 31 ) resistor r=0.0675342 //w=0.23 //l=0.115 //layer=m1 \
 //thickness=0.36 //x=3.175 //y=5.155 //x2=3.29 //y2=5.155
r570 (  3 4 ) resistor r=0.615458 //w=0.131 //l=0.645 //layer=m1 \
 //thickness=0.36 //x=3.175 //y=5.155 //x2=2.53 //y2=5.155
r571 (  2 25 ) resistor r=0.0222262 //w=0.217 //l=0.118 //layer=m1 \
 //thickness=0.36 //x=1.65 //y=5.155 //x2=1.532 //y2=5.155
r572 (  1 28 ) resistor r=0.0262263 //w=0.232 //l=0.12 //layer=m1 \
 //thickness=0.36 //x=2.29 //y=5.155 //x2=2.41 //y2=5.155
r573 (  1 2 ) resistor r=0.610687 //w=0.131 //l=0.64 //layer=m1 \
 //thickness=0.36 //x=2.29 //y=5.155 //x2=1.65 //y2=5.155
ends PM_DFFSNRNX1_PCELL\%noxref_1

subckt PM_DFFSNRNX1_PCELL\%noxref_2 ( 1 3 6 7 9 10 11 12 14 15 16 17 18 19 20 \
 21 24 27 33 36 42 43 48 51 59 67 84 93 97 98 99 100 101 102 103 104 106 112 \
 113 114 115 127 129 130 131 )
c289 ( 127 0 ) capacitor c=0.00885916f //x=13.015 //y=0.915
c290 ( 115 0 ) capacitor c=0.0612936f //x=15.815 //y=4.79
c291 ( 114 0 ) capacitor c=0.0376642f //x=16.105 //y=4.79
c292 ( 113 0 ) capacitor c=0.0346489f //x=15.77 //y=1.22
c293 ( 112 0 ) capacitor c=0.018692f //x=15.77 //y=0.875
c294 ( 106 0 ) capacitor c=0.0137077f //x=15.615 //y=1.375
c295 ( 104 0 ) capacitor c=0.0158585f //x=15.615 //y=0.72
c296 ( 103 0 ) capacitor c=0.0979523f //x=15.24 //y=1.915
c297 ( 102 0 ) capacitor c=0.0229444f //x=15.24 //y=1.53
c298 ( 101 0 ) capacitor c=0.0234359f //x=15.24 //y=1.22
c299 ( 100 0 ) capacitor c=0.019815f //x=15.24 //y=0.875
c300 ( 99 0 ) capacitor c=0.110208f //x=16.18 //y=6.02
c301 ( 98 0 ) capacitor c=0.158957f //x=15.74 //y=6.02
c302 ( 93 0 ) capacitor c=0.0014751f //x=15.54 //y=4.7
c303 ( 84 0 ) capacitor c=9.93222e-19 //x=15.54 //y=2.08
c304 ( 67 0 ) capacitor c=0.0293723f //x=12.91 //y=5.38
c305 ( 59 0 ) capacitor c=0.029137f //x=12.03 //y=5.38
c306 ( 51 0 ) capacitor c=0.0278099f //x=11.15 //y=5.38
c307 ( 48 0 ) capacitor c=5.79974e-19 //x=15.55 //y=2.59
c308 ( 43 0 ) capacitor c=9.44624e-19 //x=13.85 //y=2.59
c309 ( 42 0 ) capacitor c=0.0167517f //x=15.39 //y=2.59
c310 ( 36 0 ) capacitor c=0.0146045f //x=15.54 //y=2.59
c311 ( 33 0 ) capacitor c=0.0146969f //x=13.69 //y=2.59
c312 ( 27 0 ) capacitor c=8.8245e-19 //x=12.91 //y=5.155
c313 ( 24 0 ) capacitor c=0.00726074f //x=12.03 //y=5.155
c314 ( 21 0 ) capacitor c=0.0111234f //x=11.152 //y=5.155
c315 ( 20 0 ) capacitor c=0.0657817f //x=15.54 //y=4.575
c316 ( 19 0 ) capacitor c=0.0131932f //x=15.54 //y=2.75
c317 ( 18 0 ) capacitor c=0.00432188f //x=15.54 //y=2.43
c318 ( 17 0 ) capacitor c=0.00485584f //x=15.54 //y=2.195
c319 ( 16 0 ) capacitor c=0.0669068f //x=13.69 //y=5.07
c320 ( 15 0 ) capacitor c=0.0122936f //x=13.69 //y=2.75
c321 ( 14 0 ) capacitor c=0.0182673f //x=13.69 //y=2.43
c322 ( 12 0 ) capacitor c=0.00493487f //x=13.29 //y=1.665
c323 ( 11 0 ) capacitor c=0.0129068f //x=13.605 //y=1.665
c324 ( 10 0 ) capacitor c=0.0167992f //x=13.205 //y=1.58
c325 ( 9 0 ) capacitor c=0.0112867f //x=13.205 //y=1.125
c326 ( 7 0 ) capacitor c=0.0236685f //x=13.605 //y=5.155
c327 ( 6 0 ) capacitor c=0.00933983f //x=12.91 //y=5.38
c328 ( 3 0 ) capacitor c=0.0180822f //x=12.795 //y=5.155
c329 ( 1 0 ) capacitor c=0.0151332f //x=11.91 //y=5.155
r330 (  114 116 ) resistor r=26.9307 //w=0.15 //l=0.106066 //layer=ply \
 //thickness=0.18 //x=16.105 //y=4.79 //x2=16.18 //y2=4.865
r331 (  114 115 ) resistor r=148.702 //w=0.094 //l=0.29 //layer=ply \
 //thickness=0.18 //x=16.105 //y=4.79 //x2=15.815 //y2=4.79
r332 (  113 126 ) resistor r=45.1352 //w=0.168 //l=0.173853 //layer=ply \
 //thickness=0.18 //x=15.77 //y=1.22 //x2=15.73 //y2=1.375
r333 (  112 125 ) resistor r=45.1352 //w=0.168 //l=0.173853 //layer=ply \
 //thickness=0.18 //x=15.77 //y=0.875 //x2=15.73 //y2=0.72
r334 (  112 113 ) resistor r=176.904 //w=0.094 //l=0.345 //layer=ply \
 //thickness=0.18 //x=15.77 //y=0.875 //x2=15.77 //y2=1.22
r335 (  109 115 ) resistor r=22.7971 //w=0.269 //l=0.106066 //layer=ply \
 //thickness=0.18 //x=15.74 //y=4.865 //x2=15.815 //y2=4.79
r336 (  109 124 ) resistor r=35.8364 //w=0.269 //l=0.270185 //layer=ply \
 //thickness=0.18 //x=15.74 //y=4.865 //x2=15.54 //y2=4.7
r337 (  107 120 ) resistor r=10.701 //w=0.21 //l=0.115 //layer=ply \
 //thickness=0.18 //x=15.395 //y=1.375 //x2=15.28 //y2=1.375
r338 (  106 126 ) resistor r=5.52526 //w=0.168 //l=0.115 //layer=ply \
 //thickness=0.18 //x=15.615 //y=1.375 //x2=15.73 //y2=1.375
r339 (  105 119 ) resistor r=5.52526 //w=0.168 //l=0.115 //layer=ply \
 //thickness=0.18 //x=15.395 //y=0.72 //x2=15.28 //y2=0.72
r340 (  104 125 ) resistor r=5.52526 //w=0.168 //l=0.115 //layer=ply \
 //thickness=0.18 //x=15.615 //y=0.72 //x2=15.73 //y2=0.72
r341 (  104 105 ) resistor r=112.809 //w=0.094 //l=0.22 //layer=ply \
 //thickness=0.18 //x=15.615 //y=0.72 //x2=15.395 //y2=0.72
r342 (  103 122 ) resistor r=58.7805 //w=0.246 //l=0.373497 //layer=ply \
 //thickness=0.18 //x=15.24 //y=1.915 //x2=15.54 //y2=2.08
r343 (  102 120 ) resistor r=39.5823 //w=0.21 //l=0.173853 //layer=ply \
 //thickness=0.18 //x=15.24 //y=1.53 //x2=15.28 //y2=1.375
r344 (  102 103 ) resistor r=197.415 //w=0.094 //l=0.385 //layer=ply \
 //thickness=0.18 //x=15.24 //y=1.53 //x2=15.24 //y2=1.915
r345 (  101 120 ) resistor r=39.5823 //w=0.21 //l=0.173853 //layer=ply \
 //thickness=0.18 //x=15.24 //y=1.22 //x2=15.28 //y2=1.375
r346 (  100 119 ) resistor r=45.1352 //w=0.168 //l=0.173853 //layer=ply \
 //thickness=0.18 //x=15.24 //y=0.875 //x2=15.28 //y2=0.72
r347 (  100 101 ) resistor r=176.904 //w=0.094 //l=0.345 //layer=ply \
 //thickness=0.18 //x=15.24 //y=0.875 //x2=15.24 //y2=1.22
r348 (  99 116 ) resistor r=592.245 //w=0.094 //l=1.155 //layer=ply \
 //thickness=0.18 //x=16.18 //y=6.02 //x2=16.18 //y2=4.865
r349 (  98 109 ) resistor r=592.245 //w=0.094 //l=1.155 //layer=ply \
 //thickness=0.18 //x=15.74 //y=6.02 //x2=15.74 //y2=4.865
r350 (  97 106 ) resistor r=56.4043 //w=0.094 //l=0.11 //layer=ply \
 //thickness=0.18 //x=15.505 //y=1.375 //x2=15.615 //y2=1.375
r351 (  97 107 ) resistor r=56.4043 //w=0.094 //l=0.11 //layer=ply \
 //thickness=0.18 //x=15.505 //y=1.375 //x2=15.395 //y2=1.375
r352 (  93 124 ) resistor r=152 //w=0.17 //l=0.17 //layer=licon //count=1 \
 //x=15.54 //y=4.7 //x2=15.54 //y2=4.7
r353 (  84 122 ) resistor r=152 //w=0.17 //l=0.17 //layer=licon //count=1 \
 //x=15.54 //y=2.08 //x2=15.54 //y2=2.08
r354 (  67 131 ) resistor r=23.615 //w=0.187 //l=0.345 //layer=li \
 //thickness=0.1 //x=12.91 //y=5.38 //x2=12.91 //y2=5.725
r355 (  59 130 ) resistor r=23.615 //w=0.187 //l=0.345 //layer=li \
 //thickness=0.1 //x=12.03 //y=5.38 //x2=12.03 //y2=5.725
r356 (  51 129 ) resistor r=23.615 //w=0.187 //l=0.345 //layer=li \
 //thickness=0.1 //x=11.15 //y=5.38 //x2=11.15 //y2=5.725
r357 (  43 45 ) resistor r=0.10734 //w=0.281 //l=0.16 //layer=m2 \
 //thickness=0.36 //x=13.85 //y=2.59 //x2=13.69 //y2=2.59
r358 (  42 48 ) resistor r=0.10734 //w=0.281 //l=0.16 //layer=m2 \
 //thickness=0.36 //x=15.39 //y=2.59 //x2=15.55 //y2=2.59
r359 (  42 43 ) resistor r=1.46947 //w=0.131 //l=1.54 //layer=m2 \
 //thickness=0.36 //x=15.39 //y=2.59 //x2=13.85 //y2=2.59
r360 (  41 93 ) resistor r=9.3 //w=0.17 //l=0.17 //layer=mcon //count=1 \
 //x=15.54 //y=4.7 //x2=15.54 //y2=4.7
r361 (  39 84 ) resistor r=9.3 //w=0.17 //l=0.17 //layer=mcon //count=1 \
 //x=15.54 //y=2.08 //x2=15.54 //y2=2.08
r362 (  36 48 ) resistor r=4.5 //w=0.15 //l=0.15 //layer=via1 //count=1 \
 //x=15.55 //y=2.59 //x2=15.55 //y2=2.59
r363 (  33 45 ) resistor r=4.5 //w=0.15 //l=0.15 //layer=via1 //count=1 \
 //x=13.69 //y=2.59 //x2=13.69 //y2=2.59
r364 (  31 127 ) resistor r=9.3 //w=0.17 //l=0.17 //layer=mcon //count=1 \
 //x=13.205 //y=1.01 //x2=13.205 //y2=1.01
r365 (  29 67 ) resistor r=9.3 //w=0.17 //l=0.17 //layer=mcon //count=1 \
 //x=12.91 //y=5.38 //x2=12.91 //y2=5.38
r366 (  26 59 ) resistor r=9.3 //w=0.17 //l=0.17 //layer=mcon //count=1 \
 //x=12.03 //y=5.38 //x2=12.03 //y2=5.38
r367 (  24 26 ) resistor r=0.121228 //w=0.232 //l=0.225 //layer=m1 \
 //thickness=0.36 //x=12.03 //y=5.155 //x2=12.03 //y2=5.38
r368 (  23 51 ) resistor r=9.3 //w=0.17 //l=0.17 //layer=mcon //count=1 \
 //x=11.15 //y=5.38 //x2=11.15 //y2=5.38
r369 (  21 23 ) resistor r=0.129608 //w=0.217 //l=0.225 //layer=m1 \
 //thickness=0.36 //x=11.152 //y=5.155 //x2=11.152 //y2=5.38
r370 (  20 41 ) resistor r=0.0760407 //w=0.238 //l=0.125 //layer=m1 \
 //thickness=0.36 //x=15.54 //y=4.575 //x2=15.54 //y2=4.7
r371 (  19 36 ) resistor r=0.0914072 //w=0.382 //l=0.182428 //layer=m1 \
 //thickness=0.36 //x=15.54 //y=2.75 //x2=15.492 //y2=2.59
r372 (  19 20 ) resistor r=1.74141 //w=0.131 //l=1.825 //layer=m1 \
 //thickness=0.36 //x=15.54 //y=2.75 //x2=15.54 //y2=4.575
r373 (  18 36 ) resistor r=0.0914072 //w=0.382 //l=0.182428 //layer=m1 \
 //thickness=0.36 //x=15.54 //y=2.43 //x2=15.492 //y2=2.59
r374 (  17 39 ) resistor r=0.0719237 //w=0.222 //l=0.115 //layer=m1 \
 //thickness=0.36 //x=15.54 //y=2.195 //x2=15.54 //y2=2.08
r375 (  17 18 ) resistor r=0.224237 //w=0.131 //l=0.235 //layer=m1 \
 //thickness=0.36 //x=15.54 //y=2.195 //x2=15.54 //y2=2.43
r376 (  15 33 ) resistor r=0.0911593 //w=0.376 //l=0.184174 //layer=m1 \
 //thickness=0.36 //x=13.69 //y=2.75 //x2=13.742 //y2=2.59
r377 (  15 16 ) resistor r=2.21374 //w=0.131 //l=2.32 //layer=m1 \
 //thickness=0.36 //x=13.69 //y=2.75 //x2=13.69 //y2=5.07
r378 (  14 33 ) resistor r=0.0911593 //w=0.376 //l=0.184174 //layer=m1 \
 //thickness=0.36 //x=13.69 //y=2.43 //x2=13.742 //y2=2.59
r379 (  13 14 ) resistor r=0.648855 //w=0.131 //l=0.68 //layer=m1 \
 //thickness=0.36 //x=13.69 //y=1.75 //x2=13.69 //y2=2.43
r380 (  11 13 ) resistor r=0.0698411 //w=0.17 //l=0.120208 //layer=m1 \
 //thickness=0.36 //x=13.605 //y=1.665 //x2=13.69 //y2=1.75
r381 (  11 12 ) resistor r=0.300573 //w=0.131 //l=0.315 //layer=m1 \
 //thickness=0.36 //x=13.605 //y=1.665 //x2=13.29 //y2=1.665
r382 (  10 12 ) resistor r=0.0698411 //w=0.17 //l=0.120208 //layer=m1 \
 //thickness=0.36 //x=13.205 //y=1.58 //x2=13.29 //y2=1.665
r383 (  9 31 ) resistor r=0.0717383 //w=0.224 //l=0.115 //layer=m1 \
 //thickness=0.36 //x=13.205 //y=1.125 //x2=13.205 //y2=1.01
r384 (  9 10 ) resistor r=0.43416 //w=0.131 //l=0.455 //layer=m1 \
 //thickness=0.36 //x=13.205 //y=1.125 //x2=13.205 //y2=1.58
r385 (  8 27 ) resistor r=0.0675342 //w=0.23 //l=0.115 //layer=m1 \
 //thickness=0.36 //x=13.025 //y=5.155 //x2=12.91 //y2=5.155
r386 (  7 16 ) resistor r=0.0698411 //w=0.17 //l=0.120208 //layer=m1 \
 //thickness=0.36 //x=13.605 //y=5.155 //x2=13.69 //y2=5.07
r387 (  7 8 ) resistor r=0.553435 //w=0.131 //l=0.58 //layer=m1 \
 //thickness=0.36 //x=13.605 //y=5.155 //x2=13.025 //y2=5.155
r388 (  6 29 ) resistor r=0.00118313 //w=0.23 //layer=m1 //thickness=0.36 \
 //x=12.91 //y=5.38 //x2=12.91 //y2=5.38
r389 (  5 27 ) resistor r=0.002872 //w=0.34 //l=0.085 //layer=m1 \
 //thickness=0.36 //x=12.91 //y=5.24 //x2=12.91 //y2=5.155
r390 (  5 6 ) resistor r=0.091623 //w=0.191 //l=0.14 //layer=m1 \
 //thickness=0.36 //x=12.91 //y=5.24 //x2=12.91 //y2=5.38
r391 (  4 24 ) resistor r=0.0262263 //w=0.232 //l=0.12 //layer=m1 \
 //thickness=0.36 //x=12.15 //y=5.155 //x2=12.03 //y2=5.155
r392 (  3 27 ) resistor r=0.0675342 //w=0.23 //l=0.115 //layer=m1 \
 //thickness=0.36 //x=12.795 //y=5.155 //x2=12.91 //y2=5.155
r393 (  3 4 ) resistor r=0.615458 //w=0.131 //l=0.645 //layer=m1 \
 //thickness=0.36 //x=12.795 //y=5.155 //x2=12.15 //y2=5.155
r394 (  2 21 ) resistor r=0.0222262 //w=0.217 //l=0.118 //layer=m1 \
 //thickness=0.36 //x=11.27 //y=5.155 //x2=11.152 //y2=5.155
r395 (  1 24 ) resistor r=0.0262263 //w=0.232 //l=0.12 //layer=m1 \
 //thickness=0.36 //x=11.91 //y=5.155 //x2=12.03 //y2=5.155
r396 (  1 2 ) resistor r=0.610687 //w=0.131 //l=0.64 //layer=m1 \
 //thickness=0.36 //x=11.91 //y=5.155 //x2=11.27 //y2=5.155
ends PM_DFFSNRNX1_PCELL\%noxref_2

subckt PM_DFFSNRNX1_PCELL\%noxref_3 ( 1 2 3 4 8 14 17 19 22 26 31 36 41 45 46 \
 47 48 49 50 51 52 53 55 61 62 63 64 65 70 71 72 74 80 81 82 83 84 92 103 )
c280 ( 103 0 ) capacitor c=0.035602f //x=16.65 //y=4.7
c281 ( 92 0 ) capacitor c=0.0357436f //x=7.03 //y=4.7
c282 ( 84 0 ) capacitor c=0.0305218f //x=16.985 //y=4.79
c283 ( 83 0 ) capacitor c=0.0863671f //x=16.74 //y=1.915
c284 ( 82 0 ) capacitor c=0.0170266f //x=16.74 //y=1.45
c285 ( 81 0 ) capacitor c=0.018609f //x=16.74 //y=1.22
c286 ( 80 0 ) capacitor c=0.0186599f //x=16.74 //y=0.91
c287 ( 74 0 ) capacitor c=0.0146988f //x=16.585 //y=1.375
c288 ( 72 0 ) capacitor c=0.0148531f //x=16.585 //y=0.755
c289 ( 71 0 ) capacitor c=0.0334406f //x=16.215 //y=1.22
c290 ( 70 0 ) capacitor c=0.0173191f //x=16.215 //y=0.91
c291 ( 65 0 ) capacitor c=0.0306608f //x=7.365 //y=4.79
c292 ( 64 0 ) capacitor c=0.0863671f //x=7.12 //y=1.915
c293 ( 63 0 ) capacitor c=0.0170266f //x=7.12 //y=1.45
c294 ( 62 0 ) capacitor c=0.018609f //x=7.12 //y=1.22
c295 ( 61 0 ) capacitor c=0.0186599f //x=7.12 //y=0.91
c296 ( 55 0 ) capacitor c=0.0146988f //x=6.965 //y=1.375
c297 ( 53 0 ) capacitor c=0.0148531f //x=6.965 //y=0.755
c298 ( 52 0 ) capacitor c=0.0334406f //x=6.595 //y=1.22
c299 ( 51 0 ) capacitor c=0.0173191f //x=6.595 //y=0.91
c300 ( 50 0 ) capacitor c=0.110208f //x=17.06 //y=6.02
c301 ( 49 0 ) capacitor c=0.110214f //x=16.62 //y=6.02
c302 ( 48 0 ) capacitor c=0.110208f //x=7.44 //y=6.02
c303 ( 47 0 ) capacitor c=0.110214f //x=7 //y=6.02
c304 ( 41 0 ) capacitor c=0.00103076f //x=16.65 //y=4.7
c305 ( 36 0 ) capacitor c=0.00121786f //x=16.65 //y=2.08
c306 ( 31 0 ) capacitor c=0.00129934f //x=7.03 //y=4.7
c307 ( 26 0 ) capacitor c=0.00121786f //x=7.03 //y=2.08
c308 ( 22 0 ) capacitor c=0.00493188f //x=16.655 //y=4.44
c309 ( 19 0 ) capacitor c=0.0114111f //x=7.025 //y=4.44
c310 ( 17 0 ) capacitor c=0.262678f //x=16.495 //y=4.44
c311 ( 14 0 ) capacitor c=0.00775876f //x=16.655 //y=4.655
c312 ( 8 0 ) capacitor c=0.00779265f //x=7.025 //y=4.655
c313 ( 4 0 ) capacitor c=0.0642138f //x=16.65 //y=4.495
c314 ( 3 0 ) capacitor c=0.00378707f //x=16.65 //y=2.195
c315 ( 2 0 ) capacitor c=0.0656332f //x=7.03 //y=4.495
c316 ( 1 0 ) capacitor c=0.00380207f //x=7.03 //y=2.195
r317 (  105 106 ) resistor r=32.4568 //w=0.214 //l=0.075 //layer=ply \
 //thickness=0.18 //x=16.65 //y=4.79 //x2=16.65 //y2=4.865
r318 (  103 105 ) resistor r=20.271 //w=0.214 //l=0.09 //layer=ply \
 //thickness=0.18 //x=16.65 //y=4.7 //x2=16.65 //y2=4.79
r319 (  94 95 ) resistor r=32.4568 //w=0.214 //l=0.075 //layer=ply \
 //thickness=0.18 //x=7.03 //y=4.79 //x2=7.03 //y2=4.865
r320 (  92 94 ) resistor r=20.271 //w=0.214 //l=0.09 //layer=ply \
 //thickness=0.18 //x=7.03 //y=4.7 //x2=7.03 //y2=4.79
r321 (  85 105 ) resistor r=16.5046 //w=0.27 //l=0.135 //layer=ply \
 //thickness=0.18 //x=16.785 //y=4.79 //x2=16.65 //y2=4.79
r322 (  84 86 ) resistor r=26.9307 //w=0.15 //l=0.106066 //layer=ply \
 //thickness=0.18 //x=16.985 //y=4.79 //x2=17.06 //y2=4.865
r323 (  84 85 ) resistor r=102.553 //w=0.094 //l=0.2 //layer=ply \
 //thickness=0.18 //x=16.985 //y=4.79 //x2=16.785 //y2=4.79
r324 (  83 110 ) resistor r=38.6777 //w=0.284 //l=0.198997 //layer=ply \
 //thickness=0.18 //x=16.74 //y=1.915 //x2=16.665 //y2=2.08
r325 (  82 108 ) resistor r=21.2976 //w=0.217 //l=0.0928709 //layer=ply \
 //thickness=0.18 //x=16.74 //y=1.45 //x2=16.7 //y2=1.375
r326 (  82 83 ) resistor r=238.436 //w=0.094 //l=0.465 //layer=ply \
 //thickness=0.18 //x=16.74 //y=1.45 //x2=16.74 //y2=1.915
r327 (  81 108 ) resistor r=39.0671 //w=0.217 //l=0.173853 //layer=ply \
 //thickness=0.18 //x=16.74 //y=1.22 //x2=16.7 //y2=1.375
r328 (  80 107 ) resistor r=45.1352 //w=0.168 //l=0.173853 //layer=ply \
 //thickness=0.18 //x=16.74 //y=0.91 //x2=16.7 //y2=0.755
r329 (  80 81 ) resistor r=158.957 //w=0.094 //l=0.31 //layer=ply \
 //thickness=0.18 //x=16.74 //y=0.91 //x2=16.74 //y2=1.22
r330 (  75 101 ) resistor r=5.52526 //w=0.168 //l=0.115 //layer=ply \
 //thickness=0.18 //x=16.37 //y=1.375 //x2=16.255 //y2=1.375
r331 (  74 108 ) resistor r=11.4558 //w=0.217 //l=0.115 //layer=ply \
 //thickness=0.18 //x=16.585 //y=1.375 //x2=16.7 //y2=1.375
r332 (  73 100 ) resistor r=5.52526 //w=0.168 //l=0.115 //layer=ply \
 //thickness=0.18 //x=16.37 //y=0.755 //x2=16.255 //y2=0.755
r333 (  72 107 ) resistor r=5.52526 //w=0.168 //l=0.115 //layer=ply \
 //thickness=0.18 //x=16.585 //y=0.755 //x2=16.7 //y2=0.755
r334 (  72 73 ) resistor r=110.245 //w=0.094 //l=0.215 //layer=ply \
 //thickness=0.18 //x=16.585 //y=0.755 //x2=16.37 //y2=0.755
r335 (  71 101 ) resistor r=45.1352 //w=0.168 //l=0.173853 //layer=ply \
 //thickness=0.18 //x=16.215 //y=1.22 //x2=16.255 //y2=1.375
r336 (  70 100 ) resistor r=45.1352 //w=0.168 //l=0.173853 //layer=ply \
 //thickness=0.18 //x=16.215 //y=0.91 //x2=16.255 //y2=0.755
r337 (  70 71 ) resistor r=158.957 //w=0.094 //l=0.31 //layer=ply \
 //thickness=0.18 //x=16.215 //y=0.91 //x2=16.215 //y2=1.22
r338 (  66 94 ) resistor r=16.5046 //w=0.27 //l=0.135 //layer=ply \
 //thickness=0.18 //x=7.165 //y=4.79 //x2=7.03 //y2=4.79
r339 (  65 67 ) resistor r=26.9307 //w=0.15 //l=0.106066 //layer=ply \
 //thickness=0.18 //x=7.365 //y=4.79 //x2=7.44 //y2=4.865
r340 (  65 66 ) resistor r=102.553 //w=0.094 //l=0.2 //layer=ply \
 //thickness=0.18 //x=7.365 //y=4.79 //x2=7.165 //y2=4.79
r341 (  64 99 ) resistor r=38.6777 //w=0.284 //l=0.198997 //layer=ply \
 //thickness=0.18 //x=7.12 //y=1.915 //x2=7.045 //y2=2.08
r342 (  63 97 ) resistor r=21.2976 //w=0.217 //l=0.0928709 //layer=ply \
 //thickness=0.18 //x=7.12 //y=1.45 //x2=7.08 //y2=1.375
r343 (  63 64 ) resistor r=238.436 //w=0.094 //l=0.465 //layer=ply \
 //thickness=0.18 //x=7.12 //y=1.45 //x2=7.12 //y2=1.915
r344 (  62 97 ) resistor r=39.0671 //w=0.217 //l=0.173853 //layer=ply \
 //thickness=0.18 //x=7.12 //y=1.22 //x2=7.08 //y2=1.375
r345 (  61 96 ) resistor r=45.1352 //w=0.168 //l=0.173853 //layer=ply \
 //thickness=0.18 //x=7.12 //y=0.91 //x2=7.08 //y2=0.755
r346 (  61 62 ) resistor r=158.957 //w=0.094 //l=0.31 //layer=ply \
 //thickness=0.18 //x=7.12 //y=0.91 //x2=7.12 //y2=1.22
r347 (  56 90 ) resistor r=5.52526 //w=0.168 //l=0.115 //layer=ply \
 //thickness=0.18 //x=6.75 //y=1.375 //x2=6.635 //y2=1.375
r348 (  55 97 ) resistor r=11.4558 //w=0.217 //l=0.115 //layer=ply \
 //thickness=0.18 //x=6.965 //y=1.375 //x2=7.08 //y2=1.375
r349 (  54 89 ) resistor r=5.52526 //w=0.168 //l=0.115 //layer=ply \
 //thickness=0.18 //x=6.75 //y=0.755 //x2=6.635 //y2=0.755
r350 (  53 96 ) resistor r=5.52526 //w=0.168 //l=0.115 //layer=ply \
 //thickness=0.18 //x=6.965 //y=0.755 //x2=7.08 //y2=0.755
r351 (  53 54 ) resistor r=110.245 //w=0.094 //l=0.215 //layer=ply \
 //thickness=0.18 //x=6.965 //y=0.755 //x2=6.75 //y2=0.755
r352 (  52 90 ) resistor r=45.1352 //w=0.168 //l=0.173853 //layer=ply \
 //thickness=0.18 //x=6.595 //y=1.22 //x2=6.635 //y2=1.375
r353 (  51 89 ) resistor r=45.1352 //w=0.168 //l=0.173853 //layer=ply \
 //thickness=0.18 //x=6.595 //y=0.91 //x2=6.635 //y2=0.755
r354 (  51 52 ) resistor r=158.957 //w=0.094 //l=0.31 //layer=ply \
 //thickness=0.18 //x=6.595 //y=0.91 //x2=6.595 //y2=1.22
r355 (  50 86 ) resistor r=592.245 //w=0.094 //l=1.155 //layer=ply \
 //thickness=0.18 //x=17.06 //y=6.02 //x2=17.06 //y2=4.865
r356 (  49 106 ) resistor r=592.245 //w=0.094 //l=1.155 //layer=ply \
 //thickness=0.18 //x=16.62 //y=6.02 //x2=16.62 //y2=4.865
r357 (  48 67 ) resistor r=592.245 //w=0.094 //l=1.155 //layer=ply \
 //thickness=0.18 //x=7.44 //y=6.02 //x2=7.44 //y2=4.865
r358 (  47 95 ) resistor r=592.245 //w=0.094 //l=1.155 //layer=ply \
 //thickness=0.18 //x=7 //y=6.02 //x2=7 //y2=4.865
r359 (  46 74 ) resistor r=55.3787 //w=0.094 //l=0.108 //layer=ply \
 //thickness=0.18 //x=16.477 //y=1.375 //x2=16.585 //y2=1.375
r360 (  46 75 ) resistor r=54.866 //w=0.094 //l=0.107 //layer=ply \
 //thickness=0.18 //x=16.477 //y=1.375 //x2=16.37 //y2=1.375
r361 (  45 55 ) resistor r=55.3787 //w=0.094 //l=0.108 //layer=ply \
 //thickness=0.18 //x=6.857 //y=1.375 //x2=6.965 //y2=1.375
r362 (  45 56 ) resistor r=54.866 //w=0.094 //l=0.107 //layer=ply \
 //thickness=0.18 //x=6.857 //y=1.375 //x2=6.75 //y2=1.375
r363 (  41 103 ) resistor r=152 //w=0.17 //l=0.17 //layer=licon //count=1 \
 //x=16.65 //y=4.7 //x2=16.65 //y2=4.7
r364 (  36 110 ) resistor r=152 //w=0.17 //l=0.17 //layer=licon //count=1 \
 //x=16.65 //y=2.08 //x2=16.65 //y2=2.08
r365 (  31 92 ) resistor r=152 //w=0.17 //l=0.17 //layer=licon //count=1 \
 //x=7.03 //y=4.7 //x2=7.03 //y2=4.7
r366 (  26 99 ) resistor r=152 //w=0.17 //l=0.17 //layer=licon //count=1 \
 //x=7.03 //y=2.08 //x2=7.03 //y2=2.08
r367 (  22 24 ) resistor r=0.0926724 //w=0.29 //l=0.215 //layer=m2 \
 //thickness=0.36 //x=16.655 //y=4.44 //x2=16.655 //y2=4.655
r368 (  19 21 ) resistor r=0.0875407 //w=0.307 //l=0.215 //layer=m2 \
 //thickness=0.36 //x=7.025 //y=4.44 //x2=7.025 //y2=4.655
r369 (  18 19 ) resistor r=0.0429992 //w=0.307 //l=0.16 //layer=m2 \
 //thickness=0.36 //x=7.185 //y=4.44 //x2=7.025 //y2=4.44
r370 (  17 22 ) resistor r=0.0395695 //w=0.29 //l=0.16 //layer=m2 \
 //thickness=0.36 //x=16.495 //y=4.44 //x2=16.655 //y2=4.44
r371 (  17 18 ) resistor r=8.88359 //w=0.131 //l=9.31 //layer=m2 \
 //thickness=0.36 //x=16.495 //y=4.44 //x2=7.185 //y2=4.44
r372 (  16 41 ) resistor r=9.3 //w=0.17 //l=0.17 //layer=mcon //count=1 \
 //x=16.65 //y=4.7 //x2=16.65 //y2=4.7
r373 (  14 24 ) resistor r=4.5 //w=0.15 //l=0.15 //layer=via1 //count=1 \
 //x=16.655 //y=4.655 //x2=16.655 //y2=4.655
r374 (  14 16 ) resistor r=0.018263 //w=0.308 //l=0.045 //layer=m1 \
 //thickness=0.36 //x=16.655 //y=4.655 //x2=16.655 //y2=4.7
r375 (  12 36 ) resistor r=9.3 //w=0.17 //l=0.17 //layer=mcon //count=1 \
 //x=16.65 //y=2.08 //x2=16.65 //y2=2.08
r376 (  10 31 ) resistor r=9.3 //w=0.17 //l=0.17 //layer=mcon //count=1 \
 //x=7.03 //y=4.7 //x2=7.03 //y2=4.7
r377 (  8 21 ) resistor r=4.5 //w=0.15 //l=0.15 //layer=via1 //count=1 \
 //x=7.025 //y=4.655 //x2=7.025 //y2=4.655
r378 (  8 10 ) resistor r=0.018263 //w=0.308 //l=0.045 //layer=m1 \
 //thickness=0.36 //x=7.025 //y=4.655 //x2=7.025 //y2=4.7
r379 (  6 26 ) resistor r=9.3 //w=0.17 //l=0.17 //layer=mcon //count=1 \
 //x=7.03 //y=2.08 //x2=7.03 //y2=2.08
r380 (  4 14 ) resistor r=0.0898396 //w=0.308 //l=0.162481 //layer=m1 \
 //thickness=0.36 //x=16.65 //y=4.495 //x2=16.655 //y2=4.655
r381 (  3 12 ) resistor r=0.0715665 //w=0.226 //l=0.115996 //layer=m1 \
 //thickness=0.36 //x=16.65 //y=2.195 //x2=16.652 //y2=2.08
r382 (  3 4 ) resistor r=2.19466 //w=0.131 //l=2.3 //layer=m1 //thickness=0.36 \
 //x=16.65 //y=2.195 //x2=16.65 //y2=4.495
r383 (  2 8 ) resistor r=0.0898396 //w=0.308 //l=0.162481 //layer=m1 \
 //thickness=0.36 //x=7.03 //y=4.495 //x2=7.025 //y2=4.655
r384 (  1 6 ) resistor r=0.0715665 //w=0.226 //l=0.115996 //layer=m1 \
 //thickness=0.36 //x=7.03 //y=2.195 //x2=7.032 //y2=2.08
r385 (  1 2 ) resistor r=2.19466 //w=0.131 //l=2.3 //layer=m1 //thickness=0.36 \
 //x=7.03 //y=2.195 //x2=7.03 //y2=4.495
ends PM_DFFSNRNX1_PCELL\%noxref_3

subckt PM_DFFSNRNX1_PCELL\%noxref_4 ( 1 2 3 4 5 7 10 11 13 14 15 16 18 19 20 \
 21 22 23 24 30 33 36 39 47 49 57 62 65 66 68 71 80 85 93 101 118 127 131 132 \
 133 134 135 136 140 141 142 147 149 152 153 154 155 156 157 158 160 166 167 \
 168 169 174 175 180 191 193 194 195 )
c454 ( 191 0 ) capacitor c=0.00885916f //x=8.205 //y=0.915
c455 ( 180 0 ) capacitor c=0.0710579f //x=3.33 //y=4.7
c456 ( 175 0 ) capacitor c=0.0278202f //x=3.33 //y=1.915
c457 ( 174 0 ) capacitor c=0.0479349f //x=3.33 //y=2.08
c458 ( 169 0 ) capacitor c=0.0612936f //x=20.625 //y=4.79
c459 ( 168 0 ) capacitor c=0.0376642f //x=20.915 //y=4.79
c460 ( 167 0 ) capacitor c=0.0346489f //x=20.58 //y=1.22
c461 ( 166 0 ) capacitor c=0.018692f //x=20.58 //y=0.875
c462 ( 160 0 ) capacitor c=0.0137077f //x=20.425 //y=1.375
c463 ( 158 0 ) capacitor c=0.0158585f //x=20.425 //y=0.72
c464 ( 157 0 ) capacitor c=0.10101f //x=20.05 //y=1.915
c465 ( 156 0 ) capacitor c=0.0229444f //x=20.05 //y=1.53
c466 ( 155 0 ) capacitor c=0.0234359f //x=20.05 //y=1.22
c467 ( 154 0 ) capacitor c=0.019815f //x=20.05 //y=0.875
c468 ( 153 0 ) capacitor c=0.0443175f //x=3.85 //y=1.26
c469 ( 152 0 ) capacitor c=0.0199703f //x=3.85 //y=0.915
c470 ( 149 0 ) capacitor c=0.0162526f //x=3.695 //y=1.415
c471 ( 147 0 ) capacitor c=0.0157807f //x=3.695 //y=0.76
c472 ( 142 0 ) capacitor c=0.0220935f //x=3.32 //y=1.57
c473 ( 141 0 ) capacitor c=0.0207489f //x=3.32 //y=1.26
c474 ( 140 0 ) capacitor c=0.0194091f //x=3.32 //y=0.915
c475 ( 136 0 ) capacitor c=0.110208f //x=20.99 //y=6.02
c476 ( 135 0 ) capacitor c=0.158957f //x=20.55 //y=6.02
c477 ( 134 0 ) capacitor c=0.159671f //x=3.51 //y=6.02
c478 ( 133 0 ) capacitor c=0.110208f //x=3.07 //y=6.02
c479 ( 127 0 ) capacitor c=0.0014751f //x=20.35 //y=4.7
c480 ( 118 0 ) capacitor c=0.0012618f //x=20.35 //y=2.08
c481 ( 101 0 ) capacitor c=0.0293723f //x=8.1 //y=5.38
c482 ( 93 0 ) capacitor c=0.029137f //x=7.22 //y=5.38
c483 ( 85 0 ) capacitor c=0.0278099f //x=6.34 //y=5.38
c484 ( 80 0 ) capacitor c=7.74199e-19 //x=3.33 //y=4.7
c485 ( 71 0 ) capacitor c=0.00101179f //x=3.33 //y=2.08
c486 ( 68 0 ) capacitor c=4.92288e-19 //x=20.345 //y=3.33
c487 ( 66 0 ) capacitor c=8.37596e-19 //x=9.04 //y=3.315
c488 ( 65 0 ) capacitor c=0.126919f //x=8.72 //y=3.315
c489 ( 62 0 ) capacitor c=0.00200793f //x=3.5 //y=3.335
c490 ( 57 0 ) capacitor c=0.122828f //x=20.185 //y=3.33
c491 ( 49 0 ) capacitor c=0.015408f //x=20.345 //y=3.33
c492 ( 47 0 ) capacitor c=0.0158593f //x=8.88 //y=3.33
c493 ( 39 0 ) capacitor c=8.8245e-19 //x=8.1 //y=5.155
c494 ( 36 0 ) capacitor c=0.00740623f //x=7.22 //y=5.155
c495 ( 33 0 ) capacitor c=0.011777f //x=6.342 //y=5.155
c496 ( 30 0 ) capacitor c=0.0150828f //x=3.33 //y=3.33
c497 ( 24 0 ) capacitor c=0.041547f //x=20.35 //y=4.575
c498 ( 23 0 ) capacitor c=0.0144231f //x=20.35 //y=3.49
c499 ( 22 0 ) capacitor c=0.0291296f //x=20.35 //y=3.17
c500 ( 21 0 ) capacitor c=0.00493552f //x=20.35 //y=2.195
c501 ( 20 0 ) capacitor c=0.0450442f //x=8.88 //y=5.07
c502 ( 19 0 ) capacitor c=0.0133594f //x=8.88 //y=3.475
c503 ( 18 0 ) capacitor c=0.0401079f //x=8.88 //y=3.155
c504 ( 16 0 ) capacitor c=0.0048771f //x=8.48 //y=1.665
c505 ( 15 0 ) capacitor c=0.0132685f //x=8.795 //y=1.665
c506 ( 14 0 ) capacitor c=0.0167992f //x=8.395 //y=1.58
c507 ( 13 0 ) capacitor c=0.0113147f //x=8.395 //y=1.125
c508 ( 11 0 ) capacitor c=0.0228465f //x=8.795 //y=5.155
c509 ( 10 0 ) capacitor c=0.00933983f //x=8.1 //y=5.38
c510 ( 7 0 ) capacitor c=0.019444f //x=7.985 //y=5.155
c511 ( 5 0 ) capacitor c=0.0154674f //x=7.1 //y=5.155
c512 ( 4 0 ) capacitor c=0.0358279f //x=3.33 //y=4.57
c513 ( 3 0 ) capacitor c=0.0108741f //x=3.33 //y=3.495
c514 ( 2 0 ) capacitor c=0.0243464f //x=3.33 //y=3.175
c515 ( 1 0 ) capacitor c=0.005545f //x=3.33 //y=2.195
r516 (  174 175 ) resistor r=52.7279 //w=0.214 //l=0.165 //layer=ply \
 //thickness=0.18 //x=3.33 //y=2.08 //x2=3.33 //y2=1.915
r517 (  168 170 ) resistor r=26.9307 //w=0.15 //l=0.106066 //layer=ply \
 //thickness=0.18 //x=20.915 //y=4.79 //x2=20.99 //y2=4.865
r518 (  168 169 ) resistor r=148.702 //w=0.094 //l=0.29 //layer=ply \
 //thickness=0.18 //x=20.915 //y=4.79 //x2=20.625 //y2=4.79
r519 (  167 190 ) resistor r=45.1352 //w=0.168 //l=0.173853 //layer=ply \
 //thickness=0.18 //x=20.58 //y=1.22 //x2=20.54 //y2=1.375
r520 (  166 189 ) resistor r=45.1352 //w=0.168 //l=0.173853 //layer=ply \
 //thickness=0.18 //x=20.58 //y=0.875 //x2=20.54 //y2=0.72
r521 (  166 167 ) resistor r=176.904 //w=0.094 //l=0.345 //layer=ply \
 //thickness=0.18 //x=20.58 //y=0.875 //x2=20.58 //y2=1.22
r522 (  163 169 ) resistor r=22.7971 //w=0.269 //l=0.106066 //layer=ply \
 //thickness=0.18 //x=20.55 //y=4.865 //x2=20.625 //y2=4.79
r523 (  163 188 ) resistor r=35.8364 //w=0.269 //l=0.270185 //layer=ply \
 //thickness=0.18 //x=20.55 //y=4.865 //x2=20.35 //y2=4.7
r524 (  161 184 ) resistor r=10.701 //w=0.21 //l=0.115 //layer=ply \
 //thickness=0.18 //x=20.205 //y=1.375 //x2=20.09 //y2=1.375
r525 (  160 190 ) resistor r=5.52526 //w=0.168 //l=0.115 //layer=ply \
 //thickness=0.18 //x=20.425 //y=1.375 //x2=20.54 //y2=1.375
r526 (  159 183 ) resistor r=5.52526 //w=0.168 //l=0.115 //layer=ply \
 //thickness=0.18 //x=20.205 //y=0.72 //x2=20.09 //y2=0.72
r527 (  158 189 ) resistor r=5.52526 //w=0.168 //l=0.115 //layer=ply \
 //thickness=0.18 //x=20.425 //y=0.72 //x2=20.54 //y2=0.72
r528 (  158 159 ) resistor r=112.809 //w=0.094 //l=0.22 //layer=ply \
 //thickness=0.18 //x=20.425 //y=0.72 //x2=20.205 //y2=0.72
r529 (  157 186 ) resistor r=58.7805 //w=0.246 //l=0.373497 //layer=ply \
 //thickness=0.18 //x=20.05 //y=1.915 //x2=20.35 //y2=2.08
r530 (  156 184 ) resistor r=39.5823 //w=0.21 //l=0.173853 //layer=ply \
 //thickness=0.18 //x=20.05 //y=1.53 //x2=20.09 //y2=1.375
r531 (  156 157 ) resistor r=197.415 //w=0.094 //l=0.385 //layer=ply \
 //thickness=0.18 //x=20.05 //y=1.53 //x2=20.05 //y2=1.915
r532 (  155 184 ) resistor r=39.5823 //w=0.21 //l=0.173853 //layer=ply \
 //thickness=0.18 //x=20.05 //y=1.22 //x2=20.09 //y2=1.375
r533 (  154 183 ) resistor r=45.1352 //w=0.168 //l=0.173853 //layer=ply \
 //thickness=0.18 //x=20.05 //y=0.875 //x2=20.09 //y2=0.72
r534 (  154 155 ) resistor r=176.904 //w=0.094 //l=0.345 //layer=ply \
 //thickness=0.18 //x=20.05 //y=0.875 //x2=20.05 //y2=1.22
r535 (  153 182 ) resistor r=45.1352 //w=0.168 //l=0.173853 //layer=ply \
 //thickness=0.18 //x=3.85 //y=1.26 //x2=3.81 //y2=1.415
r536 (  152 181 ) resistor r=45.1352 //w=0.168 //l=0.173853 //layer=ply \
 //thickness=0.18 //x=3.85 //y=0.915 //x2=3.81 //y2=0.76
r537 (  152 153 ) resistor r=176.904 //w=0.094 //l=0.345 //layer=ply \
 //thickness=0.18 //x=3.85 //y=0.915 //x2=3.85 //y2=1.26
r538 (  150 178 ) resistor r=10.701 //w=0.21 //l=0.115 //layer=ply \
 //thickness=0.18 //x=3.475 //y=1.415 //x2=3.36 //y2=1.415
r539 (  149 182 ) resistor r=5.52526 //w=0.168 //l=0.115 //layer=ply \
 //thickness=0.18 //x=3.695 //y=1.415 //x2=3.81 //y2=1.415
r540 (  148 177 ) resistor r=5.52526 //w=0.168 //l=0.115 //layer=ply \
 //thickness=0.18 //x=3.475 //y=0.76 //x2=3.36 //y2=0.76
r541 (  147 181 ) resistor r=5.52526 //w=0.168 //l=0.115 //layer=ply \
 //thickness=0.18 //x=3.695 //y=0.76 //x2=3.81 //y2=0.76
r542 (  147 148 ) resistor r=112.809 //w=0.094 //l=0.22 //layer=ply \
 //thickness=0.18 //x=3.695 //y=0.76 //x2=3.475 //y2=0.76
r543 (  144 180 ) resistor r=37.236 //w=0.233 //l=0.249199 //layer=ply \
 //thickness=0.18 //x=3.51 //y=4.865 //x2=3.33 //y2=4.7
r544 (  142 178 ) resistor r=39.5823 //w=0.21 //l=0.173853 //layer=ply \
 //thickness=0.18 //x=3.32 //y=1.57 //x2=3.36 //y2=1.415
r545 (  142 175 ) resistor r=176.904 //w=0.094 //l=0.345 //layer=ply \
 //thickness=0.18 //x=3.32 //y=1.57 //x2=3.32 //y2=1.915
r546 (  141 178 ) resistor r=39.5823 //w=0.21 //l=0.173853 //layer=ply \
 //thickness=0.18 //x=3.32 //y=1.26 //x2=3.36 //y2=1.415
r547 (  140 177 ) resistor r=45.1352 //w=0.168 //l=0.173853 //layer=ply \
 //thickness=0.18 //x=3.32 //y=0.915 //x2=3.36 //y2=0.76
r548 (  140 141 ) resistor r=176.904 //w=0.094 //l=0.345 //layer=ply \
 //thickness=0.18 //x=3.32 //y=0.915 //x2=3.32 //y2=1.26
r549 (  137 180 ) resistor r=53.7854 //w=0.233 //l=0.332415 //layer=ply \
 //thickness=0.18 //x=3.07 //y=4.865 //x2=3.33 //y2=4.7
r550 (  136 170 ) resistor r=592.245 //w=0.094 //l=1.155 //layer=ply \
 //thickness=0.18 //x=20.99 //y=6.02 //x2=20.99 //y2=4.865
r551 (  135 163 ) resistor r=592.245 //w=0.094 //l=1.155 //layer=ply \
 //thickness=0.18 //x=20.55 //y=6.02 //x2=20.55 //y2=4.865
r552 (  134 144 ) resistor r=592.245 //w=0.094 //l=1.155 //layer=ply \
 //thickness=0.18 //x=3.51 //y=6.02 //x2=3.51 //y2=4.865
r553 (  133 137 ) resistor r=592.245 //w=0.094 //l=1.155 //layer=ply \
 //thickness=0.18 //x=3.07 //y=6.02 //x2=3.07 //y2=4.865
r554 (  132 160 ) resistor r=56.4043 //w=0.094 //l=0.11 //layer=ply \
 //thickness=0.18 //x=20.315 //y=1.375 //x2=20.425 //y2=1.375
r555 (  132 161 ) resistor r=56.4043 //w=0.094 //l=0.11 //layer=ply \
 //thickness=0.18 //x=20.315 //y=1.375 //x2=20.205 //y2=1.375
r556 (  131 149 ) resistor r=56.4043 //w=0.094 //l=0.11 //layer=ply \
 //thickness=0.18 //x=3.585 //y=1.415 //x2=3.695 //y2=1.415
r557 (  131 150 ) resistor r=56.4043 //w=0.094 //l=0.11 //layer=ply \
 //thickness=0.18 //x=3.585 //y=1.415 //x2=3.475 //y2=1.415
r558 (  127 188 ) resistor r=152 //w=0.17 //l=0.17 //layer=licon //count=1 \
 //x=20.35 //y=4.7 //x2=20.35 //y2=4.7
r559 (  118 186 ) resistor r=152 //w=0.17 //l=0.17 //layer=licon //count=1 \
 //x=20.35 //y=2.08 //x2=20.35 //y2=2.08
r560 (  101 195 ) resistor r=23.615 //w=0.187 //l=0.345 //layer=li \
 //thickness=0.1 //x=8.1 //y=5.38 //x2=8.1 //y2=5.725
r561 (  93 194 ) resistor r=23.615 //w=0.187 //l=0.345 //layer=li \
 //thickness=0.1 //x=7.22 //y=5.38 //x2=7.22 //y2=5.725
r562 (  85 193 ) resistor r=23.615 //w=0.187 //l=0.345 //layer=li \
 //thickness=0.1 //x=6.34 //y=5.38 //x2=6.34 //y2=5.725
r563 (  80 180 ) resistor r=152 //w=0.17 //l=0.17 //layer=licon //count=1 \
 //x=3.33 //y=4.7 //x2=3.33 //y2=4.7
r564 (  71 174 ) resistor r=152 //w=0.17 //l=0.17 //layer=licon //count=1 \
 //x=3.33 //y=2.08 //x2=3.33 //y2=2.08
r565 (  64 66 ) resistor r=0.10734 //w=0.281 //l=0.16 //layer=m2 \
 //thickness=0.36 //x=8.88 //y=3.315 //x2=9.04 //y2=3.315
r566 (  64 65 ) resistor r=0.10734 //w=0.281 //l=0.16 //layer=m2 \
 //thickness=0.36 //x=8.88 //y=3.315 //x2=8.72 //y2=3.315
r567 (  62 65 ) resistor r=4.98092 //w=0.131 //l=5.22 //layer=m2 \
 //thickness=0.36 //x=3.5 //y=3.33 //x2=8.72 //y2=3.33
r568 (  60 62 ) resistor r=0.10734 //w=0.281 //l=0.16 //layer=m2 \
 //thickness=0.36 //x=3.34 //y=3.335 //x2=3.5 //y2=3.335
r569 (  57 68 ) resistor r=0.10734 //w=0.281 //l=0.16 //layer=m2 \
 //thickness=0.36 //x=20.185 //y=3.33 //x2=20.345 //y2=3.33
r570 (  57 66 ) resistor r=10.6345 //w=0.131 //l=11.145 //layer=m2 \
 //thickness=0.36 //x=20.185 //y=3.33 //x2=9.04 //y2=3.33
r571 (  54 127 ) resistor r=9.3 //w=0.17 //l=0.17 //layer=mcon //count=1 \
 //x=20.35 //y=4.7 //x2=20.35 //y2=4.7
r572 (  52 118 ) resistor r=9.3 //w=0.17 //l=0.17 //layer=mcon //count=1 \
 //x=20.35 //y=2.08 //x2=20.35 //y2=2.08
r573 (  49 68 ) resistor r=4.5 //w=0.15 //l=0.15 //layer=via1 //count=1 \
 //x=20.345 //y=3.33 //x2=20.345 //y2=3.33
r574 (  45 64 ) resistor r=4.5 //w=0.15 //l=0.15 //layer=via1 //count=1 \
 //x=8.88 //y=3.315 //x2=8.88 //y2=3.315
r575 (  45 47 ) resistor r=0.0049867 //w=0.376 //l=0.015 //layer=m1 \
 //thickness=0.36 //x=8.932 //y=3.315 //x2=8.932 //y2=3.33
r576 (  43 191 ) resistor r=9.3 //w=0.17 //l=0.17 //layer=mcon //count=1 \
 //x=8.395 //y=1.01 //x2=8.395 //y2=1.01
r577 (  41 101 ) resistor r=9.3 //w=0.17 //l=0.17 //layer=mcon //count=1 \
 //x=8.1 //y=5.38 //x2=8.1 //y2=5.38
r578 (  38 93 ) resistor r=9.3 //w=0.17 //l=0.17 //layer=mcon //count=1 \
 //x=7.22 //y=5.38 //x2=7.22 //y2=5.38
r579 (  36 38 ) resistor r=0.121228 //w=0.232 //l=0.225 //layer=m1 \
 //thickness=0.36 //x=7.22 //y=5.155 //x2=7.22 //y2=5.38
r580 (  35 85 ) resistor r=9.3 //w=0.17 //l=0.17 //layer=mcon //count=1 \
 //x=6.34 //y=5.38 //x2=6.34 //y2=5.38
r581 (  33 35 ) resistor r=0.129608 //w=0.217 //l=0.225 //layer=m1 \
 //thickness=0.36 //x=6.342 //y=5.155 //x2=6.342 //y2=5.38
r582 (  32 60 ) resistor r=4.5 //w=0.15 //l=0.15 //layer=via1 //count=1 \
 //x=3.34 //y=3.335 //x2=3.34 //y2=3.335
r583 (  30 32 ) resistor r=0.00168464 //w=0.371 //l=0.005 //layer=m1 \
 //thickness=0.36 //x=3.387 //y=3.33 //x2=3.387 //y2=3.335
r584 (  28 80 ) resistor r=9.3 //w=0.17 //l=0.17 //layer=mcon //count=1 \
 //x=3.33 //y=4.7 //x2=3.33 //y2=4.7
r585 (  26 71 ) resistor r=9.3 //w=0.17 //l=0.17 //layer=mcon //count=1 \
 //x=3.33 //y=2.08 //x2=3.33 //y2=2.08
r586 (  24 54 ) resistor r=0.0760407 //w=0.238 //l=0.125 //layer=m1 \
 //thickness=0.36 //x=20.35 //y=4.575 //x2=20.35 //y2=4.7
r587 (  23 49 ) resistor r=0.0910802 //w=0.374 //l=0.185472 //layer=m1 \
 //thickness=0.36 //x=20.35 //y=3.49 //x2=20.295 //y2=3.33
r588 (  23 24 ) resistor r=1.03531 //w=0.131 //l=1.085 //layer=m1 \
 //thickness=0.36 //x=20.35 //y=3.49 //x2=20.35 //y2=4.575
r589 (  22 49 ) resistor r=0.0910802 //w=0.374 //l=0.185472 //layer=m1 \
 //thickness=0.36 //x=20.35 //y=3.17 //x2=20.295 //y2=3.33
r590 (  21 52 ) resistor r=0.0719237 //w=0.222 //l=0.115 //layer=m1 \
 //thickness=0.36 //x=20.35 //y=2.195 //x2=20.35 //y2=2.08
r591 (  21 22 ) resistor r=0.930344 //w=0.131 //l=0.975 //layer=m1 \
 //thickness=0.36 //x=20.35 //y=2.195 //x2=20.35 //y2=3.17
r592 (  19 47 ) resistor r=0.0861726 //w=0.376 //l=0.169012 //layer=m1 \
 //thickness=0.36 //x=8.88 //y=3.475 //x2=8.932 //y2=3.33
r593 (  19 20 ) resistor r=1.52195 //w=0.131 //l=1.595 //layer=m1 \
 //thickness=0.36 //x=8.88 //y=3.475 //x2=8.88 //y2=5.07
r594 (  18 45 ) resistor r=0.0911593 //w=0.376 //l=0.184174 //layer=m1 \
 //thickness=0.36 //x=8.88 //y=3.155 //x2=8.932 //y2=3.315
r595 (  17 18 ) resistor r=1.34065 //w=0.131 //l=1.405 //layer=m1 \
 //thickness=0.36 //x=8.88 //y=1.75 //x2=8.88 //y2=3.155
r596 (  15 17 ) resistor r=0.0698411 //w=0.17 //l=0.120208 //layer=m1 \
 //thickness=0.36 //x=8.795 //y=1.665 //x2=8.88 //y2=1.75
r597 (  15 16 ) resistor r=0.300573 //w=0.131 //l=0.315 //layer=m1 \
 //thickness=0.36 //x=8.795 //y=1.665 //x2=8.48 //y2=1.665
r598 (  14 16 ) resistor r=0.0698411 //w=0.17 //l=0.120208 //layer=m1 \
 //thickness=0.36 //x=8.395 //y=1.58 //x2=8.48 //y2=1.665
r599 (  13 43 ) resistor r=0.0717383 //w=0.224 //l=0.115 //layer=m1 \
 //thickness=0.36 //x=8.395 //y=1.125 //x2=8.395 //y2=1.01
r600 (  13 14 ) resistor r=0.43416 //w=0.131 //l=0.455 //layer=m1 \
 //thickness=0.36 //x=8.395 //y=1.125 //x2=8.395 //y2=1.58
r601 (  12 39 ) resistor r=0.0675342 //w=0.23 //l=0.115 //layer=m1 \
 //thickness=0.36 //x=8.215 //y=5.155 //x2=8.1 //y2=5.155
r602 (  11 20 ) resistor r=0.0698411 //w=0.17 //l=0.120208 //layer=m1 \
 //thickness=0.36 //x=8.795 //y=5.155 //x2=8.88 //y2=5.07
r603 (  11 12 ) resistor r=0.553435 //w=0.131 //l=0.58 //layer=m1 \
 //thickness=0.36 //x=8.795 //y=5.155 //x2=8.215 //y2=5.155
r604 (  10 41 ) resistor r=0.00118313 //w=0.23 //layer=m1 //thickness=0.36 \
 //x=8.1 //y=5.38 //x2=8.1 //y2=5.38
r605 (  9 39 ) resistor r=0.002872 //w=0.34 //l=0.085 //layer=m1 \
 //thickness=0.36 //x=8.1 //y=5.24 //x2=8.1 //y2=5.155
r606 (  9 10 ) resistor r=0.091623 //w=0.191 //l=0.14 //layer=m1 \
 //thickness=0.36 //x=8.1 //y=5.24 //x2=8.1 //y2=5.38
r607 (  8 36 ) resistor r=0.0262263 //w=0.232 //l=0.12 //layer=m1 \
 //thickness=0.36 //x=7.34 //y=5.155 //x2=7.22 //y2=5.155
r608 (  7 39 ) resistor r=0.0675342 //w=0.23 //l=0.115 //layer=m1 \
 //thickness=0.36 //x=7.985 //y=5.155 //x2=8.1 //y2=5.155
r609 (  7 8 ) resistor r=0.615458 //w=0.131 //l=0.645 //layer=m1 \
 //thickness=0.36 //x=7.985 //y=5.155 //x2=7.34 //y2=5.155
r610 (  6 33 ) resistor r=0.0222262 //w=0.217 //l=0.118 //layer=m1 \
 //thickness=0.36 //x=6.46 //y=5.155 //x2=6.342 //y2=5.155
r611 (  5 36 ) resistor r=0.0262263 //w=0.232 //l=0.12 //layer=m1 \
 //thickness=0.36 //x=7.1 //y=5.155 //x2=7.22 //y2=5.155
r612 (  5 6 ) resistor r=0.610687 //w=0.131 //l=0.64 //layer=m1 \
 //thickness=0.36 //x=7.1 //y=5.155 //x2=6.46 //y2=5.155
r613 (  4 28 ) resistor r=0.0801089 //w=0.224 //l=0.13 //layer=m1 \
 //thickness=0.36 //x=3.33 //y=4.57 //x2=3.33 //y2=4.7
r614 (  3 32 ) resistor r=0.0909648 //w=0.371 //l=0.186333 //layer=m1 \
 //thickness=0.36 //x=3.33 //y=3.495 //x2=3.387 //y2=3.335
r615 (  3 4 ) resistor r=1.02576 //w=0.131 //l=1.075 //layer=m1 \
 //thickness=0.36 //x=3.33 //y=3.495 //x2=3.33 //y2=4.57
r616 (  2 30 ) resistor r=0.0892801 //w=0.371 //l=0.181273 //layer=m1 \
 //thickness=0.36 //x=3.33 //y=3.175 //x2=3.387 //y2=3.33
r617 (  1 26 ) resistor r=0.0719237 //w=0.222 //l=0.115 //layer=m1 \
 //thickness=0.36 //x=3.33 //y=2.195 //x2=3.33 //y2=2.08
r618 (  1 2 ) resistor r=0.935115 //w=0.131 //l=0.98 //layer=m1 \
 //thickness=0.36 //x=3.33 //y=2.195 //x2=3.33 //y2=3.175
ends PM_DFFSNRNX1_PCELL\%noxref_4

subckt PM_DFFSNRNX1_PCELL\%noxref_5 ( 1 2 3 4 5 6 25 26 27 29 31 34 41 42 45 \
 50 55 60 65 70 74 75 76 77 78 79 80 81 82 83 84 85 87 93 94 95 96 97 105 106 \
 107 112 114 117 118 119 120 121 123 129 130 131 132 133 141 150 151 156 162 )
c474 ( 162 0 ) capacitor c=0.0369044f //x=21.46 //y=4.7
c475 ( 156 0 ) capacitor c=0.0710579f //x=17.76 //y=4.7
c476 ( 151 0 ) capacitor c=0.0278202f //x=17.76 //y=1.915
c477 ( 150 0 ) capacitor c=0.0491433f //x=17.76 //y=2.08
c478 ( 141 0 ) capacitor c=0.0369044f //x=2.22 //y=4.7
c479 ( 133 0 ) capacitor c=0.0309248f //x=21.795 //y=4.79
c480 ( 132 0 ) capacitor c=0.0846044f //x=21.55 //y=1.915
c481 ( 131 0 ) capacitor c=0.0170266f //x=21.55 //y=1.45
c482 ( 130 0 ) capacitor c=0.018609f //x=21.55 //y=1.22
c483 ( 129 0 ) capacitor c=0.0186599f //x=21.55 //y=0.91
c484 ( 123 0 ) capacitor c=0.0146988f //x=21.395 //y=1.375
c485 ( 121 0 ) capacitor c=0.0148531f //x=21.395 //y=0.755
c486 ( 120 0 ) capacitor c=0.0334406f //x=21.025 //y=1.22
c487 ( 119 0 ) capacitor c=0.0173191f //x=21.025 //y=0.91
c488 ( 118 0 ) capacitor c=0.0443175f //x=18.28 //y=1.26
c489 ( 117 0 ) capacitor c=0.0199703f //x=18.28 //y=0.915
c490 ( 114 0 ) capacitor c=0.0160404f //x=18.125 //y=1.415
c491 ( 112 0 ) capacitor c=0.0157807f //x=18.125 //y=0.76
c492 ( 107 0 ) capacitor c=0.0220935f //x=17.75 //y=1.57
c493 ( 106 0 ) capacitor c=0.0207489f //x=17.75 //y=1.26
c494 ( 105 0 ) capacitor c=0.0194091f //x=17.75 //y=0.915
c495 ( 97 0 ) capacitor c=0.0309248f //x=2.555 //y=4.79
c496 ( 96 0 ) capacitor c=0.0844916f //x=2.31 //y=1.915
c497 ( 95 0 ) capacitor c=0.0170266f //x=2.31 //y=1.45
c498 ( 94 0 ) capacitor c=0.018609f //x=2.31 //y=1.22
c499 ( 93 0 ) capacitor c=0.0186599f //x=2.31 //y=0.91
c500 ( 87 0 ) capacitor c=0.0146988f //x=2.155 //y=1.375
c501 ( 85 0 ) capacitor c=0.0148531f //x=2.155 //y=0.755
c502 ( 84 0 ) capacitor c=0.0334406f //x=1.785 //y=1.22
c503 ( 83 0 ) capacitor c=0.0173191f //x=1.785 //y=0.91
c504 ( 82 0 ) capacitor c=0.110208f //x=21.87 //y=6.02
c505 ( 81 0 ) capacitor c=0.110214f //x=21.43 //y=6.02
c506 ( 80 0 ) capacitor c=0.159671f //x=17.94 //y=6.02
c507 ( 79 0 ) capacitor c=0.110208f //x=17.5 //y=6.02
c508 ( 78 0 ) capacitor c=0.110208f //x=2.63 //y=6.02
c509 ( 77 0 ) capacitor c=0.110214f //x=2.19 //y=6.02
c510 ( 70 0 ) capacitor c=0.00129934f //x=21.46 //y=4.7
c511 ( 65 0 ) capacitor c=0.00121786f //x=21.46 //y=2.08
c512 ( 60 0 ) capacitor c=7.74199e-19 //x=17.76 //y=4.7
c513 ( 55 0 ) capacitor c=0.00101179f //x=17.76 //y=2.08
c514 ( 50 0 ) capacitor c=0.00129934f //x=2.22 //y=4.7
c515 ( 45 0 ) capacitor c=0.00121786f //x=2.22 //y=2.08
c516 ( 42 0 ) capacitor c=0.0826089f //x=21.295 //y=2.23
c517 ( 41 0 ) capacitor c=0.00498615f //x=21.455 //y=2.23
c518 ( 34 0 ) capacitor c=0.056224f //x=17.925 //y=2.22
c519 ( 31 0 ) capacitor c=0.00842688f //x=15.765 //y=2.205
c520 ( 29 0 ) capacitor c=0.0238746f //x=15.165 //y=2.22
c521 ( 27 0 ) capacitor c=0.0147324f //x=13.905 //y=2.205
c522 ( 26 0 ) capacitor c=0.00763541f //x=2.38 //y=2.22
c523 ( 25 0 ) capacitor c=0.276624f //x=13.305 //y=2.22
c524 ( 6 0 ) capacitor c=0.0710049f //x=21.46 //y=4.585
c525 ( 5 0 ) capacitor c=0.0121708f //x=21.46 //y=2.39
c526 ( 4 0 ) capacitor c=0.0601468f //x=17.76 //y=4.57
c527 ( 3 0 ) capacitor c=0.013109f //x=17.76 //y=2.385
c528 ( 2 0 ) capacitor c=0.0752943f //x=2.22 //y=4.585
c529 ( 1 0 ) capacitor c=0.0108884f //x=2.22 //y=2.38
r530 (  164 165 ) resistor r=32.4568 //w=0.214 //l=0.075 //layer=ply \
 //thickness=0.18 //x=21.46 //y=4.79 //x2=21.46 //y2=4.865
r531 (  162 164 ) resistor r=20.271 //w=0.214 //l=0.09 //layer=ply \
 //thickness=0.18 //x=21.46 //y=4.7 //x2=21.46 //y2=4.79
r532 (  150 151 ) resistor r=52.7279 //w=0.214 //l=0.165 //layer=ply \
 //thickness=0.18 //x=17.76 //y=2.08 //x2=17.76 //y2=1.915
r533 (  143 144 ) resistor r=32.4568 //w=0.214 //l=0.075 //layer=ply \
 //thickness=0.18 //x=2.22 //y=4.79 //x2=2.22 //y2=4.865
r534 (  141 143 ) resistor r=20.271 //w=0.214 //l=0.09 //layer=ply \
 //thickness=0.18 //x=2.22 //y=4.7 //x2=2.22 //y2=4.79
r535 (  134 164 ) resistor r=16.5046 //w=0.27 //l=0.135 //layer=ply \
 //thickness=0.18 //x=21.595 //y=4.79 //x2=21.46 //y2=4.79
r536 (  133 135 ) resistor r=26.9307 //w=0.15 //l=0.106066 //layer=ply \
 //thickness=0.18 //x=21.795 //y=4.79 //x2=21.87 //y2=4.865
r537 (  133 134 ) resistor r=102.553 //w=0.094 //l=0.2 //layer=ply \
 //thickness=0.18 //x=21.795 //y=4.79 //x2=21.595 //y2=4.79
r538 (  132 169 ) resistor r=38.6777 //w=0.284 //l=0.198997 //layer=ply \
 //thickness=0.18 //x=21.55 //y=1.915 //x2=21.475 //y2=2.08
r539 (  131 167 ) resistor r=21.2976 //w=0.217 //l=0.0928709 //layer=ply \
 //thickness=0.18 //x=21.55 //y=1.45 //x2=21.51 //y2=1.375
r540 (  131 132 ) resistor r=238.436 //w=0.094 //l=0.465 //layer=ply \
 //thickness=0.18 //x=21.55 //y=1.45 //x2=21.55 //y2=1.915
r541 (  130 167 ) resistor r=39.0671 //w=0.217 //l=0.173853 //layer=ply \
 //thickness=0.18 //x=21.55 //y=1.22 //x2=21.51 //y2=1.375
r542 (  129 166 ) resistor r=45.1352 //w=0.168 //l=0.173853 //layer=ply \
 //thickness=0.18 //x=21.55 //y=0.91 //x2=21.51 //y2=0.755
r543 (  129 130 ) resistor r=158.957 //w=0.094 //l=0.31 //layer=ply \
 //thickness=0.18 //x=21.55 //y=0.91 //x2=21.55 //y2=1.22
r544 (  124 160 ) resistor r=5.52526 //w=0.168 //l=0.115 //layer=ply \
 //thickness=0.18 //x=21.18 //y=1.375 //x2=21.065 //y2=1.375
r545 (  123 167 ) resistor r=11.4558 //w=0.217 //l=0.115 //layer=ply \
 //thickness=0.18 //x=21.395 //y=1.375 //x2=21.51 //y2=1.375
r546 (  122 159 ) resistor r=5.52526 //w=0.168 //l=0.115 //layer=ply \
 //thickness=0.18 //x=21.18 //y=0.755 //x2=21.065 //y2=0.755
r547 (  121 166 ) resistor r=5.52526 //w=0.168 //l=0.115 //layer=ply \
 //thickness=0.18 //x=21.395 //y=0.755 //x2=21.51 //y2=0.755
r548 (  121 122 ) resistor r=110.245 //w=0.094 //l=0.215 //layer=ply \
 //thickness=0.18 //x=21.395 //y=0.755 //x2=21.18 //y2=0.755
r549 (  120 160 ) resistor r=45.1352 //w=0.168 //l=0.173853 //layer=ply \
 //thickness=0.18 //x=21.025 //y=1.22 //x2=21.065 //y2=1.375
r550 (  119 159 ) resistor r=45.1352 //w=0.168 //l=0.173853 //layer=ply \
 //thickness=0.18 //x=21.025 //y=0.91 //x2=21.065 //y2=0.755
r551 (  119 120 ) resistor r=158.957 //w=0.094 //l=0.31 //layer=ply \
 //thickness=0.18 //x=21.025 //y=0.91 //x2=21.025 //y2=1.22
r552 (  118 158 ) resistor r=45.1352 //w=0.168 //l=0.173853 //layer=ply \
 //thickness=0.18 //x=18.28 //y=1.26 //x2=18.24 //y2=1.415
r553 (  117 157 ) resistor r=45.1352 //w=0.168 //l=0.173853 //layer=ply \
 //thickness=0.18 //x=18.28 //y=0.915 //x2=18.24 //y2=0.76
r554 (  117 118 ) resistor r=176.904 //w=0.094 //l=0.345 //layer=ply \
 //thickness=0.18 //x=18.28 //y=0.915 //x2=18.28 //y2=1.26
r555 (  115 154 ) resistor r=10.701 //w=0.21 //l=0.115 //layer=ply \
 //thickness=0.18 //x=17.905 //y=1.415 //x2=17.79 //y2=1.415
r556 (  114 158 ) resistor r=5.52526 //w=0.168 //l=0.115 //layer=ply \
 //thickness=0.18 //x=18.125 //y=1.415 //x2=18.24 //y2=1.415
r557 (  113 153 ) resistor r=5.52526 //w=0.168 //l=0.115 //layer=ply \
 //thickness=0.18 //x=17.905 //y=0.76 //x2=17.79 //y2=0.76
r558 (  112 157 ) resistor r=5.52526 //w=0.168 //l=0.115 //layer=ply \
 //thickness=0.18 //x=18.125 //y=0.76 //x2=18.24 //y2=0.76
r559 (  112 113 ) resistor r=112.809 //w=0.094 //l=0.22 //layer=ply \
 //thickness=0.18 //x=18.125 //y=0.76 //x2=17.905 //y2=0.76
r560 (  109 156 ) resistor r=37.236 //w=0.233 //l=0.249199 //layer=ply \
 //thickness=0.18 //x=17.94 //y=4.865 //x2=17.76 //y2=4.7
r561 (  107 154 ) resistor r=39.5823 //w=0.21 //l=0.173853 //layer=ply \
 //thickness=0.18 //x=17.75 //y=1.57 //x2=17.79 //y2=1.415
r562 (  107 151 ) resistor r=176.904 //w=0.094 //l=0.345 //layer=ply \
 //thickness=0.18 //x=17.75 //y=1.57 //x2=17.75 //y2=1.915
r563 (  106 154 ) resistor r=39.5823 //w=0.21 //l=0.173853 //layer=ply \
 //thickness=0.18 //x=17.75 //y=1.26 //x2=17.79 //y2=1.415
r564 (  105 153 ) resistor r=45.1352 //w=0.168 //l=0.173853 //layer=ply \
 //thickness=0.18 //x=17.75 //y=0.915 //x2=17.79 //y2=0.76
r565 (  105 106 ) resistor r=176.904 //w=0.094 //l=0.345 //layer=ply \
 //thickness=0.18 //x=17.75 //y=0.915 //x2=17.75 //y2=1.26
r566 (  102 156 ) resistor r=53.7854 //w=0.233 //l=0.332415 //layer=ply \
 //thickness=0.18 //x=17.5 //y=4.865 //x2=17.76 //y2=4.7
r567 (  98 143 ) resistor r=16.5046 //w=0.27 //l=0.135 //layer=ply \
 //thickness=0.18 //x=2.355 //y=4.79 //x2=2.22 //y2=4.79
r568 (  97 99 ) resistor r=26.9307 //w=0.15 //l=0.106066 //layer=ply \
 //thickness=0.18 //x=2.555 //y=4.79 //x2=2.63 //y2=4.865
r569 (  97 98 ) resistor r=102.553 //w=0.094 //l=0.2 //layer=ply \
 //thickness=0.18 //x=2.555 //y=4.79 //x2=2.355 //y2=4.79
r570 (  96 148 ) resistor r=38.6777 //w=0.284 //l=0.198997 //layer=ply \
 //thickness=0.18 //x=2.31 //y=1.915 //x2=2.235 //y2=2.08
r571 (  95 146 ) resistor r=21.2976 //w=0.217 //l=0.0928709 //layer=ply \
 //thickness=0.18 //x=2.31 //y=1.45 //x2=2.27 //y2=1.375
r572 (  95 96 ) resistor r=238.436 //w=0.094 //l=0.465 //layer=ply \
 //thickness=0.18 //x=2.31 //y=1.45 //x2=2.31 //y2=1.915
r573 (  94 146 ) resistor r=39.0671 //w=0.217 //l=0.173853 //layer=ply \
 //thickness=0.18 //x=2.31 //y=1.22 //x2=2.27 //y2=1.375
r574 (  93 145 ) resistor r=45.1352 //w=0.168 //l=0.173853 //layer=ply \
 //thickness=0.18 //x=2.31 //y=0.91 //x2=2.27 //y2=0.755
r575 (  93 94 ) resistor r=158.957 //w=0.094 //l=0.31 //layer=ply \
 //thickness=0.18 //x=2.31 //y=0.91 //x2=2.31 //y2=1.22
r576 (  88 139 ) resistor r=5.52526 //w=0.168 //l=0.115 //layer=ply \
 //thickness=0.18 //x=1.94 //y=1.375 //x2=1.825 //y2=1.375
r577 (  87 146 ) resistor r=11.4558 //w=0.217 //l=0.115 //layer=ply \
 //thickness=0.18 //x=2.155 //y=1.375 //x2=2.27 //y2=1.375
r578 (  86 138 ) resistor r=5.52526 //w=0.168 //l=0.115 //layer=ply \
 //thickness=0.18 //x=1.94 //y=0.755 //x2=1.825 //y2=0.755
r579 (  85 145 ) resistor r=5.52526 //w=0.168 //l=0.115 //layer=ply \
 //thickness=0.18 //x=2.155 //y=0.755 //x2=2.27 //y2=0.755
r580 (  85 86 ) resistor r=110.245 //w=0.094 //l=0.215 //layer=ply \
 //thickness=0.18 //x=2.155 //y=0.755 //x2=1.94 //y2=0.755
r581 (  84 139 ) resistor r=45.1352 //w=0.168 //l=0.173853 //layer=ply \
 //thickness=0.18 //x=1.785 //y=1.22 //x2=1.825 //y2=1.375
r582 (  83 138 ) resistor r=45.1352 //w=0.168 //l=0.173853 //layer=ply \
 //thickness=0.18 //x=1.785 //y=0.91 //x2=1.825 //y2=0.755
r583 (  83 84 ) resistor r=158.957 //w=0.094 //l=0.31 //layer=ply \
 //thickness=0.18 //x=1.785 //y=0.91 //x2=1.785 //y2=1.22
r584 (  82 135 ) resistor r=592.245 //w=0.094 //l=1.155 //layer=ply \
 //thickness=0.18 //x=21.87 //y=6.02 //x2=21.87 //y2=4.865
r585 (  81 165 ) resistor r=592.245 //w=0.094 //l=1.155 //layer=ply \
 //thickness=0.18 //x=21.43 //y=6.02 //x2=21.43 //y2=4.865
r586 (  80 109 ) resistor r=592.245 //w=0.094 //l=1.155 //layer=ply \
 //thickness=0.18 //x=17.94 //y=6.02 //x2=17.94 //y2=4.865
r587 (  79 102 ) resistor r=592.245 //w=0.094 //l=1.155 //layer=ply \
 //thickness=0.18 //x=17.5 //y=6.02 //x2=17.5 //y2=4.865
r588 (  78 99 ) resistor r=592.245 //w=0.094 //l=1.155 //layer=ply \
 //thickness=0.18 //x=2.63 //y=6.02 //x2=2.63 //y2=4.865
r589 (  77 144 ) resistor r=592.245 //w=0.094 //l=1.155 //layer=ply \
 //thickness=0.18 //x=2.19 //y=6.02 //x2=2.19 //y2=4.865
r590 (  76 123 ) resistor r=55.3787 //w=0.094 //l=0.108 //layer=ply \
 //thickness=0.18 //x=21.287 //y=1.375 //x2=21.395 //y2=1.375
r591 (  76 124 ) resistor r=54.866 //w=0.094 //l=0.107 //layer=ply \
 //thickness=0.18 //x=21.287 //y=1.375 //x2=21.18 //y2=1.375
r592 (  75 114 ) resistor r=56.4043 //w=0.094 //l=0.11 //layer=ply \
 //thickness=0.18 //x=18.015 //y=1.415 //x2=18.125 //y2=1.415
r593 (  75 115 ) resistor r=56.4043 //w=0.094 //l=0.11 //layer=ply \
 //thickness=0.18 //x=18.015 //y=1.415 //x2=17.905 //y2=1.415
r594 (  74 87 ) resistor r=55.3787 //w=0.094 //l=0.108 //layer=ply \
 //thickness=0.18 //x=2.047 //y=1.375 //x2=2.155 //y2=1.375
r595 (  74 88 ) resistor r=54.866 //w=0.094 //l=0.107 //layer=ply \
 //thickness=0.18 //x=2.047 //y=1.375 //x2=1.94 //y2=1.375
r596 (  70 162 ) resistor r=152 //w=0.17 //l=0.17 //layer=licon //count=1 \
 //x=21.46 //y=4.7 //x2=21.46 //y2=4.7
r597 (  65 169 ) resistor r=152 //w=0.17 //l=0.17 //layer=licon //count=1 \
 //x=21.46 //y=2.08 //x2=21.46 //y2=2.08
r598 (  60 156 ) resistor r=152 //w=0.17 //l=0.17 //layer=licon //count=1 \
 //x=17.76 //y=4.7 //x2=17.76 //y2=4.7
r599 (  55 150 ) resistor r=152 //w=0.17 //l=0.17 //layer=licon //count=1 \
 //x=17.76 //y=2.08 //x2=17.76 //y2=2.08
r600 (  50 141 ) resistor r=152 //w=0.17 //l=0.17 //layer=licon //count=1 \
 //x=2.22 //y=4.7 //x2=2.22 //y2=4.7
r601 (  45 148 ) resistor r=152 //w=0.17 //l=0.17 //layer=licon //count=1 \
 //x=2.22 //y=2.08 //x2=2.22 //y2=2.08
r602 (  41 42 ) resistor r=0.10734 //w=0.281 //l=0.16 //layer=m2 \
 //thickness=0.36 //x=21.455 //y=2.23 //x2=21.295 //y2=2.23
r603 (  34 39 ) resistor r=0.105717 //w=0.193 //l=0.162481 //layer=m2 \
 //thickness=0.36 //x=17.925 //y=2.22 //x2=17.765 //y2=2.225
r604 (  34 42 ) resistor r=3.21565 //w=0.131 //l=3.37 //layer=m2 \
 //thickness=0.36 //x=17.925 //y=2.22 //x2=21.295 //y2=2.22
r605 (  31 39 ) resistor r=1.29743 //w=0.193 //l=2.00998 //layer=m2 \
 //thickness=0.36 //x=15.765 //y=2.205 //x2=17.765 //y2=2.225
r606 (  31 32 ) resistor r=0.410305 //w=0.131 //l=0.43 //layer=m2 \
 //thickness=0.36 //x=15.765 //y=2.205 //x2=15.335 //y2=2.205
r607 (  29 32 ) resistor r=0.125 //w=0.17 //l=0.177341 //layer=m2 \
 //thickness=0.36 //x=15.165 //y=2.22 //x2=15.335 //y2=2.205
r608 (  29 30 ) resistor r=0.958969 //w=0.131 //l=1.005 //layer=m2 \
 //thickness=0.36 //x=15.165 //y=2.22 //x2=14.16 //y2=2.22
r609 (  27 30 ) resistor r=0.1875 //w=0.17 //l=0.262393 //layer=m2 \
 //thickness=0.36 //x=13.905 //y=2.205 //x2=14.16 //y2=2.22
r610 (  27 28 ) resistor r=0.410305 //w=0.131 //l=0.43 //layer=m2 \
 //thickness=0.36 //x=13.905 //y=2.205 //x2=13.475 //y2=2.205
r611 (  26 36 ) resistor r=0.10734 //w=0.281 //l=0.16 //layer=m2 \
 //thickness=0.36 //x=2.38 //y=2.22 //x2=2.22 //y2=2.22
r612 (  25 28 ) resistor r=0.125 //w=0.17 //l=0.177341 //layer=m2 \
 //thickness=0.36 //x=13.305 //y=2.22 //x2=13.475 //y2=2.205
r613 (  25 26 ) resistor r=10.4246 //w=0.131 //l=10.925 //layer=m2 \
 //thickness=0.36 //x=13.305 //y=2.22 //x2=2.38 //y2=2.22
r614 (  24 41 ) resistor r=4.5 //w=0.15 //l=0.15 //layer=via1 //count=1 \
 //x=21.455 //y=2.23 //x2=21.455 //y2=2.23
r615 (  22 65 ) resistor r=9.3 //w=0.17 //l=0.17 //layer=mcon //count=1 \
 //x=21.46 //y=2.08 //x2=21.46 //y2=2.08
r616 (  22 24 ) resistor r=0.065331 //w=0.287 //l=0.15 //layer=m1 \
 //thickness=0.36 //x=21.455 //y=2.08 //x2=21.455 //y2=2.23
r617 (  20 70 ) resistor r=9.3 //w=0.17 //l=0.17 //layer=mcon //count=1 \
 //x=21.46 //y=4.7 //x2=21.46 //y2=4.7
r618 (  18 39 ) resistor r=4.5 //w=0.15 //l=0.15 //layer=via1 //count=1 \
 //x=17.765 //y=2.225 //x2=17.765 //y2=2.225
r619 (  16 55 ) resistor r=9.3 //w=0.17 //l=0.17 //layer=mcon //count=1 \
 //x=17.76 //y=2.08 //x2=17.76 //y2=2.08
r620 (  16 18 ) resistor r=0.0631533 //w=0.287 //l=0.145 //layer=m1 \
 //thickness=0.36 //x=17.765 //y=2.08 //x2=17.765 //y2=2.225
r621 (  14 60 ) resistor r=9.3 //w=0.17 //l=0.17 //layer=mcon //count=1 \
 //x=17.76 //y=4.7 //x2=17.76 //y2=4.7
r622 (  12 36 ) resistor r=4.5 //w=0.15 //l=0.15 //layer=via1 //count=1 \
 //x=2.22 //y=2.22 //x2=2.22 //y2=2.22
r623 (  10 45 ) resistor r=9.3 //w=0.17 //l=0.17 //layer=mcon //count=1 \
 //x=2.22 //y=2.08 //x2=2.22 //y2=2.08
r624 (  10 12 ) resistor r=0.0607639 //w=0.288 //l=0.14 //layer=m1 \
 //thickness=0.36 //x=2.22 //y=2.08 //x2=2.22 //y2=2.22
r625 (  8 50 ) resistor r=9.3 //w=0.17 //l=0.17 //layer=mcon //count=1 \
 //x=2.22 //y=4.7 //x2=2.22 //y2=4.7
r626 (  6 20 ) resistor r=0.0717383 //w=0.224 //l=0.115 //layer=m1 \
 //thickness=0.36 //x=21.46 //y=4.585 //x2=21.46 //y2=4.7
r627 (  5 24 ) resistor r=0.0902915 //w=0.287 //l=0.162481 //layer=m1 \
 //thickness=0.36 //x=21.46 //y=2.39 //x2=21.455 //y2=2.23
r628 (  5 6 ) resistor r=2.09447 //w=0.131 //l=2.195 //layer=m1 \
 //thickness=0.36 //x=21.46 //y=2.39 //x2=21.46 //y2=4.585
r629 (  4 14 ) resistor r=0.0801089 //w=0.224 //l=0.13 //layer=m1 \
 //thickness=0.36 //x=17.76 //y=4.57 //x2=17.76 //y2=4.7
r630 (  3 18 ) resistor r=0.0902915 //w=0.287 //l=0.162481 //layer=m1 \
 //thickness=0.36 //x=17.76 //y=2.385 //x2=17.765 //y2=2.225
r631 (  3 4 ) resistor r=2.08492 //w=0.131 //l=2.185 //layer=m1 \
 //thickness=0.36 //x=17.76 //y=2.385 //x2=17.76 //y2=4.57
r632 (  2 8 ) resistor r=0.0717383 //w=0.224 //l=0.115 //layer=m1 \
 //thickness=0.36 //x=2.22 //y=4.585 //x2=2.22 //y2=4.7
r633 (  1 12 ) resistor r=0.0902565 //w=0.288 //l=0.16 //layer=m1 \
 //thickness=0.36 //x=2.22 //y=2.38 //x2=2.22 //y2=2.22
r634 (  1 2 ) resistor r=2.10401 //w=0.131 //l=2.205 //layer=m1 \
 //thickness=0.36 //x=2.22 //y=2.38 //x2=2.22 //y2=4.585
ends PM_DFFSNRNX1_PCELL\%noxref_5

subckt PM_DFFSNRNX1_PCELL\%noxref_6 ( 1 2 3 4 5 6 7 8 16 18 25 27 29 31 33 35 \
 40 44 53 58 67 71 72 73 74 75 76 77 78 79 81 87 88 89 90 91 96 97 98 100 106 \
 107 108 109 110 118 129 )
c332 ( 129 0 ) capacitor c=0.0369044f //x=26.27 //y=4.7
c333 ( 118 0 ) capacitor c=0.0369044f //x=11.84 //y=4.7
c334 ( 110 0 ) capacitor c=0.0309248f //x=26.605 //y=4.79
c335 ( 109 0 ) capacitor c=0.0819978f //x=26.36 //y=1.915
c336 ( 108 0 ) capacitor c=0.0170266f //x=26.36 //y=1.45
c337 ( 107 0 ) capacitor c=0.018609f //x=26.36 //y=1.22
c338 ( 106 0 ) capacitor c=0.0186599f //x=26.36 //y=0.91
c339 ( 100 0 ) capacitor c=0.0146988f //x=26.205 //y=1.375
c340 ( 98 0 ) capacitor c=0.0148531f //x=26.205 //y=0.755
c341 ( 97 0 ) capacitor c=0.0334406f //x=25.835 //y=1.22
c342 ( 96 0 ) capacitor c=0.0173191f //x=25.835 //y=0.91
c343 ( 91 0 ) capacitor c=0.0309248f //x=12.175 //y=4.79
c344 ( 90 0 ) capacitor c=0.0818898f //x=11.93 //y=1.915
c345 ( 89 0 ) capacitor c=0.0170266f //x=11.93 //y=1.45
c346 ( 88 0 ) capacitor c=0.018609f //x=11.93 //y=1.22
c347 ( 87 0 ) capacitor c=0.0186599f //x=11.93 //y=0.91
c348 ( 81 0 ) capacitor c=0.0146988f //x=11.775 //y=1.375
c349 ( 79 0 ) capacitor c=0.0148531f //x=11.775 //y=0.755
c350 ( 78 0 ) capacitor c=0.0334406f //x=11.405 //y=1.22
c351 ( 77 0 ) capacitor c=0.0173191f //x=11.405 //y=0.91
c352 ( 76 0 ) capacitor c=0.110208f //x=26.68 //y=6.02
c353 ( 75 0 ) capacitor c=0.110214f //x=26.24 //y=6.02
c354 ( 74 0 ) capacitor c=0.110208f //x=12.25 //y=6.02
c355 ( 73 0 ) capacitor c=0.110214f //x=11.81 //y=6.02
c356 ( 67 0 ) capacitor c=0.00129934f //x=26.27 //y=4.7
c357 ( 58 0 ) capacitor c=9.49278e-19 //x=26.27 //y=2.08
c358 ( 53 0 ) capacitor c=0.00129934f //x=11.84 //y=4.7
c359 ( 44 0 ) capacitor c=9.49278e-19 //x=11.84 //y=2.08
c360 ( 40 0 ) capacitor c=4.39244e-19 //x=12 //y=2.945
c361 ( 35 0 ) capacitor c=0.145407f //x=20.56 //y=2.945
c362 ( 33 0 ) capacitor c=0.0513644f //x=19.96 //y=2.96
c363 ( 31 0 ) capacitor c=0.00439983f //x=15.765 //y=2.975
c364 ( 29 0 ) capacitor c=0.0180186f //x=15.165 //y=2.96
c365 ( 27 0 ) capacitor c=0.0040604f //x=13.905 //y=2.975
c366 ( 25 0 ) capacitor c=0.0152008f //x=13.305 //y=2.96
c367 ( 18 0 ) capacitor c=0.015039f //x=26.27 //y=2.96
c368 ( 16 0 ) capacitor c=0.015039f //x=11.84 //y=2.96
c369 ( 8 0 ) capacitor c=0.0499764f //x=26.27 //y=4.585
c370 ( 7 0 ) capacitor c=0.0127136f //x=26.27 //y=3.125
c371 ( 6 0 ) capacitor c=0.0172259f //x=26.27 //y=2.805
c372 ( 5 0 ) capacitor c=0.00511599f //x=26.27 //y=2.195
c373 ( 4 0 ) capacitor c=0.0461562f //x=11.84 //y=4.585
c374 ( 3 0 ) capacitor c=0.0127247f //x=11.84 //y=3.105
c375 ( 2 0 ) capacitor c=0.0114361f //x=11.84 //y=2.785
c376 ( 1 0 ) capacitor c=0.00380207f //x=11.84 //y=2.195
r377 (  131 132 ) resistor r=32.4568 //w=0.214 //l=0.075 //layer=ply \
 //thickness=0.18 //x=26.27 //y=4.79 //x2=26.27 //y2=4.865
r378 (  129 131 ) resistor r=20.271 //w=0.214 //l=0.09 //layer=ply \
 //thickness=0.18 //x=26.27 //y=4.7 //x2=26.27 //y2=4.79
r379 (  120 121 ) resistor r=32.4568 //w=0.214 //l=0.075 //layer=ply \
 //thickness=0.18 //x=11.84 //y=4.79 //x2=11.84 //y2=4.865
r380 (  118 120 ) resistor r=20.271 //w=0.214 //l=0.09 //layer=ply \
 //thickness=0.18 //x=11.84 //y=4.7 //x2=11.84 //y2=4.79
r381 (  111 131 ) resistor r=16.5046 //w=0.27 //l=0.135 //layer=ply \
 //thickness=0.18 //x=26.405 //y=4.79 //x2=26.27 //y2=4.79
r382 (  110 112 ) resistor r=26.9307 //w=0.15 //l=0.106066 //layer=ply \
 //thickness=0.18 //x=26.605 //y=4.79 //x2=26.68 //y2=4.865
r383 (  110 111 ) resistor r=102.553 //w=0.094 //l=0.2 //layer=ply \
 //thickness=0.18 //x=26.605 //y=4.79 //x2=26.405 //y2=4.79
r384 (  109 136 ) resistor r=38.6777 //w=0.284 //l=0.198997 //layer=ply \
 //thickness=0.18 //x=26.36 //y=1.915 //x2=26.285 //y2=2.08
r385 (  108 134 ) resistor r=21.2976 //w=0.217 //l=0.0928709 //layer=ply \
 //thickness=0.18 //x=26.36 //y=1.45 //x2=26.32 //y2=1.375
r386 (  108 109 ) resistor r=238.436 //w=0.094 //l=0.465 //layer=ply \
 //thickness=0.18 //x=26.36 //y=1.45 //x2=26.36 //y2=1.915
r387 (  107 134 ) resistor r=39.0671 //w=0.217 //l=0.173853 //layer=ply \
 //thickness=0.18 //x=26.36 //y=1.22 //x2=26.32 //y2=1.375
r388 (  106 133 ) resistor r=45.1352 //w=0.168 //l=0.173853 //layer=ply \
 //thickness=0.18 //x=26.36 //y=0.91 //x2=26.32 //y2=0.755
r389 (  106 107 ) resistor r=158.957 //w=0.094 //l=0.31 //layer=ply \
 //thickness=0.18 //x=26.36 //y=0.91 //x2=26.36 //y2=1.22
r390 (  101 127 ) resistor r=5.52526 //w=0.168 //l=0.115 //layer=ply \
 //thickness=0.18 //x=25.99 //y=1.375 //x2=25.875 //y2=1.375
r391 (  100 134 ) resistor r=11.4558 //w=0.217 //l=0.115 //layer=ply \
 //thickness=0.18 //x=26.205 //y=1.375 //x2=26.32 //y2=1.375
r392 (  99 126 ) resistor r=5.52526 //w=0.168 //l=0.115 //layer=ply \
 //thickness=0.18 //x=25.99 //y=0.755 //x2=25.875 //y2=0.755
r393 (  98 133 ) resistor r=5.52526 //w=0.168 //l=0.115 //layer=ply \
 //thickness=0.18 //x=26.205 //y=0.755 //x2=26.32 //y2=0.755
r394 (  98 99 ) resistor r=110.245 //w=0.094 //l=0.215 //layer=ply \
 //thickness=0.18 //x=26.205 //y=0.755 //x2=25.99 //y2=0.755
r395 (  97 127 ) resistor r=45.1352 //w=0.168 //l=0.173853 //layer=ply \
 //thickness=0.18 //x=25.835 //y=1.22 //x2=25.875 //y2=1.375
r396 (  96 126 ) resistor r=45.1352 //w=0.168 //l=0.173853 //layer=ply \
 //thickness=0.18 //x=25.835 //y=0.91 //x2=25.875 //y2=0.755
r397 (  96 97 ) resistor r=158.957 //w=0.094 //l=0.31 //layer=ply \
 //thickness=0.18 //x=25.835 //y=0.91 //x2=25.835 //y2=1.22
r398 (  92 120 ) resistor r=16.5046 //w=0.27 //l=0.135 //layer=ply \
 //thickness=0.18 //x=11.975 //y=4.79 //x2=11.84 //y2=4.79
r399 (  91 93 ) resistor r=26.9307 //w=0.15 //l=0.106066 //layer=ply \
 //thickness=0.18 //x=12.175 //y=4.79 //x2=12.25 //y2=4.865
r400 (  91 92 ) resistor r=102.553 //w=0.094 //l=0.2 //layer=ply \
 //thickness=0.18 //x=12.175 //y=4.79 //x2=11.975 //y2=4.79
r401 (  90 125 ) resistor r=38.6777 //w=0.284 //l=0.198997 //layer=ply \
 //thickness=0.18 //x=11.93 //y=1.915 //x2=11.855 //y2=2.08
r402 (  89 123 ) resistor r=21.2976 //w=0.217 //l=0.0928709 //layer=ply \
 //thickness=0.18 //x=11.93 //y=1.45 //x2=11.89 //y2=1.375
r403 (  89 90 ) resistor r=238.436 //w=0.094 //l=0.465 //layer=ply \
 //thickness=0.18 //x=11.93 //y=1.45 //x2=11.93 //y2=1.915
r404 (  88 123 ) resistor r=39.0671 //w=0.217 //l=0.173853 //layer=ply \
 //thickness=0.18 //x=11.93 //y=1.22 //x2=11.89 //y2=1.375
r405 (  87 122 ) resistor r=45.1352 //w=0.168 //l=0.173853 //layer=ply \
 //thickness=0.18 //x=11.93 //y=0.91 //x2=11.89 //y2=0.755
r406 (  87 88 ) resistor r=158.957 //w=0.094 //l=0.31 //layer=ply \
 //thickness=0.18 //x=11.93 //y=0.91 //x2=11.93 //y2=1.22
r407 (  82 116 ) resistor r=5.52526 //w=0.168 //l=0.115 //layer=ply \
 //thickness=0.18 //x=11.56 //y=1.375 //x2=11.445 //y2=1.375
r408 (  81 123 ) resistor r=11.4558 //w=0.217 //l=0.115 //layer=ply \
 //thickness=0.18 //x=11.775 //y=1.375 //x2=11.89 //y2=1.375
r409 (  80 115 ) resistor r=5.52526 //w=0.168 //l=0.115 //layer=ply \
 //thickness=0.18 //x=11.56 //y=0.755 //x2=11.445 //y2=0.755
r410 (  79 122 ) resistor r=5.52526 //w=0.168 //l=0.115 //layer=ply \
 //thickness=0.18 //x=11.775 //y=0.755 //x2=11.89 //y2=0.755
r411 (  79 80 ) resistor r=110.245 //w=0.094 //l=0.215 //layer=ply \
 //thickness=0.18 //x=11.775 //y=0.755 //x2=11.56 //y2=0.755
r412 (  78 116 ) resistor r=45.1352 //w=0.168 //l=0.173853 //layer=ply \
 //thickness=0.18 //x=11.405 //y=1.22 //x2=11.445 //y2=1.375
r413 (  77 115 ) resistor r=45.1352 //w=0.168 //l=0.173853 //layer=ply \
 //thickness=0.18 //x=11.405 //y=0.91 //x2=11.445 //y2=0.755
r414 (  77 78 ) resistor r=158.957 //w=0.094 //l=0.31 //layer=ply \
 //thickness=0.18 //x=11.405 //y=0.91 //x2=11.405 //y2=1.22
r415 (  76 112 ) resistor r=592.245 //w=0.094 //l=1.155 //layer=ply \
 //thickness=0.18 //x=26.68 //y=6.02 //x2=26.68 //y2=4.865
r416 (  75 132 ) resistor r=592.245 //w=0.094 //l=1.155 //layer=ply \
 //thickness=0.18 //x=26.24 //y=6.02 //x2=26.24 //y2=4.865
r417 (  74 93 ) resistor r=592.245 //w=0.094 //l=1.155 //layer=ply \
 //thickness=0.18 //x=12.25 //y=6.02 //x2=12.25 //y2=4.865
r418 (  73 121 ) resistor r=592.245 //w=0.094 //l=1.155 //layer=ply \
 //thickness=0.18 //x=11.81 //y=6.02 //x2=11.81 //y2=4.865
r419 (  72 100 ) resistor r=55.3787 //w=0.094 //l=0.108 //layer=ply \
 //thickness=0.18 //x=26.097 //y=1.375 //x2=26.205 //y2=1.375
r420 (  72 101 ) resistor r=54.866 //w=0.094 //l=0.107 //layer=ply \
 //thickness=0.18 //x=26.097 //y=1.375 //x2=25.99 //y2=1.375
r421 (  71 81 ) resistor r=55.3787 //w=0.094 //l=0.108 //layer=ply \
 //thickness=0.18 //x=11.667 //y=1.375 //x2=11.775 //y2=1.375
r422 (  71 82 ) resistor r=54.866 //w=0.094 //l=0.107 //layer=ply \
 //thickness=0.18 //x=11.667 //y=1.375 //x2=11.56 //y2=1.375
r423 (  67 129 ) resistor r=152 //w=0.17 //l=0.17 //layer=licon //count=1 \
 //x=26.27 //y=4.7 //x2=26.27 //y2=4.7
r424 (  58 136 ) resistor r=152 //w=0.17 //l=0.17 //layer=licon //count=1 \
 //x=26.27 //y=2.08 //x2=26.27 //y2=2.08
r425 (  53 118 ) resistor r=152 //w=0.17 //l=0.17 //layer=licon //count=1 \
 //x=11.84 //y=4.7 //x2=11.84 //y2=4.7
r426 (  44 125 ) resistor r=152 //w=0.17 //l=0.17 //layer=licon //count=1 \
 //x=11.84 //y=2.08 //x2=11.84 //y2=2.08
r427 (  38 40 ) resistor r=0.10734 //w=0.281 //l=0.16 //layer=m2 \
 //thickness=0.36 //x=11.84 //y=2.945 //x2=12 //y2=2.945
r428 (  35 42 ) resistor r=3.98787 //w=0.179 //l=5.71999 //layer=m2 \
 //thickness=0.36 //x=20.56 //y=2.945 //x2=26.27 //y2=2.965
r429 (  35 36 ) resistor r=0.410305 //w=0.131 //l=0.43 //layer=m2 \
 //thickness=0.36 //x=20.56 //y=2.945 //x2=20.13 //y2=2.945
r430 (  33 36 ) resistor r=0.125 //w=0.17 //l=0.177341 //layer=m2 \
 //thickness=0.36 //x=19.96 //y=2.96 //x2=20.13 //y2=2.945
r431 (  33 34 ) resistor r=3.84065 //w=0.131 //l=4.025 //layer=m2 \
 //thickness=0.36 //x=19.96 //y=2.96 //x2=15.935 //y2=2.96
r432 (  31 34 ) resistor r=0.125 //w=0.17 //l=0.177341 //layer=m2 \
 //thickness=0.36 //x=15.765 //y=2.975 //x2=15.935 //y2=2.96
r433 (  31 32 ) resistor r=0.329198 //w=0.131 //l=0.345 //layer=m2 \
 //thickness=0.36 //x=15.765 //y=2.975 //x2=15.42 //y2=2.975
r434 (  29 32 ) resistor r=0.1875 //w=0.17 //l=0.262393 //layer=m2 \
 //thickness=0.36 //x=15.165 //y=2.96 //x2=15.42 //y2=2.975
r435 (  29 30 ) resistor r=1.04008 //w=0.131 //l=1.09 //layer=m2 \
 //thickness=0.36 //x=15.165 //y=2.96 //x2=14.075 //y2=2.96
r436 (  27 30 ) resistor r=0.125 //w=0.17 //l=0.177341 //layer=m2 \
 //thickness=0.36 //x=13.905 //y=2.975 //x2=14.075 //y2=2.96
r437 (  27 28 ) resistor r=0.329198 //w=0.131 //l=0.345 //layer=m2 \
 //thickness=0.36 //x=13.905 //y=2.975 //x2=13.56 //y2=2.975
r438 (  25 28 ) resistor r=0.1875 //w=0.17 //l=0.262393 //layer=m2 \
 //thickness=0.36 //x=13.305 //y=2.96 //x2=13.56 //y2=2.975
r439 (  25 40 ) resistor r=1.24523 //w=0.131 //l=1.305 //layer=m2 \
 //thickness=0.36 //x=13.305 //y=2.96 //x2=12 //y2=2.96
r440 (  24 67 ) resistor r=9.3 //w=0.17 //l=0.17 //layer=mcon //count=1 \
 //x=26.27 //y=4.7 //x2=26.27 //y2=4.7
r441 (  22 58 ) resistor r=9.3 //w=0.17 //l=0.17 //layer=mcon //count=1 \
 //x=26.27 //y=2.08 //x2=26.27 //y2=2.08
r442 (  20 42 ) resistor r=4.5 //w=0.15 //l=0.15 //layer=via1 //count=1 \
 //x=26.27 //y=2.965 //x2=26.27 //y2=2.965
r443 (  18 20 ) resistor r=0.00166223 //w=0.376 //l=0.005 //layer=m1 \
 //thickness=0.36 //x=26.217 //y=2.96 //x2=26.217 //y2=2.965
r444 (  14 38 ) resistor r=4.5 //w=0.15 //l=0.15 //layer=via1 //count=1 \
 //x=11.84 //y=2.945 //x2=11.84 //y2=2.945
r445 (  14 16 ) resistor r=0.0049867 //w=0.376 //l=0.015 //layer=m1 \
 //thickness=0.36 //x=11.892 //y=2.945 //x2=11.892 //y2=2.96
r446 (  12 53 ) resistor r=9.3 //w=0.17 //l=0.17 //layer=mcon //count=1 \
 //x=11.84 //y=4.7 //x2=11.84 //y2=4.7
r447 (  10 44 ) resistor r=9.3 //w=0.17 //l=0.17 //layer=mcon //count=1 \
 //x=11.84 //y=2.08 //x2=11.84 //y2=2.08
r448 (  8 24 ) resistor r=0.0717383 //w=0.224 //l=0.115 //layer=m1 \
 //thickness=0.36 //x=26.27 //y=4.585 //x2=26.27 //y2=4.7
r449 (  7 20 ) resistor r=0.0911593 //w=0.376 //l=0.184608 //layer=m1 \
 //thickness=0.36 //x=26.27 //y=3.125 //x2=26.217 //y2=2.965
r450 (  7 8 ) resistor r=1.39313 //w=0.131 //l=1.46 //layer=m1 \
 //thickness=0.36 //x=26.27 //y=3.125 //x2=26.27 //y2=4.585
r451 (  6 18 ) resistor r=0.0894971 //w=0.376 //l=0.179555 //layer=m1 \
 //thickness=0.36 //x=26.27 //y=2.805 //x2=26.217 //y2=2.96
r452 (  5 22 ) resistor r=0.0715665 //w=0.226 //l=0.115996 //layer=m1 \
 //thickness=0.36 //x=26.27 //y=2.195 //x2=26.272 //y2=2.08
r453 (  5 6 ) resistor r=0.582061 //w=0.131 //l=0.61 //layer=m1 \
 //thickness=0.36 //x=26.27 //y=2.195 //x2=26.27 //y2=2.805
r454 (  4 12 ) resistor r=0.0717383 //w=0.224 //l=0.115 //layer=m1 \
 //thickness=0.36 //x=11.84 //y=4.585 //x2=11.84 //y2=4.7
r455 (  3 16 ) resistor r=0.0861726 //w=0.376 //l=0.169012 //layer=m1 \
 //thickness=0.36 //x=11.84 //y=3.105 //x2=11.892 //y2=2.96
r456 (  3 4 ) resistor r=1.41221 //w=0.131 //l=1.48 //layer=m1 \
 //thickness=0.36 //x=11.84 //y=3.105 //x2=11.84 //y2=4.585
r457 (  2 14 ) resistor r=0.0911593 //w=0.376 //l=0.184174 //layer=m1 \
 //thickness=0.36 //x=11.84 //y=2.785 //x2=11.892 //y2=2.945
r458 (  1 10 ) resistor r=0.0715665 //w=0.226 //l=0.115996 //layer=m1 \
 //thickness=0.36 //x=11.84 //y=2.195 //x2=11.842 //y2=2.08
r459 (  1 2 ) resistor r=0.562977 //w=0.131 //l=0.59 //layer=m1 \
 //thickness=0.36 //x=11.84 //y=2.195 //x2=11.84 //y2=2.785
ends PM_DFFSNRNX1_PCELL\%noxref_6

subckt PM_DFFSNRNX1_PCELL\%noxref_7 ( 1 2 3 4 5 6 7 8 9 11 14 15 17 18 19 20 \
 22 23 24 25 26 27 28 34 38 45 48 51 57 61 70 72 73 77 80 81 87 96 101 110 115 \
 123 131 148 157 161 162 163 164 165 166 167 168 169 173 174 175 180 182 185 \
 186 190 191 192 197 199 202 203 207 208 209 214 216 219 220 222 223 228 232 \
 233 238 242 243 248 251 253 254 255 )
c558 ( 251 0 ) capacitor c=0.00885916f //x=17.825 //y=0.915
c559 ( 248 0 ) capacitor c=0.0651477f //x=27.38 //y=4.7
c560 ( 243 0 ) capacitor c=0.0296417f //x=27.38 //y=1.915
c561 ( 242 0 ) capacitor c=0.0504963f //x=27.38 //y=2.08
c562 ( 238 0 ) capacitor c=0.0651406f //x=12.95 //y=4.7
c563 ( 233 0 ) capacitor c=0.0278202f //x=12.95 //y=1.915
c564 ( 232 0 ) capacitor c=0.0503043f //x=12.95 //y=2.08
c565 ( 228 0 ) capacitor c=0.0653609f //x=8.14 //y=4.7
c566 ( 223 0 ) capacitor c=0.0278202f //x=8.14 //y=1.915
c567 ( 222 0 ) capacitor c=0.0503043f //x=8.14 //y=2.08
c568 ( 220 0 ) capacitor c=0.0443175f //x=27.9 //y=1.26
c569 ( 219 0 ) capacitor c=0.0199703f //x=27.9 //y=0.915
c570 ( 216 0 ) capacitor c=0.0162526f //x=27.745 //y=1.415
c571 ( 214 0 ) capacitor c=0.0157807f //x=27.745 //y=0.76
c572 ( 209 0 ) capacitor c=0.0220935f //x=27.37 //y=1.57
c573 ( 208 0 ) capacitor c=0.0207489f //x=27.37 //y=1.26
c574 ( 207 0 ) capacitor c=0.0194091f //x=27.37 //y=0.915
c575 ( 203 0 ) capacitor c=0.0443175f //x=13.47 //y=1.26
c576 ( 202 0 ) capacitor c=0.0199703f //x=13.47 //y=0.915
c577 ( 199 0 ) capacitor c=0.0162526f //x=13.315 //y=1.415
c578 ( 197 0 ) capacitor c=0.0157807f //x=13.315 //y=0.76
c579 ( 192 0 ) capacitor c=0.0220935f //x=12.94 //y=1.57
c580 ( 191 0 ) capacitor c=0.0207489f //x=12.94 //y=1.26
c581 ( 190 0 ) capacitor c=0.0194091f //x=12.94 //y=0.915
c582 ( 186 0 ) capacitor c=0.0443175f //x=8.66 //y=1.26
c583 ( 185 0 ) capacitor c=0.0199703f //x=8.66 //y=0.915
c584 ( 182 0 ) capacitor c=0.0162526f //x=8.505 //y=1.415
c585 ( 180 0 ) capacitor c=0.0157807f //x=8.505 //y=0.76
c586 ( 175 0 ) capacitor c=0.0220935f //x=8.13 //y=1.57
c587 ( 174 0 ) capacitor c=0.0207489f //x=8.13 //y=1.26
c588 ( 173 0 ) capacitor c=0.0194091f //x=8.13 //y=0.915
c589 ( 169 0 ) capacitor c=0.161796f //x=27.56 //y=6.02
c590 ( 168 0 ) capacitor c=0.110208f //x=27.12 //y=6.02
c591 ( 167 0 ) capacitor c=0.159671f //x=13.13 //y=6.02
c592 ( 166 0 ) capacitor c=0.110208f //x=12.69 //y=6.02
c593 ( 165 0 ) capacitor c=0.159671f //x=8.32 //y=6.02
c594 ( 164 0 ) capacitor c=0.110208f //x=7.88 //y=6.02
c595 ( 157 0 ) capacitor c=7.74199e-19 //x=27.38 //y=4.7
c596 ( 148 0 ) capacitor c=0.00101179f //x=27.38 //y=2.08
c597 ( 131 0 ) capacitor c=0.0293124f //x=17.72 //y=5.38
c598 ( 123 0 ) capacitor c=0.029137f //x=16.84 //y=5.38
c599 ( 115 0 ) capacitor c=0.0278099f //x=15.96 //y=5.38
c600 ( 110 0 ) capacitor c=7.74199e-19 //x=12.95 //y=4.7
c601 ( 101 0 ) capacitor c=0.00101179f //x=12.95 //y=2.08
c602 ( 96 0 ) capacitor c=7.74199e-19 //x=8.14 //y=4.7
c603 ( 87 0 ) capacitor c=0.00101179f //x=8.14 //y=2.08
c604 ( 81 0 ) capacitor c=7.011e-19 //x=13.11 //y=3.715
c605 ( 80 0 ) capacitor c=0.0540867f //x=12.79 //y=3.715
c606 ( 77 0 ) capacitor c=7.011e-19 //x=8.3 //y=3.715
c607 ( 73 0 ) capacitor c=0.0585154f //x=20.215 //y=3.715
c608 ( 72 0 ) capacitor c=0.211272f //x=20.56 //y=3.715
c609 ( 70 0 ) capacitor c=0.081831f //x=18.33 //y=3.7
c610 ( 61 0 ) capacitor c=0.0149589f //x=27.38 //y=3.7
c611 ( 57 0 ) capacitor c=0.0159778f //x=18.5 //y=3.7
c612 ( 51 0 ) capacitor c=0.0012264f //x=17.72 //y=5.155
c613 ( 48 0 ) capacitor c=0.00757116f //x=16.84 //y=5.155
c614 ( 45 0 ) capacitor c=0.0111234f //x=15.962 //y=5.155
c615 ( 38 0 ) capacitor c=0.0149589f //x=12.95 //y=3.7
c616 ( 34 0 ) capacitor c=0.0149589f //x=8.14 //y=3.7
c617 ( 28 0 ) capacitor c=0.0232166f //x=27.38 //y=4.57
c618 ( 27 0 ) capacitor c=0.0110292f //x=27.38 //y=3.865
c619 ( 26 0 ) capacitor c=0.0365666f //x=27.38 //y=3.545
c620 ( 25 0 ) capacitor c=0.00730541f //x=27.38 //y=2.195
c621 ( 24 0 ) capacitor c=0.0344233f //x=18.5 //y=5.07
c622 ( 23 0 ) capacitor c=0.0130765f //x=18.5 //y=3.875
c623 ( 22 0 ) capacitor c=0.0490588f //x=18.5 //y=3.555
c624 ( 20 0 ) capacitor c=0.00493487f //x=18.1 //y=1.665
c625 ( 19 0 ) capacitor c=0.0133342f //x=18.415 //y=1.665
c626 ( 18 0 ) capacitor c=0.0167992f //x=18.015 //y=1.58
c627 ( 17 0 ) capacitor c=0.0111491f //x=18.015 //y=1.125
c628 ( 15 0 ) capacitor c=0.0260364f //x=18.415 //y=5.155
c629 ( 14 0 ) capacitor c=0.00933983f //x=17.72 //y=5.38
c630 ( 11 0 ) capacitor c=0.0204726f //x=17.605 //y=5.155
c631 ( 9 0 ) capacitor c=0.0149191f //x=16.72 //y=5.155
c632 ( 8 0 ) capacitor c=0.0218739f //x=12.95 //y=4.57
c633 ( 7 0 ) capacitor c=0.0114939f //x=12.95 //y=3.875
c634 ( 6 0 ) capacitor c=0.029293f //x=12.95 //y=3.555
c635 ( 5 0 ) capacitor c=0.00556102f //x=12.95 //y=2.195
c636 ( 4 0 ) capacitor c=0.0217459f //x=8.14 //y=4.57
c637 ( 3 0 ) capacitor c=0.0115214f //x=8.14 //y=3.875
c638 ( 2 0 ) capacitor c=0.0332627f //x=8.14 //y=3.555
c639 ( 1 0 ) capacitor c=0.00556102f //x=8.14 //y=2.195
r640 (  242 243 ) resistor r=52.7279 //w=0.214 //l=0.165 //layer=ply \
 //thickness=0.18 //x=27.38 //y=2.08 //x2=27.38 //y2=1.915
r641 (  232 233 ) resistor r=52.7279 //w=0.214 //l=0.165 //layer=ply \
 //thickness=0.18 //x=12.95 //y=2.08 //x2=12.95 //y2=1.915
r642 (  222 223 ) resistor r=52.7279 //w=0.214 //l=0.165 //layer=ply \
 //thickness=0.18 //x=8.14 //y=2.08 //x2=8.14 //y2=1.915
r643 (  220 250 ) resistor r=45.1352 //w=0.168 //l=0.173853 //layer=ply \
 //thickness=0.18 //x=27.9 //y=1.26 //x2=27.86 //y2=1.415
r644 (  219 249 ) resistor r=45.1352 //w=0.168 //l=0.173853 //layer=ply \
 //thickness=0.18 //x=27.9 //y=0.915 //x2=27.86 //y2=0.76
r645 (  219 220 ) resistor r=176.904 //w=0.094 //l=0.345 //layer=ply \
 //thickness=0.18 //x=27.9 //y=0.915 //x2=27.9 //y2=1.26
r646 (  217 246 ) resistor r=10.701 //w=0.21 //l=0.115 //layer=ply \
 //thickness=0.18 //x=27.525 //y=1.415 //x2=27.41 //y2=1.415
r647 (  216 250 ) resistor r=5.52526 //w=0.168 //l=0.115 //layer=ply \
 //thickness=0.18 //x=27.745 //y=1.415 //x2=27.86 //y2=1.415
r648 (  215 245 ) resistor r=5.52526 //w=0.168 //l=0.115 //layer=ply \
 //thickness=0.18 //x=27.525 //y=0.76 //x2=27.41 //y2=0.76
r649 (  214 249 ) resistor r=5.52526 //w=0.168 //l=0.115 //layer=ply \
 //thickness=0.18 //x=27.745 //y=0.76 //x2=27.86 //y2=0.76
r650 (  214 215 ) resistor r=112.809 //w=0.094 //l=0.22 //layer=ply \
 //thickness=0.18 //x=27.745 //y=0.76 //x2=27.525 //y2=0.76
r651 (  211 248 ) resistor r=37.236 //w=0.233 //l=0.249199 //layer=ply \
 //thickness=0.18 //x=27.56 //y=4.865 //x2=27.38 //y2=4.7
r652 (  209 246 ) resistor r=39.5823 //w=0.21 //l=0.173853 //layer=ply \
 //thickness=0.18 //x=27.37 //y=1.57 //x2=27.41 //y2=1.415
r653 (  209 243 ) resistor r=176.904 //w=0.094 //l=0.345 //layer=ply \
 //thickness=0.18 //x=27.37 //y=1.57 //x2=27.37 //y2=1.915
r654 (  208 246 ) resistor r=39.5823 //w=0.21 //l=0.173853 //layer=ply \
 //thickness=0.18 //x=27.37 //y=1.26 //x2=27.41 //y2=1.415
r655 (  207 245 ) resistor r=45.1352 //w=0.168 //l=0.173853 //layer=ply \
 //thickness=0.18 //x=27.37 //y=0.915 //x2=27.41 //y2=0.76
r656 (  207 208 ) resistor r=176.904 //w=0.094 //l=0.345 //layer=ply \
 //thickness=0.18 //x=27.37 //y=0.915 //x2=27.37 //y2=1.26
r657 (  204 248 ) resistor r=53.7854 //w=0.233 //l=0.332415 //layer=ply \
 //thickness=0.18 //x=27.12 //y=4.865 //x2=27.38 //y2=4.7
r658 (  203 240 ) resistor r=45.1352 //w=0.168 //l=0.173853 //layer=ply \
 //thickness=0.18 //x=13.47 //y=1.26 //x2=13.43 //y2=1.415
r659 (  202 239 ) resistor r=45.1352 //w=0.168 //l=0.173853 //layer=ply \
 //thickness=0.18 //x=13.47 //y=0.915 //x2=13.43 //y2=0.76
r660 (  202 203 ) resistor r=176.904 //w=0.094 //l=0.345 //layer=ply \
 //thickness=0.18 //x=13.47 //y=0.915 //x2=13.47 //y2=1.26
r661 (  200 236 ) resistor r=10.701 //w=0.21 //l=0.115 //layer=ply \
 //thickness=0.18 //x=13.095 //y=1.415 //x2=12.98 //y2=1.415
r662 (  199 240 ) resistor r=5.52526 //w=0.168 //l=0.115 //layer=ply \
 //thickness=0.18 //x=13.315 //y=1.415 //x2=13.43 //y2=1.415
r663 (  198 235 ) resistor r=5.52526 //w=0.168 //l=0.115 //layer=ply \
 //thickness=0.18 //x=13.095 //y=0.76 //x2=12.98 //y2=0.76
r664 (  197 239 ) resistor r=5.52526 //w=0.168 //l=0.115 //layer=ply \
 //thickness=0.18 //x=13.315 //y=0.76 //x2=13.43 //y2=0.76
r665 (  197 198 ) resistor r=112.809 //w=0.094 //l=0.22 //layer=ply \
 //thickness=0.18 //x=13.315 //y=0.76 //x2=13.095 //y2=0.76
r666 (  194 238 ) resistor r=37.236 //w=0.233 //l=0.249199 //layer=ply \
 //thickness=0.18 //x=13.13 //y=4.865 //x2=12.95 //y2=4.7
r667 (  192 236 ) resistor r=39.5823 //w=0.21 //l=0.173853 //layer=ply \
 //thickness=0.18 //x=12.94 //y=1.57 //x2=12.98 //y2=1.415
r668 (  192 233 ) resistor r=176.904 //w=0.094 //l=0.345 //layer=ply \
 //thickness=0.18 //x=12.94 //y=1.57 //x2=12.94 //y2=1.915
r669 (  191 236 ) resistor r=39.5823 //w=0.21 //l=0.173853 //layer=ply \
 //thickness=0.18 //x=12.94 //y=1.26 //x2=12.98 //y2=1.415
r670 (  190 235 ) resistor r=45.1352 //w=0.168 //l=0.173853 //layer=ply \
 //thickness=0.18 //x=12.94 //y=0.915 //x2=12.98 //y2=0.76
r671 (  190 191 ) resistor r=176.904 //w=0.094 //l=0.345 //layer=ply \
 //thickness=0.18 //x=12.94 //y=0.915 //x2=12.94 //y2=1.26
r672 (  187 238 ) resistor r=53.7854 //w=0.233 //l=0.332415 //layer=ply \
 //thickness=0.18 //x=12.69 //y=4.865 //x2=12.95 //y2=4.7
r673 (  186 230 ) resistor r=45.1352 //w=0.168 //l=0.173853 //layer=ply \
 //thickness=0.18 //x=8.66 //y=1.26 //x2=8.62 //y2=1.415
r674 (  185 229 ) resistor r=45.1352 //w=0.168 //l=0.173853 //layer=ply \
 //thickness=0.18 //x=8.66 //y=0.915 //x2=8.62 //y2=0.76
r675 (  185 186 ) resistor r=176.904 //w=0.094 //l=0.345 //layer=ply \
 //thickness=0.18 //x=8.66 //y=0.915 //x2=8.66 //y2=1.26
r676 (  183 226 ) resistor r=10.701 //w=0.21 //l=0.115 //layer=ply \
 //thickness=0.18 //x=8.285 //y=1.415 //x2=8.17 //y2=1.415
r677 (  182 230 ) resistor r=5.52526 //w=0.168 //l=0.115 //layer=ply \
 //thickness=0.18 //x=8.505 //y=1.415 //x2=8.62 //y2=1.415
r678 (  181 225 ) resistor r=5.52526 //w=0.168 //l=0.115 //layer=ply \
 //thickness=0.18 //x=8.285 //y=0.76 //x2=8.17 //y2=0.76
r679 (  180 229 ) resistor r=5.52526 //w=0.168 //l=0.115 //layer=ply \
 //thickness=0.18 //x=8.505 //y=0.76 //x2=8.62 //y2=0.76
r680 (  180 181 ) resistor r=112.809 //w=0.094 //l=0.22 //layer=ply \
 //thickness=0.18 //x=8.505 //y=0.76 //x2=8.285 //y2=0.76
r681 (  177 228 ) resistor r=37.236 //w=0.233 //l=0.249199 //layer=ply \
 //thickness=0.18 //x=8.32 //y=4.865 //x2=8.14 //y2=4.7
r682 (  175 226 ) resistor r=39.5823 //w=0.21 //l=0.173853 //layer=ply \
 //thickness=0.18 //x=8.13 //y=1.57 //x2=8.17 //y2=1.415
r683 (  175 223 ) resistor r=176.904 //w=0.094 //l=0.345 //layer=ply \
 //thickness=0.18 //x=8.13 //y=1.57 //x2=8.13 //y2=1.915
r684 (  174 226 ) resistor r=39.5823 //w=0.21 //l=0.173853 //layer=ply \
 //thickness=0.18 //x=8.13 //y=1.26 //x2=8.17 //y2=1.415
r685 (  173 225 ) resistor r=45.1352 //w=0.168 //l=0.173853 //layer=ply \
 //thickness=0.18 //x=8.13 //y=0.915 //x2=8.17 //y2=0.76
r686 (  173 174 ) resistor r=176.904 //w=0.094 //l=0.345 //layer=ply \
 //thickness=0.18 //x=8.13 //y=0.915 //x2=8.13 //y2=1.26
r687 (  170 228 ) resistor r=53.7854 //w=0.233 //l=0.332415 //layer=ply \
 //thickness=0.18 //x=7.88 //y=4.865 //x2=8.14 //y2=4.7
r688 (  169 211 ) resistor r=592.245 //w=0.094 //l=1.155 //layer=ply \
 //thickness=0.18 //x=27.56 //y=6.02 //x2=27.56 //y2=4.865
r689 (  168 204 ) resistor r=592.245 //w=0.094 //l=1.155 //layer=ply \
 //thickness=0.18 //x=27.12 //y=6.02 //x2=27.12 //y2=4.865
r690 (  167 194 ) resistor r=592.245 //w=0.094 //l=1.155 //layer=ply \
 //thickness=0.18 //x=13.13 //y=6.02 //x2=13.13 //y2=4.865
r691 (  166 187 ) resistor r=592.245 //w=0.094 //l=1.155 //layer=ply \
 //thickness=0.18 //x=12.69 //y=6.02 //x2=12.69 //y2=4.865
r692 (  165 177 ) resistor r=592.245 //w=0.094 //l=1.155 //layer=ply \
 //thickness=0.18 //x=8.32 //y=6.02 //x2=8.32 //y2=4.865
r693 (  164 170 ) resistor r=592.245 //w=0.094 //l=1.155 //layer=ply \
 //thickness=0.18 //x=7.88 //y=6.02 //x2=7.88 //y2=4.865
r694 (  163 216 ) resistor r=56.4043 //w=0.094 //l=0.11 //layer=ply \
 //thickness=0.18 //x=27.635 //y=1.415 //x2=27.745 //y2=1.415
r695 (  163 217 ) resistor r=56.4043 //w=0.094 //l=0.11 //layer=ply \
 //thickness=0.18 //x=27.635 //y=1.415 //x2=27.525 //y2=1.415
r696 (  162 199 ) resistor r=56.4043 //w=0.094 //l=0.11 //layer=ply \
 //thickness=0.18 //x=13.205 //y=1.415 //x2=13.315 //y2=1.415
r697 (  162 200 ) resistor r=56.4043 //w=0.094 //l=0.11 //layer=ply \
 //thickness=0.18 //x=13.205 //y=1.415 //x2=13.095 //y2=1.415
r698 (  161 182 ) resistor r=56.4043 //w=0.094 //l=0.11 //layer=ply \
 //thickness=0.18 //x=8.395 //y=1.415 //x2=8.505 //y2=1.415
r699 (  161 183 ) resistor r=56.4043 //w=0.094 //l=0.11 //layer=ply \
 //thickness=0.18 //x=8.395 //y=1.415 //x2=8.285 //y2=1.415
r700 (  157 248 ) resistor r=152 //w=0.17 //l=0.17 //layer=licon //count=1 \
 //x=27.38 //y=4.7 //x2=27.38 //y2=4.7
r701 (  148 242 ) resistor r=152 //w=0.17 //l=0.17 //layer=licon //count=1 \
 //x=27.38 //y=2.08 //x2=27.38 //y2=2.08
r702 (  131 255 ) resistor r=23.615 //w=0.187 //l=0.345 //layer=li \
 //thickness=0.1 //x=17.72 //y=5.38 //x2=17.72 //y2=5.725
r703 (  123 254 ) resistor r=23.615 //w=0.187 //l=0.345 //layer=li \
 //thickness=0.1 //x=16.84 //y=5.38 //x2=16.84 //y2=5.725
r704 (  115 253 ) resistor r=23.615 //w=0.187 //l=0.345 //layer=li \
 //thickness=0.1 //x=15.96 //y=5.38 //x2=15.96 //y2=5.725
r705 (  110 238 ) resistor r=152 //w=0.17 //l=0.17 //layer=licon //count=1 \
 //x=12.95 //y=4.7 //x2=12.95 //y2=4.7
r706 (  101 232 ) resistor r=152 //w=0.17 //l=0.17 //layer=licon //count=1 \
 //x=12.95 //y=2.08 //x2=12.95 //y2=2.08
r707 (  96 228 ) resistor r=152 //w=0.17 //l=0.17 //layer=licon //count=1 \
 //x=8.14 //y=4.7 //x2=8.14 //y2=4.7
r708 (  87 222 ) resistor r=152 //w=0.17 //l=0.17 //layer=licon //count=1 \
 //x=8.14 //y=2.08 //x2=8.14 //y2=2.08
r709 (  79 81 ) resistor r=0.10734 //w=0.281 //l=0.16 //layer=m2 \
 //thickness=0.36 //x=12.95 //y=3.715 //x2=13.11 //y2=3.715
r710 (  79 80 ) resistor r=0.10734 //w=0.281 //l=0.16 //layer=m2 \
 //thickness=0.36 //x=12.95 //y=3.715 //x2=12.79 //y2=3.715
r711 (  77 80 ) resistor r=4.28435 //w=0.131 //l=4.49 //layer=m2 \
 //thickness=0.36 //x=8.3 //y=3.7 //x2=12.79 //y2=3.7
r712 (  75 77 ) resistor r=0.10734 //w=0.281 //l=0.16 //layer=m2 \
 //thickness=0.36 //x=8.14 //y=3.715 //x2=8.3 //y2=3.715
r713 (  73 83 ) resistor r=1.10266 //w=0.196 //l=1.725 //layer=m2 \
 //thickness=0.36 //x=20.215 //y=3.715 //x2=18.49 //y2=3.715
r714 (  72 85 ) resistor r=4.81638 //w=0.177 //l=6.825 //layer=m2 \
 //thickness=0.36 //x=20.56 //y=3.715 //x2=27.38 //y2=3.705
r715 (  72 73 ) resistor r=0.329198 //w=0.131 //l=0.345 //layer=m2 \
 //thickness=0.36 //x=20.56 //y=3.715 //x2=20.215 //y2=3.715
r716 (  70 83 ) resistor r=0.104578 //w=0.196 //l=0.167332 //layer=m2 \
 //thickness=0.36 //x=18.33 //y=3.7 //x2=18.49 //y2=3.715
r717 (  70 81 ) resistor r=4.98092 //w=0.131 //l=5.22 //layer=m2 \
 //thickness=0.36 //x=18.33 //y=3.7 //x2=13.11 //y2=3.7
r718 (  67 157 ) resistor r=9.3 //w=0.17 //l=0.17 //layer=mcon //count=1 \
 //x=27.38 //y=4.7 //x2=27.38 //y2=4.7
r719 (  65 148 ) resistor r=9.3 //w=0.17 //l=0.17 //layer=mcon //count=1 \
 //x=27.38 //y=2.08 //x2=27.38 //y2=2.08
r720 (  63 85 ) resistor r=4.5 //w=0.15 //l=0.15 //layer=via1 //count=1 \
 //x=27.38 //y=3.705 //x2=27.38 //y2=3.705
r721 (  61 63 ) resistor r=0.00166223 //w=0.376 //l=0.005 //layer=m1 \
 //thickness=0.36 //x=27.327 //y=3.7 //x2=27.327 //y2=3.705
r722 (  59 83 ) resistor r=4.5 //w=0.15 //l=0.15 //layer=via1 //count=1 \
 //x=18.49 //y=3.715 //x2=18.49 //y2=3.715
r723 (  57 59 ) resistor r=0.00490838 //w=0.382 //l=0.015 //layer=m1 \
 //thickness=0.36 //x=18.547 //y=3.7 //x2=18.547 //y2=3.715
r724 (  55 251 ) resistor r=9.3 //w=0.17 //l=0.17 //layer=mcon //count=1 \
 //x=18.015 //y=1.01 //x2=18.015 //y2=1.01
r725 (  53 131 ) resistor r=9.3 //w=0.17 //l=0.17 //layer=mcon //count=1 \
 //x=17.72 //y=5.38 //x2=17.72 //y2=5.38
r726 (  50 123 ) resistor r=9.3 //w=0.17 //l=0.17 //layer=mcon //count=1 \
 //x=16.84 //y=5.38 //x2=16.84 //y2=5.38
r727 (  48 50 ) resistor r=0.121228 //w=0.232 //l=0.225 //layer=m1 \
 //thickness=0.36 //x=16.84 //y=5.155 //x2=16.84 //y2=5.38
r728 (  47 115 ) resistor r=9.3 //w=0.17 //l=0.17 //layer=mcon //count=1 \
 //x=15.96 //y=5.38 //x2=15.96 //y2=5.38
r729 (  45 47 ) resistor r=0.129608 //w=0.217 //l=0.225 //layer=m1 \
 //thickness=0.36 //x=15.962 //y=5.155 //x2=15.962 //y2=5.38
r730 (  44 110 ) resistor r=9.3 //w=0.17 //l=0.17 //layer=mcon //count=1 \
 //x=12.95 //y=4.7 //x2=12.95 //y2=4.7
r731 (  42 101 ) resistor r=9.3 //w=0.17 //l=0.17 //layer=mcon //count=1 \
 //x=12.95 //y=2.08 //x2=12.95 //y2=2.08
r732 (  40 79 ) resistor r=4.5 //w=0.15 //l=0.15 //layer=via1 //count=1 \
 //x=12.95 //y=3.715 //x2=12.95 //y2=3.715
r733 (  38 40 ) resistor r=0.0049867 //w=0.376 //l=0.015 //layer=m1 \
 //thickness=0.36 //x=12.897 //y=3.7 //x2=12.897 //y2=3.715
r734 (  36 75 ) resistor r=4.5 //w=0.15 //l=0.15 //layer=via1 //count=1 \
 //x=8.14 //y=3.715 //x2=8.14 //y2=3.715
r735 (  34 36 ) resistor r=0.0049867 //w=0.376 //l=0.015 //layer=m1 \
 //thickness=0.36 //x=8.192 //y=3.7 //x2=8.192 //y2=3.715
r736 (  32 96 ) resistor r=9.3 //w=0.17 //l=0.17 //layer=mcon //count=1 \
 //x=8.14 //y=4.7 //x2=8.14 //y2=4.7
r737 (  30 87 ) resistor r=9.3 //w=0.17 //l=0.17 //layer=mcon //count=1 \
 //x=8.14 //y=2.08 //x2=8.14 //y2=2.08
r738 (  28 67 ) resistor r=0.0801089 //w=0.224 //l=0.13 //layer=m1 \
 //thickness=0.36 //x=27.38 //y=4.57 //x2=27.38 //y2=4.7
r739 (  27 63 ) resistor r=0.0911593 //w=0.376 //l=0.184608 //layer=m1 \
 //thickness=0.36 //x=27.38 //y=3.865 //x2=27.327 //y2=3.705
r740 (  27 28 ) resistor r=0.67271 //w=0.131 //l=0.705 //layer=m1 \
 //thickness=0.36 //x=27.38 //y=3.865 //x2=27.38 //y2=4.57
r741 (  26 61 ) resistor r=0.0894971 //w=0.376 //l=0.179555 //layer=m1 \
 //thickness=0.36 //x=27.38 //y=3.545 //x2=27.327 //y2=3.7
r742 (  25 65 ) resistor r=0.0719237 //w=0.222 //l=0.115 //layer=m1 \
 //thickness=0.36 //x=27.38 //y=2.195 //x2=27.38 //y2=2.08
r743 (  25 26 ) resistor r=1.28817 //w=0.131 //l=1.35 //layer=m1 \
 //thickness=0.36 //x=27.38 //y=2.195 //x2=27.38 //y2=3.545
r744 (  23 59 ) resistor r=0.0914072 //w=0.382 //l=0.181989 //layer=m1 \
 //thickness=0.36 //x=18.5 //y=3.875 //x2=18.547 //y2=3.715
r745 (  23 24 ) resistor r=1.14027 //w=0.131 //l=1.195 //layer=m1 \
 //thickness=0.36 //x=18.5 //y=3.875 //x2=18.5 //y2=5.07
r746 (  22 57 ) resistor r=0.0864989 //w=0.382 //l=0.166853 //layer=m1 \
 //thickness=0.36 //x=18.5 //y=3.555 //x2=18.547 //y2=3.7
r747 (  21 22 ) resistor r=1.72233 //w=0.131 //l=1.805 //layer=m1 \
 //thickness=0.36 //x=18.5 //y=1.75 //x2=18.5 //y2=3.555
r748 (  19 21 ) resistor r=0.0698411 //w=0.17 //l=0.120208 //layer=m1 \
 //thickness=0.36 //x=18.415 //y=1.665 //x2=18.5 //y2=1.75
r749 (  19 20 ) resistor r=0.300573 //w=0.131 //l=0.315 //layer=m1 \
 //thickness=0.36 //x=18.415 //y=1.665 //x2=18.1 //y2=1.665
r750 (  18 20 ) resistor r=0.0698411 //w=0.17 //l=0.120208 //layer=m1 \
 //thickness=0.36 //x=18.015 //y=1.58 //x2=18.1 //y2=1.665
r751 (  17 55 ) resistor r=0.0717383 //w=0.224 //l=0.115 //layer=m1 \
 //thickness=0.36 //x=18.015 //y=1.125 //x2=18.015 //y2=1.01
r752 (  17 18 ) resistor r=0.43416 //w=0.131 //l=0.455 //layer=m1 \
 //thickness=0.36 //x=18.015 //y=1.125 //x2=18.015 //y2=1.58
r753 (  16 51 ) resistor r=0.0675342 //w=0.23 //l=0.115 //layer=m1 \
 //thickness=0.36 //x=17.835 //y=5.155 //x2=17.72 //y2=5.155
r754 (  15 24 ) resistor r=0.0698411 //w=0.17 //l=0.120208 //layer=m1 \
 //thickness=0.36 //x=18.415 //y=5.155 //x2=18.5 //y2=5.07
r755 (  15 16 ) resistor r=0.553435 //w=0.131 //l=0.58 //layer=m1 \
 //thickness=0.36 //x=18.415 //y=5.155 //x2=17.835 //y2=5.155
r756 (  14 53 ) resistor r=0.00118313 //w=0.23 //layer=m1 //thickness=0.36 \
 //x=17.72 //y=5.38 //x2=17.72 //y2=5.38
r757 (  13 51 ) resistor r=0.002872 //w=0.34 //l=0.085 //layer=m1 \
 //thickness=0.36 //x=17.72 //y=5.24 //x2=17.72 //y2=5.155
r758 (  13 14 ) resistor r=0.091623 //w=0.191 //l=0.14 //layer=m1 \
 //thickness=0.36 //x=17.72 //y=5.24 //x2=17.72 //y2=5.38
r759 (  12 48 ) resistor r=0.0262263 //w=0.232 //l=0.12 //layer=m1 \
 //thickness=0.36 //x=16.96 //y=5.155 //x2=16.84 //y2=5.155
r760 (  11 51 ) resistor r=0.0675342 //w=0.23 //l=0.115 //layer=m1 \
 //thickness=0.36 //x=17.605 //y=5.155 //x2=17.72 //y2=5.155
r761 (  11 12 ) resistor r=0.615458 //w=0.131 //l=0.645 //layer=m1 \
 //thickness=0.36 //x=17.605 //y=5.155 //x2=16.96 //y2=5.155
r762 (  10 45 ) resistor r=0.0222262 //w=0.217 //l=0.118 //layer=m1 \
 //thickness=0.36 //x=16.08 //y=5.155 //x2=15.962 //y2=5.155
r763 (  9 48 ) resistor r=0.0262263 //w=0.232 //l=0.12 //layer=m1 \
 //thickness=0.36 //x=16.72 //y=5.155 //x2=16.84 //y2=5.155
r764 (  9 10 ) resistor r=0.610687 //w=0.131 //l=0.64 //layer=m1 \
 //thickness=0.36 //x=16.72 //y=5.155 //x2=16.08 //y2=5.155
r765 (  8 44 ) resistor r=0.0801089 //w=0.224 //l=0.13 //layer=m1 \
 //thickness=0.36 //x=12.95 //y=4.57 //x2=12.95 //y2=4.7
r766 (  7 40 ) resistor r=0.0911593 //w=0.376 //l=0.184608 //layer=m1 \
 //thickness=0.36 //x=12.95 //y=3.875 //x2=12.897 //y2=3.715
r767 (  7 8 ) resistor r=0.663168 //w=0.131 //l=0.695 //layer=m1 \
 //thickness=0.36 //x=12.95 //y=3.875 //x2=12.95 //y2=4.57
r768 (  6 38 ) resistor r=0.0861726 //w=0.376 //l=0.16944 //layer=m1 \
 //thickness=0.36 //x=12.95 //y=3.555 //x2=12.897 //y2=3.7
r769 (  5 42 ) resistor r=0.0719237 //w=0.222 //l=0.115 //layer=m1 \
 //thickness=0.36 //x=12.95 //y=2.195 //x2=12.95 //y2=2.08
r770 (  5 6 ) resistor r=1.29771 //w=0.131 //l=1.36 //layer=m1 \
 //thickness=0.36 //x=12.95 //y=2.195 //x2=12.95 //y2=3.555
r771 (  4 32 ) resistor r=0.0801089 //w=0.224 //l=0.13 //layer=m1 \
 //thickness=0.36 //x=8.14 //y=4.57 //x2=8.14 //y2=4.7
r772 (  3 36 ) resistor r=0.0911593 //w=0.376 //l=0.184174 //layer=m1 \
 //thickness=0.36 //x=8.14 //y=3.875 //x2=8.192 //y2=3.715
r773 (  3 4 ) resistor r=0.663168 //w=0.131 //l=0.695 //layer=m1 \
 //thickness=0.36 //x=8.14 //y=3.875 //x2=8.14 //y2=4.57
r774 (  2 34 ) resistor r=0.0861726 //w=0.376 //l=0.169012 //layer=m1 \
 //thickness=0.36 //x=8.14 //y=3.555 //x2=8.192 //y2=3.7
r775 (  1 30 ) resistor r=0.0719237 //w=0.222 //l=0.115 //layer=m1 \
 //thickness=0.36 //x=8.14 //y=2.195 //x2=8.14 //y2=2.08
r776 (  1 2 ) resistor r=1.29771 //w=0.131 //l=1.36 //layer=m1 \
 //thickness=0.36 //x=8.14 //y=2.195 //x2=8.14 //y2=3.555
ends PM_DFFSNRNX1_PCELL\%noxref_7

subckt PM_DFFSNRNX1_PCELL\%noxref_8 ( 49 68 77 87 95 105 123 133 141 151 169 \
 179 187 197 215 225 233 243 261 271 279 289 307 317 325 338 345 350 355 360 \
 365 370 371 372 373 374 375 376 377 378 379 380 381 382 383 384 385 386 387 \
 388 389 390 391 392 393 )
c385 ( 393 0 ) capacitor c=0.0466888f //x=27.635 //y=5.02
c386 ( 392 0 ) capacitor c=0.025619f //x=26.755 //y=5.02
c387 ( 391 0 ) capacitor c=0.0256111f //x=25.875 //y=5.02
c388 ( 390 0 ) capacitor c=0.0677293f //x=25.005 //y=5.02
c389 ( 389 0 ) capacitor c=0.0466888f //x=22.825 //y=5.02
c390 ( 388 0 ) capacitor c=0.0256166f //x=21.945 //y=5.02
c391 ( 387 0 ) capacitor c=0.0256111f //x=21.065 //y=5.02
c392 ( 386 0 ) capacitor c=0.0677057f //x=20.195 //y=5.02
c393 ( 385 0 ) capacitor c=0.0466888f //x=18.015 //y=5.02
c394 ( 384 0 ) capacitor c=0.0256166f //x=17.135 //y=5.02
c395 ( 383 0 ) capacitor c=0.0256111f //x=16.255 //y=5.02
c396 ( 382 0 ) capacitor c=0.0676538f //x=15.385 //y=5.02
c397 ( 381 0 ) capacitor c=0.0466888f //x=13.205 //y=5.02
c398 ( 380 0 ) capacitor c=0.0256166f //x=12.325 //y=5.02
c399 ( 379 0 ) capacitor c=0.0256111f //x=11.445 //y=5.02
c400 ( 378 0 ) capacitor c=0.0676529f //x=10.575 //y=5.02
c401 ( 377 0 ) capacitor c=0.0466888f //x=8.395 //y=5.02
c402 ( 376 0 ) capacitor c=0.0256166f //x=7.515 //y=5.02
c403 ( 375 0 ) capacitor c=0.0256111f //x=6.635 //y=5.02
c404 ( 374 0 ) capacitor c=0.067782f //x=5.765 //y=5.02
c405 ( 373 0 ) capacitor c=0.0466888f //x=3.585 //y=5.02
c406 ( 372 0 ) capacitor c=0.0256166f //x=2.705 //y=5.02
c407 ( 371 0 ) capacitor c=0.0256111f //x=1.825 //y=5.02
c408 ( 370 0 ) capacitor c=0.0696958f //x=0.955 //y=5.02
c409 ( 369 0 ) capacitor c=0.00591168f //x=27.78 //y=7.4
c410 ( 368 0 ) capacitor c=0.00591168f //x=26.9 //y=7.4
c411 ( 367 0 ) capacitor c=0.00591168f //x=26.02 //y=7.4
c412 ( 366 0 ) capacitor c=0.00591168f //x=25.14 //y=7.4
c413 ( 365 0 ) capacitor c=0.164598f //x=24.05 //y=7.4
c414 ( 364 0 ) capacitor c=0.00591168f //x=22.97 //y=7.4
c415 ( 363 0 ) capacitor c=0.00591168f //x=22.09 //y=7.4
c416 ( 362 0 ) capacitor c=0.00591168f //x=21.21 //y=7.4
c417 ( 361 0 ) capacitor c=0.00591168f //x=20.33 //y=7.4
c418 ( 360 0 ) capacitor c=0.164598f //x=19.24 //y=7.4
c419 ( 359 0 ) capacitor c=0.00591168f //x=18.16 //y=7.4
c420 ( 358 0 ) capacitor c=0.00591168f //x=17.28 //y=7.4
c421 ( 357 0 ) capacitor c=0.00591168f //x=16.4 //y=7.4
c422 ( 356 0 ) capacitor c=0.00591168f //x=15.52 //y=7.4
c423 ( 355 0 ) capacitor c=0.164728f //x=14.43 //y=7.4
c424 ( 354 0 ) capacitor c=0.00591168f //x=13.35 //y=7.4
c425 ( 353 0 ) capacitor c=0.00591168f //x=12.47 //y=7.4
c426 ( 352 0 ) capacitor c=0.00591168f //x=11.59 //y=7.4
c427 ( 351 0 ) capacitor c=0.00591168f //x=10.71 //y=7.4
c428 ( 350 0 ) capacitor c=0.164728f //x=9.62 //y=7.4
c429 ( 349 0 ) capacitor c=0.00591168f //x=8.54 //y=7.4
c430 ( 348 0 ) capacitor c=0.00591168f //x=7.66 //y=7.4
c431 ( 347 0 ) capacitor c=0.00591168f //x=6.78 //y=7.4
c432 ( 346 0 ) capacitor c=0.00591168f //x=5.9 //y=7.4
c433 ( 345 0 ) capacitor c=0.164805f //x=4.81 //y=7.4
c434 ( 344 0 ) capacitor c=0.00591168f //x=3.73 //y=7.4
c435 ( 343 0 ) capacitor c=0.00591168f //x=2.85 //y=7.4
c436 ( 342 0 ) capacitor c=0.00591168f //x=1.97 //y=7.4
c437 ( 341 0 ) capacitor c=0.00591168f //x=1.09 //y=7.4
c438 ( 338 0 ) capacitor c=0.275834f //x=28.12 //y=7.4
c439 ( 325 0 ) capacitor c=0.0286174f //x=27.695 //y=7.4
c440 ( 317 0 ) capacitor c=0.0286648f //x=26.815 //y=7.4
c441 ( 307 0 ) capacitor c=0.0287602f //x=25.935 //y=7.4
c442 ( 295 0 ) capacitor c=0.0452081f //x=25.055 //y=7.4
c443 ( 289 0 ) capacitor c=0.0419403f //x=23.88 //y=7.4
c444 ( 279 0 ) capacitor c=0.0286174f //x=22.885 //y=7.4
c445 ( 271 0 ) capacitor c=0.0286648f //x=22.005 //y=7.4
c446 ( 261 0 ) capacitor c=0.0287602f //x=21.125 //y=7.4
c447 ( 249 0 ) capacitor c=0.0452081f //x=20.245 //y=7.4
c448 ( 243 0 ) capacitor c=0.0419403f //x=19.07 //y=7.4
c449 ( 233 0 ) capacitor c=0.0286174f //x=18.075 //y=7.4
c450 ( 225 0 ) capacitor c=0.0286648f //x=17.195 //y=7.4
c451 ( 215 0 ) capacitor c=0.0287602f //x=16.315 //y=7.4
c452 ( 203 0 ) capacitor c=0.0452081f //x=15.435 //y=7.4
c453 ( 197 0 ) capacitor c=0.0419403f //x=14.26 //y=7.4
c454 ( 187 0 ) capacitor c=0.0286174f //x=13.265 //y=7.4
c455 ( 179 0 ) capacitor c=0.0286648f //x=12.385 //y=7.4
c456 ( 169 0 ) capacitor c=0.0287602f //x=11.505 //y=7.4
c457 ( 157 0 ) capacitor c=0.0452081f //x=10.625 //y=7.4
c458 ( 151 0 ) capacitor c=0.0419403f //x=9.45 //y=7.4
c459 ( 141 0 ) capacitor c=0.0286174f //x=8.455 //y=7.4
c460 ( 133 0 ) capacitor c=0.0286648f //x=7.575 //y=7.4
c461 ( 123 0 ) capacitor c=0.0287602f //x=6.695 //y=7.4
c462 ( 111 0 ) capacitor c=0.0452081f //x=5.815 //y=7.4
c463 ( 105 0 ) capacitor c=0.0419403f //x=4.64 //y=7.4
c464 ( 95 0 ) capacitor c=0.0286174f //x=3.645 //y=7.4
c465 ( 87 0 ) capacitor c=0.0286648f //x=2.765 //y=7.4
c466 ( 77 0 ) capacitor c=0.0287602f //x=1.885 //y=7.4
c467 ( 68 0 ) capacitor c=0.235596f //x=0.74 //y=7.4
c468 ( 65 0 ) capacitor c=0.0452081f //x=1.005 //y=7.4
c469 ( 49 0 ) capacitor c=1.06002f //x=28.12 //y=7.4
r470 (  336 369 ) resistor r=2.94794 //w=0.34 //l=0.085 //layer=li \
 //thickness=0.1 //x=27.865 //y=7.4 //x2=27.78 //y2=7.4
r471 (  336 338 ) resistor r=9.14286 //w=0.357 //l=0.255 //layer=li \
 //thickness=0.1 //x=27.865 //y=7.4 //x2=28.12 //y2=7.4
r472 (  329 369 ) resistor r=4.11603 //w=0.68 //l=0.17 //layer=li \
 //thickness=0.1 //x=27.78 //y=7.23 //x2=27.78 //y2=7.4
r473 (  329 393 ) resistor r=33.1979 //w=0.187 //l=0.485 //layer=li \
 //thickness=0.1 //x=27.78 //y=7.23 //x2=27.78 //y2=6.745
r474 (  326 368 ) resistor r=2.94794 //w=0.34 //l=0.085 //layer=li \
 //thickness=0.1 //x=26.985 //y=7.4 //x2=26.9 //y2=7.4
r475 (  326 328 ) resistor r=0.896359 //w=0.357 //l=0.025 //layer=li \
 //thickness=0.1 //x=26.985 //y=7.4 //x2=27.01 //y2=7.4
r476 (  325 369 ) resistor r=2.94794 //w=0.34 //l=0.085 //layer=li \
 //thickness=0.1 //x=27.695 //y=7.4 //x2=27.78 //y2=7.4
r477 (  325 328 ) resistor r=24.5602 //w=0.357 //l=0.685 //layer=li \
 //thickness=0.1 //x=27.695 //y=7.4 //x2=27.01 //y2=7.4
r478 (  319 368 ) resistor r=4.11603 //w=0.68 //l=0.17 //layer=li \
 //thickness=0.1 //x=26.9 //y=7.23 //x2=26.9 //y2=7.4
r479 (  319 392 ) resistor r=33.1979 //w=0.187 //l=0.485 //layer=li \
 //thickness=0.1 //x=26.9 //y=7.23 //x2=26.9 //y2=6.745
r480 (  318 367 ) resistor r=2.94794 //w=0.34 //l=0.085 //layer=li \
 //thickness=0.1 //x=26.105 //y=7.4 //x2=26.02 //y2=7.4
r481 (  317 368 ) resistor r=2.94794 //w=0.34 //l=0.085 //layer=li \
 //thickness=0.1 //x=26.815 //y=7.4 //x2=26.9 //y2=7.4
r482 (  317 318 ) resistor r=25.4566 //w=0.357 //l=0.71 //layer=li \
 //thickness=0.1 //x=26.815 //y=7.4 //x2=26.105 //y2=7.4
r483 (  311 367 ) resistor r=4.11603 //w=0.68 //l=0.17 //layer=li \
 //thickness=0.1 //x=26.02 //y=7.23 //x2=26.02 //y2=7.4
r484 (  311 391 ) resistor r=33.1979 //w=0.187 //l=0.485 //layer=li \
 //thickness=0.1 //x=26.02 //y=7.23 //x2=26.02 //y2=6.745
r485 (  308 366 ) resistor r=2.94794 //w=0.34 //l=0.085 //layer=li \
 //thickness=0.1 //x=25.225 //y=7.4 //x2=25.14 //y2=7.4
r486 (  308 310 ) resistor r=24.2017 //w=0.357 //l=0.675 //layer=li \
 //thickness=0.1 //x=25.225 //y=7.4 //x2=25.9 //y2=7.4
r487 (  307 367 ) resistor r=2.94794 //w=0.34 //l=0.085 //layer=li \
 //thickness=0.1 //x=25.935 //y=7.4 //x2=26.02 //y2=7.4
r488 (  307 310 ) resistor r=1.2549 //w=0.357 //l=0.035 //layer=li \
 //thickness=0.1 //x=25.935 //y=7.4 //x2=25.9 //y2=7.4
r489 (  299 366 ) resistor r=4.11603 //w=0.68 //l=0.17 //layer=li \
 //thickness=0.1 //x=25.14 //y=7.23 //x2=25.14 //y2=7.4
r490 (  299 390 ) resistor r=56.4706 //w=0.187 //l=0.825 //layer=li \
 //thickness=0.1 //x=25.14 //y=7.23 //x2=25.14 //y2=6.405
r491 (  296 365 ) resistor r=5.4201 //w=0.34 //l=0.17 //layer=li \
 //thickness=0.1 //x=24.22 //y=7.4 //x2=24.05 //y2=7.4
r492 (  296 298 ) resistor r=20.437 //w=0.357 //l=0.57 //layer=li \
 //thickness=0.1 //x=24.22 //y=7.4 //x2=24.79 //y2=7.4
r493 (  295 366 ) resistor r=2.94794 //w=0.34 //l=0.085 //layer=li \
 //thickness=0.1 //x=25.055 //y=7.4 //x2=25.14 //y2=7.4
r494 (  295 298 ) resistor r=9.5014 //w=0.357 //l=0.265 //layer=li \
 //thickness=0.1 //x=25.055 //y=7.4 //x2=24.79 //y2=7.4
r495 (  290 364 ) resistor r=2.94794 //w=0.34 //l=0.085 //layer=li \
 //thickness=0.1 //x=23.055 //y=7.4 //x2=22.97 //y2=7.4
r496 (  290 292 ) resistor r=9.14286 //w=0.357 //l=0.255 //layer=li \
 //thickness=0.1 //x=23.055 //y=7.4 //x2=23.31 //y2=7.4
r497 (  289 365 ) resistor r=5.4201 //w=0.34 //l=0.17 //layer=li \
 //thickness=0.1 //x=23.88 //y=7.4 //x2=24.05 //y2=7.4
r498 (  289 292 ) resistor r=20.437 //w=0.357 //l=0.57 //layer=li \
 //thickness=0.1 //x=23.88 //y=7.4 //x2=23.31 //y2=7.4
r499 (  283 364 ) resistor r=4.11603 //w=0.68 //l=0.17 //layer=li \
 //thickness=0.1 //x=22.97 //y=7.23 //x2=22.97 //y2=7.4
r500 (  283 389 ) resistor r=33.1979 //w=0.187 //l=0.485 //layer=li \
 //thickness=0.1 //x=22.97 //y=7.23 //x2=22.97 //y2=6.745
r501 (  280 363 ) resistor r=2.94794 //w=0.34 //l=0.085 //layer=li \
 //thickness=0.1 //x=22.175 //y=7.4 //x2=22.09 //y2=7.4
r502 (  280 282 ) resistor r=0.896359 //w=0.357 //l=0.025 //layer=li \
 //thickness=0.1 //x=22.175 //y=7.4 //x2=22.2 //y2=7.4
r503 (  279 364 ) resistor r=2.94794 //w=0.34 //l=0.085 //layer=li \
 //thickness=0.1 //x=22.885 //y=7.4 //x2=22.97 //y2=7.4
r504 (  279 282 ) resistor r=24.5602 //w=0.357 //l=0.685 //layer=li \
 //thickness=0.1 //x=22.885 //y=7.4 //x2=22.2 //y2=7.4
r505 (  273 363 ) resistor r=4.11603 //w=0.68 //l=0.17 //layer=li \
 //thickness=0.1 //x=22.09 //y=7.23 //x2=22.09 //y2=7.4
r506 (  273 388 ) resistor r=33.1979 //w=0.187 //l=0.485 //layer=li \
 //thickness=0.1 //x=22.09 //y=7.23 //x2=22.09 //y2=6.745
r507 (  272 362 ) resistor r=2.94794 //w=0.34 //l=0.085 //layer=li \
 //thickness=0.1 //x=21.295 //y=7.4 //x2=21.21 //y2=7.4
r508 (  271 363 ) resistor r=2.94794 //w=0.34 //l=0.085 //layer=li \
 //thickness=0.1 //x=22.005 //y=7.4 //x2=22.09 //y2=7.4
r509 (  271 272 ) resistor r=25.4566 //w=0.357 //l=0.71 //layer=li \
 //thickness=0.1 //x=22.005 //y=7.4 //x2=21.295 //y2=7.4
r510 (  265 362 ) resistor r=4.11603 //w=0.68 //l=0.17 //layer=li \
 //thickness=0.1 //x=21.21 //y=7.23 //x2=21.21 //y2=7.4
r511 (  265 387 ) resistor r=33.1979 //w=0.187 //l=0.485 //layer=li \
 //thickness=0.1 //x=21.21 //y=7.23 //x2=21.21 //y2=6.745
r512 (  262 361 ) resistor r=2.94794 //w=0.34 //l=0.085 //layer=li \
 //thickness=0.1 //x=20.415 //y=7.4 //x2=20.33 //y2=7.4
r513 (  262 264 ) resistor r=24.2017 //w=0.357 //l=0.675 //layer=li \
 //thickness=0.1 //x=20.415 //y=7.4 //x2=21.09 //y2=7.4
r514 (  261 362 ) resistor r=2.94794 //w=0.34 //l=0.085 //layer=li \
 //thickness=0.1 //x=21.125 //y=7.4 //x2=21.21 //y2=7.4
r515 (  261 264 ) resistor r=1.2549 //w=0.357 //l=0.035 //layer=li \
 //thickness=0.1 //x=21.125 //y=7.4 //x2=21.09 //y2=7.4
r516 (  253 361 ) resistor r=4.11603 //w=0.68 //l=0.17 //layer=li \
 //thickness=0.1 //x=20.33 //y=7.23 //x2=20.33 //y2=7.4
r517 (  253 386 ) resistor r=56.4706 //w=0.187 //l=0.825 //layer=li \
 //thickness=0.1 //x=20.33 //y=7.23 //x2=20.33 //y2=6.405
r518 (  250 360 ) resistor r=5.4201 //w=0.34 //l=0.17 //layer=li \
 //thickness=0.1 //x=19.41 //y=7.4 //x2=19.24 //y2=7.4
r519 (  250 252 ) resistor r=20.437 //w=0.357 //l=0.57 //layer=li \
 //thickness=0.1 //x=19.41 //y=7.4 //x2=19.98 //y2=7.4
r520 (  249 361 ) resistor r=2.94794 //w=0.34 //l=0.085 //layer=li \
 //thickness=0.1 //x=20.245 //y=7.4 //x2=20.33 //y2=7.4
r521 (  249 252 ) resistor r=9.5014 //w=0.357 //l=0.265 //layer=li \
 //thickness=0.1 //x=20.245 //y=7.4 //x2=19.98 //y2=7.4
r522 (  244 359 ) resistor r=2.94794 //w=0.34 //l=0.085 //layer=li \
 //thickness=0.1 //x=18.245 //y=7.4 //x2=18.16 //y2=7.4
r523 (  244 246 ) resistor r=9.14286 //w=0.357 //l=0.255 //layer=li \
 //thickness=0.1 //x=18.245 //y=7.4 //x2=18.5 //y2=7.4
r524 (  243 360 ) resistor r=5.4201 //w=0.34 //l=0.17 //layer=li \
 //thickness=0.1 //x=19.07 //y=7.4 //x2=19.24 //y2=7.4
r525 (  243 246 ) resistor r=20.437 //w=0.357 //l=0.57 //layer=li \
 //thickness=0.1 //x=19.07 //y=7.4 //x2=18.5 //y2=7.4
r526 (  237 359 ) resistor r=4.11603 //w=0.68 //l=0.17 //layer=li \
 //thickness=0.1 //x=18.16 //y=7.23 //x2=18.16 //y2=7.4
r527 (  237 385 ) resistor r=33.1979 //w=0.187 //l=0.485 //layer=li \
 //thickness=0.1 //x=18.16 //y=7.23 //x2=18.16 //y2=6.745
r528 (  234 358 ) resistor r=2.94794 //w=0.34 //l=0.085 //layer=li \
 //thickness=0.1 //x=17.365 //y=7.4 //x2=17.28 //y2=7.4
r529 (  234 236 ) resistor r=0.896359 //w=0.357 //l=0.025 //layer=li \
 //thickness=0.1 //x=17.365 //y=7.4 //x2=17.39 //y2=7.4
r530 (  233 359 ) resistor r=2.94794 //w=0.34 //l=0.085 //layer=li \
 //thickness=0.1 //x=18.075 //y=7.4 //x2=18.16 //y2=7.4
r531 (  233 236 ) resistor r=24.5602 //w=0.357 //l=0.685 //layer=li \
 //thickness=0.1 //x=18.075 //y=7.4 //x2=17.39 //y2=7.4
r532 (  227 358 ) resistor r=4.11603 //w=0.68 //l=0.17 //layer=li \
 //thickness=0.1 //x=17.28 //y=7.23 //x2=17.28 //y2=7.4
r533 (  227 384 ) resistor r=33.1979 //w=0.187 //l=0.485 //layer=li \
 //thickness=0.1 //x=17.28 //y=7.23 //x2=17.28 //y2=6.745
r534 (  226 357 ) resistor r=2.94794 //w=0.34 //l=0.085 //layer=li \
 //thickness=0.1 //x=16.485 //y=7.4 //x2=16.4 //y2=7.4
r535 (  225 358 ) resistor r=2.94794 //w=0.34 //l=0.085 //layer=li \
 //thickness=0.1 //x=17.195 //y=7.4 //x2=17.28 //y2=7.4
r536 (  225 226 ) resistor r=25.4566 //w=0.357 //l=0.71 //layer=li \
 //thickness=0.1 //x=17.195 //y=7.4 //x2=16.485 //y2=7.4
r537 (  219 357 ) resistor r=4.11603 //w=0.68 //l=0.17 //layer=li \
 //thickness=0.1 //x=16.4 //y=7.23 //x2=16.4 //y2=7.4
r538 (  219 383 ) resistor r=33.1979 //w=0.187 //l=0.485 //layer=li \
 //thickness=0.1 //x=16.4 //y=7.23 //x2=16.4 //y2=6.745
r539 (  216 356 ) resistor r=2.94794 //w=0.34 //l=0.085 //layer=li \
 //thickness=0.1 //x=15.605 //y=7.4 //x2=15.52 //y2=7.4
r540 (  216 218 ) resistor r=24.2017 //w=0.357 //l=0.675 //layer=li \
 //thickness=0.1 //x=15.605 //y=7.4 //x2=16.28 //y2=7.4
r541 (  215 357 ) resistor r=2.94794 //w=0.34 //l=0.085 //layer=li \
 //thickness=0.1 //x=16.315 //y=7.4 //x2=16.4 //y2=7.4
r542 (  215 218 ) resistor r=1.2549 //w=0.357 //l=0.035 //layer=li \
 //thickness=0.1 //x=16.315 //y=7.4 //x2=16.28 //y2=7.4
r543 (  207 356 ) resistor r=4.11603 //w=0.68 //l=0.17 //layer=li \
 //thickness=0.1 //x=15.52 //y=7.23 //x2=15.52 //y2=7.4
r544 (  207 382 ) resistor r=56.4706 //w=0.187 //l=0.825 //layer=li \
 //thickness=0.1 //x=15.52 //y=7.23 //x2=15.52 //y2=6.405
r545 (  204 355 ) resistor r=5.4201 //w=0.34 //l=0.17 //layer=li \
 //thickness=0.1 //x=14.6 //y=7.4 //x2=14.43 //y2=7.4
r546 (  204 206 ) resistor r=20.437 //w=0.357 //l=0.57 //layer=li \
 //thickness=0.1 //x=14.6 //y=7.4 //x2=15.17 //y2=7.4
r547 (  203 356 ) resistor r=2.94794 //w=0.34 //l=0.085 //layer=li \
 //thickness=0.1 //x=15.435 //y=7.4 //x2=15.52 //y2=7.4
r548 (  203 206 ) resistor r=9.5014 //w=0.357 //l=0.265 //layer=li \
 //thickness=0.1 //x=15.435 //y=7.4 //x2=15.17 //y2=7.4
r549 (  198 354 ) resistor r=2.94794 //w=0.34 //l=0.085 //layer=li \
 //thickness=0.1 //x=13.435 //y=7.4 //x2=13.35 //y2=7.4
r550 (  198 200 ) resistor r=9.14286 //w=0.357 //l=0.255 //layer=li \
 //thickness=0.1 //x=13.435 //y=7.4 //x2=13.69 //y2=7.4
r551 (  197 355 ) resistor r=5.4201 //w=0.34 //l=0.17 //layer=li \
 //thickness=0.1 //x=14.26 //y=7.4 //x2=14.43 //y2=7.4
r552 (  197 200 ) resistor r=20.437 //w=0.357 //l=0.57 //layer=li \
 //thickness=0.1 //x=14.26 //y=7.4 //x2=13.69 //y2=7.4
r553 (  191 354 ) resistor r=4.11603 //w=0.68 //l=0.17 //layer=li \
 //thickness=0.1 //x=13.35 //y=7.23 //x2=13.35 //y2=7.4
r554 (  191 381 ) resistor r=33.1979 //w=0.187 //l=0.485 //layer=li \
 //thickness=0.1 //x=13.35 //y=7.23 //x2=13.35 //y2=6.745
r555 (  188 353 ) resistor r=2.94794 //w=0.34 //l=0.085 //layer=li \
 //thickness=0.1 //x=12.555 //y=7.4 //x2=12.47 //y2=7.4
r556 (  188 190 ) resistor r=0.896359 //w=0.357 //l=0.025 //layer=li \
 //thickness=0.1 //x=12.555 //y=7.4 //x2=12.58 //y2=7.4
r557 (  187 354 ) resistor r=2.94794 //w=0.34 //l=0.085 //layer=li \
 //thickness=0.1 //x=13.265 //y=7.4 //x2=13.35 //y2=7.4
r558 (  187 190 ) resistor r=24.5602 //w=0.357 //l=0.685 //layer=li \
 //thickness=0.1 //x=13.265 //y=7.4 //x2=12.58 //y2=7.4
r559 (  181 353 ) resistor r=4.11603 //w=0.68 //l=0.17 //layer=li \
 //thickness=0.1 //x=12.47 //y=7.23 //x2=12.47 //y2=7.4
r560 (  181 380 ) resistor r=33.1979 //w=0.187 //l=0.485 //layer=li \
 //thickness=0.1 //x=12.47 //y=7.23 //x2=12.47 //y2=6.745
r561 (  180 352 ) resistor r=2.94794 //w=0.34 //l=0.085 //layer=li \
 //thickness=0.1 //x=11.675 //y=7.4 //x2=11.59 //y2=7.4
r562 (  179 353 ) resistor r=2.94794 //w=0.34 //l=0.085 //layer=li \
 //thickness=0.1 //x=12.385 //y=7.4 //x2=12.47 //y2=7.4
r563 (  179 180 ) resistor r=25.4566 //w=0.357 //l=0.71 //layer=li \
 //thickness=0.1 //x=12.385 //y=7.4 //x2=11.675 //y2=7.4
r564 (  173 352 ) resistor r=4.11603 //w=0.68 //l=0.17 //layer=li \
 //thickness=0.1 //x=11.59 //y=7.23 //x2=11.59 //y2=7.4
r565 (  173 379 ) resistor r=33.1979 //w=0.187 //l=0.485 //layer=li \
 //thickness=0.1 //x=11.59 //y=7.23 //x2=11.59 //y2=6.745
r566 (  170 351 ) resistor r=2.94794 //w=0.34 //l=0.085 //layer=li \
 //thickness=0.1 //x=10.795 //y=7.4 //x2=10.71 //y2=7.4
r567 (  170 172 ) resistor r=24.2017 //w=0.357 //l=0.675 //layer=li \
 //thickness=0.1 //x=10.795 //y=7.4 //x2=11.47 //y2=7.4
r568 (  169 352 ) resistor r=2.94794 //w=0.34 //l=0.085 //layer=li \
 //thickness=0.1 //x=11.505 //y=7.4 //x2=11.59 //y2=7.4
r569 (  169 172 ) resistor r=1.2549 //w=0.357 //l=0.035 //layer=li \
 //thickness=0.1 //x=11.505 //y=7.4 //x2=11.47 //y2=7.4
r570 (  161 351 ) resistor r=4.11603 //w=0.68 //l=0.17 //layer=li \
 //thickness=0.1 //x=10.71 //y=7.23 //x2=10.71 //y2=7.4
r571 (  161 378 ) resistor r=56.4706 //w=0.187 //l=0.825 //layer=li \
 //thickness=0.1 //x=10.71 //y=7.23 //x2=10.71 //y2=6.405
r572 (  158 350 ) resistor r=5.4201 //w=0.34 //l=0.17 //layer=li \
 //thickness=0.1 //x=9.79 //y=7.4 //x2=9.62 //y2=7.4
r573 (  158 160 ) resistor r=20.437 //w=0.357 //l=0.57 //layer=li \
 //thickness=0.1 //x=9.79 //y=7.4 //x2=10.36 //y2=7.4
r574 (  157 351 ) resistor r=2.94794 //w=0.34 //l=0.085 //layer=li \
 //thickness=0.1 //x=10.625 //y=7.4 //x2=10.71 //y2=7.4
r575 (  157 160 ) resistor r=9.5014 //w=0.357 //l=0.265 //layer=li \
 //thickness=0.1 //x=10.625 //y=7.4 //x2=10.36 //y2=7.4
r576 (  152 349 ) resistor r=2.94794 //w=0.34 //l=0.085 //layer=li \
 //thickness=0.1 //x=8.625 //y=7.4 //x2=8.54 //y2=7.4
r577 (  152 154 ) resistor r=9.14286 //w=0.357 //l=0.255 //layer=li \
 //thickness=0.1 //x=8.625 //y=7.4 //x2=8.88 //y2=7.4
r578 (  151 350 ) resistor r=5.4201 //w=0.34 //l=0.17 //layer=li \
 //thickness=0.1 //x=9.45 //y=7.4 //x2=9.62 //y2=7.4
r579 (  151 154 ) resistor r=20.437 //w=0.357 //l=0.57 //layer=li \
 //thickness=0.1 //x=9.45 //y=7.4 //x2=8.88 //y2=7.4
r580 (  145 349 ) resistor r=4.11603 //w=0.68 //l=0.17 //layer=li \
 //thickness=0.1 //x=8.54 //y=7.23 //x2=8.54 //y2=7.4
r581 (  145 377 ) resistor r=33.1979 //w=0.187 //l=0.485 //layer=li \
 //thickness=0.1 //x=8.54 //y=7.23 //x2=8.54 //y2=6.745
r582 (  142 348 ) resistor r=2.94794 //w=0.34 //l=0.085 //layer=li \
 //thickness=0.1 //x=7.745 //y=7.4 //x2=7.66 //y2=7.4
r583 (  142 144 ) resistor r=0.896359 //w=0.357 //l=0.025 //layer=li \
 //thickness=0.1 //x=7.745 //y=7.4 //x2=7.77 //y2=7.4
r584 (  141 349 ) resistor r=2.94794 //w=0.34 //l=0.085 //layer=li \
 //thickness=0.1 //x=8.455 //y=7.4 //x2=8.54 //y2=7.4
r585 (  141 144 ) resistor r=24.5602 //w=0.357 //l=0.685 //layer=li \
 //thickness=0.1 //x=8.455 //y=7.4 //x2=7.77 //y2=7.4
r586 (  135 348 ) resistor r=4.11603 //w=0.68 //l=0.17 //layer=li \
 //thickness=0.1 //x=7.66 //y=7.23 //x2=7.66 //y2=7.4
r587 (  135 376 ) resistor r=33.1979 //w=0.187 //l=0.485 //layer=li \
 //thickness=0.1 //x=7.66 //y=7.23 //x2=7.66 //y2=6.745
r588 (  134 347 ) resistor r=2.94794 //w=0.34 //l=0.085 //layer=li \
 //thickness=0.1 //x=6.865 //y=7.4 //x2=6.78 //y2=7.4
r589 (  133 348 ) resistor r=2.94794 //w=0.34 //l=0.085 //layer=li \
 //thickness=0.1 //x=7.575 //y=7.4 //x2=7.66 //y2=7.4
r590 (  133 134 ) resistor r=25.4566 //w=0.357 //l=0.71 //layer=li \
 //thickness=0.1 //x=7.575 //y=7.4 //x2=6.865 //y2=7.4
r591 (  127 347 ) resistor r=4.11603 //w=0.68 //l=0.17 //layer=li \
 //thickness=0.1 //x=6.78 //y=7.23 //x2=6.78 //y2=7.4
r592 (  127 375 ) resistor r=33.1979 //w=0.187 //l=0.485 //layer=li \
 //thickness=0.1 //x=6.78 //y=7.23 //x2=6.78 //y2=6.745
r593 (  124 346 ) resistor r=2.94794 //w=0.34 //l=0.085 //layer=li \
 //thickness=0.1 //x=5.985 //y=7.4 //x2=5.9 //y2=7.4
r594 (  124 126 ) resistor r=24.2017 //w=0.357 //l=0.675 //layer=li \
 //thickness=0.1 //x=5.985 //y=7.4 //x2=6.66 //y2=7.4
r595 (  123 347 ) resistor r=2.94794 //w=0.34 //l=0.085 //layer=li \
 //thickness=0.1 //x=6.695 //y=7.4 //x2=6.78 //y2=7.4
r596 (  123 126 ) resistor r=1.2549 //w=0.357 //l=0.035 //layer=li \
 //thickness=0.1 //x=6.695 //y=7.4 //x2=6.66 //y2=7.4
r597 (  115 346 ) resistor r=4.11603 //w=0.68 //l=0.17 //layer=li \
 //thickness=0.1 //x=5.9 //y=7.23 //x2=5.9 //y2=7.4
r598 (  115 374 ) resistor r=56.4706 //w=0.187 //l=0.825 //layer=li \
 //thickness=0.1 //x=5.9 //y=7.23 //x2=5.9 //y2=6.405
r599 (  112 345 ) resistor r=5.4201 //w=0.34 //l=0.17 //layer=li \
 //thickness=0.1 //x=4.98 //y=7.4 //x2=4.81 //y2=7.4
r600 (  112 114 ) resistor r=20.437 //w=0.357 //l=0.57 //layer=li \
 //thickness=0.1 //x=4.98 //y=7.4 //x2=5.55 //y2=7.4
r601 (  111 346 ) resistor r=2.94794 //w=0.34 //l=0.085 //layer=li \
 //thickness=0.1 //x=5.815 //y=7.4 //x2=5.9 //y2=7.4
r602 (  111 114 ) resistor r=9.5014 //w=0.357 //l=0.265 //layer=li \
 //thickness=0.1 //x=5.815 //y=7.4 //x2=5.55 //y2=7.4
r603 (  106 344 ) resistor r=2.94794 //w=0.34 //l=0.085 //layer=li \
 //thickness=0.1 //x=3.815 //y=7.4 //x2=3.73 //y2=7.4
r604 (  106 108 ) resistor r=9.14286 //w=0.357 //l=0.255 //layer=li \
 //thickness=0.1 //x=3.815 //y=7.4 //x2=4.07 //y2=7.4
r605 (  105 345 ) resistor r=5.4201 //w=0.34 //l=0.17 //layer=li \
 //thickness=0.1 //x=4.64 //y=7.4 //x2=4.81 //y2=7.4
r606 (  105 108 ) resistor r=20.437 //w=0.357 //l=0.57 //layer=li \
 //thickness=0.1 //x=4.64 //y=7.4 //x2=4.07 //y2=7.4
r607 (  99 344 ) resistor r=4.11603 //w=0.68 //l=0.17 //layer=li \
 //thickness=0.1 //x=3.73 //y=7.23 //x2=3.73 //y2=7.4
r608 (  99 373 ) resistor r=33.1979 //w=0.187 //l=0.485 //layer=li \
 //thickness=0.1 //x=3.73 //y=7.23 //x2=3.73 //y2=6.745
r609 (  96 343 ) resistor r=2.94794 //w=0.34 //l=0.085 //layer=li \
 //thickness=0.1 //x=2.935 //y=7.4 //x2=2.85 //y2=7.4
r610 (  96 98 ) resistor r=0.896359 //w=0.357 //l=0.025 //layer=li \
 //thickness=0.1 //x=2.935 //y=7.4 //x2=2.96 //y2=7.4
r611 (  95 344 ) resistor r=2.94794 //w=0.34 //l=0.085 //layer=li \
 //thickness=0.1 //x=3.645 //y=7.4 //x2=3.73 //y2=7.4
r612 (  95 98 ) resistor r=24.5602 //w=0.357 //l=0.685 //layer=li \
 //thickness=0.1 //x=3.645 //y=7.4 //x2=2.96 //y2=7.4
r613 (  89 343 ) resistor r=4.11603 //w=0.68 //l=0.17 //layer=li \
 //thickness=0.1 //x=2.85 //y=7.23 //x2=2.85 //y2=7.4
r614 (  89 372 ) resistor r=33.1979 //w=0.187 //l=0.485 //layer=li \
 //thickness=0.1 //x=2.85 //y=7.23 //x2=2.85 //y2=6.745
r615 (  88 342 ) resistor r=2.94794 //w=0.34 //l=0.085 //layer=li \
 //thickness=0.1 //x=2.055 //y=7.4 //x2=1.97 //y2=7.4
r616 (  87 343 ) resistor r=2.94794 //w=0.34 //l=0.085 //layer=li \
 //thickness=0.1 //x=2.765 //y=7.4 //x2=2.85 //y2=7.4
r617 (  87 88 ) resistor r=25.4566 //w=0.357 //l=0.71 //layer=li \
 //thickness=0.1 //x=2.765 //y=7.4 //x2=2.055 //y2=7.4
r618 (  81 342 ) resistor r=4.11603 //w=0.68 //l=0.17 //layer=li \
 //thickness=0.1 //x=1.97 //y=7.23 //x2=1.97 //y2=7.4
r619 (  81 371 ) resistor r=33.1979 //w=0.187 //l=0.485 //layer=li \
 //thickness=0.1 //x=1.97 //y=7.23 //x2=1.97 //y2=6.745
r620 (  78 341 ) resistor r=2.94794 //w=0.34 //l=0.085 //layer=li \
 //thickness=0.1 //x=1.175 //y=7.4 //x2=1.09 //y2=7.4
r621 (  78 80 ) resistor r=24.2017 //w=0.357 //l=0.675 //layer=li \
 //thickness=0.1 //x=1.175 //y=7.4 //x2=1.85 //y2=7.4
r622 (  77 342 ) resistor r=2.94794 //w=0.34 //l=0.085 //layer=li \
 //thickness=0.1 //x=1.885 //y=7.4 //x2=1.97 //y2=7.4
r623 (  77 80 ) resistor r=1.2549 //w=0.357 //l=0.035 //layer=li \
 //thickness=0.1 //x=1.885 //y=7.4 //x2=1.85 //y2=7.4
r624 (  69 341 ) resistor r=4.11603 //w=0.68 //l=0.17 //layer=li \
 //thickness=0.1 //x=1.09 //y=7.23 //x2=1.09 //y2=7.4
r625 (  69 370 ) resistor r=56.4706 //w=0.187 //l=0.825 //layer=li \
 //thickness=0.1 //x=1.09 //y=7.23 //x2=1.09 //y2=6.405
r626 (  65 341 ) resistor r=2.94794 //w=0.34 //l=0.085 //layer=li \
 //thickness=0.1 //x=1.005 //y=7.4 //x2=1.09 //y2=7.4
r627 (  65 68 ) resistor r=9.5014 //w=0.357 //l=0.265 //layer=li \
 //thickness=0.1 //x=1.005 //y=7.4 //x2=0.74 //y2=7.4
r628 (  49 338 ) resistor r=3.1 //w=0.17 //l=0.51 //layer=mcon //count=3 \
 //x=28.12 //y=7.4 //x2=28.12 //y2=7.4
r629 (  47 328 ) resistor r=3.1 //w=0.17 //l=0.51 //layer=mcon //count=3 \
 //x=27.01 //y=7.4 //x2=27.01 //y2=7.4
r630 (  47 49 ) resistor r=0.460963 //w=0.301 //l=1.11 //layer=m1 \
 //thickness=0.36 //x=27.01 //y=7.4 //x2=28.12 //y2=7.4
r631 (  45 310 ) resistor r=3.1 //w=0.17 //l=0.51 //layer=mcon //count=3 \
 //x=25.9 //y=7.4 //x2=25.9 //y2=7.4
r632 (  45 47 ) resistor r=0.460963 //w=0.301 //l=1.11 //layer=m1 \
 //thickness=0.36 //x=25.9 //y=7.4 //x2=27.01 //y2=7.4
r633 (  43 298 ) resistor r=3.1 //w=0.17 //l=0.51 //layer=mcon //count=3 \
 //x=24.79 //y=7.4 //x2=24.79 //y2=7.4
r634 (  43 45 ) resistor r=0.460963 //w=0.301 //l=1.11 //layer=m1 \
 //thickness=0.36 //x=24.79 //y=7.4 //x2=25.9 //y2=7.4
r635 (  41 292 ) resistor r=3.1 //w=0.17 //l=0.51 //layer=mcon //count=3 \
 //x=23.31 //y=7.4 //x2=23.31 //y2=7.4
r636 (  41 43 ) resistor r=0.614618 //w=0.301 //l=1.48 //layer=m1 \
 //thickness=0.36 //x=23.31 //y=7.4 //x2=24.79 //y2=7.4
r637 (  39 282 ) resistor r=3.1 //w=0.17 //l=0.51 //layer=mcon //count=3 \
 //x=22.2 //y=7.4 //x2=22.2 //y2=7.4
r638 (  39 41 ) resistor r=0.460963 //w=0.301 //l=1.11 //layer=m1 \
 //thickness=0.36 //x=22.2 //y=7.4 //x2=23.31 //y2=7.4
r639 (  37 264 ) resistor r=3.1 //w=0.17 //l=0.51 //layer=mcon //count=3 \
 //x=21.09 //y=7.4 //x2=21.09 //y2=7.4
r640 (  37 39 ) resistor r=0.460963 //w=0.301 //l=1.11 //layer=m1 \
 //thickness=0.36 //x=21.09 //y=7.4 //x2=22.2 //y2=7.4
r641 (  35 252 ) resistor r=3.1 //w=0.17 //l=0.51 //layer=mcon //count=3 \
 //x=19.98 //y=7.4 //x2=19.98 //y2=7.4
r642 (  35 37 ) resistor r=0.460963 //w=0.301 //l=1.11 //layer=m1 \
 //thickness=0.36 //x=19.98 //y=7.4 //x2=21.09 //y2=7.4
r643 (  33 246 ) resistor r=3.1 //w=0.17 //l=0.51 //layer=mcon //count=3 \
 //x=18.5 //y=7.4 //x2=18.5 //y2=7.4
r644 (  33 35 ) resistor r=0.614618 //w=0.301 //l=1.48 //layer=m1 \
 //thickness=0.36 //x=18.5 //y=7.4 //x2=19.98 //y2=7.4
r645 (  31 236 ) resistor r=3.1 //w=0.17 //l=0.51 //layer=mcon //count=3 \
 //x=17.39 //y=7.4 //x2=17.39 //y2=7.4
r646 (  31 33 ) resistor r=0.460963 //w=0.301 //l=1.11 //layer=m1 \
 //thickness=0.36 //x=17.39 //y=7.4 //x2=18.5 //y2=7.4
r647 (  29 218 ) resistor r=3.1 //w=0.17 //l=0.51 //layer=mcon //count=3 \
 //x=16.28 //y=7.4 //x2=16.28 //y2=7.4
r648 (  29 31 ) resistor r=0.460963 //w=0.301 //l=1.11 //layer=m1 \
 //thickness=0.36 //x=16.28 //y=7.4 //x2=17.39 //y2=7.4
r649 (  27 206 ) resistor r=3.1 //w=0.17 //l=0.51 //layer=mcon //count=3 \
 //x=15.17 //y=7.4 //x2=15.17 //y2=7.4
r650 (  27 29 ) resistor r=0.460963 //w=0.301 //l=1.11 //layer=m1 \
 //thickness=0.36 //x=15.17 //y=7.4 //x2=16.28 //y2=7.4
r651 (  25 200 ) resistor r=3.1 //w=0.17 //l=0.51 //layer=mcon //count=3 \
 //x=13.69 //y=7.4 //x2=13.69 //y2=7.4
r652 (  25 27 ) resistor r=0.614618 //w=0.301 //l=1.48 //layer=m1 \
 //thickness=0.36 //x=13.69 //y=7.4 //x2=15.17 //y2=7.4
r653 (  23 190 ) resistor r=3.1 //w=0.17 //l=0.51 //layer=mcon //count=3 \
 //x=12.58 //y=7.4 //x2=12.58 //y2=7.4
r654 (  23 25 ) resistor r=0.460963 //w=0.301 //l=1.11 //layer=m1 \
 //thickness=0.36 //x=12.58 //y=7.4 //x2=13.69 //y2=7.4
r655 (  21 172 ) resistor r=3.1 //w=0.17 //l=0.51 //layer=mcon //count=3 \
 //x=11.47 //y=7.4 //x2=11.47 //y2=7.4
r656 (  21 23 ) resistor r=0.460963 //w=0.301 //l=1.11 //layer=m1 \
 //thickness=0.36 //x=11.47 //y=7.4 //x2=12.58 //y2=7.4
r657 (  19 160 ) resistor r=3.1 //w=0.17 //l=0.51 //layer=mcon //count=3 \
 //x=10.36 //y=7.4 //x2=10.36 //y2=7.4
r658 (  19 21 ) resistor r=0.460963 //w=0.301 //l=1.11 //layer=m1 \
 //thickness=0.36 //x=10.36 //y=7.4 //x2=11.47 //y2=7.4
r659 (  17 154 ) resistor r=3.1 //w=0.17 //l=0.51 //layer=mcon //count=3 \
 //x=8.88 //y=7.4 //x2=8.88 //y2=7.4
r660 (  17 19 ) resistor r=0.614618 //w=0.301 //l=1.48 //layer=m1 \
 //thickness=0.36 //x=8.88 //y=7.4 //x2=10.36 //y2=7.4
r661 (  15 144 ) resistor r=3.1 //w=0.17 //l=0.51 //layer=mcon //count=3 \
 //x=7.77 //y=7.4 //x2=7.77 //y2=7.4
r662 (  15 17 ) resistor r=0.460963 //w=0.301 //l=1.11 //layer=m1 \
 //thickness=0.36 //x=7.77 //y=7.4 //x2=8.88 //y2=7.4
r663 (  13 126 ) resistor r=3.1 //w=0.17 //l=0.51 //layer=mcon //count=3 \
 //x=6.66 //y=7.4 //x2=6.66 //y2=7.4
r664 (  13 15 ) resistor r=0.460963 //w=0.301 //l=1.11 //layer=m1 \
 //thickness=0.36 //x=6.66 //y=7.4 //x2=7.77 //y2=7.4
r665 (  11 114 ) resistor r=3.1 //w=0.17 //l=0.51 //layer=mcon //count=3 \
 //x=5.55 //y=7.4 //x2=5.55 //y2=7.4
r666 (  11 13 ) resistor r=0.460963 //w=0.301 //l=1.11 //layer=m1 \
 //thickness=0.36 //x=5.55 //y=7.4 //x2=6.66 //y2=7.4
r667 (  9 108 ) resistor r=3.1 //w=0.17 //l=0.51 //layer=mcon //count=3 \
 //x=4.07 //y=7.4 //x2=4.07 //y2=7.4
r668 (  9 11 ) resistor r=0.614618 //w=0.301 //l=1.48 //layer=m1 \
 //thickness=0.36 //x=4.07 //y=7.4 //x2=5.55 //y2=7.4
r669 (  7 98 ) resistor r=3.1 //w=0.17 //l=0.51 //layer=mcon //count=3 \
 //x=2.96 //y=7.4 //x2=2.96 //y2=7.4
r670 (  7 9 ) resistor r=0.460963 //w=0.301 //l=1.11 //layer=m1 \
 //thickness=0.36 //x=2.96 //y=7.4 //x2=4.07 //y2=7.4
r671 (  5 80 ) resistor r=3.1 //w=0.17 //l=0.51 //layer=mcon //count=3 \
 //x=1.85 //y=7.4 //x2=1.85 //y2=7.4
r672 (  5 7 ) resistor r=0.460963 //w=0.301 //l=1.11 //layer=m1 \
 //thickness=0.36 //x=1.85 //y=7.4 //x2=2.96 //y2=7.4
r673 (  2 68 ) resistor r=3.1 //w=0.17 //l=0.51 //layer=mcon //count=3 \
 //x=0.74 //y=7.4 //x2=0.74 //y2=7.4
r674 (  2 5 ) resistor r=0.460963 //w=0.301 //l=1.11 //layer=m1 \
 //thickness=0.36 //x=0.74 //y=7.4 //x2=1.85 //y2=7.4
ends PM_DFFSNRNX1_PCELL\%noxref_8

subckt PM_DFFSNRNX1_PCELL\%noxref_9 ( 1 2 8 13 17 18 19 20 21 22 23 24 26 32 \
 33 34 35 )
c92 ( 35 0 ) capacitor c=0.0612936f //x=1.385 //y=4.79
c93 ( 34 0 ) capacitor c=0.0376642f //x=1.675 //y=4.79
c94 ( 33 0 ) capacitor c=0.0346489f //x=1.34 //y=1.22
c95 ( 32 0 ) capacitor c=0.018692f //x=1.34 //y=0.875
c96 ( 26 0 ) capacitor c=0.0137077f //x=1.185 //y=1.375
c97 ( 24 0 ) capacitor c=0.0158585f //x=1.185 //y=0.72
c98 ( 23 0 ) capacitor c=0.103534f //x=0.81 //y=1.915
c99 ( 22 0 ) capacitor c=0.0229444f //x=0.81 //y=1.53
c100 ( 21 0 ) capacitor c=0.0234359f //x=0.81 //y=1.22
c101 ( 20 0 ) capacitor c=0.019815f //x=0.81 //y=0.875
c102 ( 19 0 ) capacitor c=0.110208f //x=1.75 //y=6.02
c103 ( 18 0 ) capacitor c=0.158957f //x=1.31 //y=6.02
c104 ( 13 0 ) capacitor c=0.0014751f //x=1.11 //y=4.7
c105 ( 8 0 ) capacitor c=0.0012618f //x=1.11 //y=2.08
c106 ( 2 0 ) capacitor c=0.12781f //x=1.11 //y=4.575
c107 ( 1 0 ) capacitor c=0.0114805f //x=1.11 //y=2.195
r108 (  34 36 ) resistor r=26.9307 //w=0.15 //l=0.106066 //layer=ply \
 //thickness=0.18 //x=1.675 //y=4.79 //x2=1.75 //y2=4.865
r109 (  34 35 ) resistor r=148.702 //w=0.094 //l=0.29 //layer=ply \
 //thickness=0.18 //x=1.675 //y=4.79 //x2=1.385 //y2=4.79
r110 (  33 46 ) resistor r=45.1352 //w=0.168 //l=0.173853 //layer=ply \
 //thickness=0.18 //x=1.34 //y=1.22 //x2=1.3 //y2=1.375
r111 (  32 45 ) resistor r=45.1352 //w=0.168 //l=0.173853 //layer=ply \
 //thickness=0.18 //x=1.34 //y=0.875 //x2=1.3 //y2=0.72
r112 (  32 33 ) resistor r=176.904 //w=0.094 //l=0.345 //layer=ply \
 //thickness=0.18 //x=1.34 //y=0.875 //x2=1.34 //y2=1.22
r113 (  29 35 ) resistor r=22.7971 //w=0.269 //l=0.106066 //layer=ply \
 //thickness=0.18 //x=1.31 //y=4.865 //x2=1.385 //y2=4.79
r114 (  29 44 ) resistor r=35.8364 //w=0.269 //l=0.270185 //layer=ply \
 //thickness=0.18 //x=1.31 //y=4.865 //x2=1.11 //y2=4.7
r115 (  27 40 ) resistor r=10.701 //w=0.21 //l=0.115 //layer=ply \
 //thickness=0.18 //x=0.965 //y=1.375 //x2=0.85 //y2=1.375
r116 (  26 46 ) resistor r=5.52526 //w=0.168 //l=0.115 //layer=ply \
 //thickness=0.18 //x=1.185 //y=1.375 //x2=1.3 //y2=1.375
r117 (  25 39 ) resistor r=5.52526 //w=0.168 //l=0.115 //layer=ply \
 //thickness=0.18 //x=0.965 //y=0.72 //x2=0.85 //y2=0.72
r118 (  24 45 ) resistor r=5.52526 //w=0.168 //l=0.115 //layer=ply \
 //thickness=0.18 //x=1.185 //y=0.72 //x2=1.3 //y2=0.72
r119 (  24 25 ) resistor r=112.809 //w=0.094 //l=0.22 //layer=ply \
 //thickness=0.18 //x=1.185 //y=0.72 //x2=0.965 //y2=0.72
r120 (  23 42 ) resistor r=58.7805 //w=0.246 //l=0.373497 //layer=ply \
 //thickness=0.18 //x=0.81 //y=1.915 //x2=1.11 //y2=2.08
r121 (  22 40 ) resistor r=39.5823 //w=0.21 //l=0.173853 //layer=ply \
 //thickness=0.18 //x=0.81 //y=1.53 //x2=0.85 //y2=1.375
r122 (  22 23 ) resistor r=197.415 //w=0.094 //l=0.385 //layer=ply \
 //thickness=0.18 //x=0.81 //y=1.53 //x2=0.81 //y2=1.915
r123 (  21 40 ) resistor r=39.5823 //w=0.21 //l=0.173853 //layer=ply \
 //thickness=0.18 //x=0.81 //y=1.22 //x2=0.85 //y2=1.375
r124 (  20 39 ) resistor r=45.1352 //w=0.168 //l=0.173853 //layer=ply \
 //thickness=0.18 //x=0.81 //y=0.875 //x2=0.85 //y2=0.72
r125 (  20 21 ) resistor r=176.904 //w=0.094 //l=0.345 //layer=ply \
 //thickness=0.18 //x=0.81 //y=0.875 //x2=0.81 //y2=1.22
r126 (  19 36 ) resistor r=592.245 //w=0.094 //l=1.155 //layer=ply \
 //thickness=0.18 //x=1.75 //y=6.02 //x2=1.75 //y2=4.865
r127 (  18 29 ) resistor r=592.245 //w=0.094 //l=1.155 //layer=ply \
 //thickness=0.18 //x=1.31 //y=6.02 //x2=1.31 //y2=4.865
r128 (  17 26 ) resistor r=56.4043 //w=0.094 //l=0.11 //layer=ply \
 //thickness=0.18 //x=1.075 //y=1.375 //x2=1.185 //y2=1.375
r129 (  17 27 ) resistor r=56.4043 //w=0.094 //l=0.11 //layer=ply \
 //thickness=0.18 //x=1.075 //y=1.375 //x2=0.965 //y2=1.375
r130 (  13 44 ) resistor r=152 //w=0.17 //l=0.17 //layer=licon //count=1 \
 //x=1.11 //y=4.7 //x2=1.11 //y2=4.7
r131 (  8 42 ) resistor r=152 //w=0.17 //l=0.17 //layer=licon //count=1 \
 //x=1.11 //y=2.08 //x2=1.11 //y2=2.08
r132 (  6 13 ) resistor r=9.3 //w=0.17 //l=0.17 //layer=mcon //count=1 \
 //x=1.11 //y=4.7 //x2=1.11 //y2=4.7
r133 (  4 8 ) resistor r=9.3 //w=0.17 //l=0.17 //layer=mcon //count=1 //x=1.11 \
 //y=2.08 //x2=1.11 //y2=2.08
r134 (  2 6 ) resistor r=0.0760407 //w=0.238 //l=0.125 //layer=m1 \
 //thickness=0.36 //x=1.11 //y=4.575 //x2=1.11 //y2=4.7
r135 (  1 4 ) resistor r=0.0719237 //w=0.222 //l=0.115 //layer=m1 \
 //thickness=0.36 //x=1.11 //y=2.195 //x2=1.11 //y2=2.08
r136 (  1 2 ) resistor r=2.27099 //w=0.131 //l=2.38 //layer=m1 \
 //thickness=0.36 //x=1.11 //y=2.195 //x2=1.11 //y2=4.575
ends PM_DFFSNRNX1_PCELL\%noxref_9

subckt PM_DFFSNRNX1_PCELL\%noxref_10 ( 5 7 15 19 30 33 34 )
c69 ( 34 0 ) capacitor c=0.0443556f //x=2.965 //y=0.375
c70 ( 33 0 ) capacitor c=0.0194217f //x=1.86 //y=0.91
c71 ( 30 0 ) capacitor c=0.00141302f //x=3.1 //y=0.995
c72 ( 19 0 ) capacitor c=0.00692795f //x=4.07 //y=0.625
c73 ( 15 0 ) capacitor c=0.0155078f //x=3.985 //y=0.54
c74 ( 7 0 ) capacitor c=0.00689459f //x=3.1 //y=0.625
c75 ( 5 0 ) capacitor c=0.0235962f //x=3.015 //y=0.995
r76 (  19 34 ) resistor r=3.57586 //w=0.17 //l=0.125 //layer=li \
 //thickness=0.1 //x=4.07 //y=0.625 //x2=4.07 //y2=0.5
r77 (  19 34 ) resistor r=18.139 //w=0.187 //l=0.265 //layer=li \
 //thickness=0.1 //x=4.07 //y=0.625 //x2=4.07 //y2=0.89
r78 (  16 34 ) resistor r=3.57586 //w=0.17 //l=0.103078 //layer=li \
 //thickness=0.1 //x=3.185 //y=0.54 //x2=3.1 //y2=0.5
r79 (  16 34 ) resistor r=27.3797 //w=0.187 //l=0.4 //layer=li //thickness=0.1 \
 //x=3.185 //y=0.54 //x2=3.585 //y2=0.54
r80 (  15 34 ) resistor r=3.57586 //w=0.17 //l=0.103078 //layer=li \
 //thickness=0.1 //x=3.985 //y=0.54 //x2=4.07 //y2=0.5
r81 (  15 34 ) resistor r=27.3797 //w=0.187 //l=0.4 //layer=li //thickness=0.1 \
 //x=3.985 //y=0.54 //x2=3.585 //y2=0.54
r82 (  11 30 ) resistor r=5.4201 //w=0.17 //l=0.085 //layer=li //thickness=0.1 \
 //x=3.1 //y=1.08 //x2=3.1 //y2=0.995
r83 (  11 34 ) resistor r=10.2674 //w=0.187 //l=0.15 //layer=li \
 //thickness=0.1 //x=3.1 //y=1.08 //x2=3.1 //y2=1.23
r84 (  8 30 ) resistor r=5.4201 //w=0.17 //l=0.085 //layer=li //thickness=0.1 \
 //x=3.1 //y=0.91 //x2=3.1 //y2=0.995
r85 (  8 34 ) resistor r=1.36898 //w=0.187 //l=0.02 //layer=li //thickness=0.1 \
 //x=3.1 //y=0.91 //x2=3.1 //y2=0.89
r86 (  7 34 ) resistor r=3.57586 //w=0.17 //l=0.125 //layer=li //thickness=0.1 \
 //x=3.1 //y=0.625 //x2=3.1 //y2=0.5
r87 (  7 34 ) resistor r=18.139 //w=0.187 //l=0.265 //layer=li //thickness=0.1 \
 //x=3.1 //y=0.625 //x2=3.1 //y2=0.89
r88 (  6 33 ) resistor r=0.751729 //w=0.17 //l=0.085 //layer=li \
 //thickness=0.1 //x=2.135 //y=0.995 //x2=2.05 //y2=0.995
r89 (  5 30 ) resistor r=1.40859 //w=0.34 //l=0.085 //layer=li //thickness=0.1 \
 //x=3.015 //y=0.995 //x2=3.1 //y2=0.995
r90 (  5 6 ) resistor r=60.2353 //w=0.187 //l=0.88 //layer=li //thickness=0.1 \
 //x=3.015 //y=0.995 //x2=2.135 //y2=0.995
ends PM_DFFSNRNX1_PCELL\%noxref_10

subckt PM_DFFSNRNX1_PCELL\%noxref_11 ( 5 7 15 19 30 33 34 )
c70 ( 34 0 ) capacitor c=0.0451719f //x=7.775 //y=0.375
c71 ( 33 0 ) capacitor c=0.0194945f //x=6.67 //y=0.91
c72 ( 30 0 ) capacitor c=0.00141302f //x=7.91 //y=0.995
c73 ( 19 0 ) capacitor c=0.00692795f //x=8.88 //y=0.625
c74 ( 15 0 ) capacitor c=0.0154868f //x=8.795 //y=0.54
c75 ( 7 0 ) capacitor c=0.00689459f //x=7.91 //y=0.625
c76 ( 5 0 ) capacitor c=0.0235962f //x=7.825 //y=0.995
r77 (  19 34 ) resistor r=3.57586 //w=0.17 //l=0.125 //layer=li \
 //thickness=0.1 //x=8.88 //y=0.625 //x2=8.88 //y2=0.5
r78 (  19 34 ) resistor r=18.139 //w=0.187 //l=0.265 //layer=li \
 //thickness=0.1 //x=8.88 //y=0.625 //x2=8.88 //y2=0.89
r79 (  16 34 ) resistor r=3.57586 //w=0.17 //l=0.103078 //layer=li \
 //thickness=0.1 //x=7.995 //y=0.54 //x2=7.91 //y2=0.5
r80 (  16 34 ) resistor r=27.3797 //w=0.187 //l=0.4 //layer=li //thickness=0.1 \
 //x=7.995 //y=0.54 //x2=8.395 //y2=0.54
r81 (  15 34 ) resistor r=3.57586 //w=0.17 //l=0.103078 //layer=li \
 //thickness=0.1 //x=8.795 //y=0.54 //x2=8.88 //y2=0.5
r82 (  15 34 ) resistor r=27.3797 //w=0.187 //l=0.4 //layer=li //thickness=0.1 \
 //x=8.795 //y=0.54 //x2=8.395 //y2=0.54
r83 (  11 30 ) resistor r=5.4201 //w=0.17 //l=0.085 //layer=li //thickness=0.1 \
 //x=7.91 //y=1.08 //x2=7.91 //y2=0.995
r84 (  11 34 ) resistor r=10.2674 //w=0.187 //l=0.15 //layer=li \
 //thickness=0.1 //x=7.91 //y=1.08 //x2=7.91 //y2=1.23
r85 (  8 30 ) resistor r=5.4201 //w=0.17 //l=0.085 //layer=li //thickness=0.1 \
 //x=7.91 //y=0.91 //x2=7.91 //y2=0.995
r86 (  8 34 ) resistor r=1.36898 //w=0.187 //l=0.02 //layer=li //thickness=0.1 \
 //x=7.91 //y=0.91 //x2=7.91 //y2=0.89
r87 (  7 34 ) resistor r=3.57586 //w=0.17 //l=0.125 //layer=li //thickness=0.1 \
 //x=7.91 //y=0.625 //x2=7.91 //y2=0.5
r88 (  7 34 ) resistor r=18.139 //w=0.187 //l=0.265 //layer=li //thickness=0.1 \
 //x=7.91 //y=0.625 //x2=7.91 //y2=0.89
r89 (  6 33 ) resistor r=0.751729 //w=0.17 //l=0.085 //layer=li \
 //thickness=0.1 //x=6.945 //y=0.995 //x2=6.86 //y2=0.995
r90 (  5 30 ) resistor r=1.40859 //w=0.34 //l=0.085 //layer=li //thickness=0.1 \
 //x=7.825 //y=0.995 //x2=7.91 //y2=0.995
r91 (  5 6 ) resistor r=60.2353 //w=0.187 //l=0.88 //layer=li //thickness=0.1 \
 //x=7.825 //y=0.995 //x2=6.945 //y2=0.995
ends PM_DFFSNRNX1_PCELL\%noxref_11

subckt PM_DFFSNRNX1_PCELL\%noxref_12 ( 5 7 15 19 30 33 34 )
c71 ( 34 0 ) capacitor c=0.0442917f //x=12.585 //y=0.375
c72 ( 33 0 ) capacitor c=0.0193551f //x=11.48 //y=0.91
c73 ( 30 0 ) capacitor c=0.00141302f //x=12.72 //y=0.995
c74 ( 19 0 ) capacitor c=0.00692795f //x=13.69 //y=0.625
c75 ( 15 0 ) capacitor c=0.0154868f //x=13.605 //y=0.54
c76 ( 7 0 ) capacitor c=0.00689459f //x=12.72 //y=0.625
c77 ( 5 0 ) capacitor c=0.0235962f //x=12.635 //y=0.995
r78 (  19 34 ) resistor r=3.57586 //w=0.17 //l=0.125 //layer=li \
 //thickness=0.1 //x=13.69 //y=0.625 //x2=13.69 //y2=0.5
r79 (  19 34 ) resistor r=18.139 //w=0.187 //l=0.265 //layer=li \
 //thickness=0.1 //x=13.69 //y=0.625 //x2=13.69 //y2=0.89
r80 (  16 34 ) resistor r=3.57586 //w=0.17 //l=0.103078 //layer=li \
 //thickness=0.1 //x=12.805 //y=0.54 //x2=12.72 //y2=0.5
r81 (  16 34 ) resistor r=27.3797 //w=0.187 //l=0.4 //layer=li //thickness=0.1 \
 //x=12.805 //y=0.54 //x2=13.205 //y2=0.54
r82 (  15 34 ) resistor r=3.57586 //w=0.17 //l=0.103078 //layer=li \
 //thickness=0.1 //x=13.605 //y=0.54 //x2=13.69 //y2=0.5
r83 (  15 34 ) resistor r=27.3797 //w=0.187 //l=0.4 //layer=li //thickness=0.1 \
 //x=13.605 //y=0.54 //x2=13.205 //y2=0.54
r84 (  11 30 ) resistor r=5.4201 //w=0.17 //l=0.085 //layer=li //thickness=0.1 \
 //x=12.72 //y=1.08 //x2=12.72 //y2=0.995
r85 (  11 34 ) resistor r=10.2674 //w=0.187 //l=0.15 //layer=li \
 //thickness=0.1 //x=12.72 //y=1.08 //x2=12.72 //y2=1.23
r86 (  8 30 ) resistor r=5.4201 //w=0.17 //l=0.085 //layer=li //thickness=0.1 \
 //x=12.72 //y=0.91 //x2=12.72 //y2=0.995
r87 (  8 34 ) resistor r=1.36898 //w=0.187 //l=0.02 //layer=li //thickness=0.1 \
 //x=12.72 //y=0.91 //x2=12.72 //y2=0.89
r88 (  7 34 ) resistor r=3.57586 //w=0.17 //l=0.125 //layer=li //thickness=0.1 \
 //x=12.72 //y=0.625 //x2=12.72 //y2=0.5
r89 (  7 34 ) resistor r=18.139 //w=0.187 //l=0.265 //layer=li //thickness=0.1 \
 //x=12.72 //y=0.625 //x2=12.72 //y2=0.89
r90 (  6 33 ) resistor r=0.751729 //w=0.17 //l=0.085 //layer=li \
 //thickness=0.1 //x=11.755 //y=0.995 //x2=11.67 //y2=0.995
r91 (  5 30 ) resistor r=1.40859 //w=0.34 //l=0.085 //layer=li //thickness=0.1 \
 //x=12.635 //y=0.995 //x2=12.72 //y2=0.995
r92 (  5 6 ) resistor r=60.2353 //w=0.187 //l=0.88 //layer=li //thickness=0.1 \
 //x=12.635 //y=0.995 //x2=11.755 //y2=0.995
ends PM_DFFSNRNX1_PCELL\%noxref_12

subckt PM_DFFSNRNX1_PCELL\%noxref_13 ( 5 7 15 19 30 33 34 )
c70 ( 34 0 ) capacitor c=0.0452753f //x=17.395 //y=0.375
c71 ( 33 0 ) capacitor c=0.0194988f //x=16.29 //y=0.91
c72 ( 30 0 ) capacitor c=0.00141302f //x=17.53 //y=0.995
c73 ( 19 0 ) capacitor c=0.00692795f //x=18.5 //y=0.625
c74 ( 15 0 ) capacitor c=0.0153812f //x=18.415 //y=0.54
c75 ( 7 0 ) capacitor c=0.00689459f //x=17.53 //y=0.625
c76 ( 5 0 ) capacitor c=0.0235962f //x=17.445 //y=0.995
r77 (  19 34 ) resistor r=3.57586 //w=0.17 //l=0.125 //layer=li \
 //thickness=0.1 //x=18.5 //y=0.625 //x2=18.5 //y2=0.5
r78 (  19 34 ) resistor r=18.139 //w=0.187 //l=0.265 //layer=li \
 //thickness=0.1 //x=18.5 //y=0.625 //x2=18.5 //y2=0.89
r79 (  16 34 ) resistor r=3.57586 //w=0.17 //l=0.103078 //layer=li \
 //thickness=0.1 //x=17.615 //y=0.54 //x2=17.53 //y2=0.5
r80 (  16 34 ) resistor r=27.3797 //w=0.187 //l=0.4 //layer=li //thickness=0.1 \
 //x=17.615 //y=0.54 //x2=18.015 //y2=0.54
r81 (  15 34 ) resistor r=3.57586 //w=0.17 //l=0.103078 //layer=li \
 //thickness=0.1 //x=18.415 //y=0.54 //x2=18.5 //y2=0.5
r82 (  15 34 ) resistor r=27.3797 //w=0.187 //l=0.4 //layer=li //thickness=0.1 \
 //x=18.415 //y=0.54 //x2=18.015 //y2=0.54
r83 (  11 30 ) resistor r=5.4201 //w=0.17 //l=0.085 //layer=li //thickness=0.1 \
 //x=17.53 //y=1.08 //x2=17.53 //y2=0.995
r84 (  11 34 ) resistor r=10.2674 //w=0.187 //l=0.15 //layer=li \
 //thickness=0.1 //x=17.53 //y=1.08 //x2=17.53 //y2=1.23
r85 (  8 30 ) resistor r=5.4201 //w=0.17 //l=0.085 //layer=li //thickness=0.1 \
 //x=17.53 //y=0.91 //x2=17.53 //y2=0.995
r86 (  8 34 ) resistor r=1.36898 //w=0.187 //l=0.02 //layer=li //thickness=0.1 \
 //x=17.53 //y=0.91 //x2=17.53 //y2=0.89
r87 (  7 34 ) resistor r=3.57586 //w=0.17 //l=0.125 //layer=li //thickness=0.1 \
 //x=17.53 //y=0.625 //x2=17.53 //y2=0.5
r88 (  7 34 ) resistor r=18.139 //w=0.187 //l=0.265 //layer=li //thickness=0.1 \
 //x=17.53 //y=0.625 //x2=17.53 //y2=0.89
r89 (  6 33 ) resistor r=0.751729 //w=0.17 //l=0.085 //layer=li \
 //thickness=0.1 //x=16.565 //y=0.995 //x2=16.48 //y2=0.995
r90 (  5 30 ) resistor r=1.40859 //w=0.34 //l=0.085 //layer=li //thickness=0.1 \
 //x=17.445 //y=0.995 //x2=17.53 //y2=0.995
r91 (  5 6 ) resistor r=60.2353 //w=0.187 //l=0.88 //layer=li //thickness=0.1 \
 //x=17.445 //y=0.995 //x2=16.565 //y2=0.995
ends PM_DFFSNRNX1_PCELL\%noxref_13

subckt PM_DFFSNRNX1_PCELL\%noxref_14 ( 5 7 15 19 30 33 34 )
c69 ( 34 0 ) capacitor c=0.0451964f //x=22.205 //y=0.375
c70 ( 33 0 ) capacitor c=0.0190261f //x=21.1 //y=0.91
c71 ( 30 0 ) capacitor c=0.00141302f //x=22.34 //y=0.995
c72 ( 19 0 ) capacitor c=0.00692795f //x=23.31 //y=0.625
c73 ( 15 0 ) capacitor c=0.0155041f //x=23.225 //y=0.54
c74 ( 7 0 ) capacitor c=0.00689459f //x=22.34 //y=0.625
c75 ( 5 0 ) capacitor c=0.0247635f //x=22.255 //y=0.995
r76 (  19 34 ) resistor r=3.57586 //w=0.17 //l=0.125 //layer=li \
 //thickness=0.1 //x=23.31 //y=0.625 //x2=23.31 //y2=0.5
r77 (  19 34 ) resistor r=18.139 //w=0.187 //l=0.265 //layer=li \
 //thickness=0.1 //x=23.31 //y=0.625 //x2=23.31 //y2=0.89
r78 (  16 34 ) resistor r=3.57586 //w=0.17 //l=0.103078 //layer=li \
 //thickness=0.1 //x=22.425 //y=0.54 //x2=22.34 //y2=0.5
r79 (  16 34 ) resistor r=27.3797 //w=0.187 //l=0.4 //layer=li //thickness=0.1 \
 //x=22.425 //y=0.54 //x2=22.825 //y2=0.54
r80 (  15 34 ) resistor r=3.57586 //w=0.17 //l=0.103078 //layer=li \
 //thickness=0.1 //x=23.225 //y=0.54 //x2=23.31 //y2=0.5
r81 (  15 34 ) resistor r=27.3797 //w=0.187 //l=0.4 //layer=li //thickness=0.1 \
 //x=23.225 //y=0.54 //x2=22.825 //y2=0.54
r82 (  11 30 ) resistor r=5.4201 //w=0.17 //l=0.085 //layer=li //thickness=0.1 \
 //x=22.34 //y=1.08 //x2=22.34 //y2=0.995
r83 (  11 34 ) resistor r=10.2674 //w=0.187 //l=0.15 //layer=li \
 //thickness=0.1 //x=22.34 //y=1.08 //x2=22.34 //y2=1.23
r84 (  8 30 ) resistor r=5.4201 //w=0.17 //l=0.085 //layer=li //thickness=0.1 \
 //x=22.34 //y=0.91 //x2=22.34 //y2=0.995
r85 (  8 34 ) resistor r=1.36898 //w=0.187 //l=0.02 //layer=li //thickness=0.1 \
 //x=22.34 //y=0.91 //x2=22.34 //y2=0.89
r86 (  7 34 ) resistor r=3.57586 //w=0.17 //l=0.125 //layer=li //thickness=0.1 \
 //x=22.34 //y=0.625 //x2=22.34 //y2=0.5
r87 (  7 34 ) resistor r=18.139 //w=0.187 //l=0.265 //layer=li //thickness=0.1 \
 //x=22.34 //y=0.625 //x2=22.34 //y2=0.89
r88 (  6 33 ) resistor r=0.751729 //w=0.17 //l=0.085 //layer=li \
 //thickness=0.1 //x=21.375 //y=0.995 //x2=21.29 //y2=0.995
r89 (  5 30 ) resistor r=1.40859 //w=0.34 //l=0.085 //layer=li //thickness=0.1 \
 //x=22.255 //y=0.995 //x2=22.34 //y2=0.995
r90 (  5 6 ) resistor r=60.2353 //w=0.187 //l=0.88 //layer=li //thickness=0.1 \
 //x=22.255 //y=0.995 //x2=21.375 //y2=0.995
ends PM_DFFSNRNX1_PCELL\%noxref_14

subckt PM_DFFSNRNX1_PCELL\%noxref_15 ( 1 2 8 13 17 18 19 23 24 25 30 32 35 36 \
 38 39 44 )
c94 ( 44 0 ) capacitor c=0.0710579f //x=22.57 //y=4.7
c95 ( 39 0 ) capacitor c=0.0296417f //x=22.57 //y=1.915
c96 ( 38 0 ) capacitor c=0.0504963f //x=22.57 //y=2.08
c97 ( 36 0 ) capacitor c=0.0443175f //x=23.09 //y=1.26
c98 ( 35 0 ) capacitor c=0.0199703f //x=23.09 //y=0.915
c99 ( 32 0 ) capacitor c=0.0162526f //x=22.935 //y=1.415
c100 ( 30 0 ) capacitor c=0.0157807f //x=22.935 //y=0.76
c101 ( 25 0 ) capacitor c=0.0220935f //x=22.56 //y=1.57
c102 ( 24 0 ) capacitor c=0.0207489f //x=22.56 //y=1.26
c103 ( 23 0 ) capacitor c=0.0194091f //x=22.56 //y=0.915
c104 ( 19 0 ) capacitor c=0.161796f //x=22.75 //y=6.02
c105 ( 18 0 ) capacitor c=0.110208f //x=22.31 //y=6.02
c106 ( 13 0 ) capacitor c=7.74199e-19 //x=22.57 //y=4.7
c107 ( 8 0 ) capacitor c=0.00101179f //x=22.57 //y=2.08
c108 ( 2 0 ) capacitor c=0.0680163f //x=22.57 //y=4.57
c109 ( 1 0 ) capacitor c=0.00736027f //x=22.57 //y=2.195
r110 (  38 39 ) resistor r=52.7279 //w=0.214 //l=0.165 //layer=ply \
 //thickness=0.18 //x=22.57 //y=2.08 //x2=22.57 //y2=1.915
r111 (  36 46 ) resistor r=45.1352 //w=0.168 //l=0.173853 //layer=ply \
 //thickness=0.18 //x=23.09 //y=1.26 //x2=23.05 //y2=1.415
r112 (  35 45 ) resistor r=45.1352 //w=0.168 //l=0.173853 //layer=ply \
 //thickness=0.18 //x=23.09 //y=0.915 //x2=23.05 //y2=0.76
r113 (  35 36 ) resistor r=176.904 //w=0.094 //l=0.345 //layer=ply \
 //thickness=0.18 //x=23.09 //y=0.915 //x2=23.09 //y2=1.26
r114 (  33 42 ) resistor r=10.701 //w=0.21 //l=0.115 //layer=ply \
 //thickness=0.18 //x=22.715 //y=1.415 //x2=22.6 //y2=1.415
r115 (  32 46 ) resistor r=5.52526 //w=0.168 //l=0.115 //layer=ply \
 //thickness=0.18 //x=22.935 //y=1.415 //x2=23.05 //y2=1.415
r116 (  31 41 ) resistor r=5.52526 //w=0.168 //l=0.115 //layer=ply \
 //thickness=0.18 //x=22.715 //y=0.76 //x2=22.6 //y2=0.76
r117 (  30 45 ) resistor r=5.52526 //w=0.168 //l=0.115 //layer=ply \
 //thickness=0.18 //x=22.935 //y=0.76 //x2=23.05 //y2=0.76
r118 (  30 31 ) resistor r=112.809 //w=0.094 //l=0.22 //layer=ply \
 //thickness=0.18 //x=22.935 //y=0.76 //x2=22.715 //y2=0.76
r119 (  27 44 ) resistor r=37.236 //w=0.233 //l=0.249199 //layer=ply \
 //thickness=0.18 //x=22.75 //y=4.865 //x2=22.57 //y2=4.7
r120 (  25 42 ) resistor r=39.5823 //w=0.21 //l=0.173853 //layer=ply \
 //thickness=0.18 //x=22.56 //y=1.57 //x2=22.6 //y2=1.415
r121 (  25 39 ) resistor r=176.904 //w=0.094 //l=0.345 //layer=ply \
 //thickness=0.18 //x=22.56 //y=1.57 //x2=22.56 //y2=1.915
r122 (  24 42 ) resistor r=39.5823 //w=0.21 //l=0.173853 //layer=ply \
 //thickness=0.18 //x=22.56 //y=1.26 //x2=22.6 //y2=1.415
r123 (  23 41 ) resistor r=45.1352 //w=0.168 //l=0.173853 //layer=ply \
 //thickness=0.18 //x=22.56 //y=0.915 //x2=22.6 //y2=0.76
r124 (  23 24 ) resistor r=176.904 //w=0.094 //l=0.345 //layer=ply \
 //thickness=0.18 //x=22.56 //y=0.915 //x2=22.56 //y2=1.26
r125 (  20 44 ) resistor r=53.7854 //w=0.233 //l=0.332415 //layer=ply \
 //thickness=0.18 //x=22.31 //y=4.865 //x2=22.57 //y2=4.7
r126 (  19 27 ) resistor r=592.245 //w=0.094 //l=1.155 //layer=ply \
 //thickness=0.18 //x=22.75 //y=6.02 //x2=22.75 //y2=4.865
r127 (  18 20 ) resistor r=592.245 //w=0.094 //l=1.155 //layer=ply \
 //thickness=0.18 //x=22.31 //y=6.02 //x2=22.31 //y2=4.865
r128 (  17 32 ) resistor r=56.4043 //w=0.094 //l=0.11 //layer=ply \
 //thickness=0.18 //x=22.825 //y=1.415 //x2=22.935 //y2=1.415
r129 (  17 33 ) resistor r=56.4043 //w=0.094 //l=0.11 //layer=ply \
 //thickness=0.18 //x=22.825 //y=1.415 //x2=22.715 //y2=1.415
r130 (  13 44 ) resistor r=152 //w=0.17 //l=0.17 //layer=licon //count=1 \
 //x=22.57 //y=4.7 //x2=22.57 //y2=4.7
r131 (  8 38 ) resistor r=152 //w=0.17 //l=0.17 //layer=licon //count=1 \
 //x=22.57 //y=2.08 //x2=22.57 //y2=2.08
r132 (  6 13 ) resistor r=9.3 //w=0.17 //l=0.17 //layer=mcon //count=1 \
 //x=22.57 //y=4.7 //x2=22.57 //y2=4.7
r133 (  4 8 ) resistor r=9.3 //w=0.17 //l=0.17 //layer=mcon //count=1 \
 //x=22.57 //y=2.08 //x2=22.57 //y2=2.08
r134 (  2 6 ) resistor r=0.0801089 //w=0.224 //l=0.13 //layer=m1 \
 //thickness=0.36 //x=22.57 //y=4.57 //x2=22.57 //y2=4.7
r135 (  1 4 ) resistor r=0.0719237 //w=0.222 //l=0.115 //layer=m1 \
 //thickness=0.36 //x=22.57 //y=2.195 //x2=22.57 //y2=2.08
r136 (  1 2 ) resistor r=2.26622 //w=0.131 //l=2.375 //layer=m1 \
 //thickness=0.36 //x=22.57 //y=2.195 //x2=22.57 //y2=4.57
ends PM_DFFSNRNX1_PCELL\%noxref_15

subckt PM_DFFSNRNX1_PCELL\%noxref_16 ( 1 3 6 7 9 10 11 12 14 15 18 21 27 35 43 \
 55 57 58 59 )
c138 ( 55 0 ) capacitor c=0.00885916f //x=22.635 //y=0.915
c139 ( 43 0 ) capacitor c=0.0293124f //x=22.53 //y=5.38
c140 ( 35 0 ) capacitor c=0.029137f //x=21.65 //y=5.38
c141 ( 27 0 ) capacitor c=0.0278099f //x=20.77 //y=5.38
c142 ( 21 0 ) capacitor c=0.00134382f //x=22.53 //y=5.155
c143 ( 18 0 ) capacitor c=0.00812687f //x=21.65 //y=5.155
c144 ( 15 0 ) capacitor c=0.0115693f //x=20.772 //y=5.155
c145 ( 14 0 ) capacitor c=0.0917137f //x=23.31 //y=5.07
c146 ( 12 0 ) capacitor c=0.00647115f //x=22.91 //y=1.665
c147 ( 11 0 ) capacitor c=0.0161056f //x=23.225 //y=1.665
c148 ( 10 0 ) capacitor c=0.0167992f //x=22.825 //y=1.58
c149 ( 9 0 ) capacitor c=0.0113003f //x=22.825 //y=1.125
c150 ( 7 0 ) capacitor c=0.0270882f //x=23.225 //y=5.155
c151 ( 6 0 ) capacitor c=0.00933983f //x=22.53 //y=5.38
c152 ( 3 0 ) capacitor c=0.0204726f //x=22.415 //y=5.155
c153 ( 1 0 ) capacitor c=0.0158265f //x=21.53 //y=5.155
r154 (  43 59 ) resistor r=23.615 //w=0.187 //l=0.345 //layer=li \
 //thickness=0.1 //x=22.53 //y=5.38 //x2=22.53 //y2=5.725
r155 (  35 58 ) resistor r=23.615 //w=0.187 //l=0.345 //layer=li \
 //thickness=0.1 //x=21.65 //y=5.38 //x2=21.65 //y2=5.725
r156 (  27 57 ) resistor r=23.615 //w=0.187 //l=0.345 //layer=li \
 //thickness=0.1 //x=20.77 //y=5.38 //x2=20.77 //y2=5.725
r157 (  25 55 ) resistor r=9.3 //w=0.17 //l=0.17 //layer=mcon //count=1 \
 //x=22.825 //y=1.01 //x2=22.825 //y2=1.01
r158 (  23 43 ) resistor r=9.3 //w=0.17 //l=0.17 //layer=mcon //count=1 \
 //x=22.53 //y=5.38 //x2=22.53 //y2=5.38
r159 (  20 35 ) resistor r=9.3 //w=0.17 //l=0.17 //layer=mcon //count=1 \
 //x=21.65 //y=5.38 //x2=21.65 //y2=5.38
r160 (  18 20 ) resistor r=0.121228 //w=0.232 //l=0.225 //layer=m1 \
 //thickness=0.36 //x=21.65 //y=5.155 //x2=21.65 //y2=5.38
r161 (  17 27 ) resistor r=9.3 //w=0.17 //l=0.17 //layer=mcon //count=1 \
 //x=20.77 //y=5.38 //x2=20.77 //y2=5.38
r162 (  15 17 ) resistor r=0.129608 //w=0.217 //l=0.225 //layer=m1 \
 //thickness=0.36 //x=20.772 //y=5.155 //x2=20.772 //y2=5.38
r163 (  13 14 ) resistor r=3.16794 //w=0.131 //l=3.32 //layer=m1 \
 //thickness=0.36 //x=23.31 //y=1.75 //x2=23.31 //y2=5.07
r164 (  11 13 ) resistor r=0.0698411 //w=0.17 //l=0.120208 //layer=m1 \
 //thickness=0.36 //x=23.225 //y=1.665 //x2=23.31 //y2=1.75
r165 (  11 12 ) resistor r=0.300573 //w=0.131 //l=0.315 //layer=m1 \
 //thickness=0.36 //x=23.225 //y=1.665 //x2=22.91 //y2=1.665
r166 (  10 12 ) resistor r=0.0698411 //w=0.17 //l=0.120208 //layer=m1 \
 //thickness=0.36 //x=22.825 //y=1.58 //x2=22.91 //y2=1.665
r167 (  9 25 ) resistor r=0.0717383 //w=0.224 //l=0.115 //layer=m1 \
 //thickness=0.36 //x=22.825 //y=1.125 //x2=22.825 //y2=1.01
r168 (  9 10 ) resistor r=0.43416 //w=0.131 //l=0.455 //layer=m1 \
 //thickness=0.36 //x=22.825 //y=1.125 //x2=22.825 //y2=1.58
r169 (  8 21 ) resistor r=0.0675342 //w=0.23 //l=0.115 //layer=m1 \
 //thickness=0.36 //x=22.645 //y=5.155 //x2=22.53 //y2=5.155
r170 (  7 14 ) resistor r=0.0698411 //w=0.17 //l=0.120208 //layer=m1 \
 //thickness=0.36 //x=23.225 //y=5.155 //x2=23.31 //y2=5.07
r171 (  7 8 ) resistor r=0.553435 //w=0.131 //l=0.58 //layer=m1 \
 //thickness=0.36 //x=23.225 //y=5.155 //x2=22.645 //y2=5.155
r172 (  6 23 ) resistor r=0.00118313 //w=0.23 //layer=m1 //thickness=0.36 \
 //x=22.53 //y=5.38 //x2=22.53 //y2=5.38
r173 (  5 21 ) resistor r=0.002872 //w=0.34 //l=0.085 //layer=m1 \
 //thickness=0.36 //x=22.53 //y=5.24 //x2=22.53 //y2=5.155
r174 (  5 6 ) resistor r=0.091623 //w=0.191 //l=0.14 //layer=m1 \
 //thickness=0.36 //x=22.53 //y=5.24 //x2=22.53 //y2=5.38
r175 (  4 18 ) resistor r=0.0262263 //w=0.232 //l=0.12 //layer=m1 \
 //thickness=0.36 //x=21.77 //y=5.155 //x2=21.65 //y2=5.155
r176 (  3 21 ) resistor r=0.0675342 //w=0.23 //l=0.115 //layer=m1 \
 //thickness=0.36 //x=22.415 //y=5.155 //x2=22.53 //y2=5.155
r177 (  3 4 ) resistor r=0.615458 //w=0.131 //l=0.645 //layer=m1 \
 //thickness=0.36 //x=22.415 //y=5.155 //x2=21.77 //y2=5.155
r178 (  2 15 ) resistor r=0.0222262 //w=0.217 //l=0.118 //layer=m1 \
 //thickness=0.36 //x=20.89 //y=5.155 //x2=20.772 //y2=5.155
r179 (  1 18 ) resistor r=0.0262263 //w=0.232 //l=0.12 //layer=m1 \
 //thickness=0.36 //x=21.53 //y=5.155 //x2=21.65 //y2=5.155
r180 (  1 2 ) resistor r=0.610687 //w=0.131 //l=0.64 //layer=m1 \
 //thickness=0.36 //x=21.53 //y=5.155 //x2=20.89 //y2=5.155
ends PM_DFFSNRNX1_PCELL\%noxref_16

subckt PM_DFFSNRNX1_PCELL\%noxref_17 ( 1 6 7 18 19 30 31 42 43 54 55 66 73 76 \
 80 84 88 92 96 101 104 118 135 152 169 195 203 204 205 206 207 208 209 210 \
 211 212 213 )
c500 ( 213 0 ) capacitor c=0.00840423f //x=24.935 //y=0.875
c501 ( 212 0 ) capacitor c=0.00840423f //x=20.125 //y=0.875
c502 ( 211 0 ) capacitor c=0.00840423f //x=15.315 //y=0.875
c503 ( 210 0 ) capacitor c=0.00840423f //x=10.505 //y=0.875
c504 ( 209 0 ) capacitor c=0.00840423f //x=5.695 //y=0.875
c505 ( 208 0 ) capacitor c=0.00840423f //x=0.885 //y=0.875
c506 ( 207 0 ) capacitor c=0.113436f //x=24.05 //y=0
c507 ( 206 0 ) capacitor c=0.114051f //x=19.24 //y=0
c508 ( 205 0 ) capacitor c=0.109503f //x=14.43 //y=0
c509 ( 204 0 ) capacitor c=0.112466f //x=9.62 //y=0
c510 ( 203 0 ) capacitor c=0.109614f //x=4.81 //y=0
c511 ( 195 0 ) capacitor c=0.370836f //x=28.12 //y=0
c512 ( 169 0 ) capacitor c=0.176388f //x=23.88 //y=0
c513 ( 152 0 ) capacitor c=0.174276f //x=19.07 //y=0
c514 ( 135 0 ) capacitor c=0.174279f //x=14.26 //y=0
c515 ( 118 0 ) capacitor c=0.174279f //x=9.45 //y=0
c516 ( 104 0 ) capacitor c=0.178393f //x=0.74 //y=0
c517 ( 101 0 ) capacitor c=0.177126f //x=4.64 //y=0
c518 ( 98 0 ) capacitor c=0.00509083f //x=25.125 //y=0
c519 ( 96 0 ) capacitor c=0.013552f //x=25.125 //y=0.965
c520 ( 94 0 ) capacitor c=0.00509083f //x=20.315 //y=0
c521 ( 92 0 ) capacitor c=0.0140737f //x=20.315 //y=0.965
c522 ( 90 0 ) capacitor c=0.00509083f //x=15.505 //y=0
c523 ( 88 0 ) capacitor c=0.0139569f //x=15.505 //y=0.965
c524 ( 86 0 ) capacitor c=0.00509083f //x=10.695 //y=0
c525 ( 84 0 ) capacitor c=0.0139572f //x=10.695 //y=0.965
c526 ( 82 0 ) capacitor c=0.00509083f //x=5.885 //y=0
c527 ( 80 0 ) capacitor c=0.0140883f //x=5.885 //y=0.965
c528 ( 78 0 ) capacitor c=0.00509083f //x=1.075 //y=0
c529 ( 76 0 ) capacitor c=0.0171724f //x=1.075 //y=0.965
c530 ( 73 0 ) capacitor c=0.128992f //x=28.12 //y=0
c531 ( 66 0 ) capacitor c=0.0302305f //x=25.125 //y=0.835
c532 ( 55 0 ) capacitor c=0.150604f //x=25.04 //y=0
c533 ( 54 0 ) capacitor c=0.0302305f //x=20.315 //y=0.835
c534 ( 43 0 ) capacitor c=0.148828f //x=20.23 //y=0
c535 ( 42 0 ) capacitor c=0.0302305f //x=15.505 //y=0.835
c536 ( 31 0 ) capacitor c=0.148372f //x=15.42 //y=0
c537 ( 30 0 ) capacitor c=0.0302305f //x=10.695 //y=0.835
c538 ( 19 0 ) capacitor c=0.148791f //x=10.61 //y=0
c539 ( 18 0 ) capacitor c=0.0302305f //x=5.885 //y=0.835
c540 ( 7 0 ) capacitor c=0.148265f //x=5.8 //y=0
c541 ( 6 0 ) capacitor c=0.0302305f //x=1.075 //y=0.835
c542 ( 1 0 ) capacitor c=0.0533996f //x=0.99 //y=0
r543 (  193 195 ) resistor r=39.7983 //w=0.357 //l=1.11 //layer=li \
 //thickness=0.1 //x=27.01 //y=0 //x2=28.12 //y2=0
r544 (  191 193 ) resistor r=39.7983 //w=0.357 //l=1.11 //layer=li \
 //thickness=0.1 //x=25.9 //y=0 //x2=27.01 //y2=0
r545 (  189 191 ) resistor r=39.7983 //w=0.357 //l=1.11 //layer=li \
 //thickness=0.1 //x=24.79 //y=0 //x2=25.9 //y2=0
r546 (  187 207 ) resistor r=5.4201 //w=0.34 //l=0.17 //layer=li \
 //thickness=0.1 //x=24.22 //y=0 //x2=24.05 //y2=0
r547 (  187 189 ) resistor r=20.437 //w=0.357 //l=0.57 //layer=li \
 //thickness=0.1 //x=24.22 //y=0 //x2=24.79 //y2=0
r548 (  176 178 ) resistor r=39.7983 //w=0.357 //l=1.11 //layer=li \
 //thickness=0.1 //x=22.2 //y=0 //x2=23.31 //y2=0
r549 (  174 176 ) resistor r=39.7983 //w=0.357 //l=1.11 //layer=li \
 //thickness=0.1 //x=21.09 //y=0 //x2=22.2 //y2=0
r550 (  172 174 ) resistor r=39.7983 //w=0.357 //l=1.11 //layer=li \
 //thickness=0.1 //x=19.98 //y=0 //x2=21.09 //y2=0
r551 (  170 206 ) resistor r=5.4201 //w=0.34 //l=0.17 //layer=li \
 //thickness=0.1 //x=19.41 //y=0 //x2=19.24 //y2=0
r552 (  170 172 ) resistor r=20.437 //w=0.357 //l=0.57 //layer=li \
 //thickness=0.1 //x=19.41 //y=0 //x2=19.98 //y2=0
r553 (  169 207 ) resistor r=5.4201 //w=0.34 //l=0.17 //layer=li \
 //thickness=0.1 //x=23.88 //y=0 //x2=24.05 //y2=0
r554 (  169 178 ) resistor r=20.437 //w=0.357 //l=0.57 //layer=li \
 //thickness=0.1 //x=23.88 //y=0 //x2=23.31 //y2=0
r555 (  159 161 ) resistor r=39.7983 //w=0.357 //l=1.11 //layer=li \
 //thickness=0.1 //x=17.39 //y=0 //x2=18.5 //y2=0
r556 (  157 159 ) resistor r=39.7983 //w=0.357 //l=1.11 //layer=li \
 //thickness=0.1 //x=16.28 //y=0 //x2=17.39 //y2=0
r557 (  155 157 ) resistor r=39.7983 //w=0.357 //l=1.11 //layer=li \
 //thickness=0.1 //x=15.17 //y=0 //x2=16.28 //y2=0
r558 (  153 205 ) resistor r=5.4201 //w=0.34 //l=0.17 //layer=li \
 //thickness=0.1 //x=14.6 //y=0 //x2=14.43 //y2=0
r559 (  153 155 ) resistor r=20.437 //w=0.357 //l=0.57 //layer=li \
 //thickness=0.1 //x=14.6 //y=0 //x2=15.17 //y2=0
r560 (  152 206 ) resistor r=5.4201 //w=0.34 //l=0.17 //layer=li \
 //thickness=0.1 //x=19.07 //y=0 //x2=19.24 //y2=0
r561 (  152 161 ) resistor r=20.437 //w=0.357 //l=0.57 //layer=li \
 //thickness=0.1 //x=19.07 //y=0 //x2=18.5 //y2=0
r562 (  142 144 ) resistor r=39.7983 //w=0.357 //l=1.11 //layer=li \
 //thickness=0.1 //x=12.58 //y=0 //x2=13.69 //y2=0
r563 (  140 142 ) resistor r=39.7983 //w=0.357 //l=1.11 //layer=li \
 //thickness=0.1 //x=11.47 //y=0 //x2=12.58 //y2=0
r564 (  138 140 ) resistor r=39.7983 //w=0.357 //l=1.11 //layer=li \
 //thickness=0.1 //x=10.36 //y=0 //x2=11.47 //y2=0
r565 (  136 204 ) resistor r=5.4201 //w=0.34 //l=0.17 //layer=li \
 //thickness=0.1 //x=9.79 //y=0 //x2=9.62 //y2=0
r566 (  136 138 ) resistor r=20.437 //w=0.357 //l=0.57 //layer=li \
 //thickness=0.1 //x=9.79 //y=0 //x2=10.36 //y2=0
r567 (  135 205 ) resistor r=5.4201 //w=0.34 //l=0.17 //layer=li \
 //thickness=0.1 //x=14.26 //y=0 //x2=14.43 //y2=0
r568 (  135 144 ) resistor r=20.437 //w=0.357 //l=0.57 //layer=li \
 //thickness=0.1 //x=14.26 //y=0 //x2=13.69 //y2=0
r569 (  125 127 ) resistor r=39.7983 //w=0.357 //l=1.11 //layer=li \
 //thickness=0.1 //x=7.77 //y=0 //x2=8.88 //y2=0
r570 (  123 125 ) resistor r=39.7983 //w=0.357 //l=1.11 //layer=li \
 //thickness=0.1 //x=6.66 //y=0 //x2=7.77 //y2=0
r571 (  121 123 ) resistor r=39.7983 //w=0.357 //l=1.11 //layer=li \
 //thickness=0.1 //x=5.55 //y=0 //x2=6.66 //y2=0
r572 (  119 203 ) resistor r=5.4201 //w=0.34 //l=0.17 //layer=li \
 //thickness=0.1 //x=4.98 //y=0 //x2=4.81 //y2=0
r573 (  119 121 ) resistor r=20.437 //w=0.357 //l=0.57 //layer=li \
 //thickness=0.1 //x=4.98 //y=0 //x2=5.55 //y2=0
r574 (  118 204 ) resistor r=5.4201 //w=0.34 //l=0.17 //layer=li \
 //thickness=0.1 //x=9.45 //y=0 //x2=9.62 //y2=0
r575 (  118 127 ) resistor r=20.437 //w=0.357 //l=0.57 //layer=li \
 //thickness=0.1 //x=9.45 //y=0 //x2=8.88 //y2=0
r576 (  108 110 ) resistor r=39.7983 //w=0.357 //l=1.11 //layer=li \
 //thickness=0.1 //x=2.96 //y=0 //x2=4.07 //y2=0
r577 (  106 108 ) resistor r=39.7983 //w=0.357 //l=1.11 //layer=li \
 //thickness=0.1 //x=1.85 //y=0 //x2=2.96 //y2=0
r578 (  104 106 ) resistor r=39.7983 //w=0.357 //l=1.11 //layer=li \
 //thickness=0.1 //x=0.74 //y=0 //x2=1.85 //y2=0
r579 (  101 203 ) resistor r=5.4201 //w=0.34 //l=0.17 //layer=li \
 //thickness=0.1 //x=4.64 //y=0 //x2=4.81 //y2=0
r580 (  101 110 ) resistor r=20.437 //w=0.357 //l=0.57 //layer=li \
 //thickness=0.1 //x=4.64 //y=0 //x2=4.07 //y2=0
r581 (  96 213 ) resistor r=9.3 //w=0.17 //l=0.17 //layer=mcon //count=1 \
 //x=25.125 //y=0.965 //x2=25.125 //y2=0.965
r582 (  92 212 ) resistor r=9.3 //w=0.17 //l=0.17 //layer=mcon //count=1 \
 //x=20.315 //y=0.965 //x2=20.315 //y2=0.965
r583 (  88 211 ) resistor r=9.3 //w=0.17 //l=0.17 //layer=mcon //count=1 \
 //x=15.505 //y=0.965 //x2=15.505 //y2=0.965
r584 (  84 210 ) resistor r=9.3 //w=0.17 //l=0.17 //layer=mcon //count=1 \
 //x=10.695 //y=0.965 //x2=10.695 //y2=0.965
r585 (  80 209 ) resistor r=9.3 //w=0.17 //l=0.17 //layer=mcon //count=1 \
 //x=5.885 //y=0.965 //x2=5.885 //y2=0.965
r586 (  76 208 ) resistor r=9.3 //w=0.17 //l=0.17 //layer=mcon //count=1 \
 //x=1.075 //y=0.965 //x2=1.075 //y2=0.965
r587 (  73 195 ) resistor r=3.1 //w=0.17 //l=0.51 //layer=mcon //count=3 \
 //x=28.12 //y=0 //x2=28.12 //y2=0
r588 (  71 193 ) resistor r=3.1 //w=0.17 //l=0.51 //layer=mcon //count=3 \
 //x=27.01 //y=0 //x2=27.01 //y2=0
r589 (  71 73 ) resistor r=0.460963 //w=0.301 //l=1.11 //layer=m1 \
 //thickness=0.36 //x=27.01 //y=0 //x2=28.12 //y2=0
r590 (  69 191 ) resistor r=3.1 //w=0.17 //l=0.51 //layer=mcon //count=3 \
 //x=25.9 //y=0 //x2=25.9 //y2=0
r591 (  69 71 ) resistor r=0.460963 //w=0.301 //l=1.11 //layer=m1 \
 //thickness=0.36 //x=25.9 //y=0 //x2=27.01 //y2=0
r592 (  67 98 ) resistor r=0.0287885 //w=0.34 //l=0.085 //layer=m1 \
 //thickness=0.36 //x=25.21 //y=0 //x2=25.125 //y2=0
r593 (  67 69 ) resistor r=0.286545 //w=0.301 //l=0.69 //layer=m1 \
 //thickness=0.36 //x=25.21 //y=0 //x2=25.9 //y2=0
r594 (  66 96 ) resistor r=0.0942778 //w=0.221 //l=0.13 //layer=m1 \
 //thickness=0.36 //x=25.125 //y=0.835 //x2=25.125 //y2=0.965
r595 (  65 98 ) resistor r=0.0401957 //w=0.68 //l=0.17 //layer=m1 \
 //thickness=0.36 //x=25.125 //y=0.17 //x2=25.125 //y2=0
r596 (  65 66 ) resistor r=0.634542 //w=0.131 //l=0.665 //layer=m1 \
 //thickness=0.36 //x=25.125 //y=0.17 //x2=25.125 //y2=0.835
r597 (  64 189 ) resistor r=3.1 //w=0.17 //l=0.51 //layer=mcon //count=3 \
 //x=24.79 //y=0 //x2=24.79 //y2=0
r598 (  62 178 ) resistor r=3.1 //w=0.17 //l=0.51 //layer=mcon //count=3 \
 //x=23.31 //y=0 //x2=23.31 //y2=0
r599 (  62 64 ) resistor r=0.614618 //w=0.301 //l=1.48 //layer=m1 \
 //thickness=0.36 //x=23.31 //y=0 //x2=24.79 //y2=0
r600 (  60 176 ) resistor r=3.1 //w=0.17 //l=0.51 //layer=mcon //count=3 \
 //x=22.2 //y=0 //x2=22.2 //y2=0
r601 (  60 62 ) resistor r=0.460963 //w=0.301 //l=1.11 //layer=m1 \
 //thickness=0.36 //x=22.2 //y=0 //x2=23.31 //y2=0
r602 (  58 174 ) resistor r=3.1 //w=0.17 //l=0.51 //layer=mcon //count=3 \
 //x=21.09 //y=0 //x2=21.09 //y2=0
r603 (  58 60 ) resistor r=0.460963 //w=0.301 //l=1.11 //layer=m1 \
 //thickness=0.36 //x=21.09 //y=0 //x2=22.2 //y2=0
r604 (  56 94 ) resistor r=0.0287885 //w=0.34 //l=0.085 //layer=m1 \
 //thickness=0.36 //x=20.4 //y=0 //x2=20.315 //y2=0
r605 (  56 58 ) resistor r=0.286545 //w=0.301 //l=0.69 //layer=m1 \
 //thickness=0.36 //x=20.4 //y=0 //x2=21.09 //y2=0
r606 (  55 98 ) resistor r=0.0287885 //w=0.34 //l=0.085 //layer=m1 \
 //thickness=0.36 //x=25.04 //y=0 //x2=25.125 //y2=0
r607 (  55 64 ) resistor r=0.103821 //w=0.301 //l=0.25 //layer=m1 \
 //thickness=0.36 //x=25.04 //y=0 //x2=24.79 //y2=0
r608 (  54 92 ) resistor r=0.0942778 //w=0.221 //l=0.13 //layer=m1 \
 //thickness=0.36 //x=20.315 //y=0.835 //x2=20.315 //y2=0.965
r609 (  53 94 ) resistor r=0.0401957 //w=0.68 //l=0.17 //layer=m1 \
 //thickness=0.36 //x=20.315 //y=0.17 //x2=20.315 //y2=0
r610 (  53 54 ) resistor r=0.634542 //w=0.131 //l=0.665 //layer=m1 \
 //thickness=0.36 //x=20.315 //y=0.17 //x2=20.315 //y2=0.835
r611 (  52 172 ) resistor r=3.1 //w=0.17 //l=0.51 //layer=mcon //count=3 \
 //x=19.98 //y=0 //x2=19.98 //y2=0
r612 (  50 161 ) resistor r=3.1 //w=0.17 //l=0.51 //layer=mcon //count=3 \
 //x=18.5 //y=0 //x2=18.5 //y2=0
r613 (  50 52 ) resistor r=0.614618 //w=0.301 //l=1.48 //layer=m1 \
 //thickness=0.36 //x=18.5 //y=0 //x2=19.98 //y2=0
r614 (  48 159 ) resistor r=3.1 //w=0.17 //l=0.51 //layer=mcon //count=3 \
 //x=17.39 //y=0 //x2=17.39 //y2=0
r615 (  48 50 ) resistor r=0.460963 //w=0.301 //l=1.11 //layer=m1 \
 //thickness=0.36 //x=17.39 //y=0 //x2=18.5 //y2=0
r616 (  46 157 ) resistor r=3.1 //w=0.17 //l=0.51 //layer=mcon //count=3 \
 //x=16.28 //y=0 //x2=16.28 //y2=0
r617 (  46 48 ) resistor r=0.460963 //w=0.301 //l=1.11 //layer=m1 \
 //thickness=0.36 //x=16.28 //y=0 //x2=17.39 //y2=0
r618 (  44 90 ) resistor r=0.0287885 //w=0.34 //l=0.085 //layer=m1 \
 //thickness=0.36 //x=15.59 //y=0 //x2=15.505 //y2=0
r619 (  44 46 ) resistor r=0.286545 //w=0.301 //l=0.69 //layer=m1 \
 //thickness=0.36 //x=15.59 //y=0 //x2=16.28 //y2=0
r620 (  43 94 ) resistor r=0.0287885 //w=0.34 //l=0.085 //layer=m1 \
 //thickness=0.36 //x=20.23 //y=0 //x2=20.315 //y2=0
r621 (  43 52 ) resistor r=0.103821 //w=0.301 //l=0.25 //layer=m1 \
 //thickness=0.36 //x=20.23 //y=0 //x2=19.98 //y2=0
r622 (  42 88 ) resistor r=0.0942778 //w=0.221 //l=0.13 //layer=m1 \
 //thickness=0.36 //x=15.505 //y=0.835 //x2=15.505 //y2=0.965
r623 (  41 90 ) resistor r=0.0401957 //w=0.68 //l=0.17 //layer=m1 \
 //thickness=0.36 //x=15.505 //y=0.17 //x2=15.505 //y2=0
r624 (  41 42 ) resistor r=0.634542 //w=0.131 //l=0.665 //layer=m1 \
 //thickness=0.36 //x=15.505 //y=0.17 //x2=15.505 //y2=0.835
r625 (  40 155 ) resistor r=3.1 //w=0.17 //l=0.51 //layer=mcon //count=3 \
 //x=15.17 //y=0 //x2=15.17 //y2=0
r626 (  38 144 ) resistor r=3.1 //w=0.17 //l=0.51 //layer=mcon //count=3 \
 //x=13.69 //y=0 //x2=13.69 //y2=0
r627 (  38 40 ) resistor r=0.614618 //w=0.301 //l=1.48 //layer=m1 \
 //thickness=0.36 //x=13.69 //y=0 //x2=15.17 //y2=0
r628 (  36 142 ) resistor r=3.1 //w=0.17 //l=0.51 //layer=mcon //count=3 \
 //x=12.58 //y=0 //x2=12.58 //y2=0
r629 (  36 38 ) resistor r=0.460963 //w=0.301 //l=1.11 //layer=m1 \
 //thickness=0.36 //x=12.58 //y=0 //x2=13.69 //y2=0
r630 (  34 140 ) resistor r=3.1 //w=0.17 //l=0.51 //layer=mcon //count=3 \
 //x=11.47 //y=0 //x2=11.47 //y2=0
r631 (  34 36 ) resistor r=0.460963 //w=0.301 //l=1.11 //layer=m1 \
 //thickness=0.36 //x=11.47 //y=0 //x2=12.58 //y2=0
r632 (  32 86 ) resistor r=0.0287885 //w=0.34 //l=0.085 //layer=m1 \
 //thickness=0.36 //x=10.78 //y=0 //x2=10.695 //y2=0
r633 (  32 34 ) resistor r=0.286545 //w=0.301 //l=0.69 //layer=m1 \
 //thickness=0.36 //x=10.78 //y=0 //x2=11.47 //y2=0
r634 (  31 90 ) resistor r=0.0287885 //w=0.34 //l=0.085 //layer=m1 \
 //thickness=0.36 //x=15.42 //y=0 //x2=15.505 //y2=0
r635 (  31 40 ) resistor r=0.103821 //w=0.301 //l=0.25 //layer=m1 \
 //thickness=0.36 //x=15.42 //y=0 //x2=15.17 //y2=0
r636 (  30 84 ) resistor r=0.0942778 //w=0.221 //l=0.13 //layer=m1 \
 //thickness=0.36 //x=10.695 //y=0.835 //x2=10.695 //y2=0.965
r637 (  29 86 ) resistor r=0.0401957 //w=0.68 //l=0.17 //layer=m1 \
 //thickness=0.36 //x=10.695 //y=0.17 //x2=10.695 //y2=0
r638 (  29 30 ) resistor r=0.634542 //w=0.131 //l=0.665 //layer=m1 \
 //thickness=0.36 //x=10.695 //y=0.17 //x2=10.695 //y2=0.835
r639 (  28 138 ) resistor r=3.1 //w=0.17 //l=0.51 //layer=mcon //count=3 \
 //x=10.36 //y=0 //x2=10.36 //y2=0
r640 (  26 127 ) resistor r=3.1 //w=0.17 //l=0.51 //layer=mcon //count=3 \
 //x=8.88 //y=0 //x2=8.88 //y2=0
r641 (  26 28 ) resistor r=0.614618 //w=0.301 //l=1.48 //layer=m1 \
 //thickness=0.36 //x=8.88 //y=0 //x2=10.36 //y2=0
r642 (  24 125 ) resistor r=3.1 //w=0.17 //l=0.51 //layer=mcon //count=3 \
 //x=7.77 //y=0 //x2=7.77 //y2=0
r643 (  24 26 ) resistor r=0.460963 //w=0.301 //l=1.11 //layer=m1 \
 //thickness=0.36 //x=7.77 //y=0 //x2=8.88 //y2=0
r644 (  22 123 ) resistor r=3.1 //w=0.17 //l=0.51 //layer=mcon //count=3 \
 //x=6.66 //y=0 //x2=6.66 //y2=0
r645 (  22 24 ) resistor r=0.460963 //w=0.301 //l=1.11 //layer=m1 \
 //thickness=0.36 //x=6.66 //y=0 //x2=7.77 //y2=0
r646 (  20 82 ) resistor r=0.0287885 //w=0.34 //l=0.085 //layer=m1 \
 //thickness=0.36 //x=5.97 //y=0 //x2=5.885 //y2=0
r647 (  20 22 ) resistor r=0.286545 //w=0.301 //l=0.69 //layer=m1 \
 //thickness=0.36 //x=5.97 //y=0 //x2=6.66 //y2=0
r648 (  19 86 ) resistor r=0.0287885 //w=0.34 //l=0.085 //layer=m1 \
 //thickness=0.36 //x=10.61 //y=0 //x2=10.695 //y2=0
r649 (  19 28 ) resistor r=0.103821 //w=0.301 //l=0.25 //layer=m1 \
 //thickness=0.36 //x=10.61 //y=0 //x2=10.36 //y2=0
r650 (  18 80 ) resistor r=0.0942778 //w=0.221 //l=0.13 //layer=m1 \
 //thickness=0.36 //x=5.885 //y=0.835 //x2=5.885 //y2=0.965
r651 (  17 82 ) resistor r=0.0401957 //w=0.68 //l=0.17 //layer=m1 \
 //thickness=0.36 //x=5.885 //y=0.17 //x2=5.885 //y2=0
r652 (  17 18 ) resistor r=0.634542 //w=0.131 //l=0.665 //layer=m1 \
 //thickness=0.36 //x=5.885 //y=0.17 //x2=5.885 //y2=0.835
r653 (  16 121 ) resistor r=3.1 //w=0.17 //l=0.51 //layer=mcon //count=3 \
 //x=5.55 //y=0 //x2=5.55 //y2=0
r654 (  14 110 ) resistor r=3.1 //w=0.17 //l=0.51 //layer=mcon //count=3 \
 //x=4.07 //y=0 //x2=4.07 //y2=0
r655 (  14 16 ) resistor r=0.614618 //w=0.301 //l=1.48 //layer=m1 \
 //thickness=0.36 //x=4.07 //y=0 //x2=5.55 //y2=0
r656 (  12 108 ) resistor r=3.1 //w=0.17 //l=0.51 //layer=mcon //count=3 \
 //x=2.96 //y=0 //x2=2.96 //y2=0
r657 (  12 14 ) resistor r=0.460963 //w=0.301 //l=1.11 //layer=m1 \
 //thickness=0.36 //x=2.96 //y=0 //x2=4.07 //y2=0
r658 (  10 106 ) resistor r=3.1 //w=0.17 //l=0.51 //layer=mcon //count=3 \
 //x=1.85 //y=0 //x2=1.85 //y2=0
r659 (  10 12 ) resistor r=0.460963 //w=0.301 //l=1.11 //layer=m1 \
 //thickness=0.36 //x=1.85 //y=0 //x2=2.96 //y2=0
r660 (  8 78 ) resistor r=0.0287885 //w=0.34 //l=0.085 //layer=m1 \
 //thickness=0.36 //x=1.16 //y=0 //x2=1.075 //y2=0
r661 (  8 10 ) resistor r=0.286545 //w=0.301 //l=0.69 //layer=m1 \
 //thickness=0.36 //x=1.16 //y=0 //x2=1.85 //y2=0
r662 (  7 82 ) resistor r=0.0287885 //w=0.34 //l=0.085 //layer=m1 \
 //thickness=0.36 //x=5.8 //y=0 //x2=5.885 //y2=0
r663 (  7 16 ) resistor r=0.103821 //w=0.301 //l=0.25 //layer=m1 \
 //thickness=0.36 //x=5.8 //y=0 //x2=5.55 //y2=0
r664 (  6 76 ) resistor r=0.0942778 //w=0.221 //l=0.13 //layer=m1 \
 //thickness=0.36 //x=1.075 //y=0.835 //x2=1.075 //y2=0.965
r665 (  5 78 ) resistor r=0.0401957 //w=0.68 //l=0.17 //layer=m1 \
 //thickness=0.36 //x=1.075 //y=0.17 //x2=1.075 //y2=0
r666 (  5 6 ) resistor r=0.634542 //w=0.131 //l=0.665 //layer=m1 \
 //thickness=0.36 //x=1.075 //y=0.17 //x2=1.075 //y2=0.835
r667 (  3 104 ) resistor r=3.1 //w=0.17 //l=0.51 //layer=mcon //count=3 \
 //x=0.74 //y=0 //x2=0.74 //y2=0
r668 (  1 78 ) resistor r=0.0287885 //w=0.34 //l=0.085 //layer=m1 \
 //thickness=0.36 //x=0.99 //y=0 //x2=1.075 //y2=0
r669 (  1 3 ) resistor r=0.103821 //w=0.301 //l=0.25 //layer=m1 \
 //thickness=0.36 //x=0.99 //y=0 //x2=0.74 //y2=0
ends PM_DFFSNRNX1_PCELL\%noxref_17

subckt PM_DFFSNRNX1_PCELL\%noxref_18 ( 1 2 8 13 17 18 19 20 21 22 23 24 26 32 \
 33 34 35 )
c99 ( 35 0 ) capacitor c=0.0612936f //x=25.435 //y=4.79
c100 ( 34 0 ) capacitor c=0.0376642f //x=25.725 //y=4.79
c101 ( 33 0 ) capacitor c=0.0346489f //x=25.39 //y=1.22
c102 ( 32 0 ) capacitor c=0.018692f //x=25.39 //y=0.875
c103 ( 26 0 ) capacitor c=0.0137077f //x=25.235 //y=1.375
c104 ( 24 0 ) capacitor c=0.0158585f //x=25.235 //y=0.72
c105 ( 23 0 ) capacitor c=0.103534f //x=24.86 //y=1.915
c106 ( 22 0 ) capacitor c=0.0229444f //x=24.86 //y=1.53
c107 ( 21 0 ) capacitor c=0.0234359f //x=24.86 //y=1.22
c108 ( 20 0 ) capacitor c=0.019815f //x=24.86 //y=0.875
c109 ( 19 0 ) capacitor c=0.110208f //x=25.8 //y=6.02
c110 ( 18 0 ) capacitor c=0.158957f //x=25.36 //y=6.02
c111 ( 13 0 ) capacitor c=0.0014751f //x=25.16 //y=4.7
c112 ( 8 0 ) capacitor c=0.0012618f //x=25.16 //y=2.08
c113 ( 2 0 ) capacitor c=0.0870467f //x=25.16 //y=4.575
c114 ( 1 0 ) capacitor c=0.00681304f //x=25.16 //y=2.195
r115 (  34 36 ) resistor r=26.9307 //w=0.15 //l=0.106066 //layer=ply \
 //thickness=0.18 //x=25.725 //y=4.79 //x2=25.8 //y2=4.865
r116 (  34 35 ) resistor r=148.702 //w=0.094 //l=0.29 //layer=ply \
 //thickness=0.18 //x=25.725 //y=4.79 //x2=25.435 //y2=4.79
r117 (  33 46 ) resistor r=45.1352 //w=0.168 //l=0.173853 //layer=ply \
 //thickness=0.18 //x=25.39 //y=1.22 //x2=25.35 //y2=1.375
r118 (  32 45 ) resistor r=45.1352 //w=0.168 //l=0.173853 //layer=ply \
 //thickness=0.18 //x=25.39 //y=0.875 //x2=25.35 //y2=0.72
r119 (  32 33 ) resistor r=176.904 //w=0.094 //l=0.345 //layer=ply \
 //thickness=0.18 //x=25.39 //y=0.875 //x2=25.39 //y2=1.22
r120 (  29 35 ) resistor r=22.7971 //w=0.269 //l=0.106066 //layer=ply \
 //thickness=0.18 //x=25.36 //y=4.865 //x2=25.435 //y2=4.79
r121 (  29 44 ) resistor r=35.8364 //w=0.269 //l=0.270185 //layer=ply \
 //thickness=0.18 //x=25.36 //y=4.865 //x2=25.16 //y2=4.7
r122 (  27 40 ) resistor r=10.701 //w=0.21 //l=0.115 //layer=ply \
 //thickness=0.18 //x=25.015 //y=1.375 //x2=24.9 //y2=1.375
r123 (  26 46 ) resistor r=5.52526 //w=0.168 //l=0.115 //layer=ply \
 //thickness=0.18 //x=25.235 //y=1.375 //x2=25.35 //y2=1.375
r124 (  25 39 ) resistor r=5.52526 //w=0.168 //l=0.115 //layer=ply \
 //thickness=0.18 //x=25.015 //y=0.72 //x2=24.9 //y2=0.72
r125 (  24 45 ) resistor r=5.52526 //w=0.168 //l=0.115 //layer=ply \
 //thickness=0.18 //x=25.235 //y=0.72 //x2=25.35 //y2=0.72
r126 (  24 25 ) resistor r=112.809 //w=0.094 //l=0.22 //layer=ply \
 //thickness=0.18 //x=25.235 //y=0.72 //x2=25.015 //y2=0.72
r127 (  23 42 ) resistor r=58.7805 //w=0.246 //l=0.373497 //layer=ply \
 //thickness=0.18 //x=24.86 //y=1.915 //x2=25.16 //y2=2.08
r128 (  22 40 ) resistor r=39.5823 //w=0.21 //l=0.173853 //layer=ply \
 //thickness=0.18 //x=24.86 //y=1.53 //x2=24.9 //y2=1.375
r129 (  22 23 ) resistor r=197.415 //w=0.094 //l=0.385 //layer=ply \
 //thickness=0.18 //x=24.86 //y=1.53 //x2=24.86 //y2=1.915
r130 (  21 40 ) resistor r=39.5823 //w=0.21 //l=0.173853 //layer=ply \
 //thickness=0.18 //x=24.86 //y=1.22 //x2=24.9 //y2=1.375
r131 (  20 39 ) resistor r=45.1352 //w=0.168 //l=0.173853 //layer=ply \
 //thickness=0.18 //x=24.86 //y=0.875 //x2=24.9 //y2=0.72
r132 (  20 21 ) resistor r=176.904 //w=0.094 //l=0.345 //layer=ply \
 //thickness=0.18 //x=24.86 //y=0.875 //x2=24.86 //y2=1.22
r133 (  19 36 ) resistor r=592.245 //w=0.094 //l=1.155 //layer=ply \
 //thickness=0.18 //x=25.8 //y=6.02 //x2=25.8 //y2=4.865
r134 (  18 29 ) resistor r=592.245 //w=0.094 //l=1.155 //layer=ply \
 //thickness=0.18 //x=25.36 //y=6.02 //x2=25.36 //y2=4.865
r135 (  17 26 ) resistor r=56.4043 //w=0.094 //l=0.11 //layer=ply \
 //thickness=0.18 //x=25.125 //y=1.375 //x2=25.235 //y2=1.375
r136 (  17 27 ) resistor r=56.4043 //w=0.094 //l=0.11 //layer=ply \
 //thickness=0.18 //x=25.125 //y=1.375 //x2=25.015 //y2=1.375
r137 (  13 44 ) resistor r=152 //w=0.17 //l=0.17 //layer=licon //count=1 \
 //x=25.16 //y=4.7 //x2=25.16 //y2=4.7
r138 (  8 42 ) resistor r=152 //w=0.17 //l=0.17 //layer=licon //count=1 \
 //x=25.16 //y=2.08 //x2=25.16 //y2=2.08
r139 (  6 13 ) resistor r=9.3 //w=0.17 //l=0.17 //layer=mcon //count=1 \
 //x=25.16 //y=4.7 //x2=25.16 //y2=4.7
r140 (  4 8 ) resistor r=9.3 //w=0.17 //l=0.17 //layer=mcon //count=1 \
 //x=25.16 //y=2.08 //x2=25.16 //y2=2.08
r141 (  2 6 ) resistor r=0.0760407 //w=0.238 //l=0.125 //layer=m1 \
 //thickness=0.36 //x=25.16 //y=4.575 //x2=25.16 //y2=4.7
r142 (  1 4 ) resistor r=0.0719237 //w=0.222 //l=0.115 //layer=m1 \
 //thickness=0.36 //x=25.16 //y=2.195 //x2=25.16 //y2=2.08
r143 (  1 2 ) resistor r=2.27099 //w=0.131 //l=2.38 //layer=m1 \
 //thickness=0.36 //x=25.16 //y=2.195 //x2=25.16 //y2=4.575
ends PM_DFFSNRNX1_PCELL\%noxref_18

subckt PM_DFFSNRNX1_PCELL\%noxref_19 ( 5 7 15 19 30 33 34 )
c63 ( 34 0 ) capacitor c=0.0462219f //x=27.015 //y=0.375
c64 ( 33 0 ) capacitor c=0.018598f //x=25.91 //y=0.91
c65 ( 30 0 ) capacitor c=0.00141302f //x=27.15 //y=0.995
c66 ( 19 0 ) capacitor c=0.00745448f //x=28.12 //y=0.625
c67 ( 15 0 ) capacitor c=0.015487f //x=28.035 //y=0.54
c68 ( 7 0 ) capacitor c=0.00681713f //x=27.15 //y=0.625
c69 ( 5 0 ) capacitor c=0.0288646f //x=27.065 //y=0.995
r70 (  19 34 ) resistor r=3.57586 //w=0.17 //l=0.125 //layer=li \
 //thickness=0.1 //x=28.12 //y=0.625 //x2=28.12 //y2=0.5
r71 (  19 34 ) resistor r=18.139 //w=0.187 //l=0.265 //layer=li \
 //thickness=0.1 //x=28.12 //y=0.625 //x2=28.12 //y2=0.89
r72 (  16 34 ) resistor r=3.57586 //w=0.17 //l=0.103078 //layer=li \
 //thickness=0.1 //x=27.235 //y=0.54 //x2=27.15 //y2=0.5
r73 (  16 34 ) resistor r=27.3797 //w=0.187 //l=0.4 //layer=li //thickness=0.1 \
 //x=27.235 //y=0.54 //x2=27.635 //y2=0.54
r74 (  15 34 ) resistor r=3.57586 //w=0.17 //l=0.103078 //layer=li \
 //thickness=0.1 //x=28.035 //y=0.54 //x2=28.12 //y2=0.5
r75 (  15 34 ) resistor r=27.3797 //w=0.187 //l=0.4 //layer=li //thickness=0.1 \
 //x=28.035 //y=0.54 //x2=27.635 //y2=0.54
r76 (  11 30 ) resistor r=5.4201 //w=0.17 //l=0.085 //layer=li //thickness=0.1 \
 //x=27.15 //y=1.08 //x2=27.15 //y2=0.995
r77 (  11 34 ) resistor r=10.2674 //w=0.187 //l=0.15 //layer=li \
 //thickness=0.1 //x=27.15 //y=1.08 //x2=27.15 //y2=1.23
r78 (  8 30 ) resistor r=5.4201 //w=0.17 //l=0.085 //layer=li //thickness=0.1 \
 //x=27.15 //y=0.91 //x2=27.15 //y2=0.995
r79 (  8 34 ) resistor r=1.36898 //w=0.187 //l=0.02 //layer=li //thickness=0.1 \
 //x=27.15 //y=0.91 //x2=27.15 //y2=0.89
r80 (  7 34 ) resistor r=3.57586 //w=0.17 //l=0.125 //layer=li //thickness=0.1 \
 //x=27.15 //y=0.625 //x2=27.15 //y2=0.5
r81 (  7 34 ) resistor r=18.139 //w=0.187 //l=0.265 //layer=li //thickness=0.1 \
 //x=27.15 //y=0.625 //x2=27.15 //y2=0.89
r82 (  6 33 ) resistor r=0.751729 //w=0.17 //l=0.085 //layer=li \
 //thickness=0.1 //x=26.185 //y=0.995 //x2=26.1 //y2=0.995
r83 (  5 30 ) resistor r=1.40859 //w=0.34 //l=0.085 //layer=li //thickness=0.1 \
 //x=27.065 //y=0.995 //x2=27.15 //y2=0.995
r84 (  5 6 ) resistor r=60.2353 //w=0.187 //l=0.88 //layer=li //thickness=0.1 \
 //x=27.065 //y=0.995 //x2=26.185 //y2=0.995
ends PM_DFFSNRNX1_PCELL\%noxref_19

subckt PM_DFFSNRNX1_PCELL\%noxref_20 ( 1 3 6 7 9 10 11 12 14 15 18 21 27 35 43 \
 55 57 58 59 )
c129 ( 55 0 ) capacitor c=0.00885916f //x=27.445 //y=0.915
c130 ( 43 0 ) capacitor c=0.0293753f //x=27.34 //y=5.38
c131 ( 35 0 ) capacitor c=0.0292879f //x=26.46 //y=5.38
c132 ( 27 0 ) capacitor c=0.0278099f //x=25.58 //y=5.38
c133 ( 21 0 ) capacitor c=9.65912e-19 //x=27.34 //y=5.155
c134 ( 18 0 ) capacitor c=0.00802196f //x=26.46 //y=5.155
c135 ( 15 0 ) capacitor c=0.0115693f //x=25.582 //y=5.155
c136 ( 14 0 ) capacitor c=0.130884f //x=28.12 //y=5.07
c137 ( 12 0 ) capacitor c=0.00722566f //x=27.72 //y=1.665
c138 ( 11 0 ) capacitor c=0.018414f //x=28.035 //y=1.665
c139 ( 10 0 ) capacitor c=0.0167992f //x=27.635 //y=1.58
c140 ( 9 0 ) capacitor c=0.0143761f //x=27.635 //y=1.125
c141 ( 7 0 ) capacitor c=0.0293403f //x=28.035 //y=5.155
c142 ( 6 0 ) capacitor c=0.0124512f //x=27.34 //y=5.38
c143 ( 3 0 ) capacitor c=0.018914f //x=27.225 //y=5.155
c144 ( 1 0 ) capacitor c=0.015209f //x=26.34 //y=5.155
r145 (  43 59 ) resistor r=23.615 //w=0.187 //l=0.345 //layer=li \
 //thickness=0.1 //x=27.34 //y=5.38 //x2=27.34 //y2=5.725
r146 (  35 58 ) resistor r=23.615 //w=0.187 //l=0.345 //layer=li \
 //thickness=0.1 //x=26.46 //y=5.38 //x2=26.46 //y2=5.725
r147 (  27 57 ) resistor r=23.615 //w=0.187 //l=0.345 //layer=li \
 //thickness=0.1 //x=25.58 //y=5.38 //x2=25.58 //y2=5.725
r148 (  25 55 ) resistor r=9.3 //w=0.17 //l=0.17 //layer=mcon //count=1 \
 //x=27.635 //y=1.01 //x2=27.635 //y2=1.01
r149 (  23 43 ) resistor r=9.3 //w=0.17 //l=0.17 //layer=mcon //count=1 \
 //x=27.34 //y=5.38 //x2=27.34 //y2=5.38
r150 (  20 35 ) resistor r=9.3 //w=0.17 //l=0.17 //layer=mcon //count=1 \
 //x=26.46 //y=5.38 //x2=26.46 //y2=5.38
r151 (  18 20 ) resistor r=0.121228 //w=0.232 //l=0.225 //layer=m1 \
 //thickness=0.36 //x=26.46 //y=5.155 //x2=26.46 //y2=5.38
r152 (  17 27 ) resistor r=9.3 //w=0.17 //l=0.17 //layer=mcon //count=1 \
 //x=25.58 //y=5.38 //x2=25.58 //y2=5.38
r153 (  15 17 ) resistor r=0.129608 //w=0.217 //l=0.225 //layer=m1 \
 //thickness=0.36 //x=25.582 //y=5.155 //x2=25.582 //y2=5.38
r154 (  13 14 ) resistor r=3.16794 //w=0.131 //l=3.32 //layer=m1 \
 //thickness=0.36 //x=28.12 //y=1.75 //x2=28.12 //y2=5.07
r155 (  11 13 ) resistor r=0.0698411 //w=0.17 //l=0.120208 //layer=m1 \
 //thickness=0.36 //x=28.035 //y=1.665 //x2=28.12 //y2=1.75
r156 (  11 12 ) resistor r=0.300573 //w=0.131 //l=0.315 //layer=m1 \
 //thickness=0.36 //x=28.035 //y=1.665 //x2=27.72 //y2=1.665
r157 (  10 12 ) resistor r=0.0698411 //w=0.17 //l=0.120208 //layer=m1 \
 //thickness=0.36 //x=27.635 //y=1.58 //x2=27.72 //y2=1.665
r158 (  9 25 ) resistor r=0.0717383 //w=0.224 //l=0.115 //layer=m1 \
 //thickness=0.36 //x=27.635 //y=1.125 //x2=27.635 //y2=1.01
r159 (  9 10 ) resistor r=0.43416 //w=0.131 //l=0.455 //layer=m1 \
 //thickness=0.36 //x=27.635 //y=1.125 //x2=27.635 //y2=1.58
r160 (  8 21 ) resistor r=0.0675342 //w=0.23 //l=0.115 //layer=m1 \
 //thickness=0.36 //x=27.455 //y=5.155 //x2=27.34 //y2=5.155
r161 (  7 14 ) resistor r=0.0698411 //w=0.17 //l=0.120208 //layer=m1 \
 //thickness=0.36 //x=28.035 //y=5.155 //x2=28.12 //y2=5.07
r162 (  7 8 ) resistor r=0.553435 //w=0.131 //l=0.58 //layer=m1 \
 //thickness=0.36 //x=28.035 //y=5.155 //x2=27.455 //y2=5.155
r163 (  6 23 ) resistor r=0.00118313 //w=0.23 //layer=m1 //thickness=0.36 \
 //x=27.34 //y=5.38 //x2=27.34 //y2=5.38
r164 (  5 21 ) resistor r=0.002872 //w=0.34 //l=0.085 //layer=m1 \
 //thickness=0.36 //x=27.34 //y=5.24 //x2=27.34 //y2=5.155
r165 (  5 6 ) resistor r=0.091623 //w=0.191 //l=0.14 //layer=m1 \
 //thickness=0.36 //x=27.34 //y=5.24 //x2=27.34 //y2=5.38
r166 (  4 18 ) resistor r=0.0262263 //w=0.232 //l=0.12 //layer=m1 \
 //thickness=0.36 //x=26.58 //y=5.155 //x2=26.46 //y2=5.155
r167 (  3 21 ) resistor r=0.0675342 //w=0.23 //l=0.115 //layer=m1 \
 //thickness=0.36 //x=27.225 //y=5.155 //x2=27.34 //y2=5.155
r168 (  3 4 ) resistor r=0.615458 //w=0.131 //l=0.645 //layer=m1 \
 //thickness=0.36 //x=27.225 //y=5.155 //x2=26.58 //y2=5.155
r169 (  2 15 ) resistor r=0.0222262 //w=0.217 //l=0.118 //layer=m1 \
 //thickness=0.36 //x=25.7 //y=5.155 //x2=25.582 //y2=5.155
r170 (  1 18 ) resistor r=0.0262263 //w=0.232 //l=0.12 //layer=m1 \
 //thickness=0.36 //x=26.34 //y=5.155 //x2=26.46 //y2=5.155
r171 (  1 2 ) resistor r=0.610687 //w=0.131 //l=0.64 //layer=m1 \
 //thickness=0.36 //x=26.34 //y=5.155 //x2=25.7 //y2=5.155
ends PM_DFFSNRNX1_PCELL\%noxref_20

subckt PM_DFFSNRNX1_PCELL\%noxref_21 ( 1 5 9 13 17 35 )
c53 ( 35 0 ) capacitor c=0.0733556f //x=0.455 //y=0.375
c54 ( 17 0 ) capacitor c=0.0248144f //x=2.445 //y=1.59
c55 ( 13 0 ) capacitor c=0.0153216f //x=2.445 //y=0.54
c56 ( 9 0 ) capacitor c=0.00772076f //x=1.56 //y=0.625
c57 ( 5 0 ) capacitor c=0.0225187f //x=1.475 //y=1.59
c58 ( 1 0 ) capacitor c=0.0109947f //x=0.59 //y=1.505
r59 (  18 35 ) resistor r=5.4201 //w=0.17 //l=0.103078 //layer=li \
 //thickness=0.1 //x=1.645 //y=1.59 //x2=1.56 //y2=1.63
r60 (  18 35 ) resistor r=27.3797 //w=0.187 //l=0.4 //layer=li //thickness=0.1 \
 //x=1.645 //y=1.59 //x2=2.045 //y2=1.59
r61 (  17 35 ) resistor r=0.751729 //w=0.17 //l=0.085 //layer=li \
 //thickness=0.1 //x=2.445 //y=1.59 //x2=2.53 //y2=1.59
r62 (  17 35 ) resistor r=27.3797 //w=0.187 //l=0.4 //layer=li //thickness=0.1 \
 //x=2.445 //y=1.59 //x2=2.045 //y2=1.59
r63 (  14 35 ) resistor r=3.57586 //w=0.17 //l=0.103078 //layer=li \
 //thickness=0.1 //x=1.645 //y=0.54 //x2=1.56 //y2=0.5
r64 (  14 35 ) resistor r=27.3797 //w=0.187 //l=0.4 //layer=li //thickness=0.1 \
 //x=1.645 //y=0.54 //x2=2.045 //y2=0.54
r65 (  13 35 ) resistor r=0.751729 //w=0.17 //l=0.085 //layer=li \
 //thickness=0.1 //x=2.445 //y=0.54 //x2=2.53 //y2=0.54
r66 (  13 35 ) resistor r=27.3797 //w=0.187 //l=0.4 //layer=li //thickness=0.1 \
 //x=2.445 //y=0.54 //x2=2.045 //y2=0.54
r67 (  10 35 ) resistor r=1.40859 //w=0.34 //l=0.125 //layer=li \
 //thickness=0.1 //x=1.56 //y=1.505 //x2=1.56 //y2=1.63
r68 (  10 35 ) resistor r=42.0963 //w=0.187 //l=0.615 //layer=li \
 //thickness=0.1 //x=1.56 //y=1.505 //x2=1.56 //y2=0.89
r69 (  9 35 ) resistor r=3.57586 //w=0.17 //l=0.125 //layer=li //thickness=0.1 \
 //x=1.56 //y=0.625 //x2=1.56 //y2=0.5
r70 (  9 35 ) resistor r=18.139 //w=0.187 //l=0.265 //layer=li //thickness=0.1 \
 //x=1.56 //y=0.625 //x2=1.56 //y2=0.89
r71 (  6 35 ) resistor r=3.57586 //w=0.17 //l=0.103078 //layer=li \
 //thickness=0.1 //x=0.675 //y=1.59 //x2=0.59 //y2=1.63
r72 (  6 35 ) resistor r=27.3797 //w=0.187 //l=0.4 //layer=li //thickness=0.1 \
 //x=0.675 //y=1.59 //x2=1.075 //y2=1.59
r73 (  5 35 ) resistor r=5.4201 //w=0.17 //l=0.103078 //layer=li \
 //thickness=0.1 //x=1.475 //y=1.59 //x2=1.56 //y2=1.63
r74 (  5 35 ) resistor r=27.3797 //w=0.187 //l=0.4 //layer=li //thickness=0.1 \
 //x=1.475 //y=1.59 //x2=1.075 //y2=1.59
r75 (  1 35 ) resistor r=3.57586 //w=0.17 //l=0.125 //layer=li //thickness=0.1 \
 //x=0.59 //y=1.505 //x2=0.59 //y2=1.63
r76 (  1 35 ) resistor r=42.0963 //w=0.187 //l=0.615 //layer=li \
 //thickness=0.1 //x=0.59 //y=1.505 //x2=0.59 //y2=0.89
ends PM_DFFSNRNX1_PCELL\%noxref_21

subckt PM_DFFSNRNX1_PCELL\%noxref_22 ( 1 5 9 13 17 35 )
c58 ( 35 0 ) capacitor c=0.0691212f //x=5.265 //y=0.375
c59 ( 17 0 ) capacitor c=0.0190725f //x=7.255 //y=1.59
c60 ( 13 0 ) capacitor c=0.015325f //x=7.255 //y=0.54
c61 ( 9 0 ) capacitor c=0.00772076f //x=6.37 //y=0.625
c62 ( 5 0 ) capacitor c=0.0166941f //x=6.285 //y=1.59
c63 ( 1 0 ) capacitor c=0.00710458f //x=5.4 //y=1.505
r64 (  18 35 ) resistor r=5.4201 //w=0.17 //l=0.103078 //layer=li \
 //thickness=0.1 //x=6.455 //y=1.59 //x2=6.37 //y2=1.63
r65 (  18 35 ) resistor r=27.3797 //w=0.187 //l=0.4 //layer=li //thickness=0.1 \
 //x=6.455 //y=1.59 //x2=6.855 //y2=1.59
r66 (  17 35 ) resistor r=0.751729 //w=0.17 //l=0.085 //layer=li \
 //thickness=0.1 //x=7.255 //y=1.59 //x2=7.34 //y2=1.59
r67 (  17 35 ) resistor r=27.3797 //w=0.187 //l=0.4 //layer=li //thickness=0.1 \
 //x=7.255 //y=1.59 //x2=6.855 //y2=1.59
r68 (  14 35 ) resistor r=3.57586 //w=0.17 //l=0.103078 //layer=li \
 //thickness=0.1 //x=6.455 //y=0.54 //x2=6.37 //y2=0.5
r69 (  14 35 ) resistor r=27.3797 //w=0.187 //l=0.4 //layer=li //thickness=0.1 \
 //x=6.455 //y=0.54 //x2=6.855 //y2=0.54
r70 (  13 35 ) resistor r=0.751729 //w=0.17 //l=0.085 //layer=li \
 //thickness=0.1 //x=7.255 //y=0.54 //x2=7.34 //y2=0.54
r71 (  13 35 ) resistor r=27.3797 //w=0.187 //l=0.4 //layer=li //thickness=0.1 \
 //x=7.255 //y=0.54 //x2=6.855 //y2=0.54
r72 (  10 35 ) resistor r=1.40859 //w=0.34 //l=0.125 //layer=li \
 //thickness=0.1 //x=6.37 //y=1.505 //x2=6.37 //y2=1.63
r73 (  10 35 ) resistor r=42.0963 //w=0.187 //l=0.615 //layer=li \
 //thickness=0.1 //x=6.37 //y=1.505 //x2=6.37 //y2=0.89
r74 (  9 35 ) resistor r=3.57586 //w=0.17 //l=0.125 //layer=li //thickness=0.1 \
 //x=6.37 //y=0.625 //x2=6.37 //y2=0.5
r75 (  9 35 ) resistor r=18.139 //w=0.187 //l=0.265 //layer=li //thickness=0.1 \
 //x=6.37 //y=0.625 //x2=6.37 //y2=0.89
r76 (  6 35 ) resistor r=3.57586 //w=0.17 //l=0.103078 //layer=li \
 //thickness=0.1 //x=5.485 //y=1.59 //x2=5.4 //y2=1.63
r77 (  6 35 ) resistor r=27.3797 //w=0.187 //l=0.4 //layer=li //thickness=0.1 \
 //x=5.485 //y=1.59 //x2=5.885 //y2=1.59
r78 (  5 35 ) resistor r=5.4201 //w=0.17 //l=0.103078 //layer=li \
 //thickness=0.1 //x=6.285 //y=1.59 //x2=6.37 //y2=1.63
r79 (  5 35 ) resistor r=27.3797 //w=0.187 //l=0.4 //layer=li //thickness=0.1 \
 //x=6.285 //y=1.59 //x2=5.885 //y2=1.59
r80 (  1 35 ) resistor r=3.57586 //w=0.17 //l=0.125 //layer=li //thickness=0.1 \
 //x=5.4 //y=1.505 //x2=5.4 //y2=1.63
r81 (  1 35 ) resistor r=42.0963 //w=0.187 //l=0.615 //layer=li \
 //thickness=0.1 //x=5.4 //y=1.505 //x2=5.4 //y2=0.89
ends PM_DFFSNRNX1_PCELL\%noxref_22

subckt PM_DFFSNRNX1_PCELL\%noxref_23 ( 1 5 9 13 17 35 )
c59 ( 35 0 ) capacitor c=0.0691212f //x=10.075 //y=0.375
c60 ( 17 0 ) capacitor c=0.0190725f //x=12.065 //y=1.59
c61 ( 13 0 ) capacitor c=0.015325f //x=12.065 //y=0.54
c62 ( 9 0 ) capacitor c=0.00772076f //x=11.18 //y=0.625
c63 ( 5 0 ) capacitor c=0.0167789f //x=11.095 //y=1.59
c64 ( 1 0 ) capacitor c=0.00710458f //x=10.21 //y=1.505
r65 (  18 35 ) resistor r=5.4201 //w=0.17 //l=0.103078 //layer=li \
 //thickness=0.1 //x=11.265 //y=1.59 //x2=11.18 //y2=1.63
r66 (  18 35 ) resistor r=27.3797 //w=0.187 //l=0.4 //layer=li //thickness=0.1 \
 //x=11.265 //y=1.59 //x2=11.665 //y2=1.59
r67 (  17 35 ) resistor r=0.751729 //w=0.17 //l=0.085 //layer=li \
 //thickness=0.1 //x=12.065 //y=1.59 //x2=12.15 //y2=1.59
r68 (  17 35 ) resistor r=27.3797 //w=0.187 //l=0.4 //layer=li //thickness=0.1 \
 //x=12.065 //y=1.59 //x2=11.665 //y2=1.59
r69 (  14 35 ) resistor r=3.57586 //w=0.17 //l=0.103078 //layer=li \
 //thickness=0.1 //x=11.265 //y=0.54 //x2=11.18 //y2=0.5
r70 (  14 35 ) resistor r=27.3797 //w=0.187 //l=0.4 //layer=li //thickness=0.1 \
 //x=11.265 //y=0.54 //x2=11.665 //y2=0.54
r71 (  13 35 ) resistor r=0.751729 //w=0.17 //l=0.085 //layer=li \
 //thickness=0.1 //x=12.065 //y=0.54 //x2=12.15 //y2=0.54
r72 (  13 35 ) resistor r=27.3797 //w=0.187 //l=0.4 //layer=li //thickness=0.1 \
 //x=12.065 //y=0.54 //x2=11.665 //y2=0.54
r73 (  10 35 ) resistor r=1.40859 //w=0.34 //l=0.125 //layer=li \
 //thickness=0.1 //x=11.18 //y=1.505 //x2=11.18 //y2=1.63
r74 (  10 35 ) resistor r=42.0963 //w=0.187 //l=0.615 //layer=li \
 //thickness=0.1 //x=11.18 //y=1.505 //x2=11.18 //y2=0.89
r75 (  9 35 ) resistor r=3.57586 //w=0.17 //l=0.125 //layer=li //thickness=0.1 \
 //x=11.18 //y=0.625 //x2=11.18 //y2=0.5
r76 (  9 35 ) resistor r=18.139 //w=0.187 //l=0.265 //layer=li //thickness=0.1 \
 //x=11.18 //y=0.625 //x2=11.18 //y2=0.89
r77 (  6 35 ) resistor r=3.57586 //w=0.17 //l=0.103078 //layer=li \
 //thickness=0.1 //x=10.295 //y=1.59 //x2=10.21 //y2=1.63
r78 (  6 35 ) resistor r=27.3797 //w=0.187 //l=0.4 //layer=li //thickness=0.1 \
 //x=10.295 //y=1.59 //x2=10.695 //y2=1.59
r79 (  5 35 ) resistor r=5.4201 //w=0.17 //l=0.103078 //layer=li \
 //thickness=0.1 //x=11.095 //y=1.59 //x2=11.18 //y2=1.63
r80 (  5 35 ) resistor r=27.3797 //w=0.187 //l=0.4 //layer=li //thickness=0.1 \
 //x=11.095 //y=1.59 //x2=10.695 //y2=1.59
r81 (  1 35 ) resistor r=3.57586 //w=0.17 //l=0.125 //layer=li //thickness=0.1 \
 //x=10.21 //y=1.505 //x2=10.21 //y2=1.63
r82 (  1 35 ) resistor r=42.0963 //w=0.187 //l=0.615 //layer=li \
 //thickness=0.1 //x=10.21 //y=1.505 //x2=10.21 //y2=0.89
ends PM_DFFSNRNX1_PCELL\%noxref_23

subckt PM_DFFSNRNX1_PCELL\%noxref_24 ( 1 5 9 13 17 35 )
c60 ( 35 0 ) capacitor c=0.0691212f //x=14.885 //y=0.375
c61 ( 17 0 ) capacitor c=0.0190725f //x=16.875 //y=1.59
c62 ( 13 0 ) capacitor c=0.015325f //x=16.875 //y=0.54
c63 ( 9 0 ) capacitor c=0.00772076f //x=15.99 //y=0.625
c64 ( 5 0 ) capacitor c=0.0167589f //x=15.905 //y=1.59
c65 ( 1 0 ) capacitor c=0.00710458f //x=15.02 //y=1.505
r66 (  18 35 ) resistor r=5.4201 //w=0.17 //l=0.103078 //layer=li \
 //thickness=0.1 //x=16.075 //y=1.59 //x2=15.99 //y2=1.63
r67 (  18 35 ) resistor r=27.3797 //w=0.187 //l=0.4 //layer=li //thickness=0.1 \
 //x=16.075 //y=1.59 //x2=16.475 //y2=1.59
r68 (  17 35 ) resistor r=0.751729 //w=0.17 //l=0.085 //layer=li \
 //thickness=0.1 //x=16.875 //y=1.59 //x2=16.96 //y2=1.59
r69 (  17 35 ) resistor r=27.3797 //w=0.187 //l=0.4 //layer=li //thickness=0.1 \
 //x=16.875 //y=1.59 //x2=16.475 //y2=1.59
r70 (  14 35 ) resistor r=3.57586 //w=0.17 //l=0.103078 //layer=li \
 //thickness=0.1 //x=16.075 //y=0.54 //x2=15.99 //y2=0.5
r71 (  14 35 ) resistor r=27.3797 //w=0.187 //l=0.4 //layer=li //thickness=0.1 \
 //x=16.075 //y=0.54 //x2=16.475 //y2=0.54
r72 (  13 35 ) resistor r=0.751729 //w=0.17 //l=0.085 //layer=li \
 //thickness=0.1 //x=16.875 //y=0.54 //x2=16.96 //y2=0.54
r73 (  13 35 ) resistor r=27.3797 //w=0.187 //l=0.4 //layer=li //thickness=0.1 \
 //x=16.875 //y=0.54 //x2=16.475 //y2=0.54
r74 (  10 35 ) resistor r=1.40859 //w=0.34 //l=0.125 //layer=li \
 //thickness=0.1 //x=15.99 //y=1.505 //x2=15.99 //y2=1.63
r75 (  10 35 ) resistor r=42.0963 //w=0.187 //l=0.615 //layer=li \
 //thickness=0.1 //x=15.99 //y=1.505 //x2=15.99 //y2=0.89
r76 (  9 35 ) resistor r=3.57586 //w=0.17 //l=0.125 //layer=li //thickness=0.1 \
 //x=15.99 //y=0.625 //x2=15.99 //y2=0.5
r77 (  9 35 ) resistor r=18.139 //w=0.187 //l=0.265 //layer=li //thickness=0.1 \
 //x=15.99 //y=0.625 //x2=15.99 //y2=0.89
r78 (  6 35 ) resistor r=3.57586 //w=0.17 //l=0.103078 //layer=li \
 //thickness=0.1 //x=15.105 //y=1.59 //x2=15.02 //y2=1.63
r79 (  6 35 ) resistor r=27.3797 //w=0.187 //l=0.4 //layer=li //thickness=0.1 \
 //x=15.105 //y=1.59 //x2=15.505 //y2=1.59
r80 (  5 35 ) resistor r=5.4201 //w=0.17 //l=0.103078 //layer=li \
 //thickness=0.1 //x=15.905 //y=1.59 //x2=15.99 //y2=1.63
r81 (  5 35 ) resistor r=27.3797 //w=0.187 //l=0.4 //layer=li //thickness=0.1 \
 //x=15.905 //y=1.59 //x2=15.505 //y2=1.59
r82 (  1 35 ) resistor r=3.57586 //w=0.17 //l=0.125 //layer=li //thickness=0.1 \
 //x=15.02 //y=1.505 //x2=15.02 //y2=1.63
r83 (  1 35 ) resistor r=42.0963 //w=0.187 //l=0.615 //layer=li \
 //thickness=0.1 //x=15.02 //y=1.505 //x2=15.02 //y2=0.89
ends PM_DFFSNRNX1_PCELL\%noxref_24

subckt PM_DFFSNRNX1_PCELL\%noxref_25 ( 1 5 9 13 17 35 )
c59 ( 35 0 ) capacitor c=0.0696502f //x=19.695 //y=0.375
c60 ( 17 0 ) capacitor c=0.0190918f //x=21.685 //y=1.59
c61 ( 13 0 ) capacitor c=0.0153819f //x=21.685 //y=0.54
c62 ( 9 0 ) capacitor c=0.00772076f //x=20.8 //y=0.625
c63 ( 5 0 ) capacitor c=0.0168501f //x=20.715 //y=1.59
c64 ( 1 0 ) capacitor c=0.00710458f //x=19.83 //y=1.505
r65 (  18 35 ) resistor r=5.4201 //w=0.17 //l=0.103078 //layer=li \
 //thickness=0.1 //x=20.885 //y=1.59 //x2=20.8 //y2=1.63
r66 (  18 35 ) resistor r=27.3797 //w=0.187 //l=0.4 //layer=li //thickness=0.1 \
 //x=20.885 //y=1.59 //x2=21.285 //y2=1.59
r67 (  17 35 ) resistor r=0.751729 //w=0.17 //l=0.085 //layer=li \
 //thickness=0.1 //x=21.685 //y=1.59 //x2=21.77 //y2=1.59
r68 (  17 35 ) resistor r=27.3797 //w=0.187 //l=0.4 //layer=li //thickness=0.1 \
 //x=21.685 //y=1.59 //x2=21.285 //y2=1.59
r69 (  14 35 ) resistor r=3.57586 //w=0.17 //l=0.103078 //layer=li \
 //thickness=0.1 //x=20.885 //y=0.54 //x2=20.8 //y2=0.5
r70 (  14 35 ) resistor r=27.3797 //w=0.187 //l=0.4 //layer=li //thickness=0.1 \
 //x=20.885 //y=0.54 //x2=21.285 //y2=0.54
r71 (  13 35 ) resistor r=0.751729 //w=0.17 //l=0.085 //layer=li \
 //thickness=0.1 //x=21.685 //y=0.54 //x2=21.77 //y2=0.54
r72 (  13 35 ) resistor r=27.3797 //w=0.187 //l=0.4 //layer=li //thickness=0.1 \
 //x=21.685 //y=0.54 //x2=21.285 //y2=0.54
r73 (  10 35 ) resistor r=1.40859 //w=0.34 //l=0.125 //layer=li \
 //thickness=0.1 //x=20.8 //y=1.505 //x2=20.8 //y2=1.63
r74 (  10 35 ) resistor r=42.0963 //w=0.187 //l=0.615 //layer=li \
 //thickness=0.1 //x=20.8 //y=1.505 //x2=20.8 //y2=0.89
r75 (  9 35 ) resistor r=3.57586 //w=0.17 //l=0.125 //layer=li //thickness=0.1 \
 //x=20.8 //y=0.625 //x2=20.8 //y2=0.5
r76 (  9 35 ) resistor r=18.139 //w=0.187 //l=0.265 //layer=li //thickness=0.1 \
 //x=20.8 //y=0.625 //x2=20.8 //y2=0.89
r77 (  6 35 ) resistor r=3.57586 //w=0.17 //l=0.103078 //layer=li \
 //thickness=0.1 //x=19.915 //y=1.59 //x2=19.83 //y2=1.63
r78 (  6 35 ) resistor r=27.3797 //w=0.187 //l=0.4 //layer=li //thickness=0.1 \
 //x=19.915 //y=1.59 //x2=20.315 //y2=1.59
r79 (  5 35 ) resistor r=5.4201 //w=0.17 //l=0.103078 //layer=li \
 //thickness=0.1 //x=20.715 //y=1.59 //x2=20.8 //y2=1.63
r80 (  5 35 ) resistor r=27.3797 //w=0.187 //l=0.4 //layer=li //thickness=0.1 \
 //x=20.715 //y=1.59 //x2=20.315 //y2=1.59
r81 (  1 35 ) resistor r=3.57586 //w=0.17 //l=0.125 //layer=li //thickness=0.1 \
 //x=19.83 //y=1.505 //x2=19.83 //y2=1.63
r82 (  1 35 ) resistor r=42.0963 //w=0.187 //l=0.615 //layer=li \
 //thickness=0.1 //x=19.83 //y=1.505 //x2=19.83 //y2=0.89
ends PM_DFFSNRNX1_PCELL\%noxref_25

subckt PM_DFFSNRNX1_PCELL\%noxref_26 ( 1 5 9 13 17 35 )
c57 ( 35 0 ) capacitor c=0.0707637f //x=24.505 //y=0.375
c58 ( 17 0 ) capacitor c=0.0201638f //x=26.495 //y=1.59
c59 ( 13 0 ) capacitor c=0.0153867f //x=26.495 //y=0.54
c60 ( 9 0 ) capacitor c=0.00772076f //x=25.61 //y=0.625
c61 ( 5 0 ) capacitor c=0.0174915f //x=25.525 //y=1.59
c62 ( 1 0 ) capacitor c=0.00748697f //x=24.64 //y=1.505
r63 (  18 35 ) resistor r=5.4201 //w=0.17 //l=0.103078 //layer=li \
 //thickness=0.1 //x=25.695 //y=1.59 //x2=25.61 //y2=1.63
r64 (  18 35 ) resistor r=27.3797 //w=0.187 //l=0.4 //layer=li //thickness=0.1 \
 //x=25.695 //y=1.59 //x2=26.095 //y2=1.59
r65 (  17 35 ) resistor r=0.751729 //w=0.17 //l=0.085 //layer=li \
 //thickness=0.1 //x=26.495 //y=1.59 //x2=26.58 //y2=1.59
r66 (  17 35 ) resistor r=27.3797 //w=0.187 //l=0.4 //layer=li //thickness=0.1 \
 //x=26.495 //y=1.59 //x2=26.095 //y2=1.59
r67 (  14 35 ) resistor r=3.57586 //w=0.17 //l=0.103078 //layer=li \
 //thickness=0.1 //x=25.695 //y=0.54 //x2=25.61 //y2=0.5
r68 (  14 35 ) resistor r=27.3797 //w=0.187 //l=0.4 //layer=li //thickness=0.1 \
 //x=25.695 //y=0.54 //x2=26.095 //y2=0.54
r69 (  13 35 ) resistor r=0.751729 //w=0.17 //l=0.085 //layer=li \
 //thickness=0.1 //x=26.495 //y=0.54 //x2=26.58 //y2=0.54
r70 (  13 35 ) resistor r=27.3797 //w=0.187 //l=0.4 //layer=li //thickness=0.1 \
 //x=26.495 //y=0.54 //x2=26.095 //y2=0.54
r71 (  10 35 ) resistor r=1.40859 //w=0.34 //l=0.125 //layer=li \
 //thickness=0.1 //x=25.61 //y=1.505 //x2=25.61 //y2=1.63
r72 (  10 35 ) resistor r=42.0963 //w=0.187 //l=0.615 //layer=li \
 //thickness=0.1 //x=25.61 //y=1.505 //x2=25.61 //y2=0.89
r73 (  9 35 ) resistor r=3.57586 //w=0.17 //l=0.125 //layer=li //thickness=0.1 \
 //x=25.61 //y=0.625 //x2=25.61 //y2=0.5
r74 (  9 35 ) resistor r=18.139 //w=0.187 //l=0.265 //layer=li //thickness=0.1 \
 //x=25.61 //y=0.625 //x2=25.61 //y2=0.89
r75 (  6 35 ) resistor r=3.57586 //w=0.17 //l=0.103078 //layer=li \
 //thickness=0.1 //x=24.725 //y=1.59 //x2=24.64 //y2=1.63
r76 (  6 35 ) resistor r=27.3797 //w=0.187 //l=0.4 //layer=li //thickness=0.1 \
 //x=24.725 //y=1.59 //x2=25.125 //y2=1.59
r77 (  5 35 ) resistor r=5.4201 //w=0.17 //l=0.103078 //layer=li \
 //thickness=0.1 //x=25.525 //y=1.59 //x2=25.61 //y2=1.63
r78 (  5 35 ) resistor r=27.3797 //w=0.187 //l=0.4 //layer=li //thickness=0.1 \
 //x=25.525 //y=1.59 //x2=25.125 //y2=1.59
r79 (  1 35 ) resistor r=3.57586 //w=0.17 //l=0.125 //layer=li //thickness=0.1 \
 //x=24.64 //y=1.505 //x2=24.64 //y2=1.63
r80 (  1 35 ) resistor r=42.0963 //w=0.187 //l=0.615 //layer=li \
 //thickness=0.1 //x=24.64 //y=1.505 //x2=24.64 //y2=0.89
ends PM_DFFSNRNX1_PCELL\%noxref_26
