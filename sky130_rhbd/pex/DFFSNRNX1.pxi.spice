// File: DFFSNRNX1.spi.DFFSNRNX1.pxi
// Created: Sun Apr 12 08:32:37 2026
//
simulator lang=spectre
x_PM_DFFSNRNX1\%noxref_1 ( N_noxref_1_c_153_p N_noxref_1_c_73_p \
 N_noxref_1_c_95_p N_noxref_1_c_74_p N_noxref_1_c_75_p N_noxref_1_c_130_p \
 N_noxref_1_c_85_p N_noxref_1_c_76_p N_noxref_1_c_9_p N_noxref_1_c_67_p \
 N_noxref_1_c_17_p N_noxref_1_c_21_p N_noxref_1_c_10_p N_noxref_1_c_11_p \
 N_noxref_1_c_12_p N_noxref_1_c_87_p N_noxref_1_c_88_p N_noxref_1_c_34_p \
 N_noxref_1_c_32_p N_noxref_1_c_238_p N_noxref_1_c_159_p N_noxref_1_c_81_p \
 N_noxref_1_c_71_p N_noxref_1_c_13_p N_noxref_1_c_5_p N_noxref_1_c_105_p \
 N_noxref_1_c_14_p N_noxref_1_c_15_p N_noxref_1_c_72_p N_noxref_1_c_240_p \
 N_noxref_1_c_155_p N_noxref_1_c_82_p N_noxref_1_c_16_p N_noxref_1_c_19_p \
 N_noxref_1_c_183_p N_noxref_1_c_180_p N_noxref_1_M3_noxref_g \
 N_noxref_1_M6_noxref_g N_noxref_1_M24_noxref_g N_noxref_1_M25_noxref_g \
 N_noxref_1_M30_noxref_g N_noxref_1_M31_noxref_g N_noxref_1_c_50_p \
 N_noxref_1_c_51_p N_noxref_1_c_53_p N_noxref_1_c_24_p N_noxref_1_c_323_p \
 N_noxref_1_c_337_p N_noxref_1_c_52_p N_noxref_1_c_54_p N_noxref_1_c_29_p \
 N_noxref_1_c_30_p N_noxref_1_c_204_p N_noxref_1_c_205_p N_noxref_1_c_207_p \
 N_noxref_1_c_184_p N_noxref_1_c_326_p N_noxref_1_c_348_p N_noxref_1_c_206_p \
 N_noxref_1_c_208_p N_noxref_1_c_4_p N_noxref_1_c_191_p N_noxref_1_M2_noxref_d \
 N_noxref_1_M18_noxref_d N_noxref_1_M20_noxref_d N_noxref_1_M22_noxref_d )  \
 PM_DFFSNRNX1\%noxref_1
x_PM_DFFSNRNX1\%noxref_2 ( N_noxref_2_c_415_n N_noxref_2_c_487_p \
 N_noxref_2_c_549_p N_noxref_2_c_490_p N_noxref_2_c_503_p N_noxref_2_c_574_p \
 N_noxref_2_c_504_p N_noxref_2_c_480_p N_noxref_2_c_423_p N_noxref_2_c_440_p \
 N_noxref_2_c_435_p N_noxref_2_c_431_p N_noxref_2_c_424_p N_noxref_2_c_425_p \
 N_noxref_2_c_426_p N_noxref_2_c_416_n N_noxref_2_c_489_p N_noxref_2_c_491_p \
 N_noxref_2_c_419_n N_noxref_2_c_427_p N_noxref_2_c_442_p N_noxref_2_c_428_p \
 N_noxref_2_c_445_p N_noxref_2_c_420_n N_noxref_2_c_499_p N_noxref_2_c_540_p \
 N_noxref_2_c_429_p N_noxref_2_c_437_p N_noxref_2_M9_noxref_g \
 N_noxref_2_M36_noxref_g N_noxref_2_M37_noxref_g N_noxref_2_c_463_p \
 N_noxref_2_c_464_p N_noxref_2_c_466_p N_noxref_2_c_433_p N_noxref_2_c_665_p \
 N_noxref_2_c_675_p N_noxref_2_c_465_p N_noxref_2_c_467_p N_noxref_2_c_438_p \
 N_noxref_2_c_439_p N_noxref_2_M8_noxref_d N_noxref_2_M30_noxref_d \
 N_noxref_2_M32_noxref_d N_noxref_2_M34_noxref_d )  PM_DFFSNRNX1\%noxref_2
x_PM_DFFSNRNX1\%CLK ( CLK CLK CLK CLK CLK N_CLK_c_720_n N_CLK_c_724_n \
 N_CLK_c_726_n N_CLK_c_772_n N_CLK_c_775_n N_CLK_c_776_n N_CLK_c_730_n \
 N_CLK_c_731_n N_CLK_c_733_n N_CLK_c_784_n N_CLK_c_787_n N_CLK_c_791_n \
 N_CLK_c_736_n N_CLK_c_738_n N_CLK_c_742_n N_CLK_c_793_n N_CLK_c_797_n \
 N_CLK_M4_noxref_g N_CLK_M10_noxref_g N_CLK_M26_noxref_g N_CLK_M27_noxref_g \
 N_CLK_M38_noxref_g N_CLK_M39_noxref_g N_CLK_c_749_n N_CLK_c_752_n \
 N_CLK_c_987_p N_CLK_c_988_p N_CLK_c_754_n N_CLK_c_755_n N_CLK_c_756_n \
 N_CLK_c_757_n N_CLK_c_835_p N_CLK_c_804_n N_CLK_c_807_n N_CLK_c_1003_p \
 N_CLK_c_1004_p N_CLK_c_809_n N_CLK_c_810_n N_CLK_c_811_n N_CLK_c_812_n \
 N_CLK_c_893_p N_CLK_c_760_n N_CLK_c_815_n )  PM_DFFSNRNX1\%CLK
x_PM_DFFSNRNX1\%noxref_4 ( N_noxref_4_c_1038_n N_noxref_4_c_1039_n \
 N_noxref_4_c_1046_n N_noxref_4_c_1051_n N_noxref_4_c_1056_n \
 N_noxref_4_c_1136_n N_noxref_4_c_1124_n N_noxref_4_c_1125_n \
 N_noxref_4_c_1057_n N_noxref_4_c_1351_p N_noxref_4_c_1126_n \
 N_noxref_4_c_1058_n N_noxref_4_c_1060_n N_noxref_4_c_1065_n \
 N_noxref_4_c_1066_n N_noxref_4_c_1188_p N_noxref_4_c_1176_p \
 N_noxref_4_c_1180_p N_noxref_4_c_1177_p N_noxref_4_c_1067_n \
 N_noxref_4_c_1068_n N_noxref_4_c_1142_n N_noxref_4_c_1209_p \
 N_noxref_4_c_1288_p N_noxref_4_c_1182_p N_noxref_4_c_1073_n \
 N_noxref_4_c_1081_n N_noxref_4_c_1082_n N_noxref_4_c_1083_n \
 N_noxref_4_c_1210_p N_noxref_4_c_1127_n N_noxref_4_c_1084_n \
 N_noxref_4_c_1128_n N_noxref_4_c_1183_p N_noxref_4_c_1086_n \
 N_noxref_4_c_1087_n N_noxref_4_c_1091_n N_noxref_4_c_1165_n \
 N_noxref_4_c_1298_p N_noxref_4_c_1184_p N_noxref_4_c_1195_p \
 N_noxref_4_M2_noxref_g N_noxref_4_M12_noxref_g N_noxref_4_M22_noxref_g \
 N_noxref_4_M23_noxref_g N_noxref_4_M42_noxref_g N_noxref_4_M43_noxref_g \
 N_noxref_4_c_1100_n N_noxref_4_c_1102_n N_noxref_4_c_1105_n \
 N_noxref_4_c_1106_n N_noxref_4_c_1108_n N_noxref_4_c_1112_n \
 N_noxref_4_c_1114_n N_noxref_4_c_1249_p N_noxref_4_c_1250_p \
 N_noxref_4_c_1252_p N_noxref_4_c_1190_p N_noxref_4_c_1466_p \
 N_noxref_4_c_1476_p N_noxref_4_c_1251_p N_noxref_4_c_1253_p \
 N_noxref_4_c_1196_p N_noxref_4_c_1197_p N_noxref_4_c_1118_n \
 N_noxref_4_c_1119_n N_noxref_4_c_1121_n N_noxref_4_M5_noxref_d \
 N_noxref_4_M24_noxref_d N_noxref_4_M26_noxref_d N_noxref_4_M28_noxref_d )  \
 PM_DFFSNRNX1\%noxref_4
x_PM_DFFSNRNX1\%RN ( RN RN RN RN RN RN RN RN RN RN RN RN RN N_RN_c_1598_n \
 N_RN_c_1552_n N_RN_c_1601_n N_RN_c_1514_n N_RN_c_1555_n N_RN_c_1607_n \
 N_RN_c_1517_n N_RN_c_1620_n N_RN_c_1523_n N_RN_c_1541_n N_RN_c_1628_n \
 N_RN_c_1543_n N_RN_c_1524_n N_RN_c_1633_n N_RN_c_1525_n N_RN_c_1562_n \
 N_RN_c_1566_n N_RN_c_1640_n N_RN_c_1644_n N_RN_M1_noxref_g N_RN_M11_noxref_g \
 N_RN_M13_noxref_g N_RN_M20_noxref_g N_RN_M21_noxref_g N_RN_M40_noxref_g \
 N_RN_M41_noxref_g N_RN_M44_noxref_g N_RN_M45_noxref_g N_RN_c_1862_p \
 N_RN_c_1864_p N_RN_c_1886_p N_RN_c_1887_p N_RN_c_1654_n N_RN_c_1655_n \
 N_RN_c_1656_n N_RN_c_1657_n N_RN_c_1533_n N_RN_c_1572_n N_RN_c_1573_n \
 N_RN_c_1574_n N_RN_c_1724_p N_RN_c_1725_p N_RN_c_1726_p N_RN_c_1727_p \
 N_RN_c_1662_n N_RN_c_1665_n N_RN_c_1911_p N_RN_c_1912_p N_RN_c_1667_n \
 N_RN_c_1668_n N_RN_c_1669_n N_RN_c_1670_n N_RN_c_1692_p N_RN_c_1535_n \
 N_RN_c_1575_n N_RN_c_1578_n N_RN_c_1579_n N_RN_c_1675_n )  PM_DFFSNRNX1\%RN
x_PM_DFFSNRNX1\%QN ( QN QN QN QN QN QN QN QN N_QN_c_1946_n N_QN_c_1960_n \
 N_QN_c_2062_p N_QN_c_2038_p N_QN_c_1995_p N_QN_c_2092_p N_QN_c_2061_p \
 N_QN_c_1996_p N_QN_c_1997_p N_QN_c_1982_p N_QN_c_1977_p N_QN_c_1978_p \
 N_QN_c_1947_n N_QN_c_1962_n N_QN_c_2058_p N_QN_c_2000_p N_QN_c_1979_p \
 N_QN_c_2002_p N_QN_c_1950_n N_QN_c_1968_n N_QN_c_2059_p N_QN_c_1983_p \
 N_QN_c_1980_p N_QN_M15_noxref_g N_QN_M48_noxref_g N_QN_M49_noxref_g \
 N_QN_c_2015_p N_QN_c_2016_p N_QN_c_2018_p N_QN_c_1984_p N_QN_c_2183_p \
 N_QN_c_2193_p N_QN_c_2017_p N_QN_c_2019_p N_QN_c_1991_p N_QN_c_1992_p \
 N_QN_M14_noxref_d N_QN_M42_noxref_d N_QN_M44_noxref_d N_QN_M46_noxref_d )  \
 PM_DFFSNRNX1\%QN
x_PM_DFFSNRNX1\%SN ( SN SN SN SN SN SN N_SN_c_2234_n N_SN_c_2237_n \
 N_SN_c_2239_n N_SN_c_2240_n N_SN_c_2344_n N_SN_c_2347_n N_SN_c_2350_n \
 N_SN_c_2351_n N_SN_c_2279_n N_SN_c_2283_n N_SN_c_2287_n N_SN_c_2290_n \
 N_SN_c_2244_n N_SN_c_2245_n N_SN_c_2249_n N_SN_c_2365_n N_SN_c_2369_n \
 N_SN_M7_noxref_g N_SN_M16_noxref_g N_SN_M32_noxref_g N_SN_M33_noxref_g \
 N_SN_M50_noxref_g N_SN_M51_noxref_g N_SN_c_2256_n N_SN_c_2259_n N_SN_c_2522_p \
 N_SN_c_2523_p N_SN_c_2261_n N_SN_c_2262_n N_SN_c_2263_n N_SN_c_2264_n \
 N_SN_c_2302_n N_SN_c_2377_n N_SN_c_2380_n N_SN_c_2562_p N_SN_c_2563_p \
 N_SN_c_2382_n N_SN_c_2383_n N_SN_c_2384_n N_SN_c_2385_n N_SN_c_2475_p \
 N_SN_c_2267_n N_SN_c_2388_n )  PM_DFFSNRNX1\%SN
x_PM_DFFSNRNX1\%noxref_8 ( N_noxref_8_c_2605_n N_noxref_8_c_2606_n \
 N_noxref_8_c_2693_n N_noxref_8_c_2611_n N_noxref_8_c_2617_n \
 N_noxref_8_c_2613_n N_noxref_8_c_2625_n N_noxref_8_c_2615_n \
 N_noxref_8_c_2634_n N_noxref_8_c_2704_n N_noxref_8_c_2850_n \
 N_noxref_8_c_2852_n N_noxref_8_c_2856_n N_noxref_8_c_2862_n \
 N_noxref_8_c_2867_n N_noxref_8_c_2635_n N_noxref_8_c_2705_n \
 N_noxref_8_c_2779_n N_noxref_8_c_2707_n N_noxref_8_c_2946_n \
 N_noxref_8_c_2918_n N_noxref_8_c_2955_n N_noxref_8_c_2920_n \
 N_noxref_8_c_2708_n N_noxref_8_c_2636_n N_noxref_8_c_2637_n \
 N_noxref_8_c_2709_n N_noxref_8_c_2887_n N_noxref_8_c_2890_n \
 N_noxref_8_c_2961_n N_noxref_8_c_2715_n N_noxref_8_c_2716_n \
 N_noxref_8_c_2717_n N_noxref_8_c_2642_n N_noxref_8_c_2616_n \
 N_noxref_8_c_2798_n N_noxref_8_c_2964_n N_noxref_8_c_2800_n \
 N_noxref_8_c_2724_n N_noxref_8_c_2728_n N_noxref_8_c_2645_n \
 N_noxref_8_c_2646_n N_noxref_8_c_2650_n N_noxref_8_c_2732_n \
 N_noxref_8_c_2904_n N_noxref_8_c_2976_n N_noxref_8_c_2980_n \
 N_noxref_8_M5_noxref_g N_noxref_8_M8_noxref_g N_noxref_8_M17_noxref_g \
 N_noxref_8_M28_noxref_g N_noxref_8_M29_noxref_g N_noxref_8_M34_noxref_g \
 N_noxref_8_M35_noxref_g N_noxref_8_M52_noxref_g N_noxref_8_M53_noxref_g \
 N_noxref_8_c_2739_n N_noxref_8_c_2740_n N_noxref_8_c_2741_n \
 N_noxref_8_c_2820_n N_noxref_8_c_2822_n N_noxref_8_c_2826_n \
 N_noxref_8_c_2828_n N_noxref_8_c_2659_n N_noxref_8_c_2661_n \
 N_noxref_8_c_2664_n N_noxref_8_c_2665_n N_noxref_8_c_2667_n \
 N_noxref_8_c_2671_n N_noxref_8_c_2673_n N_noxref_8_c_2993_n \
 N_noxref_8_c_2994_n N_noxref_8_c_2995_n N_noxref_8_c_3041_p \
 N_noxref_8_c_3042_p N_noxref_8_c_3043_p N_noxref_8_c_3044_p \
 N_noxref_8_c_2742_n N_noxref_8_c_2745_n N_noxref_8_c_2746_n \
 N_noxref_8_c_2677_n N_noxref_8_c_2678_n N_noxref_8_c_2680_n \
 N_noxref_8_c_3004_n N_noxref_8_c_3007_n N_noxref_8_c_3008_n \
 N_noxref_8_M11_noxref_d N_noxref_8_M36_noxref_d N_noxref_8_M38_noxref_d \
 N_noxref_8_M40_noxref_d )  PM_DFFSNRNX1\%noxref_8
x_PM_DFFSNRNX1\%Q ( Q Q Q Q Q Q Q Q Q Q Q Q Q N_Q_c_3228_n N_Q_c_3231_n \
 N_Q_c_3232_n N_Q_c_3275_n N_Q_c_3339_n N_Q_c_3374_n N_Q_c_3376_n N_Q_c_3381_n \
 N_Q_c_3387_n N_Q_c_3392_n N_Q_c_3276_n N_Q_c_3394_n N_Q_c_3277_n N_Q_c_3340_n \
 N_Q_c_3397_n N_Q_c_3221_n N_Q_c_3401_n N_Q_c_3283_n N_Q_c_3236_n N_Q_c_3240_n \
 N_Q_c_3295_n N_Q_c_3350_n N_Q_c_3407_n N_Q_M14_noxref_g N_Q_M46_noxref_g \
 N_Q_M47_noxref_g N_Q_c_3246_n N_Q_c_3247_n N_Q_c_3248_n N_Q_c_3310_n \
 N_Q_c_3312_n N_Q_c_3316_n N_Q_c_3318_n N_Q_c_3249_n N_Q_c_3252_n N_Q_c_3253_n \
 N_Q_M17_noxref_d N_Q_M48_noxref_d N_Q_M50_noxref_d N_Q_M52_noxref_d )  \
 PM_DFFSNRNX1\%Q
x_PM_DFFSNRNX1\%VDD ( VDD N_VDD_c_3497_n N_VDD_c_3509_n N_VDD_c_3511_n \
 N_VDD_c_3514_n N_VDD_c_3518_n N_VDD_c_3522_n N_VDD_c_3523_n N_VDD_c_3615_n \
 N_VDD_c_3643_n N_VDD_c_3647_n N_VDD_c_3525_n N_VDD_c_3576_n N_VDD_c_3580_n \
 N_VDD_c_3584_n N_VDD_c_3585_n N_VDD_c_3617_n N_VDD_c_3686_n N_VDD_c_3795_n \
 N_VDD_c_3648_n N_VDD_c_3688_n N_VDD_c_3725_n N_VDD_c_3729_n N_VDD_c_3730_n \
 N_VDD_c_3763_n N_VDD_c_3797_n N_VDD_c_3799_n N_VDD_c_3527_n N_VDD_c_3533_n \
 N_VDD_c_3589_n N_VDD_c_3658_n N_VDD_c_3734_n N_VDD_M18_noxref_s \
 N_VDD_M19_noxref_d N_VDD_M21_noxref_d N_VDD_M23_noxref_d N_VDD_M24_noxref_s \
 N_VDD_M25_noxref_d N_VDD_M27_noxref_d N_VDD_M29_noxref_d N_VDD_M30_noxref_s \
 N_VDD_M31_noxref_d N_VDD_M33_noxref_d N_VDD_M35_noxref_d N_VDD_M36_noxref_s \
 N_VDD_M37_noxref_d N_VDD_M39_noxref_d N_VDD_M41_noxref_d N_VDD_M42_noxref_s \
 N_VDD_M43_noxref_d N_VDD_M45_noxref_d N_VDD_M47_noxref_d N_VDD_M48_noxref_s \
 N_VDD_M49_noxref_d N_VDD_M51_noxref_d N_VDD_M53_noxref_d )  PM_DFFSNRNX1\%VDD
x_PM_DFFSNRNX1\%D ( D D D D D D N_D_c_3919_n N_D_c_3922_n N_D_c_3926_n \
 N_D_c_3930_n N_D_M0_noxref_g N_D_M18_noxref_g N_D_M19_noxref_g N_D_c_3936_n \
 N_D_c_3937_n N_D_c_3938_n N_D_c_3939_n N_D_c_3965_p N_D_c_3973_p N_D_c_3942_n \
 N_D_c_3944_n N_D_c_3910_n N_D_c_3950_n )  PM_DFFSNRNX1\%D
x_PM_DFFSNRNX1\%noxref_12 ( N_noxref_12_c_4022_n N_noxref_12_c_4038_p \
 N_noxref_12_c_4001_n N_noxref_12_c_4040_p N_noxref_12_c_4004_n \
 N_noxref_12_M1_noxref_d N_noxref_12_M2_noxref_s )  PM_DFFSNRNX1\%noxref_12
x_PM_DFFSNRNX1\%noxref_13 ( N_noxref_13_c_4066_n N_noxref_13_c_4107_p \
 N_noxref_13_c_4085_n N_noxref_13_c_4109_p N_noxref_13_c_4088_n \
 N_noxref_13_M4_noxref_d N_noxref_13_M5_noxref_s )  PM_DFFSNRNX1\%noxref_13
x_PM_DFFSNRNX1\%noxref_14 ( N_noxref_14_c_4147_n N_noxref_14_c_4179_p \
 N_noxref_14_c_4135_n N_noxref_14_c_4181_p N_noxref_14_c_4138_n \
 N_noxref_14_M7_noxref_d N_noxref_14_M8_noxref_s )  PM_DFFSNRNX1\%noxref_14
x_PM_DFFSNRNX1\%noxref_15 ( N_noxref_15_c_4208_n N_noxref_15_c_4250_p \
 N_noxref_15_c_4224_n N_noxref_15_c_4252_p N_noxref_15_c_4229_n \
 N_noxref_15_M10_noxref_d N_noxref_15_M11_noxref_s )  PM_DFFSNRNX1\%noxref_15
x_PM_DFFSNRNX1\%noxref_16 ( N_noxref_16_c_4278_n N_noxref_16_c_4321_p \
 N_noxref_16_c_4293_n N_noxref_16_c_4323_p N_noxref_16_c_4296_n \
 N_noxref_16_M13_noxref_d N_noxref_16_M14_noxref_s )  PM_DFFSNRNX1\%noxref_16
x_PM_DFFSNRNX1\%GND ( GND N_GND_c_4715_p N_GND_c_4591_n N_GND_c_4349_n \
 N_GND_c_4353_n N_GND_c_4450_n N_GND_c_4356_n N_GND_c_4414_n N_GND_c_4418_n \
 N_GND_c_4452_n N_GND_c_4458_n N_GND_c_4495_n N_GND_c_4504_n N_GND_c_4538_n \
 N_GND_c_4583_n N_GND_c_4359_n N_GND_c_4371_n N_GND_c_4421_n N_GND_c_4462_n \
 N_GND_c_4507_n N_GND_c_4382_n N_GND_c_4584_n N_GND_c_4384_n N_GND_c_4385_n \
 N_GND_c_4434_n N_GND_c_4474_n N_GND_c_4520_n N_GND_c_4386_n N_GND_c_4394_n \
 N_GND_c_4435_n N_GND_c_4480_n N_GND_c_4521_n N_GND_M0_noxref_d \
 N_GND_M3_noxref_d N_GND_M6_noxref_d N_GND_M9_noxref_d N_GND_M12_noxref_d \
 N_GND_M15_noxref_d )  PM_DFFSNRNX1\%GND
x_PM_DFFSNRNX1\%noxref_18 ( N_noxref_18_c_4834_n N_noxref_18_c_4876_n \
 N_noxref_18_c_4851_n N_noxref_18_c_4880_n N_noxref_18_c_4856_n \
 N_noxref_18_M16_noxref_d N_noxref_18_M17_noxref_s )  PM_DFFSNRNX1\%noxref_18
x_PM_DFFSNRNX1\%noxref_19 ( N_noxref_19_c_4907_n N_noxref_19_c_4908_n \
 N_noxref_19_c_4919_n N_noxref_19_c_4897_n N_noxref_19_c_4899_n \
 N_noxref_19_M0_noxref_s )  PM_DFFSNRNX1\%noxref_19
x_PM_DFFSNRNX1\%noxref_20 ( N_noxref_20_c_4949_n N_noxref_20_c_4951_n \
 N_noxref_20_c_4980_n N_noxref_20_c_4967_n N_noxref_20_c_4960_n \
 N_noxref_20_M3_noxref_s )  PM_DFFSNRNX1\%noxref_20
x_PM_DFFSNRNX1\%noxref_21 ( N_noxref_21_c_5010_n N_noxref_21_c_5012_n \
 N_noxref_21_c_5041_n N_noxref_21_c_5027_n N_noxref_21_c_5025_n \
 N_noxref_21_M6_noxref_s )  PM_DFFSNRNX1\%noxref_21
x_PM_DFFSNRNX1\%noxref_22 ( N_noxref_22_c_5071_n N_noxref_22_c_5072_n \
 N_noxref_22_c_5100_n N_noxref_22_c_5083_n N_noxref_22_c_5085_n \
 N_noxref_22_M9_noxref_s )  PM_DFFSNRNX1\%noxref_22
x_PM_DFFSNRNX1\%noxref_23 ( N_noxref_23_c_5130_n N_noxref_23_c_5131_n \
 N_noxref_23_c_5158_n N_noxref_23_c_5142_n N_noxref_23_c_5144_n \
 N_noxref_23_M12_noxref_s )  PM_DFFSNRNX1\%noxref_23
x_PM_DFFSNRNX1\%noxref_24 ( N_noxref_24_c_5188_n N_noxref_24_c_5189_n \
 N_noxref_24_c_5223_n N_noxref_24_c_5202_n N_noxref_24_c_5204_n \
 N_noxref_24_M15_noxref_s )  PM_DFFSNRNX1\%noxref_24
cc_1 ( N_noxref_1_M31_noxref_g N_noxref_2_c_415_n ) capacitor c=0.00893512f \
 //x=11.86 //y=6.2 //x2=12.4 //y2=5.335
cc_2 ( N_noxref_1_M30_noxref_g N_noxref_2_c_416_n ) capacitor c=0.00461408f \
 //x=11.42 //y=6.2 //x2=11.642 //y2=5.335
cc_3 ( N_noxref_1_M31_noxref_g N_noxref_2_c_416_n ) capacitor c=0.00229208f \
 //x=11.86 //y=6.2 //x2=11.642 //y2=5.335
cc_4 ( N_noxref_1_c_4_p N_noxref_2_c_416_n ) capacitor c=0.00171885f \
 //x=11.785 //y=4.97 //x2=11.642 //y2=5.335
cc_5 ( N_noxref_1_c_5_p N_noxref_2_c_419_n ) capacitor c=4.16271e-19 //x=11.22 \
 //y=3.145 //x2=14.18 //y2=3.14
cc_6 ( N_noxref_1_M30_noxref_g N_noxref_2_c_420_n ) capacitor c=0.0162284f \
 //x=11.42 //y=6.2 //x2=11.64 //y2=5.56
cc_7 ( N_noxref_1_M31_noxref_g N_noxref_2_c_420_n ) capacitor c=0.0179041f \
 //x=11.86 //y=6.2 //x2=11.64 //y2=5.56
cc_8 ( N_noxref_1_c_4_p N_noxref_2_c_420_n ) capacitor c=0.00291477f \
 //x=11.785 //y=4.97 //x2=11.64 //y2=5.56
cc_9 ( N_noxref_1_c_9_p CLK ) capacitor c=0.00135141f //x=4.56 //y=2.99 \
 //x2=7.52 //y2=2.77
cc_10 ( N_noxref_1_c_10_p CLK ) capacitor c=0.0181815f //x=6.41 //y=2.985 \
 //x2=7.52 //y2=2.77
cc_11 ( N_noxref_1_c_11_p CLK ) capacitor c=0.00775443f //x=6.41 //y=3.305 \
 //x2=7.52 //y2=2.77
cc_12 ( N_noxref_1_c_12_p CLK ) capacitor c=0.00148897f //x=6.41 //y=4.755 \
 //x2=7.52 //y2=2.77
cc_13 ( N_noxref_1_c_13_p CLK ) capacitor c=2.90818e-19 //x=6.41 //y=3.145 \
 //x2=7.52 //y2=2.77
cc_14 ( N_noxref_1_c_14_p CLK ) capacitor c=0.0265956f //x=7.73 //y=3.13 \
 //x2=7.52 //y2=2.77
cc_15 ( N_noxref_1_c_15_p CLK ) capacitor c=0.00252635f //x=7.3 //y=3.13 \
 //x2=7.52 //y2=2.77
cc_16 ( N_noxref_1_c_16_p CLK ) capacitor c=4.16726e-19 //x=6.41 //y=2.26 \
 //x2=7.52 //y2=2.77
cc_17 ( N_noxref_1_c_17_p CLK ) capacitor c=0.00101272f //x=4.56 //y=5.25 \
 //x2=7.52 //y2=4.25
cc_18 ( N_noxref_1_c_12_p CLK ) capacitor c=0.0264254f //x=6.41 //y=4.755 \
 //x2=7.52 //y2=4.25
cc_19 ( N_noxref_1_c_19_p CLK ) capacitor c=3.36194e-19 //x=6.41 //y=4.88 \
 //x2=7.52 //y2=4.25
cc_20 ( N_noxref_1_c_12_p CLK ) capacitor c=3.43503e-19 //x=6.41 //y=4.755 \
 //x2=7.52 //y2=3.51
cc_21 ( N_noxref_1_c_21_p N_CLK_c_720_n ) capacitor c=0.0115546f //x=6.41 \
 //y=2.375 //x2=7.52 //y2=2.375
cc_22 ( N_noxref_1_c_14_p N_CLK_c_720_n ) capacitor c=0.00225123f //x=7.73 \
 //y=3.13 //x2=7.52 //y2=2.375
cc_23 ( N_noxref_1_c_16_p N_CLK_c_720_n ) capacitor c=5.40058e-19 //x=6.41 \
 //y=2.26 //x2=7.52 //y2=2.375
cc_24 ( N_noxref_1_c_24_p N_CLK_c_720_n ) capacitor c=0.00147006f //x=6.11 \
 //y=2.095 //x2=7.52 //y2=2.375
cc_25 ( N_noxref_1_c_12_p N_CLK_c_724_n ) capacitor c=0.00781344f //x=6.41 \
 //y=4.755 //x2=7.52 //y2=3.675
cc_26 ( N_noxref_1_c_14_p N_CLK_c_724_n ) capacitor c=0.00614747f //x=7.73 \
 //y=3.13 //x2=7.52 //y2=3.675
cc_27 ( N_noxref_1_c_12_p N_CLK_c_726_n ) capacitor c=0.0110307f //x=6.41 \
 //y=4.755 //x2=7.52 //y2=4.765
cc_28 ( N_noxref_1_c_19_p N_CLK_c_726_n ) capacitor c=2.89813e-19 //x=6.41 \
 //y=4.88 //x2=7.52 //y2=4.765
cc_29 ( N_noxref_1_c_29_p N_CLK_c_726_n ) capacitor c=7.66769e-19 //x=6.975 \
 //y=4.97 //x2=7.52 //y2=4.765
cc_30 ( N_noxref_1_c_30_p N_CLK_c_726_n ) capacitor c=7.54501e-19 //x=6.685 \
 //y=4.97 //x2=7.52 //y2=4.765
cc_31 ( N_noxref_1_c_14_p N_CLK_c_730_n ) capacitor c=0.185207f //x=7.73 \
 //y=3.13 //x2=8.985 //y2=3.51
cc_32 ( N_noxref_1_c_32_p N_CLK_c_731_n ) capacitor c=2.17089e-19 //x=11.22 \
 //y=4.755 //x2=9.585 //y2=3.495
cc_33 ( N_noxref_1_c_14_p N_CLK_c_731_n ) capacitor c=0.129756f //x=7.73 \
 //y=3.13 //x2=9.585 //y2=3.495
cc_34 ( N_noxref_1_c_34_p N_CLK_c_733_n ) capacitor c=0.00659576f //x=11.22 \
 //y=3.285 //x2=13.795 //y2=3.51
cc_35 ( N_noxref_1_c_32_p N_CLK_c_733_n ) capacitor c=0.024144f //x=11.22 \
 //y=4.755 //x2=13.795 //y2=3.51
cc_36 ( N_noxref_1_c_14_p N_CLK_c_733_n ) capacitor c=0.0368432f //x=7.73 \
 //y=3.13 //x2=13.795 //y2=3.51
cc_37 ( N_noxref_1_c_12_p N_CLK_c_736_n ) capacitor c=0.00509953f //x=6.41 \
 //y=4.755 //x2=7.675 //y2=3.515
cc_38 ( N_noxref_1_c_14_p N_CLK_c_736_n ) capacitor c=0.0365231f //x=7.73 \
 //y=3.13 //x2=7.675 //y2=3.515
cc_39 ( N_noxref_1_c_21_p N_CLK_c_738_n ) capacitor c=5.39999e-19 //x=6.41 \
 //y=2.375 //x2=7.52 //y2=2.26
cc_40 ( N_noxref_1_c_10_p N_CLK_c_738_n ) capacitor c=4.16726e-19 //x=6.41 \
 //y=2.985 //x2=7.52 //y2=2.26
cc_41 ( N_noxref_1_c_16_p N_CLK_c_738_n ) capacitor c=0.00125213f //x=6.41 \
 //y=2.26 //x2=7.52 //y2=2.26
cc_42 ( N_noxref_1_c_24_p N_CLK_c_738_n ) capacitor c=0.00214573f //x=6.11 \
 //y=2.095 //x2=7.52 //y2=2.26
cc_43 ( N_noxref_1_c_12_p N_CLK_c_742_n ) capacitor c=0.00103399f //x=6.41 \
 //y=4.755 //x2=7.52 //y2=4.88
cc_44 ( N_noxref_1_c_19_p N_CLK_c_742_n ) capacitor c=0.00113984f //x=6.41 \
 //y=4.88 //x2=7.52 //y2=4.88
cc_45 ( N_noxref_1_c_29_p N_CLK_c_742_n ) capacitor c=0.00116563f //x=6.975 \
 //y=4.97 //x2=7.52 //y2=4.88
cc_46 ( N_noxref_1_c_30_p N_CLK_c_742_n ) capacitor c=0.00129812f //x=6.685 \
 //y=4.97 //x2=7.52 //y2=4.88
cc_47 ( N_noxref_1_M24_noxref_g N_CLK_M26_noxref_g ) capacitor c=0.0106276f \
 //x=6.61 //y=6.2 //x2=7.49 //y2=6.2
cc_48 ( N_noxref_1_M25_noxref_g N_CLK_M26_noxref_g ) capacitor c=0.107144f \
 //x=7.05 //y=6.2 //x2=7.49 //y2=6.2
cc_49 ( N_noxref_1_M25_noxref_g N_CLK_M27_noxref_g ) capacitor c=0.0101598f \
 //x=7.05 //y=6.2 //x2=7.93 //y2=6.2
cc_50 ( N_noxref_1_c_50_p N_CLK_c_749_n ) capacitor c=5.72528e-19 //x=6.11 \
 //y=1.055 //x2=7.085 //y2=1.09
cc_51 ( N_noxref_1_c_51_p N_CLK_c_749_n ) capacitor c=0.00150277f //x=6.11 \
 //y=1.4 //x2=7.085 //y2=1.09
cc_52 ( N_noxref_1_c_52_p N_CLK_c_749_n ) capacitor c=0.0160123f //x=6.64 \
 //y=1.055 //x2=7.085 //y2=1.09
cc_53 ( N_noxref_1_c_53_p N_CLK_c_752_n ) capacitor c=0.00111227f //x=6.11 \
 //y=1.71 //x2=7.085 //y2=1.4
cc_54 ( N_noxref_1_c_54_p N_CLK_c_752_n ) capacitor c=0.0124075f //x=6.64 \
 //y=1.4 //x2=7.085 //y2=1.4
cc_55 ( N_noxref_1_c_52_p N_CLK_c_754_n ) capacitor c=9.19165e-19 //x=6.64 \
 //y=1.055 //x2=7.61 //y2=1.09
cc_56 ( N_noxref_1_c_54_p N_CLK_c_755_n ) capacitor c=0.0010154f //x=6.64 \
 //y=1.4 //x2=7.61 //y2=1.4
cc_57 ( N_noxref_1_c_54_p N_CLK_c_756_n ) capacitor c=9.23422e-19 //x=6.64 \
 //y=1.4 //x2=7.61 //y2=1.63
cc_58 ( N_noxref_1_c_21_p N_CLK_c_757_n ) capacitor c=0.00140534f //x=6.41 \
 //y=2.375 //x2=7.61 //y2=2.095
cc_59 ( N_noxref_1_c_16_p N_CLK_c_757_n ) capacitor c=0.0020754f //x=6.41 \
 //y=2.26 //x2=7.61 //y2=2.095
cc_60 ( N_noxref_1_c_24_p N_CLK_c_757_n ) capacitor c=0.00964411f //x=6.11 \
 //y=2.095 //x2=7.61 //y2=2.095
cc_61 ( N_noxref_1_c_12_p N_CLK_c_760_n ) capacitor c=0.00116212f //x=6.41 \
 //y=4.755 //x2=7.52 //y2=4.88
cc_62 ( N_noxref_1_c_19_p N_CLK_c_760_n ) capacitor c=0.00155973f //x=6.41 \
 //y=4.88 //x2=7.52 //y2=4.88
cc_63 ( N_noxref_1_c_29_p N_CLK_c_760_n ) capacitor c=0.0171374f //x=6.975 \
 //y=4.97 //x2=7.52 //y2=4.88
cc_64 ( N_noxref_1_c_30_p N_CLK_c_760_n ) capacitor c=0.00484466f //x=6.685 \
 //y=4.97 //x2=7.52 //y2=4.88
cc_65 ( N_noxref_1_c_9_p N_noxref_4_c_1038_n ) capacitor c=0.0154269f //x=4.56 \
 //y=2.99 //x2=3.82 //y2=2.375
cc_66 ( N_noxref_1_c_9_p N_noxref_4_c_1039_n ) capacitor c=0.0273037f //x=4.56 \
 //y=2.99 //x2=3.82 //y2=3.72
cc_67 ( N_noxref_1_c_67_p N_noxref_4_c_1039_n ) capacitor c=0.0148501f \
 //x=4.56 //y=3.31 //x2=3.82 //y2=3.72
cc_68 ( N_noxref_1_c_17_p N_noxref_4_c_1039_n ) capacitor c=0.0195141f \
 //x=4.56 //y=5.25 //x2=3.82 //y2=3.72
cc_69 ( N_noxref_1_c_10_p N_noxref_4_c_1039_n ) capacitor c=0.00174083f \
 //x=6.41 //y=2.985 //x2=3.82 //y2=3.72
cc_70 ( N_noxref_1_c_12_p N_noxref_4_c_1039_n ) capacitor c=4.30737e-19 \
 //x=6.41 //y=4.755 //x2=3.82 //y2=3.72
cc_71 ( N_noxref_1_c_71_p N_noxref_4_c_1039_n ) capacitor c=6.15181e-19 \
 //x=4.56 //y=3.145 //x2=3.82 //y2=3.72
cc_72 ( N_noxref_1_c_72_p N_noxref_4_c_1039_n ) capacitor c=0.00686863f \
 //x=4.72 //y=3.15 //x2=3.82 //y2=3.72
cc_73 ( N_noxref_1_c_73_p N_noxref_4_c_1046_n ) capacitor c=8.38638e-19 \
 //x=3.665 //y=5.335 //x2=3.82 //y2=4.04
cc_74 ( N_noxref_1_c_74_p N_noxref_4_c_1046_n ) capacitor c=0.0011767f \
 //x=4.475 //y=5.335 //x2=3.82 //y2=4.04
cc_75 ( N_noxref_1_c_75_p N_noxref_4_c_1046_n ) capacitor c=2.10199e-19 \
 //x=4.075 //y=1.305 //x2=3.82 //y2=4.04
cc_76 ( N_noxref_1_c_76_p N_noxref_4_c_1046_n ) capacitor c=8.96559e-19 \
 //x=4.16 //y=1.845 //x2=3.82 //y2=4.04
cc_77 ( N_noxref_1_c_17_p N_noxref_4_c_1046_n ) capacitor c=0.0173413f \
 //x=4.56 //y=5.25 //x2=3.82 //y2=4.04
cc_78 ( N_noxref_1_c_74_p N_noxref_4_c_1051_n ) capacitor c=0.00228791f \
 //x=4.475 //y=5.335 //x2=3.82 //y2=4.75
cc_79 ( N_noxref_1_c_17_p N_noxref_4_c_1051_n ) capacitor c=0.0448706f \
 //x=4.56 //y=5.25 //x2=3.82 //y2=4.75
cc_80 ( N_noxref_1_c_12_p N_noxref_4_c_1051_n ) capacitor c=0.00113976f \
 //x=6.41 //y=4.755 //x2=3.82 //y2=4.75
cc_81 ( N_noxref_1_c_81_p N_noxref_4_c_1051_n ) capacitor c=0.0221235f \
 //x=3.78 //y=5.335 //x2=3.82 //y2=4.75
cc_82 ( N_noxref_1_c_82_p N_noxref_4_c_1051_n ) capacitor c=0.00217653f \
 //x=3.78 //y=5.56 //x2=3.82 //y2=4.75
cc_83 ( N_noxref_1_M25_noxref_g N_noxref_4_c_1056_n ) capacitor c=0.00893512f \
 //x=7.05 //y=6.2 //x2=7.59 //y2=5.335
cc_84 ( N_noxref_1_c_14_p N_noxref_4_c_1057_n ) capacitor c=4.31646e-19 \
 //x=7.73 //y=3.13 //x2=8.885 //y2=1.305
cc_85 ( N_noxref_1_c_85_p N_noxref_4_c_1058_n ) capacitor c=0.00163399f \
 //x=4.475 //y=1.845 //x2=8.97 //y2=1.845
cc_86 ( N_noxref_1_c_14_p N_noxref_4_c_1058_n ) capacitor c=0.0105017f \
 //x=7.73 //y=3.13 //x2=8.97 //y2=1.845
cc_87 ( N_noxref_1_c_87_p N_noxref_4_c_1060_n ) capacitor c=0.00458539f \
 //x=11.22 //y=2.375 //x2=9.37 //y2=3.72
cc_88 ( N_noxref_1_c_88_p N_noxref_4_c_1060_n ) capacitor c=0.00946189f \
 //x=11.22 //y=2.965 //x2=9.37 //y2=3.72
cc_89 ( N_noxref_1_c_34_p N_noxref_4_c_1060_n ) capacitor c=0.00254755f \
 //x=11.22 //y=3.285 //x2=9.37 //y2=3.72
cc_90 ( N_noxref_1_c_32_p N_noxref_4_c_1060_n ) capacitor c=0.00556918f \
 //x=11.22 //y=4.755 //x2=9.37 //y2=3.72
cc_91 ( N_noxref_1_c_14_p N_noxref_4_c_1060_n ) capacitor c=0.0301559f \
 //x=7.73 //y=3.13 //x2=9.37 //y2=3.72
cc_92 ( N_noxref_1_c_32_p N_noxref_4_c_1065_n ) capacitor c=0.00254581f \
 //x=11.22 //y=4.755 //x2=9.37 //y2=4.04
cc_93 ( N_noxref_1_c_32_p N_noxref_4_c_1066_n ) capacitor c=0.0117881f \
 //x=11.22 //y=4.755 //x2=9.37 //y2=5.25
cc_94 ( N_noxref_1_c_17_p N_noxref_4_c_1067_n ) capacitor c=6.78671e-19 \
 //x=4.56 //y=5.25 //x2=3.82 //y2=3.88
cc_95 ( N_noxref_1_c_95_p N_noxref_4_c_1068_n ) capacitor c=6.09703e-19 \
 //x=3.78 //y=5.56 //x2=6.832 //y2=5.335
cc_96 ( N_noxref_1_c_74_p N_noxref_4_c_1068_n ) capacitor c=0.00306432f \
 //x=4.475 //y=5.335 //x2=6.832 //y2=5.335
cc_97 ( N_noxref_1_M24_noxref_g N_noxref_4_c_1068_n ) capacitor c=0.00461408f \
 //x=6.61 //y=6.2 //x2=6.832 //y2=5.335
cc_98 ( N_noxref_1_M25_noxref_g N_noxref_4_c_1068_n ) capacitor c=0.00229208f \
 //x=7.05 //y=6.2 //x2=6.832 //y2=5.335
cc_99 ( N_noxref_1_c_29_p N_noxref_4_c_1068_n ) capacitor c=0.00171885f \
 //x=6.975 //y=4.97 //x2=6.832 //y2=5.335
cc_100 ( N_noxref_1_c_76_p N_noxref_4_c_1073_n ) capacitor c=0.0052544f \
 //x=4.16 //y=1.845 //x2=7.13 //y2=3.88
cc_101 ( N_noxref_1_c_67_p N_noxref_4_c_1073_n ) capacitor c=0.00532666f \
 //x=4.56 //y=3.31 //x2=7.13 //y2=3.88
cc_102 ( N_noxref_1_c_17_p N_noxref_4_c_1073_n ) capacitor c=0.0270676f \
 //x=4.56 //y=5.25 //x2=7.13 //y2=3.88
cc_103 ( N_noxref_1_c_11_p N_noxref_4_c_1073_n ) capacitor c=0.00368531f \
 //x=6.41 //y=3.305 //x2=7.13 //y2=3.88
cc_104 ( N_noxref_1_c_12_p N_noxref_4_c_1073_n ) capacitor c=0.0300789f \
 //x=6.41 //y=4.755 //x2=7.13 //y2=3.88
cc_105 ( N_noxref_1_c_105_p N_noxref_4_c_1073_n ) capacitor c=0.0723731f \
 //x=6.25 //y=3.145 //x2=7.13 //y2=3.88
cc_106 ( N_noxref_1_c_15_p N_noxref_4_c_1073_n ) capacitor c=0.049459f //x=7.3 \
 //y=3.13 //x2=7.13 //y2=3.88
cc_107 ( N_noxref_1_c_72_p N_noxref_4_c_1073_n ) capacitor c=0.0163271f \
 //x=4.72 //y=3.15 //x2=7.13 //y2=3.88
cc_108 ( N_noxref_1_c_17_p N_noxref_4_c_1081_n ) capacitor c=0.0032735f \
 //x=4.56 //y=5.25 //x2=3.98 //y2=3.88
cc_109 ( N_noxref_1_c_14_p N_noxref_4_c_1082_n ) capacitor c=0.00865191f \
 //x=7.73 //y=3.13 //x2=7.73 //y2=3.9
cc_110 ( N_noxref_1_c_14_p N_noxref_4_c_1083_n ) capacitor c=0.00424947f \
 //x=7.73 //y=3.13 //x2=8.24 //y2=3.88
cc_111 ( N_noxref_1_c_32_p N_noxref_4_c_1084_n ) capacitor c=0.0261374f \
 //x=11.22 //y=4.755 //x2=13.22 //y2=3.865
cc_112 ( N_noxref_1_c_14_p N_noxref_4_c_1084_n ) capacitor c=0.0132903f \
 //x=7.73 //y=3.13 //x2=13.22 //y2=3.865
cc_113 ( N_noxref_1_c_9_p N_noxref_4_c_1086_n ) capacitor c=0.00163444f \
 //x=4.56 //y=2.99 //x2=3.82 //y2=2.26
cc_114 ( N_noxref_1_c_74_p N_noxref_4_c_1087_n ) capacitor c=0.00130631f \
 //x=4.475 //y=5.335 //x2=3.82 //y2=4.88
cc_115 ( N_noxref_1_c_17_p N_noxref_4_c_1087_n ) capacitor c=0.00131258f \
 //x=4.56 //y=5.25 //x2=3.82 //y2=4.88
cc_116 ( N_noxref_1_c_81_p N_noxref_4_c_1087_n ) capacitor c=0.00346456f \
 //x=3.78 //y=5.335 //x2=3.82 //y2=4.88
cc_117 ( N_noxref_1_c_82_p N_noxref_4_c_1087_n ) capacitor c=0.00552343f \
 //x=3.78 //y=5.56 //x2=3.82 //y2=4.88
cc_118 ( N_noxref_1_M24_noxref_g N_noxref_4_c_1091_n ) capacitor c=0.0162284f \
 //x=6.61 //y=6.2 //x2=6.83 //y2=5.56
cc_119 ( N_noxref_1_M25_noxref_g N_noxref_4_c_1091_n ) capacitor c=0.0179041f \
 //x=7.05 //y=6.2 //x2=6.83 //y2=5.56
cc_120 ( N_noxref_1_c_29_p N_noxref_4_c_1091_n ) capacitor c=0.00291477f \
 //x=6.975 //y=4.97 //x2=6.83 //y2=5.56
cc_121 ( N_noxref_1_c_73_p N_noxref_4_M22_noxref_g ) capacitor c=0.00955829f \
 //x=3.665 //y=5.335 //x2=3.56 //y2=6.2
cc_122 ( N_noxref_1_c_95_p N_noxref_4_M22_noxref_g ) capacitor c=0.00226521f \
 //x=3.78 //y=5.56 //x2=3.56 //y2=6.2
cc_123 ( N_noxref_1_c_82_p N_noxref_4_M22_noxref_g ) capacitor c=0.0178885f \
 //x=3.78 //y=5.56 //x2=3.56 //y2=6.2
cc_124 ( N_noxref_1_c_95_p N_noxref_4_M23_noxref_g ) capacitor c=0.00381703f \
 //x=3.78 //y=5.56 //x2=4 //y2=6.2
cc_125 ( N_noxref_1_c_74_p N_noxref_4_M23_noxref_g ) capacitor c=0.0109656f \
 //x=4.475 //y=5.335 //x2=4 //y2=6.2
cc_126 ( N_noxref_1_c_82_p N_noxref_4_M23_noxref_g ) capacitor c=0.0188608f \
 //x=3.78 //y=5.56 //x2=4 //y2=6.2
cc_127 ( N_noxref_1_c_75_p N_noxref_4_c_1100_n ) capacitor c=4.64015e-19 \
 //x=4.075 //y=1.305 //x2=3.81 //y2=1.095
cc_128 ( N_noxref_1_M2_noxref_d N_noxref_4_c_1100_n ) capacitor c=0.00137165f \
 //x=3.885 //y=1.095 //x2=3.81 //y2=1.095
cc_129 ( N_noxref_1_c_75_p N_noxref_4_c_1102_n ) capacitor c=0.0026012f \
 //x=4.075 //y=1.305 //x2=3.81 //y2=1.44
cc_130 ( N_noxref_1_c_130_p N_noxref_4_c_1102_n ) capacitor c=0.00127432f \
 //x=4.075 //y=1.76 //x2=3.81 //y2=1.44
cc_131 ( N_noxref_1_M2_noxref_d N_noxref_4_c_1102_n ) capacitor c=0.00237422f \
 //x=3.885 //y=1.095 //x2=3.81 //y2=1.44
cc_132 ( N_noxref_1_c_130_p N_noxref_4_c_1105_n ) capacitor c=0.00429966f \
 //x=4.075 //y=1.76 //x2=3.81 //y2=1.75
cc_133 ( N_noxref_1_c_75_p N_noxref_4_c_1106_n ) capacitor c=5.29969e-19 \
 //x=4.075 //y=1.305 //x2=4.185 //y2=0.94
cc_134 ( N_noxref_1_M2_noxref_d N_noxref_4_c_1106_n ) capacitor c=0.0020782f \
 //x=3.885 //y=1.095 //x2=4.185 //y2=0.94
cc_135 ( N_noxref_1_c_75_p N_noxref_4_c_1108_n ) capacitor c=5.17996e-19 \
 //x=4.075 //y=1.305 //x2=4.185 //y2=1.595
cc_136 ( N_noxref_1_c_130_p N_noxref_4_c_1108_n ) capacitor c=0.00942306f \
 //x=4.075 //y=1.76 //x2=4.185 //y2=1.595
cc_137 ( N_noxref_1_c_85_p N_noxref_4_c_1108_n ) capacitor c=0.00194716f \
 //x=4.475 //y=1.845 //x2=4.185 //y2=1.595
cc_138 ( N_noxref_1_M2_noxref_d N_noxref_4_c_1108_n ) capacitor c=0.00356097f \
 //x=3.885 //y=1.095 //x2=4.185 //y2=1.595
cc_139 ( N_noxref_1_c_75_p N_noxref_4_c_1112_n ) capacitor c=5.24634e-19 \
 //x=4.075 //y=1.305 //x2=4.34 //y2=1.095
cc_140 ( N_noxref_1_M2_noxref_d N_noxref_4_c_1112_n ) capacitor c=0.00139206f \
 //x=3.885 //y=1.095 //x2=4.34 //y2=1.095
cc_141 ( N_noxref_1_c_75_p N_noxref_4_c_1114_n ) capacitor c=0.00307978f \
 //x=4.075 //y=1.305 //x2=4.34 //y2=1.44
cc_142 ( N_noxref_1_c_130_p N_noxref_4_c_1114_n ) capacitor c=0.00363411f \
 //x=4.075 //y=1.76 //x2=4.34 //y2=1.44
cc_143 ( N_noxref_1_c_85_p N_noxref_4_c_1114_n ) capacitor c=0.00323576f \
 //x=4.475 //y=1.845 //x2=4.34 //y2=1.44
cc_144 ( N_noxref_1_M2_noxref_d N_noxref_4_c_1114_n ) capacitor c=0.00237422f \
 //x=3.885 //y=1.095 //x2=4.34 //y2=1.44
cc_145 ( N_noxref_1_c_9_p N_noxref_4_c_1118_n ) capacitor c=0.0025845f \
 //x=4.56 //y=2.99 //x2=3.82 //y2=2.26
cc_146 ( N_noxref_1_c_130_p N_noxref_4_c_1119_n ) capacitor c=0.00372124f \
 //x=4.075 //y=1.76 //x2=3.82 //y2=2.095
cc_147 ( N_noxref_1_c_9_p N_noxref_4_c_1119_n ) capacitor c=0.00282067f \
 //x=4.56 //y=2.99 //x2=3.82 //y2=2.095
cc_148 ( N_noxref_1_c_17_p N_noxref_4_c_1121_n ) capacitor c=0.00738015f \
 //x=4.56 //y=5.25 //x2=3.82 //y2=4.88
cc_149 ( N_noxref_1_c_81_p N_noxref_4_c_1121_n ) capacitor c=0.00203307f \
 //x=3.78 //y=5.335 //x2=3.82 //y2=4.88
cc_150 ( N_noxref_1_c_82_p N_noxref_4_c_1121_n ) capacitor c=0.00375636f \
 //x=3.78 //y=5.56 //x2=3.82 //y2=4.88
cc_151 ( N_noxref_1_c_9_p RN ) capacitor c=0.00143339f //x=4.56 //y=2.99 \
 //x2=2.71 //y2=2.77
cc_152 ( N_noxref_1_c_17_p RN ) capacitor c=0.00238244f //x=4.56 //y=5.25 \
 //x2=2.71 //y2=2.77
cc_153 ( N_noxref_1_c_153_p N_RN_c_1514_n ) capacitor c=0.0288436f //x=2.78 \
 //y=5.335 //x2=2.71 //y2=4.875
cc_154 ( N_noxref_1_c_17_p N_RN_c_1514_n ) capacitor c=8.56162e-19 //x=4.56 \
 //y=5.25 //x2=2.71 //y2=4.875
cc_155 ( N_noxref_1_c_155_p N_RN_c_1514_n ) capacitor c=0.00154972f //x=2.9 \
 //y=5.56 //x2=2.71 //y2=4.875
cc_156 ( N_noxref_1_c_74_p N_RN_c_1517_n ) capacitor c=0.0202595f //x=4.475 \
 //y=5.335 //x2=8.24 //y2=4.62
cc_157 ( N_noxref_1_c_17_p N_RN_c_1517_n ) capacitor c=0.032712f //x=4.56 \
 //y=5.25 //x2=8.24 //y2=4.62
cc_158 ( N_noxref_1_c_12_p N_RN_c_1517_n ) capacitor c=0.0354195f //x=6.41 \
 //y=4.755 //x2=8.24 //y2=4.62
cc_159 ( N_noxref_1_c_159_p N_RN_c_1517_n ) capacitor c=0.040052f //x=2.9 \
 //y=5.335 //x2=8.24 //y2=4.62
cc_160 ( N_noxref_1_c_105_p N_RN_c_1517_n ) capacitor c=0.00310473f //x=6.25 \
 //y=3.145 //x2=8.24 //y2=4.62
cc_161 ( N_noxref_1_c_15_p N_RN_c_1517_n ) capacitor c=0.00249331f //x=7.3 \
 //y=3.13 //x2=8.24 //y2=4.62
cc_162 ( N_noxref_1_c_32_p N_RN_c_1523_n ) capacitor c=0.0327118f //x=11.22 \
 //y=4.755 //x2=13.05 //y2=4.62
cc_163 ( N_noxref_1_c_153_p N_RN_c_1524_n ) capacitor c=0.0109661f //x=2.78 \
 //y=5.335 //x2=2.71 //y2=4.62
cc_164 ( N_noxref_1_c_153_p N_RN_c_1525_n ) capacitor c=0.00494359f //x=2.78 \
 //y=5.335 //x2=2.71 //y2=4.88
cc_165 ( N_noxref_1_c_159_p N_RN_c_1525_n ) capacitor c=0.00132214f //x=2.9 \
 //y=5.335 //x2=2.71 //y2=4.88
cc_166 ( N_noxref_1_c_153_p N_RN_M20_noxref_g ) capacitor c=0.00854418f \
 //x=2.78 //y=5.335 //x2=2.68 //y2=6.2
cc_167 ( N_noxref_1_c_159_p N_RN_M20_noxref_g ) capacitor c=0.00229818f \
 //x=2.9 //y=5.335 //x2=2.68 //y2=6.2
cc_168 ( N_noxref_1_c_155_p N_RN_M20_noxref_g ) capacitor c=0.0179041f //x=2.9 \
 //y=5.56 //x2=2.68 //y2=6.2
cc_169 ( N_noxref_1_c_73_p N_RN_M21_noxref_g ) capacitor c=0.00955829f \
 //x=3.665 //y=5.335 //x2=3.12 //y2=6.2
cc_170 ( N_noxref_1_c_159_p N_RN_M21_noxref_g ) capacitor c=0.00230699f \
 //x=2.9 //y=5.335 //x2=3.12 //y2=6.2
cc_171 ( N_noxref_1_c_155_p N_RN_M21_noxref_g ) capacitor c=0.0179041f //x=2.9 \
 //y=5.56 //x2=3.12 //y2=6.2
cc_172 ( N_noxref_1_c_159_p N_RN_c_1533_n ) capacitor c=0.00169973f //x=2.9 \
 //y=5.335 //x2=3.045 //y2=4.97
cc_173 ( N_noxref_1_c_155_p N_RN_c_1533_n ) capacitor c=0.00294585f //x=2.9 \
 //y=5.56 //x2=3.045 //y2=4.97
cc_174 ( N_noxref_1_c_153_p N_RN_c_1535_n ) capacitor c=3.44762e-19 //x=2.78 \
 //y=5.335 //x2=2.71 //y2=4.88
cc_175 ( N_noxref_1_c_88_p SN ) capacitor c=9.64871e-19 //x=11.22 //y=2.965 \
 //x2=12.33 //y2=3.14
cc_176 ( N_noxref_1_c_34_p SN ) capacitor c=0.00782998f //x=11.22 //y=3.285 \
 //x2=12.33 //y2=3.14
cc_177 ( N_noxref_1_c_32_p SN ) capacitor c=0.0328733f //x=11.22 //y=4.755 \
 //x2=12.33 //y2=3.14
cc_178 ( N_noxref_1_c_5_p SN ) capacitor c=4.28566e-19 //x=11.22 //y=3.145 \
 //x2=12.33 //y2=3.14
cc_179 ( N_noxref_1_c_14_p SN ) capacitor c=0.00513455f //x=7.73 //y=3.13 \
 //x2=12.33 //y2=3.14
cc_180 ( N_noxref_1_c_180_p SN ) capacitor c=3.36194e-19 //x=11.22 //y=4.88 \
 //x2=12.33 //y2=3.14
cc_181 ( N_noxref_1_c_88_p SN ) capacitor c=2.64384e-19 //x=11.22 //y=2.965 \
 //x2=12.33 //y2=2.77
cc_182 ( N_noxref_1_c_87_p N_SN_c_2234_n ) capacitor c=0.0115546f //x=11.22 \
 //y=2.375 //x2=12.33 //y2=2.375
cc_183 ( N_noxref_1_c_183_p N_SN_c_2234_n ) capacitor c=5.40058e-19 //x=11.22 \
 //y=2.26 //x2=12.33 //y2=2.375
cc_184 ( N_noxref_1_c_184_p N_SN_c_2234_n ) capacitor c=0.00147006f //x=10.92 \
 //y=2.095 //x2=12.33 //y2=2.375
cc_185 ( N_noxref_1_c_88_p N_SN_c_2237_n ) capacitor c=0.00664001f //x=11.22 \
 //y=2.965 //x2=12.33 //y2=2.615
cc_186 ( N_noxref_1_c_183_p N_SN_c_2237_n ) capacitor c=4.16726e-19 //x=11.22 \
 //y=2.26 //x2=12.33 //y2=2.615
cc_187 ( N_noxref_1_c_88_p N_SN_c_2239_n ) capacitor c=0.00775314f //x=11.22 \
 //y=2.965 //x2=12.33 //y2=2.935
cc_188 ( N_noxref_1_c_32_p N_SN_c_2240_n ) capacitor c=0.0110307f //x=11.22 \
 //y=4.755 //x2=12.33 //y2=4.765
cc_189 ( N_noxref_1_c_180_p N_SN_c_2240_n ) capacitor c=2.89813e-19 //x=11.22 \
 //y=4.88 //x2=12.33 //y2=4.765
cc_190 ( N_noxref_1_c_4_p N_SN_c_2240_n ) capacitor c=7.66769e-19 //x=11.785 \
 //y=4.97 //x2=12.33 //y2=4.765
cc_191 ( N_noxref_1_c_191_p N_SN_c_2240_n ) capacitor c=7.54501e-19 //x=11.495 \
 //y=4.97 //x2=12.33 //y2=4.765
cc_192 ( N_noxref_1_c_88_p N_SN_c_2244_n ) capacitor c=0.00508181f //x=11.22 \
 //y=2.965 //x2=12.49 //y2=2.775
cc_193 ( N_noxref_1_c_87_p N_SN_c_2245_n ) capacitor c=5.39999e-19 //x=11.22 \
 //y=2.375 //x2=12.33 //y2=2.26
cc_194 ( N_noxref_1_c_88_p N_SN_c_2245_n ) capacitor c=4.16726e-19 //x=11.22 \
 //y=2.965 //x2=12.33 //y2=2.26
cc_195 ( N_noxref_1_c_183_p N_SN_c_2245_n ) capacitor c=0.00125213f //x=11.22 \
 //y=2.26 //x2=12.33 //y2=2.26
cc_196 ( N_noxref_1_c_184_p N_SN_c_2245_n ) capacitor c=0.00214573f //x=10.92 \
 //y=2.095 //x2=12.33 //y2=2.26
cc_197 ( N_noxref_1_c_32_p N_SN_c_2249_n ) capacitor c=0.00103399f //x=11.22 \
 //y=4.755 //x2=12.33 //y2=4.88
cc_198 ( N_noxref_1_c_180_p N_SN_c_2249_n ) capacitor c=0.00113984f //x=11.22 \
 //y=4.88 //x2=12.33 //y2=4.88
cc_199 ( N_noxref_1_c_4_p N_SN_c_2249_n ) capacitor c=0.00116563f //x=11.785 \
 //y=4.97 //x2=12.33 //y2=4.88
cc_200 ( N_noxref_1_c_191_p N_SN_c_2249_n ) capacitor c=0.00129812f //x=11.495 \
 //y=4.97 //x2=12.33 //y2=4.88
cc_201 ( N_noxref_1_M30_noxref_g N_SN_M32_noxref_g ) capacitor c=0.0106276f \
 //x=11.42 //y=6.2 //x2=12.3 //y2=6.2
cc_202 ( N_noxref_1_M31_noxref_g N_SN_M32_noxref_g ) capacitor c=0.107144f \
 //x=11.86 //y=6.2 //x2=12.3 //y2=6.2
cc_203 ( N_noxref_1_M31_noxref_g N_SN_M33_noxref_g ) capacitor c=0.0101598f \
 //x=11.86 //y=6.2 //x2=12.74 //y2=6.2
cc_204 ( N_noxref_1_c_204_p N_SN_c_2256_n ) capacitor c=5.72528e-19 //x=10.92 \
 //y=1.055 //x2=11.895 //y2=1.09
cc_205 ( N_noxref_1_c_205_p N_SN_c_2256_n ) capacitor c=0.00150277f //x=10.92 \
 //y=1.4 //x2=11.895 //y2=1.09
cc_206 ( N_noxref_1_c_206_p N_SN_c_2256_n ) capacitor c=0.0160123f //x=11.45 \
 //y=1.055 //x2=11.895 //y2=1.09
cc_207 ( N_noxref_1_c_207_p N_SN_c_2259_n ) capacitor c=0.00111227f //x=10.92 \
 //y=1.71 //x2=11.895 //y2=1.4
cc_208 ( N_noxref_1_c_208_p N_SN_c_2259_n ) capacitor c=0.0124075f //x=11.45 \
 //y=1.4 //x2=11.895 //y2=1.4
cc_209 ( N_noxref_1_c_206_p N_SN_c_2261_n ) capacitor c=9.19165e-19 //x=11.45 \
 //y=1.055 //x2=12.42 //y2=1.09
cc_210 ( N_noxref_1_c_208_p N_SN_c_2262_n ) capacitor c=0.0010154f //x=11.45 \
 //y=1.4 //x2=12.42 //y2=1.4
cc_211 ( N_noxref_1_c_208_p N_SN_c_2263_n ) capacitor c=9.23422e-19 //x=11.45 \
 //y=1.4 //x2=12.42 //y2=1.63
cc_212 ( N_noxref_1_c_87_p N_SN_c_2264_n ) capacitor c=0.00140534f //x=11.22 \
 //y=2.375 //x2=12.42 //y2=2.095
cc_213 ( N_noxref_1_c_183_p N_SN_c_2264_n ) capacitor c=0.0020754f //x=11.22 \
 //y=2.26 //x2=12.42 //y2=2.095
cc_214 ( N_noxref_1_c_184_p N_SN_c_2264_n ) capacitor c=0.00964411f //x=10.92 \
 //y=2.095 //x2=12.42 //y2=2.095
cc_215 ( N_noxref_1_c_32_p N_SN_c_2267_n ) capacitor c=0.00116212f //x=11.22 \
 //y=4.755 //x2=12.33 //y2=4.88
cc_216 ( N_noxref_1_c_180_p N_SN_c_2267_n ) capacitor c=0.00155973f //x=11.22 \
 //y=4.88 //x2=12.33 //y2=4.88
cc_217 ( N_noxref_1_c_4_p N_SN_c_2267_n ) capacitor c=0.0171374f //x=11.785 \
 //y=4.97 //x2=12.33 //y2=4.88
cc_218 ( N_noxref_1_c_191_p N_SN_c_2267_n ) capacitor c=0.00484466f //x=11.495 \
 //y=4.97 //x2=12.33 //y2=4.88
cc_219 ( N_noxref_1_c_14_p N_noxref_8_c_2605_n ) capacitor c=0.00253812f \
 //x=7.73 //y=3.13 //x2=8.63 //y2=2.375
cc_220 ( N_noxref_1_c_10_p N_noxref_8_c_2606_n ) capacitor c=0.00109231f \
 //x=6.41 //y=2.985 //x2=8.63 //y2=4.09
cc_221 ( N_noxref_1_c_12_p N_noxref_8_c_2606_n ) capacitor c=0.00127206f \
 //x=6.41 //y=4.755 //x2=8.63 //y2=4.09
cc_222 ( N_noxref_1_c_88_p N_noxref_8_c_2606_n ) capacitor c=0.00171342f \
 //x=11.22 //y=2.965 //x2=8.63 //y2=4.09
cc_223 ( N_noxref_1_c_32_p N_noxref_8_c_2606_n ) capacitor c=9.14054e-19 \
 //x=11.22 //y=4.755 //x2=8.63 //y2=4.09
cc_224 ( N_noxref_1_c_14_p N_noxref_8_c_2606_n ) capacitor c=0.0268271f \
 //x=7.73 //y=3.13 //x2=8.63 //y2=4.09
cc_225 ( N_noxref_1_c_12_p N_noxref_8_c_2611_n ) capacitor c=3.01344e-19 \
 //x=6.41 //y=4.755 //x2=8.63 //y2=4.75
cc_226 ( N_noxref_1_c_32_p N_noxref_8_c_2611_n ) capacitor c=4.57265e-19 \
 //x=11.22 //y=4.755 //x2=8.63 //y2=4.75
cc_227 ( N_noxref_1_c_88_p N_noxref_8_c_2613_n ) capacitor c=0.00118775f \
 //x=11.22 //y=2.965 //x2=13.44 //y2=4.09
cc_228 ( N_noxref_1_c_32_p N_noxref_8_c_2613_n ) capacitor c=4.76323e-19 \
 //x=11.22 //y=4.755 //x2=13.44 //y2=4.09
cc_229 ( N_noxref_1_c_32_p N_noxref_8_c_2615_n ) capacitor c=3.01344e-19 \
 //x=11.22 //y=4.755 //x2=13.44 //y2=4.75
cc_230 ( N_noxref_1_c_32_p N_noxref_8_c_2616_n ) capacitor c=0.0249532f \
 //x=11.22 //y=4.755 //x2=13.595 //y2=4.25
cc_231 ( N_noxref_1_c_153_p N_VDD_c_3497_n ) capacitor c=0.00621352f //x=2.78 \
 //y=5.335 //x2=28.61 //y2=7.58
cc_232 ( N_noxref_1_c_73_p N_VDD_c_3497_n ) capacitor c=0.00627191f //x=3.665 \
 //y=5.335 //x2=28.61 //y2=7.58
cc_233 ( N_noxref_1_c_95_p N_VDD_c_3497_n ) capacitor c=0.00256019f //x=3.78 \
 //y=5.56 //x2=28.61 //y2=7.58
cc_234 ( N_noxref_1_c_74_p N_VDD_c_3497_n ) capacitor c=0.00829247f //x=4.475 \
 //y=5.335 //x2=28.61 //y2=7.58
cc_235 ( N_noxref_1_c_67_p N_VDD_c_3497_n ) capacitor c=4.2417e-19 //x=4.56 \
 //y=3.31 //x2=28.61 //y2=7.58
cc_236 ( N_noxref_1_c_11_p N_VDD_c_3497_n ) capacitor c=3.04695e-19 //x=6.41 \
 //y=3.305 //x2=28.61 //y2=7.58
cc_237 ( N_noxref_1_c_34_p N_VDD_c_3497_n ) capacitor c=3.52629e-19 //x=11.22 \
 //y=3.285 //x2=28.61 //y2=7.58
cc_238 ( N_noxref_1_c_238_p N_VDD_c_3497_n ) capacitor c=0.00261804f //x=2.022 \
 //y=5.335 //x2=28.61 //y2=7.58
cc_239 ( N_noxref_1_c_159_p N_VDD_c_3497_n ) capacitor c=0.00270108f //x=2.9 \
 //y=5.335 //x2=28.61 //y2=7.58
cc_240 ( N_noxref_1_c_240_p N_VDD_c_3497_n ) capacitor c=0.0024232f //x=2.02 \
 //y=5.56 //x2=28.61 //y2=7.58
cc_241 ( N_noxref_1_c_155_p N_VDD_c_3497_n ) capacitor c=0.0024232f //x=2.9 \
 //y=5.56 //x2=28.61 //y2=7.58
cc_242 ( N_noxref_1_c_82_p N_VDD_c_3497_n ) capacitor c=0.0024232f //x=3.78 \
 //y=5.56 //x2=28.61 //y2=7.58
cc_243 ( N_noxref_1_c_238_p N_VDD_c_3509_n ) capacitor c=0.00331944f //x=2.022 \
 //y=5.335 //x2=1.23 //y2=7.58
cc_244 ( N_noxref_1_c_240_p N_VDD_c_3509_n ) capacitor c=0.00509469f //x=2.02 \
 //y=5.56 //x2=1.23 //y2=7.58
cc_245 ( N_noxref_1_c_153_p N_VDD_c_3511_n ) capacitor c=0.00207166f //x=2.78 \
 //y=5.335 //x2=2.375 //y2=7.585
cc_246 ( N_noxref_1_c_238_p N_VDD_c_3511_n ) capacitor c=0.00105965f //x=2.022 \
 //y=5.335 //x2=2.375 //y2=7.585
cc_247 ( N_noxref_1_c_240_p N_VDD_c_3511_n ) capacitor c=0.0138074f //x=2.02 \
 //y=5.56 //x2=2.375 //y2=7.585
cc_248 ( N_noxref_1_c_153_p N_VDD_c_3514_n ) capacitor c=0.00177034f //x=2.78 \
 //y=5.335 //x2=3.255 //y2=7.585
cc_249 ( N_noxref_1_c_73_p N_VDD_c_3514_n ) capacitor c=0.00202922f //x=3.665 \
 //y=5.335 //x2=3.255 //y2=7.585
cc_250 ( N_noxref_1_c_159_p N_VDD_c_3514_n ) capacitor c=9.4817e-19 //x=2.9 \
 //y=5.335 //x2=3.255 //y2=7.585
cc_251 ( N_noxref_1_c_155_p N_VDD_c_3514_n ) capacitor c=0.0138074f //x=2.9 \
 //y=5.56 //x2=3.255 //y2=7.585
cc_252 ( N_noxref_1_c_73_p N_VDD_c_3518_n ) capacitor c=0.00205906f //x=3.665 \
 //y=5.335 //x2=4.135 //y2=7.585
cc_253 ( N_noxref_1_c_95_p N_VDD_c_3518_n ) capacitor c=8.49654e-19 //x=3.78 \
 //y=5.56 //x2=4.135 //y2=7.585
cc_254 ( N_noxref_1_c_74_p N_VDD_c_3518_n ) capacitor c=0.00204238f //x=4.475 \
 //y=5.335 //x2=4.135 //y2=7.585
cc_255 ( N_noxref_1_c_82_p N_VDD_c_3518_n ) capacitor c=0.0135103f //x=3.78 \
 //y=5.56 //x2=4.135 //y2=7.585
cc_256 ( N_noxref_1_c_74_p N_VDD_c_3522_n ) capacitor c=0.00183742f //x=4.475 \
 //y=5.335 //x2=5.13 //y2=7.585
cc_257 ( N_noxref_1_M24_noxref_g N_VDD_c_3523_n ) capacitor c=0.00755614f \
 //x=6.61 //y=6.2 //x2=7.185 //y2=7.585
cc_258 ( N_noxref_1_M25_noxref_g N_VDD_c_3523_n ) capacitor c=0.00755544f \
 //x=7.05 //y=6.2 //x2=7.185 //y2=7.585
cc_259 ( N_noxref_1_M30_noxref_g N_VDD_c_3525_n ) capacitor c=0.00755614f \
 //x=11.42 //y=6.2 //x2=11.995 //y2=7.585
cc_260 ( N_noxref_1_M31_noxref_g N_VDD_c_3525_n ) capacitor c=0.00755544f \
 //x=11.86 //y=6.2 //x2=11.995 //y2=7.585
cc_261 ( N_noxref_1_c_95_p N_VDD_c_3527_n ) capacitor c=0.00282782f //x=3.78 \
 //y=5.56 //x2=5.3 //y2=7.585
cc_262 ( N_noxref_1_c_17_p N_VDD_c_3527_n ) capacitor c=0.0336622f //x=4.56 \
 //y=5.25 //x2=5.3 //y2=7.585
cc_263 ( N_noxref_1_c_12_p N_VDD_c_3527_n ) capacitor c=0.0116604f //x=6.41 \
 //y=4.755 //x2=5.3 //y2=7.585
cc_264 ( N_noxref_1_c_82_p N_VDD_c_3527_n ) capacitor c=0.00777981f //x=3.78 \
 //y=5.56 //x2=5.3 //y2=7.585
cc_265 ( N_noxref_1_c_19_p N_VDD_c_3527_n ) capacitor c=0.00370784f //x=6.41 \
 //y=4.88 //x2=5.3 //y2=7.585
cc_266 ( N_noxref_1_c_30_p N_VDD_c_3527_n ) capacitor c=0.00590568f //x=6.685 \
 //y=4.97 //x2=5.3 //y2=7.585
cc_267 ( N_noxref_1_c_32_p N_VDD_c_3533_n ) capacitor c=0.0113624f //x=11.22 \
 //y=4.755 //x2=10.11 //y2=7.585
cc_268 ( N_noxref_1_c_180_p N_VDD_c_3533_n ) capacitor c=0.00370784f //x=11.22 \
 //y=4.88 //x2=10.11 //y2=7.585
cc_269 ( N_noxref_1_c_191_p N_VDD_c_3533_n ) capacitor c=0.00590568f \
 //x=11.495 //y=4.97 //x2=10.11 //y2=7.585
cc_270 ( N_noxref_1_c_238_p N_VDD_M18_noxref_s ) capacitor c=0.0453361f \
 //x=2.022 //y=5.335 //x2=1.445 //y2=5.2
cc_271 ( N_noxref_1_c_159_p N_VDD_M18_noxref_s ) capacitor c=7.80122e-19 \
 //x=2.9 //y=5.335 //x2=1.445 //y2=5.2
cc_272 ( N_noxref_1_c_240_p N_VDD_M18_noxref_s ) capacitor c=0.09305f //x=2.02 \
 //y=5.56 //x2=1.445 //y2=5.2
cc_273 ( N_noxref_1_c_153_p N_VDD_M19_noxref_d ) capacitor c=0.0077575f \
 //x=2.78 //y=5.335 //x2=2.315 //y2=5.2
cc_274 ( N_noxref_1_c_240_p N_VDD_M19_noxref_d ) capacitor c=0.0674491f \
 //x=2.02 //y=5.56 //x2=2.315 //y2=5.2
cc_275 ( N_noxref_1_c_155_p N_VDD_M19_noxref_d ) capacitor c=0.0674762f \
 //x=2.9 //y=5.56 //x2=2.315 //y2=5.2
cc_276 ( N_noxref_1_c_73_p N_VDD_M21_noxref_d ) capacitor c=0.00700141f \
 //x=3.665 //y=5.335 //x2=3.195 //y2=5.2
cc_277 ( N_noxref_1_c_155_p N_VDD_M21_noxref_d ) capacitor c=0.067493f //x=2.9 \
 //y=5.56 //x2=3.195 //y2=5.2
cc_278 ( N_noxref_1_c_82_p N_VDD_M21_noxref_d ) capacitor c=0.0674979f \
 //x=3.78 //y=5.56 //x2=3.195 //y2=5.2
cc_279 ( N_noxref_1_c_74_p N_VDD_M23_noxref_d ) capacitor c=0.00700141f \
 //x=4.475 //y=5.335 //x2=4.075 //y2=5.2
cc_280 ( N_noxref_1_c_82_p N_VDD_M23_noxref_d ) capacitor c=0.0675002f \
 //x=3.78 //y=5.56 //x2=4.075 //y2=5.2
cc_281 ( N_noxref_1_c_95_p N_VDD_M24_noxref_s ) capacitor c=0.00492616f \
 //x=3.78 //y=5.56 //x2=6.255 //y2=5.2
cc_282 ( N_noxref_1_c_74_p N_VDD_M24_noxref_s ) capacitor c=9.42705e-19 \
 //x=4.475 //y=5.335 //x2=6.255 //y2=5.2
cc_283 ( N_noxref_1_c_11_p N_VDD_M24_noxref_s ) capacitor c=5.05529e-19 \
 //x=6.41 //y=3.305 //x2=6.255 //y2=5.2
cc_284 ( N_noxref_1_c_12_p N_VDD_M24_noxref_s ) capacitor c=0.0217981f \
 //x=6.41 //y=4.755 //x2=6.255 //y2=5.2
cc_285 ( N_noxref_1_c_159_p N_VDD_M24_noxref_s ) capacitor c=2.11884e-19 \
 //x=2.9 //y=5.335 //x2=6.255 //y2=5.2
cc_286 ( N_noxref_1_c_19_p N_VDD_M24_noxref_s ) capacitor c=0.00983413f \
 //x=6.41 //y=4.88 //x2=6.255 //y2=5.2
cc_287 ( N_noxref_1_M24_noxref_g N_VDD_M24_noxref_s ) capacitor c=0.053419f \
 //x=6.61 //y=6.2 //x2=6.255 //y2=5.2
cc_288 ( N_noxref_1_c_30_p N_VDD_M24_noxref_s ) capacitor c=0.00607725f \
 //x=6.685 //y=4.97 //x2=6.255 //y2=5.2
cc_289 ( N_noxref_1_M25_noxref_g N_VDD_M25_noxref_d ) capacitor c=0.015318f \
 //x=7.05 //y=6.2 //x2=7.125 //y2=5.2
cc_290 ( N_noxref_1_c_34_p N_VDD_M30_noxref_s ) capacitor c=4.98099e-19 \
 //x=11.22 //y=3.285 //x2=11.065 //y2=5.2
cc_291 ( N_noxref_1_c_32_p N_VDD_M30_noxref_s ) capacitor c=0.0217981f \
 //x=11.22 //y=4.755 //x2=11.065 //y2=5.2
cc_292 ( N_noxref_1_c_180_p N_VDD_M30_noxref_s ) capacitor c=0.00983846f \
 //x=11.22 //y=4.88 //x2=11.065 //y2=5.2
cc_293 ( N_noxref_1_M30_noxref_g N_VDD_M30_noxref_s ) capacitor c=0.053419f \
 //x=11.42 //y=6.2 //x2=11.065 //y2=5.2
cc_294 ( N_noxref_1_c_191_p N_VDD_M30_noxref_s ) capacitor c=0.00607796f \
 //x=11.495 //y=4.97 //x2=11.065 //y2=5.2
cc_295 ( N_noxref_1_M31_noxref_g N_VDD_M31_noxref_d ) capacitor c=0.015318f \
 //x=11.86 //y=6.2 //x2=11.935 //y2=5.2
cc_296 ( N_noxref_1_c_238_p N_D_M18_noxref_g ) capacitor c=0.00501342f \
 //x=2.022 //y=5.335 //x2=1.8 //y2=6.2
cc_297 ( N_noxref_1_c_240_p N_D_M18_noxref_g ) capacitor c=0.0162284f //x=2.02 \
 //y=5.56 //x2=1.8 //y2=6.2
cc_298 ( N_noxref_1_c_153_p N_D_M19_noxref_g ) capacitor c=0.0130704f //x=2.78 \
 //y=5.335 //x2=2.24 //y2=6.2
cc_299 ( N_noxref_1_c_238_p N_D_M19_noxref_g ) capacitor c=0.00229208f \
 //x=2.022 //y=5.335 //x2=2.24 //y2=6.2
cc_300 ( N_noxref_1_c_240_p N_D_M19_noxref_g ) capacitor c=0.0179041f //x=2.02 \
 //y=5.56 //x2=2.24 //y2=6.2
cc_301 ( N_noxref_1_c_238_p N_D_c_3910_n ) capacitor c=0.00171885f //x=2.022 \
 //y=5.335 //x2=2.165 //y2=4.97
cc_302 ( N_noxref_1_c_240_p N_D_c_3910_n ) capacitor c=0.00291477f //x=2.02 \
 //y=5.56 //x2=2.165 //y2=4.97
cc_303 ( N_noxref_1_c_75_p N_noxref_12_c_4001_n ) capacitor c=0.0036878f \
 //x=4.075 //y=1.305 //x2=4.475 //y2=0.72
cc_304 ( N_noxref_1_c_85_p N_noxref_12_c_4001_n ) capacitor c=0.00366757f \
 //x=4.475 //y=1.845 //x2=4.475 //y2=0.72
cc_305 ( N_noxref_1_M2_noxref_d N_noxref_12_c_4001_n ) capacitor c=0.00949319f \
 //x=3.885 //y=1.095 //x2=4.475 //y2=0.72
cc_306 ( N_noxref_1_M2_noxref_d N_noxref_12_c_4004_n ) capacitor c=0.00120711f \
 //x=3.885 //y=1.095 //x2=3.59 //y2=1.175
cc_307 ( N_noxref_1_c_153_p N_noxref_12_M1_noxref_d ) capacitor c=0.00157145f \
 //x=2.78 //y=5.335 //x2=2.35 //y2=1.09
cc_308 ( N_noxref_1_c_75_p N_noxref_12_M1_noxref_d ) capacitor c=0.00802417f \
 //x=4.075 //y=1.305 //x2=2.35 //y2=1.09
cc_309 ( N_noxref_1_c_75_p N_noxref_12_M2_noxref_s ) capacitor c=0.0098487f \
 //x=4.075 //y=1.305 //x2=3.455 //y2=0.555
cc_310 ( N_noxref_1_c_130_p N_noxref_12_M2_noxref_s ) capacitor c=0.028602f \
 //x=4.075 //y=1.76 //x2=3.455 //y2=0.555
cc_311 ( N_noxref_1_c_85_p N_noxref_12_M2_noxref_s ) capacitor c=0.00820799f \
 //x=4.475 //y=1.845 //x2=3.455 //y2=0.555
cc_312 ( N_noxref_1_c_71_p N_noxref_12_M2_noxref_s ) capacitor c=0.00216661f \
 //x=4.56 //y=3.145 //x2=3.455 //y2=0.555
cc_313 ( N_noxref_1_M2_noxref_d N_noxref_12_M2_noxref_s ) capacitor \
 c=0.0279003f //x=3.885 //y=1.095 //x2=3.455 //y2=0.555
cc_314 ( N_noxref_1_c_14_p N_noxref_13_c_4066_n ) capacitor c=0.00448494f \
 //x=7.73 //y=3.13 //x2=8.315 //y2=1.175
cc_315 ( N_noxref_1_c_75_p N_noxref_13_M4_noxref_d ) capacitor c=3.20746e-19 \
 //x=4.075 //y=1.305 //x2=7.16 //y2=1.09
cc_316 ( N_noxref_1_c_15_p N_noxref_13_M4_noxref_d ) capacitor c=0.00448536f \
 //x=7.3 //y=3.13 //x2=7.16 //y2=1.09
cc_317 ( N_noxref_1_c_14_p N_noxref_13_M5_noxref_s ) capacitor c=0.00315657f \
 //x=7.73 //y=3.13 //x2=8.265 //y2=0.555
cc_318 ( N_noxref_1_c_75_p N_GND_c_4349_n ) capacitor c=0.00901861f //x=4.075 \
 //y=1.305 //x2=6.29 //y2=0.175
cc_319 ( N_noxref_1_c_85_p N_GND_c_4349_n ) capacitor c=0.00713708f //x=4.475 \
 //y=1.845 //x2=6.29 //y2=0.175
cc_320 ( N_noxref_1_c_67_p N_GND_c_4349_n ) capacitor c=5.5476e-19 //x=4.56 \
 //y=3.31 //x2=6.29 //y2=0.175
cc_321 ( N_noxref_1_M2_noxref_d N_GND_c_4349_n ) capacitor c=2.9462e-19 \
 //x=3.885 //y=1.095 //x2=6.29 //y2=0.175
cc_322 ( N_noxref_1_c_50_p N_GND_c_4353_n ) capacitor c=3.97665e-19 //x=6.11 \
 //y=1.055 //x2=6.375 //y2=1.015
cc_323 ( N_noxref_1_c_323_p N_GND_c_4353_n ) capacitor c=0.00864776f //x=6.485 \
 //y=0.9 //x2=6.375 //y2=1.015
cc_324 ( N_noxref_1_c_52_p N_GND_c_4353_n ) capacitor c=4.45447e-19 //x=6.64 \
 //y=1.055 //x2=6.375 //y2=1.015
cc_325 ( N_noxref_1_c_204_p N_GND_c_4356_n ) capacitor c=3.97665e-19 //x=10.92 \
 //y=1.055 //x2=11.185 //y2=1.015
cc_326 ( N_noxref_1_c_326_p N_GND_c_4356_n ) capacitor c=0.00864776f \
 //x=11.295 //y=0.9 //x2=11.185 //y2=1.015
cc_327 ( N_noxref_1_c_206_p N_GND_c_4356_n ) capacitor c=4.45447e-19 //x=11.45 \
 //y=1.055 //x2=11.185 //y2=1.015
cc_328 ( N_noxref_1_c_75_p N_GND_c_4359_n ) capacitor c=0.00543195f //x=4.075 \
 //y=1.305 //x2=6.375 //y2=1.145
cc_329 ( N_noxref_1_c_21_p N_GND_c_4359_n ) capacitor c=0.00814244f //x=6.41 \
 //y=2.375 //x2=6.375 //y2=1.145
cc_330 ( N_noxref_1_c_11_p N_GND_c_4359_n ) capacitor c=8.56802e-19 //x=6.41 \
 //y=3.305 //x2=6.375 //y2=1.145
cc_331 ( N_noxref_1_c_15_p N_GND_c_4359_n ) capacitor c=0.00273258f //x=7.3 \
 //y=3.13 //x2=6.375 //y2=1.145
cc_332 ( N_noxref_1_c_16_p N_GND_c_4359_n ) capacitor c=2.22883e-19 //x=6.41 \
 //y=2.26 //x2=6.375 //y2=1.145
cc_333 ( N_noxref_1_c_50_p N_GND_c_4359_n ) capacitor c=0.00156339f //x=6.11 \
 //y=1.055 //x2=6.375 //y2=1.145
cc_334 ( N_noxref_1_c_51_p N_GND_c_4359_n ) capacitor c=0.00352472f //x=6.11 \
 //y=1.4 //x2=6.375 //y2=1.145
cc_335 ( N_noxref_1_c_53_p N_GND_c_4359_n ) capacitor c=4.2791e-19 //x=6.11 \
 //y=1.71 //x2=6.375 //y2=1.145
cc_336 ( N_noxref_1_c_323_p N_GND_c_4359_n ) capacitor c=9.36995e-19 //x=6.485 \
 //y=0.9 //x2=6.375 //y2=1.145
cc_337 ( N_noxref_1_c_337_p N_GND_c_4359_n ) capacitor c=5.57281e-19 //x=6.485 \
 //y=1.555 //x2=6.375 //y2=1.145
cc_338 ( N_noxref_1_c_52_p N_GND_c_4359_n ) capacitor c=0.0017438f //x=6.64 \
 //y=1.055 //x2=6.375 //y2=1.145
cc_339 ( N_noxref_1_c_54_p N_GND_c_4359_n ) capacitor c=0.00276804f //x=6.64 \
 //y=1.4 //x2=6.375 //y2=1.145
cc_340 ( N_noxref_1_c_87_p N_GND_c_4371_n ) capacitor c=0.00813403f //x=11.22 \
 //y=2.375 //x2=11.185 //y2=1.145
cc_341 ( N_noxref_1_c_34_p N_GND_c_4371_n ) capacitor c=9.68888e-19 //x=11.22 \
 //y=3.285 //x2=11.185 //y2=1.145
cc_342 ( N_noxref_1_c_14_p N_GND_c_4371_n ) capacitor c=0.00280942f //x=7.73 \
 //y=3.13 //x2=11.185 //y2=1.145
cc_343 ( N_noxref_1_c_183_p N_GND_c_4371_n ) capacitor c=2.22883e-19 //x=11.22 \
 //y=2.26 //x2=11.185 //y2=1.145
cc_344 ( N_noxref_1_c_204_p N_GND_c_4371_n ) capacitor c=0.00156339f //x=10.92 \
 //y=1.055 //x2=11.185 //y2=1.145
cc_345 ( N_noxref_1_c_205_p N_GND_c_4371_n ) capacitor c=0.00352472f //x=10.92 \
 //y=1.4 //x2=11.185 //y2=1.145
cc_346 ( N_noxref_1_c_207_p N_GND_c_4371_n ) capacitor c=4.08676e-19 //x=10.92 \
 //y=1.71 //x2=11.185 //y2=1.145
cc_347 ( N_noxref_1_c_326_p N_GND_c_4371_n ) capacitor c=9.36995e-19 \
 //x=11.295 //y=0.9 //x2=11.185 //y2=1.145
cc_348 ( N_noxref_1_c_348_p N_GND_c_4371_n ) capacitor c=5.55901e-19 \
 //x=11.295 //y=1.555 //x2=11.185 //y2=1.145
cc_349 ( N_noxref_1_c_206_p N_GND_c_4371_n ) capacitor c=0.0017438f //x=11.45 \
 //y=1.055 //x2=11.185 //y2=1.145
cc_350 ( N_noxref_1_c_208_p N_GND_c_4371_n ) capacitor c=0.00276804f //x=11.45 \
 //y=1.4 //x2=11.185 //y2=1.145
cc_351 ( N_noxref_1_c_85_p N_GND_c_4382_n ) capacitor c=6.86343e-19 //x=4.475 \
 //y=1.845 //x2=5.13 //y2=0.175
cc_352 ( N_noxref_1_c_67_p N_GND_c_4382_n ) capacitor c=4.86635e-19 //x=4.56 \
 //y=3.31 //x2=5.13 //y2=0.175
cc_353 ( N_noxref_1_c_50_p N_GND_c_4384_n ) capacitor c=0.00677849f //x=6.11 \
 //y=1.055 //x2=9.94 //y2=0.175
cc_354 ( N_noxref_1_c_204_p N_GND_c_4385_n ) capacitor c=0.00677849f //x=10.92 \
 //y=1.055 //x2=14.75 //y2=0.175
cc_355 ( N_noxref_1_c_130_p N_GND_c_4386_n ) capacitor c=0.0045138f //x=4.075 \
 //y=1.76 //x2=5.3 //y2=0.175
cc_356 ( N_noxref_1_c_85_p N_GND_c_4386_n ) capacitor c=0.0349977f //x=4.475 \
 //y=1.845 //x2=5.3 //y2=0.175
cc_357 ( N_noxref_1_c_21_p N_GND_c_4386_n ) capacitor c=0.00407472f //x=6.41 \
 //y=2.375 //x2=5.3 //y2=0.175
cc_358 ( N_noxref_1_c_10_p N_GND_c_4386_n ) capacitor c=0.0118341f //x=6.41 \
 //y=2.985 //x2=5.3 //y2=0.175
cc_359 ( N_noxref_1_c_105_p N_GND_c_4386_n ) capacitor c=0.00722808f //x=6.25 \
 //y=3.145 //x2=5.3 //y2=0.175
cc_360 ( N_noxref_1_c_16_p N_GND_c_4386_n ) capacitor c=0.00394651f //x=6.41 \
 //y=2.26 //x2=5.3 //y2=0.175
cc_361 ( N_noxref_1_c_53_p N_GND_c_4386_n ) capacitor c=0.00170145f //x=6.11 \
 //y=1.71 //x2=5.3 //y2=0.175
cc_362 ( N_noxref_1_c_24_p N_GND_c_4386_n ) capacitor c=0.0103608f //x=6.11 \
 //y=2.095 //x2=5.3 //y2=0.175
cc_363 ( N_noxref_1_c_87_p N_GND_c_4394_n ) capacitor c=0.00407472f //x=11.22 \
 //y=2.375 //x2=10.11 //y2=0.175
cc_364 ( N_noxref_1_c_88_p N_GND_c_4394_n ) capacitor c=0.00907221f //x=11.22 \
 //y=2.965 //x2=10.11 //y2=0.175
cc_365 ( N_noxref_1_c_14_p N_GND_c_4394_n ) capacitor c=0.00722808f //x=7.73 \
 //y=3.13 //x2=10.11 //y2=0.175
cc_366 ( N_noxref_1_c_183_p N_GND_c_4394_n ) capacitor c=0.00394651f //x=11.22 \
 //y=2.26 //x2=10.11 //y2=0.175
cc_367 ( N_noxref_1_c_207_p N_GND_c_4394_n ) capacitor c=0.00170145f //x=10.92 \
 //y=1.71 //x2=10.11 //y2=0.175
cc_368 ( N_noxref_1_c_184_p N_GND_c_4394_n ) capacitor c=0.0103608f //x=10.92 \
 //y=2.095 //x2=10.11 //y2=0.175
cc_369 ( N_noxref_1_c_21_p N_GND_M3_noxref_d ) capacitor c=4.4417e-19 //x=6.41 \
 //y=2.375 //x2=6.185 //y2=1.055
cc_370 ( N_noxref_1_c_50_p N_GND_M3_noxref_d ) capacitor c=0.00184354f \
 //x=6.11 //y=1.055 //x2=6.185 //y2=1.055
cc_371 ( N_noxref_1_c_51_p N_GND_M3_noxref_d ) capacitor c=0.00210798f \
 //x=6.11 //y=1.4 //x2=6.185 //y2=1.055
cc_372 ( N_noxref_1_c_323_p N_GND_M3_noxref_d ) capacitor c=0.00474029f \
 //x=6.485 //y=0.9 //x2=6.185 //y2=1.055
cc_373 ( N_noxref_1_c_337_p N_GND_M3_noxref_d ) capacitor c=0.00166857f \
 //x=6.485 //y=1.555 //x2=6.185 //y2=1.055
cc_374 ( N_noxref_1_c_52_p N_GND_M3_noxref_d ) capacitor c=0.00230174f \
 //x=6.64 //y=1.055 //x2=6.185 //y2=1.055
cc_375 ( N_noxref_1_c_54_p N_GND_M3_noxref_d ) capacitor c=0.00210798f \
 //x=6.64 //y=1.4 //x2=6.185 //y2=1.055
cc_376 ( N_noxref_1_c_87_p N_GND_M6_noxref_d ) capacitor c=4.4417e-19 \
 //x=11.22 //y=2.375 //x2=10.995 //y2=1.055
cc_377 ( N_noxref_1_c_204_p N_GND_M6_noxref_d ) capacitor c=0.00184354f \
 //x=10.92 //y=1.055 //x2=10.995 //y2=1.055
cc_378 ( N_noxref_1_c_205_p N_GND_M6_noxref_d ) capacitor c=0.00210798f \
 //x=10.92 //y=1.4 //x2=10.995 //y2=1.055
cc_379 ( N_noxref_1_c_326_p N_GND_M6_noxref_d ) capacitor c=0.00474029f \
 //x=11.295 //y=0.9 //x2=10.995 //y2=1.055
cc_380 ( N_noxref_1_c_348_p N_GND_M6_noxref_d ) capacitor c=0.00166857f \
 //x=11.295 //y=1.555 //x2=10.995 //y2=1.055
cc_381 ( N_noxref_1_c_206_p N_GND_M6_noxref_d ) capacitor c=0.00230174f \
 //x=11.45 //y=1.055 //x2=10.995 //y2=1.055
cc_382 ( N_noxref_1_c_208_p N_GND_M6_noxref_d ) capacitor c=0.00210798f \
 //x=11.45 //y=1.4 //x2=10.995 //y2=1.055
cc_383 ( N_noxref_1_c_105_p N_noxref_20_c_4949_n ) capacitor c=0.00318305f \
 //x=6.25 //y=3.145 //x2=5.89 //y2=1.685
cc_384 ( N_noxref_1_c_24_p N_noxref_20_c_4949_n ) capacitor c=0.00262672f \
 //x=6.11 //y=2.095 //x2=5.89 //y2=1.685
cc_385 ( N_noxref_1_c_21_p N_noxref_20_c_4951_n ) capacitor c=0.00428451f \
 //x=6.41 //y=2.375 //x2=6.775 //y2=1.77
cc_386 ( N_noxref_1_c_11_p N_noxref_20_c_4951_n ) capacitor c=0.00258852f \
 //x=6.41 //y=3.305 //x2=6.775 //y2=1.77
cc_387 ( N_noxref_1_c_105_p N_noxref_20_c_4951_n ) capacitor c=0.0056247f \
 //x=6.25 //y=3.145 //x2=6.775 //y2=1.77
cc_388 ( N_noxref_1_c_15_p N_noxref_20_c_4951_n ) capacitor c=0.00172959f \
 //x=7.3 //y=3.13 //x2=6.775 //y2=1.77
cc_389 ( N_noxref_1_c_16_p N_noxref_20_c_4951_n ) capacitor c=0.0104666f \
 //x=6.41 //y=2.26 //x2=6.775 //y2=1.77
cc_390 ( N_noxref_1_c_53_p N_noxref_20_c_4951_n ) capacitor c=0.00705077f \
 //x=6.11 //y=1.71 //x2=6.775 //y2=1.77
cc_391 ( N_noxref_1_c_24_p N_noxref_20_c_4951_n ) capacitor c=0.0213793f \
 //x=6.11 //y=2.095 //x2=6.775 //y2=1.77
cc_392 ( N_noxref_1_c_337_p N_noxref_20_c_4951_n ) capacitor c=0.00588627f \
 //x=6.485 //y=1.555 //x2=6.775 //y2=1.77
cc_393 ( N_noxref_1_c_54_p N_noxref_20_c_4951_n ) capacitor c=0.00698822f \
 //x=6.64 //y=1.4 //x2=6.775 //y2=1.77
cc_394 ( N_noxref_1_c_15_p N_noxref_20_c_4960_n ) capacitor c=0.00914927f \
 //x=7.3 //y=3.13 //x2=7.745 //y2=1.77
cc_395 ( N_noxref_1_c_14_p N_noxref_20_M3_noxref_s ) capacitor c=0.00281052f \
 //x=7.73 //y=3.13 //x2=5.755 //y2=0.555
cc_396 ( N_noxref_1_c_15_p N_noxref_20_M3_noxref_s ) capacitor c=0.00318305f \
 //x=7.3 //y=3.13 //x2=5.755 //y2=0.555
cc_397 ( N_noxref_1_c_50_p N_noxref_20_M3_noxref_s ) capacitor c=0.0295256f \
 //x=6.11 //y=1.055 //x2=5.755 //y2=0.555
cc_398 ( N_noxref_1_c_53_p N_noxref_20_M3_noxref_s ) capacitor c=7.99997e-19 \
 //x=6.11 //y=1.71 //x2=5.755 //y2=0.555
cc_399 ( N_noxref_1_c_24_p N_noxref_20_M3_noxref_s ) capacitor c=0.00122123f \
 //x=6.11 //y=2.095 //x2=5.755 //y2=0.555
cc_400 ( N_noxref_1_c_52_p N_noxref_20_M3_noxref_s ) capacitor c=0.0125924f \
 //x=6.64 //y=1.055 //x2=5.755 //y2=0.555
cc_401 ( N_noxref_1_c_14_p N_noxref_21_c_5010_n ) capacitor c=0.00318305f \
 //x=7.73 //y=3.13 //x2=10.7 //y2=1.685
cc_402 ( N_noxref_1_c_184_p N_noxref_21_c_5010_n ) capacitor c=0.00262672f \
 //x=10.92 //y=2.095 //x2=10.7 //y2=1.685
cc_403 ( N_noxref_1_c_87_p N_noxref_21_c_5012_n ) capacitor c=0.00428451f \
 //x=11.22 //y=2.375 //x2=11.585 //y2=1.77
cc_404 ( N_noxref_1_c_34_p N_noxref_21_c_5012_n ) capacitor c=0.00332992f \
 //x=11.22 //y=3.285 //x2=11.585 //y2=1.77
cc_405 ( N_noxref_1_c_14_p N_noxref_21_c_5012_n ) capacitor c=0.00363969f \
 //x=7.73 //y=3.13 //x2=11.585 //y2=1.77
cc_406 ( N_noxref_1_c_183_p N_noxref_21_c_5012_n ) capacitor c=0.0104666f \
 //x=11.22 //y=2.26 //x2=11.585 //y2=1.77
cc_407 ( N_noxref_1_c_207_p N_noxref_21_c_5012_n ) capacitor c=0.00705077f \
 //x=10.92 //y=1.71 //x2=11.585 //y2=1.77
cc_408 ( N_noxref_1_c_184_p N_noxref_21_c_5012_n ) capacitor c=0.0206583f \
 //x=10.92 //y=2.095 //x2=11.585 //y2=1.77
cc_409 ( N_noxref_1_c_348_p N_noxref_21_c_5012_n ) capacitor c=0.00588627f \
 //x=11.295 //y=1.555 //x2=11.585 //y2=1.77
cc_410 ( N_noxref_1_c_208_p N_noxref_21_c_5012_n ) capacitor c=0.00698822f \
 //x=11.45 //y=1.4 //x2=11.585 //y2=1.77
cc_411 ( N_noxref_1_c_204_p N_noxref_21_M6_noxref_s ) capacitor c=0.0295256f \
 //x=10.92 //y=1.055 //x2=10.565 //y2=0.555
cc_412 ( N_noxref_1_c_207_p N_noxref_21_M6_noxref_s ) capacitor c=7.99997e-19 \
 //x=10.92 //y=1.71 //x2=10.565 //y2=0.555
cc_413 ( N_noxref_1_c_184_p N_noxref_21_M6_noxref_s ) capacitor c=0.00122123f \
 //x=10.92 //y=2.095 //x2=10.565 //y2=0.555
cc_414 ( N_noxref_1_c_206_p N_noxref_21_M6_noxref_s ) capacitor c=0.0125924f \
 //x=11.45 //y=1.055 //x2=10.565 //y2=0.555
cc_415 ( N_noxref_2_c_423_p CLK ) capacitor c=8.917e-19 //x=14.18 //y=2.98 \
 //x2=17.14 //y2=3.14
cc_416 ( N_noxref_2_c_424_p CLK ) capacitor c=0.0147362f //x=16.03 //y=2.975 \
 //x2=17.14 //y2=3.14
cc_417 ( N_noxref_2_c_425_p CLK ) capacitor c=0.00775314f //x=16.03 //y=3.295 \
 //x2=17.14 //y2=3.14
cc_418 ( N_noxref_2_c_426_p CLK ) capacitor c=0.00120098f //x=16.03 //y=4.755 \
 //x2=17.14 //y2=3.14
cc_419 ( N_noxref_2_c_427_p CLK ) capacitor c=2.98349e-19 //x=16.03 //y=3.14 \
 //x2=17.14 //y2=3.14
cc_420 ( N_noxref_2_c_428_p CLK ) capacitor c=0.00508571f //x=16.03 //y=3.135 \
 //x2=17.14 //y2=3.14
cc_421 ( N_noxref_2_c_429_p CLK ) capacitor c=4.16726e-19 //x=16.03 //y=2.26 \
 //x2=17.14 //y2=3.14
cc_422 ( N_noxref_2_c_426_p CLK ) capacitor c=5.01652e-19 //x=16.03 //y=4.755 \
 //x2=17.14 //y2=3.51
cc_423 ( N_noxref_2_c_431_p N_CLK_c_772_n ) capacitor c=0.0115546f //x=16.03 \
 //y=2.375 //x2=17.14 //y2=2.375
cc_424 ( N_noxref_2_c_429_p N_CLK_c_772_n ) capacitor c=5.40058e-19 //x=16.03 \
 //y=2.26 //x2=17.14 //y2=2.375
cc_425 ( N_noxref_2_c_433_p N_CLK_c_772_n ) capacitor c=0.00147006f //x=15.73 \
 //y=2.095 //x2=17.14 //y2=2.375
cc_426 ( N_noxref_2_c_426_p N_CLK_c_775_n ) capacitor c=0.00785119f //x=16.03 \
 //y=4.755 //x2=17.14 //y2=3.655
cc_427 ( N_noxref_2_c_435_p N_CLK_c_776_n ) capacitor c=8.17995e-19 //x=14.18 \
 //y=5.25 //x2=17.14 //y2=4.765
cc_428 ( N_noxref_2_c_426_p N_CLK_c_776_n ) capacitor c=0.0350583f //x=16.03 \
 //y=4.755 //x2=17.14 //y2=4.765
cc_429 ( N_noxref_2_c_437_p N_CLK_c_776_n ) capacitor c=6.26008e-19 //x=16.03 \
 //y=4.88 //x2=17.14 //y2=4.765
cc_430 ( N_noxref_2_c_438_p N_CLK_c_776_n ) capacitor c=7.66769e-19 //x=16.595 \
 //y=4.97 //x2=17.14 //y2=4.765
cc_431 ( N_noxref_2_c_439_p N_CLK_c_776_n ) capacitor c=7.54501e-19 //x=16.305 \
 //y=4.97 //x2=17.14 //y2=4.765
cc_432 ( N_noxref_2_c_440_p N_CLK_c_733_n ) capacitor c=0.00145671f //x=14.18 \
 //y=3.3 //x2=13.795 //y2=3.51
cc_433 ( N_noxref_2_c_435_p N_CLK_c_733_n ) capacitor c=3.12067e-19 //x=14.18 \
 //y=5.25 //x2=13.795 //y2=3.51
cc_434 ( N_noxref_2_c_442_p N_CLK_c_733_n ) capacitor c=0.0358254f //x=14.34 \
 //y=3.14 //x2=13.795 //y2=3.51
cc_435 ( N_noxref_2_c_440_p N_CLK_c_784_n ) capacitor c=0.00778319f //x=14.18 \
 //y=3.3 //x2=14.395 //y2=3.525
cc_436 ( N_noxref_2_c_435_p N_CLK_c_784_n ) capacitor c=0.0226562f //x=14.18 \
 //y=5.25 //x2=14.395 //y2=3.525
cc_437 ( N_noxref_2_c_445_p N_CLK_c_784_n ) capacitor c=0.127608f //x=15.87 \
 //y=3.135 //x2=14.395 //y2=3.525
cc_438 ( N_noxref_2_c_425_p N_CLK_c_787_n ) capacitor c=0.00357893f //x=16.03 \
 //y=3.295 //x2=15.645 //y2=3.51
cc_439 ( N_noxref_2_c_426_p N_CLK_c_787_n ) capacitor c=5.02803e-19 //x=16.03 \
 //y=4.755 //x2=15.645 //y2=3.51
cc_440 ( N_noxref_2_c_428_p N_CLK_c_787_n ) capacitor c=0.0353327f //x=16.03 \
 //y=3.135 //x2=15.645 //y2=3.51
cc_441 ( N_noxref_2_c_445_p N_CLK_c_787_n ) capacitor c=0.0108538f //x=15.87 \
 //y=3.135 //x2=15.645 //y2=3.51
cc_442 ( N_noxref_2_c_425_p N_CLK_c_791_n ) capacitor c=0.00282302f //x=16.03 \
 //y=3.295 //x2=16.245 //y2=3.525
cc_443 ( N_noxref_2_c_426_p N_CLK_c_791_n ) capacitor c=0.0257638f //x=16.03 \
 //y=4.755 //x2=16.245 //y2=3.525
cc_444 ( N_noxref_2_c_431_p N_CLK_c_793_n ) capacitor c=5.39999e-19 //x=16.03 \
 //y=2.375 //x2=17.14 //y2=2.26
cc_445 ( N_noxref_2_c_424_p N_CLK_c_793_n ) capacitor c=4.16726e-19 //x=16.03 \
 //y=2.975 //x2=17.14 //y2=2.26
cc_446 ( N_noxref_2_c_429_p N_CLK_c_793_n ) capacitor c=0.00125213f //x=16.03 \
 //y=2.26 //x2=17.14 //y2=2.26
cc_447 ( N_noxref_2_c_433_p N_CLK_c_793_n ) capacitor c=0.00214573f //x=15.73 \
 //y=2.095 //x2=17.14 //y2=2.26
cc_448 ( N_noxref_2_c_426_p N_CLK_c_797_n ) capacitor c=0.00103399f //x=16.03 \
 //y=4.755 //x2=17.14 //y2=4.88
cc_449 ( N_noxref_2_c_437_p N_CLK_c_797_n ) capacitor c=0.00113984f //x=16.03 \
 //y=4.88 //x2=17.14 //y2=4.88
cc_450 ( N_noxref_2_c_438_p N_CLK_c_797_n ) capacitor c=0.00116563f //x=16.595 \
 //y=4.97 //x2=17.14 //y2=4.88
cc_451 ( N_noxref_2_c_439_p N_CLK_c_797_n ) capacitor c=0.00129812f //x=16.305 \
 //y=4.97 //x2=17.14 //y2=4.88
cc_452 ( N_noxref_2_M36_noxref_g N_CLK_M38_noxref_g ) capacitor c=0.0106276f \
 //x=16.23 //y=6.2 //x2=17.11 //y2=6.2
cc_453 ( N_noxref_2_M37_noxref_g N_CLK_M38_noxref_g ) capacitor c=0.107144f \
 //x=16.67 //y=6.2 //x2=17.11 //y2=6.2
cc_454 ( N_noxref_2_M37_noxref_g N_CLK_M39_noxref_g ) capacitor c=0.0101598f \
 //x=16.67 //y=6.2 //x2=17.55 //y2=6.2
cc_455 ( N_noxref_2_c_463_p N_CLK_c_804_n ) capacitor c=5.72528e-19 //x=15.73 \
 //y=1.055 //x2=16.705 //y2=1.09
cc_456 ( N_noxref_2_c_464_p N_CLK_c_804_n ) capacitor c=0.00150277f //x=15.73 \
 //y=1.4 //x2=16.705 //y2=1.09
cc_457 ( N_noxref_2_c_465_p N_CLK_c_804_n ) capacitor c=0.0160123f //x=16.26 \
 //y=1.055 //x2=16.705 //y2=1.09
cc_458 ( N_noxref_2_c_466_p N_CLK_c_807_n ) capacitor c=0.00111227f //x=15.73 \
 //y=1.71 //x2=16.705 //y2=1.4
cc_459 ( N_noxref_2_c_467_p N_CLK_c_807_n ) capacitor c=0.0124075f //x=16.26 \
 //y=1.4 //x2=16.705 //y2=1.4
cc_460 ( N_noxref_2_c_465_p N_CLK_c_809_n ) capacitor c=9.19165e-19 //x=16.26 \
 //y=1.055 //x2=17.23 //y2=1.09
cc_461 ( N_noxref_2_c_467_p N_CLK_c_810_n ) capacitor c=0.0010154f //x=16.26 \
 //y=1.4 //x2=17.23 //y2=1.4
cc_462 ( N_noxref_2_c_467_p N_CLK_c_811_n ) capacitor c=9.23422e-19 //x=16.26 \
 //y=1.4 //x2=17.23 //y2=1.63
cc_463 ( N_noxref_2_c_431_p N_CLK_c_812_n ) capacitor c=0.00140534f //x=16.03 \
 //y=2.375 //x2=17.23 //y2=2.095
cc_464 ( N_noxref_2_c_429_p N_CLK_c_812_n ) capacitor c=0.0020754f //x=16.03 \
 //y=2.26 //x2=17.23 //y2=2.095
cc_465 ( N_noxref_2_c_433_p N_CLK_c_812_n ) capacitor c=0.00964411f //x=15.73 \
 //y=2.095 //x2=17.23 //y2=2.095
cc_466 ( N_noxref_2_c_426_p N_CLK_c_815_n ) capacitor c=0.00116212f //x=16.03 \
 //y=4.755 //x2=17.14 //y2=4.88
cc_467 ( N_noxref_2_c_437_p N_CLK_c_815_n ) capacitor c=0.00155973f //x=16.03 \
 //y=4.88 //x2=17.14 //y2=4.88
cc_468 ( N_noxref_2_c_438_p N_CLK_c_815_n ) capacitor c=0.0171374f //x=16.595 \
 //y=4.97 //x2=17.14 //y2=4.88
cc_469 ( N_noxref_2_c_439_p N_CLK_c_815_n ) capacitor c=0.00484466f //x=16.305 \
 //y=4.97 //x2=17.14 //y2=4.88
cc_470 ( N_noxref_2_c_416_n N_noxref_4_c_1124_n ) capacitor c=6.09703e-19 \
 //x=11.642 //y=5.335 //x2=8.59 //y2=5.56
cc_471 ( N_noxref_2_c_416_n N_noxref_4_c_1125_n ) capacitor c=0.00306432f \
 //x=11.642 //y=5.335 //x2=9.285 //y2=5.335
cc_472 ( N_noxref_2_c_480_p N_noxref_4_c_1126_n ) capacitor c=0.00163399f \
 //x=13.78 //y=1.845 //x2=9.285 //y2=1.845
cc_473 ( N_noxref_2_c_435_p N_noxref_4_c_1127_n ) capacitor c=5.83746e-19 \
 //x=14.18 //y=5.25 //x2=13.65 //y2=3.865
cc_474 ( N_noxref_2_c_435_p N_noxref_4_c_1128_n ) capacitor c=0.0229999f \
 //x=14.18 //y=5.25 //x2=18.605 //y2=3.88
cc_475 ( N_noxref_2_c_426_p N_noxref_4_c_1128_n ) capacitor c=0.0246527f \
 //x=16.03 //y=4.755 //x2=18.605 //y2=3.88
cc_476 ( N_noxref_2_c_445_p N_noxref_4_c_1128_n ) capacitor c=0.0102655f \
 //x=15.87 //y=3.135 //x2=18.605 //y2=3.88
cc_477 ( N_noxref_2_c_424_p RN ) capacitor c=7.3525e-19 //x=16.03 //y=2.975 \
 //x2=18.25 //y2=3.14
cc_478 ( N_noxref_2_c_426_p RN ) capacitor c=0.00174145f //x=16.03 //y=4.755 \
 //x2=18.25 //y2=3.14
cc_479 ( N_noxref_2_c_487_p N_RN_c_1523_n ) capacitor c=0.00351f //x=13.285 \
 //y=5.335 //x2=13.05 //y2=4.62
cc_480 ( N_noxref_2_c_416_n N_RN_c_1523_n ) capacitor c=0.0297308f //x=11.642 \
 //y=5.335 //x2=13.05 //y2=4.62
cc_481 ( N_noxref_2_c_489_p N_RN_c_1523_n ) capacitor c=0.0296589f //x=12.52 \
 //y=5.335 //x2=13.05 //y2=4.62
cc_482 ( N_noxref_2_c_490_p N_RN_c_1541_n ) capacitor c=0.00838291f //x=14.095 \
 //y=5.335 //x2=13.65 //y2=4.635
cc_483 ( N_noxref_2_c_491_p N_RN_c_1541_n ) capacitor c=0.00351f //x=13.4 \
 //y=5.335 //x2=13.65 //y2=4.635
cc_484 ( N_noxref_2_c_490_p N_RN_c_1543_n ) capacitor c=0.0131492f //x=14.095 \
 //y=5.335 //x2=18.855 //y2=4.632
cc_485 ( N_noxref_2_c_435_p N_RN_c_1543_n ) capacitor c=0.0304824f //x=14.18 \
 //y=5.25 //x2=18.855 //y2=4.632
cc_486 ( N_noxref_2_c_426_p N_RN_c_1543_n ) capacitor c=0.0327604f //x=16.03 \
 //y=4.755 //x2=18.855 //y2=4.632
cc_487 ( N_noxref_2_c_435_p SN ) capacitor c=0.00174755f //x=14.18 //y=5.25 \
 //x2=12.33 //y2=3.14
cc_488 ( N_noxref_2_c_423_p N_SN_c_2237_n ) capacitor c=5.9702e-19 //x=14.18 \
 //y=2.98 //x2=12.33 //y2=2.615
cc_489 ( N_noxref_2_c_415_n N_SN_c_2239_n ) capacitor c=4.00712e-19 //x=12.4 \
 //y=5.335 //x2=12.33 //y2=2.935
cc_490 ( N_noxref_2_c_489_p N_SN_c_2239_n ) capacitor c=0.00123389f //x=12.52 \
 //y=5.335 //x2=12.33 //y2=2.935
cc_491 ( N_noxref_2_c_499_p N_SN_c_2239_n ) capacitor c=3.89771e-19 //x=12.52 \
 //y=5.56 //x2=12.33 //y2=2.935
cc_492 ( N_noxref_2_c_415_n N_SN_c_2240_n ) capacitor c=0.0213631f //x=12.4 \
 //y=5.335 //x2=12.33 //y2=4.765
cc_493 ( N_noxref_2_c_489_p N_SN_c_2240_n ) capacitor c=0.00239361f //x=12.52 \
 //y=5.335 //x2=12.33 //y2=4.765
cc_494 ( N_noxref_2_c_499_p N_SN_c_2240_n ) capacitor c=6.21282e-19 //x=12.52 \
 //y=5.56 //x2=12.33 //y2=4.765
cc_495 ( N_noxref_2_c_503_p N_SN_c_2279_n ) capacitor c=5.19208e-19 //x=13.695 \
 //y=1.305 //x2=13.795 //y2=2.77
cc_496 ( N_noxref_2_c_504_p N_SN_c_2279_n ) capacitor c=0.00571042f //x=14.095 \
 //y=1.845 //x2=13.795 //y2=2.77
cc_497 ( N_noxref_2_c_480_p N_SN_c_2279_n ) capacitor c=0.00831979f //x=13.78 \
 //y=1.845 //x2=13.795 //y2=2.77
cc_498 ( N_noxref_2_c_423_p N_SN_c_2279_n ) capacitor c=3.29006e-19 //x=14.18 \
 //y=2.98 //x2=13.795 //y2=2.77
cc_499 ( N_noxref_2_c_423_p N_SN_c_2283_n ) capacitor c=0.0278947f //x=14.18 \
 //y=2.98 //x2=14.395 //y2=2.755
cc_500 ( N_noxref_2_c_440_p N_SN_c_2283_n ) capacitor c=0.00855251f //x=14.18 \
 //y=3.3 //x2=14.395 //y2=2.755
cc_501 ( N_noxref_2_c_442_p N_SN_c_2283_n ) capacitor c=0.0365231f //x=14.34 \
 //y=3.14 //x2=14.395 //y2=2.755
cc_502 ( N_noxref_2_c_445_p N_SN_c_2283_n ) capacitor c=0.133271f //x=15.87 \
 //y=3.135 //x2=14.395 //y2=2.755
cc_503 ( N_noxref_2_c_424_p N_SN_c_2287_n ) capacitor c=6.71362e-19 //x=16.03 \
 //y=2.975 //x2=15.645 //y2=2.77
cc_504 ( N_noxref_2_c_425_p N_SN_c_2287_n ) capacitor c=0.00329487f //x=16.03 \
 //y=3.295 //x2=15.645 //y2=2.77
cc_505 ( N_noxref_2_c_445_p N_SN_c_2287_n ) capacitor c=0.0109387f //x=15.87 \
 //y=3.135 //x2=15.645 //y2=2.77
cc_506 ( N_noxref_2_c_431_p N_SN_c_2290_n ) capacitor c=0.00248707f //x=16.03 \
 //y=2.375 //x2=16.245 //y2=2.75
cc_507 ( N_noxref_2_c_424_p N_SN_c_2290_n ) capacitor c=0.0278999f //x=16.03 \
 //y=2.975 //x2=16.245 //y2=2.75
cc_508 ( N_noxref_2_c_425_p N_SN_c_2290_n ) capacitor c=0.00478734f //x=16.03 \
 //y=3.295 //x2=16.245 //y2=2.75
cc_509 ( N_noxref_2_c_428_p N_SN_c_2290_n ) capacitor c=0.0365231f //x=16.03 \
 //y=3.135 //x2=16.245 //y2=2.75
cc_510 ( N_noxref_2_c_415_n N_SN_c_2249_n ) capacitor c=0.00492634f //x=12.4 \
 //y=5.335 //x2=12.33 //y2=4.88
cc_511 ( N_noxref_2_c_489_p N_SN_c_2249_n ) capacitor c=0.00132214f //x=12.52 \
 //y=5.335 //x2=12.33 //y2=4.88
cc_512 ( N_noxref_2_c_415_n N_SN_M32_noxref_g ) capacitor c=0.00858241f \
 //x=12.4 //y=5.335 //x2=12.3 //y2=6.2
cc_513 ( N_noxref_2_c_489_p N_SN_M32_noxref_g ) capacitor c=0.00229818f \
 //x=12.52 //y=5.335 //x2=12.3 //y2=6.2
cc_514 ( N_noxref_2_c_499_p N_SN_M32_noxref_g ) capacitor c=0.0179041f \
 //x=12.52 //y=5.56 //x2=12.3 //y2=6.2
cc_515 ( N_noxref_2_c_487_p N_SN_M33_noxref_g ) capacitor c=0.00955829f \
 //x=13.285 //y=5.335 //x2=12.74 //y2=6.2
cc_516 ( N_noxref_2_c_489_p N_SN_M33_noxref_g ) capacitor c=0.00230699f \
 //x=12.52 //y=5.335 //x2=12.74 //y2=6.2
cc_517 ( N_noxref_2_c_499_p N_SN_M33_noxref_g ) capacitor c=0.0179041f \
 //x=12.52 //y=5.56 //x2=12.74 //y2=6.2
cc_518 ( N_noxref_2_c_489_p N_SN_c_2302_n ) capacitor c=0.00209164f //x=12.52 \
 //y=5.335 //x2=12.665 //y2=4.97
cc_519 ( N_noxref_2_c_499_p N_SN_c_2302_n ) capacitor c=0.00290085f //x=12.52 \
 //y=5.56 //x2=12.665 //y2=4.97
cc_520 ( N_noxref_2_c_415_n N_SN_c_2267_n ) capacitor c=6.02332e-19 //x=12.4 \
 //y=5.335 //x2=12.33 //y2=4.88
cc_521 ( N_noxref_2_c_423_p N_noxref_8_c_2617_n ) capacitor c=0.0154269f \
 //x=14.18 //y=2.98 //x2=13.44 //y2=2.375
cc_522 ( N_noxref_2_c_423_p N_noxref_8_c_2613_n ) capacitor c=0.0238856f \
 //x=14.18 //y=2.98 //x2=13.44 //y2=4.09
cc_523 ( N_noxref_2_c_440_p N_noxref_8_c_2613_n ) capacitor c=0.0148501f \
 //x=14.18 //y=3.3 //x2=13.44 //y2=4.09
cc_524 ( N_noxref_2_c_435_p N_noxref_8_c_2613_n ) capacitor c=0.0315384f \
 //x=14.18 //y=5.25 //x2=13.44 //y2=4.09
cc_525 ( N_noxref_2_c_424_p N_noxref_8_c_2613_n ) capacitor c=0.0011257f \
 //x=16.03 //y=2.975 //x2=13.44 //y2=4.09
cc_526 ( N_noxref_2_c_426_p N_noxref_8_c_2613_n ) capacitor c=5.2852e-19 \
 //x=16.03 //y=4.755 //x2=13.44 //y2=4.09
cc_527 ( N_noxref_2_c_419_n N_noxref_8_c_2613_n ) capacitor c=5.84384e-19 \
 //x=14.18 //y=3.14 //x2=13.44 //y2=4.09
cc_528 ( N_noxref_2_c_442_p N_noxref_8_c_2613_n ) capacitor c=0.006875f \
 //x=14.34 //y=3.14 //x2=13.44 //y2=4.09
cc_529 ( N_noxref_2_c_487_p N_noxref_8_c_2625_n ) capacitor c=0.00282823f \
 //x=13.285 //y=5.335 //x2=13.44 //y2=4.41
cc_530 ( N_noxref_2_c_490_p N_noxref_8_c_2625_n ) capacitor c=7.2416e-19 \
 //x=14.095 //y=5.335 //x2=13.44 //y2=4.41
cc_531 ( N_noxref_2_c_435_p N_noxref_8_c_2625_n ) capacitor c=0.0144538f \
 //x=14.18 //y=5.25 //x2=13.44 //y2=4.41
cc_532 ( N_noxref_2_c_540_p N_noxref_8_c_2625_n ) capacitor c=2.31899e-19 \
 //x=13.4 //y=5.56 //x2=13.44 //y2=4.41
cc_533 ( N_noxref_2_c_490_p N_noxref_8_c_2615_n ) capacitor c=0.00228424f \
 //x=14.095 //y=5.335 //x2=13.44 //y2=4.75
cc_534 ( N_noxref_2_c_435_p N_noxref_8_c_2615_n ) capacitor c=0.0276971f \
 //x=14.18 //y=5.25 //x2=13.44 //y2=4.75
cc_535 ( N_noxref_2_c_426_p N_noxref_8_c_2615_n ) capacitor c=4.62167e-19 \
 //x=16.03 //y=4.755 //x2=13.44 //y2=4.75
cc_536 ( N_noxref_2_c_491_p N_noxref_8_c_2615_n ) capacitor c=0.0221427f \
 //x=13.4 //y=5.335 //x2=13.44 //y2=4.75
cc_537 ( N_noxref_2_c_540_p N_noxref_8_c_2615_n ) capacitor c=0.00217653f \
 //x=13.4 //y=5.56 //x2=13.44 //y2=4.75
cc_538 ( N_noxref_2_M37_noxref_g N_noxref_8_c_2634_n ) capacitor c=0.00893512f \
 //x=16.67 //y=6.2 //x2=17.21 //y2=5.335
cc_539 ( N_noxref_2_c_504_p N_noxref_8_c_2635_n ) capacitor c=0.00163399f \
 //x=14.095 //y=1.845 //x2=18.59 //y2=1.845
cc_540 ( N_noxref_2_c_435_p N_noxref_8_c_2636_n ) capacitor c=6.15063e-19 \
 //x=14.18 //y=5.25 //x2=13.435 //y2=4.25
cc_541 ( N_noxref_2_c_549_p N_noxref_8_c_2637_n ) capacitor c=6.09703e-19 \
 //x=13.4 //y=5.56 //x2=16.452 //y2=5.335
cc_542 ( N_noxref_2_c_490_p N_noxref_8_c_2637_n ) capacitor c=0.00306432f \
 //x=14.095 //y=5.335 //x2=16.452 //y2=5.335
cc_543 ( N_noxref_2_M36_noxref_g N_noxref_8_c_2637_n ) capacitor c=0.00461408f \
 //x=16.23 //y=6.2 //x2=16.452 //y2=5.335
cc_544 ( N_noxref_2_M37_noxref_g N_noxref_8_c_2637_n ) capacitor c=0.00229208f \
 //x=16.67 //y=6.2 //x2=16.452 //y2=5.335
cc_545 ( N_noxref_2_c_438_p N_noxref_8_c_2637_n ) capacitor c=0.00171885f \
 //x=16.595 //y=4.97 //x2=16.452 //y2=5.335
cc_546 ( N_noxref_2_c_435_p N_noxref_8_c_2642_n ) capacitor c=0.0229775f \
 //x=14.18 //y=5.25 //x2=18.83 //y2=4.25
cc_547 ( N_noxref_2_c_426_p N_noxref_8_c_2642_n ) capacitor c=0.024795f \
 //x=16.03 //y=4.755 //x2=18.83 //y2=4.25
cc_548 ( N_noxref_2_c_435_p N_noxref_8_c_2616_n ) capacitor c=0.00325739f \
 //x=14.18 //y=5.25 //x2=13.595 //y2=4.25
cc_549 ( N_noxref_2_c_423_p N_noxref_8_c_2645_n ) capacitor c=0.00163444f \
 //x=14.18 //y=2.98 //x2=13.44 //y2=2.26
cc_550 ( N_noxref_2_c_490_p N_noxref_8_c_2646_n ) capacitor c=0.00130631f \
 //x=14.095 //y=5.335 //x2=13.44 //y2=4.88
cc_551 ( N_noxref_2_c_435_p N_noxref_8_c_2646_n ) capacitor c=0.00131258f \
 //x=14.18 //y=5.25 //x2=13.44 //y2=4.88
cc_552 ( N_noxref_2_c_491_p N_noxref_8_c_2646_n ) capacitor c=0.00346456f \
 //x=13.4 //y=5.335 //x2=13.44 //y2=4.88
cc_553 ( N_noxref_2_c_540_p N_noxref_8_c_2646_n ) capacitor c=0.00552343f \
 //x=13.4 //y=5.56 //x2=13.44 //y2=4.88
cc_554 ( N_noxref_2_M36_noxref_g N_noxref_8_c_2650_n ) capacitor c=0.0162284f \
 //x=16.23 //y=6.2 //x2=16.45 //y2=5.56
cc_555 ( N_noxref_2_M37_noxref_g N_noxref_8_c_2650_n ) capacitor c=0.0179041f \
 //x=16.67 //y=6.2 //x2=16.45 //y2=5.56
cc_556 ( N_noxref_2_c_438_p N_noxref_8_c_2650_n ) capacitor c=0.00291477f \
 //x=16.595 //y=4.97 //x2=16.45 //y2=5.56
cc_557 ( N_noxref_2_c_487_p N_noxref_8_M34_noxref_g ) capacitor c=0.00939276f \
 //x=13.285 //y=5.335 //x2=13.18 //y2=6.2
cc_558 ( N_noxref_2_c_549_p N_noxref_8_M34_noxref_g ) capacitor c=0.00226521f \
 //x=13.4 //y=5.56 //x2=13.18 //y2=6.2
cc_559 ( N_noxref_2_c_540_p N_noxref_8_M34_noxref_g ) capacitor c=0.0178885f \
 //x=13.4 //y=5.56 //x2=13.18 //y2=6.2
cc_560 ( N_noxref_2_c_549_p N_noxref_8_M35_noxref_g ) capacitor c=0.00381703f \
 //x=13.4 //y=5.56 //x2=13.62 //y2=6.2
cc_561 ( N_noxref_2_c_490_p N_noxref_8_M35_noxref_g ) capacitor c=0.0107711f \
 //x=14.095 //y=5.335 //x2=13.62 //y2=6.2
cc_562 ( N_noxref_2_c_540_p N_noxref_8_M35_noxref_g ) capacitor c=0.0188608f \
 //x=13.4 //y=5.56 //x2=13.62 //y2=6.2
cc_563 ( N_noxref_2_c_503_p N_noxref_8_c_2659_n ) capacitor c=4.64015e-19 \
 //x=13.695 //y=1.305 //x2=13.43 //y2=1.095
cc_564 ( N_noxref_2_M8_noxref_d N_noxref_8_c_2659_n ) capacitor c=0.00137165f \
 //x=13.505 //y=1.095 //x2=13.43 //y2=1.095
cc_565 ( N_noxref_2_c_503_p N_noxref_8_c_2661_n ) capacitor c=0.0026012f \
 //x=13.695 //y=1.305 //x2=13.43 //y2=1.44
cc_566 ( N_noxref_2_c_574_p N_noxref_8_c_2661_n ) capacitor c=0.00127432f \
 //x=13.695 //y=1.76 //x2=13.43 //y2=1.44
cc_567 ( N_noxref_2_M8_noxref_d N_noxref_8_c_2661_n ) capacitor c=0.00237422f \
 //x=13.505 //y=1.095 //x2=13.43 //y2=1.44
cc_568 ( N_noxref_2_c_574_p N_noxref_8_c_2664_n ) capacitor c=0.00429966f \
 //x=13.695 //y=1.76 //x2=13.43 //y2=1.75
cc_569 ( N_noxref_2_c_503_p N_noxref_8_c_2665_n ) capacitor c=5.29969e-19 \
 //x=13.695 //y=1.305 //x2=13.805 //y2=0.94
cc_570 ( N_noxref_2_M8_noxref_d N_noxref_8_c_2665_n ) capacitor c=0.0020782f \
 //x=13.505 //y=1.095 //x2=13.805 //y2=0.94
cc_571 ( N_noxref_2_c_503_p N_noxref_8_c_2667_n ) capacitor c=5.44618e-19 \
 //x=13.695 //y=1.305 //x2=13.805 //y2=1.595
cc_572 ( N_noxref_2_c_574_p N_noxref_8_c_2667_n ) capacitor c=0.00942306f \
 //x=13.695 //y=1.76 //x2=13.805 //y2=1.595
cc_573 ( N_noxref_2_c_504_p N_noxref_8_c_2667_n ) capacitor c=0.00194716f \
 //x=14.095 //y=1.845 //x2=13.805 //y2=1.595
cc_574 ( N_noxref_2_M8_noxref_d N_noxref_8_c_2667_n ) capacitor c=0.00356097f \
 //x=13.505 //y=1.095 //x2=13.805 //y2=1.595
cc_575 ( N_noxref_2_c_503_p N_noxref_8_c_2671_n ) capacitor c=5.24634e-19 \
 //x=13.695 //y=1.305 //x2=13.96 //y2=1.095
cc_576 ( N_noxref_2_M8_noxref_d N_noxref_8_c_2671_n ) capacitor c=0.00139206f \
 //x=13.505 //y=1.095 //x2=13.96 //y2=1.095
cc_577 ( N_noxref_2_c_503_p N_noxref_8_c_2673_n ) capacitor c=0.00307978f \
 //x=13.695 //y=1.305 //x2=13.96 //y2=1.44
cc_578 ( N_noxref_2_c_574_p N_noxref_8_c_2673_n ) capacitor c=0.00363411f \
 //x=13.695 //y=1.76 //x2=13.96 //y2=1.44
cc_579 ( N_noxref_2_c_504_p N_noxref_8_c_2673_n ) capacitor c=0.00323576f \
 //x=14.095 //y=1.845 //x2=13.96 //y2=1.44
cc_580 ( N_noxref_2_M8_noxref_d N_noxref_8_c_2673_n ) capacitor c=0.00237422f \
 //x=13.505 //y=1.095 //x2=13.96 //y2=1.44
cc_581 ( N_noxref_2_c_423_p N_noxref_8_c_2677_n ) capacitor c=0.0025845f \
 //x=14.18 //y=2.98 //x2=13.44 //y2=2.26
cc_582 ( N_noxref_2_c_574_p N_noxref_8_c_2678_n ) capacitor c=0.0036273f \
 //x=13.695 //y=1.76 //x2=13.44 //y2=2.095
cc_583 ( N_noxref_2_c_423_p N_noxref_8_c_2678_n ) capacitor c=0.00282067f \
 //x=14.18 //y=2.98 //x2=13.44 //y2=2.095
cc_584 ( N_noxref_2_c_435_p N_noxref_8_c_2680_n ) capacitor c=0.00739875f \
 //x=14.18 //y=5.25 //x2=13.44 //y2=4.88
cc_585 ( N_noxref_2_c_491_p N_noxref_8_c_2680_n ) capacitor c=0.00203307f \
 //x=13.4 //y=5.335 //x2=13.44 //y2=4.88
cc_586 ( N_noxref_2_c_540_p N_noxref_8_c_2680_n ) capacitor c=0.00375636f \
 //x=13.4 //y=5.56 //x2=13.44 //y2=4.88
cc_587 ( N_noxref_2_c_415_n N_VDD_c_3497_n ) capacitor c=0.00621363f //x=12.4 \
 //y=5.335 //x2=28.61 //y2=7.58
cc_588 ( N_noxref_2_c_487_p N_VDD_c_3497_n ) capacitor c=0.00627186f \
 //x=13.285 //y=5.335 //x2=28.61 //y2=7.58
cc_589 ( N_noxref_2_c_549_p N_VDD_c_3497_n ) capacitor c=0.00256019f //x=13.4 \
 //y=5.56 //x2=28.61 //y2=7.58
cc_590 ( N_noxref_2_c_490_p N_VDD_c_3497_n ) capacitor c=0.00829249f \
 //x=14.095 //y=5.335 //x2=28.61 //y2=7.58
cc_591 ( N_noxref_2_c_440_p N_VDD_c_3497_n ) capacitor c=4.18452e-19 //x=14.18 \
 //y=3.3 //x2=28.61 //y2=7.58
cc_592 ( N_noxref_2_c_425_p N_VDD_c_3497_n ) capacitor c=3.52288e-19 //x=16.03 \
 //y=3.295 //x2=28.61 //y2=7.58
cc_593 ( N_noxref_2_c_416_n N_VDD_c_3497_n ) capacitor c=0.00261804f \
 //x=11.642 //y=5.335 //x2=28.61 //y2=7.58
cc_594 ( N_noxref_2_c_489_p N_VDD_c_3497_n ) capacitor c=0.00270108f //x=12.52 \
 //y=5.335 //x2=28.61 //y2=7.58
cc_595 ( N_noxref_2_c_420_n N_VDD_c_3497_n ) capacitor c=0.0024232f //x=11.64 \
 //y=5.56 //x2=28.61 //y2=7.58
cc_596 ( N_noxref_2_c_499_p N_VDD_c_3497_n ) capacitor c=0.0024232f //x=12.52 \
 //y=5.56 //x2=28.61 //y2=7.58
cc_597 ( N_noxref_2_c_540_p N_VDD_c_3497_n ) capacitor c=0.0024232f //x=13.4 \
 //y=5.56 //x2=28.61 //y2=7.58
cc_598 ( N_noxref_2_c_415_n N_VDD_c_3525_n ) capacitor c=0.00202922f //x=12.4 \
 //y=5.335 //x2=11.995 //y2=7.585
cc_599 ( N_noxref_2_c_416_n N_VDD_c_3525_n ) capacitor c=9.3757e-19 //x=11.642 \
 //y=5.335 //x2=11.995 //y2=7.585
cc_600 ( N_noxref_2_c_420_n N_VDD_c_3525_n ) capacitor c=0.0138074f //x=11.64 \
 //y=5.56 //x2=11.995 //y2=7.585
cc_601 ( N_noxref_2_c_415_n N_VDD_c_3576_n ) capacitor c=0.0017708f //x=12.4 \
 //y=5.335 //x2=12.875 //y2=7.585
cc_602 ( N_noxref_2_c_487_p N_VDD_c_3576_n ) capacitor c=0.00202922f \
 //x=13.285 //y=5.335 //x2=12.875 //y2=7.585
cc_603 ( N_noxref_2_c_489_p N_VDD_c_3576_n ) capacitor c=9.4822e-19 //x=12.52 \
 //y=5.335 //x2=12.875 //y2=7.585
cc_604 ( N_noxref_2_c_499_p N_VDD_c_3576_n ) capacitor c=0.0138074f //x=12.52 \
 //y=5.56 //x2=12.875 //y2=7.585
cc_605 ( N_noxref_2_c_487_p N_VDD_c_3580_n ) capacitor c=0.00205906f \
 //x=13.285 //y=5.335 //x2=13.755 //y2=7.585
cc_606 ( N_noxref_2_c_549_p N_VDD_c_3580_n ) capacitor c=8.49654e-19 //x=13.4 \
 //y=5.56 //x2=13.755 //y2=7.585
cc_607 ( N_noxref_2_c_490_p N_VDD_c_3580_n ) capacitor c=0.00204238f \
 //x=14.095 //y=5.335 //x2=13.755 //y2=7.585
cc_608 ( N_noxref_2_c_540_p N_VDD_c_3580_n ) capacitor c=0.0135103f //x=13.4 \
 //y=5.56 //x2=13.755 //y2=7.585
cc_609 ( N_noxref_2_c_490_p N_VDD_c_3584_n ) capacitor c=0.00183742f \
 //x=14.095 //y=5.335 //x2=14.75 //y2=7.585
cc_610 ( N_noxref_2_M36_noxref_g N_VDD_c_3585_n ) capacitor c=0.00755614f \
 //x=16.23 //y=6.2 //x2=16.805 //y2=7.585
cc_611 ( N_noxref_2_M37_noxref_g N_VDD_c_3585_n ) capacitor c=0.00755544f \
 //x=16.67 //y=6.2 //x2=16.805 //y2=7.585
cc_612 ( N_noxref_2_c_416_n N_VDD_c_3533_n ) capacitor c=0.0022955f //x=11.642 \
 //y=5.335 //x2=10.11 //y2=7.585
cc_613 ( N_noxref_2_c_420_n N_VDD_c_3533_n ) capacitor c=0.00509469f //x=11.64 \
 //y=5.56 //x2=10.11 //y2=7.585
cc_614 ( N_noxref_2_c_549_p N_VDD_c_3589_n ) capacitor c=0.00282782f //x=13.4 \
 //y=5.56 //x2=14.92 //y2=7.585
cc_615 ( N_noxref_2_c_435_p N_VDD_c_3589_n ) capacitor c=0.0317574f //x=14.18 \
 //y=5.25 //x2=14.92 //y2=7.585
cc_616 ( N_noxref_2_c_426_p N_VDD_c_3589_n ) capacitor c=0.0117388f //x=16.03 \
 //y=4.755 //x2=14.92 //y2=7.585
cc_617 ( N_noxref_2_c_540_p N_VDD_c_3589_n ) capacitor c=0.00777981f //x=13.4 \
 //y=5.56 //x2=14.92 //y2=7.585
cc_618 ( N_noxref_2_c_437_p N_VDD_c_3589_n ) capacitor c=0.00387428f //x=16.03 \
 //y=4.88 //x2=14.92 //y2=7.585
cc_619 ( N_noxref_2_c_439_p N_VDD_c_3589_n ) capacitor c=0.00546381f \
 //x=16.305 //y=4.97 //x2=14.92 //y2=7.585
cc_620 ( N_noxref_2_c_416_n N_VDD_M30_noxref_s ) capacitor c=0.0442713f \
 //x=11.642 //y=5.335 //x2=11.065 //y2=5.2
cc_621 ( N_noxref_2_c_489_p N_VDD_M30_noxref_s ) capacitor c=7.80122e-19 \
 //x=12.52 //y=5.335 //x2=11.065 //y2=5.2
cc_622 ( N_noxref_2_c_420_n N_VDD_M30_noxref_s ) capacitor c=0.09305f \
 //x=11.64 //y=5.56 //x2=11.065 //y2=5.2
cc_623 ( N_noxref_2_c_415_n N_VDD_M31_noxref_d ) capacitor c=0.00700141f \
 //x=12.4 //y=5.335 //x2=11.935 //y2=5.2
cc_624 ( N_noxref_2_c_420_n N_VDD_M31_noxref_d ) capacitor c=0.0674491f \
 //x=11.64 //y=5.56 //x2=11.935 //y2=5.2
cc_625 ( N_noxref_2_c_499_p N_VDD_M31_noxref_d ) capacitor c=0.0674762f \
 //x=12.52 //y=5.56 //x2=11.935 //y2=5.2
cc_626 ( N_noxref_2_c_487_p N_VDD_M33_noxref_d ) capacitor c=0.00700141f \
 //x=13.285 //y=5.335 //x2=12.815 //y2=5.2
cc_627 ( N_noxref_2_c_499_p N_VDD_M33_noxref_d ) capacitor c=0.067493f \
 //x=12.52 //y=5.56 //x2=12.815 //y2=5.2
cc_628 ( N_noxref_2_c_540_p N_VDD_M33_noxref_d ) capacitor c=0.0674979f \
 //x=13.4 //y=5.56 //x2=12.815 //y2=5.2
cc_629 ( N_noxref_2_c_490_p N_VDD_M35_noxref_d ) capacitor c=0.00700141f \
 //x=14.095 //y=5.335 //x2=13.695 //y2=5.2
cc_630 ( N_noxref_2_c_540_p N_VDD_M35_noxref_d ) capacitor c=0.0675002f \
 //x=13.4 //y=5.56 //x2=13.695 //y2=5.2
cc_631 ( N_noxref_2_c_549_p N_VDD_M36_noxref_s ) capacitor c=0.00492616f \
 //x=13.4 //y=5.56 //x2=15.875 //y2=5.2
cc_632 ( N_noxref_2_c_490_p N_VDD_M36_noxref_s ) capacitor c=9.42705e-19 \
 //x=14.095 //y=5.335 //x2=15.875 //y2=5.2
cc_633 ( N_noxref_2_c_425_p N_VDD_M36_noxref_s ) capacitor c=5.00313e-19 \
 //x=16.03 //y=3.295 //x2=15.875 //y2=5.2
cc_634 ( N_noxref_2_c_426_p N_VDD_M36_noxref_s ) capacitor c=0.0217981f \
 //x=16.03 //y=4.755 //x2=15.875 //y2=5.2
cc_635 ( N_noxref_2_c_489_p N_VDD_M36_noxref_s ) capacitor c=2.11884e-19 \
 //x=12.52 //y=5.335 //x2=15.875 //y2=5.2
cc_636 ( N_noxref_2_c_437_p N_VDD_M36_noxref_s ) capacitor c=0.00983846f \
 //x=16.03 //y=4.88 //x2=15.875 //y2=5.2
cc_637 ( N_noxref_2_M36_noxref_g N_VDD_M36_noxref_s ) capacitor c=0.053419f \
 //x=16.23 //y=6.2 //x2=15.875 //y2=5.2
cc_638 ( N_noxref_2_c_439_p N_VDD_M36_noxref_s ) capacitor c=0.00607761f \
 //x=16.305 //y=4.97 //x2=15.875 //y2=5.2
cc_639 ( N_noxref_2_M37_noxref_g N_VDD_M37_noxref_d ) capacitor c=0.015318f \
 //x=16.67 //y=6.2 //x2=16.745 //y2=5.2
cc_640 ( N_noxref_2_c_503_p N_noxref_14_c_4135_n ) capacitor c=0.0036878f \
 //x=13.695 //y=1.305 //x2=14.095 //y2=0.72
cc_641 ( N_noxref_2_c_504_p N_noxref_14_c_4135_n ) capacitor c=0.00399931f \
 //x=14.095 //y=1.845 //x2=14.095 //y2=0.72
cc_642 ( N_noxref_2_M8_noxref_d N_noxref_14_c_4135_n ) capacitor c=0.00910163f \
 //x=13.505 //y=1.095 //x2=14.095 //y2=0.72
cc_643 ( N_noxref_2_M8_noxref_d N_noxref_14_c_4138_n ) capacitor c=0.00120711f \
 //x=13.505 //y=1.095 //x2=13.21 //y2=1.175
cc_644 ( N_noxref_2_c_415_n N_noxref_14_M7_noxref_d ) capacitor c=0.00142884f \
 //x=12.4 //y=5.335 //x2=11.97 //y2=1.09
cc_645 ( N_noxref_2_c_503_p N_noxref_14_M7_noxref_d ) capacitor c=0.00802417f \
 //x=13.695 //y=1.305 //x2=11.97 //y2=1.09
cc_646 ( N_noxref_2_c_503_p N_noxref_14_M8_noxref_s ) capacitor c=0.0098487f \
 //x=13.695 //y=1.305 //x2=13.075 //y2=0.555
cc_647 ( N_noxref_2_c_574_p N_noxref_14_M8_noxref_s ) capacitor c=0.0283243f \
 //x=13.695 //y=1.76 //x2=13.075 //y2=0.555
cc_648 ( N_noxref_2_c_504_p N_noxref_14_M8_noxref_s ) capacitor c=0.0082f \
 //x=14.095 //y=1.845 //x2=13.075 //y2=0.555
cc_649 ( N_noxref_2_c_419_n N_noxref_14_M8_noxref_s ) capacitor c=0.00217661f \
 //x=14.18 //y=3.14 //x2=13.075 //y2=0.555
cc_650 ( N_noxref_2_M8_noxref_d N_noxref_14_M8_noxref_s ) capacitor \
 c=0.0279003f //x=13.505 //y=1.095 //x2=13.075 //y2=0.555
cc_651 ( N_noxref_2_c_503_p N_noxref_15_M10_noxref_d ) capacitor c=3.20746e-19 \
 //x=13.695 //y=1.305 //x2=16.78 //y2=1.09
cc_652 ( N_noxref_2_c_503_p N_GND_c_4414_n ) capacitor c=0.00901861f \
 //x=13.695 //y=1.305 //x2=15.91 //y2=0.175
cc_653 ( N_noxref_2_c_504_p N_GND_c_4414_n ) capacitor c=0.00713708f \
 //x=14.095 //y=1.845 //x2=15.91 //y2=0.175
cc_654 ( N_noxref_2_c_440_p N_GND_c_4414_n ) capacitor c=5.56106e-19 //x=14.18 \
 //y=3.3 //x2=15.91 //y2=0.175
cc_655 ( N_noxref_2_M8_noxref_d N_GND_c_4414_n ) capacitor c=2.9462e-19 \
 //x=13.505 //y=1.095 //x2=15.91 //y2=0.175
cc_656 ( N_noxref_2_c_463_p N_GND_c_4418_n ) capacitor c=3.97665e-19 //x=15.73 \
 //y=1.055 //x2=15.995 //y2=1.015
cc_657 ( N_noxref_2_c_665_p N_GND_c_4418_n ) capacitor c=0.00864776f \
 //x=16.105 //y=0.9 //x2=15.995 //y2=1.015
cc_658 ( N_noxref_2_c_465_p N_GND_c_4418_n ) capacitor c=4.45447e-19 //x=16.26 \
 //y=1.055 //x2=15.995 //y2=1.015
cc_659 ( N_noxref_2_c_503_p N_GND_c_4421_n ) capacitor c=0.00543195f \
 //x=13.695 //y=1.305 //x2=15.995 //y2=1.145
cc_660 ( N_noxref_2_c_431_p N_GND_c_4421_n ) capacitor c=0.00798179f //x=16.03 \
 //y=2.375 //x2=15.995 //y2=1.145
cc_661 ( N_noxref_2_c_425_p N_GND_c_4421_n ) capacitor c=9.4894e-19 //x=16.03 \
 //y=3.295 //x2=15.995 //y2=1.145
cc_662 ( N_noxref_2_c_429_p N_GND_c_4421_n ) capacitor c=2.22883e-19 //x=16.03 \
 //y=2.26 //x2=15.995 //y2=1.145
cc_663 ( N_noxref_2_c_463_p N_GND_c_4421_n ) capacitor c=0.00156339f //x=15.73 \
 //y=1.055 //x2=15.995 //y2=1.145
cc_664 ( N_noxref_2_c_464_p N_GND_c_4421_n ) capacitor c=0.00352472f //x=15.73 \
 //y=1.4 //x2=15.995 //y2=1.145
cc_665 ( N_noxref_2_c_466_p N_GND_c_4421_n ) capacitor c=4.09037e-19 //x=15.73 \
 //y=1.71 //x2=15.995 //y2=1.145
cc_666 ( N_noxref_2_c_665_p N_GND_c_4421_n ) capacitor c=9.36995e-19 \
 //x=16.105 //y=0.9 //x2=15.995 //y2=1.145
cc_667 ( N_noxref_2_c_675_p N_GND_c_4421_n ) capacitor c=5.56593e-19 \
 //x=16.105 //y=1.555 //x2=15.995 //y2=1.145
cc_668 ( N_noxref_2_c_465_p N_GND_c_4421_n ) capacitor c=0.0017438f //x=16.26 \
 //y=1.055 //x2=15.995 //y2=1.145
cc_669 ( N_noxref_2_c_467_p N_GND_c_4421_n ) capacitor c=0.00276804f //x=16.26 \
 //y=1.4 //x2=15.995 //y2=1.145
cc_670 ( N_noxref_2_c_504_p N_GND_c_4385_n ) capacitor c=6.86343e-19 \
 //x=14.095 //y=1.845 //x2=14.75 //y2=0.175
cc_671 ( N_noxref_2_c_440_p N_GND_c_4385_n ) capacitor c=4.88513e-19 //x=14.18 \
 //y=3.3 //x2=14.75 //y2=0.175
cc_672 ( N_noxref_2_c_463_p N_GND_c_4434_n ) capacitor c=0.00677849f //x=15.73 \
 //y=1.055 //x2=19.56 //y2=0.175
cc_673 ( N_noxref_2_c_574_p N_GND_c_4435_n ) capacitor c=0.0045138f //x=13.695 \
 //y=1.76 //x2=14.92 //y2=0.175
cc_674 ( N_noxref_2_c_504_p N_GND_c_4435_n ) capacitor c=0.0309727f //x=14.095 \
 //y=1.845 //x2=14.92 //y2=0.175
cc_675 ( N_noxref_2_c_431_p N_GND_c_4435_n ) capacitor c=0.00407472f //x=16.03 \
 //y=2.375 //x2=14.92 //y2=0.175
cc_676 ( N_noxref_2_c_424_p N_GND_c_4435_n ) capacitor c=0.00960865f //x=16.03 \
 //y=2.975 //x2=14.92 //y2=0.175
cc_677 ( N_noxref_2_c_445_p N_GND_c_4435_n ) capacitor c=0.00411812f //x=15.87 \
 //y=3.135 //x2=14.92 //y2=0.175
cc_678 ( N_noxref_2_c_429_p N_GND_c_4435_n ) capacitor c=0.00411295f //x=16.03 \
 //y=2.26 //x2=14.92 //y2=0.175
cc_679 ( N_noxref_2_c_466_p N_GND_c_4435_n ) capacitor c=0.00170145f //x=15.73 \
 //y=1.71 //x2=14.92 //y2=0.175
cc_680 ( N_noxref_2_c_433_p N_GND_c_4435_n ) capacitor c=0.00991898f //x=15.73 \
 //y=2.095 //x2=14.92 //y2=0.175
cc_681 ( N_noxref_2_c_431_p N_GND_M9_noxref_d ) capacitor c=4.4417e-19 \
 //x=16.03 //y=2.375 //x2=15.805 //y2=1.055
cc_682 ( N_noxref_2_c_463_p N_GND_M9_noxref_d ) capacitor c=0.00184354f \
 //x=15.73 //y=1.055 //x2=15.805 //y2=1.055
cc_683 ( N_noxref_2_c_464_p N_GND_M9_noxref_d ) capacitor c=0.00210798f \
 //x=15.73 //y=1.4 //x2=15.805 //y2=1.055
cc_684 ( N_noxref_2_c_665_p N_GND_M9_noxref_d ) capacitor c=0.00474029f \
 //x=16.105 //y=0.9 //x2=15.805 //y2=1.055
cc_685 ( N_noxref_2_c_675_p N_GND_M9_noxref_d ) capacitor c=0.00166857f \
 //x=16.105 //y=1.555 //x2=15.805 //y2=1.055
cc_686 ( N_noxref_2_c_465_p N_GND_M9_noxref_d ) capacitor c=0.00230174f \
 //x=16.26 //y=1.055 //x2=15.805 //y2=1.055
cc_687 ( N_noxref_2_c_467_p N_GND_M9_noxref_d ) capacitor c=0.00210798f \
 //x=16.26 //y=1.4 //x2=15.805 //y2=1.055
cc_688 ( N_noxref_2_c_433_p N_noxref_22_c_5071_n ) capacitor c=0.00262672f \
 //x=15.73 //y=2.095 //x2=15.51 //y2=1.685
cc_689 ( N_noxref_2_c_431_p N_noxref_22_c_5072_n ) capacitor c=0.00428451f \
 //x=16.03 //y=2.375 //x2=16.395 //y2=1.77
cc_690 ( N_noxref_2_c_425_p N_noxref_22_c_5072_n ) capacitor c=0.00332034f \
 //x=16.03 //y=3.295 //x2=16.395 //y2=1.77
cc_691 ( N_noxref_2_c_429_p N_noxref_22_c_5072_n ) capacitor c=0.0104666f \
 //x=16.03 //y=2.26 //x2=16.395 //y2=1.77
cc_692 ( N_noxref_2_c_466_p N_noxref_22_c_5072_n ) capacitor c=0.00705077f \
 //x=15.73 //y=1.71 //x2=16.395 //y2=1.77
cc_693 ( N_noxref_2_c_433_p N_noxref_22_c_5072_n ) capacitor c=0.0203183f \
 //x=15.73 //y=2.095 //x2=16.395 //y2=1.77
cc_694 ( N_noxref_2_c_675_p N_noxref_22_c_5072_n ) capacitor c=0.00588627f \
 //x=16.105 //y=1.555 //x2=16.395 //y2=1.77
cc_695 ( N_noxref_2_c_467_p N_noxref_22_c_5072_n ) capacitor c=0.00698822f \
 //x=16.26 //y=1.4 //x2=16.395 //y2=1.77
cc_696 ( N_noxref_2_c_463_p N_noxref_22_M9_noxref_s ) capacitor c=0.0295256f \
 //x=15.73 //y=1.055 //x2=15.375 //y2=0.555
cc_697 ( N_noxref_2_c_466_p N_noxref_22_M9_noxref_s ) capacitor c=7.99997e-19 \
 //x=15.73 //y=1.71 //x2=15.375 //y2=0.555
cc_698 ( N_noxref_2_c_433_p N_noxref_22_M9_noxref_s ) capacitor c=0.00122123f \
 //x=15.73 //y=2.095 //x2=15.375 //y2=0.555
cc_699 ( N_noxref_2_c_465_p N_noxref_22_M9_noxref_s ) capacitor c=0.0125924f \
 //x=16.26 //y=1.055 //x2=15.375 //y2=0.555
cc_700 ( N_CLK_c_724_n N_noxref_4_c_1056_n ) capacitor c=6.67864e-19 //x=7.52 \
 //y=3.675 //x2=7.59 //y2=5.335
cc_701 ( N_CLK_c_726_n N_noxref_4_c_1056_n ) capacitor c=0.0213631f //x=7.52 \
 //y=4.765 //x2=7.59 //y2=5.335
cc_702 ( N_CLK_c_742_n N_noxref_4_c_1056_n ) capacitor c=0.00492634f //x=7.52 \
 //y=4.88 //x2=7.59 //y2=5.335
cc_703 ( N_CLK_M26_noxref_g N_noxref_4_c_1056_n ) capacitor c=0.00858241f \
 //x=7.49 //y=6.2 //x2=7.59 //y2=5.335
cc_704 ( N_CLK_c_760_n N_noxref_4_c_1056_n ) capacitor c=5.66497e-19 //x=7.52 \
 //y=4.88 //x2=7.59 //y2=5.335
cc_705 ( N_CLK_M27_noxref_g N_noxref_4_c_1136_n ) capacitor c=0.00955829f \
 //x=7.93 //y=6.2 //x2=8.475 //y2=5.335
cc_706 ( CLK N_noxref_4_c_1060_n ) capacitor c=0.00198165f //x=7.52 //y=2.77 \
 //x2=9.37 //y2=3.72
cc_707 ( N_CLK_c_730_n N_noxref_4_c_1060_n ) capacitor c=3.29025e-19 //x=8.985 \
 //y=3.51 //x2=9.37 //y2=3.72
cc_708 ( N_CLK_c_731_n N_noxref_4_c_1060_n ) capacitor c=0.0225183f //x=9.585 \
 //y=3.495 //x2=9.37 //y2=3.72
cc_709 ( N_CLK_c_731_n N_noxref_4_c_1065_n ) capacitor c=0.00901057f //x=9.585 \
 //y=3.495 //x2=9.37 //y2=4.04
cc_710 ( CLK N_noxref_4_c_1066_n ) capacitor c=0.00138366f //x=7.52 //y=4.25 \
 //x2=9.37 //y2=5.25
cc_711 ( N_CLK_c_724_n N_noxref_4_c_1142_n ) capacitor c=0.00172257f //x=7.52 \
 //y=3.675 //x2=7.71 //y2=5.335
cc_712 ( N_CLK_c_726_n N_noxref_4_c_1142_n ) capacitor c=0.00239361f //x=7.52 \
 //y=4.765 //x2=7.71 //y2=5.335
cc_713 ( N_CLK_c_742_n N_noxref_4_c_1142_n ) capacitor c=0.00132214f //x=7.52 \
 //y=4.88 //x2=7.71 //y2=5.335
cc_714 ( N_CLK_M26_noxref_g N_noxref_4_c_1142_n ) capacitor c=0.00229818f \
 //x=7.49 //y=6.2 //x2=7.71 //y2=5.335
cc_715 ( N_CLK_M27_noxref_g N_noxref_4_c_1142_n ) capacitor c=0.00230699f \
 //x=7.93 //y=6.2 //x2=7.71 //y2=5.335
cc_716 ( N_CLK_c_835_p N_noxref_4_c_1142_n ) capacitor c=0.00190287f //x=7.855 \
 //y=4.97 //x2=7.71 //y2=5.335
cc_717 ( CLK N_noxref_4_c_1073_n ) capacitor c=4.99132e-19 //x=7.52 //y=4.25 \
 //x2=7.13 //y2=3.88
cc_718 ( N_CLK_c_724_n N_noxref_4_c_1073_n ) capacitor c=0.00140903f //x=7.52 \
 //y=3.675 //x2=7.13 //y2=3.88
cc_719 ( N_CLK_c_736_n N_noxref_4_c_1073_n ) capacitor c=0.0358254f //x=7.675 \
 //y=3.515 //x2=7.13 //y2=3.88
cc_720 ( CLK N_noxref_4_c_1082_n ) capacitor c=0.0252993f //x=7.52 //y=4.25 \
 //x2=7.73 //y2=3.9
cc_721 ( N_CLK_c_724_n N_noxref_4_c_1082_n ) capacitor c=0.00423326f //x=7.52 \
 //y=3.675 //x2=7.73 //y2=3.9
cc_722 ( N_CLK_c_730_n N_noxref_4_c_1082_n ) capacitor c=0.0555498f //x=8.985 \
 //y=3.51 //x2=7.73 //y2=3.9
cc_723 ( CLK N_noxref_4_c_1083_n ) capacitor c=4.03081e-19 //x=7.52 //y=4.25 \
 //x2=8.24 //y2=3.88
cc_724 ( N_CLK_c_730_n N_noxref_4_c_1083_n ) capacitor c=0.056739f //x=8.985 \
 //y=3.51 //x2=8.24 //y2=3.88
cc_725 ( N_CLK_c_733_n N_noxref_4_c_1127_n ) capacitor c=0.0411156f //x=13.795 \
 //y=3.51 //x2=13.65 //y2=3.865
cc_726 ( N_CLK_c_730_n N_noxref_4_c_1084_n ) capacitor c=0.0240778f //x=8.985 \
 //y=3.51 //x2=13.22 //y2=3.865
cc_727 ( N_CLK_c_731_n N_noxref_4_c_1084_n ) capacitor c=0.351584f //x=9.585 \
 //y=3.495 //x2=13.22 //y2=3.865
cc_728 ( N_CLK_c_733_n N_noxref_4_c_1084_n ) capacitor c=0.0567487f //x=13.795 \
 //y=3.51 //x2=13.22 //y2=3.865
cc_729 ( N_CLK_c_775_n N_noxref_4_c_1128_n ) capacitor c=0.00556805f //x=17.14 \
 //y=3.655 //x2=18.605 //y2=3.88
cc_730 ( N_CLK_c_776_n N_noxref_4_c_1128_n ) capacitor c=0.0229379f //x=17.14 \
 //y=4.765 //x2=18.605 //y2=3.88
cc_731 ( N_CLK_c_784_n N_noxref_4_c_1128_n ) capacitor c=0.140237f //x=14.395 \
 //y=3.525 //x2=18.605 //y2=3.88
cc_732 ( N_CLK_c_787_n N_noxref_4_c_1128_n ) capacitor c=0.0578733f //x=15.645 \
 //y=3.51 //x2=18.605 //y2=3.88
cc_733 ( N_CLK_c_791_n N_noxref_4_c_1128_n ) capacitor c=0.0907169f //x=16.245 \
 //y=3.525 //x2=18.605 //y2=3.88
cc_734 ( N_CLK_c_724_n N_noxref_4_c_1165_n ) capacitor c=6.16846e-19 //x=7.52 \
 //y=3.675 //x2=7.71 //y2=5.56
cc_735 ( N_CLK_c_726_n N_noxref_4_c_1165_n ) capacitor c=6.21282e-19 //x=7.52 \
 //y=4.765 //x2=7.71 //y2=5.56
cc_736 ( N_CLK_M26_noxref_g N_noxref_4_c_1165_n ) capacitor c=0.0179041f \
 //x=7.49 //y=6.2 //x2=7.71 //y2=5.56
cc_737 ( N_CLK_M27_noxref_g N_noxref_4_c_1165_n ) capacitor c=0.0179041f \
 //x=7.93 //y=6.2 //x2=7.71 //y2=5.56
cc_738 ( N_CLK_c_835_p N_noxref_4_c_1165_n ) capacitor c=0.00290085f //x=7.855 \
 //y=4.97 //x2=7.71 //y2=5.56
cc_739 ( CLK RN ) capacitor c=0.0250144f //x=17.14 //y=3.14 //x2=18.25 //y2=3.14
cc_740 ( CLK RN ) capacitor c=5.01652e-19 //x=17.14 //y=3.51 //x2=18.25 \
 //y2=3.14
cc_741 ( N_CLK_c_775_n RN ) capacitor c=0.00776638f //x=17.14 //y=3.655 \
 //x2=18.25 //y2=3.14
cc_742 ( N_CLK_c_776_n RN ) capacitor c=0.022375f //x=17.14 //y=4.765 \
 //x2=18.25 //y2=3.14
cc_743 ( N_CLK_c_791_n RN ) capacitor c=0.00520244f //x=16.245 //y=3.525 \
 //x2=18.25 //y2=3.14
cc_744 ( N_CLK_c_793_n RN ) capacitor c=4.16726e-19 //x=17.14 //y=2.26 \
 //x2=18.25 //y2=3.14
cc_745 ( N_CLK_c_772_n N_RN_c_1552_n ) capacitor c=0.0116288f //x=17.14 \
 //y=2.375 //x2=18.25 //y2=2.375
cc_746 ( N_CLK_c_793_n N_RN_c_1552_n ) capacitor c=5.39999e-19 //x=17.14 \
 //y=2.26 //x2=18.25 //y2=2.375
cc_747 ( N_CLK_c_812_n N_RN_c_1552_n ) capacitor c=0.00141236f //x=17.23 \
 //y=2.095 //x2=18.25 //y2=2.375
cc_748 ( N_CLK_c_776_n N_RN_c_1555_n ) capacitor c=0.00822284f //x=17.14 \
 //y=4.765 //x2=18.25 //y2=4.835
cc_749 ( N_CLK_c_797_n N_RN_c_1555_n ) capacitor c=8.74237e-19 //x=17.14 \
 //y=4.88 //x2=18.25 //y2=4.835
cc_750 ( N_CLK_c_815_n N_RN_c_1555_n ) capacitor c=8.65001e-19 //x=17.14 \
 //y=4.88 //x2=18.25 //y2=4.835
cc_751 ( CLK N_RN_c_1517_n ) capacitor c=0.0298145f //x=7.52 //y=4.25 \
 //x2=8.24 //y2=4.62
cc_752 ( N_CLK_c_726_n N_RN_c_1517_n ) capacitor c=0.0036605f //x=7.52 \
 //y=4.765 //x2=8.24 //y2=4.62
cc_753 ( N_CLK_c_730_n N_RN_c_1517_n ) capacitor c=0.00440121f //x=8.985 \
 //y=3.51 //x2=8.24 //y2=4.62
cc_754 ( N_CLK_c_776_n N_RN_c_1543_n ) capacitor c=0.0370187f //x=17.14 \
 //y=4.765 //x2=18.855 //y2=4.632
cc_755 ( CLK N_RN_c_1562_n ) capacitor c=4.16726e-19 //x=17.14 //y=3.14 \
 //x2=18.25 //y2=2.26
cc_756 ( N_CLK_c_772_n N_RN_c_1562_n ) capacitor c=5.42289e-19 //x=17.14 \
 //y=2.375 //x2=18.25 //y2=2.26
cc_757 ( N_CLK_c_793_n N_RN_c_1562_n ) capacitor c=0.00125213f //x=17.14 \
 //y=2.26 //x2=18.25 //y2=2.26
cc_758 ( N_CLK_c_812_n N_RN_c_1562_n ) capacitor c=0.00209664f //x=17.23 \
 //y=2.095 //x2=18.25 //y2=2.26
cc_759 ( N_CLK_c_776_n N_RN_c_1566_n ) capacitor c=4.56604e-19 //x=17.14 \
 //y=4.765 //x2=18.25 //y2=4.88
cc_760 ( N_CLK_c_797_n N_RN_c_1566_n ) capacitor c=0.00113393f //x=17.14 \
 //y=4.88 //x2=18.25 //y2=4.88
cc_761 ( N_CLK_c_815_n N_RN_c_1566_n ) capacitor c=0.0012974f //x=17.14 \
 //y=4.88 //x2=18.25 //y2=4.88
cc_762 ( N_CLK_M38_noxref_g N_RN_M40_noxref_g ) capacitor c=0.0101598f \
 //x=17.11 //y=6.2 //x2=17.99 //y2=6.2
cc_763 ( N_CLK_M39_noxref_g N_RN_M40_noxref_g ) capacitor c=0.0607518f \
 //x=17.55 //y=6.2 //x2=17.99 //y2=6.2
cc_764 ( N_CLK_M39_noxref_g N_RN_M41_noxref_g ) capacitor c=0.0101598f \
 //x=17.55 //y=6.2 //x2=18.43 //y2=6.2
cc_765 ( N_CLK_c_809_n N_RN_c_1572_n ) capacitor c=0.00456962f //x=17.23 \
 //y=1.09 //x2=18.24 //y2=1.095
cc_766 ( N_CLK_c_810_n N_RN_c_1573_n ) capacitor c=0.00438372f //x=17.23 \
 //y=1.4 //x2=18.24 //y2=1.44
cc_767 ( N_CLK_c_811_n N_RN_c_1574_n ) capacitor c=0.00438372f //x=17.23 \
 //y=1.63 //x2=18.24 //y2=1.75
cc_768 ( N_CLK_c_772_n N_RN_c_1575_n ) capacitor c=0.00139071f //x=17.14 \
 //y=2.375 //x2=18.25 //y2=2.26
cc_769 ( N_CLK_c_793_n N_RN_c_1575_n ) capacitor c=0.00204868f //x=17.14 \
 //y=2.26 //x2=18.25 //y2=2.26
cc_770 ( N_CLK_c_812_n N_RN_c_1575_n ) capacitor c=0.00933826f //x=17.23 \
 //y=2.095 //x2=18.25 //y2=2.26
cc_771 ( N_CLK_c_812_n N_RN_c_1578_n ) capacitor c=0.00438372f //x=17.23 \
 //y=2.095 //x2=18.25 //y2=2.095
cc_772 ( N_CLK_c_776_n N_RN_c_1579_n ) capacitor c=4.86312e-19 //x=17.14 \
 //y=4.765 //x2=18.25 //y2=4.88
cc_773 ( N_CLK_c_797_n N_RN_c_1579_n ) capacitor c=0.0015499f //x=17.14 \
 //y=4.88 //x2=18.25 //y2=4.88
cc_774 ( N_CLK_c_893_p N_RN_c_1579_n ) capacitor c=0.0616777f //x=17.475 \
 //y=4.97 //x2=18.25 //y2=4.88
cc_775 ( N_CLK_c_815_n N_RN_c_1579_n ) capacitor c=0.0042693f //x=17.14 \
 //y=4.88 //x2=18.25 //y2=4.88
cc_776 ( N_CLK_c_733_n SN ) capacitor c=0.0256962f //x=13.795 //y=3.51 \
 //x2=12.33 //y2=3.14
cc_777 ( N_CLK_c_733_n N_SN_c_2239_n ) capacitor c=0.00347614f //x=13.795 \
 //y=3.51 //x2=12.33 //y2=2.935
cc_778 ( N_CLK_c_733_n N_SN_c_2279_n ) capacitor c=0.0671622f //x=13.795 \
 //y=3.51 //x2=13.795 //y2=2.77
cc_779 ( N_CLK_c_784_n N_SN_c_2283_n ) capacitor c=0.00796307f //x=14.395 \
 //y=3.525 //x2=14.395 //y2=2.755
cc_780 ( N_CLK_c_787_n N_SN_c_2287_n ) capacitor c=0.00798868f //x=15.645 \
 //y=3.51 //x2=15.645 //y2=2.77
cc_781 ( CLK N_SN_c_2290_n ) capacitor c=0.030075f //x=17.14 //y=3.14 \
 //x2=16.245 //y2=2.75
cc_782 ( N_CLK_c_772_n N_SN_c_2290_n ) capacitor c=0.00303238f //x=17.14 \
 //y=2.375 //x2=16.245 //y2=2.75
cc_783 ( N_CLK_c_775_n N_SN_c_2290_n ) capacitor c=0.0033314f //x=17.14 \
 //y=3.655 //x2=16.245 //y2=2.75
cc_784 ( N_CLK_c_791_n N_SN_c_2290_n ) capacitor c=0.0504142f //x=16.245 \
 //y=3.525 //x2=16.245 //y2=2.75
cc_785 ( N_CLK_c_733_n N_SN_c_2244_n ) capacitor c=0.0161618f //x=13.795 \
 //y=3.51 //x2=12.49 //y2=2.775
cc_786 ( N_CLK_c_720_n N_noxref_8_c_2605_n ) capacitor c=0.0116288f //x=7.52 \
 //y=2.375 //x2=8.63 //y2=2.375
cc_787 ( N_CLK_c_738_n N_noxref_8_c_2605_n ) capacitor c=5.39999e-19 //x=7.52 \
 //y=2.26 //x2=8.63 //y2=2.375
cc_788 ( N_CLK_c_757_n N_noxref_8_c_2605_n ) capacitor c=0.00141236f //x=7.61 \
 //y=2.095 //x2=8.63 //y2=2.375
cc_789 ( CLK N_noxref_8_c_2606_n ) capacitor c=0.0251054f //x=7.52 //y=2.77 \
 //x2=8.63 //y2=4.09
cc_790 ( CLK N_noxref_8_c_2606_n ) capacitor c=0.00949568f //x=7.52 //y=4.25 \
 //x2=8.63 //y2=4.09
cc_791 ( CLK N_noxref_8_c_2606_n ) capacitor c=3.43503e-19 //x=7.52 //y=3.51 \
 //x2=8.63 //y2=4.09
cc_792 ( N_CLK_c_724_n N_noxref_8_c_2606_n ) capacitor c=0.0077695f //x=7.52 \
 //y=3.675 //x2=8.63 //y2=4.09
cc_793 ( N_CLK_c_730_n N_noxref_8_c_2606_n ) capacitor c=0.0214302f //x=8.985 \
 //y=3.51 //x2=8.63 //y2=4.09
cc_794 ( N_CLK_c_736_n N_noxref_8_c_2606_n ) capacitor c=0.00231654f //x=7.675 \
 //y=3.515 //x2=8.63 //y2=4.09
cc_795 ( N_CLK_c_738_n N_noxref_8_c_2606_n ) capacitor c=4.16726e-19 //x=7.52 \
 //y=2.26 //x2=8.63 //y2=4.09
cc_796 ( CLK N_noxref_8_c_2693_n ) capacitor c=0.00781079f //x=7.52 //y=4.25 \
 //x2=8.63 //y2=4.41
cc_797 ( CLK N_noxref_8_c_2611_n ) capacitor c=0.00710023f //x=7.52 //y=4.25 \
 //x2=8.63 //y2=4.75
cc_798 ( N_CLK_c_726_n N_noxref_8_c_2611_n ) capacitor c=0.0107551f //x=7.52 \
 //y=4.765 //x2=8.63 //y2=4.75
cc_799 ( N_CLK_c_742_n N_noxref_8_c_2611_n ) capacitor c=9.49821e-19 //x=7.52 \
 //y=4.88 //x2=8.63 //y2=4.75
cc_800 ( N_CLK_c_760_n N_noxref_8_c_2611_n ) capacitor c=8.42568e-19 //x=7.52 \
 //y=4.88 //x2=8.63 //y2=4.75
cc_801 ( N_CLK_c_733_n N_noxref_8_c_2613_n ) capacitor c=0.02508f //x=13.795 \
 //y=3.51 //x2=13.44 //y2=4.09
cc_802 ( N_CLK_c_775_n N_noxref_8_c_2634_n ) capacitor c=0.0015868f //x=17.14 \
 //y=3.655 //x2=17.21 //y2=5.335
cc_803 ( N_CLK_c_776_n N_noxref_8_c_2634_n ) capacitor c=0.0213631f //x=17.14 \
 //y=4.765 //x2=17.21 //y2=5.335
cc_804 ( N_CLK_c_797_n N_noxref_8_c_2634_n ) capacitor c=0.00492634f //x=17.14 \
 //y=4.88 //x2=17.21 //y2=5.335
cc_805 ( N_CLK_M38_noxref_g N_noxref_8_c_2634_n ) capacitor c=0.00858241f \
 //x=17.11 //y=6.2 //x2=17.21 //y2=5.335
cc_806 ( N_CLK_c_815_n N_noxref_8_c_2634_n ) capacitor c=5.67733e-19 //x=17.14 \
 //y=4.88 //x2=17.21 //y2=5.335
cc_807 ( N_CLK_M39_noxref_g N_noxref_8_c_2704_n ) capacitor c=0.00955829f \
 //x=17.55 //y=6.2 //x2=18.095 //y2=5.335
cc_808 ( CLK N_noxref_8_c_2705_n ) capacitor c=0.00201442f //x=17.14 //y=3.14 \
 //x2=18.99 //y2=4.09
cc_809 ( N_CLK_c_776_n N_noxref_8_c_2705_n ) capacitor c=4.06604e-19 //x=17.14 \
 //y=4.765 //x2=18.99 //y2=4.09
cc_810 ( N_CLK_c_776_n N_noxref_8_c_2707_n ) capacitor c=4.76359e-19 //x=17.14 \
 //y=4.765 //x2=18.99 //y2=5.25
cc_811 ( CLK N_noxref_8_c_2708_n ) capacitor c=3.03045e-19 //x=7.52 //y=4.25 \
 //x2=8.625 //y2=4.25
cc_812 ( N_CLK_c_775_n N_noxref_8_c_2709_n ) capacitor c=5.89563e-19 //x=17.14 \
 //y=3.655 //x2=17.33 //y2=5.335
cc_813 ( N_CLK_c_776_n N_noxref_8_c_2709_n ) capacitor c=0.00239361f //x=17.14 \
 //y=4.765 //x2=17.33 //y2=5.335
cc_814 ( N_CLK_c_797_n N_noxref_8_c_2709_n ) capacitor c=0.00132214f //x=17.14 \
 //y=4.88 //x2=17.33 //y2=5.335
cc_815 ( N_CLK_M38_noxref_g N_noxref_8_c_2709_n ) capacitor c=0.00229818f \
 //x=17.11 //y=6.2 //x2=17.33 //y2=5.335
cc_816 ( N_CLK_M39_noxref_g N_noxref_8_c_2709_n ) capacitor c=0.00230699f \
 //x=17.55 //y=6.2 //x2=17.33 //y2=5.335
cc_817 ( N_CLK_c_893_p N_noxref_8_c_2709_n ) capacitor c=0.00174293f \
 //x=17.475 //y=4.97 //x2=17.33 //y2=5.335
cc_818 ( N_CLK_c_730_n N_noxref_8_c_2715_n ) capacitor c=0.00368573f //x=8.985 \
 //y=3.51 //x2=8.985 //y2=4.25
cc_819 ( CLK N_noxref_8_c_2716_n ) capacitor c=0.00516203f //x=7.52 //y=4.25 \
 //x2=8.785 //y2=4.25
cc_820 ( N_CLK_c_731_n N_noxref_8_c_2717_n ) capacitor c=0.00180214f //x=9.585 \
 //y=3.495 //x2=9.585 //y2=4.265
cc_821 ( N_CLK_c_776_n N_noxref_8_c_2642_n ) capacitor c=0.0234979f //x=17.14 \
 //y=4.765 //x2=18.83 //y2=4.25
cc_822 ( N_CLK_c_733_n N_noxref_8_c_2642_n ) capacitor c=0.00555341f \
 //x=13.795 //y=3.51 //x2=18.83 //y2=4.25
cc_823 ( N_CLK_c_784_n N_noxref_8_c_2642_n ) capacitor c=0.00793912f \
 //x=14.395 //y=3.525 //x2=18.83 //y2=4.25
cc_824 ( N_CLK_c_787_n N_noxref_8_c_2642_n ) capacitor c=0.00305016f \
 //x=15.645 //y=3.51 //x2=18.83 //y2=4.25
cc_825 ( N_CLK_c_791_n N_noxref_8_c_2642_n ) capacitor c=0.00461925f \
 //x=16.245 //y=3.525 //x2=18.83 //y2=4.25
cc_826 ( N_CLK_c_731_n N_noxref_8_c_2616_n ) capacitor c=0.0234001f //x=9.585 \
 //y=3.495 //x2=13.595 //y2=4.25
cc_827 ( CLK N_noxref_8_c_2724_n ) capacitor c=4.16726e-19 //x=7.52 //y=2.77 \
 //x2=8.63 //y2=2.26
cc_828 ( N_CLK_c_720_n N_noxref_8_c_2724_n ) capacitor c=5.42289e-19 //x=7.52 \
 //y=2.375 //x2=8.63 //y2=2.26
cc_829 ( N_CLK_c_738_n N_noxref_8_c_2724_n ) capacitor c=0.00125213f //x=7.52 \
 //y=2.26 //x2=8.63 //y2=2.26
cc_830 ( N_CLK_c_757_n N_noxref_8_c_2724_n ) capacitor c=0.00209664f //x=7.61 \
 //y=2.095 //x2=8.63 //y2=2.26
cc_831 ( CLK N_noxref_8_c_2728_n ) capacitor c=2.94497e-19 //x=7.52 //y=4.25 \
 //x2=8.63 //y2=4.88
cc_832 ( N_CLK_c_726_n N_noxref_8_c_2728_n ) capacitor c=4.56604e-19 //x=7.52 \
 //y=4.765 //x2=8.63 //y2=4.88
cc_833 ( N_CLK_c_742_n N_noxref_8_c_2728_n ) capacitor c=0.00113985f //x=7.52 \
 //y=4.88 //x2=8.63 //y2=4.88
cc_834 ( N_CLK_c_760_n N_noxref_8_c_2728_n ) capacitor c=0.00129812f //x=7.52 \
 //y=4.88 //x2=8.63 //y2=4.88
cc_835 ( N_CLK_c_776_n N_noxref_8_c_2732_n ) capacitor c=6.21282e-19 //x=17.14 \
 //y=4.765 //x2=17.33 //y2=5.56
cc_836 ( N_CLK_M38_noxref_g N_noxref_8_c_2732_n ) capacitor c=0.0179041f \
 //x=17.11 //y=6.2 //x2=17.33 //y2=5.56
cc_837 ( N_CLK_M39_noxref_g N_noxref_8_c_2732_n ) capacitor c=0.0179041f \
 //x=17.55 //y=6.2 //x2=17.33 //y2=5.56
cc_838 ( N_CLK_c_893_p N_noxref_8_c_2732_n ) capacitor c=0.00290085f \
 //x=17.475 //y=4.97 //x2=17.33 //y2=5.56
cc_839 ( N_CLK_M26_noxref_g N_noxref_8_M28_noxref_g ) capacitor c=0.0101598f \
 //x=7.49 //y=6.2 //x2=8.37 //y2=6.2
cc_840 ( N_CLK_M27_noxref_g N_noxref_8_M28_noxref_g ) capacitor c=0.0607518f \
 //x=7.93 //y=6.2 //x2=8.37 //y2=6.2
cc_841 ( N_CLK_M27_noxref_g N_noxref_8_M29_noxref_g ) capacitor c=0.0101598f \
 //x=7.93 //y=6.2 //x2=8.81 //y2=6.2
cc_842 ( N_CLK_c_754_n N_noxref_8_c_2739_n ) capacitor c=0.00456962f //x=7.61 \
 //y=1.09 //x2=8.62 //y2=1.095
cc_843 ( N_CLK_c_755_n N_noxref_8_c_2740_n ) capacitor c=0.00438372f //x=7.61 \
 //y=1.4 //x2=8.62 //y2=1.44
cc_844 ( N_CLK_c_756_n N_noxref_8_c_2741_n ) capacitor c=0.00438372f //x=7.61 \
 //y=1.63 //x2=8.62 //y2=1.75
cc_845 ( N_CLK_c_720_n N_noxref_8_c_2742_n ) capacitor c=0.00139071f //x=7.52 \
 //y=2.375 //x2=8.63 //y2=2.26
cc_846 ( N_CLK_c_738_n N_noxref_8_c_2742_n ) capacitor c=0.00204868f //x=7.52 \
 //y=2.26 //x2=8.63 //y2=2.26
cc_847 ( N_CLK_c_757_n N_noxref_8_c_2742_n ) capacitor c=0.00933826f //x=7.61 \
 //y=2.095 //x2=8.63 //y2=2.26
cc_848 ( N_CLK_c_757_n N_noxref_8_c_2745_n ) capacitor c=0.00438372f //x=7.61 \
 //y=2.095 //x2=8.63 //y2=2.095
cc_849 ( N_CLK_c_726_n N_noxref_8_c_2746_n ) capacitor c=0.00124604f //x=7.52 \
 //y=4.765 //x2=8.63 //y2=4.88
cc_850 ( N_CLK_c_742_n N_noxref_8_c_2746_n ) capacitor c=0.00187046f //x=7.52 \
 //y=4.88 //x2=8.63 //y2=4.88
cc_851 ( N_CLK_c_835_p N_noxref_8_c_2746_n ) capacitor c=0.0616777f //x=7.855 \
 //y=4.97 //x2=8.63 //y2=4.88
cc_852 ( N_CLK_c_760_n N_noxref_8_c_2746_n ) capacitor c=0.00487508f //x=7.52 \
 //y=4.88 //x2=8.63 //y2=4.88
cc_853 ( N_CLK_M26_noxref_g N_VDD_c_3615_n ) capacitor c=0.00705252f //x=7.49 \
 //y=6.2 //x2=8.065 //y2=7.585
cc_854 ( N_CLK_M27_noxref_g N_VDD_c_3615_n ) capacitor c=0.00755544f //x=7.93 \
 //y=6.2 //x2=8.065 //y2=7.585
cc_855 ( N_CLK_M38_noxref_g N_VDD_c_3617_n ) capacitor c=0.00705252f //x=17.11 \
 //y=6.2 //x2=17.685 //y2=7.585
cc_856 ( N_CLK_M39_noxref_g N_VDD_c_3617_n ) capacitor c=0.00755544f //x=17.55 \
 //y=6.2 //x2=17.685 //y2=7.585
cc_857 ( N_CLK_M26_noxref_g N_VDD_M25_noxref_d ) capacitor c=0.015318f \
 //x=7.49 //y=6.2 //x2=7.125 //y2=5.2
cc_858 ( N_CLK_M27_noxref_g N_VDD_M27_noxref_d ) capacitor c=0.015318f \
 //x=7.93 //y=6.2 //x2=8.005 //y2=5.2
cc_859 ( N_CLK_M38_noxref_g N_VDD_M37_noxref_d ) capacitor c=0.015318f \
 //x=17.11 //y=6.2 //x2=16.745 //y2=5.2
cc_860 ( N_CLK_M39_noxref_g N_VDD_M39_noxref_d ) capacitor c=0.015318f \
 //x=17.55 //y=6.2 //x2=17.625 //y2=5.2
cc_861 ( N_CLK_c_754_n N_noxref_13_c_4066_n ) capacitor c=0.00123426f //x=7.61 \
 //y=1.09 //x2=8.315 //y2=1.175
cc_862 ( N_CLK_c_755_n N_noxref_13_c_4066_n ) capacitor c=0.0129288f //x=7.61 \
 //y=1.4 //x2=8.315 //y2=1.175
cc_863 ( N_CLK_c_756_n N_noxref_13_c_4066_n ) capacitor c=0.00132209f //x=7.61 \
 //y=1.63 //x2=8.315 //y2=1.175
cc_864 ( N_CLK_c_720_n N_noxref_13_M4_noxref_d ) capacitor c=0.00606292f \
 //x=7.52 //y=2.375 //x2=7.16 //y2=1.09
cc_865 ( N_CLK_c_738_n N_noxref_13_M4_noxref_d ) capacitor c=2.2052e-19 \
 //x=7.52 //y=2.26 //x2=7.16 //y2=1.09
cc_866 ( N_CLK_c_749_n N_noxref_13_M4_noxref_d ) capacitor c=0.00253592f \
 //x=7.085 //y=1.09 //x2=7.16 //y2=1.09
cc_867 ( N_CLK_c_752_n N_noxref_13_M4_noxref_d ) capacitor c=0.00604087f \
 //x=7.085 //y=1.4 //x2=7.16 //y2=1.09
cc_868 ( N_CLK_c_987_p N_noxref_13_M4_noxref_d ) capacitor c=0.002686f \
 //x=7.455 //y=0.935 //x2=7.16 //y2=1.09
cc_869 ( N_CLK_c_988_p N_noxref_13_M4_noxref_d ) capacitor c=0.00251995f \
 //x=7.455 //y=1.555 //x2=7.16 //y2=1.09
cc_870 ( N_CLK_c_754_n N_noxref_13_M4_noxref_d ) capacitor c=0.00314523f \
 //x=7.61 //y=1.09 //x2=7.16 //y2=1.09
cc_871 ( N_CLK_c_755_n N_noxref_13_M4_noxref_d ) capacitor c=0.00168289f \
 //x=7.61 //y=1.4 //x2=7.16 //y2=1.09
cc_872 ( N_CLK_c_756_n N_noxref_13_M4_noxref_d ) capacitor c=0.00111165f \
 //x=7.61 //y=1.63 //x2=7.16 //y2=1.09
cc_873 ( N_CLK_c_754_n N_noxref_13_M5_noxref_s ) capacitor c=7.21316e-19 \
 //x=7.61 //y=1.09 //x2=8.265 //y2=0.555
cc_874 ( N_CLK_c_755_n N_noxref_13_M5_noxref_s ) capacitor c=0.00365271f \
 //x=7.61 //y=1.4 //x2=8.265 //y2=0.555
cc_875 ( N_CLK_c_757_n N_noxref_13_M5_noxref_s ) capacitor c=9.86711e-19 \
 //x=7.61 //y=2.095 //x2=8.265 //y2=0.555
cc_876 ( N_CLK_c_809_n N_noxref_15_c_4208_n ) capacitor c=0.00123426f \
 //x=17.23 //y=1.09 //x2=17.935 //y2=1.175
cc_877 ( N_CLK_c_810_n N_noxref_15_c_4208_n ) capacitor c=0.0129288f //x=17.23 \
 //y=1.4 //x2=17.935 //y2=1.175
cc_878 ( N_CLK_c_811_n N_noxref_15_c_4208_n ) capacitor c=0.00132209f \
 //x=17.23 //y=1.63 //x2=17.935 //y2=1.175
cc_879 ( N_CLK_c_772_n N_noxref_15_M10_noxref_d ) capacitor c=0.00604066f \
 //x=17.14 //y=2.375 //x2=16.78 //y2=1.09
cc_880 ( N_CLK_c_775_n N_noxref_15_M10_noxref_d ) capacitor c=3.62462e-19 \
 //x=17.14 //y=3.655 //x2=16.78 //y2=1.09
cc_881 ( N_CLK_c_793_n N_noxref_15_M10_noxref_d ) capacitor c=2.2052e-19 \
 //x=17.14 //y=2.26 //x2=16.78 //y2=1.09
cc_882 ( N_CLK_c_804_n N_noxref_15_M10_noxref_d ) capacitor c=0.00253592f \
 //x=16.705 //y=1.09 //x2=16.78 //y2=1.09
cc_883 ( N_CLK_c_807_n N_noxref_15_M10_noxref_d ) capacitor c=0.00604087f \
 //x=16.705 //y=1.4 //x2=16.78 //y2=1.09
cc_884 ( N_CLK_c_1003_p N_noxref_15_M10_noxref_d ) capacitor c=0.002686f \
 //x=17.075 //y=0.935 //x2=16.78 //y2=1.09
cc_885 ( N_CLK_c_1004_p N_noxref_15_M10_noxref_d ) capacitor c=0.00249987f \
 //x=17.075 //y=1.555 //x2=16.78 //y2=1.09
cc_886 ( N_CLK_c_809_n N_noxref_15_M10_noxref_d ) capacitor c=0.00314523f \
 //x=17.23 //y=1.09 //x2=16.78 //y2=1.09
cc_887 ( N_CLK_c_810_n N_noxref_15_M10_noxref_d ) capacitor c=0.00168289f \
 //x=17.23 //y=1.4 //x2=16.78 //y2=1.09
cc_888 ( N_CLK_c_811_n N_noxref_15_M10_noxref_d ) capacitor c=0.00111165f \
 //x=17.23 //y=1.63 //x2=16.78 //y2=1.09
cc_889 ( N_CLK_c_809_n N_noxref_15_M11_noxref_s ) capacitor c=7.21316e-19 \
 //x=17.23 //y=1.09 //x2=17.885 //y2=0.555
cc_890 ( N_CLK_c_810_n N_noxref_15_M11_noxref_s ) capacitor c=0.00365271f \
 //x=17.23 //y=1.4 //x2=17.885 //y2=0.555
cc_891 ( N_CLK_c_812_n N_noxref_15_M11_noxref_s ) capacitor c=9.86711e-19 \
 //x=17.23 //y=2.095 //x2=17.885 //y2=0.555
cc_892 ( N_CLK_c_720_n N_GND_c_4450_n ) capacitor c=9.16602e-19 //x=7.52 \
 //y=2.375 //x2=11.1 //y2=0.175
cc_893 ( N_CLK_c_724_n N_GND_c_4450_n ) capacitor c=2.61468e-19 //x=7.52 \
 //y=3.675 //x2=11.1 //y2=0.175
cc_894 ( N_CLK_c_772_n N_GND_c_4452_n ) capacitor c=9.16602e-19 //x=17.14 \
 //y=2.375 //x2=20.72 //y2=0.175
cc_895 ( N_CLK_c_749_n N_noxref_20_c_4967_n ) capacitor c=0.0167228f //x=7.085 \
 //y=1.09 //x2=7.745 //y2=0.72
cc_896 ( N_CLK_c_754_n N_noxref_20_c_4967_n ) capacitor c=0.00534519f //x=7.61 \
 //y=1.09 //x2=7.745 //y2=0.72
cc_897 ( N_CLK_c_720_n N_noxref_20_c_4960_n ) capacitor c=0.0048147f //x=7.52 \
 //y=2.375 //x2=7.745 //y2=1.77
cc_898 ( N_CLK_c_724_n N_noxref_20_c_4960_n ) capacitor c=0.00210019f //x=7.52 \
 //y=3.675 //x2=7.745 //y2=1.77
cc_899 ( N_CLK_c_738_n N_noxref_20_c_4960_n ) capacitor c=0.0105652f //x=7.52 \
 //y=2.26 //x2=7.745 //y2=1.77
cc_900 ( N_CLK_c_752_n N_noxref_20_c_4960_n ) capacitor c=0.0153476f //x=7.085 \
 //y=1.4 //x2=7.745 //y2=1.77
cc_901 ( N_CLK_c_757_n N_noxref_20_c_4960_n ) capacitor c=0.0219438f //x=7.61 \
 //y=2.095 //x2=7.745 //y2=1.77
cc_902 ( N_CLK_c_724_n N_noxref_20_M3_noxref_s ) capacitor c=3.96991e-19 \
 //x=7.52 //y=3.675 //x2=5.755 //y2=0.555
cc_903 ( N_CLK_c_749_n N_noxref_20_M3_noxref_s ) capacitor c=0.00798959f \
 //x=7.085 //y=1.09 //x2=5.755 //y2=0.555
cc_904 ( N_CLK_c_756_n N_noxref_20_M3_noxref_s ) capacitor c=0.00212176f \
 //x=7.61 //y=1.63 //x2=5.755 //y2=0.555
cc_905 ( N_CLK_c_757_n N_noxref_20_M3_noxref_s ) capacitor c=0.00298115f \
 //x=7.61 //y=2.095 //x2=5.755 //y2=0.555
cc_906 ( N_CLK_c_733_n N_noxref_21_c_5012_n ) capacitor c=0.00280297f \
 //x=13.795 //y=3.51 //x2=11.585 //y2=1.77
cc_907 ( N_CLK_c_733_n N_noxref_21_c_5025_n ) capacitor c=0.00561751f \
 //x=13.795 //y=3.51 //x2=12.555 //y2=1.77
cc_908 ( N_CLK_c_733_n N_noxref_21_M6_noxref_s ) capacitor c=0.0026208f \
 //x=13.795 //y=3.51 //x2=10.565 //y2=0.555
cc_909 ( N_CLK_c_804_n N_noxref_22_c_5083_n ) capacitor c=0.0167228f \
 //x=16.705 //y=1.09 //x2=17.365 //y2=0.72
cc_910 ( N_CLK_c_809_n N_noxref_22_c_5083_n ) capacitor c=0.00534519f \
 //x=17.23 //y=1.09 //x2=17.365 //y2=0.72
cc_911 ( N_CLK_c_772_n N_noxref_22_c_5085_n ) capacitor c=0.0048147f //x=17.14 \
 //y=2.375 //x2=17.365 //y2=1.77
cc_912 ( N_CLK_c_775_n N_noxref_22_c_5085_n ) capacitor c=0.0021949f //x=17.14 \
 //y=3.655 //x2=17.365 //y2=1.77
cc_913 ( N_CLK_c_793_n N_noxref_22_c_5085_n ) capacitor c=0.0105652f //x=17.14 \
 //y=2.26 //x2=17.365 //y2=1.77
cc_914 ( N_CLK_c_807_n N_noxref_22_c_5085_n ) capacitor c=0.0153476f \
 //x=16.705 //y=1.4 //x2=17.365 //y2=1.77
cc_915 ( N_CLK_c_812_n N_noxref_22_c_5085_n ) capacitor c=0.0218132f //x=17.23 \
 //y=2.095 //x2=17.365 //y2=1.77
cc_916 ( N_CLK_c_804_n N_noxref_22_M9_noxref_s ) capacitor c=0.00798959f \
 //x=16.705 //y=1.09 //x2=15.375 //y2=0.555
cc_917 ( N_CLK_c_811_n N_noxref_22_M9_noxref_s ) capacitor c=0.00212176f \
 //x=17.23 //y=1.63 //x2=15.375 //y2=0.555
cc_918 ( N_CLK_c_812_n N_noxref_22_M9_noxref_s ) capacitor c=0.00298115f \
 //x=17.23 //y=2.095 //x2=15.375 //y2=0.555
cc_919 ( N_noxref_4_c_1039_n RN ) capacitor c=0.0402918f //x=3.82 //y=3.72 \
 //x2=2.71 //y2=2.77
cc_920 ( N_noxref_4_c_1046_n RN ) capacitor c=0.00775314f //x=3.82 //y=4.04 \
 //x2=2.71 //y2=2.77
cc_921 ( N_noxref_4_c_1051_n RN ) capacitor c=0.0174173f //x=3.82 //y=4.75 \
 //x2=2.71 //y2=2.77
cc_922 ( N_noxref_4_c_1067_n RN ) capacitor c=3.35971e-19 //x=3.82 //y=3.88 \
 //x2=2.71 //y2=2.77
cc_923 ( N_noxref_4_c_1081_n RN ) capacitor c=0.00508138f //x=3.98 //y=3.88 \
 //x2=2.71 //y2=2.77
cc_924 ( N_noxref_4_c_1086_n RN ) capacitor c=4.16726e-19 //x=3.82 //y=2.26 \
 //x2=2.71 //y2=2.77
cc_925 ( N_noxref_4_c_1176_p RN ) capacitor c=0.00188013f //x=20.84 //y=3.705 \
 //x2=18.25 //y2=3.14
cc_926 ( N_noxref_4_c_1177_p RN ) capacitor c=0.00104378f //x=20.84 //y=4.755 \
 //x2=18.25 //y2=3.14
cc_927 ( N_noxref_4_c_1128_n RN ) capacitor c=0.0266689f //x=18.605 //y=3.88 \
 //x2=18.25 //y2=3.14
cc_928 ( N_noxref_4_c_1176_p RN ) capacitor c=0.0382592f //x=20.84 //y=3.705 \
 //x2=21.95 //y2=3.14
cc_929 ( N_noxref_4_c_1180_p RN ) capacitor c=0.00787197f //x=20.84 //y=4.025 \
 //x2=21.95 //y2=3.14
cc_930 ( N_noxref_4_c_1177_p RN ) capacitor c=0.0143032f //x=20.84 //y=4.755 \
 //x2=21.95 //y2=3.14
cc_931 ( N_noxref_4_c_1182_p RN ) capacitor c=3.40764e-19 //x=20.84 //y=3.88 \
 //x2=21.95 //y2=3.14
cc_932 ( N_noxref_4_c_1183_p RN ) capacitor c=0.00311109f //x=19.205 //y=3.865 \
 //x2=21.95 //y2=3.14
cc_933 ( N_noxref_4_c_1184_p RN ) capacitor c=4.16726e-19 //x=20.84 //y=2.26 \
 //x2=21.95 //y2=3.14
cc_934 ( N_noxref_4_c_1038_n N_RN_c_1598_n ) capacitor c=0.0116288f //x=3.82 \
 //y=2.375 //x2=2.71 //y2=2.375
cc_935 ( N_noxref_4_c_1086_n N_RN_c_1598_n ) capacitor c=5.42289e-19 //x=3.82 \
 //y=2.26 //x2=2.71 //y2=2.375
cc_936 ( N_noxref_4_c_1118_n N_RN_c_1598_n ) capacitor c=0.00139071f //x=3.82 \
 //y=2.26 //x2=2.71 //y2=2.375
cc_937 ( N_noxref_4_c_1188_p N_RN_c_1601_n ) capacitor c=0.0115546f //x=20.84 \
 //y=2.375 //x2=21.95 //y2=2.375
cc_938 ( N_noxref_4_c_1184_p N_RN_c_1601_n ) capacitor c=5.40058e-19 //x=20.84 \
 //y=2.26 //x2=21.95 //y2=2.375
cc_939 ( N_noxref_4_c_1190_p N_RN_c_1601_n ) capacitor c=0.00147006f //x=20.54 \
 //y=2.095 //x2=21.95 //y2=2.375
cc_940 ( N_noxref_4_c_1051_n N_RN_c_1514_n ) capacitor c=0.00724943f //x=3.82 \
 //y=4.75 //x2=2.71 //y2=4.875
cc_941 ( N_noxref_4_c_1087_n N_RN_c_1514_n ) capacitor c=7.19939e-19 //x=3.82 \
 //y=4.88 //x2=2.71 //y2=4.875
cc_942 ( N_noxref_4_c_1121_n N_RN_c_1514_n ) capacitor c=0.00153266f //x=3.82 \
 //y=4.88 //x2=2.71 //y2=4.875
cc_943 ( N_noxref_4_c_1177_p N_RN_c_1607_n ) capacitor c=0.0087834f //x=20.84 \
 //y=4.755 //x2=21.945 //y2=4.84
cc_944 ( N_noxref_4_c_1195_p N_RN_c_1607_n ) capacitor c=6.32742e-19 //x=20.84 \
 //y=4.88 //x2=21.945 //y2=4.84
cc_945 ( N_noxref_4_c_1196_p N_RN_c_1607_n ) capacitor c=7.51593e-19 \
 //x=21.405 //y=4.97 //x2=21.945 //y2=4.84
cc_946 ( N_noxref_4_c_1197_p N_RN_c_1607_n ) capacitor c=8.67242e-19 \
 //x=21.115 //y=4.97 //x2=21.945 //y2=4.84
cc_947 ( N_noxref_4_c_1046_n N_RN_c_1517_n ) capacitor c=0.00307153f //x=3.82 \
 //y=4.04 //x2=8.24 //y2=4.62
cc_948 ( N_noxref_4_c_1051_n N_RN_c_1517_n ) capacitor c=0.0309039f //x=3.82 \
 //y=4.75 //x2=8.24 //y2=4.62
cc_949 ( N_noxref_4_c_1136_n N_RN_c_1517_n ) capacitor c=0.00477136f //x=8.475 \
 //y=5.335 //x2=8.24 //y2=4.62
cc_950 ( N_noxref_4_c_1068_n N_RN_c_1517_n ) capacitor c=0.0296549f //x=6.832 \
 //y=5.335 //x2=8.24 //y2=4.62
cc_951 ( N_noxref_4_c_1142_n N_RN_c_1517_n ) capacitor c=0.0294174f //x=7.71 \
 //y=5.335 //x2=8.24 //y2=4.62
cc_952 ( N_noxref_4_c_1073_n N_RN_c_1517_n ) capacitor c=0.176892f //x=7.13 \
 //y=3.88 //x2=8.24 //y2=4.62
cc_953 ( N_noxref_4_c_1081_n N_RN_c_1517_n ) capacitor c=0.0161094f //x=3.98 \
 //y=3.88 //x2=8.24 //y2=4.62
cc_954 ( N_noxref_4_c_1082_n N_RN_c_1517_n ) capacitor c=0.0254771f //x=7.73 \
 //y=3.9 //x2=8.24 //y2=4.62
cc_955 ( N_noxref_4_c_1083_n N_RN_c_1517_n ) capacitor c=0.00449326f //x=8.24 \
 //y=3.88 //x2=8.24 //y2=4.62
cc_956 ( N_noxref_4_c_1125_n N_RN_c_1620_n ) capacitor c=0.0188517f //x=9.285 \
 //y=5.335 //x2=8.84 //y2=4.635
cc_957 ( N_noxref_4_c_1066_n N_RN_c_1620_n ) capacitor c=5.32263e-19 //x=9.37 \
 //y=5.25 //x2=8.84 //y2=4.635
cc_958 ( N_noxref_4_c_1209_p N_RN_c_1620_n ) capacitor c=0.00477136f //x=8.59 \
 //y=5.335 //x2=8.84 //y2=4.635
cc_959 ( N_noxref_4_c_1210_p N_RN_c_1620_n ) capacitor c=0.00449326f //x=8.84 \
 //y=3.865 //x2=8.84 //y2=4.635
cc_960 ( N_noxref_4_c_1084_n N_RN_c_1620_n ) capacitor c=0.00214222f //x=13.22 \
 //y=3.865 //x2=8.84 //y2=4.635
cc_961 ( N_noxref_4_c_1066_n N_RN_c_1523_n ) capacitor c=0.0297409f //x=9.37 \
 //y=5.25 //x2=13.05 //y2=4.62
cc_962 ( N_noxref_4_c_1084_n N_RN_c_1523_n ) capacitor c=0.023286f //x=13.22 \
 //y=3.865 //x2=13.05 //y2=4.62
cc_963 ( N_noxref_4_c_1127_n N_RN_c_1541_n ) capacitor c=0.00183926f //x=13.65 \
 //y=3.865 //x2=13.65 //y2=4.635
cc_964 ( N_noxref_4_c_1177_p N_RN_c_1628_n ) capacitor c=0.0386525f //x=20.84 \
 //y=4.755 //x2=19.208 //y2=4.632
cc_965 ( N_noxref_4_c_1183_p N_RN_c_1628_n ) capacitor c=0.00862068f \
 //x=19.205 //y=3.865 //x2=19.208 //y2=4.632
cc_966 ( N_noxref_4_c_1127_n N_RN_c_1543_n ) capacitor c=0.029471f //x=13.65 \
 //y=3.865 //x2=18.855 //y2=4.632
cc_967 ( N_noxref_4_c_1128_n N_RN_c_1543_n ) capacitor c=0.00179405f \
 //x=18.605 //y=3.88 //x2=18.855 //y2=4.632
cc_968 ( N_noxref_4_c_1051_n N_RN_c_1524_n ) capacitor c=0.00729764f //x=3.82 \
 //y=4.75 //x2=2.71 //y2=4.62
cc_969 ( N_noxref_4_c_1038_n N_RN_c_1633_n ) capacitor c=5.39999e-19 //x=3.82 \
 //y=2.375 //x2=2.71 //y2=2.26
cc_970 ( N_noxref_4_c_1039_n N_RN_c_1633_n ) capacitor c=4.16726e-19 //x=3.82 \
 //y=3.72 //x2=2.71 //y2=2.26
cc_971 ( N_noxref_4_c_1086_n N_RN_c_1633_n ) capacitor c=0.00125213f //x=3.82 \
 //y=2.26 //x2=2.71 //y2=2.26
cc_972 ( N_noxref_4_c_1118_n N_RN_c_1633_n ) capacitor c=0.00204868f //x=3.82 \
 //y=2.26 //x2=2.71 //y2=2.26
cc_973 ( N_noxref_4_c_1051_n N_RN_c_1525_n ) capacitor c=2.06418e-19 //x=3.82 \
 //y=4.75 //x2=2.71 //y2=4.88
cc_974 ( N_noxref_4_c_1087_n N_RN_c_1525_n ) capacitor c=0.00113668f //x=3.82 \
 //y=4.88 //x2=2.71 //y2=4.88
cc_975 ( N_noxref_4_c_1121_n N_RN_c_1525_n ) capacitor c=0.00192884f //x=3.82 \
 //y=4.88 //x2=2.71 //y2=4.88
cc_976 ( N_noxref_4_c_1188_p N_RN_c_1640_n ) capacitor c=5.39999e-19 //x=20.84 \
 //y=2.375 //x2=21.95 //y2=2.26
cc_977 ( N_noxref_4_c_1176_p N_RN_c_1640_n ) capacitor c=4.16726e-19 //x=20.84 \
 //y=3.705 //x2=21.95 //y2=2.26
cc_978 ( N_noxref_4_c_1184_p N_RN_c_1640_n ) capacitor c=0.00125213f //x=20.84 \
 //y=2.26 //x2=21.95 //y2=2.26
cc_979 ( N_noxref_4_c_1190_p N_RN_c_1640_n ) capacitor c=0.00214573f //x=20.54 \
 //y=2.095 //x2=21.95 //y2=2.26
cc_980 ( N_noxref_4_c_1177_p N_RN_c_1644_n ) capacitor c=4.9638e-19 //x=20.84 \
 //y=4.755 //x2=21.95 //y2=4.88
cc_981 ( N_noxref_4_c_1195_p N_RN_c_1644_n ) capacitor c=0.00113666f //x=20.84 \
 //y=4.88 //x2=21.95 //y2=4.88
cc_982 ( N_noxref_4_c_1196_p N_RN_c_1644_n ) capacitor c=0.00116563f \
 //x=21.405 //y=4.97 //x2=21.95 //y2=4.88
cc_983 ( N_noxref_4_c_1197_p N_RN_c_1644_n ) capacitor c=0.0012974f //x=21.115 \
 //y=4.97 //x2=21.95 //y2=4.88
cc_984 ( N_noxref_4_M22_noxref_g N_RN_M20_noxref_g ) capacitor c=0.0101598f \
 //x=3.56 //y=6.2 //x2=2.68 //y2=6.2
cc_985 ( N_noxref_4_M22_noxref_g N_RN_M21_noxref_g ) capacitor c=0.0607327f \
 //x=3.56 //y=6.2 //x2=3.12 //y2=6.2
cc_986 ( N_noxref_4_M23_noxref_g N_RN_M21_noxref_g ) capacitor c=0.0101598f \
 //x=4 //y=6.2 //x2=3.12 //y2=6.2
cc_987 ( N_noxref_4_M42_noxref_g N_RN_M44_noxref_g ) capacitor c=0.0106276f \
 //x=21.04 //y=6.2 //x2=21.92 //y2=6.2
cc_988 ( N_noxref_4_M43_noxref_g N_RN_M44_noxref_g ) capacitor c=0.107144f \
 //x=21.48 //y=6.2 //x2=21.92 //y2=6.2
cc_989 ( N_noxref_4_M43_noxref_g N_RN_M45_noxref_g ) capacitor c=0.0101598f \
 //x=21.48 //y=6.2 //x2=22.36 //y2=6.2
cc_990 ( N_noxref_4_c_1100_n N_RN_c_1654_n ) capacitor c=0.00456962f //x=3.81 \
 //y=1.095 //x2=2.8 //y2=1.09
cc_991 ( N_noxref_4_c_1102_n N_RN_c_1655_n ) capacitor c=0.00438372f //x=3.81 \
 //y=1.44 //x2=2.8 //y2=1.4
cc_992 ( N_noxref_4_c_1105_n N_RN_c_1656_n ) capacitor c=0.00438372f //x=3.81 \
 //y=1.75 //x2=2.8 //y2=1.63
cc_993 ( N_noxref_4_c_1038_n N_RN_c_1657_n ) capacitor c=0.00141236f //x=3.82 \
 //y=2.375 //x2=2.8 //y2=2.095
cc_994 ( N_noxref_4_c_1086_n N_RN_c_1657_n ) capacitor c=0.00209664f //x=3.82 \
 //y=2.26 //x2=2.8 //y2=2.095
cc_995 ( N_noxref_4_c_1118_n N_RN_c_1657_n ) capacitor c=0.00933826f //x=3.82 \
 //y=2.26 //x2=2.8 //y2=2.095
cc_996 ( N_noxref_4_c_1119_n N_RN_c_1657_n ) capacitor c=0.00438372f //x=3.82 \
 //y=2.095 //x2=2.8 //y2=2.095
cc_997 ( N_noxref_4_c_1121_n N_RN_c_1533_n ) capacitor c=0.0616586f //x=3.82 \
 //y=4.88 //x2=3.045 //y2=4.97
cc_998 ( N_noxref_4_c_1249_p N_RN_c_1662_n ) capacitor c=5.72528e-19 //x=20.54 \
 //y=1.055 //x2=21.515 //y2=1.09
cc_999 ( N_noxref_4_c_1250_p N_RN_c_1662_n ) capacitor c=0.00150277f //x=20.54 \
 //y=1.4 //x2=21.515 //y2=1.09
cc_1000 ( N_noxref_4_c_1251_p N_RN_c_1662_n ) capacitor c=0.0160123f //x=21.07 \
 //y=1.055 //x2=21.515 //y2=1.09
cc_1001 ( N_noxref_4_c_1252_p N_RN_c_1665_n ) capacitor c=0.00111227f \
 //x=20.54 //y=1.71 //x2=21.515 //y2=1.4
cc_1002 ( N_noxref_4_c_1253_p N_RN_c_1665_n ) capacitor c=0.0124075f //x=21.07 \
 //y=1.4 //x2=21.515 //y2=1.4
cc_1003 ( N_noxref_4_c_1251_p N_RN_c_1667_n ) capacitor c=9.19165e-19 \
 //x=21.07 //y=1.055 //x2=22.04 //y2=1.09
cc_1004 ( N_noxref_4_c_1253_p N_RN_c_1668_n ) capacitor c=0.0010154f //x=21.07 \
 //y=1.4 //x2=22.04 //y2=1.4
cc_1005 ( N_noxref_4_c_1253_p N_RN_c_1669_n ) capacitor c=9.23422e-19 \
 //x=21.07 //y=1.4 //x2=22.04 //y2=1.63
cc_1006 ( N_noxref_4_c_1188_p N_RN_c_1670_n ) capacitor c=0.00140534f \
 //x=20.84 //y=2.375 //x2=22.04 //y2=2.095
cc_1007 ( N_noxref_4_c_1184_p N_RN_c_1670_n ) capacitor c=0.0020754f //x=20.84 \
 //y=2.26 //x2=22.04 //y2=2.095
cc_1008 ( N_noxref_4_c_1190_p N_RN_c_1670_n ) capacitor c=0.00964411f \
 //x=20.54 //y=2.095 //x2=22.04 //y2=2.095
cc_1009 ( N_noxref_4_c_1087_n N_RN_c_1535_n ) capacitor c=9.77556e-19 //x=3.82 \
 //y=4.88 //x2=2.71 //y2=4.88
cc_1010 ( N_noxref_4_c_1121_n N_RN_c_1535_n ) capacitor c=0.0042693f //x=3.82 \
 //y=4.88 //x2=2.71 //y2=4.88
cc_1011 ( N_noxref_4_c_1195_p N_RN_c_1675_n ) capacitor c=0.00123917f \
 //x=20.84 //y=4.88 //x2=21.95 //y2=4.88
cc_1012 ( N_noxref_4_c_1196_p N_RN_c_1675_n ) capacitor c=0.0169282f \
 //x=21.405 //y=4.97 //x2=21.95 //y2=4.88
cc_1013 ( N_noxref_4_c_1197_p N_RN_c_1675_n ) capacitor c=0.00406071f \
 //x=21.115 //y=4.97 //x2=21.95 //y2=4.88
cc_1014 ( N_noxref_4_M43_noxref_g N_QN_c_1946_n ) capacitor c=0.00893512f \
 //x=21.48 //y=6.2 //x2=22.02 //y2=5.335
cc_1015 ( N_noxref_4_M42_noxref_g N_QN_c_1947_n ) capacitor c=0.00461408f \
 //x=21.04 //y=6.2 //x2=21.262 //y2=5.335
cc_1016 ( N_noxref_4_M43_noxref_g N_QN_c_1947_n ) capacitor c=0.00229208f \
 //x=21.48 //y=6.2 //x2=21.262 //y2=5.335
cc_1017 ( N_noxref_4_c_1196_p N_QN_c_1947_n ) capacitor c=0.00171885f \
 //x=21.405 //y=4.97 //x2=21.262 //y2=5.335
cc_1018 ( N_noxref_4_M42_noxref_g N_QN_c_1950_n ) capacitor c=0.0162284f \
 //x=21.04 //y=6.2 //x2=21.26 //y2=5.56
cc_1019 ( N_noxref_4_M43_noxref_g N_QN_c_1950_n ) capacitor c=0.0179041f \
 //x=21.48 //y=6.2 //x2=21.26 //y2=5.56
cc_1020 ( N_noxref_4_c_1196_p N_QN_c_1950_n ) capacitor c=0.00291477f \
 //x=21.405 //y=4.97 //x2=21.26 //y2=5.56
cc_1021 ( N_noxref_4_c_1060_n SN ) capacitor c=9.10606e-19 //x=9.37 //y=3.72 \
 //x2=12.33 //y2=3.14
cc_1022 ( N_noxref_4_c_1066_n SN ) capacitor c=6.77746e-19 //x=9.37 //y=5.25 \
 //x2=12.33 //y2=3.14
cc_1023 ( N_noxref_4_c_1084_n SN ) capacitor c=0.0239363f //x=13.22 //y=3.865 \
 //x2=12.33 //y2=3.14
cc_1024 ( N_noxref_4_c_1060_n N_SN_c_2237_n ) capacitor c=5.25712e-19 //x=9.37 \
 //y=3.72 //x2=12.33 //y2=2.615
cc_1025 ( N_noxref_4_c_1127_n N_SN_c_2279_n ) capacitor c=0.00131102f \
 //x=13.65 //y=3.865 //x2=13.795 //y2=2.77
cc_1026 ( N_noxref_4_c_1084_n N_SN_c_2279_n ) capacitor c=0.00555802f \
 //x=13.22 //y=3.865 //x2=13.795 //y2=2.77
cc_1027 ( N_noxref_4_c_1128_n N_SN_c_2283_n ) capacitor c=4.2925e-19 \
 //x=18.605 //y=3.88 //x2=14.395 //y2=2.755
cc_1028 ( N_noxref_4_c_1188_p N_SN_c_2290_n ) capacitor c=0.00309104f \
 //x=20.84 //y=2.375 //x2=16.245 //y2=2.75
cc_1029 ( N_noxref_4_c_1176_p N_SN_c_2290_n ) capacitor c=0.0325701f //x=20.84 \
 //y=3.705 //x2=16.245 //y2=2.75
cc_1030 ( N_noxref_4_c_1180_p N_SN_c_2290_n ) capacitor c=0.0033428f //x=20.84 \
 //y=4.025 //x2=16.245 //y2=2.75
cc_1031 ( N_noxref_4_c_1128_n N_SN_c_2290_n ) capacitor c=0.0688264f \
 //x=18.605 //y=3.88 //x2=16.245 //y2=2.75
cc_1032 ( N_noxref_4_c_1183_p N_SN_c_2290_n ) capacitor c=0.0530765f \
 //x=19.205 //y=3.865 //x2=16.245 //y2=2.75
cc_1033 ( N_noxref_4_c_1060_n N_noxref_8_c_2605_n ) capacitor c=0.0154269f \
 //x=9.37 //y=3.72 //x2=8.63 //y2=2.375
cc_1034 ( N_noxref_4_c_1060_n N_noxref_8_c_2606_n ) capacitor c=0.0549466f \
 //x=9.37 //y=3.72 //x2=8.63 //y2=4.09
cc_1035 ( N_noxref_4_c_1065_n N_noxref_8_c_2606_n ) capacitor c=0.0146461f \
 //x=9.37 //y=4.04 //x2=8.63 //y2=4.09
cc_1036 ( N_noxref_4_c_1066_n N_noxref_8_c_2606_n ) capacitor c=0.00225729f \
 //x=9.37 //y=5.25 //x2=8.63 //y2=4.09
cc_1037 ( N_noxref_4_c_1288_p N_noxref_8_c_2606_n ) capacitor c=6.78671e-19 \
 //x=9.37 //y=3.88 //x2=8.63 //y2=4.09
cc_1038 ( N_noxref_4_c_1082_n N_noxref_8_c_2606_n ) capacitor c=3.26218e-19 \
 //x=7.73 //y=3.9 //x2=8.63 //y2=4.09
cc_1039 ( N_noxref_4_c_1083_n N_noxref_8_c_2606_n ) capacitor c=3.74737e-19 \
 //x=8.24 //y=3.88 //x2=8.63 //y2=4.09
cc_1040 ( N_noxref_4_c_1210_p N_noxref_8_c_2606_n ) capacitor c=0.0204322f \
 //x=8.84 //y=3.865 //x2=8.63 //y2=4.09
cc_1041 ( N_noxref_4_c_1084_n N_noxref_8_c_2606_n ) capacitor c=0.00316917f \
 //x=13.22 //y=3.865 //x2=8.63 //y2=4.09
cc_1042 ( N_noxref_4_c_1136_n N_noxref_8_c_2693_n ) capacitor c=0.00135731f \
 //x=8.475 //y=5.335 //x2=8.63 //y2=4.41
cc_1043 ( N_noxref_4_c_1125_n N_noxref_8_c_2693_n ) capacitor c=0.00215524f \
 //x=9.285 //y=5.335 //x2=8.63 //y2=4.41
cc_1044 ( N_noxref_4_c_1058_n N_noxref_8_c_2693_n ) capacitor c=6.90338e-19 \
 //x=8.97 //y=1.845 //x2=8.63 //y2=4.41
cc_1045 ( N_noxref_4_c_1066_n N_noxref_8_c_2693_n ) capacitor c=0.0170727f \
 //x=9.37 //y=5.25 //x2=8.63 //y2=4.41
cc_1046 ( N_noxref_4_c_1210_p N_noxref_8_c_2693_n ) capacitor c=0.00633952f \
 //x=8.84 //y=3.865 //x2=8.63 //y2=4.41
cc_1047 ( N_noxref_4_c_1298_p N_noxref_8_c_2693_n ) capacitor c=2.31899e-19 \
 //x=8.59 //y=5.56 //x2=8.63 //y2=4.41
cc_1048 ( N_noxref_4_c_1125_n N_noxref_8_c_2611_n ) capacitor c=0.00228424f \
 //x=9.285 //y=5.335 //x2=8.63 //y2=4.75
cc_1049 ( N_noxref_4_c_1066_n N_noxref_8_c_2611_n ) capacitor c=0.0276954f \
 //x=9.37 //y=5.25 //x2=8.63 //y2=4.75
cc_1050 ( N_noxref_4_c_1209_p N_noxref_8_c_2611_n ) capacitor c=0.02211f \
 //x=8.59 //y=5.335 //x2=8.63 //y2=4.75
cc_1051 ( N_noxref_4_c_1298_p N_noxref_8_c_2611_n ) capacitor c=0.00217653f \
 //x=8.59 //y=5.56 //x2=8.63 //y2=4.75
cc_1052 ( N_noxref_4_c_1127_n N_noxref_8_c_2613_n ) capacitor c=0.0216336f \
 //x=13.65 //y=3.865 //x2=13.44 //y2=4.09
cc_1053 ( N_noxref_4_c_1084_n N_noxref_8_c_2613_n ) capacitor c=3.74602e-19 \
 //x=13.22 //y=3.865 //x2=13.44 //y2=4.09
cc_1054 ( N_noxref_4_c_1127_n N_noxref_8_c_2625_n ) capacitor c=0.00450264f \
 //x=13.65 //y=3.865 //x2=13.44 //y2=4.41
cc_1055 ( N_noxref_4_c_1084_n N_noxref_8_c_2625_n ) capacitor c=0.00197547f \
 //x=13.22 //y=3.865 //x2=13.44 //y2=4.41
cc_1056 ( N_noxref_4_c_1188_p N_noxref_8_c_2705_n ) capacitor c=0.00458539f \
 //x=20.84 //y=2.375 //x2=18.99 //y2=4.09
cc_1057 ( N_noxref_4_c_1176_p N_noxref_8_c_2705_n ) capacitor c=0.022266f \
 //x=20.84 //y=3.705 //x2=18.99 //y2=4.09
cc_1058 ( N_noxref_4_c_1180_p N_noxref_8_c_2705_n ) capacitor c=0.00258423f \
 //x=20.84 //y=4.025 //x2=18.99 //y2=4.09
cc_1059 ( N_noxref_4_c_1177_p N_noxref_8_c_2705_n ) capacitor c=0.0011073f \
 //x=20.84 //y=4.755 //x2=18.99 //y2=4.09
cc_1060 ( N_noxref_4_c_1128_n N_noxref_8_c_2705_n ) capacitor c=3.12056e-19 \
 //x=18.605 //y=3.88 //x2=18.99 //y2=4.09
cc_1061 ( N_noxref_4_c_1183_p N_noxref_8_c_2705_n ) capacitor c=0.0283024f \
 //x=19.205 //y=3.865 //x2=18.99 //y2=4.09
cc_1062 ( N_noxref_4_c_1177_p N_noxref_8_c_2779_n ) capacitor c=0.00252412f \
 //x=20.84 //y=4.755 //x2=18.99 //y2=4.41
cc_1063 ( N_noxref_4_c_1183_p N_noxref_8_c_2779_n ) capacitor c=0.00918362f \
 //x=19.205 //y=3.865 //x2=18.99 //y2=4.41
cc_1064 ( N_noxref_4_c_1177_p N_noxref_8_c_2707_n ) capacitor c=0.00769177f \
 //x=20.84 //y=4.755 //x2=18.99 //y2=5.25
cc_1065 ( N_noxref_4_c_1066_n N_noxref_8_c_2708_n ) capacitor c=6.07756e-19 \
 //x=9.37 //y=5.25 //x2=8.625 //y2=4.25
cc_1066 ( N_noxref_4_c_1298_p N_noxref_8_c_2708_n ) capacitor c=2.70032e-19 \
 //x=8.59 //y=5.56 //x2=8.625 //y2=4.25
cc_1067 ( N_noxref_4_c_1065_n N_noxref_8_c_2715_n ) capacitor c=0.00127339f \
 //x=9.37 //y=4.04 //x2=8.985 //y2=4.25
cc_1068 ( N_noxref_4_c_1066_n N_noxref_8_c_2715_n ) capacitor c=2.7711e-19 \
 //x=9.37 //y=5.25 //x2=8.985 //y2=4.25
cc_1069 ( N_noxref_4_c_1210_p N_noxref_8_c_2715_n ) capacitor c=0.0107882f \
 //x=8.84 //y=3.865 //x2=8.985 //y2=4.25
cc_1070 ( N_noxref_4_c_1084_n N_noxref_8_c_2715_n ) capacitor c=0.0605463f \
 //x=13.22 //y=3.865 //x2=8.985 //y2=4.25
cc_1071 ( N_noxref_4_c_1066_n N_noxref_8_c_2716_n ) capacitor c=0.00305397f \
 //x=9.37 //y=5.25 //x2=8.785 //y2=4.25
cc_1072 ( N_noxref_4_c_1210_p N_noxref_8_c_2716_n ) capacitor c=0.0358834f \
 //x=8.84 //y=3.865 //x2=8.785 //y2=4.25
cc_1073 ( N_noxref_4_c_1065_n N_noxref_8_c_2717_n ) capacitor c=0.00758569f \
 //x=9.37 //y=4.04 //x2=9.585 //y2=4.265
cc_1074 ( N_noxref_4_c_1066_n N_noxref_8_c_2717_n ) capacitor c=0.0211151f \
 //x=9.37 //y=5.25 //x2=9.585 //y2=4.265
cc_1075 ( N_noxref_4_c_1084_n N_noxref_8_c_2717_n ) capacitor c=0.0109497f \
 //x=13.22 //y=3.865 //x2=9.585 //y2=4.265
cc_1076 ( N_noxref_4_c_1127_n N_noxref_8_c_2642_n ) capacitor c=0.447733f \
 //x=13.65 //y=3.865 //x2=18.83 //y2=4.25
cc_1077 ( N_noxref_4_c_1128_n N_noxref_8_c_2642_n ) capacitor c=0.0118795f \
 //x=18.605 //y=3.88 //x2=18.83 //y2=4.25
cc_1078 ( N_noxref_4_c_1066_n N_noxref_8_c_2616_n ) capacitor c=4.68301e-19 \
 //x=9.37 //y=5.25 //x2=13.595 //y2=4.25
cc_1079 ( N_noxref_4_c_1127_n N_noxref_8_c_2616_n ) capacitor c=0.0358686f \
 //x=13.65 //y=3.865 //x2=13.595 //y2=4.25
cc_1080 ( N_noxref_4_c_1084_n N_noxref_8_c_2616_n ) capacitor c=0.314816f \
 //x=13.22 //y=3.865 //x2=13.595 //y2=4.25
cc_1081 ( N_noxref_4_c_1177_p N_noxref_8_c_2798_n ) capacitor c=0.0015808f \
 //x=20.84 //y=4.755 //x2=19.15 //y2=4.25
cc_1082 ( N_noxref_4_c_1183_p N_noxref_8_c_2798_n ) capacitor c=0.0358686f \
 //x=19.205 //y=3.865 //x2=19.15 //y2=4.25
cc_1083 ( N_noxref_4_c_1180_p N_noxref_8_c_2800_n ) capacitor c=0.00823509f \
 //x=20.84 //y=4.025 //x2=27.71 //y2=4.265
cc_1084 ( N_noxref_4_c_1177_p N_noxref_8_c_2800_n ) capacitor c=0.0239731f \
 //x=20.84 //y=4.755 //x2=27.71 //y2=4.265
cc_1085 ( N_noxref_4_c_1183_p N_noxref_8_c_2800_n ) capacitor c=0.170238f \
 //x=19.205 //y=3.865 //x2=27.71 //y2=4.265
cc_1086 ( N_noxref_4_c_1060_n N_noxref_8_c_2724_n ) capacitor c=0.00163444f \
 //x=9.37 //y=3.72 //x2=8.63 //y2=2.26
cc_1087 ( N_noxref_4_c_1125_n N_noxref_8_c_2728_n ) capacitor c=0.00130631f \
 //x=9.285 //y=5.335 //x2=8.63 //y2=4.88
cc_1088 ( N_noxref_4_c_1066_n N_noxref_8_c_2728_n ) capacitor c=0.00131258f \
 //x=9.37 //y=5.25 //x2=8.63 //y2=4.88
cc_1089 ( N_noxref_4_c_1209_p N_noxref_8_c_2728_n ) capacitor c=0.00346456f \
 //x=8.59 //y=5.335 //x2=8.63 //y2=4.88
cc_1090 ( N_noxref_4_c_1298_p N_noxref_8_c_2728_n ) capacitor c=0.00552343f \
 //x=8.59 //y=5.56 //x2=8.63 //y2=4.88
cc_1091 ( N_noxref_4_c_1136_n N_noxref_8_M28_noxref_g ) capacitor \
 c=0.00953075f //x=8.475 //y=5.335 //x2=8.37 //y2=6.2
cc_1092 ( N_noxref_4_c_1124_n N_noxref_8_M28_noxref_g ) capacitor \
 c=0.00226521f //x=8.59 //y=5.56 //x2=8.37 //y2=6.2
cc_1093 ( N_noxref_4_c_1298_p N_noxref_8_M28_noxref_g ) capacitor c=0.0178885f \
 //x=8.59 //y=5.56 //x2=8.37 //y2=6.2
cc_1094 ( N_noxref_4_c_1124_n N_noxref_8_M29_noxref_g ) capacitor \
 c=0.00381703f //x=8.59 //y=5.56 //x2=8.81 //y2=6.2
cc_1095 ( N_noxref_4_c_1125_n N_noxref_8_M29_noxref_g ) capacitor c=0.010755f \
 //x=9.285 //y=5.335 //x2=8.81 //y2=6.2
cc_1096 ( N_noxref_4_c_1298_p N_noxref_8_M29_noxref_g ) capacitor c=0.0188608f \
 //x=8.59 //y=5.56 //x2=8.81 //y2=6.2
cc_1097 ( N_noxref_4_c_1057_n N_noxref_8_c_2739_n ) capacitor c=4.64015e-19 \
 //x=8.885 //y=1.305 //x2=8.62 //y2=1.095
cc_1098 ( N_noxref_4_M5_noxref_d N_noxref_8_c_2739_n ) capacitor c=0.00137165f \
 //x=8.695 //y=1.095 //x2=8.62 //y2=1.095
cc_1099 ( N_noxref_4_c_1057_n N_noxref_8_c_2740_n ) capacitor c=0.0026012f \
 //x=8.885 //y=1.305 //x2=8.62 //y2=1.44
cc_1100 ( N_noxref_4_c_1351_p N_noxref_8_c_2740_n ) capacitor c=0.00127432f \
 //x=8.885 //y=1.76 //x2=8.62 //y2=1.44
cc_1101 ( N_noxref_4_M5_noxref_d N_noxref_8_c_2740_n ) capacitor c=0.00237422f \
 //x=8.695 //y=1.095 //x2=8.62 //y2=1.44
cc_1102 ( N_noxref_4_c_1351_p N_noxref_8_c_2741_n ) capacitor c=0.00429966f \
 //x=8.885 //y=1.76 //x2=8.62 //y2=1.75
cc_1103 ( N_noxref_4_c_1057_n N_noxref_8_c_2820_n ) capacitor c=5.29969e-19 \
 //x=8.885 //y=1.305 //x2=8.995 //y2=0.94
cc_1104 ( N_noxref_4_M5_noxref_d N_noxref_8_c_2820_n ) capacitor c=0.0020782f \
 //x=8.695 //y=1.095 //x2=8.995 //y2=0.94
cc_1105 ( N_noxref_4_c_1057_n N_noxref_8_c_2822_n ) capacitor c=5.31244e-19 \
 //x=8.885 //y=1.305 //x2=8.995 //y2=1.595
cc_1106 ( N_noxref_4_c_1351_p N_noxref_8_c_2822_n ) capacitor c=0.00942306f \
 //x=8.885 //y=1.76 //x2=8.995 //y2=1.595
cc_1107 ( N_noxref_4_c_1126_n N_noxref_8_c_2822_n ) capacitor c=0.00194716f \
 //x=9.285 //y=1.845 //x2=8.995 //y2=1.595
cc_1108 ( N_noxref_4_M5_noxref_d N_noxref_8_c_2822_n ) capacitor c=0.00356097f \
 //x=8.695 //y=1.095 //x2=8.995 //y2=1.595
cc_1109 ( N_noxref_4_c_1057_n N_noxref_8_c_2826_n ) capacitor c=5.24634e-19 \
 //x=8.885 //y=1.305 //x2=9.15 //y2=1.095
cc_1110 ( N_noxref_4_M5_noxref_d N_noxref_8_c_2826_n ) capacitor c=0.00139206f \
 //x=8.695 //y=1.095 //x2=9.15 //y2=1.095
cc_1111 ( N_noxref_4_c_1057_n N_noxref_8_c_2828_n ) capacitor c=0.00307978f \
 //x=8.885 //y=1.305 //x2=9.15 //y2=1.44
cc_1112 ( N_noxref_4_c_1351_p N_noxref_8_c_2828_n ) capacitor c=0.00363411f \
 //x=8.885 //y=1.76 //x2=9.15 //y2=1.44
cc_1113 ( N_noxref_4_c_1126_n N_noxref_8_c_2828_n ) capacitor c=0.00323576f \
 //x=9.285 //y=1.845 //x2=9.15 //y2=1.44
cc_1114 ( N_noxref_4_M5_noxref_d N_noxref_8_c_2828_n ) capacitor c=0.00237422f \
 //x=8.695 //y=1.095 //x2=9.15 //y2=1.44
cc_1115 ( N_noxref_4_c_1060_n N_noxref_8_c_2742_n ) capacitor c=0.0025845f \
 //x=9.37 //y=3.72 //x2=8.63 //y2=2.26
cc_1116 ( N_noxref_4_c_1351_p N_noxref_8_c_2745_n ) capacitor c=0.0036273f \
 //x=8.885 //y=1.76 //x2=8.63 //y2=2.095
cc_1117 ( N_noxref_4_c_1060_n N_noxref_8_c_2745_n ) capacitor c=0.00282067f \
 //x=9.37 //y=3.72 //x2=8.63 //y2=2.095
cc_1118 ( N_noxref_4_c_1066_n N_noxref_8_c_2746_n ) capacitor c=0.00739875f \
 //x=9.37 //y=5.25 //x2=8.63 //y2=4.88
cc_1119 ( N_noxref_4_c_1209_p N_noxref_8_c_2746_n ) capacitor c=0.00203307f \
 //x=8.59 //y=5.335 //x2=8.63 //y2=4.88
cc_1120 ( N_noxref_4_c_1298_p N_noxref_8_c_2746_n ) capacitor c=0.00371829f \
 //x=8.59 //y=5.56 //x2=8.63 //y2=4.88
cc_1121 ( N_noxref_4_c_1176_p Q ) capacitor c=0.00178131f //x=20.84 //y=3.705 \
 //x2=23.06 //y2=2.4
cc_1122 ( N_noxref_4_c_1177_p Q ) capacitor c=8.3346e-19 //x=20.84 //y=4.755 \
 //x2=23.06 //y2=4.62
cc_1123 ( N_noxref_4_c_1182_p Q ) capacitor c=8.88433e-19 //x=20.84 //y=3.88 \
 //x2=23.06 //y2=3.88
cc_1124 ( N_noxref_4_c_1183_p N_Q_c_3221_n ) capacitor c=0.00243462f \
 //x=19.205 //y=3.865 //x2=23.21 //y2=3.865
cc_1125 ( N_noxref_4_c_1056_n N_VDD_c_3497_n ) capacitor c=0.00621352f \
 //x=7.59 //y=5.335 //x2=28.61 //y2=7.58
cc_1126 ( N_noxref_4_c_1136_n N_VDD_c_3497_n ) capacitor c=0.0062719f \
 //x=8.475 //y=5.335 //x2=28.61 //y2=7.58
cc_1127 ( N_noxref_4_c_1124_n N_VDD_c_3497_n ) capacitor c=0.00256019f \
 //x=8.59 //y=5.56 //x2=28.61 //y2=7.58
cc_1128 ( N_noxref_4_c_1125_n N_VDD_c_3497_n ) capacitor c=0.00829248f \
 //x=9.285 //y=5.335 //x2=28.61 //y2=7.58
cc_1129 ( N_noxref_4_c_1065_n N_VDD_c_3497_n ) capacitor c=5.1352e-19 //x=9.37 \
 //y=4.04 //x2=28.61 //y2=7.58
cc_1130 ( N_noxref_4_c_1180_p N_VDD_c_3497_n ) capacitor c=4.16002e-19 \
 //x=20.84 //y=4.025 //x2=28.61 //y2=7.58
cc_1131 ( N_noxref_4_c_1068_n N_VDD_c_3497_n ) capacitor c=0.00261804f \
 //x=6.832 //y=5.335 //x2=28.61 //y2=7.58
cc_1132 ( N_noxref_4_c_1142_n N_VDD_c_3497_n ) capacitor c=0.00270108f \
 //x=7.71 //y=5.335 //x2=28.61 //y2=7.58
cc_1133 ( N_noxref_4_c_1091_n N_VDD_c_3497_n ) capacitor c=0.0024232f //x=6.83 \
 //y=5.56 //x2=28.61 //y2=7.58
cc_1134 ( N_noxref_4_c_1165_n N_VDD_c_3497_n ) capacitor c=0.0024232f //x=7.71 \
 //y=5.56 //x2=28.61 //y2=7.58
cc_1135 ( N_noxref_4_c_1298_p N_VDD_c_3497_n ) capacitor c=0.0024232f //x=8.59 \
 //y=5.56 //x2=28.61 //y2=7.58
cc_1136 ( N_noxref_4_M22_noxref_g N_VDD_c_3518_n ) capacitor c=0.00755544f \
 //x=3.56 //y=6.2 //x2=4.135 //y2=7.585
cc_1137 ( N_noxref_4_M23_noxref_g N_VDD_c_3518_n ) capacitor c=0.00755754f \
 //x=4 //y=6.2 //x2=4.135 //y2=7.585
cc_1138 ( N_noxref_4_c_1056_n N_VDD_c_3523_n ) capacitor c=0.00202922f \
 //x=7.59 //y=5.335 //x2=7.185 //y2=7.585
cc_1139 ( N_noxref_4_c_1068_n N_VDD_c_3523_n ) capacitor c=9.3757e-19 \
 //x=6.832 //y=5.335 //x2=7.185 //y2=7.585
cc_1140 ( N_noxref_4_c_1091_n N_VDD_c_3523_n ) capacitor c=0.0138074f //x=6.83 \
 //y=5.56 //x2=7.185 //y2=7.585
cc_1141 ( N_noxref_4_c_1056_n N_VDD_c_3615_n ) capacitor c=0.0017708f //x=7.59 \
 //y=5.335 //x2=8.065 //y2=7.585
cc_1142 ( N_noxref_4_c_1136_n N_VDD_c_3615_n ) capacitor c=0.00202922f \
 //x=8.475 //y=5.335 //x2=8.065 //y2=7.585
cc_1143 ( N_noxref_4_c_1142_n N_VDD_c_3615_n ) capacitor c=9.4822e-19 //x=7.71 \
 //y=5.335 //x2=8.065 //y2=7.585
cc_1144 ( N_noxref_4_c_1165_n N_VDD_c_3615_n ) capacitor c=0.0138074f //x=7.71 \
 //y=5.56 //x2=8.065 //y2=7.585
cc_1145 ( N_noxref_4_c_1136_n N_VDD_c_3643_n ) capacitor c=0.00205906f \
 //x=8.475 //y=5.335 //x2=8.945 //y2=7.585
cc_1146 ( N_noxref_4_c_1124_n N_VDD_c_3643_n ) capacitor c=8.49654e-19 \
 //x=8.59 //y=5.56 //x2=8.945 //y2=7.585
cc_1147 ( N_noxref_4_c_1125_n N_VDD_c_3643_n ) capacitor c=0.00204238f \
 //x=9.285 //y=5.335 //x2=8.945 //y2=7.585
cc_1148 ( N_noxref_4_c_1298_p N_VDD_c_3643_n ) capacitor c=0.0135103f //x=8.59 \
 //y=5.56 //x2=8.945 //y2=7.585
cc_1149 ( N_noxref_4_c_1125_n N_VDD_c_3647_n ) capacitor c=0.00183742f \
 //x=9.285 //y=5.335 //x2=9.94 //y2=7.585
cc_1150 ( N_noxref_4_M42_noxref_g N_VDD_c_3648_n ) capacitor c=0.00755614f \
 //x=21.04 //y=6.2 //x2=21.615 //y2=7.585
cc_1151 ( N_noxref_4_M43_noxref_g N_VDD_c_3648_n ) capacitor c=0.00755544f \
 //x=21.48 //y=6.2 //x2=21.615 //y2=7.585
cc_1152 ( N_noxref_4_c_1068_n N_VDD_c_3527_n ) capacitor c=0.0022955f \
 //x=6.832 //y=5.335 //x2=5.3 //y2=7.585
cc_1153 ( N_noxref_4_c_1073_n N_VDD_c_3527_n ) capacitor c=0.00419973f \
 //x=7.13 //y=3.88 //x2=5.3 //y2=7.585
cc_1154 ( N_noxref_4_c_1087_n N_VDD_c_3527_n ) capacitor c=0.00224736f \
 //x=3.82 //y=4.88 //x2=5.3 //y2=7.585
cc_1155 ( N_noxref_4_c_1091_n N_VDD_c_3527_n ) capacitor c=0.00509469f \
 //x=6.83 //y=5.56 //x2=5.3 //y2=7.585
cc_1156 ( N_noxref_4_c_1121_n N_VDD_c_3527_n ) capacitor c=2.63786e-19 \
 //x=3.82 //y=4.88 //x2=5.3 //y2=7.585
cc_1157 ( N_noxref_4_c_1124_n N_VDD_c_3533_n ) capacitor c=0.00282782f \
 //x=8.59 //y=5.56 //x2=10.11 //y2=7.585
cc_1158 ( N_noxref_4_c_1066_n N_VDD_c_3533_n ) capacitor c=0.0316984f //x=9.37 \
 //y=5.25 //x2=10.11 //y2=7.585
cc_1159 ( N_noxref_4_c_1298_p N_VDD_c_3533_n ) capacitor c=0.00777981f \
 //x=8.59 //y=5.56 //x2=10.11 //y2=7.585
cc_1160 ( N_noxref_4_c_1177_p N_VDD_c_3658_n ) capacitor c=0.0121832f \
 //x=20.84 //y=4.755 //x2=19.73 //y2=7.585
cc_1161 ( N_noxref_4_c_1195_p N_VDD_c_3658_n ) capacitor c=0.00370784f \
 //x=20.84 //y=4.88 //x2=19.73 //y2=7.585
cc_1162 ( N_noxref_4_c_1197_p N_VDD_c_3658_n ) capacitor c=0.00590568f \
 //x=21.115 //y=4.97 //x2=19.73 //y2=7.585
cc_1163 ( N_noxref_4_M22_noxref_g N_VDD_M21_noxref_d ) capacitor c=0.015318f \
 //x=3.56 //y=6.2 //x2=3.195 //y2=5.2
cc_1164 ( N_noxref_4_M23_noxref_g N_VDD_M23_noxref_d ) capacitor c=0.0394719f \
 //x=4 //y=6.2 //x2=4.075 //y2=5.2
cc_1165 ( N_noxref_4_c_1068_n N_VDD_M24_noxref_s ) capacitor c=0.0442713f \
 //x=6.832 //y=5.335 //x2=6.255 //y2=5.2
cc_1166 ( N_noxref_4_c_1142_n N_VDD_M24_noxref_s ) capacitor c=7.80122e-19 \
 //x=7.71 //y=5.335 //x2=6.255 //y2=5.2
cc_1167 ( N_noxref_4_c_1091_n N_VDD_M24_noxref_s ) capacitor c=0.09305f \
 //x=6.83 //y=5.56 //x2=6.255 //y2=5.2
cc_1168 ( N_noxref_4_c_1056_n N_VDD_M25_noxref_d ) capacitor c=0.00700141f \
 //x=7.59 //y=5.335 //x2=7.125 //y2=5.2
cc_1169 ( N_noxref_4_c_1091_n N_VDD_M25_noxref_d ) capacitor c=0.0674491f \
 //x=6.83 //y=5.56 //x2=7.125 //y2=5.2
cc_1170 ( N_noxref_4_c_1165_n N_VDD_M25_noxref_d ) capacitor c=0.0674762f \
 //x=7.71 //y=5.56 //x2=7.125 //y2=5.2
cc_1171 ( N_noxref_4_c_1136_n N_VDD_M27_noxref_d ) capacitor c=0.00700141f \
 //x=8.475 //y=5.335 //x2=8.005 //y2=5.2
cc_1172 ( N_noxref_4_c_1165_n N_VDD_M27_noxref_d ) capacitor c=0.067493f \
 //x=7.71 //y=5.56 //x2=8.005 //y2=5.2
cc_1173 ( N_noxref_4_c_1298_p N_VDD_M27_noxref_d ) capacitor c=0.0674979f \
 //x=8.59 //y=5.56 //x2=8.005 //y2=5.2
cc_1174 ( N_noxref_4_c_1125_n N_VDD_M29_noxref_d ) capacitor c=0.00700141f \
 //x=9.285 //y=5.335 //x2=8.885 //y2=5.2
cc_1175 ( N_noxref_4_c_1298_p N_VDD_M29_noxref_d ) capacitor c=0.0675002f \
 //x=8.59 //y=5.56 //x2=8.885 //y2=5.2
cc_1176 ( N_noxref_4_c_1124_n N_VDD_M30_noxref_s ) capacitor c=0.00492616f \
 //x=8.59 //y=5.56 //x2=11.065 //y2=5.2
cc_1177 ( N_noxref_4_c_1125_n N_VDD_M30_noxref_s ) capacitor c=9.42705e-19 \
 //x=9.285 //y=5.335 //x2=11.065 //y2=5.2
cc_1178 ( N_noxref_4_c_1142_n N_VDD_M30_noxref_s ) capacitor c=2.11884e-19 \
 //x=7.71 //y=5.335 //x2=11.065 //y2=5.2
cc_1179 ( N_noxref_4_c_1180_p N_VDD_M42_noxref_s ) capacitor c=7.01301e-19 \
 //x=20.84 //y=4.025 //x2=20.685 //y2=5.2
cc_1180 ( N_noxref_4_c_1177_p N_VDD_M42_noxref_s ) capacitor c=0.0217981f \
 //x=20.84 //y=4.755 //x2=20.685 //y2=5.2
cc_1181 ( N_noxref_4_c_1195_p N_VDD_M42_noxref_s ) capacitor c=0.00983413f \
 //x=20.84 //y=4.88 //x2=20.685 //y2=5.2
cc_1182 ( N_noxref_4_M42_noxref_g N_VDD_M42_noxref_s ) capacitor c=0.053419f \
 //x=21.04 //y=6.2 //x2=20.685 //y2=5.2
cc_1183 ( N_noxref_4_c_1197_p N_VDD_M42_noxref_s ) capacitor c=0.00604508f \
 //x=21.115 //y=4.97 //x2=20.685 //y2=5.2
cc_1184 ( N_noxref_4_M43_noxref_g N_VDD_M43_noxref_d ) capacitor c=0.015318f \
 //x=21.48 //y=6.2 //x2=21.555 //y2=5.2
cc_1185 ( N_noxref_4_c_1039_n D ) capacitor c=0.00216161f //x=3.82 //y=3.72 \
 //x2=1.6 //y2=2.77
cc_1186 ( N_noxref_4_c_1051_n D ) capacitor c=0.00104684f //x=3.82 //y=4.75 \
 //x2=1.6 //y2=2.77
cc_1187 ( N_noxref_4_c_1038_n N_noxref_12_c_4001_n ) capacitor c=0.00177186f \
 //x=3.82 //y=2.375 //x2=4.475 //y2=0.72
cc_1188 ( N_noxref_4_c_1086_n N_noxref_12_c_4001_n ) capacitor c=0.00117306f \
 //x=3.82 //y=2.26 //x2=4.475 //y2=0.72
cc_1189 ( N_noxref_4_c_1100_n N_noxref_12_c_4001_n ) capacitor c=0.0206349f \
 //x=3.81 //y=1.095 //x2=4.475 //y2=0.72
cc_1190 ( N_noxref_4_c_1112_n N_noxref_12_c_4001_n ) capacitor c=0.00825432f \
 //x=4.34 //y=1.095 //x2=4.475 //y2=0.72
cc_1191 ( N_noxref_4_c_1118_n N_noxref_12_c_4001_n ) capacitor c=2.20712e-19 \
 //x=3.82 //y=2.26 //x2=4.475 //y2=0.72
cc_1192 ( N_noxref_4_c_1102_n N_noxref_12_c_4004_n ) capacitor c=0.0071177f \
 //x=3.81 //y=1.44 //x2=3.59 //y2=1.175
cc_1193 ( N_noxref_4_c_1100_n N_noxref_12_M2_noxref_s ) capacitor c=0.0071177f \
 //x=3.81 //y=1.095 //x2=3.455 //y2=0.555
cc_1194 ( N_noxref_4_c_1105_n N_noxref_12_M2_noxref_s ) capacitor c=0.0071177f \
 //x=3.81 //y=1.75 //x2=3.455 //y2=0.555
cc_1195 ( N_noxref_4_c_1112_n N_noxref_12_M2_noxref_s ) capacitor c=0.015333f \
 //x=4.34 //y=1.095 //x2=3.455 //y2=0.555
cc_1196 ( N_noxref_4_c_1114_n N_noxref_12_M2_noxref_s ) capacitor \
 c=0.00248746f //x=4.34 //y=1.44 //x2=3.455 //y2=0.555
cc_1197 ( N_noxref_4_c_1057_n N_noxref_13_c_4085_n ) capacitor c=0.00365298f \
 //x=8.885 //y=1.305 //x2=9.285 //y2=0.72
cc_1198 ( N_noxref_4_c_1126_n N_noxref_13_c_4085_n ) capacitor c=0.00366757f \
 //x=9.285 //y=1.845 //x2=9.285 //y2=0.72
cc_1199 ( N_noxref_4_M5_noxref_d N_noxref_13_c_4085_n ) capacitor \
 c=0.00910163f //x=8.695 //y=1.095 //x2=9.285 //y2=0.72
cc_1200 ( N_noxref_4_M5_noxref_d N_noxref_13_c_4088_n ) capacitor \
 c=0.00120711f //x=8.695 //y=1.095 //x2=8.4 //y2=1.175
cc_1201 ( N_noxref_4_c_1056_n N_noxref_13_M4_noxref_d ) capacitor c=0.0013488f \
 //x=7.59 //y=5.335 //x2=7.16 //y2=1.09
cc_1202 ( N_noxref_4_c_1057_n N_noxref_13_M4_noxref_d ) capacitor \
 c=0.00802417f //x=8.885 //y=1.305 //x2=7.16 //y2=1.09
cc_1203 ( N_noxref_4_c_1057_n N_noxref_13_M5_noxref_s ) capacitor c=0.0098487f \
 //x=8.885 //y=1.305 //x2=8.265 //y2=0.555
cc_1204 ( N_noxref_4_c_1351_p N_noxref_13_M5_noxref_s ) capacitor c=0.0283243f \
 //x=8.885 //y=1.76 //x2=8.265 //y2=0.555
cc_1205 ( N_noxref_4_c_1126_n N_noxref_13_M5_noxref_s ) capacitor \
 c=0.00911719f //x=9.285 //y=1.845 //x2=8.265 //y2=0.555
cc_1206 ( N_noxref_4_c_1288_p N_noxref_13_M5_noxref_s ) capacitor \
 c=0.00129723f //x=9.37 //y=3.88 //x2=8.265 //y2=0.555
cc_1207 ( N_noxref_4_M5_noxref_d N_noxref_13_M5_noxref_s ) capacitor \
 c=0.0279003f //x=8.695 //y=1.095 //x2=8.265 //y2=0.555
cc_1208 ( N_noxref_4_c_1057_n N_noxref_14_M7_noxref_d ) capacitor \
 c=3.20746e-19 //x=8.885 //y=1.305 //x2=11.97 //y2=1.09
cc_1209 ( N_noxref_4_c_1038_n N_GND_c_4349_n ) capacitor c=0.0021992f //x=3.82 \
 //y=2.375 //x2=6.29 //y2=0.175
cc_1210 ( N_noxref_4_c_1057_n N_GND_c_4450_n ) capacitor c=0.00901861f \
 //x=8.885 //y=1.305 //x2=11.1 //y2=0.175
cc_1211 ( N_noxref_4_c_1126_n N_GND_c_4450_n ) capacitor c=0.00713708f \
 //x=9.285 //y=1.845 //x2=11.1 //y2=0.175
cc_1212 ( N_noxref_4_c_1065_n N_GND_c_4450_n ) capacitor c=5.1352e-19 //x=9.37 \
 //y=4.04 //x2=11.1 //y2=0.175
cc_1213 ( N_noxref_4_M5_noxref_d N_GND_c_4450_n ) capacitor c=2.9462e-19 \
 //x=8.695 //y=1.095 //x2=11.1 //y2=0.175
cc_1214 ( N_noxref_4_c_1249_p N_GND_c_4458_n ) capacitor c=3.97665e-19 \
 //x=20.54 //y=1.055 //x2=20.805 //y2=1.015
cc_1215 ( N_noxref_4_c_1466_p N_GND_c_4458_n ) capacitor c=0.00864776f \
 //x=20.915 //y=0.9 //x2=20.805 //y2=1.015
cc_1216 ( N_noxref_4_c_1251_p N_GND_c_4458_n ) capacitor c=4.45447e-19 \
 //x=21.07 //y=1.055 //x2=20.805 //y2=1.015
cc_1217 ( N_noxref_4_c_1057_n N_GND_c_4371_n ) capacitor c=0.00543195f \
 //x=8.885 //y=1.305 //x2=11.185 //y2=1.145
cc_1218 ( N_noxref_4_c_1188_p N_GND_c_4462_n ) capacitor c=0.00799365f \
 //x=20.84 //y=2.375 //x2=20.805 //y2=1.145
cc_1219 ( N_noxref_4_c_1180_p N_GND_c_4462_n ) capacitor c=6.8785e-19 \
 //x=20.84 //y=4.025 //x2=20.805 //y2=1.145
cc_1220 ( N_noxref_4_c_1184_p N_GND_c_4462_n ) capacitor c=2.22883e-19 \
 //x=20.84 //y=2.26 //x2=20.805 //y2=1.145
cc_1221 ( N_noxref_4_c_1249_p N_GND_c_4462_n ) capacitor c=0.00156339f \
 //x=20.54 //y=1.055 //x2=20.805 //y2=1.145
cc_1222 ( N_noxref_4_c_1250_p N_GND_c_4462_n ) capacitor c=0.00352472f \
 //x=20.54 //y=1.4 //x2=20.805 //y2=1.145
cc_1223 ( N_noxref_4_c_1252_p N_GND_c_4462_n ) capacitor c=4.40132e-19 \
 //x=20.54 //y=1.71 //x2=20.805 //y2=1.145
cc_1224 ( N_noxref_4_c_1466_p N_GND_c_4462_n ) capacitor c=9.36995e-19 \
 //x=20.915 //y=0.9 //x2=20.805 //y2=1.145
cc_1225 ( N_noxref_4_c_1476_p N_GND_c_4462_n ) capacitor c=5.95779e-19 \
 //x=20.915 //y=1.555 //x2=20.805 //y2=1.145
cc_1226 ( N_noxref_4_c_1251_p N_GND_c_4462_n ) capacitor c=0.0017438f \
 //x=21.07 //y=1.055 //x2=20.805 //y2=1.145
cc_1227 ( N_noxref_4_c_1253_p N_GND_c_4462_n ) capacitor c=0.00276804f \
 //x=21.07 //y=1.4 //x2=20.805 //y2=1.145
cc_1228 ( N_noxref_4_c_1038_n N_GND_c_4382_n ) capacitor c=2.016e-19 //x=3.82 \
 //y=2.375 //x2=5.13 //y2=0.175
cc_1229 ( N_noxref_4_c_1126_n N_GND_c_4384_n ) capacitor c=6.86343e-19 \
 //x=9.285 //y=1.845 //x2=9.94 //y2=0.175
cc_1230 ( N_noxref_4_c_1249_p N_GND_c_4474_n ) capacitor c=0.00677766f \
 //x=20.54 //y=1.055 //x2=24.37 //y2=0.175
cc_1231 ( N_noxref_4_c_1086_n N_GND_c_4386_n ) capacitor c=0.00239899f \
 //x=3.82 //y=2.26 //x2=5.3 //y2=0.175
cc_1232 ( N_noxref_4_c_1114_n N_GND_c_4386_n ) capacitor c=0.00262688f \
 //x=4.34 //y=1.44 //x2=5.3 //y2=0.175
cc_1233 ( N_noxref_4_c_1118_n N_GND_c_4386_n ) capacitor c=2.63786e-19 \
 //x=3.82 //y=2.26 //x2=5.3 //y2=0.175
cc_1234 ( N_noxref_4_c_1351_p N_GND_c_4394_n ) capacitor c=0.0045138f \
 //x=8.885 //y=1.76 //x2=10.11 //y2=0.175
cc_1235 ( N_noxref_4_c_1126_n N_GND_c_4394_n ) capacitor c=0.0335382f \
 //x=9.285 //y=1.845 //x2=10.11 //y2=0.175
cc_1236 ( N_noxref_4_c_1188_p N_GND_c_4480_n ) capacitor c=0.00407472f \
 //x=20.84 //y=2.375 //x2=19.73 //y2=0.175
cc_1237 ( N_noxref_4_c_1176_p N_GND_c_4480_n ) capacitor c=0.00967862f \
 //x=20.84 //y=3.705 //x2=19.73 //y2=0.175
cc_1238 ( N_noxref_4_c_1183_p N_GND_c_4480_n ) capacitor c=0.00276652f \
 //x=19.205 //y=3.865 //x2=19.73 //y2=0.175
cc_1239 ( N_noxref_4_c_1184_p N_GND_c_4480_n ) capacitor c=0.00411295f \
 //x=20.84 //y=2.26 //x2=19.73 //y2=0.175
cc_1240 ( N_noxref_4_c_1252_p N_GND_c_4480_n ) capacitor c=0.00170145f \
 //x=20.54 //y=1.71 //x2=19.73 //y2=0.175
cc_1241 ( N_noxref_4_c_1190_p N_GND_c_4480_n ) capacitor c=0.00991898f \
 //x=20.54 //y=2.095 //x2=19.73 //y2=0.175
cc_1242 ( N_noxref_4_c_1188_p N_GND_M12_noxref_d ) capacitor c=4.4417e-19 \
 //x=20.84 //y=2.375 //x2=20.615 //y2=1.055
cc_1243 ( N_noxref_4_c_1249_p N_GND_M12_noxref_d ) capacitor c=0.00184354f \
 //x=20.54 //y=1.055 //x2=20.615 //y2=1.055
cc_1244 ( N_noxref_4_c_1250_p N_GND_M12_noxref_d ) capacitor c=0.00210798f \
 //x=20.54 //y=1.4 //x2=20.615 //y2=1.055
cc_1245 ( N_noxref_4_c_1466_p N_GND_M12_noxref_d ) capacitor c=0.00474029f \
 //x=20.915 //y=0.9 //x2=20.615 //y2=1.055
cc_1246 ( N_noxref_4_c_1476_p N_GND_M12_noxref_d ) capacitor c=0.00166857f \
 //x=20.915 //y=1.555 //x2=20.615 //y2=1.055
cc_1247 ( N_noxref_4_c_1251_p N_GND_M12_noxref_d ) capacitor c=0.00230174f \
 //x=21.07 //y=1.055 //x2=20.615 //y2=1.055
cc_1248 ( N_noxref_4_c_1253_p N_GND_M12_noxref_d ) capacitor c=0.00210798f \
 //x=21.07 //y=1.4 //x2=20.615 //y2=1.055
cc_1249 ( N_noxref_4_c_1190_p N_noxref_23_c_5130_n ) capacitor c=0.00262672f \
 //x=20.54 //y=2.095 //x2=20.32 //y2=1.685
cc_1250 ( N_noxref_4_c_1188_p N_noxref_23_c_5131_n ) capacitor c=0.00428451f \
 //x=20.84 //y=2.375 //x2=21.205 //y2=1.77
cc_1251 ( N_noxref_4_c_1180_p N_noxref_23_c_5131_n ) capacitor c=0.00210148f \
 //x=20.84 //y=4.025 //x2=21.205 //y2=1.77
cc_1252 ( N_noxref_4_c_1184_p N_noxref_23_c_5131_n ) capacitor c=0.0104666f \
 //x=20.84 //y=2.26 //x2=21.205 //y2=1.77
cc_1253 ( N_noxref_4_c_1252_p N_noxref_23_c_5131_n ) capacitor c=0.00705077f \
 //x=20.54 //y=1.71 //x2=21.205 //y2=1.77
cc_1254 ( N_noxref_4_c_1190_p N_noxref_23_c_5131_n ) capacitor c=0.0211416f \
 //x=20.54 //y=2.095 //x2=21.205 //y2=1.77
cc_1255 ( N_noxref_4_c_1476_p N_noxref_23_c_5131_n ) capacitor c=0.00588627f \
 //x=20.915 //y=1.555 //x2=21.205 //y2=1.77
cc_1256 ( N_noxref_4_c_1253_p N_noxref_23_c_5131_n ) capacitor c=0.00698822f \
 //x=21.07 //y=1.4 //x2=21.205 //y2=1.77
cc_1257 ( N_noxref_4_c_1249_p N_noxref_23_M12_noxref_s ) capacitor \
 c=0.0295256f //x=20.54 //y=1.055 //x2=20.185 //y2=0.555
cc_1258 ( N_noxref_4_c_1252_p N_noxref_23_M12_noxref_s ) capacitor \
 c=7.99997e-19 //x=20.54 //y=1.71 //x2=20.185 //y2=0.555
cc_1259 ( N_noxref_4_c_1190_p N_noxref_23_M12_noxref_s ) capacitor \
 c=0.00122123f //x=20.54 //y=2.095 //x2=20.185 //y2=0.555
cc_1260 ( N_noxref_4_c_1251_p N_noxref_23_M12_noxref_s ) capacitor \
 c=0.0125924f //x=21.07 //y=1.055 //x2=20.185 //y2=0.555
cc_1261 ( RN QN ) capacitor c=0.00144827f //x=21.95 //y=3.14 //x2=23.8 //y2=2.4
cc_1262 ( RN QN ) capacitor c=0.00203229f //x=21.95 //y=3.14 //x2=23.8 //y2=4.62
cc_1263 ( N_RN_c_1607_n N_QN_c_1946_n ) capacitor c=0.0235959f //x=21.945 \
 //y=4.84 //x2=22.02 //y2=5.335
cc_1264 ( N_RN_c_1628_n N_QN_c_1946_n ) capacitor c=0.0024504f //x=19.208 \
 //y=4.632 //x2=22.02 //y2=5.335
cc_1265 ( N_RN_c_1644_n N_QN_c_1946_n ) capacitor c=0.00492634f //x=21.95 \
 //y=4.88 //x2=22.02 //y2=5.335
cc_1266 ( N_RN_M44_noxref_g N_QN_c_1946_n ) capacitor c=0.00858003f //x=21.92 \
 //y=6.2 //x2=22.02 //y2=5.335
cc_1267 ( N_RN_c_1675_n N_QN_c_1946_n ) capacitor c=3.53407e-19 //x=21.95 \
 //y=4.88 //x2=22.02 //y2=5.335
cc_1268 ( N_RN_M45_noxref_g N_QN_c_1960_n ) capacitor c=0.0103546f //x=22.36 \
 //y=6.2 //x2=22.905 //y2=5.335
cc_1269 ( N_RN_c_1628_n N_QN_c_1947_n ) capacitor c=0.0278748f //x=19.208 \
 //y=4.632 //x2=21.262 //y2=5.335
cc_1270 ( N_RN_c_1607_n N_QN_c_1962_n ) capacitor c=0.00518578f //x=21.945 \
 //y=4.84 //x2=22.14 //y2=5.335
cc_1271 ( N_RN_c_1628_n N_QN_c_1962_n ) capacitor c=0.0020954f //x=19.208 \
 //y=4.632 //x2=22.14 //y2=5.335
cc_1272 ( N_RN_c_1644_n N_QN_c_1962_n ) capacitor c=0.00132214f //x=21.95 \
 //y=4.88 //x2=22.14 //y2=5.335
cc_1273 ( N_RN_M44_noxref_g N_QN_c_1962_n ) capacitor c=0.00229818f //x=21.92 \
 //y=6.2 //x2=22.14 //y2=5.335
cc_1274 ( N_RN_M45_noxref_g N_QN_c_1962_n ) capacitor c=0.00230699f //x=22.36 \
 //y=6.2 //x2=22.14 //y2=5.335
cc_1275 ( N_RN_c_1692_p N_QN_c_1962_n ) capacitor c=0.00170653f //x=22.285 \
 //y=4.97 //x2=22.14 //y2=5.335
cc_1276 ( N_RN_c_1607_n N_QN_c_1968_n ) capacitor c=0.00135587f //x=21.945 \
 //y=4.84 //x2=22.14 //y2=5.56
cc_1277 ( N_RN_M44_noxref_g N_QN_c_1968_n ) capacitor c=0.0179041f //x=21.92 \
 //y=6.2 //x2=22.14 //y2=5.56
cc_1278 ( N_RN_M45_noxref_g N_QN_c_1968_n ) capacitor c=0.0179041f //x=22.36 \
 //y=6.2 //x2=22.14 //y2=5.56
cc_1279 ( N_RN_c_1692_p N_QN_c_1968_n ) capacitor c=0.00293647f //x=22.285 \
 //y=4.97 //x2=22.14 //y2=5.56
cc_1280 ( N_RN_c_1523_n SN ) capacitor c=0.0272739f //x=13.05 //y=4.62 \
 //x2=12.33 //y2=3.14
cc_1281 ( N_RN_c_1523_n N_SN_c_2240_n ) capacitor c=0.00415544f //x=13.05 \
 //y=4.62 //x2=12.33 //y2=4.765
cc_1282 ( RN N_SN_c_2290_n ) capacitor c=0.0302472f //x=18.25 //y=3.14 \
 //x2=16.245 //y2=2.75
cc_1283 ( RN N_SN_c_2290_n ) capacitor c=0.0326692f //x=21.95 //y=3.14 \
 //x2=16.245 //y2=2.75
cc_1284 ( N_RN_c_1552_n N_SN_c_2290_n ) capacitor c=0.00361011f //x=18.25 \
 //y=2.375 //x2=16.245 //y2=2.75
cc_1285 ( N_RN_c_1601_n N_SN_c_2290_n ) capacitor c=0.00389779f //x=21.95 \
 //y=2.375 //x2=16.245 //y2=2.75
cc_1286 ( N_RN_c_1628_n N_SN_c_2290_n ) capacitor c=0.00244342f //x=19.208 \
 //y=4.632 //x2=16.245 //y2=2.75
cc_1287 ( N_RN_c_1517_n N_noxref_8_c_2693_n ) capacitor c=0.00113366f //x=8.24 \
 //y=4.62 //x2=8.63 //y2=4.41
cc_1288 ( N_RN_c_1620_n N_noxref_8_c_2693_n ) capacitor c=0.0036931f //x=8.84 \
 //y=4.635 //x2=8.63 //y2=4.41
cc_1289 ( N_RN_c_1517_n N_noxref_8_c_2611_n ) capacitor c=3.74821e-19 //x=8.24 \
 //y=4.62 //x2=8.63 //y2=4.75
cc_1290 ( N_RN_c_1620_n N_noxref_8_c_2611_n ) capacitor c=0.027402f //x=8.84 \
 //y=4.635 //x2=8.63 //y2=4.75
cc_1291 ( N_RN_c_1523_n N_noxref_8_c_2625_n ) capacitor c=0.00250022f \
 //x=13.05 //y=4.62 //x2=13.44 //y2=4.41
cc_1292 ( N_RN_c_1541_n N_noxref_8_c_2625_n ) capacitor c=0.00227031f \
 //x=13.65 //y=4.635 //x2=13.44 //y2=4.41
cc_1293 ( N_RN_c_1523_n N_noxref_8_c_2615_n ) capacitor c=3.74602e-19 \
 //x=13.05 //y=4.62 //x2=13.44 //y2=4.75
cc_1294 ( N_RN_c_1541_n N_noxref_8_c_2615_n ) capacitor c=0.0271426f //x=13.65 \
 //y=4.635 //x2=13.44 //y2=4.75
cc_1295 ( N_RN_c_1543_n N_noxref_8_c_2615_n ) capacitor c=3.14871e-19 \
 //x=18.855 //y=4.632 //x2=13.44 //y2=4.75
cc_1296 ( N_RN_c_1555_n N_noxref_8_c_2704_n ) capacitor c=0.00547265f \
 //x=18.25 //y=4.835 //x2=18.095 //y2=5.335
cc_1297 ( N_RN_c_1543_n N_noxref_8_c_2704_n ) capacitor c=0.00224199f \
 //x=18.855 //y=4.632 //x2=18.095 //y2=5.335
cc_1298 ( N_RN_M40_noxref_g N_noxref_8_c_2704_n ) capacitor c=0.00955829f \
 //x=17.99 //y=6.2 //x2=18.095 //y2=5.335
cc_1299 ( N_RN_M40_noxref_g N_noxref_8_c_2850_n ) capacitor c=0.00226521f \
 //x=17.99 //y=6.2 //x2=18.21 //y2=5.56
cc_1300 ( N_RN_M41_noxref_g N_noxref_8_c_2850_n ) capacitor c=0.00381703f \
 //x=18.43 //y=6.2 //x2=18.21 //y2=5.56
cc_1301 ( N_RN_c_1555_n N_noxref_8_c_2852_n ) capacitor c=0.00498327f \
 //x=18.25 //y=4.835 //x2=18.905 //y2=5.335
cc_1302 ( N_RN_c_1543_n N_noxref_8_c_2852_n ) capacitor c=0.0214679f \
 //x=18.855 //y=4.632 //x2=18.905 //y2=5.335
cc_1303 ( N_RN_c_1566_n N_noxref_8_c_2852_n ) capacitor c=0.00130631f \
 //x=18.25 //y=4.88 //x2=18.905 //y2=5.335
cc_1304 ( N_RN_M41_noxref_g N_noxref_8_c_2852_n ) capacitor c=0.0107848f \
 //x=18.43 //y=6.2 //x2=18.905 //y2=5.335
cc_1305 ( N_RN_c_1572_n N_noxref_8_c_2856_n ) capacitor c=4.64015e-19 \
 //x=18.24 //y=1.095 //x2=18.505 //y2=1.305
cc_1306 ( N_RN_c_1573_n N_noxref_8_c_2856_n ) capacitor c=0.0026012f //x=18.24 \
 //y=1.44 //x2=18.505 //y2=1.305
cc_1307 ( N_RN_c_1724_p N_noxref_8_c_2856_n ) capacitor c=5.29969e-19 \
 //x=18.615 //y=0.94 //x2=18.505 //y2=1.305
cc_1308 ( N_RN_c_1725_p N_noxref_8_c_2856_n ) capacitor c=5.48612e-19 \
 //x=18.615 //y=1.595 //x2=18.505 //y2=1.305
cc_1309 ( N_RN_c_1726_p N_noxref_8_c_2856_n ) capacitor c=5.24634e-19 \
 //x=18.77 //y=1.095 //x2=18.505 //y2=1.305
cc_1310 ( N_RN_c_1727_p N_noxref_8_c_2856_n ) capacitor c=0.00307978f \
 //x=18.77 //y=1.44 //x2=18.505 //y2=1.305
cc_1311 ( N_RN_c_1573_n N_noxref_8_c_2862_n ) capacitor c=0.00127432f \
 //x=18.24 //y=1.44 //x2=18.505 //y2=1.76
cc_1312 ( N_RN_c_1574_n N_noxref_8_c_2862_n ) capacitor c=0.00429966f \
 //x=18.24 //y=1.75 //x2=18.505 //y2=1.76
cc_1313 ( N_RN_c_1725_p N_noxref_8_c_2862_n ) capacitor c=0.00942306f \
 //x=18.615 //y=1.595 //x2=18.505 //y2=1.76
cc_1314 ( N_RN_c_1727_p N_noxref_8_c_2862_n ) capacitor c=0.00363411f \
 //x=18.77 //y=1.44 //x2=18.505 //y2=1.76
cc_1315 ( N_RN_c_1578_n N_noxref_8_c_2862_n ) capacitor c=0.0036273f //x=18.25 \
 //y=2.095 //x2=18.505 //y2=1.76
cc_1316 ( N_RN_c_1725_p N_noxref_8_c_2867_n ) capacitor c=0.00194716f \
 //x=18.615 //y=1.595 //x2=18.905 //y2=1.845
cc_1317 ( N_RN_c_1727_p N_noxref_8_c_2867_n ) capacitor c=0.00323576f \
 //x=18.77 //y=1.44 //x2=18.905 //y2=1.845
cc_1318 ( RN N_noxref_8_c_2705_n ) capacitor c=0.0720837f //x=18.25 //y=3.14 \
 //x2=18.99 //y2=4.09
cc_1319 ( RN N_noxref_8_c_2705_n ) capacitor c=0.00209412f //x=21.95 //y=3.14 \
 //x2=18.99 //y2=4.09
cc_1320 ( N_RN_c_1552_n N_noxref_8_c_2705_n ) capacitor c=0.0154269f //x=18.25 \
 //y=2.375 //x2=18.99 //y2=4.09
cc_1321 ( N_RN_c_1562_n N_noxref_8_c_2705_n ) capacitor c=0.00163444f \
 //x=18.25 //y=2.26 //x2=18.99 //y2=4.09
cc_1322 ( N_RN_c_1575_n N_noxref_8_c_2705_n ) capacitor c=0.0025845f //x=18.25 \
 //y=2.26 //x2=18.99 //y2=4.09
cc_1323 ( N_RN_c_1578_n N_noxref_8_c_2705_n ) capacitor c=0.00282067f \
 //x=18.25 //y=2.095 //x2=18.99 //y2=4.09
cc_1324 ( RN N_noxref_8_c_2779_n ) capacitor c=0.0146245f //x=18.25 //y=3.14 \
 //x2=18.99 //y2=4.41
cc_1325 ( N_RN_c_1628_n N_noxref_8_c_2779_n ) capacitor c=0.0074429f \
 //x=19.208 //y=4.632 //x2=18.99 //y2=4.41
cc_1326 ( N_RN_c_1543_n N_noxref_8_c_2779_n ) capacitor c=0.00115216f \
 //x=18.855 //y=4.632 //x2=18.99 //y2=4.41
cc_1327 ( RN N_noxref_8_c_2707_n ) capacitor c=0.00988127f //x=18.25 //y=3.14 \
 //x2=18.99 //y2=5.25
cc_1328 ( RN N_noxref_8_c_2707_n ) capacitor c=3.32832e-19 //x=21.95 //y=3.14 \
 //x2=18.99 //y2=5.25
cc_1329 ( N_RN_c_1555_n N_noxref_8_c_2707_n ) capacitor c=0.0158365f //x=18.25 \
 //y=4.835 //x2=18.99 //y2=5.25
cc_1330 ( N_RN_c_1628_n N_noxref_8_c_2707_n ) capacitor c=0.0289548f \
 //x=19.208 //y=4.632 //x2=18.99 //y2=5.25
cc_1331 ( N_RN_c_1543_n N_noxref_8_c_2707_n ) capacitor c=0.00650432f \
 //x=18.855 //y=4.632 //x2=18.99 //y2=5.25
cc_1332 ( N_RN_c_1566_n N_noxref_8_c_2707_n ) capacitor c=8.58024e-19 \
 //x=18.25 //y=4.88 //x2=18.99 //y2=5.25
cc_1333 ( N_RN_c_1579_n N_noxref_8_c_2707_n ) capacitor c=0.00596937f \
 //x=18.25 //y=4.88 //x2=18.99 //y2=5.25
cc_1334 ( N_RN_c_1543_n N_noxref_8_c_2637_n ) capacitor c=0.0291924f \
 //x=18.855 //y=4.632 //x2=16.452 //y2=5.335
cc_1335 ( N_RN_c_1543_n N_noxref_8_c_2709_n ) capacitor c=0.0382161f \
 //x=18.855 //y=4.632 //x2=17.33 //y2=5.335
cc_1336 ( N_RN_c_1555_n N_noxref_8_c_2887_n ) capacitor c=0.0194458f //x=18.25 \
 //y=4.835 //x2=18.21 //y2=5.335
cc_1337 ( N_RN_c_1566_n N_noxref_8_c_2887_n ) capacitor c=0.00346456f \
 //x=18.25 //y=4.88 //x2=18.21 //y2=5.335
cc_1338 ( N_RN_c_1579_n N_noxref_8_c_2887_n ) capacitor c=0.00203307f \
 //x=18.25 //y=4.88 //x2=18.21 //y2=5.335
cc_1339 ( RN N_noxref_8_c_2890_n ) capacitor c=6.41283e-19 //x=18.25 //y=3.14 \
 //x2=18.99 //y2=4.25
cc_1340 ( N_RN_c_1620_n N_noxref_8_c_2715_n ) capacitor c=0.0269458f //x=8.84 \
 //y=4.635 //x2=8.985 //y2=4.25
cc_1341 ( N_RN_c_1523_n N_noxref_8_c_2715_n ) capacitor c=0.0597544f //x=13.05 \
 //y=4.62 //x2=8.985 //y2=4.25
cc_1342 ( N_RN_c_1517_n N_noxref_8_c_2716_n ) capacitor c=0.0364871f //x=8.24 \
 //y=4.62 //x2=8.785 //y2=4.25
cc_1343 ( RN N_noxref_8_c_2642_n ) capacitor c=0.0216484f //x=18.25 //y=3.14 \
 //x2=18.83 //y2=4.25
cc_1344 ( N_RN_c_1555_n N_noxref_8_c_2642_n ) capacitor c=4.73489e-19 \
 //x=18.25 //y=4.835 //x2=18.83 //y2=4.25
cc_1345 ( N_RN_c_1541_n N_noxref_8_c_2642_n ) capacitor c=0.0123563f //x=13.65 \
 //y=4.635 //x2=18.83 //y2=4.25
cc_1346 ( N_RN_c_1543_n N_noxref_8_c_2642_n ) capacitor c=0.466935f //x=18.855 \
 //y=4.632 //x2=18.83 //y2=4.25
cc_1347 ( N_RN_c_1523_n N_noxref_8_c_2616_n ) capacitor c=0.366351f //x=13.05 \
 //y=4.62 //x2=13.595 //y2=4.25
cc_1348 ( RN N_noxref_8_c_2798_n ) capacitor c=0.0032735f //x=18.25 //y=3.14 \
 //x2=19.15 //y2=4.25
cc_1349 ( N_RN_c_1543_n N_noxref_8_c_2798_n ) capacitor c=0.0364085f \
 //x=18.855 //y=4.632 //x2=19.15 //y2=4.25
cc_1350 ( RN N_noxref_8_c_2800_n ) capacitor c=0.0287619f //x=21.95 //y=3.14 \
 //x2=27.71 //y2=4.265
cc_1351 ( N_RN_c_1607_n N_noxref_8_c_2800_n ) capacitor c=0.00157895f \
 //x=21.945 //y=4.84 //x2=27.71 //y2=4.265
cc_1352 ( N_RN_c_1628_n N_noxref_8_c_2800_n ) capacitor c=0.271037f //x=19.208 \
 //y=4.632 //x2=27.71 //y2=4.265
cc_1353 ( N_RN_c_1555_n N_noxref_8_c_2904_n ) capacitor c=0.00275147f \
 //x=18.25 //y=4.835 //x2=18.21 //y2=5.56
cc_1354 ( N_RN_c_1566_n N_noxref_8_c_2904_n ) capacitor c=0.00624059f \
 //x=18.25 //y=4.88 //x2=18.21 //y2=5.56
cc_1355 ( N_RN_M40_noxref_g N_noxref_8_c_2904_n ) capacitor c=0.0178885f \
 //x=17.99 //y=6.2 //x2=18.21 //y2=5.56
cc_1356 ( N_RN_M41_noxref_g N_noxref_8_c_2904_n ) capacitor c=0.0188608f \
 //x=18.43 //y=6.2 //x2=18.21 //y2=5.56
cc_1357 ( N_RN_c_1579_n N_noxref_8_c_2904_n ) capacitor c=0.00375636f \
 //x=18.25 //y=4.88 //x2=18.21 //y2=5.56
cc_1358 ( N_RN_c_1572_n N_noxref_8_M11_noxref_d ) capacitor c=0.00137165f \
 //x=18.24 //y=1.095 //x2=18.315 //y2=1.095
cc_1359 ( N_RN_c_1573_n N_noxref_8_M11_noxref_d ) capacitor c=0.00237422f \
 //x=18.24 //y=1.44 //x2=18.315 //y2=1.095
cc_1360 ( N_RN_c_1724_p N_noxref_8_M11_noxref_d ) capacitor c=0.0020782f \
 //x=18.615 //y=0.94 //x2=18.315 //y2=1.095
cc_1361 ( N_RN_c_1725_p N_noxref_8_M11_noxref_d ) capacitor c=0.00356097f \
 //x=18.615 //y=1.595 //x2=18.315 //y2=1.095
cc_1362 ( N_RN_c_1726_p N_noxref_8_M11_noxref_d ) capacitor c=0.00139206f \
 //x=18.77 //y=1.095 //x2=18.315 //y2=1.095
cc_1363 ( N_RN_c_1727_p N_noxref_8_M11_noxref_d ) capacitor c=0.00237422f \
 //x=18.77 //y=1.44 //x2=18.315 //y2=1.095
cc_1364 ( RN Q ) capacitor c=0.0372256f //x=21.95 //y=3.14 //x2=23.06 //y2=2.4
cc_1365 ( N_RN_c_1640_n Q ) capacitor c=4.16726e-19 //x=21.95 //y=2.26 \
 //x2=23.06 //y2=2.4
cc_1366 ( RN Q ) capacitor c=0.0149454f //x=21.95 //y=3.14 //x2=23.06 //y2=4.62
cc_1367 ( N_RN_c_1607_n Q ) capacitor c=0.00170579f //x=21.945 //y=4.84 \
 //x2=23.06 //y2=4.62
cc_1368 ( N_RN_c_1628_n Q ) capacitor c=0.00347078f //x=19.208 //y=4.632 \
 //x2=23.06 //y2=4.62
cc_1369 ( RN Q ) capacitor c=3.40764e-19 //x=21.95 //y=3.14 //x2=23.06 //y2=3.88
cc_1370 ( N_RN_c_1601_n N_Q_c_3228_n ) capacitor c=0.0116288f //x=21.95 \
 //y=2.375 //x2=23.06 //y2=2.375
cc_1371 ( N_RN_c_1640_n N_Q_c_3228_n ) capacitor c=5.39999e-19 //x=21.95 \
 //y=2.26 //x2=23.06 //y2=2.375
cc_1372 ( N_RN_c_1670_n N_Q_c_3228_n ) capacitor c=0.00141236f //x=22.04 \
 //y=2.095 //x2=23.06 //y2=2.375
cc_1373 ( RN N_Q_c_3231_n ) capacitor c=0.00805586f //x=21.95 //y=3.14 \
 //x2=23.06 //y2=4.025
cc_1374 ( N_RN_c_1607_n N_Q_c_3232_n ) capacitor c=0.00655684f //x=21.945 \
 //y=4.84 //x2=23.06 //y2=4.75
cc_1375 ( N_RN_c_1628_n N_Q_c_3232_n ) capacitor c=0.00573884f //x=19.208 \
 //y=4.632 //x2=23.06 //y2=4.75
cc_1376 ( N_RN_c_1644_n N_Q_c_3232_n ) capacitor c=4.14906e-19 //x=21.95 \
 //y=4.88 //x2=23.06 //y2=4.75
cc_1377 ( RN N_Q_c_3221_n ) capacitor c=0.00313859f //x=21.95 //y=3.14 \
 //x2=23.21 //y2=3.865
cc_1378 ( RN N_Q_c_3236_n ) capacitor c=4.16726e-19 //x=21.95 //y=3.14 \
 //x2=23.06 //y2=2.26
cc_1379 ( N_RN_c_1601_n N_Q_c_3236_n ) capacitor c=5.42289e-19 //x=21.95 \
 //y=2.375 //x2=23.06 //y2=2.26
cc_1380 ( N_RN_c_1640_n N_Q_c_3236_n ) capacitor c=0.00125213f //x=21.95 \
 //y=2.26 //x2=23.06 //y2=2.26
cc_1381 ( N_RN_c_1670_n N_Q_c_3236_n ) capacitor c=0.00209664f //x=22.04 \
 //y=2.095 //x2=23.06 //y2=2.26
cc_1382 ( N_RN_c_1607_n N_Q_c_3240_n ) capacitor c=7.46573e-19 //x=21.945 \
 //y=4.84 //x2=23.06 //y2=4.88
cc_1383 ( N_RN_c_1644_n N_Q_c_3240_n ) capacitor c=0.00113671f //x=21.95 \
 //y=4.88 //x2=23.06 //y2=4.88
cc_1384 ( N_RN_c_1675_n N_Q_c_3240_n ) capacitor c=9.77556e-19 //x=21.95 \
 //y=4.88 //x2=23.06 //y2=4.88
cc_1385 ( N_RN_M44_noxref_g N_Q_M46_noxref_g ) capacitor c=0.0101598f \
 //x=21.92 //y=6.2 //x2=22.8 //y2=6.2
cc_1386 ( N_RN_M45_noxref_g N_Q_M46_noxref_g ) capacitor c=0.0607518f \
 //x=22.36 //y=6.2 //x2=22.8 //y2=6.2
cc_1387 ( N_RN_M45_noxref_g N_Q_M47_noxref_g ) capacitor c=0.0101598f \
 //x=22.36 //y=6.2 //x2=23.24 //y2=6.2
cc_1388 ( N_RN_c_1667_n N_Q_c_3246_n ) capacitor c=0.00456962f //x=22.04 \
 //y=1.09 //x2=23.05 //y2=1.095
cc_1389 ( N_RN_c_1668_n N_Q_c_3247_n ) capacitor c=0.00438372f //x=22.04 \
 //y=1.4 //x2=23.05 //y2=1.44
cc_1390 ( N_RN_c_1669_n N_Q_c_3248_n ) capacitor c=0.00438372f //x=22.04 \
 //y=1.63 //x2=23.05 //y2=1.75
cc_1391 ( N_RN_c_1601_n N_Q_c_3249_n ) capacitor c=0.00139071f //x=21.95 \
 //y=2.375 //x2=23.06 //y2=2.26
cc_1392 ( N_RN_c_1640_n N_Q_c_3249_n ) capacitor c=0.00204868f //x=21.95 \
 //y=2.26 //x2=23.06 //y2=2.26
cc_1393 ( N_RN_c_1670_n N_Q_c_3249_n ) capacitor c=0.00933826f //x=22.04 \
 //y=2.095 //x2=23.06 //y2=2.26
cc_1394 ( N_RN_c_1670_n N_Q_c_3252_n ) capacitor c=0.00438372f //x=22.04 \
 //y=2.095 //x2=23.06 //y2=2.095
cc_1395 ( N_RN_c_1607_n N_Q_c_3253_n ) capacitor c=0.00135079f //x=21.945 \
 //y=4.84 //x2=23.06 //y2=4.88
cc_1396 ( N_RN_c_1644_n N_Q_c_3253_n ) capacitor c=0.00186974f //x=21.95 \
 //y=4.88 //x2=23.06 //y2=4.88
cc_1397 ( N_RN_c_1692_p N_Q_c_3253_n ) capacitor c=0.0616777f //x=22.285 \
 //y=4.97 //x2=23.06 //y2=4.88
cc_1398 ( N_RN_c_1675_n N_Q_c_3253_n ) capacitor c=0.0042693f //x=21.95 \
 //y=4.88 //x2=23.06 //y2=4.88
cc_1399 ( N_RN_c_1525_n N_VDD_c_3509_n ) capacitor c=4.26943e-19 //x=2.71 \
 //y=4.88 //x2=1.23 //y2=7.58
cc_1400 ( N_RN_M20_noxref_g N_VDD_c_3514_n ) capacitor c=0.00704943f //x=2.68 \
 //y=6.2 //x2=3.255 //y2=7.585
cc_1401 ( N_RN_M21_noxref_g N_VDD_c_3514_n ) capacitor c=0.00755544f //x=3.12 \
 //y=6.2 //x2=3.255 //y2=7.585
cc_1402 ( N_RN_M40_noxref_g N_VDD_c_3686_n ) capacitor c=0.00755544f //x=17.99 \
 //y=6.2 //x2=18.565 //y2=7.585
cc_1403 ( N_RN_M41_noxref_g N_VDD_c_3686_n ) capacitor c=0.00755754f //x=18.43 \
 //y=6.2 //x2=18.565 //y2=7.585
cc_1404 ( N_RN_M44_noxref_g N_VDD_c_3688_n ) capacitor c=0.00705252f //x=21.92 \
 //y=6.2 //x2=22.495 //y2=7.585
cc_1405 ( N_RN_M45_noxref_g N_VDD_c_3688_n ) capacitor c=0.00755544f //x=22.36 \
 //y=6.2 //x2=22.495 //y2=7.585
cc_1406 ( N_RN_c_1517_n N_VDD_c_3527_n ) capacitor c=0.0253593f //x=8.24 \
 //y=4.62 //x2=5.3 //y2=7.585
cc_1407 ( N_RN_c_1525_n N_VDD_c_3527_n ) capacitor c=2.95739e-19 //x=2.71 \
 //y=4.88 //x2=5.3 //y2=7.585
cc_1408 ( N_RN_c_1523_n N_VDD_c_3533_n ) capacitor c=0.0265533f //x=13.05 \
 //y=4.62 //x2=10.11 //y2=7.585
cc_1409 ( N_RN_c_1543_n N_VDD_c_3589_n ) capacitor c=0.0265721f //x=18.855 \
 //y=4.632 //x2=14.92 //y2=7.585
cc_1410 ( N_RN_c_1628_n N_VDD_c_3658_n ) capacitor c=0.0262951f //x=19.208 \
 //y=4.632 //x2=19.73 //y2=7.585
cc_1411 ( N_RN_c_1566_n N_VDD_c_3658_n ) capacitor c=0.0022444f //x=18.25 \
 //y=4.88 //x2=19.73 //y2=7.585
cc_1412 ( N_RN_c_1579_n N_VDD_c_3658_n ) capacitor c=2.63786e-19 //x=18.25 \
 //y=4.88 //x2=19.73 //y2=7.585
cc_1413 ( N_RN_M20_noxref_g N_VDD_M19_noxref_d ) capacitor c=0.015318f \
 //x=2.68 //y=6.2 //x2=2.315 //y2=5.2
cc_1414 ( N_RN_M21_noxref_g N_VDD_M21_noxref_d ) capacitor c=0.015318f \
 //x=3.12 //y=6.2 //x2=3.195 //y2=5.2
cc_1415 ( N_RN_c_1517_n N_VDD_M24_noxref_s ) capacitor c=8.25368e-19 //x=8.24 \
 //y=4.62 //x2=6.255 //y2=5.2
cc_1416 ( N_RN_c_1523_n N_VDD_M30_noxref_s ) capacitor c=8.27349e-19 //x=13.05 \
 //y=4.62 //x2=11.065 //y2=5.2
cc_1417 ( N_RN_c_1543_n N_VDD_M36_noxref_s ) capacitor c=8.26363e-19 \
 //x=18.855 //y=4.632 //x2=15.875 //y2=5.2
cc_1418 ( N_RN_M40_noxref_g N_VDD_M39_noxref_d ) capacitor c=0.015318f \
 //x=17.99 //y=6.2 //x2=17.625 //y2=5.2
cc_1419 ( N_RN_M41_noxref_g N_VDD_M41_noxref_d ) capacitor c=0.0394719f \
 //x=18.43 //y=6.2 //x2=18.505 //y2=5.2
cc_1420 ( N_RN_c_1628_n N_VDD_M42_noxref_s ) capacitor c=7.12085e-19 \
 //x=19.208 //y=4.632 //x2=20.685 //y2=5.2
cc_1421 ( N_RN_M44_noxref_g N_VDD_M43_noxref_d ) capacitor c=0.015318f \
 //x=21.92 //y=6.2 //x2=21.555 //y2=5.2
cc_1422 ( N_RN_M45_noxref_g N_VDD_M45_noxref_d ) capacitor c=0.015318f \
 //x=22.36 //y=6.2 //x2=22.435 //y2=5.2
cc_1423 ( RN D ) capacitor c=0.072239f //x=2.71 //y=2.77 //x2=1.6 //y2=2.77
cc_1424 ( N_RN_c_1514_n D ) capacitor c=9.81815e-19 //x=2.71 //y=4.875 \
 //x2=1.6 //y2=2.77
cc_1425 ( N_RN_c_1524_n D ) capacitor c=0.00357912f //x=2.71 //y=4.62 //x2=1.6 \
 //y2=2.77
cc_1426 ( N_RN_c_1633_n D ) capacitor c=4.16726e-19 //x=2.71 //y=2.26 //x2=1.6 \
 //y2=2.77
cc_1427 ( N_RN_c_1525_n D ) capacitor c=3.27346e-19 //x=2.71 //y=4.88 //x2=1.6 \
 //y2=2.77
cc_1428 ( N_RN_c_1598_n N_D_c_3919_n ) capacitor c=0.0115546f //x=2.71 \
 //y=2.375 //x2=1.6 //y2=2.375
cc_1429 ( N_RN_c_1633_n N_D_c_3919_n ) capacitor c=0.00375644f //x=2.71 \
 //y=2.26 //x2=1.6 //y2=2.375
cc_1430 ( N_RN_c_1657_n N_D_c_3919_n ) capacitor c=0.00140534f //x=2.8 \
 //y=2.095 //x2=1.6 //y2=2.375
cc_1431 ( N_RN_c_1514_n N_D_c_3922_n ) capacitor c=0.00673898f //x=2.71 \
 //y=4.875 //x2=1.6 //y2=4.755
cc_1432 ( N_RN_c_1524_n N_D_c_3922_n ) capacitor c=0.0062069f //x=2.71 \
 //y=4.62 //x2=1.6 //y2=4.755
cc_1433 ( N_RN_c_1525_n N_D_c_3922_n ) capacitor c=0.00369068f //x=2.71 \
 //y=4.88 //x2=1.6 //y2=4.755
cc_1434 ( N_RN_c_1535_n N_D_c_3922_n ) capacitor c=0.0011347f //x=2.71 \
 //y=4.88 //x2=1.6 //y2=4.755
cc_1435 ( RN N_D_c_3926_n ) capacitor c=4.16726e-19 //x=2.71 //y=2.77 //x2=1.6 \
 //y2=2.26
cc_1436 ( N_RN_c_1598_n N_D_c_3926_n ) capacitor c=5.40058e-19 //x=2.71 \
 //y=2.375 //x2=1.6 //y2=2.26
cc_1437 ( N_RN_c_1633_n N_D_c_3926_n ) capacitor c=0.00125213f //x=2.71 \
 //y=2.26 //x2=1.6 //y2=2.26
cc_1438 ( N_RN_c_1657_n N_D_c_3926_n ) capacitor c=0.0020754f //x=2.8 \
 //y=2.095 //x2=1.6 //y2=2.26
cc_1439 ( N_RN_c_1514_n N_D_c_3930_n ) capacitor c=6.24051e-19 //x=2.71 \
 //y=4.875 //x2=1.6 //y2=4.88
cc_1440 ( N_RN_c_1525_n N_D_c_3930_n ) capacitor c=0.00113668f //x=2.71 \
 //y=4.88 //x2=1.6 //y2=4.88
cc_1441 ( N_RN_c_1535_n N_D_c_3930_n ) capacitor c=0.00123917f //x=2.71 \
 //y=4.88 //x2=1.6 //y2=4.88
cc_1442 ( N_RN_M20_noxref_g N_D_M18_noxref_g ) capacitor c=0.0106276f //x=2.68 \
 //y=6.2 //x2=1.8 //y2=6.2
cc_1443 ( N_RN_M20_noxref_g N_D_M19_noxref_g ) capacitor c=0.107144f //x=2.68 \
 //y=6.2 //x2=2.24 //y2=6.2
cc_1444 ( N_RN_M21_noxref_g N_D_M19_noxref_g ) capacitor c=0.0101598f //x=3.12 \
 //y=6.2 //x2=2.24 //y2=6.2
cc_1445 ( N_RN_c_1862_p N_D_c_3936_n ) capacitor c=5.72528e-19 //x=2.275 \
 //y=1.09 //x2=1.3 //y2=1.055
cc_1446 ( N_RN_c_1862_p N_D_c_3937_n ) capacitor c=0.00150277f //x=2.275 \
 //y=1.09 //x2=1.3 //y2=1.4
cc_1447 ( N_RN_c_1864_p N_D_c_3938_n ) capacitor c=0.00111227f //x=2.275 \
 //y=1.4 //x2=1.3 //y2=1.71
cc_1448 ( N_RN_c_1598_n N_D_c_3939_n ) capacitor c=0.00147006f //x=2.71 \
 //y=2.375 //x2=1.3 //y2=2.095
cc_1449 ( N_RN_c_1633_n N_D_c_3939_n ) capacitor c=0.00214573f //x=2.71 \
 //y=2.26 //x2=1.3 //y2=2.095
cc_1450 ( N_RN_c_1657_n N_D_c_3939_n ) capacitor c=0.00964411f //x=2.8 \
 //y=2.095 //x2=1.3 //y2=2.095
cc_1451 ( N_RN_c_1862_p N_D_c_3942_n ) capacitor c=0.0160123f //x=2.275 \
 //y=1.09 //x2=1.83 //y2=1.055
cc_1452 ( N_RN_c_1654_n N_D_c_3942_n ) capacitor c=9.19165e-19 //x=2.8 \
 //y=1.09 //x2=1.83 //y2=1.055
cc_1453 ( N_RN_c_1864_p N_D_c_3944_n ) capacitor c=0.0124075f //x=2.275 \
 //y=1.4 //x2=1.83 //y2=1.4
cc_1454 ( N_RN_c_1655_n N_D_c_3944_n ) capacitor c=0.0010154f //x=2.8 //y=1.4 \
 //x2=1.83 //y2=1.4
cc_1455 ( N_RN_c_1656_n N_D_c_3944_n ) capacitor c=9.23422e-19 //x=2.8 \
 //y=1.63 //x2=1.83 //y2=1.4
cc_1456 ( N_RN_c_1514_n N_D_c_3910_n ) capacitor c=0.00105975f //x=2.71 \
 //y=4.875 //x2=2.165 //y2=4.97
cc_1457 ( N_RN_c_1525_n N_D_c_3910_n ) capacitor c=0.00127987f //x=2.71 \
 //y=4.88 //x2=2.165 //y2=4.97
cc_1458 ( N_RN_c_1535_n N_D_c_3910_n ) capacitor c=0.0164917f //x=2.71 \
 //y=4.88 //x2=2.165 //y2=4.97
cc_1459 ( N_RN_c_1514_n N_D_c_3950_n ) capacitor c=8.63332e-19 //x=2.71 \
 //y=4.875 //x2=1.875 //y2=4.97
cc_1460 ( N_RN_c_1525_n N_D_c_3950_n ) capacitor c=0.0012974f //x=2.71 \
 //y=4.88 //x2=1.875 //y2=4.97
cc_1461 ( N_RN_c_1535_n N_D_c_3950_n ) capacitor c=0.00406071f //x=2.71 \
 //y=4.88 //x2=1.875 //y2=4.97
cc_1462 ( N_RN_c_1654_n N_noxref_12_c_4022_n ) capacitor c=0.00123426f //x=2.8 \
 //y=1.09 //x2=3.505 //y2=1.175
cc_1463 ( N_RN_c_1655_n N_noxref_12_c_4022_n ) capacitor c=0.0129288f //x=2.8 \
 //y=1.4 //x2=3.505 //y2=1.175
cc_1464 ( N_RN_c_1656_n N_noxref_12_c_4022_n ) capacitor c=0.00132209f //x=2.8 \
 //y=1.63 //x2=3.505 //y2=1.175
cc_1465 ( N_RN_c_1598_n N_noxref_12_M1_noxref_d ) capacitor c=0.00610755f \
 //x=2.71 //y=2.375 //x2=2.35 //y2=1.09
cc_1466 ( N_RN_c_1633_n N_noxref_12_M1_noxref_d ) capacitor c=2.2052e-19 \
 //x=2.71 //y=2.26 //x2=2.35 //y2=1.09
cc_1467 ( N_RN_c_1862_p N_noxref_12_M1_noxref_d ) capacitor c=0.00253592f \
 //x=2.275 //y=1.09 //x2=2.35 //y2=1.09
cc_1468 ( N_RN_c_1864_p N_noxref_12_M1_noxref_d ) capacitor c=0.00604634f \
 //x=2.275 //y=1.4 //x2=2.35 //y2=1.09
cc_1469 ( N_RN_c_1886_p N_noxref_12_M1_noxref_d ) capacitor c=0.002686f \
 //x=2.645 //y=0.935 //x2=2.35 //y2=1.09
cc_1470 ( N_RN_c_1887_p N_noxref_12_M1_noxref_d ) capacitor c=0.00251995f \
 //x=2.645 //y=1.555 //x2=2.35 //y2=1.09
cc_1471 ( N_RN_c_1654_n N_noxref_12_M1_noxref_d ) capacitor c=0.00314523f \
 //x=2.8 //y=1.09 //x2=2.35 //y2=1.09
cc_1472 ( N_RN_c_1655_n N_noxref_12_M1_noxref_d ) capacitor c=0.00168289f \
 //x=2.8 //y=1.4 //x2=2.35 //y2=1.09
cc_1473 ( N_RN_c_1656_n N_noxref_12_M1_noxref_d ) capacitor c=0.00111165f \
 //x=2.8 //y=1.63 //x2=2.35 //y2=1.09
cc_1474 ( N_RN_c_1654_n N_noxref_12_M2_noxref_s ) capacitor c=7.21316e-19 \
 //x=2.8 //y=1.09 //x2=3.455 //y2=0.555
cc_1475 ( N_RN_c_1655_n N_noxref_12_M2_noxref_s ) capacitor c=0.00365271f \
 //x=2.8 //y=1.4 //x2=3.455 //y2=0.555
cc_1476 ( N_RN_c_1657_n N_noxref_12_M2_noxref_s ) capacitor c=9.86711e-19 \
 //x=2.8 //y=2.095 //x2=3.455 //y2=0.555
cc_1477 ( N_RN_c_1552_n N_noxref_15_c_4224_n ) capacitor c=0.00177186f \
 //x=18.25 //y=2.375 //x2=18.905 //y2=0.72
cc_1478 ( N_RN_c_1562_n N_noxref_15_c_4224_n ) capacitor c=0.00117306f \
 //x=18.25 //y=2.26 //x2=18.905 //y2=0.72
cc_1479 ( N_RN_c_1572_n N_noxref_15_c_4224_n ) capacitor c=0.0206349f \
 //x=18.24 //y=1.095 //x2=18.905 //y2=0.72
cc_1480 ( N_RN_c_1726_p N_noxref_15_c_4224_n ) capacitor c=0.00825432f \
 //x=18.77 //y=1.095 //x2=18.905 //y2=0.72
cc_1481 ( N_RN_c_1575_n N_noxref_15_c_4224_n ) capacitor c=2.20712e-19 \
 //x=18.25 //y=2.26 //x2=18.905 //y2=0.72
cc_1482 ( N_RN_c_1573_n N_noxref_15_c_4229_n ) capacitor c=0.0071177f \
 //x=18.24 //y=1.44 //x2=18.02 //y2=1.175
cc_1483 ( N_RN_c_1572_n N_noxref_15_M11_noxref_s ) capacitor c=0.0071177f \
 //x=18.24 //y=1.095 //x2=17.885 //y2=0.555
cc_1484 ( N_RN_c_1574_n N_noxref_15_M11_noxref_s ) capacitor c=0.0071177f \
 //x=18.24 //y=1.75 //x2=17.885 //y2=0.555
cc_1485 ( N_RN_c_1726_p N_noxref_15_M11_noxref_s ) capacitor c=0.015333f \
 //x=18.77 //y=1.095 //x2=17.885 //y2=0.555
cc_1486 ( N_RN_c_1727_p N_noxref_15_M11_noxref_s ) capacitor c=0.00248746f \
 //x=18.77 //y=1.44 //x2=17.885 //y2=0.555
cc_1487 ( N_RN_c_1667_n N_noxref_16_c_4278_n ) capacitor c=0.00123426f \
 //x=22.04 //y=1.09 //x2=22.745 //y2=1.175
cc_1488 ( N_RN_c_1668_n N_noxref_16_c_4278_n ) capacitor c=0.0129288f \
 //x=22.04 //y=1.4 //x2=22.745 //y2=1.175
cc_1489 ( N_RN_c_1669_n N_noxref_16_c_4278_n ) capacitor c=0.00132209f \
 //x=22.04 //y=1.63 //x2=22.745 //y2=1.175
cc_1490 ( N_RN_c_1601_n N_noxref_16_M13_noxref_d ) capacitor c=0.00604066f \
 //x=21.95 //y=2.375 //x2=21.59 //y2=1.09
cc_1491 ( N_RN_c_1640_n N_noxref_16_M13_noxref_d ) capacitor c=2.2052e-19 \
 //x=21.95 //y=2.26 //x2=21.59 //y2=1.09
cc_1492 ( N_RN_c_1662_n N_noxref_16_M13_noxref_d ) capacitor c=0.00253592f \
 //x=21.515 //y=1.09 //x2=21.59 //y2=1.09
cc_1493 ( N_RN_c_1665_n N_noxref_16_M13_noxref_d ) capacitor c=0.00604087f \
 //x=21.515 //y=1.4 //x2=21.59 //y2=1.09
cc_1494 ( N_RN_c_1911_p N_noxref_16_M13_noxref_d ) capacitor c=0.002686f \
 //x=21.885 //y=0.935 //x2=21.59 //y2=1.09
cc_1495 ( N_RN_c_1912_p N_noxref_16_M13_noxref_d ) capacitor c=0.00251995f \
 //x=21.885 //y=1.555 //x2=21.59 //y2=1.09
cc_1496 ( N_RN_c_1667_n N_noxref_16_M13_noxref_d ) capacitor c=0.00314523f \
 //x=22.04 //y=1.09 //x2=21.59 //y2=1.09
cc_1497 ( N_RN_c_1668_n N_noxref_16_M13_noxref_d ) capacitor c=0.00168289f \
 //x=22.04 //y=1.4 //x2=21.59 //y2=1.09
cc_1498 ( N_RN_c_1669_n N_noxref_16_M13_noxref_d ) capacitor c=0.00111165f \
 //x=22.04 //y=1.63 //x2=21.59 //y2=1.09
cc_1499 ( N_RN_c_1667_n N_noxref_16_M14_noxref_s ) capacitor c=7.21316e-19 \
 //x=22.04 //y=1.09 //x2=22.695 //y2=0.555
cc_1500 ( N_RN_c_1668_n N_noxref_16_M14_noxref_s ) capacitor c=0.00365271f \
 //x=22.04 //y=1.4 //x2=22.695 //y2=0.555
cc_1501 ( N_RN_c_1670_n N_noxref_16_M14_noxref_s ) capacitor c=9.86711e-19 \
 //x=22.04 //y=2.095 //x2=22.695 //y2=0.555
cc_1502 ( N_RN_c_1598_n N_GND_c_4349_n ) capacitor c=9.16616e-19 //x=2.71 \
 //y=2.375 //x2=6.29 //y2=0.175
cc_1503 ( N_RN_c_1552_n N_GND_c_4452_n ) capacitor c=0.0021992f //x=18.25 \
 //y=2.375 //x2=20.72 //y2=0.175
cc_1504 ( N_RN_c_1601_n N_GND_c_4495_n ) capacitor c=9.16602e-19 //x=21.95 \
 //y=2.375 //x2=25.53 //y2=0.175
cc_1505 ( N_RN_c_1552_n N_GND_c_4434_n ) capacitor c=2.016e-19 //x=18.25 \
 //y=2.375 //x2=19.56 //y2=0.175
cc_1506 ( N_RN_c_1562_n N_GND_c_4480_n ) capacitor c=0.00239899f //x=18.25 \
 //y=2.26 //x2=19.73 //y2=0.175
cc_1507 ( N_RN_c_1727_p N_GND_c_4480_n ) capacitor c=0.00262688f //x=18.77 \
 //y=1.44 //x2=19.73 //y2=0.175
cc_1508 ( N_RN_c_1575_n N_GND_c_4480_n ) capacitor c=2.63786e-19 //x=18.25 \
 //y=2.26 //x2=19.73 //y2=0.175
cc_1509 ( N_RN_c_1862_p N_noxref_19_c_4897_n ) capacitor c=0.0167228f \
 //x=2.275 //y=1.09 //x2=2.935 //y2=0.72
cc_1510 ( N_RN_c_1654_n N_noxref_19_c_4897_n ) capacitor c=0.00534519f //x=2.8 \
 //y=1.09 //x2=2.935 //y2=0.72
cc_1511 ( N_RN_c_1598_n N_noxref_19_c_4899_n ) capacitor c=0.0048147f //x=2.71 \
 //y=2.375 //x2=2.935 //y2=1.77
cc_1512 ( N_RN_c_1514_n N_noxref_19_c_4899_n ) capacitor c=9.35401e-19 \
 //x=2.71 //y=4.875 //x2=2.935 //y2=1.77
cc_1513 ( N_RN_c_1633_n N_noxref_19_c_4899_n ) capacitor c=0.0105652f //x=2.71 \
 //y=2.26 //x2=2.935 //y2=1.77
cc_1514 ( N_RN_c_1864_p N_noxref_19_c_4899_n ) capacitor c=0.0153476f \
 //x=2.275 //y=1.4 //x2=2.935 //y2=1.77
cc_1515 ( N_RN_c_1657_n N_noxref_19_c_4899_n ) capacitor c=0.0205547f //x=2.8 \
 //y=2.095 //x2=2.935 //y2=1.77
cc_1516 ( N_RN_c_1862_p N_noxref_19_M0_noxref_s ) capacitor c=0.00798959f \
 //x=2.275 //y=1.09 //x2=0.945 //y2=0.555
cc_1517 ( N_RN_c_1656_n N_noxref_19_M0_noxref_s ) capacitor c=0.00212176f \
 //x=2.8 //y=1.63 //x2=0.945 //y2=0.555
cc_1518 ( N_RN_c_1657_n N_noxref_19_M0_noxref_s ) capacitor c=0.00298115f \
 //x=2.8 //y=2.095 //x2=0.945 //y2=0.555
cc_1519 ( N_RN_c_1662_n N_noxref_23_c_5142_n ) capacitor c=0.0167228f \
 //x=21.515 //y=1.09 //x2=22.175 //y2=0.72
cc_1520 ( N_RN_c_1667_n N_noxref_23_c_5142_n ) capacitor c=0.00534519f \
 //x=22.04 //y=1.09 //x2=22.175 //y2=0.72
cc_1521 ( N_RN_c_1601_n N_noxref_23_c_5144_n ) capacitor c=0.0048147f \
 //x=21.95 //y=2.375 //x2=22.175 //y2=1.77
cc_1522 ( N_RN_c_1607_n N_noxref_23_c_5144_n ) capacitor c=8.71408e-19 \
 //x=21.945 //y=4.84 //x2=22.175 //y2=1.77
cc_1523 ( N_RN_c_1640_n N_noxref_23_c_5144_n ) capacitor c=0.0105652f \
 //x=21.95 //y=2.26 //x2=22.175 //y2=1.77
cc_1524 ( N_RN_c_1665_n N_noxref_23_c_5144_n ) capacitor c=0.0153476f \
 //x=21.515 //y=1.4 //x2=22.175 //y2=1.77
cc_1525 ( N_RN_c_1670_n N_noxref_23_c_5144_n ) capacitor c=0.0200931f \
 //x=22.04 //y=2.095 //x2=22.175 //y2=1.77
cc_1526 ( N_RN_c_1662_n N_noxref_23_M12_noxref_s ) capacitor c=0.00798959f \
 //x=21.515 //y=1.09 //x2=20.185 //y2=0.555
cc_1527 ( N_RN_c_1669_n N_noxref_23_M12_noxref_s ) capacitor c=0.00212176f \
 //x=22.04 //y=1.63 //x2=20.185 //y2=0.555
cc_1528 ( N_RN_c_1670_n N_noxref_23_M12_noxref_s ) capacitor c=0.00298115f \
 //x=22.04 //y=2.095 //x2=20.185 //y2=0.555
cc_1529 ( QN SN ) capacitor c=2.5865e-19 //x=23.8 //y=2.4 //x2=26.76 //y2=3.14
cc_1530 ( QN SN ) capacitor c=0.0012725f //x=23.8 //y=4.62 //x2=26.76 //y2=3.14
cc_1531 ( QN SN ) capacitor c=0.0133969f //x=25.65 //y=2.4 //x2=26.76 //y2=3.14
cc_1532 ( QN SN ) capacitor c=0.0267863f //x=25.65 //y=4.62 //x2=26.76 //y2=3.14
cc_1533 ( QN SN ) capacitor c=4.11345e-19 //x=25.65 //y=3.51 //x2=26.76 \
 //y2=3.14
cc_1534 ( N_QN_c_1977_p SN ) capacitor c=0.00776638f //x=25.65 //y=3.655 \
 //x2=26.76 //y2=3.14
cc_1535 ( N_QN_c_1978_p SN ) capacitor c=4.22428e-19 //x=25.65 //y=4.755 \
 //x2=26.76 //y2=3.14
cc_1536 ( N_QN_c_1979_p SN ) capacitor c=0.00512089f //x=25.645 //y=3.495 \
 //x2=26.76 //y2=3.14
cc_1537 ( N_QN_c_1980_p SN ) capacitor c=3.36194e-19 //x=25.65 //y=4.88 \
 //x2=26.76 //y2=3.14
cc_1538 ( QN SN ) capacitor c=2.98299e-19 //x=25.65 //y=2.4 //x2=26.76 //y2=2.77
cc_1539 ( N_QN_c_1982_p N_SN_c_2344_n ) capacitor c=0.0115546f //x=25.65 \
 //y=2.375 //x2=26.76 //y2=2.375
cc_1540 ( N_QN_c_1983_p N_SN_c_2344_n ) capacitor c=5.40058e-19 //x=25.65 \
 //y=2.26 //x2=26.76 //y2=2.375
cc_1541 ( N_QN_c_1984_p N_SN_c_2344_n ) capacitor c=0.00147006f //x=25.35 \
 //y=2.095 //x2=26.76 //y2=2.375
cc_1542 ( QN N_SN_c_2347_n ) capacitor c=5.20978e-19 //x=23.8 //y=2.4 \
 //x2=26.76 //y2=2.61
cc_1543 ( QN N_SN_c_2347_n ) capacitor c=0.00652526f //x=25.65 //y=2.4 \
 //x2=26.76 //y2=2.61
cc_1544 ( N_QN_c_1983_p N_SN_c_2347_n ) capacitor c=4.16726e-19 //x=25.65 \
 //y=2.26 //x2=26.76 //y2=2.61
cc_1545 ( QN N_SN_c_2350_n ) capacitor c=0.00774769f //x=25.65 //y=2.4 \
 //x2=26.76 //y2=2.93
cc_1546 ( N_QN_c_1978_p N_SN_c_2351_n ) capacitor c=0.0110307f //x=25.65 \
 //y=4.755 //x2=26.76 //y2=4.765
cc_1547 ( N_QN_c_1980_p N_SN_c_2351_n ) capacitor c=2.89813e-19 //x=25.65 \
 //y=4.88 //x2=26.76 //y2=4.765
cc_1548 ( N_QN_c_1991_p N_SN_c_2351_n ) capacitor c=7.66769e-19 //x=26.215 \
 //y=4.97 //x2=26.76 //y2=4.765
cc_1549 ( N_QN_c_1992_p N_SN_c_2351_n ) capacitor c=7.54501e-19 //x=25.925 \
 //y=4.97 //x2=26.76 //y2=4.765
cc_1550 ( QN N_SN_c_2290_n ) capacitor c=0.0306038f //x=23.8 //y=2.4 \
 //x2=16.245 //y2=2.75
cc_1551 ( QN N_SN_c_2290_n ) capacitor c=0.0326427f //x=25.65 //y=2.4 \
 //x2=16.245 //y2=2.75
cc_1552 ( N_QN_c_1995_p N_SN_c_2290_n ) capacitor c=5.32273e-19 //x=23.315 \
 //y=1.305 //x2=16.245 //y2=2.75
cc_1553 ( N_QN_c_1996_p N_SN_c_2290_n ) capacitor c=0.0140859f //x=23.4 \
 //y=1.845 //x2=16.245 //y2=2.75
cc_1554 ( N_QN_c_1997_p N_SN_c_2290_n ) capacitor c=0.00511475f //x=23.8 \
 //y=3.655 //x2=16.245 //y2=2.75
cc_1555 ( N_QN_c_1982_p N_SN_c_2290_n ) capacitor c=0.00279912f //x=25.65 \
 //y=2.375 //x2=16.245 //y2=2.75
cc_1556 ( N_QN_c_1977_p N_SN_c_2290_n ) capacitor c=0.00415497f //x=25.65 \
 //y=3.655 //x2=16.245 //y2=2.75
cc_1557 ( N_QN_c_2000_p N_SN_c_2290_n ) capacitor c=0.0162295f //x=23.96 \
 //y=3.495 //x2=16.245 //y2=2.75
cc_1558 ( N_QN_c_1979_p N_SN_c_2290_n ) capacitor c=0.0162294f //x=25.645 \
 //y=3.495 //x2=16.245 //y2=2.75
cc_1559 ( N_QN_c_2002_p N_SN_c_2290_n ) capacitor c=0.0708605f //x=25.485 \
 //y=3.495 //x2=16.245 //y2=2.75
cc_1560 ( QN N_SN_c_2365_n ) capacitor c=4.16726e-19 //x=25.65 //y=2.4 \
 //x2=26.76 //y2=2.26
cc_1561 ( N_QN_c_1982_p N_SN_c_2365_n ) capacitor c=5.39999e-19 //x=25.65 \
 //y=2.375 //x2=26.76 //y2=2.26
cc_1562 ( N_QN_c_1983_p N_SN_c_2365_n ) capacitor c=0.00125213f //x=25.65 \
 //y=2.26 //x2=26.76 //y2=2.26
cc_1563 ( N_QN_c_1984_p N_SN_c_2365_n ) capacitor c=0.00214573f //x=25.35 \
 //y=2.095 //x2=26.76 //y2=2.26
cc_1564 ( QN N_SN_c_2369_n ) capacitor c=3.30718e-19 //x=25.65 //y=4.62 \
 //x2=26.76 //y2=4.88
cc_1565 ( N_QN_c_1978_p N_SN_c_2369_n ) capacitor c=7.03272e-19 //x=25.65 \
 //y=4.755 //x2=26.76 //y2=4.88
cc_1566 ( N_QN_c_1980_p N_SN_c_2369_n ) capacitor c=0.00113984f //x=25.65 \
 //y=4.88 //x2=26.76 //y2=4.88
cc_1567 ( N_QN_c_1991_p N_SN_c_2369_n ) capacitor c=0.00116563f //x=26.215 \
 //y=4.97 //x2=26.76 //y2=4.88
cc_1568 ( N_QN_c_1992_p N_SN_c_2369_n ) capacitor c=0.00129812f //x=25.925 \
 //y=4.97 //x2=26.76 //y2=4.88
cc_1569 ( N_QN_M48_noxref_g N_SN_M50_noxref_g ) capacitor c=0.0106276f \
 //x=25.85 //y=6.2 //x2=26.73 //y2=6.2
cc_1570 ( N_QN_M49_noxref_g N_SN_M50_noxref_g ) capacitor c=0.107144f \
 //x=26.29 //y=6.2 //x2=26.73 //y2=6.2
cc_1571 ( N_QN_M49_noxref_g N_SN_M51_noxref_g ) capacitor c=0.0101598f \
 //x=26.29 //y=6.2 //x2=27.17 //y2=6.2
cc_1572 ( N_QN_c_2015_p N_SN_c_2377_n ) capacitor c=5.72528e-19 //x=25.35 \
 //y=1.055 //x2=26.325 //y2=1.09
cc_1573 ( N_QN_c_2016_p N_SN_c_2377_n ) capacitor c=0.00150277f //x=25.35 \
 //y=1.4 //x2=26.325 //y2=1.09
cc_1574 ( N_QN_c_2017_p N_SN_c_2377_n ) capacitor c=0.0160123f //x=25.88 \
 //y=1.055 //x2=26.325 //y2=1.09
cc_1575 ( N_QN_c_2018_p N_SN_c_2380_n ) capacitor c=0.00111227f //x=25.35 \
 //y=1.71 //x2=26.325 //y2=1.4
cc_1576 ( N_QN_c_2019_p N_SN_c_2380_n ) capacitor c=0.0124075f //x=25.88 \
 //y=1.4 //x2=26.325 //y2=1.4
cc_1577 ( N_QN_c_2017_p N_SN_c_2382_n ) capacitor c=9.19165e-19 //x=25.88 \
 //y=1.055 //x2=26.85 //y2=1.09
cc_1578 ( N_QN_c_2019_p N_SN_c_2383_n ) capacitor c=0.0010154f //x=25.88 \
 //y=1.4 //x2=26.85 //y2=1.4
cc_1579 ( N_QN_c_2019_p N_SN_c_2384_n ) capacitor c=9.23422e-19 //x=25.88 \
 //y=1.4 //x2=26.85 //y2=1.63
cc_1580 ( N_QN_c_1982_p N_SN_c_2385_n ) capacitor c=0.00140534f //x=25.65 \
 //y=2.375 //x2=26.85 //y2=2.095
cc_1581 ( N_QN_c_1983_p N_SN_c_2385_n ) capacitor c=0.0020754f //x=25.65 \
 //y=2.26 //x2=26.85 //y2=2.095
cc_1582 ( N_QN_c_1984_p N_SN_c_2385_n ) capacitor c=0.00964411f //x=25.35 \
 //y=2.095 //x2=26.85 //y2=2.095
cc_1583 ( N_QN_c_1978_p N_SN_c_2388_n ) capacitor c=0.00116212f //x=25.65 \
 //y=4.755 //x2=26.76 //y2=4.88
cc_1584 ( N_QN_c_1980_p N_SN_c_2388_n ) capacitor c=0.00155973f //x=25.65 \
 //y=4.88 //x2=26.76 //y2=4.88
cc_1585 ( N_QN_c_1991_p N_SN_c_2388_n ) capacitor c=0.0171374f //x=26.215 \
 //y=4.97 //x2=26.76 //y2=4.88
cc_1586 ( N_QN_c_1992_p N_SN_c_2388_n ) capacitor c=0.00484466f //x=25.925 \
 //y=4.97 //x2=26.76 //y2=4.88
cc_1587 ( N_QN_c_1947_n N_noxref_8_c_2850_n ) capacitor c=6.09703e-19 \
 //x=21.262 //y=5.335 //x2=18.21 //y2=5.56
cc_1588 ( N_QN_c_1947_n N_noxref_8_c_2852_n ) capacitor c=0.00306432f \
 //x=21.262 //y=5.335 //x2=18.905 //y2=5.335
cc_1589 ( N_QN_c_1996_p N_noxref_8_c_2867_n ) capacitor c=0.00163399f //x=23.4 \
 //y=1.845 //x2=18.905 //y2=1.845
cc_1590 ( QN N_noxref_8_c_2918_n ) capacitor c=0.00152193f //x=25.65 //y=2.4 \
 //x2=27.87 //y2=4.105
cc_1591 ( QN N_noxref_8_c_2918_n ) capacitor c=4.79644e-19 //x=25.65 //y=4.62 \
 //x2=27.87 //y2=4.105
cc_1592 ( QN N_noxref_8_c_2920_n ) capacitor c=6.15856e-19 //x=25.65 //y=4.62 \
 //x2=27.87 //y2=4.75
cc_1593 ( QN N_noxref_8_c_2800_n ) capacitor c=0.0300465f //x=23.8 //y=4.62 \
 //x2=27.71 //y2=4.265
cc_1594 ( QN N_noxref_8_c_2800_n ) capacitor c=0.0288152f //x=25.65 //y=4.62 \
 //x2=27.71 //y2=4.265
cc_1595 ( N_QN_c_2038_p N_noxref_8_c_2800_n ) capacitor c=0.0138652f \
 //x=23.715 //y=5.335 //x2=27.71 //y2=4.265
cc_1596 ( N_QN_c_1978_p N_noxref_8_c_2800_n ) capacitor c=0.00307641f \
 //x=25.65 //y=4.755 //x2=27.71 //y2=4.265
cc_1597 ( N_QN_c_1962_n N_noxref_8_c_2800_n ) capacitor c=0.031423f //x=22.14 \
 //y=5.335 //x2=27.71 //y2=4.265
cc_1598 ( N_QN_c_2002_p N_noxref_8_c_2800_n ) capacitor c=0.00927094f \
 //x=25.485 //y=3.495 //x2=27.71 //y2=4.265
cc_1599 ( QN Q ) capacitor c=0.0415582f //x=23.8 //y=2.4 //x2=23.06 //y2=2.4
cc_1600 ( QN Q ) capacitor c=0.00215885f //x=23.8 //y=4.62 //x2=23.06 //y2=2.4
cc_1601 ( QN Q ) capacitor c=0.00150202f //x=25.65 //y=2.4 //x2=23.06 //y2=2.4
cc_1602 ( QN Q ) capacitor c=7.6985e-19 //x=23.8 //y=3.51 //x2=23.06 //y2=2.4
cc_1603 ( N_QN_c_1997_p Q ) capacitor c=0.0151188f //x=23.8 //y=3.655 \
 //x2=23.06 //y2=2.4
cc_1604 ( N_QN_c_2000_p Q ) capacitor c=0.00696908f //x=23.96 //y=3.495 \
 //x2=23.06 //y2=2.4
cc_1605 ( QN Q ) capacitor c=0.0294187f //x=23.8 //y=4.62 //x2=23.06 //y2=4.62
cc_1606 ( QN Q ) capacitor c=0.00146083f //x=25.65 //y=4.62 //x2=23.06 //y2=4.62
cc_1607 ( QN Q ) capacitor c=7.6985e-19 //x=23.8 //y=4.62 //x2=23.06 //y2=3.88
cc_1608 ( QN N_Q_c_3228_n ) capacitor c=0.0154269f //x=23.8 //y=2.4 //x2=23.06 \
 //y2=2.375
cc_1609 ( QN N_Q_c_3231_n ) capacitor c=0.017488f //x=23.8 //y=4.62 //x2=23.06 \
 //y2=4.025
cc_1610 ( N_QN_c_1960_n N_Q_c_3231_n ) capacitor c=0.00101109f //x=22.905 \
 //y=5.335 //x2=23.06 //y2=4.025
cc_1611 ( N_QN_c_2038_p N_Q_c_3231_n ) capacitor c=0.00135056f //x=23.715 \
 //y=5.335 //x2=23.06 //y2=4.025
cc_1612 ( N_QN_c_1996_p N_Q_c_3231_n ) capacitor c=8.43174e-19 //x=23.4 \
 //y=1.845 //x2=23.06 //y2=4.025
cc_1613 ( QN N_Q_c_3232_n ) capacitor c=0.0150867f //x=23.8 //y=4.62 \
 //x2=23.06 //y2=4.75
cc_1614 ( N_QN_c_2038_p N_Q_c_3232_n ) capacitor c=0.0023499f //x=23.715 \
 //y=5.335 //x2=23.06 //y2=4.75
cc_1615 ( N_QN_c_2058_p N_Q_c_3232_n ) capacitor c=0.0224759f //x=23.02 \
 //y=5.335 //x2=23.06 //y2=4.75
cc_1616 ( N_QN_c_2059_p N_Q_c_3232_n ) capacitor c=0.00217653f //x=23.02 \
 //y=5.56 //x2=23.06 //y2=4.75
cc_1617 ( N_QN_M49_noxref_g N_Q_c_3275_n ) capacitor c=0.00973141f //x=26.29 \
 //y=6.2 //x2=26.83 //y2=5.335
cc_1618 ( N_QN_c_2061_p N_Q_c_3276_n ) capacitor c=0.00163399f //x=23.715 \
 //y=1.845 //x2=28.21 //y2=1.845
cc_1619 ( N_QN_c_2062_p N_Q_c_3277_n ) capacitor c=6.09703e-19 //x=23.02 \
 //y=5.56 //x2=26.072 //y2=5.335
cc_1620 ( N_QN_c_2038_p N_Q_c_3277_n ) capacitor c=0.00306432f //x=23.715 \
 //y=5.335 //x2=26.072 //y2=5.335
cc_1621 ( N_QN_M48_noxref_g N_Q_c_3277_n ) capacitor c=0.00461408f //x=25.85 \
 //y=6.2 //x2=26.072 //y2=5.335
cc_1622 ( N_QN_M49_noxref_g N_Q_c_3277_n ) capacitor c=0.00229208f //x=26.29 \
 //y=6.2 //x2=26.072 //y2=5.335
cc_1623 ( N_QN_c_1991_p N_Q_c_3277_n ) capacitor c=0.00171885f //x=26.215 \
 //y=4.97 //x2=26.072 //y2=5.335
cc_1624 ( QN N_Q_c_3221_n ) capacitor c=0.00333413f //x=23.8 //y=4.62 \
 //x2=23.21 //y2=3.865
cc_1625 ( QN N_Q_c_3283_n ) capacitor c=0.0216926f //x=23.8 //y=4.62 \
 //x2=28.445 //y2=3.875
cc_1626 ( QN N_Q_c_3283_n ) capacitor c=0.0242206f //x=25.65 //y=4.62 \
 //x2=28.445 //y2=3.875
cc_1627 ( N_QN_c_1997_p N_Q_c_3283_n ) capacitor c=0.00917068f //x=23.8 \
 //y=3.655 //x2=28.445 //y2=3.875
cc_1628 ( N_QN_c_1977_p N_Q_c_3283_n ) capacitor c=0.00623808f //x=25.65 \
 //y=3.655 //x2=28.445 //y2=3.875
cc_1629 ( N_QN_c_2000_p N_Q_c_3283_n ) capacitor c=0.0358686f //x=23.96 \
 //y=3.495 //x2=28.445 //y2=3.875
cc_1630 ( N_QN_c_1979_p N_Q_c_3283_n ) capacitor c=0.0358686f //x=25.645 \
 //y=3.495 //x2=28.445 //y2=3.875
cc_1631 ( N_QN_c_2002_p N_Q_c_3283_n ) capacitor c=0.133853f //x=25.485 \
 //y=3.495 //x2=28.445 //y2=3.875
cc_1632 ( QN N_Q_c_3236_n ) capacitor c=0.00163444f //x=23.8 //y=2.4 \
 //x2=23.06 //y2=2.26
cc_1633 ( QN N_Q_c_3240_n ) capacitor c=0.00131258f //x=23.8 //y=4.62 \
 //x2=23.06 //y2=4.88
cc_1634 ( N_QN_c_2038_p N_Q_c_3240_n ) capacitor c=0.00130631f //x=23.715 \
 //y=5.335 //x2=23.06 //y2=4.88
cc_1635 ( N_QN_c_2058_p N_Q_c_3240_n ) capacitor c=0.00346456f //x=23.02 \
 //y=5.335 //x2=23.06 //y2=4.88
cc_1636 ( N_QN_c_2059_p N_Q_c_3240_n ) capacitor c=0.00552343f //x=23.02 \
 //y=5.56 //x2=23.06 //y2=4.88
cc_1637 ( N_QN_M48_noxref_g N_Q_c_3295_n ) capacitor c=0.0162284f //x=25.85 \
 //y=6.2 //x2=26.07 //y2=5.56
cc_1638 ( N_QN_M49_noxref_g N_Q_c_3295_n ) capacitor c=0.0179041f //x=26.29 \
 //y=6.2 //x2=26.07 //y2=5.56
cc_1639 ( N_QN_c_1991_p N_Q_c_3295_n ) capacitor c=0.00291477f //x=26.215 \
 //y=4.97 //x2=26.07 //y2=5.56
cc_1640 ( N_QN_c_1960_n N_Q_M46_noxref_g ) capacitor c=0.0103546f //x=22.905 \
 //y=5.335 //x2=22.8 //y2=6.2
cc_1641 ( N_QN_c_2062_p N_Q_M46_noxref_g ) capacitor c=0.00226521f //x=23.02 \
 //y=5.56 //x2=22.8 //y2=6.2
cc_1642 ( N_QN_c_2059_p N_Q_M46_noxref_g ) capacitor c=0.0178885f //x=23.02 \
 //y=5.56 //x2=22.8 //y2=6.2
cc_1643 ( N_QN_c_2062_p N_Q_M47_noxref_g ) capacitor c=0.00381703f //x=23.02 \
 //y=5.56 //x2=23.24 //y2=6.2
cc_1644 ( N_QN_c_2038_p N_Q_M47_noxref_g ) capacitor c=0.0110793f //x=23.715 \
 //y=5.335 //x2=23.24 //y2=6.2
cc_1645 ( N_QN_c_2059_p N_Q_M47_noxref_g ) capacitor c=0.0188608f //x=23.02 \
 //y=5.56 //x2=23.24 //y2=6.2
cc_1646 ( N_QN_c_1995_p N_Q_c_3246_n ) capacitor c=4.64015e-19 //x=23.315 \
 //y=1.305 //x2=23.05 //y2=1.095
cc_1647 ( N_QN_M14_noxref_d N_Q_c_3246_n ) capacitor c=0.00137165f //x=23.125 \
 //y=1.095 //x2=23.05 //y2=1.095
cc_1648 ( N_QN_c_1995_p N_Q_c_3247_n ) capacitor c=0.0026012f //x=23.315 \
 //y=1.305 //x2=23.05 //y2=1.44
cc_1649 ( N_QN_c_2092_p N_Q_c_3247_n ) capacitor c=0.00127432f //x=23.315 \
 //y=1.76 //x2=23.05 //y2=1.44
cc_1650 ( N_QN_M14_noxref_d N_Q_c_3247_n ) capacitor c=0.00237422f //x=23.125 \
 //y=1.095 //x2=23.05 //y2=1.44
cc_1651 ( N_QN_c_2092_p N_Q_c_3248_n ) capacitor c=0.00429966f //x=23.315 \
 //y=1.76 //x2=23.05 //y2=1.75
cc_1652 ( N_QN_c_1995_p N_Q_c_3310_n ) capacitor c=5.29969e-19 //x=23.315 \
 //y=1.305 //x2=23.425 //y2=0.94
cc_1653 ( N_QN_M14_noxref_d N_Q_c_3310_n ) capacitor c=0.0020782f //x=23.125 \
 //y=1.095 //x2=23.425 //y2=0.94
cc_1654 ( N_QN_c_1995_p N_Q_c_3312_n ) capacitor c=5.19047e-19 //x=23.315 \
 //y=1.305 //x2=23.425 //y2=1.595
cc_1655 ( N_QN_c_2092_p N_Q_c_3312_n ) capacitor c=0.00942306f //x=23.315 \
 //y=1.76 //x2=23.425 //y2=1.595
cc_1656 ( N_QN_c_2061_p N_Q_c_3312_n ) capacitor c=0.00194716f //x=23.715 \
 //y=1.845 //x2=23.425 //y2=1.595
cc_1657 ( N_QN_M14_noxref_d N_Q_c_3312_n ) capacitor c=0.00356097f //x=23.125 \
 //y=1.095 //x2=23.425 //y2=1.595
cc_1658 ( N_QN_c_1995_p N_Q_c_3316_n ) capacitor c=5.24634e-19 //x=23.315 \
 //y=1.305 //x2=23.58 //y2=1.095
cc_1659 ( N_QN_M14_noxref_d N_Q_c_3316_n ) capacitor c=0.00139206f //x=23.125 \
 //y=1.095 //x2=23.58 //y2=1.095
cc_1660 ( N_QN_c_1995_p N_Q_c_3318_n ) capacitor c=0.00307978f //x=23.315 \
 //y=1.305 //x2=23.58 //y2=1.44
cc_1661 ( N_QN_c_2092_p N_Q_c_3318_n ) capacitor c=0.00363411f //x=23.315 \
 //y=1.76 //x2=23.58 //y2=1.44
cc_1662 ( N_QN_c_2061_p N_Q_c_3318_n ) capacitor c=0.00323576f //x=23.715 \
 //y=1.845 //x2=23.58 //y2=1.44
cc_1663 ( N_QN_M14_noxref_d N_Q_c_3318_n ) capacitor c=0.00237422f //x=23.125 \
 //y=1.095 //x2=23.58 //y2=1.44
cc_1664 ( QN N_Q_c_3249_n ) capacitor c=0.0025845f //x=23.8 //y=2.4 //x2=23.06 \
 //y2=2.26
cc_1665 ( QN N_Q_c_3252_n ) capacitor c=0.00282067f //x=23.8 //y=2.4 \
 //x2=23.06 //y2=2.095
cc_1666 ( N_QN_c_2092_p N_Q_c_3252_n ) capacitor c=0.0036273f //x=23.315 \
 //y=1.76 //x2=23.06 //y2=2.095
cc_1667 ( QN N_Q_c_3253_n ) capacitor c=0.00739875f //x=23.8 //y=4.62 \
 //x2=23.06 //y2=4.88
cc_1668 ( N_QN_c_2058_p N_Q_c_3253_n ) capacitor c=0.00203307f //x=23.02 \
 //y=5.335 //x2=23.06 //y2=4.88
cc_1669 ( N_QN_c_2059_p N_Q_c_3253_n ) capacitor c=0.00375636f //x=23.02 \
 //y=5.56 //x2=23.06 //y2=4.88
cc_1670 ( N_QN_c_1946_n N_VDD_c_3497_n ) capacitor c=0.00621352f //x=22.02 \
 //y=5.335 //x2=28.61 //y2=7.58
cc_1671 ( N_QN_c_1960_n N_VDD_c_3497_n ) capacitor c=0.00627189f //x=22.905 \
 //y=5.335 //x2=28.61 //y2=7.58
cc_1672 ( N_QN_c_2062_p N_VDD_c_3497_n ) capacitor c=0.00256019f //x=23.02 \
 //y=5.56 //x2=28.61 //y2=7.58
cc_1673 ( N_QN_c_2038_p N_VDD_c_3497_n ) capacitor c=0.00829247f //x=23.715 \
 //y=5.335 //x2=28.61 //y2=7.58
cc_1674 ( N_QN_c_1997_p N_VDD_c_3497_n ) capacitor c=4.57419e-19 //x=23.8 \
 //y=3.655 //x2=28.61 //y2=7.58
cc_1675 ( N_QN_c_1977_p N_VDD_c_3497_n ) capacitor c=3.78052e-19 //x=25.65 \
 //y=3.655 //x2=28.61 //y2=7.58
cc_1676 ( N_QN_c_1947_n N_VDD_c_3497_n ) capacitor c=0.00261804f //x=21.262 \
 //y=5.335 //x2=28.61 //y2=7.58
cc_1677 ( N_QN_c_1962_n N_VDD_c_3497_n ) capacitor c=0.00270108f //x=22.14 \
 //y=5.335 //x2=28.61 //y2=7.58
cc_1678 ( N_QN_c_1950_n N_VDD_c_3497_n ) capacitor c=0.0024232f //x=21.26 \
 //y=5.56 //x2=28.61 //y2=7.58
cc_1679 ( N_QN_c_1968_n N_VDD_c_3497_n ) capacitor c=0.0024232f //x=22.14 \
 //y=5.56 //x2=28.61 //y2=7.58
cc_1680 ( N_QN_c_2059_p N_VDD_c_3497_n ) capacitor c=0.0024232f //x=23.02 \
 //y=5.56 //x2=28.61 //y2=7.58
cc_1681 ( N_QN_c_1946_n N_VDD_c_3648_n ) capacitor c=0.00202922f //x=22.02 \
 //y=5.335 //x2=21.615 //y2=7.585
cc_1682 ( N_QN_c_1947_n N_VDD_c_3648_n ) capacitor c=9.3757e-19 //x=21.262 \
 //y=5.335 //x2=21.615 //y2=7.585
cc_1683 ( N_QN_c_1950_n N_VDD_c_3648_n ) capacitor c=0.0138074f //x=21.26 \
 //y=5.56 //x2=21.615 //y2=7.585
cc_1684 ( N_QN_c_1946_n N_VDD_c_3688_n ) capacitor c=0.0017708f //x=22.02 \
 //y=5.335 //x2=22.495 //y2=7.585
cc_1685 ( N_QN_c_1960_n N_VDD_c_3688_n ) capacitor c=0.00202922f //x=22.905 \
 //y=5.335 //x2=22.495 //y2=7.585
cc_1686 ( N_QN_c_1962_n N_VDD_c_3688_n ) capacitor c=9.4822e-19 //x=22.14 \
 //y=5.335 //x2=22.495 //y2=7.585
cc_1687 ( N_QN_c_1968_n N_VDD_c_3688_n ) capacitor c=0.0138074f //x=22.14 \
 //y=5.56 //x2=22.495 //y2=7.585
cc_1688 ( N_QN_c_1960_n N_VDD_c_3725_n ) capacitor c=0.00205906f //x=22.905 \
 //y=5.335 //x2=23.375 //y2=7.585
cc_1689 ( N_QN_c_2062_p N_VDD_c_3725_n ) capacitor c=8.49654e-19 //x=23.02 \
 //y=5.56 //x2=23.375 //y2=7.585
cc_1690 ( N_QN_c_2038_p N_VDD_c_3725_n ) capacitor c=0.00204238f //x=23.715 \
 //y=5.335 //x2=23.375 //y2=7.585
cc_1691 ( N_QN_c_2059_p N_VDD_c_3725_n ) capacitor c=0.0135103f //x=23.02 \
 //y=5.56 //x2=23.375 //y2=7.585
cc_1692 ( N_QN_c_2038_p N_VDD_c_3729_n ) capacitor c=0.00183742f //x=23.715 \
 //y=5.335 //x2=24.37 //y2=7.585
cc_1693 ( N_QN_M48_noxref_g N_VDD_c_3730_n ) capacitor c=0.00755614f //x=25.85 \
 //y=6.2 //x2=26.425 //y2=7.585
cc_1694 ( N_QN_M49_noxref_g N_VDD_c_3730_n ) capacitor c=0.00755544f //x=26.29 \
 //y=6.2 //x2=26.425 //y2=7.585
cc_1695 ( N_QN_c_1947_n N_VDD_c_3658_n ) capacitor c=0.0022955f //x=21.262 \
 //y=5.335 //x2=19.73 //y2=7.585
cc_1696 ( N_QN_c_1950_n N_VDD_c_3658_n ) capacitor c=0.00509469f //x=21.26 \
 //y=5.56 //x2=19.73 //y2=7.585
cc_1697 ( QN N_VDD_c_3734_n ) capacitor c=0.0347465f //x=23.8 //y=4.62 \
 //x2=24.54 //y2=7.585
cc_1698 ( QN N_VDD_c_3734_n ) capacitor c=0.00935853f //x=25.65 //y=4.62 \
 //x2=24.54 //y2=7.585
cc_1699 ( N_QN_c_2062_p N_VDD_c_3734_n ) capacitor c=0.00282782f //x=23.02 \
 //y=5.56 //x2=24.54 //y2=7.585
cc_1700 ( N_QN_c_1978_p N_VDD_c_3734_n ) capacitor c=0.00419437f //x=25.65 \
 //y=4.755 //x2=24.54 //y2=7.585
cc_1701 ( N_QN_c_2059_p N_VDD_c_3734_n ) capacitor c=0.00777981f //x=23.02 \
 //y=5.56 //x2=24.54 //y2=7.585
cc_1702 ( N_QN_c_1980_p N_VDD_c_3734_n ) capacitor c=0.00370784f //x=25.65 \
 //y=4.88 //x2=24.54 //y2=7.585
cc_1703 ( N_QN_c_1992_p N_VDD_c_3734_n ) capacitor c=0.00590568f //x=25.925 \
 //y=4.97 //x2=24.54 //y2=7.585
cc_1704 ( N_QN_c_1947_n N_VDD_M42_noxref_s ) capacitor c=0.0442713f //x=21.262 \
 //y=5.335 //x2=20.685 //y2=5.2
cc_1705 ( N_QN_c_1962_n N_VDD_M42_noxref_s ) capacitor c=7.80122e-19 //x=22.14 \
 //y=5.335 //x2=20.685 //y2=5.2
cc_1706 ( N_QN_c_1950_n N_VDD_M42_noxref_s ) capacitor c=0.09305f //x=21.26 \
 //y=5.56 //x2=20.685 //y2=5.2
cc_1707 ( N_QN_c_1946_n N_VDD_M43_noxref_d ) capacitor c=0.00700141f //x=22.02 \
 //y=5.335 //x2=21.555 //y2=5.2
cc_1708 ( N_QN_c_1950_n N_VDD_M43_noxref_d ) capacitor c=0.0674491f //x=21.26 \
 //y=5.56 //x2=21.555 //y2=5.2
cc_1709 ( N_QN_c_1968_n N_VDD_M43_noxref_d ) capacitor c=0.0674762f //x=22.14 \
 //y=5.56 //x2=21.555 //y2=5.2
cc_1710 ( N_QN_c_1960_n N_VDD_M45_noxref_d ) capacitor c=0.00700141f \
 //x=22.905 //y=5.335 //x2=22.435 //y2=5.2
cc_1711 ( N_QN_c_1968_n N_VDD_M45_noxref_d ) capacitor c=0.067493f //x=22.14 \
 //y=5.56 //x2=22.435 //y2=5.2
cc_1712 ( N_QN_c_2059_p N_VDD_M45_noxref_d ) capacitor c=0.0674979f //x=23.02 \
 //y=5.56 //x2=22.435 //y2=5.2
cc_1713 ( N_QN_c_2038_p N_VDD_M47_noxref_d ) capacitor c=0.00700141f \
 //x=23.715 //y=5.335 //x2=23.315 //y2=5.2
cc_1714 ( N_QN_c_2059_p N_VDD_M47_noxref_d ) capacitor c=0.0675002f //x=23.02 \
 //y=5.56 //x2=23.315 //y2=5.2
cc_1715 ( N_QN_c_2062_p N_VDD_M48_noxref_s ) capacitor c=0.00492616f //x=23.02 \
 //y=5.56 //x2=25.495 //y2=5.2
cc_1716 ( N_QN_c_2038_p N_VDD_M48_noxref_s ) capacitor c=9.42705e-19 \
 //x=23.715 //y=5.335 //x2=25.495 //y2=5.2
cc_1717 ( N_QN_c_1977_p N_VDD_M48_noxref_s ) capacitor c=6.14722e-19 //x=25.65 \
 //y=3.655 //x2=25.495 //y2=5.2
cc_1718 ( N_QN_c_1978_p N_VDD_M48_noxref_s ) capacitor c=0.0224586f //x=25.65 \
 //y=4.755 //x2=25.495 //y2=5.2
cc_1719 ( N_QN_c_1962_n N_VDD_M48_noxref_s ) capacitor c=2.11884e-19 //x=22.14 \
 //y=5.335 //x2=25.495 //y2=5.2
cc_1720 ( N_QN_c_1980_p N_VDD_M48_noxref_s ) capacitor c=0.00983413f //x=25.65 \
 //y=4.88 //x2=25.495 //y2=5.2
cc_1721 ( N_QN_M48_noxref_g N_VDD_M48_noxref_s ) capacitor c=0.053419f \
 //x=25.85 //y=6.2 //x2=25.495 //y2=5.2
cc_1722 ( N_QN_c_1992_p N_VDD_M48_noxref_s ) capacitor c=0.00485165f \
 //x=25.925 //y=4.97 //x2=25.495 //y2=5.2
cc_1723 ( N_QN_M49_noxref_g N_VDD_M49_noxref_d ) capacitor c=0.015318f \
 //x=26.29 //y=6.2 //x2=26.365 //y2=5.2
cc_1724 ( N_QN_c_1995_p N_noxref_16_c_4293_n ) capacitor c=0.0036878f \
 //x=23.315 //y=1.305 //x2=23.715 //y2=0.72
cc_1725 ( N_QN_c_2061_p N_noxref_16_c_4293_n ) capacitor c=0.00399931f \
 //x=23.715 //y=1.845 //x2=23.715 //y2=0.72
cc_1726 ( N_QN_M14_noxref_d N_noxref_16_c_4293_n ) capacitor c=0.00910163f \
 //x=23.125 //y=1.095 //x2=23.715 //y2=0.72
cc_1727 ( N_QN_M14_noxref_d N_noxref_16_c_4296_n ) capacitor c=0.00120711f \
 //x=23.125 //y=1.095 //x2=22.83 //y2=1.175
cc_1728 ( N_QN_c_1946_n N_noxref_16_M13_noxref_d ) capacitor c=0.00148104f \
 //x=22.02 //y=5.335 //x2=21.59 //y2=1.09
cc_1729 ( N_QN_c_1995_p N_noxref_16_M13_noxref_d ) capacitor c=0.00802417f \
 //x=23.315 //y=1.305 //x2=21.59 //y2=1.09
cc_1730 ( QN N_noxref_16_M14_noxref_s ) capacitor c=0.0016218f //x=23.8 \
 //y=3.51 //x2=22.695 //y2=0.555
cc_1731 ( N_QN_c_1995_p N_noxref_16_M14_noxref_s ) capacitor c=0.0098487f \
 //x=23.315 //y=1.305 //x2=22.695 //y2=0.555
cc_1732 ( N_QN_c_2092_p N_noxref_16_M14_noxref_s ) capacitor c=0.0283243f \
 //x=23.315 //y=1.76 //x2=22.695 //y2=0.555
cc_1733 ( N_QN_c_2061_p N_noxref_16_M14_noxref_s ) capacitor c=0.00871957f \
 //x=23.715 //y=1.845 //x2=22.695 //y2=0.555
cc_1734 ( N_QN_M14_noxref_d N_noxref_16_M14_noxref_s ) capacitor c=0.0279003f \
 //x=23.125 //y=1.095 //x2=22.695 //y2=0.555
cc_1735 ( N_QN_c_1995_p N_GND_c_4495_n ) capacitor c=0.00901861f //x=23.315 \
 //y=1.305 //x2=25.53 //y2=0.175
cc_1736 ( N_QN_c_2061_p N_GND_c_4495_n ) capacitor c=0.00713708f //x=23.715 \
 //y=1.845 //x2=25.53 //y2=0.175
cc_1737 ( N_QN_c_1997_p N_GND_c_4495_n ) capacitor c=5.00363e-19 //x=23.8 \
 //y=3.655 //x2=25.53 //y2=0.175
cc_1738 ( N_QN_M14_noxref_d N_GND_c_4495_n ) capacitor c=2.9462e-19 //x=23.125 \
 //y=1.095 //x2=25.53 //y2=0.175
cc_1739 ( N_QN_c_2015_p N_GND_c_4504_n ) capacitor c=3.97665e-19 //x=25.35 \
 //y=1.055 //x2=25.615 //y2=1.015
cc_1740 ( N_QN_c_2183_p N_GND_c_4504_n ) capacitor c=0.00864776f //x=25.725 \
 //y=0.9 //x2=25.615 //y2=1.015
cc_1741 ( N_QN_c_2017_p N_GND_c_4504_n ) capacitor c=4.45447e-19 //x=25.88 \
 //y=1.055 //x2=25.615 //y2=1.015
cc_1742 ( N_QN_c_1995_p N_GND_c_4507_n ) capacitor c=0.00543195f //x=23.315 \
 //y=1.305 //x2=25.615 //y2=1.145
cc_1743 ( N_QN_c_1982_p N_GND_c_4507_n ) capacitor c=0.00799365f //x=25.65 \
 //y=2.375 //x2=25.615 //y2=1.145
cc_1744 ( N_QN_c_1977_p N_GND_c_4507_n ) capacitor c=7.98798e-19 //x=25.65 \
 //y=3.655 //x2=25.615 //y2=1.145
cc_1745 ( N_QN_c_1983_p N_GND_c_4507_n ) capacitor c=2.22883e-19 //x=25.65 \
 //y=2.26 //x2=25.615 //y2=1.145
cc_1746 ( N_QN_c_2015_p N_GND_c_4507_n ) capacitor c=0.00156339f //x=25.35 \
 //y=1.055 //x2=25.615 //y2=1.145
cc_1747 ( N_QN_c_2016_p N_GND_c_4507_n ) capacitor c=0.00352472f //x=25.35 \
 //y=1.4 //x2=25.615 //y2=1.145
cc_1748 ( N_QN_c_2018_p N_GND_c_4507_n ) capacitor c=4.25936e-19 //x=25.35 \
 //y=1.71 //x2=25.615 //y2=1.145
cc_1749 ( N_QN_c_2183_p N_GND_c_4507_n ) capacitor c=7.3749e-19 //x=25.725 \
 //y=0.9 //x2=25.615 //y2=1.145
cc_1750 ( N_QN_c_2193_p N_GND_c_4507_n ) capacitor c=5.78478e-19 //x=25.725 \
 //y=1.555 //x2=25.615 //y2=1.145
cc_1751 ( N_QN_c_2017_p N_GND_c_4507_n ) capacitor c=0.00158223f //x=25.88 \
 //y=1.055 //x2=25.615 //y2=1.145
cc_1752 ( N_QN_c_2019_p N_GND_c_4507_n ) capacitor c=0.00276804f //x=25.88 \
 //y=1.4 //x2=25.615 //y2=1.145
cc_1753 ( N_QN_c_2061_p N_GND_c_4474_n ) capacitor c=6.86343e-19 //x=23.715 \
 //y=1.845 //x2=24.37 //y2=0.175
cc_1754 ( N_QN_c_1997_p N_GND_c_4474_n ) capacitor c=4.03806e-19 //x=23.8 \
 //y=3.655 //x2=24.37 //y2=0.175
cc_1755 ( N_QN_c_2015_p N_GND_c_4520_n ) capacitor c=0.00681698f //x=25.35 \
 //y=1.055 //x2=28.61 //y2=0.18
cc_1756 ( QN N_GND_c_4521_n ) capacitor c=0.00821778f //x=25.65 //y=2.4 \
 //x2=24.54 //y2=0.175
cc_1757 ( N_QN_c_2092_p N_GND_c_4521_n ) capacitor c=0.0045138f //x=23.315 \
 //y=1.76 //x2=24.54 //y2=0.175
cc_1758 ( N_QN_c_2061_p N_GND_c_4521_n ) capacitor c=0.0318268f //x=23.715 \
 //y=1.845 //x2=24.54 //y2=0.175
cc_1759 ( N_QN_c_1982_p N_GND_c_4521_n ) capacitor c=0.00407472f //x=25.65 \
 //y=2.375 //x2=24.54 //y2=0.175
cc_1760 ( N_QN_c_2002_p N_GND_c_4521_n ) capacitor c=0.00341388f //x=25.485 \
 //y=3.495 //x2=24.54 //y2=0.175
cc_1761 ( N_QN_c_1983_p N_GND_c_4521_n ) capacitor c=0.00411295f //x=25.65 \
 //y=2.26 //x2=24.54 //y2=0.175
cc_1762 ( N_QN_c_2018_p N_GND_c_4521_n ) capacitor c=0.00170145f //x=25.35 \
 //y=1.71 //x2=24.54 //y2=0.175
cc_1763 ( N_QN_c_1984_p N_GND_c_4521_n ) capacitor c=0.00991898f //x=25.35 \
 //y=2.095 //x2=24.54 //y2=0.175
cc_1764 ( N_QN_c_1982_p N_GND_M15_noxref_d ) capacitor c=4.4417e-19 //x=25.65 \
 //y=2.375 //x2=25.425 //y2=1.055
cc_1765 ( N_QN_c_2015_p N_GND_M15_noxref_d ) capacitor c=0.00184354f //x=25.35 \
 //y=1.055 //x2=25.425 //y2=1.055
cc_1766 ( N_QN_c_2016_p N_GND_M15_noxref_d ) capacitor c=0.00210798f //x=25.35 \
 //y=1.4 //x2=25.425 //y2=1.055
cc_1767 ( N_QN_c_2183_p N_GND_M15_noxref_d ) capacitor c=0.00474029f \
 //x=25.725 //y=0.9 //x2=25.425 //y2=1.055
cc_1768 ( N_QN_c_2193_p N_GND_M15_noxref_d ) capacitor c=0.00166857f \
 //x=25.725 //y=1.555 //x2=25.425 //y2=1.055
cc_1769 ( N_QN_c_2017_p N_GND_M15_noxref_d ) capacitor c=0.00230174f //x=25.88 \
 //y=1.055 //x2=25.425 //y2=1.055
cc_1770 ( N_QN_c_2019_p N_GND_M15_noxref_d ) capacitor c=0.00210798f //x=25.88 \
 //y=1.4 //x2=25.425 //y2=1.055
cc_1771 ( N_QN_c_1995_p N_noxref_18_M16_noxref_d ) capacitor c=3.20746e-19 \
 //x=23.315 //y=1.305 //x2=26.4 //y2=1.09
cc_1772 ( N_QN_c_1984_p N_noxref_24_c_5188_n ) capacitor c=0.00262672f \
 //x=25.35 //y=2.095 //x2=25.13 //y2=1.685
cc_1773 ( N_QN_c_1982_p N_noxref_24_c_5189_n ) capacitor c=0.00411069f \
 //x=25.65 //y=2.375 //x2=26.015 //y2=1.77
cc_1774 ( N_QN_c_1977_p N_noxref_24_c_5189_n ) capacitor c=0.00254914f \
 //x=25.65 //y=3.655 //x2=26.015 //y2=1.77
cc_1775 ( N_QN_c_1983_p N_noxref_24_c_5189_n ) capacitor c=0.0104666f \
 //x=25.65 //y=2.26 //x2=26.015 //y2=1.77
cc_1776 ( N_QN_c_2018_p N_noxref_24_c_5189_n ) capacitor c=0.00705077f \
 //x=25.35 //y=1.71 //x2=26.015 //y2=1.77
cc_1777 ( N_QN_c_1984_p N_noxref_24_c_5189_n ) capacitor c=0.0213095f \
 //x=25.35 //y=2.095 //x2=26.015 //y2=1.77
cc_1778 ( N_QN_c_2193_p N_noxref_24_c_5189_n ) capacitor c=0.00588627f \
 //x=25.725 //y=1.555 //x2=26.015 //y2=1.77
cc_1779 ( N_QN_c_2019_p N_noxref_24_c_5189_n ) capacitor c=0.00698822f \
 //x=25.88 //y=1.4 //x2=26.015 //y2=1.77
cc_1780 ( N_QN_c_2015_p N_noxref_24_M15_noxref_s ) capacitor c=0.0295256f \
 //x=25.35 //y=1.055 //x2=24.995 //y2=0.555
cc_1781 ( N_QN_c_2018_p N_noxref_24_M15_noxref_s ) capacitor c=7.99997e-19 \
 //x=25.35 //y=1.71 //x2=24.995 //y2=0.555
cc_1782 ( N_QN_c_1984_p N_noxref_24_M15_noxref_s ) capacitor c=0.00122123f \
 //x=25.35 //y=2.095 //x2=24.995 //y2=0.555
cc_1783 ( N_QN_c_2017_p N_noxref_24_M15_noxref_s ) capacitor c=0.0125924f \
 //x=25.88 //y=1.055 //x2=24.995 //y2=0.555
cc_1784 ( N_SN_c_2234_n N_noxref_8_c_2617_n ) capacitor c=0.0116288f //x=12.33 \
 //y=2.375 //x2=13.44 //y2=2.375
cc_1785 ( N_SN_c_2279_n N_noxref_8_c_2617_n ) capacitor c=0.0033399f \
 //x=13.795 //y=2.77 //x2=13.44 //y2=2.375
cc_1786 ( N_SN_c_2245_n N_noxref_8_c_2617_n ) capacitor c=5.39999e-19 \
 //x=12.33 //y=2.26 //x2=13.44 //y2=2.375
cc_1787 ( N_SN_c_2264_n N_noxref_8_c_2617_n ) capacitor c=0.00141236f \
 //x=12.42 //y=2.095 //x2=13.44 //y2=2.375
cc_1788 ( SN N_noxref_8_c_2613_n ) capacitor c=0.0290102f //x=12.33 //y=3.14 \
 //x2=13.44 //y2=4.09
cc_1789 ( SN N_noxref_8_c_2613_n ) capacitor c=2.66605e-19 //x=12.33 //y=2.77 \
 //x2=13.44 //y2=4.09
cc_1790 ( N_SN_c_2237_n N_noxref_8_c_2613_n ) capacitor c=0.0061661f //x=12.33 \
 //y=2.615 //x2=13.44 //y2=4.09
cc_1791 ( N_SN_c_2239_n N_noxref_8_c_2613_n ) capacitor c=0.00772613f \
 //x=12.33 //y=2.935 //x2=13.44 //y2=4.09
cc_1792 ( N_SN_c_2279_n N_noxref_8_c_2613_n ) capacitor c=0.0281766f \
 //x=13.795 //y=2.77 //x2=13.44 //y2=4.09
cc_1793 ( N_SN_c_2244_n N_noxref_8_c_2613_n ) capacitor c=0.00232443f \
 //x=12.49 //y=2.775 //x2=13.44 //y2=4.09
cc_1794 ( N_SN_c_2245_n N_noxref_8_c_2613_n ) capacitor c=4.16726e-19 \
 //x=12.33 //y=2.26 //x2=13.44 //y2=4.09
cc_1795 ( SN N_noxref_8_c_2625_n ) capacitor c=0.00774769f //x=12.33 //y=3.14 \
 //x2=13.44 //y2=4.41
cc_1796 ( SN N_noxref_8_c_2615_n ) capacitor c=0.00710041f //x=12.33 //y=3.14 \
 //x2=13.44 //y2=4.75
cc_1797 ( N_SN_c_2240_n N_noxref_8_c_2615_n ) capacitor c=0.0107551f //x=12.33 \
 //y=4.765 //x2=13.44 //y2=4.75
cc_1798 ( N_SN_c_2249_n N_noxref_8_c_2615_n ) capacitor c=9.49821e-19 \
 //x=12.33 //y=4.88 //x2=13.44 //y2=4.75
cc_1799 ( N_SN_c_2267_n N_noxref_8_c_2615_n ) capacitor c=8.42568e-19 \
 //x=12.33 //y=4.88 //x2=13.44 //y2=4.75
cc_1800 ( N_SN_c_2290_n N_noxref_8_c_2856_n ) capacitor c=5.44758e-19 \
 //x=16.245 //y=2.75 //x2=18.505 //y2=1.305
cc_1801 ( N_SN_c_2290_n N_noxref_8_c_2635_n ) capacitor c=0.0145129f \
 //x=16.245 //y=2.75 //x2=18.59 //y2=1.845
cc_1802 ( N_SN_c_2290_n N_noxref_8_c_2705_n ) capacitor c=0.0326543f \
 //x=16.245 //y=2.75 //x2=18.99 //y2=4.09
cc_1803 ( N_SN_c_2344_n N_noxref_8_c_2946_n ) capacitor c=0.0116288f //x=26.76 \
 //y=2.375 //x2=27.87 //y2=2.375
cc_1804 ( N_SN_c_2365_n N_noxref_8_c_2946_n ) capacitor c=5.39999e-19 \
 //x=26.76 //y=2.26 //x2=27.87 //y2=2.375
cc_1805 ( N_SN_c_2385_n N_noxref_8_c_2946_n ) capacitor c=0.00141236f \
 //x=26.85 //y=2.095 //x2=27.87 //y2=2.375
cc_1806 ( SN N_noxref_8_c_2918_n ) capacitor c=0.0337422f //x=26.76 //y=3.14 \
 //x2=27.87 //y2=4.105
cc_1807 ( SN N_noxref_8_c_2918_n ) capacitor c=2.99286e-19 //x=26.76 //y=2.77 \
 //x2=27.87 //y2=4.105
cc_1808 ( N_SN_c_2347_n N_noxref_8_c_2918_n ) capacitor c=0.00605135f \
 //x=26.76 //y=2.61 //x2=27.87 //y2=4.105
cc_1809 ( N_SN_c_2350_n N_noxref_8_c_2918_n ) capacitor c=0.00769355f \
 //x=26.76 //y=2.93 //x2=27.87 //y2=4.105
cc_1810 ( N_SN_c_2290_n N_noxref_8_c_2918_n ) capacitor c=0.00506355f \
 //x=16.245 //y=2.75 //x2=27.87 //y2=4.105
cc_1811 ( N_SN_c_2365_n N_noxref_8_c_2918_n ) capacitor c=4.16726e-19 \
 //x=26.76 //y=2.26 //x2=27.87 //y2=4.105
cc_1812 ( SN N_noxref_8_c_2955_n ) capacitor c=0.00779943f //x=26.76 //y=3.14 \
 //x2=27.87 //y2=4.425
cc_1813 ( SN N_noxref_8_c_2920_n ) capacitor c=0.00935388f //x=26.76 //y=3.14 \
 //x2=27.87 //y2=4.75
cc_1814 ( N_SN_c_2351_n N_noxref_8_c_2920_n ) capacitor c=0.0107551f //x=26.76 \
 //y=4.765 //x2=27.87 //y2=4.75
cc_1815 ( N_SN_c_2369_n N_noxref_8_c_2920_n ) capacitor c=9.52396e-19 \
 //x=26.76 //y=4.88 //x2=27.87 //y2=4.75
cc_1816 ( N_SN_c_2388_n N_noxref_8_c_2920_n ) capacitor c=8.42568e-19 \
 //x=26.76 //y=4.88 //x2=27.87 //y2=4.75
cc_1817 ( SN N_noxref_8_c_2636_n ) capacitor c=3.00997e-19 //x=12.33 //y=3.14 \
 //x2=13.435 //y2=4.25
cc_1818 ( SN N_noxref_8_c_2961_n ) capacitor c=5.01652e-19 //x=26.76 //y=3.14 \
 //x2=27.87 //y2=4.25
cc_1819 ( N_SN_c_2290_n N_noxref_8_c_2642_n ) capacitor c=0.00434024f \
 //x=16.245 //y=2.75 //x2=18.83 //y2=4.25
cc_1820 ( SN N_noxref_8_c_2616_n ) capacitor c=0.0253455f //x=12.33 //y=3.14 \
 //x2=13.595 //y2=4.25
cc_1821 ( SN N_noxref_8_c_2964_n ) capacitor c=0.00242466f //x=26.76 //y=3.14 \
 //x2=27.87 //y2=4.265
cc_1822 ( SN N_noxref_8_c_2800_n ) capacitor c=0.0266373f //x=26.76 //y=3.14 \
 //x2=27.71 //y2=4.265
cc_1823 ( N_SN_c_2351_n N_noxref_8_c_2800_n ) capacitor c=0.00308343f \
 //x=26.76 //y=4.765 //x2=27.71 //y2=4.265
cc_1824 ( N_SN_c_2290_n N_noxref_8_c_2800_n ) capacitor c=0.059551f //x=16.245 \
 //y=2.75 //x2=27.71 //y2=4.265
cc_1825 ( N_SN_c_2234_n N_noxref_8_c_2645_n ) capacitor c=5.42289e-19 \
 //x=12.33 //y=2.375 //x2=13.44 //y2=2.26
cc_1826 ( N_SN_c_2237_n N_noxref_8_c_2645_n ) capacitor c=4.16726e-19 \
 //x=12.33 //y=2.615 //x2=13.44 //y2=2.26
cc_1827 ( N_SN_c_2245_n N_noxref_8_c_2645_n ) capacitor c=0.00125213f \
 //x=12.33 //y=2.26 //x2=13.44 //y2=2.26
cc_1828 ( N_SN_c_2264_n N_noxref_8_c_2645_n ) capacitor c=0.00209664f \
 //x=12.42 //y=2.095 //x2=13.44 //y2=2.26
cc_1829 ( SN N_noxref_8_c_2646_n ) capacitor c=2.94497e-19 //x=12.33 //y=3.14 \
 //x2=13.44 //y2=4.88
cc_1830 ( N_SN_c_2240_n N_noxref_8_c_2646_n ) capacitor c=4.56604e-19 \
 //x=12.33 //y=4.765 //x2=13.44 //y2=4.88
cc_1831 ( N_SN_c_2249_n N_noxref_8_c_2646_n ) capacitor c=0.00113985f \
 //x=12.33 //y=4.88 //x2=13.44 //y2=4.88
cc_1832 ( N_SN_c_2267_n N_noxref_8_c_2646_n ) capacitor c=0.00129812f \
 //x=12.33 //y=4.88 //x2=13.44 //y2=4.88
cc_1833 ( N_SN_c_2344_n N_noxref_8_c_2976_n ) capacitor c=5.42289e-19 \
 //x=26.76 //y=2.375 //x2=27.87 //y2=2.26
cc_1834 ( N_SN_c_2347_n N_noxref_8_c_2976_n ) capacitor c=4.16726e-19 \
 //x=26.76 //y=2.61 //x2=27.87 //y2=2.26
cc_1835 ( N_SN_c_2365_n N_noxref_8_c_2976_n ) capacitor c=0.00125213f \
 //x=26.76 //y=2.26 //x2=27.87 //y2=2.26
cc_1836 ( N_SN_c_2385_n N_noxref_8_c_2976_n ) capacitor c=0.00209664f \
 //x=26.85 //y=2.095 //x2=27.87 //y2=2.26
cc_1837 ( SN N_noxref_8_c_2980_n ) capacitor c=2.94497e-19 //x=26.76 //y=3.14 \
 //x2=27.87 //y2=4.88
cc_1838 ( N_SN_c_2351_n N_noxref_8_c_2980_n ) capacitor c=4.56604e-19 \
 //x=26.76 //y=4.765 //x2=27.87 //y2=4.88
cc_1839 ( N_SN_c_2369_n N_noxref_8_c_2980_n ) capacitor c=0.00113985f \
 //x=26.76 //y=4.88 //x2=27.87 //y2=4.88
cc_1840 ( N_SN_c_2388_n N_noxref_8_c_2980_n ) capacitor c=0.00129812f \
 //x=26.76 //y=4.88 //x2=27.87 //y2=4.88
cc_1841 ( N_SN_M32_noxref_g N_noxref_8_M34_noxref_g ) capacitor c=0.0101598f \
 //x=12.3 //y=6.2 //x2=13.18 //y2=6.2
cc_1842 ( N_SN_M33_noxref_g N_noxref_8_M34_noxref_g ) capacitor c=0.0607518f \
 //x=12.74 //y=6.2 //x2=13.18 //y2=6.2
cc_1843 ( N_SN_M33_noxref_g N_noxref_8_M35_noxref_g ) capacitor c=0.0101598f \
 //x=12.74 //y=6.2 //x2=13.62 //y2=6.2
cc_1844 ( N_SN_M50_noxref_g N_noxref_8_M52_noxref_g ) capacitor c=0.0101598f \
 //x=26.73 //y=6.2 //x2=27.61 //y2=6.2
cc_1845 ( N_SN_M51_noxref_g N_noxref_8_M52_noxref_g ) capacitor c=0.0607518f \
 //x=27.17 //y=6.2 //x2=27.61 //y2=6.2
cc_1846 ( N_SN_M51_noxref_g N_noxref_8_M53_noxref_g ) capacitor c=0.0101598f \
 //x=27.17 //y=6.2 //x2=28.05 //y2=6.2
cc_1847 ( N_SN_c_2261_n N_noxref_8_c_2659_n ) capacitor c=0.00456962f \
 //x=12.42 //y=1.09 //x2=13.43 //y2=1.095
cc_1848 ( N_SN_c_2262_n N_noxref_8_c_2661_n ) capacitor c=0.00438372f \
 //x=12.42 //y=1.4 //x2=13.43 //y2=1.44
cc_1849 ( N_SN_c_2263_n N_noxref_8_c_2664_n ) capacitor c=0.00438372f \
 //x=12.42 //y=1.63 //x2=13.43 //y2=1.75
cc_1850 ( N_SN_c_2382_n N_noxref_8_c_2993_n ) capacitor c=0.00456962f \
 //x=26.85 //y=1.09 //x2=27.86 //y2=1.095
cc_1851 ( N_SN_c_2383_n N_noxref_8_c_2994_n ) capacitor c=0.00438372f \
 //x=26.85 //y=1.4 //x2=27.86 //y2=1.44
cc_1852 ( N_SN_c_2384_n N_noxref_8_c_2995_n ) capacitor c=0.00438372f \
 //x=26.85 //y=1.63 //x2=27.86 //y2=1.75
cc_1853 ( N_SN_c_2234_n N_noxref_8_c_2677_n ) capacitor c=0.00139071f \
 //x=12.33 //y=2.375 //x2=13.44 //y2=2.26
cc_1854 ( N_SN_c_2245_n N_noxref_8_c_2677_n ) capacitor c=0.00204868f \
 //x=12.33 //y=2.26 //x2=13.44 //y2=2.26
cc_1855 ( N_SN_c_2264_n N_noxref_8_c_2677_n ) capacitor c=0.00933826f \
 //x=12.42 //y=2.095 //x2=13.44 //y2=2.26
cc_1856 ( N_SN_c_2264_n N_noxref_8_c_2678_n ) capacitor c=0.00438372f \
 //x=12.42 //y=2.095 //x2=13.44 //y2=2.095
cc_1857 ( N_SN_c_2240_n N_noxref_8_c_2680_n ) capacitor c=0.00124604f \
 //x=12.33 //y=4.765 //x2=13.44 //y2=4.88
cc_1858 ( N_SN_c_2249_n N_noxref_8_c_2680_n ) capacitor c=0.00187046f \
 //x=12.33 //y=4.88 //x2=13.44 //y2=4.88
cc_1859 ( N_SN_c_2302_n N_noxref_8_c_2680_n ) capacitor c=0.0616777f \
 //x=12.665 //y=4.97 //x2=13.44 //y2=4.88
cc_1860 ( N_SN_c_2267_n N_noxref_8_c_2680_n ) capacitor c=0.00487508f \
 //x=12.33 //y=4.88 //x2=13.44 //y2=4.88
cc_1861 ( N_SN_c_2344_n N_noxref_8_c_3004_n ) capacitor c=0.00139071f \
 //x=26.76 //y=2.375 //x2=27.87 //y2=2.26
cc_1862 ( N_SN_c_2365_n N_noxref_8_c_3004_n ) capacitor c=0.00204868f \
 //x=26.76 //y=2.26 //x2=27.87 //y2=2.26
cc_1863 ( N_SN_c_2385_n N_noxref_8_c_3004_n ) capacitor c=0.00933826f \
 //x=26.85 //y=2.095 //x2=27.87 //y2=2.26
cc_1864 ( N_SN_c_2385_n N_noxref_8_c_3007_n ) capacitor c=0.00438372f \
 //x=26.85 //y=2.095 //x2=27.87 //y2=2.095
cc_1865 ( N_SN_c_2351_n N_noxref_8_c_3008_n ) capacitor c=0.00124604f \
 //x=26.76 //y=4.765 //x2=27.87 //y2=4.88
cc_1866 ( N_SN_c_2369_n N_noxref_8_c_3008_n ) capacitor c=0.00187046f \
 //x=26.76 //y=4.88 //x2=27.87 //y2=4.88
cc_1867 ( N_SN_c_2475_p N_noxref_8_c_3008_n ) capacitor c=0.0616777f \
 //x=27.095 //y=4.97 //x2=27.87 //y2=4.88
cc_1868 ( N_SN_c_2388_n N_noxref_8_c_3008_n ) capacitor c=0.00487508f \
 //x=26.76 //y=4.88 //x2=27.87 //y2=4.88
cc_1869 ( N_SN_c_2290_n Q ) capacitor c=0.0299047f //x=16.245 //y=2.75 \
 //x2=23.06 //y2=2.4
cc_1870 ( SN Q ) capacitor c=0.0015874f //x=26.76 //y=3.14 //x2=28.61 //y2=2.4
cc_1871 ( N_SN_c_2347_n Q ) capacitor c=5.84382e-19 //x=26.76 //y=2.61 \
 //x2=28.61 //y2=2.4
cc_1872 ( SN Q ) capacitor c=0.00198403f //x=26.76 //y=3.14 //x2=28.61 //y2=4.25
cc_1873 ( N_SN_c_2290_n N_Q_c_3228_n ) capacitor c=0.00309026f //x=16.245 \
 //y=2.75 //x2=23.06 //y2=2.375
cc_1874 ( N_SN_c_2290_n N_Q_c_3231_n ) capacitor c=0.00287069f //x=16.245 \
 //y=2.75 //x2=23.06 //y2=4.025
cc_1875 ( N_SN_c_2350_n N_Q_c_3275_n ) capacitor c=0.00112572f //x=26.76 \
 //y=2.93 //x2=26.83 //y2=5.335
cc_1876 ( N_SN_c_2351_n N_Q_c_3275_n ) capacitor c=0.0218571f //x=26.76 \
 //y=4.765 //x2=26.83 //y2=5.335
cc_1877 ( N_SN_c_2369_n N_Q_c_3275_n ) capacitor c=0.00492634f //x=26.76 \
 //y=4.88 //x2=26.83 //y2=5.335
cc_1878 ( N_SN_M50_noxref_g N_Q_c_3275_n ) capacitor c=0.00858241f //x=26.73 \
 //y=6.2 //x2=26.83 //y2=5.335
cc_1879 ( N_SN_c_2388_n N_Q_c_3275_n ) capacitor c=6.02516e-19 //x=26.76 \
 //y=4.88 //x2=26.83 //y2=5.335
cc_1880 ( N_SN_M51_noxref_g N_Q_c_3339_n ) capacitor c=0.0103546f //x=27.17 \
 //y=6.2 //x2=27.715 //y2=5.335
cc_1881 ( N_SN_c_2350_n N_Q_c_3340_n ) capacitor c=4.66263e-19 //x=26.76 \
 //y=2.93 //x2=26.95 //y2=5.335
cc_1882 ( N_SN_c_2351_n N_Q_c_3340_n ) capacitor c=0.00244335f //x=26.76 \
 //y=4.765 //x2=26.95 //y2=5.335
cc_1883 ( N_SN_c_2369_n N_Q_c_3340_n ) capacitor c=0.00132214f //x=26.76 \
 //y=4.88 //x2=26.95 //y2=5.335
cc_1884 ( N_SN_M50_noxref_g N_Q_c_3340_n ) capacitor c=0.00229818f //x=26.73 \
 //y=6.2 //x2=26.95 //y2=5.335
cc_1885 ( N_SN_M51_noxref_g N_Q_c_3340_n ) capacitor c=0.00230699f //x=27.17 \
 //y=6.2 //x2=26.95 //y2=5.335
cc_1886 ( N_SN_c_2475_p N_Q_c_3340_n ) capacitor c=0.00177795f //x=27.095 \
 //y=4.97 //x2=26.95 //y2=5.335
cc_1887 ( N_SN_c_2290_n N_Q_c_3221_n ) capacitor c=0.00831863f //x=16.245 \
 //y=2.75 //x2=23.21 //y2=3.865
cc_1888 ( SN N_Q_c_3283_n ) capacitor c=0.0275143f //x=26.76 //y=3.14 \
 //x2=28.445 //y2=3.875
cc_1889 ( N_SN_c_2350_n N_Q_c_3283_n ) capacitor c=0.00256007f //x=26.76 \
 //y=2.93 //x2=28.445 //y2=3.875
cc_1890 ( N_SN_c_2290_n N_Q_c_3283_n ) capacitor c=0.0564156f //x=16.245 \
 //y=2.75 //x2=28.445 //y2=3.875
cc_1891 ( N_SN_c_2351_n N_Q_c_3350_n ) capacitor c=6.21282e-19 //x=26.76 \
 //y=4.765 //x2=26.95 //y2=5.56
cc_1892 ( N_SN_M50_noxref_g N_Q_c_3350_n ) capacitor c=0.0179041f //x=26.73 \
 //y=6.2 //x2=26.95 //y2=5.56
cc_1893 ( N_SN_M51_noxref_g N_Q_c_3350_n ) capacitor c=0.0179041f //x=27.17 \
 //y=6.2 //x2=26.95 //y2=5.56
cc_1894 ( N_SN_c_2475_p N_Q_c_3350_n ) capacitor c=0.00290085f //x=27.095 \
 //y=4.97 //x2=26.95 //y2=5.56
cc_1895 ( N_SN_M32_noxref_g N_VDD_c_3576_n ) capacitor c=0.00705252f //x=12.3 \
 //y=6.2 //x2=12.875 //y2=7.585
cc_1896 ( N_SN_M33_noxref_g N_VDD_c_3576_n ) capacitor c=0.00755544f //x=12.74 \
 //y=6.2 //x2=12.875 //y2=7.585
cc_1897 ( N_SN_M50_noxref_g N_VDD_c_3763_n ) capacitor c=0.00705252f //x=26.73 \
 //y=6.2 //x2=27.305 //y2=7.585
cc_1898 ( N_SN_M51_noxref_g N_VDD_c_3763_n ) capacitor c=0.00755544f //x=27.17 \
 //y=6.2 //x2=27.305 //y2=7.585
cc_1899 ( N_SN_M32_noxref_g N_VDD_M31_noxref_d ) capacitor c=0.015318f \
 //x=12.3 //y=6.2 //x2=11.935 //y2=5.2
cc_1900 ( N_SN_M33_noxref_g N_VDD_M33_noxref_d ) capacitor c=0.015318f \
 //x=12.74 //y=6.2 //x2=12.815 //y2=5.2
cc_1901 ( N_SN_M50_noxref_g N_VDD_M49_noxref_d ) capacitor c=0.015318f \
 //x=26.73 //y=6.2 //x2=26.365 //y2=5.2
cc_1902 ( N_SN_M51_noxref_g N_VDD_M51_noxref_d ) capacitor c=0.015318f \
 //x=27.17 //y=6.2 //x2=27.245 //y2=5.2
cc_1903 ( N_SN_c_2279_n N_noxref_14_c_4147_n ) capacitor c=0.00528251f \
 //x=13.795 //y=2.77 //x2=13.125 //y2=1.175
cc_1904 ( N_SN_c_2261_n N_noxref_14_c_4147_n ) capacitor c=0.00123426f \
 //x=12.42 //y=1.09 //x2=13.125 //y2=1.175
cc_1905 ( N_SN_c_2262_n N_noxref_14_c_4147_n ) capacitor c=0.0129288f \
 //x=12.42 //y=1.4 //x2=13.125 //y2=1.175
cc_1906 ( N_SN_c_2263_n N_noxref_14_c_4147_n ) capacitor c=0.00132209f \
 //x=12.42 //y=1.63 //x2=13.125 //y2=1.175
cc_1907 ( N_SN_c_2279_n N_noxref_14_c_4135_n ) capacitor c=2.95739e-19 \
 //x=13.795 //y=2.77 //x2=14.095 //y2=0.72
cc_1908 ( N_SN_c_2234_n N_noxref_14_M7_noxref_d ) capacitor c=0.00603521f \
 //x=12.33 //y=2.375 //x2=11.97 //y2=1.09
cc_1909 ( N_SN_c_2239_n N_noxref_14_M7_noxref_d ) capacitor c=2.76459e-19 \
 //x=12.33 //y=2.935 //x2=11.97 //y2=1.09
cc_1910 ( N_SN_c_2244_n N_noxref_14_M7_noxref_d ) capacitor c=9.01305e-19 \
 //x=12.49 //y=2.775 //x2=11.97 //y2=1.09
cc_1911 ( N_SN_c_2245_n N_noxref_14_M7_noxref_d ) capacitor c=2.2052e-19 \
 //x=12.33 //y=2.26 //x2=11.97 //y2=1.09
cc_1912 ( N_SN_c_2256_n N_noxref_14_M7_noxref_d ) capacitor c=0.00253592f \
 //x=11.895 //y=1.09 //x2=11.97 //y2=1.09
cc_1913 ( N_SN_c_2259_n N_noxref_14_M7_noxref_d ) capacitor c=0.00604087f \
 //x=11.895 //y=1.4 //x2=11.97 //y2=1.09
cc_1914 ( N_SN_c_2522_p N_noxref_14_M7_noxref_d ) capacitor c=0.002686f \
 //x=12.265 //y=0.935 //x2=11.97 //y2=1.09
cc_1915 ( N_SN_c_2523_p N_noxref_14_M7_noxref_d ) capacitor c=0.00251995f \
 //x=12.265 //y=1.555 //x2=11.97 //y2=1.09
cc_1916 ( N_SN_c_2261_n N_noxref_14_M7_noxref_d ) capacitor c=0.00314523f \
 //x=12.42 //y=1.09 //x2=11.97 //y2=1.09
cc_1917 ( N_SN_c_2262_n N_noxref_14_M7_noxref_d ) capacitor c=0.00168289f \
 //x=12.42 //y=1.4 //x2=11.97 //y2=1.09
cc_1918 ( N_SN_c_2263_n N_noxref_14_M7_noxref_d ) capacitor c=0.00111165f \
 //x=12.42 //y=1.63 //x2=11.97 //y2=1.09
cc_1919 ( N_SN_c_2279_n N_noxref_14_M8_noxref_s ) capacitor c=0.00359935f \
 //x=13.795 //y=2.77 //x2=13.075 //y2=0.555
cc_1920 ( N_SN_c_2261_n N_noxref_14_M8_noxref_s ) capacitor c=7.21316e-19 \
 //x=12.42 //y=1.09 //x2=13.075 //y2=0.555
cc_1921 ( N_SN_c_2262_n N_noxref_14_M8_noxref_s ) capacitor c=0.00365271f \
 //x=12.42 //y=1.4 //x2=13.075 //y2=0.555
cc_1922 ( N_SN_c_2264_n N_noxref_14_M8_noxref_s ) capacitor c=9.86711e-19 \
 //x=12.42 //y=2.095 //x2=13.075 //y2=0.555
cc_1923 ( N_SN_c_2290_n N_noxref_15_c_4208_n ) capacitor c=0.00528251f \
 //x=16.245 //y=2.75 //x2=17.935 //y2=1.175
cc_1924 ( N_SN_c_2290_n N_noxref_15_c_4224_n ) capacitor c=2.35517e-19 \
 //x=16.245 //y=2.75 //x2=18.905 //y2=0.72
cc_1925 ( N_SN_c_2290_n N_noxref_15_M10_noxref_d ) capacitor c=0.00517344f \
 //x=16.245 //y=2.75 //x2=16.78 //y2=1.09
cc_1926 ( N_SN_c_2290_n N_noxref_15_M11_noxref_s ) capacitor c=0.00374095f \
 //x=16.245 //y=2.75 //x2=17.885 //y2=0.555
cc_1927 ( N_SN_c_2290_n N_noxref_16_c_4278_n ) capacitor c=0.00528251f \
 //x=16.245 //y=2.75 //x2=22.745 //y2=1.175
cc_1928 ( N_SN_c_2290_n N_noxref_16_c_4293_n ) capacitor c=2.88753e-19 \
 //x=16.245 //y=2.75 //x2=23.715 //y2=0.72
cc_1929 ( N_SN_c_2290_n N_noxref_16_M13_noxref_d ) capacitor c=0.00583909f \
 //x=16.245 //y=2.75 //x2=21.59 //y2=1.09
cc_1930 ( N_SN_c_2290_n N_noxref_16_M14_noxref_s ) capacitor c=0.00353806f \
 //x=16.245 //y=2.75 //x2=22.695 //y2=0.555
cc_1931 ( N_SN_c_2234_n N_GND_c_4414_n ) capacitor c=9.16602e-19 //x=12.33 \
 //y=2.375 //x2=15.91 //y2=0.175
cc_1932 ( N_SN_c_2239_n N_GND_c_4414_n ) capacitor c=3.78675e-19 //x=12.33 \
 //y=2.935 //x2=15.91 //y2=0.175
cc_1933 ( N_SN_c_2344_n N_GND_c_4538_n ) capacitor c=9.16602e-19 //x=26.76 \
 //y=2.375 //x2=28.61 //y2=0.18
cc_1934 ( N_SN_c_2290_n N_GND_c_4421_n ) capacitor c=0.00358941f //x=16.245 \
 //y=2.75 //x2=15.995 //y2=1.145
cc_1935 ( N_SN_c_2290_n N_GND_c_4462_n ) capacitor c=0.00362792f //x=16.245 \
 //y=2.75 //x2=20.805 //y2=1.145
cc_1936 ( N_SN_c_2290_n N_GND_c_4507_n ) capacitor c=0.00349575f //x=16.245 \
 //y=2.75 //x2=25.615 //y2=1.145
cc_1937 ( SN N_GND_c_4520_n ) capacitor c=0.00139524f //x=26.76 //y=2.77 \
 //x2=28.61 //y2=0.18
cc_1938 ( SN N_GND_c_4394_n ) capacitor c=0.00182567f //x=12.33 //y=2.77 \
 //x2=10.11 //y2=0.175
cc_1939 ( SN N_GND_c_4435_n ) capacitor c=8.89265e-19 //x=12.33 //y=2.77 \
 //x2=14.92 //y2=0.175
cc_1940 ( N_SN_c_2283_n N_GND_c_4435_n ) capacitor c=3.3758e-19 //x=14.395 \
 //y=2.755 //x2=14.92 //y2=0.175
cc_1941 ( N_SN_c_2287_n N_GND_c_4435_n ) capacitor c=0.0233701f //x=15.645 \
 //y=2.77 //x2=14.92 //y2=0.175
cc_1942 ( N_SN_c_2290_n N_GND_c_4480_n ) capacitor c=0.0247466f //x=16.245 \
 //y=2.75 //x2=19.73 //y2=0.175
cc_1943 ( SN N_GND_c_4521_n ) capacitor c=0.00124714f //x=26.76 //y=2.77 \
 //x2=24.54 //y2=0.175
cc_1944 ( N_SN_c_2290_n N_GND_c_4521_n ) capacitor c=0.0238314f //x=16.245 \
 //y=2.75 //x2=24.54 //y2=0.175
cc_1945 ( N_SN_c_2382_n N_noxref_18_c_4834_n ) capacitor c=0.00123426f \
 //x=26.85 //y=1.09 //x2=27.555 //y2=1.175
cc_1946 ( N_SN_c_2383_n N_noxref_18_c_4834_n ) capacitor c=0.0129288f \
 //x=26.85 //y=1.4 //x2=27.555 //y2=1.175
cc_1947 ( N_SN_c_2384_n N_noxref_18_c_4834_n ) capacitor c=0.00132209f \
 //x=26.85 //y=1.63 //x2=27.555 //y2=1.175
cc_1948 ( N_SN_c_2344_n N_noxref_18_M16_noxref_d ) capacitor c=0.00603481f \
 //x=26.76 //y=2.375 //x2=26.4 //y2=1.09
cc_1949 ( N_SN_c_2350_n N_noxref_18_M16_noxref_d ) capacitor c=9.05471e-19 \
 //x=26.76 //y=2.93 //x2=26.4 //y2=1.09
cc_1950 ( N_SN_c_2290_n N_noxref_18_M16_noxref_d ) capacitor c=0.00396064f \
 //x=16.245 //y=2.75 //x2=26.4 //y2=1.09
cc_1951 ( N_SN_c_2365_n N_noxref_18_M16_noxref_d ) capacitor c=2.2052e-19 \
 //x=26.76 //y=2.26 //x2=26.4 //y2=1.09
cc_1952 ( N_SN_c_2377_n N_noxref_18_M16_noxref_d ) capacitor c=0.00253592f \
 //x=26.325 //y=1.09 //x2=26.4 //y2=1.09
cc_1953 ( N_SN_c_2380_n N_noxref_18_M16_noxref_d ) capacitor c=0.00604087f \
 //x=26.325 //y=1.4 //x2=26.4 //y2=1.09
cc_1954 ( N_SN_c_2562_p N_noxref_18_M16_noxref_d ) capacitor c=0.002686f \
 //x=26.695 //y=0.935 //x2=26.4 //y2=1.09
cc_1955 ( N_SN_c_2563_p N_noxref_18_M16_noxref_d ) capacitor c=0.00248048f \
 //x=26.695 //y=1.555 //x2=26.4 //y2=1.09
cc_1956 ( N_SN_c_2382_n N_noxref_18_M16_noxref_d ) capacitor c=0.00314523f \
 //x=26.85 //y=1.09 //x2=26.4 //y2=1.09
cc_1957 ( N_SN_c_2383_n N_noxref_18_M16_noxref_d ) capacitor c=0.00168289f \
 //x=26.85 //y=1.4 //x2=26.4 //y2=1.09
cc_1958 ( N_SN_c_2384_n N_noxref_18_M16_noxref_d ) capacitor c=0.00111165f \
 //x=26.85 //y=1.63 //x2=26.4 //y2=1.09
cc_1959 ( N_SN_c_2382_n N_noxref_18_M17_noxref_s ) capacitor c=7.21316e-19 \
 //x=26.85 //y=1.09 //x2=27.505 //y2=0.555
cc_1960 ( N_SN_c_2383_n N_noxref_18_M17_noxref_s ) capacitor c=0.00365271f \
 //x=26.85 //y=1.4 //x2=27.505 //y2=0.555
cc_1961 ( N_SN_c_2385_n N_noxref_18_M17_noxref_s ) capacitor c=9.86711e-19 \
 //x=26.85 //y=2.095 //x2=27.505 //y2=0.555
cc_1962 ( N_SN_c_2256_n N_noxref_21_c_5027_n ) capacitor c=0.0167228f \
 //x=11.895 //y=1.09 //x2=12.555 //y2=0.72
cc_1963 ( N_SN_c_2261_n N_noxref_21_c_5027_n ) capacitor c=0.00534519f \
 //x=12.42 //y=1.09 //x2=12.555 //y2=0.72
cc_1964 ( N_SN_c_2234_n N_noxref_21_c_5025_n ) capacitor c=0.0048147f \
 //x=12.33 //y=2.375 //x2=12.555 //y2=1.77
cc_1965 ( N_SN_c_2239_n N_noxref_21_c_5025_n ) capacitor c=0.0032522f \
 //x=12.33 //y=2.935 //x2=12.555 //y2=1.77
cc_1966 ( N_SN_c_2245_n N_noxref_21_c_5025_n ) capacitor c=0.0105652f \
 //x=12.33 //y=2.26 //x2=12.555 //y2=1.77
cc_1967 ( N_SN_c_2259_n N_noxref_21_c_5025_n ) capacitor c=0.0153476f \
 //x=11.895 //y=1.4 //x2=12.555 //y2=1.77
cc_1968 ( N_SN_c_2264_n N_noxref_21_c_5025_n ) capacitor c=0.0197749f \
 //x=12.42 //y=2.095 //x2=12.555 //y2=1.77
cc_1969 ( N_SN_c_2239_n N_noxref_21_M6_noxref_s ) capacitor c=8.07677e-19 \
 //x=12.33 //y=2.935 //x2=10.565 //y2=0.555
cc_1970 ( N_SN_c_2279_n N_noxref_21_M6_noxref_s ) capacitor c=0.0024662f \
 //x=13.795 //y=2.77 //x2=10.565 //y2=0.555
cc_1971 ( N_SN_c_2256_n N_noxref_21_M6_noxref_s ) capacitor c=0.00798959f \
 //x=11.895 //y=1.09 //x2=10.565 //y2=0.555
cc_1972 ( N_SN_c_2263_n N_noxref_21_M6_noxref_s ) capacitor c=0.00212176f \
 //x=12.42 //y=1.63 //x2=10.565 //y2=0.555
cc_1973 ( N_SN_c_2264_n N_noxref_21_M6_noxref_s ) capacitor c=0.00298115f \
 //x=12.42 //y=2.095 //x2=10.565 //y2=0.555
cc_1974 ( N_SN_c_2287_n N_noxref_22_c_5071_n ) capacitor c=0.00375801f \
 //x=15.645 //y=2.77 //x2=15.51 //y2=1.685
cc_1975 ( N_SN_c_2287_n N_noxref_22_c_5072_n ) capacitor c=0.010092f \
 //x=15.645 //y=2.77 //x2=16.395 //y2=1.77
cc_1976 ( N_SN_c_2290_n N_noxref_22_c_5072_n ) capacitor c=0.00136156f \
 //x=16.245 //y=2.75 //x2=16.395 //y2=1.77
cc_1977 ( N_SN_c_2290_n N_noxref_22_c_5085_n ) capacitor c=0.010287f \
 //x=16.245 //y=2.75 //x2=17.365 //y2=1.77
cc_1978 ( N_SN_c_2290_n N_noxref_22_M9_noxref_s ) capacitor c=0.00698304f \
 //x=16.245 //y=2.75 //x2=15.375 //y2=0.555
cc_1979 ( N_SN_c_2290_n N_noxref_23_c_5130_n ) capacitor c=0.00375801f \
 //x=16.245 //y=2.75 //x2=20.32 //y2=1.685
cc_1980 ( N_SN_c_2290_n N_noxref_23_c_5131_n ) capacitor c=0.0118184f \
 //x=16.245 //y=2.75 //x2=21.205 //y2=1.77
cc_1981 ( N_SN_c_2290_n N_noxref_23_c_5144_n ) capacitor c=0.00983165f \
 //x=16.245 //y=2.75 //x2=22.175 //y2=1.77
cc_1982 ( N_SN_c_2290_n N_noxref_23_M12_noxref_s ) capacitor c=0.00659617f \
 //x=16.245 //y=2.75 //x2=20.185 //y2=0.555
cc_1983 ( N_SN_c_2290_n N_noxref_24_c_5188_n ) capacitor c=0.00375801f \
 //x=16.245 //y=2.75 //x2=25.13 //y2=1.685
cc_1984 ( N_SN_c_2290_n N_noxref_24_c_5189_n ) capacitor c=0.0118656f \
 //x=16.245 //y=2.75 //x2=26.015 //y2=1.77
cc_1985 ( N_SN_c_2377_n N_noxref_24_c_5202_n ) capacitor c=0.0167228f \
 //x=26.325 //y=1.09 //x2=26.985 //y2=0.72
cc_1986 ( N_SN_c_2382_n N_noxref_24_c_5202_n ) capacitor c=0.00534519f \
 //x=26.85 //y=1.09 //x2=26.985 //y2=0.72
cc_1987 ( N_SN_c_2344_n N_noxref_24_c_5204_n ) capacitor c=0.0048147f \
 //x=26.76 //y=2.375 //x2=26.985 //y2=1.77
cc_1988 ( N_SN_c_2350_n N_noxref_24_c_5204_n ) capacitor c=0.00362827f \
 //x=26.76 //y=2.93 //x2=26.985 //y2=1.77
cc_1989 ( N_SN_c_2290_n N_noxref_24_c_5204_n ) capacitor c=0.00525615f \
 //x=16.245 //y=2.75 //x2=26.985 //y2=1.77
cc_1990 ( N_SN_c_2365_n N_noxref_24_c_5204_n ) capacitor c=0.0105652f \
 //x=26.76 //y=2.26 //x2=26.985 //y2=1.77
cc_1991 ( N_SN_c_2380_n N_noxref_24_c_5204_n ) capacitor c=0.0153476f \
 //x=26.325 //y=1.4 //x2=26.985 //y2=1.77
cc_1992 ( N_SN_c_2385_n N_noxref_24_c_5204_n ) capacitor c=0.0199119f \
 //x=26.85 //y=2.095 //x2=26.985 //y2=1.77
cc_1993 ( N_SN_c_2290_n N_noxref_24_M15_noxref_s ) capacitor c=0.00375801f \
 //x=16.245 //y=2.75 //x2=24.995 //y2=0.555
cc_1994 ( N_SN_c_2377_n N_noxref_24_M15_noxref_s ) capacitor c=0.00798959f \
 //x=26.325 //y=1.09 //x2=24.995 //y2=0.555
cc_1995 ( N_SN_c_2384_n N_noxref_24_M15_noxref_s ) capacitor c=0.00212176f \
 //x=26.85 //y=1.63 //x2=24.995 //y2=0.555
cc_1996 ( N_SN_c_2385_n N_noxref_24_M15_noxref_s ) capacitor c=0.00298115f \
 //x=26.85 //y=2.095 //x2=24.995 //y2=0.555
cc_1997 ( N_noxref_8_c_2800_n Q ) capacitor c=0.0252026f //x=27.71 //y=4.265 \
 //x2=23.06 //y2=4.62
cc_1998 ( N_noxref_8_c_2946_n Q ) capacitor c=0.0154269f //x=27.87 //y=2.375 \
 //x2=28.61 //y2=2.4
cc_1999 ( N_noxref_8_c_2918_n Q ) capacitor c=0.0616967f //x=27.87 //y=4.105 \
 //x2=28.61 //y2=2.4
cc_2000 ( N_noxref_8_c_2976_n Q ) capacitor c=0.00467849f //x=27.87 //y=2.26 \
 //x2=28.61 //y2=2.4
cc_2001 ( N_noxref_8_c_3004_n Q ) capacitor c=0.0025845f //x=27.87 //y=2.26 \
 //x2=28.61 //y2=2.4
cc_2002 ( N_noxref_8_c_3007_n Q ) capacitor c=0.00282067f //x=27.87 //y=2.095 \
 //x2=28.61 //y2=2.4
cc_2003 ( N_noxref_8_c_2918_n Q ) capacitor c=0.00308208f //x=27.87 //y=4.105 \
 //x2=28.61 //y2=4.25
cc_2004 ( N_noxref_8_c_2955_n Q ) capacitor c=0.0151883f //x=27.87 //y=4.425 \
 //x2=28.61 //y2=4.25
cc_2005 ( N_noxref_8_c_2920_n Q ) capacitor c=0.030192f //x=27.87 //y=4.75 \
 //x2=28.61 //y2=4.25
cc_2006 ( N_noxref_8_c_2961_n Q ) capacitor c=0.00474526f //x=27.87 //y=4.25 \
 //x2=28.61 //y2=4.25
cc_2007 ( N_noxref_8_c_2964_n Q ) capacitor c=0.00686827f //x=27.87 //y=4.265 \
 //x2=28.61 //y2=4.25
cc_2008 ( N_noxref_8_c_2980_n Q ) capacitor c=0.00442006f //x=27.87 //y=4.88 \
 //x2=28.61 //y2=4.25
cc_2009 ( N_noxref_8_c_3008_n Q ) capacitor c=0.00739875f //x=27.87 //y=4.88 \
 //x2=28.61 //y2=4.25
cc_2010 ( N_noxref_8_c_2918_n Q ) capacitor c=6.89957e-19 //x=27.87 //y=4.105 \
 //x2=28.61 //y2=3.88
cc_2011 ( N_noxref_8_c_2800_n N_Q_c_3231_n ) capacitor c=0.00545552f //x=27.71 \
 //y=4.265 //x2=23.06 //y2=4.025
cc_2012 ( N_noxref_8_c_2800_n N_Q_c_3232_n ) capacitor c=0.00234144f //x=27.71 \
 //y=4.265 //x2=23.06 //y2=4.75
cc_2013 ( N_noxref_8_c_2955_n N_Q_c_3339_n ) capacitor c=0.00306887f //x=27.87 \
 //y=4.425 //x2=27.715 //y2=5.335
cc_2014 ( N_noxref_8_c_2964_n N_Q_c_3339_n ) capacitor c=7.63373e-19 //x=27.87 \
 //y=4.265 //x2=27.715 //y2=5.335
cc_2015 ( N_noxref_8_c_2800_n N_Q_c_3339_n ) capacitor c=0.0022026f //x=27.71 \
 //y=4.265 //x2=27.715 //y2=5.335
cc_2016 ( N_noxref_8_M52_noxref_g N_Q_c_3339_n ) capacitor c=0.00979706f \
 //x=27.61 //y=6.2 //x2=27.715 //y2=5.335
cc_2017 ( N_noxref_8_M52_noxref_g N_Q_c_3374_n ) capacitor c=0.00226521f \
 //x=27.61 //y=6.2 //x2=27.83 //y2=5.56
cc_2018 ( N_noxref_8_M53_noxref_g N_Q_c_3374_n ) capacitor c=0.00427254f \
 //x=28.05 //y=6.2 //x2=27.83 //y2=5.56
cc_2019 ( N_noxref_8_c_2955_n N_Q_c_3376_n ) capacitor c=9.32766e-19 //x=27.87 \
 //y=4.425 //x2=28.525 //y2=5.335
cc_2020 ( N_noxref_8_c_2920_n N_Q_c_3376_n ) capacitor c=0.00233888f //x=27.87 \
 //y=4.75 //x2=28.525 //y2=5.335
cc_2021 ( N_noxref_8_c_2964_n N_Q_c_3376_n ) capacitor c=0.00104327f //x=27.87 \
 //y=4.265 //x2=28.525 //y2=5.335
cc_2022 ( N_noxref_8_c_2980_n N_Q_c_3376_n ) capacitor c=0.00130631f //x=27.87 \
 //y=4.88 //x2=28.525 //y2=5.335
cc_2023 ( N_noxref_8_M53_noxref_g N_Q_c_3376_n ) capacitor c=0.0112231f \
 //x=28.05 //y=6.2 //x2=28.525 //y2=5.335
cc_2024 ( N_noxref_8_c_2993_n N_Q_c_3381_n ) capacitor c=4.64015e-19 //x=27.86 \
 //y=1.095 //x2=28.125 //y2=1.305
cc_2025 ( N_noxref_8_c_2994_n N_Q_c_3381_n ) capacitor c=0.0026012f //x=27.86 \
 //y=1.44 //x2=28.125 //y2=1.305
cc_2026 ( N_noxref_8_c_3041_p N_Q_c_3381_n ) capacitor c=5.29969e-19 \
 //x=28.235 //y=0.94 //x2=28.125 //y2=1.305
cc_2027 ( N_noxref_8_c_3042_p N_Q_c_3381_n ) capacitor c=5.39985e-19 \
 //x=28.235 //y=1.595 //x2=28.125 //y2=1.305
cc_2028 ( N_noxref_8_c_3043_p N_Q_c_3381_n ) capacitor c=5.7502e-19 //x=28.39 \
 //y=1.095 //x2=28.125 //y2=1.305
cc_2029 ( N_noxref_8_c_3044_p N_Q_c_3381_n ) capacitor c=0.00357756f //x=28.39 \
 //y=1.44 //x2=28.125 //y2=1.305
cc_2030 ( N_noxref_8_c_2994_n N_Q_c_3387_n ) capacitor c=0.00127432f //x=27.86 \
 //y=1.44 //x2=28.125 //y2=1.76
cc_2031 ( N_noxref_8_c_2995_n N_Q_c_3387_n ) capacitor c=0.00429966f //x=27.86 \
 //y=1.75 //x2=28.125 //y2=1.76
cc_2032 ( N_noxref_8_c_3042_p N_Q_c_3387_n ) capacitor c=0.00942306f \
 //x=28.235 //y=1.595 //x2=28.125 //y2=1.76
cc_2033 ( N_noxref_8_c_3044_p N_Q_c_3387_n ) capacitor c=0.00363411f //x=28.39 \
 //y=1.44 //x2=28.125 //y2=1.76
cc_2034 ( N_noxref_8_c_3007_n N_Q_c_3387_n ) capacitor c=0.0036273f //x=27.87 \
 //y=2.095 //x2=28.125 //y2=1.76
cc_2035 ( N_noxref_8_c_3042_p N_Q_c_3392_n ) capacitor c=0.00194716f \
 //x=28.235 //y=1.595 //x2=28.525 //y2=1.845
cc_2036 ( N_noxref_8_c_3044_p N_Q_c_3392_n ) capacitor c=0.00323576f //x=28.39 \
 //y=1.44 //x2=28.525 //y2=1.845
cc_2037 ( N_noxref_8_c_2918_n N_Q_c_3394_n ) capacitor c=0.0177385f //x=27.87 \
 //y=4.105 //x2=28.61 //y2=4.035
cc_2038 ( N_noxref_8_c_2800_n N_Q_c_3277_n ) capacitor c=0.022635f //x=27.71 \
 //y=4.265 //x2=26.072 //y2=5.335
cc_2039 ( N_noxref_8_c_2800_n N_Q_c_3340_n ) capacitor c=0.0255345f //x=27.71 \
 //y=4.265 //x2=26.95 //y2=5.335
cc_2040 ( N_noxref_8_c_2920_n N_Q_c_3397_n ) capacitor c=0.0231851f //x=27.87 \
 //y=4.75 //x2=27.83 //y2=5.335
cc_2041 ( N_noxref_8_c_2980_n N_Q_c_3397_n ) capacitor c=0.00346456f //x=27.87 \
 //y=4.88 //x2=27.83 //y2=5.335
cc_2042 ( N_noxref_8_c_3008_n N_Q_c_3397_n ) capacitor c=0.00203307f //x=27.87 \
 //y=4.88 //x2=27.83 //y2=5.335
cc_2043 ( N_noxref_8_c_2800_n N_Q_c_3221_n ) capacitor c=0.0365231f //x=27.71 \
 //y=4.265 //x2=23.21 //y2=3.865
cc_2044 ( N_noxref_8_c_2918_n N_Q_c_3401_n ) capacitor c=0.00328982f //x=27.87 \
 //y=4.105 //x2=28.605 //y2=3.875
cc_2045 ( N_noxref_8_c_2946_n N_Q_c_3283_n ) capacitor c=0.00144315f //x=27.87 \
 //y=2.375 //x2=28.445 //y2=3.875
cc_2046 ( N_noxref_8_c_2918_n N_Q_c_3283_n ) capacitor c=0.0258911f //x=27.87 \
 //y=4.105 //x2=28.445 //y2=3.875
cc_2047 ( N_noxref_8_c_2955_n N_Q_c_3283_n ) capacitor c=0.0066225f //x=27.87 \
 //y=4.425 //x2=28.445 //y2=3.875
cc_2048 ( N_noxref_8_c_2964_n N_Q_c_3283_n ) capacitor c=0.0374977f //x=27.87 \
 //y=4.265 //x2=28.445 //y2=3.875
cc_2049 ( N_noxref_8_c_2800_n N_Q_c_3283_n ) capacitor c=0.409055f //x=27.71 \
 //y=4.265 //x2=28.445 //y2=3.875
cc_2050 ( N_noxref_8_c_2955_n N_Q_c_3407_n ) capacitor c=2.37554e-19 //x=27.87 \
 //y=4.425 //x2=27.83 //y2=5.56
cc_2051 ( N_noxref_8_c_2920_n N_Q_c_3407_n ) capacitor c=0.00217653f //x=27.87 \
 //y=4.75 //x2=27.83 //y2=5.56
cc_2052 ( N_noxref_8_c_2980_n N_Q_c_3407_n ) capacitor c=0.00552343f //x=27.87 \
 //y=4.88 //x2=27.83 //y2=5.56
cc_2053 ( N_noxref_8_M52_noxref_g N_Q_c_3407_n ) capacitor c=0.0178885f \
 //x=27.61 //y=6.2 //x2=27.83 //y2=5.56
cc_2054 ( N_noxref_8_M53_noxref_g N_Q_c_3407_n ) capacitor c=0.0188608f \
 //x=28.05 //y=6.2 //x2=27.83 //y2=5.56
cc_2055 ( N_noxref_8_c_3008_n N_Q_c_3407_n ) capacitor c=0.00375636f //x=27.87 \
 //y=4.88 //x2=27.83 //y2=5.56
cc_2056 ( N_noxref_8_c_2993_n N_Q_M17_noxref_d ) capacitor c=0.00137165f \
 //x=27.86 //y=1.095 //x2=27.935 //y2=1.095
cc_2057 ( N_noxref_8_c_2994_n N_Q_M17_noxref_d ) capacitor c=0.00237422f \
 //x=27.86 //y=1.44 //x2=27.935 //y2=1.095
cc_2058 ( N_noxref_8_c_3041_p N_Q_M17_noxref_d ) capacitor c=0.0020782f \
 //x=28.235 //y=0.94 //x2=27.935 //y2=1.095
cc_2059 ( N_noxref_8_c_3042_p N_Q_M17_noxref_d ) capacitor c=0.00356097f \
 //x=28.235 //y=1.595 //x2=27.935 //y2=1.095
cc_2060 ( N_noxref_8_c_3043_p N_Q_M17_noxref_d ) capacitor c=0.00139206f \
 //x=28.39 //y=1.095 //x2=27.935 //y2=1.095
cc_2061 ( N_noxref_8_c_3044_p N_Q_M17_noxref_d ) capacitor c=0.00237422f \
 //x=28.39 //y=1.44 //x2=27.935 //y2=1.095
cc_2062 ( N_noxref_8_c_2634_n N_VDD_c_3497_n ) capacitor c=0.00621329f \
 //x=17.21 //y=5.335 //x2=28.61 //y2=7.58
cc_2063 ( N_noxref_8_c_2704_n N_VDD_c_3497_n ) capacitor c=0.00627191f \
 //x=18.095 //y=5.335 //x2=28.61 //y2=7.58
cc_2064 ( N_noxref_8_c_2850_n N_VDD_c_3497_n ) capacitor c=0.00256019f \
 //x=18.21 //y=5.56 //x2=28.61 //y2=7.58
cc_2065 ( N_noxref_8_c_2852_n N_VDD_c_3497_n ) capacitor c=0.00829238f \
 //x=18.905 //y=5.335 //x2=28.61 //y2=7.58
cc_2066 ( N_noxref_8_c_2779_n N_VDD_c_3497_n ) capacitor c=4.99521e-19 \
 //x=18.99 //y=4.41 //x2=28.61 //y2=7.58
cc_2067 ( N_noxref_8_c_2637_n N_VDD_c_3497_n ) capacitor c=0.00261804f \
 //x=16.452 //y=5.335 //x2=28.61 //y2=7.58
cc_2068 ( N_noxref_8_c_2709_n N_VDD_c_3497_n ) capacitor c=0.00270108f \
 //x=17.33 //y=5.335 //x2=28.61 //y2=7.58
cc_2069 ( N_noxref_8_c_2890_n N_VDD_c_3497_n ) capacitor c=3.94104e-19 \
 //x=18.99 //y=4.25 //x2=28.61 //y2=7.58
cc_2070 ( N_noxref_8_c_2650_n N_VDD_c_3497_n ) capacitor c=0.0024232f \
 //x=16.45 //y=5.56 //x2=28.61 //y2=7.58
cc_2071 ( N_noxref_8_c_2732_n N_VDD_c_3497_n ) capacitor c=0.0024232f \
 //x=17.33 //y=5.56 //x2=28.61 //y2=7.58
cc_2072 ( N_noxref_8_c_2904_n N_VDD_c_3497_n ) capacitor c=0.0024232f \
 //x=18.21 //y=5.56 //x2=28.61 //y2=7.58
cc_2073 ( N_noxref_8_M28_noxref_g N_VDD_c_3643_n ) capacitor c=0.00755544f \
 //x=8.37 //y=6.2 //x2=8.945 //y2=7.585
cc_2074 ( N_noxref_8_M29_noxref_g N_VDD_c_3643_n ) capacitor c=0.00755754f \
 //x=8.81 //y=6.2 //x2=8.945 //y2=7.585
cc_2075 ( N_noxref_8_M34_noxref_g N_VDD_c_3580_n ) capacitor c=0.00755544f \
 //x=13.18 //y=6.2 //x2=13.755 //y2=7.585
cc_2076 ( N_noxref_8_M35_noxref_g N_VDD_c_3580_n ) capacitor c=0.00755754f \
 //x=13.62 //y=6.2 //x2=13.755 //y2=7.585
cc_2077 ( N_noxref_8_c_2634_n N_VDD_c_3585_n ) capacitor c=0.00202922f \
 //x=17.21 //y=5.335 //x2=16.805 //y2=7.585
cc_2078 ( N_noxref_8_c_2637_n N_VDD_c_3585_n ) capacitor c=9.3757e-19 \
 //x=16.452 //y=5.335 //x2=16.805 //y2=7.585
cc_2079 ( N_noxref_8_c_2650_n N_VDD_c_3585_n ) capacitor c=0.0138074f \
 //x=16.45 //y=5.56 //x2=16.805 //y2=7.585
cc_2080 ( N_noxref_8_c_2634_n N_VDD_c_3617_n ) capacitor c=0.0017708f \
 //x=17.21 //y=5.335 //x2=17.685 //y2=7.585
cc_2081 ( N_noxref_8_c_2704_n N_VDD_c_3617_n ) capacitor c=0.00202922f \
 //x=18.095 //y=5.335 //x2=17.685 //y2=7.585
cc_2082 ( N_noxref_8_c_2709_n N_VDD_c_3617_n ) capacitor c=9.4822e-19 \
 //x=17.33 //y=5.335 //x2=17.685 //y2=7.585
cc_2083 ( N_noxref_8_c_2732_n N_VDD_c_3617_n ) capacitor c=0.0138074f \
 //x=17.33 //y=5.56 //x2=17.685 //y2=7.585
cc_2084 ( N_noxref_8_c_2704_n N_VDD_c_3686_n ) capacitor c=0.00205906f \
 //x=18.095 //y=5.335 //x2=18.565 //y2=7.585
cc_2085 ( N_noxref_8_c_2850_n N_VDD_c_3686_n ) capacitor c=8.49654e-19 \
 //x=18.21 //y=5.56 //x2=18.565 //y2=7.585
cc_2086 ( N_noxref_8_c_2852_n N_VDD_c_3686_n ) capacitor c=0.00204238f \
 //x=18.905 //y=5.335 //x2=18.565 //y2=7.585
cc_2087 ( N_noxref_8_c_2904_n N_VDD_c_3686_n ) capacitor c=0.0135103f \
 //x=18.21 //y=5.56 //x2=18.565 //y2=7.585
cc_2088 ( N_noxref_8_c_2852_n N_VDD_c_3795_n ) capacitor c=0.00157252f \
 //x=18.905 //y=5.335 //x2=19.56 //y2=7.585
cc_2089 ( N_noxref_8_c_2779_n N_VDD_c_3795_n ) capacitor c=4.02528e-19 \
 //x=18.99 //y=4.41 //x2=19.56 //y2=7.585
cc_2090 ( N_noxref_8_M52_noxref_g N_VDD_c_3797_n ) capacitor c=0.00755544f \
 //x=27.61 //y=6.2 //x2=28.185 //y2=7.585
cc_2091 ( N_noxref_8_M53_noxref_g N_VDD_c_3797_n ) capacitor c=0.00755754f \
 //x=28.05 //y=6.2 //x2=28.185 //y2=7.585
cc_2092 ( N_noxref_8_c_2961_n N_VDD_c_3799_n ) capacitor c=0.00152883f \
 //x=27.87 //y=4.25 //x2=28.61 //y2=7.58
cc_2093 ( N_noxref_8_c_2980_n N_VDD_c_3799_n ) capacitor c=0.00224736f \
 //x=27.87 //y=4.88 //x2=28.61 //y2=7.58
cc_2094 ( N_noxref_8_c_3008_n N_VDD_c_3799_n ) capacitor c=2.63786e-19 \
 //x=27.87 //y=4.88 //x2=28.61 //y2=7.58
cc_2095 ( N_noxref_8_c_2708_n N_VDD_c_3527_n ) capacitor c=4.5459e-19 \
 //x=8.625 //y=4.25 //x2=5.3 //y2=7.585
cc_2096 ( N_noxref_8_c_2708_n N_VDD_c_3533_n ) capacitor c=0.00138334f \
 //x=8.625 //y=4.25 //x2=10.11 //y2=7.585
cc_2097 ( N_noxref_8_c_2636_n N_VDD_c_3533_n ) capacitor c=3.33168e-19 \
 //x=13.435 //y=4.25 //x2=10.11 //y2=7.585
cc_2098 ( N_noxref_8_c_2616_n N_VDD_c_3533_n ) capacitor c=0.00897186f \
 //x=13.595 //y=4.25 //x2=10.11 //y2=7.585
cc_2099 ( N_noxref_8_c_2728_n N_VDD_c_3533_n ) capacitor c=0.00224736f \
 //x=8.63 //y=4.88 //x2=10.11 //y2=7.585
cc_2100 ( N_noxref_8_c_2746_n N_VDD_c_3533_n ) capacitor c=2.63786e-19 \
 //x=8.63 //y=4.88 //x2=10.11 //y2=7.585
cc_2101 ( N_noxref_8_c_2636_n N_VDD_c_3589_n ) capacitor c=0.00139231f \
 //x=13.435 //y=4.25 //x2=14.92 //y2=7.585
cc_2102 ( N_noxref_8_c_2637_n N_VDD_c_3589_n ) capacitor c=0.0022955f \
 //x=16.452 //y=5.335 //x2=14.92 //y2=7.585
cc_2103 ( N_noxref_8_c_2642_n N_VDD_c_3589_n ) capacitor c=0.00867114f \
 //x=18.83 //y=4.25 //x2=14.92 //y2=7.585
cc_2104 ( N_noxref_8_c_2646_n N_VDD_c_3589_n ) capacitor c=0.00224736f \
 //x=13.44 //y=4.88 //x2=14.92 //y2=7.585
cc_2105 ( N_noxref_8_c_2650_n N_VDD_c_3589_n ) capacitor c=0.00509469f \
 //x=16.45 //y=5.56 //x2=14.92 //y2=7.585
cc_2106 ( N_noxref_8_c_2680_n N_VDD_c_3589_n ) capacitor c=2.63786e-19 \
 //x=13.44 //y=4.88 //x2=14.92 //y2=7.585
cc_2107 ( N_noxref_8_c_2850_n N_VDD_c_3658_n ) capacitor c=0.00282782f \
 //x=18.21 //y=5.56 //x2=19.73 //y2=7.585
cc_2108 ( N_noxref_8_c_2779_n N_VDD_c_3658_n ) capacitor c=0.00178791f \
 //x=18.99 //y=4.41 //x2=19.73 //y2=7.585
cc_2109 ( N_noxref_8_c_2707_n N_VDD_c_3658_n ) capacitor c=0.0293653f \
 //x=18.99 //y=5.25 //x2=19.73 //y2=7.585
cc_2110 ( N_noxref_8_c_2890_n N_VDD_c_3658_n ) capacitor c=0.00505304f \
 //x=18.99 //y=4.25 //x2=19.73 //y2=7.585
cc_2111 ( N_noxref_8_c_2800_n N_VDD_c_3658_n ) capacitor c=0.00825426f \
 //x=27.71 //y=4.265 //x2=19.73 //y2=7.585
cc_2112 ( N_noxref_8_c_2904_n N_VDD_c_3658_n ) capacitor c=0.00777981f \
 //x=18.21 //y=5.56 //x2=19.73 //y2=7.585
cc_2113 ( N_noxref_8_c_2961_n N_VDD_c_3734_n ) capacitor c=3.34015e-19 \
 //x=27.87 //y=4.25 //x2=24.54 //y2=7.585
cc_2114 ( N_noxref_8_c_2800_n N_VDD_c_3734_n ) capacitor c=0.0197375f \
 //x=27.71 //y=4.265 //x2=24.54 //y2=7.585
cc_2115 ( N_noxref_8_M28_noxref_g N_VDD_M27_noxref_d ) capacitor c=0.015318f \
 //x=8.37 //y=6.2 //x2=8.005 //y2=5.2
cc_2116 ( N_noxref_8_M29_noxref_g N_VDD_M29_noxref_d ) capacitor c=0.0394719f \
 //x=8.81 //y=6.2 //x2=8.885 //y2=5.2
cc_2117 ( N_noxref_8_M34_noxref_g N_VDD_M33_noxref_d ) capacitor c=0.015318f \
 //x=13.18 //y=6.2 //x2=12.815 //y2=5.2
cc_2118 ( N_noxref_8_M35_noxref_g N_VDD_M35_noxref_d ) capacitor c=0.0394719f \
 //x=13.62 //y=6.2 //x2=13.695 //y2=5.2
cc_2119 ( N_noxref_8_c_2637_n N_VDD_M36_noxref_s ) capacitor c=0.0442713f \
 //x=16.452 //y=5.335 //x2=15.875 //y2=5.2
cc_2120 ( N_noxref_8_c_2709_n N_VDD_M36_noxref_s ) capacitor c=7.80122e-19 \
 //x=17.33 //y=5.335 //x2=15.875 //y2=5.2
cc_2121 ( N_noxref_8_c_2650_n N_VDD_M36_noxref_s ) capacitor c=0.09305f \
 //x=16.45 //y=5.56 //x2=15.875 //y2=5.2
cc_2122 ( N_noxref_8_c_2634_n N_VDD_M37_noxref_d ) capacitor c=0.00700141f \
 //x=17.21 //y=5.335 //x2=16.745 //y2=5.2
cc_2123 ( N_noxref_8_c_2650_n N_VDD_M37_noxref_d ) capacitor c=0.0674491f \
 //x=16.45 //y=5.56 //x2=16.745 //y2=5.2
cc_2124 ( N_noxref_8_c_2732_n N_VDD_M37_noxref_d ) capacitor c=0.0674762f \
 //x=17.33 //y=5.56 //x2=16.745 //y2=5.2
cc_2125 ( N_noxref_8_c_2704_n N_VDD_M39_noxref_d ) capacitor c=0.00700141f \
 //x=18.095 //y=5.335 //x2=17.625 //y2=5.2
cc_2126 ( N_noxref_8_c_2732_n N_VDD_M39_noxref_d ) capacitor c=0.067493f \
 //x=17.33 //y=5.56 //x2=17.625 //y2=5.2
cc_2127 ( N_noxref_8_c_2904_n N_VDD_M39_noxref_d ) capacitor c=0.0674979f \
 //x=18.21 //y=5.56 //x2=17.625 //y2=5.2
cc_2128 ( N_noxref_8_c_2852_n N_VDD_M41_noxref_d ) capacitor c=0.00700141f \
 //x=18.905 //y=5.335 //x2=18.505 //y2=5.2
cc_2129 ( N_noxref_8_c_2904_n N_VDD_M41_noxref_d ) capacitor c=0.0675002f \
 //x=18.21 //y=5.56 //x2=18.505 //y2=5.2
cc_2130 ( N_noxref_8_c_2850_n N_VDD_M42_noxref_s ) capacitor c=0.00492616f \
 //x=18.21 //y=5.56 //x2=20.685 //y2=5.2
cc_2131 ( N_noxref_8_c_2852_n N_VDD_M42_noxref_s ) capacitor c=9.42705e-19 \
 //x=18.905 //y=5.335 //x2=20.685 //y2=5.2
cc_2132 ( N_noxref_8_c_2709_n N_VDD_M42_noxref_s ) capacitor c=2.11884e-19 \
 //x=17.33 //y=5.335 //x2=20.685 //y2=5.2
cc_2133 ( N_noxref_8_c_2800_n N_VDD_M48_noxref_s ) capacitor c=5.36777e-19 \
 //x=27.71 //y=4.265 //x2=25.495 //y2=5.2
cc_2134 ( N_noxref_8_M52_noxref_g N_VDD_M51_noxref_d ) capacitor c=0.015318f \
 //x=27.61 //y=6.2 //x2=27.245 //y2=5.2
cc_2135 ( N_noxref_8_M53_noxref_g N_VDD_M53_noxref_d ) capacitor c=0.0394719f \
 //x=28.05 //y=6.2 //x2=28.125 //y2=5.2
cc_2136 ( N_noxref_8_c_2605_n N_noxref_13_c_4085_n ) capacitor c=0.00175916f \
 //x=8.63 //y=2.375 //x2=9.285 //y2=0.72
cc_2137 ( N_noxref_8_c_2724_n N_noxref_13_c_4085_n ) capacitor c=0.00117306f \
 //x=8.63 //y=2.26 //x2=9.285 //y2=0.72
cc_2138 ( N_noxref_8_c_2739_n N_noxref_13_c_4085_n ) capacitor c=0.0206349f \
 //x=8.62 //y=1.095 //x2=9.285 //y2=0.72
cc_2139 ( N_noxref_8_c_2826_n N_noxref_13_c_4085_n ) capacitor c=0.00825432f \
 //x=9.15 //y=1.095 //x2=9.285 //y2=0.72
cc_2140 ( N_noxref_8_c_2742_n N_noxref_13_c_4085_n ) capacitor c=2.20712e-19 \
 //x=8.63 //y=2.26 //x2=9.285 //y2=0.72
cc_2141 ( N_noxref_8_c_2740_n N_noxref_13_c_4088_n ) capacitor c=0.0071177f \
 //x=8.62 //y=1.44 //x2=8.4 //y2=1.175
cc_2142 ( N_noxref_8_c_2739_n N_noxref_13_M5_noxref_s ) capacitor c=0.0071177f \
 //x=8.62 //y=1.095 //x2=8.265 //y2=0.555
cc_2143 ( N_noxref_8_c_2741_n N_noxref_13_M5_noxref_s ) capacitor c=0.0071177f \
 //x=8.62 //y=1.75 //x2=8.265 //y2=0.555
cc_2144 ( N_noxref_8_c_2826_n N_noxref_13_M5_noxref_s ) capacitor c=0.015333f \
 //x=9.15 //y=1.095 //x2=8.265 //y2=0.555
cc_2145 ( N_noxref_8_c_2828_n N_noxref_13_M5_noxref_s ) capacitor \
 c=0.00248746f //x=9.15 //y=1.44 //x2=8.265 //y2=0.555
cc_2146 ( N_noxref_8_c_2617_n N_noxref_14_c_4135_n ) capacitor c=0.00177186f \
 //x=13.44 //y=2.375 //x2=14.095 //y2=0.72
cc_2147 ( N_noxref_8_c_2645_n N_noxref_14_c_4135_n ) capacitor c=0.00117306f \
 //x=13.44 //y=2.26 //x2=14.095 //y2=0.72
cc_2148 ( N_noxref_8_c_2659_n N_noxref_14_c_4135_n ) capacitor c=0.0206349f \
 //x=13.43 //y=1.095 //x2=14.095 //y2=0.72
cc_2149 ( N_noxref_8_c_2671_n N_noxref_14_c_4135_n ) capacitor c=0.00825432f \
 //x=13.96 //y=1.095 //x2=14.095 //y2=0.72
cc_2150 ( N_noxref_8_c_2677_n N_noxref_14_c_4135_n ) capacitor c=2.20712e-19 \
 //x=13.44 //y=2.26 //x2=14.095 //y2=0.72
cc_2151 ( N_noxref_8_c_2661_n N_noxref_14_c_4138_n ) capacitor c=0.0071177f \
 //x=13.43 //y=1.44 //x2=13.21 //y2=1.175
cc_2152 ( N_noxref_8_c_2625_n N_noxref_14_M8_noxref_s ) capacitor \
 c=7.50251e-19 //x=13.44 //y=4.41 //x2=13.075 //y2=0.555
cc_2153 ( N_noxref_8_c_2659_n N_noxref_14_M8_noxref_s ) capacitor c=0.0071177f \
 //x=13.43 //y=1.095 //x2=13.075 //y2=0.555
cc_2154 ( N_noxref_8_c_2664_n N_noxref_14_M8_noxref_s ) capacitor c=0.0071177f \
 //x=13.43 //y=1.75 //x2=13.075 //y2=0.555
cc_2155 ( N_noxref_8_c_2671_n N_noxref_14_M8_noxref_s ) capacitor c=0.015333f \
 //x=13.96 //y=1.095 //x2=13.075 //y2=0.555
cc_2156 ( N_noxref_8_c_2673_n N_noxref_14_M8_noxref_s ) capacitor \
 c=0.00248746f //x=13.96 //y=1.44 //x2=13.075 //y2=0.555
cc_2157 ( N_noxref_8_c_2856_n N_noxref_15_c_4224_n ) capacitor c=0.0036878f \
 //x=18.505 //y=1.305 //x2=18.905 //y2=0.72
cc_2158 ( N_noxref_8_c_2867_n N_noxref_15_c_4224_n ) capacitor c=0.00399931f \
 //x=18.905 //y=1.845 //x2=18.905 //y2=0.72
cc_2159 ( N_noxref_8_M11_noxref_d N_noxref_15_c_4224_n ) capacitor \
 c=0.00910163f //x=18.315 //y=1.095 //x2=18.905 //y2=0.72
cc_2160 ( N_noxref_8_M11_noxref_d N_noxref_15_c_4229_n ) capacitor \
 c=0.00120711f //x=18.315 //y=1.095 //x2=18.02 //y2=1.175
cc_2161 ( N_noxref_8_c_2634_n N_noxref_15_M10_noxref_d ) capacitor \
 c=9.48429e-19 //x=17.21 //y=5.335 //x2=16.78 //y2=1.09
cc_2162 ( N_noxref_8_c_2856_n N_noxref_15_M10_noxref_d ) capacitor \
 c=0.00802417f //x=18.505 //y=1.305 //x2=16.78 //y2=1.09
cc_2163 ( N_noxref_8_c_2856_n N_noxref_15_M11_noxref_s ) capacitor \
 c=0.0098487f //x=18.505 //y=1.305 //x2=17.885 //y2=0.555
cc_2164 ( N_noxref_8_c_2862_n N_noxref_15_M11_noxref_s ) capacitor \
 c=0.0283243f //x=18.505 //y=1.76 //x2=17.885 //y2=0.555
cc_2165 ( N_noxref_8_c_2867_n N_noxref_15_M11_noxref_s ) capacitor \
 c=0.00942148f //x=18.905 //y=1.845 //x2=17.885 //y2=0.555
cc_2166 ( N_noxref_8_c_2890_n N_noxref_15_M11_noxref_s ) capacitor \
 c=0.00108527f //x=18.99 //y=4.25 //x2=17.885 //y2=0.555
cc_2167 ( N_noxref_8_M11_noxref_d N_noxref_15_M11_noxref_s ) capacitor \
 c=0.0279003f //x=18.315 //y=1.095 //x2=17.885 //y2=0.555
cc_2168 ( N_noxref_8_c_2856_n N_noxref_16_M13_noxref_d ) capacitor \
 c=3.20746e-19 //x=18.505 //y=1.305 //x2=21.59 //y2=1.09
cc_2169 ( N_noxref_8_c_2605_n N_GND_c_4450_n ) capacitor c=0.00219894f \
 //x=8.63 //y=2.375 //x2=11.1 //y2=0.175
cc_2170 ( N_noxref_8_c_2617_n N_GND_c_4414_n ) capacitor c=0.0021992f \
 //x=13.44 //y=2.375 //x2=15.91 //y2=0.175
cc_2171 ( N_noxref_8_c_2625_n N_GND_c_4414_n ) capacitor c=2.50407e-19 \
 //x=13.44 //y=4.41 //x2=15.91 //y2=0.175
cc_2172 ( N_noxref_8_c_2856_n N_GND_c_4452_n ) capacitor c=0.00901861f \
 //x=18.505 //y=1.305 //x2=20.72 //y2=0.175
cc_2173 ( N_noxref_8_c_2867_n N_GND_c_4452_n ) capacitor c=0.00713708f \
 //x=18.905 //y=1.845 //x2=20.72 //y2=0.175
cc_2174 ( N_noxref_8_c_2779_n N_GND_c_4452_n ) capacitor c=4.58384e-19 \
 //x=18.99 //y=4.41 //x2=20.72 //y2=0.175
cc_2175 ( N_noxref_8_M11_noxref_d N_GND_c_4452_n ) capacitor c=2.9462e-19 \
 //x=18.315 //y=1.095 //x2=20.72 //y2=0.175
cc_2176 ( N_noxref_8_c_2946_n N_GND_c_4538_n ) capacitor c=0.0021992f \
 //x=27.87 //y=2.375 //x2=28.61 //y2=0.18
cc_2177 ( N_noxref_8_c_2955_n N_GND_c_4538_n ) capacitor c=2.48915e-19 \
 //x=27.87 //y=4.425 //x2=28.61 //y2=0.18
cc_2178 ( N_noxref_8_c_2856_n N_GND_c_4462_n ) capacitor c=0.00543195f \
 //x=18.505 //y=1.305 //x2=20.805 //y2=1.145
cc_2179 ( N_noxref_8_c_2605_n N_GND_c_4384_n ) capacitor c=2.016e-19 //x=8.63 \
 //y=2.375 //x2=9.94 //y2=0.175
cc_2180 ( N_noxref_8_c_2617_n N_GND_c_4385_n ) capacitor c=2.016e-19 //x=13.44 \
 //y=2.375 //x2=14.75 //y2=0.175
cc_2181 ( N_noxref_8_c_2867_n N_GND_c_4434_n ) capacitor c=6.86343e-19 \
 //x=18.905 //y=1.845 //x2=19.56 //y2=0.175
cc_2182 ( N_noxref_8_c_2946_n N_GND_c_4520_n ) capacitor c=2.016e-19 //x=27.87 \
 //y=2.375 //x2=28.61 //y2=0.18
cc_2183 ( N_noxref_8_c_2976_n N_GND_c_4520_n ) capacitor c=0.00246191f \
 //x=27.87 //y=2.26 //x2=28.61 //y2=0.18
cc_2184 ( N_noxref_8_c_3044_p N_GND_c_4520_n ) capacitor c=0.00275764f \
 //x=28.39 //y=1.44 //x2=28.61 //y2=0.18
cc_2185 ( N_noxref_8_c_2724_n N_GND_c_4394_n ) capacitor c=0.00246191f \
 //x=8.63 //y=2.26 //x2=10.11 //y2=0.175
cc_2186 ( N_noxref_8_c_2828_n N_GND_c_4394_n ) capacitor c=0.00262688f \
 //x=9.15 //y=1.44 //x2=10.11 //y2=0.175
cc_2187 ( N_noxref_8_c_2645_n N_GND_c_4435_n ) capacitor c=0.00239899f \
 //x=13.44 //y=2.26 //x2=14.92 //y2=0.175
cc_2188 ( N_noxref_8_c_2673_n N_GND_c_4435_n ) capacitor c=0.00262688f \
 //x=13.96 //y=1.44 //x2=14.92 //y2=0.175
cc_2189 ( N_noxref_8_c_2677_n N_GND_c_4435_n ) capacitor c=2.63786e-19 \
 //x=13.44 //y=2.26 //x2=14.92 //y2=0.175
cc_2190 ( N_noxref_8_c_2862_n N_GND_c_4480_n ) capacitor c=0.0045138f \
 //x=18.505 //y=1.76 //x2=19.73 //y2=0.175
cc_2191 ( N_noxref_8_c_2867_n N_GND_c_4480_n ) capacitor c=0.0324453f \
 //x=18.905 //y=1.845 //x2=19.73 //y2=0.175
cc_2192 ( N_noxref_8_c_2946_n N_noxref_18_c_4851_n ) capacitor c=0.00177186f \
 //x=27.87 //y=2.375 //x2=28.525 //y2=0.72
cc_2193 ( N_noxref_8_c_2976_n N_noxref_18_c_4851_n ) capacitor c=0.00117306f \
 //x=27.87 //y=2.26 //x2=28.525 //y2=0.72
cc_2194 ( N_noxref_8_c_2993_n N_noxref_18_c_4851_n ) capacitor c=0.0206349f \
 //x=27.86 //y=1.095 //x2=28.525 //y2=0.72
cc_2195 ( N_noxref_8_c_3043_p N_noxref_18_c_4851_n ) capacitor c=0.00825432f \
 //x=28.39 //y=1.095 //x2=28.525 //y2=0.72
cc_2196 ( N_noxref_8_c_3004_n N_noxref_18_c_4851_n ) capacitor c=2.20712e-19 \
 //x=27.87 //y=2.26 //x2=28.525 //y2=0.72
cc_2197 ( N_noxref_8_c_2994_n N_noxref_18_c_4856_n ) capacitor c=0.0071177f \
 //x=27.86 //y=1.44 //x2=27.64 //y2=1.175
cc_2198 ( N_noxref_8_c_2955_n N_noxref_18_M17_noxref_s ) capacitor \
 c=7.42881e-19 //x=27.87 //y=4.425 //x2=27.505 //y2=0.555
cc_2199 ( N_noxref_8_c_2993_n N_noxref_18_M17_noxref_s ) capacitor \
 c=0.0071177f //x=27.86 //y=1.095 //x2=27.505 //y2=0.555
cc_2200 ( N_noxref_8_c_2995_n N_noxref_18_M17_noxref_s ) capacitor \
 c=0.0071177f //x=27.86 //y=1.75 //x2=27.505 //y2=0.555
cc_2201 ( N_noxref_8_c_3043_p N_noxref_18_M17_noxref_s ) capacitor c=0.015333f \
 //x=28.39 //y=1.095 //x2=27.505 //y2=0.555
cc_2202 ( N_noxref_8_c_3044_p N_noxref_18_M17_noxref_s ) capacitor \
 c=0.00248746f //x=28.39 //y=1.44 //x2=27.505 //y2=0.555
cc_2203 ( N_Q_c_3275_n N_VDD_c_3497_n ) capacitor c=0.00621363f //x=26.83 \
 //y=5.335 //x2=28.61 //y2=7.58
cc_2204 ( N_Q_c_3339_n N_VDD_c_3497_n ) capacitor c=0.00627186f //x=27.715 \
 //y=5.335 //x2=28.61 //y2=7.58
cc_2205 ( N_Q_c_3374_n N_VDD_c_3497_n ) capacitor c=0.00256019f //x=27.83 \
 //y=5.56 //x2=28.61 //y2=7.58
cc_2206 ( N_Q_c_3376_n N_VDD_c_3497_n ) capacitor c=0.00829225f //x=28.525 \
 //y=5.335 //x2=28.61 //y2=7.58
cc_2207 ( N_Q_c_3277_n N_VDD_c_3497_n ) capacitor c=0.00261804f //x=26.072 \
 //y=5.335 //x2=28.61 //y2=7.58
cc_2208 ( N_Q_c_3340_n N_VDD_c_3497_n ) capacitor c=0.00270108f //x=26.95 \
 //y=5.335 //x2=28.61 //y2=7.58
cc_2209 ( N_Q_c_3295_n N_VDD_c_3497_n ) capacitor c=0.0024232f //x=26.07 \
 //y=5.56 //x2=28.61 //y2=7.58
cc_2210 ( N_Q_c_3350_n N_VDD_c_3497_n ) capacitor c=0.0024232f //x=26.95 \
 //y=5.56 //x2=28.61 //y2=7.58
cc_2211 ( N_Q_c_3407_n N_VDD_c_3497_n ) capacitor c=0.0024232f //x=27.83 \
 //y=5.56 //x2=28.61 //y2=7.58
cc_2212 ( N_Q_M46_noxref_g N_VDD_c_3725_n ) capacitor c=0.00755544f //x=22.8 \
 //y=6.2 //x2=23.375 //y2=7.585
cc_2213 ( N_Q_M47_noxref_g N_VDD_c_3725_n ) capacitor c=0.00755754f //x=23.24 \
 //y=6.2 //x2=23.375 //y2=7.585
cc_2214 ( N_Q_c_3275_n N_VDD_c_3730_n ) capacitor c=0.00202922f //x=26.83 \
 //y=5.335 //x2=26.425 //y2=7.585
cc_2215 ( N_Q_c_3277_n N_VDD_c_3730_n ) capacitor c=9.3757e-19 //x=26.072 \
 //y=5.335 //x2=26.425 //y2=7.585
cc_2216 ( N_Q_c_3295_n N_VDD_c_3730_n ) capacitor c=0.0138074f //x=26.07 \
 //y=5.56 //x2=26.425 //y2=7.585
cc_2217 ( N_Q_c_3275_n N_VDD_c_3763_n ) capacitor c=0.0017708f //x=26.83 \
 //y=5.335 //x2=27.305 //y2=7.585
cc_2218 ( N_Q_c_3339_n N_VDD_c_3763_n ) capacitor c=0.00202922f //x=27.715 \
 //y=5.335 //x2=27.305 //y2=7.585
cc_2219 ( N_Q_c_3340_n N_VDD_c_3763_n ) capacitor c=9.4822e-19 //x=26.95 \
 //y=5.335 //x2=27.305 //y2=7.585
cc_2220 ( N_Q_c_3350_n N_VDD_c_3763_n ) capacitor c=0.0138074f //x=26.95 \
 //y=5.56 //x2=27.305 //y2=7.585
cc_2221 ( N_Q_c_3339_n N_VDD_c_3797_n ) capacitor c=0.00205906f //x=27.715 \
 //y=5.335 //x2=28.185 //y2=7.585
cc_2222 ( N_Q_c_3374_n N_VDD_c_3797_n ) capacitor c=8.49654e-19 //x=27.83 \
 //y=5.56 //x2=28.185 //y2=7.585
cc_2223 ( N_Q_c_3376_n N_VDD_c_3797_n ) capacitor c=0.00204238f //x=28.525 \
 //y=5.335 //x2=28.185 //y2=7.585
cc_2224 ( N_Q_c_3407_n N_VDD_c_3797_n ) capacitor c=0.0135103f //x=27.83 \
 //y=5.56 //x2=28.185 //y2=7.585
cc_2225 ( Q N_VDD_c_3799_n ) capacitor c=0.0380389f //x=28.61 //y=4.25 \
 //x2=28.61 //y2=7.58
cc_2226 ( N_Q_c_3374_n N_VDD_c_3799_n ) capacitor c=0.00414616f //x=27.83 \
 //y=5.56 //x2=28.61 //y2=7.58
cc_2227 ( N_Q_c_3376_n N_VDD_c_3799_n ) capacitor c=0.00183742f //x=28.525 \
 //y=5.335 //x2=28.61 //y2=7.58
cc_2228 ( N_Q_c_3407_n N_VDD_c_3799_n ) capacitor c=0.00778106f //x=27.83 \
 //y=5.56 //x2=28.61 //y2=7.58
cc_2229 ( N_Q_c_3277_n N_VDD_c_3734_n ) capacitor c=0.0022955f //x=26.072 \
 //y=5.335 //x2=24.54 //y2=7.585
cc_2230 ( N_Q_c_3240_n N_VDD_c_3734_n ) capacitor c=0.00224736f //x=23.06 \
 //y=4.88 //x2=24.54 //y2=7.585
cc_2231 ( N_Q_c_3295_n N_VDD_c_3734_n ) capacitor c=0.00509469f //x=26.07 \
 //y=5.56 //x2=24.54 //y2=7.585
cc_2232 ( N_Q_c_3253_n N_VDD_c_3734_n ) capacitor c=2.63786e-19 //x=23.06 \
 //y=4.88 //x2=24.54 //y2=7.585
cc_2233 ( N_Q_M46_noxref_g N_VDD_M45_noxref_d ) capacitor c=0.015318f //x=22.8 \
 //y=6.2 //x2=22.435 //y2=5.2
cc_2234 ( N_Q_M47_noxref_g N_VDD_M47_noxref_d ) capacitor c=0.0394719f \
 //x=23.24 //y=6.2 //x2=23.315 //y2=5.2
cc_2235 ( N_Q_c_3277_n N_VDD_M48_noxref_s ) capacitor c=0.0442713f //x=26.072 \
 //y=5.335 //x2=25.495 //y2=5.2
cc_2236 ( N_Q_c_3340_n N_VDD_M48_noxref_s ) capacitor c=7.80122e-19 //x=26.95 \
 //y=5.335 //x2=25.495 //y2=5.2
cc_2237 ( N_Q_c_3295_n N_VDD_M48_noxref_s ) capacitor c=0.09305f //x=26.07 \
 //y=5.56 //x2=25.495 //y2=5.2
cc_2238 ( N_Q_c_3275_n N_VDD_M49_noxref_d ) capacitor c=0.00700141f //x=26.83 \
 //y=5.335 //x2=26.365 //y2=5.2
cc_2239 ( N_Q_c_3295_n N_VDD_M49_noxref_d ) capacitor c=0.0674491f //x=26.07 \
 //y=5.56 //x2=26.365 //y2=5.2
cc_2240 ( N_Q_c_3350_n N_VDD_M49_noxref_d ) capacitor c=0.0674762f //x=26.95 \
 //y=5.56 //x2=26.365 //y2=5.2
cc_2241 ( N_Q_c_3339_n N_VDD_M51_noxref_d ) capacitor c=0.00700141f //x=27.715 \
 //y=5.335 //x2=27.245 //y2=5.2
cc_2242 ( N_Q_c_3350_n N_VDD_M51_noxref_d ) capacitor c=0.067493f //x=26.95 \
 //y=5.56 //x2=27.245 //y2=5.2
cc_2243 ( N_Q_c_3407_n N_VDD_M51_noxref_d ) capacitor c=0.0675031f //x=27.83 \
 //y=5.56 //x2=27.245 //y2=5.2
cc_2244 ( N_Q_c_3376_n N_VDD_M53_noxref_d ) capacitor c=0.00700141f //x=28.525 \
 //y=5.335 //x2=28.125 //y2=5.2
cc_2245 ( N_Q_c_3407_n N_VDD_M53_noxref_d ) capacitor c=0.0675091f //x=27.83 \
 //y=5.56 //x2=28.125 //y2=5.2
cc_2246 ( N_Q_c_3228_n N_noxref_16_c_4293_n ) capacitor c=0.00177186f \
 //x=23.06 //y=2.375 //x2=23.715 //y2=0.72
cc_2247 ( N_Q_c_3236_n N_noxref_16_c_4293_n ) capacitor c=0.00117306f \
 //x=23.06 //y=2.26 //x2=23.715 //y2=0.72
cc_2248 ( N_Q_c_3246_n N_noxref_16_c_4293_n ) capacitor c=0.0206349f //x=23.05 \
 //y=1.095 //x2=23.715 //y2=0.72
cc_2249 ( N_Q_c_3316_n N_noxref_16_c_4293_n ) capacitor c=0.00825432f \
 //x=23.58 //y=1.095 //x2=23.715 //y2=0.72
cc_2250 ( N_Q_c_3249_n N_noxref_16_c_4293_n ) capacitor c=2.20712e-19 \
 //x=23.06 //y=2.26 //x2=23.715 //y2=0.72
cc_2251 ( N_Q_c_3247_n N_noxref_16_c_4296_n ) capacitor c=0.0071177f //x=23.05 \
 //y=1.44 //x2=22.83 //y2=1.175
cc_2252 ( N_Q_c_3231_n N_noxref_16_M14_noxref_s ) capacitor c=2.40103e-19 \
 //x=23.06 //y=4.025 //x2=22.695 //y2=0.555
cc_2253 ( N_Q_c_3246_n N_noxref_16_M14_noxref_s ) capacitor c=0.0071177f \
 //x=23.05 //y=1.095 //x2=22.695 //y2=0.555
cc_2254 ( N_Q_c_3248_n N_noxref_16_M14_noxref_s ) capacitor c=0.0071177f \
 //x=23.05 //y=1.75 //x2=22.695 //y2=0.555
cc_2255 ( N_Q_c_3316_n N_noxref_16_M14_noxref_s ) capacitor c=0.015333f \
 //x=23.58 //y=1.095 //x2=22.695 //y2=0.555
cc_2256 ( N_Q_c_3318_n N_noxref_16_M14_noxref_s ) capacitor c=0.00248746f \
 //x=23.58 //y=1.44 //x2=22.695 //y2=0.555
cc_2257 ( N_Q_c_3228_n N_GND_c_4495_n ) capacitor c=0.0021992f //x=23.06 \
 //y=2.375 //x2=25.53 //y2=0.175
cc_2258 ( N_Q_c_3381_n N_GND_c_4538_n ) capacitor c=0.00901861f //x=28.125 \
 //y=1.305 //x2=28.61 //y2=0.18
cc_2259 ( N_Q_c_3392_n N_GND_c_4538_n ) capacitor c=0.00713708f //x=28.525 \
 //y=1.845 //x2=28.61 //y2=0.18
cc_2260 ( N_Q_M17_noxref_d N_GND_c_4538_n ) capacitor c=2.9462e-19 //x=27.935 \
 //y=1.095 //x2=28.61 //y2=0.18
cc_2261 ( N_Q_c_3228_n N_GND_c_4474_n ) capacitor c=2.016e-19 //x=23.06 \
 //y=2.375 //x2=24.37 //y2=0.175
cc_2262 ( N_Q_c_3387_n N_GND_c_4520_n ) capacitor c=0.00518727f //x=28.125 \
 //y=1.76 //x2=28.61 //y2=0.18
cc_2263 ( N_Q_c_3392_n N_GND_c_4520_n ) capacitor c=0.0384971f //x=28.525 \
 //y=1.845 //x2=28.61 //y2=0.18
cc_2264 ( N_Q_c_3236_n N_GND_c_4521_n ) capacitor c=0.00239899f //x=23.06 \
 //y=2.26 //x2=24.54 //y2=0.175
cc_2265 ( N_Q_c_3318_n N_GND_c_4521_n ) capacitor c=0.00262688f //x=23.58 \
 //y=1.44 //x2=24.54 //y2=0.175
cc_2266 ( N_Q_c_3249_n N_GND_c_4521_n ) capacitor c=2.63786e-19 //x=23.06 \
 //y=2.26 //x2=24.54 //y2=0.175
cc_2267 ( N_Q_c_3381_n N_noxref_18_c_4851_n ) capacitor c=0.00366459f \
 //x=28.125 //y=1.305 //x2=28.525 //y2=0.72
cc_2268 ( N_Q_c_3392_n N_noxref_18_c_4851_n ) capacitor c=0.00383344f \
 //x=28.525 //y=1.845 //x2=28.525 //y2=0.72
cc_2269 ( N_Q_M17_noxref_d N_noxref_18_c_4851_n ) capacitor c=0.00910163f \
 //x=27.935 //y=1.095 //x2=28.525 //y2=0.72
cc_2270 ( N_Q_M17_noxref_d N_noxref_18_c_4856_n ) capacitor c=0.00120711f \
 //x=27.935 //y=1.095 //x2=27.64 //y2=1.175
cc_2271 ( N_Q_c_3275_n N_noxref_18_M16_noxref_d ) capacitor c=9.31944e-19 \
 //x=26.83 //y=5.335 //x2=26.4 //y2=1.09
cc_2272 ( N_Q_c_3381_n N_noxref_18_M16_noxref_d ) capacitor c=0.00803465f \
 //x=28.125 //y=1.305 //x2=26.4 //y2=1.09
cc_2273 ( Q N_noxref_18_M17_noxref_s ) capacitor c=0.00129723f //x=28.61 \
 //y=3.88 //x2=27.505 //y2=0.555
cc_2274 ( N_Q_c_3381_n N_noxref_18_M17_noxref_s ) capacitor c=0.011355f \
 //x=28.125 //y=1.305 //x2=27.505 //y2=0.555
cc_2275 ( N_Q_c_3387_n N_noxref_18_M17_noxref_s ) capacitor c=0.0283243f \
 //x=28.125 //y=1.76 //x2=27.505 //y2=0.555
cc_2276 ( N_Q_c_3392_n N_noxref_18_M17_noxref_s ) capacitor c=0.00911719f \
 //x=28.525 //y=1.845 //x2=27.505 //y2=0.555
cc_2277 ( N_Q_c_3283_n N_noxref_18_M17_noxref_s ) capacitor c=0.00198837f \
 //x=28.445 //y=3.875 //x2=27.505 //y2=0.555
cc_2278 ( N_Q_M17_noxref_d N_noxref_18_M17_noxref_s ) capacitor c=0.0279003f \
 //x=27.935 //y=1.095 //x2=27.505 //y2=0.555
cc_2279 ( N_Q_c_3283_n N_noxref_24_c_5204_n ) capacitor c=8.50003e-19 \
 //x=28.445 //y=3.875 //x2=26.985 //y2=1.77
cc_2280 ( N_Q_c_3283_n N_noxref_24_M15_noxref_s ) capacitor c=0.0020282f \
 //x=28.445 //y=3.875 //x2=24.995 //y2=0.555
cc_2281 ( N_VDD_c_3509_n D ) capacitor c=0.010959f //x=1.23 //y=7.58 //x2=1.6 \
 //y2=2.77
cc_2282 ( N_VDD_c_3509_n N_D_c_3922_n ) capacitor c=0.00805425f //x=1.23 \
 //y=7.58 //x2=1.6 //y2=4.755
cc_2283 ( N_VDD_M18_noxref_s N_D_c_3922_n ) capacitor c=0.0230396f //x=1.445 \
 //y=5.2 //x2=1.6 //y2=4.755
cc_2284 ( N_VDD_c_3509_n N_D_c_3930_n ) capacitor c=0.00371026f //x=1.23 \
 //y=7.58 //x2=1.6 //y2=4.88
cc_2285 ( N_VDD_M18_noxref_s N_D_c_3930_n ) capacitor c=0.00983413f //x=1.445 \
 //y=5.2 //x2=1.6 //y2=4.88
cc_2286 ( N_VDD_c_3511_n N_D_M18_noxref_g ) capacitor c=0.00755614f //x=2.375 \
 //y=7.585 //x2=1.8 //y2=6.2
cc_2287 ( N_VDD_M18_noxref_s N_D_M18_noxref_g ) capacitor c=0.053419f \
 //x=1.445 //y=5.2 //x2=1.8 //y2=6.2
cc_2288 ( N_VDD_c_3511_n N_D_M19_noxref_g ) capacitor c=0.00755544f //x=2.375 \
 //y=7.585 //x2=2.24 //y2=6.2
cc_2289 ( N_VDD_M19_noxref_d N_D_M19_noxref_g ) capacitor c=0.015318f \
 //x=2.315 //y=5.2 //x2=2.24 //y2=6.2
cc_2290 ( N_VDD_c_3509_n N_D_c_3950_n ) capacitor c=0.00589833f //x=1.23 \
 //y=7.58 //x2=1.875 //y2=4.97
cc_2291 ( N_VDD_M18_noxref_s N_D_c_3950_n ) capacitor c=0.00633126f //x=1.445 \
 //y=5.2 //x2=1.875 //y2=4.97
cc_2292 ( N_VDD_M18_noxref_s N_GND_c_4583_n ) capacitor c=5.21561e-19 \
 //x=1.445 //y=5.2 //x2=1.565 //y2=1.145
cc_2293 ( N_VDD_c_3509_n N_GND_c_4584_n ) capacitor c=0.00989514f //x=1.23 \
 //y=7.58 //x2=1.23 //y2=0.18
cc_2294 ( N_VDD_c_3799_n N_GND_c_4520_n ) capacitor c=0.00989514f //x=28.61 \
 //y=7.58 //x2=28.61 //y2=0.18
cc_2295 ( N_VDD_c_3527_n N_GND_c_4386_n ) capacitor c=0.00897722f //x=5.3 \
 //y=7.585 //x2=5.3 //y2=0.175
cc_2296 ( N_VDD_c_3533_n N_GND_c_4394_n ) capacitor c=0.00648134f //x=10.11 \
 //y=7.585 //x2=10.11 //y2=0.175
cc_2297 ( N_VDD_c_3589_n N_GND_c_4435_n ) capacitor c=0.00648088f //x=14.92 \
 //y=7.585 //x2=14.92 //y2=0.175
cc_2298 ( N_VDD_c_3658_n N_GND_c_4480_n ) capacitor c=0.00663779f //x=19.73 \
 //y=7.585 //x2=19.73 //y2=0.175
cc_2299 ( N_VDD_c_3734_n N_GND_c_4521_n ) capacitor c=0.00654453f //x=24.54 \
 //y=7.585 //x2=24.54 //y2=0.175
cc_2300 ( N_D_c_3936_n N_GND_c_4591_n ) capacitor c=3.97665e-19 //x=1.3 \
 //y=1.055 //x2=1.565 //y2=1.015
cc_2301 ( N_D_c_3965_p N_GND_c_4591_n ) capacitor c=0.00864776f //x=1.675 \
 //y=0.9 //x2=1.565 //y2=1.015
cc_2302 ( N_D_c_3942_n N_GND_c_4591_n ) capacitor c=4.45447e-19 //x=1.83 \
 //y=1.055 //x2=1.565 //y2=1.015
cc_2303 ( N_D_c_3919_n N_GND_c_4583_n ) capacitor c=0.00849742f //x=1.6 \
 //y=2.375 //x2=1.565 //y2=1.145
cc_2304 ( N_D_c_3926_n N_GND_c_4583_n ) capacitor c=2.22883e-19 //x=1.6 \
 //y=2.26 //x2=1.565 //y2=1.145
cc_2305 ( N_D_c_3936_n N_GND_c_4583_n ) capacitor c=0.00142616f //x=1.3 \
 //y=1.055 //x2=1.565 //y2=1.145
cc_2306 ( N_D_c_3937_n N_GND_c_4583_n ) capacitor c=0.00411286f //x=1.3 \
 //y=1.4 //x2=1.565 //y2=1.145
cc_2307 ( N_D_c_3938_n N_GND_c_4583_n ) capacitor c=4.86145e-19 //x=1.3 \
 //y=1.71 //x2=1.565 //y2=1.145
cc_2308 ( N_D_c_3965_p N_GND_c_4583_n ) capacitor c=7.3749e-19 //x=1.675 \
 //y=0.9 //x2=1.565 //y2=1.145
cc_2309 ( N_D_c_3973_p N_GND_c_4583_n ) capacitor c=6.35695e-19 //x=1.675 \
 //y=1.555 //x2=1.565 //y2=1.145
cc_2310 ( N_D_c_3942_n N_GND_c_4583_n ) capacitor c=0.0017438f //x=1.83 \
 //y=1.055 //x2=1.565 //y2=1.145
cc_2311 ( N_D_c_3944_n N_GND_c_4583_n ) capacitor c=0.00276804f //x=1.83 \
 //y=1.4 //x2=1.565 //y2=1.145
cc_2312 ( N_D_c_3936_n N_GND_c_4382_n ) capacitor c=0.00680635f //x=1.3 \
 //y=1.055 //x2=5.13 //y2=0.175
cc_2313 ( D N_GND_c_4584_n ) capacitor c=0.0126319f //x=1.6 //y=2.77 //x2=1.23 \
 //y2=0.18
cc_2314 ( N_D_c_3919_n N_GND_c_4584_n ) capacitor c=0.00779049f //x=1.6 \
 //y=2.375 //x2=1.23 //y2=0.18
cc_2315 ( N_D_c_3926_n N_GND_c_4584_n ) capacitor c=0.00394776f //x=1.6 \
 //y=2.26 //x2=1.23 //y2=0.18
cc_2316 ( N_D_c_3938_n N_GND_c_4584_n ) capacitor c=0.00295461f //x=1.3 \
 //y=1.71 //x2=1.23 //y2=0.18
cc_2317 ( N_D_c_3939_n N_GND_c_4584_n ) capacitor c=0.0112432f //x=1.3 \
 //y=2.095 //x2=1.23 //y2=0.18
cc_2318 ( N_D_c_3919_n N_GND_M0_noxref_d ) capacitor c=4.4417e-19 //x=1.6 \
 //y=2.375 //x2=1.375 //y2=1.055
cc_2319 ( N_D_c_3936_n N_GND_M0_noxref_d ) capacitor c=0.00184354f //x=1.3 \
 //y=1.055 //x2=1.375 //y2=1.055
cc_2320 ( N_D_c_3937_n N_GND_M0_noxref_d ) capacitor c=0.00210798f //x=1.3 \
 //y=1.4 //x2=1.375 //y2=1.055
cc_2321 ( N_D_c_3965_p N_GND_M0_noxref_d ) capacitor c=0.00474029f //x=1.675 \
 //y=0.9 //x2=1.375 //y2=1.055
cc_2322 ( N_D_c_3973_p N_GND_M0_noxref_d ) capacitor c=0.00166857f //x=1.675 \
 //y=1.555 //x2=1.375 //y2=1.055
cc_2323 ( N_D_c_3942_n N_GND_M0_noxref_d ) capacitor c=0.00230174f //x=1.83 \
 //y=1.055 //x2=1.375 //y2=1.055
cc_2324 ( N_D_c_3944_n N_GND_M0_noxref_d ) capacitor c=0.00210798f //x=1.83 \
 //y=1.4 //x2=1.375 //y2=1.055
cc_2325 ( N_D_c_3939_n N_noxref_19_c_4907_n ) capacitor c=0.00267608f //x=1.3 \
 //y=2.095 //x2=1.08 //y2=1.685
cc_2326 ( N_D_c_3919_n N_noxref_19_c_4908_n ) capacitor c=0.00428451f //x=1.6 \
 //y=2.375 //x2=1.965 //y2=1.77
cc_2327 ( N_D_c_3922_n N_noxref_19_c_4908_n ) capacitor c=3.1252e-19 //x=1.6 \
 //y=4.755 //x2=1.965 //y2=1.77
cc_2328 ( N_D_c_3926_n N_noxref_19_c_4908_n ) capacitor c=0.0104666f //x=1.6 \
 //y=2.26 //x2=1.965 //y2=1.77
cc_2329 ( N_D_c_3938_n N_noxref_19_c_4908_n ) capacitor c=0.00703864f //x=1.3 \
 //y=1.71 //x2=1.965 //y2=1.77
cc_2330 ( N_D_c_3939_n N_noxref_19_c_4908_n ) capacitor c=0.0232409f //x=1.3 \
 //y=2.095 //x2=1.965 //y2=1.77
cc_2331 ( N_D_c_3973_p N_noxref_19_c_4908_n ) capacitor c=0.00588627f \
 //x=1.675 //y=1.555 //x2=1.965 //y2=1.77
cc_2332 ( N_D_c_3944_n N_noxref_19_c_4908_n ) capacitor c=0.00758305f //x=1.83 \
 //y=1.4 //x2=1.965 //y2=1.77
cc_2333 ( N_D_c_3936_n N_noxref_19_M0_noxref_s ) capacitor c=0.0295256f \
 //x=1.3 //y=1.055 //x2=0.945 //y2=0.555
cc_2334 ( N_D_c_3938_n N_noxref_19_M0_noxref_s ) capacitor c=7.99997e-19 \
 //x=1.3 //y=1.71 //x2=0.945 //y2=0.555
cc_2335 ( N_D_c_3939_n N_noxref_19_M0_noxref_s ) capacitor c=0.00122123f \
 //x=1.3 //y=2.095 //x2=0.945 //y2=0.555
cc_2336 ( N_D_c_3942_n N_noxref_19_M0_noxref_s ) capacitor c=0.0125924f \
 //x=1.83 //y=1.055 //x2=0.945 //y2=0.555
cc_2337 ( N_noxref_12_c_4022_n N_GND_c_4349_n ) capacitor c=0.0079063f \
 //x=3.505 //y=1.175 //x2=6.29 //y2=0.175
cc_2338 ( N_noxref_12_c_4038_p N_GND_c_4349_n ) capacitor c=0.00674228f \
 //x=3.59 //y=0.805 //x2=6.29 //y2=0.175
cc_2339 ( N_noxref_12_c_4001_n N_GND_c_4349_n ) capacitor c=0.00960819f \
 //x=4.475 //y=0.72 //x2=6.29 //y2=0.175
cc_2340 ( N_noxref_12_c_4040_p N_GND_c_4349_n ) capacitor c=0.00232964f \
 //x=4.56 //y=0.805 //x2=6.29 //y2=0.175
cc_2341 ( N_noxref_12_M1_noxref_d N_GND_c_4349_n ) capacitor c=0.0134285f \
 //x=2.35 //y=1.09 //x2=6.29 //y2=0.175
cc_2342 ( N_noxref_12_M1_noxref_d N_GND_c_4583_n ) capacitor c=0.0156367f \
 //x=2.35 //y=1.09 //x2=1.565 //y2=1.145
cc_2343 ( N_noxref_12_c_4022_n N_GND_c_4382_n ) capacitor c=0.0080792f \
 //x=3.505 //y=1.175 //x2=5.13 //y2=0.175
cc_2344 ( N_noxref_12_c_4038_p N_GND_c_4382_n ) capacitor c=0.0140604f \
 //x=3.59 //y=0.805 //x2=5.13 //y2=0.175
cc_2345 ( N_noxref_12_c_4001_n N_GND_c_4382_n ) capacitor c=0.0364637f \
 //x=4.475 //y=0.72 //x2=5.13 //y2=0.175
cc_2346 ( N_noxref_12_c_4040_p N_GND_c_4382_n ) capacitor c=0.013886f //x=4.56 \
 //y=0.805 //x2=5.13 //y2=0.175
cc_2347 ( N_noxref_12_M2_noxref_s N_GND_c_4584_n ) capacitor c=8.16352e-19 \
 //x=3.455 //y=0.555 //x2=1.23 //y2=0.18
cc_2348 ( N_noxref_12_c_4022_n N_GND_c_4520_n ) capacitor c=3.54249e-19 \
 //x=3.505 //y=1.175 //x2=28.61 //y2=0.18
cc_2349 ( N_noxref_12_c_4001_n N_GND_c_4520_n ) capacitor c=0.00283214f \
 //x=4.475 //y=0.72 //x2=28.61 //y2=0.18
cc_2350 ( N_noxref_12_M1_noxref_d N_GND_c_4520_n ) capacitor c=2.7648e-19 \
 //x=2.35 //y=1.09 //x2=28.61 //y2=0.18
cc_2351 ( N_noxref_12_c_4040_p N_GND_c_4386_n ) capacitor c=0.037873f //x=4.56 \
 //y=0.805 //x2=5.3 //y2=0.175
cc_2352 ( N_noxref_12_M2_noxref_s N_GND_c_4386_n ) capacitor c=0.0051897f \
 //x=3.455 //y=0.555 //x2=5.3 //y2=0.175
cc_2353 ( N_noxref_12_M1_noxref_d N_GND_M0_noxref_d ) capacitor c=3.12752e-19 \
 //x=2.35 //y=1.09 //x2=1.375 //y2=1.055
cc_2354 ( N_noxref_12_c_4038_p N_noxref_19_c_4919_n ) capacitor c=2.15937e-19 \
 //x=3.59 //y=0.805 //x2=2.05 //y2=0.805
cc_2355 ( N_noxref_12_c_4022_n N_noxref_19_c_4897_n ) capacitor c=0.0132582f \
 //x=3.505 //y=1.175 //x2=2.935 //y2=0.72
cc_2356 ( N_noxref_12_M1_noxref_d N_noxref_19_c_4897_n ) capacitor c=0.016458f \
 //x=2.35 //y=1.09 //x2=2.935 //y2=0.72
cc_2357 ( N_noxref_12_c_4022_n N_noxref_19_c_4899_n ) capacitor c=0.00954209f \
 //x=3.505 //y=1.175 //x2=2.935 //y2=1.77
cc_2358 ( N_noxref_12_M1_noxref_d N_noxref_19_c_4899_n ) capacitor \
 c=0.0152717f //x=2.35 //y=1.09 //x2=2.935 //y2=1.77
cc_2359 ( N_noxref_12_c_4022_n N_noxref_19_M0_noxref_s ) capacitor c=0.023368f \
 //x=3.505 //y=1.175 //x2=0.945 //y2=0.555
cc_2360 ( N_noxref_12_c_4038_p N_noxref_19_M0_noxref_s ) capacitor \
 c=0.0175461f //x=3.59 //y=0.805 //x2=0.945 //y2=0.555
cc_2361 ( N_noxref_12_c_4040_p N_noxref_19_M0_noxref_s ) capacitor \
 c=2.98576e-19 //x=4.56 //y=0.805 //x2=0.945 //y2=0.555
cc_2362 ( N_noxref_12_M1_noxref_d N_noxref_19_M0_noxref_s ) capacitor \
 c=0.0187969f //x=2.35 //y=1.09 //x2=0.945 //y2=0.555
cc_2363 ( N_noxref_12_M2_noxref_s N_noxref_19_M0_noxref_s ) capacitor \
 c=0.0210819f //x=3.455 //y=0.555 //x2=0.945 //y2=0.555
cc_2364 ( N_noxref_12_c_4040_p N_noxref_20_M3_noxref_s ) capacitor \
 c=0.00368328f //x=4.56 //y=0.805 //x2=5.755 //y2=0.555
cc_2365 ( N_noxref_12_M2_noxref_s N_noxref_20_M3_noxref_s ) capacitor \
 c=0.00125282f //x=3.455 //y=0.555 //x2=5.755 //y2=0.555
cc_2366 ( N_noxref_13_c_4066_n N_GND_c_4450_n ) capacitor c=0.00533679f \
 //x=8.315 //y=1.175 //x2=11.1 //y2=0.175
cc_2367 ( N_noxref_13_c_4107_p N_GND_c_4450_n ) capacitor c=0.00694933f \
 //x=8.4 //y=0.805 //x2=11.1 //y2=0.175
cc_2368 ( N_noxref_13_c_4085_n N_GND_c_4450_n ) capacitor c=0.0100712f \
 //x=9.285 //y=0.72 //x2=11.1 //y2=0.175
cc_2369 ( N_noxref_13_c_4109_p N_GND_c_4450_n ) capacitor c=0.00232964f \
 //x=9.37 //y=0.805 //x2=11.1 //y2=0.175
cc_2370 ( N_noxref_13_M4_noxref_d N_GND_c_4450_n ) capacitor c=0.0134285f \
 //x=7.16 //y=1.09 //x2=11.1 //y2=0.175
cc_2371 ( N_noxref_13_M4_noxref_d N_GND_c_4359_n ) capacitor c=0.0154456f \
 //x=7.16 //y=1.09 //x2=6.375 //y2=1.145
cc_2372 ( N_noxref_13_c_4066_n N_GND_c_4384_n ) capacitor c=0.0080792f \
 //x=8.315 //y=1.175 //x2=9.94 //y2=0.175
cc_2373 ( N_noxref_13_c_4107_p N_GND_c_4384_n ) capacitor c=0.0140604f //x=8.4 \
 //y=0.805 //x2=9.94 //y2=0.175
cc_2374 ( N_noxref_13_c_4085_n N_GND_c_4384_n ) capacitor c=0.0364637f \
 //x=9.285 //y=0.72 //x2=9.94 //y2=0.175
cc_2375 ( N_noxref_13_c_4109_p N_GND_c_4384_n ) capacitor c=0.013886f //x=9.37 \
 //y=0.805 //x2=9.94 //y2=0.175
cc_2376 ( N_noxref_13_c_4066_n N_GND_c_4520_n ) capacitor c=3.54249e-19 \
 //x=8.315 //y=1.175 //x2=28.61 //y2=0.18
cc_2377 ( N_noxref_13_c_4085_n N_GND_c_4520_n ) capacitor c=0.00283214f \
 //x=9.285 //y=0.72 //x2=28.61 //y2=0.18
cc_2378 ( N_noxref_13_M4_noxref_d N_GND_c_4520_n ) capacitor c=2.7648e-19 \
 //x=7.16 //y=1.09 //x2=28.61 //y2=0.18
cc_2379 ( N_noxref_13_M5_noxref_s N_GND_c_4386_n ) capacitor c=8.16352e-19 \
 //x=8.265 //y=0.555 //x2=5.3 //y2=0.175
cc_2380 ( N_noxref_13_c_4109_p N_GND_c_4394_n ) capacitor c=0.037873f //x=9.37 \
 //y=0.805 //x2=10.11 //y2=0.175
cc_2381 ( N_noxref_13_M5_noxref_s N_GND_c_4394_n ) capacitor c=0.0051897f \
 //x=8.265 //y=0.555 //x2=10.11 //y2=0.175
cc_2382 ( N_noxref_13_M4_noxref_d N_GND_M3_noxref_d ) capacitor c=3.12752e-19 \
 //x=7.16 //y=1.09 //x2=6.185 //y2=1.055
cc_2383 ( N_noxref_13_c_4107_p N_noxref_20_c_4980_n ) capacitor c=2.15937e-19 \
 //x=8.4 //y=0.805 //x2=6.86 //y2=0.805
cc_2384 ( N_noxref_13_c_4066_n N_noxref_20_c_4967_n ) capacitor c=0.0131399f \
 //x=8.315 //y=1.175 //x2=7.745 //y2=0.72
cc_2385 ( N_noxref_13_M4_noxref_d N_noxref_20_c_4967_n ) capacitor \
 c=0.0160925f //x=7.16 //y=1.09 //x2=7.745 //y2=0.72
cc_2386 ( N_noxref_13_c_4066_n N_noxref_20_c_4960_n ) capacitor c=0.00950181f \
 //x=8.315 //y=1.175 //x2=7.745 //y2=1.77
cc_2387 ( N_noxref_13_M4_noxref_d N_noxref_20_c_4960_n ) capacitor \
 c=0.0151931f //x=7.16 //y=1.09 //x2=7.745 //y2=1.77
cc_2388 ( N_noxref_13_c_4066_n N_noxref_20_M3_noxref_s ) capacitor c=0.023093f \
 //x=8.315 //y=1.175 //x2=5.755 //y2=0.555
cc_2389 ( N_noxref_13_c_4107_p N_noxref_20_M3_noxref_s ) capacitor \
 c=0.0175461f //x=8.4 //y=0.805 //x2=5.755 //y2=0.555
cc_2390 ( N_noxref_13_c_4109_p N_noxref_20_M3_noxref_s ) capacitor \
 c=2.98576e-19 //x=9.37 //y=0.805 //x2=5.755 //y2=0.555
cc_2391 ( N_noxref_13_M4_noxref_d N_noxref_20_M3_noxref_s ) capacitor \
 c=0.0187685f //x=7.16 //y=1.09 //x2=5.755 //y2=0.555
cc_2392 ( N_noxref_13_M5_noxref_s N_noxref_20_M3_noxref_s ) capacitor \
 c=0.0210819f //x=8.265 //y=0.555 //x2=5.755 //y2=0.555
cc_2393 ( N_noxref_13_c_4109_p N_noxref_21_M6_noxref_s ) capacitor \
 c=0.00368328f //x=9.37 //y=0.805 //x2=10.565 //y2=0.555
cc_2394 ( N_noxref_13_M5_noxref_s N_noxref_21_M6_noxref_s ) capacitor \
 c=0.00125282f //x=8.265 //y=0.555 //x2=10.565 //y2=0.555
cc_2395 ( N_noxref_14_c_4147_n N_GND_c_4414_n ) capacitor c=0.00533679f \
 //x=13.125 //y=1.175 //x2=15.91 //y2=0.175
cc_2396 ( N_noxref_14_c_4179_p N_GND_c_4414_n ) capacitor c=0.00616045f \
 //x=13.21 //y=0.805 //x2=15.91 //y2=0.175
cc_2397 ( N_noxref_14_c_4135_n N_GND_c_4414_n ) capacitor c=0.00963192f \
 //x=14.095 //y=0.72 //x2=15.91 //y2=0.175
cc_2398 ( N_noxref_14_c_4181_p N_GND_c_4414_n ) capacitor c=0.00232964f \
 //x=14.18 //y=0.805 //x2=15.91 //y2=0.175
cc_2399 ( N_noxref_14_M7_noxref_d N_GND_c_4414_n ) capacitor c=0.0134285f \
 //x=11.97 //y=1.09 //x2=15.91 //y2=0.175
cc_2400 ( N_noxref_14_M7_noxref_d N_GND_c_4371_n ) capacitor c=0.0154456f \
 //x=11.97 //y=1.09 //x2=11.185 //y2=1.145
cc_2401 ( N_noxref_14_c_4147_n N_GND_c_4385_n ) capacitor c=0.0080792f \
 //x=13.125 //y=1.175 //x2=14.75 //y2=0.175
cc_2402 ( N_noxref_14_c_4179_p N_GND_c_4385_n ) capacitor c=0.0140604f \
 //x=13.21 //y=0.805 //x2=14.75 //y2=0.175
cc_2403 ( N_noxref_14_c_4135_n N_GND_c_4385_n ) capacitor c=0.0364637f \
 //x=14.095 //y=0.72 //x2=14.75 //y2=0.175
cc_2404 ( N_noxref_14_c_4181_p N_GND_c_4385_n ) capacitor c=0.013886f \
 //x=14.18 //y=0.805 //x2=14.75 //y2=0.175
cc_2405 ( N_noxref_14_c_4147_n N_GND_c_4520_n ) capacitor c=3.54249e-19 \
 //x=13.125 //y=1.175 //x2=28.61 //y2=0.18
cc_2406 ( N_noxref_14_c_4135_n N_GND_c_4520_n ) capacitor c=0.00283214f \
 //x=14.095 //y=0.72 //x2=28.61 //y2=0.18
cc_2407 ( N_noxref_14_M7_noxref_d N_GND_c_4520_n ) capacitor c=2.7648e-19 \
 //x=11.97 //y=1.09 //x2=28.61 //y2=0.18
cc_2408 ( N_noxref_14_M8_noxref_s N_GND_c_4394_n ) capacitor c=8.16352e-19 \
 //x=13.075 //y=0.555 //x2=10.11 //y2=0.175
cc_2409 ( N_noxref_14_c_4181_p N_GND_c_4435_n ) capacitor c=0.037873f \
 //x=14.18 //y=0.805 //x2=14.92 //y2=0.175
cc_2410 ( N_noxref_14_M8_noxref_s N_GND_c_4435_n ) capacitor c=0.0051897f \
 //x=13.075 //y=0.555 //x2=14.92 //y2=0.175
cc_2411 ( N_noxref_14_M7_noxref_d N_GND_M6_noxref_d ) capacitor c=3.12752e-19 \
 //x=11.97 //y=1.09 //x2=10.995 //y2=1.055
cc_2412 ( N_noxref_14_c_4179_p N_noxref_21_c_5041_n ) capacitor c=2.15937e-19 \
 //x=13.21 //y=0.805 //x2=11.67 //y2=0.805
cc_2413 ( N_noxref_14_c_4147_n N_noxref_21_c_5027_n ) capacitor c=0.0130946f \
 //x=13.125 //y=1.175 //x2=12.555 //y2=0.72
cc_2414 ( N_noxref_14_M7_noxref_d N_noxref_21_c_5027_n ) capacitor \
 c=0.0162022f //x=11.97 //y=1.09 //x2=12.555 //y2=0.72
cc_2415 ( N_noxref_14_c_4147_n N_noxref_21_c_5025_n ) capacitor c=0.00944608f \
 //x=13.125 //y=1.175 //x2=12.555 //y2=1.77
cc_2416 ( N_noxref_14_M7_noxref_d N_noxref_21_c_5025_n ) capacitor \
 c=0.0151527f //x=11.97 //y=1.09 //x2=12.555 //y2=1.77
cc_2417 ( N_noxref_14_c_4147_n N_noxref_21_M6_noxref_s ) capacitor \
 c=0.0225369f //x=13.125 //y=1.175 //x2=10.565 //y2=0.555
cc_2418 ( N_noxref_14_c_4179_p N_noxref_21_M6_noxref_s ) capacitor \
 c=0.0175461f //x=13.21 //y=0.805 //x2=10.565 //y2=0.555
cc_2419 ( N_noxref_14_c_4181_p N_noxref_21_M6_noxref_s ) capacitor \
 c=2.98576e-19 //x=14.18 //y=0.805 //x2=10.565 //y2=0.555
cc_2420 ( N_noxref_14_M7_noxref_d N_noxref_21_M6_noxref_s ) capacitor \
 c=0.0187685f //x=11.97 //y=1.09 //x2=10.565 //y2=0.555
cc_2421 ( N_noxref_14_M8_noxref_s N_noxref_21_M6_noxref_s ) capacitor \
 c=0.0210819f //x=13.075 //y=0.555 //x2=10.565 //y2=0.555
cc_2422 ( N_noxref_14_c_4181_p N_noxref_22_M9_noxref_s ) capacitor \
 c=0.00368328f //x=14.18 //y=0.805 //x2=15.375 //y2=0.555
cc_2423 ( N_noxref_14_M8_noxref_s N_noxref_22_M9_noxref_s ) capacitor \
 c=0.00125282f //x=13.075 //y=0.555 //x2=15.375 //y2=0.555
cc_2424 ( N_noxref_15_c_4208_n N_GND_c_4452_n ) capacitor c=0.00533679f \
 //x=17.935 //y=1.175 //x2=20.72 //y2=0.175
cc_2425 ( N_noxref_15_c_4250_p N_GND_c_4452_n ) capacitor c=0.00700064f \
 //x=18.02 //y=0.805 //x2=20.72 //y2=0.175
cc_2426 ( N_noxref_15_c_4224_n N_GND_c_4452_n ) capacitor c=0.00966657f \
 //x=18.905 //y=0.72 //x2=20.72 //y2=0.175
cc_2427 ( N_noxref_15_c_4252_p N_GND_c_4452_n ) capacitor c=0.00232964f \
 //x=18.99 //y=0.805 //x2=20.72 //y2=0.175
cc_2428 ( N_noxref_15_M10_noxref_d N_GND_c_4452_n ) capacitor c=0.0134285f \
 //x=16.78 //y=1.09 //x2=20.72 //y2=0.175
cc_2429 ( N_noxref_15_M10_noxref_d N_GND_c_4421_n ) capacitor c=0.0154456f \
 //x=16.78 //y=1.09 //x2=15.995 //y2=1.145
cc_2430 ( N_noxref_15_c_4208_n N_GND_c_4434_n ) capacitor c=0.0080792f \
 //x=17.935 //y=1.175 //x2=19.56 //y2=0.175
cc_2431 ( N_noxref_15_c_4250_p N_GND_c_4434_n ) capacitor c=0.0140604f \
 //x=18.02 //y=0.805 //x2=19.56 //y2=0.175
cc_2432 ( N_noxref_15_c_4224_n N_GND_c_4434_n ) capacitor c=0.0364637f \
 //x=18.905 //y=0.72 //x2=19.56 //y2=0.175
cc_2433 ( N_noxref_15_c_4252_p N_GND_c_4434_n ) capacitor c=0.013886f \
 //x=18.99 //y=0.805 //x2=19.56 //y2=0.175
cc_2434 ( N_noxref_15_c_4208_n N_GND_c_4520_n ) capacitor c=3.54249e-19 \
 //x=17.935 //y=1.175 //x2=28.61 //y2=0.18
cc_2435 ( N_noxref_15_c_4224_n N_GND_c_4520_n ) capacitor c=0.00283214f \
 //x=18.905 //y=0.72 //x2=28.61 //y2=0.18
cc_2436 ( N_noxref_15_M10_noxref_d N_GND_c_4520_n ) capacitor c=2.7648e-19 \
 //x=16.78 //y=1.09 //x2=28.61 //y2=0.18
cc_2437 ( N_noxref_15_M11_noxref_s N_GND_c_4435_n ) capacitor c=8.16352e-19 \
 //x=17.885 //y=0.555 //x2=14.92 //y2=0.175
cc_2438 ( N_noxref_15_c_4252_p N_GND_c_4480_n ) capacitor c=0.037873f \
 //x=18.99 //y=0.805 //x2=19.73 //y2=0.175
cc_2439 ( N_noxref_15_M11_noxref_s N_GND_c_4480_n ) capacitor c=0.0051897f \
 //x=17.885 //y=0.555 //x2=19.73 //y2=0.175
cc_2440 ( N_noxref_15_M10_noxref_d N_GND_M9_noxref_d ) capacitor c=3.12752e-19 \
 //x=16.78 //y=1.09 //x2=15.805 //y2=1.055
cc_2441 ( N_noxref_15_c_4250_p N_noxref_22_c_5100_n ) capacitor c=2.15937e-19 \
 //x=18.02 //y=0.805 //x2=16.48 //y2=0.805
cc_2442 ( N_noxref_15_c_4208_n N_noxref_22_c_5083_n ) capacitor c=0.0131134f \
 //x=17.935 //y=1.175 //x2=17.365 //y2=0.72
cc_2443 ( N_noxref_15_M10_noxref_d N_noxref_22_c_5083_n ) capacitor \
 c=0.0160925f //x=16.78 //y=1.09 //x2=17.365 //y2=0.72
cc_2444 ( N_noxref_15_c_4208_n N_noxref_22_c_5085_n ) capacitor c=0.00947943f \
 //x=17.935 //y=1.175 //x2=17.365 //y2=1.77
cc_2445 ( N_noxref_15_M10_noxref_d N_noxref_22_c_5085_n ) capacitor \
 c=0.0149813f //x=16.78 //y=1.09 //x2=17.365 //y2=1.77
cc_2446 ( N_noxref_15_c_4208_n N_noxref_22_M9_noxref_s ) capacitor \
 c=0.0225712f //x=17.935 //y=1.175 //x2=15.375 //y2=0.555
cc_2447 ( N_noxref_15_c_4250_p N_noxref_22_M9_noxref_s ) capacitor \
 c=0.0175461f //x=18.02 //y=0.805 //x2=15.375 //y2=0.555
cc_2448 ( N_noxref_15_c_4252_p N_noxref_22_M9_noxref_s ) capacitor \
 c=2.98576e-19 //x=18.99 //y=0.805 //x2=15.375 //y2=0.555
cc_2449 ( N_noxref_15_M10_noxref_d N_noxref_22_M9_noxref_s ) capacitor \
 c=0.0187685f //x=16.78 //y=1.09 //x2=15.375 //y2=0.555
cc_2450 ( N_noxref_15_M11_noxref_s N_noxref_22_M9_noxref_s ) capacitor \
 c=0.0210819f //x=17.885 //y=0.555 //x2=15.375 //y2=0.555
cc_2451 ( N_noxref_15_c_4252_p N_noxref_23_M12_noxref_s ) capacitor \
 c=0.00368328f //x=18.99 //y=0.805 //x2=20.185 //y2=0.555
cc_2452 ( N_noxref_15_M11_noxref_s N_noxref_23_M12_noxref_s ) capacitor \
 c=0.00125282f //x=17.885 //y=0.555 //x2=20.185 //y2=0.555
cc_2453 ( N_noxref_16_c_4278_n N_GND_c_4495_n ) capacitor c=0.00533679f \
 //x=22.745 //y=1.175 //x2=25.53 //y2=0.175
cc_2454 ( N_noxref_16_c_4321_p N_GND_c_4495_n ) capacitor c=0.00649717f \
 //x=22.83 //y=0.805 //x2=25.53 //y2=0.175
cc_2455 ( N_noxref_16_c_4293_n N_GND_c_4495_n ) capacitor c=0.0096072f \
 //x=23.715 //y=0.72 //x2=25.53 //y2=0.175
cc_2456 ( N_noxref_16_c_4323_p N_GND_c_4495_n ) capacitor c=0.00232964f \
 //x=23.8 //y=0.805 //x2=25.53 //y2=0.175
cc_2457 ( N_noxref_16_M13_noxref_d N_GND_c_4495_n ) capacitor c=0.0134285f \
 //x=21.59 //y=1.09 //x2=25.53 //y2=0.175
cc_2458 ( N_noxref_16_M13_noxref_d N_GND_c_4462_n ) capacitor c=0.0154456f \
 //x=21.59 //y=1.09 //x2=20.805 //y2=1.145
cc_2459 ( N_noxref_16_c_4278_n N_GND_c_4474_n ) capacitor c=0.0080792f \
 //x=22.745 //y=1.175 //x2=24.37 //y2=0.175
cc_2460 ( N_noxref_16_c_4321_p N_GND_c_4474_n ) capacitor c=0.0140604f \
 //x=22.83 //y=0.805 //x2=24.37 //y2=0.175
cc_2461 ( N_noxref_16_c_4293_n N_GND_c_4474_n ) capacitor c=0.0364637f \
 //x=23.715 //y=0.72 //x2=24.37 //y2=0.175
cc_2462 ( N_noxref_16_c_4323_p N_GND_c_4474_n ) capacitor c=0.013886f //x=23.8 \
 //y=0.805 //x2=24.37 //y2=0.175
cc_2463 ( N_noxref_16_c_4278_n N_GND_c_4520_n ) capacitor c=3.54249e-19 \
 //x=22.745 //y=1.175 //x2=28.61 //y2=0.18
cc_2464 ( N_noxref_16_c_4293_n N_GND_c_4520_n ) capacitor c=0.00283214f \
 //x=23.715 //y=0.72 //x2=28.61 //y2=0.18
cc_2465 ( N_noxref_16_M13_noxref_d N_GND_c_4520_n ) capacitor c=2.7648e-19 \
 //x=21.59 //y=1.09 //x2=28.61 //y2=0.18
cc_2466 ( N_noxref_16_M14_noxref_s N_GND_c_4480_n ) capacitor c=8.16352e-19 \
 //x=22.695 //y=0.555 //x2=19.73 //y2=0.175
cc_2467 ( N_noxref_16_c_4323_p N_GND_c_4521_n ) capacitor c=0.037873f //x=23.8 \
 //y=0.805 //x2=24.54 //y2=0.175
cc_2468 ( N_noxref_16_M14_noxref_s N_GND_c_4521_n ) capacitor c=0.0051897f \
 //x=22.695 //y=0.555 //x2=24.54 //y2=0.175
cc_2469 ( N_noxref_16_M13_noxref_d N_GND_M12_noxref_d ) capacitor \
 c=3.12752e-19 //x=21.59 //y=1.09 //x2=20.615 //y2=1.055
cc_2470 ( N_noxref_16_c_4321_p N_noxref_23_c_5158_n ) capacitor c=2.15937e-19 \
 //x=22.83 //y=0.805 //x2=21.29 //y2=0.805
cc_2471 ( N_noxref_16_c_4278_n N_noxref_23_c_5142_n ) capacitor c=0.0131134f \
 //x=22.745 //y=1.175 //x2=22.175 //y2=0.72
cc_2472 ( N_noxref_16_M13_noxref_d N_noxref_23_c_5142_n ) capacitor \
 c=0.0160925f //x=21.59 //y=1.09 //x2=22.175 //y2=0.72
cc_2473 ( N_noxref_16_c_4278_n N_noxref_23_c_5144_n ) capacitor c=0.00947943f \
 //x=22.745 //y=1.175 //x2=22.175 //y2=1.77
cc_2474 ( N_noxref_16_M13_noxref_d N_noxref_23_c_5144_n ) capacitor \
 c=0.0152676f //x=21.59 //y=1.09 //x2=22.175 //y2=1.77
cc_2475 ( N_noxref_16_c_4278_n N_noxref_23_M12_noxref_s ) capacitor \
 c=0.0225712f //x=22.745 //y=1.175 //x2=20.185 //y2=0.555
cc_2476 ( N_noxref_16_c_4321_p N_noxref_23_M12_noxref_s ) capacitor \
 c=0.0175461f //x=22.83 //y=0.805 //x2=20.185 //y2=0.555
cc_2477 ( N_noxref_16_c_4323_p N_noxref_23_M12_noxref_s ) capacitor \
 c=2.98576e-19 //x=23.8 //y=0.805 //x2=20.185 //y2=0.555
cc_2478 ( N_noxref_16_M13_noxref_d N_noxref_23_M12_noxref_s ) capacitor \
 c=0.0187685f //x=21.59 //y=1.09 //x2=20.185 //y2=0.555
cc_2479 ( N_noxref_16_M14_noxref_s N_noxref_23_M12_noxref_s ) capacitor \
 c=0.0210819f //x=22.695 //y=0.555 //x2=20.185 //y2=0.555
cc_2480 ( N_noxref_16_c_4323_p N_noxref_24_M15_noxref_s ) capacitor \
 c=0.00368328f //x=23.8 //y=0.805 //x2=24.995 //y2=0.555
cc_2481 ( N_noxref_16_M14_noxref_s N_noxref_24_M15_noxref_s ) capacitor \
 c=0.00125282f //x=22.695 //y=0.555 //x2=24.995 //y2=0.555
cc_2482 ( N_GND_c_4538_n N_noxref_18_c_4834_n ) capacitor c=0.0079063f \
 //x=28.61 //y=0.18 //x2=27.555 //y2=1.175
cc_2483 ( N_GND_c_4520_n N_noxref_18_c_4834_n ) capacitor c=0.00843344f \
 //x=28.61 //y=0.18 //x2=27.555 //y2=1.175
cc_2484 ( N_GND_c_4538_n N_noxref_18_c_4876_n ) capacitor c=0.00616126f \
 //x=28.61 //y=0.18 //x2=27.64 //y2=0.805
cc_2485 ( N_GND_c_4520_n N_noxref_18_c_4876_n ) capacitor c=0.0140604f \
 //x=28.61 //y=0.18 //x2=27.64 //y2=0.805
cc_2486 ( N_GND_c_4538_n N_noxref_18_c_4851_n ) capacitor c=0.0100722f \
 //x=28.61 //y=0.18 //x2=28.525 //y2=0.72
cc_2487 ( N_GND_c_4520_n N_noxref_18_c_4851_n ) capacitor c=0.0392958f \
 //x=28.61 //y=0.18 //x2=28.525 //y2=0.72
cc_2488 ( N_GND_c_4538_n N_noxref_18_c_4880_n ) capacitor c=0.00232964f \
 //x=28.61 //y=0.18 //x2=28.61 //y2=0.805
cc_2489 ( N_GND_c_4520_n N_noxref_18_c_4880_n ) capacitor c=0.0541549f \
 //x=28.61 //y=0.18 //x2=28.61 //y2=0.805
cc_2490 ( N_GND_c_4538_n N_noxref_18_M16_noxref_d ) capacitor c=0.0134285f \
 //x=28.61 //y=0.18 //x2=26.4 //y2=1.09
cc_2491 ( N_GND_c_4507_n N_noxref_18_M16_noxref_d ) capacitor c=0.0154456f \
 //x=25.615 //y=1.145 //x2=26.4 //y2=1.09
cc_2492 ( N_GND_c_4520_n N_noxref_18_M16_noxref_d ) capacitor c=2.7648e-19 \
 //x=28.61 //y=0.18 //x2=26.4 //y2=1.09
cc_2493 ( N_GND_M15_noxref_d N_noxref_18_M16_noxref_d ) capacitor \
 c=3.12752e-19 //x=25.425 //y=1.055 //x2=26.4 //y2=1.09
cc_2494 ( N_GND_c_4520_n N_noxref_18_M17_noxref_s ) capacitor c=0.00532909f \
 //x=28.61 //y=0.18 //x2=27.505 //y2=0.555
cc_2495 ( N_GND_c_4521_n N_noxref_18_M17_noxref_s ) capacitor c=8.16352e-19 \
 //x=24.54 //y=0.175 //x2=27.505 //y2=0.555
cc_2496 ( N_GND_c_4715_p N_noxref_19_c_4908_n ) capacitor c=0.00293992f \
 //x=1.48 //y=0.175 //x2=1.965 //y2=1.77
cc_2497 ( N_GND_c_4349_n N_noxref_19_c_4908_n ) capacitor c=7.69197e-19 \
 //x=6.29 //y=0.175 //x2=1.965 //y2=1.77
cc_2498 ( N_GND_c_4583_n N_noxref_19_c_4908_n ) capacitor c=0.00388652f \
 //x=1.565 //y=1.145 //x2=1.965 //y2=1.77
cc_2499 ( N_GND_c_4382_n N_noxref_19_c_4908_n ) capacitor c=0.00402452f \
 //x=5.13 //y=0.175 //x2=1.965 //y2=1.77
cc_2500 ( N_GND_M0_noxref_d N_noxref_19_c_4908_n ) capacitor c=0.00578031f \
 //x=1.375 //y=1.055 //x2=1.965 //y2=1.77
cc_2501 ( N_GND_c_4591_n N_noxref_19_c_4919_n ) capacitor c=0.0169052f \
 //x=1.565 //y=1.015 //x2=2.05 //y2=0.805
cc_2502 ( N_GND_c_4349_n N_noxref_19_c_4919_n ) capacitor c=0.00710913f \
 //x=6.29 //y=0.175 //x2=2.05 //y2=0.805
cc_2503 ( N_GND_c_4382_n N_noxref_19_c_4919_n ) capacitor c=0.0140604f \
 //x=5.13 //y=0.175 //x2=2.05 //y2=0.805
cc_2504 ( N_GND_c_4584_n N_noxref_19_c_4919_n ) capacitor c=0.00323118f \
 //x=1.23 //y=0.18 //x2=2.05 //y2=0.805
cc_2505 ( N_GND_c_4349_n N_noxref_19_c_4897_n ) capacitor c=0.0138332f \
 //x=6.29 //y=0.175 //x2=2.935 //y2=0.72
cc_2506 ( N_GND_c_4382_n N_noxref_19_c_4897_n ) capacitor c=0.0356451f \
 //x=5.13 //y=0.175 //x2=2.935 //y2=0.72
cc_2507 ( N_GND_c_4520_n N_noxref_19_c_4897_n ) capacitor c=0.00265129f \
 //x=28.61 //y=0.18 //x2=2.935 //y2=0.72
cc_2508 ( N_GND_c_4715_p N_noxref_19_M0_noxref_s ) capacitor c=0.00710913f \
 //x=1.48 //y=0.175 //x2=0.945 //y2=0.555
cc_2509 ( N_GND_c_4591_n N_noxref_19_M0_noxref_s ) capacitor c=0.0173062f \
 //x=1.565 //y=1.015 //x2=0.945 //y2=0.555
cc_2510 ( N_GND_c_4349_n N_noxref_19_M0_noxref_s ) capacitor c=0.00683407f \
 //x=6.29 //y=0.175 //x2=0.945 //y2=0.555
cc_2511 ( N_GND_c_4583_n N_noxref_19_M0_noxref_s ) capacitor c=0.0113024f \
 //x=1.565 //y=1.145 //x2=0.945 //y2=0.555
cc_2512 ( N_GND_c_4382_n N_noxref_19_M0_noxref_s ) capacitor c=0.0272246f \
 //x=5.13 //y=0.175 //x2=0.945 //y2=0.555
cc_2513 ( N_GND_c_4584_n N_noxref_19_M0_noxref_s ) capacitor c=0.0675506f \
 //x=1.23 //y=0.18 //x2=0.945 //y2=0.555
cc_2514 ( N_GND_c_4386_n N_noxref_19_M0_noxref_s ) capacitor c=0.00166413f \
 //x=5.3 //y=0.175 //x2=0.945 //y2=0.555
cc_2515 ( N_GND_M0_noxref_d N_noxref_19_M0_noxref_s ) capacitor c=0.0271316f \
 //x=1.375 //y=1.055 //x2=0.945 //y2=0.555
cc_2516 ( N_GND_c_4349_n N_noxref_20_c_4951_n ) capacitor c=0.0011329f \
 //x=6.29 //y=0.175 //x2=6.775 //y2=1.77
cc_2517 ( N_GND_c_4450_n N_noxref_20_c_4951_n ) capacitor c=6.58254e-19 \
 //x=11.1 //y=0.175 //x2=6.775 //y2=1.77
cc_2518 ( N_GND_c_4359_n N_noxref_20_c_4951_n ) capacitor c=0.0036253f \
 //x=6.375 //y=1.145 //x2=6.775 //y2=1.77
cc_2519 ( N_GND_c_4384_n N_noxref_20_c_4951_n ) capacitor c=0.0038933f \
 //x=9.94 //y=0.175 //x2=6.775 //y2=1.77
cc_2520 ( N_GND_M3_noxref_d N_noxref_20_c_4951_n ) capacitor c=0.00578031f \
 //x=6.185 //y=1.055 //x2=6.775 //y2=1.77
cc_2521 ( N_GND_c_4353_n N_noxref_20_c_4980_n ) capacitor c=0.0169052f \
 //x=6.375 //y=1.015 //x2=6.86 //y2=0.805
cc_2522 ( N_GND_c_4450_n N_noxref_20_c_4980_n ) capacitor c=0.00710913f \
 //x=11.1 //y=0.175 //x2=6.86 //y2=0.805
cc_2523 ( N_GND_c_4384_n N_noxref_20_c_4980_n ) capacitor c=0.0140604f \
 //x=9.94 //y=0.175 //x2=6.86 //y2=0.805
cc_2524 ( N_GND_c_4386_n N_noxref_20_c_4980_n ) capacitor c=0.00322478f \
 //x=5.3 //y=0.175 //x2=6.86 //y2=0.805
cc_2525 ( N_GND_c_4450_n N_noxref_20_c_4967_n ) capacitor c=0.0125973f \
 //x=11.1 //y=0.175 //x2=7.745 //y2=0.72
cc_2526 ( N_GND_c_4384_n N_noxref_20_c_4967_n ) capacitor c=0.035931f //x=9.94 \
 //y=0.175 //x2=7.745 //y2=0.72
cc_2527 ( N_GND_c_4520_n N_noxref_20_c_4967_n ) capacitor c=0.00265129f \
 //x=28.61 //y=0.18 //x2=7.745 //y2=0.72
cc_2528 ( N_GND_c_4349_n N_noxref_20_M3_noxref_s ) capacitor c=0.00710913f \
 //x=6.29 //y=0.175 //x2=5.755 //y2=0.555
cc_2529 ( N_GND_c_4353_n N_noxref_20_M3_noxref_s ) capacitor c=0.0173062f \
 //x=6.375 //y=1.015 //x2=5.755 //y2=0.555
cc_2530 ( N_GND_c_4450_n N_noxref_20_M3_noxref_s ) capacitor c=0.00590241f \
 //x=11.1 //y=0.175 //x2=5.755 //y2=0.555
cc_2531 ( N_GND_c_4359_n N_noxref_20_M3_noxref_s ) capacitor c=0.00988958f \
 //x=6.375 //y=1.145 //x2=5.755 //y2=0.555
cc_2532 ( N_GND_c_4384_n N_noxref_20_M3_noxref_s ) capacitor c=0.0274023f \
 //x=9.94 //y=0.175 //x2=5.755 //y2=0.555
cc_2533 ( N_GND_c_4386_n N_noxref_20_M3_noxref_s ) capacitor c=0.0634633f \
 //x=5.3 //y=0.175 //x2=5.755 //y2=0.555
cc_2534 ( N_GND_c_4394_n N_noxref_20_M3_noxref_s ) capacitor c=0.00166413f \
 //x=10.11 //y=0.175 //x2=5.755 //y2=0.555
cc_2535 ( N_GND_M3_noxref_d N_noxref_20_M3_noxref_s ) capacitor c=0.0271316f \
 //x=6.185 //y=1.055 //x2=5.755 //y2=0.555
cc_2536 ( N_GND_c_4450_n N_noxref_21_c_5012_n ) capacitor c=0.0011329f \
 //x=11.1 //y=0.175 //x2=11.585 //y2=1.77
cc_2537 ( N_GND_c_4414_n N_noxref_21_c_5012_n ) capacitor c=7.40908e-19 \
 //x=15.91 //y=0.175 //x2=11.585 //y2=1.77
cc_2538 ( N_GND_c_4371_n N_noxref_21_c_5012_n ) capacitor c=0.00358635f \
 //x=11.185 //y=1.145 //x2=11.585 //y2=1.77
cc_2539 ( N_GND_c_4385_n N_noxref_21_c_5012_n ) capacitor c=0.0038933f \
 //x=14.75 //y=0.175 //x2=11.585 //y2=1.77
cc_2540 ( N_GND_M6_noxref_d N_noxref_21_c_5012_n ) capacitor c=0.00578031f \
 //x=10.995 //y=1.055 //x2=11.585 //y2=1.77
cc_2541 ( N_GND_c_4356_n N_noxref_21_c_5041_n ) capacitor c=0.0169052f \
 //x=11.185 //y=1.015 //x2=11.67 //y2=0.805
cc_2542 ( N_GND_c_4414_n N_noxref_21_c_5041_n ) capacitor c=0.00710913f \
 //x=15.91 //y=0.175 //x2=11.67 //y2=0.805
cc_2543 ( N_GND_c_4385_n N_noxref_21_c_5041_n ) capacitor c=0.0140604f \
 //x=14.75 //y=0.175 //x2=11.67 //y2=0.805
cc_2544 ( N_GND_c_4394_n N_noxref_21_c_5041_n ) capacitor c=0.00322478f \
 //x=10.11 //y=0.175 //x2=11.67 //y2=0.805
cc_2545 ( N_GND_c_4414_n N_noxref_21_c_5027_n ) capacitor c=0.0124865f \
 //x=15.91 //y=0.175 //x2=12.555 //y2=0.72
cc_2546 ( N_GND_c_4385_n N_noxref_21_c_5027_n ) capacitor c=0.0358909f \
 //x=14.75 //y=0.175 //x2=12.555 //y2=0.72
cc_2547 ( N_GND_c_4520_n N_noxref_21_c_5027_n ) capacitor c=0.00265129f \
 //x=28.61 //y=0.18 //x2=12.555 //y2=0.72
cc_2548 ( N_GND_c_4450_n N_noxref_21_M6_noxref_s ) capacitor c=0.00710913f \
 //x=11.1 //y=0.175 //x2=10.565 //y2=0.555
cc_2549 ( N_GND_c_4356_n N_noxref_21_M6_noxref_s ) capacitor c=0.0173062f \
 //x=11.185 //y=1.015 //x2=10.565 //y2=0.555
cc_2550 ( N_GND_c_4414_n N_noxref_21_M6_noxref_s ) capacitor c=0.00585131f \
 //x=15.91 //y=0.175 //x2=10.565 //y2=0.555
cc_2551 ( N_GND_c_4371_n N_noxref_21_M6_noxref_s ) capacitor c=0.00988958f \
 //x=11.185 //y=1.145 //x2=10.565 //y2=0.555
cc_2552 ( N_GND_c_4385_n N_noxref_21_M6_noxref_s ) capacitor c=0.0273668f \
 //x=14.75 //y=0.175 //x2=10.565 //y2=0.555
cc_2553 ( N_GND_c_4394_n N_noxref_21_M6_noxref_s ) capacitor c=0.0634633f \
 //x=10.11 //y=0.175 //x2=10.565 //y2=0.555
cc_2554 ( N_GND_c_4435_n N_noxref_21_M6_noxref_s ) capacitor c=0.00166413f \
 //x=14.92 //y=0.175 //x2=10.565 //y2=0.555
cc_2555 ( N_GND_M6_noxref_d N_noxref_21_M6_noxref_s ) capacitor c=0.0271316f \
 //x=10.995 //y=1.055 //x2=10.565 //y2=0.555
cc_2556 ( N_GND_c_4414_n N_noxref_22_c_5072_n ) capacitor c=0.0011329f \
 //x=15.91 //y=0.175 //x2=16.395 //y2=1.77
cc_2557 ( N_GND_c_4452_n N_noxref_22_c_5072_n ) capacitor c=7.40908e-19 \
 //x=20.72 //y=0.175 //x2=16.395 //y2=1.77
cc_2558 ( N_GND_c_4421_n N_noxref_22_c_5072_n ) capacitor c=0.00358809f \
 //x=15.995 //y=1.145 //x2=16.395 //y2=1.77
cc_2559 ( N_GND_c_4434_n N_noxref_22_c_5072_n ) capacitor c=0.0038933f \
 //x=19.56 //y=0.175 //x2=16.395 //y2=1.77
cc_2560 ( N_GND_M9_noxref_d N_noxref_22_c_5072_n ) capacitor c=0.00578031f \
 //x=15.805 //y=1.055 //x2=16.395 //y2=1.77
cc_2561 ( N_GND_c_4418_n N_noxref_22_c_5100_n ) capacitor c=0.0169052f \
 //x=15.995 //y=1.015 //x2=16.48 //y2=0.805
cc_2562 ( N_GND_c_4452_n N_noxref_22_c_5100_n ) capacitor c=0.00710913f \
 //x=20.72 //y=0.175 //x2=16.48 //y2=0.805
cc_2563 ( N_GND_c_4434_n N_noxref_22_c_5100_n ) capacitor c=0.0140604f \
 //x=19.56 //y=0.175 //x2=16.48 //y2=0.805
cc_2564 ( N_GND_c_4435_n N_noxref_22_c_5100_n ) capacitor c=0.00322478f \
 //x=14.92 //y=0.175 //x2=16.48 //y2=0.805
cc_2565 ( N_GND_c_4452_n N_noxref_22_c_5083_n ) capacitor c=0.0123867f \
 //x=20.72 //y=0.175 //x2=17.365 //y2=0.72
cc_2566 ( N_GND_c_4434_n N_noxref_22_c_5083_n ) capacitor c=0.0356451f \
 //x=19.56 //y=0.175 //x2=17.365 //y2=0.72
cc_2567 ( N_GND_c_4520_n N_noxref_22_c_5083_n ) capacitor c=0.00265129f \
 //x=28.61 //y=0.18 //x2=17.365 //y2=0.72
cc_2568 ( N_GND_c_4414_n N_noxref_22_M9_noxref_s ) capacitor c=0.00710913f \
 //x=15.91 //y=0.175 //x2=15.375 //y2=0.555
cc_2569 ( N_GND_c_4418_n N_noxref_22_M9_noxref_s ) capacitor c=0.0173062f \
 //x=15.995 //y=1.015 //x2=15.375 //y2=0.555
cc_2570 ( N_GND_c_4452_n N_noxref_22_M9_noxref_s ) capacitor c=0.00683407f \
 //x=20.72 //y=0.175 //x2=15.375 //y2=0.555
cc_2571 ( N_GND_c_4421_n N_noxref_22_M9_noxref_s ) capacitor c=0.00988958f \
 //x=15.995 //y=1.145 //x2=15.375 //y2=0.555
cc_2572 ( N_GND_c_4434_n N_noxref_22_M9_noxref_s ) capacitor c=0.0272246f \
 //x=19.56 //y=0.175 //x2=15.375 //y2=0.555
cc_2573 ( N_GND_c_4435_n N_noxref_22_M9_noxref_s ) capacitor c=0.0634633f \
 //x=14.92 //y=0.175 //x2=15.375 //y2=0.555
cc_2574 ( N_GND_c_4480_n N_noxref_22_M9_noxref_s ) capacitor c=0.00166413f \
 //x=19.73 //y=0.175 //x2=15.375 //y2=0.555
cc_2575 ( N_GND_M9_noxref_d N_noxref_22_M9_noxref_s ) capacitor c=0.0271316f \
 //x=15.805 //y=1.055 //x2=15.375 //y2=0.555
cc_2576 ( N_GND_c_4452_n N_noxref_23_c_5131_n ) capacitor c=0.0011329f \
 //x=20.72 //y=0.175 //x2=21.205 //y2=1.77
cc_2577 ( N_GND_c_4495_n N_noxref_23_c_5131_n ) capacitor c=7.40908e-19 \
 //x=25.53 //y=0.175 //x2=21.205 //y2=1.77
cc_2578 ( N_GND_c_4462_n N_noxref_23_c_5131_n ) capacitor c=0.00370874f \
 //x=20.805 //y=1.145 //x2=21.205 //y2=1.77
cc_2579 ( N_GND_c_4474_n N_noxref_23_c_5131_n ) capacitor c=0.0038933f \
 //x=24.37 //y=0.175 //x2=21.205 //y2=1.77
cc_2580 ( N_GND_M12_noxref_d N_noxref_23_c_5131_n ) capacitor c=0.00578031f \
 //x=20.615 //y=1.055 //x2=21.205 //y2=1.77
cc_2581 ( N_GND_c_4458_n N_noxref_23_c_5158_n ) capacitor c=0.0169052f \
 //x=20.805 //y=1.015 //x2=21.29 //y2=0.805
cc_2582 ( N_GND_c_4495_n N_noxref_23_c_5158_n ) capacitor c=0.00710913f \
 //x=25.53 //y=0.175 //x2=21.29 //y2=0.805
cc_2583 ( N_GND_c_4474_n N_noxref_23_c_5158_n ) capacitor c=0.0140604f \
 //x=24.37 //y=0.175 //x2=21.29 //y2=0.805
cc_2584 ( N_GND_c_4480_n N_noxref_23_c_5158_n ) capacitor c=0.00322478f \
 //x=19.73 //y=0.175 //x2=21.29 //y2=0.805
cc_2585 ( N_GND_c_4495_n N_noxref_23_c_5142_n ) capacitor c=0.0124418f \
 //x=25.53 //y=0.175 //x2=22.175 //y2=0.72
cc_2586 ( N_GND_c_4474_n N_noxref_23_c_5142_n ) capacitor c=0.0356451f \
 //x=24.37 //y=0.175 //x2=22.175 //y2=0.72
cc_2587 ( N_GND_c_4520_n N_noxref_23_c_5142_n ) capacitor c=0.00265129f \
 //x=28.61 //y=0.18 //x2=22.175 //y2=0.72
cc_2588 ( N_GND_c_4452_n N_noxref_23_M12_noxref_s ) capacitor c=0.00710913f \
 //x=20.72 //y=0.175 //x2=20.185 //y2=0.555
cc_2589 ( N_GND_c_4458_n N_noxref_23_M12_noxref_s ) capacitor c=0.0173062f \
 //x=20.805 //y=1.015 //x2=20.185 //y2=0.555
cc_2590 ( N_GND_c_4495_n N_noxref_23_M12_noxref_s ) capacitor c=0.00683407f \
 //x=25.53 //y=0.175 //x2=20.185 //y2=0.555
cc_2591 ( N_GND_c_4462_n N_noxref_23_M12_noxref_s ) capacitor c=0.00988958f \
 //x=20.805 //y=1.145 //x2=20.185 //y2=0.555
cc_2592 ( N_GND_c_4474_n N_noxref_23_M12_noxref_s ) capacitor c=0.0272246f \
 //x=24.37 //y=0.175 //x2=20.185 //y2=0.555
cc_2593 ( N_GND_c_4480_n N_noxref_23_M12_noxref_s ) capacitor c=0.0634633f \
 //x=19.73 //y=0.175 //x2=20.185 //y2=0.555
cc_2594 ( N_GND_c_4521_n N_noxref_23_M12_noxref_s ) capacitor c=0.00166413f \
 //x=24.54 //y=0.175 //x2=20.185 //y2=0.555
cc_2595 ( N_GND_M12_noxref_d N_noxref_23_M12_noxref_s ) capacitor c=0.0271316f \
 //x=20.615 //y=1.055 //x2=20.185 //y2=0.555
cc_2596 ( N_GND_c_4495_n N_noxref_24_c_5189_n ) capacitor c=0.0011329f \
 //x=25.53 //y=0.175 //x2=26.015 //y2=1.77
cc_2597 ( N_GND_c_4538_n N_noxref_24_c_5189_n ) capacitor c=0.00185104f \
 //x=28.61 //y=0.18 //x2=26.015 //y2=1.77
cc_2598 ( N_GND_c_4507_n N_noxref_24_c_5189_n ) capacitor c=0.00365321f \
 //x=25.615 //y=1.145 //x2=26.015 //y2=1.77
cc_2599 ( N_GND_c_4520_n N_noxref_24_c_5189_n ) capacitor c=0.00383655f \
 //x=28.61 //y=0.18 //x2=26.015 //y2=1.77
cc_2600 ( N_GND_M15_noxref_d N_noxref_24_c_5189_n ) capacitor c=0.00578031f \
 //x=25.425 //y=1.055 //x2=26.015 //y2=1.77
cc_2601 ( N_GND_c_4504_n N_noxref_24_c_5223_n ) capacitor c=0.0169052f \
 //x=25.615 //y=1.015 //x2=26.1 //y2=0.805
cc_2602 ( N_GND_c_4538_n N_noxref_24_c_5223_n ) capacitor c=0.00710913f \
 //x=28.61 //y=0.18 //x2=26.1 //y2=0.805
cc_2603 ( N_GND_c_4520_n N_noxref_24_c_5223_n ) capacitor c=0.0140604f \
 //x=28.61 //y=0.18 //x2=26.1 //y2=0.805
cc_2604 ( N_GND_c_4521_n N_noxref_24_c_5223_n ) capacitor c=0.00322478f \
 //x=24.54 //y=0.175 //x2=26.1 //y2=0.805
cc_2605 ( N_GND_c_4538_n N_noxref_24_c_5202_n ) capacitor c=0.0130316f \
 //x=28.61 //y=0.18 //x2=26.985 //y2=0.72
cc_2606 ( N_GND_c_4520_n N_noxref_24_c_5202_n ) capacitor c=0.0382964f \
 //x=28.61 //y=0.18 //x2=26.985 //y2=0.72
cc_2607 ( N_GND_c_4495_n N_noxref_24_M15_noxref_s ) capacitor c=0.00710913f \
 //x=25.53 //y=0.175 //x2=24.995 //y2=0.555
cc_2608 ( N_GND_c_4504_n N_noxref_24_M15_noxref_s ) capacitor c=0.0173062f \
 //x=25.615 //y=1.015 //x2=24.995 //y2=0.555
cc_2609 ( N_GND_c_4538_n N_noxref_24_M15_noxref_s ) capacitor c=0.00683407f \
 //x=28.61 //y=0.18 //x2=24.995 //y2=0.555
cc_2610 ( N_GND_c_4507_n N_noxref_24_M15_noxref_s ) capacitor c=0.00988958f \
 //x=25.615 //y=1.145 //x2=24.995 //y2=0.555
cc_2611 ( N_GND_c_4520_n N_noxref_24_M15_noxref_s ) capacitor c=0.028586f \
 //x=28.61 //y=0.18 //x2=24.995 //y2=0.555
cc_2612 ( N_GND_c_4521_n N_noxref_24_M15_noxref_s ) capacitor c=0.0634633f \
 //x=24.54 //y=0.175 //x2=24.995 //y2=0.555
cc_2613 ( N_GND_M15_noxref_d N_noxref_24_M15_noxref_s ) capacitor c=0.0271316f \
 //x=25.425 //y=1.055 //x2=24.995 //y2=0.555
cc_2614 ( N_noxref_18_c_4876_n N_noxref_24_c_5223_n ) capacitor c=2.15937e-19 \
 //x=27.64 //y=0.805 //x2=26.1 //y2=0.805
cc_2615 ( N_noxref_18_c_4834_n N_noxref_24_c_5202_n ) capacitor c=0.0132325f \
 //x=27.555 //y=1.175 //x2=26.985 //y2=0.72
cc_2616 ( N_noxref_18_M16_noxref_d N_noxref_24_c_5202_n ) capacitor \
 c=0.0160925f //x=26.4 //y=1.09 //x2=26.985 //y2=0.72
cc_2617 ( N_noxref_18_c_4834_n N_noxref_24_c_5204_n ) capacitor c=0.00951811f \
 //x=27.555 //y=1.175 //x2=26.985 //y2=1.77
cc_2618 ( N_noxref_18_M16_noxref_d N_noxref_24_c_5204_n ) capacitor \
 c=0.0147964f //x=26.4 //y=1.09 //x2=26.985 //y2=1.77
cc_2619 ( N_noxref_18_c_4834_n N_noxref_24_M15_noxref_s ) capacitor \
 c=0.023368f //x=27.555 //y=1.175 //x2=24.995 //y2=0.555
cc_2620 ( N_noxref_18_c_4876_n N_noxref_24_M15_noxref_s ) capacitor \
 c=0.0182125f //x=27.64 //y=0.805 //x2=24.995 //y2=0.555
cc_2621 ( N_noxref_18_M16_noxref_d N_noxref_24_M15_noxref_s ) capacitor \
 c=0.0187685f //x=26.4 //y=1.09 //x2=24.995 //y2=0.555
cc_2622 ( N_noxref_18_M17_noxref_s N_noxref_24_M15_noxref_s ) capacitor \
 c=0.0209954f //x=27.505 //y=0.555 //x2=24.995 //y2=0.555
