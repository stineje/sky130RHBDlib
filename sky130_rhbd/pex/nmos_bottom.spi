// File: nmos_bottom.spi
// Created: Tue Apr 29 10:50:56 2025
// Program "Calibre xRC"
// Version "v2023.2_27.15"
//
simulator lang=spectre
include "/import/yukari1/lrburle/sky130RHBDlib/calibre/sky130_rhbd_output/spice/nmos_bottom.pex.spice"
subckt nmos_bottom (  )
//
M0_noxref ( noxref_1 noxref_3 noxref_2 noxref_5 ) NMOS l=0.163119 w=2.35104 m=1
c_3 ( noxref_1 0 ) capacitor c=0.00699477f //x=0.43 //y=0.5
c_6 ( noxref_2 0 ) capacitor c=0.198117f //x=0 //y=0
c_9 ( noxref_3 0 ) capacitor c=0.213616f //x=0.62 //y=0.925
//
include "/import/yukari1/lrburle/sky130RHBDlib/calibre/sky130_rhbd_output/spice/nmos_bottom.pxi.spice"
//
ends NMOS_BOTTOM
//
//
