// File: VOTERN3X1.spi
// Created: Thu Jan 22 07:10:40 2026
// Program "Calibre xRC"
// Version "v2023.2_27.15"
//
simulator lang=spectre
include "/import/yukari1/lrburle/sky130RHBDlib/sky130_rhbd/pex/VOTERN3X1.pex.spice"
subckt VOTERN3X1 (  B C A YN VDD GND )
//
// GND	GND
// VDD	VDD
// YN	YN
// A	A
// C	C
// B	B
M0_noxref ( N_GND_M0_noxref_d N_B_M0_noxref_g N_noxref_9_M0_noxref_s \
 noxref_120 ) NMOS l=0.163119 w=2.35104 m=1
M1_noxref ( N_YN_M1_noxref_d N_A_M1_noxref_g N_noxref_9_M0_noxref_s noxref_120 \
 ) NMOS l=0.163346 w=2.31104 m=1
M2_noxref ( noxref_10 N_B_M2_noxref_g N_noxref_12_M2_noxref_s noxref_120 ) \
 NMOS l=0.163119 w=2.35104 m=1
M3_noxref ( N_YN_M3_noxref_d N_C_M3_noxref_g N_noxref_12_M2_noxref_s \
 noxref_120 ) NMOS l=0.163346 w=2.31104 m=1
M4_noxref ( N_GND_M4_noxref_d N_C_M4_noxref_g N_noxref_13_M4_noxref_s \
 noxref_120 ) NMOS l=0.163119 w=2.35104 m=1
M5_noxref ( N_YN_M5_noxref_d N_A_M5_noxref_g N_noxref_13_M4_noxref_s \
 noxref_120 ) NMOS l=0.163129 w=2.31397 m=1
M6_noxref ( N_noxref_6_M6_noxref_d N_B_M6_noxref_g N_VDD_M6_noxref_s \
 noxref_118 ) PMOS l=0.15 w=2 ad=0.57 as=0.57 pd=2.57 ps=2.57 nrd=0 nrs=0 m=1
M7_noxref ( N_VDD_M7_noxref_d N_B_M7_noxref_g N_noxref_6_M6_noxref_d \
 noxref_118 ) PMOS l=0.15 w=2 ad=0.58 as=0.58 pd=2.58 ps=2.58 nrd=0 nrs=0 m=1
M8_noxref ( N_noxref_6_M8_noxref_d N_A_M8_noxref_g N_VDD_M7_noxref_d \
 noxref_118 ) PMOS l=0.15 w=2 ad=0.58 as=0.58 pd=2.58 ps=2.58 nrd=0 nrs=0 m=1
M9_noxref ( N_VDD_M9_noxref_d N_A_M9_noxref_g N_noxref_6_M8_noxref_d \
 noxref_118 ) PMOS l=0.15 w=2 ad=0.56 as=0.56 pd=2.56 ps=2.56 nrd=0 nrs=0 m=1
M10_noxref ( N_noxref_7_M10_noxref_d N_B_M10_noxref_g N_noxref_6_M10_noxref_s \
 noxref_118 ) PMOS l=0.15 w=2 ad=0.56 as=0.56 pd=2.56 ps=2.56 nrd=0 nrs=0 m=1
M11_noxref ( N_noxref_6_M11_noxref_d N_B_M11_noxref_g N_noxref_7_M10_noxref_d \
 noxref_118 ) PMOS l=0.15 w=2 ad=0.58 as=0.58 pd=2.58 ps=2.58 nrd=0 nrs=0 m=1
M12_noxref ( noxref_11 N_C_M12_noxref_g N_noxref_6_M11_noxref_d noxref_118 ) \
 PMOS l=0.15 w=2 ad=0.58 as=0.58 pd=2.58 ps=2.58 nrd=0 nrs=0 m=1
M13_noxref ( N_noxref_6_M13_noxref_d N_C_M13_noxref_g noxref_11 noxref_118 ) \
 PMOS l=0.15 w=2 ad=0.57 as=0.57 pd=2.57 ps=2.57 nrd=0 nrs=0 m=1
M14_noxref ( N_YN_M14_noxref_d N_C_M14_noxref_g N_noxref_7_M14_noxref_s \
 noxref_118 ) PMOS l=0.15 w=2 ad=0.57 as=0.57 pd=2.57 ps=2.57 nrd=0 nrs=0 m=1
M15_noxref ( N_noxref_7_M15_noxref_d N_C_M15_noxref_g N_YN_M14_noxref_d \
 noxref_118 ) PMOS l=0.15 w=2 ad=0.58 as=0.58 pd=2.58 ps=2.58 nrd=0 nrs=0 m=1
M16_noxref ( N_YN_M16_noxref_d N_A_M16_noxref_g N_noxref_7_M15_noxref_d \
 noxref_118 ) PMOS l=0.15 w=2 ad=0.58 as=0.58 pd=2.58 ps=2.58 nrd=0 nrs=0 m=1
M17_noxref ( N_noxref_7_M17_noxref_d N_A_M17_noxref_g N_YN_M16_noxref_d \
 noxref_118 ) PMOS l=0.15 w=2 ad=0.56 as=0.56 pd=2.56 ps=2.56 nrd=0 nrs=0 m=1
c_1709 ( noxref_10 0 ) capacitor c=0.0069842f //x=4.81 //y=1.045
c_1720 ( noxref_11 0 ) capacitor c=0.0143171f //x=5.775 //y=5.205
//
include "/import/yukari1/lrburle/sky130RHBDlib/sky130_rhbd/pex/VOTERN3X1.pxi.spice"
//
ends VOTERN3X1
//
//
