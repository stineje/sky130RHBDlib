// File: VOTER3X1.spi.VOTER3X1.pxi
// Created: Sun Mar 15 12:46:43 2026
//
simulator lang=spectre
x_PM_VOTER3X1\%B ( B B B B B B B B B B B N_B_c_43_p N_B_c_7_p N_B_c_54_p \
 N_B_c_3_p N_B_c_49_p N_B_c_41_p N_B_c_57_p N_B_c_8_p N_B_c_4_p \
 N_B_M0_noxref_g N_B_M2_noxref_g N_B_M7_noxref_g N_B_M8_noxref_g \
 N_B_M11_noxref_g N_B_M12_noxref_g N_B_c_79_p N_B_c_80_p N_B_c_82_p N_B_c_85_p \
 N_B_c_174_p N_B_c_175_p N_B_c_58_p N_B_c_59_p N_B_c_81_p N_B_c_83_p \
 N_B_c_25_p N_B_c_26_p N_B_c_28_p N_B_c_18_p N_B_c_183_p N_B_c_184_p \
 N_B_c_27_p N_B_c_29_p N_B_c_46_p N_B_c_12_p )  PM_VOTER3X1\%B
x_PM_VOTER3X1\%C ( C C C C C C C C C C N_C_c_245_n N_C_c_248_n N_C_c_281_p \
 N_C_c_295_p N_C_c_252_n N_C_c_282_p N_C_c_308_p N_C_c_254_n N_C_c_258_n \
 N_C_c_292_p N_C_c_285_p N_C_M3_noxref_g N_C_M4_noxref_g N_C_M13_noxref_g \
 N_C_M14_noxref_g N_C_M15_noxref_g N_C_M16_noxref_g N_C_c_264_n N_C_c_267_n \
 N_C_c_411_p N_C_c_269_n N_C_c_343_p N_C_c_344_p N_C_c_271_n N_C_c_273_n \
 N_C_c_274_n N_C_c_275_n N_C_c_276_n N_C_c_319_p N_C_c_320_p N_C_c_322_p \
 N_C_c_325_p N_C_c_425_p N_C_c_426_p N_C_c_297_p N_C_c_286_p N_C_c_321_p \
 N_C_c_323_p N_C_c_293_p )  PM_VOTER3X1\%C
x_PM_VOTER3X1\%A ( A A A A A A A A A A A N_A_c_482_n N_A_c_486_n N_A_c_489_n \
 N_A_c_547_n N_A_c_551_n N_A_c_552_n N_A_c_499_n N_A_c_556_n N_A_c_502_n \
 N_A_c_507_n N_A_c_511_n N_A_c_566_n N_A_c_569_n N_A_M1_noxref_g \
 N_A_M5_noxref_g N_A_M9_noxref_g N_A_M10_noxref_g N_A_M17_noxref_g \
 N_A_M18_noxref_g N_A_c_518_n N_A_c_521_n N_A_c_523_n N_A_c_689_p N_A_c_637_p \
 N_A_c_638_p N_A_c_526_n N_A_c_527_n N_A_c_576_n N_A_c_579_n N_A_c_581_n \
 N_A_c_630_p N_A_c_606_p N_A_c_584_n N_A_c_585_n N_A_c_586_n N_A_c_528_n \
 N_A_c_756_p N_A_c_531_n N_A_c_587_n N_A_c_615_p N_A_c_590_n )  PM_VOTER3X1\%A
x_PM_VOTER3X1\%noxref_4 ( N_noxref_4_c_777_n N_noxref_4_c_819_n \
 N_noxref_4_c_829_n N_noxref_4_c_831_n N_noxref_4_c_832_n N_noxref_4_c_833_n \
 N_noxref_4_c_778_n N_noxref_4_c_841_n N_noxref_4_c_780_n N_noxref_4_c_850_n \
 N_noxref_4_c_894_p N_noxref_4_c_851_n N_noxref_4_c_852_n N_noxref_4_c_781_n \
 N_noxref_4_c_788_n N_noxref_4_c_860_n N_noxref_4_c_864_n N_noxref_4_c_912_p \
 N_noxref_4_c_988_p N_noxref_4_c_962_p N_noxref_4_c_773_n N_noxref_4_c_975_p \
 N_noxref_4_c_867_n N_noxref_4_c_792_n N_noxref_4_c_872_n N_noxref_4_c_928_p \
 N_noxref_4_c_913_p N_noxref_4_c_802_n N_noxref_4_c_875_n N_noxref_4_c_991_p \
 N_noxref_4_c_896_p N_noxref_4_M6_noxref_g N_noxref_4_M19_noxref_g \
 N_noxref_4_M20_noxref_g N_noxref_4_c_996_p N_noxref_4_c_1044_p \
 N_noxref_4_c_1021_p N_noxref_4_c_1010_p N_noxref_4_c_922_p N_noxref_4_c_917_p \
 N_noxref_4_c_1023_p N_noxref_4_c_1047_p N_noxref_4_c_998_p \
 N_noxref_4_c_1025_p N_noxref_4_c_997_p N_noxref_4_M1_noxref_d \
 N_noxref_4_M3_noxref_d N_noxref_4_M5_noxref_d N_noxref_4_M15_noxref_d \
 N_noxref_4_M17_noxref_d )  PM_VOTER3X1\%noxref_4
x_PM_VOTER3X1\%VDD ( VDD N_VDD_c_1107_n N_VDD_c_1108_n N_VDD_c_1218_p \
 N_VDD_c_1109_n N_VDD_c_1110_n N_VDD_c_1220_p N_VDD_c_1152_n N_VDD_c_1153_n \
 N_VDD_c_1176_n N_VDD_c_1111_n N_VDD_c_1112_n N_VDD_c_1115_n N_VDD_c_1120_n \
 N_VDD_c_1138_n N_VDD_c_1185_n N_VDD_c_1123_n N_VDD_c_1129_n N_VDD_c_1171_n \
 N_VDD_c_1202_n N_VDD_M7_noxref_s N_VDD_M8_noxref_d N_VDD_M10_noxref_d \
 N_VDD_M19_noxref_s N_VDD_M20_noxref_d )  PM_VOTER3X1\%VDD
x_PM_VOTER3X1\%noxref_6 ( N_noxref_6_c_1360_n N_noxref_6_c_1362_n \
 N_noxref_6_c_1365_n N_noxref_6_c_1366_n N_noxref_6_c_1388_n \
 N_noxref_6_c_1372_n N_noxref_6_c_1376_n N_noxref_6_c_1377_n \
 N_noxref_6_c_1391_n N_noxref_6_c_1378_n N_noxref_6_c_1381_n \
 N_noxref_6_c_1382_n N_noxref_6_M7_noxref_d N_noxref_6_M9_noxref_d \
 N_noxref_6_M11_noxref_s N_noxref_6_M12_noxref_d N_noxref_6_M14_noxref_d )  \
 PM_VOTER3X1\%noxref_6
x_PM_VOTER3X1\%noxref_7 ( N_noxref_7_c_1526_n N_noxref_7_c_1539_n \
 N_noxref_7_c_1549_n N_noxref_7_c_1551_n N_noxref_7_c_1565_n \
 N_noxref_7_c_1527_n N_noxref_7_c_1553_n N_noxref_7_c_1556_n \
 N_noxref_7_c_1557_n N_noxref_7_c_1570_n N_noxref_7_c_1533_n \
 N_noxref_7_c_1558_n N_noxref_7_M11_noxref_d N_noxref_7_M15_noxref_s \
 N_noxref_7_M16_noxref_d N_noxref_7_M18_noxref_d )  PM_VOTER3X1\%noxref_7
x_PM_VOTER3X1\%GND ( GND N_GND_c_1663_n N_GND_c_1665_n N_GND_c_1737_n \
 N_GND_c_1672_n N_GND_c_1706_n N_GND_c_1709_n N_GND_c_1738_n N_GND_c_1681_n \
 N_GND_c_1682_n N_GND_c_1688_n N_GND_c_1717_n N_GND_c_1910_p N_GND_c_1783_n \
 N_GND_c_1787_n N_GND_c_1689_n N_GND_c_1720_n N_GND_c_1730_n N_GND_c_1802_n \
 N_GND_M0_noxref_d N_GND_M2_noxref_d N_GND_M4_noxref_d N_GND_M6_noxref_s )  \
 PM_VOTER3X1\%GND
x_PM_VOTER3X1\%Y ( Y Y Y Y Y Y Y N_Y_c_1934_n N_Y_c_1943_n N_Y_c_1947_n \
 N_Y_c_1948_n N_Y_c_1950_n N_Y_c_1951_n N_Y_c_1954_n N_Y_c_1962_n \
 N_Y_M6_noxref_d N_Y_M19_noxref_d )  PM_VOTER3X1\%Y
x_PM_VOTER3X1\%noxref_10 ( N_noxref_10_c_2003_n N_noxref_10_c_2007_n \
 N_noxref_10_c_2045_n N_noxref_10_c_2015_n N_noxref_10_c_2023_n \
 N_noxref_10_c_2055_n N_noxref_10_M0_noxref_s )  PM_VOTER3X1\%noxref_10
x_PM_VOTER3X1\%noxref_12 ( N_noxref_12_c_2079_n N_noxref_12_c_2080_n \
 N_noxref_12_c_2120_n N_noxref_12_c_2087_n N_noxref_12_c_2092_n \
 N_noxref_12_c_2130_n N_noxref_12_M2_noxref_s )  PM_VOTER3X1\%noxref_12
x_PM_VOTER3X1\%noxref_13 ( N_noxref_13_c_2145_n N_noxref_13_c_2149_n \
 N_noxref_13_c_2193_n N_noxref_13_c_2156_n N_noxref_13_c_2165_n \
 N_noxref_13_c_2203_n N_noxref_13_M4_noxref_s )  PM_VOTER3X1\%noxref_13
cc_1 ( B C ) capacitor c=0.0454386f //x=4.93 //y=2.77 //x2=6.41 //y2=2.77
cc_2 ( B C ) capacitor c=0.00392254f //x=4.93 //y=4.62 //x2=6.41 //y2=2.77
cc_3 ( N_B_c_3_p C ) capacitor c=0.00381786f //x=4.935 //y=4.64 //x2=6.41 \
 //y2=2.77
cc_4 ( N_B_c_4_p C ) capacitor c=2.47556e-19 //x=4.93 //y=4.62 //x2=6.41 \
 //y2=2.77
cc_5 ( B C ) capacitor c=0.00213544f //x=4.93 //y=2.77 //x2=7.89 //y2=2.77
cc_6 ( B N_C_c_245_n ) capacitor c=5.52227e-19 //x=4.93 //y=2.77 //x2=6.41 \
 //y2=2.43
cc_7 ( N_B_c_7_p N_C_c_245_n ) capacitor c=0.0033801f //x=4.93 //y=2.385 \
 //x2=6.41 //y2=2.43
cc_8 ( N_B_c_8_p N_C_c_245_n ) capacitor c=5.86738e-19 //x=4.93 //y=2.26 \
 //x2=6.41 //y2=2.43
cc_9 ( B N_C_c_248_n ) capacitor c=8.44065e-19 //x=4.93 //y=4.62 //x2=6.41 \
 //y2=4.76
cc_10 ( N_B_c_3_p N_C_c_248_n ) capacitor c=0.00106101f //x=4.935 //y=4.64 \
 //x2=6.41 //y2=4.76
cc_11 ( N_B_c_4_p N_C_c_248_n ) capacitor c=0.00389513f //x=4.93 //y=4.62 \
 //x2=6.41 //y2=4.76
cc_12 ( N_B_c_12_p N_C_c_248_n ) capacitor c=5.58186e-19 //x=4.93 //y=4.885 \
 //x2=6.41 //y2=4.76
cc_13 ( B N_C_c_252_n ) capacitor c=8.70657e-19 //x=4.93 //y=2.77 //x2=6.575 \
 //y2=2.27
cc_14 ( N_B_c_7_p N_C_c_252_n ) capacitor c=0.00564826f //x=4.93 //y=2.385 \
 //x2=6.575 //y2=2.27
cc_15 ( B N_C_c_254_n ) capacitor c=3.10803e-19 //x=4.93 //y=2.77 //x2=6.41 \
 //y2=2.26
cc_16 ( N_B_c_7_p N_C_c_254_n ) capacitor c=0.00362942f //x=4.93 //y=2.385 \
 //x2=6.41 //y2=2.26
cc_17 ( N_B_c_8_p N_C_c_254_n ) capacitor c=3.19688e-19 //x=4.93 //y=2.26 \
 //x2=6.41 //y2=2.26
cc_18 ( N_B_c_18_p N_C_c_254_n ) capacitor c=2.35599e-19 //x=4.735 //y=2.095 \
 //x2=6.41 //y2=2.26
cc_19 ( B N_C_c_258_n ) capacitor c=5.34267e-19 //x=4.93 //y=4.62 //x2=6.41 \
 //y2=4.885
cc_20 ( N_B_c_4_p N_C_c_258_n ) capacitor c=8.5191e-19 //x=4.93 //y=4.62 \
 //x2=6.41 //y2=4.885
cc_21 ( N_B_c_12_p N_C_c_258_n ) capacitor c=2.35599e-19 //x=4.93 //y=4.885 \
 //x2=6.41 //y2=4.885
cc_22 ( N_B_M11_noxref_g N_C_M13_noxref_g ) capacitor c=0.00948424f //x=4.82 \
 //y=6.205 //x2=5.7 //y2=6.205
cc_23 ( N_B_M12_noxref_g N_C_M13_noxref_g ) capacitor c=0.0638434f //x=5.26 \
 //y=6.205 //x2=5.7 //y2=6.205
cc_24 ( N_B_M12_noxref_g N_C_M14_noxref_g ) capacitor c=0.00878567f //x=5.26 \
 //y=6.205 //x2=6.14 //y2=6.205
cc_25 ( N_B_c_25_p N_C_c_264_n ) capacitor c=4.86545e-19 //x=4.735 //y=1.045 \
 //x2=5.705 //y2=1.085
cc_26 ( N_B_c_26_p N_C_c_264_n ) capacitor c=0.00152104f //x=4.735 //y=1.39 \
 //x2=5.705 //y2=1.085
cc_27 ( N_B_c_27_p N_C_c_264_n ) capacitor c=0.0159151f //x=5.265 //y=1.045 \
 //x2=5.705 //y2=1.085
cc_28 ( N_B_c_28_p N_C_c_267_n ) capacitor c=0.00109982f //x=4.735 //y=1.7 \
 //x2=5.705 //y2=1.43
cc_29 ( N_B_c_29_p N_C_c_267_n ) capacitor c=0.0158526f //x=5.265 //y=1.39 \
 //x2=5.705 //y2=1.43
cc_30 ( N_B_c_4_p N_C_c_269_n ) capacitor c=0.00110488f //x=4.93 //y=4.62 \
 //x2=5.775 //y2=4.975
cc_31 ( N_B_c_12_p N_C_c_269_n ) capacitor c=0.064577f //x=4.93 //y=4.885 \
 //x2=5.775 //y2=4.975
cc_32 ( N_B_c_4_p N_C_c_271_n ) capacitor c=2.35599e-19 //x=4.93 //y=4.62 \
 //x2=6.14 //y2=5.05
cc_33 ( N_B_c_12_p N_C_c_271_n ) capacitor c=5.35364e-19 //x=4.93 //y=4.885 \
 //x2=6.14 //y2=5.05
cc_34 ( N_B_c_27_p N_C_c_273_n ) capacitor c=0.00124821f //x=5.265 //y=1.045 \
 //x2=6.235 //y2=1.085
cc_35 ( N_B_c_29_p N_C_c_274_n ) capacitor c=0.00150765f //x=5.265 //y=1.39 \
 //x2=6.235 //y2=1.43
cc_36 ( N_B_c_29_p N_C_c_275_n ) capacitor c=4.38654e-19 //x=5.265 //y=1.39 \
 //x2=6.235 //y2=1.74
cc_37 ( N_B_c_8_p N_C_c_276_n ) capacitor c=2.35599e-19 //x=4.93 //y=2.26 \
 //x2=6.235 //y2=2.095
cc_38 ( N_B_c_18_p N_C_c_276_n ) capacitor c=4.61972e-19 //x=4.735 //y=2.095 \
 //x2=6.235 //y2=2.095
cc_39 ( B A ) capacitor c=0.0532443f //x=1.23 //y=2.77 //x2=2.34 //y2=2.77
cc_40 ( B A ) capacitor c=0.0220468f //x=4.93 //y=2.77 //x2=2.34 //y2=2.77
cc_41 ( N_B_c_41_p A ) capacitor c=4.16726e-19 //x=1.23 //y=2.26 //x2=2.34 \
 //y2=2.77
cc_42 ( B A ) capacitor c=0.00334158f //x=1.23 //y=2.77 //x2=2.34 //y2=4.25
cc_43 ( N_B_c_43_p N_A_c_482_n ) capacitor c=0.0110499f //x=1.23 //y=2.375 \
 //x2=2.34 //y2=2.375
cc_44 ( N_B_c_7_p N_A_c_482_n ) capacitor c=0.00273775f //x=4.93 //y=2.385 \
 //x2=2.34 //y2=2.375
cc_45 ( N_B_c_41_p N_A_c_482_n ) capacitor c=0.00353903f //x=1.23 //y=2.26 \
 //x2=2.34 //y2=2.375
cc_46 ( N_B_c_46_p N_A_c_482_n ) capacitor c=0.00140055f //x=1.23 //y=2.26 \
 //x2=2.34 //y2=2.375
cc_47 ( B N_A_c_486_n ) capacitor c=0.00785479f //x=1.23 //y=2.77 //x2=2.34 \
 //y2=4.365
cc_48 ( B N_A_c_486_n ) capacitor c=0.00149249f //x=4.93 //y=2.77 //x2=2.34 \
 //y2=4.365
cc_49 ( N_B_c_49_p N_A_c_486_n ) capacitor c=0.00452722f //x=4.775 //y=4.64 \
 //x2=2.34 //y2=4.365
cc_50 ( B N_A_c_489_n ) capacitor c=0.00241857f //x=1.23 //y=2.77 //x2=2.34 \
 //y2=4.71
cc_51 ( B N_A_c_489_n ) capacitor c=0.00106529f //x=4.93 //y=2.77 //x2=2.34 \
 //y2=4.71
cc_52 ( B N_A_c_489_n ) capacitor c=0.0102434f //x=1.23 //y=4.62 //x2=2.34 \
 //y2=4.71
cc_53 ( B N_A_c_489_n ) capacitor c=0.00146299f //x=4.93 //y=4.62 //x2=2.34 \
 //y2=4.71
cc_54 ( N_B_c_54_p N_A_c_489_n ) capacitor c=0.00282641f //x=1.395 //y=4.62 \
 //x2=2.34 //y2=4.71
cc_55 ( N_B_c_3_p N_A_c_489_n ) capacitor c=0.00206738f //x=4.935 //y=4.64 \
 //x2=2.34 //y2=4.71
cc_56 ( N_B_c_49_p N_A_c_489_n ) capacitor c=0.0312701f //x=4.775 //y=4.64 \
 //x2=2.34 //y2=4.71
cc_57 ( N_B_c_57_p N_A_c_489_n ) capacitor c=0.00868816f //x=1.23 //y=4.62 \
 //x2=2.34 //y2=4.71
cc_58 ( N_B_c_58_p N_A_c_489_n ) capacitor c=0.00144251f //x=1.865 //y=4.975 \
 //x2=2.34 //y2=4.71
cc_59 ( N_B_c_59_p N_A_c_489_n ) capacitor c=0.00105471f //x=1.575 //y=4.975 \
 //x2=2.34 //y2=4.71
cc_60 ( B N_A_c_499_n ) capacitor c=0.00529413f //x=1.23 //y=2.77 //x2=2.5 \
 //y2=4.205
cc_61 ( B N_A_c_499_n ) capacitor c=0.00110824f //x=4.93 //y=2.77 //x2=2.5 \
 //y2=4.205
cc_62 ( N_B_c_49_p N_A_c_499_n ) capacitor c=0.0345719f //x=4.775 //y=4.64 \
 //x2=2.5 //y2=4.205
cc_63 ( B N_A_c_502_n ) capacitor c=0.0312902f //x=4.93 //y=2.77 //x2=8.855 \
 //y2=4.21
cc_64 ( B N_A_c_502_n ) capacitor c=0.0102464f //x=4.93 //y=4.62 //x2=8.855 \
 //y2=4.21
cc_65 ( N_B_c_7_p N_A_c_502_n ) capacitor c=0.00179095f //x=4.93 //y=2.385 \
 //x2=8.855 //y2=4.21
cc_66 ( N_B_c_3_p N_A_c_502_n ) capacitor c=0.0375626f //x=4.935 //y=4.64 \
 //x2=8.855 //y2=4.21
cc_67 ( N_B_c_49_p N_A_c_502_n ) capacitor c=0.215316f //x=4.775 //y=4.64 \
 //x2=8.855 //y2=4.21
cc_68 ( B N_A_c_507_n ) capacitor c=4.16726e-19 //x=1.23 //y=2.77 //x2=2.34 \
 //y2=2.26
cc_69 ( N_B_c_43_p N_A_c_507_n ) capacitor c=0.00353903f //x=1.23 //y=2.375 \
 //x2=2.34 //y2=2.26
cc_70 ( N_B_c_41_p N_A_c_507_n ) capacitor c=0.0012665f //x=1.23 //y=2.26 \
 //x2=2.34 //y2=2.26
cc_71 ( N_B_c_46_p N_A_c_507_n ) capacitor c=0.00163906f //x=1.23 //y=2.26 \
 //x2=2.34 //y2=2.26
cc_72 ( B N_A_c_511_n ) capacitor c=0.00154972f //x=1.23 //y=4.62 //x2=2.38 \
 //y2=4.885
cc_73 ( N_B_c_57_p N_A_c_511_n ) capacitor c=0.00133991f //x=1.23 //y=4.62 \
 //x2=2.38 //y2=4.885
cc_74 ( N_B_c_58_p N_A_c_511_n ) capacitor c=0.00122675f //x=1.865 //y=4.975 \
 //x2=2.38 //y2=4.885
cc_75 ( N_B_c_59_p N_A_c_511_n ) capacitor c=0.00114302f //x=1.575 //y=4.975 \
 //x2=2.38 //y2=4.885
cc_76 ( N_B_M7_noxref_g N_A_M9_noxref_g ) capacitor c=0.0106808f //x=1.5 \
 //y=6.205 //x2=2.38 //y2=6.205
cc_77 ( N_B_M8_noxref_g N_A_M9_noxref_g ) capacitor c=0.108153f //x=1.94 \
 //y=6.205 //x2=2.38 //y2=6.205
cc_78 ( N_B_M8_noxref_g N_A_M10_noxref_g ) capacitor c=0.0103194f //x=1.94 \
 //y=6.205 //x2=2.82 //y2=6.205
cc_79 ( N_B_c_79_p N_A_c_518_n ) capacitor c=4.86545e-19 //x=1.405 //y=1.045 \
 //x2=2.375 //y2=1.085
cc_80 ( N_B_c_80_p N_A_c_518_n ) capacitor c=0.00152405f //x=1.405 //y=1.39 \
 //x2=2.375 //y2=1.085
cc_81 ( N_B_c_81_p N_A_c_518_n ) capacitor c=0.0151475f //x=1.935 //y=1.045 \
 //x2=2.375 //y2=1.085
cc_82 ( N_B_c_82_p N_A_c_521_n ) capacitor c=0.00109982f //x=1.405 //y=1.7 \
 //x2=2.375 //y2=1.43
cc_83 ( N_B_c_83_p N_A_c_521_n ) capacitor c=0.0111064f //x=1.935 //y=1.39 \
 //x2=2.375 //y2=1.43
cc_84 ( N_B_c_82_p N_A_c_523_n ) capacitor c=0.00179029f //x=1.405 //y=1.7 \
 //x2=2.375 //y2=1.74
cc_85 ( N_B_c_85_p N_A_c_523_n ) capacitor c=0.00662747f //x=1.405 //y=2.095 \
 //x2=2.375 //y2=1.74
cc_86 ( N_B_c_83_p N_A_c_523_n ) capacitor c=0.00862358f //x=1.935 //y=1.39 \
 //x2=2.375 //y2=1.74
cc_87 ( N_B_c_81_p N_A_c_526_n ) capacitor c=0.00124846f //x=1.935 //y=1.045 \
 //x2=2.905 //y2=1.085
cc_88 ( N_B_c_83_p N_A_c_527_n ) capacitor c=0.00161183f //x=1.935 //y=1.39 \
 //x2=2.905 //y2=1.43
cc_89 ( N_B_c_43_p N_A_c_528_n ) capacitor c=0.00130136f //x=1.23 //y=2.375 \
 //x2=2.34 //y2=2.26
cc_90 ( N_B_c_41_p N_A_c_528_n ) capacitor c=0.00191372f //x=1.23 //y=2.26 \
 //x2=2.34 //y2=2.26
cc_91 ( N_B_c_46_p N_A_c_528_n ) capacitor c=0.00949697f //x=1.23 //y=2.26 \
 //x2=2.34 //y2=2.26
cc_92 ( B N_A_c_531_n ) capacitor c=2.84639e-19 //x=1.23 //y=4.62 //x2=2.38 \
 //y2=4.885
cc_93 ( N_B_c_57_p N_A_c_531_n ) capacitor c=0.00197201f //x=1.23 //y=4.62 \
 //x2=2.38 //y2=4.885
cc_94 ( N_B_c_58_p N_A_c_531_n ) capacitor c=0.0203213f //x=1.865 //y=4.975 \
 //x2=2.38 //y2=4.885
cc_95 ( N_B_c_59_p N_A_c_531_n ) capacitor c=0.00427779f //x=1.575 //y=4.975 \
 //x2=2.38 //y2=4.885
cc_96 ( N_B_c_7_p N_noxref_4_c_773_n ) capacitor c=0.0108541f //x=4.93 \
 //y=2.385 //x2=5.84 //y2=1.405
cc_97 ( N_B_c_26_p N_noxref_4_c_773_n ) capacitor c=0.00242807f //x=4.735 \
 //y=1.39 //x2=5.84 //y2=1.405
cc_98 ( N_B_c_28_p N_noxref_4_c_773_n ) capacitor c=0.0026623f //x=4.735 \
 //y=1.7 //x2=5.84 //y2=1.405
cc_99 ( N_B_c_29_p N_noxref_4_c_773_n ) capacitor c=0.00413582f //x=5.265 \
 //y=1.39 //x2=5.84 //y2=1.405
cc_100 ( N_B_M7_noxref_g N_VDD_c_1107_n ) capacitor c=0.00374549f //x=1.5 \
 //y=6.205 //x2=1.28 //y2=7.035
cc_101 ( N_B_M7_noxref_g N_VDD_c_1108_n ) capacitor c=0.00441594f //x=1.5 \
 //y=6.205 //x2=1.28 //y2=7.41
cc_102 ( N_B_M8_noxref_g N_VDD_c_1109_n ) capacitor c=0.00123273f //x=1.94 \
 //y=6.205 //x2=2.16 //y2=7.035
cc_103 ( N_B_M8_noxref_g N_VDD_c_1110_n ) capacitor c=0.00137209f //x=1.94 \
 //y=6.205 //x2=2.16 //y2=7.41
cc_104 ( B N_VDD_c_1111_n ) capacitor c=2.89886e-19 //x=1.23 //y=4.62 \
 //x2=1.23 //y2=7.58
cc_105 ( B N_VDD_c_1112_n ) capacitor c=5.35585e-19 //x=1.23 //y=4.62 \
 //x2=3.65 //y2=7.585
cc_106 ( N_B_M7_noxref_g N_VDD_c_1112_n ) capacitor c=0.00778439f //x=1.5 \
 //y=6.205 //x2=3.65 //y2=7.585
cc_107 ( N_B_M8_noxref_g N_VDD_c_1112_n ) capacitor c=0.00778439f //x=1.94 \
 //y=6.205 //x2=3.65 //y2=7.585
cc_108 ( B N_VDD_c_1115_n ) capacitor c=0.00519253f //x=1.23 //y=2.77 \
 //x2=1.23 //y2=7.58
cc_109 ( B N_VDD_c_1115_n ) capacitor c=0.008788f //x=1.23 //y=4.62 //x2=1.23 \
 //y2=7.58
cc_110 ( N_B_c_57_p N_VDD_c_1115_n ) capacitor c=0.0174085f //x=1.23 //y=4.62 \
 //x2=1.23 //y2=7.58
cc_111 ( N_B_M7_noxref_g N_VDD_c_1115_n ) capacitor c=0.0191171f //x=1.5 \
 //y=6.205 //x2=1.23 //y2=7.58
cc_112 ( N_B_c_59_p N_VDD_c_1115_n ) capacitor c=0.0079396f //x=1.575 \
 //y=4.975 //x2=1.23 //y2=7.58
cc_113 ( N_B_c_4_p N_VDD_c_1120_n ) capacitor c=2.11259e-19 //x=4.93 //y=4.62 \
 //x2=6.98 //y2=7.585
cc_114 ( N_B_M11_noxref_g N_VDD_c_1120_n ) capacitor c=0.00763665f //x=4.82 \
 //y=6.205 //x2=6.98 //y2=7.585
cc_115 ( N_B_M12_noxref_g N_VDD_c_1120_n ) capacitor c=0.00782837f //x=5.26 \
 //y=6.205 //x2=6.98 //y2=7.585
cc_116 ( B N_VDD_c_1123_n ) capacitor c=0.00285166f //x=4.93 //y=2.77 \
 //x2=3.82 //y2=7.585
cc_117 ( B N_VDD_c_1123_n ) capacitor c=0.00331684f //x=4.93 //y=4.62 \
 //x2=3.82 //y2=7.585
cc_118 ( N_B_c_49_p N_VDD_c_1123_n ) capacitor c=0.0167947f //x=4.775 //y=4.64 \
 //x2=3.82 //y2=7.585
cc_119 ( N_B_c_57_p N_VDD_c_1123_n ) capacitor c=0.00117386f //x=1.23 //y=4.62 \
 //x2=3.82 //y2=7.585
cc_120 ( N_B_c_4_p N_VDD_c_1123_n ) capacitor c=0.0104424f //x=4.93 //y=4.62 \
 //x2=3.82 //y2=7.585
cc_121 ( N_B_c_12_p N_VDD_c_1123_n ) capacitor c=0.0137051f //x=4.93 //y=4.885 \
 //x2=3.82 //y2=7.585
cc_122 ( N_B_c_4_p N_VDD_c_1129_n ) capacitor c=0.00221916f //x=4.93 //y=4.62 \
 //x2=7.15 //y2=7.585
cc_123 ( B N_VDD_M7_noxref_s ) capacitor c=0.0166208f //x=1.23 //y=4.62 \
 //x2=1.145 //y2=5.205
cc_124 ( N_B_c_54_p N_VDD_M7_noxref_s ) capacitor c=0.00180521f //x=1.395 \
 //y=4.62 //x2=1.145 //y2=5.205
cc_125 ( N_B_c_57_p N_VDD_M7_noxref_s ) capacitor c=0.0122195f //x=1.23 \
 //y=4.62 //x2=1.145 //y2=5.205
cc_126 ( N_B_M7_noxref_g N_VDD_M7_noxref_s ) capacitor c=0.0510401f //x=1.5 \
 //y=6.205 //x2=1.145 //y2=5.205
cc_127 ( N_B_c_59_p N_VDD_M7_noxref_s ) capacitor c=0.00621646f //x=1.575 \
 //y=4.975 //x2=1.145 //y2=5.205
cc_128 ( N_B_M8_noxref_g N_VDD_M8_noxref_d ) capacitor c=0.0127979f //x=1.94 \
 //y=6.205 //x2=2.015 //y2=5.205
cc_129 ( N_B_c_49_p N_noxref_6_c_1360_n ) capacitor c=0.00314988f //x=4.775 \
 //y=4.64 //x2=2.485 //y2=5.39
cc_130 ( N_B_M8_noxref_g N_noxref_6_c_1360_n ) capacitor c=0.00962216f \
 //x=1.94 //y=6.205 //x2=2.485 //y2=5.39
cc_131 ( B N_noxref_6_c_1362_n ) capacitor c=0.00378061f //x=4.93 //y=4.62 \
 //x2=4.485 //y2=5.39
cc_132 ( N_B_c_49_p N_noxref_6_c_1362_n ) capacitor c=0.0894443f //x=4.775 \
 //y=4.64 //x2=4.485 //y2=5.39
cc_133 ( N_B_M11_noxref_g N_noxref_6_c_1362_n ) capacitor c=0.00366801f \
 //x=4.82 //y=6.205 //x2=4.485 //y2=5.39
cc_134 ( N_B_c_49_p N_noxref_6_c_1365_n ) capacitor c=0.00878121f //x=4.775 \
 //y=4.64 //x2=2.715 //y2=5.39
cc_135 ( B N_noxref_6_c_1366_n ) capacitor c=8.16607e-19 //x=4.93 //y=4.62 \
 //x2=5.36 //y2=7.09
cc_136 ( N_B_c_3_p N_noxref_6_c_1366_n ) capacitor c=0.00566393f //x=4.935 \
 //y=4.64 //x2=5.36 //y2=7.09
cc_137 ( N_B_c_49_p N_noxref_6_c_1366_n ) capacitor c=5.18143e-19 //x=4.775 \
 //y=4.64 //x2=5.36 //y2=7.09
cc_138 ( N_B_c_4_p N_noxref_6_c_1366_n ) capacitor c=0.00134225f //x=4.93 \
 //y=4.62 //x2=5.36 //y2=7.09
cc_139 ( N_B_M11_noxref_g N_noxref_6_c_1366_n ) capacitor c=0.00985075f \
 //x=4.82 //y=6.205 //x2=5.36 //y2=7.09
cc_140 ( N_B_M12_noxref_g N_noxref_6_c_1366_n ) capacitor c=0.00814026f \
 //x=5.26 //y=6.205 //x2=5.36 //y2=7.09
cc_141 ( N_B_c_49_p N_noxref_6_c_1372_n ) capacitor c=0.0271892f //x=4.775 \
 //y=4.64 //x2=1.722 //y2=5.39
cc_142 ( N_B_M7_noxref_g N_noxref_6_c_1372_n ) capacitor c=0.0018075f //x=1.5 \
 //y=6.205 //x2=1.722 //y2=5.39
cc_143 ( N_B_M8_noxref_g N_noxref_6_c_1372_n ) capacitor c=0.00310294f \
 //x=1.94 //y=6.205 //x2=1.722 //y2=5.39
cc_144 ( N_B_c_58_p N_noxref_6_c_1372_n ) capacitor c=0.00218288f //x=1.865 \
 //y=4.975 //x2=1.722 //y2=5.39
cc_145 ( N_B_M11_noxref_g N_noxref_6_c_1376_n ) capacitor c=0.00395967f \
 //x=4.82 //y=6.205 //x2=4.6 //y2=6.92
cc_146 ( N_B_M12_noxref_g N_noxref_6_c_1377_n ) capacitor c=0.00179771f \
 //x=5.26 //y=6.205 //x2=5.477 //y2=7.09
cc_147 ( N_B_M7_noxref_g N_noxref_6_c_1378_n ) capacitor c=0.0161645f //x=1.5 \
 //y=6.205 //x2=1.72 //y2=5.56
cc_148 ( N_B_M8_noxref_g N_noxref_6_c_1378_n ) capacitor c=0.0177598f //x=1.94 \
 //y=6.205 //x2=1.72 //y2=5.56
cc_149 ( N_B_c_58_p N_noxref_6_c_1378_n ) capacitor c=0.00293723f //x=1.865 \
 //y=4.975 //x2=1.72 //y2=5.56
cc_150 ( N_B_c_49_p N_noxref_6_c_1381_n ) capacitor c=0.00371683f //x=4.775 \
 //y=4.64 //x2=2.6 //y2=5.39
cc_151 ( B N_noxref_6_c_1382_n ) capacitor c=8.93089e-19 //x=4.93 //y=4.62 \
 //x2=4.6 //y2=5.39
cc_152 ( N_B_c_49_p N_noxref_6_c_1382_n ) capacitor c=0.00277723f //x=4.775 \
 //y=4.64 //x2=4.6 //y2=5.39
cc_153 ( N_B_M11_noxref_g N_noxref_6_c_1382_n ) capacitor c=0.0503042f \
 //x=4.82 //y=6.205 //x2=4.6 //y2=5.39
cc_154 ( N_B_M7_noxref_g N_noxref_6_M7_noxref_d ) capacitor c=0.00124621f \
 //x=1.5 //y=6.205 //x2=1.575 //y2=5.205
cc_155 ( N_B_M8_noxref_g N_noxref_6_M7_noxref_d ) capacitor c=0.00125665f \
 //x=1.94 //y=6.205 //x2=1.575 //y2=5.205
cc_156 ( N_B_M12_noxref_g N_noxref_6_M12_noxref_d ) capacitor c=0.0142133f \
 //x=5.26 //y=6.205 //x2=5.335 //y2=5.205
cc_157 ( N_B_M12_noxref_g N_noxref_7_c_1526_n ) capacitor c=0.00969072f \
 //x=5.26 //y=6.205 //x2=5.805 //y2=5.39
cc_158 ( B N_noxref_7_c_1527_n ) capacitor c=0.00879697f //x=4.93 //y=4.62 \
 //x2=5.04 //y2=5.39
cc_159 ( N_B_c_3_p N_noxref_7_c_1527_n ) capacitor c=0.00708476f //x=4.935 \
 //y=4.64 //x2=5.04 //y2=5.39
cc_160 ( N_B_c_4_p N_noxref_7_c_1527_n ) capacitor c=0.00212816f //x=4.93 \
 //y=4.62 //x2=5.04 //y2=5.39
cc_161 ( N_B_M11_noxref_g N_noxref_7_c_1527_n ) capacitor c=0.00349804f \
 //x=4.82 //y=6.205 //x2=5.04 //y2=5.39
cc_162 ( N_B_M12_noxref_g N_noxref_7_c_1527_n ) capacitor c=0.00297228f \
 //x=5.26 //y=6.205 //x2=5.04 //y2=5.39
cc_163 ( N_B_c_12_p N_noxref_7_c_1527_n ) capacitor c=0.00149603f //x=4.93 \
 //y=4.885 //x2=5.04 //y2=5.39
cc_164 ( B N_noxref_7_c_1533_n ) capacitor c=0.0012994f //x=4.93 //y=4.62 \
 //x2=5.04 //y2=5.56
cc_165 ( N_B_c_4_p N_noxref_7_c_1533_n ) capacitor c=0.00447469f //x=4.93 \
 //y=4.62 //x2=5.04 //y2=5.56
cc_166 ( N_B_M11_noxref_g N_noxref_7_c_1533_n ) capacitor c=0.0120591f \
 //x=4.82 //y=6.205 //x2=5.04 //y2=5.56
cc_167 ( N_B_M12_noxref_g N_noxref_7_c_1533_n ) capacitor c=0.015288f //x=5.26 \
 //y=6.205 //x2=5.04 //y2=5.56
cc_168 ( N_B_c_12_p N_noxref_7_c_1533_n ) capacitor c=0.00417478f //x=4.93 \
 //y=4.885 //x2=5.04 //y2=5.56
cc_169 ( B N_GND_c_1663_n ) capacitor c=3.48111e-19 //x=1.23 //y=4.62 \
 //x2=1.585 //y2=0.175
cc_170 ( N_B_c_43_p N_GND_c_1663_n ) capacitor c=0.00181546f //x=1.23 \
 //y=2.375 //x2=1.585 //y2=0.175
cc_171 ( N_B_c_79_p N_GND_c_1665_n ) capacitor c=0.00166913f //x=1.405 \
 //y=1.045 //x2=1.67 //y2=1.015
cc_172 ( N_B_c_80_p N_GND_c_1665_n ) capacitor c=0.00373916f //x=1.405 \
 //y=1.39 //x2=1.67 //y2=1.015
cc_173 ( N_B_c_82_p N_GND_c_1665_n ) capacitor c=3.46977e-19 //x=1.405 //y=1.7 \
 //x2=1.67 //y2=1.015
cc_174 ( N_B_c_174_p N_GND_c_1665_n ) capacitor c=0.00924177f //x=1.78 \
 //y=0.89 //x2=1.67 //y2=1.015
cc_175 ( N_B_c_175_p N_GND_c_1665_n ) capacitor c=7.91264e-19 //x=1.78 \
 //y=1.545 //x2=1.67 //y2=1.015
cc_176 ( N_B_c_81_p N_GND_c_1665_n ) capacitor c=0.00205853f //x=1.935 \
 //y=1.045 //x2=1.67 //y2=1.015
cc_177 ( N_B_c_83_p N_GND_c_1665_n ) capacitor c=0.00402706f //x=1.935 \
 //y=1.39 //x2=1.67 //y2=1.015
cc_178 ( N_B_c_7_p N_GND_c_1672_n ) capacitor c=0.00456909f //x=4.93 //y=2.385 \
 //x2=5 //y2=1.015
cc_179 ( N_B_c_8_p N_GND_c_1672_n ) capacitor c=4.35087e-19 //x=4.93 //y=2.26 \
 //x2=5 //y2=1.015
cc_180 ( N_B_c_25_p N_GND_c_1672_n ) capacitor c=0.00174776f //x=4.735 \
 //y=1.045 //x2=5 //y2=1.015
cc_181 ( N_B_c_26_p N_GND_c_1672_n ) capacitor c=0.00349898f //x=4.735 \
 //y=1.39 //x2=5 //y2=1.015
cc_182 ( N_B_c_28_p N_GND_c_1672_n ) capacitor c=2.39384e-19 //x=4.735 //y=1.7 \
 //x2=5 //y2=1.015
cc_183 ( N_B_c_183_p N_GND_c_1672_n ) capacitor c=0.00936969f //x=5.11 \
 //y=0.89 //x2=5 //y2=1.015
cc_184 ( N_B_c_184_p N_GND_c_1672_n ) capacitor c=0.00220551f //x=5.11 \
 //y=1.545 //x2=5 //y2=1.015
cc_185 ( N_B_c_27_p N_GND_c_1672_n ) capacitor c=0.00190243f //x=5.265 \
 //y=1.045 //x2=5 //y2=1.015
cc_186 ( N_B_c_29_p N_GND_c_1672_n ) capacitor c=0.00369501f //x=5.265 \
 //y=1.39 //x2=5 //y2=1.015
cc_187 ( N_B_c_79_p N_GND_c_1681_n ) capacitor c=0.00696333f //x=1.405 \
 //y=1.045 //x2=3.65 //y2=0.175
cc_188 ( B N_GND_c_1682_n ) capacitor c=0.0172054f //x=1.23 //y=2.77 //x2=1.23 \
 //y2=0.18
cc_189 ( N_B_c_43_p N_GND_c_1682_n ) capacitor c=0.00793669f //x=1.23 \
 //y=2.375 //x2=1.23 //y2=0.18
cc_190 ( N_B_c_41_p N_GND_c_1682_n ) capacitor c=0.00791319f //x=1.23 //y=2.26 \
 //x2=1.23 //y2=0.18
cc_191 ( N_B_c_82_p N_GND_c_1682_n ) capacitor c=0.00264481f //x=1.405 //y=1.7 \
 //x2=1.23 //y2=0.18
cc_192 ( N_B_c_85_p N_GND_c_1682_n ) capacitor c=0.00440632f //x=1.405 \
 //y=2.095 //x2=1.23 //y2=0.18
cc_193 ( N_B_c_46_p N_GND_c_1682_n ) capacitor c=0.00706746f //x=1.23 //y=2.26 \
 //x2=1.23 //y2=0.18
cc_194 ( N_B_c_25_p N_GND_c_1688_n ) capacitor c=0.00688488f //x=4.735 \
 //y=1.045 //x2=6.98 //y2=0.175
cc_195 ( B N_GND_c_1689_n ) capacitor c=0.00917348f //x=4.93 //y=2.77 \
 //x2=3.82 //y2=0.175
cc_196 ( N_B_c_7_p N_GND_c_1689_n ) capacitor c=0.00537602f //x=4.93 //y=2.385 \
 //x2=3.82 //y2=0.175
cc_197 ( N_B_c_8_p N_GND_c_1689_n ) capacitor c=0.00369534f //x=4.93 //y=2.26 \
 //x2=3.82 //y2=0.175
cc_198 ( N_B_c_18_p N_GND_c_1689_n ) capacitor c=0.00956283f //x=4.735 \
 //y=2.095 //x2=3.82 //y2=0.175
cc_199 ( N_B_c_79_p N_GND_M0_noxref_d ) capacitor c=0.00192399f //x=1.405 \
 //y=1.045 //x2=1.48 //y2=1.045
cc_200 ( N_B_c_80_p N_GND_M0_noxref_d ) capacitor c=0.00210798f //x=1.405 \
 //y=1.39 //x2=1.48 //y2=1.045
cc_201 ( N_B_c_174_p N_GND_M0_noxref_d ) capacitor c=0.00472259f //x=1.78 \
 //y=0.89 //x2=1.48 //y2=1.045
cc_202 ( N_B_c_175_p N_GND_M0_noxref_d ) capacitor c=0.00166857f //x=1.78 \
 //y=1.545 //x2=1.48 //y2=1.045
cc_203 ( N_B_c_81_p N_GND_M0_noxref_d ) capacitor c=0.00230174f //x=1.935 \
 //y=1.045 //x2=1.48 //y2=1.045
cc_204 ( N_B_c_83_p N_GND_M0_noxref_d ) capacitor c=0.00210798f //x=1.935 \
 //y=1.39 //x2=1.48 //y2=1.045
cc_205 ( N_B_c_7_p N_GND_M2_noxref_d ) capacitor c=4.20217e-19 //x=4.93 \
 //y=2.385 //x2=4.81 //y2=1.045
cc_206 ( N_B_c_25_p N_GND_M2_noxref_d ) capacitor c=0.00192399f //x=4.735 \
 //y=1.045 //x2=4.81 //y2=1.045
cc_207 ( N_B_c_26_p N_GND_M2_noxref_d ) capacitor c=0.00228784f //x=4.735 \
 //y=1.39 //x2=4.81 //y2=1.045
cc_208 ( N_B_c_183_p N_GND_M2_noxref_d ) capacitor c=0.0047434f //x=5.11 \
 //y=0.89 //x2=4.81 //y2=1.045
cc_209 ( N_B_c_184_p N_GND_M2_noxref_d ) capacitor c=0.00172481f //x=5.11 \
 //y=1.545 //x2=4.81 //y2=1.045
cc_210 ( N_B_c_27_p N_GND_M2_noxref_d ) capacitor c=0.00230174f //x=5.265 \
 //y=1.045 //x2=4.81 //y2=1.045
cc_211 ( N_B_c_29_p N_GND_M2_noxref_d ) capacitor c=0.00228784f //x=5.265 \
 //y=1.39 //x2=4.81 //y2=1.045
cc_212 ( N_B_c_43_p N_noxref_10_c_2003_n ) capacitor c=0.0033606f //x=1.23 \
 //y=2.375 //x2=1.185 //y2=1.675
cc_213 ( N_B_c_41_p N_noxref_10_c_2003_n ) capacitor c=0.0101841f //x=1.23 \
 //y=2.26 //x2=1.185 //y2=1.675
cc_214 ( N_B_c_85_p N_noxref_10_c_2003_n ) capacitor c=0.0034165f //x=1.405 \
 //y=2.095 //x2=1.185 //y2=1.675
cc_215 ( N_B_c_46_p N_noxref_10_c_2003_n ) capacitor c=0.00545516f //x=1.23 \
 //y=2.26 //x2=1.185 //y2=1.675
cc_216 ( B N_noxref_10_c_2007_n ) capacitor c=0.00272432f //x=1.23 //y=4.62 \
 //x2=2.07 //y2=1.76
cc_217 ( N_B_c_43_p N_noxref_10_c_2007_n ) capacitor c=0.00202154f //x=1.23 \
 //y=2.375 //x2=2.07 //y2=1.76
cc_218 ( N_B_c_41_p N_noxref_10_c_2007_n ) capacitor c=0.00302338f //x=1.23 \
 //y=2.26 //x2=2.07 //y2=1.76
cc_219 ( N_B_c_82_p N_noxref_10_c_2007_n ) capacitor c=0.00720513f //x=1.405 \
 //y=1.7 //x2=2.07 //y2=1.76
cc_220 ( N_B_c_85_p N_noxref_10_c_2007_n ) capacitor c=0.0151009f //x=1.405 \
 //y=2.095 //x2=2.07 //y2=1.76
cc_221 ( N_B_c_175_p N_noxref_10_c_2007_n ) capacitor c=0.0094838f //x=1.78 \
 //y=1.545 //x2=2.07 //y2=1.76
cc_222 ( N_B_c_83_p N_noxref_10_c_2007_n ) capacitor c=0.00399755f //x=1.935 \
 //y=1.39 //x2=2.07 //y2=1.76
cc_223 ( N_B_c_46_p N_noxref_10_c_2007_n ) capacitor c=0.00168953f //x=1.23 \
 //y=2.26 //x2=2.07 //y2=1.76
cc_224 ( N_B_c_85_p N_noxref_10_c_2015_n ) capacitor c=6.71402e-19 //x=1.405 \
 //y=2.095 //x2=2.155 //y2=1.675
cc_225 ( N_B_c_79_p N_noxref_10_M0_noxref_s ) capacitor c=0.030618f //x=1.405 \
 //y=1.045 //x2=1.05 //y2=0.545
cc_226 ( N_B_c_82_p N_noxref_10_M0_noxref_s ) capacitor c=0.00110192f \
 //x=1.405 //y=1.7 //x2=1.05 //y2=0.545
cc_227 ( N_B_c_81_p N_noxref_10_M0_noxref_s ) capacitor c=0.0125442f //x=1.935 \
 //y=1.045 //x2=1.05 //y2=0.545
cc_228 ( N_B_c_18_p N_noxref_12_c_2079_n ) capacitor c=0.0034165f //x=4.735 \
 //y=2.095 //x2=4.515 //y2=1.675
cc_229 ( B N_noxref_12_c_2080_n ) capacitor c=0.00299239f //x=4.93 //y=4.62 \
 //x2=5.4 //y2=1.76
cc_230 ( N_B_c_7_p N_noxref_12_c_2080_n ) capacitor c=0.00541004f //x=4.93 \
 //y=2.385 //x2=5.4 //y2=1.76
cc_231 ( N_B_c_8_p N_noxref_12_c_2080_n ) capacitor c=0.00763108f //x=4.93 \
 //y=2.26 //x2=5.4 //y2=1.76
cc_232 ( N_B_c_28_p N_noxref_12_c_2080_n ) capacitor c=0.00688171f //x=4.735 \
 //y=1.7 //x2=5.4 //y2=1.76
cc_233 ( N_B_c_18_p N_noxref_12_c_2080_n ) capacitor c=0.0192505f //x=4.735 \
 //y=2.095 //x2=5.4 //y2=1.76
cc_234 ( N_B_c_184_p N_noxref_12_c_2080_n ) capacitor c=0.00720053f //x=5.11 \
 //y=1.545 //x2=5.4 //y2=1.76
cc_235 ( N_B_c_29_p N_noxref_12_c_2080_n ) capacitor c=0.0059368f //x=5.265 \
 //y=1.39 //x2=5.4 //y2=1.76
cc_236 ( N_B_c_18_p N_noxref_12_c_2087_n ) capacitor c=0.00122123f //x=4.735 \
 //y=2.095 //x2=5.485 //y2=1.675
cc_237 ( N_B_c_25_p N_noxref_12_M2_noxref_s ) capacitor c=0.0303347f //x=4.735 \
 //y=1.045 //x2=4.38 //y2=0.545
cc_238 ( N_B_c_28_p N_noxref_12_M2_noxref_s ) capacitor c=3.48408e-19 \
 //x=4.735 //y=1.7 //x2=4.38 //y2=0.545
cc_239 ( N_B_c_27_p N_noxref_12_M2_noxref_s ) capacitor c=0.012348f //x=5.265 \
 //y=1.045 //x2=4.38 //y2=0.545
cc_240 ( C A ) capacitor c=0.0013225f //x=6.41 //y=2.77 //x2=2.34 //y2=2.77
cc_241 ( C A ) capacitor c=0.0021622f //x=6.41 //y=2.77 //x2=9 //y2=2.77
cc_242 ( C A ) capacitor c=0.0512448f //x=7.89 //y=2.77 //x2=9 //y2=2.77
cc_243 ( N_C_c_281_p A ) capacitor c=0.0011922f //x=7.89 //y=2.43 //x2=9 \
 //y2=2.77
cc_244 ( N_C_c_282_p A ) capacitor c=0.00107415f //x=7.885 //y=2.27 //x2=9 \
 //y2=2.77
cc_245 ( C A ) capacitor c=9.13182e-19 //x=6.41 //y=2.77 //x2=9 //y2=4.62
cc_246 ( C A ) capacitor c=0.0102239f //x=7.89 //y=2.77 //x2=9 //y2=4.62
cc_247 ( N_C_c_285_p A ) capacitor c=4.72208e-19 //x=7.89 //y=4.885 //x2=9 \
 //y2=4.62
cc_248 ( N_C_c_286_p A ) capacitor c=2.82097e-19 //x=8.235 //y=4.975 //x2=9 \
 //y2=4.62
cc_249 ( C A ) capacitor c=5.15538e-19 //x=7.89 //y=2.77 //x2=9 //y2=4.25
cc_250 ( C N_A_c_489_n ) capacitor c=3.22024e-19 //x=6.41 //y=2.77 //x2=2.34 \
 //y2=4.71
cc_251 ( N_C_c_248_n N_A_c_489_n ) capacitor c=0.00134435f //x=6.41 //y=4.76 \
 //x2=2.34 //y2=4.71
cc_252 ( N_C_c_281_p N_A_c_547_n ) capacitor c=0.0061363f //x=7.89 //y=2.43 \
 //x2=9 //y2=2.38
cc_253 ( N_C_c_282_p N_A_c_547_n ) capacitor c=0.00602448f //x=7.885 //y=2.27 \
 //x2=9 //y2=2.38
cc_254 ( N_C_c_292_p N_A_c_547_n ) capacitor c=2.06418e-19 //x=7.89 //y=2.26 \
 //x2=9 //y2=2.38
cc_255 ( N_C_c_293_p N_A_c_547_n ) capacitor c=6.73725e-19 //x=7.89 //y=2.26 \
 //x2=9 //y2=2.38
cc_256 ( C N_A_c_551_n ) capacitor c=0.00771726f //x=7.89 //y=2.77 //x2=9 \
 //y2=4.37
cc_257 ( N_C_c_295_p N_A_c_552_n ) capacitor c=0.011624f //x=7.89 //y=4.755 \
 //x2=9 //y2=4.74
cc_258 ( N_C_c_285_p N_A_c_552_n ) capacitor c=3.34205e-19 //x=7.89 //y=4.885 \
 //x2=9 //y2=4.74
cc_259 ( N_C_c_297_p N_A_c_552_n ) capacitor c=0.00125146f //x=8.525 //y=4.975 \
 //x2=9 //y2=4.74
cc_260 ( N_C_c_286_p N_A_c_552_n ) capacitor c=7.4985e-19 //x=8.235 //y=4.975 \
 //x2=9 //y2=4.74
cc_261 ( C N_A_c_556_n ) capacitor c=0.00250167f //x=7.89 //y=2.77 //x2=9.015 \
 //y2=4.21
cc_262 ( C N_A_c_502_n ) capacitor c=0.0355227f //x=6.41 //y=2.77 //x2=8.855 \
 //y2=4.21
cc_263 ( C N_A_c_502_n ) capacitor c=0.0340275f //x=7.89 //y=2.77 //x2=8.855 \
 //y2=4.21
cc_264 ( N_C_c_245_n N_A_c_502_n ) capacitor c=0.00231224f //x=6.41 //y=2.43 \
 //x2=8.855 //y2=4.21
cc_265 ( N_C_c_248_n N_A_c_502_n ) capacitor c=0.00500803f //x=6.41 //y=4.76 \
 //x2=8.855 //y2=4.21
cc_266 ( N_C_c_281_p N_A_c_502_n ) capacitor c=0.00231693f //x=7.89 //y=2.43 \
 //x2=8.855 //y2=4.21
cc_267 ( N_C_c_295_p N_A_c_502_n ) capacitor c=0.00475839f //x=7.89 //y=4.755 \
 //x2=8.855 //y2=4.21
cc_268 ( N_C_c_252_n N_A_c_502_n ) capacitor c=0.00472291f //x=6.575 //y=2.27 \
 //x2=8.855 //y2=4.21
cc_269 ( N_C_c_282_p N_A_c_502_n ) capacitor c=0.00472291f //x=7.885 //y=2.27 \
 //x2=8.855 //y2=4.21
cc_270 ( N_C_c_308_p N_A_c_502_n ) capacitor c=0.0202481f //x=7.725 //y=2.27 \
 //x2=8.855 //y2=4.21
cc_271 ( N_C_c_281_p N_A_c_566_n ) capacitor c=7.58956e-19 //x=7.89 //y=2.43 \
 //x2=9 //y2=2.26
cc_272 ( N_C_c_292_p N_A_c_566_n ) capacitor c=0.00113671f //x=7.89 //y=2.26 \
 //x2=9 //y2=2.26
cc_273 ( N_C_c_293_p N_A_c_566_n ) capacitor c=0.00169858f //x=7.89 //y=2.26 \
 //x2=9 //y2=2.26
cc_274 ( N_C_c_295_p N_A_c_569_n ) capacitor c=2.02321e-19 //x=7.89 //y=4.755 \
 //x2=9.02 //y2=4.885
cc_275 ( N_C_c_285_p N_A_c_569_n ) capacitor c=0.00106454f //x=7.89 //y=4.885 \
 //x2=9.02 //y2=4.885
cc_276 ( N_C_c_297_p N_A_c_569_n ) capacitor c=0.00147609f //x=8.525 //y=4.975 \
 //x2=9.02 //y2=4.885
cc_277 ( N_C_c_286_p N_A_c_569_n ) capacitor c=0.00127381f //x=8.235 //y=4.975 \
 //x2=9.02 //y2=4.885
cc_278 ( N_C_M15_noxref_g N_A_M17_noxref_g ) capacitor c=0.00935155f //x=8.16 \
 //y=6.205 //x2=9.04 //y2=6.205
cc_279 ( N_C_M16_noxref_g N_A_M17_noxref_g ) capacitor c=0.111828f //x=8.6 \
 //y=6.205 //x2=9.04 //y2=6.205
cc_280 ( N_C_M16_noxref_g N_A_M18_noxref_g ) capacitor c=0.00876656f //x=8.6 \
 //y=6.205 //x2=9.48 //y2=6.205
cc_281 ( N_C_c_319_p N_A_c_576_n ) capacitor c=4.86545e-19 //x=8.065 //y=1.045 \
 //x2=9.035 //y2=1.085
cc_282 ( N_C_c_320_p N_A_c_576_n ) capacitor c=0.00152405f //x=8.065 //y=1.39 \
 //x2=9.035 //y2=1.085
cc_283 ( N_C_c_321_p N_A_c_576_n ) capacitor c=0.0151424f //x=8.595 //y=1.045 \
 //x2=9.035 //y2=1.085
cc_284 ( N_C_c_322_p N_A_c_579_n ) capacitor c=0.00109722f //x=8.065 //y=1.7 \
 //x2=9.035 //y2=1.435
cc_285 ( N_C_c_323_p N_A_c_579_n ) capacitor c=0.0111013f //x=8.595 //y=1.39 \
 //x2=9.035 //y2=1.435
cc_286 ( N_C_c_322_p N_A_c_581_n ) capacitor c=0.00179029f //x=8.065 //y=1.7 \
 //x2=9.035 //y2=1.74
cc_287 ( N_C_c_325_p N_A_c_581_n ) capacitor c=0.00662747f //x=8.065 //y=2.095 \
 //x2=9.035 //y2=1.74
cc_288 ( N_C_c_323_p N_A_c_581_n ) capacitor c=0.00862358f //x=8.595 //y=1.39 \
 //x2=9.035 //y2=1.74
cc_289 ( N_C_c_323_p N_A_c_584_n ) capacitor c=4.75927e-19 //x=8.595 //y=1.39 \
 //x2=9.41 //y2=1.585
cc_290 ( N_C_c_321_p N_A_c_585_n ) capacitor c=0.00130607f //x=8.595 //y=1.045 \
 //x2=9.565 //y2=1.085
cc_291 ( N_C_c_323_p N_A_c_586_n ) capacitor c=0.00153205f //x=8.595 //y=1.39 \
 //x2=9.565 //y2=1.435
cc_292 ( N_C_c_281_p N_A_c_587_n ) capacitor c=0.00157228f //x=7.89 //y=2.43 \
 //x2=9 //y2=2.26
cc_293 ( N_C_c_292_p N_A_c_587_n ) capacitor c=0.00194209f //x=7.89 //y=2.26 \
 //x2=9 //y2=2.26
cc_294 ( N_C_c_293_p N_A_c_587_n ) capacitor c=0.00887988f //x=7.89 //y=2.26 \
 //x2=9 //y2=2.26
cc_295 ( N_C_c_295_p N_A_c_590_n ) capacitor c=0.00132485f //x=7.89 //y=4.755 \
 //x2=9.02 //y2=4.885
cc_296 ( N_C_c_285_p N_A_c_590_n ) capacitor c=0.00167042f //x=7.89 //y=4.885 \
 //x2=9.02 //y2=4.885
cc_297 ( N_C_c_297_p N_A_c_590_n ) capacitor c=0.022796f //x=8.525 //y=4.975 \
 //x2=9.02 //y2=4.885
cc_298 ( N_C_c_286_p N_A_c_590_n ) capacitor c=0.00470299f //x=8.235 //y=4.975 \
 //x2=9.02 //y2=4.885
cc_299 ( N_C_M16_noxref_g N_noxref_4_c_777_n ) capacitor c=0.00969448f //x=8.6 \
 //y=6.205 //x2=9.135 //y2=5.39
cc_300 ( C N_noxref_4_c_778_n ) capacitor c=0.00363479f //x=7.89 //y=2.77 \
 //x2=9.74 //y2=4.095
cc_301 ( N_C_c_281_p N_noxref_4_c_778_n ) capacitor c=8.05281e-19 //x=7.89 \
 //y=2.43 //x2=9.74 //y2=4.095
cc_302 ( C N_noxref_4_c_780_n ) capacitor c=0.00136963f //x=7.89 //y=2.77 \
 //x2=9.74 //y2=5.305
cc_303 ( N_C_c_264_n N_noxref_4_c_781_n ) capacitor c=5.10033e-19 //x=5.705 \
 //y=1.085 //x2=5.97 //y2=1.36
cc_304 ( N_C_c_267_n N_noxref_4_c_781_n ) capacitor c=0.00606934f //x=5.705 \
 //y=1.43 //x2=5.97 //y2=1.36
cc_305 ( N_C_c_343_p N_noxref_4_c_781_n ) capacitor c=4.65567e-19 //x=6.08 \
 //y=0.93 //x2=5.97 //y2=1.36
cc_306 ( N_C_c_344_p N_noxref_4_c_781_n ) capacitor c=0.00247382f //x=6.08 \
 //y=1.585 //x2=5.97 //y2=1.36
cc_307 ( N_C_c_273_n N_noxref_4_c_781_n ) capacitor c=2.15736e-19 //x=6.235 \
 //y=1.085 //x2=5.97 //y2=1.36
cc_308 ( N_C_c_274_n N_noxref_4_c_781_n ) capacitor c=0.00259159f //x=6.235 \
 //y=1.43 //x2=5.97 //y2=1.36
cc_309 ( N_C_c_275_n N_noxref_4_c_781_n ) capacitor c=0.00150348f //x=6.235 \
 //y=1.74 //x2=5.97 //y2=1.36
cc_310 ( N_C_M15_noxref_g N_noxref_4_c_788_n ) capacitor c=0.00363978f \
 //x=8.16 //y=6.205 //x2=8.38 //y2=5.39
cc_311 ( N_C_M16_noxref_g N_noxref_4_c_788_n ) capacitor c=0.00185829f //x=8.6 \
 //y=6.205 //x2=8.38 //y2=5.39
cc_312 ( N_C_c_297_p N_noxref_4_c_788_n ) capacitor c=0.0021827f //x=8.525 \
 //y=4.975 //x2=8.38 //y2=5.39
cc_313 ( N_C_c_267_n N_noxref_4_c_773_n ) capacitor c=0.00147665f //x=5.705 \
 //y=1.43 //x2=5.84 //y2=1.405
cc_314 ( N_C_c_245_n N_noxref_4_c_792_n ) capacitor c=0.00831552f //x=6.41 \
 //y=2.43 //x2=9.135 //y2=1.405
cc_315 ( N_C_c_281_p N_noxref_4_c_792_n ) capacitor c=0.00831552f //x=7.89 \
 //y=2.43 //x2=9.135 //y2=1.405
cc_316 ( N_C_c_252_n N_noxref_4_c_792_n ) capacitor c=0.0128605f //x=6.575 \
 //y=2.27 //x2=9.135 //y2=1.405
cc_317 ( N_C_c_282_p N_noxref_4_c_792_n ) capacitor c=0.0128597f //x=7.885 \
 //y=2.27 //x2=9.135 //y2=1.405
cc_318 ( N_C_c_308_p N_noxref_4_c_792_n ) capacitor c=0.0434154f //x=7.725 \
 //y=2.27 //x2=9.135 //y2=1.405
cc_319 ( N_C_c_274_n N_noxref_4_c_792_n ) capacitor c=0.00215337f //x=6.235 \
 //y=1.43 //x2=9.135 //y2=1.405
cc_320 ( N_C_c_275_n N_noxref_4_c_792_n ) capacitor c=0.00349699f //x=6.235 \
 //y=1.74 //x2=9.135 //y2=1.405
cc_321 ( N_C_c_320_p N_noxref_4_c_792_n ) capacitor c=0.00277413f //x=8.065 \
 //y=1.39 //x2=9.135 //y2=1.405
cc_322 ( N_C_c_322_p N_noxref_4_c_792_n ) capacitor c=0.00245466f //x=8.065 \
 //y=1.7 //x2=9.135 //y2=1.405
cc_323 ( N_C_c_323_p N_noxref_4_c_792_n ) capacitor c=0.00460244f //x=8.595 \
 //y=1.39 //x2=9.135 //y2=1.405
cc_324 ( N_C_M15_noxref_g N_noxref_4_c_802_n ) capacitor c=0.0120591f //x=8.16 \
 //y=6.205 //x2=8.38 //y2=5.56
cc_325 ( N_C_M16_noxref_g N_noxref_4_c_802_n ) capacitor c=0.0142133f //x=8.6 \
 //y=6.205 //x2=8.38 //y2=5.56
cc_326 ( N_C_c_297_p N_noxref_4_c_802_n ) capacitor c=0.00293135f //x=8.525 \
 //y=4.975 //x2=8.38 //y2=5.56
cc_327 ( N_C_c_264_n N_noxref_4_M3_noxref_d ) capacitor c=0.00217566f \
 //x=5.705 //y=1.085 //x2=5.78 //y2=1.085
cc_328 ( N_C_c_267_n N_noxref_4_M3_noxref_d ) capacitor c=0.00693963f \
 //x=5.705 //y=1.43 //x2=5.78 //y2=1.085
cc_329 ( N_C_c_343_p N_noxref_4_M3_noxref_d ) capacitor c=0.00234223f //x=6.08 \
 //y=0.93 //x2=5.78 //y2=1.085
cc_330 ( N_C_c_344_p N_noxref_4_M3_noxref_d ) capacitor c=0.00513213f //x=6.08 \
 //y=1.585 //x2=5.78 //y2=1.085
cc_331 ( N_C_c_273_n N_noxref_4_M3_noxref_d ) capacitor c=0.00132245f \
 //x=6.235 //y=1.085 //x2=5.78 //y2=1.085
cc_332 ( N_C_c_274_n N_noxref_4_M3_noxref_d ) capacitor c=0.00326247f \
 //x=6.235 //y=1.43 //x2=5.78 //y2=1.085
cc_333 ( N_C_c_275_n N_noxref_4_M3_noxref_d ) capacitor c=0.00231463f \
 //x=6.235 //y=1.74 //x2=5.78 //y2=1.085
cc_334 ( N_C_M13_noxref_g N_VDD_c_1120_n ) capacitor c=0.00782837f //x=5.7 \
 //y=6.205 //x2=6.98 //y2=7.585
cc_335 ( N_C_M14_noxref_g N_VDD_c_1120_n ) capacitor c=0.00782837f //x=6.14 \
 //y=6.205 //x2=6.98 //y2=7.585
cc_336 ( N_C_M15_noxref_g N_VDD_c_1138_n ) capacitor c=0.00782837f //x=8.16 \
 //y=6.205 //x2=10.31 //y2=7.585
cc_337 ( N_C_M16_noxref_g N_VDD_c_1138_n ) capacitor c=0.00782837f //x=8.6 \
 //y=6.205 //x2=10.31 //y2=7.585
cc_338 ( C N_VDD_c_1129_n ) capacitor c=0.0100754f //x=6.41 //y=2.77 //x2=7.15 \
 //y2=7.585
cc_339 ( C N_VDD_c_1129_n ) capacitor c=0.0104042f //x=7.89 //y=2.77 //x2=7.15 \
 //y2=7.585
cc_340 ( N_C_c_248_n N_VDD_c_1129_n ) capacitor c=0.00552497f //x=6.41 \
 //y=4.76 //x2=7.15 //y2=7.585
cc_341 ( N_C_c_295_p N_VDD_c_1129_n ) capacitor c=0.00593694f //x=7.89 \
 //y=4.755 //x2=7.15 //y2=7.585
cc_342 ( N_C_c_258_n N_VDD_c_1129_n ) capacitor c=0.00790417f //x=6.41 \
 //y=4.885 //x2=7.15 //y2=7.585
cc_343 ( N_C_c_285_p N_VDD_c_1129_n ) capacitor c=0.00790205f //x=7.89 \
 //y=4.885 //x2=7.15 //y2=7.585
cc_344 ( N_C_M14_noxref_g N_VDD_c_1129_n ) capacitor c=0.0138263f //x=6.14 \
 //y=6.205 //x2=7.15 //y2=7.585
cc_345 ( N_C_M15_noxref_g N_VDD_c_1129_n ) capacitor c=0.00855037f //x=8.16 \
 //y=6.205 //x2=7.15 //y2=7.585
cc_346 ( N_C_c_271_n N_VDD_c_1129_n ) capacitor c=0.00722671f //x=6.14 \
 //y=5.05 //x2=7.15 //y2=7.585
cc_347 ( N_C_c_286_p N_VDD_c_1129_n ) capacitor c=0.00720105f //x=8.235 \
 //y=4.975 //x2=7.15 //y2=7.585
cc_348 ( N_C_M13_noxref_g N_noxref_6_c_1388_n ) capacitor c=0.00814026f \
 //x=5.7 //y=6.205 //x2=6.245 //y2=7.09
cc_349 ( N_C_M14_noxref_g N_noxref_6_c_1388_n ) capacitor c=0.00937408f \
 //x=6.14 //y=6.205 //x2=6.245 //y2=7.09
cc_350 ( N_C_M13_noxref_g N_noxref_6_c_1377_n ) capacitor c=0.0017976f //x=5.7 \
 //y=6.205 //x2=5.477 //y2=7.09
cc_351 ( N_C_M14_noxref_g N_noxref_6_c_1391_n ) capacitor c=0.00395674f \
 //x=6.14 //y=6.205 //x2=6.36 //y2=6.92
cc_352 ( N_C_M13_noxref_g N_noxref_6_M12_noxref_d ) capacitor c=0.0142133f \
 //x=5.7 //y=6.205 //x2=5.335 //y2=5.205
cc_353 ( N_C_c_258_n N_noxref_6_M14_noxref_d ) capacitor c=0.00256087f \
 //x=6.41 //y=4.885 //x2=6.215 //y2=5.205
cc_354 ( N_C_M14_noxref_g N_noxref_6_M14_noxref_d ) capacitor c=0.0365939f \
 //x=6.14 //y=6.205 //x2=6.215 //y2=5.205
cc_355 ( N_C_c_271_n N_noxref_6_M14_noxref_d ) capacitor c=0.00447202f \
 //x=6.14 //y=5.05 //x2=6.215 //y2=5.205
cc_356 ( N_C_M13_noxref_g N_noxref_7_c_1526_n ) capacitor c=0.00998198f \
 //x=5.7 //y=6.205 //x2=5.805 //y2=5.39
cc_357 ( N_C_c_245_n N_noxref_7_c_1539_n ) capacitor c=0.00143791f //x=6.41 \
 //y=2.43 //x2=7.825 //y2=5.39
cc_358 ( N_C_c_248_n N_noxref_7_c_1539_n ) capacitor c=0.0227143f //x=6.41 \
 //y=4.76 //x2=7.825 //y2=5.39
cc_359 ( N_C_c_281_p N_noxref_7_c_1539_n ) capacitor c=0.00141341f //x=7.89 \
 //y=2.43 //x2=7.825 //y2=5.39
cc_360 ( N_C_c_295_p N_noxref_7_c_1539_n ) capacitor c=0.0274606f //x=7.89 \
 //y=4.755 //x2=7.825 //y2=5.39
cc_361 ( N_C_c_258_n N_noxref_7_c_1539_n ) capacitor c=0.0035251f //x=6.41 \
 //y=4.885 //x2=7.825 //y2=5.39
cc_362 ( N_C_c_285_p N_noxref_7_c_1539_n ) capacitor c=0.00429429f //x=7.89 \
 //y=4.885 //x2=7.825 //y2=5.39
cc_363 ( N_C_M14_noxref_g N_noxref_7_c_1539_n ) capacitor c=0.0119434f \
 //x=6.14 //y=6.205 //x2=7.825 //y2=5.39
cc_364 ( N_C_M15_noxref_g N_noxref_7_c_1539_n ) capacitor c=0.00372569f \
 //x=8.16 //y=6.205 //x2=7.825 //y2=5.39
cc_365 ( N_C_c_271_n N_noxref_7_c_1539_n ) capacitor c=0.00500633f //x=6.14 \
 //y=5.05 //x2=7.825 //y2=5.39
cc_366 ( N_C_c_286_p N_noxref_7_c_1539_n ) capacitor c=0.00243015f //x=8.235 \
 //y=4.975 //x2=7.825 //y2=5.39
cc_367 ( N_C_M13_noxref_g N_noxref_7_c_1549_n ) capacitor c=6.12451e-19 \
 //x=5.7 //y=6.205 //x2=6.035 //y2=5.39
cc_368 ( N_C_M14_noxref_g N_noxref_7_c_1549_n ) capacitor c=8.33934e-19 \
 //x=6.14 //y=6.205 //x2=6.035 //y2=5.39
cc_369 ( N_C_M15_noxref_g N_noxref_7_c_1551_n ) capacitor c=0.0109238f \
 //x=8.16 //y=6.205 //x2=8.705 //y2=7.09
cc_370 ( N_C_M16_noxref_g N_noxref_7_c_1551_n ) capacitor c=0.00814026f \
 //x=8.6 //y=6.205 //x2=8.705 //y2=7.09
cc_371 ( N_C_M13_noxref_g N_noxref_7_c_1553_n ) capacitor c=0.00610004f \
 //x=5.7 //y=6.205 //x2=5.92 //y2=5.39
cc_372 ( N_C_M14_noxref_g N_noxref_7_c_1553_n ) capacitor c=0.00485827f \
 //x=6.14 //y=6.205 //x2=5.92 //y2=5.39
cc_373 ( N_C_c_411_p N_noxref_7_c_1553_n ) capacitor c=0.00435703f //x=6.065 \
 //y=4.975 //x2=5.92 //y2=5.39
cc_374 ( N_C_M15_noxref_g N_noxref_7_c_1556_n ) capacitor c=0.00394587f \
 //x=8.16 //y=6.205 //x2=7.94 //y2=6.92
cc_375 ( N_C_M16_noxref_g N_noxref_7_c_1557_n ) capacitor c=0.00179267f \
 //x=8.6 //y=6.205 //x2=8.82 //y2=7.09
cc_376 ( N_C_c_295_p N_noxref_7_c_1558_n ) capacitor c=0.00533094f //x=7.89 \
 //y=4.755 //x2=7.94 //y2=5.39
cc_377 ( N_C_c_285_p N_noxref_7_c_1558_n ) capacitor c=0.013929f //x=7.89 \
 //y=4.885 //x2=7.94 //y2=5.39
cc_378 ( N_C_M15_noxref_g N_noxref_7_c_1558_n ) capacitor c=0.0510602f \
 //x=8.16 //y=6.205 //x2=7.94 //y2=5.39
cc_379 ( N_C_c_286_p N_noxref_7_c_1558_n ) capacitor c=0.00827092f //x=8.235 \
 //y=4.975 //x2=7.94 //y2=5.39
cc_380 ( N_C_M16_noxref_g N_noxref_7_M16_noxref_d ) capacitor c=0.0142133f \
 //x=8.6 //y=6.205 //x2=8.675 //y2=5.205
cc_381 ( N_C_c_245_n N_GND_c_1706_n ) capacitor c=9.61971e-19 //x=6.41 \
 //y=2.43 //x2=8.245 //y2=0.175
cc_382 ( N_C_c_281_p N_GND_c_1706_n ) capacitor c=0.00100426f //x=7.89 \
 //y=2.43 //x2=8.245 //y2=0.175
cc_383 ( N_C_c_292_p N_GND_c_1706_n ) capacitor c=2.64659e-19 //x=7.89 \
 //y=2.26 //x2=8.245 //y2=0.175
cc_384 ( N_C_c_319_p N_GND_c_1709_n ) capacitor c=0.00175529f //x=8.065 \
 //y=1.045 //x2=8.33 //y2=1.02
cc_385 ( N_C_c_320_p N_GND_c_1709_n ) capacitor c=0.00373063f //x=8.065 \
 //y=1.39 //x2=8.33 //y2=1.02
cc_386 ( N_C_c_322_p N_GND_c_1709_n ) capacitor c=3.99385e-19 //x=8.065 \
 //y=1.7 //x2=8.33 //y2=1.02
cc_387 ( N_C_c_425_p N_GND_c_1709_n ) capacitor c=0.00924233f //x=8.44 \
 //y=0.89 //x2=8.33 //y2=1.02
cc_388 ( N_C_c_426_p N_GND_c_1709_n ) capacitor c=6.20182e-19 //x=8.44 \
 //y=1.545 //x2=8.33 //y2=1.02
cc_389 ( N_C_c_321_p N_GND_c_1709_n ) capacitor c=0.00181395f //x=8.595 \
 //y=1.045 //x2=8.33 //y2=1.02
cc_390 ( N_C_c_323_p N_GND_c_1709_n ) capacitor c=0.00394995f //x=8.595 \
 //y=1.39 //x2=8.33 //y2=1.02
cc_391 ( N_C_c_245_n N_GND_c_1688_n ) capacitor c=9.4179e-19 //x=6.41 //y=2.43 \
 //x2=6.98 //y2=0.175
cc_392 ( N_C_c_281_p N_GND_c_1717_n ) capacitor c=6.59434e-19 //x=7.89 \
 //y=2.43 //x2=10.31 //y2=0.175
cc_393 ( N_C_c_319_p N_GND_c_1717_n ) capacitor c=0.00698682f //x=8.065 \
 //y=1.045 //x2=10.31 //y2=0.175
cc_394 ( N_C_c_254_n N_GND_c_1689_n ) capacitor c=3.88707e-19 //x=6.41 \
 //y=2.26 //x2=3.82 //y2=0.175
cc_395 ( C N_GND_c_1720_n ) capacitor c=0.0117547f //x=6.41 //y=2.77 //x2=7.15 \
 //y2=0.175
cc_396 ( C N_GND_c_1720_n ) capacitor c=0.0117547f //x=7.89 //y=2.77 //x2=7.15 \
 //y2=0.175
cc_397 ( N_C_c_245_n N_GND_c_1720_n ) capacitor c=0.00414357f //x=6.41 \
 //y=2.43 //x2=7.15 //y2=0.175
cc_398 ( N_C_c_281_p N_GND_c_1720_n ) capacitor c=0.00414357f //x=7.89 \
 //y=2.43 //x2=7.15 //y2=0.175
cc_399 ( N_C_c_308_p N_GND_c_1720_n ) capacitor c=0.0153655f //x=7.725 \
 //y=2.27 //x2=7.15 //y2=0.175
cc_400 ( N_C_c_254_n N_GND_c_1720_n ) capacitor c=0.00780676f //x=6.41 \
 //y=2.26 //x2=7.15 //y2=0.175
cc_401 ( N_C_c_292_p N_GND_c_1720_n ) capacitor c=0.00780676f //x=7.89 \
 //y=2.26 //x2=7.15 //y2=0.175
cc_402 ( N_C_c_276_n N_GND_c_1720_n ) capacitor c=0.00967557f //x=6.235 \
 //y=2.095 //x2=7.15 //y2=0.175
cc_403 ( N_C_c_325_p N_GND_c_1720_n ) capacitor c=0.00347725f //x=8.065 \
 //y=2.095 //x2=7.15 //y2=0.175
cc_404 ( N_C_c_293_p N_GND_c_1720_n ) capacitor c=0.00619832f //x=7.89 \
 //y=2.26 //x2=7.15 //y2=0.175
cc_405 ( N_C_c_292_p N_GND_c_1730_n ) capacitor c=2.74348e-19 //x=7.89 \
 //y=2.26 //x2=10.48 //y2=0.175
cc_406 ( N_C_c_319_p N_GND_M4_noxref_d ) capacitor c=0.00192399f //x=8.065 \
 //y=1.045 //x2=8.14 //y2=1.045
cc_407 ( N_C_c_320_p N_GND_M4_noxref_d ) capacitor c=0.00210798f //x=8.065 \
 //y=1.39 //x2=8.14 //y2=1.045
cc_408 ( N_C_c_425_p N_GND_M4_noxref_d ) capacitor c=0.00472259f //x=8.44 \
 //y=0.89 //x2=8.14 //y2=1.045
cc_409 ( N_C_c_426_p N_GND_M4_noxref_d ) capacitor c=0.00166857f //x=8.44 \
 //y=1.545 //x2=8.14 //y2=1.045
cc_410 ( N_C_c_321_p N_GND_M4_noxref_d ) capacitor c=0.00230174f //x=8.595 \
 //y=1.045 //x2=8.14 //y2=1.045
cc_411 ( N_C_c_323_p N_GND_M4_noxref_d ) capacitor c=0.00210798f //x=8.595 \
 //y=1.39 //x2=8.14 //y2=1.045
cc_412 ( N_C_M13_noxref_g noxref_11 ) capacitor c=0.00925495f //x=5.7 \
 //y=6.205 //x2=5.775 //y2=5.205
cc_413 ( N_C_M14_noxref_g noxref_11 ) capacitor c=0.00925495f //x=6.14 \
 //y=6.205 //x2=5.775 //y2=5.205
cc_414 ( N_C_c_276_n N_noxref_12_c_2087_n ) capacitor c=0.0028747f //x=6.235 \
 //y=2.095 //x2=5.485 //y2=1.675
cc_415 ( N_C_c_245_n N_noxref_12_c_2092_n ) capacitor c=7.24043e-19 //x=6.41 \
 //y=2.43 //x2=6.37 //y2=0.71
cc_416 ( N_C_c_264_n N_noxref_12_c_2092_n ) capacitor c=0.0214576f //x=5.705 \
 //y=1.085 //x2=6.37 //y2=0.71
cc_417 ( N_C_c_273_n N_noxref_12_c_2092_n ) capacitor c=0.00781103f //x=6.235 \
 //y=1.085 //x2=6.37 //y2=0.71
cc_418 ( N_C_c_245_n N_noxref_12_M2_noxref_s ) capacitor c=0.00472586f \
 //x=6.41 //y=2.43 //x2=4.38 //y2=0.545
cc_419 ( N_C_c_254_n N_noxref_12_M2_noxref_s ) capacitor c=0.010408f //x=6.41 \
 //y=2.26 //x2=4.38 //y2=0.545
cc_420 ( N_C_c_264_n N_noxref_12_M2_noxref_s ) capacitor c=0.00506846f \
 //x=5.705 //y=1.085 //x2=4.38 //y2=0.545
cc_421 ( N_C_c_267_n N_noxref_12_M2_noxref_s ) capacitor c=0.00602248f \
 //x=5.705 //y=1.43 //x2=4.38 //y2=0.545
cc_422 ( N_C_c_273_n N_noxref_12_M2_noxref_s ) capacitor c=0.028957f //x=6.235 \
 //y=1.085 //x2=4.38 //y2=0.545
cc_423 ( N_C_c_275_n N_noxref_12_M2_noxref_s ) capacitor c=0.00369225f \
 //x=6.235 //y=1.74 //x2=4.38 //y2=0.545
cc_424 ( N_C_c_276_n N_noxref_12_M2_noxref_s ) capacitor c=0.00797698f \
 //x=6.235 //y=2.095 //x2=4.38 //y2=0.545
cc_425 ( N_C_c_281_p N_noxref_13_c_2145_n ) capacitor c=0.00472586f //x=7.89 \
 //y=2.43 //x2=7.845 //y2=1.675
cc_426 ( N_C_c_292_p N_noxref_13_c_2145_n ) capacitor c=0.010408f //x=7.89 \
 //y=2.26 //x2=7.845 //y2=1.675
cc_427 ( N_C_c_325_p N_noxref_13_c_2145_n ) capacitor c=0.00262672f //x=8.065 \
 //y=2.095 //x2=7.845 //y2=1.675
cc_428 ( N_C_c_293_p N_noxref_13_c_2145_n ) capacitor c=0.00544234f //x=7.89 \
 //y=2.26 //x2=7.845 //y2=1.675
cc_429 ( N_C_c_281_p N_noxref_13_c_2149_n ) capacitor c=0.00350518f //x=7.89 \
 //y=2.43 //x2=8.73 //y2=1.76
cc_430 ( N_C_c_292_p N_noxref_13_c_2149_n ) capacitor c=0.00305795f //x=7.89 \
 //y=2.26 //x2=8.73 //y2=1.76
cc_431 ( N_C_c_322_p N_noxref_13_c_2149_n ) capacitor c=0.00712798f //x=8.065 \
 //y=1.7 //x2=8.73 //y2=1.76
cc_432 ( N_C_c_325_p N_noxref_13_c_2149_n ) capacitor c=0.013968f //x=8.065 \
 //y=2.095 //x2=8.73 //y2=1.76
cc_433 ( N_C_c_426_p N_noxref_13_c_2149_n ) capacitor c=0.00948889f //x=8.44 \
 //y=1.545 //x2=8.73 //y2=1.76
cc_434 ( N_C_c_323_p N_noxref_13_c_2149_n ) capacitor c=0.00339872f //x=8.595 \
 //y=1.39 //x2=8.73 //y2=1.76
cc_435 ( N_C_c_293_p N_noxref_13_c_2149_n ) capacitor c=0.00168631f //x=7.89 \
 //y=2.26 //x2=8.73 //y2=1.76
cc_436 ( N_C_c_325_p N_noxref_13_c_2156_n ) capacitor c=6.71402e-19 //x=8.065 \
 //y=2.095 //x2=8.815 //y2=1.675
cc_437 ( N_C_c_319_p N_noxref_13_M4_noxref_s ) capacitor c=0.0293163f \
 //x=8.065 //y=1.045 //x2=7.71 //y2=0.545
cc_438 ( N_C_c_322_p N_noxref_13_M4_noxref_s ) capacitor c=0.00110192f \
 //x=8.065 //y=1.7 //x2=7.71 //y2=0.545
cc_439 ( N_C_c_321_p N_noxref_13_M4_noxref_s ) capacitor c=0.0123625f \
 //x=8.595 //y=1.045 //x2=7.71 //y2=0.545
cc_440 ( N_A_c_551_n N_noxref_4_c_777_n ) capacitor c=0.00435926f //x=9 \
 //y=4.37 //x2=9.135 //y2=5.39
cc_441 ( N_A_c_552_n N_noxref_4_c_777_n ) capacitor c=0.0223378f //x=9 \
 //y=4.74 //x2=9.135 //y2=5.39
cc_442 ( N_A_c_556_n N_noxref_4_c_777_n ) capacitor c=7.70643e-19 //x=9.015 \
 //y=4.21 //x2=9.135 //y2=5.39
cc_443 ( N_A_c_502_n N_noxref_4_c_777_n ) capacitor c=0.0017832f //x=8.855 \
 //y=4.21 //x2=9.135 //y2=5.39
cc_444 ( N_A_c_569_n N_noxref_4_c_777_n ) capacitor c=0.00459858f //x=9.02 \
 //y=4.885 //x2=9.135 //y2=5.39
cc_445 ( N_A_M17_noxref_g N_noxref_4_c_777_n ) capacitor c=0.00846675f \
 //x=9.04 //y=6.205 //x2=9.135 //y2=5.39
cc_446 ( N_A_c_590_n N_noxref_4_c_777_n ) capacitor c=7.28626e-19 //x=9.02 \
 //y=4.885 //x2=9.135 //y2=5.39
cc_447 ( N_A_c_547_n N_noxref_4_c_819_n ) capacitor c=0.00233055f //x=9 \
 //y=2.38 //x2=9.3 //y2=1.535
cc_448 ( N_A_c_566_n N_noxref_4_c_819_n ) capacitor c=8.15893e-19 //x=9 \
 //y=2.26 //x2=9.3 //y2=1.535
cc_449 ( N_A_c_576_n N_noxref_4_c_819_n ) capacitor c=5.01861e-19 //x=9.035 \
 //y=1.085 //x2=9.3 //y2=1.535
cc_450 ( N_A_c_579_n N_noxref_4_c_819_n ) capacitor c=0.00397521f //x=9.035 \
 //y=1.435 //x2=9.3 //y2=1.535
cc_451 ( N_A_c_581_n N_noxref_4_c_819_n ) capacitor c=0.00205332f //x=9.035 \
 //y=1.74 //x2=9.3 //y2=1.535
cc_452 ( N_A_c_606_p N_noxref_4_c_819_n ) capacitor c=3.72732e-19 //x=9.41 \
 //y=0.93 //x2=9.3 //y2=1.535
cc_453 ( N_A_c_584_n N_noxref_4_c_819_n ) capacitor c=0.00187911f //x=9.41 \
 //y=1.585 //x2=9.3 //y2=1.535
cc_454 ( N_A_c_585_n N_noxref_4_c_819_n ) capacitor c=2.0901e-19 //x=9.565 \
 //y=1.085 //x2=9.3 //y2=1.535
cc_455 ( N_A_c_586_n N_noxref_4_c_819_n ) capacitor c=0.00241403f //x=9.565 \
 //y=1.435 //x2=9.3 //y2=1.535
cc_456 ( N_A_c_587_n N_noxref_4_c_819_n ) capacitor c=2.48891e-19 //x=9 \
 //y=2.26 //x2=9.3 //y2=1.535
cc_457 ( N_A_c_581_n N_noxref_4_c_829_n ) capacitor c=0.0018678f //x=9.035 \
 //y=1.74 //x2=9.3 //y2=1.74
cc_458 ( N_A_c_584_n N_noxref_4_c_829_n ) capacitor c=0.00592669f //x=9.41 \
 //y=1.585 //x2=9.3 //y2=1.74
cc_459 ( N_A_M18_noxref_g N_noxref_4_c_831_n ) capacitor c=0.0116091f //x=9.48 \
 //y=6.205 //x2=9.655 //y2=5.39
cc_460 ( N_A_c_584_n N_noxref_4_c_832_n ) capacitor c=0.0048413f //x=9.41 \
 //y=1.585 //x2=9.655 //y2=1.825
cc_461 ( N_A_c_615_p N_noxref_4_c_833_n ) capacitor c=0.00368358f //x=9 \
 //y=2.095 //x2=9.385 //y2=1.825
cc_462 ( A N_noxref_4_c_778_n ) capacitor c=0.0765587f //x=9 //y=2.77 \
 //x2=9.74 //y2=4.095
cc_463 ( N_A_c_547_n N_noxref_4_c_778_n ) capacitor c=0.0146548f //x=9 \
 //y=2.38 //x2=9.74 //y2=4.095
cc_464 ( N_A_c_551_n N_noxref_4_c_778_n ) capacitor c=0.0029642f //x=9 \
 //y=4.37 //x2=9.74 //y2=4.095
cc_465 ( N_A_c_556_n N_noxref_4_c_778_n ) capacitor c=0.00136148f //x=9.015 \
 //y=4.21 //x2=9.74 //y2=4.095
cc_466 ( N_A_c_566_n N_noxref_4_c_778_n ) capacitor c=0.00137695f //x=9 \
 //y=2.26 //x2=9.74 //y2=4.095
cc_467 ( N_A_c_587_n N_noxref_4_c_778_n ) capacitor c=0.00284078f //x=9 \
 //y=2.26 //x2=9.74 //y2=4.095
cc_468 ( N_A_c_615_p N_noxref_4_c_778_n ) capacitor c=0.00356275f //x=9 \
 //y=2.095 //x2=9.74 //y2=4.095
cc_469 ( A N_noxref_4_c_841_n ) capacitor c=0.00262509f //x=9 //y=4.62 \
 //x2=9.74 //y2=4.415
cc_470 ( A N_noxref_4_c_841_n ) capacitor c=8.95907e-19 //x=9 //y=4.25 \
 //x2=9.74 //y2=4.415
cc_471 ( N_A_c_551_n N_noxref_4_c_841_n ) capacitor c=0.0169977f //x=9 \
 //y=4.37 //x2=9.74 //y2=4.415
cc_472 ( N_A_c_556_n N_noxref_4_c_841_n ) capacitor c=0.00288053f //x=9.015 \
 //y=4.21 //x2=9.74 //y2=4.415
cc_473 ( A N_noxref_4_c_780_n ) capacitor c=0.0135184f //x=9 //y=4.62 \
 //x2=9.74 //y2=5.305
cc_474 ( N_A_c_552_n N_noxref_4_c_780_n ) capacitor c=0.017079f //x=9 //y=4.74 \
 //x2=9.74 //y2=5.305
cc_475 ( N_A_c_569_n N_noxref_4_c_780_n ) capacitor c=0.00179503f //x=9.02 \
 //y=4.885 //x2=9.74 //y2=5.305
cc_476 ( N_A_c_630_p N_noxref_4_c_780_n ) capacitor c=0.00864287f //x=9.405 \
 //y=4.975 //x2=9.74 //y2=5.305
cc_477 ( N_A_c_590_n N_noxref_4_c_780_n ) capacitor c=0.00141883f //x=9.02 \
 //y=4.885 //x2=9.74 //y2=5.305
cc_478 ( A N_noxref_4_c_850_n ) capacitor c=0.00300359f //x=9 //y=2.77 \
 //x2=11.22 //y2=4.095
cc_479 ( A N_noxref_4_c_851_n ) capacitor c=0.00111022f //x=9 //y=4.62 \
 //x2=11.22 //y2=4.76
cc_480 ( N_A_c_518_n N_noxref_4_c_852_n ) capacitor c=3.77121e-19 //x=2.375 \
 //y=1.085 //x2=2.64 //y2=1.36
cc_481 ( N_A_c_521_n N_noxref_4_c_852_n ) capacitor c=0.00250809f //x=2.375 \
 //y=1.43 //x2=2.64 //y2=1.36
cc_482 ( N_A_c_523_n N_noxref_4_c_852_n ) capacitor c=0.00152089f //x=2.375 \
 //y=1.74 //x2=2.64 //y2=1.36
cc_483 ( N_A_c_637_p N_noxref_4_c_852_n ) capacitor c=3.38306e-19 //x=2.75 \
 //y=0.93 //x2=2.64 //y2=1.36
cc_484 ( N_A_c_638_p N_noxref_4_c_852_n ) capacitor c=0.0022369f //x=2.75 \
 //y=1.585 //x2=2.64 //y2=1.36
cc_485 ( N_A_c_526_n N_noxref_4_c_852_n ) capacitor c=3.16128e-19 //x=2.905 \
 //y=1.085 //x2=2.64 //y2=1.36
cc_486 ( N_A_c_527_n N_noxref_4_c_852_n ) capacitor c=0.00792546f //x=2.905 \
 //y=1.43 //x2=2.64 //y2=1.36
cc_487 ( N_A_c_502_n N_noxref_4_c_788_n ) capacitor c=0.0169094f //x=8.855 \
 //y=4.21 //x2=8.38 //y2=5.39
cc_488 ( N_A_c_556_n N_noxref_4_c_860_n ) capacitor c=6.25661e-19 //x=9.015 \
 //y=4.21 //x2=9.257 //y2=5.39
cc_489 ( N_A_M17_noxref_g N_noxref_4_c_860_n ) capacitor c=0.00180711f \
 //x=9.04 //y=6.205 //x2=9.257 //y2=5.39
cc_490 ( N_A_M18_noxref_g N_noxref_4_c_860_n ) capacitor c=0.0027483f //x=9.48 \
 //y=6.205 //x2=9.257 //y2=5.39
cc_491 ( N_A_c_630_p N_noxref_4_c_860_n ) capacitor c=0.00216603f //x=9.405 \
 //y=4.975 //x2=9.257 //y2=5.39
cc_492 ( A N_noxref_4_c_864_n ) capacitor c=0.0102219f //x=9 //y=4.25 \
 //x2=9.74 //y2=4.25
cc_493 ( N_A_c_551_n N_noxref_4_c_864_n ) capacitor c=6.9092e-19 //x=9 \
 //y=4.37 //x2=9.74 //y2=4.25
cc_494 ( N_A_c_527_n N_noxref_4_c_773_n ) capacitor c=0.00147665f //x=2.905 \
 //y=1.43 //x2=5.84 //y2=1.405
cc_495 ( N_A_c_581_n N_noxref_4_c_867_n ) capacitor c=0.00131018f //x=9.035 \
 //y=1.74 //x2=9.295 //y2=1.405
cc_496 ( N_A_c_584_n N_noxref_4_c_867_n ) capacitor c=0.00184285f //x=9.41 \
 //y=1.585 //x2=9.295 //y2=1.405
cc_497 ( N_A_c_547_n N_noxref_4_c_792_n ) capacitor c=0.00997796f //x=9 \
 //y=2.38 //x2=9.135 //y2=1.405
cc_498 ( N_A_c_579_n N_noxref_4_c_792_n ) capacitor c=0.00107668f //x=9.035 \
 //y=1.435 //x2=9.135 //y2=1.405
cc_499 ( N_A_c_581_n N_noxref_4_c_792_n ) capacitor c=8.64037e-19 //x=9.035 \
 //y=1.74 //x2=9.135 //y2=1.405
cc_500 ( A N_noxref_4_c_872_n ) capacitor c=0.00114496f //x=9 //y=4.62 \
 //x2=9.9 //y2=4.255
cc_501 ( N_A_c_551_n N_noxref_4_c_872_n ) capacitor c=0.0028493f //x=9 \
 //y=4.37 //x2=9.9 //y2=4.255
cc_502 ( N_A_c_556_n N_noxref_4_c_872_n ) capacitor c=0.018987f //x=9.015 \
 //y=4.21 //x2=9.9 //y2=4.255
cc_503 ( N_A_M17_noxref_g N_noxref_4_c_875_n ) capacitor c=0.0141401f //x=9.04 \
 //y=6.205 //x2=9.26 //y2=5.56
cc_504 ( N_A_M18_noxref_g N_noxref_4_c_875_n ) capacitor c=0.0139971f //x=9.48 \
 //y=6.205 //x2=9.26 //y2=5.56
cc_505 ( N_A_c_630_p N_noxref_4_c_875_n ) capacitor c=0.00293135f //x=9.405 \
 //y=4.975 //x2=9.26 //y2=5.56
cc_506 ( N_A_c_518_n N_noxref_4_M1_noxref_d ) capacitor c=0.00218556f \
 //x=2.375 //y=1.085 //x2=2.45 //y2=1.085
cc_507 ( N_A_c_521_n N_noxref_4_M1_noxref_d ) capacitor c=0.00327871f \
 //x=2.375 //y=1.43 //x2=2.45 //y2=1.085
cc_508 ( N_A_c_523_n N_noxref_4_M1_noxref_d ) capacitor c=0.00254845f \
 //x=2.375 //y=1.74 //x2=2.45 //y2=1.085
cc_509 ( N_A_c_637_p N_noxref_4_M1_noxref_d ) capacitor c=0.00235569f //x=2.75 \
 //y=0.93 //x2=2.45 //y2=1.085
cc_510 ( N_A_c_638_p N_noxref_4_M1_noxref_d ) capacitor c=0.00523156f //x=2.75 \
 //y=1.585 //x2=2.45 //y2=1.085
cc_511 ( N_A_c_526_n N_noxref_4_M1_noxref_d ) capacitor c=0.00131413f \
 //x=2.905 //y=1.085 //x2=2.45 //y2=1.085
cc_512 ( N_A_c_527_n N_noxref_4_M1_noxref_d ) capacitor c=0.0065758f //x=2.905 \
 //y=1.43 //x2=2.45 //y2=1.085
cc_513 ( N_A_c_576_n N_noxref_4_M5_noxref_d ) capacitor c=0.00226395f \
 //x=9.035 //y=1.085 //x2=9.11 //y2=1.085
cc_514 ( N_A_c_579_n N_noxref_4_M5_noxref_d ) capacitor c=0.004517f //x=9.035 \
 //y=1.435 //x2=9.11 //y2=1.085
cc_515 ( N_A_c_581_n N_noxref_4_M5_noxref_d ) capacitor c=0.00275912f \
 //x=9.035 //y=1.74 //x2=9.11 //y2=1.085
cc_516 ( N_A_c_606_p N_noxref_4_M5_noxref_d ) capacitor c=0.00234223f //x=9.41 \
 //y=0.93 //x2=9.11 //y2=1.085
cc_517 ( N_A_c_584_n N_noxref_4_M5_noxref_d ) capacitor c=0.00707878f //x=9.41 \
 //y=1.585 //x2=9.11 //y2=1.085
cc_518 ( N_A_c_585_n N_noxref_4_M5_noxref_d ) capacitor c=0.00132831f \
 //x=9.565 //y=1.085 //x2=9.11 //y2=1.085
cc_519 ( N_A_c_586_n N_noxref_4_M5_noxref_d ) capacitor c=0.00330743f \
 //x=9.565 //y=1.435 //x2=9.11 //y2=1.085
cc_520 ( N_A_M9_noxref_g N_VDD_c_1109_n ) capacitor c=0.00125343f //x=2.38 \
 //y=6.205 //x2=2.16 //y2=7.035
cc_521 ( N_A_M9_noxref_g N_VDD_c_1110_n ) capacitor c=0.00137209f //x=2.38 \
 //y=6.205 //x2=2.16 //y2=7.41
cc_522 ( N_A_M10_noxref_g N_VDD_c_1152_n ) capacitor c=0.00373588f //x=2.82 \
 //y=6.205 //x2=3.04 //y2=7.035
cc_523 ( N_A_M10_noxref_g N_VDD_c_1153_n ) capacitor c=0.00300944f //x=2.82 \
 //y=6.205 //x2=3.04 //y2=7.41
cc_524 ( N_A_M9_noxref_g N_VDD_c_1112_n ) capacitor c=0.007206f //x=2.38 \
 //y=6.205 //x2=3.65 //y2=7.585
cc_525 ( N_A_M10_noxref_g N_VDD_c_1112_n ) capacitor c=0.00778439f //x=2.82 \
 //y=6.205 //x2=3.65 //y2=7.585
cc_526 ( A N_VDD_c_1115_n ) capacitor c=9.52781e-19 //x=2.34 //y=4.25 \
 //x2=1.23 //y2=7.58
cc_527 ( N_A_c_489_n N_VDD_c_1115_n ) capacitor c=2.16363e-19 //x=2.34 \
 //y=4.71 //x2=1.23 //y2=7.58
cc_528 ( N_A_M17_noxref_g N_VDD_c_1138_n ) capacitor c=0.00728344f //x=9.04 \
 //y=6.205 //x2=10.31 //y2=7.585
cc_529 ( N_A_M18_noxref_g N_VDD_c_1138_n ) capacitor c=0.00782837f //x=9.48 \
 //y=6.205 //x2=10.31 //y2=7.585
cc_530 ( A N_VDD_c_1123_n ) capacitor c=0.00144593f //x=2.34 //y=4.25 \
 //x2=3.82 //y2=7.585
cc_531 ( N_A_c_486_n N_VDD_c_1123_n ) capacitor c=5.31543e-19 //x=2.34 \
 //y=4.365 //x2=3.82 //y2=7.585
cc_532 ( N_A_c_489_n N_VDD_c_1123_n ) capacitor c=0.00746843f //x=2.34 \
 //y=4.71 //x2=3.82 //y2=7.585
cc_533 ( N_A_c_502_n N_VDD_c_1123_n ) capacitor c=0.00801328f //x=8.855 \
 //y=4.21 //x2=3.82 //y2=7.585
cc_534 ( N_A_c_511_n N_VDD_c_1123_n ) capacitor c=0.00250302f //x=2.38 \
 //y=4.885 //x2=3.82 //y2=7.585
cc_535 ( N_A_c_689_p N_VDD_c_1123_n ) capacitor c=0.0117152f //x=2.745 \
 //y=4.975 //x2=3.82 //y2=7.585
cc_536 ( N_A_c_531_n N_VDD_c_1123_n ) capacitor c=2.76772e-19 //x=2.38 \
 //y=4.885 //x2=3.82 //y2=7.585
cc_537 ( A N_VDD_c_1129_n ) capacitor c=8.21577e-19 //x=9 //y=4.25 //x2=7.15 \
 //y2=7.585
cc_538 ( N_A_c_552_n N_VDD_c_1129_n ) capacitor c=5.18027e-19 //x=9 //y=4.74 \
 //x2=7.15 //y2=7.585
cc_539 ( N_A_c_502_n N_VDD_c_1129_n ) capacitor c=0.0135112f //x=8.855 \
 //y=4.21 //x2=7.15 //y2=7.585
cc_540 ( N_A_c_569_n N_VDD_c_1129_n ) capacitor c=6.64651e-19 //x=9.02 \
 //y=4.885 //x2=7.15 //y2=7.585
cc_541 ( N_A_c_569_n N_VDD_c_1171_n ) capacitor c=0.00237807f //x=9.02 \
 //y=4.885 //x2=10.48 //y2=7.585
cc_542 ( N_A_c_630_p N_VDD_c_1171_n ) capacitor c=0.0170421f //x=9.405 \
 //y=4.975 //x2=10.48 //y2=7.585
cc_543 ( N_A_c_590_n N_VDD_c_1171_n ) capacitor c=2.70151e-19 //x=9.02 \
 //y=4.885 //x2=10.48 //y2=7.585
cc_544 ( N_A_M9_noxref_g N_VDD_M8_noxref_d ) capacitor c=0.0127979f //x=2.38 \
 //y=6.205 //x2=2.015 //y2=5.205
cc_545 ( N_A_M10_noxref_g N_VDD_M10_noxref_d ) capacitor c=0.0463918f //x=2.82 \
 //y=6.205 //x2=2.895 //y2=5.205
cc_546 ( A N_noxref_6_c_1360_n ) capacitor c=3.71828e-19 //x=2.34 //y=4.25 \
 //x2=2.485 //y2=5.39
cc_547 ( N_A_c_486_n N_noxref_6_c_1360_n ) capacitor c=0.00150537f //x=2.34 \
 //y=4.365 //x2=2.485 //y2=5.39
cc_548 ( N_A_c_489_n N_noxref_6_c_1360_n ) capacitor c=0.0211744f //x=2.34 \
 //y=4.71 //x2=2.485 //y2=5.39
cc_549 ( N_A_c_511_n N_noxref_6_c_1360_n ) capacitor c=0.004587f //x=2.38 \
 //y=4.885 //x2=2.485 //y2=5.39
cc_550 ( N_A_M9_noxref_g N_noxref_6_c_1360_n ) capacitor c=0.00913391f \
 //x=2.38 //y=6.205 //x2=2.485 //y2=5.39
cc_551 ( N_A_c_531_n N_noxref_6_c_1360_n ) capacitor c=6.87087e-19 //x=2.38 \
 //y=4.885 //x2=2.485 //y2=5.39
cc_552 ( N_A_M10_noxref_g N_noxref_6_c_1362_n ) capacitor c=0.011434f //x=2.82 \
 //y=6.205 //x2=4.485 //y2=5.39
cc_553 ( N_A_c_486_n N_noxref_6_c_1365_n ) capacitor c=0.00145195f //x=2.34 \
 //y=4.365 //x2=2.715 //y2=5.39
cc_554 ( N_A_c_489_n N_noxref_6_c_1365_n ) capacitor c=0.00252287f //x=2.34 \
 //y=4.71 //x2=2.715 //y2=5.39
cc_555 ( N_A_M9_noxref_g N_noxref_6_c_1365_n ) capacitor c=7.72756e-19 \
 //x=2.38 //y=6.205 //x2=2.715 //y2=5.39
cc_556 ( N_A_M10_noxref_g N_noxref_6_c_1365_n ) capacitor c=8.30848e-19 \
 //x=2.82 //y=6.205 //x2=2.715 //y2=5.39
cc_557 ( N_A_c_486_n N_noxref_6_c_1381_n ) capacitor c=0.00167023f //x=2.34 \
 //y=4.365 //x2=2.6 //y2=5.39
cc_558 ( N_A_M9_noxref_g N_noxref_6_c_1381_n ) capacitor c=0.021802f //x=2.38 \
 //y=6.205 //x2=2.6 //y2=5.39
cc_559 ( N_A_M10_noxref_g N_noxref_6_c_1381_n ) capacitor c=0.0189969f \
 //x=2.82 //y=6.205 //x2=2.6 //y2=5.39
cc_560 ( N_A_c_689_p N_noxref_6_c_1381_n ) capacitor c=0.00449628f //x=2.745 \
 //y=4.975 //x2=2.6 //y2=5.39
cc_561 ( N_A_M9_noxref_g N_noxref_6_M9_noxref_d ) capacitor c=0.00122946f \
 //x=2.38 //y=6.205 //x2=2.455 //y2=5.205
cc_562 ( N_A_M10_noxref_g N_noxref_6_M9_noxref_d ) capacitor c=0.00123972f \
 //x=2.82 //y=6.205 //x2=2.455 //y2=5.205
cc_563 ( N_A_c_502_n N_noxref_7_c_1539_n ) capacitor c=0.0620335f //x=8.855 \
 //y=4.21 //x2=7.825 //y2=5.39
cc_564 ( N_A_c_502_n N_noxref_7_c_1549_n ) capacitor c=0.00869836f //x=8.855 \
 //y=4.21 //x2=6.035 //y2=5.39
cc_565 ( N_A_M17_noxref_g N_noxref_7_c_1565_n ) capacitor c=0.00793695f \
 //x=9.04 //y=6.205 //x2=9.57 //y2=7.09
cc_566 ( N_A_M18_noxref_g N_noxref_7_c_1565_n ) capacitor c=0.00937408f \
 //x=9.48 //y=6.205 //x2=9.57 //y2=7.09
cc_567 ( N_A_c_502_n N_noxref_7_c_1527_n ) capacitor c=0.0270459f //x=8.855 \
 //y=4.21 //x2=5.04 //y2=5.39
cc_568 ( N_A_c_502_n N_noxref_7_c_1553_n ) capacitor c=0.00166893f //x=8.855 \
 //y=4.21 //x2=5.92 //y2=5.39
cc_569 ( N_A_M17_noxref_g N_noxref_7_c_1557_n ) capacitor c=0.00177216f \
 //x=9.04 //y=6.205 //x2=8.82 //y2=7.09
cc_570 ( N_A_M18_noxref_g N_noxref_7_c_1570_n ) capacitor c=0.00422002f \
 //x=9.48 //y=6.205 //x2=9.7 //y2=6.92
cc_571 ( N_A_c_502_n N_noxref_7_c_1558_n ) capacitor c=2.11035e-19 //x=8.855 \
 //y=4.21 //x2=7.94 //y2=5.39
cc_572 ( N_A_M17_noxref_g N_noxref_7_M16_noxref_d ) capacitor c=0.0142133f \
 //x=9.04 //y=6.205 //x2=8.675 //y2=5.205
cc_573 ( N_A_c_590_n N_noxref_7_M16_noxref_d ) capacitor c=6.61209e-19 \
 //x=9.02 //y=4.885 //x2=8.675 //y2=5.205
cc_574 ( N_A_M18_noxref_g N_noxref_7_M18_noxref_d ) capacitor c=0.0365939f \
 //x=9.48 //y=6.205 //x2=9.555 //y2=5.205
cc_575 ( N_A_c_482_n N_GND_c_1737_n ) capacitor c=0.00214826f //x=2.34 \
 //y=2.375 //x2=4.915 //y2=0.175
cc_576 ( N_A_c_547_n N_GND_c_1738_n ) capacitor c=4.6307e-19 //x=9 //y=2.38 \
 //x2=11.96 //y2=0.18
cc_577 ( N_A_c_482_n N_GND_c_1681_n ) capacitor c=3.76947e-19 //x=2.34 \
 //y=2.375 //x2=3.65 //y2=0.175
cc_578 ( N_A_c_547_n N_GND_c_1717_n ) capacitor c=3.29013e-19 //x=9 //y=2.38 \
 //x2=10.31 //y2=0.175
cc_579 ( A N_GND_c_1689_n ) capacitor c=0.00617359f //x=2.34 //y=2.77 \
 //x2=3.82 //y2=0.175
cc_580 ( N_A_c_482_n N_GND_c_1689_n ) capacitor c=0.00295886f //x=2.34 \
 //y=2.375 //x2=3.82 //y2=0.175
cc_581 ( N_A_c_502_n N_GND_c_1689_n ) capacitor c=0.00357341f //x=8.855 \
 //y=4.21 //x2=3.82 //y2=0.175
cc_582 ( N_A_c_507_n N_GND_c_1689_n ) capacitor c=0.00245228f //x=2.34 \
 //y=2.26 //x2=3.82 //y2=0.175
cc_583 ( N_A_c_528_n N_GND_c_1689_n ) capacitor c=2.63786e-19 //x=2.34 \
 //y=2.26 //x2=3.82 //y2=0.175
cc_584 ( N_A_c_502_n N_GND_c_1720_n ) capacitor c=0.0025451f //x=8.855 \
 //y=4.21 //x2=7.15 //y2=0.175
cc_585 ( N_A_c_566_n N_GND_c_1730_n ) capacitor c=0.00224736f //x=9 //y=2.26 \
 //x2=10.48 //y2=0.175
cc_586 ( N_A_c_584_n N_GND_c_1730_n ) capacitor c=0.00264662f //x=9.41 \
 //y=1.585 //x2=10.48 //y2=0.175
cc_587 ( N_A_c_587_n N_GND_c_1730_n ) capacitor c=2.63786e-19 //x=9 //y=2.26 \
 //x2=10.48 //y2=0.175
cc_588 ( N_A_c_482_n N_noxref_10_c_2015_n ) capacitor c=7.20375e-19 //x=2.34 \
 //y=2.375 //x2=2.155 //y2=1.675
cc_589 ( N_A_c_486_n N_noxref_10_c_2015_n ) capacitor c=3.32532e-19 //x=2.34 \
 //y=4.365 //x2=2.155 //y2=1.675
cc_590 ( N_A_c_523_n N_noxref_10_c_2015_n ) capacitor c=0.00746306f //x=2.375 \
 //y=1.74 //x2=2.155 //y2=1.675
cc_591 ( N_A_c_528_n N_noxref_10_c_2015_n ) capacitor c=0.00175173f //x=2.34 \
 //y=2.26 //x2=2.155 //y2=1.675
cc_592 ( N_A_c_482_n N_noxref_10_c_2023_n ) capacitor c=0.00135256f //x=2.34 \
 //y=2.375 //x2=3.04 //y2=0.71
cc_593 ( N_A_c_507_n N_noxref_10_c_2023_n ) capacitor c=8.82141e-19 //x=2.34 \
 //y=2.26 //x2=3.04 //y2=0.71
cc_594 ( N_A_c_518_n N_noxref_10_c_2023_n ) capacitor c=0.0200392f //x=2.375 \
 //y=1.085 //x2=3.04 //y2=0.71
cc_595 ( N_A_c_526_n N_noxref_10_c_2023_n ) capacitor c=0.00825432f //x=2.905 \
 //y=1.085 //x2=3.04 //y2=0.71
cc_596 ( N_A_c_528_n N_noxref_10_c_2023_n ) capacitor c=2.1838e-19 //x=2.34 \
 //y=2.26 //x2=3.04 //y2=0.71
cc_597 ( N_A_c_502_n N_noxref_10_M0_noxref_s ) capacitor c=0.00170283f \
 //x=8.855 //y=4.21 //x2=1.05 //y2=0.545
cc_598 ( N_A_c_518_n N_noxref_10_M0_noxref_s ) capacitor c=0.00746306f \
 //x=2.375 //y=1.085 //x2=1.05 //y2=0.545
cc_599 ( N_A_c_523_n N_noxref_10_M0_noxref_s ) capacitor c=0.00211573f \
 //x=2.375 //y=1.74 //x2=1.05 //y2=0.545
cc_600 ( N_A_c_526_n N_noxref_10_M0_noxref_s ) capacitor c=0.014227f //x=2.905 \
 //y=1.085 //x2=1.05 //y2=0.545
cc_601 ( N_A_c_527_n N_noxref_10_M0_noxref_s ) capacitor c=0.00733269f \
 //x=2.905 //y=1.43 //x2=1.05 //y2=0.545
cc_602 ( N_A_c_756_p N_noxref_10_M0_noxref_s ) capacitor c=0.00392195f \
 //x=2.34 //y=2.095 //x2=1.05 //y2=0.545
cc_603 ( N_A_c_502_n N_noxref_12_c_2079_n ) capacitor c=0.00155386f //x=8.855 \
 //y=4.21 //x2=4.515 //y2=1.675
cc_604 ( N_A_c_502_n N_noxref_12_c_2080_n ) capacitor c=0.00692346f //x=8.855 \
 //y=4.21 //x2=5.4 //y2=1.76
cc_605 ( N_A_c_502_n N_noxref_12_c_2087_n ) capacitor c=0.00170283f //x=8.855 \
 //y=4.21 //x2=5.485 //y2=1.675
cc_606 ( N_A_c_502_n N_noxref_13_c_2149_n ) capacitor c=0.00782785f //x=8.855 \
 //y=4.21 //x2=8.73 //y2=1.76
cc_607 ( N_A_c_547_n N_noxref_13_c_2156_n ) capacitor c=7.26555e-19 //x=9 \
 //y=2.38 //x2=8.815 //y2=1.675
cc_608 ( N_A_c_551_n N_noxref_13_c_2156_n ) capacitor c=9.42734e-19 //x=9 \
 //y=4.37 //x2=8.815 //y2=1.675
cc_609 ( N_A_c_581_n N_noxref_13_c_2156_n ) capacitor c=0.00830822f //x=9.035 \
 //y=1.74 //x2=8.815 //y2=1.675
cc_610 ( N_A_c_587_n N_noxref_13_c_2156_n ) capacitor c=0.00175172f //x=9 \
 //y=2.26 //x2=8.815 //y2=1.675
cc_611 ( N_A_c_547_n N_noxref_13_c_2165_n ) capacitor c=5.72205e-19 //x=9 \
 //y=2.38 //x2=9.7 //y2=0.71
cc_612 ( N_A_c_566_n N_noxref_13_c_2165_n ) capacitor c=8.37879e-19 //x=9 \
 //y=2.26 //x2=9.7 //y2=0.71
cc_613 ( N_A_c_576_n N_noxref_13_c_2165_n ) capacitor c=0.0202024f //x=9.035 \
 //y=1.085 //x2=9.7 //y2=0.71
cc_614 ( N_A_c_585_n N_noxref_13_c_2165_n ) capacitor c=0.00825432f //x=9.565 \
 //y=1.085 //x2=9.7 //y2=0.71
cc_615 ( N_A_c_587_n N_noxref_13_c_2165_n ) capacitor c=2.1838e-19 //x=9 \
 //y=2.26 //x2=9.7 //y2=0.71
cc_616 ( N_A_c_576_n N_noxref_13_M4_noxref_s ) capacitor c=0.00830822f \
 //x=9.035 //y=1.085 //x2=7.71 //y2=0.545
cc_617 ( N_A_c_584_n N_noxref_13_M4_noxref_s ) capacitor c=0.00271091f \
 //x=9.41 //y=1.585 //x2=7.71 //y2=0.545
cc_618 ( N_A_c_585_n N_noxref_13_M4_noxref_s ) capacitor c=0.0142835f \
 //x=9.565 //y=1.085 //x2=7.71 //y2=0.545
cc_619 ( N_noxref_4_c_831_n N_VDD_c_1176_n ) capacitor c=2.26208e-19 //x=9.655 \
 //y=5.39 //x2=11.96 //y2=7.58
cc_620 ( N_noxref_4_c_841_n N_VDD_c_1176_n ) capacitor c=4.99801e-19 //x=9.74 \
 //y=4.415 //x2=11.96 //y2=7.58
cc_621 ( N_noxref_4_c_894_p N_VDD_c_1176_n ) capacitor c=3.0454e-19 //x=11.22 \
 //y=4.415 //x2=11.96 //y2=7.58
cc_622 ( N_noxref_4_c_851_n N_VDD_c_1176_n ) capacitor c=5.73169e-19 //x=11.22 \
 //y=4.76 //x2=11.96 //y2=7.58
cc_623 ( N_noxref_4_c_896_p N_VDD_c_1176_n ) capacitor c=3.40755e-19 //x=11.22 \
 //y=4.88 //x2=11.96 //y2=7.58
cc_624 ( N_noxref_4_c_831_n N_VDD_c_1138_n ) capacitor c=0.00135523f //x=9.655 \
 //y=5.39 //x2=10.31 //y2=7.585
cc_625 ( N_noxref_4_c_841_n N_VDD_c_1138_n ) capacitor c=4.02953e-19 //x=9.74 \
 //y=4.415 //x2=10.31 //y2=7.585
cc_626 ( N_noxref_4_c_802_n N_VDD_c_1138_n ) capacitor c=0.00488797f //x=8.38 \
 //y=5.56 //x2=10.31 //y2=7.585
cc_627 ( N_noxref_4_c_875_n N_VDD_c_1138_n ) capacitor c=0.00513429f //x=9.26 \
 //y=5.56 //x2=10.31 //y2=7.585
cc_628 ( N_noxref_4_c_851_n N_VDD_c_1185_n ) capacitor c=5.48929e-19 //x=11.22 \
 //y=4.76 //x2=11.95 //y2=7.585
cc_629 ( N_noxref_4_M19_noxref_g N_VDD_c_1185_n ) capacitor c=0.00753931f \
 //x=11.375 //y=6.2 //x2=11.95 //y2=7.585
cc_630 ( N_noxref_4_M20_noxref_g N_VDD_c_1185_n ) capacitor c=0.00755544f \
 //x=11.815 //y=6.2 //x2=11.95 //y2=7.585
cc_631 ( N_noxref_4_c_780_n N_VDD_c_1129_n ) capacitor c=0.00128037f //x=9.74 \
 //y=5.305 //x2=7.15 //y2=7.585
cc_632 ( N_noxref_4_c_802_n N_VDD_c_1129_n ) capacitor c=0.00535462f //x=8.38 \
 //y=5.56 //x2=7.15 //y2=7.585
cc_633 ( N_noxref_4_c_841_n N_VDD_c_1171_n ) capacitor c=0.0019054f //x=9.74 \
 //y=4.415 //x2=10.48 //y2=7.585
cc_634 ( N_noxref_4_c_780_n N_VDD_c_1171_n ) capacitor c=0.0249794f //x=9.74 \
 //y=5.305 //x2=10.48 //y2=7.585
cc_635 ( N_noxref_4_c_894_p N_VDD_c_1171_n ) capacitor c=0.0019054f //x=11.22 \
 //y=4.415 //x2=10.48 //y2=7.585
cc_636 ( N_noxref_4_c_851_n N_VDD_c_1171_n ) capacitor c=0.0128286f //x=11.22 \
 //y=4.76 //x2=10.48 //y2=7.585
cc_637 ( N_noxref_4_c_860_n N_VDD_c_1171_n ) capacitor c=0.00265362f //x=9.257 \
 //y=5.39 //x2=10.48 //y2=7.585
cc_638 ( N_noxref_4_c_864_n N_VDD_c_1171_n ) capacitor c=0.00486566f //x=9.74 \
 //y=4.25 //x2=10.48 //y2=7.585
cc_639 ( N_noxref_4_c_912_p N_VDD_c_1171_n ) capacitor c=0.00486566f //x=11.22 \
 //y=4.25 //x2=10.48 //y2=7.585
cc_640 ( N_noxref_4_c_913_p N_VDD_c_1171_n ) capacitor c=0.0183218f //x=11.06 \
 //y=4.255 //x2=10.48 //y2=7.585
cc_641 ( N_noxref_4_c_875_n N_VDD_c_1171_n ) capacitor c=0.00899475f //x=9.26 \
 //y=5.56 //x2=10.48 //y2=7.585
cc_642 ( N_noxref_4_c_896_p N_VDD_c_1171_n ) capacitor c=0.0079528f //x=11.22 \
 //y=4.88 //x2=10.48 //y2=7.585
cc_643 ( N_noxref_4_M19_noxref_g N_VDD_c_1171_n ) capacitor c=0.00873815f \
 //x=11.375 //y=6.2 //x2=10.48 //y2=7.585
cc_644 ( N_noxref_4_c_917_p N_VDD_c_1171_n ) capacitor c=0.00799922f //x=11.45 \
 //y=4.97 //x2=10.48 //y2=7.585
cc_645 ( N_noxref_4_c_912_p N_VDD_c_1202_n ) capacitor c=0.00143727f //x=11.22 \
 //y=4.25 //x2=11.96 //y2=7.58
cc_646 ( N_noxref_4_c_802_n N_VDD_c_1202_n ) capacitor c=2.32853e-19 //x=8.38 \
 //y=5.56 //x2=11.96 //y2=7.58
cc_647 ( N_noxref_4_c_875_n N_VDD_c_1202_n ) capacitor c=2.32853e-19 //x=9.26 \
 //y=5.56 //x2=11.96 //y2=7.58
cc_648 ( N_noxref_4_c_896_p N_VDD_c_1202_n ) capacitor c=0.00235165f //x=11.22 \
 //y=4.88 //x2=11.96 //y2=7.58
cc_649 ( N_noxref_4_c_922_p N_VDD_c_1202_n ) capacitor c=0.0195827f //x=11.74 \
 //y=4.97 //x2=11.96 //y2=7.58
cc_650 ( N_noxref_4_c_917_p N_VDD_c_1202_n ) capacitor c=2.63786e-19 //x=11.45 \
 //y=4.97 //x2=11.96 //y2=7.58
cc_651 ( N_noxref_4_c_831_n N_VDD_M19_noxref_s ) capacitor c=0.00343522f \
 //x=9.655 //y=5.39 //x2=11.02 //y2=5.2
cc_652 ( N_noxref_4_c_894_p N_VDD_M19_noxref_s ) capacitor c=0.00247632f \
 //x=11.22 //y=4.415 //x2=11.02 //y2=5.2
cc_653 ( N_noxref_4_c_851_n N_VDD_M19_noxref_s ) capacitor c=0.0208734f \
 //x=11.22 //y=4.76 //x2=11.02 //y2=5.2
cc_654 ( N_noxref_4_c_860_n N_VDD_M19_noxref_s ) capacitor c=0.00575207f \
 //x=9.257 //y=5.39 //x2=11.02 //y2=5.2
cc_655 ( N_noxref_4_c_928_p N_VDD_M19_noxref_s ) capacitor c=6.60267e-19 \
 //x=11.22 //y=4.255 //x2=11.02 //y2=5.2
cc_656 ( N_noxref_4_c_913_p N_VDD_M19_noxref_s ) capacitor c=3.46335e-19 \
 //x=11.06 //y=4.255 //x2=11.02 //y2=5.2
cc_657 ( N_noxref_4_c_896_p N_VDD_M19_noxref_s ) capacitor c=0.00986169f \
 //x=11.22 //y=4.88 //x2=11.02 //y2=5.2
cc_658 ( N_noxref_4_M19_noxref_g N_VDD_M19_noxref_s ) capacitor c=0.0573441f \
 //x=11.375 //y=6.2 //x2=11.02 //y2=5.2
cc_659 ( N_noxref_4_c_917_p N_VDD_M19_noxref_s ) capacitor c=0.0053173f \
 //x=11.45 //y=4.97 //x2=11.02 //y2=5.2
cc_660 ( N_noxref_4_M20_noxref_g N_VDD_M20_noxref_d ) capacitor c=0.0572684f \
 //x=11.815 //y=6.2 //x2=11.89 //y2=5.2
cc_661 ( N_noxref_4_c_852_n N_noxref_6_c_1362_n ) capacitor c=2.92364e-19 \
 //x=2.64 //y=1.36 //x2=4.485 //y2=5.39
cc_662 ( N_noxref_4_c_852_n N_noxref_6_c_1365_n ) capacitor c=3.81263e-19 \
 //x=2.64 //y=1.36 //x2=2.715 //y2=5.39
cc_663 ( N_noxref_4_c_780_n N_noxref_7_c_1539_n ) capacitor c=5.76261e-19 \
 //x=9.74 //y=5.305 //x2=7.825 //y2=5.39
cc_664 ( N_noxref_4_c_788_n N_noxref_7_c_1539_n ) capacitor c=0.0327245f \
 //x=8.38 //y=5.39 //x2=7.825 //y2=5.39
cc_665 ( N_noxref_4_c_802_n N_noxref_7_c_1539_n ) capacitor c=0.00238429f \
 //x=8.38 //y=5.56 //x2=7.825 //y2=5.39
cc_666 ( N_noxref_4_c_781_n N_noxref_7_c_1549_n ) capacitor c=7.85501e-19 \
 //x=5.97 //y=1.36 //x2=6.035 //y2=5.39
cc_667 ( N_noxref_4_c_777_n N_noxref_7_c_1551_n ) capacitor c=0.00311493f \
 //x=9.135 //y=5.39 //x2=8.705 //y2=7.09
cc_668 ( N_noxref_4_c_788_n N_noxref_7_c_1551_n ) capacitor c=0.00538798f \
 //x=8.38 //y=5.39 //x2=8.705 //y2=7.09
cc_669 ( N_noxref_4_c_802_n N_noxref_7_c_1551_n ) capacitor c=0.00406191f \
 //x=8.38 //y=5.56 //x2=8.705 //y2=7.09
cc_670 ( N_noxref_4_c_777_n N_noxref_7_c_1565_n ) capacitor c=0.00305195f \
 //x=9.135 //y=5.39 //x2=9.57 //y2=7.09
cc_671 ( N_noxref_4_c_831_n N_noxref_7_c_1565_n ) capacitor c=0.00291085f \
 //x=9.655 //y=5.39 //x2=9.57 //y2=7.09
cc_672 ( N_noxref_4_c_860_n N_noxref_7_c_1565_n ) capacitor c=0.00559082f \
 //x=9.257 //y=5.39 //x2=9.57 //y2=7.09
cc_673 ( N_noxref_4_c_875_n N_noxref_7_c_1565_n ) capacitor c=0.00396177f \
 //x=9.26 //y=5.56 //x2=9.57 //y2=7.09
cc_674 ( N_noxref_4_c_788_n N_noxref_7_c_1527_n ) capacitor c=0.00240034f \
 //x=8.38 //y=5.39 //x2=5.04 //y2=5.39
cc_675 ( N_noxref_4_c_777_n N_noxref_7_c_1557_n ) capacitor c=0.00459659f \
 //x=9.135 //y=5.39 //x2=8.82 //y2=7.09
cc_676 ( N_noxref_4_c_831_n N_noxref_7_c_1570_n ) capacitor c=0.00536247f \
 //x=9.655 //y=5.39 //x2=9.7 //y2=6.92
cc_677 ( N_noxref_4_c_780_n N_noxref_7_c_1558_n ) capacitor c=5.23099e-19 \
 //x=9.74 //y=5.305 //x2=7.94 //y2=5.39
cc_678 ( N_noxref_4_c_788_n N_noxref_7_c_1558_n ) capacitor c=0.010446f \
 //x=8.38 //y=5.39 //x2=7.94 //y2=5.39
cc_679 ( N_noxref_4_c_802_n N_noxref_7_c_1558_n ) capacitor c=0.0649815f \
 //x=8.38 //y=5.56 //x2=7.94 //y2=5.39
cc_680 ( N_noxref_4_c_777_n N_noxref_7_M16_noxref_d ) capacitor c=0.00678641f \
 //x=9.135 //y=5.39 //x2=8.675 //y2=5.205
cc_681 ( N_noxref_4_c_860_n N_noxref_7_M16_noxref_d ) capacitor c=0.00184359f \
 //x=9.257 //y=5.39 //x2=8.675 //y2=5.205
cc_682 ( N_noxref_4_c_802_n N_noxref_7_M16_noxref_d ) capacitor c=0.0476949f \
 //x=8.38 //y=5.56 //x2=8.675 //y2=5.205
cc_683 ( N_noxref_4_c_875_n N_noxref_7_M16_noxref_d ) capacitor c=0.0473507f \
 //x=9.26 //y=5.56 //x2=8.675 //y2=5.205
cc_684 ( N_noxref_4_c_831_n N_noxref_7_M18_noxref_d ) capacitor c=0.00735506f \
 //x=9.655 //y=5.39 //x2=9.555 //y2=5.205
cc_685 ( N_noxref_4_c_860_n N_noxref_7_M18_noxref_d ) capacitor c=0.0012641f \
 //x=9.257 //y=5.39 //x2=9.555 //y2=5.205
cc_686 ( N_noxref_4_c_864_n N_noxref_7_M18_noxref_d ) capacitor c=0.00165396f \
 //x=9.74 //y=4.25 //x2=9.555 //y2=5.205
cc_687 ( N_noxref_4_c_875_n N_noxref_7_M18_noxref_d ) capacitor c=0.0473507f \
 //x=9.26 //y=5.56 //x2=9.555 //y2=5.205
cc_688 ( N_noxref_4_c_852_n N_GND_c_1665_n ) capacitor c=0.00185513f //x=2.64 \
 //y=1.36 //x2=1.67 //y2=1.015
cc_689 ( N_noxref_4_c_962_p N_GND_c_1665_n ) capacitor c=7.42708e-19 //x=2.805 \
 //y=1.405 //x2=1.67 //y2=1.015
cc_690 ( N_noxref_4_M1_noxref_d N_GND_c_1665_n ) capacitor c=2.62581e-19 \
 //x=2.45 //y=1.085 //x2=1.67 //y2=1.015
cc_691 ( N_noxref_4_c_852_n N_GND_c_1737_n ) capacitor c=0.00560741f //x=2.64 \
 //y=1.36 //x2=4.915 //y2=0.175
cc_692 ( N_noxref_4_c_962_p N_GND_c_1737_n ) capacitor c=0.00701775f //x=2.805 \
 //y=1.405 //x2=4.915 //y2=0.175
cc_693 ( N_noxref_4_c_773_n N_GND_c_1737_n ) capacitor c=0.113183f //x=5.84 \
 //y=1.405 //x2=4.915 //y2=0.175
cc_694 ( N_noxref_4_M1_noxref_d N_GND_c_1737_n ) capacitor c=2.01013e-19 \
 //x=2.45 //y=1.085 //x2=4.915 //y2=0.175
cc_695 ( N_noxref_4_c_852_n N_GND_c_1672_n ) capacitor c=3.05541e-19 //x=2.64 \
 //y=1.36 //x2=5 //y2=1.015
cc_696 ( N_noxref_4_c_781_n N_GND_c_1672_n ) capacitor c=0.00263562f //x=5.97 \
 //y=1.36 //x2=5 //y2=1.015
cc_697 ( N_noxref_4_c_962_p N_GND_c_1672_n ) capacitor c=4.33523e-19 //x=2.805 \
 //y=1.405 //x2=5 //y2=1.015
cc_698 ( N_noxref_4_c_773_n N_GND_c_1672_n ) capacitor c=0.0203963f //x=5.84 \
 //y=1.405 //x2=5 //y2=1.015
cc_699 ( N_noxref_4_M3_noxref_d N_GND_c_1672_n ) capacitor c=2.62581e-19 \
 //x=5.78 //y=1.085 //x2=5 //y2=1.015
cc_700 ( N_noxref_4_c_781_n N_GND_c_1706_n ) capacitor c=0.00848351f //x=5.97 \
 //y=1.36 //x2=8.245 //y2=0.175
cc_701 ( N_noxref_4_c_773_n N_GND_c_1706_n ) capacitor c=0.0330907f //x=5.84 \
 //y=1.405 //x2=8.245 //y2=0.175
cc_702 ( N_noxref_4_c_975_p N_GND_c_1706_n ) capacitor c=0.00561615f //x=6.1 \
 //y=1.405 //x2=8.245 //y2=0.175
cc_703 ( N_noxref_4_c_792_n N_GND_c_1706_n ) capacitor c=0.105627f //x=9.135 \
 //y=1.405 //x2=8.245 //y2=0.175
cc_704 ( N_noxref_4_M3_noxref_d N_GND_c_1706_n ) capacitor c=2.01013e-19 \
 //x=5.78 //y=1.085 //x2=8.245 //y2=0.175
cc_705 ( N_noxref_4_c_819_n N_GND_c_1709_n ) capacitor c=0.00195467f //x=9.3 \
 //y=1.535 //x2=8.33 //y2=1.02
cc_706 ( N_noxref_4_c_781_n N_GND_c_1709_n ) capacitor c=8.32974e-19 //x=5.97 \
 //y=1.36 //x2=8.33 //y2=1.02
cc_707 ( N_noxref_4_c_788_n N_GND_c_1709_n ) capacitor c=9.01285e-19 //x=8.38 \
 //y=5.39 //x2=8.33 //y2=1.02
cc_708 ( N_noxref_4_c_867_n N_GND_c_1709_n ) capacitor c=8.08914e-19 //x=9.295 \
 //y=1.405 //x2=8.33 //y2=1.02
cc_709 ( N_noxref_4_c_792_n N_GND_c_1709_n ) capacitor c=0.0204811f //x=9.135 \
 //y=1.405 //x2=8.33 //y2=1.02
cc_710 ( N_noxref_4_M5_noxref_d N_GND_c_1709_n ) capacitor c=2.62581e-19 \
 //x=9.11 //y=1.085 //x2=8.33 //y2=1.02
cc_711 ( N_noxref_4_c_819_n N_GND_c_1738_n ) capacitor c=0.00524308f //x=9.3 \
 //y=1.535 //x2=11.96 //y2=0.18
cc_712 ( N_noxref_4_c_832_n N_GND_c_1738_n ) capacitor c=0.0062416f //x=9.655 \
 //y=1.825 //x2=11.96 //y2=0.18
cc_713 ( N_noxref_4_c_841_n N_GND_c_1738_n ) capacitor c=3.81645e-19 //x=9.74 \
 //y=4.415 //x2=11.96 //y2=0.18
cc_714 ( N_noxref_4_c_894_p N_GND_c_1738_n ) capacitor c=3.80542e-19 //x=11.22 \
 //y=4.415 //x2=11.96 //y2=0.18
cc_715 ( N_noxref_4_c_988_p N_GND_c_1738_n ) capacitor c=0.00249122f //x=11.22 \
 //y=2.265 //x2=11.96 //y2=0.18
cc_716 ( N_noxref_4_c_867_n N_GND_c_1738_n ) capacitor c=0.00777895f //x=9.295 \
 //y=1.405 //x2=11.96 //y2=0.18
cc_717 ( N_noxref_4_c_792_n N_GND_c_1738_n ) capacitor c=0.038217f //x=9.135 \
 //y=1.405 //x2=11.96 //y2=0.18
cc_718 ( N_noxref_4_c_991_p N_GND_c_1738_n ) capacitor c=7.5371e-19 //x=11.22 \
 //y=2.265 //x2=11.96 //y2=0.18
cc_719 ( N_noxref_4_M5_noxref_d N_GND_c_1738_n ) capacitor c=2.01013e-19 \
 //x=9.11 //y=1.085 //x2=11.96 //y2=0.18
cc_720 ( N_noxref_4_c_832_n N_GND_c_1717_n ) capacitor c=7.45235e-19 //x=9.655 \
 //y=1.825 //x2=10.31 //y2=0.175
cc_721 ( N_noxref_4_c_988_p N_GND_c_1783_n ) capacitor c=0.00114179f //x=11.22 \
 //y=2.265 //x2=11.505 //y2=0.715
cc_722 ( N_noxref_4_c_991_p N_GND_c_1783_n ) capacitor c=3.95714e-19 //x=11.22 \
 //y=2.265 //x2=11.505 //y2=0.715
cc_723 ( N_noxref_4_c_996_p N_GND_c_1783_n ) capacitor c=0.0125549f //x=11.33 \
 //y=1.09 //x2=11.505 //y2=0.715
cc_724 ( N_noxref_4_c_997_p N_GND_c_1783_n ) capacitor c=2.1838e-19 //x=11.22 \
 //y=2.265 //x2=11.505 //y2=0.715
cc_725 ( N_noxref_4_c_998_p N_GND_c_1787_n ) capacitor c=0.0134289f //x=11.86 \
 //y=1.09 //x2=11.995 //y2=0.715
cc_726 ( N_noxref_4_c_773_n N_GND_c_1689_n ) capacitor c=0.0248964f //x=5.84 \
 //y=1.405 //x2=3.82 //y2=0.175
cc_727 ( N_noxref_4_M1_noxref_d N_GND_c_1689_n ) capacitor c=0.00128657f \
 //x=2.45 //y=1.085 //x2=3.82 //y2=0.175
cc_728 ( N_noxref_4_c_778_n N_GND_c_1720_n ) capacitor c=0.00135353f //x=9.74 \
 //y=4.095 //x2=7.15 //y2=0.175
cc_729 ( N_noxref_4_c_792_n N_GND_c_1720_n ) capacitor c=0.0183315f //x=9.135 \
 //y=1.405 //x2=7.15 //y2=0.175
cc_730 ( N_noxref_4_M3_noxref_d N_GND_c_1720_n ) capacitor c=0.00129152f \
 //x=5.78 //y=1.085 //x2=7.15 //y2=0.175
cc_731 ( N_noxref_4_c_829_n N_GND_c_1730_n ) capacitor c=0.00248396f //x=9.3 \
 //y=1.74 //x2=10.48 //y2=0.175
cc_732 ( N_noxref_4_c_832_n N_GND_c_1730_n ) capacitor c=0.0274191f //x=9.655 \
 //y=1.825 //x2=10.48 //y2=0.175
cc_733 ( N_noxref_4_c_850_n N_GND_c_1730_n ) capacitor c=0.0103129f //x=11.22 \
 //y=4.095 //x2=10.48 //y2=0.175
cc_734 ( N_noxref_4_c_988_p N_GND_c_1730_n ) capacitor c=0.00682461f //x=11.22 \
 //y=2.265 //x2=10.48 //y2=0.175
cc_735 ( N_noxref_4_c_913_p N_GND_c_1730_n ) capacitor c=0.0035382f //x=11.06 \
 //y=4.255 //x2=10.48 //y2=0.175
cc_736 ( N_noxref_4_c_991_p N_GND_c_1730_n ) capacitor c=0.00733236f //x=11.22 \
 //y=2.265 //x2=10.48 //y2=0.175
cc_737 ( N_noxref_4_c_1010_p N_GND_c_1730_n ) capacitor c=0.00427116f \
 //x=11.33 //y=2.1 //x2=10.48 //y2=0.175
cc_738 ( N_noxref_4_c_997_p N_GND_c_1730_n ) capacitor c=0.00786308f //x=11.22 \
 //y=2.265 //x2=10.48 //y2=0.175
cc_739 ( N_noxref_4_M5_noxref_d N_GND_c_1730_n ) capacitor c=0.00165161f \
 //x=9.11 //y=1.085 //x2=10.48 //y2=0.175
cc_740 ( N_noxref_4_c_819_n N_GND_c_1802_n ) capacitor c=3.45583e-19 //x=9.3 \
 //y=1.535 //x2=12.08 //y2=0.175
cc_741 ( N_noxref_4_c_781_n N_GND_c_1802_n ) capacitor c=3.45583e-19 //x=5.97 \
 //y=1.36 //x2=12.08 //y2=0.175
cc_742 ( N_noxref_4_c_991_p N_GND_c_1802_n ) capacitor c=0.0022444f //x=11.22 \
 //y=2.265 //x2=12.08 //y2=0.175
cc_743 ( N_noxref_4_c_997_p N_GND_c_1802_n ) capacitor c=2.63786e-19 //x=11.22 \
 //y=2.265 //x2=12.08 //y2=0.175
cc_744 ( N_noxref_4_c_894_p N_GND_M6_noxref_s ) capacitor c=4.66358e-19 \
 //x=11.22 //y=4.415 //x2=10.975 //y2=0.55
cc_745 ( N_noxref_4_c_988_p N_GND_M6_noxref_s ) capacitor c=0.00297876f \
 //x=11.22 //y=2.265 //x2=10.975 //y2=0.55
cc_746 ( N_noxref_4_c_991_p N_GND_M6_noxref_s ) capacitor c=0.00651326f \
 //x=11.22 //y=2.265 //x2=10.975 //y2=0.55
cc_747 ( N_noxref_4_c_996_p N_GND_M6_noxref_s ) capacitor c=0.0301091f \
 //x=11.33 //y=1.09 //x2=10.975 //y2=0.55
cc_748 ( N_noxref_4_c_1021_p N_GND_M6_noxref_s ) capacitor c=0.002132f \
 //x=11.33 //y=1.745 //x2=10.975 //y2=0.55
cc_749 ( N_noxref_4_c_1010_p N_GND_M6_noxref_s ) capacitor c=0.00304786f \
 //x=11.33 //y=2.1 //x2=10.975 //y2=0.55
cc_750 ( N_noxref_4_c_1023_p N_GND_M6_noxref_s ) capacitor c=0.00517463f \
 //x=11.705 //y=0.935 //x2=10.975 //y2=0.55
cc_751 ( N_noxref_4_c_998_p N_GND_M6_noxref_s ) capacitor c=0.0153553f \
 //x=11.86 //y=1.09 //x2=10.975 //y2=0.55
cc_752 ( N_noxref_4_c_1025_p N_GND_M6_noxref_s ) capacitor c=0.00629878f \
 //x=11.86 //y=1.435 //x2=10.975 //y2=0.55
cc_753 ( N_noxref_4_c_997_p N_GND_M6_noxref_s ) capacitor c=0.00660555f \
 //x=11.22 //y=2.265 //x2=10.975 //y2=0.55
cc_754 ( N_noxref_4_c_778_n Y ) capacitor c=0.00353207f //x=9.74 //y=4.095 \
 //x2=11.96 //y2=2.405
cc_755 ( N_noxref_4_c_780_n Y ) capacitor c=0.00159336f //x=9.74 //y=5.305 \
 //x2=11.96 //y2=2.405
cc_756 ( N_noxref_4_c_850_n Y ) capacitor c=0.078466f //x=11.22 //y=4.095 \
 //x2=11.96 //y2=2.405
cc_757 ( N_noxref_4_c_894_p Y ) capacitor c=0.0149195f //x=11.22 //y=4.415 \
 //x2=11.96 //y2=2.405
cc_758 ( N_noxref_4_c_851_n Y ) capacitor c=0.0217291f //x=11.22 //y=4.76 \
 //x2=11.96 //y2=2.405
cc_759 ( N_noxref_4_c_912_p Y ) capacitor c=0.00459089f //x=11.22 //y=4.25 \
 //x2=11.96 //y2=2.405
cc_760 ( N_noxref_4_c_988_p Y ) capacitor c=0.00825076f //x=11.22 //y=2.265 \
 //x2=11.96 //y2=2.405
cc_761 ( N_noxref_4_c_928_p Y ) capacitor c=0.00699818f //x=11.22 //y=4.255 \
 //x2=11.96 //y2=2.405
cc_762 ( N_noxref_4_c_991_p Y ) capacitor c=0.0023016f //x=11.22 //y=2.265 \
 //x2=11.96 //y2=2.405
cc_763 ( N_noxref_4_c_896_p Y ) capacitor c=0.00250262f //x=11.22 //y=4.88 \
 //x2=11.96 //y2=2.405
cc_764 ( N_noxref_4_c_922_p Y ) capacitor c=4.08297e-19 //x=11.74 //y=4.97 \
 //x2=11.96 //y2=2.405
cc_765 ( N_noxref_4_c_917_p Y ) capacitor c=0.00124564f //x=11.45 //y=4.97 \
 //x2=11.96 //y2=2.405
cc_766 ( N_noxref_4_c_997_p Y ) capacitor c=0.00112403f //x=11.22 //y=2.265 \
 //x2=11.96 //y2=2.405
cc_767 ( N_noxref_4_c_819_n N_Y_c_1934_n ) capacitor c=0.00149649f //x=9.3 \
 //y=1.535 //x2=11.59 //y2=1.935
cc_768 ( N_noxref_4_c_829_n N_Y_c_1934_n ) capacitor c=0.00189939f //x=9.3 \
 //y=1.74 //x2=11.59 //y2=1.935
cc_769 ( N_noxref_4_c_832_n N_Y_c_1934_n ) capacitor c=0.00329389f //x=9.655 \
 //y=1.825 //x2=11.59 //y2=1.935
cc_770 ( N_noxref_4_c_867_n N_Y_c_1934_n ) capacitor c=0.00587899f //x=9.295 \
 //y=1.405 //x2=11.59 //y2=1.935
cc_771 ( N_noxref_4_c_1044_p N_Y_c_1934_n ) capacitor c=0.0010801f //x=11.33 \
 //y=1.435 //x2=11.59 //y2=1.935
cc_772 ( N_noxref_4_c_1021_p N_Y_c_1934_n ) capacitor c=0.00523499f //x=11.33 \
 //y=1.745 //x2=11.59 //y2=1.935
cc_773 ( N_noxref_4_c_1010_p N_Y_c_1934_n ) capacitor c=0.00376062f //x=11.33 \
 //y=2.1 //x2=11.59 //y2=1.935
cc_774 ( N_noxref_4_c_1047_p N_Y_c_1934_n ) capacitor c=0.00934105f //x=11.705 \
 //y=1.59 //x2=11.59 //y2=1.935
cc_775 ( N_noxref_4_c_1025_p N_Y_c_1934_n ) capacitor c=0.00362207f //x=11.86 \
 //y=1.435 //x2=11.59 //y2=1.935
cc_776 ( N_noxref_4_c_831_n N_Y_c_1943_n ) capacitor c=0.00315048f //x=9.655 \
 //y=5.39 //x2=11.595 //y2=5.42
cc_777 ( N_noxref_4_c_860_n N_Y_c_1943_n ) capacitor c=5.82161e-19 //x=9.257 \
 //y=5.39 //x2=11.595 //y2=5.42
cc_778 ( N_noxref_4_M19_noxref_g N_Y_c_1943_n ) capacitor c=0.00141266f \
 //x=11.375 //y=6.2 //x2=11.595 //y2=5.42
cc_779 ( N_noxref_4_M20_noxref_g N_Y_c_1943_n ) capacitor c=0.00377331f \
 //x=11.815 //y=6.2 //x2=11.595 //y2=5.42
cc_780 ( N_noxref_4_c_1047_p N_Y_c_1947_n ) capacitor c=0.00180253f //x=11.705 \
 //y=1.59 //x2=11.875 //y2=2.02
cc_781 ( N_noxref_4_c_778_n N_Y_c_1948_n ) capacitor c=0.00329389f //x=9.74 \
 //y=4.095 //x2=11.675 //y2=2.02
cc_782 ( N_noxref_4_c_997_p N_Y_c_1948_n ) capacitor c=0.00376062f //x=11.22 \
 //y=2.265 //x2=11.675 //y2=2.02
cc_783 ( N_noxref_4_M20_noxref_g N_Y_c_1950_n ) capacitor c=0.00966342f \
 //x=11.815 //y=6.2 //x2=11.875 //y2=5.14
cc_784 ( N_noxref_4_c_780_n N_Y_c_1951_n ) capacitor c=0.00293539f //x=9.74 \
 //y=5.305 //x2=11.68 //y2=5.14
cc_785 ( N_noxref_4_M19_noxref_g N_Y_c_1951_n ) capacitor c=0.00427521f \
 //x=11.375 //y=6.2 //x2=11.68 //y2=5.14
cc_786 ( N_noxref_4_c_922_p N_Y_c_1951_n ) capacitor c=0.00262283f //x=11.74 \
 //y=4.97 //x2=11.68 //y2=5.14
cc_787 ( N_noxref_4_c_819_n N_Y_c_1954_n ) capacitor c=0.00142298f //x=9.3 \
 //y=1.535 //x2=11.59 //y2=1.185
cc_788 ( N_noxref_4_c_867_n N_Y_c_1954_n ) capacitor c=0.00109769f //x=9.295 \
 //y=1.405 //x2=11.59 //y2=1.185
cc_789 ( N_noxref_4_c_996_p N_Y_c_1954_n ) capacitor c=0.0018223f //x=11.33 \
 //y=1.09 //x2=11.59 //y2=1.185
cc_790 ( N_noxref_4_c_1044_p N_Y_c_1954_n ) capacitor c=0.00375161f //x=11.33 \
 //y=1.435 //x2=11.59 //y2=1.185
cc_791 ( N_noxref_4_c_1023_p N_Y_c_1954_n ) capacitor c=5.57924e-19 //x=11.705 \
 //y=0.935 //x2=11.59 //y2=1.185
cc_792 ( N_noxref_4_c_1047_p N_Y_c_1954_n ) capacitor c=5.75878e-19 //x=11.705 \
 //y=1.59 //x2=11.59 //y2=1.185
cc_793 ( N_noxref_4_c_998_p N_Y_c_1954_n ) capacitor c=0.00160969f //x=11.86 \
 //y=1.09 //x2=11.59 //y2=1.185
cc_794 ( N_noxref_4_c_1025_p N_Y_c_1954_n ) capacitor c=0.00411132f //x=11.86 \
 //y=1.435 //x2=11.59 //y2=1.185
cc_795 ( N_noxref_4_M19_noxref_g N_Y_c_1962_n ) capacitor c=0.0162066f \
 //x=11.375 //y=6.2 //x2=11.595 //y2=5.56
cc_796 ( N_noxref_4_M20_noxref_g N_Y_c_1962_n ) capacitor c=0.0162066f \
 //x=11.815 //y=6.2 //x2=11.595 //y2=5.56
cc_797 ( N_noxref_4_c_922_p N_Y_c_1962_n ) capacitor c=0.00290963f //x=11.74 \
 //y=4.97 //x2=11.595 //y2=5.56
cc_798 ( N_noxref_4_c_996_p N_Y_M6_noxref_d ) capacitor c=0.00137914f \
 //x=11.33 //y=1.09 //x2=11.405 //y2=1.09
cc_799 ( N_noxref_4_c_1044_p N_Y_M6_noxref_d ) capacitor c=0.0023891f \
 //x=11.33 //y=1.435 //x2=11.405 //y2=1.09
cc_800 ( N_noxref_4_c_1023_p N_Y_M6_noxref_d ) capacitor c=0.0020782f \
 //x=11.705 //y=0.935 //x2=11.405 //y2=1.09
cc_801 ( N_noxref_4_c_1047_p N_Y_M6_noxref_d ) capacitor c=0.00356097f \
 //x=11.705 //y=1.59 //x2=11.405 //y2=1.09
cc_802 ( N_noxref_4_c_998_p N_Y_M6_noxref_d ) capacitor c=0.00138452f \
 //x=11.86 //y=1.09 //x2=11.405 //y2=1.09
cc_803 ( N_noxref_4_c_1025_p N_Y_M6_noxref_d ) capacitor c=0.00235934f \
 //x=11.86 //y=1.435 //x2=11.405 //y2=1.09
cc_804 ( N_noxref_4_c_852_n N_noxref_10_c_2023_n ) capacitor c=0.00587436f \
 //x=2.64 //y=1.36 //x2=3.04 //y2=0.71
cc_805 ( N_noxref_4_c_773_n N_noxref_10_c_2023_n ) capacitor c=0.00185906f \
 //x=5.84 //y=1.405 //x2=3.04 //y2=0.71
cc_806 ( N_noxref_4_M1_noxref_d N_noxref_10_c_2023_n ) capacitor c=0.0136817f \
 //x=2.45 //y=1.085 //x2=3.04 //y2=0.71
cc_807 ( N_noxref_4_c_852_n N_noxref_10_M0_noxref_s ) capacitor c=0.0131763f \
 //x=2.64 //y=1.36 //x2=1.05 //y2=0.545
cc_808 ( N_noxref_4_c_773_n N_noxref_10_M0_noxref_s ) capacitor c=0.0123961f \
 //x=5.84 //y=1.405 //x2=1.05 //y2=0.545
cc_809 ( N_noxref_4_M1_noxref_d N_noxref_10_M0_noxref_s ) capacitor \
 c=0.0446285f //x=2.45 //y=1.085 //x2=1.05 //y2=0.545
cc_810 ( N_noxref_4_c_773_n N_noxref_12_c_2080_n ) capacitor c=0.0151405f \
 //x=5.84 //y=1.405 //x2=5.4 //y2=1.76
cc_811 ( N_noxref_4_c_781_n N_noxref_12_c_2092_n ) capacitor c=0.0057298f \
 //x=5.97 //y=1.36 //x2=6.37 //y2=0.71
cc_812 ( N_noxref_4_c_773_n N_noxref_12_c_2092_n ) capacitor c=0.00185906f \
 //x=5.84 //y=1.405 //x2=6.37 //y2=0.71
cc_813 ( N_noxref_4_c_792_n N_noxref_12_c_2092_n ) capacitor c=0.00454743f \
 //x=9.135 //y=1.405 //x2=6.37 //y2=0.71
cc_814 ( N_noxref_4_M3_noxref_d N_noxref_12_c_2092_n ) capacitor c=0.0130616f \
 //x=5.78 //y=1.085 //x2=6.37 //y2=0.71
cc_815 ( N_noxref_4_c_781_n N_noxref_12_M2_noxref_s ) capacitor c=0.0103808f \
 //x=5.97 //y=1.36 //x2=4.38 //y2=0.545
cc_816 ( N_noxref_4_c_773_n N_noxref_12_M2_noxref_s ) capacitor c=0.0271564f \
 //x=5.84 //y=1.405 //x2=4.38 //y2=0.545
cc_817 ( N_noxref_4_c_792_n N_noxref_12_M2_noxref_s ) capacitor c=0.00742061f \
 //x=9.135 //y=1.405 //x2=4.38 //y2=0.545
cc_818 ( N_noxref_4_M3_noxref_d N_noxref_12_M2_noxref_s ) capacitor \
 c=0.0441243f //x=5.78 //y=1.085 //x2=4.38 //y2=0.545
cc_819 ( N_noxref_4_c_792_n N_noxref_13_c_2149_n ) capacitor c=0.0135245f \
 //x=9.135 //y=1.405 //x2=8.73 //y2=1.76
cc_820 ( N_noxref_4_c_833_n N_noxref_13_c_2156_n ) capacitor c=0.00714695f \
 //x=9.385 //y=1.825 //x2=8.815 //y2=1.675
cc_821 ( N_noxref_4_c_778_n N_noxref_13_c_2156_n ) capacitor c=2.92748e-19 \
 //x=9.74 //y=4.095 //x2=8.815 //y2=1.675
cc_822 ( N_noxref_4_c_819_n N_noxref_13_c_2165_n ) capacitor c=0.00515582f \
 //x=9.3 //y=1.535 //x2=9.7 //y2=0.71
cc_823 ( N_noxref_4_c_832_n N_noxref_13_c_2165_n ) capacitor c=0.00332518f \
 //x=9.655 //y=1.825 //x2=9.7 //y2=0.71
cc_824 ( N_noxref_4_c_867_n N_noxref_13_c_2165_n ) capacitor c=0.00224828f \
 //x=9.295 //y=1.405 //x2=9.7 //y2=0.71
cc_825 ( N_noxref_4_c_792_n N_noxref_13_c_2165_n ) capacitor c=0.00185838f \
 //x=9.135 //y=1.405 //x2=9.7 //y2=0.71
cc_826 ( N_noxref_4_M5_noxref_d N_noxref_13_c_2165_n ) capacitor c=0.0135038f \
 //x=9.11 //y=1.085 //x2=9.7 //y2=0.71
cc_827 ( N_noxref_4_c_819_n N_noxref_13_M4_noxref_s ) capacitor c=0.010254f \
 //x=9.3 //y=1.535 //x2=7.71 //y2=0.545
cc_828 ( N_noxref_4_c_829_n N_noxref_13_M4_noxref_s ) capacitor c=0.00775201f \
 //x=9.3 //y=1.74 //x2=7.71 //y2=0.545
cc_829 ( N_noxref_4_c_832_n N_noxref_13_M4_noxref_s ) capacitor c=0.00706721f \
 //x=9.655 //y=1.825 //x2=7.71 //y2=0.545
cc_830 ( N_noxref_4_c_864_n N_noxref_13_M4_noxref_s ) capacitor c=7.05604e-19 \
 //x=9.74 //y=4.25 //x2=7.71 //y2=0.545
cc_831 ( N_noxref_4_c_867_n N_noxref_13_M4_noxref_s ) capacitor c=0.0090031f \
 //x=9.295 //y=1.405 //x2=7.71 //y2=0.545
cc_832 ( N_noxref_4_c_792_n N_noxref_13_M4_noxref_s ) capacitor c=0.0219823f \
 //x=9.135 //y=1.405 //x2=7.71 //y2=0.545
cc_833 ( N_noxref_4_M5_noxref_d N_noxref_13_M4_noxref_s ) capacitor \
 c=0.0431094f //x=9.11 //y=1.085 //x2=7.71 //y2=0.545
cc_834 ( N_VDD_c_1218_p N_noxref_6_c_1360_n ) capacitor c=4.78686e-19 \
 //x=2.075 //y=7.585 //x2=2.485 //y2=5.39
cc_835 ( N_VDD_c_1109_n N_noxref_6_c_1360_n ) capacitor c=0.00476346f //x=2.16 \
 //y=7.035 //x2=2.485 //y2=5.39
cc_836 ( N_VDD_c_1220_p N_noxref_6_c_1360_n ) capacitor c=5.98042e-19 \
 //x=2.955 //y=7.585 //x2=2.485 //y2=5.39
cc_837 ( N_VDD_c_1112_n N_noxref_6_c_1360_n ) capacitor c=0.00734603f //x=3.65 \
 //y=7.585 //x2=2.485 //y2=5.39
cc_838 ( N_VDD_M8_noxref_d N_noxref_6_c_1360_n ) capacitor c=0.00679741f \
 //x=2.015 //y=5.205 //x2=2.485 //y2=5.39
cc_839 ( N_VDD_c_1220_p N_noxref_6_c_1362_n ) capacitor c=5.52065e-19 \
 //x=2.955 //y=7.585 //x2=4.485 //y2=5.39
cc_840 ( N_VDD_c_1152_n N_noxref_6_c_1362_n ) capacitor c=0.0040485f //x=3.04 \
 //y=7.035 //x2=4.485 //y2=5.39
cc_841 ( N_VDD_c_1176_n N_noxref_6_c_1362_n ) capacitor c=0.0140204f //x=11.96 \
 //y=7.58 //x2=4.485 //y2=5.39
cc_842 ( N_VDD_c_1112_n N_noxref_6_c_1362_n ) capacitor c=0.00703326f //x=3.65 \
 //y=7.585 //x2=4.485 //y2=5.39
cc_843 ( N_VDD_c_1120_n N_noxref_6_c_1362_n ) capacitor c=0.00273146f //x=6.98 \
 //y=7.585 //x2=4.485 //y2=5.39
cc_844 ( N_VDD_c_1123_n N_noxref_6_c_1362_n ) capacitor c=0.039327f //x=3.82 \
 //y=7.585 //x2=4.485 //y2=5.39
cc_845 ( N_VDD_M10_noxref_d N_noxref_6_c_1362_n ) capacitor c=0.0138307f \
 //x=2.895 //y=5.205 //x2=4.485 //y2=5.39
cc_846 ( N_VDD_c_1115_n N_noxref_6_c_1365_n ) capacitor c=2.89592e-19 //x=1.23 \
 //y=7.58 //x2=2.715 //y2=5.39
cc_847 ( N_VDD_c_1123_n N_noxref_6_c_1365_n ) capacitor c=3.35418e-19 //x=3.82 \
 //y=7.585 //x2=2.715 //y2=5.39
cc_848 ( N_VDD_M10_noxref_d N_noxref_6_c_1365_n ) capacitor c=6.02701e-19 \
 //x=2.895 //y=5.205 //x2=2.715 //y2=5.39
cc_849 ( N_VDD_c_1202_n N_noxref_6_c_1366_n ) capacitor c=0.00223213f \
 //x=11.96 //y=7.58 //x2=5.36 //y2=7.09
cc_850 ( N_VDD_c_1202_n N_noxref_6_c_1388_n ) capacitor c=0.00223213f \
 //x=11.96 //y=7.58 //x2=6.245 //y2=7.09
cc_851 ( N_VDD_M7_noxref_s N_noxref_6_c_1372_n ) capacitor c=0.0567031f \
 //x=1.145 //y=5.205 //x2=1.722 //y2=5.39
cc_852 ( N_VDD_c_1152_n N_noxref_6_c_1376_n ) capacitor c=0.00979658f //x=3.04 \
 //y=7.035 //x2=4.6 //y2=6.92
cc_853 ( N_VDD_c_1153_n N_noxref_6_c_1376_n ) capacitor c=0.00197255f //x=3.04 \
 //y=7.41 //x2=4.6 //y2=6.92
cc_854 ( N_VDD_c_1176_n N_noxref_6_c_1376_n ) capacitor c=0.172093f //x=11.96 \
 //y=7.58 //x2=4.6 //y2=6.92
cc_855 ( N_VDD_c_1120_n N_noxref_6_c_1376_n ) capacitor c=0.0401324f //x=6.98 \
 //y=7.585 //x2=4.6 //y2=6.92
cc_856 ( N_VDD_c_1123_n N_noxref_6_c_1376_n ) capacitor c=0.00739076f //x=3.82 \
 //y=7.585 //x2=4.6 //y2=6.92
cc_857 ( N_VDD_c_1202_n N_noxref_6_c_1376_n ) capacitor c=0.00112916f \
 //x=11.96 //y=7.58 //x2=4.6 //y2=6.92
cc_858 ( N_VDD_c_1202_n N_noxref_6_c_1377_n ) capacitor c=0.00112693f \
 //x=11.96 //y=7.58 //x2=5.477 //y2=7.09
cc_859 ( N_VDD_c_1176_n N_noxref_6_c_1391_n ) capacitor c=0.0021469f //x=11.96 \
 //y=7.58 //x2=6.36 //y2=6.92
cc_860 ( N_VDD_c_1120_n N_noxref_6_c_1391_n ) capacitor c=4.35699e-19 //x=6.98 \
 //y=7.585 //x2=6.36 //y2=6.92
cc_861 ( N_VDD_c_1129_n N_noxref_6_c_1391_n ) capacitor c=0.00733935f //x=7.15 \
 //y=7.585 //x2=6.36 //y2=6.92
cc_862 ( N_VDD_c_1202_n N_noxref_6_c_1391_n ) capacitor c=0.00112693f \
 //x=11.96 //y=7.58 //x2=6.36 //y2=6.92
cc_863 ( N_VDD_c_1107_n N_noxref_6_c_1378_n ) capacitor c=0.0041288f //x=1.28 \
 //y=7.035 //x2=1.72 //y2=5.56
cc_864 ( N_VDD_c_1108_n N_noxref_6_c_1378_n ) capacitor c=0.00145923f //x=1.28 \
 //y=7.41 //x2=1.72 //y2=5.56
cc_865 ( N_VDD_c_1218_p N_noxref_6_c_1378_n ) capacitor c=0.00233559f \
 //x=2.075 //y=7.585 //x2=1.72 //y2=5.56
cc_866 ( N_VDD_c_1109_n N_noxref_6_c_1378_n ) capacitor c=0.00220869f //x=2.16 \
 //y=7.035 //x2=1.72 //y2=5.56
cc_867 ( N_VDD_c_1110_n N_noxref_6_c_1378_n ) capacitor c=0.00130452f //x=2.16 \
 //y=7.41 //x2=1.72 //y2=5.56
cc_868 ( N_VDD_c_1112_n N_noxref_6_c_1378_n ) capacitor c=0.0112616f //x=3.65 \
 //y=7.585 //x2=1.72 //y2=5.56
cc_869 ( N_VDD_c_1115_n N_noxref_6_c_1378_n ) capacitor c=0.00724623f //x=1.23 \
 //y=7.58 //x2=1.72 //y2=5.56
cc_870 ( N_VDD_c_1202_n N_noxref_6_c_1378_n ) capacitor c=0.00141431f \
 //x=11.96 //y=7.58 //x2=1.72 //y2=5.56
cc_871 ( N_VDD_M7_noxref_s N_noxref_6_c_1378_n ) capacitor c=0.0916487f \
 //x=1.145 //y=5.205 //x2=1.72 //y2=5.56
cc_872 ( N_VDD_M8_noxref_d N_noxref_6_c_1378_n ) capacitor c=0.0724825f \
 //x=2.015 //y=5.205 //x2=1.72 //y2=5.56
cc_873 ( N_VDD_c_1109_n N_noxref_6_c_1381_n ) capacitor c=0.00230229f //x=2.16 \
 //y=7.035 //x2=2.6 //y2=5.39
cc_874 ( N_VDD_c_1110_n N_noxref_6_c_1381_n ) capacitor c=0.00130452f //x=2.16 \
 //y=7.41 //x2=2.6 //y2=5.39
cc_875 ( N_VDD_c_1220_p N_noxref_6_c_1381_n ) capacitor c=0.00233409f \
 //x=2.955 //y=7.585 //x2=2.6 //y2=5.39
cc_876 ( N_VDD_c_1152_n N_noxref_6_c_1381_n ) capacitor c=0.00225444f //x=3.04 \
 //y=7.035 //x2=2.6 //y2=5.39
cc_877 ( N_VDD_c_1153_n N_noxref_6_c_1381_n ) capacitor c=0.00130452f //x=3.04 \
 //y=7.41 //x2=2.6 //y2=5.39
cc_878 ( N_VDD_c_1112_n N_noxref_6_c_1381_n ) capacitor c=0.0112507f //x=3.65 \
 //y=7.585 //x2=2.6 //y2=5.39
cc_879 ( N_VDD_c_1115_n N_noxref_6_c_1381_n ) capacitor c=0.00105746f //x=1.23 \
 //y=7.58 //x2=2.6 //y2=5.39
cc_880 ( N_VDD_c_1123_n N_noxref_6_c_1381_n ) capacitor c=0.00924237f //x=3.82 \
 //y=7.585 //x2=2.6 //y2=5.39
cc_881 ( N_VDD_c_1202_n N_noxref_6_c_1381_n ) capacitor c=0.00141642f \
 //x=11.96 //y=7.58 //x2=2.6 //y2=5.39
cc_882 ( N_VDD_M7_noxref_s N_noxref_6_c_1381_n ) capacitor c=0.00151756f \
 //x=1.145 //y=5.205 //x2=2.6 //y2=5.39
cc_883 ( N_VDD_M8_noxref_d N_noxref_6_c_1381_n ) capacitor c=0.0724825f \
 //x=2.015 //y=5.205 //x2=2.6 //y2=5.39
cc_884 ( N_VDD_M10_noxref_d N_noxref_6_c_1381_n ) capacitor c=0.0886704f \
 //x=2.895 //y=5.205 //x2=2.6 //y2=5.39
cc_885 ( N_VDD_c_1176_n N_noxref_6_c_1382_n ) capacitor c=0.00204931f \
 //x=11.96 //y=7.58 //x2=4.6 //y2=5.39
cc_886 ( N_VDD_c_1120_n N_noxref_6_c_1382_n ) capacitor c=0.00853641f //x=6.98 \
 //y=7.585 //x2=4.6 //y2=5.39
cc_887 ( N_VDD_c_1123_n N_noxref_6_c_1382_n ) capacitor c=0.0602194f //x=3.82 \
 //y=7.585 //x2=4.6 //y2=5.39
cc_888 ( N_VDD_c_1129_n N_noxref_6_c_1382_n ) capacitor c=6.42159e-19 //x=7.15 \
 //y=7.585 //x2=4.6 //y2=5.39
cc_889 ( N_VDD_c_1202_n N_noxref_6_c_1382_n ) capacitor c=0.00100974f \
 //x=11.96 //y=7.58 //x2=4.6 //y2=5.39
cc_890 ( N_VDD_M10_noxref_d N_noxref_6_c_1382_n ) capacitor c=0.00230512f \
 //x=2.895 //y=5.205 //x2=4.6 //y2=5.39
cc_891 ( N_VDD_c_1107_n N_noxref_6_M7_noxref_d ) capacitor c=0.0391448f \
 //x=1.28 //y=7.035 //x2=1.575 //y2=5.205
cc_892 ( N_VDD_c_1108_n N_noxref_6_M7_noxref_d ) capacitor c=0.00985747f \
 //x=1.28 //y=7.41 //x2=1.575 //y2=5.205
cc_893 ( N_VDD_c_1218_p N_noxref_6_M7_noxref_d ) capacitor c=0.0238892f \
 //x=2.075 //y=7.585 //x2=1.575 //y2=5.205
cc_894 ( N_VDD_c_1109_n N_noxref_6_M7_noxref_d ) capacitor c=0.0380657f \
 //x=2.16 //y=7.035 //x2=1.575 //y2=5.205
cc_895 ( N_VDD_c_1110_n N_noxref_6_M7_noxref_d ) capacitor c=0.0100015f \
 //x=2.16 //y=7.41 //x2=1.575 //y2=5.205
cc_896 ( N_VDD_c_1112_n N_noxref_6_M7_noxref_d ) capacitor c=0.00302682f \
 //x=3.65 //y=7.585 //x2=1.575 //y2=5.205
cc_897 ( N_VDD_c_1202_n N_noxref_6_M7_noxref_d ) capacitor c=0.00112916f \
 //x=11.96 //y=7.58 //x2=1.575 //y2=5.205
cc_898 ( N_VDD_M7_noxref_s N_noxref_6_M7_noxref_d ) capacitor c=0.00271779f \
 //x=1.145 //y=5.205 //x2=1.575 //y2=5.205
cc_899 ( N_VDD_M8_noxref_d N_noxref_6_M7_noxref_d ) capacitor c=0.00360728f \
 //x=2.015 //y=5.205 //x2=1.575 //y2=5.205
cc_900 ( N_VDD_c_1109_n N_noxref_6_M9_noxref_d ) capacitor c=0.0379915f \
 //x=2.16 //y=7.035 //x2=2.455 //y2=5.205
cc_901 ( N_VDD_c_1110_n N_noxref_6_M9_noxref_d ) capacitor c=0.0100015f \
 //x=2.16 //y=7.41 //x2=2.455 //y2=5.205
cc_902 ( N_VDD_c_1220_p N_noxref_6_M9_noxref_d ) capacitor c=0.0230655f \
 //x=2.955 //y=7.585 //x2=2.455 //y2=5.205
cc_903 ( N_VDD_c_1152_n N_noxref_6_M9_noxref_d ) capacitor c=0.0379915f \
 //x=3.04 //y=7.035 //x2=2.455 //y2=5.205
cc_904 ( N_VDD_c_1153_n N_noxref_6_M9_noxref_d ) capacitor c=0.0100015f \
 //x=3.04 //y=7.41 //x2=2.455 //y2=5.205
cc_905 ( N_VDD_c_1112_n N_noxref_6_M9_noxref_d ) capacitor c=0.00283306f \
 //x=3.65 //y=7.585 //x2=2.455 //y2=5.205
cc_906 ( N_VDD_c_1202_n N_noxref_6_M9_noxref_d ) capacitor c=0.00112916f \
 //x=11.96 //y=7.58 //x2=2.455 //y2=5.205
cc_907 ( N_VDD_M8_noxref_d N_noxref_6_M9_noxref_d ) capacitor c=0.00351276f \
 //x=2.015 //y=5.205 //x2=2.455 //y2=5.205
cc_908 ( N_VDD_M10_noxref_d N_noxref_6_M9_noxref_d ) capacitor c=0.00355849f \
 //x=2.895 //y=5.205 //x2=2.455 //y2=5.205
cc_909 ( N_VDD_c_1176_n N_noxref_6_M12_noxref_d ) capacitor c=0.00206569f \
 //x=11.96 //y=7.58 //x2=5.335 //y2=5.205
cc_910 ( N_VDD_c_1120_n N_noxref_6_M12_noxref_d ) capacitor c=0.00856914f \
 //x=6.98 //y=7.585 //x2=5.335 //y2=5.205
cc_911 ( N_VDD_c_1202_n N_noxref_6_M12_noxref_d ) capacitor c=0.00100487f \
 //x=11.96 //y=7.58 //x2=5.335 //y2=5.205
cc_912 ( N_VDD_c_1176_n N_noxref_6_M14_noxref_d ) capacitor c=0.00206569f \
 //x=11.96 //y=7.58 //x2=6.215 //y2=5.205
cc_913 ( N_VDD_c_1120_n N_noxref_6_M14_noxref_d ) capacitor c=0.00856914f \
 //x=6.98 //y=7.585 //x2=6.215 //y2=5.205
cc_914 ( N_VDD_c_1129_n N_noxref_6_M14_noxref_d ) capacitor c=0.0448255f \
 //x=7.15 //y=7.585 //x2=6.215 //y2=5.205
cc_915 ( N_VDD_c_1202_n N_noxref_6_M14_noxref_d ) capacitor c=0.00100487f \
 //x=11.96 //y=7.58 //x2=6.215 //y2=5.205
cc_916 ( N_VDD_c_1176_n N_noxref_7_c_1539_n ) capacitor c=0.0143613f //x=11.96 \
 //y=7.58 //x2=7.825 //y2=5.39
cc_917 ( N_VDD_c_1120_n N_noxref_7_c_1539_n ) capacitor c=0.00398048f //x=6.98 \
 //y=7.585 //x2=7.825 //y2=5.39
cc_918 ( N_VDD_c_1138_n N_noxref_7_c_1539_n ) capacitor c=0.00275849f \
 //x=10.31 //y=7.585 //x2=7.825 //y2=5.39
cc_919 ( N_VDD_c_1129_n N_noxref_7_c_1539_n ) capacitor c=0.042287f //x=7.15 \
 //y=7.585 //x2=7.825 //y2=5.39
cc_920 ( N_VDD_c_1129_n N_noxref_7_c_1549_n ) capacitor c=6.67754e-19 //x=7.15 \
 //y=7.585 //x2=6.035 //y2=5.39
cc_921 ( N_VDD_c_1202_n N_noxref_7_c_1551_n ) capacitor c=0.00223213f \
 //x=11.96 //y=7.58 //x2=8.705 //y2=7.09
cc_922 ( N_VDD_c_1202_n N_noxref_7_c_1565_n ) capacitor c=0.00223213f \
 //x=11.96 //y=7.58 //x2=9.57 //y2=7.09
cc_923 ( N_VDD_c_1129_n N_noxref_7_c_1527_n ) capacitor c=0.00108821f //x=7.15 \
 //y=7.585 //x2=5.04 //y2=5.39
cc_924 ( N_VDD_M7_noxref_s N_noxref_7_c_1527_n ) capacitor c=4.98377e-19 \
 //x=1.145 //y=5.205 //x2=5.04 //y2=5.39
cc_925 ( N_VDD_c_1129_n N_noxref_7_c_1553_n ) capacitor c=0.00456697f //x=7.15 \
 //y=7.585 //x2=5.92 //y2=5.39
cc_926 ( N_VDD_c_1176_n N_noxref_7_c_1556_n ) capacitor c=0.172244f //x=11.96 \
 //y=7.58 //x2=7.94 //y2=6.92
cc_927 ( N_VDD_c_1138_n N_noxref_7_c_1556_n ) capacitor c=0.0392376f //x=10.31 \
 //y=7.585 //x2=7.94 //y2=6.92
cc_928 ( N_VDD_c_1129_n N_noxref_7_c_1556_n ) capacitor c=0.00730382f //x=7.15 \
 //y=7.585 //x2=7.94 //y2=6.92
cc_929 ( N_VDD_c_1202_n N_noxref_7_c_1556_n ) capacitor c=0.00112916f \
 //x=11.96 //y=7.58 //x2=7.94 //y2=6.92
cc_930 ( N_VDD_c_1202_n N_noxref_7_c_1557_n ) capacitor c=0.00112693f \
 //x=11.96 //y=7.58 //x2=8.82 //y2=7.09
cc_931 ( N_VDD_c_1176_n N_noxref_7_c_1570_n ) capacitor c=0.00215296f \
 //x=11.96 //y=7.58 //x2=9.7 //y2=6.92
cc_932 ( N_VDD_c_1138_n N_noxref_7_c_1570_n ) capacitor c=4.60826e-19 \
 //x=10.31 //y=7.585 //x2=9.7 //y2=6.92
cc_933 ( N_VDD_c_1171_n N_noxref_7_c_1570_n ) capacitor c=0.0114263f //x=10.48 \
 //y=7.585 //x2=9.7 //y2=6.92
cc_934 ( N_VDD_c_1202_n N_noxref_7_c_1570_n ) capacitor c=0.00112732f \
 //x=11.96 //y=7.58 //x2=9.7 //y2=6.92
cc_935 ( N_VDD_c_1120_n N_noxref_7_c_1533_n ) capacitor c=0.00475693f //x=6.98 \
 //y=7.585 //x2=5.04 //y2=5.56
cc_936 ( N_VDD_c_1123_n N_noxref_7_c_1533_n ) capacitor c=0.00539528f //x=3.82 \
 //y=7.585 //x2=5.04 //y2=5.56
cc_937 ( N_VDD_c_1129_n N_noxref_7_c_1533_n ) capacitor c=0.00106566f //x=7.15 \
 //y=7.585 //x2=5.04 //y2=5.56
cc_938 ( N_VDD_c_1202_n N_noxref_7_c_1533_n ) capacitor c=2.32853e-19 \
 //x=11.96 //y=7.58 //x2=5.04 //y2=5.56
cc_939 ( N_VDD_c_1176_n N_noxref_7_c_1558_n ) capacitor c=0.00204931f \
 //x=11.96 //y=7.58 //x2=7.94 //y2=5.39
cc_940 ( N_VDD_c_1138_n N_noxref_7_c_1558_n ) capacitor c=0.00853641f \
 //x=10.31 //y=7.585 //x2=7.94 //y2=5.39
cc_941 ( N_VDD_c_1129_n N_noxref_7_c_1558_n ) capacitor c=0.0592438f //x=7.15 \
 //y=7.585 //x2=7.94 //y2=5.39
cc_942 ( N_VDD_c_1171_n N_noxref_7_c_1558_n ) capacitor c=0.00100394f \
 //x=10.48 //y=7.585 //x2=7.94 //y2=5.39
cc_943 ( N_VDD_c_1202_n N_noxref_7_c_1558_n ) capacitor c=0.00100974f \
 //x=11.96 //y=7.58 //x2=7.94 //y2=5.39
cc_944 ( N_VDD_c_1176_n N_noxref_7_M16_noxref_d ) capacitor c=0.00206569f \
 //x=11.96 //y=7.58 //x2=8.675 //y2=5.205
cc_945 ( N_VDD_c_1138_n N_noxref_7_M16_noxref_d ) capacitor c=0.00856914f \
 //x=10.31 //y=7.585 //x2=8.675 //y2=5.205
cc_946 ( N_VDD_c_1202_n N_noxref_7_M16_noxref_d ) capacitor c=0.00100487f \
 //x=11.96 //y=7.58 //x2=8.675 //y2=5.205
cc_947 ( N_VDD_c_1176_n N_noxref_7_M18_noxref_d ) capacitor c=0.00206569f \
 //x=11.96 //y=7.58 //x2=9.555 //y2=5.205
cc_948 ( N_VDD_c_1138_n N_noxref_7_M18_noxref_d ) capacitor c=0.00856914f \
 //x=10.31 //y=7.585 //x2=9.555 //y2=5.205
cc_949 ( N_VDD_c_1171_n N_noxref_7_M18_noxref_d ) capacitor c=0.0443649f \
 //x=10.48 //y=7.585 //x2=9.555 //y2=5.205
cc_950 ( N_VDD_c_1202_n N_noxref_7_M18_noxref_d ) capacitor c=0.00100487f \
 //x=11.96 //y=7.58 //x2=9.555 //y2=5.205
cc_951 ( N_VDD_M19_noxref_s N_noxref_7_M18_noxref_d ) capacitor c=0.00249451f \
 //x=11.02 //y=5.2 //x2=9.555 //y2=5.205
cc_952 ( N_VDD_c_1115_n N_GND_c_1682_n ) capacitor c=0.00989514f //x=1.23 \
 //y=7.58 //x2=1.23 //y2=0.18
cc_953 ( N_VDD_c_1123_n N_GND_c_1689_n ) capacitor c=0.00655202f //x=3.82 \
 //y=7.585 //x2=3.82 //y2=0.175
cc_954 ( N_VDD_c_1129_n N_GND_c_1720_n ) capacitor c=0.00684375f //x=7.15 \
 //y=7.585 //x2=7.15 //y2=0.175
cc_955 ( N_VDD_c_1171_n N_GND_c_1730_n ) capacitor c=0.00655202f //x=10.48 \
 //y=7.585 //x2=10.48 //y2=0.175
cc_956 ( N_VDD_c_1202_n N_GND_c_1802_n ) capacitor c=0.00989514f //x=11.96 \
 //y=7.58 //x2=12.08 //y2=0.175
cc_957 ( N_VDD_c_1202_n Y ) capacitor c=0.0293824f //x=11.96 //y=7.58 \
 //x2=11.96 //y2=2.405
cc_958 ( N_VDD_c_1176_n N_Y_c_1943_n ) capacitor c=0.00259721f //x=11.96 \
 //y=7.58 //x2=11.595 //y2=5.42
cc_959 ( N_VDD_c_1185_n N_Y_c_1943_n ) capacitor c=0.00100699f //x=11.95 \
 //y=7.585 //x2=11.595 //y2=5.42
cc_960 ( N_VDD_c_1202_n N_Y_c_1943_n ) capacitor c=0.00295945f //x=11.96 \
 //y=7.58 //x2=11.595 //y2=5.42
cc_961 ( N_VDD_M19_noxref_s N_Y_c_1943_n ) capacitor c=0.0465774f //x=11.02 \
 //y=5.2 //x2=11.595 //y2=5.42
cc_962 ( N_VDD_M20_noxref_d N_Y_c_1943_n ) capacitor c=0.0486749f //x=11.89 \
 //y=5.2 //x2=11.595 //y2=5.42
cc_963 ( N_VDD_c_1176_n N_Y_c_1950_n ) capacitor c=0.00199795f //x=11.96 \
 //y=7.58 //x2=11.875 //y2=5.14
cc_964 ( N_VDD_c_1185_n N_Y_c_1950_n ) capacitor c=0.00207379f //x=11.95 \
 //y=7.585 //x2=11.875 //y2=5.14
cc_965 ( N_VDD_M20_noxref_d N_Y_c_1950_n ) capacitor c=0.0235609f //x=11.89 \
 //y=5.2 //x2=11.875 //y2=5.14
cc_966 ( N_VDD_c_1171_n N_Y_c_1951_n ) capacitor c=0.00484013f //x=10.48 \
 //y=7.585 //x2=11.68 //y2=5.14
cc_967 ( N_VDD_c_1176_n N_Y_c_1962_n ) capacitor c=0.00241566f //x=11.96 \
 //y=7.58 //x2=11.595 //y2=5.56
cc_968 ( N_VDD_c_1185_n N_Y_c_1962_n ) capacitor c=0.0138017f //x=11.95 \
 //y=7.585 //x2=11.595 //y2=5.56
cc_969 ( N_VDD_c_1171_n N_Y_c_1962_n ) capacitor c=0.00819514f //x=10.48 \
 //y=7.585 //x2=11.595 //y2=5.56
cc_970 ( N_VDD_c_1202_n N_Y_c_1962_n ) capacitor c=0.00960934f //x=11.96 \
 //y=7.58 //x2=11.595 //y2=5.56
cc_971 ( N_VDD_M19_noxref_s N_Y_c_1962_n ) capacitor c=0.0897898f //x=11.02 \
 //y=5.2 //x2=11.595 //y2=5.56
cc_972 ( N_VDD_M20_noxref_d N_Y_c_1962_n ) capacitor c=0.0929254f //x=11.89 \
 //y=5.2 //x2=11.595 //y2=5.56
cc_973 ( N_VDD_c_1120_n noxref_11 ) capacitor c=0.0048583f //x=6.98 //y=7.585 \
 //x2=5.775 //y2=5.205
cc_974 ( N_VDD_c_1129_n noxref_11 ) capacitor c=0.00487712f //x=7.15 //y=7.585 \
 //x2=5.775 //y2=5.205
cc_975 ( N_VDD_c_1202_n noxref_11 ) capacitor c=2.31538e-19 //x=11.96 //y=7.58 \
 //x2=5.775 //y2=5.205
cc_976 ( N_noxref_6_c_1366_n N_noxref_7_c_1526_n ) capacitor c=0.00321697f \
 //x=5.36 //y=7.09 //x2=5.805 //y2=5.39
cc_977 ( N_noxref_6_c_1388_n N_noxref_7_c_1526_n ) capacitor c=0.00331901f \
 //x=6.245 //y=7.09 //x2=5.805 //y2=5.39
cc_978 ( N_noxref_6_c_1377_n N_noxref_7_c_1526_n ) capacitor c=0.0047685f \
 //x=5.477 //y=7.09 //x2=5.805 //y2=5.39
cc_979 ( N_noxref_6_M12_noxref_d N_noxref_7_c_1526_n ) capacitor c=0.00678641f \
 //x=5.335 //y=5.205 //x2=5.805 //y2=5.39
cc_980 ( N_noxref_6_c_1388_n N_noxref_7_c_1539_n ) capacitor c=0.00331901f \
 //x=6.245 //y=7.09 //x2=7.825 //y2=5.39
cc_981 ( N_noxref_6_c_1391_n N_noxref_7_c_1539_n ) capacitor c=0.00466077f \
 //x=6.36 //y=6.92 //x2=7.825 //y2=5.39
cc_982 ( N_noxref_6_M14_noxref_d N_noxref_7_c_1539_n ) capacitor c=0.00491419f \
 //x=6.215 //y=5.205 //x2=7.825 //y2=5.39
cc_983 ( N_noxref_6_c_1362_n N_noxref_7_c_1549_n ) capacitor c=9.81e-19 \
 //x=4.485 //y=5.39 //x2=6.035 //y2=5.39
cc_984 ( N_noxref_6_c_1388_n N_noxref_7_c_1549_n ) capacitor c=0.00439275f \
 //x=6.245 //y=7.09 //x2=6.035 //y2=5.39
cc_985 ( N_noxref_6_c_1362_n N_noxref_7_c_1527_n ) capacitor c=0.033638f \
 //x=4.485 //y=5.39 //x2=5.04 //y2=5.39
cc_986 ( N_noxref_6_c_1366_n N_noxref_7_c_1527_n ) capacitor c=0.0048075f \
 //x=5.36 //y=7.09 //x2=5.04 //y2=5.39
cc_987 ( N_noxref_6_c_1372_n N_noxref_7_c_1527_n ) capacitor c=0.00241473f \
 //x=1.722 //y=5.39 //x2=5.04 //y2=5.39
cc_988 ( N_noxref_6_c_1382_n N_noxref_7_c_1527_n ) capacitor c=0.0100239f \
 //x=4.6 //y=5.39 //x2=5.04 //y2=5.39
cc_989 ( N_noxref_6_c_1362_n N_noxref_7_c_1553_n ) capacitor c=5.61108e-19 \
 //x=4.485 //y=5.39 //x2=5.92 //y2=5.39
cc_990 ( N_noxref_6_c_1382_n N_noxref_7_c_1553_n ) capacitor c=0.00225426f \
 //x=4.6 //y=5.39 //x2=5.92 //y2=5.39
cc_991 ( N_noxref_6_c_1377_n N_noxref_7_c_1556_n ) capacitor c=2.01993e-19 \
 //x=5.477 //y=7.09 //x2=7.94 //y2=6.92
cc_992 ( N_noxref_6_c_1391_n N_noxref_7_c_1556_n ) capacitor c=0.0130503f \
 //x=6.36 //y=6.92 //x2=7.94 //y2=6.92
cc_993 ( N_noxref_6_c_1391_n N_noxref_7_c_1557_n ) capacitor c=2.01769e-19 \
 //x=6.36 //y=6.92 //x2=8.82 //y2=7.09
cc_994 ( N_noxref_6_c_1362_n N_noxref_7_c_1533_n ) capacitor c=0.00238961f \
 //x=4.485 //y=5.39 //x2=5.04 //y2=5.56
cc_995 ( N_noxref_6_c_1366_n N_noxref_7_c_1533_n ) capacitor c=0.00406191f \
 //x=5.36 //y=7.09 //x2=5.04 //y2=5.56
cc_996 ( N_noxref_6_c_1382_n N_noxref_7_c_1533_n ) capacitor c=0.0651197f \
 //x=4.6 //y=5.39 //x2=5.04 //y2=5.56
cc_997 ( N_noxref_6_M12_noxref_d N_noxref_7_c_1533_n ) capacitor c=0.0479141f \
 //x=5.335 //y=5.205 //x2=5.04 //y2=5.56
cc_998 ( N_noxref_6_M14_noxref_d N_noxref_7_c_1558_n ) capacitor c=0.00143256f \
 //x=6.215 //y=5.205 //x2=7.94 //y2=5.39
cc_999 ( N_noxref_6_c_1372_n N_GND_c_1665_n ) capacitor c=0.00133245f \
 //x=1.722 //y=5.39 //x2=1.67 //y2=1.015
cc_1000 ( N_noxref_6_c_1362_n N_GND_c_1689_n ) capacitor c=0.00146427f \
 //x=4.485 //y=5.39 //x2=3.82 //y2=0.175
cc_1001 ( N_noxref_6_c_1388_n noxref_11 ) capacitor c=0.00419873f //x=6.245 \
 //y=7.09 //x2=5.775 //y2=5.205
cc_1002 ( N_noxref_6_M12_noxref_d noxref_11 ) capacitor c=0.0489565f //x=5.335 \
 //y=5.205 //x2=5.775 //y2=5.205
cc_1003 ( N_noxref_6_M14_noxref_d noxref_11 ) capacitor c=0.0489382f //x=6.215 \
 //y=5.205 //x2=5.775 //y2=5.205
cc_1004 ( N_noxref_6_c_1382_n N_noxref_12_c_2079_n ) capacitor c=0.00112302f \
 //x=4.6 //y=5.39 //x2=4.515 //y2=1.675
cc_1005 ( N_noxref_7_c_1527_n N_GND_c_1672_n ) capacitor c=2.10485e-19 \
 //x=5.04 //y=5.39 //x2=5 //y2=1.015
cc_1006 ( N_noxref_7_c_1539_n N_GND_c_1720_n ) capacitor c=0.00146427f \
 //x=7.825 //y=5.39 //x2=7.15 //y2=0.175
cc_1007 ( N_noxref_7_c_1553_n noxref_11 ) capacitor c=0.0218948f //x=5.92 \
 //y=5.39 //x2=5.775 //y2=5.205
cc_1008 ( N_noxref_7_c_1533_n noxref_11 ) capacitor c=0.00561178f //x=5.04 \
 //y=5.56 //x2=5.775 //y2=5.205
cc_1009 ( N_GND_c_1730_n N_Y_c_1934_n ) capacitor c=0.00272952f //x=10.48 \
 //y=0.175 //x2=11.59 //y2=1.935
cc_1010 ( N_GND_c_1802_n N_Y_c_1934_n ) capacitor c=0.00122336f //x=12.08 \
 //y=0.175 //x2=11.59 //y2=1.935
cc_1011 ( N_GND_M6_noxref_s N_Y_c_1934_n ) capacitor c=0.0325498f //x=10.975 \
 //y=0.55 //x2=11.59 //y2=1.935
cc_1012 ( N_GND_c_1738_n N_Y_c_1947_n ) capacitor c=0.00497604f //x=11.96 \
 //y=0.18 //x2=11.875 //y2=2.02
cc_1013 ( N_GND_c_1787_n N_Y_c_1947_n ) capacitor c=0.00321695f //x=11.995 \
 //y=0.715 //x2=11.875 //y2=2.02
cc_1014 ( N_GND_c_1802_n N_Y_c_1947_n ) capacitor c=0.030726f //x=12.08 \
 //y=0.175 //x2=11.875 //y2=2.02
cc_1015 ( N_GND_M6_noxref_s N_Y_c_1947_n ) capacitor c=0.00565821f //x=10.975 \
 //y=0.55 //x2=11.875 //y2=2.02
cc_1016 ( N_GND_c_1709_n N_Y_c_1954_n ) capacitor c=0.00306788f //x=8.33 \
 //y=1.02 //x2=11.59 //y2=1.185
cc_1017 ( N_GND_c_1738_n N_Y_c_1954_n ) capacitor c=0.00998676f //x=11.96 \
 //y=0.18 //x2=11.59 //y2=1.185
cc_1018 ( N_GND_c_1783_n N_Y_c_1954_n ) capacitor c=0.00124813f //x=11.505 \
 //y=0.715 //x2=11.59 //y2=1.185
cc_1019 ( N_GND_c_1787_n N_Y_c_1954_n ) capacitor c=0.00130539f //x=11.995 \
 //y=0.715 //x2=11.59 //y2=1.185
cc_1020 ( N_GND_c_1802_n N_Y_c_1954_n ) capacitor c=2.8029e-19 //x=12.08 \
 //y=0.175 //x2=11.59 //y2=1.185
cc_1021 ( N_GND_M6_noxref_s N_Y_c_1954_n ) capacitor c=0.0161656f //x=10.975 \
 //y=0.55 //x2=11.59 //y2=1.185
cc_1022 ( N_GND_c_1738_n N_Y_M6_noxref_d ) capacitor c=0.00119455f //x=11.96 \
 //y=0.18 //x2=11.405 //y2=1.09
cc_1023 ( N_GND_c_1802_n N_Y_M6_noxref_d ) capacitor c=2.70835e-19 //x=12.08 \
 //y=0.175 //x2=11.405 //y2=1.09
cc_1024 ( N_GND_M6_noxref_s N_Y_M6_noxref_d ) capacitor c=0.0377642f \
 //x=10.975 //y=0.55 //x2=11.405 //y2=1.09
cc_1025 ( N_GND_c_1663_n N_noxref_10_c_2007_n ) capacitor c=0.00260651f \
 //x=1.585 //y=0.175 //x2=2.07 //y2=1.76
cc_1026 ( N_GND_c_1665_n N_noxref_10_c_2007_n ) capacitor c=0.0049241f \
 //x=1.67 //y=1.015 //x2=2.07 //y2=1.76
cc_1027 ( N_GND_c_1737_n N_noxref_10_c_2007_n ) capacitor c=7.74325e-19 \
 //x=4.915 //y=0.175 //x2=2.07 //y2=1.76
cc_1028 ( N_GND_c_1681_n N_noxref_10_c_2007_n ) capacitor c=0.0040842f \
 //x=3.65 //y=0.175 //x2=2.07 //y2=1.76
cc_1029 ( N_GND_M0_noxref_d N_noxref_10_c_2007_n ) capacitor c=0.00579662f \
 //x=1.48 //y=1.045 //x2=2.07 //y2=1.76
cc_1030 ( N_GND_c_1665_n N_noxref_10_c_2045_n ) capacitor c=0.0120153f \
 //x=1.67 //y=1.015 //x2=2.155 //y2=0.795
cc_1031 ( N_GND_c_1737_n N_noxref_10_c_2045_n ) capacitor c=0.00645839f \
 //x=4.915 //y=0.175 //x2=2.155 //y2=0.795
cc_1032 ( N_GND_c_1681_n N_noxref_10_c_2045_n ) capacitor c=0.0146613f \
 //x=3.65 //y=0.175 //x2=2.155 //y2=0.795
cc_1033 ( N_GND_c_1682_n N_noxref_10_c_2045_n ) capacitor c=0.00283732f \
 //x=1.23 //y=0.18 //x2=2.155 //y2=0.795
cc_1034 ( N_GND_c_1689_n N_noxref_10_c_2045_n ) capacitor c=2.99356e-19 \
 //x=3.82 //y=0.175 //x2=2.155 //y2=0.795
cc_1035 ( N_GND_c_1802_n N_noxref_10_c_2045_n ) capacitor c=0.00145873f \
 //x=12.08 //y=0.175 //x2=2.155 //y2=0.795
cc_1036 ( N_GND_c_1682_n N_noxref_10_c_2015_n ) capacitor c=2.91423e-19 \
 //x=1.23 //y=0.18 //x2=2.155 //y2=1.675
cc_1037 ( N_GND_c_1737_n N_noxref_10_c_2023_n ) capacitor c=0.0109835f \
 //x=4.915 //y=0.175 //x2=3.04 //y2=0.71
cc_1038 ( N_GND_c_1681_n N_noxref_10_c_2023_n ) capacitor c=0.0375489f \
 //x=3.65 //y=0.175 //x2=3.04 //y2=0.71
cc_1039 ( N_GND_c_1802_n N_noxref_10_c_2023_n ) capacitor c=0.00199095f \
 //x=12.08 //y=0.175 //x2=3.04 //y2=0.71
cc_1040 ( N_GND_c_1737_n N_noxref_10_c_2055_n ) capacitor c=0.0045077f \
 //x=4.915 //y=0.175 //x2=3.125 //y2=0.795
cc_1041 ( N_GND_c_1681_n N_noxref_10_c_2055_n ) capacitor c=0.0144994f \
 //x=3.65 //y=0.175 //x2=3.125 //y2=0.795
cc_1042 ( N_GND_c_1689_n N_noxref_10_c_2055_n ) capacitor c=0.0540895f \
 //x=3.82 //y=0.175 //x2=3.125 //y2=0.795
cc_1043 ( N_GND_c_1802_n N_noxref_10_c_2055_n ) capacitor c=0.00145873f \
 //x=12.08 //y=0.175 //x2=3.125 //y2=0.795
cc_1044 ( N_GND_c_1663_n N_noxref_10_M0_noxref_s ) capacitor c=0.00282008f \
 //x=1.585 //y=0.175 //x2=1.05 //y2=0.545
cc_1045 ( N_GND_c_1665_n N_noxref_10_M0_noxref_s ) capacitor c=0.0302994f \
 //x=1.67 //y=1.015 //x2=1.05 //y2=0.545
cc_1046 ( N_GND_c_1681_n N_noxref_10_M0_noxref_s ) capacitor c=0.014658f \
 //x=3.65 //y=0.175 //x2=1.05 //y2=0.545
cc_1047 ( N_GND_c_1682_n N_noxref_10_M0_noxref_s ) capacitor c=0.0568002f \
 //x=1.23 //y=0.18 //x2=1.05 //y2=0.545
cc_1048 ( N_GND_c_1689_n N_noxref_10_M0_noxref_s ) capacitor c=0.00250794f \
 //x=3.82 //y=0.175 //x2=1.05 //y2=0.545
cc_1049 ( N_GND_c_1802_n N_noxref_10_M0_noxref_s ) capacitor c=0.00145873f \
 //x=12.08 //y=0.175 //x2=1.05 //y2=0.545
cc_1050 ( N_GND_M0_noxref_d N_noxref_10_M0_noxref_s ) capacitor c=0.0271433f \
 //x=1.48 //y=1.045 //x2=1.05 //y2=0.545
cc_1051 ( N_GND_c_1737_n N_noxref_12_c_2080_n ) capacitor c=0.0010065f \
 //x=4.915 //y=0.175 //x2=5.4 //y2=1.76
cc_1052 ( N_GND_c_1672_n N_noxref_12_c_2080_n ) capacitor c=0.00375883f //x=5 \
 //y=1.015 //x2=5.4 //y2=1.76
cc_1053 ( N_GND_c_1706_n N_noxref_12_c_2080_n ) capacitor c=7.45647e-19 \
 //x=8.245 //y=0.175 //x2=5.4 //y2=1.76
cc_1054 ( N_GND_c_1688_n N_noxref_12_c_2080_n ) capacitor c=0.00358266f \
 //x=6.98 //y=0.175 //x2=5.4 //y2=1.76
cc_1055 ( N_GND_M2_noxref_d N_noxref_12_c_2080_n ) capacitor c=0.00750663f \
 //x=4.81 //y=1.045 //x2=5.4 //y2=1.76
cc_1056 ( N_GND_c_1672_n N_noxref_12_c_2120_n ) capacitor c=0.0120153f //x=5 \
 //y=1.015 //x2=5.485 //y2=0.795
cc_1057 ( N_GND_c_1706_n N_noxref_12_c_2120_n ) capacitor c=0.0045077f \
 //x=8.245 //y=0.175 //x2=5.485 //y2=0.795
cc_1058 ( N_GND_c_1688_n N_noxref_12_c_2120_n ) capacitor c=0.0144994f \
 //x=6.98 //y=0.175 //x2=5.485 //y2=0.795
cc_1059 ( N_GND_c_1689_n N_noxref_12_c_2120_n ) capacitor c=0.00226009f \
 //x=3.82 //y=0.175 //x2=5.485 //y2=0.795
cc_1060 ( N_GND_c_1720_n N_noxref_12_c_2120_n ) capacitor c=2.99356e-19 \
 //x=7.15 //y=0.175 //x2=5.485 //y2=0.795
cc_1061 ( N_GND_c_1802_n N_noxref_12_c_2120_n ) capacitor c=0.00145873f \
 //x=12.08 //y=0.175 //x2=5.485 //y2=0.795
cc_1062 ( N_GND_c_1689_n N_noxref_12_c_2087_n ) capacitor c=2.91423e-19 \
 //x=3.82 //y=0.175 //x2=5.485 //y2=1.675
cc_1063 ( N_GND_c_1706_n N_noxref_12_c_2092_n ) capacitor c=0.0122738f \
 //x=8.245 //y=0.175 //x2=6.37 //y2=0.71
cc_1064 ( N_GND_c_1688_n N_noxref_12_c_2092_n ) capacitor c=0.0374965f \
 //x=6.98 //y=0.175 //x2=6.37 //y2=0.71
cc_1065 ( N_GND_c_1802_n N_noxref_12_c_2092_n ) capacitor c=0.00199095f \
 //x=12.08 //y=0.175 //x2=6.37 //y2=0.71
cc_1066 ( N_GND_c_1706_n N_noxref_12_c_2130_n ) capacitor c=0.00251499f \
 //x=8.245 //y=0.175 //x2=6.455 //y2=0.795
cc_1067 ( N_GND_c_1688_n N_noxref_12_c_2130_n ) capacitor c=0.0144994f \
 //x=6.98 //y=0.175 //x2=6.455 //y2=0.795
cc_1068 ( N_GND_c_1720_n N_noxref_12_c_2130_n ) capacitor c=0.0528155f \
 //x=7.15 //y=0.175 //x2=6.455 //y2=0.795
cc_1069 ( N_GND_c_1802_n N_noxref_12_c_2130_n ) capacitor c=0.00145873f \
 //x=12.08 //y=0.175 //x2=6.455 //y2=0.795
cc_1070 ( N_GND_c_1737_n N_noxref_12_M2_noxref_s ) capacitor c=0.0045077f \
 //x=4.915 //y=0.175 //x2=4.38 //y2=0.545
cc_1071 ( N_GND_c_1672_n N_noxref_12_M2_noxref_s ) capacitor c=0.0251079f \
 //x=5 //y=1.015 //x2=4.38 //y2=0.545
cc_1072 ( N_GND_c_1688_n N_noxref_12_M2_noxref_s ) capacitor c=0.0144994f \
 //x=6.98 //y=0.175 //x2=4.38 //y2=0.545
cc_1073 ( N_GND_c_1689_n N_noxref_12_M2_noxref_s ) capacitor c=0.0536459f \
 //x=3.82 //y=0.175 //x2=4.38 //y2=0.545
cc_1074 ( N_GND_c_1720_n N_noxref_12_M2_noxref_s ) capacitor c=0.00291802f \
 //x=7.15 //y=0.175 //x2=4.38 //y2=0.545
cc_1075 ( N_GND_c_1802_n N_noxref_12_M2_noxref_s ) capacitor c=0.00145873f \
 //x=12.08 //y=0.175 //x2=4.38 //y2=0.545
cc_1076 ( N_GND_M2_noxref_d N_noxref_12_M2_noxref_s ) capacitor c=0.0296569f \
 //x=4.81 //y=1.045 //x2=4.38 //y2=0.545
cc_1077 ( N_GND_c_1706_n N_noxref_13_c_2149_n ) capacitor c=9.5216e-19 \
 //x=8.245 //y=0.175 //x2=8.73 //y2=1.76
cc_1078 ( N_GND_c_1709_n N_noxref_13_c_2149_n ) capacitor c=0.0048201f \
 //x=8.33 //y=1.02 //x2=8.73 //y2=1.76
cc_1079 ( N_GND_c_1738_n N_noxref_13_c_2149_n ) capacitor c=0.00204479f \
 //x=11.96 //y=0.18 //x2=8.73 //y2=1.76
cc_1080 ( N_GND_c_1717_n N_noxref_13_c_2149_n ) capacitor c=0.00357558f \
 //x=10.31 //y=0.175 //x2=8.73 //y2=1.76
cc_1081 ( N_GND_M4_noxref_d N_noxref_13_c_2149_n ) capacitor c=0.00579662f \
 //x=8.14 //y=1.045 //x2=8.73 //y2=1.76
cc_1082 ( N_GND_c_1709_n N_noxref_13_c_2193_n ) capacitor c=0.0167642f \
 //x=8.33 //y=1.02 //x2=8.815 //y2=0.795
cc_1083 ( N_GND_c_1738_n N_noxref_13_c_2193_n ) capacitor c=0.00310354f \
 //x=11.96 //y=0.18 //x2=8.815 //y2=0.795
cc_1084 ( N_GND_c_1717_n N_noxref_13_c_2193_n ) capacitor c=0.0144994f \
 //x=10.31 //y=0.175 //x2=8.815 //y2=0.795
cc_1085 ( N_GND_c_1720_n N_noxref_13_c_2193_n ) capacitor c=0.00225073f \
 //x=7.15 //y=0.175 //x2=8.815 //y2=0.795
cc_1086 ( N_GND_c_1730_n N_noxref_13_c_2193_n ) capacitor c=2.21767e-19 \
 //x=10.48 //y=0.175 //x2=8.815 //y2=0.795
cc_1087 ( N_GND_c_1802_n N_noxref_13_c_2193_n ) capacitor c=0.00145873f \
 //x=12.08 //y=0.175 //x2=8.815 //y2=0.795
cc_1088 ( N_GND_c_1720_n N_noxref_13_c_2156_n ) capacitor c=2.86225e-19 \
 //x=7.15 //y=0.175 //x2=8.815 //y2=1.675
cc_1089 ( N_GND_c_1738_n N_noxref_13_c_2165_n ) capacitor c=0.00939457f \
 //x=11.96 //y=0.18 //x2=9.7 //y2=0.71
cc_1090 ( N_GND_c_1717_n N_noxref_13_c_2165_n ) capacitor c=0.0375173f \
 //x=10.31 //y=0.175 //x2=9.7 //y2=0.71
cc_1091 ( N_GND_c_1802_n N_noxref_13_c_2165_n ) capacitor c=0.00199095f \
 //x=12.08 //y=0.175 //x2=9.7 //y2=0.71
cc_1092 ( N_GND_c_1738_n N_noxref_13_c_2203_n ) capacitor c=0.00326972f \
 //x=11.96 //y=0.18 //x2=9.785 //y2=0.795
cc_1093 ( N_GND_c_1717_n N_noxref_13_c_2203_n ) capacitor c=0.0144881f \
 //x=10.31 //y=0.175 //x2=9.785 //y2=0.795
cc_1094 ( N_GND_c_1910_p N_noxref_13_c_2203_n ) capacitor c=0.00211385f \
 //x=11.11 //y=0.63 //x2=9.785 //y2=0.795
cc_1095 ( N_GND_c_1730_n N_noxref_13_c_2203_n ) capacitor c=0.0406122f \
 //x=10.48 //y=0.175 //x2=9.785 //y2=0.795
cc_1096 ( N_GND_c_1802_n N_noxref_13_c_2203_n ) capacitor c=0.00145029f \
 //x=12.08 //y=0.175 //x2=9.785 //y2=0.795
cc_1097 ( N_GND_c_1706_n N_noxref_13_M4_noxref_s ) capacitor c=0.00251499f \
 //x=8.245 //y=0.175 //x2=7.71 //y2=0.545
cc_1098 ( N_GND_c_1709_n N_noxref_13_M4_noxref_s ) capacitor c=0.0250671f \
 //x=8.33 //y=1.02 //x2=7.71 //y2=0.545
cc_1099 ( N_GND_c_1717_n N_noxref_13_M4_noxref_s ) capacitor c=0.0144994f \
 //x=10.31 //y=0.175 //x2=7.71 //y2=0.545
cc_1100 ( N_GND_c_1720_n N_noxref_13_M4_noxref_s ) capacitor c=0.0528929f \
 //x=7.15 //y=0.175 //x2=7.71 //y2=0.545
cc_1101 ( N_GND_c_1730_n N_noxref_13_M4_noxref_s ) capacitor c=0.00580588f \
 //x=10.48 //y=0.175 //x2=7.71 //y2=0.545
cc_1102 ( N_GND_c_1802_n N_noxref_13_M4_noxref_s ) capacitor c=0.00145873f \
 //x=12.08 //y=0.175 //x2=7.71 //y2=0.545
cc_1103 ( N_GND_M4_noxref_d N_noxref_13_M4_noxref_s ) capacitor c=0.0272383f \
 //x=8.14 //y=1.045 //x2=7.71 //y2=0.545
cc_1104 ( N_GND_M6_noxref_s N_noxref_13_M4_noxref_s ) capacitor c=0.00317066f \
 //x=10.975 //y=0.55 //x2=7.71 //y2=0.545
cc_1105 ( N_noxref_10_M0_noxref_s N_noxref_12_c_2079_n ) capacitor \
 c=0.00220044f //x=1.05 //y=0.545 //x2=4.515 //y2=1.675
cc_1106 ( N_noxref_10_c_2055_n N_noxref_12_M2_noxref_s ) capacitor \
 c=0.00220044f //x=3.125 //y=0.795 //x2=4.38 //y2=0.545
cc_1107 ( N_noxref_12_M2_noxref_s N_noxref_13_c_2145_n ) capacitor \
 c=0.00244935f //x=4.38 //y=0.545 //x2=7.845 //y2=1.675
cc_1108 ( N_noxref_12_c_2130_n N_noxref_13_M4_noxref_s ) capacitor \
 c=0.00244935f //x=6.455 //y=0.795 //x2=7.71 //y2=0.545
