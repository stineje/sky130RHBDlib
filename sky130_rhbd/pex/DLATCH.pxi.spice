// File: DLATCH.spi.DLATCH.pxi
// Created: Tue Apr 29 10:41:54 2025
//
simulator lang=spectre
x_PM_DLATCH\%GND ( GND N_GND_c_9_p N_GND_c_29_p N_GND_c_91_p N_GND_c_250_p \
 N_GND_c_19_p N_GND_c_25_p N_GND_c_57_p N_GND_c_247_p N_GND_c_37_p \
 N_GND_c_45_p N_GND_c_273_p N_GND_c_59_p N_GND_c_60_p N_GND_c_74_p \
 N_GND_c_99_p N_GND_c_270_p N_GND_c_100_p N_GND_c_116_p N_GND_c_128_p \
 N_GND_c_144_p N_GND_c_163_p N_GND_c_166_p N_GND_c_153_p N_GND_c_154_p \
 N_GND_c_155_p N_GND_c_178_p N_GND_c_195_p N_GND_c_199_p N_GND_c_2_p \
 N_GND_c_3_p N_GND_c_4_p N_GND_c_5_p N_GND_c_6_p N_GND_c_7_p N_GND_c_8_p \
 N_GND_c_1_p N_GND_M0_noxref_s N_GND_M1_noxref_d N_GND_M3_noxref_s \
 N_GND_M4_noxref_d N_GND_M6_noxref_s N_GND_M7_noxref_s N_GND_M9_noxref_s )  \
 PM_DLATCH\%GND
x_PM_DLATCH\%VDD ( VDD N_VDD_c_288_p N_VDD_c_289_p N_VDD_c_358_p N_VDD_c_359_p \
 N_VDD_c_295_p N_VDD_c_309_p N_VDD_c_361_p N_VDD_c_362_p N_VDD_c_322_p \
 N_VDD_c_364_p N_VDD_c_365_p N_VDD_c_344_p N_VDD_c_390_p N_VDD_c_413_p \
 N_VDD_c_476_p N_VDD_c_447_p N_VDD_c_450_p N_VDD_c_467_p N_VDD_c_279_n \
 N_VDD_c_280_n N_VDD_c_281_n N_VDD_c_282_n N_VDD_c_283_n N_VDD_c_284_n \
 N_VDD_c_285_n N_VDD_c_286_n N_VDD_M11_noxref_s N_VDD_M12_noxref_d \
 N_VDD_M13_noxref_s N_VDD_M14_noxref_d N_VDD_M16_noxref_d N_VDD_M17_noxref_s \
 N_VDD_M18_noxref_d N_VDD_M19_noxref_s N_VDD_M20_noxref_d N_VDD_M22_noxref_d \
 N_VDD_M23_noxref_s N_VDD_M24_noxref_d N_VDD_M25_noxref_d N_VDD_M29_noxref_d ) \
 PM_DLATCH\%VDD
x_PM_DLATCH\%noxref_3 ( N_noxref_3_c_546_n N_noxref_3_c_549_n \
 N_noxref_3_c_551_n N_noxref_3_c_622_p N_noxref_3_c_571_n N_noxref_3_c_574_n \
 N_noxref_3_c_554_n N_noxref_3_c_555_n N_noxref_3_M1_noxref_g \
 N_noxref_3_M13_noxref_g N_noxref_3_M14_noxref_g N_noxref_3_c_556_n \
 N_noxref_3_c_558_n N_noxref_3_c_609_p N_noxref_3_c_559_n N_noxref_3_c_560_n \
 N_noxref_3_c_561_n N_noxref_3_c_562_n N_noxref_3_c_564_n N_noxref_3_c_584_n \
 N_noxref_3_M0_noxref_d N_noxref_3_M11_noxref_d )  PM_DLATCH\%noxref_3
x_PM_DLATCH\%noxref_4 ( N_noxref_4_c_725_p N_noxref_4_c_726_p \
 N_noxref_4_c_685_n N_noxref_4_c_689_n N_noxref_4_c_691_n N_noxref_4_c_663_n \
 N_noxref_4_c_727_p N_noxref_4_c_665_n N_noxref_4_c_666_n N_noxref_4_c_746_p \
 N_noxref_4_M3_noxref_g N_noxref_4_M17_noxref_g N_noxref_4_M18_noxref_g \
 N_noxref_4_c_671_n N_noxref_4_c_779_p N_noxref_4_c_780_p N_noxref_4_c_673_n \
 N_noxref_4_c_705_n N_noxref_4_c_706_n N_noxref_4_c_674_n N_noxref_4_c_767_p \
 N_noxref_4_c_675_n N_noxref_4_c_677_n N_noxref_4_c_678_n \
 N_noxref_4_M2_noxref_d N_noxref_4_M13_noxref_d N_noxref_4_M15_noxref_d )  \
 PM_DLATCH\%noxref_4
x_PM_DLATCH\%GATE ( N_GATE_c_797_n N_GATE_c_806_n GATE GATE GATE GATE GATE \
 GATE GATE GATE GATE N_GATE_c_835_n N_GATE_c_807_n N_GATE_c_809_n \
 N_GATE_M2_noxref_g N_GATE_M4_noxref_g N_GATE_M15_noxref_g N_GATE_M16_noxref_g \
 N_GATE_M19_noxref_g N_GATE_M20_noxref_g N_GATE_c_844_n N_GATE_c_847_n \
 N_GATE_c_849_n N_GATE_c_878_n N_GATE_c_880_n N_GATE_c_881_n N_GATE_c_852_n \
 N_GATE_c_853_n N_GATE_c_810_n N_GATE_c_812_n N_GATE_c_910_p N_GATE_c_813_n \
 N_GATE_c_814_n N_GATE_c_815_n N_GATE_c_816_n N_GATE_c_818_n N_GATE_c_854_n \
 N_GATE_c_887_n N_GATE_c_856_n N_GATE_c_833_n )  PM_DLATCH\%GATE
x_PM_DLATCH\%D ( N_D_c_958_n N_D_c_959_n D D D D D D D D D D D D D N_D_c_961_n \
 N_D_c_1065_n N_D_c_966_n N_D_M0_noxref_g N_D_M5_noxref_g N_D_M11_noxref_g \
 N_D_M12_noxref_g N_D_M21_noxref_g N_D_M22_noxref_g N_D_c_968_n N_D_c_1036_n \
 N_D_c_1037_n N_D_c_970_n N_D_c_1017_n N_D_c_1018_n N_D_c_971_n N_D_c_1044_n \
 N_D_c_972_n N_D_c_974_n N_D_c_1073_n N_D_c_1076_n N_D_c_1078_n N_D_c_1099_p \
 N_D_c_1108_p N_D_c_1094_p N_D_c_1081_n N_D_c_1082_n N_D_c_975_n N_D_c_1083_n \
 N_D_c_1101_p N_D_c_1085_n )  PM_DLATCH\%D
x_PM_DLATCH\%noxref_7 ( N_noxref_7_c_1135_n N_noxref_7_c_1141_n \
 N_noxref_7_c_1164_n N_noxref_7_c_1168_n N_noxref_7_c_1170_n \
 N_noxref_7_c_1142_n N_noxref_7_c_1236_p N_noxref_7_c_1144_n \
 N_noxref_7_c_1145_n N_noxref_7_c_1222_n N_noxref_7_M6_noxref_g \
 N_noxref_7_M23_noxref_g N_noxref_7_M24_noxref_g N_noxref_7_c_1150_n \
 N_noxref_7_c_1255_p N_noxref_7_c_1256_p N_noxref_7_c_1152_n \
 N_noxref_7_c_1184_n N_noxref_7_c_1185_n N_noxref_7_c_1153_n \
 N_noxref_7_c_1243_p N_noxref_7_c_1154_n N_noxref_7_c_1156_n \
 N_noxref_7_c_1157_n N_noxref_7_M5_noxref_d N_noxref_7_M19_noxref_d \
 N_noxref_7_M21_noxref_d )  PM_DLATCH\%noxref_7
x_PM_DLATCH\%noxref_8 ( N_noxref_8_c_1274_n N_noxref_8_c_1326_n \
 N_noxref_8_c_1280_n N_noxref_8_c_1329_n N_noxref_8_c_1305_n \
 N_noxref_8_c_1308_n N_noxref_8_c_1283_n N_noxref_8_c_1284_n \
 N_noxref_8_c_1312_n N_noxref_8_M7_noxref_g N_noxref_8_M25_noxref_g \
 N_noxref_8_M26_noxref_g N_noxref_8_c_1287_n N_noxref_8_c_1381_p \
 N_noxref_8_c_1382_p N_noxref_8_c_1289_n N_noxref_8_c_1291_n \
 N_noxref_8_c_1385_p N_noxref_8_c_1391_p N_noxref_8_c_1292_n \
 N_noxref_8_c_1294_n N_noxref_8_c_1320_n N_noxref_8_M3_noxref_d \
 N_noxref_8_M17_noxref_d )  PM_DLATCH\%noxref_8
x_PM_DLATCH\%Q ( N_Q_c_1438_n N_Q_c_1444_n Q Q Q Q Q Q Q Q Q Q N_Q_c_1447_n \
 N_Q_c_1494_n N_Q_c_1476_n N_Q_c_1478_n N_Q_c_1451_n N_Q_c_1456_n N_Q_c_1480_n \
 N_Q_M9_noxref_g N_Q_M29_noxref_g N_Q_M30_noxref_g N_Q_c_1459_n N_Q_c_1526_p \
 N_Q_c_1527_p N_Q_c_1461_n N_Q_c_1463_n N_Q_c_1584_p N_Q_c_1512_p N_Q_c_1464_n \
 N_Q_c_1466_n N_Q_c_1488_n N_Q_M7_noxref_d N_Q_M8_noxref_d N_Q_M27_noxref_d )  \
 PM_DLATCH\%Q
x_PM_DLATCH\%noxref_10 ( N_noxref_10_c_1605_n N_noxref_10_c_1631_n \
 N_noxref_10_c_1606_n N_noxref_10_c_1652_n N_noxref_10_c_1634_n \
 N_noxref_10_c_1637_n N_noxref_10_c_1609_n N_noxref_10_c_1695_n \
 N_noxref_10_c_1610_n N_noxref_10_M10_noxref_g N_noxref_10_M31_noxref_g \
 N_noxref_10_M32_noxref_g N_noxref_10_c_1612_n N_noxref_10_c_1707_n \
 N_noxref_10_c_1710_n N_noxref_10_c_1723_p N_noxref_10_c_1614_n \
 N_noxref_10_c_1615_n N_noxref_10_c_1616_n N_noxref_10_c_1714_n \
 N_noxref_10_c_1715_n N_noxref_10_c_1717_n N_noxref_10_c_1718_n \
 N_noxref_10_M6_noxref_d N_noxref_10_M23_noxref_d )  PM_DLATCH\%noxref_10
x_PM_DLATCH\%noxref_11 ( N_noxref_11_c_1767_n N_noxref_11_c_1769_n \
 N_noxref_11_c_1809_n N_noxref_11_c_1770_n N_noxref_11_c_1772_n \
 N_noxref_11_c_1847_n N_noxref_11_c_1797_n N_noxref_11_c_1799_n \
 N_noxref_11_c_1776_n N_noxref_11_c_1780_n N_noxref_11_M8_noxref_g \
 N_noxref_11_M27_noxref_g N_noxref_11_M28_noxref_g N_noxref_11_c_1781_n \
 N_noxref_11_c_1820_n N_noxref_11_c_1823_n N_noxref_11_c_1860_n \
 N_noxref_11_c_1783_n N_noxref_11_c_1784_n N_noxref_11_c_1785_n \
 N_noxref_11_c_1827_n N_noxref_11_c_1828_n N_noxref_11_c_1830_n \
 N_noxref_11_c_1831_n N_noxref_11_M9_noxref_d N_noxref_11_M10_noxref_d \
 N_noxref_11_M31_noxref_d )  PM_DLATCH\%noxref_11
x_PM_DLATCH\%noxref_12 ( N_noxref_12_c_1929_n N_noxref_12_c_1930_n \
 N_noxref_12_c_1934_n N_noxref_12_c_1937_n N_noxref_12_c_1938_n \
 N_noxref_12_c_1941_n N_noxref_12_M1_noxref_s )  PM_DLATCH\%noxref_12
x_PM_DLATCH\%noxref_13 ( N_noxref_13_c_1984_n N_noxref_13_c_1985_n \
 N_noxref_13_c_1989_n N_noxref_13_c_1992_n N_noxref_13_c_1993_n \
 N_noxref_13_c_1996_n N_noxref_13_M4_noxref_s )  PM_DLATCH\%noxref_13
x_PM_DLATCH\%noxref_14 ( N_noxref_14_c_2038_n N_noxref_14_c_2043_n \
 N_noxref_14_c_2045_n N_noxref_14_c_2046_n N_noxref_14_M25_noxref_s \
 N_noxref_14_M26_noxref_d N_noxref_14_M28_noxref_d )  PM_DLATCH\%noxref_14
x_PM_DLATCH\%noxref_15 ( N_noxref_15_c_2081_n N_noxref_15_c_2085_n \
 N_noxref_15_c_2086_n N_noxref_15_c_2087_n N_noxref_15_M29_noxref_s \
 N_noxref_15_M30_noxref_d N_noxref_15_M32_noxref_d )  PM_DLATCH\%noxref_15
cc_1 ( N_GND_c_1_p N_VDD_c_279_n ) capacitor c=0.00989514f //x=19.775 \
 //y=0.175 //x2=19.73 //y2=7.58
cc_2 ( N_GND_c_2_p N_VDD_c_280_n ) capacitor c=0.00989514f //x=1.12 //y=0.175 \
 //x2=1.23 //y2=7.58
cc_3 ( N_GND_c_3_p N_VDD_c_281_n ) capacitor c=0.00524733f //x=2.71 //y=0.175 \
 //x2=2.71 //y2=7.585
cc_4 ( N_GND_c_4_p N_VDD_c_282_n ) capacitor c=0.00479032f //x=6.04 //y=0.175 \
 //x2=6.04 //y2=7.585
cc_5 ( N_GND_c_5_p N_VDD_c_283_n ) capacitor c=0.00474917f //x=8.26 //y=0.175 \
 //x2=8.26 //y2=7.585
cc_6 ( N_GND_c_6_p N_VDD_c_284_n ) capacitor c=0.00828486f //x=11.59 //y=0.175 \
 //x2=11.59 //y2=7.585
cc_7 ( N_GND_c_7_p N_VDD_c_285_n ) capacitor c=0.00524733f //x=13.81 //y=0.175 \
 //x2=13.81 //y2=7.585
cc_8 ( N_GND_c_8_p N_VDD_c_286_n ) capacitor c=0.00500791f //x=17.14 //y=0.175 \
 //x2=17.14 //y2=7.585
cc_9 ( N_GND_c_9_p N_noxref_3_c_546_n ) capacitor c=0.0125822f //x=19.73 \
 //y=0.18 //x2=3.705 //y2=3.88
cc_10 ( N_GND_c_3_p N_noxref_3_c_546_n ) capacitor c=0.00533026f //x=2.71 \
 //y=0.175 //x2=3.705 //y2=3.88
cc_11 ( N_GND_M0_noxref_s N_noxref_3_c_546_n ) capacitor c=9.53705e-19 \
 //x=0.985 //y=0.55 //x2=3.705 //y2=3.88
cc_12 ( N_GND_c_9_p N_noxref_3_c_549_n ) capacitor c=0.00170127f //x=19.73 \
 //y=0.18 //x2=2.085 //y2=3.88
cc_13 ( N_GND_M0_noxref_s N_noxref_3_c_549_n ) capacitor c=4.89865e-19 \
 //x=0.985 //y=0.55 //x2=2.085 //y2=3.88
cc_14 ( N_GND_c_9_p N_noxref_3_c_551_n ) capacitor c=0.00135097f //x=19.73 \
 //y=0.18 //x2=1.885 //y2=2.26
cc_15 ( N_GND_c_3_p N_noxref_3_c_551_n ) capacitor c=0.0296841f //x=2.71 \
 //y=0.175 //x2=1.885 //y2=2.26
cc_16 ( N_GND_M0_noxref_s N_noxref_3_c_551_n ) capacitor c=0.00988997f \
 //x=0.985 //y=0.55 //x2=1.885 //y2=2.26
cc_17 ( N_GND_c_2_p N_noxref_3_c_554_n ) capacitor c=8.10282e-19 //x=1.12 \
 //y=0.175 //x2=1.97 //y2=3.88
cc_18 ( N_GND_c_3_p N_noxref_3_c_555_n ) capacitor c=0.0179404f //x=2.71 \
 //y=0.175 //x2=3.82 //y2=2.26
cc_19 ( N_GND_c_19_p N_noxref_3_c_556_n ) capacitor c=0.00135783f //x=3.805 \
 //y=0.175 //x2=3.625 //y2=1.045
cc_20 ( N_GND_M1_noxref_d N_noxref_3_c_556_n ) capacitor c=0.00220047f //x=3.7 \
 //y=1.045 //x2=3.625 //y2=1.045
cc_21 ( N_GND_M1_noxref_d N_noxref_3_c_558_n ) capacitor c=0.00255985f //x=3.7 \
 //y=1.045 //x2=3.625 //y2=1.39
cc_22 ( N_GND_c_3_p N_noxref_3_c_559_n ) capacitor c=0.0114883f //x=2.71 \
 //y=0.175 //x2=3.625 //y2=2.095
cc_23 ( N_GND_M1_noxref_d N_noxref_3_c_560_n ) capacitor c=0.0131374f //x=3.7 \
 //y=1.045 //x2=4 //y2=0.89
cc_24 ( N_GND_M1_noxref_d N_noxref_3_c_561_n ) capacitor c=0.00193146f //x=3.7 \
 //y=1.045 //x2=4 //y2=1.545
cc_25 ( N_GND_c_25_p N_noxref_3_c_562_n ) capacitor c=0.00131234f //x=5.87 \
 //y=0.175 //x2=4.155 //y2=1.045
cc_26 ( N_GND_M1_noxref_d N_noxref_3_c_562_n ) capacitor c=0.00257848f //x=3.7 \
 //y=1.045 //x2=4.155 //y2=1.045
cc_27 ( N_GND_M1_noxref_d N_noxref_3_c_564_n ) capacitor c=0.00255985f //x=3.7 \
 //y=1.045 //x2=4.155 //y2=1.39
cc_28 ( N_GND_c_9_p N_noxref_3_M0_noxref_d ) capacitor c=0.00136332f //x=19.73 \
 //y=0.18 //x2=1.415 //y2=1.09
cc_29 ( N_GND_c_29_p N_noxref_3_M0_noxref_d ) capacitor c=0.0151922f //x=1.52 \
 //y=0.715 //x2=1.415 //y2=1.09
cc_30 ( N_GND_c_2_p N_noxref_3_M0_noxref_d ) capacitor c=0.0094373f //x=1.12 \
 //y=0.175 //x2=1.415 //y2=1.09
cc_31 ( N_GND_c_3_p N_noxref_3_M0_noxref_d ) capacitor c=0.00949241f //x=2.71 \
 //y=0.175 //x2=1.415 //y2=1.09
cc_32 ( N_GND_M0_noxref_s N_noxref_3_M0_noxref_d ) capacitor c=0.076995f \
 //x=0.985 //y=0.55 //x2=1.415 //y2=1.09
cc_33 ( N_GND_c_4_p N_noxref_4_c_663_n ) capacitor c=0.0461206f //x=6.04 \
 //y=0.175 //x2=5.215 //y2=1.835
cc_34 ( N_GND_M3_noxref_s N_noxref_4_c_663_n ) capacitor c=3.37896e-19 \
 //x=6.535 //y=0.55 //x2=5.215 //y2=1.835
cc_35 ( N_GND_c_3_p N_noxref_4_c_665_n ) capacitor c=0.00101801f //x=2.71 \
 //y=0.175 //x2=5.3 //y2=3.51
cc_36 ( N_GND_c_9_p N_noxref_4_c_666_n ) capacitor c=0.00183809f //x=19.73 \
 //y=0.18 //x2=6.78 //y2=2.265
cc_37 ( N_GND_c_37_p N_noxref_4_c_666_n ) capacitor c=7.85046e-19 //x=7.07 \
 //y=0.715 //x2=6.78 //y2=2.265
cc_38 ( N_GND_c_4_p N_noxref_4_c_666_n ) capacitor c=0.029021f //x=6.04 \
 //y=0.175 //x2=6.78 //y2=2.265
cc_39 ( N_GND_c_5_p N_noxref_4_c_666_n ) capacitor c=0.00118911f //x=8.26 \
 //y=0.175 //x2=6.78 //y2=2.265
cc_40 ( N_GND_M3_noxref_s N_noxref_4_c_666_n ) capacitor c=0.0102609f \
 //x=6.535 //y=0.55 //x2=6.78 //y2=2.265
cc_41 ( N_GND_c_37_p N_noxref_4_c_671_n ) capacitor c=0.01232f //x=7.07 \
 //y=0.715 //x2=6.89 //y2=1.09
cc_42 ( N_GND_M3_noxref_s N_noxref_4_c_671_n ) capacitor c=0.0317689f \
 //x=6.535 //y=0.55 //x2=6.89 //y2=1.09
cc_43 ( N_GND_c_4_p N_noxref_4_c_673_n ) capacitor c=0.00562003f //x=6.04 \
 //y=0.175 //x2=6.89 //y2=2.1
cc_44 ( N_GND_M3_noxref_s N_noxref_4_c_674_n ) capacitor c=0.0048929f \
 //x=6.535 //y=0.55 //x2=7.265 //y2=0.935
cc_45 ( N_GND_c_45_p N_noxref_4_c_675_n ) capacitor c=0.0119203f //x=7.555 \
 //y=0.715 //x2=7.42 //y2=1.09
cc_46 ( N_GND_M3_noxref_s N_noxref_4_c_675_n ) capacitor c=0.0143355f \
 //x=6.535 //y=0.55 //x2=7.42 //y2=1.09
cc_47 ( N_GND_M3_noxref_s N_noxref_4_c_677_n ) capacitor c=0.0074042f \
 //x=6.535 //y=0.55 //x2=7.42 //y2=1.435
cc_48 ( N_GND_c_37_p N_noxref_4_c_678_n ) capacitor c=2.1838e-19 //x=7.07 \
 //y=0.715 //x2=6.78 //y2=2.265
cc_49 ( N_GND_c_4_p N_noxref_4_c_678_n ) capacitor c=0.0108179f //x=6.04 \
 //y=0.175 //x2=6.78 //y2=2.265
cc_50 ( N_GND_M3_noxref_s N_noxref_4_c_678_n ) capacitor c=0.00652921f \
 //x=6.535 //y=0.55 //x2=6.78 //y2=2.265
cc_51 ( N_GND_c_3_p N_noxref_4_M2_noxref_d ) capacitor c=8.58106e-19 //x=2.71 \
 //y=0.175 //x2=4.67 //y2=1.085
cc_52 ( N_GND_c_4_p N_noxref_4_M2_noxref_d ) capacitor c=0.00616547f //x=6.04 \
 //y=0.175 //x2=4.67 //y2=1.085
cc_53 ( N_GND_M1_noxref_d N_noxref_4_M2_noxref_d ) capacitor c=0.00143464f \
 //x=3.7 //y=1.045 //x2=4.67 //y2=1.085
cc_54 ( N_GND_M3_noxref_s N_noxref_4_M2_noxref_d ) capacitor c=2.09402e-19 \
 //x=6.535 //y=0.55 //x2=4.67 //y2=1.085
cc_55 ( N_GND_c_9_p N_GATE_c_797_n ) capacitor c=0.0383014f //x=19.73 //y=0.18 \
 //x2=9.255 //y2=3.14
cc_56 ( N_GND_c_25_p N_GATE_c_797_n ) capacitor c=0.00209137f //x=5.87 \
 //y=0.175 //x2=9.255 //y2=3.14
cc_57 ( N_GND_c_57_p N_GATE_c_797_n ) capacitor c=0.00134601f //x=6.585 \
 //y=0.175 //x2=9.255 //y2=3.14
cc_58 ( N_GND_c_37_p N_GATE_c_797_n ) capacitor c=0.00140377f //x=7.07 \
 //y=0.715 //x2=9.255 //y2=3.14
cc_59 ( N_GND_c_59_p N_GATE_c_797_n ) capacitor c=0.00129706f //x=8.09 \
 //y=0.175 //x2=9.255 //y2=3.14
cc_60 ( N_GND_c_60_p N_GATE_c_797_n ) capacitor c=0.00230319f //x=9.355 \
 //y=0.175 //x2=9.255 //y2=3.14
cc_61 ( N_GND_c_4_p N_GATE_c_797_n ) capacitor c=0.0144855f //x=6.04 //y=0.175 \
 //x2=9.255 //y2=3.14
cc_62 ( N_GND_c_5_p N_GATE_c_797_n ) capacitor c=0.0144855f //x=8.26 //y=0.175 \
 //x2=9.255 //y2=3.14
cc_63 ( N_GND_M3_noxref_s N_GATE_c_797_n ) capacitor c=0.00500333f //x=6.535 \
 //y=0.55 //x2=9.255 //y2=3.14
cc_64 ( N_GND_c_9_p N_GATE_c_806_n ) capacitor c=0.00191181f //x=19.73 \
 //y=0.18 //x2=4.675 //y2=3.14
cc_65 ( N_GND_c_3_p N_GATE_c_807_n ) capacitor c=9.2064e-19 //x=2.71 //y=0.175 \
 //x2=4.56 //y2=2.26
cc_66 ( N_GND_c_4_p N_GATE_c_807_n ) capacitor c=9.53263e-19 //x=6.04 \
 //y=0.175 //x2=4.56 //y2=2.26
cc_67 ( N_GND_c_5_p N_GATE_c_809_n ) capacitor c=0.0179404f //x=8.26 //y=0.175 \
 //x2=9.37 //y2=2.26
cc_68 ( N_GND_c_60_p N_GATE_c_810_n ) capacitor c=0.00135783f //x=9.355 \
 //y=0.175 //x2=9.175 //y2=1.045
cc_69 ( N_GND_M4_noxref_d N_GATE_c_810_n ) capacitor c=0.00220047f //x=9.25 \
 //y=1.045 //x2=9.175 //y2=1.045
cc_70 ( N_GND_M4_noxref_d N_GATE_c_812_n ) capacitor c=0.00255985f //x=9.25 \
 //y=1.045 //x2=9.175 //y2=1.39
cc_71 ( N_GND_c_5_p N_GATE_c_813_n ) capacitor c=0.0114883f //x=8.26 //y=0.175 \
 //x2=9.175 //y2=2.095
cc_72 ( N_GND_M4_noxref_d N_GATE_c_814_n ) capacitor c=0.0131374f //x=9.25 \
 //y=1.045 //x2=9.55 //y2=0.89
cc_73 ( N_GND_M4_noxref_d N_GATE_c_815_n ) capacitor c=0.00193146f //x=9.25 \
 //y=1.045 //x2=9.55 //y2=1.545
cc_74 ( N_GND_c_74_p N_GATE_c_816_n ) capacitor c=0.00131234f //x=11.42 \
 //y=0.175 //x2=9.705 //y2=1.045
cc_75 ( N_GND_M4_noxref_d N_GATE_c_816_n ) capacitor c=0.00257848f //x=9.25 \
 //y=1.045 //x2=9.705 //y2=1.045
cc_76 ( N_GND_M4_noxref_d N_GATE_c_818_n ) capacitor c=0.00255985f //x=9.25 \
 //y=1.045 //x2=9.705 //y2=1.39
cc_77 ( N_GND_c_9_p N_D_c_958_n ) capacitor c=0.0153615f //x=19.73 //y=0.18 \
 //x2=9.995 //y2=4.25
cc_78 ( N_GND_c_9_p N_D_c_959_n ) capacitor c=0.00155673f //x=19.73 //y=0.18 \
 //x2=1.345 //y2=4.25
cc_79 ( N_GND_M0_noxref_s N_D_c_959_n ) capacitor c=5.91354e-19 //x=0.985 \
 //y=0.55 //x2=1.345 //y2=4.25
cc_80 ( N_GND_c_9_p N_D_c_961_n ) capacitor c=0.00187068f //x=19.73 //y=0.18 \
 //x2=1.23 //y2=2.265
cc_81 ( N_GND_c_29_p N_D_c_961_n ) capacitor c=8.01092e-19 //x=1.52 //y=0.715 \
 //x2=1.23 //y2=2.265
cc_82 ( N_GND_c_2_p N_D_c_961_n ) capacitor c=0.0293771f //x=1.12 //y=0.175 \
 //x2=1.23 //y2=2.265
cc_83 ( N_GND_c_3_p N_D_c_961_n ) capacitor c=0.00118911f //x=2.71 //y=0.175 \
 //x2=1.23 //y2=2.265
cc_84 ( N_GND_M0_noxref_s N_D_c_961_n ) capacitor c=0.0111016f //x=0.985 \
 //y=0.55 //x2=1.23 //y2=2.265
cc_85 ( N_GND_c_5_p N_D_c_966_n ) capacitor c=9.2064e-19 //x=8.26 //y=0.175 \
 //x2=10.11 //y2=2.26
cc_86 ( N_GND_c_6_p N_D_c_966_n ) capacitor c=9.53263e-19 //x=11.59 //y=0.175 \
 //x2=10.11 //y2=2.26
cc_87 ( N_GND_c_29_p N_D_c_968_n ) capacitor c=0.0120525f //x=1.52 //y=0.715 \
 //x2=1.34 //y2=1.09
cc_88 ( N_GND_M0_noxref_s N_D_c_968_n ) capacitor c=0.0316657f //x=0.985 \
 //y=0.55 //x2=1.34 //y2=1.09
cc_89 ( N_GND_c_2_p N_D_c_970_n ) capacitor c=0.0124051f //x=1.12 //y=0.175 \
 //x2=1.34 //y2=2.1
cc_90 ( N_GND_M0_noxref_s N_D_c_971_n ) capacitor c=0.00483567f //x=0.985 \
 //y=0.55 //x2=1.715 //y2=0.935
cc_91 ( N_GND_c_91_p N_D_c_972_n ) capacitor c=0.0118631f //x=2.005 //y=0.715 \
 //x2=1.87 //y2=1.09
cc_92 ( N_GND_M0_noxref_s N_D_c_972_n ) capacitor c=0.0143355f //x=0.985 \
 //y=0.55 //x2=1.87 //y2=1.09
cc_93 ( N_GND_M0_noxref_s N_D_c_974_n ) capacitor c=0.0074042f //x=0.985 \
 //y=0.55 //x2=1.87 //y2=1.435
cc_94 ( N_GND_c_29_p N_D_c_975_n ) capacitor c=2.1838e-19 //x=1.52 //y=0.715 \
 //x2=1.23 //y2=2.265
cc_95 ( N_GND_c_2_p N_D_c_975_n ) capacitor c=0.0108179f //x=1.12 //y=0.175 \
 //x2=1.23 //y2=2.265
cc_96 ( N_GND_M0_noxref_s N_D_c_975_n ) capacitor c=0.006558f //x=0.985 \
 //y=0.55 //x2=1.23 //y2=2.265
cc_97 ( N_GND_c_9_p N_noxref_7_c_1135_n ) capacitor c=0.0116242f //x=19.73 \
 //y=0.18 //x2=12.215 //y2=3.51
cc_98 ( N_GND_c_74_p N_noxref_7_c_1135_n ) capacitor c=0.00157084f //x=11.42 \
 //y=0.175 //x2=12.215 //y2=3.51
cc_99 ( N_GND_c_99_p N_noxref_7_c_1135_n ) capacitor c=0.00110287f //x=12.135 \
 //y=0.175 //x2=12.215 //y2=3.51
cc_100 ( N_GND_c_100_p N_noxref_7_c_1135_n ) capacitor c=3.56654e-19 //x=12.62 \
 //y=0.715 //x2=12.215 //y2=3.51
cc_101 ( N_GND_c_6_p N_noxref_7_c_1135_n ) capacitor c=0.00820859f //x=11.59 \
 //y=0.175 //x2=12.215 //y2=3.51
cc_102 ( N_GND_M6_noxref_s N_noxref_7_c_1135_n ) capacitor c=0.00175419f \
 //x=12.085 //y=0.55 //x2=12.215 //y2=3.51
cc_103 ( N_GND_c_9_p N_noxref_7_c_1141_n ) capacitor c=0.00174433f //x=19.73 \
 //y=0.18 //x2=10.965 //y2=3.51
cc_104 ( N_GND_c_6_p N_noxref_7_c_1142_n ) capacitor c=0.0461206f //x=11.59 \
 //y=0.175 //x2=10.765 //y2=1.835
cc_105 ( N_GND_M6_noxref_s N_noxref_7_c_1142_n ) capacitor c=3.37896e-19 \
 //x=12.085 //y=0.55 //x2=10.765 //y2=1.835
cc_106 ( N_GND_c_5_p N_noxref_7_c_1144_n ) capacitor c=0.00101801f //x=8.26 \
 //y=0.175 //x2=10.85 //y2=3.51
cc_107 ( N_GND_c_9_p N_noxref_7_c_1145_n ) capacitor c=0.00184912f //x=19.73 \
 //y=0.18 //x2=12.33 //y2=2.265
cc_108 ( N_GND_c_100_p N_noxref_7_c_1145_n ) capacitor c=7.87839e-19 //x=12.62 \
 //y=0.715 //x2=12.33 //y2=2.265
cc_109 ( N_GND_c_6_p N_noxref_7_c_1145_n ) capacitor c=0.029021f //x=11.59 \
 //y=0.175 //x2=12.33 //y2=2.265
cc_110 ( N_GND_c_7_p N_noxref_7_c_1145_n ) capacitor c=0.00118911f //x=13.81 \
 //y=0.175 //x2=12.33 //y2=2.265
cc_111 ( N_GND_M6_noxref_s N_noxref_7_c_1145_n ) capacitor c=0.0109322f \
 //x=12.085 //y=0.55 //x2=12.33 //y2=2.265
cc_112 ( N_GND_c_100_p N_noxref_7_c_1150_n ) capacitor c=0.01232f //x=12.62 \
 //y=0.715 //x2=12.44 //y2=1.09
cc_113 ( N_GND_M6_noxref_s N_noxref_7_c_1150_n ) capacitor c=0.0317792f \
 //x=12.085 //y=0.55 //x2=12.44 //y2=1.09
cc_114 ( N_GND_c_6_p N_noxref_7_c_1152_n ) capacitor c=0.00562003f //x=11.59 \
 //y=0.175 //x2=12.44 //y2=2.1
cc_115 ( N_GND_M6_noxref_s N_noxref_7_c_1153_n ) capacitor c=0.0048929f \
 //x=12.085 //y=0.55 //x2=12.815 //y2=0.935
cc_116 ( N_GND_c_116_p N_noxref_7_c_1154_n ) capacitor c=0.0119203f //x=13.105 \
 //y=0.715 //x2=12.97 //y2=1.09
cc_117 ( N_GND_M6_noxref_s N_noxref_7_c_1154_n ) capacitor c=0.0143355f \
 //x=12.085 //y=0.55 //x2=12.97 //y2=1.09
cc_118 ( N_GND_M6_noxref_s N_noxref_7_c_1156_n ) capacitor c=0.0074042f \
 //x=12.085 //y=0.55 //x2=12.97 //y2=1.435
cc_119 ( N_GND_c_100_p N_noxref_7_c_1157_n ) capacitor c=2.1838e-19 //x=12.62 \
 //y=0.715 //x2=12.33 //y2=2.265
cc_120 ( N_GND_c_6_p N_noxref_7_c_1157_n ) capacitor c=0.0108179f //x=11.59 \
 //y=0.175 //x2=12.33 //y2=2.265
cc_121 ( N_GND_M6_noxref_s N_noxref_7_c_1157_n ) capacitor c=0.006558f \
 //x=12.085 //y=0.55 //x2=12.33 //y2=2.265
cc_122 ( N_GND_c_5_p N_noxref_7_M5_noxref_d ) capacitor c=8.58106e-19 //x=8.26 \
 //y=0.175 //x2=10.22 //y2=1.085
cc_123 ( N_GND_c_6_p N_noxref_7_M5_noxref_d ) capacitor c=0.00616547f \
 //x=11.59 //y=0.175 //x2=10.22 //y2=1.085
cc_124 ( N_GND_M4_noxref_d N_noxref_7_M5_noxref_d ) capacitor c=0.00143464f \
 //x=9.25 //y=1.045 //x2=10.22 //y2=1.085
cc_125 ( N_GND_M6_noxref_s N_noxref_7_M5_noxref_d ) capacitor c=2.09402e-19 \
 //x=12.085 //y=0.55 //x2=10.22 //y2=1.085
cc_126 ( N_GND_c_9_p N_noxref_8_c_1274_n ) capacitor c=0.0318084f //x=19.73 \
 //y=0.18 //x2=14.805 //y2=3.88
cc_127 ( N_GND_c_100_p N_noxref_8_c_1274_n ) capacitor c=6.67769e-19 //x=12.62 \
 //y=0.715 //x2=14.805 //y2=3.88
cc_128 ( N_GND_c_128_p N_noxref_8_c_1274_n ) capacitor c=8.6578e-19 //x=14.905 \
 //y=0.71 //x2=14.805 //y2=3.88
cc_129 ( N_GND_c_7_p N_noxref_8_c_1274_n ) capacitor c=0.00533026f //x=13.81 \
 //y=0.175 //x2=14.805 //y2=3.88
cc_130 ( N_GND_M6_noxref_s N_noxref_8_c_1274_n ) capacitor c=0.00141735f \
 //x=12.085 //y=0.55 //x2=14.805 //y2=3.88
cc_131 ( N_GND_M7_noxref_s N_noxref_8_c_1274_n ) capacitor c=0.00180308f \
 //x=14.37 //y=0.545 //x2=14.805 //y2=3.88
cc_132 ( N_GND_c_9_p N_noxref_8_c_1280_n ) capacitor c=0.00130814f //x=19.73 \
 //y=0.18 //x2=7.435 //y2=2.26
cc_133 ( N_GND_c_5_p N_noxref_8_c_1280_n ) capacitor c=0.0296841f //x=8.26 \
 //y=0.175 //x2=7.435 //y2=2.26
cc_134 ( N_GND_M3_noxref_s N_noxref_8_c_1280_n ) capacitor c=0.0096778f \
 //x=6.535 //y=0.55 //x2=7.435 //y2=2.26
cc_135 ( N_GND_c_4_p N_noxref_8_c_1283_n ) capacitor c=8.10282e-19 //x=6.04 \
 //y=0.175 //x2=7.52 //y2=3.88
cc_136 ( N_GND_c_9_p N_noxref_8_c_1284_n ) capacitor c=5.99269e-19 //x=19.73 \
 //y=0.18 //x2=14.92 //y2=2.26
cc_137 ( N_GND_c_128_p N_noxref_8_c_1284_n ) capacitor c=0.00135452f \
 //x=14.905 //y=0.71 //x2=14.92 //y2=2.26
cc_138 ( N_GND_c_7_p N_noxref_8_c_1284_n ) capacitor c=0.0175793f //x=13.81 \
 //y=0.175 //x2=14.92 //y2=2.26
cc_139 ( N_GND_c_128_p N_noxref_8_c_1287_n ) capacitor c=0.0125802f //x=14.905 \
 //y=0.71 //x2=14.725 //y2=1.085
cc_140 ( N_GND_M7_noxref_s N_noxref_8_c_1287_n ) capacitor c=0.0318086f \
 //x=14.37 //y=0.545 //x2=14.725 //y2=1.085
cc_141 ( N_GND_c_128_p N_noxref_8_c_1289_n ) capacitor c=2.1838e-19 //x=14.905 \
 //y=0.71 //x2=14.725 //y2=2.095
cc_142 ( N_GND_c_7_p N_noxref_8_c_1289_n ) capacitor c=0.0114883f //x=13.81 \
 //y=0.175 //x2=14.725 //y2=2.095
cc_143 ( N_GND_M7_noxref_s N_noxref_8_c_1291_n ) capacitor c=0.00476921f \
 //x=14.37 //y=0.545 //x2=15.1 //y2=0.93
cc_144 ( N_GND_c_144_p N_noxref_8_c_1292_n ) capacitor c=0.0113338f //x=15.39 \
 //y=0.71 //x2=15.255 //y2=1.085
cc_145 ( N_GND_M7_noxref_s N_noxref_8_c_1292_n ) capacitor c=0.00514143f \
 //x=14.37 //y=0.545 //x2=15.255 //y2=1.085
cc_146 ( N_GND_M7_noxref_s N_noxref_8_c_1294_n ) capacitor c=8.33128e-19 \
 //x=14.37 //y=0.545 //x2=15.255 //y2=1.43
cc_147 ( N_GND_c_9_p N_noxref_8_M3_noxref_d ) capacitor c=0.00124116f \
 //x=19.73 //y=0.18 //x2=6.965 //y2=1.09
cc_148 ( N_GND_c_37_p N_noxref_8_M3_noxref_d ) capacitor c=0.0150664f //x=7.07 \
 //y=0.715 //x2=6.965 //y2=1.09
cc_149 ( N_GND_c_4_p N_noxref_8_M3_noxref_d ) capacitor c=0.00924905f //x=6.04 \
 //y=0.175 //x2=6.965 //y2=1.09
cc_150 ( N_GND_c_5_p N_noxref_8_M3_noxref_d ) capacitor c=0.00949241f //x=8.26 \
 //y=0.175 //x2=6.965 //y2=1.09
cc_151 ( N_GND_M3_noxref_s N_noxref_8_M3_noxref_d ) capacitor c=0.076995f \
 //x=6.535 //y=0.55 //x2=6.965 //y2=1.09
cc_152 ( N_GND_c_9_p N_Q_c_1438_n ) capacitor c=0.0143768f //x=19.73 //y=0.18 \
 //x2=18.135 //y2=3.51
cc_153 ( N_GND_c_153_p N_Q_c_1438_n ) capacitor c=0.00136355f //x=16.97 \
 //y=0.175 //x2=18.135 //y2=3.51
cc_154 ( N_GND_c_154_p N_Q_c_1438_n ) capacitor c=0.00136355f //x=17.75 \
 //y=0.175 //x2=18.135 //y2=3.51
cc_155 ( N_GND_c_155_p N_Q_c_1438_n ) capacitor c=0.00131946f //x=18.235 \
 //y=0.71 //x2=18.135 //y2=3.51
cc_156 ( N_GND_c_8_p N_Q_c_1438_n ) capacitor c=0.00820859f //x=17.14 \
 //y=0.175 //x2=18.135 //y2=3.51
cc_157 ( N_GND_M9_noxref_s N_Q_c_1438_n ) capacitor c=0.00234522f //x=17.7 \
 //y=0.545 //x2=18.135 //y2=3.51
cc_158 ( N_GND_c_9_p N_Q_c_1444_n ) capacitor c=0.00192552f //x=19.73 //y=0.18 \
 //x2=16.515 //y2=3.51
cc_159 ( N_GND_M7_noxref_s N_Q_c_1444_n ) capacitor c=6.85334e-19 //x=14.37 \
 //y=0.545 //x2=16.515 //y2=3.51
cc_160 ( N_GND_c_7_p Q ) capacitor c=0.00101801f //x=13.81 //y=0.175 //x2=16.4 \
 //y2=2.4
cc_161 ( N_GND_c_9_p N_Q_c_1447_n ) capacitor c=0.00257034f //x=19.73 //y=0.18 \
 //x2=15.875 //y2=1.835
cc_162 ( N_GND_c_144_p N_Q_c_1447_n ) capacitor c=0.00381844f //x=15.39 \
 //y=0.71 //x2=15.875 //y2=1.835
cc_163 ( N_GND_c_163_p N_Q_c_1447_n ) capacitor c=0.00320884f //x=15.875 \
 //y=0.71 //x2=15.875 //y2=1.835
cc_164 ( N_GND_M7_noxref_s N_Q_c_1447_n ) capacitor c=0.0172045f //x=14.37 \
 //y=0.545 //x2=15.875 //y2=1.835
cc_165 ( N_GND_c_9_p N_Q_c_1451_n ) capacitor c=0.00187872f //x=19.73 //y=0.18 \
 //x2=16.315 //y2=1.835
cc_166 ( N_GND_c_166_p N_Q_c_1451_n ) capacitor c=0.00477569f //x=16.36 \
 //y=0.71 //x2=16.315 //y2=1.835
cc_167 ( N_GND_c_8_p N_Q_c_1451_n ) capacitor c=0.0466045f //x=17.14 //y=0.175 \
 //x2=16.315 //y2=1.835
cc_168 ( N_GND_M7_noxref_s N_Q_c_1451_n ) capacitor c=0.0158849f //x=14.37 \
 //y=0.545 //x2=16.315 //y2=1.835
cc_169 ( N_GND_M9_noxref_s N_Q_c_1451_n ) capacitor c=3.16502e-19 //x=17.7 \
 //y=0.545 //x2=16.315 //y2=1.835
cc_170 ( N_GND_c_9_p N_Q_c_1456_n ) capacitor c=5.94184e-19 //x=19.73 //y=0.18 \
 //x2=18.25 //y2=2.26
cc_171 ( N_GND_c_155_p N_Q_c_1456_n ) capacitor c=0.00135015f //x=18.235 \
 //y=0.71 //x2=18.25 //y2=2.26
cc_172 ( N_GND_c_8_p N_Q_c_1456_n ) capacitor c=0.0175793f //x=17.14 //y=0.175 \
 //x2=18.25 //y2=2.26
cc_173 ( N_GND_c_155_p N_Q_c_1459_n ) capacitor c=0.0126046f //x=18.235 \
 //y=0.71 //x2=18.055 //y2=1.085
cc_174 ( N_GND_M9_noxref_s N_Q_c_1459_n ) capacitor c=0.0318086f //x=17.7 \
 //y=0.545 //x2=18.055 //y2=1.085
cc_175 ( N_GND_c_155_p N_Q_c_1461_n ) capacitor c=2.1838e-19 //x=18.235 \
 //y=0.71 //x2=18.055 //y2=2.095
cc_176 ( N_GND_c_8_p N_Q_c_1461_n ) capacitor c=0.0130778f //x=17.14 //y=0.175 \
 //x2=18.055 //y2=2.095
cc_177 ( N_GND_M9_noxref_s N_Q_c_1463_n ) capacitor c=0.00479357f //x=17.7 \
 //y=0.545 //x2=18.43 //y2=0.93
cc_178 ( N_GND_c_178_p N_Q_c_1464_n ) capacitor c=0.0113581f //x=18.72 \
 //y=0.71 //x2=18.585 //y2=1.085
cc_179 ( N_GND_M9_noxref_s N_Q_c_1464_n ) capacitor c=0.00514143f //x=17.7 \
 //y=0.545 //x2=18.585 //y2=1.085
cc_180 ( N_GND_M9_noxref_s N_Q_c_1466_n ) capacitor c=8.33128e-19 //x=17.7 \
 //y=0.545 //x2=18.585 //y2=1.43
cc_181 ( N_GND_c_9_p N_Q_M7_noxref_d ) capacitor c=0.00113079f //x=19.73 \
 //y=0.18 //x2=14.8 //y2=1.085
cc_182 ( N_GND_c_7_p N_Q_M7_noxref_d ) capacitor c=0.00416273f //x=13.81 \
 //y=0.175 //x2=14.8 //y2=1.085
cc_183 ( N_GND_c_8_p N_Q_M7_noxref_d ) capacitor c=2.57516e-19 //x=17.14 \
 //y=0.175 //x2=14.8 //y2=1.085
cc_184 ( N_GND_M7_noxref_s N_Q_M7_noxref_d ) capacitor c=0.0767963f //x=14.37 \
 //y=0.545 //x2=14.8 //y2=1.085
cc_185 ( N_GND_c_9_p N_Q_M8_noxref_d ) capacitor c=0.00132665f //x=19.73 \
 //y=0.18 //x2=15.77 //y2=1.085
cc_186 ( N_GND_c_8_p N_Q_M8_noxref_d ) capacitor c=0.00609243f //x=17.14 \
 //y=0.175 //x2=15.77 //y2=1.085
cc_187 ( N_GND_M7_noxref_s N_Q_M8_noxref_d ) capacitor c=0.060983f //x=14.37 \
 //y=0.545 //x2=15.77 //y2=1.085
cc_188 ( N_GND_c_9_p N_noxref_10_c_1605_n ) capacitor c=0.0130168f //x=19.73 \
 //y=0.18 //x2=18.875 //y2=4.25
cc_189 ( N_GND_c_9_p N_noxref_10_c_1606_n ) capacitor c=0.00134692f //x=19.73 \
 //y=0.18 //x2=12.985 //y2=2.26
cc_190 ( N_GND_c_7_p N_noxref_10_c_1606_n ) capacitor c=0.0296841f //x=13.81 \
 //y=0.175 //x2=12.985 //y2=2.26
cc_191 ( N_GND_M6_noxref_s N_noxref_10_c_1606_n ) capacitor c=0.00988752f \
 //x=12.085 //y=0.55 //x2=12.985 //y2=2.26
cc_192 ( N_GND_c_6_p N_noxref_10_c_1609_n ) capacitor c=8.10282e-19 //x=11.59 \
 //y=0.175 //x2=13.07 //y2=4.25
cc_193 ( N_GND_c_8_p N_noxref_10_c_1610_n ) capacitor c=9.2064e-19 //x=17.14 \
 //y=0.175 //x2=18.99 //y2=2.26
cc_194 ( N_GND_c_1_p N_noxref_10_c_1610_n ) capacitor c=9.53263e-19 //x=19.775 \
 //y=0.175 //x2=18.99 //y2=2.26
cc_195 ( N_GND_c_195_p N_noxref_10_c_1612_n ) capacitor c=0.0110074f \
 //x=19.205 //y=0.71 //x2=19.025 //y2=1.085
cc_196 ( N_GND_M9_noxref_s N_noxref_10_c_1612_n ) capacitor c=0.00590563f \
 //x=17.7 //y=0.545 //x2=19.025 //y2=1.085
cc_197 ( N_GND_M9_noxref_s N_noxref_10_c_1614_n ) capacitor c=0.00469471f \
 //x=17.7 //y=0.545 //x2=19.4 //y2=0.93
cc_198 ( N_GND_M9_noxref_s N_noxref_10_c_1615_n ) capacitor c=0.00316186f \
 //x=17.7 //y=0.545 //x2=19.4 //y2=1.585
cc_199 ( N_GND_c_199_p N_noxref_10_c_1616_n ) capacitor c=0.0112593f //x=19.69 \
 //y=0.71 //x2=19.555 //y2=1.085
cc_200 ( N_GND_M9_noxref_s N_noxref_10_c_1616_n ) capacitor c=0.0142835f \
 //x=17.7 //y=0.545 //x2=19.555 //y2=1.085
cc_201 ( N_GND_c_9_p N_noxref_10_M6_noxref_d ) capacitor c=0.00132545f \
 //x=19.73 //y=0.18 //x2=12.515 //y2=1.09
cc_202 ( N_GND_c_100_p N_noxref_10_M6_noxref_d ) capacitor c=0.0151409f \
 //x=12.62 //y=0.715 //x2=12.515 //y2=1.09
cc_203 ( N_GND_c_6_p N_noxref_10_M6_noxref_d ) capacitor c=0.00924905f \
 //x=11.59 //y=0.175 //x2=12.515 //y2=1.09
cc_204 ( N_GND_c_7_p N_noxref_10_M6_noxref_d ) capacitor c=0.00949241f \
 //x=13.81 //y=0.175 //x2=12.515 //y2=1.09
cc_205 ( N_GND_M6_noxref_s N_noxref_10_M6_noxref_d ) capacitor c=0.076995f \
 //x=12.085 //y=0.55 //x2=12.515 //y2=1.09
cc_206 ( N_GND_c_9_p N_noxref_11_c_1767_n ) capacitor c=0.0190547f //x=19.73 \
 //y=0.18 //x2=19.615 //y2=3.88
cc_207 ( N_GND_M9_noxref_s N_noxref_11_c_1767_n ) capacitor c=6.25703e-19 \
 //x=17.7 //y=0.545 //x2=19.615 //y2=3.88
cc_208 ( N_GND_c_9_p N_noxref_11_c_1769_n ) capacitor c=0.0016537f //x=19.73 \
 //y=0.18 //x2=15.775 //y2=3.88
cc_209 ( N_GND_c_7_p N_noxref_11_c_1770_n ) capacitor c=9.2064e-19 //x=13.81 \
 //y=0.175 //x2=15.66 //y2=2.26
cc_210 ( N_GND_c_8_p N_noxref_11_c_1770_n ) capacitor c=9.53263e-19 //x=17.14 \
 //y=0.175 //x2=15.66 //y2=2.26
cc_211 ( N_GND_c_9_p N_noxref_11_c_1772_n ) capacitor c=0.00254965f //x=19.73 \
 //y=0.18 //x2=19.205 //y2=1.835
cc_212 ( N_GND_c_178_p N_noxref_11_c_1772_n ) capacitor c=0.00380217f \
 //x=18.72 //y=0.71 //x2=19.205 //y2=1.835
cc_213 ( N_GND_c_195_p N_noxref_11_c_1772_n ) capacitor c=0.00320926f \
 //x=19.205 //y=0.71 //x2=19.205 //y2=1.835
cc_214 ( N_GND_M9_noxref_s N_noxref_11_c_1772_n ) capacitor c=0.0171536f \
 //x=17.7 //y=0.545 //x2=19.205 //y2=1.835
cc_215 ( N_GND_c_9_p N_noxref_11_c_1776_n ) capacitor c=0.00190274f //x=19.73 \
 //y=0.18 //x2=19.645 //y2=1.835
cc_216 ( N_GND_c_199_p N_noxref_11_c_1776_n ) capacitor c=0.00477812f \
 //x=19.69 //y=0.71 //x2=19.645 //y2=1.835
cc_217 ( N_GND_c_1_p N_noxref_11_c_1776_n ) capacitor c=0.0471746f //x=19.775 \
 //y=0.175 //x2=19.645 //y2=1.835
cc_218 ( N_GND_M9_noxref_s N_noxref_11_c_1776_n ) capacitor c=0.0159972f \
 //x=17.7 //y=0.545 //x2=19.645 //y2=1.835
cc_219 ( N_GND_c_8_p N_noxref_11_c_1780_n ) capacitor c=9.64732e-19 //x=17.14 \
 //y=0.175 //x2=19.73 //y2=3.88
cc_220 ( N_GND_c_163_p N_noxref_11_c_1781_n ) capacitor c=0.0110074f \
 //x=15.875 //y=0.71 //x2=15.695 //y2=1.085
cc_221 ( N_GND_M7_noxref_s N_noxref_11_c_1781_n ) capacitor c=0.00590563f \
 //x=14.37 //y=0.545 //x2=15.695 //y2=1.085
cc_222 ( N_GND_M7_noxref_s N_noxref_11_c_1783_n ) capacitor c=0.00469471f \
 //x=14.37 //y=0.545 //x2=16.07 //y2=0.93
cc_223 ( N_GND_M7_noxref_s N_noxref_11_c_1784_n ) capacitor c=0.00316186f \
 //x=14.37 //y=0.545 //x2=16.07 //y2=1.585
cc_224 ( N_GND_c_166_p N_noxref_11_c_1785_n ) capacitor c=0.0112593f //x=16.36 \
 //y=0.71 //x2=16.225 //y2=1.085
cc_225 ( N_GND_M7_noxref_s N_noxref_11_c_1785_n ) capacitor c=0.0142835f \
 //x=14.37 //y=0.545 //x2=16.225 //y2=1.085
cc_226 ( N_GND_c_9_p N_noxref_11_M9_noxref_d ) capacitor c=0.00108998f \
 //x=19.73 //y=0.18 //x2=18.13 //y2=1.085
cc_227 ( N_GND_c_8_p N_noxref_11_M9_noxref_d ) capacitor c=0.00416273f \
 //x=17.14 //y=0.175 //x2=18.13 //y2=1.085
cc_228 ( N_GND_c_1_p N_noxref_11_M9_noxref_d ) capacitor c=2.57516e-19 \
 //x=19.775 //y=0.175 //x2=18.13 //y2=1.085
cc_229 ( N_GND_M9_noxref_s N_noxref_11_M9_noxref_d ) capacitor c=0.0767676f \
 //x=17.7 //y=0.545 //x2=18.13 //y2=1.085
cc_230 ( N_GND_c_9_p N_noxref_11_M10_noxref_d ) capacitor c=0.00132665f \
 //x=19.73 //y=0.18 //x2=19.1 //y2=1.085
cc_231 ( N_GND_c_1_p N_noxref_11_M10_noxref_d ) capacitor c=0.0061094f \
 //x=19.775 //y=0.175 //x2=19.1 //y2=1.085
cc_232 ( N_GND_M9_noxref_s N_noxref_11_M10_noxref_d ) capacitor c=0.060983f \
 //x=17.7 //y=0.545 //x2=19.1 //y2=1.085
cc_233 ( N_GND_M0_noxref_s N_noxref_12_c_1929_n ) capacitor c=0.0013253f \
 //x=0.985 //y=0.55 //x2=3.405 //y2=1.675
cc_234 ( N_GND_c_9_p N_noxref_12_c_1930_n ) capacitor c=0.00565631f //x=19.73 \
 //y=0.18 //x2=4.29 //y2=1.76
cc_235 ( N_GND_c_19_p N_noxref_12_c_1930_n ) capacitor c=0.00111556f //x=3.805 \
 //y=0.175 //x2=4.29 //y2=1.76
cc_236 ( N_GND_c_25_p N_noxref_12_c_1930_n ) capacitor c=0.00181083f //x=5.87 \
 //y=0.175 //x2=4.29 //y2=1.76
cc_237 ( N_GND_M1_noxref_d N_noxref_12_c_1930_n ) capacitor c=0.00901923f \
 //x=3.7 //y=1.045 //x2=4.29 //y2=1.76
cc_238 ( N_GND_c_9_p N_noxref_12_c_1934_n ) capacitor c=0.00505864f //x=19.73 \
 //y=0.18 //x2=4.375 //y2=0.795
cc_239 ( N_GND_c_25_p N_noxref_12_c_1934_n ) capacitor c=0.01472f //x=5.87 \
 //y=0.175 //x2=4.375 //y2=0.795
cc_240 ( N_GND_M1_noxref_d N_noxref_12_c_1934_n ) capacitor c=0.033812f \
 //x=3.7 //y=1.045 //x2=4.375 //y2=0.795
cc_241 ( N_GND_c_3_p N_noxref_12_c_1937_n ) capacitor c=2.91423e-19 //x=2.71 \
 //y=0.175 //x2=4.375 //y2=1.675
cc_242 ( N_GND_c_9_p N_noxref_12_c_1938_n ) capacitor c=0.011627f //x=19.73 \
 //y=0.18 //x2=5.26 //y2=0.71
cc_243 ( N_GND_c_25_p N_noxref_12_c_1938_n ) capacitor c=0.0375558f //x=5.87 \
 //y=0.175 //x2=5.26 //y2=0.71
cc_244 ( N_GND_c_1_p N_noxref_12_c_1938_n ) capacitor c=0.0019969f //x=19.775 \
 //y=0.175 //x2=5.26 //y2=0.71
cc_245 ( N_GND_c_9_p N_noxref_12_c_1941_n ) capacitor c=0.00282884f //x=19.73 \
 //y=0.18 //x2=5.345 //y2=0.795
cc_246 ( N_GND_c_25_p N_noxref_12_c_1941_n ) capacitor c=0.0148206f //x=5.87 \
 //y=0.175 //x2=5.345 //y2=0.795
cc_247 ( N_GND_c_247_p N_noxref_12_c_1941_n ) capacitor c=9.77746e-19 //x=6.67 \
 //y=0.63 //x2=5.345 //y2=0.795
cc_248 ( N_GND_c_4_p N_noxref_12_c_1941_n ) capacitor c=0.0431718f //x=6.04 \
 //y=0.175 //x2=5.345 //y2=0.795
cc_249 ( N_GND_c_9_p N_noxref_12_M1_noxref_s ) capacitor c=0.00302993f \
 //x=19.73 //y=0.18 //x2=3.27 //y2=0.545
cc_250 ( N_GND_c_250_p N_noxref_12_M1_noxref_s ) capacitor c=0.0013253f \
 //x=2.09 //y=0.63 //x2=3.27 //y2=0.545
cc_251 ( N_GND_c_19_p N_noxref_12_M1_noxref_s ) capacitor c=0.014661f \
 //x=3.805 //y=0.175 //x2=3.27 //y2=0.545
cc_252 ( N_GND_c_3_p N_noxref_12_M1_noxref_s ) capacitor c=0.058339f //x=2.71 \
 //y=0.175 //x2=3.27 //y2=0.545
cc_253 ( N_GND_c_4_p N_noxref_12_M1_noxref_s ) capacitor c=0.00198098f \
 //x=6.04 //y=0.175 //x2=3.27 //y2=0.545
cc_254 ( N_GND_M1_noxref_d N_noxref_12_M1_noxref_s ) capacitor c=0.0334197f \
 //x=3.7 //y=1.045 //x2=3.27 //y2=0.545
cc_255 ( N_GND_M3_noxref_s N_noxref_12_M1_noxref_s ) capacitor c=9.77746e-19 \
 //x=6.535 //y=0.55 //x2=3.27 //y2=0.545
cc_256 ( N_GND_M3_noxref_s N_noxref_13_c_1984_n ) capacitor c=0.0013253f \
 //x=6.535 //y=0.55 //x2=8.955 //y2=1.675
cc_257 ( N_GND_c_9_p N_noxref_13_c_1985_n ) capacitor c=0.00550127f //x=19.73 \
 //y=0.18 //x2=9.84 //y2=1.76
cc_258 ( N_GND_c_60_p N_noxref_13_c_1985_n ) capacitor c=0.00113088f //x=9.355 \
 //y=0.175 //x2=9.84 //y2=1.76
cc_259 ( N_GND_c_74_p N_noxref_13_c_1985_n ) capacitor c=0.00181083f //x=11.42 \
 //y=0.175 //x2=9.84 //y2=1.76
cc_260 ( N_GND_M4_noxref_d N_noxref_13_c_1985_n ) capacitor c=0.00890717f \
 //x=9.25 //y=1.045 //x2=9.84 //y2=1.76
cc_261 ( N_GND_c_9_p N_noxref_13_c_1989_n ) capacitor c=0.00302993f //x=19.73 \
 //y=0.18 //x2=9.925 //y2=0.795
cc_262 ( N_GND_c_74_p N_noxref_13_c_1989_n ) capacitor c=0.014661f //x=11.42 \
 //y=0.175 //x2=9.925 //y2=0.795
cc_263 ( N_GND_M4_noxref_d N_noxref_13_c_1989_n ) capacitor c=0.033812f \
 //x=9.25 //y=1.045 //x2=9.925 //y2=0.795
cc_264 ( N_GND_c_5_p N_noxref_13_c_1992_n ) capacitor c=2.91423e-19 //x=8.26 \
 //y=0.175 //x2=9.925 //y2=1.675
cc_265 ( N_GND_c_9_p N_noxref_13_c_1993_n ) capacitor c=0.0123724f //x=19.73 \
 //y=0.18 //x2=10.81 //y2=0.71
cc_266 ( N_GND_c_74_p N_noxref_13_c_1993_n ) capacitor c=0.0373555f //x=11.42 \
 //y=0.175 //x2=10.81 //y2=0.71
cc_267 ( N_GND_c_1_p N_noxref_13_c_1993_n ) capacitor c=0.0019969f //x=19.775 \
 //y=0.175 //x2=10.81 //y2=0.71
cc_268 ( N_GND_c_9_p N_noxref_13_c_1996_n ) capacitor c=0.00292583f //x=19.73 \
 //y=0.18 //x2=10.895 //y2=0.795
cc_269 ( N_GND_c_74_p N_noxref_13_c_1996_n ) capacitor c=0.0148875f //x=11.42 \
 //y=0.175 //x2=10.895 //y2=0.795
cc_270 ( N_GND_c_270_p N_noxref_13_c_1996_n ) capacitor c=9.77746e-19 \
 //x=12.22 //y=0.63 //x2=10.895 //y2=0.795
cc_271 ( N_GND_c_6_p N_noxref_13_c_1996_n ) capacitor c=0.0431718f //x=11.59 \
 //y=0.175 //x2=10.895 //y2=0.795
cc_272 ( N_GND_c_9_p N_noxref_13_M4_noxref_s ) capacitor c=0.00282968f \
 //x=19.73 //y=0.18 //x2=8.82 //y2=0.545
cc_273 ( N_GND_c_273_p N_noxref_13_M4_noxref_s ) capacitor c=0.0013253f \
 //x=7.64 //y=0.63 //x2=8.82 //y2=0.545
cc_274 ( N_GND_c_60_p N_noxref_13_M4_noxref_s ) capacitor c=0.014886f \
 //x=9.355 //y=0.175 //x2=8.82 //y2=0.545
cc_275 ( N_GND_c_5_p N_noxref_13_M4_noxref_s ) capacitor c=0.058339f //x=8.26 \
 //y=0.175 //x2=8.82 //y2=0.545
cc_276 ( N_GND_c_6_p N_noxref_13_M4_noxref_s ) capacitor c=0.00198098f \
 //x=11.59 //y=0.175 //x2=8.82 //y2=0.545
cc_277 ( N_GND_M4_noxref_d N_noxref_13_M4_noxref_s ) capacitor c=0.0334197f \
 //x=9.25 //y=1.045 //x2=8.82 //y2=0.545
cc_278 ( N_GND_M6_noxref_s N_noxref_13_M4_noxref_s ) capacitor c=9.77746e-19 \
 //x=12.085 //y=0.55 //x2=8.82 //y2=0.545
cc_279 ( N_VDD_c_281_n N_noxref_3_c_546_n ) capacitor c=0.00290918f //x=2.71 \
 //y=7.585 //x2=3.705 //y2=3.88
cc_280 ( N_VDD_c_288_p N_noxref_3_c_571_n ) capacitor c=0.00122938f //x=19.73 \
 //y=7.58 //x2=1.885 //y2=4.76
cc_281 ( N_VDD_c_289_p N_noxref_3_c_571_n ) capacitor c=9.09621e-19 //x=1.96 \
 //y=7.585 //x2=1.885 //y2=4.76
cc_282 ( N_VDD_M12_noxref_d N_noxref_3_c_571_n ) capacitor c=0.00609295f \
 //x=1.9 //y=5.2 //x2=1.885 //y2=4.76
cc_283 ( N_VDD_c_280_n N_noxref_3_c_574_n ) capacitor c=0.0179238f //x=1.23 \
 //y=7.58 //x2=1.69 //y2=4.76
cc_284 ( N_VDD_c_280_n N_noxref_3_c_554_n ) capacitor c=5.65246e-19 //x=1.23 \
 //y=7.58 //x2=1.97 //y2=3.88
cc_285 ( N_VDD_c_281_n N_noxref_3_c_554_n ) capacitor c=0.0221282f //x=2.71 \
 //y=7.585 //x2=1.97 //y2=3.88
cc_286 ( N_VDD_c_288_p N_noxref_3_c_555_n ) capacitor c=0.00126176f //x=19.73 \
 //y=7.58 //x2=3.82 //y2=2.26
cc_287 ( N_VDD_c_295_p N_noxref_3_c_555_n ) capacitor c=2.88573e-19 //x=4.295 \
 //y=7.585 //x2=3.82 //y2=2.26
cc_288 ( N_VDD_c_281_n N_noxref_3_c_555_n ) capacitor c=0.0160215f //x=2.71 \
 //y=7.585 //x2=3.82 //y2=2.26
cc_289 ( N_VDD_c_295_p N_noxref_3_M13_noxref_g ) capacitor c=0.00732332f \
 //x=4.295 //y=7.585 //x2=3.72 //y2=6.2
cc_290 ( N_VDD_M13_noxref_s N_noxref_3_M13_noxref_g ) capacitor c=0.054195f \
 //x=3.365 //y=5.2 //x2=3.72 //y2=6.2
cc_291 ( N_VDD_c_295_p N_noxref_3_M14_noxref_g ) capacitor c=0.00677553f \
 //x=4.295 //y=7.585 //x2=4.16 //y2=6.2
cc_292 ( N_VDD_M14_noxref_d N_noxref_3_M14_noxref_g ) capacitor c=0.015318f \
 //x=4.235 //y=5.2 //x2=4.16 //y2=6.2
cc_293 ( N_VDD_c_281_n N_noxref_3_c_584_n ) capacitor c=0.012849f //x=2.71 \
 //y=7.585 //x2=3.82 //y2=4.88
cc_294 ( N_VDD_c_288_p N_noxref_3_M11_noxref_d ) capacitor c=0.00285234f \
 //x=19.73 //y=7.58 //x2=1.46 //y2=5.2
cc_295 ( N_VDD_c_289_p N_noxref_3_M11_noxref_d ) capacitor c=0.0141568f \
 //x=1.96 //y=7.585 //x2=1.46 //y2=5.2
cc_296 ( N_VDD_c_281_n N_noxref_3_M11_noxref_d ) capacitor c=0.0204591f \
 //x=2.71 //y=7.585 //x2=1.46 //y2=5.2
cc_297 ( N_VDD_M11_noxref_s N_noxref_3_M11_noxref_d ) capacitor c=0.0843065f \
 //x=1.03 //y=5.2 //x2=1.46 //y2=5.2
cc_298 ( N_VDD_M12_noxref_d N_noxref_3_M11_noxref_d ) capacitor c=0.0832641f \
 //x=1.9 //y=5.2 //x2=1.46 //y2=5.2
cc_299 ( N_VDD_c_288_p N_noxref_4_c_685_n ) capacitor c=0.00460177f //x=19.73 \
 //y=7.58 //x2=4.735 //y2=5.38
cc_300 ( N_VDD_c_295_p N_noxref_4_c_685_n ) capacitor c=4.49205e-19 //x=4.295 \
 //y=7.585 //x2=4.735 //y2=5.38
cc_301 ( N_VDD_c_309_p N_noxref_4_c_685_n ) capacitor c=4.49205e-19 //x=5.175 \
 //y=7.585 //x2=4.735 //y2=5.38
cc_302 ( N_VDD_M14_noxref_d N_noxref_4_c_685_n ) capacitor c=0.0126931f \
 //x=4.235 //y=5.2 //x2=4.735 //y2=5.38
cc_303 ( N_VDD_c_281_n N_noxref_4_c_689_n ) capacitor c=0.00985474f //x=2.71 \
 //y=7.585 //x2=4.025 //y2=5.38
cc_304 ( N_VDD_M13_noxref_s N_noxref_4_c_689_n ) capacitor c=0.087833f \
 //x=3.365 //y=5.2 //x2=4.025 //y2=5.38
cc_305 ( N_VDD_c_288_p N_noxref_4_c_691_n ) capacitor c=0.0030743f //x=19.73 \
 //y=7.58 //x2=5.215 //y2=5.38
cc_306 ( N_VDD_c_309_p N_noxref_4_c_691_n ) capacitor c=7.74005e-19 //x=5.175 \
 //y=7.585 //x2=5.215 //y2=5.38
cc_307 ( N_VDD_M16_noxref_d N_noxref_4_c_691_n ) capacitor c=0.016158f \
 //x=5.115 //y=5.2 //x2=5.215 //y2=5.38
cc_308 ( N_VDD_c_281_n N_noxref_4_c_665_n ) capacitor c=0.00159771f //x=2.71 \
 //y=7.585 //x2=5.3 //y2=3.51
cc_309 ( N_VDD_c_282_n N_noxref_4_c_665_n ) capacitor c=0.0454286f //x=6.04 \
 //y=7.585 //x2=5.3 //y2=3.51
cc_310 ( N_VDD_c_288_p N_noxref_4_c_666_n ) capacitor c=0.00157791f //x=19.73 \
 //y=7.58 //x2=6.78 //y2=2.265
cc_311 ( N_VDD_c_282_n N_noxref_4_c_666_n ) capacitor c=0.026597f //x=6.04 \
 //y=7.585 //x2=6.78 //y2=2.265
cc_312 ( N_VDD_c_283_n N_noxref_4_c_666_n ) capacitor c=0.00141507f //x=8.26 \
 //y=7.585 //x2=6.78 //y2=2.265
cc_313 ( N_VDD_M17_noxref_s N_noxref_4_c_666_n ) capacitor c=0.0089782f \
 //x=6.58 //y=5.2 //x2=6.78 //y2=2.265
cc_314 ( N_VDD_c_322_p N_noxref_4_M17_noxref_g ) capacitor c=0.00753931f \
 //x=7.51 //y=7.585 //x2=6.935 //y2=6.2
cc_315 ( N_VDD_c_282_n N_noxref_4_M17_noxref_g ) capacitor c=0.00895557f \
 //x=6.04 //y=7.585 //x2=6.935 //y2=6.2
cc_316 ( N_VDD_M17_noxref_s N_noxref_4_M17_noxref_g ) capacitor c=0.0528676f \
 //x=6.58 //y=5.2 //x2=6.935 //y2=6.2
cc_317 ( N_VDD_c_322_p N_noxref_4_M18_noxref_g ) capacitor c=0.00702238f \
 //x=7.51 //y=7.585 //x2=7.375 //y2=6.2
cc_318 ( N_VDD_M18_noxref_d N_noxref_4_M18_noxref_g ) capacitor c=0.0528676f \
 //x=7.45 //y=5.2 //x2=7.375 //y2=6.2
cc_319 ( N_VDD_c_283_n N_noxref_4_c_705_n ) capacitor c=0.0110053f //x=8.26 \
 //y=7.585 //x2=7.3 //y2=4.97
cc_320 ( N_VDD_c_282_n N_noxref_4_c_706_n ) capacitor c=0.011132f //x=6.04 \
 //y=7.585 //x2=7.01 //y2=4.97
cc_321 ( N_VDD_M17_noxref_s N_noxref_4_c_706_n ) capacitor c=0.00524587f \
 //x=6.58 //y=5.2 //x2=7.01 //y2=4.97
cc_322 ( N_VDD_c_288_p N_noxref_4_M13_noxref_d ) capacitor c=0.00285139f \
 //x=19.73 //y=7.58 //x2=3.795 //y2=5.2
cc_323 ( N_VDD_c_295_p N_noxref_4_M13_noxref_d ) capacitor c=0.0141209f \
 //x=4.295 //y=7.585 //x2=3.795 //y2=5.2
cc_324 ( N_VDD_c_282_n N_noxref_4_M13_noxref_d ) capacitor c=6.94454e-19 \
 //x=6.04 //y=7.585 //x2=3.795 //y2=5.2
cc_325 ( N_VDD_M14_noxref_d N_noxref_4_M13_noxref_d ) capacitor c=0.0664752f \
 //x=4.235 //y=5.2 //x2=3.795 //y2=5.2
cc_326 ( N_VDD_c_288_p N_noxref_4_M15_noxref_d ) capacitor c=0.00285139f \
 //x=19.73 //y=7.58 //x2=4.675 //y2=5.2
cc_327 ( N_VDD_c_309_p N_noxref_4_M15_noxref_d ) capacitor c=0.0141209f \
 //x=5.175 //y=7.585 //x2=4.675 //y2=5.2
cc_328 ( N_VDD_c_282_n N_noxref_4_M15_noxref_d ) capacitor c=0.0120541f \
 //x=6.04 //y=7.585 //x2=4.675 //y2=5.2
cc_329 ( N_VDD_M13_noxref_s N_noxref_4_M15_noxref_d ) capacitor c=0.00111971f \
 //x=3.365 //y=5.2 //x2=4.675 //y2=5.2
cc_330 ( N_VDD_M14_noxref_d N_noxref_4_M15_noxref_d ) capacitor c=0.0664752f \
 //x=4.235 //y=5.2 //x2=4.675 //y2=5.2
cc_331 ( N_VDD_M16_noxref_d N_noxref_4_M15_noxref_d ) capacitor c=0.0664752f \
 //x=5.115 //y=5.2 //x2=4.675 //y2=5.2
cc_332 ( N_VDD_M17_noxref_s N_noxref_4_M15_noxref_d ) capacitor c=5.1407e-19 \
 //x=6.58 //y=5.2 //x2=4.675 //y2=5.2
cc_333 ( N_VDD_c_281_n N_GATE_c_807_n ) capacitor c=6.52727e-19 //x=2.71 \
 //y=7.585 //x2=4.56 //y2=2.26
cc_334 ( N_VDD_c_282_n N_GATE_c_807_n ) capacitor c=5.44923e-19 //x=6.04 \
 //y=7.585 //x2=4.56 //y2=2.26
cc_335 ( N_VDD_c_288_p N_GATE_c_809_n ) capacitor c=0.00126176f //x=19.73 \
 //y=7.58 //x2=9.37 //y2=2.26
cc_336 ( N_VDD_c_344_p N_GATE_c_809_n ) capacitor c=2.88573e-19 //x=9.845 \
 //y=7.585 //x2=9.37 //y2=2.26
cc_337 ( N_VDD_c_283_n N_GATE_c_809_n ) capacitor c=0.0160121f //x=8.26 \
 //y=7.585 //x2=9.37 //y2=2.26
cc_338 ( N_VDD_c_309_p N_GATE_M15_noxref_g ) capacitor c=0.00678607f //x=5.175 \
 //y=7.585 //x2=4.6 //y2=6.2
cc_339 ( N_VDD_M14_noxref_d N_GATE_M15_noxref_g ) capacitor c=0.015318f \
 //x=4.235 //y=5.2 //x2=4.6 //y2=6.2
cc_340 ( N_VDD_c_309_p N_GATE_M16_noxref_g ) capacitor c=0.00677553f //x=5.175 \
 //y=7.585 //x2=5.04 //y2=6.2
cc_341 ( N_VDD_c_282_n N_GATE_M16_noxref_g ) capacitor c=0.00904525f //x=6.04 \
 //y=7.585 //x2=5.04 //y2=6.2
cc_342 ( N_VDD_M16_noxref_d N_GATE_M16_noxref_g ) capacitor c=0.0430452f \
 //x=5.115 //y=5.2 //x2=5.04 //y2=6.2
cc_343 ( N_VDD_c_344_p N_GATE_M19_noxref_g ) capacitor c=0.00732332f //x=9.845 \
 //y=7.585 //x2=9.27 //y2=6.2
cc_344 ( N_VDD_M19_noxref_s N_GATE_M19_noxref_g ) capacitor c=0.054195f \
 //x=8.915 //y=5.2 //x2=9.27 //y2=6.2
cc_345 ( N_VDD_c_344_p N_GATE_M20_noxref_g ) capacitor c=0.00677553f //x=9.845 \
 //y=7.585 //x2=9.71 //y2=6.2
cc_346 ( N_VDD_M20_noxref_d N_GATE_M20_noxref_g ) capacitor c=0.015318f \
 //x=9.785 //y=5.2 //x2=9.71 //y2=6.2
cc_347 ( N_VDD_c_283_n N_GATE_c_833_n ) capacitor c=0.012849f //x=8.26 \
 //y=7.585 //x2=9.37 //y2=4.88
cc_348 ( N_VDD_c_288_p N_D_c_958_n ) capacitor c=0.0594951f //x=19.73 //y=7.58 \
 //x2=9.995 //y2=4.25
cc_349 ( N_VDD_c_289_p N_D_c_958_n ) capacitor c=9.77383e-19 //x=1.96 \
 //y=7.585 //x2=9.995 //y2=4.25
cc_350 ( N_VDD_c_358_p N_D_c_958_n ) capacitor c=0.00124324f //x=2.54 \
 //y=7.585 //x2=9.995 //y2=4.25
cc_351 ( N_VDD_c_359_p N_D_c_958_n ) capacitor c=0.00172127f //x=3.415 \
 //y=7.585 //x2=9.995 //y2=4.25
cc_352 ( N_VDD_c_295_p N_D_c_958_n ) capacitor c=6.61227e-19 //x=4.295 \
 //y=7.585 //x2=9.995 //y2=4.25
cc_353 ( N_VDD_c_361_p N_D_c_958_n ) capacitor c=0.00168633f //x=5.87 \
 //y=7.585 //x2=9.995 //y2=4.25
cc_354 ( N_VDD_c_362_p N_D_c_958_n ) capacitor c=0.00128334f //x=6.63 \
 //y=7.585 //x2=9.995 //y2=4.25
cc_355 ( N_VDD_c_322_p N_D_c_958_n ) capacitor c=0.00111964f //x=7.51 \
 //y=7.585 //x2=9.995 //y2=4.25
cc_356 ( N_VDD_c_364_p N_D_c_958_n ) capacitor c=0.00124324f //x=8.09 \
 //y=7.585 //x2=9.995 //y2=4.25
cc_357 ( N_VDD_c_365_p N_D_c_958_n ) capacitor c=0.00172127f //x=8.965 \
 //y=7.585 //x2=9.995 //y2=4.25
cc_358 ( N_VDD_c_344_p N_D_c_958_n ) capacitor c=6.61227e-19 //x=9.845 \
 //y=7.585 //x2=9.995 //y2=4.25
cc_359 ( N_VDD_c_281_n N_D_c_958_n ) capacitor c=0.0269493f //x=2.71 //y=7.585 \
 //x2=9.995 //y2=4.25
cc_360 ( N_VDD_c_282_n N_D_c_958_n ) capacitor c=0.0269011f //x=6.04 //y=7.585 \
 //x2=9.995 //y2=4.25
cc_361 ( N_VDD_c_283_n N_D_c_958_n ) capacitor c=0.0269493f //x=8.26 //y=7.585 \
 //x2=9.995 //y2=4.25
cc_362 ( N_VDD_M12_noxref_d N_D_c_958_n ) capacitor c=0.00213864f //x=1.9 \
 //y=5.2 //x2=9.995 //y2=4.25
cc_363 ( N_VDD_M13_noxref_s N_D_c_958_n ) capacitor c=0.00363045f //x=3.365 \
 //y=5.2 //x2=9.995 //y2=4.25
cc_364 ( N_VDD_M16_noxref_d N_D_c_958_n ) capacitor c=5.05316e-19 //x=5.115 \
 //y=5.2 //x2=9.995 //y2=4.25
cc_365 ( N_VDD_M17_noxref_s N_D_c_958_n ) capacitor c=0.00191095f //x=6.58 \
 //y=5.2 //x2=9.995 //y2=4.25
cc_366 ( N_VDD_M18_noxref_d N_D_c_958_n ) capacitor c=0.00213864f //x=7.45 \
 //y=5.2 //x2=9.995 //y2=4.25
cc_367 ( N_VDD_M19_noxref_s N_D_c_958_n ) capacitor c=0.00363045f //x=8.915 \
 //y=5.2 //x2=9.995 //y2=4.25
cc_368 ( N_VDD_c_288_p N_D_c_959_n ) capacitor c=0.001884f //x=19.73 //y=7.58 \
 //x2=1.345 //y2=4.25
cc_369 ( N_VDD_c_280_n N_D_c_959_n ) capacitor c=0.00238507f //x=1.23 //y=7.58 \
 //x2=1.345 //y2=4.25
cc_370 ( N_VDD_M11_noxref_s N_D_c_959_n ) capacitor c=0.00185033f //x=1.03 \
 //y=5.2 //x2=1.345 //y2=4.25
cc_371 ( N_VDD_c_288_p N_D_c_961_n ) capacitor c=0.00157688f //x=19.73 \
 //y=7.58 //x2=1.23 //y2=2.265
cc_372 ( N_VDD_c_280_n N_D_c_961_n ) capacitor c=0.0272385f //x=1.23 //y=7.58 \
 //x2=1.23 //y2=2.265
cc_373 ( N_VDD_c_281_n N_D_c_961_n ) capacitor c=0.00139956f //x=2.71 \
 //y=7.585 //x2=1.23 //y2=2.265
cc_374 ( N_VDD_M11_noxref_s N_D_c_961_n ) capacitor c=0.00896399f //x=1.03 \
 //y=5.2 //x2=1.23 //y2=2.265
cc_375 ( N_VDD_c_283_n N_D_c_966_n ) capacitor c=6.2696e-19 //x=8.26 //y=7.585 \
 //x2=10.11 //y2=2.26
cc_376 ( N_VDD_c_284_n N_D_c_966_n ) capacitor c=6.61994e-19 //x=11.59 \
 //y=7.585 //x2=10.11 //y2=2.26
cc_377 ( N_VDD_c_289_p N_D_M11_noxref_g ) capacitor c=0.00753931f //x=1.96 \
 //y=7.585 //x2=1.385 //y2=6.2
cc_378 ( N_VDD_c_280_n N_D_M11_noxref_g ) capacitor c=0.0241676f //x=1.23 \
 //y=7.58 //x2=1.385 //y2=6.2
cc_379 ( N_VDD_M11_noxref_s N_D_M11_noxref_g ) capacitor c=0.0528676f //x=1.03 \
 //y=5.2 //x2=1.385 //y2=6.2
cc_380 ( N_VDD_c_289_p N_D_M12_noxref_g ) capacitor c=0.00702238f //x=1.96 \
 //y=7.585 //x2=1.825 //y2=6.2
cc_381 ( N_VDD_M12_noxref_d N_D_M12_noxref_g ) capacitor c=0.0528676f //x=1.9 \
 //y=5.2 //x2=1.825 //y2=6.2
cc_382 ( N_VDD_c_390_p N_D_M21_noxref_g ) capacitor c=0.00678607f //x=10.725 \
 //y=7.585 //x2=10.15 //y2=6.2
cc_383 ( N_VDD_M20_noxref_d N_D_M21_noxref_g ) capacitor c=0.015318f //x=9.785 \
 //y=5.2 //x2=10.15 //y2=6.2
cc_384 ( N_VDD_c_390_p N_D_M22_noxref_g ) capacitor c=0.00677553f //x=10.725 \
 //y=7.585 //x2=10.59 //y2=6.2
cc_385 ( N_VDD_c_284_n N_D_M22_noxref_g ) capacitor c=0.00904525f //x=11.59 \
 //y=7.585 //x2=10.59 //y2=6.2
cc_386 ( N_VDD_M22_noxref_d N_D_M22_noxref_g ) capacitor c=0.0430452f \
 //x=10.665 //y=5.2 //x2=10.59 //y2=6.2
cc_387 ( N_VDD_c_281_n N_D_c_1017_n ) capacitor c=0.0110053f //x=2.71 \
 //y=7.585 //x2=1.75 //y2=4.97
cc_388 ( N_VDD_c_280_n N_D_c_1018_n ) capacitor c=0.011132f //x=1.23 //y=7.58 \
 //x2=1.46 //y2=4.97
cc_389 ( N_VDD_M11_noxref_s N_D_c_1018_n ) capacitor c=0.00524561f //x=1.03 \
 //y=5.2 //x2=1.46 //y2=4.97
cc_390 ( N_VDD_c_288_p N_noxref_7_c_1164_n ) capacitor c=0.00459998f //x=19.73 \
 //y=7.58 //x2=10.285 //y2=5.38
cc_391 ( N_VDD_c_344_p N_noxref_7_c_1164_n ) capacitor c=4.49205e-19 //x=9.845 \
 //y=7.585 //x2=10.285 //y2=5.38
cc_392 ( N_VDD_c_390_p N_noxref_7_c_1164_n ) capacitor c=4.49193e-19 \
 //x=10.725 //y=7.585 //x2=10.285 //y2=5.38
cc_393 ( N_VDD_M20_noxref_d N_noxref_7_c_1164_n ) capacitor c=0.0126907f \
 //x=9.785 //y=5.2 //x2=10.285 //y2=5.38
cc_394 ( N_VDD_c_283_n N_noxref_7_c_1168_n ) capacitor c=0.00985474f //x=8.26 \
 //y=7.585 //x2=9.575 //y2=5.38
cc_395 ( N_VDD_M19_noxref_s N_noxref_7_c_1168_n ) capacitor c=0.087833f \
 //x=8.915 //y=5.2 //x2=9.575 //y2=5.38
cc_396 ( N_VDD_c_288_p N_noxref_7_c_1170_n ) capacitor c=0.00312262f //x=19.73 \
 //y=7.58 //x2=10.765 //y2=5.38
cc_397 ( N_VDD_c_390_p N_noxref_7_c_1170_n ) capacitor c=7.22416e-19 \
 //x=10.725 //y=7.585 //x2=10.765 //y2=5.38
cc_398 ( N_VDD_M22_noxref_d N_noxref_7_c_1170_n ) capacitor c=0.0163548f \
 //x=10.665 //y=5.2 //x2=10.765 //y2=5.38
cc_399 ( N_VDD_c_283_n N_noxref_7_c_1144_n ) capacitor c=0.00159771f //x=8.26 \
 //y=7.585 //x2=10.85 //y2=3.51
cc_400 ( N_VDD_c_284_n N_noxref_7_c_1144_n ) capacitor c=0.0457825f //x=11.59 \
 //y=7.585 //x2=10.85 //y2=3.51
cc_401 ( N_VDD_c_288_p N_noxref_7_c_1145_n ) capacitor c=0.00159012f //x=19.73 \
 //y=7.58 //x2=12.33 //y2=2.265
cc_402 ( N_VDD_c_284_n N_noxref_7_c_1145_n ) capacitor c=0.0269509f //x=11.59 \
 //y=7.585 //x2=12.33 //y2=2.265
cc_403 ( N_VDD_c_285_n N_noxref_7_c_1145_n ) capacitor c=0.00151144f //x=13.81 \
 //y=7.585 //x2=12.33 //y2=2.265
cc_404 ( N_VDD_M23_noxref_s N_noxref_7_c_1145_n ) capacitor c=0.00942294f \
 //x=12.13 //y=5.2 //x2=12.33 //y2=2.265
cc_405 ( N_VDD_c_413_p N_noxref_7_M23_noxref_g ) capacitor c=0.00753931f \
 //x=13.06 //y=7.585 //x2=12.485 //y2=6.2
cc_406 ( N_VDD_c_284_n N_noxref_7_M23_noxref_g ) capacitor c=0.00895557f \
 //x=11.59 //y=7.585 //x2=12.485 //y2=6.2
cc_407 ( N_VDD_M23_noxref_s N_noxref_7_M23_noxref_g ) capacitor c=0.0528676f \
 //x=12.13 //y=5.2 //x2=12.485 //y2=6.2
cc_408 ( N_VDD_c_413_p N_noxref_7_M24_noxref_g ) capacitor c=0.00702238f \
 //x=13.06 //y=7.585 //x2=12.925 //y2=6.2
cc_409 ( N_VDD_M24_noxref_d N_noxref_7_M24_noxref_g ) capacitor c=0.0528676f \
 //x=13 //y=5.2 //x2=12.925 //y2=6.2
cc_410 ( N_VDD_c_285_n N_noxref_7_c_1184_n ) capacitor c=0.012136f //x=13.81 \
 //y=7.585 //x2=12.85 //y2=4.97
cc_411 ( N_VDD_c_284_n N_noxref_7_c_1185_n ) capacitor c=0.011132f //x=11.59 \
 //y=7.585 //x2=12.56 //y2=4.97
cc_412 ( N_VDD_M23_noxref_s N_noxref_7_c_1185_n ) capacitor c=0.0052728f \
 //x=12.13 //y=5.2 //x2=12.56 //y2=4.97
cc_413 ( N_VDD_c_288_p N_noxref_7_M19_noxref_d ) capacitor c=0.00285139f \
 //x=19.73 //y=7.58 //x2=9.345 //y2=5.2
cc_414 ( N_VDD_c_344_p N_noxref_7_M19_noxref_d ) capacitor c=0.0141209f \
 //x=9.845 //y=7.585 //x2=9.345 //y2=5.2
cc_415 ( N_VDD_c_284_n N_noxref_7_M19_noxref_d ) capacitor c=6.94454e-19 \
 //x=11.59 //y=7.585 //x2=9.345 //y2=5.2
cc_416 ( N_VDD_M20_noxref_d N_noxref_7_M19_noxref_d ) capacitor c=0.0664752f \
 //x=9.785 //y=5.2 //x2=9.345 //y2=5.2
cc_417 ( N_VDD_c_288_p N_noxref_7_M21_noxref_d ) capacitor c=0.00294258f \
 //x=19.73 //y=7.58 //x2=10.225 //y2=5.2
cc_418 ( N_VDD_c_390_p N_noxref_7_M21_noxref_d ) capacitor c=0.0138783f \
 //x=10.725 //y=7.585 //x2=10.225 //y2=5.2
cc_419 ( N_VDD_c_284_n N_noxref_7_M21_noxref_d ) capacitor c=0.0120541f \
 //x=11.59 //y=7.585 //x2=10.225 //y2=5.2
cc_420 ( N_VDD_M19_noxref_s N_noxref_7_M21_noxref_d ) capacitor c=0.00111971f \
 //x=8.915 //y=5.2 //x2=10.225 //y2=5.2
cc_421 ( N_VDD_M20_noxref_d N_noxref_7_M21_noxref_d ) capacitor c=0.0664752f \
 //x=9.785 //y=5.2 //x2=10.225 //y2=5.2
cc_422 ( N_VDD_M22_noxref_d N_noxref_7_M21_noxref_d ) capacitor c=0.0664752f \
 //x=10.665 //y=5.2 //x2=10.225 //y2=5.2
cc_423 ( N_VDD_M23_noxref_s N_noxref_7_M21_noxref_d ) capacitor c=5.1407e-19 \
 //x=12.13 //y=5.2 //x2=10.225 //y2=5.2
cc_424 ( N_VDD_c_288_p N_noxref_8_c_1274_n ) capacitor c=0.0313108f //x=19.73 \
 //y=7.58 //x2=14.805 //y2=3.88
cc_425 ( N_VDD_c_284_n N_noxref_8_c_1274_n ) capacitor c=0.0109526f //x=11.59 \
 //y=7.585 //x2=14.805 //y2=3.88
cc_426 ( N_VDD_c_285_n N_noxref_8_c_1274_n ) capacitor c=0.00290918f //x=13.81 \
 //y=7.585 //x2=14.805 //y2=3.88
cc_427 ( N_VDD_M22_noxref_d N_noxref_8_c_1274_n ) capacitor c=4.00443e-19 \
 //x=10.665 //y=5.2 //x2=14.805 //y2=3.88
cc_428 ( N_VDD_M23_noxref_s N_noxref_8_c_1274_n ) capacitor c=0.00141988f \
 //x=12.13 //y=5.2 //x2=14.805 //y2=3.88
cc_429 ( N_VDD_c_288_p N_noxref_8_c_1305_n ) capacitor c=0.00122938f //x=19.73 \
 //y=7.58 //x2=7.435 //y2=4.76
cc_430 ( N_VDD_c_322_p N_noxref_8_c_1305_n ) capacitor c=9.09621e-19 //x=7.51 \
 //y=7.585 //x2=7.435 //y2=4.76
cc_431 ( N_VDD_M18_noxref_d N_noxref_8_c_1305_n ) capacitor c=0.00609295f \
 //x=7.45 //y=5.2 //x2=7.435 //y2=4.76
cc_432 ( N_VDD_c_282_n N_noxref_8_c_1308_n ) capacitor c=0.017572f //x=6.04 \
 //y=7.585 //x2=7.24 //y2=4.76
cc_433 ( N_VDD_c_282_n N_noxref_8_c_1283_n ) capacitor c=4.16331e-19 //x=6.04 \
 //y=7.585 //x2=7.52 //y2=3.88
cc_434 ( N_VDD_c_283_n N_noxref_8_c_1283_n ) capacitor c=0.0221565f //x=8.26 \
 //y=7.585 //x2=7.52 //y2=3.88
cc_435 ( N_VDD_c_285_n N_noxref_8_c_1284_n ) capacitor c=0.00965534f //x=13.81 \
 //y=7.585 //x2=14.92 //y2=2.26
cc_436 ( N_VDD_c_288_p N_noxref_8_c_1312_n ) capacitor c=2.76902e-19 //x=19.73 \
 //y=7.58 //x2=14.765 //y2=4.885
cc_437 ( N_VDD_c_285_n N_noxref_8_c_1312_n ) capacitor c=0.00860173f //x=13.81 \
 //y=7.585 //x2=14.765 //y2=4.885
cc_438 ( N_VDD_M25_noxref_d N_noxref_8_c_1312_n ) capacitor c=3.42955e-19 \
 //x=14.895 //y=5.205 //x2=14.765 //y2=4.885
cc_439 ( N_VDD_c_447_p N_noxref_8_M25_noxref_g ) capacitor c=0.00683851f \
 //x=14.955 //y=7.585 //x2=14.82 //y2=6.205
cc_440 ( N_VDD_c_285_n N_noxref_8_M25_noxref_g ) capacitor c=0.00730892f \
 //x=13.81 //y=7.585 //x2=14.82 //y2=6.205
cc_441 ( N_VDD_M25_noxref_d N_noxref_8_M25_noxref_g ) capacitor c=0.0156786f \
 //x=14.895 //y=5.205 //x2=14.82 //y2=6.205
cc_442 ( N_VDD_c_450_p N_noxref_8_M26_noxref_g ) capacitor c=0.0068279f \
 //x=16.97 //y=7.585 //x2=15.26 //y2=6.205
cc_443 ( N_VDD_M25_noxref_d N_noxref_8_M26_noxref_g ) capacitor c=0.0183011f \
 //x=14.895 //y=5.205 //x2=15.26 //y2=6.205
cc_444 ( N_VDD_c_285_n N_noxref_8_c_1320_n ) capacitor c=0.00890932f //x=13.81 \
 //y=7.585 //x2=14.765 //y2=4.885
cc_445 ( N_VDD_c_288_p N_noxref_8_M17_noxref_d ) capacitor c=0.00285234f \
 //x=19.73 //y=7.58 //x2=7.01 //y2=5.2
cc_446 ( N_VDD_c_322_p N_noxref_8_M17_noxref_d ) capacitor c=0.0141568f \
 //x=7.51 //y=7.585 //x2=7.01 //y2=5.2
cc_447 ( N_VDD_c_283_n N_noxref_8_M17_noxref_d ) capacitor c=0.0204591f \
 //x=8.26 //y=7.585 //x2=7.01 //y2=5.2
cc_448 ( N_VDD_M17_noxref_s N_noxref_8_M17_noxref_d ) capacitor c=0.0843065f \
 //x=6.58 //y=5.2 //x2=7.01 //y2=5.2
cc_449 ( N_VDD_M18_noxref_d N_noxref_8_M17_noxref_d ) capacitor c=0.0832641f \
 //x=7.45 //y=5.2 //x2=7.01 //y2=5.2
cc_450 ( N_VDD_c_285_n Q ) capacitor c=0.00163766f //x=13.81 //y=7.585 \
 //x2=16.4 //y2=2.4
cc_451 ( N_VDD_c_286_n Q ) capacitor c=0.0456569f //x=17.14 //y=7.585 \
 //x2=16.4 //y2=2.4
cc_452 ( N_VDD_c_288_p N_Q_c_1476_n ) capacitor c=0.00162098f //x=19.73 \
 //y=7.58 //x2=16.315 //y2=5.39
cc_453 ( N_VDD_c_450_p N_Q_c_1476_n ) capacitor c=0.00139575f //x=16.97 \
 //y=7.585 //x2=16.315 //y2=5.39
cc_454 ( N_VDD_c_285_n N_Q_c_1478_n ) capacitor c=8.9933e-19 //x=13.81 \
 //y=7.585 //x2=16.005 //y2=5.39
cc_455 ( N_VDD_c_286_n N_Q_c_1456_n ) capacitor c=0.00965391f //x=17.14 \
 //y=7.585 //x2=18.25 //y2=2.26
cc_456 ( N_VDD_c_288_p N_Q_c_1480_n ) capacitor c=2.76902e-19 //x=19.73 \
 //y=7.58 //x2=18.095 //y2=4.885
cc_457 ( N_VDD_c_286_n N_Q_c_1480_n ) capacitor c=0.00860173f //x=17.14 \
 //y=7.585 //x2=18.095 //y2=4.885
cc_458 ( N_VDD_M29_noxref_d N_Q_c_1480_n ) capacitor c=3.42955e-19 //x=18.225 \
 //y=5.205 //x2=18.095 //y2=4.885
cc_459 ( N_VDD_c_467_p N_Q_M29_noxref_g ) capacitor c=0.00683851f //x=18.285 \
 //y=7.585 //x2=18.15 //y2=6.205
cc_460 ( N_VDD_c_286_n N_Q_M29_noxref_g ) capacitor c=0.00966601f //x=17.14 \
 //y=7.585 //x2=18.15 //y2=6.205
cc_461 ( N_VDD_M29_noxref_d N_Q_M29_noxref_g ) capacitor c=0.0156786f \
 //x=18.225 //y=5.205 //x2=18.15 //y2=6.205
cc_462 ( N_VDD_c_279_n N_Q_M30_noxref_g ) capacitor c=0.0068279f //x=19.73 \
 //y=7.58 //x2=18.59 //y2=6.205
cc_463 ( N_VDD_M29_noxref_d N_Q_M30_noxref_g ) capacitor c=0.0183011f \
 //x=18.225 //y=5.205 //x2=18.59 //y2=6.205
cc_464 ( N_VDD_c_286_n N_Q_c_1488_n ) capacitor c=0.00890932f //x=17.14 \
 //y=7.585 //x2=18.095 //y2=4.885
cc_465 ( N_VDD_c_286_n N_Q_M27_noxref_d ) capacitor c=0.00966019f //x=17.14 \
 //y=7.585 //x2=15.775 //y2=5.205
cc_466 ( N_VDD_M25_noxref_d N_Q_M27_noxref_d ) capacitor c=0.00561178f \
 //x=14.895 //y=5.205 //x2=15.775 //y2=5.205
cc_467 ( N_VDD_c_288_p N_noxref_10_c_1605_n ) capacitor c=0.039275f //x=19.73 \
 //y=7.58 //x2=18.875 //y2=4.25
cc_468 ( N_VDD_c_476_p N_noxref_10_c_1605_n ) capacitor c=0.00124324f \
 //x=13.64 //y=7.585 //x2=18.875 //y2=4.25
cc_469 ( N_VDD_c_447_p N_noxref_10_c_1605_n ) capacitor c=0.00213587f \
 //x=14.955 //y=7.585 //x2=18.875 //y2=4.25
cc_470 ( N_VDD_c_450_p N_noxref_10_c_1605_n ) capacitor c=0.00239586f \
 //x=16.97 //y=7.585 //x2=18.875 //y2=4.25
cc_471 ( N_VDD_c_467_p N_noxref_10_c_1605_n ) capacitor c=0.00213587f \
 //x=18.285 //y=7.585 //x2=18.875 //y2=4.25
cc_472 ( N_VDD_c_285_n N_noxref_10_c_1605_n ) capacitor c=0.0269493f //x=13.81 \
 //y=7.585 //x2=18.875 //y2=4.25
cc_473 ( N_VDD_c_286_n N_noxref_10_c_1605_n ) capacitor c=0.0269493f //x=17.14 \
 //y=7.585 //x2=18.875 //y2=4.25
cc_474 ( N_VDD_M24_noxref_d N_noxref_10_c_1605_n ) capacitor c=9.09749e-19 \
 //x=13 //y=5.2 //x2=18.875 //y2=4.25
cc_475 ( N_VDD_c_288_p N_noxref_10_c_1631_n ) capacitor c=0.00187427f \
 //x=19.73 //y=7.58 //x2=13.185 //y2=4.25
cc_476 ( N_VDD_c_285_n N_noxref_10_c_1631_n ) capacitor c=0.00104972f \
 //x=13.81 //y=7.585 //x2=13.185 //y2=4.25
cc_477 ( N_VDD_M24_noxref_d N_noxref_10_c_1631_n ) capacitor c=0.00130587f \
 //x=13 //y=5.2 //x2=13.185 //y2=4.25
cc_478 ( N_VDD_c_288_p N_noxref_10_c_1634_n ) capacitor c=0.0012368f //x=19.73 \
 //y=7.58 //x2=12.985 //y2=4.76
cc_479 ( N_VDD_c_413_p N_noxref_10_c_1634_n ) capacitor c=8.86824e-19 \
 //x=13.06 //y=7.585 //x2=12.985 //y2=4.76
cc_480 ( N_VDD_M24_noxref_d N_noxref_10_c_1634_n ) capacitor c=0.00572963f \
 //x=13 //y=5.2 //x2=12.985 //y2=4.76
cc_481 ( N_VDD_c_284_n N_noxref_10_c_1637_n ) capacitor c=0.017572f //x=11.59 \
 //y=7.585 //x2=12.79 //y2=4.76
cc_482 ( N_VDD_c_284_n N_noxref_10_c_1609_n ) capacitor c=5.33401e-19 \
 //x=11.59 //y=7.585 //x2=13.07 //y2=4.25
cc_483 ( N_VDD_c_285_n N_noxref_10_c_1609_n ) capacitor c=0.0225488f //x=13.81 \
 //y=7.585 //x2=13.07 //y2=4.25
cc_484 ( N_VDD_c_279_n N_noxref_10_c_1610_n ) capacitor c=6.69172e-19 \
 //x=19.73 //y=7.58 //x2=18.99 //y2=2.26
cc_485 ( N_VDD_c_286_n N_noxref_10_c_1610_n ) capacitor c=6.68284e-19 \
 //x=17.14 //y=7.585 //x2=18.99 //y2=2.26
cc_486 ( N_VDD_c_279_n N_noxref_10_M31_noxref_g ) capacitor c=0.00516984f \
 //x=19.73 //y=7.58 //x2=19.03 //y2=6.205
cc_487 ( N_VDD_c_279_n N_noxref_10_M32_noxref_g ) capacitor c=0.0322627f \
 //x=19.73 //y=7.58 //x2=19.47 //y2=6.205
cc_488 ( N_VDD_c_288_p N_noxref_10_M23_noxref_d ) capacitor c=0.00294329f \
 //x=19.73 //y=7.58 //x2=12.56 //y2=5.2
cc_489 ( N_VDD_c_413_p N_noxref_10_M23_noxref_d ) capacitor c=0.0139426f \
 //x=13.06 //y=7.585 //x2=12.56 //y2=5.2
cc_490 ( N_VDD_c_285_n N_noxref_10_M23_noxref_d ) capacitor c=0.0204646f \
 //x=13.81 //y=7.585 //x2=12.56 //y2=5.2
cc_491 ( N_VDD_M23_noxref_s N_noxref_10_M23_noxref_d ) capacitor c=0.0843065f \
 //x=12.13 //y=5.2 //x2=12.56 //y2=5.2
cc_492 ( N_VDD_M24_noxref_d N_noxref_10_M23_noxref_d ) capacitor c=0.0832641f \
 //x=13 //y=5.2 //x2=12.56 //y2=5.2
cc_493 ( N_VDD_c_288_p N_noxref_11_c_1767_n ) capacitor c=0.0161517f //x=19.73 \
 //y=7.58 //x2=19.615 //y2=3.88
cc_494 ( N_VDD_c_285_n N_noxref_11_c_1770_n ) capacitor c=6.93509e-19 \
 //x=13.81 //y=7.585 //x2=15.66 //y2=2.26
cc_495 ( N_VDD_c_286_n N_noxref_11_c_1770_n ) capacitor c=5.88692e-19 \
 //x=17.14 //y=7.585 //x2=15.66 //y2=2.26
cc_496 ( N_VDD_c_288_p N_noxref_11_c_1797_n ) capacitor c=0.00162432f \
 //x=19.73 //y=7.58 //x2=19.645 //y2=5.39
cc_497 ( N_VDD_c_279_n N_noxref_11_c_1797_n ) capacitor c=0.00137054f \
 //x=19.73 //y=7.58 //x2=19.645 //y2=5.39
cc_498 ( N_VDD_c_286_n N_noxref_11_c_1799_n ) capacitor c=8.9933e-19 //x=17.14 \
 //y=7.585 //x2=19.335 //y2=5.39
cc_499 ( N_VDD_c_279_n N_noxref_11_c_1780_n ) capacitor c=0.0467856f //x=19.73 \
 //y=7.58 //x2=19.73 //y2=3.88
cc_500 ( N_VDD_c_286_n N_noxref_11_c_1780_n ) capacitor c=0.00155409f \
 //x=17.14 //y=7.585 //x2=19.73 //y2=3.88
cc_501 ( N_VDD_c_450_p N_noxref_11_M27_noxref_g ) capacitor c=0.00516984f \
 //x=16.97 //y=7.585 //x2=15.7 //y2=6.205
cc_502 ( N_VDD_c_450_p N_noxref_11_M28_noxref_g ) capacitor c=0.00515938f \
 //x=16.97 //y=7.585 //x2=16.14 //y2=6.205
cc_503 ( N_VDD_c_286_n N_noxref_11_M28_noxref_g ) capacitor c=0.010456f \
 //x=17.14 //y=7.585 //x2=16.14 //y2=6.205
cc_504 ( N_VDD_c_279_n N_noxref_11_M31_noxref_d ) capacitor c=0.00991513f \
 //x=19.73 //y=7.58 //x2=19.105 //y2=5.205
cc_505 ( N_VDD_M29_noxref_d N_noxref_11_M31_noxref_d ) capacitor c=0.00561178f \
 //x=18.225 //y=5.205 //x2=19.105 //y2=5.205
cc_506 ( N_VDD_c_288_p N_noxref_14_c_2038_n ) capacitor c=0.00453074f \
 //x=19.73 //y=7.58 //x2=15.395 //y2=5.39
cc_507 ( N_VDD_c_447_p N_noxref_14_c_2038_n ) capacitor c=4.53029e-19 \
 //x=14.955 //y=7.585 //x2=15.395 //y2=5.39
cc_508 ( N_VDD_c_450_p N_noxref_14_c_2038_n ) capacitor c=4.53029e-19 \
 //x=16.97 //y=7.585 //x2=15.395 //y2=5.39
cc_509 ( N_VDD_c_286_n N_noxref_14_c_2038_n ) capacitor c=0.00289291f \
 //x=17.14 //y=7.585 //x2=15.395 //y2=5.39
cc_510 ( N_VDD_M25_noxref_d N_noxref_14_c_2038_n ) capacitor c=0.0125692f \
 //x=14.895 //y=5.205 //x2=15.395 //y2=5.39
cc_511 ( N_VDD_c_285_n N_noxref_14_c_2043_n ) capacitor c=0.0669114f //x=13.81 \
 //y=7.585 //x2=14.685 //y2=5.39
cc_512 ( N_VDD_M24_noxref_d N_noxref_14_c_2043_n ) capacitor c=0.00289186f \
 //x=13 //y=5.2 //x2=14.685 //y2=5.39
cc_513 ( N_VDD_c_279_n N_noxref_14_c_2045_n ) capacitor c=0.0024277f //x=19.73 \
 //y=7.58 //x2=16.275 //y2=7.09
cc_514 ( N_VDD_c_288_p N_noxref_14_c_2046_n ) capacitor c=0.0170507f //x=19.73 \
 //y=7.58 //x2=15.565 //y2=7.09
cc_515 ( N_VDD_c_450_p N_noxref_14_c_2046_n ) capacitor c=0.0617392f //x=16.97 \
 //y=7.585 //x2=15.565 //y2=7.09
cc_516 ( N_VDD_c_288_p N_noxref_14_M25_noxref_s ) capacitor c=0.00287776f \
 //x=19.73 //y=7.58 //x2=14.465 //y2=5.205
cc_517 ( N_VDD_c_447_p N_noxref_14_M25_noxref_s ) capacitor c=0.0144012f \
 //x=14.955 //y=7.585 //x2=14.465 //y2=5.205
cc_518 ( N_VDD_M25_noxref_d N_noxref_14_M25_noxref_s ) capacitor c=0.0667021f \
 //x=14.895 //y=5.205 //x2=14.465 //y2=5.205
cc_519 ( N_VDD_c_285_n N_noxref_14_M26_noxref_d ) capacitor c=8.88629e-19 \
 //x=13.81 //y=7.585 //x2=15.335 //y2=5.205
cc_520 ( N_VDD_M25_noxref_d N_noxref_14_M26_noxref_d ) capacitor c=0.0659925f \
 //x=14.895 //y=5.205 //x2=15.335 //y2=5.205
cc_521 ( N_VDD_c_286_n N_noxref_14_M28_noxref_d ) capacitor c=0.0520312f \
 //x=17.14 //y=7.585 //x2=16.215 //y2=5.205
cc_522 ( N_VDD_M25_noxref_d N_noxref_14_M28_noxref_d ) capacitor c=0.00107819f \
 //x=14.895 //y=5.205 //x2=16.215 //y2=5.205
cc_523 ( N_VDD_c_288_p N_noxref_15_c_2081_n ) capacitor c=0.00453074f \
 //x=19.73 //y=7.58 //x2=18.725 //y2=5.39
cc_524 ( N_VDD_c_467_p N_noxref_15_c_2081_n ) capacitor c=4.53029e-19 \
 //x=18.285 //y=7.585 //x2=18.725 //y2=5.39
cc_525 ( N_VDD_c_279_n N_noxref_15_c_2081_n ) capacitor c=0.00334594f \
 //x=19.73 //y=7.58 //x2=18.725 //y2=5.39
cc_526 ( N_VDD_M29_noxref_d N_noxref_15_c_2081_n ) capacitor c=0.0125692f \
 //x=18.225 //y=5.205 //x2=18.725 //y2=5.39
cc_527 ( N_VDD_c_286_n N_noxref_15_c_2085_n ) capacitor c=0.0669114f //x=17.14 \
 //y=7.585 //x2=18.015 //y2=5.39
cc_528 ( N_VDD_c_279_n N_noxref_15_c_2086_n ) capacitor c=0.0024277f //x=19.73 \
 //y=7.58 //x2=19.605 //y2=7.09
cc_529 ( N_VDD_c_288_p N_noxref_15_c_2087_n ) capacitor c=0.0173902f //x=19.73 \
 //y=7.58 //x2=18.895 //y2=7.09
cc_530 ( N_VDD_c_279_n N_noxref_15_c_2087_n ) capacitor c=0.0593166f //x=19.73 \
 //y=7.58 //x2=18.895 //y2=7.09
cc_531 ( N_VDD_c_288_p N_noxref_15_M29_noxref_s ) capacitor c=0.00287776f \
 //x=19.73 //y=7.58 //x2=17.795 //y2=5.205
cc_532 ( N_VDD_c_467_p N_noxref_15_M29_noxref_s ) capacitor c=0.0144012f \
 //x=18.285 //y=7.585 //x2=17.795 //y2=5.205
cc_533 ( N_VDD_M29_noxref_d N_noxref_15_M29_noxref_s ) capacitor c=0.0667021f \
 //x=18.225 //y=5.205 //x2=17.795 //y2=5.205
cc_534 ( N_VDD_c_286_n N_noxref_15_M30_noxref_d ) capacitor c=8.88629e-19 \
 //x=17.14 //y=7.585 //x2=18.665 //y2=5.205
cc_535 ( N_VDD_M29_noxref_d N_noxref_15_M30_noxref_d ) capacitor c=0.0659925f \
 //x=18.225 //y=5.205 //x2=18.665 //y2=5.205
cc_536 ( N_VDD_c_279_n N_noxref_15_M32_noxref_d ) capacitor c=0.0528345f \
 //x=19.73 //y=7.58 //x2=19.545 //y2=5.205
cc_537 ( N_VDD_M29_noxref_d N_noxref_15_M32_noxref_d ) capacitor c=0.00107819f \
 //x=18.225 //y=5.205 //x2=19.545 //y2=5.205
cc_538 ( N_noxref_3_M14_noxref_g N_noxref_4_c_685_n ) capacitor c=0.017965f \
 //x=4.16 //y=6.2 //x2=4.735 //y2=5.38
cc_539 ( N_noxref_3_c_555_n N_noxref_4_c_689_n ) capacitor c=0.00530485f \
 //x=3.82 //y=2.26 //x2=4.025 //y2=5.38
cc_540 ( N_noxref_3_M13_noxref_g N_noxref_4_c_689_n ) capacitor c=0.0177326f \
 //x=3.72 //y=6.2 //x2=4.025 //y2=5.38
cc_541 ( N_noxref_3_c_584_n N_noxref_4_c_689_n ) capacitor c=0.00582246f \
 //x=3.82 //y=4.88 //x2=4.025 //y2=5.38
cc_542 ( N_noxref_3_c_555_n N_noxref_4_c_665_n ) capacitor c=0.00415973f \
 //x=3.82 //y=2.26 //x2=5.3 //y2=3.51
cc_543 ( N_noxref_3_M14_noxref_g N_noxref_4_M13_noxref_d ) capacitor \
 c=0.0173476f //x=4.16 //y=6.2 //x2=3.795 //y2=5.2
cc_544 ( N_noxref_3_c_555_n N_GATE_c_806_n ) capacitor c=0.00735597f //x=3.82 \
 //y=2.26 //x2=4.675 //y2=3.14
cc_545 ( N_noxref_3_c_555_n N_GATE_c_835_n ) capacitor c=0.00400249f //x=3.82 \
 //y=2.26 //x2=4.56 //y2=4.715
cc_546 ( N_noxref_3_c_584_n N_GATE_c_835_n ) capacitor c=0.00417994f //x=3.82 \
 //y=4.88 //x2=4.56 //y2=4.715
cc_547 ( N_noxref_3_c_546_n N_GATE_c_807_n ) capacitor c=0.00490755f //x=3.705 \
 //y=3.88 //x2=4.56 //y2=2.26
cc_548 ( N_noxref_3_c_554_n N_GATE_c_807_n ) capacitor c=0.00123666f //x=1.97 \
 //y=3.88 //x2=4.56 //y2=2.26
cc_549 ( N_noxref_3_c_555_n N_GATE_c_807_n ) capacitor c=0.081372f //x=3.82 \
 //y=2.26 //x2=4.56 //y2=2.26
cc_550 ( N_noxref_3_c_559_n N_GATE_c_807_n ) capacitor c=0.00308814f //x=3.625 \
 //y=2.095 //x2=4.56 //y2=2.26
cc_551 ( N_noxref_3_M13_noxref_g N_GATE_M15_noxref_g ) capacitor c=0.0104611f \
 //x=3.72 //y=6.2 //x2=4.6 //y2=6.2
cc_552 ( N_noxref_3_M14_noxref_g N_GATE_M15_noxref_g ) capacitor c=0.106811f \
 //x=4.16 //y=6.2 //x2=4.6 //y2=6.2
cc_553 ( N_noxref_3_M14_noxref_g N_GATE_M16_noxref_g ) capacitor c=0.0100341f \
 //x=4.16 //y=6.2 //x2=5.04 //y2=6.2
cc_554 ( N_noxref_3_c_556_n N_GATE_c_844_n ) capacitor c=4.86506e-19 //x=3.625 \
 //y=1.045 //x2=4.595 //y2=1.085
cc_555 ( N_noxref_3_c_558_n N_GATE_c_844_n ) capacitor c=0.00152104f //x=3.625 \
 //y=1.39 //x2=4.595 //y2=1.085
cc_556 ( N_noxref_3_c_562_n N_GATE_c_844_n ) capacitor c=0.0151475f //x=4.155 \
 //y=1.045 //x2=4.595 //y2=1.085
cc_557 ( N_noxref_3_c_609_p N_GATE_c_847_n ) capacitor c=0.00109982f //x=3.625 \
 //y=1.7 //x2=4.595 //y2=1.43
cc_558 ( N_noxref_3_c_564_n N_GATE_c_847_n ) capacitor c=0.0111064f //x=4.155 \
 //y=1.39 //x2=4.595 //y2=1.43
cc_559 ( N_noxref_3_c_609_p N_GATE_c_849_n ) capacitor c=9.57794e-19 //x=3.625 \
 //y=1.7 //x2=4.595 //y2=1.74
cc_560 ( N_noxref_3_c_559_n N_GATE_c_849_n ) capacitor c=0.00662747f //x=3.625 \
 //y=2.095 //x2=4.595 //y2=1.74
cc_561 ( N_noxref_3_c_564_n N_GATE_c_849_n ) capacitor c=0.00862358f //x=4.155 \
 //y=1.39 //x2=4.595 //y2=1.74
cc_562 ( N_noxref_3_c_562_n N_GATE_c_852_n ) capacitor c=0.00124821f //x=4.155 \
 //y=1.045 //x2=5.125 //y2=1.085
cc_563 ( N_noxref_3_c_564_n N_GATE_c_853_n ) capacitor c=0.00200715f //x=4.155 \
 //y=1.39 //x2=5.125 //y2=1.43
cc_564 ( N_noxref_3_c_555_n N_GATE_c_854_n ) capacitor c=0.00307062f //x=3.82 \
 //y=2.26 //x2=4.56 //y2=2.26
cc_565 ( N_noxref_3_c_559_n N_GATE_c_854_n ) capacitor c=0.0179092f //x=3.625 \
 //y=2.095 //x2=4.56 //y2=2.26
cc_566 ( N_noxref_3_c_555_n N_GATE_c_856_n ) capacitor c=0.00344981f //x=3.82 \
 //y=2.26 //x2=4.59 //y2=4.88
cc_567 ( N_noxref_3_c_584_n N_GATE_c_856_n ) capacitor c=0.0293367f //x=3.82 \
 //y=4.88 //x2=4.59 //y2=4.88
cc_568 ( N_noxref_3_c_546_n N_D_c_958_n ) capacitor c=0.175715f //x=3.705 \
 //y=3.88 //x2=9.995 //y2=4.25
cc_569 ( N_noxref_3_c_549_n N_D_c_958_n ) capacitor c=0.0289632f //x=2.085 \
 //y=3.88 //x2=9.995 //y2=4.25
cc_570 ( N_noxref_3_c_622_p N_D_c_958_n ) capacitor c=0.00224547f //x=1.685 \
 //y=2.26 //x2=9.995 //y2=4.25
cc_571 ( N_noxref_3_c_574_n N_D_c_958_n ) capacitor c=0.0123666f //x=1.69 \
 //y=4.76 //x2=9.995 //y2=4.25
cc_572 ( N_noxref_3_c_554_n N_D_c_958_n ) capacitor c=0.0237647f //x=1.97 \
 //y=3.88 //x2=9.995 //y2=4.25
cc_573 ( N_noxref_3_c_555_n N_D_c_958_n ) capacitor c=0.0242341f //x=3.82 \
 //y=2.26 //x2=9.995 //y2=4.25
cc_574 ( N_noxref_3_c_584_n N_D_c_958_n ) capacitor c=0.00703556f //x=3.82 \
 //y=4.88 //x2=9.995 //y2=4.25
cc_575 ( N_noxref_3_c_554_n N_D_c_959_n ) capacitor c=0.00179385f //x=1.97 \
 //y=3.88 //x2=1.345 //y2=4.25
cc_576 ( N_noxref_3_c_549_n N_D_c_961_n ) capacitor c=0.00584488f //x=2.085 \
 //y=3.88 //x2=1.23 //y2=2.265
cc_577 ( N_noxref_3_c_574_n N_D_c_961_n ) capacitor c=0.0250789f //x=1.69 \
 //y=4.76 //x2=1.23 //y2=2.265
cc_578 ( N_noxref_3_c_554_n N_D_c_961_n ) capacitor c=0.068057f //x=1.97 \
 //y=3.88 //x2=1.23 //y2=2.265
cc_579 ( N_noxref_3_c_555_n N_D_c_961_n ) capacitor c=0.00137586f //x=3.82 \
 //y=2.26 //x2=1.23 //y2=2.265
cc_580 ( N_noxref_3_M0_noxref_d N_D_c_961_n ) capacitor c=0.0175773f //x=1.415 \
 //y=1.09 //x2=1.23 //y2=2.265
cc_581 ( N_noxref_3_M11_noxref_d N_D_M11_noxref_g ) capacitor c=0.0219309f \
 //x=1.46 //y=5.2 //x2=1.385 //y2=6.2
cc_582 ( N_noxref_3_M11_noxref_d N_D_M12_noxref_g ) capacitor c=0.021902f \
 //x=1.46 //y=5.2 //x2=1.825 //y2=6.2
cc_583 ( N_noxref_3_M0_noxref_d N_D_c_968_n ) capacitor c=0.00218556f \
 //x=1.415 //y=1.09 //x2=1.34 //y2=1.09
cc_584 ( N_noxref_3_M0_noxref_d N_D_c_1036_n ) capacitor c=0.00347355f \
 //x=1.415 //y=1.09 //x2=1.34 //y2=1.435
cc_585 ( N_noxref_3_M0_noxref_d N_D_c_1037_n ) capacitor c=0.00742431f \
 //x=1.415 //y=1.09 //x2=1.34 //y2=1.745
cc_586 ( N_noxref_3_M0_noxref_d N_D_c_970_n ) capacitor c=0.00957707f \
 //x=1.415 //y=1.09 //x2=1.34 //y2=2.1
cc_587 ( N_noxref_3_c_571_n N_D_c_1017_n ) capacitor c=0.0099173f //x=1.885 \
 //y=4.76 //x2=1.75 //y2=4.97
cc_588 ( N_noxref_3_M11_noxref_d N_D_c_1017_n ) capacitor c=0.0146106f \
 //x=1.46 //y=5.2 //x2=1.75 //y2=4.97
cc_589 ( N_noxref_3_c_574_n N_D_c_1018_n ) capacitor c=0.00962086f //x=1.69 \
 //y=4.76 //x2=1.46 //y2=4.97
cc_590 ( N_noxref_3_M11_noxref_d N_D_c_1018_n ) capacitor c=0.00307344f \
 //x=1.46 //y=5.2 //x2=1.46 //y2=4.97
cc_591 ( N_noxref_3_M0_noxref_d N_D_c_971_n ) capacitor c=0.00220879f \
 //x=1.415 //y=1.09 //x2=1.715 //y2=0.935
cc_592 ( N_noxref_3_c_551_n N_D_c_1044_n ) capacitor c=0.0023507f //x=1.885 \
 //y=2.26 //x2=1.715 //y2=1.59
cc_593 ( N_noxref_3_M0_noxref_d N_D_c_1044_n ) capacitor c=0.0138447f \
 //x=1.415 //y=1.09 //x2=1.715 //y2=1.59
cc_594 ( N_noxref_3_M0_noxref_d N_D_c_972_n ) capacitor c=0.00218624f \
 //x=1.415 //y=1.09 //x2=1.87 //y2=1.09
cc_595 ( N_noxref_3_M0_noxref_d N_D_c_974_n ) capacitor c=0.00601286f \
 //x=1.415 //y=1.09 //x2=1.87 //y2=1.435
cc_596 ( N_noxref_3_c_622_p N_D_c_975_n ) capacitor c=0.0167852f //x=1.685 \
 //y=2.26 //x2=1.23 //y2=2.265
cc_597 ( N_noxref_3_c_554_n N_D_c_975_n ) capacitor c=8.49451e-19 //x=1.97 \
 //y=3.88 //x2=1.23 //y2=2.265
cc_598 ( N_noxref_3_c_546_n N_noxref_8_c_1326_n ) capacitor c=0.00396702f \
 //x=3.705 //y=3.88 //x2=7.635 //y2=3.88
cc_599 ( N_noxref_3_c_546_n N_noxref_12_c_1929_n ) capacitor c=0.00188872f \
 //x=3.705 //y=3.88 //x2=3.405 //y2=1.675
cc_600 ( N_noxref_3_c_559_n N_noxref_12_c_1929_n ) capacitor c=0.0034165f \
 //x=3.625 //y=2.095 //x2=3.405 //y2=1.675
cc_601 ( N_noxref_3_c_546_n N_noxref_12_c_1930_n ) capacitor c=0.0056636f \
 //x=3.705 //y=3.88 //x2=4.29 //y2=1.76
cc_602 ( N_noxref_3_c_555_n N_noxref_12_c_1930_n ) capacitor c=0.011766f \
 //x=3.82 //y=2.26 //x2=4.29 //y2=1.76
cc_603 ( N_noxref_3_c_609_p N_noxref_12_c_1930_n ) capacitor c=0.00703567f \
 //x=3.625 //y=1.7 //x2=4.29 //y2=1.76
cc_604 ( N_noxref_3_c_559_n N_noxref_12_c_1930_n ) capacitor c=0.0207598f \
 //x=3.625 //y=2.095 //x2=4.29 //y2=1.76
cc_605 ( N_noxref_3_c_561_n N_noxref_12_c_1930_n ) capacitor c=0.00780629f \
 //x=4 //y=1.545 //x2=4.29 //y2=1.76
cc_606 ( N_noxref_3_c_564_n N_noxref_12_c_1930_n ) capacitor c=0.00339872f \
 //x=4.155 //y=1.39 //x2=4.29 //y2=1.76
cc_607 ( N_noxref_3_c_559_n N_noxref_12_c_1937_n ) capacitor c=6.71402e-19 \
 //x=3.625 //y=2.095 //x2=4.375 //y2=1.675
cc_608 ( N_noxref_3_c_556_n N_noxref_12_M1_noxref_s ) capacitor c=0.0326577f \
 //x=3.625 //y=1.045 //x2=3.27 //y2=0.545
cc_609 ( N_noxref_3_c_609_p N_noxref_12_M1_noxref_s ) capacitor c=3.48408e-19 \
 //x=3.625 //y=1.7 //x2=3.27 //y2=0.545
cc_610 ( N_noxref_3_c_562_n N_noxref_12_M1_noxref_s ) capacitor c=0.0120759f \
 //x=4.155 //y=1.045 //x2=3.27 //y2=0.545
cc_611 ( N_noxref_4_c_725_p N_GATE_c_797_n ) capacitor c=0.140643f //x=6.665 \
 //y=3.51 //x2=9.255 //y2=3.14
cc_612 ( N_noxref_4_c_726_p N_GATE_c_797_n ) capacitor c=0.0292689f //x=5.415 \
 //y=3.51 //x2=9.255 //y2=3.14
cc_613 ( N_noxref_4_c_727_p N_GATE_c_797_n ) capacitor c=0.00745069f //x=4.945 \
 //y=1.835 //x2=9.255 //y2=3.14
cc_614 ( N_noxref_4_c_665_n N_GATE_c_797_n ) capacitor c=0.0254565f //x=5.3 \
 //y=3.51 //x2=9.255 //y2=3.14
cc_615 ( N_noxref_4_c_666_n N_GATE_c_797_n ) capacitor c=0.024764f //x=6.78 \
 //y=2.265 //x2=9.255 //y2=3.14
cc_616 ( N_noxref_4_c_678_n N_GATE_c_797_n ) capacitor c=0.00335064f //x=6.78 \
 //y=2.265 //x2=9.255 //y2=3.14
cc_617 ( N_noxref_4_c_665_n N_GATE_c_806_n ) capacitor c=0.00179385f //x=5.3 \
 //y=3.51 //x2=4.675 //y2=3.14
cc_618 ( N_noxref_4_c_685_n N_GATE_c_835_n ) capacitor c=0.0129927f //x=4.735 \
 //y=5.38 //x2=4.56 //y2=4.715
cc_619 ( N_noxref_4_c_665_n N_GATE_c_835_n ) capacitor c=0.0101204f //x=5.3 \
 //y=3.51 //x2=4.56 //y2=4.715
cc_620 ( N_noxref_4_c_726_p N_GATE_c_807_n ) capacitor c=0.00717888f //x=5.415 \
 //y=3.51 //x2=4.56 //y2=2.26
cc_621 ( N_noxref_4_c_665_n N_GATE_c_807_n ) capacitor c=0.0753231f //x=5.3 \
 //y=3.51 //x2=4.56 //y2=2.26
cc_622 ( N_noxref_4_c_666_n N_GATE_c_807_n ) capacitor c=0.00146756f //x=6.78 \
 //y=2.265 //x2=4.56 //y2=2.26
cc_623 ( N_noxref_4_c_666_n N_GATE_c_809_n ) capacitor c=0.00110316f //x=6.78 \
 //y=2.265 //x2=9.37 //y2=2.26
cc_624 ( N_noxref_4_c_685_n N_GATE_M15_noxref_g ) capacitor c=0.0166421f \
 //x=4.735 //y=5.38 //x2=4.6 //y2=6.2
cc_625 ( N_noxref_4_M15_noxref_d N_GATE_M15_noxref_g ) capacitor c=0.0173476f \
 //x=4.675 //y=5.2 //x2=4.6 //y2=6.2
cc_626 ( N_noxref_4_c_691_n N_GATE_M16_noxref_g ) capacitor c=0.0199348f \
 //x=5.215 //y=5.38 //x2=5.04 //y2=6.2
cc_627 ( N_noxref_4_M15_noxref_d N_GATE_M16_noxref_g ) capacitor c=0.0179769f \
 //x=4.675 //y=5.2 //x2=5.04 //y2=6.2
cc_628 ( N_noxref_4_M2_noxref_d N_GATE_c_844_n ) capacitor c=0.00217566f \
 //x=4.67 //y=1.085 //x2=4.595 //y2=1.085
cc_629 ( N_noxref_4_M2_noxref_d N_GATE_c_847_n ) capacitor c=0.0034598f \
 //x=4.67 //y=1.085 //x2=4.595 //y2=1.43
cc_630 ( N_noxref_4_M2_noxref_d N_GATE_c_849_n ) capacitor c=0.0065582f \
 //x=4.67 //y=1.085 //x2=4.595 //y2=1.74
cc_631 ( N_noxref_4_c_665_n N_GATE_c_878_n ) capacitor c=0.0142673f //x=5.3 \
 //y=3.51 //x2=4.965 //y2=4.97
cc_632 ( N_noxref_4_c_746_p N_GATE_c_878_n ) capacitor c=0.00408717f //x=4.82 \
 //y=5.38 //x2=4.965 //y2=4.97
cc_633 ( N_noxref_4_M2_noxref_d N_GATE_c_880_n ) capacitor c=0.00241102f \
 //x=4.67 //y=1.085 //x2=4.97 //y2=0.93
cc_634 ( N_noxref_4_c_663_n N_GATE_c_881_n ) capacitor c=0.00359704f //x=5.215 \
 //y=1.835 //x2=4.97 //y2=1.585
cc_635 ( N_noxref_4_M2_noxref_d N_GATE_c_881_n ) capacitor c=0.0138845f \
 //x=4.67 //y=1.085 //x2=4.97 //y2=1.585
cc_636 ( N_noxref_4_M2_noxref_d N_GATE_c_852_n ) capacitor c=0.00132245f \
 //x=4.67 //y=1.085 //x2=5.125 //y2=1.085
cc_637 ( N_noxref_4_c_663_n N_GATE_c_853_n ) capacitor c=0.00457401f //x=5.215 \
 //y=1.835 //x2=5.125 //y2=1.43
cc_638 ( N_noxref_4_M2_noxref_d N_GATE_c_853_n ) capacitor c=0.00566463f \
 //x=4.67 //y=1.085 //x2=5.125 //y2=1.43
cc_639 ( N_noxref_4_c_665_n N_GATE_c_854_n ) capacitor c=0.00877984f //x=5.3 \
 //y=3.51 //x2=4.56 //y2=2.26
cc_640 ( N_noxref_4_c_665_n N_GATE_c_887_n ) capacitor c=0.00306024f //x=5.3 \
 //y=3.51 //x2=4.56 //y2=2.095
cc_641 ( N_noxref_4_M2_noxref_d N_GATE_c_887_n ) capacitor c=0.00660593f \
 //x=4.67 //y=1.085 //x2=4.56 //y2=2.095
cc_642 ( N_noxref_4_c_685_n N_GATE_c_856_n ) capacitor c=0.00346635f //x=4.735 \
 //y=5.38 //x2=4.59 //y2=4.88
cc_643 ( N_noxref_4_c_665_n N_GATE_c_856_n ) capacitor c=0.00533692f //x=5.3 \
 //y=3.51 //x2=4.59 //y2=4.88
cc_644 ( N_noxref_4_c_725_p N_D_c_958_n ) capacitor c=0.0717956f //x=6.665 \
 //y=3.51 //x2=9.995 //y2=4.25
cc_645 ( N_noxref_4_c_726_p N_D_c_958_n ) capacitor c=0.0134762f //x=5.415 \
 //y=3.51 //x2=9.995 //y2=4.25
cc_646 ( N_noxref_4_c_685_n N_D_c_958_n ) capacitor c=0.0140425f //x=4.735 \
 //y=5.38 //x2=9.995 //y2=4.25
cc_647 ( N_noxref_4_c_689_n N_D_c_958_n ) capacitor c=0.0135379f //x=4.025 \
 //y=5.38 //x2=9.995 //y2=4.25
cc_648 ( N_noxref_4_c_665_n N_D_c_958_n ) capacitor c=0.0256796f //x=5.3 \
 //y=3.51 //x2=9.995 //y2=4.25
cc_649 ( N_noxref_4_c_666_n N_D_c_958_n ) capacitor c=0.0245751f //x=6.78 \
 //y=2.265 //x2=9.995 //y2=4.25
cc_650 ( N_noxref_4_c_706_n N_D_c_958_n ) capacitor c=0.00520686f //x=7.01 \
 //y=4.97 //x2=9.995 //y2=4.25
cc_651 ( N_noxref_4_c_725_p N_noxref_7_c_1141_n ) capacitor c=0.00359266f \
 //x=6.665 //y=3.51 //x2=10.965 //y2=3.51
cc_652 ( N_noxref_4_c_666_n N_noxref_8_c_1326_n ) capacitor c=0.00481534f \
 //x=6.78 //y=2.265 //x2=7.635 //y2=3.88
cc_653 ( N_noxref_4_c_767_p N_noxref_8_c_1280_n ) capacitor c=0.0023507f \
 //x=7.265 //y=1.59 //x2=7.435 //y2=2.26
cc_654 ( N_noxref_4_c_678_n N_noxref_8_c_1329_n ) capacitor c=0.0167852f \
 //x=6.78 //y=2.265 //x2=7.235 //y2=2.26
cc_655 ( N_noxref_4_c_705_n N_noxref_8_c_1305_n ) capacitor c=0.0099173f \
 //x=7.3 //y=4.97 //x2=7.435 //y2=4.76
cc_656 ( N_noxref_4_c_666_n N_noxref_8_c_1308_n ) capacitor c=0.0250789f \
 //x=6.78 //y=2.265 //x2=7.24 //y2=4.76
cc_657 ( N_noxref_4_c_706_n N_noxref_8_c_1308_n ) capacitor c=0.00962086f \
 //x=7.01 //y=4.97 //x2=7.24 //y2=4.76
cc_658 ( N_noxref_4_c_725_p N_noxref_8_c_1283_n ) capacitor c=0.00502038f \
 //x=6.665 //y=3.51 //x2=7.52 //y2=3.88
cc_659 ( N_noxref_4_c_665_n N_noxref_8_c_1283_n ) capacitor c=0.00111766f \
 //x=5.3 //y=3.51 //x2=7.52 //y2=3.88
cc_660 ( N_noxref_4_c_666_n N_noxref_8_c_1283_n ) capacitor c=0.0632861f \
 //x=6.78 //y=2.265 //x2=7.52 //y2=3.88
cc_661 ( N_noxref_4_c_678_n N_noxref_8_c_1283_n ) capacitor c=8.49451e-19 \
 //x=6.78 //y=2.265 //x2=7.52 //y2=3.88
cc_662 ( N_noxref_4_c_665_n N_noxref_8_M3_noxref_d ) capacitor c=3.35192e-19 \
 //x=5.3 //y=3.51 //x2=6.965 //y2=1.09
cc_663 ( N_noxref_4_c_666_n N_noxref_8_M3_noxref_d ) capacitor c=0.0175773f \
 //x=6.78 //y=2.265 //x2=6.965 //y2=1.09
cc_664 ( N_noxref_4_c_671_n N_noxref_8_M3_noxref_d ) capacitor c=0.00218556f \
 //x=6.89 //y=1.09 //x2=6.965 //y2=1.09
cc_665 ( N_noxref_4_c_779_p N_noxref_8_M3_noxref_d ) capacitor c=0.00347355f \
 //x=6.89 //y=1.435 //x2=6.965 //y2=1.09
cc_666 ( N_noxref_4_c_780_p N_noxref_8_M3_noxref_d ) capacitor c=0.00742431f \
 //x=6.89 //y=1.745 //x2=6.965 //y2=1.09
cc_667 ( N_noxref_4_c_673_n N_noxref_8_M3_noxref_d ) capacitor c=0.00957707f \
 //x=6.89 //y=2.1 //x2=6.965 //y2=1.09
cc_668 ( N_noxref_4_c_674_n N_noxref_8_M3_noxref_d ) capacitor c=0.00220879f \
 //x=7.265 //y=0.935 //x2=6.965 //y2=1.09
cc_669 ( N_noxref_4_c_767_p N_noxref_8_M3_noxref_d ) capacitor c=0.0138447f \
 //x=7.265 //y=1.59 //x2=6.965 //y2=1.09
cc_670 ( N_noxref_4_c_675_n N_noxref_8_M3_noxref_d ) capacitor c=0.00218624f \
 //x=7.42 //y=1.09 //x2=6.965 //y2=1.09
cc_671 ( N_noxref_4_c_677_n N_noxref_8_M3_noxref_d ) capacitor c=0.00601286f \
 //x=7.42 //y=1.435 //x2=6.965 //y2=1.09
cc_672 ( N_noxref_4_c_665_n N_noxref_8_M17_noxref_d ) capacitor c=6.3502e-19 \
 //x=5.3 //y=3.51 //x2=7.01 //y2=5.2
cc_673 ( N_noxref_4_M17_noxref_g N_noxref_8_M17_noxref_d ) capacitor \
 c=0.0219309f //x=6.935 //y=6.2 //x2=7.01 //y2=5.2
cc_674 ( N_noxref_4_M18_noxref_g N_noxref_8_M17_noxref_d ) capacitor \
 c=0.021902f //x=7.375 //y=6.2 //x2=7.01 //y2=5.2
cc_675 ( N_noxref_4_c_705_n N_noxref_8_M17_noxref_d ) capacitor c=0.0146106f \
 //x=7.3 //y=4.97 //x2=7.01 //y2=5.2
cc_676 ( N_noxref_4_c_706_n N_noxref_8_M17_noxref_d ) capacitor c=0.00307344f \
 //x=7.01 //y=4.97 //x2=7.01 //y2=5.2
cc_677 ( N_noxref_4_c_727_p N_noxref_12_c_1929_n ) capacitor c=3.15806e-19 \
 //x=4.945 //y=1.835 //x2=3.405 //y2=1.675
cc_678 ( N_noxref_4_c_727_p N_noxref_12_c_1937_n ) capacitor c=0.0201674f \
 //x=4.945 //y=1.835 //x2=4.375 //y2=1.675
cc_679 ( N_noxref_4_c_663_n N_noxref_12_c_1938_n ) capacitor c=0.00464204f \
 //x=5.215 //y=1.835 //x2=5.26 //y2=0.71
cc_680 ( N_noxref_4_M2_noxref_d N_noxref_12_c_1938_n ) capacitor c=0.0117318f \
 //x=4.67 //y=1.085 //x2=5.26 //y2=0.71
cc_681 ( N_noxref_4_c_663_n N_noxref_12_M1_noxref_s ) capacitor c=0.0140283f \
 //x=5.215 //y=1.835 //x2=3.27 //y2=0.545
cc_682 ( N_noxref_4_M2_noxref_d N_noxref_12_M1_noxref_s ) capacitor \
 c=0.0437911f //x=4.67 //y=1.085 //x2=3.27 //y2=0.545
cc_683 ( N_GATE_c_797_n N_D_c_958_n ) capacitor c=0.0419288f //x=9.255 \
 //y=3.14 //x2=9.995 //y2=4.25
cc_684 ( N_GATE_c_806_n N_D_c_958_n ) capacitor c=0.0076696f //x=4.675 \
 //y=3.14 //x2=9.995 //y2=4.25
cc_685 ( N_GATE_c_835_n N_D_c_958_n ) capacitor c=0.00135863f //x=4.56 \
 //y=4.715 //x2=9.995 //y2=4.25
cc_686 ( N_GATE_c_807_n N_D_c_958_n ) capacitor c=0.0247652f //x=4.56 //y=2.26 \
 //x2=9.995 //y2=4.25
cc_687 ( N_GATE_c_809_n N_D_c_958_n ) capacitor c=0.0241934f //x=9.37 //y=2.26 \
 //x2=9.995 //y2=4.25
cc_688 ( N_GATE_c_878_n N_D_c_958_n ) capacitor c=0.00561113f //x=4.965 \
 //y=4.97 //x2=9.995 //y2=4.25
cc_689 ( N_GATE_c_856_n N_D_c_958_n ) capacitor c=0.00127126f //x=4.59 \
 //y=4.88 //x2=9.995 //y2=4.25
cc_690 ( N_GATE_c_833_n N_D_c_958_n ) capacitor c=0.00844647f //x=9.37 \
 //y=4.88 //x2=9.995 //y2=4.25
cc_691 ( N_GATE_c_809_n N_D_c_1065_n ) capacitor c=0.00400249f //x=9.37 \
 //y=2.26 //x2=10.11 //y2=4.715
cc_692 ( N_GATE_c_833_n N_D_c_1065_n ) capacitor c=0.00417994f //x=9.37 \
 //y=4.88 //x2=10.11 //y2=4.715
cc_693 ( N_GATE_c_797_n N_D_c_966_n ) capacitor c=0.00735597f //x=9.255 \
 //y=3.14 //x2=10.11 //y2=2.26
cc_694 ( N_GATE_c_809_n N_D_c_966_n ) capacitor c=0.0803993f //x=9.37 //y=2.26 \
 //x2=10.11 //y2=2.26
cc_695 ( N_GATE_c_813_n N_D_c_966_n ) capacitor c=0.00308814f //x=9.175 \
 //y=2.095 //x2=10.11 //y2=2.26
cc_696 ( N_GATE_M19_noxref_g N_D_M21_noxref_g ) capacitor c=0.0104611f \
 //x=9.27 //y=6.2 //x2=10.15 //y2=6.2
cc_697 ( N_GATE_M20_noxref_g N_D_M21_noxref_g ) capacitor c=0.106811f //x=9.71 \
 //y=6.2 //x2=10.15 //y2=6.2
cc_698 ( N_GATE_M20_noxref_g N_D_M22_noxref_g ) capacitor c=0.0100341f \
 //x=9.71 //y=6.2 //x2=10.59 //y2=6.2
cc_699 ( N_GATE_c_810_n N_D_c_1073_n ) capacitor c=4.86506e-19 //x=9.175 \
 //y=1.045 //x2=10.145 //y2=1.085
cc_700 ( N_GATE_c_812_n N_D_c_1073_n ) capacitor c=0.00152104f //x=9.175 \
 //y=1.39 //x2=10.145 //y2=1.085
cc_701 ( N_GATE_c_816_n N_D_c_1073_n ) capacitor c=0.0151475f //x=9.705 \
 //y=1.045 //x2=10.145 //y2=1.085
cc_702 ( N_GATE_c_910_p N_D_c_1076_n ) capacitor c=0.00109982f //x=9.175 \
 //y=1.7 //x2=10.145 //y2=1.43
cc_703 ( N_GATE_c_818_n N_D_c_1076_n ) capacitor c=0.0111064f //x=9.705 \
 //y=1.39 //x2=10.145 //y2=1.43
cc_704 ( N_GATE_c_910_p N_D_c_1078_n ) capacitor c=9.57794e-19 //x=9.175 \
 //y=1.7 //x2=10.145 //y2=1.74
cc_705 ( N_GATE_c_813_n N_D_c_1078_n ) capacitor c=0.00662747f //x=9.175 \
 //y=2.095 //x2=10.145 //y2=1.74
cc_706 ( N_GATE_c_818_n N_D_c_1078_n ) capacitor c=0.00862358f //x=9.705 \
 //y=1.39 //x2=10.145 //y2=1.74
cc_707 ( N_GATE_c_816_n N_D_c_1081_n ) capacitor c=0.00124821f //x=9.705 \
 //y=1.045 //x2=10.675 //y2=1.085
cc_708 ( N_GATE_c_818_n N_D_c_1082_n ) capacitor c=0.00200715f //x=9.705 \
 //y=1.39 //x2=10.675 //y2=1.43
cc_709 ( N_GATE_c_809_n N_D_c_1083_n ) capacitor c=0.00307062f //x=9.37 \
 //y=2.26 //x2=10.11 //y2=2.26
cc_710 ( N_GATE_c_813_n N_D_c_1083_n ) capacitor c=0.0179092f //x=9.175 \
 //y=2.095 //x2=10.11 //y2=2.26
cc_711 ( N_GATE_c_809_n N_D_c_1085_n ) capacitor c=0.00344981f //x=9.37 \
 //y=2.26 //x2=10.14 //y2=4.88
cc_712 ( N_GATE_c_833_n N_D_c_1085_n ) capacitor c=0.0293367f //x=9.37 \
 //y=4.88 //x2=10.14 //y2=4.88
cc_713 ( N_GATE_M20_noxref_g N_noxref_7_c_1164_n ) capacitor c=0.017965f \
 //x=9.71 //y=6.2 //x2=10.285 //y2=5.38
cc_714 ( N_GATE_c_809_n N_noxref_7_c_1168_n ) capacitor c=0.00549854f //x=9.37 \
 //y=2.26 //x2=9.575 //y2=5.38
cc_715 ( N_GATE_M19_noxref_g N_noxref_7_c_1168_n ) capacitor c=0.0177326f \
 //x=9.27 //y=6.2 //x2=9.575 //y2=5.38
cc_716 ( N_GATE_c_833_n N_noxref_7_c_1168_n ) capacitor c=0.00582246f //x=9.37 \
 //y=4.88 //x2=9.575 //y2=5.38
cc_717 ( N_GATE_c_809_n N_noxref_7_c_1144_n ) capacitor c=0.00423287f //x=9.37 \
 //y=2.26 //x2=10.85 //y2=3.51
cc_718 ( N_GATE_M20_noxref_g N_noxref_7_M19_noxref_d ) capacitor c=0.0173476f \
 //x=9.71 //y=6.2 //x2=9.345 //y2=5.2
cc_719 ( N_GATE_c_797_n N_noxref_8_c_1274_n ) capacitor c=0.0866346f //x=9.255 \
 //y=3.14 //x2=14.805 //y2=3.88
cc_720 ( N_GATE_c_809_n N_noxref_8_c_1274_n ) capacitor c=0.0213789f //x=9.37 \
 //y=2.26 //x2=14.805 //y2=3.88
cc_721 ( N_GATE_c_797_n N_noxref_8_c_1326_n ) capacitor c=0.0132252f //x=9.255 \
 //y=3.14 //x2=7.635 //y2=3.88
cc_722 ( N_GATE_c_809_n N_noxref_8_c_1326_n ) capacitor c=7.01366e-19 //x=9.37 \
 //y=2.26 //x2=7.635 //y2=3.88
cc_723 ( N_GATE_c_809_n N_noxref_8_c_1280_n ) capacitor c=0.0121599f //x=9.37 \
 //y=2.26 //x2=7.435 //y2=2.26
cc_724 ( N_GATE_c_797_n N_noxref_8_c_1329_n ) capacitor c=0.00763858f \
 //x=9.255 //y=3.14 //x2=7.235 //y2=2.26
cc_725 ( N_GATE_c_797_n N_noxref_8_c_1283_n ) capacitor c=0.0266199f //x=9.255 \
 //y=3.14 //x2=7.52 //y2=3.88
cc_726 ( N_GATE_c_806_n N_noxref_12_c_1937_n ) capacitor c=8.77911e-19 \
 //x=4.675 //y=3.14 //x2=4.375 //y2=1.675
cc_727 ( N_GATE_c_849_n N_noxref_12_c_1937_n ) capacitor c=0.00623646f \
 //x=4.595 //y=1.74 //x2=4.375 //y2=1.675
cc_728 ( N_GATE_c_854_n N_noxref_12_c_1937_n ) capacitor c=0.00174417f \
 //x=4.56 //y=2.26 //x2=4.375 //y2=1.675
cc_729 ( N_GATE_c_797_n N_noxref_12_c_1938_n ) capacitor c=5.58937e-19 \
 //x=9.255 //y=3.14 //x2=5.26 //y2=0.71
cc_730 ( N_GATE_c_807_n N_noxref_12_c_1938_n ) capacitor c=0.00159167f \
 //x=4.56 //y=2.26 //x2=5.26 //y2=0.71
cc_731 ( N_GATE_c_844_n N_noxref_12_c_1938_n ) capacitor c=0.0188655f \
 //x=4.595 //y=1.085 //x2=5.26 //y2=0.71
cc_732 ( N_GATE_c_852_n N_noxref_12_c_1938_n ) capacitor c=0.00656458f \
 //x=5.125 //y=1.085 //x2=5.26 //y2=0.71
cc_733 ( N_GATE_c_854_n N_noxref_12_c_1938_n ) capacitor c=2.1838e-19 //x=4.56 \
 //y=2.26 //x2=5.26 //y2=0.71
cc_734 ( N_GATE_c_797_n N_noxref_12_M1_noxref_s ) capacitor c=6.20367e-19 \
 //x=9.255 //y=3.14 //x2=3.27 //y2=0.545
cc_735 ( N_GATE_c_844_n N_noxref_12_M1_noxref_s ) capacitor c=0.00623646f \
 //x=4.595 //y=1.085 //x2=3.27 //y2=0.545
cc_736 ( N_GATE_c_852_n N_noxref_12_M1_noxref_s ) capacitor c=0.0143002f \
 //x=5.125 //y=1.085 //x2=3.27 //y2=0.545
cc_737 ( N_GATE_c_853_n N_noxref_12_M1_noxref_s ) capacitor c=0.00290153f \
 //x=5.125 //y=1.43 //x2=3.27 //y2=0.545
cc_738 ( N_GATE_c_797_n N_noxref_13_c_1984_n ) capacitor c=0.00321948f \
 //x=9.255 //y=3.14 //x2=8.955 //y2=1.675
cc_739 ( N_GATE_c_813_n N_noxref_13_c_1984_n ) capacitor c=0.0034165f \
 //x=9.175 //y=2.095 //x2=8.955 //y2=1.675
cc_740 ( N_GATE_c_797_n N_noxref_13_c_1985_n ) capacitor c=0.00765882f \
 //x=9.255 //y=3.14 //x2=9.84 //y2=1.76
cc_741 ( N_GATE_c_809_n N_noxref_13_c_1985_n ) capacitor c=0.0115783f //x=9.37 \
 //y=2.26 //x2=9.84 //y2=1.76
cc_742 ( N_GATE_c_910_p N_noxref_13_c_1985_n ) capacitor c=0.00703567f \
 //x=9.175 //y=1.7 //x2=9.84 //y2=1.76
cc_743 ( N_GATE_c_813_n N_noxref_13_c_1985_n ) capacitor c=0.01939f //x=9.175 \
 //y=2.095 //x2=9.84 //y2=1.76
cc_744 ( N_GATE_c_815_n N_noxref_13_c_1985_n ) capacitor c=0.00780629f \
 //x=9.55 //y=1.545 //x2=9.84 //y2=1.76
cc_745 ( N_GATE_c_818_n N_noxref_13_c_1985_n ) capacitor c=0.00339872f \
 //x=9.705 //y=1.39 //x2=9.84 //y2=1.76
cc_746 ( N_GATE_c_813_n N_noxref_13_c_1992_n ) capacitor c=6.71402e-19 \
 //x=9.175 //y=2.095 //x2=9.925 //y2=1.675
cc_747 ( N_GATE_c_810_n N_noxref_13_M4_noxref_s ) capacitor c=0.0326577f \
 //x=9.175 //y=1.045 //x2=8.82 //y2=0.545
cc_748 ( N_GATE_c_910_p N_noxref_13_M4_noxref_s ) capacitor c=3.48408e-19 \
 //x=9.175 //y=1.7 //x2=8.82 //y2=0.545
cc_749 ( N_GATE_c_816_n N_noxref_13_M4_noxref_s ) capacitor c=0.0120759f \
 //x=9.705 //y=1.045 //x2=8.82 //y2=0.545
cc_750 ( N_D_c_966_n N_noxref_7_c_1141_n ) capacitor c=0.00502038f //x=10.11 \
 //y=2.26 //x2=10.965 //y2=3.51
cc_751 ( N_D_c_958_n N_noxref_7_c_1164_n ) capacitor c=0.00208151f //x=9.995 \
 //y=4.25 //x2=10.285 //y2=5.38
cc_752 ( N_D_c_1065_n N_noxref_7_c_1164_n ) capacitor c=0.0129205f //x=10.11 \
 //y=4.715 //x2=10.285 //y2=5.38
cc_753 ( N_D_M21_noxref_g N_noxref_7_c_1164_n ) capacitor c=0.0166421f \
 //x=10.15 //y=6.2 //x2=10.285 //y2=5.38
cc_754 ( N_D_c_1085_n N_noxref_7_c_1164_n ) capacitor c=0.00346627f //x=10.14 \
 //y=4.88 //x2=10.285 //y2=5.38
cc_755 ( N_D_c_958_n N_noxref_7_c_1168_n ) capacitor c=0.01319f //x=9.995 \
 //y=4.25 //x2=9.575 //y2=5.38
cc_756 ( N_D_M22_noxref_g N_noxref_7_c_1170_n ) capacitor c=0.0206783f \
 //x=10.59 //y=6.2 //x2=10.765 //y2=5.38
cc_757 ( N_D_c_1094_p N_noxref_7_c_1142_n ) capacitor c=0.00359704f //x=10.52 \
 //y=1.585 //x2=10.765 //y2=1.835
cc_758 ( N_D_c_1082_n N_noxref_7_c_1142_n ) capacitor c=0.00457401f //x=10.675 \
 //y=1.43 //x2=10.765 //y2=1.835
cc_759 ( N_D_c_958_n N_noxref_7_c_1144_n ) capacitor c=0.0044695f //x=9.995 \
 //y=4.25 //x2=10.85 //y2=3.51
cc_760 ( N_D_c_1065_n N_noxref_7_c_1144_n ) capacitor c=0.0101204f //x=10.11 \
 //y=4.715 //x2=10.85 //y2=3.51
cc_761 ( N_D_c_966_n N_noxref_7_c_1144_n ) capacitor c=0.0770799f //x=10.11 \
 //y=2.26 //x2=10.85 //y2=3.51
cc_762 ( N_D_c_1099_p N_noxref_7_c_1144_n ) capacitor c=0.0142673f //x=10.515 \
 //y=4.97 //x2=10.85 //y2=3.51
cc_763 ( N_D_c_1083_n N_noxref_7_c_1144_n ) capacitor c=0.00877984f //x=10.11 \
 //y=2.26 //x2=10.85 //y2=3.51
cc_764 ( N_D_c_1101_p N_noxref_7_c_1144_n ) capacitor c=0.00306024f //x=10.11 \
 //y=2.095 //x2=10.85 //y2=3.51
cc_765 ( N_D_c_1085_n N_noxref_7_c_1144_n ) capacitor c=0.00533692f //x=10.14 \
 //y=4.88 //x2=10.85 //y2=3.51
cc_766 ( N_D_c_966_n N_noxref_7_c_1145_n ) capacitor c=0.00129241f //x=10.11 \
 //y=2.26 //x2=12.33 //y2=2.265
cc_767 ( N_D_c_1099_p N_noxref_7_c_1222_n ) capacitor c=0.00421574f //x=10.515 \
 //y=4.97 //x2=10.37 //y2=5.38
cc_768 ( N_D_c_1073_n N_noxref_7_M5_noxref_d ) capacitor c=0.00217566f \
 //x=10.145 //y=1.085 //x2=10.22 //y2=1.085
cc_769 ( N_D_c_1076_n N_noxref_7_M5_noxref_d ) capacitor c=0.0034598f \
 //x=10.145 //y=1.43 //x2=10.22 //y2=1.085
cc_770 ( N_D_c_1078_n N_noxref_7_M5_noxref_d ) capacitor c=0.0065582f \
 //x=10.145 //y=1.74 //x2=10.22 //y2=1.085
cc_771 ( N_D_c_1108_p N_noxref_7_M5_noxref_d ) capacitor c=0.00241102f \
 //x=10.52 //y=0.93 //x2=10.22 //y2=1.085
cc_772 ( N_D_c_1094_p N_noxref_7_M5_noxref_d ) capacitor c=0.0138845f \
 //x=10.52 //y=1.585 //x2=10.22 //y2=1.085
cc_773 ( N_D_c_1081_n N_noxref_7_M5_noxref_d ) capacitor c=0.00132245f \
 //x=10.675 //y=1.085 //x2=10.22 //y2=1.085
cc_774 ( N_D_c_1082_n N_noxref_7_M5_noxref_d ) capacitor c=0.00566463f \
 //x=10.675 //y=1.43 //x2=10.22 //y2=1.085
cc_775 ( N_D_c_1101_p N_noxref_7_M5_noxref_d ) capacitor c=0.00660593f \
 //x=10.11 //y=2.095 //x2=10.22 //y2=1.085
cc_776 ( N_D_M21_noxref_g N_noxref_7_M21_noxref_d ) capacitor c=0.0173476f \
 //x=10.15 //y=6.2 //x2=10.225 //y2=5.2
cc_777 ( N_D_M22_noxref_g N_noxref_7_M21_noxref_d ) capacitor c=0.0179769f \
 //x=10.59 //y=6.2 //x2=10.225 //y2=5.2
cc_778 ( N_D_c_958_n N_noxref_8_c_1274_n ) capacitor c=0.239964f //x=9.995 \
 //y=4.25 //x2=14.805 //y2=3.88
cc_779 ( N_D_c_966_n N_noxref_8_c_1274_n ) capacitor c=0.0243898f //x=10.11 \
 //y=2.26 //x2=14.805 //y2=3.88
cc_780 ( N_D_c_1099_p N_noxref_8_c_1274_n ) capacitor c=0.00624857f //x=10.515 \
 //y=4.97 //x2=14.805 //y2=3.88
cc_781 ( N_D_c_1085_n N_noxref_8_c_1274_n ) capacitor c=3.27069e-19 //x=10.14 \
 //y=4.88 //x2=14.805 //y2=3.88
cc_782 ( N_D_c_958_n N_noxref_8_c_1326_n ) capacitor c=0.0289632f //x=9.995 \
 //y=4.25 //x2=7.635 //y2=3.88
cc_783 ( N_D_c_958_n N_noxref_8_c_1308_n ) capacitor c=0.0123666f //x=9.995 \
 //y=4.25 //x2=7.24 //y2=4.76
cc_784 ( N_D_c_958_n N_noxref_8_c_1283_n ) capacitor c=0.0237455f //x=9.995 \
 //y=4.25 //x2=7.52 //y2=3.88
cc_785 ( N_D_c_966_n N_noxref_8_c_1283_n ) capacitor c=0.00147206f //x=10.11 \
 //y=2.26 //x2=7.52 //y2=3.88
cc_786 ( N_D_c_958_n N_noxref_10_c_1631_n ) capacitor c=0.00564994f //x=9.995 \
 //y=4.25 //x2=13.185 //y2=4.25
cc_787 ( N_D_c_958_n N_noxref_12_c_1930_n ) capacitor c=0.00234538f //x=9.995 \
 //y=4.25 //x2=4.29 //y2=1.76
cc_788 ( N_D_c_958_n N_noxref_12_c_1937_n ) capacitor c=9.3567e-19 //x=9.995 \
 //y=4.25 //x2=4.375 //y2=1.675
cc_789 ( N_D_c_1078_n N_noxref_13_c_1992_n ) capacitor c=0.00623646f \
 //x=10.145 //y=1.74 //x2=9.925 //y2=1.675
cc_790 ( N_D_c_1083_n N_noxref_13_c_1992_n ) capacitor c=0.00176439f //x=10.11 \
 //y=2.26 //x2=9.925 //y2=1.675
cc_791 ( N_D_c_966_n N_noxref_13_c_1993_n ) capacitor c=0.0016032f //x=10.11 \
 //y=2.26 //x2=10.81 //y2=0.71
cc_792 ( N_D_c_1073_n N_noxref_13_c_1993_n ) capacitor c=0.0188655f //x=10.145 \
 //y=1.085 //x2=10.81 //y2=0.71
cc_793 ( N_D_c_1081_n N_noxref_13_c_1993_n ) capacitor c=0.00656458f \
 //x=10.675 //y=1.085 //x2=10.81 //y2=0.71
cc_794 ( N_D_c_1083_n N_noxref_13_c_1993_n ) capacitor c=2.1838e-19 //x=10.11 \
 //y=2.26 //x2=10.81 //y2=0.71
cc_795 ( N_D_c_1073_n N_noxref_13_M4_noxref_s ) capacitor c=0.00623646f \
 //x=10.145 //y=1.085 //x2=8.82 //y2=0.545
cc_796 ( N_D_c_1081_n N_noxref_13_M4_noxref_s ) capacitor c=0.0143002f \
 //x=10.675 //y=1.085 //x2=8.82 //y2=0.545
cc_797 ( N_D_c_1082_n N_noxref_13_M4_noxref_s ) capacitor c=0.00290153f \
 //x=10.675 //y=1.43 //x2=8.82 //y2=0.545
cc_798 ( N_noxref_7_c_1135_n N_noxref_8_c_1274_n ) capacitor c=0.142515f \
 //x=12.215 //y=3.51 //x2=14.805 //y2=3.88
cc_799 ( N_noxref_7_c_1141_n N_noxref_8_c_1274_n ) capacitor c=0.0293967f \
 //x=10.965 //y=3.51 //x2=14.805 //y2=3.88
cc_800 ( N_noxref_7_c_1164_n N_noxref_8_c_1274_n ) capacitor c=0.00978117f \
 //x=10.285 //y=5.38 //x2=14.805 //y2=3.88
cc_801 ( N_noxref_7_c_1236_p N_noxref_8_c_1274_n ) capacitor c=0.00378729f \
 //x=10.495 //y=1.835 //x2=14.805 //y2=3.88
cc_802 ( N_noxref_7_c_1144_n N_noxref_8_c_1274_n ) capacitor c=0.0257951f \
 //x=10.85 //y=3.51 //x2=14.805 //y2=3.88
cc_803 ( N_noxref_7_c_1145_n N_noxref_8_c_1274_n ) capacitor c=0.025066f \
 //x=12.33 //y=2.265 //x2=14.805 //y2=3.88
cc_804 ( N_noxref_7_c_1185_n N_noxref_8_c_1274_n ) capacitor c=0.00582422f \
 //x=12.56 //y=4.97 //x2=14.805 //y2=3.88
cc_805 ( N_noxref_7_c_1145_n N_noxref_8_c_1284_n ) capacitor c=0.00107428f \
 //x=12.33 //y=2.265 //x2=14.92 //y2=2.26
cc_806 ( N_noxref_7_c_1135_n N_Q_c_1444_n ) capacitor c=0.00359266f //x=12.215 \
 //y=3.51 //x2=16.515 //y2=3.51
cc_807 ( N_noxref_7_c_1145_n N_noxref_10_c_1631_n ) capacitor c=0.0044695f \
 //x=12.33 //y=2.265 //x2=13.185 //y2=4.25
cc_808 ( N_noxref_7_c_1243_p N_noxref_10_c_1606_n ) capacitor c=0.0023507f \
 //x=12.815 //y=1.59 //x2=12.985 //y2=2.26
cc_809 ( N_noxref_7_c_1157_n N_noxref_10_c_1652_n ) capacitor c=0.0167852f \
 //x=12.33 //y=2.265 //x2=12.785 //y2=2.26
cc_810 ( N_noxref_7_c_1184_n N_noxref_10_c_1634_n ) capacitor c=0.00997878f \
 //x=12.85 //y=4.97 //x2=12.985 //y2=4.76
cc_811 ( N_noxref_7_c_1145_n N_noxref_10_c_1637_n ) capacitor c=0.0250878f \
 //x=12.33 //y=2.265 //x2=12.79 //y2=4.76
cc_812 ( N_noxref_7_c_1185_n N_noxref_10_c_1637_n ) capacitor c=0.00962086f \
 //x=12.56 //y=4.97 //x2=12.79 //y2=4.76
cc_813 ( N_noxref_7_c_1135_n N_noxref_10_c_1609_n ) capacitor c=0.00502038f \
 //x=12.215 //y=3.51 //x2=13.07 //y2=4.25
cc_814 ( N_noxref_7_c_1144_n N_noxref_10_c_1609_n ) capacitor c=0.0011405f \
 //x=10.85 //y=3.51 //x2=13.07 //y2=4.25
cc_815 ( N_noxref_7_c_1145_n N_noxref_10_c_1609_n ) capacitor c=0.0668092f \
 //x=12.33 //y=2.265 //x2=13.07 //y2=4.25
cc_816 ( N_noxref_7_c_1157_n N_noxref_10_c_1609_n ) capacitor c=8.49451e-19 \
 //x=12.33 //y=2.265 //x2=13.07 //y2=4.25
cc_817 ( N_noxref_7_c_1144_n N_noxref_10_M6_noxref_d ) capacitor c=3.35192e-19 \
 //x=10.85 //y=3.51 //x2=12.515 //y2=1.09
cc_818 ( N_noxref_7_c_1145_n N_noxref_10_M6_noxref_d ) capacitor c=0.0175773f \
 //x=12.33 //y=2.265 //x2=12.515 //y2=1.09
cc_819 ( N_noxref_7_c_1150_n N_noxref_10_M6_noxref_d ) capacitor c=0.00218556f \
 //x=12.44 //y=1.09 //x2=12.515 //y2=1.09
cc_820 ( N_noxref_7_c_1255_p N_noxref_10_M6_noxref_d ) capacitor c=0.00347355f \
 //x=12.44 //y=1.435 //x2=12.515 //y2=1.09
cc_821 ( N_noxref_7_c_1256_p N_noxref_10_M6_noxref_d ) capacitor c=0.00742431f \
 //x=12.44 //y=1.745 //x2=12.515 //y2=1.09
cc_822 ( N_noxref_7_c_1152_n N_noxref_10_M6_noxref_d ) capacitor c=0.00957707f \
 //x=12.44 //y=2.1 //x2=12.515 //y2=1.09
cc_823 ( N_noxref_7_c_1153_n N_noxref_10_M6_noxref_d ) capacitor c=0.00220879f \
 //x=12.815 //y=0.935 //x2=12.515 //y2=1.09
cc_824 ( N_noxref_7_c_1243_p N_noxref_10_M6_noxref_d ) capacitor c=0.0138447f \
 //x=12.815 //y=1.59 //x2=12.515 //y2=1.09
cc_825 ( N_noxref_7_c_1154_n N_noxref_10_M6_noxref_d ) capacitor c=0.00218624f \
 //x=12.97 //y=1.09 //x2=12.515 //y2=1.09
cc_826 ( N_noxref_7_c_1156_n N_noxref_10_M6_noxref_d ) capacitor c=0.00601286f \
 //x=12.97 //y=1.435 //x2=12.515 //y2=1.09
cc_827 ( N_noxref_7_c_1144_n N_noxref_10_M23_noxref_d ) capacitor c=6.3502e-19 \
 //x=10.85 //y=3.51 //x2=12.56 //y2=5.2
cc_828 ( N_noxref_7_M23_noxref_g N_noxref_10_M23_noxref_d ) capacitor \
 c=0.0219309f //x=12.485 //y=6.2 //x2=12.56 //y2=5.2
cc_829 ( N_noxref_7_M24_noxref_g N_noxref_10_M23_noxref_d ) capacitor \
 c=0.021902f //x=12.925 //y=6.2 //x2=12.56 //y2=5.2
cc_830 ( N_noxref_7_c_1184_n N_noxref_10_M23_noxref_d ) capacitor c=0.0146106f \
 //x=12.85 //y=4.97 //x2=12.56 //y2=5.2
cc_831 ( N_noxref_7_c_1185_n N_noxref_10_M23_noxref_d ) capacitor \
 c=0.00307344f //x=12.56 //y=4.97 //x2=12.56 //y2=5.2
cc_832 ( N_noxref_7_c_1236_p N_noxref_13_c_1984_n ) capacitor c=3.15806e-19 \
 //x=10.495 //y=1.835 //x2=8.955 //y2=1.675
cc_833 ( N_noxref_7_c_1236_p N_noxref_13_c_1992_n ) capacitor c=0.0201674f \
 //x=10.495 //y=1.835 //x2=9.925 //y2=1.675
cc_834 ( N_noxref_7_c_1142_n N_noxref_13_c_1993_n ) capacitor c=0.0046686f \
 //x=10.765 //y=1.835 //x2=10.81 //y2=0.71
cc_835 ( N_noxref_7_M5_noxref_d N_noxref_13_c_1993_n ) capacitor c=0.0117932f \
 //x=10.22 //y=1.085 //x2=10.81 //y2=0.71
cc_836 ( N_noxref_7_c_1141_n N_noxref_13_M4_noxref_s ) capacitor c=3.47564e-19 \
 //x=10.965 //y=3.51 //x2=8.82 //y2=0.545
cc_837 ( N_noxref_7_c_1142_n N_noxref_13_M4_noxref_s ) capacitor c=0.0141735f \
 //x=10.765 //y=1.835 //x2=8.82 //y2=0.545
cc_838 ( N_noxref_7_M5_noxref_d N_noxref_13_M4_noxref_s ) capacitor \
 c=0.0437911f //x=10.22 //y=1.085 //x2=8.82 //y2=0.545
cc_839 ( N_noxref_8_c_1284_n Q ) capacitor c=0.00359995f //x=14.92 //y=2.26 \
 //x2=16.4 //y2=2.4
cc_840 ( N_noxref_8_c_1294_n N_Q_c_1447_n ) capacitor c=0.00431513f //x=15.255 \
 //y=1.43 //x2=15.875 //y2=1.835
cc_841 ( N_noxref_8_c_1274_n N_Q_c_1494_n ) capacitor c=6.76081e-19 //x=14.805 \
 //y=3.88 //x2=15.075 //y2=1.835
cc_842 ( N_noxref_8_c_1284_n N_Q_c_1494_n ) capacitor c=0.0110776f //x=14.92 \
 //y=2.26 //x2=15.075 //y2=1.835
cc_843 ( N_noxref_8_c_1289_n N_Q_c_1494_n ) capacitor c=0.00589082f //x=14.725 \
 //y=2.095 //x2=15.075 //y2=1.835
cc_844 ( N_noxref_8_c_1287_n N_Q_M7_noxref_d ) capacitor c=0.0013184f \
 //x=14.725 //y=1.085 //x2=14.8 //y2=1.085
cc_845 ( N_noxref_8_c_1381_p N_Q_M7_noxref_d ) capacitor c=0.0034598f \
 //x=14.725 //y=1.43 //x2=14.8 //y2=1.085
cc_846 ( N_noxref_8_c_1382_p N_Q_M7_noxref_d ) capacitor c=0.00300148f \
 //x=14.725 //y=1.74 //x2=14.8 //y2=1.085
cc_847 ( N_noxref_8_c_1289_n N_Q_M7_noxref_d ) capacitor c=0.00273686f \
 //x=14.725 //y=2.095 //x2=14.8 //y2=1.085
cc_848 ( N_noxref_8_c_1291_n N_Q_M7_noxref_d ) capacitor c=0.00241102f \
 //x=15.1 //y=0.93 //x2=14.8 //y2=1.085
cc_849 ( N_noxref_8_c_1385_p N_Q_M7_noxref_d ) capacitor c=0.0123304f //x=15.1 \
 //y=1.585 //x2=14.8 //y2=1.085
cc_850 ( N_noxref_8_c_1292_n N_Q_M7_noxref_d ) capacitor c=0.00219619f \
 //x=15.255 //y=1.085 //x2=14.8 //y2=1.085
cc_851 ( N_noxref_8_c_1294_n N_Q_M7_noxref_d ) capacitor c=0.00603828f \
 //x=15.255 //y=1.43 //x2=14.8 //y2=1.085
cc_852 ( N_noxref_8_c_1274_n N_noxref_10_c_1605_n ) capacitor c=0.175903f \
 //x=14.805 //y=3.88 //x2=18.875 //y2=4.25
cc_853 ( N_noxref_8_c_1284_n N_noxref_10_c_1605_n ) capacitor c=0.0239848f \
 //x=14.92 //y=2.26 //x2=18.875 //y2=4.25
cc_854 ( N_noxref_8_c_1312_n N_noxref_10_c_1605_n ) capacitor c=0.00699941f \
 //x=14.765 //y=4.885 //x2=18.875 //y2=4.25
cc_855 ( N_noxref_8_c_1391_p N_noxref_10_c_1605_n ) capacitor c=0.00503266f \
 //x=15.185 //y=4.975 //x2=18.875 //y2=4.25
cc_856 ( N_noxref_8_c_1320_n N_noxref_10_c_1605_n ) capacitor c=0.00111449f \
 //x=14.765 //y=4.885 //x2=18.875 //y2=4.25
cc_857 ( N_noxref_8_c_1274_n N_noxref_10_c_1631_n ) capacitor c=0.029084f \
 //x=14.805 //y=3.88 //x2=13.185 //y2=4.25
cc_858 ( N_noxref_8_c_1284_n N_noxref_10_c_1631_n ) capacitor c=3.50683e-19 \
 //x=14.92 //y=2.26 //x2=13.185 //y2=4.25
cc_859 ( N_noxref_8_c_1284_n N_noxref_10_c_1606_n ) capacitor c=0.0139741f \
 //x=14.92 //y=2.26 //x2=12.985 //y2=2.26
cc_860 ( N_noxref_8_c_1274_n N_noxref_10_c_1652_n ) capacitor c=0.00360671f \
 //x=14.805 //y=3.88 //x2=12.785 //y2=2.26
cc_861 ( N_noxref_8_c_1274_n N_noxref_10_c_1637_n ) capacitor c=0.00677394f \
 //x=14.805 //y=3.88 //x2=12.79 //y2=4.76
cc_862 ( N_noxref_8_c_1274_n N_noxref_10_c_1609_n ) capacitor c=0.0267087f \
 //x=14.805 //y=3.88 //x2=13.07 //y2=4.25
cc_863 ( N_noxref_8_c_1274_n N_noxref_11_c_1769_n ) capacitor c=0.0244534f \
 //x=14.805 //y=3.88 //x2=15.775 //y2=3.88
cc_864 ( N_noxref_8_c_1284_n N_noxref_11_c_1769_n ) capacitor c=0.00245879f \
 //x=14.92 //y=2.26 //x2=15.775 //y2=3.88
cc_865 ( N_noxref_8_c_1312_n N_noxref_11_c_1809_n ) capacitor c=0.0450681f \
 //x=14.765 //y=4.885 //x2=15.66 //y2=4.72
cc_866 ( N_noxref_8_c_1391_p N_noxref_11_c_1809_n ) capacitor c=0.00146509f \
 //x=15.185 //y=4.975 //x2=15.66 //y2=4.72
cc_867 ( N_noxref_8_c_1320_n N_noxref_11_c_1809_n ) capacitor c=0.00112871f \
 //x=14.765 //y=4.885 //x2=15.66 //y2=4.72
cc_868 ( N_noxref_8_c_1274_n N_noxref_11_c_1770_n ) capacitor c=0.00246068f \
 //x=14.805 //y=3.88 //x2=15.66 //y2=2.26
cc_869 ( N_noxref_8_c_1284_n N_noxref_11_c_1770_n ) capacitor c=0.0432793f \
 //x=14.92 //y=2.26 //x2=15.66 //y2=2.26
cc_870 ( N_noxref_8_c_1289_n N_noxref_11_c_1770_n ) capacitor c=0.00308814f \
 //x=14.725 //y=2.095 //x2=15.66 //y2=2.26
cc_871 ( N_noxref_8_M25_noxref_g N_noxref_11_M27_noxref_g ) capacitor \
 c=0.0100243f //x=14.82 //y=6.205 //x2=15.7 //y2=6.205
cc_872 ( N_noxref_8_M26_noxref_g N_noxref_11_M27_noxref_g ) capacitor \
 c=0.107798f //x=15.26 //y=6.205 //x2=15.7 //y2=6.205
cc_873 ( N_noxref_8_M26_noxref_g N_noxref_11_M28_noxref_g ) capacitor \
 c=0.0094155f //x=15.26 //y=6.205 //x2=16.14 //y2=6.205
cc_874 ( N_noxref_8_c_1287_n N_noxref_11_c_1781_n ) capacitor c=0.00125788f \
 //x=14.725 //y=1.085 //x2=15.695 //y2=1.085
cc_875 ( N_noxref_8_c_1292_n N_noxref_11_c_1781_n ) capacitor c=0.0126654f \
 //x=15.255 //y=1.085 //x2=15.695 //y2=1.085
cc_876 ( N_noxref_8_c_1381_p N_noxref_11_c_1820_n ) capacitor c=0.00148539f \
 //x=14.725 //y=1.43 //x2=15.695 //y2=1.435
cc_877 ( N_noxref_8_c_1382_p N_noxref_11_c_1820_n ) capacitor c=0.00105591f \
 //x=14.725 //y=1.74 //x2=15.695 //y2=1.435
cc_878 ( N_noxref_8_c_1294_n N_noxref_11_c_1820_n ) capacitor c=0.0126654f \
 //x=15.255 //y=1.43 //x2=15.695 //y2=1.435
cc_879 ( N_noxref_8_c_1382_p N_noxref_11_c_1823_n ) capacitor c=0.00109549f \
 //x=14.725 //y=1.74 //x2=15.695 //y2=1.74
cc_880 ( N_noxref_8_c_1294_n N_noxref_11_c_1823_n ) capacitor c=0.00886999f \
 //x=15.255 //y=1.43 //x2=15.695 //y2=1.74
cc_881 ( N_noxref_8_c_1294_n N_noxref_11_c_1784_n ) capacitor c=0.00123863f \
 //x=15.255 //y=1.43 //x2=16.07 //y2=1.585
cc_882 ( N_noxref_8_c_1292_n N_noxref_11_c_1785_n ) capacitor c=0.00132934f \
 //x=15.255 //y=1.085 //x2=16.225 //y2=1.085
cc_883 ( N_noxref_8_c_1294_n N_noxref_11_c_1827_n ) capacitor c=0.00150734f \
 //x=15.255 //y=1.43 //x2=16.225 //y2=1.435
cc_884 ( N_noxref_8_c_1284_n N_noxref_11_c_1828_n ) capacitor c=0.00307062f \
 //x=14.92 //y=2.26 //x2=15.66 //y2=2.26
cc_885 ( N_noxref_8_c_1289_n N_noxref_11_c_1828_n ) capacitor c=0.0179092f \
 //x=14.725 //y=2.095 //x2=15.66 //y2=2.26
cc_886 ( N_noxref_8_c_1289_n N_noxref_11_c_1830_n ) capacitor c=0.00577193f \
 //x=14.725 //y=2.095 //x2=15.66 //y2=2.095
cc_887 ( N_noxref_8_c_1312_n N_noxref_11_c_1831_n ) capacitor c=0.00336963f \
 //x=14.765 //y=4.885 //x2=15.695 //y2=4.885
cc_888 ( N_noxref_8_c_1391_p N_noxref_11_c_1831_n ) capacitor c=0.020271f \
 //x=15.185 //y=4.975 //x2=15.695 //y2=4.885
cc_889 ( N_noxref_8_c_1320_n N_noxref_11_c_1831_n ) capacitor c=0.00546725f \
 //x=14.765 //y=4.885 //x2=15.695 //y2=4.885
cc_890 ( N_noxref_8_c_1274_n N_noxref_13_c_1985_n ) capacitor c=0.00299723f \
 //x=14.805 //y=3.88 //x2=9.84 //y2=1.76
cc_891 ( N_noxref_8_c_1274_n N_noxref_13_c_1992_n ) capacitor c=0.00187232f \
 //x=14.805 //y=3.88 //x2=9.925 //y2=1.675
cc_892 ( N_noxref_8_c_1274_n N_noxref_13_c_1993_n ) capacitor c=4.7198e-19 \
 //x=14.805 //y=3.88 //x2=10.81 //y2=0.71
cc_893 ( N_noxref_8_c_1312_n N_noxref_14_c_2038_n ) capacitor c=0.00575148f \
 //x=14.765 //y=4.885 //x2=15.395 //y2=5.39
cc_894 ( N_noxref_8_M25_noxref_g N_noxref_14_c_2038_n ) capacitor c=0.0182391f \
 //x=14.82 //y=6.205 //x2=15.395 //y2=5.39
cc_895 ( N_noxref_8_M26_noxref_g N_noxref_14_c_2038_n ) capacitor c=0.0179851f \
 //x=15.26 //y=6.205 //x2=15.395 //y2=5.39
cc_896 ( N_noxref_8_c_1391_p N_noxref_14_c_2038_n ) capacitor c=0.00364886f \
 //x=15.185 //y=4.975 //x2=15.395 //y2=5.39
cc_897 ( N_noxref_8_c_1320_n N_noxref_14_c_2038_n ) capacitor c=0.0017421f \
 //x=14.765 //y=4.885 //x2=15.395 //y2=5.39
cc_898 ( N_noxref_8_c_1312_n N_noxref_14_c_2043_n ) capacitor c=0.0118149f \
 //x=14.765 //y=4.885 //x2=14.685 //y2=5.39
cc_899 ( N_noxref_8_c_1320_n N_noxref_14_c_2043_n ) capacitor c=0.00521692f \
 //x=14.765 //y=4.885 //x2=14.685 //y2=5.39
cc_900 ( N_noxref_8_M25_noxref_g N_noxref_14_M25_noxref_s ) capacitor \
 c=0.0473218f //x=14.82 //y=6.205 //x2=14.465 //y2=5.205
cc_901 ( N_noxref_8_M26_noxref_g N_noxref_14_M26_noxref_d ) capacitor \
 c=0.0170604f //x=15.26 //y=6.205 //x2=15.335 //y2=5.205
cc_902 ( N_Q_c_1438_n N_noxref_10_c_1605_n ) capacitor c=0.0107208f //x=18.135 \
 //y=3.51 //x2=18.875 //y2=4.25
cc_903 ( N_Q_c_1444_n N_noxref_10_c_1605_n ) capacitor c=8.88421e-19 \
 //x=16.515 //y=3.51 //x2=18.875 //y2=4.25
cc_904 ( Q N_noxref_10_c_1605_n ) capacitor c=0.0231862f //x=16.4 //y=2.4 \
 //x2=18.875 //y2=4.25
cc_905 ( N_Q_c_1494_n N_noxref_10_c_1605_n ) capacitor c=0.00331066f \
 //x=15.075 //y=1.835 //x2=18.875 //y2=4.25
cc_906 ( N_Q_c_1478_n N_noxref_10_c_1605_n ) capacitor c=0.0117991f //x=16.005 \
 //y=5.39 //x2=18.875 //y2=4.25
cc_907 ( N_Q_c_1456_n N_noxref_10_c_1605_n ) capacitor c=0.0239633f //x=18.25 \
 //y=2.26 //x2=18.875 //y2=4.25
cc_908 ( N_Q_c_1480_n N_noxref_10_c_1605_n ) capacitor c=0.00699941f \
 //x=18.095 //y=4.885 //x2=18.875 //y2=4.25
cc_909 ( N_Q_c_1512_p N_noxref_10_c_1605_n ) capacitor c=0.00642535f \
 //x=18.515 //y=4.975 //x2=18.875 //y2=4.25
cc_910 ( N_Q_c_1488_n N_noxref_10_c_1605_n ) capacitor c=0.00111449f \
 //x=18.095 //y=4.885 //x2=18.875 //y2=4.25
cc_911 ( N_Q_c_1480_n N_noxref_10_c_1695_n ) capacitor c=0.0438179f //x=18.095 \
 //y=4.885 //x2=18.99 //y2=4.72
cc_912 ( N_Q_c_1512_p N_noxref_10_c_1695_n ) capacitor c=0.00146509f \
 //x=18.515 //y=4.975 //x2=18.99 //y2=4.72
cc_913 ( N_Q_c_1488_n N_noxref_10_c_1695_n ) capacitor c=0.00112871f \
 //x=18.095 //y=4.885 //x2=18.99 //y2=4.72
cc_914 ( N_Q_c_1438_n N_noxref_10_c_1610_n ) capacitor c=0.00720056f \
 //x=18.135 //y=3.51 //x2=18.99 //y2=2.26
cc_915 ( Q N_noxref_10_c_1610_n ) capacitor c=0.00107361f //x=16.4 //y=2.4 \
 //x2=18.99 //y2=2.26
cc_916 ( N_Q_c_1456_n N_noxref_10_c_1610_n ) capacitor c=0.0418764f //x=18.25 \
 //y=2.26 //x2=18.99 //y2=2.26
cc_917 ( N_Q_c_1461_n N_noxref_10_c_1610_n ) capacitor c=0.00308814f \
 //x=18.055 //y=2.095 //x2=18.99 //y2=2.26
cc_918 ( N_Q_M29_noxref_g N_noxref_10_M31_noxref_g ) capacitor c=0.0100243f \
 //x=18.15 //y=6.205 //x2=19.03 //y2=6.205
cc_919 ( N_Q_M30_noxref_g N_noxref_10_M31_noxref_g ) capacitor c=0.107798f \
 //x=18.59 //y=6.205 //x2=19.03 //y2=6.205
cc_920 ( N_Q_M30_noxref_g N_noxref_10_M32_noxref_g ) capacitor c=0.0094155f \
 //x=18.59 //y=6.205 //x2=19.47 //y2=6.205
cc_921 ( N_Q_c_1459_n N_noxref_10_c_1612_n ) capacitor c=0.00125788f \
 //x=18.055 //y=1.085 //x2=19.025 //y2=1.085
cc_922 ( N_Q_c_1464_n N_noxref_10_c_1612_n ) capacitor c=0.0126654f //x=18.585 \
 //y=1.085 //x2=19.025 //y2=1.085
cc_923 ( N_Q_c_1526_p N_noxref_10_c_1707_n ) capacitor c=0.00148539f \
 //x=18.055 //y=1.43 //x2=19.025 //y2=1.435
cc_924 ( N_Q_c_1527_p N_noxref_10_c_1707_n ) capacitor c=0.00105591f \
 //x=18.055 //y=1.74 //x2=19.025 //y2=1.435
cc_925 ( N_Q_c_1466_n N_noxref_10_c_1707_n ) capacitor c=0.0126654f //x=18.585 \
 //y=1.43 //x2=19.025 //y2=1.435
cc_926 ( N_Q_c_1527_p N_noxref_10_c_1710_n ) capacitor c=0.00109549f \
 //x=18.055 //y=1.74 //x2=19.025 //y2=1.74
cc_927 ( N_Q_c_1466_n N_noxref_10_c_1710_n ) capacitor c=0.00886999f \
 //x=18.585 //y=1.43 //x2=19.025 //y2=1.74
cc_928 ( N_Q_c_1466_n N_noxref_10_c_1615_n ) capacitor c=0.00123863f \
 //x=18.585 //y=1.43 //x2=19.4 //y2=1.585
cc_929 ( N_Q_c_1464_n N_noxref_10_c_1616_n ) capacitor c=0.00132934f \
 //x=18.585 //y=1.085 //x2=19.555 //y2=1.085
cc_930 ( N_Q_c_1466_n N_noxref_10_c_1714_n ) capacitor c=0.00150734f \
 //x=18.585 //y=1.43 //x2=19.555 //y2=1.435
cc_931 ( N_Q_c_1456_n N_noxref_10_c_1715_n ) capacitor c=0.00307062f //x=18.25 \
 //y=2.26 //x2=18.99 //y2=2.26
cc_932 ( N_Q_c_1461_n N_noxref_10_c_1715_n ) capacitor c=0.0179092f //x=18.055 \
 //y=2.095 //x2=18.99 //y2=2.26
cc_933 ( N_Q_c_1461_n N_noxref_10_c_1717_n ) capacitor c=0.00577193f \
 //x=18.055 //y=2.095 //x2=18.99 //y2=2.095
cc_934 ( N_Q_c_1480_n N_noxref_10_c_1718_n ) capacitor c=0.00336963f \
 //x=18.095 //y=4.885 //x2=19.025 //y2=4.885
cc_935 ( N_Q_c_1512_p N_noxref_10_c_1718_n ) capacitor c=0.020271f //x=18.515 \
 //y=4.975 //x2=19.025 //y2=4.885
cc_936 ( N_Q_c_1488_n N_noxref_10_c_1718_n ) capacitor c=0.00546725f \
 //x=18.095 //y=4.885 //x2=19.025 //y2=4.885
cc_937 ( N_Q_c_1438_n N_noxref_11_c_1767_n ) capacitor c=0.17519f //x=18.135 \
 //y=3.51 //x2=19.615 //y2=3.88
cc_938 ( N_Q_c_1444_n N_noxref_11_c_1767_n ) capacitor c=0.0293975f //x=16.515 \
 //y=3.51 //x2=19.615 //y2=3.88
cc_939 ( Q N_noxref_11_c_1767_n ) capacitor c=0.0206034f //x=16.4 //y=2.4 \
 //x2=19.615 //y2=3.88
cc_940 ( N_Q_c_1447_n N_noxref_11_c_1767_n ) capacitor c=0.00475418f \
 //x=15.875 //y=1.835 //x2=19.615 //y2=3.88
cc_941 ( N_Q_c_1456_n N_noxref_11_c_1767_n ) capacitor c=0.0205626f //x=18.25 \
 //y=2.26 //x2=19.615 //y2=3.88
cc_942 ( Q N_noxref_11_c_1769_n ) capacitor c=0.00117715f //x=16.4 //y=2.4 \
 //x2=15.775 //y2=3.88
cc_943 ( N_Q_c_1447_n N_noxref_11_c_1769_n ) capacitor c=0.00142742f \
 //x=15.875 //y=1.835 //x2=15.775 //y2=3.88
cc_944 ( Q N_noxref_11_c_1809_n ) capacitor c=0.0102183f //x=16.4 //y=2.4 \
 //x2=15.66 //y2=4.72
cc_945 ( N_Q_c_1444_n N_noxref_11_c_1770_n ) capacitor c=0.00503413f \
 //x=16.515 //y=3.51 //x2=15.66 //y2=2.26
cc_946 ( Q N_noxref_11_c_1770_n ) capacitor c=0.0761604f //x=16.4 //y=2.4 \
 //x2=15.66 //y2=2.26
cc_947 ( N_Q_c_1447_n N_noxref_11_c_1770_n ) capacitor c=0.0165015f //x=15.875 \
 //y=1.835 //x2=15.66 //y2=2.26
cc_948 ( N_Q_c_1456_n N_noxref_11_c_1770_n ) capacitor c=0.001003f //x=18.25 \
 //y=2.26 //x2=15.66 //y2=2.26
cc_949 ( N_Q_c_1466_n N_noxref_11_c_1772_n ) capacitor c=0.00431513f \
 //x=18.585 //y=1.43 //x2=19.205 //y2=1.835
cc_950 ( N_Q_c_1438_n N_noxref_11_c_1847_n ) capacitor c=8.73015e-19 \
 //x=18.135 //y=3.51 //x2=18.405 //y2=1.835
cc_951 ( N_Q_c_1456_n N_noxref_11_c_1847_n ) capacitor c=0.011f //x=18.25 \
 //y=2.26 //x2=18.405 //y2=1.835
cc_952 ( N_Q_c_1461_n N_noxref_11_c_1847_n ) capacitor c=0.00589082f \
 //x=18.055 //y=2.095 //x2=18.405 //y2=1.835
cc_953 ( Q N_noxref_11_c_1780_n ) capacitor c=3.5517e-19 //x=16.4 //y=2.4 \
 //x2=19.73 //y2=3.88
cc_954 ( N_Q_c_1456_n N_noxref_11_c_1780_n ) capacitor c=0.00391834f //x=18.25 \
 //y=2.26 //x2=19.73 //y2=3.88
cc_955 ( N_Q_c_1478_n N_noxref_11_M27_noxref_g ) capacitor c=0.0132788f \
 //x=16.005 //y=5.39 //x2=15.7 //y2=6.205
cc_956 ( N_Q_c_1476_n N_noxref_11_M28_noxref_g ) capacitor c=0.0193734f \
 //x=16.315 //y=5.39 //x2=16.14 //y2=6.205
cc_957 ( N_Q_M27_noxref_d N_noxref_11_M28_noxref_g ) capacitor c=0.0136385f \
 //x=15.775 //y=5.205 //x2=16.14 //y2=6.205
cc_958 ( N_Q_M8_noxref_d N_noxref_11_c_1781_n ) capacitor c=0.00226395f \
 //x=15.77 //y=1.085 //x2=15.695 //y2=1.085
cc_959 ( N_Q_M8_noxref_d N_noxref_11_c_1820_n ) capacitor c=0.0035101f \
 //x=15.77 //y=1.085 //x2=15.695 //y2=1.435
cc_960 ( N_Q_c_1447_n N_noxref_11_c_1823_n ) capacitor c=0.0021898f //x=15.875 \
 //y=1.835 //x2=15.695 //y2=1.74
cc_961 ( N_Q_M7_noxref_d N_noxref_11_c_1823_n ) capacitor c=0.00148728f \
 //x=14.8 //y=1.085 //x2=15.695 //y2=1.74
cc_962 ( N_Q_M8_noxref_d N_noxref_11_c_1823_n ) capacitor c=0.00546704f \
 //x=15.77 //y=1.085 //x2=15.695 //y2=1.74
cc_963 ( Q N_noxref_11_c_1860_n ) capacitor c=0.0144455f //x=16.4 //y=2.4 \
 //x2=16.065 //y2=4.975
cc_964 ( N_Q_c_1478_n N_noxref_11_c_1860_n ) capacitor c=0.00405122f \
 //x=16.005 //y=5.39 //x2=16.065 //y2=4.975
cc_965 ( N_Q_M8_noxref_d N_noxref_11_c_1783_n ) capacitor c=0.00241102f \
 //x=15.77 //y=1.085 //x2=16.07 //y2=0.93
cc_966 ( N_Q_c_1451_n N_noxref_11_c_1784_n ) capacitor c=0.00801563f \
 //x=16.315 //y=1.835 //x2=16.07 //y2=1.585
cc_967 ( N_Q_M8_noxref_d N_noxref_11_c_1784_n ) capacitor c=0.0158021f \
 //x=15.77 //y=1.085 //x2=16.07 //y2=1.585
cc_968 ( N_Q_M8_noxref_d N_noxref_11_c_1785_n ) capacitor c=0.00132831f \
 //x=15.77 //y=1.085 //x2=16.225 //y2=1.085
cc_969 ( N_Q_M8_noxref_d N_noxref_11_c_1827_n ) capacitor c=0.0035101f \
 //x=15.77 //y=1.085 //x2=16.225 //y2=1.435
cc_970 ( Q N_noxref_11_c_1828_n ) capacitor c=0.00877984f //x=16.4 //y=2.4 \
 //x2=15.66 //y2=2.26
cc_971 ( N_Q_c_1447_n N_noxref_11_c_1828_n ) capacitor c=0.00635719f \
 //x=15.875 //y=1.835 //x2=15.66 //y2=2.26
cc_972 ( Q N_noxref_11_c_1830_n ) capacitor c=0.00306024f //x=16.4 //y=2.4 \
 //x2=15.66 //y2=2.095
cc_973 ( N_Q_c_1447_n N_noxref_11_c_1830_n ) capacitor c=0.0189722f //x=15.875 \
 //y=1.835 //x2=15.66 //y2=2.095
cc_974 ( N_Q_M8_noxref_d N_noxref_11_c_1830_n ) capacitor c=3.4952e-19 \
 //x=15.77 //y=1.085 //x2=15.66 //y2=2.095
cc_975 ( Q N_noxref_11_c_1831_n ) capacitor c=0.00537091f //x=16.4 //y=2.4 \
 //x2=15.695 //y2=4.885
cc_976 ( N_Q_c_1459_n N_noxref_11_M9_noxref_d ) capacitor c=0.0013184f \
 //x=18.055 //y=1.085 //x2=18.13 //y2=1.085
cc_977 ( N_Q_c_1526_p N_noxref_11_M9_noxref_d ) capacitor c=0.0034598f \
 //x=18.055 //y=1.43 //x2=18.13 //y2=1.085
cc_978 ( N_Q_c_1527_p N_noxref_11_M9_noxref_d ) capacitor c=0.00300148f \
 //x=18.055 //y=1.74 //x2=18.13 //y2=1.085
cc_979 ( N_Q_c_1461_n N_noxref_11_M9_noxref_d ) capacitor c=0.00273686f \
 //x=18.055 //y=2.095 //x2=18.13 //y2=1.085
cc_980 ( N_Q_c_1463_n N_noxref_11_M9_noxref_d ) capacitor c=0.00241102f \
 //x=18.43 //y=0.93 //x2=18.13 //y2=1.085
cc_981 ( N_Q_c_1584_p N_noxref_11_M9_noxref_d ) capacitor c=0.0123304f \
 //x=18.43 //y=1.585 //x2=18.13 //y2=1.085
cc_982 ( N_Q_c_1464_n N_noxref_11_M9_noxref_d ) capacitor c=0.00219619f \
 //x=18.585 //y=1.085 //x2=18.13 //y2=1.085
cc_983 ( N_Q_c_1466_n N_noxref_11_M9_noxref_d ) capacitor c=0.00603828f \
 //x=18.585 //y=1.43 //x2=18.13 //y2=1.085
cc_984 ( N_Q_c_1478_n N_noxref_14_c_2038_n ) capacitor c=0.0348754f //x=16.005 \
 //y=5.39 //x2=15.395 //y2=5.39
cc_985 ( N_Q_c_1476_n N_noxref_14_c_2045_n ) capacitor c=0.00163797f \
 //x=16.315 //y=5.39 //x2=16.275 //y2=7.09
cc_986 ( N_Q_M27_noxref_d N_noxref_14_c_2045_n ) capacitor c=0.0117542f \
 //x=15.775 //y=5.205 //x2=16.275 //y2=7.09
cc_987 ( N_Q_M27_noxref_d N_noxref_14_M25_noxref_s ) capacitor c=0.00107541f \
 //x=15.775 //y=5.205 //x2=14.465 //y2=5.205
cc_988 ( N_Q_M27_noxref_d N_noxref_14_M26_noxref_d ) capacitor c=0.0348754f \
 //x=15.775 //y=5.205 //x2=15.335 //y2=5.205
cc_989 ( N_Q_c_1476_n N_noxref_14_M28_noxref_d ) capacitor c=0.0154581f \
 //x=16.315 //y=5.39 //x2=16.215 //y2=5.205
cc_990 ( N_Q_M27_noxref_d N_noxref_14_M28_noxref_d ) capacitor c=0.0458293f \
 //x=15.775 //y=5.205 //x2=16.215 //y2=5.205
cc_991 ( N_Q_c_1480_n N_noxref_15_c_2081_n ) capacitor c=0.00598167f \
 //x=18.095 //y=4.885 //x2=18.725 //y2=5.39
cc_992 ( N_Q_M29_noxref_g N_noxref_15_c_2081_n ) capacitor c=0.0182391f \
 //x=18.15 //y=6.205 //x2=18.725 //y2=5.39
cc_993 ( N_Q_M30_noxref_g N_noxref_15_c_2081_n ) capacitor c=0.0179851f \
 //x=18.59 //y=6.205 //x2=18.725 //y2=5.39
cc_994 ( N_Q_c_1512_p N_noxref_15_c_2081_n ) capacitor c=0.00364886f \
 //x=18.515 //y=4.975 //x2=18.725 //y2=5.39
cc_995 ( N_Q_c_1488_n N_noxref_15_c_2081_n ) capacitor c=0.0017421f //x=18.095 \
 //y=4.885 //x2=18.725 //y2=5.39
cc_996 ( N_Q_c_1476_n N_noxref_15_c_2085_n ) capacitor c=2.91997e-19 \
 //x=16.315 //y=5.39 //x2=18.015 //y2=5.39
cc_997 ( N_Q_c_1480_n N_noxref_15_c_2085_n ) capacitor c=0.0118149f //x=18.095 \
 //y=4.885 //x2=18.015 //y2=5.39
cc_998 ( N_Q_c_1488_n N_noxref_15_c_2085_n ) capacitor c=0.00521692f \
 //x=18.095 //y=4.885 //x2=18.015 //y2=5.39
cc_999 ( N_Q_M29_noxref_g N_noxref_15_M29_noxref_s ) capacitor c=0.0473218f \
 //x=18.15 //y=6.205 //x2=17.795 //y2=5.205
cc_1000 ( N_Q_M27_noxref_d N_noxref_15_M29_noxref_s ) capacitor c=4.36987e-19 \
 //x=15.775 //y=5.205 //x2=17.795 //y2=5.205
cc_1001 ( N_Q_M30_noxref_g N_noxref_15_M30_noxref_d ) capacitor c=0.0170604f \
 //x=18.59 //y=6.205 //x2=18.665 //y2=5.205
cc_1002 ( N_noxref_10_c_1605_n N_noxref_11_c_1767_n ) capacitor c=0.304105f \
 //x=18.875 //y=4.25 //x2=19.615 //y2=3.88
cc_1003 ( N_noxref_10_c_1610_n N_noxref_11_c_1767_n ) capacitor c=0.0254944f \
 //x=18.99 //y=2.26 //x2=19.615 //y2=3.88
cc_1004 ( N_noxref_10_c_1723_p N_noxref_11_c_1767_n ) capacitor c=0.00618637f \
 //x=19.395 //y=4.975 //x2=19.615 //y2=3.88
cc_1005 ( N_noxref_10_c_1718_n N_noxref_11_c_1767_n ) capacitor c=4.87994e-19 \
 //x=19.025 //y=4.885 //x2=19.615 //y2=3.88
cc_1006 ( N_noxref_10_c_1605_n N_noxref_11_c_1769_n ) capacitor c=0.0290123f \
 //x=18.875 //y=4.25 //x2=15.775 //y2=3.88
cc_1007 ( N_noxref_10_c_1605_n N_noxref_11_c_1809_n ) capacitor c=0.00139965f \
 //x=18.875 //y=4.25 //x2=15.66 //y2=4.72
cc_1008 ( N_noxref_10_c_1605_n N_noxref_11_c_1770_n ) capacitor c=0.0226474f \
 //x=18.875 //y=4.25 //x2=15.66 //y2=2.26
cc_1009 ( N_noxref_10_c_1609_n N_noxref_11_c_1770_n ) capacitor c=0.00120654f \
 //x=13.07 //y=4.25 //x2=15.66 //y2=2.26
cc_1010 ( N_noxref_10_c_1610_n N_noxref_11_c_1772_n ) capacitor c=0.0165035f \
 //x=18.99 //y=2.26 //x2=19.205 //y2=1.835
cc_1011 ( N_noxref_10_c_1710_n N_noxref_11_c_1772_n ) capacitor c=0.0021898f \
 //x=19.025 //y=1.74 //x2=19.205 //y2=1.835
cc_1012 ( N_noxref_10_c_1715_n N_noxref_11_c_1772_n ) capacitor c=0.00635719f \
 //x=18.99 //y=2.26 //x2=19.205 //y2=1.835
cc_1013 ( N_noxref_10_c_1717_n N_noxref_11_c_1772_n ) capacitor c=0.0189735f \
 //x=18.99 //y=2.095 //x2=19.205 //y2=1.835
cc_1014 ( N_noxref_10_M32_noxref_g N_noxref_11_c_1797_n ) capacitor \
 c=0.0201101f //x=19.47 //y=6.205 //x2=19.645 //y2=5.39
cc_1015 ( N_noxref_10_M31_noxref_g N_noxref_11_c_1799_n ) capacitor \
 c=0.0132788f //x=19.03 //y=6.205 //x2=19.335 //y2=5.39
cc_1016 ( N_noxref_10_c_1723_p N_noxref_11_c_1799_n ) capacitor c=0.00417892f \
 //x=19.395 //y=4.975 //x2=19.335 //y2=5.39
cc_1017 ( N_noxref_10_c_1615_n N_noxref_11_c_1776_n ) capacitor c=0.00801563f \
 //x=19.4 //y=1.585 //x2=19.645 //y2=1.835
cc_1018 ( N_noxref_10_c_1605_n N_noxref_11_c_1780_n ) capacitor c=0.00642908f \
 //x=18.875 //y=4.25 //x2=19.73 //y2=3.88
cc_1019 ( N_noxref_10_c_1695_n N_noxref_11_c_1780_n ) capacitor c=0.0102183f \
 //x=18.99 //y=4.72 //x2=19.73 //y2=3.88
cc_1020 ( N_noxref_10_c_1610_n N_noxref_11_c_1780_n ) capacitor c=0.0788359f \
 //x=18.99 //y=2.26 //x2=19.73 //y2=3.88
cc_1021 ( N_noxref_10_c_1723_p N_noxref_11_c_1780_n ) capacitor c=0.0144455f \
 //x=19.395 //y=4.975 //x2=19.73 //y2=3.88
cc_1022 ( N_noxref_10_c_1715_n N_noxref_11_c_1780_n ) capacitor c=0.00877984f \
 //x=18.99 //y=2.26 //x2=19.73 //y2=3.88
cc_1023 ( N_noxref_10_c_1717_n N_noxref_11_c_1780_n ) capacitor c=0.00306024f \
 //x=18.99 //y=2.095 //x2=19.73 //y2=3.88
cc_1024 ( N_noxref_10_c_1718_n N_noxref_11_c_1780_n ) capacitor c=0.00537091f \
 //x=19.025 //y=4.885 //x2=19.73 //y2=3.88
cc_1025 ( N_noxref_10_c_1605_n N_noxref_11_c_1860_n ) capacitor c=0.00742954f \
 //x=18.875 //y=4.25 //x2=16.065 //y2=4.975
cc_1026 ( N_noxref_10_c_1605_n N_noxref_11_c_1831_n ) capacitor c=0.00136049f \
 //x=18.875 //y=4.25 //x2=15.695 //y2=4.885
cc_1027 ( N_noxref_10_c_1710_n N_noxref_11_M9_noxref_d ) capacitor \
 c=0.00148728f //x=19.025 //y=1.74 //x2=18.13 //y2=1.085
cc_1028 ( N_noxref_10_c_1612_n N_noxref_11_M10_noxref_d ) capacitor \
 c=0.00226395f //x=19.025 //y=1.085 //x2=19.1 //y2=1.085
cc_1029 ( N_noxref_10_c_1707_n N_noxref_11_M10_noxref_d ) capacitor \
 c=0.0035101f //x=19.025 //y=1.435 //x2=19.1 //y2=1.085
cc_1030 ( N_noxref_10_c_1710_n N_noxref_11_M10_noxref_d ) capacitor \
 c=0.00546704f //x=19.025 //y=1.74 //x2=19.1 //y2=1.085
cc_1031 ( N_noxref_10_c_1614_n N_noxref_11_M10_noxref_d ) capacitor \
 c=0.00241102f //x=19.4 //y=0.93 //x2=19.1 //y2=1.085
cc_1032 ( N_noxref_10_c_1615_n N_noxref_11_M10_noxref_d ) capacitor \
 c=0.0158021f //x=19.4 //y=1.585 //x2=19.1 //y2=1.085
cc_1033 ( N_noxref_10_c_1616_n N_noxref_11_M10_noxref_d ) capacitor \
 c=0.00132831f //x=19.555 //y=1.085 //x2=19.1 //y2=1.085
cc_1034 ( N_noxref_10_c_1714_n N_noxref_11_M10_noxref_d ) capacitor \
 c=0.0035101f //x=19.555 //y=1.435 //x2=19.1 //y2=1.085
cc_1035 ( N_noxref_10_c_1717_n N_noxref_11_M10_noxref_d ) capacitor \
 c=3.4952e-19 //x=18.99 //y=2.095 //x2=19.1 //y2=1.085
cc_1036 ( N_noxref_10_M32_noxref_g N_noxref_11_M31_noxref_d ) capacitor \
 c=0.0136385f //x=19.47 //y=6.205 //x2=19.105 //y2=5.205
cc_1037 ( N_noxref_10_c_1605_n N_noxref_14_c_2038_n ) capacitor c=0.0142961f \
 //x=18.875 //y=4.25 //x2=15.395 //y2=5.39
cc_1038 ( N_noxref_10_c_1605_n N_noxref_14_c_2043_n ) capacitor c=0.0037532f \
 //x=18.875 //y=4.25 //x2=14.685 //y2=5.39
cc_1039 ( N_noxref_10_c_1605_n N_noxref_14_c_2045_n ) capacitor c=3.11234e-19 \
 //x=18.875 //y=4.25 //x2=16.275 //y2=7.09
cc_1040 ( N_noxref_10_c_1605_n N_noxref_15_c_2081_n ) capacitor c=0.0145703f \
 //x=18.875 //y=4.25 //x2=18.725 //y2=5.39
cc_1041 ( N_noxref_10_M31_noxref_g N_noxref_15_c_2081_n ) capacitor \
 c=0.0170604f //x=19.03 //y=6.205 //x2=18.725 //y2=5.39
cc_1042 ( N_noxref_10_c_1718_n N_noxref_15_c_2081_n ) capacitor c=2.28171e-19 \
 //x=19.025 //y=4.885 //x2=18.725 //y2=5.39
cc_1043 ( N_noxref_10_c_1605_n N_noxref_15_c_2085_n ) capacitor c=0.0037532f \
 //x=18.875 //y=4.25 //x2=18.015 //y2=5.39
cc_1044 ( N_noxref_10_c_1695_n N_noxref_15_c_2086_n ) capacitor c=8.01329e-19 \
 //x=18.99 //y=4.72 //x2=19.605 //y2=7.09
cc_1045 ( N_noxref_10_M31_noxref_g N_noxref_15_c_2086_n ) capacitor \
 c=0.0148439f //x=19.03 //y=6.205 //x2=19.605 //y2=7.09
cc_1046 ( N_noxref_10_M32_noxref_g N_noxref_15_c_2086_n ) capacitor \
 c=0.0163195f //x=19.47 //y=6.205 //x2=19.605 //y2=7.09
cc_1047 ( N_noxref_10_M32_noxref_g N_noxref_15_M32_noxref_d ) capacitor \
 c=0.0351101f //x=19.47 //y=6.205 //x2=19.545 //y2=5.205
cc_1048 ( N_noxref_11_M27_noxref_g N_noxref_14_c_2038_n ) capacitor \
 c=0.0170604f //x=15.7 //y=6.205 //x2=15.395 //y2=5.39
cc_1049 ( N_noxref_11_c_1831_n N_noxref_14_c_2038_n ) capacitor c=2.28218e-19 \
 //x=15.695 //y=4.885 //x2=15.395 //y2=5.39
cc_1050 ( N_noxref_11_c_1809_n N_noxref_14_c_2045_n ) capacitor c=8.02844e-19 \
 //x=15.66 //y=4.72 //x2=16.275 //y2=7.09
cc_1051 ( N_noxref_11_M27_noxref_g N_noxref_14_c_2045_n ) capacitor \
 c=0.0148443f //x=15.7 //y=6.205 //x2=16.275 //y2=7.09
cc_1052 ( N_noxref_11_M28_noxref_g N_noxref_14_c_2045_n ) capacitor \
 c=0.0163191f //x=16.14 //y=6.205 //x2=16.275 //y2=7.09
cc_1053 ( N_noxref_11_M28_noxref_g N_noxref_14_M28_noxref_d ) capacitor \
 c=0.0351101f //x=16.14 //y=6.205 //x2=16.215 //y2=5.205
cc_1054 ( N_noxref_11_c_1799_n N_noxref_15_c_2081_n ) capacitor c=0.0348754f \
 //x=19.335 //y=5.39 //x2=18.725 //y2=5.39
cc_1055 ( N_noxref_11_c_1797_n N_noxref_15_c_2086_n ) capacitor c=0.00165939f \
 //x=19.645 //y=5.39 //x2=19.605 //y2=7.09
cc_1056 ( N_noxref_11_M31_noxref_d N_noxref_15_c_2086_n ) capacitor \
 c=0.011777f //x=19.105 //y=5.205 //x2=19.605 //y2=7.09
cc_1057 ( N_noxref_11_M31_noxref_d N_noxref_15_M29_noxref_s ) capacitor \
 c=0.00107541f //x=19.105 //y=5.205 //x2=17.795 //y2=5.205
cc_1058 ( N_noxref_11_M31_noxref_d N_noxref_15_M30_noxref_d ) capacitor \
 c=0.0348754f //x=19.105 //y=5.205 //x2=18.665 //y2=5.205
cc_1059 ( N_noxref_11_c_1797_n N_noxref_15_M32_noxref_d ) capacitor \
 c=0.0156425f //x=19.645 //y=5.39 //x2=19.545 //y2=5.205
cc_1060 ( N_noxref_11_M31_noxref_d N_noxref_15_M32_noxref_d ) capacitor \
 c=0.0458293f //x=19.105 //y=5.205 //x2=19.545 //y2=5.205
cc_1061 ( N_noxref_14_M28_noxref_d N_noxref_15_M29_noxref_s ) capacitor \
 c=0.00195151f //x=16.215 //y=5.205 //x2=17.795 //y2=5.205
