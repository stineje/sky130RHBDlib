// File: DLATCH.spi.DLATCH.pxi
// Created: Thu Jan 22 07:05:41 2026
//
simulator lang=spectre
x_PM_DLATCH\%noxref_1 ( N_noxref_1_c_2_p N_noxref_1_c_6_p N_noxref_1_c_4_p \
 N_noxref_1_c_124_p N_noxref_1_c_99_p N_noxref_1_c_84_p N_noxref_1_c_23_p \
 N_noxref_1_c_71_p N_noxref_1_c_7_p N_noxref_1_c_5_p N_noxref_1_c_10_p \
 N_noxref_1_c_3_p N_noxref_1_c_74_p N_noxref_1_c_30_p N_noxref_1_c_40_p \
 N_noxref_1_c_11_p N_noxref_1_c_8_p N_noxref_1_c_75_p N_noxref_1_c_32_p \
 N_noxref_1_c_92_p N_noxref_1_c_97_p N_noxref_1_c_25_p N_noxref_1_c_12_p \
 N_noxref_1_M1_noxref_g N_noxref_1_M13_noxref_g N_noxref_1_M14_noxref_g \
 N_noxref_1_c_54_p N_noxref_1_c_55_p N_noxref_1_c_57_p N_noxref_1_c_42_p \
 N_noxref_1_c_173_p N_noxref_1_c_174_p N_noxref_1_c_56_p N_noxref_1_c_58_p \
 N_noxref_1_c_15_p N_noxref_1_M0_noxref_d N_noxref_1_M11_noxref_d )  \
 PM_DLATCH\%noxref_1
x_PM_DLATCH\%noxref_2 ( N_noxref_2_c_221_n N_noxref_2_c_222_n \
 N_noxref_2_c_285_p N_noxref_2_c_263_p N_noxref_2_c_255_p N_noxref_2_c_224_n \
 N_noxref_2_c_246_p N_noxref_2_c_226_n N_noxref_2_c_244_p N_noxref_2_c_272_p \
 N_noxref_2_c_248_p N_noxref_2_c_229_n N_noxref_2_c_257_p N_noxref_2_c_383_p \
 N_noxref_2_c_236_n N_noxref_2_c_249_p N_noxref_2_c_345_p N_noxref_2_c_276_p \
 N_noxref_2_c_269_p N_noxref_2_c_250_p N_noxref_2_c_277_p N_noxref_2_c_237_n \
 N_noxref_2_c_259_p N_noxref_2_c_348_p N_noxref_2_c_354_p \
 N_noxref_2_M3_noxref_g N_noxref_2_M17_noxref_g N_noxref_2_M18_noxref_g \
 N_noxref_2_c_359_p N_noxref_2_c_325_p N_noxref_2_c_326_p N_noxref_2_c_327_p \
 N_noxref_2_c_340_p N_noxref_2_c_356_p N_noxref_2_c_361_p N_noxref_2_c_328_p \
 N_noxref_2_c_363_p N_noxref_2_c_329_p N_noxref_2_c_336_p \
 N_noxref_2_M2_noxref_d N_noxref_2_M13_noxref_d N_noxref_2_M15_noxref_d )  \
 PM_DLATCH\%noxref_2
x_PM_DLATCH\%GATE ( GATE GATE GATE GATE GATE GATE GATE GATE GATE \
 N_GATE_c_495_n N_GATE_c_496_n N_GATE_c_603_p N_GATE_c_499_n N_GATE_c_614_p \
 N_GATE_c_611_p N_GATE_c_549_n N_GATE_c_553_n N_GATE_c_557_n N_GATE_c_560_n \
 N_GATE_c_502_n N_GATE_c_503_n N_GATE_c_507_n N_GATE_c_605_p N_GATE_c_607_p \
 N_GATE_M2_noxref_g N_GATE_M4_noxref_g N_GATE_M15_noxref_g N_GATE_M16_noxref_g \
 N_GATE_M19_noxref_g N_GATE_M20_noxref_g N_GATE_c_513_n N_GATE_c_516_n \
 N_GATE_c_518_n N_GATE_c_580_n N_GATE_c_583_n N_GATE_c_585_n N_GATE_c_521_n \
 N_GATE_c_522_n N_GATE_c_638_p N_GATE_c_639_p N_GATE_c_641_p N_GATE_c_616_p \
 N_GATE_c_714_p N_GATE_c_715_p N_GATE_c_640_p N_GATE_c_642_p N_GATE_c_523_n \
 N_GATE_c_596_n N_GATE_c_526_n N_GATE_c_608_p )  PM_DLATCH\%GATE
x_PM_DLATCH\%D ( D D D D D D D D D D D D D N_D_c_777_n N_D_c_778_n N_D_c_843_n \
 N_D_c_844_n N_D_c_779_n N_D_c_847_n N_D_c_780_n N_D_c_850_n N_D_c_781_n \
 N_D_c_791_n N_D_c_792_n N_D_c_861_n N_D_c_865_n N_D_M0_noxref_g \
 N_D_M5_noxref_g N_D_M11_noxref_g N_D_M12_noxref_g N_D_M21_noxref_g \
 N_D_M22_noxref_g N_D_c_799_n N_D_c_801_n N_D_c_804_n N_D_c_805_n N_D_c_806_n \
 N_D_c_810_n N_D_c_811_n N_D_c_813_n N_D_c_817_n N_D_c_819_n N_D_c_871_n \
 N_D_c_874_n N_D_c_876_n N_D_c_915_p N_D_c_927_p N_D_c_896_p N_D_c_879_n \
 N_D_c_880_n N_D_c_822_n N_D_c_881_n N_D_c_898_p N_D_c_884_n )  PM_DLATCH\%D
x_PM_DLATCH\%noxref_5 ( N_noxref_5_c_1040_n N_noxref_5_c_1061_n \
 N_noxref_5_c_1066_n N_noxref_5_c_1067_n N_noxref_5_c_1120_p \
 N_noxref_5_c_1041_n N_noxref_5_c_1074_n N_noxref_5_c_1042_n \
 N_noxref_5_c_1084_n N_noxref_5_c_1128_p N_noxref_5_c_1085_n \
 N_noxref_5_c_1043_n N_noxref_5_c_1088_n N_noxref_5_c_1198_p \
 N_noxref_5_c_1092_n N_noxref_5_c_1098_n N_noxref_5_c_1159_p \
 N_noxref_5_c_1160_p N_noxref_5_c_1127_p N_noxref_5_c_1099_n \
 N_noxref_5_c_1131_p N_noxref_5_c_1049_n N_noxref_5_c_1100_n \
 N_noxref_5_c_1162_p N_noxref_5_c_1168_p N_noxref_5_M6_noxref_g \
 N_noxref_5_M23_noxref_g N_noxref_5_M24_noxref_g N_noxref_5_c_1173_p \
 N_noxref_5_c_1138_p N_noxref_5_c_1139_p N_noxref_5_c_1140_p \
 N_noxref_5_c_1153_p N_noxref_5_c_1170_p N_noxref_5_c_1175_p \
 N_noxref_5_c_1141_p N_noxref_5_c_1177_p N_noxref_5_c_1142_p \
 N_noxref_5_c_1149_p N_noxref_5_M5_noxref_d N_noxref_5_M19_noxref_d \
 N_noxref_5_M21_noxref_d )  PM_DLATCH\%noxref_5
x_PM_DLATCH\%noxref_6 ( N_noxref_6_c_1298_n N_noxref_6_c_1305_n \
 N_noxref_6_c_1309_n N_noxref_6_c_1310_n N_noxref_6_c_1312_n \
 N_noxref_6_c_1313_n N_noxref_6_c_1316_n N_noxref_6_c_1325_n \
 N_noxref_6_c_1327_n N_noxref_6_c_1385_n N_noxref_6_c_1422_p \
 N_noxref_6_c_1386_n N_noxref_6_c_1332_n N_noxref_6_c_1340_n \
 N_noxref_6_c_1459_p N_noxref_6_c_1408_p N_noxref_6_c_1448_p \
 N_noxref_6_c_1363_n N_noxref_6_c_1396_n N_noxref_6_c_1399_n \
 N_noxref_6_c_1403_n N_noxref_6_c_1341_n N_noxref_6_c_1342_n \
 N_noxref_6_c_1407_p N_noxref_6_c_1409_p N_noxref_6_M7_noxref_g \
 N_noxref_6_M25_noxref_g N_noxref_6_M26_noxref_g N_noxref_6_c_1410_p \
 N_noxref_6_c_1411_p N_noxref_6_c_1417_p N_noxref_6_c_1418_p \
 N_noxref_6_c_1412_p N_noxref_6_c_1413_p N_noxref_6_c_1466_p \
 N_noxref_6_c_1414_p N_noxref_6_c_1415_p N_noxref_6_c_1479_p \
 N_noxref_6_M3_noxref_d N_noxref_6_M17_noxref_d )  PM_DLATCH\%noxref_6
x_PM_DLATCH\%Q ( Q Q Q Q Q Q Q Q Q Q N_Q_c_1602_n N_Q_c_1597_n N_Q_c_1615_n \
 N_Q_c_1598_n N_Q_c_1703_p N_Q_c_1621_n N_Q_c_1740_p N_Q_c_1720_p N_Q_c_1698_p \
 N_Q_c_1642_p N_Q_c_1748_p N_Q_c_1634_p N_Q_c_1649_p N_Q_c_1652_p N_Q_c_1699_p \
 N_Q_c_1643_p N_Q_c_1662_p N_Q_c_1756_p N_Q_c_1653_p N_Q_c_1644_p \
 N_Q_M9_noxref_g N_Q_M29_noxref_g N_Q_M30_noxref_g N_Q_c_1675_p N_Q_c_1677_p \
 N_Q_c_1678_p N_Q_c_1651_p N_Q_c_1708_p N_Q_c_1709_p N_Q_c_1654_p N_Q_c_1676_p \
 N_Q_c_1679_p N_Q_c_1671_p N_Q_M7_noxref_d N_Q_M8_noxref_d N_Q_M27_noxref_d )  \
 PM_DLATCH\%Q
x_PM_DLATCH\%noxref_8 ( N_noxref_8_c_1902_n N_noxref_8_c_1909_n \
 N_noxref_8_c_1913_n N_noxref_8_c_1914_n N_noxref_8_c_1916_n \
 N_noxref_8_c_1917_n N_noxref_8_c_1920_n N_noxref_8_c_1930_n \
 N_noxref_8_c_1932_n N_noxref_8_c_1982_n N_noxref_8_c_1990_n \
 N_noxref_8_c_1937_n N_noxref_8_c_1901_n N_noxref_8_c_1993_n \
 N_noxref_8_c_1994_n N_noxref_8_c_1997_n N_noxref_8_c_2000_n \
 N_noxref_8_c_1947_n N_noxref_8_c_2002_n N_noxref_8_c_1971_n \
 N_noxref_8_c_1948_n N_noxref_8_c_2009_n N_noxref_8_c_2013_n \
 N_noxref_8_M10_noxref_g N_noxref_8_M31_noxref_g N_noxref_8_M32_noxref_g \
 N_noxref_8_c_2020_n N_noxref_8_c_2022_n N_noxref_8_c_2025_n \
 N_noxref_8_c_2065_p N_noxref_8_c_2049_p N_noxref_8_c_2027_n \
 N_noxref_8_c_2028_n N_noxref_8_c_2029_n N_noxref_8_c_2030_n \
 N_noxref_8_c_2033_n N_noxref_8_c_2034_n N_noxref_8_M6_noxref_d \
 N_noxref_8_M23_noxref_d )  PM_DLATCH\%noxref_8
x_PM_DLATCH\%noxref_9 ( N_noxref_9_c_2181_n N_noxref_9_c_2183_n \
 N_noxref_9_c_2236_n N_noxref_9_c_2245_n N_noxref_9_c_2252_n \
 N_noxref_9_c_2253_n N_noxref_9_c_2336_n N_noxref_9_c_2259_n \
 N_noxref_9_c_2346_n N_noxref_9_c_2347_n N_noxref_9_c_2261_n \
 N_noxref_9_c_2353_n N_noxref_9_c_2263_n N_noxref_9_c_2186_n \
 N_noxref_9_c_2189_n N_noxref_9_c_2192_n N_noxref_9_c_2193_n \
 N_noxref_9_c_2273_n N_noxref_9_c_2371_n N_noxref_9_c_2195_n \
 N_noxref_9_c_2373_n N_noxref_9_c_2276_n N_noxref_9_c_2197_n \
 N_noxref_9_c_2201_n N_noxref_9_c_2379_n N_noxref_9_M8_noxref_g \
 N_noxref_9_M27_noxref_g N_noxref_9_M28_noxref_g N_noxref_9_c_2208_n \
 N_noxref_9_c_2210_n N_noxref_9_c_2213_n N_noxref_9_c_2300_n \
 N_noxref_9_c_2303_n N_noxref_9_c_2215_n N_noxref_9_c_2216_n \
 N_noxref_9_c_2217_n N_noxref_9_c_2218_n N_noxref_9_c_2221_n \
 N_noxref_9_c_2222_n N_noxref_9_M9_noxref_d N_noxref_9_M10_noxref_d \
 N_noxref_9_M31_noxref_d )  PM_DLATCH\%noxref_9
x_PM_DLATCH\%VDD ( VDD N_VDD_c_2464_n N_VDD_c_2679_n N_VDD_c_2681_n \
 N_VDD_c_2715_n N_VDD_c_2717_n N_VDD_c_2719_n N_VDD_c_2774_n N_VDD_c_2470_n \
 N_VDD_c_2473_n N_VDD_c_2512_n N_VDD_c_2517_n N_VDD_c_2560_n N_VDD_c_2583_n \
 N_VDD_c_2638_n N_VDD_c_2686_n N_VDD_c_2723_n N_VDD_c_2476_n N_VDD_c_2479_n \
 N_VDD_c_2523_n N_VDD_c_2531_n N_VDD_c_2600_n N_VDD_c_2652_n N_VDD_c_2700_n \
 N_VDD_M11_noxref_s N_VDD_M12_noxref_d N_VDD_M13_noxref_s N_VDD_M14_noxref_d \
 N_VDD_M16_noxref_d N_VDD_M17_noxref_s N_VDD_M18_noxref_d N_VDD_M19_noxref_s \
 N_VDD_M20_noxref_d N_VDD_M22_noxref_d N_VDD_M23_noxref_s N_VDD_M24_noxref_d \
 N_VDD_M25_noxref_d N_VDD_M29_noxref_d )  PM_DLATCH\%VDD
x_PM_DLATCH\%GND ( GND N_GND_c_2872_n N_GND_c_2919_n N_GND_c_2995_n \
 N_GND_c_2878_n N_GND_c_2889_n N_GND_c_2959_n N_GND_c_2970_n N_GND_c_2892_n \
 N_GND_c_2893_n N_GND_c_3239_p N_GND_c_2896_n N_GND_c_3234_p N_GND_c_2931_n \
 N_GND_c_2935_n N_GND_c_3267_p N_GND_c_2974_n N_GND_c_3262_p N_GND_c_3034_n \
 N_GND_c_3038_n N_GND_c_3073_n N_GND_c_3111_n N_GND_c_3115_n N_GND_c_3151_n \
 N_GND_c_2897_n N_GND_c_2899_n N_GND_c_2937_n N_GND_c_2944_n N_GND_c_3010_n \
 N_GND_c_3048_n N_GND_c_3122_n N_GND_c_2905_n N_GND_M0_noxref_s \
 N_GND_M1_noxref_d N_GND_M3_noxref_s N_GND_M4_noxref_d N_GND_M6_noxref_s \
 N_GND_M7_noxref_s N_GND_M9_noxref_s )  PM_DLATCH\%GND
x_PM_DLATCH\%noxref_12 ( N_noxref_12_c_3273_n N_noxref_12_c_3292_n \
 N_noxref_12_c_3279_n N_noxref_12_c_3283_n N_noxref_12_c_3284_n \
 N_noxref_12_c_3299_n N_noxref_12_c_3285_n N_noxref_12_c_3289_n \
 N_noxref_12_M25_noxref_s N_noxref_12_M26_noxref_d N_noxref_12_M28_noxref_d )  \
 PM_DLATCH\%noxref_12
x_PM_DLATCH\%noxref_13 ( N_noxref_13_c_3368_n N_noxref_13_c_3390_n \
 N_noxref_13_c_3375_n N_noxref_13_c_3381_n N_noxref_13_c_3382_n \
 N_noxref_13_c_3402_n N_noxref_13_c_3383_n N_noxref_13_c_3387_n \
 N_noxref_13_M29_noxref_s N_noxref_13_M30_noxref_d N_noxref_13_M32_noxref_d )  \
 PM_DLATCH\%noxref_13
x_PM_DLATCH\%noxref_14 ( N_noxref_14_c_3459_n N_noxref_14_c_3461_n \
 N_noxref_14_c_3503_n N_noxref_14_c_3469_n N_noxref_14_c_3474_n \
 N_noxref_14_c_3512_n N_noxref_14_M1_noxref_s )  PM_DLATCH\%noxref_14
x_PM_DLATCH\%noxref_15 ( N_noxref_15_c_3525_n N_noxref_15_c_3527_n \
 N_noxref_15_c_3569_n N_noxref_15_c_3535_n N_noxref_15_c_3543_n \
 N_noxref_15_c_3578_n N_noxref_15_M4_noxref_s )  PM_DLATCH\%noxref_15
cc_1 ( N_noxref_1_M14_noxref_g N_noxref_2_c_221_n ) capacitor c=0.00967396f \
 //x=4.16 //y=6.2 //x2=4.705 //y2=5.38
cc_2 ( N_noxref_1_c_2_p N_noxref_2_c_222_n ) capacitor c=0.00495291f //x=1.6 \
 //y=1.935 //x2=4.86 //y2=1.75
cc_3 ( N_noxref_1_c_3_p N_noxref_2_c_222_n ) capacitor c=4.16137e-19 //x=1.6 \
 //y=1.185 //x2=4.86 //y2=1.75
cc_4 ( N_noxref_1_c_4_p N_noxref_2_c_224_n ) capacitor c=0.00198687f //x=1.885 \
 //y=2.02 //x2=5.3 //y2=3.35
cc_5 ( N_noxref_1_c_5_p N_noxref_2_c_224_n ) capacitor c=0.00388612f //x=3.82 \
 //y=3.72 //x2=5.3 //y2=3.35
cc_6 ( N_noxref_1_c_6_p N_noxref_2_c_226_n ) capacitor c=6.68558e-19 //x=1.605 \
 //y=5.42 //x2=5.3 //y2=5.295
cc_7 ( N_noxref_1_c_7_p N_noxref_2_c_226_n ) capacitor c=0.00217431f //x=1.97 \
 //y=5.055 //x2=5.3 //y2=5.295
cc_8 ( N_noxref_1_c_8_p N_noxref_2_c_226_n ) capacitor c=0.00224784f //x=3.822 \
 //y=4.74 //x2=5.3 //y2=5.295
cc_9 ( N_noxref_1_c_6_p N_noxref_2_c_229_n ) capacitor c=6.32156e-19 //x=1.605 \
 //y=5.42 //x2=3.94 //y2=5.56
cc_10 ( N_noxref_1_c_10_p N_noxref_2_c_229_n ) capacitor c=9.87004e-19 \
 //x=3.82 //y=4.025 //x2=3.94 //y2=5.56
cc_11 ( N_noxref_1_c_11_p N_noxref_2_c_229_n ) capacitor c=0.0118019f //x=3.82 \
 //y=4.88 //x2=3.94 //y2=5.56
cc_12 ( N_noxref_1_c_12_p N_noxref_2_c_229_n ) capacitor c=0.00277154f \
 //x=3.82 //y=4.88 //x2=3.94 //y2=5.56
cc_13 ( N_noxref_1_M13_noxref_g N_noxref_2_c_229_n ) capacitor c=0.00203628f \
 //x=3.72 //y=6.2 //x2=3.94 //y2=5.56
cc_14 ( N_noxref_1_M14_noxref_g N_noxref_2_c_229_n ) capacitor c=0.00192712f \
 //x=4.16 //y=6.2 //x2=3.94 //y2=5.56
cc_15 ( N_noxref_1_c_15_p N_noxref_2_c_229_n ) capacitor c=0.00182904f \
 //x=3.82 //y=4.88 //x2=3.94 //y2=5.56
cc_16 ( N_noxref_1_c_3_p N_noxref_2_c_236_n ) capacitor c=6.80839e-19 //x=1.6 \
 //y=1.185 //x2=4.86 //y2=1.18
cc_17 ( N_noxref_1_c_10_p N_noxref_2_c_237_n ) capacitor c=2.93593e-19 \
 //x=3.82 //y=4.025 //x2=3.94 //y2=5.56
cc_18 ( N_noxref_1_c_11_p N_noxref_2_c_237_n ) capacitor c=0.00104426f \
 //x=3.82 //y=4.88 //x2=3.94 //y2=5.56
cc_19 ( N_noxref_1_c_12_p N_noxref_2_c_237_n ) capacitor c=0.00377369f \
 //x=3.82 //y=4.88 //x2=3.94 //y2=5.56
cc_20 ( N_noxref_1_M13_noxref_g N_noxref_2_c_237_n ) capacitor c=0.0158358f \
 //x=3.72 //y=6.2 //x2=3.94 //y2=5.56
cc_21 ( N_noxref_1_M14_noxref_g N_noxref_2_c_237_n ) capacitor c=0.0178987f \
 //x=4.16 //y=6.2 //x2=3.94 //y2=5.56
cc_22 ( N_noxref_1_c_15_p N_noxref_2_c_237_n ) capacitor c=0.0043218f //x=3.82 \
 //y=4.88 //x2=3.94 //y2=5.56
cc_23 ( N_noxref_1_c_23_p GATE ) capacitor c=0.00178606f //x=1.97 //y=3.72 \
 //x2=4.56 //y2=2.77
cc_24 ( N_noxref_1_c_5_p GATE ) capacitor c=0.0259743f //x=3.82 //y=3.72 \
 //x2=4.56 //y2=2.77
cc_25 ( N_noxref_1_c_25_p GATE ) capacitor c=3.49899e-19 //x=3.82 //y=2.26 \
 //x2=4.56 //y2=2.77
cc_26 ( N_noxref_1_c_23_p GATE ) capacitor c=7.07873e-19 //x=1.97 //y=3.72 \
 //x2=4.56 //y2=3.51
cc_27 ( N_noxref_1_c_7_p GATE ) capacitor c=0.00192226f //x=1.97 //y=5.055 \
 //x2=4.56 //y2=3.51
cc_28 ( N_noxref_1_c_5_p GATE ) capacitor c=0.0183701f //x=3.82 //y=3.72 \
 //x2=4.56 //y2=3.51
cc_29 ( N_noxref_1_c_10_p GATE ) capacitor c=0.0148337f //x=3.82 //y=4.025 \
 //x2=4.56 //y2=3.51
cc_30 ( N_noxref_1_c_30_p GATE ) capacitor c=8.35899e-19 //x=3.82 //y=3.88 \
 //x2=4.56 //y2=3.51
cc_31 ( N_noxref_1_c_8_p GATE ) capacitor c=0.0285269f //x=3.822 //y=4.74 \
 //x2=4.56 //y2=3.51
cc_32 ( N_noxref_1_c_32_p GATE ) capacitor c=0.00661365f //x=3.83 //y=3.865 \
 //x2=4.56 //y2=3.51
cc_33 ( N_noxref_1_c_12_p GATE ) capacitor c=3.02466e-19 //x=3.82 //y=4.88 \
 //x2=4.56 //y2=3.51
cc_34 ( N_noxref_1_c_15_p GATE ) capacitor c=0.00108965f //x=3.82 //y=4.88 \
 //x2=4.56 //y2=3.51
cc_35 ( N_noxref_1_c_5_p GATE ) capacitor c=0.00103412f //x=3.82 //y=3.72 \
 //x2=4.56 //y2=3.14
cc_36 ( N_noxref_1_c_5_p N_GATE_c_495_n ) capacitor c=0.0144144f //x=3.82 \
 //y=3.72 //x2=4.56 //y2=3.305
cc_37 ( N_noxref_1_c_11_p N_GATE_c_496_n ) capacitor c=0.0172958f //x=3.82 \
 //y=4.88 //x2=4.56 //y2=4.735
cc_38 ( N_noxref_1_c_12_p N_GATE_c_496_n ) capacitor c=4.73677e-19 //x=3.82 \
 //y=4.88 //x2=4.56 //y2=4.735
cc_39 ( N_noxref_1_c_15_p N_GATE_c_496_n ) capacitor c=9.22067e-19 //x=3.82 \
 //y=4.88 //x2=4.56 //y2=4.735
cc_40 ( N_noxref_1_c_40_p N_GATE_c_499_n ) capacitor c=0.0205342f //x=3.82 \
 //y=2.26 //x2=4.56 //y2=2.26
cc_41 ( N_noxref_1_c_25_p N_GATE_c_499_n ) capacitor c=5.16867e-19 //x=3.82 \
 //y=2.26 //x2=4.56 //y2=2.26
cc_42 ( N_noxref_1_c_42_p N_GATE_c_499_n ) capacitor c=0.00167888f //x=3.625 \
 //y=2.095 //x2=4.56 //y2=2.26
cc_43 ( N_noxref_1_c_5_p N_GATE_c_502_n ) capacitor c=0.0065845f //x=3.82 \
 //y=3.72 //x2=4.715 //y2=3.152
cc_44 ( N_noxref_1_c_5_p N_GATE_c_503_n ) capacitor c=3.49899e-19 //x=3.82 \
 //y=3.72 //x2=4.56 //y2=2.26
cc_45 ( N_noxref_1_c_40_p N_GATE_c_503_n ) capacitor c=5.24723e-19 //x=3.82 \
 //y=2.26 //x2=4.56 //y2=2.26
cc_46 ( N_noxref_1_c_25_p N_GATE_c_503_n ) capacitor c=0.00485709f //x=3.82 \
 //y=2.26 //x2=4.56 //y2=2.26
cc_47 ( N_noxref_1_c_42_p N_GATE_c_503_n ) capacitor c=0.00190888f //x=3.625 \
 //y=2.095 //x2=4.56 //y2=2.26
cc_48 ( N_noxref_1_c_11_p N_GATE_c_507_n ) capacitor c=4.80626e-19 //x=3.82 \
 //y=4.88 //x2=4.59 //y2=4.88
cc_49 ( N_noxref_1_c_12_p N_GATE_c_507_n ) capacitor c=0.00397338f //x=3.82 \
 //y=4.88 //x2=4.59 //y2=4.88
cc_50 ( N_noxref_1_c_15_p N_GATE_c_507_n ) capacitor c=0.00283894f //x=3.82 \
 //y=4.88 //x2=4.59 //y2=4.88
cc_51 ( N_noxref_1_M13_noxref_g N_GATE_M15_noxref_g ) capacitor c=0.0104892f \
 //x=3.72 //y=6.2 //x2=4.6 //y2=6.2
cc_52 ( N_noxref_1_M14_noxref_g N_GATE_M15_noxref_g ) capacitor c=0.107636f \
 //x=4.16 //y=6.2 //x2=4.6 //y2=6.2
cc_53 ( N_noxref_1_M14_noxref_g N_GATE_M16_noxref_g ) capacitor c=0.0100341f \
 //x=4.16 //y=6.2 //x2=5.04 //y2=6.2
cc_54 ( N_noxref_1_c_54_p N_GATE_c_513_n ) capacitor c=4.86545e-19 //x=3.625 \
 //y=1.045 //x2=4.595 //y2=1.085
cc_55 ( N_noxref_1_c_55_p N_GATE_c_513_n ) capacitor c=0.00152405f //x=3.625 \
 //y=1.39 //x2=4.595 //y2=1.085
cc_56 ( N_noxref_1_c_56_p N_GATE_c_513_n ) capacitor c=0.0151475f //x=4.155 \
 //y=1.045 //x2=4.595 //y2=1.085
cc_57 ( N_noxref_1_c_57_p N_GATE_c_516_n ) capacitor c=0.00109982f //x=3.625 \
 //y=1.7 //x2=4.595 //y2=1.43
cc_58 ( N_noxref_1_c_58_p N_GATE_c_516_n ) capacitor c=0.0111064f //x=4.155 \
 //y=1.39 //x2=4.595 //y2=1.43
cc_59 ( N_noxref_1_c_57_p N_GATE_c_518_n ) capacitor c=9.58243e-19 //x=3.625 \
 //y=1.7 //x2=4.595 //y2=1.74
cc_60 ( N_noxref_1_c_42_p N_GATE_c_518_n ) capacitor c=0.00662747f //x=3.625 \
 //y=2.095 //x2=4.595 //y2=1.74
cc_61 ( N_noxref_1_c_58_p N_GATE_c_518_n ) capacitor c=0.00862358f //x=4.155 \
 //y=1.39 //x2=4.595 //y2=1.74
cc_62 ( N_noxref_1_c_56_p N_GATE_c_521_n ) capacitor c=0.00127211f //x=4.155 \
 //y=1.045 //x2=5.125 //y2=1.085
cc_63 ( N_noxref_1_c_58_p N_GATE_c_522_n ) capacitor c=0.00204774f //x=4.155 \
 //y=1.39 //x2=5.125 //y2=1.43
cc_64 ( N_noxref_1_c_40_p N_GATE_c_523_n ) capacitor c=0.00167305f //x=3.82 \
 //y=2.26 //x2=4.56 //y2=2.26
cc_65 ( N_noxref_1_c_25_p N_GATE_c_523_n ) capacitor c=0.00266443f //x=3.82 \
 //y=2.26 //x2=4.56 //y2=2.26
cc_66 ( N_noxref_1_c_42_p N_GATE_c_523_n ) capacitor c=0.0181449f //x=3.625 \
 //y=2.095 //x2=4.56 //y2=2.26
cc_67 ( N_noxref_1_c_11_p N_GATE_c_526_n ) capacitor c=0.00158715f //x=3.82 \
 //y=4.88 //x2=4.59 //y2=4.88
cc_68 ( N_noxref_1_c_12_p N_GATE_c_526_n ) capacitor c=0.00237977f //x=3.82 \
 //y=4.88 //x2=4.59 //y2=4.88
cc_69 ( N_noxref_1_c_15_p N_GATE_c_526_n ) capacitor c=0.0297875f //x=3.82 \
 //y=4.88 //x2=4.59 //y2=4.88
cc_70 ( N_noxref_1_c_23_p D ) capacitor c=0.0594341f //x=1.97 //y=3.72 \
 //x2=1.23 //y2=2.77
cc_71 ( N_noxref_1_c_71_p D ) capacitor c=0.0147423f //x=1.97 //y=4.025 \
 //x2=1.23 //y2=2.77
cc_72 ( N_noxref_1_c_7_p D ) capacitor c=0.00369026f //x=1.97 //y=5.055 \
 //x2=1.23 //y2=2.77
cc_73 ( N_noxref_1_c_5_p D ) capacitor c=0.00303746f //x=3.82 //y=3.72 \
 //x2=1.23 //y2=2.77
cc_74 ( N_noxref_1_c_74_p D ) capacitor c=0.00539621f //x=1.97 //y=3.88 \
 //x2=1.23 //y2=2.77
cc_75 ( N_noxref_1_c_75_p D ) capacitor c=0.00658039f //x=2.125 //y=3.872 \
 //x2=1.23 //y2=2.77
cc_76 ( N_noxref_1_c_7_p D ) capacitor c=0.0149262f //x=1.97 //y=5.055 \
 //x2=1.23 //y2=4.62
cc_77 ( N_noxref_1_c_8_p D ) capacitor c=0.00103783f //x=3.822 //y=4.74 \
 //x2=1.23 //y2=4.62
cc_78 ( N_noxref_1_c_7_p D ) capacitor c=0.00103412f //x=1.97 //y=5.055 \
 //x2=1.23 //y2=4.25
cc_79 ( N_noxref_1_c_7_p N_D_c_777_n ) capacitor c=0.0170559f //x=1.97 \
 //y=5.055 //x2=1.23 //y2=4.415
cc_80 ( N_noxref_1_c_7_p N_D_c_778_n ) capacitor c=0.0169388f //x=1.97 \
 //y=5.055 //x2=1.23 //y2=4.76
cc_81 ( N_noxref_1_c_23_p N_D_c_779_n ) capacitor c=0.0181783f //x=1.97 \
 //y=3.72 //x2=1.23 //y2=2.265
cc_82 ( N_noxref_1_c_7_p N_D_c_780_n ) capacitor c=0.00294615f //x=1.97 \
 //y=5.055 //x2=1.39 //y2=4.262
cc_83 ( N_noxref_1_c_6_p N_D_c_781_n ) capacitor c=6.95554e-19 //x=1.605 \
 //y=5.42 //x2=9.95 //y2=4.262
cc_84 ( N_noxref_1_c_84_p N_D_c_781_n ) capacitor c=0.0122741f //x=1.69 \
 //y=5.14 //x2=9.95 //y2=4.262
cc_85 ( N_noxref_1_c_71_p N_D_c_781_n ) capacitor c=0.00677566f //x=1.97 \
 //y=4.025 //x2=9.95 //y2=4.262
cc_86 ( N_noxref_1_c_7_p N_D_c_781_n ) capacitor c=0.0265003f //x=1.97 \
 //y=5.055 //x2=9.95 //y2=4.262
cc_87 ( N_noxref_1_c_10_p N_D_c_781_n ) capacitor c=0.00714163f //x=3.82 \
 //y=4.025 //x2=9.95 //y2=4.262
cc_88 ( N_noxref_1_c_11_p N_D_c_781_n ) capacitor c=0.00240472f //x=3.82 \
 //y=4.88 //x2=9.95 //y2=4.262
cc_89 ( N_noxref_1_c_8_p N_D_c_781_n ) capacitor c=0.0267501f //x=3.822 \
 //y=4.74 //x2=9.95 //y2=4.262
cc_90 ( N_noxref_1_c_75_p N_D_c_781_n ) capacitor c=0.0374339f //x=2.125 \
 //y=3.872 //x2=9.95 //y2=4.262
cc_91 ( N_noxref_1_c_32_p N_D_c_781_n ) capacitor c=0.0374339f //x=3.83 \
 //y=3.865 //x2=9.95 //y2=4.262
cc_92 ( N_noxref_1_c_92_p N_D_c_781_n ) capacitor c=0.14651f //x=3.67 \
 //y=3.872 //x2=9.95 //y2=4.262
cc_93 ( N_noxref_1_c_23_p N_D_c_791_n ) capacitor c=4.71798e-19 //x=1.97 \
 //y=3.72 //x2=1.23 //y2=2.265
cc_94 ( N_noxref_1_c_7_p N_D_c_792_n ) capacitor c=0.00160039f //x=1.97 \
 //y=5.055 //x2=1.23 //y2=4.88
cc_95 ( N_noxref_1_c_6_p N_D_M11_noxref_g ) capacitor c=0.00141266f //x=1.605 \
 //y=5.42 //x2=1.385 //y2=6.2
cc_96 ( N_noxref_1_c_84_p N_D_M11_noxref_g ) capacitor c=0.00534267f //x=1.69 \
 //y=5.14 //x2=1.385 //y2=6.2
cc_97 ( N_noxref_1_c_97_p N_D_M11_noxref_g ) capacitor c=0.0162066f //x=1.605 \
 //y=5.56 //x2=1.385 //y2=6.2
cc_98 ( N_noxref_1_c_6_p N_D_M12_noxref_g ) capacitor c=0.0035262f //x=1.605 \
 //y=5.42 //x2=1.825 //y2=6.2
cc_99 ( N_noxref_1_c_99_p N_D_M12_noxref_g ) capacitor c=0.00931174f //x=1.885 \
 //y=5.14 //x2=1.825 //y2=6.2
cc_100 ( N_noxref_1_c_97_p N_D_M12_noxref_g ) capacitor c=0.0162066f //x=1.605 \
 //y=5.56 //x2=1.825 //y2=6.2
cc_101 ( N_noxref_1_c_3_p N_D_c_799_n ) capacitor c=0.00187726f //x=1.6 \
 //y=1.185 //x2=1.34 //y2=1.09
cc_102 ( N_noxref_1_M0_noxref_d N_D_c_799_n ) capacitor c=0.00137914f \
 //x=1.415 //y=1.09 //x2=1.34 //y2=1.09
cc_103 ( N_noxref_1_c_2_p N_D_c_801_n ) capacitor c=0.0012792f //x=1.6 \
 //y=1.935 //x2=1.34 //y2=1.435
cc_104 ( N_noxref_1_c_3_p N_D_c_801_n ) capacitor c=0.00414335f //x=1.6 \
 //y=1.185 //x2=1.34 //y2=1.435
cc_105 ( N_noxref_1_M0_noxref_d N_D_c_801_n ) capacitor c=0.0023891f //x=1.415 \
 //y=1.09 //x2=1.34 //y2=1.435
cc_106 ( N_noxref_1_c_2_p N_D_c_804_n ) capacitor c=0.00561986f //x=1.6 \
 //y=1.935 //x2=1.34 //y2=1.745
cc_107 ( N_noxref_1_c_2_p N_D_c_805_n ) capacitor c=0.00440271f //x=1.6 \
 //y=1.935 //x2=1.34 //y2=2.1
cc_108 ( N_noxref_1_c_84_p N_D_c_806_n ) capacitor c=0.00262283f //x=1.69 \
 //y=5.14 //x2=1.75 //y2=4.97
cc_109 ( N_noxref_1_c_71_p N_D_c_806_n ) capacitor c=0.00128136f //x=1.97 \
 //y=4.025 //x2=1.75 //y2=4.97
cc_110 ( N_noxref_1_c_7_p N_D_c_806_n ) capacitor c=0.00208891f //x=1.97 \
 //y=5.055 //x2=1.75 //y2=4.97
cc_111 ( N_noxref_1_c_97_p N_D_c_806_n ) capacitor c=0.00290963f //x=1.605 \
 //y=5.56 //x2=1.75 //y2=4.97
cc_112 ( N_noxref_1_c_7_p N_D_c_810_n ) capacitor c=0.00140024f //x=1.97 \
 //y=5.055 //x2=1.46 //y2=4.97
cc_113 ( N_noxref_1_c_3_p N_D_c_811_n ) capacitor c=5.57924e-19 //x=1.6 \
 //y=1.185 //x2=1.715 //y2=0.935
cc_114 ( N_noxref_1_M0_noxref_d N_D_c_811_n ) capacitor c=0.0020782f //x=1.415 \
 //y=1.09 //x2=1.715 //y2=0.935
cc_115 ( N_noxref_1_c_2_p N_D_c_813_n ) capacitor c=0.00953922f //x=1.6 \
 //y=1.935 //x2=1.715 //y2=1.59
cc_116 ( N_noxref_1_c_4_p N_D_c_813_n ) capacitor c=0.00180253f //x=1.885 \
 //y=2.02 //x2=1.715 //y2=1.59
cc_117 ( N_noxref_1_c_3_p N_D_c_813_n ) capacitor c=5.75878e-19 //x=1.6 \
 //y=1.185 //x2=1.715 //y2=1.59
cc_118 ( N_noxref_1_M0_noxref_d N_D_c_813_n ) capacitor c=0.00356097f \
 //x=1.415 //y=1.09 //x2=1.715 //y2=1.59
cc_119 ( N_noxref_1_c_3_p N_D_c_817_n ) capacitor c=0.00148146f //x=1.6 \
 //y=1.185 //x2=1.87 //y2=1.09
cc_120 ( N_noxref_1_M0_noxref_d N_D_c_817_n ) capacitor c=0.00138452f \
 //x=1.415 //y=1.09 //x2=1.87 //y2=1.09
cc_121 ( N_noxref_1_c_2_p N_D_c_819_n ) capacitor c=0.00344663f //x=1.6 \
 //y=1.935 //x2=1.87 //y2=1.435
cc_122 ( N_noxref_1_c_3_p N_D_c_819_n ) capacitor c=0.00356478f //x=1.6 \
 //y=1.185 //x2=1.87 //y2=1.435
cc_123 ( N_noxref_1_M0_noxref_d N_D_c_819_n ) capacitor c=0.00235934f \
 //x=1.415 //y=1.09 //x2=1.87 //y2=1.435
cc_124 ( N_noxref_1_c_124_p N_D_c_822_n ) capacitor c=0.00440271f //x=1.685 \
 //y=2.02 //x2=1.23 //y2=2.265
cc_125 ( N_noxref_1_c_23_p N_D_c_822_n ) capacitor c=0.00275704f //x=1.97 \
 //y=3.72 //x2=1.23 //y2=2.265
cc_126 ( N_noxref_1_c_6_p N_VDD_c_2464_n ) capacitor c=0.00259718f //x=1.605 \
 //y=5.42 //x2=14.955 //y2=7.585
cc_127 ( N_noxref_1_c_99_p N_VDD_c_2464_n ) capacitor c=0.00266633f //x=1.885 \
 //y=5.14 //x2=14.955 //y2=7.585
cc_128 ( N_noxref_1_c_10_p N_VDD_c_2464_n ) capacitor c=2.10171e-19 //x=3.82 \
 //y=4.025 //x2=14.955 //y2=7.585
cc_129 ( N_noxref_1_c_11_p N_VDD_c_2464_n ) capacitor c=9.07241e-19 //x=3.82 \
 //y=4.88 //x2=14.955 //y2=7.585
cc_130 ( N_noxref_1_c_97_p N_VDD_c_2464_n ) capacitor c=0.00241566f //x=1.605 \
 //y=5.56 //x2=14.955 //y2=7.585
cc_131 ( N_noxref_1_c_12_p N_VDD_c_2464_n ) capacitor c=6.22888e-19 //x=3.82 \
 //y=4.88 //x2=14.955 //y2=7.585
cc_132 ( N_noxref_1_c_6_p N_VDD_c_2470_n ) capacitor c=8.96756e-19 //x=1.605 \
 //y=5.42 //x2=1.96 //y2=7.585
cc_133 ( N_noxref_1_c_99_p N_VDD_c_2470_n ) capacitor c=0.00197507f //x=1.885 \
 //y=5.14 //x2=1.96 //y2=7.585
cc_134 ( N_noxref_1_c_97_p N_VDD_c_2470_n ) capacitor c=0.0138017f //x=1.605 \
 //y=5.56 //x2=1.96 //y2=7.585
cc_135 ( N_noxref_1_c_11_p N_VDD_c_2473_n ) capacitor c=6.28113e-19 //x=3.82 \
 //y=4.88 //x2=4.295 //y2=7.585
cc_136 ( N_noxref_1_M13_noxref_g N_VDD_c_2473_n ) capacitor c=0.00732618f \
 //x=3.72 //y=6.2 //x2=4.295 //y2=7.585
cc_137 ( N_noxref_1_M14_noxref_g N_VDD_c_2473_n ) capacitor c=0.00755544f \
 //x=4.16 //y=6.2 //x2=4.295 //y2=7.585
cc_138 ( N_noxref_1_c_84_p N_VDD_c_2476_n ) capacitor c=0.00685597f //x=1.69 \
 //y=5.14 //x2=1.23 //y2=7.58
cc_139 ( N_noxref_1_c_7_p N_VDD_c_2476_n ) capacitor c=2.43252e-19 //x=1.97 \
 //y=5.055 //x2=1.23 //y2=7.58
cc_140 ( N_noxref_1_c_97_p N_VDD_c_2476_n ) capacitor c=0.00823838f //x=1.605 \
 //y=5.56 //x2=1.23 //y2=7.58
cc_141 ( N_noxref_1_c_6_p N_VDD_c_2479_n ) capacitor c=0.00231872f //x=1.605 \
 //y=5.42 //x2=2.71 //y2=7.585
cc_142 ( N_noxref_1_c_7_p N_VDD_c_2479_n ) capacitor c=0.0218471f //x=1.97 \
 //y=5.055 //x2=2.71 //y2=7.585
cc_143 ( N_noxref_1_c_11_p N_VDD_c_2479_n ) capacitor c=0.00447349f //x=3.82 \
 //y=4.88 //x2=2.71 //y2=7.585
cc_144 ( N_noxref_1_c_8_p N_VDD_c_2479_n ) capacitor c=0.00704389f //x=3.822 \
 //y=4.74 //x2=2.71 //y2=7.585
cc_145 ( N_noxref_1_c_92_p N_VDD_c_2479_n ) capacitor c=0.00271717f //x=3.67 \
 //y=3.872 //x2=2.71 //y2=7.585
cc_146 ( N_noxref_1_c_97_p N_VDD_c_2479_n ) capacitor c=0.00824867f //x=1.605 \
 //y=5.56 //x2=2.71 //y2=7.585
cc_147 ( N_noxref_1_c_12_p N_VDD_c_2479_n ) capacitor c=0.00387138f //x=3.82 \
 //y=4.88 //x2=2.71 //y2=7.585
cc_148 ( N_noxref_1_c_15_p N_VDD_c_2479_n ) capacitor c=0.0117285f //x=3.82 \
 //y=4.88 //x2=2.71 //y2=7.585
cc_149 ( N_noxref_1_c_6_p N_VDD_M11_noxref_s ) capacitor c=0.0480012f \
 //x=1.605 //y=5.42 //x2=1.03 //y2=5.2
cc_150 ( N_noxref_1_c_97_p N_VDD_M11_noxref_s ) capacitor c=0.0922749f \
 //x=1.605 //y=5.56 //x2=1.03 //y2=5.2
cc_151 ( N_noxref_1_c_6_p N_VDD_M12_noxref_d ) capacitor c=0.0474638f \
 //x=1.605 //y=5.42 //x2=1.9 //y2=5.2
cc_152 ( N_noxref_1_c_99_p N_VDD_M12_noxref_d ) capacitor c=0.0210992f \
 //x=1.885 //y=5.14 //x2=1.9 //y2=5.2
cc_153 ( N_noxref_1_c_71_p N_VDD_M12_noxref_d ) capacitor c=0.00304924f \
 //x=1.97 //y=4.025 //x2=1.9 //y2=5.2
cc_154 ( N_noxref_1_c_74_p N_VDD_M12_noxref_d ) capacitor c=5.54681e-19 \
 //x=1.97 //y=3.88 //x2=1.9 //y2=5.2
cc_155 ( N_noxref_1_c_97_p N_VDD_M12_noxref_d ) capacitor c=0.0911955f \
 //x=1.605 //y=5.56 //x2=1.9 //y2=5.2
cc_156 ( N_noxref_1_c_6_p N_VDD_M13_noxref_s ) capacitor c=0.00155698f \
 //x=1.605 //y=5.42 //x2=3.365 //y2=5.2
cc_157 ( N_noxref_1_c_10_p N_VDD_M13_noxref_s ) capacitor c=0.00144564f \
 //x=3.82 //y=4.025 //x2=3.365 //y2=5.2
cc_158 ( N_noxref_1_M13_noxref_g N_VDD_M13_noxref_s ) capacitor c=0.0567929f \
 //x=3.72 //y=6.2 //x2=3.365 //y2=5.2
cc_159 ( N_noxref_1_M14_noxref_g N_VDD_M14_noxref_d ) capacitor c=0.015318f \
 //x=4.16 //y=6.2 //x2=4.235 //y2=5.2
cc_160 ( N_noxref_1_c_4_p N_GND_c_2872_n ) capacitor c=0.00499609f //x=1.885 \
 //y=2.02 //x2=3.805 //y2=0.175
cc_161 ( N_noxref_1_c_71_p N_GND_c_2872_n ) capacitor c=4.56398e-19 //x=1.97 \
 //y=4.025 //x2=3.805 //y2=0.175
cc_162 ( N_noxref_1_c_10_p N_GND_c_2872_n ) capacitor c=3.15101e-19 //x=3.82 \
 //y=4.025 //x2=3.805 //y2=0.175
cc_163 ( N_noxref_1_c_3_p N_GND_c_2872_n ) capacitor c=0.00998676f //x=1.6 \
 //y=1.185 //x2=3.805 //y2=0.175
cc_164 ( N_noxref_1_c_40_p N_GND_c_2872_n ) capacitor c=6.6172e-19 //x=3.82 \
 //y=2.26 //x2=3.805 //y2=0.175
cc_165 ( N_noxref_1_M0_noxref_d N_GND_c_2872_n ) capacitor c=0.00119455f \
 //x=1.415 //y=1.09 //x2=3.805 //y2=0.175
cc_166 ( N_noxref_1_c_10_p N_GND_c_2878_n ) capacitor c=3.19606e-19 //x=3.82 \
 //y=4.025 //x2=3.89 //y2=1.135
cc_167 ( N_noxref_1_c_3_p N_GND_c_2878_n ) capacitor c=0.00524331f //x=1.6 \
 //y=1.185 //x2=3.89 //y2=1.135
cc_168 ( N_noxref_1_c_40_p N_GND_c_2878_n ) capacitor c=0.00709624f //x=3.82 \
 //y=2.26 //x2=3.89 //y2=1.135
cc_169 ( N_noxref_1_c_25_p N_GND_c_2878_n ) capacitor c=2.13705e-19 //x=3.82 \
 //y=2.26 //x2=3.89 //y2=1.135
cc_170 ( N_noxref_1_c_54_p N_GND_c_2878_n ) capacitor c=0.00154831f //x=3.625 \
 //y=1.045 //x2=3.89 //y2=1.135
cc_171 ( N_noxref_1_c_55_p N_GND_c_2878_n ) capacitor c=0.00354198f //x=3.625 \
 //y=1.39 //x2=3.89 //y2=1.135
cc_172 ( N_noxref_1_c_57_p N_GND_c_2878_n ) capacitor c=4.2764e-19 //x=3.625 \
 //y=1.7 //x2=3.89 //y2=1.135
cc_173 ( N_noxref_1_c_173_p N_GND_c_2878_n ) capacitor c=7.35788e-19 //x=4 \
 //y=0.89 //x2=3.89 //y2=1.135
cc_174 ( N_noxref_1_c_174_p N_GND_c_2878_n ) capacitor c=6.15759e-19 //x=4 \
 //y=1.545 //x2=3.89 //y2=1.135
cc_175 ( N_noxref_1_c_56_p N_GND_c_2878_n ) capacitor c=0.00174905f //x=4.155 \
 //y=1.045 //x2=3.89 //y2=1.135
cc_176 ( N_noxref_1_c_58_p N_GND_c_2878_n ) capacitor c=0.00296337f //x=4.155 \
 //y=1.39 //x2=3.89 //y2=1.135
cc_177 ( N_noxref_1_c_54_p N_GND_c_2889_n ) capacitor c=3.51399e-19 //x=3.625 \
 //y=1.045 //x2=3.887 //y2=1.005
cc_178 ( N_noxref_1_c_173_p N_GND_c_2889_n ) capacitor c=0.00864609f //x=4 \
 //y=0.89 //x2=3.887 //y2=1.005
cc_179 ( N_noxref_1_c_56_p N_GND_c_2889_n ) capacitor c=4.45447e-19 //x=4.155 \
 //y=1.045 //x2=3.887 //y2=1.005
cc_180 ( N_noxref_1_c_3_p N_GND_c_2892_n ) capacitor c=0.00124813f //x=1.6 \
 //y=1.185 //x2=1.515 //y2=0.715
cc_181 ( N_noxref_1_c_4_p N_GND_c_2893_n ) capacitor c=0.00320203f //x=1.885 \
 //y=2.02 //x2=2.005 //y2=0.715
cc_182 ( N_noxref_1_c_3_p N_GND_c_2893_n ) capacitor c=0.00130539f //x=1.6 \
 //y=1.185 //x2=2.005 //y2=0.715
cc_183 ( N_noxref_1_c_74_p N_GND_c_2893_n ) capacitor c=2.41704e-19 //x=1.97 \
 //y=3.88 //x2=2.005 //y2=0.715
cc_184 ( N_noxref_1_c_54_p N_GND_c_2896_n ) capacitor c=0.00690758f //x=3.625 \
 //y=1.045 //x2=5.87 //y2=0.175
cc_185 ( N_noxref_1_c_2_p N_GND_c_2897_n ) capacitor c=0.00520602f //x=1.6 \
 //y=1.935 //x2=1.12 //y2=0.175
cc_186 ( N_noxref_1_c_23_p N_GND_c_2897_n ) capacitor c=2.14154e-19 //x=1.97 \
 //y=3.72 //x2=1.12 //y2=0.175
cc_187 ( N_noxref_1_c_4_p N_GND_c_2899_n ) capacitor c=0.0230294f //x=1.885 \
 //y=2.02 //x2=2.71 //y2=0.175
cc_188 ( N_noxref_1_c_5_p N_GND_c_2899_n ) capacitor c=0.00829739f //x=3.82 \
 //y=3.72 //x2=2.71 //y2=0.175
cc_189 ( N_noxref_1_c_40_p N_GND_c_2899_n ) capacitor c=0.00427323f //x=3.82 \
 //y=2.26 //x2=2.71 //y2=0.175
cc_190 ( N_noxref_1_c_92_p N_GND_c_2899_n ) capacitor c=0.00440673f //x=3.67 \
 //y=3.872 //x2=2.71 //y2=0.175
cc_191 ( N_noxref_1_c_25_p N_GND_c_2899_n ) capacitor c=0.0038607f //x=3.82 \
 //y=2.26 //x2=2.71 //y2=0.175
cc_192 ( N_noxref_1_c_42_p N_GND_c_2899_n ) capacitor c=0.00887845f //x=3.625 \
 //y=2.095 //x2=2.71 //y2=0.175
cc_193 ( N_noxref_1_c_3_p N_GND_c_2905_n ) capacitor c=2.8029e-19 //x=1.6 \
 //y=1.185 //x2=19.73 //y2=0.18
cc_194 ( N_noxref_1_c_2_p N_GND_M0_noxref_s ) capacitor c=0.0339428f //x=1.6 \
 //y=1.935 //x2=0.985 //y2=0.55
cc_195 ( N_noxref_1_c_4_p N_GND_M0_noxref_s ) capacitor c=0.00407415f \
 //x=1.885 //y=2.02 //x2=0.985 //y2=0.55
cc_196 ( N_noxref_1_c_71_p N_GND_M0_noxref_s ) capacitor c=0.00104522f \
 //x=1.97 //y=4.025 //x2=0.985 //y2=0.55
cc_197 ( N_noxref_1_c_3_p N_GND_M0_noxref_s ) capacitor c=0.0157322f //x=1.6 \
 //y=1.185 //x2=0.985 //y2=0.55
cc_198 ( N_noxref_1_c_74_p N_GND_M0_noxref_s ) capacitor c=5.90702e-19 \
 //x=1.97 //y=3.88 //x2=0.985 //y2=0.55
cc_199 ( N_noxref_1_M0_noxref_d N_GND_M0_noxref_s ) capacitor c=0.0377642f \
 //x=1.415 //y=1.09 //x2=0.985 //y2=0.55
cc_200 ( N_noxref_1_c_40_p N_GND_M1_noxref_d ) capacitor c=2.20438e-19 \
 //x=3.82 //y=2.26 //x2=3.7 //y2=1.045
cc_201 ( N_noxref_1_c_54_p N_GND_M1_noxref_d ) capacitor c=0.00192399f \
 //x=3.625 //y=1.045 //x2=3.7 //y2=1.045
cc_202 ( N_noxref_1_c_55_p N_GND_M1_noxref_d ) capacitor c=0.00210798f \
 //x=3.625 //y=1.39 //x2=3.7 //y2=1.045
cc_203 ( N_noxref_1_c_173_p N_GND_M1_noxref_d ) capacitor c=0.00472259f //x=4 \
 //y=0.89 //x2=3.7 //y2=1.045
cc_204 ( N_noxref_1_c_174_p N_GND_M1_noxref_d ) capacitor c=0.00166857f //x=4 \
 //y=1.545 //x2=3.7 //y2=1.045
cc_205 ( N_noxref_1_c_56_p N_GND_M1_noxref_d ) capacitor c=0.00230174f \
 //x=4.155 //y=1.045 //x2=3.7 //y2=1.045
cc_206 ( N_noxref_1_c_58_p N_GND_M1_noxref_d ) capacitor c=0.00210798f \
 //x=4.155 //y=1.39 //x2=3.7 //y2=1.045
cc_207 ( N_noxref_1_c_92_p N_noxref_14_c_3459_n ) capacitor c=0.00214296f \
 //x=3.67 //y=3.872 //x2=3.405 //y2=1.675
cc_208 ( N_noxref_1_c_42_p N_noxref_14_c_3459_n ) capacitor c=0.00262672f \
 //x=3.625 //y=2.095 //x2=3.405 //y2=1.675
cc_209 ( N_noxref_1_c_10_p N_noxref_14_c_3461_n ) capacitor c=0.00362844f \
 //x=3.82 //y=4.025 //x2=4.29 //y2=1.76
cc_210 ( N_noxref_1_c_40_p N_noxref_14_c_3461_n ) capacitor c=0.00459552f \
 //x=3.82 //y=2.26 //x2=4.29 //y2=1.76
cc_211 ( N_noxref_1_c_92_p N_noxref_14_c_3461_n ) capacitor c=0.00120647f \
 //x=3.67 //y=3.872 //x2=4.29 //y2=1.76
cc_212 ( N_noxref_1_c_25_p N_noxref_14_c_3461_n ) capacitor c=0.00763108f \
 //x=3.82 //y=2.26 //x2=4.29 //y2=1.76
cc_213 ( N_noxref_1_c_57_p N_noxref_14_c_3461_n ) capacitor c=0.00695869f \
 //x=3.625 //y=1.7 //x2=4.29 //y2=1.76
cc_214 ( N_noxref_1_c_42_p N_noxref_14_c_3461_n ) capacitor c=0.018584f \
 //x=3.625 //y=2.095 //x2=4.29 //y2=1.76
cc_215 ( N_noxref_1_c_174_p N_noxref_14_c_3461_n ) capacitor c=0.00723574f \
 //x=4 //y=1.545 //x2=4.29 //y2=1.76
cc_216 ( N_noxref_1_c_58_p N_noxref_14_c_3461_n ) capacitor c=0.00399755f \
 //x=4.155 //y=1.39 //x2=4.29 //y2=1.76
cc_217 ( N_noxref_1_c_42_p N_noxref_14_c_3469_n ) capacitor c=6.71402e-19 \
 //x=3.625 //y=2.095 //x2=4.375 //y2=1.675
cc_218 ( N_noxref_1_c_54_p N_noxref_14_M1_noxref_s ) capacitor c=0.0294925f \
 //x=3.625 //y=1.045 //x2=3.27 //y2=0.545
cc_219 ( N_noxref_1_c_57_p N_noxref_14_M1_noxref_s ) capacitor c=3.48408e-19 \
 //x=3.625 //y=1.7 //x2=3.27 //y2=0.545
cc_220 ( N_noxref_1_c_56_p N_noxref_14_M1_noxref_s ) capacitor c=0.0125442f \
 //x=4.155 //y=1.045 //x2=3.27 //y2=0.545
cc_221 ( N_noxref_2_c_224_n GATE ) capacitor c=0.0259641f //x=5.3 //y=3.35 \
 //x2=4.56 //y2=2.77
cc_222 ( N_noxref_2_c_244_p GATE ) capacitor c=0.00183573f //x=6.78 //y=3.35 \
 //x2=4.56 //y2=2.77
cc_223 ( N_noxref_2_c_224_n GATE ) capacitor c=0.00206187f //x=5.3 //y=3.35 \
 //x2=4.56 //y2=3.51
cc_224 ( N_noxref_2_c_246_p GATE ) capacitor c=0.0148501f //x=5.3 //y=3.67 \
 //x2=4.56 //y2=3.51
cc_225 ( N_noxref_2_c_226_n GATE ) capacitor c=0.0432947f //x=5.3 //y=5.295 \
 //x2=4.56 //y2=3.51
cc_226 ( N_noxref_2_c_248_p GATE ) capacitor c=0.0028426f //x=6.78 //y=4.76 \
 //x2=4.56 //y2=3.51
cc_227 ( N_noxref_2_c_249_p GATE ) capacitor c=6.03895e-19 //x=5.3 //y=3.51 \
 //x2=4.56 //y2=3.51
cc_228 ( N_noxref_2_c_250_p GATE ) capacitor c=0.00687742f //x=5.46 //y=3.51 \
 //x2=4.56 //y2=3.51
cc_229 ( N_noxref_2_c_244_p GATE ) capacitor c=0.00176758f //x=6.78 //y=3.35 \
 //x2=9.37 //y2=2.77
cc_230 ( N_noxref_2_c_248_p GATE ) capacitor c=0.0025615f //x=6.78 //y=4.76 \
 //x2=9.37 //y2=3.51
cc_231 ( N_noxref_2_c_224_n GATE ) capacitor c=0.00103412f //x=5.3 //y=3.35 \
 //x2=4.56 //y2=3.14
cc_232 ( N_noxref_2_c_221_n N_GATE_c_495_n ) capacitor c=9.45757e-19 //x=4.705 \
 //y=5.38 //x2=4.56 //y2=3.305
cc_233 ( N_noxref_2_c_255_p N_GATE_c_495_n ) capacitor c=8.10449e-19 //x=4.945 \
 //y=1.835 //x2=4.56 //y2=3.305
cc_234 ( N_noxref_2_c_224_n N_GATE_c_495_n ) capacitor c=0.016632f //x=5.3 \
 //y=3.35 //x2=4.56 //y2=3.305
cc_235 ( N_noxref_2_c_257_p N_GATE_c_495_n ) capacitor c=0.00108216f //x=4.82 \
 //y=5.38 //x2=4.56 //y2=3.305
cc_236 ( N_noxref_2_c_236_n N_GATE_c_495_n ) capacitor c=2.77783e-19 //x=4.86 \
 //y=1.18 //x2=4.56 //y2=3.305
cc_237 ( N_noxref_2_c_259_p N_GATE_c_495_n ) capacitor c=2.58653e-19 //x=4.82 \
 //y=5.56 //x2=4.56 //y2=3.305
cc_238 ( N_noxref_2_c_221_n N_GATE_c_496_n ) capacitor c=0.0223265f //x=4.705 \
 //y=5.38 //x2=4.56 //y2=4.735
cc_239 ( N_noxref_2_c_226_n N_GATE_c_496_n ) capacitor c=0.016905f //x=5.3 \
 //y=5.295 //x2=4.56 //y2=4.735
cc_240 ( N_noxref_2_c_224_n N_GATE_c_499_n ) capacitor c=0.015397f //x=5.3 \
 //y=3.35 //x2=4.56 //y2=2.26
cc_241 ( N_noxref_2_c_263_p N_GATE_c_549_n ) capacitor c=0.0043574f //x=5.215 \
 //y=1.835 //x2=4.915 //y2=3.14
cc_242 ( N_noxref_2_c_255_p N_GATE_c_549_n ) capacitor c=0.0044221f //x=4.945 \
 //y=1.835 //x2=4.915 //y2=3.14
cc_243 ( N_noxref_2_c_224_n N_GATE_c_549_n ) capacitor c=2.7585e-19 //x=5.3 \
 //y=3.35 //x2=4.915 //y2=3.14
cc_244 ( N_noxref_2_c_236_n N_GATE_c_549_n ) capacitor c=2.9373e-19 //x=4.86 \
 //y=1.18 //x2=4.915 //y2=3.14
cc_245 ( N_noxref_2_c_224_n N_GATE_c_553_n ) capacitor c=0.0271787f //x=5.3 \
 //y=3.35 //x2=5.515 //y2=3.125
cc_246 ( N_noxref_2_c_246_p N_GATE_c_553_n ) capacitor c=0.00808101f //x=5.3 \
 //y=3.67 //x2=5.515 //y2=3.125
cc_247 ( N_noxref_2_c_269_p N_GATE_c_553_n ) capacitor c=0.0976086f //x=6.615 \
 //y=3.51 //x2=5.515 //y2=3.125
cc_248 ( N_noxref_2_c_250_p N_GATE_c_553_n ) capacitor c=0.0365231f //x=5.46 \
 //y=3.51 //x2=5.515 //y2=3.125
cc_249 ( N_noxref_2_c_244_p N_GATE_c_557_n ) capacitor c=4.49947e-19 //x=6.78 \
 //y=3.35 //x2=6.39 //y2=3.14
cc_250 ( N_noxref_2_c_272_p N_GATE_c_557_n ) capacitor c=0.00276844f //x=6.78 \
 //y=3.67 //x2=6.39 //y2=3.14
cc_251 ( N_noxref_2_c_269_p N_GATE_c_557_n ) capacitor c=0.0112003f //x=6.615 \
 //y=3.51 //x2=6.39 //y2=3.14
cc_252 ( N_noxref_2_c_244_p N_GATE_c_560_n ) capacitor c=0.0265002f //x=6.78 \
 //y=3.35 //x2=6.99 //y2=3.125
cc_253 ( N_noxref_2_c_272_p N_GATE_c_560_n ) capacitor c=0.00448915f //x=6.78 \
 //y=3.67 //x2=6.99 //y2=3.125
cc_254 ( N_noxref_2_c_276_p N_GATE_c_560_n ) capacitor c=0.0027091f //x=6.78 \
 //y=2.265 //x2=6.99 //y2=3.125
cc_255 ( N_noxref_2_c_277_p N_GATE_c_560_n ) capacitor c=0.0365231f //x=6.775 \
 //y=3.51 //x2=6.99 //y2=3.125
cc_256 ( N_noxref_2_c_224_n N_GATE_c_502_n ) capacitor c=0.00272823f //x=5.3 \
 //y=3.35 //x2=4.715 //y2=3.152
cc_257 ( N_noxref_2_c_224_n N_GATE_c_503_n ) capacitor c=9.90728e-19 //x=5.3 \
 //y=3.35 //x2=4.56 //y2=2.26
cc_258 ( N_noxref_2_c_221_n N_GATE_c_507_n ) capacitor c=0.00469257f //x=4.705 \
 //y=5.38 //x2=4.59 //y2=4.88
cc_259 ( N_noxref_2_c_226_n N_GATE_c_507_n ) capacitor c=7.76118e-19 //x=5.3 \
 //y=5.295 //x2=4.59 //y2=4.88
cc_260 ( N_noxref_2_c_221_n N_GATE_M15_noxref_g ) capacitor c=0.00842859f \
 //x=4.705 //y=5.38 //x2=4.6 //y2=6.2
cc_261 ( N_noxref_2_c_257_p N_GATE_M15_noxref_g ) capacitor c=0.00192712f \
 //x=4.82 //y=5.38 //x2=4.6 //y2=6.2
cc_262 ( N_noxref_2_c_259_p N_GATE_M15_noxref_g ) capacitor c=0.0178987f \
 //x=4.82 //y=5.56 //x2=4.6 //y2=6.2
cc_263 ( N_noxref_2_c_285_p N_GATE_M16_noxref_g ) capacitor c=0.0110279f \
 //x=5.215 //y=5.38 //x2=5.04 //y2=6.2
cc_264 ( N_noxref_2_c_257_p N_GATE_M16_noxref_g ) capacitor c=0.00291595f \
 //x=4.82 //y=5.38 //x2=5.04 //y2=6.2
cc_265 ( N_noxref_2_c_259_p N_GATE_M16_noxref_g ) capacitor c=0.0178506f \
 //x=4.82 //y=5.56 //x2=5.04 //y2=6.2
cc_266 ( N_noxref_2_c_236_n N_GATE_c_513_n ) capacitor c=0.00120406f //x=4.86 \
 //y=1.18 //x2=4.595 //y2=1.085
cc_267 ( N_noxref_2_M2_noxref_d N_GATE_c_513_n ) capacitor c=0.00137165f \
 //x=4.67 //y=1.085 //x2=4.595 //y2=1.085
cc_268 ( N_noxref_2_c_222_n N_GATE_c_516_n ) capacitor c=0.00118531f //x=4.86 \
 //y=1.75 //x2=4.595 //y2=1.43
cc_269 ( N_noxref_2_c_236_n N_GATE_c_516_n ) capacitor c=0.00218558f //x=4.86 \
 //y=1.18 //x2=4.595 //y2=1.43
cc_270 ( N_noxref_2_M2_noxref_d N_GATE_c_516_n ) capacitor c=0.00237422f \
 //x=4.67 //y=1.085 //x2=4.595 //y2=1.43
cc_271 ( N_noxref_2_c_222_n N_GATE_c_518_n ) capacitor c=0.00437687f //x=4.86 \
 //y=1.75 //x2=4.595 //y2=1.74
cc_272 ( N_noxref_2_c_226_n N_GATE_c_580_n ) capacitor c=0.0084741f //x=5.3 \
 //y=5.295 //x2=4.965 //y2=4.97
cc_273 ( N_noxref_2_c_257_p N_GATE_c_580_n ) capacitor c=0.00196809f //x=4.82 \
 //y=5.38 //x2=4.965 //y2=4.97
cc_274 ( N_noxref_2_c_259_p N_GATE_c_580_n ) capacitor c=0.00291714f //x=4.82 \
 //y=5.56 //x2=4.965 //y2=4.97
cc_275 ( N_noxref_2_c_236_n N_GATE_c_583_n ) capacitor c=5.50523e-19 //x=4.86 \
 //y=1.18 //x2=4.97 //y2=0.93
cc_276 ( N_noxref_2_M2_noxref_d N_GATE_c_583_n ) capacitor c=0.0020782f \
 //x=4.67 //y=1.085 //x2=4.97 //y2=0.93
cc_277 ( N_noxref_2_c_222_n N_GATE_c_585_n ) capacitor c=0.00897029f //x=4.86 \
 //y=1.75 //x2=4.97 //y2=1.585
cc_278 ( N_noxref_2_c_263_p N_GATE_c_585_n ) capacitor c=0.00194324f //x=5.215 \
 //y=1.835 //x2=4.97 //y2=1.585
cc_279 ( N_noxref_2_c_236_n N_GATE_c_585_n ) capacitor c=4.93963e-19 //x=4.86 \
 //y=1.18 //x2=4.97 //y2=1.585
cc_280 ( N_noxref_2_M2_noxref_d N_GATE_c_585_n ) capacitor c=0.00356097f \
 //x=4.67 //y=1.085 //x2=4.97 //y2=1.585
cc_281 ( N_noxref_2_c_236_n N_GATE_c_521_n ) capacitor c=0.00109707f //x=4.86 \
 //y=1.18 //x2=5.125 //y2=1.085
cc_282 ( N_noxref_2_M2_noxref_d N_GATE_c_521_n ) capacitor c=8.50095e-19 \
 //x=4.67 //y=1.085 //x2=5.125 //y2=1.085
cc_283 ( N_noxref_2_c_222_n N_GATE_c_522_n ) capacitor c=0.00303393f //x=4.86 \
 //y=1.75 //x2=5.125 //y2=1.43
cc_284 ( N_noxref_2_c_263_p N_GATE_c_522_n ) capacitor c=0.00323005f //x=5.215 \
 //y=1.835 //x2=5.125 //y2=1.43
cc_285 ( N_noxref_2_c_236_n N_GATE_c_522_n ) capacitor c=0.00312043f //x=4.86 \
 //y=1.18 //x2=5.125 //y2=1.43
cc_286 ( N_noxref_2_M2_noxref_d N_GATE_c_522_n ) capacitor c=0.00237422f \
 //x=4.67 //y=1.085 //x2=5.125 //y2=1.43
cc_287 ( N_noxref_2_c_224_n N_GATE_c_523_n ) capacitor c=0.00281392f //x=5.3 \
 //y=3.35 //x2=4.56 //y2=2.26
cc_288 ( N_noxref_2_c_222_n N_GATE_c_596_n ) capacitor c=0.00348382f //x=4.86 \
 //y=1.75 //x2=4.56 //y2=2.095
cc_289 ( N_noxref_2_c_224_n N_GATE_c_596_n ) capacitor c=0.00309521f //x=5.3 \
 //y=3.35 //x2=4.56 //y2=2.095
cc_290 ( N_noxref_2_c_221_n N_GATE_c_526_n ) capacitor c=9.29998e-19 //x=4.705 \
 //y=5.38 //x2=4.59 //y2=4.88
cc_291 ( N_noxref_2_c_226_n N_GATE_c_526_n ) capacitor c=0.00142201f //x=5.3 \
 //y=5.295 //x2=4.59 //y2=4.88
cc_292 ( N_noxref_2_c_246_p N_D_c_781_n ) capacitor c=0.00519831f //x=5.3 \
 //y=3.67 //x2=9.95 //y2=4.262
cc_293 ( N_noxref_2_c_226_n N_D_c_781_n ) capacitor c=0.030923f //x=5.3 \
 //y=5.295 //x2=9.95 //y2=4.262
cc_294 ( N_noxref_2_c_272_p N_D_c_781_n ) capacitor c=0.0043026f //x=6.78 \
 //y=3.67 //x2=9.95 //y2=4.262
cc_295 ( N_noxref_2_c_248_p N_D_c_781_n ) capacitor c=0.0326049f //x=6.78 \
 //y=4.76 //x2=9.95 //y2=4.262
cc_296 ( N_noxref_2_c_229_n N_D_c_781_n ) capacitor c=0.0180468f //x=3.94 \
 //y=5.56 //x2=9.95 //y2=4.262
cc_297 ( N_noxref_2_c_257_p N_D_c_781_n ) capacitor c=0.015528f //x=4.82 \
 //y=5.38 //x2=9.95 //y2=4.262
cc_298 ( N_noxref_2_c_269_p N_D_c_781_n ) capacitor c=0.052443f //x=6.615 \
 //y=3.51 //x2=9.95 //y2=4.262
cc_299 ( N_noxref_2_c_250_p N_D_c_781_n ) capacitor c=0.0157335f //x=5.46 \
 //y=3.51 //x2=9.95 //y2=4.262
cc_300 ( N_noxref_2_c_277_p N_D_c_781_n ) capacitor c=0.0157335f //x=6.775 \
 //y=3.51 //x2=9.95 //y2=4.262
cc_301 ( N_noxref_2_c_222_n N_noxref_6_c_1298_n ) capacitor c=0.00466656f \
 //x=4.86 //y=1.75 //x2=7.15 //y2=1.935
cc_302 ( N_noxref_2_c_263_p N_noxref_6_c_1298_n ) capacitor c=0.00328586f \
 //x=5.215 //y=1.835 //x2=7.15 //y2=1.935
cc_303 ( N_noxref_2_c_325_p N_noxref_6_c_1298_n ) capacitor c=0.00108934f \
 //x=6.89 //y=1.435 //x2=7.15 //y2=1.935
cc_304 ( N_noxref_2_c_326_p N_noxref_6_c_1298_n ) capacitor c=0.00524682f \
 //x=6.89 //y=1.745 //x2=7.15 //y2=1.935
cc_305 ( N_noxref_2_c_327_p N_noxref_6_c_1298_n ) capacitor c=0.00376309f \
 //x=6.89 //y=2.1 //x2=7.15 //y2=1.935
cc_306 ( N_noxref_2_c_328_p N_noxref_6_c_1298_n ) capacitor c=0.00921f \
 //x=7.265 //y=1.59 //x2=7.15 //y2=1.935
cc_307 ( N_noxref_2_c_329_p N_noxref_6_c_1298_n ) capacitor c=0.00344663f \
 //x=7.42 //y=1.435 //x2=7.15 //y2=1.935
cc_308 ( N_noxref_2_c_285_p N_noxref_6_c_1305_n ) capacitor c=0.00310351f \
 //x=5.215 //y=5.38 //x2=7.155 //y2=5.42
cc_309 ( N_noxref_2_c_257_p N_noxref_6_c_1305_n ) capacitor c=5.44332e-19 \
 //x=4.82 //y=5.38 //x2=7.155 //y2=5.42
cc_310 ( N_noxref_2_M17_noxref_g N_noxref_6_c_1305_n ) capacitor c=0.00141266f \
 //x=6.935 //y=6.2 //x2=7.155 //y2=5.42
cc_311 ( N_noxref_2_M18_noxref_g N_noxref_6_c_1305_n ) capacitor c=0.0035262f \
 //x=7.375 //y=6.2 //x2=7.155 //y2=5.42
cc_312 ( N_noxref_2_c_328_p N_noxref_6_c_1309_n ) capacitor c=0.00180253f \
 //x=7.265 //y=1.59 //x2=7.435 //y2=2.02
cc_313 ( N_noxref_2_c_224_n N_noxref_6_c_1310_n ) capacitor c=0.00328586f \
 //x=5.3 //y=3.35 //x2=7.235 //y2=2.02
cc_314 ( N_noxref_2_c_336_p N_noxref_6_c_1310_n ) capacitor c=0.00376309f \
 //x=6.78 //y=2.265 //x2=7.235 //y2=2.02
cc_315 ( N_noxref_2_M18_noxref_g N_noxref_6_c_1312_n ) capacitor c=0.00933399f \
 //x=7.375 //y=6.2 //x2=7.435 //y2=5.14
cc_316 ( N_noxref_2_c_226_n N_noxref_6_c_1313_n ) capacitor c=0.00292756f \
 //x=5.3 //y=5.295 //x2=7.24 //y2=5.14
cc_317 ( N_noxref_2_M17_noxref_g N_noxref_6_c_1313_n ) capacitor c=0.00427521f \
 //x=6.935 //y=6.2 //x2=7.24 //y2=5.14
cc_318 ( N_noxref_2_c_340_p N_noxref_6_c_1313_n ) capacitor c=0.00262283f \
 //x=7.3 //y=4.97 //x2=7.24 //y2=5.14
cc_319 ( N_noxref_2_c_224_n N_noxref_6_c_1316_n ) capacitor c=0.00348672f \
 //x=5.3 //y=3.35 //x2=7.52 //y2=3.72
cc_320 ( N_noxref_2_c_244_p N_noxref_6_c_1316_n ) capacitor c=0.0370942f \
 //x=6.78 //y=3.35 //x2=7.52 //y2=3.72
cc_321 ( N_noxref_2_c_272_p N_noxref_6_c_1316_n ) capacitor c=0.0146933f \
 //x=6.78 //y=3.67 //x2=7.52 //y2=3.72
cc_322 ( N_noxref_2_c_248_p N_noxref_6_c_1316_n ) capacitor c=0.00225898f \
 //x=6.78 //y=4.76 //x2=7.52 //y2=3.72
cc_323 ( N_noxref_2_c_345_p N_noxref_6_c_1316_n ) capacitor c=6.03895e-19 \
 //x=6.775 //y=3.51 //x2=7.52 //y2=3.72
cc_324 ( N_noxref_2_c_276_p N_noxref_6_c_1316_n ) capacitor c=0.017436f \
 //x=6.78 //y=2.265 //x2=7.52 //y2=3.72
cc_325 ( N_noxref_2_c_277_p N_noxref_6_c_1316_n ) capacitor c=0.00684338f \
 //x=6.775 //y=3.51 //x2=7.52 //y2=3.72
cc_326 ( N_noxref_2_c_348_p N_noxref_6_c_1316_n ) capacitor c=4.71798e-19 \
 //x=6.78 //y=2.265 //x2=7.52 //y2=3.72
cc_327 ( N_noxref_2_c_336_p N_noxref_6_c_1316_n ) capacitor c=0.00270592f \
 //x=6.78 //y=2.265 //x2=7.52 //y2=3.72
cc_328 ( N_noxref_2_c_248_p N_noxref_6_c_1325_n ) capacitor c=0.0145151f \
 //x=6.78 //y=4.76 //x2=7.52 //y2=4.025
cc_329 ( N_noxref_2_c_340_p N_noxref_6_c_1325_n ) capacitor c=0.00120127f \
 //x=7.3 //y=4.97 //x2=7.52 //y2=4.025
cc_330 ( N_noxref_2_c_226_n N_noxref_6_c_1327_n ) capacitor c=0.00230216f \
 //x=5.3 //y=5.295 //x2=7.52 //y2=5.055
cc_331 ( N_noxref_2_c_248_p N_noxref_6_c_1327_n ) capacitor c=0.0456197f \
 //x=6.78 //y=4.76 //x2=7.52 //y2=5.055
cc_332 ( N_noxref_2_c_354_p N_noxref_6_c_1327_n ) capacitor c=0.00160039f \
 //x=6.78 //y=4.88 //x2=7.52 //y2=5.055
cc_333 ( N_noxref_2_c_340_p N_noxref_6_c_1327_n ) capacitor c=0.00208891f \
 //x=7.3 //y=4.97 //x2=7.52 //y2=5.055
cc_334 ( N_noxref_2_c_356_p N_noxref_6_c_1327_n ) capacitor c=0.00140024f \
 //x=7.01 //y=4.97 //x2=7.52 //y2=5.055
cc_335 ( N_noxref_2_c_222_n N_noxref_6_c_1332_n ) capacitor c=6.23317e-19 \
 //x=4.86 //y=1.75 //x2=7.15 //y2=1.185
cc_336 ( N_noxref_2_c_236_n N_noxref_6_c_1332_n ) capacitor c=0.00597106f \
 //x=4.86 //y=1.18 //x2=7.15 //y2=1.185
cc_337 ( N_noxref_2_c_359_p N_noxref_6_c_1332_n ) capacitor c=0.00175305f \
 //x=6.89 //y=1.09 //x2=7.15 //y2=1.185
cc_338 ( N_noxref_2_c_325_p N_noxref_6_c_1332_n ) capacitor c=0.00354487f \
 //x=6.89 //y=1.435 //x2=7.15 //y2=1.185
cc_339 ( N_noxref_2_c_361_p N_noxref_6_c_1332_n ) capacitor c=5.57924e-19 \
 //x=7.265 //y=0.935 //x2=7.15 //y2=1.185
cc_340 ( N_noxref_2_c_328_p N_noxref_6_c_1332_n ) capacitor c=5.75878e-19 \
 //x=7.265 //y=1.59 //x2=7.15 //y2=1.185
cc_341 ( N_noxref_2_c_363_p N_noxref_6_c_1332_n ) capacitor c=0.00148146f \
 //x=7.42 //y=1.09 //x2=7.15 //y2=1.185
cc_342 ( N_noxref_2_c_329_p N_noxref_6_c_1332_n ) capacitor c=0.00356478f \
 //x=7.42 //y=1.435 //x2=7.15 //y2=1.185
cc_343 ( N_noxref_2_c_248_p N_noxref_6_c_1340_n ) capacitor c=8.35899e-19 \
 //x=6.78 //y=4.76 //x2=7.52 //y2=3.88
cc_344 ( N_noxref_2_c_248_p N_noxref_6_c_1341_n ) capacitor c=0.00654118f \
 //x=6.78 //y=4.76 //x2=7.68 //y2=3.872
cc_345 ( N_noxref_2_M17_noxref_g N_noxref_6_c_1342_n ) capacitor c=0.0162066f \
 //x=6.935 //y=6.2 //x2=7.155 //y2=5.56
cc_346 ( N_noxref_2_M18_noxref_g N_noxref_6_c_1342_n ) capacitor c=0.0162066f \
 //x=7.375 //y=6.2 //x2=7.155 //y2=5.56
cc_347 ( N_noxref_2_c_340_p N_noxref_6_c_1342_n ) capacitor c=0.00290963f \
 //x=7.3 //y=4.97 //x2=7.155 //y2=5.56
cc_348 ( N_noxref_2_c_359_p N_noxref_6_M3_noxref_d ) capacitor c=0.00137914f \
 //x=6.89 //y=1.09 //x2=6.965 //y2=1.09
cc_349 ( N_noxref_2_c_325_p N_noxref_6_M3_noxref_d ) capacitor c=0.0023891f \
 //x=6.89 //y=1.435 //x2=6.965 //y2=1.09
cc_350 ( N_noxref_2_c_361_p N_noxref_6_M3_noxref_d ) capacitor c=0.0020782f \
 //x=7.265 //y=0.935 //x2=6.965 //y2=1.09
cc_351 ( N_noxref_2_c_328_p N_noxref_6_M3_noxref_d ) capacitor c=0.00356097f \
 //x=7.265 //y=1.59 //x2=6.965 //y2=1.09
cc_352 ( N_noxref_2_c_363_p N_noxref_6_M3_noxref_d ) capacitor c=0.00138452f \
 //x=7.42 //y=1.09 //x2=6.965 //y2=1.09
cc_353 ( N_noxref_2_c_329_p N_noxref_6_M3_noxref_d ) capacitor c=0.00235934f \
 //x=7.42 //y=1.435 //x2=6.965 //y2=1.09
cc_354 ( N_noxref_2_c_221_n N_VDD_c_2464_n ) capacitor c=0.00648287f //x=4.705 \
 //y=5.38 //x2=14.955 //y2=7.585
cc_355 ( N_noxref_2_c_285_p N_VDD_c_2464_n ) capacitor c=0.00492584f //x=5.215 \
 //y=5.38 //x2=14.955 //y2=7.585
cc_356 ( N_noxref_2_c_246_p N_VDD_c_2464_n ) capacitor c=4.64497e-19 //x=5.3 \
 //y=3.67 //x2=14.955 //y2=7.585
cc_357 ( N_noxref_2_c_272_p N_VDD_c_2464_n ) capacitor c=2.69767e-19 //x=6.78 \
 //y=3.67 //x2=14.955 //y2=7.585
cc_358 ( N_noxref_2_c_248_p N_VDD_c_2464_n ) capacitor c=5.73169e-19 //x=6.78 \
 //y=4.76 //x2=14.955 //y2=7.585
cc_359 ( N_noxref_2_c_229_n N_VDD_c_2464_n ) capacitor c=0.00368834f //x=3.94 \
 //y=5.56 //x2=14.955 //y2=7.585
cc_360 ( N_noxref_2_c_257_p N_VDD_c_2464_n ) capacitor c=8.42537e-19 //x=4.82 \
 //y=5.38 //x2=14.955 //y2=7.585
cc_361 ( N_noxref_2_c_383_p N_VDD_c_2464_n ) capacitor c=0.00285853f //x=4.82 \
 //y=5.56 //x2=14.955 //y2=7.585
cc_362 ( N_noxref_2_c_237_n N_VDD_c_2464_n ) capacitor c=0.00224881f //x=3.94 \
 //y=5.56 //x2=14.955 //y2=7.585
cc_363 ( N_noxref_2_c_259_p N_VDD_c_2464_n ) capacitor c=0.00224881f //x=4.82 \
 //y=5.56 //x2=14.955 //y2=7.585
cc_364 ( N_noxref_2_c_354_p N_VDD_c_2464_n ) capacitor c=3.40755e-19 //x=6.78 \
 //y=4.88 //x2=14.955 //y2=7.585
cc_365 ( N_noxref_2_c_221_n N_VDD_c_2473_n ) capacitor c=0.00208087f //x=4.705 \
 //y=5.38 //x2=4.295 //y2=7.585
cc_366 ( N_noxref_2_c_229_n N_VDD_c_2473_n ) capacitor c=9.41185e-19 //x=3.94 \
 //y=5.56 //x2=4.295 //y2=7.585
cc_367 ( N_noxref_2_c_237_n N_VDD_c_2473_n ) capacitor c=0.0136705f //x=3.94 \
 //y=5.56 //x2=4.295 //y2=7.585
cc_368 ( N_noxref_2_c_221_n N_VDD_c_2512_n ) capacitor c=0.00180737f //x=4.705 \
 //y=5.38 //x2=5.175 //y2=7.585
cc_369 ( N_noxref_2_c_285_p N_VDD_c_2512_n ) capacitor c=0.00208087f //x=5.215 \
 //y=5.38 //x2=5.175 //y2=7.585
cc_370 ( N_noxref_2_c_257_p N_VDD_c_2512_n ) capacitor c=4.23719e-19 //x=4.82 \
 //y=5.38 //x2=5.175 //y2=7.585
cc_371 ( N_noxref_2_c_383_p N_VDD_c_2512_n ) capacitor c=5.77976e-19 //x=4.82 \
 //y=5.56 //x2=5.175 //y2=7.585
cc_372 ( N_noxref_2_c_259_p N_VDD_c_2512_n ) capacitor c=0.0136705f //x=4.82 \
 //y=5.56 //x2=5.175 //y2=7.585
cc_373 ( N_noxref_2_c_248_p N_VDD_c_2517_n ) capacitor c=5.48929e-19 //x=6.78 \
 //y=4.76 //x2=7.51 //y2=7.585
cc_374 ( N_noxref_2_M17_noxref_g N_VDD_c_2517_n ) capacitor c=0.00753931f \
 //x=6.935 //y=6.2 //x2=7.51 //y2=7.585
cc_375 ( N_noxref_2_M18_noxref_g N_VDD_c_2517_n ) capacitor c=0.00755544f \
 //x=7.375 //y=6.2 //x2=7.51 //y2=7.585
cc_376 ( N_noxref_2_c_226_n N_VDD_c_2479_n ) capacitor c=0.00133592f //x=5.3 \
 //y=5.295 //x2=2.71 //y2=7.585
cc_377 ( N_noxref_2_c_229_n N_VDD_c_2479_n ) capacitor c=5.11447e-19 //x=3.94 \
 //y=5.56 //x2=2.71 //y2=7.585
cc_378 ( N_noxref_2_c_237_n N_VDD_c_2479_n ) capacitor c=0.0064135f //x=3.94 \
 //y=5.56 //x2=2.71 //y2=7.585
cc_379 ( N_noxref_2_c_226_n N_VDD_c_2523_n ) capacitor c=0.0279622f //x=5.3 \
 //y=5.295 //x2=6.04 //y2=7.585
cc_380 ( N_noxref_2_c_248_p N_VDD_c_2523_n ) capacitor c=0.0153926f //x=6.78 \
 //y=4.76 //x2=6.04 //y2=7.585
cc_381 ( N_noxref_2_c_257_p N_VDD_c_2523_n ) capacitor c=0.002343f //x=4.82 \
 //y=5.38 //x2=6.04 //y2=7.585
cc_382 ( N_noxref_2_c_383_p N_VDD_c_2523_n ) capacitor c=4.0348e-19 //x=4.82 \
 //y=5.56 //x2=6.04 //y2=7.585
cc_383 ( N_noxref_2_c_259_p N_VDD_c_2523_n ) capacitor c=0.0101861f //x=4.82 \
 //y=5.56 //x2=6.04 //y2=7.585
cc_384 ( N_noxref_2_c_354_p N_VDD_c_2523_n ) capacitor c=0.00795305f //x=6.78 \
 //y=4.88 //x2=6.04 //y2=7.585
cc_385 ( N_noxref_2_M17_noxref_g N_VDD_c_2523_n ) capacitor c=0.00713158f \
 //x=6.935 //y=6.2 //x2=6.04 //y2=7.585
cc_386 ( N_noxref_2_c_356_p N_VDD_c_2523_n ) capacitor c=0.00799922f //x=7.01 \
 //y=4.97 //x2=6.04 //y2=7.585
cc_387 ( N_noxref_2_c_354_p N_VDD_c_2531_n ) capacitor c=0.00235165f //x=6.78 \
 //y=4.88 //x2=8.26 //y2=7.585
cc_388 ( N_noxref_2_c_340_p N_VDD_c_2531_n ) capacitor c=0.00780996f //x=7.3 \
 //y=4.97 //x2=8.26 //y2=7.585
cc_389 ( N_noxref_2_c_356_p N_VDD_c_2531_n ) capacitor c=2.63786e-19 //x=7.01 \
 //y=4.97 //x2=8.26 //y2=7.585
cc_390 ( N_noxref_2_c_229_n N_VDD_M12_noxref_d ) capacitor c=0.00114029f \
 //x=3.94 //y=5.56 //x2=1.9 //y2=5.2
cc_391 ( N_noxref_2_c_229_n N_VDD_M13_noxref_s ) capacitor c=0.0604727f \
 //x=3.94 //y=5.56 //x2=3.365 //y2=5.2
cc_392 ( N_noxref_2_c_257_p N_VDD_M13_noxref_s ) capacitor c=6.52457e-19 \
 //x=4.82 //y=5.38 //x2=3.365 //y2=5.2
cc_393 ( N_noxref_2_c_237_n N_VDD_M13_noxref_s ) capacitor c=0.0887533f \
 //x=3.94 //y=5.56 //x2=3.365 //y2=5.2
cc_394 ( N_noxref_2_c_221_n N_VDD_M14_noxref_d ) capacitor c=0.00734094f \
 //x=4.705 //y=5.38 //x2=4.235 //y2=5.2
cc_395 ( N_noxref_2_c_229_n N_VDD_M14_noxref_d ) capacitor c=0.0043528f \
 //x=3.94 //y=5.56 //x2=4.235 //y2=5.2
cc_396 ( N_noxref_2_c_383_p N_VDD_M14_noxref_d ) capacitor c=0.0043528f \
 //x=4.82 //y=5.56 //x2=4.235 //y2=5.2
cc_397 ( N_noxref_2_c_237_n N_VDD_M14_noxref_d ) capacitor c=0.065554f \
 //x=3.94 //y=5.56 //x2=4.235 //y2=5.2
cc_398 ( N_noxref_2_c_259_p N_VDD_M14_noxref_d ) capacitor c=0.065554f \
 //x=4.82 //y=5.56 //x2=4.235 //y2=5.2
cc_399 ( N_noxref_2_c_285_p N_VDD_M16_noxref_d ) capacitor c=0.00934027f \
 //x=5.215 //y=5.38 //x2=5.115 //y2=5.2
cc_400 ( N_noxref_2_c_383_p N_VDD_M16_noxref_d ) capacitor c=0.00921458f \
 //x=4.82 //y=5.56 //x2=5.115 //y2=5.2
cc_401 ( N_noxref_2_c_249_p N_VDD_M16_noxref_d ) capacitor c=9.65951e-19 \
 //x=5.3 //y=3.51 //x2=5.115 //y2=5.2
cc_402 ( N_noxref_2_c_259_p N_VDD_M16_noxref_d ) capacitor c=0.065554f \
 //x=4.82 //y=5.56 //x2=5.115 //y2=5.2
cc_403 ( N_noxref_2_c_285_p N_VDD_M17_noxref_s ) capacitor c=0.00316782f \
 //x=5.215 //y=5.38 //x2=6.58 //y2=5.2
cc_404 ( N_noxref_2_c_272_p N_VDD_M17_noxref_s ) capacitor c=0.00125782f \
 //x=6.78 //y=3.67 //x2=6.58 //y2=5.2
cc_405 ( N_noxref_2_c_248_p N_VDD_M17_noxref_s ) capacitor c=0.0212063f \
 //x=6.78 //y=4.76 //x2=6.58 //y2=5.2
cc_406 ( N_noxref_2_c_257_p N_VDD_M17_noxref_s ) capacitor c=0.00460957f \
 //x=4.82 //y=5.38 //x2=6.58 //y2=5.2
cc_407 ( N_noxref_2_c_383_p N_VDD_M17_noxref_s ) capacitor c=0.00135645f \
 //x=4.82 //y=5.56 //x2=6.58 //y2=5.2
cc_408 ( N_noxref_2_c_354_p N_VDD_M17_noxref_s ) capacitor c=0.00986169f \
 //x=6.78 //y=4.88 //x2=6.58 //y2=5.2
cc_409 ( N_noxref_2_M17_noxref_g N_VDD_M17_noxref_s ) capacitor c=0.0573441f \
 //x=6.935 //y=6.2 //x2=6.58 //y2=5.2
cc_410 ( N_noxref_2_c_356_p N_VDD_M17_noxref_s ) capacitor c=0.00524567f \
 //x=7.01 //y=4.97 //x2=6.58 //y2=5.2
cc_411 ( N_noxref_2_M18_noxref_g N_VDD_M18_noxref_d ) capacitor c=0.0572684f \
 //x=7.375 //y=6.2 //x2=7.45 //y2=5.2
cc_412 ( N_noxref_2_c_263_p N_GND_c_2919_n ) capacitor c=0.00654514f //x=5.215 \
 //y=1.835 //x2=9.355 //y2=0.175
cc_413 ( N_noxref_2_c_246_p N_GND_c_2919_n ) capacitor c=4.52555e-19 //x=5.3 \
 //y=3.67 //x2=9.355 //y2=0.175
cc_414 ( N_noxref_2_c_272_p N_GND_c_2919_n ) capacitor c=4.65445e-19 //x=6.78 \
 //y=3.67 //x2=9.355 //y2=0.175
cc_415 ( N_noxref_2_c_236_n N_GND_c_2919_n ) capacitor c=0.00964814f //x=4.86 \
 //y=1.18 //x2=9.355 //y2=0.175
cc_416 ( N_noxref_2_c_276_p N_GND_c_2919_n ) capacitor c=0.00249122f //x=6.78 \
 //y=2.265 //x2=9.355 //y2=0.175
cc_417 ( N_noxref_2_c_348_p N_GND_c_2919_n ) capacitor c=7.5371e-19 //x=6.78 \
 //y=2.265 //x2=9.355 //y2=0.175
cc_418 ( N_noxref_2_M2_noxref_d N_GND_c_2919_n ) capacitor c=3.01769e-19 \
 //x=4.67 //y=1.085 //x2=9.355 //y2=0.175
cc_419 ( N_noxref_2_c_229_n N_GND_c_2878_n ) capacitor c=4.73623e-19 //x=3.94 \
 //y=5.56 //x2=3.89 //y2=1.135
cc_420 ( N_noxref_2_c_236_n N_GND_c_2878_n ) capacitor c=0.0140211f //x=4.86 \
 //y=1.18 //x2=3.89 //y2=1.135
cc_421 ( N_noxref_2_M2_noxref_d N_GND_c_2878_n ) capacitor c=2.93544e-19 \
 //x=4.67 //y=1.085 //x2=3.89 //y2=1.135
cc_422 ( N_noxref_2_c_263_p N_GND_c_2896_n ) capacitor c=7.75992e-19 //x=5.215 \
 //y=1.835 //x2=5.87 //y2=0.175
cc_423 ( N_noxref_2_c_246_p N_GND_c_2896_n ) capacitor c=3.21306e-19 //x=5.3 \
 //y=3.67 //x2=5.87 //y2=0.175
cc_424 ( N_noxref_2_c_276_p N_GND_c_2931_n ) capacitor c=0.00114179f //x=6.78 \
 //y=2.265 //x2=7.065 //y2=0.715
cc_425 ( N_noxref_2_c_348_p N_GND_c_2931_n ) capacitor c=3.95714e-19 //x=6.78 \
 //y=2.265 //x2=7.065 //y2=0.715
cc_426 ( N_noxref_2_c_359_p N_GND_c_2931_n ) capacitor c=0.0125444f //x=6.89 \
 //y=1.09 //x2=7.065 //y2=0.715
cc_427 ( N_noxref_2_c_336_p N_GND_c_2931_n ) capacitor c=2.1838e-19 //x=6.78 \
 //y=2.265 //x2=7.065 //y2=0.715
cc_428 ( N_noxref_2_c_363_p N_GND_c_2935_n ) capacitor c=0.0132772f //x=7.42 \
 //y=1.09 //x2=7.555 //y2=0.715
cc_429 ( N_noxref_2_c_224_n N_GND_c_2899_n ) capacitor c=9.34543e-19 //x=5.3 \
 //y=3.35 //x2=2.71 //y2=0.175
cc_430 ( N_noxref_2_c_222_n N_GND_c_2937_n ) capacitor c=0.00269515f //x=4.86 \
 //y=1.75 //x2=6.04 //y2=0.175
cc_431 ( N_noxref_2_c_263_p N_GND_c_2937_n ) capacitor c=0.027102f //x=5.215 \
 //y=1.835 //x2=6.04 //y2=0.175
cc_432 ( N_noxref_2_c_244_p N_GND_c_2937_n ) capacitor c=0.0103129f //x=6.78 \
 //y=3.35 //x2=6.04 //y2=0.175
cc_433 ( N_noxref_2_c_276_p N_GND_c_2937_n ) capacitor c=0.00682461f //x=6.78 \
 //y=2.265 //x2=6.04 //y2=0.175
cc_434 ( N_noxref_2_c_348_p N_GND_c_2937_n ) capacitor c=0.00733236f //x=6.78 \
 //y=2.265 //x2=6.04 //y2=0.175
cc_435 ( N_noxref_2_c_327_p N_GND_c_2937_n ) capacitor c=0.00427677f //x=6.89 \
 //y=2.1 //x2=6.04 //y2=0.175
cc_436 ( N_noxref_2_c_336_p N_GND_c_2937_n ) capacitor c=0.00785621f //x=6.78 \
 //y=2.265 //x2=6.04 //y2=0.175
cc_437 ( N_noxref_2_c_348_p N_GND_c_2944_n ) capacitor c=0.00230732f //x=6.78 \
 //y=2.265 //x2=8.26 //y2=0.175
cc_438 ( N_noxref_2_c_236_n N_GND_c_2905_n ) capacitor c=2.83275e-19 //x=4.86 \
 //y=1.18 //x2=19.73 //y2=0.18
cc_439 ( N_noxref_2_c_236_n N_GND_M1_noxref_d ) capacitor c=2.82748e-19 \
 //x=4.86 //y=1.18 //x2=3.7 //y2=1.045
cc_440 ( N_noxref_2_c_272_p N_GND_M3_noxref_s ) capacitor c=8.20337e-19 \
 //x=6.78 //y=3.67 //x2=6.535 //y2=0.55
cc_441 ( N_noxref_2_c_276_p N_GND_M3_noxref_s ) capacitor c=0.00297876f \
 //x=6.78 //y=2.265 //x2=6.535 //y2=0.55
cc_442 ( N_noxref_2_c_348_p N_GND_M3_noxref_s ) capacitor c=0.00651326f \
 //x=6.78 //y=2.265 //x2=6.535 //y2=0.55
cc_443 ( N_noxref_2_c_359_p N_GND_M3_noxref_s ) capacitor c=0.0300814f \
 //x=6.89 //y=1.09 //x2=6.535 //y2=0.55
cc_444 ( N_noxref_2_c_326_p N_GND_M3_noxref_s ) capacitor c=0.002132f //x=6.89 \
 //y=1.745 //x2=6.535 //y2=0.55
cc_445 ( N_noxref_2_c_327_p N_GND_M3_noxref_s ) capacitor c=0.00304786f \
 //x=6.89 //y=2.1 //x2=6.535 //y2=0.55
cc_446 ( N_noxref_2_c_361_p N_GND_M3_noxref_s ) capacitor c=0.00517463f \
 //x=7.265 //y=0.935 //x2=6.535 //y2=0.55
cc_447 ( N_noxref_2_c_363_p N_GND_M3_noxref_s ) capacitor c=0.0153553f \
 //x=7.42 //y=1.09 //x2=6.535 //y2=0.55
cc_448 ( N_noxref_2_c_329_p N_GND_M3_noxref_s ) capacitor c=0.00629878f \
 //x=7.42 //y=1.435 //x2=6.535 //y2=0.55
cc_449 ( N_noxref_2_c_336_p N_GND_M3_noxref_s ) capacitor c=0.00405173f \
 //x=6.78 //y=2.265 //x2=6.535 //y2=0.55
cc_450 ( N_noxref_2_c_255_p N_noxref_14_c_3469_n ) capacitor c=0.00900974f \
 //x=4.945 //y=1.835 //x2=4.375 //y2=1.675
cc_451 ( N_noxref_2_c_263_p N_noxref_14_c_3474_n ) capacitor c=0.00373013f \
 //x=5.215 //y=1.835 //x2=5.26 //y2=0.71
cc_452 ( N_noxref_2_c_236_n N_noxref_14_c_3474_n ) capacitor c=0.003751f \
 //x=4.86 //y=1.18 //x2=5.26 //y2=0.71
cc_453 ( N_noxref_2_M2_noxref_d N_noxref_14_c_3474_n ) capacitor c=0.00910163f \
 //x=4.67 //y=1.085 //x2=5.26 //y2=0.71
cc_454 ( N_noxref_2_c_222_n N_noxref_14_M1_noxref_s ) capacitor c=0.0156395f \
 //x=4.86 //y=1.75 //x2=3.27 //y2=0.545
cc_455 ( N_noxref_2_c_263_p N_noxref_14_M1_noxref_s ) capacitor c=0.00640979f \
 //x=5.215 //y=1.835 //x2=3.27 //y2=0.545
cc_456 ( N_noxref_2_c_246_p N_noxref_14_M1_noxref_s ) capacitor c=4.17069e-19 \
 //x=5.3 //y=3.67 //x2=3.27 //y2=0.545
cc_457 ( N_noxref_2_c_236_n N_noxref_14_M1_noxref_s ) capacitor c=0.00896428f \
 //x=4.86 //y=1.18 //x2=3.27 //y2=0.545
cc_458 ( N_noxref_2_c_249_p N_noxref_14_M1_noxref_s ) capacitor c=0.0010514f \
 //x=5.3 //y=3.51 //x2=3.27 //y2=0.545
cc_459 ( N_noxref_2_M2_noxref_d N_noxref_14_M1_noxref_s ) capacitor \
 c=0.0275552f //x=4.67 //y=1.085 //x2=3.27 //y2=0.545
cc_460 ( GATE D ) capacitor c=0.0259743f //x=9.37 //y=2.77 //x2=10.11 //y2=2.4
cc_461 ( GATE D ) capacitor c=0.0326136f //x=9.37 //y=3.51 //x2=10.11 //y2=2.4
cc_462 ( GATE D ) capacitor c=0.00103412f //x=9.37 //y=3.14 //x2=10.11 //y2=2.4
cc_463 ( N_GATE_c_603_p D ) capacitor c=0.0142612f //x=9.37 //y=3.305 \
 //x2=10.11 //y2=2.4
cc_464 ( N_GATE_c_560_n D ) capacitor c=0.00654139f //x=6.99 //y=3.125 \
 //x2=10.11 //y2=2.4
cc_465 ( N_GATE_c_605_p D ) capacitor c=3.49899e-19 //x=9.37 //y=2.26 \
 //x2=10.11 //y2=2.4
cc_466 ( GATE D ) capacitor c=0.0136061f //x=9.37 //y=3.51 //x2=10.11 //y2=4.62
cc_467 ( N_GATE_c_607_p D ) capacitor c=3.02466e-19 //x=9.37 //y=4.88 \
 //x2=10.11 //y2=4.62
cc_468 ( N_GATE_c_608_p D ) capacitor c=0.00108965f //x=9.37 //y=4.88 \
 //x2=10.11 //y2=4.62
cc_469 ( GATE D ) capacitor c=0.00103412f //x=9.37 //y=3.51 //x2=10.11 //y2=4.25
cc_470 ( GATE N_D_c_843_n ) capacitor c=0.0167524f //x=9.37 //y=3.51 \
 //x2=10.11 //y2=4.415
cc_471 ( N_GATE_c_611_p N_D_c_844_n ) capacitor c=0.0172958f //x=9.37 //y=4.88 \
 //x2=10.11 //y2=4.735
cc_472 ( N_GATE_c_607_p N_D_c_844_n ) capacitor c=4.73677e-19 //x=9.37 \
 //y=4.88 //x2=10.11 //y2=4.735
cc_473 ( N_GATE_c_608_p N_D_c_844_n ) capacitor c=9.22067e-19 //x=9.37 \
 //y=4.88 //x2=10.11 //y2=4.735
cc_474 ( N_GATE_c_614_p N_D_c_847_n ) capacitor c=0.0205342f //x=9.37 //y=2.26 \
 //x2=10.11 //y2=2.26
cc_475 ( N_GATE_c_605_p N_D_c_847_n ) capacitor c=5.16867e-19 //x=9.37 \
 //y=2.26 //x2=10.11 //y2=2.26
cc_476 ( N_GATE_c_616_p N_D_c_847_n ) capacitor c=0.00167888f //x=9.175 \
 //y=2.095 //x2=10.11 //y2=2.26
cc_477 ( GATE N_D_c_850_n ) capacitor c=0.00294615f //x=9.37 //y=3.51 \
 //x2=10.11 //y2=4.255
cc_478 ( GATE N_D_c_781_n ) capacitor c=0.0284728f //x=4.56 //y=3.51 //x2=9.95 \
 //y2=4.262
cc_479 ( GATE N_D_c_781_n ) capacitor c=0.0261823f //x=9.37 //y=3.51 //x2=9.95 \
 //y2=4.262
cc_480 ( N_GATE_c_495_n N_D_c_781_n ) capacitor c=0.00258363f //x=4.56 \
 //y=3.305 //x2=9.95 //y2=4.262
cc_481 ( N_GATE_c_496_n N_D_c_781_n ) capacitor c=0.00289674f //x=4.56 \
 //y=4.735 //x2=9.95 //y2=4.262
cc_482 ( N_GATE_c_611_p N_D_c_781_n ) capacitor c=0.00319632f //x=9.37 \
 //y=4.88 //x2=9.95 //y2=4.262
cc_483 ( N_GATE_c_549_n N_D_c_781_n ) capacitor c=0.0155572f //x=4.915 \
 //y=3.14 //x2=9.95 //y2=4.262
cc_484 ( N_GATE_c_553_n N_D_c_781_n ) capacitor c=0.00438934f //x=5.515 \
 //y=3.125 //x2=9.95 //y2=4.262
cc_485 ( N_GATE_c_557_n N_D_c_781_n ) capacitor c=0.00678772f //x=6.39 \
 //y=3.14 //x2=9.95 //y2=4.262
cc_486 ( N_GATE_c_560_n N_D_c_781_n ) capacitor c=0.0178747f //x=6.99 \
 //y=3.125 //x2=9.95 //y2=4.262
cc_487 ( N_GATE_c_502_n N_D_c_781_n ) capacitor c=0.0084305f //x=4.715 \
 //y=3.152 //x2=9.95 //y2=4.262
cc_488 ( GATE N_D_c_861_n ) capacitor c=3.49899e-19 //x=9.37 //y=2.77 \
 //x2=10.11 //y2=2.26
cc_489 ( N_GATE_c_614_p N_D_c_861_n ) capacitor c=5.24723e-19 //x=9.37 \
 //y=2.26 //x2=10.11 //y2=2.26
cc_490 ( N_GATE_c_605_p N_D_c_861_n ) capacitor c=0.00485709f //x=9.37 \
 //y=2.26 //x2=10.11 //y2=2.26
cc_491 ( N_GATE_c_616_p N_D_c_861_n ) capacitor c=0.00190888f //x=9.175 \
 //y=2.095 //x2=10.11 //y2=2.26
cc_492 ( N_GATE_c_611_p N_D_c_865_n ) capacitor c=4.80626e-19 //x=9.37 \
 //y=4.88 //x2=10.14 //y2=4.88
cc_493 ( N_GATE_c_607_p N_D_c_865_n ) capacitor c=0.00397338f //x=9.37 \
 //y=4.88 //x2=10.14 //y2=4.88
cc_494 ( N_GATE_c_608_p N_D_c_865_n ) capacitor c=0.00283894f //x=9.37 \
 //y=4.88 //x2=10.14 //y2=4.88
cc_495 ( N_GATE_M19_noxref_g N_D_M21_noxref_g ) capacitor c=0.0104892f \
 //x=9.27 //y=6.2 //x2=10.15 //y2=6.2
cc_496 ( N_GATE_M20_noxref_g N_D_M21_noxref_g ) capacitor c=0.107636f //x=9.71 \
 //y=6.2 //x2=10.15 //y2=6.2
cc_497 ( N_GATE_M20_noxref_g N_D_M22_noxref_g ) capacitor c=0.0100341f \
 //x=9.71 //y=6.2 //x2=10.59 //y2=6.2
cc_498 ( N_GATE_c_638_p N_D_c_871_n ) capacitor c=4.86545e-19 //x=9.175 \
 //y=1.045 //x2=10.145 //y2=1.085
cc_499 ( N_GATE_c_639_p N_D_c_871_n ) capacitor c=0.00152405f //x=9.175 \
 //y=1.39 //x2=10.145 //y2=1.085
cc_500 ( N_GATE_c_640_p N_D_c_871_n ) capacitor c=0.0151475f //x=9.705 \
 //y=1.045 //x2=10.145 //y2=1.085
cc_501 ( N_GATE_c_641_p N_D_c_874_n ) capacitor c=0.00109982f //x=9.175 \
 //y=1.7 //x2=10.145 //y2=1.43
cc_502 ( N_GATE_c_642_p N_D_c_874_n ) capacitor c=0.0111064f //x=9.705 \
 //y=1.39 //x2=10.145 //y2=1.43
cc_503 ( N_GATE_c_641_p N_D_c_876_n ) capacitor c=9.58243e-19 //x=9.175 \
 //y=1.7 //x2=10.145 //y2=1.74
cc_504 ( N_GATE_c_616_p N_D_c_876_n ) capacitor c=0.00662747f //x=9.175 \
 //y=2.095 //x2=10.145 //y2=1.74
cc_505 ( N_GATE_c_642_p N_D_c_876_n ) capacitor c=0.00862358f //x=9.705 \
 //y=1.39 //x2=10.145 //y2=1.74
cc_506 ( N_GATE_c_640_p N_D_c_879_n ) capacitor c=0.00127211f //x=9.705 \
 //y=1.045 //x2=10.675 //y2=1.085
cc_507 ( N_GATE_c_642_p N_D_c_880_n ) capacitor c=0.00204774f //x=9.705 \
 //y=1.39 //x2=10.675 //y2=1.43
cc_508 ( N_GATE_c_614_p N_D_c_881_n ) capacitor c=0.00167305f //x=9.37 \
 //y=2.26 //x2=10.11 //y2=2.26
cc_509 ( N_GATE_c_605_p N_D_c_881_n ) capacitor c=0.00266443f //x=9.37 \
 //y=2.26 //x2=10.11 //y2=2.26
cc_510 ( N_GATE_c_616_p N_D_c_881_n ) capacitor c=0.0181449f //x=9.175 \
 //y=2.095 //x2=10.11 //y2=2.26
cc_511 ( N_GATE_c_611_p N_D_c_884_n ) capacitor c=0.00158715f //x=9.37 \
 //y=4.88 //x2=10.14 //y2=4.88
cc_512 ( N_GATE_c_607_p N_D_c_884_n ) capacitor c=0.00237977f //x=9.37 \
 //y=4.88 //x2=10.14 //y2=4.88
cc_513 ( N_GATE_c_608_p N_D_c_884_n ) capacitor c=0.0297875f //x=9.37 //y=4.88 \
 //x2=10.14 //y2=4.88
cc_514 ( N_GATE_M20_noxref_g N_noxref_5_c_1040_n ) capacitor c=0.00967396f \
 //x=9.71 //y=6.2 //x2=10.255 //y2=5.38
cc_515 ( GATE N_noxref_5_c_1041_n ) capacitor c=0.00270367f //x=9.37 //y=2.77 \
 //x2=10.85 //y2=3.35
cc_516 ( GATE N_noxref_5_c_1042_n ) capacitor c=0.00345803f //x=9.37 //y=3.51 \
 //x2=10.85 //y2=5.295
cc_517 ( N_GATE_c_603_p N_noxref_5_c_1043_n ) capacitor c=5.02822e-19 //x=9.37 \
 //y=3.305 //x2=9.49 //y2=5.56
cc_518 ( N_GATE_c_611_p N_noxref_5_c_1043_n ) capacitor c=0.0118019f //x=9.37 \
 //y=4.88 //x2=9.49 //y2=5.56
cc_519 ( N_GATE_c_607_p N_noxref_5_c_1043_n ) capacitor c=0.00277154f //x=9.37 \
 //y=4.88 //x2=9.49 //y2=5.56
cc_520 ( N_GATE_M19_noxref_g N_noxref_5_c_1043_n ) capacitor c=0.00203628f \
 //x=9.27 //y=6.2 //x2=9.49 //y2=5.56
cc_521 ( N_GATE_M20_noxref_g N_noxref_5_c_1043_n ) capacitor c=0.00192712f \
 //x=9.71 //y=6.2 //x2=9.49 //y2=5.56
cc_522 ( N_GATE_c_608_p N_noxref_5_c_1043_n ) capacitor c=0.00196675f //x=9.37 \
 //y=4.88 //x2=9.49 //y2=5.56
cc_523 ( N_GATE_c_611_p N_noxref_5_c_1049_n ) capacitor c=0.00104426f //x=9.37 \
 //y=4.88 //x2=9.49 //y2=5.56
cc_524 ( N_GATE_c_607_p N_noxref_5_c_1049_n ) capacitor c=0.00377369f //x=9.37 \
 //y=4.88 //x2=9.49 //y2=5.56
cc_525 ( N_GATE_M19_noxref_g N_noxref_5_c_1049_n ) capacitor c=0.0158358f \
 //x=9.27 //y=6.2 //x2=9.49 //y2=5.56
cc_526 ( N_GATE_M20_noxref_g N_noxref_5_c_1049_n ) capacitor c=0.0178987f \
 //x=9.71 //y=6.2 //x2=9.49 //y2=5.56
cc_527 ( N_GATE_c_608_p N_noxref_5_c_1049_n ) capacitor c=0.0043218f //x=9.37 \
 //y=4.88 //x2=9.49 //y2=5.56
cc_528 ( N_GATE_c_560_n N_noxref_6_c_1310_n ) capacitor c=0.00974744f //x=6.99 \
 //y=3.125 //x2=7.235 //y2=2.02
cc_529 ( GATE N_noxref_6_c_1316_n ) capacitor c=0.00991597f //x=9.37 //y=2.77 \
 //x2=7.52 //y2=3.72
cc_530 ( GATE N_noxref_6_c_1316_n ) capacitor c=0.00730062f //x=9.37 //y=3.51 \
 //x2=7.52 //y2=3.72
cc_531 ( N_GATE_c_603_p N_noxref_6_c_1316_n ) capacitor c=0.00238767f //x=9.37 \
 //y=3.305 //x2=7.52 //y2=3.72
cc_532 ( N_GATE_c_614_p N_noxref_6_c_1316_n ) capacitor c=0.00457386f //x=9.37 \
 //y=2.26 //x2=7.52 //y2=3.72
cc_533 ( N_GATE_c_560_n N_noxref_6_c_1316_n ) capacitor c=0.0331819f //x=6.99 \
 //y=3.125 //x2=7.52 //y2=3.72
cc_534 ( GATE N_noxref_6_c_1325_n ) capacitor c=0.00238767f //x=9.37 //y=3.51 \
 //x2=7.52 //y2=4.025
cc_535 ( N_GATE_c_560_n N_noxref_6_c_1325_n ) capacitor c=0.00409636f //x=6.99 \
 //y=3.125 //x2=7.52 //y2=4.025
cc_536 ( GATE N_noxref_6_c_1327_n ) capacitor c=0.00946946f //x=9.37 //y=3.51 \
 //x2=7.52 //y2=5.055
cc_537 ( N_GATE_c_611_p N_noxref_6_c_1327_n ) capacitor c=0.00476843f //x=9.37 \
 //y=4.88 //x2=7.52 //y2=5.055
cc_538 ( N_GATE_c_560_n N_noxref_6_c_1332_n ) capacitor c=6.00397e-19 //x=6.99 \
 //y=3.125 //x2=7.15 //y2=1.185
cc_539 ( GATE N_noxref_6_c_1340_n ) capacitor c=2.07016e-19 //x=9.37 //y=3.51 \
 //x2=7.52 //y2=3.88
cc_540 ( GATE N_noxref_6_c_1363_n ) capacitor c=0.0252913f //x=9.37 //y=3.51 \
 //x2=10.465 //y2=3.88
cc_541 ( N_GATE_c_603_p N_noxref_6_c_1363_n ) capacitor c=0.00355272f //x=9.37 \
 //y=3.305 //x2=10.465 //y2=3.88
cc_542 ( N_GATE_c_560_n N_noxref_6_c_1363_n ) capacitor c=0.0869164f //x=6.99 \
 //y=3.125 //x2=10.465 //y2=3.88
cc_543 ( GATE N_noxref_6_c_1341_n ) capacitor c=0.00142272f //x=9.37 //y=3.51 \
 //x2=7.68 //y2=3.872
cc_544 ( N_GATE_c_560_n N_noxref_6_c_1341_n ) capacitor c=0.0157065f //x=6.99 \
 //y=3.125 //x2=7.68 //y2=3.872
cc_545 ( N_GATE_c_611_p N_VDD_c_2464_n ) capacitor c=9.07241e-19 //x=9.37 \
 //y=4.88 //x2=14.955 //y2=7.585
cc_546 ( N_GATE_c_607_p N_VDD_c_2464_n ) capacitor c=6.22888e-19 //x=9.37 \
 //y=4.88 //x2=14.955 //y2=7.585
cc_547 ( N_GATE_M15_noxref_g N_VDD_c_2512_n ) capacitor c=0.00697352f //x=4.6 \
 //y=6.2 //x2=5.175 //y2=7.585
cc_548 ( N_GATE_M16_noxref_g N_VDD_c_2512_n ) capacitor c=0.00755544f //x=5.04 \
 //y=6.2 //x2=5.175 //y2=7.585
cc_549 ( N_GATE_c_611_p N_VDD_c_2560_n ) capacitor c=6.28113e-19 //x=9.37 \
 //y=4.88 //x2=9.845 //y2=7.585
cc_550 ( N_GATE_M19_noxref_g N_VDD_c_2560_n ) capacitor c=0.00732618f //x=9.27 \
 //y=6.2 //x2=9.845 //y2=7.585
cc_551 ( N_GATE_M20_noxref_g N_VDD_c_2560_n ) capacitor c=0.00755544f //x=9.71 \
 //y=6.2 //x2=9.845 //y2=7.585
cc_552 ( N_GATE_c_507_n N_VDD_c_2523_n ) capacitor c=0.00226427f //x=4.59 \
 //y=4.88 //x2=6.04 //y2=7.585
cc_553 ( N_GATE_c_580_n N_VDD_c_2523_n ) capacitor c=0.0129375f //x=4.965 \
 //y=4.97 //x2=6.04 //y2=7.585
cc_554 ( N_GATE_c_526_n N_VDD_c_2523_n ) capacitor c=2.73429e-19 //x=4.59 \
 //y=4.88 //x2=6.04 //y2=7.585
cc_555 ( GATE N_VDD_c_2531_n ) capacitor c=0.00675188f //x=9.37 //y=3.51 \
 //x2=8.26 //y2=7.585
cc_556 ( N_GATE_c_611_p N_VDD_c_2531_n ) capacitor c=0.00447349f //x=9.37 \
 //y=4.88 //x2=8.26 //y2=7.585
cc_557 ( N_GATE_c_607_p N_VDD_c_2531_n ) capacitor c=0.00370494f //x=9.37 \
 //y=4.88 //x2=8.26 //y2=7.585
cc_558 ( N_GATE_c_608_p N_VDD_c_2531_n ) capacitor c=0.0121704f //x=9.37 \
 //y=4.88 //x2=8.26 //y2=7.585
cc_559 ( N_GATE_M15_noxref_g N_VDD_M14_noxref_d ) capacitor c=0.015318f \
 //x=4.6 //y=6.2 //x2=4.235 //y2=5.2
cc_560 ( N_GATE_c_526_n N_VDD_M14_noxref_d ) capacitor c=3.32552e-19 //x=4.59 \
 //y=4.88 //x2=4.235 //y2=5.2
cc_561 ( N_GATE_M16_noxref_g N_VDD_M16_noxref_d ) capacitor c=0.0430452f \
 //x=5.04 //y=6.2 //x2=5.115 //y2=5.2
cc_562 ( N_GATE_c_603_p N_VDD_M19_noxref_s ) capacitor c=8.99344e-19 //x=9.37 \
 //y=3.305 //x2=8.915 //y2=5.2
cc_563 ( N_GATE_M19_noxref_g N_VDD_M19_noxref_s ) capacitor c=0.0567929f \
 //x=9.27 //y=6.2 //x2=8.915 //y2=5.2
cc_564 ( N_GATE_M20_noxref_g N_VDD_M20_noxref_d ) capacitor c=0.015318f \
 //x=9.71 //y=6.2 //x2=9.785 //y2=5.2
cc_565 ( N_GATE_c_495_n N_GND_c_2919_n ) capacitor c=2.46283e-19 //x=4.56 \
 //y=3.305 //x2=9.355 //y2=0.175
cc_566 ( N_GATE_c_499_n N_GND_c_2919_n ) capacitor c=0.00234561f //x=4.56 \
 //y=2.26 //x2=9.355 //y2=0.175
cc_567 ( N_GATE_c_603_p N_GND_c_2959_n ) capacitor c=2.27689e-19 //x=9.37 \
 //y=3.305 //x2=9.44 //y2=1.135
cc_568 ( N_GATE_c_614_p N_GND_c_2959_n ) capacitor c=0.00679558f //x=9.37 \
 //y=2.26 //x2=9.44 //y2=1.135
cc_569 ( N_GATE_c_560_n N_GND_c_2959_n ) capacitor c=0.00263851f //x=6.99 \
 //y=3.125 //x2=9.44 //y2=1.135
cc_570 ( N_GATE_c_605_p N_GND_c_2959_n ) capacitor c=2.13705e-19 //x=9.37 \
 //y=2.26 //x2=9.44 //y2=1.135
cc_571 ( N_GATE_c_638_p N_GND_c_2959_n ) capacitor c=0.00175094f //x=9.175 \
 //y=1.045 //x2=9.44 //y2=1.135
cc_572 ( N_GATE_c_639_p N_GND_c_2959_n ) capacitor c=0.00354198f //x=9.175 \
 //y=1.39 //x2=9.44 //y2=1.135
cc_573 ( N_GATE_c_641_p N_GND_c_2959_n ) capacitor c=4.2764e-19 //x=9.175 \
 //y=1.7 //x2=9.44 //y2=1.135
cc_574 ( N_GATE_c_714_p N_GND_c_2959_n ) capacitor c=7.35788e-19 //x=9.55 \
 //y=0.89 //x2=9.44 //y2=1.135
cc_575 ( N_GATE_c_715_p N_GND_c_2959_n ) capacitor c=6.23308e-19 //x=9.55 \
 //y=1.545 //x2=9.44 //y2=1.135
cc_576 ( N_GATE_c_640_p N_GND_c_2959_n ) capacitor c=0.00158609f //x=9.705 \
 //y=1.045 //x2=9.44 //y2=1.135
cc_577 ( N_GATE_c_642_p N_GND_c_2959_n ) capacitor c=0.00296337f //x=9.705 \
 //y=1.39 //x2=9.44 //y2=1.135
cc_578 ( N_GATE_c_638_p N_GND_c_2970_n ) capacitor c=3.51399e-19 //x=9.175 \
 //y=1.045 //x2=9.437 //y2=1.005
cc_579 ( N_GATE_c_714_p N_GND_c_2970_n ) capacitor c=0.00864609f //x=9.55 \
 //y=0.89 //x2=9.437 //y2=1.005
cc_580 ( N_GATE_c_640_p N_GND_c_2970_n ) capacitor c=4.45447e-19 //x=9.705 \
 //y=1.045 //x2=9.437 //y2=1.005
cc_581 ( N_GATE_c_499_n N_GND_c_2896_n ) capacitor c=3.77328e-19 //x=4.56 \
 //y=2.26 //x2=5.87 //y2=0.175
cc_582 ( N_GATE_c_638_p N_GND_c_2974_n ) capacitor c=0.00691994f //x=9.175 \
 //y=1.045 //x2=11.42 //y2=0.175
cc_583 ( N_GATE_c_557_n N_GND_c_2937_n ) capacitor c=0.00725442f //x=6.39 \
 //y=3.14 //x2=6.04 //y2=0.175
cc_584 ( N_GATE_c_503_n N_GND_c_2937_n ) capacitor c=0.00224736f //x=4.56 \
 //y=2.26 //x2=6.04 //y2=0.175
cc_585 ( N_GATE_c_522_n N_GND_c_2937_n ) capacitor c=0.00275184f //x=5.125 \
 //y=1.43 //x2=6.04 //y2=0.175
cc_586 ( N_GATE_c_523_n N_GND_c_2937_n ) capacitor c=2.63786e-19 //x=4.56 \
 //y=2.26 //x2=6.04 //y2=0.175
cc_587 ( GATE N_GND_c_2944_n ) capacitor c=0.00829739f //x=9.37 //y=2.77 \
 //x2=8.26 //y2=0.175
cc_588 ( N_GATE_c_614_p N_GND_c_2944_n ) capacitor c=0.00427323f //x=9.37 \
 //y=2.26 //x2=8.26 //y2=0.175
cc_589 ( N_GATE_c_560_n N_GND_c_2944_n ) capacitor c=0.00725442f //x=6.99 \
 //y=3.125 //x2=8.26 //y2=0.175
cc_590 ( N_GATE_c_605_p N_GND_c_2944_n ) capacitor c=0.00369427f //x=9.37 \
 //y=2.26 //x2=8.26 //y2=0.175
cc_591 ( N_GATE_c_616_p N_GND_c_2944_n ) capacitor c=0.00932032f //x=9.175 \
 //y=2.095 //x2=8.26 //y2=0.175
cc_592 ( N_GATE_c_560_n N_GND_M3_noxref_s ) capacitor c=0.00310451f //x=6.99 \
 //y=3.125 //x2=6.535 //y2=0.55
cc_593 ( N_GATE_c_614_p N_GND_M4_noxref_d ) capacitor c=2.20438e-19 //x=9.37 \
 //y=2.26 //x2=9.25 //y2=1.045
cc_594 ( N_GATE_c_638_p N_GND_M4_noxref_d ) capacitor c=0.00192399f //x=9.175 \
 //y=1.045 //x2=9.25 //y2=1.045
cc_595 ( N_GATE_c_639_p N_GND_M4_noxref_d ) capacitor c=0.00210798f //x=9.175 \
 //y=1.39 //x2=9.25 //y2=1.045
cc_596 ( N_GATE_c_714_p N_GND_M4_noxref_d ) capacitor c=0.00472259f //x=9.55 \
 //y=0.89 //x2=9.25 //y2=1.045
cc_597 ( N_GATE_c_715_p N_GND_M4_noxref_d ) capacitor c=0.00166857f //x=9.55 \
 //y=1.545 //x2=9.25 //y2=1.045
cc_598 ( N_GATE_c_640_p N_GND_M4_noxref_d ) capacitor c=0.00230174f //x=9.705 \
 //y=1.045 //x2=9.25 //y2=1.045
cc_599 ( N_GATE_c_642_p N_GND_M4_noxref_d ) capacitor c=0.00210798f //x=9.705 \
 //y=1.39 //x2=9.25 //y2=1.045
cc_600 ( N_GATE_c_495_n N_noxref_14_c_3469_n ) capacitor c=8.6972e-19 //x=4.56 \
 //y=3.305 //x2=4.375 //y2=1.675
cc_601 ( N_GATE_c_499_n N_noxref_14_c_3469_n ) capacitor c=7.50092e-19 \
 //x=4.56 //y=2.26 //x2=4.375 //y2=1.675
cc_602 ( N_GATE_c_518_n N_noxref_14_c_3469_n ) capacitor c=0.00888238f \
 //x=4.595 //y=1.74 //x2=4.375 //y2=1.675
cc_603 ( N_GATE_c_523_n N_noxref_14_c_3469_n ) capacitor c=0.00173993f \
 //x=4.56 //y=2.26 //x2=4.375 //y2=1.675
cc_604 ( N_GATE_c_495_n N_noxref_14_c_3474_n ) capacitor c=2.60366e-19 \
 //x=4.56 //y=3.305 //x2=5.26 //y2=0.71
cc_605 ( N_GATE_c_499_n N_noxref_14_c_3474_n ) capacitor c=0.001463f //x=4.56 \
 //y=2.26 //x2=5.26 //y2=0.71
cc_606 ( N_GATE_c_503_n N_noxref_14_c_3474_n ) capacitor c=8.82141e-19 \
 //x=4.56 //y=2.26 //x2=5.26 //y2=0.71
cc_607 ( N_GATE_c_513_n N_noxref_14_c_3474_n ) capacitor c=0.0200738f \
 //x=4.595 //y=1.085 //x2=5.26 //y2=0.71
cc_608 ( N_GATE_c_521_n N_noxref_14_c_3474_n ) capacitor c=0.00825432f \
 //x=5.125 //y=1.085 //x2=5.26 //y2=0.71
cc_609 ( N_GATE_c_523_n N_noxref_14_c_3474_n ) capacitor c=2.1838e-19 //x=4.56 \
 //y=2.26 //x2=5.26 //y2=0.71
cc_610 ( N_GATE_c_553_n N_noxref_14_M1_noxref_s ) capacitor c=5.85337e-19 \
 //x=5.515 //y=3.125 //x2=3.27 //y2=0.545
cc_611 ( N_GATE_c_513_n N_noxref_14_M1_noxref_s ) capacitor c=0.00888238f \
 //x=4.595 //y=1.085 //x2=3.27 //y2=0.545
cc_612 ( N_GATE_c_521_n N_noxref_14_M1_noxref_s ) capacitor c=0.015333f \
 //x=5.125 //y=1.085 //x2=3.27 //y2=0.545
cc_613 ( N_GATE_c_522_n N_noxref_14_M1_noxref_s ) capacitor c=0.00248746f \
 //x=5.125 //y=1.43 //x2=3.27 //y2=0.545
cc_614 ( N_GATE_c_560_n N_noxref_15_c_3525_n ) capacitor c=0.00317601f \
 //x=6.99 //y=3.125 //x2=8.955 //y2=1.675
cc_615 ( N_GATE_c_616_p N_noxref_15_c_3525_n ) capacitor c=0.00262672f \
 //x=9.175 //y=2.095 //x2=8.955 //y2=1.675
cc_616 ( N_GATE_c_603_p N_noxref_15_c_3527_n ) capacitor c=0.00456436f \
 //x=9.37 //y=3.305 //x2=9.84 //y2=1.76
cc_617 ( N_GATE_c_614_p N_noxref_15_c_3527_n ) capacitor c=0.00509504f \
 //x=9.37 //y=2.26 //x2=9.84 //y2=1.76
cc_618 ( N_GATE_c_560_n N_noxref_15_c_3527_n ) capacitor c=0.00118517f \
 //x=6.99 //y=3.125 //x2=9.84 //y2=1.76
cc_619 ( N_GATE_c_605_p N_noxref_15_c_3527_n ) capacitor c=0.00763108f \
 //x=9.37 //y=2.26 //x2=9.84 //y2=1.76
cc_620 ( N_GATE_c_641_p N_noxref_15_c_3527_n ) capacitor c=0.00697076f \
 //x=9.175 //y=1.7 //x2=9.84 //y2=1.76
cc_621 ( N_GATE_c_616_p N_noxref_15_c_3527_n ) capacitor c=0.0174293f \
 //x=9.175 //y=2.095 //x2=9.84 //y2=1.76
cc_622 ( N_GATE_c_715_p N_noxref_15_c_3527_n ) capacitor c=0.00723574f \
 //x=9.55 //y=1.545 //x2=9.84 //y2=1.76
cc_623 ( N_GATE_c_642_p N_noxref_15_c_3527_n ) capacitor c=0.00339872f \
 //x=9.705 //y=1.39 //x2=9.84 //y2=1.76
cc_624 ( N_GATE_c_616_p N_noxref_15_c_3535_n ) capacitor c=6.71402e-19 \
 //x=9.175 //y=2.095 //x2=9.925 //y2=1.675
cc_625 ( N_GATE_c_638_p N_noxref_15_M4_noxref_s ) capacitor c=0.0294925f \
 //x=9.175 //y=1.045 //x2=8.82 //y2=0.545
cc_626 ( N_GATE_c_641_p N_noxref_15_M4_noxref_s ) capacitor c=3.48408e-19 \
 //x=9.175 //y=1.7 //x2=8.82 //y2=0.545
cc_627 ( N_GATE_c_640_p N_noxref_15_M4_noxref_s ) capacitor c=0.0125442f \
 //x=9.705 //y=1.045 //x2=8.82 //y2=0.545
cc_628 ( N_D_c_843_n N_noxref_5_c_1040_n ) capacitor c=0.00425668f //x=10.11 \
 //y=4.415 //x2=10.255 //y2=5.38
cc_629 ( N_D_c_844_n N_noxref_5_c_1040_n ) capacitor c=0.0220515f //x=10.11 \
 //y=4.735 //x2=10.255 //y2=5.38
cc_630 ( N_D_c_850_n N_noxref_5_c_1040_n ) capacitor c=0.00119924f //x=10.11 \
 //y=4.255 //x2=10.255 //y2=5.38
cc_631 ( N_D_c_781_n N_noxref_5_c_1040_n ) capacitor c=0.00156936f //x=9.95 \
 //y=4.262 //x2=10.255 //y2=5.38
cc_632 ( N_D_c_865_n N_noxref_5_c_1040_n ) capacitor c=0.00469257f //x=10.14 \
 //y=4.88 //x2=10.255 //y2=5.38
cc_633 ( N_D_M21_noxref_g N_noxref_5_c_1040_n ) capacitor c=0.00842859f \
 //x=10.15 //y=6.2 //x2=10.255 //y2=5.38
cc_634 ( N_D_c_884_n N_noxref_5_c_1040_n ) capacitor c=8.41897e-19 //x=10.14 \
 //y=4.88 //x2=10.255 //y2=5.38
cc_635 ( N_D_c_874_n N_noxref_5_c_1061_n ) capacitor c=0.00118531f //x=10.145 \
 //y=1.43 //x2=10.41 //y2=1.75
cc_636 ( N_D_c_876_n N_noxref_5_c_1061_n ) capacitor c=0.00437687f //x=10.145 \
 //y=1.74 //x2=10.41 //y2=1.75
cc_637 ( N_D_c_896_p N_noxref_5_c_1061_n ) capacitor c=0.00897029f //x=10.52 \
 //y=1.585 //x2=10.41 //y2=1.75
cc_638 ( N_D_c_880_n N_noxref_5_c_1061_n ) capacitor c=0.00303393f //x=10.675 \
 //y=1.43 //x2=10.41 //y2=1.75
cc_639 ( N_D_c_898_p N_noxref_5_c_1061_n ) capacitor c=0.00348382f //x=10.11 \
 //y=2.095 //x2=10.41 //y2=1.75
cc_640 ( N_D_M22_noxref_g N_noxref_5_c_1066_n ) capacitor c=0.0112707f \
 //x=10.59 //y=6.2 //x2=10.765 //y2=5.38
cc_641 ( N_D_c_896_p N_noxref_5_c_1067_n ) capacitor c=0.00194324f //x=10.52 \
 //y=1.585 //x2=10.765 //y2=1.835
cc_642 ( N_D_c_880_n N_noxref_5_c_1067_n ) capacitor c=0.00323005f //x=10.675 \
 //y=1.43 //x2=10.765 //y2=1.835
cc_643 ( D N_noxref_5_c_1041_n ) capacitor c=0.0415223f //x=10.11 //y=2.4 \
 //x2=10.85 //y2=3.35
cc_644 ( N_D_c_847_n N_noxref_5_c_1041_n ) capacitor c=0.015397f //x=10.11 \
 //y=2.26 //x2=10.85 //y2=3.35
cc_645 ( N_D_c_861_n N_noxref_5_c_1041_n ) capacitor c=9.90728e-19 //x=10.11 \
 //y=2.26 //x2=10.85 //y2=3.35
cc_646 ( N_D_c_881_n N_noxref_5_c_1041_n ) capacitor c=0.00281392f //x=10.11 \
 //y=2.26 //x2=10.85 //y2=3.35
cc_647 ( N_D_c_898_p N_noxref_5_c_1041_n ) capacitor c=0.00309521f //x=10.11 \
 //y=2.095 //x2=10.85 //y2=3.35
cc_648 ( D N_noxref_5_c_1074_n ) capacitor c=0.0148501f //x=10.11 //y=2.4 \
 //x2=10.85 //y2=3.67
cc_649 ( D N_noxref_5_c_1042_n ) capacitor c=0.0173298f //x=10.11 //y=2.4 \
 //x2=10.85 //y2=5.295
cc_650 ( D N_noxref_5_c_1042_n ) capacitor c=0.0133092f //x=10.11 //y=4.62 \
 //x2=10.85 //y2=5.295
cc_651 ( D N_noxref_5_c_1042_n ) capacitor c=7.30116e-19 //x=10.11 //y=4.25 \
 //x2=10.85 //y2=5.295
cc_652 ( N_D_c_843_n N_noxref_5_c_1042_n ) capacitor c=0.0142612f //x=10.11 \
 //y=4.415 //x2=10.85 //y2=5.295
cc_653 ( N_D_c_844_n N_noxref_5_c_1042_n ) capacitor c=0.016905f //x=10.11 \
 //y=4.735 //x2=10.85 //y2=5.295
cc_654 ( N_D_c_850_n N_noxref_5_c_1042_n ) capacitor c=0.00654092f //x=10.11 \
 //y=4.255 //x2=10.85 //y2=5.295
cc_655 ( N_D_c_865_n N_noxref_5_c_1042_n ) capacitor c=7.76118e-19 //x=10.14 \
 //y=4.88 //x2=10.85 //y2=5.295
cc_656 ( N_D_c_915_p N_noxref_5_c_1042_n ) capacitor c=0.0084741f //x=10.515 \
 //y=4.97 //x2=10.85 //y2=5.295
cc_657 ( N_D_c_884_n N_noxref_5_c_1042_n ) capacitor c=0.00142201f //x=10.14 \
 //y=4.88 //x2=10.85 //y2=5.295
cc_658 ( D N_noxref_5_c_1084_n ) capacitor c=0.00255565f //x=10.11 //y=2.4 \
 //x2=12.33 //y2=3.35
cc_659 ( D N_noxref_5_c_1085_n ) capacitor c=3.45028e-19 //x=10.11 //y=2.4 \
 //x2=12.33 //y2=4.76
cc_660 ( D N_noxref_5_c_1085_n ) capacitor c=0.00109645f //x=10.11 //y=4.62 \
 //x2=12.33 //y2=4.76
cc_661 ( N_D_c_781_n N_noxref_5_c_1043_n ) capacitor c=0.013395f //x=9.95 \
 //y=4.262 //x2=9.49 //y2=5.56
cc_662 ( N_D_c_850_n N_noxref_5_c_1088_n ) capacitor c=2.43286e-19 //x=10.11 \
 //y=4.255 //x2=10.37 //y2=5.38
cc_663 ( N_D_M21_noxref_g N_noxref_5_c_1088_n ) capacitor c=0.00192712f \
 //x=10.15 //y=6.2 //x2=10.37 //y2=5.38
cc_664 ( N_D_M22_noxref_g N_noxref_5_c_1088_n ) capacitor c=0.00291595f \
 //x=10.59 //y=6.2 //x2=10.37 //y2=5.38
cc_665 ( N_D_c_915_p N_noxref_5_c_1088_n ) capacitor c=0.0020909f //x=10.515 \
 //y=4.97 //x2=10.37 //y2=5.38
cc_666 ( N_D_c_871_n N_noxref_5_c_1092_n ) capacitor c=0.00120406f //x=10.145 \
 //y=1.085 //x2=10.41 //y2=1.18
cc_667 ( N_D_c_874_n N_noxref_5_c_1092_n ) capacitor c=0.00218558f //x=10.145 \
 //y=1.43 //x2=10.41 //y2=1.18
cc_668 ( N_D_c_927_p N_noxref_5_c_1092_n ) capacitor c=5.50523e-19 //x=10.52 \
 //y=0.93 //x2=10.41 //y2=1.18
cc_669 ( N_D_c_896_p N_noxref_5_c_1092_n ) capacitor c=5.67071e-19 //x=10.52 \
 //y=1.585 //x2=10.41 //y2=1.18
cc_670 ( N_D_c_879_n N_noxref_5_c_1092_n ) capacitor c=0.00109715f //x=10.675 \
 //y=1.085 //x2=10.41 //y2=1.18
cc_671 ( N_D_c_880_n N_noxref_5_c_1092_n ) capacitor c=0.00312043f //x=10.675 \
 //y=1.43 //x2=10.41 //y2=1.18
cc_672 ( D N_noxref_5_c_1098_n ) capacitor c=6.03895e-19 //x=10.11 //y=2.4 \
 //x2=10.85 //y2=3.51
cc_673 ( D N_noxref_5_c_1099_n ) capacitor c=0.00687742f //x=10.11 //y=2.4 \
 //x2=11.01 //y2=3.51
cc_674 ( N_D_M21_noxref_g N_noxref_5_c_1100_n ) capacitor c=0.0178987f \
 //x=10.15 //y=6.2 //x2=10.37 //y2=5.56
cc_675 ( N_D_M22_noxref_g N_noxref_5_c_1100_n ) capacitor c=0.0178506f \
 //x=10.59 //y=6.2 //x2=10.37 //y2=5.56
cc_676 ( N_D_c_915_p N_noxref_5_c_1100_n ) capacitor c=0.00291714f //x=10.515 \
 //y=4.97 //x2=10.37 //y2=5.56
cc_677 ( N_D_c_871_n N_noxref_5_M5_noxref_d ) capacitor c=0.00137165f \
 //x=10.145 //y=1.085 //x2=10.22 //y2=1.085
cc_678 ( N_D_c_874_n N_noxref_5_M5_noxref_d ) capacitor c=0.00237422f \
 //x=10.145 //y=1.43 //x2=10.22 //y2=1.085
cc_679 ( N_D_c_927_p N_noxref_5_M5_noxref_d ) capacitor c=0.0020782f //x=10.52 \
 //y=0.93 //x2=10.22 //y2=1.085
cc_680 ( N_D_c_896_p N_noxref_5_M5_noxref_d ) capacitor c=0.00356097f \
 //x=10.52 //y=1.585 //x2=10.22 //y2=1.085
cc_681 ( N_D_c_879_n N_noxref_5_M5_noxref_d ) capacitor c=8.50095e-19 \
 //x=10.675 //y=1.085 //x2=10.22 //y2=1.085
cc_682 ( N_D_c_880_n N_noxref_5_M5_noxref_d ) capacitor c=0.00237422f \
 //x=10.675 //y=1.43 //x2=10.22 //y2=1.085
cc_683 ( N_D_c_781_n N_noxref_6_c_1305_n ) capacitor c=7.51869e-19 //x=9.95 \
 //y=4.262 //x2=7.155 //y2=5.42
cc_684 ( N_D_c_781_n N_noxref_6_c_1313_n ) capacitor c=0.0123652f //x=9.95 \
 //y=4.262 //x2=7.24 //y2=5.14
cc_685 ( D N_noxref_6_c_1316_n ) capacitor c=0.00397343f //x=10.11 //y=2.4 \
 //x2=7.52 //y2=3.72
cc_686 ( N_D_c_781_n N_noxref_6_c_1325_n ) capacitor c=0.00670377f //x=9.95 \
 //y=4.262 //x2=7.52 //y2=4.025
cc_687 ( D N_noxref_6_c_1327_n ) capacitor c=0.00133526f //x=10.11 //y=4.62 \
 //x2=7.52 //y2=5.055
cc_688 ( N_D_c_781_n N_noxref_6_c_1327_n ) capacitor c=0.0275267f //x=9.95 \
 //y=4.262 //x2=7.52 //y2=5.055
cc_689 ( D N_noxref_6_c_1363_n ) capacitor c=0.025722f //x=10.11 //y=2.4 \
 //x2=10.465 //y2=3.88
cc_690 ( N_D_c_843_n N_noxref_6_c_1363_n ) capacitor c=0.00667156f //x=10.11 \
 //y=4.415 //x2=10.465 //y2=3.88
cc_691 ( N_D_c_847_n N_noxref_6_c_1363_n ) capacitor c=0.00161218f //x=10.11 \
 //y=2.26 //x2=10.465 //y2=3.88
cc_692 ( N_D_c_850_n N_noxref_6_c_1363_n ) capacitor c=0.036924f //x=10.11 \
 //y=4.255 //x2=10.465 //y2=3.88
cc_693 ( N_D_c_781_n N_noxref_6_c_1363_n ) capacitor c=0.206708f //x=9.95 \
 //y=4.262 //x2=10.465 //y2=3.88
cc_694 ( N_D_c_781_n N_noxref_6_c_1341_n ) capacitor c=0.0364613f //x=9.95 \
 //y=4.262 //x2=7.68 //y2=3.872
cc_695 ( D N_noxref_8_c_1901_n ) capacitor c=2.47942e-19 //x=10.11 //y=4.25 \
 //x2=13.07 //y2=4.25
cc_696 ( N_D_c_777_n N_VDD_c_2464_n ) capacitor c=3.15741e-19 //x=1.23 \
 //y=4.415 //x2=14.955 //y2=7.585
cc_697 ( N_D_c_778_n N_VDD_c_2464_n ) capacitor c=5.73169e-19 //x=1.23 \
 //y=4.76 //x2=14.955 //y2=7.585
cc_698 ( N_D_c_792_n N_VDD_c_2464_n ) capacitor c=3.40755e-19 //x=1.23 \
 //y=4.88 //x2=14.955 //y2=7.585
cc_699 ( N_D_c_777_n N_VDD_c_2470_n ) capacitor c=2.90549e-19 //x=1.23 \
 //y=4.415 //x2=1.96 //y2=7.585
cc_700 ( N_D_c_778_n N_VDD_c_2470_n ) capacitor c=5.48929e-19 //x=1.23 \
 //y=4.76 //x2=1.96 //y2=7.585
cc_701 ( N_D_M11_noxref_g N_VDD_c_2470_n ) capacitor c=0.00753931f //x=1.385 \
 //y=6.2 //x2=1.96 //y2=7.585
cc_702 ( N_D_M12_noxref_g N_VDD_c_2470_n ) capacitor c=0.00755544f //x=1.825 \
 //y=6.2 //x2=1.96 //y2=7.585
cc_703 ( N_D_M21_noxref_g N_VDD_c_2583_n ) capacitor c=0.00697352f //x=10.15 \
 //y=6.2 //x2=10.725 //y2=7.585
cc_704 ( N_D_M22_noxref_g N_VDD_c_2583_n ) capacitor c=0.00755544f //x=10.59 \
 //y=6.2 //x2=10.725 //y2=7.585
cc_705 ( D N_VDD_c_2476_n ) capacitor c=0.0101026f //x=1.23 //y=4.62 //x2=1.23 \
 //y2=7.58
cc_706 ( D N_VDD_c_2476_n ) capacitor c=0.00440981f //x=1.23 //y=4.25 \
 //x2=1.23 //y2=7.58
cc_707 ( N_D_c_777_n N_VDD_c_2476_n ) capacitor c=0.00271545f //x=1.23 \
 //y=4.415 //x2=1.23 //y2=7.58
cc_708 ( N_D_c_778_n N_VDD_c_2476_n ) capacitor c=0.00869686f //x=1.23 \
 //y=4.76 //x2=1.23 //y2=7.58
cc_709 ( N_D_c_792_n N_VDD_c_2476_n ) capacitor c=0.00851507f //x=1.23 \
 //y=4.88 //x2=1.23 //y2=7.58
cc_710 ( N_D_M11_noxref_g N_VDD_c_2476_n ) capacitor c=0.0186157f //x=1.385 \
 //y=6.2 //x2=1.23 //y2=7.58
cc_711 ( N_D_c_810_n N_VDD_c_2476_n ) capacitor c=0.00701819f //x=1.46 \
 //y=4.97 //x2=1.23 //y2=7.58
cc_712 ( D N_VDD_c_2479_n ) capacitor c=0.00133985f //x=1.23 //y=4.25 \
 //x2=2.71 //y2=7.585
cc_713 ( N_D_c_781_n N_VDD_c_2479_n ) capacitor c=0.0194436f //x=9.95 \
 //y=4.262 //x2=2.71 //y2=7.585
cc_714 ( N_D_c_792_n N_VDD_c_2479_n ) capacitor c=0.00235165f //x=1.23 \
 //y=4.88 //x2=2.71 //y2=7.585
cc_715 ( N_D_c_806_n N_VDD_c_2479_n ) capacitor c=0.00780996f //x=1.75 \
 //y=4.97 //x2=2.71 //y2=7.585
cc_716 ( N_D_c_810_n N_VDD_c_2479_n ) capacitor c=2.63786e-19 //x=1.46 \
 //y=4.97 //x2=2.71 //y2=7.585
cc_717 ( N_D_c_781_n N_VDD_c_2523_n ) capacitor c=0.0196363f //x=9.95 \
 //y=4.262 //x2=6.04 //y2=7.585
cc_718 ( D N_VDD_c_2531_n ) capacitor c=8.50173e-19 //x=10.11 //y=4.25 \
 //x2=8.26 //y2=7.585
cc_719 ( N_D_c_781_n N_VDD_c_2531_n ) capacitor c=0.0194487f //x=9.95 \
 //y=4.262 //x2=8.26 //y2=7.585
cc_720 ( D N_VDD_c_2600_n ) capacitor c=0.00143727f //x=10.11 //y=4.25 \
 //x2=11.59 //y2=7.585
cc_721 ( N_D_c_865_n N_VDD_c_2600_n ) capacitor c=0.00226427f //x=10.14 \
 //y=4.88 //x2=11.59 //y2=7.585
cc_722 ( N_D_c_915_p N_VDD_c_2600_n ) capacitor c=0.0129375f //x=10.515 \
 //y=4.97 //x2=11.59 //y2=7.585
cc_723 ( N_D_c_884_n N_VDD_c_2600_n ) capacitor c=2.73429e-19 //x=10.14 \
 //y=4.88 //x2=11.59 //y2=7.585
cc_724 ( N_D_c_777_n N_VDD_M11_noxref_s ) capacitor c=0.00211589f //x=1.23 \
 //y=4.415 //x2=1.03 //y2=5.2
cc_725 ( N_D_c_778_n N_VDD_M11_noxref_s ) capacitor c=0.0208734f //x=1.23 \
 //y=4.76 //x2=1.03 //y2=5.2
cc_726 ( N_D_c_780_n N_VDD_M11_noxref_s ) capacitor c=6.59418e-19 //x=1.39 \
 //y=4.262 //x2=1.03 //y2=5.2
cc_727 ( N_D_c_792_n N_VDD_M11_noxref_s ) capacitor c=0.00986169f //x=1.23 \
 //y=4.88 //x2=1.03 //y2=5.2
cc_728 ( N_D_M11_noxref_g N_VDD_M11_noxref_s ) capacitor c=0.0573441f \
 //x=1.385 //y=6.2 //x2=1.03 //y2=5.2
cc_729 ( N_D_c_810_n N_VDD_M11_noxref_s ) capacitor c=0.0053173f //x=1.46 \
 //y=4.97 //x2=1.03 //y2=5.2
cc_730 ( N_D_c_781_n N_VDD_M12_noxref_d ) capacitor c=0.00224347f //x=9.95 \
 //y=4.262 //x2=1.9 //y2=5.2
cc_731 ( N_D_M12_noxref_g N_VDD_M12_noxref_d ) capacitor c=0.0572684f \
 //x=1.825 //y=6.2 //x2=1.9 //y2=5.2
cc_732 ( N_D_c_781_n N_VDD_M13_noxref_s ) capacitor c=0.00542893f //x=9.95 \
 //y=4.262 //x2=3.365 //y2=5.2
cc_733 ( N_D_c_781_n N_VDD_M17_noxref_s ) capacitor c=0.00130658f //x=9.95 \
 //y=4.262 //x2=6.58 //y2=5.2
cc_734 ( N_D_c_781_n N_VDD_M18_noxref_d ) capacitor c=0.00224242f //x=9.95 \
 //y=4.262 //x2=7.45 //y2=5.2
cc_735 ( N_D_c_781_n N_VDD_M19_noxref_s ) capacitor c=0.00564089f //x=9.95 \
 //y=4.262 //x2=8.915 //y2=5.2
cc_736 ( N_D_M21_noxref_g N_VDD_M20_noxref_d ) capacitor c=0.015318f //x=10.15 \
 //y=6.2 //x2=9.785 //y2=5.2
cc_737 ( N_D_c_884_n N_VDD_M20_noxref_d ) capacitor c=3.50465e-19 //x=10.14 \
 //y=4.88 //x2=9.785 //y2=5.2
cc_738 ( N_D_M22_noxref_g N_VDD_M22_noxref_d ) capacitor c=0.0430452f \
 //x=10.59 //y=6.2 //x2=10.665 //y2=5.2
cc_739 ( N_D_c_777_n N_GND_c_2872_n ) capacitor c=2.71305e-19 //x=1.23 \
 //y=4.415 //x2=3.805 //y2=0.175
cc_740 ( N_D_c_779_n N_GND_c_2872_n ) capacitor c=0.00249122f //x=1.23 \
 //y=2.265 //x2=3.805 //y2=0.175
cc_741 ( N_D_c_791_n N_GND_c_2872_n ) capacitor c=7.5371e-19 //x=1.23 \
 //y=2.265 //x2=3.805 //y2=0.175
cc_742 ( N_D_c_843_n N_GND_c_2995_n ) capacitor c=2.68756e-19 //x=10.11 \
 //y=4.415 //x2=19.73 //y2=0.18
cc_743 ( N_D_c_847_n N_GND_c_2995_n ) capacitor c=0.00234561f //x=10.11 \
 //y=2.26 //x2=19.73 //y2=0.18
cc_744 ( N_D_c_779_n N_GND_c_2892_n ) capacitor c=0.00108343f //x=1.23 \
 //y=2.265 //x2=1.515 //y2=0.715
cc_745 ( N_D_c_791_n N_GND_c_2892_n ) capacitor c=3.95714e-19 //x=1.23 \
 //y=2.265 //x2=1.515 //y2=0.715
cc_746 ( N_D_c_799_n N_GND_c_2892_n ) capacitor c=0.0124814f //x=1.34 //y=1.09 \
 //x2=1.515 //y2=0.715
cc_747 ( N_D_c_822_n N_GND_c_2892_n ) capacitor c=2.1838e-19 //x=1.23 \
 //y=2.265 //x2=1.515 //y2=0.715
cc_748 ( N_D_c_817_n N_GND_c_2893_n ) capacitor c=0.0132772f //x=1.87 //y=1.09 \
 //x2=2.005 //y2=0.715
cc_749 ( N_D_c_847_n N_GND_c_2974_n ) capacitor c=3.77328e-19 //x=10.11 \
 //y=2.26 //x2=11.42 //y2=0.175
cc_750 ( D N_GND_c_2897_n ) capacitor c=0.0146622f //x=1.23 //y=2.77 //x2=1.12 \
 //y2=0.175
cc_751 ( N_D_c_779_n N_GND_c_2897_n ) capacitor c=0.0100674f //x=1.23 \
 //y=2.265 //x2=1.12 //y2=0.175
cc_752 ( N_D_c_791_n N_GND_c_2897_n ) capacitor c=0.00789228f //x=1.23 \
 //y=2.265 //x2=1.12 //y2=0.175
cc_753 ( N_D_c_805_n N_GND_c_2897_n ) capacitor c=0.00552086f //x=1.34 //y=2.1 \
 //x2=1.12 //y2=0.175
cc_754 ( N_D_c_822_n N_GND_c_2897_n ) capacitor c=0.00687518f //x=1.23 \
 //y=2.265 //x2=1.12 //y2=0.175
cc_755 ( N_D_c_791_n N_GND_c_2899_n ) capacitor c=0.0022444f //x=1.23 \
 //y=2.265 //x2=2.71 //y2=0.175
cc_756 ( N_D_c_822_n N_GND_c_2899_n ) capacitor c=2.63786e-19 //x=1.23 \
 //y=2.265 //x2=2.71 //y2=0.175
cc_757 ( N_D_c_861_n N_GND_c_3010_n ) capacitor c=0.00231028f //x=10.11 \
 //y=2.26 //x2=11.59 //y2=0.175
cc_758 ( N_D_c_880_n N_GND_c_3010_n ) capacitor c=0.00275184f //x=10.675 \
 //y=1.43 //x2=11.59 //y2=0.175
cc_759 ( N_D_c_777_n N_GND_M0_noxref_s ) capacitor c=2.06534e-19 //x=1.23 \
 //y=4.415 //x2=0.985 //y2=0.55
cc_760 ( N_D_c_779_n N_GND_M0_noxref_s ) capacitor c=0.00297876f //x=1.23 \
 //y=2.265 //x2=0.985 //y2=0.55
cc_761 ( N_D_c_791_n N_GND_M0_noxref_s ) capacitor c=0.00651326f //x=1.23 \
 //y=2.265 //x2=0.985 //y2=0.55
cc_762 ( N_D_c_799_n N_GND_M0_noxref_s ) capacitor c=0.0300221f //x=1.34 \
 //y=1.09 //x2=0.985 //y2=0.55
cc_763 ( N_D_c_804_n N_GND_M0_noxref_s ) capacitor c=0.002132f //x=1.34 \
 //y=1.745 //x2=0.985 //y2=0.55
cc_764 ( N_D_c_805_n N_GND_M0_noxref_s ) capacitor c=0.00304786f //x=1.34 \
 //y=2.1 //x2=0.985 //y2=0.55
cc_765 ( N_D_c_811_n N_GND_M0_noxref_s ) capacitor c=0.00517463f //x=1.715 \
 //y=0.935 //x2=0.985 //y2=0.55
cc_766 ( N_D_c_817_n N_GND_M0_noxref_s ) capacitor c=0.0153553f //x=1.87 \
 //y=1.09 //x2=0.985 //y2=0.55
cc_767 ( N_D_c_819_n N_GND_M0_noxref_s ) capacitor c=0.00629878f //x=1.87 \
 //y=1.435 //x2=0.985 //y2=0.55
cc_768 ( N_D_c_822_n N_GND_M0_noxref_s ) capacitor c=0.00660555f //x=1.23 \
 //y=2.265 //x2=0.985 //y2=0.55
cc_769 ( N_D_c_843_n N_noxref_15_c_3535_n ) capacitor c=9.47168e-19 //x=10.11 \
 //y=4.415 //x2=9.925 //y2=1.675
cc_770 ( N_D_c_847_n N_noxref_15_c_3535_n ) capacitor c=7.50092e-19 //x=10.11 \
 //y=2.26 //x2=9.925 //y2=1.675
cc_771 ( N_D_c_876_n N_noxref_15_c_3535_n ) capacitor c=0.00888238f //x=10.145 \
 //y=1.74 //x2=9.925 //y2=1.675
cc_772 ( N_D_c_881_n N_noxref_15_c_3535_n ) capacitor c=0.00175171f //x=10.11 \
 //y=2.26 //x2=9.925 //y2=1.675
cc_773 ( N_D_c_847_n N_noxref_15_c_3543_n ) capacitor c=0.00141156f //x=10.11 \
 //y=2.26 //x2=10.81 //y2=0.71
cc_774 ( N_D_c_861_n N_noxref_15_c_3543_n ) capacitor c=8.82141e-19 //x=10.11 \
 //y=2.26 //x2=10.81 //y2=0.71
cc_775 ( N_D_c_871_n N_noxref_15_c_3543_n ) capacitor c=0.0199501f //x=10.145 \
 //y=1.085 //x2=10.81 //y2=0.71
cc_776 ( N_D_c_879_n N_noxref_15_c_3543_n ) capacitor c=0.00825432f //x=10.675 \
 //y=1.085 //x2=10.81 //y2=0.71
cc_777 ( N_D_c_881_n N_noxref_15_c_3543_n ) capacitor c=2.1838e-19 //x=10.11 \
 //y=2.26 //x2=10.81 //y2=0.71
cc_778 ( N_D_c_871_n N_noxref_15_M4_noxref_s ) capacitor c=0.00888238f \
 //x=10.145 //y=1.085 //x2=8.82 //y2=0.545
cc_779 ( N_D_c_879_n N_noxref_15_M4_noxref_s ) capacitor c=0.015333f \
 //x=10.675 //y=1.085 //x2=8.82 //y2=0.545
cc_780 ( N_D_c_880_n N_noxref_15_M4_noxref_s ) capacitor c=0.00248746f \
 //x=10.675 //y=1.43 //x2=8.82 //y2=0.545
cc_781 ( N_noxref_5_c_1061_n N_noxref_6_c_1298_n ) capacitor c=0.00498121f \
 //x=10.41 //y=1.75 //x2=7.15 //y2=1.935
cc_782 ( N_noxref_5_c_1042_n N_noxref_6_c_1305_n ) capacitor c=6.68558e-19 \
 //x=10.85 //y=5.295 //x2=7.155 //y2=5.42
cc_783 ( N_noxref_5_c_1043_n N_noxref_6_c_1305_n ) capacitor c=6.16426e-19 \
 //x=9.49 //y=5.56 //x2=7.155 //y2=5.42
cc_784 ( N_noxref_5_c_1041_n N_noxref_6_c_1309_n ) capacitor c=0.00198687f \
 //x=10.85 //y=3.35 //x2=7.435 //y2=2.02
cc_785 ( N_noxref_5_c_1042_n N_noxref_6_c_1327_n ) capacitor c=0.00217431f \
 //x=10.85 //y=5.295 //x2=7.52 //y2=5.055
cc_786 ( N_noxref_5_c_1084_n N_noxref_6_c_1385_n ) capacitor c=0.00208723f \
 //x=12.33 //y=3.35 //x2=14.92 //y2=3.72
cc_787 ( N_noxref_5_c_1085_n N_noxref_6_c_1386_n ) capacitor c=0.00207238f \
 //x=12.33 //y=4.76 //x2=14.92 //y2=4.765
cc_788 ( N_noxref_5_c_1061_n N_noxref_6_c_1332_n ) capacitor c=4.16137e-19 \
 //x=10.41 //y=1.75 //x2=7.15 //y2=1.185
cc_789 ( N_noxref_5_c_1092_n N_noxref_6_c_1332_n ) capacitor c=6.80839e-19 \
 //x=10.41 //y=1.18 //x2=7.15 //y2=1.185
cc_790 ( N_noxref_5_c_1066_n N_noxref_6_c_1363_n ) capacitor c=0.00584114f \
 //x=10.765 //y=5.38 //x2=10.465 //y2=3.88
cc_791 ( N_noxref_5_c_1067_n N_noxref_6_c_1363_n ) capacitor c=0.00187984f \
 //x=10.765 //y=1.835 //x2=10.465 //y2=3.88
cc_792 ( N_noxref_5_c_1120_p N_noxref_6_c_1363_n ) capacitor c=0.003151f \
 //x=10.495 //y=1.835 //x2=10.465 //y2=3.88
cc_793 ( N_noxref_5_c_1074_n N_noxref_6_c_1363_n ) capacitor c=0.00138342f \
 //x=10.85 //y=3.67 //x2=10.465 //y2=3.88
cc_794 ( N_noxref_5_c_1042_n N_noxref_6_c_1363_n ) capacitor c=3.11404e-19 \
 //x=10.85 //y=5.295 //x2=10.465 //y2=3.88
cc_795 ( N_noxref_5_c_1088_n N_noxref_6_c_1363_n ) capacitor c=0.00616704f \
 //x=10.37 //y=5.38 //x2=10.465 //y2=3.88
cc_796 ( N_noxref_5_c_1099_n N_noxref_6_c_1363_n ) capacitor c=0.0373759f \
 //x=11.01 //y=3.51 //x2=10.465 //y2=3.88
cc_797 ( N_noxref_5_c_1074_n N_noxref_6_c_1396_n ) capacitor c=0.00767084f \
 //x=10.85 //y=3.67 //x2=11.068 //y2=3.892
cc_798 ( N_noxref_5_c_1042_n N_noxref_6_c_1396_n ) capacitor c=0.0280447f \
 //x=10.85 //y=5.295 //x2=11.068 //y2=3.892
cc_799 ( N_noxref_5_c_1127_p N_noxref_6_c_1396_n ) capacitor c=0.101769f \
 //x=12.165 //y=3.51 //x2=11.068 //y2=3.892
cc_800 ( N_noxref_5_c_1128_p N_noxref_6_c_1399_n ) capacitor c=0.00426779f \
 //x=12.33 //y=3.67 //x2=11.94 //y2=3.88
cc_801 ( N_noxref_5_c_1085_n N_noxref_6_c_1399_n ) capacitor c=4.49947e-19 \
 //x=12.33 //y=4.76 //x2=11.94 //y2=3.88
cc_802 ( N_noxref_5_c_1127_p N_noxref_6_c_1399_n ) capacitor c=0.0117648f \
 //x=12.165 //y=3.51 //x2=11.94 //y2=3.88
cc_803 ( N_noxref_5_c_1131_p N_noxref_6_c_1399_n ) capacitor c=0.0374497f \
 //x=12.325 //y=3.51 //x2=11.94 //y2=3.88
cc_804 ( N_noxref_5_c_1128_p N_noxref_6_c_1403_n ) capacitor c=0.00301505f \
 //x=12.33 //y=3.67 //x2=12.54 //y2=3.895
cc_805 ( N_noxref_5_c_1085_n N_noxref_6_c_1403_n ) capacitor c=0.0291899f \
 //x=12.33 //y=4.76 //x2=12.54 //y2=3.895
cc_806 ( N_noxref_5_c_1061_n N_Q_c_1597_n ) capacitor c=3.56665e-19 //x=10.41 \
 //y=1.75 //x2=14.99 //y2=1.75
cc_807 ( N_noxref_5_c_1067_n N_Q_c_1598_n ) capacitor c=3.3474e-19 //x=10.765 \
 //y=1.835 //x2=15.075 //y2=1.835
cc_808 ( N_noxref_5_c_1061_n N_noxref_8_c_1902_n ) capacitor c=0.0044864f \
 //x=10.41 //y=1.75 //x2=12.7 //y2=1.935
cc_809 ( N_noxref_5_c_1067_n N_noxref_8_c_1902_n ) capacitor c=0.00320685f \
 //x=10.765 //y=1.835 //x2=12.7 //y2=1.935
cc_810 ( N_noxref_5_c_1138_p N_noxref_8_c_1902_n ) capacitor c=0.00108934f \
 //x=12.44 //y=1.435 //x2=12.7 //y2=1.935
cc_811 ( N_noxref_5_c_1139_p N_noxref_8_c_1902_n ) capacitor c=0.00524682f \
 //x=12.44 //y=1.745 //x2=12.7 //y2=1.935
cc_812 ( N_noxref_5_c_1140_p N_noxref_8_c_1902_n ) capacitor c=0.00376309f \
 //x=12.44 //y=2.1 //x2=12.7 //y2=1.935
cc_813 ( N_noxref_5_c_1141_p N_noxref_8_c_1902_n ) capacitor c=0.0090274f \
 //x=12.815 //y=1.59 //x2=12.7 //y2=1.935
cc_814 ( N_noxref_5_c_1142_p N_noxref_8_c_1902_n ) capacitor c=0.00324043f \
 //x=12.97 //y=1.435 //x2=12.7 //y2=1.935
cc_815 ( N_noxref_5_c_1066_n N_noxref_8_c_1909_n ) capacitor c=0.00310478f \
 //x=10.765 //y=5.38 //x2=12.705 //y2=5.42
cc_816 ( N_noxref_5_c_1088_n N_noxref_8_c_1909_n ) capacitor c=5.44332e-19 \
 //x=10.37 //y=5.38 //x2=12.705 //y2=5.42
cc_817 ( N_noxref_5_M23_noxref_g N_noxref_8_c_1909_n ) capacitor c=0.00141266f \
 //x=12.485 //y=6.2 //x2=12.705 //y2=5.42
cc_818 ( N_noxref_5_M24_noxref_g N_noxref_8_c_1909_n ) capacitor c=0.0035313f \
 //x=12.925 //y=6.2 //x2=12.705 //y2=5.42
cc_819 ( N_noxref_5_c_1141_p N_noxref_8_c_1913_n ) capacitor c=0.00180253f \
 //x=12.815 //y=1.59 //x2=12.985 //y2=2.02
cc_820 ( N_noxref_5_c_1041_n N_noxref_8_c_1914_n ) capacitor c=0.00320685f \
 //x=10.85 //y=3.35 //x2=12.785 //y2=2.02
cc_821 ( N_noxref_5_c_1149_p N_noxref_8_c_1914_n ) capacitor c=0.00376309f \
 //x=12.33 //y=2.265 //x2=12.785 //y2=2.02
cc_822 ( N_noxref_5_M24_noxref_g N_noxref_8_c_1916_n ) capacitor c=0.00916923f \
 //x=12.925 //y=6.2 //x2=12.985 //y2=5.14
cc_823 ( N_noxref_5_c_1042_n N_noxref_8_c_1917_n ) capacitor c=0.00292883f \
 //x=10.85 //y=5.295 //x2=12.79 //y2=5.14
cc_824 ( N_noxref_5_M23_noxref_g N_noxref_8_c_1917_n ) capacitor c=0.00427521f \
 //x=12.485 //y=6.2 //x2=12.79 //y2=5.14
cc_825 ( N_noxref_5_c_1153_p N_noxref_8_c_1917_n ) capacitor c=0.00262283f \
 //x=12.85 //y=4.97 //x2=12.79 //y2=5.14
cc_826 ( N_noxref_5_c_1041_n N_noxref_8_c_1920_n ) capacitor c=0.00339603f \
 //x=10.85 //y=3.35 //x2=13.07 //y2=4.105
cc_827 ( N_noxref_5_c_1042_n N_noxref_8_c_1920_n ) capacitor c=3.43218e-19 \
 //x=10.85 //y=5.295 //x2=13.07 //y2=4.105
cc_828 ( N_noxref_5_c_1084_n N_noxref_8_c_1920_n ) capacitor c=0.0409193f \
 //x=12.33 //y=3.35 //x2=13.07 //y2=4.105
cc_829 ( N_noxref_5_c_1128_p N_noxref_8_c_1920_n ) capacitor c=0.0146933f \
 //x=12.33 //y=3.67 //x2=13.07 //y2=4.105
cc_830 ( N_noxref_5_c_1085_n N_noxref_8_c_1920_n ) capacitor c=0.0170874f \
 //x=12.33 //y=4.76 //x2=13.07 //y2=4.105
cc_831 ( N_noxref_5_c_1159_p N_noxref_8_c_1920_n ) capacitor c=6.03895e-19 \
 //x=12.325 //y=3.51 //x2=13.07 //y2=4.105
cc_832 ( N_noxref_5_c_1160_p N_noxref_8_c_1920_n ) capacitor c=0.017436f \
 //x=12.33 //y=2.265 //x2=13.07 //y2=4.105
cc_833 ( N_noxref_5_c_1131_p N_noxref_8_c_1920_n ) capacitor c=0.00684338f \
 //x=12.325 //y=3.51 //x2=13.07 //y2=4.105
cc_834 ( N_noxref_5_c_1162_p N_noxref_8_c_1920_n ) capacitor c=4.71798e-19 \
 //x=12.33 //y=2.265 //x2=13.07 //y2=4.105
cc_835 ( N_noxref_5_c_1149_p N_noxref_8_c_1920_n ) capacitor c=0.00270592f \
 //x=12.33 //y=2.265 //x2=13.07 //y2=4.105
cc_836 ( N_noxref_5_c_1085_n N_noxref_8_c_1930_n ) capacitor c=0.0142612f \
 //x=12.33 //y=4.76 //x2=13.07 //y2=4.41
cc_837 ( N_noxref_5_c_1153_p N_noxref_8_c_1930_n ) capacitor c=9.91639e-19 \
 //x=12.85 //y=4.97 //x2=13.07 //y2=4.41
cc_838 ( N_noxref_5_c_1042_n N_noxref_8_c_1932_n ) capacitor c=0.0018558f \
 //x=10.85 //y=5.295 //x2=13.07 //y2=5.055
cc_839 ( N_noxref_5_c_1085_n N_noxref_8_c_1932_n ) capacitor c=0.0309437f \
 //x=12.33 //y=4.76 //x2=13.07 //y2=5.055
cc_840 ( N_noxref_5_c_1168_p N_noxref_8_c_1932_n ) capacitor c=0.00383777f \
 //x=12.33 //y=4.88 //x2=13.07 //y2=5.055
cc_841 ( N_noxref_5_c_1153_p N_noxref_8_c_1932_n ) capacitor c=0.00208891f \
 //x=12.85 //y=4.97 //x2=13.07 //y2=5.055
cc_842 ( N_noxref_5_c_1170_p N_noxref_8_c_1932_n ) capacitor c=0.00140024f \
 //x=12.56 //y=4.97 //x2=13.07 //y2=5.055
cc_843 ( N_noxref_5_c_1061_n N_noxref_8_c_1937_n ) capacitor c=6.23317e-19 \
 //x=10.41 //y=1.75 //x2=12.7 //y2=1.185
cc_844 ( N_noxref_5_c_1092_n N_noxref_8_c_1937_n ) capacitor c=0.00596895f \
 //x=10.41 //y=1.18 //x2=12.7 //y2=1.185
cc_845 ( N_noxref_5_c_1173_p N_noxref_8_c_1937_n ) capacitor c=0.00175305f \
 //x=12.44 //y=1.09 //x2=12.7 //y2=1.185
cc_846 ( N_noxref_5_c_1138_p N_noxref_8_c_1937_n ) capacitor c=0.00354487f \
 //x=12.44 //y=1.435 //x2=12.7 //y2=1.185
cc_847 ( N_noxref_5_c_1175_p N_noxref_8_c_1937_n ) capacitor c=5.57924e-19 \
 //x=12.815 //y=0.935 //x2=12.7 //y2=1.185
cc_848 ( N_noxref_5_c_1141_p N_noxref_8_c_1937_n ) capacitor c=5.75878e-19 \
 //x=12.815 //y=1.59 //x2=12.7 //y2=1.185
cc_849 ( N_noxref_5_c_1177_p N_noxref_8_c_1937_n ) capacitor c=0.00148463f \
 //x=12.97 //y=1.09 //x2=12.7 //y2=1.185
cc_850 ( N_noxref_5_c_1142_p N_noxref_8_c_1937_n ) capacitor c=0.00349964f \
 //x=12.97 //y=1.435 //x2=12.7 //y2=1.185
cc_851 ( N_noxref_5_c_1085_n N_noxref_8_c_1901_n ) capacitor c=7.17e-19 \
 //x=12.33 //y=4.76 //x2=13.07 //y2=4.25
cc_852 ( N_noxref_5_c_1153_p N_noxref_8_c_1901_n ) capacitor c=2.84121e-19 \
 //x=12.85 //y=4.97 //x2=13.07 //y2=4.25
cc_853 ( N_noxref_5_c_1085_n N_noxref_8_c_1947_n ) capacitor c=0.00654092f \
 //x=12.33 //y=4.76 //x2=13.23 //y2=4.257
cc_854 ( N_noxref_5_M23_noxref_g N_noxref_8_c_1948_n ) capacitor c=0.0162066f \
 //x=12.485 //y=6.2 //x2=12.705 //y2=5.56
cc_855 ( N_noxref_5_M24_noxref_g N_noxref_8_c_1948_n ) capacitor c=0.0162066f \
 //x=12.925 //y=6.2 //x2=12.705 //y2=5.56
cc_856 ( N_noxref_5_c_1153_p N_noxref_8_c_1948_n ) capacitor c=0.00290963f \
 //x=12.85 //y=4.97 //x2=12.705 //y2=5.56
cc_857 ( N_noxref_5_c_1173_p N_noxref_8_M6_noxref_d ) capacitor c=0.00137914f \
 //x=12.44 //y=1.09 //x2=12.515 //y2=1.09
cc_858 ( N_noxref_5_c_1138_p N_noxref_8_M6_noxref_d ) capacitor c=0.0023891f \
 //x=12.44 //y=1.435 //x2=12.515 //y2=1.09
cc_859 ( N_noxref_5_c_1175_p N_noxref_8_M6_noxref_d ) capacitor c=0.0020782f \
 //x=12.815 //y=0.935 //x2=12.515 //y2=1.09
cc_860 ( N_noxref_5_c_1141_p N_noxref_8_M6_noxref_d ) capacitor c=0.00356097f \
 //x=12.815 //y=1.59 //x2=12.515 //y2=1.09
cc_861 ( N_noxref_5_c_1177_p N_noxref_8_M6_noxref_d ) capacitor c=0.00138452f \
 //x=12.97 //y=1.09 //x2=12.515 //y2=1.09
cc_862 ( N_noxref_5_c_1142_p N_noxref_8_M6_noxref_d ) capacitor c=0.00235934f \
 //x=12.97 //y=1.435 //x2=12.515 //y2=1.09
cc_863 ( N_noxref_5_c_1040_n N_VDD_c_2464_n ) capacitor c=0.00648267f \
 //x=10.255 //y=5.38 //x2=14.955 //y2=7.585
cc_864 ( N_noxref_5_c_1066_n N_VDD_c_2464_n ) capacitor c=0.00492584f \
 //x=10.765 //y=5.38 //x2=14.955 //y2=7.585
cc_865 ( N_noxref_5_c_1074_n N_VDD_c_2464_n ) capacitor c=4.58384e-19 \
 //x=10.85 //y=3.67 //x2=14.955 //y2=7.585
cc_866 ( N_noxref_5_c_1128_p N_VDD_c_2464_n ) capacitor c=2.66043e-19 \
 //x=12.33 //y=3.67 //x2=14.955 //y2=7.585
cc_867 ( N_noxref_5_c_1085_n N_VDD_c_2464_n ) capacitor c=5.73169e-19 \
 //x=12.33 //y=4.76 //x2=14.955 //y2=7.585
cc_868 ( N_noxref_5_c_1043_n N_VDD_c_2464_n ) capacitor c=0.00368834f //x=9.49 \
 //y=5.56 //x2=14.955 //y2=7.585
cc_869 ( N_noxref_5_c_1088_n N_VDD_c_2464_n ) capacitor c=8.42623e-19 \
 //x=10.37 //y=5.38 //x2=14.955 //y2=7.585
cc_870 ( N_noxref_5_c_1198_p N_VDD_c_2464_n ) capacitor c=0.00285853f \
 //x=10.37 //y=5.56 //x2=14.955 //y2=7.585
cc_871 ( N_noxref_5_c_1049_n N_VDD_c_2464_n ) capacitor c=0.00224881f //x=9.49 \
 //y=5.56 //x2=14.955 //y2=7.585
cc_872 ( N_noxref_5_c_1100_n N_VDD_c_2464_n ) capacitor c=0.00224881f \
 //x=10.37 //y=5.56 //x2=14.955 //y2=7.585
cc_873 ( N_noxref_5_c_1168_p N_VDD_c_2464_n ) capacitor c=3.40755e-19 \
 //x=12.33 //y=4.88 //x2=14.955 //y2=7.585
cc_874 ( N_noxref_5_c_1040_n N_VDD_c_2560_n ) capacitor c=0.00208087f \
 //x=10.255 //y=5.38 //x2=9.845 //y2=7.585
cc_875 ( N_noxref_5_c_1043_n N_VDD_c_2560_n ) capacitor c=9.41185e-19 //x=9.49 \
 //y=5.56 //x2=9.845 //y2=7.585
cc_876 ( N_noxref_5_c_1049_n N_VDD_c_2560_n ) capacitor c=0.0136705f //x=9.49 \
 //y=5.56 //x2=9.845 //y2=7.585
cc_877 ( N_noxref_5_c_1040_n N_VDD_c_2583_n ) capacitor c=0.00180737f \
 //x=10.255 //y=5.38 //x2=10.725 //y2=7.585
cc_878 ( N_noxref_5_c_1066_n N_VDD_c_2583_n ) capacitor c=0.00208087f \
 //x=10.765 //y=5.38 //x2=10.725 //y2=7.585
cc_879 ( N_noxref_5_c_1088_n N_VDD_c_2583_n ) capacitor c=4.23719e-19 \
 //x=10.37 //y=5.38 //x2=10.725 //y2=7.585
cc_880 ( N_noxref_5_c_1198_p N_VDD_c_2583_n ) capacitor c=5.77976e-19 \
 //x=10.37 //y=5.56 //x2=10.725 //y2=7.585
cc_881 ( N_noxref_5_c_1100_n N_VDD_c_2583_n ) capacitor c=0.0136705f //x=10.37 \
 //y=5.56 //x2=10.725 //y2=7.585
cc_882 ( N_noxref_5_c_1085_n N_VDD_c_2638_n ) capacitor c=5.48929e-19 \
 //x=12.33 //y=4.76 //x2=13.06 //y2=7.585
cc_883 ( N_noxref_5_M23_noxref_g N_VDD_c_2638_n ) capacitor c=0.00753931f \
 //x=12.485 //y=6.2 //x2=13.06 //y2=7.585
cc_884 ( N_noxref_5_M24_noxref_g N_VDD_c_2638_n ) capacitor c=0.00751326f \
 //x=12.925 //y=6.2 //x2=13.06 //y2=7.585
cc_885 ( N_noxref_5_c_1042_n N_VDD_c_2531_n ) capacitor c=0.00133592f \
 //x=10.85 //y=5.295 //x2=8.26 //y2=7.585
cc_886 ( N_noxref_5_c_1043_n N_VDD_c_2531_n ) capacitor c=5.11447e-19 //x=9.49 \
 //y=5.56 //x2=8.26 //y2=7.585
cc_887 ( N_noxref_5_c_1049_n N_VDD_c_2531_n ) capacitor c=0.0064135f //x=9.49 \
 //y=5.56 //x2=8.26 //y2=7.585
cc_888 ( N_noxref_5_c_1042_n N_VDD_c_2600_n ) capacitor c=0.0275588f //x=10.85 \
 //y=5.295 //x2=11.59 //y2=7.585
cc_889 ( N_noxref_5_c_1085_n N_VDD_c_2600_n ) capacitor c=0.0152189f //x=12.33 \
 //y=4.76 //x2=11.59 //y2=7.585
cc_890 ( N_noxref_5_c_1088_n N_VDD_c_2600_n ) capacitor c=0.002343f //x=10.37 \
 //y=5.38 //x2=11.59 //y2=7.585
cc_891 ( N_noxref_5_c_1198_p N_VDD_c_2600_n ) capacitor c=4.0348e-19 //x=10.37 \
 //y=5.56 //x2=11.59 //y2=7.585
cc_892 ( N_noxref_5_c_1100_n N_VDD_c_2600_n ) capacitor c=0.0101861f //x=10.37 \
 //y=5.56 //x2=11.59 //y2=7.585
cc_893 ( N_noxref_5_c_1168_p N_VDD_c_2600_n ) capacitor c=0.00795305f \
 //x=12.33 //y=4.88 //x2=11.59 //y2=7.585
cc_894 ( N_noxref_5_M23_noxref_g N_VDD_c_2600_n ) capacitor c=0.00713158f \
 //x=12.485 //y=6.2 //x2=11.59 //y2=7.585
cc_895 ( N_noxref_5_c_1170_p N_VDD_c_2600_n ) capacitor c=0.00799922f \
 //x=12.56 //y=4.97 //x2=11.59 //y2=7.585
cc_896 ( N_noxref_5_c_1168_p N_VDD_c_2652_n ) capacitor c=0.00241457f \
 //x=12.33 //y=4.88 //x2=13.81 //y2=7.585
cc_897 ( N_noxref_5_c_1153_p N_VDD_c_2652_n ) capacitor c=0.00809791f \
 //x=12.85 //y=4.97 //x2=13.81 //y2=7.585
cc_898 ( N_noxref_5_c_1043_n N_VDD_M18_noxref_d ) capacitor c=0.00114029f \
 //x=9.49 //y=5.56 //x2=7.45 //y2=5.2
cc_899 ( N_noxref_5_c_1043_n N_VDD_M19_noxref_s ) capacitor c=0.0604727f \
 //x=9.49 //y=5.56 //x2=8.915 //y2=5.2
cc_900 ( N_noxref_5_c_1088_n N_VDD_M19_noxref_s ) capacitor c=6.52457e-19 \
 //x=10.37 //y=5.38 //x2=8.915 //y2=5.2
cc_901 ( N_noxref_5_c_1049_n N_VDD_M19_noxref_s ) capacitor c=0.0887533f \
 //x=9.49 //y=5.56 //x2=8.915 //y2=5.2
cc_902 ( N_noxref_5_c_1040_n N_VDD_M20_noxref_d ) capacitor c=0.00734094f \
 //x=10.255 //y=5.38 //x2=9.785 //y2=5.2
cc_903 ( N_noxref_5_c_1043_n N_VDD_M20_noxref_d ) capacitor c=0.0043528f \
 //x=9.49 //y=5.56 //x2=9.785 //y2=5.2
cc_904 ( N_noxref_5_c_1198_p N_VDD_M20_noxref_d ) capacitor c=0.0043528f \
 //x=10.37 //y=5.56 //x2=9.785 //y2=5.2
cc_905 ( N_noxref_5_c_1049_n N_VDD_M20_noxref_d ) capacitor c=0.065554f \
 //x=9.49 //y=5.56 //x2=9.785 //y2=5.2
cc_906 ( N_noxref_5_c_1100_n N_VDD_M20_noxref_d ) capacitor c=0.065554f \
 //x=10.37 //y=5.56 //x2=9.785 //y2=5.2
cc_907 ( N_noxref_5_c_1066_n N_VDD_M22_noxref_d ) capacitor c=0.00934027f \
 //x=10.765 //y=5.38 //x2=10.665 //y2=5.2
cc_908 ( N_noxref_5_c_1198_p N_VDD_M22_noxref_d ) capacitor c=0.00921458f \
 //x=10.37 //y=5.56 //x2=10.665 //y2=5.2
cc_909 ( N_noxref_5_c_1098_n N_VDD_M22_noxref_d ) capacitor c=9.65951e-19 \
 //x=10.85 //y=3.51 //x2=10.665 //y2=5.2
cc_910 ( N_noxref_5_c_1100_n N_VDD_M22_noxref_d ) capacitor c=0.065554f \
 //x=10.37 //y=5.56 //x2=10.665 //y2=5.2
cc_911 ( N_noxref_5_c_1066_n N_VDD_M23_noxref_s ) capacitor c=0.00316782f \
 //x=10.765 //y=5.38 //x2=12.13 //y2=5.2
cc_912 ( N_noxref_5_c_1128_p N_VDD_M23_noxref_s ) capacitor c=0.00125909f \
 //x=12.33 //y=3.67 //x2=12.13 //y2=5.2
cc_913 ( N_noxref_5_c_1085_n N_VDD_M23_noxref_s ) capacitor c=0.021233f \
 //x=12.33 //y=4.76 //x2=12.13 //y2=5.2
cc_914 ( N_noxref_5_c_1088_n N_VDD_M23_noxref_s ) capacitor c=0.00460957f \
 //x=10.37 //y=5.38 //x2=12.13 //y2=5.2
cc_915 ( N_noxref_5_c_1198_p N_VDD_M23_noxref_s ) capacitor c=0.00135645f \
 //x=10.37 //y=5.56 //x2=12.13 //y2=5.2
cc_916 ( N_noxref_5_c_1168_p N_VDD_M23_noxref_s ) capacitor c=0.00986169f \
 //x=12.33 //y=4.88 //x2=12.13 //y2=5.2
cc_917 ( N_noxref_5_M23_noxref_g N_VDD_M23_noxref_s ) capacitor c=0.0573441f \
 //x=12.485 //y=6.2 //x2=12.13 //y2=5.2
cc_918 ( N_noxref_5_c_1170_p N_VDD_M23_noxref_s ) capacitor c=0.00524567f \
 //x=12.56 //y=4.97 //x2=12.13 //y2=5.2
cc_919 ( N_noxref_5_M24_noxref_g N_VDD_M24_noxref_d ) capacitor c=0.0572684f \
 //x=12.925 //y=6.2 //x2=13 //y2=5.2
cc_920 ( N_noxref_5_c_1067_n N_GND_c_2995_n ) capacitor c=0.00654514f \
 //x=10.765 //y=1.835 //x2=19.73 //y2=0.18
cc_921 ( N_noxref_5_c_1074_n N_GND_c_2995_n ) capacitor c=4.52555e-19 \
 //x=10.85 //y=3.67 //x2=19.73 //y2=0.18
cc_922 ( N_noxref_5_c_1128_p N_GND_c_2995_n ) capacitor c=4.40979e-19 \
 //x=12.33 //y=3.67 //x2=19.73 //y2=0.18
cc_923 ( N_noxref_5_c_1092_n N_GND_c_2995_n ) capacitor c=0.00964814f \
 //x=10.41 //y=1.18 //x2=19.73 //y2=0.18
cc_924 ( N_noxref_5_c_1160_p N_GND_c_2995_n ) capacitor c=0.00249122f \
 //x=12.33 //y=2.265 //x2=19.73 //y2=0.18
cc_925 ( N_noxref_5_c_1162_p N_GND_c_2995_n ) capacitor c=7.5371e-19 //x=12.33 \
 //y=2.265 //x2=19.73 //y2=0.18
cc_926 ( N_noxref_5_M5_noxref_d N_GND_c_2995_n ) capacitor c=3.01769e-19 \
 //x=10.22 //y=1.085 //x2=19.73 //y2=0.18
cc_927 ( N_noxref_5_c_1043_n N_GND_c_2959_n ) capacitor c=7.06452e-19 //x=9.49 \
 //y=5.56 //x2=9.44 //y2=1.135
cc_928 ( N_noxref_5_c_1092_n N_GND_c_2959_n ) capacitor c=0.0140211f //x=10.41 \
 //y=1.18 //x2=9.44 //y2=1.135
cc_929 ( N_noxref_5_M5_noxref_d N_GND_c_2959_n ) capacitor c=2.93544e-19 \
 //x=10.22 //y=1.085 //x2=9.44 //y2=1.135
cc_930 ( N_noxref_5_c_1067_n N_GND_c_2974_n ) capacitor c=7.75992e-19 \
 //x=10.765 //y=1.835 //x2=11.42 //y2=0.175
cc_931 ( N_noxref_5_c_1074_n N_GND_c_2974_n ) capacitor c=3.21306e-19 \
 //x=10.85 //y=3.67 //x2=11.42 //y2=0.175
cc_932 ( N_noxref_5_c_1160_p N_GND_c_3034_n ) capacitor c=0.00114179f \
 //x=12.33 //y=2.265 //x2=12.615 //y2=0.715
cc_933 ( N_noxref_5_c_1162_p N_GND_c_3034_n ) capacitor c=3.95714e-19 \
 //x=12.33 //y=2.265 //x2=12.615 //y2=0.715
cc_934 ( N_noxref_5_c_1173_p N_GND_c_3034_n ) capacitor c=0.0125444f //x=12.44 \
 //y=1.09 //x2=12.615 //y2=0.715
cc_935 ( N_noxref_5_c_1149_p N_GND_c_3034_n ) capacitor c=2.1838e-19 //x=12.33 \
 //y=2.265 //x2=12.615 //y2=0.715
cc_936 ( N_noxref_5_c_1177_p N_GND_c_3038_n ) capacitor c=0.0133145f //x=12.97 \
 //y=1.09 //x2=13.105 //y2=0.715
cc_937 ( N_noxref_5_c_1041_n N_GND_c_2944_n ) capacitor c=9.34543e-19 \
 //x=10.85 //y=3.35 //x2=8.26 //y2=0.175
cc_938 ( N_noxref_5_c_1061_n N_GND_c_3010_n ) capacitor c=0.00269515f \
 //x=10.41 //y=1.75 //x2=11.59 //y2=0.175
cc_939 ( N_noxref_5_c_1067_n N_GND_c_3010_n ) capacitor c=0.027102f //x=10.765 \
 //y=1.835 //x2=11.59 //y2=0.175
cc_940 ( N_noxref_5_c_1084_n N_GND_c_3010_n ) capacitor c=0.0103129f //x=12.33 \
 //y=3.35 //x2=11.59 //y2=0.175
cc_941 ( N_noxref_5_c_1160_p N_GND_c_3010_n ) capacitor c=0.00682461f \
 //x=12.33 //y=2.265 //x2=11.59 //y2=0.175
cc_942 ( N_noxref_5_c_1127_p N_GND_c_3010_n ) capacitor c=0.00560367f \
 //x=12.165 //y=3.51 //x2=11.59 //y2=0.175
cc_943 ( N_noxref_5_c_1162_p N_GND_c_3010_n ) capacitor c=0.00733236f \
 //x=12.33 //y=2.265 //x2=11.59 //y2=0.175
cc_944 ( N_noxref_5_c_1140_p N_GND_c_3010_n ) capacitor c=0.00427677f \
 //x=12.44 //y=2.1 //x2=11.59 //y2=0.175
cc_945 ( N_noxref_5_c_1149_p N_GND_c_3010_n ) capacitor c=0.00785621f \
 //x=12.33 //y=2.265 //x2=11.59 //y2=0.175
cc_946 ( N_noxref_5_c_1162_p N_GND_c_3048_n ) capacitor c=0.0022444f //x=12.33 \
 //y=2.265 //x2=13.81 //y2=0.175
cc_947 ( N_noxref_5_c_1149_p N_GND_c_3048_n ) capacitor c=2.63786e-19 \
 //x=12.33 //y=2.265 //x2=13.81 //y2=0.175
cc_948 ( N_noxref_5_c_1092_n N_GND_c_2905_n ) capacitor c=2.83275e-19 \
 //x=10.41 //y=1.18 //x2=19.73 //y2=0.18
cc_949 ( N_noxref_5_c_1092_n N_GND_M4_noxref_d ) capacitor c=2.82748e-19 \
 //x=10.41 //y=1.18 //x2=9.25 //y2=1.045
cc_950 ( N_noxref_5_c_1128_p N_GND_M6_noxref_s ) capacitor c=8.20337e-19 \
 //x=12.33 //y=3.67 //x2=12.085 //y2=0.55
cc_951 ( N_noxref_5_c_1160_p N_GND_M6_noxref_s ) capacitor c=0.00297876f \
 //x=12.33 //y=2.265 //x2=12.085 //y2=0.55
cc_952 ( N_noxref_5_c_1162_p N_GND_M6_noxref_s ) capacitor c=0.00651326f \
 //x=12.33 //y=2.265 //x2=12.085 //y2=0.55
cc_953 ( N_noxref_5_c_1173_p N_GND_M6_noxref_s ) capacitor c=0.0300873f \
 //x=12.44 //y=1.09 //x2=12.085 //y2=0.55
cc_954 ( N_noxref_5_c_1139_p N_GND_M6_noxref_s ) capacitor c=0.002132f \
 //x=12.44 //y=1.745 //x2=12.085 //y2=0.55
cc_955 ( N_noxref_5_c_1140_p N_GND_M6_noxref_s ) capacitor c=0.00304786f \
 //x=12.44 //y=2.1 //x2=12.085 //y2=0.55
cc_956 ( N_noxref_5_c_1175_p N_GND_M6_noxref_s ) capacitor c=0.00517463f \
 //x=12.815 //y=0.935 //x2=12.085 //y2=0.55
cc_957 ( N_noxref_5_c_1177_p N_GND_M6_noxref_s ) capacitor c=0.0153553f \
 //x=12.97 //y=1.09 //x2=12.085 //y2=0.55
cc_958 ( N_noxref_5_c_1142_p N_GND_M6_noxref_s ) capacitor c=0.00629878f \
 //x=12.97 //y=1.435 //x2=12.085 //y2=0.55
cc_959 ( N_noxref_5_c_1149_p N_GND_M6_noxref_s ) capacitor c=0.00405173f \
 //x=12.33 //y=2.265 //x2=12.085 //y2=0.55
cc_960 ( N_noxref_5_c_1120_p N_noxref_15_c_3535_n ) capacitor c=0.00900974f \
 //x=10.495 //y=1.835 //x2=9.925 //y2=1.675
cc_961 ( N_noxref_5_c_1067_n N_noxref_15_c_3543_n ) capacitor c=0.00373013f \
 //x=10.765 //y=1.835 //x2=10.81 //y2=0.71
cc_962 ( N_noxref_5_c_1092_n N_noxref_15_c_3543_n ) capacitor c=0.00367971f \
 //x=10.41 //y=1.18 //x2=10.81 //y2=0.71
cc_963 ( N_noxref_5_M5_noxref_d N_noxref_15_c_3543_n ) capacitor c=0.00910163f \
 //x=10.22 //y=1.085 //x2=10.81 //y2=0.71
cc_964 ( N_noxref_5_c_1061_n N_noxref_15_M4_noxref_s ) capacitor c=0.0156395f \
 //x=10.41 //y=1.75 //x2=8.82 //y2=0.545
cc_965 ( N_noxref_5_c_1067_n N_noxref_15_M4_noxref_s ) capacitor c=0.00640979f \
 //x=10.765 //y=1.835 //x2=8.82 //y2=0.545
cc_966 ( N_noxref_5_c_1074_n N_noxref_15_M4_noxref_s ) capacitor c=4.17069e-19 \
 //x=10.85 //y=3.67 //x2=8.82 //y2=0.545
cc_967 ( N_noxref_5_c_1092_n N_noxref_15_M4_noxref_s ) capacitor c=0.00896448f \
 //x=10.41 //y=1.18 //x2=8.82 //y2=0.545
cc_968 ( N_noxref_5_c_1098_n N_noxref_15_M4_noxref_s ) capacitor c=0.0010514f \
 //x=10.85 //y=3.51 //x2=8.82 //y2=0.545
cc_969 ( N_noxref_5_M5_noxref_d N_noxref_15_M4_noxref_s ) capacitor \
 c=0.0275552f //x=10.22 //y=1.085 //x2=8.82 //y2=0.545
cc_970 ( N_noxref_6_c_1385_n Q ) capacitor c=0.0032526f //x=14.92 //y=3.72 \
 //x2=16.4 //y2=2.4
cc_971 ( N_noxref_6_c_1386_n Q ) capacitor c=0.00346648f //x=14.92 //y=4.765 \
 //x2=16.4 //y2=4.62
cc_972 ( N_noxref_6_c_1407_p Q ) capacitor c=2.44646e-19 //x=14.765 //y=4.885 \
 //x2=16.4 //y2=4.62
cc_973 ( N_noxref_6_c_1408_p N_Q_c_1602_n ) capacitor c=0.00120004f //x=14.92 \
 //y=2.26 //x2=14.99 //y2=1.305
cc_974 ( N_noxref_6_c_1409_p N_Q_c_1602_n ) capacitor c=7.02188e-19 //x=14.92 \
 //y=2.26 //x2=14.99 //y2=1.305
cc_975 ( N_noxref_6_c_1410_p N_Q_c_1602_n ) capacitor c=6.03241e-19 //x=14.725 \
 //y=1.085 //x2=14.99 //y2=1.305
cc_976 ( N_noxref_6_c_1411_p N_Q_c_1602_n ) capacitor c=0.00325126f //x=14.725 \
 //y=1.43 //x2=14.99 //y2=1.305
cc_977 ( N_noxref_6_c_1412_p N_Q_c_1602_n ) capacitor c=5.29726e-19 //x=15.1 \
 //y=0.93 //x2=14.99 //y2=1.305
cc_978 ( N_noxref_6_c_1413_p N_Q_c_1602_n ) capacitor c=6.07114e-19 //x=15.1 \
 //y=1.585 //x2=14.99 //y2=1.305
cc_979 ( N_noxref_6_c_1414_p N_Q_c_1602_n ) capacitor c=5.57259e-19 //x=15.255 \
 //y=1.085 //x2=14.99 //y2=1.305
cc_980 ( N_noxref_6_c_1415_p N_Q_c_1602_n ) capacitor c=0.00212774f //x=15.255 \
 //y=1.43 //x2=14.99 //y2=1.305
cc_981 ( N_noxref_6_c_1411_p N_Q_c_1597_n ) capacitor c=0.00108322f //x=14.725 \
 //y=1.43 //x2=14.99 //y2=1.75
cc_982 ( N_noxref_6_c_1417_p N_Q_c_1597_n ) capacitor c=0.00312733f //x=14.725 \
 //y=1.74 //x2=14.99 //y2=1.75
cc_983 ( N_noxref_6_c_1418_p N_Q_c_1597_n ) capacitor c=0.00326244f //x=14.725 \
 //y=2.095 //x2=14.99 //y2=1.75
cc_984 ( N_noxref_6_c_1413_p N_Q_c_1597_n ) capacitor c=0.00672368f //x=15.1 \
 //y=1.585 //x2=14.99 //y2=1.75
cc_985 ( N_noxref_6_c_1415_p N_Q_c_1597_n ) capacitor c=0.00253555f //x=15.255 \
 //y=1.43 //x2=14.99 //y2=1.75
cc_986 ( N_noxref_6_c_1415_p N_Q_c_1615_n ) capacitor c=7.25274e-19 //x=15.255 \
 //y=1.43 //x2=15.875 //y2=1.835
cc_987 ( N_noxref_6_c_1422_p N_Q_c_1598_n ) capacitor c=6.06305e-19 //x=14.92 \
 //y=4.025 //x2=15.075 //y2=1.835
cc_988 ( N_noxref_6_c_1408_p N_Q_c_1598_n ) capacitor c=0.0166269f //x=14.92 \
 //y=2.26 //x2=15.075 //y2=1.835
cc_989 ( N_noxref_6_c_1403_n N_Q_c_1598_n ) capacitor c=4.25094e-19 //x=12.54 \
 //y=3.895 //x2=15.075 //y2=1.835
cc_990 ( N_noxref_6_c_1409_p N_Q_c_1598_n ) capacitor c=0.00293572f //x=14.92 \
 //y=2.26 //x2=15.075 //y2=1.835
cc_991 ( N_noxref_6_c_1418_p N_Q_c_1598_n ) capacitor c=0.00115959f //x=14.725 \
 //y=2.095 //x2=15.075 //y2=1.835
cc_992 ( N_noxref_6_c_1415_p N_Q_c_1621_n ) capacitor c=6.29838e-19 //x=15.255 \
 //y=1.43 //x2=15.96 //y2=1.75
cc_993 ( N_noxref_6_c_1408_p N_Q_M7_noxref_d ) capacitor c=7.18966e-19 \
 //x=14.92 //y=2.26 //x2=14.8 //y2=1.085
cc_994 ( N_noxref_6_c_1409_p N_Q_M7_noxref_d ) capacitor c=0.00132086f \
 //x=14.92 //y=2.26 //x2=14.8 //y2=1.085
cc_995 ( N_noxref_6_c_1410_p N_Q_M7_noxref_d ) capacitor c=0.00124139f \
 //x=14.725 //y=1.085 //x2=14.8 //y2=1.085
cc_996 ( N_noxref_6_c_1411_p N_Q_M7_noxref_d ) capacitor c=0.00237422f \
 //x=14.725 //y=1.43 //x2=14.8 //y2=1.085
cc_997 ( N_noxref_6_c_1418_p N_Q_M7_noxref_d ) capacitor c=4.64713e-19 \
 //x=14.725 //y=2.095 //x2=14.8 //y2=1.085
cc_998 ( N_noxref_6_c_1412_p N_Q_M7_noxref_d ) capacitor c=0.00213893f \
 //x=15.1 //y=0.93 //x2=14.8 //y2=1.085
cc_999 ( N_noxref_6_c_1413_p N_Q_M7_noxref_d ) capacitor c=0.00345753f \
 //x=15.1 //y=1.585 //x2=14.8 //y2=1.085
cc_1000 ( N_noxref_6_c_1414_p N_Q_M7_noxref_d ) capacitor c=0.00211919f \
 //x=15.255 //y=1.085 //x2=14.8 //y2=1.085
cc_1001 ( N_noxref_6_c_1415_p N_Q_M7_noxref_d ) capacitor c=0.00237422f \
 //x=15.255 //y=1.43 //x2=14.8 //y2=1.085
cc_1002 ( N_noxref_6_c_1403_n N_noxref_8_c_1909_n ) capacitor c=5.77131e-19 \
 //x=12.54 //y=3.895 //x2=12.705 //y2=5.42
cc_1003 ( N_noxref_6_c_1403_n N_noxref_8_c_1914_n ) capacitor c=0.0053272f \
 //x=12.54 //y=3.895 //x2=12.785 //y2=2.02
cc_1004 ( N_noxref_6_c_1403_n N_noxref_8_c_1917_n ) capacitor c=0.00798755f \
 //x=12.54 //y=3.895 //x2=12.79 //y2=5.14
cc_1005 ( N_noxref_6_c_1385_n N_noxref_8_c_1920_n ) capacitor c=0.0234755f \
 //x=14.92 //y=3.72 //x2=13.07 //y2=4.105
cc_1006 ( N_noxref_6_c_1422_p N_noxref_8_c_1920_n ) capacitor c=0.00238767f \
 //x=14.92 //y=4.025 //x2=13.07 //y2=4.105
cc_1007 ( N_noxref_6_c_1386_n N_noxref_8_c_1920_n ) capacitor c=0.00129137f \
 //x=14.92 //y=4.765 //x2=13.07 //y2=4.105
cc_1008 ( N_noxref_6_c_1408_p N_noxref_8_c_1920_n ) capacitor c=0.00473642f \
 //x=14.92 //y=2.26 //x2=13.07 //y2=4.105
cc_1009 ( N_noxref_6_c_1403_n N_noxref_8_c_1920_n ) capacitor c=0.0307525f \
 //x=12.54 //y=3.895 //x2=13.07 //y2=4.105
cc_1010 ( N_noxref_6_c_1386_n N_noxref_8_c_1930_n ) capacitor c=0.00236599f \
 //x=14.92 //y=4.765 //x2=13.07 //y2=4.41
cc_1011 ( N_noxref_6_c_1403_n N_noxref_8_c_1930_n ) capacitor c=0.00759261f \
 //x=12.54 //y=3.895 //x2=13.07 //y2=4.41
cc_1012 ( N_noxref_6_c_1386_n N_noxref_8_c_1932_n ) capacitor c=0.00546816f \
 //x=14.92 //y=4.765 //x2=13.07 //y2=5.055
cc_1013 ( N_noxref_6_c_1448_p N_noxref_8_c_1932_n ) capacitor c=0.00642329f \
 //x=14.765 //y=4.885 //x2=13.07 //y2=5.055
cc_1014 ( N_noxref_6_c_1386_n N_noxref_8_c_1947_n ) capacitor c=0.00142272f \
 //x=14.92 //y=4.765 //x2=13.23 //y2=4.257
cc_1015 ( N_noxref_6_c_1403_n N_noxref_8_c_1947_n ) capacitor c=0.0374339f \
 //x=12.54 //y=3.895 //x2=13.23 //y2=4.257
cc_1016 ( N_noxref_6_c_1422_p N_noxref_8_c_1971_n ) capacitor c=0.00512312f \
 //x=14.92 //y=4.025 //x2=18.83 //y2=4.257
cc_1017 ( N_noxref_6_c_1386_n N_noxref_8_c_1971_n ) capacitor c=0.0262234f \
 //x=14.92 //y=4.765 //x2=18.83 //y2=4.257
cc_1018 ( N_noxref_6_c_1448_p N_noxref_8_c_1971_n ) capacitor c=0.00890565f \
 //x=14.765 //y=4.885 //x2=18.83 //y2=4.257
cc_1019 ( N_noxref_6_c_1403_n N_noxref_8_c_1971_n ) capacitor c=0.182677f \
 //x=12.54 //y=3.895 //x2=18.83 //y2=4.257
cc_1020 ( N_noxref_6_c_1407_p N_noxref_8_c_1971_n ) capacitor c=0.00460112f \
 //x=14.765 //y=4.885 //x2=18.83 //y2=4.257
cc_1021 ( N_noxref_6_c_1385_n N_noxref_9_c_2181_n ) capacitor c=0.0579544f \
 //x=14.92 //y=3.72 //x2=15.66 //y2=3.72
cc_1022 ( N_noxref_6_c_1409_p N_noxref_9_c_2181_n ) capacitor c=2.61947e-19 \
 //x=14.92 //y=2.26 //x2=15.66 //y2=3.72
cc_1023 ( N_noxref_6_c_1422_p N_noxref_9_c_2183_n ) capacitor c=0.0208555f \
 //x=14.92 //y=4.025 //x2=15.66 //y2=4.025
cc_1024 ( N_noxref_6_c_1459_p N_noxref_9_c_2183_n ) capacitor c=5.9727e-19 \
 //x=14.92 //y=3.88 //x2=15.66 //y2=4.025
cc_1025 ( N_noxref_6_c_1403_n N_noxref_9_c_2183_n ) capacitor c=0.00309276f \
 //x=12.54 //y=3.895 //x2=15.66 //y2=4.025
cc_1026 ( N_noxref_6_c_1408_p N_noxref_9_c_2186_n ) capacitor c=0.0217252f \
 //x=14.92 //y=2.26 //x2=15.66 //y2=2.26
cc_1027 ( N_noxref_6_c_1409_p N_noxref_9_c_2186_n ) capacitor c=5.41079e-19 \
 //x=14.92 //y=2.26 //x2=15.66 //y2=2.26
cc_1028 ( N_noxref_6_c_1418_p N_noxref_9_c_2186_n ) capacitor c=0.00178181f \
 //x=14.725 //y=2.095 //x2=15.66 //y2=2.26
cc_1029 ( N_noxref_6_c_1448_p N_noxref_9_c_2189_n ) capacitor c=0.0208224f \
 //x=14.765 //y=4.885 //x2=15.695 //y2=4.885
cc_1030 ( N_noxref_6_c_1407_p N_noxref_9_c_2189_n ) capacitor c=0.00105182f \
 //x=14.765 //y=4.885 //x2=15.695 //y2=4.885
cc_1031 ( N_noxref_6_c_1466_p N_noxref_9_c_2189_n ) capacitor c=0.00107587f \
 //x=15.185 //y=4.975 //x2=15.695 //y2=4.885
cc_1032 ( N_noxref_6_c_1386_n N_noxref_9_c_2192_n ) capacitor c=0.0196037f \
 //x=14.92 //y=4.765 //x2=15.695 //y2=4.74
cc_1033 ( N_noxref_6_c_1422_p N_noxref_9_c_2193_n ) capacitor c=5.9727e-19 \
 //x=14.92 //y=4.025 //x2=15.66 //y2=3.88
cc_1034 ( N_noxref_6_c_1459_p N_noxref_9_c_2193_n ) capacitor c=0.0101825f \
 //x=14.92 //y=3.88 //x2=15.66 //y2=3.88
cc_1035 ( N_noxref_6_c_1422_p N_noxref_9_c_2195_n ) capacitor c=0.00309294f \
 //x=14.92 //y=4.025 //x2=15.82 //y2=3.872
cc_1036 ( N_noxref_6_c_1403_n N_noxref_9_c_2195_n ) capacitor c=0.0230391f \
 //x=12.54 //y=3.895 //x2=15.82 //y2=3.872
cc_1037 ( N_noxref_6_c_1385_n N_noxref_9_c_2197_n ) capacitor c=2.61947e-19 \
 //x=14.92 //y=3.72 //x2=15.66 //y2=2.26
cc_1038 ( N_noxref_6_c_1408_p N_noxref_9_c_2197_n ) capacitor c=5.24865e-19 \
 //x=14.92 //y=2.26 //x2=15.66 //y2=2.26
cc_1039 ( N_noxref_6_c_1409_p N_noxref_9_c_2197_n ) capacitor c=0.00525888f \
 //x=14.92 //y=2.26 //x2=15.66 //y2=2.26
cc_1040 ( N_noxref_6_c_1418_p N_noxref_9_c_2197_n ) capacitor c=0.00190888f \
 //x=14.725 //y=2.095 //x2=15.66 //y2=2.26
cc_1041 ( N_noxref_6_c_1448_p N_noxref_9_c_2201_n ) capacitor c=4.32488e-19 \
 //x=14.765 //y=4.885 //x2=15.695 //y2=4.885
cc_1042 ( N_noxref_6_c_1407_p N_noxref_9_c_2201_n ) capacitor c=0.00242589f \
 //x=14.765 //y=4.885 //x2=15.695 //y2=4.885
cc_1043 ( N_noxref_6_c_1466_p N_noxref_9_c_2201_n ) capacitor c=0.00116837f \
 //x=15.185 //y=4.975 //x2=15.695 //y2=4.885
cc_1044 ( N_noxref_6_c_1479_p N_noxref_9_c_2201_n ) capacitor c=0.00121814f \
 //x=14.765 //y=4.885 //x2=15.695 //y2=4.885
cc_1045 ( N_noxref_6_M25_noxref_g N_noxref_9_M27_noxref_g ) capacitor \
 c=0.0101077f //x=14.82 //y=6.205 //x2=15.7 //y2=6.205
cc_1046 ( N_noxref_6_M26_noxref_g N_noxref_9_M27_noxref_g ) capacitor \
 c=0.109254f //x=15.26 //y=6.205 //x2=15.7 //y2=6.205
cc_1047 ( N_noxref_6_M26_noxref_g N_noxref_9_M28_noxref_g ) capacitor \
 c=0.00945018f //x=15.26 //y=6.205 //x2=16.14 //y2=6.205
cc_1048 ( N_noxref_6_c_1410_p N_noxref_9_c_2208_n ) capacitor c=0.00125788f \
 //x=14.725 //y=1.085 //x2=15.695 //y2=1.085
cc_1049 ( N_noxref_6_c_1414_p N_noxref_9_c_2208_n ) capacitor c=0.0126654f \
 //x=15.255 //y=1.085 //x2=15.695 //y2=1.085
cc_1050 ( N_noxref_6_c_1411_p N_noxref_9_c_2210_n ) capacitor c=0.00149727f \
 //x=14.725 //y=1.43 //x2=15.695 //y2=1.435
cc_1051 ( N_noxref_6_c_1417_p N_noxref_9_c_2210_n ) capacitor c=0.00111802f \
 //x=14.725 //y=1.74 //x2=15.695 //y2=1.435
cc_1052 ( N_noxref_6_c_1415_p N_noxref_9_c_2210_n ) capacitor c=0.0126654f \
 //x=15.255 //y=1.43 //x2=15.695 //y2=1.435
cc_1053 ( N_noxref_6_c_1417_p N_noxref_9_c_2213_n ) capacitor c=0.00116305f \
 //x=14.725 //y=1.74 //x2=15.695 //y2=1.74
cc_1054 ( N_noxref_6_c_1415_p N_noxref_9_c_2213_n ) capacitor c=0.00938322f \
 //x=15.255 //y=1.43 //x2=15.695 //y2=1.74
cc_1055 ( N_noxref_6_c_1415_p N_noxref_9_c_2215_n ) capacitor c=0.00131492f \
 //x=15.255 //y=1.43 //x2=16.07 //y2=1.585
cc_1056 ( N_noxref_6_c_1414_p N_noxref_9_c_2216_n ) capacitor c=0.00132934f \
 //x=15.255 //y=1.085 //x2=16.225 //y2=1.085
cc_1057 ( N_noxref_6_c_1415_p N_noxref_9_c_2217_n ) capacitor c=0.00151998f \
 //x=15.255 //y=1.43 //x2=16.225 //y2=1.435
cc_1058 ( N_noxref_6_c_1408_p N_noxref_9_c_2218_n ) capacitor c=0.00173144f \
 //x=14.92 //y=2.26 //x2=15.66 //y2=2.26
cc_1059 ( N_noxref_6_c_1409_p N_noxref_9_c_2218_n ) capacitor c=0.0018937f \
 //x=14.92 //y=2.26 //x2=15.66 //y2=2.26
cc_1060 ( N_noxref_6_c_1418_p N_noxref_9_c_2218_n ) capacitor c=0.0181449f \
 //x=14.725 //y=2.095 //x2=15.66 //y2=2.26
cc_1061 ( N_noxref_6_c_1418_p N_noxref_9_c_2221_n ) capacitor c=0.00636965f \
 //x=14.725 //y=2.095 //x2=15.66 //y2=2.095
cc_1062 ( N_noxref_6_c_1386_n N_noxref_9_c_2222_n ) capacitor c=0.00117265f \
 //x=14.92 //y=4.765 //x2=15.695 //y2=4.885
cc_1063 ( N_noxref_6_c_1448_p N_noxref_9_c_2222_n ) capacitor c=4.8456e-19 \
 //x=14.765 //y=4.885 //x2=15.695 //y2=4.885
cc_1064 ( N_noxref_6_c_1407_p N_noxref_9_c_2222_n ) capacitor c=0.00211373f \
 //x=14.765 //y=4.885 //x2=15.695 //y2=4.885
cc_1065 ( N_noxref_6_c_1466_p N_noxref_9_c_2222_n ) capacitor c=0.0203928f \
 //x=15.185 //y=4.975 //x2=15.695 //y2=4.885
cc_1066 ( N_noxref_6_c_1479_p N_noxref_9_c_2222_n ) capacitor c=0.00590438f \
 //x=14.765 //y=4.885 //x2=15.695 //y2=4.885
cc_1067 ( N_noxref_6_c_1305_n N_VDD_c_2464_n ) capacitor c=0.00259721f \
 //x=7.155 //y=5.42 //x2=14.955 //y2=7.585
cc_1068 ( N_noxref_6_c_1312_n N_VDD_c_2464_n ) capacitor c=0.00266633f \
 //x=7.435 //y=5.14 //x2=14.955 //y2=7.585
cc_1069 ( N_noxref_6_c_1342_n N_VDD_c_2464_n ) capacitor c=0.00241566f \
 //x=7.155 //y=5.56 //x2=14.955 //y2=7.585
cc_1070 ( N_noxref_6_M25_noxref_g N_VDD_c_2679_n ) capacitor c=0.00122608f \
 //x=14.82 //y=6.205 //x2=15.04 //y2=7.035
cc_1071 ( N_noxref_6_M26_noxref_g N_VDD_c_2679_n ) capacitor c=0.00122608f \
 //x=15.26 //y=6.205 //x2=15.04 //y2=7.035
cc_1072 ( N_noxref_6_M25_noxref_g N_VDD_c_2681_n ) capacitor c=0.00205385f \
 //x=14.82 //y=6.205 //x2=15.04 //y2=7.41
cc_1073 ( N_noxref_6_M26_noxref_g N_VDD_c_2681_n ) capacitor c=0.00282432f \
 //x=15.26 //y=6.205 //x2=15.04 //y2=7.41
cc_1074 ( N_noxref_6_c_1305_n N_VDD_c_2517_n ) capacitor c=8.96756e-19 \
 //x=7.155 //y=5.42 //x2=7.51 //y2=7.585
cc_1075 ( N_noxref_6_c_1312_n N_VDD_c_2517_n ) capacitor c=0.00197507f \
 //x=7.435 //y=5.14 //x2=7.51 //y2=7.585
cc_1076 ( N_noxref_6_c_1342_n N_VDD_c_2517_n ) capacitor c=0.0138017f \
 //x=7.155 //y=5.56 //x2=7.51 //y2=7.585
cc_1077 ( N_noxref_6_M25_noxref_g N_VDD_c_2686_n ) capacitor c=0.00720181f \
 //x=14.82 //y=6.205 //x2=16.97 //y2=7.585
cc_1078 ( N_noxref_6_M26_noxref_g N_VDD_c_2686_n ) capacitor c=0.00778439f \
 //x=15.26 //y=6.205 //x2=16.97 //y2=7.585
cc_1079 ( N_noxref_6_c_1313_n N_VDD_c_2523_n ) capacitor c=0.00464635f \
 //x=7.24 //y=5.14 //x2=6.04 //y2=7.585
cc_1080 ( N_noxref_6_c_1342_n N_VDD_c_2523_n ) capacitor c=0.00821397f \
 //x=7.155 //y=5.56 //x2=6.04 //y2=7.585
cc_1081 ( N_noxref_6_c_1305_n N_VDD_c_2531_n ) capacitor c=0.00231872f \
 //x=7.155 //y=5.42 //x2=8.26 //y2=7.585
cc_1082 ( N_noxref_6_c_1327_n N_VDD_c_2531_n ) capacitor c=0.0221274f //x=7.52 \
 //y=5.055 //x2=8.26 //y2=7.585
cc_1083 ( N_noxref_6_c_1342_n N_VDD_c_2531_n ) capacitor c=0.00824308f \
 //x=7.155 //y=5.56 //x2=8.26 //y2=7.585
cc_1084 ( N_noxref_6_c_1399_n N_VDD_c_2600_n ) capacitor c=0.00643448f \
 //x=11.94 //y=3.88 //x2=11.59 //y2=7.585
cc_1085 ( N_noxref_6_c_1386_n N_VDD_c_2652_n ) capacitor c=0.00690473f \
 //x=14.92 //y=4.765 //x2=13.81 //y2=7.585
cc_1086 ( N_noxref_6_c_1448_p N_VDD_c_2652_n ) capacitor c=0.00344941f \
 //x=14.765 //y=4.885 //x2=13.81 //y2=7.585
cc_1087 ( N_noxref_6_c_1403_n N_VDD_c_2652_n ) capacitor c=0.00271717f \
 //x=12.54 //y=3.895 //x2=13.81 //y2=7.585
cc_1088 ( N_noxref_6_c_1407_p N_VDD_c_2652_n ) capacitor c=0.00643194f \
 //x=14.765 //y=4.885 //x2=13.81 //y2=7.585
cc_1089 ( N_noxref_6_M25_noxref_g N_VDD_c_2652_n ) capacitor c=0.00817584f \
 //x=14.82 //y=6.205 //x2=13.81 //y2=7.585
cc_1090 ( N_noxref_6_c_1479_p N_VDD_c_2652_n ) capacitor c=0.00438848f \
 //x=14.765 //y=4.885 //x2=13.81 //y2=7.585
cc_1091 ( N_noxref_6_c_1407_p N_VDD_c_2700_n ) capacitor c=3.49022e-19 \
 //x=14.765 //y=4.885 //x2=17.14 //y2=7.585
cc_1092 ( N_noxref_6_c_1305_n N_VDD_M13_noxref_s ) capacitor c=2.62188e-19 \
 //x=7.155 //y=5.42 //x2=3.365 //y2=5.2
cc_1093 ( N_noxref_6_c_1305_n N_VDD_M17_noxref_s ) capacitor c=0.0465774f \
 //x=7.155 //y=5.42 //x2=6.58 //y2=5.2
cc_1094 ( N_noxref_6_c_1342_n N_VDD_M17_noxref_s ) capacitor c=0.0899011f \
 //x=7.155 //y=5.56 //x2=6.58 //y2=5.2
cc_1095 ( N_noxref_6_c_1305_n N_VDD_M18_noxref_d ) capacitor c=0.0474638f \
 //x=7.155 //y=5.42 //x2=7.45 //y2=5.2
cc_1096 ( N_noxref_6_c_1312_n N_VDD_M18_noxref_d ) capacitor c=0.0210992f \
 //x=7.435 //y=5.14 //x2=7.45 //y2=5.2
cc_1097 ( N_noxref_6_c_1325_n N_VDD_M18_noxref_d ) capacitor c=0.00306621f \
 //x=7.52 //y=4.025 //x2=7.45 //y2=5.2
cc_1098 ( N_noxref_6_c_1340_n N_VDD_M18_noxref_d ) capacitor c=5.54681e-19 \
 //x=7.52 //y=3.88 //x2=7.45 //y2=5.2
cc_1099 ( N_noxref_6_c_1342_n N_VDD_M18_noxref_d ) capacitor c=0.0907f \
 //x=7.155 //y=5.56 //x2=7.45 //y2=5.2
cc_1100 ( N_noxref_6_c_1305_n N_VDD_M19_noxref_s ) capacitor c=0.00151378f \
 //x=7.155 //y=5.42 //x2=8.915 //y2=5.2
cc_1101 ( N_noxref_6_c_1399_n N_VDD_M23_noxref_s ) capacitor c=9.1968e-19 \
 //x=11.94 //y=3.88 //x2=12.13 //y2=5.2
cc_1102 ( N_noxref_6_c_1459_p N_VDD_M25_noxref_d ) capacitor c=6.32902e-19 \
 //x=14.92 //y=3.88 //x2=14.895 //y2=5.205
cc_1103 ( N_noxref_6_M25_noxref_g N_VDD_M25_noxref_d ) capacitor c=0.0130453f \
 //x=14.82 //y=6.205 //x2=14.895 //y2=5.205
cc_1104 ( N_noxref_6_M26_noxref_g N_VDD_M25_noxref_d ) capacitor c=0.0142727f \
 //x=15.26 //y=6.205 //x2=14.895 //y2=5.205
cc_1105 ( N_noxref_6_c_1466_p N_VDD_M25_noxref_d ) capacitor c=0.00237147f \
 //x=15.185 //y=4.975 //x2=14.895 //y2=5.205
cc_1106 ( N_noxref_6_c_1309_n N_GND_c_2919_n ) capacitor c=0.00499609f \
 //x=7.435 //y=2.02 //x2=9.355 //y2=0.175
cc_1107 ( N_noxref_6_c_1325_n N_GND_c_2919_n ) capacitor c=4.77314e-19 \
 //x=7.52 //y=4.025 //x2=9.355 //y2=0.175
cc_1108 ( N_noxref_6_c_1332_n N_GND_c_2919_n ) capacitor c=0.00998676f \
 //x=7.15 //y=1.185 //x2=9.355 //y2=0.175
cc_1109 ( N_noxref_6_M3_noxref_d N_GND_c_2919_n ) capacitor c=0.00119455f \
 //x=6.965 //y=1.09 //x2=9.355 //y2=0.175
cc_1110 ( N_noxref_6_c_1422_p N_GND_c_2995_n ) capacitor c=2.23491e-19 \
 //x=14.92 //y=4.025 //x2=19.73 //y2=0.18
cc_1111 ( N_noxref_6_c_1408_p N_GND_c_2995_n ) capacitor c=8.84449e-19 \
 //x=14.92 //y=2.26 //x2=19.73 //y2=0.18
cc_1112 ( N_noxref_6_c_1332_n N_GND_c_2959_n ) capacitor c=0.00522864f \
 //x=7.15 //y=1.185 //x2=9.44 //y2=1.135
cc_1113 ( N_noxref_6_c_1332_n N_GND_c_2931_n ) capacitor c=0.00124813f \
 //x=7.15 //y=1.185 //x2=7.065 //y2=0.715
cc_1114 ( N_noxref_6_c_1309_n N_GND_c_2935_n ) capacitor c=0.00319441f \
 //x=7.435 //y=2.02 //x2=7.555 //y2=0.715
cc_1115 ( N_noxref_6_c_1332_n N_GND_c_2935_n ) capacitor c=0.00130539f \
 //x=7.15 //y=1.185 //x2=7.555 //y2=0.715
cc_1116 ( N_noxref_6_c_1340_n N_GND_c_2935_n ) capacitor c=2.41704e-19 \
 //x=7.52 //y=3.88 //x2=7.555 //y2=0.715
cc_1117 ( N_noxref_6_c_1422_p N_GND_c_3073_n ) capacitor c=3.16669e-19 \
 //x=14.92 //y=4.025 //x2=15.39 //y2=0.71
cc_1118 ( N_noxref_6_c_1408_p N_GND_c_3073_n ) capacitor c=0.0010437f \
 //x=14.92 //y=2.26 //x2=15.39 //y2=0.71
cc_1119 ( N_noxref_6_c_1409_p N_GND_c_3073_n ) capacitor c=4.19728e-19 \
 //x=14.92 //y=2.26 //x2=15.39 //y2=0.71
cc_1120 ( N_noxref_6_c_1410_p N_GND_c_3073_n ) capacitor c=0.0211652f \
 //x=14.725 //y=1.085 //x2=15.39 //y2=0.71
cc_1121 ( N_noxref_6_c_1418_p N_GND_c_3073_n ) capacitor c=2.1838e-19 \
 //x=14.725 //y=2.095 //x2=15.39 //y2=0.71
cc_1122 ( N_noxref_6_c_1414_p N_GND_c_3073_n ) capacitor c=0.00805599f \
 //x=15.255 //y=1.085 //x2=15.39 //y2=0.71
cc_1123 ( N_noxref_6_c_1298_n N_GND_c_2937_n ) capacitor c=0.00272952f \
 //x=7.15 //y=1.935 //x2=6.04 //y2=0.175
cc_1124 ( N_noxref_6_c_1309_n N_GND_c_2944_n ) capacitor c=0.0230294f \
 //x=7.435 //y=2.02 //x2=8.26 //y2=0.175
cc_1125 ( N_noxref_6_c_1385_n N_GND_c_3048_n ) capacitor c=0.00821798f \
 //x=14.92 //y=3.72 //x2=13.81 //y2=0.175
cc_1126 ( N_noxref_6_c_1408_p N_GND_c_3048_n ) capacitor c=0.00446799f \
 //x=14.92 //y=2.26 //x2=13.81 //y2=0.175
cc_1127 ( N_noxref_6_c_1403_n N_GND_c_3048_n ) capacitor c=0.00440673f \
 //x=12.54 //y=3.895 //x2=13.81 //y2=0.175
cc_1128 ( N_noxref_6_c_1409_p N_GND_c_3048_n ) capacitor c=0.00369203f \
 //x=14.92 //y=2.26 //x2=13.81 //y2=0.175
cc_1129 ( N_noxref_6_c_1418_p N_GND_c_3048_n ) capacitor c=0.00932032f \
 //x=14.725 //y=2.095 //x2=13.81 //y2=0.175
cc_1130 ( N_noxref_6_c_1332_n N_GND_c_2905_n ) capacitor c=2.8029e-19 //x=7.15 \
 //y=1.185 //x2=19.73 //y2=0.18
cc_1131 ( N_noxref_6_c_1298_n N_GND_M3_noxref_s ) capacitor c=0.0298527f \
 //x=7.15 //y=1.935 //x2=6.535 //y2=0.55
cc_1132 ( N_noxref_6_c_1309_n N_GND_M3_noxref_s ) capacitor c=0.00407415f \
 //x=7.435 //y=2.02 //x2=6.535 //y2=0.55
cc_1133 ( N_noxref_6_c_1325_n N_GND_M3_noxref_s ) capacitor c=0.00105284f \
 //x=7.52 //y=4.025 //x2=6.535 //y2=0.55
cc_1134 ( N_noxref_6_c_1332_n N_GND_M3_noxref_s ) capacitor c=0.0140692f \
 //x=7.15 //y=1.185 //x2=6.535 //y2=0.55
cc_1135 ( N_noxref_6_c_1340_n N_GND_M3_noxref_s ) capacitor c=5.90702e-19 \
 //x=7.52 //y=3.88 //x2=6.535 //y2=0.55
cc_1136 ( N_noxref_6_M3_noxref_d N_GND_M3_noxref_s ) capacitor c=0.0377642f \
 //x=6.965 //y=1.09 //x2=6.535 //y2=0.55
cc_1137 ( N_noxref_6_c_1403_n N_GND_M6_noxref_s ) capacitor c=0.00135574f \
 //x=12.54 //y=3.895 //x2=12.085 //y2=0.55
cc_1138 ( N_noxref_6_c_1403_n N_GND_M7_noxref_s ) capacitor c=0.00215337f \
 //x=12.54 //y=3.895 //x2=14.37 //y2=0.545
cc_1139 ( N_noxref_6_c_1410_p N_GND_M7_noxref_s ) capacitor c=0.0329097f \
 //x=14.725 //y=1.085 //x2=14.37 //y2=0.545
cc_1140 ( N_noxref_6_c_1414_p N_GND_M7_noxref_s ) capacitor c=0.00605785f \
 //x=15.255 //y=1.085 //x2=14.37 //y2=0.545
cc_1141 ( N_noxref_6_c_1415_p N_GND_M7_noxref_s ) capacitor c=0.00120103f \
 //x=15.255 //y=1.43 //x2=14.37 //y2=0.545
cc_1142 ( N_noxref_6_c_1422_p N_noxref_12_c_3273_n ) capacitor c=9.70303e-19 \
 //x=14.92 //y=4.025 //x2=15.36 //y2=5.39
cc_1143 ( N_noxref_6_c_1448_p N_noxref_12_c_3273_n ) capacitor c=0.00749854f \
 //x=14.765 //y=4.885 //x2=15.36 //y2=5.39
cc_1144 ( N_noxref_6_c_1407_p N_noxref_12_c_3273_n ) capacitor c=0.00104675f \
 //x=14.765 //y=4.885 //x2=15.36 //y2=5.39
cc_1145 ( N_noxref_6_M25_noxref_g N_noxref_12_c_3273_n ) capacitor c=0.009911f \
 //x=14.82 //y=6.205 //x2=15.36 //y2=5.39
cc_1146 ( N_noxref_6_M26_noxref_g N_noxref_12_c_3273_n ) capacitor \
 c=0.00982237f //x=15.26 //y=6.205 //x2=15.36 //y2=5.39
cc_1147 ( N_noxref_6_c_1466_p N_noxref_12_c_3273_n ) capacitor c=0.00170064f \
 //x=15.185 //y=4.975 //x2=15.36 //y2=5.39
cc_1148 ( N_noxref_6_c_1448_p N_noxref_12_c_3279_n ) capacitor c=0.0239616f \
 //x=14.765 //y=4.885 //x2=14.6 //y2=5.39
cc_1149 ( N_noxref_6_c_1407_p N_noxref_12_c_3279_n ) capacitor c=0.00565356f \
 //x=14.765 //y=4.885 //x2=14.6 //y2=5.39
cc_1150 ( N_noxref_6_M25_noxref_g N_noxref_12_c_3279_n ) capacitor \
 c=0.00403872f //x=14.82 //y=6.205 //x2=14.6 //y2=5.39
cc_1151 ( N_noxref_6_c_1479_p N_noxref_12_c_3279_n ) capacitor c=9.12041e-19 \
 //x=14.765 //y=4.885 //x2=14.6 //y2=5.39
cc_1152 ( N_noxref_6_M26_noxref_g N_noxref_12_c_3283_n ) capacitor \
 c=0.0018094f //x=15.26 //y=6.205 //x2=15.48 //y2=5.39
cc_1153 ( N_noxref_6_M26_noxref_g N_noxref_12_c_3284_n ) capacitor \
 c=0.00180782f //x=15.26 //y=6.205 //x2=15.48 //y2=6.92
cc_1154 ( N_noxref_6_c_1448_p N_noxref_12_c_3285_n ) capacitor c=0.00154424f \
 //x=14.765 //y=4.885 //x2=14.6 //y2=5.56
cc_1155 ( N_noxref_6_c_1407_p N_noxref_12_c_3285_n ) capacitor c=0.00126834f \
 //x=14.765 //y=4.885 //x2=14.6 //y2=5.56
cc_1156 ( N_noxref_6_M25_noxref_g N_noxref_12_c_3285_n ) capacitor \
 c=0.0483843f //x=14.82 //y=6.205 //x2=14.6 //y2=5.56
cc_1157 ( N_noxref_6_c_1479_p N_noxref_12_c_3285_n ) capacitor c=0.00297041f \
 //x=14.765 //y=4.885 //x2=14.6 //y2=5.56
cc_1158 ( N_noxref_6_M26_noxref_g N_noxref_12_c_3289_n ) capacitor \
 c=0.0170175f //x=15.26 //y=6.205 //x2=15.48 //y2=5.56
cc_1159 ( N_noxref_6_M25_noxref_g N_noxref_12_M25_noxref_s ) capacitor \
 c=0.00378422f //x=14.82 //y=6.205 //x2=14.465 //y2=5.205
cc_1160 ( N_noxref_6_c_1363_n N_noxref_15_c_3527_n ) capacitor c=0.00399369f \
 //x=10.465 //y=3.88 //x2=9.84 //y2=1.76
cc_1161 ( N_noxref_6_c_1363_n N_noxref_15_c_3535_n ) capacitor c=0.00175436f \
 //x=10.465 //y=3.88 //x2=9.925 //y2=1.675
cc_1162 ( N_Q_c_1597_n N_noxref_8_c_1902_n ) capacitor c=0.00665212f //x=14.99 \
 //y=1.75 //x2=12.7 //y2=1.935
cc_1163 ( N_Q_c_1621_n N_noxref_8_c_1902_n ) capacitor c=6.25488e-19 //x=15.96 \
 //y=1.75 //x2=12.7 //y2=1.935
cc_1164 ( Q N_noxref_8_c_1909_n ) capacitor c=7.65451e-19 //x=16.4 //y=4.62 \
 //x2=12.705 //y2=5.42
cc_1165 ( N_Q_c_1634_p N_noxref_8_c_1909_n ) capacitor c=3.52602e-19 \
 //x=15.915 //y=5.39 //x2=12.705 //y2=5.42
cc_1166 ( Q N_noxref_8_c_1913_n ) capacitor c=0.00198397f //x=16.4 //y=2.4 \
 //x2=12.985 //y2=2.02
cc_1167 ( Q N_noxref_8_c_1932_n ) capacitor c=0.00214273f //x=16.4 //y=4.62 \
 //x2=13.07 //y2=5.055
cc_1168 ( Q N_noxref_8_c_1982_n ) capacitor c=0.00214101f //x=16.4 //y=2.4 \
 //x2=18.99 //y2=4.105
cc_1169 ( Q N_noxref_8_c_1982_n ) capacitor c=7.22121e-19 //x=16.4 //y=4.62 \
 //x2=18.99 //y2=4.105
cc_1170 ( Q N_noxref_8_c_1982_n ) capacitor c=0.0425254f //x=18.25 //y=2.4 \
 //x2=18.99 //y2=4.105
cc_1171 ( Q N_noxref_8_c_1982_n ) capacitor c=0.0171585f //x=18.25 //y=4.62 \
 //x2=18.99 //y2=4.105
cc_1172 ( Q N_noxref_8_c_1982_n ) capacitor c=8.35899e-19 //x=18.25 //y=3.51 \
 //x2=18.99 //y2=4.105
cc_1173 ( N_Q_c_1642_p N_noxref_8_c_1982_n ) capacitor c=0.0145151f //x=18.25 \
 //y=3.655 //x2=18.99 //y2=4.105
cc_1174 ( N_Q_c_1643_p N_noxref_8_c_1982_n ) capacitor c=0.00654765f //x=18.25 \
 //y=3.495 //x2=18.99 //y2=4.105
cc_1175 ( N_Q_c_1644_p N_noxref_8_c_1982_n ) capacitor c=2.61947e-19 //x=18.25 \
 //y=2.26 //x2=18.99 //y2=4.105
cc_1176 ( Q N_noxref_8_c_1990_n ) capacitor c=0.0167524f //x=18.25 //y=4.62 \
 //x2=18.99 //y2=4.41
cc_1177 ( N_Q_c_1602_n N_noxref_8_c_1937_n ) capacitor c=0.00602995f //x=14.99 \
 //y=1.305 //x2=12.7 //y2=1.185
cc_1178 ( N_Q_c_1597_n N_noxref_8_c_1937_n ) capacitor c=5.1658e-19 //x=14.99 \
 //y=1.75 //x2=12.7 //y2=1.185
cc_1179 ( Q N_noxref_8_c_1993_n ) capacitor c=9.61164e-19 //x=18.25 //y=4.62 \
 //x2=18.99 //y2=4.25
cc_1180 ( N_Q_c_1649_p N_noxref_8_c_1994_n ) capacitor c=0.0217252f //x=18.25 \
 //y=2.26 //x2=18.99 //y2=2.26
cc_1181 ( N_Q_c_1644_p N_noxref_8_c_1994_n ) capacitor c=5.41079e-19 //x=18.25 \
 //y=2.26 //x2=18.99 //y2=2.26
cc_1182 ( N_Q_c_1651_p N_noxref_8_c_1994_n ) capacitor c=0.00178181f \
 //x=18.055 //y=2.095 //x2=18.99 //y2=2.26
cc_1183 ( N_Q_c_1652_p N_noxref_8_c_1997_n ) capacitor c=0.0134852f //x=18.095 \
 //y=4.885 //x2=19.025 //y2=4.885
cc_1184 ( N_Q_c_1653_p N_noxref_8_c_1997_n ) capacitor c=0.00105182f \
 //x=18.095 //y=4.885 //x2=19.025 //y2=4.885
cc_1185 ( N_Q_c_1654_p N_noxref_8_c_1997_n ) capacitor c=0.00107587f \
 //x=18.515 //y=4.975 //x2=19.025 //y2=4.885
cc_1186 ( Q N_noxref_8_c_2000_n ) capacitor c=0.00167832f //x=16.4 //y=4.62 \
 //x2=19.025 //y2=4.74
cc_1187 ( Q N_noxref_8_c_2000_n ) capacitor c=0.0122664f //x=18.25 //y=4.62 \
 //x2=19.025 //y2=4.74
cc_1188 ( Q N_noxref_8_c_2002_n ) capacitor c=0.00294615f //x=18.25 //y=4.62 \
 //x2=18.99 //y2=4.25
cc_1189 ( Q N_noxref_8_c_1971_n ) capacitor c=0.02915f //x=16.4 //y=4.62 \
 //x2=18.83 //y2=4.257
cc_1190 ( Q N_noxref_8_c_1971_n ) capacitor c=0.0259502f //x=18.25 //y=4.62 \
 //x2=18.83 //y2=4.257
cc_1191 ( N_Q_c_1634_p N_noxref_8_c_1971_n ) capacitor c=0.0146575f //x=15.915 \
 //y=5.39 //x2=18.83 //y2=4.257
cc_1192 ( N_Q_c_1652_p N_noxref_8_c_1971_n ) capacitor c=0.009793f //x=18.095 \
 //y=4.885 //x2=18.83 //y2=4.257
cc_1193 ( N_Q_c_1662_p N_noxref_8_c_1971_n ) capacitor c=0.00975132f //x=18.09 \
 //y=3.502 //x2=18.83 //y2=4.257
cc_1194 ( N_Q_c_1653_p N_noxref_8_c_1971_n ) capacitor c=0.00460112f \
 //x=18.095 //y=4.885 //x2=18.83 //y2=4.257
cc_1195 ( Q N_noxref_8_c_2009_n ) capacitor c=2.61947e-19 //x=18.25 //y=2.4 \
 //x2=18.99 //y2=2.26
cc_1196 ( N_Q_c_1649_p N_noxref_8_c_2009_n ) capacitor c=5.24865e-19 //x=18.25 \
 //y=2.26 //x2=18.99 //y2=2.26
cc_1197 ( N_Q_c_1644_p N_noxref_8_c_2009_n ) capacitor c=0.00445529f //x=18.25 \
 //y=2.26 //x2=18.99 //y2=2.26
cc_1198 ( N_Q_c_1651_p N_noxref_8_c_2009_n ) capacitor c=0.00267961f \
 //x=18.055 //y=2.095 //x2=18.99 //y2=2.26
cc_1199 ( N_Q_c_1652_p N_noxref_8_c_2013_n ) capacitor c=4.32488e-19 \
 //x=18.095 //y=4.885 //x2=19.025 //y2=4.885
cc_1200 ( N_Q_c_1653_p N_noxref_8_c_2013_n ) capacitor c=0.00242589f \
 //x=18.095 //y=4.885 //x2=19.025 //y2=4.885
cc_1201 ( N_Q_c_1654_p N_noxref_8_c_2013_n ) capacitor c=0.00116837f \
 //x=18.515 //y=4.975 //x2=19.025 //y2=4.885
cc_1202 ( N_Q_c_1671_p N_noxref_8_c_2013_n ) capacitor c=0.00121814f \
 //x=18.095 //y=4.885 //x2=19.025 //y2=4.885
cc_1203 ( N_Q_M29_noxref_g N_noxref_8_M31_noxref_g ) capacitor c=0.0101077f \
 //x=18.15 //y=6.205 //x2=19.03 //y2=6.205
cc_1204 ( N_Q_M30_noxref_g N_noxref_8_M31_noxref_g ) capacitor c=0.109254f \
 //x=18.59 //y=6.205 //x2=19.03 //y2=6.205
cc_1205 ( N_Q_M30_noxref_g N_noxref_8_M32_noxref_g ) capacitor c=0.00945018f \
 //x=18.59 //y=6.205 //x2=19.47 //y2=6.205
cc_1206 ( N_Q_c_1675_p N_noxref_8_c_2020_n ) capacitor c=0.00125788f \
 //x=18.055 //y=1.085 //x2=19.025 //y2=1.085
cc_1207 ( N_Q_c_1676_p N_noxref_8_c_2020_n ) capacitor c=0.0126654f //x=18.585 \
 //y=1.085 //x2=19.025 //y2=1.085
cc_1208 ( N_Q_c_1677_p N_noxref_8_c_2022_n ) capacitor c=0.00149727f \
 //x=18.055 //y=1.43 //x2=19.025 //y2=1.435
cc_1209 ( N_Q_c_1678_p N_noxref_8_c_2022_n ) capacitor c=0.00111802f \
 //x=18.055 //y=1.74 //x2=19.025 //y2=1.435
cc_1210 ( N_Q_c_1679_p N_noxref_8_c_2022_n ) capacitor c=0.0126654f //x=18.585 \
 //y=1.43 //x2=19.025 //y2=1.435
cc_1211 ( N_Q_c_1678_p N_noxref_8_c_2025_n ) capacitor c=0.00116305f \
 //x=18.055 //y=1.74 //x2=19.025 //y2=1.74
cc_1212 ( N_Q_c_1679_p N_noxref_8_c_2025_n ) capacitor c=0.00938322f \
 //x=18.585 //y=1.43 //x2=19.025 //y2=1.74
cc_1213 ( N_Q_c_1679_p N_noxref_8_c_2027_n ) capacitor c=0.00131492f \
 //x=18.585 //y=1.43 //x2=19.4 //y2=1.585
cc_1214 ( N_Q_c_1676_p N_noxref_8_c_2028_n ) capacitor c=0.00132934f \
 //x=18.585 //y=1.085 //x2=19.555 //y2=1.085
cc_1215 ( N_Q_c_1679_p N_noxref_8_c_2029_n ) capacitor c=0.00151998f \
 //x=18.585 //y=1.43 //x2=19.555 //y2=1.435
cc_1216 ( N_Q_c_1649_p N_noxref_8_c_2030_n ) capacitor c=0.00173144f //x=18.25 \
 //y=2.26 //x2=18.99 //y2=2.26
cc_1217 ( N_Q_c_1644_p N_noxref_8_c_2030_n ) capacitor c=0.00266443f //x=18.25 \
 //y=2.26 //x2=18.99 //y2=2.26
cc_1218 ( N_Q_c_1651_p N_noxref_8_c_2030_n ) capacitor c=0.0181449f //x=18.055 \
 //y=2.095 //x2=18.99 //y2=2.26
cc_1219 ( N_Q_c_1651_p N_noxref_8_c_2033_n ) capacitor c=0.00636965f \
 //x=18.055 //y=2.095 //x2=18.99 //y2=2.095
cc_1220 ( Q N_noxref_8_c_2034_n ) capacitor c=0.00117265f //x=18.25 //y=4.62 \
 //x2=19.025 //y2=4.885
cc_1221 ( N_Q_c_1652_p N_noxref_8_c_2034_n ) capacitor c=4.8456e-19 //x=18.095 \
 //y=4.885 //x2=19.025 //y2=4.885
cc_1222 ( N_Q_c_1653_p N_noxref_8_c_2034_n ) capacitor c=0.00211373f \
 //x=18.095 //y=4.885 //x2=19.025 //y2=4.885
cc_1223 ( N_Q_c_1654_p N_noxref_8_c_2034_n ) capacitor c=0.0203928f //x=18.515 \
 //y=4.975 //x2=19.025 //y2=4.885
cc_1224 ( N_Q_c_1671_p N_noxref_8_c_2034_n ) capacitor c=0.00590438f \
 //x=18.095 //y=4.885 //x2=19.025 //y2=4.885
cc_1225 ( Q N_noxref_9_c_2181_n ) capacitor c=0.042503f //x=16.4 //y=2.4 \
 //x2=15.66 //y2=3.72
cc_1226 ( Q N_noxref_9_c_2181_n ) capacitor c=0.0028341f //x=16.4 //y=4.62 \
 //x2=15.66 //y2=3.72
cc_1227 ( Q N_noxref_9_c_2181_n ) capacitor c=0.00211383f //x=18.25 //y=2.4 \
 //x2=15.66 //y2=3.72
cc_1228 ( Q N_noxref_9_c_2181_n ) capacitor c=8.35899e-19 //x=16.4 //y=3.51 \
 //x2=15.66 //y2=3.72
cc_1229 ( N_Q_c_1698_p N_noxref_9_c_2181_n ) capacitor c=0.0145151f //x=16.4 \
 //y=3.655 //x2=15.66 //y2=3.72
cc_1230 ( N_Q_c_1699_p N_noxref_9_c_2181_n ) capacitor c=0.00654765f //x=16.56 \
 //y=3.502 //x2=15.66 //y2=3.72
cc_1231 ( Q N_noxref_9_c_2183_n ) capacitor c=0.0170063f //x=16.4 //y=4.62 \
 //x2=15.66 //y2=4.025
cc_1232 ( N_Q_c_1615_n N_noxref_9_c_2183_n ) capacitor c=0.00195058f \
 //x=15.875 //y=1.835 //x2=15.66 //y2=4.025
cc_1233 ( N_Q_c_1634_p N_noxref_9_c_2183_n ) capacitor c=0.00172474f \
 //x=15.915 //y=5.39 //x2=15.66 //y2=4.025
cc_1234 ( N_Q_c_1703_p N_noxref_9_c_2236_n ) capacitor c=0.00607433f //x=15.96 \
 //y=1.3 //x2=18.32 //y2=1.305
cc_1235 ( N_Q_c_1649_p N_noxref_9_c_2236_n ) capacitor c=0.00118583f //x=18.25 \
 //y=2.26 //x2=18.32 //y2=1.305
cc_1236 ( N_Q_c_1644_p N_noxref_9_c_2236_n ) capacitor c=7.02188e-19 //x=18.25 \
 //y=2.26 //x2=18.32 //y2=1.305
cc_1237 ( N_Q_c_1675_p N_noxref_9_c_2236_n ) capacitor c=6.05707e-19 \
 //x=18.055 //y=1.085 //x2=18.32 //y2=1.305
cc_1238 ( N_Q_c_1677_p N_noxref_9_c_2236_n ) capacitor c=0.00327855f \
 //x=18.055 //y=1.43 //x2=18.32 //y2=1.305
cc_1239 ( N_Q_c_1708_p N_noxref_9_c_2236_n ) capacitor c=5.29726e-19 //x=18.43 \
 //y=0.93 //x2=18.32 //y2=1.305
cc_1240 ( N_Q_c_1709_p N_noxref_9_c_2236_n ) capacitor c=6.03709e-19 //x=18.43 \
 //y=1.585 //x2=18.32 //y2=1.305
cc_1241 ( N_Q_c_1676_p N_noxref_9_c_2236_n ) capacitor c=5.57259e-19 \
 //x=18.585 //y=1.085 //x2=18.32 //y2=1.305
cc_1242 ( N_Q_c_1679_p N_noxref_9_c_2236_n ) capacitor c=0.00212774f \
 //x=18.585 //y=1.43 //x2=18.32 //y2=1.305
cc_1243 ( N_Q_c_1597_n N_noxref_9_c_2245_n ) capacitor c=6.24608e-19 //x=14.99 \
 //y=1.75 //x2=18.32 //y2=1.75
cc_1244 ( N_Q_c_1621_n N_noxref_9_c_2245_n ) capacitor c=0.00427895f //x=15.96 \
 //y=1.75 //x2=18.32 //y2=1.75
cc_1245 ( N_Q_c_1677_p N_noxref_9_c_2245_n ) capacitor c=0.00109347f \
 //x=18.055 //y=1.43 //x2=18.32 //y2=1.75
cc_1246 ( N_Q_c_1678_p N_noxref_9_c_2245_n ) capacitor c=0.00314841f \
 //x=18.055 //y=1.74 //x2=18.32 //y2=1.75
cc_1247 ( N_Q_c_1651_p N_noxref_9_c_2245_n ) capacitor c=0.00309965f \
 //x=18.055 //y=2.095 //x2=18.32 //y2=1.75
cc_1248 ( N_Q_c_1709_p N_noxref_9_c_2245_n ) capacitor c=0.00674367f //x=18.43 \
 //y=1.585 //x2=18.32 //y2=1.75
cc_1249 ( N_Q_c_1679_p N_noxref_9_c_2245_n ) capacitor c=0.00253555f \
 //x=18.585 //y=1.43 //x2=18.32 //y2=1.75
cc_1250 ( N_Q_c_1679_p N_noxref_9_c_2252_n ) capacitor c=7.25274e-19 \
 //x=18.585 //y=1.43 //x2=19.205 //y2=1.835
cc_1251 ( N_Q_c_1720_p N_noxref_9_c_2253_n ) capacitor c=0.00378258f \
 //x=16.315 //y=1.835 //x2=18.405 //y2=1.835
cc_1252 ( N_Q_c_1642_p N_noxref_9_c_2253_n ) capacitor c=7.12225e-19 //x=18.25 \
 //y=3.655 //x2=18.405 //y2=1.835
cc_1253 ( N_Q_c_1649_p N_noxref_9_c_2253_n ) capacitor c=0.0165234f //x=18.25 \
 //y=2.26 //x2=18.405 //y2=1.835
cc_1254 ( N_Q_c_1643_p N_noxref_9_c_2253_n ) capacitor c=4.77471e-19 //x=18.25 \
 //y=3.495 //x2=18.405 //y2=1.835
cc_1255 ( N_Q_c_1644_p N_noxref_9_c_2253_n ) capacitor c=0.00293572f //x=18.25 \
 //y=2.26 //x2=18.405 //y2=1.835
cc_1256 ( N_Q_c_1651_p N_noxref_9_c_2253_n ) capacitor c=0.0011377f //x=18.055 \
 //y=2.095 //x2=18.405 //y2=1.835
cc_1257 ( N_Q_c_1621_n N_noxref_9_c_2259_n ) capacitor c=6.26629e-19 //x=15.96 \
 //y=1.75 //x2=19.29 //y2=1.75
cc_1258 ( N_Q_c_1679_p N_noxref_9_c_2259_n ) capacitor c=6.29838e-19 \
 //x=18.585 //y=1.43 //x2=19.29 //y2=1.75
cc_1259 ( Q N_noxref_9_c_2261_n ) capacitor c=0.00204276f //x=16.4 //y=2.4 \
 //x2=19.73 //y2=3.74
cc_1260 ( Q N_noxref_9_c_2261_n ) capacitor c=0.0032526f //x=18.25 //y=2.4 \
 //x2=19.73 //y2=3.74
cc_1261 ( Q N_noxref_9_c_2263_n ) capacitor c=0.0029334f //x=16.4 //y=4.62 \
 //x2=19.73 //y2=5.305
cc_1262 ( Q N_noxref_9_c_2263_n ) capacitor c=0.00389426f //x=18.25 //y=4.62 \
 //x2=19.73 //y2=5.305
cc_1263 ( N_Q_c_1653_p N_noxref_9_c_2263_n ) capacitor c=2.44646e-19 \
 //x=18.095 //y=4.885 //x2=19.73 //y2=5.305
cc_1264 ( Q N_noxref_9_c_2186_n ) capacitor c=0.0160491f //x=16.4 //y=2.4 \
 //x2=15.66 //y2=2.26
cc_1265 ( N_Q_c_1615_n N_noxref_9_c_2186_n ) capacitor c=0.0305271f //x=15.875 \
 //y=1.835 //x2=15.66 //y2=2.26
cc_1266 ( Q N_noxref_9_c_2189_n ) capacitor c=0.0175188f //x=16.4 //y=4.62 \
 //x2=15.695 //y2=4.885
cc_1267 ( N_Q_c_1634_p N_noxref_9_c_2189_n ) capacitor c=0.00199057f \
 //x=15.915 //y=5.39 //x2=15.695 //y2=4.885
cc_1268 ( Q N_noxref_9_c_2192_n ) capacitor c=0.0282149f //x=16.4 //y=4.62 \
 //x2=15.695 //y2=4.74
cc_1269 ( Q N_noxref_9_c_2192_n ) capacitor c=0.00161522f //x=18.25 //y=4.62 \
 //x2=15.695 //y2=4.74
cc_1270 ( Q N_noxref_9_c_2193_n ) capacitor c=8.35899e-19 //x=16.4 //y=4.62 \
 //x2=15.66 //y2=3.88
cc_1271 ( N_Q_c_1740_p N_noxref_9_c_2273_n ) capacitor c=7.58745e-19 \
 //x=16.315 //y=5.39 //x2=19.245 //y2=5.39
cc_1272 ( Q N_noxref_9_c_2195_n ) capacitor c=0.00294615f //x=16.4 //y=4.62 \
 //x2=15.82 //y2=3.872
cc_1273 ( N_Q_c_1615_n N_noxref_9_c_2195_n ) capacitor c=7.33088e-19 \
 //x=15.875 //y=1.835 //x2=15.82 //y2=3.872
cc_1274 ( Q N_noxref_9_c_2276_n ) capacitor c=0.0216925f //x=16.4 //y=4.62 \
 //x2=19.565 //y2=3.892
cc_1275 ( Q N_noxref_9_c_2276_n ) capacitor c=0.0227755f //x=18.25 //y=4.62 \
 //x2=19.565 //y2=3.892
cc_1276 ( N_Q_c_1615_n N_noxref_9_c_2276_n ) capacitor c=9.97925e-19 \
 //x=15.875 //y=1.835 //x2=19.565 //y2=3.892
cc_1277 ( N_Q_c_1698_p N_noxref_9_c_2276_n ) capacitor c=0.0091804f //x=16.4 \
 //y=3.655 //x2=19.565 //y2=3.892
cc_1278 ( N_Q_c_1642_p N_noxref_9_c_2276_n ) capacitor c=0.00547934f //x=18.25 \
 //y=3.655 //x2=19.565 //y2=3.892
cc_1279 ( N_Q_c_1748_p N_noxref_9_c_2276_n ) capacitor c=0.00436122f //x=15.96 \
 //y=1.835 //x2=19.565 //y2=3.892
cc_1280 ( N_Q_c_1699_p N_noxref_9_c_2276_n ) capacitor c=0.0367805f //x=16.56 \
 //y=3.502 //x2=19.565 //y2=3.892
cc_1281 ( N_Q_c_1643_p N_noxref_9_c_2276_n ) capacitor c=0.0367805f //x=18.25 \
 //y=3.495 //x2=19.565 //y2=3.892
cc_1282 ( N_Q_c_1662_p N_noxref_9_c_2276_n ) capacitor c=0.139988f //x=18.09 \
 //y=3.502 //x2=19.565 //y2=3.892
cc_1283 ( Q N_noxref_9_c_2197_n ) capacitor c=8.61986e-19 //x=16.4 //y=2.4 \
 //x2=15.66 //y2=2.26
cc_1284 ( N_Q_c_1615_n N_noxref_9_c_2197_n ) capacitor c=0.00491852f \
 //x=15.875 //y=1.835 //x2=15.66 //y2=2.26
cc_1285 ( Q N_noxref_9_c_2201_n ) capacitor c=0.00351933f //x=16.4 //y=4.62 \
 //x2=15.695 //y2=4.885
cc_1286 ( N_Q_c_1634_p N_noxref_9_M27_noxref_g ) capacitor c=0.00184899f \
 //x=15.915 //y=5.39 //x2=15.7 //y2=6.205
cc_1287 ( N_Q_c_1756_p N_noxref_9_M27_noxref_g ) capacitor c=0.0120591f \
 //x=15.92 //y=5.56 //x2=15.7 //y2=6.205
cc_1288 ( N_Q_c_1740_p N_noxref_9_M28_noxref_g ) capacitor c=0.0104409f \
 //x=16.315 //y=5.39 //x2=16.14 //y2=6.205
cc_1289 ( N_Q_c_1634_p N_noxref_9_M28_noxref_g ) capacitor c=0.0027897f \
 //x=15.915 //y=5.39 //x2=16.14 //y2=6.205
cc_1290 ( N_Q_c_1756_p N_noxref_9_M28_noxref_g ) capacitor c=0.0140704f \
 //x=15.92 //y=5.56 //x2=16.14 //y2=6.205
cc_1291 ( N_Q_c_1703_p N_noxref_9_c_2208_n ) capacitor c=0.00112851f //x=15.96 \
 //y=1.3 //x2=15.695 //y2=1.085
cc_1292 ( N_Q_M8_noxref_d N_noxref_9_c_2208_n ) capacitor c=0.00218694f \
 //x=15.77 //y=1.085 //x2=15.695 //y2=1.085
cc_1293 ( N_Q_c_1703_p N_noxref_9_c_2210_n ) capacitor c=0.0021447f //x=15.96 \
 //y=1.3 //x2=15.695 //y2=1.435
cc_1294 ( N_Q_c_1621_n N_noxref_9_c_2210_n ) capacitor c=7.7986e-19 //x=15.96 \
 //y=1.75 //x2=15.695 //y2=1.435
cc_1295 ( N_Q_M8_noxref_d N_noxref_9_c_2210_n ) capacitor c=0.00237422f \
 //x=15.77 //y=1.085 //x2=15.695 //y2=1.435
cc_1296 ( N_Q_c_1597_n N_noxref_9_c_2213_n ) capacitor c=0.00120307f //x=14.99 \
 //y=1.75 //x2=15.695 //y2=1.74
cc_1297 ( N_Q_c_1621_n N_noxref_9_c_2213_n ) capacitor c=0.00364979f //x=15.96 \
 //y=1.75 //x2=15.695 //y2=1.74
cc_1298 ( Q N_noxref_9_c_2300_n ) capacitor c=0.00854359f //x=16.4 //y=4.62 \
 //x2=16.065 //y2=4.975
cc_1299 ( N_Q_c_1634_p N_noxref_9_c_2300_n ) capacitor c=0.00189536f \
 //x=15.915 //y=5.39 //x2=16.065 //y2=4.975
cc_1300 ( N_Q_c_1756_p N_noxref_9_c_2300_n ) capacitor c=0.00293135f //x=15.92 \
 //y=5.56 //x2=16.065 //y2=4.975
cc_1301 ( N_Q_c_1703_p N_noxref_9_c_2303_n ) capacitor c=5.32053e-19 //x=15.96 \
 //y=1.3 //x2=16.07 //y2=0.93
cc_1302 ( N_Q_M8_noxref_d N_noxref_9_c_2303_n ) capacitor c=0.00213893f \
 //x=15.77 //y=1.085 //x2=16.07 //y2=0.93
cc_1303 ( N_Q_c_1703_p N_noxref_9_c_2215_n ) capacitor c=5.25031e-19 //x=15.96 \
 //y=1.3 //x2=16.07 //y2=1.585
cc_1304 ( N_Q_c_1621_n N_noxref_9_c_2215_n ) capacitor c=0.00957298f //x=15.96 \
 //y=1.75 //x2=16.07 //y2=1.585
cc_1305 ( N_Q_c_1720_p N_noxref_9_c_2215_n ) capacitor c=0.00500113f \
 //x=16.315 //y=1.835 //x2=16.07 //y2=1.585
cc_1306 ( N_Q_M8_noxref_d N_noxref_9_c_2215_n ) capacitor c=0.00357974f \
 //x=15.77 //y=1.085 //x2=16.07 //y2=1.585
cc_1307 ( N_Q_c_1703_p N_noxref_9_c_2216_n ) capacitor c=8.07186e-19 //x=15.96 \
 //y=1.3 //x2=16.225 //y2=1.085
cc_1308 ( N_Q_M8_noxref_d N_noxref_9_c_2216_n ) capacitor c=0.0012513f \
 //x=15.77 //y=1.085 //x2=16.225 //y2=1.085
cc_1309 ( N_Q_c_1703_p N_noxref_9_c_2217_n ) capacitor c=0.00325254f //x=15.96 \
 //y=1.3 //x2=16.225 //y2=1.435
cc_1310 ( N_Q_c_1621_n N_noxref_9_c_2217_n ) capacitor c=0.00116202f //x=15.96 \
 //y=1.75 //x2=16.225 //y2=1.435
cc_1311 ( N_Q_M8_noxref_d N_noxref_9_c_2217_n ) capacitor c=0.00237422f \
 //x=15.77 //y=1.085 //x2=16.225 //y2=1.435
cc_1312 ( Q N_noxref_9_c_2218_n ) capacitor c=0.0028062f //x=16.4 //y=2.4 \
 //x2=15.66 //y2=2.26
cc_1313 ( N_Q_c_1615_n N_noxref_9_c_2218_n ) capacitor c=0.00146119f \
 //x=15.875 //y=1.835 //x2=15.66 //y2=2.26
cc_1314 ( Q N_noxref_9_c_2221_n ) capacitor c=0.00312016f //x=16.4 //y=2.4 \
 //x2=15.66 //y2=2.095
cc_1315 ( N_Q_c_1615_n N_noxref_9_c_2221_n ) capacitor c=0.00817459f \
 //x=15.875 //y=1.835 //x2=15.66 //y2=2.095
cc_1316 ( Q N_noxref_9_c_2222_n ) capacitor c=0.00141757f //x=16.4 //y=4.62 \
 //x2=15.695 //y2=4.885
cc_1317 ( N_Q_c_1649_p N_noxref_9_M9_noxref_d ) capacitor c=7.18966e-19 \
 //x=18.25 //y=2.26 //x2=18.13 //y2=1.085
cc_1318 ( N_Q_c_1644_p N_noxref_9_M9_noxref_d ) capacitor c=0.00150225f \
 //x=18.25 //y=2.26 //x2=18.13 //y2=1.085
cc_1319 ( N_Q_c_1675_p N_noxref_9_M9_noxref_d ) capacitor c=0.00124139f \
 //x=18.055 //y=1.085 //x2=18.13 //y2=1.085
cc_1320 ( N_Q_c_1677_p N_noxref_9_M9_noxref_d ) capacitor c=0.00237422f \
 //x=18.055 //y=1.43 //x2=18.13 //y2=1.085
cc_1321 ( N_Q_c_1651_p N_noxref_9_M9_noxref_d ) capacitor c=4.64713e-19 \
 //x=18.055 //y=2.095 //x2=18.13 //y2=1.085
cc_1322 ( N_Q_c_1708_p N_noxref_9_M9_noxref_d ) capacitor c=0.00213893f \
 //x=18.43 //y=0.93 //x2=18.13 //y2=1.085
cc_1323 ( N_Q_c_1709_p N_noxref_9_M9_noxref_d ) capacitor c=0.00345753f \
 //x=18.43 //y=1.585 //x2=18.13 //y2=1.085
cc_1324 ( N_Q_c_1676_p N_noxref_9_M9_noxref_d ) capacitor c=0.00211919f \
 //x=18.585 //y=1.085 //x2=18.13 //y2=1.085
cc_1325 ( N_Q_c_1679_p N_noxref_9_M9_noxref_d ) capacitor c=0.00237422f \
 //x=18.585 //y=1.43 //x2=18.13 //y2=1.085
cc_1326 ( N_Q_c_1740_p N_VDD_c_2715_n ) capacitor c=2.90144e-19 //x=16.315 \
 //y=5.39 //x2=18.285 //y2=7.585
cc_1327 ( N_Q_c_1698_p N_VDD_c_2715_n ) capacitor c=4.57113e-19 //x=16.4 \
 //y=3.655 //x2=18.285 //y2=7.585
cc_1328 ( N_Q_M29_noxref_g N_VDD_c_2717_n ) capacitor c=0.00122608f //x=18.15 \
 //y=6.205 //x2=18.37 //y2=7.035
cc_1329 ( N_Q_M30_noxref_g N_VDD_c_2717_n ) capacitor c=0.00122608f //x=18.59 \
 //y=6.205 //x2=18.37 //y2=7.035
cc_1330 ( N_Q_M29_noxref_g N_VDD_c_2719_n ) capacitor c=0.00193078f //x=18.15 \
 //y=6.205 //x2=18.37 //y2=7.41
cc_1331 ( N_Q_M30_noxref_g N_VDD_c_2719_n ) capacitor c=0.00294739f //x=18.59 \
 //y=6.205 //x2=18.37 //y2=7.41
cc_1332 ( N_Q_c_1740_p N_VDD_c_2686_n ) capacitor c=0.00131078f //x=16.315 \
 //y=5.39 //x2=16.97 //y2=7.585
cc_1333 ( N_Q_c_1756_p N_VDD_c_2686_n ) capacitor c=0.00488797f //x=15.92 \
 //y=5.56 //x2=16.97 //y2=7.585
cc_1334 ( N_Q_c_1653_p N_VDD_c_2723_n ) capacitor c=3.49022e-19 //x=18.095 \
 //y=4.885 //x2=19.73 //y2=7.58
cc_1335 ( N_Q_M29_noxref_g N_VDD_c_2723_n ) capacitor c=0.00737762f //x=18.15 \
 //y=6.205 //x2=19.73 //y2=7.58
cc_1336 ( N_Q_M30_noxref_g N_VDD_c_2723_n ) capacitor c=0.00760847f //x=18.59 \
 //y=6.205 //x2=19.73 //y2=7.58
cc_1337 ( Q N_VDD_c_2652_n ) capacitor c=0.00126419f //x=16.4 //y=4.62 \
 //x2=13.81 //y2=7.585
cc_1338 ( Q N_VDD_c_2700_n ) capacitor c=0.0301302f //x=16.4 //y=4.62 \
 //x2=17.14 //y2=7.585
cc_1339 ( Q N_VDD_c_2700_n ) capacitor c=0.00664116f //x=18.25 //y=4.62 \
 //x2=17.14 //y2=7.585
cc_1340 ( N_Q_c_1634_p N_VDD_c_2700_n ) capacitor c=0.00270468f //x=15.915 \
 //y=5.39 //x2=17.14 //y2=7.585
cc_1341 ( N_Q_c_1652_p N_VDD_c_2700_n ) capacitor c=0.00344941f //x=18.095 \
 //y=4.885 //x2=17.14 //y2=7.585
cc_1342 ( N_Q_c_1756_p N_VDD_c_2700_n ) capacitor c=0.00923288f //x=15.92 \
 //y=5.56 //x2=17.14 //y2=7.585
cc_1343 ( N_Q_c_1653_p N_VDD_c_2700_n ) capacitor c=0.00616738f //x=18.095 \
 //y=4.885 //x2=17.14 //y2=7.585
cc_1344 ( N_Q_M29_noxref_g N_VDD_c_2700_n ) capacitor c=0.00926945f //x=18.15 \
 //y=6.205 //x2=17.14 //y2=7.585
cc_1345 ( N_Q_c_1671_p N_VDD_c_2700_n ) capacitor c=0.004975f //x=18.095 \
 //y=4.885 //x2=17.14 //y2=7.585
cc_1346 ( N_Q_c_1634_p N_VDD_M24_noxref_d ) capacitor c=2.8473e-19 //x=15.915 \
 //y=5.39 //x2=13 //y2=5.2
cc_1347 ( N_Q_c_1756_p N_VDD_M25_noxref_d ) capacitor c=0.00560948f //x=15.92 \
 //y=5.56 //x2=14.895 //y2=5.205
cc_1348 ( Q N_VDD_M29_noxref_d ) capacitor c=4.99766e-19 //x=18.25 //y=3.51 \
 //x2=18.225 //y2=5.205
cc_1349 ( N_Q_M29_noxref_g N_VDD_M29_noxref_d ) capacitor c=0.0130453f \
 //x=18.15 //y=6.205 //x2=18.225 //y2=5.205
cc_1350 ( N_Q_M30_noxref_g N_VDD_M29_noxref_d ) capacitor c=0.0142727f \
 //x=18.59 //y=6.205 //x2=18.225 //y2=5.205
cc_1351 ( N_Q_c_1654_p N_VDD_M29_noxref_d ) capacitor c=0.00239008f //x=18.515 \
 //y=4.975 //x2=18.225 //y2=5.205
cc_1352 ( Q N_GND_c_2995_n ) capacitor c=3.83892e-19 //x=16.4 //y=3.51 \
 //x2=19.73 //y2=0.18
cc_1353 ( N_Q_c_1602_n N_GND_c_2995_n ) capacitor c=0.00990085f //x=14.99 \
 //y=1.305 //x2=19.73 //y2=0.18
cc_1354 ( N_Q_c_1615_n N_GND_c_2995_n ) capacitor c=0.00677923f //x=15.875 \
 //y=1.835 //x2=19.73 //y2=0.18
cc_1355 ( N_Q_c_1703_p N_GND_c_2995_n ) capacitor c=0.0106318f //x=15.96 \
 //y=1.3 //x2=19.73 //y2=0.18
cc_1356 ( N_Q_c_1720_p N_GND_c_2995_n ) capacitor c=0.00667116f //x=16.315 \
 //y=1.835 //x2=19.73 //y2=0.18
cc_1357 ( N_Q_c_1698_p N_GND_c_2995_n ) capacitor c=4.96846e-19 //x=16.4 \
 //y=3.655 //x2=19.73 //y2=0.18
cc_1358 ( N_Q_c_1642_p N_GND_c_2995_n ) capacitor c=2.54206e-19 //x=18.25 \
 //y=3.655 //x2=19.73 //y2=0.18
cc_1359 ( N_Q_c_1649_p N_GND_c_2995_n ) capacitor c=8.84449e-19 //x=18.25 \
 //y=2.26 //x2=19.73 //y2=0.18
cc_1360 ( N_Q_M7_noxref_d N_GND_c_2995_n ) capacitor c=3.01769e-19 //x=14.8 \
 //y=1.085 //x2=19.73 //y2=0.18
cc_1361 ( N_Q_M8_noxref_d N_GND_c_2995_n ) capacitor c=3.01769e-19 //x=15.77 \
 //y=1.085 //x2=19.73 //y2=0.18
cc_1362 ( N_Q_c_1602_n N_GND_c_3073_n ) capacitor c=0.00373729f //x=14.99 \
 //y=1.305 //x2=15.39 //y2=0.71
cc_1363 ( N_Q_c_1615_n N_GND_c_3073_n ) capacitor c=0.00128856f //x=15.875 \
 //y=1.835 //x2=15.39 //y2=0.71
cc_1364 ( N_Q_M7_noxref_d N_GND_c_3073_n ) capacitor c=0.0122548f //x=14.8 \
 //y=1.085 //x2=15.39 //y2=0.71
cc_1365 ( N_Q_c_1615_n N_GND_c_3111_n ) capacitor c=0.00128298f //x=15.875 \
 //y=1.835 //x2=16.36 //y2=0.71
cc_1366 ( N_Q_c_1703_p N_GND_c_3111_n ) capacitor c=0.0048144f //x=15.96 \
 //y=1.3 //x2=16.36 //y2=0.71
cc_1367 ( N_Q_c_1720_p N_GND_c_3111_n ) capacitor c=0.00353189f //x=16.315 \
 //y=1.835 //x2=16.36 //y2=0.71
cc_1368 ( N_Q_M8_noxref_d N_GND_c_3111_n ) capacitor c=0.0126716f //x=15.77 \
 //y=1.085 //x2=16.36 //y2=0.71
cc_1369 ( N_Q_c_1642_p N_GND_c_3115_n ) capacitor c=4.08952e-19 //x=18.25 \
 //y=3.655 //x2=18.72 //y2=0.71
cc_1370 ( N_Q_c_1649_p N_GND_c_3115_n ) capacitor c=0.0010437f //x=18.25 \
 //y=2.26 //x2=18.72 //y2=0.71
cc_1371 ( N_Q_c_1644_p N_GND_c_3115_n ) capacitor c=4.19728e-19 //x=18.25 \
 //y=2.26 //x2=18.72 //y2=0.71
cc_1372 ( N_Q_c_1675_p N_GND_c_3115_n ) capacitor c=0.0211652f //x=18.055 \
 //y=1.085 //x2=18.72 //y2=0.71
cc_1373 ( N_Q_c_1651_p N_GND_c_3115_n ) capacitor c=2.1838e-19 //x=18.055 \
 //y=2.095 //x2=18.72 //y2=0.71
cc_1374 ( N_Q_c_1676_p N_GND_c_3115_n ) capacitor c=0.00805599f //x=18.585 \
 //y=1.085 //x2=18.72 //y2=0.71
cc_1375 ( Q N_GND_c_3048_n ) capacitor c=9.34543e-19 //x=16.4 //y=2.4 \
 //x2=13.81 //y2=0.175
cc_1376 ( Q N_GND_c_3122_n ) capacitor c=0.00821798f //x=18.25 //y=2.4 \
 //x2=17.14 //y2=0.175
cc_1377 ( N_Q_c_1621_n N_GND_c_3122_n ) capacitor c=0.00306421f //x=15.96 \
 //y=1.75 //x2=17.14 //y2=0.175
cc_1378 ( N_Q_c_1720_p N_GND_c_3122_n ) capacitor c=0.0304475f //x=16.315 \
 //y=1.835 //x2=17.14 //y2=0.175
cc_1379 ( N_Q_c_1649_p N_GND_c_3122_n ) capacitor c=0.00446799f //x=18.25 \
 //y=2.26 //x2=17.14 //y2=0.175
cc_1380 ( N_Q_c_1662_p N_GND_c_3122_n ) capacitor c=0.00560367f //x=18.09 \
 //y=3.502 //x2=17.14 //y2=0.175
cc_1381 ( N_Q_c_1644_p N_GND_c_3122_n ) capacitor c=0.00369203f //x=18.25 \
 //y=2.26 //x2=17.14 //y2=0.175
cc_1382 ( N_Q_c_1651_p N_GND_c_3122_n ) capacitor c=0.0101489f //x=18.055 \
 //y=2.095 //x2=17.14 //y2=0.175
cc_1383 ( Q N_GND_M7_noxref_s ) capacitor c=0.00106787f //x=16.4 //y=3.51 \
 //x2=14.37 //y2=0.545
cc_1384 ( N_Q_c_1602_n N_GND_M7_noxref_s ) capacitor c=0.00934626f //x=14.99 \
 //y=1.305 //x2=14.37 //y2=0.545
cc_1385 ( N_Q_c_1597_n N_GND_M7_noxref_s ) capacitor c=0.0227687f //x=14.99 \
 //y=1.75 //x2=14.37 //y2=0.545
cc_1386 ( N_Q_c_1615_n N_GND_M7_noxref_s ) capacitor c=0.00839449f //x=15.875 \
 //y=1.835 //x2=14.37 //y2=0.545
cc_1387 ( N_Q_c_1703_p N_GND_M7_noxref_s ) capacitor c=0.00928773f //x=15.96 \
 //y=1.3 //x2=14.37 //y2=0.545
cc_1388 ( N_Q_c_1621_n N_GND_M7_noxref_s ) capacitor c=0.0107302f //x=15.96 \
 //y=1.75 //x2=14.37 //y2=0.545
cc_1389 ( N_Q_c_1720_p N_GND_M7_noxref_s ) capacitor c=0.0070507f //x=16.315 \
 //y=1.835 //x2=14.37 //y2=0.545
cc_1390 ( N_Q_c_1698_p N_GND_M7_noxref_s ) capacitor c=4.17902e-19 //x=16.4 \
 //y=3.655 //x2=14.37 //y2=0.545
cc_1391 ( N_Q_M7_noxref_d N_GND_M7_noxref_s ) capacitor c=0.0297221f //x=14.8 \
 //y=1.085 //x2=14.37 //y2=0.545
cc_1392 ( N_Q_M8_noxref_d N_GND_M7_noxref_s ) capacitor c=0.029747f //x=15.77 \
 //y=1.085 //x2=14.37 //y2=0.545
cc_1393 ( N_Q_c_1662_p N_GND_M9_noxref_s ) capacitor c=0.00265904f //x=18.09 \
 //y=3.502 //x2=17.7 //y2=0.545
cc_1394 ( N_Q_c_1675_p N_GND_M9_noxref_s ) capacitor c=0.0329097f //x=18.055 \
 //y=1.085 //x2=17.7 //y2=0.545
cc_1395 ( N_Q_c_1676_p N_GND_M9_noxref_s ) capacitor c=0.00605785f //x=18.585 \
 //y=1.085 //x2=17.7 //y2=0.545
cc_1396 ( N_Q_c_1679_p N_GND_M9_noxref_s ) capacitor c=0.00120103f //x=18.585 \
 //y=1.43 //x2=17.7 //y2=0.545
cc_1397 ( N_Q_c_1598_n N_noxref_12_c_3273_n ) capacitor c=0.00205867f \
 //x=15.075 //y=1.835 //x2=15.36 //y2=5.39
cc_1398 ( N_Q_c_1740_p N_noxref_12_c_3292_n ) capacitor c=0.00301289f \
 //x=16.315 //y=5.39 //x2=16.23 //y2=7.09
cc_1399 ( N_Q_c_1634_p N_noxref_12_c_3292_n ) capacitor c=0.00513626f \
 //x=15.915 //y=5.39 //x2=16.23 //y2=7.09
cc_1400 ( N_Q_c_1756_p N_noxref_12_c_3292_n ) capacitor c=0.00406191f \
 //x=15.92 //y=5.56 //x2=16.23 //y2=7.09
cc_1401 ( N_Q_c_1634_p N_noxref_12_c_3279_n ) capacitor c=5.08928e-19 \
 //x=15.915 //y=5.39 //x2=14.6 //y2=5.39
cc_1402 ( N_Q_c_1615_n N_noxref_12_c_3283_n ) capacitor c=0.00225083f \
 //x=15.875 //y=1.835 //x2=15.48 //y2=5.39
cc_1403 ( N_Q_c_1634_p N_noxref_12_c_3283_n ) capacitor c=0.0514662f \
 //x=15.915 //y=5.39 //x2=15.48 //y2=5.39
cc_1404 ( N_Q_c_1756_p N_noxref_12_c_3283_n ) capacitor c=0.00266f //x=15.92 \
 //y=5.56 //x2=15.48 //y2=5.39
cc_1405 ( N_Q_c_1740_p N_noxref_12_c_3299_n ) capacitor c=0.00564659f \
 //x=16.315 //y=5.39 //x2=16.36 //y2=6.92
cc_1406 ( N_Q_c_1634_p N_noxref_12_c_3289_n ) capacitor c=0.00275395f \
 //x=15.915 //y=5.39 //x2=15.48 //y2=5.56
cc_1407 ( N_Q_c_1756_p N_noxref_12_c_3289_n ) capacitor c=0.0684745f //x=15.92 \
 //y=5.56 //x2=15.48 //y2=5.56
cc_1408 ( Q N_noxref_12_M28_noxref_d ) capacitor c=9.55403e-19 //x=16.4 \
 //y=3.51 //x2=16.215 //y2=5.205
cc_1409 ( N_Q_c_1740_p N_noxref_12_M28_noxref_d ) capacitor c=0.00810041f \
 //x=16.315 //y=5.39 //x2=16.215 //y2=5.205
cc_1410 ( N_Q_c_1756_p N_noxref_12_M28_noxref_d ) capacitor c=0.0478953f \
 //x=15.92 //y=5.56 //x2=16.215 //y2=5.205
cc_1411 ( Q N_noxref_13_c_3368_n ) capacitor c=6.72044e-19 //x=18.25 //y=3.51 \
 //x2=18.69 //y2=5.39
cc_1412 ( N_Q_c_1642_p N_noxref_13_c_3368_n ) capacitor c=7.19396e-19 \
 //x=18.25 //y=3.655 //x2=18.69 //y2=5.39
cc_1413 ( N_Q_c_1652_p N_noxref_13_c_3368_n ) capacitor c=0.00756274f \
 //x=18.095 //y=4.885 //x2=18.69 //y2=5.39
cc_1414 ( N_Q_c_1653_p N_noxref_13_c_3368_n ) capacitor c=0.00104675f \
 //x=18.095 //y=4.885 //x2=18.69 //y2=5.39
cc_1415 ( N_Q_M29_noxref_g N_noxref_13_c_3368_n ) capacitor c=0.0106511f \
 //x=18.15 //y=6.205 //x2=18.69 //y2=5.39
cc_1416 ( N_Q_M30_noxref_g N_noxref_13_c_3368_n ) capacitor c=0.00911022f \
 //x=18.59 //y=6.205 //x2=18.69 //y2=5.39
cc_1417 ( N_Q_c_1654_p N_noxref_13_c_3368_n ) capacitor c=0.00178204f \
 //x=18.515 //y=4.975 //x2=18.69 //y2=5.39
cc_1418 ( N_Q_c_1740_p N_noxref_13_c_3375_n ) capacitor c=0.0043859f \
 //x=16.315 //y=5.39 //x2=17.93 //y2=5.39
cc_1419 ( N_Q_c_1634_p N_noxref_13_c_3375_n ) capacitor c=0.00513745f \
 //x=15.915 //y=5.39 //x2=17.93 //y2=5.39
cc_1420 ( N_Q_c_1652_p N_noxref_13_c_3375_n ) capacitor c=0.0241407f \
 //x=18.095 //y=4.885 //x2=17.93 //y2=5.39
cc_1421 ( N_Q_c_1653_p N_noxref_13_c_3375_n ) capacitor c=0.00565356f \
 //x=18.095 //y=4.885 //x2=17.93 //y2=5.39
cc_1422 ( N_Q_M29_noxref_g N_noxref_13_c_3375_n ) capacitor c=0.00403872f \
 //x=18.15 //y=6.205 //x2=17.93 //y2=5.39
cc_1423 ( N_Q_c_1671_p N_noxref_13_c_3375_n ) capacitor c=9.12041e-19 \
 //x=18.095 //y=4.885 //x2=17.93 //y2=5.39
cc_1424 ( N_Q_M30_noxref_g N_noxref_13_c_3381_n ) capacitor c=0.0018094f \
 //x=18.59 //y=6.205 //x2=18.81 //y2=5.39
cc_1425 ( N_Q_M30_noxref_g N_noxref_13_c_3382_n ) capacitor c=0.00180782f \
 //x=18.59 //y=6.205 //x2=18.81 //y2=6.92
cc_1426 ( N_Q_c_1652_p N_noxref_13_c_3383_n ) capacitor c=0.00154424f \
 //x=18.095 //y=4.885 //x2=17.93 //y2=5.56
cc_1427 ( N_Q_c_1653_p N_noxref_13_c_3383_n ) capacitor c=0.00126834f \
 //x=18.095 //y=4.885 //x2=17.93 //y2=5.56
cc_1428 ( N_Q_M29_noxref_g N_noxref_13_c_3383_n ) capacitor c=0.0483843f \
 //x=18.15 //y=6.205 //x2=17.93 //y2=5.56
cc_1429 ( N_Q_c_1671_p N_noxref_13_c_3383_n ) capacitor c=0.00297041f \
 //x=18.095 //y=4.885 //x2=17.93 //y2=5.56
cc_1430 ( N_Q_M30_noxref_g N_noxref_13_c_3387_n ) capacitor c=0.0170175f \
 //x=18.59 //y=6.205 //x2=18.81 //y2=5.56
cc_1431 ( N_Q_M29_noxref_g N_noxref_13_M29_noxref_s ) capacitor c=0.00378422f \
 //x=18.15 //y=6.205 //x2=17.795 //y2=5.205
cc_1432 ( N_noxref_8_c_1920_n N_noxref_9_c_2181_n ) capacitor c=0.00335545f \
 //x=13.07 //y=4.105 //x2=15.66 //y2=3.72
cc_1433 ( N_noxref_8_c_1971_n N_noxref_9_c_2183_n ) capacitor c=0.0053236f \
 //x=18.83 //y=4.257 //x2=15.66 //y2=4.025
cc_1434 ( N_noxref_8_c_2025_n N_noxref_9_c_2245_n ) capacitor c=0.00120307f \
 //x=19.025 //y=1.74 //x2=18.32 //y2=1.75
cc_1435 ( N_noxref_8_c_1990_n N_noxref_9_c_2252_n ) capacitor c=0.00168563f \
 //x=18.99 //y=4.41 //x2=19.205 //y2=1.835
cc_1436 ( N_noxref_8_c_1994_n N_noxref_9_c_2252_n ) capacitor c=0.0305386f \
 //x=18.99 //y=2.26 //x2=19.205 //y2=1.835
cc_1437 ( N_noxref_8_c_2009_n N_noxref_9_c_2252_n ) capacitor c=0.00491852f \
 //x=18.99 //y=2.26 //x2=19.205 //y2=1.835
cc_1438 ( N_noxref_8_c_2030_n N_noxref_9_c_2252_n ) capacitor c=0.00147817f \
 //x=18.99 //y=2.26 //x2=19.205 //y2=1.835
cc_1439 ( N_noxref_8_c_2033_n N_noxref_9_c_2252_n ) capacitor c=0.00817459f \
 //x=18.99 //y=2.095 //x2=19.205 //y2=1.835
cc_1440 ( N_noxref_8_c_2020_n N_noxref_9_c_2336_n ) capacitor c=0.00112851f \
 //x=19.025 //y=1.085 //x2=19.29 //y2=1.3
cc_1441 ( N_noxref_8_c_2022_n N_noxref_9_c_2336_n ) capacitor c=0.0021447f \
 //x=19.025 //y=1.435 //x2=19.29 //y2=1.3
cc_1442 ( N_noxref_8_c_2049_p N_noxref_9_c_2336_n ) capacitor c=5.32053e-19 \
 //x=19.4 //y=0.93 //x2=19.29 //y2=1.3
cc_1443 ( N_noxref_8_c_2027_n N_noxref_9_c_2336_n ) capacitor c=5.60411e-19 \
 //x=19.4 //y=1.585 //x2=19.29 //y2=1.3
cc_1444 ( N_noxref_8_c_2028_n N_noxref_9_c_2336_n ) capacitor c=8.66912e-19 \
 //x=19.555 //y=1.085 //x2=19.29 //y2=1.3
cc_1445 ( N_noxref_8_c_2029_n N_noxref_9_c_2336_n ) capacitor c=0.00377102f \
 //x=19.555 //y=1.435 //x2=19.29 //y2=1.3
cc_1446 ( N_noxref_8_c_2022_n N_noxref_9_c_2259_n ) capacitor c=7.7986e-19 \
 //x=19.025 //y=1.435 //x2=19.29 //y2=1.75
cc_1447 ( N_noxref_8_c_2025_n N_noxref_9_c_2259_n ) capacitor c=0.00364979f \
 //x=19.025 //y=1.74 //x2=19.29 //y2=1.75
cc_1448 ( N_noxref_8_c_2027_n N_noxref_9_c_2259_n ) capacitor c=0.0100338f \
 //x=19.4 //y=1.585 //x2=19.29 //y2=1.75
cc_1449 ( N_noxref_8_c_2029_n N_noxref_9_c_2259_n ) capacitor c=0.00135417f \
 //x=19.555 //y=1.435 //x2=19.29 //y2=1.75
cc_1450 ( N_noxref_8_M32_noxref_g N_noxref_9_c_2346_n ) capacitor c=0.0104981f \
 //x=19.47 //y=6.205 //x2=19.645 //y2=5.39
cc_1451 ( N_noxref_8_c_2027_n N_noxref_9_c_2347_n ) capacitor c=0.00500113f \
 //x=19.4 //y=1.585 //x2=19.645 //y2=1.835
cc_1452 ( N_noxref_8_c_1982_n N_noxref_9_c_2261_n ) capacitor c=0.0613563f \
 //x=18.99 //y=4.105 //x2=19.73 //y2=3.74
cc_1453 ( N_noxref_8_c_1994_n N_noxref_9_c_2261_n ) capacitor c=0.0160491f \
 //x=18.99 //y=2.26 //x2=19.73 //y2=3.74
cc_1454 ( N_noxref_8_c_2009_n N_noxref_9_c_2261_n ) capacitor c=0.0043954f \
 //x=18.99 //y=2.26 //x2=19.73 //y2=3.74
cc_1455 ( N_noxref_8_c_2030_n N_noxref_9_c_2261_n ) capacitor c=0.0028062f \
 //x=18.99 //y=2.26 //x2=19.73 //y2=3.74
cc_1456 ( N_noxref_8_c_2033_n N_noxref_9_c_2261_n ) capacitor c=0.00311553f \
 //x=18.99 //y=2.095 //x2=19.73 //y2=3.74
cc_1457 ( N_noxref_8_c_1982_n N_noxref_9_c_2353_n ) capacitor c=0.0171096f \
 //x=18.99 //y=4.105 //x2=19.73 //y2=4.045
cc_1458 ( N_noxref_8_c_2065_p N_noxref_9_c_2353_n ) capacitor c=0.00127346f \
 //x=19.395 //y=4.975 //x2=19.73 //y2=4.045
cc_1459 ( N_noxref_8_c_1982_n N_noxref_9_c_2263_n ) capacitor c=0.00267122f \
 //x=18.99 //y=4.105 //x2=19.73 //y2=5.305
cc_1460 ( N_noxref_8_c_1990_n N_noxref_9_c_2263_n ) capacitor c=0.0143283f \
 //x=18.99 //y=4.41 //x2=19.73 //y2=5.305
cc_1461 ( N_noxref_8_c_1993_n N_noxref_9_c_2263_n ) capacitor c=0.00474294f \
 //x=18.99 //y=4.25 //x2=19.73 //y2=5.305
cc_1462 ( N_noxref_8_c_1997_n N_noxref_9_c_2263_n ) capacitor c=0.0175188f \
 //x=19.025 //y=4.885 //x2=19.73 //y2=5.305
cc_1463 ( N_noxref_8_c_2000_n N_noxref_9_c_2263_n ) capacitor c=0.0144163f \
 //x=19.025 //y=4.74 //x2=19.73 //y2=5.305
cc_1464 ( N_noxref_8_c_2002_n N_noxref_9_c_2263_n ) capacitor c=0.00654092f \
 //x=18.99 //y=4.25 //x2=19.73 //y2=5.305
cc_1465 ( N_noxref_8_c_2013_n N_noxref_9_c_2263_n ) capacitor c=0.00454427f \
 //x=19.025 //y=4.885 //x2=19.73 //y2=5.305
cc_1466 ( N_noxref_8_c_2065_p N_noxref_9_c_2263_n ) capacitor c=0.00852293f \
 //x=19.395 //y=4.975 //x2=19.73 //y2=5.305
cc_1467 ( N_noxref_8_c_2034_n N_noxref_9_c_2263_n ) capacitor c=0.00141757f \
 //x=19.025 //y=4.885 //x2=19.73 //y2=5.305
cc_1468 ( N_noxref_8_c_1971_n N_noxref_9_c_2189_n ) capacitor c=0.00266476f \
 //x=18.83 //y=4.257 //x2=15.695 //y2=4.885
cc_1469 ( N_noxref_8_c_1932_n N_noxref_9_c_2192_n ) capacitor c=0.00168616f \
 //x=13.07 //y=5.055 //x2=15.695 //y2=4.74
cc_1470 ( N_noxref_8_c_1971_n N_noxref_9_c_2192_n ) capacitor c=0.0242764f \
 //x=18.83 //y=4.257 //x2=15.695 //y2=4.74
cc_1471 ( N_noxref_8_c_1997_n N_noxref_9_c_2273_n ) capacitor c=0.00198722f \
 //x=19.025 //y=4.885 //x2=19.245 //y2=5.39
cc_1472 ( N_noxref_8_M31_noxref_g N_noxref_9_c_2273_n ) capacitor \
 c=0.00184899f //x=19.03 //y=6.205 //x2=19.245 //y2=5.39
cc_1473 ( N_noxref_8_M32_noxref_g N_noxref_9_c_2273_n ) capacitor \
 c=0.00339097f //x=19.47 //y=6.205 //x2=19.245 //y2=5.39
cc_1474 ( N_noxref_8_c_2065_p N_noxref_9_c_2273_n ) capacitor c=0.00213157f \
 //x=19.395 //y=4.975 //x2=19.245 //y2=5.39
cc_1475 ( N_noxref_8_c_1982_n N_noxref_9_c_2371_n ) capacitor c=0.00103412f \
 //x=18.99 //y=4.105 //x2=19.73 //y2=3.88
cc_1476 ( N_noxref_8_c_1971_n N_noxref_9_c_2195_n ) capacitor c=0.0374339f \
 //x=18.83 //y=4.257 //x2=15.82 //y2=3.872
cc_1477 ( N_noxref_8_c_1982_n N_noxref_9_c_2373_n ) capacitor c=0.00296083f \
 //x=18.99 //y=4.105 //x2=19.725 //y2=3.885
cc_1478 ( N_noxref_8_c_1982_n N_noxref_9_c_2276_n ) capacitor c=0.0244465f \
 //x=18.99 //y=4.105 //x2=19.565 //y2=3.892
cc_1479 ( N_noxref_8_c_1990_n N_noxref_9_c_2276_n ) capacitor c=0.00615333f \
 //x=18.99 //y=4.41 //x2=19.565 //y2=3.892
cc_1480 ( N_noxref_8_c_1994_n N_noxref_9_c_2276_n ) capacitor c=0.00226111f \
 //x=18.99 //y=2.26 //x2=19.565 //y2=3.892
cc_1481 ( N_noxref_8_c_2002_n N_noxref_9_c_2276_n ) capacitor c=0.0374339f \
 //x=18.99 //y=4.25 //x2=19.565 //y2=3.892
cc_1482 ( N_noxref_8_c_1971_n N_noxref_9_c_2276_n ) capacitor c=0.272844f \
 //x=18.83 //y=4.257 //x2=19.565 //y2=3.892
cc_1483 ( N_noxref_8_M31_noxref_g N_noxref_9_c_2379_n ) capacitor c=0.0120591f \
 //x=19.03 //y=6.205 //x2=19.25 //y2=5.56
cc_1484 ( N_noxref_8_M32_noxref_g N_noxref_9_c_2379_n ) capacitor c=0.0140704f \
 //x=19.47 //y=6.205 //x2=19.25 //y2=5.56
cc_1485 ( N_noxref_8_c_2065_p N_noxref_9_c_2379_n ) capacitor c=0.00293135f \
 //x=19.395 //y=4.975 //x2=19.25 //y2=5.56
cc_1486 ( N_noxref_8_c_2020_n N_noxref_9_M10_noxref_d ) capacitor \
 c=0.00218694f //x=19.025 //y=1.085 //x2=19.1 //y2=1.085
cc_1487 ( N_noxref_8_c_2022_n N_noxref_9_M10_noxref_d ) capacitor \
 c=0.00237422f //x=19.025 //y=1.435 //x2=19.1 //y2=1.085
cc_1488 ( N_noxref_8_c_2049_p N_noxref_9_M10_noxref_d ) capacitor \
 c=0.00213893f //x=19.4 //y=0.93 //x2=19.1 //y2=1.085
cc_1489 ( N_noxref_8_c_2027_n N_noxref_9_M10_noxref_d ) capacitor \
 c=0.00357974f //x=19.4 //y=1.585 //x2=19.1 //y2=1.085
cc_1490 ( N_noxref_8_c_2028_n N_noxref_9_M10_noxref_d ) capacitor c=0.0012513f \
 //x=19.555 //y=1.085 //x2=19.1 //y2=1.085
cc_1491 ( N_noxref_8_c_2029_n N_noxref_9_M10_noxref_d ) capacitor \
 c=0.00237422f //x=19.555 //y=1.435 //x2=19.1 //y2=1.085
cc_1492 ( N_noxref_8_c_1909_n N_VDD_c_2464_n ) capacitor c=0.00259721f \
 //x=12.705 //y=5.42 //x2=14.955 //y2=7.585
cc_1493 ( N_noxref_8_c_1916_n N_VDD_c_2464_n ) capacitor c=0.00266629f \
 //x=12.985 //y=5.14 //x2=14.955 //y2=7.585
cc_1494 ( N_noxref_8_c_1948_n N_VDD_c_2464_n ) capacitor c=0.00241566f \
 //x=12.705 //y=5.56 //x2=14.955 //y2=7.585
cc_1495 ( N_noxref_8_c_1909_n N_VDD_c_2638_n ) capacitor c=8.96756e-19 \
 //x=12.705 //y=5.42 //x2=13.06 //y2=7.585
cc_1496 ( N_noxref_8_c_1916_n N_VDD_c_2638_n ) capacitor c=0.0019409f \
 //x=12.985 //y=5.14 //x2=13.06 //y2=7.585
cc_1497 ( N_noxref_8_c_1948_n N_VDD_c_2638_n ) capacitor c=0.0138017f \
 //x=12.705 //y=5.56 //x2=13.06 //y2=7.585
cc_1498 ( N_noxref_8_c_1993_n N_VDD_c_2723_n ) capacitor c=0.00143077f \
 //x=18.99 //y=4.25 //x2=19.73 //y2=7.58
cc_1499 ( N_noxref_8_c_2013_n N_VDD_c_2723_n ) capacitor c=0.00231379f \
 //x=19.025 //y=4.885 //x2=19.73 //y2=7.58
cc_1500 ( N_noxref_8_M31_noxref_g N_VDD_c_2723_n ) capacitor c=0.00724816f \
 //x=19.03 //y=6.205 //x2=19.73 //y2=7.58
cc_1501 ( N_noxref_8_M32_noxref_g N_VDD_c_2723_n ) capacitor c=0.00782837f \
 //x=19.47 //y=6.205 //x2=19.73 //y2=7.58
cc_1502 ( N_noxref_8_c_2065_p N_VDD_c_2723_n ) capacitor c=0.0258764f \
 //x=19.395 //y=4.975 //x2=19.73 //y2=7.58
cc_1503 ( N_noxref_8_c_2034_n N_VDD_c_2723_n ) capacitor c=2.75092e-19 \
 //x=19.025 //y=4.885 //x2=19.73 //y2=7.58
cc_1504 ( N_noxref_8_c_1917_n N_VDD_c_2600_n ) capacitor c=0.00464635f \
 //x=12.79 //y=5.14 //x2=11.59 //y2=7.585
cc_1505 ( N_noxref_8_c_1901_n N_VDD_c_2600_n ) capacitor c=0.00143077f \
 //x=13.07 //y=4.25 //x2=11.59 //y2=7.585
cc_1506 ( N_noxref_8_c_1948_n N_VDD_c_2600_n ) capacitor c=0.00820745f \
 //x=12.705 //y=5.56 //x2=11.59 //y2=7.585
cc_1507 ( N_noxref_8_c_1909_n N_VDD_c_2652_n ) capacitor c=0.00233135f \
 //x=12.705 //y=5.42 //x2=13.81 //y2=7.585
cc_1508 ( N_noxref_8_c_1930_n N_VDD_c_2652_n ) capacitor c=0.00178791f \
 //x=13.07 //y=4.41 //x2=13.81 //y2=7.585
cc_1509 ( N_noxref_8_c_1932_n N_VDD_c_2652_n ) capacitor c=0.0192973f \
 //x=13.07 //y=5.055 //x2=13.81 //y2=7.585
cc_1510 ( N_noxref_8_c_1901_n N_VDD_c_2652_n ) capacitor c=0.00491003f \
 //x=13.07 //y=4.25 //x2=13.81 //y2=7.585
cc_1511 ( N_noxref_8_c_1971_n N_VDD_c_2652_n ) capacitor c=0.0191057f \
 //x=18.83 //y=4.257 //x2=13.81 //y2=7.585
cc_1512 ( N_noxref_8_c_1948_n N_VDD_c_2652_n ) capacitor c=0.00821732f \
 //x=12.705 //y=5.56 //x2=13.81 //y2=7.585
cc_1513 ( N_noxref_8_c_1993_n N_VDD_c_2700_n ) capacitor c=8.4651e-19 \
 //x=18.99 //y=4.25 //x2=17.14 //y2=7.585
cc_1514 ( N_noxref_8_c_1971_n N_VDD_c_2700_n ) capacitor c=0.0196019f \
 //x=18.83 //y=4.257 //x2=17.14 //y2=7.585
cc_1515 ( N_noxref_8_c_1909_n N_VDD_M19_noxref_s ) capacitor c=2.62188e-19 \
 //x=12.705 //y=5.42 //x2=8.915 //y2=5.2
cc_1516 ( N_noxref_8_c_1909_n N_VDD_M23_noxref_s ) capacitor c=0.0465774f \
 //x=12.705 //y=5.42 //x2=12.13 //y2=5.2
cc_1517 ( N_noxref_8_c_1948_n N_VDD_M23_noxref_s ) capacitor c=0.0897769f \
 //x=12.705 //y=5.56 //x2=12.13 //y2=5.2
cc_1518 ( N_noxref_8_c_1909_n N_VDD_M24_noxref_d ) capacitor c=0.0474638f \
 //x=12.705 //y=5.42 //x2=13 //y2=5.2
cc_1519 ( N_noxref_8_c_1916_n N_VDD_M24_noxref_d ) capacitor c=0.0201557f \
 //x=12.985 //y=5.14 //x2=13 //y2=5.2
cc_1520 ( N_noxref_8_c_1930_n N_VDD_M24_noxref_d ) capacitor c=0.00435213f \
 //x=13.07 //y=4.41 //x2=13 //y2=5.2
cc_1521 ( N_noxref_8_c_1901_n N_VDD_M24_noxref_d ) capacitor c=0.00163743f \
 //x=13.07 //y=4.25 //x2=13 //y2=5.2
cc_1522 ( N_noxref_8_c_1947_n N_VDD_M24_noxref_d ) capacitor c=0.00115989f \
 //x=13.23 //y=4.257 //x2=13 //y2=5.2
cc_1523 ( N_noxref_8_c_1971_n N_VDD_M24_noxref_d ) capacitor c=4.80798e-19 \
 //x=18.83 //y=4.257 //x2=13 //y2=5.2
cc_1524 ( N_noxref_8_c_1948_n N_VDD_M24_noxref_d ) capacitor c=0.0904512f \
 //x=12.705 //y=5.56 //x2=13 //y2=5.2
cc_1525 ( N_noxref_8_c_1913_n N_GND_c_2995_n ) capacitor c=0.00499609f \
 //x=12.985 //y=2.02 //x2=19.73 //y2=0.18
cc_1526 ( N_noxref_8_c_1930_n N_GND_c_2995_n ) capacitor c=4.35733e-19 \
 //x=13.07 //y=4.41 //x2=19.73 //y2=0.18
cc_1527 ( N_noxref_8_c_1937_n N_GND_c_2995_n ) capacitor c=0.00998676f \
 //x=12.7 //y=1.185 //x2=19.73 //y2=0.18
cc_1528 ( N_noxref_8_M6_noxref_d N_GND_c_2995_n ) capacitor c=0.00119455f \
 //x=12.515 //y=1.09 //x2=19.73 //y2=0.18
cc_1529 ( N_noxref_8_c_1937_n N_GND_c_3034_n ) capacitor c=0.00124813f \
 //x=12.7 //y=1.185 //x2=12.615 //y2=0.715
cc_1530 ( N_noxref_8_c_1913_n N_GND_c_3038_n ) capacitor c=0.00311091f \
 //x=12.985 //y=2.02 //x2=13.105 //y2=0.715
cc_1531 ( N_noxref_8_c_1937_n N_GND_c_3038_n ) capacitor c=0.00130539f \
 //x=12.7 //y=1.185 //x2=13.105 //y2=0.715
cc_1532 ( N_noxref_8_c_1901_n N_GND_c_3038_n ) capacitor c=2.04781e-19 \
 //x=13.07 //y=4.25 //x2=13.105 //y2=0.715
cc_1533 ( N_noxref_8_c_1994_n N_GND_c_3151_n ) capacitor c=3.09398e-19 \
 //x=18.99 //y=2.26 //x2=19.69 //y2=0.71
cc_1534 ( N_noxref_8_c_2009_n N_GND_c_3151_n ) capacitor c=8.64363e-19 \
 //x=18.99 //y=2.26 //x2=19.69 //y2=0.71
cc_1535 ( N_noxref_8_c_2020_n N_GND_c_3151_n ) capacitor c=0.0210318f \
 //x=19.025 //y=1.085 //x2=19.69 //y2=0.71
cc_1536 ( N_noxref_8_c_2028_n N_GND_c_3151_n ) capacitor c=0.00825432f \
 //x=19.555 //y=1.085 //x2=19.69 //y2=0.71
cc_1537 ( N_noxref_8_c_2030_n N_GND_c_3151_n ) capacitor c=2.1838e-19 \
 //x=18.99 //y=2.26 //x2=19.69 //y2=0.71
cc_1538 ( N_noxref_8_c_1902_n N_GND_c_3010_n ) capacitor c=0.00272952f \
 //x=12.7 //y=1.935 //x2=11.59 //y2=0.175
cc_1539 ( N_noxref_8_c_1913_n N_GND_c_3048_n ) capacitor c=0.023022f \
 //x=12.985 //y=2.02 //x2=13.81 //y2=0.175
cc_1540 ( N_noxref_8_c_1937_n N_GND_c_2905_n ) capacitor c=2.8029e-19 //x=12.7 \
 //y=1.185 //x2=19.73 //y2=0.18
cc_1541 ( N_noxref_8_c_2009_n N_GND_c_2905_n ) capacitor c=0.00224736f \
 //x=18.99 //y=2.26 //x2=19.73 //y2=0.18
cc_1542 ( N_noxref_8_c_2027_n N_GND_c_2905_n ) capacitor c=0.00300407f \
 //x=19.4 //y=1.585 //x2=19.73 //y2=0.18
cc_1543 ( N_noxref_8_c_2030_n N_GND_c_2905_n ) capacitor c=2.63786e-19 \
 //x=18.99 //y=2.26 //x2=19.73 //y2=0.18
cc_1544 ( N_noxref_8_c_1902_n N_GND_M6_noxref_s ) capacitor c=0.0287657f \
 //x=12.7 //y=1.935 //x2=12.085 //y2=0.55
cc_1545 ( N_noxref_8_c_1913_n N_GND_M6_noxref_s ) capacitor c=0.0042252f \
 //x=12.985 //y=2.02 //x2=12.085 //y2=0.55
cc_1546 ( N_noxref_8_c_1930_n N_GND_M6_noxref_s ) capacitor c=8.08732e-19 \
 //x=13.07 //y=4.41 //x2=12.085 //y2=0.55
cc_1547 ( N_noxref_8_c_1937_n N_GND_M6_noxref_s ) capacitor c=0.0139466f \
 //x=12.7 //y=1.185 //x2=12.085 //y2=0.55
cc_1548 ( N_noxref_8_c_1901_n N_GND_M6_noxref_s ) capacitor c=4.73387e-19 \
 //x=13.07 //y=4.25 //x2=12.085 //y2=0.55
cc_1549 ( N_noxref_8_M6_noxref_d N_GND_M6_noxref_s ) capacitor c=0.0377642f \
 //x=12.515 //y=1.09 //x2=12.085 //y2=0.55
cc_1550 ( N_noxref_8_c_2020_n N_GND_M9_noxref_s ) capacitor c=0.00720961f \
 //x=19.025 //y=1.085 //x2=17.7 //y2=0.545
cc_1551 ( N_noxref_8_c_2027_n N_GND_M9_noxref_s ) capacitor c=0.00271091f \
 //x=19.4 //y=1.585 //x2=17.7 //y2=0.545
cc_1552 ( N_noxref_8_c_2028_n N_GND_M9_noxref_s ) capacitor c=0.0151996f \
 //x=19.555 //y=1.085 //x2=17.7 //y2=0.545
cc_1553 ( N_noxref_8_c_2030_n N_GND_M9_noxref_s ) capacitor c=0.00119136f \
 //x=18.99 //y=2.26 //x2=17.7 //y2=0.545
cc_1554 ( N_noxref_8_c_1971_n N_noxref_12_c_3273_n ) capacitor c=0.0162019f \
 //x=18.83 //y=4.257 //x2=15.36 //y2=5.39
cc_1555 ( N_noxref_8_c_1909_n N_noxref_12_c_3279_n ) capacitor c=0.00174649f \
 //x=12.705 //y=5.42 //x2=14.6 //y2=5.39
cc_1556 ( N_noxref_8_c_1971_n N_noxref_12_c_3279_n ) capacitor c=0.00338679f \
 //x=18.83 //y=4.257 //x2=14.6 //y2=5.39
cc_1557 ( N_noxref_8_c_1971_n N_noxref_13_c_3368_n ) capacitor c=0.0141459f \
 //x=18.83 //y=4.257 //x2=18.69 //y2=5.39
cc_1558 ( N_noxref_8_c_1997_n N_noxref_13_c_3390_n ) capacitor c=0.00213672f \
 //x=19.025 //y=4.885 //x2=19.56 //y2=7.09
cc_1559 ( N_noxref_8_c_2013_n N_noxref_13_c_3390_n ) capacitor c=0.00233585f \
 //x=19.025 //y=4.885 //x2=19.56 //y2=7.09
cc_1560 ( N_noxref_8_M31_noxref_g N_noxref_13_c_3390_n ) capacitor \
 c=0.00777443f //x=19.03 //y=6.205 //x2=19.56 //y2=7.09
cc_1561 ( N_noxref_8_M32_noxref_g N_noxref_13_c_3390_n ) capacitor \
 c=0.0093887f //x=19.47 //y=6.205 //x2=19.56 //y2=7.09
cc_1562 ( N_noxref_8_c_1971_n N_noxref_13_c_3375_n ) capacitor c=0.00365089f \
 //x=18.83 //y=4.257 //x2=17.93 //y2=5.39
cc_1563 ( N_noxref_8_c_1990_n N_noxref_13_c_3381_n ) capacitor c=0.00547103f \
 //x=18.99 //y=4.41 //x2=18.81 //y2=5.39
cc_1564 ( N_noxref_8_c_1997_n N_noxref_13_c_3381_n ) capacitor c=0.00257222f \
 //x=19.025 //y=4.885 //x2=18.81 //y2=5.39
cc_1565 ( N_noxref_8_c_2002_n N_noxref_13_c_3381_n ) capacitor c=0.00119074f \
 //x=18.99 //y=4.25 //x2=18.81 //y2=5.39
cc_1566 ( N_noxref_8_c_1971_n N_noxref_13_c_3381_n ) capacitor c=0.00157613f \
 //x=18.83 //y=4.257 //x2=18.81 //y2=5.39
cc_1567 ( N_noxref_8_M31_noxref_g N_noxref_13_c_3381_n ) capacitor \
 c=0.00176767f //x=19.03 //y=6.205 //x2=18.81 //y2=5.39
cc_1568 ( N_noxref_8_c_2034_n N_noxref_13_c_3381_n ) capacitor c=5.54604e-19 \
 //x=19.025 //y=4.885 //x2=18.81 //y2=5.39
cc_1569 ( N_noxref_8_M31_noxref_g N_noxref_13_c_3382_n ) capacitor \
 c=0.00186228f //x=19.03 //y=6.205 //x2=18.81 //y2=6.92
cc_1570 ( N_noxref_8_M32_noxref_g N_noxref_13_c_3402_n ) capacitor \
 c=0.00410728f //x=19.47 //y=6.205 //x2=19.69 //y2=6.92
cc_1571 ( N_noxref_8_c_1990_n N_noxref_13_c_3387_n ) capacitor c=0.00152856f \
 //x=18.99 //y=4.41 //x2=18.81 //y2=5.56
cc_1572 ( N_noxref_8_M31_noxref_g N_noxref_13_c_3387_n ) capacitor \
 c=0.0170175f //x=19.03 //y=6.205 //x2=18.81 //y2=5.56
cc_1573 ( N_noxref_8_M32_noxref_g N_noxref_13_M32_noxref_d ) capacitor \
 c=0.0365939f //x=19.47 //y=6.205 //x2=19.545 //y2=5.205
cc_1574 ( N_noxref_9_c_2346_n N_VDD_c_2774_n ) capacitor c=2.90144e-19 \
 //x=19.645 //y=5.39 //x2=19.73 //y2=7.58
cc_1575 ( N_noxref_9_M27_noxref_g N_VDD_c_2686_n ) capacitor c=0.00724816f \
 //x=15.7 //y=6.205 //x2=16.97 //y2=7.585
cc_1576 ( N_noxref_9_M28_noxref_g N_VDD_c_2686_n ) capacitor c=0.00782837f \
 //x=16.14 //y=6.205 //x2=16.97 //y2=7.585
cc_1577 ( N_noxref_9_c_2346_n N_VDD_c_2723_n ) capacitor c=6.92778e-19 \
 //x=19.645 //y=5.39 //x2=19.73 //y2=7.58
cc_1578 ( N_noxref_9_c_2263_n N_VDD_c_2723_n ) capacitor c=0.0373567f \
 //x=19.73 //y=5.305 //x2=19.73 //y2=7.58
cc_1579 ( N_noxref_9_c_2273_n N_VDD_c_2723_n ) capacitor c=0.00422052f \
 //x=19.245 //y=5.39 //x2=19.73 //y2=7.58
cc_1580 ( N_noxref_9_c_2379_n N_VDD_c_2723_n ) capacitor c=0.0143677f \
 //x=19.25 //y=5.56 //x2=19.73 //y2=7.58
cc_1581 ( N_noxref_9_c_2263_n N_VDD_c_2700_n ) capacitor c=0.00144046f \
 //x=19.73 //y=5.305 //x2=17.14 //y2=7.585
cc_1582 ( N_noxref_9_c_2201_n N_VDD_c_2700_n ) capacitor c=0.00231379f \
 //x=15.695 //y=4.885 //x2=17.14 //y2=7.585
cc_1583 ( N_noxref_9_c_2300_n N_VDD_c_2700_n ) capacitor c=0.016784f \
 //x=16.065 //y=4.975 //x2=17.14 //y2=7.585
cc_1584 ( N_noxref_9_c_2222_n N_VDD_c_2700_n ) capacitor c=2.75092e-19 \
 //x=15.695 //y=4.885 //x2=17.14 //y2=7.585
cc_1585 ( N_noxref_9_c_2379_n N_VDD_M29_noxref_d ) capacitor c=0.00561178f \
 //x=19.25 //y=5.56 //x2=18.225 //y2=5.205
cc_1586 ( N_noxref_9_c_2236_n N_GND_c_2995_n ) capacitor c=0.00990085f \
 //x=18.32 //y=1.305 //x2=19.73 //y2=0.18
cc_1587 ( N_noxref_9_c_2252_n N_GND_c_2995_n ) capacitor c=0.00677787f \
 //x=19.205 //y=1.835 //x2=19.73 //y2=0.18
cc_1588 ( N_noxref_9_c_2336_n N_GND_c_2995_n ) capacitor c=0.0106318f \
 //x=19.29 //y=1.3 //x2=19.73 //y2=0.18
cc_1589 ( N_noxref_9_c_2347_n N_GND_c_2995_n ) capacitor c=0.00667117f \
 //x=19.645 //y=1.835 //x2=19.73 //y2=0.18
cc_1590 ( N_noxref_9_M9_noxref_d N_GND_c_2995_n ) capacitor c=3.01769e-19 \
 //x=18.13 //y=1.085 //x2=19.73 //y2=0.18
cc_1591 ( N_noxref_9_M10_noxref_d N_GND_c_2995_n ) capacitor c=3.01769e-19 \
 //x=19.1 //y=1.085 //x2=19.73 //y2=0.18
cc_1592 ( N_noxref_9_c_2186_n N_GND_c_3111_n ) capacitor c=3.09398e-19 \
 //x=15.66 //y=2.26 //x2=16.36 //y2=0.71
cc_1593 ( N_noxref_9_c_2197_n N_GND_c_3111_n ) capacitor c=8.64363e-19 \
 //x=15.66 //y=2.26 //x2=16.36 //y2=0.71
cc_1594 ( N_noxref_9_c_2208_n N_GND_c_3111_n ) capacitor c=0.0211076f \
 //x=15.695 //y=1.085 //x2=16.36 //y2=0.71
cc_1595 ( N_noxref_9_c_2216_n N_GND_c_3111_n ) capacitor c=0.00825432f \
 //x=16.225 //y=1.085 //x2=16.36 //y2=0.71
cc_1596 ( N_noxref_9_c_2218_n N_GND_c_3111_n ) capacitor c=2.1838e-19 \
 //x=15.66 //y=2.26 //x2=16.36 //y2=0.71
cc_1597 ( N_noxref_9_c_2236_n N_GND_c_3115_n ) capacitor c=0.00373729f \
 //x=18.32 //y=1.305 //x2=18.72 //y2=0.71
cc_1598 ( N_noxref_9_c_2252_n N_GND_c_3115_n ) capacitor c=0.00128856f \
 //x=19.205 //y=1.835 //x2=18.72 //y2=0.71
cc_1599 ( N_noxref_9_M9_noxref_d N_GND_c_3115_n ) capacitor c=0.0122548f \
 //x=18.13 //y=1.085 //x2=18.72 //y2=0.71
cc_1600 ( N_noxref_9_c_2252_n N_GND_c_3151_n ) capacitor c=0.00128298f \
 //x=19.205 //y=1.835 //x2=19.69 //y2=0.71
cc_1601 ( N_noxref_9_c_2336_n N_GND_c_3151_n ) capacitor c=0.00469733f \
 //x=19.29 //y=1.3 //x2=19.69 //y2=0.71
cc_1602 ( N_noxref_9_c_2347_n N_GND_c_3151_n ) capacitor c=0.00369882f \
 //x=19.645 //y=1.835 //x2=19.69 //y2=0.71
cc_1603 ( N_noxref_9_M10_noxref_d N_GND_c_3151_n ) capacitor c=0.0122548f \
 //x=19.1 //y=1.085 //x2=19.69 //y2=0.71
cc_1604 ( N_noxref_9_c_2261_n N_GND_c_3122_n ) capacitor c=0.00121611f \
 //x=19.73 //y=3.74 //x2=17.14 //y2=0.175
cc_1605 ( N_noxref_9_c_2197_n N_GND_c_3122_n ) capacitor c=0.00231028f \
 //x=15.66 //y=2.26 //x2=17.14 //y2=0.175
cc_1606 ( N_noxref_9_c_2215_n N_GND_c_3122_n ) capacitor c=0.0028635f \
 //x=16.07 //y=1.585 //x2=17.14 //y2=0.175
cc_1607 ( N_noxref_9_c_2259_n N_GND_c_2905_n ) capacitor c=0.00532028f \
 //x=19.29 //y=1.75 //x2=19.73 //y2=0.18
cc_1608 ( N_noxref_9_c_2347_n N_GND_c_2905_n ) capacitor c=0.0385015f \
 //x=19.645 //y=1.835 //x2=19.73 //y2=0.18
cc_1609 ( N_noxref_9_c_2208_n N_GND_M7_noxref_s ) capacitor c=0.00720961f \
 //x=15.695 //y=1.085 //x2=14.37 //y2=0.545
cc_1610 ( N_noxref_9_c_2215_n N_GND_M7_noxref_s ) capacitor c=0.00271091f \
 //x=16.07 //y=1.585 //x2=14.37 //y2=0.545
cc_1611 ( N_noxref_9_c_2216_n N_GND_M7_noxref_s ) capacitor c=0.0151996f \
 //x=16.225 //y=1.085 //x2=14.37 //y2=0.545
cc_1612 ( N_noxref_9_c_2218_n N_GND_M7_noxref_s ) capacitor c=0.00119136f \
 //x=15.66 //y=2.26 //x2=14.37 //y2=0.545
cc_1613 ( N_noxref_9_c_2236_n N_GND_M9_noxref_s ) capacitor c=0.00922375f \
 //x=18.32 //y=1.305 //x2=17.7 //y2=0.545
cc_1614 ( N_noxref_9_c_2245_n N_GND_M9_noxref_s ) capacitor c=0.0225586f \
 //x=18.32 //y=1.75 //x2=17.7 //y2=0.545
cc_1615 ( N_noxref_9_c_2252_n N_GND_M9_noxref_s ) capacitor c=0.00756761f \
 //x=19.205 //y=1.835 //x2=17.7 //y2=0.545
cc_1616 ( N_noxref_9_c_2336_n N_GND_M9_noxref_s ) capacitor c=0.0110093f \
 //x=19.29 //y=1.3 //x2=17.7 //y2=0.545
cc_1617 ( N_noxref_9_c_2259_n N_GND_M9_noxref_s ) capacitor c=0.0124822f \
 //x=19.29 //y=1.75 //x2=17.7 //y2=0.545
cc_1618 ( N_noxref_9_c_2347_n N_GND_M9_noxref_s ) capacitor c=0.00737383f \
 //x=19.645 //y=1.835 //x2=17.7 //y2=0.545
cc_1619 ( N_noxref_9_c_2353_n N_GND_M9_noxref_s ) capacitor c=2.62161e-19 \
 //x=19.73 //y=4.045 //x2=17.7 //y2=0.545
cc_1620 ( N_noxref_9_c_2371_n N_GND_M9_noxref_s ) capacitor c=8.54723e-19 \
 //x=19.73 //y=3.88 //x2=17.7 //y2=0.545
cc_1621 ( N_noxref_9_M9_noxref_d N_GND_M9_noxref_s ) capacitor c=0.0297221f \
 //x=18.13 //y=1.085 //x2=17.7 //y2=0.545
cc_1622 ( N_noxref_9_M10_noxref_d N_GND_M9_noxref_s ) capacitor c=0.029747f \
 //x=19.1 //y=1.085 //x2=17.7 //y2=0.545
cc_1623 ( N_noxref_9_c_2189_n N_noxref_12_c_3292_n ) capacitor c=0.00213686f \
 //x=15.695 //y=4.885 //x2=16.23 //y2=7.09
cc_1624 ( N_noxref_9_c_2201_n N_noxref_12_c_3292_n ) capacitor c=0.00233585f \
 //x=15.695 //y=4.885 //x2=16.23 //y2=7.09
cc_1625 ( N_noxref_9_M27_noxref_g N_noxref_12_c_3292_n ) capacitor \
 c=0.00777443f //x=15.7 //y=6.205 //x2=16.23 //y2=7.09
cc_1626 ( N_noxref_9_M28_noxref_g N_noxref_12_c_3292_n ) capacitor \
 c=0.0093887f //x=16.14 //y=6.205 //x2=16.23 //y2=7.09
cc_1627 ( N_noxref_9_c_2183_n N_noxref_12_c_3283_n ) capacitor c=0.00210342f \
 //x=15.66 //y=4.025 //x2=15.48 //y2=5.39
cc_1628 ( N_noxref_9_c_2189_n N_noxref_12_c_3283_n ) capacitor c=0.00257641f \
 //x=15.695 //y=4.885 //x2=15.48 //y2=5.39
cc_1629 ( N_noxref_9_M27_noxref_g N_noxref_12_c_3283_n ) capacitor \
 c=0.00176767f //x=15.7 //y=6.205 //x2=15.48 //y2=5.39
cc_1630 ( N_noxref_9_c_2222_n N_noxref_12_c_3283_n ) capacitor c=5.89864e-19 \
 //x=15.695 //y=4.885 //x2=15.48 //y2=5.39
cc_1631 ( N_noxref_9_M27_noxref_g N_noxref_12_c_3284_n ) capacitor \
 c=0.00186228f //x=15.7 //y=6.205 //x2=15.48 //y2=6.92
cc_1632 ( N_noxref_9_M28_noxref_g N_noxref_12_c_3299_n ) capacitor \
 c=0.00410728f //x=16.14 //y=6.205 //x2=16.36 //y2=6.92
cc_1633 ( N_noxref_9_M27_noxref_g N_noxref_12_c_3289_n ) capacitor \
 c=0.0170175f //x=15.7 //y=6.205 //x2=15.48 //y2=5.56
cc_1634 ( N_noxref_9_M28_noxref_g N_noxref_12_M28_noxref_d ) capacitor \
 c=0.0365939f //x=16.14 //y=6.205 //x2=16.215 //y2=5.205
cc_1635 ( N_noxref_9_c_2236_n N_noxref_13_c_3368_n ) capacitor c=2.74245e-19 \
 //x=18.32 //y=1.305 //x2=18.69 //y2=5.39
cc_1636 ( N_noxref_9_c_2253_n N_noxref_13_c_3368_n ) capacitor c=0.00188356f \
 //x=18.405 //y=1.835 //x2=18.69 //y2=5.39
cc_1637 ( N_noxref_9_c_2346_n N_noxref_13_c_3390_n ) capacitor c=0.00300849f \
 //x=19.645 //y=5.39 //x2=19.56 //y2=7.09
cc_1638 ( N_noxref_9_c_2273_n N_noxref_13_c_3390_n ) capacitor c=0.00513857f \
 //x=19.245 //y=5.39 //x2=19.56 //y2=7.09
cc_1639 ( N_noxref_9_c_2379_n N_noxref_13_c_3390_n ) capacitor c=0.00406191f \
 //x=19.25 //y=5.56 //x2=19.56 //y2=7.09
cc_1640 ( N_noxref_9_c_2273_n N_noxref_13_c_3375_n ) capacitor c=5.08928e-19 \
 //x=19.245 //y=5.39 //x2=17.93 //y2=5.39
cc_1641 ( N_noxref_9_c_2252_n N_noxref_13_c_3381_n ) capacitor c=0.00188356f \
 //x=19.205 //y=1.835 //x2=18.81 //y2=5.39
cc_1642 ( N_noxref_9_c_2273_n N_noxref_13_c_3381_n ) capacitor c=0.0529958f \
 //x=19.245 //y=5.39 //x2=18.81 //y2=5.39
cc_1643 ( N_noxref_9_c_2379_n N_noxref_13_c_3381_n ) capacitor c=0.00398527f \
 //x=19.25 //y=5.56 //x2=18.81 //y2=5.39
cc_1644 ( N_noxref_9_c_2346_n N_noxref_13_c_3402_n ) capacitor c=0.00564456f \
 //x=19.645 //y=5.39 //x2=19.69 //y2=6.92
cc_1645 ( N_noxref_9_c_2273_n N_noxref_13_c_3387_n ) capacitor c=0.00464132f \
 //x=19.245 //y=5.39 //x2=18.81 //y2=5.56
cc_1646 ( N_noxref_9_c_2379_n N_noxref_13_c_3387_n ) capacitor c=0.0684933f \
 //x=19.25 //y=5.56 //x2=18.81 //y2=5.56
cc_1647 ( N_noxref_9_c_2346_n N_noxref_13_M32_noxref_d ) capacitor \
 c=0.00777357f //x=19.645 //y=5.39 //x2=19.545 //y2=5.205
cc_1648 ( N_noxref_9_c_2371_n N_noxref_13_M32_noxref_d ) capacitor \
 c=0.00120919f //x=19.73 //y=3.88 //x2=19.545 //y2=5.205
cc_1649 ( N_noxref_9_c_2379_n N_noxref_13_M32_noxref_d ) capacitor \
 c=0.0479141f //x=19.25 //y=5.56 //x2=19.545 //y2=5.205
cc_1650 ( N_VDD_c_2476_n N_GND_c_2897_n ) capacitor c=0.00989514f //x=1.23 \
 //y=7.58 //x2=1.12 //y2=0.175
cc_1651 ( N_VDD_c_2479_n N_GND_c_2899_n ) capacitor c=0.00663779f //x=2.71 \
 //y=7.585 //x2=2.71 //y2=0.175
cc_1652 ( N_VDD_c_2523_n N_GND_c_2937_n ) capacitor c=0.00650455f //x=6.04 \
 //y=7.585 //x2=6.04 //y2=0.175
cc_1653 ( N_VDD_c_2531_n N_GND_c_2944_n ) capacitor c=0.00648088f //x=8.26 \
 //y=7.585 //x2=8.26 //y2=0.175
cc_1654 ( N_VDD_c_2600_n N_GND_c_3010_n ) capacitor c=0.00904041f //x=11.59 \
 //y=7.585 //x2=11.59 //y2=0.175
cc_1655 ( N_VDD_c_2652_n N_GND_c_3048_n ) capacitor c=0.00663779f //x=13.81 \
 //y=7.585 //x2=13.81 //y2=0.175
cc_1656 ( N_VDD_c_2700_n N_GND_c_3122_n ) capacitor c=0.00654453f //x=17.14 \
 //y=7.585 //x2=17.14 //y2=0.175
cc_1657 ( N_VDD_c_2723_n N_GND_c_2905_n ) capacitor c=0.00989514f //x=19.73 \
 //y=7.58 //x2=19.73 //y2=0.18
cc_1658 ( N_VDD_c_2464_n N_noxref_12_c_3273_n ) capacitor c=0.00198753f \
 //x=14.955 //y=7.585 //x2=15.36 //y2=5.39
cc_1659 ( N_VDD_c_2679_n N_noxref_12_c_3273_n ) capacitor c=0.00492734f \
 //x=15.04 //y=7.035 //x2=15.36 //y2=5.39
cc_1660 ( N_VDD_c_2715_n N_noxref_12_c_3273_n ) capacitor c=5.38405e-19 \
 //x=18.285 //y=7.585 //x2=15.36 //y2=5.39
cc_1661 ( N_VDD_c_2686_n N_noxref_12_c_3273_n ) capacitor c=0.00585493f \
 //x=16.97 //y=7.585 //x2=15.36 //y2=5.39
cc_1662 ( N_VDD_M25_noxref_d N_noxref_12_c_3273_n ) capacitor c=0.00639723f \
 //x=14.895 //y=5.205 //x2=15.36 //y2=5.39
cc_1663 ( N_VDD_c_2723_n N_noxref_12_c_3292_n ) capacitor c=0.0022388f \
 //x=19.73 //y=7.58 //x2=16.23 //y2=7.09
cc_1664 ( N_VDD_c_2652_n N_noxref_12_c_3279_n ) capacitor c=0.00713363f \
 //x=13.81 //y=7.585 //x2=14.6 //y2=5.39
cc_1665 ( N_VDD_M24_noxref_d N_noxref_12_c_3279_n ) capacitor c=0.0123722f \
 //x=13 //y=5.2 //x2=14.6 //y2=5.39
cc_1666 ( N_VDD_c_2679_n N_noxref_12_c_3284_n ) capacitor c=0.0375498f \
 //x=15.04 //y=7.035 //x2=15.48 //y2=6.92
cc_1667 ( N_VDD_c_2681_n N_noxref_12_c_3284_n ) capacitor c=0.0104317f \
 //x=15.04 //y=7.41 //x2=15.48 //y2=6.92
cc_1668 ( N_VDD_c_2715_n N_noxref_12_c_3284_n ) capacitor c=0.0975797f \
 //x=18.285 //y=7.585 //x2=15.48 //y2=6.92
cc_1669 ( N_VDD_c_2686_n N_noxref_12_c_3284_n ) capacitor c=0.020049f \
 //x=16.97 //y=7.585 //x2=15.48 //y2=6.92
cc_1670 ( N_VDD_c_2723_n N_noxref_12_c_3284_n ) capacitor c=0.00112916f \
 //x=19.73 //y=7.58 //x2=15.48 //y2=6.92
cc_1671 ( N_VDD_M25_noxref_d N_noxref_12_c_3284_n ) capacitor c=0.00510287f \
 //x=14.895 //y=5.205 //x2=15.48 //y2=6.92
cc_1672 ( N_VDD_c_2679_n N_noxref_12_c_3299_n ) capacitor c=6.1128e-19 \
 //x=15.04 //y=7.035 //x2=16.36 //y2=6.92
cc_1673 ( N_VDD_c_2715_n N_noxref_12_c_3299_n ) capacitor c=0.00193184f \
 //x=18.285 //y=7.585 //x2=16.36 //y2=6.92
cc_1674 ( N_VDD_c_2717_n N_noxref_12_c_3299_n ) capacitor c=5.94673e-19 \
 //x=18.37 //y=7.035 //x2=16.36 //y2=6.92
cc_1675 ( N_VDD_c_2686_n N_noxref_12_c_3299_n ) capacitor c=9.3761e-19 \
 //x=16.97 //y=7.585 //x2=16.36 //y2=6.92
cc_1676 ( N_VDD_c_2723_n N_noxref_12_c_3299_n ) capacitor c=0.00112713f \
 //x=19.73 //y=7.58 //x2=16.36 //y2=6.92
cc_1677 ( N_VDD_c_2700_n N_noxref_12_c_3299_n ) capacitor c=0.00713778f \
 //x=17.14 //y=7.585 //x2=16.36 //y2=6.92
cc_1678 ( N_VDD_c_2464_n N_noxref_12_c_3285_n ) capacitor c=0.00240365f \
 //x=14.955 //y=7.585 //x2=14.6 //y2=5.56
cc_1679 ( N_VDD_c_2679_n N_noxref_12_c_3285_n ) capacitor c=0.00220777f \
 //x=15.04 //y=7.035 //x2=14.6 //y2=5.56
cc_1680 ( N_VDD_c_2681_n N_noxref_12_c_3285_n ) capacitor c=0.00154298f \
 //x=15.04 //y=7.41 //x2=14.6 //y2=5.56
cc_1681 ( N_VDD_c_2686_n N_noxref_12_c_3285_n ) capacitor c=0.0126473f \
 //x=16.97 //y=7.585 //x2=14.6 //y2=5.56
cc_1682 ( N_VDD_c_2723_n N_noxref_12_c_3285_n ) capacitor c=2.28864e-19 \
 //x=19.73 //y=7.58 //x2=14.6 //y2=5.56
cc_1683 ( N_VDD_c_2652_n N_noxref_12_c_3285_n ) capacitor c=0.0558076f \
 //x=13.81 //y=7.585 //x2=14.6 //y2=5.56
cc_1684 ( N_VDD_M24_noxref_d N_noxref_12_c_3285_n ) capacitor c=0.00262214f \
 //x=13 //y=5.2 //x2=14.6 //y2=5.56
cc_1685 ( N_VDD_M25_noxref_d N_noxref_12_c_3285_n ) capacitor c=0.0737268f \
 //x=14.895 //y=5.205 //x2=14.6 //y2=5.56
cc_1686 ( N_VDD_c_2679_n N_noxref_12_c_3289_n ) capacitor c=0.00211426f \
 //x=15.04 //y=7.035 //x2=15.48 //y2=5.56
cc_1687 ( N_VDD_c_2681_n N_noxref_12_c_3289_n ) capacitor c=4.62894e-19 \
 //x=15.04 //y=7.41 //x2=15.48 //y2=5.56
cc_1688 ( N_VDD_c_2715_n N_noxref_12_c_3289_n ) capacitor c=0.00205411f \
 //x=18.285 //y=7.585 //x2=15.48 //y2=5.56
cc_1689 ( N_VDD_c_2686_n N_noxref_12_c_3289_n ) capacitor c=0.0085453f \
 //x=16.97 //y=7.585 //x2=15.48 //y2=5.56
cc_1690 ( N_VDD_c_2723_n N_noxref_12_c_3289_n ) capacitor c=2.28864e-19 \
 //x=19.73 //y=7.58 //x2=15.48 //y2=5.56
cc_1691 ( N_VDD_M25_noxref_d N_noxref_12_c_3289_n ) capacitor c=0.067415f \
 //x=14.895 //y=5.205 //x2=15.48 //y2=5.56
cc_1692 ( N_VDD_c_2464_n N_noxref_12_M25_noxref_s ) capacitor c=0.0245962f \
 //x=14.955 //y=7.585 //x2=14.465 //y2=5.205
cc_1693 ( N_VDD_c_2679_n N_noxref_12_M25_noxref_s ) capacitor c=0.0378001f \
 //x=15.04 //y=7.035 //x2=14.465 //y2=5.205
cc_1694 ( N_VDD_c_2681_n N_noxref_12_M25_noxref_s ) capacitor c=0.0124823f \
 //x=15.04 //y=7.41 //x2=14.465 //y2=5.205
cc_1695 ( N_VDD_c_2686_n N_noxref_12_M25_noxref_s ) capacitor c=0.00293047f \
 //x=16.97 //y=7.585 //x2=14.465 //y2=5.205
cc_1696 ( N_VDD_c_2652_n N_noxref_12_M25_noxref_s ) capacitor c=0.00933367f \
 //x=13.81 //y=7.585 //x2=14.465 //y2=5.205
cc_1697 ( N_VDD_M25_noxref_d N_noxref_12_M25_noxref_s ) capacitor \
 c=0.00566597f //x=14.895 //y=5.205 //x2=14.465 //y2=5.205
cc_1698 ( N_VDD_c_2715_n N_noxref_12_M28_noxref_d ) capacitor c=0.00206569f \
 //x=18.285 //y=7.585 //x2=16.215 //y2=5.205
cc_1699 ( N_VDD_c_2686_n N_noxref_12_M28_noxref_d ) capacitor c=0.00856914f \
 //x=16.97 //y=7.585 //x2=16.215 //y2=5.205
cc_1700 ( N_VDD_c_2723_n N_noxref_12_M28_noxref_d ) capacitor c=2.28864e-19 \
 //x=19.73 //y=7.58 //x2=16.215 //y2=5.205
cc_1701 ( N_VDD_c_2700_n N_noxref_12_M28_noxref_d ) capacitor c=0.0456839f \
 //x=17.14 //y=7.585 //x2=16.215 //y2=5.205
cc_1702 ( N_VDD_c_2715_n N_noxref_13_c_3368_n ) capacitor c=5.98028e-19 \
 //x=18.285 //y=7.585 //x2=18.69 //y2=5.39
cc_1703 ( N_VDD_c_2717_n N_noxref_13_c_3368_n ) capacitor c=0.00492769f \
 //x=18.37 //y=7.035 //x2=18.69 //y2=5.39
cc_1704 ( N_VDD_c_2774_n N_noxref_13_c_3368_n ) capacitor c=0.00192799f \
 //x=19.73 //y=7.58 //x2=18.69 //y2=5.39
cc_1705 ( N_VDD_c_2723_n N_noxref_13_c_3368_n ) capacitor c=0.00590635f \
 //x=19.73 //y=7.58 //x2=18.69 //y2=5.39
cc_1706 ( N_VDD_M29_noxref_d N_noxref_13_c_3368_n ) capacitor c=0.00648599f \
 //x=18.225 //y=5.205 //x2=18.69 //y2=5.39
cc_1707 ( N_VDD_c_2723_n N_noxref_13_c_3390_n ) capacitor c=0.0022388f \
 //x=19.73 //y=7.58 //x2=19.56 //y2=7.09
cc_1708 ( N_VDD_c_2700_n N_noxref_13_c_3375_n ) capacitor c=0.00764075f \
 //x=17.14 //y=7.585 //x2=17.93 //y2=5.39
cc_1709 ( N_VDD_c_2717_n N_noxref_13_c_3382_n ) capacitor c=0.0377581f \
 //x=18.37 //y=7.035 //x2=18.81 //y2=6.92
cc_1710 ( N_VDD_c_2719_n N_noxref_13_c_3382_n ) capacitor c=0.0104319f \
 //x=18.37 //y=7.41 //x2=18.81 //y2=6.92
cc_1711 ( N_VDD_c_2774_n N_noxref_13_c_3382_n ) capacitor c=0.0980606f \
 //x=19.73 //y=7.58 //x2=18.81 //y2=6.92
cc_1712 ( N_VDD_c_2723_n N_noxref_13_c_3382_n ) capacitor c=0.0208711f \
 //x=19.73 //y=7.58 //x2=18.81 //y2=6.92
cc_1713 ( N_VDD_M29_noxref_d N_noxref_13_c_3382_n ) capacitor c=0.00510285f \
 //x=18.225 //y=5.205 //x2=18.81 //y2=6.92
cc_1714 ( N_VDD_c_2717_n N_noxref_13_c_3402_n ) capacitor c=6.1128e-19 \
 //x=18.37 //y=7.035 //x2=19.69 //y2=6.92
cc_1715 ( N_VDD_c_2774_n N_noxref_13_c_3402_n ) capacitor c=0.00193184f \
 //x=19.73 //y=7.58 //x2=19.69 //y2=6.92
cc_1716 ( N_VDD_c_2723_n N_noxref_13_c_3402_n ) capacitor c=0.0111893f \
 //x=19.73 //y=7.58 //x2=19.69 //y2=6.92
cc_1717 ( N_VDD_c_2715_n N_noxref_13_c_3383_n ) capacitor c=0.00240365f \
 //x=18.285 //y=7.585 //x2=17.93 //y2=5.56
cc_1718 ( N_VDD_c_2717_n N_noxref_13_c_3383_n ) capacitor c=0.00220777f \
 //x=18.37 //y=7.035 //x2=17.93 //y2=5.56
cc_1719 ( N_VDD_c_2719_n N_noxref_13_c_3383_n ) capacitor c=0.00154298f \
 //x=18.37 //y=7.41 //x2=17.93 //y2=5.56
cc_1720 ( N_VDD_c_2723_n N_noxref_13_c_3383_n ) capacitor c=0.0128762f \
 //x=19.73 //y=7.58 //x2=17.93 //y2=5.56
cc_1721 ( N_VDD_c_2700_n N_noxref_13_c_3383_n ) capacitor c=0.0574402f \
 //x=17.14 //y=7.585 //x2=17.93 //y2=5.56
cc_1722 ( N_VDD_M29_noxref_d N_noxref_13_c_3383_n ) capacitor c=0.0738196f \
 //x=18.225 //y=5.205 //x2=17.93 //y2=5.56
cc_1723 ( N_VDD_c_2717_n N_noxref_13_c_3387_n ) capacitor c=0.00211426f \
 //x=18.37 //y=7.035 //x2=18.81 //y2=5.56
cc_1724 ( N_VDD_c_2719_n N_noxref_13_c_3387_n ) capacitor c=4.62894e-19 \
 //x=18.37 //y=7.41 //x2=18.81 //y2=5.56
cc_1725 ( N_VDD_c_2774_n N_noxref_13_c_3387_n ) capacitor c=0.00205411f \
 //x=19.73 //y=7.58 //x2=18.81 //y2=5.56
cc_1726 ( N_VDD_c_2723_n N_noxref_13_c_3387_n ) capacitor c=0.00877417f \
 //x=19.73 //y=7.58 //x2=18.81 //y2=5.56
cc_1727 ( N_VDD_M29_noxref_d N_noxref_13_c_3387_n ) capacitor c=0.0674471f \
 //x=18.225 //y=5.205 //x2=18.81 //y2=5.56
cc_1728 ( N_VDD_c_2715_n N_noxref_13_M29_noxref_s ) capacitor c=0.0245962f \
 //x=18.285 //y=7.585 //x2=17.795 //y2=5.205
cc_1729 ( N_VDD_c_2717_n N_noxref_13_M29_noxref_s ) capacitor c=0.0368106f \
 //x=18.37 //y=7.035 //x2=17.795 //y2=5.205
cc_1730 ( N_VDD_c_2719_n N_noxref_13_M29_noxref_s ) capacitor c=0.0124823f \
 //x=18.37 //y=7.41 //x2=17.795 //y2=5.205
cc_1731 ( N_VDD_c_2723_n N_noxref_13_M29_noxref_s ) capacitor c=0.00293047f \
 //x=19.73 //y=7.58 //x2=17.795 //y2=5.205
cc_1732 ( N_VDD_c_2700_n N_noxref_13_M29_noxref_s ) capacitor c=0.00571261f \
 //x=17.14 //y=7.585 //x2=17.795 //y2=5.205
cc_1733 ( N_VDD_M29_noxref_d N_noxref_13_M29_noxref_s ) capacitor \
 c=0.00378833f //x=18.225 //y=5.205 //x2=17.795 //y2=5.205
cc_1734 ( N_VDD_c_2774_n N_noxref_13_M32_noxref_d ) capacitor c=0.00206569f \
 //x=19.73 //y=7.58 //x2=19.545 //y2=5.205
cc_1735 ( N_VDD_c_2723_n N_noxref_13_M32_noxref_d ) capacitor c=0.0540429f \
 //x=19.73 //y=7.58 //x2=19.545 //y2=5.205
cc_1736 ( N_GND_M0_noxref_s N_noxref_14_c_3459_n ) capacitor c=0.0029758f \
 //x=0.985 //y=0.55 //x2=3.405 //y2=1.675
cc_1737 ( N_GND_c_2872_n N_noxref_14_c_3461_n ) capacitor c=0.00245371f \
 //x=3.805 //y=0.175 //x2=4.29 //y2=1.76
cc_1738 ( N_GND_c_2919_n N_noxref_14_c_3461_n ) capacitor c=7.74325e-19 \
 //x=9.355 //y=0.175 //x2=4.29 //y2=1.76
cc_1739 ( N_GND_c_2878_n N_noxref_14_c_3461_n ) capacitor c=0.00397948f \
 //x=3.89 //y=1.135 //x2=4.29 //y2=1.76
cc_1740 ( N_GND_c_2896_n N_noxref_14_c_3461_n ) capacitor c=0.00375345f \
 //x=5.87 //y=0.175 //x2=4.29 //y2=1.76
cc_1741 ( N_GND_M1_noxref_d N_noxref_14_c_3461_n ) capacitor c=0.00578453f \
 //x=3.7 //y=1.045 //x2=4.29 //y2=1.76
cc_1742 ( N_GND_c_2919_n N_noxref_14_c_3503_n ) capacitor c=0.00552746f \
 //x=9.355 //y=0.175 //x2=4.375 //y2=0.795
cc_1743 ( N_GND_c_2889_n N_noxref_14_c_3503_n ) capacitor c=0.0167642f \
 //x=3.887 //y=1.005 //x2=4.375 //y2=0.795
cc_1744 ( N_GND_c_2896_n N_noxref_14_c_3503_n ) capacitor c=0.0147234f \
 //x=5.87 //y=0.175 //x2=4.375 //y2=0.795
cc_1745 ( N_GND_c_2899_n N_noxref_14_c_3503_n ) capacitor c=0.00282499f \
 //x=2.71 //y=0.175 //x2=4.375 //y2=0.795
cc_1746 ( N_GND_c_2937_n N_noxref_14_c_3503_n ) capacitor c=2.21767e-19 \
 //x=6.04 //y=0.175 //x2=4.375 //y2=0.795
cc_1747 ( N_GND_c_2899_n N_noxref_14_c_3469_n ) capacitor c=2.84609e-19 \
 //x=2.71 //y=0.175 //x2=4.375 //y2=1.675
cc_1748 ( N_GND_c_2919_n N_noxref_14_c_3474_n ) capacitor c=0.00966754f \
 //x=9.355 //y=0.175 //x2=5.26 //y2=0.71
cc_1749 ( N_GND_c_2896_n N_noxref_14_c_3474_n ) capacitor c=0.0374802f \
 //x=5.87 //y=0.175 //x2=5.26 //y2=0.71
cc_1750 ( N_GND_c_2905_n N_noxref_14_c_3474_n ) capacitor c=0.0019969f \
 //x=19.73 //y=0.18 //x2=5.26 //y2=0.71
cc_1751 ( N_GND_c_2919_n N_noxref_14_c_3512_n ) capacitor c=0.00250904f \
 //x=9.355 //y=0.175 //x2=5.345 //y2=0.795
cc_1752 ( N_GND_c_2896_n N_noxref_14_c_3512_n ) capacitor c=0.0145784f \
 //x=5.87 //y=0.175 //x2=5.345 //y2=0.795
cc_1753 ( N_GND_c_3234_p N_noxref_14_c_3512_n ) capacitor c=0.00209572f \
 //x=6.67 //y=0.63 //x2=5.345 //y2=0.795
cc_1754 ( N_GND_c_2937_n N_noxref_14_c_3512_n ) capacitor c=0.0402083f \
 //x=6.04 //y=0.175 //x2=5.345 //y2=0.795
cc_1755 ( N_GND_c_2872_n N_noxref_14_M1_noxref_s ) capacitor c=0.00724992f \
 //x=3.805 //y=0.175 //x2=3.27 //y2=0.545
cc_1756 ( N_GND_c_2878_n N_noxref_14_M1_noxref_s ) capacitor c=0.0100498f \
 //x=3.89 //y=1.135 //x2=3.27 //y2=0.545
cc_1757 ( N_GND_c_2889_n N_noxref_14_M1_noxref_s ) capacitor c=0.0173062f \
 //x=3.887 //y=1.005 //x2=3.27 //y2=0.545
cc_1758 ( N_GND_c_3239_p N_noxref_14_M1_noxref_s ) capacitor c=0.0029758f \
 //x=2.09 //y=0.63 //x2=3.27 //y2=0.545
cc_1759 ( N_GND_c_2896_n N_noxref_14_M1_noxref_s ) capacitor c=0.014661f \
 //x=5.87 //y=0.175 //x2=3.27 //y2=0.545
cc_1760 ( N_GND_c_2899_n N_noxref_14_M1_noxref_s ) capacitor c=0.0528146f \
 //x=2.71 //y=0.175 //x2=3.27 //y2=0.545
cc_1761 ( N_GND_c_2937_n N_noxref_14_M1_noxref_s ) capacitor c=0.00642652f \
 //x=6.04 //y=0.175 //x2=3.27 //y2=0.545
cc_1762 ( N_GND_M1_noxref_d N_noxref_14_M1_noxref_s ) capacitor c=0.0271276f \
 //x=3.7 //y=1.045 //x2=3.27 //y2=0.545
cc_1763 ( N_GND_M3_noxref_s N_noxref_14_M1_noxref_s ) capacitor c=0.0031675f \
 //x=6.535 //y=0.55 //x2=3.27 //y2=0.545
cc_1764 ( N_GND_M3_noxref_s N_noxref_15_c_3525_n ) capacitor c=0.0029758f \
 //x=6.535 //y=0.55 //x2=8.955 //y2=1.675
cc_1765 ( N_GND_c_2919_n N_noxref_15_c_3527_n ) capacitor c=9.69275e-19 \
 //x=9.355 //y=0.175 //x2=9.84 //y2=1.76
cc_1766 ( N_GND_c_2995_n N_noxref_15_c_3527_n ) capacitor c=0.00203804f \
 //x=19.73 //y=0.18 //x2=9.84 //y2=1.76
cc_1767 ( N_GND_c_2959_n N_noxref_15_c_3527_n ) capacitor c=0.00396294f \
 //x=9.44 //y=1.135 //x2=9.84 //y2=1.76
cc_1768 ( N_GND_c_2974_n N_noxref_15_c_3527_n ) capacitor c=0.00387051f \
 //x=11.42 //y=0.175 //x2=9.84 //y2=1.76
cc_1769 ( N_GND_M4_noxref_d N_noxref_15_c_3527_n ) capacitor c=0.00578453f \
 //x=9.25 //y=1.045 //x2=9.84 //y2=1.76
cc_1770 ( N_GND_c_2995_n N_noxref_15_c_3569_n ) capacitor c=0.00560433f \
 //x=19.73 //y=0.18 //x2=9.925 //y2=0.795
cc_1771 ( N_GND_c_2970_n N_noxref_15_c_3569_n ) capacitor c=0.0167642f \
 //x=9.437 //y=1.005 //x2=9.925 //y2=0.795
cc_1772 ( N_GND_c_2974_n N_noxref_15_c_3569_n ) capacitor c=0.0146605f \
 //x=11.42 //y=0.175 //x2=9.925 //y2=0.795
cc_1773 ( N_GND_c_2944_n N_noxref_15_c_3569_n ) capacitor c=0.00282499f \
 //x=8.26 //y=0.175 //x2=9.925 //y2=0.795
cc_1774 ( N_GND_c_3010_n N_noxref_15_c_3569_n ) capacitor c=2.21767e-19 \
 //x=11.59 //y=0.175 //x2=9.925 //y2=0.795
cc_1775 ( N_GND_c_2944_n N_noxref_15_c_3535_n ) capacitor c=2.84609e-19 \
 //x=8.26 //y=0.175 //x2=9.925 //y2=1.675
cc_1776 ( N_GND_c_2995_n N_noxref_15_c_3543_n ) capacitor c=0.00993166f \
 //x=19.73 //y=0.18 //x2=10.81 //y2=0.71
cc_1777 ( N_GND_c_2974_n N_noxref_15_c_3543_n ) capacitor c=0.0374802f \
 //x=11.42 //y=0.175 //x2=10.81 //y2=0.71
cc_1778 ( N_GND_c_2905_n N_noxref_15_c_3543_n ) capacitor c=0.0019969f \
 //x=19.73 //y=0.18 //x2=10.81 //y2=0.71
cc_1779 ( N_GND_c_2995_n N_noxref_15_c_3578_n ) capacitor c=0.00250904f \
 //x=19.73 //y=0.18 //x2=10.895 //y2=0.795
cc_1780 ( N_GND_c_2974_n N_noxref_15_c_3578_n ) capacitor c=0.0145784f \
 //x=11.42 //y=0.175 //x2=10.895 //y2=0.795
cc_1781 ( N_GND_c_3262_p N_noxref_15_c_3578_n ) capacitor c=0.00209572f \
 //x=12.22 //y=0.63 //x2=10.895 //y2=0.795
cc_1782 ( N_GND_c_3010_n N_noxref_15_c_3578_n ) capacitor c=0.0402083f \
 //x=11.59 //y=0.175 //x2=10.895 //y2=0.795
cc_1783 ( N_GND_c_2919_n N_noxref_15_M4_noxref_s ) capacitor c=0.00724992f \
 //x=9.355 //y=0.175 //x2=8.82 //y2=0.545
cc_1784 ( N_GND_c_2959_n N_noxref_15_M4_noxref_s ) capacitor c=0.0100435f \
 //x=9.44 //y=1.135 //x2=8.82 //y2=0.545
cc_1785 ( N_GND_c_2970_n N_noxref_15_M4_noxref_s ) capacitor c=0.0173062f \
 //x=9.437 //y=1.005 //x2=8.82 //y2=0.545
cc_1786 ( N_GND_c_3267_p N_noxref_15_M4_noxref_s ) capacitor c=0.0029758f \
 //x=7.64 //y=0.63 //x2=8.82 //y2=0.545
cc_1787 ( N_GND_c_2974_n N_noxref_15_M4_noxref_s ) capacitor c=0.014661f \
 //x=11.42 //y=0.175 //x2=8.82 //y2=0.545
cc_1788 ( N_GND_c_2944_n N_noxref_15_M4_noxref_s ) capacitor c=0.0528146f \
 //x=8.26 //y=0.175 //x2=8.82 //y2=0.545
cc_1789 ( N_GND_c_3010_n N_noxref_15_M4_noxref_s ) capacitor c=0.00642652f \
 //x=11.59 //y=0.175 //x2=8.82 //y2=0.545
cc_1790 ( N_GND_M4_noxref_d N_noxref_15_M4_noxref_s ) capacitor c=0.0271276f \
 //x=9.25 //y=1.045 //x2=8.82 //y2=0.545
cc_1791 ( N_GND_M6_noxref_s N_noxref_15_M4_noxref_s ) capacitor c=0.0031675f \
 //x=12.085 //y=0.55 //x2=8.82 //y2=0.545
cc_1792 ( N_noxref_12_c_3283_n N_noxref_13_c_3375_n ) capacitor c=0.00120008f \
 //x=15.48 //y=5.39 //x2=17.93 //y2=5.39
cc_1793 ( N_noxref_12_M28_noxref_d N_noxref_13_c_3383_n ) capacitor \
 c=0.00134877f //x=16.215 //y=5.205 //x2=17.93 //y2=5.56
cc_1794 ( N_noxref_12_c_3284_n N_noxref_13_M29_noxref_s ) capacitor \
 c=2.04839e-19 //x=15.48 //y=6.92 //x2=17.795 //y2=5.205
cc_1795 ( N_noxref_12_c_3299_n N_noxref_13_M29_noxref_s ) capacitor \
 c=0.0118379f //x=16.36 //y=6.92 //x2=17.795 //y2=5.205
