// File: XNOR2X1.spi.XNOR2X1.pxi
// Created: Sun Mar 15 12:47:06 2026
//
simulator lang=spectre
x_PM_XNOR2X1\%A ( A A A A A A A A A A A A N_A_c_30_p N_A_c_31_p N_A_c_17_p \
 N_A_c_32_p N_A_c_33_p N_A_c_18_p N_A_c_34_p N_A_c_35_p N_A_c_6_p N_A_c_19_p \
 N_A_c_37_p N_A_c_72_p N_A_c_95_p N_A_M0_noxref_g N_A_M1_noxref_g \
 N_A_M6_noxref_g N_A_M7_noxref_g N_A_M8_noxref_g N_A_M9_noxref_g N_A_c_41_p \
 N_A_c_1_p N_A_c_2_p N_A_c_3_p N_A_c_14_p N_A_c_39_p N_A_c_43_p N_A_c_4_p \
 N_A_c_45_p N_A_c_5_p N_A_c_81_p N_A_c_82_p N_A_c_84_p N_A_c_73_p N_A_c_185_p \
 N_A_c_186_p N_A_c_83_p N_A_c_85_p N_A_c_10_p N_A_c_103_p )  PM_XNOR2X1\%A
x_PM_XNOR2X1\%noxref_2 ( N_noxref_2_c_236_n N_noxref_2_c_241_n \
 N_noxref_2_c_244_n N_noxref_2_c_245_n N_noxref_2_c_246_n N_noxref_2_c_247_n \
 N_noxref_2_c_250_n N_noxref_2_c_256_n N_noxref_2_c_259_n N_noxref_2_c_300_p \
 N_noxref_2_c_275_n N_noxref_2_c_302_p N_noxref_2_c_303_p N_noxref_2_c_276_n \
 N_noxref_2_c_282_n N_noxref_2_c_304_p N_noxref_2_c_283_n N_noxref_2_c_305_p \
 N_noxref_2_c_286_n N_noxref_2_c_291_n N_noxref_2_c_306_p N_noxref_2_c_309_p \
 N_noxref_2_M4_noxref_g N_noxref_2_M14_noxref_g N_noxref_2_M15_noxref_g \
 N_noxref_2_c_327_p N_noxref_2_c_328_p N_noxref_2_c_334_p N_noxref_2_c_307_p \
 N_noxref_2_c_329_p N_noxref_2_c_330_p N_noxref_2_c_331_p N_noxref_2_c_332_p \
 N_noxref_2_c_310_p N_noxref_2_M0_noxref_d N_noxref_2_M6_noxref_d )  \
 PM_XNOR2X1\%noxref_2
x_PM_XNOR2X1\%Y ( Y Y Y Y N_Y_c_538_n N_Y_c_539_n N_Y_c_678_p N_Y_c_541_n \
 N_Y_c_542_n N_Y_c_520_n N_Y_c_521_n N_Y_c_522_n N_Y_c_551_n N_Y_c_559_n \
 N_Y_c_564_n N_Y_c_567_n N_Y_c_573_n N_Y_c_578_n N_Y_c_581_n N_Y_c_524_n \
 N_Y_c_582_n N_Y_c_525_n N_Y_c_587_n N_Y_c_588_n N_Y_c_683_p N_Y_c_590_n \
 N_Y_M2_noxref_d N_Y_M4_noxref_d N_Y_M10_noxref_d N_Y_M14_noxref_d )  \
 PM_XNOR2X1\%Y
x_PM_XNOR2X1\%noxref_4 ( N_noxref_4_c_819_n N_noxref_4_c_822_n \
 N_noxref_4_c_845_n N_noxref_4_c_873_n N_noxref_4_c_846_n N_noxref_4_c_847_n \
 N_noxref_4_c_880_n N_noxref_4_c_985_p N_noxref_4_c_881_n N_noxref_4_c_979_p \
 N_noxref_4_c_994_p N_noxref_4_c_882_n N_noxref_4_c_884_n N_noxref_4_c_824_n \
 N_noxref_4_c_849_n N_noxref_4_c_893_n N_noxref_4_c_948_p N_noxref_4_c_894_n \
 N_noxref_4_c_851_n N_noxref_4_c_825_n N_noxref_4_c_853_n N_noxref_4_c_902_n \
 N_noxref_4_c_903_n N_noxref_4_c_854_n N_noxref_4_c_826_n N_noxref_4_c_859_n \
 N_noxref_4_c_996_p N_noxref_4_M2_noxref_g N_noxref_4_M12_noxref_g \
 N_noxref_4_M13_noxref_g N_noxref_4_c_829_n N_noxref_4_c_832_n \
 N_noxref_4_c_834_n N_noxref_4_c_837_n N_noxref_4_c_925_n N_noxref_4_c_927_n \
 N_noxref_4_c_840_n N_noxref_4_c_841_n N_noxref_4_c_865_n \
 N_noxref_4_M5_noxref_d N_noxref_4_M16_noxref_d )  PM_XNOR2X1\%noxref_4
x_PM_XNOR2X1\%B ( B B B B B B B B B B N_B_c_1125_n N_B_c_1148_n N_B_c_1249_n \
 N_B_c_1250_n N_B_c_1254_n N_B_c_1152_n N_B_c_1200_n N_B_c_1128_n N_B_c_1154_n \
 N_B_c_1209_n N_B_c_1267_n N_B_c_1268_n N_B_c_1210_n N_B_c_1155_n N_B_c_1131_n \
 N_B_c_1157_n N_B_c_1280_n N_B_c_1281_n N_B_M3_noxref_g N_B_M5_noxref_g \
 N_B_M10_noxref_g N_B_M11_noxref_g N_B_M16_noxref_g N_B_M17_noxref_g \
 N_B_c_1161_n N_B_c_1162_n N_B_c_1163_n N_B_c_1165_n N_B_c_1366_p N_B_c_1367_p \
 N_B_c_1169_n N_B_c_1171_n N_B_c_1291_n N_B_c_1293_n N_B_c_1297_n N_B_c_1299_n \
 N_B_c_1302_n N_B_c_1304_n N_B_c_1307_n N_B_c_1309_n N_B_c_1311_n N_B_c_1314_n \
 N_B_c_1315_n N_B_c_1138_n N_B_c_1316_n )  PM_XNOR2X1\%B
x_PM_XNOR2X1\%VDD ( VDD N_VDD_c_1422_n N_VDD_c_1425_n N_VDD_c_1427_n \
 N_VDD_c_1490_n N_VDD_c_1512_n N_VDD_c_1514_n N_VDD_c_1491_n N_VDD_c_1429_n \
 N_VDD_c_1433_n N_VDD_c_1471_n N_VDD_c_1522_n N_VDD_c_1435_n N_VDD_c_1442_n \
 N_VDD_c_1480_n N_VDD_c_1481_n N_VDD_c_1483_n N_VDD_M6_noxref_s \
 N_VDD_M7_noxref_d N_VDD_M8_noxref_d N_VDD_M12_noxref_d N_VDD_M16_noxref_s \
 N_VDD_M17_noxref_d )  PM_XNOR2X1\%VDD
x_PM_XNOR2X1\%noxref_7 ( N_noxref_7_c_1679_n N_noxref_7_c_1696_n \
 N_noxref_7_c_1686_n N_noxref_7_c_1689_n N_noxref_7_c_1690_n \
 N_noxref_7_c_1702_n N_noxref_7_c_1691_n N_noxref_7_c_1693_n \
 N_noxref_7_M8_noxref_s N_noxref_7_M9_noxref_d N_noxref_7_M11_noxref_d )  \
 PM_XNOR2X1\%noxref_7
x_PM_XNOR2X1\%noxref_8 ( N_noxref_8_c_1785_n N_noxref_8_c_1764_n \
 N_noxref_8_c_1774_n N_noxref_8_c_1766_n N_noxref_8_c_1767_n \
 N_noxref_8_c_1768_n N_noxref_8_c_1797_n N_noxref_8_c_1769_n \
 N_noxref_8_M12_noxref_s N_noxref_8_M13_noxref_d N_noxref_8_M15_noxref_d )  \
 PM_XNOR2X1\%noxref_8
x_PM_XNOR2X1\%GND ( GND N_GND_c_1850_n N_GND_c_1855_n N_GND_c_1933_n \
 N_GND_c_1905_n N_GND_c_1940_n N_GND_c_1863_n N_GND_c_1867_n N_GND_c_2059_p \
 N_GND_c_1868_n N_GND_c_1945_n N_GND_c_2082_p N_GND_c_1960_n N_GND_c_1963_n \
 N_GND_c_1869_n N_GND_c_1874_n N_GND_c_1917_n N_GND_c_1919_n N_GND_c_1923_n \
 N_GND_M0_noxref_s N_GND_M1_noxref_d N_GND_M3_noxref_d N_GND_M5_noxref_s )  \
 PM_XNOR2X1\%GND
x_PM_XNOR2X1\%noxref_10 ( N_noxref_10_c_2093_n N_noxref_10_c_2094_n \
 N_noxref_10_c_2132_n N_noxref_10_c_2101_n N_noxref_10_c_2108_n \
 N_noxref_10_c_2142_n N_noxref_10_M1_noxref_s )  PM_XNOR2X1\%noxref_10
x_PM_XNOR2X1\%noxref_11 ( N_noxref_11_c_2157_n N_noxref_11_c_2158_n \
 N_noxref_11_c_2199_n N_noxref_11_c_2159_n N_noxref_11_c_2161_n \
 N_noxref_11_c_2209_n N_noxref_11_M3_noxref_s )  PM_XNOR2X1\%noxref_11
cc_1 ( N_A_c_1_p N_noxref_2_c_236_n ) capacitor c=0.0012792f //x=1.34 \
 //y=1.435 //x2=1.6 //y2=1.935
cc_2 ( N_A_c_2_p N_noxref_2_c_236_n ) capacitor c=0.00561986f //x=1.34 \
 //y=1.745 //x2=1.6 //y2=1.935
cc_3 ( N_A_c_3_p N_noxref_2_c_236_n ) capacitor c=0.00440271f //x=1.34 //y=2.1 \
 //x2=1.6 //y2=1.935
cc_4 ( N_A_c_4_p N_noxref_2_c_236_n ) capacitor c=0.00953922f //x=1.715 \
 //y=1.59 //x2=1.6 //y2=1.935
cc_5 ( N_A_c_5_p N_noxref_2_c_236_n ) capacitor c=0.00344663f //x=1.87 \
 //y=1.435 //x2=1.6 //y2=1.935
cc_6 ( N_A_c_6_p N_noxref_2_c_241_n ) capacitor c=6.95554e-19 //x=3.665 \
 //y=4.295 //x2=1.605 //y2=5.42
cc_7 ( N_A_M6_noxref_g N_noxref_2_c_241_n ) capacitor c=0.00141266f //x=1.385 \
 //y=6.2 //x2=1.605 //y2=5.42
cc_8 ( N_A_M7_noxref_g N_noxref_2_c_241_n ) capacitor c=0.00352414f //x=1.825 \
 //y=6.2 //x2=1.605 //y2=5.42
cc_9 ( N_A_c_4_p N_noxref_2_c_244_n ) capacitor c=0.00180253f //x=1.715 \
 //y=1.59 //x2=1.885 //y2=2.02
cc_10 ( N_A_c_10_p N_noxref_2_c_245_n ) capacitor c=0.00440271f //x=1.23 \
 //y=2.265 //x2=1.685 //y2=2.02
cc_11 ( N_A_M7_noxref_g N_noxref_2_c_246_n ) capacitor c=0.0095893f //x=1.825 \
 //y=6.2 //x2=1.885 //y2=5.14
cc_12 ( N_A_c_6_p N_noxref_2_c_247_n ) capacitor c=0.0134563f //x=3.665 \
 //y=4.295 //x2=1.69 //y2=5.14
cc_13 ( N_A_M6_noxref_g N_noxref_2_c_247_n ) capacitor c=0.00534267f //x=1.385 \
 //y=6.2 //x2=1.69 //y2=5.14
cc_14 ( N_A_c_14_p N_noxref_2_c_247_n ) capacitor c=0.00262283f //x=1.75 \
 //y=4.97 //x2=1.69 //y2=5.14
cc_15 ( A N_noxref_2_c_250_n ) capacitor c=0.008006f //x=1.23 //y=2.77 \
 //x2=1.97 //y2=2.615
cc_16 ( A N_noxref_2_c_250_n ) capacitor c=0.00317586f //x=3.82 //y=2.77 \
 //x2=1.97 //y2=2.615
cc_17 ( N_A_c_17_p N_noxref_2_c_250_n ) capacitor c=0.00491431f //x=3.82 \
 //y=2.41 //x2=1.97 //y2=2.615
cc_18 ( N_A_c_18_p N_noxref_2_c_250_n ) capacitor c=0.0181783f //x=1.23 \
 //y=2.265 //x2=1.97 //y2=2.615
cc_19 ( N_A_c_19_p N_noxref_2_c_250_n ) capacitor c=4.71798e-19 //x=1.23 \
 //y=2.265 //x2=1.97 //y2=2.615
cc_20 ( N_A_c_10_p N_noxref_2_c_250_n ) capacitor c=0.00275704f //x=1.23 \
 //y=2.265 //x2=1.97 //y2=2.615
cc_21 ( A N_noxref_2_c_256_n ) capacitor c=0.0147607f //x=1.23 //y=2.77 \
 //x2=1.97 //y2=2.935
cc_22 ( A N_noxref_2_c_256_n ) capacitor c=0.00251745f //x=3.82 //y=2.77 \
 //x2=1.97 //y2=2.935
cc_23 ( N_A_c_6_p N_noxref_2_c_256_n ) capacitor c=0.00251873f //x=3.665 \
 //y=4.295 //x2=1.97 //y2=2.935
cc_24 ( A N_noxref_2_c_259_n ) capacitor c=0.0578343f //x=1.23 //y=2.77 \
 //x2=1.97 //y2=5.055
cc_25 ( A N_noxref_2_c_259_n ) capacitor c=0.0131753f //x=1.23 //y=4.62 \
 //x2=1.97 //y2=5.055
cc_26 ( A N_noxref_2_c_259_n ) capacitor c=0.0228091f //x=3.82 //y=2.77 \
 //x2=1.97 //y2=5.055
cc_27 ( A N_noxref_2_c_259_n ) capacitor c=0.00468956f //x=3.82 //y=4.62 \
 //x2=1.97 //y2=5.055
cc_28 ( A N_noxref_2_c_259_n ) capacitor c=9.78797e-19 //x=1.23 //y=4.25 \
 //x2=1.97 //y2=5.055
cc_29 ( A N_noxref_2_c_259_n ) capacitor c=2.45384e-19 //x=3.82 //y=4.25 \
 //x2=1.97 //y2=5.055
cc_30 ( N_A_c_30_p N_noxref_2_c_259_n ) capacitor c=0.0178943f //x=1.23 \
 //y=4.455 //x2=1.97 //y2=5.055
cc_31 ( N_A_c_31_p N_noxref_2_c_259_n ) capacitor c=0.0169522f //x=1.23 \
 //y=4.76 //x2=1.97 //y2=5.055
cc_32 ( N_A_c_32_p N_noxref_2_c_259_n ) capacitor c=0.00247347f //x=3.82 \
 //y=4.455 //x2=1.97 //y2=5.055
cc_33 ( N_A_c_33_p N_noxref_2_c_259_n ) capacitor c=0.00439873f //x=3.82 \
 //y=4.76 //x2=1.97 //y2=5.055
cc_34 ( N_A_c_34_p N_noxref_2_c_259_n ) capacitor c=0.0032735f //x=1.39 \
 //y=4.295 //x2=1.97 //y2=5.055
cc_35 ( N_A_c_35_p N_noxref_2_c_259_n ) capacitor c=0.00157696f //x=3.825 \
 //y=4.295 //x2=1.97 //y2=5.055
cc_36 ( N_A_c_6_p N_noxref_2_c_259_n ) capacitor c=0.0319178f //x=3.665 \
 //y=4.295 //x2=1.97 //y2=5.055
cc_37 ( N_A_c_37_p N_noxref_2_c_259_n ) capacitor c=0.00160039f //x=1.23 \
 //y=4.88 //x2=1.97 //y2=5.055
cc_38 ( N_A_c_14_p N_noxref_2_c_259_n ) capacitor c=0.00208891f //x=1.75 \
 //y=4.97 //x2=1.97 //y2=5.055
cc_39 ( N_A_c_39_p N_noxref_2_c_259_n ) capacitor c=0.00140024f //x=1.46 \
 //y=4.97 //x2=1.97 //y2=5.055
cc_40 ( A N_noxref_2_c_275_n ) capacitor c=3.84525e-19 //x=3.82 //y=2.77 \
 //x2=8.13 //y2=4.625
cc_41 ( N_A_c_41_p N_noxref_2_c_276_n ) capacitor c=0.00187726f //x=1.34 \
 //y=1.09 //x2=1.6 //y2=1.185
cc_42 ( N_A_c_1_p N_noxref_2_c_276_n ) capacitor c=0.00414335f //x=1.34 \
 //y=1.435 //x2=1.6 //y2=1.185
cc_43 ( N_A_c_43_p N_noxref_2_c_276_n ) capacitor c=5.57924e-19 //x=1.715 \
 //y=0.935 //x2=1.6 //y2=1.185
cc_44 ( N_A_c_4_p N_noxref_2_c_276_n ) capacitor c=5.75878e-19 //x=1.715 \
 //y=1.59 //x2=1.6 //y2=1.185
cc_45 ( N_A_c_45_p N_noxref_2_c_276_n ) capacitor c=0.00148359f //x=1.87 \
 //y=1.09 //x2=1.6 //y2=1.185
cc_46 ( N_A_c_5_p N_noxref_2_c_276_n ) capacitor c=0.00354805f //x=1.87 \
 //y=1.435 //x2=1.6 //y2=1.185
cc_47 ( A N_noxref_2_c_282_n ) capacitor c=0.00349355f //x=1.23 //y=2.77 \
 //x2=1.97 //y2=2.77
cc_48 ( A N_noxref_2_c_283_n ) capacitor c=0.0068343f //x=1.23 //y=2.77 \
 //x2=2.135 //y2=2.775
cc_49 ( A N_noxref_2_c_283_n ) capacitor c=0.00158465f //x=3.82 //y=2.77 \
 //x2=2.135 //y2=2.775
cc_50 ( N_A_c_6_p N_noxref_2_c_283_n ) capacitor c=0.00526669f //x=3.665 \
 //y=4.295 //x2=2.135 //y2=2.775
cc_51 ( A N_noxref_2_c_286_n ) capacitor c=0.0336374f //x=3.82 //y=2.77 \
 //x2=8.085 //y2=2.75
cc_52 ( N_A_c_17_p N_noxref_2_c_286_n ) capacitor c=0.00460402f //x=3.82 \
 //y=2.41 //x2=8.085 //y2=2.75
cc_53 ( N_A_c_32_p N_noxref_2_c_286_n ) capacitor c=0.0021643f //x=3.82 \
 //y=4.455 //x2=8.085 //y2=2.75
cc_54 ( N_A_c_35_p N_noxref_2_c_286_n ) capacitor c=0.00500245f //x=3.825 \
 //y=4.295 //x2=8.085 //y2=2.75
cc_55 ( N_A_c_6_p N_noxref_2_c_286_n ) capacitor c=0.0375329f //x=3.665 \
 //y=4.295 //x2=8.085 //y2=2.75
cc_56 ( N_A_M6_noxref_g N_noxref_2_c_291_n ) capacitor c=0.0162066f //x=1.385 \
 //y=6.2 //x2=1.605 //y2=5.56
cc_57 ( N_A_M7_noxref_g N_noxref_2_c_291_n ) capacitor c=0.0162066f //x=1.825 \
 //y=6.2 //x2=1.605 //y2=5.56
cc_58 ( N_A_c_14_p N_noxref_2_c_291_n ) capacitor c=0.00290963f //x=1.75 \
 //y=4.97 //x2=1.605 //y2=5.56
cc_59 ( N_A_c_41_p N_noxref_2_M0_noxref_d ) capacitor c=0.00137914f //x=1.34 \
 //y=1.09 //x2=1.415 //y2=1.09
cc_60 ( N_A_c_1_p N_noxref_2_M0_noxref_d ) capacitor c=0.0023891f //x=1.34 \
 //y=1.435 //x2=1.415 //y2=1.09
cc_61 ( N_A_c_43_p N_noxref_2_M0_noxref_d ) capacitor c=0.0020782f //x=1.715 \
 //y=0.935 //x2=1.415 //y2=1.09
cc_62 ( N_A_c_4_p N_noxref_2_M0_noxref_d ) capacitor c=0.00356097f //x=1.715 \
 //y=1.59 //x2=1.415 //y2=1.09
cc_63 ( N_A_c_45_p N_noxref_2_M0_noxref_d ) capacitor c=0.00138452f //x=1.87 \
 //y=1.09 //x2=1.415 //y2=1.09
cc_64 ( N_A_c_5_p N_noxref_2_M0_noxref_d ) capacitor c=0.00235934f //x=1.87 \
 //y=1.435 //x2=1.415 //y2=1.09
cc_65 ( A N_Y_c_520_n ) capacitor c=0.00969277f //x=3.82 //y=2.77 //x2=5.42 \
 //y2=3.645
cc_66 ( A N_Y_c_521_n ) capacitor c=0.00562008f //x=3.82 //y=2.77 //x2=5.42 \
 //y2=3.995
cc_67 ( A N_Y_c_522_n ) capacitor c=0.00233906f //x=3.82 //y=2.77 //x2=5.42 \
 //y2=5.3
cc_68 ( A N_Y_c_522_n ) capacitor c=0.00164653f //x=3.82 //y=4.62 //x2=5.42 \
 //y2=5.3
cc_69 ( A N_Y_c_524_n ) capacitor c=8.31378e-19 //x=3.82 //y=2.77 //x2=5.3 \
 //y2=3.88
cc_70 ( A N_Y_c_525_n ) capacitor c=0.00417565f //x=3.82 //y=2.77 //x2=5.465 \
 //y2=3.835
cc_71 ( N_A_c_17_p N_noxref_4_c_819_n ) capacitor c=0.0111189f //x=3.82 \
 //y=2.41 //x2=4.93 //y2=2.385
cc_72 ( N_A_c_72_p N_noxref_4_c_819_n ) capacitor c=3.31511e-19 //x=3.82 \
 //y=2.26 //x2=4.93 //y2=2.385
cc_73 ( N_A_c_73_p N_noxref_4_c_819_n ) capacitor c=0.00133617f //x=3.625 \
 //y=2.095 //x2=4.93 //y2=2.385
cc_74 ( A N_noxref_4_c_822_n ) capacitor c=0.0144142f //x=3.82 //y=2.77 \
 //x2=4.93 //y2=3.025
cc_75 ( N_A_c_17_p N_noxref_4_c_822_n ) capacitor c=0.00108096f //x=3.82 \
 //y=2.41 //x2=4.93 //y2=3.025
cc_76 ( A N_noxref_4_c_824_n ) capacitor c=0.00898808f //x=3.82 //y=2.77 \
 //x2=4.93 //y2=3.14
cc_77 ( A N_noxref_4_c_825_n ) capacitor c=0.0053872f //x=3.82 //y=2.77 \
 //x2=5.075 //y2=3.185
cc_78 ( N_A_c_17_p N_noxref_4_c_826_n ) capacitor c=8.83803e-19 //x=3.82 \
 //y=2.41 //x2=4.93 //y2=2.26
cc_79 ( N_A_c_72_p N_noxref_4_c_826_n ) capacitor c=0.00114266f //x=3.82 \
 //y=2.26 //x2=4.93 //y2=2.26
cc_80 ( N_A_c_73_p N_noxref_4_c_826_n ) capacitor c=0.00190275f //x=3.625 \
 //y=2.095 //x2=4.93 //y2=2.26
cc_81 ( N_A_c_81_p N_noxref_4_c_829_n ) capacitor c=4.86545e-19 //x=3.625 \
 //y=1.045 //x2=4.595 //y2=1.085
cc_82 ( N_A_c_82_p N_noxref_4_c_829_n ) capacitor c=0.00152104f //x=3.625 \
 //y=1.39 //x2=4.595 //y2=1.085
cc_83 ( N_A_c_83_p N_noxref_4_c_829_n ) capacitor c=0.0157772f //x=4.155 \
 //y=1.045 //x2=4.595 //y2=1.085
cc_84 ( N_A_c_84_p N_noxref_4_c_832_n ) capacitor c=0.00109982f //x=3.625 \
 //y=1.7 //x2=4.595 //y2=1.43
cc_85 ( N_A_c_85_p N_noxref_4_c_832_n ) capacitor c=0.0117362f //x=4.155 \
 //y=1.39 //x2=4.595 //y2=1.43
cc_86 ( N_A_c_84_p N_noxref_4_c_834_n ) capacitor c=9.58243e-19 //x=3.625 \
 //y=1.7 //x2=4.595 //y2=1.74
cc_87 ( N_A_c_73_p N_noxref_4_c_834_n ) capacitor c=0.00662747f //x=3.625 \
 //y=2.095 //x2=4.595 //y2=1.74
cc_88 ( N_A_c_85_p N_noxref_4_c_834_n ) capacitor c=0.00862358f //x=4.155 \
 //y=1.39 //x2=4.595 //y2=1.74
cc_89 ( N_A_c_17_p N_noxref_4_c_837_n ) capacitor c=0.00175374f //x=3.82 \
 //y=2.41 //x2=4.595 //y2=2.095
cc_90 ( N_A_c_72_p N_noxref_4_c_837_n ) capacitor c=0.00214703f //x=3.82 \
 //y=2.26 //x2=4.595 //y2=2.095
cc_91 ( N_A_c_73_p N_noxref_4_c_837_n ) capacitor c=0.0121683f //x=3.625 \
 //y=2.095 //x2=4.595 //y2=2.095
cc_92 ( N_A_c_83_p N_noxref_4_c_840_n ) capacitor c=0.00124821f //x=4.155 \
 //y=1.045 //x2=5.125 //y2=1.085
cc_93 ( N_A_c_85_p N_noxref_4_c_841_n ) capacitor c=0.00204774f //x=4.155 \
 //y=1.39 //x2=5.125 //y2=1.43
cc_94 ( A B ) capacitor c=0.00705752f //x=3.82 //y=4.62 //x2=4.93 //y2=4.62
cc_95 ( N_A_c_95_p B ) capacitor c=3.75029e-19 //x=3.82 //y=4.88 //x2=4.93 \
 //y2=4.62
cc_96 ( A B ) capacitor c=3.5216e-19 //x=3.82 //y=2.77 //x2=4.93 //y2=4.25
cc_97 ( A B ) capacitor c=0.00113548f //x=3.82 //y=4.62 //x2=4.93 //y2=4.25
cc_98 ( A B ) capacitor c=0.0056532f //x=3.82 //y=4.25 //x2=4.93 //y2=4.25
cc_99 ( N_A_c_32_p B ) capacitor c=0.00892849f //x=3.82 //y=4.455 //x2=4.93 \
 //y2=4.25
cc_100 ( N_A_c_35_p B ) capacitor c=0.00267334f //x=3.825 //y=4.295 //x2=4.93 \
 //y2=4.25
cc_101 ( N_A_c_33_p N_B_c_1125_n ) capacitor c=0.0112009f //x=3.82 //y=4.76 \
 //x2=4.93 //y2=4.76
cc_102 ( N_A_c_95_p N_B_c_1125_n ) capacitor c=4.56604e-19 //x=3.82 //y=4.88 \
 //x2=4.93 //y2=4.76
cc_103 ( N_A_c_103_p N_B_c_1125_n ) capacitor c=0.00131752f //x=3.82 //y=4.88 \
 //x2=4.93 //y2=4.76
cc_104 ( A N_B_c_1128_n ) capacitor c=5.6846e-19 //x=3.82 //y=4.62 //x2=4.91 \
 //y2=4.25
cc_105 ( N_A_c_32_p N_B_c_1128_n ) capacitor c=0.00217482f //x=3.82 //y=4.455 \
 //x2=4.91 //y2=4.25
cc_106 ( N_A_c_35_p N_B_c_1128_n ) capacitor c=0.00977878f //x=3.825 //y=4.295 \
 //x2=4.91 //y2=4.25
cc_107 ( A N_B_c_1131_n ) capacitor c=3.75029e-19 //x=3.82 //y=4.62 //x2=4.93 \
 //y2=4.88
cc_108 ( N_A_c_33_p N_B_c_1131_n ) capacitor c=4.56604e-19 //x=3.82 //y=4.76 \
 //x2=4.93 //y2=4.88
cc_109 ( N_A_c_95_p N_B_c_1131_n ) capacitor c=0.00114285f //x=3.82 //y=4.88 \
 //x2=4.93 //y2=4.88
cc_110 ( N_A_c_103_p N_B_c_1131_n ) capacitor c=0.00195576f //x=3.82 //y=4.88 \
 //x2=4.93 //y2=4.88
cc_111 ( N_A_M8_noxref_g N_B_M10_noxref_g ) capacitor c=0.010199f //x=3.72 \
 //y=6.2 //x2=4.6 //y2=6.2
cc_112 ( N_A_M9_noxref_g N_B_M10_noxref_g ) capacitor c=0.0618855f //x=4.16 \
 //y=6.2 //x2=4.6 //y2=6.2
cc_113 ( N_A_M9_noxref_g N_B_M11_noxref_g ) capacitor c=0.00945236f //x=4.16 \
 //y=6.2 //x2=5.04 //y2=6.2
cc_114 ( N_A_c_33_p N_B_c_1138_n ) capacitor c=0.00131186f //x=3.82 //y=4.76 \
 //x2=4.93 //y2=4.88
cc_115 ( N_A_c_95_p N_B_c_1138_n ) capacitor c=0.0019442f //x=3.82 //y=4.88 \
 //x2=4.93 //y2=4.88
cc_116 ( N_A_c_103_p N_B_c_1138_n ) capacitor c=0.067621f //x=3.82 //y=4.88 \
 //x2=4.93 //y2=4.88
cc_117 ( N_A_c_30_p N_VDD_c_1422_n ) capacitor c=3.16961e-19 //x=1.23 \
 //y=4.455 //x2=3.855 //y2=7.585
cc_118 ( N_A_c_31_p N_VDD_c_1422_n ) capacitor c=5.73169e-19 //x=1.23 //y=4.76 \
 //x2=3.855 //y2=7.585
cc_119 ( N_A_c_37_p N_VDD_c_1422_n ) capacitor c=3.40755e-19 //x=1.23 //y=4.88 \
 //x2=3.855 //y2=7.585
cc_120 ( N_A_M8_noxref_g N_VDD_c_1425_n ) capacitor c=0.00421585f //x=3.72 \
 //y=6.2 //x2=3.94 //y2=6.7
cc_121 ( N_A_M9_noxref_g N_VDD_c_1425_n ) capacitor c=0.00397605f //x=4.16 \
 //y=6.2 //x2=3.94 //y2=6.7
cc_122 ( N_A_M8_noxref_g N_VDD_c_1427_n ) capacitor c=0.00555236f //x=3.72 \
 //y=6.2 //x2=3.94 //y2=7.41
cc_123 ( N_A_M9_noxref_g N_VDD_c_1427_n ) capacitor c=0.00559783f //x=4.16 \
 //y=6.2 //x2=3.94 //y2=7.41
cc_124 ( N_A_c_30_p N_VDD_c_1429_n ) capacitor c=2.91857e-19 //x=1.23 \
 //y=4.455 //x2=1.96 //y2=7.585
cc_125 ( N_A_c_31_p N_VDD_c_1429_n ) capacitor c=5.48929e-19 //x=1.23 //y=4.76 \
 //x2=1.96 //y2=7.585
cc_126 ( N_A_M6_noxref_g N_VDD_c_1429_n ) capacitor c=0.00753931f //x=1.385 \
 //y=6.2 //x2=1.96 //y2=7.585
cc_127 ( N_A_M7_noxref_g N_VDD_c_1429_n ) capacitor c=0.00755544f //x=1.825 \
 //y=6.2 //x2=1.96 //y2=7.585
cc_128 ( N_A_M8_noxref_g N_VDD_c_1433_n ) capacitor c=0.00732618f //x=3.72 \
 //y=6.2 //x2=5.87 //y2=7.585
cc_129 ( N_A_M9_noxref_g N_VDD_c_1433_n ) capacitor c=0.00773472f //x=4.16 \
 //y=6.2 //x2=5.87 //y2=7.585
cc_130 ( A N_VDD_c_1435_n ) capacitor c=0.00885311f //x=1.23 //y=4.62 \
 //x2=1.23 //y2=7.58
cc_131 ( A N_VDD_c_1435_n ) capacitor c=0.00440981f //x=1.23 //y=4.25 \
 //x2=1.23 //y2=7.58
cc_132 ( N_A_c_30_p N_VDD_c_1435_n ) capacitor c=0.00394762f //x=1.23 \
 //y=4.455 //x2=1.23 //y2=7.58
cc_133 ( N_A_c_31_p N_VDD_c_1435_n ) capacitor c=0.00871538f //x=1.23 //y=4.76 \
 //x2=1.23 //y2=7.58
cc_134 ( N_A_c_37_p N_VDD_c_1435_n ) capacitor c=0.00795505f //x=1.23 //y=4.88 \
 //x2=1.23 //y2=7.58
cc_135 ( N_A_M6_noxref_g N_VDD_c_1435_n ) capacitor c=0.0150194f //x=1.385 \
 //y=6.2 //x2=1.23 //y2=7.58
cc_136 ( N_A_c_39_p N_VDD_c_1435_n ) capacitor c=0.00799922f //x=1.46 //y=4.97 \
 //x2=1.23 //y2=7.58
cc_137 ( A N_VDD_c_1442_n ) capacitor c=0.00471652f //x=3.82 //y=4.62 \
 //x2=2.71 //y2=7.585
cc_138 ( A N_VDD_c_1442_n ) capacitor c=0.00133985f //x=1.23 //y=4.25 \
 //x2=2.71 //y2=7.585
cc_139 ( A N_VDD_c_1442_n ) capacitor c=0.00247563f //x=3.82 //y=4.25 \
 //x2=2.71 //y2=7.585
cc_140 ( N_A_c_32_p N_VDD_c_1442_n ) capacitor c=0.00192032f //x=3.82 \
 //y=4.455 //x2=2.71 //y2=7.585
cc_141 ( N_A_c_33_p N_VDD_c_1442_n ) capacitor c=0.00391704f //x=3.82 //y=4.76 \
 //x2=2.71 //y2=7.585
cc_142 ( N_A_c_6_p N_VDD_c_1442_n ) capacitor c=0.0192133f //x=3.665 //y=4.295 \
 //x2=2.71 //y2=7.585
cc_143 ( N_A_c_37_p N_VDD_c_1442_n ) capacitor c=0.00235165f //x=1.23 //y=4.88 \
 //x2=2.71 //y2=7.585
cc_144 ( N_A_c_95_p N_VDD_c_1442_n ) capacitor c=0.00370683f //x=3.82 //y=4.88 \
 //x2=2.71 //y2=7.585
cc_145 ( N_A_c_14_p N_VDD_c_1442_n ) capacitor c=0.00838585f //x=1.75 //y=4.97 \
 //x2=2.71 //y2=7.585
cc_146 ( N_A_c_39_p N_VDD_c_1442_n ) capacitor c=2.63786e-19 //x=1.46 //y=4.97 \
 //x2=2.71 //y2=7.585
cc_147 ( N_A_c_103_p N_VDD_c_1442_n ) capacitor c=0.0160742f //x=3.82 //y=4.88 \
 //x2=2.71 //y2=7.585
cc_148 ( N_A_c_30_p N_VDD_M6_noxref_s ) capacitor c=0.00194465f //x=1.23 \
 //y=4.455 //x2=1.03 //y2=5.2
cc_149 ( N_A_c_31_p N_VDD_M6_noxref_s ) capacitor c=0.0220877f //x=1.23 \
 //y=4.76 //x2=1.03 //y2=5.2
cc_150 ( N_A_c_34_p N_VDD_M6_noxref_s ) capacitor c=5.9996e-19 //x=1.39 \
 //y=4.295 //x2=1.03 //y2=5.2
cc_151 ( N_A_c_37_p N_VDD_M6_noxref_s ) capacitor c=0.00986169f //x=1.23 \
 //y=4.88 //x2=1.03 //y2=5.2
cc_152 ( N_A_M6_noxref_g N_VDD_M6_noxref_s ) capacitor c=0.0573441f //x=1.385 \
 //y=6.2 //x2=1.03 //y2=5.2
cc_153 ( N_A_c_39_p N_VDD_M6_noxref_s ) capacitor c=0.00529723f //x=1.46 \
 //y=4.97 //x2=1.03 //y2=5.2
cc_154 ( N_A_c_6_p N_VDD_M7_noxref_d ) capacitor c=0.00270279f //x=3.665 \
 //y=4.295 //x2=1.9 //y2=5.2
cc_155 ( N_A_M7_noxref_g N_VDD_M7_noxref_d ) capacitor c=0.0572684f //x=1.825 \
 //y=6.2 //x2=1.9 //y2=5.2
cc_156 ( N_A_c_95_p N_VDD_M8_noxref_d ) capacitor c=0.0015298f //x=3.82 \
 //y=4.88 //x2=3.795 //y2=5.2
cc_157 ( N_A_M8_noxref_g N_VDD_M8_noxref_d ) capacitor c=0.00917375f //x=3.72 \
 //y=6.2 //x2=3.795 //y2=5.2
cc_158 ( N_A_M9_noxref_g N_VDD_M8_noxref_d ) capacitor c=0.00917375f //x=4.16 \
 //y=6.2 //x2=3.795 //y2=5.2
cc_159 ( N_A_c_103_p N_VDD_M8_noxref_d ) capacitor c=0.00331893f //x=3.82 \
 //y=4.88 //x2=3.795 //y2=5.2
cc_160 ( N_A_c_32_p N_noxref_7_c_1679_n ) capacitor c=0.00192699f //x=3.82 \
 //y=4.455 //x2=4.265 //y2=5.385
cc_161 ( N_A_c_33_p N_noxref_7_c_1679_n ) capacitor c=0.0209222f //x=3.82 \
 //y=4.76 //x2=4.265 //y2=5.385
cc_162 ( N_A_c_35_p N_noxref_7_c_1679_n ) capacitor c=0.00174202f //x=3.825 \
 //y=4.295 //x2=4.265 //y2=5.385
cc_163 ( N_A_c_95_p N_noxref_7_c_1679_n ) capacitor c=0.00412201f //x=3.82 \
 //y=4.88 //x2=4.265 //y2=5.385
cc_164 ( N_A_M8_noxref_g N_noxref_7_c_1679_n ) capacitor c=0.0102413f //x=3.72 \
 //y=6.2 //x2=4.265 //y2=5.385
cc_165 ( N_A_M9_noxref_g N_noxref_7_c_1679_n ) capacitor c=0.0136407f //x=4.16 \
 //y=6.2 //x2=4.265 //y2=5.385
cc_166 ( N_A_c_103_p N_noxref_7_c_1679_n ) capacitor c=0.00183061f //x=3.82 \
 //y=4.88 //x2=4.265 //y2=5.385
cc_167 ( N_A_c_32_p N_noxref_7_c_1686_n ) capacitor c=0.00220276f //x=3.82 \
 //y=4.455 //x2=3.505 //y2=5.385
cc_168 ( N_A_c_6_p N_noxref_7_c_1686_n ) capacitor c=0.00647784f //x=3.665 \
 //y=4.295 //x2=3.505 //y2=5.385
cc_169 ( N_A_M8_noxref_g N_noxref_7_c_1686_n ) capacitor c=0.00428908f \
 //x=3.72 //y=6.2 //x2=3.505 //y2=5.385
cc_170 ( N_A_M9_noxref_g N_noxref_7_c_1689_n ) capacitor c=0.00178392f \
 //x=4.16 //y=6.2 //x2=4.382 //y2=5.385
cc_171 ( N_A_M9_noxref_g N_noxref_7_c_1690_n ) capacitor c=0.00188042f \
 //x=4.16 //y=6.2 //x2=4.38 //y2=6.915
cc_172 ( N_A_c_32_p N_noxref_7_c_1691_n ) capacitor c=3.5629e-19 //x=3.82 \
 //y=4.455 //x2=3.5 //y2=5.555
cc_173 ( N_A_M8_noxref_g N_noxref_7_c_1691_n ) capacitor c=0.0466274f //x=3.72 \
 //y=6.2 //x2=3.5 //y2=5.555
cc_174 ( N_A_M9_noxref_g N_noxref_7_c_1693_n ) capacitor c=0.0183685f //x=4.16 \
 //y=6.2 //x2=4.38 //y2=5.555
cc_175 ( N_A_M8_noxref_g N_noxref_7_M8_noxref_s ) capacitor c=0.00518103f \
 //x=3.72 //y=6.2 //x2=3.365 //y2=5.2
cc_176 ( N_A_c_30_p N_GND_c_1850_n ) capacitor c=2.70856e-19 //x=1.23 \
 //y=4.455 //x2=3.805 //y2=0.175
cc_177 ( N_A_c_17_p N_GND_c_1850_n ) capacitor c=7.52441e-19 //x=3.82 //y=2.41 \
 //x2=3.805 //y2=0.175
cc_178 ( N_A_c_32_p N_GND_c_1850_n ) capacitor c=2.75179e-19 //x=3.82 \
 //y=4.455 //x2=3.805 //y2=0.175
cc_179 ( N_A_c_18_p N_GND_c_1850_n ) capacitor c=0.00249122f //x=1.23 \
 //y=2.265 //x2=3.805 //y2=0.175
cc_180 ( N_A_c_19_p N_GND_c_1850_n ) capacitor c=7.5371e-19 //x=1.23 //y=2.265 \
 //x2=3.805 //y2=0.175
cc_181 ( N_A_c_17_p N_GND_c_1855_n ) capacitor c=0.00608659f //x=3.82 //y=2.41 \
 //x2=3.89 //y2=1.02
cc_182 ( N_A_c_72_p N_GND_c_1855_n ) capacitor c=4.2774e-19 //x=3.82 //y=2.26 \
 //x2=3.89 //y2=1.02
cc_183 ( N_A_c_81_p N_GND_c_1855_n ) capacitor c=0.00147588f //x=3.625 \
 //y=1.045 //x2=3.89 //y2=1.02
cc_184 ( N_A_c_82_p N_GND_c_1855_n ) capacitor c=0.00298332f //x=3.625 \
 //y=1.39 //x2=3.89 //y2=1.02
cc_185 ( N_A_c_185_p N_GND_c_1855_n ) capacitor c=0.00927154f //x=4 //y=0.89 \
 //x2=3.89 //y2=1.02
cc_186 ( N_A_c_186_p N_GND_c_1855_n ) capacitor c=5.99853e-19 //x=4 //y=1.545 \
 //x2=3.89 //y2=1.02
cc_187 ( N_A_c_83_p N_GND_c_1855_n ) capacitor c=0.00166772f //x=4.155 \
 //y=1.045 //x2=3.89 //y2=1.02
cc_188 ( N_A_c_85_p N_GND_c_1855_n ) capacitor c=0.00229582f //x=4.155 \
 //y=1.39 //x2=3.89 //y2=1.02
cc_189 ( N_A_c_18_p N_GND_c_1863_n ) capacitor c=0.00108343f //x=1.23 \
 //y=2.265 //x2=1.515 //y2=0.715
cc_190 ( N_A_c_19_p N_GND_c_1863_n ) capacitor c=3.95714e-19 //x=1.23 \
 //y=2.265 //x2=1.515 //y2=0.715
cc_191 ( N_A_c_41_p N_GND_c_1863_n ) capacitor c=0.0124814f //x=1.34 //y=1.09 \
 //x2=1.515 //y2=0.715
cc_192 ( N_A_c_10_p N_GND_c_1863_n ) capacitor c=2.1838e-19 //x=1.23 //y=2.265 \
 //x2=1.515 //y2=0.715
cc_193 ( N_A_c_45_p N_GND_c_1867_n ) capacitor c=0.0130753f //x=1.87 //y=1.09 \
 //x2=2.005 //y2=0.715
cc_194 ( N_A_c_81_p N_GND_c_1868_n ) capacitor c=0.00691328f //x=3.625 \
 //y=1.045 //x2=5.87 //y2=0.175
cc_195 ( A N_GND_c_1869_n ) capacitor c=0.0137596f //x=1.23 //y=2.77 //x2=1.12 \
 //y2=0.175
cc_196 ( N_A_c_18_p N_GND_c_1869_n ) capacitor c=0.0100674f //x=1.23 //y=2.265 \
 //x2=1.12 //y2=0.175
cc_197 ( N_A_c_19_p N_GND_c_1869_n ) capacitor c=0.00733542f //x=1.23 \
 //y=2.265 //x2=1.12 //y2=0.175
cc_198 ( N_A_c_3_p N_GND_c_1869_n ) capacitor c=0.00552086f //x=1.34 //y=2.1 \
 //x2=1.12 //y2=0.175
cc_199 ( N_A_c_10_p N_GND_c_1869_n ) capacitor c=0.00785621f //x=1.23 \
 //y=2.265 //x2=1.12 //y2=0.175
cc_200 ( A N_GND_c_1874_n ) capacitor c=0.00691543f //x=3.82 //y=2.77 \
 //x2=2.71 //y2=0.175
cc_201 ( N_A_c_17_p N_GND_c_1874_n ) capacitor c=0.00459806f //x=3.82 //y=2.41 \
 //x2=2.71 //y2=0.175
cc_202 ( N_A_c_6_p N_GND_c_1874_n ) capacitor c=0.00224398f //x=3.665 \
 //y=4.295 //x2=2.71 //y2=0.175
cc_203 ( N_A_c_19_p N_GND_c_1874_n ) capacitor c=0.0022444f //x=1.23 //y=2.265 \
 //x2=2.71 //y2=0.175
cc_204 ( N_A_c_72_p N_GND_c_1874_n ) capacitor c=0.00385846f //x=3.82 //y=2.26 \
 //x2=2.71 //y2=0.175
cc_205 ( N_A_c_73_p N_GND_c_1874_n ) capacitor c=0.00887431f //x=3.625 \
 //y=2.095 //x2=2.71 //y2=0.175
cc_206 ( N_A_c_10_p N_GND_c_1874_n ) capacitor c=2.63786e-19 //x=1.23 \
 //y=2.265 //x2=2.71 //y2=0.175
cc_207 ( N_A_c_30_p N_GND_M0_noxref_s ) capacitor c=2.04723e-19 //x=1.23 \
 //y=4.455 //x2=0.985 //y2=0.55
cc_208 ( N_A_c_18_p N_GND_M0_noxref_s ) capacitor c=0.00297876f //x=1.23 \
 //y=2.265 //x2=0.985 //y2=0.55
cc_209 ( N_A_c_19_p N_GND_M0_noxref_s ) capacitor c=0.00651326f //x=1.23 \
 //y=2.265 //x2=0.985 //y2=0.55
cc_210 ( N_A_c_41_p N_GND_M0_noxref_s ) capacitor c=0.0300221f //x=1.34 \
 //y=1.09 //x2=0.985 //y2=0.55
cc_211 ( N_A_c_2_p N_GND_M0_noxref_s ) capacitor c=0.002132f //x=1.34 \
 //y=1.745 //x2=0.985 //y2=0.55
cc_212 ( N_A_c_3_p N_GND_M0_noxref_s ) capacitor c=0.00304786f //x=1.34 \
 //y=2.1 //x2=0.985 //y2=0.55
cc_213 ( N_A_c_43_p N_GND_M0_noxref_s ) capacitor c=0.00517463f //x=1.715 \
 //y=0.935 //x2=0.985 //y2=0.55
cc_214 ( N_A_c_45_p N_GND_M0_noxref_s ) capacitor c=0.0153553f //x=1.87 \
 //y=1.09 //x2=0.985 //y2=0.55
cc_215 ( N_A_c_5_p N_GND_M0_noxref_s ) capacitor c=0.00629878f //x=1.87 \
 //y=1.435 //x2=0.985 //y2=0.55
cc_216 ( N_A_c_10_p N_GND_M0_noxref_s ) capacitor c=0.00660555f //x=1.23 \
 //y=2.265 //x2=0.985 //y2=0.55
cc_217 ( N_A_c_17_p N_GND_M1_noxref_d ) capacitor c=4.2739e-19 //x=3.82 \
 //y=2.41 //x2=3.7 //y2=1.045
cc_218 ( N_A_c_81_p N_GND_M1_noxref_d ) capacitor c=0.00192399f //x=3.625 \
 //y=1.045 //x2=3.7 //y2=1.045
cc_219 ( N_A_c_82_p N_GND_M1_noxref_d ) capacitor c=0.00228784f //x=3.625 \
 //y=1.39 //x2=3.7 //y2=1.045
cc_220 ( N_A_c_185_p N_GND_M1_noxref_d ) capacitor c=0.0047434f //x=4 //y=0.89 \
 //x2=3.7 //y2=1.045
cc_221 ( N_A_c_186_p N_GND_M1_noxref_d ) capacitor c=0.00172481f //x=4 \
 //y=1.545 //x2=3.7 //y2=1.045
cc_222 ( N_A_c_83_p N_GND_M1_noxref_d ) capacitor c=0.00230174f //x=4.155 \
 //y=1.045 //x2=3.7 //y2=1.045
cc_223 ( N_A_c_85_p N_GND_M1_noxref_d ) capacitor c=0.00228784f //x=4.155 \
 //y=1.39 //x2=3.7 //y2=1.045
cc_224 ( N_A_c_73_p N_noxref_10_c_2093_n ) capacitor c=0.00262672f //x=3.625 \
 //y=2.095 //x2=3.405 //y2=1.675
cc_225 ( N_A_c_17_p N_noxref_10_c_2094_n ) capacitor c=0.00501576f //x=3.82 \
 //y=2.41 //x2=4.29 //y2=1.76
cc_226 ( N_A_c_32_p N_noxref_10_c_2094_n ) capacitor c=0.00315352f //x=3.82 \
 //y=4.455 //x2=4.29 //y2=1.76
cc_227 ( N_A_c_72_p N_noxref_10_c_2094_n ) capacitor c=0.00763108f //x=3.82 \
 //y=2.26 //x2=4.29 //y2=1.76
cc_228 ( N_A_c_84_p N_noxref_10_c_2094_n ) capacitor c=0.0069585f //x=3.625 \
 //y=1.7 //x2=4.29 //y2=1.76
cc_229 ( N_A_c_73_p N_noxref_10_c_2094_n ) capacitor c=0.0175627f //x=3.625 \
 //y=2.095 //x2=4.29 //y2=1.76
cc_230 ( N_A_c_186_p N_noxref_10_c_2094_n ) capacitor c=0.00720058f //x=4 \
 //y=1.545 //x2=4.29 //y2=1.76
cc_231 ( N_A_c_85_p N_noxref_10_c_2094_n ) capacitor c=0.00339872f //x=4.155 \
 //y=1.39 //x2=4.29 //y2=1.76
cc_232 ( N_A_c_73_p N_noxref_10_c_2101_n ) capacitor c=6.71402e-19 //x=3.625 \
 //y=2.095 //x2=4.375 //y2=1.675
cc_233 ( N_A_c_81_p N_noxref_10_M1_noxref_s ) capacitor c=0.0293797f //x=3.625 \
 //y=1.045 //x2=3.27 //y2=0.545
cc_234 ( N_A_c_84_p N_noxref_10_M1_noxref_s ) capacitor c=3.48408e-19 \
 //x=3.625 //y=1.7 //x2=3.27 //y2=0.545
cc_235 ( N_A_c_83_p N_noxref_10_M1_noxref_s ) capacitor c=0.0124314f //x=4.155 \
 //y=1.045 //x2=3.27 //y2=0.545
cc_236 ( N_noxref_2_c_300_p Y ) capacitor c=0.0345936f //x=8.13 //y=2.915 \
 //x2=8.63 //y2=2.4
cc_237 ( N_noxref_2_c_275_n Y ) capacitor c=0.0508488f //x=8.13 //y=4.625 \
 //x2=8.63 //y2=2.4
cc_238 ( N_noxref_2_c_302_p Y ) capacitor c=0.0315493f //x=8.26 //y=2.385 \
 //x2=8.63 //y2=2.4
cc_239 ( N_noxref_2_c_303_p Y ) capacitor c=0.0178085f //x=8.26 //y=2.595 \
 //x2=8.63 //y2=2.4
cc_240 ( N_noxref_2_c_304_p Y ) capacitor c=0.00287239f //x=8.26 //y=2.77 \
 //x2=8.63 //y2=2.4
cc_241 ( N_noxref_2_c_305_p Y ) capacitor c=0.0126551f //x=8.245 //y=2.75 \
 //x2=8.63 //y2=2.4
cc_242 ( N_noxref_2_c_306_p Y ) capacitor c=0.00291366f //x=8.26 //y=2.26 \
 //x2=8.63 //y2=2.4
cc_243 ( N_noxref_2_c_307_p Y ) capacitor c=0.0084769f //x=7.925 //y=2.095 \
 //x2=8.63 //y2=2.4
cc_244 ( N_noxref_2_c_275_n Y ) capacitor c=0.0750066f //x=8.13 //y=4.625 \
 //x2=8.63 //y2=4.99
cc_245 ( N_noxref_2_c_309_p Y ) capacitor c=0.00242208f //x=8.26 //y=4.88 \
 //x2=8.63 //y2=4.99
cc_246 ( N_noxref_2_c_310_p Y ) capacitor c=0.00933199f //x=8.26 //y=4.88 \
 //x2=8.63 //y2=4.99
cc_247 ( N_noxref_2_c_275_n Y ) capacitor c=0.00513879f //x=8.13 //y=4.625 \
 //x2=8.63 //y2=3.88
cc_248 ( N_noxref_2_c_286_n N_Y_c_538_n ) capacitor c=4.97573e-19 //x=8.085 \
 //y=2.75 //x2=4.86 //y2=1.295
cc_249 ( N_noxref_2_c_236_n N_Y_c_539_n ) capacitor c=0.00493811f //x=1.6 \
 //y=1.935 //x2=4.86 //y2=1.745
cc_250 ( N_noxref_2_c_276_n N_Y_c_539_n ) capacitor c=4.17953e-19 //x=1.6 \
 //y=1.185 //x2=4.86 //y2=1.745
cc_251 ( N_noxref_2_c_286_n N_Y_c_541_n ) capacitor c=0.00739595f //x=8.085 \
 //y=2.75 //x2=5.335 //y2=1.83
cc_252 ( N_noxref_2_c_286_n N_Y_c_542_n ) capacitor c=0.00107797f //x=8.085 \
 //y=2.75 //x2=4.945 //y2=1.83
cc_253 ( N_noxref_2_c_244_n N_Y_c_520_n ) capacitor c=0.00189597f //x=1.885 \
 //y=2.02 //x2=5.42 //y2=3.645
cc_254 ( N_noxref_2_c_300_p N_Y_c_520_n ) capacitor c=0.00136571f //x=8.13 \
 //y=2.915 //x2=5.42 //y2=3.645
cc_255 ( N_noxref_2_c_303_p N_Y_c_520_n ) capacitor c=4.8287e-19 //x=8.26 \
 //y=2.595 //x2=5.42 //y2=3.645
cc_256 ( N_noxref_2_c_286_n N_Y_c_520_n ) capacitor c=0.027366f //x=8.085 \
 //y=2.75 //x2=5.42 //y2=3.645
cc_257 ( N_noxref_2_c_275_n N_Y_c_521_n ) capacitor c=0.00767831f //x=8.13 \
 //y=4.625 //x2=5.42 //y2=3.995
cc_258 ( N_noxref_2_c_241_n N_Y_c_522_n ) capacitor c=6.97655e-19 //x=1.605 \
 //y=5.42 //x2=5.42 //y2=5.3
cc_259 ( N_noxref_2_c_259_n N_Y_c_522_n ) capacitor c=0.00223299f //x=1.97 \
 //y=5.055 //x2=5.42 //y2=5.3
cc_260 ( N_noxref_2_c_275_n N_Y_c_522_n ) capacitor c=4.82377e-19 //x=8.13 \
 //y=4.625 //x2=5.42 //y2=5.3
cc_261 ( N_noxref_2_c_300_p N_Y_c_551_n ) capacitor c=4.73637e-19 //x=8.13 \
 //y=2.915 //x2=8.19 //y2=1.3
cc_262 ( N_noxref_2_c_305_p N_Y_c_551_n ) capacitor c=2.49761e-19 //x=8.245 \
 //y=2.75 //x2=8.19 //y2=1.3
cc_263 ( N_noxref_2_c_327_p N_Y_c_551_n ) capacitor c=8.07133e-19 //x=7.925 \
 //y=1.085 //x2=8.19 //y2=1.3
cc_264 ( N_noxref_2_c_328_p N_Y_c_551_n ) capacitor c=0.0020872f //x=7.925 \
 //y=1.43 //x2=8.19 //y2=1.3
cc_265 ( N_noxref_2_c_329_p N_Y_c_551_n ) capacitor c=5.3577e-19 //x=8.3 \
 //y=0.93 //x2=8.19 //y2=1.3
cc_266 ( N_noxref_2_c_330_p N_Y_c_551_n ) capacitor c=4.55105e-19 //x=8.3 \
 //y=1.585 //x2=8.19 //y2=1.3
cc_267 ( N_noxref_2_c_331_p N_Y_c_551_n ) capacitor c=6.55329e-19 //x=8.455 \
 //y=1.085 //x2=8.19 //y2=1.3
cc_268 ( N_noxref_2_c_332_p N_Y_c_551_n ) capacitor c=0.00312902f //x=8.455 \
 //y=1.43 //x2=8.19 //y2=1.3
cc_269 ( N_noxref_2_c_328_p N_Y_c_559_n ) capacitor c=0.00119008f //x=7.925 \
 //y=1.43 //x2=8.19 //y2=1.745
cc_270 ( N_noxref_2_c_334_p N_Y_c_559_n ) capacitor c=0.00410123f //x=7.925 \
 //y=1.74 //x2=8.19 //y2=1.745
cc_271 ( N_noxref_2_c_307_p N_Y_c_559_n ) capacitor c=0.00329274f //x=7.925 \
 //y=2.095 //x2=8.19 //y2=1.745
cc_272 ( N_noxref_2_c_330_p N_Y_c_559_n ) capacitor c=0.00743418f //x=8.3 \
 //y=1.585 //x2=8.19 //y2=1.745
cc_273 ( N_noxref_2_c_332_p N_Y_c_559_n ) capacitor c=0.00303393f //x=8.455 \
 //y=1.43 //x2=8.19 //y2=1.745
cc_274 ( N_noxref_2_c_275_n N_Y_c_564_n ) capacitor c=0.00404703f //x=8.13 \
 //y=4.625 //x2=8.545 //y2=5.385
cc_275 ( N_noxref_2_c_309_p N_Y_c_564_n ) capacitor c=0.00104675f //x=8.26 \
 //y=4.88 //x2=8.545 //y2=5.385
cc_276 ( N_noxref_2_M15_noxref_g N_Y_c_564_n ) capacitor c=0.00979435f \
 //x=8.37 //y=6.2 //x2=8.545 //y2=5.385
cc_277 ( N_noxref_2_c_300_p N_Y_c_567_n ) capacitor c=7.47623e-19 //x=8.13 \
 //y=2.915 //x2=8.545 //y2=1.83
cc_278 ( N_noxref_2_c_302_p N_Y_c_567_n ) capacitor c=0.00327978f //x=8.26 \
 //y=2.385 //x2=8.545 //y2=1.83
cc_279 ( N_noxref_2_c_305_p N_Y_c_567_n ) capacitor c=3.70779e-19 //x=8.245 \
 //y=2.75 //x2=8.545 //y2=1.83
cc_280 ( N_noxref_2_c_306_p N_Y_c_567_n ) capacitor c=0.00147657f //x=8.26 \
 //y=2.26 //x2=8.545 //y2=1.83
cc_281 ( N_noxref_2_c_330_p N_Y_c_567_n ) capacitor c=0.00124426f //x=8.3 \
 //y=1.585 //x2=8.545 //y2=1.83
cc_282 ( N_noxref_2_c_332_p N_Y_c_567_n ) capacitor c=0.00300259f //x=8.455 \
 //y=1.43 //x2=8.545 //y2=1.83
cc_283 ( N_noxref_2_c_300_p N_Y_c_573_n ) capacitor c=0.00136672f //x=8.13 \
 //y=2.915 //x2=8.275 //y2=1.83
cc_284 ( N_noxref_2_c_302_p N_Y_c_573_n ) capacitor c=0.0234751f //x=8.26 \
 //y=2.385 //x2=8.275 //y2=1.83
cc_285 ( N_noxref_2_c_305_p N_Y_c_573_n ) capacitor c=6.62009e-19 //x=8.245 \
 //y=2.75 //x2=8.275 //y2=1.83
cc_286 ( N_noxref_2_c_306_p N_Y_c_573_n ) capacitor c=0.00408137f //x=8.26 \
 //y=2.26 //x2=8.275 //y2=1.83
cc_287 ( N_noxref_2_c_307_p N_Y_c_573_n ) capacitor c=0.00193155f //x=7.925 \
 //y=2.095 //x2=8.275 //y2=1.83
cc_288 ( N_noxref_2_c_300_p N_Y_c_578_n ) capacitor c=0.00114284f //x=8.13 \
 //y=2.915 //x2=8.63 //y2=4.115
cc_289 ( N_noxref_2_c_275_n N_Y_c_578_n ) capacitor c=0.037021f //x=8.13 \
 //y=4.625 //x2=8.63 //y2=4.115
cc_290 ( N_noxref_2_c_310_p N_Y_c_578_n ) capacitor c=7.32551e-19 //x=8.26 \
 //y=4.88 //x2=8.63 //y2=4.115
cc_291 ( N_noxref_2_c_241_n N_Y_c_581_n ) capacitor c=3.86497e-19 //x=1.605 \
 //y=5.42 //x2=4.82 //y2=5.385
cc_292 ( N_noxref_2_c_275_n N_Y_c_582_n ) capacitor c=0.027931f //x=8.13 \
 //y=4.625 //x2=8.15 //y2=5.385
cc_293 ( N_noxref_2_c_309_p N_Y_c_582_n ) capacitor c=0.00390963f //x=8.26 \
 //y=4.88 //x2=8.15 //y2=5.385
cc_294 ( N_noxref_2_M14_noxref_g N_Y_c_582_n ) capacitor c=0.00194596f \
 //x=7.93 //y=6.2 //x2=8.15 //y2=5.385
cc_295 ( N_noxref_2_M15_noxref_g N_Y_c_582_n ) capacitor c=0.00286922f \
 //x=8.37 //y=6.2 //x2=8.15 //y2=5.385
cc_296 ( N_noxref_2_c_310_p N_Y_c_582_n ) capacitor c=0.00191226f //x=8.26 \
 //y=4.88 //x2=8.15 //y2=5.385
cc_297 ( N_noxref_2_c_275_n N_Y_c_587_n ) capacitor c=0.00590878f //x=8.13 \
 //y=4.625 //x2=8.675 //y2=3.925
cc_298 ( N_noxref_2_c_275_n N_Y_c_588_n ) capacitor c=0.0206982f //x=8.13 \
 //y=4.625 //x2=8.485 //y2=3.925
cc_299 ( N_noxref_2_c_286_n N_Y_c_588_n ) capacitor c=0.0053728f //x=8.085 \
 //y=2.75 //x2=8.485 //y2=3.925
cc_300 ( N_noxref_2_c_275_n N_Y_c_590_n ) capacitor c=0.00419694f //x=8.13 \
 //y=4.625 //x2=8.15 //y2=5.555
cc_301 ( N_noxref_2_c_309_p N_Y_c_590_n ) capacitor c=0.00419714f //x=8.26 \
 //y=4.88 //x2=8.15 //y2=5.555
cc_302 ( N_noxref_2_M14_noxref_g N_Y_c_590_n ) capacitor c=0.0120591f //x=7.93 \
 //y=6.2 //x2=8.15 //y2=5.555
cc_303 ( N_noxref_2_M15_noxref_g N_Y_c_590_n ) capacitor c=0.0140704f //x=8.37 \
 //y=6.2 //x2=8.15 //y2=5.555
cc_304 ( N_noxref_2_c_310_p N_Y_c_590_n ) capacitor c=0.00438806f //x=8.26 \
 //y=4.88 //x2=8.15 //y2=5.555
cc_305 ( N_noxref_2_c_300_p N_Y_M4_noxref_d ) capacitor c=3.37013e-19 //x=8.13 \
 //y=2.915 //x2=8 //y2=1.085
cc_306 ( N_noxref_2_c_302_p N_Y_M4_noxref_d ) capacitor c=9.14309e-19 //x=8.26 \
 //y=2.385 //x2=8 //y2=1.085
cc_307 ( N_noxref_2_c_306_p N_Y_M4_noxref_d ) capacitor c=0.00150225f //x=8.26 \
 //y=2.26 //x2=8 //y2=1.085
cc_308 ( N_noxref_2_c_327_p N_Y_M4_noxref_d ) capacitor c=0.00209865f \
 //x=7.925 //y=1.085 //x2=8 //y2=1.085
cc_309 ( N_noxref_2_c_328_p N_Y_M4_noxref_d ) capacitor c=0.00237422f \
 //x=7.925 //y=1.43 //x2=8 //y2=1.085
cc_310 ( N_noxref_2_c_329_p N_Y_M4_noxref_d ) capacitor c=0.00213893f //x=8.3 \
 //y=0.93 //x2=8 //y2=1.085
cc_311 ( N_noxref_2_c_330_p N_Y_M4_noxref_d ) capacitor c=0.00345753f //x=8.3 \
 //y=1.585 //x2=8 //y2=1.085
cc_312 ( N_noxref_2_c_331_p N_Y_M4_noxref_d ) capacitor c=0.00124544f \
 //x=8.455 //y=1.085 //x2=8 //y2=1.085
cc_313 ( N_noxref_2_c_332_p N_Y_M4_noxref_d ) capacitor c=0.00237422f \
 //x=8.455 //y=1.43 //x2=8 //y2=1.085
cc_314 ( N_noxref_2_c_286_n N_noxref_4_c_819_n ) capacitor c=0.00250792f \
 //x=8.085 //y=2.75 //x2=4.93 //y2=2.385
cc_315 ( N_noxref_2_c_250_n N_noxref_4_c_822_n ) capacitor c=5.23847e-19 \
 //x=1.97 //y=2.615 //x2=4.93 //y2=3.025
cc_316 ( N_noxref_2_c_286_n N_noxref_4_c_822_n ) capacitor c=0.0233255f \
 //x=8.085 //y=2.75 //x2=4.93 //y2=3.025
cc_317 ( N_noxref_2_c_303_p N_noxref_4_c_845_n ) capacitor c=0.00108584f \
 //x=8.26 //y=2.595 //x2=10.11 //y2=2.965
cc_318 ( N_noxref_2_c_275_n N_noxref_4_c_846_n ) capacitor c=0.0026964f \
 //x=8.13 //y=4.625 //x2=10.11 //y2=4.505
cc_319 ( N_noxref_2_c_275_n N_noxref_4_c_847_n ) capacitor c=4.39865e-19 \
 //x=8.13 //y=4.625 //x2=10.11 //y2=4.915
cc_320 ( N_noxref_2_c_286_n N_noxref_4_c_824_n ) capacitor c=0.00509077f \
 //x=8.085 //y=2.75 //x2=4.93 //y2=3.14
cc_321 ( N_noxref_2_c_275_n N_noxref_4_c_849_n ) capacitor c=0.0148957f \
 //x=8.13 //y=4.625 //x2=7.15 //y2=4.62
cc_322 ( N_noxref_2_c_309_p N_noxref_4_c_849_n ) capacitor c=2.21237e-19 \
 //x=8.26 //y=4.88 //x2=7.15 //y2=4.62
cc_323 ( N_noxref_2_c_275_n N_noxref_4_c_851_n ) capacitor c=0.0355012f \
 //x=8.13 //y=4.625 //x2=9.95 //y2=4.677
cc_324 ( N_noxref_2_c_286_n N_noxref_4_c_825_n ) capacitor c=0.0336483f \
 //x=8.085 //y=2.75 //x2=5.075 //y2=3.185
cc_325 ( N_noxref_2_c_275_n N_noxref_4_c_853_n ) capacitor c=0.00286826f \
 //x=8.13 //y=4.625 //x2=7.135 //y2=4.677
cc_326 ( N_noxref_2_c_300_p N_noxref_4_c_854_n ) capacitor c=0.00802588f \
 //x=8.13 //y=2.915 //x2=9.96 //y2=3.125
cc_327 ( N_noxref_2_c_275_n N_noxref_4_c_854_n ) capacitor c=0.0195174f \
 //x=8.13 //y=4.625 //x2=9.96 //y2=3.125
cc_328 ( N_noxref_2_c_304_p N_noxref_4_c_854_n ) capacitor c=0.00161456f \
 //x=8.26 //y=2.77 //x2=9.96 //y2=3.125
cc_329 ( N_noxref_2_c_305_p N_noxref_4_c_854_n ) capacitor c=0.0367566f \
 //x=8.245 //y=2.75 //x2=9.96 //y2=3.125
cc_330 ( N_noxref_2_c_286_n N_noxref_4_c_854_n ) capacitor c=0.274723f \
 //x=8.085 //y=2.75 //x2=9.96 //y2=3.125
cc_331 ( N_noxref_2_c_275_n N_noxref_4_c_859_n ) capacitor c=0.00337162f \
 //x=8.13 //y=4.625 //x2=7.15 //y2=4.62
cc_332 ( N_noxref_2_c_309_p N_noxref_4_c_859_n ) capacitor c=0.00157085f \
 //x=8.26 //y=4.88 //x2=7.15 //y2=4.62
cc_333 ( N_noxref_2_c_310_p N_noxref_4_c_859_n ) capacitor c=0.00183f //x=8.26 \
 //y=4.88 //x2=7.15 //y2=4.62
cc_334 ( N_noxref_2_M14_noxref_g N_noxref_4_M12_noxref_g ) capacitor \
 c=0.0102018f //x=7.93 //y=6.2 //x2=7.05 //y2=6.2
cc_335 ( N_noxref_2_M14_noxref_g N_noxref_4_M13_noxref_g ) capacitor \
 c=0.0618273f //x=7.93 //y=6.2 //x2=7.49 //y2=6.2
cc_336 ( N_noxref_2_M15_noxref_g N_noxref_4_M13_noxref_g ) capacitor \
 c=0.00945236f //x=8.37 //y=6.2 //x2=7.49 //y2=6.2
cc_337 ( N_noxref_2_c_275_n N_noxref_4_c_865_n ) capacitor c=7.74131e-19 \
 //x=8.13 //y=4.625 //x2=7.15 //y2=4.88
cc_338 ( N_noxref_2_c_309_p N_noxref_4_c_865_n ) capacitor c=0.00165977f \
 //x=8.26 //y=4.88 //x2=7.15 //y2=4.88
cc_339 ( N_noxref_2_c_310_p N_noxref_4_c_865_n ) capacitor c=0.0663512f \
 //x=8.26 //y=4.88 //x2=7.15 //y2=4.88
cc_340 ( N_noxref_2_c_259_n B ) capacitor c=6.27081e-19 //x=1.97 //y=5.055 \
 //x2=4.93 //y2=4.62
cc_341 ( N_noxref_2_c_300_p B ) capacitor c=0.0206435f //x=8.13 //y=2.915 \
 //x2=7.15 //y2=2.4
cc_342 ( N_noxref_2_c_303_p B ) capacitor c=0.00540306f //x=8.26 //y=2.595 \
 //x2=7.15 //y2=2.4
cc_343 ( N_noxref_2_c_305_p B ) capacitor c=0.0015359f //x=8.245 //y=2.75 \
 //x2=7.15 //y2=2.4
cc_344 ( N_noxref_2_c_286_n B ) capacitor c=0.027872f //x=8.085 //y=2.75 \
 //x2=7.15 //y2=2.4
cc_345 ( N_noxref_2_c_306_p B ) capacitor c=3.33331e-19 //x=8.26 //y=2.26 \
 //x2=7.15 //y2=2.4
cc_346 ( N_noxref_2_c_275_n B ) capacitor c=0.0105627f //x=8.13 //y=4.625 \
 //x2=7.15 //y2=3.51
cc_347 ( N_noxref_2_c_302_p N_B_c_1148_n ) capacitor c=0.0115204f //x=8.26 \
 //y=2.385 //x2=7.15 //y2=2.385
cc_348 ( N_noxref_2_c_286_n N_B_c_1148_n ) capacitor c=0.00307438f //x=8.085 \
 //y=2.75 //x2=7.15 //y2=2.385
cc_349 ( N_noxref_2_c_306_p N_B_c_1148_n ) capacitor c=3.73267e-19 //x=8.26 \
 //y=2.26 //x2=7.15 //y2=2.385
cc_350 ( N_noxref_2_c_307_p N_B_c_1148_n ) capacitor c=0.00148195f //x=7.925 \
 //y=2.095 //x2=7.15 //y2=2.385
cc_351 ( N_noxref_2_c_275_n N_B_c_1152_n ) capacitor c=0.0257858f //x=8.13 \
 //y=4.625 //x2=8.205 //y2=4.25
cc_352 ( N_noxref_2_c_286_n N_B_c_1128_n ) capacitor c=6.57891e-19 //x=8.085 \
 //y=2.75 //x2=4.91 //y2=4.25
cc_353 ( N_noxref_2_c_275_n N_B_c_1154_n ) capacitor c=0.00270765f //x=8.13 \
 //y=4.625 //x2=7.315 //y2=3.52
cc_354 ( N_noxref_2_c_275_n N_B_c_1155_n ) capacitor c=0.0196581f //x=8.13 \
 //y=4.625 //x2=10.735 //y2=3.585
cc_355 ( N_noxref_2_c_286_n N_B_c_1155_n ) capacitor c=0.00459184f //x=8.085 \
 //y=2.75 //x2=10.735 //y2=3.585
cc_356 ( N_noxref_2_c_302_p N_B_c_1157_n ) capacitor c=5.11751e-19 //x=8.26 \
 //y=2.385 //x2=7.15 //y2=2.26
cc_357 ( N_noxref_2_c_303_p N_B_c_1157_n ) capacitor c=3.33331e-19 //x=8.26 \
 //y=2.595 //x2=7.15 //y2=2.26
cc_358 ( N_noxref_2_c_306_p N_B_c_1157_n ) capacitor c=0.00114285f //x=8.26 \
 //y=2.26 //x2=7.15 //y2=2.26
cc_359 ( N_noxref_2_c_307_p N_B_c_1157_n ) capacitor c=0.00230486f //x=7.925 \
 //y=2.095 //x2=7.15 //y2=2.26
cc_360 ( N_noxref_2_c_327_p N_B_c_1161_n ) capacitor c=4.86545e-19 //x=7.925 \
 //y=1.085 //x2=6.955 //y2=1.045
cc_361 ( N_noxref_2_c_327_p N_B_c_1162_n ) capacitor c=0.00152104f //x=7.925 \
 //y=1.085 //x2=6.955 //y2=1.39
cc_362 ( N_noxref_2_c_328_p N_B_c_1163_n ) capacitor c=0.00109982f //x=7.925 \
 //y=1.43 //x2=6.955 //y2=1.7
cc_363 ( N_noxref_2_c_334_p N_B_c_1163_n ) capacitor c=9.57794e-19 //x=7.925 \
 //y=1.74 //x2=6.955 //y2=1.7
cc_364 ( N_noxref_2_c_302_p N_B_c_1165_n ) capacitor c=0.00139976f //x=8.26 \
 //y=2.385 //x2=6.955 //y2=2.095
cc_365 ( N_noxref_2_c_306_p N_B_c_1165_n ) capacitor c=0.00187625f //x=8.26 \
 //y=2.26 //x2=6.955 //y2=2.095
cc_366 ( N_noxref_2_c_334_p N_B_c_1165_n ) capacitor c=0.00662747f //x=7.925 \
 //y=1.74 //x2=6.955 //y2=2.095
cc_367 ( N_noxref_2_c_307_p N_B_c_1165_n ) capacitor c=0.0121418f //x=7.925 \
 //y=2.095 //x2=6.955 //y2=2.095
cc_368 ( N_noxref_2_c_327_p N_B_c_1169_n ) capacitor c=0.0157772f //x=7.925 \
 //y=1.085 //x2=7.485 //y2=1.045
cc_369 ( N_noxref_2_c_331_p N_B_c_1169_n ) capacitor c=0.00124821f //x=8.455 \
 //y=1.085 //x2=7.485 //y2=1.045
cc_370 ( N_noxref_2_c_328_p N_B_c_1171_n ) capacitor c=0.0117362f //x=7.925 \
 //y=1.43 //x2=7.485 //y2=1.39
cc_371 ( N_noxref_2_c_334_p N_B_c_1171_n ) capacitor c=0.00862358f //x=7.925 \
 //y=1.74 //x2=7.485 //y2=1.39
cc_372 ( N_noxref_2_c_332_p N_B_c_1171_n ) capacitor c=0.00204774f //x=8.455 \
 //y=1.43 //x2=7.485 //y2=1.39
cc_373 ( N_noxref_2_c_241_n N_VDD_c_1422_n ) capacitor c=0.00259718f //x=1.605 \
 //y=5.42 //x2=3.855 //y2=7.585
cc_374 ( N_noxref_2_c_246_n N_VDD_c_1422_n ) capacitor c=0.00199795f //x=1.885 \
 //y=5.14 //x2=3.855 //y2=7.585
cc_375 ( N_noxref_2_c_291_n N_VDD_c_1422_n ) capacitor c=0.00241566f //x=1.605 \
 //y=5.56 //x2=3.855 //y2=7.585
cc_376 ( N_noxref_2_c_241_n N_VDD_c_1429_n ) capacitor c=8.96756e-19 //x=1.605 \
 //y=5.42 //x2=1.96 //y2=7.585
cc_377 ( N_noxref_2_c_246_n N_VDD_c_1429_n ) capacitor c=0.00197507f //x=1.885 \
 //y=5.14 //x2=1.96 //y2=7.585
cc_378 ( N_noxref_2_c_291_n N_VDD_c_1429_n ) capacitor c=0.0138017f //x=1.605 \
 //y=5.56 //x2=1.96 //y2=7.585
cc_379 ( N_noxref_2_M14_noxref_g N_VDD_c_1471_n ) capacitor c=0.00777954f \
 //x=7.93 //y=6.2 //x2=9.2 //y2=7.585
cc_380 ( N_noxref_2_M15_noxref_g N_VDD_c_1471_n ) capacitor c=0.0075884f \
 //x=8.37 //y=6.2 //x2=9.2 //y2=7.585
cc_381 ( N_noxref_2_c_247_n N_VDD_c_1435_n ) capacitor c=0.00685597f //x=1.69 \
 //y=5.14 //x2=1.23 //y2=7.58
cc_382 ( N_noxref_2_c_259_n N_VDD_c_1435_n ) capacitor c=2.43252e-19 //x=1.97 \
 //y=5.055 //x2=1.23 //y2=7.58
cc_383 ( N_noxref_2_c_291_n N_VDD_c_1435_n ) capacitor c=0.00822773f //x=1.605 \
 //y=5.56 //x2=1.23 //y2=7.58
cc_384 ( N_noxref_2_c_241_n N_VDD_c_1442_n ) capacitor c=0.00232499f //x=1.605 \
 //y=5.42 //x2=2.71 //y2=7.585
cc_385 ( N_noxref_2_c_259_n N_VDD_c_1442_n ) capacitor c=0.0218431f //x=1.97 \
 //y=5.055 //x2=2.71 //y2=7.585
cc_386 ( N_noxref_2_c_286_n N_VDD_c_1442_n ) capacitor c=0.00182463f //x=8.085 \
 //y=2.75 //x2=2.71 //y2=7.585
cc_387 ( N_noxref_2_c_291_n N_VDD_c_1442_n ) capacitor c=0.00820644f //x=1.605 \
 //y=5.56 //x2=2.71 //y2=7.585
cc_388 ( N_noxref_2_c_275_n N_VDD_c_1480_n ) capacitor c=9.69738e-19 //x=8.13 \
 //y=4.625 //x2=6.04 //y2=7.585
cc_389 ( N_noxref_2_c_309_p N_VDD_c_1481_n ) capacitor c=0.00356451f //x=8.26 \
 //y=4.88 //x2=9.37 //y2=7.585
cc_390 ( N_noxref_2_c_310_p N_VDD_c_1481_n ) capacitor c=0.0193101f //x=8.26 \
 //y=4.88 //x2=9.37 //y2=7.585
cc_391 ( N_noxref_2_c_291_n N_VDD_c_1483_n ) capacitor c=0.00135089f //x=1.605 \
 //y=5.56 //x2=10.85 //y2=7.58
cc_392 ( N_noxref_2_c_241_n N_VDD_M6_noxref_s ) capacitor c=0.0480012f \
 //x=1.605 //y=5.42 //x2=1.03 //y2=5.2
cc_393 ( N_noxref_2_c_291_n N_VDD_M6_noxref_s ) capacitor c=0.0920717f \
 //x=1.605 //y=5.56 //x2=1.03 //y2=5.2
cc_394 ( N_noxref_2_c_241_n N_VDD_M7_noxref_d ) capacitor c=0.0474638f \
 //x=1.605 //y=5.42 //x2=1.9 //y2=5.2
cc_395 ( N_noxref_2_c_246_n N_VDD_M7_noxref_d ) capacitor c=0.021356f \
 //x=1.885 //y=5.14 //x2=1.9 //y2=5.2
cc_396 ( N_noxref_2_c_256_n N_VDD_M7_noxref_d ) capacitor c=0.00162898f \
 //x=1.97 //y=2.935 //x2=1.9 //y2=5.2
cc_397 ( N_noxref_2_c_291_n N_VDD_M7_noxref_d ) capacitor c=0.0908278f \
 //x=1.605 //y=5.56 //x2=1.9 //y2=5.2
cc_398 ( N_noxref_2_c_241_n N_noxref_7_c_1686_n ) capacitor c=0.00196278f \
 //x=1.605 //y=5.42 //x2=3.505 //y2=5.385
cc_399 ( N_noxref_2_M14_noxref_g N_noxref_8_c_1764_n ) capacitor c=0.00902452f \
 //x=7.93 //y=6.2 //x2=8.47 //y2=7.085
cc_400 ( N_noxref_2_M15_noxref_g N_noxref_8_c_1764_n ) capacitor c=0.00932765f \
 //x=8.37 //y=6.2 //x2=8.47 //y2=7.085
cc_401 ( N_noxref_2_M14_noxref_g N_noxref_8_c_1766_n ) capacitor c=0.00187506f \
 //x=7.93 //y=6.2 //x2=7.71 //y2=5.385
cc_402 ( N_noxref_2_M14_noxref_g N_noxref_8_c_1767_n ) capacitor c=0.00184755f \
 //x=7.93 //y=6.2 //x2=7.71 //y2=6.915
cc_403 ( N_noxref_2_M15_noxref_g N_noxref_8_c_1768_n ) capacitor c=0.00406946f \
 //x=8.37 //y=6.2 //x2=8.59 //y2=6.915
cc_404 ( N_noxref_2_M14_noxref_g N_noxref_8_c_1769_n ) capacitor c=0.0171015f \
 //x=7.93 //y=6.2 //x2=7.71 //y2=5.555
cc_405 ( N_noxref_2_M15_noxref_g N_noxref_8_M15_noxref_d ) capacitor \
 c=0.0365939f //x=8.37 //y=6.2 //x2=8.445 //y2=5.2
cc_406 ( N_noxref_2_c_244_n N_GND_c_1850_n ) capacitor c=0.00499594f //x=1.885 \
 //y=2.02 //x2=3.805 //y2=0.175
cc_407 ( N_noxref_2_c_256_n N_GND_c_1850_n ) capacitor c=6.43754e-19 //x=1.97 \
 //y=2.935 //x2=3.805 //y2=0.175
cc_408 ( N_noxref_2_c_276_n N_GND_c_1850_n ) capacitor c=0.00998676f //x=1.6 \
 //y=1.185 //x2=3.805 //y2=0.175
cc_409 ( N_noxref_2_c_282_n N_GND_c_1850_n ) capacitor c=4.46354e-19 //x=1.97 \
 //y=2.77 //x2=3.805 //y2=0.175
cc_410 ( N_noxref_2_M0_noxref_d N_GND_c_1850_n ) capacitor c=0.00119455f \
 //x=1.415 //y=1.09 //x2=3.805 //y2=0.175
cc_411 ( N_noxref_2_c_276_n N_GND_c_1855_n ) capacitor c=0.00548656f //x=1.6 \
 //y=1.185 //x2=3.89 //y2=1.02
cc_412 ( N_noxref_2_c_286_n N_GND_c_1855_n ) capacitor c=0.00339002f //x=8.085 \
 //y=2.75 //x2=3.89 //y2=1.02
cc_413 ( N_noxref_2_c_286_n N_GND_c_1905_n ) capacitor c=0.00403936f //x=8.085 \
 //y=2.75 //x2=7.22 //y2=1.02
cc_414 ( N_noxref_2_c_276_n N_GND_c_1863_n ) capacitor c=0.00124813f //x=1.6 \
 //y=1.185 //x2=1.515 //y2=0.715
cc_415 ( N_noxref_2_c_244_n N_GND_c_1867_n ) capacitor c=0.00306467f //x=1.885 \
 //y=2.02 //x2=2.005 //y2=0.715
cc_416 ( N_noxref_2_c_276_n N_GND_c_1867_n ) capacitor c=0.00130539f //x=1.6 \
 //y=1.185 //x2=2.005 //y2=0.715
cc_417 ( N_noxref_2_c_282_n N_GND_c_1867_n ) capacitor c=4.2833e-19 //x=1.97 \
 //y=2.77 //x2=2.005 //y2=0.715
cc_418 ( N_noxref_2_c_236_n N_GND_c_1869_n ) capacitor c=0.00520602f //x=1.6 \
 //y=1.935 //x2=1.12 //y2=0.175
cc_419 ( N_noxref_2_c_250_n N_GND_c_1869_n ) capacitor c=2.14154e-19 //x=1.97 \
 //y=2.615 //x2=1.12 //y2=0.175
cc_420 ( N_noxref_2_c_282_n N_GND_c_1869_n ) capacitor c=0.00313158f //x=1.97 \
 //y=2.77 //x2=1.12 //y2=0.175
cc_421 ( N_noxref_2_c_244_n N_GND_c_1874_n ) capacitor c=0.0160813f //x=1.885 \
 //y=2.02 //x2=2.71 //y2=0.175
cc_422 ( N_noxref_2_c_256_n N_GND_c_1874_n ) capacitor c=0.00433472f //x=1.97 \
 //y=2.935 //x2=2.71 //y2=0.175
cc_423 ( N_noxref_2_c_282_n N_GND_c_1874_n ) capacitor c=0.0101807f //x=1.97 \
 //y=2.77 //x2=2.71 //y2=0.175
cc_424 ( N_noxref_2_c_286_n N_GND_c_1874_n ) capacitor c=0.0241204f //x=8.085 \
 //y=2.75 //x2=2.71 //y2=0.175
cc_425 ( N_noxref_2_c_304_p N_GND_c_1917_n ) capacitor c=0.00118906f //x=8.26 \
 //y=2.77 //x2=6.04 //y2=0.175
cc_426 ( N_noxref_2_c_286_n N_GND_c_1917_n ) capacitor c=0.023659f //x=8.085 \
 //y=2.75 //x2=6.04 //y2=0.175
cc_427 ( N_noxref_2_c_304_p N_GND_c_1919_n ) capacitor c=0.00499198f //x=8.26 \
 //y=2.77 //x2=9.37 //y2=0.175
cc_428 ( N_noxref_2_c_306_p N_GND_c_1919_n ) capacitor c=0.00371073f //x=8.26 \
 //y=2.26 //x2=9.37 //y2=0.175
cc_429 ( N_noxref_2_c_307_p N_GND_c_1919_n ) capacitor c=0.00535915f //x=7.925 \
 //y=2.095 //x2=9.37 //y2=0.175
cc_430 ( N_noxref_2_c_332_p N_GND_c_1919_n ) capacitor c=0.00230557f //x=8.455 \
 //y=1.43 //x2=9.37 //y2=0.175
cc_431 ( N_noxref_2_c_276_n N_GND_c_1923_n ) capacitor c=2.8029e-19 //x=1.6 \
 //y=1.185 //x2=10.96 //y2=0.175
cc_432 ( N_noxref_2_M0_noxref_d N_GND_c_1923_n ) capacitor c=2.70835e-19 \
 //x=1.415 //y=1.09 //x2=10.96 //y2=0.175
cc_433 ( N_noxref_2_c_236_n N_GND_M0_noxref_s ) capacitor c=0.0339487f //x=1.6 \
 //y=1.935 //x2=0.985 //y2=0.55
cc_434 ( N_noxref_2_c_244_n N_GND_M0_noxref_s ) capacitor c=0.00316907f \
 //x=1.885 //y=2.02 //x2=0.985 //y2=0.55
cc_435 ( N_noxref_2_c_256_n N_GND_M0_noxref_s ) capacitor c=0.00298445f \
 //x=1.97 //y=2.935 //x2=0.985 //y2=0.55
cc_436 ( N_noxref_2_c_276_n N_GND_M0_noxref_s ) capacitor c=0.0157018f //x=1.6 \
 //y=1.185 //x2=0.985 //y2=0.55
cc_437 ( N_noxref_2_c_282_n N_GND_M0_noxref_s ) capacitor c=0.00227202f \
 //x=1.97 //y=2.77 //x2=0.985 //y2=0.55
cc_438 ( N_noxref_2_M0_noxref_d N_GND_M0_noxref_s ) capacitor c=0.0377642f \
 //x=1.415 //y=1.09 //x2=0.985 //y2=0.55
cc_439 ( N_noxref_2_c_286_n N_noxref_10_c_2093_n ) capacitor c=0.00353446f \
 //x=8.085 //y=2.75 //x2=3.405 //y2=1.675
cc_440 ( N_noxref_2_c_286_n N_noxref_10_c_2094_n ) capacitor c=0.0112499f \
 //x=8.085 //y=2.75 //x2=4.29 //y2=1.76
cc_441 ( N_noxref_2_c_286_n N_noxref_10_c_2101_n ) capacitor c=0.00353446f \
 //x=8.085 //y=2.75 //x2=4.375 //y2=1.675
cc_442 ( N_noxref_2_c_286_n N_noxref_10_c_2108_n ) capacitor c=0.00225188f \
 //x=8.085 //y=2.75 //x2=5.26 //y2=0.71
cc_443 ( N_noxref_2_c_286_n N_noxref_11_c_2157_n ) capacitor c=0.00374141f \
 //x=8.085 //y=2.75 //x2=6.735 //y2=1.675
cc_444 ( N_noxref_2_c_286_n N_noxref_11_c_2158_n ) capacitor c=0.0117989f \
 //x=8.085 //y=2.75 //x2=7.62 //y2=1.76
cc_445 ( N_noxref_2_c_286_n N_noxref_11_c_2159_n ) capacitor c=0.00374141f \
 //x=8.085 //y=2.75 //x2=7.705 //y2=1.675
cc_446 ( N_noxref_2_c_334_p N_noxref_11_c_2159_n ) capacitor c=0.00882422f \
 //x=7.925 //y=1.74 //x2=7.705 //y2=1.675
cc_447 ( N_noxref_2_c_300_p N_noxref_11_c_2161_n ) capacitor c=5.02788e-19 \
 //x=8.13 //y=2.915 //x2=8.59 //y2=0.71
cc_448 ( N_noxref_2_c_286_n N_noxref_11_c_2161_n ) capacitor c=0.00148528f \
 //x=8.085 //y=2.75 //x2=8.59 //y2=0.71
cc_449 ( N_noxref_2_c_306_p N_noxref_11_c_2161_n ) capacitor c=4.19248e-19 \
 //x=8.26 //y=2.26 //x2=8.59 //y2=0.71
cc_450 ( N_noxref_2_c_327_p N_noxref_11_c_2161_n ) capacitor c=0.0204192f \
 //x=7.925 //y=1.085 //x2=8.59 //y2=0.71
cc_451 ( N_noxref_2_c_307_p N_noxref_11_c_2161_n ) capacitor c=2.1838e-19 \
 //x=7.925 //y=2.095 //x2=8.59 //y2=0.71
cc_452 ( N_noxref_2_c_331_p N_noxref_11_c_2161_n ) capacitor c=0.00825432f \
 //x=8.455 //y=1.085 //x2=8.59 //y2=0.71
cc_453 ( N_noxref_2_c_327_p N_noxref_11_M3_noxref_s ) capacitor c=0.00882422f \
 //x=7.925 //y=1.085 //x2=6.6 //y2=0.545
cc_454 ( N_noxref_2_c_331_p N_noxref_11_M3_noxref_s ) capacitor c=0.0152167f \
 //x=8.455 //y=1.085 //x2=6.6 //y2=0.545
cc_455 ( N_noxref_2_c_332_p N_noxref_11_M3_noxref_s ) capacitor c=0.00248746f \
 //x=8.455 //y=1.43 //x2=6.6 //y2=0.545
cc_456 ( N_Y_c_541_n N_noxref_4_c_819_n ) capacitor c=0.00241258f //x=5.335 \
 //y=1.83 //x2=4.93 //y2=2.385
cc_457 ( N_Y_c_542_n N_noxref_4_c_819_n ) capacitor c=0.0234589f //x=4.945 \
 //y=1.83 //x2=4.93 //y2=2.385
cc_458 ( N_Y_c_520_n N_noxref_4_c_819_n ) capacitor c=0.0239555f //x=5.42 \
 //y=3.645 //x2=4.93 //y2=2.385
cc_459 ( N_Y_M2_noxref_d N_noxref_4_c_819_n ) capacitor c=4.63726e-19 //x=4.67 \
 //y=1.085 //x2=4.93 //y2=2.385
cc_460 ( N_Y_c_520_n N_noxref_4_c_822_n ) capacitor c=0.0408178f //x=5.42 \
 //y=3.645 //x2=4.93 //y2=3.025
cc_461 ( Y N_noxref_4_c_873_n ) capacitor c=0.00416973f //x=8.63 //y=2.4 \
 //x2=10.11 //y2=3.29
cc_462 ( Y N_noxref_4_c_846_n ) capacitor c=0.0067674f //x=8.63 //y=2.4 \
 //x2=10.11 //y2=4.505
cc_463 ( Y N_noxref_4_c_846_n ) capacitor c=0.0050433f //x=8.63 //y=4.99 \
 //x2=10.11 //y2=4.505
cc_464 ( Y N_noxref_4_c_846_n ) capacitor c=2.63678e-19 //x=8.63 //y=3.88 \
 //x2=10.11 //y2=4.505
cc_465 ( N_Y_c_578_n N_noxref_4_c_846_n ) capacitor c=0.00668443f //x=8.63 \
 //y=4.115 //x2=10.11 //y2=4.505
cc_466 ( N_Y_c_587_n N_noxref_4_c_846_n ) capacitor c=0.00500598f //x=8.675 \
 //y=3.925 //x2=10.11 //y2=4.505
cc_467 ( Y N_noxref_4_c_847_n ) capacitor c=0.00637317f //x=8.63 //y=4.99 \
 //x2=10.11 //y2=4.915
cc_468 ( Y N_noxref_4_c_880_n ) capacitor c=0.00653269f //x=8.63 //y=4.99 \
 //x2=10.11 //y2=5.055
cc_469 ( Y N_noxref_4_c_881_n ) capacitor c=0.0208241f //x=8.63 //y=2.4 \
 //x2=10.195 //y2=2.02
cc_470 ( Y N_noxref_4_c_882_n ) capacitor c=0.00270091f //x=8.63 //y=4.99 \
 //x2=10.475 //y2=5.42
cc_471 ( N_Y_c_582_n N_noxref_4_c_882_n ) capacitor c=5.24591e-19 //x=8.15 \
 //y=5.385 //x2=10.475 //y2=5.42
cc_472 ( N_Y_c_559_n N_noxref_4_c_884_n ) capacitor c=0.00459956f //x=8.19 \
 //y=1.745 //x2=10.48 //y2=1.935
cc_473 ( N_Y_c_567_n N_noxref_4_c_884_n ) capacitor c=0.00337985f //x=8.545 \
 //y=1.83 //x2=10.48 //y2=1.935
cc_474 ( N_Y_c_541_n N_noxref_4_c_824_n ) capacitor c=0.00237006f //x=5.335 \
 //y=1.83 //x2=4.93 //y2=3.14
cc_475 ( N_Y_c_542_n N_noxref_4_c_824_n ) capacitor c=8.19809e-19 //x=4.945 \
 //y=1.83 //x2=4.93 //y2=3.14
cc_476 ( N_Y_c_520_n N_noxref_4_c_824_n ) capacitor c=0.0350575f //x=5.42 \
 //y=3.645 //x2=4.93 //y2=3.14
cc_477 ( N_Y_c_521_n N_noxref_4_c_824_n ) capacitor c=0.00209369f //x=5.42 \
 //y=3.995 //x2=4.93 //y2=3.14
cc_478 ( N_Y_c_525_n N_noxref_4_c_824_n ) capacitor c=4.58007e-19 //x=5.465 \
 //y=3.835 //x2=4.93 //y2=3.14
cc_479 ( Y N_noxref_4_c_849_n ) capacitor c=5.23264e-19 //x=8.63 //y=4.99 \
 //x2=7.15 //y2=4.62
cc_480 ( N_Y_c_522_n N_noxref_4_c_849_n ) capacitor c=0.00574532f //x=5.42 \
 //y=5.3 //x2=7.15 //y2=4.62
cc_481 ( Y N_noxref_4_c_893_n ) capacitor c=3.33906e-19 //x=8.63 //y=2.4 \
 //x2=10.11 //y2=3.14
cc_482 ( N_Y_c_551_n N_noxref_4_c_894_n ) capacitor c=0.00594237f //x=8.19 \
 //y=1.3 //x2=10.48 //y2=1.185
cc_483 ( N_Y_c_559_n N_noxref_4_c_894_n ) capacitor c=6.23317e-19 //x=8.19 \
 //y=1.745 //x2=10.48 //y2=1.185
cc_484 ( Y N_noxref_4_c_851_n ) capacitor c=0.0243353f //x=8.63 //y=4.99 \
 //x2=9.95 //y2=4.677
cc_485 ( N_Y_c_564_n N_noxref_4_c_851_n ) capacitor c=0.00477221f //x=8.545 \
 //y=5.385 //x2=9.95 //y2=4.677
cc_486 ( N_Y_c_582_n N_noxref_4_c_851_n ) capacitor c=5.20373e-19 //x=8.15 \
 //y=5.385 //x2=9.95 //y2=4.677
cc_487 ( N_Y_c_588_n N_noxref_4_c_851_n ) capacitor c=0.0083515f //x=8.485 \
 //y=3.925 //x2=9.95 //y2=4.677
cc_488 ( N_Y_c_520_n N_noxref_4_c_825_n ) capacitor c=0.00497477f //x=5.42 \
 //y=3.645 //x2=5.075 //y2=3.185
cc_489 ( N_Y_c_522_n N_noxref_4_c_853_n ) capacitor c=0.00354512f //x=5.42 \
 //y=5.3 //x2=7.135 //y2=4.677
cc_490 ( Y N_noxref_4_c_902_n ) capacitor c=0.00198563f //x=8.63 //y=4.99 \
 //x2=10.11 //y2=4.677
cc_491 ( Y N_noxref_4_c_903_n ) capacitor c=0.00194025f //x=8.63 //y=2.4 \
 //x2=10.12 //y2=3.125
cc_492 ( Y N_noxref_4_c_854_n ) capacitor c=0.0269697f //x=8.63 //y=2.4 \
 //x2=9.96 //y2=3.125
cc_493 ( N_Y_c_520_n N_noxref_4_c_854_n ) capacitor c=0.0220543f //x=5.42 \
 //y=3.645 //x2=9.96 //y2=3.125
cc_494 ( N_Y_c_521_n N_noxref_4_c_854_n ) capacitor c=0.00541814f //x=5.42 \
 //y=3.995 //x2=9.96 //y2=3.125
cc_495 ( N_Y_c_567_n N_noxref_4_c_854_n ) capacitor c=0.00271448f //x=8.545 \
 //y=1.83 //x2=9.96 //y2=3.125
cc_496 ( N_Y_c_525_n N_noxref_4_c_854_n ) capacitor c=0.0169345f //x=5.465 \
 //y=3.835 //x2=9.96 //y2=3.125
cc_497 ( N_Y_c_588_n N_noxref_4_c_854_n ) capacitor c=0.0755129f //x=8.485 \
 //y=3.925 //x2=9.96 //y2=3.125
cc_498 ( N_Y_c_541_n N_noxref_4_c_826_n ) capacitor c=0.00147657f //x=5.335 \
 //y=1.83 //x2=4.93 //y2=2.26
cc_499 ( N_Y_c_542_n N_noxref_4_c_826_n ) capacitor c=0.00408612f //x=4.945 \
 //y=1.83 //x2=4.93 //y2=2.26
cc_500 ( N_Y_c_520_n N_noxref_4_c_826_n ) capacitor c=0.00208077f //x=5.42 \
 //y=3.645 //x2=4.93 //y2=2.26
cc_501 ( N_Y_M2_noxref_d N_noxref_4_c_826_n ) capacitor c=0.00152066f //x=4.67 \
 //y=1.085 //x2=4.93 //y2=2.26
cc_502 ( Y N_noxref_4_c_859_n ) capacitor c=2.5871e-19 //x=8.63 //y=4.99 \
 //x2=7.15 //y2=4.62
cc_503 ( N_Y_c_538_n N_noxref_4_c_829_n ) capacitor c=4.12337e-19 //x=4.86 \
 //y=1.295 //x2=4.595 //y2=1.085
cc_504 ( N_Y_M2_noxref_d N_noxref_4_c_829_n ) capacitor c=0.00209865f //x=4.67 \
 //y=1.085 //x2=4.595 //y2=1.085
cc_505 ( N_Y_c_538_n N_noxref_4_c_832_n ) capacitor c=0.00203341f //x=4.86 \
 //y=1.295 //x2=4.595 //y2=1.43
cc_506 ( N_Y_c_539_n N_noxref_4_c_832_n ) capacitor c=0.00118531f //x=4.86 \
 //y=1.745 //x2=4.595 //y2=1.43
cc_507 ( N_Y_M2_noxref_d N_noxref_4_c_832_n ) capacitor c=0.00237422f //x=4.67 \
 //y=1.085 //x2=4.595 //y2=1.43
cc_508 ( N_Y_c_539_n N_noxref_4_c_834_n ) capacitor c=0.00409175f //x=4.86 \
 //y=1.745 //x2=4.595 //y2=1.74
cc_509 ( N_Y_c_539_n N_noxref_4_c_837_n ) capacitor c=0.00341876f //x=4.86 \
 //y=1.745 //x2=4.595 //y2=2.095
cc_510 ( N_Y_c_542_n N_noxref_4_c_837_n ) capacitor c=0.00212262f //x=4.945 \
 //y=1.83 //x2=4.595 //y2=2.095
cc_511 ( N_Y_c_520_n N_noxref_4_c_837_n ) capacitor c=0.0080874f //x=5.42 \
 //y=3.645 //x2=4.595 //y2=2.095
cc_512 ( N_Y_M2_noxref_d N_noxref_4_c_837_n ) capacitor c=4.64713e-19 //x=4.67 \
 //y=1.085 //x2=4.595 //y2=2.095
cc_513 ( N_Y_c_538_n N_noxref_4_c_925_n ) capacitor c=5.26869e-19 //x=4.86 \
 //y=1.295 //x2=4.97 //y2=0.93
cc_514 ( N_Y_M2_noxref_d N_noxref_4_c_925_n ) capacitor c=0.00213893f //x=4.67 \
 //y=1.085 //x2=4.97 //y2=0.93
cc_515 ( N_Y_c_538_n N_noxref_4_c_927_n ) capacitor c=4.90979e-19 //x=4.86 \
 //y=1.295 //x2=4.97 //y2=1.585
cc_516 ( N_Y_c_539_n N_noxref_4_c_927_n ) capacitor c=0.00761559f //x=4.86 \
 //y=1.745 //x2=4.97 //y2=1.585
cc_517 ( N_Y_c_541_n N_noxref_4_c_927_n ) capacitor c=0.00124531f //x=5.335 \
 //y=1.83 //x2=4.97 //y2=1.585
cc_518 ( N_Y_M2_noxref_d N_noxref_4_c_927_n ) capacitor c=0.00345426f //x=4.67 \
 //y=1.085 //x2=4.97 //y2=1.585
cc_519 ( N_Y_c_538_n N_noxref_4_c_840_n ) capacitor c=4.45278e-19 //x=4.86 \
 //y=1.295 //x2=5.125 //y2=1.085
cc_520 ( N_Y_M2_noxref_d N_noxref_4_c_840_n ) capacitor c=0.00124544f //x=4.67 \
 //y=1.085 //x2=5.125 //y2=1.085
cc_521 ( N_Y_c_538_n N_noxref_4_c_841_n ) capacitor c=0.00307857f //x=4.86 \
 //y=1.295 //x2=5.125 //y2=1.43
cc_522 ( N_Y_c_539_n N_noxref_4_c_841_n ) capacitor c=0.003249f //x=4.86 \
 //y=1.745 //x2=5.125 //y2=1.43
cc_523 ( N_Y_c_541_n N_noxref_4_c_841_n ) capacitor c=0.00300259f //x=5.335 \
 //y=1.83 //x2=5.125 //y2=1.43
cc_524 ( N_Y_M2_noxref_d N_noxref_4_c_841_n ) capacitor c=0.00237422f //x=4.67 \
 //y=1.085 //x2=5.125 //y2=1.43
cc_525 ( N_Y_c_522_n B ) capacitor c=0.0174979f //x=5.42 //y=5.3 //x2=4.93 \
 //y2=4.62
cc_526 ( Y B ) capacitor c=0.00389145f //x=8.63 //y=2.4 //x2=7.15 //y2=2.4
cc_527 ( N_Y_c_520_n B ) capacitor c=0.012683f //x=5.42 //y=3.645 //x2=7.15 \
 //y2=2.4
cc_528 ( Y B ) capacitor c=0.00297528f //x=8.63 //y=2.4 //x2=10.85 //y2=2.77
cc_529 ( Y B ) capacitor c=4.66514e-19 //x=8.63 //y=4.99 //x2=10.85 //y2=4.62
cc_530 ( N_Y_c_678_p B ) capacitor c=0.00261073f //x=5.335 //y=5.385 //x2=4.93 \
 //y2=4.25
cc_531 ( N_Y_c_521_n B ) capacitor c=0.00427316f //x=5.42 //y=3.995 //x2=4.93 \
 //y2=4.25
cc_532 ( N_Y_c_522_n B ) capacitor c=0.0421181f //x=5.42 //y=5.3 //x2=4.93 \
 //y2=4.25
cc_533 ( N_Y_c_581_n B ) capacitor c=0.00200698f //x=4.82 //y=5.385 //x2=4.93 \
 //y2=4.25
cc_534 ( N_Y_c_525_n B ) capacitor c=6.19174e-19 //x=5.465 //y=3.835 //x2=4.93 \
 //y2=4.25
cc_535 ( N_Y_c_683_p B ) capacitor c=6.31328e-19 //x=4.82 //y=5.555 //x2=4.93 \
 //y2=4.25
cc_536 ( N_Y_c_520_n B ) capacitor c=0.00394835f //x=5.42 //y=3.645 //x2=7.15 \
 //y2=3.51
cc_537 ( N_Y_c_588_n B ) capacitor c=0.00495379f //x=8.485 //y=3.925 //x2=7.15 \
 //y2=3.51
cc_538 ( N_Y_c_678_p N_B_c_1125_n ) capacitor c=0.00213356f //x=5.335 \
 //y=5.385 //x2=4.93 //y2=4.76
cc_539 ( N_Y_c_522_n N_B_c_1125_n ) capacitor c=0.0232702f //x=5.42 //y=5.3 \
 //x2=4.93 //y2=4.76
cc_540 ( N_Y_c_581_n N_B_c_1125_n ) capacitor c=0.0199113f //x=4.82 //y=5.385 \
 //x2=4.93 //y2=4.76
cc_541 ( N_Y_c_683_p N_B_c_1125_n ) capacitor c=0.00134103f //x=4.82 //y=5.555 \
 //x2=4.93 //y2=4.76
cc_542 ( Y N_B_c_1148_n ) capacitor c=4.5875e-19 //x=8.63 //y=2.4 //x2=7.15 \
 //y2=2.385
cc_543 ( N_Y_c_520_n N_B_c_1148_n ) capacitor c=0.00513041f //x=5.42 //y=3.645 \
 //x2=7.15 //y2=2.385
cc_544 ( Y N_B_c_1152_n ) capacitor c=0.00167703f //x=8.63 //y=4.99 //x2=8.205 \
 //y2=4.25
cc_545 ( N_Y_c_678_p N_B_c_1152_n ) capacitor c=0.00511972f //x=5.335 \
 //y=5.385 //x2=8.205 //y2=4.25
cc_546 ( N_Y_c_521_n N_B_c_1152_n ) capacitor c=0.00673958f //x=5.42 //y=3.995 \
 //x2=8.205 //y2=4.25
cc_547 ( N_Y_c_522_n N_B_c_1152_n ) capacitor c=0.0268007f //x=5.42 //y=5.3 \
 //x2=8.205 //y2=4.25
cc_548 ( N_Y_c_524_n N_B_c_1152_n ) capacitor c=0.00148331f //x=5.3 //y=3.88 \
 //x2=8.205 //y2=4.25
cc_549 ( N_Y_c_525_n N_B_c_1152_n ) capacitor c=0.0337385f //x=5.465 //y=3.835 \
 //x2=8.205 //y2=4.25
cc_550 ( N_Y_c_588_n N_B_c_1152_n ) capacitor c=0.271601f //x=8.485 //y=3.925 \
 //x2=8.205 //y2=4.25
cc_551 ( Y N_B_c_1200_n ) capacitor c=0.0192042f //x=8.63 //y=4.99 //x2=9.005 \
 //y2=4.34
cc_552 ( N_Y_c_578_n N_B_c_1200_n ) capacitor c=0.00788654f //x=8.63 //y=4.115 \
 //x2=9.005 //y2=4.34
cc_553 ( N_Y_c_587_n N_B_c_1200_n ) capacitor c=0.0416028f //x=8.675 //y=3.925 \
 //x2=9.005 //y2=4.34
cc_554 ( N_Y_c_588_n N_B_c_1200_n ) capacitor c=0.0100949f //x=8.485 //y=3.925 \
 //x2=9.005 //y2=4.34
cc_555 ( N_Y_c_678_p N_B_c_1128_n ) capacitor c=5.8188e-19 //x=5.335 //y=5.385 \
 //x2=4.91 //y2=4.25
cc_556 ( N_Y_c_522_n N_B_c_1128_n ) capacitor c=0.0045505f //x=5.42 //y=5.3 \
 //x2=4.91 //y2=4.25
cc_557 ( N_Y_c_581_n N_B_c_1128_n ) capacitor c=0.00110921f //x=4.82 //y=5.385 \
 //x2=4.91 //y2=4.25
cc_558 ( N_Y_c_520_n N_B_c_1154_n ) capacitor c=0.00352878f //x=5.42 //y=3.645 \
 //x2=7.315 //y2=3.52
cc_559 ( N_Y_c_588_n N_B_c_1154_n ) capacitor c=0.0355767f //x=8.485 //y=3.925 \
 //x2=7.315 //y2=3.52
cc_560 ( Y N_B_c_1209_n ) capacitor c=0.00233696f //x=8.63 //y=4.99 //x2=9.092 \
 //y2=4.25
cc_561 ( N_Y_c_587_n N_B_c_1210_n ) capacitor c=3.78661e-19 //x=8.675 \
 //y=3.925 //x2=10.925 //y2=3.585
cc_562 ( Y N_B_c_1155_n ) capacitor c=0.0208051f //x=8.63 //y=2.4 //x2=10.735 \
 //y2=3.585
cc_563 ( N_Y_c_578_n N_B_c_1155_n ) capacitor c=0.0101082f //x=8.63 //y=4.115 \
 //x2=10.735 //y2=3.585
cc_564 ( N_Y_c_587_n N_B_c_1155_n ) capacitor c=0.0416028f //x=8.675 //y=3.925 \
 //x2=10.735 //y2=3.585
cc_565 ( N_Y_c_588_n N_B_c_1155_n ) capacitor c=0.0929227f //x=8.485 //y=3.925 \
 //x2=10.735 //y2=3.585
cc_566 ( N_Y_c_678_p N_B_c_1131_n ) capacitor c=0.00104675f //x=5.335 \
 //y=5.385 //x2=4.93 //y2=4.88
cc_567 ( N_Y_c_522_n N_B_c_1131_n ) capacitor c=0.00448211f //x=5.42 //y=5.3 \
 //x2=4.93 //y2=4.88
cc_568 ( N_Y_c_581_n N_B_c_1131_n ) capacitor c=0.00390431f //x=4.82 //y=5.385 \
 //x2=4.93 //y2=4.88
cc_569 ( N_Y_c_683_p N_B_c_1131_n ) capacitor c=0.00341371f //x=4.82 //y=5.555 \
 //x2=4.93 //y2=4.88
cc_570 ( Y N_B_c_1157_n ) capacitor c=2.0676e-19 //x=8.63 //y=2.4 //x2=7.15 \
 //y2=2.26
cc_571 ( N_Y_c_581_n N_B_M10_noxref_g ) capacitor c=0.00182501f //x=4.82 \
 //y=5.385 //x2=4.6 //y2=6.2
cc_572 ( N_Y_c_683_p N_B_M10_noxref_g ) capacitor c=0.0120591f //x=4.82 \
 //y=5.555 //x2=4.6 //y2=6.2
cc_573 ( N_Y_c_678_p N_B_M11_noxref_g ) capacitor c=0.00993231f //x=5.335 \
 //y=5.385 //x2=5.04 //y2=6.2
cc_574 ( N_Y_c_581_n N_B_M11_noxref_g ) capacitor c=0.00284403f //x=4.82 \
 //y=5.385 //x2=5.04 //y2=6.2
cc_575 ( N_Y_c_683_p N_B_M11_noxref_g ) capacitor c=0.0140704f //x=4.82 \
 //y=5.555 //x2=5.04 //y2=6.2
cc_576 ( N_Y_c_522_n N_B_c_1138_n ) capacitor c=0.0103069f //x=5.42 //y=5.3 \
 //x2=4.93 //y2=4.88
cc_577 ( N_Y_c_581_n N_B_c_1138_n ) capacitor c=0.0020575f //x=4.82 //y=5.385 \
 //x2=4.93 //y2=4.88
cc_578 ( N_Y_c_683_p N_B_c_1138_n ) capacitor c=0.00438277f //x=4.82 //y=5.555 \
 //x2=4.93 //y2=4.88
cc_579 ( N_Y_c_678_p N_VDD_c_1490_n ) capacitor c=0.00189974f //x=5.335 \
 //y=5.385 //x2=7.185 //y2=7.585
cc_580 ( N_Y_c_564_n N_VDD_c_1491_n ) capacitor c=2.24244e-19 //x=8.545 \
 //y=5.385 //x2=10.85 //y2=7.58
cc_581 ( N_Y_c_578_n N_VDD_c_1491_n ) capacitor c=4.03634e-19 //x=8.63 \
 //y=4.115 //x2=10.85 //y2=7.58
cc_582 ( N_Y_c_678_p N_VDD_c_1433_n ) capacitor c=9.36942e-19 //x=5.335 \
 //y=5.385 //x2=5.87 //y2=7.585
cc_583 ( N_Y_c_683_p N_VDD_c_1433_n ) capacitor c=0.00509706f //x=4.82 \
 //y=5.555 //x2=5.87 //y2=7.585
cc_584 ( N_Y_c_578_n N_VDD_c_1471_n ) capacitor c=2.94174e-19 //x=8.63 \
 //y=4.115 //x2=9.2 //y2=7.585
cc_585 ( N_Y_c_590_n N_VDD_c_1471_n ) capacitor c=0.00485234f //x=8.15 \
 //y=5.555 //x2=9.2 //y2=7.585
cc_586 ( N_Y_c_522_n N_VDD_c_1442_n ) capacitor c=0.00127957f //x=5.42 //y=5.3 \
 //x2=2.71 //y2=7.585
cc_587 ( Y N_VDD_c_1480_n ) capacitor c=0.00124531f //x=8.63 //y=4.99 \
 //x2=6.04 //y2=7.585
cc_588 ( N_Y_c_522_n N_VDD_c_1480_n ) capacitor c=0.03407f //x=5.42 //y=5.3 \
 //x2=6.04 //y2=7.585
cc_589 ( N_Y_c_581_n N_VDD_c_1480_n ) capacitor c=0.00270997f //x=4.82 \
 //y=5.385 //x2=6.04 //y2=7.585
cc_590 ( N_Y_c_683_p N_VDD_c_1480_n ) capacitor c=0.00917967f //x=4.82 \
 //y=5.555 //x2=6.04 //y2=7.585
cc_591 ( Y N_VDD_c_1481_n ) capacitor c=0.024753f //x=8.63 //y=4.99 //x2=9.37 \
 //y2=7.585
cc_592 ( N_Y_c_582_n N_VDD_c_1481_n ) capacitor c=0.00267424f //x=8.15 \
 //y=5.385 //x2=9.37 //y2=7.585
cc_593 ( N_Y_c_590_n N_VDD_c_1481_n ) capacitor c=0.00920296f //x=8.15 \
 //y=5.555 //x2=9.37 //y2=7.585
cc_594 ( N_Y_c_683_p N_VDD_c_1483_n ) capacitor c=2.29347e-19 //x=4.82 \
 //y=5.555 //x2=10.85 //y2=7.58
cc_595 ( N_Y_c_590_n N_VDD_c_1483_n ) capacitor c=2.29347e-19 //x=8.15 \
 //y=5.555 //x2=10.85 //y2=7.58
cc_596 ( N_Y_c_581_n N_VDD_M7_noxref_d ) capacitor c=2.46201e-19 //x=4.82 \
 //y=5.385 //x2=1.9 //y2=5.2
cc_597 ( N_Y_c_683_p N_VDD_M8_noxref_d ) capacitor c=0.00464126f //x=4.82 \
 //y=5.555 //x2=3.795 //y2=5.2
cc_598 ( N_Y_c_590_n N_VDD_M12_noxref_d ) capacitor c=0.00464102f //x=8.15 \
 //y=5.555 //x2=7.125 //y2=5.2
cc_599 ( N_Y_c_564_n N_VDD_M16_noxref_s ) capacitor c=0.00326151f //x=8.545 \
 //y=5.385 //x2=9.91 //y2=5.2
cc_600 ( N_Y_c_582_n N_VDD_M16_noxref_s ) capacitor c=0.00581388f //x=8.15 \
 //y=5.385 //x2=9.91 //y2=5.2
cc_601 ( N_Y_c_678_p N_noxref_7_c_1696_n ) capacitor c=0.00314935f //x=5.335 \
 //y=5.385 //x2=5.14 //y2=7.085
cc_602 ( N_Y_c_581_n N_noxref_7_c_1696_n ) capacitor c=0.00483895f //x=4.82 \
 //y=5.385 //x2=5.14 //y2=7.085
cc_603 ( N_Y_c_683_p N_noxref_7_c_1696_n ) capacitor c=0.00407104f //x=4.82 \
 //y=5.555 //x2=5.14 //y2=7.085
cc_604 ( N_Y_c_581_n N_noxref_7_c_1686_n ) capacitor c=6.31772e-19 //x=4.82 \
 //y=5.385 //x2=3.505 //y2=5.385
cc_605 ( N_Y_c_581_n N_noxref_7_c_1689_n ) capacitor c=0.0508622f //x=4.82 \
 //y=5.385 //x2=4.382 //y2=5.385
cc_606 ( N_Y_c_683_p N_noxref_7_c_1689_n ) capacitor c=0.00265537f //x=4.82 \
 //y=5.555 //x2=4.382 //y2=5.385
cc_607 ( N_Y_c_678_p N_noxref_7_c_1702_n ) capacitor c=0.00509624f //x=5.335 \
 //y=5.385 //x2=5.26 //y2=6.915
cc_608 ( N_Y_c_581_n N_noxref_7_c_1693_n ) capacitor c=0.00256534f //x=4.82 \
 //y=5.385 //x2=4.38 //y2=5.555
cc_609 ( N_Y_c_683_p N_noxref_7_c_1693_n ) capacitor c=0.0673888f //x=4.82 \
 //y=5.555 //x2=4.38 //y2=5.555
cc_610 ( N_Y_c_678_p N_noxref_7_M11_noxref_d ) capacitor c=0.00596205f \
 //x=5.335 //y=5.385 //x2=5.115 //y2=5.2
cc_611 ( N_Y_c_524_n N_noxref_7_M11_noxref_d ) capacitor c=0.00225613f //x=5.3 \
 //y=3.88 //x2=5.115 //y2=5.2
cc_612 ( N_Y_c_683_p N_noxref_7_M11_noxref_d ) capacitor c=0.0471918f //x=4.82 \
 //y=5.555 //x2=5.115 //y2=5.2
cc_613 ( N_Y_c_564_n N_noxref_8_c_1764_n ) capacitor c=0.00305745f //x=8.545 \
 //y=5.385 //x2=8.47 //y2=7.085
cc_614 ( N_Y_c_582_n N_noxref_8_c_1764_n ) capacitor c=0.00506747f //x=8.15 \
 //y=5.385 //x2=8.47 //y2=7.085
cc_615 ( N_Y_c_590_n N_noxref_8_c_1764_n ) capacitor c=0.00407104f //x=8.15 \
 //y=5.555 //x2=8.47 //y2=7.085
cc_616 ( N_Y_c_678_p N_noxref_8_c_1774_n ) capacitor c=0.00525273f //x=5.335 \
 //y=5.385 //x2=6.83 //y2=5.385
cc_617 ( N_Y_c_581_n N_noxref_8_c_1774_n ) capacitor c=0.00499619f //x=4.82 \
 //y=5.385 //x2=6.83 //y2=5.385
cc_618 ( N_Y_c_582_n N_noxref_8_c_1774_n ) capacitor c=6.57436e-19 //x=8.15 \
 //y=5.385 //x2=6.83 //y2=5.385
cc_619 ( N_Y_c_582_n N_noxref_8_c_1766_n ) capacitor c=0.0519034f //x=8.15 \
 //y=5.385 //x2=7.71 //y2=5.385
cc_620 ( N_Y_c_590_n N_noxref_8_c_1766_n ) capacitor c=0.00247636f //x=8.15 \
 //y=5.555 //x2=7.71 //y2=5.385
cc_621 ( N_Y_c_564_n N_noxref_8_c_1768_n ) capacitor c=0.00502035f //x=8.545 \
 //y=5.385 //x2=8.59 //y2=6.915
cc_622 ( N_Y_c_582_n N_noxref_8_c_1769_n ) capacitor c=0.0025396f //x=8.15 \
 //y=5.385 //x2=7.71 //y2=5.555
cc_623 ( N_Y_c_590_n N_noxref_8_c_1769_n ) capacitor c=0.0673446f //x=8.15 \
 //y=5.555 //x2=7.71 //y2=5.555
cc_624 ( Y N_noxref_8_M15_noxref_d ) capacitor c=0.0012136f //x=8.63 //y=3.88 \
 //x2=8.445 //y2=5.2
cc_625 ( N_Y_c_564_n N_noxref_8_M15_noxref_d ) capacitor c=0.00776857f \
 //x=8.545 //y=5.385 //x2=8.445 //y2=5.2
cc_626 ( N_Y_c_590_n N_noxref_8_M15_noxref_d ) capacitor c=0.0473254f //x=8.15 \
 //y=5.555 //x2=8.445 //y2=5.2
cc_627 ( N_Y_c_538_n N_GND_c_1855_n ) capacitor c=0.0155245f //x=4.86 \
 //y=1.295 //x2=3.89 //y2=1.02
cc_628 ( N_Y_M2_noxref_d N_GND_c_1855_n ) capacitor c=5.48773e-19 //x=4.67 \
 //y=1.085 //x2=3.89 //y2=1.02
cc_629 ( N_Y_c_538_n N_GND_c_1933_n ) capacitor c=0.00948324f //x=4.86 \
 //y=1.295 //x2=7.135 //y2=0.175
cc_630 ( N_Y_c_541_n N_GND_c_1933_n ) capacitor c=0.00847343f //x=5.335 \
 //y=1.83 //x2=7.135 //y2=0.175
cc_631 ( N_Y_c_521_n N_GND_c_1933_n ) capacitor c=3.90265e-19 //x=5.42 \
 //y=3.995 //x2=7.135 //y2=0.175
cc_632 ( N_Y_M2_noxref_d N_GND_c_1933_n ) capacitor c=3.01769e-19 //x=4.67 \
 //y=1.085 //x2=7.135 //y2=0.175
cc_633 ( N_Y_c_538_n N_GND_c_1905_n ) capacitor c=0.00587017f //x=4.86 \
 //y=1.295 //x2=7.22 //y2=1.02
cc_634 ( N_Y_c_551_n N_GND_c_1905_n ) capacitor c=0.016074f //x=8.19 //y=1.3 \
 //x2=7.22 //y2=1.02
cc_635 ( N_Y_M4_noxref_d N_GND_c_1905_n ) capacitor c=5.55977e-19 //x=8 \
 //y=1.085 //x2=7.22 //y2=1.02
cc_636 ( N_Y_c_551_n N_GND_c_1940_n ) capacitor c=0.00967902f //x=8.19 //y=1.3 \
 //x2=10.85 //y2=0.18
cc_637 ( N_Y_c_567_n N_GND_c_1940_n ) capacitor c=0.00657171f //x=8.545 \
 //y=1.83 //x2=10.85 //y2=0.18
cc_638 ( N_Y_c_578_n N_GND_c_1940_n ) capacitor c=3.78926e-19 //x=8.63 \
 //y=4.115 //x2=10.85 //y2=0.18
cc_639 ( N_Y_M4_noxref_d N_GND_c_1940_n ) capacitor c=3.01769e-19 //x=8 \
 //y=1.085 //x2=10.85 //y2=0.18
cc_640 ( N_Y_c_541_n N_GND_c_1868_n ) capacitor c=0.00137454f //x=5.335 \
 //y=1.83 //x2=5.87 //y2=0.175
cc_641 ( N_Y_c_567_n N_GND_c_1945_n ) capacitor c=7.80198e-19 //x=8.545 \
 //y=1.83 //x2=9.2 //y2=0.175
cc_642 ( N_Y_c_520_n N_GND_c_1874_n ) capacitor c=8.42561e-19 //x=5.42 \
 //y=3.645 //x2=2.71 //y2=0.175
cc_643 ( Y N_GND_c_1917_n ) capacitor c=8.23221e-19 //x=8.63 //y=2.4 //x2=6.04 \
 //y2=0.175
cc_644 ( N_Y_c_539_n N_GND_c_1917_n ) capacitor c=0.00289817f //x=4.86 \
 //y=1.745 //x2=6.04 //y2=0.175
cc_645 ( N_Y_c_541_n N_GND_c_1917_n ) capacitor c=0.0327177f //x=5.335 \
 //y=1.83 //x2=6.04 //y2=0.175
cc_646 ( N_Y_c_559_n N_GND_c_1919_n ) capacitor c=0.00262965f //x=8.19 \
 //y=1.745 //x2=9.37 //y2=0.175
cc_647 ( N_Y_c_567_n N_GND_c_1919_n ) capacitor c=0.0238079f //x=8.545 \
 //y=1.83 //x2=9.37 //y2=0.175
cc_648 ( N_Y_c_538_n N_GND_c_1923_n ) capacitor c=3.01891e-19 //x=4.86 \
 //y=1.295 //x2=10.96 //y2=0.175
cc_649 ( N_Y_c_551_n N_GND_c_1923_n ) capacitor c=3.01891e-19 //x=8.19 //y=1.3 \
 //x2=10.96 //y2=0.175
cc_650 ( N_Y_c_538_n N_GND_M1_noxref_d ) capacitor c=5.45329e-19 //x=4.86 \
 //y=1.295 //x2=3.7 //y2=1.045
cc_651 ( N_Y_c_551_n N_GND_M3_noxref_d ) capacitor c=5.48773e-19 //x=8.19 \
 //y=1.3 //x2=7.03 //y2=1.045
cc_652 ( N_Y_c_542_n N_noxref_10_c_2101_n ) capacitor c=0.00898362f //x=4.945 \
 //y=1.83 //x2=4.375 //y2=1.675
cc_653 ( N_Y_c_538_n N_noxref_10_c_2108_n ) capacitor c=0.00342795f //x=4.86 \
 //y=1.295 //x2=5.26 //y2=0.71
cc_654 ( N_Y_c_541_n N_noxref_10_c_2108_n ) capacitor c=0.00367592f //x=5.335 \
 //y=1.83 //x2=5.26 //y2=0.71
cc_655 ( N_Y_M2_noxref_d N_noxref_10_c_2108_n ) capacitor c=0.0122548f \
 //x=4.67 //y=1.085 //x2=5.26 //y2=0.71
cc_656 ( N_Y_c_538_n N_noxref_10_M1_noxref_s ) capacitor c=0.00880873f \
 //x=4.86 //y=1.295 //x2=3.27 //y2=0.545
cc_657 ( N_Y_c_539_n N_noxref_10_M1_noxref_s ) capacitor c=0.0162314f //x=4.86 \
 //y=1.745 //x2=3.27 //y2=0.545
cc_658 ( N_Y_c_541_n N_noxref_10_M1_noxref_s ) capacitor c=0.00832408f \
 //x=5.335 //y=1.83 //x2=3.27 //y2=0.545
cc_659 ( N_Y_c_524_n N_noxref_10_M1_noxref_s ) capacitor c=8.7263e-19 //x=5.3 \
 //y=3.88 //x2=3.27 //y2=0.545
cc_660 ( N_Y_M2_noxref_d N_noxref_10_M1_noxref_s ) capacitor c=0.0297733f \
 //x=4.67 //y=1.085 //x2=3.27 //y2=0.545
cc_661 ( N_Y_c_573_n N_noxref_11_c_2159_n ) capacitor c=0.00902033f //x=8.275 \
 //y=1.83 //x2=7.705 //y2=1.675
cc_662 ( N_Y_c_551_n N_noxref_11_c_2161_n ) capacitor c=0.00361131f //x=8.19 \
 //y=1.3 //x2=8.59 //y2=0.71
cc_663 ( N_Y_c_567_n N_noxref_11_c_2161_n ) capacitor c=0.00367648f //x=8.545 \
 //y=1.83 //x2=8.59 //y2=0.71
cc_664 ( N_Y_M4_noxref_d N_noxref_11_c_2161_n ) capacitor c=0.0122548f //x=8 \
 //y=1.085 //x2=8.59 //y2=0.71
cc_665 ( Y N_noxref_11_M3_noxref_s ) capacitor c=8.41716e-19 //x=8.63 //y=3.88 \
 //x2=6.6 //y2=0.545
cc_666 ( N_Y_c_551_n N_noxref_11_M3_noxref_s ) capacitor c=0.00924101f \
 //x=8.19 //y=1.3 //x2=6.6 //y2=0.545
cc_667 ( N_Y_c_559_n N_noxref_11_M3_noxref_s ) capacitor c=0.0156555f //x=8.19 \
 //y=1.745 //x2=6.6 //y2=0.545
cc_668 ( N_Y_c_567_n N_noxref_11_M3_noxref_s ) capacitor c=0.00674411f \
 //x=8.545 //y=1.83 //x2=6.6 //y2=0.545
cc_669 ( N_Y_c_578_n N_noxref_11_M3_noxref_s ) capacitor c=3.27628e-19 \
 //x=8.63 //y=4.115 //x2=6.6 //y2=0.545
cc_670 ( N_Y_M4_noxref_d N_noxref_11_M3_noxref_s ) capacitor c=0.029767f //x=8 \
 //y=1.085 //x2=6.6 //y2=0.545
cc_671 ( N_noxref_4_c_849_n B ) capacitor c=3.71793e-19 //x=7.15 //y=4.62 \
 //x2=4.93 //y2=4.62
cc_672 ( N_noxref_4_c_822_n B ) capacitor c=0.00177537f //x=4.93 //y=3.025 \
 //x2=7.15 //y2=2.4
cc_673 ( N_noxref_4_c_854_n B ) capacitor c=0.0235865f //x=9.96 //y=3.125 \
 //x2=7.15 //y2=2.4
cc_674 ( N_noxref_4_c_845_n B ) capacitor c=0.0235892f //x=10.11 //y=2.965 \
 //x2=10.85 //y2=2.77
cc_675 ( N_noxref_4_c_873_n B ) capacitor c=0.0158655f //x=10.11 //y=3.29 \
 //x2=10.85 //y2=2.77
cc_676 ( N_noxref_4_c_846_n B ) capacitor c=0.00451109f //x=10.11 //y=4.505 \
 //x2=10.85 //y2=2.77
cc_677 ( N_noxref_4_c_893_n B ) capacitor c=0.00556422f //x=10.11 //y=3.14 \
 //x2=10.85 //y2=2.77
cc_678 ( N_noxref_4_c_903_n B ) capacitor c=0.00704249f //x=10.12 //y=3.125 \
 //x2=10.85 //y2=2.77
cc_679 ( N_noxref_4_c_846_n B ) capacitor c=0.0160124f //x=10.11 //y=4.505 \
 //x2=10.85 //y2=3.88
cc_680 ( N_noxref_4_c_846_n B ) capacitor c=0.00188951f //x=10.11 //y=4.505 \
 //x2=10.85 //y2=4.62
cc_681 ( N_noxref_4_c_847_n B ) capacitor c=0.0121778f //x=10.11 //y=4.915 \
 //x2=10.85 //y2=4.62
cc_682 ( N_noxref_4_c_948_p B ) capacitor c=0.00300289f //x=10.11 //y=4.62 \
 //x2=10.85 //y2=4.62
cc_683 ( N_noxref_4_c_902_n B ) capacitor c=0.00366824f //x=10.11 //y=4.677 \
 //x2=10.85 //y2=4.62
cc_684 ( N_noxref_4_c_824_n B ) capacitor c=0.0199211f //x=4.93 //y=3.14 \
 //x2=4.93 //y2=4.25
cc_685 ( N_noxref_4_c_825_n B ) capacitor c=0.00388693f //x=5.075 //y=3.185 \
 //x2=4.93 //y2=4.25
cc_686 ( N_noxref_4_c_854_n B ) capacitor c=4.93016e-19 //x=9.96 //y=3.125 \
 //x2=4.93 //y2=4.25
cc_687 ( N_noxref_4_c_849_n B ) capacitor c=0.0101755f //x=7.15 //y=4.62 \
 //x2=7.15 //y2=3.51
cc_688 ( N_noxref_4_c_854_n B ) capacitor c=0.00656124f //x=9.96 //y=3.125 \
 //x2=7.15 //y2=3.51
cc_689 ( N_noxref_4_c_859_n B ) capacitor c=0.00773567f //x=7.15 //y=4.62 \
 //x2=7.15 //y2=3.51
cc_690 ( N_noxref_4_c_846_n B ) capacitor c=0.020969f //x=10.11 //y=4.505 \
 //x2=10.85 //y2=3.51
cc_691 ( N_noxref_4_c_846_n B ) capacitor c=0.00138341f //x=10.11 //y=4.505 \
 //x2=10.85 //y2=4.25
cc_692 ( N_noxref_4_c_846_n N_B_c_1249_n ) capacitor c=0.0176456f //x=10.11 \
 //y=4.505 //x2=10.85 //y2=4.455
cc_693 ( N_noxref_4_c_847_n N_B_c_1250_n ) capacitor c=0.00916673f //x=10.11 \
 //y=4.915 //x2=10.85 //y2=4.76
cc_694 ( N_noxref_4_c_880_n N_B_c_1250_n ) capacitor c=0.00772912f //x=10.11 \
 //y=5.055 //x2=10.85 //y2=4.76
cc_695 ( N_noxref_4_c_948_p N_B_c_1250_n ) capacitor c=2.40257e-19 //x=10.11 \
 //y=4.62 //x2=10.85 //y2=4.76
cc_696 ( N_noxref_4_c_902_n N_B_c_1250_n ) capacitor c=0.00411491f //x=10.11 \
 //y=4.677 //x2=10.85 //y2=4.76
cc_697 ( N_noxref_4_c_845_n N_B_c_1254_n ) capacitor c=0.0181783f //x=10.11 \
 //y=2.965 //x2=10.85 //y2=2.265
cc_698 ( N_noxref_4_c_824_n N_B_c_1152_n ) capacitor c=4.93016e-19 //x=4.93 \
 //y=3.14 //x2=8.205 //y2=4.25
cc_699 ( N_noxref_4_c_849_n N_B_c_1152_n ) capacitor c=0.0102699f //x=7.15 \
 //y=4.62 //x2=8.205 //y2=4.25
cc_700 ( N_noxref_4_c_851_n N_B_c_1152_n ) capacitor c=0.144574f //x=9.95 \
 //y=4.677 //x2=8.205 //y2=4.25
cc_701 ( N_noxref_4_c_853_n N_B_c_1152_n ) capacitor c=0.0481199f //x=7.135 \
 //y=4.677 //x2=8.205 //y2=4.25
cc_702 ( N_noxref_4_c_854_n N_B_c_1152_n ) capacitor c=0.00927047f //x=9.96 \
 //y=3.125 //x2=8.205 //y2=4.25
cc_703 ( N_noxref_4_c_859_n N_B_c_1152_n ) capacitor c=0.00164847f //x=7.15 \
 //y=4.62 //x2=8.205 //y2=4.25
cc_704 ( N_noxref_4_c_854_n N_B_c_1200_n ) capacitor c=4.43371e-19 //x=9.96 \
 //y=3.125 //x2=9.005 //y2=4.34
cc_705 ( N_noxref_4_c_824_n N_B_c_1128_n ) capacitor c=7.94193e-19 //x=4.93 \
 //y=3.14 //x2=4.91 //y2=4.25
cc_706 ( N_noxref_4_c_825_n N_B_c_1128_n ) capacitor c=0.00847078f //x=5.075 \
 //y=3.185 //x2=4.91 //y2=4.25
cc_707 ( N_noxref_4_c_854_n N_B_c_1154_n ) capacitor c=0.0358686f //x=9.96 \
 //y=3.125 //x2=7.315 //y2=3.52
cc_708 ( N_noxref_4_c_846_n N_B_c_1209_n ) capacitor c=0.00149931f //x=10.11 \
 //y=4.505 //x2=9.092 //y2=4.25
cc_709 ( N_noxref_4_c_854_n N_B_c_1209_n ) capacitor c=0.00452617f //x=9.96 \
 //y=3.125 //x2=9.092 //y2=4.25
cc_710 ( N_noxref_4_c_846_n N_B_c_1267_n ) capacitor c=0.0023574f //x=10.11 \
 //y=4.505 //x2=10.87 //y2=4.295
cc_711 ( N_noxref_4_c_846_n N_B_c_1268_n ) capacitor c=0.024867f //x=10.11 \
 //y=4.505 //x2=10.71 //y2=4.295
cc_712 ( N_noxref_4_c_847_n N_B_c_1268_n ) capacitor c=0.00653709f //x=10.11 \
 //y=4.915 //x2=10.71 //y2=4.295
cc_713 ( N_noxref_4_c_979_p N_B_c_1268_n ) capacitor c=0.0100884f //x=10.39 \
 //y=5.14 //x2=10.71 //y2=4.295
cc_714 ( N_noxref_4_c_882_n N_B_c_1268_n ) capacitor c=6.95554e-19 //x=10.475 \
 //y=5.42 //x2=10.71 //y2=4.295
cc_715 ( N_noxref_4_c_851_n N_B_c_1268_n ) capacitor c=0.0858117f //x=9.95 \
 //y=4.677 //x2=10.71 //y2=4.295
cc_716 ( N_noxref_4_c_846_n N_B_c_1210_n ) capacitor c=0.00440076f //x=10.11 \
 //y=4.505 //x2=10.925 //y2=3.585
cc_717 ( N_noxref_4_c_873_n N_B_c_1155_n ) capacitor c=0.00735142f //x=10.11 \
 //y=3.29 //x2=10.735 //y2=3.585
cc_718 ( N_noxref_4_c_846_n N_B_c_1155_n ) capacitor c=0.0234201f //x=10.11 \
 //y=4.505 //x2=10.735 //y2=3.585
cc_719 ( N_noxref_4_c_985_p N_B_c_1155_n ) capacitor c=0.00570424f //x=10.395 \
 //y=2.02 //x2=10.735 //y2=3.585
cc_720 ( N_noxref_4_c_851_n N_B_c_1155_n ) capacitor c=0.00351804f //x=9.95 \
 //y=4.677 //x2=10.735 //y2=3.585
cc_721 ( N_noxref_4_c_903_n N_B_c_1155_n ) capacitor c=0.0368427f //x=10.12 \
 //y=3.125 //x2=10.735 //y2=3.585
cc_722 ( N_noxref_4_c_854_n N_B_c_1155_n ) capacitor c=0.230398f //x=9.96 \
 //y=3.125 //x2=10.735 //y2=3.585
cc_723 ( N_noxref_4_c_845_n N_B_c_1280_n ) capacitor c=4.71798e-19 //x=10.11 \
 //y=2.965 //x2=10.85 //y2=2.265
cc_724 ( N_noxref_4_c_847_n N_B_c_1281_n ) capacitor c=9.76098e-19 //x=10.11 \
 //y=4.915 //x2=10.85 //y2=4.88
cc_725 ( N_noxref_4_c_880_n N_B_c_1281_n ) capacitor c=0.00101709f //x=10.11 \
 //y=5.055 //x2=10.85 //y2=4.88
cc_726 ( N_noxref_4_c_948_p N_B_c_1281_n ) capacitor c=0.00170133f //x=10.11 \
 //y=4.62 //x2=10.85 //y2=4.88
cc_727 ( N_noxref_4_c_979_p N_B_M16_noxref_g ) capacitor c=0.0069321f \
 //x=10.39 //y=5.14 //x2=10.255 //y2=6.2
cc_728 ( N_noxref_4_c_994_p N_B_M16_noxref_g ) capacitor c=0.00222545f \
 //x=10.195 //y=5.14 //x2=10.255 //y2=6.2
cc_729 ( N_noxref_4_c_882_n N_B_M16_noxref_g ) capacitor c=0.00332234f \
 //x=10.475 //y=5.42 //x2=10.255 //y2=6.2
cc_730 ( N_noxref_4_c_996_p N_B_M16_noxref_g ) capacitor c=0.0162066f \
 //x=10.475 //y=5.56 //x2=10.255 //y2=6.2
cc_731 ( N_noxref_4_c_979_p N_B_M17_noxref_g ) capacitor c=0.00534267f \
 //x=10.39 //y=5.14 //x2=10.695 //y2=6.2
cc_732 ( N_noxref_4_c_882_n N_B_M17_noxref_g ) capacitor c=0.00141266f \
 //x=10.475 //y=5.42 //x2=10.695 //y2=6.2
cc_733 ( N_noxref_4_c_996_p N_B_M17_noxref_g ) capacitor c=0.0162066f \
 //x=10.475 //y=5.56 //x2=10.695 //y2=6.2
cc_734 ( N_noxref_4_c_894_n N_B_c_1291_n ) capacitor c=0.0014717f //x=10.48 \
 //y=1.185 //x2=10.21 //y2=1.09
cc_735 ( N_noxref_4_M5_noxref_d N_B_c_1291_n ) capacitor c=0.00136418f \
 //x=10.285 //y=1.09 //x2=10.21 //y2=1.09
cc_736 ( N_noxref_4_c_985_p N_B_c_1293_n ) capacitor c=0.00180253f //x=10.395 \
 //y=2.02 //x2=10.21 //y2=1.435
cc_737 ( N_noxref_4_c_884_n N_B_c_1293_n ) capacitor c=0.00322824f //x=10.48 \
 //y=1.935 //x2=10.21 //y2=1.435
cc_738 ( N_noxref_4_c_894_n N_B_c_1293_n ) capacitor c=0.00350441f //x=10.48 \
 //y=1.185 //x2=10.21 //y2=1.435
cc_739 ( N_noxref_4_M5_noxref_d N_B_c_1293_n ) capacitor c=0.00235934f \
 //x=10.285 //y=1.09 //x2=10.21 //y2=1.435
cc_740 ( N_noxref_4_c_979_p N_B_c_1297_n ) capacitor c=0.00262283f //x=10.39 \
 //y=5.14 //x2=10.62 //y2=4.97
cc_741 ( N_noxref_4_c_996_p N_B_c_1297_n ) capacitor c=0.00290963f //x=10.475 \
 //y=5.56 //x2=10.62 //y2=4.97
cc_742 ( N_noxref_4_c_847_n N_B_c_1299_n ) capacitor c=0.00202157f //x=10.11 \
 //y=4.915 //x2=10.33 //y2=4.97
cc_743 ( N_noxref_4_c_880_n N_B_c_1299_n ) capacitor c=0.00154279f //x=10.11 \
 //y=5.055 //x2=10.33 //y2=4.97
cc_744 ( N_noxref_4_c_948_p N_B_c_1299_n ) capacitor c=5.77529e-19 //x=10.11 \
 //y=4.62 //x2=10.33 //y2=4.97
cc_745 ( N_noxref_4_c_894_n N_B_c_1302_n ) capacitor c=5.57924e-19 //x=10.48 \
 //y=1.185 //x2=10.585 //y2=0.935
cc_746 ( N_noxref_4_M5_noxref_d N_B_c_1302_n ) capacitor c=0.0020782f \
 //x=10.285 //y=1.09 //x2=10.585 //y2=0.935
cc_747 ( N_noxref_4_c_884_n N_B_c_1304_n ) capacitor c=0.00935661f //x=10.48 \
 //y=1.935 //x2=10.585 //y2=1.59
cc_748 ( N_noxref_4_c_894_n N_B_c_1304_n ) capacitor c=5.75878e-19 //x=10.48 \
 //y=1.185 //x2=10.585 //y2=1.59
cc_749 ( N_noxref_4_M5_noxref_d N_B_c_1304_n ) capacitor c=0.00356097f \
 //x=10.285 //y=1.09 //x2=10.585 //y2=1.59
cc_750 ( N_noxref_4_c_847_n N_B_c_1307_n ) capacitor c=0.00186493f //x=10.11 \
 //y=4.915 //x2=10.695 //y2=5.045
cc_751 ( N_noxref_4_c_948_p N_B_c_1307_n ) capacitor c=0.00115199f //x=10.11 \
 //y=4.62 //x2=10.695 //y2=5.045
cc_752 ( N_noxref_4_c_894_n N_B_c_1309_n ) capacitor c=0.0018901f //x=10.48 \
 //y=1.185 //x2=10.74 //y2=1.09
cc_753 ( N_noxref_4_M5_noxref_d N_B_c_1309_n ) capacitor c=0.00139961f \
 //x=10.285 //y=1.09 //x2=10.74 //y2=1.09
cc_754 ( N_noxref_4_c_884_n N_B_c_1311_n ) capacitor c=0.0012792f //x=10.48 \
 //y=1.935 //x2=10.74 //y2=1.435
cc_755 ( N_noxref_4_c_894_n N_B_c_1311_n ) capacitor c=0.00414335f //x=10.48 \
 //y=1.185 //x2=10.74 //y2=1.435
cc_756 ( N_noxref_4_M5_noxref_d N_B_c_1311_n ) capacitor c=0.0023891f \
 //x=10.285 //y=1.09 //x2=10.74 //y2=1.435
cc_757 ( N_noxref_4_c_884_n N_B_c_1314_n ) capacitor c=0.0056351f //x=10.48 \
 //y=1.935 //x2=10.74 //y2=1.745
cc_758 ( N_noxref_4_c_884_n N_B_c_1315_n ) capacitor c=0.00440271f //x=10.48 \
 //y=1.935 //x2=10.74 //y2=2.1
cc_759 ( N_noxref_4_c_845_n N_B_c_1316_n ) capacitor c=0.00275704f //x=10.11 \
 //y=2.965 //x2=10.74 //y2=2.265
cc_760 ( N_noxref_4_c_985_p N_B_c_1316_n ) capacitor c=0.00440271f //x=10.395 \
 //y=2.02 //x2=10.74 //y2=2.265
cc_761 ( N_noxref_4_M12_noxref_g N_VDD_c_1512_n ) capacitor c=0.00366759f \
 //x=7.05 //y=6.2 //x2=7.27 //y2=6.69
cc_762 ( N_noxref_4_M13_noxref_g N_VDD_c_1512_n ) capacitor c=0.00390412f \
 //x=7.49 //y=6.2 //x2=7.27 //y2=6.69
cc_763 ( N_noxref_4_M12_noxref_g N_VDD_c_1514_n ) capacitor c=0.00504618f \
 //x=7.05 //y=6.2 //x2=7.27 //y2=7.41
cc_764 ( N_noxref_4_M13_noxref_g N_VDD_c_1514_n ) capacitor c=0.00586893f \
 //x=7.49 //y=6.2 //x2=7.27 //y2=7.41
cc_765 ( N_noxref_4_c_847_n N_VDD_c_1491_n ) capacitor c=2.1116e-19 //x=10.11 \
 //y=4.915 //x2=10.85 //y2=7.58
cc_766 ( N_noxref_4_c_994_p N_VDD_c_1491_n ) capacitor c=0.0020014f //x=10.195 \
 //y=5.14 //x2=10.85 //y2=7.58
cc_767 ( N_noxref_4_c_882_n N_VDD_c_1491_n ) capacitor c=0.00259718f \
 //x=10.475 //y=5.42 //x2=10.85 //y2=7.58
cc_768 ( N_noxref_4_c_996_p N_VDD_c_1491_n ) capacitor c=0.00241566f \
 //x=10.475 //y=5.56 //x2=10.85 //y2=7.58
cc_769 ( N_noxref_4_M12_noxref_g N_VDD_c_1471_n ) capacitor c=0.00750251f \
 //x=7.05 //y=6.2 //x2=9.2 //y2=7.585
cc_770 ( N_noxref_4_M13_noxref_g N_VDD_c_1471_n ) capacitor c=0.00755544f \
 //x=7.49 //y=6.2 //x2=9.2 //y2=7.585
cc_771 ( N_noxref_4_c_994_p N_VDD_c_1522_n ) capacitor c=0.00193873f \
 //x=10.195 //y=5.14 //x2=10.83 //y2=7.585
cc_772 ( N_noxref_4_c_882_n N_VDD_c_1522_n ) capacitor c=8.96756e-19 \
 //x=10.475 //y=5.42 //x2=10.83 //y2=7.585
cc_773 ( N_noxref_4_c_996_p N_VDD_c_1522_n ) capacitor c=0.0138017f //x=10.475 \
 //y=5.56 //x2=10.83 //y2=7.585
cc_774 ( N_noxref_4_c_849_n N_VDD_c_1480_n ) capacitor c=0.00424081f //x=7.15 \
 //y=4.62 //x2=6.04 //y2=7.585
cc_775 ( N_noxref_4_c_859_n N_VDD_c_1480_n ) capacitor c=0.00994313f //x=7.15 \
 //y=4.62 //x2=6.04 //y2=7.585
cc_776 ( N_noxref_4_c_865_n N_VDD_c_1480_n ) capacitor c=0.0157659f //x=7.15 \
 //y=4.88 //x2=6.04 //y2=7.585
cc_777 ( N_noxref_4_c_846_n N_VDD_c_1481_n ) capacitor c=0.00363828f //x=10.11 \
 //y=4.505 //x2=9.37 //y2=7.585
cc_778 ( N_noxref_4_c_847_n N_VDD_c_1481_n ) capacitor c=0.00657295f //x=10.11 \
 //y=4.915 //x2=9.37 //y2=7.585
cc_779 ( N_noxref_4_c_880_n N_VDD_c_1481_n ) capacitor c=0.00666218f //x=10.11 \
 //y=5.055 //x2=9.37 //y2=7.585
cc_780 ( N_noxref_4_c_882_n N_VDD_c_1481_n ) capacitor c=0.00203464f \
 //x=10.475 //y=5.42 //x2=9.37 //y2=7.585
cc_781 ( N_noxref_4_c_948_p N_VDD_c_1481_n ) capacitor c=0.011595f //x=10.11 \
 //y=4.62 //x2=9.37 //y2=7.585
cc_782 ( N_noxref_4_c_851_n N_VDD_c_1481_n ) capacitor c=0.023836f //x=9.95 \
 //y=4.677 //x2=9.37 //y2=7.585
cc_783 ( N_noxref_4_c_859_n N_VDD_c_1481_n ) capacitor c=0.00171757f //x=7.15 \
 //y=4.62 //x2=9.37 //y2=7.585
cc_784 ( N_noxref_4_c_996_p N_VDD_c_1481_n ) capacitor c=0.00821734f \
 //x=10.475 //y=5.56 //x2=9.37 //y2=7.585
cc_785 ( N_noxref_4_c_880_n N_VDD_c_1483_n ) capacitor c=2.43252e-19 //x=10.11 \
 //y=5.055 //x2=10.85 //y2=7.58
cc_786 ( N_noxref_4_c_979_p N_VDD_c_1483_n ) capacitor c=0.00685597f //x=10.39 \
 //y=5.14 //x2=10.85 //y2=7.58
cc_787 ( N_noxref_4_c_948_p N_VDD_c_1483_n ) capacitor c=0.00288508f //x=10.11 \
 //y=4.62 //x2=10.85 //y2=7.58
cc_788 ( N_noxref_4_c_996_p N_VDD_c_1483_n ) capacitor c=0.00958319f \
 //x=10.475 //y=5.56 //x2=10.85 //y2=7.58
cc_789 ( N_noxref_4_c_859_n N_VDD_M12_noxref_d ) capacitor c=0.00176891f \
 //x=7.15 //y=4.62 //x2=7.125 //y2=5.2
cc_790 ( N_noxref_4_M12_noxref_g N_VDD_M12_noxref_d ) capacitor c=0.00896756f \
 //x=7.05 //y=6.2 //x2=7.125 //y2=5.2
cc_791 ( N_noxref_4_M13_noxref_g N_VDD_M12_noxref_d ) capacitor c=0.00896756f \
 //x=7.49 //y=6.2 //x2=7.125 //y2=5.2
cc_792 ( N_noxref_4_c_865_n N_VDD_M12_noxref_d ) capacitor c=0.00302778f \
 //x=7.15 //y=4.88 //x2=7.125 //y2=5.2
cc_793 ( N_noxref_4_c_847_n N_VDD_M16_noxref_s ) capacitor c=0.00797506f \
 //x=10.11 //y=4.915 //x2=9.91 //y2=5.2
cc_794 ( N_noxref_4_c_994_p N_VDD_M16_noxref_s ) capacitor c=0.0199504f \
 //x=10.195 //y=5.14 //x2=9.91 //y2=5.2
cc_795 ( N_noxref_4_c_882_n N_VDD_M16_noxref_s ) capacitor c=0.0474638f \
 //x=10.475 //y=5.42 //x2=9.91 //y2=5.2
cc_796 ( N_noxref_4_c_948_p N_VDD_M16_noxref_s ) capacitor c=0.00349095f \
 //x=10.11 //y=4.62 //x2=9.91 //y2=5.2
cc_797 ( N_noxref_4_c_851_n N_VDD_M16_noxref_s ) capacitor c=6.44015e-19 \
 //x=9.95 //y=4.677 //x2=9.91 //y2=5.2
cc_798 ( N_noxref_4_c_902_n N_VDD_M16_noxref_s ) capacitor c=0.00172219f \
 //x=10.11 //y=4.677 //x2=9.91 //y2=5.2
cc_799 ( N_noxref_4_c_996_p N_VDD_M16_noxref_s ) capacitor c=0.0909213f \
 //x=10.475 //y=5.56 //x2=9.91 //y2=5.2
cc_800 ( N_noxref_4_c_882_n N_VDD_M17_noxref_d ) capacitor c=0.0480012f \
 //x=10.475 //y=5.42 //x2=10.77 //y2=5.2
cc_801 ( N_noxref_4_c_996_p N_VDD_M17_noxref_d ) capacitor c=0.0921592f \
 //x=10.475 //y=5.56 //x2=10.77 //y2=5.2
cc_802 ( N_noxref_4_c_849_n N_noxref_8_c_1785_n ) capacitor c=0.0213208f \
 //x=7.15 //y=4.62 //x2=7.59 //y2=5.385
cc_803 ( N_noxref_4_c_851_n N_noxref_8_c_1785_n ) capacitor c=0.0207296f \
 //x=9.95 //y=4.677 //x2=7.59 //y2=5.385
cc_804 ( N_noxref_4_c_853_n N_noxref_8_c_1785_n ) capacitor c=0.0083836f \
 //x=7.135 //y=4.677 //x2=7.59 //y2=5.385
cc_805 ( N_noxref_4_c_859_n N_noxref_8_c_1785_n ) capacitor c=0.00466928f \
 //x=7.15 //y=4.62 //x2=7.59 //y2=5.385
cc_806 ( N_noxref_4_M12_noxref_g N_noxref_8_c_1785_n ) capacitor c=0.011159f \
 //x=7.05 //y=6.2 //x2=7.59 //y2=5.385
cc_807 ( N_noxref_4_M13_noxref_g N_noxref_8_c_1785_n ) capacitor c=0.00878308f \
 //x=7.49 //y=6.2 //x2=7.59 //y2=5.385
cc_808 ( N_noxref_4_c_865_n N_noxref_8_c_1785_n ) capacitor c=0.00140241f \
 //x=7.15 //y=4.88 //x2=7.59 //y2=5.385
cc_809 ( N_noxref_4_M12_noxref_g N_noxref_8_c_1774_n ) capacitor c=0.00413602f \
 //x=7.05 //y=6.2 //x2=6.83 //y2=5.385
cc_810 ( N_noxref_4_c_882_n N_noxref_8_c_1766_n ) capacitor c=4.00761e-19 \
 //x=10.475 //y=5.42 //x2=7.71 //y2=5.385
cc_811 ( N_noxref_4_c_851_n N_noxref_8_c_1766_n ) capacitor c=0.00110484f \
 //x=9.95 //y=4.677 //x2=7.71 //y2=5.385
cc_812 ( N_noxref_4_M13_noxref_g N_noxref_8_c_1766_n ) capacitor c=0.00189987f \
 //x=7.49 //y=6.2 //x2=7.71 //y2=5.385
cc_813 ( N_noxref_4_M13_noxref_g N_noxref_8_c_1767_n ) capacitor c=0.00196943f \
 //x=7.49 //y=6.2 //x2=7.71 //y2=6.915
cc_814 ( N_noxref_4_M12_noxref_g N_noxref_8_c_1797_n ) capacitor c=0.0467392f \
 //x=7.05 //y=6.2 //x2=6.83 //y2=5.555
cc_815 ( N_noxref_4_M13_noxref_g N_noxref_8_c_1769_n ) capacitor c=0.0185551f \
 //x=7.49 //y=6.2 //x2=7.71 //y2=5.555
cc_816 ( N_noxref_4_M12_noxref_g N_noxref_8_M12_noxref_s ) capacitor \
 c=0.00606105f //x=7.05 //y=6.2 //x2=6.695 //y2=5.2
cc_817 ( N_noxref_4_c_873_n N_GND_c_1940_n ) capacitor c=5.52288e-19 //x=10.11 \
 //y=3.29 //x2=10.85 //y2=0.18
cc_818 ( N_noxref_4_c_881_n N_GND_c_1940_n ) capacitor c=0.0049877f //x=10.195 \
 //y=2.02 //x2=10.85 //y2=0.18
cc_819 ( N_noxref_4_c_894_n N_GND_c_1940_n ) capacitor c=0.00982892f //x=10.48 \
 //y=1.185 //x2=10.85 //y2=0.18
cc_820 ( N_noxref_4_M5_noxref_d N_GND_c_1940_n ) capacitor c=0.00119455f \
 //x=10.285 //y=1.09 //x2=10.85 //y2=0.18
cc_821 ( N_noxref_4_c_881_n N_GND_c_1960_n ) capacitor c=0.00314748f \
 //x=10.195 //y=2.02 //x2=10.395 //y2=0.715
cc_822 ( N_noxref_4_c_893_n N_GND_c_1960_n ) capacitor c=3.38432e-19 //x=10.11 \
 //y=3.14 //x2=10.395 //y2=0.715
cc_823 ( N_noxref_4_c_894_n N_GND_c_1960_n ) capacitor c=0.00130539f //x=10.48 \
 //y=1.185 //x2=10.395 //y2=0.715
cc_824 ( N_noxref_4_c_894_n N_GND_c_1963_n ) capacitor c=0.00127339f //x=10.48 \
 //y=1.185 //x2=10.875 //y2=0.715
cc_825 ( N_noxref_4_c_826_n N_GND_c_1874_n ) capacitor c=3.96461e-19 //x=4.93 \
 //y=2.26 //x2=2.71 //y2=0.175
cc_826 ( N_noxref_4_c_854_n N_GND_c_1917_n ) capacitor c=0.00412647f //x=9.96 \
 //y=3.125 //x2=6.04 //y2=0.175
cc_827 ( N_noxref_4_c_826_n N_GND_c_1917_n ) capacitor c=0.00354768f //x=4.93 \
 //y=2.26 //x2=6.04 //y2=0.175
cc_828 ( N_noxref_4_c_837_n N_GND_c_1917_n ) capacitor c=0.00582212f //x=4.595 \
 //y=2.095 //x2=6.04 //y2=0.175
cc_829 ( N_noxref_4_c_841_n N_GND_c_1917_n ) capacitor c=0.00230557f //x=5.125 \
 //y=1.43 //x2=6.04 //y2=0.175
cc_830 ( N_noxref_4_c_881_n N_GND_c_1919_n ) capacitor c=0.0208341f //x=10.195 \
 //y=2.02 //x2=9.37 //y2=0.175
cc_831 ( N_noxref_4_c_854_n N_GND_c_1919_n ) capacitor c=0.0072809f //x=9.96 \
 //y=3.125 //x2=9.37 //y2=0.175
cc_832 ( N_noxref_4_c_845_n N_GND_c_1923_n ) capacitor c=2.14154e-19 //x=10.11 \
 //y=2.965 //x2=10.96 //y2=0.175
cc_833 ( N_noxref_4_c_884_n N_GND_c_1923_n ) capacitor c=0.00520602f //x=10.48 \
 //y=1.935 //x2=10.96 //y2=0.175
cc_834 ( N_noxref_4_c_894_n N_GND_c_1923_n ) capacitor c=2.8029e-19 //x=10.48 \
 //y=1.185 //x2=10.96 //y2=0.175
cc_835 ( N_noxref_4_M5_noxref_d N_GND_c_1923_n ) capacitor c=2.70835e-19 \
 //x=10.285 //y=1.09 //x2=10.96 //y2=0.175
cc_836 ( N_noxref_4_c_873_n N_GND_M5_noxref_s ) capacitor c=0.00201228f \
 //x=10.11 //y=3.29 //x2=9.865 //y2=0.55
cc_837 ( N_noxref_4_c_881_n N_GND_M5_noxref_s ) capacitor c=0.0034445f \
 //x=10.195 //y=2.02 //x2=9.865 //y2=0.55
cc_838 ( N_noxref_4_c_884_n N_GND_M5_noxref_s ) capacitor c=0.0325033f \
 //x=10.48 //y=1.935 //x2=9.865 //y2=0.55
cc_839 ( N_noxref_4_c_893_n N_GND_M5_noxref_s ) capacitor c=0.00117218f \
 //x=10.11 //y=3.14 //x2=9.865 //y2=0.55
cc_840 ( N_noxref_4_c_894_n N_GND_M5_noxref_s ) capacitor c=0.0156181f \
 //x=10.48 //y=1.185 //x2=9.865 //y2=0.55
cc_841 ( N_noxref_4_M5_noxref_d N_GND_M5_noxref_s ) capacitor c=0.0377642f \
 //x=10.285 //y=1.09 //x2=9.865 //y2=0.55
cc_842 ( N_noxref_4_c_834_n N_noxref_10_c_2101_n ) capacitor c=0.00882422f \
 //x=4.595 //y=1.74 //x2=4.375 //y2=1.675
cc_843 ( N_noxref_4_c_826_n N_noxref_10_c_2108_n ) capacitor c=4.21808e-19 \
 //x=4.93 //y=2.26 //x2=5.26 //y2=0.71
cc_844 ( N_noxref_4_c_829_n N_noxref_10_c_2108_n ) capacitor c=0.020405f \
 //x=4.595 //y=1.085 //x2=5.26 //y2=0.71
cc_845 ( N_noxref_4_c_837_n N_noxref_10_c_2108_n ) capacitor c=2.1838e-19 \
 //x=4.595 //y=2.095 //x2=5.26 //y2=0.71
cc_846 ( N_noxref_4_c_840_n N_noxref_10_c_2108_n ) capacitor c=0.00825432f \
 //x=5.125 //y=1.085 //x2=5.26 //y2=0.71
cc_847 ( N_noxref_4_c_829_n N_noxref_10_M1_noxref_s ) capacitor c=0.00882422f \
 //x=4.595 //y=1.085 //x2=3.27 //y2=0.545
cc_848 ( N_noxref_4_c_840_n N_noxref_10_M1_noxref_s ) capacitor c=0.0152167f \
 //x=5.125 //y=1.085 //x2=3.27 //y2=0.545
cc_849 ( N_noxref_4_c_841_n N_noxref_10_M1_noxref_s ) capacitor c=0.00248746f \
 //x=5.125 //y=1.43 //x2=3.27 //y2=0.545
cc_850 ( N_noxref_4_c_849_n N_noxref_11_c_2158_n ) capacitor c=3.98532e-19 \
 //x=7.15 //y=4.62 //x2=7.62 //y2=1.76
cc_851 ( N_noxref_4_c_854_n N_noxref_11_M3_noxref_s ) capacitor c=6.422e-19 \
 //x=9.96 //y=3.125 //x2=6.6 //y2=0.545
cc_852 ( B N_VDD_c_1491_n ) capacitor c=2.13654e-19 //x=10.85 //y=3.51 \
 //x2=10.85 //y2=7.58
cc_853 ( N_B_c_1249_n N_VDD_c_1491_n ) capacitor c=3.13357e-19 //x=10.85 \
 //y=4.455 //x2=10.85 //y2=7.58
cc_854 ( N_B_c_1250_n N_VDD_c_1491_n ) capacitor c=5.73169e-19 //x=10.85 \
 //y=4.76 //x2=10.85 //y2=7.58
cc_855 ( N_B_c_1281_n N_VDD_c_1491_n ) capacitor c=3.40755e-19 //x=10.85 \
 //y=4.88 //x2=10.85 //y2=7.58
cc_856 ( N_B_M10_noxref_g N_VDD_c_1433_n ) capacitor c=0.00777954f //x=4.6 \
 //y=6.2 //x2=5.87 //y2=7.585
cc_857 ( N_B_M11_noxref_g N_VDD_c_1433_n ) capacitor c=0.00758899f //x=5.04 \
 //y=6.2 //x2=5.87 //y2=7.585
cc_858 ( N_B_c_1249_n N_VDD_c_1522_n ) capacitor c=2.89655e-19 //x=10.85 \
 //y=4.455 //x2=10.83 //y2=7.585
cc_859 ( N_B_c_1250_n N_VDD_c_1522_n ) capacitor c=5.48929e-19 //x=10.85 \
 //y=4.76 //x2=10.83 //y2=7.585
cc_860 ( N_B_M16_noxref_g N_VDD_c_1522_n ) capacitor c=0.00750393f //x=10.255 \
 //y=6.2 //x2=10.83 //y2=7.585
cc_861 ( N_B_M17_noxref_g N_VDD_c_1522_n ) capacitor c=0.00753931f //x=10.695 \
 //y=6.2 //x2=10.83 //y2=7.585
cc_862 ( B N_VDD_c_1480_n ) capacitor c=0.00228729f //x=4.93 //y=4.25 \
 //x2=6.04 //y2=7.585
cc_863 ( N_B_c_1152_n N_VDD_c_1480_n ) capacitor c=0.0193201f //x=8.205 \
 //y=4.25 //x2=6.04 //y2=7.585
cc_864 ( N_B_c_1131_n N_VDD_c_1480_n ) capacitor c=0.00347959f //x=4.93 \
 //y=4.88 //x2=6.04 //y2=7.585
cc_865 ( N_B_c_1138_n N_VDD_c_1480_n ) capacitor c=0.0200066f //x=4.93 \
 //y=4.88 //x2=6.04 //y2=7.585
cc_866 ( B N_VDD_c_1481_n ) capacitor c=0.00133985f //x=10.85 //y=4.25 \
 //x2=9.37 //y2=7.585
cc_867 ( N_B_c_1209_n N_VDD_c_1481_n ) capacitor c=0.00290871f //x=9.092 \
 //y=4.25 //x2=9.37 //y2=7.585
cc_868 ( N_B_c_1268_n N_VDD_c_1481_n ) capacitor c=0.00889529f //x=10.71 \
 //y=4.295 //x2=9.37 //y2=7.585
cc_869 ( N_B_c_1281_n N_VDD_c_1481_n ) capacitor c=0.00186252f //x=10.85 \
 //y=4.88 //x2=9.37 //y2=7.585
cc_870 ( N_B_c_1299_n N_VDD_c_1481_n ) capacitor c=0.00914963f //x=10.33 \
 //y=4.97 //x2=9.37 //y2=7.585
cc_871 ( N_B_c_1307_n N_VDD_c_1481_n ) capacitor c=2.63786e-19 //x=10.695 \
 //y=5.045 //x2=9.37 //y2=7.585
cc_872 ( B N_VDD_c_1483_n ) capacitor c=0.00792555f //x=10.85 //y=4.62 \
 //x2=10.85 //y2=7.58
cc_873 ( B N_VDD_c_1483_n ) capacitor c=0.00440289f //x=10.85 //y=4.25 \
 //x2=10.85 //y2=7.58
cc_874 ( N_B_c_1249_n N_VDD_c_1483_n ) capacitor c=0.00408483f //x=10.85 \
 //y=4.455 //x2=10.85 //y2=7.58
cc_875 ( N_B_c_1250_n N_VDD_c_1483_n ) capacitor c=0.00869686f //x=10.85 \
 //y=4.76 //x2=10.85 //y2=7.58
cc_876 ( N_B_c_1281_n N_VDD_c_1483_n ) capacitor c=0.00795821f //x=10.85 \
 //y=4.88 //x2=10.85 //y2=7.58
cc_877 ( N_B_M17_noxref_g N_VDD_c_1483_n ) capacitor c=0.0181495f //x=10.695 \
 //y=6.2 //x2=10.85 //y2=7.58
cc_878 ( N_B_c_1307_n N_VDD_c_1483_n ) capacitor c=0.00800599f //x=10.695 \
 //y=5.045 //x2=10.85 //y2=7.58
cc_879 ( N_B_M16_noxref_g N_VDD_M16_noxref_s ) capacitor c=0.0572684f \
 //x=10.255 //y=6.2 //x2=9.91 //y2=5.2
cc_880 ( N_B_c_1249_n N_VDD_M17_noxref_d ) capacitor c=0.0021799f //x=10.85 \
 //y=4.455 //x2=10.77 //y2=5.2
cc_881 ( N_B_c_1250_n N_VDD_M17_noxref_d ) capacitor c=0.0208697f //x=10.85 \
 //y=4.76 //x2=10.77 //y2=5.2
cc_882 ( N_B_c_1267_n N_VDD_M17_noxref_d ) capacitor c=9.3589e-19 //x=10.87 \
 //y=4.295 //x2=10.77 //y2=5.2
cc_883 ( N_B_c_1281_n N_VDD_M17_noxref_d ) capacitor c=0.00986062f //x=10.85 \
 //y=4.88 //x2=10.77 //y2=5.2
cc_884 ( N_B_M17_noxref_g N_VDD_M17_noxref_d ) capacitor c=0.0573441f \
 //x=10.695 //y=6.2 //x2=10.77 //y2=5.2
cc_885 ( N_B_c_1307_n N_VDD_M17_noxref_d ) capacitor c=0.00531424f //x=10.695 \
 //y=5.045 //x2=10.77 //y2=5.2
cc_886 ( N_B_M10_noxref_g N_noxref_7_c_1696_n ) capacitor c=0.00908041f \
 //x=4.6 //y=6.2 //x2=5.14 //y2=7.085
cc_887 ( N_B_M11_noxref_g N_noxref_7_c_1696_n ) capacitor c=0.00931785f \
 //x=5.04 //y=6.2 //x2=5.14 //y2=7.085
cc_888 ( N_B_M10_noxref_g N_noxref_7_c_1689_n ) capacitor c=0.0018225f //x=4.6 \
 //y=6.2 //x2=4.382 //y2=5.385
cc_889 ( N_B_M10_noxref_g N_noxref_7_c_1690_n ) capacitor c=0.00184265f \
 //x=4.6 //y=6.2 //x2=4.38 //y2=6.915
cc_890 ( N_B_M11_noxref_g N_noxref_7_c_1702_n ) capacitor c=0.00415884f \
 //x=5.04 //y=6.2 //x2=5.26 //y2=6.915
cc_891 ( N_B_M10_noxref_g N_noxref_7_c_1693_n ) capacitor c=0.0170175f //x=4.6 \
 //y=6.2 //x2=4.38 //y2=5.555
cc_892 ( N_B_M11_noxref_g N_noxref_7_M11_noxref_d ) capacitor c=0.0365939f \
 //x=5.04 //y=6.2 //x2=5.115 //y2=5.2
cc_893 ( N_B_c_1152_n N_noxref_8_c_1774_n ) capacitor c=0.00663912f //x=8.205 \
 //y=4.25 //x2=6.83 //y2=5.385
cc_894 ( B N_GND_c_1905_n ) capacitor c=4.7571e-19 //x=7.15 //y=3.51 //x2=7.22 \
 //y2=1.02
cc_895 ( N_B_c_1148_n N_GND_c_1905_n ) capacitor c=0.00617118f //x=7.15 \
 //y=2.385 //x2=7.22 //y2=1.02
cc_896 ( N_B_c_1157_n N_GND_c_1905_n ) capacitor c=4.2774e-19 //x=7.15 \
 //y=2.26 //x2=7.22 //y2=1.02
cc_897 ( N_B_c_1161_n N_GND_c_1905_n ) capacitor c=0.00164549f //x=6.955 \
 //y=1.045 //x2=7.22 //y2=1.02
cc_898 ( N_B_c_1162_n N_GND_c_1905_n ) capacitor c=0.00307659f //x=6.955 \
 //y=1.39 //x2=7.22 //y2=1.02
cc_899 ( N_B_c_1163_n N_GND_c_1905_n ) capacitor c=2.34235e-19 //x=6.955 \
 //y=1.7 //x2=7.22 //y2=1.02
cc_900 ( N_B_c_1366_p N_GND_c_1905_n ) capacitor c=0.00927154f //x=7.33 \
 //y=0.89 //x2=7.22 //y2=1.02
cc_901 ( N_B_c_1367_p N_GND_c_1905_n ) capacitor c=5.55831e-19 //x=7.33 \
 //y=1.545 //x2=7.22 //y2=1.02
cc_902 ( N_B_c_1169_n N_GND_c_1905_n ) capacitor c=0.00166642f //x=7.485 \
 //y=1.045 //x2=7.22 //y2=1.02
cc_903 ( N_B_c_1171_n N_GND_c_1905_n ) capacitor c=0.00258519f //x=7.485 \
 //y=1.39 //x2=7.22 //y2=1.02
cc_904 ( B N_GND_c_1940_n ) capacitor c=6.30928e-19 //x=10.85 //y=3.51 \
 //x2=10.85 //y2=0.18
cc_905 ( N_B_c_1254_n N_GND_c_1940_n ) capacitor c=0.00249122f //x=10.85 \
 //y=2.265 //x2=10.85 //y2=0.18
cc_906 ( N_B_c_1280_n N_GND_c_1940_n ) capacitor c=7.5371e-19 //x=10.85 \
 //y=2.265 //x2=10.85 //y2=0.18
cc_907 ( N_B_c_1161_n N_GND_c_1945_n ) capacitor c=0.0069223f //x=6.955 \
 //y=1.045 //x2=9.2 //y2=0.175
cc_908 ( N_B_c_1291_n N_GND_c_1960_n ) capacitor c=0.0132013f //x=10.21 \
 //y=1.09 //x2=10.395 //y2=0.715
cc_909 ( B N_GND_c_1963_n ) capacitor c=3.61051e-19 //x=10.85 //y=3.51 \
 //x2=10.875 //y2=0.715
cc_910 ( N_B_c_1254_n N_GND_c_1963_n ) capacitor c=0.00114179f //x=10.85 \
 //y=2.265 //x2=10.875 //y2=0.715
cc_911 ( N_B_c_1280_n N_GND_c_1963_n ) capacitor c=3.95714e-19 //x=10.85 \
 //y=2.265 //x2=10.875 //y2=0.715
cc_912 ( N_B_c_1309_n N_GND_c_1963_n ) capacitor c=0.0126466f //x=10.74 \
 //y=1.09 //x2=10.875 //y2=0.715
cc_913 ( N_B_c_1316_n N_GND_c_1963_n ) capacitor c=2.1838e-19 //x=10.74 \
 //y=2.265 //x2=10.875 //y2=0.715
cc_914 ( B N_GND_c_1917_n ) capacitor c=0.00668731f //x=7.15 //y=2.4 //x2=6.04 \
 //y2=0.175
cc_915 ( N_B_c_1148_n N_GND_c_1917_n ) capacitor c=0.00409555f //x=7.15 \
 //y=2.385 //x2=6.04 //y2=0.175
cc_916 ( N_B_c_1157_n N_GND_c_1917_n ) capacitor c=0.00412987f //x=7.15 \
 //y=2.26 //x2=6.04 //y2=0.175
cc_917 ( N_B_c_1163_n N_GND_c_1917_n ) capacitor c=0.0015404f //x=6.955 \
 //y=1.7 //x2=6.04 //y2=0.175
cc_918 ( N_B_c_1165_n N_GND_c_1917_n ) capacitor c=0.008955f //x=6.955 \
 //y=2.095 //x2=6.04 //y2=0.175
cc_919 ( N_B_c_1157_n N_GND_c_1919_n ) capacitor c=4.3717e-19 //x=7.15 \
 //y=2.26 //x2=9.37 //y2=0.175
cc_920 ( N_B_c_1280_n N_GND_c_1919_n ) capacitor c=0.0022444f //x=10.85 \
 //y=2.265 //x2=9.37 //y2=0.175
cc_921 ( N_B_c_1316_n N_GND_c_1919_n ) capacitor c=2.63786e-19 //x=10.74 \
 //y=2.265 //x2=9.37 //y2=0.175
cc_922 ( B N_GND_c_1923_n ) capacitor c=0.0146622f //x=10.85 //y=2.77 \
 //x2=10.96 //y2=0.175
cc_923 ( N_B_c_1254_n N_GND_c_1923_n ) capacitor c=0.0100674f //x=10.85 \
 //y=2.265 //x2=10.96 //y2=0.175
cc_924 ( N_B_c_1280_n N_GND_c_1923_n ) capacitor c=0.00733542f //x=10.85 \
 //y=2.265 //x2=10.96 //y2=0.175
cc_925 ( N_B_c_1315_n N_GND_c_1923_n ) capacitor c=0.0055761f //x=10.74 \
 //y=2.1 //x2=10.96 //y2=0.175
cc_926 ( N_B_c_1316_n N_GND_c_1923_n ) capacitor c=0.00785621f //x=10.74 \
 //y=2.265 //x2=10.96 //y2=0.175
cc_927 ( N_B_c_1148_n N_GND_M3_noxref_d ) capacitor c=4.28437e-19 //x=7.15 \
 //y=2.385 //x2=7.03 //y2=1.045
cc_928 ( N_B_c_1161_n N_GND_M3_noxref_d ) capacitor c=0.00192399f //x=6.955 \
 //y=1.045 //x2=7.03 //y2=1.045
cc_929 ( N_B_c_1162_n N_GND_M3_noxref_d ) capacitor c=0.00228784f //x=6.955 \
 //y=1.39 //x2=7.03 //y2=1.045
cc_930 ( N_B_c_1366_p N_GND_M3_noxref_d ) capacitor c=0.0047434f //x=7.33 \
 //y=0.89 //x2=7.03 //y2=1.045
cc_931 ( N_B_c_1367_p N_GND_M3_noxref_d ) capacitor c=0.00172481f //x=7.33 \
 //y=1.545 //x2=7.03 //y2=1.045
cc_932 ( N_B_c_1169_n N_GND_M3_noxref_d ) capacitor c=0.00230174f //x=7.485 \
 //y=1.045 //x2=7.03 //y2=1.045
cc_933 ( N_B_c_1171_n N_GND_M3_noxref_d ) capacitor c=0.00228784f //x=7.485 \
 //y=1.39 //x2=7.03 //y2=1.045
cc_934 ( B N_GND_M5_noxref_s ) capacitor c=8.86191e-19 //x=10.85 //y=3.51 \
 //x2=9.865 //y2=0.55
cc_935 ( N_B_c_1254_n N_GND_M5_noxref_s ) capacitor c=0.00297876f //x=10.85 \
 //y=2.265 //x2=9.865 //y2=0.55
cc_936 ( N_B_c_1280_n N_GND_M5_noxref_s ) capacitor c=0.00651326f //x=10.85 \
 //y=2.265 //x2=9.865 //y2=0.55
cc_937 ( N_B_c_1291_n N_GND_M5_noxref_s ) capacitor c=0.0153553f //x=10.21 \
 //y=1.09 //x2=9.865 //y2=0.55
cc_938 ( N_B_c_1293_n N_GND_M5_noxref_s ) capacitor c=0.00629878f //x=10.21 \
 //y=1.435 //x2=9.865 //y2=0.55
cc_939 ( N_B_c_1302_n N_GND_M5_noxref_s ) capacitor c=0.00521375f //x=10.585 \
 //y=0.935 //x2=9.865 //y2=0.55
cc_940 ( N_B_c_1309_n N_GND_M5_noxref_s ) capacitor c=0.0301049f //x=10.74 \
 //y=1.09 //x2=9.865 //y2=0.55
cc_941 ( N_B_c_1314_n N_GND_M5_noxref_s ) capacitor c=0.002132f //x=10.74 \
 //y=1.745 //x2=9.865 //y2=0.55
cc_942 ( N_B_c_1315_n N_GND_M5_noxref_s ) capacitor c=0.00304786f //x=10.74 \
 //y=2.1 //x2=9.865 //y2=0.55
cc_943 ( N_B_c_1316_n N_GND_M5_noxref_s ) capacitor c=0.00660555f //x=10.74 \
 //y=2.265 //x2=9.865 //y2=0.55
cc_944 ( N_B_c_1165_n N_noxref_11_c_2157_n ) capacitor c=0.00262672f //x=6.955 \
 //y=2.095 //x2=6.735 //y2=1.675
cc_945 ( B N_noxref_11_c_2158_n ) capacitor c=0.00225097f //x=7.15 //y=3.51 \
 //x2=7.62 //y2=1.76
cc_946 ( N_B_c_1148_n N_noxref_11_c_2158_n ) capacitor c=0.00501755f //x=7.15 \
 //y=2.385 //x2=7.62 //y2=1.76
cc_947 ( N_B_c_1157_n N_noxref_11_c_2158_n ) capacitor c=0.0100501f //x=7.15 \
 //y=2.26 //x2=7.62 //y2=1.76
cc_948 ( N_B_c_1163_n N_noxref_11_c_2158_n ) capacitor c=0.00697093f //x=6.955 \
 //y=1.7 //x2=7.62 //y2=1.76
cc_949 ( N_B_c_1165_n N_noxref_11_c_2158_n ) capacitor c=0.0176366f //x=6.955 \
 //y=2.095 //x2=7.62 //y2=1.76
cc_950 ( N_B_c_1367_p N_noxref_11_c_2158_n ) capacitor c=0.00718985f //x=7.33 \
 //y=1.545 //x2=7.62 //y2=1.76
cc_951 ( N_B_c_1171_n N_noxref_11_c_2158_n ) capacitor c=0.00339872f //x=7.485 \
 //y=1.39 //x2=7.62 //y2=1.76
cc_952 ( N_B_c_1165_n N_noxref_11_c_2159_n ) capacitor c=6.71402e-19 //x=6.955 \
 //y=2.095 //x2=7.705 //y2=1.675
cc_953 ( N_B_c_1161_n N_noxref_11_M3_noxref_s ) capacitor c=0.0293797f \
 //x=6.955 //y=1.045 //x2=6.6 //y2=0.545
cc_954 ( N_B_c_1163_n N_noxref_11_M3_noxref_s ) capacitor c=3.48408e-19 \
 //x=6.955 //y=1.7 //x2=6.6 //y2=0.545
cc_955 ( N_B_c_1169_n N_noxref_11_M3_noxref_s ) capacitor c=0.0124314f \
 //x=7.485 //y=1.045 //x2=6.6 //y2=0.545
cc_956 ( N_VDD_c_1422_n N_noxref_7_c_1679_n ) capacitor c=0.0018734f //x=3.855 \
 //y=7.585 //x2=4.265 //y2=5.385
cc_957 ( N_VDD_c_1425_n N_noxref_7_c_1679_n ) capacitor c=0.00656257f //x=3.94 \
 //y=6.7 //x2=4.265 //y2=5.385
cc_958 ( N_VDD_c_1490_n N_noxref_7_c_1679_n ) capacitor c=5.9643e-19 //x=7.185 \
 //y=7.585 //x2=4.265 //y2=5.385
cc_959 ( N_VDD_c_1433_n N_noxref_7_c_1679_n ) capacitor c=0.00603627f //x=5.87 \
 //y=7.585 //x2=4.265 //y2=5.385
cc_960 ( N_VDD_M8_noxref_d N_noxref_7_c_1679_n ) capacitor c=0.00555899f \
 //x=3.795 //y=5.2 //x2=4.265 //y2=5.385
cc_961 ( N_VDD_c_1483_n N_noxref_7_c_1696_n ) capacitor c=0.00218824f \
 //x=10.85 //y=7.58 //x2=5.14 //y2=7.085
cc_962 ( N_VDD_c_1442_n N_noxref_7_c_1686_n ) capacitor c=0.00744512f //x=2.71 \
 //y=7.585 //x2=3.505 //y2=5.385
cc_963 ( N_VDD_M7_noxref_d N_noxref_7_c_1686_n ) capacitor c=0.0125893f \
 //x=1.9 //y=5.2 //x2=3.505 //y2=5.385
cc_964 ( N_VDD_c_1427_n N_noxref_7_c_1690_n ) capacitor c=0.0392008f //x=3.94 \
 //y=7.41 //x2=4.38 //y2=6.915
cc_965 ( N_VDD_c_1490_n N_noxref_7_c_1690_n ) capacitor c=0.0965083f //x=7.185 \
 //y=7.585 //x2=4.38 //y2=6.915
cc_966 ( N_VDD_c_1433_n N_noxref_7_c_1690_n ) capacitor c=0.0204249f //x=5.87 \
 //y=7.585 //x2=4.38 //y2=6.915
cc_967 ( N_VDD_c_1483_n N_noxref_7_c_1690_n ) capacitor c=0.0011052f //x=10.85 \
 //y=7.58 //x2=4.38 //y2=6.915
cc_968 ( N_VDD_M8_noxref_d N_noxref_7_c_1690_n ) capacitor c=2.33785e-19 \
 //x=3.795 //y=5.2 //x2=4.38 //y2=6.915
cc_969 ( N_VDD_c_1427_n N_noxref_7_c_1702_n ) capacitor c=0.00108205f //x=3.94 \
 //y=7.41 //x2=5.26 //y2=6.915
cc_970 ( N_VDD_c_1490_n N_noxref_7_c_1702_n ) capacitor c=0.00182647f \
 //x=7.185 //y=7.585 //x2=5.26 //y2=6.915
cc_971 ( N_VDD_c_1514_n N_noxref_7_c_1702_n ) capacitor c=0.0024891f //x=7.27 \
 //y=7.41 //x2=5.26 //y2=6.915
cc_972 ( N_VDD_c_1433_n N_noxref_7_c_1702_n ) capacitor c=5.77493e-19 //x=5.87 \
 //y=7.585 //x2=5.26 //y2=6.915
cc_973 ( N_VDD_c_1480_n N_noxref_7_c_1702_n ) capacitor c=0.00746631f //x=6.04 \
 //y=7.585 //x2=5.26 //y2=6.915
cc_974 ( N_VDD_c_1483_n N_noxref_7_c_1702_n ) capacitor c=0.00110341f \
 //x=10.85 //y=7.58 //x2=5.26 //y2=6.915
cc_975 ( N_VDD_c_1422_n N_noxref_7_c_1691_n ) capacitor c=0.00215808f \
 //x=3.855 //y=7.585 //x2=3.5 //y2=5.555
cc_976 ( N_VDD_c_1425_n N_noxref_7_c_1691_n ) capacitor c=0.00720093f //x=3.94 \
 //y=6.7 //x2=3.5 //y2=5.555
cc_977 ( N_VDD_c_1427_n N_noxref_7_c_1691_n ) capacitor c=0.00206125f //x=3.94 \
 //y=7.41 //x2=3.5 //y2=5.555
cc_978 ( N_VDD_c_1433_n N_noxref_7_c_1691_n ) capacitor c=0.00845645f //x=5.87 \
 //y=7.585 //x2=3.5 //y2=5.555
cc_979 ( N_VDD_c_1442_n N_noxref_7_c_1691_n ) capacitor c=0.0521809f //x=2.71 \
 //y=7.585 //x2=3.5 //y2=5.555
cc_980 ( N_VDD_c_1483_n N_noxref_7_c_1691_n ) capacitor c=9.85326e-19 \
 //x=10.85 //y=7.58 //x2=3.5 //y2=5.555
cc_981 ( N_VDD_M7_noxref_d N_noxref_7_c_1691_n ) capacitor c=0.00275426f \
 //x=1.9 //y=5.2 //x2=3.5 //y2=5.555
cc_982 ( N_VDD_M8_noxref_d N_noxref_7_c_1691_n ) capacitor c=0.0490499f \
 //x=3.795 //y=5.2 //x2=3.5 //y2=5.555
cc_983 ( N_VDD_c_1425_n N_noxref_7_c_1693_n ) capacitor c=0.00635282f //x=3.94 \
 //y=6.7 //x2=4.38 //y2=5.555
cc_984 ( N_VDD_c_1427_n N_noxref_7_c_1693_n ) capacitor c=0.00298186f //x=3.94 \
 //y=7.41 //x2=4.38 //y2=5.555
cc_985 ( N_VDD_c_1490_n N_noxref_7_c_1693_n ) capacitor c=0.00203449f \
 //x=7.185 //y=7.585 //x2=4.38 //y2=5.555
cc_986 ( N_VDD_c_1433_n N_noxref_7_c_1693_n ) capacitor c=0.0084192f //x=5.87 \
 //y=7.585 //x2=4.38 //y2=5.555
cc_987 ( N_VDD_c_1483_n N_noxref_7_c_1693_n ) capacitor c=9.85326e-19 \
 //x=10.85 //y=7.58 //x2=4.38 //y2=5.555
cc_988 ( N_VDD_M8_noxref_d N_noxref_7_c_1693_n ) capacitor c=0.0489791f \
 //x=3.795 //y=5.2 //x2=4.38 //y2=5.555
cc_989 ( N_VDD_c_1422_n N_noxref_7_M8_noxref_s ) capacitor c=0.0200102f \
 //x=3.855 //y=7.585 //x2=3.365 //y2=5.2
cc_990 ( N_VDD_c_1427_n N_noxref_7_M8_noxref_s ) capacitor c=0.0364051f \
 //x=3.94 //y=7.41 //x2=3.365 //y2=5.2
cc_991 ( N_VDD_c_1433_n N_noxref_7_M8_noxref_s ) capacitor c=0.00353569f \
 //x=5.87 //y=7.585 //x2=3.365 //y2=5.2
cc_992 ( N_VDD_c_1442_n N_noxref_7_M8_noxref_s ) capacitor c=0.00864701f \
 //x=2.71 //y=7.585 //x2=3.365 //y2=5.2
cc_993 ( N_VDD_c_1483_n N_noxref_7_M8_noxref_s ) capacitor c=7.76446e-19 \
 //x=10.85 //y=7.58 //x2=3.365 //y2=5.2
cc_994 ( N_VDD_M8_noxref_d N_noxref_7_M8_noxref_s ) capacitor c=5.61083e-19 \
 //x=3.795 //y=5.2 //x2=3.365 //y2=5.2
cc_995 ( N_VDD_c_1490_n N_noxref_7_M11_noxref_d ) capacitor c=0.00204601f \
 //x=7.185 //y=7.585 //x2=5.115 //y2=5.2
cc_996 ( N_VDD_c_1433_n N_noxref_7_M11_noxref_d ) capacitor c=0.00844271f \
 //x=5.87 //y=7.585 //x2=5.115 //y2=5.2
cc_997 ( N_VDD_c_1480_n N_noxref_7_M11_noxref_d ) capacitor c=0.0449126f \
 //x=6.04 //y=7.585 //x2=5.115 //y2=5.2
cc_998 ( N_VDD_c_1483_n N_noxref_7_M11_noxref_d ) capacitor c=9.81989e-19 \
 //x=10.85 //y=7.58 //x2=5.115 //y2=5.2
cc_999 ( N_VDD_c_1490_n N_noxref_8_c_1785_n ) capacitor c=5.50694e-19 \
 //x=7.185 //y=7.585 //x2=7.59 //y2=5.385
cc_1000 ( N_VDD_c_1512_n N_noxref_8_c_1785_n ) capacitor c=0.00626281f \
 //x=7.27 //y=6.69 //x2=7.59 //y2=5.385
cc_1001 ( N_VDD_c_1491_n N_noxref_8_c_1785_n ) capacitor c=0.00188103f \
 //x=10.85 //y=7.58 //x2=7.59 //y2=5.385
cc_1002 ( N_VDD_c_1471_n N_noxref_8_c_1785_n ) capacitor c=0.00587089f //x=9.2 \
 //y=7.585 //x2=7.59 //y2=5.385
cc_1003 ( N_VDD_M12_noxref_d N_noxref_8_c_1785_n ) capacitor c=0.00560574f \
 //x=7.125 //y=5.2 //x2=7.59 //y2=5.385
cc_1004 ( N_VDD_c_1483_n N_noxref_8_c_1764_n ) capacitor c=0.00218824f \
 //x=10.85 //y=7.58 //x2=8.47 //y2=7.085
cc_1005 ( N_VDD_c_1480_n N_noxref_8_c_1774_n ) capacitor c=0.00765055f \
 //x=6.04 //y=7.585 //x2=6.83 //y2=5.385
cc_1006 ( N_VDD_M16_noxref_s N_noxref_8_c_1766_n ) capacitor c=8.13769e-19 \
 //x=9.91 //y=5.2 //x2=7.71 //y2=5.385
cc_1007 ( N_VDD_c_1514_n N_noxref_8_c_1767_n ) capacitor c=0.0400183f //x=7.27 \
 //y=7.41 //x2=7.71 //y2=6.915
cc_1008 ( N_VDD_c_1491_n N_noxref_8_c_1767_n ) capacitor c=0.0968686f \
 //x=10.85 //y=7.58 //x2=7.71 //y2=6.915
cc_1009 ( N_VDD_c_1471_n N_noxref_8_c_1767_n ) capacitor c=0.0205866f //x=9.2 \
 //y=7.585 //x2=7.71 //y2=6.915
cc_1010 ( N_VDD_c_1483_n N_noxref_8_c_1767_n ) capacitor c=0.0011052f \
 //x=10.85 //y=7.58 //x2=7.71 //y2=6.915
cc_1011 ( N_VDD_c_1514_n N_noxref_8_c_1768_n ) capacitor c=0.00106865f \
 //x=7.27 //y=7.41 //x2=8.59 //y2=6.915
cc_1012 ( N_VDD_c_1491_n N_noxref_8_c_1768_n ) capacitor c=0.00223016f \
 //x=10.85 //y=7.58 //x2=8.59 //y2=6.915
cc_1013 ( N_VDD_c_1471_n N_noxref_8_c_1768_n ) capacitor c=6.92169e-19 //x=9.2 \
 //y=7.585 //x2=8.59 //y2=6.915
cc_1014 ( N_VDD_c_1481_n N_noxref_8_c_1768_n ) capacitor c=0.0114707f //x=9.37 \
 //y=7.585 //x2=8.59 //y2=6.915
cc_1015 ( N_VDD_c_1483_n N_noxref_8_c_1768_n ) capacitor c=0.00110321f \
 //x=10.85 //y=7.58 //x2=8.59 //y2=6.915
cc_1016 ( N_VDD_c_1490_n N_noxref_8_c_1797_n ) capacitor c=0.00208659f \
 //x=7.185 //y=7.585 //x2=6.83 //y2=5.555
cc_1017 ( N_VDD_c_1512_n N_noxref_8_c_1797_n ) capacitor c=0.00603066f \
 //x=7.27 //y=6.69 //x2=6.83 //y2=5.555
cc_1018 ( N_VDD_c_1514_n N_noxref_8_c_1797_n ) capacitor c=0.0019759f //x=7.27 \
 //y=7.41 //x2=6.83 //y2=5.555
cc_1019 ( N_VDD_c_1471_n N_noxref_8_c_1797_n ) capacitor c=0.00844377f //x=9.2 \
 //y=7.585 //x2=6.83 //y2=5.555
cc_1020 ( N_VDD_c_1480_n N_noxref_8_c_1797_n ) capacitor c=0.0531681f //x=6.04 \
 //y=7.585 //x2=6.83 //y2=5.555
cc_1021 ( N_VDD_c_1483_n N_noxref_8_c_1797_n ) capacitor c=9.85326e-19 \
 //x=10.85 //y=7.58 //x2=6.83 //y2=5.555
cc_1022 ( N_VDD_M12_noxref_d N_noxref_8_c_1797_n ) capacitor c=0.0480037f \
 //x=7.125 //y=5.2 //x2=6.83 //y2=5.555
cc_1023 ( N_VDD_c_1512_n N_noxref_8_c_1769_n ) capacitor c=0.00693978f \
 //x=7.27 //y=6.69 //x2=7.71 //y2=5.555
cc_1024 ( N_VDD_c_1514_n N_noxref_8_c_1769_n ) capacitor c=0.00340774f \
 //x=7.27 //y=7.41 //x2=7.71 //y2=5.555
cc_1025 ( N_VDD_c_1491_n N_noxref_8_c_1769_n ) capacitor c=0.00203434f \
 //x=10.85 //y=7.58 //x2=7.71 //y2=5.555
cc_1026 ( N_VDD_c_1471_n N_noxref_8_c_1769_n ) capacitor c=0.00841892f //x=9.2 \
 //y=7.585 //x2=7.71 //y2=5.555
cc_1027 ( N_VDD_c_1480_n N_noxref_8_c_1769_n ) capacitor c=0.00122422f \
 //x=6.04 //y=7.585 //x2=7.71 //y2=5.555
cc_1028 ( N_VDD_c_1481_n N_noxref_8_c_1769_n ) capacitor c=0.00100823f \
 //x=9.37 //y=7.585 //x2=7.71 //y2=5.555
cc_1029 ( N_VDD_c_1483_n N_noxref_8_c_1769_n ) capacitor c=9.8537e-19 \
 //x=10.85 //y=7.58 //x2=7.71 //y2=5.555
cc_1030 ( N_VDD_M12_noxref_d N_noxref_8_c_1769_n ) capacitor c=0.0478637f \
 //x=7.125 //y=5.2 //x2=7.71 //y2=5.555
cc_1031 ( N_VDD_c_1427_n N_noxref_8_M12_noxref_s ) capacitor c=6.12118e-19 \
 //x=3.94 //y=7.41 //x2=6.695 //y2=5.2
cc_1032 ( N_VDD_c_1490_n N_noxref_8_M12_noxref_s ) capacitor c=0.0224371f \
 //x=7.185 //y=7.585 //x2=6.695 //y2=5.2
cc_1033 ( N_VDD_c_1514_n N_noxref_8_M12_noxref_s ) capacitor c=0.0371326f \
 //x=7.27 //y=7.41 //x2=6.695 //y2=5.2
cc_1034 ( N_VDD_c_1471_n N_noxref_8_M12_noxref_s ) capacitor c=0.00364495f \
 //x=9.2 //y=7.585 //x2=6.695 //y2=5.2
cc_1035 ( N_VDD_c_1480_n N_noxref_8_M12_noxref_s ) capacitor c=0.00616009f \
 //x=6.04 //y=7.585 //x2=6.695 //y2=5.2
cc_1036 ( N_VDD_c_1483_n N_noxref_8_M12_noxref_s ) capacitor c=8.68951e-19 \
 //x=10.85 //y=7.58 //x2=6.695 //y2=5.2
cc_1037 ( N_VDD_M12_noxref_d N_noxref_8_M12_noxref_s ) capacitor c=2.80542e-19 \
 //x=7.125 //y=5.2 //x2=6.695 //y2=5.2
cc_1038 ( N_VDD_c_1491_n N_noxref_8_M15_noxref_d ) capacitor c=0.00204601f \
 //x=10.85 //y=7.58 //x2=8.445 //y2=5.2
cc_1039 ( N_VDD_c_1471_n N_noxref_8_M15_noxref_d ) capacitor c=0.00844271f \
 //x=9.2 //y=7.585 //x2=8.445 //y2=5.2
cc_1040 ( N_VDD_c_1481_n N_noxref_8_M15_noxref_d ) capacitor c=0.0442363f \
 //x=9.37 //y=7.585 //x2=8.445 //y2=5.2
cc_1041 ( N_VDD_c_1483_n N_noxref_8_M15_noxref_d ) capacitor c=9.81989e-19 \
 //x=10.85 //y=7.58 //x2=8.445 //y2=5.2
cc_1042 ( N_VDD_M16_noxref_s N_noxref_8_M15_noxref_d ) capacitor c=0.00279795f \
 //x=9.91 //y=5.2 //x2=8.445 //y2=5.2
cc_1043 ( N_VDD_c_1435_n N_GND_c_1869_n ) capacitor c=0.00989514f //x=1.23 \
 //y=7.58 //x2=1.12 //y2=0.175
cc_1044 ( N_VDD_c_1442_n N_GND_c_1874_n ) capacitor c=0.00680738f //x=2.71 \
 //y=7.585 //x2=2.71 //y2=0.175
cc_1045 ( N_VDD_c_1480_n N_GND_c_1917_n ) capacitor c=0.00647929f //x=6.04 \
 //y=7.585 //x2=6.04 //y2=0.175
cc_1046 ( N_VDD_c_1481_n N_GND_c_1919_n ) capacitor c=0.0065041f //x=9.37 \
 //y=7.585 //x2=9.37 //y2=0.175
cc_1047 ( N_VDD_c_1483_n N_GND_c_1923_n ) capacitor c=0.00989514f //x=10.85 \
 //y=7.58 //x2=10.96 //y2=0.175
cc_1048 ( N_noxref_7_c_1689_n N_noxref_8_c_1774_n ) capacitor c=0.00121759f \
 //x=4.382 //y=5.385 //x2=6.83 //y2=5.385
cc_1049 ( N_noxref_7_c_1702_n N_noxref_8_c_1767_n ) capacitor c=3.7734e-19 \
 //x=5.26 //y=6.915 //x2=7.71 //y2=6.915
cc_1050 ( N_noxref_7_M11_noxref_d N_noxref_8_c_1797_n ) capacitor \
 c=0.00205908f //x=5.115 //y=5.2 //x2=6.83 //y2=5.555
cc_1051 ( N_noxref_7_c_1690_n N_noxref_8_M12_noxref_s ) capacitor \
 c=2.09567e-19 //x=4.38 //y=6.915 //x2=6.695 //y2=5.2
cc_1052 ( N_noxref_7_c_1702_n N_noxref_8_M12_noxref_s ) capacitor c=0.0118386f \
 //x=5.26 //y=6.915 //x2=6.695 //y2=5.2
cc_1053 ( N_noxref_7_c_1679_n N_GND_c_1855_n ) capacitor c=2.23763e-19 \
 //x=4.265 //y=5.385 //x2=3.89 //y2=1.02
cc_1054 ( N_GND_M0_noxref_s N_noxref_10_c_2093_n ) capacitor c=0.00297559f \
 //x=0.985 //y=0.55 //x2=3.405 //y2=1.675
cc_1055 ( N_GND_c_1850_n N_noxref_10_c_2094_n ) capacitor c=0.00252338f \
 //x=3.805 //y=0.175 //x2=4.29 //y2=1.76
cc_1056 ( N_GND_c_1855_n N_noxref_10_c_2094_n ) capacitor c=0.00327362f \
 //x=3.89 //y=1.02 //x2=4.29 //y2=1.76
cc_1057 ( N_GND_c_1933_n N_noxref_10_c_2094_n ) capacitor c=7.45647e-19 \
 //x=7.135 //y=0.175 //x2=4.29 //y2=1.76
cc_1058 ( N_GND_c_1868_n N_noxref_10_c_2094_n ) capacitor c=0.00378415f \
 //x=5.87 //y=0.175 //x2=4.29 //y2=1.76
cc_1059 ( N_GND_M1_noxref_d N_noxref_10_c_2094_n ) capacitor c=0.00751163f \
 //x=3.7 //y=1.045 //x2=4.29 //y2=1.76
cc_1060 ( N_GND_c_1855_n N_noxref_10_c_2132_n ) capacitor c=0.0120153f \
 //x=3.89 //y=1.02 //x2=4.375 //y2=0.795
cc_1061 ( N_GND_c_1933_n N_noxref_10_c_2132_n ) capacitor c=0.00724992f \
 //x=7.135 //y=0.175 //x2=4.375 //y2=0.795
cc_1062 ( N_GND_c_1868_n N_noxref_10_c_2132_n ) capacitor c=0.014661f //x=5.87 \
 //y=0.175 //x2=4.375 //y2=0.795
cc_1063 ( N_GND_c_1874_n N_noxref_10_c_2132_n ) capacitor c=0.00275521f \
 //x=2.71 //y=0.175 //x2=4.375 //y2=0.795
cc_1064 ( N_GND_c_1917_n N_noxref_10_c_2132_n ) capacitor c=2.99356e-19 \
 //x=6.04 //y=0.175 //x2=4.375 //y2=0.795
cc_1065 ( N_GND_c_1923_n N_noxref_10_c_2132_n ) capacitor c=0.00145873f \
 //x=10.96 //y=0.175 //x2=4.375 //y2=0.795
cc_1066 ( N_GND_c_1874_n N_noxref_10_c_2101_n ) capacitor c=2.8481e-19 \
 //x=2.71 //y=0.175 //x2=4.375 //y2=1.675
cc_1067 ( N_GND_c_1933_n N_noxref_10_c_2108_n ) capacitor c=0.0132286f \
 //x=7.135 //y=0.175 //x2=5.26 //y2=0.71
cc_1068 ( N_GND_c_1868_n N_noxref_10_c_2108_n ) capacitor c=0.0373298f \
 //x=5.87 //y=0.175 //x2=5.26 //y2=0.71
cc_1069 ( N_GND_c_1923_n N_noxref_10_c_2108_n ) capacitor c=0.00199432f \
 //x=10.96 //y=0.175 //x2=5.26 //y2=0.71
cc_1070 ( N_GND_c_1933_n N_noxref_10_c_2142_n ) capacitor c=0.00236147f \
 //x=7.135 //y=0.175 //x2=5.345 //y2=0.795
cc_1071 ( N_GND_c_1868_n N_noxref_10_c_2142_n ) capacitor c=0.0144685f \
 //x=5.87 //y=0.175 //x2=5.345 //y2=0.795
cc_1072 ( N_GND_c_1917_n N_noxref_10_c_2142_n ) capacitor c=0.0391763f \
 //x=6.04 //y=0.175 //x2=5.345 //y2=0.795
cc_1073 ( N_GND_c_1923_n N_noxref_10_c_2142_n ) capacitor c=0.00145015f \
 //x=10.96 //y=0.175 //x2=5.345 //y2=0.795
cc_1074 ( N_GND_c_1850_n N_noxref_10_M1_noxref_s ) capacitor c=0.00724992f \
 //x=3.805 //y=0.175 //x2=3.27 //y2=0.545
cc_1075 ( N_GND_c_1855_n N_noxref_10_M1_noxref_s ) capacitor c=0.026477f \
 //x=3.89 //y=1.02 //x2=3.27 //y2=0.545
cc_1076 ( N_GND_c_2059_p N_noxref_10_M1_noxref_s ) capacitor c=0.00297559f \
 //x=2.09 //y=0.63 //x2=3.27 //y2=0.545
cc_1077 ( N_GND_c_1868_n N_noxref_10_M1_noxref_s ) capacitor c=0.014661f \
 //x=5.87 //y=0.175 //x2=3.27 //y2=0.545
cc_1078 ( N_GND_c_1874_n N_noxref_10_M1_noxref_s ) capacitor c=0.052807f \
 //x=2.71 //y=0.175 //x2=3.27 //y2=0.545
cc_1079 ( N_GND_c_1917_n N_noxref_10_M1_noxref_s ) capacitor c=0.00638766f \
 //x=6.04 //y=0.175 //x2=3.27 //y2=0.545
cc_1080 ( N_GND_c_1923_n N_noxref_10_M1_noxref_s ) capacitor c=0.00145873f \
 //x=10.96 //y=0.175 //x2=3.27 //y2=0.545
cc_1081 ( N_GND_M1_noxref_d N_noxref_10_M1_noxref_s ) capacitor c=0.0294112f \
 //x=3.7 //y=1.045 //x2=3.27 //y2=0.545
cc_1082 ( N_GND_c_1933_n N_noxref_11_c_2158_n ) capacitor c=0.0011359f \
 //x=7.135 //y=0.175 //x2=7.62 //y2=1.76
cc_1083 ( N_GND_c_1905_n N_noxref_11_c_2158_n ) capacitor c=0.00356826f \
 //x=7.22 //y=1.02 //x2=7.62 //y2=1.76
cc_1084 ( N_GND_c_1940_n N_noxref_11_c_2158_n ) capacitor c=0.00186489f \
 //x=10.85 //y=0.18 //x2=7.62 //y2=1.76
cc_1085 ( N_GND_c_1945_n N_noxref_11_c_2158_n ) capacitor c=0.00388617f \
 //x=9.2 //y=0.175 //x2=7.62 //y2=1.76
cc_1086 ( N_GND_M3_noxref_d N_noxref_11_c_2158_n ) capacitor c=0.00751163f \
 //x=7.03 //y=1.045 //x2=7.62 //y2=1.76
cc_1087 ( N_GND_c_1905_n N_noxref_11_c_2199_n ) capacitor c=0.0167642f \
 //x=7.22 //y=1.02 //x2=7.705 //y2=0.795
cc_1088 ( N_GND_c_1940_n N_noxref_11_c_2199_n ) capacitor c=0.00724992f \
 //x=10.85 //y=0.18 //x2=7.705 //y2=0.795
cc_1089 ( N_GND_c_1945_n N_noxref_11_c_2199_n ) capacitor c=0.014661f //x=9.2 \
 //y=0.175 //x2=7.705 //y2=0.795
cc_1090 ( N_GND_c_1917_n N_noxref_11_c_2199_n ) capacitor c=0.00275571f \
 //x=6.04 //y=0.175 //x2=7.705 //y2=0.795
cc_1091 ( N_GND_c_1919_n N_noxref_11_c_2199_n ) capacitor c=2.21767e-19 \
 //x=9.37 //y=0.175 //x2=7.705 //y2=0.795
cc_1092 ( N_GND_c_1923_n N_noxref_11_c_2199_n ) capacitor c=0.00145873f \
 //x=10.96 //y=0.175 //x2=7.705 //y2=0.795
cc_1093 ( N_GND_c_1917_n N_noxref_11_c_2159_n ) capacitor c=2.83682e-19 \
 //x=6.04 //y=0.175 //x2=7.705 //y2=1.675
cc_1094 ( N_GND_c_1940_n N_noxref_11_c_2161_n ) capacitor c=0.0125026f \
 //x=10.85 //y=0.18 //x2=8.59 //y2=0.71
cc_1095 ( N_GND_c_1945_n N_noxref_11_c_2161_n ) capacitor c=0.0374098f //x=9.2 \
 //y=0.175 //x2=8.59 //y2=0.71
cc_1096 ( N_GND_c_1923_n N_noxref_11_c_2161_n ) capacitor c=0.00199432f \
 //x=10.96 //y=0.175 //x2=8.59 //y2=0.71
cc_1097 ( N_GND_c_1940_n N_noxref_11_c_2209_n ) capacitor c=0.00253441f \
 //x=10.85 //y=0.18 //x2=8.675 //y2=0.795
cc_1098 ( N_GND_c_1945_n N_noxref_11_c_2209_n ) capacitor c=0.0144879f //x=9.2 \
 //y=0.175 //x2=8.675 //y2=0.795
cc_1099 ( N_GND_c_2082_p N_noxref_11_c_2209_n ) capacitor c=0.00211803f \
 //x=9.99 //y=0.63 //x2=8.675 //y2=0.795
cc_1100 ( N_GND_c_1919_n N_noxref_11_c_2209_n ) capacitor c=0.0401867f \
 //x=9.37 //y=0.175 //x2=8.675 //y2=0.795
cc_1101 ( N_GND_c_1923_n N_noxref_11_c_2209_n ) capacitor c=0.00145015f \
 //x=10.96 //y=0.175 //x2=8.675 //y2=0.795
cc_1102 ( N_GND_c_1933_n N_noxref_11_M3_noxref_s ) capacitor c=0.00724992f \
 //x=7.135 //y=0.175 //x2=6.6 //y2=0.545
cc_1103 ( N_GND_c_1905_n N_noxref_11_M3_noxref_s ) capacitor c=0.0220962f \
 //x=7.22 //y=1.02 //x2=6.6 //y2=0.545
cc_1104 ( N_GND_c_1945_n N_noxref_11_M3_noxref_s ) capacitor c=0.014661f \
 //x=9.2 //y=0.175 //x2=6.6 //y2=0.545
cc_1105 ( N_GND_c_1917_n N_noxref_11_M3_noxref_s ) capacitor c=0.0518032f \
 //x=6.04 //y=0.175 //x2=6.6 //y2=0.545
cc_1106 ( N_GND_c_1919_n N_noxref_11_M3_noxref_s ) capacitor c=0.00635619f \
 //x=9.37 //y=0.175 //x2=6.6 //y2=0.545
cc_1107 ( N_GND_c_1923_n N_noxref_11_M3_noxref_s ) capacitor c=0.00145873f \
 //x=10.96 //y=0.175 //x2=6.6 //y2=0.545
cc_1108 ( N_GND_M3_noxref_d N_noxref_11_M3_noxref_s ) capacitor c=0.0293978f \
 //x=7.03 //y=1.045 //x2=6.6 //y2=0.545
cc_1109 ( N_GND_M5_noxref_s N_noxref_11_M3_noxref_s ) capacitor c=0.00320428f \
 //x=9.865 //y=0.55 //x2=6.6 //y2=0.545
cc_1110 ( N_noxref_10_c_2101_n N_noxref_11_c_2157_n ) capacitor c=5.32163e-19 \
 //x=4.375 //y=1.675 //x2=6.735 //y2=1.675
cc_1111 ( N_noxref_10_c_2142_n N_noxref_11_M3_noxref_s ) capacitor \
 c=0.00453102f //x=5.345 //y=0.795 //x2=6.6 //y2=0.545
cc_1112 ( N_noxref_10_M1_noxref_s N_noxref_11_M3_noxref_s ) capacitor \
 c=5.32163e-19 //x=3.27 //y=0.545 //x2=6.6 //y2=0.545
