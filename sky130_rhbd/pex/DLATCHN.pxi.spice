// File: DLATCHN.spi.DLATCHN.pxi
// Created: Thu Jan 22 07:05:53 2026
//
simulator lang=spectre
x_PM_DLATCHN\%noxref_1 ( N_noxref_1_c_2_p N_noxref_1_c_6_p N_noxref_1_c_4_p \
 N_noxref_1_c_25_p N_noxref_1_c_115_p N_noxref_1_c_26_p N_noxref_1_c_27_p \
 N_noxref_1_c_51_p N_noxref_1_c_7_p N_noxref_1_c_5_p N_noxref_1_c_10_p \
 N_noxref_1_c_3_p N_noxref_1_c_90_p N_noxref_1_c_38_p N_noxref_1_c_45_p \
 N_noxref_1_c_11_p N_noxref_1_c_8_p N_noxref_1_c_56_p N_noxref_1_c_41_p \
 N_noxref_1_c_58_p N_noxref_1_c_113_p N_noxref_1_c_32_p N_noxref_1_c_12_p \
 N_noxref_1_M2_noxref_g N_noxref_1_M16_noxref_g N_noxref_1_M17_noxref_g \
 N_noxref_1_c_70_p N_noxref_1_c_71_p N_noxref_1_c_73_p N_noxref_1_c_47_p \
 N_noxref_1_c_187_p N_noxref_1_c_188_p N_noxref_1_c_72_p N_noxref_1_c_74_p \
 N_noxref_1_c_15_p N_noxref_1_M1_noxref_d N_noxref_1_M14_noxref_d )  \
 PM_DLATCHN\%noxref_1
x_PM_DLATCHN\%noxref_2 ( N_noxref_2_c_231_n N_noxref_2_c_232_n \
 N_noxref_2_c_293_p N_noxref_2_c_276_p N_noxref_2_c_256_p N_noxref_2_c_234_n \
 N_noxref_2_c_263_p N_noxref_2_c_236_n N_noxref_2_c_254_p N_noxref_2_c_281_p \
 N_noxref_2_c_265_p N_noxref_2_c_239_n N_noxref_2_c_258_p N_noxref_2_c_391_p \
 N_noxref_2_c_246_n N_noxref_2_c_266_p N_noxref_2_c_353_p N_noxref_2_c_285_p \
 N_noxref_2_c_274_p N_noxref_2_c_267_p N_noxref_2_c_286_p N_noxref_2_c_247_n \
 N_noxref_2_c_260_p N_noxref_2_c_356_p N_noxref_2_c_362_p \
 N_noxref_2_M4_noxref_g N_noxref_2_M20_noxref_g N_noxref_2_M21_noxref_g \
 N_noxref_2_c_367_p N_noxref_2_c_333_p N_noxref_2_c_334_p N_noxref_2_c_335_p \
 N_noxref_2_c_348_p N_noxref_2_c_364_p N_noxref_2_c_369_p N_noxref_2_c_336_p \
 N_noxref_2_c_371_p N_noxref_2_c_337_p N_noxref_2_c_344_p \
 N_noxref_2_M3_noxref_d N_noxref_2_M16_noxref_d N_noxref_2_M18_noxref_d )  \
 PM_DLATCHN\%noxref_2
x_PM_DLATCHN\%noxref_3 ( N_noxref_3_c_490_n N_noxref_3_c_491_n \
 N_noxref_3_c_492_n N_noxref_3_c_796_p N_noxref_3_c_493_n N_noxref_3_c_732_p \
 N_noxref_3_c_494_n N_noxref_3_c_623_p N_noxref_3_c_495_n N_noxref_3_c_497_n \
 N_noxref_3_c_500_n N_noxref_3_c_501_n N_noxref_3_c_568_n N_noxref_3_c_630_p \
 N_noxref_3_c_511_n N_noxref_3_c_625_p N_noxref_3_c_512_n N_noxref_3_c_515_n \
 N_noxref_3_c_631_p N_noxref_3_c_648_p N_noxref_3_c_643_p N_noxref_3_c_571_n \
 N_noxref_3_c_516_n N_noxref_3_c_572_n N_noxref_3_c_526_n N_noxref_3_c_580_n \
 N_noxref_3_c_583_n N_noxref_3_c_627_p N_noxref_3_c_722_p N_noxref_3_c_527_n \
 N_noxref_3_c_531_n N_noxref_3_c_634_p N_noxref_3_c_636_p \
 N_noxref_3_M3_noxref_g N_noxref_3_M5_noxref_g N_noxref_3_M18_noxref_g \
 N_noxref_3_M19_noxref_g N_noxref_3_M22_noxref_g N_noxref_3_M23_noxref_g \
 N_noxref_3_c_537_n N_noxref_3_c_540_n N_noxref_3_c_542_n N_noxref_3_c_602_n \
 N_noxref_3_c_605_n N_noxref_3_c_607_n N_noxref_3_c_545_n N_noxref_3_c_546_n \
 N_noxref_3_c_673_p N_noxref_3_c_674_p N_noxref_3_c_676_p N_noxref_3_c_650_p \
 N_noxref_3_c_812_p N_noxref_3_c_813_p N_noxref_3_c_675_p N_noxref_3_c_677_p \
 N_noxref_3_c_547_n N_noxref_3_c_618_n N_noxref_3_c_550_n N_noxref_3_c_637_p \
 N_noxref_3_M0_noxref_d N_noxref_3_M12_noxref_d )  PM_DLATCHN\%noxref_3
x_PM_DLATCHN\%D ( D D D D D D D D D D N_D_c_895_n N_D_c_896_n N_D_c_971_n \
 N_D_c_972_n N_D_c_897_n N_D_c_977_n N_D_c_898_n N_D_c_982_n N_D_c_899_n \
 N_D_c_909_n N_D_c_910_n N_D_c_992_n N_D_c_996_n N_D_M1_noxref_g \
 N_D_M6_noxref_g N_D_M14_noxref_g N_D_M15_noxref_g N_D_M24_noxref_g \
 N_D_M25_noxref_g N_D_c_917_n N_D_c_919_n N_D_c_922_n N_D_c_923_n N_D_c_924_n \
 N_D_c_928_n N_D_c_929_n N_D_c_931_n N_D_c_935_n N_D_c_937_n N_D_c_1002_n \
 N_D_c_1005_n N_D_c_1007_n N_D_c_1046_p N_D_c_1057_p N_D_c_1027_p N_D_c_1010_n \
 N_D_c_1011_n N_D_c_940_n N_D_c_1012_n N_D_c_1029_p N_D_c_1015_n )  \
 PM_DLATCHN\%D
x_PM_DLATCHN\%noxref_5 ( N_noxref_5_c_1171_n N_noxref_5_c_1192_n \
 N_noxref_5_c_1197_n N_noxref_5_c_1198_n N_noxref_5_c_1250_p \
 N_noxref_5_c_1172_n N_noxref_5_c_1205_n N_noxref_5_c_1173_n \
 N_noxref_5_c_1215_n N_noxref_5_c_1258_p N_noxref_5_c_1216_n \
 N_noxref_5_c_1174_n N_noxref_5_c_1219_n N_noxref_5_c_1328_p \
 N_noxref_5_c_1222_n N_noxref_5_c_1228_n N_noxref_5_c_1289_p \
 N_noxref_5_c_1290_p N_noxref_5_c_1257_p N_noxref_5_c_1229_n \
 N_noxref_5_c_1261_p N_noxref_5_c_1180_n N_noxref_5_c_1230_n \
 N_noxref_5_c_1292_p N_noxref_5_c_1298_p N_noxref_5_M7_noxref_g \
 N_noxref_5_M26_noxref_g N_noxref_5_M27_noxref_g N_noxref_5_c_1303_p \
 N_noxref_5_c_1268_p N_noxref_5_c_1269_p N_noxref_5_c_1270_p \
 N_noxref_5_c_1283_p N_noxref_5_c_1300_p N_noxref_5_c_1305_p \
 N_noxref_5_c_1271_p N_noxref_5_c_1307_p N_noxref_5_c_1272_p \
 N_noxref_5_c_1279_p N_noxref_5_M6_noxref_d N_noxref_5_M22_noxref_d \
 N_noxref_5_M24_noxref_d )  PM_DLATCHN\%noxref_5
x_PM_DLATCHN\%noxref_6 ( N_noxref_6_c_1429_n N_noxref_6_c_1436_n \
 N_noxref_6_c_1440_n N_noxref_6_c_1441_n N_noxref_6_c_1443_n \
 N_noxref_6_c_1444_n N_noxref_6_c_1447_n N_noxref_6_c_1456_n \
 N_noxref_6_c_1458_n N_noxref_6_c_1515_n N_noxref_6_c_1552_p \
 N_noxref_6_c_1516_n N_noxref_6_c_1463_n N_noxref_6_c_1471_n \
 N_noxref_6_c_1590_p N_noxref_6_c_1538_p N_noxref_6_c_1578_p \
 N_noxref_6_c_1493_n N_noxref_6_c_1526_n N_noxref_6_c_1529_n \
 N_noxref_6_c_1533_n N_noxref_6_c_1472_n N_noxref_6_c_1473_n \
 N_noxref_6_c_1537_p N_noxref_6_c_1539_p N_noxref_6_M8_noxref_g \
 N_noxref_6_M28_noxref_g N_noxref_6_M29_noxref_g N_noxref_6_c_1540_p \
 N_noxref_6_c_1541_p N_noxref_6_c_1547_p N_noxref_6_c_1548_p \
 N_noxref_6_c_1542_p N_noxref_6_c_1543_p N_noxref_6_c_1597_p \
 N_noxref_6_c_1544_p N_noxref_6_c_1545_p N_noxref_6_c_1610_p \
 N_noxref_6_M4_noxref_d N_noxref_6_M20_noxref_d )  PM_DLATCHN\%noxref_6
x_PM_DLATCHN\%Q ( Q Q Q Q Q Q Q Q Q Q N_Q_c_1733_n N_Q_c_1728_n N_Q_c_1746_n \
 N_Q_c_1729_n N_Q_c_1834_p N_Q_c_1752_n N_Q_c_1871_p N_Q_c_1851_p N_Q_c_1829_p \
 N_Q_c_1773_p N_Q_c_1877_p N_Q_c_1765_p N_Q_c_1780_p N_Q_c_1783_p N_Q_c_1830_p \
 N_Q_c_1774_p N_Q_c_1793_p N_Q_c_1887_p N_Q_c_1784_p N_Q_c_1775_p \
 N_Q_M10_noxref_g N_Q_M32_noxref_g N_Q_M33_noxref_g N_Q_c_1806_p N_Q_c_1808_p \
 N_Q_c_1809_p N_Q_c_1782_p N_Q_c_1839_p N_Q_c_1840_p N_Q_c_1785_p N_Q_c_1807_p \
 N_Q_c_1810_p N_Q_c_1802_p N_Q_M8_noxref_d N_Q_M9_noxref_d N_Q_M30_noxref_d )  \
 PM_DLATCHN\%Q
x_PM_DLATCHN\%noxref_8 ( N_noxref_8_c_2033_n N_noxref_8_c_2040_n \
 N_noxref_8_c_2044_n N_noxref_8_c_2045_n N_noxref_8_c_2047_n \
 N_noxref_8_c_2048_n N_noxref_8_c_2051_n N_noxref_8_c_2061_n \
 N_noxref_8_c_2063_n N_noxref_8_c_2114_n N_noxref_8_c_2122_n \
 N_noxref_8_c_2068_n N_noxref_8_c_2032_n N_noxref_8_c_2125_n \
 N_noxref_8_c_2126_n N_noxref_8_c_2129_n N_noxref_8_c_2132_n \
 N_noxref_8_c_2078_n N_noxref_8_c_2134_n N_noxref_8_c_2103_n \
 N_noxref_8_c_2079_n N_noxref_8_c_2141_n N_noxref_8_c_2145_n \
 N_noxref_8_M11_noxref_g N_noxref_8_M34_noxref_g N_noxref_8_M35_noxref_g \
 N_noxref_8_c_2152_n N_noxref_8_c_2154_n N_noxref_8_c_2157_n \
 N_noxref_8_c_2197_p N_noxref_8_c_2181_p N_noxref_8_c_2159_n \
 N_noxref_8_c_2160_n N_noxref_8_c_2161_n N_noxref_8_c_2162_n \
 N_noxref_8_c_2165_n N_noxref_8_c_2166_n N_noxref_8_M7_noxref_d \
 N_noxref_8_M26_noxref_d )  PM_DLATCHN\%noxref_8
x_PM_DLATCHN\%noxref_9 ( N_noxref_9_c_2313_n N_noxref_9_c_2315_n \
 N_noxref_9_c_2368_n N_noxref_9_c_2377_n N_noxref_9_c_2384_n \
 N_noxref_9_c_2385_n N_noxref_9_c_2468_n N_noxref_9_c_2391_n \
 N_noxref_9_c_2478_n N_noxref_9_c_2479_n N_noxref_9_c_2393_n \
 N_noxref_9_c_2485_n N_noxref_9_c_2395_n N_noxref_9_c_2318_n \
 N_noxref_9_c_2321_n N_noxref_9_c_2324_n N_noxref_9_c_2325_n \
 N_noxref_9_c_2405_n N_noxref_9_c_2503_n N_noxref_9_c_2406_n \
 N_noxref_9_c_2327_n N_noxref_9_c_2510_n N_noxref_9_c_2329_n \
 N_noxref_9_c_2333_n N_noxref_9_c_2511_n N_noxref_9_M9_noxref_g \
 N_noxref_9_M30_noxref_g N_noxref_9_M31_noxref_g N_noxref_9_c_2340_n \
 N_noxref_9_c_2342_n N_noxref_9_c_2345_n N_noxref_9_c_2432_n \
 N_noxref_9_c_2435_n N_noxref_9_c_2347_n N_noxref_9_c_2348_n \
 N_noxref_9_c_2349_n N_noxref_9_c_2350_n N_noxref_9_c_2353_n \
 N_noxref_9_c_2354_n N_noxref_9_M10_noxref_d N_noxref_9_M11_noxref_d \
 N_noxref_9_M34_noxref_d )  PM_DLATCHN\%noxref_9
x_PM_DLATCHN\%VDD ( VDD N_VDD_c_2596_n N_VDD_c_2830_n N_VDD_c_2832_n \
 N_VDD_c_2866_n N_VDD_c_2868_n N_VDD_c_2870_n N_VDD_c_2925_n N_VDD_c_2692_n \
 N_VDD_c_2602_n N_VDD_c_2605_n N_VDD_c_2643_n N_VDD_c_2648_n N_VDD_c_2697_n \
 N_VDD_c_2734_n N_VDD_c_2788_n N_VDD_c_2837_n N_VDD_c_2874_n N_VDD_c_2700_n \
 N_VDD_c_2608_n N_VDD_c_2610_n N_VDD_c_2654_n N_VDD_c_2662_n N_VDD_c_2750_n \
 N_VDD_c_2802_n N_VDD_c_2851_n N_VDD_M12_noxref_s N_VDD_M13_noxref_d \
 N_VDD_M14_noxref_s N_VDD_M15_noxref_d N_VDD_M16_noxref_s N_VDD_M17_noxref_d \
 N_VDD_M19_noxref_d N_VDD_M20_noxref_s N_VDD_M21_noxref_d N_VDD_M22_noxref_s \
 N_VDD_M23_noxref_d N_VDD_M25_noxref_d N_VDD_M26_noxref_s N_VDD_M27_noxref_d \
 N_VDD_M28_noxref_d N_VDD_M32_noxref_d )  PM_DLATCHN\%VDD
x_PM_DLATCHN\%GATE_N ( GATE_N GATE_N GATE_N GATE_N GATE_N GATE_N \
 N_GATE_N_c_3045_n N_GATE_N_c_3046_n N_GATE_N_c_3047_n N_GATE_N_c_3048_n \
 N_GATE_N_M0_noxref_g N_GATE_N_M12_noxref_g N_GATE_N_M13_noxref_g \
 N_GATE_N_c_3055_n N_GATE_N_c_3057_n N_GATE_N_c_3060_n N_GATE_N_c_3061_n \
 N_GATE_N_c_3062_n N_GATE_N_c_3065_n N_GATE_N_c_3066_n N_GATE_N_c_3068_n \
 N_GATE_N_c_3072_n N_GATE_N_c_3074_n N_GATE_N_c_3077_n )  PM_DLATCHN\%GATE_N
x_PM_DLATCHN\%GND ( GND N_GND_c_3122_n N_GND_c_3166_n N_GND_c_3264_n \
 N_GND_c_3128_n N_GND_c_3138_n N_GND_c_3212_n N_GND_c_3222_n N_GND_c_3225_n \
 N_GND_c_3226_n N_GND_c_3141_n N_GND_c_3142_n N_GND_c_3532_p N_GND_c_3145_n \
 N_GND_c_3527_p N_GND_c_3178_n N_GND_c_3182_n N_GND_c_3560_p N_GND_c_3230_n \
 N_GND_c_3555_p N_GND_c_3303_n N_GND_c_3307_n N_GND_c_3342_n N_GND_c_3380_n \
 N_GND_c_3384_n N_GND_c_3420_n N_GND_c_3146_n N_GND_c_3232_n N_GND_c_3147_n \
 N_GND_c_3148_n N_GND_c_3185_n N_GND_c_3192_n N_GND_c_3279_n N_GND_c_3318_n \
 N_GND_c_3391_n N_GND_M0_noxref_s N_GND_M1_noxref_s N_GND_M2_noxref_d \
 N_GND_M4_noxref_s N_GND_M5_noxref_d N_GND_M7_noxref_s N_GND_M8_noxref_s \
 N_GND_M10_noxref_s )  PM_DLATCHN\%GND
x_PM_DLATCHN\%noxref_13 ( N_noxref_13_c_3566_n N_noxref_13_c_3585_n \
 N_noxref_13_c_3572_n N_noxref_13_c_3576_n N_noxref_13_c_3577_n \
 N_noxref_13_c_3592_n N_noxref_13_c_3578_n N_noxref_13_c_3582_n \
 N_noxref_13_M28_noxref_s N_noxref_13_M29_noxref_d N_noxref_13_M31_noxref_d )  \
 PM_DLATCHN\%noxref_13
x_PM_DLATCHN\%noxref_14 ( N_noxref_14_c_3659_n N_noxref_14_c_3681_n \
 N_noxref_14_c_3666_n N_noxref_14_c_3672_n N_noxref_14_c_3673_n \
 N_noxref_14_c_3693_n N_noxref_14_c_3674_n N_noxref_14_c_3678_n \
 N_noxref_14_M32_noxref_s N_noxref_14_M33_noxref_d N_noxref_14_M35_noxref_d )  \
 PM_DLATCHN\%noxref_14
x_PM_DLATCHN\%noxref_15 ( N_noxref_15_c_3750_n N_noxref_15_c_3751_n \
 N_noxref_15_c_3795_n N_noxref_15_c_3758_n N_noxref_15_c_3763_n \
 N_noxref_15_c_3804_n N_noxref_15_M2_noxref_s )  PM_DLATCHN\%noxref_15
x_PM_DLATCHN\%noxref_16 ( N_noxref_16_c_3817_n N_noxref_16_c_3819_n \
 N_noxref_16_c_3861_n N_noxref_16_c_3827_n N_noxref_16_c_3835_n \
 N_noxref_16_c_3870_n N_noxref_16_M5_noxref_s )  PM_DLATCHN\%noxref_16
cc_1 ( N_noxref_1_M17_noxref_g N_noxref_2_c_231_n ) capacitor c=0.00967396f \
 //x=6.38 //y=6.2 //x2=6.925 //y2=5.38
cc_2 ( N_noxref_1_c_2_p N_noxref_2_c_232_n ) capacitor c=0.00495291f //x=3.82 \
 //y=1.935 //x2=7.08 //y2=1.75
cc_3 ( N_noxref_1_c_3_p N_noxref_2_c_232_n ) capacitor c=4.16137e-19 //x=3.82 \
 //y=1.185 //x2=7.08 //y2=1.75
cc_4 ( N_noxref_1_c_4_p N_noxref_2_c_234_n ) capacitor c=0.00198687f //x=4.105 \
 //y=2.02 //x2=7.52 //y2=3.35
cc_5 ( N_noxref_1_c_5_p N_noxref_2_c_234_n ) capacitor c=0.00348124f //x=6.04 \
 //y=3.705 //x2=7.52 //y2=3.35
cc_6 ( N_noxref_1_c_6_p N_noxref_2_c_236_n ) capacitor c=6.68558e-19 //x=3.825 \
 //y=5.42 //x2=7.52 //y2=5.295
cc_7 ( N_noxref_1_c_7_p N_noxref_2_c_236_n ) capacitor c=0.00217431f //x=4.19 \
 //y=5.055 //x2=7.52 //y2=5.295
cc_8 ( N_noxref_1_c_8_p N_noxref_2_c_236_n ) capacitor c=0.00224784f //x=6.042 \
 //y=4.74 //x2=7.52 //y2=5.295
cc_9 ( N_noxref_1_c_6_p N_noxref_2_c_239_n ) capacitor c=6.16426e-19 //x=3.825 \
 //y=5.42 //x2=6.16 //y2=5.56
cc_10 ( N_noxref_1_c_10_p N_noxref_2_c_239_n ) capacitor c=7.15631e-19 \
 //x=6.04 //y=4.025 //x2=6.16 //y2=5.56
cc_11 ( N_noxref_1_c_11_p N_noxref_2_c_239_n ) capacitor c=0.0118019f //x=6.04 \
 //y=4.88 //x2=6.16 //y2=5.56
cc_12 ( N_noxref_1_c_12_p N_noxref_2_c_239_n ) capacitor c=0.00277154f \
 //x=6.04 //y=4.88 //x2=6.16 //y2=5.56
cc_13 ( N_noxref_1_M16_noxref_g N_noxref_2_c_239_n ) capacitor c=0.00203628f \
 //x=5.94 //y=6.2 //x2=6.16 //y2=5.56
cc_14 ( N_noxref_1_M17_noxref_g N_noxref_2_c_239_n ) capacitor c=0.00192712f \
 //x=6.38 //y=6.2 //x2=6.16 //y2=5.56
cc_15 ( N_noxref_1_c_15_p N_noxref_2_c_239_n ) capacitor c=0.00190205f \
 //x=6.04 //y=4.88 //x2=6.16 //y2=5.56
cc_16 ( N_noxref_1_c_3_p N_noxref_2_c_246_n ) capacitor c=6.80839e-19 //x=3.82 \
 //y=1.185 //x2=7.08 //y2=1.18
cc_17 ( N_noxref_1_c_10_p N_noxref_2_c_247_n ) capacitor c=2.05912e-19 \
 //x=6.04 //y=4.025 //x2=6.16 //y2=5.56
cc_18 ( N_noxref_1_c_11_p N_noxref_2_c_247_n ) capacitor c=0.00104426f \
 //x=6.04 //y=4.88 //x2=6.16 //y2=5.56
cc_19 ( N_noxref_1_c_12_p N_noxref_2_c_247_n ) capacitor c=0.00377369f \
 //x=6.04 //y=4.88 //x2=6.16 //y2=5.56
cc_20 ( N_noxref_1_M16_noxref_g N_noxref_2_c_247_n ) capacitor c=0.0158358f \
 //x=5.94 //y=6.2 //x2=6.16 //y2=5.56
cc_21 ( N_noxref_1_M17_noxref_g N_noxref_2_c_247_n ) capacitor c=0.0178987f \
 //x=6.38 //y=6.2 //x2=6.16 //y2=5.56
cc_22 ( N_noxref_1_c_15_p N_noxref_2_c_247_n ) capacitor c=0.0043218f //x=6.04 \
 //y=4.88 //x2=6.16 //y2=5.56
cc_23 ( N_noxref_1_c_2_p N_noxref_3_c_490_n ) capacitor c=0.00735936f //x=3.82 \
 //y=1.935 //x2=1.6 //y2=1.935
cc_24 ( N_noxref_1_c_6_p N_noxref_3_c_491_n ) capacitor c=0.00207307f \
 //x=3.825 //y=5.42 //x2=1.605 //y2=5.42
cc_25 ( N_noxref_1_c_25_p N_noxref_3_c_492_n ) capacitor c=0.00350547f \
 //x=3.905 //y=2.02 //x2=1.885 //y2=2.02
cc_26 ( N_noxref_1_c_26_p N_noxref_3_c_493_n ) capacitor c=0.00349209f \
 //x=3.91 //y=5.14 //x2=1.885 //y2=5.14
cc_27 ( N_noxref_1_c_27_p N_noxref_3_c_494_n ) capacitor c=0.00299284f \
 //x=4.19 //y=3.705 //x2=1.97 //y2=2.985
cc_28 ( N_noxref_1_c_27_p N_noxref_3_c_495_n ) capacitor c=4.4547e-19 //x=4.19 \
 //y=3.705 //x2=1.97 //y2=5.055
cc_29 ( N_noxref_1_c_7_p N_noxref_3_c_495_n ) capacitor c=0.0024808f //x=4.19 \
 //y=5.055 //x2=1.97 //y2=5.055
cc_30 ( N_noxref_1_c_27_p N_noxref_3_c_497_n ) capacitor c=0.00175965f \
 //x=4.19 //y=3.705 //x2=6.78 //y2=2.975
cc_31 ( N_noxref_1_c_5_p N_noxref_3_c_497_n ) capacitor c=0.0250104f //x=6.04 \
 //y=3.705 //x2=6.78 //y2=2.975
cc_32 ( N_noxref_1_c_32_p N_noxref_3_c_497_n ) capacitor c=3.49899e-19 \
 //x=6.04 //y=2.26 //x2=6.78 //y2=2.975
cc_33 ( N_noxref_1_c_5_p N_noxref_3_c_500_n ) capacitor c=0.0146245f //x=6.04 \
 //y=3.705 //x2=6.78 //y2=3.295
cc_34 ( N_noxref_1_c_27_p N_noxref_3_c_501_n ) capacitor c=6.9664e-19 //x=4.19 \
 //y=3.705 //x2=6.78 //y2=4.735
cc_35 ( N_noxref_1_c_7_p N_noxref_3_c_501_n ) capacitor c=0.00192226f //x=4.19 \
 //y=5.055 //x2=6.78 //y2=4.735
cc_36 ( N_noxref_1_c_5_p N_noxref_3_c_501_n ) capacitor c=0.0180837f //x=6.04 \
 //y=3.705 //x2=6.78 //y2=4.735
cc_37 ( N_noxref_1_c_10_p N_noxref_3_c_501_n ) capacitor c=0.014957f //x=6.04 \
 //y=4.025 //x2=6.78 //y2=4.735
cc_38 ( N_noxref_1_c_38_p N_noxref_3_c_501_n ) capacitor c=7.6985e-19 //x=6.04 \
 //y=3.88 //x2=6.78 //y2=4.735
cc_39 ( N_noxref_1_c_11_p N_noxref_3_c_501_n ) capacitor c=0.0172958f //x=6.04 \
 //y=4.88 //x2=6.78 //y2=4.735
cc_40 ( N_noxref_1_c_8_p N_noxref_3_c_501_n ) capacitor c=0.0285269f //x=6.042 \
 //y=4.74 //x2=6.78 //y2=4.735
cc_41 ( N_noxref_1_c_41_p N_noxref_3_c_501_n ) capacitor c=0.00693433f \
 //x=6.035 //y=3.865 //x2=6.78 //y2=4.735
cc_42 ( N_noxref_1_c_12_p N_noxref_3_c_501_n ) capacitor c=7.76143e-19 \
 //x=6.04 //y=4.88 //x2=6.78 //y2=4.735
cc_43 ( N_noxref_1_c_15_p N_noxref_3_c_501_n ) capacitor c=0.00201171f \
 //x=6.04 //y=4.88 //x2=6.78 //y2=4.735
cc_44 ( N_noxref_1_c_3_p N_noxref_3_c_511_n ) capacitor c=0.00707218f //x=3.82 \
 //y=1.185 //x2=1.6 //y2=1.185
cc_45 ( N_noxref_1_c_45_p N_noxref_3_c_512_n ) capacitor c=0.0205342f //x=6.04 \
 //y=2.26 //x2=6.78 //y2=2.26
cc_46 ( N_noxref_1_c_32_p N_noxref_3_c_512_n ) capacitor c=5.16867e-19 \
 //x=6.04 //y=2.26 //x2=6.78 //y2=2.26
cc_47 ( N_noxref_1_c_47_p N_noxref_3_c_512_n ) capacitor c=0.00167888f \
 //x=5.845 //y=2.095 //x2=6.78 //y2=2.26
cc_48 ( N_noxref_1_c_5_p N_noxref_3_c_515_n ) capacitor c=6.89957e-19 //x=6.04 \
 //y=3.705 //x2=6.78 //y2=3.14
cc_49 ( N_noxref_1_c_25_p N_noxref_3_c_516_n ) capacitor c=0.00971104f \
 //x=3.905 //y=2.02 //x2=6.62 //y2=3.14
cc_50 ( N_noxref_1_c_27_p N_noxref_3_c_516_n ) capacitor c=0.0317062f //x=4.19 \
 //y=3.705 //x2=6.62 //y2=3.14
cc_51 ( N_noxref_1_c_51_p N_noxref_3_c_516_n ) capacitor c=0.00417387f \
 //x=4.19 //y=4.025 //x2=6.62 //y2=3.14
cc_52 ( N_noxref_1_c_5_p N_noxref_3_c_516_n ) capacitor c=0.0294305f //x=6.04 \
 //y=3.705 //x2=6.62 //y2=3.14
cc_53 ( N_noxref_1_c_10_p N_noxref_3_c_516_n ) capacitor c=0.00352419f \
 //x=6.04 //y=4.025 //x2=6.62 //y2=3.14
cc_54 ( N_noxref_1_c_3_p N_noxref_3_c_516_n ) capacitor c=5.48008e-19 //x=3.82 \
 //y=1.185 //x2=6.62 //y2=3.14
cc_55 ( N_noxref_1_c_45_p N_noxref_3_c_516_n ) capacitor c=0.00270352f \
 //x=6.04 //y=2.26 //x2=6.62 //y2=3.14
cc_56 ( N_noxref_1_c_56_p N_noxref_3_c_516_n ) capacitor c=0.0162295f \
 //x=4.345 //y=3.865 //x2=6.62 //y2=3.14
cc_57 ( N_noxref_1_c_41_p N_noxref_3_c_516_n ) capacitor c=0.0162295f \
 //x=6.035 //y=3.865 //x2=6.62 //y2=3.14
cc_58 ( N_noxref_1_c_58_p N_noxref_3_c_516_n ) capacitor c=0.0705351f \
 //x=5.875 //y=3.865 //x2=6.62 //y2=3.14
cc_59 ( N_noxref_1_c_5_p N_noxref_3_c_526_n ) capacitor c=0.0032735f //x=6.04 \
 //y=3.705 //x2=7.305 //y2=3.125
cc_60 ( N_noxref_1_c_5_p N_noxref_3_c_527_n ) capacitor c=3.49899e-19 //x=6.04 \
 //y=3.705 //x2=6.78 //y2=2.26
cc_61 ( N_noxref_1_c_45_p N_noxref_3_c_527_n ) capacitor c=5.24723e-19 \
 //x=6.04 //y=2.26 //x2=6.78 //y2=2.26
cc_62 ( N_noxref_1_c_32_p N_noxref_3_c_527_n ) capacitor c=0.00485709f \
 //x=6.04 //y=2.26 //x2=6.78 //y2=2.26
cc_63 ( N_noxref_1_c_47_p N_noxref_3_c_527_n ) capacitor c=0.00190888f \
 //x=5.845 //y=2.095 //x2=6.78 //y2=2.26
cc_64 ( N_noxref_1_c_11_p N_noxref_3_c_531_n ) capacitor c=4.80626e-19 \
 //x=6.04 //y=4.88 //x2=6.81 //y2=4.88
cc_65 ( N_noxref_1_c_12_p N_noxref_3_c_531_n ) capacitor c=0.00397338f \
 //x=6.04 //y=4.88 //x2=6.81 //y2=4.88
cc_66 ( N_noxref_1_c_15_p N_noxref_3_c_531_n ) capacitor c=0.00283894f \
 //x=6.04 //y=4.88 //x2=6.81 //y2=4.88
cc_67 ( N_noxref_1_M16_noxref_g N_noxref_3_M18_noxref_g ) capacitor \
 c=0.0104892f //x=5.94 //y=6.2 //x2=6.82 //y2=6.2
cc_68 ( N_noxref_1_M17_noxref_g N_noxref_3_M18_noxref_g ) capacitor \
 c=0.107636f //x=6.38 //y=6.2 //x2=6.82 //y2=6.2
cc_69 ( N_noxref_1_M17_noxref_g N_noxref_3_M19_noxref_g ) capacitor \
 c=0.0100341f //x=6.38 //y=6.2 //x2=7.26 //y2=6.2
cc_70 ( N_noxref_1_c_70_p N_noxref_3_c_537_n ) capacitor c=4.86545e-19 \
 //x=5.845 //y=1.045 //x2=6.815 //y2=1.085
cc_71 ( N_noxref_1_c_71_p N_noxref_3_c_537_n ) capacitor c=0.00152405f \
 //x=5.845 //y=1.39 //x2=6.815 //y2=1.085
cc_72 ( N_noxref_1_c_72_p N_noxref_3_c_537_n ) capacitor c=0.0151475f \
 //x=6.375 //y=1.045 //x2=6.815 //y2=1.085
cc_73 ( N_noxref_1_c_73_p N_noxref_3_c_540_n ) capacitor c=0.00109982f \
 //x=5.845 //y=1.7 //x2=6.815 //y2=1.43
cc_74 ( N_noxref_1_c_74_p N_noxref_3_c_540_n ) capacitor c=0.0111064f \
 //x=6.375 //y=1.39 //x2=6.815 //y2=1.43
cc_75 ( N_noxref_1_c_73_p N_noxref_3_c_542_n ) capacitor c=9.58243e-19 \
 //x=5.845 //y=1.7 //x2=6.815 //y2=1.74
cc_76 ( N_noxref_1_c_47_p N_noxref_3_c_542_n ) capacitor c=0.00662747f \
 //x=5.845 //y=2.095 //x2=6.815 //y2=1.74
cc_77 ( N_noxref_1_c_74_p N_noxref_3_c_542_n ) capacitor c=0.00862358f \
 //x=6.375 //y=1.39 //x2=6.815 //y2=1.74
cc_78 ( N_noxref_1_c_72_p N_noxref_3_c_545_n ) capacitor c=0.00127211f \
 //x=6.375 //y=1.045 //x2=7.345 //y2=1.085
cc_79 ( N_noxref_1_c_74_p N_noxref_3_c_546_n ) capacitor c=0.00204774f \
 //x=6.375 //y=1.39 //x2=7.345 //y2=1.43
cc_80 ( N_noxref_1_c_45_p N_noxref_3_c_547_n ) capacitor c=0.00167305f \
 //x=6.04 //y=2.26 //x2=6.78 //y2=2.26
cc_81 ( N_noxref_1_c_32_p N_noxref_3_c_547_n ) capacitor c=0.00266443f \
 //x=6.04 //y=2.26 //x2=6.78 //y2=2.26
cc_82 ( N_noxref_1_c_47_p N_noxref_3_c_547_n ) capacitor c=0.0181449f \
 //x=5.845 //y=2.095 //x2=6.78 //y2=2.26
cc_83 ( N_noxref_1_c_11_p N_noxref_3_c_550_n ) capacitor c=0.00158715f \
 //x=6.04 //y=4.88 //x2=6.81 //y2=4.88
cc_84 ( N_noxref_1_c_12_p N_noxref_3_c_550_n ) capacitor c=0.00237977f \
 //x=6.04 //y=4.88 //x2=6.81 //y2=4.88
cc_85 ( N_noxref_1_c_15_p N_noxref_3_c_550_n ) capacitor c=0.0297875f //x=6.04 \
 //y=4.88 //x2=6.81 //y2=4.88
cc_86 ( N_noxref_1_c_27_p D ) capacitor c=0.0541267f //x=4.19 //y=3.705 \
 //x2=3.45 //y2=2.77
cc_87 ( N_noxref_1_c_51_p D ) capacitor c=0.015283f //x=4.19 //y=4.025 \
 //x2=3.45 //y2=2.77
cc_88 ( N_noxref_1_c_7_p D ) capacitor c=0.0028341f //x=4.19 //y=5.055 \
 //x2=3.45 //y2=2.77
cc_89 ( N_noxref_1_c_5_p D ) capacitor c=0.00255019f //x=6.04 //y=3.705 \
 //x2=3.45 //y2=2.77
cc_90 ( N_noxref_1_c_90_p D ) capacitor c=7.6985e-19 //x=4.19 //y=3.88 \
 //x2=3.45 //y2=2.77
cc_91 ( N_noxref_1_c_56_p D ) capacitor c=0.00700421f //x=4.345 //y=3.865 \
 //x2=3.45 //y2=2.77
cc_92 ( N_noxref_1_c_7_p D ) capacitor c=0.0143307f //x=4.19 //y=5.055 \
 //x2=3.45 //y2=4.62
cc_93 ( N_noxref_1_c_8_p D ) capacitor c=0.00104522f //x=6.042 //y=4.74 \
 //x2=3.45 //y2=4.62
cc_94 ( N_noxref_1_c_7_p D ) capacitor c=6.15063e-19 //x=4.19 //y=5.055 \
 //x2=3.45 //y2=4.25
cc_95 ( N_noxref_1_c_7_p N_D_c_895_n ) capacitor c=0.0173413f //x=4.19 \
 //y=5.055 //x2=3.45 //y2=4.41
cc_96 ( N_noxref_1_c_7_p N_D_c_896_n ) capacitor c=0.016613f //x=4.19 \
 //y=5.055 //x2=3.45 //y2=4.76
cc_97 ( N_noxref_1_c_27_p N_D_c_897_n ) capacitor c=0.017436f //x=4.19 \
 //y=3.705 //x2=3.45 //y2=2.265
cc_98 ( N_noxref_1_c_7_p N_D_c_898_n ) capacitor c=0.0032735f //x=4.19 \
 //y=5.055 //x2=3.61 //y2=4.25
cc_99 ( N_noxref_1_c_6_p N_D_c_899_n ) capacitor c=6.95554e-19 //x=3.825 \
 //y=5.42 //x2=12.165 //y2=4.265
cc_100 ( N_noxref_1_c_26_p N_D_c_899_n ) capacitor c=0.0122741f //x=3.91 \
 //y=5.14 //x2=12.165 //y2=4.265
cc_101 ( N_noxref_1_c_51_p N_D_c_899_n ) capacitor c=0.00677539f //x=4.19 \
 //y=4.025 //x2=12.165 //y2=4.265
cc_102 ( N_noxref_1_c_7_p N_D_c_899_n ) capacitor c=0.0265003f //x=4.19 \
 //y=5.055 //x2=12.165 //y2=4.265
cc_103 ( N_noxref_1_c_10_p N_D_c_899_n ) capacitor c=0.0069615f //x=6.04 \
 //y=4.025 //x2=12.165 //y2=4.265
cc_104 ( N_noxref_1_c_11_p N_D_c_899_n ) capacitor c=0.00240472f //x=6.04 \
 //y=4.88 //x2=12.165 //y2=4.265
cc_105 ( N_noxref_1_c_8_p N_D_c_899_n ) capacitor c=0.0267501f //x=6.042 \
 //y=4.74 //x2=12.165 //y2=4.265
cc_106 ( N_noxref_1_c_56_p N_D_c_899_n ) capacitor c=0.0365231f //x=4.345 \
 //y=3.865 //x2=12.165 //y2=4.265
cc_107 ( N_noxref_1_c_41_p N_D_c_899_n ) capacitor c=0.0365231f //x=6.035 \
 //y=3.865 //x2=12.165 //y2=4.265
cc_108 ( N_noxref_1_c_58_p N_D_c_899_n ) capacitor c=0.13968f //x=5.875 \
 //y=3.865 //x2=12.165 //y2=4.265
cc_109 ( N_noxref_1_c_27_p N_D_c_909_n ) capacitor c=4.71798e-19 //x=4.19 \
 //y=3.705 //x2=3.45 //y2=2.265
cc_110 ( N_noxref_1_c_7_p N_D_c_910_n ) capacitor c=0.00160039f //x=4.19 \
 //y=5.055 //x2=3.45 //y2=4.88
cc_111 ( N_noxref_1_c_6_p N_D_M14_noxref_g ) capacitor c=0.00141266f //x=3.825 \
 //y=5.42 //x2=3.605 //y2=6.2
cc_112 ( N_noxref_1_c_26_p N_D_M14_noxref_g ) capacitor c=0.00439203f //x=3.91 \
 //y=5.14 //x2=3.605 //y2=6.2
cc_113 ( N_noxref_1_c_113_p N_D_M14_noxref_g ) capacitor c=0.0162066f \
 //x=3.825 //y=5.56 //x2=3.605 //y2=6.2
cc_114 ( N_noxref_1_c_6_p N_D_M15_noxref_g ) capacitor c=0.0035262f //x=3.825 \
 //y=5.42 //x2=4.045 //y2=6.2
cc_115 ( N_noxref_1_c_115_p N_D_M15_noxref_g ) capacitor c=0.00931174f \
 //x=4.105 //y=5.14 //x2=4.045 //y2=6.2
cc_116 ( N_noxref_1_c_113_p N_D_M15_noxref_g ) capacitor c=0.0162066f \
 //x=3.825 //y=5.56 //x2=4.045 //y2=6.2
cc_117 ( N_noxref_1_c_3_p N_D_c_917_n ) capacitor c=0.00174488f //x=3.82 \
 //y=1.185 //x2=3.56 //y2=1.09
cc_118 ( N_noxref_1_M1_noxref_d N_D_c_917_n ) capacitor c=0.00137914f \
 //x=3.635 //y=1.09 //x2=3.56 //y2=1.09
cc_119 ( N_noxref_1_c_2_p N_D_c_919_n ) capacitor c=0.00107851f //x=3.82 \
 //y=1.935 //x2=3.56 //y2=1.435
cc_120 ( N_noxref_1_c_3_p N_D_c_919_n ) capacitor c=0.00350474f //x=3.82 \
 //y=1.185 //x2=3.56 //y2=1.435
cc_121 ( N_noxref_1_M1_noxref_d N_D_c_919_n ) capacitor c=0.0023891f //x=3.635 \
 //y=1.09 //x2=3.56 //y2=1.435
cc_122 ( N_noxref_1_c_2_p N_D_c_922_n ) capacitor c=0.00522452f //x=3.82 \
 //y=1.935 //x2=3.56 //y2=1.745
cc_123 ( N_noxref_1_c_2_p N_D_c_923_n ) capacitor c=0.00384134f //x=3.82 \
 //y=1.935 //x2=3.56 //y2=2.1
cc_124 ( N_noxref_1_c_26_p N_D_c_924_n ) capacitor c=0.00262283f //x=3.91 \
 //y=5.14 //x2=3.97 //y2=4.97
cc_125 ( N_noxref_1_c_51_p N_D_c_924_n ) capacitor c=0.00128366f //x=4.19 \
 //y=4.025 //x2=3.97 //y2=4.97
cc_126 ( N_noxref_1_c_7_p N_D_c_924_n ) capacitor c=0.00208891f //x=4.19 \
 //y=5.055 //x2=3.97 //y2=4.97
cc_127 ( N_noxref_1_c_113_p N_D_c_924_n ) capacitor c=0.00290963f //x=3.825 \
 //y=5.56 //x2=3.97 //y2=4.97
cc_128 ( N_noxref_1_c_7_p N_D_c_928_n ) capacitor c=0.00140024f //x=4.19 \
 //y=5.055 //x2=3.68 //y2=4.97
cc_129 ( N_noxref_1_c_3_p N_D_c_929_n ) capacitor c=5.57924e-19 //x=3.82 \
 //y=1.185 //x2=3.935 //y2=0.935
cc_130 ( N_noxref_1_M1_noxref_d N_D_c_929_n ) capacitor c=0.0020782f //x=3.635 \
 //y=1.09 //x2=3.935 //y2=0.935
cc_131 ( N_noxref_1_c_2_p N_D_c_931_n ) capacitor c=0.00918878f //x=3.82 \
 //y=1.935 //x2=3.935 //y2=1.59
cc_132 ( N_noxref_1_c_4_p N_D_c_931_n ) capacitor c=0.00180253f //x=4.105 \
 //y=2.02 //x2=3.935 //y2=1.59
cc_133 ( N_noxref_1_c_3_p N_D_c_931_n ) capacitor c=5.75878e-19 //x=3.82 \
 //y=1.185 //x2=3.935 //y2=1.59
cc_134 ( N_noxref_1_M1_noxref_d N_D_c_931_n ) capacitor c=0.00356097f \
 //x=3.635 //y=1.09 //x2=3.935 //y2=1.59
cc_135 ( N_noxref_1_c_3_p N_D_c_935_n ) capacitor c=0.00148146f //x=3.82 \
 //y=1.185 //x2=4.09 //y2=1.09
cc_136 ( N_noxref_1_M1_noxref_d N_D_c_935_n ) capacitor c=0.00138452f \
 //x=3.635 //y=1.09 //x2=4.09 //y2=1.09
cc_137 ( N_noxref_1_c_2_p N_D_c_937_n ) capacitor c=0.00344663f //x=3.82 \
 //y=1.935 //x2=4.09 //y2=1.435
cc_138 ( N_noxref_1_c_3_p N_D_c_937_n ) capacitor c=0.00356478f //x=3.82 \
 //y=1.185 //x2=4.09 //y2=1.435
cc_139 ( N_noxref_1_M1_noxref_d N_D_c_937_n ) capacitor c=0.00235934f \
 //x=3.635 //y=1.09 //x2=4.09 //y2=1.435
cc_140 ( N_noxref_1_c_25_p N_D_c_940_n ) capacitor c=0.00384134f //x=3.905 \
 //y=2.02 //x2=3.45 //y2=2.265
cc_141 ( N_noxref_1_c_27_p N_D_c_940_n ) capacitor c=0.00270592f //x=4.19 \
 //y=3.705 //x2=3.45 //y2=2.265
cc_142 ( N_noxref_1_c_6_p N_VDD_c_2596_n ) capacitor c=0.00259718f //x=3.825 \
 //y=5.42 //x2=17.175 //y2=7.585
cc_143 ( N_noxref_1_c_115_p N_VDD_c_2596_n ) capacitor c=0.00266633f //x=4.105 \
 //y=5.14 //x2=17.175 //y2=7.585
cc_144 ( N_noxref_1_c_10_p N_VDD_c_2596_n ) capacitor c=2.11935e-19 //x=6.04 \
 //y=4.025 //x2=17.175 //y2=7.585
cc_145 ( N_noxref_1_c_11_p N_VDD_c_2596_n ) capacitor c=9.07241e-19 //x=6.04 \
 //y=4.88 //x2=17.175 //y2=7.585
cc_146 ( N_noxref_1_c_113_p N_VDD_c_2596_n ) capacitor c=0.00241566f //x=3.825 \
 //y=5.56 //x2=17.175 //y2=7.585
cc_147 ( N_noxref_1_c_12_p N_VDD_c_2596_n ) capacitor c=6.22888e-19 //x=6.04 \
 //y=4.88 //x2=17.175 //y2=7.585
cc_148 ( N_noxref_1_c_6_p N_VDD_c_2602_n ) capacitor c=8.96756e-19 //x=3.825 \
 //y=5.42 //x2=4.18 //y2=7.585
cc_149 ( N_noxref_1_c_115_p N_VDD_c_2602_n ) capacitor c=0.00197507f //x=4.105 \
 //y=5.14 //x2=4.18 //y2=7.585
cc_150 ( N_noxref_1_c_113_p N_VDD_c_2602_n ) capacitor c=0.0138017f //x=3.825 \
 //y=5.56 //x2=4.18 //y2=7.585
cc_151 ( N_noxref_1_c_11_p N_VDD_c_2605_n ) capacitor c=6.28113e-19 //x=6.04 \
 //y=4.88 //x2=6.515 //y2=7.585
cc_152 ( N_noxref_1_M16_noxref_g N_VDD_c_2605_n ) capacitor c=0.00732618f \
 //x=5.94 //y=6.2 //x2=6.515 //y2=7.585
cc_153 ( N_noxref_1_M17_noxref_g N_VDD_c_2605_n ) capacitor c=0.00755544f \
 //x=6.38 //y=6.2 //x2=6.515 //y2=7.585
cc_154 ( N_noxref_1_c_26_p N_VDD_c_2608_n ) capacitor c=0.0049725f //x=3.91 \
 //y=5.14 //x2=2.71 //y2=7.585
cc_155 ( N_noxref_1_c_113_p N_VDD_c_2608_n ) capacitor c=0.00823309f //x=3.825 \
 //y=5.56 //x2=2.71 //y2=7.585
cc_156 ( N_noxref_1_c_6_p N_VDD_c_2610_n ) capacitor c=0.00231872f //x=3.825 \
 //y=5.42 //x2=4.93 //y2=7.585
cc_157 ( N_noxref_1_c_7_p N_VDD_c_2610_n ) capacitor c=0.0218471f //x=4.19 \
 //y=5.055 //x2=4.93 //y2=7.585
cc_158 ( N_noxref_1_c_11_p N_VDD_c_2610_n ) capacitor c=0.00447349f //x=6.04 \
 //y=4.88 //x2=4.93 //y2=7.585
cc_159 ( N_noxref_1_c_8_p N_VDD_c_2610_n ) capacitor c=0.00704389f //x=6.042 \
 //y=4.74 //x2=4.93 //y2=7.585
cc_160 ( N_noxref_1_c_113_p N_VDD_c_2610_n ) capacitor c=0.00824867f //x=3.825 \
 //y=5.56 //x2=4.93 //y2=7.585
cc_161 ( N_noxref_1_c_12_p N_VDD_c_2610_n ) capacitor c=0.00370494f //x=6.04 \
 //y=4.88 //x2=4.93 //y2=7.585
cc_162 ( N_noxref_1_c_15_p N_VDD_c_2610_n ) capacitor c=0.0121704f //x=6.04 \
 //y=4.88 //x2=4.93 //y2=7.585
cc_163 ( N_noxref_1_c_6_p N_VDD_M13_noxref_d ) capacitor c=9.53785e-19 \
 //x=3.825 //y=5.42 //x2=1.9 //y2=5.2
cc_164 ( N_noxref_1_c_6_p N_VDD_M14_noxref_s ) capacitor c=0.0465566f \
 //x=3.825 //y=5.42 //x2=3.25 //y2=5.2
cc_165 ( N_noxref_1_c_113_p N_VDD_M14_noxref_s ) capacitor c=0.0900574f \
 //x=3.825 //y=5.56 //x2=3.25 //y2=5.2
cc_166 ( N_noxref_1_c_6_p N_VDD_M15_noxref_d ) capacitor c=0.0474638f \
 //x=3.825 //y=5.42 //x2=4.12 //y2=5.2
cc_167 ( N_noxref_1_c_115_p N_VDD_M15_noxref_d ) capacitor c=0.0210992f \
 //x=4.105 //y=5.14 //x2=4.12 //y2=5.2
cc_168 ( N_noxref_1_c_51_p N_VDD_M15_noxref_d ) capacitor c=0.00305765f \
 //x=4.19 //y=4.025 //x2=4.12 //y2=5.2
cc_169 ( N_noxref_1_c_90_p N_VDD_M15_noxref_d ) capacitor c=5.54681e-19 \
 //x=4.19 //y=3.88 //x2=4.12 //y2=5.2
cc_170 ( N_noxref_1_c_113_p N_VDD_M15_noxref_d ) capacitor c=0.0907631f \
 //x=3.825 //y=5.56 //x2=4.12 //y2=5.2
cc_171 ( N_noxref_1_c_6_p N_VDD_M16_noxref_s ) capacitor c=0.00151378f \
 //x=3.825 //y=5.42 //x2=5.585 //y2=5.2
cc_172 ( N_noxref_1_c_10_p N_VDD_M16_noxref_s ) capacitor c=0.00144564f \
 //x=6.04 //y=4.025 //x2=5.585 //y2=5.2
cc_173 ( N_noxref_1_M16_noxref_g N_VDD_M16_noxref_s ) capacitor c=0.0567929f \
 //x=5.94 //y=6.2 //x2=5.585 //y2=5.2
cc_174 ( N_noxref_1_M17_noxref_g N_VDD_M17_noxref_d ) capacitor c=0.015318f \
 //x=6.38 //y=6.2 //x2=6.455 //y2=5.2
cc_175 ( N_noxref_1_c_4_p N_GND_c_3122_n ) capacitor c=0.00499609f //x=4.105 \
 //y=2.02 //x2=6.025 //y2=0.175
cc_176 ( N_noxref_1_c_51_p N_GND_c_3122_n ) capacitor c=4.77708e-19 //x=4.19 \
 //y=4.025 //x2=6.025 //y2=0.175
cc_177 ( N_noxref_1_c_10_p N_GND_c_3122_n ) capacitor c=3.17498e-19 //x=6.04 \
 //y=4.025 //x2=6.025 //y2=0.175
cc_178 ( N_noxref_1_c_3_p N_GND_c_3122_n ) capacitor c=0.0101446f //x=3.82 \
 //y=1.185 //x2=6.025 //y2=0.175
cc_179 ( N_noxref_1_c_45_p N_GND_c_3122_n ) capacitor c=6.6172e-19 //x=6.04 \
 //y=2.26 //x2=6.025 //y2=0.175
cc_180 ( N_noxref_1_M1_noxref_d N_GND_c_3122_n ) capacitor c=0.00119455f \
 //x=3.635 //y=1.09 //x2=6.025 //y2=0.175
cc_181 ( N_noxref_1_c_3_p N_GND_c_3128_n ) capacitor c=0.00522864f //x=3.82 \
 //y=1.185 //x2=6.11 //y2=1.135
cc_182 ( N_noxref_1_c_45_p N_GND_c_3128_n ) capacitor c=0.00681392f //x=6.04 \
 //y=2.26 //x2=6.11 //y2=1.135
cc_183 ( N_noxref_1_c_32_p N_GND_c_3128_n ) capacitor c=2.13705e-19 //x=6.04 \
 //y=2.26 //x2=6.11 //y2=1.135
cc_184 ( N_noxref_1_c_70_p N_GND_c_3128_n ) capacitor c=0.00154831f //x=5.845 \
 //y=1.045 //x2=6.11 //y2=1.135
cc_185 ( N_noxref_1_c_71_p N_GND_c_3128_n ) capacitor c=0.00354198f //x=5.845 \
 //y=1.39 //x2=6.11 //y2=1.135
cc_186 ( N_noxref_1_c_73_p N_GND_c_3128_n ) capacitor c=4.2764e-19 //x=5.845 \
 //y=1.7 //x2=6.11 //y2=1.135
cc_187 ( N_noxref_1_c_187_p N_GND_c_3128_n ) capacitor c=7.35788e-19 //x=6.22 \
 //y=0.89 //x2=6.11 //y2=1.135
cc_188 ( N_noxref_1_c_188_p N_GND_c_3128_n ) capacitor c=6.38426e-19 //x=6.22 \
 //y=1.545 //x2=6.11 //y2=1.135
cc_189 ( N_noxref_1_c_72_p N_GND_c_3128_n ) capacitor c=0.00174905f //x=6.375 \
 //y=1.045 //x2=6.11 //y2=1.135
cc_190 ( N_noxref_1_c_74_p N_GND_c_3128_n ) capacitor c=0.00296337f //x=6.375 \
 //y=1.39 //x2=6.11 //y2=1.135
cc_191 ( N_noxref_1_c_70_p N_GND_c_3138_n ) capacitor c=3.51399e-19 //x=5.845 \
 //y=1.045 //x2=6.107 //y2=1.005
cc_192 ( N_noxref_1_c_187_p N_GND_c_3138_n ) capacitor c=0.00864609f //x=6.22 \
 //y=0.89 //x2=6.107 //y2=1.005
cc_193 ( N_noxref_1_c_72_p N_GND_c_3138_n ) capacitor c=4.45447e-19 //x=6.375 \
 //y=1.045 //x2=6.107 //y2=1.005
cc_194 ( N_noxref_1_c_3_p N_GND_c_3141_n ) capacitor c=0.00124813f //x=3.82 \
 //y=1.185 //x2=3.735 //y2=0.715
cc_195 ( N_noxref_1_c_4_p N_GND_c_3142_n ) capacitor c=0.00320203f //x=4.105 \
 //y=2.02 //x2=4.225 //y2=0.715
cc_196 ( N_noxref_1_c_3_p N_GND_c_3142_n ) capacitor c=0.00130539f //x=3.82 \
 //y=1.185 //x2=4.225 //y2=0.715
cc_197 ( N_noxref_1_c_90_p N_GND_c_3142_n ) capacitor c=2.41704e-19 //x=4.19 \
 //y=3.88 //x2=4.225 //y2=0.715
cc_198 ( N_noxref_1_c_70_p N_GND_c_3145_n ) capacitor c=0.00690758f //x=5.845 \
 //y=1.045 //x2=8.09 //y2=0.175
cc_199 ( N_noxref_1_c_3_p N_GND_c_3146_n ) capacitor c=2.8029e-19 //x=3.82 \
 //y=1.185 //x2=22.32 //y2=0.18
cc_200 ( N_noxref_1_c_2_p N_GND_c_3147_n ) capacitor c=0.00291377f //x=3.82 \
 //y=1.935 //x2=2.71 //y2=0.175
cc_201 ( N_noxref_1_c_4_p N_GND_c_3148_n ) capacitor c=0.0230294f //x=4.105 \
 //y=2.02 //x2=4.93 //y2=0.175
cc_202 ( N_noxref_1_c_5_p N_GND_c_3148_n ) capacitor c=0.00829739f //x=6.04 \
 //y=3.705 //x2=4.93 //y2=0.175
cc_203 ( N_noxref_1_c_45_p N_GND_c_3148_n ) capacitor c=0.00427323f //x=6.04 \
 //y=2.26 //x2=4.93 //y2=0.175
cc_204 ( N_noxref_1_c_32_p N_GND_c_3148_n ) capacitor c=0.00369427f //x=6.04 \
 //y=2.26 //x2=4.93 //y2=0.175
cc_205 ( N_noxref_1_c_47_p N_GND_c_3148_n ) capacitor c=0.00932032f //x=5.845 \
 //y=2.095 //x2=4.93 //y2=0.175
cc_206 ( N_noxref_1_c_2_p N_GND_M1_noxref_s ) capacitor c=0.0300549f //x=3.82 \
 //y=1.935 //x2=3.205 //y2=0.55
cc_207 ( N_noxref_1_c_4_p N_GND_M1_noxref_s ) capacitor c=0.00407415f \
 //x=4.105 //y=2.02 //x2=3.205 //y2=0.55
cc_208 ( N_noxref_1_c_51_p N_GND_M1_noxref_s ) capacitor c=0.00105912f \
 //x=4.19 //y=4.025 //x2=3.205 //y2=0.55
cc_209 ( N_noxref_1_c_3_p N_GND_M1_noxref_s ) capacitor c=0.013981f //x=3.82 \
 //y=1.185 //x2=3.205 //y2=0.55
cc_210 ( N_noxref_1_c_90_p N_GND_M1_noxref_s ) capacitor c=5.90702e-19 \
 //x=4.19 //y=3.88 //x2=3.205 //y2=0.55
cc_211 ( N_noxref_1_M1_noxref_d N_GND_M1_noxref_s ) capacitor c=0.0377642f \
 //x=3.635 //y=1.09 //x2=3.205 //y2=0.55
cc_212 ( N_noxref_1_c_45_p N_GND_M2_noxref_d ) capacitor c=2.20438e-19 \
 //x=6.04 //y=2.26 //x2=5.92 //y2=1.045
cc_213 ( N_noxref_1_c_70_p N_GND_M2_noxref_d ) capacitor c=0.00192399f \
 //x=5.845 //y=1.045 //x2=5.92 //y2=1.045
cc_214 ( N_noxref_1_c_71_p N_GND_M2_noxref_d ) capacitor c=0.00210798f \
 //x=5.845 //y=1.39 //x2=5.92 //y2=1.045
cc_215 ( N_noxref_1_c_187_p N_GND_M2_noxref_d ) capacitor c=0.00472259f \
 //x=6.22 //y=0.89 //x2=5.92 //y2=1.045
cc_216 ( N_noxref_1_c_188_p N_GND_M2_noxref_d ) capacitor c=0.00166857f \
 //x=6.22 //y=1.545 //x2=5.92 //y2=1.045
cc_217 ( N_noxref_1_c_72_p N_GND_M2_noxref_d ) capacitor c=0.00230174f \
 //x=6.375 //y=1.045 //x2=5.92 //y2=1.045
cc_218 ( N_noxref_1_c_74_p N_GND_M2_noxref_d ) capacitor c=0.00210798f \
 //x=6.375 //y=1.39 //x2=5.92 //y2=1.045
cc_219 ( N_noxref_1_c_47_p N_noxref_15_c_3750_n ) capacitor c=0.00262672f \
 //x=5.845 //y=2.095 //x2=5.625 //y2=1.675
cc_220 ( N_noxref_1_c_10_p N_noxref_15_c_3751_n ) capacitor c=0.00353525f \
 //x=6.04 //y=4.025 //x2=6.51 //y2=1.76
cc_221 ( N_noxref_1_c_45_p N_noxref_15_c_3751_n ) capacitor c=0.00459552f \
 //x=6.04 //y=2.26 //x2=6.51 //y2=1.76
cc_222 ( N_noxref_1_c_32_p N_noxref_15_c_3751_n ) capacitor c=0.00763108f \
 //x=6.04 //y=2.26 //x2=6.51 //y2=1.76
cc_223 ( N_noxref_1_c_73_p N_noxref_15_c_3751_n ) capacitor c=0.00695869f \
 //x=5.845 //y=1.7 //x2=6.51 //y2=1.76
cc_224 ( N_noxref_1_c_47_p N_noxref_15_c_3751_n ) capacitor c=0.018093f \
 //x=5.845 //y=2.095 //x2=6.51 //y2=1.76
cc_225 ( N_noxref_1_c_188_p N_noxref_15_c_3751_n ) capacitor c=0.00723574f \
 //x=6.22 //y=1.545 //x2=6.51 //y2=1.76
cc_226 ( N_noxref_1_c_74_p N_noxref_15_c_3751_n ) capacitor c=0.00339872f \
 //x=6.375 //y=1.39 //x2=6.51 //y2=1.76
cc_227 ( N_noxref_1_c_47_p N_noxref_15_c_3758_n ) capacitor c=6.71402e-19 \
 //x=5.845 //y=2.095 //x2=6.595 //y2=1.675
cc_228 ( N_noxref_1_c_70_p N_noxref_15_M2_noxref_s ) capacitor c=0.0294925f \
 //x=5.845 //y=1.045 //x2=5.49 //y2=0.545
cc_229 ( N_noxref_1_c_73_p N_noxref_15_M2_noxref_s ) capacitor c=3.48408e-19 \
 //x=5.845 //y=1.7 //x2=5.49 //y2=0.545
cc_230 ( N_noxref_1_c_72_p N_noxref_15_M2_noxref_s ) capacitor c=0.0125442f \
 //x=6.375 //y=1.045 //x2=5.49 //y2=0.545
cc_231 ( N_noxref_2_c_234_n N_noxref_3_c_497_n ) capacitor c=0.0250002f \
 //x=7.52 //y=3.35 //x2=6.78 //y2=2.975
cc_232 ( N_noxref_2_c_254_p N_noxref_3_c_497_n ) capacitor c=0.00180339f //x=9 \
 //y=3.35 //x2=6.78 //y2=2.975
cc_233 ( N_noxref_2_c_231_n N_noxref_3_c_500_n ) capacitor c=9.55193e-19 \
 //x=6.925 //y=5.38 //x2=6.78 //y2=3.295
cc_234 ( N_noxref_2_c_256_p N_noxref_3_c_500_n ) capacitor c=8.10449e-19 \
 //x=7.165 //y=1.835 //x2=6.78 //y2=3.295
cc_235 ( N_noxref_2_c_234_n N_noxref_3_c_500_n ) capacitor c=0.0172716f \
 //x=7.52 //y=3.35 //x2=6.78 //y2=3.295
cc_236 ( N_noxref_2_c_258_p N_noxref_3_c_500_n ) capacitor c=0.00103213f \
 //x=7.04 //y=5.38 //x2=6.78 //y2=3.295
cc_237 ( N_noxref_2_c_246_n N_noxref_3_c_500_n ) capacitor c=2.77783e-19 \
 //x=7.08 //y=1.18 //x2=6.78 //y2=3.295
cc_238 ( N_noxref_2_c_260_p N_noxref_3_c_500_n ) capacitor c=2.58653e-19 \
 //x=7.04 //y=5.56 //x2=6.78 //y2=3.295
cc_239 ( N_noxref_2_c_231_n N_noxref_3_c_501_n ) capacitor c=0.0223265f \
 //x=6.925 //y=5.38 //x2=6.78 //y2=4.735
cc_240 ( N_noxref_2_c_234_n N_noxref_3_c_501_n ) capacitor c=0.00245069f \
 //x=7.52 //y=3.35 //x2=6.78 //y2=4.735
cc_241 ( N_noxref_2_c_263_p N_noxref_3_c_501_n ) capacitor c=0.0148501f \
 //x=7.52 //y=3.67 //x2=6.78 //y2=4.735
cc_242 ( N_noxref_2_c_236_n N_noxref_3_c_501_n ) capacitor c=0.0601625f \
 //x=7.52 //y=5.295 //x2=6.78 //y2=4.735
cc_243 ( N_noxref_2_c_265_p N_noxref_3_c_501_n ) capacitor c=0.0028426f //x=9 \
 //y=4.76 //x2=6.78 //y2=4.735
cc_244 ( N_noxref_2_c_266_p N_noxref_3_c_501_n ) capacitor c=6.03895e-19 \
 //x=7.52 //y=3.51 //x2=6.78 //y2=4.735
cc_245 ( N_noxref_2_c_267_p N_noxref_3_c_501_n ) capacitor c=0.00687742f \
 //x=7.68 //y=3.51 //x2=6.78 //y2=4.735
cc_246 ( N_noxref_2_c_254_p N_noxref_3_c_568_n ) capacitor c=0.00171671f //x=9 \
 //y=3.35 //x2=11.59 //y2=2.98
cc_247 ( N_noxref_2_c_234_n N_noxref_3_c_512_n ) capacitor c=0.015397f \
 //x=7.52 //y=3.35 //x2=6.78 //y2=2.26
cc_248 ( N_noxref_2_c_234_n N_noxref_3_c_515_n ) capacitor c=6.89957e-19 \
 //x=7.52 //y=3.35 //x2=6.78 //y2=3.14
cc_249 ( N_noxref_2_c_265_p N_noxref_3_c_571_n ) capacitor c=0.00258663f //x=9 \
 //y=4.76 //x2=11.592 //y2=4.74
cc_250 ( N_noxref_2_c_234_n N_noxref_3_c_572_n ) capacitor c=0.0271771f \
 //x=7.52 //y=3.35 //x2=7.735 //y2=3.125
cc_251 ( N_noxref_2_c_263_p N_noxref_3_c_572_n ) capacitor c=0.00808101f \
 //x=7.52 //y=3.67 //x2=7.735 //y2=3.125
cc_252 ( N_noxref_2_c_274_p N_noxref_3_c_572_n ) capacitor c=0.0976086f \
 //x=8.835 //y=3.51 //x2=7.735 //y2=3.125
cc_253 ( N_noxref_2_c_267_p N_noxref_3_c_572_n ) capacitor c=0.0365231f \
 //x=7.68 //y=3.51 //x2=7.735 //y2=3.125
cc_254 ( N_noxref_2_c_276_p N_noxref_3_c_526_n ) capacitor c=0.0043574f \
 //x=7.435 //y=1.835 //x2=7.305 //y2=3.125
cc_255 ( N_noxref_2_c_256_p N_noxref_3_c_526_n ) capacitor c=0.00443361f \
 //x=7.165 //y=1.835 //x2=7.305 //y2=3.125
cc_256 ( N_noxref_2_c_234_n N_noxref_3_c_526_n ) capacitor c=0.00334194f \
 //x=7.52 //y=3.35 //x2=7.305 //y2=3.125
cc_257 ( N_noxref_2_c_246_n N_noxref_3_c_526_n ) capacitor c=2.9373e-19 \
 //x=7.08 //y=1.18 //x2=7.305 //y2=3.125
cc_258 ( N_noxref_2_c_254_p N_noxref_3_c_580_n ) capacitor c=4.49947e-19 //x=9 \
 //y=3.35 //x2=8.61 //y2=3.14
cc_259 ( N_noxref_2_c_281_p N_noxref_3_c_580_n ) capacitor c=0.00276844f //x=9 \
 //y=3.67 //x2=8.61 //y2=3.14
cc_260 ( N_noxref_2_c_274_p N_noxref_3_c_580_n ) capacitor c=0.0112003f \
 //x=8.835 //y=3.51 //x2=8.61 //y2=3.14
cc_261 ( N_noxref_2_c_254_p N_noxref_3_c_583_n ) capacitor c=0.0265002f //x=9 \
 //y=3.35 //x2=9.21 //y2=3.125
cc_262 ( N_noxref_2_c_281_p N_noxref_3_c_583_n ) capacitor c=0.00448915f //x=9 \
 //y=3.67 //x2=9.21 //y2=3.125
cc_263 ( N_noxref_2_c_285_p N_noxref_3_c_583_n ) capacitor c=0.0027091f //x=9 \
 //y=2.265 //x2=9.21 //y2=3.125
cc_264 ( N_noxref_2_c_286_p N_noxref_3_c_583_n ) capacitor c=0.0365231f \
 //x=8.995 //y=3.51 //x2=9.21 //y2=3.125
cc_265 ( N_noxref_2_c_234_n N_noxref_3_c_527_n ) capacitor c=9.90728e-19 \
 //x=7.52 //y=3.35 //x2=6.78 //y2=2.26
cc_266 ( N_noxref_2_c_231_n N_noxref_3_c_531_n ) capacitor c=0.00469257f \
 //x=6.925 //y=5.38 //x2=6.81 //y2=4.88
cc_267 ( N_noxref_2_c_236_n N_noxref_3_c_531_n ) capacitor c=7.76118e-19 \
 //x=7.52 //y=5.295 //x2=6.81 //y2=4.88
cc_268 ( N_noxref_2_c_231_n N_noxref_3_M18_noxref_g ) capacitor c=0.00842859f \
 //x=6.925 //y=5.38 //x2=6.82 //y2=6.2
cc_269 ( N_noxref_2_c_258_p N_noxref_3_M18_noxref_g ) capacitor c=0.00192712f \
 //x=7.04 //y=5.38 //x2=6.82 //y2=6.2
cc_270 ( N_noxref_2_c_260_p N_noxref_3_M18_noxref_g ) capacitor c=0.0178987f \
 //x=7.04 //y=5.56 //x2=6.82 //y2=6.2
cc_271 ( N_noxref_2_c_293_p N_noxref_3_M19_noxref_g ) capacitor c=0.0110279f \
 //x=7.435 //y=5.38 //x2=7.26 //y2=6.2
cc_272 ( N_noxref_2_c_258_p N_noxref_3_M19_noxref_g ) capacitor c=0.00291595f \
 //x=7.04 //y=5.38 //x2=7.26 //y2=6.2
cc_273 ( N_noxref_2_c_260_p N_noxref_3_M19_noxref_g ) capacitor c=0.0178506f \
 //x=7.04 //y=5.56 //x2=7.26 //y2=6.2
cc_274 ( N_noxref_2_c_246_n N_noxref_3_c_537_n ) capacitor c=0.00120406f \
 //x=7.08 //y=1.18 //x2=6.815 //y2=1.085
cc_275 ( N_noxref_2_M3_noxref_d N_noxref_3_c_537_n ) capacitor c=0.00137165f \
 //x=6.89 //y=1.085 //x2=6.815 //y2=1.085
cc_276 ( N_noxref_2_c_232_n N_noxref_3_c_540_n ) capacitor c=0.00118531f \
 //x=7.08 //y=1.75 //x2=6.815 //y2=1.43
cc_277 ( N_noxref_2_c_246_n N_noxref_3_c_540_n ) capacitor c=0.00218558f \
 //x=7.08 //y=1.18 //x2=6.815 //y2=1.43
cc_278 ( N_noxref_2_M3_noxref_d N_noxref_3_c_540_n ) capacitor c=0.00237422f \
 //x=6.89 //y=1.085 //x2=6.815 //y2=1.43
cc_279 ( N_noxref_2_c_232_n N_noxref_3_c_542_n ) capacitor c=0.00437687f \
 //x=7.08 //y=1.75 //x2=6.815 //y2=1.74
cc_280 ( N_noxref_2_c_236_n N_noxref_3_c_602_n ) capacitor c=0.0084741f \
 //x=7.52 //y=5.295 //x2=7.185 //y2=4.97
cc_281 ( N_noxref_2_c_258_p N_noxref_3_c_602_n ) capacitor c=0.00196809f \
 //x=7.04 //y=5.38 //x2=7.185 //y2=4.97
cc_282 ( N_noxref_2_c_260_p N_noxref_3_c_602_n ) capacitor c=0.00291714f \
 //x=7.04 //y=5.56 //x2=7.185 //y2=4.97
cc_283 ( N_noxref_2_c_246_n N_noxref_3_c_605_n ) capacitor c=5.50523e-19 \
 //x=7.08 //y=1.18 //x2=7.19 //y2=0.93
cc_284 ( N_noxref_2_M3_noxref_d N_noxref_3_c_605_n ) capacitor c=0.0020782f \
 //x=6.89 //y=1.085 //x2=7.19 //y2=0.93
cc_285 ( N_noxref_2_c_232_n N_noxref_3_c_607_n ) capacitor c=0.00897029f \
 //x=7.08 //y=1.75 //x2=7.19 //y2=1.585
cc_286 ( N_noxref_2_c_276_p N_noxref_3_c_607_n ) capacitor c=0.00194324f \
 //x=7.435 //y=1.835 //x2=7.19 //y2=1.585
cc_287 ( N_noxref_2_c_246_n N_noxref_3_c_607_n ) capacitor c=4.93963e-19 \
 //x=7.08 //y=1.18 //x2=7.19 //y2=1.585
cc_288 ( N_noxref_2_M3_noxref_d N_noxref_3_c_607_n ) capacitor c=0.00356097f \
 //x=6.89 //y=1.085 //x2=7.19 //y2=1.585
cc_289 ( N_noxref_2_c_246_n N_noxref_3_c_545_n ) capacitor c=0.00109707f \
 //x=7.08 //y=1.18 //x2=7.345 //y2=1.085
cc_290 ( N_noxref_2_M3_noxref_d N_noxref_3_c_545_n ) capacitor c=8.50095e-19 \
 //x=6.89 //y=1.085 //x2=7.345 //y2=1.085
cc_291 ( N_noxref_2_c_232_n N_noxref_3_c_546_n ) capacitor c=0.00303393f \
 //x=7.08 //y=1.75 //x2=7.345 //y2=1.43
cc_292 ( N_noxref_2_c_276_p N_noxref_3_c_546_n ) capacitor c=0.00323005f \
 //x=7.435 //y=1.835 //x2=7.345 //y2=1.43
cc_293 ( N_noxref_2_c_246_n N_noxref_3_c_546_n ) capacitor c=0.00312043f \
 //x=7.08 //y=1.18 //x2=7.345 //y2=1.43
cc_294 ( N_noxref_2_M3_noxref_d N_noxref_3_c_546_n ) capacitor c=0.00237422f \
 //x=6.89 //y=1.085 //x2=7.345 //y2=1.43
cc_295 ( N_noxref_2_c_234_n N_noxref_3_c_547_n ) capacitor c=0.00281392f \
 //x=7.52 //y=3.35 //x2=6.78 //y2=2.26
cc_296 ( N_noxref_2_c_232_n N_noxref_3_c_618_n ) capacitor c=0.00348382f \
 //x=7.08 //y=1.75 //x2=6.78 //y2=2.095
cc_297 ( N_noxref_2_c_234_n N_noxref_3_c_618_n ) capacitor c=0.00309521f \
 //x=7.52 //y=3.35 //x2=6.78 //y2=2.095
cc_298 ( N_noxref_2_c_231_n N_noxref_3_c_550_n ) capacitor c=9.30456e-19 \
 //x=6.925 //y=5.38 //x2=6.81 //y2=4.88
cc_299 ( N_noxref_2_c_236_n N_noxref_3_c_550_n ) capacitor c=0.00142201f \
 //x=7.52 //y=5.295 //x2=6.81 //y2=4.88
cc_300 ( N_noxref_2_c_263_p N_D_c_899_n ) capacitor c=0.00519831f //x=7.52 \
 //y=3.67 //x2=12.165 //y2=4.265
cc_301 ( N_noxref_2_c_236_n N_D_c_899_n ) capacitor c=0.030923f //x=7.52 \
 //y=5.295 //x2=12.165 //y2=4.265
cc_302 ( N_noxref_2_c_281_p N_D_c_899_n ) capacitor c=0.0043026f //x=9 \
 //y=3.67 //x2=12.165 //y2=4.265
cc_303 ( N_noxref_2_c_265_p N_D_c_899_n ) capacitor c=0.0326049f //x=9 \
 //y=4.76 //x2=12.165 //y2=4.265
cc_304 ( N_noxref_2_c_239_n N_D_c_899_n ) capacitor c=0.0181163f //x=6.16 \
 //y=5.56 //x2=12.165 //y2=4.265
cc_305 ( N_noxref_2_c_258_p N_D_c_899_n ) capacitor c=0.015527f //x=7.04 \
 //y=5.38 //x2=12.165 //y2=4.265
cc_306 ( N_noxref_2_c_274_p N_D_c_899_n ) capacitor c=0.052443f //x=8.835 \
 //y=3.51 //x2=12.165 //y2=4.265
cc_307 ( N_noxref_2_c_267_p N_D_c_899_n ) capacitor c=0.0157335f //x=7.68 \
 //y=3.51 //x2=12.165 //y2=4.265
cc_308 ( N_noxref_2_c_286_p N_D_c_899_n ) capacitor c=0.0157335f //x=8.995 \
 //y=3.51 //x2=12.165 //y2=4.265
cc_309 ( N_noxref_2_c_232_n N_noxref_6_c_1429_n ) capacitor c=0.00466656f \
 //x=7.08 //y=1.75 //x2=9.37 //y2=1.935
cc_310 ( N_noxref_2_c_276_p N_noxref_6_c_1429_n ) capacitor c=0.00328586f \
 //x=7.435 //y=1.835 //x2=9.37 //y2=1.935
cc_311 ( N_noxref_2_c_333_p N_noxref_6_c_1429_n ) capacitor c=0.00108934f \
 //x=9.11 //y=1.435 //x2=9.37 //y2=1.935
cc_312 ( N_noxref_2_c_334_p N_noxref_6_c_1429_n ) capacitor c=0.00524682f \
 //x=9.11 //y=1.745 //x2=9.37 //y2=1.935
cc_313 ( N_noxref_2_c_335_p N_noxref_6_c_1429_n ) capacitor c=0.00376309f \
 //x=9.11 //y=2.1 //x2=9.37 //y2=1.935
cc_314 ( N_noxref_2_c_336_p N_noxref_6_c_1429_n ) capacitor c=0.00921f \
 //x=9.485 //y=1.59 //x2=9.37 //y2=1.935
cc_315 ( N_noxref_2_c_337_p N_noxref_6_c_1429_n ) capacitor c=0.00344663f \
 //x=9.64 //y=1.435 //x2=9.37 //y2=1.935
cc_316 ( N_noxref_2_c_293_p N_noxref_6_c_1436_n ) capacitor c=0.00310351f \
 //x=7.435 //y=5.38 //x2=9.375 //y2=5.42
cc_317 ( N_noxref_2_c_258_p N_noxref_6_c_1436_n ) capacitor c=5.44332e-19 \
 //x=7.04 //y=5.38 //x2=9.375 //y2=5.42
cc_318 ( N_noxref_2_M20_noxref_g N_noxref_6_c_1436_n ) capacitor c=0.00141266f \
 //x=9.155 //y=6.2 //x2=9.375 //y2=5.42
cc_319 ( N_noxref_2_M21_noxref_g N_noxref_6_c_1436_n ) capacitor c=0.0035262f \
 //x=9.595 //y=6.2 //x2=9.375 //y2=5.42
cc_320 ( N_noxref_2_c_336_p N_noxref_6_c_1440_n ) capacitor c=0.00180253f \
 //x=9.485 //y=1.59 //x2=9.655 //y2=2.02
cc_321 ( N_noxref_2_c_234_n N_noxref_6_c_1441_n ) capacitor c=0.00328586f \
 //x=7.52 //y=3.35 //x2=9.455 //y2=2.02
cc_322 ( N_noxref_2_c_344_p N_noxref_6_c_1441_n ) capacitor c=0.00376309f \
 //x=9 //y=2.265 //x2=9.455 //y2=2.02
cc_323 ( N_noxref_2_M21_noxref_g N_noxref_6_c_1443_n ) capacitor c=0.00933399f \
 //x=9.595 //y=6.2 //x2=9.655 //y2=5.14
cc_324 ( N_noxref_2_c_236_n N_noxref_6_c_1444_n ) capacitor c=0.00292756f \
 //x=7.52 //y=5.295 //x2=9.46 //y2=5.14
cc_325 ( N_noxref_2_M20_noxref_g N_noxref_6_c_1444_n ) capacitor c=0.00427521f \
 //x=9.155 //y=6.2 //x2=9.46 //y2=5.14
cc_326 ( N_noxref_2_c_348_p N_noxref_6_c_1444_n ) capacitor c=0.00262283f \
 //x=9.52 //y=4.97 //x2=9.46 //y2=5.14
cc_327 ( N_noxref_2_c_234_n N_noxref_6_c_1447_n ) capacitor c=0.00348672f \
 //x=7.52 //y=3.35 //x2=9.74 //y2=3.705
cc_328 ( N_noxref_2_c_254_p N_noxref_6_c_1447_n ) capacitor c=0.0370942f //x=9 \
 //y=3.35 //x2=9.74 //y2=3.705
cc_329 ( N_noxref_2_c_281_p N_noxref_6_c_1447_n ) capacitor c=0.0146933f //x=9 \
 //y=3.67 //x2=9.74 //y2=3.705
cc_330 ( N_noxref_2_c_265_p N_noxref_6_c_1447_n ) capacitor c=0.00158373f \
 //x=9 //y=4.76 //x2=9.74 //y2=3.705
cc_331 ( N_noxref_2_c_353_p N_noxref_6_c_1447_n ) capacitor c=6.03895e-19 \
 //x=8.995 //y=3.51 //x2=9.74 //y2=3.705
cc_332 ( N_noxref_2_c_285_p N_noxref_6_c_1447_n ) capacitor c=0.017436f //x=9 \
 //y=2.265 //x2=9.74 //y2=3.705
cc_333 ( N_noxref_2_c_286_p N_noxref_6_c_1447_n ) capacitor c=0.00684338f \
 //x=8.995 //y=3.51 //x2=9.74 //y2=3.705
cc_334 ( N_noxref_2_c_356_p N_noxref_6_c_1447_n ) capacitor c=4.71798e-19 \
 //x=9 //y=2.265 //x2=9.74 //y2=3.705
cc_335 ( N_noxref_2_c_344_p N_noxref_6_c_1447_n ) capacitor c=0.00270592f \
 //x=9 //y=2.265 //x2=9.74 //y2=3.705
cc_336 ( N_noxref_2_c_265_p N_noxref_6_c_1456_n ) capacitor c=0.0151188f //x=9 \
 //y=4.76 //x2=9.74 //y2=4.025
cc_337 ( N_noxref_2_c_348_p N_noxref_6_c_1456_n ) capacitor c=0.00120343f \
 //x=9.52 //y=4.97 //x2=9.74 //y2=4.025
cc_338 ( N_noxref_2_c_236_n N_noxref_6_c_1458_n ) capacitor c=0.00230216f \
 //x=7.52 //y=5.295 //x2=9.74 //y2=5.055
cc_339 ( N_noxref_2_c_265_p N_noxref_6_c_1458_n ) capacitor c=0.0456197f //x=9 \
 //y=4.76 //x2=9.74 //y2=5.055
cc_340 ( N_noxref_2_c_362_p N_noxref_6_c_1458_n ) capacitor c=0.00160039f \
 //x=9 //y=4.88 //x2=9.74 //y2=5.055
cc_341 ( N_noxref_2_c_348_p N_noxref_6_c_1458_n ) capacitor c=0.00208891f \
 //x=9.52 //y=4.97 //x2=9.74 //y2=5.055
cc_342 ( N_noxref_2_c_364_p N_noxref_6_c_1458_n ) capacitor c=0.00140024f \
 //x=9.23 //y=4.97 //x2=9.74 //y2=5.055
cc_343 ( N_noxref_2_c_232_n N_noxref_6_c_1463_n ) capacitor c=6.23317e-19 \
 //x=7.08 //y=1.75 //x2=9.37 //y2=1.185
cc_344 ( N_noxref_2_c_246_n N_noxref_6_c_1463_n ) capacitor c=0.00597106f \
 //x=7.08 //y=1.18 //x2=9.37 //y2=1.185
cc_345 ( N_noxref_2_c_367_p N_noxref_6_c_1463_n ) capacitor c=0.00175305f \
 //x=9.11 //y=1.09 //x2=9.37 //y2=1.185
cc_346 ( N_noxref_2_c_333_p N_noxref_6_c_1463_n ) capacitor c=0.00354487f \
 //x=9.11 //y=1.435 //x2=9.37 //y2=1.185
cc_347 ( N_noxref_2_c_369_p N_noxref_6_c_1463_n ) capacitor c=5.57924e-19 \
 //x=9.485 //y=0.935 //x2=9.37 //y2=1.185
cc_348 ( N_noxref_2_c_336_p N_noxref_6_c_1463_n ) capacitor c=5.75878e-19 \
 //x=9.485 //y=1.59 //x2=9.37 //y2=1.185
cc_349 ( N_noxref_2_c_371_p N_noxref_6_c_1463_n ) capacitor c=0.00148146f \
 //x=9.64 //y=1.09 //x2=9.37 //y2=1.185
cc_350 ( N_noxref_2_c_337_p N_noxref_6_c_1463_n ) capacitor c=0.00356478f \
 //x=9.64 //y=1.435 //x2=9.37 //y2=1.185
cc_351 ( N_noxref_2_c_265_p N_noxref_6_c_1471_n ) capacitor c=7.6985e-19 //x=9 \
 //y=4.76 //x2=9.74 //y2=3.88
cc_352 ( N_noxref_2_c_265_p N_noxref_6_c_1472_n ) capacitor c=0.00696258f \
 //x=9 //y=4.76 //x2=9.9 //y2=3.865
cc_353 ( N_noxref_2_M20_noxref_g N_noxref_6_c_1473_n ) capacitor c=0.0162066f \
 //x=9.155 //y=6.2 //x2=9.375 //y2=5.56
cc_354 ( N_noxref_2_M21_noxref_g N_noxref_6_c_1473_n ) capacitor c=0.0162066f \
 //x=9.595 //y=6.2 //x2=9.375 //y2=5.56
cc_355 ( N_noxref_2_c_348_p N_noxref_6_c_1473_n ) capacitor c=0.00290963f \
 //x=9.52 //y=4.97 //x2=9.375 //y2=5.56
cc_356 ( N_noxref_2_c_367_p N_noxref_6_M4_noxref_d ) capacitor c=0.00137914f \
 //x=9.11 //y=1.09 //x2=9.185 //y2=1.09
cc_357 ( N_noxref_2_c_333_p N_noxref_6_M4_noxref_d ) capacitor c=0.0023891f \
 //x=9.11 //y=1.435 //x2=9.185 //y2=1.09
cc_358 ( N_noxref_2_c_369_p N_noxref_6_M4_noxref_d ) capacitor c=0.0020782f \
 //x=9.485 //y=0.935 //x2=9.185 //y2=1.09
cc_359 ( N_noxref_2_c_336_p N_noxref_6_M4_noxref_d ) capacitor c=0.00356097f \
 //x=9.485 //y=1.59 //x2=9.185 //y2=1.09
cc_360 ( N_noxref_2_c_371_p N_noxref_6_M4_noxref_d ) capacitor c=0.00138452f \
 //x=9.64 //y=1.09 //x2=9.185 //y2=1.09
cc_361 ( N_noxref_2_c_337_p N_noxref_6_M4_noxref_d ) capacitor c=0.00235934f \
 //x=9.64 //y=1.435 //x2=9.185 //y2=1.09
cc_362 ( N_noxref_2_c_231_n N_VDD_c_2596_n ) capacitor c=0.00648288f //x=6.925 \
 //y=5.38 //x2=17.175 //y2=7.585
cc_363 ( N_noxref_2_c_293_p N_VDD_c_2596_n ) capacitor c=0.00492584f //x=7.435 \
 //y=5.38 //x2=17.175 //y2=7.585
cc_364 ( N_noxref_2_c_263_p N_VDD_c_2596_n ) capacitor c=4.64497e-19 //x=7.52 \
 //y=3.67 //x2=17.175 //y2=7.585
cc_365 ( N_noxref_2_c_281_p N_VDD_c_2596_n ) capacitor c=2.69767e-19 //x=9 \
 //y=3.67 //x2=17.175 //y2=7.585
cc_366 ( N_noxref_2_c_265_p N_VDD_c_2596_n ) capacitor c=5.73169e-19 //x=9 \
 //y=4.76 //x2=17.175 //y2=7.585
cc_367 ( N_noxref_2_c_239_n N_VDD_c_2596_n ) capacitor c=0.00368834f //x=6.16 \
 //y=5.56 //x2=17.175 //y2=7.585
cc_368 ( N_noxref_2_c_258_p N_VDD_c_2596_n ) capacitor c=8.42537e-19 //x=7.04 \
 //y=5.38 //x2=17.175 //y2=7.585
cc_369 ( N_noxref_2_c_391_p N_VDD_c_2596_n ) capacitor c=0.00285853f //x=7.04 \
 //y=5.56 //x2=17.175 //y2=7.585
cc_370 ( N_noxref_2_c_247_n N_VDD_c_2596_n ) capacitor c=0.00224881f //x=6.16 \
 //y=5.56 //x2=17.175 //y2=7.585
cc_371 ( N_noxref_2_c_260_p N_VDD_c_2596_n ) capacitor c=0.00224881f //x=7.04 \
 //y=5.56 //x2=17.175 //y2=7.585
cc_372 ( N_noxref_2_c_362_p N_VDD_c_2596_n ) capacitor c=3.40755e-19 //x=9 \
 //y=4.88 //x2=17.175 //y2=7.585
cc_373 ( N_noxref_2_c_231_n N_VDD_c_2605_n ) capacitor c=0.00208087f //x=6.925 \
 //y=5.38 //x2=6.515 //y2=7.585
cc_374 ( N_noxref_2_c_239_n N_VDD_c_2605_n ) capacitor c=9.41185e-19 //x=6.16 \
 //y=5.56 //x2=6.515 //y2=7.585
cc_375 ( N_noxref_2_c_247_n N_VDD_c_2605_n ) capacitor c=0.0136705f //x=6.16 \
 //y=5.56 //x2=6.515 //y2=7.585
cc_376 ( N_noxref_2_c_231_n N_VDD_c_2643_n ) capacitor c=0.00180737f //x=6.925 \
 //y=5.38 //x2=7.395 //y2=7.585
cc_377 ( N_noxref_2_c_293_p N_VDD_c_2643_n ) capacitor c=0.00208087f //x=7.435 \
 //y=5.38 //x2=7.395 //y2=7.585
cc_378 ( N_noxref_2_c_258_p N_VDD_c_2643_n ) capacitor c=4.23719e-19 //x=7.04 \
 //y=5.38 //x2=7.395 //y2=7.585
cc_379 ( N_noxref_2_c_391_p N_VDD_c_2643_n ) capacitor c=5.77976e-19 //x=7.04 \
 //y=5.56 //x2=7.395 //y2=7.585
cc_380 ( N_noxref_2_c_260_p N_VDD_c_2643_n ) capacitor c=0.0136705f //x=7.04 \
 //y=5.56 //x2=7.395 //y2=7.585
cc_381 ( N_noxref_2_c_265_p N_VDD_c_2648_n ) capacitor c=5.48929e-19 //x=9 \
 //y=4.76 //x2=9.73 //y2=7.585
cc_382 ( N_noxref_2_M20_noxref_g N_VDD_c_2648_n ) capacitor c=0.00753931f \
 //x=9.155 //y=6.2 //x2=9.73 //y2=7.585
cc_383 ( N_noxref_2_M21_noxref_g N_VDD_c_2648_n ) capacitor c=0.00755544f \
 //x=9.595 //y=6.2 //x2=9.73 //y2=7.585
cc_384 ( N_noxref_2_c_236_n N_VDD_c_2610_n ) capacitor c=0.00133592f //x=7.52 \
 //y=5.295 //x2=4.93 //y2=7.585
cc_385 ( N_noxref_2_c_239_n N_VDD_c_2610_n ) capacitor c=5.11447e-19 //x=6.16 \
 //y=5.56 //x2=4.93 //y2=7.585
cc_386 ( N_noxref_2_c_247_n N_VDD_c_2610_n ) capacitor c=0.0064135f //x=6.16 \
 //y=5.56 //x2=4.93 //y2=7.585
cc_387 ( N_noxref_2_c_236_n N_VDD_c_2654_n ) capacitor c=0.0279622f //x=7.52 \
 //y=5.295 //x2=8.26 //y2=7.585
cc_388 ( N_noxref_2_c_265_p N_VDD_c_2654_n ) capacitor c=0.0153926f //x=9 \
 //y=4.76 //x2=8.26 //y2=7.585
cc_389 ( N_noxref_2_c_258_p N_VDD_c_2654_n ) capacitor c=0.002343f //x=7.04 \
 //y=5.38 //x2=8.26 //y2=7.585
cc_390 ( N_noxref_2_c_391_p N_VDD_c_2654_n ) capacitor c=4.0348e-19 //x=7.04 \
 //y=5.56 //x2=8.26 //y2=7.585
cc_391 ( N_noxref_2_c_260_p N_VDD_c_2654_n ) capacitor c=0.0101861f //x=7.04 \
 //y=5.56 //x2=8.26 //y2=7.585
cc_392 ( N_noxref_2_c_362_p N_VDD_c_2654_n ) capacitor c=0.00795305f //x=9 \
 //y=4.88 //x2=8.26 //y2=7.585
cc_393 ( N_noxref_2_M20_noxref_g N_VDD_c_2654_n ) capacitor c=0.00713158f \
 //x=9.155 //y=6.2 //x2=8.26 //y2=7.585
cc_394 ( N_noxref_2_c_364_p N_VDD_c_2654_n ) capacitor c=0.00799922f //x=9.23 \
 //y=4.97 //x2=8.26 //y2=7.585
cc_395 ( N_noxref_2_c_362_p N_VDD_c_2662_n ) capacitor c=0.00235165f //x=9 \
 //y=4.88 //x2=10.48 //y2=7.585
cc_396 ( N_noxref_2_c_348_p N_VDD_c_2662_n ) capacitor c=0.00780996f //x=9.52 \
 //y=4.97 //x2=10.48 //y2=7.585
cc_397 ( N_noxref_2_c_364_p N_VDD_c_2662_n ) capacitor c=2.63786e-19 //x=9.23 \
 //y=4.97 //x2=10.48 //y2=7.585
cc_398 ( N_noxref_2_c_239_n N_VDD_M15_noxref_d ) capacitor c=0.00114029f \
 //x=6.16 //y=5.56 //x2=4.12 //y2=5.2
cc_399 ( N_noxref_2_c_239_n N_VDD_M16_noxref_s ) capacitor c=0.0604727f \
 //x=6.16 //y=5.56 //x2=5.585 //y2=5.2
cc_400 ( N_noxref_2_c_258_p N_VDD_M16_noxref_s ) capacitor c=6.52457e-19 \
 //x=7.04 //y=5.38 //x2=5.585 //y2=5.2
cc_401 ( N_noxref_2_c_247_n N_VDD_M16_noxref_s ) capacitor c=0.0887533f \
 //x=6.16 //y=5.56 //x2=5.585 //y2=5.2
cc_402 ( N_noxref_2_c_231_n N_VDD_M17_noxref_d ) capacitor c=0.00734094f \
 //x=6.925 //y=5.38 //x2=6.455 //y2=5.2
cc_403 ( N_noxref_2_c_239_n N_VDD_M17_noxref_d ) capacitor c=0.0043528f \
 //x=6.16 //y=5.56 //x2=6.455 //y2=5.2
cc_404 ( N_noxref_2_c_391_p N_VDD_M17_noxref_d ) capacitor c=0.0043528f \
 //x=7.04 //y=5.56 //x2=6.455 //y2=5.2
cc_405 ( N_noxref_2_c_247_n N_VDD_M17_noxref_d ) capacitor c=0.065554f \
 //x=6.16 //y=5.56 //x2=6.455 //y2=5.2
cc_406 ( N_noxref_2_c_260_p N_VDD_M17_noxref_d ) capacitor c=0.065554f \
 //x=7.04 //y=5.56 //x2=6.455 //y2=5.2
cc_407 ( N_noxref_2_c_293_p N_VDD_M19_noxref_d ) capacitor c=0.00934027f \
 //x=7.435 //y=5.38 //x2=7.335 //y2=5.2
cc_408 ( N_noxref_2_c_391_p N_VDD_M19_noxref_d ) capacitor c=0.00921458f \
 //x=7.04 //y=5.56 //x2=7.335 //y2=5.2
cc_409 ( N_noxref_2_c_266_p N_VDD_M19_noxref_d ) capacitor c=9.65951e-19 \
 //x=7.52 //y=3.51 //x2=7.335 //y2=5.2
cc_410 ( N_noxref_2_c_260_p N_VDD_M19_noxref_d ) capacitor c=0.065554f \
 //x=7.04 //y=5.56 //x2=7.335 //y2=5.2
cc_411 ( N_noxref_2_c_293_p N_VDD_M20_noxref_s ) capacitor c=0.00316782f \
 //x=7.435 //y=5.38 //x2=8.8 //y2=5.2
cc_412 ( N_noxref_2_c_281_p N_VDD_M20_noxref_s ) capacitor c=0.00125782f //x=9 \
 //y=3.67 //x2=8.8 //y2=5.2
cc_413 ( N_noxref_2_c_265_p N_VDD_M20_noxref_s ) capacitor c=0.0212063f //x=9 \
 //y=4.76 //x2=8.8 //y2=5.2
cc_414 ( N_noxref_2_c_258_p N_VDD_M20_noxref_s ) capacitor c=0.00460957f \
 //x=7.04 //y=5.38 //x2=8.8 //y2=5.2
cc_415 ( N_noxref_2_c_391_p N_VDD_M20_noxref_s ) capacitor c=0.00135645f \
 //x=7.04 //y=5.56 //x2=8.8 //y2=5.2
cc_416 ( N_noxref_2_c_362_p N_VDD_M20_noxref_s ) capacitor c=0.00986169f //x=9 \
 //y=4.88 //x2=8.8 //y2=5.2
cc_417 ( N_noxref_2_M20_noxref_g N_VDD_M20_noxref_s ) capacitor c=0.0573441f \
 //x=9.155 //y=6.2 //x2=8.8 //y2=5.2
cc_418 ( N_noxref_2_c_364_p N_VDD_M20_noxref_s ) capacitor c=0.00403393f \
 //x=9.23 //y=4.97 //x2=8.8 //y2=5.2
cc_419 ( N_noxref_2_M21_noxref_g N_VDD_M21_noxref_d ) capacitor c=0.0572684f \
 //x=9.595 //y=6.2 //x2=9.67 //y2=5.2
cc_420 ( N_noxref_2_c_276_p N_GND_c_3166_n ) capacitor c=0.00654514f //x=7.435 \
 //y=1.835 //x2=11.575 //y2=0.175
cc_421 ( N_noxref_2_c_263_p N_GND_c_3166_n ) capacitor c=4.52555e-19 //x=7.52 \
 //y=3.67 //x2=11.575 //y2=0.175
cc_422 ( N_noxref_2_c_281_p N_GND_c_3166_n ) capacitor c=4.65445e-19 //x=9 \
 //y=3.67 //x2=11.575 //y2=0.175
cc_423 ( N_noxref_2_c_246_n N_GND_c_3166_n ) capacitor c=0.00964814f //x=7.08 \
 //y=1.18 //x2=11.575 //y2=0.175
cc_424 ( N_noxref_2_c_285_p N_GND_c_3166_n ) capacitor c=0.00249122f //x=9 \
 //y=2.265 //x2=11.575 //y2=0.175
cc_425 ( N_noxref_2_c_356_p N_GND_c_3166_n ) capacitor c=7.5371e-19 //x=9 \
 //y=2.265 //x2=11.575 //y2=0.175
cc_426 ( N_noxref_2_M3_noxref_d N_GND_c_3166_n ) capacitor c=3.01769e-19 \
 //x=6.89 //y=1.085 //x2=11.575 //y2=0.175
cc_427 ( N_noxref_2_c_239_n N_GND_c_3128_n ) capacitor c=6.68112e-19 //x=6.16 \
 //y=5.56 //x2=6.11 //y2=1.135
cc_428 ( N_noxref_2_c_246_n N_GND_c_3128_n ) capacitor c=0.0140211f //x=7.08 \
 //y=1.18 //x2=6.11 //y2=1.135
cc_429 ( N_noxref_2_M3_noxref_d N_GND_c_3128_n ) capacitor c=2.93544e-19 \
 //x=6.89 //y=1.085 //x2=6.11 //y2=1.135
cc_430 ( N_noxref_2_c_276_p N_GND_c_3145_n ) capacitor c=7.75992e-19 //x=7.435 \
 //y=1.835 //x2=8.09 //y2=0.175
cc_431 ( N_noxref_2_c_263_p N_GND_c_3145_n ) capacitor c=3.21306e-19 //x=7.52 \
 //y=3.67 //x2=8.09 //y2=0.175
cc_432 ( N_noxref_2_c_285_p N_GND_c_3178_n ) capacitor c=0.00114179f //x=9 \
 //y=2.265 //x2=9.285 //y2=0.715
cc_433 ( N_noxref_2_c_356_p N_GND_c_3178_n ) capacitor c=3.95714e-19 //x=9 \
 //y=2.265 //x2=9.285 //y2=0.715
cc_434 ( N_noxref_2_c_367_p N_GND_c_3178_n ) capacitor c=0.0125444f //x=9.11 \
 //y=1.09 //x2=9.285 //y2=0.715
cc_435 ( N_noxref_2_c_344_p N_GND_c_3178_n ) capacitor c=2.1838e-19 //x=9 \
 //y=2.265 //x2=9.285 //y2=0.715
cc_436 ( N_noxref_2_c_371_p N_GND_c_3182_n ) capacitor c=0.0132772f //x=9.64 \
 //y=1.09 //x2=9.775 //y2=0.715
cc_437 ( N_noxref_2_c_246_n N_GND_c_3146_n ) capacitor c=2.83275e-19 //x=7.08 \
 //y=1.18 //x2=22.32 //y2=0.18
cc_438 ( N_noxref_2_c_234_n N_GND_c_3148_n ) capacitor c=9.34543e-19 //x=7.52 \
 //y=3.35 //x2=4.93 //y2=0.175
cc_439 ( N_noxref_2_c_232_n N_GND_c_3185_n ) capacitor c=0.00269515f //x=7.08 \
 //y=1.75 //x2=8.26 //y2=0.175
cc_440 ( N_noxref_2_c_276_p N_GND_c_3185_n ) capacitor c=0.027102f //x=7.435 \
 //y=1.835 //x2=8.26 //y2=0.175
cc_441 ( N_noxref_2_c_254_p N_GND_c_3185_n ) capacitor c=0.0103129f //x=9 \
 //y=3.35 //x2=8.26 //y2=0.175
cc_442 ( N_noxref_2_c_285_p N_GND_c_3185_n ) capacitor c=0.00682461f //x=9 \
 //y=2.265 //x2=8.26 //y2=0.175
cc_443 ( N_noxref_2_c_356_p N_GND_c_3185_n ) capacitor c=0.00733236f //x=9 \
 //y=2.265 //x2=8.26 //y2=0.175
cc_444 ( N_noxref_2_c_335_p N_GND_c_3185_n ) capacitor c=0.00427677f //x=9.11 \
 //y=2.1 //x2=8.26 //y2=0.175
cc_445 ( N_noxref_2_c_344_p N_GND_c_3185_n ) capacitor c=0.00785621f //x=9 \
 //y=2.265 //x2=8.26 //y2=0.175
cc_446 ( N_noxref_2_c_356_p N_GND_c_3192_n ) capacitor c=0.00230732f //x=9 \
 //y=2.265 //x2=10.48 //y2=0.175
cc_447 ( N_noxref_2_c_246_n N_GND_M2_noxref_d ) capacitor c=2.82748e-19 \
 //x=7.08 //y=1.18 //x2=5.92 //y2=1.045
cc_448 ( N_noxref_2_c_281_p N_GND_M4_noxref_s ) capacitor c=8.20337e-19 //x=9 \
 //y=3.67 //x2=8.755 //y2=0.55
cc_449 ( N_noxref_2_c_285_p N_GND_M4_noxref_s ) capacitor c=0.00297876f //x=9 \
 //y=2.265 //x2=8.755 //y2=0.55
cc_450 ( N_noxref_2_c_356_p N_GND_M4_noxref_s ) capacitor c=0.00651326f //x=9 \
 //y=2.265 //x2=8.755 //y2=0.55
cc_451 ( N_noxref_2_c_367_p N_GND_M4_noxref_s ) capacitor c=0.0300814f \
 //x=9.11 //y=1.09 //x2=8.755 //y2=0.55
cc_452 ( N_noxref_2_c_334_p N_GND_M4_noxref_s ) capacitor c=0.002132f //x=9.11 \
 //y=1.745 //x2=8.755 //y2=0.55
cc_453 ( N_noxref_2_c_335_p N_GND_M4_noxref_s ) capacitor c=0.00304786f \
 //x=9.11 //y=2.1 //x2=8.755 //y2=0.55
cc_454 ( N_noxref_2_c_369_p N_GND_M4_noxref_s ) capacitor c=0.00517463f \
 //x=9.485 //y=0.935 //x2=8.755 //y2=0.55
cc_455 ( N_noxref_2_c_371_p N_GND_M4_noxref_s ) capacitor c=0.0153553f \
 //x=9.64 //y=1.09 //x2=8.755 //y2=0.55
cc_456 ( N_noxref_2_c_337_p N_GND_M4_noxref_s ) capacitor c=0.00629878f \
 //x=9.64 //y=1.435 //x2=8.755 //y2=0.55
cc_457 ( N_noxref_2_c_344_p N_GND_M4_noxref_s ) capacitor c=0.00405173f //x=9 \
 //y=2.265 //x2=8.755 //y2=0.55
cc_458 ( N_noxref_2_c_256_p N_noxref_15_c_3758_n ) capacitor c=0.00900974f \
 //x=7.165 //y=1.835 //x2=6.595 //y2=1.675
cc_459 ( N_noxref_2_c_276_p N_noxref_15_c_3763_n ) capacitor c=0.00373013f \
 //x=7.435 //y=1.835 //x2=7.48 //y2=0.71
cc_460 ( N_noxref_2_c_246_n N_noxref_15_c_3763_n ) capacitor c=0.003751f \
 //x=7.08 //y=1.18 //x2=7.48 //y2=0.71
cc_461 ( N_noxref_2_M3_noxref_d N_noxref_15_c_3763_n ) capacitor c=0.00910163f \
 //x=6.89 //y=1.085 //x2=7.48 //y2=0.71
cc_462 ( N_noxref_2_c_232_n N_noxref_15_M2_noxref_s ) capacitor c=0.0156395f \
 //x=7.08 //y=1.75 //x2=5.49 //y2=0.545
cc_463 ( N_noxref_2_c_276_p N_noxref_15_M2_noxref_s ) capacitor c=0.00640979f \
 //x=7.435 //y=1.835 //x2=5.49 //y2=0.545
cc_464 ( N_noxref_2_c_263_p N_noxref_15_M2_noxref_s ) capacitor c=4.17069e-19 \
 //x=7.52 //y=3.67 //x2=5.49 //y2=0.545
cc_465 ( N_noxref_2_c_246_n N_noxref_15_M2_noxref_s ) capacitor c=0.00896428f \
 //x=7.08 //y=1.18 //x2=5.49 //y2=0.545
cc_466 ( N_noxref_2_c_266_p N_noxref_15_M2_noxref_s ) capacitor c=0.0010514f \
 //x=7.52 //y=3.51 //x2=5.49 //y2=0.545
cc_467 ( N_noxref_2_M3_noxref_d N_noxref_15_M2_noxref_s ) capacitor \
 c=0.0275552f //x=6.89 //y=1.085 //x2=5.49 //y2=0.545
cc_468 ( N_noxref_3_c_494_n D ) capacitor c=0.011201f //x=1.97 //y=2.985 \
 //x2=3.45 //y2=2.77
cc_469 ( N_noxref_3_c_623_p D ) capacitor c=0.00404955f //x=1.97 //y=3.305 \
 //x2=3.45 //y2=2.77
cc_470 ( N_noxref_3_c_495_n D ) capacitor c=0.0189046f //x=1.97 //y=5.055 \
 //x2=3.45 //y2=2.77
cc_471 ( N_noxref_3_c_625_p D ) capacitor c=2.03239e-19 //x=1.97 //y=3.14 \
 //x2=3.45 //y2=2.77
cc_472 ( N_noxref_3_c_516_n D ) capacitor c=0.0309026f //x=6.62 //y=3.14 \
 //x2=3.45 //y2=2.77
cc_473 ( N_noxref_3_c_627_p D ) capacitor c=0.00192158f //x=2.13 //y=3.145 \
 //x2=3.45 //y2=2.77
cc_474 ( N_noxref_3_c_495_n D ) capacitor c=0.0065873f //x=1.97 //y=5.055 \
 //x2=3.45 //y2=4.62
cc_475 ( N_noxref_3_c_568_n D ) capacitor c=0.0252075f //x=11.59 //y=2.98 \
 //x2=12.33 //y2=2.77
cc_476 ( N_noxref_3_c_630_p D ) capacitor c=0.0146933f //x=11.59 //y=3.3 \
 //x2=12.33 //y2=2.77
cc_477 ( N_noxref_3_c_631_p D ) capacitor c=6.78671e-19 //x=11.585 //y=3.14 \
 //x2=12.33 //y2=2.77
cc_478 ( N_noxref_3_c_571_n D ) capacitor c=0.0325992f //x=11.592 //y=4.74 \
 //x2=12.33 //y2=2.77
cc_479 ( N_noxref_3_c_583_n D ) capacitor c=0.00683477f //x=9.21 //y=3.125 \
 //x2=12.33 //y2=2.77
cc_480 ( N_noxref_3_c_634_p D ) capacitor c=3.49899e-19 //x=11.59 //y=2.26 \
 //x2=12.33 //y2=2.77
cc_481 ( N_noxref_3_c_571_n D ) capacitor c=0.0131852f //x=11.592 //y=4.74 \
 //x2=12.33 //y2=4.62
cc_482 ( N_noxref_3_c_636_p D ) capacitor c=3.02466e-19 //x=11.59 //y=4.88 \
 //x2=12.33 //y2=4.62
cc_483 ( N_noxref_3_c_637_p D ) capacitor c=0.00108965f //x=11.59 //y=4.88 \
 //x2=12.33 //y2=4.62
cc_484 ( N_noxref_3_c_571_n D ) capacitor c=9.19401e-19 //x=11.592 //y=4.74 \
 //x2=12.33 //y2=4.25
cc_485 ( N_noxref_3_c_495_n N_D_c_895_n ) capacitor c=0.00483937f //x=1.97 \
 //y=5.055 //x2=3.45 //y2=4.41
cc_486 ( N_noxref_3_c_516_n N_D_c_895_n ) capacitor c=0.00328691f //x=6.62 \
 //y=3.14 //x2=3.45 //y2=4.41
cc_487 ( N_noxref_3_c_495_n N_D_c_896_n ) capacitor c=0.00608903f //x=1.97 \
 //y=5.055 //x2=3.45 //y2=4.76
cc_488 ( N_noxref_3_c_571_n N_D_c_971_n ) capacitor c=0.0176705f //x=11.592 \
 //y=4.74 //x2=12.33 //y2=4.425
cc_489 ( N_noxref_3_c_643_p N_D_c_972_n ) capacitor c=0.0172958f //x=11.59 \
 //y=4.88 //x2=12.33 //y2=4.735
cc_490 ( N_noxref_3_c_636_p N_D_c_972_n ) capacitor c=4.73677e-19 //x=11.59 \
 //y=4.88 //x2=12.33 //y2=4.735
cc_491 ( N_noxref_3_c_637_p N_D_c_972_n ) capacitor c=9.22067e-19 //x=11.59 \
 //y=4.88 //x2=12.33 //y2=4.735
cc_492 ( N_noxref_3_c_494_n N_D_c_897_n ) capacitor c=0.00669852f //x=1.97 \
 //y=2.985 //x2=3.45 //y2=2.265
cc_493 ( N_noxref_3_c_516_n N_D_c_897_n ) capacitor c=0.00350231f //x=6.62 \
 //y=3.14 //x2=3.45 //y2=2.265
cc_494 ( N_noxref_3_c_648_p N_D_c_977_n ) capacitor c=0.0205342f //x=11.59 \
 //y=2.26 //x2=12.33 //y2=2.26
cc_495 ( N_noxref_3_c_634_p N_D_c_977_n ) capacitor c=5.16867e-19 //x=11.59 \
 //y=2.26 //x2=12.33 //y2=2.26
cc_496 ( N_noxref_3_c_650_p N_D_c_977_n ) capacitor c=0.00167888f //x=11.395 \
 //y=2.095 //x2=12.33 //y2=2.26
cc_497 ( N_noxref_3_c_495_n N_D_c_898_n ) capacitor c=0.0040249f //x=1.97 \
 //y=5.055 //x2=3.61 //y2=4.25
cc_498 ( N_noxref_3_c_516_n N_D_c_898_n ) capacitor c=0.00838209f //x=6.62 \
 //y=3.14 //x2=3.61 //y2=4.25
cc_499 ( N_noxref_3_c_571_n N_D_c_982_n ) capacitor c=0.00328982f //x=11.592 \
 //y=4.74 //x2=12.325 //y2=4.265
cc_500 ( N_noxref_3_c_500_n N_D_c_899_n ) capacitor c=0.00253352f //x=6.78 \
 //y=3.295 //x2=12.165 //y2=4.265
cc_501 ( N_noxref_3_c_501_n N_D_c_899_n ) capacitor c=0.0314125f //x=6.78 \
 //y=4.735 //x2=12.165 //y2=4.265
cc_502 ( N_noxref_3_c_643_p N_D_c_899_n ) capacitor c=0.00320011f //x=11.59 \
 //y=4.88 //x2=12.165 //y2=4.265
cc_503 ( N_noxref_3_c_571_n N_D_c_899_n ) capacitor c=0.0261823f //x=11.592 \
 //y=4.74 //x2=12.165 //y2=4.265
cc_504 ( N_noxref_3_c_516_n N_D_c_899_n ) capacitor c=0.0375675f //x=6.62 \
 //y=3.14 //x2=12.165 //y2=4.265
cc_505 ( N_noxref_3_c_572_n N_D_c_899_n ) capacitor c=0.00438934f //x=7.735 \
 //y=3.125 //x2=12.165 //y2=4.265
cc_506 ( N_noxref_3_c_526_n N_D_c_899_n ) capacitor c=0.0237844f //x=7.305 \
 //y=3.125 //x2=12.165 //y2=4.265
cc_507 ( N_noxref_3_c_580_n N_D_c_899_n ) capacitor c=0.00678772f //x=8.61 \
 //y=3.14 //x2=12.165 //y2=4.265
cc_508 ( N_noxref_3_c_583_n N_D_c_899_n ) capacitor c=0.0178587f //x=9.21 \
 //y=3.125 //x2=12.165 //y2=4.265
cc_509 ( N_noxref_3_c_568_n N_D_c_992_n ) capacitor c=3.49899e-19 //x=11.59 \
 //y=2.98 //x2=12.33 //y2=2.26
cc_510 ( N_noxref_3_c_648_p N_D_c_992_n ) capacitor c=5.24723e-19 //x=11.59 \
 //y=2.26 //x2=12.33 //y2=2.26
cc_511 ( N_noxref_3_c_634_p N_D_c_992_n ) capacitor c=0.00485709f //x=11.59 \
 //y=2.26 //x2=12.33 //y2=2.26
cc_512 ( N_noxref_3_c_650_p N_D_c_992_n ) capacitor c=0.00190888f //x=11.395 \
 //y=2.095 //x2=12.33 //y2=2.26
cc_513 ( N_noxref_3_c_643_p N_D_c_996_n ) capacitor c=4.80626e-19 //x=11.59 \
 //y=4.88 //x2=12.36 //y2=4.88
cc_514 ( N_noxref_3_c_636_p N_D_c_996_n ) capacitor c=0.00397338f //x=11.59 \
 //y=4.88 //x2=12.36 //y2=4.88
cc_515 ( N_noxref_3_c_637_p N_D_c_996_n ) capacitor c=0.00283894f //x=11.59 \
 //y=4.88 //x2=12.36 //y2=4.88
cc_516 ( N_noxref_3_M22_noxref_g N_D_M24_noxref_g ) capacitor c=0.0104892f \
 //x=11.49 //y=6.2 //x2=12.37 //y2=6.2
cc_517 ( N_noxref_3_M23_noxref_g N_D_M24_noxref_g ) capacitor c=0.107636f \
 //x=11.93 //y=6.2 //x2=12.37 //y2=6.2
cc_518 ( N_noxref_3_M23_noxref_g N_D_M25_noxref_g ) capacitor c=0.0100341f \
 //x=11.93 //y=6.2 //x2=12.81 //y2=6.2
cc_519 ( N_noxref_3_c_673_p N_D_c_1002_n ) capacitor c=4.86545e-19 //x=11.395 \
 //y=1.045 //x2=12.365 //y2=1.085
cc_520 ( N_noxref_3_c_674_p N_D_c_1002_n ) capacitor c=0.00152405f //x=11.395 \
 //y=1.39 //x2=12.365 //y2=1.085
cc_521 ( N_noxref_3_c_675_p N_D_c_1002_n ) capacitor c=0.0151475f //x=11.925 \
 //y=1.045 //x2=12.365 //y2=1.085
cc_522 ( N_noxref_3_c_676_p N_D_c_1005_n ) capacitor c=0.00109982f //x=11.395 \
 //y=1.7 //x2=12.365 //y2=1.43
cc_523 ( N_noxref_3_c_677_p N_D_c_1005_n ) capacitor c=0.0111064f //x=11.925 \
 //y=1.39 //x2=12.365 //y2=1.43
cc_524 ( N_noxref_3_c_676_p N_D_c_1007_n ) capacitor c=9.58243e-19 //x=11.395 \
 //y=1.7 //x2=12.365 //y2=1.74
cc_525 ( N_noxref_3_c_650_p N_D_c_1007_n ) capacitor c=0.00662747f //x=11.395 \
 //y=2.095 //x2=12.365 //y2=1.74
cc_526 ( N_noxref_3_c_677_p N_D_c_1007_n ) capacitor c=0.00862358f //x=11.925 \
 //y=1.39 //x2=12.365 //y2=1.74
cc_527 ( N_noxref_3_c_675_p N_D_c_1010_n ) capacitor c=0.00127211f //x=11.925 \
 //y=1.045 //x2=12.895 //y2=1.085
cc_528 ( N_noxref_3_c_677_p N_D_c_1011_n ) capacitor c=0.00204774f //x=11.925 \
 //y=1.39 //x2=12.895 //y2=1.43
cc_529 ( N_noxref_3_c_648_p N_D_c_1012_n ) capacitor c=0.00167305f //x=11.59 \
 //y=2.26 //x2=12.33 //y2=2.26
cc_530 ( N_noxref_3_c_634_p N_D_c_1012_n ) capacitor c=0.00266443f //x=11.59 \
 //y=2.26 //x2=12.33 //y2=2.26
cc_531 ( N_noxref_3_c_650_p N_D_c_1012_n ) capacitor c=0.0181449f //x=11.395 \
 //y=2.095 //x2=12.33 //y2=2.26
cc_532 ( N_noxref_3_c_643_p N_D_c_1015_n ) capacitor c=0.00158715f //x=11.59 \
 //y=4.88 //x2=12.36 //y2=4.88
cc_533 ( N_noxref_3_c_636_p N_D_c_1015_n ) capacitor c=0.00237977f //x=11.59 \
 //y=4.88 //x2=12.36 //y2=4.88
cc_534 ( N_noxref_3_c_637_p N_D_c_1015_n ) capacitor c=0.0297875f //x=11.59 \
 //y=4.88 //x2=12.36 //y2=4.88
cc_535 ( N_noxref_3_M23_noxref_g N_noxref_5_c_1171_n ) capacitor c=0.00967396f \
 //x=11.93 //y=6.2 //x2=12.475 //y2=5.38
cc_536 ( N_noxref_3_c_568_n N_noxref_5_c_1172_n ) capacitor c=0.00265358f \
 //x=11.59 //y=2.98 //x2=13.07 //y2=3.35
cc_537 ( N_noxref_3_c_571_n N_noxref_5_c_1173_n ) capacitor c=0.00343715f \
 //x=11.592 //y=4.74 //x2=13.07 //y2=5.295
cc_538 ( N_noxref_3_c_630_p N_noxref_5_c_1174_n ) capacitor c=4.50546e-19 \
 //x=11.59 //y=3.3 //x2=11.71 //y2=5.56
cc_539 ( N_noxref_3_c_643_p N_noxref_5_c_1174_n ) capacitor c=0.0118019f \
 //x=11.59 //y=4.88 //x2=11.71 //y2=5.56
cc_540 ( N_noxref_3_c_636_p N_noxref_5_c_1174_n ) capacitor c=0.00277154f \
 //x=11.59 //y=4.88 //x2=11.71 //y2=5.56
cc_541 ( N_noxref_3_M22_noxref_g N_noxref_5_c_1174_n ) capacitor c=0.00203628f \
 //x=11.49 //y=6.2 //x2=11.71 //y2=5.56
cc_542 ( N_noxref_3_M23_noxref_g N_noxref_5_c_1174_n ) capacitor c=0.00192712f \
 //x=11.93 //y=6.2 //x2=11.71 //y2=5.56
cc_543 ( N_noxref_3_c_637_p N_noxref_5_c_1174_n ) capacitor c=0.00198037f \
 //x=11.59 //y=4.88 //x2=11.71 //y2=5.56
cc_544 ( N_noxref_3_c_643_p N_noxref_5_c_1180_n ) capacitor c=0.00104426f \
 //x=11.59 //y=4.88 //x2=11.71 //y2=5.56
cc_545 ( N_noxref_3_c_636_p N_noxref_5_c_1180_n ) capacitor c=0.00377369f \
 //x=11.59 //y=4.88 //x2=11.71 //y2=5.56
cc_546 ( N_noxref_3_M22_noxref_g N_noxref_5_c_1180_n ) capacitor c=0.0158358f \
 //x=11.49 //y=6.2 //x2=11.71 //y2=5.56
cc_547 ( N_noxref_3_M23_noxref_g N_noxref_5_c_1180_n ) capacitor c=0.0178987f \
 //x=11.93 //y=6.2 //x2=11.71 //y2=5.56
cc_548 ( N_noxref_3_c_637_p N_noxref_5_c_1180_n ) capacitor c=0.0043218f \
 //x=11.59 //y=4.88 //x2=11.71 //y2=5.56
cc_549 ( N_noxref_3_c_583_n N_noxref_6_c_1441_n ) capacitor c=0.00973885f \
 //x=9.21 //y=3.125 //x2=9.455 //y2=2.02
cc_550 ( N_noxref_3_c_568_n N_noxref_6_c_1447_n ) capacitor c=0.00967055f \
 //x=11.59 //y=2.98 //x2=9.74 //y2=3.705
cc_551 ( N_noxref_3_c_630_p N_noxref_6_c_1447_n ) capacitor c=0.00255078f \
 //x=11.59 //y=3.3 //x2=9.74 //y2=3.705
cc_552 ( N_noxref_3_c_648_p N_noxref_6_c_1447_n ) capacitor c=0.00457386f \
 //x=11.59 //y=2.26 //x2=9.74 //y2=3.705
cc_553 ( N_noxref_3_c_571_n N_noxref_6_c_1447_n ) capacitor c=0.00709858f \
 //x=11.592 //y=4.74 //x2=9.74 //y2=3.705
cc_554 ( N_noxref_3_c_583_n N_noxref_6_c_1447_n ) capacitor c=0.0332519f \
 //x=9.21 //y=3.125 //x2=9.74 //y2=3.705
cc_555 ( N_noxref_3_c_571_n N_noxref_6_c_1456_n ) capacitor c=0.00254697f \
 //x=11.592 //y=4.74 //x2=9.74 //y2=4.025
cc_556 ( N_noxref_3_c_583_n N_noxref_6_c_1456_n ) capacitor c=0.00411752f \
 //x=9.21 //y=3.125 //x2=9.74 //y2=4.025
cc_557 ( N_noxref_3_c_643_p N_noxref_6_c_1458_n ) capacitor c=0.00476843f \
 //x=11.59 //y=4.88 //x2=9.74 //y2=5.055
cc_558 ( N_noxref_3_c_571_n N_noxref_6_c_1458_n ) capacitor c=0.00946946f \
 //x=11.592 //y=4.74 //x2=9.74 //y2=5.055
cc_559 ( N_noxref_3_c_583_n N_noxref_6_c_1463_n ) capacitor c=6.00397e-19 \
 //x=9.21 //y=3.125 //x2=9.37 //y2=1.185
cc_560 ( N_noxref_3_c_630_p N_noxref_6_c_1493_n ) capacitor c=0.00348468f \
 //x=11.59 //y=3.3 //x2=12.685 //y2=3.88
cc_561 ( N_noxref_3_c_571_n N_noxref_6_c_1493_n ) capacitor c=0.0253217f \
 //x=11.592 //y=4.74 //x2=12.685 //y2=3.88
cc_562 ( N_noxref_3_c_583_n N_noxref_6_c_1493_n ) capacitor c=0.0865898f \
 //x=9.21 //y=3.125 //x2=12.685 //y2=3.88
cc_563 ( N_noxref_3_c_571_n N_noxref_6_c_1472_n ) capacitor c=0.00159838f \
 //x=11.592 //y=4.74 //x2=9.9 //y2=3.865
cc_564 ( N_noxref_3_c_583_n N_noxref_6_c_1472_n ) capacitor c=0.0162295f \
 //x=9.21 //y=3.125 //x2=9.9 //y2=3.865
cc_565 ( N_noxref_3_c_491_n N_VDD_c_2596_n ) capacitor c=0.00259721f //x=1.605 \
 //y=5.42 //x2=17.175 //y2=7.585
cc_566 ( N_noxref_3_c_493_n N_VDD_c_2596_n ) capacitor c=0.0020016f //x=1.885 \
 //y=5.14 //x2=17.175 //y2=7.585
cc_567 ( N_noxref_3_c_643_p N_VDD_c_2596_n ) capacitor c=9.07241e-19 //x=11.59 \
 //y=4.88 //x2=17.175 //y2=7.585
cc_568 ( N_noxref_3_c_722_p N_VDD_c_2596_n ) capacitor c=0.00241566f //x=1.605 \
 //y=5.56 //x2=17.175 //y2=7.585
cc_569 ( N_noxref_3_c_636_p N_VDD_c_2596_n ) capacitor c=6.22888e-19 //x=11.59 \
 //y=4.88 //x2=17.175 //y2=7.585
cc_570 ( N_noxref_3_c_491_n N_VDD_c_2692_n ) capacitor c=0.00100699f //x=1.605 \
 //y=5.42 //x2=1.96 //y2=7.585
cc_571 ( N_noxref_3_c_493_n N_VDD_c_2692_n ) capacitor c=0.00206008f //x=1.885 \
 //y=5.14 //x2=1.96 //y2=7.585
cc_572 ( N_noxref_3_c_722_p N_VDD_c_2692_n ) capacitor c=0.0138017f //x=1.605 \
 //y=5.56 //x2=1.96 //y2=7.585
cc_573 ( N_noxref_3_M18_noxref_g N_VDD_c_2643_n ) capacitor c=0.00697352f \
 //x=6.82 //y=6.2 //x2=7.395 //y2=7.585
cc_574 ( N_noxref_3_M19_noxref_g N_VDD_c_2643_n ) capacitor c=0.00755544f \
 //x=7.26 //y=6.2 //x2=7.395 //y2=7.585
cc_575 ( N_noxref_3_c_643_p N_VDD_c_2697_n ) capacitor c=6.28113e-19 //x=11.59 \
 //y=4.88 //x2=12.065 //y2=7.585
cc_576 ( N_noxref_3_M22_noxref_g N_VDD_c_2697_n ) capacitor c=0.00732618f \
 //x=11.49 //y=6.2 //x2=12.065 //y2=7.585
cc_577 ( N_noxref_3_M23_noxref_g N_VDD_c_2697_n ) capacitor c=0.00755544f \
 //x=11.93 //y=6.2 //x2=12.065 //y2=7.585
cc_578 ( N_noxref_3_c_732_p N_VDD_c_2700_n ) capacitor c=0.00685597f //x=1.69 \
 //y=5.14 //x2=1.23 //y2=7.58
cc_579 ( N_noxref_3_c_495_n N_VDD_c_2700_n ) capacitor c=2.43252e-19 //x=1.97 \
 //y=5.055 //x2=1.23 //y2=7.58
cc_580 ( N_noxref_3_c_722_p N_VDD_c_2700_n ) capacitor c=0.00824382f //x=1.605 \
 //y=5.56 //x2=1.23 //y2=7.58
cc_581 ( N_noxref_3_c_491_n N_VDD_c_2608_n ) capacitor c=0.00217227f //x=1.605 \
 //y=5.42 //x2=2.71 //y2=7.585
cc_582 ( N_noxref_3_c_495_n N_VDD_c_2608_n ) capacitor c=0.0204045f //x=1.97 \
 //y=5.055 //x2=2.71 //y2=7.585
cc_583 ( N_noxref_3_c_516_n N_VDD_c_2608_n ) capacitor c=0.0039749f //x=6.62 \
 //y=3.14 //x2=2.71 //y2=7.585
cc_584 ( N_noxref_3_c_722_p N_VDD_c_2608_n ) capacitor c=0.00827037f //x=1.605 \
 //y=5.56 //x2=2.71 //y2=7.585
cc_585 ( N_noxref_3_c_531_n N_VDD_c_2654_n ) capacitor c=0.00226427f //x=6.81 \
 //y=4.88 //x2=8.26 //y2=7.585
cc_586 ( N_noxref_3_c_602_n N_VDD_c_2654_n ) capacitor c=0.0129375f //x=7.185 \
 //y=4.97 //x2=8.26 //y2=7.585
cc_587 ( N_noxref_3_c_550_n N_VDD_c_2654_n ) capacitor c=2.73429e-19 //x=6.81 \
 //y=4.88 //x2=8.26 //y2=7.585
cc_588 ( N_noxref_3_c_643_p N_VDD_c_2662_n ) capacitor c=0.00447349f //x=11.59 \
 //y=4.88 //x2=10.48 //y2=7.585
cc_589 ( N_noxref_3_c_571_n N_VDD_c_2662_n ) capacitor c=0.00675188f \
 //x=11.592 //y=4.74 //x2=10.48 //y2=7.585
cc_590 ( N_noxref_3_c_636_p N_VDD_c_2662_n ) capacitor c=0.00370494f //x=11.59 \
 //y=4.88 //x2=10.48 //y2=7.585
cc_591 ( N_noxref_3_c_637_p N_VDD_c_2662_n ) capacitor c=0.0121704f //x=11.59 \
 //y=4.88 //x2=10.48 //y2=7.585
cc_592 ( N_noxref_3_c_491_n N_VDD_M12_noxref_s ) capacitor c=0.0480012f \
 //x=1.605 //y=5.42 //x2=1.03 //y2=5.2
cc_593 ( N_noxref_3_c_722_p N_VDD_M12_noxref_s ) capacitor c=0.092379f \
 //x=1.605 //y=5.56 //x2=1.03 //y2=5.2
cc_594 ( N_noxref_3_c_491_n N_VDD_M13_noxref_d ) capacitor c=0.0474638f \
 //x=1.605 //y=5.42 //x2=1.9 //y2=5.2
cc_595 ( N_noxref_3_c_493_n N_VDD_M13_noxref_d ) capacitor c=0.0213944f \
 //x=1.885 //y=5.14 //x2=1.9 //y2=5.2
cc_596 ( N_noxref_3_c_623_p N_VDD_M13_noxref_d ) capacitor c=0.00186591f \
 //x=1.97 //y=3.305 //x2=1.9 //y2=5.2
cc_597 ( N_noxref_3_c_722_p N_VDD_M13_noxref_d ) capacitor c=0.0913728f \
 //x=1.605 //y=5.56 //x2=1.9 //y2=5.2
cc_598 ( N_noxref_3_c_491_n N_VDD_M14_noxref_s ) capacitor c=8.11512e-19 \
 //x=1.605 //y=5.42 //x2=3.25 //y2=5.2
cc_599 ( N_noxref_3_M18_noxref_g N_VDD_M17_noxref_d ) capacitor c=0.015318f \
 //x=6.82 //y=6.2 //x2=6.455 //y2=5.2
cc_600 ( N_noxref_3_c_550_n N_VDD_M17_noxref_d ) capacitor c=3.32552e-19 \
 //x=6.81 //y=4.88 //x2=6.455 //y2=5.2
cc_601 ( N_noxref_3_M19_noxref_g N_VDD_M19_noxref_d ) capacitor c=0.0430452f \
 //x=7.26 //y=6.2 //x2=7.335 //y2=5.2
cc_602 ( N_noxref_3_c_630_p N_VDD_M22_noxref_s ) capacitor c=8.99344e-19 \
 //x=11.59 //y=3.3 //x2=11.135 //y2=5.2
cc_603 ( N_noxref_3_M22_noxref_g N_VDD_M22_noxref_s ) capacitor c=0.0567929f \
 //x=11.49 //y=6.2 //x2=11.135 //y2=5.2
cc_604 ( N_noxref_3_M23_noxref_g N_VDD_M23_noxref_d ) capacitor c=0.015318f \
 //x=11.93 //y=6.2 //x2=12.005 //y2=5.2
cc_605 ( N_noxref_3_c_494_n GATE_N ) capacitor c=0.0245607f //x=1.97 //y=2.985 \
 //x2=1.23 //y2=2.77
cc_606 ( N_noxref_3_c_623_p GATE_N ) capacitor c=0.0149195f //x=1.97 //y=3.305 \
 //x2=1.23 //y2=2.77
cc_607 ( N_noxref_3_c_495_n GATE_N ) capacitor c=0.0666305f //x=1.97 //y=5.055 \
 //x2=1.23 //y2=2.77
cc_608 ( N_noxref_3_c_625_p GATE_N ) capacitor c=0.00548505f //x=1.97 //y=3.14 \
 //x2=1.23 //y2=2.77
cc_609 ( N_noxref_3_c_627_p GATE_N ) capacitor c=0.00686827f //x=2.13 \
 //y=3.145 //x2=1.23 //y2=2.77
cc_610 ( N_noxref_3_c_495_n N_GATE_N_c_3045_n ) capacitor c=0.0169388f \
 //x=1.97 //y=5.055 //x2=1.23 //y2=4.76
cc_611 ( N_noxref_3_c_494_n N_GATE_N_c_3046_n ) capacitor c=0.0181783f \
 //x=1.97 //y=2.985 //x2=1.23 //y2=2.265
cc_612 ( N_noxref_3_c_494_n N_GATE_N_c_3047_n ) capacitor c=4.71798e-19 \
 //x=1.97 //y=2.985 //x2=1.23 //y2=2.265
cc_613 ( N_noxref_3_c_495_n N_GATE_N_c_3048_n ) capacitor c=0.00160039f \
 //x=1.97 //y=5.055 //x2=1.23 //y2=4.88
cc_614 ( N_noxref_3_c_491_n N_GATE_N_M12_noxref_g ) capacitor c=0.00141266f \
 //x=1.605 //y=5.42 //x2=1.385 //y2=6.2
cc_615 ( N_noxref_3_c_732_p N_GATE_N_M12_noxref_g ) capacitor c=0.00534267f \
 //x=1.69 //y=5.14 //x2=1.385 //y2=6.2
cc_616 ( N_noxref_3_c_722_p N_GATE_N_M12_noxref_g ) capacitor c=0.0162066f \
 //x=1.605 //y=5.56 //x2=1.385 //y2=6.2
cc_617 ( N_noxref_3_c_491_n N_GATE_N_M13_noxref_g ) capacitor c=0.00344289f \
 //x=1.605 //y=5.42 //x2=1.825 //y2=6.2
cc_618 ( N_noxref_3_c_493_n N_GATE_N_M13_noxref_g ) capacitor c=0.0095245f \
 //x=1.885 //y=5.14 //x2=1.825 //y2=6.2
cc_619 ( N_noxref_3_c_722_p N_GATE_N_M13_noxref_g ) capacitor c=0.0162066f \
 //x=1.605 //y=5.56 //x2=1.825 //y2=6.2
cc_620 ( N_noxref_3_c_511_n N_GATE_N_c_3055_n ) capacitor c=0.00187726f \
 //x=1.6 //y=1.185 //x2=1.34 //y2=1.09
cc_621 ( N_noxref_3_M0_noxref_d N_GATE_N_c_3055_n ) capacitor c=0.00137914f \
 //x=1.415 //y=1.09 //x2=1.34 //y2=1.09
cc_622 ( N_noxref_3_c_490_n N_GATE_N_c_3057_n ) capacitor c=0.0012792f //x=1.6 \
 //y=1.935 //x2=1.34 //y2=1.435
cc_623 ( N_noxref_3_c_511_n N_GATE_N_c_3057_n ) capacitor c=0.00414335f \
 //x=1.6 //y=1.185 //x2=1.34 //y2=1.435
cc_624 ( N_noxref_3_M0_noxref_d N_GATE_N_c_3057_n ) capacitor c=0.0023891f \
 //x=1.415 //y=1.09 //x2=1.34 //y2=1.435
cc_625 ( N_noxref_3_c_490_n N_GATE_N_c_3060_n ) capacitor c=0.00561986f \
 //x=1.6 //y=1.935 //x2=1.34 //y2=1.745
cc_626 ( N_noxref_3_c_490_n N_GATE_N_c_3061_n ) capacitor c=0.00440271f \
 //x=1.6 //y=1.935 //x2=1.34 //y2=2.1
cc_627 ( N_noxref_3_c_732_p N_GATE_N_c_3062_n ) capacitor c=0.00262283f \
 //x=1.69 //y=5.14 //x2=1.75 //y2=4.97
cc_628 ( N_noxref_3_c_495_n N_GATE_N_c_3062_n ) capacitor c=0.00208891f \
 //x=1.97 //y=5.055 //x2=1.75 //y2=4.97
cc_629 ( N_noxref_3_c_722_p N_GATE_N_c_3062_n ) capacitor c=0.00290963f \
 //x=1.605 //y=5.56 //x2=1.75 //y2=4.97
cc_630 ( N_noxref_3_c_495_n N_GATE_N_c_3065_n ) capacitor c=0.00140024f \
 //x=1.97 //y=5.055 //x2=1.46 //y2=4.97
cc_631 ( N_noxref_3_c_511_n N_GATE_N_c_3066_n ) capacitor c=5.57924e-19 \
 //x=1.6 //y=1.185 //x2=1.715 //y2=0.935
cc_632 ( N_noxref_3_M0_noxref_d N_GATE_N_c_3066_n ) capacitor c=0.0020782f \
 //x=1.415 //y=1.09 //x2=1.715 //y2=0.935
cc_633 ( N_noxref_3_c_490_n N_GATE_N_c_3068_n ) capacitor c=0.00933629f \
 //x=1.6 //y=1.935 //x2=1.715 //y2=1.59
cc_634 ( N_noxref_3_c_492_n N_GATE_N_c_3068_n ) capacitor c=0.00180253f \
 //x=1.885 //y=2.02 //x2=1.715 //y2=1.59
cc_635 ( N_noxref_3_c_511_n N_GATE_N_c_3068_n ) capacitor c=5.75878e-19 \
 //x=1.6 //y=1.185 //x2=1.715 //y2=1.59
cc_636 ( N_noxref_3_M0_noxref_d N_GATE_N_c_3068_n ) capacitor c=0.00356097f \
 //x=1.415 //y=1.09 //x2=1.715 //y2=1.59
cc_637 ( N_noxref_3_c_511_n N_GATE_N_c_3072_n ) capacitor c=0.0014754f //x=1.6 \
 //y=1.185 //x2=1.87 //y2=1.09
cc_638 ( N_noxref_3_M0_noxref_d N_GATE_N_c_3072_n ) capacitor c=0.00138452f \
 //x=1.415 //y=1.09 //x2=1.87 //y2=1.09
cc_639 ( N_noxref_3_c_490_n N_GATE_N_c_3074_n ) capacitor c=0.00321841f \
 //x=1.6 //y=1.935 //x2=1.87 //y2=1.435
cc_640 ( N_noxref_3_c_511_n N_GATE_N_c_3074_n ) capacitor c=0.0034642f //x=1.6 \
 //y=1.185 //x2=1.87 //y2=1.435
cc_641 ( N_noxref_3_M0_noxref_d N_GATE_N_c_3074_n ) capacitor c=0.00235934f \
 //x=1.415 //y=1.09 //x2=1.87 //y2=1.435
cc_642 ( N_noxref_3_c_796_p N_GATE_N_c_3077_n ) capacitor c=0.00440271f \
 //x=1.685 //y=2.02 //x2=1.23 //y2=2.265
cc_643 ( N_noxref_3_c_494_n N_GATE_N_c_3077_n ) capacitor c=0.00275704f \
 //x=1.97 //y=2.985 //x2=1.23 //y2=2.265
cc_644 ( N_noxref_3_c_492_n N_GND_c_3122_n ) capacitor c=0.00499605f //x=1.885 \
 //y=2.02 //x2=6.025 //y2=0.175
cc_645 ( N_noxref_3_c_623_p N_GND_c_3122_n ) capacitor c=5.53383e-19 //x=1.97 \
 //y=3.305 //x2=6.025 //y2=0.175
cc_646 ( N_noxref_3_c_511_n N_GND_c_3122_n ) capacitor c=0.00998676f //x=1.6 \
 //y=1.185 //x2=6.025 //y2=0.175
cc_647 ( N_noxref_3_c_625_p N_GND_c_3122_n ) capacitor c=3.8564e-19 //x=1.97 \
 //y=3.14 //x2=6.025 //y2=0.175
cc_648 ( N_noxref_3_M0_noxref_d N_GND_c_3122_n ) capacitor c=0.00119455f \
 //x=1.415 //y=1.09 //x2=6.025 //y2=0.175
cc_649 ( N_noxref_3_c_500_n N_GND_c_3166_n ) capacitor c=2.39731e-19 //x=6.78 \
 //y=3.295 //x2=11.575 //y2=0.175
cc_650 ( N_noxref_3_c_512_n N_GND_c_3166_n ) capacitor c=0.00234561f //x=6.78 \
 //y=2.26 //x2=11.575 //y2=0.175
cc_651 ( N_noxref_3_c_516_n N_GND_c_3128_n ) capacitor c=0.00320181f //x=6.62 \
 //y=3.14 //x2=6.11 //y2=1.135
cc_652 ( N_noxref_3_c_648_p N_GND_c_3212_n ) capacitor c=0.00678863f //x=11.59 \
 //y=2.26 //x2=11.66 //y2=1.135
cc_653 ( N_noxref_3_c_583_n N_GND_c_3212_n ) capacitor c=0.00260869f //x=9.21 \
 //y=3.125 //x2=11.66 //y2=1.135
cc_654 ( N_noxref_3_c_634_p N_GND_c_3212_n ) capacitor c=2.13705e-19 //x=11.59 \
 //y=2.26 //x2=11.66 //y2=1.135
cc_655 ( N_noxref_3_c_673_p N_GND_c_3212_n ) capacitor c=0.00175094f \
 //x=11.395 //y=1.045 //x2=11.66 //y2=1.135
cc_656 ( N_noxref_3_c_674_p N_GND_c_3212_n ) capacitor c=0.00354198f \
 //x=11.395 //y=1.39 //x2=11.66 //y2=1.135
cc_657 ( N_noxref_3_c_676_p N_GND_c_3212_n ) capacitor c=4.2764e-19 //x=11.395 \
 //y=1.7 //x2=11.66 //y2=1.135
cc_658 ( N_noxref_3_c_812_p N_GND_c_3212_n ) capacitor c=7.35788e-19 //x=11.77 \
 //y=0.89 //x2=11.66 //y2=1.135
cc_659 ( N_noxref_3_c_813_p N_GND_c_3212_n ) capacitor c=6.38426e-19 //x=11.77 \
 //y=1.545 //x2=11.66 //y2=1.135
cc_660 ( N_noxref_3_c_675_p N_GND_c_3212_n ) capacitor c=0.00158609f \
 //x=11.925 //y=1.045 //x2=11.66 //y2=1.135
cc_661 ( N_noxref_3_c_677_p N_GND_c_3212_n ) capacitor c=0.00296337f \
 //x=11.925 //y=1.39 //x2=11.66 //y2=1.135
cc_662 ( N_noxref_3_c_673_p N_GND_c_3222_n ) capacitor c=3.51399e-19 \
 //x=11.395 //y=1.045 //x2=11.657 //y2=1.005
cc_663 ( N_noxref_3_c_812_p N_GND_c_3222_n ) capacitor c=0.00864609f //x=11.77 \
 //y=0.89 //x2=11.657 //y2=1.005
cc_664 ( N_noxref_3_c_675_p N_GND_c_3222_n ) capacitor c=4.45447e-19 \
 //x=11.925 //y=1.045 //x2=11.657 //y2=1.005
cc_665 ( N_noxref_3_c_511_n N_GND_c_3225_n ) capacitor c=0.00124813f //x=1.6 \
 //y=1.185 //x2=1.515 //y2=0.715
cc_666 ( N_noxref_3_c_492_n N_GND_c_3226_n ) capacitor c=0.00311862f //x=1.885 \
 //y=2.02 //x2=2.005 //y2=0.715
cc_667 ( N_noxref_3_c_511_n N_GND_c_3226_n ) capacitor c=0.00130539f //x=1.6 \
 //y=1.185 //x2=2.005 //y2=0.715
cc_668 ( N_noxref_3_c_625_p N_GND_c_3226_n ) capacitor c=3.38432e-19 //x=1.97 \
 //y=3.14 //x2=2.005 //y2=0.715
cc_669 ( N_noxref_3_c_512_n N_GND_c_3145_n ) capacitor c=3.77328e-19 //x=6.78 \
 //y=2.26 //x2=8.09 //y2=0.175
cc_670 ( N_noxref_3_c_673_p N_GND_c_3230_n ) capacitor c=0.00691994f \
 //x=11.395 //y=1.045 //x2=13.64 //y2=0.175
cc_671 ( N_noxref_3_c_511_n N_GND_c_3146_n ) capacitor c=2.8029e-19 //x=1.6 \
 //y=1.185 //x2=22.32 //y2=0.18
cc_672 ( N_noxref_3_c_490_n N_GND_c_3232_n ) capacitor c=0.00520602f //x=1.6 \
 //y=1.935 //x2=1.12 //y2=0.175
cc_673 ( N_noxref_3_c_494_n N_GND_c_3232_n ) capacitor c=2.14154e-19 //x=1.97 \
 //y=2.985 //x2=1.12 //y2=0.175
cc_674 ( N_noxref_3_c_492_n N_GND_c_3147_n ) capacitor c=0.0211648f //x=1.885 \
 //y=2.02 //x2=2.71 //y2=0.175
cc_675 ( N_noxref_3_c_516_n N_GND_c_3147_n ) capacitor c=0.00725442f //x=6.62 \
 //y=3.14 //x2=2.71 //y2=0.175
cc_676 ( N_noxref_3_c_516_n N_GND_c_3148_n ) capacitor c=0.00725442f //x=6.62 \
 //y=3.14 //x2=4.93 //y2=0.175
cc_677 ( N_noxref_3_c_580_n N_GND_c_3185_n ) capacitor c=0.00725442f //x=8.61 \
 //y=3.14 //x2=8.26 //y2=0.175
cc_678 ( N_noxref_3_c_527_n N_GND_c_3185_n ) capacitor c=0.00224736f //x=6.78 \
 //y=2.26 //x2=8.26 //y2=0.175
cc_679 ( N_noxref_3_c_546_n N_GND_c_3185_n ) capacitor c=0.00275184f //x=7.345 \
 //y=1.43 //x2=8.26 //y2=0.175
cc_680 ( N_noxref_3_c_547_n N_GND_c_3185_n ) capacitor c=2.63786e-19 //x=6.78 \
 //y=2.26 //x2=8.26 //y2=0.175
cc_681 ( N_noxref_3_c_568_n N_GND_c_3192_n ) capacitor c=0.00829739f //x=11.59 \
 //y=2.98 //x2=10.48 //y2=0.175
cc_682 ( N_noxref_3_c_648_p N_GND_c_3192_n ) capacitor c=0.00427323f //x=11.59 \
 //y=2.26 //x2=10.48 //y2=0.175
cc_683 ( N_noxref_3_c_583_n N_GND_c_3192_n ) capacitor c=0.00725442f //x=9.21 \
 //y=3.125 //x2=10.48 //y2=0.175
cc_684 ( N_noxref_3_c_634_p N_GND_c_3192_n ) capacitor c=0.0038607f //x=11.59 \
 //y=2.26 //x2=10.48 //y2=0.175
cc_685 ( N_noxref_3_c_650_p N_GND_c_3192_n ) capacitor c=0.00887845f \
 //x=11.395 //y=2.095 //x2=10.48 //y2=0.175
cc_686 ( N_noxref_3_c_490_n N_GND_M0_noxref_s ) capacitor c=0.0327121f //x=1.6 \
 //y=1.935 //x2=0.985 //y2=0.55
cc_687 ( N_noxref_3_c_492_n N_GND_M0_noxref_s ) capacitor c=0.0035733f \
 //x=1.885 //y=2.02 //x2=0.985 //y2=0.55
cc_688 ( N_noxref_3_c_623_p N_GND_M0_noxref_s ) capacitor c=0.00202648f \
 //x=1.97 //y=3.305 //x2=0.985 //y2=0.55
cc_689 ( N_noxref_3_c_511_n N_GND_M0_noxref_s ) capacitor c=0.0155288f //x=1.6 \
 //y=1.185 //x2=0.985 //y2=0.55
cc_690 ( N_noxref_3_c_625_p N_GND_M0_noxref_s ) capacitor c=0.00117218f \
 //x=1.97 //y=3.14 //x2=0.985 //y2=0.55
cc_691 ( N_noxref_3_M0_noxref_d N_GND_M0_noxref_s ) capacitor c=0.0377642f \
 //x=1.415 //y=1.09 //x2=0.985 //y2=0.55
cc_692 ( N_noxref_3_c_516_n N_GND_M1_noxref_s ) capacitor c=0.00325114f \
 //x=6.62 //y=3.14 //x2=3.205 //y2=0.55
cc_693 ( N_noxref_3_c_583_n N_GND_M4_noxref_s ) capacitor c=0.00310109f \
 //x=9.21 //y=3.125 //x2=8.755 //y2=0.55
cc_694 ( N_noxref_3_c_648_p N_GND_M5_noxref_d ) capacitor c=2.20438e-19 \
 //x=11.59 //y=2.26 //x2=11.47 //y2=1.045
cc_695 ( N_noxref_3_c_673_p N_GND_M5_noxref_d ) capacitor c=0.00192399f \
 //x=11.395 //y=1.045 //x2=11.47 //y2=1.045
cc_696 ( N_noxref_3_c_674_p N_GND_M5_noxref_d ) capacitor c=0.00210798f \
 //x=11.395 //y=1.39 //x2=11.47 //y2=1.045
cc_697 ( N_noxref_3_c_812_p N_GND_M5_noxref_d ) capacitor c=0.00472259f \
 //x=11.77 //y=0.89 //x2=11.47 //y2=1.045
cc_698 ( N_noxref_3_c_813_p N_GND_M5_noxref_d ) capacitor c=0.00166857f \
 //x=11.77 //y=1.545 //x2=11.47 //y2=1.045
cc_699 ( N_noxref_3_c_675_p N_GND_M5_noxref_d ) capacitor c=0.00230174f \
 //x=11.925 //y=1.045 //x2=11.47 //y2=1.045
cc_700 ( N_noxref_3_c_677_p N_GND_M5_noxref_d ) capacitor c=0.00210798f \
 //x=11.925 //y=1.39 //x2=11.47 //y2=1.045
cc_701 ( N_noxref_3_c_516_n N_noxref_15_c_3750_n ) capacitor c=0.00317601f \
 //x=6.62 //y=3.14 //x2=5.625 //y2=1.675
cc_702 ( N_noxref_3_c_516_n N_noxref_15_c_3751_n ) capacitor c=0.00987757f \
 //x=6.62 //y=3.14 //x2=6.51 //y2=1.76
cc_703 ( N_noxref_3_c_500_n N_noxref_15_c_3758_n ) capacitor c=8.09267e-19 \
 //x=6.78 //y=3.295 //x2=6.595 //y2=1.675
cc_704 ( N_noxref_3_c_512_n N_noxref_15_c_3758_n ) capacitor c=7.50092e-19 \
 //x=6.78 //y=2.26 //x2=6.595 //y2=1.675
cc_705 ( N_noxref_3_c_516_n N_noxref_15_c_3758_n ) capacitor c=0.00193667f \
 //x=6.62 //y=3.14 //x2=6.595 //y2=1.675
cc_706 ( N_noxref_3_c_542_n N_noxref_15_c_3758_n ) capacitor c=0.00888238f \
 //x=6.815 //y=1.74 //x2=6.595 //y2=1.675
cc_707 ( N_noxref_3_c_547_n N_noxref_15_c_3758_n ) capacitor c=0.0017398f \
 //x=6.78 //y=2.26 //x2=6.595 //y2=1.675
cc_708 ( N_noxref_3_c_500_n N_noxref_15_c_3763_n ) capacitor c=2.67419e-19 \
 //x=6.78 //y=3.295 //x2=7.48 //y2=0.71
cc_709 ( N_noxref_3_c_512_n N_noxref_15_c_3763_n ) capacitor c=0.001463f \
 //x=6.78 //y=2.26 //x2=7.48 //y2=0.71
cc_710 ( N_noxref_3_c_527_n N_noxref_15_c_3763_n ) capacitor c=8.82141e-19 \
 //x=6.78 //y=2.26 //x2=7.48 //y2=0.71
cc_711 ( N_noxref_3_c_537_n N_noxref_15_c_3763_n ) capacitor c=0.0200738f \
 //x=6.815 //y=1.085 //x2=7.48 //y2=0.71
cc_712 ( N_noxref_3_c_545_n N_noxref_15_c_3763_n ) capacitor c=0.00825432f \
 //x=7.345 //y=1.085 //x2=7.48 //y2=0.71
cc_713 ( N_noxref_3_c_547_n N_noxref_15_c_3763_n ) capacitor c=2.1838e-19 \
 //x=6.78 //y=2.26 //x2=7.48 //y2=0.71
cc_714 ( N_noxref_3_c_572_n N_noxref_15_M2_noxref_s ) capacitor c=5.85337e-19 \
 //x=7.735 //y=3.125 //x2=5.49 //y2=0.545
cc_715 ( N_noxref_3_c_537_n N_noxref_15_M2_noxref_s ) capacitor c=0.00888238f \
 //x=6.815 //y=1.085 //x2=5.49 //y2=0.545
cc_716 ( N_noxref_3_c_545_n N_noxref_15_M2_noxref_s ) capacitor c=0.015333f \
 //x=7.345 //y=1.085 //x2=5.49 //y2=0.545
cc_717 ( N_noxref_3_c_546_n N_noxref_15_M2_noxref_s ) capacitor c=0.00248746f \
 //x=7.345 //y=1.43 //x2=5.49 //y2=0.545
cc_718 ( N_noxref_3_c_583_n N_noxref_16_c_3817_n ) capacitor c=0.00317601f \
 //x=9.21 //y=3.125 //x2=11.175 //y2=1.675
cc_719 ( N_noxref_3_c_650_p N_noxref_16_c_3817_n ) capacitor c=0.00262672f \
 //x=11.395 //y=2.095 //x2=11.175 //y2=1.675
cc_720 ( N_noxref_3_c_630_p N_noxref_16_c_3819_n ) capacitor c=0.00452128f \
 //x=11.59 //y=3.3 //x2=12.06 //y2=1.76
cc_721 ( N_noxref_3_c_648_p N_noxref_16_c_3819_n ) capacitor c=0.00509504f \
 //x=11.59 //y=2.26 //x2=12.06 //y2=1.76
cc_722 ( N_noxref_3_c_583_n N_noxref_16_c_3819_n ) capacitor c=0.00118517f \
 //x=9.21 //y=3.125 //x2=12.06 //y2=1.76
cc_723 ( N_noxref_3_c_634_p N_noxref_16_c_3819_n ) capacitor c=0.00763108f \
 //x=11.59 //y=2.26 //x2=12.06 //y2=1.76
cc_724 ( N_noxref_3_c_676_p N_noxref_16_c_3819_n ) capacitor c=0.00697076f \
 //x=11.395 //y=1.7 //x2=12.06 //y2=1.76
cc_725 ( N_noxref_3_c_650_p N_noxref_16_c_3819_n ) capacitor c=0.0174138f \
 //x=11.395 //y=2.095 //x2=12.06 //y2=1.76
cc_726 ( N_noxref_3_c_813_p N_noxref_16_c_3819_n ) capacitor c=0.00723574f \
 //x=11.77 //y=1.545 //x2=12.06 //y2=1.76
cc_727 ( N_noxref_3_c_677_p N_noxref_16_c_3819_n ) capacitor c=0.00339872f \
 //x=11.925 //y=1.39 //x2=12.06 //y2=1.76
cc_728 ( N_noxref_3_c_650_p N_noxref_16_c_3827_n ) capacitor c=6.71402e-19 \
 //x=11.395 //y=2.095 //x2=12.145 //y2=1.675
cc_729 ( N_noxref_3_c_673_p N_noxref_16_M5_noxref_s ) capacitor c=0.0294925f \
 //x=11.395 //y=1.045 //x2=11.04 //y2=0.545
cc_730 ( N_noxref_3_c_676_p N_noxref_16_M5_noxref_s ) capacitor c=3.48408e-19 \
 //x=11.395 //y=1.7 //x2=11.04 //y2=0.545
cc_731 ( N_noxref_3_c_675_p N_noxref_16_M5_noxref_s ) capacitor c=0.0125442f \
 //x=11.925 //y=1.045 //x2=11.04 //y2=0.545
cc_732 ( N_D_c_971_n N_noxref_5_c_1171_n ) capacitor c=0.00424872f //x=12.33 \
 //y=4.425 //x2=12.475 //y2=5.38
cc_733 ( N_D_c_972_n N_noxref_5_c_1171_n ) capacitor c=0.0222361f //x=12.33 \
 //y=4.735 //x2=12.475 //y2=5.38
cc_734 ( N_D_c_982_n N_noxref_5_c_1171_n ) capacitor c=0.00128868f //x=12.325 \
 //y=4.265 //x2=12.475 //y2=5.38
cc_735 ( N_D_c_899_n N_noxref_5_c_1171_n ) capacitor c=0.00149414f //x=12.165 \
 //y=4.265 //x2=12.475 //y2=5.38
cc_736 ( N_D_c_996_n N_noxref_5_c_1171_n ) capacitor c=0.00469257f //x=12.36 \
 //y=4.88 //x2=12.475 //y2=5.38
cc_737 ( N_D_M24_noxref_g N_noxref_5_c_1171_n ) capacitor c=0.00842859f \
 //x=12.37 //y=6.2 //x2=12.475 //y2=5.38
cc_738 ( N_D_c_1015_n N_noxref_5_c_1171_n ) capacitor c=8.40673e-19 //x=12.36 \
 //y=4.88 //x2=12.475 //y2=5.38
cc_739 ( N_D_c_1005_n N_noxref_5_c_1192_n ) capacitor c=0.00118531f //x=12.365 \
 //y=1.43 //x2=12.63 //y2=1.75
cc_740 ( N_D_c_1007_n N_noxref_5_c_1192_n ) capacitor c=0.00437687f //x=12.365 \
 //y=1.74 //x2=12.63 //y2=1.75
cc_741 ( N_D_c_1027_p N_noxref_5_c_1192_n ) capacitor c=0.00897029f //x=12.74 \
 //y=1.585 //x2=12.63 //y2=1.75
cc_742 ( N_D_c_1011_n N_noxref_5_c_1192_n ) capacitor c=0.00303393f //x=12.895 \
 //y=1.43 //x2=12.63 //y2=1.75
cc_743 ( N_D_c_1029_p N_noxref_5_c_1192_n ) capacitor c=0.00348382f //x=12.33 \
 //y=2.095 //x2=12.63 //y2=1.75
cc_744 ( N_D_M25_noxref_g N_noxref_5_c_1197_n ) capacitor c=0.0112687f \
 //x=12.81 //y=6.2 //x2=12.985 //y2=5.38
cc_745 ( N_D_c_1027_p N_noxref_5_c_1198_n ) capacitor c=0.00194324f //x=12.74 \
 //y=1.585 //x2=12.985 //y2=1.835
cc_746 ( N_D_c_1011_n N_noxref_5_c_1198_n ) capacitor c=0.00323005f //x=12.895 \
 //y=1.43 //x2=12.985 //y2=1.835
cc_747 ( D N_noxref_5_c_1172_n ) capacitor c=0.0415076f //x=12.33 //y=2.77 \
 //x2=13.07 //y2=3.35
cc_748 ( N_D_c_977_n N_noxref_5_c_1172_n ) capacitor c=0.015397f //x=12.33 \
 //y=2.26 //x2=13.07 //y2=3.35
cc_749 ( N_D_c_992_n N_noxref_5_c_1172_n ) capacitor c=9.90728e-19 //x=12.33 \
 //y=2.26 //x2=13.07 //y2=3.35
cc_750 ( N_D_c_1012_n N_noxref_5_c_1172_n ) capacitor c=0.00281392f //x=12.33 \
 //y=2.26 //x2=13.07 //y2=3.35
cc_751 ( N_D_c_1029_p N_noxref_5_c_1172_n ) capacitor c=0.00309521f //x=12.33 \
 //y=2.095 //x2=13.07 //y2=3.35
cc_752 ( D N_noxref_5_c_1205_n ) capacitor c=0.0148501f //x=12.33 //y=2.77 \
 //x2=13.07 //y2=3.67
cc_753 ( D N_noxref_5_c_1173_n ) capacitor c=0.0170969f //x=12.33 //y=2.77 \
 //x2=13.07 //y2=5.295
cc_754 ( D N_noxref_5_c_1173_n ) capacitor c=0.01289f //x=12.33 //y=4.62 \
 //x2=13.07 //y2=5.295
cc_755 ( D N_noxref_5_c_1173_n ) capacitor c=6.77171e-19 //x=12.33 //y=4.25 \
 //x2=13.07 //y2=5.295
cc_756 ( N_D_c_971_n N_noxref_5_c_1173_n ) capacitor c=0.014956f //x=12.33 \
 //y=4.425 //x2=13.07 //y2=5.295
cc_757 ( N_D_c_972_n N_noxref_5_c_1173_n ) capacitor c=0.016905f //x=12.33 \
 //y=4.735 //x2=13.07 //y2=5.295
cc_758 ( N_D_c_982_n N_noxref_5_c_1173_n ) capacitor c=0.0068343f //x=12.325 \
 //y=4.265 //x2=13.07 //y2=5.295
cc_759 ( N_D_c_996_n N_noxref_5_c_1173_n ) capacitor c=7.76118e-19 //x=12.36 \
 //y=4.88 //x2=13.07 //y2=5.295
cc_760 ( N_D_c_1046_p N_noxref_5_c_1173_n ) capacitor c=0.0084741f //x=12.735 \
 //y=4.97 //x2=13.07 //y2=5.295
cc_761 ( N_D_c_1015_n N_noxref_5_c_1173_n ) capacitor c=0.00142201f //x=12.36 \
 //y=4.88 //x2=13.07 //y2=5.295
cc_762 ( D N_noxref_5_c_1215_n ) capacitor c=0.00255565f //x=12.33 //y=2.77 \
 //x2=14.55 //y2=3.35
cc_763 ( D N_noxref_5_c_1216_n ) capacitor c=3.37262e-19 //x=12.33 //y=2.77 \
 //x2=14.55 //y2=4.76
cc_764 ( D N_noxref_5_c_1216_n ) capacitor c=0.00105982f //x=12.33 //y=4.62 \
 //x2=14.55 //y2=4.76
cc_765 ( N_D_c_899_n N_noxref_5_c_1174_n ) capacitor c=0.0134013f //x=12.165 \
 //y=4.265 //x2=11.71 //y2=5.56
cc_766 ( N_D_M24_noxref_g N_noxref_5_c_1219_n ) capacitor c=0.00192712f \
 //x=12.37 //y=6.2 //x2=12.59 //y2=5.38
cc_767 ( N_D_M25_noxref_g N_noxref_5_c_1219_n ) capacitor c=0.00291595f \
 //x=12.81 //y=6.2 //x2=12.59 //y2=5.38
cc_768 ( N_D_c_1046_p N_noxref_5_c_1219_n ) capacitor c=0.0020909f //x=12.735 \
 //y=4.97 //x2=12.59 //y2=5.38
cc_769 ( N_D_c_1002_n N_noxref_5_c_1222_n ) capacitor c=0.00120406f //x=12.365 \
 //y=1.085 //x2=12.63 //y2=1.18
cc_770 ( N_D_c_1005_n N_noxref_5_c_1222_n ) capacitor c=0.00218558f //x=12.365 \
 //y=1.43 //x2=12.63 //y2=1.18
cc_771 ( N_D_c_1057_p N_noxref_5_c_1222_n ) capacitor c=5.50523e-19 //x=12.74 \
 //y=0.93 //x2=12.63 //y2=1.18
cc_772 ( N_D_c_1027_p N_noxref_5_c_1222_n ) capacitor c=5.67071e-19 //x=12.74 \
 //y=1.585 //x2=12.63 //y2=1.18
cc_773 ( N_D_c_1010_n N_noxref_5_c_1222_n ) capacitor c=0.00109715f //x=12.895 \
 //y=1.085 //x2=12.63 //y2=1.18
cc_774 ( N_D_c_1011_n N_noxref_5_c_1222_n ) capacitor c=0.00312043f //x=12.895 \
 //y=1.43 //x2=12.63 //y2=1.18
cc_775 ( D N_noxref_5_c_1228_n ) capacitor c=6.03895e-19 //x=12.33 //y=2.77 \
 //x2=13.07 //y2=3.51
cc_776 ( D N_noxref_5_c_1229_n ) capacitor c=0.00687742f //x=12.33 //y=2.77 \
 //x2=13.23 //y2=3.51
cc_777 ( N_D_M24_noxref_g N_noxref_5_c_1230_n ) capacitor c=0.0178987f \
 //x=12.37 //y=6.2 //x2=12.59 //y2=5.56
cc_778 ( N_D_M25_noxref_g N_noxref_5_c_1230_n ) capacitor c=0.0178506f \
 //x=12.81 //y=6.2 //x2=12.59 //y2=5.56
cc_779 ( N_D_c_1046_p N_noxref_5_c_1230_n ) capacitor c=0.00291714f //x=12.735 \
 //y=4.97 //x2=12.59 //y2=5.56
cc_780 ( N_D_c_1002_n N_noxref_5_M6_noxref_d ) capacitor c=0.00137165f \
 //x=12.365 //y=1.085 //x2=12.44 //y2=1.085
cc_781 ( N_D_c_1005_n N_noxref_5_M6_noxref_d ) capacitor c=0.00237422f \
 //x=12.365 //y=1.43 //x2=12.44 //y2=1.085
cc_782 ( N_D_c_1057_p N_noxref_5_M6_noxref_d ) capacitor c=0.0020782f \
 //x=12.74 //y=0.93 //x2=12.44 //y2=1.085
cc_783 ( N_D_c_1027_p N_noxref_5_M6_noxref_d ) capacitor c=0.00356097f \
 //x=12.74 //y=1.585 //x2=12.44 //y2=1.085
cc_784 ( N_D_c_1010_n N_noxref_5_M6_noxref_d ) capacitor c=8.50095e-19 \
 //x=12.895 //y=1.085 //x2=12.44 //y2=1.085
cc_785 ( N_D_c_1011_n N_noxref_5_M6_noxref_d ) capacitor c=0.00237422f \
 //x=12.895 //y=1.43 //x2=12.44 //y2=1.085
cc_786 ( N_D_c_899_n N_noxref_6_c_1436_n ) capacitor c=7.51869e-19 //x=12.165 \
 //y=4.265 //x2=9.375 //y2=5.42
cc_787 ( N_D_c_899_n N_noxref_6_c_1444_n ) capacitor c=0.0123652f //x=12.165 \
 //y=4.265 //x2=9.46 //y2=5.14
cc_788 ( D N_noxref_6_c_1447_n ) capacitor c=0.00394453f //x=12.33 //y=2.77 \
 //x2=9.74 //y2=3.705
cc_789 ( N_D_c_899_n N_noxref_6_c_1456_n ) capacitor c=0.00670349f //x=12.165 \
 //y=4.265 //x2=9.74 //y2=4.025
cc_790 ( D N_noxref_6_c_1458_n ) capacitor c=0.00130061f //x=12.33 //y=4.62 \
 //x2=9.74 //y2=5.055
cc_791 ( N_D_c_899_n N_noxref_6_c_1458_n ) capacitor c=0.0275267f //x=12.165 \
 //y=4.265 //x2=9.74 //y2=5.055
cc_792 ( D N_noxref_6_c_1493_n ) capacitor c=0.0258513f //x=12.33 //y=2.77 \
 //x2=12.685 //y2=3.88
cc_793 ( N_D_c_971_n N_noxref_6_c_1493_n ) capacitor c=0.00653372f //x=12.33 \
 //y=4.425 //x2=12.685 //y2=3.88
cc_794 ( N_D_c_977_n N_noxref_6_c_1493_n ) capacitor c=0.00160813f //x=12.33 \
 //y=2.26 //x2=12.685 //y2=3.88
cc_795 ( N_D_c_982_n N_noxref_6_c_1493_n ) capacitor c=0.0374977f //x=12.325 \
 //y=4.265 //x2=12.685 //y2=3.88
cc_796 ( N_D_c_899_n N_noxref_6_c_1493_n ) capacitor c=0.206335f //x=12.165 \
 //y=4.265 //x2=12.685 //y2=3.88
cc_797 ( N_D_c_899_n N_noxref_6_c_1472_n ) capacitor c=0.0365231f //x=12.165 \
 //y=4.265 //x2=9.9 //y2=3.865
cc_798 ( D N_noxref_8_c_2032_n ) capacitor c=2.47942e-19 //x=12.33 //y=4.25 \
 //x2=15.29 //y2=4.25
cc_799 ( N_D_c_895_n N_VDD_c_2596_n ) capacitor c=3.15774e-19 //x=3.45 \
 //y=4.41 //x2=17.175 //y2=7.585
cc_800 ( N_D_c_896_n N_VDD_c_2596_n ) capacitor c=5.73169e-19 //x=3.45 \
 //y=4.76 //x2=17.175 //y2=7.585
cc_801 ( N_D_c_910_n N_VDD_c_2596_n ) capacitor c=3.40755e-19 //x=3.45 \
 //y=4.88 //x2=17.175 //y2=7.585
cc_802 ( N_D_c_895_n N_VDD_c_2602_n ) capacitor c=2.9011e-19 //x=3.45 //y=4.41 \
 //x2=4.18 //y2=7.585
cc_803 ( N_D_c_896_n N_VDD_c_2602_n ) capacitor c=5.48929e-19 //x=3.45 \
 //y=4.76 //x2=4.18 //y2=7.585
cc_804 ( N_D_M14_noxref_g N_VDD_c_2602_n ) capacitor c=0.00753931f //x=3.605 \
 //y=6.2 //x2=4.18 //y2=7.585
cc_805 ( N_D_M15_noxref_g N_VDD_c_2602_n ) capacitor c=0.00755544f //x=4.045 \
 //y=6.2 //x2=4.18 //y2=7.585
cc_806 ( N_D_M24_noxref_g N_VDD_c_2734_n ) capacitor c=0.00697352f //x=12.37 \
 //y=6.2 //x2=12.945 //y2=7.585
cc_807 ( N_D_M25_noxref_g N_VDD_c_2734_n ) capacitor c=0.00755544f //x=12.81 \
 //y=6.2 //x2=12.945 //y2=7.585
cc_808 ( D N_VDD_c_2608_n ) capacitor c=0.00706931f //x=3.45 //y=4.62 \
 //x2=2.71 //y2=7.585
cc_809 ( D N_VDD_c_2608_n ) capacitor c=0.00480807f //x=3.45 //y=4.25 \
 //x2=2.71 //y2=7.585
cc_810 ( N_D_c_895_n N_VDD_c_2608_n ) capacitor c=0.00158408f //x=3.45 \
 //y=4.41 //x2=2.71 //y2=7.585
cc_811 ( N_D_c_896_n N_VDD_c_2608_n ) capacitor c=0.00581275f //x=3.45 \
 //y=4.76 //x2=2.71 //y2=7.585
cc_812 ( N_D_c_910_n N_VDD_c_2608_n ) capacitor c=0.00795272f //x=3.45 \
 //y=4.88 //x2=2.71 //y2=7.585
cc_813 ( N_D_M14_noxref_g N_VDD_c_2608_n ) capacitor c=0.00634455f //x=3.605 \
 //y=6.2 //x2=2.71 //y2=7.585
cc_814 ( N_D_c_928_n N_VDD_c_2608_n ) capacitor c=0.00799922f //x=3.68 \
 //y=4.97 //x2=2.71 //y2=7.585
cc_815 ( D N_VDD_c_2610_n ) capacitor c=0.00133334f //x=3.45 //y=4.25 \
 //x2=4.93 //y2=7.585
cc_816 ( N_D_c_899_n N_VDD_c_2610_n ) capacitor c=0.0194436f //x=12.165 \
 //y=4.265 //x2=4.93 //y2=7.585
cc_817 ( N_D_c_910_n N_VDD_c_2610_n ) capacitor c=0.00241457f //x=3.45 \
 //y=4.88 //x2=4.93 //y2=7.585
cc_818 ( N_D_c_924_n N_VDD_c_2610_n ) capacitor c=0.00780996f //x=3.97 \
 //y=4.97 //x2=4.93 //y2=7.585
cc_819 ( N_D_c_899_n N_VDD_c_2654_n ) capacitor c=0.0196363f //x=12.165 \
 //y=4.265 //x2=8.26 //y2=7.585
cc_820 ( D N_VDD_c_2662_n ) capacitor c=8.50173e-19 //x=12.33 //y=4.25 \
 //x2=10.48 //y2=7.585
cc_821 ( N_D_c_899_n N_VDD_c_2662_n ) capacitor c=0.0194487f //x=12.165 \
 //y=4.265 //x2=10.48 //y2=7.585
cc_822 ( D N_VDD_c_2750_n ) capacitor c=0.00143727f //x=12.33 //y=4.25 \
 //x2=13.81 //y2=7.585
cc_823 ( N_D_c_996_n N_VDD_c_2750_n ) capacitor c=0.00226427f //x=12.36 \
 //y=4.88 //x2=13.81 //y2=7.585
cc_824 ( N_D_c_1046_p N_VDD_c_2750_n ) capacitor c=0.0129375f //x=12.735 \
 //y=4.97 //x2=13.81 //y2=7.585
cc_825 ( N_D_c_1015_n N_VDD_c_2750_n ) capacitor c=2.73429e-19 //x=12.36 \
 //y=4.88 //x2=13.81 //y2=7.585
cc_826 ( N_D_c_895_n N_VDD_M14_noxref_s ) capacitor c=0.00210928f //x=3.45 \
 //y=4.41 //x2=3.25 //y2=5.2
cc_827 ( N_D_c_896_n N_VDD_M14_noxref_s ) capacitor c=0.0208738f //x=3.45 \
 //y=4.76 //x2=3.25 //y2=5.2
cc_828 ( N_D_c_898_n N_VDD_M14_noxref_s ) capacitor c=6.57934e-19 //x=3.61 \
 //y=4.25 //x2=3.25 //y2=5.2
cc_829 ( N_D_c_910_n N_VDD_M14_noxref_s ) capacitor c=0.00986169f //x=3.45 \
 //y=4.88 //x2=3.25 //y2=5.2
cc_830 ( N_D_M14_noxref_g N_VDD_M14_noxref_s ) capacitor c=0.0573441f \
 //x=3.605 //y=6.2 //x2=3.25 //y2=5.2
cc_831 ( N_D_c_928_n N_VDD_M14_noxref_s ) capacitor c=0.00531767f //x=3.68 \
 //y=4.97 //x2=3.25 //y2=5.2
cc_832 ( N_D_c_899_n N_VDD_M15_noxref_d ) capacitor c=0.00224347f //x=12.165 \
 //y=4.265 //x2=4.12 //y2=5.2
cc_833 ( N_D_M15_noxref_g N_VDD_M15_noxref_d ) capacitor c=0.0572684f \
 //x=4.045 //y=6.2 //x2=4.12 //y2=5.2
cc_834 ( N_D_c_899_n N_VDD_M16_noxref_s ) capacitor c=0.00542893f //x=12.165 \
 //y=4.265 //x2=5.585 //y2=5.2
cc_835 ( N_D_c_899_n N_VDD_M20_noxref_s ) capacitor c=0.00130658f //x=12.165 \
 //y=4.265 //x2=8.8 //y2=5.2
cc_836 ( N_D_c_899_n N_VDD_M21_noxref_d ) capacitor c=0.00224242f //x=12.165 \
 //y=4.265 //x2=9.67 //y2=5.2
cc_837 ( N_D_c_899_n N_VDD_M22_noxref_s ) capacitor c=0.00564089f //x=12.165 \
 //y=4.265 //x2=11.135 //y2=5.2
cc_838 ( N_D_M24_noxref_g N_VDD_M23_noxref_d ) capacitor c=0.015318f //x=12.37 \
 //y=6.2 //x2=12.005 //y2=5.2
cc_839 ( N_D_c_1015_n N_VDD_M23_noxref_d ) capacitor c=3.50465e-19 //x=12.36 \
 //y=4.88 //x2=12.005 //y2=5.2
cc_840 ( N_D_M25_noxref_g N_VDD_M25_noxref_d ) capacitor c=0.0430452f \
 //x=12.81 //y=6.2 //x2=12.885 //y2=5.2
cc_841 ( D GATE_N ) capacitor c=0.00422401f //x=3.45 //y=2.77 //x2=1.23 \
 //y2=2.77
cc_842 ( D GATE_N ) capacitor c=0.00111139f //x=3.45 //y=4.62 //x2=1.23 \
 //y2=2.77
cc_843 ( N_D_c_895_n N_GND_c_3122_n ) capacitor c=2.92641e-19 //x=3.45 \
 //y=4.41 //x2=6.025 //y2=0.175
cc_844 ( N_D_c_897_n N_GND_c_3122_n ) capacitor c=0.00249122f //x=3.45 \
 //y=2.265 //x2=6.025 //y2=0.175
cc_845 ( N_D_c_909_n N_GND_c_3122_n ) capacitor c=7.5371e-19 //x=3.45 \
 //y=2.265 //x2=6.025 //y2=0.175
cc_846 ( N_D_c_971_n N_GND_c_3264_n ) capacitor c=2.61326e-19 //x=12.33 \
 //y=4.425 //x2=22.32 //y2=0.18
cc_847 ( N_D_c_977_n N_GND_c_3264_n ) capacitor c=0.00234561f //x=12.33 \
 //y=2.26 //x2=22.32 //y2=0.18
cc_848 ( N_D_c_897_n N_GND_c_3141_n ) capacitor c=0.00114179f //x=3.45 \
 //y=2.265 //x2=3.735 //y2=0.715
cc_849 ( N_D_c_909_n N_GND_c_3141_n ) capacitor c=3.95714e-19 //x=3.45 \
 //y=2.265 //x2=3.735 //y2=0.715
cc_850 ( N_D_c_917_n N_GND_c_3141_n ) capacitor c=0.0125549f //x=3.56 //y=1.09 \
 //x2=3.735 //y2=0.715
cc_851 ( N_D_c_940_n N_GND_c_3141_n ) capacitor c=2.1838e-19 //x=3.45 \
 //y=2.265 //x2=3.735 //y2=0.715
cc_852 ( N_D_c_935_n N_GND_c_3142_n ) capacitor c=0.0132772f //x=4.09 //y=1.09 \
 //x2=4.225 //y2=0.715
cc_853 ( N_D_c_977_n N_GND_c_3230_n ) capacitor c=3.77328e-19 //x=12.33 \
 //y=2.26 //x2=13.64 //y2=0.175
cc_854 ( D N_GND_c_3147_n ) capacitor c=0.0103129f //x=3.45 //y=2.77 //x2=2.71 \
 //y2=0.175
cc_855 ( N_D_c_897_n N_GND_c_3147_n ) capacitor c=0.00682461f //x=3.45 \
 //y=2.265 //x2=2.71 //y2=0.175
cc_856 ( N_D_c_909_n N_GND_c_3147_n ) capacitor c=0.00788913f //x=3.45 \
 //y=2.265 //x2=2.71 //y2=0.175
cc_857 ( N_D_c_923_n N_GND_c_3147_n ) capacitor c=0.00344321f //x=3.56 //y=2.1 \
 //x2=2.71 //y2=0.175
cc_858 ( N_D_c_940_n N_GND_c_3147_n ) capacitor c=0.00687518f //x=3.45 \
 //y=2.265 //x2=2.71 //y2=0.175
cc_859 ( N_D_c_909_n N_GND_c_3148_n ) capacitor c=0.0022444f //x=3.45 \
 //y=2.265 //x2=4.93 //y2=0.175
cc_860 ( N_D_c_940_n N_GND_c_3148_n ) capacitor c=2.63786e-19 //x=3.45 \
 //y=2.265 //x2=4.93 //y2=0.175
cc_861 ( N_D_c_992_n N_GND_c_3279_n ) capacitor c=0.00231028f //x=12.33 \
 //y=2.26 //x2=13.81 //y2=0.175
cc_862 ( N_D_c_1011_n N_GND_c_3279_n ) capacitor c=0.00275184f //x=12.895 \
 //y=1.43 //x2=13.81 //y2=0.175
cc_863 ( N_D_c_895_n N_GND_M1_noxref_s ) capacitor c=2.54885e-19 //x=3.45 \
 //y=4.41 //x2=3.205 //y2=0.55
cc_864 ( N_D_c_897_n N_GND_M1_noxref_s ) capacitor c=0.00297876f //x=3.45 \
 //y=2.265 //x2=3.205 //y2=0.55
cc_865 ( N_D_c_909_n N_GND_M1_noxref_s ) capacitor c=0.00476545f //x=3.45 \
 //y=2.265 //x2=3.205 //y2=0.55
cc_866 ( N_D_c_917_n N_GND_M1_noxref_s ) capacitor c=0.0300221f //x=3.56 \
 //y=1.09 //x2=3.205 //y2=0.55
cc_867 ( N_D_c_922_n N_GND_M1_noxref_s ) capacitor c=0.002132f //x=3.56 \
 //y=1.745 //x2=3.205 //y2=0.55
cc_868 ( N_D_c_923_n N_GND_M1_noxref_s ) capacitor c=0.00304786f //x=3.56 \
 //y=2.1 //x2=3.205 //y2=0.55
cc_869 ( N_D_c_929_n N_GND_M1_noxref_s ) capacitor c=0.00517463f //x=3.935 \
 //y=0.935 //x2=3.205 //y2=0.55
cc_870 ( N_D_c_935_n N_GND_M1_noxref_s ) capacitor c=0.0153553f //x=4.09 \
 //y=1.09 //x2=3.205 //y2=0.55
cc_871 ( N_D_c_937_n N_GND_M1_noxref_s ) capacitor c=0.00629878f //x=4.09 \
 //y=1.435 //x2=3.205 //y2=0.55
cc_872 ( N_D_c_940_n N_GND_M1_noxref_s ) capacitor c=0.00660555f //x=3.45 \
 //y=2.265 //x2=3.205 //y2=0.55
cc_873 ( N_D_c_971_n N_noxref_16_c_3827_n ) capacitor c=9.56559e-19 //x=12.33 \
 //y=4.425 //x2=12.145 //y2=1.675
cc_874 ( N_D_c_977_n N_noxref_16_c_3827_n ) capacitor c=7.50092e-19 //x=12.33 \
 //y=2.26 //x2=12.145 //y2=1.675
cc_875 ( N_D_c_1007_n N_noxref_16_c_3827_n ) capacitor c=0.00888238f \
 //x=12.365 //y=1.74 //x2=12.145 //y2=1.675
cc_876 ( N_D_c_1012_n N_noxref_16_c_3827_n ) capacitor c=0.00175171f //x=12.33 \
 //y=2.26 //x2=12.145 //y2=1.675
cc_877 ( N_D_c_977_n N_noxref_16_c_3835_n ) capacitor c=0.00141156f //x=12.33 \
 //y=2.26 //x2=13.03 //y2=0.71
cc_878 ( N_D_c_992_n N_noxref_16_c_3835_n ) capacitor c=8.82141e-19 //x=12.33 \
 //y=2.26 //x2=13.03 //y2=0.71
cc_879 ( N_D_c_1002_n N_noxref_16_c_3835_n ) capacitor c=0.0199501f //x=12.365 \
 //y=1.085 //x2=13.03 //y2=0.71
cc_880 ( N_D_c_1010_n N_noxref_16_c_3835_n ) capacitor c=0.00825432f \
 //x=12.895 //y=1.085 //x2=13.03 //y2=0.71
cc_881 ( N_D_c_1012_n N_noxref_16_c_3835_n ) capacitor c=2.1838e-19 //x=12.33 \
 //y=2.26 //x2=13.03 //y2=0.71
cc_882 ( N_D_c_1002_n N_noxref_16_M5_noxref_s ) capacitor c=0.00888238f \
 //x=12.365 //y=1.085 //x2=11.04 //y2=0.545
cc_883 ( N_D_c_1010_n N_noxref_16_M5_noxref_s ) capacitor c=0.015333f \
 //x=12.895 //y=1.085 //x2=11.04 //y2=0.545
cc_884 ( N_D_c_1011_n N_noxref_16_M5_noxref_s ) capacitor c=0.00248746f \
 //x=12.895 //y=1.43 //x2=11.04 //y2=0.545
cc_885 ( N_noxref_5_c_1192_n N_noxref_6_c_1429_n ) capacitor c=0.00498121f \
 //x=12.63 //y=1.75 //x2=9.37 //y2=1.935
cc_886 ( N_noxref_5_c_1173_n N_noxref_6_c_1436_n ) capacitor c=6.68558e-19 \
 //x=13.07 //y=5.295 //x2=9.375 //y2=5.42
cc_887 ( N_noxref_5_c_1174_n N_noxref_6_c_1436_n ) capacitor c=6.16426e-19 \
 //x=11.71 //y=5.56 //x2=9.375 //y2=5.42
cc_888 ( N_noxref_5_c_1172_n N_noxref_6_c_1440_n ) capacitor c=0.00198687f \
 //x=13.07 //y=3.35 //x2=9.655 //y2=2.02
cc_889 ( N_noxref_5_c_1173_n N_noxref_6_c_1458_n ) capacitor c=0.00217431f \
 //x=13.07 //y=5.295 //x2=9.74 //y2=5.055
cc_890 ( N_noxref_5_c_1215_n N_noxref_6_c_1515_n ) capacitor c=0.00208723f \
 //x=14.55 //y=3.35 //x2=17.14 //y2=3.705
cc_891 ( N_noxref_5_c_1216_n N_noxref_6_c_1516_n ) capacitor c=0.00207736f \
 //x=14.55 //y=4.76 //x2=17.14 //y2=4.765
cc_892 ( N_noxref_5_c_1192_n N_noxref_6_c_1463_n ) capacitor c=4.16137e-19 \
 //x=12.63 //y=1.75 //x2=9.37 //y2=1.185
cc_893 ( N_noxref_5_c_1222_n N_noxref_6_c_1463_n ) capacitor c=6.80839e-19 \
 //x=12.63 //y=1.18 //x2=9.37 //y2=1.185
cc_894 ( N_noxref_5_c_1197_n N_noxref_6_c_1493_n ) capacitor c=0.00576241f \
 //x=12.985 //y=5.38 //x2=12.685 //y2=3.88
cc_895 ( N_noxref_5_c_1198_n N_noxref_6_c_1493_n ) capacitor c=0.00188982f \
 //x=12.985 //y=1.835 //x2=12.685 //y2=3.88
cc_896 ( N_noxref_5_c_1250_p N_noxref_6_c_1493_n ) capacitor c=0.003151f \
 //x=12.715 //y=1.835 //x2=12.685 //y2=3.88
cc_897 ( N_noxref_5_c_1205_n N_noxref_6_c_1493_n ) capacitor c=0.0013831f \
 //x=13.07 //y=3.67 //x2=12.685 //y2=3.88
cc_898 ( N_noxref_5_c_1173_n N_noxref_6_c_1493_n ) capacitor c=3.11404e-19 \
 //x=13.07 //y=5.295 //x2=12.685 //y2=3.88
cc_899 ( N_noxref_5_c_1219_n N_noxref_6_c_1493_n ) capacitor c=0.00628529f \
 //x=12.59 //y=5.38 //x2=12.685 //y2=3.88
cc_900 ( N_noxref_5_c_1229_n N_noxref_6_c_1493_n ) capacitor c=0.0374497f \
 //x=13.23 //y=3.51 //x2=12.685 //y2=3.88
cc_901 ( N_noxref_5_c_1205_n N_noxref_6_c_1526_n ) capacitor c=0.00768025f \
 //x=13.07 //y=3.67 //x2=13.285 //y2=3.895
cc_902 ( N_noxref_5_c_1173_n N_noxref_6_c_1526_n ) capacitor c=0.0283748f \
 //x=13.07 //y=5.295 //x2=13.285 //y2=3.895
cc_903 ( N_noxref_5_c_1257_p N_noxref_6_c_1526_n ) capacitor c=0.101789f \
 //x=14.385 //y=3.51 //x2=13.285 //y2=3.895
cc_904 ( N_noxref_5_c_1258_p N_noxref_6_c_1529_n ) capacitor c=0.00426779f \
 //x=14.55 //y=3.67 //x2=14.16 //y2=3.88
cc_905 ( N_noxref_5_c_1216_n N_noxref_6_c_1529_n ) capacitor c=4.49947e-19 \
 //x=14.55 //y=4.76 //x2=14.16 //y2=3.88
cc_906 ( N_noxref_5_c_1257_p N_noxref_6_c_1529_n ) capacitor c=0.0117648f \
 //x=14.385 //y=3.51 //x2=14.16 //y2=3.88
cc_907 ( N_noxref_5_c_1261_p N_noxref_6_c_1529_n ) capacitor c=0.0374497f \
 //x=14.545 //y=3.51 //x2=14.16 //y2=3.88
cc_908 ( N_noxref_5_c_1258_p N_noxref_6_c_1533_n ) capacitor c=0.00301505f \
 //x=14.55 //y=3.67 //x2=14.76 //y2=3.895
cc_909 ( N_noxref_5_c_1216_n N_noxref_6_c_1533_n ) capacitor c=0.0291899f \
 //x=14.55 //y=4.76 //x2=14.76 //y2=3.895
cc_910 ( N_noxref_5_c_1192_n N_Q_c_1728_n ) capacitor c=3.56665e-19 //x=12.63 \
 //y=1.75 //x2=17.21 //y2=1.75
cc_911 ( N_noxref_5_c_1198_n N_Q_c_1729_n ) capacitor c=3.3474e-19 //x=12.985 \
 //y=1.835 //x2=17.295 //y2=1.835
cc_912 ( N_noxref_5_c_1192_n N_noxref_8_c_2033_n ) capacitor c=0.0044864f \
 //x=12.63 //y=1.75 //x2=14.92 //y2=1.935
cc_913 ( N_noxref_5_c_1198_n N_noxref_8_c_2033_n ) capacitor c=0.00320685f \
 //x=12.985 //y=1.835 //x2=14.92 //y2=1.935
cc_914 ( N_noxref_5_c_1268_p N_noxref_8_c_2033_n ) capacitor c=0.00108934f \
 //x=14.66 //y=1.435 //x2=14.92 //y2=1.935
cc_915 ( N_noxref_5_c_1269_p N_noxref_8_c_2033_n ) capacitor c=0.00524682f \
 //x=14.66 //y=1.745 //x2=14.92 //y2=1.935
cc_916 ( N_noxref_5_c_1270_p N_noxref_8_c_2033_n ) capacitor c=0.00376309f \
 //x=14.66 //y=2.1 //x2=14.92 //y2=1.935
cc_917 ( N_noxref_5_c_1271_p N_noxref_8_c_2033_n ) capacitor c=0.0090274f \
 //x=15.035 //y=1.59 //x2=14.92 //y2=1.935
cc_918 ( N_noxref_5_c_1272_p N_noxref_8_c_2033_n ) capacitor c=0.00324043f \
 //x=15.19 //y=1.435 //x2=14.92 //y2=1.935
cc_919 ( N_noxref_5_c_1197_n N_noxref_8_c_2040_n ) capacitor c=0.00310478f \
 //x=12.985 //y=5.38 //x2=14.925 //y2=5.42
cc_920 ( N_noxref_5_c_1219_n N_noxref_8_c_2040_n ) capacitor c=5.44332e-19 \
 //x=12.59 //y=5.38 //x2=14.925 //y2=5.42
cc_921 ( N_noxref_5_M26_noxref_g N_noxref_8_c_2040_n ) capacitor c=0.00141266f \
 //x=14.705 //y=6.2 //x2=14.925 //y2=5.42
cc_922 ( N_noxref_5_M27_noxref_g N_noxref_8_c_2040_n ) capacitor c=0.0035313f \
 //x=15.145 //y=6.2 //x2=14.925 //y2=5.42
cc_923 ( N_noxref_5_c_1271_p N_noxref_8_c_2044_n ) capacitor c=0.00180253f \
 //x=15.035 //y=1.59 //x2=15.205 //y2=2.02
cc_924 ( N_noxref_5_c_1172_n N_noxref_8_c_2045_n ) capacitor c=0.00320685f \
 //x=13.07 //y=3.35 //x2=15.005 //y2=2.02
cc_925 ( N_noxref_5_c_1279_p N_noxref_8_c_2045_n ) capacitor c=0.00376309f \
 //x=14.55 //y=2.265 //x2=15.005 //y2=2.02
cc_926 ( N_noxref_5_M27_noxref_g N_noxref_8_c_2047_n ) capacitor c=0.00911943f \
 //x=15.145 //y=6.2 //x2=15.205 //y2=5.14
cc_927 ( N_noxref_5_c_1173_n N_noxref_8_c_2048_n ) capacitor c=0.00292883f \
 //x=13.07 //y=5.295 //x2=15.01 //y2=5.14
cc_928 ( N_noxref_5_M26_noxref_g N_noxref_8_c_2048_n ) capacitor c=0.00427521f \
 //x=14.705 //y=6.2 //x2=15.01 //y2=5.14
cc_929 ( N_noxref_5_c_1283_p N_noxref_8_c_2048_n ) capacitor c=0.00262283f \
 //x=15.07 //y=4.97 //x2=15.01 //y2=5.14
cc_930 ( N_noxref_5_c_1172_n N_noxref_8_c_2051_n ) capacitor c=0.00339603f \
 //x=13.07 //y=3.35 //x2=15.29 //y2=4.12
cc_931 ( N_noxref_5_c_1173_n N_noxref_8_c_2051_n ) capacitor c=3.56171e-19 \
 //x=13.07 //y=5.295 //x2=15.29 //y2=4.12
cc_932 ( N_noxref_5_c_1215_n N_noxref_8_c_2051_n ) capacitor c=0.0409193f \
 //x=14.55 //y=3.35 //x2=15.29 //y2=4.12
cc_933 ( N_noxref_5_c_1258_p N_noxref_8_c_2051_n ) capacitor c=0.0146933f \
 //x=14.55 //y=3.67 //x2=15.29 //y2=4.12
cc_934 ( N_noxref_5_c_1216_n N_noxref_8_c_2051_n ) capacitor c=0.0176625f \
 //x=14.55 //y=4.76 //x2=15.29 //y2=4.12
cc_935 ( N_noxref_5_c_1289_p N_noxref_8_c_2051_n ) capacitor c=6.03895e-19 \
 //x=14.545 //y=3.51 //x2=15.29 //y2=4.12
cc_936 ( N_noxref_5_c_1290_p N_noxref_8_c_2051_n ) capacitor c=0.017436f \
 //x=14.55 //y=2.265 //x2=15.29 //y2=4.12
cc_937 ( N_noxref_5_c_1261_p N_noxref_8_c_2051_n ) capacitor c=0.00684338f \
 //x=14.545 //y=3.51 //x2=15.29 //y2=4.12
cc_938 ( N_noxref_5_c_1292_p N_noxref_8_c_2051_n ) capacitor c=4.71798e-19 \
 //x=14.55 //y=2.265 //x2=15.29 //y2=4.12
cc_939 ( N_noxref_5_c_1279_p N_noxref_8_c_2051_n ) capacitor c=0.00270592f \
 //x=14.55 //y=2.265 //x2=15.29 //y2=4.12
cc_940 ( N_noxref_5_c_1216_n N_noxref_8_c_2061_n ) capacitor c=0.0152911f \
 //x=14.55 //y=4.76 //x2=15.29 //y2=4.44
cc_941 ( N_noxref_5_c_1283_p N_noxref_8_c_2061_n ) capacitor c=0.0010902f \
 //x=15.07 //y=4.97 //x2=15.29 //y2=4.44
cc_942 ( N_noxref_5_c_1173_n N_noxref_8_c_2063_n ) capacitor c=0.00175587f \
 //x=13.07 //y=5.295 //x2=15.29 //y2=5.055
cc_943 ( N_noxref_5_c_1216_n N_noxref_8_c_2063_n ) capacitor c=0.0297122f \
 //x=14.55 //y=4.76 //x2=15.29 //y2=5.055
cc_944 ( N_noxref_5_c_1298_p N_noxref_8_c_2063_n ) capacitor c=0.00383777f \
 //x=14.55 //y=4.88 //x2=15.29 //y2=5.055
cc_945 ( N_noxref_5_c_1283_p N_noxref_8_c_2063_n ) capacitor c=0.00208891f \
 //x=15.07 //y=4.97 //x2=15.29 //y2=5.055
cc_946 ( N_noxref_5_c_1300_p N_noxref_8_c_2063_n ) capacitor c=0.00140024f \
 //x=14.78 //y=4.97 //x2=15.29 //y2=5.055
cc_947 ( N_noxref_5_c_1192_n N_noxref_8_c_2068_n ) capacitor c=6.23317e-19 \
 //x=12.63 //y=1.75 //x2=14.92 //y2=1.185
cc_948 ( N_noxref_5_c_1222_n N_noxref_8_c_2068_n ) capacitor c=0.00596895f \
 //x=12.63 //y=1.18 //x2=14.92 //y2=1.185
cc_949 ( N_noxref_5_c_1303_p N_noxref_8_c_2068_n ) capacitor c=0.00175305f \
 //x=14.66 //y=1.09 //x2=14.92 //y2=1.185
cc_950 ( N_noxref_5_c_1268_p N_noxref_8_c_2068_n ) capacitor c=0.00354487f \
 //x=14.66 //y=1.435 //x2=14.92 //y2=1.185
cc_951 ( N_noxref_5_c_1305_p N_noxref_8_c_2068_n ) capacitor c=5.57924e-19 \
 //x=15.035 //y=0.935 //x2=14.92 //y2=1.185
cc_952 ( N_noxref_5_c_1271_p N_noxref_8_c_2068_n ) capacitor c=5.75878e-19 \
 //x=15.035 //y=1.59 //x2=14.92 //y2=1.185
cc_953 ( N_noxref_5_c_1307_p N_noxref_8_c_2068_n ) capacitor c=0.00148463f \
 //x=15.19 //y=1.09 //x2=14.92 //y2=1.185
cc_954 ( N_noxref_5_c_1272_p N_noxref_8_c_2068_n ) capacitor c=0.00349964f \
 //x=15.19 //y=1.435 //x2=14.92 //y2=1.185
cc_955 ( N_noxref_5_c_1216_n N_noxref_8_c_2032_n ) capacitor c=8.36007e-19 \
 //x=14.55 //y=4.76 //x2=15.29 //y2=4.25
cc_956 ( N_noxref_5_c_1283_p N_noxref_8_c_2032_n ) capacitor c=2.84121e-19 \
 //x=15.07 //y=4.97 //x2=15.29 //y2=4.25
cc_957 ( N_noxref_5_c_1216_n N_noxref_8_c_2078_n ) capacitor c=0.00690268f \
 //x=14.55 //y=4.76 //x2=15.445 //y2=4.28
cc_958 ( N_noxref_5_M26_noxref_g N_noxref_8_c_2079_n ) capacitor c=0.0162066f \
 //x=14.705 //y=6.2 //x2=14.925 //y2=5.56
cc_959 ( N_noxref_5_M27_noxref_g N_noxref_8_c_2079_n ) capacitor c=0.0162066f \
 //x=15.145 //y=6.2 //x2=14.925 //y2=5.56
cc_960 ( N_noxref_5_c_1283_p N_noxref_8_c_2079_n ) capacitor c=0.00290963f \
 //x=15.07 //y=4.97 //x2=14.925 //y2=5.56
cc_961 ( N_noxref_5_c_1303_p N_noxref_8_M7_noxref_d ) capacitor c=0.00137914f \
 //x=14.66 //y=1.09 //x2=14.735 //y2=1.09
cc_962 ( N_noxref_5_c_1268_p N_noxref_8_M7_noxref_d ) capacitor c=0.0023891f \
 //x=14.66 //y=1.435 //x2=14.735 //y2=1.09
cc_963 ( N_noxref_5_c_1305_p N_noxref_8_M7_noxref_d ) capacitor c=0.0020782f \
 //x=15.035 //y=0.935 //x2=14.735 //y2=1.09
cc_964 ( N_noxref_5_c_1271_p N_noxref_8_M7_noxref_d ) capacitor c=0.00356097f \
 //x=15.035 //y=1.59 //x2=14.735 //y2=1.09
cc_965 ( N_noxref_5_c_1307_p N_noxref_8_M7_noxref_d ) capacitor c=0.00138452f \
 //x=15.19 //y=1.09 //x2=14.735 //y2=1.09
cc_966 ( N_noxref_5_c_1272_p N_noxref_8_M7_noxref_d ) capacitor c=0.00235934f \
 //x=15.19 //y=1.435 //x2=14.735 //y2=1.09
cc_967 ( N_noxref_5_c_1171_n N_VDD_c_2596_n ) capacitor c=0.00648267f \
 //x=12.475 //y=5.38 //x2=17.175 //y2=7.585
cc_968 ( N_noxref_5_c_1197_n N_VDD_c_2596_n ) capacitor c=0.00492584f \
 //x=12.985 //y=5.38 //x2=17.175 //y2=7.585
cc_969 ( N_noxref_5_c_1205_n N_VDD_c_2596_n ) capacitor c=4.58384e-19 \
 //x=13.07 //y=3.67 //x2=17.175 //y2=7.585
cc_970 ( N_noxref_5_c_1258_p N_VDD_c_2596_n ) capacitor c=2.66043e-19 \
 //x=14.55 //y=3.67 //x2=17.175 //y2=7.585
cc_971 ( N_noxref_5_c_1216_n N_VDD_c_2596_n ) capacitor c=5.73169e-19 \
 //x=14.55 //y=4.76 //x2=17.175 //y2=7.585
cc_972 ( N_noxref_5_c_1174_n N_VDD_c_2596_n ) capacitor c=0.00368834f \
 //x=11.71 //y=5.56 //x2=17.175 //y2=7.585
cc_973 ( N_noxref_5_c_1219_n N_VDD_c_2596_n ) capacitor c=8.42651e-19 \
 //x=12.59 //y=5.38 //x2=17.175 //y2=7.585
cc_974 ( N_noxref_5_c_1328_p N_VDD_c_2596_n ) capacitor c=0.00285853f \
 //x=12.59 //y=5.56 //x2=17.175 //y2=7.585
cc_975 ( N_noxref_5_c_1180_n N_VDD_c_2596_n ) capacitor c=0.00224881f \
 //x=11.71 //y=5.56 //x2=17.175 //y2=7.585
cc_976 ( N_noxref_5_c_1230_n N_VDD_c_2596_n ) capacitor c=0.00224881f \
 //x=12.59 //y=5.56 //x2=17.175 //y2=7.585
cc_977 ( N_noxref_5_c_1298_p N_VDD_c_2596_n ) capacitor c=3.40755e-19 \
 //x=14.55 //y=4.88 //x2=17.175 //y2=7.585
cc_978 ( N_noxref_5_c_1171_n N_VDD_c_2697_n ) capacitor c=0.00208087f \
 //x=12.475 //y=5.38 //x2=12.065 //y2=7.585
cc_979 ( N_noxref_5_c_1174_n N_VDD_c_2697_n ) capacitor c=9.41185e-19 \
 //x=11.71 //y=5.56 //x2=12.065 //y2=7.585
cc_980 ( N_noxref_5_c_1180_n N_VDD_c_2697_n ) capacitor c=0.0136705f //x=11.71 \
 //y=5.56 //x2=12.065 //y2=7.585
cc_981 ( N_noxref_5_c_1171_n N_VDD_c_2734_n ) capacitor c=0.00180737f \
 //x=12.475 //y=5.38 //x2=12.945 //y2=7.585
cc_982 ( N_noxref_5_c_1197_n N_VDD_c_2734_n ) capacitor c=0.00208087f \
 //x=12.985 //y=5.38 //x2=12.945 //y2=7.585
cc_983 ( N_noxref_5_c_1219_n N_VDD_c_2734_n ) capacitor c=4.23719e-19 \
 //x=12.59 //y=5.38 //x2=12.945 //y2=7.585
cc_984 ( N_noxref_5_c_1328_p N_VDD_c_2734_n ) capacitor c=5.77976e-19 \
 //x=12.59 //y=5.56 //x2=12.945 //y2=7.585
cc_985 ( N_noxref_5_c_1230_n N_VDD_c_2734_n ) capacitor c=0.0136705f //x=12.59 \
 //y=5.56 //x2=12.945 //y2=7.585
cc_986 ( N_noxref_5_c_1216_n N_VDD_c_2788_n ) capacitor c=5.48929e-19 \
 //x=14.55 //y=4.76 //x2=15.28 //y2=7.585
cc_987 ( N_noxref_5_M26_noxref_g N_VDD_c_2788_n ) capacitor c=0.00753931f \
 //x=14.705 //y=6.2 //x2=15.28 //y2=7.585
cc_988 ( N_noxref_5_M27_noxref_g N_VDD_c_2788_n ) capacitor c=0.00751326f \
 //x=15.145 //y=6.2 //x2=15.28 //y2=7.585
cc_989 ( N_noxref_5_c_1173_n N_VDD_c_2662_n ) capacitor c=0.00133592f \
 //x=13.07 //y=5.295 //x2=10.48 //y2=7.585
cc_990 ( N_noxref_5_c_1174_n N_VDD_c_2662_n ) capacitor c=5.11447e-19 \
 //x=11.71 //y=5.56 //x2=10.48 //y2=7.585
cc_991 ( N_noxref_5_c_1180_n N_VDD_c_2662_n ) capacitor c=0.0064135f //x=11.71 \
 //y=5.56 //x2=10.48 //y2=7.585
cc_992 ( N_noxref_5_c_1173_n N_VDD_c_2750_n ) capacitor c=0.0275588f //x=13.07 \
 //y=5.295 //x2=13.81 //y2=7.585
cc_993 ( N_noxref_5_c_1216_n N_VDD_c_2750_n ) capacitor c=0.0152189f //x=14.55 \
 //y=4.76 //x2=13.81 //y2=7.585
cc_994 ( N_noxref_5_c_1219_n N_VDD_c_2750_n ) capacitor c=0.002343f //x=12.59 \
 //y=5.38 //x2=13.81 //y2=7.585
cc_995 ( N_noxref_5_c_1328_p N_VDD_c_2750_n ) capacitor c=4.0348e-19 //x=12.59 \
 //y=5.56 //x2=13.81 //y2=7.585
cc_996 ( N_noxref_5_c_1230_n N_VDD_c_2750_n ) capacitor c=0.0101861f //x=12.59 \
 //y=5.56 //x2=13.81 //y2=7.585
cc_997 ( N_noxref_5_c_1298_p N_VDD_c_2750_n ) capacitor c=0.00795305f \
 //x=14.55 //y=4.88 //x2=13.81 //y2=7.585
cc_998 ( N_noxref_5_M26_noxref_g N_VDD_c_2750_n ) capacitor c=0.00713158f \
 //x=14.705 //y=6.2 //x2=13.81 //y2=7.585
cc_999 ( N_noxref_5_c_1300_p N_VDD_c_2750_n ) capacitor c=0.00799922f \
 //x=14.78 //y=4.97 //x2=13.81 //y2=7.585
cc_1000 ( N_noxref_5_c_1298_p N_VDD_c_2802_n ) capacitor c=0.00235165f \
 //x=14.55 //y=4.88 //x2=16.03 //y2=7.585
cc_1001 ( N_noxref_5_c_1283_p N_VDD_c_2802_n ) capacitor c=0.00809791f \
 //x=15.07 //y=4.97 //x2=16.03 //y2=7.585
cc_1002 ( N_noxref_5_c_1300_p N_VDD_c_2802_n ) capacitor c=2.63786e-19 \
 //x=14.78 //y=4.97 //x2=16.03 //y2=7.585
cc_1003 ( N_noxref_5_c_1174_n N_VDD_M21_noxref_d ) capacitor c=0.00114029f \
 //x=11.71 //y=5.56 //x2=9.67 //y2=5.2
cc_1004 ( N_noxref_5_c_1174_n N_VDD_M22_noxref_s ) capacitor c=0.0604727f \
 //x=11.71 //y=5.56 //x2=11.135 //y2=5.2
cc_1005 ( N_noxref_5_c_1219_n N_VDD_M22_noxref_s ) capacitor c=6.52457e-19 \
 //x=12.59 //y=5.38 //x2=11.135 //y2=5.2
cc_1006 ( N_noxref_5_c_1180_n N_VDD_M22_noxref_s ) capacitor c=0.0887533f \
 //x=11.71 //y=5.56 //x2=11.135 //y2=5.2
cc_1007 ( N_noxref_5_c_1171_n N_VDD_M23_noxref_d ) capacitor c=0.00734094f \
 //x=12.475 //y=5.38 //x2=12.005 //y2=5.2
cc_1008 ( N_noxref_5_c_1174_n N_VDD_M23_noxref_d ) capacitor c=0.0043528f \
 //x=11.71 //y=5.56 //x2=12.005 //y2=5.2
cc_1009 ( N_noxref_5_c_1328_p N_VDD_M23_noxref_d ) capacitor c=0.0043528f \
 //x=12.59 //y=5.56 //x2=12.005 //y2=5.2
cc_1010 ( N_noxref_5_c_1180_n N_VDD_M23_noxref_d ) capacitor c=0.065554f \
 //x=11.71 //y=5.56 //x2=12.005 //y2=5.2
cc_1011 ( N_noxref_5_c_1230_n N_VDD_M23_noxref_d ) capacitor c=0.065554f \
 //x=12.59 //y=5.56 //x2=12.005 //y2=5.2
cc_1012 ( N_noxref_5_c_1197_n N_VDD_M25_noxref_d ) capacitor c=0.00934027f \
 //x=12.985 //y=5.38 //x2=12.885 //y2=5.2
cc_1013 ( N_noxref_5_c_1328_p N_VDD_M25_noxref_d ) capacitor c=0.00921458f \
 //x=12.59 //y=5.56 //x2=12.885 //y2=5.2
cc_1014 ( N_noxref_5_c_1228_n N_VDD_M25_noxref_d ) capacitor c=9.65951e-19 \
 //x=13.07 //y=3.51 //x2=12.885 //y2=5.2
cc_1015 ( N_noxref_5_c_1230_n N_VDD_M25_noxref_d ) capacitor c=0.065554f \
 //x=12.59 //y=5.56 //x2=12.885 //y2=5.2
cc_1016 ( N_noxref_5_c_1197_n N_VDD_M26_noxref_s ) capacitor c=0.00316782f \
 //x=12.985 //y=5.38 //x2=14.35 //y2=5.2
cc_1017 ( N_noxref_5_c_1258_p N_VDD_M26_noxref_s ) capacitor c=0.00125909f \
 //x=14.55 //y=3.67 //x2=14.35 //y2=5.2
cc_1018 ( N_noxref_5_c_1216_n N_VDD_M26_noxref_s ) capacitor c=0.021233f \
 //x=14.55 //y=4.76 //x2=14.35 //y2=5.2
cc_1019 ( N_noxref_5_c_1219_n N_VDD_M26_noxref_s ) capacitor c=0.00460957f \
 //x=12.59 //y=5.38 //x2=14.35 //y2=5.2
cc_1020 ( N_noxref_5_c_1328_p N_VDD_M26_noxref_s ) capacitor c=0.00135645f \
 //x=12.59 //y=5.56 //x2=14.35 //y2=5.2
cc_1021 ( N_noxref_5_c_1298_p N_VDD_M26_noxref_s ) capacitor c=0.00986169f \
 //x=14.55 //y=4.88 //x2=14.35 //y2=5.2
cc_1022 ( N_noxref_5_M26_noxref_g N_VDD_M26_noxref_s ) capacitor c=0.0573441f \
 //x=14.705 //y=6.2 //x2=14.35 //y2=5.2
cc_1023 ( N_noxref_5_c_1300_p N_VDD_M26_noxref_s ) capacitor c=0.00524567f \
 //x=14.78 //y=4.97 //x2=14.35 //y2=5.2
cc_1024 ( N_noxref_5_M27_noxref_g N_VDD_M27_noxref_d ) capacitor c=0.0572684f \
 //x=15.145 //y=6.2 //x2=15.22 //y2=5.2
cc_1025 ( N_noxref_5_c_1198_n N_GND_c_3264_n ) capacitor c=0.00654514f \
 //x=12.985 //y=1.835 //x2=22.32 //y2=0.18
cc_1026 ( N_noxref_5_c_1205_n N_GND_c_3264_n ) capacitor c=4.52555e-19 \
 //x=13.07 //y=3.67 //x2=22.32 //y2=0.18
cc_1027 ( N_noxref_5_c_1258_p N_GND_c_3264_n ) capacitor c=4.40979e-19 \
 //x=14.55 //y=3.67 //x2=22.32 //y2=0.18
cc_1028 ( N_noxref_5_c_1222_n N_GND_c_3264_n ) capacitor c=0.00964814f \
 //x=12.63 //y=1.18 //x2=22.32 //y2=0.18
cc_1029 ( N_noxref_5_c_1290_p N_GND_c_3264_n ) capacitor c=0.00249122f \
 //x=14.55 //y=2.265 //x2=22.32 //y2=0.18
cc_1030 ( N_noxref_5_c_1292_p N_GND_c_3264_n ) capacitor c=7.5371e-19 \
 //x=14.55 //y=2.265 //x2=22.32 //y2=0.18
cc_1031 ( N_noxref_5_M6_noxref_d N_GND_c_3264_n ) capacitor c=3.01769e-19 \
 //x=12.44 //y=1.085 //x2=22.32 //y2=0.18
cc_1032 ( N_noxref_5_c_1174_n N_GND_c_3212_n ) capacitor c=7.75642e-19 \
 //x=11.71 //y=5.56 //x2=11.66 //y2=1.135
cc_1033 ( N_noxref_5_c_1222_n N_GND_c_3212_n ) capacitor c=0.0140211f \
 //x=12.63 //y=1.18 //x2=11.66 //y2=1.135
cc_1034 ( N_noxref_5_M6_noxref_d N_GND_c_3212_n ) capacitor c=2.93544e-19 \
 //x=12.44 //y=1.085 //x2=11.66 //y2=1.135
cc_1035 ( N_noxref_5_c_1198_n N_GND_c_3230_n ) capacitor c=7.75992e-19 \
 //x=12.985 //y=1.835 //x2=13.64 //y2=0.175
cc_1036 ( N_noxref_5_c_1205_n N_GND_c_3230_n ) capacitor c=3.21306e-19 \
 //x=13.07 //y=3.67 //x2=13.64 //y2=0.175
cc_1037 ( N_noxref_5_c_1290_p N_GND_c_3303_n ) capacitor c=0.00114179f \
 //x=14.55 //y=2.265 //x2=14.835 //y2=0.715
cc_1038 ( N_noxref_5_c_1292_p N_GND_c_3303_n ) capacitor c=3.95714e-19 \
 //x=14.55 //y=2.265 //x2=14.835 //y2=0.715
cc_1039 ( N_noxref_5_c_1303_p N_GND_c_3303_n ) capacitor c=0.0125444f \
 //x=14.66 //y=1.09 //x2=14.835 //y2=0.715
cc_1040 ( N_noxref_5_c_1279_p N_GND_c_3303_n ) capacitor c=2.1838e-19 \
 //x=14.55 //y=2.265 //x2=14.835 //y2=0.715
cc_1041 ( N_noxref_5_c_1307_p N_GND_c_3307_n ) capacitor c=0.0133145f \
 //x=15.19 //y=1.09 //x2=15.325 //y2=0.715
cc_1042 ( N_noxref_5_c_1222_n N_GND_c_3146_n ) capacitor c=2.83275e-19 \
 //x=12.63 //y=1.18 //x2=22.32 //y2=0.18
cc_1043 ( N_noxref_5_c_1172_n N_GND_c_3192_n ) capacitor c=9.34543e-19 \
 //x=13.07 //y=3.35 //x2=10.48 //y2=0.175
cc_1044 ( N_noxref_5_c_1192_n N_GND_c_3279_n ) capacitor c=0.00269515f \
 //x=12.63 //y=1.75 //x2=13.81 //y2=0.175
cc_1045 ( N_noxref_5_c_1198_n N_GND_c_3279_n ) capacitor c=0.027102f \
 //x=12.985 //y=1.835 //x2=13.81 //y2=0.175
cc_1046 ( N_noxref_5_c_1215_n N_GND_c_3279_n ) capacitor c=0.0103129f \
 //x=14.55 //y=3.35 //x2=13.81 //y2=0.175
cc_1047 ( N_noxref_5_c_1290_p N_GND_c_3279_n ) capacitor c=0.00682461f \
 //x=14.55 //y=2.265 //x2=13.81 //y2=0.175
cc_1048 ( N_noxref_5_c_1257_p N_GND_c_3279_n ) capacitor c=0.00560367f \
 //x=14.385 //y=3.51 //x2=13.81 //y2=0.175
cc_1049 ( N_noxref_5_c_1292_p N_GND_c_3279_n ) capacitor c=0.00733236f \
 //x=14.55 //y=2.265 //x2=13.81 //y2=0.175
cc_1050 ( N_noxref_5_c_1270_p N_GND_c_3279_n ) capacitor c=0.00427677f \
 //x=14.66 //y=2.1 //x2=13.81 //y2=0.175
cc_1051 ( N_noxref_5_c_1279_p N_GND_c_3279_n ) capacitor c=0.00785621f \
 //x=14.55 //y=2.265 //x2=13.81 //y2=0.175
cc_1052 ( N_noxref_5_c_1292_p N_GND_c_3318_n ) capacitor c=0.0022444f \
 //x=14.55 //y=2.265 //x2=16.03 //y2=0.175
cc_1053 ( N_noxref_5_c_1279_p N_GND_c_3318_n ) capacitor c=2.63786e-19 \
 //x=14.55 //y=2.265 //x2=16.03 //y2=0.175
cc_1054 ( N_noxref_5_c_1222_n N_GND_M5_noxref_d ) capacitor c=2.82748e-19 \
 //x=12.63 //y=1.18 //x2=11.47 //y2=1.045
cc_1055 ( N_noxref_5_c_1258_p N_GND_M7_noxref_s ) capacitor c=8.20337e-19 \
 //x=14.55 //y=3.67 //x2=14.305 //y2=0.55
cc_1056 ( N_noxref_5_c_1290_p N_GND_M7_noxref_s ) capacitor c=0.00297876f \
 //x=14.55 //y=2.265 //x2=14.305 //y2=0.55
cc_1057 ( N_noxref_5_c_1292_p N_GND_M7_noxref_s ) capacitor c=0.00651326f \
 //x=14.55 //y=2.265 //x2=14.305 //y2=0.55
cc_1058 ( N_noxref_5_c_1303_p N_GND_M7_noxref_s ) capacitor c=0.0300873f \
 //x=14.66 //y=1.09 //x2=14.305 //y2=0.55
cc_1059 ( N_noxref_5_c_1269_p N_GND_M7_noxref_s ) capacitor c=0.002132f \
 //x=14.66 //y=1.745 //x2=14.305 //y2=0.55
cc_1060 ( N_noxref_5_c_1270_p N_GND_M7_noxref_s ) capacitor c=0.00304786f \
 //x=14.66 //y=2.1 //x2=14.305 //y2=0.55
cc_1061 ( N_noxref_5_c_1305_p N_GND_M7_noxref_s ) capacitor c=0.00517463f \
 //x=15.035 //y=0.935 //x2=14.305 //y2=0.55
cc_1062 ( N_noxref_5_c_1307_p N_GND_M7_noxref_s ) capacitor c=0.0153553f \
 //x=15.19 //y=1.09 //x2=14.305 //y2=0.55
cc_1063 ( N_noxref_5_c_1272_p N_GND_M7_noxref_s ) capacitor c=0.00629878f \
 //x=15.19 //y=1.435 //x2=14.305 //y2=0.55
cc_1064 ( N_noxref_5_c_1279_p N_GND_M7_noxref_s ) capacitor c=0.00405173f \
 //x=14.55 //y=2.265 //x2=14.305 //y2=0.55
cc_1065 ( N_noxref_5_c_1250_p N_noxref_16_c_3827_n ) capacitor c=0.00900974f \
 //x=12.715 //y=1.835 //x2=12.145 //y2=1.675
cc_1066 ( N_noxref_5_c_1198_n N_noxref_16_c_3835_n ) capacitor c=0.00373013f \
 //x=12.985 //y=1.835 //x2=13.03 //y2=0.71
cc_1067 ( N_noxref_5_c_1222_n N_noxref_16_c_3835_n ) capacitor c=0.00367971f \
 //x=12.63 //y=1.18 //x2=13.03 //y2=0.71
cc_1068 ( N_noxref_5_M6_noxref_d N_noxref_16_c_3835_n ) capacitor \
 c=0.00910163f //x=12.44 //y=1.085 //x2=13.03 //y2=0.71
cc_1069 ( N_noxref_5_c_1192_n N_noxref_16_M5_noxref_s ) capacitor c=0.0156395f \
 //x=12.63 //y=1.75 //x2=11.04 //y2=0.545
cc_1070 ( N_noxref_5_c_1198_n N_noxref_16_M5_noxref_s ) capacitor \
 c=0.00640979f //x=12.985 //y=1.835 //x2=11.04 //y2=0.545
cc_1071 ( N_noxref_5_c_1205_n N_noxref_16_M5_noxref_s ) capacitor \
 c=4.17069e-19 //x=13.07 //y=3.67 //x2=11.04 //y2=0.545
cc_1072 ( N_noxref_5_c_1222_n N_noxref_16_M5_noxref_s ) capacitor \
 c=0.00896448f //x=12.63 //y=1.18 //x2=11.04 //y2=0.545
cc_1073 ( N_noxref_5_c_1228_n N_noxref_16_M5_noxref_s ) capacitor c=0.0010514f \
 //x=13.07 //y=3.51 //x2=11.04 //y2=0.545
cc_1074 ( N_noxref_5_M6_noxref_d N_noxref_16_M5_noxref_s ) capacitor \
 c=0.0275552f //x=12.44 //y=1.085 //x2=11.04 //y2=0.545
cc_1075 ( N_noxref_6_c_1515_n Q ) capacitor c=0.0032224f //x=17.14 //y=3.705 \
 //x2=18.62 //y2=2.4
cc_1076 ( N_noxref_6_c_1516_n Q ) capacitor c=0.00346648f //x=17.14 //y=4.765 \
 //x2=18.62 //y2=4.62
cc_1077 ( N_noxref_6_c_1537_p Q ) capacitor c=2.44646e-19 //x=16.985 //y=4.885 \
 //x2=18.62 //y2=4.62
cc_1078 ( N_noxref_6_c_1538_p N_Q_c_1733_n ) capacitor c=0.00120004f //x=17.14 \
 //y=2.26 //x2=17.21 //y2=1.305
cc_1079 ( N_noxref_6_c_1539_p N_Q_c_1733_n ) capacitor c=7.02188e-19 //x=17.14 \
 //y=2.26 //x2=17.21 //y2=1.305
cc_1080 ( N_noxref_6_c_1540_p N_Q_c_1733_n ) capacitor c=6.03241e-19 \
 //x=16.945 //y=1.085 //x2=17.21 //y2=1.305
cc_1081 ( N_noxref_6_c_1541_p N_Q_c_1733_n ) capacitor c=0.00325126f \
 //x=16.945 //y=1.43 //x2=17.21 //y2=1.305
cc_1082 ( N_noxref_6_c_1542_p N_Q_c_1733_n ) capacitor c=5.29726e-19 //x=17.32 \
 //y=0.93 //x2=17.21 //y2=1.305
cc_1083 ( N_noxref_6_c_1543_p N_Q_c_1733_n ) capacitor c=6.14781e-19 //x=17.32 \
 //y=1.585 //x2=17.21 //y2=1.305
cc_1084 ( N_noxref_6_c_1544_p N_Q_c_1733_n ) capacitor c=5.57259e-19 \
 //x=17.475 //y=1.085 //x2=17.21 //y2=1.305
cc_1085 ( N_noxref_6_c_1545_p N_Q_c_1733_n ) capacitor c=0.00212774f \
 //x=17.475 //y=1.43 //x2=17.21 //y2=1.305
cc_1086 ( N_noxref_6_c_1541_p N_Q_c_1728_n ) capacitor c=0.00108322f \
 //x=16.945 //y=1.43 //x2=17.21 //y2=1.75
cc_1087 ( N_noxref_6_c_1547_p N_Q_c_1728_n ) capacitor c=0.00312733f \
 //x=16.945 //y=1.74 //x2=17.21 //y2=1.75
cc_1088 ( N_noxref_6_c_1548_p N_Q_c_1728_n ) capacitor c=0.00326244f \
 //x=16.945 //y=2.095 //x2=17.21 //y2=1.75
cc_1089 ( N_noxref_6_c_1543_p N_Q_c_1728_n ) capacitor c=0.00672368f //x=17.32 \
 //y=1.585 //x2=17.21 //y2=1.75
cc_1090 ( N_noxref_6_c_1545_p N_Q_c_1728_n ) capacitor c=0.00253555f \
 //x=17.475 //y=1.43 //x2=17.21 //y2=1.75
cc_1091 ( N_noxref_6_c_1545_p N_Q_c_1746_n ) capacitor c=7.25274e-19 \
 //x=17.475 //y=1.43 //x2=18.095 //y2=1.835
cc_1092 ( N_noxref_6_c_1552_p N_Q_c_1729_n ) capacitor c=5.68021e-19 //x=17.14 \
 //y=4.025 //x2=17.295 //y2=1.835
cc_1093 ( N_noxref_6_c_1538_p N_Q_c_1729_n ) capacitor c=0.0166235f //x=17.14 \
 //y=2.26 //x2=17.295 //y2=1.835
cc_1094 ( N_noxref_6_c_1533_n N_Q_c_1729_n ) capacitor c=3.78299e-19 //x=14.76 \
 //y=3.895 //x2=17.295 //y2=1.835
cc_1095 ( N_noxref_6_c_1539_p N_Q_c_1729_n ) capacitor c=0.00293572f //x=17.14 \
 //y=2.26 //x2=17.295 //y2=1.835
cc_1096 ( N_noxref_6_c_1548_p N_Q_c_1729_n ) capacitor c=0.00115881f \
 //x=16.945 //y=2.095 //x2=17.295 //y2=1.835
cc_1097 ( N_noxref_6_c_1545_p N_Q_c_1752_n ) capacitor c=6.29838e-19 \
 //x=17.475 //y=1.43 //x2=18.18 //y2=1.75
cc_1098 ( N_noxref_6_c_1538_p N_Q_M8_noxref_d ) capacitor c=7.18966e-19 \
 //x=17.14 //y=2.26 //x2=17.02 //y2=1.085
cc_1099 ( N_noxref_6_c_1539_p N_Q_M8_noxref_d ) capacitor c=0.00132086f \
 //x=17.14 //y=2.26 //x2=17.02 //y2=1.085
cc_1100 ( N_noxref_6_c_1540_p N_Q_M8_noxref_d ) capacitor c=0.00124139f \
 //x=16.945 //y=1.085 //x2=17.02 //y2=1.085
cc_1101 ( N_noxref_6_c_1541_p N_Q_M8_noxref_d ) capacitor c=0.00237422f \
 //x=16.945 //y=1.43 //x2=17.02 //y2=1.085
cc_1102 ( N_noxref_6_c_1548_p N_Q_M8_noxref_d ) capacitor c=4.64713e-19 \
 //x=16.945 //y=2.095 //x2=17.02 //y2=1.085
cc_1103 ( N_noxref_6_c_1542_p N_Q_M8_noxref_d ) capacitor c=0.00213893f \
 //x=17.32 //y=0.93 //x2=17.02 //y2=1.085
cc_1104 ( N_noxref_6_c_1543_p N_Q_M8_noxref_d ) capacitor c=0.00345753f \
 //x=17.32 //y=1.585 //x2=17.02 //y2=1.085
cc_1105 ( N_noxref_6_c_1544_p N_Q_M8_noxref_d ) capacitor c=0.00211919f \
 //x=17.475 //y=1.085 //x2=17.02 //y2=1.085
cc_1106 ( N_noxref_6_c_1545_p N_Q_M8_noxref_d ) capacitor c=0.00237422f \
 //x=17.475 //y=1.43 //x2=17.02 //y2=1.085
cc_1107 ( N_noxref_6_c_1533_n N_noxref_8_c_2040_n ) capacitor c=5.77131e-19 \
 //x=14.76 //y=3.895 //x2=14.925 //y2=5.42
cc_1108 ( N_noxref_6_c_1533_n N_noxref_8_c_2045_n ) capacitor c=0.00531867f \
 //x=14.76 //y=3.895 //x2=15.005 //y2=2.02
cc_1109 ( N_noxref_6_c_1533_n N_noxref_8_c_2048_n ) capacitor c=0.00778963f \
 //x=14.76 //y=3.895 //x2=15.01 //y2=5.14
cc_1110 ( N_noxref_6_c_1515_n N_noxref_8_c_2051_n ) capacitor c=0.0232058f \
 //x=17.14 //y=3.705 //x2=15.29 //y2=4.12
cc_1111 ( N_noxref_6_c_1552_p N_noxref_8_c_2051_n ) capacitor c=0.00255195f \
 //x=17.14 //y=4.025 //x2=15.29 //y2=4.12
cc_1112 ( N_noxref_6_c_1516_n N_noxref_8_c_2051_n ) capacitor c=0.00147543f \
 //x=17.14 //y=4.765 //x2=15.29 //y2=4.12
cc_1113 ( N_noxref_6_c_1538_p N_noxref_8_c_2051_n ) capacitor c=0.00473642f \
 //x=17.14 //y=2.26 //x2=15.29 //y2=4.12
cc_1114 ( N_noxref_6_c_1533_n N_noxref_8_c_2051_n ) capacitor c=0.0309656f \
 //x=14.76 //y=3.895 //x2=15.29 //y2=4.12
cc_1115 ( N_noxref_6_c_1516_n N_noxref_8_c_2061_n ) capacitor c=0.00251059f \
 //x=17.14 //y=4.765 //x2=15.29 //y2=4.44
cc_1116 ( N_noxref_6_c_1533_n N_noxref_8_c_2061_n ) capacitor c=0.00731075f \
 //x=14.76 //y=3.895 //x2=15.29 //y2=4.44
cc_1117 ( N_noxref_6_c_1516_n N_noxref_8_c_2063_n ) capacitor c=0.00500417f \
 //x=17.14 //y=4.765 //x2=15.29 //y2=5.055
cc_1118 ( N_noxref_6_c_1578_p N_noxref_8_c_2063_n ) capacitor c=0.00642329f \
 //x=16.985 //y=4.885 //x2=15.29 //y2=5.055
cc_1119 ( N_noxref_6_c_1516_n N_noxref_8_c_2032_n ) capacitor c=2.97717e-19 \
 //x=17.14 //y=4.765 //x2=15.29 //y2=4.25
cc_1120 ( N_noxref_6_c_1516_n N_noxref_8_c_2078_n ) capacitor c=0.00157696f \
 //x=17.14 //y=4.765 //x2=15.445 //y2=4.28
cc_1121 ( N_noxref_6_c_1533_n N_noxref_8_c_2078_n ) capacitor c=0.0359946f \
 //x=14.76 //y=3.895 //x2=15.445 //y2=4.28
cc_1122 ( N_noxref_6_c_1552_p N_noxref_8_c_2103_n ) capacitor c=0.00504331f \
 //x=17.14 //y=4.025 //x2=21.045 //y2=4.265
cc_1123 ( N_noxref_6_c_1516_n N_noxref_8_c_2103_n ) capacitor c=0.0262234f \
 //x=17.14 //y=4.765 //x2=21.045 //y2=4.265
cc_1124 ( N_noxref_6_c_1578_p N_noxref_8_c_2103_n ) capacitor c=0.00890123f \
 //x=16.985 //y=4.885 //x2=21.045 //y2=4.265
cc_1125 ( N_noxref_6_c_1533_n N_noxref_8_c_2103_n ) capacitor c=0.18274f \
 //x=14.76 //y=3.895 //x2=21.045 //y2=4.265
cc_1126 ( N_noxref_6_c_1537_p N_noxref_8_c_2103_n ) capacitor c=0.00460112f \
 //x=16.985 //y=4.885 //x2=21.045 //y2=4.265
cc_1127 ( N_noxref_6_c_1515_n N_noxref_9_c_2313_n ) capacitor c=0.0572338f \
 //x=17.14 //y=3.705 //x2=17.88 //y2=3.705
cc_1128 ( N_noxref_6_c_1539_p N_noxref_9_c_2313_n ) capacitor c=2.61947e-19 \
 //x=17.14 //y=2.26 //x2=17.88 //y2=3.705
cc_1129 ( N_noxref_6_c_1552_p N_noxref_9_c_2315_n ) capacitor c=0.0212009f \
 //x=17.14 //y=4.025 //x2=17.88 //y2=4.025
cc_1130 ( N_noxref_6_c_1590_p N_noxref_9_c_2315_n ) capacitor c=5.9727e-19 \
 //x=17.14 //y=3.88 //x2=17.88 //y2=4.025
cc_1131 ( N_noxref_6_c_1533_n N_noxref_9_c_2315_n ) capacitor c=0.00321261f \
 //x=14.76 //y=3.895 //x2=17.88 //y2=4.025
cc_1132 ( N_noxref_6_c_1538_p N_noxref_9_c_2318_n ) capacitor c=0.0217252f \
 //x=17.14 //y=2.26 //x2=17.88 //y2=2.26
cc_1133 ( N_noxref_6_c_1539_p N_noxref_9_c_2318_n ) capacitor c=5.41079e-19 \
 //x=17.14 //y=2.26 //x2=17.88 //y2=2.26
cc_1134 ( N_noxref_6_c_1548_p N_noxref_9_c_2318_n ) capacitor c=0.00178181f \
 //x=16.945 //y=2.095 //x2=17.88 //y2=2.26
cc_1135 ( N_noxref_6_c_1578_p N_noxref_9_c_2321_n ) capacitor c=0.0208224f \
 //x=16.985 //y=4.885 //x2=17.915 //y2=4.885
cc_1136 ( N_noxref_6_c_1537_p N_noxref_9_c_2321_n ) capacitor c=0.00105182f \
 //x=16.985 //y=4.885 //x2=17.915 //y2=4.885
cc_1137 ( N_noxref_6_c_1597_p N_noxref_9_c_2321_n ) capacitor c=0.00107587f \
 //x=17.405 //y=4.975 //x2=17.915 //y2=4.885
cc_1138 ( N_noxref_6_c_1516_n N_noxref_9_c_2324_n ) capacitor c=0.0196037f \
 //x=17.14 //y=4.765 //x2=17.915 //y2=4.74
cc_1139 ( N_noxref_6_c_1552_p N_noxref_9_c_2325_n ) capacitor c=5.87928e-19 \
 //x=17.14 //y=4.025 //x2=17.88 //y2=3.88
cc_1140 ( N_noxref_6_c_1590_p N_noxref_9_c_2325_n ) capacitor c=0.0102282f \
 //x=17.14 //y=3.88 //x2=17.88 //y2=3.88
cc_1141 ( N_noxref_6_c_1552_p N_noxref_9_c_2327_n ) capacitor c=0.00321379f \
 //x=17.14 //y=4.025 //x2=18.04 //y2=3.865
cc_1142 ( N_noxref_6_c_1533_n N_noxref_9_c_2327_n ) capacitor c=0.0235101f \
 //x=14.76 //y=3.895 //x2=18.04 //y2=3.865
cc_1143 ( N_noxref_6_c_1515_n N_noxref_9_c_2329_n ) capacitor c=2.61947e-19 \
 //x=17.14 //y=3.705 //x2=17.88 //y2=2.26
cc_1144 ( N_noxref_6_c_1538_p N_noxref_9_c_2329_n ) capacitor c=5.24865e-19 \
 //x=17.14 //y=2.26 //x2=17.88 //y2=2.26
cc_1145 ( N_noxref_6_c_1539_p N_noxref_9_c_2329_n ) capacitor c=0.00525888f \
 //x=17.14 //y=2.26 //x2=17.88 //y2=2.26
cc_1146 ( N_noxref_6_c_1548_p N_noxref_9_c_2329_n ) capacitor c=0.00190888f \
 //x=16.945 //y=2.095 //x2=17.88 //y2=2.26
cc_1147 ( N_noxref_6_c_1578_p N_noxref_9_c_2333_n ) capacitor c=4.32488e-19 \
 //x=16.985 //y=4.885 //x2=17.915 //y2=4.885
cc_1148 ( N_noxref_6_c_1537_p N_noxref_9_c_2333_n ) capacitor c=0.00242589f \
 //x=16.985 //y=4.885 //x2=17.915 //y2=4.885
cc_1149 ( N_noxref_6_c_1597_p N_noxref_9_c_2333_n ) capacitor c=0.00116837f \
 //x=17.405 //y=4.975 //x2=17.915 //y2=4.885
cc_1150 ( N_noxref_6_c_1610_p N_noxref_9_c_2333_n ) capacitor c=0.00121814f \
 //x=16.985 //y=4.885 //x2=17.915 //y2=4.885
cc_1151 ( N_noxref_6_M28_noxref_g N_noxref_9_M30_noxref_g ) capacitor \
 c=0.0101077f //x=17.04 //y=6.205 //x2=17.92 //y2=6.205
cc_1152 ( N_noxref_6_M29_noxref_g N_noxref_9_M30_noxref_g ) capacitor \
 c=0.109254f //x=17.48 //y=6.205 //x2=17.92 //y2=6.205
cc_1153 ( N_noxref_6_M29_noxref_g N_noxref_9_M31_noxref_g ) capacitor \
 c=0.00945018f //x=17.48 //y=6.205 //x2=18.36 //y2=6.205
cc_1154 ( N_noxref_6_c_1540_p N_noxref_9_c_2340_n ) capacitor c=0.00125788f \
 //x=16.945 //y=1.085 //x2=17.915 //y2=1.085
cc_1155 ( N_noxref_6_c_1544_p N_noxref_9_c_2340_n ) capacitor c=0.0126654f \
 //x=17.475 //y=1.085 //x2=17.915 //y2=1.085
cc_1156 ( N_noxref_6_c_1541_p N_noxref_9_c_2342_n ) capacitor c=0.00149727f \
 //x=16.945 //y=1.43 //x2=17.915 //y2=1.435
cc_1157 ( N_noxref_6_c_1547_p N_noxref_9_c_2342_n ) capacitor c=0.00111802f \
 //x=16.945 //y=1.74 //x2=17.915 //y2=1.435
cc_1158 ( N_noxref_6_c_1545_p N_noxref_9_c_2342_n ) capacitor c=0.0126654f \
 //x=17.475 //y=1.43 //x2=17.915 //y2=1.435
cc_1159 ( N_noxref_6_c_1547_p N_noxref_9_c_2345_n ) capacitor c=0.00116305f \
 //x=16.945 //y=1.74 //x2=17.915 //y2=1.74
cc_1160 ( N_noxref_6_c_1545_p N_noxref_9_c_2345_n ) capacitor c=0.00938322f \
 //x=17.475 //y=1.43 //x2=17.915 //y2=1.74
cc_1161 ( N_noxref_6_c_1545_p N_noxref_9_c_2347_n ) capacitor c=0.00131492f \
 //x=17.475 //y=1.43 //x2=18.29 //y2=1.585
cc_1162 ( N_noxref_6_c_1544_p N_noxref_9_c_2348_n ) capacitor c=0.00132934f \
 //x=17.475 //y=1.085 //x2=18.445 //y2=1.085
cc_1163 ( N_noxref_6_c_1545_p N_noxref_9_c_2349_n ) capacitor c=0.00151998f \
 //x=17.475 //y=1.43 //x2=18.445 //y2=1.435
cc_1164 ( N_noxref_6_c_1538_p N_noxref_9_c_2350_n ) capacitor c=0.00173144f \
 //x=17.14 //y=2.26 //x2=17.88 //y2=2.26
cc_1165 ( N_noxref_6_c_1539_p N_noxref_9_c_2350_n ) capacitor c=0.0018937f \
 //x=17.14 //y=2.26 //x2=17.88 //y2=2.26
cc_1166 ( N_noxref_6_c_1548_p N_noxref_9_c_2350_n ) capacitor c=0.0181449f \
 //x=16.945 //y=2.095 //x2=17.88 //y2=2.26
cc_1167 ( N_noxref_6_c_1548_p N_noxref_9_c_2353_n ) capacitor c=0.00636965f \
 //x=16.945 //y=2.095 //x2=17.88 //y2=2.095
cc_1168 ( N_noxref_6_c_1516_n N_noxref_9_c_2354_n ) capacitor c=0.00117265f \
 //x=17.14 //y=4.765 //x2=17.915 //y2=4.885
cc_1169 ( N_noxref_6_c_1578_p N_noxref_9_c_2354_n ) capacitor c=4.8456e-19 \
 //x=16.985 //y=4.885 //x2=17.915 //y2=4.885
cc_1170 ( N_noxref_6_c_1537_p N_noxref_9_c_2354_n ) capacitor c=0.00211373f \
 //x=16.985 //y=4.885 //x2=17.915 //y2=4.885
cc_1171 ( N_noxref_6_c_1597_p N_noxref_9_c_2354_n ) capacitor c=0.0203928f \
 //x=17.405 //y=4.975 //x2=17.915 //y2=4.885
cc_1172 ( N_noxref_6_c_1610_p N_noxref_9_c_2354_n ) capacitor c=0.00590438f \
 //x=16.985 //y=4.885 //x2=17.915 //y2=4.885
cc_1173 ( N_noxref_6_c_1436_n N_VDD_c_2596_n ) capacitor c=0.00259721f \
 //x=9.375 //y=5.42 //x2=17.175 //y2=7.585
cc_1174 ( N_noxref_6_c_1443_n N_VDD_c_2596_n ) capacitor c=0.00266633f \
 //x=9.655 //y=5.14 //x2=17.175 //y2=7.585
cc_1175 ( N_noxref_6_c_1473_n N_VDD_c_2596_n ) capacitor c=0.00241566f \
 //x=9.375 //y=5.56 //x2=17.175 //y2=7.585
cc_1176 ( N_noxref_6_M28_noxref_g N_VDD_c_2830_n ) capacitor c=0.00122608f \
 //x=17.04 //y=6.205 //x2=17.26 //y2=7.035
cc_1177 ( N_noxref_6_M29_noxref_g N_VDD_c_2830_n ) capacitor c=0.00122608f \
 //x=17.48 //y=6.205 //x2=17.26 //y2=7.035
cc_1178 ( N_noxref_6_M28_noxref_g N_VDD_c_2832_n ) capacitor c=0.00205385f \
 //x=17.04 //y=6.205 //x2=17.26 //y2=7.41
cc_1179 ( N_noxref_6_M29_noxref_g N_VDD_c_2832_n ) capacitor c=0.00282432f \
 //x=17.48 //y=6.205 //x2=17.26 //y2=7.41
cc_1180 ( N_noxref_6_c_1436_n N_VDD_c_2648_n ) capacitor c=8.96756e-19 \
 //x=9.375 //y=5.42 //x2=9.73 //y2=7.585
cc_1181 ( N_noxref_6_c_1443_n N_VDD_c_2648_n ) capacitor c=0.00197507f \
 //x=9.655 //y=5.14 //x2=9.73 //y2=7.585
cc_1182 ( N_noxref_6_c_1473_n N_VDD_c_2648_n ) capacitor c=0.0138017f \
 //x=9.375 //y=5.56 //x2=9.73 //y2=7.585
cc_1183 ( N_noxref_6_M28_noxref_g N_VDD_c_2837_n ) capacitor c=0.00720181f \
 //x=17.04 //y=6.205 //x2=19.19 //y2=7.585
cc_1184 ( N_noxref_6_M29_noxref_g N_VDD_c_2837_n ) capacitor c=0.00778439f \
 //x=17.48 //y=6.205 //x2=19.19 //y2=7.585
cc_1185 ( N_noxref_6_c_1444_n N_VDD_c_2654_n ) capacitor c=0.00464635f \
 //x=9.46 //y=5.14 //x2=8.26 //y2=7.585
cc_1186 ( N_noxref_6_c_1473_n N_VDD_c_2654_n ) capacitor c=0.00821397f \
 //x=9.375 //y=5.56 //x2=8.26 //y2=7.585
cc_1187 ( N_noxref_6_c_1436_n N_VDD_c_2662_n ) capacitor c=0.00231872f \
 //x=9.375 //y=5.42 //x2=10.48 //y2=7.585
cc_1188 ( N_noxref_6_c_1458_n N_VDD_c_2662_n ) capacitor c=0.0221274f //x=9.74 \
 //y=5.055 //x2=10.48 //y2=7.585
cc_1189 ( N_noxref_6_c_1473_n N_VDD_c_2662_n ) capacitor c=0.00824308f \
 //x=9.375 //y=5.56 //x2=10.48 //y2=7.585
cc_1190 ( N_noxref_6_c_1529_n N_VDD_c_2750_n ) capacitor c=0.00643448f \
 //x=14.16 //y=3.88 //x2=13.81 //y2=7.585
cc_1191 ( N_noxref_6_c_1516_n N_VDD_c_2802_n ) capacitor c=0.00689978f \
 //x=17.14 //y=4.765 //x2=16.03 //y2=7.585
cc_1192 ( N_noxref_6_c_1578_p N_VDD_c_2802_n ) capacitor c=0.00344941f \
 //x=16.985 //y=4.885 //x2=16.03 //y2=7.585
cc_1193 ( N_noxref_6_c_1533_n N_VDD_c_2802_n ) capacitor c=0.00271717f \
 //x=14.76 //y=3.895 //x2=16.03 //y2=7.585
cc_1194 ( N_noxref_6_c_1537_p N_VDD_c_2802_n ) capacitor c=0.00616738f \
 //x=16.985 //y=4.885 //x2=16.03 //y2=7.585
cc_1195 ( N_noxref_6_M28_noxref_g N_VDD_c_2802_n ) capacitor c=0.00817584f \
 //x=17.04 //y=6.205 //x2=16.03 //y2=7.585
cc_1196 ( N_noxref_6_c_1610_p N_VDD_c_2802_n ) capacitor c=0.004975f \
 //x=16.985 //y=4.885 //x2=16.03 //y2=7.585
cc_1197 ( N_noxref_6_c_1537_p N_VDD_c_2851_n ) capacitor c=3.49022e-19 \
 //x=16.985 //y=4.885 //x2=19.36 //y2=7.585
cc_1198 ( N_noxref_6_c_1436_n N_VDD_M16_noxref_s ) capacitor c=2.62188e-19 \
 //x=9.375 //y=5.42 //x2=5.585 //y2=5.2
cc_1199 ( N_noxref_6_c_1436_n N_VDD_M20_noxref_s ) capacitor c=0.0465774f \
 //x=9.375 //y=5.42 //x2=8.8 //y2=5.2
cc_1200 ( N_noxref_6_c_1473_n N_VDD_M20_noxref_s ) capacitor c=0.0899011f \
 //x=9.375 //y=5.56 //x2=8.8 //y2=5.2
cc_1201 ( N_noxref_6_c_1436_n N_VDD_M21_noxref_d ) capacitor c=0.0474638f \
 //x=9.375 //y=5.42 //x2=9.67 //y2=5.2
cc_1202 ( N_noxref_6_c_1443_n N_VDD_M21_noxref_d ) capacitor c=0.0210992f \
 //x=9.655 //y=5.14 //x2=9.67 //y2=5.2
cc_1203 ( N_noxref_6_c_1456_n N_VDD_M21_noxref_d ) capacitor c=0.00307539f \
 //x=9.74 //y=4.025 //x2=9.67 //y2=5.2
cc_1204 ( N_noxref_6_c_1471_n N_VDD_M21_noxref_d ) capacitor c=5.54681e-19 \
 //x=9.74 //y=3.88 //x2=9.67 //y2=5.2
cc_1205 ( N_noxref_6_c_1473_n N_VDD_M21_noxref_d ) capacitor c=0.0907f \
 //x=9.375 //y=5.56 //x2=9.67 //y2=5.2
cc_1206 ( N_noxref_6_c_1436_n N_VDD_M22_noxref_s ) capacitor c=0.00151378f \
 //x=9.375 //y=5.42 //x2=11.135 //y2=5.2
cc_1207 ( N_noxref_6_c_1529_n N_VDD_M26_noxref_s ) capacitor c=9.1968e-19 \
 //x=14.16 //y=3.88 //x2=14.35 //y2=5.2
cc_1208 ( N_noxref_6_c_1590_p N_VDD_M28_noxref_d ) capacitor c=6.32902e-19 \
 //x=17.14 //y=3.88 //x2=17.115 //y2=5.205
cc_1209 ( N_noxref_6_M28_noxref_g N_VDD_M28_noxref_d ) capacitor c=0.0130453f \
 //x=17.04 //y=6.205 //x2=17.115 //y2=5.205
cc_1210 ( N_noxref_6_M29_noxref_g N_VDD_M28_noxref_d ) capacitor c=0.0142727f \
 //x=17.48 //y=6.205 //x2=17.115 //y2=5.205
cc_1211 ( N_noxref_6_c_1597_p N_VDD_M28_noxref_d ) capacitor c=0.00237147f \
 //x=17.405 //y=4.975 //x2=17.115 //y2=5.205
cc_1212 ( N_noxref_6_c_1440_n N_GND_c_3166_n ) capacitor c=0.00499609f \
 //x=9.655 //y=2.02 //x2=11.575 //y2=0.175
cc_1213 ( N_noxref_6_c_1456_n N_GND_c_3166_n ) capacitor c=4.78376e-19 \
 //x=9.74 //y=4.025 //x2=11.575 //y2=0.175
cc_1214 ( N_noxref_6_c_1463_n N_GND_c_3166_n ) capacitor c=0.00998676f \
 //x=9.37 //y=1.185 //x2=11.575 //y2=0.175
cc_1215 ( N_noxref_6_M4_noxref_d N_GND_c_3166_n ) capacitor c=0.00119455f \
 //x=9.185 //y=1.09 //x2=11.575 //y2=0.175
cc_1216 ( N_noxref_6_c_1552_p N_GND_c_3264_n ) capacitor c=2.24411e-19 \
 //x=17.14 //y=4.025 //x2=22.32 //y2=0.18
cc_1217 ( N_noxref_6_c_1538_p N_GND_c_3264_n ) capacitor c=8.84449e-19 \
 //x=17.14 //y=2.26 //x2=22.32 //y2=0.18
cc_1218 ( N_noxref_6_c_1463_n N_GND_c_3212_n ) capacitor c=0.00522864f \
 //x=9.37 //y=1.185 //x2=11.66 //y2=1.135
cc_1219 ( N_noxref_6_c_1463_n N_GND_c_3178_n ) capacitor c=0.00124813f \
 //x=9.37 //y=1.185 //x2=9.285 //y2=0.715
cc_1220 ( N_noxref_6_c_1440_n N_GND_c_3182_n ) capacitor c=0.00319441f \
 //x=9.655 //y=2.02 //x2=9.775 //y2=0.715
cc_1221 ( N_noxref_6_c_1463_n N_GND_c_3182_n ) capacitor c=0.00130539f \
 //x=9.37 //y=1.185 //x2=9.775 //y2=0.715
cc_1222 ( N_noxref_6_c_1471_n N_GND_c_3182_n ) capacitor c=2.41704e-19 \
 //x=9.74 //y=3.88 //x2=9.775 //y2=0.715
cc_1223 ( N_noxref_6_c_1552_p N_GND_c_3342_n ) capacitor c=3.19565e-19 \
 //x=17.14 //y=4.025 //x2=17.61 //y2=0.71
cc_1224 ( N_noxref_6_c_1538_p N_GND_c_3342_n ) capacitor c=0.0010437f \
 //x=17.14 //y=2.26 //x2=17.61 //y2=0.71
cc_1225 ( N_noxref_6_c_1539_p N_GND_c_3342_n ) capacitor c=4.19728e-19 \
 //x=17.14 //y=2.26 //x2=17.61 //y2=0.71
cc_1226 ( N_noxref_6_c_1540_p N_GND_c_3342_n ) capacitor c=0.0211652f \
 //x=16.945 //y=1.085 //x2=17.61 //y2=0.71
cc_1227 ( N_noxref_6_c_1548_p N_GND_c_3342_n ) capacitor c=2.1838e-19 \
 //x=16.945 //y=2.095 //x2=17.61 //y2=0.71
cc_1228 ( N_noxref_6_c_1544_p N_GND_c_3342_n ) capacitor c=0.00805599f \
 //x=17.475 //y=1.085 //x2=17.61 //y2=0.71
cc_1229 ( N_noxref_6_c_1463_n N_GND_c_3146_n ) capacitor c=2.8029e-19 //x=9.37 \
 //y=1.185 //x2=22.32 //y2=0.18
cc_1230 ( N_noxref_6_c_1429_n N_GND_c_3185_n ) capacitor c=0.00272952f \
 //x=9.37 //y=1.935 //x2=8.26 //y2=0.175
cc_1231 ( N_noxref_6_c_1440_n N_GND_c_3192_n ) capacitor c=0.0230294f \
 //x=9.655 //y=2.02 //x2=10.48 //y2=0.175
cc_1232 ( N_noxref_6_c_1515_n N_GND_c_3318_n ) capacitor c=0.00821798f \
 //x=17.14 //y=3.705 //x2=16.03 //y2=0.175
cc_1233 ( N_noxref_6_c_1538_p N_GND_c_3318_n ) capacitor c=0.00446799f \
 //x=17.14 //y=2.26 //x2=16.03 //y2=0.175
cc_1234 ( N_noxref_6_c_1533_n N_GND_c_3318_n ) capacitor c=0.00440673f \
 //x=14.76 //y=3.895 //x2=16.03 //y2=0.175
cc_1235 ( N_noxref_6_c_1539_p N_GND_c_3318_n ) capacitor c=0.00369203f \
 //x=17.14 //y=2.26 //x2=16.03 //y2=0.175
cc_1236 ( N_noxref_6_c_1548_p N_GND_c_3318_n ) capacitor c=0.00932032f \
 //x=16.945 //y=2.095 //x2=16.03 //y2=0.175
cc_1237 ( N_noxref_6_c_1429_n N_GND_M4_noxref_s ) capacitor c=0.0298527f \
 //x=9.37 //y=1.935 //x2=8.755 //y2=0.55
cc_1238 ( N_noxref_6_c_1440_n N_GND_M4_noxref_s ) capacitor c=0.00407415f \
 //x=9.655 //y=2.02 //x2=8.755 //y2=0.55
cc_1239 ( N_noxref_6_c_1456_n N_GND_M4_noxref_s ) capacitor c=0.00106774f \
 //x=9.74 //y=4.025 //x2=8.755 //y2=0.55
cc_1240 ( N_noxref_6_c_1463_n N_GND_M4_noxref_s ) capacitor c=0.0140692f \
 //x=9.37 //y=1.185 //x2=8.755 //y2=0.55
cc_1241 ( N_noxref_6_c_1471_n N_GND_M4_noxref_s ) capacitor c=5.90702e-19 \
 //x=9.74 //y=3.88 //x2=8.755 //y2=0.55
cc_1242 ( N_noxref_6_M4_noxref_d N_GND_M4_noxref_s ) capacitor c=0.0377642f \
 //x=9.185 //y=1.09 //x2=8.755 //y2=0.55
cc_1243 ( N_noxref_6_c_1533_n N_GND_M7_noxref_s ) capacitor c=0.00136083f \
 //x=14.76 //y=3.895 //x2=14.305 //y2=0.55
cc_1244 ( N_noxref_6_c_1533_n N_GND_M8_noxref_s ) capacitor c=0.00215337f \
 //x=14.76 //y=3.895 //x2=16.59 //y2=0.545
cc_1245 ( N_noxref_6_c_1540_p N_GND_M8_noxref_s ) capacitor c=0.0329097f \
 //x=16.945 //y=1.085 //x2=16.59 //y2=0.545
cc_1246 ( N_noxref_6_c_1544_p N_GND_M8_noxref_s ) capacitor c=0.00605785f \
 //x=17.475 //y=1.085 //x2=16.59 //y2=0.545
cc_1247 ( N_noxref_6_c_1545_p N_GND_M8_noxref_s ) capacitor c=0.00120103f \
 //x=17.475 //y=1.43 //x2=16.59 //y2=0.545
cc_1248 ( N_noxref_6_c_1552_p N_noxref_13_c_3566_n ) capacitor c=9.07323e-19 \
 //x=17.14 //y=4.025 //x2=17.58 //y2=5.39
cc_1249 ( N_noxref_6_c_1578_p N_noxref_13_c_3566_n ) capacitor c=0.00749854f \
 //x=16.985 //y=4.885 //x2=17.58 //y2=5.39
cc_1250 ( N_noxref_6_c_1537_p N_noxref_13_c_3566_n ) capacitor c=0.00104675f \
 //x=16.985 //y=4.885 //x2=17.58 //y2=5.39
cc_1251 ( N_noxref_6_M28_noxref_g N_noxref_13_c_3566_n ) capacitor c=0.009911f \
 //x=17.04 //y=6.205 //x2=17.58 //y2=5.39
cc_1252 ( N_noxref_6_M29_noxref_g N_noxref_13_c_3566_n ) capacitor \
 c=0.00982237f //x=17.48 //y=6.205 //x2=17.58 //y2=5.39
cc_1253 ( N_noxref_6_c_1597_p N_noxref_13_c_3566_n ) capacitor c=0.00171927f \
 //x=17.405 //y=4.975 //x2=17.58 //y2=5.39
cc_1254 ( N_noxref_6_c_1578_p N_noxref_13_c_3572_n ) capacitor c=0.0239616f \
 //x=16.985 //y=4.885 //x2=16.82 //y2=5.39
cc_1255 ( N_noxref_6_c_1537_p N_noxref_13_c_3572_n ) capacitor c=0.00565356f \
 //x=16.985 //y=4.885 //x2=16.82 //y2=5.39
cc_1256 ( N_noxref_6_M28_noxref_g N_noxref_13_c_3572_n ) capacitor \
 c=0.00403872f //x=17.04 //y=6.205 //x2=16.82 //y2=5.39
cc_1257 ( N_noxref_6_c_1610_p N_noxref_13_c_3572_n ) capacitor c=9.12041e-19 \
 //x=16.985 //y=4.885 //x2=16.82 //y2=5.39
cc_1258 ( N_noxref_6_M29_noxref_g N_noxref_13_c_3576_n ) capacitor \
 c=0.0018094f //x=17.48 //y=6.205 //x2=17.7 //y2=5.39
cc_1259 ( N_noxref_6_M29_noxref_g N_noxref_13_c_3577_n ) capacitor \
 c=0.00180782f //x=17.48 //y=6.205 //x2=17.7 //y2=6.92
cc_1260 ( N_noxref_6_c_1578_p N_noxref_13_c_3578_n ) capacitor c=0.00154424f \
 //x=16.985 //y=4.885 //x2=16.82 //y2=5.56
cc_1261 ( N_noxref_6_c_1537_p N_noxref_13_c_3578_n ) capacitor c=0.00126834f \
 //x=16.985 //y=4.885 //x2=16.82 //y2=5.56
cc_1262 ( N_noxref_6_M28_noxref_g N_noxref_13_c_3578_n ) capacitor \
 c=0.0483843f //x=17.04 //y=6.205 //x2=16.82 //y2=5.56
cc_1263 ( N_noxref_6_c_1610_p N_noxref_13_c_3578_n ) capacitor c=0.00297041f \
 //x=16.985 //y=4.885 //x2=16.82 //y2=5.56
cc_1264 ( N_noxref_6_M29_noxref_g N_noxref_13_c_3582_n ) capacitor \
 c=0.0170175f //x=17.48 //y=6.205 //x2=17.7 //y2=5.56
cc_1265 ( N_noxref_6_M28_noxref_g N_noxref_13_M28_noxref_s ) capacitor \
 c=0.00378422f //x=17.04 //y=6.205 //x2=16.685 //y2=5.205
cc_1266 ( N_noxref_6_c_1493_n N_noxref_16_c_3819_n ) capacitor c=0.00405138f \
 //x=12.685 //y=3.88 //x2=12.06 //y2=1.76
cc_1267 ( N_noxref_6_c_1493_n N_noxref_16_c_3827_n ) capacitor c=0.00175239f \
 //x=12.685 //y=3.88 //x2=12.145 //y2=1.675
cc_1268 ( N_Q_c_1728_n N_noxref_8_c_2033_n ) capacitor c=0.00665212f //x=17.21 \
 //y=1.75 //x2=14.92 //y2=1.935
cc_1269 ( N_Q_c_1752_n N_noxref_8_c_2033_n ) capacitor c=6.25488e-19 //x=18.18 \
 //y=1.75 //x2=14.92 //y2=1.935
cc_1270 ( Q N_noxref_8_c_2040_n ) capacitor c=7.65451e-19 //x=18.62 //y=4.62 \
 //x2=14.925 //y2=5.42
cc_1271 ( N_Q_c_1765_p N_noxref_8_c_2040_n ) capacitor c=3.52602e-19 \
 //x=18.135 //y=5.39 //x2=14.925 //y2=5.42
cc_1272 ( Q N_noxref_8_c_2044_n ) capacitor c=0.00198397f //x=18.62 //y=2.4 \
 //x2=15.205 //y2=2.02
cc_1273 ( Q N_noxref_8_c_2063_n ) capacitor c=0.00214273f //x=18.62 //y=4.62 \
 //x2=15.29 //y2=5.055
cc_1274 ( Q N_noxref_8_c_2114_n ) capacitor c=0.00211871f //x=18.62 //y=2.4 \
 //x2=21.21 //y2=4.105
cc_1275 ( Q N_noxref_8_c_2114_n ) capacitor c=7.22121e-19 //x=18.62 //y=4.62 \
 //x2=21.21 //y2=4.105
cc_1276 ( Q N_noxref_8_c_2114_n ) capacitor c=0.0418501f //x=20.47 //y=2.4 \
 //x2=21.21 //y2=4.105
cc_1277 ( Q N_noxref_8_c_2114_n ) capacitor c=0.0171416f //x=20.47 //y=4.62 \
 //x2=21.21 //y2=4.105
cc_1278 ( Q N_noxref_8_c_2114_n ) capacitor c=7.6985e-19 //x=20.47 //y=3.51 \
 //x2=21.21 //y2=4.105
cc_1279 ( N_Q_c_1773_p N_noxref_8_c_2114_n ) capacitor c=0.014957f //x=20.47 \
 //y=3.655 //x2=21.21 //y2=4.105
cc_1280 ( N_Q_c_1774_p N_noxref_8_c_2114_n ) capacitor c=0.00693433f \
 //x=20.465 //y=3.495 //x2=21.21 //y2=4.105
cc_1281 ( N_Q_c_1775_p N_noxref_8_c_2114_n ) capacitor c=2.61947e-19 //x=20.47 \
 //y=2.26 //x2=21.21 //y2=4.105
cc_1282 ( Q N_noxref_8_c_2122_n ) capacitor c=0.0176705f //x=20.47 //y=4.62 \
 //x2=21.21 //y2=4.425
cc_1283 ( N_Q_c_1733_n N_noxref_8_c_2068_n ) capacitor c=0.00602995f //x=17.21 \
 //y=1.305 //x2=14.92 //y2=1.185
cc_1284 ( N_Q_c_1728_n N_noxref_8_c_2068_n ) capacitor c=5.1658e-19 //x=17.21 \
 //y=1.75 //x2=14.92 //y2=1.185
cc_1285 ( Q N_noxref_8_c_2125_n ) capacitor c=9.19401e-19 //x=20.47 //y=4.62 \
 //x2=21.21 //y2=4.25
cc_1286 ( N_Q_c_1780_p N_noxref_8_c_2126_n ) capacitor c=0.0217252f //x=20.47 \
 //y=2.26 //x2=21.21 //y2=2.26
cc_1287 ( N_Q_c_1775_p N_noxref_8_c_2126_n ) capacitor c=5.41079e-19 //x=20.47 \
 //y=2.26 //x2=21.21 //y2=2.26
cc_1288 ( N_Q_c_1782_p N_noxref_8_c_2126_n ) capacitor c=0.00178181f \
 //x=20.275 //y=2.095 //x2=21.21 //y2=2.26
cc_1289 ( N_Q_c_1783_p N_noxref_8_c_2129_n ) capacitor c=0.0131772f //x=20.315 \
 //y=4.885 //x2=21.245 //y2=4.885
cc_1290 ( N_Q_c_1784_p N_noxref_8_c_2129_n ) capacitor c=0.00105182f \
 //x=20.315 //y=4.885 //x2=21.245 //y2=4.885
cc_1291 ( N_Q_c_1785_p N_noxref_8_c_2129_n ) capacitor c=0.00107587f \
 //x=20.735 //y=4.975 //x2=21.245 //y2=4.885
cc_1292 ( Q N_noxref_8_c_2132_n ) capacitor c=0.00163641f //x=18.62 //y=4.62 \
 //x2=21.245 //y2=4.74
cc_1293 ( Q N_noxref_8_c_2132_n ) capacitor c=0.0119584f //x=20.47 //y=4.62 \
 //x2=21.245 //y2=4.74
cc_1294 ( Q N_noxref_8_c_2134_n ) capacitor c=0.00328982f //x=20.47 //y=4.62 \
 //x2=21.205 //y2=4.265
cc_1295 ( Q N_noxref_8_c_2103_n ) capacitor c=0.02915f //x=18.62 //y=4.62 \
 //x2=21.045 //y2=4.265
cc_1296 ( Q N_noxref_8_c_2103_n ) capacitor c=0.0259502f //x=20.47 //y=4.62 \
 //x2=21.045 //y2=4.265
cc_1297 ( N_Q_c_1765_p N_noxref_8_c_2103_n ) capacitor c=0.0146371f //x=18.135 \
 //y=5.39 //x2=21.045 //y2=4.265
cc_1298 ( N_Q_c_1783_p N_noxref_8_c_2103_n ) capacitor c=0.00978943f \
 //x=20.315 //y=4.885 //x2=21.045 //y2=4.265
cc_1299 ( N_Q_c_1793_p N_noxref_8_c_2103_n ) capacitor c=0.00975132f \
 //x=20.305 //y=3.495 //x2=21.045 //y2=4.265
cc_1300 ( N_Q_c_1784_p N_noxref_8_c_2103_n ) capacitor c=0.00460112f \
 //x=20.315 //y=4.885 //x2=21.045 //y2=4.265
cc_1301 ( Q N_noxref_8_c_2141_n ) capacitor c=2.61947e-19 //x=20.47 //y=2.4 \
 //x2=21.21 //y2=2.26
cc_1302 ( N_Q_c_1780_p N_noxref_8_c_2141_n ) capacitor c=5.24865e-19 //x=20.47 \
 //y=2.26 //x2=21.21 //y2=2.26
cc_1303 ( N_Q_c_1775_p N_noxref_8_c_2141_n ) capacitor c=0.00445529f //x=20.47 \
 //y=2.26 //x2=21.21 //y2=2.26
cc_1304 ( N_Q_c_1782_p N_noxref_8_c_2141_n ) capacitor c=0.00267961f \
 //x=20.275 //y=2.095 //x2=21.21 //y2=2.26
cc_1305 ( N_Q_c_1783_p N_noxref_8_c_2145_n ) capacitor c=4.32488e-19 \
 //x=20.315 //y=4.885 //x2=21.245 //y2=4.885
cc_1306 ( N_Q_c_1784_p N_noxref_8_c_2145_n ) capacitor c=0.00242589f \
 //x=20.315 //y=4.885 //x2=21.245 //y2=4.885
cc_1307 ( N_Q_c_1785_p N_noxref_8_c_2145_n ) capacitor c=0.00116837f \
 //x=20.735 //y=4.975 //x2=21.245 //y2=4.885
cc_1308 ( N_Q_c_1802_p N_noxref_8_c_2145_n ) capacitor c=0.00121814f \
 //x=20.315 //y=4.885 //x2=21.245 //y2=4.885
cc_1309 ( N_Q_M32_noxref_g N_noxref_8_M34_noxref_g ) capacitor c=0.0101077f \
 //x=20.37 //y=6.205 //x2=21.25 //y2=6.205
cc_1310 ( N_Q_M33_noxref_g N_noxref_8_M34_noxref_g ) capacitor c=0.109254f \
 //x=20.81 //y=6.205 //x2=21.25 //y2=6.205
cc_1311 ( N_Q_M33_noxref_g N_noxref_8_M35_noxref_g ) capacitor c=0.00945018f \
 //x=20.81 //y=6.205 //x2=21.69 //y2=6.205
cc_1312 ( N_Q_c_1806_p N_noxref_8_c_2152_n ) capacitor c=0.00125788f \
 //x=20.275 //y=1.085 //x2=21.245 //y2=1.085
cc_1313 ( N_Q_c_1807_p N_noxref_8_c_2152_n ) capacitor c=0.0126654f //x=20.805 \
 //y=1.085 //x2=21.245 //y2=1.085
cc_1314 ( N_Q_c_1808_p N_noxref_8_c_2154_n ) capacitor c=0.00149727f \
 //x=20.275 //y=1.43 //x2=21.245 //y2=1.435
cc_1315 ( N_Q_c_1809_p N_noxref_8_c_2154_n ) capacitor c=0.00111802f \
 //x=20.275 //y=1.74 //x2=21.245 //y2=1.435
cc_1316 ( N_Q_c_1810_p N_noxref_8_c_2154_n ) capacitor c=0.0126654f //x=20.805 \
 //y=1.43 //x2=21.245 //y2=1.435
cc_1317 ( N_Q_c_1809_p N_noxref_8_c_2157_n ) capacitor c=0.00116305f \
 //x=20.275 //y=1.74 //x2=21.245 //y2=1.74
cc_1318 ( N_Q_c_1810_p N_noxref_8_c_2157_n ) capacitor c=0.00938322f \
 //x=20.805 //y=1.43 //x2=21.245 //y2=1.74
cc_1319 ( N_Q_c_1810_p N_noxref_8_c_2159_n ) capacitor c=0.00131492f \
 //x=20.805 //y=1.43 //x2=21.62 //y2=1.585
cc_1320 ( N_Q_c_1807_p N_noxref_8_c_2160_n ) capacitor c=0.00132934f \
 //x=20.805 //y=1.085 //x2=21.775 //y2=1.085
cc_1321 ( N_Q_c_1810_p N_noxref_8_c_2161_n ) capacitor c=0.00151998f \
 //x=20.805 //y=1.43 //x2=21.775 //y2=1.435
cc_1322 ( N_Q_c_1780_p N_noxref_8_c_2162_n ) capacitor c=0.00173144f //x=20.47 \
 //y=2.26 //x2=21.21 //y2=2.26
cc_1323 ( N_Q_c_1775_p N_noxref_8_c_2162_n ) capacitor c=0.00266443f //x=20.47 \
 //y=2.26 //x2=21.21 //y2=2.26
cc_1324 ( N_Q_c_1782_p N_noxref_8_c_2162_n ) capacitor c=0.0181449f //x=20.275 \
 //y=2.095 //x2=21.21 //y2=2.26
cc_1325 ( N_Q_c_1782_p N_noxref_8_c_2165_n ) capacitor c=0.00636965f \
 //x=20.275 //y=2.095 //x2=21.21 //y2=2.095
cc_1326 ( Q N_noxref_8_c_2166_n ) capacitor c=0.00117265f //x=20.47 //y=4.62 \
 //x2=21.245 //y2=4.885
cc_1327 ( N_Q_c_1783_p N_noxref_8_c_2166_n ) capacitor c=4.8456e-19 //x=20.315 \
 //y=4.885 //x2=21.245 //y2=4.885
cc_1328 ( N_Q_c_1784_p N_noxref_8_c_2166_n ) capacitor c=0.00211373f \
 //x=20.315 //y=4.885 //x2=21.245 //y2=4.885
cc_1329 ( N_Q_c_1785_p N_noxref_8_c_2166_n ) capacitor c=0.0203928f //x=20.735 \
 //y=4.975 //x2=21.245 //y2=4.885
cc_1330 ( N_Q_c_1802_p N_noxref_8_c_2166_n ) capacitor c=0.00590438f \
 //x=20.315 //y=4.885 //x2=21.245 //y2=4.885
cc_1331 ( Q N_noxref_9_c_2313_n ) capacitor c=0.0418277f //x=18.62 //y=2.4 \
 //x2=17.88 //y2=3.705
cc_1332 ( Q N_noxref_9_c_2313_n ) capacitor c=0.00215885f //x=18.62 //y=4.62 \
 //x2=17.88 //y2=3.705
cc_1333 ( Q N_noxref_9_c_2313_n ) capacitor c=0.00209153f //x=20.47 //y=2.4 \
 //x2=17.88 //y2=3.705
cc_1334 ( Q N_noxref_9_c_2313_n ) capacitor c=7.6985e-19 //x=18.62 //y=3.51 \
 //x2=17.88 //y2=3.705
cc_1335 ( N_Q_c_1829_p N_noxref_9_c_2313_n ) capacitor c=0.015283f //x=18.62 \
 //y=3.655 //x2=17.88 //y2=3.705
cc_1336 ( N_Q_c_1830_p N_noxref_9_c_2313_n ) capacitor c=0.00700421f \
 //x=18.775 //y=3.495 //x2=17.88 //y2=3.705
cc_1337 ( Q N_noxref_9_c_2315_n ) capacitor c=0.01761f //x=18.62 //y=4.62 \
 //x2=17.88 //y2=4.025
cc_1338 ( N_Q_c_1746_n N_noxref_9_c_2315_n ) capacitor c=0.00195834f \
 //x=18.095 //y=1.835 //x2=17.88 //y2=4.025
cc_1339 ( N_Q_c_1765_p N_noxref_9_c_2315_n ) capacitor c=0.00172488f \
 //x=18.135 //y=5.39 //x2=17.88 //y2=4.025
cc_1340 ( N_Q_c_1834_p N_noxref_9_c_2368_n ) capacitor c=0.00607433f //x=18.18 \
 //y=1.3 //x2=20.54 //y2=1.305
cc_1341 ( N_Q_c_1780_p N_noxref_9_c_2368_n ) capacitor c=0.00118558f //x=20.47 \
 //y=2.26 //x2=20.54 //y2=1.305
cc_1342 ( N_Q_c_1775_p N_noxref_9_c_2368_n ) capacitor c=7.02188e-19 //x=20.47 \
 //y=2.26 //x2=20.54 //y2=1.305
cc_1343 ( N_Q_c_1806_p N_noxref_9_c_2368_n ) capacitor c=6.05707e-19 \
 //x=20.275 //y=1.085 //x2=20.54 //y2=1.305
cc_1344 ( N_Q_c_1808_p N_noxref_9_c_2368_n ) capacitor c=0.00327855f \
 //x=20.275 //y=1.43 //x2=20.54 //y2=1.305
cc_1345 ( N_Q_c_1839_p N_noxref_9_c_2368_n ) capacitor c=5.29726e-19 //x=20.65 \
 //y=0.93 //x2=20.54 //y2=1.305
cc_1346 ( N_Q_c_1840_p N_noxref_9_c_2368_n ) capacitor c=6.14781e-19 //x=20.65 \
 //y=1.585 //x2=20.54 //y2=1.305
cc_1347 ( N_Q_c_1807_p N_noxref_9_c_2368_n ) capacitor c=5.57259e-19 \
 //x=20.805 //y=1.085 //x2=20.54 //y2=1.305
cc_1348 ( N_Q_c_1810_p N_noxref_9_c_2368_n ) capacitor c=0.00212774f \
 //x=20.805 //y=1.43 //x2=20.54 //y2=1.305
cc_1349 ( N_Q_c_1728_n N_noxref_9_c_2377_n ) capacitor c=6.24608e-19 //x=17.21 \
 //y=1.75 //x2=20.54 //y2=1.75
cc_1350 ( N_Q_c_1752_n N_noxref_9_c_2377_n ) capacitor c=0.00427895f //x=18.18 \
 //y=1.75 //x2=20.54 //y2=1.75
cc_1351 ( N_Q_c_1808_p N_noxref_9_c_2377_n ) capacitor c=0.00109347f \
 //x=20.275 //y=1.43 //x2=20.54 //y2=1.75
cc_1352 ( N_Q_c_1809_p N_noxref_9_c_2377_n ) capacitor c=0.00314841f \
 //x=20.275 //y=1.74 //x2=20.54 //y2=1.75
cc_1353 ( N_Q_c_1782_p N_noxref_9_c_2377_n ) capacitor c=0.00309965f \
 //x=20.275 //y=2.095 //x2=20.54 //y2=1.75
cc_1354 ( N_Q_c_1840_p N_noxref_9_c_2377_n ) capacitor c=0.00674367f //x=20.65 \
 //y=1.585 //x2=20.54 //y2=1.75
cc_1355 ( N_Q_c_1810_p N_noxref_9_c_2377_n ) capacitor c=0.00253555f \
 //x=20.805 //y=1.43 //x2=20.54 //y2=1.75
cc_1356 ( N_Q_c_1810_p N_noxref_9_c_2384_n ) capacitor c=7.25274e-19 \
 //x=20.805 //y=1.43 //x2=21.425 //y2=1.835
cc_1357 ( N_Q_c_1851_p N_noxref_9_c_2385_n ) capacitor c=0.00378258f \
 //x=18.535 //y=1.835 //x2=20.625 //y2=1.835
cc_1358 ( N_Q_c_1773_p N_noxref_9_c_2385_n ) capacitor c=6.6443e-19 //x=20.47 \
 //y=3.655 //x2=20.625 //y2=1.835
cc_1359 ( N_Q_c_1780_p N_noxref_9_c_2385_n ) capacitor c=0.0165182f //x=20.47 \
 //y=2.26 //x2=20.625 //y2=1.835
cc_1360 ( N_Q_c_1774_p N_noxref_9_c_2385_n ) capacitor c=4.25943e-19 \
 //x=20.465 //y=3.495 //x2=20.625 //y2=1.835
cc_1361 ( N_Q_c_1775_p N_noxref_9_c_2385_n ) capacitor c=0.00293572f //x=20.47 \
 //y=2.26 //x2=20.625 //y2=1.835
cc_1362 ( N_Q_c_1782_p N_noxref_9_c_2385_n ) capacitor c=0.00113668f \
 //x=20.275 //y=2.095 //x2=20.625 //y2=1.835
cc_1363 ( N_Q_c_1752_n N_noxref_9_c_2391_n ) capacitor c=6.26629e-19 //x=18.18 \
 //y=1.75 //x2=21.51 //y2=1.75
cc_1364 ( N_Q_c_1810_p N_noxref_9_c_2391_n ) capacitor c=6.29838e-19 \
 //x=20.805 //y=1.43 //x2=21.51 //y2=1.75
cc_1365 ( Q N_noxref_9_c_2393_n ) capacitor c=0.00204276f //x=18.62 //y=2.4 \
 //x2=21.95 //y2=3.72
cc_1366 ( Q N_noxref_9_c_2393_n ) capacitor c=0.0032224f //x=20.47 //y=2.4 \
 //x2=21.95 //y2=3.72
cc_1367 ( Q N_noxref_9_c_2395_n ) capacitor c=0.0029334f //x=18.62 //y=4.62 \
 //x2=21.95 //y2=5.305
cc_1368 ( Q N_noxref_9_c_2395_n ) capacitor c=0.00389175f //x=20.47 //y=4.62 \
 //x2=21.95 //y2=5.305
cc_1369 ( N_Q_c_1784_p N_noxref_9_c_2395_n ) capacitor c=2.44646e-19 \
 //x=20.315 //y=4.885 //x2=21.95 //y2=5.305
cc_1370 ( Q N_noxref_9_c_2318_n ) capacitor c=0.0160491f //x=18.62 //y=2.4 \
 //x2=17.88 //y2=2.26
cc_1371 ( N_Q_c_1746_n N_noxref_9_c_2318_n ) capacitor c=0.0305247f //x=18.095 \
 //y=1.835 //x2=17.88 //y2=2.26
cc_1372 ( Q N_noxref_9_c_2321_n ) capacitor c=0.0175188f //x=18.62 //y=4.62 \
 //x2=17.915 //y2=4.885
cc_1373 ( N_Q_c_1765_p N_noxref_9_c_2321_n ) capacitor c=0.00199057f \
 //x=18.135 //y=5.39 //x2=17.915 //y2=4.885
cc_1374 ( Q N_noxref_9_c_2324_n ) capacitor c=0.0282149f //x=18.62 //y=4.62 \
 //x2=17.915 //y2=4.74
cc_1375 ( Q N_noxref_9_c_2324_n ) capacitor c=0.00161522f //x=20.47 //y=4.62 \
 //x2=17.915 //y2=4.74
cc_1376 ( Q N_noxref_9_c_2325_n ) capacitor c=7.6985e-19 //x=18.62 //y=4.62 \
 //x2=17.88 //y2=3.88
cc_1377 ( N_Q_c_1871_p N_noxref_9_c_2405_n ) capacitor c=7.58745e-19 \
 //x=18.535 //y=5.39 //x2=21.465 //y2=5.39
cc_1378 ( Q N_noxref_9_c_2406_n ) capacitor c=0.0216925f //x=18.62 //y=4.62 \
 //x2=21.785 //y2=3.88
cc_1379 ( Q N_noxref_9_c_2406_n ) capacitor c=0.0227755f //x=20.47 //y=4.62 \
 //x2=21.785 //y2=3.88
cc_1380 ( N_Q_c_1746_n N_noxref_9_c_2406_n ) capacitor c=9.97925e-19 \
 //x=18.095 //y=1.835 //x2=21.785 //y2=3.88
cc_1381 ( N_Q_c_1829_p N_noxref_9_c_2406_n ) capacitor c=0.00925032f //x=18.62 \
 //y=3.655 //x2=21.785 //y2=3.88
cc_1382 ( N_Q_c_1773_p N_noxref_9_c_2406_n ) capacitor c=0.00539485f //x=20.47 \
 //y=3.655 //x2=21.785 //y2=3.88
cc_1383 ( N_Q_c_1877_p N_noxref_9_c_2406_n ) capacitor c=0.00429302f //x=18.18 \
 //y=1.835 //x2=21.785 //y2=3.88
cc_1384 ( N_Q_c_1830_p N_noxref_9_c_2406_n ) capacitor c=0.0368432f //x=18.775 \
 //y=3.495 //x2=21.785 //y2=3.88
cc_1385 ( N_Q_c_1774_p N_noxref_9_c_2406_n ) capacitor c=0.0368432f //x=20.465 \
 //y=3.495 //x2=21.785 //y2=3.88
cc_1386 ( N_Q_c_1793_p N_noxref_9_c_2406_n ) capacitor c=0.139988f //x=20.305 \
 //y=3.495 //x2=21.785 //y2=3.88
cc_1387 ( Q N_noxref_9_c_2327_n ) capacitor c=0.0032735f //x=18.62 //y=4.62 \
 //x2=18.04 //y2=3.865
cc_1388 ( N_Q_c_1746_n N_noxref_9_c_2327_n ) capacitor c=7.37127e-19 \
 //x=18.095 //y=1.835 //x2=18.04 //y2=3.865
cc_1389 ( Q N_noxref_9_c_2329_n ) capacitor c=8.61986e-19 //x=18.62 //y=2.4 \
 //x2=17.88 //y2=2.26
cc_1390 ( N_Q_c_1746_n N_noxref_9_c_2329_n ) capacitor c=0.00491852f \
 //x=18.095 //y=1.835 //x2=17.88 //y2=2.26
cc_1391 ( Q N_noxref_9_c_2333_n ) capacitor c=0.00351933f //x=18.62 //y=4.62 \
 //x2=17.915 //y2=4.885
cc_1392 ( N_Q_c_1765_p N_noxref_9_M30_noxref_g ) capacitor c=0.00184899f \
 //x=18.135 //y=5.39 //x2=17.92 //y2=6.205
cc_1393 ( N_Q_c_1887_p N_noxref_9_M30_noxref_g ) capacitor c=0.0120591f \
 //x=18.14 //y=5.56 //x2=17.92 //y2=6.205
cc_1394 ( N_Q_c_1871_p N_noxref_9_M31_noxref_g ) capacitor c=0.0104409f \
 //x=18.535 //y=5.39 //x2=18.36 //y2=6.205
cc_1395 ( N_Q_c_1765_p N_noxref_9_M31_noxref_g ) capacitor c=0.0027897f \
 //x=18.135 //y=5.39 //x2=18.36 //y2=6.205
cc_1396 ( N_Q_c_1887_p N_noxref_9_M31_noxref_g ) capacitor c=0.0140704f \
 //x=18.14 //y=5.56 //x2=18.36 //y2=6.205
cc_1397 ( N_Q_c_1834_p N_noxref_9_c_2340_n ) capacitor c=0.00112851f //x=18.18 \
 //y=1.3 //x2=17.915 //y2=1.085
cc_1398 ( N_Q_M9_noxref_d N_noxref_9_c_2340_n ) capacitor c=0.00218694f \
 //x=17.99 //y=1.085 //x2=17.915 //y2=1.085
cc_1399 ( N_Q_c_1834_p N_noxref_9_c_2342_n ) capacitor c=0.0021447f //x=18.18 \
 //y=1.3 //x2=17.915 //y2=1.435
cc_1400 ( N_Q_c_1752_n N_noxref_9_c_2342_n ) capacitor c=7.7986e-19 //x=18.18 \
 //y=1.75 //x2=17.915 //y2=1.435
cc_1401 ( N_Q_M9_noxref_d N_noxref_9_c_2342_n ) capacitor c=0.00237422f \
 //x=17.99 //y=1.085 //x2=17.915 //y2=1.435
cc_1402 ( N_Q_c_1728_n N_noxref_9_c_2345_n ) capacitor c=0.00120307f //x=17.21 \
 //y=1.75 //x2=17.915 //y2=1.74
cc_1403 ( N_Q_c_1752_n N_noxref_9_c_2345_n ) capacitor c=0.00364979f //x=18.18 \
 //y=1.75 //x2=17.915 //y2=1.74
cc_1404 ( Q N_noxref_9_c_2432_n ) capacitor c=0.00854359f //x=18.62 //y=4.62 \
 //x2=18.285 //y2=4.975
cc_1405 ( N_Q_c_1765_p N_noxref_9_c_2432_n ) capacitor c=0.00189536f \
 //x=18.135 //y=5.39 //x2=18.285 //y2=4.975
cc_1406 ( N_Q_c_1887_p N_noxref_9_c_2432_n ) capacitor c=0.00293135f //x=18.14 \
 //y=5.56 //x2=18.285 //y2=4.975
cc_1407 ( N_Q_c_1834_p N_noxref_9_c_2435_n ) capacitor c=5.32053e-19 //x=18.18 \
 //y=1.3 //x2=18.29 //y2=0.93
cc_1408 ( N_Q_M9_noxref_d N_noxref_9_c_2435_n ) capacitor c=0.00213893f \
 //x=17.99 //y=1.085 //x2=18.29 //y2=0.93
cc_1409 ( N_Q_c_1834_p N_noxref_9_c_2347_n ) capacitor c=5.25031e-19 //x=18.18 \
 //y=1.3 //x2=18.29 //y2=1.585
cc_1410 ( N_Q_c_1752_n N_noxref_9_c_2347_n ) capacitor c=0.00957298f //x=18.18 \
 //y=1.75 //x2=18.29 //y2=1.585
cc_1411 ( N_Q_c_1851_p N_noxref_9_c_2347_n ) capacitor c=0.00500113f \
 //x=18.535 //y=1.835 //x2=18.29 //y2=1.585
cc_1412 ( N_Q_M9_noxref_d N_noxref_9_c_2347_n ) capacitor c=0.00357974f \
 //x=17.99 //y=1.085 //x2=18.29 //y2=1.585
cc_1413 ( N_Q_c_1834_p N_noxref_9_c_2348_n ) capacitor c=8.07186e-19 //x=18.18 \
 //y=1.3 //x2=18.445 //y2=1.085
cc_1414 ( N_Q_M9_noxref_d N_noxref_9_c_2348_n ) capacitor c=0.0012513f \
 //x=17.99 //y=1.085 //x2=18.445 //y2=1.085
cc_1415 ( N_Q_c_1834_p N_noxref_9_c_2349_n ) capacitor c=0.00325254f //x=18.18 \
 //y=1.3 //x2=18.445 //y2=1.435
cc_1416 ( N_Q_c_1752_n N_noxref_9_c_2349_n ) capacitor c=0.00116202f //x=18.18 \
 //y=1.75 //x2=18.445 //y2=1.435
cc_1417 ( N_Q_M9_noxref_d N_noxref_9_c_2349_n ) capacitor c=0.00237422f \
 //x=17.99 //y=1.085 //x2=18.445 //y2=1.435
cc_1418 ( Q N_noxref_9_c_2350_n ) capacitor c=0.0028062f //x=18.62 //y=2.4 \
 //x2=17.88 //y2=2.26
cc_1419 ( N_Q_c_1746_n N_noxref_9_c_2350_n ) capacitor c=0.00146043f \
 //x=18.095 //y=1.835 //x2=17.88 //y2=2.26
cc_1420 ( Q N_noxref_9_c_2353_n ) capacitor c=0.00312016f //x=18.62 //y=2.4 \
 //x2=17.88 //y2=2.095
cc_1421 ( N_Q_c_1746_n N_noxref_9_c_2353_n ) capacitor c=0.00817459f \
 //x=18.095 //y=1.835 //x2=17.88 //y2=2.095
cc_1422 ( Q N_noxref_9_c_2354_n ) capacitor c=0.00141757f //x=18.62 //y=4.62 \
 //x2=17.915 //y2=4.885
cc_1423 ( N_Q_c_1780_p N_noxref_9_M10_noxref_d ) capacitor c=7.18966e-19 \
 //x=20.47 //y=2.26 //x2=20.35 //y2=1.085
cc_1424 ( N_Q_c_1775_p N_noxref_9_M10_noxref_d ) capacitor c=0.00150225f \
 //x=20.47 //y=2.26 //x2=20.35 //y2=1.085
cc_1425 ( N_Q_c_1806_p N_noxref_9_M10_noxref_d ) capacitor c=0.00124139f \
 //x=20.275 //y=1.085 //x2=20.35 //y2=1.085
cc_1426 ( N_Q_c_1808_p N_noxref_9_M10_noxref_d ) capacitor c=0.00237422f \
 //x=20.275 //y=1.43 //x2=20.35 //y2=1.085
cc_1427 ( N_Q_c_1782_p N_noxref_9_M10_noxref_d ) capacitor c=4.64713e-19 \
 //x=20.275 //y=2.095 //x2=20.35 //y2=1.085
cc_1428 ( N_Q_c_1839_p N_noxref_9_M10_noxref_d ) capacitor c=0.00213893f \
 //x=20.65 //y=0.93 //x2=20.35 //y2=1.085
cc_1429 ( N_Q_c_1840_p N_noxref_9_M10_noxref_d ) capacitor c=0.00345753f \
 //x=20.65 //y=1.585 //x2=20.35 //y2=1.085
cc_1430 ( N_Q_c_1807_p N_noxref_9_M10_noxref_d ) capacitor c=0.00211919f \
 //x=20.805 //y=1.085 //x2=20.35 //y2=1.085
cc_1431 ( N_Q_c_1810_p N_noxref_9_M10_noxref_d ) capacitor c=0.00237422f \
 //x=20.805 //y=1.43 //x2=20.35 //y2=1.085
cc_1432 ( N_Q_c_1871_p N_VDD_c_2866_n ) capacitor c=2.90144e-19 //x=18.535 \
 //y=5.39 //x2=20.505 //y2=7.585
cc_1433 ( N_Q_c_1829_p N_VDD_c_2866_n ) capacitor c=4.56938e-19 //x=18.62 \
 //y=3.655 //x2=20.505 //y2=7.585
cc_1434 ( N_Q_M32_noxref_g N_VDD_c_2868_n ) capacitor c=0.00122608f //x=20.37 \
 //y=6.205 //x2=20.59 //y2=7.035
cc_1435 ( N_Q_M33_noxref_g N_VDD_c_2868_n ) capacitor c=0.00122608f //x=20.81 \
 //y=6.205 //x2=20.59 //y2=7.035
cc_1436 ( N_Q_M32_noxref_g N_VDD_c_2870_n ) capacitor c=0.00193078f //x=20.37 \
 //y=6.205 //x2=20.59 //y2=7.41
cc_1437 ( N_Q_M33_noxref_g N_VDD_c_2870_n ) capacitor c=0.00294739f //x=20.81 \
 //y=6.205 //x2=20.59 //y2=7.41
cc_1438 ( N_Q_c_1871_p N_VDD_c_2837_n ) capacitor c=0.00130179f //x=18.535 \
 //y=5.39 //x2=19.19 //y2=7.585
cc_1439 ( N_Q_c_1887_p N_VDD_c_2837_n ) capacitor c=0.00488797f //x=18.14 \
 //y=5.56 //x2=19.19 //y2=7.585
cc_1440 ( N_Q_c_1784_p N_VDD_c_2874_n ) capacitor c=3.49022e-19 //x=20.315 \
 //y=4.885 //x2=22.32 //y2=7.58
cc_1441 ( N_Q_M32_noxref_g N_VDD_c_2874_n ) capacitor c=0.00737762f //x=20.37 \
 //y=6.205 //x2=22.32 //y2=7.58
cc_1442 ( N_Q_M33_noxref_g N_VDD_c_2874_n ) capacitor c=0.00760847f //x=20.81 \
 //y=6.205 //x2=22.32 //y2=7.58
cc_1443 ( Q N_VDD_c_2802_n ) capacitor c=0.00126419f //x=18.62 //y=4.62 \
 //x2=16.03 //y2=7.585
cc_1444 ( Q N_VDD_c_2851_n ) capacitor c=0.0301302f //x=18.62 //y=4.62 \
 //x2=19.36 //y2=7.585
cc_1445 ( Q N_VDD_c_2851_n ) capacitor c=0.00664116f //x=20.47 //y=4.62 \
 //x2=19.36 //y2=7.585
cc_1446 ( N_Q_c_1765_p N_VDD_c_2851_n ) capacitor c=0.00270468f //x=18.135 \
 //y=5.39 //x2=19.36 //y2=7.585
cc_1447 ( N_Q_c_1783_p N_VDD_c_2851_n ) capacitor c=0.00344941f //x=20.315 \
 //y=4.885 //x2=19.36 //y2=7.585
cc_1448 ( N_Q_c_1887_p N_VDD_c_2851_n ) capacitor c=0.00923288f //x=18.14 \
 //y=5.56 //x2=19.36 //y2=7.585
cc_1449 ( N_Q_c_1784_p N_VDD_c_2851_n ) capacitor c=0.00616738f //x=20.315 \
 //y=4.885 //x2=19.36 //y2=7.585
cc_1450 ( N_Q_M32_noxref_g N_VDD_c_2851_n ) capacitor c=0.00926945f //x=20.37 \
 //y=6.205 //x2=19.36 //y2=7.585
cc_1451 ( N_Q_c_1802_p N_VDD_c_2851_n ) capacitor c=0.004975f //x=20.315 \
 //y=4.885 //x2=19.36 //y2=7.585
cc_1452 ( N_Q_c_1765_p N_VDD_M27_noxref_d ) capacitor c=2.8473e-19 //x=18.135 \
 //y=5.39 //x2=15.22 //y2=5.2
cc_1453 ( N_Q_c_1887_p N_VDD_M28_noxref_d ) capacitor c=0.00560948f //x=18.14 \
 //y=5.56 //x2=17.115 //y2=5.205
cc_1454 ( Q N_VDD_M32_noxref_d ) capacitor c=4.99766e-19 //x=20.47 //y=3.51 \
 //x2=20.445 //y2=5.205
cc_1455 ( N_Q_M32_noxref_g N_VDD_M32_noxref_d ) capacitor c=0.0130453f \
 //x=20.37 //y=6.205 //x2=20.445 //y2=5.205
cc_1456 ( N_Q_M33_noxref_g N_VDD_M32_noxref_d ) capacitor c=0.0142727f \
 //x=20.81 //y=6.205 //x2=20.445 //y2=5.205
cc_1457 ( N_Q_c_1785_p N_VDD_M32_noxref_d ) capacitor c=0.00239008f //x=20.735 \
 //y=4.975 //x2=20.445 //y2=5.205
cc_1458 ( Q N_GND_c_3264_n ) capacitor c=3.83892e-19 //x=18.62 //y=3.51 \
 //x2=22.32 //y2=0.18
cc_1459 ( N_Q_c_1733_n N_GND_c_3264_n ) capacitor c=0.00996669f //x=17.21 \
 //y=1.305 //x2=22.32 //y2=0.18
cc_1460 ( N_Q_c_1746_n N_GND_c_3264_n ) capacitor c=0.00677923f //x=18.095 \
 //y=1.835 //x2=22.32 //y2=0.18
cc_1461 ( N_Q_c_1834_p N_GND_c_3264_n ) capacitor c=0.0106318f //x=18.18 \
 //y=1.3 //x2=22.32 //y2=0.18
cc_1462 ( N_Q_c_1851_p N_GND_c_3264_n ) capacitor c=0.00667116f //x=18.535 \
 //y=1.835 //x2=22.32 //y2=0.18
cc_1463 ( N_Q_c_1829_p N_GND_c_3264_n ) capacitor c=4.97367e-19 //x=18.62 \
 //y=3.655 //x2=22.32 //y2=0.18
cc_1464 ( N_Q_c_1773_p N_GND_c_3264_n ) capacitor c=2.55376e-19 //x=20.47 \
 //y=3.655 //x2=22.32 //y2=0.18
cc_1465 ( N_Q_c_1780_p N_GND_c_3264_n ) capacitor c=8.84449e-19 //x=20.47 \
 //y=2.26 //x2=22.32 //y2=0.18
cc_1466 ( N_Q_M8_noxref_d N_GND_c_3264_n ) capacitor c=3.01769e-19 //x=17.02 \
 //y=1.085 //x2=22.32 //y2=0.18
cc_1467 ( N_Q_M9_noxref_d N_GND_c_3264_n ) capacitor c=3.01769e-19 //x=17.99 \
 //y=1.085 //x2=22.32 //y2=0.18
cc_1468 ( N_Q_c_1733_n N_GND_c_3342_n ) capacitor c=0.00372564f //x=17.21 \
 //y=1.305 //x2=17.61 //y2=0.71
cc_1469 ( N_Q_c_1746_n N_GND_c_3342_n ) capacitor c=0.00128856f //x=18.095 \
 //y=1.835 //x2=17.61 //y2=0.71
cc_1470 ( N_Q_M8_noxref_d N_GND_c_3342_n ) capacitor c=0.0122548f //x=17.02 \
 //y=1.085 //x2=17.61 //y2=0.71
cc_1471 ( N_Q_c_1746_n N_GND_c_3380_n ) capacitor c=0.00128298f //x=18.095 \
 //y=1.835 //x2=18.58 //y2=0.71
cc_1472 ( N_Q_c_1834_p N_GND_c_3380_n ) capacitor c=0.0048144f //x=18.18 \
 //y=1.3 //x2=18.58 //y2=0.71
cc_1473 ( N_Q_c_1851_p N_GND_c_3380_n ) capacitor c=0.00353984f //x=18.535 \
 //y=1.835 //x2=18.58 //y2=0.71
cc_1474 ( N_Q_M9_noxref_d N_GND_c_3380_n ) capacitor c=0.0126716f //x=17.99 \
 //y=1.085 //x2=18.58 //y2=0.71
cc_1475 ( N_Q_c_1773_p N_GND_c_3384_n ) capacitor c=4.12959e-19 //x=20.47 \
 //y=3.655 //x2=20.94 //y2=0.71
cc_1476 ( N_Q_c_1780_p N_GND_c_3384_n ) capacitor c=0.0010437f //x=20.47 \
 //y=2.26 //x2=20.94 //y2=0.71
cc_1477 ( N_Q_c_1775_p N_GND_c_3384_n ) capacitor c=4.19728e-19 //x=20.47 \
 //y=2.26 //x2=20.94 //y2=0.71
cc_1478 ( N_Q_c_1806_p N_GND_c_3384_n ) capacitor c=0.0211652f //x=20.275 \
 //y=1.085 //x2=20.94 //y2=0.71
cc_1479 ( N_Q_c_1782_p N_GND_c_3384_n ) capacitor c=2.1838e-19 //x=20.275 \
 //y=2.095 //x2=20.94 //y2=0.71
cc_1480 ( N_Q_c_1807_p N_GND_c_3384_n ) capacitor c=0.00805599f //x=20.805 \
 //y=1.085 //x2=20.94 //y2=0.71
cc_1481 ( Q N_GND_c_3318_n ) capacitor c=9.34543e-19 //x=18.62 //y=2.4 \
 //x2=16.03 //y2=0.175
cc_1482 ( Q N_GND_c_3391_n ) capacitor c=0.00821798f //x=20.47 //y=2.4 \
 //x2=19.36 //y2=0.175
cc_1483 ( N_Q_c_1752_n N_GND_c_3391_n ) capacitor c=0.00306421f //x=18.18 \
 //y=1.75 //x2=19.36 //y2=0.175
cc_1484 ( N_Q_c_1851_p N_GND_c_3391_n ) capacitor c=0.0304475f //x=18.535 \
 //y=1.835 //x2=19.36 //y2=0.175
cc_1485 ( N_Q_c_1780_p N_GND_c_3391_n ) capacitor c=0.00446799f //x=20.47 \
 //y=2.26 //x2=19.36 //y2=0.175
cc_1486 ( N_Q_c_1793_p N_GND_c_3391_n ) capacitor c=0.00560367f //x=20.305 \
 //y=3.495 //x2=19.36 //y2=0.175
cc_1487 ( N_Q_c_1775_p N_GND_c_3391_n ) capacitor c=0.00385846f //x=20.47 \
 //y=2.26 //x2=19.36 //y2=0.175
cc_1488 ( N_Q_c_1782_p N_GND_c_3391_n ) capacitor c=0.00970706f //x=20.275 \
 //y=2.095 //x2=19.36 //y2=0.175
cc_1489 ( Q N_GND_M8_noxref_s ) capacitor c=0.00106787f //x=18.62 //y=3.51 \
 //x2=16.59 //y2=0.545
cc_1490 ( N_Q_c_1733_n N_GND_M8_noxref_s ) capacitor c=0.00934626f //x=17.21 \
 //y=1.305 //x2=16.59 //y2=0.545
cc_1491 ( N_Q_c_1728_n N_GND_M8_noxref_s ) capacitor c=0.0227687f //x=17.21 \
 //y=1.75 //x2=16.59 //y2=0.545
cc_1492 ( N_Q_c_1746_n N_GND_M8_noxref_s ) capacitor c=0.00839449f //x=18.095 \
 //y=1.835 //x2=16.59 //y2=0.545
cc_1493 ( N_Q_c_1834_p N_GND_M8_noxref_s ) capacitor c=0.00928773f //x=18.18 \
 //y=1.3 //x2=16.59 //y2=0.545
cc_1494 ( N_Q_c_1752_n N_GND_M8_noxref_s ) capacitor c=0.0107302f //x=18.18 \
 //y=1.75 //x2=16.59 //y2=0.545
cc_1495 ( N_Q_c_1851_p N_GND_M8_noxref_s ) capacitor c=0.0070507f //x=18.535 \
 //y=1.835 //x2=16.59 //y2=0.545
cc_1496 ( N_Q_c_1829_p N_GND_M8_noxref_s ) capacitor c=4.26628e-19 //x=18.62 \
 //y=3.655 //x2=16.59 //y2=0.545
cc_1497 ( N_Q_M8_noxref_d N_GND_M8_noxref_s ) capacitor c=0.0297221f //x=17.02 \
 //y=1.085 //x2=16.59 //y2=0.545
cc_1498 ( N_Q_M9_noxref_d N_GND_M8_noxref_s ) capacitor c=0.029747f //x=17.99 \
 //y=1.085 //x2=16.59 //y2=0.545
cc_1499 ( N_Q_c_1793_p N_GND_M10_noxref_s ) capacitor c=0.00265904f //x=20.305 \
 //y=3.495 //x2=19.92 //y2=0.545
cc_1500 ( N_Q_c_1806_p N_GND_M10_noxref_s ) capacitor c=0.0329097f //x=20.275 \
 //y=1.085 //x2=19.92 //y2=0.545
cc_1501 ( N_Q_c_1807_p N_GND_M10_noxref_s ) capacitor c=0.00605785f //x=20.805 \
 //y=1.085 //x2=19.92 //y2=0.545
cc_1502 ( N_Q_c_1810_p N_GND_M10_noxref_s ) capacitor c=0.00120103f //x=20.805 \
 //y=1.43 //x2=19.92 //y2=0.545
cc_1503 ( N_Q_c_1729_n N_noxref_13_c_3566_n ) capacitor c=0.0020748f \
 //x=17.295 //y=1.835 //x2=17.58 //y2=5.39
cc_1504 ( N_Q_c_1871_p N_noxref_13_c_3585_n ) capacitor c=0.00301289f \
 //x=18.535 //y=5.39 //x2=18.45 //y2=7.09
cc_1505 ( N_Q_c_1765_p N_noxref_13_c_3585_n ) capacitor c=0.00513626f \
 //x=18.135 //y=5.39 //x2=18.45 //y2=7.09
cc_1506 ( N_Q_c_1887_p N_noxref_13_c_3585_n ) capacitor c=0.00406191f \
 //x=18.14 //y=5.56 //x2=18.45 //y2=7.09
cc_1507 ( N_Q_c_1765_p N_noxref_13_c_3572_n ) capacitor c=6.34305e-19 \
 //x=18.135 //y=5.39 //x2=16.82 //y2=5.39
cc_1508 ( N_Q_c_1746_n N_noxref_13_c_3576_n ) capacitor c=0.0022669f \
 //x=18.095 //y=1.835 //x2=17.7 //y2=5.39
cc_1509 ( N_Q_c_1765_p N_noxref_13_c_3576_n ) capacitor c=0.0514662f \
 //x=18.135 //y=5.39 //x2=17.7 //y2=5.39
cc_1510 ( N_Q_c_1887_p N_noxref_13_c_3576_n ) capacitor c=0.00266f //x=18.14 \
 //y=5.56 //x2=17.7 //y2=5.39
cc_1511 ( N_Q_c_1871_p N_noxref_13_c_3592_n ) capacitor c=0.00564579f \
 //x=18.535 //y=5.39 //x2=18.58 //y2=6.92
cc_1512 ( N_Q_c_1765_p N_noxref_13_c_3582_n ) capacitor c=0.00275395f \
 //x=18.135 //y=5.39 //x2=17.7 //y2=5.56
cc_1513 ( N_Q_c_1887_p N_noxref_13_c_3582_n ) capacitor c=0.0684745f //x=18.14 \
 //y=5.56 //x2=17.7 //y2=5.56
cc_1514 ( Q N_noxref_13_M31_noxref_d ) capacitor c=9.55403e-19 //x=18.62 \
 //y=3.51 //x2=18.435 //y2=5.205
cc_1515 ( N_Q_c_1871_p N_noxref_13_M31_noxref_d ) capacitor c=0.00810041f \
 //x=18.535 //y=5.39 //x2=18.435 //y2=5.205
cc_1516 ( N_Q_c_1887_p N_noxref_13_M31_noxref_d ) capacitor c=0.0478953f \
 //x=18.14 //y=5.56 //x2=18.435 //y2=5.205
cc_1517 ( Q N_noxref_14_c_3659_n ) capacitor c=6.72044e-19 //x=20.47 //y=3.51 \
 //x2=20.91 //y2=5.39
cc_1518 ( N_Q_c_1773_p N_noxref_14_c_3659_n ) capacitor c=6.72747e-19 \
 //x=20.47 //y=3.655 //x2=20.91 //y2=5.39
cc_1519 ( N_Q_c_1783_p N_noxref_14_c_3659_n ) capacitor c=0.00756274f \
 //x=20.315 //y=4.885 //x2=20.91 //y2=5.39
cc_1520 ( N_Q_c_1784_p N_noxref_14_c_3659_n ) capacitor c=0.00104675f \
 //x=20.315 //y=4.885 //x2=20.91 //y2=5.39
cc_1521 ( N_Q_M32_noxref_g N_noxref_14_c_3659_n ) capacitor c=0.0106511f \
 //x=20.37 //y=6.205 //x2=20.91 //y2=5.39
cc_1522 ( N_Q_M33_noxref_g N_noxref_14_c_3659_n ) capacitor c=0.00911022f \
 //x=20.81 //y=6.205 //x2=20.91 //y2=5.39
cc_1523 ( N_Q_c_1785_p N_noxref_14_c_3659_n ) capacitor c=0.00179525f \
 //x=20.735 //y=4.975 //x2=20.91 //y2=5.39
cc_1524 ( N_Q_c_1871_p N_noxref_14_c_3666_n ) capacitor c=0.0043859f \
 //x=18.535 //y=5.39 //x2=20.15 //y2=5.39
cc_1525 ( N_Q_c_1765_p N_noxref_14_c_3666_n ) capacitor c=0.00513745f \
 //x=18.135 //y=5.39 //x2=20.15 //y2=5.39
cc_1526 ( N_Q_c_1783_p N_noxref_14_c_3666_n ) capacitor c=0.0241407f \
 //x=20.315 //y=4.885 //x2=20.15 //y2=5.39
cc_1527 ( N_Q_c_1784_p N_noxref_14_c_3666_n ) capacitor c=0.00565356f \
 //x=20.315 //y=4.885 //x2=20.15 //y2=5.39
cc_1528 ( N_Q_M32_noxref_g N_noxref_14_c_3666_n ) capacitor c=0.00403872f \
 //x=20.37 //y=6.205 //x2=20.15 //y2=5.39
cc_1529 ( N_Q_c_1802_p N_noxref_14_c_3666_n ) capacitor c=9.12041e-19 \
 //x=20.315 //y=4.885 //x2=20.15 //y2=5.39
cc_1530 ( N_Q_M33_noxref_g N_noxref_14_c_3672_n ) capacitor c=0.0018094f \
 //x=20.81 //y=6.205 //x2=21.03 //y2=5.39
cc_1531 ( N_Q_M33_noxref_g N_noxref_14_c_3673_n ) capacitor c=0.00180782f \
 //x=20.81 //y=6.205 //x2=21.03 //y2=6.92
cc_1532 ( N_Q_c_1783_p N_noxref_14_c_3674_n ) capacitor c=0.00154424f \
 //x=20.315 //y=4.885 //x2=20.15 //y2=5.56
cc_1533 ( N_Q_c_1784_p N_noxref_14_c_3674_n ) capacitor c=0.00126834f \
 //x=20.315 //y=4.885 //x2=20.15 //y2=5.56
cc_1534 ( N_Q_M32_noxref_g N_noxref_14_c_3674_n ) capacitor c=0.0483843f \
 //x=20.37 //y=6.205 //x2=20.15 //y2=5.56
cc_1535 ( N_Q_c_1802_p N_noxref_14_c_3674_n ) capacitor c=0.00297041f \
 //x=20.315 //y=4.885 //x2=20.15 //y2=5.56
cc_1536 ( N_Q_M33_noxref_g N_noxref_14_c_3678_n ) capacitor c=0.0170175f \
 //x=20.81 //y=6.205 //x2=21.03 //y2=5.56
cc_1537 ( N_Q_M32_noxref_g N_noxref_14_M32_noxref_s ) capacitor c=0.00378422f \
 //x=20.37 //y=6.205 //x2=20.015 //y2=5.205
cc_1538 ( N_noxref_8_c_2051_n N_noxref_9_c_2313_n ) capacitor c=0.00333932f \
 //x=15.29 //y=4.12 //x2=17.88 //y2=3.705
cc_1539 ( N_noxref_8_c_2103_n N_noxref_9_c_2315_n ) capacitor c=0.00532344f \
 //x=21.045 //y=4.265 //x2=17.88 //y2=4.025
cc_1540 ( N_noxref_8_c_2157_n N_noxref_9_c_2377_n ) capacitor c=0.00120307f \
 //x=21.245 //y=1.74 //x2=20.54 //y2=1.75
cc_1541 ( N_noxref_8_c_2122_n N_noxref_9_c_2384_n ) capacitor c=0.00163901f \
 //x=21.21 //y=4.425 //x2=21.425 //y2=1.835
cc_1542 ( N_noxref_8_c_2126_n N_noxref_9_c_2384_n ) capacitor c=0.0305386f \
 //x=21.21 //y=2.26 //x2=21.425 //y2=1.835
cc_1543 ( N_noxref_8_c_2141_n N_noxref_9_c_2384_n ) capacitor c=0.00491852f \
 //x=21.21 //y=2.26 //x2=21.425 //y2=1.835
cc_1544 ( N_noxref_8_c_2162_n N_noxref_9_c_2384_n ) capacitor c=0.00147817f \
 //x=21.21 //y=2.26 //x2=21.425 //y2=1.835
cc_1545 ( N_noxref_8_c_2165_n N_noxref_9_c_2384_n ) capacitor c=0.00817459f \
 //x=21.21 //y=2.095 //x2=21.425 //y2=1.835
cc_1546 ( N_noxref_8_c_2152_n N_noxref_9_c_2468_n ) capacitor c=0.00112851f \
 //x=21.245 //y=1.085 //x2=21.51 //y2=1.3
cc_1547 ( N_noxref_8_c_2154_n N_noxref_9_c_2468_n ) capacitor c=0.0021447f \
 //x=21.245 //y=1.435 //x2=21.51 //y2=1.3
cc_1548 ( N_noxref_8_c_2181_p N_noxref_9_c_2468_n ) capacitor c=5.32053e-19 \
 //x=21.62 //y=0.93 //x2=21.51 //y2=1.3
cc_1549 ( N_noxref_8_c_2159_n N_noxref_9_c_2468_n ) capacitor c=5.60411e-19 \
 //x=21.62 //y=1.585 //x2=21.51 //y2=1.3
cc_1550 ( N_noxref_8_c_2160_n N_noxref_9_c_2468_n ) capacitor c=8.66912e-19 \
 //x=21.775 //y=1.085 //x2=21.51 //y2=1.3
cc_1551 ( N_noxref_8_c_2161_n N_noxref_9_c_2468_n ) capacitor c=0.00377102f \
 //x=21.775 //y=1.435 //x2=21.51 //y2=1.3
cc_1552 ( N_noxref_8_c_2154_n N_noxref_9_c_2391_n ) capacitor c=7.7986e-19 \
 //x=21.245 //y=1.435 //x2=21.51 //y2=1.75
cc_1553 ( N_noxref_8_c_2157_n N_noxref_9_c_2391_n ) capacitor c=0.00364979f \
 //x=21.245 //y=1.74 //x2=21.51 //y2=1.75
cc_1554 ( N_noxref_8_c_2159_n N_noxref_9_c_2391_n ) capacitor c=0.0100338f \
 //x=21.62 //y=1.585 //x2=21.51 //y2=1.75
cc_1555 ( N_noxref_8_c_2161_n N_noxref_9_c_2391_n ) capacitor c=0.00135417f \
 //x=21.775 //y=1.435 //x2=21.51 //y2=1.75
cc_1556 ( N_noxref_8_M35_noxref_g N_noxref_9_c_2478_n ) capacitor c=0.0104981f \
 //x=21.69 //y=6.205 //x2=21.865 //y2=5.39
cc_1557 ( N_noxref_8_c_2159_n N_noxref_9_c_2479_n ) capacitor c=0.00500113f \
 //x=21.62 //y=1.585 //x2=21.865 //y2=1.835
cc_1558 ( N_noxref_8_c_2114_n N_noxref_9_c_2393_n ) capacitor c=0.0605043f \
 //x=21.21 //y=4.105 //x2=21.95 //y2=3.72
cc_1559 ( N_noxref_8_c_2126_n N_noxref_9_c_2393_n ) capacitor c=0.0160491f \
 //x=21.21 //y=2.26 //x2=21.95 //y2=3.72
cc_1560 ( N_noxref_8_c_2141_n N_noxref_9_c_2393_n ) capacitor c=0.0043954f \
 //x=21.21 //y=2.26 //x2=21.95 //y2=3.72
cc_1561 ( N_noxref_8_c_2162_n N_noxref_9_c_2393_n ) capacitor c=0.0028062f \
 //x=21.21 //y=2.26 //x2=21.95 //y2=3.72
cc_1562 ( N_noxref_8_c_2165_n N_noxref_9_c_2393_n ) capacitor c=0.00311553f \
 //x=21.21 //y=2.095 //x2=21.95 //y2=3.72
cc_1563 ( N_noxref_8_c_2114_n N_noxref_9_c_2485_n ) capacitor c=0.0177385f \
 //x=21.21 //y=4.105 //x2=21.95 //y2=4.04
cc_1564 ( N_noxref_8_c_2197_p N_noxref_9_c_2485_n ) capacitor c=0.00127346f \
 //x=21.615 //y=4.975 //x2=21.95 //y2=4.04
cc_1565 ( N_noxref_8_c_2114_n N_noxref_9_c_2395_n ) capacitor c=0.00287935f \
 //x=21.21 //y=4.105 //x2=21.95 //y2=5.305
cc_1566 ( N_noxref_8_c_2122_n N_noxref_9_c_2395_n ) capacitor c=0.0150234f \
 //x=21.21 //y=4.425 //x2=21.95 //y2=5.305
cc_1567 ( N_noxref_8_c_2125_n N_noxref_9_c_2395_n ) capacitor c=0.00475541f \
 //x=21.21 //y=4.25 //x2=21.95 //y2=5.305
cc_1568 ( N_noxref_8_c_2129_n N_noxref_9_c_2395_n ) capacitor c=0.0175188f \
 //x=21.245 //y=4.885 //x2=21.95 //y2=5.305
cc_1569 ( N_noxref_8_c_2132_n N_noxref_9_c_2395_n ) capacitor c=0.0137769f \
 //x=21.245 //y=4.74 //x2=21.95 //y2=5.305
cc_1570 ( N_noxref_8_c_2134_n N_noxref_9_c_2395_n ) capacitor c=0.0068343f \
 //x=21.205 //y=4.265 //x2=21.95 //y2=5.305
cc_1571 ( N_noxref_8_c_2145_n N_noxref_9_c_2395_n ) capacitor c=0.00454427f \
 //x=21.245 //y=4.885 //x2=21.95 //y2=5.305
cc_1572 ( N_noxref_8_c_2197_p N_noxref_9_c_2395_n ) capacitor c=0.00852293f \
 //x=21.615 //y=4.975 //x2=21.95 //y2=5.305
cc_1573 ( N_noxref_8_c_2166_n N_noxref_9_c_2395_n ) capacitor c=0.00141757f \
 //x=21.245 //y=4.885 //x2=21.95 //y2=5.305
cc_1574 ( N_noxref_8_c_2103_n N_noxref_9_c_2321_n ) capacitor c=0.00266476f \
 //x=21.045 //y=4.265 //x2=17.915 //y2=4.885
cc_1575 ( N_noxref_8_c_2063_n N_noxref_9_c_2324_n ) capacitor c=0.001586f \
 //x=15.29 //y=5.055 //x2=17.915 //y2=4.74
cc_1576 ( N_noxref_8_c_2103_n N_noxref_9_c_2324_n ) capacitor c=0.0242764f \
 //x=21.045 //y=4.265 //x2=17.915 //y2=4.74
cc_1577 ( N_noxref_8_c_2129_n N_noxref_9_c_2405_n ) capacitor c=0.00198652f \
 //x=21.245 //y=4.885 //x2=21.465 //y2=5.39
cc_1578 ( N_noxref_8_M34_noxref_g N_noxref_9_c_2405_n ) capacitor \
 c=0.00184899f //x=21.25 //y=6.205 //x2=21.465 //y2=5.39
cc_1579 ( N_noxref_8_M35_noxref_g N_noxref_9_c_2405_n ) capacitor \
 c=0.00339097f //x=21.69 //y=6.205 //x2=21.465 //y2=5.39
cc_1580 ( N_noxref_8_c_2197_p N_noxref_9_c_2405_n ) capacitor c=0.00213157f \
 //x=21.615 //y=4.975 //x2=21.465 //y2=5.39
cc_1581 ( N_noxref_8_c_2114_n N_noxref_9_c_2503_n ) capacitor c=6.78671e-19 \
 //x=21.21 //y=4.105 //x2=21.945 //y2=3.88
cc_1582 ( N_noxref_8_c_2114_n N_noxref_9_c_2406_n ) capacitor c=0.0244465f \
 //x=21.21 //y=4.105 //x2=21.785 //y2=3.88
cc_1583 ( N_noxref_8_c_2122_n N_noxref_9_c_2406_n ) capacitor c=0.00594019f \
 //x=21.21 //y=4.425 //x2=21.785 //y2=3.88
cc_1584 ( N_noxref_8_c_2126_n N_noxref_9_c_2406_n ) capacitor c=0.00226111f \
 //x=21.21 //y=2.26 //x2=21.785 //y2=3.88
cc_1585 ( N_noxref_8_c_2134_n N_noxref_9_c_2406_n ) capacitor c=0.0374977f \
 //x=21.205 //y=4.265 //x2=21.785 //y2=3.88
cc_1586 ( N_noxref_8_c_2103_n N_noxref_9_c_2406_n ) capacitor c=0.272429f \
 //x=21.045 //y=4.265 //x2=21.785 //y2=3.88
cc_1587 ( N_noxref_8_c_2103_n N_noxref_9_c_2327_n ) capacitor c=0.0374977f \
 //x=21.045 //y=4.265 //x2=18.04 //y2=3.865
cc_1588 ( N_noxref_8_c_2114_n N_noxref_9_c_2510_n ) capacitor c=0.00328982f \
 //x=21.21 //y=4.105 //x2=21.945 //y2=3.88
cc_1589 ( N_noxref_8_M34_noxref_g N_noxref_9_c_2511_n ) capacitor c=0.0120591f \
 //x=21.25 //y=6.205 //x2=21.47 //y2=5.56
cc_1590 ( N_noxref_8_M35_noxref_g N_noxref_9_c_2511_n ) capacitor c=0.0140704f \
 //x=21.69 //y=6.205 //x2=21.47 //y2=5.56
cc_1591 ( N_noxref_8_c_2197_p N_noxref_9_c_2511_n ) capacitor c=0.00293135f \
 //x=21.615 //y=4.975 //x2=21.47 //y2=5.56
cc_1592 ( N_noxref_8_c_2152_n N_noxref_9_M11_noxref_d ) capacitor \
 c=0.00218694f //x=21.245 //y=1.085 //x2=21.32 //y2=1.085
cc_1593 ( N_noxref_8_c_2154_n N_noxref_9_M11_noxref_d ) capacitor \
 c=0.00237422f //x=21.245 //y=1.435 //x2=21.32 //y2=1.085
cc_1594 ( N_noxref_8_c_2181_p N_noxref_9_M11_noxref_d ) capacitor \
 c=0.00213893f //x=21.62 //y=0.93 //x2=21.32 //y2=1.085
cc_1595 ( N_noxref_8_c_2159_n N_noxref_9_M11_noxref_d ) capacitor \
 c=0.00357974f //x=21.62 //y=1.585 //x2=21.32 //y2=1.085
cc_1596 ( N_noxref_8_c_2160_n N_noxref_9_M11_noxref_d ) capacitor c=0.0012513f \
 //x=21.775 //y=1.085 //x2=21.32 //y2=1.085
cc_1597 ( N_noxref_8_c_2161_n N_noxref_9_M11_noxref_d ) capacitor \
 c=0.00237422f //x=21.775 //y=1.435 //x2=21.32 //y2=1.085
cc_1598 ( N_noxref_8_c_2040_n N_VDD_c_2596_n ) capacitor c=0.00259721f \
 //x=14.925 //y=5.42 //x2=17.175 //y2=7.585
cc_1599 ( N_noxref_8_c_2047_n N_VDD_c_2596_n ) capacitor c=0.00266629f \
 //x=15.205 //y=5.14 //x2=17.175 //y2=7.585
cc_1600 ( N_noxref_8_c_2079_n N_VDD_c_2596_n ) capacitor c=0.00241566f \
 //x=14.925 //y=5.56 //x2=17.175 //y2=7.585
cc_1601 ( N_noxref_8_c_2040_n N_VDD_c_2788_n ) capacitor c=8.96756e-19 \
 //x=14.925 //y=5.42 //x2=15.28 //y2=7.585
cc_1602 ( N_noxref_8_c_2047_n N_VDD_c_2788_n ) capacitor c=0.0019409f \
 //x=15.205 //y=5.14 //x2=15.28 //y2=7.585
cc_1603 ( N_noxref_8_c_2079_n N_VDD_c_2788_n ) capacitor c=0.0138017f \
 //x=14.925 //y=5.56 //x2=15.28 //y2=7.585
cc_1604 ( N_noxref_8_c_2125_n N_VDD_c_2874_n ) capacitor c=0.00143727f \
 //x=21.21 //y=4.25 //x2=22.32 //y2=7.58
cc_1605 ( N_noxref_8_c_2145_n N_VDD_c_2874_n ) capacitor c=0.00231379f \
 //x=21.245 //y=4.885 //x2=22.32 //y2=7.58
cc_1606 ( N_noxref_8_M34_noxref_g N_VDD_c_2874_n ) capacitor c=0.00724816f \
 //x=21.25 //y=6.205 //x2=22.32 //y2=7.58
cc_1607 ( N_noxref_8_M35_noxref_g N_VDD_c_2874_n ) capacitor c=0.00782837f \
 //x=21.69 //y=6.205 //x2=22.32 //y2=7.58
cc_1608 ( N_noxref_8_c_2197_p N_VDD_c_2874_n ) capacitor c=0.0258764f \
 //x=21.615 //y=4.975 //x2=22.32 //y2=7.58
cc_1609 ( N_noxref_8_c_2166_n N_VDD_c_2874_n ) capacitor c=2.75092e-19 \
 //x=21.245 //y=4.885 //x2=22.32 //y2=7.58
cc_1610 ( N_noxref_8_c_2048_n N_VDD_c_2750_n ) capacitor c=0.00464635f \
 //x=15.01 //y=5.14 //x2=13.81 //y2=7.585
cc_1611 ( N_noxref_8_c_2032_n N_VDD_c_2750_n ) capacitor c=0.00143727f \
 //x=15.29 //y=4.25 //x2=13.81 //y2=7.585
cc_1612 ( N_noxref_8_c_2079_n N_VDD_c_2750_n ) capacitor c=0.00820745f \
 //x=14.925 //y=5.56 //x2=13.81 //y2=7.585
cc_1613 ( N_noxref_8_c_2040_n N_VDD_c_2802_n ) capacitor c=0.00233135f \
 //x=14.925 //y=5.42 //x2=16.03 //y2=7.585
cc_1614 ( N_noxref_8_c_2061_n N_VDD_c_2802_n ) capacitor c=0.00244085f \
 //x=15.29 //y=4.44 //x2=16.03 //y2=7.585
cc_1615 ( N_noxref_8_c_2063_n N_VDD_c_2802_n ) capacitor c=0.0186486f \
 //x=15.29 //y=5.055 //x2=16.03 //y2=7.585
cc_1616 ( N_noxref_8_c_2032_n N_VDD_c_2802_n ) capacitor c=0.00493928f \
 //x=15.29 //y=4.25 //x2=16.03 //y2=7.585
cc_1617 ( N_noxref_8_c_2103_n N_VDD_c_2802_n ) capacitor c=0.0191057f \
 //x=21.045 //y=4.265 //x2=16.03 //y2=7.585
cc_1618 ( N_noxref_8_c_2079_n N_VDD_c_2802_n ) capacitor c=0.00821732f \
 //x=14.925 //y=5.56 //x2=16.03 //y2=7.585
cc_1619 ( N_noxref_8_c_2125_n N_VDD_c_2851_n ) capacitor c=8.50173e-19 \
 //x=21.21 //y=4.25 //x2=19.36 //y2=7.585
cc_1620 ( N_noxref_8_c_2103_n N_VDD_c_2851_n ) capacitor c=0.0196019f \
 //x=21.045 //y=4.265 //x2=19.36 //y2=7.585
cc_1621 ( N_noxref_8_c_2040_n N_VDD_M22_noxref_s ) capacitor c=2.62188e-19 \
 //x=14.925 //y=5.42 //x2=11.135 //y2=5.2
cc_1622 ( N_noxref_8_c_2040_n N_VDD_M26_noxref_s ) capacitor c=0.0465774f \
 //x=14.925 //y=5.42 //x2=14.35 //y2=5.2
cc_1623 ( N_noxref_8_c_2079_n N_VDD_M26_noxref_s ) capacitor c=0.0897769f \
 //x=14.925 //y=5.56 //x2=14.35 //y2=5.2
cc_1624 ( N_noxref_8_c_2040_n N_VDD_M27_noxref_d ) capacitor c=0.0474638f \
 //x=14.925 //y=5.42 //x2=15.22 //y2=5.2
cc_1625 ( N_noxref_8_c_2047_n N_VDD_M27_noxref_d ) capacitor c=0.0201521f \
 //x=15.205 //y=5.14 //x2=15.22 //y2=5.2
cc_1626 ( N_noxref_8_c_2061_n N_VDD_M27_noxref_d ) capacitor c=0.00468348f \
 //x=15.29 //y=4.44 //x2=15.22 //y2=5.2
cc_1627 ( N_noxref_8_c_2032_n N_VDD_M27_noxref_d ) capacitor c=0.00133028f \
 //x=15.29 //y=4.25 //x2=15.22 //y2=5.2
cc_1628 ( N_noxref_8_c_2078_n N_VDD_M27_noxref_d ) capacitor c=0.00110511f \
 //x=15.445 //y=4.28 //x2=15.22 //y2=5.2
cc_1629 ( N_noxref_8_c_2103_n N_VDD_M27_noxref_d ) capacitor c=5.53164e-19 \
 //x=21.045 //y=4.265 //x2=15.22 //y2=5.2
cc_1630 ( N_noxref_8_c_2079_n N_VDD_M27_noxref_d ) capacitor c=0.0904512f \
 //x=14.925 //y=5.56 //x2=15.22 //y2=5.2
cc_1631 ( N_noxref_8_c_2044_n N_GND_c_3264_n ) capacitor c=0.00499609f \
 //x=15.205 //y=2.02 //x2=22.32 //y2=0.18
cc_1632 ( N_noxref_8_c_2061_n N_GND_c_3264_n ) capacitor c=4.35164e-19 \
 //x=15.29 //y=4.44 //x2=22.32 //y2=0.18
cc_1633 ( N_noxref_8_c_2068_n N_GND_c_3264_n ) capacitor c=0.00998676f \
 //x=14.92 //y=1.185 //x2=22.32 //y2=0.18
cc_1634 ( N_noxref_8_M7_noxref_d N_GND_c_3264_n ) capacitor c=0.00119455f \
 //x=14.735 //y=1.09 //x2=22.32 //y2=0.18
cc_1635 ( N_noxref_8_c_2068_n N_GND_c_3303_n ) capacitor c=0.00124813f \
 //x=14.92 //y=1.185 //x2=14.835 //y2=0.715
cc_1636 ( N_noxref_8_c_2044_n N_GND_c_3307_n ) capacitor c=0.00311091f \
 //x=15.205 //y=2.02 //x2=15.325 //y2=0.715
cc_1637 ( N_noxref_8_c_2068_n N_GND_c_3307_n ) capacitor c=0.00130539f \
 //x=14.92 //y=1.185 //x2=15.325 //y2=0.715
cc_1638 ( N_noxref_8_c_2032_n N_GND_c_3307_n ) capacitor c=2.04781e-19 \
 //x=15.29 //y=4.25 //x2=15.325 //y2=0.715
cc_1639 ( N_noxref_8_c_2126_n N_GND_c_3420_n ) capacitor c=3.09398e-19 \
 //x=21.21 //y=2.26 //x2=21.91 //y2=0.71
cc_1640 ( N_noxref_8_c_2141_n N_GND_c_3420_n ) capacitor c=8.64363e-19 \
 //x=21.21 //y=2.26 //x2=21.91 //y2=0.71
cc_1641 ( N_noxref_8_c_2152_n N_GND_c_3420_n ) capacitor c=0.0210318f \
 //x=21.245 //y=1.085 //x2=21.91 //y2=0.71
cc_1642 ( N_noxref_8_c_2160_n N_GND_c_3420_n ) capacitor c=0.00825432f \
 //x=21.775 //y=1.085 //x2=21.91 //y2=0.71
cc_1643 ( N_noxref_8_c_2162_n N_GND_c_3420_n ) capacitor c=2.1838e-19 \
 //x=21.21 //y=2.26 //x2=21.91 //y2=0.71
cc_1644 ( N_noxref_8_c_2068_n N_GND_c_3146_n ) capacitor c=2.8029e-19 \
 //x=14.92 //y=1.185 //x2=22.32 //y2=0.18
cc_1645 ( N_noxref_8_c_2141_n N_GND_c_3146_n ) capacitor c=0.00224736f \
 //x=21.21 //y=2.26 //x2=22.32 //y2=0.18
cc_1646 ( N_noxref_8_c_2159_n N_GND_c_3146_n ) capacitor c=0.00300407f \
 //x=21.62 //y=1.585 //x2=22.32 //y2=0.18
cc_1647 ( N_noxref_8_c_2162_n N_GND_c_3146_n ) capacitor c=2.63786e-19 \
 //x=21.21 //y=2.26 //x2=22.32 //y2=0.18
cc_1648 ( N_noxref_8_c_2033_n N_GND_c_3279_n ) capacitor c=0.00272952f \
 //x=14.92 //y=1.935 //x2=13.81 //y2=0.175
cc_1649 ( N_noxref_8_c_2044_n N_GND_c_3318_n ) capacitor c=0.023022f \
 //x=15.205 //y=2.02 //x2=16.03 //y2=0.175
cc_1650 ( N_noxref_8_c_2033_n N_GND_M7_noxref_s ) capacitor c=0.0287657f \
 //x=14.92 //y=1.935 //x2=14.305 //y2=0.55
cc_1651 ( N_noxref_8_c_2044_n N_GND_M7_noxref_s ) capacitor c=0.0042252f \
 //x=15.205 //y=2.02 //x2=14.305 //y2=0.55
cc_1652 ( N_noxref_8_c_2061_n N_GND_M7_noxref_s ) capacitor c=8.03398e-19 \
 //x=15.29 //y=4.44 //x2=14.305 //y2=0.55
cc_1653 ( N_noxref_8_c_2068_n N_GND_M7_noxref_s ) capacitor c=0.0139466f \
 //x=14.92 //y=1.185 //x2=14.305 //y2=0.55
cc_1654 ( N_noxref_8_c_2032_n N_GND_M7_noxref_s ) capacitor c=4.73387e-19 \
 //x=15.29 //y=4.25 //x2=14.305 //y2=0.55
cc_1655 ( N_noxref_8_M7_noxref_d N_GND_M7_noxref_s ) capacitor c=0.0377642f \
 //x=14.735 //y=1.09 //x2=14.305 //y2=0.55
cc_1656 ( N_noxref_8_c_2152_n N_GND_M10_noxref_s ) capacitor c=0.00720961f \
 //x=21.245 //y=1.085 //x2=19.92 //y2=0.545
cc_1657 ( N_noxref_8_c_2159_n N_GND_M10_noxref_s ) capacitor c=0.00271091f \
 //x=21.62 //y=1.585 //x2=19.92 //y2=0.545
cc_1658 ( N_noxref_8_c_2160_n N_GND_M10_noxref_s ) capacitor c=0.0151996f \
 //x=21.775 //y=1.085 //x2=19.92 //y2=0.545
cc_1659 ( N_noxref_8_c_2162_n N_GND_M10_noxref_s ) capacitor c=0.00119136f \
 //x=21.21 //y=2.26 //x2=19.92 //y2=0.545
cc_1660 ( N_noxref_8_c_2103_n N_noxref_13_c_3566_n ) capacitor c=0.0162121f \
 //x=21.045 //y=4.265 //x2=17.58 //y2=5.39
cc_1661 ( N_noxref_8_c_2040_n N_noxref_13_c_3572_n ) capacitor c=0.00174649f \
 //x=14.925 //y=5.42 //x2=16.82 //y2=5.39
cc_1662 ( N_noxref_8_c_2103_n N_noxref_13_c_3572_n ) capacitor c=0.00338679f \
 //x=21.045 //y=4.265 //x2=16.82 //y2=5.39
cc_1663 ( N_noxref_8_c_2103_n N_noxref_14_c_3659_n ) capacitor c=0.0141499f \
 //x=21.045 //y=4.265 //x2=20.91 //y2=5.39
cc_1664 ( N_noxref_8_c_2129_n N_noxref_14_c_3681_n ) capacitor c=0.00213672f \
 //x=21.245 //y=4.885 //x2=21.78 //y2=7.09
cc_1665 ( N_noxref_8_c_2145_n N_noxref_14_c_3681_n ) capacitor c=0.00233585f \
 //x=21.245 //y=4.885 //x2=21.78 //y2=7.09
cc_1666 ( N_noxref_8_M34_noxref_g N_noxref_14_c_3681_n ) capacitor \
 c=0.00777443f //x=21.25 //y=6.205 //x2=21.78 //y2=7.09
cc_1667 ( N_noxref_8_M35_noxref_g N_noxref_14_c_3681_n ) capacitor \
 c=0.0093887f //x=21.69 //y=6.205 //x2=21.78 //y2=7.09
cc_1668 ( N_noxref_8_c_2103_n N_noxref_14_c_3666_n ) capacitor c=0.00365089f \
 //x=21.045 //y=4.265 //x2=20.15 //y2=5.39
cc_1669 ( N_noxref_8_c_2122_n N_noxref_14_c_3672_n ) capacitor c=0.00555654f \
 //x=21.21 //y=4.425 //x2=21.03 //y2=5.39
cc_1670 ( N_noxref_8_c_2129_n N_noxref_14_c_3672_n ) capacitor c=0.00257134f \
 //x=21.245 //y=4.885 //x2=21.03 //y2=5.39
cc_1671 ( N_noxref_8_c_2134_n N_noxref_14_c_3672_n ) capacitor c=0.0012852f \
 //x=21.205 //y=4.265 //x2=21.03 //y2=5.39
cc_1672 ( N_noxref_8_c_2103_n N_noxref_14_c_3672_n ) capacitor c=0.0015006f \
 //x=21.045 //y=4.265 //x2=21.03 //y2=5.39
cc_1673 ( N_noxref_8_M34_noxref_g N_noxref_14_c_3672_n ) capacitor \
 c=0.00176767f //x=21.25 //y=6.205 //x2=21.03 //y2=5.39
cc_1674 ( N_noxref_8_c_2166_n N_noxref_14_c_3672_n ) capacitor c=5.53197e-19 \
 //x=21.245 //y=4.885 //x2=21.03 //y2=5.39
cc_1675 ( N_noxref_8_M34_noxref_g N_noxref_14_c_3673_n ) capacitor \
 c=0.00186228f //x=21.25 //y=6.205 //x2=21.03 //y2=6.92
cc_1676 ( N_noxref_8_M35_noxref_g N_noxref_14_c_3693_n ) capacitor \
 c=0.00410728f //x=21.69 //y=6.205 //x2=21.91 //y2=6.92
cc_1677 ( N_noxref_8_c_2122_n N_noxref_14_c_3678_n ) capacitor c=0.0015444f \
 //x=21.21 //y=4.425 //x2=21.03 //y2=5.56
cc_1678 ( N_noxref_8_M34_noxref_g N_noxref_14_c_3678_n ) capacitor \
 c=0.0170175f //x=21.25 //y=6.205 //x2=21.03 //y2=5.56
cc_1679 ( N_noxref_8_M35_noxref_g N_noxref_14_M35_noxref_d ) capacitor \
 c=0.0365939f //x=21.69 //y=6.205 //x2=21.765 //y2=5.205
cc_1680 ( N_noxref_9_c_2478_n N_VDD_c_2925_n ) capacitor c=2.90144e-19 \
 //x=21.865 //y=5.39 //x2=22.32 //y2=7.58
cc_1681 ( N_noxref_9_M30_noxref_g N_VDD_c_2837_n ) capacitor c=0.00724816f \
 //x=17.92 //y=6.205 //x2=19.19 //y2=7.585
cc_1682 ( N_noxref_9_M31_noxref_g N_VDD_c_2837_n ) capacitor c=0.00782837f \
 //x=18.36 //y=6.205 //x2=19.19 //y2=7.585
cc_1683 ( N_noxref_9_c_2478_n N_VDD_c_2874_n ) capacitor c=6.92778e-19 \
 //x=21.865 //y=5.39 //x2=22.32 //y2=7.58
cc_1684 ( N_noxref_9_c_2395_n N_VDD_c_2874_n ) capacitor c=0.0373591f \
 //x=21.95 //y=5.305 //x2=22.32 //y2=7.58
cc_1685 ( N_noxref_9_c_2405_n N_VDD_c_2874_n ) capacitor c=0.00422052f \
 //x=21.465 //y=5.39 //x2=22.32 //y2=7.58
cc_1686 ( N_noxref_9_c_2511_n N_VDD_c_2874_n ) capacitor c=0.0143677f \
 //x=21.47 //y=5.56 //x2=22.32 //y2=7.58
cc_1687 ( N_noxref_9_c_2395_n N_VDD_c_2851_n ) capacitor c=0.00143978f \
 //x=21.95 //y=5.305 //x2=19.36 //y2=7.585
cc_1688 ( N_noxref_9_c_2333_n N_VDD_c_2851_n ) capacitor c=0.00231379f \
 //x=17.915 //y=4.885 //x2=19.36 //y2=7.585
cc_1689 ( N_noxref_9_c_2432_n N_VDD_c_2851_n ) capacitor c=0.016784f \
 //x=18.285 //y=4.975 //x2=19.36 //y2=7.585
cc_1690 ( N_noxref_9_c_2354_n N_VDD_c_2851_n ) capacitor c=2.75092e-19 \
 //x=17.915 //y=4.885 //x2=19.36 //y2=7.585
cc_1691 ( N_noxref_9_c_2511_n N_VDD_M32_noxref_d ) capacitor c=0.00561178f \
 //x=21.47 //y=5.56 //x2=20.445 //y2=5.205
cc_1692 ( N_noxref_9_c_2368_n N_GND_c_3264_n ) capacitor c=0.00996669f \
 //x=20.54 //y=1.305 //x2=22.32 //y2=0.18
cc_1693 ( N_noxref_9_c_2384_n N_GND_c_3264_n ) capacitor c=0.00677787f \
 //x=21.425 //y=1.835 //x2=22.32 //y2=0.18
cc_1694 ( N_noxref_9_c_2468_n N_GND_c_3264_n ) capacitor c=0.0106318f \
 //x=21.51 //y=1.3 //x2=22.32 //y2=0.18
cc_1695 ( N_noxref_9_c_2479_n N_GND_c_3264_n ) capacitor c=0.00667117f \
 //x=21.865 //y=1.835 //x2=22.32 //y2=0.18
cc_1696 ( N_noxref_9_M10_noxref_d N_GND_c_3264_n ) capacitor c=3.01769e-19 \
 //x=20.35 //y=1.085 //x2=22.32 //y2=0.18
cc_1697 ( N_noxref_9_M11_noxref_d N_GND_c_3264_n ) capacitor c=3.01769e-19 \
 //x=21.32 //y=1.085 //x2=22.32 //y2=0.18
cc_1698 ( N_noxref_9_c_2318_n N_GND_c_3380_n ) capacitor c=3.09398e-19 \
 //x=17.88 //y=2.26 //x2=18.58 //y2=0.71
cc_1699 ( N_noxref_9_c_2329_n N_GND_c_3380_n ) capacitor c=8.64363e-19 \
 //x=17.88 //y=2.26 //x2=18.58 //y2=0.71
cc_1700 ( N_noxref_9_c_2340_n N_GND_c_3380_n ) capacitor c=0.0211076f \
 //x=17.915 //y=1.085 //x2=18.58 //y2=0.71
cc_1701 ( N_noxref_9_c_2348_n N_GND_c_3380_n ) capacitor c=0.00825432f \
 //x=18.445 //y=1.085 //x2=18.58 //y2=0.71
cc_1702 ( N_noxref_9_c_2350_n N_GND_c_3380_n ) capacitor c=2.1838e-19 \
 //x=17.88 //y=2.26 //x2=18.58 //y2=0.71
cc_1703 ( N_noxref_9_c_2368_n N_GND_c_3384_n ) capacitor c=0.00372564f \
 //x=20.54 //y=1.305 //x2=20.94 //y2=0.71
cc_1704 ( N_noxref_9_c_2384_n N_GND_c_3384_n ) capacitor c=0.00128856f \
 //x=21.425 //y=1.835 //x2=20.94 //y2=0.71
cc_1705 ( N_noxref_9_M10_noxref_d N_GND_c_3384_n ) capacitor c=0.0122548f \
 //x=20.35 //y=1.085 //x2=20.94 //y2=0.71
cc_1706 ( N_noxref_9_c_2384_n N_GND_c_3420_n ) capacitor c=0.00128298f \
 //x=21.425 //y=1.835 //x2=21.91 //y2=0.71
cc_1707 ( N_noxref_9_c_2468_n N_GND_c_3420_n ) capacitor c=0.00469733f \
 //x=21.51 //y=1.3 //x2=21.91 //y2=0.71
cc_1708 ( N_noxref_9_c_2479_n N_GND_c_3420_n ) capacitor c=0.00369882f \
 //x=21.865 //y=1.835 //x2=21.91 //y2=0.71
cc_1709 ( N_noxref_9_M11_noxref_d N_GND_c_3420_n ) capacitor c=0.0122548f \
 //x=21.32 //y=1.085 //x2=21.91 //y2=0.71
cc_1710 ( N_noxref_9_c_2391_n N_GND_c_3146_n ) capacitor c=0.00532028f \
 //x=21.51 //y=1.75 //x2=22.32 //y2=0.18
cc_1711 ( N_noxref_9_c_2479_n N_GND_c_3146_n ) capacitor c=0.0385015f \
 //x=21.865 //y=1.835 //x2=22.32 //y2=0.18
cc_1712 ( N_noxref_9_c_2393_n N_GND_c_3391_n ) capacitor c=0.00121611f \
 //x=21.95 //y=3.72 //x2=19.36 //y2=0.175
cc_1713 ( N_noxref_9_c_2329_n N_GND_c_3391_n ) capacitor c=0.00231028f \
 //x=17.88 //y=2.26 //x2=19.36 //y2=0.175
cc_1714 ( N_noxref_9_c_2347_n N_GND_c_3391_n ) capacitor c=0.0028635f \
 //x=18.29 //y=1.585 //x2=19.36 //y2=0.175
cc_1715 ( N_noxref_9_c_2340_n N_GND_M8_noxref_s ) capacitor c=0.00720961f \
 //x=17.915 //y=1.085 //x2=16.59 //y2=0.545
cc_1716 ( N_noxref_9_c_2347_n N_GND_M8_noxref_s ) capacitor c=0.00271091f \
 //x=18.29 //y=1.585 //x2=16.59 //y2=0.545
cc_1717 ( N_noxref_9_c_2348_n N_GND_M8_noxref_s ) capacitor c=0.0151996f \
 //x=18.445 //y=1.085 //x2=16.59 //y2=0.545
cc_1718 ( N_noxref_9_c_2350_n N_GND_M8_noxref_s ) capacitor c=0.00119136f \
 //x=17.88 //y=2.26 //x2=16.59 //y2=0.545
cc_1719 ( N_noxref_9_c_2368_n N_GND_M10_noxref_s ) capacitor c=0.00922375f \
 //x=20.54 //y=1.305 //x2=19.92 //y2=0.545
cc_1720 ( N_noxref_9_c_2377_n N_GND_M10_noxref_s ) capacitor c=0.0225586f \
 //x=20.54 //y=1.75 //x2=19.92 //y2=0.545
cc_1721 ( N_noxref_9_c_2384_n N_GND_M10_noxref_s ) capacitor c=0.00756761f \
 //x=21.425 //y=1.835 //x2=19.92 //y2=0.545
cc_1722 ( N_noxref_9_c_2468_n N_GND_M10_noxref_s ) capacitor c=0.0110093f \
 //x=21.51 //y=1.3 //x2=19.92 //y2=0.545
cc_1723 ( N_noxref_9_c_2391_n N_GND_M10_noxref_s ) capacitor c=0.0124822f \
 //x=21.51 //y=1.75 //x2=19.92 //y2=0.545
cc_1724 ( N_noxref_9_c_2479_n N_GND_M10_noxref_s ) capacitor c=0.00737383f \
 //x=21.865 //y=1.835 //x2=19.92 //y2=0.545
cc_1725 ( N_noxref_9_c_2485_n N_GND_M10_noxref_s ) capacitor c=2.69689e-19 \
 //x=21.95 //y=4.04 //x2=19.92 //y2=0.545
cc_1726 ( N_noxref_9_c_2503_n N_GND_M10_noxref_s ) capacitor c=8.54723e-19 \
 //x=21.945 //y=3.88 //x2=19.92 //y2=0.545
cc_1727 ( N_noxref_9_M10_noxref_d N_GND_M10_noxref_s ) capacitor c=0.0297221f \
 //x=20.35 //y=1.085 //x2=19.92 //y2=0.545
cc_1728 ( N_noxref_9_M11_noxref_d N_GND_M10_noxref_s ) capacitor c=0.029747f \
 //x=21.32 //y=1.085 //x2=19.92 //y2=0.545
cc_1729 ( N_noxref_9_c_2321_n N_noxref_13_c_3585_n ) capacitor c=0.00213686f \
 //x=17.915 //y=4.885 //x2=18.45 //y2=7.09
cc_1730 ( N_noxref_9_c_2333_n N_noxref_13_c_3585_n ) capacitor c=0.00233585f \
 //x=17.915 //y=4.885 //x2=18.45 //y2=7.09
cc_1731 ( N_noxref_9_M30_noxref_g N_noxref_13_c_3585_n ) capacitor \
 c=0.00777443f //x=17.92 //y=6.205 //x2=18.45 //y2=7.09
cc_1732 ( N_noxref_9_M31_noxref_g N_noxref_13_c_3585_n ) capacitor \
 c=0.0093887f //x=18.36 //y=6.205 //x2=18.45 //y2=7.09
cc_1733 ( N_noxref_9_c_2315_n N_noxref_13_c_3576_n ) capacitor c=0.00211135f \
 //x=17.88 //y=4.025 //x2=17.7 //y2=5.39
cc_1734 ( N_noxref_9_c_2321_n N_noxref_13_c_3576_n ) capacitor c=0.00257641f \
 //x=17.915 //y=4.885 //x2=17.7 //y2=5.39
cc_1735 ( N_noxref_9_M30_noxref_g N_noxref_13_c_3576_n ) capacitor \
 c=0.00176767f //x=17.92 //y=6.205 //x2=17.7 //y2=5.39
cc_1736 ( N_noxref_9_c_2354_n N_noxref_13_c_3576_n ) capacitor c=5.89864e-19 \
 //x=17.915 //y=4.885 //x2=17.7 //y2=5.39
cc_1737 ( N_noxref_9_M30_noxref_g N_noxref_13_c_3577_n ) capacitor \
 c=0.00186228f //x=17.92 //y=6.205 //x2=17.7 //y2=6.92
cc_1738 ( N_noxref_9_M31_noxref_g N_noxref_13_c_3592_n ) capacitor \
 c=0.00410728f //x=18.36 //y=6.205 //x2=18.58 //y2=6.92
cc_1739 ( N_noxref_9_M30_noxref_g N_noxref_13_c_3582_n ) capacitor \
 c=0.0170175f //x=17.92 //y=6.205 //x2=17.7 //y2=5.56
cc_1740 ( N_noxref_9_M31_noxref_g N_noxref_13_M31_noxref_d ) capacitor \
 c=0.0365939f //x=18.36 //y=6.205 //x2=18.435 //y2=5.205
cc_1741 ( N_noxref_9_c_2368_n N_noxref_14_c_3659_n ) capacitor c=2.97625e-19 \
 //x=20.54 //y=1.305 //x2=20.91 //y2=5.39
cc_1742 ( N_noxref_9_c_2385_n N_noxref_14_c_3659_n ) capacitor c=0.00190123f \
 //x=20.625 //y=1.835 //x2=20.91 //y2=5.39
cc_1743 ( N_noxref_9_c_2478_n N_noxref_14_c_3681_n ) capacitor c=0.00300849f \
 //x=21.865 //y=5.39 //x2=21.78 //y2=7.09
cc_1744 ( N_noxref_9_c_2405_n N_noxref_14_c_3681_n ) capacitor c=0.00513934f \
 //x=21.465 //y=5.39 //x2=21.78 //y2=7.09
cc_1745 ( N_noxref_9_c_2511_n N_noxref_14_c_3681_n ) capacitor c=0.00406191f \
 //x=21.47 //y=5.56 //x2=21.78 //y2=7.09
cc_1746 ( N_noxref_9_c_2405_n N_noxref_14_c_3666_n ) capacitor c=5.08928e-19 \
 //x=21.465 //y=5.39 //x2=20.15 //y2=5.39
cc_1747 ( N_noxref_9_c_2384_n N_noxref_14_c_3672_n ) capacitor c=0.00190123f \
 //x=21.425 //y=1.835 //x2=21.03 //y2=5.39
cc_1748 ( N_noxref_9_c_2405_n N_noxref_14_c_3672_n ) capacitor c=0.0529958f \
 //x=21.465 //y=5.39 //x2=21.03 //y2=5.39
cc_1749 ( N_noxref_9_c_2511_n N_noxref_14_c_3672_n ) capacitor c=0.00398527f \
 //x=21.47 //y=5.56 //x2=21.03 //y2=5.39
cc_1750 ( N_noxref_9_c_2478_n N_noxref_14_c_3693_n ) capacitor c=0.00564456f \
 //x=21.865 //y=5.39 //x2=21.91 //y2=6.92
cc_1751 ( N_noxref_9_c_2405_n N_noxref_14_c_3678_n ) capacitor c=0.00464132f \
 //x=21.465 //y=5.39 //x2=21.03 //y2=5.56
cc_1752 ( N_noxref_9_c_2511_n N_noxref_14_c_3678_n ) capacitor c=0.0684933f \
 //x=21.47 //y=5.56 //x2=21.03 //y2=5.56
cc_1753 ( N_noxref_9_c_2478_n N_noxref_14_M35_noxref_d ) capacitor \
 c=0.00777357f //x=21.865 //y=5.39 //x2=21.765 //y2=5.205
cc_1754 ( N_noxref_9_c_2503_n N_noxref_14_M35_noxref_d ) capacitor \
 c=0.00120919f //x=21.945 //y=3.88 //x2=21.765 //y2=5.205
cc_1755 ( N_noxref_9_c_2511_n N_noxref_14_M35_noxref_d ) capacitor \
 c=0.0479141f //x=21.47 //y=5.56 //x2=21.765 //y2=5.205
cc_1756 ( N_VDD_c_2700_n GATE_N ) capacitor c=0.0140262f //x=1.23 //y=7.58 \
 //x2=1.23 //y2=2.77
cc_1757 ( N_VDD_c_2596_n N_GATE_N_c_3045_n ) capacitor c=5.73169e-19 \
 //x=17.175 //y=7.585 //x2=1.23 //y2=4.76
cc_1758 ( N_VDD_c_2692_n N_GATE_N_c_3045_n ) capacitor c=5.48929e-19 //x=1.96 \
 //y=7.585 //x2=1.23 //y2=4.76
cc_1759 ( N_VDD_c_2700_n N_GATE_N_c_3045_n ) capacitor c=0.00869686f //x=1.23 \
 //y=7.58 //x2=1.23 //y2=4.76
cc_1760 ( N_VDD_M12_noxref_s N_GATE_N_c_3045_n ) capacitor c=0.0218259f \
 //x=1.03 //y=5.2 //x2=1.23 //y2=4.76
cc_1761 ( N_VDD_c_2596_n N_GATE_N_c_3048_n ) capacitor c=3.40755e-19 \
 //x=17.175 //y=7.585 //x2=1.23 //y2=4.88
cc_1762 ( N_VDD_c_2700_n N_GATE_N_c_3048_n ) capacitor c=0.00795821f //x=1.23 \
 //y=7.58 //x2=1.23 //y2=4.88
cc_1763 ( N_VDD_c_2608_n N_GATE_N_c_3048_n ) capacitor c=0.00235165f //x=2.71 \
 //y=7.585 //x2=1.23 //y2=4.88
cc_1764 ( N_VDD_M12_noxref_s N_GATE_N_c_3048_n ) capacitor c=0.00986169f \
 //x=1.03 //y=5.2 //x2=1.23 //y2=4.88
cc_1765 ( N_VDD_c_2692_n N_GATE_N_M12_noxref_g ) capacitor c=0.00753931f \
 //x=1.96 //y=7.585 //x2=1.385 //y2=6.2
cc_1766 ( N_VDD_c_2700_n N_GATE_N_M12_noxref_g ) capacitor c=0.0210133f \
 //x=1.23 //y=7.58 //x2=1.385 //y2=6.2
cc_1767 ( N_VDD_M12_noxref_s N_GATE_N_M12_noxref_g ) capacitor c=0.0573441f \
 //x=1.03 //y=5.2 //x2=1.385 //y2=6.2
cc_1768 ( N_VDD_c_2692_n N_GATE_N_M13_noxref_g ) capacitor c=0.00755544f \
 //x=1.96 //y=7.585 //x2=1.825 //y2=6.2
cc_1769 ( N_VDD_M13_noxref_d N_GATE_N_M13_noxref_g ) capacitor c=0.0572684f \
 //x=1.9 //y=5.2 //x2=1.825 //y2=6.2
cc_1770 ( N_VDD_c_2608_n N_GATE_N_c_3062_n ) capacitor c=0.00780996f //x=2.71 \
 //y=7.585 //x2=1.75 //y2=4.97
cc_1771 ( N_VDD_c_2700_n N_GATE_N_c_3065_n ) capacitor c=0.00799922f //x=1.23 \
 //y=7.58 //x2=1.46 //y2=4.97
cc_1772 ( N_VDD_c_2608_n N_GATE_N_c_3065_n ) capacitor c=2.63786e-19 //x=2.71 \
 //y=7.585 //x2=1.46 //y2=4.97
cc_1773 ( N_VDD_M12_noxref_s N_GATE_N_c_3065_n ) capacitor c=0.00524271f \
 //x=1.03 //y=5.2 //x2=1.46 //y2=4.97
cc_1774 ( N_VDD_c_2874_n N_GND_c_3146_n ) capacitor c=0.00989514f //x=22.32 \
 //y=7.58 //x2=22.32 //y2=0.18
cc_1775 ( N_VDD_c_2700_n N_GND_c_3232_n ) capacitor c=0.00989514f //x=1.23 \
 //y=7.58 //x2=1.12 //y2=0.175
cc_1776 ( N_VDD_c_2608_n N_GND_c_3147_n ) capacitor c=0.00915826f //x=2.71 \
 //y=7.585 //x2=2.71 //y2=0.175
cc_1777 ( N_VDD_c_2610_n N_GND_c_3148_n ) capacitor c=0.00648088f //x=4.93 \
 //y=7.585 //x2=4.93 //y2=0.175
cc_1778 ( N_VDD_c_2654_n N_GND_c_3185_n ) capacitor c=0.00650455f //x=8.26 \
 //y=7.585 //x2=8.26 //y2=0.175
cc_1779 ( N_VDD_c_2662_n N_GND_c_3192_n ) capacitor c=0.00648088f //x=10.48 \
 //y=7.585 //x2=10.48 //y2=0.175
cc_1780 ( N_VDD_c_2750_n N_GND_c_3279_n ) capacitor c=0.00904041f //x=13.81 \
 //y=7.585 //x2=13.81 //y2=0.175
cc_1781 ( N_VDD_c_2802_n N_GND_c_3318_n ) capacitor c=0.00663779f //x=16.03 \
 //y=7.585 //x2=16.03 //y2=0.175
cc_1782 ( N_VDD_c_2851_n N_GND_c_3391_n ) capacitor c=0.00654453f //x=19.36 \
 //y=7.585 //x2=19.36 //y2=0.175
cc_1783 ( N_VDD_c_2596_n N_noxref_13_c_3566_n ) capacitor c=0.00198753f \
 //x=17.175 //y=7.585 //x2=17.58 //y2=5.39
cc_1784 ( N_VDD_c_2830_n N_noxref_13_c_3566_n ) capacitor c=0.00492743f \
 //x=17.26 //y=7.035 //x2=17.58 //y2=5.39
cc_1785 ( N_VDD_c_2866_n N_noxref_13_c_3566_n ) capacitor c=5.38405e-19 \
 //x=20.505 //y=7.585 //x2=17.58 //y2=5.39
cc_1786 ( N_VDD_c_2837_n N_noxref_13_c_3566_n ) capacitor c=0.00585493f \
 //x=19.19 //y=7.585 //x2=17.58 //y2=5.39
cc_1787 ( N_VDD_M28_noxref_d N_noxref_13_c_3566_n ) capacitor c=0.00639723f \
 //x=17.115 //y=5.205 //x2=17.58 //y2=5.39
cc_1788 ( N_VDD_c_2874_n N_noxref_13_c_3585_n ) capacitor c=0.0022402f \
 //x=22.32 //y=7.58 //x2=18.45 //y2=7.09
cc_1789 ( N_VDD_c_2802_n N_noxref_13_c_3572_n ) capacitor c=0.00713363f \
 //x=16.03 //y=7.585 //x2=16.82 //y2=5.39
cc_1790 ( N_VDD_M27_noxref_d N_noxref_13_c_3572_n ) capacitor c=0.0123722f \
 //x=15.22 //y=5.2 //x2=16.82 //y2=5.39
cc_1791 ( N_VDD_c_2830_n N_noxref_13_c_3577_n ) capacitor c=0.0375498f \
 //x=17.26 //y=7.035 //x2=17.7 //y2=6.92
cc_1792 ( N_VDD_c_2832_n N_noxref_13_c_3577_n ) capacitor c=0.0104317f \
 //x=17.26 //y=7.41 //x2=17.7 //y2=6.92
cc_1793 ( N_VDD_c_2866_n N_noxref_13_c_3577_n ) capacitor c=0.0975883f \
 //x=20.505 //y=7.585 //x2=17.7 //y2=6.92
cc_1794 ( N_VDD_c_2837_n N_noxref_13_c_3577_n ) capacitor c=0.020049f \
 //x=19.19 //y=7.585 //x2=17.7 //y2=6.92
cc_1795 ( N_VDD_M28_noxref_d N_noxref_13_c_3577_n ) capacitor c=0.00510287f \
 //x=17.115 //y=5.205 //x2=17.7 //y2=6.92
cc_1796 ( N_VDD_c_2830_n N_noxref_13_c_3592_n ) capacitor c=6.1128e-19 \
 //x=17.26 //y=7.035 //x2=18.58 //y2=6.92
cc_1797 ( N_VDD_c_2866_n N_noxref_13_c_3592_n ) capacitor c=0.00193184f \
 //x=20.505 //y=7.585 //x2=18.58 //y2=6.92
cc_1798 ( N_VDD_c_2868_n N_noxref_13_c_3592_n ) capacitor c=5.94673e-19 \
 //x=20.59 //y=7.035 //x2=18.58 //y2=6.92
cc_1799 ( N_VDD_c_2837_n N_noxref_13_c_3592_n ) capacitor c=9.3761e-19 \
 //x=19.19 //y=7.585 //x2=18.58 //y2=6.92
cc_1800 ( N_VDD_c_2851_n N_noxref_13_c_3592_n ) capacitor c=0.00713778f \
 //x=19.36 //y=7.585 //x2=18.58 //y2=6.92
cc_1801 ( N_VDD_c_2596_n N_noxref_13_c_3578_n ) capacitor c=0.00240365f \
 //x=17.175 //y=7.585 //x2=16.82 //y2=5.56
cc_1802 ( N_VDD_c_2830_n N_noxref_13_c_3578_n ) capacitor c=0.00220777f \
 //x=17.26 //y=7.035 //x2=16.82 //y2=5.56
cc_1803 ( N_VDD_c_2832_n N_noxref_13_c_3578_n ) capacitor c=0.00154298f \
 //x=17.26 //y=7.41 //x2=16.82 //y2=5.56
cc_1804 ( N_VDD_c_2837_n N_noxref_13_c_3578_n ) capacitor c=0.0126473f \
 //x=19.19 //y=7.585 //x2=16.82 //y2=5.56
cc_1805 ( N_VDD_c_2874_n N_noxref_13_c_3578_n ) capacitor c=2.28864e-19 \
 //x=22.32 //y=7.58 //x2=16.82 //y2=5.56
cc_1806 ( N_VDD_c_2802_n N_noxref_13_c_3578_n ) capacitor c=0.0558076f \
 //x=16.03 //y=7.585 //x2=16.82 //y2=5.56
cc_1807 ( N_VDD_M27_noxref_d N_noxref_13_c_3578_n ) capacitor c=0.00262214f \
 //x=15.22 //y=5.2 //x2=16.82 //y2=5.56
cc_1808 ( N_VDD_M28_noxref_d N_noxref_13_c_3578_n ) capacitor c=0.0737268f \
 //x=17.115 //y=5.205 //x2=16.82 //y2=5.56
cc_1809 ( N_VDD_c_2830_n N_noxref_13_c_3582_n ) capacitor c=0.00211426f \
 //x=17.26 //y=7.035 //x2=17.7 //y2=5.56
cc_1810 ( N_VDD_c_2832_n N_noxref_13_c_3582_n ) capacitor c=4.62894e-19 \
 //x=17.26 //y=7.41 //x2=17.7 //y2=5.56
cc_1811 ( N_VDD_c_2866_n N_noxref_13_c_3582_n ) capacitor c=0.00205411f \
 //x=20.505 //y=7.585 //x2=17.7 //y2=5.56
cc_1812 ( N_VDD_c_2837_n N_noxref_13_c_3582_n ) capacitor c=0.0085453f \
 //x=19.19 //y=7.585 //x2=17.7 //y2=5.56
cc_1813 ( N_VDD_c_2874_n N_noxref_13_c_3582_n ) capacitor c=2.28864e-19 \
 //x=22.32 //y=7.58 //x2=17.7 //y2=5.56
cc_1814 ( N_VDD_M28_noxref_d N_noxref_13_c_3582_n ) capacitor c=0.067415f \
 //x=17.115 //y=5.205 //x2=17.7 //y2=5.56
cc_1815 ( N_VDD_c_2596_n N_noxref_13_M28_noxref_s ) capacitor c=0.0245962f \
 //x=17.175 //y=7.585 //x2=16.685 //y2=5.205
cc_1816 ( N_VDD_c_2830_n N_noxref_13_M28_noxref_s ) capacitor c=0.0378001f \
 //x=17.26 //y=7.035 //x2=16.685 //y2=5.205
cc_1817 ( N_VDD_c_2832_n N_noxref_13_M28_noxref_s ) capacitor c=0.0124823f \
 //x=17.26 //y=7.41 //x2=16.685 //y2=5.205
cc_1818 ( N_VDD_c_2837_n N_noxref_13_M28_noxref_s ) capacitor c=0.00293047f \
 //x=19.19 //y=7.585 //x2=16.685 //y2=5.205
cc_1819 ( N_VDD_c_2802_n N_noxref_13_M28_noxref_s ) capacitor c=0.00933367f \
 //x=16.03 //y=7.585 //x2=16.685 //y2=5.205
cc_1820 ( N_VDD_M28_noxref_d N_noxref_13_M28_noxref_s ) capacitor \
 c=0.00566597f //x=17.115 //y=5.205 //x2=16.685 //y2=5.205
cc_1821 ( N_VDD_c_2866_n N_noxref_13_M31_noxref_d ) capacitor c=0.00206569f \
 //x=20.505 //y=7.585 //x2=18.435 //y2=5.205
cc_1822 ( N_VDD_c_2837_n N_noxref_13_M31_noxref_d ) capacitor c=0.00856914f \
 //x=19.19 //y=7.585 //x2=18.435 //y2=5.205
cc_1823 ( N_VDD_c_2874_n N_noxref_13_M31_noxref_d ) capacitor c=2.28864e-19 \
 //x=22.32 //y=7.58 //x2=18.435 //y2=5.205
cc_1824 ( N_VDD_c_2851_n N_noxref_13_M31_noxref_d ) capacitor c=0.0456839f \
 //x=19.36 //y=7.585 //x2=18.435 //y2=5.205
cc_1825 ( N_VDD_c_2866_n N_noxref_14_c_3659_n ) capacitor c=5.98028e-19 \
 //x=20.505 //y=7.585 //x2=20.91 //y2=5.39
cc_1826 ( N_VDD_c_2868_n N_noxref_14_c_3659_n ) capacitor c=0.00492778f \
 //x=20.59 //y=7.035 //x2=20.91 //y2=5.39
cc_1827 ( N_VDD_c_2925_n N_noxref_14_c_3659_n ) capacitor c=0.00192799f \
 //x=22.32 //y=7.58 //x2=20.91 //y2=5.39
cc_1828 ( N_VDD_c_2874_n N_noxref_14_c_3659_n ) capacitor c=0.00590635f \
 //x=22.32 //y=7.58 //x2=20.91 //y2=5.39
cc_1829 ( N_VDD_M32_noxref_d N_noxref_14_c_3659_n ) capacitor c=0.00648599f \
 //x=20.445 //y=5.205 //x2=20.91 //y2=5.39
cc_1830 ( N_VDD_c_2874_n N_noxref_14_c_3681_n ) capacitor c=0.0022402f \
 //x=22.32 //y=7.58 //x2=21.78 //y2=7.09
cc_1831 ( N_VDD_c_2851_n N_noxref_14_c_3666_n ) capacitor c=0.00764075f \
 //x=19.36 //y=7.585 //x2=20.15 //y2=5.39
cc_1832 ( N_VDD_c_2868_n N_noxref_14_c_3673_n ) capacitor c=0.0377581f \
 //x=20.59 //y=7.035 //x2=21.03 //y2=6.92
cc_1833 ( N_VDD_c_2870_n N_noxref_14_c_3673_n ) capacitor c=0.0104319f \
 //x=20.59 //y=7.41 //x2=21.03 //y2=6.92
cc_1834 ( N_VDD_c_2925_n N_noxref_14_c_3673_n ) capacitor c=0.0980606f \
 //x=22.32 //y=7.58 //x2=21.03 //y2=6.92
cc_1835 ( N_VDD_c_2874_n N_noxref_14_c_3673_n ) capacitor c=0.0197419f \
 //x=22.32 //y=7.58 //x2=21.03 //y2=6.92
cc_1836 ( N_VDD_M32_noxref_d N_noxref_14_c_3673_n ) capacitor c=0.00510285f \
 //x=20.445 //y=5.205 //x2=21.03 //y2=6.92
cc_1837 ( N_VDD_c_2868_n N_noxref_14_c_3693_n ) capacitor c=6.1128e-19 \
 //x=20.59 //y=7.035 //x2=21.91 //y2=6.92
cc_1838 ( N_VDD_c_2925_n N_noxref_14_c_3693_n ) capacitor c=0.00193184f \
 //x=22.32 //y=7.58 //x2=21.91 //y2=6.92
cc_1839 ( N_VDD_c_2874_n N_noxref_14_c_3693_n ) capacitor c=0.0100622f \
 //x=22.32 //y=7.58 //x2=21.91 //y2=6.92
cc_1840 ( N_VDD_c_2866_n N_noxref_14_c_3674_n ) capacitor c=0.00240365f \
 //x=20.505 //y=7.585 //x2=20.15 //y2=5.56
cc_1841 ( N_VDD_c_2868_n N_noxref_14_c_3674_n ) capacitor c=0.00220777f \
 //x=20.59 //y=7.035 //x2=20.15 //y2=5.56
cc_1842 ( N_VDD_c_2870_n N_noxref_14_c_3674_n ) capacitor c=0.00154298f \
 //x=20.59 //y=7.41 //x2=20.15 //y2=5.56
cc_1843 ( N_VDD_c_2874_n N_noxref_14_c_3674_n ) capacitor c=0.0128762f \
 //x=22.32 //y=7.58 //x2=20.15 //y2=5.56
cc_1844 ( N_VDD_c_2851_n N_noxref_14_c_3674_n ) capacitor c=0.0574402f \
 //x=19.36 //y=7.585 //x2=20.15 //y2=5.56
cc_1845 ( N_VDD_M32_noxref_d N_noxref_14_c_3674_n ) capacitor c=0.0738196f \
 //x=20.445 //y=5.205 //x2=20.15 //y2=5.56
cc_1846 ( N_VDD_c_2868_n N_noxref_14_c_3678_n ) capacitor c=0.00211426f \
 //x=20.59 //y=7.035 //x2=21.03 //y2=5.56
cc_1847 ( N_VDD_c_2870_n N_noxref_14_c_3678_n ) capacitor c=4.62894e-19 \
 //x=20.59 //y=7.41 //x2=21.03 //y2=5.56
cc_1848 ( N_VDD_c_2925_n N_noxref_14_c_3678_n ) capacitor c=0.00205411f \
 //x=22.32 //y=7.58 //x2=21.03 //y2=5.56
cc_1849 ( N_VDD_c_2874_n N_noxref_14_c_3678_n ) capacitor c=0.00877417f \
 //x=22.32 //y=7.58 //x2=21.03 //y2=5.56
cc_1850 ( N_VDD_M32_noxref_d N_noxref_14_c_3678_n ) capacitor c=0.0674471f \
 //x=20.445 //y=5.205 //x2=21.03 //y2=5.56
cc_1851 ( N_VDD_c_2866_n N_noxref_14_M32_noxref_s ) capacitor c=0.0245962f \
 //x=20.505 //y=7.585 //x2=20.015 //y2=5.205
cc_1852 ( N_VDD_c_2868_n N_noxref_14_M32_noxref_s ) capacitor c=0.0368106f \
 //x=20.59 //y=7.035 //x2=20.015 //y2=5.205
cc_1853 ( N_VDD_c_2870_n N_noxref_14_M32_noxref_s ) capacitor c=0.0124823f \
 //x=20.59 //y=7.41 //x2=20.015 //y2=5.205
cc_1854 ( N_VDD_c_2874_n N_noxref_14_M32_noxref_s ) capacitor c=0.00293047f \
 //x=22.32 //y=7.58 //x2=20.015 //y2=5.205
cc_1855 ( N_VDD_c_2851_n N_noxref_14_M32_noxref_s ) capacitor c=0.00571261f \
 //x=19.36 //y=7.585 //x2=20.015 //y2=5.205
cc_1856 ( N_VDD_M32_noxref_d N_noxref_14_M32_noxref_s ) capacitor \
 c=0.00378833f //x=20.445 //y=5.205 //x2=20.015 //y2=5.205
cc_1857 ( N_VDD_c_2925_n N_noxref_14_M35_noxref_d ) capacitor c=0.00206569f \
 //x=22.32 //y=7.58 //x2=21.765 //y2=5.205
cc_1858 ( N_VDD_c_2874_n N_noxref_14_M35_noxref_d ) capacitor c=0.0540429f \
 //x=22.32 //y=7.58 //x2=21.765 //y2=5.205
cc_1859 ( N_GATE_N_c_3046_n N_GND_c_3122_n ) capacitor c=0.00249124f //x=1.23 \
 //y=2.265 //x2=6.025 //y2=0.175
cc_1860 ( N_GATE_N_c_3047_n N_GND_c_3122_n ) capacitor c=0.00118266f //x=1.23 \
 //y=2.265 //x2=6.025 //y2=0.175
cc_1861 ( N_GATE_N_c_3046_n N_GND_c_3225_n ) capacitor c=0.00108343f //x=1.23 \
 //y=2.265 //x2=1.515 //y2=0.715
cc_1862 ( N_GATE_N_c_3047_n N_GND_c_3225_n ) capacitor c=3.95714e-19 //x=1.23 \
 //y=2.265 //x2=1.515 //y2=0.715
cc_1863 ( N_GATE_N_c_3055_n N_GND_c_3225_n ) capacitor c=0.0124814f //x=1.34 \
 //y=1.09 //x2=1.515 //y2=0.715
cc_1864 ( N_GATE_N_c_3077_n N_GND_c_3225_n ) capacitor c=2.1838e-19 //x=1.23 \
 //y=2.265 //x2=1.515 //y2=0.715
cc_1865 ( N_GATE_N_c_3072_n N_GND_c_3226_n ) capacitor c=0.0131622f //x=1.87 \
 //y=1.09 //x2=2.005 //y2=0.715
cc_1866 ( GATE_N N_GND_c_3232_n ) capacitor c=0.0146622f //x=1.23 //y=2.77 \
 //x2=1.12 //y2=0.175
cc_1867 ( N_GATE_N_c_3046_n N_GND_c_3232_n ) capacitor c=0.0100674f //x=1.23 \
 //y=2.265 //x2=1.12 //y2=0.175
cc_1868 ( N_GATE_N_c_3047_n N_GND_c_3232_n ) capacitor c=0.00733542f //x=1.23 \
 //y=2.265 //x2=1.12 //y2=0.175
cc_1869 ( N_GATE_N_c_3061_n N_GND_c_3232_n ) capacitor c=0.00574171f //x=1.34 \
 //y=2.1 //x2=1.12 //y2=0.175
cc_1870 ( N_GATE_N_c_3077_n N_GND_c_3232_n ) capacitor c=0.00785621f //x=1.23 \
 //y=2.265 //x2=1.12 //y2=0.175
cc_1871 ( N_GATE_N_c_3047_n N_GND_c_3147_n ) capacitor c=0.0022444f //x=1.23 \
 //y=2.265 //x2=2.71 //y2=0.175
cc_1872 ( N_GATE_N_c_3077_n N_GND_c_3147_n ) capacitor c=2.63786e-19 //x=1.23 \
 //y=2.265 //x2=2.71 //y2=0.175
cc_1873 ( N_GATE_N_c_3046_n N_GND_M0_noxref_s ) capacitor c=0.00297929f \
 //x=1.23 //y=2.265 //x2=0.985 //y2=0.55
cc_1874 ( N_GATE_N_c_3047_n N_GND_M0_noxref_s ) capacitor c=0.00476545f \
 //x=1.23 //y=2.265 //x2=0.985 //y2=0.55
cc_1875 ( N_GATE_N_c_3055_n N_GND_M0_noxref_s ) capacitor c=0.0299684f \
 //x=1.34 //y=1.09 //x2=0.985 //y2=0.55
cc_1876 ( N_GATE_N_c_3060_n N_GND_M0_noxref_s ) capacitor c=0.002132f //x=1.34 \
 //y=1.745 //x2=0.985 //y2=0.55
cc_1877 ( N_GATE_N_c_3061_n N_GND_M0_noxref_s ) capacitor c=0.00304786f \
 //x=1.34 //y=2.1 //x2=0.985 //y2=0.55
cc_1878 ( N_GATE_N_c_3066_n N_GND_M0_noxref_s ) capacitor c=0.00517463f \
 //x=1.715 //y=0.935 //x2=0.985 //y2=0.55
cc_1879 ( N_GATE_N_c_3072_n N_GND_M0_noxref_s ) capacitor c=0.0153553f \
 //x=1.87 //y=1.09 //x2=0.985 //y2=0.55
cc_1880 ( N_GATE_N_c_3074_n N_GND_M0_noxref_s ) capacitor c=0.00629878f \
 //x=1.87 //y=1.435 //x2=0.985 //y2=0.55
cc_1881 ( N_GATE_N_c_3077_n N_GND_M0_noxref_s ) capacitor c=0.00659456f \
 //x=1.23 //y=2.265 //x2=0.985 //y2=0.55
cc_1882 ( N_GND_M1_noxref_s N_noxref_15_c_3750_n ) capacitor c=0.0029758f \
 //x=3.205 //y=0.55 //x2=5.625 //y2=1.675
cc_1883 ( N_GND_c_3122_n N_noxref_15_c_3751_n ) capacitor c=0.00242438f \
 //x=6.025 //y=0.175 //x2=6.51 //y2=1.76
cc_1884 ( N_GND_c_3166_n N_noxref_15_c_3751_n ) capacitor c=7.45647e-19 \
 //x=11.575 //y=0.175 //x2=6.51 //y2=1.76
cc_1885 ( N_GND_c_3128_n N_noxref_15_c_3751_n ) capacitor c=0.00402206f \
 //x=6.11 //y=1.135 //x2=6.51 //y2=1.76
cc_1886 ( N_GND_c_3145_n N_noxref_15_c_3751_n ) capacitor c=0.00375345f \
 //x=8.09 //y=0.175 //x2=6.51 //y2=1.76
cc_1887 ( N_GND_M2_noxref_d N_noxref_15_c_3751_n ) capacitor c=0.00578453f \
 //x=5.92 //y=1.045 //x2=6.51 //y2=1.76
cc_1888 ( N_GND_c_3166_n N_noxref_15_c_3795_n ) capacitor c=0.00565598f \
 //x=11.575 //y=0.175 //x2=6.595 //y2=0.795
cc_1889 ( N_GND_c_3138_n N_noxref_15_c_3795_n ) capacitor c=0.0167642f \
 //x=6.107 //y=1.005 //x2=6.595 //y2=0.795
cc_1890 ( N_GND_c_3145_n N_noxref_15_c_3795_n ) capacitor c=0.0147157f \
 //x=8.09 //y=0.175 //x2=6.595 //y2=0.795
cc_1891 ( N_GND_c_3148_n N_noxref_15_c_3795_n ) capacitor c=0.00282499f \
 //x=4.93 //y=0.175 //x2=6.595 //y2=0.795
cc_1892 ( N_GND_c_3185_n N_noxref_15_c_3795_n ) capacitor c=2.21767e-19 \
 //x=8.26 //y=0.175 //x2=6.595 //y2=0.795
cc_1893 ( N_GND_c_3148_n N_noxref_15_c_3758_n ) capacitor c=2.84609e-19 \
 //x=4.93 //y=0.175 //x2=6.595 //y2=1.675
cc_1894 ( N_GND_c_3166_n N_noxref_15_c_3763_n ) capacitor c=0.00966567f \
 //x=11.575 //y=0.175 //x2=7.48 //y2=0.71
cc_1895 ( N_GND_c_3145_n N_noxref_15_c_3763_n ) capacitor c=0.0374802f \
 //x=8.09 //y=0.175 //x2=7.48 //y2=0.71
cc_1896 ( N_GND_c_3146_n N_noxref_15_c_3763_n ) capacitor c=0.00199816f \
 //x=22.32 //y=0.18 //x2=7.48 //y2=0.71
cc_1897 ( N_GND_c_3166_n N_noxref_15_c_3804_n ) capacitor c=0.00250904f \
 //x=11.575 //y=0.175 //x2=7.565 //y2=0.795
cc_1898 ( N_GND_c_3145_n N_noxref_15_c_3804_n ) capacitor c=0.0145784f \
 //x=8.09 //y=0.175 //x2=7.565 //y2=0.795
cc_1899 ( N_GND_c_3527_p N_noxref_15_c_3804_n ) capacitor c=0.00209572f \
 //x=8.89 //y=0.63 //x2=7.565 //y2=0.795
cc_1900 ( N_GND_c_3185_n N_noxref_15_c_3804_n ) capacitor c=0.0402083f \
 //x=8.26 //y=0.175 //x2=7.565 //y2=0.795
cc_1901 ( N_GND_c_3122_n N_noxref_15_M2_noxref_s ) capacitor c=0.00724992f \
 //x=6.025 //y=0.175 //x2=5.49 //y2=0.545
cc_1902 ( N_GND_c_3128_n N_noxref_15_M2_noxref_s ) capacitor c=0.0100498f \
 //x=6.11 //y=1.135 //x2=5.49 //y2=0.545
cc_1903 ( N_GND_c_3138_n N_noxref_15_M2_noxref_s ) capacitor c=0.0173062f \
 //x=6.107 //y=1.005 //x2=5.49 //y2=0.545
cc_1904 ( N_GND_c_3532_p N_noxref_15_M2_noxref_s ) capacitor c=0.0029758f \
 //x=4.31 //y=0.63 //x2=5.49 //y2=0.545
cc_1905 ( N_GND_c_3145_n N_noxref_15_M2_noxref_s ) capacitor c=0.014661f \
 //x=8.09 //y=0.175 //x2=5.49 //y2=0.545
cc_1906 ( N_GND_c_3148_n N_noxref_15_M2_noxref_s ) capacitor c=0.0528146f \
 //x=4.93 //y=0.175 //x2=5.49 //y2=0.545
cc_1907 ( N_GND_c_3185_n N_noxref_15_M2_noxref_s ) capacitor c=0.00642652f \
 //x=8.26 //y=0.175 //x2=5.49 //y2=0.545
cc_1908 ( N_GND_M2_noxref_d N_noxref_15_M2_noxref_s ) capacitor c=0.0271276f \
 //x=5.92 //y=1.045 //x2=5.49 //y2=0.545
cc_1909 ( N_GND_M4_noxref_s N_noxref_15_M2_noxref_s ) capacitor c=0.0031675f \
 //x=8.755 //y=0.55 //x2=5.49 //y2=0.545
cc_1910 ( N_GND_M4_noxref_s N_noxref_16_c_3817_n ) capacitor c=0.0029758f \
 //x=8.755 //y=0.55 //x2=11.175 //y2=1.675
cc_1911 ( N_GND_c_3166_n N_noxref_16_c_3819_n ) capacitor c=9.69275e-19 \
 //x=11.575 //y=0.175 //x2=12.06 //y2=1.76
cc_1912 ( N_GND_c_3264_n N_noxref_16_c_3819_n ) capacitor c=0.00203804f \
 //x=22.32 //y=0.18 //x2=12.06 //y2=1.76
cc_1913 ( N_GND_c_3212_n N_noxref_16_c_3819_n ) capacitor c=0.00398897f \
 //x=11.66 //y=1.135 //x2=12.06 //y2=1.76
cc_1914 ( N_GND_c_3230_n N_noxref_16_c_3819_n ) capacitor c=0.00387051f \
 //x=13.64 //y=0.175 //x2=12.06 //y2=1.76
cc_1915 ( N_GND_M5_noxref_d N_noxref_16_c_3819_n ) capacitor c=0.00578453f \
 //x=11.47 //y=1.045 //x2=12.06 //y2=1.76
cc_1916 ( N_GND_c_3264_n N_noxref_16_c_3861_n ) capacitor c=0.0056036f \
 //x=22.32 //y=0.18 //x2=12.145 //y2=0.795
cc_1917 ( N_GND_c_3222_n N_noxref_16_c_3861_n ) capacitor c=0.0167642f \
 //x=11.657 //y=1.005 //x2=12.145 //y2=0.795
cc_1918 ( N_GND_c_3230_n N_noxref_16_c_3861_n ) capacitor c=0.0146605f \
 //x=13.64 //y=0.175 //x2=12.145 //y2=0.795
cc_1919 ( N_GND_c_3192_n N_noxref_16_c_3861_n ) capacitor c=0.00282499f \
 //x=10.48 //y=0.175 //x2=12.145 //y2=0.795
cc_1920 ( N_GND_c_3279_n N_noxref_16_c_3861_n ) capacitor c=2.21767e-19 \
 //x=13.81 //y=0.175 //x2=12.145 //y2=0.795
cc_1921 ( N_GND_c_3192_n N_noxref_16_c_3827_n ) capacitor c=2.84609e-19 \
 //x=10.48 //y=0.175 //x2=12.145 //y2=1.675
cc_1922 ( N_GND_c_3264_n N_noxref_16_c_3835_n ) capacitor c=0.00996596f \
 //x=22.32 //y=0.18 //x2=13.03 //y2=0.71
cc_1923 ( N_GND_c_3230_n N_noxref_16_c_3835_n ) capacitor c=0.0374802f \
 //x=13.64 //y=0.175 //x2=13.03 //y2=0.71
cc_1924 ( N_GND_c_3146_n N_noxref_16_c_3835_n ) capacitor c=0.00199816f \
 //x=22.32 //y=0.18 //x2=13.03 //y2=0.71
cc_1925 ( N_GND_c_3264_n N_noxref_16_c_3870_n ) capacitor c=0.00250904f \
 //x=22.32 //y=0.18 //x2=13.115 //y2=0.795
cc_1926 ( N_GND_c_3230_n N_noxref_16_c_3870_n ) capacitor c=0.0145784f \
 //x=13.64 //y=0.175 //x2=13.115 //y2=0.795
cc_1927 ( N_GND_c_3555_p N_noxref_16_c_3870_n ) capacitor c=0.00209572f \
 //x=14.44 //y=0.63 //x2=13.115 //y2=0.795
cc_1928 ( N_GND_c_3279_n N_noxref_16_c_3870_n ) capacitor c=0.0402083f \
 //x=13.81 //y=0.175 //x2=13.115 //y2=0.795
cc_1929 ( N_GND_c_3166_n N_noxref_16_M5_noxref_s ) capacitor c=0.00724992f \
 //x=11.575 //y=0.175 //x2=11.04 //y2=0.545
cc_1930 ( N_GND_c_3212_n N_noxref_16_M5_noxref_s ) capacitor c=0.0100435f \
 //x=11.66 //y=1.135 //x2=11.04 //y2=0.545
cc_1931 ( N_GND_c_3222_n N_noxref_16_M5_noxref_s ) capacitor c=0.0173062f \
 //x=11.657 //y=1.005 //x2=11.04 //y2=0.545
cc_1932 ( N_GND_c_3560_p N_noxref_16_M5_noxref_s ) capacitor c=0.0029758f \
 //x=9.86 //y=0.63 //x2=11.04 //y2=0.545
cc_1933 ( N_GND_c_3230_n N_noxref_16_M5_noxref_s ) capacitor c=0.014661f \
 //x=13.64 //y=0.175 //x2=11.04 //y2=0.545
cc_1934 ( N_GND_c_3192_n N_noxref_16_M5_noxref_s ) capacitor c=0.0528146f \
 //x=10.48 //y=0.175 //x2=11.04 //y2=0.545
cc_1935 ( N_GND_c_3279_n N_noxref_16_M5_noxref_s ) capacitor c=0.00642652f \
 //x=13.81 //y=0.175 //x2=11.04 //y2=0.545
cc_1936 ( N_GND_M5_noxref_d N_noxref_16_M5_noxref_s ) capacitor c=0.0271276f \
 //x=11.47 //y=1.045 //x2=11.04 //y2=0.545
cc_1937 ( N_GND_M7_noxref_s N_noxref_16_M5_noxref_s ) capacitor c=0.0031675f \
 //x=14.305 //y=0.55 //x2=11.04 //y2=0.545
cc_1938 ( N_noxref_13_c_3576_n N_noxref_14_c_3666_n ) capacitor c=0.00120008f \
 //x=17.7 //y=5.39 //x2=20.15 //y2=5.39
cc_1939 ( N_noxref_13_M31_noxref_d N_noxref_14_c_3674_n ) capacitor \
 c=0.00134877f //x=18.435 //y=5.205 //x2=20.15 //y2=5.56
cc_1940 ( N_noxref_13_c_3577_n N_noxref_14_M32_noxref_s ) capacitor \
 c=2.04839e-19 //x=17.7 //y=6.92 //x2=20.015 //y2=5.205
cc_1941 ( N_noxref_13_c_3592_n N_noxref_14_M32_noxref_s ) capacitor \
 c=0.0118379f //x=18.58 //y=6.92 //x2=20.015 //y2=5.205
