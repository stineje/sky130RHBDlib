// File: DLATCHN.spi.DLATCHN.pxi
// Created: Tue Apr 29 10:42:06 2025
//
simulator lang=spectre
x_PM_DLATCHN\%GND ( GND N_GND_c_10_p N_GND_c_90_p N_GND_c_256_p N_GND_c_52_p \
 N_GND_c_53_p N_GND_c_25_p N_GND_c_105_p N_GND_c_279_p N_GND_c_55_p \
 N_GND_c_15_p N_GND_c_21_p N_GND_c_65_p N_GND_c_276_p N_GND_c_33_p \
 N_GND_c_41_p N_GND_c_302_p N_GND_c_67_p N_GND_c_68_p N_GND_c_86_p \
 N_GND_c_113_p N_GND_c_299_p N_GND_c_114_p N_GND_c_130_p N_GND_c_142_p \
 N_GND_c_158_p N_GND_c_177_p N_GND_c_180_p N_GND_c_167_p N_GND_c_168_p \
 N_GND_c_169_p N_GND_c_192_p N_GND_c_209_p N_GND_c_213_p N_GND_c_1_p \
 N_GND_c_2_p N_GND_c_3_p N_GND_c_4_p N_GND_c_5_p N_GND_c_6_p N_GND_c_7_p \
 N_GND_c_8_p N_GND_c_9_p N_GND_M0_noxref_s N_GND_M1_noxref_s N_GND_M2_noxref_d \
 N_GND_M4_noxref_s N_GND_M5_noxref_d N_GND_M7_noxref_s N_GND_M8_noxref_s \
 N_GND_M10_noxref_s )  PM_DLATCHN\%GND
x_PM_DLATCHN\%VDD ( VDD N_VDD_c_317_p N_VDD_c_376_p N_VDD_c_318_p \
 N_VDD_c_403_p N_VDD_c_404_p N_VDD_c_324_p N_VDD_c_338_p N_VDD_c_406_p \
 N_VDD_c_407_p N_VDD_c_351_p N_VDD_c_409_p N_VDD_c_410_p N_VDD_c_384_p \
 N_VDD_c_435_p N_VDD_c_458_p N_VDD_c_521_p N_VDD_c_492_p N_VDD_c_495_p \
 N_VDD_c_512_p N_VDD_c_308_n N_VDD_c_309_n N_VDD_c_310_n N_VDD_c_311_n \
 N_VDD_c_312_n N_VDD_c_313_n N_VDD_c_314_n N_VDD_c_315_n N_VDD_c_316_n \
 N_VDD_M12_noxref_s N_VDD_M13_noxref_d N_VDD_M14_noxref_s N_VDD_M15_noxref_d \
 N_VDD_M16_noxref_s N_VDD_M17_noxref_d N_VDD_M19_noxref_d N_VDD_M20_noxref_s \
 N_VDD_M21_noxref_d N_VDD_M22_noxref_s N_VDD_M23_noxref_d N_VDD_M25_noxref_d \
 N_VDD_M26_noxref_s N_VDD_M27_noxref_d N_VDD_M28_noxref_d N_VDD_M32_noxref_d ) \
 PM_DLATCHN\%VDD
x_PM_DLATCHN\%noxref_3 ( N_noxref_3_c_647_p N_noxref_3_c_648_p \
 N_noxref_3_c_603_n N_noxref_3_c_649_p N_noxref_3_c_622_n N_noxref_3_c_625_n \
 N_noxref_3_c_606_n N_noxref_3_c_607_n N_noxref_3_M2_noxref_g \
 N_noxref_3_M16_noxref_g N_noxref_3_M17_noxref_g N_noxref_3_c_608_n \
 N_noxref_3_c_610_n N_noxref_3_c_667_p N_noxref_3_c_611_n N_noxref_3_c_612_n \
 N_noxref_3_c_613_n N_noxref_3_c_614_n N_noxref_3_c_616_n N_noxref_3_c_635_n \
 N_noxref_3_M1_noxref_d N_noxref_3_M14_noxref_d )  PM_DLATCHN\%noxref_3
x_PM_DLATCHN\%noxref_4 ( N_noxref_4_c_782_p N_noxref_4_c_783_p \
 N_noxref_4_c_742_n N_noxref_4_c_746_n N_noxref_4_c_748_n N_noxref_4_c_720_n \
 N_noxref_4_c_784_p N_noxref_4_c_722_n N_noxref_4_c_723_n N_noxref_4_c_803_p \
 N_noxref_4_M4_noxref_g N_noxref_4_M20_noxref_g N_noxref_4_M21_noxref_g \
 N_noxref_4_c_728_n N_noxref_4_c_836_p N_noxref_4_c_837_p N_noxref_4_c_730_n \
 N_noxref_4_c_762_n N_noxref_4_c_763_n N_noxref_4_c_731_n N_noxref_4_c_824_p \
 N_noxref_4_c_732_n N_noxref_4_c_734_n N_noxref_4_c_735_n \
 N_noxref_4_M3_noxref_d N_noxref_4_M16_noxref_d N_noxref_4_M18_noxref_d )  \
 PM_DLATCHN\%noxref_4
x_PM_DLATCHN\%noxref_5 ( N_noxref_5_c_854_n N_noxref_5_c_864_n \
 N_noxref_5_c_866_n N_noxref_5_c_875_n N_noxref_5_c_876_n N_noxref_5_c_1063_p \
 N_noxref_5_c_902_n N_noxref_5_c_905_n N_noxref_5_c_879_n N_noxref_5_c_936_n \
 N_noxref_5_c_880_n N_noxref_5_c_882_n N_noxref_5_M3_noxref_g \
 N_noxref_5_M5_noxref_g N_noxref_5_M18_noxref_g N_noxref_5_M19_noxref_g \
 N_noxref_5_M22_noxref_g N_noxref_5_M23_noxref_g N_noxref_5_c_945_n \
 N_noxref_5_c_948_n N_noxref_5_c_950_n N_noxref_5_c_981_n N_noxref_5_c_983_n \
 N_noxref_5_c_984_n N_noxref_5_c_953_n N_noxref_5_c_954_n N_noxref_5_c_883_n \
 N_noxref_5_c_885_n N_noxref_5_c_1019_p N_noxref_5_c_886_n N_noxref_5_c_887_n \
 N_noxref_5_c_888_n N_noxref_5_c_889_n N_noxref_5_c_891_n N_noxref_5_c_955_n \
 N_noxref_5_c_990_n N_noxref_5_c_957_n N_noxref_5_c_922_n \
 N_noxref_5_M0_noxref_d N_noxref_5_M12_noxref_d )  PM_DLATCHN\%noxref_5
x_PM_DLATCHN\%D ( N_D_c_1109_n N_D_c_1129_n D D D D D D D D D D N_D_c_1092_n \
 N_D_c_1201_n N_D_c_1097_n N_D_M1_noxref_g N_D_M6_noxref_g N_D_M14_noxref_g \
 N_D_M15_noxref_g N_D_M24_noxref_g N_D_M25_noxref_g N_D_c_1099_n N_D_c_1166_n \
 N_D_c_1167_n N_D_c_1101_n N_D_c_1148_n N_D_c_1149_n N_D_c_1102_n N_D_c_1174_n \
 N_D_c_1103_n N_D_c_1105_n N_D_c_1209_n N_D_c_1212_n N_D_c_1214_n N_D_c_1236_p \
 N_D_c_1245_p N_D_c_1231_p N_D_c_1217_n N_D_c_1218_n N_D_c_1106_n N_D_c_1220_n \
 N_D_c_1238_p N_D_c_1222_n )  PM_DLATCHN\%D
x_PM_DLATCHN\%noxref_7 ( N_noxref_7_c_1271_n N_noxref_7_c_1277_n \
 N_noxref_7_c_1300_n N_noxref_7_c_1304_n N_noxref_7_c_1306_n \
 N_noxref_7_c_1278_n N_noxref_7_c_1372_p N_noxref_7_c_1280_n \
 N_noxref_7_c_1281_n N_noxref_7_c_1358_n N_noxref_7_M7_noxref_g \
 N_noxref_7_M26_noxref_g N_noxref_7_M27_noxref_g N_noxref_7_c_1286_n \
 N_noxref_7_c_1391_p N_noxref_7_c_1392_p N_noxref_7_c_1288_n \
 N_noxref_7_c_1320_n N_noxref_7_c_1321_n N_noxref_7_c_1289_n \
 N_noxref_7_c_1379_p N_noxref_7_c_1290_n N_noxref_7_c_1292_n \
 N_noxref_7_c_1293_n N_noxref_7_M6_noxref_d N_noxref_7_M22_noxref_d \
 N_noxref_7_M24_noxref_d )  PM_DLATCHN\%noxref_7
x_PM_DLATCHN\%noxref_8 ( N_noxref_8_c_1410_n N_noxref_8_c_1462_n \
 N_noxref_8_c_1416_n N_noxref_8_c_1465_n N_noxref_8_c_1441_n \
 N_noxref_8_c_1444_n N_noxref_8_c_1419_n N_noxref_8_c_1420_n \
 N_noxref_8_c_1448_n N_noxref_8_M8_noxref_g N_noxref_8_M28_noxref_g \
 N_noxref_8_M29_noxref_g N_noxref_8_c_1423_n N_noxref_8_c_1517_p \
 N_noxref_8_c_1518_p N_noxref_8_c_1425_n N_noxref_8_c_1427_n \
 N_noxref_8_c_1521_p N_noxref_8_c_1527_p N_noxref_8_c_1428_n \
 N_noxref_8_c_1430_n N_noxref_8_c_1456_n N_noxref_8_M4_noxref_d \
 N_noxref_8_M20_noxref_d )  PM_DLATCHN\%noxref_8
x_PM_DLATCHN\%Q ( N_Q_c_1574_n N_Q_c_1580_n Q Q Q Q Q Q Q Q Q Q N_Q_c_1583_n \
 N_Q_c_1630_n N_Q_c_1612_n N_Q_c_1614_n N_Q_c_1587_n N_Q_c_1592_n N_Q_c_1616_n \
 N_Q_M10_noxref_g N_Q_M32_noxref_g N_Q_M33_noxref_g N_Q_c_1595_n N_Q_c_1662_p \
 N_Q_c_1663_p N_Q_c_1597_n N_Q_c_1599_n N_Q_c_1720_p N_Q_c_1648_p N_Q_c_1600_n \
 N_Q_c_1602_n N_Q_c_1624_n N_Q_M8_noxref_d N_Q_M9_noxref_d N_Q_M30_noxref_d )  \
 PM_DLATCHN\%Q
x_PM_DLATCHN\%noxref_10 ( N_noxref_10_c_1741_n N_noxref_10_c_1767_n \
 N_noxref_10_c_1742_n N_noxref_10_c_1788_n N_noxref_10_c_1770_n \
 N_noxref_10_c_1773_n N_noxref_10_c_1745_n N_noxref_10_c_1831_n \
 N_noxref_10_c_1746_n N_noxref_10_M11_noxref_g N_noxref_10_M34_noxref_g \
 N_noxref_10_M35_noxref_g N_noxref_10_c_1748_n N_noxref_10_c_1843_n \
 N_noxref_10_c_1846_n N_noxref_10_c_1859_p N_noxref_10_c_1750_n \
 N_noxref_10_c_1751_n N_noxref_10_c_1752_n N_noxref_10_c_1850_n \
 N_noxref_10_c_1851_n N_noxref_10_c_1853_n N_noxref_10_c_1854_n \
 N_noxref_10_M7_noxref_d N_noxref_10_M26_noxref_d )  PM_DLATCHN\%noxref_10
x_PM_DLATCHN\%noxref_11 ( N_noxref_11_c_1903_n N_noxref_11_c_1905_n \
 N_noxref_11_c_1945_n N_noxref_11_c_1906_n N_noxref_11_c_1908_n \
 N_noxref_11_c_1983_n N_noxref_11_c_1933_n N_noxref_11_c_1935_n \
 N_noxref_11_c_1912_n N_noxref_11_c_1916_n N_noxref_11_M9_noxref_g \
 N_noxref_11_M30_noxref_g N_noxref_11_M31_noxref_g N_noxref_11_c_1917_n \
 N_noxref_11_c_1956_n N_noxref_11_c_1959_n N_noxref_11_c_1996_n \
 N_noxref_11_c_1919_n N_noxref_11_c_1920_n N_noxref_11_c_1921_n \
 N_noxref_11_c_1963_n N_noxref_11_c_1964_n N_noxref_11_c_1966_n \
 N_noxref_11_c_1967_n N_noxref_11_M10_noxref_d N_noxref_11_M11_noxref_d \
 N_noxref_11_M34_noxref_d )  PM_DLATCHN\%noxref_11
x_PM_DLATCHN\%GATE_N ( GATE_N GATE_N GATE_N GATE_N GATE_N GATE_N \
 N_GATE_N_c_2065_n N_GATE_N_M0_noxref_g N_GATE_N_M12_noxref_g \
 N_GATE_N_M13_noxref_g N_GATE_N_c_2070_n N_GATE_N_c_2099_n N_GATE_N_c_2100_n \
 N_GATE_N_c_2072_n N_GATE_N_c_2089_n N_GATE_N_c_2090_n N_GATE_N_c_2073_n \
 N_GATE_N_c_2107_n N_GATE_N_c_2074_n N_GATE_N_c_2076_n N_GATE_N_c_2077_n )  \
 PM_DLATCHN\%GATE_N
x_PM_DLATCHN\%noxref_13 ( N_noxref_13_c_2114_n N_noxref_13_c_2115_n \
 N_noxref_13_c_2119_n N_noxref_13_c_2122_n N_noxref_13_c_2123_n \
 N_noxref_13_c_2126_n N_noxref_13_M2_noxref_s )  PM_DLATCHN\%noxref_13
x_PM_DLATCHN\%noxref_14 ( N_noxref_14_c_2168_n N_noxref_14_c_2169_n \
 N_noxref_14_c_2173_n N_noxref_14_c_2176_n N_noxref_14_c_2177_n \
 N_noxref_14_c_2180_n N_noxref_14_M5_noxref_s )  PM_DLATCHN\%noxref_14
x_PM_DLATCHN\%noxref_15 ( N_noxref_15_c_2222_n N_noxref_15_c_2227_n \
 N_noxref_15_c_2229_n N_noxref_15_c_2230_n N_noxref_15_M28_noxref_s \
 N_noxref_15_M29_noxref_d N_noxref_15_M31_noxref_d )  PM_DLATCHN\%noxref_15
x_PM_DLATCHN\%noxref_16 ( N_noxref_16_c_2265_n N_noxref_16_c_2269_n \
 N_noxref_16_c_2270_n N_noxref_16_c_2271_n N_noxref_16_M32_noxref_s \
 N_noxref_16_M33_noxref_d N_noxref_16_M35_noxref_d )  PM_DLATCHN\%noxref_16
cc_1 ( N_GND_c_1_p N_VDD_c_308_n ) capacitor c=0.00989514f //x=22.32 //y=0.18 \
 //x2=22.32 //y2=7.58
cc_2 ( N_GND_c_2_p N_VDD_c_309_n ) capacitor c=0.00989514f //x=1.12 //y=0.175 \
 //x2=1.23 //y2=7.58
cc_3 ( N_GND_c_3_p N_VDD_c_310_n ) capacitor c=0.00851402f //x=2.71 //y=0.175 \
 //x2=2.71 //y2=7.585
cc_4 ( N_GND_c_4_p N_VDD_c_311_n ) capacitor c=0.00474917f //x=4.93 //y=0.175 \
 //x2=4.93 //y2=7.585
cc_5 ( N_GND_c_5_p N_VDD_c_312_n ) capacitor c=0.00479032f //x=8.26 //y=0.175 \
 //x2=8.26 //y2=7.585
cc_6 ( N_GND_c_6_p N_VDD_c_313_n ) capacitor c=0.00474917f //x=10.48 //y=0.175 \
 //x2=10.48 //y2=7.585
cc_7 ( N_GND_c_7_p N_VDD_c_314_n ) capacitor c=0.00828486f //x=13.81 //y=0.175 \
 //x2=13.81 //y2=7.585
cc_8 ( N_GND_c_8_p N_VDD_c_315_n ) capacitor c=0.00524733f //x=16.03 //y=0.175 \
 //x2=16.03 //y2=7.585
cc_9 ( N_GND_c_9_p N_VDD_c_316_n ) capacitor c=0.00500791f //x=19.36 //y=0.175 \
 //x2=19.36 //y2=7.585
cc_10 ( N_GND_c_10_p N_noxref_3_c_603_n ) capacitor c=0.00130814f //x=22.32 \
 //y=0.18 //x2=4.105 //y2=2.26
cc_11 ( N_GND_c_4_p N_noxref_3_c_603_n ) capacitor c=0.0296841f //x=4.93 \
 //y=0.175 //x2=4.105 //y2=2.26
cc_12 ( N_GND_M1_noxref_s N_noxref_3_c_603_n ) capacitor c=0.0096778f \
 //x=3.205 //y=0.55 //x2=4.105 //y2=2.26
cc_13 ( N_GND_c_3_p N_noxref_3_c_606_n ) capacitor c=8.10282e-19 //x=2.71 \
 //y=0.175 //x2=4.19 //y2=3.88
cc_14 ( N_GND_c_4_p N_noxref_3_c_607_n ) capacitor c=0.0179404f //x=4.93 \
 //y=0.175 //x2=6.04 //y2=2.26
cc_15 ( N_GND_c_15_p N_noxref_3_c_608_n ) capacitor c=0.00135783f //x=6.025 \
 //y=0.175 //x2=5.845 //y2=1.045
cc_16 ( N_GND_M2_noxref_d N_noxref_3_c_608_n ) capacitor c=0.00220047f \
 //x=5.92 //y=1.045 //x2=5.845 //y2=1.045
cc_17 ( N_GND_M2_noxref_d N_noxref_3_c_610_n ) capacitor c=0.00255985f \
 //x=5.92 //y=1.045 //x2=5.845 //y2=1.39
cc_18 ( N_GND_c_4_p N_noxref_3_c_611_n ) capacitor c=0.0114883f //x=4.93 \
 //y=0.175 //x2=5.845 //y2=2.095
cc_19 ( N_GND_M2_noxref_d N_noxref_3_c_612_n ) capacitor c=0.0131374f //x=5.92 \
 //y=1.045 //x2=6.22 //y2=0.89
cc_20 ( N_GND_M2_noxref_d N_noxref_3_c_613_n ) capacitor c=0.00193146f \
 //x=5.92 //y=1.045 //x2=6.22 //y2=1.545
cc_21 ( N_GND_c_21_p N_noxref_3_c_614_n ) capacitor c=0.00131234f //x=8.09 \
 //y=0.175 //x2=6.375 //y2=1.045
cc_22 ( N_GND_M2_noxref_d N_noxref_3_c_614_n ) capacitor c=0.00257848f \
 //x=5.92 //y=1.045 //x2=6.375 //y2=1.045
cc_23 ( N_GND_M2_noxref_d N_noxref_3_c_616_n ) capacitor c=0.00255985f \
 //x=5.92 //y=1.045 //x2=6.375 //y2=1.39
cc_24 ( N_GND_c_10_p N_noxref_3_M1_noxref_d ) capacitor c=0.00124116f \
 //x=22.32 //y=0.18 //x2=3.635 //y2=1.09
cc_25 ( N_GND_c_25_p N_noxref_3_M1_noxref_d ) capacitor c=0.0150664f //x=3.74 \
 //y=0.715 //x2=3.635 //y2=1.09
cc_26 ( N_GND_c_3_p N_noxref_3_M1_noxref_d ) capacitor c=0.00924905f //x=2.71 \
 //y=0.175 //x2=3.635 //y2=1.09
cc_27 ( N_GND_c_4_p N_noxref_3_M1_noxref_d ) capacitor c=0.00949241f //x=4.93 \
 //y=0.175 //x2=3.635 //y2=1.09
cc_28 ( N_GND_M1_noxref_s N_noxref_3_M1_noxref_d ) capacitor c=0.076995f \
 //x=3.205 //y=0.55 //x2=3.635 //y2=1.09
cc_29 ( N_GND_c_5_p N_noxref_4_c_720_n ) capacitor c=0.0461206f //x=8.26 \
 //y=0.175 //x2=7.435 //y2=1.835
cc_30 ( N_GND_M4_noxref_s N_noxref_4_c_720_n ) capacitor c=3.37896e-19 \
 //x=8.755 //y=0.55 //x2=7.435 //y2=1.835
cc_31 ( N_GND_c_4_p N_noxref_4_c_722_n ) capacitor c=0.00101801f //x=4.93 \
 //y=0.175 //x2=7.52 //y2=3.51
cc_32 ( N_GND_c_10_p N_noxref_4_c_723_n ) capacitor c=0.00183809f //x=22.32 \
 //y=0.18 //x2=9 //y2=2.265
cc_33 ( N_GND_c_33_p N_noxref_4_c_723_n ) capacitor c=7.85046e-19 //x=9.29 \
 //y=0.715 //x2=9 //y2=2.265
cc_34 ( N_GND_c_5_p N_noxref_4_c_723_n ) capacitor c=0.029021f //x=8.26 \
 //y=0.175 //x2=9 //y2=2.265
cc_35 ( N_GND_c_6_p N_noxref_4_c_723_n ) capacitor c=0.00118911f //x=10.48 \
 //y=0.175 //x2=9 //y2=2.265
cc_36 ( N_GND_M4_noxref_s N_noxref_4_c_723_n ) capacitor c=0.0102609f \
 //x=8.755 //y=0.55 //x2=9 //y2=2.265
cc_37 ( N_GND_c_33_p N_noxref_4_c_728_n ) capacitor c=0.01232f //x=9.29 \
 //y=0.715 //x2=9.11 //y2=1.09
cc_38 ( N_GND_M4_noxref_s N_noxref_4_c_728_n ) capacitor c=0.0317689f \
 //x=8.755 //y=0.55 //x2=9.11 //y2=1.09
cc_39 ( N_GND_c_5_p N_noxref_4_c_730_n ) capacitor c=0.00562003f //x=8.26 \
 //y=0.175 //x2=9.11 //y2=2.1
cc_40 ( N_GND_M4_noxref_s N_noxref_4_c_731_n ) capacitor c=0.0048929f \
 //x=8.755 //y=0.55 //x2=9.485 //y2=0.935
cc_41 ( N_GND_c_41_p N_noxref_4_c_732_n ) capacitor c=0.0119203f //x=9.775 \
 //y=0.715 //x2=9.64 //y2=1.09
cc_42 ( N_GND_M4_noxref_s N_noxref_4_c_732_n ) capacitor c=0.0143355f \
 //x=8.755 //y=0.55 //x2=9.64 //y2=1.09
cc_43 ( N_GND_M4_noxref_s N_noxref_4_c_734_n ) capacitor c=0.0074042f \
 //x=8.755 //y=0.55 //x2=9.64 //y2=1.435
cc_44 ( N_GND_c_33_p N_noxref_4_c_735_n ) capacitor c=2.1838e-19 //x=9.29 \
 //y=0.715 //x2=9 //y2=2.265
cc_45 ( N_GND_c_5_p N_noxref_4_c_735_n ) capacitor c=0.0108179f //x=8.26 \
 //y=0.175 //x2=9 //y2=2.265
cc_46 ( N_GND_M4_noxref_s N_noxref_4_c_735_n ) capacitor c=0.00652921f \
 //x=8.755 //y=0.55 //x2=9 //y2=2.265
cc_47 ( N_GND_c_4_p N_noxref_4_M3_noxref_d ) capacitor c=8.58106e-19 //x=4.93 \
 //y=0.175 //x2=6.89 //y2=1.085
cc_48 ( N_GND_c_5_p N_noxref_4_M3_noxref_d ) capacitor c=0.00616547f //x=8.26 \
 //y=0.175 //x2=6.89 //y2=1.085
cc_49 ( N_GND_M2_noxref_d N_noxref_4_M3_noxref_d ) capacitor c=0.00143464f \
 //x=5.92 //y=1.045 //x2=6.89 //y2=1.085
cc_50 ( N_GND_M4_noxref_s N_noxref_4_M3_noxref_d ) capacitor c=2.09402e-19 \
 //x=8.755 //y=0.55 //x2=6.89 //y2=1.085
cc_51 ( N_GND_c_10_p N_noxref_5_c_854_n ) capacitor c=0.0365635f //x=22.32 \
 //y=0.18 //x2=6.665 //y2=3.14
cc_52 ( N_GND_c_52_p N_noxref_5_c_854_n ) capacitor c=0.00129706f //x=2.54 \
 //y=0.175 //x2=6.665 //y2=3.14
cc_53 ( N_GND_c_53_p N_noxref_5_c_854_n ) capacitor c=0.00134601f //x=3.255 \
 //y=0.175 //x2=6.665 //y2=3.14
cc_54 ( N_GND_c_25_p N_noxref_5_c_854_n ) capacitor c=0.00132025f //x=3.74 \
 //y=0.715 //x2=6.665 //y2=3.14
cc_55 ( N_GND_c_55_p N_noxref_5_c_854_n ) capacitor c=0.00129706f //x=4.76 \
 //y=0.175 //x2=6.665 //y2=3.14
cc_56 ( N_GND_c_15_p N_noxref_5_c_854_n ) capacitor c=0.00233562f //x=6.025 \
 //y=0.175 //x2=6.665 //y2=3.14
cc_57 ( N_GND_c_3_p N_noxref_5_c_854_n ) capacitor c=0.0144855f //x=2.71 \
 //y=0.175 //x2=6.665 //y2=3.14
cc_58 ( N_GND_c_4_p N_noxref_5_c_854_n ) capacitor c=0.0144855f //x=4.93 \
 //y=0.175 //x2=6.665 //y2=3.14
cc_59 ( N_GND_M0_noxref_s N_noxref_5_c_854_n ) capacitor c=0.00169621f \
 //x=0.985 //y=0.55 //x2=6.665 //y2=3.14
cc_60 ( N_GND_M1_noxref_s N_noxref_5_c_854_n ) capacitor c=0.00496251f \
 //x=3.205 //y=0.55 //x2=6.665 //y2=3.14
cc_61 ( N_GND_c_10_p N_noxref_5_c_864_n ) capacitor c=0.00205746f //x=22.32 \
 //y=0.18 //x2=2.085 //y2=3.14
cc_62 ( N_GND_M0_noxref_s N_noxref_5_c_864_n ) capacitor c=8.45642e-19 \
 //x=0.985 //y=0.55 //x2=2.085 //y2=3.14
cc_63 ( N_GND_c_10_p N_noxref_5_c_866_n ) capacitor c=0.0383014f //x=22.32 \
 //y=0.18 //x2=11.475 //y2=3.14
cc_64 ( N_GND_c_21_p N_noxref_5_c_866_n ) capacitor c=0.00209137f //x=8.09 \
 //y=0.175 //x2=11.475 //y2=3.14
cc_65 ( N_GND_c_65_p N_noxref_5_c_866_n ) capacitor c=0.00134601f //x=8.805 \
 //y=0.175 //x2=11.475 //y2=3.14
cc_66 ( N_GND_c_33_p N_noxref_5_c_866_n ) capacitor c=0.00140377f //x=9.29 \
 //y=0.715 //x2=11.475 //y2=3.14
cc_67 ( N_GND_c_67_p N_noxref_5_c_866_n ) capacitor c=0.00129706f //x=10.31 \
 //y=0.175 //x2=11.475 //y2=3.14
cc_68 ( N_GND_c_68_p N_noxref_5_c_866_n ) capacitor c=0.00230319f //x=11.575 \
 //y=0.175 //x2=11.475 //y2=3.14
cc_69 ( N_GND_c_5_p N_noxref_5_c_866_n ) capacitor c=0.0144855f //x=8.26 \
 //y=0.175 //x2=11.475 //y2=3.14
cc_70 ( N_GND_c_6_p N_noxref_5_c_866_n ) capacitor c=0.0144855f //x=10.48 \
 //y=0.175 //x2=11.475 //y2=3.14
cc_71 ( N_GND_M4_noxref_s N_noxref_5_c_866_n ) capacitor c=0.00500333f \
 //x=8.755 //y=0.55 //x2=11.475 //y2=3.14
cc_72 ( N_GND_c_10_p N_noxref_5_c_875_n ) capacitor c=0.00168138f //x=22.32 \
 //y=0.18 //x2=6.895 //y2=3.14
cc_73 ( N_GND_c_10_p N_noxref_5_c_876_n ) capacitor c=0.0013991f //x=22.32 \
 //y=0.18 //x2=1.885 //y2=2.26
cc_74 ( N_GND_c_3_p N_noxref_5_c_876_n ) capacitor c=0.0297979f //x=2.71 \
 //y=0.175 //x2=1.885 //y2=2.26
cc_75 ( N_GND_M0_noxref_s N_noxref_5_c_876_n ) capacitor c=0.00929f //x=0.985 \
 //y=0.55 //x2=1.885 //y2=2.26
cc_76 ( N_GND_c_2_p N_noxref_5_c_879_n ) capacitor c=8.10282e-19 //x=1.12 \
 //y=0.175 //x2=1.97 //y2=3.14
cc_77 ( N_GND_c_4_p N_noxref_5_c_880_n ) capacitor c=9.2064e-19 //x=4.93 \
 //y=0.175 //x2=6.78 //y2=2.26
cc_78 ( N_GND_c_5_p N_noxref_5_c_880_n ) capacitor c=9.53263e-19 //x=8.26 \
 //y=0.175 //x2=6.78 //y2=2.26
cc_79 ( N_GND_c_6_p N_noxref_5_c_882_n ) capacitor c=0.0179404f //x=10.48 \
 //y=0.175 //x2=11.59 //y2=2.26
cc_80 ( N_GND_c_68_p N_noxref_5_c_883_n ) capacitor c=0.00135783f //x=11.575 \
 //y=0.175 //x2=11.395 //y2=1.045
cc_81 ( N_GND_M5_noxref_d N_noxref_5_c_883_n ) capacitor c=0.00220047f \
 //x=11.47 //y=1.045 //x2=11.395 //y2=1.045
cc_82 ( N_GND_M5_noxref_d N_noxref_5_c_885_n ) capacitor c=0.00255985f \
 //x=11.47 //y=1.045 //x2=11.395 //y2=1.39
cc_83 ( N_GND_c_6_p N_noxref_5_c_886_n ) capacitor c=0.0114883f //x=10.48 \
 //y=0.175 //x2=11.395 //y2=2.095
cc_84 ( N_GND_M5_noxref_d N_noxref_5_c_887_n ) capacitor c=0.0131374f \
 //x=11.47 //y=1.045 //x2=11.77 //y2=0.89
cc_85 ( N_GND_M5_noxref_d N_noxref_5_c_888_n ) capacitor c=0.00193146f \
 //x=11.47 //y=1.045 //x2=11.77 //y2=1.545
cc_86 ( N_GND_c_86_p N_noxref_5_c_889_n ) capacitor c=0.00131234f //x=13.64 \
 //y=0.175 //x2=11.925 //y2=1.045
cc_87 ( N_GND_M5_noxref_d N_noxref_5_c_889_n ) capacitor c=0.00257848f \
 //x=11.47 //y=1.045 //x2=11.925 //y2=1.045
cc_88 ( N_GND_M5_noxref_d N_noxref_5_c_891_n ) capacitor c=0.00255985f \
 //x=11.47 //y=1.045 //x2=11.925 //y2=1.39
cc_89 ( N_GND_c_10_p N_noxref_5_M0_noxref_d ) capacitor c=0.00194747f \
 //x=22.32 //y=0.18 //x2=1.415 //y2=1.09
cc_90 ( N_GND_c_90_p N_noxref_5_M0_noxref_d ) capacitor c=0.014622f //x=1.52 \
 //y=0.715 //x2=1.415 //y2=1.09
cc_91 ( N_GND_c_2_p N_noxref_5_M0_noxref_d ) capacitor c=0.0094373f //x=1.12 \
 //y=0.175 //x2=1.415 //y2=1.09
cc_92 ( N_GND_c_3_p N_noxref_5_M0_noxref_d ) capacitor c=0.00945919f //x=2.71 \
 //y=0.175 //x2=1.415 //y2=1.09
cc_93 ( N_GND_M0_noxref_s N_noxref_5_M0_noxref_d ) capacitor c=0.076995f \
 //x=0.985 //y=0.55 //x2=1.415 //y2=1.09
cc_94 ( N_GND_c_10_p N_D_c_1092_n ) capacitor c=0.00183809f //x=22.32 //y=0.18 \
 //x2=3.45 //y2=2.265
cc_95 ( N_GND_c_25_p N_D_c_1092_n ) capacitor c=7.85046e-19 //x=3.74 //y=0.715 \
 //x2=3.45 //y2=2.265
cc_96 ( N_GND_c_3_p N_D_c_1092_n ) capacitor c=0.029021f //x=2.71 //y=0.175 \
 //x2=3.45 //y2=2.265
cc_97 ( N_GND_c_4_p N_D_c_1092_n ) capacitor c=0.00118911f //x=4.93 //y=0.175 \
 //x2=3.45 //y2=2.265
cc_98 ( N_GND_M1_noxref_s N_D_c_1092_n ) capacitor c=0.01079f //x=3.205 \
 //y=0.55 //x2=3.45 //y2=2.265
cc_99 ( N_GND_c_6_p N_D_c_1097_n ) capacitor c=9.2064e-19 //x=10.48 //y=0.175 \
 //x2=12.33 //y2=2.26
cc_100 ( N_GND_c_7_p N_D_c_1097_n ) capacitor c=9.53263e-19 //x=13.81 \
 //y=0.175 //x2=12.33 //y2=2.26
cc_101 ( N_GND_c_25_p N_D_c_1099_n ) capacitor c=0.01232f //x=3.74 //y=0.715 \
 //x2=3.56 //y2=1.09
cc_102 ( N_GND_M1_noxref_s N_D_c_1099_n ) capacitor c=0.0316657f //x=3.205 \
 //y=0.55 //x2=3.56 //y2=1.09
cc_103 ( N_GND_c_3_p N_D_c_1101_n ) capacitor c=0.0038551f //x=2.71 //y=0.175 \
 //x2=3.56 //y2=2.1
cc_104 ( N_GND_M1_noxref_s N_D_c_1102_n ) capacitor c=0.0048929f //x=3.205 \
 //y=0.55 //x2=3.935 //y2=0.935
cc_105 ( N_GND_c_105_p N_D_c_1103_n ) capacitor c=0.0119203f //x=4.225 \
 //y=0.715 //x2=4.09 //y2=1.09
cc_106 ( N_GND_M1_noxref_s N_D_c_1103_n ) capacitor c=0.0143355f //x=3.205 \
 //y=0.55 //x2=4.09 //y2=1.09
cc_107 ( N_GND_M1_noxref_s N_D_c_1105_n ) capacitor c=0.0074042f //x=3.205 \
 //y=0.55 //x2=4.09 //y2=1.435
cc_108 ( N_GND_c_25_p N_D_c_1106_n ) capacitor c=2.1838e-19 //x=3.74 //y=0.715 \
 //x2=3.45 //y2=2.265
cc_109 ( N_GND_c_3_p N_D_c_1106_n ) capacitor c=0.0108179f //x=2.71 //y=0.175 \
 //x2=3.45 //y2=2.265
cc_110 ( N_GND_M1_noxref_s N_D_c_1106_n ) capacitor c=0.00652921f //x=3.205 \
 //y=0.55 //x2=3.45 //y2=2.265
cc_111 ( N_GND_c_10_p N_noxref_7_c_1271_n ) capacitor c=0.0116242f //x=22.32 \
 //y=0.18 //x2=14.435 //y2=3.51
cc_112 ( N_GND_c_86_p N_noxref_7_c_1271_n ) capacitor c=0.00157084f //x=13.64 \
 //y=0.175 //x2=14.435 //y2=3.51
cc_113 ( N_GND_c_113_p N_noxref_7_c_1271_n ) capacitor c=0.00110287f \
 //x=14.355 //y=0.175 //x2=14.435 //y2=3.51
cc_114 ( N_GND_c_114_p N_noxref_7_c_1271_n ) capacitor c=3.56654e-19 //x=14.84 \
 //y=0.715 //x2=14.435 //y2=3.51
cc_115 ( N_GND_c_7_p N_noxref_7_c_1271_n ) capacitor c=0.00820859f //x=13.81 \
 //y=0.175 //x2=14.435 //y2=3.51
cc_116 ( N_GND_M7_noxref_s N_noxref_7_c_1271_n ) capacitor c=0.00175419f \
 //x=14.305 //y=0.55 //x2=14.435 //y2=3.51
cc_117 ( N_GND_c_10_p N_noxref_7_c_1277_n ) capacitor c=0.00174433f //x=22.32 \
 //y=0.18 //x2=13.185 //y2=3.51
cc_118 ( N_GND_c_7_p N_noxref_7_c_1278_n ) capacitor c=0.0461206f //x=13.81 \
 //y=0.175 //x2=12.985 //y2=1.835
cc_119 ( N_GND_M7_noxref_s N_noxref_7_c_1278_n ) capacitor c=3.37896e-19 \
 //x=14.305 //y=0.55 //x2=12.985 //y2=1.835
cc_120 ( N_GND_c_6_p N_noxref_7_c_1280_n ) capacitor c=0.00101801f //x=10.48 \
 //y=0.175 //x2=13.07 //y2=3.51
cc_121 ( N_GND_c_10_p N_noxref_7_c_1281_n ) capacitor c=0.00184912f //x=22.32 \
 //y=0.18 //x2=14.55 //y2=2.265
cc_122 ( N_GND_c_114_p N_noxref_7_c_1281_n ) capacitor c=7.87839e-19 //x=14.84 \
 //y=0.715 //x2=14.55 //y2=2.265
cc_123 ( N_GND_c_7_p N_noxref_7_c_1281_n ) capacitor c=0.029021f //x=13.81 \
 //y=0.175 //x2=14.55 //y2=2.265
cc_124 ( N_GND_c_8_p N_noxref_7_c_1281_n ) capacitor c=0.00118911f //x=16.03 \
 //y=0.175 //x2=14.55 //y2=2.265
cc_125 ( N_GND_M7_noxref_s N_noxref_7_c_1281_n ) capacitor c=0.0109322f \
 //x=14.305 //y=0.55 //x2=14.55 //y2=2.265
cc_126 ( N_GND_c_114_p N_noxref_7_c_1286_n ) capacitor c=0.01232f //x=14.84 \
 //y=0.715 //x2=14.66 //y2=1.09
cc_127 ( N_GND_M7_noxref_s N_noxref_7_c_1286_n ) capacitor c=0.0317792f \
 //x=14.305 //y=0.55 //x2=14.66 //y2=1.09
cc_128 ( N_GND_c_7_p N_noxref_7_c_1288_n ) capacitor c=0.00562003f //x=13.81 \
 //y=0.175 //x2=14.66 //y2=2.1
cc_129 ( N_GND_M7_noxref_s N_noxref_7_c_1289_n ) capacitor c=0.0048929f \
 //x=14.305 //y=0.55 //x2=15.035 //y2=0.935
cc_130 ( N_GND_c_130_p N_noxref_7_c_1290_n ) capacitor c=0.0119203f //x=15.325 \
 //y=0.715 //x2=15.19 //y2=1.09
cc_131 ( N_GND_M7_noxref_s N_noxref_7_c_1290_n ) capacitor c=0.0143355f \
 //x=14.305 //y=0.55 //x2=15.19 //y2=1.09
cc_132 ( N_GND_M7_noxref_s N_noxref_7_c_1292_n ) capacitor c=0.0074042f \
 //x=14.305 //y=0.55 //x2=15.19 //y2=1.435
cc_133 ( N_GND_c_114_p N_noxref_7_c_1293_n ) capacitor c=2.1838e-19 //x=14.84 \
 //y=0.715 //x2=14.55 //y2=2.265
cc_134 ( N_GND_c_7_p N_noxref_7_c_1293_n ) capacitor c=0.0108179f //x=13.81 \
 //y=0.175 //x2=14.55 //y2=2.265
cc_135 ( N_GND_M7_noxref_s N_noxref_7_c_1293_n ) capacitor c=0.006558f \
 //x=14.305 //y=0.55 //x2=14.55 //y2=2.265
cc_136 ( N_GND_c_6_p N_noxref_7_M6_noxref_d ) capacitor c=8.58106e-19 \
 //x=10.48 //y=0.175 //x2=12.44 //y2=1.085
cc_137 ( N_GND_c_7_p N_noxref_7_M6_noxref_d ) capacitor c=0.00616547f \
 //x=13.81 //y=0.175 //x2=12.44 //y2=1.085
cc_138 ( N_GND_M5_noxref_d N_noxref_7_M6_noxref_d ) capacitor c=0.00143464f \
 //x=11.47 //y=1.045 //x2=12.44 //y2=1.085
cc_139 ( N_GND_M7_noxref_s N_noxref_7_M6_noxref_d ) capacitor c=2.09402e-19 \
 //x=14.305 //y=0.55 //x2=12.44 //y2=1.085
cc_140 ( N_GND_c_10_p N_noxref_8_c_1410_n ) capacitor c=0.0318084f //x=22.32 \
 //y=0.18 //x2=17.025 //y2=3.88
cc_141 ( N_GND_c_114_p N_noxref_8_c_1410_n ) capacitor c=6.67769e-19 //x=14.84 \
 //y=0.715 //x2=17.025 //y2=3.88
cc_142 ( N_GND_c_142_p N_noxref_8_c_1410_n ) capacitor c=8.6578e-19 //x=17.125 \
 //y=0.71 //x2=17.025 //y2=3.88
cc_143 ( N_GND_c_8_p N_noxref_8_c_1410_n ) capacitor c=0.00533026f //x=16.03 \
 //y=0.175 //x2=17.025 //y2=3.88
cc_144 ( N_GND_M7_noxref_s N_noxref_8_c_1410_n ) capacitor c=0.00141735f \
 //x=14.305 //y=0.55 //x2=17.025 //y2=3.88
cc_145 ( N_GND_M8_noxref_s N_noxref_8_c_1410_n ) capacitor c=0.00180308f \
 //x=16.59 //y=0.545 //x2=17.025 //y2=3.88
cc_146 ( N_GND_c_10_p N_noxref_8_c_1416_n ) capacitor c=0.00130814f //x=22.32 \
 //y=0.18 //x2=9.655 //y2=2.26
cc_147 ( N_GND_c_6_p N_noxref_8_c_1416_n ) capacitor c=0.0296841f //x=10.48 \
 //y=0.175 //x2=9.655 //y2=2.26
cc_148 ( N_GND_M4_noxref_s N_noxref_8_c_1416_n ) capacitor c=0.0096778f \
 //x=8.755 //y=0.55 //x2=9.655 //y2=2.26
cc_149 ( N_GND_c_5_p N_noxref_8_c_1419_n ) capacitor c=8.10282e-19 //x=8.26 \
 //y=0.175 //x2=9.74 //y2=3.88
cc_150 ( N_GND_c_10_p N_noxref_8_c_1420_n ) capacitor c=5.99269e-19 //x=22.32 \
 //y=0.18 //x2=17.14 //y2=2.26
cc_151 ( N_GND_c_142_p N_noxref_8_c_1420_n ) capacitor c=0.00135452f \
 //x=17.125 //y=0.71 //x2=17.14 //y2=2.26
cc_152 ( N_GND_c_8_p N_noxref_8_c_1420_n ) capacitor c=0.0175793f //x=16.03 \
 //y=0.175 //x2=17.14 //y2=2.26
cc_153 ( N_GND_c_142_p N_noxref_8_c_1423_n ) capacitor c=0.0125802f //x=17.125 \
 //y=0.71 //x2=16.945 //y2=1.085
cc_154 ( N_GND_M8_noxref_s N_noxref_8_c_1423_n ) capacitor c=0.0318086f \
 //x=16.59 //y=0.545 //x2=16.945 //y2=1.085
cc_155 ( N_GND_c_142_p N_noxref_8_c_1425_n ) capacitor c=2.1838e-19 //x=17.125 \
 //y=0.71 //x2=16.945 //y2=2.095
cc_156 ( N_GND_c_8_p N_noxref_8_c_1425_n ) capacitor c=0.0114883f //x=16.03 \
 //y=0.175 //x2=16.945 //y2=2.095
cc_157 ( N_GND_M8_noxref_s N_noxref_8_c_1427_n ) capacitor c=0.00476921f \
 //x=16.59 //y=0.545 //x2=17.32 //y2=0.93
cc_158 ( N_GND_c_158_p N_noxref_8_c_1428_n ) capacitor c=0.0113338f //x=17.61 \
 //y=0.71 //x2=17.475 //y2=1.085
cc_159 ( N_GND_M8_noxref_s N_noxref_8_c_1428_n ) capacitor c=0.00514143f \
 //x=16.59 //y=0.545 //x2=17.475 //y2=1.085
cc_160 ( N_GND_M8_noxref_s N_noxref_8_c_1430_n ) capacitor c=8.33128e-19 \
 //x=16.59 //y=0.545 //x2=17.475 //y2=1.43
cc_161 ( N_GND_c_10_p N_noxref_8_M4_noxref_d ) capacitor c=0.00124116f \
 //x=22.32 //y=0.18 //x2=9.185 //y2=1.09
cc_162 ( N_GND_c_33_p N_noxref_8_M4_noxref_d ) capacitor c=0.0150664f //x=9.29 \
 //y=0.715 //x2=9.185 //y2=1.09
cc_163 ( N_GND_c_5_p N_noxref_8_M4_noxref_d ) capacitor c=0.00924905f //x=8.26 \
 //y=0.175 //x2=9.185 //y2=1.09
cc_164 ( N_GND_c_6_p N_noxref_8_M4_noxref_d ) capacitor c=0.00949241f \
 //x=10.48 //y=0.175 //x2=9.185 //y2=1.09
cc_165 ( N_GND_M4_noxref_s N_noxref_8_M4_noxref_d ) capacitor c=0.076995f \
 //x=8.755 //y=0.55 //x2=9.185 //y2=1.09
cc_166 ( N_GND_c_10_p N_Q_c_1574_n ) capacitor c=0.0143768f //x=22.32 //y=0.18 \
 //x2=20.355 //y2=3.51
cc_167 ( N_GND_c_167_p N_Q_c_1574_n ) capacitor c=0.00136355f //x=19.19 \
 //y=0.175 //x2=20.355 //y2=3.51
cc_168 ( N_GND_c_168_p N_Q_c_1574_n ) capacitor c=0.00136355f //x=19.97 \
 //y=0.175 //x2=20.355 //y2=3.51
cc_169 ( N_GND_c_169_p N_Q_c_1574_n ) capacitor c=0.00131946f //x=20.455 \
 //y=0.71 //x2=20.355 //y2=3.51
cc_170 ( N_GND_c_9_p N_Q_c_1574_n ) capacitor c=0.00820859f //x=19.36 \
 //y=0.175 //x2=20.355 //y2=3.51
cc_171 ( N_GND_M10_noxref_s N_Q_c_1574_n ) capacitor c=0.00234522f //x=19.92 \
 //y=0.545 //x2=20.355 //y2=3.51
cc_172 ( N_GND_c_10_p N_Q_c_1580_n ) capacitor c=0.00192552f //x=22.32 \
 //y=0.18 //x2=18.735 //y2=3.51
cc_173 ( N_GND_M8_noxref_s N_Q_c_1580_n ) capacitor c=6.85334e-19 //x=16.59 \
 //y=0.545 //x2=18.735 //y2=3.51
cc_174 ( N_GND_c_8_p Q ) capacitor c=0.00101801f //x=16.03 //y=0.175 \
 //x2=18.62 //y2=2.4
cc_175 ( N_GND_c_10_p N_Q_c_1583_n ) capacitor c=0.00257034f //x=22.32 \
 //y=0.18 //x2=18.095 //y2=1.835
cc_176 ( N_GND_c_158_p N_Q_c_1583_n ) capacitor c=0.00381844f //x=17.61 \
 //y=0.71 //x2=18.095 //y2=1.835
cc_177 ( N_GND_c_177_p N_Q_c_1583_n ) capacitor c=0.00320884f //x=18.095 \
 //y=0.71 //x2=18.095 //y2=1.835
cc_178 ( N_GND_M8_noxref_s N_Q_c_1583_n ) capacitor c=0.0172045f //x=16.59 \
 //y=0.545 //x2=18.095 //y2=1.835
cc_179 ( N_GND_c_10_p N_Q_c_1587_n ) capacitor c=0.00187872f //x=22.32 \
 //y=0.18 //x2=18.535 //y2=1.835
cc_180 ( N_GND_c_180_p N_Q_c_1587_n ) capacitor c=0.00477569f //x=18.58 \
 //y=0.71 //x2=18.535 //y2=1.835
cc_181 ( N_GND_c_9_p N_Q_c_1587_n ) capacitor c=0.0466045f //x=19.36 //y=0.175 \
 //x2=18.535 //y2=1.835
cc_182 ( N_GND_M8_noxref_s N_Q_c_1587_n ) capacitor c=0.0158849f //x=16.59 \
 //y=0.545 //x2=18.535 //y2=1.835
cc_183 ( N_GND_M10_noxref_s N_Q_c_1587_n ) capacitor c=3.16502e-19 //x=19.92 \
 //y=0.545 //x2=18.535 //y2=1.835
cc_184 ( N_GND_c_10_p N_Q_c_1592_n ) capacitor c=5.94184e-19 //x=22.32 \
 //y=0.18 //x2=20.47 //y2=2.26
cc_185 ( N_GND_c_169_p N_Q_c_1592_n ) capacitor c=0.00135015f //x=20.455 \
 //y=0.71 //x2=20.47 //y2=2.26
cc_186 ( N_GND_c_9_p N_Q_c_1592_n ) capacitor c=0.0175793f //x=19.36 //y=0.175 \
 //x2=20.47 //y2=2.26
cc_187 ( N_GND_c_169_p N_Q_c_1595_n ) capacitor c=0.0126046f //x=20.455 \
 //y=0.71 //x2=20.275 //y2=1.085
cc_188 ( N_GND_M10_noxref_s N_Q_c_1595_n ) capacitor c=0.0318086f //x=19.92 \
 //y=0.545 //x2=20.275 //y2=1.085
cc_189 ( N_GND_c_169_p N_Q_c_1597_n ) capacitor c=2.1838e-19 //x=20.455 \
 //y=0.71 //x2=20.275 //y2=2.095
cc_190 ( N_GND_c_9_p N_Q_c_1597_n ) capacitor c=0.0130778f //x=19.36 //y=0.175 \
 //x2=20.275 //y2=2.095
cc_191 ( N_GND_M10_noxref_s N_Q_c_1599_n ) capacitor c=0.00479357f //x=19.92 \
 //y=0.545 //x2=20.65 //y2=0.93
cc_192 ( N_GND_c_192_p N_Q_c_1600_n ) capacitor c=0.0113581f //x=20.94 \
 //y=0.71 //x2=20.805 //y2=1.085
cc_193 ( N_GND_M10_noxref_s N_Q_c_1600_n ) capacitor c=0.00514143f //x=19.92 \
 //y=0.545 //x2=20.805 //y2=1.085
cc_194 ( N_GND_M10_noxref_s N_Q_c_1602_n ) capacitor c=8.33128e-19 //x=19.92 \
 //y=0.545 //x2=20.805 //y2=1.43
cc_195 ( N_GND_c_10_p N_Q_M8_noxref_d ) capacitor c=0.00113079f //x=22.32 \
 //y=0.18 //x2=17.02 //y2=1.085
cc_196 ( N_GND_c_8_p N_Q_M8_noxref_d ) capacitor c=0.00416273f //x=16.03 \
 //y=0.175 //x2=17.02 //y2=1.085
cc_197 ( N_GND_c_9_p N_Q_M8_noxref_d ) capacitor c=2.57516e-19 //x=19.36 \
 //y=0.175 //x2=17.02 //y2=1.085
cc_198 ( N_GND_M8_noxref_s N_Q_M8_noxref_d ) capacitor c=0.0767963f //x=16.59 \
 //y=0.545 //x2=17.02 //y2=1.085
cc_199 ( N_GND_c_10_p N_Q_M9_noxref_d ) capacitor c=0.00132665f //x=22.32 \
 //y=0.18 //x2=17.99 //y2=1.085
cc_200 ( N_GND_c_9_p N_Q_M9_noxref_d ) capacitor c=0.00609243f //x=19.36 \
 //y=0.175 //x2=17.99 //y2=1.085
cc_201 ( N_GND_M8_noxref_s N_Q_M9_noxref_d ) capacitor c=0.060983f //x=16.59 \
 //y=0.545 //x2=17.99 //y2=1.085
cc_202 ( N_GND_c_10_p N_noxref_10_c_1741_n ) capacitor c=0.0130168f //x=22.32 \
 //y=0.18 //x2=21.095 //y2=4.25
cc_203 ( N_GND_c_10_p N_noxref_10_c_1742_n ) capacitor c=0.00134692f //x=22.32 \
 //y=0.18 //x2=15.205 //y2=2.26
cc_204 ( N_GND_c_8_p N_noxref_10_c_1742_n ) capacitor c=0.0296841f //x=16.03 \
 //y=0.175 //x2=15.205 //y2=2.26
cc_205 ( N_GND_M7_noxref_s N_noxref_10_c_1742_n ) capacitor c=0.00988752f \
 //x=14.305 //y=0.55 //x2=15.205 //y2=2.26
cc_206 ( N_GND_c_7_p N_noxref_10_c_1745_n ) capacitor c=8.10282e-19 //x=13.81 \
 //y=0.175 //x2=15.29 //y2=4.25
cc_207 ( N_GND_c_1_p N_noxref_10_c_1746_n ) capacitor c=9.53263e-19 //x=22.32 \
 //y=0.18 //x2=21.21 //y2=2.26
cc_208 ( N_GND_c_9_p N_noxref_10_c_1746_n ) capacitor c=9.2064e-19 //x=19.36 \
 //y=0.175 //x2=21.21 //y2=2.26
cc_209 ( N_GND_c_209_p N_noxref_10_c_1748_n ) capacitor c=0.0110074f \
 //x=21.425 //y=0.71 //x2=21.245 //y2=1.085
cc_210 ( N_GND_M10_noxref_s N_noxref_10_c_1748_n ) capacitor c=0.00590563f \
 //x=19.92 //y=0.545 //x2=21.245 //y2=1.085
cc_211 ( N_GND_M10_noxref_s N_noxref_10_c_1750_n ) capacitor c=0.00469471f \
 //x=19.92 //y=0.545 //x2=21.62 //y2=0.93
cc_212 ( N_GND_M10_noxref_s N_noxref_10_c_1751_n ) capacitor c=0.00316186f \
 //x=19.92 //y=0.545 //x2=21.62 //y2=1.585
cc_213 ( N_GND_c_213_p N_noxref_10_c_1752_n ) capacitor c=0.0112593f //x=21.91 \
 //y=0.71 //x2=21.775 //y2=1.085
cc_214 ( N_GND_M10_noxref_s N_noxref_10_c_1752_n ) capacitor c=0.0142835f \
 //x=19.92 //y=0.545 //x2=21.775 //y2=1.085
cc_215 ( N_GND_c_10_p N_noxref_10_M7_noxref_d ) capacitor c=0.00132545f \
 //x=22.32 //y=0.18 //x2=14.735 //y2=1.09
cc_216 ( N_GND_c_114_p N_noxref_10_M7_noxref_d ) capacitor c=0.0151409f \
 //x=14.84 //y=0.715 //x2=14.735 //y2=1.09
cc_217 ( N_GND_c_7_p N_noxref_10_M7_noxref_d ) capacitor c=0.00924905f \
 //x=13.81 //y=0.175 //x2=14.735 //y2=1.09
cc_218 ( N_GND_c_8_p N_noxref_10_M7_noxref_d ) capacitor c=0.00949241f \
 //x=16.03 //y=0.175 //x2=14.735 //y2=1.09
cc_219 ( N_GND_M7_noxref_s N_noxref_10_M7_noxref_d ) capacitor c=0.076995f \
 //x=14.305 //y=0.55 //x2=14.735 //y2=1.09
cc_220 ( N_GND_c_10_p N_noxref_11_c_1903_n ) capacitor c=0.0190547f //x=22.32 \
 //y=0.18 //x2=21.835 //y2=3.88
cc_221 ( N_GND_M10_noxref_s N_noxref_11_c_1903_n ) capacitor c=6.25703e-19 \
 //x=19.92 //y=0.545 //x2=21.835 //y2=3.88
cc_222 ( N_GND_c_10_p N_noxref_11_c_1905_n ) capacitor c=0.0016537f //x=22.32 \
 //y=0.18 //x2=17.995 //y2=3.88
cc_223 ( N_GND_c_8_p N_noxref_11_c_1906_n ) capacitor c=9.2064e-19 //x=16.03 \
 //y=0.175 //x2=17.88 //y2=2.26
cc_224 ( N_GND_c_9_p N_noxref_11_c_1906_n ) capacitor c=9.53263e-19 //x=19.36 \
 //y=0.175 //x2=17.88 //y2=2.26
cc_225 ( N_GND_c_10_p N_noxref_11_c_1908_n ) capacitor c=0.00254965f //x=22.32 \
 //y=0.18 //x2=21.425 //y2=1.835
cc_226 ( N_GND_c_192_p N_noxref_11_c_1908_n ) capacitor c=0.00380217f \
 //x=20.94 //y=0.71 //x2=21.425 //y2=1.835
cc_227 ( N_GND_c_209_p N_noxref_11_c_1908_n ) capacitor c=0.00320926f \
 //x=21.425 //y=0.71 //x2=21.425 //y2=1.835
cc_228 ( N_GND_M10_noxref_s N_noxref_11_c_1908_n ) capacitor c=0.0171536f \
 //x=19.92 //y=0.545 //x2=21.425 //y2=1.835
cc_229 ( N_GND_c_10_p N_noxref_11_c_1912_n ) capacitor c=0.00190274f //x=22.32 \
 //y=0.18 //x2=21.865 //y2=1.835
cc_230 ( N_GND_c_213_p N_noxref_11_c_1912_n ) capacitor c=0.00477812f \
 //x=21.91 //y=0.71 //x2=21.865 //y2=1.835
cc_231 ( N_GND_c_1_p N_noxref_11_c_1912_n ) capacitor c=0.0471746f //x=22.32 \
 //y=0.18 //x2=21.865 //y2=1.835
cc_232 ( N_GND_M10_noxref_s N_noxref_11_c_1912_n ) capacitor c=0.0159972f \
 //x=19.92 //y=0.545 //x2=21.865 //y2=1.835
cc_233 ( N_GND_c_9_p N_noxref_11_c_1916_n ) capacitor c=9.64732e-19 //x=19.36 \
 //y=0.175 //x2=21.95 //y2=3.88
cc_234 ( N_GND_c_177_p N_noxref_11_c_1917_n ) capacitor c=0.0110074f \
 //x=18.095 //y=0.71 //x2=17.915 //y2=1.085
cc_235 ( N_GND_M8_noxref_s N_noxref_11_c_1917_n ) capacitor c=0.00590563f \
 //x=16.59 //y=0.545 //x2=17.915 //y2=1.085
cc_236 ( N_GND_M8_noxref_s N_noxref_11_c_1919_n ) capacitor c=0.00469471f \
 //x=16.59 //y=0.545 //x2=18.29 //y2=0.93
cc_237 ( N_GND_M8_noxref_s N_noxref_11_c_1920_n ) capacitor c=0.00316186f \
 //x=16.59 //y=0.545 //x2=18.29 //y2=1.585
cc_238 ( N_GND_c_180_p N_noxref_11_c_1921_n ) capacitor c=0.0112593f //x=18.58 \
 //y=0.71 //x2=18.445 //y2=1.085
cc_239 ( N_GND_M8_noxref_s N_noxref_11_c_1921_n ) capacitor c=0.0142835f \
 //x=16.59 //y=0.545 //x2=18.445 //y2=1.085
cc_240 ( N_GND_c_10_p N_noxref_11_M10_noxref_d ) capacitor c=0.00108998f \
 //x=22.32 //y=0.18 //x2=20.35 //y2=1.085
cc_241 ( N_GND_c_1_p N_noxref_11_M10_noxref_d ) capacitor c=2.57516e-19 \
 //x=22.32 //y=0.18 //x2=20.35 //y2=1.085
cc_242 ( N_GND_c_9_p N_noxref_11_M10_noxref_d ) capacitor c=0.00416273f \
 //x=19.36 //y=0.175 //x2=20.35 //y2=1.085
cc_243 ( N_GND_M10_noxref_s N_noxref_11_M10_noxref_d ) capacitor c=0.0767676f \
 //x=19.92 //y=0.545 //x2=20.35 //y2=1.085
cc_244 ( N_GND_c_10_p N_noxref_11_M11_noxref_d ) capacitor c=0.00132665f \
 //x=22.32 //y=0.18 //x2=21.32 //y2=1.085
cc_245 ( N_GND_c_1_p N_noxref_11_M11_noxref_d ) capacitor c=0.0061094f \
 //x=22.32 //y=0.18 //x2=21.32 //y2=1.085
cc_246 ( N_GND_M10_noxref_s N_noxref_11_M11_noxref_d ) capacitor c=0.060983f \
 //x=19.92 //y=0.545 //x2=21.32 //y2=1.085
cc_247 ( N_GND_c_10_p N_GATE_N_c_2065_n ) capacitor c=0.00203126f //x=22.32 \
 //y=0.18 //x2=1.23 //y2=2.265
cc_248 ( N_GND_c_90_p N_GATE_N_c_2065_n ) capacitor c=8.01092e-19 //x=1.52 \
 //y=0.715 //x2=1.23 //y2=2.265
cc_249 ( N_GND_c_2_p N_GATE_N_c_2065_n ) capacitor c=0.0293771f //x=1.12 \
 //y=0.175 //x2=1.23 //y2=2.265
cc_250 ( N_GND_c_3_p N_GATE_N_c_2065_n ) capacitor c=0.00118352f //x=2.71 \
 //y=0.175 //x2=1.23 //y2=2.265
cc_251 ( N_GND_M0_noxref_s N_GATE_N_c_2065_n ) capacitor c=0.0107289f \
 //x=0.985 //y=0.55 //x2=1.23 //y2=2.265
cc_252 ( N_GND_c_90_p N_GATE_N_c_2070_n ) capacitor c=0.0120525f //x=1.52 \
 //y=0.715 //x2=1.34 //y2=1.09
cc_253 ( N_GND_M0_noxref_s N_GATE_N_c_2070_n ) capacitor c=0.0315727f \
 //x=0.985 //y=0.55 //x2=1.34 //y2=1.09
cc_254 ( N_GND_c_2_p N_GATE_N_c_2072_n ) capacitor c=0.0124051f //x=1.12 \
 //y=0.175 //x2=1.34 //y2=2.1
cc_255 ( N_GND_M0_noxref_s N_GATE_N_c_2073_n ) capacitor c=0.00483567f \
 //x=0.985 //y=0.55 //x2=1.715 //y2=0.935
cc_256 ( N_GND_c_256_p N_GATE_N_c_2074_n ) capacitor c=0.0118631f //x=2.005 \
 //y=0.715 //x2=1.87 //y2=1.09
cc_257 ( N_GND_M0_noxref_s N_GATE_N_c_2074_n ) capacitor c=0.0143355f \
 //x=0.985 //y=0.55 //x2=1.87 //y2=1.09
cc_258 ( N_GND_M0_noxref_s N_GATE_N_c_2076_n ) capacitor c=0.0074042f \
 //x=0.985 //y=0.55 //x2=1.87 //y2=1.435
cc_259 ( N_GND_c_90_p N_GATE_N_c_2077_n ) capacitor c=2.1838e-19 //x=1.52 \
 //y=0.715 //x2=1.23 //y2=2.265
cc_260 ( N_GND_c_2_p N_GATE_N_c_2077_n ) capacitor c=0.0108179f //x=1.12 \
 //y=0.175 //x2=1.23 //y2=2.265
cc_261 ( N_GND_M0_noxref_s N_GATE_N_c_2077_n ) capacitor c=0.00650301f \
 //x=0.985 //y=0.55 //x2=1.23 //y2=2.265
cc_262 ( N_GND_M1_noxref_s N_noxref_13_c_2114_n ) capacitor c=0.0013253f \
 //x=3.205 //y=0.55 //x2=5.625 //y2=1.675
cc_263 ( N_GND_c_10_p N_noxref_13_c_2115_n ) capacitor c=0.00542295f //x=22.32 \
 //y=0.18 //x2=6.51 //y2=1.76
cc_264 ( N_GND_c_15_p N_noxref_13_c_2115_n ) capacitor c=0.00113088f //x=6.025 \
 //y=0.175 //x2=6.51 //y2=1.76
cc_265 ( N_GND_c_21_p N_noxref_13_c_2115_n ) capacitor c=0.00182616f //x=8.09 \
 //y=0.175 //x2=6.51 //y2=1.76
cc_266 ( N_GND_M2_noxref_d N_noxref_13_c_2115_n ) capacitor c=0.00890252f \
 //x=5.92 //y=1.045 //x2=6.51 //y2=1.76
cc_267 ( N_GND_c_10_p N_noxref_13_c_2119_n ) capacitor c=0.0028289f //x=22.32 \
 //y=0.18 //x2=6.595 //y2=0.795
cc_268 ( N_GND_c_21_p N_noxref_13_c_2119_n ) capacitor c=0.0148855f //x=8.09 \
 //y=0.175 //x2=6.595 //y2=0.795
cc_269 ( N_GND_M2_noxref_d N_noxref_13_c_2119_n ) capacitor c=0.033812f \
 //x=5.92 //y=1.045 //x2=6.595 //y2=0.795
cc_270 ( N_GND_c_4_p N_noxref_13_c_2122_n ) capacitor c=2.91423e-19 //x=4.93 \
 //y=0.175 //x2=6.595 //y2=1.675
cc_271 ( N_GND_c_10_p N_noxref_13_c_2123_n ) capacitor c=0.011627f //x=22.32 \
 //y=0.18 //x2=7.48 //y2=0.71
cc_272 ( N_GND_c_21_p N_noxref_13_c_2123_n ) capacitor c=0.0375558f //x=8.09 \
 //y=0.175 //x2=7.48 //y2=0.71
cc_273 ( N_GND_c_1_p N_noxref_13_c_2123_n ) capacitor c=0.00199816f //x=22.32 \
 //y=0.18 //x2=7.48 //y2=0.71
cc_274 ( N_GND_c_10_p N_noxref_13_c_2126_n ) capacitor c=0.00282884f //x=22.32 \
 //y=0.18 //x2=7.565 //y2=0.795
cc_275 ( N_GND_c_21_p N_noxref_13_c_2126_n ) capacitor c=0.0148206f //x=8.09 \
 //y=0.175 //x2=7.565 //y2=0.795
cc_276 ( N_GND_c_276_p N_noxref_13_c_2126_n ) capacitor c=9.77746e-19 //x=8.89 \
 //y=0.63 //x2=7.565 //y2=0.795
cc_277 ( N_GND_c_5_p N_noxref_13_c_2126_n ) capacitor c=0.0431718f //x=8.26 \
 //y=0.175 //x2=7.565 //y2=0.795
cc_278 ( N_GND_c_10_p N_noxref_13_M2_noxref_s ) capacitor c=0.00282968f \
 //x=22.32 //y=0.18 //x2=5.49 //y2=0.545
cc_279 ( N_GND_c_279_p N_noxref_13_M2_noxref_s ) capacitor c=0.0013253f \
 //x=4.31 //y=0.63 //x2=5.49 //y2=0.545
cc_280 ( N_GND_c_15_p N_noxref_13_M2_noxref_s ) capacitor c=0.014886f \
 //x=6.025 //y=0.175 //x2=5.49 //y2=0.545
cc_281 ( N_GND_c_4_p N_noxref_13_M2_noxref_s ) capacitor c=0.058339f //x=4.93 \
 //y=0.175 //x2=5.49 //y2=0.545
cc_282 ( N_GND_c_5_p N_noxref_13_M2_noxref_s ) capacitor c=0.00198098f \
 //x=8.26 //y=0.175 //x2=5.49 //y2=0.545
cc_283 ( N_GND_M2_noxref_d N_noxref_13_M2_noxref_s ) capacitor c=0.0334197f \
 //x=5.92 //y=1.045 //x2=5.49 //y2=0.545
cc_284 ( N_GND_M4_noxref_s N_noxref_13_M2_noxref_s ) capacitor c=9.77746e-19 \
 //x=8.755 //y=0.55 //x2=5.49 //y2=0.545
cc_285 ( N_GND_M4_noxref_s N_noxref_14_c_2168_n ) capacitor c=0.0013253f \
 //x=8.755 //y=0.55 //x2=11.175 //y2=1.675
cc_286 ( N_GND_c_10_p N_noxref_14_c_2169_n ) capacitor c=0.00550127f //x=22.32 \
 //y=0.18 //x2=12.06 //y2=1.76
cc_287 ( N_GND_c_68_p N_noxref_14_c_2169_n ) capacitor c=0.00113088f \
 //x=11.575 //y=0.175 //x2=12.06 //y2=1.76
cc_288 ( N_GND_c_86_p N_noxref_14_c_2169_n ) capacitor c=0.00181083f //x=13.64 \
 //y=0.175 //x2=12.06 //y2=1.76
cc_289 ( N_GND_M5_noxref_d N_noxref_14_c_2169_n ) capacitor c=0.00890717f \
 //x=11.47 //y=1.045 //x2=12.06 //y2=1.76
cc_290 ( N_GND_c_10_p N_noxref_14_c_2173_n ) capacitor c=0.00302993f //x=22.32 \
 //y=0.18 //x2=12.145 //y2=0.795
cc_291 ( N_GND_c_86_p N_noxref_14_c_2173_n ) capacitor c=0.014661f //x=13.64 \
 //y=0.175 //x2=12.145 //y2=0.795
cc_292 ( N_GND_M5_noxref_d N_noxref_14_c_2173_n ) capacitor c=0.033812f \
 //x=11.47 //y=1.045 //x2=12.145 //y2=0.795
cc_293 ( N_GND_c_6_p N_noxref_14_c_2176_n ) capacitor c=2.91423e-19 //x=10.48 \
 //y=0.175 //x2=12.145 //y2=1.675
cc_294 ( N_GND_c_10_p N_noxref_14_c_2177_n ) capacitor c=0.0123724f //x=22.32 \
 //y=0.18 //x2=13.03 //y2=0.71
cc_295 ( N_GND_c_86_p N_noxref_14_c_2177_n ) capacitor c=0.0373555f //x=13.64 \
 //y=0.175 //x2=13.03 //y2=0.71
cc_296 ( N_GND_c_1_p N_noxref_14_c_2177_n ) capacitor c=0.00199816f //x=22.32 \
 //y=0.18 //x2=13.03 //y2=0.71
cc_297 ( N_GND_c_10_p N_noxref_14_c_2180_n ) capacitor c=0.00292583f //x=22.32 \
 //y=0.18 //x2=13.115 //y2=0.795
cc_298 ( N_GND_c_86_p N_noxref_14_c_2180_n ) capacitor c=0.0148875f //x=13.64 \
 //y=0.175 //x2=13.115 //y2=0.795
cc_299 ( N_GND_c_299_p N_noxref_14_c_2180_n ) capacitor c=9.77746e-19 \
 //x=14.44 //y=0.63 //x2=13.115 //y2=0.795
cc_300 ( N_GND_c_7_p N_noxref_14_c_2180_n ) capacitor c=0.0431718f //x=13.81 \
 //y=0.175 //x2=13.115 //y2=0.795
cc_301 ( N_GND_c_10_p N_noxref_14_M5_noxref_s ) capacitor c=0.00282968f \
 //x=22.32 //y=0.18 //x2=11.04 //y2=0.545
cc_302 ( N_GND_c_302_p N_noxref_14_M5_noxref_s ) capacitor c=0.0013253f \
 //x=9.86 //y=0.63 //x2=11.04 //y2=0.545
cc_303 ( N_GND_c_68_p N_noxref_14_M5_noxref_s ) capacitor c=0.014886f \
 //x=11.575 //y=0.175 //x2=11.04 //y2=0.545
cc_304 ( N_GND_c_6_p N_noxref_14_M5_noxref_s ) capacitor c=0.058339f //x=10.48 \
 //y=0.175 //x2=11.04 //y2=0.545
cc_305 ( N_GND_c_7_p N_noxref_14_M5_noxref_s ) capacitor c=0.00198098f \
 //x=13.81 //y=0.175 //x2=11.04 //y2=0.545
cc_306 ( N_GND_M5_noxref_d N_noxref_14_M5_noxref_s ) capacitor c=0.0334197f \
 //x=11.47 //y=1.045 //x2=11.04 //y2=0.545
cc_307 ( N_GND_M7_noxref_s N_noxref_14_M5_noxref_s ) capacitor c=9.77746e-19 \
 //x=14.305 //y=0.55 //x2=11.04 //y2=0.545
cc_308 ( N_VDD_c_317_p N_noxref_3_c_622_n ) capacitor c=0.00122938f //x=22.32 \
 //y=7.58 //x2=4.105 //y2=4.76
cc_309 ( N_VDD_c_318_p N_noxref_3_c_622_n ) capacitor c=9.09621e-19 //x=4.18 \
 //y=7.585 //x2=4.105 //y2=4.76
cc_310 ( N_VDD_M15_noxref_d N_noxref_3_c_622_n ) capacitor c=0.00609295f \
 //x=4.12 //y=5.2 //x2=4.105 //y2=4.76
cc_311 ( N_VDD_c_310_n N_noxref_3_c_625_n ) capacitor c=0.017572f //x=2.71 \
 //y=7.585 //x2=3.91 //y2=4.76
cc_312 ( N_VDD_c_310_n N_noxref_3_c_606_n ) capacitor c=5.65246e-19 //x=2.71 \
 //y=7.585 //x2=4.19 //y2=3.88
cc_313 ( N_VDD_c_311_n N_noxref_3_c_606_n ) capacitor c=0.0221282f //x=4.93 \
 //y=7.585 //x2=4.19 //y2=3.88
cc_314 ( N_VDD_c_317_p N_noxref_3_c_607_n ) capacitor c=0.00126176f //x=22.32 \
 //y=7.58 //x2=6.04 //y2=2.26
cc_315 ( N_VDD_c_324_p N_noxref_3_c_607_n ) capacitor c=2.88573e-19 //x=6.515 \
 //y=7.585 //x2=6.04 //y2=2.26
cc_316 ( N_VDD_c_311_n N_noxref_3_c_607_n ) capacitor c=0.0160215f //x=4.93 \
 //y=7.585 //x2=6.04 //y2=2.26
cc_317 ( N_VDD_c_324_p N_noxref_3_M16_noxref_g ) capacitor c=0.00732332f \
 //x=6.515 //y=7.585 //x2=5.94 //y2=6.2
cc_318 ( N_VDD_M16_noxref_s N_noxref_3_M16_noxref_g ) capacitor c=0.054195f \
 //x=5.585 //y=5.2 //x2=5.94 //y2=6.2
cc_319 ( N_VDD_c_324_p N_noxref_3_M17_noxref_g ) capacitor c=0.00677553f \
 //x=6.515 //y=7.585 //x2=6.38 //y2=6.2
cc_320 ( N_VDD_M17_noxref_d N_noxref_3_M17_noxref_g ) capacitor c=0.015318f \
 //x=6.455 //y=5.2 //x2=6.38 //y2=6.2
cc_321 ( N_VDD_c_311_n N_noxref_3_c_635_n ) capacitor c=0.012849f //x=4.93 \
 //y=7.585 //x2=6.04 //y2=4.88
cc_322 ( N_VDD_c_317_p N_noxref_3_M14_noxref_d ) capacitor c=0.00285234f \
 //x=22.32 //y=7.58 //x2=3.68 //y2=5.2
cc_323 ( N_VDD_c_318_p N_noxref_3_M14_noxref_d ) capacitor c=0.0141568f \
 //x=4.18 //y=7.585 //x2=3.68 //y2=5.2
cc_324 ( N_VDD_c_311_n N_noxref_3_M14_noxref_d ) capacitor c=0.0204591f \
 //x=4.93 //y=7.585 //x2=3.68 //y2=5.2
cc_325 ( N_VDD_M14_noxref_s N_noxref_3_M14_noxref_d ) capacitor c=0.0843065f \
 //x=3.25 //y=5.2 //x2=3.68 //y2=5.2
cc_326 ( N_VDD_M15_noxref_d N_noxref_3_M14_noxref_d ) capacitor c=0.0832641f \
 //x=4.12 //y=5.2 //x2=3.68 //y2=5.2
cc_327 ( N_VDD_c_317_p N_noxref_4_c_742_n ) capacitor c=0.00460177f //x=22.32 \
 //y=7.58 //x2=6.955 //y2=5.38
cc_328 ( N_VDD_c_324_p N_noxref_4_c_742_n ) capacitor c=4.49205e-19 //x=6.515 \
 //y=7.585 //x2=6.955 //y2=5.38
cc_329 ( N_VDD_c_338_p N_noxref_4_c_742_n ) capacitor c=4.49205e-19 //x=7.395 \
 //y=7.585 //x2=6.955 //y2=5.38
cc_330 ( N_VDD_M17_noxref_d N_noxref_4_c_742_n ) capacitor c=0.0126931f \
 //x=6.455 //y=5.2 //x2=6.955 //y2=5.38
cc_331 ( N_VDD_c_311_n N_noxref_4_c_746_n ) capacitor c=0.00985474f //x=4.93 \
 //y=7.585 //x2=6.245 //y2=5.38
cc_332 ( N_VDD_M16_noxref_s N_noxref_4_c_746_n ) capacitor c=0.087833f \
 //x=5.585 //y=5.2 //x2=6.245 //y2=5.38
cc_333 ( N_VDD_c_317_p N_noxref_4_c_748_n ) capacitor c=0.0030743f //x=22.32 \
 //y=7.58 //x2=7.435 //y2=5.38
cc_334 ( N_VDD_c_338_p N_noxref_4_c_748_n ) capacitor c=7.74005e-19 //x=7.395 \
 //y=7.585 //x2=7.435 //y2=5.38
cc_335 ( N_VDD_M19_noxref_d N_noxref_4_c_748_n ) capacitor c=0.016158f \
 //x=7.335 //y=5.2 //x2=7.435 //y2=5.38
cc_336 ( N_VDD_c_311_n N_noxref_4_c_722_n ) capacitor c=0.00159771f //x=4.93 \
 //y=7.585 //x2=7.52 //y2=3.51
cc_337 ( N_VDD_c_312_n N_noxref_4_c_722_n ) capacitor c=0.0454286f //x=8.26 \
 //y=7.585 //x2=7.52 //y2=3.51
cc_338 ( N_VDD_c_317_p N_noxref_4_c_723_n ) capacitor c=0.00157791f //x=22.32 \
 //y=7.58 //x2=9 //y2=2.265
cc_339 ( N_VDD_c_312_n N_noxref_4_c_723_n ) capacitor c=0.026597f //x=8.26 \
 //y=7.585 //x2=9 //y2=2.265
cc_340 ( N_VDD_c_313_n N_noxref_4_c_723_n ) capacitor c=0.00141507f //x=10.48 \
 //y=7.585 //x2=9 //y2=2.265
cc_341 ( N_VDD_M20_noxref_s N_noxref_4_c_723_n ) capacitor c=0.0089782f \
 //x=8.8 //y=5.2 //x2=9 //y2=2.265
cc_342 ( N_VDD_c_351_p N_noxref_4_M20_noxref_g ) capacitor c=0.00753931f \
 //x=9.73 //y=7.585 //x2=9.155 //y2=6.2
cc_343 ( N_VDD_c_312_n N_noxref_4_M20_noxref_g ) capacitor c=0.00895557f \
 //x=8.26 //y=7.585 //x2=9.155 //y2=6.2
cc_344 ( N_VDD_M20_noxref_s N_noxref_4_M20_noxref_g ) capacitor c=0.0528676f \
 //x=8.8 //y=5.2 //x2=9.155 //y2=6.2
cc_345 ( N_VDD_c_351_p N_noxref_4_M21_noxref_g ) capacitor c=0.00702238f \
 //x=9.73 //y=7.585 //x2=9.595 //y2=6.2
cc_346 ( N_VDD_M21_noxref_d N_noxref_4_M21_noxref_g ) capacitor c=0.0528676f \
 //x=9.67 //y=5.2 //x2=9.595 //y2=6.2
cc_347 ( N_VDD_c_313_n N_noxref_4_c_762_n ) capacitor c=0.0110053f //x=10.48 \
 //y=7.585 //x2=9.52 //y2=4.97
cc_348 ( N_VDD_c_312_n N_noxref_4_c_763_n ) capacitor c=0.011132f //x=8.26 \
 //y=7.585 //x2=9.23 //y2=4.97
cc_349 ( N_VDD_M20_noxref_s N_noxref_4_c_763_n ) capacitor c=0.00524587f \
 //x=8.8 //y=5.2 //x2=9.23 //y2=4.97
cc_350 ( N_VDD_c_317_p N_noxref_4_M16_noxref_d ) capacitor c=0.00285139f \
 //x=22.32 //y=7.58 //x2=6.015 //y2=5.2
cc_351 ( N_VDD_c_324_p N_noxref_4_M16_noxref_d ) capacitor c=0.0141209f \
 //x=6.515 //y=7.585 //x2=6.015 //y2=5.2
cc_352 ( N_VDD_c_312_n N_noxref_4_M16_noxref_d ) capacitor c=6.94454e-19 \
 //x=8.26 //y=7.585 //x2=6.015 //y2=5.2
cc_353 ( N_VDD_M17_noxref_d N_noxref_4_M16_noxref_d ) capacitor c=0.0664752f \
 //x=6.455 //y=5.2 //x2=6.015 //y2=5.2
cc_354 ( N_VDD_c_317_p N_noxref_4_M18_noxref_d ) capacitor c=0.00285139f \
 //x=22.32 //y=7.58 //x2=6.895 //y2=5.2
cc_355 ( N_VDD_c_338_p N_noxref_4_M18_noxref_d ) capacitor c=0.0141209f \
 //x=7.395 //y=7.585 //x2=6.895 //y2=5.2
cc_356 ( N_VDD_c_312_n N_noxref_4_M18_noxref_d ) capacitor c=0.0120541f \
 //x=8.26 //y=7.585 //x2=6.895 //y2=5.2
cc_357 ( N_VDD_M16_noxref_s N_noxref_4_M18_noxref_d ) capacitor c=0.00111971f \
 //x=5.585 //y=5.2 //x2=6.895 //y2=5.2
cc_358 ( N_VDD_M17_noxref_d N_noxref_4_M18_noxref_d ) capacitor c=0.0664752f \
 //x=6.455 //y=5.2 //x2=6.895 //y2=5.2
cc_359 ( N_VDD_M19_noxref_d N_noxref_4_M18_noxref_d ) capacitor c=0.0664752f \
 //x=7.335 //y=5.2 //x2=6.895 //y2=5.2
cc_360 ( N_VDD_M20_noxref_s N_noxref_4_M18_noxref_d ) capacitor c=5.1407e-19 \
 //x=8.8 //y=5.2 //x2=6.895 //y2=5.2
cc_361 ( N_VDD_c_317_p N_noxref_5_c_854_n ) capacitor c=0.00821756f //x=22.32 \
 //y=7.58 //x2=6.665 //y2=3.14
cc_362 ( N_VDD_c_310_n N_noxref_5_c_854_n ) capacitor c=0.00462892f //x=2.71 \
 //y=7.585 //x2=6.665 //y2=3.14
cc_363 ( N_VDD_M13_noxref_d N_noxref_5_c_854_n ) capacitor c=3.55491e-19 \
 //x=1.9 //y=5.2 //x2=6.665 //y2=3.14
cc_364 ( N_VDD_c_317_p N_noxref_5_c_864_n ) capacitor c=0.00151191f //x=22.32 \
 //y=7.58 //x2=2.085 //y2=3.14
cc_365 ( N_VDD_M13_noxref_d N_noxref_5_c_864_n ) capacitor c=5.46794e-19 \
 //x=1.9 //y=5.2 //x2=2.085 //y2=3.14
cc_366 ( N_VDD_c_317_p N_noxref_5_c_902_n ) capacitor c=0.00142953f //x=22.32 \
 //y=7.58 //x2=1.885 //y2=4.76
cc_367 ( N_VDD_c_376_p N_noxref_5_c_902_n ) capacitor c=8.83313e-19 //x=1.96 \
 //y=7.585 //x2=1.885 //y2=4.76
cc_368 ( N_VDD_M13_noxref_d N_noxref_5_c_902_n ) capacitor c=0.00632713f \
 //x=1.9 //y=5.2 //x2=1.885 //y2=4.76
cc_369 ( N_VDD_c_309_n N_noxref_5_c_905_n ) capacitor c=0.0179238f //x=1.23 \
 //y=7.58 //x2=1.69 //y2=4.76
cc_370 ( N_VDD_c_309_n N_noxref_5_c_879_n ) capacitor c=5.8953e-19 //x=1.23 \
 //y=7.58 //x2=1.97 //y2=3.14
cc_371 ( N_VDD_c_310_n N_noxref_5_c_879_n ) capacitor c=0.0230589f //x=2.71 \
 //y=7.585 //x2=1.97 //y2=3.14
cc_372 ( N_VDD_c_311_n N_noxref_5_c_880_n ) capacitor c=6.52727e-19 //x=4.93 \
 //y=7.585 //x2=6.78 //y2=2.26
cc_373 ( N_VDD_c_312_n N_noxref_5_c_880_n ) capacitor c=5.44923e-19 //x=8.26 \
 //y=7.585 //x2=6.78 //y2=2.26
cc_374 ( N_VDD_c_317_p N_noxref_5_c_882_n ) capacitor c=0.00126176f //x=22.32 \
 //y=7.58 //x2=11.59 //y2=2.26
cc_375 ( N_VDD_c_384_p N_noxref_5_c_882_n ) capacitor c=2.88573e-19 //x=12.065 \
 //y=7.585 //x2=11.59 //y2=2.26
cc_376 ( N_VDD_c_313_n N_noxref_5_c_882_n ) capacitor c=0.0160121f //x=10.48 \
 //y=7.585 //x2=11.59 //y2=2.26
cc_377 ( N_VDD_c_338_p N_noxref_5_M18_noxref_g ) capacitor c=0.00678607f \
 //x=7.395 //y=7.585 //x2=6.82 //y2=6.2
cc_378 ( N_VDD_M17_noxref_d N_noxref_5_M18_noxref_g ) capacitor c=0.015318f \
 //x=6.455 //y=5.2 //x2=6.82 //y2=6.2
cc_379 ( N_VDD_c_338_p N_noxref_5_M19_noxref_g ) capacitor c=0.00677553f \
 //x=7.395 //y=7.585 //x2=7.26 //y2=6.2
cc_380 ( N_VDD_c_312_n N_noxref_5_M19_noxref_g ) capacitor c=0.00904525f \
 //x=8.26 //y=7.585 //x2=7.26 //y2=6.2
cc_381 ( N_VDD_M19_noxref_d N_noxref_5_M19_noxref_g ) capacitor c=0.0430452f \
 //x=7.335 //y=5.2 //x2=7.26 //y2=6.2
cc_382 ( N_VDD_c_384_p N_noxref_5_M22_noxref_g ) capacitor c=0.00732332f \
 //x=12.065 //y=7.585 //x2=11.49 //y2=6.2
cc_383 ( N_VDD_M22_noxref_s N_noxref_5_M22_noxref_g ) capacitor c=0.054195f \
 //x=11.135 //y=5.2 //x2=11.49 //y2=6.2
cc_384 ( N_VDD_c_384_p N_noxref_5_M23_noxref_g ) capacitor c=0.00677553f \
 //x=12.065 //y=7.585 //x2=11.93 //y2=6.2
cc_385 ( N_VDD_M23_noxref_d N_noxref_5_M23_noxref_g ) capacitor c=0.015318f \
 //x=12.005 //y=5.2 //x2=11.93 //y2=6.2
cc_386 ( N_VDD_c_313_n N_noxref_5_c_922_n ) capacitor c=0.012849f //x=10.48 \
 //y=7.585 //x2=11.59 //y2=4.88
cc_387 ( N_VDD_c_317_p N_noxref_5_M12_noxref_d ) capacitor c=0.00710215f \
 //x=22.32 //y=7.58 //x2=1.46 //y2=5.2
cc_388 ( N_VDD_c_376_p N_noxref_5_M12_noxref_d ) capacitor c=0.0139426f \
 //x=1.96 //y=7.585 //x2=1.46 //y2=5.2
cc_389 ( N_VDD_c_310_n N_noxref_5_M12_noxref_d ) capacitor c=0.0201812f \
 //x=2.71 //y=7.585 //x2=1.46 //y2=5.2
cc_390 ( N_VDD_M12_noxref_s N_noxref_5_M12_noxref_d ) capacitor c=0.0843065f \
 //x=1.03 //y=5.2 //x2=1.46 //y2=5.2
cc_391 ( N_VDD_M13_noxref_d N_noxref_5_M12_noxref_d ) capacitor c=0.0832641f \
 //x=1.9 //y=5.2 //x2=1.46 //y2=5.2
cc_392 ( N_VDD_c_317_p N_D_c_1109_n ) capacitor c=0.059495f //x=22.32 //y=7.58 \
 //x2=12.215 //y2=4.25
cc_393 ( N_VDD_c_318_p N_D_c_1109_n ) capacitor c=9.77383e-19 //x=4.18 \
 //y=7.585 //x2=12.215 //y2=4.25
cc_394 ( N_VDD_c_403_p N_D_c_1109_n ) capacitor c=0.00124324f //x=4.76 \
 //y=7.585 //x2=12.215 //y2=4.25
cc_395 ( N_VDD_c_404_p N_D_c_1109_n ) capacitor c=0.00172127f //x=5.635 \
 //y=7.585 //x2=12.215 //y2=4.25
cc_396 ( N_VDD_c_324_p N_D_c_1109_n ) capacitor c=6.61227e-19 //x=6.515 \
 //y=7.585 //x2=12.215 //y2=4.25
cc_397 ( N_VDD_c_406_p N_D_c_1109_n ) capacitor c=0.00168633f //x=8.09 \
 //y=7.585 //x2=12.215 //y2=4.25
cc_398 ( N_VDD_c_407_p N_D_c_1109_n ) capacitor c=0.00128334f //x=8.85 \
 //y=7.585 //x2=12.215 //y2=4.25
cc_399 ( N_VDD_c_351_p N_D_c_1109_n ) capacitor c=0.00111964f //x=9.73 \
 //y=7.585 //x2=12.215 //y2=4.25
cc_400 ( N_VDD_c_409_p N_D_c_1109_n ) capacitor c=0.00124324f //x=10.31 \
 //y=7.585 //x2=12.215 //y2=4.25
cc_401 ( N_VDD_c_410_p N_D_c_1109_n ) capacitor c=0.00172127f //x=11.185 \
 //y=7.585 //x2=12.215 //y2=4.25
cc_402 ( N_VDD_c_384_p N_D_c_1109_n ) capacitor c=6.61227e-19 //x=12.065 \
 //y=7.585 //x2=12.215 //y2=4.25
cc_403 ( N_VDD_c_311_n N_D_c_1109_n ) capacitor c=0.0269493f //x=4.93 \
 //y=7.585 //x2=12.215 //y2=4.25
cc_404 ( N_VDD_c_312_n N_D_c_1109_n ) capacitor c=0.0269011f //x=8.26 \
 //y=7.585 //x2=12.215 //y2=4.25
cc_405 ( N_VDD_c_313_n N_D_c_1109_n ) capacitor c=0.0269493f //x=10.48 \
 //y=7.585 //x2=12.215 //y2=4.25
cc_406 ( N_VDD_M15_noxref_d N_D_c_1109_n ) capacitor c=0.00213864f //x=4.12 \
 //y=5.2 //x2=12.215 //y2=4.25
cc_407 ( N_VDD_M16_noxref_s N_D_c_1109_n ) capacitor c=0.00363045f //x=5.585 \
 //y=5.2 //x2=12.215 //y2=4.25
cc_408 ( N_VDD_M19_noxref_d N_D_c_1109_n ) capacitor c=5.05316e-19 //x=7.335 \
 //y=5.2 //x2=12.215 //y2=4.25
cc_409 ( N_VDD_M20_noxref_s N_D_c_1109_n ) capacitor c=0.00191095f //x=8.8 \
 //y=5.2 //x2=12.215 //y2=4.25
cc_410 ( N_VDD_M21_noxref_d N_D_c_1109_n ) capacitor c=0.00213864f //x=9.67 \
 //y=5.2 //x2=12.215 //y2=4.25
cc_411 ( N_VDD_M22_noxref_s N_D_c_1109_n ) capacitor c=0.00363045f //x=11.135 \
 //y=5.2 //x2=12.215 //y2=4.25
cc_412 ( N_VDD_c_317_p N_D_c_1129_n ) capacitor c=0.00188396f //x=22.32 \
 //y=7.58 //x2=3.565 //y2=4.25
cc_413 ( N_VDD_c_310_n N_D_c_1129_n ) capacitor c=0.0029188f //x=2.71 \
 //y=7.585 //x2=3.565 //y2=4.25
cc_414 ( N_VDD_M14_noxref_s N_D_c_1129_n ) capacitor c=0.00188667f //x=3.25 \
 //y=5.2 //x2=3.565 //y2=4.25
cc_415 ( N_VDD_c_317_p N_D_c_1092_n ) capacitor c=0.00157688f //x=22.32 \
 //y=7.58 //x2=3.45 //y2=2.265
cc_416 ( N_VDD_c_310_n N_D_c_1092_n ) capacitor c=0.0269501f //x=2.71 \
 //y=7.585 //x2=3.45 //y2=2.265
cc_417 ( N_VDD_c_311_n N_D_c_1092_n ) capacitor c=0.00139956f //x=4.93 \
 //y=7.585 //x2=3.45 //y2=2.265
cc_418 ( N_VDD_M14_noxref_s N_D_c_1092_n ) capacitor c=0.00896399f //x=3.25 \
 //y=5.2 //x2=3.45 //y2=2.265
cc_419 ( N_VDD_c_313_n N_D_c_1097_n ) capacitor c=6.2696e-19 //x=10.48 \
 //y=7.585 //x2=12.33 //y2=2.26
cc_420 ( N_VDD_c_314_n N_D_c_1097_n ) capacitor c=6.61994e-19 //x=13.81 \
 //y=7.585 //x2=12.33 //y2=2.26
cc_421 ( N_VDD_c_318_p N_D_M14_noxref_g ) capacitor c=0.00753931f //x=4.18 \
 //y=7.585 //x2=3.605 //y2=6.2
cc_422 ( N_VDD_c_310_n N_D_M14_noxref_g ) capacitor c=0.00653241f //x=2.71 \
 //y=7.585 //x2=3.605 //y2=6.2
cc_423 ( N_VDD_M14_noxref_s N_D_M14_noxref_g ) capacitor c=0.0528676f //x=3.25 \
 //y=5.2 //x2=3.605 //y2=6.2
cc_424 ( N_VDD_c_318_p N_D_M15_noxref_g ) capacitor c=0.00702238f //x=4.18 \
 //y=7.585 //x2=4.045 //y2=6.2
cc_425 ( N_VDD_M15_noxref_d N_D_M15_noxref_g ) capacitor c=0.0528676f //x=4.12 \
 //y=5.2 //x2=4.045 //y2=6.2
cc_426 ( N_VDD_c_435_p N_D_M24_noxref_g ) capacitor c=0.00678607f //x=12.945 \
 //y=7.585 //x2=12.37 //y2=6.2
cc_427 ( N_VDD_M23_noxref_d N_D_M24_noxref_g ) capacitor c=0.015318f \
 //x=12.005 //y=5.2 //x2=12.37 //y2=6.2
cc_428 ( N_VDD_c_435_p N_D_M25_noxref_g ) capacitor c=0.00677553f //x=12.945 \
 //y=7.585 //x2=12.81 //y2=6.2
cc_429 ( N_VDD_c_314_n N_D_M25_noxref_g ) capacitor c=0.00904525f //x=13.81 \
 //y=7.585 //x2=12.81 //y2=6.2
cc_430 ( N_VDD_M25_noxref_d N_D_M25_noxref_g ) capacitor c=0.0430452f \
 //x=12.885 //y=5.2 //x2=12.81 //y2=6.2
cc_431 ( N_VDD_c_311_n N_D_c_1148_n ) capacitor c=0.0110053f //x=4.93 \
 //y=7.585 //x2=3.97 //y2=4.97
cc_432 ( N_VDD_c_310_n N_D_c_1149_n ) capacitor c=0.011132f //x=2.71 //y=7.585 \
 //x2=3.68 //y2=4.97
cc_433 ( N_VDD_M14_noxref_s N_D_c_1149_n ) capacitor c=0.00524561f //x=3.25 \
 //y=5.2 //x2=3.68 //y2=4.97
cc_434 ( N_VDD_c_317_p N_noxref_7_c_1300_n ) capacitor c=0.00459998f //x=22.32 \
 //y=7.58 //x2=12.505 //y2=5.38
cc_435 ( N_VDD_c_384_p N_noxref_7_c_1300_n ) capacitor c=4.49205e-19 \
 //x=12.065 //y=7.585 //x2=12.505 //y2=5.38
cc_436 ( N_VDD_c_435_p N_noxref_7_c_1300_n ) capacitor c=4.49193e-19 \
 //x=12.945 //y=7.585 //x2=12.505 //y2=5.38
cc_437 ( N_VDD_M23_noxref_d N_noxref_7_c_1300_n ) capacitor c=0.0126907f \
 //x=12.005 //y=5.2 //x2=12.505 //y2=5.38
cc_438 ( N_VDD_c_313_n N_noxref_7_c_1304_n ) capacitor c=0.00985474f //x=10.48 \
 //y=7.585 //x2=11.795 //y2=5.38
cc_439 ( N_VDD_M22_noxref_s N_noxref_7_c_1304_n ) capacitor c=0.087833f \
 //x=11.135 //y=5.2 //x2=11.795 //y2=5.38
cc_440 ( N_VDD_c_317_p N_noxref_7_c_1306_n ) capacitor c=0.00312262f //x=22.32 \
 //y=7.58 //x2=12.985 //y2=5.38
cc_441 ( N_VDD_c_435_p N_noxref_7_c_1306_n ) capacitor c=7.22416e-19 \
 //x=12.945 //y=7.585 //x2=12.985 //y2=5.38
cc_442 ( N_VDD_M25_noxref_d N_noxref_7_c_1306_n ) capacitor c=0.0163548f \
 //x=12.885 //y=5.2 //x2=12.985 //y2=5.38
cc_443 ( N_VDD_c_313_n N_noxref_7_c_1280_n ) capacitor c=0.00159771f //x=10.48 \
 //y=7.585 //x2=13.07 //y2=3.51
cc_444 ( N_VDD_c_314_n N_noxref_7_c_1280_n ) capacitor c=0.0457825f //x=13.81 \
 //y=7.585 //x2=13.07 //y2=3.51
cc_445 ( N_VDD_c_317_p N_noxref_7_c_1281_n ) capacitor c=0.00159012f //x=22.32 \
 //y=7.58 //x2=14.55 //y2=2.265
cc_446 ( N_VDD_c_314_n N_noxref_7_c_1281_n ) capacitor c=0.0269509f //x=13.81 \
 //y=7.585 //x2=14.55 //y2=2.265
cc_447 ( N_VDD_c_315_n N_noxref_7_c_1281_n ) capacitor c=0.00151144f //x=16.03 \
 //y=7.585 //x2=14.55 //y2=2.265
cc_448 ( N_VDD_M26_noxref_s N_noxref_7_c_1281_n ) capacitor c=0.00942294f \
 //x=14.35 //y=5.2 //x2=14.55 //y2=2.265
cc_449 ( N_VDD_c_458_p N_noxref_7_M26_noxref_g ) capacitor c=0.00753931f \
 //x=15.28 //y=7.585 //x2=14.705 //y2=6.2
cc_450 ( N_VDD_c_314_n N_noxref_7_M26_noxref_g ) capacitor c=0.00895557f \
 //x=13.81 //y=7.585 //x2=14.705 //y2=6.2
cc_451 ( N_VDD_M26_noxref_s N_noxref_7_M26_noxref_g ) capacitor c=0.0528676f \
 //x=14.35 //y=5.2 //x2=14.705 //y2=6.2
cc_452 ( N_VDD_c_458_p N_noxref_7_M27_noxref_g ) capacitor c=0.00702238f \
 //x=15.28 //y=7.585 //x2=15.145 //y2=6.2
cc_453 ( N_VDD_M27_noxref_d N_noxref_7_M27_noxref_g ) capacitor c=0.0528676f \
 //x=15.22 //y=5.2 //x2=15.145 //y2=6.2
cc_454 ( N_VDD_c_315_n N_noxref_7_c_1320_n ) capacitor c=0.012136f //x=16.03 \
 //y=7.585 //x2=15.07 //y2=4.97
cc_455 ( N_VDD_c_314_n N_noxref_7_c_1321_n ) capacitor c=0.011132f //x=13.81 \
 //y=7.585 //x2=14.78 //y2=4.97
cc_456 ( N_VDD_M26_noxref_s N_noxref_7_c_1321_n ) capacitor c=0.0052728f \
 //x=14.35 //y=5.2 //x2=14.78 //y2=4.97
cc_457 ( N_VDD_c_317_p N_noxref_7_M22_noxref_d ) capacitor c=0.00285139f \
 //x=22.32 //y=7.58 //x2=11.565 //y2=5.2
cc_458 ( N_VDD_c_384_p N_noxref_7_M22_noxref_d ) capacitor c=0.0141209f \
 //x=12.065 //y=7.585 //x2=11.565 //y2=5.2
cc_459 ( N_VDD_c_314_n N_noxref_7_M22_noxref_d ) capacitor c=6.94454e-19 \
 //x=13.81 //y=7.585 //x2=11.565 //y2=5.2
cc_460 ( N_VDD_M23_noxref_d N_noxref_7_M22_noxref_d ) capacitor c=0.0664752f \
 //x=12.005 //y=5.2 //x2=11.565 //y2=5.2
cc_461 ( N_VDD_c_317_p N_noxref_7_M24_noxref_d ) capacitor c=0.00294258f \
 //x=22.32 //y=7.58 //x2=12.445 //y2=5.2
cc_462 ( N_VDD_c_435_p N_noxref_7_M24_noxref_d ) capacitor c=0.0138783f \
 //x=12.945 //y=7.585 //x2=12.445 //y2=5.2
cc_463 ( N_VDD_c_314_n N_noxref_7_M24_noxref_d ) capacitor c=0.0120541f \
 //x=13.81 //y=7.585 //x2=12.445 //y2=5.2
cc_464 ( N_VDD_M22_noxref_s N_noxref_7_M24_noxref_d ) capacitor c=0.00111971f \
 //x=11.135 //y=5.2 //x2=12.445 //y2=5.2
cc_465 ( N_VDD_M23_noxref_d N_noxref_7_M24_noxref_d ) capacitor c=0.0664752f \
 //x=12.005 //y=5.2 //x2=12.445 //y2=5.2
cc_466 ( N_VDD_M25_noxref_d N_noxref_7_M24_noxref_d ) capacitor c=0.0664752f \
 //x=12.885 //y=5.2 //x2=12.445 //y2=5.2
cc_467 ( N_VDD_M26_noxref_s N_noxref_7_M24_noxref_d ) capacitor c=5.1407e-19 \
 //x=14.35 //y=5.2 //x2=12.445 //y2=5.2
cc_468 ( N_VDD_c_317_p N_noxref_8_c_1410_n ) capacitor c=0.0313108f //x=22.32 \
 //y=7.58 //x2=17.025 //y2=3.88
cc_469 ( N_VDD_c_314_n N_noxref_8_c_1410_n ) capacitor c=0.0109526f //x=13.81 \
 //y=7.585 //x2=17.025 //y2=3.88
cc_470 ( N_VDD_c_315_n N_noxref_8_c_1410_n ) capacitor c=0.00290918f //x=16.03 \
 //y=7.585 //x2=17.025 //y2=3.88
cc_471 ( N_VDD_M25_noxref_d N_noxref_8_c_1410_n ) capacitor c=4.00443e-19 \
 //x=12.885 //y=5.2 //x2=17.025 //y2=3.88
cc_472 ( N_VDD_M26_noxref_s N_noxref_8_c_1410_n ) capacitor c=0.00141988f \
 //x=14.35 //y=5.2 //x2=17.025 //y2=3.88
cc_473 ( N_VDD_c_317_p N_noxref_8_c_1441_n ) capacitor c=0.00122938f //x=22.32 \
 //y=7.58 //x2=9.655 //y2=4.76
cc_474 ( N_VDD_c_351_p N_noxref_8_c_1441_n ) capacitor c=9.09621e-19 //x=9.73 \
 //y=7.585 //x2=9.655 //y2=4.76
cc_475 ( N_VDD_M21_noxref_d N_noxref_8_c_1441_n ) capacitor c=0.00609295f \
 //x=9.67 //y=5.2 //x2=9.655 //y2=4.76
cc_476 ( N_VDD_c_312_n N_noxref_8_c_1444_n ) capacitor c=0.017572f //x=8.26 \
 //y=7.585 //x2=9.46 //y2=4.76
cc_477 ( N_VDD_c_312_n N_noxref_8_c_1419_n ) capacitor c=4.16331e-19 //x=8.26 \
 //y=7.585 //x2=9.74 //y2=3.88
cc_478 ( N_VDD_c_313_n N_noxref_8_c_1419_n ) capacitor c=0.0221565f //x=10.48 \
 //y=7.585 //x2=9.74 //y2=3.88
cc_479 ( N_VDD_c_315_n N_noxref_8_c_1420_n ) capacitor c=0.00965534f //x=16.03 \
 //y=7.585 //x2=17.14 //y2=2.26
cc_480 ( N_VDD_c_317_p N_noxref_8_c_1448_n ) capacitor c=2.76902e-19 //x=22.32 \
 //y=7.58 //x2=16.985 //y2=4.885
cc_481 ( N_VDD_c_315_n N_noxref_8_c_1448_n ) capacitor c=0.00860173f //x=16.03 \
 //y=7.585 //x2=16.985 //y2=4.885
cc_482 ( N_VDD_M28_noxref_d N_noxref_8_c_1448_n ) capacitor c=3.42955e-19 \
 //x=17.115 //y=5.205 //x2=16.985 //y2=4.885
cc_483 ( N_VDD_c_492_p N_noxref_8_M28_noxref_g ) capacitor c=0.00683851f \
 //x=17.175 //y=7.585 //x2=17.04 //y2=6.205
cc_484 ( N_VDD_c_315_n N_noxref_8_M28_noxref_g ) capacitor c=0.00730892f \
 //x=16.03 //y=7.585 //x2=17.04 //y2=6.205
cc_485 ( N_VDD_M28_noxref_d N_noxref_8_M28_noxref_g ) capacitor c=0.0156786f \
 //x=17.115 //y=5.205 //x2=17.04 //y2=6.205
cc_486 ( N_VDD_c_495_p N_noxref_8_M29_noxref_g ) capacitor c=0.0068279f \
 //x=19.19 //y=7.585 //x2=17.48 //y2=6.205
cc_487 ( N_VDD_M28_noxref_d N_noxref_8_M29_noxref_g ) capacitor c=0.0183011f \
 //x=17.115 //y=5.205 //x2=17.48 //y2=6.205
cc_488 ( N_VDD_c_315_n N_noxref_8_c_1456_n ) capacitor c=0.00890932f //x=16.03 \
 //y=7.585 //x2=16.985 //y2=4.885
cc_489 ( N_VDD_c_317_p N_noxref_8_M20_noxref_d ) capacitor c=0.00285234f \
 //x=22.32 //y=7.58 //x2=9.23 //y2=5.2
cc_490 ( N_VDD_c_351_p N_noxref_8_M20_noxref_d ) capacitor c=0.0141568f \
 //x=9.73 //y=7.585 //x2=9.23 //y2=5.2
cc_491 ( N_VDD_c_313_n N_noxref_8_M20_noxref_d ) capacitor c=0.0204591f \
 //x=10.48 //y=7.585 //x2=9.23 //y2=5.2
cc_492 ( N_VDD_M20_noxref_s N_noxref_8_M20_noxref_d ) capacitor c=0.0843065f \
 //x=8.8 //y=5.2 //x2=9.23 //y2=5.2
cc_493 ( N_VDD_M21_noxref_d N_noxref_8_M20_noxref_d ) capacitor c=0.0832641f \
 //x=9.67 //y=5.2 //x2=9.23 //y2=5.2
cc_494 ( N_VDD_c_315_n Q ) capacitor c=0.00163766f //x=16.03 //y=7.585 \
 //x2=18.62 //y2=2.4
cc_495 ( N_VDD_c_316_n Q ) capacitor c=0.0456569f //x=19.36 //y=7.585 \
 //x2=18.62 //y2=2.4
cc_496 ( N_VDD_c_317_p N_Q_c_1612_n ) capacitor c=0.00162098f //x=22.32 \
 //y=7.58 //x2=18.535 //y2=5.39
cc_497 ( N_VDD_c_495_p N_Q_c_1612_n ) capacitor c=0.00139575f //x=19.19 \
 //y=7.585 //x2=18.535 //y2=5.39
cc_498 ( N_VDD_c_315_n N_Q_c_1614_n ) capacitor c=8.9933e-19 //x=16.03 \
 //y=7.585 //x2=18.225 //y2=5.39
cc_499 ( N_VDD_c_316_n N_Q_c_1592_n ) capacitor c=0.00965391f //x=19.36 \
 //y=7.585 //x2=20.47 //y2=2.26
cc_500 ( N_VDD_c_317_p N_Q_c_1616_n ) capacitor c=2.76902e-19 //x=22.32 \
 //y=7.58 //x2=20.315 //y2=4.885
cc_501 ( N_VDD_c_316_n N_Q_c_1616_n ) capacitor c=0.00860173f //x=19.36 \
 //y=7.585 //x2=20.315 //y2=4.885
cc_502 ( N_VDD_M32_noxref_d N_Q_c_1616_n ) capacitor c=3.42955e-19 //x=20.445 \
 //y=5.205 //x2=20.315 //y2=4.885
cc_503 ( N_VDD_c_512_p N_Q_M32_noxref_g ) capacitor c=0.00683851f //x=20.505 \
 //y=7.585 //x2=20.37 //y2=6.205
cc_504 ( N_VDD_c_316_n N_Q_M32_noxref_g ) capacitor c=0.00966601f //x=19.36 \
 //y=7.585 //x2=20.37 //y2=6.205
cc_505 ( N_VDD_M32_noxref_d N_Q_M32_noxref_g ) capacitor c=0.0156786f \
 //x=20.445 //y=5.205 //x2=20.37 //y2=6.205
cc_506 ( N_VDD_c_308_n N_Q_M33_noxref_g ) capacitor c=0.0068279f //x=22.32 \
 //y=7.58 //x2=20.81 //y2=6.205
cc_507 ( N_VDD_M32_noxref_d N_Q_M33_noxref_g ) capacitor c=0.0183011f \
 //x=20.445 //y=5.205 //x2=20.81 //y2=6.205
cc_508 ( N_VDD_c_316_n N_Q_c_1624_n ) capacitor c=0.00890932f //x=19.36 \
 //y=7.585 //x2=20.315 //y2=4.885
cc_509 ( N_VDD_c_316_n N_Q_M30_noxref_d ) capacitor c=0.00966019f //x=19.36 \
 //y=7.585 //x2=17.995 //y2=5.205
cc_510 ( N_VDD_M28_noxref_d N_Q_M30_noxref_d ) capacitor c=0.00561178f \
 //x=17.115 //y=5.205 //x2=17.995 //y2=5.205
cc_511 ( N_VDD_c_317_p N_noxref_10_c_1741_n ) capacitor c=0.039275f //x=22.32 \
 //y=7.58 //x2=21.095 //y2=4.25
cc_512 ( N_VDD_c_521_p N_noxref_10_c_1741_n ) capacitor c=0.00124324f \
 //x=15.86 //y=7.585 //x2=21.095 //y2=4.25
cc_513 ( N_VDD_c_492_p N_noxref_10_c_1741_n ) capacitor c=0.00213587f \
 //x=17.175 //y=7.585 //x2=21.095 //y2=4.25
cc_514 ( N_VDD_c_495_p N_noxref_10_c_1741_n ) capacitor c=0.00239586f \
 //x=19.19 //y=7.585 //x2=21.095 //y2=4.25
cc_515 ( N_VDD_c_512_p N_noxref_10_c_1741_n ) capacitor c=0.00213587f \
 //x=20.505 //y=7.585 //x2=21.095 //y2=4.25
cc_516 ( N_VDD_c_315_n N_noxref_10_c_1741_n ) capacitor c=0.0269493f //x=16.03 \
 //y=7.585 //x2=21.095 //y2=4.25
cc_517 ( N_VDD_c_316_n N_noxref_10_c_1741_n ) capacitor c=0.0269493f //x=19.36 \
 //y=7.585 //x2=21.095 //y2=4.25
cc_518 ( N_VDD_M27_noxref_d N_noxref_10_c_1741_n ) capacitor c=9.09749e-19 \
 //x=15.22 //y=5.2 //x2=21.095 //y2=4.25
cc_519 ( N_VDD_c_317_p N_noxref_10_c_1767_n ) capacitor c=0.00187427f \
 //x=22.32 //y=7.58 //x2=15.405 //y2=4.25
cc_520 ( N_VDD_c_315_n N_noxref_10_c_1767_n ) capacitor c=0.00104972f \
 //x=16.03 //y=7.585 //x2=15.405 //y2=4.25
cc_521 ( N_VDD_M27_noxref_d N_noxref_10_c_1767_n ) capacitor c=0.00130587f \
 //x=15.22 //y=5.2 //x2=15.405 //y2=4.25
cc_522 ( N_VDD_c_317_p N_noxref_10_c_1770_n ) capacitor c=0.0012368f //x=22.32 \
 //y=7.58 //x2=15.205 //y2=4.76
cc_523 ( N_VDD_c_458_p N_noxref_10_c_1770_n ) capacitor c=8.86824e-19 \
 //x=15.28 //y=7.585 //x2=15.205 //y2=4.76
cc_524 ( N_VDD_M27_noxref_d N_noxref_10_c_1770_n ) capacitor c=0.00572963f \
 //x=15.22 //y=5.2 //x2=15.205 //y2=4.76
cc_525 ( N_VDD_c_314_n N_noxref_10_c_1773_n ) capacitor c=0.017572f //x=13.81 \
 //y=7.585 //x2=15.01 //y2=4.76
cc_526 ( N_VDD_c_314_n N_noxref_10_c_1745_n ) capacitor c=5.33401e-19 \
 //x=13.81 //y=7.585 //x2=15.29 //y2=4.25
cc_527 ( N_VDD_c_315_n N_noxref_10_c_1745_n ) capacitor c=0.0225488f //x=16.03 \
 //y=7.585 //x2=15.29 //y2=4.25
cc_528 ( N_VDD_c_308_n N_noxref_10_c_1746_n ) capacitor c=6.69172e-19 \
 //x=22.32 //y=7.58 //x2=21.21 //y2=2.26
cc_529 ( N_VDD_c_316_n N_noxref_10_c_1746_n ) capacitor c=6.68284e-19 \
 //x=19.36 //y=7.585 //x2=21.21 //y2=2.26
cc_530 ( N_VDD_c_308_n N_noxref_10_M34_noxref_g ) capacitor c=0.00516984f \
 //x=22.32 //y=7.58 //x2=21.25 //y2=6.205
cc_531 ( N_VDD_c_308_n N_noxref_10_M35_noxref_g ) capacitor c=0.0322627f \
 //x=22.32 //y=7.58 //x2=21.69 //y2=6.205
cc_532 ( N_VDD_c_317_p N_noxref_10_M26_noxref_d ) capacitor c=0.00294329f \
 //x=22.32 //y=7.58 //x2=14.78 //y2=5.2
cc_533 ( N_VDD_c_458_p N_noxref_10_M26_noxref_d ) capacitor c=0.0139426f \
 //x=15.28 //y=7.585 //x2=14.78 //y2=5.2
cc_534 ( N_VDD_c_315_n N_noxref_10_M26_noxref_d ) capacitor c=0.0204646f \
 //x=16.03 //y=7.585 //x2=14.78 //y2=5.2
cc_535 ( N_VDD_M26_noxref_s N_noxref_10_M26_noxref_d ) capacitor c=0.0843065f \
 //x=14.35 //y=5.2 //x2=14.78 //y2=5.2
cc_536 ( N_VDD_M27_noxref_d N_noxref_10_M26_noxref_d ) capacitor c=0.0832641f \
 //x=15.22 //y=5.2 //x2=14.78 //y2=5.2
cc_537 ( N_VDD_c_317_p N_noxref_11_c_1903_n ) capacitor c=0.0161517f //x=22.32 \
 //y=7.58 //x2=21.835 //y2=3.88
cc_538 ( N_VDD_c_315_n N_noxref_11_c_1906_n ) capacitor c=6.93509e-19 \
 //x=16.03 //y=7.585 //x2=17.88 //y2=2.26
cc_539 ( N_VDD_c_316_n N_noxref_11_c_1906_n ) capacitor c=5.88692e-19 \
 //x=19.36 //y=7.585 //x2=17.88 //y2=2.26
cc_540 ( N_VDD_c_317_p N_noxref_11_c_1933_n ) capacitor c=0.00162432f \
 //x=22.32 //y=7.58 //x2=21.865 //y2=5.39
cc_541 ( N_VDD_c_308_n N_noxref_11_c_1933_n ) capacitor c=0.00137054f \
 //x=22.32 //y=7.58 //x2=21.865 //y2=5.39
cc_542 ( N_VDD_c_316_n N_noxref_11_c_1935_n ) capacitor c=8.9933e-19 //x=19.36 \
 //y=7.585 //x2=21.555 //y2=5.39
cc_543 ( N_VDD_c_308_n N_noxref_11_c_1916_n ) capacitor c=0.0467856f //x=22.32 \
 //y=7.58 //x2=21.95 //y2=3.88
cc_544 ( N_VDD_c_316_n N_noxref_11_c_1916_n ) capacitor c=0.00155409f \
 //x=19.36 //y=7.585 //x2=21.95 //y2=3.88
cc_545 ( N_VDD_c_495_p N_noxref_11_M30_noxref_g ) capacitor c=0.00516984f \
 //x=19.19 //y=7.585 //x2=17.92 //y2=6.205
cc_546 ( N_VDD_c_495_p N_noxref_11_M31_noxref_g ) capacitor c=0.00515938f \
 //x=19.19 //y=7.585 //x2=18.36 //y2=6.205
cc_547 ( N_VDD_c_316_n N_noxref_11_M31_noxref_g ) capacitor c=0.010456f \
 //x=19.36 //y=7.585 //x2=18.36 //y2=6.205
cc_548 ( N_VDD_c_308_n N_noxref_11_M34_noxref_d ) capacitor c=0.00991513f \
 //x=22.32 //y=7.58 //x2=21.325 //y2=5.205
cc_549 ( N_VDD_M32_noxref_d N_noxref_11_M34_noxref_d ) capacitor c=0.00561178f \
 //x=20.445 //y=5.205 //x2=21.325 //y2=5.205
cc_550 ( N_VDD_c_317_p N_GATE_N_c_2065_n ) capacitor c=0.00177734f //x=22.32 \
 //y=7.58 //x2=1.23 //y2=2.265
cc_551 ( N_VDD_c_309_n N_GATE_N_c_2065_n ) capacitor c=0.0274978f //x=1.23 \
 //y=7.58 //x2=1.23 //y2=2.265
cc_552 ( N_VDD_c_310_n N_GATE_N_c_2065_n ) capacitor c=0.00152624f //x=2.71 \
 //y=7.585 //x2=1.23 //y2=2.265
cc_553 ( N_VDD_M12_noxref_s N_GATE_N_c_2065_n ) capacitor c=0.0095914f \
 //x=1.03 //y=5.2 //x2=1.23 //y2=2.265
cc_554 ( N_VDD_c_376_p N_GATE_N_M12_noxref_g ) capacitor c=0.00753931f \
 //x=1.96 //y=7.585 //x2=1.385 //y2=6.2
cc_555 ( N_VDD_c_309_n N_GATE_N_M12_noxref_g ) capacitor c=0.0241676f //x=1.23 \
 //y=7.58 //x2=1.385 //y2=6.2
cc_556 ( N_VDD_M12_noxref_s N_GATE_N_M12_noxref_g ) capacitor c=0.0528676f \
 //x=1.03 //y=5.2 //x2=1.385 //y2=6.2
cc_557 ( N_VDD_c_376_p N_GATE_N_M13_noxref_g ) capacitor c=0.00702238f \
 //x=1.96 //y=7.585 //x2=1.825 //y2=6.2
cc_558 ( N_VDD_M13_noxref_d N_GATE_N_M13_noxref_g ) capacitor c=0.0528676f \
 //x=1.9 //y=5.2 //x2=1.825 //y2=6.2
cc_559 ( N_VDD_c_310_n N_GATE_N_c_2089_n ) capacitor c=0.0099588f //x=2.71 \
 //y=7.585 //x2=1.75 //y2=4.97
cc_560 ( N_VDD_c_309_n N_GATE_N_c_2090_n ) capacitor c=0.011132f //x=1.23 \
 //y=7.58 //x2=1.46 //y2=4.97
cc_561 ( N_VDD_M12_noxref_s N_GATE_N_c_2090_n ) capacitor c=0.00519692f \
 //x=1.03 //y=5.2 //x2=1.46 //y2=4.97
cc_562 ( N_VDD_c_317_p N_noxref_15_c_2222_n ) capacitor c=0.00453074f \
 //x=22.32 //y=7.58 //x2=17.615 //y2=5.39
cc_563 ( N_VDD_c_492_p N_noxref_15_c_2222_n ) capacitor c=4.53029e-19 \
 //x=17.175 //y=7.585 //x2=17.615 //y2=5.39
cc_564 ( N_VDD_c_495_p N_noxref_15_c_2222_n ) capacitor c=4.53029e-19 \
 //x=19.19 //y=7.585 //x2=17.615 //y2=5.39
cc_565 ( N_VDD_c_316_n N_noxref_15_c_2222_n ) capacitor c=0.00289291f \
 //x=19.36 //y=7.585 //x2=17.615 //y2=5.39
cc_566 ( N_VDD_M28_noxref_d N_noxref_15_c_2222_n ) capacitor c=0.0125692f \
 //x=17.115 //y=5.205 //x2=17.615 //y2=5.39
cc_567 ( N_VDD_c_315_n N_noxref_15_c_2227_n ) capacitor c=0.0669114f //x=16.03 \
 //y=7.585 //x2=16.905 //y2=5.39
cc_568 ( N_VDD_M27_noxref_d N_noxref_15_c_2227_n ) capacitor c=0.00289186f \
 //x=15.22 //y=5.2 //x2=16.905 //y2=5.39
cc_569 ( N_VDD_c_308_n N_noxref_15_c_2229_n ) capacitor c=0.00242923f \
 //x=22.32 //y=7.58 //x2=18.495 //y2=7.09
cc_570 ( N_VDD_c_317_p N_noxref_15_c_2230_n ) capacitor c=0.0170507f //x=22.32 \
 //y=7.58 //x2=17.785 //y2=7.09
cc_571 ( N_VDD_c_495_p N_noxref_15_c_2230_n ) capacitor c=0.0617392f //x=19.19 \
 //y=7.585 //x2=17.785 //y2=7.09
cc_572 ( N_VDD_c_317_p N_noxref_15_M28_noxref_s ) capacitor c=0.00287776f \
 //x=22.32 //y=7.58 //x2=16.685 //y2=5.205
cc_573 ( N_VDD_c_492_p N_noxref_15_M28_noxref_s ) capacitor c=0.0144012f \
 //x=17.175 //y=7.585 //x2=16.685 //y2=5.205
cc_574 ( N_VDD_M28_noxref_d N_noxref_15_M28_noxref_s ) capacitor c=0.0667021f \
 //x=17.115 //y=5.205 //x2=16.685 //y2=5.205
cc_575 ( N_VDD_c_315_n N_noxref_15_M29_noxref_d ) capacitor c=8.88629e-19 \
 //x=16.03 //y=7.585 //x2=17.555 //y2=5.205
cc_576 ( N_VDD_M28_noxref_d N_noxref_15_M29_noxref_d ) capacitor c=0.0659925f \
 //x=17.115 //y=5.205 //x2=17.555 //y2=5.205
cc_577 ( N_VDD_c_316_n N_noxref_15_M31_noxref_d ) capacitor c=0.0520312f \
 //x=19.36 //y=7.585 //x2=18.435 //y2=5.205
cc_578 ( N_VDD_M28_noxref_d N_noxref_15_M31_noxref_d ) capacitor c=0.00107819f \
 //x=17.115 //y=5.205 //x2=18.435 //y2=5.205
cc_579 ( N_VDD_c_317_p N_noxref_16_c_2265_n ) capacitor c=0.00453074f \
 //x=22.32 //y=7.58 //x2=20.945 //y2=5.39
cc_580 ( N_VDD_c_512_p N_noxref_16_c_2265_n ) capacitor c=4.53029e-19 \
 //x=20.505 //y=7.585 //x2=20.945 //y2=5.39
cc_581 ( N_VDD_c_308_n N_noxref_16_c_2265_n ) capacitor c=0.00334594f \
 //x=22.32 //y=7.58 //x2=20.945 //y2=5.39
cc_582 ( N_VDD_M32_noxref_d N_noxref_16_c_2265_n ) capacitor c=0.0125692f \
 //x=20.445 //y=5.205 //x2=20.945 //y2=5.39
cc_583 ( N_VDD_c_316_n N_noxref_16_c_2269_n ) capacitor c=0.0669114f //x=19.36 \
 //y=7.585 //x2=20.235 //y2=5.39
cc_584 ( N_VDD_c_308_n N_noxref_16_c_2270_n ) capacitor c=0.00242923f \
 //x=22.32 //y=7.58 //x2=21.825 //y2=7.09
cc_585 ( N_VDD_c_317_p N_noxref_16_c_2271_n ) capacitor c=0.0173902f //x=22.32 \
 //y=7.58 //x2=21.115 //y2=7.09
cc_586 ( N_VDD_c_308_n N_noxref_16_c_2271_n ) capacitor c=0.0593166f //x=22.32 \
 //y=7.58 //x2=21.115 //y2=7.09
cc_587 ( N_VDD_c_317_p N_noxref_16_M32_noxref_s ) capacitor c=0.00287776f \
 //x=22.32 //y=7.58 //x2=20.015 //y2=5.205
cc_588 ( N_VDD_c_512_p N_noxref_16_M32_noxref_s ) capacitor c=0.0144012f \
 //x=20.505 //y=7.585 //x2=20.015 //y2=5.205
cc_589 ( N_VDD_M32_noxref_d N_noxref_16_M32_noxref_s ) capacitor c=0.0667021f \
 //x=20.445 //y=5.205 //x2=20.015 //y2=5.205
cc_590 ( N_VDD_c_316_n N_noxref_16_M33_noxref_d ) capacitor c=8.88629e-19 \
 //x=19.36 //y=7.585 //x2=20.885 //y2=5.205
cc_591 ( N_VDD_M32_noxref_d N_noxref_16_M33_noxref_d ) capacitor c=0.0659925f \
 //x=20.445 //y=5.205 //x2=20.885 //y2=5.205
cc_592 ( N_VDD_c_308_n N_noxref_16_M35_noxref_d ) capacitor c=0.0528345f \
 //x=22.32 //y=7.58 //x2=21.765 //y2=5.205
cc_593 ( N_VDD_M32_noxref_d N_noxref_16_M35_noxref_d ) capacitor c=0.00107819f \
 //x=20.445 //y=5.205 //x2=21.765 //y2=5.205
cc_594 ( N_noxref_3_M17_noxref_g N_noxref_4_c_742_n ) capacitor c=0.017965f \
 //x=6.38 //y=6.2 //x2=6.955 //y2=5.38
cc_595 ( N_noxref_3_c_607_n N_noxref_4_c_746_n ) capacitor c=0.00530485f \
 //x=6.04 //y=2.26 //x2=6.245 //y2=5.38
cc_596 ( N_noxref_3_M16_noxref_g N_noxref_4_c_746_n ) capacitor c=0.0177326f \
 //x=5.94 //y=6.2 //x2=6.245 //y2=5.38
cc_597 ( N_noxref_3_c_635_n N_noxref_4_c_746_n ) capacitor c=0.00582246f \
 //x=6.04 //y=4.88 //x2=6.245 //y2=5.38
cc_598 ( N_noxref_3_c_607_n N_noxref_4_c_722_n ) capacitor c=0.00389301f \
 //x=6.04 //y=2.26 //x2=7.52 //y2=3.51
cc_599 ( N_noxref_3_M17_noxref_g N_noxref_4_M16_noxref_d ) capacitor \
 c=0.0173476f //x=6.38 //y=6.2 //x2=6.015 //y2=5.2
cc_600 ( N_noxref_3_c_647_p N_noxref_5_c_854_n ) capacitor c=0.0865136f \
 //x=5.925 //y=3.88 //x2=6.665 //y2=3.14
cc_601 ( N_noxref_3_c_648_p N_noxref_5_c_854_n ) capacitor c=0.0132252f \
 //x=4.305 //y=3.88 //x2=6.665 //y2=3.14
cc_602 ( N_noxref_3_c_649_p N_noxref_5_c_854_n ) capacitor c=0.00763858f \
 //x=3.905 //y=2.26 //x2=6.665 //y2=3.14
cc_603 ( N_noxref_3_c_606_n N_noxref_5_c_854_n ) capacitor c=0.02605f //x=4.19 \
 //y=3.88 //x2=6.665 //y2=3.14
cc_604 ( N_noxref_3_c_607_n N_noxref_5_c_854_n ) capacitor c=0.0258542f \
 //x=6.04 //y=2.26 //x2=6.665 //y2=3.14
cc_605 ( N_noxref_3_c_611_n N_noxref_5_c_854_n ) capacitor c=0.00425556f \
 //x=5.845 //y=2.095 //x2=6.665 //y2=3.14
cc_606 ( N_noxref_3_c_607_n N_noxref_5_c_875_n ) capacitor c=0.00179385f \
 //x=6.04 //y=2.26 //x2=6.895 //y2=3.14
cc_607 ( N_noxref_3_c_606_n N_noxref_5_c_879_n ) capacitor c=0.0010728f \
 //x=4.19 //y=3.88 //x2=1.97 //y2=3.14
cc_608 ( N_noxref_3_c_607_n N_noxref_5_c_936_n ) capacitor c=0.00400249f \
 //x=6.04 //y=2.26 //x2=6.78 //y2=4.715
cc_609 ( N_noxref_3_c_635_n N_noxref_5_c_936_n ) capacitor c=0.00417994f \
 //x=6.04 //y=4.88 //x2=6.78 //y2=4.715
cc_610 ( N_noxref_3_c_647_p N_noxref_5_c_880_n ) capacitor c=0.00490755f \
 //x=5.925 //y=3.88 //x2=6.78 //y2=2.26
cc_611 ( N_noxref_3_c_606_n N_noxref_5_c_880_n ) capacitor c=0.00112757f \
 //x=4.19 //y=3.88 //x2=6.78 //y2=2.26
cc_612 ( N_noxref_3_c_607_n N_noxref_5_c_880_n ) capacitor c=0.0807197f \
 //x=6.04 //y=2.26 //x2=6.78 //y2=2.26
cc_613 ( N_noxref_3_c_611_n N_noxref_5_c_880_n ) capacitor c=0.00308814f \
 //x=5.845 //y=2.095 //x2=6.78 //y2=2.26
cc_614 ( N_noxref_3_M16_noxref_g N_noxref_5_M18_noxref_g ) capacitor \
 c=0.0104611f //x=5.94 //y=6.2 //x2=6.82 //y2=6.2
cc_615 ( N_noxref_3_M17_noxref_g N_noxref_5_M18_noxref_g ) capacitor \
 c=0.106811f //x=6.38 //y=6.2 //x2=6.82 //y2=6.2
cc_616 ( N_noxref_3_M17_noxref_g N_noxref_5_M19_noxref_g ) capacitor \
 c=0.0100341f //x=6.38 //y=6.2 //x2=7.26 //y2=6.2
cc_617 ( N_noxref_3_c_608_n N_noxref_5_c_945_n ) capacitor c=4.86506e-19 \
 //x=5.845 //y=1.045 //x2=6.815 //y2=1.085
cc_618 ( N_noxref_3_c_610_n N_noxref_5_c_945_n ) capacitor c=0.00152104f \
 //x=5.845 //y=1.39 //x2=6.815 //y2=1.085
cc_619 ( N_noxref_3_c_614_n N_noxref_5_c_945_n ) capacitor c=0.0151475f \
 //x=6.375 //y=1.045 //x2=6.815 //y2=1.085
cc_620 ( N_noxref_3_c_667_p N_noxref_5_c_948_n ) capacitor c=0.00109982f \
 //x=5.845 //y=1.7 //x2=6.815 //y2=1.43
cc_621 ( N_noxref_3_c_616_n N_noxref_5_c_948_n ) capacitor c=0.0111064f \
 //x=6.375 //y=1.39 //x2=6.815 //y2=1.43
cc_622 ( N_noxref_3_c_667_p N_noxref_5_c_950_n ) capacitor c=9.57794e-19 \
 //x=5.845 //y=1.7 //x2=6.815 //y2=1.74
cc_623 ( N_noxref_3_c_611_n N_noxref_5_c_950_n ) capacitor c=0.00662747f \
 //x=5.845 //y=2.095 //x2=6.815 //y2=1.74
cc_624 ( N_noxref_3_c_616_n N_noxref_5_c_950_n ) capacitor c=0.00862358f \
 //x=6.375 //y=1.39 //x2=6.815 //y2=1.74
cc_625 ( N_noxref_3_c_614_n N_noxref_5_c_953_n ) capacitor c=0.00124821f \
 //x=6.375 //y=1.045 //x2=7.345 //y2=1.085
cc_626 ( N_noxref_3_c_616_n N_noxref_5_c_954_n ) capacitor c=0.00200715f \
 //x=6.375 //y=1.39 //x2=7.345 //y2=1.43
cc_627 ( N_noxref_3_c_607_n N_noxref_5_c_955_n ) capacitor c=0.00307062f \
 //x=6.04 //y=2.26 //x2=6.78 //y2=2.26
cc_628 ( N_noxref_3_c_611_n N_noxref_5_c_955_n ) capacitor c=0.0179092f \
 //x=5.845 //y=2.095 //x2=6.78 //y2=2.26
cc_629 ( N_noxref_3_c_607_n N_noxref_5_c_957_n ) capacitor c=0.00344981f \
 //x=6.04 //y=2.26 //x2=6.81 //y2=4.88
cc_630 ( N_noxref_3_c_635_n N_noxref_5_c_957_n ) capacitor c=0.0293367f \
 //x=6.04 //y=4.88 //x2=6.81 //y2=4.88
cc_631 ( N_noxref_3_M1_noxref_d N_noxref_5_M0_noxref_d ) capacitor \
 c=2.55525e-19 //x=3.635 //y=1.09 //x2=1.415 //y2=1.09
cc_632 ( N_noxref_3_M14_noxref_d N_noxref_5_M12_noxref_d ) capacitor \
 c=7.38512e-19 //x=3.68 //y=5.2 //x2=1.46 //y2=5.2
cc_633 ( N_noxref_3_c_647_p N_D_c_1109_n ) capacitor c=0.175715f //x=5.925 \
 //y=3.88 //x2=12.215 //y2=4.25
cc_634 ( N_noxref_3_c_648_p N_D_c_1109_n ) capacitor c=0.0289632f //x=4.305 \
 //y=3.88 //x2=12.215 //y2=4.25
cc_635 ( N_noxref_3_c_625_n N_D_c_1109_n ) capacitor c=0.0123666f //x=3.91 \
 //y=4.76 //x2=12.215 //y2=4.25
cc_636 ( N_noxref_3_c_606_n N_D_c_1109_n ) capacitor c=0.0237647f //x=4.19 \
 //y=3.88 //x2=12.215 //y2=4.25
cc_637 ( N_noxref_3_c_607_n N_D_c_1109_n ) capacitor c=0.0242341f //x=6.04 \
 //y=2.26 //x2=12.215 //y2=4.25
cc_638 ( N_noxref_3_c_635_n N_D_c_1109_n ) capacitor c=0.00703556f //x=6.04 \
 //y=4.88 //x2=12.215 //y2=4.25
cc_639 ( N_noxref_3_c_606_n N_D_c_1129_n ) capacitor c=0.00179385f //x=4.19 \
 //y=3.88 //x2=3.565 //y2=4.25
cc_640 ( N_noxref_3_c_648_p N_D_c_1092_n ) capacitor c=0.00720056f //x=4.305 \
 //y=3.88 //x2=3.45 //y2=2.265
cc_641 ( N_noxref_3_c_625_n N_D_c_1092_n ) capacitor c=0.0253118f //x=3.91 \
 //y=4.76 //x2=3.45 //y2=2.265
cc_642 ( N_noxref_3_c_606_n N_D_c_1092_n ) capacitor c=0.0652069f //x=4.19 \
 //y=3.88 //x2=3.45 //y2=2.265
cc_643 ( N_noxref_3_c_607_n N_D_c_1092_n ) capacitor c=0.00105083f //x=6.04 \
 //y=2.26 //x2=3.45 //y2=2.265
cc_644 ( N_noxref_3_M1_noxref_d N_D_c_1092_n ) capacitor c=0.0177062f \
 //x=3.635 //y=1.09 //x2=3.45 //y2=2.265
cc_645 ( N_noxref_3_M14_noxref_d N_D_M14_noxref_g ) capacitor c=0.0219309f \
 //x=3.68 //y=5.2 //x2=3.605 //y2=6.2
cc_646 ( N_noxref_3_M14_noxref_d N_D_M15_noxref_g ) capacitor c=0.021902f \
 //x=3.68 //y=5.2 //x2=4.045 //y2=6.2
cc_647 ( N_noxref_3_M1_noxref_d N_D_c_1099_n ) capacitor c=0.00218556f \
 //x=3.635 //y=1.09 //x2=3.56 //y2=1.09
cc_648 ( N_noxref_3_M1_noxref_d N_D_c_1166_n ) capacitor c=0.00347355f \
 //x=3.635 //y=1.09 //x2=3.56 //y2=1.435
cc_649 ( N_noxref_3_M1_noxref_d N_D_c_1167_n ) capacitor c=0.00742431f \
 //x=3.635 //y=1.09 //x2=3.56 //y2=1.745
cc_650 ( N_noxref_3_M1_noxref_d N_D_c_1101_n ) capacitor c=0.00957707f \
 //x=3.635 //y=1.09 //x2=3.56 //y2=2.1
cc_651 ( N_noxref_3_c_622_n N_D_c_1148_n ) capacitor c=0.0099173f //x=4.105 \
 //y=4.76 //x2=3.97 //y2=4.97
cc_652 ( N_noxref_3_M14_noxref_d N_D_c_1148_n ) capacitor c=0.0146106f \
 //x=3.68 //y=5.2 //x2=3.97 //y2=4.97
cc_653 ( N_noxref_3_c_625_n N_D_c_1149_n ) capacitor c=0.00962086f //x=3.91 \
 //y=4.76 //x2=3.68 //y2=4.97
cc_654 ( N_noxref_3_M14_noxref_d N_D_c_1149_n ) capacitor c=0.00307344f \
 //x=3.68 //y=5.2 //x2=3.68 //y2=4.97
cc_655 ( N_noxref_3_M1_noxref_d N_D_c_1102_n ) capacitor c=0.00220879f \
 //x=3.635 //y=1.09 //x2=3.935 //y2=0.935
cc_656 ( N_noxref_3_c_603_n N_D_c_1174_n ) capacitor c=0.0023507f //x=4.105 \
 //y=2.26 //x2=3.935 //y2=1.59
cc_657 ( N_noxref_3_M1_noxref_d N_D_c_1174_n ) capacitor c=0.0138447f \
 //x=3.635 //y=1.09 //x2=3.935 //y2=1.59
cc_658 ( N_noxref_3_M1_noxref_d N_D_c_1103_n ) capacitor c=0.00218624f \
 //x=3.635 //y=1.09 //x2=4.09 //y2=1.09
cc_659 ( N_noxref_3_M1_noxref_d N_D_c_1105_n ) capacitor c=0.00601286f \
 //x=3.635 //y=1.09 //x2=4.09 //y2=1.435
cc_660 ( N_noxref_3_c_649_p N_D_c_1106_n ) capacitor c=0.0167852f //x=3.905 \
 //y=2.26 //x2=3.45 //y2=2.265
cc_661 ( N_noxref_3_c_606_n N_D_c_1106_n ) capacitor c=8.49451e-19 //x=4.19 \
 //y=3.88 //x2=3.45 //y2=2.265
cc_662 ( N_noxref_3_c_647_p N_noxref_8_c_1462_n ) capacitor c=0.00396702f \
 //x=5.925 //y=3.88 //x2=9.855 //y2=3.88
cc_663 ( N_noxref_3_c_611_n N_noxref_13_c_2114_n ) capacitor c=0.0034165f \
 //x=5.845 //y=2.095 //x2=5.625 //y2=1.675
cc_664 ( N_noxref_3_c_607_n N_noxref_13_c_2115_n ) capacitor c=0.0115894f \
 //x=6.04 //y=2.26 //x2=6.51 //y2=1.76
cc_665 ( N_noxref_3_c_667_p N_noxref_13_c_2115_n ) capacitor c=0.00703567f \
 //x=5.845 //y=1.7 //x2=6.51 //y2=1.76
cc_666 ( N_noxref_3_c_611_n N_noxref_13_c_2115_n ) capacitor c=0.01939f \
 //x=5.845 //y=2.095 //x2=6.51 //y2=1.76
cc_667 ( N_noxref_3_c_613_n N_noxref_13_c_2115_n ) capacitor c=0.00780629f \
 //x=6.22 //y=1.545 //x2=6.51 //y2=1.76
cc_668 ( N_noxref_3_c_616_n N_noxref_13_c_2115_n ) capacitor c=0.00339872f \
 //x=6.375 //y=1.39 //x2=6.51 //y2=1.76
cc_669 ( N_noxref_3_c_611_n N_noxref_13_c_2122_n ) capacitor c=6.71402e-19 \
 //x=5.845 //y=2.095 //x2=6.595 //y2=1.675
cc_670 ( N_noxref_3_c_608_n N_noxref_13_M2_noxref_s ) capacitor c=0.0326577f \
 //x=5.845 //y=1.045 //x2=5.49 //y2=0.545
cc_671 ( N_noxref_3_c_667_p N_noxref_13_M2_noxref_s ) capacitor c=3.48408e-19 \
 //x=5.845 //y=1.7 //x2=5.49 //y2=0.545
cc_672 ( N_noxref_3_c_614_n N_noxref_13_M2_noxref_s ) capacitor c=0.0120759f \
 //x=6.375 //y=1.045 //x2=5.49 //y2=0.545
cc_673 ( N_noxref_4_c_782_p N_noxref_5_c_866_n ) capacitor c=0.140643f \
 //x=8.885 //y=3.51 //x2=11.475 //y2=3.14
cc_674 ( N_noxref_4_c_783_p N_noxref_5_c_866_n ) capacitor c=0.0292689f \
 //x=7.635 //y=3.51 //x2=11.475 //y2=3.14
cc_675 ( N_noxref_4_c_784_p N_noxref_5_c_866_n ) capacitor c=0.00745069f \
 //x=7.165 //y=1.835 //x2=11.475 //y2=3.14
cc_676 ( N_noxref_4_c_722_n N_noxref_5_c_866_n ) capacitor c=0.0254565f \
 //x=7.52 //y=3.51 //x2=11.475 //y2=3.14
cc_677 ( N_noxref_4_c_723_n N_noxref_5_c_866_n ) capacitor c=0.0247839f //x=9 \
 //y=2.265 //x2=11.475 //y2=3.14
cc_678 ( N_noxref_4_c_735_n N_noxref_5_c_866_n ) capacitor c=0.00335064f //x=9 \
 //y=2.265 //x2=11.475 //y2=3.14
cc_679 ( N_noxref_4_c_722_n N_noxref_5_c_875_n ) capacitor c=0.00179385f \
 //x=7.52 //y=3.51 //x2=6.895 //y2=3.14
cc_680 ( N_noxref_4_c_742_n N_noxref_5_c_936_n ) capacitor c=0.0130467f \
 //x=6.955 //y=5.38 //x2=6.78 //y2=4.715
cc_681 ( N_noxref_4_c_722_n N_noxref_5_c_936_n ) capacitor c=0.0101204f \
 //x=7.52 //y=3.51 //x2=6.78 //y2=4.715
cc_682 ( N_noxref_4_c_783_p N_noxref_5_c_880_n ) capacitor c=0.00717888f \
 //x=7.635 //y=3.51 //x2=6.78 //y2=2.26
cc_683 ( N_noxref_4_c_722_n N_noxref_5_c_880_n ) capacitor c=0.0753231f \
 //x=7.52 //y=3.51 //x2=6.78 //y2=2.26
cc_684 ( N_noxref_4_c_723_n N_noxref_5_c_880_n ) capacitor c=0.00146756f //x=9 \
 //y=2.265 //x2=6.78 //y2=2.26
cc_685 ( N_noxref_4_c_723_n N_noxref_5_c_882_n ) capacitor c=0.00110316f //x=9 \
 //y=2.265 //x2=11.59 //y2=2.26
cc_686 ( N_noxref_4_c_742_n N_noxref_5_M18_noxref_g ) capacitor c=0.0166421f \
 //x=6.955 //y=5.38 //x2=6.82 //y2=6.2
cc_687 ( N_noxref_4_M18_noxref_d N_noxref_5_M18_noxref_g ) capacitor \
 c=0.0173476f //x=6.895 //y=5.2 //x2=6.82 //y2=6.2
cc_688 ( N_noxref_4_c_748_n N_noxref_5_M19_noxref_g ) capacitor c=0.0199348f \
 //x=7.435 //y=5.38 //x2=7.26 //y2=6.2
cc_689 ( N_noxref_4_M18_noxref_d N_noxref_5_M19_noxref_g ) capacitor \
 c=0.0179769f //x=6.895 //y=5.2 //x2=7.26 //y2=6.2
cc_690 ( N_noxref_4_M3_noxref_d N_noxref_5_c_945_n ) capacitor c=0.00217566f \
 //x=6.89 //y=1.085 //x2=6.815 //y2=1.085
cc_691 ( N_noxref_4_M3_noxref_d N_noxref_5_c_948_n ) capacitor c=0.0034598f \
 //x=6.89 //y=1.085 //x2=6.815 //y2=1.43
cc_692 ( N_noxref_4_M3_noxref_d N_noxref_5_c_950_n ) capacitor c=0.0065582f \
 //x=6.89 //y=1.085 //x2=6.815 //y2=1.74
cc_693 ( N_noxref_4_c_722_n N_noxref_5_c_981_n ) capacitor c=0.0142673f \
 //x=7.52 //y=3.51 //x2=7.185 //y2=4.97
cc_694 ( N_noxref_4_c_803_p N_noxref_5_c_981_n ) capacitor c=0.00408717f \
 //x=7.04 //y=5.38 //x2=7.185 //y2=4.97
cc_695 ( N_noxref_4_M3_noxref_d N_noxref_5_c_983_n ) capacitor c=0.00241102f \
 //x=6.89 //y=1.085 //x2=7.19 //y2=0.93
cc_696 ( N_noxref_4_c_720_n N_noxref_5_c_984_n ) capacitor c=0.00359704f \
 //x=7.435 //y=1.835 //x2=7.19 //y2=1.585
cc_697 ( N_noxref_4_M3_noxref_d N_noxref_5_c_984_n ) capacitor c=0.0138845f \
 //x=6.89 //y=1.085 //x2=7.19 //y2=1.585
cc_698 ( N_noxref_4_M3_noxref_d N_noxref_5_c_953_n ) capacitor c=0.00132245f \
 //x=6.89 //y=1.085 //x2=7.345 //y2=1.085
cc_699 ( N_noxref_4_c_720_n N_noxref_5_c_954_n ) capacitor c=0.00457401f \
 //x=7.435 //y=1.835 //x2=7.345 //y2=1.43
cc_700 ( N_noxref_4_M3_noxref_d N_noxref_5_c_954_n ) capacitor c=0.00566463f \
 //x=6.89 //y=1.085 //x2=7.345 //y2=1.43
cc_701 ( N_noxref_4_c_722_n N_noxref_5_c_955_n ) capacitor c=0.00877984f \
 //x=7.52 //y=3.51 //x2=6.78 //y2=2.26
cc_702 ( N_noxref_4_c_722_n N_noxref_5_c_990_n ) capacitor c=0.00306024f \
 //x=7.52 //y=3.51 //x2=6.78 //y2=2.095
cc_703 ( N_noxref_4_M3_noxref_d N_noxref_5_c_990_n ) capacitor c=0.00660593f \
 //x=6.89 //y=1.085 //x2=6.78 //y2=2.095
cc_704 ( N_noxref_4_c_742_n N_noxref_5_c_957_n ) capacitor c=0.00346635f \
 //x=6.955 //y=5.38 //x2=6.81 //y2=4.88
cc_705 ( N_noxref_4_c_722_n N_noxref_5_c_957_n ) capacitor c=0.00533692f \
 //x=7.52 //y=3.51 //x2=6.81 //y2=4.88
cc_706 ( N_noxref_4_c_782_p N_D_c_1109_n ) capacitor c=0.0717956f //x=8.885 \
 //y=3.51 //x2=12.215 //y2=4.25
cc_707 ( N_noxref_4_c_783_p N_D_c_1109_n ) capacitor c=0.0134762f //x=7.635 \
 //y=3.51 //x2=12.215 //y2=4.25
cc_708 ( N_noxref_4_c_742_n N_D_c_1109_n ) capacitor c=0.0140425f //x=6.955 \
 //y=5.38 //x2=12.215 //y2=4.25
cc_709 ( N_noxref_4_c_746_n N_D_c_1109_n ) capacitor c=0.013796f //x=6.245 \
 //y=5.38 //x2=12.215 //y2=4.25
cc_710 ( N_noxref_4_c_722_n N_D_c_1109_n ) capacitor c=0.0256796f //x=7.52 \
 //y=3.51 //x2=12.215 //y2=4.25
cc_711 ( N_noxref_4_c_723_n N_D_c_1109_n ) capacitor c=0.0245751f //x=9 \
 //y=2.265 //x2=12.215 //y2=4.25
cc_712 ( N_noxref_4_c_763_n N_D_c_1109_n ) capacitor c=0.00520686f //x=9.23 \
 //y=4.97 //x2=12.215 //y2=4.25
cc_713 ( N_noxref_4_c_782_p N_noxref_7_c_1277_n ) capacitor c=0.00359266f \
 //x=8.885 //y=3.51 //x2=13.185 //y2=3.51
cc_714 ( N_noxref_4_c_723_n N_noxref_8_c_1462_n ) capacitor c=0.00481534f \
 //x=9 //y=2.265 //x2=9.855 //y2=3.88
cc_715 ( N_noxref_4_c_824_p N_noxref_8_c_1416_n ) capacitor c=0.0023507f \
 //x=9.485 //y=1.59 //x2=9.655 //y2=2.26
cc_716 ( N_noxref_4_c_735_n N_noxref_8_c_1465_n ) capacitor c=0.0167852f //x=9 \
 //y=2.265 //x2=9.455 //y2=2.26
cc_717 ( N_noxref_4_c_762_n N_noxref_8_c_1441_n ) capacitor c=0.0099173f \
 //x=9.52 //y=4.97 //x2=9.655 //y2=4.76
cc_718 ( N_noxref_4_c_723_n N_noxref_8_c_1444_n ) capacitor c=0.0250789f //x=9 \
 //y=2.265 //x2=9.46 //y2=4.76
cc_719 ( N_noxref_4_c_763_n N_noxref_8_c_1444_n ) capacitor c=0.00962086f \
 //x=9.23 //y=4.97 //x2=9.46 //y2=4.76
cc_720 ( N_noxref_4_c_782_p N_noxref_8_c_1419_n ) capacitor c=0.00502038f \
 //x=8.885 //y=3.51 //x2=9.74 //y2=3.88
cc_721 ( N_noxref_4_c_722_n N_noxref_8_c_1419_n ) capacitor c=0.00111766f \
 //x=7.52 //y=3.51 //x2=9.74 //y2=3.88
cc_722 ( N_noxref_4_c_723_n N_noxref_8_c_1419_n ) capacitor c=0.0632861f //x=9 \
 //y=2.265 //x2=9.74 //y2=3.88
cc_723 ( N_noxref_4_c_735_n N_noxref_8_c_1419_n ) capacitor c=8.49451e-19 \
 //x=9 //y=2.265 //x2=9.74 //y2=3.88
cc_724 ( N_noxref_4_c_722_n N_noxref_8_M4_noxref_d ) capacitor c=3.35192e-19 \
 //x=7.52 //y=3.51 //x2=9.185 //y2=1.09
cc_725 ( N_noxref_4_c_723_n N_noxref_8_M4_noxref_d ) capacitor c=0.0175773f \
 //x=9 //y=2.265 //x2=9.185 //y2=1.09
cc_726 ( N_noxref_4_c_728_n N_noxref_8_M4_noxref_d ) capacitor c=0.00218556f \
 //x=9.11 //y=1.09 //x2=9.185 //y2=1.09
cc_727 ( N_noxref_4_c_836_p N_noxref_8_M4_noxref_d ) capacitor c=0.00347355f \
 //x=9.11 //y=1.435 //x2=9.185 //y2=1.09
cc_728 ( N_noxref_4_c_837_p N_noxref_8_M4_noxref_d ) capacitor c=0.00742431f \
 //x=9.11 //y=1.745 //x2=9.185 //y2=1.09
cc_729 ( N_noxref_4_c_730_n N_noxref_8_M4_noxref_d ) capacitor c=0.00957707f \
 //x=9.11 //y=2.1 //x2=9.185 //y2=1.09
cc_730 ( N_noxref_4_c_731_n N_noxref_8_M4_noxref_d ) capacitor c=0.00220879f \
 //x=9.485 //y=0.935 //x2=9.185 //y2=1.09
cc_731 ( N_noxref_4_c_824_p N_noxref_8_M4_noxref_d ) capacitor c=0.0138447f \
 //x=9.485 //y=1.59 //x2=9.185 //y2=1.09
cc_732 ( N_noxref_4_c_732_n N_noxref_8_M4_noxref_d ) capacitor c=0.00218624f \
 //x=9.64 //y=1.09 //x2=9.185 //y2=1.09
cc_733 ( N_noxref_4_c_734_n N_noxref_8_M4_noxref_d ) capacitor c=0.00601286f \
 //x=9.64 //y=1.435 //x2=9.185 //y2=1.09
cc_734 ( N_noxref_4_c_722_n N_noxref_8_M20_noxref_d ) capacitor c=6.3502e-19 \
 //x=7.52 //y=3.51 //x2=9.23 //y2=5.2
cc_735 ( N_noxref_4_M20_noxref_g N_noxref_8_M20_noxref_d ) capacitor \
 c=0.0219309f //x=9.155 //y=6.2 //x2=9.23 //y2=5.2
cc_736 ( N_noxref_4_M21_noxref_g N_noxref_8_M20_noxref_d ) capacitor \
 c=0.021902f //x=9.595 //y=6.2 //x2=9.23 //y2=5.2
cc_737 ( N_noxref_4_c_762_n N_noxref_8_M20_noxref_d ) capacitor c=0.0146106f \
 //x=9.52 //y=4.97 //x2=9.23 //y2=5.2
cc_738 ( N_noxref_4_c_763_n N_noxref_8_M20_noxref_d ) capacitor c=0.00307344f \
 //x=9.23 //y=4.97 //x2=9.23 //y2=5.2
cc_739 ( N_noxref_4_c_784_p N_noxref_13_c_2114_n ) capacitor c=3.15806e-19 \
 //x=7.165 //y=1.835 //x2=5.625 //y2=1.675
cc_740 ( N_noxref_4_c_784_p N_noxref_13_c_2122_n ) capacitor c=0.0201674f \
 //x=7.165 //y=1.835 //x2=6.595 //y2=1.675
cc_741 ( N_noxref_4_c_720_n N_noxref_13_c_2123_n ) capacitor c=0.00464204f \
 //x=7.435 //y=1.835 //x2=7.48 //y2=0.71
cc_742 ( N_noxref_4_M3_noxref_d N_noxref_13_c_2123_n ) capacitor c=0.0117318f \
 //x=6.89 //y=1.085 //x2=7.48 //y2=0.71
cc_743 ( N_noxref_4_c_720_n N_noxref_13_M2_noxref_s ) capacitor c=0.0140283f \
 //x=7.435 //y=1.835 //x2=5.49 //y2=0.545
cc_744 ( N_noxref_4_M3_noxref_d N_noxref_13_M2_noxref_s ) capacitor \
 c=0.0437911f //x=6.89 //y=1.085 //x2=5.49 //y2=0.545
cc_745 ( N_noxref_5_c_854_n N_D_c_1109_n ) capacitor c=0.0363828f //x=6.665 \
 //y=3.14 //x2=12.215 //y2=4.25
cc_746 ( N_noxref_5_c_866_n N_D_c_1109_n ) capacitor c=0.0419288f //x=11.475 \
 //y=3.14 //x2=12.215 //y2=4.25
cc_747 ( N_noxref_5_c_875_n N_D_c_1109_n ) capacitor c=0.00683655f //x=6.895 \
 //y=3.14 //x2=12.215 //y2=4.25
cc_748 ( N_noxref_5_c_936_n N_D_c_1109_n ) capacitor c=0.00135863f //x=6.78 \
 //y=4.715 //x2=12.215 //y2=4.25
cc_749 ( N_noxref_5_c_880_n N_D_c_1109_n ) capacitor c=0.0247652f //x=6.78 \
 //y=2.26 //x2=12.215 //y2=4.25
cc_750 ( N_noxref_5_c_882_n N_D_c_1109_n ) capacitor c=0.0241934f //x=11.59 \
 //y=2.26 //x2=12.215 //y2=4.25
cc_751 ( N_noxref_5_c_981_n N_D_c_1109_n ) capacitor c=0.00561113f //x=7.185 \
 //y=4.97 //x2=12.215 //y2=4.25
cc_752 ( N_noxref_5_c_957_n N_D_c_1109_n ) capacitor c=0.00127126f //x=6.81 \
 //y=4.88 //x2=12.215 //y2=4.25
cc_753 ( N_noxref_5_c_922_n N_D_c_1109_n ) capacitor c=0.00844647f //x=11.59 \
 //y=4.88 //x2=12.215 //y2=4.25
cc_754 ( N_noxref_5_c_854_n N_D_c_1129_n ) capacitor c=0.00784092f //x=6.665 \
 //y=3.14 //x2=3.565 //y2=4.25
cc_755 ( N_noxref_5_c_879_n N_D_c_1129_n ) capacitor c=0.00259319f //x=1.97 \
 //y=3.14 //x2=3.565 //y2=4.25
cc_756 ( N_noxref_5_c_854_n N_D_c_1092_n ) capacitor c=0.026881f //x=6.665 \
 //y=3.14 //x2=3.45 //y2=2.265
cc_757 ( N_noxref_5_c_864_n N_D_c_1092_n ) capacitor c=7.62524e-19 //x=2.085 \
 //y=3.14 //x2=3.45 //y2=2.265
cc_758 ( N_noxref_5_c_876_n N_D_c_1092_n ) capacitor c=0.0192313f //x=1.885 \
 //y=2.26 //x2=3.45 //y2=2.265
cc_759 ( N_noxref_5_c_882_n N_D_c_1201_n ) capacitor c=0.00400249f //x=11.59 \
 //y=2.26 //x2=12.33 //y2=4.715
cc_760 ( N_noxref_5_c_922_n N_D_c_1201_n ) capacitor c=0.00417994f //x=11.59 \
 //y=4.88 //x2=12.33 //y2=4.715
cc_761 ( N_noxref_5_c_866_n N_D_c_1097_n ) capacitor c=0.00735597f //x=11.475 \
 //y=3.14 //x2=12.33 //y2=2.26
cc_762 ( N_noxref_5_c_882_n N_D_c_1097_n ) capacitor c=0.0803993f //x=11.59 \
 //y=2.26 //x2=12.33 //y2=2.26
cc_763 ( N_noxref_5_c_886_n N_D_c_1097_n ) capacitor c=0.00308814f //x=11.395 \
 //y=2.095 //x2=12.33 //y2=2.26
cc_764 ( N_noxref_5_M22_noxref_g N_D_M24_noxref_g ) capacitor c=0.0104611f \
 //x=11.49 //y=6.2 //x2=12.37 //y2=6.2
cc_765 ( N_noxref_5_M23_noxref_g N_D_M24_noxref_g ) capacitor c=0.106811f \
 //x=11.93 //y=6.2 //x2=12.37 //y2=6.2
cc_766 ( N_noxref_5_M23_noxref_g N_D_M25_noxref_g ) capacitor c=0.0100341f \
 //x=11.93 //y=6.2 //x2=12.81 //y2=6.2
cc_767 ( N_noxref_5_c_883_n N_D_c_1209_n ) capacitor c=4.86506e-19 //x=11.395 \
 //y=1.045 //x2=12.365 //y2=1.085
cc_768 ( N_noxref_5_c_885_n N_D_c_1209_n ) capacitor c=0.00152104f //x=11.395 \
 //y=1.39 //x2=12.365 //y2=1.085
cc_769 ( N_noxref_5_c_889_n N_D_c_1209_n ) capacitor c=0.0151475f //x=11.925 \
 //y=1.045 //x2=12.365 //y2=1.085
cc_770 ( N_noxref_5_c_1019_p N_D_c_1212_n ) capacitor c=0.00109982f //x=11.395 \
 //y=1.7 //x2=12.365 //y2=1.43
cc_771 ( N_noxref_5_c_891_n N_D_c_1212_n ) capacitor c=0.0111064f //x=11.925 \
 //y=1.39 //x2=12.365 //y2=1.43
cc_772 ( N_noxref_5_c_1019_p N_D_c_1214_n ) capacitor c=9.57794e-19 //x=11.395 \
 //y=1.7 //x2=12.365 //y2=1.74
cc_773 ( N_noxref_5_c_886_n N_D_c_1214_n ) capacitor c=0.00662747f //x=11.395 \
 //y=2.095 //x2=12.365 //y2=1.74
cc_774 ( N_noxref_5_c_891_n N_D_c_1214_n ) capacitor c=0.00862358f //x=11.925 \
 //y=1.39 //x2=12.365 //y2=1.74
cc_775 ( N_noxref_5_c_889_n N_D_c_1217_n ) capacitor c=0.00124821f //x=11.925 \
 //y=1.045 //x2=12.895 //y2=1.085
cc_776 ( N_noxref_5_c_891_n N_D_c_1218_n ) capacitor c=0.00200715f //x=11.925 \
 //y=1.39 //x2=12.895 //y2=1.43
cc_777 ( N_noxref_5_c_854_n N_D_c_1106_n ) capacitor c=0.00327833f //x=6.665 \
 //y=3.14 //x2=3.45 //y2=2.265
cc_778 ( N_noxref_5_c_882_n N_D_c_1220_n ) capacitor c=0.00307062f //x=11.59 \
 //y=2.26 //x2=12.33 //y2=2.26
cc_779 ( N_noxref_5_c_886_n N_D_c_1220_n ) capacitor c=0.0179092f //x=11.395 \
 //y=2.095 //x2=12.33 //y2=2.26
cc_780 ( N_noxref_5_c_882_n N_D_c_1222_n ) capacitor c=0.00344981f //x=11.59 \
 //y=2.26 //x2=12.36 //y2=4.88
cc_781 ( N_noxref_5_c_922_n N_D_c_1222_n ) capacitor c=0.0293367f //x=11.59 \
 //y=4.88 //x2=12.36 //y2=4.88
cc_782 ( N_noxref_5_M23_noxref_g N_noxref_7_c_1300_n ) capacitor c=0.017965f \
 //x=11.93 //y=6.2 //x2=12.505 //y2=5.38
cc_783 ( N_noxref_5_c_882_n N_noxref_7_c_1304_n ) capacitor c=0.00549854f \
 //x=11.59 //y=2.26 //x2=11.795 //y2=5.38
cc_784 ( N_noxref_5_M22_noxref_g N_noxref_7_c_1304_n ) capacitor c=0.0177326f \
 //x=11.49 //y=6.2 //x2=11.795 //y2=5.38
cc_785 ( N_noxref_5_c_922_n N_noxref_7_c_1304_n ) capacitor c=0.00582246f \
 //x=11.59 //y=4.88 //x2=11.795 //y2=5.38
cc_786 ( N_noxref_5_c_882_n N_noxref_7_c_1280_n ) capacitor c=0.00423287f \
 //x=11.59 //y=2.26 //x2=13.07 //y2=3.51
cc_787 ( N_noxref_5_M23_noxref_g N_noxref_7_M22_noxref_d ) capacitor \
 c=0.0173476f //x=11.93 //y=6.2 //x2=11.565 //y2=5.2
cc_788 ( N_noxref_5_c_866_n N_noxref_8_c_1410_n ) capacitor c=0.0866346f \
 //x=11.475 //y=3.14 //x2=17.025 //y2=3.88
cc_789 ( N_noxref_5_c_882_n N_noxref_8_c_1410_n ) capacitor c=0.0213789f \
 //x=11.59 //y=2.26 //x2=17.025 //y2=3.88
cc_790 ( N_noxref_5_c_866_n N_noxref_8_c_1462_n ) capacitor c=0.0132252f \
 //x=11.475 //y=3.14 //x2=9.855 //y2=3.88
cc_791 ( N_noxref_5_c_882_n N_noxref_8_c_1462_n ) capacitor c=7.01366e-19 \
 //x=11.59 //y=2.26 //x2=9.855 //y2=3.88
cc_792 ( N_noxref_5_c_882_n N_noxref_8_c_1416_n ) capacitor c=0.0121599f \
 //x=11.59 //y=2.26 //x2=9.655 //y2=2.26
cc_793 ( N_noxref_5_c_866_n N_noxref_8_c_1465_n ) capacitor c=0.00763858f \
 //x=11.475 //y=3.14 //x2=9.455 //y2=2.26
cc_794 ( N_noxref_5_c_866_n N_noxref_8_c_1419_n ) capacitor c=0.0266199f \
 //x=11.475 //y=3.14 //x2=9.74 //y2=3.88
cc_795 ( N_noxref_5_c_864_n N_GATE_N_c_2065_n ) capacitor c=0.00599141f \
 //x=2.085 //y=3.14 //x2=1.23 //y2=2.265
cc_796 ( N_noxref_5_c_905_n N_GATE_N_c_2065_n ) capacitor c=0.0250789f \
 //x=1.69 //y=4.76 //x2=1.23 //y2=2.265
cc_797 ( N_noxref_5_c_879_n N_GATE_N_c_2065_n ) capacitor c=0.0704256f \
 //x=1.97 //y=3.14 //x2=1.23 //y2=2.265
cc_798 ( N_noxref_5_M0_noxref_d N_GATE_N_c_2065_n ) capacitor c=0.0175773f \
 //x=1.415 //y=1.09 //x2=1.23 //y2=2.265
cc_799 ( N_noxref_5_M12_noxref_d N_GATE_N_M12_noxref_g ) capacitor \
 c=0.0219309f //x=1.46 //y=5.2 //x2=1.385 //y2=6.2
cc_800 ( N_noxref_5_M12_noxref_d N_GATE_N_M13_noxref_g ) capacitor c=0.021902f \
 //x=1.46 //y=5.2 //x2=1.825 //y2=6.2
cc_801 ( N_noxref_5_M0_noxref_d N_GATE_N_c_2070_n ) capacitor c=0.00218556f \
 //x=1.415 //y=1.09 //x2=1.34 //y2=1.09
cc_802 ( N_noxref_5_M0_noxref_d N_GATE_N_c_2099_n ) capacitor c=0.00347355f \
 //x=1.415 //y=1.09 //x2=1.34 //y2=1.435
cc_803 ( N_noxref_5_M0_noxref_d N_GATE_N_c_2100_n ) capacitor c=0.00742431f \
 //x=1.415 //y=1.09 //x2=1.34 //y2=1.745
cc_804 ( N_noxref_5_M0_noxref_d N_GATE_N_c_2072_n ) capacitor c=0.00957707f \
 //x=1.415 //y=1.09 //x2=1.34 //y2=2.1
cc_805 ( N_noxref_5_c_902_n N_GATE_N_c_2089_n ) capacitor c=0.0101013f \
 //x=1.885 //y=4.76 //x2=1.75 //y2=4.97
cc_806 ( N_noxref_5_M12_noxref_d N_GATE_N_c_2089_n ) capacitor c=0.0148755f \
 //x=1.46 //y=5.2 //x2=1.75 //y2=4.97
cc_807 ( N_noxref_5_c_905_n N_GATE_N_c_2090_n ) capacitor c=0.00962086f \
 //x=1.69 //y=4.76 //x2=1.46 //y2=4.97
cc_808 ( N_noxref_5_M12_noxref_d N_GATE_N_c_2090_n ) capacitor c=0.00307344f \
 //x=1.46 //y=5.2 //x2=1.46 //y2=4.97
cc_809 ( N_noxref_5_M0_noxref_d N_GATE_N_c_2073_n ) capacitor c=0.00220879f \
 //x=1.415 //y=1.09 //x2=1.715 //y2=0.935
cc_810 ( N_noxref_5_c_876_n N_GATE_N_c_2107_n ) capacitor c=0.0023507f \
 //x=1.885 //y=2.26 //x2=1.715 //y2=1.59
cc_811 ( N_noxref_5_M0_noxref_d N_GATE_N_c_2107_n ) capacitor c=0.0138447f \
 //x=1.415 //y=1.09 //x2=1.715 //y2=1.59
cc_812 ( N_noxref_5_M0_noxref_d N_GATE_N_c_2074_n ) capacitor c=0.00218624f \
 //x=1.415 //y=1.09 //x2=1.87 //y2=1.09
cc_813 ( N_noxref_5_M0_noxref_d N_GATE_N_c_2076_n ) capacitor c=0.00601286f \
 //x=1.415 //y=1.09 //x2=1.87 //y2=1.435
cc_814 ( N_noxref_5_c_1063_p N_GATE_N_c_2077_n ) capacitor c=0.0167852f \
 //x=1.685 //y=2.26 //x2=1.23 //y2=2.265
cc_815 ( N_noxref_5_c_879_n N_GATE_N_c_2077_n ) capacitor c=8.49451e-19 \
 //x=1.97 //y=3.14 //x2=1.23 //y2=2.265
cc_816 ( N_noxref_5_c_854_n N_noxref_13_c_2114_n ) capacitor c=0.00321948f \
 //x=6.665 //y=3.14 //x2=5.625 //y2=1.675
cc_817 ( N_noxref_5_c_854_n N_noxref_13_c_2115_n ) capacitor c=0.0126836f \
 //x=6.665 //y=3.14 //x2=6.51 //y2=1.76
cc_818 ( N_noxref_5_c_854_n N_noxref_13_c_2122_n ) capacitor c=0.00292809f \
 //x=6.665 //y=3.14 //x2=6.595 //y2=1.675
cc_819 ( N_noxref_5_c_875_n N_noxref_13_c_2122_n ) capacitor c=3.09768e-19 \
 //x=6.895 //y=3.14 //x2=6.595 //y2=1.675
cc_820 ( N_noxref_5_c_950_n N_noxref_13_c_2122_n ) capacitor c=0.00623646f \
 //x=6.815 //y=1.74 //x2=6.595 //y2=1.675
cc_821 ( N_noxref_5_c_955_n N_noxref_13_c_2122_n ) capacitor c=0.00174417f \
 //x=6.78 //y=2.26 //x2=6.595 //y2=1.675
cc_822 ( N_noxref_5_c_866_n N_noxref_13_c_2123_n ) capacitor c=5.58937e-19 \
 //x=11.475 //y=3.14 //x2=7.48 //y2=0.71
cc_823 ( N_noxref_5_c_880_n N_noxref_13_c_2123_n ) capacitor c=0.00159167f \
 //x=6.78 //y=2.26 //x2=7.48 //y2=0.71
cc_824 ( N_noxref_5_c_945_n N_noxref_13_c_2123_n ) capacitor c=0.0188655f \
 //x=6.815 //y=1.085 //x2=7.48 //y2=0.71
cc_825 ( N_noxref_5_c_953_n N_noxref_13_c_2123_n ) capacitor c=0.00656458f \
 //x=7.345 //y=1.085 //x2=7.48 //y2=0.71
cc_826 ( N_noxref_5_c_955_n N_noxref_13_c_2123_n ) capacitor c=2.1838e-19 \
 //x=6.78 //y=2.26 //x2=7.48 //y2=0.71
cc_827 ( N_noxref_5_c_866_n N_noxref_13_M2_noxref_s ) capacitor c=6.20367e-19 \
 //x=11.475 //y=3.14 //x2=5.49 //y2=0.545
cc_828 ( N_noxref_5_c_945_n N_noxref_13_M2_noxref_s ) capacitor c=0.00623646f \
 //x=6.815 //y=1.085 //x2=5.49 //y2=0.545
cc_829 ( N_noxref_5_c_953_n N_noxref_13_M2_noxref_s ) capacitor c=0.0143002f \
 //x=7.345 //y=1.085 //x2=5.49 //y2=0.545
cc_830 ( N_noxref_5_c_954_n N_noxref_13_M2_noxref_s ) capacitor c=0.00290153f \
 //x=7.345 //y=1.43 //x2=5.49 //y2=0.545
cc_831 ( N_noxref_5_c_866_n N_noxref_14_c_2168_n ) capacitor c=0.00321948f \
 //x=11.475 //y=3.14 //x2=11.175 //y2=1.675
cc_832 ( N_noxref_5_c_886_n N_noxref_14_c_2168_n ) capacitor c=0.0034165f \
 //x=11.395 //y=2.095 //x2=11.175 //y2=1.675
cc_833 ( N_noxref_5_c_866_n N_noxref_14_c_2169_n ) capacitor c=0.00765882f \
 //x=11.475 //y=3.14 //x2=12.06 //y2=1.76
cc_834 ( N_noxref_5_c_882_n N_noxref_14_c_2169_n ) capacitor c=0.0115783f \
 //x=11.59 //y=2.26 //x2=12.06 //y2=1.76
cc_835 ( N_noxref_5_c_1019_p N_noxref_14_c_2169_n ) capacitor c=0.00703567f \
 //x=11.395 //y=1.7 //x2=12.06 //y2=1.76
cc_836 ( N_noxref_5_c_886_n N_noxref_14_c_2169_n ) capacitor c=0.01939f \
 //x=11.395 //y=2.095 //x2=12.06 //y2=1.76
cc_837 ( N_noxref_5_c_888_n N_noxref_14_c_2169_n ) capacitor c=0.00780629f \
 //x=11.77 //y=1.545 //x2=12.06 //y2=1.76
cc_838 ( N_noxref_5_c_891_n N_noxref_14_c_2169_n ) capacitor c=0.00339872f \
 //x=11.925 //y=1.39 //x2=12.06 //y2=1.76
cc_839 ( N_noxref_5_c_886_n N_noxref_14_c_2176_n ) capacitor c=6.71402e-19 \
 //x=11.395 //y=2.095 //x2=12.145 //y2=1.675
cc_840 ( N_noxref_5_c_883_n N_noxref_14_M5_noxref_s ) capacitor c=0.0326577f \
 //x=11.395 //y=1.045 //x2=11.04 //y2=0.545
cc_841 ( N_noxref_5_c_1019_p N_noxref_14_M5_noxref_s ) capacitor c=3.48408e-19 \
 //x=11.395 //y=1.7 //x2=11.04 //y2=0.545
cc_842 ( N_noxref_5_c_889_n N_noxref_14_M5_noxref_s ) capacitor c=0.0120759f \
 //x=11.925 //y=1.045 //x2=11.04 //y2=0.545
cc_843 ( N_D_c_1097_n N_noxref_7_c_1277_n ) capacitor c=0.00502038f //x=12.33 \
 //y=2.26 //x2=13.185 //y2=3.51
cc_844 ( N_D_c_1109_n N_noxref_7_c_1300_n ) capacitor c=0.00208151f //x=12.215 \
 //y=4.25 //x2=12.505 //y2=5.38
cc_845 ( N_D_c_1201_n N_noxref_7_c_1300_n ) capacitor c=0.0129205f //x=12.33 \
 //y=4.715 //x2=12.505 //y2=5.38
cc_846 ( N_D_M24_noxref_g N_noxref_7_c_1300_n ) capacitor c=0.0166421f \
 //x=12.37 //y=6.2 //x2=12.505 //y2=5.38
cc_847 ( N_D_c_1222_n N_noxref_7_c_1300_n ) capacitor c=0.00346627f //x=12.36 \
 //y=4.88 //x2=12.505 //y2=5.38
cc_848 ( N_D_c_1109_n N_noxref_7_c_1304_n ) capacitor c=0.01319f //x=12.215 \
 //y=4.25 //x2=11.795 //y2=5.38
cc_849 ( N_D_M25_noxref_g N_noxref_7_c_1306_n ) capacitor c=0.0206783f \
 //x=12.81 //y=6.2 //x2=12.985 //y2=5.38
cc_850 ( N_D_c_1231_p N_noxref_7_c_1278_n ) capacitor c=0.00359704f //x=12.74 \
 //y=1.585 //x2=12.985 //y2=1.835
cc_851 ( N_D_c_1218_n N_noxref_7_c_1278_n ) capacitor c=0.00457401f //x=12.895 \
 //y=1.43 //x2=12.985 //y2=1.835
cc_852 ( N_D_c_1109_n N_noxref_7_c_1280_n ) capacitor c=0.0044695f //x=12.215 \
 //y=4.25 //x2=13.07 //y2=3.51
cc_853 ( N_D_c_1201_n N_noxref_7_c_1280_n ) capacitor c=0.0101204f //x=12.33 \
 //y=4.715 //x2=13.07 //y2=3.51
cc_854 ( N_D_c_1097_n N_noxref_7_c_1280_n ) capacitor c=0.0770799f //x=12.33 \
 //y=2.26 //x2=13.07 //y2=3.51
cc_855 ( N_D_c_1236_p N_noxref_7_c_1280_n ) capacitor c=0.0142673f //x=12.735 \
 //y=4.97 //x2=13.07 //y2=3.51
cc_856 ( N_D_c_1220_n N_noxref_7_c_1280_n ) capacitor c=0.00877984f //x=12.33 \
 //y=2.26 //x2=13.07 //y2=3.51
cc_857 ( N_D_c_1238_p N_noxref_7_c_1280_n ) capacitor c=0.00306024f //x=12.33 \
 //y=2.095 //x2=13.07 //y2=3.51
cc_858 ( N_D_c_1222_n N_noxref_7_c_1280_n ) capacitor c=0.00533692f //x=12.36 \
 //y=4.88 //x2=13.07 //y2=3.51
cc_859 ( N_D_c_1097_n N_noxref_7_c_1281_n ) capacitor c=0.00129241f //x=12.33 \
 //y=2.26 //x2=14.55 //y2=2.265
cc_860 ( N_D_c_1236_p N_noxref_7_c_1358_n ) capacitor c=0.00421574f //x=12.735 \
 //y=4.97 //x2=12.59 //y2=5.38
cc_861 ( N_D_c_1209_n N_noxref_7_M6_noxref_d ) capacitor c=0.00217566f \
 //x=12.365 //y=1.085 //x2=12.44 //y2=1.085
cc_862 ( N_D_c_1212_n N_noxref_7_M6_noxref_d ) capacitor c=0.0034598f \
 //x=12.365 //y=1.43 //x2=12.44 //y2=1.085
cc_863 ( N_D_c_1214_n N_noxref_7_M6_noxref_d ) capacitor c=0.0065582f \
 //x=12.365 //y=1.74 //x2=12.44 //y2=1.085
cc_864 ( N_D_c_1245_p N_noxref_7_M6_noxref_d ) capacitor c=0.00241102f \
 //x=12.74 //y=0.93 //x2=12.44 //y2=1.085
cc_865 ( N_D_c_1231_p N_noxref_7_M6_noxref_d ) capacitor c=0.0138845f \
 //x=12.74 //y=1.585 //x2=12.44 //y2=1.085
cc_866 ( N_D_c_1217_n N_noxref_7_M6_noxref_d ) capacitor c=0.00132245f \
 //x=12.895 //y=1.085 //x2=12.44 //y2=1.085
cc_867 ( N_D_c_1218_n N_noxref_7_M6_noxref_d ) capacitor c=0.00566463f \
 //x=12.895 //y=1.43 //x2=12.44 //y2=1.085
cc_868 ( N_D_c_1238_p N_noxref_7_M6_noxref_d ) capacitor c=0.00660593f \
 //x=12.33 //y=2.095 //x2=12.44 //y2=1.085
cc_869 ( N_D_M24_noxref_g N_noxref_7_M24_noxref_d ) capacitor c=0.0173476f \
 //x=12.37 //y=6.2 //x2=12.445 //y2=5.2
cc_870 ( N_D_M25_noxref_g N_noxref_7_M24_noxref_d ) capacitor c=0.0179769f \
 //x=12.81 //y=6.2 //x2=12.445 //y2=5.2
cc_871 ( N_D_c_1109_n N_noxref_8_c_1410_n ) capacitor c=0.239964f //x=12.215 \
 //y=4.25 //x2=17.025 //y2=3.88
cc_872 ( N_D_c_1097_n N_noxref_8_c_1410_n ) capacitor c=0.0243898f //x=12.33 \
 //y=2.26 //x2=17.025 //y2=3.88
cc_873 ( N_D_c_1236_p N_noxref_8_c_1410_n ) capacitor c=0.00624857f //x=12.735 \
 //y=4.97 //x2=17.025 //y2=3.88
cc_874 ( N_D_c_1222_n N_noxref_8_c_1410_n ) capacitor c=3.27069e-19 //x=12.36 \
 //y=4.88 //x2=17.025 //y2=3.88
cc_875 ( N_D_c_1109_n N_noxref_8_c_1462_n ) capacitor c=0.0289632f //x=12.215 \
 //y=4.25 //x2=9.855 //y2=3.88
cc_876 ( N_D_c_1109_n N_noxref_8_c_1444_n ) capacitor c=0.0123666f //x=12.215 \
 //y=4.25 //x2=9.46 //y2=4.76
cc_877 ( N_D_c_1109_n N_noxref_8_c_1419_n ) capacitor c=0.0237455f //x=12.215 \
 //y=4.25 //x2=9.74 //y2=3.88
cc_878 ( N_D_c_1097_n N_noxref_8_c_1419_n ) capacitor c=0.00147206f //x=12.33 \
 //y=2.26 //x2=9.74 //y2=3.88
cc_879 ( N_D_c_1109_n N_noxref_10_c_1767_n ) capacitor c=0.00564994f \
 //x=12.215 //y=4.25 //x2=15.405 //y2=4.25
cc_880 ( N_D_c_1092_n N_GATE_N_c_2065_n ) capacitor c=0.00175665f //x=3.45 \
 //y=2.265 //x2=1.23 //y2=2.265
cc_881 ( N_D_c_1214_n N_noxref_14_c_2176_n ) capacitor c=0.00623646f \
 //x=12.365 //y=1.74 //x2=12.145 //y2=1.675
cc_882 ( N_D_c_1220_n N_noxref_14_c_2176_n ) capacitor c=0.00176439f //x=12.33 \
 //y=2.26 //x2=12.145 //y2=1.675
cc_883 ( N_D_c_1097_n N_noxref_14_c_2177_n ) capacitor c=0.0016032f //x=12.33 \
 //y=2.26 //x2=13.03 //y2=0.71
cc_884 ( N_D_c_1209_n N_noxref_14_c_2177_n ) capacitor c=0.0188655f //x=12.365 \
 //y=1.085 //x2=13.03 //y2=0.71
cc_885 ( N_D_c_1217_n N_noxref_14_c_2177_n ) capacitor c=0.00656458f \
 //x=12.895 //y=1.085 //x2=13.03 //y2=0.71
cc_886 ( N_D_c_1220_n N_noxref_14_c_2177_n ) capacitor c=2.1838e-19 //x=12.33 \
 //y=2.26 //x2=13.03 //y2=0.71
cc_887 ( N_D_c_1209_n N_noxref_14_M5_noxref_s ) capacitor c=0.00623646f \
 //x=12.365 //y=1.085 //x2=11.04 //y2=0.545
cc_888 ( N_D_c_1217_n N_noxref_14_M5_noxref_s ) capacitor c=0.0143002f \
 //x=12.895 //y=1.085 //x2=11.04 //y2=0.545
cc_889 ( N_D_c_1218_n N_noxref_14_M5_noxref_s ) capacitor c=0.00290153f \
 //x=12.895 //y=1.43 //x2=11.04 //y2=0.545
cc_890 ( N_noxref_7_c_1271_n N_noxref_8_c_1410_n ) capacitor c=0.142515f \
 //x=14.435 //y=3.51 //x2=17.025 //y2=3.88
cc_891 ( N_noxref_7_c_1277_n N_noxref_8_c_1410_n ) capacitor c=0.0293967f \
 //x=13.185 //y=3.51 //x2=17.025 //y2=3.88
cc_892 ( N_noxref_7_c_1300_n N_noxref_8_c_1410_n ) capacitor c=0.00978117f \
 //x=12.505 //y=5.38 //x2=17.025 //y2=3.88
cc_893 ( N_noxref_7_c_1372_p N_noxref_8_c_1410_n ) capacitor c=0.00378729f \
 //x=12.715 //y=1.835 //x2=17.025 //y2=3.88
cc_894 ( N_noxref_7_c_1280_n N_noxref_8_c_1410_n ) capacitor c=0.0257951f \
 //x=13.07 //y=3.51 //x2=17.025 //y2=3.88
cc_895 ( N_noxref_7_c_1281_n N_noxref_8_c_1410_n ) capacitor c=0.025066f \
 //x=14.55 //y=2.265 //x2=17.025 //y2=3.88
cc_896 ( N_noxref_7_c_1321_n N_noxref_8_c_1410_n ) capacitor c=0.00582422f \
 //x=14.78 //y=4.97 //x2=17.025 //y2=3.88
cc_897 ( N_noxref_7_c_1281_n N_noxref_8_c_1420_n ) capacitor c=0.00107428f \
 //x=14.55 //y=2.265 //x2=17.14 //y2=2.26
cc_898 ( N_noxref_7_c_1271_n N_Q_c_1580_n ) capacitor c=0.00359266f //x=14.435 \
 //y=3.51 //x2=18.735 //y2=3.51
cc_899 ( N_noxref_7_c_1281_n N_noxref_10_c_1767_n ) capacitor c=0.0044695f \
 //x=14.55 //y=2.265 //x2=15.405 //y2=4.25
cc_900 ( N_noxref_7_c_1379_p N_noxref_10_c_1742_n ) capacitor c=0.0023507f \
 //x=15.035 //y=1.59 //x2=15.205 //y2=2.26
cc_901 ( N_noxref_7_c_1293_n N_noxref_10_c_1788_n ) capacitor c=0.0167852f \
 //x=14.55 //y=2.265 //x2=15.005 //y2=2.26
cc_902 ( N_noxref_7_c_1320_n N_noxref_10_c_1770_n ) capacitor c=0.00997878f \
 //x=15.07 //y=4.97 //x2=15.205 //y2=4.76
cc_903 ( N_noxref_7_c_1281_n N_noxref_10_c_1773_n ) capacitor c=0.0250878f \
 //x=14.55 //y=2.265 //x2=15.01 //y2=4.76
cc_904 ( N_noxref_7_c_1321_n N_noxref_10_c_1773_n ) capacitor c=0.00962086f \
 //x=14.78 //y=4.97 //x2=15.01 //y2=4.76
cc_905 ( N_noxref_7_c_1271_n N_noxref_10_c_1745_n ) capacitor c=0.00502038f \
 //x=14.435 //y=3.51 //x2=15.29 //y2=4.25
cc_906 ( N_noxref_7_c_1280_n N_noxref_10_c_1745_n ) capacitor c=0.0011405f \
 //x=13.07 //y=3.51 //x2=15.29 //y2=4.25
cc_907 ( N_noxref_7_c_1281_n N_noxref_10_c_1745_n ) capacitor c=0.0668092f \
 //x=14.55 //y=2.265 //x2=15.29 //y2=4.25
cc_908 ( N_noxref_7_c_1293_n N_noxref_10_c_1745_n ) capacitor c=8.49451e-19 \
 //x=14.55 //y=2.265 //x2=15.29 //y2=4.25
cc_909 ( N_noxref_7_c_1280_n N_noxref_10_M7_noxref_d ) capacitor c=3.35192e-19 \
 //x=13.07 //y=3.51 //x2=14.735 //y2=1.09
cc_910 ( N_noxref_7_c_1281_n N_noxref_10_M7_noxref_d ) capacitor c=0.0175773f \
 //x=14.55 //y=2.265 //x2=14.735 //y2=1.09
cc_911 ( N_noxref_7_c_1286_n N_noxref_10_M7_noxref_d ) capacitor c=0.00218556f \
 //x=14.66 //y=1.09 //x2=14.735 //y2=1.09
cc_912 ( N_noxref_7_c_1391_p N_noxref_10_M7_noxref_d ) capacitor c=0.00347355f \
 //x=14.66 //y=1.435 //x2=14.735 //y2=1.09
cc_913 ( N_noxref_7_c_1392_p N_noxref_10_M7_noxref_d ) capacitor c=0.00742431f \
 //x=14.66 //y=1.745 //x2=14.735 //y2=1.09
cc_914 ( N_noxref_7_c_1288_n N_noxref_10_M7_noxref_d ) capacitor c=0.00957707f \
 //x=14.66 //y=2.1 //x2=14.735 //y2=1.09
cc_915 ( N_noxref_7_c_1289_n N_noxref_10_M7_noxref_d ) capacitor c=0.00220879f \
 //x=15.035 //y=0.935 //x2=14.735 //y2=1.09
cc_916 ( N_noxref_7_c_1379_p N_noxref_10_M7_noxref_d ) capacitor c=0.0138447f \
 //x=15.035 //y=1.59 //x2=14.735 //y2=1.09
cc_917 ( N_noxref_7_c_1290_n N_noxref_10_M7_noxref_d ) capacitor c=0.00218624f \
 //x=15.19 //y=1.09 //x2=14.735 //y2=1.09
cc_918 ( N_noxref_7_c_1292_n N_noxref_10_M7_noxref_d ) capacitor c=0.00601286f \
 //x=15.19 //y=1.435 //x2=14.735 //y2=1.09
cc_919 ( N_noxref_7_c_1280_n N_noxref_10_M26_noxref_d ) capacitor c=6.3502e-19 \
 //x=13.07 //y=3.51 //x2=14.78 //y2=5.2
cc_920 ( N_noxref_7_M26_noxref_g N_noxref_10_M26_noxref_d ) capacitor \
 c=0.0219309f //x=14.705 //y=6.2 //x2=14.78 //y2=5.2
cc_921 ( N_noxref_7_M27_noxref_g N_noxref_10_M26_noxref_d ) capacitor \
 c=0.021902f //x=15.145 //y=6.2 //x2=14.78 //y2=5.2
cc_922 ( N_noxref_7_c_1320_n N_noxref_10_M26_noxref_d ) capacitor c=0.0146106f \
 //x=15.07 //y=4.97 //x2=14.78 //y2=5.2
cc_923 ( N_noxref_7_c_1321_n N_noxref_10_M26_noxref_d ) capacitor \
 c=0.00307344f //x=14.78 //y=4.97 //x2=14.78 //y2=5.2
cc_924 ( N_noxref_7_c_1372_p N_noxref_14_c_2168_n ) capacitor c=3.15806e-19 \
 //x=12.715 //y=1.835 //x2=11.175 //y2=1.675
cc_925 ( N_noxref_7_c_1372_p N_noxref_14_c_2176_n ) capacitor c=0.0201674f \
 //x=12.715 //y=1.835 //x2=12.145 //y2=1.675
cc_926 ( N_noxref_7_c_1278_n N_noxref_14_c_2177_n ) capacitor c=0.0046686f \
 //x=12.985 //y=1.835 //x2=13.03 //y2=0.71
cc_927 ( N_noxref_7_M6_noxref_d N_noxref_14_c_2177_n ) capacitor c=0.0117932f \
 //x=12.44 //y=1.085 //x2=13.03 //y2=0.71
cc_928 ( N_noxref_7_c_1277_n N_noxref_14_M5_noxref_s ) capacitor c=3.47564e-19 \
 //x=13.185 //y=3.51 //x2=11.04 //y2=0.545
cc_929 ( N_noxref_7_c_1278_n N_noxref_14_M5_noxref_s ) capacitor c=0.0141735f \
 //x=12.985 //y=1.835 //x2=11.04 //y2=0.545
cc_930 ( N_noxref_7_M6_noxref_d N_noxref_14_M5_noxref_s ) capacitor \
 c=0.0437911f //x=12.44 //y=1.085 //x2=11.04 //y2=0.545
cc_931 ( N_noxref_8_c_1420_n Q ) capacitor c=0.00359995f //x=17.14 //y=2.26 \
 //x2=18.62 //y2=2.4
cc_932 ( N_noxref_8_c_1430_n N_Q_c_1583_n ) capacitor c=0.00431513f //x=17.475 \
 //y=1.43 //x2=18.095 //y2=1.835
cc_933 ( N_noxref_8_c_1410_n N_Q_c_1630_n ) capacitor c=6.76081e-19 //x=17.025 \
 //y=3.88 //x2=17.295 //y2=1.835
cc_934 ( N_noxref_8_c_1420_n N_Q_c_1630_n ) capacitor c=0.0110776f //x=17.14 \
 //y=2.26 //x2=17.295 //y2=1.835
cc_935 ( N_noxref_8_c_1425_n N_Q_c_1630_n ) capacitor c=0.00589082f //x=16.945 \
 //y=2.095 //x2=17.295 //y2=1.835
cc_936 ( N_noxref_8_c_1423_n N_Q_M8_noxref_d ) capacitor c=0.0013184f \
 //x=16.945 //y=1.085 //x2=17.02 //y2=1.085
cc_937 ( N_noxref_8_c_1517_p N_Q_M8_noxref_d ) capacitor c=0.0034598f \
 //x=16.945 //y=1.43 //x2=17.02 //y2=1.085
cc_938 ( N_noxref_8_c_1518_p N_Q_M8_noxref_d ) capacitor c=0.00300148f \
 //x=16.945 //y=1.74 //x2=17.02 //y2=1.085
cc_939 ( N_noxref_8_c_1425_n N_Q_M8_noxref_d ) capacitor c=0.00273686f \
 //x=16.945 //y=2.095 //x2=17.02 //y2=1.085
cc_940 ( N_noxref_8_c_1427_n N_Q_M8_noxref_d ) capacitor c=0.00241102f \
 //x=17.32 //y=0.93 //x2=17.02 //y2=1.085
cc_941 ( N_noxref_8_c_1521_p N_Q_M8_noxref_d ) capacitor c=0.0123304f \
 //x=17.32 //y=1.585 //x2=17.02 //y2=1.085
cc_942 ( N_noxref_8_c_1428_n N_Q_M8_noxref_d ) capacitor c=0.00219619f \
 //x=17.475 //y=1.085 //x2=17.02 //y2=1.085
cc_943 ( N_noxref_8_c_1430_n N_Q_M8_noxref_d ) capacitor c=0.00603828f \
 //x=17.475 //y=1.43 //x2=17.02 //y2=1.085
cc_944 ( N_noxref_8_c_1410_n N_noxref_10_c_1741_n ) capacitor c=0.175903f \
 //x=17.025 //y=3.88 //x2=21.095 //y2=4.25
cc_945 ( N_noxref_8_c_1420_n N_noxref_10_c_1741_n ) capacitor c=0.0239848f \
 //x=17.14 //y=2.26 //x2=21.095 //y2=4.25
cc_946 ( N_noxref_8_c_1448_n N_noxref_10_c_1741_n ) capacitor c=0.00699941f \
 //x=16.985 //y=4.885 //x2=21.095 //y2=4.25
cc_947 ( N_noxref_8_c_1527_p N_noxref_10_c_1741_n ) capacitor c=0.00503266f \
 //x=17.405 //y=4.975 //x2=21.095 //y2=4.25
cc_948 ( N_noxref_8_c_1456_n N_noxref_10_c_1741_n ) capacitor c=0.00111449f \
 //x=16.985 //y=4.885 //x2=21.095 //y2=4.25
cc_949 ( N_noxref_8_c_1410_n N_noxref_10_c_1767_n ) capacitor c=0.029084f \
 //x=17.025 //y=3.88 //x2=15.405 //y2=4.25
cc_950 ( N_noxref_8_c_1420_n N_noxref_10_c_1767_n ) capacitor c=3.50683e-19 \
 //x=17.14 //y=2.26 //x2=15.405 //y2=4.25
cc_951 ( N_noxref_8_c_1420_n N_noxref_10_c_1742_n ) capacitor c=0.0139741f \
 //x=17.14 //y=2.26 //x2=15.205 //y2=2.26
cc_952 ( N_noxref_8_c_1410_n N_noxref_10_c_1788_n ) capacitor c=0.00360671f \
 //x=17.025 //y=3.88 //x2=15.005 //y2=2.26
cc_953 ( N_noxref_8_c_1410_n N_noxref_10_c_1773_n ) capacitor c=0.00677394f \
 //x=17.025 //y=3.88 //x2=15.01 //y2=4.76
cc_954 ( N_noxref_8_c_1410_n N_noxref_10_c_1745_n ) capacitor c=0.0267087f \
 //x=17.025 //y=3.88 //x2=15.29 //y2=4.25
cc_955 ( N_noxref_8_c_1410_n N_noxref_11_c_1905_n ) capacitor c=0.0244534f \
 //x=17.025 //y=3.88 //x2=17.995 //y2=3.88
cc_956 ( N_noxref_8_c_1420_n N_noxref_11_c_1905_n ) capacitor c=0.00245879f \
 //x=17.14 //y=2.26 //x2=17.995 //y2=3.88
cc_957 ( N_noxref_8_c_1448_n N_noxref_11_c_1945_n ) capacitor c=0.0450681f \
 //x=16.985 //y=4.885 //x2=17.88 //y2=4.72
cc_958 ( N_noxref_8_c_1527_p N_noxref_11_c_1945_n ) capacitor c=0.00146509f \
 //x=17.405 //y=4.975 //x2=17.88 //y2=4.72
cc_959 ( N_noxref_8_c_1456_n N_noxref_11_c_1945_n ) capacitor c=0.00112871f \
 //x=16.985 //y=4.885 //x2=17.88 //y2=4.72
cc_960 ( N_noxref_8_c_1410_n N_noxref_11_c_1906_n ) capacitor c=0.00246068f \
 //x=17.025 //y=3.88 //x2=17.88 //y2=2.26
cc_961 ( N_noxref_8_c_1420_n N_noxref_11_c_1906_n ) capacitor c=0.0432793f \
 //x=17.14 //y=2.26 //x2=17.88 //y2=2.26
cc_962 ( N_noxref_8_c_1425_n N_noxref_11_c_1906_n ) capacitor c=0.00308814f \
 //x=16.945 //y=2.095 //x2=17.88 //y2=2.26
cc_963 ( N_noxref_8_M28_noxref_g N_noxref_11_M30_noxref_g ) capacitor \
 c=0.0100243f //x=17.04 //y=6.205 //x2=17.92 //y2=6.205
cc_964 ( N_noxref_8_M29_noxref_g N_noxref_11_M30_noxref_g ) capacitor \
 c=0.107798f //x=17.48 //y=6.205 //x2=17.92 //y2=6.205
cc_965 ( N_noxref_8_M29_noxref_g N_noxref_11_M31_noxref_g ) capacitor \
 c=0.0094155f //x=17.48 //y=6.205 //x2=18.36 //y2=6.205
cc_966 ( N_noxref_8_c_1423_n N_noxref_11_c_1917_n ) capacitor c=0.00125788f \
 //x=16.945 //y=1.085 //x2=17.915 //y2=1.085
cc_967 ( N_noxref_8_c_1428_n N_noxref_11_c_1917_n ) capacitor c=0.0126654f \
 //x=17.475 //y=1.085 //x2=17.915 //y2=1.085
cc_968 ( N_noxref_8_c_1517_p N_noxref_11_c_1956_n ) capacitor c=0.00148539f \
 //x=16.945 //y=1.43 //x2=17.915 //y2=1.435
cc_969 ( N_noxref_8_c_1518_p N_noxref_11_c_1956_n ) capacitor c=0.00105591f \
 //x=16.945 //y=1.74 //x2=17.915 //y2=1.435
cc_970 ( N_noxref_8_c_1430_n N_noxref_11_c_1956_n ) capacitor c=0.0126654f \
 //x=17.475 //y=1.43 //x2=17.915 //y2=1.435
cc_971 ( N_noxref_8_c_1518_p N_noxref_11_c_1959_n ) capacitor c=0.00109549f \
 //x=16.945 //y=1.74 //x2=17.915 //y2=1.74
cc_972 ( N_noxref_8_c_1430_n N_noxref_11_c_1959_n ) capacitor c=0.00886999f \
 //x=17.475 //y=1.43 //x2=17.915 //y2=1.74
cc_973 ( N_noxref_8_c_1430_n N_noxref_11_c_1920_n ) capacitor c=0.00123863f \
 //x=17.475 //y=1.43 //x2=18.29 //y2=1.585
cc_974 ( N_noxref_8_c_1428_n N_noxref_11_c_1921_n ) capacitor c=0.00132934f \
 //x=17.475 //y=1.085 //x2=18.445 //y2=1.085
cc_975 ( N_noxref_8_c_1430_n N_noxref_11_c_1963_n ) capacitor c=0.00150734f \
 //x=17.475 //y=1.43 //x2=18.445 //y2=1.435
cc_976 ( N_noxref_8_c_1420_n N_noxref_11_c_1964_n ) capacitor c=0.00307062f \
 //x=17.14 //y=2.26 //x2=17.88 //y2=2.26
cc_977 ( N_noxref_8_c_1425_n N_noxref_11_c_1964_n ) capacitor c=0.0179092f \
 //x=16.945 //y=2.095 //x2=17.88 //y2=2.26
cc_978 ( N_noxref_8_c_1425_n N_noxref_11_c_1966_n ) capacitor c=0.00577193f \
 //x=16.945 //y=2.095 //x2=17.88 //y2=2.095
cc_979 ( N_noxref_8_c_1448_n N_noxref_11_c_1967_n ) capacitor c=0.00336963f \
 //x=16.985 //y=4.885 //x2=17.915 //y2=4.885
cc_980 ( N_noxref_8_c_1527_p N_noxref_11_c_1967_n ) capacitor c=0.020271f \
 //x=17.405 //y=4.975 //x2=17.915 //y2=4.885
cc_981 ( N_noxref_8_c_1456_n N_noxref_11_c_1967_n ) capacitor c=0.00546725f \
 //x=16.985 //y=4.885 //x2=17.915 //y2=4.885
cc_982 ( N_noxref_8_c_1410_n N_noxref_14_c_2169_n ) capacitor c=0.00299723f \
 //x=17.025 //y=3.88 //x2=12.06 //y2=1.76
cc_983 ( N_noxref_8_c_1410_n N_noxref_14_c_2176_n ) capacitor c=0.00187232f \
 //x=17.025 //y=3.88 //x2=12.145 //y2=1.675
cc_984 ( N_noxref_8_c_1410_n N_noxref_14_c_2177_n ) capacitor c=4.7198e-19 \
 //x=17.025 //y=3.88 //x2=13.03 //y2=0.71
cc_985 ( N_noxref_8_c_1448_n N_noxref_15_c_2222_n ) capacitor c=0.00575148f \
 //x=16.985 //y=4.885 //x2=17.615 //y2=5.39
cc_986 ( N_noxref_8_M28_noxref_g N_noxref_15_c_2222_n ) capacitor c=0.0182391f \
 //x=17.04 //y=6.205 //x2=17.615 //y2=5.39
cc_987 ( N_noxref_8_M29_noxref_g N_noxref_15_c_2222_n ) capacitor c=0.0179851f \
 //x=17.48 //y=6.205 //x2=17.615 //y2=5.39
cc_988 ( N_noxref_8_c_1527_p N_noxref_15_c_2222_n ) capacitor c=0.00364886f \
 //x=17.405 //y=4.975 //x2=17.615 //y2=5.39
cc_989 ( N_noxref_8_c_1456_n N_noxref_15_c_2222_n ) capacitor c=0.0017421f \
 //x=16.985 //y=4.885 //x2=17.615 //y2=5.39
cc_990 ( N_noxref_8_c_1448_n N_noxref_15_c_2227_n ) capacitor c=0.0118149f \
 //x=16.985 //y=4.885 //x2=16.905 //y2=5.39
cc_991 ( N_noxref_8_c_1456_n N_noxref_15_c_2227_n ) capacitor c=0.00521692f \
 //x=16.985 //y=4.885 //x2=16.905 //y2=5.39
cc_992 ( N_noxref_8_M28_noxref_g N_noxref_15_M28_noxref_s ) capacitor \
 c=0.0473218f //x=17.04 //y=6.205 //x2=16.685 //y2=5.205
cc_993 ( N_noxref_8_M29_noxref_g N_noxref_15_M29_noxref_d ) capacitor \
 c=0.0170604f //x=17.48 //y=6.205 //x2=17.555 //y2=5.205
cc_994 ( N_Q_c_1574_n N_noxref_10_c_1741_n ) capacitor c=0.0107208f //x=20.355 \
 //y=3.51 //x2=21.095 //y2=4.25
cc_995 ( N_Q_c_1580_n N_noxref_10_c_1741_n ) capacitor c=8.88421e-19 \
 //x=18.735 //y=3.51 //x2=21.095 //y2=4.25
cc_996 ( Q N_noxref_10_c_1741_n ) capacitor c=0.0231862f //x=18.62 //y=2.4 \
 //x2=21.095 //y2=4.25
cc_997 ( N_Q_c_1630_n N_noxref_10_c_1741_n ) capacitor c=0.00331066f \
 //x=17.295 //y=1.835 //x2=21.095 //y2=4.25
cc_998 ( N_Q_c_1614_n N_noxref_10_c_1741_n ) capacitor c=0.0117991f //x=18.225 \
 //y=5.39 //x2=21.095 //y2=4.25
cc_999 ( N_Q_c_1592_n N_noxref_10_c_1741_n ) capacitor c=0.0239633f //x=20.47 \
 //y=2.26 //x2=21.095 //y2=4.25
cc_1000 ( N_Q_c_1616_n N_noxref_10_c_1741_n ) capacitor c=0.00699941f \
 //x=20.315 //y=4.885 //x2=21.095 //y2=4.25
cc_1001 ( N_Q_c_1648_p N_noxref_10_c_1741_n ) capacitor c=0.00642535f \
 //x=20.735 //y=4.975 //x2=21.095 //y2=4.25
cc_1002 ( N_Q_c_1624_n N_noxref_10_c_1741_n ) capacitor c=0.00111449f \
 //x=20.315 //y=4.885 //x2=21.095 //y2=4.25
cc_1003 ( N_Q_c_1616_n N_noxref_10_c_1831_n ) capacitor c=0.0438179f \
 //x=20.315 //y=4.885 //x2=21.21 //y2=4.72
cc_1004 ( N_Q_c_1648_p N_noxref_10_c_1831_n ) capacitor c=0.00146509f \
 //x=20.735 //y=4.975 //x2=21.21 //y2=4.72
cc_1005 ( N_Q_c_1624_n N_noxref_10_c_1831_n ) capacitor c=0.00112871f \
 //x=20.315 //y=4.885 //x2=21.21 //y2=4.72
cc_1006 ( N_Q_c_1574_n N_noxref_10_c_1746_n ) capacitor c=0.00720056f \
 //x=20.355 //y=3.51 //x2=21.21 //y2=2.26
cc_1007 ( Q N_noxref_10_c_1746_n ) capacitor c=0.00107361f //x=18.62 //y=2.4 \
 //x2=21.21 //y2=2.26
cc_1008 ( N_Q_c_1592_n N_noxref_10_c_1746_n ) capacitor c=0.0418764f //x=20.47 \
 //y=2.26 //x2=21.21 //y2=2.26
cc_1009 ( N_Q_c_1597_n N_noxref_10_c_1746_n ) capacitor c=0.00308814f \
 //x=20.275 //y=2.095 //x2=21.21 //y2=2.26
cc_1010 ( N_Q_M32_noxref_g N_noxref_10_M34_noxref_g ) capacitor c=0.0100243f \
 //x=20.37 //y=6.205 //x2=21.25 //y2=6.205
cc_1011 ( N_Q_M33_noxref_g N_noxref_10_M34_noxref_g ) capacitor c=0.107798f \
 //x=20.81 //y=6.205 //x2=21.25 //y2=6.205
cc_1012 ( N_Q_M33_noxref_g N_noxref_10_M35_noxref_g ) capacitor c=0.0094155f \
 //x=20.81 //y=6.205 //x2=21.69 //y2=6.205
cc_1013 ( N_Q_c_1595_n N_noxref_10_c_1748_n ) capacitor c=0.00125788f \
 //x=20.275 //y=1.085 //x2=21.245 //y2=1.085
cc_1014 ( N_Q_c_1600_n N_noxref_10_c_1748_n ) capacitor c=0.0126654f \
 //x=20.805 //y=1.085 //x2=21.245 //y2=1.085
cc_1015 ( N_Q_c_1662_p N_noxref_10_c_1843_n ) capacitor c=0.00148539f \
 //x=20.275 //y=1.43 //x2=21.245 //y2=1.435
cc_1016 ( N_Q_c_1663_p N_noxref_10_c_1843_n ) capacitor c=0.00105591f \
 //x=20.275 //y=1.74 //x2=21.245 //y2=1.435
cc_1017 ( N_Q_c_1602_n N_noxref_10_c_1843_n ) capacitor c=0.0126654f \
 //x=20.805 //y=1.43 //x2=21.245 //y2=1.435
cc_1018 ( N_Q_c_1663_p N_noxref_10_c_1846_n ) capacitor c=0.00109549f \
 //x=20.275 //y=1.74 //x2=21.245 //y2=1.74
cc_1019 ( N_Q_c_1602_n N_noxref_10_c_1846_n ) capacitor c=0.00886999f \
 //x=20.805 //y=1.43 //x2=21.245 //y2=1.74
cc_1020 ( N_Q_c_1602_n N_noxref_10_c_1751_n ) capacitor c=0.00123863f \
 //x=20.805 //y=1.43 //x2=21.62 //y2=1.585
cc_1021 ( N_Q_c_1600_n N_noxref_10_c_1752_n ) capacitor c=0.00132934f \
 //x=20.805 //y=1.085 //x2=21.775 //y2=1.085
cc_1022 ( N_Q_c_1602_n N_noxref_10_c_1850_n ) capacitor c=0.00150734f \
 //x=20.805 //y=1.43 //x2=21.775 //y2=1.435
cc_1023 ( N_Q_c_1592_n N_noxref_10_c_1851_n ) capacitor c=0.00307062f \
 //x=20.47 //y=2.26 //x2=21.21 //y2=2.26
cc_1024 ( N_Q_c_1597_n N_noxref_10_c_1851_n ) capacitor c=0.0179092f \
 //x=20.275 //y=2.095 //x2=21.21 //y2=2.26
cc_1025 ( N_Q_c_1597_n N_noxref_10_c_1853_n ) capacitor c=0.00577193f \
 //x=20.275 //y=2.095 //x2=21.21 //y2=2.095
cc_1026 ( N_Q_c_1616_n N_noxref_10_c_1854_n ) capacitor c=0.00336963f \
 //x=20.315 //y=4.885 //x2=21.245 //y2=4.885
cc_1027 ( N_Q_c_1648_p N_noxref_10_c_1854_n ) capacitor c=0.020271f //x=20.735 \
 //y=4.975 //x2=21.245 //y2=4.885
cc_1028 ( N_Q_c_1624_n N_noxref_10_c_1854_n ) capacitor c=0.00546725f \
 //x=20.315 //y=4.885 //x2=21.245 //y2=4.885
cc_1029 ( N_Q_c_1574_n N_noxref_11_c_1903_n ) capacitor c=0.17519f //x=20.355 \
 //y=3.51 //x2=21.835 //y2=3.88
cc_1030 ( N_Q_c_1580_n N_noxref_11_c_1903_n ) capacitor c=0.0293975f \
 //x=18.735 //y=3.51 //x2=21.835 //y2=3.88
cc_1031 ( Q N_noxref_11_c_1903_n ) capacitor c=0.0206034f //x=18.62 //y=2.4 \
 //x2=21.835 //y2=3.88
cc_1032 ( N_Q_c_1583_n N_noxref_11_c_1903_n ) capacitor c=0.00475418f \
 //x=18.095 //y=1.835 //x2=21.835 //y2=3.88
cc_1033 ( N_Q_c_1592_n N_noxref_11_c_1903_n ) capacitor c=0.0205626f //x=20.47 \
 //y=2.26 //x2=21.835 //y2=3.88
cc_1034 ( Q N_noxref_11_c_1905_n ) capacitor c=0.00117715f //x=18.62 //y=2.4 \
 //x2=17.995 //y2=3.88
cc_1035 ( N_Q_c_1583_n N_noxref_11_c_1905_n ) capacitor c=0.00142742f \
 //x=18.095 //y=1.835 //x2=17.995 //y2=3.88
cc_1036 ( Q N_noxref_11_c_1945_n ) capacitor c=0.0102183f //x=18.62 //y=2.4 \
 //x2=17.88 //y2=4.72
cc_1037 ( N_Q_c_1580_n N_noxref_11_c_1906_n ) capacitor c=0.00503413f \
 //x=18.735 //y=3.51 //x2=17.88 //y2=2.26
cc_1038 ( Q N_noxref_11_c_1906_n ) capacitor c=0.0761604f //x=18.62 //y=2.4 \
 //x2=17.88 //y2=2.26
cc_1039 ( N_Q_c_1583_n N_noxref_11_c_1906_n ) capacitor c=0.0165015f \
 //x=18.095 //y=1.835 //x2=17.88 //y2=2.26
cc_1040 ( N_Q_c_1592_n N_noxref_11_c_1906_n ) capacitor c=0.001003f //x=20.47 \
 //y=2.26 //x2=17.88 //y2=2.26
cc_1041 ( N_Q_c_1602_n N_noxref_11_c_1908_n ) capacitor c=0.00431513f \
 //x=20.805 //y=1.43 //x2=21.425 //y2=1.835
cc_1042 ( N_Q_c_1574_n N_noxref_11_c_1983_n ) capacitor c=8.73015e-19 \
 //x=20.355 //y=3.51 //x2=20.625 //y2=1.835
cc_1043 ( N_Q_c_1592_n N_noxref_11_c_1983_n ) capacitor c=0.011f //x=20.47 \
 //y=2.26 //x2=20.625 //y2=1.835
cc_1044 ( N_Q_c_1597_n N_noxref_11_c_1983_n ) capacitor c=0.00589082f \
 //x=20.275 //y=2.095 //x2=20.625 //y2=1.835
cc_1045 ( Q N_noxref_11_c_1916_n ) capacitor c=3.5517e-19 //x=18.62 //y=2.4 \
 //x2=21.95 //y2=3.88
cc_1046 ( N_Q_c_1592_n N_noxref_11_c_1916_n ) capacitor c=0.00391834f \
 //x=20.47 //y=2.26 //x2=21.95 //y2=3.88
cc_1047 ( N_Q_c_1614_n N_noxref_11_M30_noxref_g ) capacitor c=0.0132788f \
 //x=18.225 //y=5.39 //x2=17.92 //y2=6.205
cc_1048 ( N_Q_c_1612_n N_noxref_11_M31_noxref_g ) capacitor c=0.0193734f \
 //x=18.535 //y=5.39 //x2=18.36 //y2=6.205
cc_1049 ( N_Q_M30_noxref_d N_noxref_11_M31_noxref_g ) capacitor c=0.0136385f \
 //x=17.995 //y=5.205 //x2=18.36 //y2=6.205
cc_1050 ( N_Q_M9_noxref_d N_noxref_11_c_1917_n ) capacitor c=0.00226395f \
 //x=17.99 //y=1.085 //x2=17.915 //y2=1.085
cc_1051 ( N_Q_M9_noxref_d N_noxref_11_c_1956_n ) capacitor c=0.0035101f \
 //x=17.99 //y=1.085 //x2=17.915 //y2=1.435
cc_1052 ( N_Q_c_1583_n N_noxref_11_c_1959_n ) capacitor c=0.0021898f \
 //x=18.095 //y=1.835 //x2=17.915 //y2=1.74
cc_1053 ( N_Q_M8_noxref_d N_noxref_11_c_1959_n ) capacitor c=0.00148728f \
 //x=17.02 //y=1.085 //x2=17.915 //y2=1.74
cc_1054 ( N_Q_M9_noxref_d N_noxref_11_c_1959_n ) capacitor c=0.00546704f \
 //x=17.99 //y=1.085 //x2=17.915 //y2=1.74
cc_1055 ( Q N_noxref_11_c_1996_n ) capacitor c=0.0144455f //x=18.62 //y=2.4 \
 //x2=18.285 //y2=4.975
cc_1056 ( N_Q_c_1614_n N_noxref_11_c_1996_n ) capacitor c=0.00405122f \
 //x=18.225 //y=5.39 //x2=18.285 //y2=4.975
cc_1057 ( N_Q_M9_noxref_d N_noxref_11_c_1919_n ) capacitor c=0.00241102f \
 //x=17.99 //y=1.085 //x2=18.29 //y2=0.93
cc_1058 ( N_Q_c_1587_n N_noxref_11_c_1920_n ) capacitor c=0.00801563f \
 //x=18.535 //y=1.835 //x2=18.29 //y2=1.585
cc_1059 ( N_Q_M9_noxref_d N_noxref_11_c_1920_n ) capacitor c=0.0158021f \
 //x=17.99 //y=1.085 //x2=18.29 //y2=1.585
cc_1060 ( N_Q_M9_noxref_d N_noxref_11_c_1921_n ) capacitor c=0.00132831f \
 //x=17.99 //y=1.085 //x2=18.445 //y2=1.085
cc_1061 ( N_Q_M9_noxref_d N_noxref_11_c_1963_n ) capacitor c=0.0035101f \
 //x=17.99 //y=1.085 //x2=18.445 //y2=1.435
cc_1062 ( Q N_noxref_11_c_1964_n ) capacitor c=0.00877984f //x=18.62 //y=2.4 \
 //x2=17.88 //y2=2.26
cc_1063 ( N_Q_c_1583_n N_noxref_11_c_1964_n ) capacitor c=0.00635719f \
 //x=18.095 //y=1.835 //x2=17.88 //y2=2.26
cc_1064 ( Q N_noxref_11_c_1966_n ) capacitor c=0.00306024f //x=18.62 //y=2.4 \
 //x2=17.88 //y2=2.095
cc_1065 ( N_Q_c_1583_n N_noxref_11_c_1966_n ) capacitor c=0.0189722f \
 //x=18.095 //y=1.835 //x2=17.88 //y2=2.095
cc_1066 ( N_Q_M9_noxref_d N_noxref_11_c_1966_n ) capacitor c=3.4952e-19 \
 //x=17.99 //y=1.085 //x2=17.88 //y2=2.095
cc_1067 ( Q N_noxref_11_c_1967_n ) capacitor c=0.00537091f //x=18.62 //y=2.4 \
 //x2=17.915 //y2=4.885
cc_1068 ( N_Q_c_1595_n N_noxref_11_M10_noxref_d ) capacitor c=0.0013184f \
 //x=20.275 //y=1.085 //x2=20.35 //y2=1.085
cc_1069 ( N_Q_c_1662_p N_noxref_11_M10_noxref_d ) capacitor c=0.0034598f \
 //x=20.275 //y=1.43 //x2=20.35 //y2=1.085
cc_1070 ( N_Q_c_1663_p N_noxref_11_M10_noxref_d ) capacitor c=0.00300148f \
 //x=20.275 //y=1.74 //x2=20.35 //y2=1.085
cc_1071 ( N_Q_c_1597_n N_noxref_11_M10_noxref_d ) capacitor c=0.00273686f \
 //x=20.275 //y=2.095 //x2=20.35 //y2=1.085
cc_1072 ( N_Q_c_1599_n N_noxref_11_M10_noxref_d ) capacitor c=0.00241102f \
 //x=20.65 //y=0.93 //x2=20.35 //y2=1.085
cc_1073 ( N_Q_c_1720_p N_noxref_11_M10_noxref_d ) capacitor c=0.0123304f \
 //x=20.65 //y=1.585 //x2=20.35 //y2=1.085
cc_1074 ( N_Q_c_1600_n N_noxref_11_M10_noxref_d ) capacitor c=0.00219619f \
 //x=20.805 //y=1.085 //x2=20.35 //y2=1.085
cc_1075 ( N_Q_c_1602_n N_noxref_11_M10_noxref_d ) capacitor c=0.00603828f \
 //x=20.805 //y=1.43 //x2=20.35 //y2=1.085
cc_1076 ( N_Q_c_1614_n N_noxref_15_c_2222_n ) capacitor c=0.0348754f \
 //x=18.225 //y=5.39 //x2=17.615 //y2=5.39
cc_1077 ( N_Q_c_1612_n N_noxref_15_c_2229_n ) capacitor c=0.00163797f \
 //x=18.535 //y=5.39 //x2=18.495 //y2=7.09
cc_1078 ( N_Q_M30_noxref_d N_noxref_15_c_2229_n ) capacitor c=0.0117542f \
 //x=17.995 //y=5.205 //x2=18.495 //y2=7.09
cc_1079 ( N_Q_M30_noxref_d N_noxref_15_M28_noxref_s ) capacitor c=0.00107541f \
 //x=17.995 //y=5.205 //x2=16.685 //y2=5.205
cc_1080 ( N_Q_M30_noxref_d N_noxref_15_M29_noxref_d ) capacitor c=0.0348754f \
 //x=17.995 //y=5.205 //x2=17.555 //y2=5.205
cc_1081 ( N_Q_c_1612_n N_noxref_15_M31_noxref_d ) capacitor c=0.0154581f \
 //x=18.535 //y=5.39 //x2=18.435 //y2=5.205
cc_1082 ( N_Q_M30_noxref_d N_noxref_15_M31_noxref_d ) capacitor c=0.0458293f \
 //x=17.995 //y=5.205 //x2=18.435 //y2=5.205
cc_1083 ( N_Q_c_1616_n N_noxref_16_c_2265_n ) capacitor c=0.00598167f \
 //x=20.315 //y=4.885 //x2=20.945 //y2=5.39
cc_1084 ( N_Q_M32_noxref_g N_noxref_16_c_2265_n ) capacitor c=0.0182391f \
 //x=20.37 //y=6.205 //x2=20.945 //y2=5.39
cc_1085 ( N_Q_M33_noxref_g N_noxref_16_c_2265_n ) capacitor c=0.0179851f \
 //x=20.81 //y=6.205 //x2=20.945 //y2=5.39
cc_1086 ( N_Q_c_1648_p N_noxref_16_c_2265_n ) capacitor c=0.00364886f \
 //x=20.735 //y=4.975 //x2=20.945 //y2=5.39
cc_1087 ( N_Q_c_1624_n N_noxref_16_c_2265_n ) capacitor c=0.0017421f \
 //x=20.315 //y=4.885 //x2=20.945 //y2=5.39
cc_1088 ( N_Q_c_1612_n N_noxref_16_c_2269_n ) capacitor c=2.91997e-19 \
 //x=18.535 //y=5.39 //x2=20.235 //y2=5.39
cc_1089 ( N_Q_c_1616_n N_noxref_16_c_2269_n ) capacitor c=0.0118149f \
 //x=20.315 //y=4.885 //x2=20.235 //y2=5.39
cc_1090 ( N_Q_c_1624_n N_noxref_16_c_2269_n ) capacitor c=0.00521692f \
 //x=20.315 //y=4.885 //x2=20.235 //y2=5.39
cc_1091 ( N_Q_M32_noxref_g N_noxref_16_M32_noxref_s ) capacitor c=0.0473218f \
 //x=20.37 //y=6.205 //x2=20.015 //y2=5.205
cc_1092 ( N_Q_M30_noxref_d N_noxref_16_M32_noxref_s ) capacitor c=4.36987e-19 \
 //x=17.995 //y=5.205 //x2=20.015 //y2=5.205
cc_1093 ( N_Q_M33_noxref_g N_noxref_16_M33_noxref_d ) capacitor c=0.0170604f \
 //x=20.81 //y=6.205 //x2=20.885 //y2=5.205
cc_1094 ( N_noxref_10_c_1741_n N_noxref_11_c_1903_n ) capacitor c=0.304105f \
 //x=21.095 //y=4.25 //x2=21.835 //y2=3.88
cc_1095 ( N_noxref_10_c_1746_n N_noxref_11_c_1903_n ) capacitor c=0.0254944f \
 //x=21.21 //y=2.26 //x2=21.835 //y2=3.88
cc_1096 ( N_noxref_10_c_1859_p N_noxref_11_c_1903_n ) capacitor c=0.00618637f \
 //x=21.615 //y=4.975 //x2=21.835 //y2=3.88
cc_1097 ( N_noxref_10_c_1854_n N_noxref_11_c_1903_n ) capacitor c=4.87994e-19 \
 //x=21.245 //y=4.885 //x2=21.835 //y2=3.88
cc_1098 ( N_noxref_10_c_1741_n N_noxref_11_c_1905_n ) capacitor c=0.0290123f \
 //x=21.095 //y=4.25 //x2=17.995 //y2=3.88
cc_1099 ( N_noxref_10_c_1741_n N_noxref_11_c_1945_n ) capacitor c=0.00139965f \
 //x=21.095 //y=4.25 //x2=17.88 //y2=4.72
cc_1100 ( N_noxref_10_c_1741_n N_noxref_11_c_1906_n ) capacitor c=0.0226474f \
 //x=21.095 //y=4.25 //x2=17.88 //y2=2.26
cc_1101 ( N_noxref_10_c_1745_n N_noxref_11_c_1906_n ) capacitor c=0.00120654f \
 //x=15.29 //y=4.25 //x2=17.88 //y2=2.26
cc_1102 ( N_noxref_10_c_1746_n N_noxref_11_c_1908_n ) capacitor c=0.0165035f \
 //x=21.21 //y=2.26 //x2=21.425 //y2=1.835
cc_1103 ( N_noxref_10_c_1846_n N_noxref_11_c_1908_n ) capacitor c=0.0021898f \
 //x=21.245 //y=1.74 //x2=21.425 //y2=1.835
cc_1104 ( N_noxref_10_c_1851_n N_noxref_11_c_1908_n ) capacitor c=0.00635719f \
 //x=21.21 //y=2.26 //x2=21.425 //y2=1.835
cc_1105 ( N_noxref_10_c_1853_n N_noxref_11_c_1908_n ) capacitor c=0.0189735f \
 //x=21.21 //y=2.095 //x2=21.425 //y2=1.835
cc_1106 ( N_noxref_10_M35_noxref_g N_noxref_11_c_1933_n ) capacitor \
 c=0.0201101f //x=21.69 //y=6.205 //x2=21.865 //y2=5.39
cc_1107 ( N_noxref_10_M34_noxref_g N_noxref_11_c_1935_n ) capacitor \
 c=0.0132788f //x=21.25 //y=6.205 //x2=21.555 //y2=5.39
cc_1108 ( N_noxref_10_c_1859_p N_noxref_11_c_1935_n ) capacitor c=0.00417892f \
 //x=21.615 //y=4.975 //x2=21.555 //y2=5.39
cc_1109 ( N_noxref_10_c_1751_n N_noxref_11_c_1912_n ) capacitor c=0.00801563f \
 //x=21.62 //y=1.585 //x2=21.865 //y2=1.835
cc_1110 ( N_noxref_10_c_1741_n N_noxref_11_c_1916_n ) capacitor c=0.00642908f \
 //x=21.095 //y=4.25 //x2=21.95 //y2=3.88
cc_1111 ( N_noxref_10_c_1831_n N_noxref_11_c_1916_n ) capacitor c=0.0102183f \
 //x=21.21 //y=4.72 //x2=21.95 //y2=3.88
cc_1112 ( N_noxref_10_c_1746_n N_noxref_11_c_1916_n ) capacitor c=0.0788359f \
 //x=21.21 //y=2.26 //x2=21.95 //y2=3.88
cc_1113 ( N_noxref_10_c_1859_p N_noxref_11_c_1916_n ) capacitor c=0.0144455f \
 //x=21.615 //y=4.975 //x2=21.95 //y2=3.88
cc_1114 ( N_noxref_10_c_1851_n N_noxref_11_c_1916_n ) capacitor c=0.00877984f \
 //x=21.21 //y=2.26 //x2=21.95 //y2=3.88
cc_1115 ( N_noxref_10_c_1853_n N_noxref_11_c_1916_n ) capacitor c=0.00306024f \
 //x=21.21 //y=2.095 //x2=21.95 //y2=3.88
cc_1116 ( N_noxref_10_c_1854_n N_noxref_11_c_1916_n ) capacitor c=0.00537091f \
 //x=21.245 //y=4.885 //x2=21.95 //y2=3.88
cc_1117 ( N_noxref_10_c_1741_n N_noxref_11_c_1996_n ) capacitor c=0.00742954f \
 //x=21.095 //y=4.25 //x2=18.285 //y2=4.975
cc_1118 ( N_noxref_10_c_1741_n N_noxref_11_c_1967_n ) capacitor c=0.00136049f \
 //x=21.095 //y=4.25 //x2=17.915 //y2=4.885
cc_1119 ( N_noxref_10_c_1846_n N_noxref_11_M10_noxref_d ) capacitor \
 c=0.00148728f //x=21.245 //y=1.74 //x2=20.35 //y2=1.085
cc_1120 ( N_noxref_10_c_1748_n N_noxref_11_M11_noxref_d ) capacitor \
 c=0.00226395f //x=21.245 //y=1.085 //x2=21.32 //y2=1.085
cc_1121 ( N_noxref_10_c_1843_n N_noxref_11_M11_noxref_d ) capacitor \
 c=0.0035101f //x=21.245 //y=1.435 //x2=21.32 //y2=1.085
cc_1122 ( N_noxref_10_c_1846_n N_noxref_11_M11_noxref_d ) capacitor \
 c=0.00546704f //x=21.245 //y=1.74 //x2=21.32 //y2=1.085
cc_1123 ( N_noxref_10_c_1750_n N_noxref_11_M11_noxref_d ) capacitor \
 c=0.00241102f //x=21.62 //y=0.93 //x2=21.32 //y2=1.085
cc_1124 ( N_noxref_10_c_1751_n N_noxref_11_M11_noxref_d ) capacitor \
 c=0.0158021f //x=21.62 //y=1.585 //x2=21.32 //y2=1.085
cc_1125 ( N_noxref_10_c_1752_n N_noxref_11_M11_noxref_d ) capacitor \
 c=0.00132831f //x=21.775 //y=1.085 //x2=21.32 //y2=1.085
cc_1126 ( N_noxref_10_c_1850_n N_noxref_11_M11_noxref_d ) capacitor \
 c=0.0035101f //x=21.775 //y=1.435 //x2=21.32 //y2=1.085
cc_1127 ( N_noxref_10_c_1853_n N_noxref_11_M11_noxref_d ) capacitor \
 c=3.4952e-19 //x=21.21 //y=2.095 //x2=21.32 //y2=1.085
cc_1128 ( N_noxref_10_M35_noxref_g N_noxref_11_M34_noxref_d ) capacitor \
 c=0.0136385f //x=21.69 //y=6.205 //x2=21.325 //y2=5.205
cc_1129 ( N_noxref_10_c_1741_n N_noxref_15_c_2222_n ) capacitor c=0.0142961f \
 //x=21.095 //y=4.25 //x2=17.615 //y2=5.39
cc_1130 ( N_noxref_10_c_1741_n N_noxref_15_c_2227_n ) capacitor c=0.0037532f \
 //x=21.095 //y=4.25 //x2=16.905 //y2=5.39
cc_1131 ( N_noxref_10_c_1741_n N_noxref_15_c_2229_n ) capacitor c=3.11234e-19 \
 //x=21.095 //y=4.25 //x2=18.495 //y2=7.09
cc_1132 ( N_noxref_10_c_1741_n N_noxref_16_c_2265_n ) capacitor c=0.0145703f \
 //x=21.095 //y=4.25 //x2=20.945 //y2=5.39
cc_1133 ( N_noxref_10_M34_noxref_g N_noxref_16_c_2265_n ) capacitor \
 c=0.0170604f //x=21.25 //y=6.205 //x2=20.945 //y2=5.39
cc_1134 ( N_noxref_10_c_1854_n N_noxref_16_c_2265_n ) capacitor c=2.28171e-19 \
 //x=21.245 //y=4.885 //x2=20.945 //y2=5.39
cc_1135 ( N_noxref_10_c_1741_n N_noxref_16_c_2269_n ) capacitor c=0.0037532f \
 //x=21.095 //y=4.25 //x2=20.235 //y2=5.39
cc_1136 ( N_noxref_10_c_1831_n N_noxref_16_c_2270_n ) capacitor c=8.01329e-19 \
 //x=21.21 //y=4.72 //x2=21.825 //y2=7.09
cc_1137 ( N_noxref_10_M34_noxref_g N_noxref_16_c_2270_n ) capacitor \
 c=0.0148439f //x=21.25 //y=6.205 //x2=21.825 //y2=7.09
cc_1138 ( N_noxref_10_M35_noxref_g N_noxref_16_c_2270_n ) capacitor \
 c=0.0163195f //x=21.69 //y=6.205 //x2=21.825 //y2=7.09
cc_1139 ( N_noxref_10_M35_noxref_g N_noxref_16_M35_noxref_d ) capacitor \
 c=0.0351101f //x=21.69 //y=6.205 //x2=21.765 //y2=5.205
cc_1140 ( N_noxref_11_M30_noxref_g N_noxref_15_c_2222_n ) capacitor \
 c=0.0170604f //x=17.92 //y=6.205 //x2=17.615 //y2=5.39
cc_1141 ( N_noxref_11_c_1967_n N_noxref_15_c_2222_n ) capacitor c=2.28218e-19 \
 //x=17.915 //y=4.885 //x2=17.615 //y2=5.39
cc_1142 ( N_noxref_11_c_1945_n N_noxref_15_c_2229_n ) capacitor c=8.02844e-19 \
 //x=17.88 //y=4.72 //x2=18.495 //y2=7.09
cc_1143 ( N_noxref_11_M30_noxref_g N_noxref_15_c_2229_n ) capacitor \
 c=0.0148443f //x=17.92 //y=6.205 //x2=18.495 //y2=7.09
cc_1144 ( N_noxref_11_M31_noxref_g N_noxref_15_c_2229_n ) capacitor \
 c=0.0163191f //x=18.36 //y=6.205 //x2=18.495 //y2=7.09
cc_1145 ( N_noxref_11_M31_noxref_g N_noxref_15_M31_noxref_d ) capacitor \
 c=0.0351101f //x=18.36 //y=6.205 //x2=18.435 //y2=5.205
cc_1146 ( N_noxref_11_c_1935_n N_noxref_16_c_2265_n ) capacitor c=0.0348754f \
 //x=21.555 //y=5.39 //x2=20.945 //y2=5.39
cc_1147 ( N_noxref_11_c_1933_n N_noxref_16_c_2270_n ) capacitor c=0.00165939f \
 //x=21.865 //y=5.39 //x2=21.825 //y2=7.09
cc_1148 ( N_noxref_11_M34_noxref_d N_noxref_16_c_2270_n ) capacitor \
 c=0.011777f //x=21.325 //y=5.205 //x2=21.825 //y2=7.09
cc_1149 ( N_noxref_11_M34_noxref_d N_noxref_16_M32_noxref_s ) capacitor \
 c=0.00107541f //x=21.325 //y=5.205 //x2=20.015 //y2=5.205
cc_1150 ( N_noxref_11_M34_noxref_d N_noxref_16_M33_noxref_d ) capacitor \
 c=0.0348754f //x=21.325 //y=5.205 //x2=20.885 //y2=5.205
cc_1151 ( N_noxref_11_c_1933_n N_noxref_16_M35_noxref_d ) capacitor \
 c=0.0156425f //x=21.865 //y=5.39 //x2=21.765 //y2=5.205
cc_1152 ( N_noxref_11_M34_noxref_d N_noxref_16_M35_noxref_d ) capacitor \
 c=0.0458293f //x=21.325 //y=5.205 //x2=21.765 //y2=5.205
cc_1153 ( N_noxref_15_M31_noxref_d N_noxref_16_M32_noxref_s ) capacitor \
 c=0.00195151f //x=18.435 //y=5.205 //x2=20.015 //y2=5.205
