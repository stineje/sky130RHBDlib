// File: nmos_bottom.spi.pex
// Created: Thu Jan 22 07:14:30 2026
// Program "Calibre xRC"
// Version "v2023.2_27.15"
// Nominal Temperature: 30C
// Circuit Temperature: 30C
//
simulator lang=spectre
