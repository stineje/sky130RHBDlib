// File: nmos_bottom.spi.pex
// Created: Tue Apr 29 10:50:56 2025
// Program "Calibre xRC"
// Version "v2023.2_27.15"
// Nominal Temperature: 30C
// Circuit Temperature: 30C
//
simulator lang=spectre
