// File: VOTERN3X1.spi.pex
// Created: Thu Jan 22 07:10:40 2026
// Program "Calibre xRC"
// Version "v2023.2_27.15"
// Nominal Temperature: 30C
// Circuit Temperature: 30C
//
simulator lang=spectre
subckt PM_VOTERN3X1\%B ( 1 2 3 4 5 6 7 8 9 10 11 12 19 37 42 43 46 51 57 62 67 \
 68 69 70 71 72 73 74 75 76 80 82 85 86 87 88 92 93 94 95 99 101 107 108 110 \
 123 )
c231 ( 123 0 ) capacitor c=0.0692896f //x=4.93 //y=4.885
c232 ( 110 0 ) capacitor c=0.0603371f //x=1.23 //y=2.26
c233 ( 108 0 ) capacitor c=0.0344584f //x=5.265 //y=1.39
c234 ( 107 0 ) capacitor c=0.0188421f //x=5.265 //y=1.045
c235 ( 101 0 ) capacitor c=0.0141798f //x=5.11 //y=1.545
c236 ( 99 0 ) capacitor c=0.0160622f //x=5.11 //y=0.89
c237 ( 95 0 ) capacitor c=0.103881f //x=4.735 //y=2.095
c238 ( 94 0 ) capacitor c=0.0227978f //x=4.735 //y=1.7
c239 ( 93 0 ) capacitor c=0.0234352f //x=4.735 //y=1.39
c240 ( 92 0 ) capacitor c=0.0200371f //x=4.735 //y=1.045
c241 ( 88 0 ) capacitor c=0.0318956f //x=1.935 //y=1.39
c242 ( 87 0 ) capacitor c=0.0186809f //x=1.935 //y=1.045
c243 ( 86 0 ) capacitor c=0.0624333f //x=1.575 //y=4.975
c244 ( 85 0 ) capacitor c=0.0375163f //x=1.865 //y=4.975
c245 ( 82 0 ) capacitor c=0.0157936f //x=1.78 //y=1.545
c246 ( 80 0 ) capacitor c=0.0158553f //x=1.78 //y=0.89
c247 ( 76 0 ) capacitor c=0.0302441f //x=1.405 //y=2.095
c248 ( 75 0 ) capacitor c=0.0238107f //x=1.405 //y=1.7
c249 ( 74 0 ) capacitor c=0.0234359f //x=1.405 //y=1.39
c250 ( 73 0 ) capacitor c=0.0199332f //x=1.405 //y=1.045
c251 ( 72 0 ) capacitor c=0.111167f //x=5.26 //y=6.205
c252 ( 71 0 ) capacitor c=0.154978f //x=4.82 //y=6.205
c253 ( 70 0 ) capacitor c=0.110282f //x=1.94 //y=6.205
c254 ( 69 0 ) capacitor c=0.155219f //x=1.5 //y=6.205
c255 ( 62 0 ) capacitor c=0.0156727f //x=4.93 //y=4.62
c256 ( 57 0 ) capacitor c=0.00133484f //x=4.93 //y=2.26
c257 ( 51 0 ) capacitor c=0.0125733f //x=1.23 //y=4.62
c258 ( 46 0 ) capacitor c=7.43216e-19 //x=1.23 //y=2.26
c259 ( 43 0 ) capacitor c=0.0876578f //x=4.775 //y=4.64
c260 ( 42 0 ) capacitor c=0.00642399f //x=4.935 //y=4.64
c261 ( 37 0 ) capacitor c=0.00920482f //x=1.395 //y=4.62
c262 ( 19 0 ) capacitor c=0.00894425f //x=4.93 //y=2.385
c263 ( 12 0 ) capacitor c=0.0100386f //x=1.23 //y=2.375
c264 ( 11 0 ) capacitor c=0.0127073f //x=4.93 //y=4.62
c265 ( 10 0 ) capacitor c=0.0139929f //x=1.23 //y=4.62
c266 ( 6 0 ) capacitor c=0.0851523f //x=4.93 //y=2.77
c267 ( 1 0 ) capacitor c=0.0996103f //x=1.23 //y=2.77
r268 (  121 123 ) resistor r=22.7554 //w=0.233 //l=0.11 //layer=ply \
 //thickness=0.18 //x=4.82 //y=4.885 //x2=4.93 //y2=4.885
r269 (  108 125 ) resistor r=45.1352 //w=0.168 //l=0.173853 //layer=ply \
 //thickness=0.18 //x=5.265 //y=1.39 //x2=5.225 //y2=1.545
r270 (  107 124 ) resistor r=45.1352 //w=0.168 //l=0.173853 //layer=ply \
 //thickness=0.18 //x=5.265 //y=1.045 //x2=5.225 //y2=0.89
r271 (  107 108 ) resistor r=176.904 //w=0.094 //l=0.345 //layer=ply \
 //thickness=0.18 //x=5.265 //y=1.045 //x2=5.265 //y2=1.39
r272 (  104 123 ) resistor r=68.2661 //w=0.233 //l=0.404166 //layer=ply \
 //thickness=0.18 //x=5.26 //y=5.05 //x2=4.93 //y2=4.885
r273 (  102 120 ) resistor r=10.701 //w=0.21 //l=0.115 //layer=ply \
 //thickness=0.18 //x=4.89 //y=1.545 //x2=4.775 //y2=1.545
r274 (  101 125 ) resistor r=5.52526 //w=0.168 //l=0.115 //layer=ply \
 //thickness=0.18 //x=5.11 //y=1.545 //x2=5.225 //y2=1.545
r275 (  100 119 ) resistor r=5.52526 //w=0.168 //l=0.115 //layer=ply \
 //thickness=0.18 //x=4.89 //y=0.89 //x2=4.775 //y2=0.89
r276 (  99 124 ) resistor r=5.52526 //w=0.168 //l=0.115 //layer=ply \
 //thickness=0.18 //x=5.11 //y=0.89 //x2=5.225 //y2=0.89
r277 (  99 100 ) resistor r=112.809 //w=0.094 //l=0.22 //layer=ply \
 //thickness=0.18 //x=5.11 //y=0.89 //x2=4.89 //y2=0.89
r278 (  96 121 ) resistor r=13.0941 //w=0.233 //l=0.165 //layer=ply \
 //thickness=0.18 //x=4.82 //y=5.05 //x2=4.82 //y2=4.885
r279 (  95 118 ) resistor r=34.8111 //w=0.27 //l=0.264953 //layer=ply \
 //thickness=0.18 //x=4.735 //y=2.095 //x2=4.93 //y2=2.26
r280 (  94 120 ) resistor r=39.5823 //w=0.21 //l=0.173853 //layer=ply \
 //thickness=0.18 //x=4.735 //y=1.7 //x2=4.775 //y2=1.545
r281 (  94 95 ) resistor r=202.543 //w=0.094 //l=0.395 //layer=ply \
 //thickness=0.18 //x=4.735 //y=1.7 //x2=4.735 //y2=2.095
r282 (  93 120 ) resistor r=39.5823 //w=0.21 //l=0.173853 //layer=ply \
 //thickness=0.18 //x=4.735 //y=1.39 //x2=4.775 //y2=1.545
r283 (  92 119 ) resistor r=45.1352 //w=0.168 //l=0.173853 //layer=ply \
 //thickness=0.18 //x=4.735 //y=1.045 //x2=4.775 //y2=0.89
r284 (  92 93 ) resistor r=176.904 //w=0.094 //l=0.345 //layer=ply \
 //thickness=0.18 //x=4.735 //y=1.045 //x2=4.735 //y2=1.39
r285 (  88 116 ) resistor r=45.1352 //w=0.168 //l=0.173853 //layer=ply \
 //thickness=0.18 //x=1.935 //y=1.39 //x2=1.895 //y2=1.545
r286 (  87 115 ) resistor r=45.1352 //w=0.168 //l=0.173853 //layer=ply \
 //thickness=0.18 //x=1.935 //y=1.045 //x2=1.895 //y2=0.89
r287 (  87 88 ) resistor r=176.904 //w=0.094 //l=0.345 //layer=ply \
 //thickness=0.18 //x=1.935 //y=1.045 //x2=1.935 //y2=1.39
r288 (  85 89 ) resistor r=26.9307 //w=0.15 //l=0.106066 //layer=ply \
 //thickness=0.18 //x=1.865 //y=4.975 //x2=1.94 //y2=5.05
r289 (  85 86 ) resistor r=148.702 //w=0.094 //l=0.29 //layer=ply \
 //thickness=0.18 //x=1.865 //y=4.975 //x2=1.575 //y2=4.975
r290 (  83 114 ) resistor r=10.701 //w=0.21 //l=0.115 //layer=ply \
 //thickness=0.18 //x=1.56 //y=1.545 //x2=1.445 //y2=1.545
r291 (  82 116 ) resistor r=5.52526 //w=0.168 //l=0.115 //layer=ply \
 //thickness=0.18 //x=1.78 //y=1.545 //x2=1.895 //y2=1.545
r292 (  81 113 ) resistor r=5.52526 //w=0.168 //l=0.115 //layer=ply \
 //thickness=0.18 //x=1.56 //y=0.89 //x2=1.445 //y2=0.89
r293 (  80 115 ) resistor r=5.52526 //w=0.168 //l=0.115 //layer=ply \
 //thickness=0.18 //x=1.78 //y=0.89 //x2=1.895 //y2=0.89
r294 (  80 81 ) resistor r=112.809 //w=0.094 //l=0.22 //layer=ply \
 //thickness=0.18 //x=1.78 //y=0.89 //x2=1.56 //y2=0.89
r295 (  77 86 ) resistor r=22.1787 //w=0.252 //l=0.106066 //layer=ply \
 //thickness=0.18 //x=1.5 //y=5.05 //x2=1.575 //y2=4.975
r296 (  77 112 ) resistor r=51.6429 //w=0.252 //l=0.34271 //layer=ply \
 //thickness=0.18 //x=1.5 //y=5.05 //x2=1.23 //y2=4.885
r297 (  76 110 ) resistor r=30.4513 //w=0.277 //l=0.243926 //layer=ply \
 //thickness=0.18 //x=1.405 //y=2.095 //x2=1.23 //y2=2.26
r298 (  75 114 ) resistor r=39.5823 //w=0.21 //l=0.173853 //layer=ply \
 //thickness=0.18 //x=1.405 //y=1.7 //x2=1.445 //y2=1.545
r299 (  75 76 ) resistor r=202.543 //w=0.094 //l=0.395 //layer=ply \
 //thickness=0.18 //x=1.405 //y=1.7 //x2=1.405 //y2=2.095
r300 (  74 114 ) resistor r=39.5823 //w=0.21 //l=0.173853 //layer=ply \
 //thickness=0.18 //x=1.405 //y=1.39 //x2=1.445 //y2=1.545
r301 (  73 113 ) resistor r=45.1352 //w=0.168 //l=0.173853 //layer=ply \
 //thickness=0.18 //x=1.405 //y=1.045 //x2=1.445 //y2=0.89
r302 (  73 74 ) resistor r=176.904 //w=0.094 //l=0.345 //layer=ply \
 //thickness=0.18 //x=1.405 //y=1.045 //x2=1.405 //y2=1.39
r303 (  72 104 ) resistor r=592.245 //w=0.094 //l=1.155 //layer=ply \
 //thickness=0.18 //x=5.26 //y=6.205 //x2=5.26 //y2=5.05
r304 (  71 96 ) resistor r=592.245 //w=0.094 //l=1.155 //layer=ply \
 //thickness=0.18 //x=4.82 //y=6.205 //x2=4.82 //y2=5.05
r305 (  70 89 ) resistor r=592.245 //w=0.094 //l=1.155 //layer=ply \
 //thickness=0.18 //x=1.94 //y=6.205 //x2=1.94 //y2=5.05
r306 (  69 77 ) resistor r=592.245 //w=0.094 //l=1.155 //layer=ply \
 //thickness=0.18 //x=1.5 //y=6.205 //x2=1.5 //y2=5.05
r307 (  68 101 ) resistor r=56.4043 //w=0.094 //l=0.11 //layer=ply \
 //thickness=0.18 //x=5 //y=1.545 //x2=5.11 //y2=1.545
r308 (  68 102 ) resistor r=56.4043 //w=0.094 //l=0.11 //layer=ply \
 //thickness=0.18 //x=5 //y=1.545 //x2=4.89 //y2=1.545
r309 (  67 82 ) resistor r=56.4043 //w=0.094 //l=0.11 //layer=ply \
 //thickness=0.18 //x=1.67 //y=1.545 //x2=1.78 //y2=1.545
r310 (  67 83 ) resistor r=56.4043 //w=0.094 //l=0.11 //layer=ply \
 //thickness=0.18 //x=1.67 //y=1.545 //x2=1.56 //y2=1.545
r311 (  65 123 ) resistor r=152 //w=0.17 //l=0.17 //layer=licon //count=1 \
 //x=4.93 //y=4.885 //x2=4.93 //y2=4.885
r312 (  62 65 ) resistor r=18.139 //w=0.187 //l=0.265 //layer=li \
 //thickness=0.1 //x=4.93 //y=4.62 //x2=4.93 //y2=4.885
r313 (  57 118 ) resistor r=152 //w=0.17 //l=0.17 //layer=licon //count=1 \
 //x=4.93 //y=2.26 //x2=4.93 //y2=2.26
r314 (  54 112 ) resistor r=152 //w=0.17 //l=0.17 //layer=licon //count=1 \
 //x=1.23 //y=4.885 //x2=1.23 //y2=4.885
r315 (  51 54 ) resistor r=18.139 //w=0.187 //l=0.265 //layer=li \
 //thickness=0.1 //x=1.23 //y=4.62 //x2=1.23 //y2=4.885
r316 (  46 110 ) resistor r=152 //w=0.17 //l=0.17 //layer=licon //count=1 \
 //x=1.23 //y=2.26 //x2=1.23 //y2=2.26
r317 (  42 43 ) resistor r=0.10734 //w=0.281 //l=0.16 //layer=m2 \
 //thickness=0.36 //x=4.935 //y=4.64 //x2=4.775 //y2=4.64
r318 (  37 39 ) resistor r=0.10734 //w=0.281 //l=0.16 //layer=m2 \
 //thickness=0.36 //x=1.395 //y=4.62 //x2=1.235 //y2=4.62
r319 (  37 43 ) resistor r=3.22519 //w=0.131 //l=3.38 //layer=m2 \
 //thickness=0.36 //x=1.395 //y=4.62 //x2=4.775 //y2=4.62
r320 (  35 57 ) resistor r=9.3 //w=0.17 //l=0.17 //layer=mcon //count=1 \
 //x=4.93 //y=2.26 //x2=4.93 //y2=2.26
r321 (  33 42 ) resistor r=4.5 //w=0.15 //l=0.15 //layer=via1 //count=1 \
 //x=4.935 //y=4.64 //x2=4.935 //y2=4.64
r322 (  26 46 ) resistor r=9.3 //w=0.17 //l=0.17 //layer=mcon //count=1 \
 //x=1.23 //y=2.26 //x2=1.23 //y2=2.26
r323 (  19 35 ) resistor r=0.0761125 //w=0.237 //l=0.126491 //layer=m1 \
 //thickness=0.36 //x=4.93 //y=2.385 //x2=4.927 //y2=2.26
r324 (  12 26 ) resistor r=0.0717383 //w=0.224 //l=0.115 //layer=m1 \
 //thickness=0.36 //x=1.23 //y=2.375 //x2=1.23 //y2=2.26
r325 (  11 62 ) resistor r=9.3 //w=0.17 //l=0.17 //layer=mcon //count=1 \
 //x=4.93 //y=4.62 //x2=4.93 //y2=4.62
r326 (  11 33 ) resistor r=0.00659631 //w=0.379 //l=0.02 //layer=m1 \
 //thickness=0.36 //x=4.88 //y=4.62 //x2=4.88 //y2=4.64
r327 (  11 20 ) resistor r=0.0863342 //w=0.379 //l=0.168152 //layer=m1 \
 //thickness=0.36 //x=4.88 //y=4.62 //x2=4.93 //y2=4.475
r328 (  10 51 ) resistor r=9.3 //w=0.17 //l=0.17 //layer=mcon //count=1 \
 //x=1.23 //y=4.62 //x2=1.23 //y2=4.62
r329 (  10 39 ) resistor r=4.5 //w=0.15 //l=0.15 //layer=via1 //count=1 \
 //x=1.235 //y=4.62 //x2=1.235 //y2=4.62
r330 (  10 13 ) resistor r=0.0898201 //w=0.322 //l=0.185472 //layer=m1 \
 //thickness=0.36 //x=1.285 //y=4.62 //x2=1.23 //y2=4.46
r331 (  9 20 ) resistor r=0.567748 //w=0.131 //l=0.595 //layer=m1 \
 //thickness=0.36 //x=4.93 //y=3.88 //x2=4.93 //y2=4.475
r332 (  8 9 ) resistor r=0.353053 //w=0.131 //l=0.37 //layer=m1 \
 //thickness=0.36 //x=4.93 //y=3.51 //x2=4.93 //y2=3.88
r333 (  7 8 ) resistor r=0.353053 //w=0.131 //l=0.37 //layer=m1 \
 //thickness=0.36 //x=4.93 //y=3.14 //x2=4.93 //y2=3.51
r334 (  6 7 ) resistor r=0.353053 //w=0.131 //l=0.37 //layer=m1 \
 //thickness=0.36 //x=4.93 //y=2.77 //x2=4.93 //y2=3.14
r335 (  6 19 ) resistor r=0.367366 //w=0.131 //l=0.385 //layer=m1 \
 //thickness=0.36 //x=4.93 //y=2.77 //x2=4.93 //y2=2.385
r336 (  5 13 ) resistor r=0.200382 //w=0.131 //l=0.21 //layer=m1 \
 //thickness=0.36 //x=1.23 //y=4.25 //x2=1.23 //y2=4.46
r337 (  4 5 ) resistor r=0.353053 //w=0.131 //l=0.37 //layer=m1 \
 //thickness=0.36 //x=1.23 //y=3.88 //x2=1.23 //y2=4.25
r338 (  3 4 ) resistor r=0.353053 //w=0.131 //l=0.37 //layer=m1 \
 //thickness=0.36 //x=1.23 //y=3.51 //x2=1.23 //y2=3.88
r339 (  2 3 ) resistor r=0.353053 //w=0.131 //l=0.37 //layer=m1 \
 //thickness=0.36 //x=1.23 //y=3.14 //x2=1.23 //y2=3.51
r340 (  1 2 ) resistor r=0.353053 //w=0.131 //l=0.37 //layer=m1 \
 //thickness=0.36 //x=1.23 //y=2.77 //x2=1.23 //y2=3.14
r341 (  1 12 ) resistor r=0.376908 //w=0.131 //l=0.395 //layer=m1 \
 //thickness=0.36 //x=1.23 //y=2.77 //x2=1.23 //y2=2.375
ends PM_VOTERN3X1\%B

subckt PM_VOTERN3X1\%C ( 1 2 3 4 5 6 7 8 9 10 11 12 18 19 42 44 45 48 53 58 63 \
 67 68 69 70 71 72 76 77 78 79 80 82 85 88 89 90 91 92 93 94 95 99 101 104 105 \
 106 107 120 )
c238 ( 120 0 ) capacitor c=0.0586737f //x=7.89 //y=2.26
c239 ( 107 0 ) capacitor c=0.0318956f //x=8.595 //y=1.39
c240 ( 106 0 ) capacitor c=0.0186809f //x=8.595 //y=1.045
c241 ( 105 0 ) capacitor c=0.0659968f //x=8.235 //y=4.975
c242 ( 104 0 ) capacitor c=0.0373387f //x=8.525 //y=4.975
c243 ( 101 0 ) capacitor c=0.0157936f //x=8.44 //y=1.545
c244 ( 99 0 ) capacitor c=0.0158553f //x=8.44 //y=0.89
c245 ( 95 0 ) capacitor c=0.0302441f //x=8.065 //y=2.095
c246 ( 94 0 ) capacitor c=0.0238107f //x=8.065 //y=1.7
c247 ( 93 0 ) capacitor c=0.0234359f //x=8.065 //y=1.39
c248 ( 92 0 ) capacitor c=0.0199332f //x=8.065 //y=1.045
c249 ( 91 0 ) capacitor c=0.0972519f //x=6.235 //y=2.095
c250 ( 90 0 ) capacitor c=0.0251353f //x=6.235 //y=1.74
c251 ( 89 0 ) capacitor c=0.0234318f //x=6.235 //y=1.43
c252 ( 88 0 ) capacitor c=0.0192547f //x=6.235 //y=1.085
c253 ( 85 0 ) capacitor c=0.0714656f //x=6.14 //y=5.05
c254 ( 82 0 ) capacitor c=0.0186579f //x=6.08 //y=1.585
c255 ( 80 0 ) capacitor c=0.0157803f //x=6.08 //y=0.93
c256 ( 79 0 ) capacitor c=0.0134011f //x=5.775 //y=4.975
c257 ( 78 0 ) capacitor c=0.0243282f //x=6.065 //y=4.975
c258 ( 77 0 ) capacitor c=0.0364928f //x=5.705 //y=1.43
c259 ( 76 0 ) capacitor c=0.0174823f //x=5.705 //y=1.085
c260 ( 72 0 ) capacitor c=0.11081f //x=8.6 //y=6.205
c261 ( 71 0 ) capacitor c=0.154997f //x=8.16 //y=6.205
c262 ( 70 0 ) capacitor c=0.155934f //x=6.14 //y=6.205
c263 ( 69 0 ) capacitor c=0.110594f //x=5.7 //y=6.205
c264 ( 63 0 ) capacitor c=7.7962e-19 //x=7.89 //y=4.885
c265 ( 58 0 ) capacitor c=7.89145e-19 //x=7.89 //y=2.26
c266 ( 53 0 ) capacitor c=7.79163e-19 //x=6.41 //y=4.885
c267 ( 48 0 ) capacitor c=7.43216e-19 //x=6.41 //y=2.26
c268 ( 45 0 ) capacitor c=0.0208859f //x=7.725 //y=2.27
c269 ( 44 0 ) capacitor c=0.00241177f //x=7.885 //y=2.27
c270 ( 42 0 ) capacitor c=0.0031771f //x=6.575 //y=2.27
c271 ( 19 0 ) capacitor c=0.00623797f //x=7.89 //y=4.755
c272 ( 18 0 ) capacitor c=0.00995077f //x=7.89 //y=2.43
c273 ( 12 0 ) capacitor c=0.00859821f //x=6.41 //y=4.76
c274 ( 11 0 ) capacitor c=0.0102822f //x=6.41 //y=2.43
c275 ( 6 0 ) capacitor c=0.0721899f //x=7.89 //y=2.77
c276 ( 1 0 ) capacitor c=0.0779094f //x=6.41 //y=2.77
r277 (  107 126 ) resistor r=45.1352 //w=0.168 //l=0.173853 //layer=ply \
 //thickness=0.18 //x=8.595 //y=1.39 //x2=8.555 //y2=1.545
r278 (  106 125 ) resistor r=45.1352 //w=0.168 //l=0.173853 //layer=ply \
 //thickness=0.18 //x=8.595 //y=1.045 //x2=8.555 //y2=0.89
r279 (  106 107 ) resistor r=176.904 //w=0.094 //l=0.345 //layer=ply \
 //thickness=0.18 //x=8.595 //y=1.045 //x2=8.595 //y2=1.39
r280 (  104 108 ) resistor r=26.9307 //w=0.15 //l=0.106066 //layer=ply \
 //thickness=0.18 //x=8.525 //y=4.975 //x2=8.6 //y2=5.05
r281 (  104 105 ) resistor r=148.702 //w=0.094 //l=0.29 //layer=ply \
 //thickness=0.18 //x=8.525 //y=4.975 //x2=8.235 //y2=4.975
r282 (  102 124 ) resistor r=10.701 //w=0.21 //l=0.115 //layer=ply \
 //thickness=0.18 //x=8.22 //y=1.545 //x2=8.105 //y2=1.545
r283 (  101 126 ) resistor r=5.52526 //w=0.168 //l=0.115 //layer=ply \
 //thickness=0.18 //x=8.44 //y=1.545 //x2=8.555 //y2=1.545
r284 (  100 123 ) resistor r=5.52526 //w=0.168 //l=0.115 //layer=ply \
 //thickness=0.18 //x=8.22 //y=0.89 //x2=8.105 //y2=0.89
r285 (  99 125 ) resistor r=5.52526 //w=0.168 //l=0.115 //layer=ply \
 //thickness=0.18 //x=8.44 //y=0.89 //x2=8.555 //y2=0.89
r286 (  99 100 ) resistor r=112.809 //w=0.094 //l=0.22 //layer=ply \
 //thickness=0.18 //x=8.44 //y=0.89 //x2=8.22 //y2=0.89
r287 (  96 105 ) resistor r=22.1787 //w=0.252 //l=0.106066 //layer=ply \
 //thickness=0.18 //x=8.16 //y=5.05 //x2=8.235 //y2=4.975
r288 (  96 122 ) resistor r=51.6429 //w=0.252 //l=0.34271 //layer=ply \
 //thickness=0.18 //x=8.16 //y=5.05 //x2=7.89 //y2=4.885
r289 (  95 120 ) resistor r=30.4513 //w=0.277 //l=0.243926 //layer=ply \
 //thickness=0.18 //x=8.065 //y=2.095 //x2=7.89 //y2=2.26
r290 (  94 124 ) resistor r=39.5823 //w=0.21 //l=0.173853 //layer=ply \
 //thickness=0.18 //x=8.065 //y=1.7 //x2=8.105 //y2=1.545
r291 (  94 95 ) resistor r=202.543 //w=0.094 //l=0.395 //layer=ply \
 //thickness=0.18 //x=8.065 //y=1.7 //x2=8.065 //y2=2.095
r292 (  93 124 ) resistor r=39.5823 //w=0.21 //l=0.173853 //layer=ply \
 //thickness=0.18 //x=8.065 //y=1.39 //x2=8.105 //y2=1.545
r293 (  92 123 ) resistor r=45.1352 //w=0.168 //l=0.173853 //layer=ply \
 //thickness=0.18 //x=8.065 //y=1.045 //x2=8.105 //y2=0.89
r294 (  92 93 ) resistor r=176.904 //w=0.094 //l=0.345 //layer=ply \
 //thickness=0.18 //x=8.065 //y=1.045 //x2=8.065 //y2=1.39
r295 (  91 116 ) resistor r=30.4513 //w=0.277 //l=0.243926 //layer=ply \
 //thickness=0.18 //x=6.235 //y=2.095 //x2=6.41 //y2=2.26
r296 (  90 114 ) resistor r=39.5823 //w=0.21 //l=0.173853 //layer=ply \
 //thickness=0.18 //x=6.235 //y=1.74 //x2=6.195 //y2=1.585
r297 (  90 91 ) resistor r=182.032 //w=0.094 //l=0.355 //layer=ply \
 //thickness=0.18 //x=6.235 //y=1.74 //x2=6.235 //y2=2.095
r298 (  89 114 ) resistor r=39.5823 //w=0.21 //l=0.173853 //layer=ply \
 //thickness=0.18 //x=6.235 //y=1.43 //x2=6.195 //y2=1.585
r299 (  88 113 ) resistor r=45.1352 //w=0.168 //l=0.173853 //layer=ply \
 //thickness=0.18 //x=6.235 //y=1.085 //x2=6.195 //y2=0.93
r300 (  88 89 ) resistor r=176.904 //w=0.094 //l=0.345 //layer=ply \
 //thickness=0.18 //x=6.235 //y=1.085 //x2=6.235 //y2=1.43
r301 (  85 118 ) resistor r=51.6429 //w=0.252 //l=0.34271 //layer=ply \
 //thickness=0.18 //x=6.14 //y=5.05 //x2=6.41 //y2=4.885
r302 (  83 112 ) resistor r=5.52526 //w=0.168 //l=0.115 //layer=ply \
 //thickness=0.18 //x=5.86 //y=1.585 //x2=5.745 //y2=1.585
r303 (  82 114 ) resistor r=10.701 //w=0.21 //l=0.115 //layer=ply \
 //thickness=0.18 //x=6.08 //y=1.585 //x2=6.195 //y2=1.585
r304 (  81 111 ) resistor r=5.52526 //w=0.168 //l=0.115 //layer=ply \
 //thickness=0.18 //x=5.86 //y=0.93 //x2=5.745 //y2=0.93
r305 (  80 113 ) resistor r=5.52526 //w=0.168 //l=0.115 //layer=ply \
 //thickness=0.18 //x=6.08 //y=0.93 //x2=6.195 //y2=0.93
r306 (  80 81 ) resistor r=112.809 //w=0.094 //l=0.22 //layer=ply \
 //thickness=0.18 //x=6.08 //y=0.93 //x2=5.86 //y2=0.93
r307 (  78 85 ) resistor r=22.1787 //w=0.252 //l=0.106066 //layer=ply \
 //thickness=0.18 //x=6.065 //y=4.975 //x2=6.14 //y2=5.05
r308 (  78 79 ) resistor r=148.702 //w=0.094 //l=0.29 //layer=ply \
 //thickness=0.18 //x=6.065 //y=4.975 //x2=5.775 //y2=4.975
r309 (  77 112 ) resistor r=45.1352 //w=0.168 //l=0.173853 //layer=ply \
 //thickness=0.18 //x=5.705 //y=1.43 //x2=5.745 //y2=1.585
r310 (  76 111 ) resistor r=45.1352 //w=0.168 //l=0.173853 //layer=ply \
 //thickness=0.18 //x=5.705 //y=1.085 //x2=5.745 //y2=0.93
r311 (  76 77 ) resistor r=176.904 //w=0.094 //l=0.345 //layer=ply \
 //thickness=0.18 //x=5.705 //y=1.085 //x2=5.705 //y2=1.43
r312 (  73 79 ) resistor r=26.9307 //w=0.15 //l=0.106066 //layer=ply \
 //thickness=0.18 //x=5.7 //y=5.05 //x2=5.775 //y2=4.975
r313 (  72 108 ) resistor r=592.245 //w=0.094 //l=1.155 //layer=ply \
 //thickness=0.18 //x=8.6 //y=6.205 //x2=8.6 //y2=5.05
r314 (  71 96 ) resistor r=592.245 //w=0.094 //l=1.155 //layer=ply \
 //thickness=0.18 //x=8.16 //y=6.205 //x2=8.16 //y2=5.05
r315 (  70 85 ) resistor r=592.245 //w=0.094 //l=1.155 //layer=ply \
 //thickness=0.18 //x=6.14 //y=6.205 //x2=6.14 //y2=5.05
r316 (  69 73 ) resistor r=592.245 //w=0.094 //l=1.155 //layer=ply \
 //thickness=0.18 //x=5.7 //y=6.205 //x2=5.7 //y2=5.05
r317 (  68 101 ) resistor r=56.4043 //w=0.094 //l=0.11 //layer=ply \
 //thickness=0.18 //x=8.33 //y=1.545 //x2=8.44 //y2=1.545
r318 (  68 102 ) resistor r=56.4043 //w=0.094 //l=0.11 //layer=ply \
 //thickness=0.18 //x=8.33 //y=1.545 //x2=8.22 //y2=1.545
r319 (  67 82 ) resistor r=56.4043 //w=0.094 //l=0.11 //layer=ply \
 //thickness=0.18 //x=5.97 //y=1.585 //x2=6.08 //y2=1.585
r320 (  67 83 ) resistor r=56.4043 //w=0.094 //l=0.11 //layer=ply \
 //thickness=0.18 //x=5.97 //y=1.585 //x2=5.86 //y2=1.585
r321 (  63 122 ) resistor r=152 //w=0.17 //l=0.17 //layer=licon //count=1 \
 //x=7.89 //y=4.885 //x2=7.89 //y2=4.885
r322 (  58 120 ) resistor r=152 //w=0.17 //l=0.17 //layer=licon //count=1 \
 //x=7.89 //y=2.26 //x2=7.89 //y2=2.26
r323 (  53 118 ) resistor r=152 //w=0.17 //l=0.17 //layer=licon //count=1 \
 //x=6.41 //y=4.885 //x2=6.41 //y2=4.885
r324 (  48 116 ) resistor r=152 //w=0.17 //l=0.17 //layer=licon //count=1 \
 //x=6.41 //y=2.26 //x2=6.41 //y2=2.26
r325 (  44 45 ) resistor r=0.10734 //w=0.281 //l=0.16 //layer=m2 \
 //thickness=0.36 //x=7.885 //y=2.27 //x2=7.725 //y2=2.27
r326 (  42 45 ) resistor r=1.09733 //w=0.131 //l=1.15 //layer=m2 \
 //thickness=0.36 //x=6.575 //y=2.26 //x2=7.725 //y2=2.26
r327 (  40 42 ) resistor r=0.10734 //w=0.281 //l=0.16 //layer=m2 \
 //thickness=0.36 //x=6.415 //y=2.27 //x2=6.575 //y2=2.27
r328 (  36 63 ) resistor r=9.3 //w=0.17 //l=0.17 //layer=mcon //count=1 \
 //x=7.89 //y=4.885 //x2=7.89 //y2=4.885
r329 (  34 44 ) resistor r=4.5 //w=0.15 //l=0.15 //layer=via1 //count=1 \
 //x=7.885 //y=2.27 //x2=7.885 //y2=2.27
r330 (  32 58 ) resistor r=9.3 //w=0.17 //l=0.17 //layer=mcon //count=1 \
 //x=7.89 //y=2.26 //x2=7.89 //y2=2.26
r331 (  32 34 ) resistor r=0.00334225 //w=0.374 //l=0.01 //layer=m1 \
 //thickness=0.36 //x=7.835 //y=2.26 //x2=7.835 //y2=2.27
r332 (  30 40 ) resistor r=4.5 //w=0.15 //l=0.15 //layer=via1 //count=1 \
 //x=6.415 //y=2.27 //x2=6.415 //y2=2.27
r333 (  28 48 ) resistor r=9.3 //w=0.17 //l=0.17 //layer=mcon //count=1 \
 //x=6.41 //y=2.26 //x2=6.41 //y2=2.26
r334 (  28 30 ) resistor r=0.00334225 //w=0.374 //l=0.01 //layer=m1 \
 //thickness=0.36 //x=6.465 //y=2.26 //x2=6.465 //y2=2.27
r335 (  26 53 ) resistor r=9.3 //w=0.17 //l=0.17 //layer=mcon //count=1 \
 //x=6.41 //y=4.885 //x2=6.41 //y2=4.885
r336 (  19 36 ) resistor r=0.0777782 //w=0.252 //l=0.131491 //layer=m1 \
 //thickness=0.36 //x=7.89 //y=4.755 //x2=7.887 //y2=4.885
r337 (  18 34 ) resistor r=0.0910802 //w=0.374 //l=0.185472 //layer=m1 \
 //thickness=0.36 //x=7.89 //y=2.43 //x2=7.835 //y2=2.27
r338 (  12 26 ) resistor r=0.075298 //w=0.252 //l=0.125 //layer=m1 \
 //thickness=0.36 //x=6.41 //y=4.76 //x2=6.41 //y2=4.885
r339 (  11 30 ) resistor r=0.0910802 //w=0.374 //l=0.185472 //layer=m1 \
 //thickness=0.36 //x=6.41 //y=2.43 //x2=6.465 //y2=2.27
r340 (  10 19 ) resistor r=0.128817 //w=0.131 //l=0.135 //layer=m1 \
 //thickness=0.36 //x=7.89 //y=4.62 //x2=7.89 //y2=4.755
r341 (  9 10 ) resistor r=0.706107 //w=0.131 //l=0.74 //layer=m1 \
 //thickness=0.36 //x=7.89 //y=3.88 //x2=7.89 //y2=4.62
r342 (  8 9 ) resistor r=0.353053 //w=0.131 //l=0.37 //layer=m1 \
 //thickness=0.36 //x=7.89 //y=3.51 //x2=7.89 //y2=3.88
r343 (  7 8 ) resistor r=0.353053 //w=0.131 //l=0.37 //layer=m1 \
 //thickness=0.36 //x=7.89 //y=3.14 //x2=7.89 //y2=3.51
r344 (  6 7 ) resistor r=0.353053 //w=0.131 //l=0.37 //layer=m1 \
 //thickness=0.36 //x=7.89 //y=2.77 //x2=7.89 //y2=3.14
r345 (  6 18 ) resistor r=0.324427 //w=0.131 //l=0.34 //layer=m1 \
 //thickness=0.36 //x=7.89 //y=2.77 //x2=7.89 //y2=2.43
r346 (  5 12 ) resistor r=0.133588 //w=0.131 //l=0.14 //layer=m1 \
 //thickness=0.36 //x=6.41 //y=4.62 //x2=6.41 //y2=4.76
r347 (  4 5 ) resistor r=0.706107 //w=0.131 //l=0.74 //layer=m1 \
 //thickness=0.36 //x=6.41 //y=3.88 //x2=6.41 //y2=4.62
r348 (  3 4 ) resistor r=0.353053 //w=0.131 //l=0.37 //layer=m1 \
 //thickness=0.36 //x=6.41 //y=3.51 //x2=6.41 //y2=3.88
r349 (  2 3 ) resistor r=0.353053 //w=0.131 //l=0.37 //layer=m1 \
 //thickness=0.36 //x=6.41 //y=3.14 //x2=6.41 //y2=3.51
r350 (  1 2 ) resistor r=0.353053 //w=0.131 //l=0.37 //layer=m1 \
 //thickness=0.36 //x=6.41 //y=2.77 //x2=6.41 //y2=3.14
r351 (  1 11 ) resistor r=0.324427 //w=0.131 //l=0.34 //layer=m1 \
 //thickness=0.36 //x=6.41 //y=2.77 //x2=6.41 //y2=2.43
ends PM_VOTERN3X1\%C

subckt PM_VOTERN3X1\%A ( 1 2 3 4 5 6 7 8 9 10 11 12 18 19 20 26 27 50 52 53 56 \
 65 70 79 83 84 85 86 87 88 89 90 91 96 98 100 106 107 108 109 110 115 117 119 \
 125 126 128 129 132 140 141 144 )
c284 ( 144 0 ) capacitor c=0.0370698f //x=9.02 //y=4.885
c285 ( 141 0 ) capacitor c=0.030265f //x=9 //y=2.095
c286 ( 140 0 ) capacitor c=0.0512002f //x=9 //y=2.26
c287 ( 132 0 ) capacitor c=0.0387879f //x=2.38 //y=4.885
c288 ( 129 0 ) capacitor c=0.0300885f //x=2.34 //y=2.095
c289 ( 128 0 ) capacitor c=0.0554483f //x=2.34 //y=2.26
c290 ( 126 0 ) capacitor c=0.0237734f //x=9.565 //y=1.435
c291 ( 125 0 ) capacitor c=0.0191782f //x=9.565 //y=1.085
c292 ( 119 0 ) capacitor c=0.0361171f //x=9.41 //y=1.585
c293 ( 117 0 ) capacitor c=0.0157803f //x=9.41 //y=0.93
c294 ( 115 0 ) capacitor c=0.0376354f //x=9.405 //y=4.975
c295 ( 110 0 ) capacitor c=0.020493f //x=9.035 //y=1.74
c296 ( 109 0 ) capacitor c=0.0167049f //x=9.035 //y=1.435
c297 ( 108 0 ) capacitor c=0.0174993f //x=9.035 //y=1.085
c298 ( 107 0 ) capacitor c=0.0443648f //x=2.905 //y=1.43
c299 ( 106 0 ) capacitor c=0.0192211f //x=2.905 //y=1.085
c300 ( 100 0 ) capacitor c=0.0186579f //x=2.75 //y=1.585
c301 ( 98 0 ) capacitor c=0.0157795f //x=2.75 //y=0.93
c302 ( 96 0 ) capacitor c=0.0351351f //x=2.745 //y=4.975
c303 ( 91 0 ) capacitor c=0.0209124f //x=2.375 //y=1.74
c304 ( 90 0 ) capacitor c=0.016848f //x=2.375 //y=1.43
c305 ( 89 0 ) capacitor c=0.0174777f //x=2.375 //y=1.085
c306 ( 88 0 ) capacitor c=0.155887f //x=9.48 //y=6.205
c307 ( 87 0 ) capacitor c=0.1106f //x=9.04 //y=6.205
c308 ( 86 0 ) capacitor c=0.154859f //x=2.82 //y=6.205
c309 ( 85 0 ) capacitor c=0.110573f //x=2.38 //y=6.205
c310 ( 79 0 ) capacitor c=8.10734e-19 //x=9.02 //y=4.885
c311 ( 70 0 ) capacitor c=0.00105273f //x=9 //y=2.26
c312 ( 65 0 ) capacitor c=0.00155312f //x=2.38 //y=4.885
c313 ( 56 0 ) capacitor c=0.00152737f //x=2.34 //y=2.26
c314 ( 53 0 ) capacitor c=0.208122f //x=8.855 //y=4.21
c315 ( 52 0 ) capacitor c=0.00479868f //x=9.015 //y=4.21
c316 ( 50 0 ) capacitor c=0.00579767f //x=2.5 //y=4.205
c317 ( 27 0 ) capacitor c=0.00541423f //x=9 //y=4.74
c318 ( 26 0 ) capacitor c=0.0110536f //x=9 //y=4.37
c319 ( 20 0 ) capacitor c=0.00651439f //x=9 //y=2.38
c320 ( 19 0 ) capacitor c=0.0189667f //x=2.34 //y=4.71
c321 ( 18 0 ) capacitor c=0.0126228f //x=2.34 //y=4.365
c322 ( 12 0 ) capacitor c=0.00920415f //x=2.34 //y=2.375
c323 ( 11 0 ) capacitor c=0.0148587f //x=9 //y=4.25
c324 ( 10 0 ) capacitor c=0.0153807f //x=2.34 //y=4.25
c325 ( 9 0 ) capacitor c=0.00702155f //x=9 //y=4.62
c326 ( 5 0 ) capacitor c=0.0499737f //x=9 //y=2.77
c327 ( 1 0 ) capacitor c=0.0685407f //x=2.34 //y=2.77
r328 (  146 147 ) resistor r=32.4568 //w=0.214 //l=0.075 //layer=ply \
 //thickness=0.18 //x=9.02 //y=4.975 //x2=9.02 //y2=5.05
r329 (  144 146 ) resistor r=20.271 //w=0.214 //l=0.09 //layer=ply \
 //thickness=0.18 //x=9.02 //y=4.885 //x2=9.02 //y2=4.975
r330 (  140 141 ) resistor r=52.7279 //w=0.214 //l=0.165 //layer=ply \
 //thickness=0.18 //x=9 //y=2.26 //x2=9 //y2=2.095
r331 (  132 134 ) resistor r=20.271 //w=0.214 //l=0.09 //layer=ply \
 //thickness=0.18 //x=2.38 //y=4.885 //x2=2.38 //y2=4.975
r332 (  128 129 ) resistor r=52.7279 //w=0.214 //l=0.165 //layer=ply \
 //thickness=0.18 //x=2.34 //y=2.26 //x2=2.34 //y2=2.095
r333 (  126 151 ) resistor r=4.95774 //w=0.164 //l=0.112 //layer=ply \
 //thickness=0.18 //x=9.565 //y=1.435 //x2=9.565 //y2=1.547
r334 (  125 150 ) resistor r=45.1352 //w=0.168 //l=0.173853 //layer=ply \
 //thickness=0.18 //x=9.565 //y=1.085 //x2=9.525 //y2=0.93
r335 (  125 126 ) resistor r=179.468 //w=0.094 //l=0.35 //layer=ply \
 //thickness=0.18 //x=9.565 //y=1.085 //x2=9.565 //y2=1.435
r336 (  120 149 ) resistor r=10.8103 //w=0.211 //l=0.115 //layer=ply \
 //thickness=0.18 //x=9.19 //y=1.585 //x2=9.075 //y2=1.585
r337 (  119 151 ) resistor r=45.9962 //w=0.164 //l=0.17296 //layer=ply \
 //thickness=0.18 //x=9.41 //y=1.585 //x2=9.565 //y2=1.547
r338 (  118 148 ) resistor r=5.52526 //w=0.168 //l=0.115 //layer=ply \
 //thickness=0.18 //x=9.19 //y=0.93 //x2=9.075 //y2=0.93
r339 (  117 150 ) resistor r=5.52526 //w=0.168 //l=0.115 //layer=ply \
 //thickness=0.18 //x=9.41 //y=0.93 //x2=9.525 //y2=0.93
r340 (  117 118 ) resistor r=112.809 //w=0.094 //l=0.22 //layer=ply \
 //thickness=0.18 //x=9.41 //y=0.93 //x2=9.19 //y2=0.93
r341 (  116 146 ) resistor r=16.5046 //w=0.27 //l=0.135 //layer=ply \
 //thickness=0.18 //x=9.155 //y=4.975 //x2=9.02 //y2=4.975
r342 (  115 122 ) resistor r=26.9307 //w=0.15 //l=0.106066 //layer=ply \
 //thickness=0.18 //x=9.405 //y=4.975 //x2=9.48 //y2=5.05
r343 (  115 116 ) resistor r=128.191 //w=0.094 //l=0.25 //layer=ply \
 //thickness=0.18 //x=9.405 //y=4.975 //x2=9.155 //y2=4.975
r344 (  110 149 ) resistor r=39.5036 //w=0.211 //l=0.173853 //layer=ply \
 //thickness=0.18 //x=9.035 //y=1.74 //x2=9.075 //y2=1.585
r345 (  110 141 ) resistor r=182.032 //w=0.094 //l=0.355 //layer=ply \
 //thickness=0.18 //x=9.035 //y=1.74 //x2=9.035 //y2=2.095
r346 (  109 149 ) resistor r=38.3614 //w=0.211 //l=0.168819 //layer=ply \
 //thickness=0.18 //x=9.035 //y=1.435 //x2=9.075 //y2=1.585
r347 (  108 148 ) resistor r=45.1352 //w=0.168 //l=0.173853 //layer=ply \
 //thickness=0.18 //x=9.035 //y=1.085 //x2=9.075 //y2=0.93
r348 (  108 109 ) resistor r=179.468 //w=0.094 //l=0.35 //layer=ply \
 //thickness=0.18 //x=9.035 //y=1.085 //x2=9.035 //y2=1.435
r349 (  107 138 ) resistor r=45.1352 //w=0.168 //l=0.173853 //layer=ply \
 //thickness=0.18 //x=2.905 //y=1.43 //x2=2.865 //y2=1.585
r350 (  106 137 ) resistor r=45.1352 //w=0.168 //l=0.173853 //layer=ply \
 //thickness=0.18 //x=2.905 //y=1.085 //x2=2.865 //y2=0.93
r351 (  106 107 ) resistor r=176.904 //w=0.094 //l=0.345 //layer=ply \
 //thickness=0.18 //x=2.905 //y=1.085 //x2=2.905 //y2=1.43
r352 (  101 136 ) resistor r=10.701 //w=0.21 //l=0.115 //layer=ply \
 //thickness=0.18 //x=2.53 //y=1.585 //x2=2.415 //y2=1.585
r353 (  100 138 ) resistor r=5.52526 //w=0.168 //l=0.115 //layer=ply \
 //thickness=0.18 //x=2.75 //y=1.585 //x2=2.865 //y2=1.585
r354 (  99 135 ) resistor r=5.52526 //w=0.168 //l=0.115 //layer=ply \
 //thickness=0.18 //x=2.53 //y=0.93 //x2=2.415 //y2=0.93
r355 (  98 137 ) resistor r=5.52526 //w=0.168 //l=0.115 //layer=ply \
 //thickness=0.18 //x=2.75 //y=0.93 //x2=2.865 //y2=0.93
r356 (  98 99 ) resistor r=112.809 //w=0.094 //l=0.22 //layer=ply \
 //thickness=0.18 //x=2.75 //y=0.93 //x2=2.53 //y2=0.93
r357 (  97 134 ) resistor r=16.5046 //w=0.27 //l=0.135 //layer=ply \
 //thickness=0.18 //x=2.515 //y=4.975 //x2=2.38 //y2=4.975
r358 (  96 103 ) resistor r=26.9307 //w=0.15 //l=0.106066 //layer=ply \
 //thickness=0.18 //x=2.745 //y=4.975 //x2=2.82 //y2=5.05
r359 (  96 97 ) resistor r=117.936 //w=0.094 //l=0.23 //layer=ply \
 //thickness=0.18 //x=2.745 //y=4.975 //x2=2.515 //y2=4.975
r360 (  93 134 ) resistor r=32.4568 //w=0.214 //l=0.075 //layer=ply \
 //thickness=0.18 //x=2.38 //y=5.05 //x2=2.38 //y2=4.975
r361 (  91 136 ) resistor r=39.5823 //w=0.21 //l=0.173853 //layer=ply \
 //thickness=0.18 //x=2.375 //y=1.74 //x2=2.415 //y2=1.585
r362 (  91 129 ) resistor r=182.032 //w=0.094 //l=0.355 //layer=ply \
 //thickness=0.18 //x=2.375 //y=1.74 //x2=2.375 //y2=2.095
r363 (  90 136 ) resistor r=39.5823 //w=0.21 //l=0.173853 //layer=ply \
 //thickness=0.18 //x=2.375 //y=1.43 //x2=2.415 //y2=1.585
r364 (  89 135 ) resistor r=45.1352 //w=0.168 //l=0.173853 //layer=ply \
 //thickness=0.18 //x=2.375 //y=1.085 //x2=2.415 //y2=0.93
r365 (  89 90 ) resistor r=176.904 //w=0.094 //l=0.345 //layer=ply \
 //thickness=0.18 //x=2.375 //y=1.085 //x2=2.375 //y2=1.43
r366 (  88 122 ) resistor r=592.245 //w=0.094 //l=1.155 //layer=ply \
 //thickness=0.18 //x=9.48 //y=6.205 //x2=9.48 //y2=5.05
r367 (  87 147 ) resistor r=592.245 //w=0.094 //l=1.155 //layer=ply \
 //thickness=0.18 //x=9.04 //y=6.205 //x2=9.04 //y2=5.05
r368 (  86 103 ) resistor r=592.245 //w=0.094 //l=1.155 //layer=ply \
 //thickness=0.18 //x=2.82 //y=6.205 //x2=2.82 //y2=5.05
r369 (  85 93 ) resistor r=592.245 //w=0.094 //l=1.155 //layer=ply \
 //thickness=0.18 //x=2.38 //y=6.205 //x2=2.38 //y2=5.05
r370 (  84 119 ) resistor r=56.4043 //w=0.094 //l=0.11 //layer=ply \
 //thickness=0.18 //x=9.3 //y=1.585 //x2=9.41 //y2=1.585
r371 (  84 120 ) resistor r=56.4043 //w=0.094 //l=0.11 //layer=ply \
 //thickness=0.18 //x=9.3 //y=1.585 //x2=9.19 //y2=1.585
r372 (  83 100 ) resistor r=56.4043 //w=0.094 //l=0.11 //layer=ply \
 //thickness=0.18 //x=2.64 //y=1.585 //x2=2.75 //y2=1.585
r373 (  83 101 ) resistor r=56.4043 //w=0.094 //l=0.11 //layer=ply \
 //thickness=0.18 //x=2.64 //y=1.585 //x2=2.53 //y2=1.585
r374 (  79 144 ) resistor r=152 //w=0.17 //l=0.17 //layer=licon //count=1 \
 //x=9.02 //y=4.885 //x2=9.02 //y2=4.885
r375 (  70 140 ) resistor r=152 //w=0.17 //l=0.17 //layer=licon //count=1 \
 //x=9 //y=2.26 //x2=9 //y2=2.26
r376 (  65 132 ) resistor r=152 //w=0.17 //l=0.17 //layer=licon //count=1 \
 //x=2.38 //y=4.885 //x2=2.38 //y2=4.885
r377 (  56 128 ) resistor r=152 //w=0.17 //l=0.17 //layer=licon //count=1 \
 //x=2.34 //y=2.26 //x2=2.34 //y2=2.26
r378 (  52 53 ) resistor r=0.104807 //w=0.281 //l=0.16 //layer=m2 \
 //thickness=0.36 //x=9.015 //y=4.21 //x2=8.855 //y2=4.21
r379 (  50 53 ) resistor r=5.84099 //w=0.136 //l=6.355 //layer=m2 \
 //thickness=0.36 //x=2.5 //y=4.252 //x2=8.855 //y2=4.252
r380 (  48 50 ) resistor r=0.104807 //w=0.281 //l=0.16 //layer=m2 \
 //thickness=0.36 //x=2.34 //y=4.205 //x2=2.5 //y2=4.205
r381 (  44 79 ) resistor r=9.3 //w=0.17 //l=0.17 //layer=mcon //count=1 \
 //x=9.02 //y=4.885 //x2=9.02 //y2=4.885
r382 (  42 70 ) resistor r=9.3 //w=0.17 //l=0.17 //layer=mcon //count=1 //x=9 \
 //y=2.26 //x2=9 //y2=2.26
r383 (  38 52 ) resistor r=4.5 //w=0.15 //l=0.15 //layer=via1 //count=1 \
 //x=9.015 //y=4.21 //x2=9.015 //y2=4.21
r384 (  34 48 ) resistor r=4.5 //w=0.15 //l=0.15 //layer=via1 //count=1 \
 //x=2.34 //y=4.205 //x2=2.34 //y2=4.205
r385 (  32 65 ) resistor r=9.3 //w=0.17 //l=0.17 //layer=mcon //count=1 \
 //x=2.38 //y=4.885 //x2=2.38 //y2=4.885
r386 (  30 56 ) resistor r=9.3 //w=0.17 //l=0.17 //layer=mcon //count=1 \
 //x=2.34 //y=2.26 //x2=2.34 //y2=2.26
r387 (  27 44 ) resistor r=0.0893515 //w=0.219 //l=0.154677 //layer=m1 \
 //thickness=0.36 //x=9 //y=4.74 //x2=9.02 //y2=4.885
r388 (  21 38 ) resistor r=0.0914932 //w=0.384 //l=0.181108 //layer=m1 \
 //thickness=0.36 //x=9 //y=4.05 //x2=8.955 //y2=4.21
r389 (  20 42 ) resistor r=0.0744285 //w=0.225 //l=0.12 //layer=m1 \
 //thickness=0.36 //x=9 //y=2.38 //x2=9 //y2=2.26
r390 (  19 32 ) resistor r=0.100665 //w=0.248 //l=0.193972 //layer=m1 \
 //thickness=0.36 //x=2.34 //y=4.71 //x2=2.38 //y2=4.885
r391 (  18 19 ) resistor r=0.329198 //w=0.131 //l=0.345 //layer=m1 \
 //thickness=0.36 //x=2.34 //y=4.365 //x2=2.34 //y2=4.71
r392 (  13 34 ) resistor r=0.0911593 //w=0.376 //l=0.184174 //layer=m1 \
 //thickness=0.36 //x=2.34 //y=4.045 //x2=2.392 //y2=4.205
r393 (  12 30 ) resistor r=0.0717383 //w=0.224 //l=0.115 //layer=m1 \
 //thickness=0.36 //x=2.34 //y=2.375 //x2=2.34 //y2=2.26
r394 (  11 26 ) resistor r=0.0784723 //w=0.384 //l=0.140712 //layer=m1 \
 //thickness=0.36 //x=8.955 //y=4.25 //x2=9 //y2=4.37
r395 (  11 38 ) resistor r=0.0130208 //w=0.384 //l=0.04 //layer=m1 \
 //thickness=0.36 //x=8.955 //y=4.25 //x2=8.955 //y2=4.21
r396 (  10 18 ) resistor r=0.0761992 //w=0.376 //l=0.138582 //layer=m1 \
 //thickness=0.36 //x=2.392 //y=4.25 //x2=2.34 //y2=4.365
r397 (  10 34 ) resistor r=0.0149601 //w=0.376 //l=0.045 //layer=m1 \
 //thickness=0.36 //x=2.392 //y=4.25 //x2=2.392 //y2=4.205
r398 (  9 27 ) resistor r=0.114504 //w=0.131 //l=0.12 //layer=m1 \
 //thickness=0.36 //x=9 //y=4.62 //x2=9 //y2=4.74
r399 (  9 26 ) resistor r=0.23855 //w=0.131 //l=0.25 //layer=m1 \
 //thickness=0.36 //x=9 //y=4.62 //x2=9 //y2=4.37
r400 (  8 21 ) resistor r=0.162214 //w=0.131 //l=0.17 //layer=m1 \
 //thickness=0.36 //x=9 //y=3.88 //x2=9 //y2=4.05
r401 (  7 8 ) resistor r=0.353053 //w=0.131 //l=0.37 //layer=m1 \
 //thickness=0.36 //x=9 //y=3.51 //x2=9 //y2=3.88
r402 (  6 7 ) resistor r=0.353053 //w=0.131 //l=0.37 //layer=m1 \
 //thickness=0.36 //x=9 //y=3.14 //x2=9 //y2=3.51
r403 (  5 6 ) resistor r=0.353053 //w=0.131 //l=0.37 //layer=m1 \
 //thickness=0.36 //x=9 //y=2.77 //x2=9 //y2=3.14
r404 (  5 20 ) resistor r=0.372137 //w=0.131 //l=0.39 //layer=m1 \
 //thickness=0.36 //x=9 //y=2.77 //x2=9 //y2=2.38
r405 (  4 13 ) resistor r=0.157443 //w=0.131 //l=0.165 //layer=m1 \
 //thickness=0.36 //x=2.34 //y=3.88 //x2=2.34 //y2=4.045
r406 (  3 4 ) resistor r=0.353053 //w=0.131 //l=0.37 //layer=m1 \
 //thickness=0.36 //x=2.34 //y=3.51 //x2=2.34 //y2=3.88
r407 (  2 3 ) resistor r=0.353053 //w=0.131 //l=0.37 //layer=m1 \
 //thickness=0.36 //x=2.34 //y=3.14 //x2=2.34 //y2=3.51
r408 (  1 2 ) resistor r=0.353053 //w=0.131 //l=0.37 //layer=m1 \
 //thickness=0.36 //x=2.34 //y=2.77 //x2=2.34 //y2=3.14
r409 (  1 12 ) resistor r=0.376908 //w=0.131 //l=0.395 //layer=m1 \
 //thickness=0.36 //x=2.34 //y=2.77 //x2=2.34 //y2=2.375
ends PM_VOTERN3X1\%A

subckt PM_VOTERN3X1\%YN ( 1 2 3 4 5 6 7 8 9 11 12 13 15 16 28 32 35 38 52 55 \
 56 58 59 68 76 93 94 95 99 100 )
c205 ( 95 0 ) capacitor c=0.009897f //x=9.11 //y=1.085
c206 ( 94 0 ) capacitor c=0.0110388f //x=5.78 //y=1.085
c207 ( 93 0 ) capacitor c=0.0110842f //x=2.45 //y=1.085
c208 ( 76 0 ) capacitor c=0.0265472f //x=9.26 //y=5.56
c209 ( 68 0 ) capacitor c=0.0232072f //x=8.38 //y=5.56
c210 ( 59 0 ) capacitor c=0.0866731f //x=9.135 //y=1.405
c211 ( 58 0 ) capacitor c=0.0257508f //x=9.295 //y=1.405
c212 ( 56 0 ) capacitor c=0.0121686f //x=6.1 //y=1.405
c213 ( 55 0 ) capacitor c=0.125205f //x=5.84 //y=1.405
c214 ( 52 0 ) capacitor c=0.00933361f //x=2.805 //y=1.405
c215 ( 38 0 ) capacitor c=0.01557f //x=9.257 //y=5.39
c216 ( 35 0 ) capacitor c=0.0155006f //x=8.38 //y=5.39
c217 ( 32 0 ) capacitor c=0.0087298f //x=5.97 //y=1.36
c218 ( 28 0 ) capacitor c=0.00730171f //x=2.64 //y=1.36
c219 ( 16 0 ) capacitor c=0.00834076f //x=9.385 //y=1.825
c220 ( 15 0 ) capacitor c=0.0162177f //x=9.655 //y=1.825
c221 ( 13 0 ) capacitor c=0.0128896f //x=9.655 //y=5.39
c222 ( 12 0 ) capacitor c=0.00871794f //x=9.3 //y=1.74
c223 ( 11 0 ) capacitor c=0.00698506f //x=9.3 //y=1.535
c224 ( 9 0 ) capacitor c=0.0116295f //x=9.135 //y=5.39
c225 ( 1 0 ) capacitor c=0.133093f //x=9.74 //y=2.4
r226 (  92 93 ) resistor r=13.3953 //w=0.172 //l=0.18 //layer=li \
 //thickness=0.1 //x=2.637 //y=1.36 //x2=2.637 //y2=1.18
r227 (  87 95 ) resistor r=12.3209 //w=0.187 //l=0.18 //layer=li \
 //thickness=0.1 //x=9.3 //y=1.36 //x2=9.3 //y2=1.18
r228 (  76 100 ) resistor r=23.2727 //w=0.187 //l=0.34 //layer=li \
 //thickness=0.1 //x=9.26 //y=5.56 //x2=9.26 //y2=5.9
r229 (  68 99 ) resistor r=23.2727 //w=0.187 //l=0.34 //layer=li \
 //thickness=0.1 //x=8.38 //y=5.56 //x2=8.38 //y2=5.9
r230 (  65 94 ) resistor r=12.3209 //w=0.187 //l=0.18 //layer=li \
 //thickness=0.1 //x=5.97 //y=1.36 //x2=5.97 //y2=1.18
r231 (  58 59 ) resistor r=0.10734 //w=0.281 //l=0.16 //layer=m2 \
 //thickness=0.36 //x=9.295 //y=1.405 //x2=9.135 //y2=1.405
r232 (  56 59 ) resistor r=2.89599 //w=0.131 //l=3.035 //layer=m2 \
 //thickness=0.36 //x=6.1 //y=1.36 //x2=9.135 //y2=1.36
r233 (  54 56 ) resistor r=0.0942778 //w=0.221 //l=0.13 //layer=m2 \
 //thickness=0.36 //x=5.97 //y=1.405 //x2=6.1 //y2=1.405
r234 (  54 55 ) resistor r=0.0942778 //w=0.221 //l=0.13 //layer=m2 \
 //thickness=0.36 //x=5.97 //y=1.405 //x2=5.84 //y2=1.405
r235 (  52 55 ) resistor r=2.89599 //w=0.131 //l=3.035 //layer=m2 \
 //thickness=0.36 //x=2.805 //y=1.36 //x2=5.84 //y2=1.36
r236 (  50 52 ) resistor r=0.10734 //w=0.281 //l=0.16 //layer=m2 \
 //thickness=0.36 //x=2.645 //y=1.405 //x2=2.805 //y2=1.405
r237 (  44 58 ) resistor r=4.5 //w=0.15 //l=0.15 //layer=via1 //count=1 \
 //x=9.295 //y=1.405 //x2=9.295 //y2=1.405
r238 (  42 87 ) resistor r=9.3 //w=0.17 //l=0.17 //layer=mcon //count=1 \
 //x=9.3 //y=1.36 //x2=9.3 //y2=1.36
r239 (  42 44 ) resistor r=0.0163043 //w=0.345 //l=0.045 //layer=m1 \
 //thickness=0.36 //x=9.24 //y=1.36 //x2=9.24 //y2=1.405
r240 (  40 76 ) resistor r=9.3 //w=0.17 //l=0.17 //layer=mcon //count=1 \
 //x=9.26 //y=5.56 //x2=9.26 //y2=5.56
r241 (  38 40 ) resistor r=0.0944444 //w=0.225 //l=0.17 //layer=m1 \
 //thickness=0.36 //x=9.257 //y=5.39 //x2=9.257 //y2=5.56
r242 (  37 68 ) resistor r=9.3 //w=0.17 //l=0.17 //layer=mcon //count=1 \
 //x=8.38 //y=5.56 //x2=8.38 //y2=5.56
r243 (  35 37 ) resistor r=0.0936123 //w=0.227 //l=0.17 //layer=m1 \
 //thickness=0.36 //x=8.38 //y=5.39 //x2=8.38 //y2=5.56
r244 (  34 54 ) resistor r=4.5 //w=0.15 //l=0.15 //layer=via1 //count=1 \
 //x=5.97 //y=1.405 //x2=5.97 //y2=1.405
r245 (  32 65 ) resistor r=9.3 //w=0.17 //l=0.17 //layer=mcon //count=1 \
 //x=5.97 //y=1.36 //x2=5.97 //y2=1.36
r246 (  32 34 ) resistor r=0.0163043 //w=0.345 //l=0.045 //layer=m1 \
 //thickness=0.36 //x=5.91 //y=1.36 //x2=5.91 //y2=1.405
r247 (  30 50 ) resistor r=4.5 //w=0.15 //l=0.15 //layer=via1 //count=1 \
 //x=2.645 //y=1.405 //x2=2.645 //y2=1.405
r248 (  28 92 ) resistor r=9.3 //w=0.17 //l=0.17 //layer=mcon //count=1 \
 //x=2.64 //y=1.36 //x2=2.64 //y2=1.36
r249 (  28 30 ) resistor r=0.0150401 //w=0.374 //l=0.045 //layer=m1 \
 //thickness=0.36 //x=2.695 //y=1.36 //x2=2.695 //y2=1.405
r250 (  15 17 ) resistor r=0.0698411 //w=0.17 //l=0.120208 //layer=m1 \
 //thickness=0.36 //x=9.655 //y=1.825 //x2=9.74 //y2=1.91
r251 (  15 16 ) resistor r=0.257634 //w=0.131 //l=0.27 //layer=m1 \
 //thickness=0.36 //x=9.655 //y=1.825 //x2=9.385 //y2=1.825
r252 (  14 38 ) resistor r=0.0243946 //w=0.225 //l=0.123 //layer=m1 \
 //thickness=0.36 //x=9.38 //y=5.39 //x2=9.257 //y2=5.39
r253 (  13 18 ) resistor r=0.0698411 //w=0.17 //l=0.120208 //layer=m1 \
 //thickness=0.36 //x=9.655 //y=5.39 //x2=9.74 //y2=5.305
r254 (  13 14 ) resistor r=0.262405 //w=0.131 //l=0.275 //layer=m1 \
 //thickness=0.36 //x=9.655 //y=5.39 //x2=9.38 //y2=5.39
r255 (  12 16 ) resistor r=0.0698411 //w=0.17 //l=0.120208 //layer=m1 \
 //thickness=0.36 //x=9.3 //y=1.74 //x2=9.385 //y2=1.825
r256 (  11 44 ) resistor r=0.0792909 //w=0.345 //l=0.157162 //layer=m1 \
 //thickness=0.36 //x=9.3 //y=1.535 //x2=9.24 //y2=1.405
r257 (  11 12 ) resistor r=0.195611 //w=0.131 //l=0.205 //layer=m1 \
 //thickness=0.36 //x=9.3 //y=1.535 //x2=9.3 //y2=1.74
r258 (  10 35 ) resistor r=0.0249239 //w=0.227 //l=0.125 //layer=m1 \
 //thickness=0.36 //x=8.505 //y=5.39 //x2=8.38 //y2=5.39
r259 (  9 38 ) resistor r=0.0243946 //w=0.225 //l=0.122 //layer=m1 \
 //thickness=0.36 //x=9.135 //y=5.39 //x2=9.257 //y2=5.39
r260 (  9 10 ) resistor r=0.601145 //w=0.131 //l=0.63 //layer=m1 \
 //thickness=0.36 //x=9.135 //y=5.39 //x2=8.505 //y2=5.39
r261 (  8 18 ) resistor r=0.300573 //w=0.131 //l=0.315 //layer=m1 \
 //thickness=0.36 //x=9.74 //y=4.99 //x2=9.74 //y2=5.305
r262 (  7 8 ) resistor r=0.353053 //w=0.131 //l=0.37 //layer=m1 \
 //thickness=0.36 //x=9.74 //y=4.62 //x2=9.74 //y2=4.99
r263 (  6 7 ) resistor r=0.353053 //w=0.131 //l=0.37 //layer=m1 \
 //thickness=0.36 //x=9.74 //y=4.25 //x2=9.74 //y2=4.62
r264 (  5 6 ) resistor r=0.353053 //w=0.131 //l=0.37 //layer=m1 \
 //thickness=0.36 //x=9.74 //y=3.88 //x2=9.74 //y2=4.25
r265 (  4 5 ) resistor r=0.353053 //w=0.131 //l=0.37 //layer=m1 \
 //thickness=0.36 //x=9.74 //y=3.51 //x2=9.74 //y2=3.88
r266 (  3 4 ) resistor r=0.353053 //w=0.131 //l=0.37 //layer=m1 \
 //thickness=0.36 //x=9.74 //y=3.14 //x2=9.74 //y2=3.51
r267 (  2 3 ) resistor r=0.353053 //w=0.131 //l=0.37 //layer=m1 \
 //thickness=0.36 //x=9.74 //y=2.77 //x2=9.74 //y2=3.14
r268 (  1 2 ) resistor r=0.353053 //w=0.131 //l=0.37 //layer=m1 \
 //thickness=0.36 //x=9.74 //y=2.4 //x2=9.74 //y2=2.77
r269 (  1 17 ) resistor r=0.467557 //w=0.131 //l=0.49 //layer=m1 \
 //thickness=0.36 //x=9.74 //y=2.4 //x2=9.74 //y2=1.91
ends PM_VOTERN3X1\%YN

subckt PM_VOTERN3X1\%VDD ( 1 4 5 6 8 9 10 14 15 29 32 45 48 80 95 98 99 100 \
 101 102 )
c194 ( 102 0 ) capacitor c=0.0424825f //x=2.895 //y=5.205
c195 ( 101 0 ) capacitor c=0.0224071f //x=2.015 //y=5.205
c196 ( 100 0 ) capacitor c=0.0512787f //x=1.145 //y=5.205
c197 ( 99 0 ) capacitor c=0.121249f //x=7.15 //y=7.585
c198 ( 98 0 ) capacitor c=0.126253f //x=3.82 //y=7.585
c199 ( 95 0 ) capacitor c=0.369119f //x=9.74 //y=7.58
c200 ( 80 0 ) capacitor c=0.131873f //x=6.98 //y=7.585
c201 ( 48 0 ) capacitor c=0.23158f //x=1.23 //y=7.58
c202 ( 45 0 ) capacitor c=0.133054f //x=3.65 //y=7.585
c203 ( 40 0 ) capacitor c=0.00499323f //x=3.04 //y=7.585
c204 ( 37 0 ) capacitor c=0.00499323f //x=2.16 //y=7.585
c205 ( 32 0 ) capacitor c=0.0700507f //x=1.23 //y=7.58
c206 ( 29 0 ) capacitor c=0.270843f //x=9.74 //y=7.58
c207 ( 15 0 ) capacitor c=0.00657976f //x=3.04 //y=7.41
c208 ( 14 0 ) capacitor c=0.00827249f //x=3.04 //y=7.035
c209 ( 10 0 ) capacitor c=0.0220779f //x=2.955 //y=7.585
c210 ( 9 0 ) capacitor c=0.00369726f //x=2.16 //y=7.41
c211 ( 8 0 ) capacitor c=0.00650208f //x=2.16 //y=7.035
c212 ( 6 0 ) capacitor c=0.02242f //x=2.075 //y=7.585
c213 ( 5 0 ) capacitor c=0.0090067f //x=1.28 //y=7.41
c214 ( 4 0 ) capacitor c=0.0125184f //x=1.28 //y=7.035
r215 (  93 95 ) resistor r=38.7139 //w=0.367 //l=1.11 //layer=li \
 //thickness=0.1 //x=8.63 //y=7.585 //x2=9.74 //y2=7.585
r216 (  91 93 ) resistor r=38.7139 //w=0.367 //l=1.11 //layer=li \
 //thickness=0.1 //x=7.52 //y=7.585 //x2=8.63 //y2=7.585
r217 (  89 99 ) resistor r=5.29055 //w=0.35 //l=0.17 //layer=li \
 //thickness=0.1 //x=7.32 //y=7.585 //x2=7.15 //y2=7.585
r218 (  89 91 ) resistor r=6.97548 //w=0.367 //l=0.2 //layer=li \
 //thickness=0.1 //x=7.32 //y=7.585 //x2=7.52 //y2=7.585
r219 (  83 85 ) resistor r=38.7139 //w=0.367 //l=1.11 //layer=li \
 //thickness=0.1 //x=4.93 //y=7.585 //x2=6.04 //y2=7.585
r220 (  81 98 ) resistor r=5.29055 //w=0.35 //l=0.17 //layer=li \
 //thickness=0.1 //x=3.99 //y=7.585 //x2=3.82 //y2=7.585
r221 (  81 83 ) resistor r=32.7847 //w=0.367 //l=0.94 //layer=li \
 //thickness=0.1 //x=3.99 //y=7.585 //x2=4.93 //y2=7.585
r222 (  80 99 ) resistor r=5.29055 //w=0.35 //l=0.17 //layer=li \
 //thickness=0.1 //x=6.98 //y=7.585 //x2=7.15 //y2=7.585
r223 (  80 85 ) resistor r=32.7847 //w=0.367 //l=0.94 //layer=li \
 //thickness=0.1 //x=6.98 //y=7.585 //x2=6.04 //y2=7.585
r224 (  76 102 ) resistor r=23.2727 //w=0.187 //l=0.34 //layer=li \
 //thickness=0.1 //x=3.04 //y=6.92 //x2=3.04 //y2=6.58
r225 (  61 100 ) resistor r=23.2727 //w=0.187 //l=0.34 //layer=li \
 //thickness=0.1 //x=1.28 //y=6.92 //x2=1.28 //y2=6.58
r226 (  50 52 ) resistor r=38.7139 //w=0.367 //l=1.11 //layer=li \
 //thickness=0.1 //x=2.34 //y=7.585 //x2=3.45 //y2=7.585
r227 (  48 50 ) resistor r=38.7139 //w=0.367 //l=1.11 //layer=li \
 //thickness=0.1 //x=1.23 //y=7.585 //x2=2.34 //y2=7.585
r228 (  45 98 ) resistor r=5.29055 //w=0.35 //l=0.17 //layer=li \
 //thickness=0.1 //x=3.65 //y=7.585 //x2=3.82 //y2=7.585
r229 (  45 52 ) resistor r=6.97548 //w=0.367 //l=0.2 //layer=li \
 //thickness=0.1 //x=3.65 //y=7.585 //x2=3.45 //y2=7.585
r230 (  42 76 ) resistor r=9.3 //w=0.17 //l=0.17 //layer=mcon //count=1 \
 //x=3.04 //y=6.92 //x2=3.04 //y2=6.92
r231 (  39 101 ) resistor r=9.3 //w=0.17 //l=0.17 //layer=mcon //count=1 \
 //x=2.16 //y=6.92 //x2=2.16 //y2=6.92
r232 (  36 61 ) resistor r=9.3 //w=0.17 //l=0.17 //layer=mcon //count=1 \
 //x=1.28 //y=6.92 //x2=1.28 //y2=6.92
r233 (  32 48 ) resistor r=3.1 //w=0.17 //l=0.51 //layer=mcon //count=3 \
 //x=1.23 //y=7.58 //x2=1.23 //y2=7.58
r234 (  29 95 ) resistor r=3.1 //w=0.17 //l=0.51 //layer=mcon //count=3 \
 //x=9.74 //y=7.58 //x2=9.74 //y2=7.58
r235 (  27 93 ) resistor r=3.1 //w=0.17 //l=0.51 //layer=mcon //count=3 \
 //x=8.63 //y=7.58 //x2=8.63 //y2=7.58
r236 (  27 29 ) resistor r=0.446141 //w=0.311 //l=1.11 //layer=m1 \
 //thickness=0.36 //x=8.63 //y=7.585 //x2=9.74 //y2=7.585
r237 (  25 91 ) resistor r=3.1 //w=0.17 //l=0.51 //layer=mcon //count=3 \
 //x=7.52 //y=7.58 //x2=7.52 //y2=7.58
r238 (  25 27 ) resistor r=0.446141 //w=0.311 //l=1.11 //layer=m1 \
 //thickness=0.36 //x=7.52 //y=7.585 //x2=8.63 //y2=7.585
r239 (  23 85 ) resistor r=3.1 //w=0.17 //l=0.51 //layer=mcon //count=3 \
 //x=6.04 //y=7.58 //x2=6.04 //y2=7.58
r240 (  23 25 ) resistor r=0.594855 //w=0.311 //l=1.48 //layer=m1 \
 //thickness=0.36 //x=6.04 //y=7.585 //x2=7.52 //y2=7.585
r241 (  20 83 ) resistor r=3.1 //w=0.17 //l=0.51 //layer=mcon //count=3 \
 //x=4.93 //y=7.58 //x2=4.93 //y2=7.58
r242 (  18 52 ) resistor r=3.1 //w=0.17 //l=0.51 //layer=mcon //count=3 \
 //x=3.45 //y=7.58 //x2=3.45 //y2=7.58
r243 (  18 20 ) resistor r=0.594855 //w=0.311 //l=1.48 //layer=m1 \
 //thickness=0.36 //x=3.45 //y=7.585 //x2=4.93 //y2=7.585
r244 (  16 40 ) resistor r=0.028033 //w=0.35 //l=0.085 //layer=m1 \
 //thickness=0.36 //x=3.125 //y=7.585 //x2=3.04 //y2=7.585
r245 (  16 18 ) resistor r=0.130627 //w=0.311 //l=0.325 //layer=m1 \
 //thickness=0.36 //x=3.125 //y=7.585 //x2=3.45 //y2=7.585
r246 (  15 40 ) resistor r=0.0413265 //w=0.7 //l=0.175 //layer=m1 \
 //thickness=0.36 //x=3.04 //y=7.41 //x2=3.04 //y2=7.585
r247 (  14 42 ) resistor r=0.0715665 //w=0.226 //l=0.115 //layer=m1 \
 //thickness=0.36 //x=3.04 //y=7.035 //x2=3.04 //y2=6.92
r248 (  14 15 ) resistor r=0.357824 //w=0.131 //l=0.375 //layer=m1 \
 //thickness=0.36 //x=3.04 //y=7.035 //x2=3.04 //y2=7.41
r249 (  13 50 ) resistor r=3.1 //w=0.17 //l=0.51 //layer=mcon //count=3 \
 //x=2.34 //y=7.58 //x2=2.34 //y2=7.58
r250 (  11 37 ) resistor r=0.028033 //w=0.35 //l=0.085 //layer=m1 \
 //thickness=0.36 //x=2.245 //y=7.585 //x2=2.16 //y2=7.585
r251 (  11 13 ) resistor r=0.0381833 //w=0.311 //l=0.095 //layer=m1 \
 //thickness=0.36 //x=2.245 //y=7.585 //x2=2.34 //y2=7.585
r252 (  10 40 ) resistor r=0.028033 //w=0.35 //l=0.085 //layer=m1 \
 //thickness=0.36 //x=2.955 //y=7.585 //x2=3.04 //y2=7.585
r253 (  10 13 ) resistor r=0.247186 //w=0.311 //l=0.615 //layer=m1 \
 //thickness=0.36 //x=2.955 //y=7.585 //x2=2.34 //y2=7.585
r254 (  9 37 ) resistor r=0.0413265 //w=0.7 //l=0.175 //layer=m1 \
 //thickness=0.36 //x=2.16 //y=7.41 //x2=2.16 //y2=7.585
r255 (  8 39 ) resistor r=0.0715665 //w=0.226 //l=0.117473 //layer=m1 \
 //thickness=0.36 //x=2.16 //y=7.035 //x2=2.165 //y2=6.92
r256 (  8 9 ) resistor r=0.357824 //w=0.131 //l=0.375 //layer=m1 \
 //thickness=0.36 //x=2.16 //y=7.035 //x2=2.16 //y2=7.41
r257 (  7 32 ) resistor r=0.028033 //w=0.35 //l=0.085 //layer=m1 \
 //thickness=0.36 //x=1.365 //y=7.585 //x2=1.28 //y2=7.585
r258 (  6 37 ) resistor r=0.028033 //w=0.35 //l=0.085 //layer=m1 \
 //thickness=0.36 //x=2.075 //y=7.585 //x2=2.16 //y2=7.585
r259 (  6 7 ) resistor r=0.28537 //w=0.311 //l=0.71 //layer=m1 \
 //thickness=0.36 //x=2.075 //y=7.585 //x2=1.365 //y2=7.585
r260 (  5 32 ) resistor r=0.0413265 //w=0.7 //l=0.175 //layer=m1 \
 //thickness=0.36 //x=1.28 //y=7.41 //x2=1.28 //y2=7.585
r261 (  4 36 ) resistor r=0.0712609 //w=0.23 //l=0.11649 //layer=m1 \
 //thickness=0.36 //x=1.28 //y=7.035 //x2=1.277 //y2=6.92
r262 (  4 5 ) resistor r=0.357824 //w=0.131 //l=0.375 //layer=m1 \
 //thickness=0.36 //x=1.28 //y=7.035 //x2=1.28 //y2=7.41
r263 (  1 23 ) resistor r=0.223071 //w=0.311 //l=0.555 //layer=m1 \
 //thickness=0.36 //x=5.485 //y=7.585 //x2=6.04 //y2=7.585
r264 (  1 20 ) resistor r=0.223071 //w=0.311 //l=0.555 //layer=m1 \
 //thickness=0.36 //x=5.485 //y=7.585 //x2=4.93 //y2=7.585
ends PM_VOTERN3X1\%VDD

subckt PM_VOTERN3X1\%noxref_6 ( 1 3 4 5 7 9 19 25 27 30 40 49 71 72 73 74 75 )
c166 ( 75 0 ) capacitor c=0.0354016f //x=6.215 //y=5.205
c167 ( 74 0 ) capacitor c=0.0241107f //x=5.335 //y=5.205
c168 ( 72 0 ) capacitor c=0.00544792f //x=2.455 //y=5.205
c169 ( 71 0 ) capacitor c=0.00516996f //x=1.575 //y=5.205
c170 ( 49 0 ) capacitor c=0.0508454f //x=4.6 //y=5.39
c171 ( 40 0 ) capacitor c=0.0363371f //x=2.6 //y=5.39
c172 ( 30 0 ) capacitor c=0.0294643f //x=1.72 //y=5.56
c173 ( 27 0 ) capacitor c=0.00984489f //x=6.36 //y=6.92
c174 ( 25 0 ) capacitor c=0.0059844f //x=5.477 //y=7.09
c175 ( 19 0 ) capacitor c=0.00975753f //x=4.6 //y=6.92
c176 ( 9 0 ) capacitor c=0.014892f //x=1.722 //y=5.39
c177 ( 7 0 ) capacitor c=0.00787288f //x=6.245 //y=7.09
c178 ( 5 0 ) capacitor c=0.00659042f //x=5.36 //y=7.09
c179 ( 4 0 ) capacitor c=0.00573286f //x=2.715 //y=5.39
c180 ( 3 0 ) capacitor c=0.0636102f //x=4.485 //y=5.39
c181 ( 1 0 ) capacitor c=0.0145996f //x=2.485 //y=5.39
r182 (  49 73 ) resistor r=58.1818 //w=0.187 //l=0.85 //layer=li \
 //thickness=0.1 //x=4.6 //y=5.39 //x2=4.6 //y2=6.24
r183 (  40 72 ) resistor r=58.1818 //w=0.187 //l=0.85 //layer=li \
 //thickness=0.1 //x=2.6 //y=5.39 //x2=2.6 //y2=6.24
r184 (  30 71 ) resistor r=23.2727 //w=0.187 //l=0.34 //layer=li \
 //thickness=0.1 //x=1.72 //y=5.56 //x2=1.72 //y2=5.9
r185 (  27 75 ) resistor r=9.3 //w=0.17 //l=0.17 //layer=mcon //count=1 \
 //x=6.36 //y=6.92 //x2=6.36 //y2=6.92
r186 (  27 28 ) resistor r=0.0988372 //w=0.215 //l=0.17 //layer=m1 \
 //thickness=0.36 //x=6.362 //y=6.92 //x2=6.362 //y2=7.09
r187 (  24 74 ) resistor r=9.3 //w=0.17 //l=0.17 //layer=mcon //count=1 \
 //x=5.48 //y=6.92 //x2=5.48 //y2=6.92
r188 (  24 25 ) resistor r=0.0940266 //w=0.226 //l=0.17 //layer=m1 \
 //thickness=0.36 //x=5.477 //y=6.92 //x2=5.477 //y2=7.09
r189 (  22 49 ) resistor r=9.3 //w=0.17 //l=0.17 //layer=mcon //count=1 \
 //x=4.6 //y=5.39 //x2=4.6 //y2=5.39
r190 (  19 73 ) resistor r=9.3 //w=0.17 //l=0.17 //layer=mcon //count=1 \
 //x=4.6 //y=6.92 //x2=4.6 //y2=6.92
r191 (  19 20 ) resistor r=0.0979263 //w=0.217 //l=0.17 //layer=m1 \
 //thickness=0.36 //x=4.602 //y=6.92 //x2=4.602 //y2=7.09
r192 (  15 40 ) resistor r=9.3 //w=0.17 //l=0.17 //layer=mcon //count=1 \
 //x=2.6 //y=5.39 //x2=2.6 //y2=5.39
r193 (  11 30 ) resistor r=9.3 //w=0.17 //l=0.17 //layer=mcon //count=1 \
 //x=1.72 //y=5.56 //x2=1.72 //y2=5.56
r194 (  9 11 ) resistor r=0.0944444 //w=0.225 //l=0.17 //layer=m1 \
 //thickness=0.36 //x=1.722 //y=5.39 //x2=1.722 //y2=5.56
r195 (  8 25 ) resistor r=0.0246599 //w=0.226 //l=0.118 //layer=m1 \
 //thickness=0.36 //x=5.595 //y=7.09 //x2=5.477 //y2=7.09
r196 (  7 28 ) resistor r=0.0216707 //w=0.215 //l=0.117 //layer=m1 \
 //thickness=0.36 //x=6.245 //y=7.09 //x2=6.362 //y2=7.09
r197 (  7 8 ) resistor r=0.620229 //w=0.131 //l=0.65 //layer=m1 \
 //thickness=0.36 //x=6.245 //y=7.09 //x2=5.595 //y2=7.09
r198 (  6 20 ) resistor r=0.0222262 //w=0.217 //l=0.118 //layer=m1 \
 //thickness=0.36 //x=4.72 //y=7.09 //x2=4.602 //y2=7.09
r199 (  5 25 ) resistor r=0.0246599 //w=0.226 //l=0.117 //layer=m1 \
 //thickness=0.36 //x=5.36 //y=7.09 //x2=5.477 //y2=7.09
r200 (  5 6 ) resistor r=0.610687 //w=0.131 //l=0.64 //layer=m1 \
 //thickness=0.36 //x=5.36 //y=7.09 //x2=4.72 //y2=7.09
r201 (  4 15 ) resistor r=0.0880901 //w=0.191 //l=0.115 //layer=m1 \
 //thickness=0.36 //x=2.715 //y=5.39 //x2=2.6 //y2=5.39
r202 (  3 22 ) resistor r=0.0717383 //w=0.224 //l=0.115 //layer=m1 \
 //thickness=0.36 //x=4.485 //y=5.39 //x2=4.6 //y2=5.39
r203 (  3 4 ) resistor r=1.68893 //w=0.131 //l=1.77 //layer=m1 \
 //thickness=0.36 //x=4.485 //y=5.39 //x2=2.715 //y2=5.39
r204 (  2 9 ) resistor r=0.0243946 //w=0.225 //l=0.123 //layer=m1 \
 //thickness=0.36 //x=1.845 //y=5.39 //x2=1.722 //y2=5.39
r205 (  1 15 ) resistor r=0.0880901 //w=0.191 //l=0.115 //layer=m1 \
 //thickness=0.36 //x=2.485 //y=5.39 //x2=2.6 //y2=5.39
r206 (  1 2 ) resistor r=0.610687 //w=0.131 //l=0.64 //layer=m1 \
 //thickness=0.36 //x=2.485 //y=5.39 //x2=1.845 //y2=5.39
ends PM_VOTERN3X1\%noxref_6

subckt PM_VOTERN3X1\%noxref_7 ( 1 3 4 5 7 9 13 15 21 23 26 38 60 61 62 63 )
c124 ( 63 0 ) capacitor c=0.0346626f //x=9.555 //y=5.205
c125 ( 62 0 ) capacitor c=0.0239063f //x=8.675 //y=5.205
c126 ( 38 0 ) capacitor c=0.0496943f //x=7.94 //y=5.39
c127 ( 26 0 ) capacitor c=0.0229521f //x=5.04 //y=5.56
c128 ( 23 0 ) capacitor c=0.0159821f //x=9.7 //y=6.92
c129 ( 21 0 ) capacitor c=0.00566376f //x=8.82 //y=7.09
c130 ( 15 0 ) capacitor c=0.00945187f //x=7.94 //y=6.92
c131 ( 13 0 ) capacitor c=0.0163615f //x=5.92 //y=5.39
c132 ( 9 0 ) capacitor c=0.0150333f //x=5.04 //y=5.39
c133 ( 7 0 ) capacitor c=0.0068287f //x=9.57 //y=7.09
c134 ( 5 0 ) capacitor c=0.00878908f //x=8.705 //y=7.09
c135 ( 4 0 ) capacitor c=0.00822986f //x=6.035 //y=5.39
c136 ( 3 0 ) capacitor c=0.0577233f //x=7.825 //y=5.39
c137 ( 1 0 ) capacitor c=0.018311f //x=5.805 //y=5.39
r138 (  38 61 ) resistor r=58.1818 //w=0.187 //l=0.85 //layer=li \
 //thickness=0.1 //x=7.94 //y=5.39 //x2=7.94 //y2=6.24
r139 (  26 60 ) resistor r=23.2727 //w=0.187 //l=0.34 //layer=li \
 //thickness=0.1 //x=5.04 //y=5.56 //x2=5.04 //y2=5.9
r140 (  23 63 ) resistor r=9.3 //w=0.17 //l=0.17 //layer=mcon //count=1 \
 //x=9.7 //y=6.92 //x2=9.7 //y2=6.92
r141 (  23 24 ) resistor r=0.0923913 //w=0.23 //l=0.17 //layer=m1 \
 //thickness=0.36 //x=9.695 //y=6.92 //x2=9.695 //y2=7.09
r142 (  20 62 ) resistor r=9.3 //w=0.17 //l=0.17 //layer=mcon //count=1 \
 //x=8.82 //y=6.92 //x2=8.82 //y2=6.92
r143 (  20 21 ) resistor r=0.0957207 //w=0.222 //l=0.17 //layer=m1 \
 //thickness=0.36 //x=8.82 //y=6.92 //x2=8.82 //y2=7.09
r144 (  18 38 ) resistor r=9.3 //w=0.17 //l=0.17 //layer=mcon //count=1 \
 //x=7.94 //y=5.39 //x2=7.94 //y2=5.39
r145 (  15 61 ) resistor r=9.3 //w=0.17 //l=0.17 //layer=mcon //count=1 \
 //x=7.94 //y=6.92 //x2=7.94 //y2=6.92
r146 (  15 16 ) resistor r=0.100236 //w=0.212 //l=0.17 //layer=m1 \
 //thickness=0.36 //x=7.94 //y=6.92 //x2=7.94 //y2=7.09
r147 (  11 26 ) resistor r=9.3 //w=0.17 //l=0.17 //layer=mcon //count=1 \
 //x=5.04 //y=5.56 //x2=5.04 //y2=5.56
r148 (  9 11 ) resistor r=0.100236 //w=0.212 //l=0.17 //layer=m1 \
 //thickness=0.36 //x=5.04 //y=5.39 //x2=5.04 //y2=5.56
r149 (  8 21 ) resistor r=0.0235912 //w=0.222 //l=0.115 //layer=m1 \
 //thickness=0.36 //x=8.935 //y=7.09 //x2=8.82 //y2=7.09
r150 (  7 24 ) resistor r=0.0257089 //w=0.23 //l=0.125 //layer=m1 \
 //thickness=0.36 //x=9.57 //y=7.09 //x2=9.695 //y2=7.09
r151 (  7 8 ) resistor r=0.605916 //w=0.131 //l=0.635 //layer=m1 \
 //thickness=0.36 //x=9.57 //y=7.09 //x2=8.935 //y2=7.09
r152 (  6 16 ) resistor r=0.0208269 //w=0.212 //l=0.115 //layer=m1 \
 //thickness=0.36 //x=8.055 //y=7.09 //x2=7.94 //y2=7.09
r153 (  5 21 ) resistor r=0.0235912 //w=0.222 //l=0.115 //layer=m1 \
 //thickness=0.36 //x=8.705 //y=7.09 //x2=8.82 //y2=7.09
r154 (  5 6 ) resistor r=0.620229 //w=0.131 //l=0.65 //layer=m1 \
 //thickness=0.36 //x=8.705 //y=7.09 //x2=8.055 //y2=7.09
r155 (  4 13 ) resistor r=0.0880901 //w=0.191 //l=0.115 //layer=m1 \
 //thickness=0.36 //x=6.035 //y=5.39 //x2=5.92 //y2=5.39
r156 (  3 18 ) resistor r=0.0717383 //w=0.224 //l=0.115 //layer=m1 \
 //thickness=0.36 //x=7.825 //y=5.39 //x2=7.94 //y2=5.39
r157 (  3 4 ) resistor r=1.70802 //w=0.131 //l=1.79 //layer=m1 \
 //thickness=0.36 //x=7.825 //y=5.39 //x2=6.035 //y2=5.39
r158 (  2 9 ) resistor r=0.0208269 //w=0.212 //l=0.115 //layer=m1 \
 //thickness=0.36 //x=5.155 //y=5.39 //x2=5.04 //y2=5.39
r159 (  1 13 ) resistor r=0.0880901 //w=0.191 //l=0.115 //layer=m1 \
 //thickness=0.36 //x=5.805 //y=5.39 //x2=5.92 //y2=5.39
r160 (  1 2 ) resistor r=0.620229 //w=0.131 //l=0.65 //layer=m1 \
 //thickness=0.36 //x=5.805 //y=5.39 //x2=5.155 //y2=5.39
ends PM_VOTERN3X1\%noxref_7

subckt PM_VOTERN3X1\%GND ( 1 2 7 8 16 24 29 35 41 44 56 71 79 80 81 82 )
c187 ( 82 0 ) capacitor c=0.00828027f //x=8.14 //y=1.045
c188 ( 81 0 ) capacitor c=0.0083251f //x=1.48 //y=1.045
c189 ( 80 0 ) capacitor c=0.110423f //x=7.15 //y=0.175
c190 ( 79 0 ) capacitor c=0.124595f //x=3.82 //y=0.175
c191 ( 71 0 ) capacitor c=0.331202f //x=9.74 //y=0.18
c192 ( 56 0 ) capacitor c=0.118825f //x=6.98 //y=0.175
c193 ( 44 0 ) capacitor c=0.199174f //x=1.23 //y=0.18
c194 ( 41 0 ) capacitor c=0.122869f //x=3.65 //y=0.175
c195 ( 36 0 ) capacitor c=0.00509083f //x=8.33 //y=0.175
c196 ( 35 0 ) capacitor c=0.0256262f //x=4.93 //y=0.18
c197 ( 31 0 ) capacitor c=0.00509083f //x=1.67 //y=0.175
c198 ( 29 0 ) capacitor c=0.102594f //x=9.74 //y=0.18
c199 ( 24 0 ) capacitor c=0.0435289f //x=8.33 //y=1.02
c200 ( 16 0 ) capacitor c=0.10749f //x=8.245 //y=0.175
c201 ( 8 0 ) capacitor c=0.112566f //x=4.915 //y=0.175
c202 ( 7 0 ) capacitor c=0.044044f //x=1.67 //y=1.015
c203 ( 2 0 ) capacitor c=0.0754302f //x=1.585 //y=0.175
r204 (  69 71 ) resistor r=38.7139 //w=0.367 //l=1.11 //layer=li \
 //thickness=0.1 //x=8.63 //y=0.175 //x2=9.74 //y2=0.175
r205 (  67 69 ) resistor r=38.7139 //w=0.367 //l=1.11 //layer=li \
 //thickness=0.1 //x=7.52 //y=0.175 //x2=8.63 //y2=0.175
r206 (  65 80 ) resistor r=5.29055 //w=0.35 //l=0.17 //layer=li \
 //thickness=0.1 //x=7.32 //y=0.175 //x2=7.15 //y2=0.175
r207 (  65 67 ) resistor r=6.97548 //w=0.367 //l=0.2 //layer=li \
 //thickness=0.1 //x=7.32 //y=0.175 //x2=7.52 //y2=0.175
r208 (  59 61 ) resistor r=38.7139 //w=0.367 //l=1.11 //layer=li \
 //thickness=0.1 //x=4.93 //y=0.175 //x2=6.04 //y2=0.175
r209 (  57 79 ) resistor r=5.29055 //w=0.35 //l=0.17 //layer=li \
 //thickness=0.1 //x=3.99 //y=0.175 //x2=3.82 //y2=0.175
r210 (  57 59 ) resistor r=32.7847 //w=0.367 //l=0.94 //layer=li \
 //thickness=0.1 //x=3.99 //y=0.175 //x2=4.93 //y2=0.175
r211 (  56 80 ) resistor r=5.29055 //w=0.35 //l=0.17 //layer=li \
 //thickness=0.1 //x=6.98 //y=0.175 //x2=7.15 //y2=0.175
r212 (  56 61 ) resistor r=32.7847 //w=0.367 //l=0.94 //layer=li \
 //thickness=0.1 //x=6.98 //y=0.175 //x2=6.04 //y2=0.175
r213 (  46 48 ) resistor r=38.7139 //w=0.367 //l=1.11 //layer=li \
 //thickness=0.1 //x=2.34 //y=0.175 //x2=3.45 //y2=0.175
r214 (  44 46 ) resistor r=38.7139 //w=0.367 //l=1.11 //layer=li \
 //thickness=0.1 //x=1.23 //y=0.175 //x2=2.34 //y2=0.175
r215 (  41 79 ) resistor r=5.29055 //w=0.35 //l=0.17 //layer=li \
 //thickness=0.1 //x=3.65 //y=0.175 //x2=3.82 //y2=0.175
r216 (  41 48 ) resistor r=6.97548 //w=0.367 //l=0.2 //layer=li \
 //thickness=0.1 //x=3.65 //y=0.175 //x2=3.45 //y2=0.175
r217 (  38 82 ) resistor r=9.3 //w=0.17 //l=0.17 //layer=mcon //count=1 \
 //x=8.33 //y=1.135 //x2=8.33 //y2=1.135
r218 (  35 59 ) resistor r=3.1 //w=0.17 //l=0.51 //layer=mcon //count=3 \
 //x=4.93 //y=0.18 //x2=4.93 //y2=0.18
r219 (  33 81 ) resistor r=9.3 //w=0.17 //l=0.17 //layer=mcon //count=1 \
 //x=1.67 //y=1.135 //x2=1.67 //y2=1.135
r220 (  29 71 ) resistor r=3.1 //w=0.17 //l=0.51 //layer=mcon //count=3 \
 //x=9.74 //y=0.18 //x2=9.74 //y2=0.18
r221 (  27 69 ) resistor r=3.1 //w=0.17 //l=0.51 //layer=mcon //count=3 \
 //x=8.63 //y=0.18 //x2=8.63 //y2=0.18
r222 (  27 29 ) resistor r=0.446141 //w=0.311 //l=1.11 //layer=m1 \
 //thickness=0.36 //x=8.63 //y=0.175 //x2=9.74 //y2=0.175
r223 (  25 36 ) resistor r=0.028033 //w=0.35 //l=0.085 //layer=m1 \
 //thickness=0.36 //x=8.415 //y=0.175 //x2=8.33 //y2=0.175
r224 (  25 27 ) resistor r=0.0864148 //w=0.311 //l=0.215 //layer=m1 \
 //thickness=0.36 //x=8.415 //y=0.175 //x2=8.63 //y2=0.175
r225 (  24 38 ) resistor r=0.0703067 //w=0.254 //l=0.11649 //layer=m1 \
 //thickness=0.36 //x=8.33 //y=1.02 //x2=8.327 //y2=1.135
r226 (  23 36 ) resistor r=0.0413265 //w=0.7 //l=0.175 //layer=m1 \
 //thickness=0.36 //x=8.33 //y=0.35 //x2=8.33 //y2=0.175
r227 (  23 24 ) resistor r=0.639313 //w=0.131 //l=0.67 //layer=m1 \
 //thickness=0.36 //x=8.33 //y=0.35 //x2=8.33 //y2=1.02
r228 (  22 67 ) resistor r=3.1 //w=0.17 //l=0.51 //layer=mcon //count=3 \
 //x=7.52 //y=0.18 //x2=7.52 //y2=0.18
r229 (  20 61 ) resistor r=3.1 //w=0.17 //l=0.51 //layer=mcon //count=3 \
 //x=6.04 //y=0.18 //x2=6.04 //y2=0.18
r230 (  20 22 ) resistor r=0.594855 //w=0.311 //l=1.48 //layer=m1 \
 //thickness=0.36 //x=6.04 //y=0.175 //x2=7.52 //y2=0.175
r231 (  17 35 ) resistor r=0.028033 //w=0.35 //l=0.085 //layer=m1 \
 //thickness=0.36 //x=5.085 //y=0.175 //x2=5 //y2=0.175
r232 (  16 36 ) resistor r=0.028033 //w=0.35 //l=0.085 //layer=m1 \
 //thickness=0.36 //x=8.245 //y=0.175 //x2=8.33 //y2=0.175
r233 (  16 22 ) resistor r=0.291399 //w=0.311 //l=0.725 //layer=m1 \
 //thickness=0.36 //x=8.245 //y=0.175 //x2=7.52 //y2=0.175
r234 (  13 48 ) resistor r=3.1 //w=0.17 //l=0.51 //layer=mcon //count=3 \
 //x=3.45 //y=0.18 //x2=3.45 //y2=0.18
r235 (  11 46 ) resistor r=3.1 //w=0.17 //l=0.51 //layer=mcon //count=3 \
 //x=2.34 //y=0.18 //x2=2.34 //y2=0.18
r236 (  11 13 ) resistor r=0.446141 //w=0.311 //l=1.11 //layer=m1 \
 //thickness=0.36 //x=2.34 //y=0.175 //x2=3.45 //y2=0.175
r237 (  9 31 ) resistor r=0.028033 //w=0.35 //l=0.085 //layer=m1 \
 //thickness=0.36 //x=1.755 //y=0.175 //x2=1.67 //y2=0.175
r238 (  9 11 ) resistor r=0.235129 //w=0.311 //l=0.585 //layer=m1 \
 //thickness=0.36 //x=1.755 //y=0.175 //x2=2.34 //y2=0.175
r239 (  8 35 ) resistor r=0.028033 //w=0.35 //l=0.085 //layer=m1 \
 //thickness=0.36 //x=4.915 //y=0.175 //x2=5 //y2=0.175
r240 (  8 13 ) resistor r=0.588826 //w=0.311 //l=1.465 //layer=m1 \
 //thickness=0.36 //x=4.915 //y=0.175 //x2=3.45 //y2=0.175
r241 (  7 33 ) resistor r=0.0729089 //w=0.249 //l=0.120996 //layer=m1 \
 //thickness=0.36 //x=1.67 //y=1.015 //x2=1.672 //y2=1.135
r242 (  6 31 ) resistor r=0.0413265 //w=0.7 //l=0.175 //layer=m1 \
 //thickness=0.36 //x=1.67 //y=0.35 //x2=1.67 //y2=0.175
r243 (  6 7 ) resistor r=0.634542 //w=0.131 //l=0.665 //layer=m1 \
 //thickness=0.36 //x=1.67 //y=0.35 //x2=1.67 //y2=1.015
r244 (  4 44 ) resistor r=3.1 //w=0.17 //l=0.51 //layer=mcon //count=3 \
 //x=1.23 //y=0.18 //x2=1.23 //y2=0.18
r245 (  2 31 ) resistor r=0.028033 //w=0.35 //l=0.085 //layer=m1 \
 //thickness=0.36 //x=1.585 //y=0.175 //x2=1.67 //y2=0.175
r246 (  2 4 ) resistor r=0.142685 //w=0.311 //l=0.355 //layer=m1 \
 //thickness=0.36 //x=1.585 //y=0.175 //x2=1.23 //y2=0.175
r247 (  1 20 ) resistor r=0.223071 //w=0.311 //l=0.555 //layer=m1 \
 //thickness=0.36 //x=5.485 //y=0.175 //x2=6.04 //y2=0.175
r248 (  1 17 ) resistor r=0.160772 //w=0.311 //l=0.4 //layer=m1 \
 //thickness=0.36 //x=5.485 //y=0.175 //x2=5.085 //y2=0.175
ends PM_VOTERN3X1\%GND

subckt PM_VOTERN3X1\%noxref_9 ( 1 5 9 10 13 17 29 )
c65 ( 29 0 ) capacitor c=0.0786297f //x=1.05 //y=0.545
c66 ( 17 0 ) capacitor c=0.00678917f //x=3.125 //y=0.795
c67 ( 13 0 ) capacitor c=0.0154169f //x=3.04 //y=0.71
c68 ( 10 0 ) capacitor c=0.00990031f //x=2.155 //y=1.675
c69 ( 9 0 ) capacitor c=0.00770028f //x=2.155 //y=0.795
c70 ( 5 0 ) capacitor c=0.028994f //x=2.07 //y=1.76
c71 ( 1 0 ) capacitor c=0.0049595f //x=1.185 //y=1.675
r72 (  17 29 ) resistor r=3.57586 //w=0.17 //l=0.125 //layer=li \
 //thickness=0.1 //x=3.125 //y=0.795 //x2=3.125 //y2=0.67
r73 (  17 29 ) resistor r=41.4118 //w=0.187 //l=0.605 //layer=li \
 //thickness=0.1 //x=3.125 //y=0.795 //x2=3.125 //y2=1.4
r74 (  14 29 ) resistor r=3.57586 //w=0.17 //l=0.103078 //layer=li \
 //thickness=0.1 //x=2.24 //y=0.71 //x2=2.155 //y2=0.67
r75 (  14 29 ) resistor r=27.0374 //w=0.187 //l=0.395 //layer=li \
 //thickness=0.1 //x=2.24 //y=0.71 //x2=2.635 //y2=0.71
r76 (  13 29 ) resistor r=3.57586 //w=0.17 //l=0.103078 //layer=li \
 //thickness=0.1 //x=3.04 //y=0.71 //x2=3.125 //y2=0.67
r77 (  13 29 ) resistor r=27.7219 //w=0.187 //l=0.405 //layer=li \
 //thickness=0.1 //x=3.04 //y=0.71 //x2=2.635 //y2=0.71
r78 (  10 29 ) resistor r=3.57586 //w=0.17 //l=0.125 //layer=li \
 //thickness=0.1 //x=2.155 //y=1.675 //x2=2.155 //y2=1.8
r79 (  10 29 ) resistor r=42.0963 //w=0.187 //l=0.615 //layer=li \
 //thickness=0.1 //x=2.155 //y=1.675 //x2=2.155 //y2=1.06
r80 (  9 29 ) resistor r=3.57586 //w=0.17 //l=0.125 //layer=li //thickness=0.1 \
 //x=2.155 //y=0.795 //x2=2.155 //y2=0.67
r81 (  9 29 ) resistor r=18.139 //w=0.187 //l=0.265 //layer=li //thickness=0.1 \
 //x=2.155 //y=0.795 //x2=2.155 //y2=1.06
r82 (  6 29 ) resistor r=3.57586 //w=0.17 //l=0.103078 //layer=li \
 //thickness=0.1 //x=1.27 //y=1.76 //x2=1.185 //y2=1.8
r83 (  6 29 ) resistor r=27.3797 //w=0.187 //l=0.4 //layer=li //thickness=0.1 \
 //x=1.27 //y=1.76 //x2=1.67 //y2=1.76
r84 (  5 29 ) resistor r=3.57586 //w=0.17 //l=0.103078 //layer=li \
 //thickness=0.1 //x=2.07 //y=1.76 //x2=2.155 //y2=1.8
r85 (  5 29 ) resistor r=27.3797 //w=0.187 //l=0.4 //layer=li //thickness=0.1 \
 //x=2.07 //y=1.76 //x2=1.67 //y2=1.76
r86 (  1 29 ) resistor r=3.57586 //w=0.17 //l=0.125 //layer=li //thickness=0.1 \
 //x=1.185 //y=1.675 //x2=1.185 //y2=1.8
r87 (  1 29 ) resistor r=42.0963 //w=0.187 //l=0.615 //layer=li \
 //thickness=0.1 //x=1.185 //y=1.675 //x2=1.185 //y2=1.06
ends PM_VOTERN3X1\%noxref_9

subckt PM_VOTERN3X1\%noxref_12 ( 1 5 9 10 13 17 29 )
c66 ( 29 0 ) capacitor c=0.07461f //x=4.38 //y=0.545
c67 ( 17 0 ) capacitor c=0.00678917f //x=6.455 //y=0.795
c68 ( 13 0 ) capacitor c=0.0158009f //x=6.37 //y=0.71
c69 ( 10 0 ) capacitor c=0.009705f //x=5.485 //y=1.675
c70 ( 9 0 ) capacitor c=0.00770028f //x=5.485 //y=0.795
c71 ( 5 0 ) capacitor c=0.0202311f //x=5.4 //y=1.76
c72 ( 1 0 ) capacitor c=0.00935657f //x=4.515 //y=1.675
r73 (  17 29 ) resistor r=3.57586 //w=0.17 //l=0.125 //layer=li \
 //thickness=0.1 //x=6.455 //y=0.795 //x2=6.455 //y2=0.67
r74 (  17 29 ) resistor r=41.4118 //w=0.187 //l=0.605 //layer=li \
 //thickness=0.1 //x=6.455 //y=0.795 //x2=6.455 //y2=1.4
r75 (  14 29 ) resistor r=3.57586 //w=0.17 //l=0.103078 //layer=li \
 //thickness=0.1 //x=5.57 //y=0.71 //x2=5.485 //y2=0.67
r76 (  14 29 ) resistor r=27.3797 //w=0.187 //l=0.4 //layer=li //thickness=0.1 \
 //x=5.57 //y=0.71 //x2=5.97 //y2=0.71
r77 (  13 29 ) resistor r=3.57586 //w=0.17 //l=0.103078 //layer=li \
 //thickness=0.1 //x=6.37 //y=0.71 //x2=6.455 //y2=0.67
r78 (  13 29 ) resistor r=27.3797 //w=0.187 //l=0.4 //layer=li //thickness=0.1 \
 //x=6.37 //y=0.71 //x2=5.97 //y2=0.71
r79 (  10 29 ) resistor r=3.57586 //w=0.17 //l=0.125 //layer=li \
 //thickness=0.1 //x=5.485 //y=1.675 //x2=5.485 //y2=1.8
r80 (  10 29 ) resistor r=42.0963 //w=0.187 //l=0.615 //layer=li \
 //thickness=0.1 //x=5.485 //y=1.675 //x2=5.485 //y2=1.06
r81 (  9 29 ) resistor r=3.57586 //w=0.17 //l=0.125 //layer=li //thickness=0.1 \
 //x=5.485 //y=0.795 //x2=5.485 //y2=0.67
r82 (  9 29 ) resistor r=18.139 //w=0.187 //l=0.265 //layer=li //thickness=0.1 \
 //x=5.485 //y=0.795 //x2=5.485 //y2=1.06
r83 (  6 29 ) resistor r=3.57586 //w=0.17 //l=0.103078 //layer=li \
 //thickness=0.1 //x=4.6 //y=1.76 //x2=4.515 //y2=1.8
r84 (  6 29 ) resistor r=27.3797 //w=0.187 //l=0.4 //layer=li //thickness=0.1 \
 //x=4.6 //y=1.76 //x2=5 //y2=1.76
r85 (  5 29 ) resistor r=3.57586 //w=0.17 //l=0.103078 //layer=li \
 //thickness=0.1 //x=5.4 //y=1.76 //x2=5.485 //y2=1.8
r86 (  5 29 ) resistor r=27.3797 //w=0.187 //l=0.4 //layer=li //thickness=0.1 \
 //x=5.4 //y=1.76 //x2=5 //y2=1.76
r87 (  1 29 ) resistor r=3.57586 //w=0.17 //l=0.125 //layer=li //thickness=0.1 \
 //x=4.515 //y=1.675 //x2=4.515 //y2=1.8
r88 (  1 29 ) resistor r=42.0963 //w=0.187 //l=0.615 //layer=li \
 //thickness=0.1 //x=4.515 //y=1.675 //x2=4.515 //y2=1.06
ends PM_VOTERN3X1\%noxref_12

subckt PM_VOTERN3X1\%noxref_13 ( 1 5 9 10 13 17 29 )
c62 ( 29 0 ) capacitor c=0.0687486f //x=7.71 //y=0.545
c63 ( 17 0 ) capacitor c=0.00709795f //x=9.785 //y=0.795
c64 ( 13 0 ) capacitor c=0.0152565f //x=9.7 //y=0.71
c65 ( 10 0 ) capacitor c=0.0075177f //x=8.815 //y=1.675
c66 ( 9 0 ) capacitor c=0.00770028f //x=8.815 //y=0.795
c67 ( 5 0 ) capacitor c=0.0236235f //x=8.73 //y=1.76
c68 ( 1 0 ) capacitor c=0.00498306f //x=7.845 //y=1.675
r69 (  17 29 ) resistor r=3.57586 //w=0.17 //l=0.125 //layer=li \
 //thickness=0.1 //x=9.785 //y=0.795 //x2=9.785 //y2=0.67
r70 (  17 29 ) resistor r=18.139 //w=0.187 //l=0.265 //layer=li \
 //thickness=0.1 //x=9.785 //y=0.795 //x2=9.785 //y2=1.06
r71 (  14 29 ) resistor r=3.57586 //w=0.17 //l=0.103078 //layer=li \
 //thickness=0.1 //x=8.9 //y=0.71 //x2=8.815 //y2=0.67
r72 (  14 29 ) resistor r=27.3797 //w=0.187 //l=0.4 //layer=li //thickness=0.1 \
 //x=8.9 //y=0.71 //x2=9.3 //y2=0.71
r73 (  13 29 ) resistor r=3.57586 //w=0.17 //l=0.103078 //layer=li \
 //thickness=0.1 //x=9.7 //y=0.71 //x2=9.785 //y2=0.67
r74 (  13 29 ) resistor r=27.3797 //w=0.187 //l=0.4 //layer=li //thickness=0.1 \
 //x=9.7 //y=0.71 //x2=9.3 //y2=0.71
r75 (  10 29 ) resistor r=3.57586 //w=0.17 //l=0.125 //layer=li \
 //thickness=0.1 //x=8.815 //y=1.675 //x2=8.815 //y2=1.8
r76 (  10 29 ) resistor r=42.0963 //w=0.187 //l=0.615 //layer=li \
 //thickness=0.1 //x=8.815 //y=1.675 //x2=8.815 //y2=1.06
r77 (  9 29 ) resistor r=3.57586 //w=0.17 //l=0.125 //layer=li //thickness=0.1 \
 //x=8.815 //y=0.795 //x2=8.815 //y2=0.67
r78 (  9 29 ) resistor r=18.139 //w=0.187 //l=0.265 //layer=li //thickness=0.1 \
 //x=8.815 //y=0.795 //x2=8.815 //y2=1.06
r79 (  6 29 ) resistor r=3.57586 //w=0.17 //l=0.103078 //layer=li \
 //thickness=0.1 //x=7.93 //y=1.76 //x2=7.845 //y2=1.8
r80 (  6 29 ) resistor r=27.3797 //w=0.187 //l=0.4 //layer=li //thickness=0.1 \
 //x=7.93 //y=1.76 //x2=8.33 //y2=1.76
r81 (  5 29 ) resistor r=3.57586 //w=0.17 //l=0.103078 //layer=li \
 //thickness=0.1 //x=8.73 //y=1.76 //x2=8.815 //y2=1.8
r82 (  5 29 ) resistor r=27.3797 //w=0.187 //l=0.4 //layer=li //thickness=0.1 \
 //x=8.73 //y=1.76 //x2=8.33 //y2=1.76
r83 (  1 29 ) resistor r=3.57586 //w=0.17 //l=0.125 //layer=li //thickness=0.1 \
 //x=7.845 //y=1.675 //x2=7.845 //y2=1.8
r84 (  1 29 ) resistor r=42.0963 //w=0.187 //l=0.615 //layer=li \
 //thickness=0.1 //x=7.845 //y=1.675 //x2=7.845 //y2=1.06
ends PM_VOTERN3X1\%noxref_13
