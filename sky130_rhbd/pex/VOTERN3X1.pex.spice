// File: VOTERN3X1.spi.pex
// Created: Tue Apr 29 10:46:51 2025
// Program "Calibre xRC"
// Version "v2023.2_27.15"
// Nominal Temperature: 30C
// Circuit Temperature: 30C
//
simulator lang=spectre
subckt PM_VOTERN3X1\%GND ( 1 19 23 26 31 39 45 51 64 68 71 73 74 75 )
c138 ( 75 0 ) capacitor c=0.0215071f //x=8.14 //y=1.045
c139 ( 74 0 ) capacitor c=0.0215071f //x=4.81 //y=1.045
c140 ( 73 0 ) capacitor c=0.0208055f //x=1.48 //y=1.045
c141 ( 72 0 ) capacitor c=0.00446416f //x=8.33 //y=0.175
c142 ( 71 0 ) capacitor c=0.101602f //x=7.15 //y=0.175
c143 ( 70 0 ) capacitor c=0.00446416f //x=4.93 //y=0.18
c144 ( 68 0 ) capacitor c=0.11818f //x=3.82 //y=0.175
c145 ( 67 0 ) capacitor c=0.00446416f //x=1.67 //y=0.175
c146 ( 64 0 ) capacitor c=0.278733f //x=9.74 //y=0.18
c147 ( 51 0 ) capacitor c=0.0393378f //x=8.245 //y=0.175
c148 ( 45 0 ) capacitor c=0.0725462f //x=6.98 //y=0.175
c149 ( 39 0 ) capacitor c=0.0391794f //x=4.915 //y=0.175
c150 ( 31 0 ) capacitor c=0.0726871f //x=3.65 //y=0.175
c151 ( 26 0 ) capacitor c=0.195706f //x=1.23 //y=0.18
c152 ( 23 0 ) capacitor c=0.0425937f //x=1.585 //y=0.175
c153 ( 19 0 ) capacitor c=0.374238f //x=9.74 //y=0.18
r154 (  62 64 ) resistor r=38.7139 //w=0.367 //l=1.11 //layer=li \
 //thickness=0.1 //x=8.63 //y=0.175 //x2=9.74 //y2=0.175
r155 (  60 72 ) resistor r=2.87058 //w=0.35 //l=0.085 //layer=li \
 //thickness=0.1 //x=8.415 //y=0.175 //x2=8.33 //y2=0.175
r156 (  60 62 ) resistor r=7.49864 //w=0.367 //l=0.215 //layer=li \
 //thickness=0.1 //x=8.415 //y=0.175 //x2=8.63 //y2=0.175
r157 (  55 72 ) resistor r=4.23183 //w=0.7 //l=0.175 //layer=li \
 //thickness=0.1 //x=8.33 //y=0.35 //x2=8.33 //y2=0.175
r158 (  55 75 ) resistor r=53.7326 //w=0.187 //l=0.785 //layer=li \
 //thickness=0.1 //x=8.33 //y=0.35 //x2=8.33 //y2=1.135
r159 (  52 71 ) resistor r=5.29055 //w=0.35 //l=0.17 //layer=li \
 //thickness=0.1 //x=7.32 //y=0.175 //x2=7.15 //y2=0.175
r160 (  52 54 ) resistor r=6.97548 //w=0.367 //l=0.2 //layer=li \
 //thickness=0.1 //x=7.32 //y=0.175 //x2=7.52 //y2=0.175
r161 (  51 72 ) resistor r=2.87058 //w=0.35 //l=0.085 //layer=li \
 //thickness=0.1 //x=8.245 //y=0.175 //x2=8.33 //y2=0.175
r162 (  51 54 ) resistor r=25.2861 //w=0.367 //l=0.725 //layer=li \
 //thickness=0.1 //x=8.245 //y=0.175 //x2=7.52 //y2=0.175
r163 (  46 70 ) resistor r=2.87058 //w=0.35 //l=0.085 //layer=li \
 //thickness=0.1 //x=5.085 //y=0.175 //x2=5 //y2=0.175
r164 (  46 48 ) resistor r=33.3079 //w=0.367 //l=0.955 //layer=li \
 //thickness=0.1 //x=5.085 //y=0.175 //x2=6.04 //y2=0.175
r165 (  45 71 ) resistor r=5.29055 //w=0.35 //l=0.17 //layer=li \
 //thickness=0.1 //x=6.98 //y=0.175 //x2=7.15 //y2=0.175
r166 (  45 48 ) resistor r=32.7847 //w=0.367 //l=0.94 //layer=li \
 //thickness=0.1 //x=6.98 //y=0.175 //x2=6.04 //y2=0.175
r167 (  41 70 ) resistor r=4.23183 //w=0.7 //l=0.175 //layer=li \
 //thickness=0.1 //x=5 //y=0.35 //x2=5 //y2=0.175
r168 (  41 74 ) resistor r=53.7326 //w=0.187 //l=0.785 //layer=li \
 //thickness=0.1 //x=5 //y=0.35 //x2=5 //y2=1.135
r169 (  40 68 ) resistor r=5.29055 //w=0.35 //l=0.17 //layer=li \
 //thickness=0.1 //x=3.99 //y=0.175 //x2=3.82 //y2=0.175
r170 (  39 70 ) resistor r=2.87058 //w=0.35 //l=0.085 //layer=li \
 //thickness=0.1 //x=4.915 //y=0.175 //x2=5 //y2=0.175
r171 (  39 40 ) resistor r=32.2616 //w=0.367 //l=0.925 //layer=li \
 //thickness=0.1 //x=4.915 //y=0.175 //x2=3.99 //y2=0.175
r172 (  34 36 ) resistor r=38.7139 //w=0.367 //l=1.11 //layer=li \
 //thickness=0.1 //x=2.34 //y=0.175 //x2=3.45 //y2=0.175
r173 (  32 67 ) resistor r=2.87058 //w=0.35 //l=0.085 //layer=li \
 //thickness=0.1 //x=1.755 //y=0.175 //x2=1.67 //y2=0.175
r174 (  32 34 ) resistor r=20.4033 //w=0.367 //l=0.585 //layer=li \
 //thickness=0.1 //x=1.755 //y=0.175 //x2=2.34 //y2=0.175
r175 (  31 68 ) resistor r=5.29055 //w=0.35 //l=0.17 //layer=li \
 //thickness=0.1 //x=3.65 //y=0.175 //x2=3.82 //y2=0.175
r176 (  31 36 ) resistor r=6.97548 //w=0.367 //l=0.2 //layer=li \
 //thickness=0.1 //x=3.65 //y=0.175 //x2=3.45 //y2=0.175
r177 (  27 67 ) resistor r=4.23183 //w=0.7 //l=0.175 //layer=li \
 //thickness=0.1 //x=1.67 //y=0.35 //x2=1.67 //y2=0.175
r178 (  27 73 ) resistor r=53.7326 //w=0.187 //l=0.785 //layer=li \
 //thickness=0.1 //x=1.67 //y=0.35 //x2=1.67 //y2=1.135
r179 (  23 67 ) resistor r=2.87058 //w=0.35 //l=0.085 //layer=li \
 //thickness=0.1 //x=1.585 //y=0.175 //x2=1.67 //y2=0.175
r180 (  23 26 ) resistor r=12.3815 //w=0.367 //l=0.355 //layer=li \
 //thickness=0.1 //x=1.585 //y=0.175 //x2=1.23 //y2=0.175
r181 (  19 64 ) resistor r=3.1 //w=0.17 //l=0.51 //layer=mcon //count=3 \
 //x=9.74 //y=0.18 //x2=9.74 //y2=0.18
r182 (  17 62 ) resistor r=3.1 //w=0.17 //l=0.51 //layer=mcon //count=3 \
 //x=8.63 //y=0.18 //x2=8.63 //y2=0.18
r183 (  17 19 ) resistor r=0.446141 //w=0.311 //l=1.11 //layer=m1 \
 //thickness=0.36 //x=8.63 //y=0.175 //x2=9.74 //y2=0.175
r184 (  15 54 ) resistor r=3.1 //w=0.17 //l=0.51 //layer=mcon //count=3 \
 //x=7.52 //y=0.18 //x2=7.52 //y2=0.18
r185 (  15 17 ) resistor r=0.446141 //w=0.311 //l=1.11 //layer=m1 \
 //thickness=0.36 //x=7.52 //y=0.175 //x2=8.63 //y2=0.175
r186 (  13 48 ) resistor r=3.1 //w=0.17 //l=0.51 //layer=mcon //count=3 \
 //x=6.04 //y=0.18 //x2=6.04 //y2=0.18
r187 (  13 15 ) resistor r=0.594855 //w=0.311 //l=1.48 //layer=m1 \
 //thickness=0.36 //x=6.04 //y=0.175 //x2=7.52 //y2=0.175
r188 (  10 70 ) resistor r=3.1 //w=0.17 //l=0.51 //layer=mcon //count=3 \
 //x=4.93 //y=0.18 //x2=4.93 //y2=0.18
r189 (  8 36 ) resistor r=3.1 //w=0.17 //l=0.51 //layer=mcon //count=3 \
 //x=3.45 //y=0.18 //x2=3.45 //y2=0.18
r190 (  8 10 ) resistor r=0.594855 //w=0.311 //l=1.48 //layer=m1 \
 //thickness=0.36 //x=3.45 //y=0.175 //x2=4.93 //y2=0.175
r191 (  6 34 ) resistor r=3.1 //w=0.17 //l=0.51 //layer=mcon //count=3 \
 //x=2.34 //y=0.18 //x2=2.34 //y2=0.18
r192 (  6 8 ) resistor r=0.446141 //w=0.311 //l=1.11 //layer=m1 \
 //thickness=0.36 //x=2.34 //y=0.175 //x2=3.45 //y2=0.175
r193 (  3 26 ) resistor r=3.1 //w=0.17 //l=0.51 //layer=mcon //count=3 \
 //x=1.23 //y=0.18 //x2=1.23 //y2=0.18
r194 (  3 6 ) resistor r=0.446141 //w=0.311 //l=1.11 //layer=m1 \
 //thickness=0.36 //x=1.23 //y=0.175 //x2=2.34 //y2=0.175
r195 (  1 13 ) resistor r=0.223071 //w=0.311 //l=0.555 //layer=m1 \
 //thickness=0.36 //x=5.485 //y=0.175 //x2=6.04 //y2=0.175
r196 (  1 10 ) resistor r=0.223071 //w=0.311 //l=0.555 //layer=m1 \
 //thickness=0.36 //x=5.485 //y=0.175 //x2=4.93 //y2=0.175
ends PM_VOTERN3X1\%GND

subckt PM_VOTERN3X1\%VDD ( 1 19 31 39 55 70 74 77 78 79 80 81 )
c106 ( 81 0 ) capacitor c=0.0476809f //x=2.895 //y=5.205
c107 ( 80 0 ) capacitor c=0.0241715f //x=2.015 //y=5.205
c108 ( 79 0 ) capacitor c=0.0467094f //x=1.145 //y=5.205
c109 ( 78 0 ) capacitor c=0.113266f //x=7.15 //y=7.585
c110 ( 77 0 ) capacitor c=0.121189f //x=3.82 //y=7.585
c111 ( 76 0 ) capacitor c=0.00597439f //x=3.04 //y=7.585
c112 ( 75 0 ) capacitor c=0.00597439f //x=2.16 //y=7.585
c113 ( 74 0 ) capacitor c=0.264173f //x=1.23 //y=7.58
c114 ( 70 0 ) capacitor c=0.356757f //x=9.74 //y=7.58
c115 ( 55 0 ) capacitor c=0.12864f //x=6.98 //y=7.585
c116 ( 49 0 ) capacitor c=0.0277785f //x=3.65 //y=7.585
c117 ( 39 0 ) capacitor c=0.0295446f //x=2.955 //y=7.585
c118 ( 31 0 ) capacitor c=0.029367f //x=2.075 //y=7.585
c119 ( 19 0 ) capacitor c=0.418413f //x=9.74 //y=7.58
r120 (  68 70 ) resistor r=38.7139 //w=0.367 //l=1.11 //layer=li \
 //thickness=0.1 //x=8.63 //y=7.585 //x2=9.74 //y2=7.585
r121 (  66 68 ) resistor r=38.7139 //w=0.367 //l=1.11 //layer=li \
 //thickness=0.1 //x=7.52 //y=7.585 //x2=8.63 //y2=7.585
r122 (  64 78 ) resistor r=5.29055 //w=0.35 //l=0.17 //layer=li \
 //thickness=0.1 //x=7.32 //y=7.585 //x2=7.15 //y2=7.585
r123 (  64 66 ) resistor r=6.97548 //w=0.367 //l=0.2 //layer=li \
 //thickness=0.1 //x=7.32 //y=7.585 //x2=7.52 //y2=7.585
r124 (  58 60 ) resistor r=38.7139 //w=0.367 //l=1.11 //layer=li \
 //thickness=0.1 //x=4.93 //y=7.585 //x2=6.04 //y2=7.585
r125 (  56 77 ) resistor r=5.29055 //w=0.35 //l=0.17 //layer=li \
 //thickness=0.1 //x=3.99 //y=7.585 //x2=3.82 //y2=7.585
r126 (  56 58 ) resistor r=32.7847 //w=0.367 //l=0.94 //layer=li \
 //thickness=0.1 //x=3.99 //y=7.585 //x2=4.93 //y2=7.585
r127 (  55 78 ) resistor r=5.29055 //w=0.35 //l=0.17 //layer=li \
 //thickness=0.1 //x=6.98 //y=7.585 //x2=7.15 //y2=7.585
r128 (  55 60 ) resistor r=32.7847 //w=0.367 //l=0.94 //layer=li \
 //thickness=0.1 //x=6.98 //y=7.585 //x2=6.04 //y2=7.585
r129 (  50 76 ) resistor r=2.87058 //w=0.35 //l=0.085 //layer=li \
 //thickness=0.1 //x=3.125 //y=7.585 //x2=3.04 //y2=7.585
r130 (  50 52 ) resistor r=11.3351 //w=0.367 //l=0.325 //layer=li \
 //thickness=0.1 //x=3.125 //y=7.585 //x2=3.45 //y2=7.585
r131 (  49 77 ) resistor r=5.29055 //w=0.35 //l=0.17 //layer=li \
 //thickness=0.1 //x=3.65 //y=7.585 //x2=3.82 //y2=7.585
r132 (  49 52 ) resistor r=6.97548 //w=0.367 //l=0.2 //layer=li \
 //thickness=0.1 //x=3.65 //y=7.585 //x2=3.45 //y2=7.585
r133 (  43 76 ) resistor r=4.23183 //w=0.7 //l=0.175 //layer=li \
 //thickness=0.1 //x=3.04 //y=7.41 //x2=3.04 //y2=7.585
r134 (  43 81 ) resistor r=56.8128 //w=0.187 //l=0.83 //layer=li \
 //thickness=0.1 //x=3.04 //y=7.41 //x2=3.04 //y2=6.58
r135 (  40 75 ) resistor r=2.87058 //w=0.35 //l=0.085 //layer=li \
 //thickness=0.1 //x=2.245 //y=7.585 //x2=2.16 //y2=7.585
r136 (  40 42 ) resistor r=3.31335 //w=0.367 //l=0.095 //layer=li \
 //thickness=0.1 //x=2.245 //y=7.585 //x2=2.34 //y2=7.585
r137 (  39 76 ) resistor r=2.87058 //w=0.35 //l=0.085 //layer=li \
 //thickness=0.1 //x=2.955 //y=7.585 //x2=3.04 //y2=7.585
r138 (  39 42 ) resistor r=21.4496 //w=0.367 //l=0.615 //layer=li \
 //thickness=0.1 //x=2.955 //y=7.585 //x2=2.34 //y2=7.585
r139 (  33 75 ) resistor r=4.23183 //w=0.7 //l=0.175 //layer=li \
 //thickness=0.1 //x=2.16 //y=7.41 //x2=2.16 //y2=7.585
r140 (  33 80 ) resistor r=33.5401 //w=0.187 //l=0.49 //layer=li \
 //thickness=0.1 //x=2.16 //y=7.41 //x2=2.16 //y2=6.92
r141 (  32 74 ) resistor r=2.87058 //w=0.35 //l=0.085 //layer=li \
 //thickness=0.1 //x=1.365 //y=7.585 //x2=1.28 //y2=7.585
r142 (  31 75 ) resistor r=2.87058 //w=0.35 //l=0.085 //layer=li \
 //thickness=0.1 //x=2.075 //y=7.585 //x2=2.16 //y2=7.585
r143 (  31 32 ) resistor r=24.7629 //w=0.367 //l=0.71 //layer=li \
 //thickness=0.1 //x=2.075 //y=7.585 //x2=1.365 //y2=7.585
r144 (  25 74 ) resistor r=4.23183 //w=0.7 //l=0.175 //layer=li \
 //thickness=0.1 //x=1.28 //y=7.41 //x2=1.28 //y2=7.585
r145 (  25 79 ) resistor r=56.8128 //w=0.187 //l=0.83 //layer=li \
 //thickness=0.1 //x=1.28 //y=7.41 //x2=1.28 //y2=6.58
r146 (  19 70 ) resistor r=3.1 //w=0.17 //l=0.51 //layer=mcon //count=3 \
 //x=9.74 //y=7.58 //x2=9.74 //y2=7.58
r147 (  17 68 ) resistor r=3.1 //w=0.17 //l=0.51 //layer=mcon //count=3 \
 //x=8.63 //y=7.58 //x2=8.63 //y2=7.58
r148 (  17 19 ) resistor r=0.446141 //w=0.311 //l=1.11 //layer=m1 \
 //thickness=0.36 //x=8.63 //y=7.585 //x2=9.74 //y2=7.585
r149 (  15 66 ) resistor r=3.1 //w=0.17 //l=0.51 //layer=mcon //count=3 \
 //x=7.52 //y=7.58 //x2=7.52 //y2=7.58
r150 (  15 17 ) resistor r=0.446141 //w=0.311 //l=1.11 //layer=m1 \
 //thickness=0.36 //x=7.52 //y=7.585 //x2=8.63 //y2=7.585
r151 (  13 60 ) resistor r=3.1 //w=0.17 //l=0.51 //layer=mcon //count=3 \
 //x=6.04 //y=7.58 //x2=6.04 //y2=7.58
r152 (  13 15 ) resistor r=0.594855 //w=0.311 //l=1.48 //layer=m1 \
 //thickness=0.36 //x=6.04 //y=7.585 //x2=7.52 //y2=7.585
r153 (  10 58 ) resistor r=3.1 //w=0.17 //l=0.51 //layer=mcon //count=3 \
 //x=4.93 //y=7.58 //x2=4.93 //y2=7.58
r154 (  8 52 ) resistor r=3.1 //w=0.17 //l=0.51 //layer=mcon //count=3 \
 //x=3.45 //y=7.58 //x2=3.45 //y2=7.58
r155 (  8 10 ) resistor r=0.594855 //w=0.311 //l=1.48 //layer=m1 \
 //thickness=0.36 //x=3.45 //y=7.585 //x2=4.93 //y2=7.585
r156 (  6 42 ) resistor r=3.1 //w=0.17 //l=0.51 //layer=mcon //count=3 \
 //x=2.34 //y=7.58 //x2=2.34 //y2=7.58
r157 (  6 8 ) resistor r=0.446141 //w=0.311 //l=1.11 //layer=m1 \
 //thickness=0.36 //x=2.34 //y=7.585 //x2=3.45 //y2=7.585
r158 (  3 74 ) resistor r=3.1 //w=0.17 //l=0.51 //layer=mcon //count=3 \
 //x=1.23 //y=7.58 //x2=1.23 //y2=7.58
r159 (  3 6 ) resistor r=0.446141 //w=0.311 //l=1.11 //layer=m1 \
 //thickness=0.36 //x=1.23 //y=7.585 //x2=2.34 //y2=7.585
r160 (  1 13 ) resistor r=0.223071 //w=0.311 //l=0.555 //layer=m1 \
 //thickness=0.36 //x=5.485 //y=7.585 //x2=6.04 //y2=7.585
r161 (  1 10 ) resistor r=0.223071 //w=0.311 //l=0.555 //layer=m1 \
 //thickness=0.36 //x=5.485 //y=7.585 //x2=4.93 //y2=7.585
ends PM_VOTERN3X1\%VDD

subckt PM_VOTERN3X1\%noxref_3 ( 1 2 13 14 15 23 29 30 37 49 50 51 52 53 54 )
c91 ( 54 0 ) capacitor c=0.034295f //x=6.215 //y=5.205
c92 ( 53 0 ) capacitor c=0.0174957f //x=5.335 //y=5.205
c93 ( 51 0 ) capacitor c=0.0214849f //x=2.455 //y=5.205
c94 ( 50 0 ) capacitor c=0.0218033f //x=1.575 //y=5.205
c95 ( 49 0 ) capacitor c=0.00115294f //x=5.48 //y=7.09
c96 ( 37 0 ) capacitor c=0.0131338f //x=6.275 //y=7.09
c97 ( 30 0 ) capacitor c=0.00386507f //x=4.685 //y=7.09
c98 ( 29 0 ) capacitor c=0.0100992f //x=5.395 //y=7.09
c99 ( 23 0 ) capacitor c=0.0453878f //x=4.6 //y=5.39
c100 ( 15 0 ) capacitor c=0.00855201f //x=2.6 //y=5.475
c101 ( 14 0 ) capacitor c=0.00290434f //x=1.805 //y=5.39
c102 ( 13 0 ) capacitor c=0.0150963f //x=2.515 //y=5.39
c103 ( 2 0 ) capacitor c=0.0111402f //x=2.715 //y=5.39
c104 ( 1 0 ) capacitor c=0.0706872f //x=4.485 //y=5.39
r105 (  39 54 ) resistor r=5.81818 //w=0.187 //l=0.085 //layer=li \
 //thickness=0.1 //x=6.36 //y=7.005 //x2=6.36 //y2=6.92
r106 (  38 49 ) resistor r=5.4201 //w=0.17 //l=0.085 //layer=li \
 //thickness=0.1 //x=5.565 //y=7.09 //x2=5.48 //y2=7.09
r107 (  37 39 ) resistor r=7.15173 //w=0.17 //l=0.120208 //layer=li \
 //thickness=0.1 //x=6.275 //y=7.09 //x2=6.36 //y2=7.005
r108 (  37 38 ) resistor r=48.5989 //w=0.187 //l=0.71 //layer=li \
 //thickness=0.1 //x=6.275 //y=7.09 //x2=5.565 //y2=7.09
r109 (  31 49 ) resistor r=1.40859 //w=0.34 //l=0.085 //layer=li \
 //thickness=0.1 //x=5.48 //y=7.005 //x2=5.48 //y2=7.09
r110 (  31 53 ) resistor r=5.81818 //w=0.187 //l=0.085 //layer=li \
 //thickness=0.1 //x=5.48 //y=7.005 //x2=5.48 //y2=6.92
r111 (  29 49 ) resistor r=5.4201 //w=0.17 //l=0.085 //layer=li \
 //thickness=0.1 //x=5.395 //y=7.09 //x2=5.48 //y2=7.09
r112 (  29 30 ) resistor r=48.5989 //w=0.187 //l=0.71 //layer=li \
 //thickness=0.1 //x=5.395 //y=7.09 //x2=4.685 //y2=7.09
r113 (  23 52 ) resistor r=58.1818 //w=0.187 //l=0.85 //layer=li \
 //thickness=0.1 //x=4.6 //y=5.39 //x2=4.6 //y2=6.24
r114 (  21 30 ) resistor r=7.15173 //w=0.17 //l=0.120208 //layer=li \
 //thickness=0.1 //x=4.6 //y=7.005 //x2=4.685 //y2=7.09
r115 (  21 52 ) resistor r=5.81818 //w=0.187 //l=0.085 //layer=li \
 //thickness=0.1 //x=4.6 //y=7.005 //x2=4.6 //y2=6.92
r116 (  15 48 ) resistor r=3.57586 //w=0.17 //l=0.125 //layer=li \
 //thickness=0.1 //x=2.6 //y=5.475 //x2=2.6 //y2=5.35
r117 (  15 51 ) resistor r=52.3636 //w=0.187 //l=0.765 //layer=li \
 //thickness=0.1 //x=2.6 //y=5.475 //x2=2.6 //y2=6.24
r118 (  13 48 ) resistor r=3.57586 //w=0.17 //l=0.103078 //layer=li \
 //thickness=0.1 //x=2.515 //y=5.39 //x2=2.6 //y2=5.35
r119 (  13 14 ) resistor r=48.5989 //w=0.187 //l=0.71 //layer=li \
 //thickness=0.1 //x=2.515 //y=5.39 //x2=1.805 //y2=5.39
r120 (  7 14 ) resistor r=7.15173 //w=0.17 //l=0.120208 //layer=li \
 //thickness=0.1 //x=1.72 //y=5.475 //x2=1.805 //y2=5.39
r121 (  7 50 ) resistor r=29.0909 //w=0.187 //l=0.425 //layer=li \
 //thickness=0.1 //x=1.72 //y=5.475 //x2=1.72 //y2=5.9
r122 (  6 23 ) resistor r=9.3 //w=0.17 //l=0.17 //layer=mcon //count=1 //x=4.6 \
 //y=5.39 //x2=4.6 //y2=5.39
r123 (  4 48 ) resistor r=9.3 //w=0.17 //l=0.17 //layer=mcon //count=1 //x=2.6 \
 //y=5.39 //x2=2.6 //y2=5.39
r124 (  2 4 ) resistor r=0.0717383 //w=0.224 //l=0.115 //layer=m1 \
 //thickness=0.36 //x=2.715 //y=5.39 //x2=2.6 //y2=5.39
r125 (  1 6 ) resistor r=0.0717383 //w=0.224 //l=0.115 //layer=m1 \
 //thickness=0.36 //x=4.485 //y=5.39 //x2=4.6 //y2=5.39
r126 (  1 2 ) resistor r=1.68893 //w=0.131 //l=1.77 //layer=m1 \
 //thickness=0.36 //x=4.485 //y=5.39 //x2=2.715 //y2=5.39
ends PM_VOTERN3X1\%noxref_3

subckt PM_VOTERN3X1\%B ( 1 2 7 8 9 10 11 12 13 14 15 16 17 19 32 43 44 45 46 \
 47 48 49 50 51 52 56 58 61 62 63 64 68 69 70 71 75 77 83 84 86 99 )
c153 ( 99 0 ) capacitor c=0.0655948f //x=4.93 //y=4.885
c154 ( 86 0 ) capacitor c=0.0582862f //x=1.23 //y=2.26
c155 ( 84 0 ) capacitor c=0.0342409f //x=5.265 //y=1.39
c156 ( 83 0 ) capacitor c=0.0187384f //x=5.265 //y=1.045
c157 ( 77 0 ) capacitor c=0.0141797f //x=5.11 //y=1.545
c158 ( 75 0 ) capacitor c=0.0149844f //x=5.11 //y=0.89
c159 ( 71 0 ) capacitor c=0.10193f //x=4.735 //y=2.095
c160 ( 70 0 ) capacitor c=0.0225105f //x=4.735 //y=1.7
c161 ( 69 0 ) capacitor c=0.0234376f //x=4.735 //y=1.39
c162 ( 68 0 ) capacitor c=0.0199343f //x=4.735 //y=1.045
c163 ( 64 0 ) capacitor c=0.0318948f //x=1.935 //y=1.39
c164 ( 63 0 ) capacitor c=0.0187384f //x=1.935 //y=1.045
c165 ( 62 0 ) capacitor c=0.0607141f //x=1.575 //y=4.975
c166 ( 61 0 ) capacitor c=0.0292043f //x=1.865 //y=4.975
c167 ( 58 0 ) capacitor c=0.0157913f //x=1.78 //y=1.545
c168 ( 56 0 ) capacitor c=0.0149844f //x=1.78 //y=0.89
c169 ( 52 0 ) capacitor c=0.0302441f //x=1.405 //y=2.095
c170 ( 51 0 ) capacitor c=0.0238107f //x=1.405 //y=1.7
c171 ( 50 0 ) capacitor c=0.0234352f //x=1.405 //y=1.39
c172 ( 49 0 ) capacitor c=0.0199931f //x=1.405 //y=1.045
c173 ( 48 0 ) capacitor c=0.110336f //x=5.26 //y=6.205
c174 ( 47 0 ) capacitor c=0.154049f //x=4.82 //y=6.205
c175 ( 46 0 ) capacitor c=0.110003f //x=1.94 //y=6.205
c176 ( 45 0 ) capacitor c=0.15424f //x=1.5 //y=6.205
c177 ( 32 0 ) capacitor c=0.122411f //x=4.93 //y=2.26
c178 ( 19 0 ) capacitor c=0.12196f //x=1.23 //y=2.26
c179 ( 2 0 ) capacitor c=0.0208472f //x=1.345 //y=4.62
c180 ( 1 0 ) capacitor c=0.119494f //x=4.815 //y=4.62
r181 (  97 99 ) resistor r=22.7554 //w=0.233 //l=0.11 //layer=ply \
 //thickness=0.18 //x=4.82 //y=4.885 //x2=4.93 //y2=4.885
r182 (  84 101 ) resistor r=45.1352 //w=0.168 //l=0.173853 //layer=ply \
 //thickness=0.18 //x=5.265 //y=1.39 //x2=5.225 //y2=1.545
r183 (  83 100 ) resistor r=45.1352 //w=0.168 //l=0.173853 //layer=ply \
 //thickness=0.18 //x=5.265 //y=1.045 //x2=5.225 //y2=0.89
r184 (  83 84 ) resistor r=176.904 //w=0.094 //l=0.345 //layer=ply \
 //thickness=0.18 //x=5.265 //y=1.045 //x2=5.265 //y2=1.39
r185 (  80 99 ) resistor r=68.2661 //w=0.233 //l=0.404166 //layer=ply \
 //thickness=0.18 //x=5.26 //y=5.05 //x2=4.93 //y2=4.885
r186 (  78 96 ) resistor r=10.701 //w=0.21 //l=0.115 //layer=ply \
 //thickness=0.18 //x=4.89 //y=1.545 //x2=4.775 //y2=1.545
r187 (  77 101 ) resistor r=5.52526 //w=0.168 //l=0.115 //layer=ply \
 //thickness=0.18 //x=5.11 //y=1.545 //x2=5.225 //y2=1.545
r188 (  76 95 ) resistor r=5.52526 //w=0.168 //l=0.115 //layer=ply \
 //thickness=0.18 //x=4.89 //y=0.89 //x2=4.775 //y2=0.89
r189 (  75 100 ) resistor r=5.52526 //w=0.168 //l=0.115 //layer=ply \
 //thickness=0.18 //x=5.11 //y=0.89 //x2=5.225 //y2=0.89
r190 (  75 76 ) resistor r=112.809 //w=0.094 //l=0.22 //layer=ply \
 //thickness=0.18 //x=5.11 //y=0.89 //x2=4.89 //y2=0.89
r191 (  72 97 ) resistor r=13.0941 //w=0.233 //l=0.165 //layer=ply \
 //thickness=0.18 //x=4.82 //y=5.05 //x2=4.82 //y2=4.885
r192 (  71 94 ) resistor r=34.8111 //w=0.27 //l=0.264953 //layer=ply \
 //thickness=0.18 //x=4.735 //y=2.095 //x2=4.93 //y2=2.26
r193 (  70 96 ) resistor r=39.5823 //w=0.21 //l=0.173853 //layer=ply \
 //thickness=0.18 //x=4.735 //y=1.7 //x2=4.775 //y2=1.545
r194 (  70 71 ) resistor r=202.543 //w=0.094 //l=0.395 //layer=ply \
 //thickness=0.18 //x=4.735 //y=1.7 //x2=4.735 //y2=2.095
r195 (  69 96 ) resistor r=39.5823 //w=0.21 //l=0.173853 //layer=ply \
 //thickness=0.18 //x=4.735 //y=1.39 //x2=4.775 //y2=1.545
r196 (  68 95 ) resistor r=45.1352 //w=0.168 //l=0.173853 //layer=ply \
 //thickness=0.18 //x=4.735 //y=1.045 //x2=4.775 //y2=0.89
r197 (  68 69 ) resistor r=176.904 //w=0.094 //l=0.345 //layer=ply \
 //thickness=0.18 //x=4.735 //y=1.045 //x2=4.735 //y2=1.39
r198 (  64 92 ) resistor r=45.1352 //w=0.168 //l=0.173853 //layer=ply \
 //thickness=0.18 //x=1.935 //y=1.39 //x2=1.895 //y2=1.545
r199 (  63 91 ) resistor r=45.1352 //w=0.168 //l=0.173853 //layer=ply \
 //thickness=0.18 //x=1.935 //y=1.045 //x2=1.895 //y2=0.89
r200 (  63 64 ) resistor r=176.904 //w=0.094 //l=0.345 //layer=ply \
 //thickness=0.18 //x=1.935 //y=1.045 //x2=1.935 //y2=1.39
r201 (  61 65 ) resistor r=26.9307 //w=0.15 //l=0.106066 //layer=ply \
 //thickness=0.18 //x=1.865 //y=4.975 //x2=1.94 //y2=5.05
r202 (  61 62 ) resistor r=148.702 //w=0.094 //l=0.29 //layer=ply \
 //thickness=0.18 //x=1.865 //y=4.975 //x2=1.575 //y2=4.975
r203 (  59 90 ) resistor r=10.701 //w=0.21 //l=0.115 //layer=ply \
 //thickness=0.18 //x=1.56 //y=1.545 //x2=1.445 //y2=1.545
r204 (  58 92 ) resistor r=5.52526 //w=0.168 //l=0.115 //layer=ply \
 //thickness=0.18 //x=1.78 //y=1.545 //x2=1.895 //y2=1.545
r205 (  57 89 ) resistor r=5.52526 //w=0.168 //l=0.115 //layer=ply \
 //thickness=0.18 //x=1.56 //y=0.89 //x2=1.445 //y2=0.89
r206 (  56 91 ) resistor r=5.52526 //w=0.168 //l=0.115 //layer=ply \
 //thickness=0.18 //x=1.78 //y=0.89 //x2=1.895 //y2=0.89
r207 (  56 57 ) resistor r=112.809 //w=0.094 //l=0.22 //layer=ply \
 //thickness=0.18 //x=1.78 //y=0.89 //x2=1.56 //y2=0.89
r208 (  53 62 ) resistor r=22.1787 //w=0.252 //l=0.106066 //layer=ply \
 //thickness=0.18 //x=1.5 //y=5.05 //x2=1.575 //y2=4.975
r209 (  53 88 ) resistor r=51.6429 //w=0.252 //l=0.34271 //layer=ply \
 //thickness=0.18 //x=1.5 //y=5.05 //x2=1.23 //y2=4.885
r210 (  52 86 ) resistor r=30.4513 //w=0.277 //l=0.243926 //layer=ply \
 //thickness=0.18 //x=1.405 //y=2.095 //x2=1.23 //y2=2.26
r211 (  51 90 ) resistor r=39.5823 //w=0.21 //l=0.173853 //layer=ply \
 //thickness=0.18 //x=1.405 //y=1.7 //x2=1.445 //y2=1.545
r212 (  51 52 ) resistor r=202.543 //w=0.094 //l=0.395 //layer=ply \
 //thickness=0.18 //x=1.405 //y=1.7 //x2=1.405 //y2=2.095
r213 (  50 90 ) resistor r=39.5823 //w=0.21 //l=0.173853 //layer=ply \
 //thickness=0.18 //x=1.405 //y=1.39 //x2=1.445 //y2=1.545
r214 (  49 89 ) resistor r=45.1352 //w=0.168 //l=0.173853 //layer=ply \
 //thickness=0.18 //x=1.405 //y=1.045 //x2=1.445 //y2=0.89
r215 (  49 50 ) resistor r=176.904 //w=0.094 //l=0.345 //layer=ply \
 //thickness=0.18 //x=1.405 //y=1.045 //x2=1.405 //y2=1.39
r216 (  48 80 ) resistor r=592.245 //w=0.094 //l=1.155 //layer=ply \
 //thickness=0.18 //x=5.26 //y=6.205 //x2=5.26 //y2=5.05
r217 (  47 72 ) resistor r=592.245 //w=0.094 //l=1.155 //layer=ply \
 //thickness=0.18 //x=4.82 //y=6.205 //x2=4.82 //y2=5.05
r218 (  46 65 ) resistor r=592.245 //w=0.094 //l=1.155 //layer=ply \
 //thickness=0.18 //x=1.94 //y=6.205 //x2=1.94 //y2=5.05
r219 (  45 53 ) resistor r=592.245 //w=0.094 //l=1.155 //layer=ply \
 //thickness=0.18 //x=1.5 //y=6.205 //x2=1.5 //y2=5.05
r220 (  44 77 ) resistor r=56.4043 //w=0.094 //l=0.11 //layer=ply \
 //thickness=0.18 //x=5 //y=1.545 //x2=5.11 //y2=1.545
r221 (  44 78 ) resistor r=56.4043 //w=0.094 //l=0.11 //layer=ply \
 //thickness=0.18 //x=5 //y=1.545 //x2=4.89 //y2=1.545
r222 (  43 58 ) resistor r=56.4043 //w=0.094 //l=0.11 //layer=ply \
 //thickness=0.18 //x=1.67 //y=1.545 //x2=1.78 //y2=1.545
r223 (  43 59 ) resistor r=56.4043 //w=0.094 //l=0.11 //layer=ply \
 //thickness=0.18 //x=1.67 //y=1.545 //x2=1.56 //y2=1.545
r224 (  41 99 ) resistor r=152 //w=0.17 //l=0.17 //layer=licon //count=1 \
 //x=4.93 //y=4.885 //x2=4.93 //y2=4.885
r225 (  32 94 ) resistor r=152 //w=0.17 //l=0.17 //layer=licon //count=1 \
 //x=4.93 //y=2.26 //x2=4.93 //y2=2.26
r226 (  29 88 ) resistor r=152 //w=0.17 //l=0.17 //layer=licon //count=1 \
 //x=1.23 //y=4.885 //x2=1.23 //y2=4.885
r227 (  19 86 ) resistor r=152 //w=0.17 //l=0.17 //layer=licon //count=1 \
 //x=1.23 //y=2.26 //x2=1.23 //y2=2.26
r228 (  17 41 ) resistor r=18.139 //w=0.187 //l=0.265 //layer=li \
 //thickness=0.1 //x=4.93 //y=4.62 //x2=4.93 //y2=4.885
r229 (  16 17 ) resistor r=50.6524 //w=0.187 //l=0.74 //layer=li \
 //thickness=0.1 //x=4.93 //y=3.88 //x2=4.93 //y2=4.62
r230 (  15 16 ) resistor r=25.3262 //w=0.187 //l=0.37 //layer=li \
 //thickness=0.1 //x=4.93 //y=3.51 //x2=4.93 //y2=3.88
r231 (  14 15 ) resistor r=25.3262 //w=0.187 //l=0.37 //layer=li \
 //thickness=0.1 //x=4.93 //y=3.14 //x2=4.93 //y2=3.51
r232 (  13 14 ) resistor r=25.3262 //w=0.187 //l=0.37 //layer=li \
 //thickness=0.1 //x=4.93 //y=2.77 //x2=4.93 //y2=3.14
r233 (  13 32 ) resistor r=34.9091 //w=0.187 //l=0.51 //layer=li \
 //thickness=0.1 //x=4.93 //y=2.77 //x2=4.93 //y2=2.26
r234 (  12 29 ) resistor r=18.139 //w=0.187 //l=0.265 //layer=li \
 //thickness=0.1 //x=1.23 //y=4.62 //x2=1.23 //y2=4.885
r235 (  11 12 ) resistor r=25.3262 //w=0.187 //l=0.37 //layer=li \
 //thickness=0.1 //x=1.23 //y=4.25 //x2=1.23 //y2=4.62
r236 (  10 11 ) resistor r=25.3262 //w=0.187 //l=0.37 //layer=li \
 //thickness=0.1 //x=1.23 //y=3.88 //x2=1.23 //y2=4.25
r237 (  9 10 ) resistor r=25.3262 //w=0.187 //l=0.37 //layer=li \
 //thickness=0.1 //x=1.23 //y=3.51 //x2=1.23 //y2=3.88
r238 (  8 9 ) resistor r=25.3262 //w=0.187 //l=0.37 //layer=li //thickness=0.1 \
 //x=1.23 //y=3.14 //x2=1.23 //y2=3.51
r239 (  7 8 ) resistor r=25.3262 //w=0.187 //l=0.37 //layer=li //thickness=0.1 \
 //x=1.23 //y=2.77 //x2=1.23 //y2=3.14
r240 (  7 19 ) resistor r=34.9091 //w=0.187 //l=0.51 //layer=li \
 //thickness=0.1 //x=1.23 //y=2.77 //x2=1.23 //y2=2.26
r241 (  6 17 ) resistor r=9.3 //w=0.17 //l=0.17 //layer=mcon //count=1 \
 //x=4.93 //y=4.62 //x2=4.93 //y2=4.62
r242 (  4 12 ) resistor r=9.3 //w=0.17 //l=0.17 //layer=mcon //count=1 \
 //x=1.23 //y=4.62 //x2=1.23 //y2=4.62
r243 (  2 4 ) resistor r=0.0717383 //w=0.224 //l=0.115 //layer=m1 \
 //thickness=0.36 //x=1.345 //y=4.62 //x2=1.23 //y2=4.62
r244 (  1 6 ) resistor r=0.0717383 //w=0.224 //l=0.115 //layer=m1 \
 //thickness=0.36 //x=4.815 //y=4.62 //x2=4.93 //y2=4.62
r245 (  1 2 ) resistor r=3.31107 //w=0.131 //l=3.47 //layer=m1 \
 //thickness=0.36 //x=4.815 //y=4.62 //x2=1.345 //y2=4.62
ends PM_VOTERN3X1\%B

subckt PM_VOTERN3X1\%C ( 1 2 7 8 9 10 11 12 13 14 15 16 18 30 41 42 43 44 45 \
 46 50 51 52 53 54 56 59 62 63 64 65 66 67 68 69 73 75 78 79 80 81 94 )
c165 ( 94 0 ) capacitor c=0.0583848f //x=7.89 //y=2.26
c166 ( 81 0 ) capacitor c=0.0316774f //x=8.595 //y=1.39
c167 ( 80 0 ) capacitor c=0.0187384f //x=8.595 //y=1.045
c168 ( 79 0 ) capacitor c=0.0590362f //x=8.235 //y=4.975
c169 ( 78 0 ) capacitor c=0.0296075f //x=8.525 //y=4.975
c170 ( 75 0 ) capacitor c=0.0157912f //x=8.44 //y=1.545
c171 ( 73 0 ) capacitor c=0.0149844f //x=8.44 //y=0.89
c172 ( 69 0 ) capacitor c=0.0302441f //x=8.065 //y=2.095
c173 ( 68 0 ) capacitor c=0.0234157f //x=8.065 //y=1.7
c174 ( 67 0 ) capacitor c=0.0234376f //x=8.065 //y=1.39
c175 ( 66 0 ) capacitor c=0.0199931f //x=8.065 //y=1.045
c176 ( 65 0 ) capacitor c=0.0970773f //x=6.235 //y=2.095
c177 ( 64 0 ) capacitor c=0.0249466f //x=6.235 //y=1.74
c178 ( 63 0 ) capacitor c=0.0234397f //x=6.235 //y=1.43
c179 ( 62 0 ) capacitor c=0.0193195f //x=6.235 //y=1.085
c180 ( 59 0 ) capacitor c=0.0631944f //x=6.14 //y=5.05
c181 ( 56 0 ) capacitor c=0.0187941f //x=6.08 //y=1.585
c182 ( 54 0 ) capacitor c=0.0157803f //x=6.08 //y=0.93
c183 ( 53 0 ) capacitor c=0.010629f //x=5.775 //y=4.975
c184 ( 52 0 ) capacitor c=0.0194269f //x=6.065 //y=4.975
c185 ( 51 0 ) capacitor c=0.0365717f //x=5.705 //y=1.43
c186 ( 50 0 ) capacitor c=0.0175988f //x=5.705 //y=1.085
c187 ( 46 0 ) capacitor c=0.110622f //x=8.6 //y=6.205
c188 ( 45 0 ) capacitor c=0.154068f //x=8.16 //y=6.205
c189 ( 44 0 ) capacitor c=0.154291f //x=6.14 //y=6.205
c190 ( 43 0 ) capacitor c=0.110404f //x=5.7 //y=6.205
c191 ( 30 0 ) capacitor c=0.100999f //x=7.89 //y=2.26
c192 ( 18 0 ) capacitor c=0.109253f //x=6.41 //y=2.26
c193 ( 2 0 ) capacitor c=0.011507f //x=6.525 //y=2.26
c194 ( 1 0 ) capacitor c=0.0463146f //x=7.775 //y=2.26
r195 (  81 100 ) resistor r=45.1352 //w=0.168 //l=0.173853 //layer=ply \
 //thickness=0.18 //x=8.595 //y=1.39 //x2=8.555 //y2=1.545
r196 (  80 99 ) resistor r=45.1352 //w=0.168 //l=0.173853 //layer=ply \
 //thickness=0.18 //x=8.595 //y=1.045 //x2=8.555 //y2=0.89
r197 (  80 81 ) resistor r=176.904 //w=0.094 //l=0.345 //layer=ply \
 //thickness=0.18 //x=8.595 //y=1.045 //x2=8.595 //y2=1.39
r198 (  78 82 ) resistor r=26.9307 //w=0.15 //l=0.106066 //layer=ply \
 //thickness=0.18 //x=8.525 //y=4.975 //x2=8.6 //y2=5.05
r199 (  78 79 ) resistor r=148.702 //w=0.094 //l=0.29 //layer=ply \
 //thickness=0.18 //x=8.525 //y=4.975 //x2=8.235 //y2=4.975
r200 (  76 98 ) resistor r=10.701 //w=0.21 //l=0.115 //layer=ply \
 //thickness=0.18 //x=8.22 //y=1.545 //x2=8.105 //y2=1.545
r201 (  75 100 ) resistor r=5.52526 //w=0.168 //l=0.115 //layer=ply \
 //thickness=0.18 //x=8.44 //y=1.545 //x2=8.555 //y2=1.545
r202 (  74 97 ) resistor r=5.52526 //w=0.168 //l=0.115 //layer=ply \
 //thickness=0.18 //x=8.22 //y=0.89 //x2=8.105 //y2=0.89
r203 (  73 99 ) resistor r=5.52526 //w=0.168 //l=0.115 //layer=ply \
 //thickness=0.18 //x=8.44 //y=0.89 //x2=8.555 //y2=0.89
r204 (  73 74 ) resistor r=112.809 //w=0.094 //l=0.22 //layer=ply \
 //thickness=0.18 //x=8.44 //y=0.89 //x2=8.22 //y2=0.89
r205 (  70 79 ) resistor r=22.1787 //w=0.252 //l=0.106066 //layer=ply \
 //thickness=0.18 //x=8.16 //y=5.05 //x2=8.235 //y2=4.975
r206 (  70 96 ) resistor r=51.6429 //w=0.252 //l=0.34271 //layer=ply \
 //thickness=0.18 //x=8.16 //y=5.05 //x2=7.89 //y2=4.885
r207 (  69 94 ) resistor r=30.4513 //w=0.277 //l=0.243926 //layer=ply \
 //thickness=0.18 //x=8.065 //y=2.095 //x2=7.89 //y2=2.26
r208 (  68 98 ) resistor r=39.5823 //w=0.21 //l=0.173853 //layer=ply \
 //thickness=0.18 //x=8.065 //y=1.7 //x2=8.105 //y2=1.545
r209 (  68 69 ) resistor r=202.543 //w=0.094 //l=0.395 //layer=ply \
 //thickness=0.18 //x=8.065 //y=1.7 //x2=8.065 //y2=2.095
r210 (  67 98 ) resistor r=39.5823 //w=0.21 //l=0.173853 //layer=ply \
 //thickness=0.18 //x=8.065 //y=1.39 //x2=8.105 //y2=1.545
r211 (  66 97 ) resistor r=45.1352 //w=0.168 //l=0.173853 //layer=ply \
 //thickness=0.18 //x=8.065 //y=1.045 //x2=8.105 //y2=0.89
r212 (  66 67 ) resistor r=176.904 //w=0.094 //l=0.345 //layer=ply \
 //thickness=0.18 //x=8.065 //y=1.045 //x2=8.065 //y2=1.39
r213 (  65 90 ) resistor r=30.4513 //w=0.277 //l=0.243926 //layer=ply \
 //thickness=0.18 //x=6.235 //y=2.095 //x2=6.41 //y2=2.26
r214 (  64 88 ) resistor r=39.5823 //w=0.21 //l=0.173853 //layer=ply \
 //thickness=0.18 //x=6.235 //y=1.74 //x2=6.195 //y2=1.585
r215 (  64 65 ) resistor r=182.032 //w=0.094 //l=0.355 //layer=ply \
 //thickness=0.18 //x=6.235 //y=1.74 //x2=6.235 //y2=2.095
r216 (  63 88 ) resistor r=39.5823 //w=0.21 //l=0.173853 //layer=ply \
 //thickness=0.18 //x=6.235 //y=1.43 //x2=6.195 //y2=1.585
r217 (  62 87 ) resistor r=45.1352 //w=0.168 //l=0.173853 //layer=ply \
 //thickness=0.18 //x=6.235 //y=1.085 //x2=6.195 //y2=0.93
r218 (  62 63 ) resistor r=176.904 //w=0.094 //l=0.345 //layer=ply \
 //thickness=0.18 //x=6.235 //y=1.085 //x2=6.235 //y2=1.43
r219 (  59 92 ) resistor r=51.6429 //w=0.252 //l=0.34271 //layer=ply \
 //thickness=0.18 //x=6.14 //y=5.05 //x2=6.41 //y2=4.885
r220 (  57 86 ) resistor r=5.52526 //w=0.168 //l=0.115 //layer=ply \
 //thickness=0.18 //x=5.86 //y=1.585 //x2=5.745 //y2=1.585
r221 (  56 88 ) resistor r=10.701 //w=0.21 //l=0.115 //layer=ply \
 //thickness=0.18 //x=6.08 //y=1.585 //x2=6.195 //y2=1.585
r222 (  55 85 ) resistor r=5.52526 //w=0.168 //l=0.115 //layer=ply \
 //thickness=0.18 //x=5.86 //y=0.93 //x2=5.745 //y2=0.93
r223 (  54 87 ) resistor r=5.52526 //w=0.168 //l=0.115 //layer=ply \
 //thickness=0.18 //x=6.08 //y=0.93 //x2=6.195 //y2=0.93
r224 (  54 55 ) resistor r=112.809 //w=0.094 //l=0.22 //layer=ply \
 //thickness=0.18 //x=6.08 //y=0.93 //x2=5.86 //y2=0.93
r225 (  52 59 ) resistor r=22.1787 //w=0.252 //l=0.106066 //layer=ply \
 //thickness=0.18 //x=6.065 //y=4.975 //x2=6.14 //y2=5.05
r226 (  52 53 ) resistor r=148.702 //w=0.094 //l=0.29 //layer=ply \
 //thickness=0.18 //x=6.065 //y=4.975 //x2=5.775 //y2=4.975
r227 (  51 86 ) resistor r=45.1352 //w=0.168 //l=0.173853 //layer=ply \
 //thickness=0.18 //x=5.705 //y=1.43 //x2=5.745 //y2=1.585
r228 (  50 85 ) resistor r=45.1352 //w=0.168 //l=0.173853 //layer=ply \
 //thickness=0.18 //x=5.705 //y=1.085 //x2=5.745 //y2=0.93
r229 (  50 51 ) resistor r=176.904 //w=0.094 //l=0.345 //layer=ply \
 //thickness=0.18 //x=5.705 //y=1.085 //x2=5.705 //y2=1.43
r230 (  47 53 ) resistor r=26.9307 //w=0.15 //l=0.106066 //layer=ply \
 //thickness=0.18 //x=5.7 //y=5.05 //x2=5.775 //y2=4.975
r231 (  46 82 ) resistor r=592.245 //w=0.094 //l=1.155 //layer=ply \
 //thickness=0.18 //x=8.6 //y=6.205 //x2=8.6 //y2=5.05
r232 (  45 70 ) resistor r=592.245 //w=0.094 //l=1.155 //layer=ply \
 //thickness=0.18 //x=8.16 //y=6.205 //x2=8.16 //y2=5.05
r233 (  44 59 ) resistor r=592.245 //w=0.094 //l=1.155 //layer=ply \
 //thickness=0.18 //x=6.14 //y=6.205 //x2=6.14 //y2=5.05
r234 (  43 47 ) resistor r=592.245 //w=0.094 //l=1.155 //layer=ply \
 //thickness=0.18 //x=5.7 //y=6.205 //x2=5.7 //y2=5.05
r235 (  42 75 ) resistor r=56.4043 //w=0.094 //l=0.11 //layer=ply \
 //thickness=0.18 //x=8.33 //y=1.545 //x2=8.44 //y2=1.545
r236 (  42 76 ) resistor r=56.4043 //w=0.094 //l=0.11 //layer=ply \
 //thickness=0.18 //x=8.33 //y=1.545 //x2=8.22 //y2=1.545
r237 (  41 56 ) resistor r=56.4043 //w=0.094 //l=0.11 //layer=ply \
 //thickness=0.18 //x=5.97 //y=1.585 //x2=6.08 //y2=1.585
r238 (  41 57 ) resistor r=56.4043 //w=0.094 //l=0.11 //layer=ply \
 //thickness=0.18 //x=5.97 //y=1.585 //x2=5.86 //y2=1.585
r239 (  39 96 ) resistor r=152 //w=0.17 //l=0.17 //layer=licon //count=1 \
 //x=7.89 //y=4.885 //x2=7.89 //y2=4.885
r240 (  30 94 ) resistor r=152 //w=0.17 //l=0.17 //layer=licon //count=1 \
 //x=7.89 //y=2.26 //x2=7.89 //y2=2.26
r241 (  27 92 ) resistor r=152 //w=0.17 //l=0.17 //layer=licon //count=1 \
 //x=6.41 //y=4.885 //x2=6.41 //y2=4.885
r242 (  18 90 ) resistor r=152 //w=0.17 //l=0.17 //layer=licon //count=1 \
 //x=6.41 //y=2.26 //x2=6.41 //y2=2.26
r243 (  16 39 ) resistor r=18.139 //w=0.187 //l=0.265 //layer=li \
 //thickness=0.1 //x=7.89 //y=4.62 //x2=7.89 //y2=4.885
r244 (  15 16 ) resistor r=50.6524 //w=0.187 //l=0.74 //layer=li \
 //thickness=0.1 //x=7.89 //y=3.88 //x2=7.89 //y2=4.62
r245 (  14 15 ) resistor r=25.3262 //w=0.187 //l=0.37 //layer=li \
 //thickness=0.1 //x=7.89 //y=3.51 //x2=7.89 //y2=3.88
r246 (  13 14 ) resistor r=25.3262 //w=0.187 //l=0.37 //layer=li \
 //thickness=0.1 //x=7.89 //y=3.14 //x2=7.89 //y2=3.51
r247 (  12 13 ) resistor r=25.3262 //w=0.187 //l=0.37 //layer=li \
 //thickness=0.1 //x=7.89 //y=2.77 //x2=7.89 //y2=3.14
r248 (  12 30 ) resistor r=34.9091 //w=0.187 //l=0.51 //layer=li \
 //thickness=0.1 //x=7.89 //y=2.77 //x2=7.89 //y2=2.26
r249 (  11 27 ) resistor r=18.139 //w=0.187 //l=0.265 //layer=li \
 //thickness=0.1 //x=6.41 //y=4.62 //x2=6.41 //y2=4.885
r250 (  10 11 ) resistor r=50.6524 //w=0.187 //l=0.74 //layer=li \
 //thickness=0.1 //x=6.41 //y=3.88 //x2=6.41 //y2=4.62
r251 (  9 10 ) resistor r=25.3262 //w=0.187 //l=0.37 //layer=li \
 //thickness=0.1 //x=6.41 //y=3.51 //x2=6.41 //y2=3.88
r252 (  8 9 ) resistor r=25.3262 //w=0.187 //l=0.37 //layer=li //thickness=0.1 \
 //x=6.41 //y=3.14 //x2=6.41 //y2=3.51
r253 (  7 8 ) resistor r=25.3262 //w=0.187 //l=0.37 //layer=li //thickness=0.1 \
 //x=6.41 //y=2.77 //x2=6.41 //y2=3.14
r254 (  7 18 ) resistor r=34.9091 //w=0.187 //l=0.51 //layer=li \
 //thickness=0.1 //x=6.41 //y=2.77 //x2=6.41 //y2=2.26
r255 (  6 30 ) resistor r=9.3 //w=0.17 //l=0.17 //layer=mcon //count=1 \
 //x=7.89 //y=2.26 //x2=7.89 //y2=2.26
r256 (  4 18 ) resistor r=9.3 //w=0.17 //l=0.17 //layer=mcon //count=1 \
 //x=6.41 //y=2.26 //x2=6.41 //y2=2.26
r257 (  2 4 ) resistor r=0.0717383 //w=0.224 //l=0.115 //layer=m1 \
 //thickness=0.36 //x=6.525 //y=2.26 //x2=6.41 //y2=2.26
r258 (  1 6 ) resistor r=0.0717383 //w=0.224 //l=0.115 //layer=m1 \
 //thickness=0.36 //x=7.775 //y=2.26 //x2=7.89 //y2=2.26
r259 (  1 2 ) resistor r=1.19275 //w=0.131 //l=1.25 //layer=m1 \
 //thickness=0.36 //x=7.775 //y=2.26 //x2=6.525 //y2=2.26
ends PM_VOTERN3X1\%C

subckt PM_VOTERN3X1\%noxref_6 ( 1 2 13 14 15 21 27 28 35 45 46 47 48 49 50 )
c86 ( 50 0 ) capacitor c=0.0308836f //x=9.555 //y=5.205
c87 ( 49 0 ) capacitor c=0.0173945f //x=8.675 //y=5.205
c88 ( 47 0 ) capacitor c=0.0169278f //x=5.775 //y=5.205
c89 ( 46 0 ) capacitor c=0.0166762f //x=4.895 //y=5.205
c90 ( 45 0 ) capacitor c=0.00115294f //x=8.82 //y=7.09
c91 ( 35 0 ) capacitor c=0.0134683f //x=9.615 //y=7.09
c92 ( 28 0 ) capacitor c=0.00388794f //x=8.025 //y=7.09
c93 ( 27 0 ) capacitor c=0.0107731f //x=8.735 //y=7.09
c94 ( 21 0 ) capacitor c=0.0442221f //x=7.94 //y=5.39
c95 ( 15 0 ) capacitor c=0.0103611f //x=5.92 //y=5.475
c96 ( 14 0 ) capacitor c=0.00227812f //x=5.125 //y=5.39
c97 ( 13 0 ) capacitor c=0.0177888f //x=5.835 //y=5.39
c98 ( 2 0 ) capacitor c=0.00818801f //x=6.035 //y=5.39
c99 ( 1 0 ) capacitor c=0.0820623f //x=7.825 //y=5.39
r100 (  37 50 ) resistor r=5.81818 //w=0.187 //l=0.085 //layer=li \
 //thickness=0.1 //x=9.7 //y=7.005 //x2=9.7 //y2=6.92
r101 (  36 45 ) resistor r=5.4201 //w=0.17 //l=0.085 //layer=li \
 //thickness=0.1 //x=8.905 //y=7.09 //x2=8.82 //y2=7.09
r102 (  35 37 ) resistor r=7.15173 //w=0.17 //l=0.120208 //layer=li \
 //thickness=0.1 //x=9.615 //y=7.09 //x2=9.7 //y2=7.005
r103 (  35 36 ) resistor r=48.5989 //w=0.187 //l=0.71 //layer=li \
 //thickness=0.1 //x=9.615 //y=7.09 //x2=8.905 //y2=7.09
r104 (  29 45 ) resistor r=1.40859 //w=0.34 //l=0.085 //layer=li \
 //thickness=0.1 //x=8.82 //y=7.005 //x2=8.82 //y2=7.09
r105 (  29 49 ) resistor r=5.81818 //w=0.187 //l=0.085 //layer=li \
 //thickness=0.1 //x=8.82 //y=7.005 //x2=8.82 //y2=6.92
r106 (  27 45 ) resistor r=5.4201 //w=0.17 //l=0.085 //layer=li \
 //thickness=0.1 //x=8.735 //y=7.09 //x2=8.82 //y2=7.09
r107 (  27 28 ) resistor r=48.5989 //w=0.187 //l=0.71 //layer=li \
 //thickness=0.1 //x=8.735 //y=7.09 //x2=8.025 //y2=7.09
r108 (  21 48 ) resistor r=58.1818 //w=0.187 //l=0.85 //layer=li \
 //thickness=0.1 //x=7.94 //y=5.39 //x2=7.94 //y2=6.24
r109 (  19 28 ) resistor r=7.15173 //w=0.17 //l=0.120208 //layer=li \
 //thickness=0.1 //x=7.94 //y=7.005 //x2=8.025 //y2=7.09
r110 (  19 48 ) resistor r=5.81818 //w=0.187 //l=0.085 //layer=li \
 //thickness=0.1 //x=7.94 //y=7.005 //x2=7.94 //y2=6.92
r111 (  15 44 ) resistor r=3.57586 //w=0.17 //l=0.125 //layer=li \
 //thickness=0.1 //x=5.92 //y=5.475 //x2=5.92 //y2=5.35
r112 (  15 47 ) resistor r=52.3636 //w=0.187 //l=0.765 //layer=li \
 //thickness=0.1 //x=5.92 //y=5.475 //x2=5.92 //y2=6.24
r113 (  13 44 ) resistor r=3.57586 //w=0.17 //l=0.103078 //layer=li \
 //thickness=0.1 //x=5.835 //y=5.39 //x2=5.92 //y2=5.35
r114 (  13 14 ) resistor r=48.5989 //w=0.187 //l=0.71 //layer=li \
 //thickness=0.1 //x=5.835 //y=5.39 //x2=5.125 //y2=5.39
r115 (  7 14 ) resistor r=7.15173 //w=0.17 //l=0.120208 //layer=li \
 //thickness=0.1 //x=5.04 //y=5.475 //x2=5.125 //y2=5.39
r116 (  7 46 ) resistor r=29.0909 //w=0.187 //l=0.425 //layer=li \
 //thickness=0.1 //x=5.04 //y=5.475 //x2=5.04 //y2=5.9
r117 (  6 21 ) resistor r=9.3 //w=0.17 //l=0.17 //layer=mcon //count=1 \
 //x=7.94 //y=5.39 //x2=7.94 //y2=5.39
r118 (  4 44 ) resistor r=9.3 //w=0.17 //l=0.17 //layer=mcon //count=1 \
 //x=5.92 //y=5.39 //x2=5.92 //y2=5.39
r119 (  2 4 ) resistor r=0.0717383 //w=0.224 //l=0.115 //layer=m1 \
 //thickness=0.36 //x=6.035 //y=5.39 //x2=5.92 //y2=5.39
r120 (  1 6 ) resistor r=0.0717383 //w=0.224 //l=0.115 //layer=m1 \
 //thickness=0.36 //x=7.825 //y=5.39 //x2=7.94 //y2=5.39
r121 (  1 2 ) resistor r=1.70802 //w=0.131 //l=1.79 //layer=m1 \
 //thickness=0.36 //x=7.825 //y=5.39 //x2=6.035 //y2=5.39
ends PM_VOTERN3X1\%noxref_6

subckt PM_VOTERN3X1\%A ( 1 2 7 8 9 10 11 12 13 14 15 16 17 18 20 30 42 45 46 \
 47 48 49 50 51 52 53 58 60 62 68 69 70 71 72 77 79 81 87 88 90 91 94 102 103 \
 106 )
c180 ( 106 0 ) capacitor c=0.0352016f //x=9.02 //y=4.885
c181 ( 103 0 ) capacitor c=0.0279733f //x=9 //y=2.095
c182 ( 102 0 ) capacitor c=0.0467621f //x=9 //y=2.26
c183 ( 94 0 ) capacitor c=0.0384604f //x=2.38 //y=4.885
c184 ( 91 0 ) capacitor c=0.0300885f //x=2.34 //y=2.095
c185 ( 90 0 ) capacitor c=0.053505f //x=2.34 //y=2.26
c186 ( 88 0 ) capacitor c=0.0237734f //x=9.565 //y=1.435
c187 ( 87 0 ) capacitor c=0.0191782f //x=9.565 //y=1.085
c188 ( 81 0 ) capacitor c=0.0351663f //x=9.41 //y=1.585
c189 ( 79 0 ) capacitor c=0.0157803f //x=9.41 //y=0.93
c190 ( 77 0 ) capacitor c=0.0373879f //x=9.405 //y=4.975
c191 ( 72 0 ) capacitor c=0.0200628f //x=9.035 //y=1.74
c192 ( 71 0 ) capacitor c=0.0168575f //x=9.035 //y=1.435
c193 ( 70 0 ) capacitor c=0.0174993f //x=9.035 //y=1.085
c194 ( 69 0 ) capacitor c=0.0447087f //x=2.905 //y=1.43
c195 ( 68 0 ) capacitor c=0.019286f //x=2.905 //y=1.085
c196 ( 62 0 ) capacitor c=0.0187932f //x=2.75 //y=1.585
c197 ( 60 0 ) capacitor c=0.0157795f //x=2.75 //y=0.93
c198 ( 58 0 ) capacitor c=0.029531f //x=2.745 //y=4.975
c199 ( 53 0 ) capacitor c=0.0206178f //x=2.375 //y=1.74
c200 ( 52 0 ) capacitor c=0.016848f //x=2.375 //y=1.43
c201 ( 51 0 ) capacitor c=0.0174777f //x=2.375 //y=1.085
c202 ( 50 0 ) capacitor c=0.15325f //x=9.48 //y=6.205
c203 ( 49 0 ) capacitor c=0.110411f //x=9.04 //y=6.205
c204 ( 48 0 ) capacitor c=0.154236f //x=2.82 //y=6.205
c205 ( 47 0 ) capacitor c=0.110294f //x=2.38 //y=6.205
c206 ( 42 0 ) capacitor c=0.00501304f //x=9.02 //y=4.885
c207 ( 30 0 ) capacitor c=0.0902071f //x=9 //y=2.26
c208 ( 20 0 ) capacitor c=0.11342f //x=2.34 //y=2.26
c209 ( 18 0 ) capacitor c=0.00669947f //x=2.34 //y=4.72
c210 ( 2 0 ) capacitor c=0.0161064f //x=2.455 //y=4.25
c211 ( 1 0 ) capacitor c=0.304963f //x=8.885 //y=4.25
r212 (  108 109 ) resistor r=32.4568 //w=0.214 //l=0.075 //layer=ply \
 //thickness=0.18 //x=9.02 //y=4.975 //x2=9.02 //y2=5.05
r213 (  106 108 ) resistor r=20.271 //w=0.214 //l=0.09 //layer=ply \
 //thickness=0.18 //x=9.02 //y=4.885 //x2=9.02 //y2=4.975
r214 (  102 103 ) resistor r=52.7279 //w=0.214 //l=0.165 //layer=ply \
 //thickness=0.18 //x=9 //y=2.26 //x2=9 //y2=2.095
r215 (  94 96 ) resistor r=20.271 //w=0.214 //l=0.09 //layer=ply \
 //thickness=0.18 //x=2.38 //y=4.885 //x2=2.38 //y2=4.975
r216 (  90 91 ) resistor r=52.7279 //w=0.214 //l=0.165 //layer=ply \
 //thickness=0.18 //x=2.34 //y=2.26 //x2=2.34 //y2=2.095
r217 (  88 113 ) resistor r=4.95774 //w=0.164 //l=0.112 //layer=ply \
 //thickness=0.18 //x=9.565 //y=1.435 //x2=9.565 //y2=1.547
r218 (  87 112 ) resistor r=45.1352 //w=0.168 //l=0.173853 //layer=ply \
 //thickness=0.18 //x=9.565 //y=1.085 //x2=9.525 //y2=0.93
r219 (  87 88 ) resistor r=179.468 //w=0.094 //l=0.35 //layer=ply \
 //thickness=0.18 //x=9.565 //y=1.085 //x2=9.565 //y2=1.435
r220 (  82 111 ) resistor r=10.8103 //w=0.211 //l=0.115 //layer=ply \
 //thickness=0.18 //x=9.19 //y=1.585 //x2=9.075 //y2=1.585
r221 (  81 113 ) resistor r=45.9962 //w=0.164 //l=0.17296 //layer=ply \
 //thickness=0.18 //x=9.41 //y=1.585 //x2=9.565 //y2=1.547
r222 (  80 110 ) resistor r=5.52526 //w=0.168 //l=0.115 //layer=ply \
 //thickness=0.18 //x=9.19 //y=0.93 //x2=9.075 //y2=0.93
r223 (  79 112 ) resistor r=5.52526 //w=0.168 //l=0.115 //layer=ply \
 //thickness=0.18 //x=9.41 //y=0.93 //x2=9.525 //y2=0.93
r224 (  79 80 ) resistor r=112.809 //w=0.094 //l=0.22 //layer=ply \
 //thickness=0.18 //x=9.41 //y=0.93 //x2=9.19 //y2=0.93
r225 (  78 108 ) resistor r=16.5046 //w=0.27 //l=0.135 //layer=ply \
 //thickness=0.18 //x=9.155 //y=4.975 //x2=9.02 //y2=4.975
r226 (  77 84 ) resistor r=26.9307 //w=0.15 //l=0.106066 //layer=ply \
 //thickness=0.18 //x=9.405 //y=4.975 //x2=9.48 //y2=5.05
r227 (  77 78 ) resistor r=128.191 //w=0.094 //l=0.25 //layer=ply \
 //thickness=0.18 //x=9.405 //y=4.975 //x2=9.155 //y2=4.975
r228 (  72 111 ) resistor r=39.5036 //w=0.211 //l=0.173853 //layer=ply \
 //thickness=0.18 //x=9.035 //y=1.74 //x2=9.075 //y2=1.585
r229 (  72 103 ) resistor r=182.032 //w=0.094 //l=0.355 //layer=ply \
 //thickness=0.18 //x=9.035 //y=1.74 //x2=9.035 //y2=2.095
r230 (  71 111 ) resistor r=38.3614 //w=0.211 //l=0.168819 //layer=ply \
 //thickness=0.18 //x=9.035 //y=1.435 //x2=9.075 //y2=1.585
r231 (  70 110 ) resistor r=45.1352 //w=0.168 //l=0.173853 //layer=ply \
 //thickness=0.18 //x=9.035 //y=1.085 //x2=9.075 //y2=0.93
r232 (  70 71 ) resistor r=179.468 //w=0.094 //l=0.35 //layer=ply \
 //thickness=0.18 //x=9.035 //y=1.085 //x2=9.035 //y2=1.435
r233 (  69 100 ) resistor r=45.1352 //w=0.168 //l=0.173853 //layer=ply \
 //thickness=0.18 //x=2.905 //y=1.43 //x2=2.865 //y2=1.585
r234 (  68 99 ) resistor r=45.1352 //w=0.168 //l=0.173853 //layer=ply \
 //thickness=0.18 //x=2.905 //y=1.085 //x2=2.865 //y2=0.93
r235 (  68 69 ) resistor r=176.904 //w=0.094 //l=0.345 //layer=ply \
 //thickness=0.18 //x=2.905 //y=1.085 //x2=2.905 //y2=1.43
r236 (  63 98 ) resistor r=10.701 //w=0.21 //l=0.115 //layer=ply \
 //thickness=0.18 //x=2.53 //y=1.585 //x2=2.415 //y2=1.585
r237 (  62 100 ) resistor r=5.52526 //w=0.168 //l=0.115 //layer=ply \
 //thickness=0.18 //x=2.75 //y=1.585 //x2=2.865 //y2=1.585
r238 (  61 97 ) resistor r=5.52526 //w=0.168 //l=0.115 //layer=ply \
 //thickness=0.18 //x=2.53 //y=0.93 //x2=2.415 //y2=0.93
r239 (  60 99 ) resistor r=5.52526 //w=0.168 //l=0.115 //layer=ply \
 //thickness=0.18 //x=2.75 //y=0.93 //x2=2.865 //y2=0.93
r240 (  60 61 ) resistor r=112.809 //w=0.094 //l=0.22 //layer=ply \
 //thickness=0.18 //x=2.75 //y=0.93 //x2=2.53 //y2=0.93
r241 (  59 96 ) resistor r=16.5046 //w=0.27 //l=0.135 //layer=ply \
 //thickness=0.18 //x=2.515 //y=4.975 //x2=2.38 //y2=4.975
r242 (  58 65 ) resistor r=26.9307 //w=0.15 //l=0.106066 //layer=ply \
 //thickness=0.18 //x=2.745 //y=4.975 //x2=2.82 //y2=5.05
r243 (  58 59 ) resistor r=117.936 //w=0.094 //l=0.23 //layer=ply \
 //thickness=0.18 //x=2.745 //y=4.975 //x2=2.515 //y2=4.975
r244 (  55 96 ) resistor r=32.4568 //w=0.214 //l=0.075 //layer=ply \
 //thickness=0.18 //x=2.38 //y=5.05 //x2=2.38 //y2=4.975
r245 (  53 98 ) resistor r=39.5823 //w=0.21 //l=0.173853 //layer=ply \
 //thickness=0.18 //x=2.375 //y=1.74 //x2=2.415 //y2=1.585
r246 (  53 91 ) resistor r=182.032 //w=0.094 //l=0.355 //layer=ply \
 //thickness=0.18 //x=2.375 //y=1.74 //x2=2.375 //y2=2.095
r247 (  52 98 ) resistor r=39.5823 //w=0.21 //l=0.173853 //layer=ply \
 //thickness=0.18 //x=2.375 //y=1.43 //x2=2.415 //y2=1.585
r248 (  51 97 ) resistor r=45.1352 //w=0.168 //l=0.173853 //layer=ply \
 //thickness=0.18 //x=2.375 //y=1.085 //x2=2.415 //y2=0.93
r249 (  51 52 ) resistor r=176.904 //w=0.094 //l=0.345 //layer=ply \
 //thickness=0.18 //x=2.375 //y=1.085 //x2=2.375 //y2=1.43
r250 (  50 84 ) resistor r=592.245 //w=0.094 //l=1.155 //layer=ply \
 //thickness=0.18 //x=9.48 //y=6.205 //x2=9.48 //y2=5.05
r251 (  49 109 ) resistor r=592.245 //w=0.094 //l=1.155 //layer=ply \
 //thickness=0.18 //x=9.04 //y=6.205 //x2=9.04 //y2=5.05
r252 (  48 65 ) resistor r=592.245 //w=0.094 //l=1.155 //layer=ply \
 //thickness=0.18 //x=2.82 //y=6.205 //x2=2.82 //y2=5.05
r253 (  47 55 ) resistor r=592.245 //w=0.094 //l=1.155 //layer=ply \
 //thickness=0.18 //x=2.38 //y=6.205 //x2=2.38 //y2=5.05
r254 (  46 81 ) resistor r=56.4043 //w=0.094 //l=0.11 //layer=ply \
 //thickness=0.18 //x=9.3 //y=1.585 //x2=9.41 //y2=1.585
r255 (  46 82 ) resistor r=56.4043 //w=0.094 //l=0.11 //layer=ply \
 //thickness=0.18 //x=9.3 //y=1.585 //x2=9.19 //y2=1.585
r256 (  45 62 ) resistor r=56.4043 //w=0.094 //l=0.11 //layer=ply \
 //thickness=0.18 //x=2.64 //y=1.585 //x2=2.75 //y2=1.585
r257 (  45 63 ) resistor r=56.4043 //w=0.094 //l=0.11 //layer=ply \
 //thickness=0.18 //x=2.64 //y=1.585 //x2=2.53 //y2=1.585
r258 (  42 106 ) resistor r=152 //w=0.17 //l=0.17 //layer=licon //count=1 \
 //x=9.02 //y=4.885 //x2=9.02 //y2=4.885
r259 (  42 43 ) resistor r=10.3507 //w=0.207 //l=0.165 //layer=li \
 //thickness=0.1 //x=9.01 //y=4.885 //x2=9.01 //y2=4.72
r260 (  40 94 ) resistor r=152 //w=0.17 //l=0.17 //layer=licon //count=1 \
 //x=2.38 //y=4.885 //x2=2.38 //y2=4.885
r261 (  30 102 ) resistor r=152 //w=0.17 //l=0.17 //layer=licon //count=1 \
 //x=9 //y=2.26 //x2=9 //y2=2.26
r262 (  20 90 ) resistor r=152 //w=0.17 //l=0.17 //layer=licon //count=1 \
 //x=2.34 //y=2.26 //x2=2.34 //y2=2.26
r263 (  18 40 ) resistor r=11.2426 //w=0.191 //l=0.174714 //layer=li \
 //thickness=0.1 //x=2.34 //y=4.72 //x2=2.36 //y2=4.885
r264 (  17 43 ) resistor r=6.84492 //w=0.187 //l=0.1 //layer=li \
 //thickness=0.1 //x=9 //y=4.62 //x2=9 //y2=4.72
r265 (  16 17 ) resistor r=25.3262 //w=0.187 //l=0.37 //layer=li \
 //thickness=0.1 //x=9 //y=4.25 //x2=9 //y2=4.62
r266 (  15 16 ) resistor r=25.3262 //w=0.187 //l=0.37 //layer=li \
 //thickness=0.1 //x=9 //y=3.88 //x2=9 //y2=4.25
r267 (  14 15 ) resistor r=25.3262 //w=0.187 //l=0.37 //layer=li \
 //thickness=0.1 //x=9 //y=3.51 //x2=9 //y2=3.88
r268 (  13 14 ) resistor r=25.3262 //w=0.187 //l=0.37 //layer=li \
 //thickness=0.1 //x=9 //y=3.14 //x2=9 //y2=3.51
r269 (  12 13 ) resistor r=25.3262 //w=0.187 //l=0.37 //layer=li \
 //thickness=0.1 //x=9 //y=2.77 //x2=9 //y2=3.14
r270 (  12 30 ) resistor r=34.9091 //w=0.187 //l=0.51 //layer=li \
 //thickness=0.1 //x=9 //y=2.77 //x2=9 //y2=2.26
r271 (  11 18 ) resistor r=32.1711 //w=0.187 //l=0.47 //layer=li \
 //thickness=0.1 //x=2.34 //y=4.25 //x2=2.34 //y2=4.72
r272 (  10 11 ) resistor r=25.3262 //w=0.187 //l=0.37 //layer=li \
 //thickness=0.1 //x=2.34 //y=3.88 //x2=2.34 //y2=4.25
r273 (  9 10 ) resistor r=25.3262 //w=0.187 //l=0.37 //layer=li \
 //thickness=0.1 //x=2.34 //y=3.51 //x2=2.34 //y2=3.88
r274 (  8 9 ) resistor r=25.3262 //w=0.187 //l=0.37 //layer=li //thickness=0.1 \
 //x=2.34 //y=3.14 //x2=2.34 //y2=3.51
r275 (  7 8 ) resistor r=25.3262 //w=0.187 //l=0.37 //layer=li //thickness=0.1 \
 //x=2.34 //y=2.77 //x2=2.34 //y2=3.14
r276 (  7 20 ) resistor r=34.9091 //w=0.187 //l=0.51 //layer=li \
 //thickness=0.1 //x=2.34 //y=2.77 //x2=2.34 //y2=2.26
r277 (  6 16 ) resistor r=9.3 //w=0.17 //l=0.17 //layer=mcon //count=1 //x=9 \
 //y=4.25 //x2=9 //y2=4.25
r278 (  4 11 ) resistor r=9.3 //w=0.17 //l=0.17 //layer=mcon //count=1 \
 //x=2.34 //y=4.25 //x2=2.34 //y2=4.25
r279 (  2 4 ) resistor r=0.0717383 //w=0.224 //l=0.115 //layer=m1 \
 //thickness=0.36 //x=2.455 //y=4.25 //x2=2.34 //y2=4.25
r280 (  1 6 ) resistor r=0.0717383 //w=0.224 //l=0.115 //layer=m1 \
 //thickness=0.36 //x=8.885 //y=4.25 //x2=9 //y2=4.25
r281 (  1 2 ) resistor r=6.1355 //w=0.131 //l=6.43 //layer=m1 //thickness=0.36 \
 //x=8.885 //y=4.25 //x2=2.455 //y2=4.25
ends PM_VOTERN3X1\%A

subckt PM_VOTERN3X1\%YN ( 1 2 3 4 11 12 13 14 15 16 17 18 31 32 45 47 48 63 64 \
 65 66 70 71 )
c158 ( 71 0 ) capacitor c=0.0167617f //x=9.115 //y=5.205
c159 ( 70 0 ) capacitor c=0.0164812f //x=8.235 //y=5.205
c160 ( 66 0 ) capacitor c=0.0108176f //x=9.11 //y=1.085
c161 ( 65 0 ) capacitor c=0.0131637f //x=5.78 //y=1.085
c162 ( 64 0 ) capacitor c=0.0131367f //x=2.45 //y=1.085
c163 ( 63 0 ) capacitor c=0.00421476f //x=9.26 //y=5.39
c164 ( 48 0 ) capacitor c=0.00775877f //x=9.385 //y=1.825
c165 ( 47 0 ) capacitor c=0.0165978f //x=9.655 //y=1.825
c166 ( 45 0 ) capacitor c=0.0164794f //x=9.655 //y=5.39
c167 ( 32 0 ) capacitor c=0.0029383f //x=8.465 //y=5.39
c168 ( 31 0 ) capacitor c=0.0159694f //x=9.175 //y=5.39
c169 ( 11 0 ) capacitor c=0.133261f //x=9.74 //y=2.4
c170 ( 4 0 ) capacitor c=0.0117447f //x=6.085 //y=1.36
c171 ( 3 0 ) capacitor c=0.0835197f //x=9.185 //y=1.36
c172 ( 2 0 ) capacitor c=0.0203114f //x=2.755 //y=1.36
c173 ( 1 0 ) capacitor c=0.0989941f //x=5.855 //y=1.36
r174 (  62 64 ) resistor r=13.3953 //w=0.172 //l=0.18 //layer=li \
 //thickness=0.1 //x=2.637 //y=1.36 //x2=2.637 //y2=1.18
r175 (  47 49 ) resistor r=7.15173 //w=0.17 //l=0.120208 //layer=li \
 //thickness=0.1 //x=9.655 //y=1.825 //x2=9.74 //y2=1.91
r176 (  47 48 ) resistor r=18.4813 //w=0.187 //l=0.27 //layer=li \
 //thickness=0.1 //x=9.655 //y=1.825 //x2=9.385 //y2=1.825
r177 (  46 63 ) resistor r=5.4201 //w=0.17 //l=0.085 //layer=li \
 //thickness=0.1 //x=9.345 //y=5.39 //x2=9.26 //y2=5.39
r178 (  45 50 ) resistor r=7.15173 //w=0.17 //l=0.120208 //layer=li \
 //thickness=0.1 //x=9.655 //y=5.39 //x2=9.74 //y2=5.305
r179 (  45 46 ) resistor r=21.2193 //w=0.187 //l=0.31 //layer=li \
 //thickness=0.1 //x=9.655 //y=5.39 //x2=9.345 //y2=5.39
r180 (  44 66 ) resistor r=12.3209 //w=0.187 //l=0.18 //layer=li \
 //thickness=0.1 //x=9.3 //y=1.36 //x2=9.3 //y2=1.18
r181 (  39 48 ) resistor r=7.15173 //w=0.17 //l=0.120208 //layer=li \
 //thickness=0.1 //x=9.3 //y=1.74 //x2=9.385 //y2=1.825
r182 (  39 44 ) resistor r=26.0107 //w=0.187 //l=0.38 //layer=li \
 //thickness=0.1 //x=9.3 //y=1.74 //x2=9.3 //y2=1.36
r183 (  33 63 ) resistor r=1.40859 //w=0.34 //l=0.085 //layer=li \
 //thickness=0.1 //x=9.26 //y=5.475 //x2=9.26 //y2=5.39
r184 (  33 71 ) resistor r=29.0909 //w=0.187 //l=0.425 //layer=li \
 //thickness=0.1 //x=9.26 //y=5.475 //x2=9.26 //y2=5.9
r185 (  31 63 ) resistor r=5.4201 //w=0.17 //l=0.085 //layer=li \
 //thickness=0.1 //x=9.175 //y=5.39 //x2=9.26 //y2=5.39
r186 (  31 32 ) resistor r=48.5989 //w=0.187 //l=0.71 //layer=li \
 //thickness=0.1 //x=9.175 //y=5.39 //x2=8.465 //y2=5.39
r187 (  25 32 ) resistor r=7.15173 //w=0.17 //l=0.120208 //layer=li \
 //thickness=0.1 //x=8.38 //y=5.475 //x2=8.465 //y2=5.39
r188 (  25 70 ) resistor r=29.0909 //w=0.187 //l=0.425 //layer=li \
 //thickness=0.1 //x=8.38 //y=5.475 //x2=8.38 //y2=5.9
r189 (  23 65 ) resistor r=12.3209 //w=0.187 //l=0.18 //layer=li \
 //thickness=0.1 //x=5.97 //y=1.36 //x2=5.97 //y2=1.18
r190 (  18 50 ) resistor r=21.5615 //w=0.187 //l=0.315 //layer=li \
 //thickness=0.1 //x=9.74 //y=4.99 //x2=9.74 //y2=5.305
r191 (  17 18 ) resistor r=25.3262 //w=0.187 //l=0.37 //layer=li \
 //thickness=0.1 //x=9.74 //y=4.62 //x2=9.74 //y2=4.99
r192 (  16 17 ) resistor r=25.3262 //w=0.187 //l=0.37 //layer=li \
 //thickness=0.1 //x=9.74 //y=4.25 //x2=9.74 //y2=4.62
r193 (  15 16 ) resistor r=25.3262 //w=0.187 //l=0.37 //layer=li \
 //thickness=0.1 //x=9.74 //y=3.88 //x2=9.74 //y2=4.25
r194 (  14 15 ) resistor r=25.3262 //w=0.187 //l=0.37 //layer=li \
 //thickness=0.1 //x=9.74 //y=3.51 //x2=9.74 //y2=3.88
r195 (  13 14 ) resistor r=25.3262 //w=0.187 //l=0.37 //layer=li \
 //thickness=0.1 //x=9.74 //y=3.14 //x2=9.74 //y2=3.51
r196 (  12 13 ) resistor r=25.3262 //w=0.187 //l=0.37 //layer=li \
 //thickness=0.1 //x=9.74 //y=2.77 //x2=9.74 //y2=3.14
r197 (  11 12 ) resistor r=25.3262 //w=0.187 //l=0.37 //layer=li \
 //thickness=0.1 //x=9.74 //y=2.4 //x2=9.74 //y2=2.77
r198 (  11 49 ) resistor r=33.5401 //w=0.187 //l=0.49 //layer=li \
 //thickness=0.1 //x=9.74 //y=2.4 //x2=9.74 //y2=1.91
r199 (  10 44 ) resistor r=9.3 //w=0.17 //l=0.17 //layer=mcon //count=1 \
 //x=9.3 //y=1.36 //x2=9.3 //y2=1.36
r200 (  8 23 ) resistor r=9.3 //w=0.17 //l=0.17 //layer=mcon //count=1 \
 //x=5.97 //y=1.36 //x2=5.97 //y2=1.36
r201 (  6 62 ) resistor r=9.3 //w=0.17 //l=0.17 //layer=mcon //count=1 \
 //x=2.64 //y=1.36 //x2=2.64 //y2=1.36
r202 (  4 8 ) resistor r=0.0880901 //w=0.191 //l=0.115 //layer=m1 \
 //thickness=0.36 //x=6.085 //y=1.36 //x2=5.97 //y2=1.36
r203 (  3 10 ) resistor r=0.0717383 //w=0.224 //l=0.115 //layer=m1 \
 //thickness=0.36 //x=9.185 //y=1.36 //x2=9.3 //y2=1.36
r204 (  3 4 ) resistor r=2.95802 //w=0.131 //l=3.1 //layer=m1 //thickness=0.36 \
 //x=9.185 //y=1.36 //x2=6.085 //y2=1.36
r205 (  2 6 ) resistor r=0.0717383 //w=0.224 //l=0.115 //layer=m1 \
 //thickness=0.36 //x=2.755 //y=1.36 //x2=2.64 //y2=1.36
r206 (  1 8 ) resistor r=0.0880901 //w=0.191 //l=0.115 //layer=m1 \
 //thickness=0.36 //x=5.855 //y=1.36 //x2=5.97 //y2=1.36
r207 (  1 2 ) resistor r=2.95802 //w=0.131 //l=3.1 //layer=m1 //thickness=0.36 \
 //x=5.855 //y=1.36 //x2=2.755 //y2=1.36
ends PM_VOTERN3X1\%YN

subckt PM_VOTERN3X1\%noxref_9 ( 1 5 9 10 13 17 29 )
c54 ( 29 0 ) capacitor c=0.0790202f //x=1.05 //y=0.545
c55 ( 17 0 ) capacitor c=0.0072249f //x=3.125 //y=0.795
c56 ( 13 0 ) capacitor c=0.0156987f //x=3.04 //y=0.71
c57 ( 10 0 ) capacitor c=0.0104129f //x=2.155 //y=1.675
c58 ( 9 0 ) capacitor c=0.006761f //x=2.155 //y=0.795
c59 ( 5 0 ) capacitor c=0.029726f //x=2.07 //y=1.76
c60 ( 1 0 ) capacitor c=0.00522395f //x=1.185 //y=1.675
r61 (  17 29 ) resistor r=3.57586 //w=0.17 //l=0.125 //layer=li \
 //thickness=0.1 //x=3.125 //y=0.795 //x2=3.125 //y2=0.67
r62 (  17 29 ) resistor r=41.4118 //w=0.187 //l=0.605 //layer=li \
 //thickness=0.1 //x=3.125 //y=0.795 //x2=3.125 //y2=1.4
r63 (  14 29 ) resistor r=3.57586 //w=0.17 //l=0.103078 //layer=li \
 //thickness=0.1 //x=2.24 //y=0.71 //x2=2.155 //y2=0.67
r64 (  14 29 ) resistor r=27.0374 //w=0.187 //l=0.395 //layer=li \
 //thickness=0.1 //x=2.24 //y=0.71 //x2=2.635 //y2=0.71
r65 (  13 29 ) resistor r=3.57586 //w=0.17 //l=0.103078 //layer=li \
 //thickness=0.1 //x=3.04 //y=0.71 //x2=3.125 //y2=0.67
r66 (  13 29 ) resistor r=27.7219 //w=0.187 //l=0.405 //layer=li \
 //thickness=0.1 //x=3.04 //y=0.71 //x2=2.635 //y2=0.71
r67 (  10 29 ) resistor r=3.57586 //w=0.17 //l=0.125 //layer=li \
 //thickness=0.1 //x=2.155 //y=1.675 //x2=2.155 //y2=1.8
r68 (  10 29 ) resistor r=42.0963 //w=0.187 //l=0.615 //layer=li \
 //thickness=0.1 //x=2.155 //y=1.675 //x2=2.155 //y2=1.06
r69 (  9 29 ) resistor r=3.57586 //w=0.17 //l=0.125 //layer=li //thickness=0.1 \
 //x=2.155 //y=0.795 //x2=2.155 //y2=0.67
r70 (  9 29 ) resistor r=18.139 //w=0.187 //l=0.265 //layer=li //thickness=0.1 \
 //x=2.155 //y=0.795 //x2=2.155 //y2=1.06
r71 (  6 29 ) resistor r=3.57586 //w=0.17 //l=0.103078 //layer=li \
 //thickness=0.1 //x=1.27 //y=1.76 //x2=1.185 //y2=1.8
r72 (  6 29 ) resistor r=27.3797 //w=0.187 //l=0.4 //layer=li //thickness=0.1 \
 //x=1.27 //y=1.76 //x2=1.67 //y2=1.76
r73 (  5 29 ) resistor r=3.57586 //w=0.17 //l=0.103078 //layer=li \
 //thickness=0.1 //x=2.07 //y=1.76 //x2=2.155 //y2=1.8
r74 (  5 29 ) resistor r=27.3797 //w=0.187 //l=0.4 //layer=li //thickness=0.1 \
 //x=2.07 //y=1.76 //x2=1.67 //y2=1.76
r75 (  1 29 ) resistor r=3.57586 //w=0.17 //l=0.125 //layer=li //thickness=0.1 \
 //x=1.185 //y=1.675 //x2=1.185 //y2=1.8
r76 (  1 29 ) resistor r=42.0963 //w=0.187 //l=0.615 //layer=li \
 //thickness=0.1 //x=1.185 //y=1.675 //x2=1.185 //y2=1.06
ends PM_VOTERN3X1\%noxref_9

subckt PM_VOTERN3X1\%noxref_10 ( 1 5 9 10 13 17 29 )
c56 ( 29 0 ) capacitor c=0.0723467f //x=4.38 //y=0.545
c57 ( 17 0 ) capacitor c=0.0072249f //x=6.455 //y=0.795
c58 ( 13 0 ) capacitor c=0.0155051f //x=6.37 //y=0.71
c59 ( 10 0 ) capacitor c=0.0121386f //x=5.485 //y=1.675
c60 ( 9 0 ) capacitor c=0.006761f //x=5.485 //y=0.795
c61 ( 5 0 ) capacitor c=0.0249342f //x=5.4 //y=1.76
c62 ( 1 0 ) capacitor c=0.0107269f //x=4.515 //y=1.675
r63 (  17 29 ) resistor r=3.57586 //w=0.17 //l=0.125 //layer=li \
 //thickness=0.1 //x=6.455 //y=0.795 //x2=6.455 //y2=0.67
r64 (  17 29 ) resistor r=41.4118 //w=0.187 //l=0.605 //layer=li \
 //thickness=0.1 //x=6.455 //y=0.795 //x2=6.455 //y2=1.4
r65 (  14 29 ) resistor r=3.57586 //w=0.17 //l=0.103078 //layer=li \
 //thickness=0.1 //x=5.57 //y=0.71 //x2=5.485 //y2=0.67
r66 (  14 29 ) resistor r=27.3797 //w=0.187 //l=0.4 //layer=li //thickness=0.1 \
 //x=5.57 //y=0.71 //x2=5.97 //y2=0.71
r67 (  13 29 ) resistor r=3.57586 //w=0.17 //l=0.103078 //layer=li \
 //thickness=0.1 //x=6.37 //y=0.71 //x2=6.455 //y2=0.67
r68 (  13 29 ) resistor r=27.3797 //w=0.187 //l=0.4 //layer=li //thickness=0.1 \
 //x=6.37 //y=0.71 //x2=5.97 //y2=0.71
r69 (  10 29 ) resistor r=3.57586 //w=0.17 //l=0.125 //layer=li \
 //thickness=0.1 //x=5.485 //y=1.675 //x2=5.485 //y2=1.8
r70 (  10 29 ) resistor r=42.0963 //w=0.187 //l=0.615 //layer=li \
 //thickness=0.1 //x=5.485 //y=1.675 //x2=5.485 //y2=1.06
r71 (  9 29 ) resistor r=3.57586 //w=0.17 //l=0.125 //layer=li //thickness=0.1 \
 //x=5.485 //y=0.795 //x2=5.485 //y2=0.67
r72 (  9 29 ) resistor r=18.139 //w=0.187 //l=0.265 //layer=li //thickness=0.1 \
 //x=5.485 //y=0.795 //x2=5.485 //y2=1.06
r73 (  6 29 ) resistor r=3.57586 //w=0.17 //l=0.103078 //layer=li \
 //thickness=0.1 //x=4.6 //y=1.76 //x2=4.515 //y2=1.8
r74 (  6 29 ) resistor r=27.3797 //w=0.187 //l=0.4 //layer=li //thickness=0.1 \
 //x=4.6 //y=1.76 //x2=5 //y2=1.76
r75 (  5 29 ) resistor r=3.57586 //w=0.17 //l=0.103078 //layer=li \
 //thickness=0.1 //x=5.4 //y=1.76 //x2=5.485 //y2=1.8
r76 (  5 29 ) resistor r=27.3797 //w=0.187 //l=0.4 //layer=li //thickness=0.1 \
 //x=5.4 //y=1.76 //x2=5 //y2=1.76
r77 (  1 29 ) resistor r=3.57586 //w=0.17 //l=0.125 //layer=li //thickness=0.1 \
 //x=4.515 //y=1.675 //x2=4.515 //y2=1.8
r78 (  1 29 ) resistor r=42.0963 //w=0.187 //l=0.615 //layer=li \
 //thickness=0.1 //x=4.515 //y=1.675 //x2=4.515 //y2=1.06
ends PM_VOTERN3X1\%noxref_10

subckt PM_VOTERN3X1\%noxref_11 ( 1 5 9 10 13 17 29 )
c51 ( 29 0 ) capacitor c=0.0643762f //x=7.71 //y=0.545
c52 ( 17 0 ) capacitor c=0.00722228f //x=9.785 //y=0.795
c53 ( 13 0 ) capacitor c=0.0141607f //x=9.7 //y=0.71
c54 ( 10 0 ) capacitor c=0.00928228f //x=8.815 //y=1.675
c55 ( 9 0 ) capacitor c=0.006761f //x=8.815 //y=0.795
c56 ( 5 0 ) capacitor c=0.0289528f //x=8.73 //y=1.76
c57 ( 1 0 ) capacitor c=0.00481264f //x=7.845 //y=1.675
r58 (  17 29 ) resistor r=3.57586 //w=0.17 //l=0.125 //layer=li \
 //thickness=0.1 //x=9.785 //y=0.795 //x2=9.785 //y2=0.67
r59 (  17 29 ) resistor r=18.139 //w=0.187 //l=0.265 //layer=li \
 //thickness=0.1 //x=9.785 //y=0.795 //x2=9.785 //y2=1.06
r60 (  14 29 ) resistor r=3.57586 //w=0.17 //l=0.103078 //layer=li \
 //thickness=0.1 //x=8.9 //y=0.71 //x2=8.815 //y2=0.67
r61 (  14 29 ) resistor r=27.3797 //w=0.187 //l=0.4 //layer=li //thickness=0.1 \
 //x=8.9 //y=0.71 //x2=9.3 //y2=0.71
r62 (  13 29 ) resistor r=3.57586 //w=0.17 //l=0.103078 //layer=li \
 //thickness=0.1 //x=9.7 //y=0.71 //x2=9.785 //y2=0.67
r63 (  13 29 ) resistor r=27.3797 //w=0.187 //l=0.4 //layer=li //thickness=0.1 \
 //x=9.7 //y=0.71 //x2=9.3 //y2=0.71
r64 (  10 29 ) resistor r=3.57586 //w=0.17 //l=0.125 //layer=li \
 //thickness=0.1 //x=8.815 //y=1.675 //x2=8.815 //y2=1.8
r65 (  10 29 ) resistor r=42.0963 //w=0.187 //l=0.615 //layer=li \
 //thickness=0.1 //x=8.815 //y=1.675 //x2=8.815 //y2=1.06
r66 (  9 29 ) resistor r=3.57586 //w=0.17 //l=0.125 //layer=li //thickness=0.1 \
 //x=8.815 //y=0.795 //x2=8.815 //y2=0.67
r67 (  9 29 ) resistor r=18.139 //w=0.187 //l=0.265 //layer=li //thickness=0.1 \
 //x=8.815 //y=0.795 //x2=8.815 //y2=1.06
r68 (  6 29 ) resistor r=3.57586 //w=0.17 //l=0.103078 //layer=li \
 //thickness=0.1 //x=7.93 //y=1.76 //x2=7.845 //y2=1.8
r69 (  6 29 ) resistor r=27.3797 //w=0.187 //l=0.4 //layer=li //thickness=0.1 \
 //x=7.93 //y=1.76 //x2=8.33 //y2=1.76
r70 (  5 29 ) resistor r=3.57586 //w=0.17 //l=0.103078 //layer=li \
 //thickness=0.1 //x=8.73 //y=1.76 //x2=8.815 //y2=1.8
r71 (  5 29 ) resistor r=27.3797 //w=0.187 //l=0.4 //layer=li //thickness=0.1 \
 //x=8.73 //y=1.76 //x2=8.33 //y2=1.76
r72 (  1 29 ) resistor r=3.57586 //w=0.17 //l=0.125 //layer=li //thickness=0.1 \
 //x=7.845 //y=1.675 //x2=7.845 //y2=1.8
r73 (  1 29 ) resistor r=42.0963 //w=0.187 //l=0.615 //layer=li \
 //thickness=0.1 //x=7.845 //y=1.675 //x2=7.845 //y2=1.06
ends PM_VOTERN3X1\%noxref_11
