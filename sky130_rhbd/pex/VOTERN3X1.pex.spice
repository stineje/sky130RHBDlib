// File: VOTERN3X1.spi.pex
// Created: Fri Feb 20 10:17:16 2026
// Program "Calibre xRC"
// Version "v2023.2_27.15"
// Nominal Temperature: 30C
// Circuit Temperature: 30C
//
simulator lang=spectre
subckt PM_VOTERN3X1\%B ( 1 2 3 4 5 6 7 8 9 10 11 12 19 37 42 43 46 51 57 62 67 \
 68 69 70 71 72 73 74 75 76 80 82 85 86 87 88 92 93 94 95 99 101 107 108 110 \
 123 )
c239 ( 123 0 ) capacitor c=0.0692896f //x=4.93 //y=4.885
c240 ( 110 0 ) capacitor c=0.0603371f //x=1.23 //y=2.26
c241 ( 108 0 ) capacitor c=0.0344584f //x=5.265 //y=1.39
c242 ( 107 0 ) capacitor c=0.0186809f //x=5.265 //y=1.045
c243 ( 101 0 ) capacitor c=0.0141797f //x=5.11 //y=1.545
c244 ( 99 0 ) capacitor c=0.0158553f //x=5.11 //y=0.89
c245 ( 95 0 ) capacitor c=0.103881f //x=4.735 //y=2.095
c246 ( 94 0 ) capacitor c=0.0227978f //x=4.735 //y=1.7
c247 ( 93 0 ) capacitor c=0.0234352f //x=4.735 //y=1.39
c248 ( 92 0 ) capacitor c=0.0198759f //x=4.735 //y=1.045
c249 ( 88 0 ) capacitor c=0.0318956f //x=1.935 //y=1.39
c250 ( 87 0 ) capacitor c=0.0186809f //x=1.935 //y=1.045
c251 ( 86 0 ) capacitor c=0.0624333f //x=1.575 //y=4.975
c252 ( 85 0 ) capacitor c=0.0375163f //x=1.865 //y=4.975
c253 ( 82 0 ) capacitor c=0.0157936f //x=1.78 //y=1.545
c254 ( 80 0 ) capacitor c=0.0158553f //x=1.78 //y=0.89
c255 ( 76 0 ) capacitor c=0.0302441f //x=1.405 //y=2.095
c256 ( 75 0 ) capacitor c=0.0238107f //x=1.405 //y=1.7
c257 ( 74 0 ) capacitor c=0.0234359f //x=1.405 //y=1.39
c258 ( 73 0 ) capacitor c=0.0199332f //x=1.405 //y=1.045
c259 ( 72 0 ) capacitor c=0.110525f //x=5.26 //y=6.205
c260 ( 71 0 ) capacitor c=0.154978f //x=4.82 //y=6.205
c261 ( 70 0 ) capacitor c=0.110282f //x=1.94 //y=6.205
c262 ( 69 0 ) capacitor c=0.155219f //x=1.5 //y=6.205
c263 ( 62 0 ) capacitor c=0.0156727f //x=4.93 //y=4.62
c264 ( 57 0 ) capacitor c=0.00126053f //x=4.93 //y=2.26
c265 ( 51 0 ) capacitor c=0.0125733f //x=1.23 //y=4.62
c266 ( 46 0 ) capacitor c=7.43216e-19 //x=1.23 //y=2.26
c267 ( 43 0 ) capacitor c=0.0876578f //x=4.775 //y=4.64
c268 ( 42 0 ) capacitor c=0.00642399f //x=4.935 //y=4.64
c269 ( 37 0 ) capacitor c=0.00920482f //x=1.395 //y=4.62
c270 ( 19 0 ) capacitor c=0.00888199f //x=4.93 //y=2.385
c271 ( 12 0 ) capacitor c=0.0100386f //x=1.23 //y=2.375
c272 ( 11 0 ) capacitor c=0.0127992f //x=4.93 //y=4.62
c273 ( 10 0 ) capacitor c=0.0139929f //x=1.23 //y=4.62
c274 ( 6 0 ) capacitor c=0.0851523f //x=4.93 //y=2.77
c275 ( 1 0 ) capacitor c=0.0996103f //x=1.23 //y=2.77
r276 (  121 123 ) resistor r=22.7554 //w=0.233 //l=0.11 //layer=ply \
 //thickness=0.18 //x=4.82 //y=4.885 //x2=4.93 //y2=4.885
r277 (  108 125 ) resistor r=45.1352 //w=0.168 //l=0.173853 //layer=ply \
 //thickness=0.18 //x=5.265 //y=1.39 //x2=5.225 //y2=1.545
r278 (  107 124 ) resistor r=45.1352 //w=0.168 //l=0.173853 //layer=ply \
 //thickness=0.18 //x=5.265 //y=1.045 //x2=5.225 //y2=0.89
r279 (  107 108 ) resistor r=176.904 //w=0.094 //l=0.345 //layer=ply \
 //thickness=0.18 //x=5.265 //y=1.045 //x2=5.265 //y2=1.39
r280 (  104 123 ) resistor r=68.2661 //w=0.233 //l=0.404166 //layer=ply \
 //thickness=0.18 //x=5.26 //y=5.05 //x2=4.93 //y2=4.885
r281 (  102 120 ) resistor r=10.701 //w=0.21 //l=0.115 //layer=ply \
 //thickness=0.18 //x=4.89 //y=1.545 //x2=4.775 //y2=1.545
r282 (  101 125 ) resistor r=5.52526 //w=0.168 //l=0.115 //layer=ply \
 //thickness=0.18 //x=5.11 //y=1.545 //x2=5.225 //y2=1.545
r283 (  100 119 ) resistor r=5.52526 //w=0.168 //l=0.115 //layer=ply \
 //thickness=0.18 //x=4.89 //y=0.89 //x2=4.775 //y2=0.89
r284 (  99 124 ) resistor r=5.52526 //w=0.168 //l=0.115 //layer=ply \
 //thickness=0.18 //x=5.11 //y=0.89 //x2=5.225 //y2=0.89
r285 (  99 100 ) resistor r=112.809 //w=0.094 //l=0.22 //layer=ply \
 //thickness=0.18 //x=5.11 //y=0.89 //x2=4.89 //y2=0.89
r286 (  96 121 ) resistor r=13.0941 //w=0.233 //l=0.165 //layer=ply \
 //thickness=0.18 //x=4.82 //y=5.05 //x2=4.82 //y2=4.885
r287 (  95 118 ) resistor r=34.8111 //w=0.27 //l=0.264953 //layer=ply \
 //thickness=0.18 //x=4.735 //y=2.095 //x2=4.93 //y2=2.26
r288 (  94 120 ) resistor r=39.5823 //w=0.21 //l=0.173853 //layer=ply \
 //thickness=0.18 //x=4.735 //y=1.7 //x2=4.775 //y2=1.545
r289 (  94 95 ) resistor r=202.543 //w=0.094 //l=0.395 //layer=ply \
 //thickness=0.18 //x=4.735 //y=1.7 //x2=4.735 //y2=2.095
r290 (  93 120 ) resistor r=39.5823 //w=0.21 //l=0.173853 //layer=ply \
 //thickness=0.18 //x=4.735 //y=1.39 //x2=4.775 //y2=1.545
r291 (  92 119 ) resistor r=45.1352 //w=0.168 //l=0.173853 //layer=ply \
 //thickness=0.18 //x=4.735 //y=1.045 //x2=4.775 //y2=0.89
r292 (  92 93 ) resistor r=176.904 //w=0.094 //l=0.345 //layer=ply \
 //thickness=0.18 //x=4.735 //y=1.045 //x2=4.735 //y2=1.39
r293 (  88 116 ) resistor r=45.1352 //w=0.168 //l=0.173853 //layer=ply \
 //thickness=0.18 //x=1.935 //y=1.39 //x2=1.895 //y2=1.545
r294 (  87 115 ) resistor r=45.1352 //w=0.168 //l=0.173853 //layer=ply \
 //thickness=0.18 //x=1.935 //y=1.045 //x2=1.895 //y2=0.89
r295 (  87 88 ) resistor r=176.904 //w=0.094 //l=0.345 //layer=ply \
 //thickness=0.18 //x=1.935 //y=1.045 //x2=1.935 //y2=1.39
r296 (  85 89 ) resistor r=26.9307 //w=0.15 //l=0.106066 //layer=ply \
 //thickness=0.18 //x=1.865 //y=4.975 //x2=1.94 //y2=5.05
r297 (  85 86 ) resistor r=148.702 //w=0.094 //l=0.29 //layer=ply \
 //thickness=0.18 //x=1.865 //y=4.975 //x2=1.575 //y2=4.975
r298 (  83 114 ) resistor r=10.701 //w=0.21 //l=0.115 //layer=ply \
 //thickness=0.18 //x=1.56 //y=1.545 //x2=1.445 //y2=1.545
r299 (  82 116 ) resistor r=5.52526 //w=0.168 //l=0.115 //layer=ply \
 //thickness=0.18 //x=1.78 //y=1.545 //x2=1.895 //y2=1.545
r300 (  81 113 ) resistor r=5.52526 //w=0.168 //l=0.115 //layer=ply \
 //thickness=0.18 //x=1.56 //y=0.89 //x2=1.445 //y2=0.89
r301 (  80 115 ) resistor r=5.52526 //w=0.168 //l=0.115 //layer=ply \
 //thickness=0.18 //x=1.78 //y=0.89 //x2=1.895 //y2=0.89
r302 (  80 81 ) resistor r=112.809 //w=0.094 //l=0.22 //layer=ply \
 //thickness=0.18 //x=1.78 //y=0.89 //x2=1.56 //y2=0.89
r303 (  77 86 ) resistor r=22.1787 //w=0.252 //l=0.106066 //layer=ply \
 //thickness=0.18 //x=1.5 //y=5.05 //x2=1.575 //y2=4.975
r304 (  77 112 ) resistor r=51.6429 //w=0.252 //l=0.34271 //layer=ply \
 //thickness=0.18 //x=1.5 //y=5.05 //x2=1.23 //y2=4.885
r305 (  76 110 ) resistor r=30.4513 //w=0.277 //l=0.243926 //layer=ply \
 //thickness=0.18 //x=1.405 //y=2.095 //x2=1.23 //y2=2.26
r306 (  75 114 ) resistor r=39.5823 //w=0.21 //l=0.173853 //layer=ply \
 //thickness=0.18 //x=1.405 //y=1.7 //x2=1.445 //y2=1.545
r307 (  75 76 ) resistor r=202.543 //w=0.094 //l=0.395 //layer=ply \
 //thickness=0.18 //x=1.405 //y=1.7 //x2=1.405 //y2=2.095
r308 (  74 114 ) resistor r=39.5823 //w=0.21 //l=0.173853 //layer=ply \
 //thickness=0.18 //x=1.405 //y=1.39 //x2=1.445 //y2=1.545
r309 (  73 113 ) resistor r=45.1352 //w=0.168 //l=0.173853 //layer=ply \
 //thickness=0.18 //x=1.405 //y=1.045 //x2=1.445 //y2=0.89
r310 (  73 74 ) resistor r=176.904 //w=0.094 //l=0.345 //layer=ply \
 //thickness=0.18 //x=1.405 //y=1.045 //x2=1.405 //y2=1.39
r311 (  72 104 ) resistor r=592.245 //w=0.094 //l=1.155 //layer=ply \
 //thickness=0.18 //x=5.26 //y=6.205 //x2=5.26 //y2=5.05
r312 (  71 96 ) resistor r=592.245 //w=0.094 //l=1.155 //layer=ply \
 //thickness=0.18 //x=4.82 //y=6.205 //x2=4.82 //y2=5.05
r313 (  70 89 ) resistor r=592.245 //w=0.094 //l=1.155 //layer=ply \
 //thickness=0.18 //x=1.94 //y=6.205 //x2=1.94 //y2=5.05
r314 (  69 77 ) resistor r=592.245 //w=0.094 //l=1.155 //layer=ply \
 //thickness=0.18 //x=1.5 //y=6.205 //x2=1.5 //y2=5.05
r315 (  68 101 ) resistor r=56.4043 //w=0.094 //l=0.11 //layer=ply \
 //thickness=0.18 //x=5 //y=1.545 //x2=5.11 //y2=1.545
r316 (  68 102 ) resistor r=56.4043 //w=0.094 //l=0.11 //layer=ply \
 //thickness=0.18 //x=5 //y=1.545 //x2=4.89 //y2=1.545
r317 (  67 82 ) resistor r=56.4043 //w=0.094 //l=0.11 //layer=ply \
 //thickness=0.18 //x=1.67 //y=1.545 //x2=1.78 //y2=1.545
r318 (  67 83 ) resistor r=56.4043 //w=0.094 //l=0.11 //layer=ply \
 //thickness=0.18 //x=1.67 //y=1.545 //x2=1.56 //y2=1.545
r319 (  65 123 ) resistor r=152 //w=0.17 //l=0.17 //layer=licon //count=1 \
 //x=4.93 //y=4.885 //x2=4.93 //y2=4.885
r320 (  62 65 ) resistor r=18.139 //w=0.187 //l=0.265 //layer=li \
 //thickness=0.1 //x=4.93 //y=4.62 //x2=4.93 //y2=4.885
r321 (  57 118 ) resistor r=152 //w=0.17 //l=0.17 //layer=licon //count=1 \
 //x=4.93 //y=2.26 //x2=4.93 //y2=2.26
r322 (  54 112 ) resistor r=152 //w=0.17 //l=0.17 //layer=licon //count=1 \
 //x=1.23 //y=4.885 //x2=1.23 //y2=4.885
r323 (  51 54 ) resistor r=18.139 //w=0.187 //l=0.265 //layer=li \
 //thickness=0.1 //x=1.23 //y=4.62 //x2=1.23 //y2=4.885
r324 (  46 110 ) resistor r=152 //w=0.17 //l=0.17 //layer=licon //count=1 \
 //x=1.23 //y=2.26 //x2=1.23 //y2=2.26
r325 (  42 43 ) resistor r=0.10734 //w=0.281 //l=0.16 //layer=m2 \
 //thickness=0.36 //x=4.935 //y=4.64 //x2=4.775 //y2=4.64
r326 (  37 39 ) resistor r=0.10734 //w=0.281 //l=0.16 //layer=m2 \
 //thickness=0.36 //x=1.395 //y=4.62 //x2=1.235 //y2=4.62
r327 (  37 43 ) resistor r=3.22519 //w=0.131 //l=3.38 //layer=m2 \
 //thickness=0.36 //x=1.395 //y=4.62 //x2=4.775 //y2=4.62
r328 (  35 57 ) resistor r=9.3 //w=0.17 //l=0.17 //layer=mcon //count=1 \
 //x=4.93 //y=2.26 //x2=4.93 //y2=2.26
r329 (  33 42 ) resistor r=4.5 //w=0.15 //l=0.15 //layer=via1 //count=1 \
 //x=4.935 //y=4.64 //x2=4.935 //y2=4.64
r330 (  26 46 ) resistor r=9.3 //w=0.17 //l=0.17 //layer=mcon //count=1 \
 //x=1.23 //y=2.26 //x2=1.23 //y2=2.26
r331 (  19 35 ) resistor r=0.0761125 //w=0.237 //l=0.126491 //layer=m1 \
 //thickness=0.36 //x=4.93 //y=2.385 //x2=4.927 //y2=2.26
r332 (  12 26 ) resistor r=0.0717383 //w=0.224 //l=0.115 //layer=m1 \
 //thickness=0.36 //x=1.23 //y=2.375 //x2=1.23 //y2=2.26
r333 (  11 62 ) resistor r=9.3 //w=0.17 //l=0.17 //layer=mcon //count=1 \
 //x=4.93 //y=4.62 //x2=4.93 //y2=4.62
r334 (  11 33 ) resistor r=0.00659631 //w=0.379 //l=0.02 //layer=m1 \
 //thickness=0.36 //x=4.88 //y=4.62 //x2=4.88 //y2=4.64
r335 (  11 20 ) resistor r=0.0863342 //w=0.379 //l=0.168152 //layer=m1 \
 //thickness=0.36 //x=4.88 //y=4.62 //x2=4.93 //y2=4.475
r336 (  10 51 ) resistor r=9.3 //w=0.17 //l=0.17 //layer=mcon //count=1 \
 //x=1.23 //y=4.62 //x2=1.23 //y2=4.62
r337 (  10 39 ) resistor r=4.5 //w=0.15 //l=0.15 //layer=via1 //count=1 \
 //x=1.235 //y=4.62 //x2=1.235 //y2=4.62
r338 (  10 13 ) resistor r=0.0898201 //w=0.322 //l=0.185472 //layer=m1 \
 //thickness=0.36 //x=1.285 //y=4.62 //x2=1.23 //y2=4.46
r339 (  9 20 ) resistor r=0.567748 //w=0.131 //l=0.595 //layer=m1 \
 //thickness=0.36 //x=4.93 //y=3.88 //x2=4.93 //y2=4.475
r340 (  8 9 ) resistor r=0.353053 //w=0.131 //l=0.37 //layer=m1 \
 //thickness=0.36 //x=4.93 //y=3.51 //x2=4.93 //y2=3.88
r341 (  7 8 ) resistor r=0.353053 //w=0.131 //l=0.37 //layer=m1 \
 //thickness=0.36 //x=4.93 //y=3.14 //x2=4.93 //y2=3.51
r342 (  6 7 ) resistor r=0.353053 //w=0.131 //l=0.37 //layer=m1 \
 //thickness=0.36 //x=4.93 //y=2.77 //x2=4.93 //y2=3.14
r343 (  6 19 ) resistor r=0.367366 //w=0.131 //l=0.385 //layer=m1 \
 //thickness=0.36 //x=4.93 //y=2.77 //x2=4.93 //y2=2.385
r344 (  5 13 ) resistor r=0.200382 //w=0.131 //l=0.21 //layer=m1 \
 //thickness=0.36 //x=1.23 //y=4.25 //x2=1.23 //y2=4.46
r345 (  4 5 ) resistor r=0.353053 //w=0.131 //l=0.37 //layer=m1 \
 //thickness=0.36 //x=1.23 //y=3.88 //x2=1.23 //y2=4.25
r346 (  3 4 ) resistor r=0.353053 //w=0.131 //l=0.37 //layer=m1 \
 //thickness=0.36 //x=1.23 //y=3.51 //x2=1.23 //y2=3.88
r347 (  2 3 ) resistor r=0.353053 //w=0.131 //l=0.37 //layer=m1 \
 //thickness=0.36 //x=1.23 //y=3.14 //x2=1.23 //y2=3.51
r348 (  1 2 ) resistor r=0.353053 //w=0.131 //l=0.37 //layer=m1 \
 //thickness=0.36 //x=1.23 //y=2.77 //x2=1.23 //y2=3.14
r349 (  1 12 ) resistor r=0.376908 //w=0.131 //l=0.395 //layer=m1 \
 //thickness=0.36 //x=1.23 //y=2.77 //x2=1.23 //y2=2.375
ends PM_VOTERN3X1\%B

subckt PM_VOTERN3X1\%C ( 1 2 3 4 5 6 7 8 9 10 11 12 18 19 42 44 45 48 53 58 63 \
 67 68 69 70 71 72 76 77 78 79 80 82 85 88 89 90 91 92 93 94 95 99 101 104 105 \
 106 107 120 )
c236 ( 120 0 ) capacitor c=0.0586737f //x=7.89 //y=2.26
c237 ( 107 0 ) capacitor c=0.0318956f //x=8.595 //y=1.39
c238 ( 106 0 ) capacitor c=0.0186809f //x=8.595 //y=1.045
c239 ( 105 0 ) capacitor c=0.0659968f //x=8.235 //y=4.975
c240 ( 104 0 ) capacitor c=0.0373387f //x=8.525 //y=4.975
c241 ( 101 0 ) capacitor c=0.0157936f //x=8.44 //y=1.545
c242 ( 99 0 ) capacitor c=0.0158553f //x=8.44 //y=0.89
c243 ( 95 0 ) capacitor c=0.0302441f //x=8.065 //y=2.095
c244 ( 94 0 ) capacitor c=0.0238107f //x=8.065 //y=1.7
c245 ( 93 0 ) capacitor c=0.0234359f //x=8.065 //y=1.39
c246 ( 92 0 ) capacitor c=0.0199332f //x=8.065 //y=1.045
c247 ( 91 0 ) capacitor c=0.0972519f //x=6.235 //y=2.095
c248 ( 90 0 ) capacitor c=0.0251353f //x=6.235 //y=1.74
c249 ( 89 0 ) capacitor c=0.0234318f //x=6.235 //y=1.43
c250 ( 88 0 ) capacitor c=0.0192547f //x=6.235 //y=1.085
c251 ( 85 0 ) capacitor c=0.0714656f //x=6.14 //y=5.05
c252 ( 82 0 ) capacitor c=0.0186579f //x=6.08 //y=1.585
c253 ( 80 0 ) capacitor c=0.0157803f //x=6.08 //y=0.93
c254 ( 79 0 ) capacitor c=0.0134011f //x=5.775 //y=4.975
c255 ( 78 0 ) capacitor c=0.0243282f //x=6.065 //y=4.975
c256 ( 77 0 ) capacitor c=0.0364928f //x=5.705 //y=1.43
c257 ( 76 0 ) capacitor c=0.0174823f //x=5.705 //y=1.085
c258 ( 72 0 ) capacitor c=0.11081f //x=8.6 //y=6.205
c259 ( 71 0 ) capacitor c=0.154997f //x=8.16 //y=6.205
c260 ( 70 0 ) capacitor c=0.155934f //x=6.14 //y=6.205
c261 ( 69 0 ) capacitor c=0.110593f //x=5.7 //y=6.205
c262 ( 63 0 ) capacitor c=7.7962e-19 //x=7.89 //y=4.885
c263 ( 58 0 ) capacitor c=7.89145e-19 //x=7.89 //y=2.26
c264 ( 53 0 ) capacitor c=7.79163e-19 //x=6.41 //y=4.885
c265 ( 48 0 ) capacitor c=7.43216e-19 //x=6.41 //y=2.26
c266 ( 45 0 ) capacitor c=0.0208859f //x=7.725 //y=2.27
c267 ( 44 0 ) capacitor c=0.00241177f //x=7.885 //y=2.27
c268 ( 42 0 ) capacitor c=0.0031771f //x=6.575 //y=2.27
c269 ( 19 0 ) capacitor c=0.00623797f //x=7.89 //y=4.755
c270 ( 18 0 ) capacitor c=0.00995077f //x=7.89 //y=2.43
c271 ( 12 0 ) capacitor c=0.00859821f //x=6.41 //y=4.76
c272 ( 11 0 ) capacitor c=0.0102822f //x=6.41 //y=2.43
c273 ( 6 0 ) capacitor c=0.0721899f //x=7.89 //y=2.77
c274 ( 1 0 ) capacitor c=0.0779094f //x=6.41 //y=2.77
r275 (  107 126 ) resistor r=45.1352 //w=0.168 //l=0.173853 //layer=ply \
 //thickness=0.18 //x=8.595 //y=1.39 //x2=8.555 //y2=1.545
r276 (  106 125 ) resistor r=45.1352 //w=0.168 //l=0.173853 //layer=ply \
 //thickness=0.18 //x=8.595 //y=1.045 //x2=8.555 //y2=0.89
r277 (  106 107 ) resistor r=176.904 //w=0.094 //l=0.345 //layer=ply \
 //thickness=0.18 //x=8.595 //y=1.045 //x2=8.595 //y2=1.39
r278 (  104 108 ) resistor r=26.9307 //w=0.15 //l=0.106066 //layer=ply \
 //thickness=0.18 //x=8.525 //y=4.975 //x2=8.6 //y2=5.05
r279 (  104 105 ) resistor r=148.702 //w=0.094 //l=0.29 //layer=ply \
 //thickness=0.18 //x=8.525 //y=4.975 //x2=8.235 //y2=4.975
r280 (  102 124 ) resistor r=10.701 //w=0.21 //l=0.115 //layer=ply \
 //thickness=0.18 //x=8.22 //y=1.545 //x2=8.105 //y2=1.545
r281 (  101 126 ) resistor r=5.52526 //w=0.168 //l=0.115 //layer=ply \
 //thickness=0.18 //x=8.44 //y=1.545 //x2=8.555 //y2=1.545
r282 (  100 123 ) resistor r=5.52526 //w=0.168 //l=0.115 //layer=ply \
 //thickness=0.18 //x=8.22 //y=0.89 //x2=8.105 //y2=0.89
r283 (  99 125 ) resistor r=5.52526 //w=0.168 //l=0.115 //layer=ply \
 //thickness=0.18 //x=8.44 //y=0.89 //x2=8.555 //y2=0.89
r284 (  99 100 ) resistor r=112.809 //w=0.094 //l=0.22 //layer=ply \
 //thickness=0.18 //x=8.44 //y=0.89 //x2=8.22 //y2=0.89
r285 (  96 105 ) resistor r=22.1787 //w=0.252 //l=0.106066 //layer=ply \
 //thickness=0.18 //x=8.16 //y=5.05 //x2=8.235 //y2=4.975
r286 (  96 122 ) resistor r=51.6429 //w=0.252 //l=0.34271 //layer=ply \
 //thickness=0.18 //x=8.16 //y=5.05 //x2=7.89 //y2=4.885
r287 (  95 120 ) resistor r=30.4513 //w=0.277 //l=0.243926 //layer=ply \
 //thickness=0.18 //x=8.065 //y=2.095 //x2=7.89 //y2=2.26
r288 (  94 124 ) resistor r=39.5823 //w=0.21 //l=0.173853 //layer=ply \
 //thickness=0.18 //x=8.065 //y=1.7 //x2=8.105 //y2=1.545
r289 (  94 95 ) resistor r=202.543 //w=0.094 //l=0.395 //layer=ply \
 //thickness=0.18 //x=8.065 //y=1.7 //x2=8.065 //y2=2.095
r290 (  93 124 ) resistor r=39.5823 //w=0.21 //l=0.173853 //layer=ply \
 //thickness=0.18 //x=8.065 //y=1.39 //x2=8.105 //y2=1.545
r291 (  92 123 ) resistor r=45.1352 //w=0.168 //l=0.173853 //layer=ply \
 //thickness=0.18 //x=8.065 //y=1.045 //x2=8.105 //y2=0.89
r292 (  92 93 ) resistor r=176.904 //w=0.094 //l=0.345 //layer=ply \
 //thickness=0.18 //x=8.065 //y=1.045 //x2=8.065 //y2=1.39
r293 (  91 116 ) resistor r=30.4513 //w=0.277 //l=0.243926 //layer=ply \
 //thickness=0.18 //x=6.235 //y=2.095 //x2=6.41 //y2=2.26
r294 (  90 114 ) resistor r=39.5823 //w=0.21 //l=0.173853 //layer=ply \
 //thickness=0.18 //x=6.235 //y=1.74 //x2=6.195 //y2=1.585
r295 (  90 91 ) resistor r=182.032 //w=0.094 //l=0.355 //layer=ply \
 //thickness=0.18 //x=6.235 //y=1.74 //x2=6.235 //y2=2.095
r296 (  89 114 ) resistor r=39.5823 //w=0.21 //l=0.173853 //layer=ply \
 //thickness=0.18 //x=6.235 //y=1.43 //x2=6.195 //y2=1.585
r297 (  88 113 ) resistor r=45.1352 //w=0.168 //l=0.173853 //layer=ply \
 //thickness=0.18 //x=6.235 //y=1.085 //x2=6.195 //y2=0.93
r298 (  88 89 ) resistor r=176.904 //w=0.094 //l=0.345 //layer=ply \
 //thickness=0.18 //x=6.235 //y=1.085 //x2=6.235 //y2=1.43
r299 (  85 118 ) resistor r=51.6429 //w=0.252 //l=0.34271 //layer=ply \
 //thickness=0.18 //x=6.14 //y=5.05 //x2=6.41 //y2=4.885
r300 (  83 112 ) resistor r=5.52526 //w=0.168 //l=0.115 //layer=ply \
 //thickness=0.18 //x=5.86 //y=1.585 //x2=5.745 //y2=1.585
r301 (  82 114 ) resistor r=10.701 //w=0.21 //l=0.115 //layer=ply \
 //thickness=0.18 //x=6.08 //y=1.585 //x2=6.195 //y2=1.585
r302 (  81 111 ) resistor r=5.52526 //w=0.168 //l=0.115 //layer=ply \
 //thickness=0.18 //x=5.86 //y=0.93 //x2=5.745 //y2=0.93
r303 (  80 113 ) resistor r=5.52526 //w=0.168 //l=0.115 //layer=ply \
 //thickness=0.18 //x=6.08 //y=0.93 //x2=6.195 //y2=0.93
r304 (  80 81 ) resistor r=112.809 //w=0.094 //l=0.22 //layer=ply \
 //thickness=0.18 //x=6.08 //y=0.93 //x2=5.86 //y2=0.93
r305 (  78 85 ) resistor r=22.1787 //w=0.252 //l=0.106066 //layer=ply \
 //thickness=0.18 //x=6.065 //y=4.975 //x2=6.14 //y2=5.05
r306 (  78 79 ) resistor r=148.702 //w=0.094 //l=0.29 //layer=ply \
 //thickness=0.18 //x=6.065 //y=4.975 //x2=5.775 //y2=4.975
r307 (  77 112 ) resistor r=45.1352 //w=0.168 //l=0.173853 //layer=ply \
 //thickness=0.18 //x=5.705 //y=1.43 //x2=5.745 //y2=1.585
r308 (  76 111 ) resistor r=45.1352 //w=0.168 //l=0.173853 //layer=ply \
 //thickness=0.18 //x=5.705 //y=1.085 //x2=5.745 //y2=0.93
r309 (  76 77 ) resistor r=176.904 //w=0.094 //l=0.345 //layer=ply \
 //thickness=0.18 //x=5.705 //y=1.085 //x2=5.705 //y2=1.43
r310 (  73 79 ) resistor r=26.9307 //w=0.15 //l=0.106066 //layer=ply \
 //thickness=0.18 //x=5.7 //y=5.05 //x2=5.775 //y2=4.975
r311 (  72 108 ) resistor r=592.245 //w=0.094 //l=1.155 //layer=ply \
 //thickness=0.18 //x=8.6 //y=6.205 //x2=8.6 //y2=5.05
r312 (  71 96 ) resistor r=592.245 //w=0.094 //l=1.155 //layer=ply \
 //thickness=0.18 //x=8.16 //y=6.205 //x2=8.16 //y2=5.05
r313 (  70 85 ) resistor r=592.245 //w=0.094 //l=1.155 //layer=ply \
 //thickness=0.18 //x=6.14 //y=6.205 //x2=6.14 //y2=5.05
r314 (  69 73 ) resistor r=592.245 //w=0.094 //l=1.155 //layer=ply \
 //thickness=0.18 //x=5.7 //y=6.205 //x2=5.7 //y2=5.05
r315 (  68 101 ) resistor r=56.4043 //w=0.094 //l=0.11 //layer=ply \
 //thickness=0.18 //x=8.33 //y=1.545 //x2=8.44 //y2=1.545
r316 (  68 102 ) resistor r=56.4043 //w=0.094 //l=0.11 //layer=ply \
 //thickness=0.18 //x=8.33 //y=1.545 //x2=8.22 //y2=1.545
r317 (  67 82 ) resistor r=56.4043 //w=0.094 //l=0.11 //layer=ply \
 //thickness=0.18 //x=5.97 //y=1.585 //x2=6.08 //y2=1.585
r318 (  67 83 ) resistor r=56.4043 //w=0.094 //l=0.11 //layer=ply \
 //thickness=0.18 //x=5.97 //y=1.585 //x2=5.86 //y2=1.585
r319 (  63 122 ) resistor r=152 //w=0.17 //l=0.17 //layer=licon //count=1 \
 //x=7.89 //y=4.885 //x2=7.89 //y2=4.885
r320 (  58 120 ) resistor r=152 //w=0.17 //l=0.17 //layer=licon //count=1 \
 //x=7.89 //y=2.26 //x2=7.89 //y2=2.26
r321 (  53 118 ) resistor r=152 //w=0.17 //l=0.17 //layer=licon //count=1 \
 //x=6.41 //y=4.885 //x2=6.41 //y2=4.885
r322 (  48 116 ) resistor r=152 //w=0.17 //l=0.17 //layer=licon //count=1 \
 //x=6.41 //y=2.26 //x2=6.41 //y2=2.26
r323 (  44 45 ) resistor r=0.10734 //w=0.281 //l=0.16 //layer=m2 \
 //thickness=0.36 //x=7.885 //y=2.27 //x2=7.725 //y2=2.27
r324 (  42 45 ) resistor r=1.09733 //w=0.131 //l=1.15 //layer=m2 \
 //thickness=0.36 //x=6.575 //y=2.26 //x2=7.725 //y2=2.26
r325 (  40 42 ) resistor r=0.10734 //w=0.281 //l=0.16 //layer=m2 \
 //thickness=0.36 //x=6.415 //y=2.27 //x2=6.575 //y2=2.27
r326 (  36 63 ) resistor r=9.3 //w=0.17 //l=0.17 //layer=mcon //count=1 \
 //x=7.89 //y=4.885 //x2=7.89 //y2=4.885
r327 (  34 44 ) resistor r=4.5 //w=0.15 //l=0.15 //layer=via1 //count=1 \
 //x=7.885 //y=2.27 //x2=7.885 //y2=2.27
r328 (  32 58 ) resistor r=9.3 //w=0.17 //l=0.17 //layer=mcon //count=1 \
 //x=7.89 //y=2.26 //x2=7.89 //y2=2.26
r329 (  32 34 ) resistor r=0.00334225 //w=0.374 //l=0.01 //layer=m1 \
 //thickness=0.36 //x=7.835 //y=2.26 //x2=7.835 //y2=2.27
r330 (  30 40 ) resistor r=4.5 //w=0.15 //l=0.15 //layer=via1 //count=1 \
 //x=6.415 //y=2.27 //x2=6.415 //y2=2.27
r331 (  28 48 ) resistor r=9.3 //w=0.17 //l=0.17 //layer=mcon //count=1 \
 //x=6.41 //y=2.26 //x2=6.41 //y2=2.26
r332 (  28 30 ) resistor r=0.00334225 //w=0.374 //l=0.01 //layer=m1 \
 //thickness=0.36 //x=6.465 //y=2.26 //x2=6.465 //y2=2.27
r333 (  26 53 ) resistor r=9.3 //w=0.17 //l=0.17 //layer=mcon //count=1 \
 //x=6.41 //y=4.885 //x2=6.41 //y2=4.885
r334 (  19 36 ) resistor r=0.0777782 //w=0.252 //l=0.131491 //layer=m1 \
 //thickness=0.36 //x=7.89 //y=4.755 //x2=7.887 //y2=4.885
r335 (  18 34 ) resistor r=0.0910802 //w=0.374 //l=0.185472 //layer=m1 \
 //thickness=0.36 //x=7.89 //y=2.43 //x2=7.835 //y2=2.27
r336 (  12 26 ) resistor r=0.075298 //w=0.252 //l=0.125 //layer=m1 \
 //thickness=0.36 //x=6.41 //y=4.76 //x2=6.41 //y2=4.885
r337 (  11 30 ) resistor r=0.0910802 //w=0.374 //l=0.185472 //layer=m1 \
 //thickness=0.36 //x=6.41 //y=2.43 //x2=6.465 //y2=2.27
r338 (  10 19 ) resistor r=0.128817 //w=0.131 //l=0.135 //layer=m1 \
 //thickness=0.36 //x=7.89 //y=4.62 //x2=7.89 //y2=4.755
r339 (  9 10 ) resistor r=0.706107 //w=0.131 //l=0.74 //layer=m1 \
 //thickness=0.36 //x=7.89 //y=3.88 //x2=7.89 //y2=4.62
r340 (  8 9 ) resistor r=0.353053 //w=0.131 //l=0.37 //layer=m1 \
 //thickness=0.36 //x=7.89 //y=3.51 //x2=7.89 //y2=3.88
r341 (  7 8 ) resistor r=0.353053 //w=0.131 //l=0.37 //layer=m1 \
 //thickness=0.36 //x=7.89 //y=3.14 //x2=7.89 //y2=3.51
r342 (  6 7 ) resistor r=0.353053 //w=0.131 //l=0.37 //layer=m1 \
 //thickness=0.36 //x=7.89 //y=2.77 //x2=7.89 //y2=3.14
r343 (  6 18 ) resistor r=0.324427 //w=0.131 //l=0.34 //layer=m1 \
 //thickness=0.36 //x=7.89 //y=2.77 //x2=7.89 //y2=2.43
r344 (  5 12 ) resistor r=0.133588 //w=0.131 //l=0.14 //layer=m1 \
 //thickness=0.36 //x=6.41 //y=4.62 //x2=6.41 //y2=4.76
r345 (  4 5 ) resistor r=0.706107 //w=0.131 //l=0.74 //layer=m1 \
 //thickness=0.36 //x=6.41 //y=3.88 //x2=6.41 //y2=4.62
r346 (  3 4 ) resistor r=0.353053 //w=0.131 //l=0.37 //layer=m1 \
 //thickness=0.36 //x=6.41 //y=3.51 //x2=6.41 //y2=3.88
r347 (  2 3 ) resistor r=0.353053 //w=0.131 //l=0.37 //layer=m1 \
 //thickness=0.36 //x=6.41 //y=3.14 //x2=6.41 //y2=3.51
r348 (  1 2 ) resistor r=0.353053 //w=0.131 //l=0.37 //layer=m1 \
 //thickness=0.36 //x=6.41 //y=2.77 //x2=6.41 //y2=3.14
r349 (  1 11 ) resistor r=0.324427 //w=0.131 //l=0.34 //layer=m1 \
 //thickness=0.36 //x=6.41 //y=2.77 //x2=6.41 //y2=2.43
ends PM_VOTERN3X1\%C

subckt PM_VOTERN3X1\%A ( 1 2 3 4 5 6 7 8 9 10 11 12 18 19 20 26 27 50 52 53 56 \
 65 70 79 83 84 85 86 87 88 89 90 91 96 98 100 106 107 108 109 110 115 117 119 \
 125 126 128 129 132 140 141 144 )
c284 ( 144 0 ) capacitor c=0.0370698f //x=9.02 //y=4.885
c285 ( 141 0 ) capacitor c=0.030265f //x=9 //y=2.095
c286 ( 140 0 ) capacitor c=0.0512002f //x=9 //y=2.26
c287 ( 132 0 ) capacitor c=0.0387879f //x=2.38 //y=4.885
c288 ( 129 0 ) capacitor c=0.0300885f //x=2.34 //y=2.095
c289 ( 128 0 ) capacitor c=0.0554483f //x=2.34 //y=2.26
c290 ( 126 0 ) capacitor c=0.0237734f //x=9.565 //y=1.435
c291 ( 125 0 ) capacitor c=0.0191782f //x=9.565 //y=1.085
c292 ( 119 0 ) capacitor c=0.0361171f //x=9.41 //y=1.585
c293 ( 117 0 ) capacitor c=0.0157803f //x=9.41 //y=0.93
c294 ( 115 0 ) capacitor c=0.0376354f //x=9.405 //y=4.975
c295 ( 110 0 ) capacitor c=0.020493f //x=9.035 //y=1.74
c296 ( 109 0 ) capacitor c=0.0167049f //x=9.035 //y=1.435
c297 ( 108 0 ) capacitor c=0.0174993f //x=9.035 //y=1.085
c298 ( 107 0 ) capacitor c=0.0443648f //x=2.905 //y=1.43
c299 ( 106 0 ) capacitor c=0.0192211f //x=2.905 //y=1.085
c300 ( 100 0 ) capacitor c=0.0186579f //x=2.75 //y=1.585
c301 ( 98 0 ) capacitor c=0.0157795f //x=2.75 //y=0.93
c302 ( 96 0 ) capacitor c=0.0351351f //x=2.745 //y=4.975
c303 ( 91 0 ) capacitor c=0.0209124f //x=2.375 //y=1.74
c304 ( 90 0 ) capacitor c=0.016848f //x=2.375 //y=1.43
c305 ( 89 0 ) capacitor c=0.0174777f //x=2.375 //y=1.085
c306 ( 88 0 ) capacitor c=0.155887f //x=9.48 //y=6.205
c307 ( 87 0 ) capacitor c=0.1106f //x=9.04 //y=6.205
c308 ( 86 0 ) capacitor c=0.154859f //x=2.82 //y=6.205
c309 ( 85 0 ) capacitor c=0.110573f //x=2.38 //y=6.205
c310 ( 79 0 ) capacitor c=8.10734e-19 //x=9.02 //y=4.885
c311 ( 70 0 ) capacitor c=0.00105273f //x=9 //y=2.26
c312 ( 65 0 ) capacitor c=0.00155312f //x=2.38 //y=4.885
c313 ( 56 0 ) capacitor c=0.00152737f //x=2.34 //y=2.26
c314 ( 53 0 ) capacitor c=0.208122f //x=8.855 //y=4.21
c315 ( 52 0 ) capacitor c=0.00479868f //x=9.015 //y=4.21
c316 ( 50 0 ) capacitor c=0.00579767f //x=2.5 //y=4.205
c317 ( 27 0 ) capacitor c=0.00541423f //x=9 //y=4.74
c318 ( 26 0 ) capacitor c=0.0110536f //x=9 //y=4.37
c319 ( 20 0 ) capacitor c=0.00651439f //x=9 //y=2.38
c320 ( 19 0 ) capacitor c=0.0189667f //x=2.34 //y=4.71
c321 ( 18 0 ) capacitor c=0.0126228f //x=2.34 //y=4.365
c322 ( 12 0 ) capacitor c=0.00920415f //x=2.34 //y=2.375
c323 ( 11 0 ) capacitor c=0.0148587f //x=9 //y=4.25
c324 ( 10 0 ) capacitor c=0.0153807f //x=2.34 //y=4.25
c325 ( 9 0 ) capacitor c=0.00702155f //x=9 //y=4.62
c326 ( 5 0 ) capacitor c=0.0499737f //x=9 //y=2.77
c327 ( 1 0 ) capacitor c=0.0685407f //x=2.34 //y=2.77
r328 (  146 147 ) resistor r=32.4568 //w=0.214 //l=0.075 //layer=ply \
 //thickness=0.18 //x=9.02 //y=4.975 //x2=9.02 //y2=5.05
r329 (  144 146 ) resistor r=20.271 //w=0.214 //l=0.09 //layer=ply \
 //thickness=0.18 //x=9.02 //y=4.885 //x2=9.02 //y2=4.975
r330 (  140 141 ) resistor r=52.7279 //w=0.214 //l=0.165 //layer=ply \
 //thickness=0.18 //x=9 //y=2.26 //x2=9 //y2=2.095
r331 (  132 134 ) resistor r=20.271 //w=0.214 //l=0.09 //layer=ply \
 //thickness=0.18 //x=2.38 //y=4.885 //x2=2.38 //y2=4.975
r332 (  128 129 ) resistor r=52.7279 //w=0.214 //l=0.165 //layer=ply \
 //thickness=0.18 //x=2.34 //y=2.26 //x2=2.34 //y2=2.095
r333 (  126 151 ) resistor r=4.95774 //w=0.164 //l=0.112 //layer=ply \
 //thickness=0.18 //x=9.565 //y=1.435 //x2=9.565 //y2=1.547
r334 (  125 150 ) resistor r=45.1352 //w=0.168 //l=0.173853 //layer=ply \
 //thickness=0.18 //x=9.565 //y=1.085 //x2=9.525 //y2=0.93
r335 (  125 126 ) resistor r=179.468 //w=0.094 //l=0.35 //layer=ply \
 //thickness=0.18 //x=9.565 //y=1.085 //x2=9.565 //y2=1.435
r336 (  120 149 ) resistor r=10.8103 //w=0.211 //l=0.115 //layer=ply \
 //thickness=0.18 //x=9.19 //y=1.585 //x2=9.075 //y2=1.585
r337 (  119 151 ) resistor r=45.9962 //w=0.164 //l=0.17296 //layer=ply \
 //thickness=0.18 //x=9.41 //y=1.585 //x2=9.565 //y2=1.547
r338 (  118 148 ) resistor r=5.52526 //w=0.168 //l=0.115 //layer=ply \
 //thickness=0.18 //x=9.19 //y=0.93 //x2=9.075 //y2=0.93
r339 (  117 150 ) resistor r=5.52526 //w=0.168 //l=0.115 //layer=ply \
 //thickness=0.18 //x=9.41 //y=0.93 //x2=9.525 //y2=0.93
r340 (  117 118 ) resistor r=112.809 //w=0.094 //l=0.22 //layer=ply \
 //thickness=0.18 //x=9.41 //y=0.93 //x2=9.19 //y2=0.93
r341 (  116 146 ) resistor r=16.5046 //w=0.27 //l=0.135 //layer=ply \
 //thickness=0.18 //x=9.155 //y=4.975 //x2=9.02 //y2=4.975
r342 (  115 122 ) resistor r=26.9307 //w=0.15 //l=0.106066 //layer=ply \
 //thickness=0.18 //x=9.405 //y=4.975 //x2=9.48 //y2=5.05
r343 (  115 116 ) resistor r=128.191 //w=0.094 //l=0.25 //layer=ply \
 //thickness=0.18 //x=9.405 //y=4.975 //x2=9.155 //y2=4.975
r344 (  110 149 ) resistor r=39.5036 //w=0.211 //l=0.173853 //layer=ply \
 //thickness=0.18 //x=9.035 //y=1.74 //x2=9.075 //y2=1.585
r345 (  110 141 ) resistor r=182.032 //w=0.094 //l=0.355 //layer=ply \
 //thickness=0.18 //x=9.035 //y=1.74 //x2=9.035 //y2=2.095
r346 (  109 149 ) resistor r=38.3614 //w=0.211 //l=0.168819 //layer=ply \
 //thickness=0.18 //x=9.035 //y=1.435 //x2=9.075 //y2=1.585
r347 (  108 148 ) resistor r=45.1352 //w=0.168 //l=0.173853 //layer=ply \
 //thickness=0.18 //x=9.035 //y=1.085 //x2=9.075 //y2=0.93
r348 (  108 109 ) resistor r=179.468 //w=0.094 //l=0.35 //layer=ply \
 //thickness=0.18 //x=9.035 //y=1.085 //x2=9.035 //y2=1.435
r349 (  107 138 ) resistor r=45.1352 //w=0.168 //l=0.173853 //layer=ply \
 //thickness=0.18 //x=2.905 //y=1.43 //x2=2.865 //y2=1.585
r350 (  106 137 ) resistor r=45.1352 //w=0.168 //l=0.173853 //layer=ply \
 //thickness=0.18 //x=2.905 //y=1.085 //x2=2.865 //y2=0.93
r351 (  106 107 ) resistor r=176.904 //w=0.094 //l=0.345 //layer=ply \
 //thickness=0.18 //x=2.905 //y=1.085 //x2=2.905 //y2=1.43
r352 (  101 136 ) resistor r=10.701 //w=0.21 //l=0.115 //layer=ply \
 //thickness=0.18 //x=2.53 //y=1.585 //x2=2.415 //y2=1.585
r353 (  100 138 ) resistor r=5.52526 //w=0.168 //l=0.115 //layer=ply \
 //thickness=0.18 //x=2.75 //y=1.585 //x2=2.865 //y2=1.585
r354 (  99 135 ) resistor r=5.52526 //w=0.168 //l=0.115 //layer=ply \
 //thickness=0.18 //x=2.53 //y=0.93 //x2=2.415 //y2=0.93
r355 (  98 137 ) resistor r=5.52526 //w=0.168 //l=0.115 //layer=ply \
 //thickness=0.18 //x=2.75 //y=0.93 //x2=2.865 //y2=0.93
r356 (  98 99 ) resistor r=112.809 //w=0.094 //l=0.22 //layer=ply \
 //thickness=0.18 //x=2.75 //y=0.93 //x2=2.53 //y2=0.93
r357 (  97 134 ) resistor r=16.5046 //w=0.27 //l=0.135 //layer=ply \
 //thickness=0.18 //x=2.515 //y=4.975 //x2=2.38 //y2=4.975
r358 (  96 103 ) resistor r=26.9307 //w=0.15 //l=0.106066 //layer=ply \
 //thickness=0.18 //x=2.745 //y=4.975 //x2=2.82 //y2=5.05
r359 (  96 97 ) resistor r=117.936 //w=0.094 //l=0.23 //layer=ply \
 //thickness=0.18 //x=2.745 //y=4.975 //x2=2.515 //y2=4.975
r360 (  93 134 ) resistor r=32.4568 //w=0.214 //l=0.075 //layer=ply \
 //thickness=0.18 //x=2.38 //y=5.05 //x2=2.38 //y2=4.975
r361 (  91 136 ) resistor r=39.5823 //w=0.21 //l=0.173853 //layer=ply \
 //thickness=0.18 //x=2.375 //y=1.74 //x2=2.415 //y2=1.585
r362 (  91 129 ) resistor r=182.032 //w=0.094 //l=0.355 //layer=ply \
 //thickness=0.18 //x=2.375 //y=1.74 //x2=2.375 //y2=2.095
r363 (  90 136 ) resistor r=39.5823 //w=0.21 //l=0.173853 //layer=ply \
 //thickness=0.18 //x=2.375 //y=1.43 //x2=2.415 //y2=1.585
r364 (  89 135 ) resistor r=45.1352 //w=0.168 //l=0.173853 //layer=ply \
 //thickness=0.18 //x=2.375 //y=1.085 //x2=2.415 //y2=0.93
r365 (  89 90 ) resistor r=176.904 //w=0.094 //l=0.345 //layer=ply \
 //thickness=0.18 //x=2.375 //y=1.085 //x2=2.375 //y2=1.43
r366 (  88 122 ) resistor r=592.245 //w=0.094 //l=1.155 //layer=ply \
 //thickness=0.18 //x=9.48 //y=6.205 //x2=9.48 //y2=5.05
r367 (  87 147 ) resistor r=592.245 //w=0.094 //l=1.155 //layer=ply \
 //thickness=0.18 //x=9.04 //y=6.205 //x2=9.04 //y2=5.05
r368 (  86 103 ) resistor r=592.245 //w=0.094 //l=1.155 //layer=ply \
 //thickness=0.18 //x=2.82 //y=6.205 //x2=2.82 //y2=5.05
r369 (  85 93 ) resistor r=592.245 //w=0.094 //l=1.155 //layer=ply \
 //thickness=0.18 //x=2.38 //y=6.205 //x2=2.38 //y2=5.05
r370 (  84 119 ) resistor r=56.4043 //w=0.094 //l=0.11 //layer=ply \
 //thickness=0.18 //x=9.3 //y=1.585 //x2=9.41 //y2=1.585
r371 (  84 120 ) resistor r=56.4043 //w=0.094 //l=0.11 //layer=ply \
 //thickness=0.18 //x=9.3 //y=1.585 //x2=9.19 //y2=1.585
r372 (  83 100 ) resistor r=56.4043 //w=0.094 //l=0.11 //layer=ply \
 //thickness=0.18 //x=2.64 //y=1.585 //x2=2.75 //y2=1.585
r373 (  83 101 ) resistor r=56.4043 //w=0.094 //l=0.11 //layer=ply \
 //thickness=0.18 //x=2.64 //y=1.585 //x2=2.53 //y2=1.585
r374 (  79 144 ) resistor r=152 //w=0.17 //l=0.17 //layer=licon //count=1 \
 //x=9.02 //y=4.885 //x2=9.02 //y2=4.885
r375 (  70 140 ) resistor r=152 //w=0.17 //l=0.17 //layer=licon //count=1 \
 //x=9 //y=2.26 //x2=9 //y2=2.26
r376 (  65 132 ) resistor r=152 //w=0.17 //l=0.17 //layer=licon //count=1 \
 //x=2.38 //y=4.885 //x2=2.38 //y2=4.885
r377 (  56 128 ) resistor r=152 //w=0.17 //l=0.17 //layer=licon //count=1 \
 //x=2.34 //y=2.26 //x2=2.34 //y2=2.26
r378 (  52 53 ) resistor r=0.104807 //w=0.281 //l=0.16 //layer=m2 \
 //thickness=0.36 //x=9.015 //y=4.21 //x2=8.855 //y2=4.21
r379 (  50 53 ) resistor r=5.84099 //w=0.136 //l=6.355 //layer=m2 \
 //thickness=0.36 //x=2.5 //y=4.252 //x2=8.855 //y2=4.252
r380 (  48 50 ) resistor r=0.104807 //w=0.281 //l=0.16 //layer=m2 \
 //thickness=0.36 //x=2.34 //y=4.205 //x2=2.5 //y2=4.205
r381 (  44 79 ) resistor r=9.3 //w=0.17 //l=0.17 //layer=mcon //count=1 \
 //x=9.02 //y=4.885 //x2=9.02 //y2=4.885
r382 (  42 70 ) resistor r=9.3 //w=0.17 //l=0.17 //layer=mcon //count=1 //x=9 \
 //y=2.26 //x2=9 //y2=2.26
r383 (  38 52 ) resistor r=4.5 //w=0.15 //l=0.15 //layer=via1 //count=1 \
 //x=9.015 //y=4.21 //x2=9.015 //y2=4.21
r384 (  34 48 ) resistor r=4.5 //w=0.15 //l=0.15 //layer=via1 //count=1 \
 //x=2.34 //y=4.205 //x2=2.34 //y2=4.205
r385 (  32 65 ) resistor r=9.3 //w=0.17 //l=0.17 //layer=mcon //count=1 \
 //x=2.38 //y=4.885 //x2=2.38 //y2=4.885
r386 (  30 56 ) resistor r=9.3 //w=0.17 //l=0.17 //layer=mcon //count=1 \
 //x=2.34 //y=2.26 //x2=2.34 //y2=2.26
r387 (  27 44 ) resistor r=0.0893515 //w=0.219 //l=0.154677 //layer=m1 \
 //thickness=0.36 //x=9 //y=4.74 //x2=9.02 //y2=4.885
r388 (  21 38 ) resistor r=0.0914932 //w=0.384 //l=0.181108 //layer=m1 \
 //thickness=0.36 //x=9 //y=4.05 //x2=8.955 //y2=4.21
r389 (  20 42 ) resistor r=0.0744285 //w=0.225 //l=0.12 //layer=m1 \
 //thickness=0.36 //x=9 //y=2.38 //x2=9 //y2=2.26
r390 (  19 32 ) resistor r=0.100665 //w=0.248 //l=0.193972 //layer=m1 \
 //thickness=0.36 //x=2.34 //y=4.71 //x2=2.38 //y2=4.885
r391 (  18 19 ) resistor r=0.329198 //w=0.131 //l=0.345 //layer=m1 \
 //thickness=0.36 //x=2.34 //y=4.365 //x2=2.34 //y2=4.71
r392 (  13 34 ) resistor r=0.0911593 //w=0.376 //l=0.184174 //layer=m1 \
 //thickness=0.36 //x=2.34 //y=4.045 //x2=2.392 //y2=4.205
r393 (  12 30 ) resistor r=0.0717383 //w=0.224 //l=0.115 //layer=m1 \
 //thickness=0.36 //x=2.34 //y=2.375 //x2=2.34 //y2=2.26
r394 (  11 26 ) resistor r=0.0784723 //w=0.384 //l=0.140712 //layer=m1 \
 //thickness=0.36 //x=8.955 //y=4.25 //x2=9 //y2=4.37
r395 (  11 38 ) resistor r=0.0130208 //w=0.384 //l=0.04 //layer=m1 \
 //thickness=0.36 //x=8.955 //y=4.25 //x2=8.955 //y2=4.21
r396 (  10 18 ) resistor r=0.0761992 //w=0.376 //l=0.138582 //layer=m1 \
 //thickness=0.36 //x=2.392 //y=4.25 //x2=2.34 //y2=4.365
r397 (  10 34 ) resistor r=0.0149601 //w=0.376 //l=0.045 //layer=m1 \
 //thickness=0.36 //x=2.392 //y=4.25 //x2=2.392 //y2=4.205
r398 (  9 27 ) resistor r=0.114504 //w=0.131 //l=0.12 //layer=m1 \
 //thickness=0.36 //x=9 //y=4.62 //x2=9 //y2=4.74
r399 (  9 26 ) resistor r=0.23855 //w=0.131 //l=0.25 //layer=m1 \
 //thickness=0.36 //x=9 //y=4.62 //x2=9 //y2=4.37
r400 (  8 21 ) resistor r=0.162214 //w=0.131 //l=0.17 //layer=m1 \
 //thickness=0.36 //x=9 //y=3.88 //x2=9 //y2=4.05
r401 (  7 8 ) resistor r=0.353053 //w=0.131 //l=0.37 //layer=m1 \
 //thickness=0.36 //x=9 //y=3.51 //x2=9 //y2=3.88
r402 (  6 7 ) resistor r=0.353053 //w=0.131 //l=0.37 //layer=m1 \
 //thickness=0.36 //x=9 //y=3.14 //x2=9 //y2=3.51
r403 (  5 6 ) resistor r=0.353053 //w=0.131 //l=0.37 //layer=m1 \
 //thickness=0.36 //x=9 //y=2.77 //x2=9 //y2=3.14
r404 (  5 20 ) resistor r=0.372137 //w=0.131 //l=0.39 //layer=m1 \
 //thickness=0.36 //x=9 //y=2.77 //x2=9 //y2=2.38
r405 (  4 13 ) resistor r=0.157443 //w=0.131 //l=0.165 //layer=m1 \
 //thickness=0.36 //x=2.34 //y=3.88 //x2=2.34 //y2=4.045
r406 (  3 4 ) resistor r=0.353053 //w=0.131 //l=0.37 //layer=m1 \
 //thickness=0.36 //x=2.34 //y=3.51 //x2=2.34 //y2=3.88
r407 (  2 3 ) resistor r=0.353053 //w=0.131 //l=0.37 //layer=m1 \
 //thickness=0.36 //x=2.34 //y=3.14 //x2=2.34 //y2=3.51
r408 (  1 2 ) resistor r=0.353053 //w=0.131 //l=0.37 //layer=m1 \
 //thickness=0.36 //x=2.34 //y=2.77 //x2=2.34 //y2=3.14
r409 (  1 12 ) resistor r=0.376908 //w=0.131 //l=0.395 //layer=m1 \
 //thickness=0.36 //x=2.34 //y=2.77 //x2=2.34 //y2=2.375
ends PM_VOTERN3X1\%A

subckt PM_VOTERN3X1\%YN ( 1 2 3 4 5 6 7 8 9 11 12 13 15 16 28 32 35 38 52 55 \
 56 58 59 68 76 93 94 95 99 100 )
c207 ( 95 0 ) capacitor c=0.009897f //x=9.11 //y=1.085
c208 ( 94 0 ) capacitor c=0.0108944f //x=5.78 //y=1.085
c209 ( 93 0 ) capacitor c=0.0110396f //x=2.45 //y=1.085
c210 ( 76 0 ) capacitor c=0.0265472f //x=9.26 //y=5.56
c211 ( 68 0 ) capacitor c=0.0232072f //x=8.38 //y=5.56
c212 ( 59 0 ) capacitor c=0.0866731f //x=9.135 //y=1.405
c213 ( 58 0 ) capacitor c=0.0257508f //x=9.295 //y=1.405
c214 ( 56 0 ) capacitor c=0.0121686f //x=6.1 //y=1.405
c215 ( 55 0 ) capacitor c=0.125391f //x=5.84 //y=1.405
c216 ( 52 0 ) capacitor c=0.00933361f //x=2.805 //y=1.405
c217 ( 38 0 ) capacitor c=0.01557f //x=9.257 //y=5.39
c218 ( 35 0 ) capacitor c=0.0155006f //x=8.38 //y=5.39
c219 ( 32 0 ) capacitor c=0.00887677f //x=5.97 //y=1.36
c220 ( 28 0 ) capacitor c=0.00728958f //x=2.64 //y=1.36
c221 ( 16 0 ) capacitor c=0.00834076f //x=9.385 //y=1.825
c222 ( 15 0 ) capacitor c=0.0162177f //x=9.655 //y=1.825
c223 ( 13 0 ) capacitor c=0.0128896f //x=9.655 //y=5.39
c224 ( 12 0 ) capacitor c=0.00871794f //x=9.3 //y=1.74
c225 ( 11 0 ) capacitor c=0.00698506f //x=9.3 //y=1.535
c226 ( 9 0 ) capacitor c=0.0116295f //x=9.135 //y=5.39
c227 ( 1 0 ) capacitor c=0.133093f //x=9.74 //y=2.4
r228 (  92 93 ) resistor r=13.3953 //w=0.172 //l=0.18 //layer=li \
 //thickness=0.1 //x=2.637 //y=1.36 //x2=2.637 //y2=1.18
r229 (  87 95 ) resistor r=12.3209 //w=0.187 //l=0.18 //layer=li \
 //thickness=0.1 //x=9.3 //y=1.36 //x2=9.3 //y2=1.18
r230 (  76 100 ) resistor r=23.2727 //w=0.187 //l=0.34 //layer=li \
 //thickness=0.1 //x=9.26 //y=5.56 //x2=9.26 //y2=5.9
r231 (  68 99 ) resistor r=23.2727 //w=0.187 //l=0.34 //layer=li \
 //thickness=0.1 //x=8.38 //y=5.56 //x2=8.38 //y2=5.9
r232 (  65 94 ) resistor r=12.3209 //w=0.187 //l=0.18 //layer=li \
 //thickness=0.1 //x=5.97 //y=1.36 //x2=5.97 //y2=1.18
r233 (  58 59 ) resistor r=0.10734 //w=0.281 //l=0.16 //layer=m2 \
 //thickness=0.36 //x=9.295 //y=1.405 //x2=9.135 //y2=1.405
r234 (  56 59 ) resistor r=2.89599 //w=0.131 //l=3.035 //layer=m2 \
 //thickness=0.36 //x=6.1 //y=1.36 //x2=9.135 //y2=1.36
r235 (  54 56 ) resistor r=0.0942778 //w=0.221 //l=0.13 //layer=m2 \
 //thickness=0.36 //x=5.97 //y=1.405 //x2=6.1 //y2=1.405
r236 (  54 55 ) resistor r=0.0942778 //w=0.221 //l=0.13 //layer=m2 \
 //thickness=0.36 //x=5.97 //y=1.405 //x2=5.84 //y2=1.405
r237 (  52 55 ) resistor r=2.89599 //w=0.131 //l=3.035 //layer=m2 \
 //thickness=0.36 //x=2.805 //y=1.36 //x2=5.84 //y2=1.36
r238 (  50 52 ) resistor r=0.10734 //w=0.281 //l=0.16 //layer=m2 \
 //thickness=0.36 //x=2.645 //y=1.405 //x2=2.805 //y2=1.405
r239 (  44 58 ) resistor r=4.5 //w=0.15 //l=0.15 //layer=via1 //count=1 \
 //x=9.295 //y=1.405 //x2=9.295 //y2=1.405
r240 (  42 87 ) resistor r=9.3 //w=0.17 //l=0.17 //layer=mcon //count=1 \
 //x=9.3 //y=1.36 //x2=9.3 //y2=1.36
r241 (  42 44 ) resistor r=0.0163043 //w=0.345 //l=0.045 //layer=m1 \
 //thickness=0.36 //x=9.24 //y=1.36 //x2=9.24 //y2=1.405
r242 (  40 76 ) resistor r=9.3 //w=0.17 //l=0.17 //layer=mcon //count=1 \
 //x=9.26 //y=5.56 //x2=9.26 //y2=5.56
r243 (  38 40 ) resistor r=0.0944444 //w=0.225 //l=0.17 //layer=m1 \
 //thickness=0.36 //x=9.257 //y=5.39 //x2=9.257 //y2=5.56
r244 (  37 68 ) resistor r=9.3 //w=0.17 //l=0.17 //layer=mcon //count=1 \
 //x=8.38 //y=5.56 //x2=8.38 //y2=5.56
r245 (  35 37 ) resistor r=0.0936123 //w=0.227 //l=0.17 //layer=m1 \
 //thickness=0.36 //x=8.38 //y=5.39 //x2=8.38 //y2=5.56
r246 (  34 54 ) resistor r=4.5 //w=0.15 //l=0.15 //layer=via1 //count=1 \
 //x=5.97 //y=1.405 //x2=5.97 //y2=1.405
r247 (  32 65 ) resistor r=9.3 //w=0.17 //l=0.17 //layer=mcon //count=1 \
 //x=5.97 //y=1.36 //x2=5.97 //y2=1.36
r248 (  32 34 ) resistor r=0.0163043 //w=0.345 //l=0.045 //layer=m1 \
 //thickness=0.36 //x=5.91 //y=1.36 //x2=5.91 //y2=1.405
r249 (  30 50 ) resistor r=4.5 //w=0.15 //l=0.15 //layer=via1 //count=1 \
 //x=2.645 //y=1.405 //x2=2.645 //y2=1.405
r250 (  28 92 ) resistor r=9.3 //w=0.17 //l=0.17 //layer=mcon //count=1 \
 //x=2.64 //y=1.36 //x2=2.64 //y2=1.36
r251 (  28 30 ) resistor r=0.0150401 //w=0.374 //l=0.045 //layer=m1 \
 //thickness=0.36 //x=2.695 //y=1.36 //x2=2.695 //y2=1.405
r252 (  15 17 ) resistor r=0.0698411 //w=0.17 //l=0.120208 //layer=m1 \
 //thickness=0.36 //x=9.655 //y=1.825 //x2=9.74 //y2=1.91
r253 (  15 16 ) resistor r=0.257634 //w=0.131 //l=0.27 //layer=m1 \
 //thickness=0.36 //x=9.655 //y=1.825 //x2=9.385 //y2=1.825
r254 (  14 38 ) resistor r=0.0243946 //w=0.225 //l=0.123 //layer=m1 \
 //thickness=0.36 //x=9.38 //y=5.39 //x2=9.257 //y2=5.39
r255 (  13 18 ) resistor r=0.0698411 //w=0.17 //l=0.120208 //layer=m1 \
 //thickness=0.36 //x=9.655 //y=5.39 //x2=9.74 //y2=5.305
r256 (  13 14 ) resistor r=0.262405 //w=0.131 //l=0.275 //layer=m1 \
 //thickness=0.36 //x=9.655 //y=5.39 //x2=9.38 //y2=5.39
r257 (  12 16 ) resistor r=0.0698411 //w=0.17 //l=0.120208 //layer=m1 \
 //thickness=0.36 //x=9.3 //y=1.74 //x2=9.385 //y2=1.825
r258 (  11 44 ) resistor r=0.0792909 //w=0.345 //l=0.157162 //layer=m1 \
 //thickness=0.36 //x=9.3 //y=1.535 //x2=9.24 //y2=1.405
r259 (  11 12 ) resistor r=0.195611 //w=0.131 //l=0.205 //layer=m1 \
 //thickness=0.36 //x=9.3 //y=1.535 //x2=9.3 //y2=1.74
r260 (  10 35 ) resistor r=0.0249239 //w=0.227 //l=0.125 //layer=m1 \
 //thickness=0.36 //x=8.505 //y=5.39 //x2=8.38 //y2=5.39
r261 (  9 38 ) resistor r=0.0243946 //w=0.225 //l=0.122 //layer=m1 \
 //thickness=0.36 //x=9.135 //y=5.39 //x2=9.257 //y2=5.39
r262 (  9 10 ) resistor r=0.601145 //w=0.131 //l=0.63 //layer=m1 \
 //thickness=0.36 //x=9.135 //y=5.39 //x2=8.505 //y2=5.39
r263 (  8 18 ) resistor r=0.300573 //w=0.131 //l=0.315 //layer=m1 \
 //thickness=0.36 //x=9.74 //y=4.99 //x2=9.74 //y2=5.305
r264 (  7 8 ) resistor r=0.353053 //w=0.131 //l=0.37 //layer=m1 \
 //thickness=0.36 //x=9.74 //y=4.62 //x2=9.74 //y2=4.99
r265 (  6 7 ) resistor r=0.353053 //w=0.131 //l=0.37 //layer=m1 \
 //thickness=0.36 //x=9.74 //y=4.25 //x2=9.74 //y2=4.62
r266 (  5 6 ) resistor r=0.353053 //w=0.131 //l=0.37 //layer=m1 \
 //thickness=0.36 //x=9.74 //y=3.88 //x2=9.74 //y2=4.25
r267 (  4 5 ) resistor r=0.353053 //w=0.131 //l=0.37 //layer=m1 \
 //thickness=0.36 //x=9.74 //y=3.51 //x2=9.74 //y2=3.88
r268 (  3 4 ) resistor r=0.353053 //w=0.131 //l=0.37 //layer=m1 \
 //thickness=0.36 //x=9.74 //y=3.14 //x2=9.74 //y2=3.51
r269 (  2 3 ) resistor r=0.353053 //w=0.131 //l=0.37 //layer=m1 \
 //thickness=0.36 //x=9.74 //y=2.77 //x2=9.74 //y2=3.14
r270 (  1 2 ) resistor r=0.353053 //w=0.131 //l=0.37 //layer=m1 \
 //thickness=0.36 //x=9.74 //y=2.4 //x2=9.74 //y2=2.77
r271 (  1 17 ) resistor r=0.467557 //w=0.131 //l=0.49 //layer=m1 \
 //thickness=0.36 //x=9.74 //y=2.4 //x2=9.74 //y2=1.91
ends PM_VOTERN3X1\%YN

subckt PM_VOTERN3X1\%VDD ( 1 4 5 6 8 9 10 14 15 29 32 45 48 80 95 98 99 100 \
 101 102 )
c190 ( 102 0 ) capacitor c=0.0424825f //x=2.895 //y=5.205
c191 ( 101 0 ) capacitor c=0.0224071f //x=2.015 //y=5.205
c192 ( 100 0 ) capacitor c=0.0512787f //x=1.145 //y=5.205
c193 ( 99 0 ) capacitor c=0.120833f //x=7.15 //y=7.585
c194 ( 98 0 ) capacitor c=0.126253f //x=3.82 //y=7.585
c195 ( 95 0 ) capacitor c=0.369119f //x=9.74 //y=7.58
c196 ( 80 0 ) capacitor c=0.131873f //x=6.98 //y=7.585
c197 ( 48 0 ) capacitor c=0.23158f //x=1.23 //y=7.58
c198 ( 45 0 ) capacitor c=0.133054f //x=3.65 //y=7.585
c199 ( 40 0 ) capacitor c=0.00499323f //x=3.04 //y=7.585
c200 ( 37 0 ) capacitor c=0.00499323f //x=2.16 //y=7.585
c201 ( 32 0 ) capacitor c=0.0700507f //x=1.23 //y=7.58
c202 ( 29 0 ) capacitor c=0.270843f //x=9.74 //y=7.58
c203 ( 15 0 ) capacitor c=0.00657976f //x=3.04 //y=7.41
c204 ( 14 0 ) capacitor c=0.00827249f //x=3.04 //y=7.035
c205 ( 10 0 ) capacitor c=0.0220779f //x=2.955 //y=7.585
c206 ( 9 0 ) capacitor c=0.00369726f //x=2.16 //y=7.41
c207 ( 8 0 ) capacitor c=0.00650208f //x=2.16 //y=7.035
c208 ( 6 0 ) capacitor c=0.02242f //x=2.075 //y=7.585
c209 ( 5 0 ) capacitor c=0.0090067f //x=1.28 //y=7.41
c210 ( 4 0 ) capacitor c=0.0125184f //x=1.28 //y=7.035
r211 (  93 95 ) resistor r=38.7139 //w=0.367 //l=1.11 //layer=li \
 //thickness=0.1 //x=8.63 //y=7.585 //x2=9.74 //y2=7.585
r212 (  91 93 ) resistor r=38.7139 //w=0.367 //l=1.11 //layer=li \
 //thickness=0.1 //x=7.52 //y=7.585 //x2=8.63 //y2=7.585
r213 (  89 99 ) resistor r=5.29055 //w=0.35 //l=0.17 //layer=li \
 //thickness=0.1 //x=7.32 //y=7.585 //x2=7.15 //y2=7.585
r214 (  89 91 ) resistor r=6.97548 //w=0.367 //l=0.2 //layer=li \
 //thickness=0.1 //x=7.32 //y=7.585 //x2=7.52 //y2=7.585
r215 (  83 85 ) resistor r=38.7139 //w=0.367 //l=1.11 //layer=li \
 //thickness=0.1 //x=4.93 //y=7.585 //x2=6.04 //y2=7.585
r216 (  81 98 ) resistor r=5.29055 //w=0.35 //l=0.17 //layer=li \
 //thickness=0.1 //x=3.99 //y=7.585 //x2=3.82 //y2=7.585
r217 (  81 83 ) resistor r=32.7847 //w=0.367 //l=0.94 //layer=li \
 //thickness=0.1 //x=3.99 //y=7.585 //x2=4.93 //y2=7.585
r218 (  80 99 ) resistor r=5.29055 //w=0.35 //l=0.17 //layer=li \
 //thickness=0.1 //x=6.98 //y=7.585 //x2=7.15 //y2=7.585
r219 (  80 85 ) resistor r=32.7847 //w=0.367 //l=0.94 //layer=li \
 //thickness=0.1 //x=6.98 //y=7.585 //x2=6.04 //y2=7.585
r220 (  76 102 ) resistor r=23.2727 //w=0.187 //l=0.34 //layer=li \
 //thickness=0.1 //x=3.04 //y=6.92 //x2=3.04 //y2=6.58
r221 (  61 100 ) resistor r=23.2727 //w=0.187 //l=0.34 //layer=li \
 //thickness=0.1 //x=1.28 //y=6.92 //x2=1.28 //y2=6.58
r222 (  50 52 ) resistor r=38.7139 //w=0.367 //l=1.11 //layer=li \
 //thickness=0.1 //x=2.34 //y=7.585 //x2=3.45 //y2=7.585
r223 (  48 50 ) resistor r=38.7139 //w=0.367 //l=1.11 //layer=li \
 //thickness=0.1 //x=1.23 //y=7.585 //x2=2.34 //y2=7.585
r224 (  45 98 ) resistor r=5.29055 //w=0.35 //l=0.17 //layer=li \
 //thickness=0.1 //x=3.65 //y=7.585 //x2=3.82 //y2=7.585
r225 (  45 52 ) resistor r=6.97548 //w=0.367 //l=0.2 //layer=li \
 //thickness=0.1 //x=3.65 //y=7.585 //x2=3.45 //y2=7.585
r226 (  42 76 ) resistor r=9.3 //w=0.17 //l=0.17 //layer=mcon //count=1 \
 //x=3.04 //y=6.92 //x2=3.04 //y2=6.92
r227 (  39 101 ) resistor r=9.3 //w=0.17 //l=0.17 //layer=mcon //count=1 \
 //x=2.16 //y=6.92 //x2=2.16 //y2=6.92
r228 (  36 61 ) resistor r=9.3 //w=0.17 //l=0.17 //layer=mcon //count=1 \
 //x=1.28 //y=6.92 //x2=1.28 //y2=6.92
r229 (  32 48 ) resistor r=3.1 //w=0.17 //l=0.51 //layer=mcon //count=3 \
 //x=1.23 //y=7.58 //x2=1.23 //y2=7.58
r230 (  29 95 ) resistor r=3.1 //w=0.17 //l=0.51 //layer=mcon //count=3 \
 //x=9.74 //y=7.58 //x2=9.74 //y2=7.58
r231 (  27 93 ) resistor r=3.1 //w=0.17 //l=0.51 //layer=mcon //count=3 \
 //x=8.63 //y=7.58 //x2=8.63 //y2=7.58
r232 (  27 29 ) resistor r=0.446141 //w=0.311 //l=1.11 //layer=m1 \
 //thickness=0.36 //x=8.63 //y=7.585 //x2=9.74 //y2=7.585
r233 (  25 91 ) resistor r=3.1 //w=0.17 //l=0.51 //layer=mcon //count=3 \
 //x=7.52 //y=7.58 //x2=7.52 //y2=7.58
r234 (  25 27 ) resistor r=0.446141 //w=0.311 //l=1.11 //layer=m1 \
 //thickness=0.36 //x=7.52 //y=7.585 //x2=8.63 //y2=7.585
r235 (  23 85 ) resistor r=3.1 //w=0.17 //l=0.51 //layer=mcon //count=3 \
 //x=6.04 //y=7.58 //x2=6.04 //y2=7.58
r236 (  23 25 ) resistor r=0.594855 //w=0.311 //l=1.48 //layer=m1 \
 //thickness=0.36 //x=6.04 //y=7.585 //x2=7.52 //y2=7.585
r237 (  20 83 ) resistor r=3.1 //w=0.17 //l=0.51 //layer=mcon //count=3 \
 //x=4.93 //y=7.58 //x2=4.93 //y2=7.58
r238 (  18 52 ) resistor r=3.1 //w=0.17 //l=0.51 //layer=mcon //count=3 \
 //x=3.45 //y=7.58 //x2=3.45 //y2=7.58
r239 (  18 20 ) resistor r=0.594855 //w=0.311 //l=1.48 //layer=m1 \
 //thickness=0.36 //x=3.45 //y=7.585 //x2=4.93 //y2=7.585
r240 (  16 40 ) resistor r=0.028033 //w=0.35 //l=0.085 //layer=m1 \
 //thickness=0.36 //x=3.125 //y=7.585 //x2=3.04 //y2=7.585
r241 (  16 18 ) resistor r=0.130627 //w=0.311 //l=0.325 //layer=m1 \
 //thickness=0.36 //x=3.125 //y=7.585 //x2=3.45 //y2=7.585
r242 (  15 40 ) resistor r=0.0413265 //w=0.7 //l=0.175 //layer=m1 \
 //thickness=0.36 //x=3.04 //y=7.41 //x2=3.04 //y2=7.585
r243 (  14 42 ) resistor r=0.0715665 //w=0.226 //l=0.115 //layer=m1 \
 //thickness=0.36 //x=3.04 //y=7.035 //x2=3.04 //y2=6.92
r244 (  14 15 ) resistor r=0.357824 //w=0.131 //l=0.375 //layer=m1 \
 //thickness=0.36 //x=3.04 //y=7.035 //x2=3.04 //y2=7.41
r245 (  13 50 ) resistor r=3.1 //w=0.17 //l=0.51 //layer=mcon //count=3 \
 //x=2.34 //y=7.58 //x2=2.34 //y2=7.58
r246 (  11 37 ) resistor r=0.028033 //w=0.35 //l=0.085 //layer=m1 \
 //thickness=0.36 //x=2.245 //y=7.585 //x2=2.16 //y2=7.585
r247 (  11 13 ) resistor r=0.0381833 //w=0.311 //l=0.095 //layer=m1 \
 //thickness=0.36 //x=2.245 //y=7.585 //x2=2.34 //y2=7.585
r248 (  10 40 ) resistor r=0.028033 //w=0.35 //l=0.085 //layer=m1 \
 //thickness=0.36 //x=2.955 //y=7.585 //x2=3.04 //y2=7.585
r249 (  10 13 ) resistor r=0.247186 //w=0.311 //l=0.615 //layer=m1 \
 //thickness=0.36 //x=2.955 //y=7.585 //x2=2.34 //y2=7.585
r250 (  9 37 ) resistor r=0.0413265 //w=0.7 //l=0.175 //layer=m1 \
 //thickness=0.36 //x=2.16 //y=7.41 //x2=2.16 //y2=7.585
r251 (  8 39 ) resistor r=0.0715665 //w=0.226 //l=0.117473 //layer=m1 \
 //thickness=0.36 //x=2.16 //y=7.035 //x2=2.165 //y2=6.92
r252 (  8 9 ) resistor r=0.357824 //w=0.131 //l=0.375 //layer=m1 \
 //thickness=0.36 //x=2.16 //y=7.035 //x2=2.16 //y2=7.41
r253 (  7 32 ) resistor r=0.028033 //w=0.35 //l=0.085 //layer=m1 \
 //thickness=0.36 //x=1.365 //y=7.585 //x2=1.28 //y2=7.585
r254 (  6 37 ) resistor r=0.028033 //w=0.35 //l=0.085 //layer=m1 \
 //thickness=0.36 //x=2.075 //y=7.585 //x2=2.16 //y2=7.585
r255 (  6 7 ) resistor r=0.28537 //w=0.311 //l=0.71 //layer=m1 \
 //thickness=0.36 //x=2.075 //y=7.585 //x2=1.365 //y2=7.585
r256 (  5 32 ) resistor r=0.0413265 //w=0.7 //l=0.175 //layer=m1 \
 //thickness=0.36 //x=1.28 //y=7.41 //x2=1.28 //y2=7.585
r257 (  4 36 ) resistor r=0.0712609 //w=0.23 //l=0.11649 //layer=m1 \
 //thickness=0.36 //x=1.28 //y=7.035 //x2=1.277 //y2=6.92
r258 (  4 5 ) resistor r=0.357824 //w=0.131 //l=0.375 //layer=m1 \
 //thickness=0.36 //x=1.28 //y=7.035 //x2=1.28 //y2=7.41
r259 (  1 23 ) resistor r=0.223071 //w=0.311 //l=0.555 //layer=m1 \
 //thickness=0.36 //x=5.485 //y=7.585 //x2=6.04 //y2=7.585
r260 (  1 20 ) resistor r=0.223071 //w=0.311 //l=0.555 //layer=m1 \
 //thickness=0.36 //x=5.485 //y=7.585 //x2=4.93 //y2=7.585
ends PM_VOTERN3X1\%VDD

subckt PM_VOTERN3X1\%noxref_6 ( 1 3 4 5 7 9 19 25 27 30 40 49 71 72 73 74 75 )
c165 ( 75 0 ) capacitor c=0.0354016f //x=6.215 //y=5.205
c166 ( 74 0 ) capacitor c=0.0241107f //x=5.335 //y=5.205
c167 ( 72 0 ) capacitor c=0.00544792f //x=2.455 //y=5.205
c168 ( 71 0 ) capacitor c=0.00516996f //x=1.575 //y=5.205
c169 ( 49 0 ) capacitor c=0.0509795f //x=4.6 //y=5.39
c170 ( 40 0 ) capacitor c=0.0363371f //x=2.6 //y=5.39
c171 ( 30 0 ) capacitor c=0.0294643f //x=1.72 //y=5.56
c172 ( 27 0 ) capacitor c=0.00984489f //x=6.36 //y=6.92
c173 ( 25 0 ) capacitor c=0.0059844f //x=5.477 //y=7.09
c174 ( 19 0 ) capacitor c=0.00975753f //x=4.6 //y=6.92
c175 ( 9 0 ) capacitor c=0.014892f //x=1.722 //y=5.39
c176 ( 7 0 ) capacitor c=0.00787288f //x=6.245 //y=7.09
c177 ( 5 0 ) capacitor c=0.00659042f //x=5.36 //y=7.09
c178 ( 4 0 ) capacitor c=0.00573286f //x=2.715 //y=5.39
c179 ( 3 0 ) capacitor c=0.0636102f //x=4.485 //y=5.39
c180 ( 1 0 ) capacitor c=0.0145996f //x=2.485 //y=5.39
r181 (  49 73 ) resistor r=58.1818 //w=0.187 //l=0.85 //layer=li \
 //thickness=0.1 //x=4.6 //y=5.39 //x2=4.6 //y2=6.24
r182 (  40 72 ) resistor r=58.1818 //w=0.187 //l=0.85 //layer=li \
 //thickness=0.1 //x=2.6 //y=5.39 //x2=2.6 //y2=6.24
r183 (  30 71 ) resistor r=23.2727 //w=0.187 //l=0.34 //layer=li \
 //thickness=0.1 //x=1.72 //y=5.56 //x2=1.72 //y2=5.9
r184 (  27 75 ) resistor r=9.3 //w=0.17 //l=0.17 //layer=mcon //count=1 \
 //x=6.36 //y=6.92 //x2=6.36 //y2=6.92
r185 (  27 28 ) resistor r=0.0988372 //w=0.215 //l=0.17 //layer=m1 \
 //thickness=0.36 //x=6.362 //y=6.92 //x2=6.362 //y2=7.09
r186 (  24 74 ) resistor r=9.3 //w=0.17 //l=0.17 //layer=mcon //count=1 \
 //x=5.48 //y=6.92 //x2=5.48 //y2=6.92
r187 (  24 25 ) resistor r=0.0940266 //w=0.226 //l=0.17 //layer=m1 \
 //thickness=0.36 //x=5.477 //y=6.92 //x2=5.477 //y2=7.09
r188 (  22 49 ) resistor r=9.3 //w=0.17 //l=0.17 //layer=mcon //count=1 \
 //x=4.6 //y=5.39 //x2=4.6 //y2=5.39
r189 (  19 73 ) resistor r=9.3 //w=0.17 //l=0.17 //layer=mcon //count=1 \
 //x=4.6 //y=6.92 //x2=4.6 //y2=6.92
r190 (  19 20 ) resistor r=0.0979263 //w=0.217 //l=0.17 //layer=m1 \
 //thickness=0.36 //x=4.602 //y=6.92 //x2=4.602 //y2=7.09
r191 (  15 40 ) resistor r=9.3 //w=0.17 //l=0.17 //layer=mcon //count=1 \
 //x=2.6 //y=5.39 //x2=2.6 //y2=5.39
r192 (  11 30 ) resistor r=9.3 //w=0.17 //l=0.17 //layer=mcon //count=1 \
 //x=1.72 //y=5.56 //x2=1.72 //y2=5.56
r193 (  9 11 ) resistor r=0.0944444 //w=0.225 //l=0.17 //layer=m1 \
 //thickness=0.36 //x=1.722 //y=5.39 //x2=1.722 //y2=5.56
r194 (  8 25 ) resistor r=0.0246599 //w=0.226 //l=0.118 //layer=m1 \
 //thickness=0.36 //x=5.595 //y=7.09 //x2=5.477 //y2=7.09
r195 (  7 28 ) resistor r=0.0216707 //w=0.215 //l=0.117 //layer=m1 \
 //thickness=0.36 //x=6.245 //y=7.09 //x2=6.362 //y2=7.09
r196 (  7 8 ) resistor r=0.620229 //w=0.131 //l=0.65 //layer=m1 \
 //thickness=0.36 //x=6.245 //y=7.09 //x2=5.595 //y2=7.09
r197 (  6 20 ) resistor r=0.0222262 //w=0.217 //l=0.118 //layer=m1 \
 //thickness=0.36 //x=4.72 //y=7.09 //x2=4.602 //y2=7.09
r198 (  5 25 ) resistor r=0.0246599 //w=0.226 //l=0.117 //layer=m1 \
 //thickness=0.36 //x=5.36 //y=7.09 //x2=5.477 //y2=7.09
r199 (  5 6 ) resistor r=0.610687 //w=0.131 //l=0.64 //layer=m1 \
 //thickness=0.36 //x=5.36 //y=7.09 //x2=4.72 //y2=7.09
r200 (  4 15 ) resistor r=0.0880901 //w=0.191 //l=0.115 //layer=m1 \
 //thickness=0.36 //x=2.715 //y=5.39 //x2=2.6 //y2=5.39
r201 (  3 22 ) resistor r=0.0717383 //w=0.224 //l=0.115 //layer=m1 \
 //thickness=0.36 //x=4.485 //y=5.39 //x2=4.6 //y2=5.39
r202 (  3 4 ) resistor r=1.68893 //w=0.131 //l=1.77 //layer=m1 \
 //thickness=0.36 //x=4.485 //y=5.39 //x2=2.715 //y2=5.39
r203 (  2 9 ) resistor r=0.0243946 //w=0.225 //l=0.123 //layer=m1 \
 //thickness=0.36 //x=1.845 //y=5.39 //x2=1.722 //y2=5.39
r204 (  1 15 ) resistor r=0.0880901 //w=0.191 //l=0.115 //layer=m1 \
 //thickness=0.36 //x=2.485 //y=5.39 //x2=2.6 //y2=5.39
r205 (  1 2 ) resistor r=0.610687 //w=0.131 //l=0.64 //layer=m1 \
 //thickness=0.36 //x=2.485 //y=5.39 //x2=1.845 //y2=5.39
ends PM_VOTERN3X1\%noxref_6

subckt PM_VOTERN3X1\%noxref_7 ( 1 3 4 5 7 9 15 21 23 26 34 40 62 63 64 65 66 )
c126 ( 66 0 ) capacitor c=0.0346626f //x=9.555 //y=5.205
c127 ( 65 0 ) capacitor c=0.0239063f //x=8.675 //y=5.205
c128 ( 40 0 ) capacitor c=0.0496943f //x=7.94 //y=5.39
c129 ( 34 0 ) capacitor c=0.0324071f //x=5.92 //y=5.39
c130 ( 26 0 ) capacitor c=0.0224248f //x=5.04 //y=5.56
c131 ( 23 0 ) capacitor c=0.0159821f //x=9.7 //y=6.92
c132 ( 21 0 ) capacitor c=0.00566376f //x=8.82 //y=7.09
c133 ( 15 0 ) capacitor c=0.00945187f //x=7.94 //y=6.92
c134 ( 9 0 ) capacitor c=0.0152859f //x=5.04 //y=5.39
c135 ( 7 0 ) capacitor c=0.0068287f //x=9.57 //y=7.09
c136 ( 5 0 ) capacitor c=0.00878908f //x=8.705 //y=7.09
c137 ( 4 0 ) capacitor c=0.00709931f //x=6.035 //y=5.39
c138 ( 3 0 ) capacitor c=0.0577233f //x=7.825 //y=5.39
c139 ( 1 0 ) capacitor c=0.018311f //x=5.805 //y=5.39
r140 (  40 64 ) resistor r=58.1818 //w=0.187 //l=0.85 //layer=li \
 //thickness=0.1 //x=7.94 //y=5.39 //x2=7.94 //y2=6.24
r141 (  34 63 ) resistor r=58.1818 //w=0.187 //l=0.85 //layer=li \
 //thickness=0.1 //x=5.92 //y=5.39 //x2=5.92 //y2=6.24
r142 (  26 62 ) resistor r=23.2727 //w=0.187 //l=0.34 //layer=li \
 //thickness=0.1 //x=5.04 //y=5.56 //x2=5.04 //y2=5.9
r143 (  23 66 ) resistor r=9.3 //w=0.17 //l=0.17 //layer=mcon //count=1 \
 //x=9.7 //y=6.92 //x2=9.7 //y2=6.92
r144 (  23 24 ) resistor r=0.0923913 //w=0.23 //l=0.17 //layer=m1 \
 //thickness=0.36 //x=9.695 //y=6.92 //x2=9.695 //y2=7.09
r145 (  20 65 ) resistor r=9.3 //w=0.17 //l=0.17 //layer=mcon //count=1 \
 //x=8.82 //y=6.92 //x2=8.82 //y2=6.92
r146 (  20 21 ) resistor r=0.0957207 //w=0.222 //l=0.17 //layer=m1 \
 //thickness=0.36 //x=8.82 //y=6.92 //x2=8.82 //y2=7.09
r147 (  18 40 ) resistor r=9.3 //w=0.17 //l=0.17 //layer=mcon //count=1 \
 //x=7.94 //y=5.39 //x2=7.94 //y2=5.39
r148 (  15 64 ) resistor r=9.3 //w=0.17 //l=0.17 //layer=mcon //count=1 \
 //x=7.94 //y=6.92 //x2=7.94 //y2=6.92
r149 (  15 16 ) resistor r=0.100236 //w=0.212 //l=0.17 //layer=m1 \
 //thickness=0.36 //x=7.94 //y=6.92 //x2=7.94 //y2=7.09
r150 (  13 34 ) resistor r=9.3 //w=0.17 //l=0.17 //layer=mcon //count=1 \
 //x=5.92 //y=5.39 //x2=5.92 //y2=5.39
r151 (  11 26 ) resistor r=9.3 //w=0.17 //l=0.17 //layer=mcon //count=1 \
 //x=5.04 //y=5.56 //x2=5.04 //y2=5.56
r152 (  9 11 ) resistor r=0.100236 //w=0.212 //l=0.17 //layer=m1 \
 //thickness=0.36 //x=5.04 //y=5.39 //x2=5.04 //y2=5.56
r153 (  8 21 ) resistor r=0.0235912 //w=0.222 //l=0.115 //layer=m1 \
 //thickness=0.36 //x=8.935 //y=7.09 //x2=8.82 //y2=7.09
r154 (  7 24 ) resistor r=0.0257089 //w=0.23 //l=0.125 //layer=m1 \
 //thickness=0.36 //x=9.57 //y=7.09 //x2=9.695 //y2=7.09
r155 (  7 8 ) resistor r=0.605916 //w=0.131 //l=0.635 //layer=m1 \
 //thickness=0.36 //x=9.57 //y=7.09 //x2=8.935 //y2=7.09
r156 (  6 16 ) resistor r=0.0208269 //w=0.212 //l=0.115 //layer=m1 \
 //thickness=0.36 //x=8.055 //y=7.09 //x2=7.94 //y2=7.09
r157 (  5 21 ) resistor r=0.0235912 //w=0.222 //l=0.115 //layer=m1 \
 //thickness=0.36 //x=8.705 //y=7.09 //x2=8.82 //y2=7.09
r158 (  5 6 ) resistor r=0.620229 //w=0.131 //l=0.65 //layer=m1 \
 //thickness=0.36 //x=8.705 //y=7.09 //x2=8.055 //y2=7.09
r159 (  4 13 ) resistor r=0.0880901 //w=0.191 //l=0.115 //layer=m1 \
 //thickness=0.36 //x=6.035 //y=5.39 //x2=5.92 //y2=5.39
r160 (  3 18 ) resistor r=0.0717383 //w=0.224 //l=0.115 //layer=m1 \
 //thickness=0.36 //x=7.825 //y=5.39 //x2=7.94 //y2=5.39
r161 (  3 4 ) resistor r=1.70802 //w=0.131 //l=1.79 //layer=m1 \
 //thickness=0.36 //x=7.825 //y=5.39 //x2=6.035 //y2=5.39
r162 (  2 9 ) resistor r=0.0208269 //w=0.212 //l=0.115 //layer=m1 \
 //thickness=0.36 //x=5.155 //y=5.39 //x2=5.04 //y2=5.39
r163 (  1 13 ) resistor r=0.0880901 //w=0.191 //l=0.115 //layer=m1 \
 //thickness=0.36 //x=5.805 //y=5.39 //x2=5.92 //y2=5.39
r164 (  1 2 ) resistor r=0.620229 //w=0.131 //l=0.65 //layer=m1 \
 //thickness=0.36 //x=5.805 //y=5.39 //x2=5.155 //y2=5.39
ends PM_VOTERN3X1\%noxref_7

subckt PM_VOTERN3X1\%GND ( 1 2 7 8 15 16 24 29 43 46 58 78 86 87 88 89 90 )
c204 ( 90 0 ) capacitor c=0.00828027f //x=8.14 //y=1.045
c205 ( 89 0 ) capacitor c=0.00867576f //x=4.81 //y=1.045
c206 ( 88 0 ) capacitor c=0.0083251f //x=1.48 //y=1.045
c207 ( 87 0 ) capacitor c=0.110294f //x=7.15 //y=0.175
c208 ( 86 0 ) capacitor c=0.124285f //x=3.82 //y=0.175
c209 ( 78 0 ) capacitor c=0.331202f //x=9.74 //y=0.18
c210 ( 58 0 ) capacitor c=0.118812f //x=6.98 //y=0.175
c211 ( 46 0 ) capacitor c=0.199174f //x=1.23 //y=0.18
c212 ( 43 0 ) capacitor c=0.122869f //x=3.65 //y=0.175
c213 ( 38 0 ) capacitor c=0.00509083f //x=8.33 //y=0.175
c214 ( 35 0 ) capacitor c=0.00510068f //x=4.93 //y=0.18
c215 ( 31 0 ) capacitor c=0.00509083f //x=1.67 //y=0.175
c216 ( 29 0 ) capacitor c=0.102594f //x=9.74 //y=0.18
c217 ( 24 0 ) capacitor c=0.0371563f //x=8.33 //y=1.02
c218 ( 16 0 ) capacitor c=0.107366f //x=8.245 //y=0.175
c219 ( 15 0 ) capacitor c=0.0274205f //x=5 //y=1.015
c220 ( 8 0 ) capacitor c=0.112424f //x=4.915 //y=0.175
c221 ( 7 0 ) capacitor c=0.0375179f //x=1.67 //y=1.015
c222 ( 2 0 ) capacitor c=0.0754302f //x=1.585 //y=0.175
r223 (  76 78 ) resistor r=38.7139 //w=0.367 //l=1.11 //layer=li \
 //thickness=0.1 //x=8.63 //y=0.175 //x2=9.74 //y2=0.175
r224 (  74 76 ) resistor r=38.7139 //w=0.367 //l=1.11 //layer=li \
 //thickness=0.1 //x=7.52 //y=0.175 //x2=8.63 //y2=0.175
r225 (  72 87 ) resistor r=5.29055 //w=0.35 //l=0.17 //layer=li \
 //thickness=0.1 //x=7.32 //y=0.175 //x2=7.15 //y2=0.175
r226 (  72 74 ) resistor r=6.97548 //w=0.367 //l=0.2 //layer=li \
 //thickness=0.1 //x=7.32 //y=0.175 //x2=7.52 //y2=0.175
r227 (  61 63 ) resistor r=38.7139 //w=0.367 //l=1.11 //layer=li \
 //thickness=0.1 //x=4.93 //y=0.175 //x2=6.04 //y2=0.175
r228 (  59 86 ) resistor r=5.29055 //w=0.35 //l=0.17 //layer=li \
 //thickness=0.1 //x=3.99 //y=0.175 //x2=3.82 //y2=0.175
r229 (  59 61 ) resistor r=32.7847 //w=0.367 //l=0.94 //layer=li \
 //thickness=0.1 //x=3.99 //y=0.175 //x2=4.93 //y2=0.175
r230 (  58 87 ) resistor r=5.29055 //w=0.35 //l=0.17 //layer=li \
 //thickness=0.1 //x=6.98 //y=0.175 //x2=7.15 //y2=0.175
r231 (  58 63 ) resistor r=32.7847 //w=0.367 //l=0.94 //layer=li \
 //thickness=0.1 //x=6.98 //y=0.175 //x2=6.04 //y2=0.175
r232 (  48 50 ) resistor r=38.7139 //w=0.367 //l=1.11 //layer=li \
 //thickness=0.1 //x=2.34 //y=0.175 //x2=3.45 //y2=0.175
r233 (  46 48 ) resistor r=38.7139 //w=0.367 //l=1.11 //layer=li \
 //thickness=0.1 //x=1.23 //y=0.175 //x2=2.34 //y2=0.175
r234 (  43 86 ) resistor r=5.29055 //w=0.35 //l=0.17 //layer=li \
 //thickness=0.1 //x=3.65 //y=0.175 //x2=3.82 //y2=0.175
r235 (  43 50 ) resistor r=6.97548 //w=0.367 //l=0.2 //layer=li \
 //thickness=0.1 //x=3.65 //y=0.175 //x2=3.45 //y2=0.175
r236 (  40 90 ) resistor r=9.3 //w=0.17 //l=0.17 //layer=mcon //count=1 \
 //x=8.33 //y=1.135 //x2=8.33 //y2=1.135
r237 (  37 89 ) resistor r=9.3 //w=0.17 //l=0.17 //layer=mcon //count=1 //x=5 \
 //y=1.135 //x2=5 //y2=1.135
r238 (  35 61 ) resistor r=3.1 //w=0.17 //l=0.51 //layer=mcon //count=3 \
 //x=4.93 //y=0.18 //x2=4.93 //y2=0.18
r239 (  33 88 ) resistor r=9.3 //w=0.17 //l=0.17 //layer=mcon //count=1 \
 //x=1.67 //y=1.135 //x2=1.67 //y2=1.135
r240 (  29 78 ) resistor r=3.1 //w=0.17 //l=0.51 //layer=mcon //count=3 \
 //x=9.74 //y=0.18 //x2=9.74 //y2=0.18
r241 (  27 76 ) resistor r=3.1 //w=0.17 //l=0.51 //layer=mcon //count=3 \
 //x=8.63 //y=0.18 //x2=8.63 //y2=0.18
r242 (  27 29 ) resistor r=0.446141 //w=0.311 //l=1.11 //layer=m1 \
 //thickness=0.36 //x=8.63 //y=0.175 //x2=9.74 //y2=0.175
r243 (  25 38 ) resistor r=0.028033 //w=0.35 //l=0.085 //layer=m1 \
 //thickness=0.36 //x=8.415 //y=0.175 //x2=8.33 //y2=0.175
r244 (  25 27 ) resistor r=0.0864148 //w=0.311 //l=0.215 //layer=m1 \
 //thickness=0.36 //x=8.415 //y=0.175 //x2=8.63 //y2=0.175
r245 (  24 40 ) resistor r=0.0703067 //w=0.254 //l=0.11649 //layer=m1 \
 //thickness=0.36 //x=8.33 //y=1.02 //x2=8.327 //y2=1.135
r246 (  23 38 ) resistor r=0.0413265 //w=0.7 //l=0.175 //layer=m1 \
 //thickness=0.36 //x=8.33 //y=0.35 //x2=8.33 //y2=0.175
r247 (  23 24 ) resistor r=0.639313 //w=0.131 //l=0.67 //layer=m1 \
 //thickness=0.36 //x=8.33 //y=0.35 //x2=8.33 //y2=1.02
r248 (  22 74 ) resistor r=3.1 //w=0.17 //l=0.51 //layer=mcon //count=3 \
 //x=7.52 //y=0.18 //x2=7.52 //y2=0.18
r249 (  20 63 ) resistor r=3.1 //w=0.17 //l=0.51 //layer=mcon //count=3 \
 //x=6.04 //y=0.18 //x2=6.04 //y2=0.18
r250 (  20 22 ) resistor r=0.594855 //w=0.311 //l=1.48 //layer=m1 \
 //thickness=0.36 //x=6.04 //y=0.175 //x2=7.52 //y2=0.175
r251 (  17 35 ) resistor r=0.028033 //w=0.35 //l=0.085 //layer=m1 \
 //thickness=0.36 //x=5.085 //y=0.175 //x2=5 //y2=0.175
r252 (  16 38 ) resistor r=0.028033 //w=0.35 //l=0.085 //layer=m1 \
 //thickness=0.36 //x=8.245 //y=0.175 //x2=8.33 //y2=0.175
r253 (  16 22 ) resistor r=0.291399 //w=0.311 //l=0.725 //layer=m1 \
 //thickness=0.36 //x=8.245 //y=0.175 //x2=7.52 //y2=0.175
r254 (  15 37 ) resistor r=0.0738201 //w=0.232 //l=0.121491 //layer=m1 \
 //thickness=0.36 //x=5 //y=1.015 //x2=4.997 //y2=1.135
r255 (  14 35 ) resistor r=0.0413265 //w=0.7 //l=0.175 //layer=m1 \
 //thickness=0.36 //x=5 //y=0.35 //x2=5 //y2=0.175
r256 (  14 15 ) resistor r=0.634542 //w=0.131 //l=0.665 //layer=m1 \
 //thickness=0.36 //x=5 //y=0.35 //x2=5 //y2=1.015
r257 (  13 50 ) resistor r=3.1 //w=0.17 //l=0.51 //layer=mcon //count=3 \
 //x=3.45 //y=0.18 //x2=3.45 //y2=0.18
r258 (  11 48 ) resistor r=3.1 //w=0.17 //l=0.51 //layer=mcon //count=3 \
 //x=2.34 //y=0.18 //x2=2.34 //y2=0.18
r259 (  11 13 ) resistor r=0.446141 //w=0.311 //l=1.11 //layer=m1 \
 //thickness=0.36 //x=2.34 //y=0.175 //x2=3.45 //y2=0.175
r260 (  9 31 ) resistor r=0.028033 //w=0.35 //l=0.085 //layer=m1 \
 //thickness=0.36 //x=1.755 //y=0.175 //x2=1.67 //y2=0.175
r261 (  9 11 ) resistor r=0.235129 //w=0.311 //l=0.585 //layer=m1 \
 //thickness=0.36 //x=1.755 //y=0.175 //x2=2.34 //y2=0.175
r262 (  8 35 ) resistor r=0.028033 //w=0.35 //l=0.085 //layer=m1 \
 //thickness=0.36 //x=4.915 //y=0.175 //x2=5 //y2=0.175
r263 (  8 13 ) resistor r=0.588826 //w=0.311 //l=1.465 //layer=m1 \
 //thickness=0.36 //x=4.915 //y=0.175 //x2=3.45 //y2=0.175
r264 (  7 33 ) resistor r=0.0729089 //w=0.249 //l=0.120996 //layer=m1 \
 //thickness=0.36 //x=1.67 //y=1.015 //x2=1.672 //y2=1.135
r265 (  6 31 ) resistor r=0.0413265 //w=0.7 //l=0.175 //layer=m1 \
 //thickness=0.36 //x=1.67 //y=0.35 //x2=1.67 //y2=0.175
r266 (  6 7 ) resistor r=0.634542 //w=0.131 //l=0.665 //layer=m1 \
 //thickness=0.36 //x=1.67 //y=0.35 //x2=1.67 //y2=1.015
r267 (  4 46 ) resistor r=3.1 //w=0.17 //l=0.51 //layer=mcon //count=3 \
 //x=1.23 //y=0.18 //x2=1.23 //y2=0.18
r268 (  2 31 ) resistor r=0.028033 //w=0.35 //l=0.085 //layer=m1 \
 //thickness=0.36 //x=1.585 //y=0.175 //x2=1.67 //y2=0.175
r269 (  2 4 ) resistor r=0.142685 //w=0.311 //l=0.355 //layer=m1 \
 //thickness=0.36 //x=1.585 //y=0.175 //x2=1.23 //y2=0.175
r270 (  1 20 ) resistor r=0.223071 //w=0.311 //l=0.555 //layer=m1 \
 //thickness=0.36 //x=5.485 //y=0.175 //x2=6.04 //y2=0.175
r271 (  1 17 ) resistor r=0.160772 //w=0.311 //l=0.4 //layer=m1 \
 //thickness=0.36 //x=5.485 //y=0.175 //x2=5.085 //y2=0.175
ends PM_VOTERN3X1\%GND

subckt PM_VOTERN3X1\%noxref_9 ( 1 5 9 10 13 17 29 )
c65 ( 29 0 ) capacitor c=0.0782322f //x=1.05 //y=0.545
c66 ( 17 0 ) capacitor c=0.00678917f //x=3.125 //y=0.795
c67 ( 13 0 ) capacitor c=0.0154169f //x=3.04 //y=0.71
c68 ( 10 0 ) capacitor c=0.00990031f //x=2.155 //y=1.675
c69 ( 9 0 ) capacitor c=0.00770028f //x=2.155 //y=0.795
c70 ( 5 0 ) capacitor c=0.028994f //x=2.07 //y=1.76
c71 ( 1 0 ) capacitor c=0.0049595f //x=1.185 //y=1.675
r72 (  17 29 ) resistor r=3.57586 //w=0.17 //l=0.125 //layer=li \
 //thickness=0.1 //x=3.125 //y=0.795 //x2=3.125 //y2=0.67
r73 (  17 29 ) resistor r=41.4118 //w=0.187 //l=0.605 //layer=li \
 //thickness=0.1 //x=3.125 //y=0.795 //x2=3.125 //y2=1.4
r74 (  14 29 ) resistor r=3.57586 //w=0.17 //l=0.103078 //layer=li \
 //thickness=0.1 //x=2.24 //y=0.71 //x2=2.155 //y2=0.67
r75 (  14 29 ) resistor r=27.0374 //w=0.187 //l=0.395 //layer=li \
 //thickness=0.1 //x=2.24 //y=0.71 //x2=2.635 //y2=0.71
r76 (  13 29 ) resistor r=3.57586 //w=0.17 //l=0.103078 //layer=li \
 //thickness=0.1 //x=3.04 //y=0.71 //x2=3.125 //y2=0.67
r77 (  13 29 ) resistor r=27.7219 //w=0.187 //l=0.405 //layer=li \
 //thickness=0.1 //x=3.04 //y=0.71 //x2=2.635 //y2=0.71
r78 (  10 29 ) resistor r=3.57586 //w=0.17 //l=0.125 //layer=li \
 //thickness=0.1 //x=2.155 //y=1.675 //x2=2.155 //y2=1.8
r79 (  10 29 ) resistor r=42.0963 //w=0.187 //l=0.615 //layer=li \
 //thickness=0.1 //x=2.155 //y=1.675 //x2=2.155 //y2=1.06
r80 (  9 29 ) resistor r=3.57586 //w=0.17 //l=0.125 //layer=li //thickness=0.1 \
 //x=2.155 //y=0.795 //x2=2.155 //y2=0.67
r81 (  9 29 ) resistor r=18.139 //w=0.187 //l=0.265 //layer=li //thickness=0.1 \
 //x=2.155 //y=0.795 //x2=2.155 //y2=1.06
r82 (  6 29 ) resistor r=3.57586 //w=0.17 //l=0.103078 //layer=li \
 //thickness=0.1 //x=1.27 //y=1.76 //x2=1.185 //y2=1.8
r83 (  6 29 ) resistor r=27.3797 //w=0.187 //l=0.4 //layer=li //thickness=0.1 \
 //x=1.27 //y=1.76 //x2=1.67 //y2=1.76
r84 (  5 29 ) resistor r=3.57586 //w=0.17 //l=0.103078 //layer=li \
 //thickness=0.1 //x=2.07 //y=1.76 //x2=2.155 //y2=1.8
r85 (  5 29 ) resistor r=27.3797 //w=0.187 //l=0.4 //layer=li //thickness=0.1 \
 //x=2.07 //y=1.76 //x2=1.67 //y2=1.76
r86 (  1 29 ) resistor r=3.57586 //w=0.17 //l=0.125 //layer=li //thickness=0.1 \
 //x=1.185 //y=1.675 //x2=1.185 //y2=1.8
r87 (  1 29 ) resistor r=42.0963 //w=0.187 //l=0.615 //layer=li \
 //thickness=0.1 //x=1.185 //y=1.675 //x2=1.185 //y2=1.06
ends PM_VOTERN3X1\%noxref_9

subckt PM_VOTERN3X1\%noxref_10 ( 1 5 9 10 13 17 29 )
c66 ( 29 0 ) capacitor c=0.0738284f //x=4.38 //y=0.545
c67 ( 17 0 ) capacitor c=0.00678917f //x=6.455 //y=0.795
c68 ( 13 0 ) capacitor c=0.0158009f //x=6.37 //y=0.71
c69 ( 10 0 ) capacitor c=0.009705f //x=5.485 //y=1.675
c70 ( 9 0 ) capacitor c=0.00770028f //x=5.485 //y=0.795
c71 ( 5 0 ) capacitor c=0.0201517f //x=5.4 //y=1.76
c72 ( 1 0 ) capacitor c=0.00935657f //x=4.515 //y=1.675
r73 (  17 29 ) resistor r=3.57586 //w=0.17 //l=0.125 //layer=li \
 //thickness=0.1 //x=6.455 //y=0.795 //x2=6.455 //y2=0.67
r74 (  17 29 ) resistor r=41.4118 //w=0.187 //l=0.605 //layer=li \
 //thickness=0.1 //x=6.455 //y=0.795 //x2=6.455 //y2=1.4
r75 (  14 29 ) resistor r=3.57586 //w=0.17 //l=0.103078 //layer=li \
 //thickness=0.1 //x=5.57 //y=0.71 //x2=5.485 //y2=0.67
r76 (  14 29 ) resistor r=27.3797 //w=0.187 //l=0.4 //layer=li //thickness=0.1 \
 //x=5.57 //y=0.71 //x2=5.97 //y2=0.71
r77 (  13 29 ) resistor r=3.57586 //w=0.17 //l=0.103078 //layer=li \
 //thickness=0.1 //x=6.37 //y=0.71 //x2=6.455 //y2=0.67
r78 (  13 29 ) resistor r=27.3797 //w=0.187 //l=0.4 //layer=li //thickness=0.1 \
 //x=6.37 //y=0.71 //x2=5.97 //y2=0.71
r79 (  10 29 ) resistor r=3.57586 //w=0.17 //l=0.125 //layer=li \
 //thickness=0.1 //x=5.485 //y=1.675 //x2=5.485 //y2=1.8
r80 (  10 29 ) resistor r=42.0963 //w=0.187 //l=0.615 //layer=li \
 //thickness=0.1 //x=5.485 //y=1.675 //x2=5.485 //y2=1.06
r81 (  9 29 ) resistor r=3.57586 //w=0.17 //l=0.125 //layer=li //thickness=0.1 \
 //x=5.485 //y=0.795 //x2=5.485 //y2=0.67
r82 (  9 29 ) resistor r=18.139 //w=0.187 //l=0.265 //layer=li //thickness=0.1 \
 //x=5.485 //y=0.795 //x2=5.485 //y2=1.06
r83 (  6 29 ) resistor r=3.57586 //w=0.17 //l=0.103078 //layer=li \
 //thickness=0.1 //x=4.6 //y=1.76 //x2=4.515 //y2=1.8
r84 (  6 29 ) resistor r=27.3797 //w=0.187 //l=0.4 //layer=li //thickness=0.1 \
 //x=4.6 //y=1.76 //x2=5 //y2=1.76
r85 (  5 29 ) resistor r=3.57586 //w=0.17 //l=0.103078 //layer=li \
 //thickness=0.1 //x=5.4 //y=1.76 //x2=5.485 //y2=1.8
r86 (  5 29 ) resistor r=27.3797 //w=0.187 //l=0.4 //layer=li //thickness=0.1 \
 //x=5.4 //y=1.76 //x2=5 //y2=1.76
r87 (  1 29 ) resistor r=3.57586 //w=0.17 //l=0.125 //layer=li //thickness=0.1 \
 //x=4.515 //y=1.675 //x2=4.515 //y2=1.8
r88 (  1 29 ) resistor r=42.0963 //w=0.187 //l=0.615 //layer=li \
 //thickness=0.1 //x=4.515 //y=1.675 //x2=4.515 //y2=1.06
ends PM_VOTERN3X1\%noxref_10

subckt PM_VOTERN3X1\%noxref_11 ( 1 5 9 10 13 17 29 )
c62 ( 29 0 ) capacitor c=0.0685992f //x=7.71 //y=0.545
c63 ( 17 0 ) capacitor c=0.00709795f //x=9.785 //y=0.795
c64 ( 13 0 ) capacitor c=0.0152565f //x=9.7 //y=0.71
c65 ( 10 0 ) capacitor c=0.0075177f //x=8.815 //y=1.675
c66 ( 9 0 ) capacitor c=0.00770028f //x=8.815 //y=0.795
c67 ( 5 0 ) capacitor c=0.0236235f //x=8.73 //y=1.76
c68 ( 1 0 ) capacitor c=0.00498306f //x=7.845 //y=1.675
r69 (  17 29 ) resistor r=3.57586 //w=0.17 //l=0.125 //layer=li \
 //thickness=0.1 //x=9.785 //y=0.795 //x2=9.785 //y2=0.67
r70 (  17 29 ) resistor r=18.139 //w=0.187 //l=0.265 //layer=li \
 //thickness=0.1 //x=9.785 //y=0.795 //x2=9.785 //y2=1.06
r71 (  14 29 ) resistor r=3.57586 //w=0.17 //l=0.103078 //layer=li \
 //thickness=0.1 //x=8.9 //y=0.71 //x2=8.815 //y2=0.67
r72 (  14 29 ) resistor r=27.3797 //w=0.187 //l=0.4 //layer=li //thickness=0.1 \
 //x=8.9 //y=0.71 //x2=9.3 //y2=0.71
r73 (  13 29 ) resistor r=3.57586 //w=0.17 //l=0.103078 //layer=li \
 //thickness=0.1 //x=9.7 //y=0.71 //x2=9.785 //y2=0.67
r74 (  13 29 ) resistor r=27.3797 //w=0.187 //l=0.4 //layer=li //thickness=0.1 \
 //x=9.7 //y=0.71 //x2=9.3 //y2=0.71
r75 (  10 29 ) resistor r=3.57586 //w=0.17 //l=0.125 //layer=li \
 //thickness=0.1 //x=8.815 //y=1.675 //x2=8.815 //y2=1.8
r76 (  10 29 ) resistor r=42.0963 //w=0.187 //l=0.615 //layer=li \
 //thickness=0.1 //x=8.815 //y=1.675 //x2=8.815 //y2=1.06
r77 (  9 29 ) resistor r=3.57586 //w=0.17 //l=0.125 //layer=li //thickness=0.1 \
 //x=8.815 //y=0.795 //x2=8.815 //y2=0.67
r78 (  9 29 ) resistor r=18.139 //w=0.187 //l=0.265 //layer=li //thickness=0.1 \
 //x=8.815 //y=0.795 //x2=8.815 //y2=1.06
r79 (  6 29 ) resistor r=3.57586 //w=0.17 //l=0.103078 //layer=li \
 //thickness=0.1 //x=7.93 //y=1.76 //x2=7.845 //y2=1.8
r80 (  6 29 ) resistor r=27.3797 //w=0.187 //l=0.4 //layer=li //thickness=0.1 \
 //x=7.93 //y=1.76 //x2=8.33 //y2=1.76
r81 (  5 29 ) resistor r=3.57586 //w=0.17 //l=0.103078 //layer=li \
 //thickness=0.1 //x=8.73 //y=1.76 //x2=8.815 //y2=1.8
r82 (  5 29 ) resistor r=27.3797 //w=0.187 //l=0.4 //layer=li //thickness=0.1 \
 //x=8.73 //y=1.76 //x2=8.33 //y2=1.76
r83 (  1 29 ) resistor r=3.57586 //w=0.17 //l=0.125 //layer=li //thickness=0.1 \
 //x=7.845 //y=1.675 //x2=7.845 //y2=1.8
r84 (  1 29 ) resistor r=42.0963 //w=0.187 //l=0.615 //layer=li \
 //thickness=0.1 //x=7.845 //y=1.675 //x2=7.845 //y2=1.06
ends PM_VOTERN3X1\%noxref_11
