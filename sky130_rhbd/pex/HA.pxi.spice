// File: HA.spi.HA.pxi
// Created: Fri Feb 20 10:12:57 2026
//
simulator lang=spectre
x_PM_HA\%noxref_1 ( N_noxref_1_c_11_p N_noxref_1_c_27_p N_noxref_1_c_29_p \
 N_noxref_1_c_28_p N_noxref_1_c_42_p N_noxref_1_c_1_p N_noxref_1_c_33_p \
 N_noxref_1_c_2_p N_noxref_1_c_4_p N_noxref_1_c_58_p N_noxref_1_c_5_p \
 N_noxref_1_c_7_p N_noxref_1_c_15_p N_noxref_1_c_107_p N_noxref_1_c_45_p \
 N_noxref_1_c_36_p N_noxref_1_c_164_p N_noxref_1_c_165_p N_noxref_1_c_16_p \
 N_noxref_1_c_37_p N_noxref_1_c_61_p N_noxref_1_c_8_p N_noxref_1_c_46_p \
 N_noxref_1_c_167_p N_noxref_1_c_110_p N_noxref_1_M2_noxref_g \
 N_noxref_1_M13_noxref_g N_noxref_1_M14_noxref_g N_noxref_1_c_192_p \
 N_noxref_1_c_174_p N_noxref_1_c_175_p N_noxref_1_c_176_p N_noxref_1_c_134_p \
 N_noxref_1_c_132_p N_noxref_1_c_194_p N_noxref_1_c_177_p N_noxref_1_c_196_p \
 N_noxref_1_c_178_p N_noxref_1_c_171_p N_noxref_1_M1_noxref_d \
 N_noxref_1_M9_noxref_d N_noxref_1_M11_noxref_d )  PM_HA\%noxref_1
x_PM_HA\%A ( A A A A A A A A A A A A A A A N_A_c_261_n N_A_c_308_p N_A_c_309_p \
 N_A_c_297_p N_A_c_310_p N_A_c_311_p N_A_c_384_p N_A_c_263_n N_A_c_298_p \
 N_A_c_265_n N_A_c_271_n N_A_c_312_p N_A_c_313_p N_A_c_286_p N_A_c_357_p \
 N_A_c_272_n N_A_c_299_p N_A_c_315_p N_A_c_380_p N_A_c_343_p N_A_M0_noxref_g \
 N_A_M3_noxref_g N_A_M4_noxref_g N_A_M9_noxref_g N_A_M10_noxref_g \
 N_A_M15_noxref_g N_A_M16_noxref_g N_A_M17_noxref_g N_A_M18_noxref_g \
 N_A_c_428_p N_A_c_429_p N_A_c_431_p N_A_c_386_p N_A_c_562_p N_A_c_563_p \
 N_A_c_430_p N_A_c_432_p N_A_c_318_p N_A_c_281_p N_A_c_282_p N_A_c_283_p \
 N_A_c_294_p N_A_c_317_p N_A_c_320_p N_A_c_284_p N_A_c_322_p N_A_c_285_p \
 N_A_c_438_p N_A_c_439_p N_A_c_441_p N_A_c_381_p N_A_c_552_p N_A_c_553_p \
 N_A_c_440_p N_A_c_442_p N_A_c_279_n N_A_c_290_p N_A_c_344_p )  PM_HA\%A
x_PM_HA\%noxref_3 ( N_noxref_3_c_639_n N_noxref_3_c_641_n N_noxref_3_c_652_n \
 N_noxref_3_c_642_n N_noxref_3_c_654_n N_noxref_3_c_643_n N_noxref_3_c_658_n \
 N_noxref_3_c_664_n N_noxref_3_c_666_n N_noxref_3_c_703_p N_noxref_3_c_708_p \
 N_noxref_3_c_711_p N_noxref_3_c_704_p N_noxref_3_c_681_n N_noxref_3_c_687_n \
 N_noxref_3_c_713_p N_noxref_3_c_718_p N_noxref_3_c_688_n N_noxref_3_c_714_p \
 N_noxref_3_c_690_n N_noxref_3_c_693_n N_noxref_3_c_715_p N_noxref_3_c_719_p \
 N_noxref_3_M7_noxref_g N_noxref_3_M23_noxref_g N_noxref_3_M24_noxref_g \
 N_noxref_3_c_731_p N_noxref_3_c_732_p N_noxref_3_c_738_p N_noxref_3_c_716_p \
 N_noxref_3_c_733_p N_noxref_3_c_734_p N_noxref_3_c_735_p N_noxref_3_c_736_p \
 N_noxref_3_c_720_p N_noxref_3_M3_noxref_d N_noxref_3_M15_noxref_d )  \
 PM_HA\%noxref_3
x_PM_HA\%SUM ( SUM SUM SUM SUM SUM SUM SUM SUM N_SUM_c_963_n N_SUM_c_965_n \
 N_SUM_c_1026_p N_SUM_c_967_n N_SUM_c_968_n N_SUM_c_969_n N_SUM_c_970_n \
 N_SUM_c_978_n N_SUM_c_983_n N_SUM_c_986_n N_SUM_c_992_n N_SUM_c_997_n \
 N_SUM_c_1001_n N_SUM_c_1002_n N_SUM_c_1007_n N_SUM_c_1008_n N_SUM_c_1009_n \
 N_SUM_c_1032_p N_SUM_c_1011_n N_SUM_M5_noxref_d N_SUM_M7_noxref_d \
 N_SUM_M19_noxref_d N_SUM_M23_noxref_d )  PM_HA\%SUM
x_PM_HA\%noxref_5 ( N_noxref_5_c_1291_n N_noxref_5_c_1240_n \
 N_noxref_5_c_1255_n N_noxref_5_c_1259_n N_noxref_5_c_1264_n \
 N_noxref_5_c_1302_n N_noxref_5_c_1266_n N_noxref_5_c_1308_n \
 N_noxref_5_c_1267_n N_noxref_5_c_1391_p N_noxref_5_c_1310_n \
 N_noxref_5_c_1398_p N_noxref_5_c_1413_p N_noxref_5_c_1311_n \
 N_noxref_5_c_1313_n N_noxref_5_c_1244_n N_noxref_5_c_1268_n \
 N_noxref_5_c_1318_n N_noxref_5_c_1319_n N_noxref_5_c_1320_n \
 N_noxref_5_c_1322_n N_noxref_5_c_1269_n N_noxref_5_c_1325_n \
 N_noxref_5_c_1271_n N_noxref_5_c_1333_n N_noxref_5_c_1273_n \
 N_noxref_5_c_1245_n N_noxref_5_c_1275_n N_noxref_5_c_1415_p \
 N_noxref_5_M6_noxref_g N_noxref_5_M19_noxref_g N_noxref_5_M20_noxref_g \
 N_noxref_5_c_1278_n N_noxref_5_c_1279_n N_noxref_5_c_1280_n \
 N_noxref_5_c_1282_n N_noxref_5_c_1486_p N_noxref_5_c_1487_p \
 N_noxref_5_c_1286_n N_noxref_5_c_1288_n N_noxref_5_c_1252_n \
 N_noxref_5_M8_noxref_d N_noxref_5_M25_noxref_d )  PM_HA\%noxref_5
x_PM_HA\%B ( B B B B B B B B B B B B B B N_B_c_1543_n N_B_c_1549_n \
 N_B_c_1625_n N_B_c_1628_n N_B_c_1822_n N_B_c_1551_n N_B_c_1823_n N_B_c_1824_n \
 N_B_c_1552_n N_B_c_1557_n N_B_c_1560_n N_B_c_1564_n N_B_c_1637_n N_B_c_1639_n \
 N_B_c_1644_n N_B_c_1647_n N_B_c_1650_n N_B_c_1755_n N_B_c_1655_n N_B_c_1717_n \
 N_B_c_1840_n N_B_c_1846_n N_B_c_1721_n N_B_c_1566_n N_B_c_1658_n N_B_c_1659_n \
 N_B_c_1567_n N_B_c_1568_n N_B_c_1668_n N_B_c_1725_n N_B_c_1861_n N_B_c_1862_n \
 N_B_M1_noxref_g N_B_M5_noxref_g N_B_M8_noxref_g N_B_M11_noxref_g \
 N_B_M12_noxref_g N_B_M21_noxref_g N_B_M22_noxref_g N_B_M25_noxref_g \
 N_B_M26_noxref_g N_B_c_1576_n N_B_c_1578_n N_B_c_1581_n N_B_c_1582_n \
 N_B_c_1585_n N_B_c_1587_n N_B_c_1591_n N_B_c_1593_n N_B_c_1684_n N_B_c_1687_n \
 N_B_c_1689_n N_B_c_1692_n N_B_c_1789_n N_B_c_1791_n N_B_c_1695_n N_B_c_1696_n \
 N_B_c_1870_n N_B_c_1872_n N_B_c_1876_n N_B_c_1878_n N_B_c_1881_n N_B_c_1883_n \
 N_B_c_1923_p N_B_c_1886_n N_B_c_1888_n N_B_c_1891_n N_B_c_1892_n N_B_c_1597_n \
 N_B_c_1598_n N_B_c_1600_n N_B_c_1732_n N_B_c_1893_n )  PM_HA\%B
x_PM_HA\%VDD ( VDD N_VDD_c_2034_n N_VDD_c_2098_n N_VDD_c_2100_n N_VDD_c_2179_n \
 N_VDD_c_2230_n N_VDD_c_2232_n N_VDD_c_2181_n N_VDD_c_2045_n N_VDD_c_2048_n \
 N_VDD_c_2053_n N_VDD_c_2105_n N_VDD_c_2109_n N_VDD_c_2161_n N_VDD_c_2206_n \
 N_VDD_c_2056_n N_VDD_c_2059_n N_VDD_c_2067_n N_VDD_c_2127_n N_VDD_c_2168_n \
 N_VDD_c_2169_n N_VDD_c_2070_n N_VDD_M9_noxref_s N_VDD_M10_noxref_d \
 N_VDD_M12_noxref_d N_VDD_M13_noxref_s N_VDD_M14_noxref_d N_VDD_M15_noxref_s \
 N_VDD_M16_noxref_d N_VDD_M17_noxref_d N_VDD_M21_noxref_d N_VDD_M25_noxref_s \
 N_VDD_M26_noxref_d )  PM_HA\%VDD
x_PM_HA\%COUT ( COUT COUT COUT COUT COUT N_COUT_c_2401_n N_COUT_c_2408_n \
 N_COUT_c_2412_n N_COUT_c_2413_n N_COUT_c_2415_n N_COUT_c_2416_n \
 N_COUT_c_2419_n N_COUT_c_2427_n N_COUT_M2_noxref_d N_COUT_M13_noxref_d )  \
 PM_HA\%COUT
x_PM_HA\%noxref_9 ( N_noxref_9_c_2489_n N_noxref_9_c_2506_n \
 N_noxref_9_c_2496_n N_noxref_9_c_2499_n N_noxref_9_c_2500_n \
 N_noxref_9_c_2512_n N_noxref_9_c_2501_n N_noxref_9_c_2503_n \
 N_noxref_9_M17_noxref_s N_noxref_9_M18_noxref_d N_noxref_9_M20_noxref_d )  \
 PM_HA\%noxref_9
x_PM_HA\%noxref_10 ( N_noxref_10_c_2602_n N_noxref_10_c_2580_n \
 N_noxref_10_c_2590_n N_noxref_10_c_2582_n N_noxref_10_c_2583_n \
 N_noxref_10_c_2584_n N_noxref_10_c_2613_n N_noxref_10_c_2585_n \
 N_noxref_10_M21_noxref_s N_noxref_10_M22_noxref_d N_noxref_10_M24_noxref_d )  \
 PM_HA\%noxref_10
x_PM_HA\%GND ( GND N_GND_c_2699_n N_GND_c_2661_n N_GND_c_2703_n N_GND_c_2805_n \
 N_GND_c_2777_n N_GND_c_2778_n N_GND_c_2668_n N_GND_c_2721_n N_GND_c_2670_n \
 N_GND_c_2672_n N_GND_c_2949_p N_GND_c_2673_n N_GND_c_2677_n N_GND_c_2730_n \
 N_GND_c_2734_n N_GND_c_2983_p N_GND_c_2735_n N_GND_c_2816_n N_GND_c_3006_p \
 N_GND_c_2841_n N_GND_c_2844_n N_GND_c_2678_n N_GND_c_2686_n N_GND_c_2741_n \
 N_GND_c_2789_n N_GND_c_2791_n N_GND_c_2687_n N_GND_M0_noxref_d \
 N_GND_M2_noxref_s N_GND_M3_noxref_s N_GND_M4_noxref_d N_GND_M6_noxref_d \
 N_GND_M8_noxref_s )  PM_HA\%GND
x_PM_HA\%noxref_12 ( N_noxref_12_c_3027_n N_noxref_12_c_3028_n \
 N_noxref_12_c_3056_n N_noxref_12_c_3017_n N_noxref_12_c_3018_n \
 N_noxref_12_c_3066_n N_noxref_12_M0_noxref_s )  PM_HA\%noxref_12
x_PM_HA\%noxref_13 ( N_noxref_13_c_3080_n N_noxref_13_c_3081_n \
 N_noxref_13_c_3121_n N_noxref_13_c_3088_n N_noxref_13_c_3095_n \
 N_noxref_13_c_3131_n N_noxref_13_M4_noxref_s )  PM_HA\%noxref_13
x_PM_HA\%noxref_14 ( N_noxref_14_c_3146_n N_noxref_14_c_3147_n \
 N_noxref_14_c_3187_n N_noxref_14_c_3148_n N_noxref_14_c_3150_n \
 N_noxref_14_c_3197_n N_noxref_14_M6_noxref_s )  PM_HA\%noxref_14
cc_1 ( N_noxref_1_c_1_p A ) capacitor c=0.00327648f //x=3.08 //y=3.35 //x2=1.6 \
 //y2=2.77
cc_2 ( N_noxref_1_c_2_p A ) capacitor c=0.00131053f //x=3.08 //y=5.295 \
 //x2=1.6 //y2=2.77
cc_3 ( N_noxref_1_c_2_p A ) capacitor c=0.0016008f //x=3.08 //y=5.295 //x2=1.6 \
 //y2=4.62
cc_4 ( N_noxref_1_c_4_p A ) capacitor c=0.00228108f //x=4.56 //y=3.35 \
 //x2=6.78 //y2=2.77
cc_5 ( N_noxref_1_c_5_p A ) capacitor c=3.57552e-19 //x=4.56 //y=4.76 \
 //x2=6.78 //y2=2.77
cc_6 ( N_noxref_1_c_5_p A ) capacitor c=0.00111139f //x=4.56 //y=4.76 \
 //x2=6.78 //y2=4.62
cc_7 ( N_noxref_1_c_7_p N_A_c_261_n ) capacitor c=0.003477f //x=1.72 //y=5.56 \
 //x2=1.6 //y2=4.41
cc_8 ( N_noxref_1_c_8_p N_A_c_261_n ) capacitor c=9.41964e-19 //x=1.72 \
 //y=5.56 //x2=1.6 //y2=4.41
cc_9 ( N_noxref_1_c_7_p N_A_c_263_n ) capacitor c=0.0117972f //x=1.72 //y=5.56 \
 //x2=1.6 //y2=4.88
cc_10 ( N_noxref_1_c_8_p N_A_c_263_n ) capacitor c=0.00104426f //x=1.72 \
 //y=5.56 //x2=1.6 //y2=4.88
cc_11 ( N_noxref_1_c_11_p N_A_c_265_n ) capacitor c=0.0140055f //x=2.485 \
 //y=5.38 //x2=6.62 //y2=4.25
cc_12 ( N_noxref_1_c_2_p N_A_c_265_n ) capacitor c=0.0285754f //x=3.08 \
 //y=5.295 //x2=6.62 //y2=4.25
cc_13 ( N_noxref_1_c_5_p N_A_c_265_n ) capacitor c=0.0302573f //x=4.56 \
 //y=4.76 //x2=6.62 //y2=4.25
cc_14 ( N_noxref_1_c_7_p N_A_c_265_n ) capacitor c=0.00158593f //x=1.72 \
 //y=5.56 //x2=6.62 //y2=4.25
cc_15 ( N_noxref_1_c_15_p N_A_c_265_n ) capacitor c=0.0151322f //x=2.6 \
 //y=5.38 //x2=6.62 //y2=4.25
cc_16 ( N_noxref_1_c_16_p N_A_c_265_n ) capacitor c=0.0074797f //x=4.395 \
 //y=3.51 //x2=6.62 //y2=4.25
cc_17 ( N_noxref_1_c_7_p N_A_c_271_n ) capacitor c=6.54514e-19 //x=1.72 \
 //y=5.56 //x2=1.76 //y2=4.25
cc_18 ( N_noxref_1_c_7_p N_A_c_272_n ) capacitor c=0.00277154f //x=1.72 \
 //y=5.56 //x2=1.6 //y2=4.88
cc_19 ( N_noxref_1_c_8_p N_A_c_272_n ) capacitor c=0.00377369f //x=1.72 \
 //y=5.56 //x2=1.6 //y2=4.88
cc_20 ( N_noxref_1_c_7_p N_A_M9_noxref_g ) capacitor c=0.0020878f //x=1.72 \
 //y=5.56 //x2=1.5 //y2=6.2
cc_21 ( N_noxref_1_c_8_p N_A_M9_noxref_g ) capacitor c=0.0158358f //x=1.72 \
 //y=5.56 //x2=1.5 //y2=6.2
cc_22 ( N_noxref_1_c_11_p N_A_M10_noxref_g ) capacitor c=0.00967396f //x=2.485 \
 //y=5.38 //x2=1.94 //y2=6.2
cc_23 ( N_noxref_1_c_7_p N_A_M10_noxref_g ) capacitor c=0.00192712f //x=1.72 \
 //y=5.56 //x2=1.94 //y2=6.2
cc_24 ( N_noxref_1_c_8_p N_A_M10_noxref_g ) capacitor c=0.0178987f //x=1.72 \
 //y=5.56 //x2=1.94 //y2=6.2
cc_25 ( N_noxref_1_c_7_p N_A_c_279_n ) capacitor c=0.00199287f //x=1.72 \
 //y=5.56 //x2=1.6 //y2=4.88
cc_26 ( N_noxref_1_c_8_p N_A_c_279_n ) capacitor c=0.00322228f //x=1.72 \
 //y=5.56 //x2=1.6 //y2=4.88
cc_27 ( N_noxref_1_c_27_p N_noxref_3_c_639_n ) capacitor c=3.58717e-19 \
 //x=2.64 //y=1.75 //x2=7.15 //y2=1.935
cc_28 ( N_noxref_1_c_28_p N_noxref_3_c_639_n ) capacitor c=3.32295e-19 \
 //x=2.995 //y=1.835 //x2=7.15 //y2=1.935
cc_29 ( N_noxref_1_c_29_p N_noxref_3_c_641_n ) capacitor c=2.95093e-19 \
 //x=2.995 //y=5.38 //x2=7.155 //y2=5.42
cc_30 ( N_noxref_1_c_1_p N_noxref_3_c_642_n ) capacitor c=3.32295e-19 //x=3.08 \
 //y=3.35 //x2=7.235 //y2=2.02
cc_31 ( N_noxref_1_c_2_p N_noxref_3_c_643_n ) capacitor c=2.95093e-19 //x=3.08 \
 //y=5.295 //x2=7.24 //y2=5.14
cc_32 ( N_noxref_1_c_1_p B ) capacitor c=0.0428886f //x=3.08 //y=3.35 \
 //x2=2.34 //y2=2.77
cc_33 ( N_noxref_1_c_33_p B ) capacitor c=0.0148501f //x=3.08 //y=3.67 \
 //x2=2.34 //y2=2.77
cc_34 ( N_noxref_1_c_2_p B ) capacitor c=0.00158373f //x=3.08 //y=5.295 \
 //x2=2.34 //y2=2.77
cc_35 ( N_noxref_1_c_4_p B ) capacitor c=0.00222924f //x=4.56 //y=3.35 \
 //x2=2.34 //y2=2.77
cc_36 ( N_noxref_1_c_36_p B ) capacitor c=6.03895e-19 //x=3.08 //y=3.51 \
 //x2=2.34 //y2=2.77
cc_37 ( N_noxref_1_c_37_p B ) capacitor c=0.00687742f //x=3.24 //y=3.51 \
 //x2=2.34 //y2=2.77
cc_38 ( N_noxref_1_c_2_p B ) capacitor c=0.0279806f //x=3.08 //y=5.295 \
 //x2=2.34 //y2=4.62
cc_39 ( N_noxref_1_c_5_p B ) capacitor c=0.00163029f //x=4.56 //y=4.76 \
 //x2=2.34 //y2=4.62
cc_40 ( N_noxref_1_c_2_p B ) capacitor c=9.19401e-19 //x=3.08 //y=5.295 \
 //x2=2.34 //y2=3.88
cc_41 ( N_noxref_1_c_11_p N_B_c_1543_n ) capacitor c=0.00141839f //x=2.485 \
 //y=5.38 //x2=2.34 //y2=4.025
cc_42 ( N_noxref_1_c_42_p N_B_c_1543_n ) capacitor c=4.69451e-19 //x=2.725 \
 //y=1.835 //x2=2.34 //y2=4.025
cc_43 ( N_noxref_1_c_2_p N_B_c_1543_n ) capacitor c=0.0176028f //x=3.08 \
 //y=5.295 //x2=2.34 //y2=4.025
cc_44 ( N_noxref_1_c_15_p N_B_c_1543_n ) capacitor c=0.00161205f //x=2.6 \
 //y=5.38 //x2=2.34 //y2=4.025
cc_45 ( N_noxref_1_c_45_p N_B_c_1543_n ) capacitor c=2.03e-19 //x=2.64 \
 //y=1.18 //x2=2.34 //y2=4.025
cc_46 ( N_noxref_1_c_46_p N_B_c_1543_n ) capacitor c=4.37971e-19 //x=2.6 \
 //y=5.56 //x2=2.34 //y2=4.025
cc_47 ( N_noxref_1_c_11_p N_B_c_1549_n ) capacitor c=0.0221293f //x=2.485 \
 //y=5.38 //x2=2.34 //y2=4.735
cc_48 ( N_noxref_1_c_2_p N_B_c_1549_n ) capacitor c=0.016905f //x=3.08 \
 //y=5.295 //x2=2.34 //y2=4.735
cc_49 ( N_noxref_1_c_1_p N_B_c_1551_n ) capacitor c=0.015397f //x=3.08 \
 //y=3.35 //x2=2.34 //y2=2.26
cc_50 ( N_noxref_1_c_28_p N_B_c_1552_n ) capacitor c=0.00188982f //x=2.995 \
 //y=1.835 //x2=2.695 //y2=3.88
cc_51 ( N_noxref_1_c_42_p N_B_c_1552_n ) capacitor c=0.00292019f //x=2.725 \
 //y=1.835 //x2=2.695 //y2=3.88
cc_52 ( N_noxref_1_c_33_p N_B_c_1552_n ) capacitor c=0.0013831f //x=3.08 \
 //y=3.67 //x2=2.695 //y2=3.88
cc_53 ( N_noxref_1_c_2_p N_B_c_1552_n ) capacitor c=2.75635e-19 //x=3.08 \
 //y=5.295 //x2=2.695 //y2=3.88
cc_54 ( N_noxref_1_c_37_p N_B_c_1552_n ) capacitor c=0.0367952f //x=3.24 \
 //y=3.51 //x2=2.695 //y2=3.88
cc_55 ( N_noxref_1_c_33_p N_B_c_1557_n ) capacitor c=0.00768025f //x=3.08 \
 //y=3.67 //x2=3.295 //y2=3.895
cc_56 ( N_noxref_1_c_2_p N_B_c_1557_n ) capacitor c=0.0211393f //x=3.08 \
 //y=5.295 //x2=3.295 //y2=3.895
cc_57 ( N_noxref_1_c_16_p N_B_c_1557_n ) capacitor c=0.0983118f //x=4.395 \
 //y=3.51 //x2=3.295 //y2=3.895
cc_58 ( N_noxref_1_c_58_p N_B_c_1560_n ) capacitor c=0.00426779f //x=4.56 \
 //y=3.67 //x2=4.17 //y2=3.88
cc_59 ( N_noxref_1_c_5_p N_B_c_1560_n ) capacitor c=4.49947e-19 //x=4.56 \
 //y=4.76 //x2=4.17 //y2=3.88
cc_60 ( N_noxref_1_c_16_p N_B_c_1560_n ) capacitor c=0.0115461f //x=4.395 \
 //y=3.51 //x2=4.17 //y2=3.88
cc_61 ( N_noxref_1_c_61_p N_B_c_1560_n ) capacitor c=0.0367952f //x=4.555 \
 //y=3.51 //x2=4.17 //y2=3.88
cc_62 ( N_noxref_1_c_58_p N_B_c_1564_n ) capacitor c=0.00301505f //x=4.56 \
 //y=3.67 //x2=4.77 //y2=3.895
cc_63 ( N_noxref_1_c_5_p N_B_c_1564_n ) capacitor c=0.0220178f //x=4.56 \
 //y=4.76 //x2=4.77 //y2=3.895
cc_64 ( N_noxref_1_c_2_p N_B_c_1566_n ) capacitor c=0.00317846f //x=3.08 \
 //y=5.295 //x2=2.505 //y2=3.865
cc_65 ( N_noxref_1_c_1_p N_B_c_1567_n ) capacitor c=0.00335761f //x=3.08 \
 //y=3.35 //x2=2.34 //y2=2.26
cc_66 ( N_noxref_1_c_11_p N_B_c_1568_n ) capacitor c=0.00469257f //x=2.485 \
 //y=5.38 //x2=2.37 //y2=4.88
cc_67 ( N_noxref_1_c_2_p N_B_c_1568_n ) capacitor c=7.76118e-19 //x=3.08 \
 //y=5.295 //x2=2.37 //y2=4.88
cc_68 ( N_noxref_1_c_11_p N_B_M11_noxref_g ) capacitor c=0.00842859f //x=2.485 \
 //y=5.38 //x2=2.38 //y2=6.2
cc_69 ( N_noxref_1_c_15_p N_B_M11_noxref_g ) capacitor c=0.00192712f //x=2.6 \
 //y=5.38 //x2=2.38 //y2=6.2
cc_70 ( N_noxref_1_c_46_p N_B_M11_noxref_g ) capacitor c=0.0178987f //x=2.6 \
 //y=5.56 //x2=2.38 //y2=6.2
cc_71 ( N_noxref_1_c_29_p N_B_M12_noxref_g ) capacitor c=0.0110279f //x=2.995 \
 //y=5.38 //x2=2.82 //y2=6.2
cc_72 ( N_noxref_1_c_15_p N_B_M12_noxref_g ) capacitor c=0.00291595f //x=2.6 \
 //y=5.38 //x2=2.82 //y2=6.2
cc_73 ( N_noxref_1_c_46_p N_B_M12_noxref_g ) capacitor c=0.0178506f //x=2.6 \
 //y=5.56 //x2=2.82 //y2=6.2
cc_74 ( N_noxref_1_c_45_p N_B_c_1576_n ) capacitor c=0.00120406f //x=2.64 \
 //y=1.18 //x2=2.375 //y2=1.085
cc_75 ( N_noxref_1_M1_noxref_d N_B_c_1576_n ) capacitor c=0.00137165f //x=2.45 \
 //y=1.085 //x2=2.375 //y2=1.085
cc_76 ( N_noxref_1_c_27_p N_B_c_1578_n ) capacitor c=0.00127432f //x=2.64 \
 //y=1.75 //x2=2.375 //y2=1.43
cc_77 ( N_noxref_1_c_45_p N_B_c_1578_n ) capacitor c=0.00220847f //x=2.64 \
 //y=1.18 //x2=2.375 //y2=1.43
cc_78 ( N_noxref_1_M1_noxref_d N_B_c_1578_n ) capacitor c=0.00237422f //x=2.45 \
 //y=1.085 //x2=2.375 //y2=1.43
cc_79 ( N_noxref_1_c_27_p N_B_c_1581_n ) capacitor c=0.00454577f //x=2.64 \
 //y=1.75 //x2=2.375 //y2=1.74
cc_80 ( N_noxref_1_c_2_p N_B_c_1582_n ) capacitor c=0.00874009f //x=3.08 \
 //y=5.295 //x2=2.745 //y2=4.97
cc_81 ( N_noxref_1_c_15_p N_B_c_1582_n ) capacitor c=0.00183711f //x=2.6 \
 //y=5.38 //x2=2.745 //y2=4.97
cc_82 ( N_noxref_1_c_46_p N_B_c_1582_n ) capacitor c=0.00291714f //x=2.6 \
 //y=5.56 //x2=2.745 //y2=4.97
cc_83 ( N_noxref_1_c_45_p N_B_c_1585_n ) capacitor c=5.50523e-19 //x=2.64 \
 //y=1.18 //x2=2.75 //y2=0.93
cc_84 ( N_noxref_1_M1_noxref_d N_B_c_1585_n ) capacitor c=0.0020782f //x=2.45 \
 //y=1.085 //x2=2.75 //y2=0.93
cc_85 ( N_noxref_1_c_27_p N_B_c_1587_n ) capacitor c=0.00910917f //x=2.64 \
 //y=1.75 //x2=2.75 //y2=1.585
cc_86 ( N_noxref_1_c_28_p N_B_c_1587_n ) capacitor c=0.00194324f //x=2.995 \
 //y=1.835 //x2=2.75 //y2=1.585
cc_87 ( N_noxref_1_c_45_p N_B_c_1587_n ) capacitor c=5.31395e-19 //x=2.64 \
 //y=1.18 //x2=2.75 //y2=1.585
cc_88 ( N_noxref_1_M1_noxref_d N_B_c_1587_n ) capacitor c=0.00356097f //x=2.45 \
 //y=1.085 //x2=2.75 //y2=1.585
cc_89 ( N_noxref_1_c_45_p N_B_c_1591_n ) capacitor c=0.00109893f //x=2.64 \
 //y=1.18 //x2=2.905 //y2=1.085
cc_90 ( N_noxref_1_M1_noxref_d N_B_c_1591_n ) capacitor c=8.50095e-19 //x=2.45 \
 //y=1.085 //x2=2.905 //y2=1.085
cc_91 ( N_noxref_1_c_27_p N_B_c_1593_n ) capacitor c=0.00303393f //x=2.64 \
 //y=1.75 //x2=2.905 //y2=1.43
cc_92 ( N_noxref_1_c_28_p N_B_c_1593_n ) capacitor c=0.00323005f //x=2.995 \
 //y=1.835 //x2=2.905 //y2=1.43
cc_93 ( N_noxref_1_c_45_p N_B_c_1593_n ) capacitor c=0.00312043f //x=2.64 \
 //y=1.18 //x2=2.905 //y2=1.43
cc_94 ( N_noxref_1_M1_noxref_d N_B_c_1593_n ) capacitor c=0.00237422f //x=2.45 \
 //y=1.085 //x2=2.905 //y2=1.43
cc_95 ( N_noxref_1_c_1_p N_B_c_1597_n ) capacitor c=0.00285392f //x=3.08 \
 //y=3.35 //x2=2.34 //y2=2.26
cc_96 ( N_noxref_1_c_27_p N_B_c_1598_n ) capacitor c=0.00371023f //x=2.64 \
 //y=1.75 //x2=2.34 //y2=2.095
cc_97 ( N_noxref_1_c_1_p N_B_c_1598_n ) capacitor c=0.00341496f //x=3.08 \
 //y=3.35 //x2=2.34 //y2=2.095
cc_98 ( N_noxref_1_c_11_p N_B_c_1600_n ) capacitor c=8.87334e-19 //x=2.485 \
 //y=5.38 //x2=2.37 //y2=4.88
cc_99 ( N_noxref_1_c_2_p N_B_c_1600_n ) capacitor c=0.00142201f //x=3.08 \
 //y=5.295 //x2=2.37 //y2=4.88
cc_100 ( N_noxref_1_c_11_p N_VDD_c_2034_n ) capacitor c=0.00648282f //x=2.485 \
 //y=5.38 //x2=9.405 //y2=7.585
cc_101 ( N_noxref_1_c_29_p N_VDD_c_2034_n ) capacitor c=0.00492584f //x=2.995 \
 //y=5.38 //x2=9.405 //y2=7.585
cc_102 ( N_noxref_1_c_33_p N_VDD_c_2034_n ) capacitor c=4.58384e-19 //x=3.08 \
 //y=3.67 //x2=9.405 //y2=7.585
cc_103 ( N_noxref_1_c_58_p N_VDD_c_2034_n ) capacitor c=2.66043e-19 //x=4.56 \
 //y=3.67 //x2=9.405 //y2=7.585
cc_104 ( N_noxref_1_c_5_p N_VDD_c_2034_n ) capacitor c=5.73169e-19 //x=4.56 \
 //y=4.76 //x2=9.405 //y2=7.585
cc_105 ( N_noxref_1_c_7_p N_VDD_c_2034_n ) capacitor c=0.00368817f //x=1.72 \
 //y=5.56 //x2=9.405 //y2=7.585
cc_106 ( N_noxref_1_c_15_p N_VDD_c_2034_n ) capacitor c=8.42537e-19 //x=2.6 \
 //y=5.38 //x2=9.405 //y2=7.585
cc_107 ( N_noxref_1_c_107_p N_VDD_c_2034_n ) capacitor c=0.00285853f //x=2.6 \
 //y=5.56 //x2=9.405 //y2=7.585
cc_108 ( N_noxref_1_c_8_p N_VDD_c_2034_n ) capacitor c=0.00224881f //x=1.72 \
 //y=5.56 //x2=9.405 //y2=7.585
cc_109 ( N_noxref_1_c_46_p N_VDD_c_2034_n ) capacitor c=0.00224881f //x=2.6 \
 //y=5.56 //x2=9.405 //y2=7.585
cc_110 ( N_noxref_1_c_110_p N_VDD_c_2034_n ) capacitor c=3.40755e-19 //x=4.56 \
 //y=4.88 //x2=9.405 //y2=7.585
cc_111 ( N_noxref_1_c_11_p N_VDD_c_2045_n ) capacitor c=0.00208087f //x=2.485 \
 //y=5.38 //x2=2.075 //y2=7.585
cc_112 ( N_noxref_1_c_7_p N_VDD_c_2045_n ) capacitor c=9.41185e-19 //x=1.72 \
 //y=5.56 //x2=2.075 //y2=7.585
cc_113 ( N_noxref_1_c_8_p N_VDD_c_2045_n ) capacitor c=0.0136705f //x=1.72 \
 //y=5.56 //x2=2.075 //y2=7.585
cc_114 ( N_noxref_1_c_11_p N_VDD_c_2048_n ) capacitor c=0.00180737f //x=2.485 \
 //y=5.38 //x2=2.955 //y2=7.585
cc_115 ( N_noxref_1_c_29_p N_VDD_c_2048_n ) capacitor c=0.00208087f //x=2.995 \
 //y=5.38 //x2=2.955 //y2=7.585
cc_116 ( N_noxref_1_c_15_p N_VDD_c_2048_n ) capacitor c=4.23719e-19 //x=2.6 \
 //y=5.38 //x2=2.955 //y2=7.585
cc_117 ( N_noxref_1_c_107_p N_VDD_c_2048_n ) capacitor c=5.77976e-19 //x=2.6 \
 //y=5.56 //x2=2.955 //y2=7.585
cc_118 ( N_noxref_1_c_46_p N_VDD_c_2048_n ) capacitor c=0.0136705f //x=2.6 \
 //y=5.56 //x2=2.955 //y2=7.585
cc_119 ( N_noxref_1_c_5_p N_VDD_c_2053_n ) capacitor c=5.48929e-19 //x=4.56 \
 //y=4.76 //x2=5.29 //y2=7.585
cc_120 ( N_noxref_1_M13_noxref_g N_VDD_c_2053_n ) capacitor c=0.00753931f \
 //x=4.715 //y=6.2 //x2=5.29 //y2=7.585
cc_121 ( N_noxref_1_M14_noxref_g N_VDD_c_2053_n ) capacitor c=0.00755544f \
 //x=5.155 //y=6.2 //x2=5.29 //y2=7.585
cc_122 ( N_noxref_1_c_2_p N_VDD_c_2056_n ) capacitor c=0.00197052f //x=3.08 \
 //y=5.295 //x2=1.23 //y2=7.58
cc_123 ( N_noxref_1_c_7_p N_VDD_c_2056_n ) capacitor c=6.39392e-19 //x=1.72 \
 //y=5.56 //x2=1.23 //y2=7.58
cc_124 ( N_noxref_1_c_8_p N_VDD_c_2056_n ) capacitor c=0.0064135f //x=1.72 \
 //y=5.56 //x2=1.23 //y2=7.58
cc_125 ( N_noxref_1_c_2_p N_VDD_c_2059_n ) capacitor c=0.0277675f //x=3.08 \
 //y=5.295 //x2=3.82 //y2=7.585
cc_126 ( N_noxref_1_c_5_p N_VDD_c_2059_n ) capacitor c=0.0153926f //x=4.56 \
 //y=4.76 //x2=3.82 //y2=7.585
cc_127 ( N_noxref_1_c_15_p N_VDD_c_2059_n ) capacitor c=0.002343f //x=2.6 \
 //y=5.38 //x2=3.82 //y2=7.585
cc_128 ( N_noxref_1_c_107_p N_VDD_c_2059_n ) capacitor c=4.0348e-19 //x=2.6 \
 //y=5.56 //x2=3.82 //y2=7.585
cc_129 ( N_noxref_1_c_46_p N_VDD_c_2059_n ) capacitor c=0.0101861f //x=2.6 \
 //y=5.56 //x2=3.82 //y2=7.585
cc_130 ( N_noxref_1_c_110_p N_VDD_c_2059_n ) capacitor c=0.00795305f //x=4.56 \
 //y=4.88 //x2=3.82 //y2=7.585
cc_131 ( N_noxref_1_M13_noxref_g N_VDD_c_2059_n ) capacitor c=0.00713874f \
 //x=4.715 //y=6.2 //x2=3.82 //y2=7.585
cc_132 ( N_noxref_1_c_132_p N_VDD_c_2059_n ) capacitor c=0.00799922f //x=4.79 \
 //y=4.97 //x2=3.82 //y2=7.585
cc_133 ( N_noxref_1_c_110_p N_VDD_c_2067_n ) capacitor c=0.00235165f //x=4.56 \
 //y=4.88 //x2=6.04 //y2=7.585
cc_134 ( N_noxref_1_c_134_p N_VDD_c_2067_n ) capacitor c=0.00780996f //x=5.08 \
 //y=4.97 //x2=6.04 //y2=7.585
cc_135 ( N_noxref_1_c_132_p N_VDD_c_2067_n ) capacitor c=2.63786e-19 //x=4.79 \
 //y=4.97 //x2=6.04 //y2=7.585
cc_136 ( N_noxref_1_c_8_p N_VDD_c_2070_n ) capacitor c=0.00135089f //x=1.72 \
 //y=5.56 //x2=16.4 //y2=7.58
cc_137 ( N_noxref_1_c_46_p N_VDD_c_2070_n ) capacitor c=0.00135089f //x=2.6 \
 //y=5.56 //x2=16.4 //y2=7.58
cc_138 ( N_noxref_1_c_7_p N_VDD_M9_noxref_s ) capacitor c=0.062494f //x=1.72 \
 //y=5.56 //x2=1.145 //y2=5.2
cc_139 ( N_noxref_1_c_15_p N_VDD_M9_noxref_s ) capacitor c=6.52457e-19 //x=2.6 \
 //y=5.38 //x2=1.145 //y2=5.2
cc_140 ( N_noxref_1_c_8_p N_VDD_M9_noxref_s ) capacitor c=0.0906717f //x=1.72 \
 //y=5.56 //x2=1.145 //y2=5.2
cc_141 ( N_noxref_1_c_11_p N_VDD_M10_noxref_d ) capacitor c=0.00734094f \
 //x=2.485 //y=5.38 //x2=2.015 //y2=5.2
cc_142 ( N_noxref_1_c_7_p N_VDD_M10_noxref_d ) capacitor c=0.0043528f //x=1.72 \
 //y=5.56 //x2=2.015 //y2=5.2
cc_143 ( N_noxref_1_c_107_p N_VDD_M10_noxref_d ) capacitor c=0.0043528f \
 //x=2.6 //y=5.56 //x2=2.015 //y2=5.2
cc_144 ( N_noxref_1_c_8_p N_VDD_M10_noxref_d ) capacitor c=0.065554f //x=1.72 \
 //y=5.56 //x2=2.015 //y2=5.2
cc_145 ( N_noxref_1_c_46_p N_VDD_M10_noxref_d ) capacitor c=0.065554f //x=2.6 \
 //y=5.56 //x2=2.015 //y2=5.2
cc_146 ( N_noxref_1_c_29_p N_VDD_M12_noxref_d ) capacitor c=0.00934027f \
 //x=2.995 //y=5.38 //x2=2.895 //y2=5.2
cc_147 ( N_noxref_1_c_107_p N_VDD_M12_noxref_d ) capacitor c=0.00921458f \
 //x=2.6 //y=5.56 //x2=2.895 //y2=5.2
cc_148 ( N_noxref_1_c_36_p N_VDD_M12_noxref_d ) capacitor c=9.65951e-19 \
 //x=3.08 //y=3.51 //x2=2.895 //y2=5.2
cc_149 ( N_noxref_1_c_46_p N_VDD_M12_noxref_d ) capacitor c=0.065554f //x=2.6 \
 //y=5.56 //x2=2.895 //y2=5.2
cc_150 ( N_noxref_1_c_29_p N_VDD_M13_noxref_s ) capacitor c=0.00316782f \
 //x=2.995 //y=5.38 //x2=4.36 //y2=5.2
cc_151 ( N_noxref_1_c_58_p N_VDD_M13_noxref_s ) capacitor c=0.00125292f \
 //x=4.56 //y=3.67 //x2=4.36 //y2=5.2
cc_152 ( N_noxref_1_c_5_p N_VDD_M13_noxref_s ) capacitor c=0.0209961f //x=4.56 \
 //y=4.76 //x2=4.36 //y2=5.2
cc_153 ( N_noxref_1_c_15_p N_VDD_M13_noxref_s ) capacitor c=0.00460957f \
 //x=2.6 //y=5.38 //x2=4.36 //y2=5.2
cc_154 ( N_noxref_1_c_107_p N_VDD_M13_noxref_s ) capacitor c=0.00135645f \
 //x=2.6 //y=5.56 //x2=4.36 //y2=5.2
cc_155 ( N_noxref_1_c_110_p N_VDD_M13_noxref_s ) capacitor c=0.00914073f \
 //x=4.56 //y=4.88 //x2=4.36 //y2=5.2
cc_156 ( N_noxref_1_M13_noxref_g N_VDD_M13_noxref_s ) capacitor c=0.0573441f \
 //x=4.715 //y=6.2 //x2=4.36 //y2=5.2
cc_157 ( N_noxref_1_c_132_p N_VDD_M13_noxref_s ) capacitor c=0.00524567f \
 //x=4.79 //y=4.97 //x2=4.36 //y2=5.2
cc_158 ( N_noxref_1_M14_noxref_g N_VDD_M14_noxref_d ) capacitor c=0.0572684f \
 //x=5.155 //y=6.2 //x2=5.23 //y2=5.2
cc_159 ( N_noxref_1_c_1_p COUT ) capacitor c=0.00269396f //x=3.08 //y=3.35 \
 //x2=5.3 //y2=2.4
cc_160 ( N_noxref_1_c_2_p COUT ) capacitor c=0.00253725f //x=3.08 //y=5.295 \
 //x2=5.3 //y2=2.4
cc_161 ( N_noxref_1_c_4_p COUT ) capacitor c=0.040826f //x=4.56 //y=3.35 \
 //x2=5.3 //y2=2.4
cc_162 ( N_noxref_1_c_58_p COUT ) capacitor c=0.0146933f //x=4.56 //y=3.67 \
 //x2=5.3 //y2=2.4
cc_163 ( N_noxref_1_c_5_p COUT ) capacitor c=0.049466f //x=4.56 //y=4.76 \
 //x2=5.3 //y2=2.4
cc_164 ( N_noxref_1_c_164_p COUT ) capacitor c=6.03895e-19 //x=4.555 //y=3.51 \
 //x2=5.3 //y2=2.4
cc_165 ( N_noxref_1_c_165_p COUT ) capacitor c=0.00825076f //x=4.56 //y=2.265 \
 //x2=5.3 //y2=2.4
cc_166 ( N_noxref_1_c_61_p COUT ) capacitor c=0.00684338f //x=4.555 //y=3.51 \
 //x2=5.3 //y2=2.4
cc_167 ( N_noxref_1_c_167_p COUT ) capacitor c=4.71798e-19 //x=4.56 //y=2.265 \
 //x2=5.3 //y2=2.4
cc_168 ( N_noxref_1_c_110_p COUT ) capacitor c=0.0010551f //x=4.56 //y=4.88 \
 //x2=5.3 //y2=2.4
cc_169 ( N_noxref_1_c_134_p COUT ) capacitor c=4.08297e-19 //x=5.08 //y=4.97 \
 //x2=5.3 //y2=2.4
cc_170 ( N_noxref_1_c_132_p COUT ) capacitor c=0.00124564f //x=4.79 //y=4.97 \
 //x2=5.3 //y2=2.4
cc_171 ( N_noxref_1_c_171_p COUT ) capacitor c=0.00112403f //x=4.56 //y=2.265 \
 //x2=5.3 //y2=2.4
cc_172 ( N_noxref_1_c_27_p N_COUT_c_2401_n ) capacitor c=0.0044864f //x=2.64 \
 //y=1.75 //x2=4.93 //y2=1.935
cc_173 ( N_noxref_1_c_28_p N_COUT_c_2401_n ) capacitor c=0.00304552f //x=2.995 \
 //y=1.835 //x2=4.93 //y2=1.935
cc_174 ( N_noxref_1_c_174_p N_COUT_c_2401_n ) capacitor c=0.00108934f //x=4.67 \
 //y=1.435 //x2=4.93 //y2=1.935
cc_175 ( N_noxref_1_c_175_p N_COUT_c_2401_n ) capacitor c=0.00524682f //x=4.67 \
 //y=1.745 //x2=4.93 //y2=1.935
cc_176 ( N_noxref_1_c_176_p N_COUT_c_2401_n ) capacitor c=0.00376309f //x=4.67 \
 //y=2.1 //x2=4.93 //y2=1.935
cc_177 ( N_noxref_1_c_177_p N_COUT_c_2401_n ) capacitor c=0.00900708f \
 //x=5.045 //y=1.59 //x2=4.93 //y2=1.935
cc_178 ( N_noxref_1_c_178_p N_COUT_c_2401_n ) capacitor c=0.00321841f //x=5.2 \
 //y=1.435 //x2=4.93 //y2=1.935
cc_179 ( N_noxref_1_c_29_p N_COUT_c_2408_n ) capacitor c=0.00295701f //x=2.995 \
 //y=5.38 //x2=4.935 //y2=5.42
cc_180 ( N_noxref_1_c_15_p N_COUT_c_2408_n ) capacitor c=5.44332e-19 //x=2.6 \
 //y=5.38 //x2=4.935 //y2=5.42
cc_181 ( N_noxref_1_M13_noxref_g N_COUT_c_2408_n ) capacitor c=0.00141266f \
 //x=4.715 //y=6.2 //x2=4.935 //y2=5.42
cc_182 ( N_noxref_1_M14_noxref_g N_COUT_c_2408_n ) capacitor c=0.00344289f \
 //x=5.155 //y=6.2 //x2=4.935 //y2=5.42
cc_183 ( N_noxref_1_c_177_p N_COUT_c_2412_n ) capacitor c=0.00180253f \
 //x=5.045 //y=1.59 //x2=5.215 //y2=2.02
cc_184 ( N_noxref_1_c_1_p N_COUT_c_2413_n ) capacitor c=0.00304552f //x=3.08 \
 //y=3.35 //x2=5.015 //y2=2.02
cc_185 ( N_noxref_1_c_171_p N_COUT_c_2413_n ) capacitor c=0.00376309f //x=4.56 \
 //y=2.265 //x2=5.015 //y2=2.02
cc_186 ( N_noxref_1_M14_noxref_g N_COUT_c_2415_n ) capacitor c=0.00966342f \
 //x=5.155 //y=6.2 //x2=5.215 //y2=5.14
cc_187 ( N_noxref_1_c_2_p N_COUT_c_2416_n ) capacitor c=0.00278106f //x=3.08 \
 //y=5.295 //x2=5.02 //y2=5.14
cc_188 ( N_noxref_1_M13_noxref_g N_COUT_c_2416_n ) capacitor c=0.00427521f \
 //x=4.715 //y=6.2 //x2=5.02 //y2=5.14
cc_189 ( N_noxref_1_c_134_p N_COUT_c_2416_n ) capacitor c=0.00262283f //x=5.08 \
 //y=4.97 //x2=5.02 //y2=5.14
cc_190 ( N_noxref_1_c_27_p N_COUT_c_2419_n ) capacitor c=6.23317e-19 //x=2.64 \
 //y=1.75 //x2=4.93 //y2=1.185
cc_191 ( N_noxref_1_c_45_p N_COUT_c_2419_n ) capacitor c=0.00596895f //x=2.64 \
 //y=1.18 //x2=4.93 //y2=1.185
cc_192 ( N_noxref_1_c_192_p N_COUT_c_2419_n ) capacitor c=0.00175305f //x=4.67 \
 //y=1.09 //x2=4.93 //y2=1.185
cc_193 ( N_noxref_1_c_174_p N_COUT_c_2419_n ) capacitor c=0.00354487f //x=4.67 \
 //y=1.435 //x2=4.93 //y2=1.185
cc_194 ( N_noxref_1_c_194_p N_COUT_c_2419_n ) capacitor c=5.57924e-19 \
 //x=5.045 //y=0.935 //x2=4.93 //y2=1.185
cc_195 ( N_noxref_1_c_177_p N_COUT_c_2419_n ) capacitor c=5.75878e-19 \
 //x=5.045 //y=1.59 //x2=4.93 //y2=1.185
cc_196 ( N_noxref_1_c_196_p N_COUT_c_2419_n ) capacitor c=0.0014754f //x=5.2 \
 //y=1.09 //x2=4.93 //y2=1.185
cc_197 ( N_noxref_1_c_178_p N_COUT_c_2419_n ) capacitor c=0.0034642f //x=5.2 \
 //y=1.435 //x2=4.93 //y2=1.185
cc_198 ( N_noxref_1_M13_noxref_g N_COUT_c_2427_n ) capacitor c=0.0162066f \
 //x=4.715 //y=6.2 //x2=4.935 //y2=5.56
cc_199 ( N_noxref_1_M14_noxref_g N_COUT_c_2427_n ) capacitor c=0.0162066f \
 //x=5.155 //y=6.2 //x2=4.935 //y2=5.56
cc_200 ( N_noxref_1_c_134_p N_COUT_c_2427_n ) capacitor c=0.00290963f //x=5.08 \
 //y=4.97 //x2=4.935 //y2=5.56
cc_201 ( N_noxref_1_c_192_p N_COUT_M2_noxref_d ) capacitor c=0.00137914f \
 //x=4.67 //y=1.09 //x2=4.745 //y2=1.09
cc_202 ( N_noxref_1_c_174_p N_COUT_M2_noxref_d ) capacitor c=0.0023891f \
 //x=4.67 //y=1.435 //x2=4.745 //y2=1.09
cc_203 ( N_noxref_1_c_194_p N_COUT_M2_noxref_d ) capacitor c=0.0020782f \
 //x=5.045 //y=0.935 //x2=4.745 //y2=1.09
cc_204 ( N_noxref_1_c_177_p N_COUT_M2_noxref_d ) capacitor c=0.00356097f \
 //x=5.045 //y=1.59 //x2=4.745 //y2=1.09
cc_205 ( N_noxref_1_c_196_p N_COUT_M2_noxref_d ) capacitor c=0.00138452f \
 //x=5.2 //y=1.09 //x2=4.745 //y2=1.09
cc_206 ( N_noxref_1_c_178_p N_COUT_M2_noxref_d ) capacitor c=0.00235934f \
 //x=5.2 //y=1.435 //x2=4.745 //y2=1.09
cc_207 ( N_noxref_1_c_28_p N_GND_c_2661_n ) capacitor c=0.00654514f //x=2.995 \
 //y=1.835 //x2=9.355 //y2=0.175
cc_208 ( N_noxref_1_c_33_p N_GND_c_2661_n ) capacitor c=4.52555e-19 //x=3.08 \
 //y=3.67 //x2=9.355 //y2=0.175
cc_209 ( N_noxref_1_c_58_p N_GND_c_2661_n ) capacitor c=4.40979e-19 //x=4.56 \
 //y=3.67 //x2=9.355 //y2=0.175
cc_210 ( N_noxref_1_c_45_p N_GND_c_2661_n ) capacitor c=0.00964814f //x=2.64 \
 //y=1.18 //x2=9.355 //y2=0.175
cc_211 ( N_noxref_1_c_165_p N_GND_c_2661_n ) capacitor c=0.00249122f //x=4.56 \
 //y=2.265 //x2=9.355 //y2=0.175
cc_212 ( N_noxref_1_c_167_p N_GND_c_2661_n ) capacitor c=7.5371e-19 //x=4.56 \
 //y=2.265 //x2=9.355 //y2=0.175
cc_213 ( N_noxref_1_M1_noxref_d N_GND_c_2661_n ) capacitor c=3.01769e-19 \
 //x=2.45 //y=1.085 //x2=9.355 //y2=0.175
cc_214 ( N_noxref_1_c_45_p N_GND_c_2668_n ) capacitor c=0.0141956f //x=2.64 \
 //y=1.18 //x2=1.67 //y2=1.135
cc_215 ( N_noxref_1_M1_noxref_d N_GND_c_2668_n ) capacitor c=2.93544e-19 \
 //x=2.45 //y=1.085 //x2=1.67 //y2=1.135
cc_216 ( N_noxref_1_c_28_p N_GND_c_2670_n ) capacitor c=7.75992e-19 //x=2.995 \
 //y=1.835 //x2=3.65 //y2=0.175
cc_217 ( N_noxref_1_c_33_p N_GND_c_2670_n ) capacitor c=3.21306e-19 //x=3.08 \
 //y=3.67 //x2=3.65 //y2=0.175
cc_218 ( N_noxref_1_c_1_p N_GND_c_2672_n ) capacitor c=0.00139243f //x=3.08 \
 //y=3.35 //x2=1.23 //y2=0.18
cc_219 ( N_noxref_1_c_165_p N_GND_c_2673_n ) capacitor c=0.00114179f //x=4.56 \
 //y=2.265 //x2=4.845 //y2=0.715
cc_220 ( N_noxref_1_c_167_p N_GND_c_2673_n ) capacitor c=3.95714e-19 //x=4.56 \
 //y=2.265 //x2=4.845 //y2=0.715
cc_221 ( N_noxref_1_c_192_p N_GND_c_2673_n ) capacitor c=0.0125444f //x=4.67 \
 //y=1.09 //x2=4.845 //y2=0.715
cc_222 ( N_noxref_1_c_171_p N_GND_c_2673_n ) capacitor c=2.1838e-19 //x=4.56 \
 //y=2.265 //x2=4.845 //y2=0.715
cc_223 ( N_noxref_1_c_196_p N_GND_c_2677_n ) capacitor c=0.0134289f //x=5.2 \
 //y=1.09 //x2=5.335 //y2=0.715
cc_224 ( N_noxref_1_c_27_p N_GND_c_2678_n ) capacitor c=0.00269515f //x=2.64 \
 //y=1.75 //x2=3.82 //y2=0.175
cc_225 ( N_noxref_1_c_28_p N_GND_c_2678_n ) capacitor c=0.0271666f //x=2.995 \
 //y=1.835 //x2=3.82 //y2=0.175
cc_226 ( N_noxref_1_c_4_p N_GND_c_2678_n ) capacitor c=0.0103129f //x=4.56 \
 //y=3.35 //x2=3.82 //y2=0.175
cc_227 ( N_noxref_1_c_165_p N_GND_c_2678_n ) capacitor c=0.00682461f //x=4.56 \
 //y=2.265 //x2=3.82 //y2=0.175
cc_228 ( N_noxref_1_c_16_p N_GND_c_2678_n ) capacitor c=0.00560367f //x=4.395 \
 //y=3.51 //x2=3.82 //y2=0.175
cc_229 ( N_noxref_1_c_167_p N_GND_c_2678_n ) capacitor c=0.00788922f //x=4.56 \
 //y=2.265 //x2=3.82 //y2=0.175
cc_230 ( N_noxref_1_c_176_p N_GND_c_2678_n ) capacitor c=0.00427677f //x=4.67 \
 //y=2.1 //x2=3.82 //y2=0.175
cc_231 ( N_noxref_1_c_171_p N_GND_c_2678_n ) capacitor c=0.00688205f //x=4.56 \
 //y=2.265 //x2=3.82 //y2=0.175
cc_232 ( N_noxref_1_c_167_p N_GND_c_2686_n ) capacitor c=0.00230732f //x=4.56 \
 //y=2.265 //x2=6.04 //y2=0.175
cc_233 ( N_noxref_1_c_45_p N_GND_c_2687_n ) capacitor c=2.83275e-19 //x=2.64 \
 //y=1.18 //x2=16.51 //y2=0.175
cc_234 ( N_noxref_1_c_45_p N_GND_M0_noxref_d ) capacitor c=2.82748e-19 \
 //x=2.64 //y=1.18 //x2=1.48 //y2=1.045
cc_235 ( N_noxref_1_c_58_p N_GND_M2_noxref_s ) capacitor c=8.20337e-19 \
 //x=4.56 //y=3.67 //x2=4.315 //y2=0.55
cc_236 ( N_noxref_1_c_165_p N_GND_M2_noxref_s ) capacitor c=0.00297876f \
 //x=4.56 //y=2.265 //x2=4.315 //y2=0.55
cc_237 ( N_noxref_1_c_167_p N_GND_M2_noxref_s ) capacitor c=0.00651326f \
 //x=4.56 //y=2.265 //x2=4.315 //y2=0.55
cc_238 ( N_noxref_1_c_192_p N_GND_M2_noxref_s ) capacitor c=0.0300814f \
 //x=4.67 //y=1.09 //x2=4.315 //y2=0.55
cc_239 ( N_noxref_1_c_175_p N_GND_M2_noxref_s ) capacitor c=0.002132f //x=4.67 \
 //y=1.745 //x2=4.315 //y2=0.55
cc_240 ( N_noxref_1_c_176_p N_GND_M2_noxref_s ) capacitor c=0.00304786f \
 //x=4.67 //y=2.1 //x2=4.315 //y2=0.55
cc_241 ( N_noxref_1_c_194_p N_GND_M2_noxref_s ) capacitor c=0.00517463f \
 //x=5.045 //y=0.935 //x2=4.315 //y2=0.55
cc_242 ( N_noxref_1_c_196_p N_GND_M2_noxref_s ) capacitor c=0.0153553f //x=5.2 \
 //y=1.09 //x2=4.315 //y2=0.55
cc_243 ( N_noxref_1_c_178_p N_GND_M2_noxref_s ) capacitor c=0.00629878f \
 //x=5.2 //y=1.435 //x2=4.315 //y2=0.55
cc_244 ( N_noxref_1_c_171_p N_GND_M2_noxref_s ) capacitor c=0.00405173f \
 //x=4.56 //y=2.265 //x2=4.315 //y2=0.55
cc_245 ( N_noxref_1_c_42_p N_noxref_12_c_3017_n ) capacitor c=0.0103386f \
 //x=2.725 //y=1.835 //x2=2.155 //y2=1.675
cc_246 ( N_noxref_1_c_28_p N_noxref_12_c_3018_n ) capacitor c=0.00373013f \
 //x=2.995 //y=1.835 //x2=3.04 //y2=0.71
cc_247 ( N_noxref_1_c_45_p N_noxref_12_c_3018_n ) capacitor c=0.003751f \
 //x=2.64 //y=1.18 //x2=3.04 //y2=0.71
cc_248 ( N_noxref_1_M1_noxref_d N_noxref_12_c_3018_n ) capacitor c=0.00910163f \
 //x=2.45 //y=1.085 //x2=3.04 //y2=0.71
cc_249 ( N_noxref_1_c_27_p N_noxref_12_M0_noxref_s ) capacitor c=0.017321f \
 //x=2.64 //y=1.75 //x2=1.05 //y2=0.545
cc_250 ( N_noxref_1_c_28_p N_noxref_12_M0_noxref_s ) capacitor c=0.00640979f \
 //x=2.995 //y=1.835 //x2=1.05 //y2=0.545
cc_251 ( N_noxref_1_c_33_p N_noxref_12_M0_noxref_s ) capacitor c=4.17069e-19 \
 //x=3.08 //y=3.67 //x2=1.05 //y2=0.545
cc_252 ( N_noxref_1_c_45_p N_noxref_12_M0_noxref_s ) capacitor c=0.0090315f \
 //x=2.64 //y=1.18 //x2=1.05 //y2=0.545
cc_253 ( N_noxref_1_c_36_p N_noxref_12_M0_noxref_s ) capacitor c=0.0010514f \
 //x=3.08 //y=3.51 //x2=1.05 //y2=0.545
cc_254 ( N_noxref_1_M1_noxref_d N_noxref_12_M0_noxref_s ) capacitor \
 c=0.0275552f //x=2.45 //y=1.085 //x2=1.05 //y2=0.545
cc_255 ( N_A_c_281_p N_noxref_3_c_639_n ) capacitor c=0.00107851f //x=6.89 \
 //y=1.435 //x2=7.15 //y2=1.935
cc_256 ( N_A_c_282_p N_noxref_3_c_639_n ) capacitor c=0.00522452f //x=6.89 \
 //y=1.745 //x2=7.15 //y2=1.935
cc_257 ( N_A_c_283_p N_noxref_3_c_639_n ) capacitor c=0.00384134f //x=6.89 \
 //y=2.1 //x2=7.15 //y2=1.935
cc_258 ( N_A_c_284_p N_noxref_3_c_639_n ) capacitor c=0.00918878f //x=7.265 \
 //y=1.59 //x2=7.15 //y2=1.935
cc_259 ( N_A_c_285_p N_noxref_3_c_639_n ) capacitor c=0.00344663f //x=7.42 \
 //y=1.435 //x2=7.15 //y2=1.935
cc_260 ( N_A_c_286_p N_noxref_3_c_641_n ) capacitor c=6.95554e-19 //x=9.205 \
 //y=4.255 //x2=7.155 //y2=5.42
cc_261 ( N_A_M15_noxref_g N_noxref_3_c_641_n ) capacitor c=0.00141266f \
 //x=6.935 //y=6.2 //x2=7.155 //y2=5.42
cc_262 ( N_A_M16_noxref_g N_noxref_3_c_641_n ) capacitor c=0.00352414f \
 //x=7.375 //y=6.2 //x2=7.155 //y2=5.42
cc_263 ( N_A_c_284_p N_noxref_3_c_652_n ) capacitor c=0.00180253f //x=7.265 \
 //y=1.59 //x2=7.435 //y2=2.02
cc_264 ( N_A_c_290_p N_noxref_3_c_642_n ) capacitor c=0.00384134f //x=6.78 \
 //y=2.265 //x2=7.235 //y2=2.02
cc_265 ( N_A_M16_noxref_g N_noxref_3_c_654_n ) capacitor c=0.00958461f \
 //x=7.375 //y=6.2 //x2=7.435 //y2=5.14
cc_266 ( N_A_c_286_p N_noxref_3_c_643_n ) capacitor c=0.0134401f //x=9.205 \
 //y=4.255 //x2=7.24 //y2=5.14
cc_267 ( N_A_M15_noxref_g N_noxref_3_c_643_n ) capacitor c=0.00439203f \
 //x=6.935 //y=6.2 //x2=7.24 //y2=5.14
cc_268 ( N_A_c_294_p N_noxref_3_c_643_n ) capacitor c=0.00262283f //x=7.3 \
 //y=4.97 //x2=7.24 //y2=5.14
cc_269 ( A N_noxref_3_c_658_n ) capacitor c=0.00741005f //x=6.78 //y=2.77 \
 //x2=7.52 //y2=2.61
cc_270 ( A N_noxref_3_c_658_n ) capacitor c=0.00298036f //x=9.37 //y=3.14 \
 //x2=7.52 //y2=2.61
cc_271 ( N_A_c_297_p N_noxref_3_c_658_n ) capacitor c=0.00495348f //x=9.37 \
 //y=2.42 //x2=7.52 //y2=2.61
cc_272 ( N_A_c_298_p N_noxref_3_c_658_n ) capacitor c=0.017436f //x=6.78 \
 //y=2.265 //x2=7.52 //y2=2.61
cc_273 ( N_A_c_299_p N_noxref_3_c_658_n ) capacitor c=4.71798e-19 //x=6.78 \
 //y=2.265 //x2=7.52 //y2=2.61
cc_274 ( N_A_c_290_p N_noxref_3_c_658_n ) capacitor c=0.00270592f //x=6.78 \
 //y=2.265 //x2=7.52 //y2=2.61
cc_275 ( A N_noxref_3_c_664_n ) capacitor c=0.0148501f //x=6.78 //y=2.77 \
 //x2=7.52 //y2=2.93
cc_276 ( A N_noxref_3_c_664_n ) capacitor c=0.00251111f //x=9.37 //y=3.14 \
 //x2=7.52 //y2=2.93
cc_277 ( A N_noxref_3_c_666_n ) capacitor c=0.051025f //x=6.78 //y=2.77 \
 //x2=7.52 //y2=5.055
cc_278 ( A N_noxref_3_c_666_n ) capacitor c=0.0143307f //x=6.78 //y=4.62 \
 //x2=7.52 //y2=5.055
cc_279 ( A N_noxref_3_c_666_n ) capacitor c=0.0197107f //x=9.37 //y=3.14 \
 //x2=7.52 //y2=5.055
cc_280 ( A N_noxref_3_c_666_n ) capacitor c=0.00539064f //x=9.37 //y=4.62 \
 //x2=7.52 //y2=5.055
cc_281 ( A N_noxref_3_c_666_n ) capacitor c=5.56854e-19 //x=6.78 //y=4.25 \
 //x2=7.52 //y2=5.055
cc_282 ( N_A_c_308_p N_noxref_3_c_666_n ) capacitor c=0.0173413f //x=6.78 \
 //y=4.41 //x2=7.52 //y2=5.055
cc_283 ( N_A_c_309_p N_noxref_3_c_666_n ) capacitor c=0.016653f //x=6.78 \
 //y=4.76 //x2=7.52 //y2=5.055
cc_284 ( N_A_c_310_p N_noxref_3_c_666_n ) capacitor c=0.00250563f //x=9.37 \
 //y=4.415 //x2=7.52 //y2=5.055
cc_285 ( N_A_c_311_p N_noxref_3_c_666_n ) capacitor c=0.0043276f //x=9.37 \
 //y=4.765 //x2=7.52 //y2=5.055
cc_286 ( N_A_c_312_p N_noxref_3_c_666_n ) capacitor c=0.0032735f //x=6.94 \
 //y=4.25 //x2=7.52 //y2=5.055
cc_287 ( N_A_c_313_p N_noxref_3_c_666_n ) capacitor c=0.00158465f //x=9.365 \
 //y=4.255 //x2=7.52 //y2=5.055
cc_288 ( N_A_c_286_p N_noxref_3_c_666_n ) capacitor c=0.0267757f //x=9.205 \
 //y=4.255 //x2=7.52 //y2=5.055
cc_289 ( N_A_c_315_p N_noxref_3_c_666_n ) capacitor c=0.00152249f //x=6.78 \
 //y=4.88 //x2=7.52 //y2=5.055
cc_290 ( N_A_c_294_p N_noxref_3_c_666_n ) capacitor c=0.00208693f //x=7.3 \
 //y=4.97 //x2=7.52 //y2=5.055
cc_291 ( N_A_c_317_p N_noxref_3_c_666_n ) capacitor c=0.00140024f //x=7.01 \
 //y=4.97 //x2=7.52 //y2=5.055
cc_292 ( N_A_c_318_p N_noxref_3_c_681_n ) capacitor c=0.00174488f //x=6.89 \
 //y=1.09 //x2=7.15 //y2=1.185
cc_293 ( N_A_c_281_p N_noxref_3_c_681_n ) capacitor c=0.00350474f //x=6.89 \
 //y=1.435 //x2=7.15 //y2=1.185
cc_294 ( N_A_c_320_p N_noxref_3_c_681_n ) capacitor c=5.57924e-19 //x=7.265 \
 //y=0.935 //x2=7.15 //y2=1.185
cc_295 ( N_A_c_284_p N_noxref_3_c_681_n ) capacitor c=5.75878e-19 //x=7.265 \
 //y=1.59 //x2=7.15 //y2=1.185
cc_296 ( N_A_c_322_p N_noxref_3_c_681_n ) capacitor c=0.00148359f //x=7.42 \
 //y=1.09 //x2=7.15 //y2=1.185
cc_297 ( N_A_c_285_p N_noxref_3_c_681_n ) capacitor c=0.00356717f //x=7.42 \
 //y=1.435 //x2=7.15 //y2=1.185
cc_298 ( A N_noxref_3_c_687_n ) capacitor c=6.15063e-19 //x=6.78 //y=2.77 \
 //x2=7.52 //y2=2.77
cc_299 ( A N_noxref_3_c_688_n ) capacitor c=0.00686827f //x=6.78 //y=2.77 \
 //x2=7.68 //y2=2.77
cc_300 ( A N_noxref_3_c_688_n ) capacitor c=0.0015808f //x=9.37 //y=3.14 \
 //x2=7.68 //y2=2.77
cc_301 ( A N_noxref_3_c_690_n ) capacitor c=0.0326899f //x=9.37 //y=3.14 \
 //x2=13.635 //y2=2.755
cc_302 ( N_A_c_297_p N_noxref_3_c_690_n ) capacitor c=0.00431408f //x=9.37 \
 //y=2.42 //x2=13.635 //y2=2.755
cc_303 ( N_A_c_286_p N_noxref_3_c_690_n ) capacitor c=0.00530424f //x=9.205 \
 //y=4.255 //x2=13.635 //y2=2.755
cc_304 ( N_A_M15_noxref_g N_noxref_3_c_693_n ) capacitor c=0.0162066f \
 //x=6.935 //y=6.2 //x2=7.155 //y2=5.56
cc_305 ( N_A_M16_noxref_g N_noxref_3_c_693_n ) capacitor c=0.0162066f \
 //x=7.375 //y=6.2 //x2=7.155 //y2=5.56
cc_306 ( N_A_c_294_p N_noxref_3_c_693_n ) capacitor c=0.00290963f //x=7.3 \
 //y=4.97 //x2=7.155 //y2=5.56
cc_307 ( N_A_c_318_p N_noxref_3_M3_noxref_d ) capacitor c=0.00137914f //x=6.89 \
 //y=1.09 //x2=6.965 //y2=1.09
cc_308 ( N_A_c_281_p N_noxref_3_M3_noxref_d ) capacitor c=0.0023891f //x=6.89 \
 //y=1.435 //x2=6.965 //y2=1.09
cc_309 ( N_A_c_320_p N_noxref_3_M3_noxref_d ) capacitor c=0.0020782f //x=7.265 \
 //y=0.935 //x2=6.965 //y2=1.09
cc_310 ( N_A_c_284_p N_noxref_3_M3_noxref_d ) capacitor c=0.00356097f \
 //x=7.265 //y=1.59 //x2=6.965 //y2=1.09
cc_311 ( N_A_c_322_p N_noxref_3_M3_noxref_d ) capacitor c=0.00138452f //x=7.42 \
 //y=1.09 //x2=6.965 //y2=1.09
cc_312 ( N_A_c_285_p N_noxref_3_M3_noxref_d ) capacitor c=0.00235934f //x=7.42 \
 //y=1.435 //x2=6.965 //y2=1.09
cc_313 ( A SUM ) capacitor c=0.0119329f //x=9.37 //y=3.14 //x2=10.97 //y2=2.4
cc_314 ( A SUM ) capacitor c=2.17357e-19 //x=9.37 //y=4.62 //x2=10.97 //y2=4.99
cc_315 ( A N_noxref_5_c_1240_n ) capacitor c=0.00146181f //x=9.37 //y=4.62 \
 //x2=10.48 //y2=4.765
cc_316 ( N_A_c_311_p N_noxref_5_c_1240_n ) capacitor c=0.00453933f //x=9.37 \
 //y=4.765 //x2=10.48 //y2=4.765
cc_317 ( N_A_c_343_p N_noxref_5_c_1240_n ) capacitor c=8.48688e-19 //x=9.37 \
 //y=4.88 //x2=10.48 //y2=4.765
cc_318 ( N_A_c_344_p N_noxref_5_c_1240_n ) capacitor c=0.00135672f //x=9.37 \
 //y=4.88 //x2=10.48 //y2=4.765
cc_319 ( A N_noxref_5_c_1244_n ) capacitor c=0.00506587f //x=9.37 //y=4.25 \
 //x2=10.525 //y2=4.415
cc_320 ( A N_noxref_5_c_1245_n ) capacitor c=4.16726e-19 //x=9.37 //y=4.62 \
 //x2=10.48 //y2=4.88
cc_321 ( N_A_c_311_p N_noxref_5_c_1245_n ) capacitor c=3.31511e-19 //x=9.37 \
 //y=4.765 //x2=10.48 //y2=4.88
cc_322 ( N_A_c_343_p N_noxref_5_c_1245_n ) capacitor c=0.00113696f //x=9.37 \
 //y=4.88 //x2=10.48 //y2=4.88
cc_323 ( N_A_c_344_p N_noxref_5_c_1245_n ) capacitor c=0.00195576f //x=9.37 \
 //y=4.88 //x2=10.48 //y2=4.88
cc_324 ( N_A_M17_noxref_g N_noxref_5_M19_noxref_g ) capacitor c=0.0102032f \
 //x=9.27 //y=6.2 //x2=10.15 //y2=6.2
cc_325 ( N_A_M18_noxref_g N_noxref_5_M19_noxref_g ) capacitor c=0.0618855f \
 //x=9.71 //y=6.2 //x2=10.15 //y2=6.2
cc_326 ( N_A_M18_noxref_g N_noxref_5_M20_noxref_g ) capacitor c=0.00945236f \
 //x=9.71 //y=6.2 //x2=10.59 //y2=6.2
cc_327 ( N_A_c_311_p N_noxref_5_c_1252_n ) capacitor c=0.0012806f //x=9.37 \
 //y=4.765 //x2=10.48 //y2=4.88
cc_328 ( N_A_c_343_p N_noxref_5_c_1252_n ) capacitor c=0.0019442f //x=9.37 \
 //y=4.88 //x2=10.48 //y2=4.88
cc_329 ( N_A_c_344_p N_noxref_5_c_1252_n ) capacitor c=0.067621f //x=9.37 \
 //y=4.88 //x2=10.48 //y2=4.88
cc_330 ( A B ) capacitor c=0.0602426f //x=1.6 //y=2.77 //x2=2.34 //y2=2.77
cc_331 ( N_A_c_357_p B ) capacitor c=3.49899e-19 //x=1.6 //y=2.26 //x2=2.34 \
 //y2=2.77
cc_332 ( A B ) capacitor c=0.00287935f //x=1.6 //y=2.77 //x2=2.34 //y2=4.62
cc_333 ( A B ) capacitor c=0.0145105f //x=1.6 //y=4.62 //x2=2.34 //y2=4.62
cc_334 ( A B ) capacitor c=6.18664e-19 //x=1.6 //y=4.25 //x2=2.34 //y2=4.62
cc_335 ( N_A_c_261_n B ) capacitor c=0.0177262f //x=1.6 //y=4.41 //x2=2.34 \
 //y2=4.62
cc_336 ( N_A_c_265_n B ) capacitor c=0.0228266f //x=6.62 //y=4.25 //x2=2.34 \
 //y2=4.62
cc_337 ( N_A_c_271_n B ) capacitor c=0.0032735f //x=1.76 //y=4.25 //x2=2.34 \
 //y2=4.62
cc_338 ( N_A_c_272_n B ) capacitor c=3.02466e-19 //x=1.6 //y=4.88 //x2=2.34 \
 //y2=4.62
cc_339 ( N_A_c_279_n B ) capacitor c=0.00108965f //x=1.6 //y=4.88 //x2=2.34 \
 //y2=4.62
cc_340 ( A B ) capacitor c=0.00557479f //x=1.6 //y=2.77 //x2=2.34 //y2=3.88
cc_341 ( A B ) capacitor c=0.0200789f //x=9.37 //y=3.14 //x2=10.11 //y2=3.88
cc_342 ( A B ) capacitor c=0.00989192f //x=9.37 //y=4.62 //x2=10.11 //y2=3.88
cc_343 ( A B ) capacitor c=5.36056e-19 //x=9.37 //y=4.25 //x2=10.11 //y2=3.88
cc_344 ( N_A_c_310_p B ) capacitor c=0.0142591f //x=9.37 //y=4.415 //x2=10.11 \
 //y2=3.88
cc_345 ( N_A_c_313_p B ) capacitor c=0.00283049f //x=9.365 //y=4.255 \
 //x2=10.11 //y2=3.88
cc_346 ( A B ) capacitor c=0.00832877f //x=9.37 //y=3.14 //x2=10.48 //y2=3.14
cc_347 ( A N_B_c_1543_n ) capacitor c=0.0150245f //x=1.6 //y=2.77 //x2=2.34 \
 //y2=4.025
cc_348 ( N_A_c_265_n N_B_c_1543_n ) capacitor c=0.00525429f //x=6.62 //y=4.25 \
 //x2=2.34 //y2=4.025
cc_349 ( N_A_c_263_n N_B_c_1549_n ) capacitor c=0.0172958f //x=1.6 //y=4.88 \
 //x2=2.34 //y2=4.735
cc_350 ( N_A_c_265_n N_B_c_1549_n ) capacitor c=0.00234208f //x=6.62 //y=4.25 \
 //x2=2.34 //y2=4.735
cc_351 ( N_A_c_272_n N_B_c_1549_n ) capacitor c=4.73677e-19 //x=1.6 //y=4.88 \
 //x2=2.34 //y2=4.735
cc_352 ( N_A_c_279_n N_B_c_1549_n ) capacitor c=9.22067e-19 //x=1.6 //y=4.88 \
 //x2=2.34 //y2=4.735
cc_353 ( N_A_c_297_p N_B_c_1625_n ) capacitor c=0.012348f //x=9.37 //y=2.42 \
 //x2=10.48 //y2=2.415
cc_354 ( N_A_c_380_p N_B_c_1625_n ) capacitor c=4.19574e-19 //x=9.37 //y=2.265 \
 //x2=10.48 //y2=2.415
cc_355 ( N_A_c_381_p N_B_c_1625_n ) capacitor c=0.00149735f //x=9.175 //y=2.1 \
 //x2=10.48 //y2=2.415
cc_356 ( A N_B_c_1628_n ) capacitor c=0.0134937f //x=9.37 //y=3.14 //x2=10.48 \
 //y2=2.995
cc_357 ( N_A_c_297_p N_B_c_1628_n ) capacitor c=2.06286e-19 //x=9.37 //y=2.42 \
 //x2=10.48 //y2=2.995
cc_358 ( N_A_c_384_p N_B_c_1551_n ) capacitor c=0.0205342f //x=1.6 //y=2.26 \
 //x2=2.34 //y2=2.26
cc_359 ( N_A_c_357_p N_B_c_1551_n ) capacitor c=5.16867e-19 //x=1.6 //y=2.26 \
 //x2=2.34 //y2=2.26
cc_360 ( N_A_c_386_p N_B_c_1551_n ) capacitor c=0.00167888f //x=1.405 \
 //y=2.095 //x2=2.34 //y2=2.26
cc_361 ( N_A_c_265_n N_B_c_1552_n ) capacitor c=0.0856328f //x=6.62 //y=4.25 \
 //x2=2.695 //y2=3.88
cc_362 ( N_A_c_265_n N_B_c_1557_n ) capacitor c=0.0810827f //x=6.62 //y=4.25 \
 //x2=3.295 //y2=3.895
cc_363 ( N_A_c_265_n N_B_c_1560_n ) capacitor c=0.0606196f //x=6.62 //y=4.25 \
 //x2=4.17 //y2=3.88
cc_364 ( N_A_c_265_n N_B_c_1564_n ) capacitor c=0.154103f //x=6.62 //y=4.25 \
 //x2=4.77 //y2=3.895
cc_365 ( A N_B_c_1637_n ) capacitor c=4.2882e-19 //x=6.78 //y=2.77 //x2=6.395 \
 //y2=3.88
cc_366 ( N_A_c_265_n N_B_c_1637_n ) capacitor c=0.013157f //x=6.62 //y=4.25 \
 //x2=6.395 //y2=3.88
cc_367 ( A N_B_c_1639_n ) capacitor c=0.0277306f //x=6.78 //y=2.77 //x2=6.995 \
 //y2=3.865
cc_368 ( N_A_c_308_p N_B_c_1639_n ) capacitor c=0.00825178f //x=6.78 //y=4.41 \
 //x2=6.995 //y2=3.865
cc_369 ( N_A_c_298_p N_B_c_1639_n ) capacitor c=0.00207471f //x=6.78 //y=2.265 \
 //x2=6.995 //y2=3.865
cc_370 ( N_A_c_312_p N_B_c_1639_n ) capacitor c=0.0374977f //x=6.94 //y=4.25 \
 //x2=6.995 //y2=3.865
cc_371 ( N_A_c_286_p N_B_c_1639_n ) capacitor c=0.199793f //x=9.205 //y=4.255 \
 //x2=6.995 //y2=3.865
cc_372 ( A N_B_c_1644_n ) capacitor c=3.08546e-19 //x=9.37 //y=3.14 //x2=8.98 \
 //y2=3.88
cc_373 ( N_A_c_310_p N_B_c_1644_n ) capacitor c=0.00235777f //x=9.37 //y=4.415 \
 //x2=8.98 //y2=3.88
cc_374 ( N_A_c_286_p N_B_c_1644_n ) capacitor c=0.0115653f //x=9.205 //y=4.255 \
 //x2=8.98 //y2=3.88
cc_375 ( A N_B_c_1647_n ) capacitor c=0.025596f //x=9.37 //y=3.14 //x2=9.58 \
 //y2=3.87
cc_376 ( N_A_c_310_p N_B_c_1647_n ) capacitor c=0.00505577f //x=9.37 //y=4.415 \
 //x2=9.58 //y2=3.87
cc_377 ( N_A_c_313_p N_B_c_1647_n ) capacitor c=0.0368432f //x=9.365 //y=4.255 \
 //x2=9.58 //y2=3.87
cc_378 ( A N_B_c_1650_n ) capacitor c=0.00157657f //x=9.37 //y=3.14 //x2=10.11 \
 //y2=4.96
cc_379 ( A N_B_c_1650_n ) capacitor c=0.00792111f //x=9.37 //y=4.62 //x2=10.11 \
 //y2=4.96
cc_380 ( N_A_c_310_p N_B_c_1650_n ) capacitor c=0.00307522f //x=9.37 //y=4.415 \
 //x2=10.11 //y2=4.96
cc_381 ( N_A_c_311_p N_B_c_1650_n ) capacitor c=0.00860703f //x=9.37 //y=4.765 \
 //x2=10.11 //y2=4.96
cc_382 ( N_A_c_313_p N_B_c_1650_n ) capacitor c=0.015409f //x=9.365 //y=4.255 \
 //x2=10.11 //y2=4.96
cc_383 ( N_A_c_311_p N_B_c_1655_n ) capacitor c=0.00114781f //x=9.37 //y=4.765 \
 //x2=10.195 //y2=5.045
cc_384 ( A N_B_c_1566_n ) capacitor c=0.00693848f //x=1.6 //y=2.77 //x2=2.505 \
 //y2=3.865
cc_385 ( N_A_c_265_n N_B_c_1566_n ) capacitor c=0.0374977f //x=6.62 //y=4.25 \
 //x2=2.505 //y2=3.865
cc_386 ( A N_B_c_1658_n ) capacitor c=0.00330338f //x=9.37 //y=3.14 \
 //x2=10.105 //y2=3.87
cc_387 ( A N_B_c_1659_n ) capacitor c=0.00513442f //x=9.37 //y=3.14 //x2=10.64 \
 //y2=3.155
cc_388 ( A N_B_c_1567_n ) capacitor c=3.49899e-19 //x=1.6 //y=2.77 //x2=2.34 \
 //y2=2.26
cc_389 ( N_A_c_384_p N_B_c_1567_n ) capacitor c=0.00370824f //x=1.6 //y=2.26 \
 //x2=2.34 //y2=2.26
cc_390 ( N_A_c_357_p N_B_c_1567_n ) capacitor c=0.00445529f //x=1.6 //y=2.26 \
 //x2=2.34 //y2=2.26
cc_391 ( N_A_c_386_p N_B_c_1567_n ) capacitor c=0.00267961f //x=1.405 \
 //y=2.095 //x2=2.34 //y2=2.26
cc_392 ( A N_B_c_1568_n ) capacitor c=2.1563e-19 //x=1.6 //y=4.62 //x2=2.37 \
 //y2=4.88
cc_393 ( N_A_c_263_n N_B_c_1568_n ) capacitor c=0.00389736f //x=1.6 //y=4.88 \
 //x2=2.37 //y2=4.88
cc_394 ( N_A_c_272_n N_B_c_1568_n ) capacitor c=0.00397338f //x=1.6 //y=4.88 \
 //x2=2.37 //y2=4.88
cc_395 ( N_A_c_279_n N_B_c_1568_n ) capacitor c=0.00283894f //x=1.6 //y=4.88 \
 //x2=2.37 //y2=4.88
cc_396 ( N_A_c_297_p N_B_c_1668_n ) capacitor c=5.56121e-19 //x=9.37 //y=2.42 \
 //x2=10.48 //y2=2.265
cc_397 ( N_A_c_380_p N_B_c_1668_n ) capacitor c=0.00114269f //x=9.37 //y=2.265 \
 //x2=10.48 //y2=2.265
cc_398 ( N_A_c_381_p N_B_c_1668_n ) capacitor c=0.00187625f //x=9.175 //y=2.1 \
 //x2=10.48 //y2=2.265
cc_399 ( N_A_M9_noxref_g N_B_M11_noxref_g ) capacitor c=0.0104892f //x=1.5 \
 //y=6.2 //x2=2.38 //y2=6.2
cc_400 ( N_A_M10_noxref_g N_B_M11_noxref_g ) capacitor c=0.107636f //x=1.94 \
 //y=6.2 //x2=2.38 //y2=6.2
cc_401 ( N_A_M10_noxref_g N_B_M12_noxref_g ) capacitor c=0.0100341f //x=1.94 \
 //y=6.2 //x2=2.82 //y2=6.2
cc_402 ( N_A_c_428_p N_B_c_1576_n ) capacitor c=4.86545e-19 //x=1.405 \
 //y=1.045 //x2=2.375 //y2=1.085
cc_403 ( N_A_c_429_p N_B_c_1576_n ) capacitor c=0.00152405f //x=1.405 //y=1.39 \
 //x2=2.375 //y2=1.085
cc_404 ( N_A_c_430_p N_B_c_1576_n ) capacitor c=0.0151475f //x=1.935 //y=1.045 \
 //x2=2.375 //y2=1.085
cc_405 ( N_A_c_431_p N_B_c_1578_n ) capacitor c=0.00109982f //x=1.405 //y=1.7 \
 //x2=2.375 //y2=1.43
cc_406 ( N_A_c_432_p N_B_c_1578_n ) capacitor c=0.0111064f //x=1.935 //y=1.39 \
 //x2=2.375 //y2=1.43
cc_407 ( N_A_c_431_p N_B_c_1581_n ) capacitor c=9.58243e-19 //x=1.405 //y=1.7 \
 //x2=2.375 //y2=1.74
cc_408 ( N_A_c_386_p N_B_c_1581_n ) capacitor c=0.00662747f //x=1.405 \
 //y=2.095 //x2=2.375 //y2=1.74
cc_409 ( N_A_c_432_p N_B_c_1581_n ) capacitor c=0.00862358f //x=1.935 //y=1.39 \
 //x2=2.375 //y2=1.74
cc_410 ( N_A_c_430_p N_B_c_1591_n ) capacitor c=0.00127211f //x=1.935 \
 //y=1.045 //x2=2.905 //y2=1.085
cc_411 ( N_A_c_432_p N_B_c_1593_n ) capacitor c=0.00204774f //x=1.935 //y=1.39 \
 //x2=2.905 //y2=1.43
cc_412 ( N_A_c_438_p N_B_c_1684_n ) capacitor c=4.86545e-19 //x=9.175 //y=1.05 \
 //x2=10.145 //y2=1.09
cc_413 ( N_A_c_439_p N_B_c_1684_n ) capacitor c=0.00152405f //x=9.175 \
 //y=1.395 //x2=10.145 //y2=1.09
cc_414 ( N_A_c_440_p N_B_c_1684_n ) capacitor c=0.0157772f //x=9.705 //y=1.05 \
 //x2=10.145 //y2=1.09
cc_415 ( N_A_c_441_p N_B_c_1687_n ) capacitor c=0.00109982f //x=9.175 \
 //y=1.705 //x2=10.145 //y2=1.435
cc_416 ( N_A_c_442_p N_B_c_1687_n ) capacitor c=0.0117362f //x=9.705 //y=1.395 \
 //x2=10.145 //y2=1.435
cc_417 ( N_A_c_441_p N_B_c_1689_n ) capacitor c=9.58243e-19 //x=9.175 \
 //y=1.705 //x2=10.145 //y2=1.745
cc_418 ( N_A_c_381_p N_B_c_1689_n ) capacitor c=0.00662747f //x=9.175 //y=2.1 \
 //x2=10.145 //y2=1.745
cc_419 ( N_A_c_442_p N_B_c_1689_n ) capacitor c=0.00862358f //x=9.705 \
 //y=1.395 //x2=10.145 //y2=1.745
cc_420 ( N_A_c_297_p N_B_c_1692_n ) capacitor c=0.00170155f //x=9.37 //y=2.42 \
 //x2=10.145 //y2=2.1
cc_421 ( N_A_c_380_p N_B_c_1692_n ) capacitor c=0.00214703f //x=9.37 //y=2.265 \
 //x2=10.145 //y2=2.1
cc_422 ( N_A_c_381_p N_B_c_1692_n ) capacitor c=0.012184f //x=9.175 //y=2.1 \
 //x2=10.145 //y2=2.1
cc_423 ( N_A_c_440_p N_B_c_1695_n ) capacitor c=0.00127211f //x=9.705 //y=1.05 \
 //x2=10.675 //y2=1.09
cc_424 ( N_A_c_442_p N_B_c_1696_n ) capacitor c=0.00204774f //x=9.705 \
 //y=1.395 //x2=10.675 //y2=1.435
cc_425 ( N_A_c_384_p N_B_c_1597_n ) capacitor c=0.00167305f //x=1.6 //y=2.26 \
 //x2=2.34 //y2=2.26
cc_426 ( N_A_c_357_p N_B_c_1597_n ) capacitor c=0.00266443f //x=1.6 //y=2.26 \
 //x2=2.34 //y2=2.26
cc_427 ( N_A_c_386_p N_B_c_1597_n ) capacitor c=0.0181449f //x=1.405 //y=2.095 \
 //x2=2.34 //y2=2.26
cc_428 ( N_A_c_263_n N_B_c_1600_n ) capacitor c=0.00158715f //x=1.6 //y=4.88 \
 //x2=2.37 //y2=4.88
cc_429 ( N_A_c_272_n N_B_c_1600_n ) capacitor c=0.00237977f //x=1.6 //y=4.88 \
 //x2=2.37 //y2=4.88
cc_430 ( N_A_c_279_n N_B_c_1600_n ) capacitor c=0.0297875f //x=1.6 //y=4.88 \
 //x2=2.37 //y2=4.88
cc_431 ( N_A_c_308_p N_VDD_c_2034_n ) capacitor c=3.15774e-19 //x=6.78 \
 //y=4.41 //x2=9.405 //y2=7.585
cc_432 ( N_A_c_309_p N_VDD_c_2034_n ) capacitor c=5.73987e-19 //x=6.78 \
 //y=4.76 //x2=9.405 //y2=7.585
cc_433 ( N_A_c_263_n N_VDD_c_2034_n ) capacitor c=9.07241e-19 //x=1.6 //y=4.88 \
 //x2=9.405 //y2=7.585
cc_434 ( N_A_c_272_n N_VDD_c_2034_n ) capacitor c=6.22888e-19 //x=1.6 //y=4.88 \
 //x2=9.405 //y2=7.585
cc_435 ( N_A_c_315_p N_VDD_c_2034_n ) capacitor c=3.40755e-19 //x=6.78 \
 //y=4.88 //x2=9.405 //y2=7.585
cc_436 ( N_A_M17_noxref_g N_VDD_c_2098_n ) capacitor c=0.00404722f //x=9.27 \
 //y=6.2 //x2=9.49 //y2=6.7
cc_437 ( N_A_M18_noxref_g N_VDD_c_2098_n ) capacitor c=0.00381678f //x=9.71 \
 //y=6.2 //x2=9.49 //y2=6.7
cc_438 ( N_A_M17_noxref_g N_VDD_c_2100_n ) capacitor c=0.00543844f //x=9.27 \
 //y=6.2 //x2=9.49 //y2=7.41
cc_439 ( N_A_M18_noxref_g N_VDD_c_2100_n ) capacitor c=0.00573531f //x=9.71 \
 //y=6.2 //x2=9.49 //y2=7.41
cc_440 ( N_A_c_263_n N_VDD_c_2045_n ) capacitor c=6.28113e-19 //x=1.6 //y=4.88 \
 //x2=2.075 //y2=7.585
cc_441 ( N_A_M9_noxref_g N_VDD_c_2045_n ) capacitor c=0.00732618f //x=1.5 \
 //y=6.2 //x2=2.075 //y2=7.585
cc_442 ( N_A_M10_noxref_g N_VDD_c_2045_n ) capacitor c=0.00755544f //x=1.94 \
 //y=6.2 //x2=2.075 //y2=7.585
cc_443 ( N_A_c_308_p N_VDD_c_2105_n ) capacitor c=2.9011e-19 //x=6.78 //y=4.41 \
 //x2=7.51 //y2=7.585
cc_444 ( N_A_c_309_p N_VDD_c_2105_n ) capacitor c=5.49211e-19 //x=6.78 \
 //y=4.76 //x2=7.51 //y2=7.585
cc_445 ( N_A_M15_noxref_g N_VDD_c_2105_n ) capacitor c=0.00753931f //x=6.935 \
 //y=6.2 //x2=7.51 //y2=7.585
cc_446 ( N_A_M16_noxref_g N_VDD_c_2105_n ) capacitor c=0.00755544f //x=7.375 \
 //y=6.2 //x2=7.51 //y2=7.585
cc_447 ( N_A_M17_noxref_g N_VDD_c_2109_n ) capacitor c=0.00732618f //x=9.27 \
 //y=6.2 //x2=11.42 //y2=7.585
cc_448 ( N_A_M18_noxref_g N_VDD_c_2109_n ) capacitor c=0.00773472f //x=9.71 \
 //y=6.2 //x2=11.42 //y2=7.585
cc_449 ( A N_VDD_c_2056_n ) capacitor c=0.00749832f //x=1.6 //y=4.62 //x2=1.23 \
 //y2=7.58
cc_450 ( A N_VDD_c_2056_n ) capacitor c=0.00215102f //x=1.6 //y=4.25 //x2=1.23 \
 //y2=7.58
cc_451 ( N_A_c_261_n N_VDD_c_2056_n ) capacitor c=0.00173827f //x=1.6 //y=4.41 \
 //x2=1.23 //y2=7.58
cc_452 ( N_A_c_263_n N_VDD_c_2056_n ) capacitor c=0.00867681f //x=1.6 //y=4.88 \
 //x2=1.23 //y2=7.58
cc_453 ( N_A_c_272_n N_VDD_c_2056_n ) capacitor c=0.00387379f //x=1.6 //y=4.88 \
 //x2=1.23 //y2=7.58
cc_454 ( N_A_c_279_n N_VDD_c_2056_n ) capacitor c=0.0230346f //x=1.6 //y=4.88 \
 //x2=1.23 //y2=7.58
cc_455 ( A N_VDD_c_2059_n ) capacitor c=5.7886e-19 //x=1.6 //y=4.25 //x2=3.82 \
 //y2=7.585
cc_456 ( N_A_c_265_n N_VDD_c_2059_n ) capacitor c=0.0195785f //x=6.62 //y=4.25 \
 //x2=3.82 //y2=7.585
cc_457 ( A N_VDD_c_2067_n ) capacitor c=0.00706931f //x=6.78 //y=4.62 \
 //x2=6.04 //y2=7.585
cc_458 ( A N_VDD_c_2067_n ) capacitor c=0.00485571f //x=6.78 //y=4.25 \
 //x2=6.04 //y2=7.585
cc_459 ( N_A_c_308_p N_VDD_c_2067_n ) capacitor c=0.00149742f //x=6.78 \
 //y=4.41 //x2=6.04 //y2=7.585
cc_460 ( N_A_c_309_p N_VDD_c_2067_n ) capacitor c=0.00587248f //x=6.78 \
 //y=4.76 //x2=6.04 //y2=7.585
cc_461 ( N_A_c_265_n N_VDD_c_2067_n ) capacitor c=0.0191331f //x=6.62 //y=4.25 \
 //x2=6.04 //y2=7.585
cc_462 ( N_A_c_315_p N_VDD_c_2067_n ) capacitor c=0.00795227f //x=6.78 \
 //y=4.88 //x2=6.04 //y2=7.585
cc_463 ( N_A_M15_noxref_g N_VDD_c_2067_n ) capacitor c=0.00634455f //x=6.935 \
 //y=6.2 //x2=6.04 //y2=7.585
cc_464 ( N_A_c_317_p N_VDD_c_2067_n ) capacitor c=0.00799922f //x=7.01 \
 //y=4.97 //x2=6.04 //y2=7.585
cc_465 ( A N_VDD_c_2127_n ) capacitor c=0.00542852f //x=9.37 //y=4.62 \
 //x2=8.26 //y2=7.585
cc_466 ( A N_VDD_c_2127_n ) capacitor c=0.00133334f //x=6.78 //y=4.25 \
 //x2=8.26 //y2=7.585
cc_467 ( A N_VDD_c_2127_n ) capacitor c=0.00247452f //x=9.37 //y=4.25 \
 //x2=8.26 //y2=7.585
cc_468 ( N_A_c_310_p N_VDD_c_2127_n ) capacitor c=0.00129292f //x=9.37 \
 //y=4.415 //x2=8.26 //y2=7.585
cc_469 ( N_A_c_311_p N_VDD_c_2127_n ) capacitor c=0.00433917f //x=9.37 \
 //y=4.765 //x2=8.26 //y2=7.585
cc_470 ( N_A_c_286_p N_VDD_c_2127_n ) capacitor c=0.0192116f //x=9.205 \
 //y=4.255 //x2=8.26 //y2=7.585
cc_471 ( N_A_c_315_p N_VDD_c_2127_n ) capacitor c=0.00235165f //x=6.78 \
 //y=4.88 //x2=8.26 //y2=7.585
cc_472 ( N_A_c_343_p N_VDD_c_2127_n ) capacitor c=0.00370212f //x=9.37 \
 //y=4.88 //x2=8.26 //y2=7.585
cc_473 ( N_A_c_294_p N_VDD_c_2127_n ) capacitor c=0.00838585f //x=7.3 //y=4.97 \
 //x2=8.26 //y2=7.585
cc_474 ( N_A_c_317_p N_VDD_c_2127_n ) capacitor c=2.63786e-19 //x=7.01 \
 //y=4.97 //x2=8.26 //y2=7.585
cc_475 ( N_A_c_344_p N_VDD_c_2127_n ) capacitor c=0.0160934f //x=9.37 //y=4.88 \
 //x2=8.26 //y2=7.585
cc_476 ( N_A_M9_noxref_g N_VDD_M9_noxref_s ) capacitor c=0.0567929f //x=1.5 \
 //y=6.2 //x2=1.145 //y2=5.2
cc_477 ( N_A_M10_noxref_g N_VDD_M10_noxref_d ) capacitor c=0.015318f //x=1.94 \
 //y=6.2 //x2=2.015 //y2=5.2
cc_478 ( N_A_c_265_n N_VDD_M13_noxref_s ) capacitor c=0.00130658f //x=6.62 \
 //y=4.25 //x2=4.36 //y2=5.2
cc_479 ( N_A_c_265_n N_VDD_M14_noxref_d ) capacitor c=0.00270327f //x=6.62 \
 //y=4.25 //x2=5.23 //y2=5.2
cc_480 ( N_A_c_308_p N_VDD_M15_noxref_s ) capacitor c=0.0021098f //x=6.78 \
 //y=4.41 //x2=6.58 //y2=5.2
cc_481 ( N_A_c_309_p N_VDD_M15_noxref_s ) capacitor c=0.0209128f //x=6.78 \
 //y=4.76 //x2=6.58 //y2=5.2
cc_482 ( N_A_c_265_n N_VDD_M15_noxref_s ) capacitor c=4.99673e-19 //x=6.62 \
 //y=4.25 //x2=6.58 //y2=5.2
cc_483 ( N_A_c_312_p N_VDD_M15_noxref_s ) capacitor c=6.11792e-19 //x=6.94 \
 //y=4.25 //x2=6.58 //y2=5.2
cc_484 ( N_A_c_315_p N_VDD_M15_noxref_s ) capacitor c=0.00986169f //x=6.78 \
 //y=4.88 //x2=6.58 //y2=5.2
cc_485 ( N_A_M15_noxref_g N_VDD_M15_noxref_s ) capacitor c=0.0573441f \
 //x=6.935 //y=6.2 //x2=6.58 //y2=5.2
cc_486 ( N_A_c_317_p N_VDD_M15_noxref_s ) capacitor c=0.00531638f //x=7.01 \
 //y=4.97 //x2=6.58 //y2=5.2
cc_487 ( N_A_c_286_p N_VDD_M16_noxref_d ) capacitor c=0.00268693f //x=9.205 \
 //y=4.255 //x2=7.45 //y2=5.2
cc_488 ( N_A_M16_noxref_g N_VDD_M16_noxref_d ) capacitor c=0.0572684f \
 //x=7.375 //y=6.2 //x2=7.45 //y2=5.2
cc_489 ( N_A_c_343_p N_VDD_M17_noxref_d ) capacitor c=0.0013074f //x=9.37 \
 //y=4.88 //x2=9.345 //y2=5.2
cc_490 ( N_A_M17_noxref_g N_VDD_M17_noxref_d ) capacitor c=0.00896756f \
 //x=9.27 //y=6.2 //x2=9.345 //y2=5.2
cc_491 ( N_A_M18_noxref_g N_VDD_M17_noxref_d ) capacitor c=0.00896756f \
 //x=9.71 //y=6.2 //x2=9.345 //y2=5.2
cc_492 ( N_A_c_344_p N_VDD_M17_noxref_d ) capacitor c=0.00329802f //x=9.37 \
 //y=4.88 //x2=9.345 //y2=5.2
cc_493 ( A COUT ) capacitor c=0.0347206f //x=6.78 //y=2.77 //x2=5.3 //y2=2.4
cc_494 ( A COUT ) capacitor c=0.0065873f //x=6.78 //y=4.62 //x2=5.3 //y2=2.4
cc_495 ( N_A_c_308_p COUT ) capacitor c=0.0036244f //x=6.78 //y=4.41 //x2=5.3 \
 //y2=2.4
cc_496 ( N_A_c_309_p COUT ) capacitor c=0.00636591f //x=6.78 //y=4.76 //x2=5.3 \
 //y2=2.4
cc_497 ( N_A_c_298_p COUT ) capacitor c=0.0069554f //x=6.78 //y=2.265 //x2=5.3 \
 //y2=2.4
cc_498 ( N_A_c_265_n COUT ) capacitor c=0.0275572f //x=6.62 //y=4.25 //x2=5.3 \
 //y2=2.4
cc_499 ( N_A_c_312_p COUT ) capacitor c=0.00192158f //x=6.94 //y=4.25 //x2=5.3 \
 //y2=2.4
cc_500 ( N_A_c_265_n N_COUT_c_2408_n ) capacitor c=7.51869e-19 //x=6.62 \
 //y=4.25 //x2=4.935 //y2=5.42
cc_501 ( N_A_c_265_n N_COUT_c_2416_n ) capacitor c=0.0137165f //x=6.62 \
 //y=4.25 //x2=5.02 //y2=5.14
cc_502 ( N_A_c_310_p N_noxref_9_c_2489_n ) capacitor c=0.00177848f //x=9.37 \
 //y=4.415 //x2=9.81 //y2=5.385
cc_503 ( N_A_c_311_p N_noxref_9_c_2489_n ) capacitor c=0.0209582f //x=9.37 \
 //y=4.765 //x2=9.81 //y2=5.385
cc_504 ( N_A_c_313_p N_noxref_9_c_2489_n ) capacitor c=0.00177887f //x=9.365 \
 //y=4.255 //x2=9.81 //y2=5.385
cc_505 ( N_A_c_343_p N_noxref_9_c_2489_n ) capacitor c=0.00412201f //x=9.37 \
 //y=4.88 //x2=9.81 //y2=5.385
cc_506 ( N_A_M17_noxref_g N_noxref_9_c_2489_n ) capacitor c=0.0102378f \
 //x=9.27 //y=6.2 //x2=9.81 //y2=5.385
cc_507 ( N_A_M18_noxref_g N_noxref_9_c_2489_n ) capacitor c=0.0110474f \
 //x=9.71 //y=6.2 //x2=9.81 //y2=5.385
cc_508 ( N_A_c_344_p N_noxref_9_c_2489_n ) capacitor c=0.00186066f //x=9.37 \
 //y=4.88 //x2=9.81 //y2=5.385
cc_509 ( N_A_c_310_p N_noxref_9_c_2496_n ) capacitor c=0.00206536f //x=9.37 \
 //y=4.415 //x2=9.057 //y2=5.385
cc_510 ( N_A_c_286_p N_noxref_9_c_2496_n ) capacitor c=0.00599277f //x=9.205 \
 //y=4.255 //x2=9.057 //y2=5.385
cc_511 ( N_A_M17_noxref_g N_noxref_9_c_2496_n ) capacitor c=0.00402951f \
 //x=9.27 //y=6.2 //x2=9.057 //y2=5.385
cc_512 ( N_A_M18_noxref_g N_noxref_9_c_2499_n ) capacitor c=0.00178158f \
 //x=9.71 //y=6.2 //x2=9.93 //y2=5.385
cc_513 ( N_A_M18_noxref_g N_noxref_9_c_2500_n ) capacitor c=0.00182026f \
 //x=9.71 //y=6.2 //x2=9.93 //y2=6.915
cc_514 ( N_A_c_310_p N_noxref_9_c_2501_n ) capacitor c=3.5629e-19 //x=9.37 \
 //y=4.415 //x2=9.05 //y2=5.555
cc_515 ( N_A_M17_noxref_g N_noxref_9_c_2501_n ) capacitor c=0.0467484f \
 //x=9.27 //y=6.2 //x2=9.05 //y2=5.555
cc_516 ( N_A_M18_noxref_g N_noxref_9_c_2503_n ) capacitor c=0.0184757f \
 //x=9.71 //y=6.2 //x2=9.93 //y2=5.555
cc_517 ( N_A_M17_noxref_g N_noxref_9_M17_noxref_s ) capacitor c=0.0057176f \
 //x=9.27 //y=6.2 //x2=8.915 //y2=5.2
cc_518 ( N_A_c_384_p N_GND_c_2699_n ) capacitor c=6.6172e-19 //x=1.6 //y=2.26 \
 //x2=1.585 //y2=0.175
cc_519 ( N_A_c_308_p N_GND_c_2661_n ) capacitor c=2.87403e-19 //x=6.78 \
 //y=4.41 //x2=9.355 //y2=0.175
cc_520 ( N_A_c_298_p N_GND_c_2661_n ) capacitor c=0.00249122f //x=6.78 \
 //y=2.265 //x2=9.355 //y2=0.175
cc_521 ( N_A_c_299_p N_GND_c_2661_n ) capacitor c=7.5371e-19 //x=6.78 \
 //y=2.265 //x2=9.355 //y2=0.175
cc_522 ( N_A_c_297_p N_GND_c_2703_n ) capacitor c=0.00568908f //x=9.37 \
 //y=2.42 //x2=9.44 //y2=1.025
cc_523 ( N_A_c_380_p N_GND_c_2703_n ) capacitor c=4.20185e-19 //x=9.37 \
 //y=2.265 //x2=9.44 //y2=1.025
cc_524 ( N_A_c_438_p N_GND_c_2703_n ) capacitor c=0.00146326f //x=9.175 \
 //y=1.05 //x2=9.44 //y2=1.025
cc_525 ( N_A_c_439_p N_GND_c_2703_n ) capacitor c=0.00305617f //x=9.175 \
 //y=1.395 //x2=9.44 //y2=1.025
cc_526 ( N_A_c_552_p N_GND_c_2703_n ) capacitor c=0.00943115f //x=9.55 \
 //y=0.895 //x2=9.44 //y2=1.025
cc_527 ( N_A_c_553_p N_GND_c_2703_n ) capacitor c=6.13264e-19 //x=9.55 \
 //y=1.55 //x2=9.44 //y2=1.025
cc_528 ( N_A_c_440_p N_GND_c_2703_n ) capacitor c=0.00176231f //x=9.705 \
 //y=1.05 //x2=9.44 //y2=1.025
cc_529 ( N_A_c_442_p N_GND_c_2703_n ) capacitor c=0.00234543f //x=9.705 \
 //y=1.395 //x2=9.44 //y2=1.025
cc_530 ( N_A_c_261_n N_GND_c_2668_n ) capacitor c=6.41964e-19 //x=1.6 //y=4.41 \
 //x2=1.67 //y2=1.135
cc_531 ( N_A_c_384_p N_GND_c_2668_n ) capacitor c=0.00709624f //x=1.6 //y=2.26 \
 //x2=1.67 //y2=1.135
cc_532 ( N_A_c_357_p N_GND_c_2668_n ) capacitor c=2.13705e-19 //x=1.6 //y=2.26 \
 //x2=1.67 //y2=1.135
cc_533 ( N_A_c_428_p N_GND_c_2668_n ) capacitor c=0.00156094f //x=1.405 \
 //y=1.045 //x2=1.67 //y2=1.135
cc_534 ( N_A_c_429_p N_GND_c_2668_n ) capacitor c=0.00413828f //x=1.405 \
 //y=1.39 //x2=1.67 //y2=1.135
cc_535 ( N_A_c_431_p N_GND_c_2668_n ) capacitor c=4.2764e-19 //x=1.405 //y=1.7 \
 //x2=1.67 //y2=1.135
cc_536 ( N_A_c_562_p N_GND_c_2668_n ) capacitor c=7.35788e-19 //x=1.78 \
 //y=0.89 //x2=1.67 //y2=1.135
cc_537 ( N_A_c_563_p N_GND_c_2668_n ) capacitor c=6.15464e-19 //x=1.78 \
 //y=1.545 //x2=1.67 //y2=1.135
cc_538 ( N_A_c_430_p N_GND_c_2668_n ) capacitor c=0.00174905f //x=1.935 \
 //y=1.045 //x2=1.67 //y2=1.135
cc_539 ( N_A_c_432_p N_GND_c_2668_n ) capacitor c=0.00294528f //x=1.935 \
 //y=1.39 //x2=1.67 //y2=1.135
cc_540 ( N_A_c_428_p N_GND_c_2721_n ) capacitor c=3.51399e-19 //x=1.405 \
 //y=1.045 //x2=1.667 //y2=1.005
cc_541 ( N_A_c_562_p N_GND_c_2721_n ) capacitor c=0.00864609f //x=1.78 \
 //y=0.89 //x2=1.667 //y2=1.005
cc_542 ( N_A_c_430_p N_GND_c_2721_n ) capacitor c=4.45447e-19 //x=1.935 \
 //y=1.045 //x2=1.667 //y2=1.005
cc_543 ( N_A_c_428_p N_GND_c_2670_n ) capacitor c=0.00690758f //x=1.405 \
 //y=1.045 //x2=3.65 //y2=0.175
cc_544 ( A N_GND_c_2672_n ) capacitor c=0.0117984f //x=1.6 //y=2.77 //x2=1.23 \
 //y2=0.18
cc_545 ( N_A_c_384_p N_GND_c_2672_n ) capacitor c=0.0082376f //x=1.6 //y=2.26 \
 //x2=1.23 //y2=0.18
cc_546 ( N_A_c_357_p N_GND_c_2672_n ) capacitor c=0.00369668f //x=1.6 //y=2.26 \
 //x2=1.23 //y2=0.18
cc_547 ( N_A_c_431_p N_GND_c_2672_n ) capacitor c=0.0015404f //x=1.405 //y=1.7 \
 //x2=1.23 //y2=0.18
cc_548 ( N_A_c_386_p N_GND_c_2672_n ) capacitor c=0.00950704f //x=1.405 \
 //y=2.095 //x2=1.23 //y2=0.18
cc_549 ( N_A_c_298_p N_GND_c_2730_n ) capacitor c=0.00114179f //x=6.78 \
 //y=2.265 //x2=7.065 //y2=0.715
cc_550 ( N_A_c_299_p N_GND_c_2730_n ) capacitor c=3.95714e-19 //x=6.78 \
 //y=2.265 //x2=7.065 //y2=0.715
cc_551 ( N_A_c_318_p N_GND_c_2730_n ) capacitor c=0.0125549f //x=6.89 //y=1.09 \
 //x2=7.065 //y2=0.715
cc_552 ( N_A_c_290_p N_GND_c_2730_n ) capacitor c=2.1838e-19 //x=6.78 \
 //y=2.265 //x2=7.065 //y2=0.715
cc_553 ( N_A_c_322_p N_GND_c_2734_n ) capacitor c=0.0130753f //x=7.42 //y=1.09 \
 //x2=7.555 //y2=0.715
cc_554 ( N_A_c_438_p N_GND_c_2735_n ) capacitor c=0.00684005f //x=9.175 \
 //y=1.05 //x2=11.42 //y2=0.175
cc_555 ( A N_GND_c_2686_n ) capacitor c=0.00945205f //x=6.78 //y=2.77 \
 //x2=6.04 //y2=0.175
cc_556 ( N_A_c_298_p N_GND_c_2686_n ) capacitor c=0.00682461f //x=6.78 \
 //y=2.265 //x2=6.04 //y2=0.175
cc_557 ( N_A_c_299_p N_GND_c_2686_n ) capacitor c=0.00733227f //x=6.78 \
 //y=2.265 //x2=6.04 //y2=0.175
cc_558 ( N_A_c_283_p N_GND_c_2686_n ) capacitor c=0.00344321f //x=6.89 //y=2.1 \
 //x2=6.04 //y2=0.175
cc_559 ( N_A_c_290_p N_GND_c_2686_n ) capacitor c=0.00785621f //x=6.78 \
 //y=2.265 //x2=6.04 //y2=0.175
cc_560 ( A N_GND_c_2741_n ) capacitor c=0.00679229f //x=9.37 //y=3.14 \
 //x2=8.26 //y2=0.175
cc_561 ( N_A_c_297_p N_GND_c_2741_n ) capacitor c=0.00458673f //x=9.37 \
 //y=2.42 //x2=8.26 //y2=0.175
cc_562 ( N_A_c_299_p N_GND_c_2741_n ) capacitor c=0.00230732f //x=6.78 \
 //y=2.265 //x2=8.26 //y2=0.175
cc_563 ( N_A_c_380_p N_GND_c_2741_n ) capacitor c=0.00369227f //x=9.37 \
 //y=2.265 //x2=8.26 //y2=0.175
cc_564 ( N_A_c_381_p N_GND_c_2741_n ) capacitor c=0.00932032f //x=9.175 \
 //y=2.1 //x2=8.26 //y2=0.175
cc_565 ( N_A_c_384_p N_GND_M0_noxref_d ) capacitor c=2.20438e-19 //x=1.6 \
 //y=2.26 //x2=1.48 //y2=1.045
cc_566 ( N_A_c_428_p N_GND_M0_noxref_d ) capacitor c=0.00192399f //x=1.405 \
 //y=1.045 //x2=1.48 //y2=1.045
cc_567 ( N_A_c_429_p N_GND_M0_noxref_d ) capacitor c=0.00210798f //x=1.405 \
 //y=1.39 //x2=1.48 //y2=1.045
cc_568 ( N_A_c_562_p N_GND_M0_noxref_d ) capacitor c=0.00472259f //x=1.78 \
 //y=0.89 //x2=1.48 //y2=1.045
cc_569 ( N_A_c_563_p N_GND_M0_noxref_d ) capacitor c=0.00166857f //x=1.78 \
 //y=1.545 //x2=1.48 //y2=1.045
cc_570 ( N_A_c_430_p N_GND_M0_noxref_d ) capacitor c=0.00230174f //x=1.935 \
 //y=1.045 //x2=1.48 //y2=1.045
cc_571 ( N_A_c_432_p N_GND_M0_noxref_d ) capacitor c=0.00210798f //x=1.935 \
 //y=1.39 //x2=1.48 //y2=1.045
cc_572 ( N_A_c_308_p N_GND_M3_noxref_s ) capacitor c=2.54885e-19 //x=6.78 \
 //y=4.41 //x2=6.535 //y2=0.55
cc_573 ( N_A_c_298_p N_GND_M3_noxref_s ) capacitor c=0.00297876f //x=6.78 \
 //y=2.265 //x2=6.535 //y2=0.55
cc_574 ( N_A_c_299_p N_GND_M3_noxref_s ) capacitor c=0.00476545f //x=6.78 \
 //y=2.265 //x2=6.535 //y2=0.55
cc_575 ( N_A_c_318_p N_GND_M3_noxref_s ) capacitor c=0.0300238f //x=6.89 \
 //y=1.09 //x2=6.535 //y2=0.55
cc_576 ( N_A_c_282_p N_GND_M3_noxref_s ) capacitor c=0.002132f //x=6.89 \
 //y=1.745 //x2=6.535 //y2=0.55
cc_577 ( N_A_c_283_p N_GND_M3_noxref_s ) capacitor c=0.00304786f //x=6.89 \
 //y=2.1 //x2=6.535 //y2=0.55
cc_578 ( N_A_c_320_p N_GND_M3_noxref_s ) capacitor c=0.00517463f //x=7.265 \
 //y=0.935 //x2=6.535 //y2=0.55
cc_579 ( N_A_c_322_p N_GND_M3_noxref_s ) capacitor c=0.0153553f //x=7.42 \
 //y=1.09 //x2=6.535 //y2=0.55
cc_580 ( N_A_c_285_p N_GND_M3_noxref_s ) capacitor c=0.00629878f //x=7.42 \
 //y=1.435 //x2=6.535 //y2=0.55
cc_581 ( N_A_c_290_p N_GND_M3_noxref_s ) capacitor c=0.00660555f //x=6.78 \
 //y=2.265 //x2=6.535 //y2=0.55
cc_582 ( N_A_c_297_p N_GND_M4_noxref_d ) capacitor c=4.22955e-19 //x=9.37 \
 //y=2.42 //x2=9.25 //y2=1.05
cc_583 ( N_A_c_438_p N_GND_M4_noxref_d ) capacitor c=0.00192399f //x=9.175 \
 //y=1.05 //x2=9.25 //y2=1.05
cc_584 ( N_A_c_439_p N_GND_M4_noxref_d ) capacitor c=0.00210798f //x=9.175 \
 //y=1.395 //x2=9.25 //y2=1.05
cc_585 ( N_A_c_552_p N_GND_M4_noxref_d ) capacitor c=0.00473146f //x=9.55 \
 //y=0.895 //x2=9.25 //y2=1.05
cc_586 ( N_A_c_553_p N_GND_M4_noxref_d ) capacitor c=0.00166857f //x=9.55 \
 //y=1.55 //x2=9.25 //y2=1.05
cc_587 ( N_A_c_440_p N_GND_M4_noxref_d ) capacitor c=0.00230174f //x=9.705 \
 //y=1.05 //x2=9.25 //y2=1.05
cc_588 ( N_A_c_442_p N_GND_M4_noxref_d ) capacitor c=0.00210798f //x=9.705 \
 //y=1.395 //x2=9.25 //y2=1.05
cc_589 ( N_A_c_386_p N_noxref_12_c_3027_n ) capacitor c=0.00262672f //x=1.405 \
 //y=2.095 //x2=1.185 //y2=1.675
cc_590 ( N_A_c_261_n N_noxref_12_c_3028_n ) capacitor c=0.00162433f //x=1.6 \
 //y=4.41 //x2=2.07 //y2=1.76
cc_591 ( N_A_c_384_p N_noxref_12_c_3028_n ) capacitor c=0.00459552f //x=1.6 \
 //y=2.26 //x2=2.07 //y2=1.76
cc_592 ( N_A_c_357_p N_noxref_12_c_3028_n ) capacitor c=0.00763108f //x=1.6 \
 //y=2.26 //x2=2.07 //y2=1.76
cc_593 ( N_A_c_431_p N_noxref_12_c_3028_n ) capacitor c=0.00695869f //x=1.405 \
 //y=1.7 //x2=2.07 //y2=1.76
cc_594 ( N_A_c_386_p N_noxref_12_c_3028_n ) capacitor c=0.0193099f //x=1.405 \
 //y=2.095 //x2=2.07 //y2=1.76
cc_595 ( N_A_c_563_p N_noxref_12_c_3028_n ) capacitor c=0.00723574f //x=1.78 \
 //y=1.545 //x2=2.07 //y2=1.76
cc_596 ( N_A_c_432_p N_noxref_12_c_3028_n ) capacitor c=0.00395763f //x=1.935 \
 //y=1.39 //x2=2.07 //y2=1.76
cc_597 ( N_A_c_386_p N_noxref_12_c_3017_n ) capacitor c=6.71402e-19 //x=1.405 \
 //y=2.095 //x2=2.155 //y2=1.675
cc_598 ( N_A_c_428_p N_noxref_12_M0_noxref_s ) capacitor c=0.0294925f \
 //x=1.405 //y=1.045 //x2=1.05 //y2=0.545
cc_599 ( N_A_c_431_p N_noxref_12_M0_noxref_s ) capacitor c=3.48408e-19 \
 //x=1.405 //y=1.7 //x2=1.05 //y2=0.545
cc_600 ( N_A_c_430_p N_noxref_12_M0_noxref_s ) capacitor c=0.0125442f \
 //x=1.935 //y=1.045 //x2=1.05 //y2=0.545
cc_601 ( N_A_c_381_p N_noxref_13_c_3080_n ) capacitor c=0.00262672f //x=9.175 \
 //y=2.1 //x2=8.955 //y2=1.68
cc_602 ( N_A_c_297_p N_noxref_13_c_3081_n ) capacitor c=0.0055766f //x=9.37 \
 //y=2.42 //x2=9.84 //y2=1.765
cc_603 ( N_A_c_310_p N_noxref_13_c_3081_n ) capacitor c=0.0031725f //x=9.37 \
 //y=4.415 //x2=9.84 //y2=1.765
cc_604 ( N_A_c_380_p N_noxref_13_c_3081_n ) capacitor c=0.00763108f //x=9.37 \
 //y=2.265 //x2=9.84 //y2=1.765
cc_605 ( N_A_c_441_p N_noxref_13_c_3081_n ) capacitor c=0.00697581f //x=9.175 \
 //y=1.705 //x2=9.84 //y2=1.765
cc_606 ( N_A_c_381_p N_noxref_13_c_3081_n ) capacitor c=0.0174019f //x=9.175 \
 //y=2.1 //x2=9.84 //y2=1.765
cc_607 ( N_A_c_553_p N_noxref_13_c_3081_n ) capacitor c=0.00725092f //x=9.55 \
 //y=1.55 //x2=9.84 //y2=1.765
cc_608 ( N_A_c_442_p N_noxref_13_c_3081_n ) capacitor c=0.0034036f //x=9.705 \
 //y=1.395 //x2=9.84 //y2=1.765
cc_609 ( N_A_c_381_p N_noxref_13_c_3088_n ) capacitor c=6.71402e-19 //x=9.175 \
 //y=2.1 //x2=9.925 //y2=1.68
cc_610 ( N_A_c_438_p N_noxref_13_M4_noxref_s ) capacitor c=0.0294925f \
 //x=9.175 //y=1.05 //x2=8.82 //y2=0.55
cc_611 ( N_A_c_441_p N_noxref_13_M4_noxref_s ) capacitor c=3.48408e-19 \
 //x=9.175 //y=1.705 //x2=8.82 //y2=0.55
cc_612 ( N_A_c_440_p N_noxref_13_M4_noxref_s ) capacitor c=0.0125442f \
 //x=9.705 //y=1.05 //x2=8.82 //y2=0.55
cc_613 ( N_noxref_3_c_652_n SUM ) capacitor c=0.00197799f //x=7.435 //y=2.02 \
 //x2=10.97 //y2=2.4
cc_614 ( N_noxref_3_c_703_p SUM ) capacitor c=0.00174515f //x=13.69 //y=2.915 \
 //x2=10.97 //y2=2.4
cc_615 ( N_noxref_3_c_704_p SUM ) capacitor c=4.56327e-19 //x=13.81 //y=2.595 \
 //x2=10.97 //y2=2.4
cc_616 ( N_noxref_3_c_690_n SUM ) capacitor c=0.0274064f //x=13.635 //y=2.755 \
 //x2=10.97 //y2=2.4
cc_617 ( N_noxref_3_c_641_n SUM ) capacitor c=6.97655e-19 //x=7.155 //y=5.42 \
 //x2=10.97 //y2=4.99
cc_618 ( N_noxref_3_c_666_n SUM ) capacitor c=0.00161877f //x=7.52 //y=5.055 \
 //x2=10.97 //y2=4.99
cc_619 ( N_noxref_3_c_708_p SUM ) capacitor c=0.0048012f //x=13.69 //y=4.73 \
 //x2=10.97 //y2=4.99
cc_620 ( N_noxref_3_c_703_p SUM ) capacitor c=0.0345487f //x=13.69 //y=2.915 \
 //x2=14.18 //y2=2.4
cc_621 ( N_noxref_3_c_708_p SUM ) capacitor c=0.0520611f //x=13.69 //y=4.73 \
 //x2=14.18 //y2=2.4
cc_622 ( N_noxref_3_c_711_p SUM ) capacitor c=0.0335163f //x=13.81 //y=2.41 \
 //x2=14.18 //y2=2.4
cc_623 ( N_noxref_3_c_704_p SUM ) capacitor c=0.015798f //x=13.81 //y=2.595 \
 //x2=14.18 //y2=2.4
cc_624 ( N_noxref_3_c_713_p SUM ) capacitor c=0.00268185f //x=13.81 //y=2.77 \
 //x2=14.18 //y2=2.4
cc_625 ( N_noxref_3_c_714_p SUM ) capacitor c=0.0127171f //x=13.795 //y=2.755 \
 //x2=14.18 //y2=2.4
cc_626 ( N_noxref_3_c_715_p SUM ) capacitor c=0.00263396f //x=13.81 //y=2.265 \
 //x2=14.18 //y2=2.4
cc_627 ( N_noxref_3_c_716_p SUM ) capacitor c=0.00855577f //x=13.475 //y=2.1 \
 //x2=14.18 //y2=2.4
cc_628 ( N_noxref_3_c_708_p SUM ) capacitor c=0.0421585f //x=13.69 //y=4.73 \
 //x2=14.18 //y2=4.99
cc_629 ( N_noxref_3_c_718_p SUM ) capacitor c=0.0332398f //x=13.69 //y=4.877 \
 //x2=14.18 //y2=4.99
cc_630 ( N_noxref_3_c_719_p SUM ) capacitor c=0.00262905f //x=13.81 //y=4.88 \
 //x2=14.18 //y2=4.99
cc_631 ( N_noxref_3_c_720_p SUM ) capacitor c=0.0109587f //x=13.81 //y=4.88 \
 //x2=14.18 //y2=4.99
cc_632 ( N_noxref_3_c_708_p SUM ) capacitor c=0.00518857f //x=13.69 //y=4.73 \
 //x2=14.18 //y2=3.88
cc_633 ( N_noxref_3_c_681_n N_SUM_c_963_n ) capacitor c=7.0089e-19 //x=7.15 \
 //y=1.185 //x2=10.41 //y2=1.305
cc_634 ( N_noxref_3_c_690_n N_SUM_c_963_n ) capacitor c=4.93684e-19 //x=13.635 \
 //y=2.755 //x2=10.41 //y2=1.305
cc_635 ( N_noxref_3_c_639_n N_SUM_c_965_n ) capacitor c=0.00496974f //x=7.15 \
 //y=1.935 //x2=10.41 //y2=1.75
cc_636 ( N_noxref_3_c_681_n N_SUM_c_965_n ) capacitor c=3.46581e-19 //x=7.15 \
 //y=1.185 //x2=10.41 //y2=1.75
cc_637 ( N_noxref_3_c_690_n N_SUM_c_967_n ) capacitor c=0.00757486f //x=13.635 \
 //y=2.755 //x2=10.885 //y2=1.835
cc_638 ( N_noxref_3_c_690_n N_SUM_c_968_n ) capacitor c=8.06158e-19 //x=13.635 \
 //y=2.755 //x2=10.495 //y2=1.835
cc_639 ( N_noxref_3_c_708_p N_SUM_c_969_n ) capacitor c=0.00197512f //x=13.69 \
 //y=4.73 //x2=10.97 //y2=4.055
cc_640 ( N_noxref_3_c_703_p N_SUM_c_970_n ) capacitor c=4.06021e-19 //x=13.69 \
 //y=2.915 //x2=13.74 //y2=1.3
cc_641 ( N_noxref_3_c_714_p N_SUM_c_970_n ) capacitor c=2.49465e-19 //x=13.795 \
 //y=2.755 //x2=13.74 //y2=1.3
cc_642 ( N_noxref_3_c_731_p N_SUM_c_970_n ) capacitor c=4.13109e-19 //x=13.475 \
 //y=1.09 //x2=13.74 //y2=1.3
cc_643 ( N_noxref_3_c_732_p N_SUM_c_970_n ) capacitor c=0.00213f //x=13.475 \
 //y=1.435 //x2=13.74 //y2=1.3
cc_644 ( N_noxref_3_c_733_p N_SUM_c_970_n ) capacitor c=5.28423e-19 //x=13.85 \
 //y=0.935 //x2=13.74 //y2=1.3
cc_645 ( N_noxref_3_c_734_p N_SUM_c_970_n ) capacitor c=4.49341e-19 //x=13.85 \
 //y=1.59 //x2=13.74 //y2=1.3
cc_646 ( N_noxref_3_c_735_p N_SUM_c_970_n ) capacitor c=4.42805e-19 //x=14.005 \
 //y=1.09 //x2=13.74 //y2=1.3
cc_647 ( N_noxref_3_c_736_p N_SUM_c_970_n ) capacitor c=0.00304778f //x=14.005 \
 //y=1.435 //x2=13.74 //y2=1.3
cc_648 ( N_noxref_3_c_732_p N_SUM_c_978_n ) capacitor c=0.00119008f //x=13.475 \
 //y=1.435 //x2=13.74 //y2=1.75
cc_649 ( N_noxref_3_c_738_p N_SUM_c_978_n ) capacitor c=0.00410123f //x=13.475 \
 //y=1.745 //x2=13.74 //y2=1.75
cc_650 ( N_noxref_3_c_716_p N_SUM_c_978_n ) capacitor c=0.00329274f //x=13.475 \
 //y=2.1 //x2=13.74 //y2=1.75
cc_651 ( N_noxref_3_c_734_p N_SUM_c_978_n ) capacitor c=0.00740116f //x=13.85 \
 //y=1.59 //x2=13.74 //y2=1.75
cc_652 ( N_noxref_3_c_736_p N_SUM_c_978_n ) capacitor c=0.00303393f //x=14.005 \
 //y=1.435 //x2=13.74 //y2=1.75
cc_653 ( N_noxref_3_c_718_p N_SUM_c_983_n ) capacitor c=0.00245563f //x=13.69 \
 //y=4.877 //x2=14.095 //y2=5.385
cc_654 ( N_noxref_3_c_719_p N_SUM_c_983_n ) capacitor c=0.00104675f //x=13.81 \
 //y=4.88 //x2=14.095 //y2=5.385
cc_655 ( N_noxref_3_M24_noxref_g N_SUM_c_983_n ) capacitor c=0.00983704f \
 //x=13.92 //y=6.2 //x2=14.095 //y2=5.385
cc_656 ( N_noxref_3_c_703_p N_SUM_c_986_n ) capacitor c=7.52676e-19 //x=13.69 \
 //y=2.915 //x2=14.095 //y2=1.835
cc_657 ( N_noxref_3_c_711_p N_SUM_c_986_n ) capacitor c=0.00329057f //x=13.81 \
 //y=2.41 //x2=14.095 //y2=1.835
cc_658 ( N_noxref_3_c_714_p N_SUM_c_986_n ) capacitor c=3.72305e-19 //x=13.795 \
 //y=2.755 //x2=14.095 //y2=1.835
cc_659 ( N_noxref_3_c_715_p N_SUM_c_986_n ) capacitor c=0.00147657f //x=13.81 \
 //y=2.265 //x2=14.095 //y2=1.835
cc_660 ( N_noxref_3_c_734_p N_SUM_c_986_n ) capacitor c=0.00124662f //x=13.85 \
 //y=1.59 //x2=14.095 //y2=1.835
cc_661 ( N_noxref_3_c_736_p N_SUM_c_986_n ) capacitor c=0.00300547f //x=14.005 \
 //y=1.435 //x2=14.095 //y2=1.835
cc_662 ( N_noxref_3_c_703_p N_SUM_c_992_n ) capacitor c=0.00108723f //x=13.69 \
 //y=2.915 //x2=13.825 //y2=1.835
cc_663 ( N_noxref_3_c_711_p N_SUM_c_992_n ) capacitor c=0.0245822f //x=13.81 \
 //y=2.41 //x2=13.825 //y2=1.835
cc_664 ( N_noxref_3_c_714_p N_SUM_c_992_n ) capacitor c=4.74754e-19 //x=13.795 \
 //y=2.755 //x2=13.825 //y2=1.835
cc_665 ( N_noxref_3_c_715_p N_SUM_c_992_n ) capacitor c=0.00408056f //x=13.81 \
 //y=2.265 //x2=13.825 //y2=1.835
cc_666 ( N_noxref_3_c_716_p N_SUM_c_992_n ) capacitor c=0.00189997f //x=13.475 \
 //y=2.1 //x2=13.825 //y2=1.835
cc_667 ( N_noxref_3_c_703_p N_SUM_c_997_n ) capacitor c=0.0011496f //x=13.69 \
 //y=2.915 //x2=14.18 //y2=4.055
cc_668 ( N_noxref_3_c_708_p N_SUM_c_997_n ) capacitor c=0.0328751f //x=13.69 \
 //y=4.73 //x2=14.18 //y2=4.055
cc_669 ( N_noxref_3_c_718_p N_SUM_c_997_n ) capacitor c=2.21717e-19 //x=13.69 \
 //y=4.877 //x2=14.18 //y2=4.055
cc_670 ( N_noxref_3_c_720_p N_SUM_c_997_n ) capacitor c=0.00109921f //x=13.81 \
 //y=4.88 //x2=14.18 //y2=4.055
cc_671 ( N_noxref_3_c_641_n N_SUM_c_1001_n ) capacitor c=3.86497e-19 //x=7.155 \
 //y=5.42 //x2=10.37 //y2=5.385
cc_672 ( N_noxref_3_c_718_p N_SUM_c_1002_n ) capacitor c=0.0275415f //x=13.69 \
 //y=4.877 //x2=13.7 //y2=5.385
cc_673 ( N_noxref_3_c_719_p N_SUM_c_1002_n ) capacitor c=0.0039033f //x=13.81 \
 //y=4.88 //x2=13.7 //y2=5.385
cc_674 ( N_noxref_3_M23_noxref_g N_SUM_c_1002_n ) capacitor c=0.00179079f \
 //x=13.48 //y=6.2 //x2=13.7 //y2=5.385
cc_675 ( N_noxref_3_M24_noxref_g N_SUM_c_1002_n ) capacitor c=0.00270394f \
 //x=13.92 //y=6.2 //x2=13.7 //y2=5.385
cc_676 ( N_noxref_3_c_720_p N_SUM_c_1002_n ) capacitor c=0.00190838f //x=13.81 \
 //y=4.88 //x2=13.7 //y2=5.385
cc_677 ( N_noxref_3_c_690_n N_SUM_c_1007_n ) capacitor c=7.7387e-19 //x=13.635 \
 //y=2.755 //x2=11.175 //y2=3.895
cc_678 ( N_noxref_3_c_708_p N_SUM_c_1008_n ) capacitor c=0.00368778f //x=13.69 \
 //y=4.73 //x2=14.195 //y2=3.895
cc_679 ( N_noxref_3_c_708_p N_SUM_c_1009_n ) capacitor c=0.0208701f //x=13.69 \
 //y=4.73 //x2=14.035 //y2=3.895
cc_680 ( N_noxref_3_c_690_n N_SUM_c_1009_n ) capacitor c=0.0049308f //x=13.635 \
 //y=2.755 //x2=14.035 //y2=3.895
cc_681 ( N_noxref_3_c_718_p N_SUM_c_1011_n ) capacitor c=0.00369516f //x=13.69 \
 //y=4.877 //x2=13.7 //y2=5.555
cc_682 ( N_noxref_3_c_719_p N_SUM_c_1011_n ) capacitor c=0.00414273f //x=13.81 \
 //y=4.88 //x2=13.7 //y2=5.555
cc_683 ( N_noxref_3_M23_noxref_g N_SUM_c_1011_n ) capacitor c=0.0120591f \
 //x=13.48 //y=6.2 //x2=13.7 //y2=5.555
cc_684 ( N_noxref_3_M24_noxref_g N_SUM_c_1011_n ) capacitor c=0.0140704f \
 //x=13.92 //y=6.2 //x2=13.7 //y2=5.555
cc_685 ( N_noxref_3_c_720_p N_SUM_c_1011_n ) capacitor c=0.0044017f //x=13.81 \
 //y=4.88 //x2=13.7 //y2=5.555
cc_686 ( N_noxref_3_c_703_p N_SUM_M7_noxref_d ) capacitor c=2.74358e-19 \
 //x=13.69 //y=2.915 //x2=13.55 //y2=1.09
cc_687 ( N_noxref_3_c_711_p N_SUM_M7_noxref_d ) capacitor c=9.49603e-19 \
 //x=13.81 //y=2.41 //x2=13.55 //y2=1.09
cc_688 ( N_noxref_3_c_715_p N_SUM_M7_noxref_d ) capacitor c=0.00150031f \
 //x=13.81 //y=2.265 //x2=13.55 //y2=1.09
cc_689 ( N_noxref_3_c_731_p N_SUM_M7_noxref_d ) capacitor c=0.00137165f \
 //x=13.475 //y=1.09 //x2=13.55 //y2=1.09
cc_690 ( N_noxref_3_c_732_p N_SUM_M7_noxref_d ) capacitor c=0.00237422f \
 //x=13.475 //y=1.435 //x2=13.55 //y2=1.09
cc_691 ( N_noxref_3_c_733_p N_SUM_M7_noxref_d ) capacitor c=0.0020782f \
 //x=13.85 //y=0.935 //x2=13.55 //y2=1.09
cc_692 ( N_noxref_3_c_734_p N_SUM_M7_noxref_d ) capacitor c=0.00344131f \
 //x=13.85 //y=1.59 //x2=13.55 //y2=1.09
cc_693 ( N_noxref_3_c_735_p N_SUM_M7_noxref_d ) capacitor c=8.50094e-19 \
 //x=14.005 //y=1.09 //x2=13.55 //y2=1.09
cc_694 ( N_noxref_3_c_736_p N_SUM_M7_noxref_d ) capacitor c=0.00237422f \
 //x=14.005 //y=1.435 //x2=13.55 //y2=1.09
cc_695 ( N_noxref_3_c_711_p N_noxref_5_c_1255_n ) capacitor c=0.0111982f \
 //x=13.81 //y=2.41 //x2=12.7 //y2=2.385
cc_696 ( N_noxref_3_c_690_n N_noxref_5_c_1255_n ) capacitor c=0.00333983f \
 //x=13.635 //y=2.755 //x2=12.7 //y2=2.385
cc_697 ( N_noxref_3_c_715_p N_noxref_5_c_1255_n ) capacitor c=3.75556e-19 \
 //x=13.81 //y=2.265 //x2=12.7 //y2=2.385
cc_698 ( N_noxref_3_c_716_p N_noxref_5_c_1255_n ) capacitor c=0.00152667f \
 //x=13.475 //y=2.1 //x2=12.7 //y2=2.385
cc_699 ( N_noxref_3_c_703_p N_noxref_5_c_1259_n ) capacitor c=0.0214146f \
 //x=13.69 //y=2.915 //x2=12.7 //y2=3.385
cc_700 ( N_noxref_3_c_711_p N_noxref_5_c_1259_n ) capacitor c=0.00108959f \
 //x=13.81 //y=2.41 //x2=12.7 //y2=3.385
cc_701 ( N_noxref_3_c_704_p N_noxref_5_c_1259_n ) capacitor c=0.00492906f \
 //x=13.81 //y=2.595 //x2=12.7 //y2=3.385
cc_702 ( N_noxref_3_c_714_p N_noxref_5_c_1259_n ) capacitor c=0.00147011f \
 //x=13.795 //y=2.755 //x2=12.7 //y2=3.385
cc_703 ( N_noxref_3_c_690_n N_noxref_5_c_1259_n ) capacitor c=0.0279132f \
 //x=13.635 //y=2.755 //x2=12.7 //y2=3.385
cc_704 ( N_noxref_3_c_708_p N_noxref_5_c_1264_n ) capacitor c=8.64336e-19 \
 //x=13.69 //y=4.73 //x2=15.66 //y2=3.335
cc_705 ( N_noxref_3_c_704_p N_noxref_5_c_1264_n ) capacitor c=0.00105161f \
 //x=13.81 //y=2.595 //x2=15.66 //y2=3.335
cc_706 ( N_noxref_3_c_708_p N_noxref_5_c_1266_n ) capacitor c=0.00125828f \
 //x=13.69 //y=4.73 //x2=15.66 //y2=4.135
cc_707 ( N_noxref_3_c_708_p N_noxref_5_c_1267_n ) capacitor c=6.04659e-19 \
 //x=13.69 //y=4.73 //x2=15.66 //y2=5.055
cc_708 ( N_noxref_3_c_708_p N_noxref_5_c_1268_n ) capacitor c=0.0100855f \
 //x=13.69 //y=4.73 //x2=12.7 //y2=3.51
cc_709 ( N_noxref_3_c_708_p N_noxref_5_c_1269_n ) capacitor c=0.00284758f \
 //x=13.69 //y=4.73 //x2=12.86 //y2=3.525
cc_710 ( N_noxref_3_c_690_n N_noxref_5_c_1269_n ) capacitor c=0.0011786f \
 //x=13.635 //y=2.755 //x2=12.86 //y2=3.525
cc_711 ( N_noxref_3_c_708_p N_noxref_5_c_1271_n ) capacitor c=0.0217961f \
 //x=13.69 //y=4.73 //x2=15.505 //y2=4.27
cc_712 ( N_noxref_3_c_690_n N_noxref_5_c_1271_n ) capacitor c=0.00109024f \
 //x=13.635 //y=2.755 //x2=15.505 //y2=4.27
cc_713 ( N_noxref_3_c_708_p N_noxref_5_c_1273_n ) capacitor c=0.0196397f \
 //x=13.69 //y=4.73 //x2=15.535 //y2=3.495
cc_714 ( N_noxref_3_c_690_n N_noxref_5_c_1273_n ) capacitor c=0.0046655f \
 //x=13.635 //y=2.755 //x2=15.535 //y2=3.495
cc_715 ( N_noxref_3_c_711_p N_noxref_5_c_1275_n ) capacitor c=7.23736e-19 \
 //x=13.81 //y=2.41 //x2=12.7 //y2=2.265
cc_716 ( N_noxref_3_c_715_p N_noxref_5_c_1275_n ) capacitor c=0.00114264f \
 //x=13.81 //y=2.265 //x2=12.7 //y2=2.265
cc_717 ( N_noxref_3_c_716_p N_noxref_5_c_1275_n ) capacitor c=0.00214703f \
 //x=13.475 //y=2.1 //x2=12.7 //y2=2.265
cc_718 ( N_noxref_3_c_731_p N_noxref_5_c_1278_n ) capacitor c=4.86545e-19 \
 //x=13.475 //y=1.09 //x2=12.505 //y2=1.05
cc_719 ( N_noxref_3_c_731_p N_noxref_5_c_1279_n ) capacitor c=0.00152405f \
 //x=13.475 //y=1.09 //x2=12.505 //y2=1.395
cc_720 ( N_noxref_3_c_732_p N_noxref_5_c_1280_n ) capacitor c=0.00109982f \
 //x=13.475 //y=1.435 //x2=12.505 //y2=1.705
cc_721 ( N_noxref_3_c_738_p N_noxref_5_c_1280_n ) capacitor c=9.58243e-19 \
 //x=13.475 //y=1.745 //x2=12.505 //y2=1.705
cc_722 ( N_noxref_3_c_711_p N_noxref_5_c_1282_n ) capacitor c=0.00153002f \
 //x=13.81 //y=2.41 //x2=12.505 //y2=2.1
cc_723 ( N_noxref_3_c_715_p N_noxref_5_c_1282_n ) capacitor c=0.00187625f \
 //x=13.81 //y=2.265 //x2=12.505 //y2=2.1
cc_724 ( N_noxref_3_c_738_p N_noxref_5_c_1282_n ) capacitor c=0.00662747f \
 //x=13.475 //y=1.745 //x2=12.505 //y2=2.1
cc_725 ( N_noxref_3_c_716_p N_noxref_5_c_1282_n ) capacitor c=0.012184f \
 //x=13.475 //y=2.1 //x2=12.505 //y2=2.1
cc_726 ( N_noxref_3_c_731_p N_noxref_5_c_1286_n ) capacitor c=0.0157772f \
 //x=13.475 //y=1.09 //x2=13.035 //y2=1.05
cc_727 ( N_noxref_3_c_735_p N_noxref_5_c_1286_n ) capacitor c=0.00127211f \
 //x=14.005 //y=1.09 //x2=13.035 //y2=1.05
cc_728 ( N_noxref_3_c_732_p N_noxref_5_c_1288_n ) capacitor c=0.0117362f \
 //x=13.475 //y=1.435 //x2=13.035 //y2=1.395
cc_729 ( N_noxref_3_c_738_p N_noxref_5_c_1288_n ) capacitor c=0.00862358f \
 //x=13.475 //y=1.745 //x2=13.035 //y2=1.395
cc_730 ( N_noxref_3_c_736_p N_noxref_5_c_1288_n ) capacitor c=0.00204774f \
 //x=14.005 //y=1.435 //x2=13.035 //y2=1.395
cc_731 ( N_noxref_3_c_690_n B ) capacitor c=0.00663846f //x=13.635 //y=2.755 \
 //x2=10.11 //y2=3.88
cc_732 ( N_noxref_3_c_690_n B ) capacitor c=0.00512176f //x=13.635 //y=2.755 \
 //x2=10.48 //y2=3.14
cc_733 ( N_noxref_3_c_708_p B ) capacitor c=0.0128176f //x=13.69 //y=4.73 \
 //x2=12.7 //y2=4.62
cc_734 ( N_noxref_3_c_719_p B ) capacitor c=2.2865e-19 //x=13.81 //y=4.88 \
 //x2=12.7 //y2=4.62
cc_735 ( N_noxref_3_c_690_n N_B_c_1625_n ) capacitor c=0.00315782f //x=13.635 \
 //y=2.755 //x2=10.48 //y2=2.415
cc_736 ( N_noxref_3_c_658_n N_B_c_1628_n ) capacitor c=4.78474e-19 //x=7.52 \
 //y=2.61 //x2=10.48 //y2=2.995
cc_737 ( N_noxref_3_c_690_n N_B_c_1628_n ) capacitor c=0.0230148f //x=13.635 \
 //y=2.755 //x2=10.48 //y2=2.995
cc_738 ( N_noxref_3_c_642_n N_B_c_1639_n ) capacitor c=0.00235713f //x=7.235 \
 //y=2.02 //x2=6.995 //y2=3.865
cc_739 ( N_noxref_3_c_666_n N_B_c_1639_n ) capacitor c=4.14772e-19 //x=7.52 \
 //y=5.055 //x2=6.995 //y2=3.865
cc_740 ( N_noxref_3_c_652_n N_B_c_1644_n ) capacitor c=0.00211977f //x=7.435 \
 //y=2.02 //x2=8.98 //y2=3.88
cc_741 ( N_noxref_3_c_664_n N_B_c_1644_n ) capacitor c=0.00328142f //x=7.52 \
 //y=2.93 //x2=8.98 //y2=3.88
cc_742 ( N_noxref_3_c_666_n N_B_c_1644_n ) capacitor c=0.0271603f //x=7.52 \
 //y=5.055 //x2=8.98 //y2=3.88
cc_743 ( N_noxref_3_c_688_n N_B_c_1644_n ) capacitor c=0.00835894f //x=7.68 \
 //y=2.77 //x2=8.98 //y2=3.88
cc_744 ( N_noxref_3_c_690_n N_B_c_1644_n ) capacitor c=0.0634769f //x=13.635 \
 //y=2.755 //x2=8.98 //y2=3.88
cc_745 ( N_noxref_3_c_703_p N_B_c_1717_n ) capacitor c=0.00753295f //x=13.69 \
 //y=2.915 //x2=15.31 //y2=3.14
cc_746 ( N_noxref_3_c_708_p N_B_c_1717_n ) capacitor c=0.0196093f //x=13.69 \
 //y=4.73 //x2=15.31 //y2=3.14
cc_747 ( N_noxref_3_c_714_p N_B_c_1717_n ) capacitor c=0.0367867f //x=13.795 \
 //y=2.755 //x2=15.31 //y2=3.14
cc_748 ( N_noxref_3_c_690_n N_B_c_1717_n ) capacitor c=0.270373f //x=13.635 \
 //y=2.755 //x2=15.31 //y2=3.14
cc_749 ( N_noxref_3_c_708_p N_B_c_1721_n ) capacitor c=0.0248503f //x=13.69 \
 //y=4.73 //x2=15.535 //y2=4.655
cc_750 ( N_noxref_3_c_718_p N_B_c_1721_n ) capacitor c=0.0201961f //x=13.69 \
 //y=4.877 //x2=15.535 //y2=4.655
cc_751 ( N_noxref_3_c_690_n N_B_c_1658_n ) capacitor c=0.0201626f //x=13.635 \
 //y=2.755 //x2=10.105 //y2=3.87
cc_752 ( N_noxref_3_c_690_n N_B_c_1659_n ) capacitor c=0.0367391f //x=13.635 \
 //y=2.755 //x2=10.64 //y2=3.155
cc_753 ( N_noxref_3_c_708_p N_B_c_1725_n ) capacitor c=9.46427e-19 //x=13.69 \
 //y=4.73 //x2=12.7 //y2=4.62
cc_754 ( N_noxref_3_c_718_p N_B_c_1725_n ) capacitor c=0.0027039f //x=13.69 \
 //y=4.877 //x2=12.7 //y2=4.62
cc_755 ( N_noxref_3_c_719_p N_B_c_1725_n ) capacitor c=0.00143289f //x=13.81 \
 //y=4.88 //x2=12.7 //y2=4.62
cc_756 ( N_noxref_3_c_720_p N_B_c_1725_n ) capacitor c=0.0018309f //x=13.81 \
 //y=4.88 //x2=12.7 //y2=4.62
cc_757 ( N_noxref_3_M23_noxref_g N_B_M21_noxref_g ) capacitor c=0.0102032f \
 //x=13.48 //y=6.2 //x2=12.6 //y2=6.2
cc_758 ( N_noxref_3_M23_noxref_g N_B_M22_noxref_g ) capacitor c=0.0618439f \
 //x=13.48 //y=6.2 //x2=13.04 //y2=6.2
cc_759 ( N_noxref_3_M24_noxref_g N_B_M22_noxref_g ) capacitor c=0.00945236f \
 //x=13.92 //y=6.2 //x2=13.04 //y2=6.2
cc_760 ( N_noxref_3_c_718_p N_B_c_1732_n ) capacitor c=0.00105639f //x=13.69 \
 //y=4.877 //x2=12.7 //y2=4.88
cc_761 ( N_noxref_3_c_719_p N_B_c_1732_n ) capacitor c=0.00166675f //x=13.81 \
 //y=4.88 //x2=12.7 //y2=4.88
cc_762 ( N_noxref_3_c_720_p N_B_c_1732_n ) capacitor c=0.0664454f //x=13.81 \
 //y=4.88 //x2=12.7 //y2=4.88
cc_763 ( N_noxref_3_c_641_n N_VDD_c_2034_n ) capacitor c=0.00259718f //x=7.155 \
 //y=5.42 //x2=9.405 //y2=7.585
cc_764 ( N_noxref_3_c_654_n N_VDD_c_2034_n ) capacitor c=0.00266269f //x=7.435 \
 //y=5.14 //x2=9.405 //y2=7.585
cc_765 ( N_noxref_3_c_693_n N_VDD_c_2034_n ) capacitor c=0.00241566f //x=7.155 \
 //y=5.56 //x2=9.405 //y2=7.585
cc_766 ( N_noxref_3_c_641_n N_VDD_c_2105_n ) capacitor c=8.96756e-19 //x=7.155 \
 //y=5.42 //x2=7.51 //y2=7.585
cc_767 ( N_noxref_3_c_654_n N_VDD_c_2105_n ) capacitor c=0.00197507f //x=7.435 \
 //y=5.14 //x2=7.51 //y2=7.585
cc_768 ( N_noxref_3_c_693_n N_VDD_c_2105_n ) capacitor c=0.0138017f //x=7.155 \
 //y=5.56 //x2=7.51 //y2=7.585
cc_769 ( N_noxref_3_M23_noxref_g N_VDD_c_2161_n ) capacitor c=0.00777954f \
 //x=13.48 //y=6.2 //x2=14.75 //y2=7.585
cc_770 ( N_noxref_3_M24_noxref_g N_VDD_c_2161_n ) capacitor c=0.00758899f \
 //x=13.92 //y=6.2 //x2=14.75 //y2=7.585
cc_771 ( N_noxref_3_c_643_n N_VDD_c_2067_n ) capacitor c=0.0049725f //x=7.24 \
 //y=5.14 //x2=6.04 //y2=7.585
cc_772 ( N_noxref_3_c_693_n N_VDD_c_2067_n ) capacitor c=0.00822234f //x=7.155 \
 //y=5.56 //x2=6.04 //y2=7.585
cc_773 ( N_noxref_3_c_641_n N_VDD_c_2127_n ) capacitor c=0.00232499f //x=7.155 \
 //y=5.42 //x2=8.26 //y2=7.585
cc_774 ( N_noxref_3_c_666_n N_VDD_c_2127_n ) capacitor c=0.022029f //x=7.52 \
 //y=5.055 //x2=8.26 //y2=7.585
cc_775 ( N_noxref_3_c_693_n N_VDD_c_2127_n ) capacitor c=0.00820601f //x=7.155 \
 //y=5.56 //x2=8.26 //y2=7.585
cc_776 ( N_noxref_3_c_708_p N_VDD_c_2168_n ) capacitor c=8.19548e-19 //x=13.69 \
 //y=4.73 //x2=11.59 //y2=7.585
cc_777 ( N_noxref_3_c_719_p N_VDD_c_2169_n ) capacitor c=0.00347772f //x=13.81 \
 //y=4.88 //x2=14.92 //y2=7.585
cc_778 ( N_noxref_3_c_720_p N_VDD_c_2169_n ) capacitor c=0.0199669f //x=13.81 \
 //y=4.88 //x2=14.92 //y2=7.585
cc_779 ( N_noxref_3_c_693_n N_VDD_c_2070_n ) capacitor c=0.00135089f //x=7.155 \
 //y=5.56 //x2=16.4 //y2=7.58
cc_780 ( N_noxref_3_c_641_n N_VDD_M14_noxref_d ) capacitor c=9.53785e-19 \
 //x=7.155 //y=5.42 //x2=5.23 //y2=5.2
cc_781 ( N_noxref_3_c_641_n N_VDD_M15_noxref_s ) capacitor c=0.0465566f \
 //x=7.155 //y=5.42 //x2=6.58 //y2=5.2
cc_782 ( N_noxref_3_c_693_n N_VDD_M15_noxref_s ) capacitor c=0.0898521f \
 //x=7.155 //y=5.56 //x2=6.58 //y2=5.2
cc_783 ( N_noxref_3_c_641_n N_VDD_M16_noxref_d ) capacitor c=0.0474638f \
 //x=7.155 //y=5.42 //x2=7.45 //y2=5.2
cc_784 ( N_noxref_3_c_654_n N_VDD_M16_noxref_d ) capacitor c=0.021356f \
 //x=7.435 //y=5.14 //x2=7.45 //y2=5.2
cc_785 ( N_noxref_3_c_664_n N_VDD_M16_noxref_d ) capacitor c=0.00162177f \
 //x=7.52 //y=2.93 //x2=7.45 //y2=5.2
cc_786 ( N_noxref_3_c_693_n N_VDD_M16_noxref_d ) capacitor c=0.0903919f \
 //x=7.155 //y=5.56 //x2=7.45 //y2=5.2
cc_787 ( N_noxref_3_c_658_n COUT ) capacitor c=0.00184304f //x=7.52 //y=2.61 \
 //x2=5.3 //y2=2.4
cc_788 ( N_noxref_3_c_666_n COUT ) capacitor c=0.00415104f //x=7.52 //y=5.055 \
 //x2=5.3 //y2=2.4
cc_789 ( N_noxref_3_c_639_n N_COUT_c_2401_n ) capacitor c=0.00704656f //x=7.15 \
 //y=1.935 //x2=4.93 //y2=1.935
cc_790 ( N_noxref_3_c_641_n N_COUT_c_2408_n ) capacitor c=0.00197056f \
 //x=7.155 //y=5.42 //x2=4.935 //y2=5.42
cc_791 ( N_noxref_3_c_642_n N_COUT_c_2412_n ) capacitor c=0.00392297f \
 //x=7.235 //y=2.02 //x2=5.215 //y2=2.02
cc_792 ( N_noxref_3_c_643_n N_COUT_c_2415_n ) capacitor c=0.00390812f //x=7.24 \
 //y=5.14 //x2=5.215 //y2=5.14
cc_793 ( N_noxref_3_c_681_n N_COUT_c_2419_n ) capacitor c=0.00705205f //x=7.15 \
 //y=1.185 //x2=4.93 //y2=1.185
cc_794 ( N_noxref_3_c_641_n N_noxref_9_c_2496_n ) capacitor c=0.00182388f \
 //x=7.155 //y=5.42 //x2=9.057 //y2=5.385
cc_795 ( N_noxref_3_M23_noxref_g N_noxref_10_c_2580_n ) capacitor \
 c=0.00901373f //x=13.48 //y=6.2 //x2=14.02 //y2=7.085
cc_796 ( N_noxref_3_M24_noxref_g N_noxref_10_c_2580_n ) capacitor \
 c=0.00932531f //x=13.92 //y=6.2 //x2=14.02 //y2=7.085
cc_797 ( N_noxref_3_M23_noxref_g N_noxref_10_c_2582_n ) capacitor \
 c=0.00175157f //x=13.48 //y=6.2 //x2=13.26 //y2=5.385
cc_798 ( N_noxref_3_M23_noxref_g N_noxref_10_c_2583_n ) capacitor \
 c=0.00178586f //x=13.48 //y=6.2 //x2=13.26 //y2=6.915
cc_799 ( N_noxref_3_M24_noxref_g N_noxref_10_c_2584_n ) capacitor \
 c=0.00406674f //x=13.92 //y=6.2 //x2=14.14 //y2=6.915
cc_800 ( N_noxref_3_M23_noxref_g N_noxref_10_c_2585_n ) capacitor c=0.0170175f \
 //x=13.48 //y=6.2 //x2=13.26 //y2=5.555
cc_801 ( N_noxref_3_M24_noxref_g N_noxref_10_M24_noxref_d ) capacitor \
 c=0.0365939f //x=13.92 //y=6.2 //x2=13.995 //y2=5.2
cc_802 ( N_noxref_3_c_652_n N_GND_c_2661_n ) capacitor c=0.00499594f //x=7.435 \
 //y=2.02 //x2=9.355 //y2=0.175
cc_803 ( N_noxref_3_c_664_n N_GND_c_2661_n ) capacitor c=6.43251e-19 //x=7.52 \
 //y=2.93 //x2=9.355 //y2=0.175
cc_804 ( N_noxref_3_c_681_n N_GND_c_2661_n ) capacitor c=0.00998676f //x=7.15 \
 //y=1.185 //x2=9.355 //y2=0.175
cc_805 ( N_noxref_3_c_687_n N_GND_c_2661_n ) capacitor c=4.46354e-19 //x=7.52 \
 //y=2.77 //x2=9.355 //y2=0.175
cc_806 ( N_noxref_3_M3_noxref_d N_GND_c_2661_n ) capacitor c=0.00119455f \
 //x=6.965 //y=1.09 //x2=9.355 //y2=0.175
cc_807 ( N_noxref_3_c_681_n N_GND_c_2703_n ) capacitor c=0.00528311f //x=7.15 \
 //y=1.185 //x2=9.44 //y2=1.025
cc_808 ( N_noxref_3_c_690_n N_GND_c_2703_n ) capacitor c=0.00379351f \
 //x=13.635 //y=2.755 //x2=9.44 //y2=1.025
cc_809 ( N_noxref_3_c_690_n N_GND_c_2777_n ) capacitor c=0.00361852f \
 //x=13.635 //y=2.755 //x2=12.77 //y2=1.025
cc_810 ( N_noxref_3_c_703_p N_GND_c_2778_n ) capacitor c=2.07687e-19 //x=13.69 \
 //y=2.915 //x2=16.4 //y2=0.18
cc_811 ( N_noxref_3_c_681_n N_GND_c_2730_n ) capacitor c=0.00124813f //x=7.15 \
 //y=1.185 //x2=7.065 //y2=0.715
cc_812 ( N_noxref_3_c_652_n N_GND_c_2734_n ) capacitor c=0.0030723f //x=7.435 \
 //y=2.02 //x2=7.555 //y2=0.715
cc_813 ( N_noxref_3_c_681_n N_GND_c_2734_n ) capacitor c=0.00130539f //x=7.15 \
 //y=1.185 //x2=7.555 //y2=0.715
cc_814 ( N_noxref_3_c_687_n N_GND_c_2734_n ) capacitor c=4.2833e-19 //x=7.52 \
 //y=2.77 //x2=7.555 //y2=0.715
cc_815 ( N_noxref_3_c_639_n N_GND_c_2686_n ) capacitor c=0.00291377f //x=7.15 \
 //y=1.935 //x2=6.04 //y2=0.175
cc_816 ( N_noxref_3_c_687_n N_GND_c_2686_n ) capacitor c=0.00313158f //x=7.52 \
 //y=2.77 //x2=6.04 //y2=0.175
cc_817 ( N_noxref_3_c_652_n N_GND_c_2741_n ) capacitor c=0.0161089f //x=7.435 \
 //y=2.02 //x2=8.26 //y2=0.175
cc_818 ( N_noxref_3_c_664_n N_GND_c_2741_n ) capacitor c=0.00439621f //x=7.52 \
 //y=2.93 //x2=8.26 //y2=0.175
cc_819 ( N_noxref_3_c_687_n N_GND_c_2741_n ) capacitor c=0.0101813f //x=7.52 \
 //y=2.77 //x2=8.26 //y2=0.175
cc_820 ( N_noxref_3_c_690_n N_GND_c_2741_n ) capacitor c=0.0235403f //x=13.635 \
 //y=2.755 //x2=8.26 //y2=0.175
cc_821 ( N_noxref_3_c_713_p N_GND_c_2789_n ) capacitor c=0.00118906f //x=13.81 \
 //y=2.77 //x2=11.59 //y2=0.175
cc_822 ( N_noxref_3_c_690_n N_GND_c_2789_n ) capacitor c=0.0236769f //x=13.635 \
 //y=2.755 //x2=11.59 //y2=0.175
cc_823 ( N_noxref_3_c_713_p N_GND_c_2791_n ) capacitor c=0.00499198f //x=13.81 \
 //y=2.77 //x2=14.92 //y2=0.175
cc_824 ( N_noxref_3_c_715_p N_GND_c_2791_n ) capacitor c=0.00371073f //x=13.81 \
 //y=2.265 //x2=14.92 //y2=0.175
cc_825 ( N_noxref_3_c_716_p N_GND_c_2791_n ) capacitor c=0.00539594f \
 //x=13.475 //y=2.1 //x2=14.92 //y2=0.175
cc_826 ( N_noxref_3_c_736_p N_GND_c_2791_n ) capacitor c=0.00230557f \
 //x=14.005 //y=1.435 //x2=14.92 //y2=0.175
cc_827 ( N_noxref_3_c_681_n N_GND_c_2687_n ) capacitor c=2.8029e-19 //x=7.15 \
 //y=1.185 //x2=16.51 //y2=0.175
cc_828 ( N_noxref_3_M3_noxref_d N_GND_c_2687_n ) capacitor c=2.70835e-19 \
 //x=6.965 //y=1.09 //x2=16.51 //y2=0.175
cc_829 ( N_noxref_3_c_639_n N_GND_M3_noxref_s ) capacitor c=0.0300565f \
 //x=7.15 //y=1.935 //x2=6.535 //y2=0.55
cc_830 ( N_noxref_3_c_652_n N_GND_M3_noxref_s ) capacitor c=0.00316907f \
 //x=7.435 //y=2.02 //x2=6.535 //y2=0.55
cc_831 ( N_noxref_3_c_664_n N_GND_M3_noxref_s ) capacitor c=0.00297082f \
 //x=7.52 //y=2.93 //x2=6.535 //y2=0.55
cc_832 ( N_noxref_3_c_681_n N_GND_M3_noxref_s ) capacitor c=0.0139882f \
 //x=7.15 //y=1.185 //x2=6.535 //y2=0.55
cc_833 ( N_noxref_3_c_687_n N_GND_M3_noxref_s ) capacitor c=0.00227202f \
 //x=7.52 //y=2.77 //x2=6.535 //y2=0.55
cc_834 ( N_noxref_3_M3_noxref_d N_GND_M3_noxref_s ) capacitor c=0.0377642f \
 //x=6.965 //y=1.09 //x2=6.535 //y2=0.55
cc_835 ( N_noxref_3_c_690_n N_noxref_13_c_3080_n ) capacitor c=0.0037497f \
 //x=13.635 //y=2.755 //x2=8.955 //y2=1.68
cc_836 ( N_noxref_3_c_690_n N_noxref_13_c_3081_n ) capacitor c=0.0113045f \
 //x=13.635 //y=2.755 //x2=9.84 //y2=1.765
cc_837 ( N_noxref_3_c_690_n N_noxref_13_c_3088_n ) capacitor c=0.00346979f \
 //x=13.635 //y=2.755 //x2=9.925 //y2=1.68
cc_838 ( N_noxref_3_c_690_n N_noxref_13_c_3095_n ) capacitor c=0.00227166f \
 //x=13.635 //y=2.755 //x2=10.81 //y2=0.715
cc_839 ( N_noxref_3_c_690_n N_noxref_14_c_3146_n ) capacitor c=0.0037497f \
 //x=13.635 //y=2.755 //x2=12.285 //y2=1.68
cc_840 ( N_noxref_3_c_690_n N_noxref_14_c_3147_n ) capacitor c=0.0117017f \
 //x=13.635 //y=2.755 //x2=13.17 //y2=1.765
cc_841 ( N_noxref_3_c_690_n N_noxref_14_c_3148_n ) capacitor c=0.0037497f \
 //x=13.635 //y=2.755 //x2=13.255 //y2=1.68
cc_842 ( N_noxref_3_c_738_p N_noxref_14_c_3148_n ) capacitor c=0.00888238f \
 //x=13.475 //y=1.745 //x2=13.255 //y2=1.68
cc_843 ( N_noxref_3_c_703_p N_noxref_14_c_3150_n ) capacitor c=5.34835e-19 \
 //x=13.69 //y=2.915 //x2=14.14 //y2=0.715
cc_844 ( N_noxref_3_c_690_n N_noxref_14_c_3150_n ) capacitor c=0.00149097f \
 //x=13.635 //y=2.755 //x2=14.14 //y2=0.715
cc_845 ( N_noxref_3_c_715_p N_noxref_14_c_3150_n ) capacitor c=4.1952e-19 \
 //x=13.81 //y=2.265 //x2=14.14 //y2=0.715
cc_846 ( N_noxref_3_c_731_p N_noxref_14_c_3150_n ) capacitor c=0.0204604f \
 //x=13.475 //y=1.09 //x2=14.14 //y2=0.715
cc_847 ( N_noxref_3_c_716_p N_noxref_14_c_3150_n ) capacitor c=2.1838e-19 \
 //x=13.475 //y=2.1 //x2=14.14 //y2=0.715
cc_848 ( N_noxref_3_c_735_p N_noxref_14_c_3150_n ) capacitor c=0.00825432f \
 //x=14.005 //y=1.09 //x2=14.14 //y2=0.715
cc_849 ( N_noxref_3_c_731_p N_noxref_14_M6_noxref_s ) capacitor c=0.00888238f \
 //x=13.475 //y=1.09 //x2=12.15 //y2=0.55
cc_850 ( N_noxref_3_c_735_p N_noxref_14_M6_noxref_s ) capacitor c=0.015333f \
 //x=14.005 //y=1.09 //x2=12.15 //y2=0.55
cc_851 ( N_noxref_3_c_736_p N_noxref_14_M6_noxref_s ) capacitor c=0.00248746f \
 //x=14.005 //y=1.435 //x2=12.15 //y2=0.55
cc_852 ( SUM N_noxref_5_c_1291_n ) capacitor c=0.045828f //x=10.97 //y=4.99 \
 //x2=10.48 //y2=4.575
cc_853 ( N_SUM_c_1026_p N_noxref_5_c_1291_n ) capacitor c=0.0025962f \
 //x=10.885 //y=5.385 //x2=10.48 //y2=4.575
cc_854 ( N_SUM_c_967_n N_noxref_5_c_1291_n ) capacitor c=2.64348e-19 \
 //x=10.885 //y=1.835 //x2=10.48 //y2=4.575
cc_855 ( N_SUM_c_1001_n N_noxref_5_c_1291_n ) capacitor c=6.66577e-19 \
 //x=10.37 //y=5.385 //x2=10.48 //y2=4.575
cc_856 ( SUM N_noxref_5_c_1240_n ) capacitor c=0.0334637f //x=10.97 //y=4.99 \
 //x2=10.48 //y2=4.765
cc_857 ( N_SUM_c_1026_p N_noxref_5_c_1240_n ) capacitor c=0.00223526f \
 //x=10.885 //y=5.385 //x2=10.48 //y2=4.765
cc_858 ( N_SUM_c_1001_n N_noxref_5_c_1240_n ) capacitor c=0.0171937f //x=10.37 \
 //y=5.385 //x2=10.48 //y2=4.765
cc_859 ( N_SUM_c_1032_p N_noxref_5_c_1240_n ) capacitor c=0.00137304f \
 //x=10.37 //y=5.555 //x2=10.48 //y2=4.765
cc_860 ( SUM N_noxref_5_c_1255_n ) capacitor c=0.00484003f //x=10.97 //y=2.4 \
 //x2=12.7 //y2=2.385
cc_861 ( SUM N_noxref_5_c_1259_n ) capacitor c=0.0129604f //x=10.97 //y=2.4 \
 //x2=12.7 //y2=3.385
cc_862 ( SUM N_noxref_5_c_1259_n ) capacitor c=0.00378988f //x=14.18 //y=2.4 \
 //x2=12.7 //y2=3.385
cc_863 ( SUM N_noxref_5_c_1302_n ) capacitor c=0.00398704f //x=14.18 //y=2.4 \
 //x2=15.66 //y2=3.655
cc_864 ( SUM N_noxref_5_c_1266_n ) capacitor c=0.0016325f //x=14.18 //y=2.4 \
 //x2=15.66 //y2=4.135
cc_865 ( SUM N_noxref_5_c_1266_n ) capacitor c=0.00139895f //x=14.18 //y=4.99 \
 //x2=15.66 //y2=4.135
cc_866 ( SUM N_noxref_5_c_1266_n ) capacitor c=3.17649e-19 //x=14.18 //y=3.88 \
 //x2=15.66 //y2=4.135
cc_867 ( N_SUM_c_997_n N_noxref_5_c_1266_n ) capacitor c=0.00493311f //x=14.18 \
 //y=4.055 //x2=15.66 //y2=4.135
cc_868 ( N_SUM_c_1008_n N_noxref_5_c_1266_n ) capacitor c=0.005854f //x=14.195 \
 //y=3.895 //x2=15.66 //y2=4.135
cc_869 ( SUM N_noxref_5_c_1308_n ) capacitor c=0.00436509f //x=14.18 //y=4.99 \
 //x2=15.66 //y2=4.43
cc_870 ( SUM N_noxref_5_c_1267_n ) capacitor c=0.0135782f //x=14.18 //y=4.99 \
 //x2=15.66 //y2=5.055
cc_871 ( SUM N_noxref_5_c_1310_n ) capacitor c=0.0263739f //x=14.18 //y=2.4 \
 //x2=15.745 //y2=2.02
cc_872 ( SUM N_noxref_5_c_1311_n ) capacitor c=0.00270091f //x=14.18 //y=4.99 \
 //x2=16.025 //y2=5.42
cc_873 ( N_SUM_c_1002_n N_noxref_5_c_1311_n ) capacitor c=4.99083e-19 //x=13.7 \
 //y=5.385 //x2=16.025 //y2=5.42
cc_874 ( N_SUM_c_978_n N_noxref_5_c_1313_n ) capacitor c=0.00464508f //x=13.74 \
 //y=1.75 //x2=16.03 //y2=1.935
cc_875 ( N_SUM_c_986_n N_noxref_5_c_1313_n ) capacitor c=0.00329276f \
 //x=14.095 //y=1.835 //x2=16.03 //y2=1.935
cc_876 ( SUM N_noxref_5_c_1244_n ) capacitor c=0.00631451f //x=10.97 //y=4.99 \
 //x2=10.525 //y2=4.415
cc_877 ( SUM N_noxref_5_c_1268_n ) capacitor c=0.00403661f //x=10.97 //y=2.4 \
 //x2=12.7 //y2=3.51
cc_878 ( N_SUM_c_1009_n N_noxref_5_c_1268_n ) capacitor c=0.00760299f \
 //x=14.035 //y=3.895 //x2=12.7 //y2=3.51
cc_879 ( SUM N_noxref_5_c_1318_n ) capacitor c=2.17715e-19 //x=14.18 //y=2.4 \
 //x2=15.66 //y2=3.51
cc_880 ( SUM N_noxref_5_c_1319_n ) capacitor c=5.93415e-19 //x=14.18 //y=4.99 \
 //x2=15.66 //y2=4.25
cc_881 ( N_SUM_c_970_n N_noxref_5_c_1320_n ) capacitor c=0.00582787f //x=13.74 \
 //y=1.3 //x2=16.03 //y2=1.185
cc_882 ( N_SUM_c_978_n N_noxref_5_c_1320_n ) capacitor c=6.23317e-19 //x=13.74 \
 //y=1.75 //x2=16.03 //y2=1.185
cc_883 ( SUM N_noxref_5_c_1322_n ) capacitor c=0.00664189f //x=10.97 //y=4.99 \
 //x2=10.525 //y2=4.28
cc_884 ( SUM N_noxref_5_c_1269_n ) capacitor c=0.00354109f //x=10.97 //y=2.4 \
 //x2=12.86 //y2=3.525
cc_885 ( N_SUM_c_1009_n N_noxref_5_c_1269_n ) capacitor c=0.0349865f \
 //x=14.035 //y=3.895 //x2=12.86 //y2=3.525
cc_886 ( SUM N_noxref_5_c_1325_n ) capacitor c=0.0016766f //x=14.18 //y=4.99 \
 //x2=15.665 //y2=4.27
cc_887 ( SUM N_noxref_5_c_1271_n ) capacitor c=0.0227803f //x=10.97 //y=4.99 \
 //x2=15.505 //y2=4.27
cc_888 ( SUM N_noxref_5_c_1271_n ) capacitor c=0.0201136f //x=14.18 //y=4.99 \
 //x2=15.505 //y2=4.27
cc_889 ( N_SUM_c_969_n N_noxref_5_c_1271_n ) capacitor c=0.00564019f //x=10.97 \
 //y=4.055 //x2=15.505 //y2=4.27
cc_890 ( N_SUM_c_997_n N_noxref_5_c_1271_n ) capacitor c=0.00540116f //x=14.18 \
 //y=4.055 //x2=15.505 //y2=4.27
cc_891 ( N_SUM_c_1007_n N_noxref_5_c_1271_n ) capacitor c=0.0358686f \
 //x=11.175 //y=3.895 //x2=15.505 //y2=4.27
cc_892 ( N_SUM_c_1008_n N_noxref_5_c_1271_n ) capacitor c=0.0360345f \
 //x=14.195 //y=3.895 //x2=15.505 //y2=4.27
cc_893 ( N_SUM_c_1009_n N_noxref_5_c_1271_n ) capacitor c=0.247957f //x=14.035 \
 //y=3.895 //x2=15.505 //y2=4.27
cc_894 ( SUM N_noxref_5_c_1333_n ) capacitor c=0.00191229f //x=14.18 //y=2.4 \
 //x2=15.695 //y2=3.495
cc_895 ( SUM N_noxref_5_c_1273_n ) capacitor c=0.0203568f //x=14.18 //y=2.4 \
 //x2=15.535 //y2=3.495
cc_896 ( N_SUM_c_997_n N_noxref_5_c_1273_n ) capacitor c=0.0076014f //x=14.18 \
 //y=4.055 //x2=15.535 //y2=3.495
cc_897 ( N_SUM_c_1008_n N_noxref_5_c_1273_n ) capacitor c=0.0360345f \
 //x=14.195 //y=3.895 //x2=15.535 //y2=3.495
cc_898 ( N_SUM_c_1009_n N_noxref_5_c_1273_n ) capacitor c=0.0922798f \
 //x=14.035 //y=3.895 //x2=15.535 //y2=3.495
cc_899 ( SUM N_noxref_5_c_1245_n ) capacitor c=0.00457096f //x=10.97 //y=4.99 \
 //x2=10.48 //y2=4.88
cc_900 ( N_SUM_c_1026_p N_noxref_5_c_1245_n ) capacitor c=0.00104675f \
 //x=10.885 //y=5.385 //x2=10.48 //y2=4.88
cc_901 ( N_SUM_c_1001_n N_noxref_5_c_1245_n ) capacitor c=0.00390413f \
 //x=10.37 //y=5.385 //x2=10.48 //y2=4.88
cc_902 ( N_SUM_c_1032_p N_noxref_5_c_1245_n ) capacitor c=0.00341371f \
 //x=10.37 //y=5.555 //x2=10.48 //y2=4.88
cc_903 ( N_SUM_c_1001_n N_noxref_5_M19_noxref_g ) capacitor c=0.00179689f \
 //x=10.37 //y=5.385 //x2=10.15 //y2=6.2
cc_904 ( N_SUM_c_1032_p N_noxref_5_M19_noxref_g ) capacitor c=0.0120591f \
 //x=10.37 //y=5.555 //x2=10.15 //y2=6.2
cc_905 ( N_SUM_c_1026_p N_noxref_5_M20_noxref_g ) capacitor c=0.00976373f \
 //x=10.885 //y=5.385 //x2=10.59 //y2=6.2
cc_906 ( N_SUM_c_1001_n N_noxref_5_M20_noxref_g ) capacitor c=0.00277466f \
 //x=10.37 //y=5.385 //x2=10.59 //y2=6.2
cc_907 ( N_SUM_c_1032_p N_noxref_5_M20_noxref_g ) capacitor c=0.0140704f \
 //x=10.37 //y=5.555 //x2=10.59 //y2=6.2
cc_908 ( SUM N_noxref_5_c_1252_n ) capacitor c=0.00986822f //x=10.97 //y=4.99 \
 //x2=10.48 //y2=4.88
cc_909 ( N_SUM_c_1001_n N_noxref_5_c_1252_n ) capacitor c=0.00203067f \
 //x=10.37 //y=5.385 //x2=10.48 //y2=4.88
cc_910 ( N_SUM_c_1032_p N_noxref_5_c_1252_n ) capacitor c=0.00435839f \
 //x=10.37 //y=5.555 //x2=10.48 //y2=4.88
cc_911 ( SUM B ) capacitor c=0.00186903f //x=14.18 //y=2.4 //x2=16.4 //y2=2.77
cc_912 ( SUM B ) capacitor c=0.00118611f //x=14.18 //y=2.4 //x2=16.4 //y2=3.51
cc_913 ( SUM B ) capacitor c=0.00142372f //x=14.18 //y=4.99 //x2=16.4 //y2=3.51
cc_914 ( SUM B ) capacitor c=0.00284187f //x=10.97 //y=2.4 //x2=10.11 //y2=3.88
cc_915 ( SUM B ) capacitor c=0.00362964f //x=10.97 //y=4.99 //x2=10.11 //y2=3.88
cc_916 ( SUM B ) capacitor c=0.00758181f //x=11.02 //y=3.88 //x2=10.11 //y2=3.88
cc_917 ( N_SUM_c_969_n B ) capacitor c=0.0137021f //x=10.97 //y=4.055 \
 //x2=10.11 //y2=3.88
cc_918 ( N_SUM_c_1007_n B ) capacitor c=0.00285514f //x=11.175 //y=3.895 \
 //x2=10.11 //y2=3.88
cc_919 ( SUM B ) capacitor c=0.0348988f //x=10.97 //y=2.4 //x2=10.48 //y2=3.14
cc_920 ( N_SUM_c_967_n B ) capacitor c=0.00236659f //x=10.885 //y=1.835 \
 //x2=10.48 //y2=3.14
cc_921 ( N_SUM_c_968_n B ) capacitor c=7.25731e-19 //x=10.495 //y=1.835 \
 //x2=10.48 //y2=3.14
cc_922 ( N_SUM_c_1001_n B ) capacitor c=2.87883e-19 //x=10.37 //y=5.385 \
 //x2=10.48 //y2=3.14
cc_923 ( SUM B ) capacitor c=0.00461217f //x=10.97 //y=4.99 //x2=12.7 //y2=4.62
cc_924 ( SUM N_B_c_1625_n ) capacitor c=0.0257645f //x=10.97 //y=2.4 \
 //x2=10.48 //y2=2.415
cc_925 ( N_SUM_c_967_n N_B_c_1625_n ) capacitor c=0.00282714f //x=10.885 \
 //y=1.835 //x2=10.48 //y2=2.415
cc_926 ( N_SUM_c_968_n N_B_c_1625_n ) capacitor c=0.0240673f //x=10.495 \
 //y=1.835 //x2=10.48 //y2=2.415
cc_927 ( N_SUM_M5_noxref_d N_B_c_1625_n ) capacitor c=4.61207e-19 //x=10.22 \
 //y=1.09 //x2=10.48 //y2=2.415
cc_928 ( SUM N_B_c_1628_n ) capacitor c=0.0370664f //x=10.97 //y=2.4 \
 //x2=10.48 //y2=2.995
cc_929 ( SUM N_B_c_1650_n ) capacitor c=0.00164938f //x=10.97 //y=4.99 \
 //x2=10.11 //y2=4.96
cc_930 ( N_SUM_c_1007_n N_B_c_1650_n ) capacitor c=0.00116229f //x=11.175 \
 //y=3.895 //x2=10.11 //y2=4.96
cc_931 ( SUM N_B_c_1755_n ) capacitor c=0.0299731f //x=10.97 //y=4.99 \
 //x2=12.54 //y2=5.045
cc_932 ( N_SUM_c_1001_n N_B_c_1755_n ) capacitor c=0.0301487f //x=10.37 \
 //y=5.385 //x2=12.54 //y2=5.045
cc_933 ( N_SUM_c_1009_n N_B_c_1755_n ) capacitor c=0.00489848f //x=14.035 \
 //y=3.895 //x2=12.54 //y2=5.045
cc_934 ( SUM N_B_c_1717_n ) capacitor c=0.0222476f //x=10.97 //y=2.4 \
 //x2=15.31 //y2=3.14
cc_935 ( SUM N_B_c_1717_n ) capacitor c=0.0277835f //x=14.18 //y=2.4 \
 //x2=15.31 //y2=3.14
cc_936 ( N_SUM_c_969_n N_B_c_1717_n ) capacitor c=0.00652184f //x=10.97 \
 //y=4.055 //x2=15.31 //y2=3.14
cc_937 ( N_SUM_c_986_n N_B_c_1717_n ) capacitor c=0.00271047f //x=14.095 \
 //y=1.835 //x2=15.31 //y2=3.14
cc_938 ( N_SUM_c_1007_n N_B_c_1717_n ) capacitor c=0.0157015f //x=11.175 \
 //y=3.895 //x2=15.31 //y2=3.14
cc_939 ( N_SUM_c_1008_n N_B_c_1717_n ) capacitor c=7.21807e-19 //x=14.195 \
 //y=3.895 //x2=15.31 //y2=3.14
cc_940 ( N_SUM_c_1009_n N_B_c_1717_n ) capacitor c=0.0680498f //x=14.035 \
 //y=3.895 //x2=15.31 //y2=3.14
cc_941 ( SUM N_B_c_1721_n ) capacitor c=0.0049246f //x=10.97 //y=4.99 \
 //x2=15.535 //y2=4.655
cc_942 ( SUM N_B_c_1721_n ) capacitor c=0.0297377f //x=14.18 //y=4.99 \
 //x2=15.535 //y2=4.655
cc_943 ( N_SUM_c_983_n N_B_c_1721_n ) capacitor c=0.00552068f //x=14.095 \
 //y=5.385 //x2=15.535 //y2=4.655
cc_944 ( N_SUM_c_1002_n N_B_c_1721_n ) capacitor c=6.46296e-19 //x=13.7 \
 //y=5.385 //x2=15.535 //y2=4.655
cc_945 ( N_SUM_c_1008_n N_B_c_1721_n ) capacitor c=7.60969e-19 //x=14.195 \
 //y=3.895 //x2=15.535 //y2=4.655
cc_946 ( N_SUM_c_1009_n N_B_c_1721_n ) capacitor c=0.00744882f //x=14.035 \
 //y=3.895 //x2=15.535 //y2=4.655
cc_947 ( SUM N_B_c_1658_n ) capacitor c=5.20247e-19 //x=10.97 //y=2.4 \
 //x2=10.105 //y2=3.87
cc_948 ( N_SUM_c_969_n N_B_c_1658_n ) capacitor c=0.00254555f //x=10.97 \
 //y=4.055 //x2=10.105 //y2=3.87
cc_949 ( N_SUM_c_1007_n N_B_c_1658_n ) capacitor c=0.0144463f //x=11.175 \
 //y=3.895 //x2=10.105 //y2=3.87
cc_950 ( SUM N_B_c_1659_n ) capacitor c=0.00470736f //x=10.97 //y=2.4 \
 //x2=10.64 //y2=3.155
cc_951 ( SUM N_B_c_1668_n ) capacitor c=0.00169572f //x=10.97 //y=2.4 \
 //x2=10.48 //y2=2.265
cc_952 ( N_SUM_c_967_n N_B_c_1668_n ) capacitor c=0.00147657f //x=10.885 \
 //y=1.835 //x2=10.48 //y2=2.265
cc_953 ( N_SUM_c_968_n N_B_c_1668_n ) capacitor c=0.00408056f //x=10.495 \
 //y=1.835 //x2=10.48 //y2=2.265
cc_954 ( N_SUM_M5_noxref_d N_B_c_1668_n ) capacitor c=0.00150031f //x=10.22 \
 //y=1.09 //x2=10.48 //y2=2.265
cc_955 ( N_SUM_c_963_n N_B_c_1684_n ) capacitor c=5.45132e-19 //x=10.41 \
 //y=1.305 //x2=10.145 //y2=1.09
cc_956 ( N_SUM_M5_noxref_d N_B_c_1684_n ) capacitor c=0.00137165f //x=10.22 \
 //y=1.09 //x2=10.145 //y2=1.09
cc_957 ( N_SUM_c_963_n N_B_c_1687_n ) capacitor c=0.00220865f //x=10.41 \
 //y=1.305 //x2=10.145 //y2=1.435
cc_958 ( N_SUM_c_965_n N_B_c_1687_n ) capacitor c=0.00118531f //x=10.41 \
 //y=1.75 //x2=10.145 //y2=1.435
cc_959 ( N_SUM_M5_noxref_d N_B_c_1687_n ) capacitor c=0.00237422f //x=10.22 \
 //y=1.09 //x2=10.145 //y2=1.435
cc_960 ( N_SUM_c_965_n N_B_c_1689_n ) capacitor c=0.00409175f //x=10.41 \
 //y=1.75 //x2=10.145 //y2=1.745
cc_961 ( SUM N_B_c_1692_n ) capacitor c=0.00810353f //x=10.97 //y=2.4 \
 //x2=10.145 //y2=2.1
cc_962 ( N_SUM_c_965_n N_B_c_1692_n ) capacitor c=0.00341876f //x=10.41 \
 //y=1.75 //x2=10.145 //y2=2.1
cc_963 ( N_SUM_c_968_n N_B_c_1692_n ) capacitor c=0.00203544f //x=10.495 \
 //y=1.835 //x2=10.145 //y2=2.1
cc_964 ( N_SUM_M5_noxref_d N_B_c_1692_n ) capacitor c=4.64071e-19 //x=10.22 \
 //y=1.09 //x2=10.145 //y2=2.1
cc_965 ( N_SUM_c_963_n N_B_c_1789_n ) capacitor c=5.33629e-19 //x=10.41 \
 //y=1.305 //x2=10.52 //y2=0.935
cc_966 ( N_SUM_M5_noxref_d N_B_c_1789_n ) capacitor c=0.0020782f //x=10.22 \
 //y=1.09 //x2=10.52 //y2=0.935
cc_967 ( N_SUM_c_963_n N_B_c_1791_n ) capacitor c=5.44173e-19 //x=10.41 \
 //y=1.305 //x2=10.52 //y2=1.59
cc_968 ( N_SUM_c_965_n N_B_c_1791_n ) capacitor c=0.00758256f //x=10.41 \
 //y=1.75 //x2=10.52 //y2=1.59
cc_969 ( N_SUM_c_967_n N_B_c_1791_n ) capacitor c=0.00122055f //x=10.885 \
 //y=1.835 //x2=10.52 //y2=1.59
cc_970 ( N_SUM_M5_noxref_d N_B_c_1791_n ) capacitor c=0.00344131f //x=10.22 \
 //y=1.09 //x2=10.52 //y2=1.59
cc_971 ( N_SUM_c_963_n N_B_c_1695_n ) capacitor c=6.34991e-19 //x=10.41 \
 //y=1.305 //x2=10.675 //y2=1.09
cc_972 ( N_SUM_M5_noxref_d N_B_c_1695_n ) capacitor c=8.50094e-19 //x=10.22 \
 //y=1.09 //x2=10.675 //y2=1.09
cc_973 ( N_SUM_c_963_n N_B_c_1696_n ) capacitor c=0.00320504f //x=10.41 \
 //y=1.305 //x2=10.675 //y2=1.435
cc_974 ( N_SUM_c_965_n N_B_c_1696_n ) capacitor c=0.003249f //x=10.41 //y=1.75 \
 //x2=10.675 //y2=1.435
cc_975 ( N_SUM_c_967_n N_B_c_1696_n ) capacitor c=0.00300547f //x=10.885 \
 //y=1.835 //x2=10.675 //y2=1.435
cc_976 ( N_SUM_M5_noxref_d N_B_c_1696_n ) capacitor c=0.00237422f //x=10.22 \
 //y=1.09 //x2=10.675 //y2=1.435
cc_977 ( N_SUM_c_1026_p N_VDD_c_2179_n ) capacitor c=0.00189842f //x=10.885 \
 //y=5.385 //x2=12.735 //y2=7.585
cc_978 ( N_SUM_c_969_n N_VDD_c_2179_n ) capacitor c=6.60328e-19 //x=10.97 \
 //y=4.055 //x2=12.735 //y2=7.585
cc_979 ( N_SUM_c_983_n N_VDD_c_2181_n ) capacitor c=2.88396e-19 //x=14.095 \
 //y=5.385 //x2=16.4 //y2=7.58
cc_980 ( N_SUM_c_997_n N_VDD_c_2181_n ) capacitor c=2.35309e-19 //x=14.18 \
 //y=4.055 //x2=16.4 //y2=7.58
cc_981 ( N_SUM_c_1026_p N_VDD_c_2109_n ) capacitor c=9.37362e-19 //x=10.885 \
 //y=5.385 //x2=11.42 //y2=7.585
cc_982 ( N_SUM_c_1032_p N_VDD_c_2109_n ) capacitor c=0.00472214f //x=10.37 \
 //y=5.555 //x2=11.42 //y2=7.585
cc_983 ( N_SUM_c_1011_n N_VDD_c_2161_n ) capacitor c=0.00472214f //x=13.7 \
 //y=5.555 //x2=14.75 //y2=7.585
cc_984 ( SUM N_VDD_c_2127_n ) capacitor c=0.00106255f //x=10.97 //y=4.99 \
 //x2=8.26 //y2=7.585
cc_985 ( SUM N_VDD_c_2168_n ) capacitor c=0.0323444f //x=10.97 //y=4.99 \
 //x2=11.59 //y2=7.585
cc_986 ( SUM N_VDD_c_2168_n ) capacitor c=0.0010621f //x=14.18 //y=4.99 \
 //x2=11.59 //y2=7.585
cc_987 ( N_SUM_c_1001_n N_VDD_c_2168_n ) capacitor c=0.00269155f //x=10.37 \
 //y=5.385 //x2=11.59 //y2=7.585
cc_988 ( N_SUM_c_1032_p N_VDD_c_2168_n ) capacitor c=0.0091804f //x=10.37 \
 //y=5.555 //x2=11.59 //y2=7.585
cc_989 ( SUM N_VDD_c_2169_n ) capacitor c=0.0251234f //x=14.18 //y=4.99 \
 //x2=14.92 //y2=7.585
cc_990 ( N_SUM_c_1002_n N_VDD_c_2169_n ) capacitor c=0.00261447f //x=13.7 \
 //y=5.385 //x2=14.92 //y2=7.585
cc_991 ( N_SUM_c_1011_n N_VDD_c_2169_n ) capacitor c=0.00920443f //x=13.7 \
 //y=5.555 //x2=14.92 //y2=7.585
cc_992 ( N_SUM_c_1032_p N_VDD_c_2070_n ) capacitor c=2.29347e-19 //x=10.37 \
 //y=5.555 //x2=16.4 //y2=7.58
cc_993 ( N_SUM_c_1011_n N_VDD_c_2070_n ) capacitor c=2.29347e-19 //x=13.7 \
 //y=5.555 //x2=16.4 //y2=7.58
cc_994 ( N_SUM_c_1001_n N_VDD_M16_noxref_d ) capacitor c=2.46246e-19 //x=10.37 \
 //y=5.385 //x2=7.45 //y2=5.2
cc_995 ( N_SUM_c_1032_p N_VDD_M17_noxref_d ) capacitor c=0.00464138f //x=10.37 \
 //y=5.555 //x2=9.345 //y2=5.2
cc_996 ( N_SUM_c_1011_n N_VDD_M21_noxref_d ) capacitor c=0.00464146f //x=13.7 \
 //y=5.555 //x2=12.675 //y2=5.2
cc_997 ( N_SUM_c_983_n N_VDD_M25_noxref_s ) capacitor c=0.0032599f //x=14.095 \
 //y=5.385 //x2=15.46 //y2=5.2
cc_998 ( N_SUM_c_1002_n N_VDD_M25_noxref_s ) capacitor c=0.0057075f //x=13.7 \
 //y=5.385 //x2=15.46 //y2=5.2
cc_999 ( N_SUM_c_1026_p N_noxref_9_c_2506_n ) capacitor c=0.00286418f \
 //x=10.885 //y=5.385 //x2=10.695 //y2=7.085
cc_1000 ( N_SUM_c_1001_n N_noxref_9_c_2506_n ) capacitor c=0.00472823f \
 //x=10.37 //y=5.385 //x2=10.695 //y2=7.085
cc_1001 ( N_SUM_c_1032_p N_noxref_9_c_2506_n ) capacitor c=0.00407104f \
 //x=10.37 //y=5.555 //x2=10.695 //y2=7.085
cc_1002 ( N_SUM_c_1001_n N_noxref_9_c_2496_n ) capacitor c=6.22227e-19 \
 //x=10.37 //y=5.385 //x2=9.057 //y2=5.385
cc_1003 ( N_SUM_c_1001_n N_noxref_9_c_2499_n ) capacitor c=0.0507834f \
 //x=10.37 //y=5.385 //x2=9.93 //y2=5.385
cc_1004 ( N_SUM_c_1032_p N_noxref_9_c_2499_n ) capacitor c=0.00270385f \
 //x=10.37 //y=5.555 //x2=9.93 //y2=5.385
cc_1005 ( N_SUM_c_1026_p N_noxref_9_c_2512_n ) capacitor c=0.00436326f \
 //x=10.885 //y=5.385 //x2=10.81 //y2=6.915
cc_1006 ( N_SUM_c_1001_n N_noxref_9_c_2503_n ) capacitor c=0.00261471f \
 //x=10.37 //y=5.385 //x2=9.93 //y2=5.555
cc_1007 ( N_SUM_c_1032_p N_noxref_9_c_2503_n ) capacitor c=0.0673924f \
 //x=10.37 //y=5.555 //x2=9.93 //y2=5.555
cc_1008 ( N_SUM_c_1026_p N_noxref_9_M20_noxref_d ) capacitor c=0.00704645f \
 //x=10.885 //y=5.385 //x2=10.665 //y2=5.2
cc_1009 ( N_SUM_c_1032_p N_noxref_9_M20_noxref_d ) capacitor c=0.0472015f \
 //x=10.37 //y=5.555 //x2=10.665 //y2=5.2
cc_1010 ( N_SUM_c_983_n N_noxref_10_c_2580_n ) capacitor c=0.00314935f \
 //x=14.095 //y=5.385 //x2=14.02 //y2=7.085
cc_1011 ( N_SUM_c_1002_n N_noxref_10_c_2580_n ) capacitor c=0.00482905f \
 //x=13.7 //y=5.385 //x2=14.02 //y2=7.085
cc_1012 ( N_SUM_c_1011_n N_noxref_10_c_2580_n ) capacitor c=0.00407104f \
 //x=13.7 //y=5.555 //x2=14.02 //y2=7.085
cc_1013 ( N_SUM_c_1026_p N_noxref_10_c_2590_n ) capacitor c=0.00476373f \
 //x=10.885 //y=5.385 //x2=12.38 //y2=5.385
cc_1014 ( N_SUM_c_1001_n N_noxref_10_c_2590_n ) capacitor c=0.00509041f \
 //x=10.37 //y=5.385 //x2=12.38 //y2=5.385
cc_1015 ( N_SUM_c_1002_n N_noxref_10_c_2590_n ) capacitor c=6.06937e-19 \
 //x=13.7 //y=5.385 //x2=12.38 //y2=5.385
cc_1016 ( N_SUM_c_1002_n N_noxref_10_c_2582_n ) capacitor c=0.0501053f \
 //x=13.7 //y=5.385 //x2=13.26 //y2=5.385
cc_1017 ( N_SUM_c_1011_n N_noxref_10_c_2582_n ) capacitor c=0.0026584f \
 //x=13.7 //y=5.555 //x2=13.26 //y2=5.385
cc_1018 ( N_SUM_c_983_n N_noxref_10_c_2584_n ) capacitor c=0.00500806f \
 //x=14.095 //y=5.385 //x2=14.14 //y2=6.915
cc_1019 ( N_SUM_c_1002_n N_noxref_10_c_2585_n ) capacitor c=0.00266093f \
 //x=13.7 //y=5.385 //x2=13.26 //y2=5.555
cc_1020 ( N_SUM_c_1011_n N_noxref_10_c_2585_n ) capacitor c=0.0674619f \
 //x=13.7 //y=5.555 //x2=13.26 //y2=5.555
cc_1021 ( SUM N_noxref_10_M24_noxref_d ) capacitor c=0.0012136f //x=14.18 \
 //y=3.88 //x2=13.995 //y2=5.2
cc_1022 ( N_SUM_c_983_n N_noxref_10_M24_noxref_d ) capacitor c=0.00776833f \
 //x=14.095 //y=5.385 //x2=13.995 //y2=5.2
cc_1023 ( N_SUM_c_1011_n N_noxref_10_M24_noxref_d ) capacitor c=0.0473277f \
 //x=13.7 //y=5.555 //x2=13.995 //y2=5.2
cc_1024 ( N_SUM_c_963_n N_GND_c_2703_n ) capacitor c=0.0136681f //x=10.41 \
 //y=1.305 //x2=9.44 //y2=1.025
cc_1025 ( N_SUM_M5_noxref_d N_GND_c_2703_n ) capacitor c=5.48773e-19 //x=10.22 \
 //y=1.09 //x2=9.44 //y2=1.025
cc_1026 ( N_SUM_c_963_n N_GND_c_2805_n ) capacitor c=0.0092877f //x=10.41 \
 //y=1.305 //x2=12.685 //y2=0.175
cc_1027 ( N_SUM_c_967_n N_GND_c_2805_n ) capacitor c=0.00838435f //x=10.885 \
 //y=1.835 //x2=12.685 //y2=0.175
cc_1028 ( N_SUM_c_969_n N_GND_c_2805_n ) capacitor c=0.00102334f //x=10.97 \
 //y=4.055 //x2=12.685 //y2=0.175
cc_1029 ( N_SUM_M5_noxref_d N_GND_c_2805_n ) capacitor c=2.98166e-19 //x=10.22 \
 //y=1.09 //x2=12.685 //y2=0.175
cc_1030 ( N_SUM_c_963_n N_GND_c_2777_n ) capacitor c=0.00519351f //x=10.41 \
 //y=1.305 //x2=12.77 //y2=1.025
cc_1031 ( N_SUM_c_970_n N_GND_c_2777_n ) capacitor c=0.0136059f //x=13.74 \
 //y=1.3 //x2=12.77 //y2=1.025
cc_1032 ( N_SUM_M7_noxref_d N_GND_c_2777_n ) capacitor c=5.45329e-19 //x=13.55 \
 //y=1.09 //x2=12.77 //y2=1.025
cc_1033 ( N_SUM_c_970_n N_GND_c_2778_n ) capacitor c=0.00910268f //x=13.74 \
 //y=1.3 //x2=16.4 //y2=0.18
cc_1034 ( N_SUM_c_986_n N_GND_c_2778_n ) capacitor c=0.00654915f //x=14.095 \
 //y=1.835 //x2=16.4 //y2=0.18
cc_1035 ( N_SUM_M7_noxref_d N_GND_c_2778_n ) capacitor c=2.98166e-19 //x=13.55 \
 //y=1.09 //x2=16.4 //y2=0.18
cc_1036 ( N_SUM_c_967_n N_GND_c_2735_n ) capacitor c=0.001371f //x=10.885 \
 //y=1.835 //x2=11.42 //y2=0.175
cc_1037 ( N_SUM_c_986_n N_GND_c_2816_n ) capacitor c=7.81285e-19 //x=14.095 \
 //y=1.835 //x2=14.75 //y2=0.175
cc_1038 ( SUM N_GND_c_2741_n ) capacitor c=8.64413e-19 //x=10.97 //y=2.4 \
 //x2=8.26 //y2=0.175
cc_1039 ( SUM N_GND_c_2789_n ) capacitor c=9.20071e-19 //x=14.18 //y=2.4 \
 //x2=11.59 //y2=0.175
cc_1040 ( N_SUM_c_965_n N_GND_c_2789_n ) capacitor c=0.00289817f //x=10.41 \
 //y=1.75 //x2=11.59 //y2=0.175
cc_1041 ( N_SUM_c_967_n N_GND_c_2789_n ) capacitor c=0.032706f //x=10.885 \
 //y=1.835 //x2=11.59 //y2=0.175
cc_1042 ( N_SUM_c_978_n N_GND_c_2791_n ) capacitor c=0.00262965f //x=13.74 \
 //y=1.75 //x2=14.92 //y2=0.175
cc_1043 ( N_SUM_c_986_n N_GND_c_2791_n ) capacitor c=0.0237295f //x=14.095 \
 //y=1.835 //x2=14.92 //y2=0.175
cc_1044 ( N_SUM_c_963_n N_GND_c_2687_n ) capacitor c=2.8441e-19 //x=10.41 \
 //y=1.305 //x2=16.51 //y2=0.175
cc_1045 ( N_SUM_c_970_n N_GND_c_2687_n ) capacitor c=2.8441e-19 //x=13.74 \
 //y=1.3 //x2=16.51 //y2=0.175
cc_1046 ( N_SUM_c_963_n N_GND_M4_noxref_d ) capacitor c=5.45409e-19 //x=10.41 \
 //y=1.305 //x2=9.25 //y2=1.05
cc_1047 ( N_SUM_c_970_n N_GND_M6_noxref_d ) capacitor c=5.45329e-19 //x=13.74 \
 //y=1.3 //x2=12.58 //y2=1.05
cc_1048 ( N_SUM_c_968_n N_noxref_13_c_3088_n ) capacitor c=0.00898362f \
 //x=10.495 //y=1.835 //x2=9.925 //y2=1.68
cc_1049 ( N_SUM_c_963_n N_noxref_13_c_3095_n ) capacitor c=0.00352617f \
 //x=10.41 //y=1.305 //x2=10.81 //y2=0.715
cc_1050 ( N_SUM_c_967_n N_noxref_13_c_3095_n ) capacitor c=0.00362992f \
 //x=10.885 //y=1.835 //x2=10.81 //y2=0.715
cc_1051 ( N_SUM_M5_noxref_d N_noxref_13_c_3095_n ) capacitor c=0.00910163f \
 //x=10.22 //y=1.09 //x2=10.81 //y2=0.715
cc_1052 ( SUM N_noxref_13_M4_noxref_s ) capacitor c=4.48997e-19 //x=11.02 \
 //y=3.88 //x2=8.82 //y2=0.55
cc_1053 ( N_SUM_c_963_n N_noxref_13_M4_noxref_s ) capacitor c=0.00888619f \
 //x=10.41 //y=1.305 //x2=8.82 //y2=0.55
cc_1054 ( N_SUM_c_965_n N_noxref_13_M4_noxref_s ) capacitor c=0.0161119f \
 //x=10.41 //y=1.75 //x2=8.82 //y2=0.55
cc_1055 ( N_SUM_c_967_n N_noxref_13_M4_noxref_s ) capacitor c=0.00879038f \
 //x=10.885 //y=1.835 //x2=8.82 //y2=0.55
cc_1056 ( N_SUM_M5_noxref_d N_noxref_13_M4_noxref_s ) capacitor c=0.0275562f \
 //x=10.22 //y=1.09 //x2=8.82 //y2=0.55
cc_1057 ( N_SUM_c_992_n N_noxref_14_c_3148_n ) capacitor c=0.00902033f \
 //x=13.825 //y=1.835 //x2=13.255 //y2=1.68
cc_1058 ( N_SUM_c_970_n N_noxref_14_c_3150_n ) capacitor c=0.00340242f \
 //x=13.74 //y=1.3 //x2=14.14 //y2=0.715
cc_1059 ( N_SUM_c_986_n N_noxref_14_c_3150_n ) capacitor c=0.00367965f \
 //x=14.095 //y=1.835 //x2=14.14 //y2=0.715
cc_1060 ( N_SUM_M7_noxref_d N_noxref_14_c_3150_n ) capacitor c=0.00910163f \
 //x=13.55 //y=1.09 //x2=14.14 //y2=0.715
cc_1061 ( SUM N_noxref_14_M6_noxref_s ) capacitor c=8.43954e-19 //x=14.18 \
 //y=3.88 //x2=12.15 //y2=0.55
cc_1062 ( N_SUM_c_970_n N_noxref_14_M6_noxref_s ) capacitor c=0.00845391f \
 //x=13.74 //y=1.3 //x2=12.15 //y2=0.55
cc_1063 ( N_SUM_c_978_n N_noxref_14_M6_noxref_s ) capacitor c=0.0157899f \
 //x=13.74 //y=1.75 //x2=12.15 //y2=0.55
cc_1064 ( N_SUM_c_986_n N_noxref_14_M6_noxref_s ) capacitor c=0.00674704f \
 //x=14.095 //y=1.835 //x2=12.15 //y2=0.55
cc_1065 ( N_SUM_c_997_n N_noxref_14_M6_noxref_s ) capacitor c=3.19116e-19 \
 //x=14.18 //y=4.055 //x2=12.15 //y2=0.55
cc_1066 ( N_SUM_M7_noxref_d N_noxref_14_M6_noxref_s ) capacitor c=0.0275615f \
 //x=13.55 //y=1.09 //x2=12.15 //y2=0.55
cc_1067 ( N_noxref_5_c_1264_n B ) capacitor c=0.0242837f //x=15.66 //y=3.335 \
 //x2=16.4 //y2=2.77
cc_1068 ( N_noxref_5_c_1264_n B ) capacitor c=0.00161653f //x=15.66 //y=3.335 \
 //x2=16.4 //y2=3.51
cc_1069 ( N_noxref_5_c_1302_n B ) capacitor c=0.0164061f //x=15.66 //y=3.655 \
 //x2=16.4 //y2=3.51
cc_1070 ( N_noxref_5_c_1266_n B ) capacitor c=0.0211948f //x=15.66 //y=4.135 \
 //x2=16.4 //y2=3.51
cc_1071 ( N_noxref_5_c_1308_n B ) capacitor c=0.0143392f //x=15.66 //y=4.43 \
 //x2=16.4 //y2=3.51
cc_1072 ( N_noxref_5_c_1267_n B ) capacitor c=0.0105049f //x=15.66 //y=5.055 \
 //x2=16.4 //y2=3.51
cc_1073 ( N_noxref_5_c_1318_n B ) capacitor c=0.00549287f //x=15.66 //y=3.51 \
 //x2=16.4 //y2=3.51
cc_1074 ( N_noxref_5_c_1319_n B ) capacitor c=0.00478955f //x=15.66 //y=4.25 \
 //x2=16.4 //y2=3.51
cc_1075 ( N_noxref_5_c_1325_n B ) capacitor c=0.00688969f //x=15.665 //y=4.27 \
 //x2=16.4 //y2=3.51
cc_1076 ( N_noxref_5_c_1333_n B ) capacitor c=0.00722096f //x=15.695 //y=3.495 \
 //x2=16.4 //y2=3.51
cc_1077 ( N_noxref_5_c_1291_n B ) capacitor c=0.0485556f //x=10.48 //y=4.575 \
 //x2=10.11 //y2=3.88
cc_1078 ( N_noxref_5_c_1240_n B ) capacitor c=0.00998553f //x=10.48 //y=4.765 \
 //x2=10.11 //y2=3.88
cc_1079 ( N_noxref_5_c_1244_n B ) capacitor c=0.00297752f //x=10.525 //y=4.415 \
 //x2=10.11 //y2=3.88
cc_1080 ( N_noxref_5_c_1322_n B ) capacitor c=0.00296826f //x=10.525 //y=4.28 \
 //x2=10.11 //y2=3.88
cc_1081 ( N_noxref_5_c_1252_n B ) capacitor c=0.0091055f //x=10.48 //y=4.88 \
 //x2=10.11 //y2=3.88
cc_1082 ( N_noxref_5_c_1291_n B ) capacitor c=0.0132081f //x=10.48 //y=4.575 \
 //x2=10.48 //y2=3.14
cc_1083 ( N_noxref_5_c_1244_n B ) capacitor c=0.0075172f //x=10.525 //y=4.415 \
 //x2=10.48 //y2=3.14
cc_1084 ( N_noxref_5_c_1268_n B ) capacitor c=0.00927997f //x=12.7 //y=3.51 \
 //x2=12.7 //y2=4.62
cc_1085 ( N_noxref_5_c_1271_n B ) capacitor c=0.00931051f //x=15.505 //y=4.27 \
 //x2=12.7 //y2=4.62
cc_1086 ( N_noxref_5_c_1264_n B ) capacitor c=6.78671e-19 //x=15.66 //y=3.335 \
 //x2=16.4 //y2=3.14
cc_1087 ( N_noxref_5_c_1259_n N_B_c_1628_n ) capacitor c=0.00171814f //x=12.7 \
 //y=3.385 //x2=10.48 //y2=2.995
cc_1088 ( N_noxref_5_c_1264_n N_B_c_1822_n ) capacitor c=0.0175711f //x=15.66 \
 //y=3.335 //x2=16.4 //y2=3.3
cc_1089 ( N_noxref_5_c_1267_n N_B_c_1823_n ) capacitor c=0.0140261f //x=15.66 \
 //y=5.055 //x2=16.4 //y2=4.88
cc_1090 ( N_noxref_5_c_1264_n N_B_c_1824_n ) capacitor c=0.0181783f //x=15.66 \
 //y=3.335 //x2=16.4 //y2=2.265
cc_1091 ( N_noxref_5_c_1291_n N_B_c_1650_n ) capacitor c=0.00691309f //x=10.48 \
 //y=4.575 //x2=10.11 //y2=4.96
cc_1092 ( N_noxref_5_c_1240_n N_B_c_1650_n ) capacitor c=0.017438f //x=10.48 \
 //y=4.765 //x2=10.11 //y2=4.96
cc_1093 ( N_noxref_5_c_1322_n N_B_c_1650_n ) capacitor c=0.0431446f //x=10.525 \
 //y=4.28 //x2=10.11 //y2=4.96
cc_1094 ( N_noxref_5_c_1291_n N_B_c_1755_n ) capacitor c=0.00188821f //x=10.48 \
 //y=4.575 //x2=12.54 //y2=5.045
cc_1095 ( N_noxref_5_c_1240_n N_B_c_1755_n ) capacitor c=0.0130257f //x=10.48 \
 //y=4.765 //x2=12.54 //y2=5.045
cc_1096 ( N_noxref_5_c_1322_n N_B_c_1755_n ) capacitor c=0.0191019f //x=10.525 \
 //y=4.28 //x2=12.54 //y2=5.045
cc_1097 ( N_noxref_5_c_1271_n N_B_c_1755_n ) capacitor c=0.0737905f //x=15.505 \
 //y=4.27 //x2=12.54 //y2=5.045
cc_1098 ( N_noxref_5_c_1291_n N_B_c_1717_n ) capacitor c=8.94562e-19 //x=10.48 \
 //y=4.575 //x2=15.31 //y2=3.14
cc_1099 ( N_noxref_5_c_1259_n N_B_c_1717_n ) capacitor c=0.0236671f //x=12.7 \
 //y=3.385 //x2=15.31 //y2=3.14
cc_1100 ( N_noxref_5_c_1264_n N_B_c_1717_n ) capacitor c=9.10138e-19 //x=15.66 \
 //y=3.335 //x2=15.31 //y2=3.14
cc_1101 ( N_noxref_5_c_1302_n N_B_c_1717_n ) capacitor c=0.00252824f //x=15.66 \
 //y=3.655 //x2=15.31 //y2=3.14
cc_1102 ( N_noxref_5_c_1268_n N_B_c_1717_n ) capacitor c=0.00324894f //x=12.7 \
 //y=3.51 //x2=15.31 //y2=3.14
cc_1103 ( N_noxref_5_c_1322_n N_B_c_1717_n ) capacitor c=0.0176563f //x=10.525 \
 //y=4.28 //x2=15.31 //y2=3.14
cc_1104 ( N_noxref_5_c_1269_n N_B_c_1717_n ) capacitor c=0.0368037f //x=12.86 \
 //y=3.525 //x2=15.31 //y2=3.14
cc_1105 ( N_noxref_5_c_1273_n N_B_c_1717_n ) capacitor c=0.234687f //x=15.535 \
 //y=3.495 //x2=15.31 //y2=3.14
cc_1106 ( N_noxref_5_c_1264_n N_B_c_1840_n ) capacitor c=0.0299619f //x=15.66 \
 //y=3.335 //x2=15.91 //y2=3.11
cc_1107 ( N_noxref_5_c_1302_n N_B_c_1840_n ) capacitor c=0.00405043f //x=15.66 \
 //y=3.655 //x2=15.91 //y2=3.11
cc_1108 ( N_noxref_5_c_1391_p N_B_c_1840_n ) capacitor c=0.00929464f \
 //x=15.945 //y=2.02 //x2=15.91 //y2=3.11
cc_1109 ( N_noxref_5_c_1320_n N_B_c_1840_n ) capacitor c=4.71823e-19 //x=16.03 \
 //y=1.185 //x2=15.91 //y2=3.11
cc_1110 ( N_noxref_5_c_1325_n N_B_c_1840_n ) capacitor c=9.16478e-19 \
 //x=15.665 //y=4.27 //x2=15.91 //y2=3.11
cc_1111 ( N_noxref_5_c_1333_n N_B_c_1840_n ) capacitor c=0.0365231f //x=15.695 \
 //y=3.495 //x2=15.91 //y2=3.11
cc_1112 ( N_noxref_5_c_1302_n N_B_c_1846_n ) capacitor c=2.76741e-19 //x=15.66 \
 //y=3.655 //x2=15.88 //y2=4.655
cc_1113 ( N_noxref_5_c_1308_n N_B_c_1846_n ) capacitor c=0.00242768f //x=15.66 \
 //y=4.43 //x2=15.88 //y2=4.655
cc_1114 ( N_noxref_5_c_1267_n N_B_c_1846_n ) capacitor c=0.0330232f //x=15.66 \
 //y=5.055 //x2=15.88 //y2=4.655
cc_1115 ( N_noxref_5_c_1398_p N_B_c_1846_n ) capacitor c=0.0170287f //x=15.94 \
 //y=5.14 //x2=15.88 //y2=4.655
cc_1116 ( N_noxref_5_c_1311_n N_B_c_1846_n ) capacitor c=0.00103017f \
 //x=16.025 //y=5.42 //x2=15.88 //y2=4.655
cc_1117 ( N_noxref_5_c_1333_n N_B_c_1846_n ) capacitor c=0.00164053f \
 //x=15.695 //y=3.495 //x2=15.88 //y2=4.655
cc_1118 ( N_noxref_5_c_1308_n N_B_c_1721_n ) capacitor c=0.00285949f //x=15.66 \
 //y=4.43 //x2=15.535 //y2=4.655
cc_1119 ( N_noxref_5_c_1267_n N_B_c_1721_n ) capacitor c=0.00100708f //x=15.66 \
 //y=5.055 //x2=15.535 //y2=4.655
cc_1120 ( N_noxref_5_c_1325_n N_B_c_1721_n ) capacitor c=0.0364799f //x=15.665 \
 //y=4.27 //x2=15.535 //y2=4.655
cc_1121 ( N_noxref_5_c_1271_n N_B_c_1721_n ) capacitor c=0.285916f //x=15.505 \
 //y=4.27 //x2=15.535 //y2=4.655
cc_1122 ( N_noxref_5_c_1273_n N_B_c_1721_n ) capacitor c=0.00392621f \
 //x=15.535 //y=3.495 //x2=15.535 //y2=4.655
cc_1123 ( N_noxref_5_c_1291_n N_B_c_1659_n ) capacitor c=0.00406614f //x=10.48 \
 //y=4.575 //x2=10.64 //y2=3.155
cc_1124 ( N_noxref_5_c_1322_n N_B_c_1659_n ) capacitor c=0.00735888f \
 //x=10.525 //y=4.28 //x2=10.64 //y2=3.155
cc_1125 ( N_noxref_5_c_1268_n N_B_c_1725_n ) capacitor c=0.00778656f //x=12.7 \
 //y=3.51 //x2=12.7 //y2=4.62
cc_1126 ( N_noxref_5_c_1271_n N_B_c_1725_n ) capacitor c=0.00158244f \
 //x=15.505 //y=4.27 //x2=12.7 //y2=4.62
cc_1127 ( N_noxref_5_c_1264_n N_B_c_1861_n ) capacitor c=4.71798e-19 //x=15.66 \
 //y=3.335 //x2=16.4 //y2=2.265
cc_1128 ( N_noxref_5_c_1267_n N_B_c_1862_n ) capacitor c=5.88334e-19 //x=15.66 \
 //y=5.055 //x2=16.4 //y2=4.88
cc_1129 ( N_noxref_5_c_1398_p N_B_M25_noxref_g ) capacitor c=0.00681176f \
 //x=15.94 //y=5.14 //x2=15.805 //y2=6.2
cc_1130 ( N_noxref_5_c_1413_p N_B_M25_noxref_g ) capacitor c=0.00222545f \
 //x=15.745 //y=5.14 //x2=15.805 //y2=6.2
cc_1131 ( N_noxref_5_c_1311_n N_B_M25_noxref_g ) capacitor c=0.00332234f \
 //x=16.025 //y=5.42 //x2=15.805 //y2=6.2
cc_1132 ( N_noxref_5_c_1415_p N_B_M25_noxref_g ) capacitor c=0.0162066f \
 //x=16.025 //y=5.56 //x2=15.805 //y2=6.2
cc_1133 ( N_noxref_5_c_1398_p N_B_M26_noxref_g ) capacitor c=0.00534267f \
 //x=15.94 //y=5.14 //x2=16.245 //y2=6.2
cc_1134 ( N_noxref_5_c_1311_n N_B_M26_noxref_g ) capacitor c=0.00141266f \
 //x=16.025 //y=5.42 //x2=16.245 //y2=6.2
cc_1135 ( N_noxref_5_c_1415_p N_B_M26_noxref_g ) capacitor c=0.0162066f \
 //x=16.025 //y=5.56 //x2=16.245 //y2=6.2
cc_1136 ( N_noxref_5_c_1320_n N_B_c_1870_n ) capacitor c=0.00147264f //x=16.03 \
 //y=1.185 //x2=15.76 //y2=1.09
cc_1137 ( N_noxref_5_M8_noxref_d N_B_c_1870_n ) capacitor c=0.00136418f \
 //x=15.835 //y=1.09 //x2=15.76 //y2=1.09
cc_1138 ( N_noxref_5_c_1391_p N_B_c_1872_n ) capacitor c=0.00180253f \
 //x=15.945 //y=2.02 //x2=15.76 //y2=1.435
cc_1139 ( N_noxref_5_c_1313_n N_B_c_1872_n ) capacitor c=0.00322824f //x=16.03 \
 //y=1.935 //x2=15.76 //y2=1.435
cc_1140 ( N_noxref_5_c_1320_n N_B_c_1872_n ) capacitor c=0.00350441f //x=16.03 \
 //y=1.185 //x2=15.76 //y2=1.435
cc_1141 ( N_noxref_5_M8_noxref_d N_B_c_1872_n ) capacitor c=0.00235934f \
 //x=15.835 //y=1.09 //x2=15.76 //y2=1.435
cc_1142 ( N_noxref_5_c_1398_p N_B_c_1876_n ) capacitor c=0.00262283f //x=15.94 \
 //y=5.14 //x2=16.17 //y2=4.97
cc_1143 ( N_noxref_5_c_1415_p N_B_c_1876_n ) capacitor c=0.00290963f \
 //x=16.025 //y=5.56 //x2=16.17 //y2=4.97
cc_1144 ( N_noxref_5_c_1308_n N_B_c_1878_n ) capacitor c=0.00105397f //x=15.66 \
 //y=4.43 //x2=15.88 //y2=4.97
cc_1145 ( N_noxref_5_c_1267_n N_B_c_1878_n ) capacitor c=0.00203237f //x=15.66 \
 //y=5.055 //x2=15.88 //y2=4.97
cc_1146 ( N_noxref_5_c_1319_n N_B_c_1878_n ) capacitor c=2.84121e-19 //x=15.66 \
 //y=4.25 //x2=15.88 //y2=4.97
cc_1147 ( N_noxref_5_c_1320_n N_B_c_1881_n ) capacitor c=5.57924e-19 //x=16.03 \
 //y=1.185 //x2=16.135 //y2=0.935
cc_1148 ( N_noxref_5_M8_noxref_d N_B_c_1881_n ) capacitor c=0.0020782f \
 //x=15.835 //y=1.09 //x2=16.135 //y2=0.935
cc_1149 ( N_noxref_5_c_1313_n N_B_c_1883_n ) capacitor c=0.00935661f //x=16.03 \
 //y=1.935 //x2=16.135 //y2=1.59
cc_1150 ( N_noxref_5_c_1320_n N_B_c_1883_n ) capacitor c=5.75878e-19 //x=16.03 \
 //y=1.185 //x2=16.135 //y2=1.59
cc_1151 ( N_noxref_5_M8_noxref_d N_B_c_1883_n ) capacitor c=0.00356097f \
 //x=15.835 //y=1.09 //x2=16.135 //y2=1.59
cc_1152 ( N_noxref_5_c_1320_n N_B_c_1886_n ) capacitor c=0.0018901f //x=16.03 \
 //y=1.185 //x2=16.29 //y2=1.09
cc_1153 ( N_noxref_5_M8_noxref_d N_B_c_1886_n ) capacitor c=0.00139961f \
 //x=15.835 //y=1.09 //x2=16.29 //y2=1.09
cc_1154 ( N_noxref_5_c_1313_n N_B_c_1888_n ) capacitor c=0.0012792f //x=16.03 \
 //y=1.935 //x2=16.29 //y2=1.435
cc_1155 ( N_noxref_5_c_1320_n N_B_c_1888_n ) capacitor c=0.00414335f //x=16.03 \
 //y=1.185 //x2=16.29 //y2=1.435
cc_1156 ( N_noxref_5_M8_noxref_d N_B_c_1888_n ) capacitor c=0.0023891f \
 //x=15.835 //y=1.09 //x2=16.29 //y2=1.435
cc_1157 ( N_noxref_5_c_1313_n N_B_c_1891_n ) capacitor c=0.0056351f //x=16.03 \
 //y=1.935 //x2=16.29 //y2=1.745
cc_1158 ( N_noxref_5_c_1313_n N_B_c_1892_n ) capacitor c=0.00440271f //x=16.03 \
 //y=1.935 //x2=16.29 //y2=2.1
cc_1159 ( N_noxref_5_c_1264_n N_B_c_1893_n ) capacitor c=0.00275704f //x=15.66 \
 //y=3.335 //x2=16.29 //y2=2.265
cc_1160 ( N_noxref_5_c_1391_p N_B_c_1893_n ) capacitor c=0.00440271f \
 //x=15.945 //y=2.02 //x2=16.29 //y2=2.265
cc_1161 ( N_noxref_5_c_1413_p N_VDD_c_2181_n ) capacitor c=0.00200156f \
 //x=15.745 //y=5.14 //x2=16.4 //y2=7.58
cc_1162 ( N_noxref_5_c_1311_n N_VDD_c_2181_n ) capacitor c=0.00259718f \
 //x=16.025 //y=5.42 //x2=16.4 //y2=7.58
cc_1163 ( N_noxref_5_c_1415_p N_VDD_c_2181_n ) capacitor c=0.00241566f \
 //x=16.025 //y=5.56 //x2=16.4 //y2=7.58
cc_1164 ( N_noxref_5_M19_noxref_g N_VDD_c_2109_n ) capacitor c=0.00777954f \
 //x=10.15 //y=6.2 //x2=11.42 //y2=7.585
cc_1165 ( N_noxref_5_M20_noxref_g N_VDD_c_2109_n ) capacitor c=0.00758899f \
 //x=10.59 //y=6.2 //x2=11.42 //y2=7.585
cc_1166 ( N_noxref_5_c_1413_p N_VDD_c_2206_n ) capacitor c=0.0019409f \
 //x=15.745 //y=5.14 //x2=16.38 //y2=7.585
cc_1167 ( N_noxref_5_c_1311_n N_VDD_c_2206_n ) capacitor c=8.96756e-19 \
 //x=16.025 //y=5.42 //x2=16.38 //y2=7.585
cc_1168 ( N_noxref_5_c_1415_p N_VDD_c_2206_n ) capacitor c=0.0138017f \
 //x=16.025 //y=5.56 //x2=16.38 //y2=7.585
cc_1169 ( N_noxref_5_c_1244_n N_VDD_c_2168_n ) capacitor c=0.00225757f \
 //x=10.525 //y=4.415 //x2=11.59 //y2=7.585
cc_1170 ( N_noxref_5_c_1271_n N_VDD_c_2168_n ) capacitor c=0.0117894f \
 //x=15.505 //y=4.27 //x2=11.59 //y2=7.585
cc_1171 ( N_noxref_5_c_1245_n N_VDD_c_2168_n ) capacitor c=0.00343782f \
 //x=10.48 //y=4.88 //x2=11.59 //y2=7.585
cc_1172 ( N_noxref_5_c_1252_n N_VDD_c_2168_n ) capacitor c=0.0196358f \
 //x=10.48 //y=4.88 //x2=11.59 //y2=7.585
cc_1173 ( N_noxref_5_c_1308_n N_VDD_c_2169_n ) capacitor c=0.00193791f \
 //x=15.66 //y=4.43 //x2=14.92 //y2=7.585
cc_1174 ( N_noxref_5_c_1267_n N_VDD_c_2169_n ) capacitor c=0.0160087f \
 //x=15.66 //y=5.055 //x2=14.92 //y2=7.585
cc_1175 ( N_noxref_5_c_1311_n N_VDD_c_2169_n ) capacitor c=0.00203464f \
 //x=16.025 //y=5.42 //x2=14.92 //y2=7.585
cc_1176 ( N_noxref_5_c_1319_n N_VDD_c_2169_n ) capacitor c=0.00491566f \
 //x=15.66 //y=4.25 //x2=14.92 //y2=7.585
cc_1177 ( N_noxref_5_c_1271_n N_VDD_c_2169_n ) capacitor c=0.00929033f \
 //x=15.505 //y=4.27 //x2=14.92 //y2=7.585
cc_1178 ( N_noxref_5_c_1415_p N_VDD_c_2169_n ) capacitor c=0.00821754f \
 //x=16.025 //y=5.56 //x2=14.92 //y2=7.585
cc_1179 ( N_noxref_5_c_1267_n N_VDD_c_2070_n ) capacitor c=2.43252e-19 \
 //x=15.66 //y=5.055 //x2=16.4 //y2=7.58
cc_1180 ( N_noxref_5_c_1398_p N_VDD_c_2070_n ) capacitor c=0.00685597f \
 //x=15.94 //y=5.14 //x2=16.4 //y2=7.58
cc_1181 ( N_noxref_5_c_1319_n N_VDD_c_2070_n ) capacitor c=0.00143727f \
 //x=15.66 //y=4.25 //x2=16.4 //y2=7.58
cc_1182 ( N_noxref_5_c_1415_p N_VDD_c_2070_n ) capacitor c=0.00958323f \
 //x=16.025 //y=5.56 //x2=16.4 //y2=7.58
cc_1183 ( N_noxref_5_c_1308_n N_VDD_M25_noxref_s ) capacitor c=0.00402344f \
 //x=15.66 //y=4.43 //x2=15.46 //y2=5.2
cc_1184 ( N_noxref_5_c_1413_p N_VDD_M25_noxref_s ) capacitor c=0.0201085f \
 //x=15.745 //y=5.14 //x2=15.46 //y2=5.2
cc_1185 ( N_noxref_5_c_1311_n N_VDD_M25_noxref_s ) capacitor c=0.0474638f \
 //x=16.025 //y=5.42 //x2=15.46 //y2=5.2
cc_1186 ( N_noxref_5_c_1319_n N_VDD_M25_noxref_s ) capacitor c=0.00133028f \
 //x=15.66 //y=4.25 //x2=15.46 //y2=5.2
cc_1187 ( N_noxref_5_c_1415_p N_VDD_M25_noxref_s ) capacitor c=0.0909229f \
 //x=16.025 //y=5.56 //x2=15.46 //y2=5.2
cc_1188 ( N_noxref_5_c_1311_n N_VDD_M26_noxref_d ) capacitor c=0.0480012f \
 //x=16.025 //y=5.42 //x2=16.32 //y2=5.2
cc_1189 ( N_noxref_5_c_1415_p N_VDD_M26_noxref_d ) capacitor c=0.09216f \
 //x=16.025 //y=5.56 //x2=16.32 //y2=5.2
cc_1190 ( N_noxref_5_M19_noxref_g N_noxref_9_c_2506_n ) capacitor \
 c=0.00773812f //x=10.15 //y=6.2 //x2=10.695 //y2=7.085
cc_1191 ( N_noxref_5_M20_noxref_g N_noxref_9_c_2506_n ) capacitor \
 c=0.00931391f //x=10.59 //y=6.2 //x2=10.695 //y2=7.085
cc_1192 ( N_noxref_5_M19_noxref_g N_noxref_9_c_2499_n ) capacitor \
 c=0.00179653f //x=10.15 //y=6.2 //x2=9.93 //y2=5.385
cc_1193 ( N_noxref_5_M19_noxref_g N_noxref_9_c_2500_n ) capacitor \
 c=0.00179267f //x=10.15 //y=6.2 //x2=9.93 //y2=6.915
cc_1194 ( N_noxref_5_M20_noxref_g N_noxref_9_c_2512_n ) capacitor \
 c=0.00394587f //x=10.59 //y=6.2 //x2=10.81 //y2=6.915
cc_1195 ( N_noxref_5_M19_noxref_g N_noxref_9_c_2503_n ) capacitor c=0.0170175f \
 //x=10.15 //y=6.2 //x2=9.93 //y2=5.555
cc_1196 ( N_noxref_5_M20_noxref_g N_noxref_9_M20_noxref_d ) capacitor \
 c=0.0365939f //x=10.59 //y=6.2 //x2=10.665 //y2=5.2
cc_1197 ( N_noxref_5_c_1311_n N_noxref_10_c_2582_n ) capacitor c=4.00761e-19 \
 //x=16.025 //y=5.42 //x2=13.26 //y2=5.385
cc_1198 ( N_noxref_5_c_1255_n N_GND_c_2777_n ) capacitor c=0.00559046f \
 //x=12.7 //y=2.385 //x2=12.77 //y2=1.025
cc_1199 ( N_noxref_5_c_1268_n N_GND_c_2777_n ) capacitor c=3.43549e-19 \
 //x=12.7 //y=3.51 //x2=12.77 //y2=1.025
cc_1200 ( N_noxref_5_c_1275_n N_GND_c_2777_n ) capacitor c=4.17987e-19 \
 //x=12.7 //y=2.265 //x2=12.77 //y2=1.025
cc_1201 ( N_noxref_5_c_1278_n N_GND_c_2777_n ) capacitor c=0.00144305f \
 //x=12.505 //y=1.05 //x2=12.77 //y2=1.025
cc_1202 ( N_noxref_5_c_1279_n N_GND_c_2777_n ) capacitor c=0.00300481f \
 //x=12.505 //y=1.395 //x2=12.77 //y2=1.025
cc_1203 ( N_noxref_5_c_1486_p N_GND_c_2777_n ) capacitor c=0.00923477f \
 //x=12.88 //y=0.895 //x2=12.77 //y2=1.025
cc_1204 ( N_noxref_5_c_1487_p N_GND_c_2777_n ) capacitor c=5.58852e-19 \
 //x=12.88 //y=1.55 //x2=12.77 //y2=1.025
cc_1205 ( N_noxref_5_c_1286_n N_GND_c_2777_n ) capacitor c=0.00167052f \
 //x=13.035 //y=1.05 //x2=12.77 //y2=1.025
cc_1206 ( N_noxref_5_c_1288_n N_GND_c_2777_n ) capacitor c=0.00212338f \
 //x=13.035 //y=1.395 //x2=12.77 //y2=1.025
cc_1207 ( N_noxref_5_c_1302_n N_GND_c_2778_n ) capacitor c=5.17261e-19 \
 //x=15.66 //y=3.655 //x2=16.4 //y2=0.18
cc_1208 ( N_noxref_5_c_1310_n N_GND_c_2778_n ) capacitor c=0.00499608f \
 //x=15.745 //y=2.02 //x2=16.4 //y2=0.18
cc_1209 ( N_noxref_5_c_1320_n N_GND_c_2778_n ) capacitor c=0.00982892f \
 //x=16.03 //y=1.185 //x2=16.4 //y2=0.18
cc_1210 ( N_noxref_5_M8_noxref_d N_GND_c_2778_n ) capacitor c=0.00119455f \
 //x=15.835 //y=1.09 //x2=16.4 //y2=0.18
cc_1211 ( N_noxref_5_c_1278_n N_GND_c_2816_n ) capacitor c=0.00687977f \
 //x=12.505 //y=1.05 //x2=14.75 //y2=0.175
cc_1212 ( N_noxref_5_c_1310_n N_GND_c_2841_n ) capacitor c=0.00321244f \
 //x=15.745 //y=2.02 //x2=15.945 //y2=0.715
cc_1213 ( N_noxref_5_c_1318_n N_GND_c_2841_n ) capacitor c=2.56765e-19 \
 //x=15.66 //y=3.51 //x2=15.945 //y2=0.715
cc_1214 ( N_noxref_5_c_1320_n N_GND_c_2841_n ) capacitor c=0.00130539f \
 //x=16.03 //y=1.185 //x2=15.945 //y2=0.715
cc_1215 ( N_noxref_5_c_1320_n N_GND_c_2844_n ) capacitor c=0.00127339f \
 //x=16.03 //y=1.185 //x2=16.425 //y2=0.715
cc_1216 ( N_noxref_5_c_1255_n N_GND_c_2789_n ) capacitor c=0.00394736f \
 //x=12.7 //y=2.385 //x2=11.59 //y2=0.175
cc_1217 ( N_noxref_5_c_1259_n N_GND_c_2789_n ) capacitor c=0.00664422f \
 //x=12.7 //y=3.385 //x2=11.59 //y2=0.175
cc_1218 ( N_noxref_5_c_1275_n N_GND_c_2789_n ) capacitor c=0.00369503f \
 //x=12.7 //y=2.265 //x2=11.59 //y2=0.175
cc_1219 ( N_noxref_5_c_1280_n N_GND_c_2789_n ) capacitor c=0.0015404f \
 //x=12.505 //y=1.705 //x2=11.59 //y2=0.175
cc_1220 ( N_noxref_5_c_1282_n N_GND_c_2789_n ) capacitor c=0.00950704f \
 //x=12.505 //y=2.1 //x2=11.59 //y2=0.175
cc_1221 ( N_noxref_5_c_1310_n N_GND_c_2791_n ) capacitor c=0.0205341f \
 //x=15.745 //y=2.02 //x2=14.92 //y2=0.175
cc_1222 ( N_noxref_5_c_1264_n N_GND_c_2687_n ) capacitor c=2.14154e-19 \
 //x=15.66 //y=3.335 //x2=16.51 //y2=0.175
cc_1223 ( N_noxref_5_c_1313_n N_GND_c_2687_n ) capacitor c=0.00520602f \
 //x=16.03 //y=1.935 //x2=16.51 //y2=0.175
cc_1224 ( N_noxref_5_c_1320_n N_GND_c_2687_n ) capacitor c=2.8029e-19 \
 //x=16.03 //y=1.185 //x2=16.51 //y2=0.175
cc_1225 ( N_noxref_5_M8_noxref_d N_GND_c_2687_n ) capacitor c=2.70835e-19 \
 //x=15.835 //y=1.09 //x2=16.51 //y2=0.175
cc_1226 ( N_noxref_5_c_1255_n N_GND_M6_noxref_d ) capacitor c=4.23034e-19 \
 //x=12.7 //y=2.385 //x2=12.58 //y2=1.05
cc_1227 ( N_noxref_5_c_1278_n N_GND_M6_noxref_d ) capacitor c=0.00192399f \
 //x=12.505 //y=1.05 //x2=12.58 //y2=1.05
cc_1228 ( N_noxref_5_c_1279_n N_GND_M6_noxref_d ) capacitor c=0.00210798f \
 //x=12.505 //y=1.395 //x2=12.58 //y2=1.05
cc_1229 ( N_noxref_5_c_1486_p N_GND_M6_noxref_d ) capacitor c=0.00473146f \
 //x=12.88 //y=0.895 //x2=12.58 //y2=1.05
cc_1230 ( N_noxref_5_c_1487_p N_GND_M6_noxref_d ) capacitor c=0.00166857f \
 //x=12.88 //y=1.55 //x2=12.58 //y2=1.05
cc_1231 ( N_noxref_5_c_1286_n N_GND_M6_noxref_d ) capacitor c=0.00230174f \
 //x=13.035 //y=1.05 //x2=12.58 //y2=1.05
cc_1232 ( N_noxref_5_c_1288_n N_GND_M6_noxref_d ) capacitor c=0.00210798f \
 //x=13.035 //y=1.395 //x2=12.58 //y2=1.05
cc_1233 ( N_noxref_5_c_1302_n N_GND_M8_noxref_s ) capacitor c=0.00134951f \
 //x=15.66 //y=3.655 //x2=15.415 //y2=0.55
cc_1234 ( N_noxref_5_c_1310_n N_GND_M8_noxref_s ) capacitor c=0.00386445f \
 //x=15.745 //y=2.02 //x2=15.415 //y2=0.55
cc_1235 ( N_noxref_5_c_1313_n N_GND_M8_noxref_s ) capacitor c=0.032512f \
 //x=16.03 //y=1.935 //x2=15.415 //y2=0.55
cc_1236 ( N_noxref_5_c_1318_n N_GND_M8_noxref_s ) capacitor c=7.24897e-19 \
 //x=15.66 //y=3.51 //x2=15.415 //y2=0.55
cc_1237 ( N_noxref_5_c_1320_n N_GND_M8_noxref_s ) capacitor c=0.0156198f \
 //x=16.03 //y=1.185 //x2=15.415 //y2=0.55
cc_1238 ( N_noxref_5_M8_noxref_d N_GND_M8_noxref_s ) capacitor c=0.0377642f \
 //x=15.835 //y=1.09 //x2=15.415 //y2=0.55
cc_1239 ( N_noxref_5_c_1282_n N_noxref_14_c_3146_n ) capacitor c=0.00262672f \
 //x=12.505 //y=2.1 //x2=12.285 //y2=1.68
cc_1240 ( N_noxref_5_c_1255_n N_noxref_14_c_3147_n ) capacitor c=0.00528521f \
 //x=12.7 //y=2.385 //x2=13.17 //y2=1.765
cc_1241 ( N_noxref_5_c_1268_n N_noxref_14_c_3147_n ) capacitor c=0.00232678f \
 //x=12.7 //y=3.51 //x2=13.17 //y2=1.765
cc_1242 ( N_noxref_5_c_1275_n N_noxref_14_c_3147_n ) capacitor c=0.00763108f \
 //x=12.7 //y=2.265 //x2=13.17 //y2=1.765
cc_1243 ( N_noxref_5_c_1280_n N_noxref_14_c_3147_n ) capacitor c=0.00697569f \
 //x=12.505 //y=1.705 //x2=13.17 //y2=1.765
cc_1244 ( N_noxref_5_c_1282_n N_noxref_14_c_3147_n ) capacitor c=0.0174857f \
 //x=12.505 //y=2.1 //x2=13.17 //y2=1.765
cc_1245 ( N_noxref_5_c_1487_p N_noxref_14_c_3147_n ) capacitor c=0.00725634f \
 //x=12.88 //y=1.55 //x2=13.17 //y2=1.765
cc_1246 ( N_noxref_5_c_1288_n N_noxref_14_c_3147_n ) capacitor c=0.0034036f \
 //x=13.035 //y=1.395 //x2=13.17 //y2=1.765
cc_1247 ( N_noxref_5_c_1282_n N_noxref_14_c_3148_n ) capacitor c=6.71402e-19 \
 //x=12.505 //y=2.1 //x2=13.255 //y2=1.68
cc_1248 ( N_noxref_5_c_1278_n N_noxref_14_M6_noxref_s ) capacitor c=0.0294925f \
 //x=12.505 //y=1.05 //x2=12.15 //y2=0.55
cc_1249 ( N_noxref_5_c_1280_n N_noxref_14_M6_noxref_s ) capacitor \
 c=3.48408e-19 //x=12.505 //y=1.705 //x2=12.15 //y2=0.55
cc_1250 ( N_noxref_5_c_1286_n N_noxref_14_M6_noxref_s ) capacitor c=0.0125442f \
 //x=13.035 //y=1.05 //x2=12.15 //y2=0.55
cc_1251 ( N_B_M21_noxref_g N_VDD_c_2230_n ) capacitor c=0.00365752f //x=12.6 \
 //y=6.2 //x2=12.82 //y2=6.69
cc_1252 ( N_B_M22_noxref_g N_VDD_c_2230_n ) capacitor c=0.00387858f //x=13.04 \
 //y=6.2 //x2=12.82 //y2=6.69
cc_1253 ( N_B_M21_noxref_g N_VDD_c_2232_n ) capacitor c=0.00522062f //x=12.6 \
 //y=6.2 //x2=12.82 //y2=7.41
cc_1254 ( N_B_M22_noxref_g N_VDD_c_2232_n ) capacitor c=0.00588679f //x=13.04 \
 //y=6.2 //x2=12.82 //y2=7.41
cc_1255 ( N_B_c_1822_n N_VDD_c_2181_n ) capacitor c=2.19449e-19 //x=16.4 \
 //y=3.3 //x2=16.4 //y2=7.58
cc_1256 ( N_B_c_1823_n N_VDD_c_2181_n ) capacitor c=2.80614e-19 //x=16.4 \
 //y=4.88 //x2=16.4 //y2=7.58
cc_1257 ( N_B_c_1862_n N_VDD_c_2181_n ) capacitor c=3.40755e-19 //x=16.4 \
 //y=4.88 //x2=16.4 //y2=7.58
cc_1258 ( N_B_M11_noxref_g N_VDD_c_2048_n ) capacitor c=0.00697352f //x=2.38 \
 //y=6.2 //x2=2.955 //y2=7.585
cc_1259 ( N_B_M12_noxref_g N_VDD_c_2048_n ) capacitor c=0.00755544f //x=2.82 \
 //y=6.2 //x2=2.955 //y2=7.585
cc_1260 ( N_B_M21_noxref_g N_VDD_c_2161_n ) capacitor c=0.00750251f //x=12.6 \
 //y=6.2 //x2=14.75 //y2=7.585
cc_1261 ( N_B_M22_noxref_g N_VDD_c_2161_n ) capacitor c=0.00755544f //x=13.04 \
 //y=6.2 //x2=14.75 //y2=7.585
cc_1262 ( N_B_c_1823_n N_VDD_c_2206_n ) capacitor c=2.31683e-19 //x=16.4 \
 //y=4.88 //x2=16.38 //y2=7.585
cc_1263 ( N_B_M25_noxref_g N_VDD_c_2206_n ) capacitor c=0.00751326f //x=15.805 \
 //y=6.2 //x2=16.38 //y2=7.585
cc_1264 ( N_B_M26_noxref_g N_VDD_c_2206_n ) capacitor c=0.00753931f //x=16.245 \
 //y=6.2 //x2=16.38 //y2=7.585
cc_1265 ( N_B_c_1568_n N_VDD_c_2059_n ) capacitor c=0.00226427f //x=2.37 \
 //y=4.88 //x2=3.82 //y2=7.585
cc_1266 ( N_B_c_1582_n N_VDD_c_2059_n ) capacitor c=0.0129375f //x=2.745 \
 //y=4.97 //x2=3.82 //y2=7.585
cc_1267 ( N_B_c_1600_n N_VDD_c_2059_n ) capacitor c=2.73429e-19 //x=2.37 \
 //y=4.88 //x2=3.82 //y2=7.585
cc_1268 ( N_B_c_1637_n N_VDD_c_2067_n ) capacitor c=0.00271717f //x=6.395 \
 //y=3.88 //x2=6.04 //y2=7.585
cc_1269 ( N_B_c_1655_n N_VDD_c_2127_n ) capacitor c=0.00150408f //x=10.195 \
 //y=5.045 //x2=8.26 //y2=7.585
cc_1270 ( B N_VDD_c_2168_n ) capacitor c=0.00343839f //x=12.7 //y=4.62 \
 //x2=11.59 //y2=7.585
cc_1271 ( N_B_c_1755_n N_VDD_c_2168_n ) capacitor c=0.0275153f //x=12.54 \
 //y=5.045 //x2=11.59 //y2=7.585
cc_1272 ( N_B_c_1721_n N_VDD_c_2168_n ) capacitor c=0.00138316f //x=15.535 \
 //y=4.655 //x2=11.59 //y2=7.585
cc_1273 ( N_B_c_1725_n N_VDD_c_2168_n ) capacitor c=0.00953891f //x=12.7 \
 //y=4.62 //x2=11.59 //y2=7.585
cc_1274 ( N_B_c_1732_n N_VDD_c_2168_n ) capacitor c=0.0156948f //x=12.7 \
 //y=4.88 //x2=11.59 //y2=7.585
cc_1275 ( N_B_c_1721_n N_VDD_c_2169_n ) capacitor c=0.0259477f //x=15.535 \
 //y=4.655 //x2=14.92 //y2=7.585
cc_1276 ( N_B_c_1725_n N_VDD_c_2169_n ) capacitor c=0.00166632f //x=12.7 \
 //y=4.62 //x2=14.92 //y2=7.585
cc_1277 ( N_B_c_1862_n N_VDD_c_2169_n ) capacitor c=0.00235165f //x=16.4 \
 //y=4.88 //x2=14.92 //y2=7.585
cc_1278 ( N_B_c_1878_n N_VDD_c_2169_n ) capacitor c=0.00915756f //x=15.88 \
 //y=4.97 //x2=14.92 //y2=7.585
cc_1279 ( N_B_c_1923_p N_VDD_c_2169_n ) capacitor c=2.63786e-19 //x=16.245 \
 //y=5.045 //x2=14.92 //y2=7.585
cc_1280 ( B N_VDD_c_2070_n ) capacitor c=0.0117359f //x=16.4 //y=3.51 \
 //x2=16.4 //y2=7.58
cc_1281 ( N_B_c_1823_n N_VDD_c_2070_n ) capacitor c=0.00699438f //x=16.4 \
 //y=4.88 //x2=16.4 //y2=7.58
cc_1282 ( N_B_c_1862_n N_VDD_c_2070_n ) capacitor c=0.00803468f //x=16.4 \
 //y=4.88 //x2=16.4 //y2=7.58
cc_1283 ( N_B_M26_noxref_g N_VDD_c_2070_n ) capacitor c=0.0181495f //x=16.245 \
 //y=6.2 //x2=16.4 //y2=7.58
cc_1284 ( N_B_c_1923_p N_VDD_c_2070_n ) capacitor c=0.0061994f //x=16.245 \
 //y=5.045 //x2=16.4 //y2=7.58
cc_1285 ( N_B_M11_noxref_g N_VDD_M10_noxref_d ) capacitor c=0.015318f //x=2.38 \
 //y=6.2 //x2=2.015 //y2=5.2
cc_1286 ( N_B_c_1600_n N_VDD_M10_noxref_d ) capacitor c=3.32552e-19 //x=2.37 \
 //y=4.88 //x2=2.015 //y2=5.2
cc_1287 ( N_B_M12_noxref_g N_VDD_M12_noxref_d ) capacitor c=0.0430452f \
 //x=2.82 //y=6.2 //x2=2.895 //y2=5.2
cc_1288 ( N_B_c_1725_n N_VDD_M21_noxref_d ) capacitor c=0.00198053f //x=12.7 \
 //y=4.62 //x2=12.675 //y2=5.2
cc_1289 ( N_B_M21_noxref_g N_VDD_M21_noxref_d ) capacitor c=0.00896756f \
 //x=12.6 //y=6.2 //x2=12.675 //y2=5.2
cc_1290 ( N_B_M22_noxref_g N_VDD_M21_noxref_d ) capacitor c=0.00896756f \
 //x=13.04 //y=6.2 //x2=12.675 //y2=5.2
cc_1291 ( N_B_c_1732_n N_VDD_M21_noxref_d ) capacitor c=0.00318882f //x=12.7 \
 //y=4.88 //x2=12.675 //y2=5.2
cc_1292 ( N_B_c_1721_n N_VDD_M25_noxref_s ) capacitor c=0.00303281f //x=15.535 \
 //y=4.655 //x2=15.46 //y2=5.2
cc_1293 ( N_B_M25_noxref_g N_VDD_M25_noxref_s ) capacitor c=0.0572684f \
 //x=15.805 //y=6.2 //x2=15.46 //y2=5.2
cc_1294 ( N_B_c_1823_n N_VDD_M26_noxref_d ) capacitor c=0.0220603f //x=16.4 \
 //y=4.88 //x2=16.32 //y2=5.2
cc_1295 ( N_B_c_1846_n N_VDD_M26_noxref_d ) capacitor c=0.00616847f //x=15.88 \
 //y=4.655 //x2=16.32 //y2=5.2
cc_1296 ( N_B_c_1862_n N_VDD_M26_noxref_d ) capacitor c=0.00986169f //x=16.4 \
 //y=4.88 //x2=16.32 //y2=5.2
cc_1297 ( N_B_M26_noxref_g N_VDD_M26_noxref_d ) capacitor c=0.0573441f \
 //x=16.245 //y=6.2 //x2=16.32 //y2=5.2
cc_1298 ( N_B_c_1923_p N_VDD_M26_noxref_d ) capacitor c=0.00463894f //x=16.245 \
 //y=5.045 //x2=16.32 //y2=5.2
cc_1299 ( N_B_c_1564_n COUT ) capacitor c=5.32263e-19 //x=4.77 //y=3.895 \
 //x2=5.3 //y2=2.4
cc_1300 ( N_B_c_1637_n COUT ) capacitor c=0.0294548f //x=6.395 //y=3.88 \
 //x2=5.3 //y2=2.4
cc_1301 ( N_B_c_1637_n N_COUT_c_2412_n ) capacitor c=0.00271225f //x=6.395 \
 //y=3.88 //x2=5.215 //y2=2.02
cc_1302 ( N_B_c_1564_n N_COUT_c_2413_n ) capacitor c=0.00286809f //x=4.77 \
 //y=3.895 //x2=5.015 //y2=2.02
cc_1303 ( N_B_c_1647_n N_noxref_9_c_2489_n ) capacitor c=0.00356639f //x=9.58 \
 //y=3.87 //x2=9.81 //y2=5.385
cc_1304 ( N_B_c_1658_n N_noxref_9_c_2489_n ) capacitor c=0.00704427f \
 //x=10.105 //y=3.87 //x2=9.81 //y2=5.385
cc_1305 ( B N_noxref_9_c_2506_n ) capacitor c=9.64474e-19 //x=10.11 //y=3.88 \
 //x2=10.695 //y2=7.085
cc_1306 ( N_B_c_1655_n N_noxref_9_c_2506_n ) capacitor c=0.00432582f \
 //x=10.195 //y=5.045 //x2=10.695 //y2=7.085
cc_1307 ( B N_noxref_9_c_2499_n ) capacitor c=0.00494232f //x=10.11 //y=3.88 \
 //x2=9.93 //y2=5.385
cc_1308 ( N_B_c_1655_n N_noxref_9_c_2499_n ) capacitor c=0.00108508f \
 //x=10.195 //y=5.045 //x2=9.93 //y2=5.385
cc_1309 ( N_B_c_1658_n N_noxref_9_c_2499_n ) capacitor c=0.00223056f \
 //x=10.105 //y=3.87 //x2=9.93 //y2=5.385
cc_1310 ( B N_noxref_9_c_2503_n ) capacitor c=9.68518e-19 //x=10.11 //y=3.88 \
 //x2=9.93 //y2=5.555
cc_1311 ( B N_noxref_10_c_2602_n ) capacitor c=0.0184309f //x=12.7 //y=4.62 \
 //x2=13.145 //y2=5.385
cc_1312 ( N_B_c_1721_n N_noxref_10_c_2602_n ) capacitor c=0.0336014f \
 //x=15.535 //y=4.655 //x2=13.145 //y2=5.385
cc_1313 ( N_B_c_1725_n N_noxref_10_c_2602_n ) capacitor c=0.00318417f //x=12.7 \
 //y=4.62 //x2=13.145 //y2=5.385
cc_1314 ( N_B_M21_noxref_g N_noxref_10_c_2602_n ) capacitor c=0.0109419f \
 //x=12.6 //y=6.2 //x2=13.145 //y2=5.385
cc_1315 ( N_B_M22_noxref_g N_noxref_10_c_2602_n ) capacitor c=0.00889995f \
 //x=13.04 //y=6.2 //x2=13.145 //y2=5.385
cc_1316 ( N_B_c_1732_n N_noxref_10_c_2602_n ) capacitor c=0.00140744f //x=12.7 \
 //y=4.88 //x2=13.145 //y2=5.385
cc_1317 ( N_B_c_1755_n N_noxref_10_c_2590_n ) capacitor c=0.0140288f //x=12.54 \
 //y=5.045 //x2=12.38 //y2=5.385
cc_1318 ( N_B_M21_noxref_g N_noxref_10_c_2590_n ) capacitor c=0.00394587f \
 //x=12.6 //y=6.2 //x2=12.38 //y2=5.385
cc_1319 ( N_B_c_1721_n N_noxref_10_c_2582_n ) capacitor c=9.55296e-19 \
 //x=15.535 //y=4.655 //x2=13.26 //y2=5.385
cc_1320 ( N_B_M22_noxref_g N_noxref_10_c_2582_n ) capacitor c=0.00179267f \
 //x=13.04 //y=6.2 //x2=13.26 //y2=5.385
cc_1321 ( N_B_M22_noxref_g N_noxref_10_c_2583_n ) capacitor c=0.00182026f \
 //x=13.04 //y=6.2 //x2=13.26 //y2=6.915
cc_1322 ( N_B_M21_noxref_g N_noxref_10_c_2613_n ) capacitor c=0.046753f \
 //x=12.6 //y=6.2 //x2=12.38 //y2=5.555
cc_1323 ( N_B_M22_noxref_g N_noxref_10_c_2585_n ) capacitor c=0.0184757f \
 //x=13.04 //y=6.2 //x2=13.26 //y2=5.555
cc_1324 ( N_B_M21_noxref_g N_noxref_10_M21_noxref_s ) capacitor c=0.00526487f \
 //x=12.6 //y=6.2 //x2=12.245 //y2=5.2
cc_1325 ( N_B_c_1551_n N_GND_c_2661_n ) capacitor c=0.00234561f //x=2.34 \
 //y=2.26 //x2=9.355 //y2=0.175
cc_1326 ( B N_GND_c_2805_n ) capacitor c=6.63781e-19 //x=10.11 //y=3.88 \
 //x2=12.685 //y2=0.175
cc_1327 ( N_B_c_1822_n N_GND_c_2778_n ) capacitor c=3.74671e-19 //x=16.4 \
 //y=3.3 //x2=16.4 //y2=0.18
cc_1328 ( N_B_c_1824_n N_GND_c_2778_n ) capacitor c=0.00249098f //x=16.4 \
 //y=2.265 //x2=16.4 //y2=0.18
cc_1329 ( N_B_c_1861_n N_GND_c_2778_n ) capacitor c=7.5371e-19 //x=16.4 \
 //y=2.265 //x2=16.4 //y2=0.18
cc_1330 ( N_B_c_1551_n N_GND_c_2670_n ) capacitor c=3.77328e-19 //x=2.34 \
 //y=2.26 //x2=3.65 //y2=0.175
cc_1331 ( N_B_c_1870_n N_GND_c_2841_n ) capacitor c=0.0132669f //x=15.76 \
 //y=1.09 //x2=15.945 //y2=0.715
cc_1332 ( N_B_c_1822_n N_GND_c_2844_n ) capacitor c=5.06357e-19 //x=16.4 \
 //y=3.3 //x2=16.425 //y2=0.715
cc_1333 ( N_B_c_1824_n N_GND_c_2844_n ) capacitor c=0.00114179f //x=16.4 \
 //y=2.265 //x2=16.425 //y2=0.715
cc_1334 ( N_B_c_1861_n N_GND_c_2844_n ) capacitor c=3.95714e-19 //x=16.4 \
 //y=2.265 //x2=16.425 //y2=0.715
cc_1335 ( N_B_c_1886_n N_GND_c_2844_n ) capacitor c=0.0126466f //x=16.29 \
 //y=1.09 //x2=16.425 //y2=0.715
cc_1336 ( N_B_c_1893_n N_GND_c_2844_n ) capacitor c=2.1838e-19 //x=16.29 \
 //y=2.265 //x2=16.425 //y2=0.715
cc_1337 ( N_B_c_1567_n N_GND_c_2678_n ) capacitor c=0.00224736f //x=2.34 \
 //y=2.26 //x2=3.82 //y2=0.175
cc_1338 ( N_B_c_1593_n N_GND_c_2678_n ) capacitor c=0.00275184f //x=2.905 \
 //y=1.43 //x2=3.82 //y2=0.175
cc_1339 ( N_B_c_1597_n N_GND_c_2678_n ) capacitor c=2.63786e-19 //x=2.34 \
 //y=2.26 //x2=3.82 //y2=0.175
cc_1340 ( N_B_c_1637_n N_GND_c_2686_n ) capacitor c=0.00440673f //x=6.395 \
 //y=3.88 //x2=6.04 //y2=0.175
cc_1341 ( N_B_c_1644_n N_GND_c_2741_n ) capacitor c=0.00276652f //x=8.98 \
 //y=3.88 //x2=8.26 //y2=0.175
cc_1342 ( N_B_c_1717_n N_GND_c_2789_n ) capacitor c=0.00411812f //x=15.31 \
 //y=3.14 //x2=11.59 //y2=0.175
cc_1343 ( N_B_c_1668_n N_GND_c_2789_n ) capacitor c=0.00348382f //x=10.48 \
 //y=2.265 //x2=11.59 //y2=0.175
cc_1344 ( N_B_c_1692_n N_GND_c_2789_n ) capacitor c=0.00583872f //x=10.145 \
 //y=2.1 //x2=11.59 //y2=0.175
cc_1345 ( N_B_c_1696_n N_GND_c_2789_n ) capacitor c=0.00230557f //x=10.675 \
 //y=1.435 //x2=11.59 //y2=0.175
cc_1346 ( N_B_c_1717_n N_GND_c_2791_n ) capacitor c=0.00725442f //x=15.31 \
 //y=3.14 //x2=14.92 //y2=0.175
cc_1347 ( N_B_c_1861_n N_GND_c_2791_n ) capacitor c=0.0022444f //x=16.4 \
 //y=2.265 //x2=14.92 //y2=0.175
cc_1348 ( N_B_c_1893_n N_GND_c_2791_n ) capacitor c=2.63786e-19 //x=16.29 \
 //y=2.265 //x2=14.92 //y2=0.175
cc_1349 ( B N_GND_c_2687_n ) capacitor c=0.0146622f //x=16.4 //y=2.77 \
 //x2=16.51 //y2=0.175
cc_1350 ( N_B_c_1824_n N_GND_c_2687_n ) capacitor c=0.0100674f //x=16.4 \
 //y=2.265 //x2=16.51 //y2=0.175
cc_1351 ( N_B_c_1861_n N_GND_c_2687_n ) capacitor c=0.00733542f //x=16.4 \
 //y=2.265 //x2=16.51 //y2=0.175
cc_1352 ( N_B_c_1892_n N_GND_c_2687_n ) capacitor c=0.00574455f //x=16.29 \
 //y=2.1 //x2=16.51 //y2=0.175
cc_1353 ( N_B_c_1893_n N_GND_c_2687_n ) capacitor c=0.00785621f //x=16.29 \
 //y=2.265 //x2=16.51 //y2=0.175
cc_1354 ( N_B_c_1637_n N_GND_M2_noxref_s ) capacitor c=0.00151311f //x=6.395 \
 //y=3.88 //x2=4.315 //y2=0.55
cc_1355 ( N_B_c_1639_n N_GND_M3_noxref_s ) capacitor c=8.43261e-19 //x=6.995 \
 //y=3.865 //x2=6.535 //y2=0.55
cc_1356 ( N_B_c_1822_n N_GND_M8_noxref_s ) capacitor c=5.465e-19 //x=16.4 \
 //y=3.3 //x2=15.415 //y2=0.55
cc_1357 ( N_B_c_1824_n N_GND_M8_noxref_s ) capacitor c=0.00297779f //x=16.4 \
 //y=2.265 //x2=15.415 //y2=0.55
cc_1358 ( N_B_c_1717_n N_GND_M8_noxref_s ) capacitor c=0.00188685f //x=15.31 \
 //y=3.14 //x2=15.415 //y2=0.55
cc_1359 ( N_B_c_1861_n N_GND_M8_noxref_s ) capacitor c=0.00651326f //x=16.4 \
 //y=2.265 //x2=15.415 //y2=0.55
cc_1360 ( N_B_c_1870_n N_GND_M8_noxref_s ) capacitor c=0.0153553f //x=15.76 \
 //y=1.09 //x2=15.415 //y2=0.55
cc_1361 ( N_B_c_1872_n N_GND_M8_noxref_s ) capacitor c=0.00629878f //x=15.76 \
 //y=1.435 //x2=15.415 //y2=0.55
cc_1362 ( N_B_c_1881_n N_GND_M8_noxref_s ) capacitor c=0.00521375f //x=16.135 \
 //y=0.935 //x2=15.415 //y2=0.55
cc_1363 ( N_B_c_1886_n N_GND_M8_noxref_s ) capacitor c=0.030052f //x=16.29 \
 //y=1.09 //x2=15.415 //y2=0.55
cc_1364 ( N_B_c_1891_n N_GND_M8_noxref_s ) capacitor c=0.002132f //x=16.29 \
 //y=1.745 //x2=15.415 //y2=0.55
cc_1365 ( N_B_c_1892_n N_GND_M8_noxref_s ) capacitor c=0.00304786f //x=16.29 \
 //y=2.1 //x2=15.415 //y2=0.55
cc_1366 ( N_B_c_1893_n N_GND_M8_noxref_s ) capacitor c=0.0065996f //x=16.29 \
 //y=2.265 //x2=15.415 //y2=0.55
cc_1367 ( N_B_c_1543_n N_noxref_12_c_3017_n ) capacitor c=3.8114e-19 //x=2.34 \
 //y=4.025 //x2=2.155 //y2=1.675
cc_1368 ( N_B_c_1551_n N_noxref_12_c_3017_n ) capacitor c=7.50092e-19 //x=2.34 \
 //y=2.26 //x2=2.155 //y2=1.675
cc_1369 ( N_B_c_1581_n N_noxref_12_c_3017_n ) capacitor c=0.00888238f \
 //x=2.375 //y=1.74 //x2=2.155 //y2=1.675
cc_1370 ( N_B_c_1597_n N_noxref_12_c_3017_n ) capacitor c=0.00175171f //x=2.34 \
 //y=2.26 //x2=2.155 //y2=1.675
cc_1371 ( N_B_c_1551_n N_noxref_12_c_3018_n ) capacitor c=0.001463f //x=2.34 \
 //y=2.26 //x2=3.04 //y2=0.71
cc_1372 ( N_B_c_1567_n N_noxref_12_c_3018_n ) capacitor c=8.82141e-19 //x=2.34 \
 //y=2.26 //x2=3.04 //y2=0.71
cc_1373 ( N_B_c_1576_n N_noxref_12_c_3018_n ) capacitor c=0.0200738f //x=2.375 \
 //y=1.085 //x2=3.04 //y2=0.71
cc_1374 ( N_B_c_1591_n N_noxref_12_c_3018_n ) capacitor c=0.00825432f \
 //x=2.905 //y=1.085 //x2=3.04 //y2=0.71
cc_1375 ( N_B_c_1597_n N_noxref_12_c_3018_n ) capacitor c=2.1838e-19 //x=2.34 \
 //y=2.26 //x2=3.04 //y2=0.71
cc_1376 ( N_B_c_1576_n N_noxref_12_M0_noxref_s ) capacitor c=0.00888238f \
 //x=2.375 //y=1.085 //x2=1.05 //y2=0.545
cc_1377 ( N_B_c_1591_n N_noxref_12_M0_noxref_s ) capacitor c=0.015333f \
 //x=2.905 //y=1.085 //x2=1.05 //y2=0.545
cc_1378 ( N_B_c_1593_n N_noxref_12_M0_noxref_s ) capacitor c=0.00248746f \
 //x=2.905 //y=1.43 //x2=1.05 //y2=0.545
cc_1379 ( B N_noxref_13_c_3088_n ) capacitor c=0.00140836f //x=10.11 //y=3.88 \
 //x2=9.925 //y2=1.68
cc_1380 ( N_B_c_1689_n N_noxref_13_c_3088_n ) capacitor c=0.00888238f \
 //x=10.145 //y=1.745 //x2=9.925 //y2=1.68
cc_1381 ( B N_noxref_13_c_3095_n ) capacitor c=0.00109168f //x=10.11 //y=3.88 \
 //x2=10.81 //y2=0.715
cc_1382 ( N_B_c_1668_n N_noxref_13_c_3095_n ) capacitor c=4.16328e-19 \
 //x=10.48 //y=2.265 //x2=10.81 //y2=0.715
cc_1383 ( N_B_c_1684_n N_noxref_13_c_3095_n ) capacitor c=0.02018f //x=10.145 \
 //y=1.09 //x2=10.81 //y2=0.715
cc_1384 ( N_B_c_1692_n N_noxref_13_c_3095_n ) capacitor c=2.1838e-19 \
 //x=10.145 //y=2.1 //x2=10.81 //y2=0.715
cc_1385 ( N_B_c_1695_n N_noxref_13_c_3095_n ) capacitor c=0.00825432f \
 //x=10.675 //y=1.09 //x2=10.81 //y2=0.715
cc_1386 ( N_B_c_1684_n N_noxref_13_M4_noxref_s ) capacitor c=0.00888238f \
 //x=10.145 //y=1.09 //x2=8.82 //y2=0.55
cc_1387 ( N_B_c_1695_n N_noxref_13_M4_noxref_s ) capacitor c=0.015333f \
 //x=10.675 //y=1.09 //x2=8.82 //y2=0.55
cc_1388 ( N_B_c_1696_n N_noxref_13_M4_noxref_s ) capacitor c=0.00248746f \
 //x=10.675 //y=1.435 //x2=8.82 //y2=0.55
cc_1389 ( N_B_c_1717_n N_noxref_14_M6_noxref_s ) capacitor c=6.41629e-19 \
 //x=15.31 //y=3.14 //x2=12.15 //y2=0.55
cc_1390 ( N_VDD_c_2067_n COUT ) capacitor c=0.0210096f //x=6.04 //y=7.585 \
 //x2=5.3 //y2=2.4
cc_1391 ( N_VDD_c_2034_n N_COUT_c_2408_n ) capacitor c=0.00259721f //x=9.405 \
 //y=7.585 //x2=4.935 //y2=5.42
cc_1392 ( N_VDD_c_2053_n N_COUT_c_2408_n ) capacitor c=8.96756e-19 //x=5.29 \
 //y=7.585 //x2=4.935 //y2=5.42
cc_1393 ( N_VDD_c_2067_n N_COUT_c_2408_n ) capacitor c=0.00217227f //x=6.04 \
 //y=7.585 //x2=4.935 //y2=5.42
cc_1394 ( N_VDD_M9_noxref_s N_COUT_c_2408_n ) capacitor c=2.62188e-19 \
 //x=1.145 //y=5.2 //x2=4.935 //y2=5.42
cc_1395 ( N_VDD_M13_noxref_s N_COUT_c_2408_n ) capacitor c=0.0465774f //x=4.36 \
 //y=5.2 //x2=4.935 //y2=5.42
cc_1396 ( N_VDD_M14_noxref_d N_COUT_c_2408_n ) capacitor c=0.0474638f //x=5.23 \
 //y=5.2 //x2=4.935 //y2=5.42
cc_1397 ( N_VDD_M15_noxref_s N_COUT_c_2408_n ) capacitor c=8.11512e-19 \
 //x=6.58 //y=5.2 //x2=4.935 //y2=5.42
cc_1398 ( N_VDD_c_2034_n N_COUT_c_2415_n ) capacitor c=0.00199795f //x=9.405 \
 //y=7.585 //x2=5.215 //y2=5.14
cc_1399 ( N_VDD_c_2053_n N_COUT_c_2415_n ) capacitor c=0.00197507f //x=5.29 \
 //y=7.585 //x2=5.215 //y2=5.14
cc_1400 ( N_VDD_M14_noxref_d N_COUT_c_2415_n ) capacitor c=0.0223364f //x=5.23 \
 //y=5.2 //x2=5.215 //y2=5.14
cc_1401 ( N_VDD_c_2059_n N_COUT_c_2416_n ) capacitor c=0.00464635f //x=3.82 \
 //y=7.585 //x2=5.02 //y2=5.14
cc_1402 ( N_VDD_c_2034_n N_COUT_c_2427_n ) capacitor c=0.00241566f //x=9.405 \
 //y=7.585 //x2=4.935 //y2=5.56
cc_1403 ( N_VDD_c_2053_n N_COUT_c_2427_n ) capacitor c=0.0138017f //x=5.29 \
 //y=7.585 //x2=4.935 //y2=5.56
cc_1404 ( N_VDD_c_2059_n N_COUT_c_2427_n ) capacitor c=0.00821941f //x=3.82 \
 //y=7.585 //x2=4.935 //y2=5.56
cc_1405 ( N_VDD_c_2067_n N_COUT_c_2427_n ) capacitor c=0.00826477f //x=6.04 \
 //y=7.585 //x2=4.935 //y2=5.56
cc_1406 ( N_VDD_c_2070_n N_COUT_c_2427_n ) capacitor c=0.00135089f //x=16.4 \
 //y=7.58 //x2=4.935 //y2=5.56
cc_1407 ( N_VDD_M13_noxref_s N_COUT_c_2427_n ) capacitor c=0.0900053f //x=4.36 \
 //y=5.2 //x2=4.935 //y2=5.56
cc_1408 ( N_VDD_M14_noxref_d N_COUT_c_2427_n ) capacitor c=0.0908773f //x=5.23 \
 //y=5.2 //x2=4.935 //y2=5.56
cc_1409 ( N_VDD_c_2034_n N_noxref_9_c_2489_n ) capacitor c=0.00175386f \
 //x=9.405 //y=7.585 //x2=9.81 //y2=5.385
cc_1410 ( N_VDD_c_2098_n N_noxref_9_c_2489_n ) capacitor c=0.00657437f \
 //x=9.49 //y=6.7 //x2=9.81 //y2=5.385
cc_1411 ( N_VDD_c_2179_n N_noxref_9_c_2489_n ) capacitor c=5.36854e-19 \
 //x=12.735 //y=7.585 //x2=9.81 //y2=5.385
cc_1412 ( N_VDD_c_2109_n N_noxref_9_c_2489_n ) capacitor c=0.00579317f \
 //x=11.42 //y=7.585 //x2=9.81 //y2=5.385
cc_1413 ( N_VDD_M17_noxref_d N_noxref_9_c_2489_n ) capacitor c=0.0056162f \
 //x=9.345 //y=5.2 //x2=9.81 //y2=5.385
cc_1414 ( N_VDD_c_2070_n N_noxref_9_c_2506_n ) capacitor c=0.00219107f \
 //x=16.4 //y=7.58 //x2=10.695 //y2=7.085
cc_1415 ( N_VDD_c_2034_n N_noxref_9_c_2496_n ) capacitor c=4.41493e-19 \
 //x=9.405 //y=7.585 //x2=9.057 //y2=5.385
cc_1416 ( N_VDD_c_2109_n N_noxref_9_c_2496_n ) capacitor c=2.31756e-19 \
 //x=11.42 //y=7.585 //x2=9.057 //y2=5.385
cc_1417 ( N_VDD_c_2127_n N_noxref_9_c_2496_n ) capacitor c=0.00721415f \
 //x=8.26 //y=7.585 //x2=9.057 //y2=5.385
cc_1418 ( N_VDD_M16_noxref_d N_noxref_9_c_2496_n ) capacitor c=0.0122414f \
 //x=7.45 //y=5.2 //x2=9.057 //y2=5.385
cc_1419 ( N_VDD_c_2100_n N_noxref_9_c_2500_n ) capacitor c=0.0389154f //x=9.49 \
 //y=7.41 //x2=9.93 //y2=6.915
cc_1420 ( N_VDD_c_2179_n N_noxref_9_c_2500_n ) capacitor c=0.0967872f \
 //x=12.735 //y=7.585 //x2=9.93 //y2=6.915
cc_1421 ( N_VDD_c_2109_n N_noxref_9_c_2500_n ) capacitor c=0.0182898f \
 //x=11.42 //y=7.585 //x2=9.93 //y2=6.915
cc_1422 ( N_VDD_c_2070_n N_noxref_9_c_2500_n ) capacitor c=0.0011052f //x=16.4 \
 //y=7.58 //x2=9.93 //y2=6.915
cc_1423 ( N_VDD_c_2100_n N_noxref_9_c_2512_n ) capacitor c=0.00102965f \
 //x=9.49 //y=7.41 //x2=10.81 //y2=6.915
cc_1424 ( N_VDD_c_2179_n N_noxref_9_c_2512_n ) capacitor c=0.00184284f \
 //x=12.735 //y=7.585 //x2=10.81 //y2=6.915
cc_1425 ( N_VDD_c_2232_n N_noxref_9_c_2512_n ) capacitor c=0.002629f //x=12.82 \
 //y=7.41 //x2=10.81 //y2=6.915
cc_1426 ( N_VDD_c_2109_n N_noxref_9_c_2512_n ) capacitor c=5.81313e-19 \
 //x=11.42 //y=7.585 //x2=10.81 //y2=6.915
cc_1427 ( N_VDD_c_2168_n N_noxref_9_c_2512_n ) capacitor c=0.00746969f \
 //x=11.59 //y=7.585 //x2=10.81 //y2=6.915
cc_1428 ( N_VDD_c_2070_n N_noxref_9_c_2512_n ) capacitor c=0.00110302f \
 //x=16.4 //y=7.58 //x2=10.81 //y2=6.915
cc_1429 ( N_VDD_c_2034_n N_noxref_9_c_2501_n ) capacitor c=0.00209062f \
 //x=9.405 //y=7.585 //x2=9.05 //y2=5.555
cc_1430 ( N_VDD_c_2098_n N_noxref_9_c_2501_n ) capacitor c=0.00716177f \
 //x=9.49 //y=6.7 //x2=9.05 //y2=5.555
cc_1431 ( N_VDD_c_2100_n N_noxref_9_c_2501_n ) capacitor c=0.00218649f \
 //x=9.49 //y=7.41 //x2=9.05 //y2=5.555
cc_1432 ( N_VDD_c_2109_n N_noxref_9_c_2501_n ) capacitor c=0.00844587f \
 //x=11.42 //y=7.585 //x2=9.05 //y2=5.555
cc_1433 ( N_VDD_c_2127_n N_noxref_9_c_2501_n ) capacitor c=0.0523125f //x=8.26 \
 //y=7.585 //x2=9.05 //y2=5.555
cc_1434 ( N_VDD_c_2070_n N_noxref_9_c_2501_n ) capacitor c=9.85326e-19 \
 //x=16.4 //y=7.58 //x2=9.05 //y2=5.555
cc_1435 ( N_VDD_M16_noxref_d N_noxref_9_c_2501_n ) capacitor c=0.00276503f \
 //x=7.45 //y=5.2 //x2=9.05 //y2=5.555
cc_1436 ( N_VDD_M17_noxref_d N_noxref_9_c_2501_n ) capacitor c=0.0478566f \
 //x=9.345 //y=5.2 //x2=9.05 //y2=5.555
cc_1437 ( N_VDD_c_2098_n N_noxref_9_c_2503_n ) capacitor c=0.00626175f \
 //x=9.49 //y=6.7 //x2=9.93 //y2=5.555
cc_1438 ( N_VDD_c_2100_n N_noxref_9_c_2503_n ) capacitor c=0.00311588f \
 //x=9.49 //y=7.41 //x2=9.93 //y2=5.555
cc_1439 ( N_VDD_c_2179_n N_noxref_9_c_2503_n ) capacitor c=0.00203449f \
 //x=12.735 //y=7.585 //x2=9.93 //y2=5.555
cc_1440 ( N_VDD_c_2109_n N_noxref_9_c_2503_n ) capacitor c=0.0084192f \
 //x=11.42 //y=7.585 //x2=9.93 //y2=5.555
cc_1441 ( N_VDD_c_2070_n N_noxref_9_c_2503_n ) capacitor c=9.85326e-19 \
 //x=16.4 //y=7.58 //x2=9.93 //y2=5.555
cc_1442 ( N_VDD_M17_noxref_d N_noxref_9_c_2503_n ) capacitor c=0.047843f \
 //x=9.345 //y=5.2 //x2=9.93 //y2=5.555
cc_1443 ( N_VDD_c_2034_n N_noxref_9_M17_noxref_s ) capacitor c=0.0218384f \
 //x=9.405 //y=7.585 //x2=8.915 //y2=5.2
cc_1444 ( N_VDD_c_2100_n N_noxref_9_M17_noxref_s ) capacitor c=0.0369805f \
 //x=9.49 //y=7.41 //x2=8.915 //y2=5.2
cc_1445 ( N_VDD_c_2109_n N_noxref_9_M17_noxref_s ) capacitor c=0.00343047f \
 //x=11.42 //y=7.585 //x2=8.915 //y2=5.2
cc_1446 ( N_VDD_c_2127_n N_noxref_9_M17_noxref_s ) capacitor c=0.00927581f \
 //x=8.26 //y=7.585 //x2=8.915 //y2=5.2
cc_1447 ( N_VDD_c_2070_n N_noxref_9_M17_noxref_s ) capacitor c=8.52457e-19 \
 //x=16.4 //y=7.58 //x2=8.915 //y2=5.2
cc_1448 ( N_VDD_c_2179_n N_noxref_9_M20_noxref_d ) capacitor c=0.00204601f \
 //x=12.735 //y=7.585 //x2=10.665 //y2=5.2
cc_1449 ( N_VDD_c_2109_n N_noxref_9_M20_noxref_d ) capacitor c=0.00844271f \
 //x=11.42 //y=7.585 //x2=10.665 //y2=5.2
cc_1450 ( N_VDD_c_2168_n N_noxref_9_M20_noxref_d ) capacitor c=0.0449172f \
 //x=11.59 //y=7.585 //x2=10.665 //y2=5.2
cc_1451 ( N_VDD_c_2070_n N_noxref_9_M20_noxref_d ) capacitor c=9.81989e-19 \
 //x=16.4 //y=7.58 //x2=10.665 //y2=5.2
cc_1452 ( N_VDD_c_2179_n N_noxref_10_c_2602_n ) capacitor c=5.9643e-19 \
 //x=12.735 //y=7.585 //x2=13.145 //y2=5.385
cc_1453 ( N_VDD_c_2230_n N_noxref_10_c_2602_n ) capacitor c=0.00608477f \
 //x=12.82 //y=6.69 //x2=13.145 //y2=5.385
cc_1454 ( N_VDD_c_2181_n N_noxref_10_c_2602_n ) capacitor c=0.0019922f \
 //x=16.4 //y=7.58 //x2=13.145 //y2=5.385
cc_1455 ( N_VDD_c_2161_n N_noxref_10_c_2602_n ) capacitor c=0.00595345f \
 //x=14.75 //y=7.585 //x2=13.145 //y2=5.385
cc_1456 ( N_VDD_M21_noxref_d N_noxref_10_c_2602_n ) capacitor c=0.00560574f \
 //x=12.675 //y=5.2 //x2=13.145 //y2=5.385
cc_1457 ( N_VDD_c_2070_n N_noxref_10_c_2580_n ) capacitor c=0.00219107f \
 //x=16.4 //y=7.58 //x2=14.02 //y2=7.085
cc_1458 ( N_VDD_c_2168_n N_noxref_10_c_2590_n ) capacitor c=0.00751288f \
 //x=11.59 //y=7.585 //x2=12.38 //y2=5.385
cc_1459 ( N_VDD_M25_noxref_s N_noxref_10_c_2582_n ) capacitor c=7.50235e-19 \
 //x=15.46 //y=5.2 //x2=13.26 //y2=5.385
cc_1460 ( N_VDD_c_2232_n N_noxref_10_c_2583_n ) capacitor c=0.0393574f \
 //x=12.82 //y=7.41 //x2=13.26 //y2=6.915
cc_1461 ( N_VDD_c_2181_n N_noxref_10_c_2583_n ) capacitor c=0.09647f //x=16.4 \
 //y=7.58 //x2=13.26 //y2=6.915
cc_1462 ( N_VDD_c_2161_n N_noxref_10_c_2583_n ) capacitor c=0.0204087f \
 //x=14.75 //y=7.585 //x2=13.26 //y2=6.915
cc_1463 ( N_VDD_c_2070_n N_noxref_10_c_2583_n ) capacitor c=0.0011052f \
 //x=16.4 //y=7.58 //x2=13.26 //y2=6.915
cc_1464 ( N_VDD_c_2232_n N_noxref_10_c_2584_n ) capacitor c=0.00105525f \
 //x=12.82 //y=7.41 //x2=14.14 //y2=6.915
cc_1465 ( N_VDD_c_2181_n N_noxref_10_c_2584_n ) capacitor c=0.00191156f \
 //x=16.4 //y=7.58 //x2=14.14 //y2=6.915
cc_1466 ( N_VDD_c_2161_n N_noxref_10_c_2584_n ) capacitor c=5.93287e-19 \
 //x=14.75 //y=7.585 //x2=14.14 //y2=6.915
cc_1467 ( N_VDD_c_2169_n N_noxref_10_c_2584_n ) capacitor c=0.0114198f \
 //x=14.92 //y=7.585 //x2=14.14 //y2=6.915
cc_1468 ( N_VDD_c_2070_n N_noxref_10_c_2584_n ) capacitor c=0.00110321f \
 //x=16.4 //y=7.58 //x2=14.14 //y2=6.915
cc_1469 ( N_VDD_c_2179_n N_noxref_10_c_2613_n ) capacitor c=0.00210247f \
 //x=12.735 //y=7.585 //x2=12.38 //y2=5.555
cc_1470 ( N_VDD_c_2230_n N_noxref_10_c_2613_n ) capacitor c=0.00601924f \
 //x=12.82 //y=6.69 //x2=12.38 //y2=5.555
cc_1471 ( N_VDD_c_2232_n N_noxref_10_c_2613_n ) capacitor c=0.00237006f \
 //x=12.82 //y=7.41 //x2=12.38 //y2=5.555
cc_1472 ( N_VDD_c_2161_n N_noxref_10_c_2613_n ) capacitor c=0.00845221f \
 //x=14.75 //y=7.585 //x2=12.38 //y2=5.555
cc_1473 ( N_VDD_c_2168_n N_noxref_10_c_2613_n ) capacitor c=0.0532223f \
 //x=11.59 //y=7.585 //x2=12.38 //y2=5.555
cc_1474 ( N_VDD_c_2070_n N_noxref_10_c_2613_n ) capacitor c=9.85326e-19 \
 //x=16.4 //y=7.58 //x2=12.38 //y2=5.555
cc_1475 ( N_VDD_M21_noxref_d N_noxref_10_c_2613_n ) capacitor c=0.0479465f \
 //x=12.675 //y=5.2 //x2=12.38 //y2=5.555
cc_1476 ( N_VDD_c_2230_n N_noxref_10_c_2585_n ) capacitor c=0.00689217f \
 //x=12.82 //y=6.69 //x2=13.26 //y2=5.555
cc_1477 ( N_VDD_c_2232_n N_noxref_10_c_2585_n ) capacitor c=0.00366379f \
 //x=12.82 //y=7.41 //x2=13.26 //y2=5.555
cc_1478 ( N_VDD_c_2181_n N_noxref_10_c_2585_n ) capacitor c=0.00203449f \
 //x=16.4 //y=7.58 //x2=13.26 //y2=5.555
cc_1479 ( N_VDD_c_2161_n N_noxref_10_c_2585_n ) capacitor c=0.0084192f \
 //x=14.75 //y=7.585 //x2=13.26 //y2=5.555
cc_1480 ( N_VDD_c_2070_n N_noxref_10_c_2585_n ) capacitor c=9.85326e-19 \
 //x=16.4 //y=7.58 //x2=13.26 //y2=5.555
cc_1481 ( N_VDD_M21_noxref_d N_noxref_10_c_2585_n ) capacitor c=0.0478672f \
 //x=12.675 //y=5.2 //x2=13.26 //y2=5.555
cc_1482 ( N_VDD_c_2100_n N_noxref_10_M21_noxref_s ) capacitor c=4.52323e-19 \
 //x=9.49 //y=7.41 //x2=12.245 //y2=5.2
cc_1483 ( N_VDD_c_2179_n N_noxref_10_M21_noxref_s ) capacitor c=0.0219956f \
 //x=12.735 //y=7.585 //x2=12.245 //y2=5.2
cc_1484 ( N_VDD_c_2232_n N_noxref_10_M21_noxref_s ) capacitor c=0.0339466f \
 //x=12.82 //y=7.41 //x2=12.245 //y2=5.2
cc_1485 ( N_VDD_c_2161_n N_noxref_10_M21_noxref_s ) capacitor c=0.00289402f \
 //x=14.75 //y=7.585 //x2=12.245 //y2=5.2
cc_1486 ( N_VDD_c_2168_n N_noxref_10_M21_noxref_s ) capacitor c=0.00541973f \
 //x=11.59 //y=7.585 //x2=12.245 //y2=5.2
cc_1487 ( N_VDD_c_2070_n N_noxref_10_M21_noxref_s ) capacitor c=8.06314e-19 \
 //x=16.4 //y=7.58 //x2=12.245 //y2=5.2
cc_1488 ( N_VDD_c_2181_n N_noxref_10_M24_noxref_d ) capacitor c=0.00204601f \
 //x=16.4 //y=7.58 //x2=13.995 //y2=5.2
cc_1489 ( N_VDD_c_2161_n N_noxref_10_M24_noxref_d ) capacitor c=0.00844271f \
 //x=14.75 //y=7.585 //x2=13.995 //y2=5.2
cc_1490 ( N_VDD_c_2169_n N_noxref_10_M24_noxref_d ) capacitor c=0.0442402f \
 //x=14.92 //y=7.585 //x2=13.995 //y2=5.2
cc_1491 ( N_VDD_c_2070_n N_noxref_10_M24_noxref_d ) capacitor c=9.81989e-19 \
 //x=16.4 //y=7.58 //x2=13.995 //y2=5.2
cc_1492 ( N_VDD_M25_noxref_s N_noxref_10_M24_noxref_d ) capacitor \
 c=0.00279822f //x=15.46 //y=5.2 //x2=13.995 //y2=5.2
cc_1493 ( N_VDD_c_2056_n N_GND_c_2672_n ) capacitor c=0.00989514f //x=1.23 \
 //y=7.58 //x2=1.23 //y2=0.18
cc_1494 ( N_VDD_c_2059_n N_GND_c_2678_n ) capacitor c=0.00654453f //x=3.82 \
 //y=7.585 //x2=3.82 //y2=0.175
cc_1495 ( N_VDD_c_2067_n N_GND_c_2686_n ) capacitor c=0.00663779f //x=6.04 \
 //y=7.585 //x2=6.04 //y2=0.175
cc_1496 ( N_VDD_c_2127_n N_GND_c_2741_n ) capacitor c=0.00663779f //x=8.26 \
 //y=7.585 //x2=8.26 //y2=0.175
cc_1497 ( N_VDD_c_2168_n N_GND_c_2789_n ) capacitor c=0.00647951f //x=11.59 \
 //y=7.585 //x2=11.59 //y2=0.175
cc_1498 ( N_VDD_c_2169_n N_GND_c_2791_n ) capacitor c=0.00650455f //x=14.92 \
 //y=7.585 //x2=14.92 //y2=0.175
cc_1499 ( N_VDD_c_2070_n N_GND_c_2687_n ) capacitor c=0.00989514f //x=16.4 \
 //y=7.58 //x2=16.51 //y2=0.175
cc_1500 ( N_COUT_c_2412_n N_GND_c_2661_n ) capacitor c=0.00497604f //x=5.215 \
 //y=2.02 //x2=9.355 //y2=0.175
cc_1501 ( N_COUT_c_2419_n N_GND_c_2661_n ) capacitor c=0.00998676f //x=4.93 \
 //y=1.185 //x2=9.355 //y2=0.175
cc_1502 ( N_COUT_M2_noxref_d N_GND_c_2661_n ) capacitor c=0.00119455f \
 //x=4.745 //y=1.09 //x2=9.355 //y2=0.175
cc_1503 ( N_COUT_c_2419_n N_GND_c_2673_n ) capacitor c=0.00124813f //x=4.93 \
 //y=1.185 //x2=4.845 //y2=0.715
cc_1504 ( N_COUT_c_2412_n N_GND_c_2677_n ) capacitor c=0.00321695f //x=5.215 \
 //y=2.02 //x2=5.335 //y2=0.715
cc_1505 ( N_COUT_c_2419_n N_GND_c_2677_n ) capacitor c=0.00130539f //x=4.93 \
 //y=1.185 //x2=5.335 //y2=0.715
cc_1506 ( N_COUT_c_2401_n N_GND_c_2678_n ) capacitor c=0.00272952f //x=4.93 \
 //y=1.935 //x2=3.82 //y2=0.175
cc_1507 ( N_COUT_c_2412_n N_GND_c_2686_n ) capacitor c=0.0218039f //x=5.215 \
 //y=2.02 //x2=6.04 //y2=0.175
cc_1508 ( N_COUT_c_2419_n N_GND_c_2687_n ) capacitor c=2.8029e-19 //x=4.93 \
 //y=1.185 //x2=16.51 //y2=0.175
cc_1509 ( N_COUT_M2_noxref_d N_GND_c_2687_n ) capacitor c=2.70835e-19 \
 //x=4.745 //y=1.09 //x2=16.51 //y2=0.175
cc_1510 ( N_COUT_c_2401_n N_GND_M2_noxref_s ) capacitor c=0.0286221f //x=4.93 \
 //y=1.935 //x2=4.315 //y2=0.55
cc_1511 ( N_COUT_c_2412_n N_GND_M2_noxref_s ) capacitor c=0.00461411f \
 //x=5.215 //y=2.02 //x2=4.315 //y2=0.55
cc_1512 ( N_COUT_c_2419_n N_GND_M2_noxref_s ) capacitor c=0.0138658f //x=4.93 \
 //y=1.185 //x2=4.315 //y2=0.55
cc_1513 ( N_COUT_M2_noxref_d N_GND_M2_noxref_s ) capacitor c=0.0377642f \
 //x=4.745 //y=1.09 //x2=4.315 //y2=0.55
cc_1514 ( N_noxref_9_c_2499_n N_noxref_10_c_2590_n ) capacitor c=0.00119247f \
 //x=9.93 //y=5.385 //x2=12.38 //y2=5.385
cc_1515 ( N_noxref_9_c_2512_n N_noxref_10_c_2583_n ) capacitor c=5.03119e-19 \
 //x=10.81 //y=6.915 //x2=13.26 //y2=6.915
cc_1516 ( N_noxref_9_M20_noxref_d N_noxref_10_c_2613_n ) capacitor \
 c=0.00208849f //x=10.665 //y=5.2 //x2=12.38 //y2=5.555
cc_1517 ( N_noxref_9_c_2512_n N_noxref_10_M21_noxref_s ) capacitor \
 c=0.0112164f //x=10.81 //y=6.915 //x2=12.245 //y2=5.2
cc_1518 ( N_noxref_9_c_2489_n N_GND_c_2703_n ) capacitor c=2.9226e-19 //x=9.81 \
 //y=5.385 //x2=9.44 //y2=1.025
cc_1519 ( N_GND_c_2699_n N_noxref_12_c_3028_n ) capacitor c=0.00267873f \
 //x=1.585 //y=0.175 //x2=2.07 //y2=1.76
cc_1520 ( N_GND_c_2661_n N_noxref_12_c_3028_n ) capacitor c=7.74325e-19 \
 //x=9.355 //y=0.175 //x2=2.07 //y2=1.76
cc_1521 ( N_GND_c_2668_n N_noxref_12_c_3028_n ) capacitor c=0.00395626f \
 //x=1.67 //y=1.135 //x2=2.07 //y2=1.76
cc_1522 ( N_GND_c_2670_n N_noxref_12_c_3028_n ) capacitor c=0.00375345f \
 //x=3.65 //y=0.175 //x2=2.07 //y2=1.76
cc_1523 ( N_GND_M0_noxref_d N_noxref_12_c_3028_n ) capacitor c=0.00578453f \
 //x=1.48 //y=1.045 //x2=2.07 //y2=1.76
cc_1524 ( N_GND_c_2661_n N_noxref_12_c_3056_n ) capacitor c=0.00583399f \
 //x=9.355 //y=0.175 //x2=2.155 //y2=0.795
cc_1525 ( N_GND_c_2721_n N_noxref_12_c_3056_n ) capacitor c=0.0167642f \
 //x=1.667 //y=1.005 //x2=2.155 //y2=0.795
cc_1526 ( N_GND_c_2670_n N_noxref_12_c_3056_n ) capacitor c=0.0146605f \
 //x=3.65 //y=0.175 //x2=2.155 //y2=0.795
cc_1527 ( N_GND_c_2672_n N_noxref_12_c_3056_n ) capacitor c=0.00283128f \
 //x=1.23 //y=0.18 //x2=2.155 //y2=0.795
cc_1528 ( N_GND_c_2678_n N_noxref_12_c_3056_n ) capacitor c=2.21767e-19 \
 //x=3.82 //y=0.175 //x2=2.155 //y2=0.795
cc_1529 ( N_GND_c_2687_n N_noxref_12_c_3056_n ) capacitor c=0.00145873f \
 //x=16.51 //y=0.175 //x2=2.155 //y2=0.795
cc_1530 ( N_GND_c_2672_n N_noxref_12_c_3017_n ) capacitor c=2.85935e-19 \
 //x=1.23 //y=0.18 //x2=2.155 //y2=1.675
cc_1531 ( N_GND_c_2661_n N_noxref_12_c_3018_n ) capacitor c=0.00972941f \
 //x=9.355 //y=0.175 //x2=3.04 //y2=0.71
cc_1532 ( N_GND_c_2670_n N_noxref_12_c_3018_n ) capacitor c=0.0374802f \
 //x=3.65 //y=0.175 //x2=3.04 //y2=0.71
cc_1533 ( N_GND_c_2687_n N_noxref_12_c_3018_n ) capacitor c=0.0019969f \
 //x=16.51 //y=0.175 //x2=3.04 //y2=0.71
cc_1534 ( N_GND_c_2661_n N_noxref_12_c_3066_n ) capacitor c=0.00250904f \
 //x=9.355 //y=0.175 //x2=3.125 //y2=0.795
cc_1535 ( N_GND_c_2670_n N_noxref_12_c_3066_n ) capacitor c=0.0145784f \
 //x=3.65 //y=0.175 //x2=3.125 //y2=0.795
cc_1536 ( N_GND_c_2949_p N_noxref_12_c_3066_n ) capacitor c=0.00209572f \
 //x=4.45 //y=0.63 //x2=3.125 //y2=0.795
cc_1537 ( N_GND_c_2678_n N_noxref_12_c_3066_n ) capacitor c=0.0402083f \
 //x=3.82 //y=0.175 //x2=3.125 //y2=0.795
cc_1538 ( N_GND_c_2687_n N_noxref_12_c_3066_n ) capacitor c=0.00145015f \
 //x=16.51 //y=0.175 //x2=3.125 //y2=0.795
cc_1539 ( N_GND_c_2699_n N_noxref_12_M0_noxref_s ) capacitor c=0.00724992f \
 //x=1.585 //y=0.175 //x2=1.05 //y2=0.545
cc_1540 ( N_GND_c_2668_n N_noxref_12_M0_noxref_s ) capacitor c=0.011456f \
 //x=1.67 //y=1.135 //x2=1.05 //y2=0.545
cc_1541 ( N_GND_c_2721_n N_noxref_12_M0_noxref_s ) capacitor c=0.0173062f \
 //x=1.667 //y=1.005 //x2=1.05 //y2=0.545
cc_1542 ( N_GND_c_2670_n N_noxref_12_M0_noxref_s ) capacitor c=0.014661f \
 //x=3.65 //y=0.175 //x2=1.05 //y2=0.545
cc_1543 ( N_GND_c_2672_n N_noxref_12_M0_noxref_s ) capacitor c=0.0559891f \
 //x=1.23 //y=0.18 //x2=1.05 //y2=0.545
cc_1544 ( N_GND_c_2678_n N_noxref_12_M0_noxref_s ) capacitor c=0.00642652f \
 //x=3.82 //y=0.175 //x2=1.05 //y2=0.545
cc_1545 ( N_GND_c_2687_n N_noxref_12_M0_noxref_s ) capacitor c=0.00145873f \
 //x=16.51 //y=0.175 //x2=1.05 //y2=0.545
cc_1546 ( N_GND_M0_noxref_d N_noxref_12_M0_noxref_s ) capacitor c=0.0271276f \
 //x=1.48 //y=1.045 //x2=1.05 //y2=0.545
cc_1547 ( N_GND_M2_noxref_s N_noxref_12_M0_noxref_s ) capacitor c=0.0031675f \
 //x=4.315 //y=0.55 //x2=1.05 //y2=0.545
cc_1548 ( N_GND_M3_noxref_s N_noxref_13_c_3080_n ) capacitor c=0.00297957f \
 //x=6.535 //y=0.55 //x2=8.955 //y2=1.68
cc_1549 ( N_GND_c_2661_n N_noxref_13_c_3081_n ) capacitor c=9.97081e-19 \
 //x=9.355 //y=0.175 //x2=9.84 //y2=1.765
cc_1550 ( N_GND_c_2703_n N_noxref_13_c_3081_n ) capacitor c=0.00329826f \
 //x=9.44 //y=1.025 //x2=9.84 //y2=1.765
cc_1551 ( N_GND_c_2805_n N_noxref_13_c_3081_n ) capacitor c=7.43272e-19 \
 //x=12.685 //y=0.175 //x2=9.84 //y2=1.765
cc_1552 ( N_GND_c_2735_n N_noxref_13_c_3081_n ) capacitor c=0.00394683f \
 //x=11.42 //y=0.175 //x2=9.84 //y2=1.765
cc_1553 ( N_GND_M4_noxref_d N_noxref_13_c_3081_n ) capacitor c=0.00578453f \
 //x=9.25 //y=1.05 //x2=9.84 //y2=1.765
cc_1554 ( N_GND_c_2703_n N_noxref_13_c_3121_n ) capacitor c=0.0120153f \
 //x=9.44 //y=1.025 //x2=9.925 //y2=0.8
cc_1555 ( N_GND_c_2805_n N_noxref_13_c_3121_n ) capacitor c=0.00311404f \
 //x=12.685 //y=0.175 //x2=9.925 //y2=0.8
cc_1556 ( N_GND_c_2735_n N_noxref_13_c_3121_n ) capacitor c=0.0143523f \
 //x=11.42 //y=0.175 //x2=9.925 //y2=0.8
cc_1557 ( N_GND_c_2741_n N_noxref_13_c_3121_n ) capacitor c=0.00282499f \
 //x=8.26 //y=0.175 //x2=9.925 //y2=0.8
cc_1558 ( N_GND_c_2789_n N_noxref_13_c_3121_n ) capacitor c=2.99356e-19 \
 //x=11.59 //y=0.175 //x2=9.925 //y2=0.8
cc_1559 ( N_GND_c_2687_n N_noxref_13_c_3121_n ) capacitor c=0.00141889f \
 //x=16.51 //y=0.175 //x2=9.925 //y2=0.8
cc_1560 ( N_GND_c_2741_n N_noxref_13_c_3088_n ) capacitor c=2.8481e-19 \
 //x=8.26 //y=0.175 //x2=9.925 //y2=1.68
cc_1561 ( N_GND_c_2805_n N_noxref_13_c_3095_n ) capacitor c=0.0104238f \
 //x=12.685 //y=0.175 //x2=10.81 //y2=0.715
cc_1562 ( N_GND_c_2735_n N_noxref_13_c_3095_n ) capacitor c=0.0368722f \
 //x=11.42 //y=0.175 //x2=10.81 //y2=0.715
cc_1563 ( N_GND_c_2687_n N_noxref_13_c_3095_n ) capacitor c=0.0019508f \
 //x=16.51 //y=0.175 //x2=10.81 //y2=0.715
cc_1564 ( N_GND_c_2805_n N_noxref_13_c_3131_n ) capacitor c=0.00234408f \
 //x=12.685 //y=0.175 //x2=10.895 //y2=0.8
cc_1565 ( N_GND_c_2735_n N_noxref_13_c_3131_n ) capacitor c=0.0141679f \
 //x=11.42 //y=0.175 //x2=10.895 //y2=0.8
cc_1566 ( N_GND_c_2789_n N_noxref_13_c_3131_n ) capacitor c=0.0392084f \
 //x=11.59 //y=0.175 //x2=10.895 //y2=0.8
cc_1567 ( N_GND_c_2687_n N_noxref_13_c_3131_n ) capacitor c=0.00141054f \
 //x=16.51 //y=0.175 //x2=10.895 //y2=0.8
cc_1568 ( N_GND_c_2661_n N_noxref_13_M4_noxref_s ) capacitor c=0.00717833f \
 //x=9.355 //y=0.175 //x2=8.82 //y2=0.55
cc_1569 ( N_GND_c_2703_n N_noxref_13_M4_noxref_s ) capacitor c=0.0262211f \
 //x=9.44 //y=1.025 //x2=8.82 //y2=0.55
cc_1570 ( N_GND_c_2983_p N_noxref_13_M4_noxref_s ) capacitor c=0.00297957f \
 //x=7.64 //y=0.63 //x2=8.82 //y2=0.55
cc_1571 ( N_GND_c_2735_n N_noxref_13_M4_noxref_s ) capacitor c=0.0143523f \
 //x=11.42 //y=0.175 //x2=8.82 //y2=0.55
cc_1572 ( N_GND_c_2741_n N_noxref_13_M4_noxref_s ) capacitor c=0.0528189f \
 //x=8.26 //y=0.175 //x2=8.82 //y2=0.55
cc_1573 ( N_GND_c_2789_n N_noxref_13_M4_noxref_s ) capacitor c=0.00645748f \
 //x=11.59 //y=0.175 //x2=8.82 //y2=0.55
cc_1574 ( N_GND_c_2687_n N_noxref_13_M4_noxref_s ) capacitor c=0.00141889f \
 //x=16.51 //y=0.175 //x2=8.82 //y2=0.55
cc_1575 ( N_GND_M4_noxref_d N_noxref_13_M4_noxref_s ) capacitor c=0.0271984f \
 //x=9.25 //y=1.05 //x2=8.82 //y2=0.55
cc_1576 ( N_GND_c_2805_n N_noxref_14_c_3147_n ) capacitor c=0.0011344f \
 //x=12.685 //y=0.175 //x2=13.17 //y2=1.765
cc_1577 ( N_GND_c_2777_n N_noxref_14_c_3147_n ) capacitor c=0.00300742f \
 //x=12.77 //y=1.025 //x2=13.17 //y2=1.765
cc_1578 ( N_GND_c_2778_n N_noxref_14_c_3147_n ) capacitor c=0.00192969f \
 //x=16.4 //y=0.18 //x2=13.17 //y2=1.765
cc_1579 ( N_GND_c_2816_n N_noxref_14_c_3147_n ) capacitor c=0.00388936f \
 //x=14.75 //y=0.175 //x2=13.17 //y2=1.765
cc_1580 ( N_GND_M6_noxref_d N_noxref_14_c_3147_n ) capacitor c=0.00578453f \
 //x=12.58 //y=1.05 //x2=13.17 //y2=1.765
cc_1581 ( N_GND_c_2777_n N_noxref_14_c_3187_n ) capacitor c=0.0167642f \
 //x=12.77 //y=1.025 //x2=13.255 //y2=0.8
cc_1582 ( N_GND_c_2778_n N_noxref_14_c_3187_n ) capacitor c=0.00717833f \
 //x=16.4 //y=0.18 //x2=13.255 //y2=0.8
cc_1583 ( N_GND_c_2816_n N_noxref_14_c_3187_n ) capacitor c=0.0143523f \
 //x=14.75 //y=0.175 //x2=13.255 //y2=0.8
cc_1584 ( N_GND_c_2789_n N_noxref_14_c_3187_n ) capacitor c=0.00282553f \
 //x=11.59 //y=0.175 //x2=13.255 //y2=0.8
cc_1585 ( N_GND_c_2791_n N_noxref_14_c_3187_n ) capacitor c=2.21767e-19 \
 //x=14.92 //y=0.175 //x2=13.255 //y2=0.8
cc_1586 ( N_GND_c_2687_n N_noxref_14_c_3187_n ) capacitor c=0.00141889f \
 //x=16.51 //y=0.175 //x2=13.255 //y2=0.8
cc_1587 ( N_GND_c_2789_n N_noxref_14_c_3148_n ) capacitor c=2.83682e-19 \
 //x=11.59 //y=0.175 //x2=13.255 //y2=1.68
cc_1588 ( N_GND_c_2778_n N_noxref_14_c_3150_n ) capacitor c=0.0115899f \
 //x=16.4 //y=0.18 //x2=14.14 //y2=0.715
cc_1589 ( N_GND_c_2816_n N_noxref_14_c_3150_n ) capacitor c=0.0368722f \
 //x=14.75 //y=0.175 //x2=14.14 //y2=0.715
cc_1590 ( N_GND_c_2687_n N_noxref_14_c_3150_n ) capacitor c=0.0019508f \
 //x=16.51 //y=0.175 //x2=14.14 //y2=0.715
cc_1591 ( N_GND_c_2778_n N_noxref_14_c_3197_n ) capacitor c=0.00251347f \
 //x=16.4 //y=0.18 //x2=14.225 //y2=0.8
cc_1592 ( N_GND_c_2816_n N_noxref_14_c_3197_n ) capacitor c=0.0141858f \
 //x=14.75 //y=0.175 //x2=14.225 //y2=0.8
cc_1593 ( N_GND_c_3006_p N_noxref_14_c_3197_n ) capacitor c=0.00212205f \
 //x=15.54 //y=0.63 //x2=14.225 //y2=0.8
cc_1594 ( N_GND_c_2791_n N_noxref_14_c_3197_n ) capacitor c=0.0402f //x=14.92 \
 //y=0.175 //x2=14.225 //y2=0.8
cc_1595 ( N_GND_c_2687_n N_noxref_14_c_3197_n ) capacitor c=0.00141054f \
 //x=16.51 //y=0.175 //x2=14.225 //y2=0.8
cc_1596 ( N_GND_c_2805_n N_noxref_14_M6_noxref_s ) capacitor c=0.00717833f \
 //x=12.685 //y=0.175 //x2=12.15 //y2=0.55
cc_1597 ( N_GND_c_2777_n N_noxref_14_M6_noxref_s ) capacitor c=0.02175f \
 //x=12.77 //y=1.025 //x2=12.15 //y2=0.55
cc_1598 ( N_GND_c_2816_n N_noxref_14_M6_noxref_s ) capacitor c=0.0143523f \
 //x=14.75 //y=0.175 //x2=12.15 //y2=0.55
cc_1599 ( N_GND_c_2789_n N_noxref_14_M6_noxref_s ) capacitor c=0.0518398f \
 //x=11.59 //y=0.175 //x2=12.15 //y2=0.55
cc_1600 ( N_GND_c_2791_n N_noxref_14_M6_noxref_s ) capacitor c=0.00642631f \
 //x=14.92 //y=0.175 //x2=12.15 //y2=0.55
cc_1601 ( N_GND_c_2687_n N_noxref_14_M6_noxref_s ) capacitor c=0.00141889f \
 //x=16.51 //y=0.175 //x2=12.15 //y2=0.55
cc_1602 ( N_GND_M6_noxref_d N_noxref_14_M6_noxref_s ) capacitor c=0.0272028f \
 //x=12.58 //y=1.05 //x2=12.15 //y2=0.55
cc_1603 ( N_GND_M8_noxref_s N_noxref_14_M6_noxref_s ) capacitor c=0.0032083f \
 //x=15.415 //y=0.55 //x2=12.15 //y2=0.55
cc_1604 ( N_noxref_13_c_3088_n N_noxref_14_c_3146_n ) capacitor c=5.32163e-19 \
 //x=9.925 //y=1.68 //x2=12.285 //y2=1.68
cc_1605 ( N_noxref_13_c_3131_n N_noxref_14_M6_noxref_s ) capacitor \
 c=0.00453341f //x=10.895 //y=0.8 //x2=12.15 //y2=0.55
cc_1606 ( N_noxref_13_M4_noxref_s N_noxref_14_M6_noxref_s ) capacitor \
 c=5.32163e-19 //x=8.82 //y=0.55 //x2=12.15 //y2=0.55
