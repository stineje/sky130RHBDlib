// File: xor2X1_pcell.spi.pex
// Created: Fri Feb 20 10:24:15 2026
// Program "Calibre xRC"
// Version "v2023.2_27.15"
// Nominal Temperature: 30C
// Circuit Temperature: 30C
//
simulator lang=spectre
subckt PM_XOR2X1_PCELL\%noxref_1 ( 2 3 4 5 6 7 8 10 15 18 26 31 32 35 44 49 58 \
 62 63 64 65 66 67 68 69 70 71 75 76 77 79 85 86 87 88 89 90 94 96 99 100 105 \
 119 )
c229 ( 119 0 ) capacitor c=0.066434f //x=3.33 //y=4.7
c230 ( 105 0 ) capacitor c=0.0564228f //x=0.74 //y=2.085
c231 ( 100 0 ) capacitor c=0.0318956f //x=3.665 //y=1.215
c232 ( 99 0 ) capacitor c=0.0186836f //x=3.665 //y=0.87
c233 ( 96 0 ) capacitor c=0.0141821f //x=3.51 //y=1.37
c234 ( 94 0 ) capacitor c=0.0158569f //x=3.51 //y=0.715
c235 ( 90 0 ) capacitor c=0.0900967f //x=3.135 //y=1.92
c236 ( 89 0 ) capacitor c=0.0230021f //x=3.135 //y=1.525
c237 ( 88 0 ) capacitor c=0.0234359f //x=3.135 //y=1.215
c238 ( 87 0 ) capacitor c=0.0198787f //x=3.135 //y=0.87
c239 ( 86 0 ) capacitor c=0.0439576f //x=1.38 //y=1.255
c240 ( 85 0 ) capacitor c=0.0201087f //x=1.38 //y=0.91
c241 ( 79 0 ) capacitor c=0.0161986f //x=1.225 //y=1.41
c242 ( 77 0 ) capacitor c=0.0157807f //x=1.225 //y=0.755
c243 ( 76 0 ) capacitor c=0.0497323f //x=0.97 //y=4.79
c244 ( 75 0 ) capacitor c=0.0399032f //x=1.26 //y=4.79
c245 ( 71 0 ) capacitor c=0.0301471f //x=0.85 //y=1.92
c246 ( 70 0 ) capacitor c=0.0255349f //x=0.85 //y=1.565
c247 ( 69 0 ) capacitor c=0.0234346f //x=0.85 //y=1.255
c248 ( 68 0 ) capacitor c=0.02013f //x=0.85 //y=0.91
c249 ( 67 0 ) capacitor c=0.110998f //x=3.67 //y=6.02
c250 ( 66 0 ) capacitor c=0.155253f //x=3.23 //y=6.02
c251 ( 65 0 ) capacitor c=0.153944f //x=1.335 //y=6.02
c252 ( 64 0 ) capacitor c=0.154411f //x=0.895 //y=6.02
c253 ( 58 0 ) capacitor c=0.00101674f //x=3.33 //y=4.7
c254 ( 49 0 ) capacitor c=0.00134654f //x=3.33 //y=2.085
c255 ( 44 0 ) capacitor c=6.76699e-19 //x=0.74 //y=4.7
c256 ( 35 0 ) capacitor c=9.11699e-19 //x=0.74 //y=2.085
c257 ( 32 0 ) capacitor c=0.0790837f //x=3.165 //y=4.075
c258 ( 31 0 ) capacitor c=0.00269492f //x=3.325 //y=4.075
c259 ( 26 0 ) capacitor c=0.0100228f //x=0.9 //y=4.07
c260 ( 18 0 ) capacitor c=0.0152624f //x=3.33 //y=4.07
c261 ( 15 0 ) capacitor c=0.0154384f //x=0.74 //y=4.07
c262 ( 10 0 ) capacitor c=0.0139259f //x=0.74 //y=2.085
c263 ( 8 0 ) capacitor c=0.0133496f //x=3.33 //y=4.585
c264 ( 7 0 ) capacitor c=0.0120877f //x=3.33 //y=4.235
c265 ( 6 0 ) capacitor c=0.0570128f //x=3.33 //y=3.915
c266 ( 5 0 ) capacitor c=0.00729001f //x=3.33 //y=2.24
c267 ( 4 0 ) capacitor c=0.018367f //x=0.74 //y=4.58
c268 ( 3 0 ) capacitor c=0.0121029f //x=0.74 //y=4.23
c269 ( 2 0 ) capacitor c=0.0760032f //x=0.74 //y=3.91
r270 (  117 119 ) resistor r=20.6867 //w=0.233 //l=0.1 //layer=ply \
 //thickness=0.18 //x=3.23 //y=4.7 //x2=3.33 //y2=4.7
r271 (  105 106 ) resistor r=17.5563 //w=0.302 //l=0.11 //layer=ply \
 //thickness=0.18 //x=0.74 //y=2.085 //x2=0.85 //y2=2.085
r272 (  101 119 ) resistor r=70.3348 //w=0.233 //l=0.414367 //layer=ply \
 //thickness=0.18 //x=3.67 //y=4.865 //x2=3.33 //y2=4.7
r273 (  100 121 ) resistor r=45.1352 //w=0.168 //l=0.173853 //layer=ply \
 //thickness=0.18 //x=3.665 //y=1.215 //x2=3.625 //y2=1.37
r274 (  99 120 ) resistor r=45.1352 //w=0.168 //l=0.173853 //layer=ply \
 //thickness=0.18 //x=3.665 //y=0.87 //x2=3.625 //y2=0.715
r275 (  99 100 ) resistor r=176.904 //w=0.094 //l=0.345 //layer=ply \
 //thickness=0.18 //x=3.665 //y=0.87 //x2=3.665 //y2=1.215
r276 (  97 116 ) resistor r=10.701 //w=0.21 //l=0.115 //layer=ply \
 //thickness=0.18 //x=3.29 //y=1.37 //x2=3.175 //y2=1.37
r277 (  96 121 ) resistor r=5.52526 //w=0.168 //l=0.115 //layer=ply \
 //thickness=0.18 //x=3.51 //y=1.37 //x2=3.625 //y2=1.37
r278 (  95 115 ) resistor r=5.52526 //w=0.168 //l=0.115 //layer=ply \
 //thickness=0.18 //x=3.29 //y=0.715 //x2=3.175 //y2=0.715
r279 (  94 120 ) resistor r=5.52526 //w=0.168 //l=0.115 //layer=ply \
 //thickness=0.18 //x=3.51 //y=0.715 //x2=3.625 //y2=0.715
r280 (  94 95 ) resistor r=112.809 //w=0.094 //l=0.22 //layer=ply \
 //thickness=0.18 //x=3.51 //y=0.715 //x2=3.29 //y2=0.715
r281 (  91 117 ) resistor r=13.0941 //w=0.233 //l=0.165 //layer=ply \
 //thickness=0.18 //x=3.23 //y=4.865 //x2=3.23 //y2=4.7
r282 (  90 114 ) resistor r=34.8111 //w=0.27 //l=0.264953 //layer=ply \
 //thickness=0.18 //x=3.135 //y=1.92 //x2=3.33 //y2=2.085
r283 (  89 116 ) resistor r=39.5823 //w=0.21 //l=0.173853 //layer=ply \
 //thickness=0.18 //x=3.135 //y=1.525 //x2=3.175 //y2=1.37
r284 (  89 90 ) resistor r=202.543 //w=0.094 //l=0.395 //layer=ply \
 //thickness=0.18 //x=3.135 //y=1.525 //x2=3.135 //y2=1.92
r285 (  88 116 ) resistor r=39.5823 //w=0.21 //l=0.173853 //layer=ply \
 //thickness=0.18 //x=3.135 //y=1.215 //x2=3.175 //y2=1.37
r286 (  87 115 ) resistor r=45.1352 //w=0.168 //l=0.173853 //layer=ply \
 //thickness=0.18 //x=3.135 //y=0.87 //x2=3.175 //y2=0.715
r287 (  87 88 ) resistor r=176.904 //w=0.094 //l=0.345 //layer=ply \
 //thickness=0.18 //x=3.135 //y=0.87 //x2=3.135 //y2=1.215
r288 (  86 112 ) resistor r=45.1352 //w=0.168 //l=0.173853 //layer=ply \
 //thickness=0.18 //x=1.38 //y=1.255 //x2=1.34 //y2=1.41
r289 (  85 111 ) resistor r=45.1352 //w=0.168 //l=0.173853 //layer=ply \
 //thickness=0.18 //x=1.38 //y=0.91 //x2=1.34 //y2=0.755
r290 (  85 86 ) resistor r=176.904 //w=0.094 //l=0.345 //layer=ply \
 //thickness=0.18 //x=1.38 //y=0.91 //x2=1.38 //y2=1.255
r291 (  80 110 ) resistor r=10.701 //w=0.21 //l=0.115 //layer=ply \
 //thickness=0.18 //x=1.005 //y=1.41 //x2=0.89 //y2=1.41
r292 (  79 112 ) resistor r=5.52526 //w=0.168 //l=0.115 //layer=ply \
 //thickness=0.18 //x=1.225 //y=1.41 //x2=1.34 //y2=1.41
r293 (  78 109 ) resistor r=5.52526 //w=0.168 //l=0.115 //layer=ply \
 //thickness=0.18 //x=1.005 //y=0.755 //x2=0.89 //y2=0.755
r294 (  77 111 ) resistor r=5.52526 //w=0.168 //l=0.115 //layer=ply \
 //thickness=0.18 //x=1.225 //y=0.755 //x2=1.34 //y2=0.755
r295 (  77 78 ) resistor r=112.809 //w=0.094 //l=0.22 //layer=ply \
 //thickness=0.18 //x=1.225 //y=0.755 //x2=1.005 //y2=0.755
r296 (  75 82 ) resistor r=26.9307 //w=0.15 //l=0.106066 //layer=ply \
 //thickness=0.18 //x=1.26 //y=4.79 //x2=1.335 //y2=4.865
r297 (  75 76 ) resistor r=148.702 //w=0.094 //l=0.29 //layer=ply \
 //thickness=0.18 //x=1.26 //y=4.79 //x2=0.97 //y2=4.79
r298 (  72 76 ) resistor r=23.403 //w=0.284 //l=0.106066 //layer=ply \
 //thickness=0.18 //x=0.895 //y=4.865 //x2=0.97 //y2=4.79
r299 (  72 108 ) resistor r=26.3063 //w=0.284 //l=0.229783 //layer=ply \
 //thickness=0.18 //x=0.895 //y=4.865 //x2=0.74 //y2=4.7
r300 (  71 106 ) resistor r=19.1248 //w=0.302 //l=0.165 //layer=ply \
 //thickness=0.18 //x=0.85 //y=1.92 //x2=0.85 //y2=2.085
r301 (  70 110 ) resistor r=39.5823 //w=0.21 //l=0.173853 //layer=ply \
 //thickness=0.18 //x=0.85 //y=1.565 //x2=0.89 //y2=1.41
r302 (  70 71 ) resistor r=182.032 //w=0.094 //l=0.355 //layer=ply \
 //thickness=0.18 //x=0.85 //y=1.565 //x2=0.85 //y2=1.92
r303 (  69 110 ) resistor r=39.5823 //w=0.21 //l=0.173853 //layer=ply \
 //thickness=0.18 //x=0.85 //y=1.255 //x2=0.89 //y2=1.41
r304 (  68 109 ) resistor r=45.1352 //w=0.168 //l=0.173853 //layer=ply \
 //thickness=0.18 //x=0.85 //y=0.91 //x2=0.89 //y2=0.755
r305 (  68 69 ) resistor r=176.904 //w=0.094 //l=0.345 //layer=ply \
 //thickness=0.18 //x=0.85 //y=0.91 //x2=0.85 //y2=1.255
r306 (  67 101 ) resistor r=592.245 //w=0.094 //l=1.155 //layer=ply \
 //thickness=0.18 //x=3.67 //y=6.02 //x2=3.67 //y2=4.865
r307 (  66 91 ) resistor r=592.245 //w=0.094 //l=1.155 //layer=ply \
 //thickness=0.18 //x=3.23 //y=6.02 //x2=3.23 //y2=4.865
r308 (  65 82 ) resistor r=592.245 //w=0.094 //l=1.155 //layer=ply \
 //thickness=0.18 //x=1.335 //y=6.02 //x2=1.335 //y2=4.865
r309 (  64 72 ) resistor r=592.245 //w=0.094 //l=1.155 //layer=ply \
 //thickness=0.18 //x=0.895 //y=6.02 //x2=0.895 //y2=4.865
r310 (  63 96 ) resistor r=56.4043 //w=0.094 //l=0.11 //layer=ply \
 //thickness=0.18 //x=3.4 //y=1.37 //x2=3.51 //y2=1.37
r311 (  63 97 ) resistor r=56.4043 //w=0.094 //l=0.11 //layer=ply \
 //thickness=0.18 //x=3.4 //y=1.37 //x2=3.29 //y2=1.37
r312 (  62 79 ) resistor r=56.4043 //w=0.094 //l=0.11 //layer=ply \
 //thickness=0.18 //x=1.115 //y=1.41 //x2=1.225 //y2=1.41
r313 (  62 80 ) resistor r=56.4043 //w=0.094 //l=0.11 //layer=ply \
 //thickness=0.18 //x=1.115 //y=1.41 //x2=1.005 //y2=1.41
r314 (  58 119 ) resistor r=152 //w=0.17 //l=0.17 //layer=licon //count=1 \
 //x=3.33 //y=4.7 //x2=3.33 //y2=4.7
r315 (  49 114 ) resistor r=152 //w=0.17 //l=0.17 //layer=licon //count=1 \
 //x=3.33 //y=2.085 //x2=3.33 //y2=2.085
r316 (  44 108 ) resistor r=152 //w=0.17 //l=0.17 //layer=licon //count=1 \
 //x=0.74 //y=4.7 //x2=0.74 //y2=4.7
r317 (  35 105 ) resistor r=152 //w=0.17 //l=0.17 //layer=licon //count=1 \
 //x=0.74 //y=2.085 //x2=0.74 //y2=2.085
r318 (  31 32 ) resistor r=0.10734 //w=0.281 //l=0.16 //layer=m2 \
 //thickness=0.36 //x=3.325 //y=4.075 //x2=3.165 //y2=4.075
r319 (  26 28 ) resistor r=0.10734 //w=0.281 //l=0.16 //layer=m2 \
 //thickness=0.36 //x=0.9 //y=4.07 //x2=0.74 //y2=4.07
r320 (  26 32 ) resistor r=2.16126 //w=0.131 //l=2.265 //layer=m2 \
 //thickness=0.36 //x=0.9 //y=4.07 //x2=3.165 //y2=4.07
r321 (  24 58 ) resistor r=9.3 //w=0.17 //l=0.17 //layer=mcon //count=1 \
 //x=3.33 //y=4.7 //x2=3.33 //y2=4.7
r322 (  22 49 ) resistor r=9.3 //w=0.17 //l=0.17 //layer=mcon //count=1 \
 //x=3.33 //y=2.085 //x2=3.33 //y2=2.085
r323 (  20 31 ) resistor r=4.5 //w=0.15 //l=0.15 //layer=via1 //count=1 \
 //x=3.325 //y=4.075 //x2=3.325 //y2=4.075
r324 (  18 20 ) resistor r=0.00167112 //w=0.374 //l=0.005 //layer=m1 \
 //thickness=0.36 //x=3.275 //y=4.07 //x2=3.275 //y2=4.075
r325 (  15 28 ) resistor r=4.5 //w=0.15 //l=0.15 //layer=via1 //count=1 \
 //x=0.74 //y=4.07 //x2=0.74 //y2=4.07
r326 (  13 44 ) resistor r=9.3 //w=0.17 //l=0.17 //layer=mcon //count=1 \
 //x=0.74 //y=4.7 //x2=0.74 //y2=4.7
r327 (  10 35 ) resistor r=9.3 //w=0.17 //l=0.17 //layer=mcon //count=1 \
 //x=0.74 //y=2.085 //x2=0.74 //y2=2.085
r328 (  8 24 ) resistor r=0.0717383 //w=0.224 //l=0.115 //layer=m1 \
 //thickness=0.36 //x=3.33 //y=4.585 //x2=3.33 //y2=4.7
r329 (  7 20 ) resistor r=0.0910802 //w=0.374 //l=0.185472 //layer=m1 \
 //thickness=0.36 //x=3.33 //y=4.235 //x2=3.275 //y2=4.075
r330 (  7 8 ) resistor r=0.333969 //w=0.131 //l=0.35 //layer=m1 \
 //thickness=0.36 //x=3.33 //y=4.235 //x2=3.33 //y2=4.585
r331 (  6 18 ) resistor r=0.089409 //w=0.374 //l=0.180416 //layer=m1 \
 //thickness=0.36 //x=3.33 //y=3.915 //x2=3.275 //y2=4.07
r332 (  5 22 ) resistor r=0.0916619 //w=0.239 //l=0.156493 //layer=m1 \
 //thickness=0.36 //x=3.33 //y=2.24 //x2=3.327 //y2=2.085
r333 (  5 6 ) resistor r=1.59828 //w=0.131 //l=1.675 //layer=m1 \
 //thickness=0.36 //x=3.33 //y=2.24 //x2=3.33 //y2=3.915
r334 (  4 13 ) resistor r=0.0731974 //w=0.242 //l=0.122474 //layer=m1 \
 //thickness=0.36 //x=0.74 //y=4.58 //x2=0.745 //y2=4.7
r335 (  3 15 ) resistor r=0.0911593 //w=0.376 //l=0.184174 //layer=m1 \
 //thickness=0.36 //x=0.74 //y=4.23 //x2=0.792 //y2=4.07
r336 (  3 4 ) resistor r=0.333969 //w=0.131 //l=0.35 //layer=m1 \
 //thickness=0.36 //x=0.74 //y=4.23 //x2=0.74 //y2=4.58
r337 (  2 15 ) resistor r=0.0911593 //w=0.376 //l=0.184174 //layer=m1 \
 //thickness=0.36 //x=0.74 //y=3.91 //x2=0.792 //y2=4.07
r338 (  1 10 ) resistor r=0.116051 //w=0.211 //l=0.165 //layer=m1 \
 //thickness=0.36 //x=0.74 //y=2.25 //x2=0.74 //y2=2.085
r339 (  1 2 ) resistor r=1.58397 //w=0.131 //l=1.66 //layer=m1 \
 //thickness=0.36 //x=0.74 //y=2.25 //x2=0.74 //y2=3.91
ends PM_XOR2X1_PCELL\%noxref_1

subckt PM_XOR2X1_PCELL\%noxref_2 ( 2 4 5 6 7 8 10 11 12 13 14 15 16 18 23 28 \
 31 35 40 41 49 61 70 74 75 76 77 78 79 80 84 86 92 93 101 103 105 )
c287 ( 103 0 ) capacitor c=0.00869746f //x=0.925 //y=0.91
c288 ( 101 0 ) capacitor c=0.069457f //x=7.77 //y=4.7
c289 ( 93 0 ) capacitor c=0.0423887f //x=7.965 //y=1.255
c290 ( 92 0 ) capacitor c=0.0191585f //x=7.965 //y=0.91
c291 ( 86 0 ) capacitor c=0.0125357f //x=7.81 //y=1.41
c292 ( 84 0 ) capacitor c=0.0157807f //x=7.81 //y=0.755
c293 ( 80 0 ) capacitor c=0.0959389f //x=7.435 //y=1.92
c294 ( 79 0 ) capacitor c=0.0197088f //x=7.435 //y=1.565
c295 ( 78 0 ) capacitor c=0.0168511f //x=7.435 //y=1.255
c296 ( 77 0 ) capacitor c=0.0174128f //x=7.435 //y=0.91
c297 ( 76 0 ) capacitor c=0.155893f //x=7.88 //y=6.02
c298 ( 75 0 ) capacitor c=0.110553f //x=7.44 //y=6.02
c299 ( 70 0 ) capacitor c=8.33364e-19 //x=7.77 //y=4.7
c300 ( 61 0 ) capacitor c=6.44043e-19 //x=7.77 //y=2.085
c301 ( 49 0 ) capacitor c=0.0261398f //x=1.115 //y=5.38
c302 ( 41 0 ) capacitor c=0.180751f //x=7.595 //y=2.575
c303 ( 40 0 ) capacitor c=0.00351837f //x=7.755 //y=2.575
c304 ( 35 0 ) capacitor c=0.00290249f //x=1.64 //y=2.59
c305 ( 31 0 ) capacitor c=0.00861163f //x=7.65 //y=4.697
c306 ( 28 0 ) capacitor c=0.0149988f //x=7.77 //y=2.59
c307 ( 23 0 ) capacitor c=0.0140935f //x=1.48 //y=2.59
c308 ( 18 0 ) capacitor c=0.0191391f //x=1.11 //y=1.005
c309 ( 16 0 ) capacitor c=0.00313372f //x=7.77 //y=2.415
c310 ( 15 0 ) capacitor c=0.00460007f //x=7.77 //y=2.23
c311 ( 14 0 ) capacitor c=0.0399807f //x=7.65 //y=4.55
c312 ( 13 0 ) capacitor c=0.00872805f //x=7.65 //y=2.735
c313 ( 12 0 ) capacitor c=0.0612378f //x=1.48 //y=4.875
c314 ( 11 0 ) capacitor c=0.0126342f //x=1.48 //y=2.75
c315 ( 10 0 ) capacitor c=0.00946852f //x=1.48 //y=2.43
c316 ( 8 0 ) capacitor c=0.00632795f //x=1.2 //y=4.96
c317 ( 7 0 ) capacitor c=0.00769652f //x=1.395 //y=4.96
c318 ( 6 0 ) capacitor c=0.00882254f //x=1.195 //y=1.84
c319 ( 5 0 ) capacitor c=0.0120888f //x=1.395 //y=1.84
c320 ( 4 0 ) capacitor c=0.0119286f //x=1.115 //y=5.24
c321 ( 2 0 ) capacitor c=0.0184592f //x=1.11 //y=1.755
r322 (  101 102 ) resistor r=22.7554 //w=0.233 //l=0.11 //layer=ply \
 //thickness=0.18 //x=7.77 //y=4.7 //x2=7.88 //y2=4.7
r323 (  93 99 ) resistor r=45.1352 //w=0.168 //l=0.173853 //layer=ply \
 //thickness=0.18 //x=7.965 //y=1.255 //x2=7.925 //y2=1.41
r324 (  92 98 ) resistor r=45.1352 //w=0.168 //l=0.173853 //layer=ply \
 //thickness=0.18 //x=7.965 //y=0.91 //x2=7.925 //y2=0.755
r325 (  92 93 ) resistor r=176.904 //w=0.094 //l=0.345 //layer=ply \
 //thickness=0.18 //x=7.965 //y=0.91 //x2=7.965 //y2=1.255
r326 (  89 102 ) resistor r=13.0941 //w=0.233 //l=0.165 //layer=ply \
 //thickness=0.18 //x=7.88 //y=4.865 //x2=7.88 //y2=4.7
r327 (  87 95 ) resistor r=10.701 //w=0.21 //l=0.115 //layer=ply \
 //thickness=0.18 //x=7.59 //y=1.41 //x2=7.475 //y2=1.41
r328 (  86 99 ) resistor r=5.52526 //w=0.168 //l=0.115 //layer=ply \
 //thickness=0.18 //x=7.81 //y=1.41 //x2=7.925 //y2=1.41
r329 (  85 94 ) resistor r=5.52526 //w=0.168 //l=0.115 //layer=ply \
 //thickness=0.18 //x=7.59 //y=0.755 //x2=7.475 //y2=0.755
r330 (  84 98 ) resistor r=5.52526 //w=0.168 //l=0.115 //layer=ply \
 //thickness=0.18 //x=7.81 //y=0.755 //x2=7.925 //y2=0.755
r331 (  84 85 ) resistor r=112.809 //w=0.094 //l=0.22 //layer=ply \
 //thickness=0.18 //x=7.81 //y=0.755 //x2=7.59 //y2=0.755
r332 (  81 101 ) resistor r=68.2661 //w=0.233 //l=0.404166 //layer=ply \
 //thickness=0.18 //x=7.44 //y=4.865 //x2=7.77 //y2=4.7
r333 (  80 97 ) resistor r=67.2792 //w=0.24 //l=0.438891 //layer=ply \
 //thickness=0.18 //x=7.435 //y=1.92 //x2=7.77 //y2=2.16
r334 (  79 95 ) resistor r=39.5823 //w=0.21 //l=0.173853 //layer=ply \
 //thickness=0.18 //x=7.435 //y=1.565 //x2=7.475 //y2=1.41
r335 (  79 80 ) resistor r=182.032 //w=0.094 //l=0.355 //layer=ply \
 //thickness=0.18 //x=7.435 //y=1.565 //x2=7.435 //y2=1.92
r336 (  78 95 ) resistor r=39.5823 //w=0.21 //l=0.173853 //layer=ply \
 //thickness=0.18 //x=7.435 //y=1.255 //x2=7.475 //y2=1.41
r337 (  77 94 ) resistor r=45.1352 //w=0.168 //l=0.173853 //layer=ply \
 //thickness=0.18 //x=7.435 //y=0.91 //x2=7.475 //y2=0.755
r338 (  77 78 ) resistor r=176.904 //w=0.094 //l=0.345 //layer=ply \
 //thickness=0.18 //x=7.435 //y=0.91 //x2=7.435 //y2=1.255
r339 (  76 89 ) resistor r=592.245 //w=0.094 //l=1.155 //layer=ply \
 //thickness=0.18 //x=7.88 //y=6.02 //x2=7.88 //y2=4.865
r340 (  75 81 ) resistor r=592.245 //w=0.094 //l=1.155 //layer=ply \
 //thickness=0.18 //x=7.44 //y=6.02 //x2=7.44 //y2=4.865
r341 (  74 86 ) resistor r=56.4043 //w=0.094 //l=0.11 //layer=ply \
 //thickness=0.18 //x=7.7 //y=1.41 //x2=7.81 //y2=1.41
r342 (  74 87 ) resistor r=56.4043 //w=0.094 //l=0.11 //layer=ply \
 //thickness=0.18 //x=7.7 //y=1.41 //x2=7.59 //y2=1.41
r343 (  70 101 ) resistor r=152 //w=0.17 //l=0.17 //layer=licon //count=1 \
 //x=7.77 //y=4.7 //x2=7.77 //y2=4.7
r344 (  61 97 ) resistor r=152 //w=0.17 //l=0.17 //layer=licon //count=1 \
 //x=7.77 //y=2.085 //x2=7.77 //y2=2.085
r345 (  49 105 ) resistor r=23.615 //w=0.187 //l=0.345 //layer=li \
 //thickness=0.1 //x=1.115 //y=5.38 //x2=1.115 //y2=5.725
r346 (  40 41 ) resistor r=0.10734 //w=0.281 //l=0.16 //layer=m2 \
 //thickness=0.36 //x=7.755 //y=2.575 //x2=7.595 //y2=2.575
r347 (  35 37 ) resistor r=0.10734 //w=0.281 //l=0.16 //layer=m2 \
 //thickness=0.36 //x=1.64 //y=2.59 //x2=1.48 //y2=2.59
r348 (  35 41 ) resistor r=5.68225 //w=0.131 //l=5.955 //layer=m2 \
 //thickness=0.36 //x=1.64 //y=2.59 //x2=7.595 //y2=2.59
r349 (  33 70 ) resistor r=9.3 //w=0.17 //l=0.17 //layer=mcon //count=1 \
 //x=7.77 //y=4.7 //x2=7.77 //y2=4.7
r350 (  31 33 ) resistor r=0.0528169 //w=0.284 //l=0.12 //layer=m1 \
 //thickness=0.36 //x=7.65 //y=4.697 //x2=7.77 //y2=4.697
r351 (  30 61 ) resistor r=9.3 //w=0.17 //l=0.17 //layer=mcon //count=1 \
 //x=7.77 //y=2.085 //x2=7.77 //y2=2.085
r352 (  26 40 ) resistor r=4.5 //w=0.15 //l=0.15 //layer=via1 //count=1 \
 //x=7.755 //y=2.575 //x2=7.755 //y2=2.575
r353 (  26 28 ) resistor r=0.00501337 //w=0.374 //l=0.015 //layer=m1 \
 //thickness=0.36 //x=7.71 //y=2.575 //x2=7.71 //y2=2.59
r354 (  23 37 ) resistor r=4.5 //w=0.15 //l=0.15 //layer=via1 //count=1 \
 //x=1.48 //y=2.59 //x2=1.48 //y2=2.59
r355 (  21 49 ) resistor r=9.3 //w=0.17 //l=0.17 //layer=mcon //count=1 \
 //x=1.115 //y=5.38 //x2=1.115 //y2=5.38
r356 (  18 103 ) resistor r=9.3 //w=0.17 //l=0.17 //layer=mcon //count=1 \
 //x=1.11 //y=1.005 //x2=1.11 //y2=1.005
r357 (  16 26 ) resistor r=0.0910802 //w=0.374 //l=0.187617 //layer=m1 \
 //thickness=0.36 //x=7.77 //y=2.415 //x2=7.71 //y2=2.575
r358 (  15 30 ) resistor r=0.0853765 //w=0.25 //l=0.146492 //layer=m1 \
 //thickness=0.36 //x=7.77 //y=2.23 //x2=7.767 //y2=2.085
r359 (  15 16 ) resistor r=0.176527 //w=0.131 //l=0.185 //layer=m1 \
 //thickness=0.36 //x=7.77 //y=2.23 //x2=7.77 //y2=2.415
r360 (  14 31 ) resistor r=0.0383145 //w=0.284 //l=0.147 //layer=m1 \
 //thickness=0.36 //x=7.65 //y=4.55 //x2=7.65 //y2=4.697
r361 (  13 28 ) resistor r=0.0860668 //w=0.374 //l=0.172409 //layer=m1 \
 //thickness=0.36 //x=7.65 //y=2.735 //x2=7.71 //y2=2.59
r362 (  13 14 ) resistor r=1.73187 //w=0.131 //l=1.815 //layer=m1 \
 //thickness=0.36 //x=7.65 //y=2.735 //x2=7.65 //y2=4.55
r363 (  11 23 ) resistor r=0.0911593 //w=0.376 //l=0.184174 //layer=m1 \
 //thickness=0.36 //x=1.48 //y=2.75 //x2=1.532 //y2=2.59
r364 (  11 12 ) resistor r=2.02767 //w=0.131 //l=2.125 //layer=m1 \
 //thickness=0.36 //x=1.48 //y=2.75 //x2=1.48 //y2=4.875
r365 (  10 23 ) resistor r=0.0911593 //w=0.376 //l=0.184174 //layer=m1 \
 //thickness=0.36 //x=1.48 //y=2.43 //x2=1.532 //y2=2.59
r366 (  9 10 ) resistor r=0.48187 //w=0.131 //l=0.505 //layer=m1 \
 //thickness=0.36 //x=1.48 //y=1.925 //x2=1.48 //y2=2.43
r367 (  7 12 ) resistor r=0.0698411 //w=0.17 //l=0.120208 //layer=m1 \
 //thickness=0.36 //x=1.395 //y=4.96 //x2=1.48 //y2=4.875
r368 (  7 8 ) resistor r=0.186069 //w=0.131 //l=0.195 //layer=m1 \
 //thickness=0.36 //x=1.395 //y=4.96 //x2=1.2 //y2=4.96
r369 (  5 9 ) resistor r=0.0698411 //w=0.17 //l=0.120208 //layer=m1 \
 //thickness=0.36 //x=1.395 //y=1.84 //x2=1.48 //y2=1.925
r370 (  5 6 ) resistor r=0.19084 //w=0.131 //l=0.2 //layer=m1 //thickness=0.36 \
 //x=1.395 //y=1.84 //x2=1.195 //y2=1.84
r371 (  4 21 ) resistor r=0.086672 //w=0.218 //l=0.14 //layer=m1 \
 //thickness=0.36 //x=1.115 //y=5.24 //x2=1.115 //y2=5.38
r372 (  3 8 ) resistor r=0.0698411 //w=0.17 //l=0.120208 //layer=m1 \
 //thickness=0.36 //x=1.115 //y=5.045 //x2=1.2 //y2=4.96
r373 (  3 4 ) resistor r=0.186069 //w=0.131 //l=0.195 //layer=m1 \
 //thickness=0.36 //x=1.115 //y=5.045 //x2=1.115 //y2=5.24
r374 (  2 6 ) resistor r=0.0698411 //w=0.17 //l=0.120208 //layer=m1 \
 //thickness=0.36 //x=1.11 //y=1.755 //x2=1.195 //y2=1.84
r375 (  1 18 ) resistor r=0.105739 //w=0.201 //l=0.145 //layer=m1 \
 //thickness=0.36 //x=1.11 //y=1.15 //x2=1.11 //y2=1.005
r376 (  1 2 ) resistor r=0.57729 //w=0.131 //l=0.605 //layer=m1 \
 //thickness=0.36 //x=1.11 //y=1.15 //x2=1.11 //y2=1.755
ends PM_XOR2X1_PCELL\%noxref_2

subckt PM_XOR2X1_PCELL\%noxref_3 ( 1 2 3 5 6 8 9 10 11 12 13 15 16 18 19 20 21 \
 27 30 36 44 46 47 50 67 83 84 87 88 )
c294 ( 84 0 ) capacitor c=0.00849198f //x=7.51 //y=0.91
c295 ( 83 0 ) capacitor c=0.00849198f //x=4.18 //y=0.91
c296 ( 67 0 ) capacitor c=0.0232369f //x=7.66 //y=5.375
c297 ( 50 0 ) capacitor c=0.0235809f //x=4.33 //y=5.375
c298 ( 47 0 ) capacitor c=0.0332019f //x=7.995 //y=3.715
c299 ( 46 0 ) capacitor c=0.0137849f //x=8.155 //y=3.715
c300 ( 44 0 ) capacitor c=0.00571035f //x=5.135 //y=3.715
c301 ( 36 0 ) capacitor c=0.0170398f //x=8.14 //y=3.7
c302 ( 30 0 ) capacitor c=0.01028f //x=7.66 //y=5.205
c303 ( 27 0 ) capacitor c=0.0184853f //x=4.98 //y=3.7
c304 ( 21 0 ) capacitor c=0.0123291f //x=4.33 //y=5.205
c305 ( 20 0 ) capacitor c=0.0240725f //x=8.14 //y=5.12
c306 ( 19 0 ) capacitor c=0.0122445f //x=8.14 //y=3.875
c307 ( 18 0 ) capacitor c=0.0358152f //x=8.14 //y=3.555
c308 ( 16 0 ) capacitor c=0.00233399f //x=7.785 //y=1.655
c309 ( 15 0 ) capacitor c=0.0103724f //x=8.055 //y=1.655
c310 ( 13 0 ) capacitor c=0.00837252f //x=8.055 //y=5.205
c311 ( 12 0 ) capacitor c=0.00892846f //x=7.7 //y=1.57
c312 ( 11 0 ) capacitor c=0.00950665f //x=7.7 //y=1.12
c313 ( 10 0 ) capacitor c=0.0269411f //x=4.93 //y=5.12
c314 ( 9 0 ) capacitor c=0.0170141f //x=4.93 //y=3.875
c315 ( 8 0 ) capacitor c=0.0460606f //x=4.93 //y=3.555
c316 ( 6 0 ) capacitor c=0.00266748f //x=4.455 //y=1.655
c317 ( 5 0 ) capacitor c=0.0137763f //x=4.845 //y=1.655
c318 ( 3 0 ) capacitor c=0.0126655f //x=4.845 //y=5.205
c319 ( 2 0 ) capacitor c=0.00993239f //x=4.37 //y=1.57
c320 ( 1 0 ) capacitor c=0.0101596f //x=4.37 //y=1.125
r321 (  67 88 ) resistor r=23.2727 //w=0.187 //l=0.34 //layer=li \
 //thickness=0.1 //x=7.66 //y=5.375 //x2=7.66 //y2=5.715
r322 (  50 87 ) resistor r=23.2727 //w=0.187 //l=0.34 //layer=li \
 //thickness=0.1 //x=4.33 //y=5.375 //x2=4.33 //y2=5.715
r323 (  46 47 ) resistor r=0.10734 //w=0.281 //l=0.16 //layer=m2 \
 //thickness=0.36 //x=8.155 //y=3.715 //x2=7.995 //y2=3.715
r324 (  44 47 ) resistor r=2.72901 //w=0.131 //l=2.86 //layer=m2 \
 //thickness=0.36 //x=5.135 //y=3.73 //x2=7.995 //y2=3.73
r325 (  42 44 ) resistor r=0.10734 //w=0.281 //l=0.16 //layer=m2 \
 //thickness=0.36 //x=4.975 //y=3.715 //x2=5.135 //y2=3.715
r326 (  38 46 ) resistor r=4.5 //w=0.15 //l=0.15 //layer=via1 //count=1 \
 //x=8.155 //y=3.715 //x2=8.155 //y2=3.715
r327 (  36 38 ) resistor r=0.00501337 //w=0.374 //l=0.015 //layer=m1 \
 //thickness=0.36 //x=8.09 //y=3.7 //x2=8.09 //y2=3.715
r328 (  34 84 ) resistor r=9.3 //w=0.17 //l=0.17 //layer=mcon //count=1 \
 //x=7.7 //y=1.005 //x2=7.7 //y2=1.005
r329 (  32 67 ) resistor r=9.3 //w=0.17 //l=0.17 //layer=mcon //count=1 \
 //x=7.66 //y=5.375 //x2=7.66 //y2=5.375
r330 (  30 32 ) resistor r=0.100236 //w=0.212 //l=0.17 //layer=m1 \
 //thickness=0.36 //x=7.66 //y=5.205 //x2=7.66 //y2=5.375
r331 (  29 42 ) resistor r=4.5 //w=0.15 //l=0.15 //layer=via1 //count=1 \
 //x=4.975 //y=3.715 //x2=4.975 //y2=3.715
r332 (  27 29 ) resistor r=0.0049867 //w=0.376 //l=0.015 //layer=m1 \
 //thickness=0.36 //x=5.03 //y=3.7 //x2=5.03 //y2=3.715
r333 (  25 83 ) resistor r=9.3 //w=0.17 //l=0.17 //layer=mcon //count=1 \
 //x=4.37 //y=1.005 //x2=4.37 //y2=1.005
r334 (  23 50 ) resistor r=9.3 //w=0.17 //l=0.17 //layer=mcon //count=1 \
 //x=4.33 //y=5.375 //x2=4.33 //y2=5.375
r335 (  21 23 ) resistor r=0.100236 //w=0.212 //l=0.17 //layer=m1 \
 //thickness=0.36 //x=4.33 //y=5.205 //x2=4.33 //y2=5.375
r336 (  19 38 ) resistor r=0.0910802 //w=0.374 //l=0.183303 //layer=m1 \
 //thickness=0.36 //x=8.14 //y=3.875 //x2=8.09 //y2=3.715
r337 (  19 20 ) resistor r=1.18798 //w=0.131 //l=1.245 //layer=m1 \
 //thickness=0.36 //x=8.14 //y=3.875 //x2=8.14 //y2=5.12
r338 (  18 36 ) resistor r=0.0860668 //w=0.374 //l=0.168152 //layer=m1 \
 //thickness=0.36 //x=8.14 //y=3.555 //x2=8.09 //y2=3.7
r339 (  17 18 ) resistor r=1.73187 //w=0.131 //l=1.815 //layer=m1 \
 //thickness=0.36 //x=8.14 //y=1.74 //x2=8.14 //y2=3.555
r340 (  15 17 ) resistor r=0.0698411 //w=0.17 //l=0.120208 //layer=m1 \
 //thickness=0.36 //x=8.055 //y=1.655 //x2=8.14 //y2=1.74
r341 (  15 16 ) resistor r=0.257634 //w=0.131 //l=0.27 //layer=m1 \
 //thickness=0.36 //x=8.055 //y=1.655 //x2=7.785 //y2=1.655
r342 (  14 30 ) resistor r=0.0208269 //w=0.212 //l=0.115 //layer=m1 \
 //thickness=0.36 //x=7.775 //y=5.205 //x2=7.66 //y2=5.205
r343 (  13 20 ) resistor r=0.0698411 //w=0.17 //l=0.120208 //layer=m1 \
 //thickness=0.36 //x=8.055 //y=5.205 //x2=8.14 //y2=5.12
r344 (  13 14 ) resistor r=0.267176 //w=0.131 //l=0.28 //layer=m1 \
 //thickness=0.36 //x=8.055 //y=5.205 //x2=7.775 //y2=5.205
r345 (  12 16 ) resistor r=0.0698411 //w=0.17 //l=0.120208 //layer=m1 \
 //thickness=0.36 //x=7.7 //y=1.57 //x2=7.785 //y2=1.655
r346 (  11 34 ) resistor r=0.0717383 //w=0.224 //l=0.115 //layer=m1 \
 //thickness=0.36 //x=7.7 //y=1.12 //x2=7.7 //y2=1.005
r347 (  11 12 ) resistor r=0.429389 //w=0.131 //l=0.45 //layer=m1 \
 //thickness=0.36 //x=7.7 //y=1.12 //x2=7.7 //y2=1.57
r348 (  9 29 ) resistor r=0.0911593 //w=0.376 //l=0.203961 //layer=m1 \
 //thickness=0.36 //x=4.93 //y=3.875 //x2=5.03 //y2=3.715
r349 (  9 10 ) resistor r=1.18798 //w=0.131 //l=1.245 //layer=m1 \
 //thickness=0.36 //x=4.93 //y=3.875 //x2=4.93 //y2=5.12
r350 (  8 27 ) resistor r=0.0861726 //w=0.376 //l=0.188481 //layer=m1 \
 //thickness=0.36 //x=4.93 //y=3.555 //x2=5.03 //y2=3.7
r351 (  7 8 ) resistor r=1.73187 //w=0.131 //l=1.815 //layer=m1 \
 //thickness=0.36 //x=4.93 //y=1.74 //x2=4.93 //y2=3.555
r352 (  5 7 ) resistor r=0.0698411 //w=0.17 //l=0.120208 //layer=m1 \
 //thickness=0.36 //x=4.845 //y=1.655 //x2=4.93 //y2=1.74
r353 (  5 6 ) resistor r=0.372137 //w=0.131 //l=0.39 //layer=m1 \
 //thickness=0.36 //x=4.845 //y=1.655 //x2=4.455 //y2=1.655
r354 (  4 21 ) resistor r=0.0208269 //w=0.212 //l=0.115 //layer=m1 \
 //thickness=0.36 //x=4.445 //y=5.205 //x2=4.33 //y2=5.205
r355 (  3 10 ) resistor r=0.0698411 //w=0.17 //l=0.120208 //layer=m1 \
 //thickness=0.36 //x=4.845 //y=5.205 //x2=4.93 //y2=5.12
r356 (  3 4 ) resistor r=0.381679 //w=0.131 //l=0.4 //layer=m1 \
 //thickness=0.36 //x=4.845 //y=5.205 //x2=4.445 //y2=5.205
r357 (  2 6 ) resistor r=0.0698411 //w=0.17 //l=0.120208 //layer=m1 \
 //thickness=0.36 //x=4.37 //y=1.57 //x2=4.455 //y2=1.655
r358 (  1 25 ) resistor r=0.0740619 //w=0.229 //l=0.120996 //layer=m1 \
 //thickness=0.36 //x=4.37 //y=1.125 //x2=4.372 //y2=1.005
r359 (  1 2 ) resistor r=0.424618 //w=0.131 //l=0.445 //layer=m1 \
 //thickness=0.36 //x=4.37 //y=1.125 //x2=4.37 //y2=1.57
ends PM_XOR2X1_PCELL\%noxref_3

subckt PM_XOR2X1_PCELL\%noxref_4 ( 1 2 3 4 6 7 8 9 10 11 12 13 14 16 18 24 28 \
 34 36 40 48 54 56 57 60 61 68 73 90 102 103 104 111 112 113 114 115 117 120 \
 121 123 131 133 )
c293 ( 131 0 ) capacitor c=0.00869746f //x=9.795 //y=0.91
c294 ( 123 0 ) capacitor c=0.0652604f //x=4.44 //y=4.7
c295 ( 121 0 ) capacitor c=0.0318956f //x=6.995 //y=1.215
c296 ( 120 0 ) capacitor c=0.0186836f //x=6.995 //y=0.87
c297 ( 117 0 ) capacitor c=0.0141821f //x=6.84 //y=1.37
c298 ( 115 0 ) capacitor c=0.0158569f //x=6.84 //y=0.715
c299 ( 114 0 ) capacitor c=0.0874759f //x=6.465 //y=1.92
c300 ( 113 0 ) capacitor c=0.0230012f //x=6.465 //y=1.525
c301 ( 112 0 ) capacitor c=0.0234359f //x=6.465 //y=1.215
c302 ( 111 0 ) capacitor c=0.0198787f //x=6.465 //y=0.87
c303 ( 104 0 ) capacitor c=0.155893f //x=4.55 //y=6.02
c304 ( 103 0 ) capacitor c=0.110553f //x=4.11 //y=6.02
c305 ( 90 0 ) capacitor c=0.0261682f //x=9.985 //y=5.38
c306 ( 73 0 ) capacitor c=0.00142446f //x=6.66 //y=2.085
c307 ( 68 0 ) capacitor c=5.34599e-19 //x=4.44 //y=4.7
c308 ( 61 0 ) capacitor c=0.0256835f //x=9.495 //y=3.315
c309 ( 60 0 ) capacitor c=3.18161e-19 //x=9.655 //y=3.315
c310 ( 57 0 ) capacitor c=0.0774801f //x=9.465 //y=4.09
c311 ( 56 0 ) capacitor c=0.00326455f //x=9.625 //y=4.09
c312 ( 54 0 ) capacitor c=0.00256557f //x=6.82 //y=3.345
c313 ( 48 0 ) capacitor c=0.00536919f //x=4.485 //y=4.1
c314 ( 40 0 ) capacitor c=0.0190626f //x=9.99 //y=1.005
c315 ( 36 0 ) capacitor c=0.0136177f //x=9.62 //y=4.07
c316 ( 34 0 ) capacitor c=0.0164437f //x=9.62 //y=3.33
c317 ( 28 0 ) capacitor c=0.0312922f //x=6.66 //y=3.33
c318 ( 24 0 ) capacitor c=0.0153143f //x=4.485 //y=4.235
c319 ( 18 0 ) capacitor c=0.0169987f //x=9.99 //y=1.755
c320 ( 16 0 ) capacitor c=0.0116416f //x=9.985 //y=5.24
c321 ( 14 0 ) capacitor c=0.0026268f //x=9.705 //y=4.96
c322 ( 13 0 ) capacitor c=0.00884994f //x=9.9 //y=4.96
c323 ( 12 0 ) capacitor c=0.00445515f //x=9.705 //y=1.84
c324 ( 11 0 ) capacitor c=0.014706f //x=9.905 //y=1.84
c325 ( 10 0 ) capacitor c=0.00919778f //x=9.62 //y=4.875
c326 ( 9 0 ) capacitor c=0.0114707f //x=9.62 //y=4.25
c327 ( 8 0 ) capacitor c=0.0112194f //x=9.62 //y=3.955
c328 ( 7 0 ) capacitor c=0.0126935f //x=9.62 //y=3.475
c329 ( 6 0 ) capacitor c=0.0252511f //x=9.62 //y=3.155
c330 ( 4 0 ) capacitor c=0.0259221f //x=6.66 //y=3.205
c331 ( 3 0 ) capacitor c=0.00668061f //x=6.66 //y=2.205
c332 ( 2 0 ) capacitor c=0.00688284f //x=4.44 //y=4.585
c333 ( 1 0 ) capacitor c=0.0149303f //x=4.44 //y=4.395
r334 (  123 124 ) resistor r=22.7554 //w=0.233 //l=0.11 //layer=ply \
 //thickness=0.18 //x=4.44 //y=4.7 //x2=4.55 //y2=4.7
r335 (  121 130 ) resistor r=45.1352 //w=0.168 //l=0.173853 //layer=ply \
 //thickness=0.18 //x=6.995 //y=1.215 //x2=6.955 //y2=1.37
r336 (  120 129 ) resistor r=45.1352 //w=0.168 //l=0.173853 //layer=ply \
 //thickness=0.18 //x=6.995 //y=0.87 //x2=6.955 //y2=0.715
r337 (  120 121 ) resistor r=176.904 //w=0.094 //l=0.345 //layer=ply \
 //thickness=0.18 //x=6.995 //y=0.87 //x2=6.995 //y2=1.215
r338 (  118 128 ) resistor r=10.701 //w=0.21 //l=0.115 //layer=ply \
 //thickness=0.18 //x=6.62 //y=1.37 //x2=6.505 //y2=1.37
r339 (  117 130 ) resistor r=5.52526 //w=0.168 //l=0.115 //layer=ply \
 //thickness=0.18 //x=6.84 //y=1.37 //x2=6.955 //y2=1.37
r340 (  116 127 ) resistor r=5.52526 //w=0.168 //l=0.115 //layer=ply \
 //thickness=0.18 //x=6.62 //y=0.715 //x2=6.505 //y2=0.715
r341 (  115 129 ) resistor r=5.52526 //w=0.168 //l=0.115 //layer=ply \
 //thickness=0.18 //x=6.84 //y=0.715 //x2=6.955 //y2=0.715
r342 (  115 116 ) resistor r=112.809 //w=0.094 //l=0.22 //layer=ply \
 //thickness=0.18 //x=6.84 //y=0.715 //x2=6.62 //y2=0.715
r343 (  114 126 ) resistor r=34.8111 //w=0.27 //l=0.264953 //layer=ply \
 //thickness=0.18 //x=6.465 //y=1.92 //x2=6.66 //y2=2.085
r344 (  113 128 ) resistor r=39.5823 //w=0.21 //l=0.173853 //layer=ply \
 //thickness=0.18 //x=6.465 //y=1.525 //x2=6.505 //y2=1.37
r345 (  113 114 ) resistor r=202.543 //w=0.094 //l=0.395 //layer=ply \
 //thickness=0.18 //x=6.465 //y=1.525 //x2=6.465 //y2=1.92
r346 (  112 128 ) resistor r=39.5823 //w=0.21 //l=0.173853 //layer=ply \
 //thickness=0.18 //x=6.465 //y=1.215 //x2=6.505 //y2=1.37
r347 (  111 127 ) resistor r=45.1352 //w=0.168 //l=0.173853 //layer=ply \
 //thickness=0.18 //x=6.465 //y=0.87 //x2=6.505 //y2=0.715
r348 (  111 112 ) resistor r=176.904 //w=0.094 //l=0.345 //layer=ply \
 //thickness=0.18 //x=6.465 //y=0.87 //x2=6.465 //y2=1.215
r349 (  108 124 ) resistor r=13.0941 //w=0.233 //l=0.165 //layer=ply \
 //thickness=0.18 //x=4.55 //y=4.865 //x2=4.55 //y2=4.7
r350 (  105 123 ) resistor r=68.2661 //w=0.233 //l=0.404166 //layer=ply \
 //thickness=0.18 //x=4.11 //y=4.865 //x2=4.44 //y2=4.7
r351 (  104 108 ) resistor r=592.245 //w=0.094 //l=1.155 //layer=ply \
 //thickness=0.18 //x=4.55 //y=6.02 //x2=4.55 //y2=4.865
r352 (  103 105 ) resistor r=592.245 //w=0.094 //l=1.155 //layer=ply \
 //thickness=0.18 //x=4.11 //y=6.02 //x2=4.11 //y2=4.865
r353 (  102 117 ) resistor r=56.4043 //w=0.094 //l=0.11 //layer=ply \
 //thickness=0.18 //x=6.73 //y=1.37 //x2=6.84 //y2=1.37
r354 (  102 118 ) resistor r=56.4043 //w=0.094 //l=0.11 //layer=ply \
 //thickness=0.18 //x=6.73 //y=1.37 //x2=6.62 //y2=1.37
r355 (  90 133 ) resistor r=23.615 //w=0.187 //l=0.345 //layer=li \
 //thickness=0.1 //x=9.985 //y=5.38 //x2=9.985 //y2=5.725
r356 (  73 126 ) resistor r=152 //w=0.17 //l=0.17 //layer=licon //count=1 \
 //x=6.66 //y=2.085 //x2=6.66 //y2=2.085
r357 (  68 123 ) resistor r=152 //w=0.17 //l=0.17 //layer=licon //count=1 \
 //x=4.44 //y=4.7 //x2=4.44 //y2=4.7
r358 (  60 61 ) resistor r=0.10734 //w=0.281 //l=0.16 //layer=m2 \
 //thickness=0.36 //x=9.655 //y=3.315 //x2=9.495 //y2=3.315
r359 (  56 57 ) resistor r=0.10734 //w=0.281 //l=0.16 //layer=m2 \
 //thickness=0.36 //x=9.625 //y=4.09 //x2=9.465 //y2=4.09
r360 (  54 61 ) resistor r=2.55248 //w=0.131 //l=2.675 //layer=m2 \
 //thickness=0.36 //x=6.82 //y=3.33 //x2=9.495 //y2=3.33
r361 (  52 54 ) resistor r=0.10734 //w=0.281 //l=0.16 //layer=m2 \
 //thickness=0.36 //x=6.66 //y=3.345 //x2=6.82 //y2=3.345
r362 (  48 50 ) resistor r=0.0539137 //w=0.313 //l=0.135 //layer=m2 \
 //thickness=0.36 //x=4.485 //y=4.1 //x2=4.485 //y2=4.235
r363 (  45 48 ) resistor r=0.0441684 //w=0.313 //l=0.16 //layer=m2 \
 //thickness=0.36 //x=4.645 //y=4.1 //x2=4.485 //y2=4.1
r364 (  45 57 ) resistor r=4.59924 //w=0.131 //l=4.82 //layer=m2 \
 //thickness=0.36 //x=4.645 //y=4.1 //x2=9.465 //y2=4.1
r365 (  43 90 ) resistor r=9.3 //w=0.17 //l=0.17 //layer=mcon //count=1 \
 //x=9.985 //y=5.38 //x2=9.985 //y2=5.38
r366 (  40 131 ) resistor r=9.3 //w=0.17 //l=0.17 //layer=mcon //count=1 \
 //x=9.99 //y=1.005 //x2=9.99 //y2=1.005
r367 (  38 56 ) resistor r=4.5 //w=0.15 //l=0.15 //layer=via1 //count=1 \
 //x=9.625 //y=4.09 //x2=9.625 //y2=4.09
r368 (  36 38 ) resistor r=0.0065445 //w=0.382 //l=0.02 //layer=m1 \
 //thickness=0.36 //x=9.57 //y=4.07 //x2=9.57 //y2=4.09
r369 (  32 60 ) resistor r=4.5 //w=0.15 //l=0.15 //layer=via1 //count=1 \
 //x=9.655 //y=3.315 //x2=9.655 //y2=3.315
r370 (  32 34 ) resistor r=0.00474684 //w=0.395 //l=0.015 //layer=m1 \
 //thickness=0.36 //x=9.585 //y=3.315 //x2=9.585 //y2=3.33
r371 (  30 52 ) resistor r=4.5 //w=0.15 //l=0.15 //layer=via1 //count=1 \
 //x=6.66 //y=3.345 //x2=6.66 //y2=3.345
r372 (  28 30 ) resistor r=0.00493421 //w=0.38 //l=0.015 //layer=m1 \
 //thickness=0.36 //x=6.712 //y=3.33 //x2=6.712 //y2=3.345
r373 (  26 73 ) resistor r=9.3 //w=0.17 //l=0.17 //layer=mcon //count=1 \
 //x=6.66 //y=2.085 //x2=6.66 //y2=2.085
r374 (  24 50 ) resistor r=4.5 //w=0.15 //l=0.15 //layer=via1 //count=1 \
 //x=4.485 //y=4.235 //x2=4.485 //y2=4.235
r375 (  20 68 ) resistor r=9.3 //w=0.17 //l=0.17 //layer=mcon //count=1 \
 //x=4.44 //y=4.7 //x2=4.44 //y2=4.7
r376 (  17 40 ) resistor r=0.105739 //w=0.201 //l=0.145 //layer=m1 \
 //thickness=0.36 //x=9.99 //y=1.15 //x2=9.99 //y2=1.005
r377 (  17 18 ) resistor r=0.57729 //w=0.131 //l=0.605 //layer=m1 \
 //thickness=0.36 //x=9.99 //y=1.15 //x2=9.99 //y2=1.755
r378 (  16 43 ) resistor r=0.086672 //w=0.218 //l=0.14 //layer=m1 \
 //thickness=0.36 //x=9.985 //y=5.24 //x2=9.985 //y2=5.38
r379 (  15 16 ) resistor r=0.186069 //w=0.131 //l=0.195 //layer=m1 \
 //thickness=0.36 //x=9.985 //y=5.045 //x2=9.985 //y2=5.24
r380 (  13 15 ) resistor r=0.0698411 //w=0.17 //l=0.120208 //layer=m1 \
 //thickness=0.36 //x=9.9 //y=4.96 //x2=9.985 //y2=5.045
r381 (  13 14 ) resistor r=0.186069 //w=0.131 //l=0.195 //layer=m1 \
 //thickness=0.36 //x=9.9 //y=4.96 //x2=9.705 //y2=4.96
r382 (  11 18 ) resistor r=0.0698411 //w=0.17 //l=0.120208 //layer=m1 \
 //thickness=0.36 //x=9.905 //y=1.84 //x2=9.99 //y2=1.755
r383 (  11 12 ) resistor r=0.19084 //w=0.131 //l=0.2 //layer=m1 \
 //thickness=0.36 //x=9.905 //y=1.84 //x2=9.705 //y2=1.84
r384 (  10 14 ) resistor r=0.0698411 //w=0.17 //l=0.120208 //layer=m1 \
 //thickness=0.36 //x=9.62 //y=4.875 //x2=9.705 //y2=4.96
r385 (  9 38 ) resistor r=0.0914072 //w=0.382 //l=0.183303 //layer=m1 \
 //thickness=0.36 //x=9.62 //y=4.25 //x2=9.57 //y2=4.09
r386 (  9 10 ) resistor r=0.596374 //w=0.131 //l=0.625 //layer=m1 \
 //thickness=0.36 //x=9.62 //y=4.25 //x2=9.62 //y2=4.875
r387 (  8 36 ) resistor r=0.0766821 //w=0.382 //l=0.13775 //layer=m1 \
 //thickness=0.36 //x=9.62 //y=3.955 //x2=9.57 //y2=4.07
r388 (  7 34 ) resistor r=0.087246 //w=0.395 //l=0.161555 //layer=m1 \
 //thickness=0.36 //x=9.62 //y=3.475 //x2=9.585 //y2=3.33
r389 (  7 8 ) resistor r=0.458015 //w=0.131 //l=0.48 //layer=m1 \
 //thickness=0.36 //x=9.62 //y=3.475 //x2=9.62 //y2=3.955
r390 (  6 32 ) resistor r=0.0919929 //w=0.395 //l=0.176635 //layer=m1 \
 //thickness=0.36 //x=9.62 //y=3.155 //x2=9.585 //y2=3.315
r391 (  5 12 ) resistor r=0.0698411 //w=0.17 //l=0.120208 //layer=m1 \
 //thickness=0.36 //x=9.62 //y=1.925 //x2=9.705 //y2=1.84
r392 (  5 6 ) resistor r=1.17366 //w=0.131 //l=1.23 //layer=m1 \
 //thickness=0.36 //x=9.62 //y=1.925 //x2=9.62 //y2=3.155
r393 (  4 28 ) resistor r=0.0798098 //w=0.38 //l=0.148745 //layer=m1 \
 //thickness=0.36 //x=6.66 //y=3.205 //x2=6.712 //y2=3.33
r394 (  3 26 ) resistor r=0.0736049 //w=0.235 //l=0.12 //layer=m1 \
 //thickness=0.36 //x=6.66 //y=2.205 //x2=6.66 //y2=2.085
r395 (  3 4 ) resistor r=0.954198 //w=0.131 //l=1 //layer=m1 //thickness=0.36 \
 //x=6.66 //y=2.205 //x2=6.66 //y2=3.205
r396 (  2 20 ) resistor r=0.0704783 //w=0.246 //l=0.115 //layer=m1 \
 //thickness=0.36 //x=4.44 //y=4.585 //x2=4.44 //y2=4.7
r397 (  1 24 ) resistor r=0.0902587 //w=0.349 //l=0.187617 //layer=m1 \
 //thickness=0.36 //x=4.44 //y=4.395 //x2=4.5 //y2=4.235
r398 (  1 2 ) resistor r=0.181298 //w=0.131 //l=0.19 //layer=m1 \
 //thickness=0.36 //x=4.44 //y=4.395 //x2=4.44 //y2=4.585
ends PM_XOR2X1_PCELL\%noxref_4

subckt PM_XOR2X1_PCELL\%noxref_5 ( 1 2 4 5 10 14 18 21 22 27 29 31 33 34 38 46 \
 55 61 70 74 75 76 77 78 79 80 81 82 83 84 86 89 90 97 98 102 103 104 106 109 \
 112 113 114 115 124 129 )
c273 ( 129 0 ) capacitor c=0.052693f //x=10.25 //y=2.085
c274 ( 124 0 ) capacitor c=0.0660028f //x=6.66 //y=4.7
c275 ( 115 0 ) capacitor c=0.0301471f //x=10.25 //y=1.92
c276 ( 114 0 ) capacitor c=0.0255528f //x=10.25 //y=1.565
c277 ( 113 0 ) capacitor c=0.0234346f //x=10.25 //y=1.255
c278 ( 112 0 ) capacitor c=0.0201416f //x=10.25 //y=0.91
c279 ( 109 0 ) capacitor c=0.0550305f //x=10.205 //y=4.865
c280 ( 106 0 ) capacitor c=0.0161986f //x=10.095 //y=1.41
c281 ( 104 0 ) capacitor c=0.0157807f //x=10.095 //y=0.755
c282 ( 103 0 ) capacitor c=0.0146709f //x=9.84 //y=4.79
c283 ( 102 0 ) capacitor c=0.0244235f //x=10.13 //y=4.79
c284 ( 98 0 ) capacitor c=0.0439428f //x=9.72 //y=1.255
c285 ( 97 0 ) capacitor c=0.020097f //x=9.72 //y=0.91
c286 ( 90 0 ) capacitor c=0.0423887f //x=4.635 //y=1.255
c287 ( 89 0 ) capacitor c=0.0192582f //x=4.635 //y=0.91
c288 ( 86 0 ) capacitor c=0.0126237f //x=4.48 //y=1.41
c289 ( 84 0 ) capacitor c=0.0157807f //x=4.48 //y=0.755
c290 ( 83 0 ) capacitor c=0.0975376f //x=4.105 //y=1.92
c291 ( 82 0 ) capacitor c=0.0197088f //x=4.105 //y=1.565
c292 ( 81 0 ) capacitor c=0.0168511f //x=4.105 //y=1.255
c293 ( 80 0 ) capacitor c=0.0175047f //x=4.105 //y=0.91
c294 ( 79 0 ) capacitor c=0.154411f //x=10.205 //y=6.02
c295 ( 78 0 ) capacitor c=0.153944f //x=9.765 //y=6.02
c296 ( 77 0 ) capacitor c=0.110998f //x=7 //y=6.02
c297 ( 76 0 ) capacitor c=0.155254f //x=6.56 //y=6.02
c298 ( 70 0 ) capacitor c=9.53974e-19 //x=10.36 //y=4.7
c299 ( 61 0 ) capacitor c=6.43121e-19 //x=10.36 //y=2.085
c300 ( 55 0 ) capacitor c=0.0143209f //x=6.66 //y=4.44
c301 ( 46 0 ) capacitor c=5.55171e-19 //x=4.44 //y=2.085
c302 ( 38 0 ) capacitor c=3.76718e-19 //x=4.6 //y=2.975
c303 ( 34 0 ) capacitor c=0.0641543f //x=9.495 //y=4.475
c304 ( 33 0 ) capacitor c=0.0205912f //x=9.84 //y=4.475
c305 ( 31 0 ) capacitor c=0.0260571f //x=9.87 //y=2.93
c306 ( 29 0 ) capacitor c=0.0850652f //x=9.27 //y=2.96
c307 ( 27 0 ) capacitor c=0.01346f //x=10.36 //y=2.085
c308 ( 22 0 ) capacitor c=0.0565408f //x=10.37 //y=4.545
c309 ( 21 0 ) capacitor c=0.0061858f //x=10.36 //y=4.7
c310 ( 18 0 ) capacitor c=0.0169856f //x=10.355 //y=2.96
c311 ( 14 0 ) capacitor c=0.013641f //x=6.66 //y=4.44
c312 ( 10 0 ) capacitor c=0.0271598f //x=4.44 //y=2.96
c313 ( 5 0 ) capacitor c=0.0140818f //x=10.36 //y=3.12
c314 ( 4 0 ) capacitor c=0.0178622f //x=10.36 //y=2.8
c315 ( 2 0 ) capacitor c=0.011511f //x=4.44 //y=2.815
c316 ( 1 0 ) capacitor c=0.0047199f //x=4.44 //y=2.235
r317 (  129 131 ) resistor r=17.5563 //w=0.302 //l=0.11 //layer=ply \
 //thickness=0.18 //x=10.25 //y=2.085 //x2=10.36 //y2=2.085
r318 (  122 124 ) resistor r=20.6867 //w=0.233 //l=0.1 //layer=ply \
 //thickness=0.18 //x=6.56 //y=4.7 //x2=6.66 //y2=4.7
r319 (  115 129 ) resistor r=19.1248 //w=0.302 //l=0.165 //layer=ply \
 //thickness=0.18 //x=10.25 //y=1.92 //x2=10.25 //y2=2.085
r320 (  114 128 ) resistor r=39.5823 //w=0.21 //l=0.173853 //layer=ply \
 //thickness=0.18 //x=10.25 //y=1.565 //x2=10.21 //y2=1.41
r321 (  114 115 ) resistor r=182.032 //w=0.094 //l=0.355 //layer=ply \
 //thickness=0.18 //x=10.25 //y=1.565 //x2=10.25 //y2=1.92
r322 (  113 128 ) resistor r=39.5823 //w=0.21 //l=0.173853 //layer=ply \
 //thickness=0.18 //x=10.25 //y=1.255 //x2=10.21 //y2=1.41
r323 (  112 127 ) resistor r=45.1352 //w=0.168 //l=0.173853 //layer=ply \
 //thickness=0.18 //x=10.25 //y=0.91 //x2=10.21 //y2=0.755
r324 (  112 113 ) resistor r=176.904 //w=0.094 //l=0.345 //layer=ply \
 //thickness=0.18 //x=10.25 //y=0.91 //x2=10.25 //y2=1.255
r325 (  109 133 ) resistor r=26.3063 //w=0.284 //l=0.229783 //layer=ply \
 //thickness=0.18 //x=10.205 //y=4.865 //x2=10.36 //y2=4.7
r326 (  107 126 ) resistor r=5.52526 //w=0.168 //l=0.115 //layer=ply \
 //thickness=0.18 //x=9.875 //y=1.41 //x2=9.76 //y2=1.41
r327 (  106 128 ) resistor r=10.701 //w=0.21 //l=0.115 //layer=ply \
 //thickness=0.18 //x=10.095 //y=1.41 //x2=10.21 //y2=1.41
r328 (  105 125 ) resistor r=5.52526 //w=0.168 //l=0.115 //layer=ply \
 //thickness=0.18 //x=9.875 //y=0.755 //x2=9.76 //y2=0.755
r329 (  104 127 ) resistor r=5.52526 //w=0.168 //l=0.115 //layer=ply \
 //thickness=0.18 //x=10.095 //y=0.755 //x2=10.21 //y2=0.755
r330 (  104 105 ) resistor r=112.809 //w=0.094 //l=0.22 //layer=ply \
 //thickness=0.18 //x=10.095 //y=0.755 //x2=9.875 //y2=0.755
r331 (  102 109 ) resistor r=23.403 //w=0.284 //l=0.106066 //layer=ply \
 //thickness=0.18 //x=10.13 //y=4.79 //x2=10.205 //y2=4.865
r332 (  102 103 ) resistor r=148.702 //w=0.094 //l=0.29 //layer=ply \
 //thickness=0.18 //x=10.13 //y=4.79 //x2=9.84 //y2=4.79
r333 (  99 103 ) resistor r=26.9307 //w=0.15 //l=0.106066 //layer=ply \
 //thickness=0.18 //x=9.765 //y=4.865 //x2=9.84 //y2=4.79
r334 (  98 126 ) resistor r=45.1352 //w=0.168 //l=0.173853 //layer=ply \
 //thickness=0.18 //x=9.72 //y=1.255 //x2=9.76 //y2=1.41
r335 (  97 125 ) resistor r=45.1352 //w=0.168 //l=0.173853 //layer=ply \
 //thickness=0.18 //x=9.72 //y=0.91 //x2=9.76 //y2=0.755
r336 (  97 98 ) resistor r=176.904 //w=0.094 //l=0.345 //layer=ply \
 //thickness=0.18 //x=9.72 //y=0.91 //x2=9.72 //y2=1.255
r337 (  94 124 ) resistor r=70.3348 //w=0.233 //l=0.414367 //layer=ply \
 //thickness=0.18 //x=7 //y=4.865 //x2=6.66 //y2=4.7
r338 (  91 122 ) resistor r=13.0941 //w=0.233 //l=0.165 //layer=ply \
 //thickness=0.18 //x=6.56 //y=4.865 //x2=6.56 //y2=4.7
r339 (  90 121 ) resistor r=45.1352 //w=0.168 //l=0.173853 //layer=ply \
 //thickness=0.18 //x=4.635 //y=1.255 //x2=4.595 //y2=1.41
r340 (  89 120 ) resistor r=45.1352 //w=0.168 //l=0.173853 //layer=ply \
 //thickness=0.18 //x=4.635 //y=0.91 //x2=4.595 //y2=0.755
r341 (  89 90 ) resistor r=176.904 //w=0.094 //l=0.345 //layer=ply \
 //thickness=0.18 //x=4.635 //y=0.91 //x2=4.635 //y2=1.255
r342 (  87 117 ) resistor r=10.701 //w=0.21 //l=0.115 //layer=ply \
 //thickness=0.18 //x=4.26 //y=1.41 //x2=4.145 //y2=1.41
r343 (  86 121 ) resistor r=5.52526 //w=0.168 //l=0.115 //layer=ply \
 //thickness=0.18 //x=4.48 //y=1.41 //x2=4.595 //y2=1.41
r344 (  85 116 ) resistor r=5.52526 //w=0.168 //l=0.115 //layer=ply \
 //thickness=0.18 //x=4.26 //y=0.755 //x2=4.145 //y2=0.755
r345 (  84 120 ) resistor r=5.52526 //w=0.168 //l=0.115 //layer=ply \
 //thickness=0.18 //x=4.48 //y=0.755 //x2=4.595 //y2=0.755
r346 (  84 85 ) resistor r=112.809 //w=0.094 //l=0.22 //layer=ply \
 //thickness=0.18 //x=4.48 //y=0.755 //x2=4.26 //y2=0.755
r347 (  83 119 ) resistor r=67.2792 //w=0.24 //l=0.438891 //layer=ply \
 //thickness=0.18 //x=4.105 //y=1.92 //x2=4.44 //y2=2.16
r348 (  82 117 ) resistor r=39.5823 //w=0.21 //l=0.173853 //layer=ply \
 //thickness=0.18 //x=4.105 //y=1.565 //x2=4.145 //y2=1.41
r349 (  82 83 ) resistor r=182.032 //w=0.094 //l=0.355 //layer=ply \
 //thickness=0.18 //x=4.105 //y=1.565 //x2=4.105 //y2=1.92
r350 (  81 117 ) resistor r=39.5823 //w=0.21 //l=0.173853 //layer=ply \
 //thickness=0.18 //x=4.105 //y=1.255 //x2=4.145 //y2=1.41
r351 (  80 116 ) resistor r=45.1352 //w=0.168 //l=0.173853 //layer=ply \
 //thickness=0.18 //x=4.105 //y=0.91 //x2=4.145 //y2=0.755
r352 (  80 81 ) resistor r=176.904 //w=0.094 //l=0.345 //layer=ply \
 //thickness=0.18 //x=4.105 //y=0.91 //x2=4.105 //y2=1.255
r353 (  79 109 ) resistor r=592.245 //w=0.094 //l=1.155 //layer=ply \
 //thickness=0.18 //x=10.205 //y=6.02 //x2=10.205 //y2=4.865
r354 (  78 99 ) resistor r=592.245 //w=0.094 //l=1.155 //layer=ply \
 //thickness=0.18 //x=9.765 //y=6.02 //x2=9.765 //y2=4.865
r355 (  77 94 ) resistor r=592.245 //w=0.094 //l=1.155 //layer=ply \
 //thickness=0.18 //x=7 //y=6.02 //x2=7 //y2=4.865
r356 (  76 91 ) resistor r=592.245 //w=0.094 //l=1.155 //layer=ply \
 //thickness=0.18 //x=6.56 //y=6.02 //x2=6.56 //y2=4.865
r357 (  75 106 ) resistor r=56.4043 //w=0.094 //l=0.11 //layer=ply \
 //thickness=0.18 //x=9.985 //y=1.41 //x2=10.095 //y2=1.41
r358 (  75 107 ) resistor r=56.4043 //w=0.094 //l=0.11 //layer=ply \
 //thickness=0.18 //x=9.985 //y=1.41 //x2=9.875 //y2=1.41
r359 (  74 86 ) resistor r=56.4043 //w=0.094 //l=0.11 //layer=ply \
 //thickness=0.18 //x=4.37 //y=1.41 //x2=4.48 //y2=1.41
r360 (  74 87 ) resistor r=56.4043 //w=0.094 //l=0.11 //layer=ply \
 //thickness=0.18 //x=4.37 //y=1.41 //x2=4.26 //y2=1.41
r361 (  70 133 ) resistor r=152 //w=0.17 //l=0.17 //layer=licon //count=1 \
 //x=10.36 //y=4.7 //x2=10.36 //y2=4.7
r362 (  61 131 ) resistor r=152 //w=0.17 //l=0.17 //layer=licon //count=1 \
 //x=10.36 //y=2.085 //x2=10.36 //y2=2.085
r363 (  58 124 ) resistor r=152 //w=0.17 //l=0.17 //layer=licon //count=1 \
 //x=6.66 //y=4.7 //x2=6.66 //y2=4.7
r364 (  55 58 ) resistor r=17.7968 //w=0.187 //l=0.26 //layer=li \
 //thickness=0.1 //x=6.66 //y=4.44 //x2=6.66 //y2=4.7
r365 (  46 119 ) resistor r=152 //w=0.17 //l=0.17 //layer=licon //count=1 \
 //x=4.44 //y=2.085 //x2=4.44 //y2=2.085
r366 (  36 38 ) resistor r=0.10734 //w=0.281 //l=0.16 //layer=m2 \
 //thickness=0.36 //x=4.44 //y=2.975 //x2=4.6 //y2=2.975
r367 (  34 40 ) resistor r=1.89634 //w=0.187 //l=2.8584 //layer=m2 \
 //thickness=0.36 //x=9.495 //y=4.475 //x2=6.66 //y2=4.522
r368 (  33 44 ) resistor r=0.244112 //w=0.3 //l=0.630476 //layer=m2 \
 //thickness=0.36 //x=9.84 //y=4.475 //x2=10.37 //y2=4.695
r369 (  33 34 ) resistor r=0.329198 //w=0.131 //l=0.345 //layer=m2 \
 //thickness=0.36 //x=9.84 //y=4.475 //x2=9.495 //y2=4.475
r370 (  31 42 ) resistor r=0.259285 //w=0.245 //l=0.499775 //layer=m2 \
 //thickness=0.36 //x=9.87 //y=2.93 //x2=10.355 //y2=2.96
r371 (  31 32 ) resistor r=0.410305 //w=0.131 //l=0.43 //layer=m2 \
 //thickness=0.36 //x=9.87 //y=2.93 //x2=9.44 //y2=2.93
r372 (  29 32 ) resistor r=0.125 //w=0.17 //l=0.184391 //layer=m2 \
 //thickness=0.36 //x=9.27 //y=2.96 //x2=9.44 //y2=2.93
r373 (  29 38 ) resistor r=4.45611 //w=0.131 //l=4.67 //layer=m2 \
 //thickness=0.36 //x=9.27 //y=2.96 //x2=4.6 //y2=2.96
r374 (  27 61 ) resistor r=9.3 //w=0.17 //l=0.17 //layer=mcon //count=1 \
 //x=10.36 //y=2.085 //x2=10.36 //y2=2.085
r375 (  24 44 ) resistor r=4.5 //w=0.15 //l=0.15 //layer=via1 //count=1 \
 //x=10.37 //y=4.705 //x2=10.37 //y2=4.705
r376 (  21 70 ) resistor r=9.3 //w=0.17 //l=0.17 //layer=mcon //count=1 \
 //x=10.36 //y=4.7 //x2=10.36 //y2=4.7
r377 (  21 24 ) resistor r=0.0022242 //w=0.281 //l=0.005 //layer=m1 \
 //thickness=0.36 //x=10.37 //y=4.7 //x2=10.37 //y2=4.705
r378 (  21 22 ) resistor r=0.105116 //w=0.281 //l=0.155 //layer=m1 \
 //thickness=0.36 //x=10.37 //y=4.7 //x2=10.37 //y2=4.545
r379 (  18 42 ) resistor r=4.5 //w=0.15 //l=0.15 //layer=via1 //count=1 \
 //x=10.355 //y=2.96 //x2=10.355 //y2=2.96
r380 (  16 40 ) resistor r=4.5 //w=0.15 //l=0.15 //layer=via1 //count=1 \
 //x=6.66 //y=4.53 //x2=6.66 //y2=4.53
r381 (  14 55 ) resistor r=9.3 //w=0.17 //l=0.17 //layer=mcon //count=1 \
 //x=6.66 //y=4.44 //x2=6.66 //y2=4.44
r382 (  14 16 ) resistor r=0.0317797 //w=0.354 //l=0.09 //layer=m1 \
 //thickness=0.36 //x=6.712 //y=4.44 //x2=6.712 //y2=4.53
r383 (  12 36 ) resistor r=4.5 //w=0.15 //l=0.15 //layer=via1 //count=1 \
 //x=4.44 //y=2.975 //x2=4.44 //y2=2.975
r384 (  10 12 ) resistor r=0.0049867 //w=0.376 //l=0.015 //layer=m1 \
 //thickness=0.36 //x=4.492 //y=2.96 //x2=4.492 //y2=2.975
r385 (  8 46 ) resistor r=9.3 //w=0.17 //l=0.17 //layer=mcon //count=1 \
 //x=4.44 //y=2.085 //x2=4.44 //y2=2.085
r386 (  5 18 ) resistor r=0.0910802 //w=0.374 //l=0.185472 //layer=m1 \
 //thickness=0.36 //x=10.36 //y=3.12 //x2=10.305 //y2=2.96
r387 (  5 22 ) resistor r=1.35973 //w=0.131 //l=1.425 //layer=m1 \
 //thickness=0.36 //x=10.36 //y=3.12 //x2=10.36 //y2=4.545
r388 (  4 18 ) resistor r=0.0910802 //w=0.374 //l=0.185472 //layer=m1 \
 //thickness=0.36 //x=10.36 //y=2.8 //x2=10.305 //y2=2.96
r389 (  3 27 ) resistor r=0.116051 //w=0.211 //l=0.165 //layer=m1 \
 //thickness=0.36 //x=10.36 //y=2.25 //x2=10.36 //y2=2.085
r390 (  3 4 ) resistor r=0.524809 //w=0.131 //l=0.55 //layer=m1 \
 //thickness=0.36 //x=10.36 //y=2.25 //x2=10.36 //y2=2.8
r391 (  2 10 ) resistor r=0.0861726 //w=0.376 //l=0.169012 //layer=m1 \
 //thickness=0.36 //x=4.44 //y=2.815 //x2=4.492 //y2=2.96
r392 (  1 8 ) resistor r=0.0891709 //w=0.238 //l=0.151493 //layer=m1 \
 //thickness=0.36 //x=4.44 //y=2.235 //x2=4.437 //y2=2.085
r393 (  1 2 ) resistor r=0.553435 //w=0.131 //l=0.58 //layer=m1 \
 //thickness=0.36 //x=4.44 //y=2.235 //x2=4.44 //y2=2.815
ends PM_XOR2X1_PCELL\%noxref_5

subckt PM_XOR2X1_PCELL\%noxref_6 ( 1 9 10 11 17 18 27 55 71 85 111 126 128 129 \
 130 134 135 136 137 138 139 140 )
c242 ( 140 0 ) capacitor c=0.0599796f //x=10.28 //y=5.02
c243 ( 139 0 ) capacitor c=0.0577658f //x=9.42 //y=5.02
c244 ( 138 0 ) capacitor c=0.0170134f //x=6.635 //y=5.02
c245 ( 137 0 ) capacitor c=0.0170965f //x=3.305 //y=5.02
c246 ( 136 0 ) capacitor c=0.0586401f //x=1.41 //y=5.02
c247 ( 135 0 ) capacitor c=0.0605585f //x=0.54 //y=5.02
c248 ( 134 0 ) capacitor c=0.238591f //x=10.36 //y=7.4
c249 ( 132 0 ) capacitor c=0.00591168f //x=9.62 //y=7.4
c250 ( 130 0 ) capacitor c=0.118046f //x=8.88 //y=7.4
c251 ( 129 0 ) capacitor c=0.11877f //x=5.55 //y=7.4
c252 ( 128 0 ) capacitor c=0.121695f //x=2.22 //y=7.4
c253 ( 127 0 ) capacitor c=0.00591168f //x=1.555 //y=7.4
c254 ( 126 0 ) capacitor c=0.237536f //x=0.74 //y=7.4
c255 ( 111 0 ) capacitor c=0.0288001f //x=10.34 //y=7.4
c256 ( 101 0 ) capacitor c=0.0206483f //x=9.46 //y=7.4
c257 ( 85 0 ) capacitor c=0.138737f //x=8.71 //y=7.4
c258 ( 71 0 ) capacitor c=0.137963f //x=5.38 //y=7.4
c259 ( 65 0 ) capacitor c=0.0210379f //x=2.05 //y=7.4
c260 ( 55 0 ) capacitor c=0.0284438f //x=1.47 //y=7.4
c261 ( 36 0 ) capacitor c=0.00510392f //x=6.78 //y=7.4
c262 ( 33 0 ) capacitor c=0.00510392f //x=3.45 //y=7.4
c263 ( 27 0 ) capacitor c=0.163694f //x=10.36 //y=7.4
c264 ( 18 0 ) capacitor c=0.0147928f //x=6.78 //y=7.23
c265 ( 17 0 ) capacitor c=0.0127236f //x=6.78 //y=6.51
c266 ( 11 0 ) capacitor c=0.110241f //x=6.695 //y=7.4
c267 ( 10 0 ) capacitor c=0.0153981f //x=3.45 //y=7.23
c268 ( 9 0 ) capacitor c=0.013349f //x=3.45 //y=6.52
c269 ( 1 0 ) capacitor c=0.140683f //x=3.365 //y=7.4
r270 (  113 134 ) resistor r=4.11603 //w=0.68 //l=0.17 //layer=li \
 //thickness=0.1 //x=10.425 //y=7.23 //x2=10.425 //y2=7.4
r271 (  113 140 ) resistor r=56.4706 //w=0.187 //l=0.825 //layer=li \
 //thickness=0.1 //x=10.425 //y=7.23 //x2=10.425 //y2=6.405
r272 (  112 132 ) resistor r=2.94794 //w=0.34 //l=0.085 //layer=li \
 //thickness=0.1 //x=9.63 //y=7.4 //x2=9.545 //y2=7.4
r273 (  111 134 ) resistor r=2.94794 //w=0.34 //l=0.085 //layer=li \
 //thickness=0.1 //x=10.34 //y=7.4 //x2=10.425 //y2=7.4
r274 (  111 112 ) resistor r=25.4566 //w=0.357 //l=0.71 //layer=li \
 //thickness=0.1 //x=10.34 //y=7.4 //x2=9.63 //y2=7.4
r275 (  103 132 ) resistor r=4.11603 //w=0.68 //l=0.17 //layer=li \
 //thickness=0.1 //x=9.545 //y=7.23 //x2=9.545 //y2=7.4
r276 (  103 139 ) resistor r=56.4706 //w=0.187 //l=0.825 //layer=li \
 //thickness=0.1 //x=9.545 //y=7.23 //x2=9.545 //y2=6.405
r277 (  102 130 ) resistor r=5.4201 //w=0.34 //l=0.17 //layer=li \
 //thickness=0.1 //x=9.05 //y=7.4 //x2=8.88 //y2=7.4
r278 (  101 132 ) resistor r=2.94794 //w=0.34 //l=0.085 //layer=li \
 //thickness=0.1 //x=9.46 //y=7.4 //x2=9.545 //y2=7.4
r279 (  101 102 ) resistor r=14.7003 //w=0.357 //l=0.41 //layer=li \
 //thickness=0.1 //x=9.46 //y=7.4 //x2=9.05 //y2=7.4
r280 (  97 138 ) resistor r=23.2727 //w=0.187 //l=0.34 //layer=li \
 //thickness=0.1 //x=6.78 //y=6.395 //x2=6.78 //y2=6.055
r281 (  90 92 ) resistor r=39.7983 //w=0.357 //l=1.11 //layer=li \
 //thickness=0.1 //x=7.03 //y=7.4 //x2=8.14 //y2=7.4
r282 (  88 90 ) resistor r=39.7983 //w=0.357 //l=1.11 //layer=li \
 //thickness=0.1 //x=5.92 //y=7.4 //x2=7.03 //y2=7.4
r283 (  86 129 ) resistor r=5.4201 //w=0.34 //l=0.17 //layer=li \
 //thickness=0.1 //x=5.72 //y=7.4 //x2=5.55 //y2=7.4
r284 (  86 88 ) resistor r=7.17087 //w=0.357 //l=0.2 //layer=li \
 //thickness=0.1 //x=5.72 //y=7.4 //x2=5.92 //y2=7.4
r285 (  85 130 ) resistor r=5.4201 //w=0.34 //l=0.17 //layer=li \
 //thickness=0.1 //x=8.71 //y=7.4 //x2=8.88 //y2=7.4
r286 (  85 92 ) resistor r=20.437 //w=0.357 //l=0.57 //layer=li \
 //thickness=0.1 //x=8.71 //y=7.4 //x2=8.14 //y2=7.4
r287 (  81 137 ) resistor r=23.2727 //w=0.187 //l=0.34 //layer=li \
 //thickness=0.1 //x=3.45 //y=6.395 //x2=3.45 //y2=6.055
r288 (  74 76 ) resistor r=39.7983 //w=0.357 //l=1.11 //layer=li \
 //thickness=0.1 //x=3.33 //y=7.4 //x2=4.44 //y2=7.4
r289 (  72 128 ) resistor r=5.4201 //w=0.34 //l=0.17 //layer=li \
 //thickness=0.1 //x=2.39 //y=7.4 //x2=2.22 //y2=7.4
r290 (  72 74 ) resistor r=33.7031 //w=0.357 //l=0.94 //layer=li \
 //thickness=0.1 //x=2.39 //y=7.4 //x2=3.33 //y2=7.4
r291 (  71 129 ) resistor r=5.4201 //w=0.34 //l=0.17 //layer=li \
 //thickness=0.1 //x=5.38 //y=7.4 //x2=5.55 //y2=7.4
r292 (  71 76 ) resistor r=33.7031 //w=0.357 //l=0.94 //layer=li \
 //thickness=0.1 //x=5.38 //y=7.4 //x2=4.44 //y2=7.4
r293 (  66 127 ) resistor r=2.94794 //w=0.34 //l=0.085 //layer=li \
 //thickness=0.1 //x=1.64 //y=7.4 //x2=1.555 //y2=7.4
r294 (  66 68 ) resistor r=7.52941 //w=0.357 //l=0.21 //layer=li \
 //thickness=0.1 //x=1.64 //y=7.4 //x2=1.85 //y2=7.4
r295 (  65 128 ) resistor r=5.4201 //w=0.34 //l=0.17 //layer=li \
 //thickness=0.1 //x=2.05 //y=7.4 //x2=2.22 //y2=7.4
r296 (  65 68 ) resistor r=7.17087 //w=0.357 //l=0.2 //layer=li \
 //thickness=0.1 //x=2.05 //y=7.4 //x2=1.85 //y2=7.4
r297 (  57 127 ) resistor r=4.11603 //w=0.68 //l=0.17 //layer=li \
 //thickness=0.1 //x=1.555 //y=7.23 //x2=1.555 //y2=7.4
r298 (  57 136 ) resistor r=56.4706 //w=0.187 //l=0.825 //layer=li \
 //thickness=0.1 //x=1.555 //y=7.23 //x2=1.555 //y2=6.405
r299 (  56 126 ) resistor r=2.94794 //w=0.34 //l=0.085 //layer=li \
 //thickness=0.1 //x=0.76 //y=7.4 //x2=0.675 //y2=7.4
r300 (  55 127 ) resistor r=2.94794 //w=0.34 //l=0.085 //layer=li \
 //thickness=0.1 //x=1.47 //y=7.4 //x2=1.555 //y2=7.4
r301 (  55 56 ) resistor r=25.4566 //w=0.357 //l=0.71 //layer=li \
 //thickness=0.1 //x=1.47 //y=7.4 //x2=0.76 //y2=7.4
r302 (  47 126 ) resistor r=4.11603 //w=0.68 //l=0.17 //layer=li \
 //thickness=0.1 //x=0.675 //y=7.23 //x2=0.675 //y2=7.4
r303 (  47 135 ) resistor r=56.4706 //w=0.187 //l=0.825 //layer=li \
 //thickness=0.1 //x=0.675 //y=7.23 //x2=0.675 //y2=6.405
r304 (  38 97 ) resistor r=9.3 //w=0.17 //l=0.17 //layer=mcon //count=1 \
 //x=6.78 //y=6.395 //x2=6.78 //y2=6.395
r305 (  35 81 ) resistor r=9.3 //w=0.17 //l=0.17 //layer=mcon //count=1 \
 //x=3.45 //y=6.395 //x2=3.45 //y2=6.395
r306 (  27 134 ) resistor r=4.65 //w=0.17 //l=0.34 //layer=mcon //count=2 \
 //x=10.36 //y=7.4 //x2=10.36 //y2=7.4
r307 (  25 132 ) resistor r=3.1 //w=0.17 //l=0.51 //layer=mcon //count=3 \
 //x=9.62 //y=7.4 //x2=9.62 //y2=7.4
r308 (  25 27 ) resistor r=0.307309 //w=0.301 //l=0.74 //layer=m1 \
 //thickness=0.36 //x=9.62 //y=7.4 //x2=10.36 //y2=7.4
r309 (  23 92 ) resistor r=3.1 //w=0.17 //l=0.51 //layer=mcon //count=3 \
 //x=8.14 //y=7.4 //x2=8.14 //y2=7.4
r310 (  23 25 ) resistor r=0.614618 //w=0.301 //l=1.48 //layer=m1 \
 //thickness=0.36 //x=8.14 //y=7.4 //x2=9.62 //y2=7.4
r311 (  21 90 ) resistor r=3.1 //w=0.17 //l=0.51 //layer=mcon //count=3 \
 //x=7.03 //y=7.4 //x2=7.03 //y2=7.4
r312 (  21 23 ) resistor r=0.460963 //w=0.301 //l=1.11 //layer=m1 \
 //thickness=0.36 //x=7.03 //y=7.4 //x2=8.14 //y2=7.4
r313 (  19 36 ) resistor r=0.0287885 //w=0.34 //l=0.085 //layer=m1 \
 //thickness=0.36 //x=6.865 //y=7.4 //x2=6.78 //y2=7.4
r314 (  19 21 ) resistor r=0.0685216 //w=0.301 //l=0.165 //layer=m1 \
 //thickness=0.36 //x=6.865 //y=7.4 //x2=7.03 //y2=7.4
r315 (  18 36 ) resistor r=0.0401957 //w=0.68 //l=0.17 //layer=m1 \
 //thickness=0.36 //x=6.78 //y=7.23 //x2=6.78 //y2=7.4
r316 (  17 38 ) resistor r=0.0717383 //w=0.224 //l=0.115 //layer=m1 \
 //thickness=0.36 //x=6.78 //y=6.51 //x2=6.78 //y2=6.395
r317 (  17 18 ) resistor r=0.687023 //w=0.131 //l=0.72 //layer=m1 \
 //thickness=0.36 //x=6.78 //y=6.51 //x2=6.78 //y2=7.23
r318 (  16 88 ) resistor r=3.1 //w=0.17 //l=0.51 //layer=mcon //count=3 \
 //x=5.92 //y=7.4 //x2=5.92 //y2=7.4
r319 (  14 76 ) resistor r=3.1 //w=0.17 //l=0.51 //layer=mcon //count=3 \
 //x=4.44 //y=7.4 //x2=4.44 //y2=7.4
r320 (  14 16 ) resistor r=0.614618 //w=0.301 //l=1.48 //layer=m1 \
 //thickness=0.36 //x=4.44 //y=7.4 //x2=5.92 //y2=7.4
r321 (  12 33 ) resistor r=0.0287885 //w=0.34 //l=0.085 //layer=m1 \
 //thickness=0.36 //x=3.535 //y=7.4 //x2=3.45 //y2=7.4
r322 (  12 14 ) resistor r=0.375831 //w=0.301 //l=0.905 //layer=m1 \
 //thickness=0.36 //x=3.535 //y=7.4 //x2=4.44 //y2=7.4
r323 (  11 36 ) resistor r=0.0287885 //w=0.34 //l=0.085 //layer=m1 \
 //thickness=0.36 //x=6.695 //y=7.4 //x2=6.78 //y2=7.4
r324 (  11 16 ) resistor r=0.321844 //w=0.301 //l=0.775 //layer=m1 \
 //thickness=0.36 //x=6.695 //y=7.4 //x2=5.92 //y2=7.4
r325 (  10 33 ) resistor r=0.0401957 //w=0.68 //l=0.17 //layer=m1 \
 //thickness=0.36 //x=3.45 //y=7.23 //x2=3.45 //y2=7.4
r326 (  9 35 ) resistor r=0.0773187 //w=0.224 //l=0.125 //layer=m1 \
 //thickness=0.36 //x=3.45 //y=6.52 //x2=3.45 //y2=6.395
r327 (  9 10 ) resistor r=0.677481 //w=0.131 //l=0.71 //layer=m1 \
 //thickness=0.36 //x=3.45 //y=6.52 //x2=3.45 //y2=7.23
r328 (  8 74 ) resistor r=3.1 //w=0.17 //l=0.51 //layer=mcon //count=3 \
 //x=3.33 //y=7.4 //x2=3.33 //y2=7.4
r329 (  6 68 ) resistor r=3.1 //w=0.17 //l=0.51 //layer=mcon //count=3 \
 //x=1.85 //y=7.4 //x2=1.85 //y2=7.4
r330 (  6 8 ) resistor r=0.614618 //w=0.301 //l=1.48 //layer=m1 \
 //thickness=0.36 //x=1.85 //y=7.4 //x2=3.33 //y2=7.4
r331 (  3 126 ) resistor r=3.1 //w=0.17 //l=0.51 //layer=mcon //count=3 \
 //x=0.74 //y=7.4 //x2=0.74 //y2=7.4
r332 (  3 6 ) resistor r=0.460963 //w=0.301 //l=1.11 //layer=m1 \
 //thickness=0.36 //x=0.74 //y=7.4 //x2=1.85 //y2=7.4
r333 (  1 33 ) resistor r=0.0287885 //w=0.34 //l=0.085 //layer=m1 \
 //thickness=0.36 //x=3.365 //y=7.4 //x2=3.45 //y2=7.4
r334 (  1 8 ) resistor r=0.0145349 //w=0.301 //l=0.035 //layer=m1 \
 //thickness=0.36 //x=3.365 //y=7.4 //x2=3.33 //y2=7.4
ends PM_XOR2X1_PCELL\%noxref_6

subckt PM_XOR2X1_PCELL\%noxref_7 ( 1 3 5 10 14 17 20 30 46 47 48 )
c83 ( 48 0 ) capacitor c=0.0367727f //x=4.625 //y=5.02
c84 ( 46 0 ) capacitor c=0.0184616f //x=2.875 //y=5.02
c85 ( 30 0 ) capacitor c=0.0317225f //x=3.89 //y=5.375
c86 ( 20 0 ) capacitor c=0.0447371f //x=3.01 //y=5.375
c87 ( 17 0 ) capacitor c=0.0100496f //x=4.77 //y=6.735
c88 ( 14 0 ) capacitor c=0.00636436f //x=3.89 //y=6.735
c89 ( 10 0 ) capacitor c=0.012342f //x=3.89 //y=5.205
c90 ( 5 0 ) capacitor c=0.0123915f //x=3.017 //y=5.205
c91 ( 3 0 ) capacitor c=0.00891704f //x=4.655 //y=6.905
c92 ( 1 0 ) capacitor c=0.0141892f //x=3.77 //y=5.205
r93 (  37 47 ) resistor r=23.2727 //w=0.187 //l=0.34 //layer=li \
 //thickness=0.1 //x=3.89 //y=6.735 //x2=3.89 //y2=6.395
r94 (  30 47 ) resistor r=23.2727 //w=0.187 //l=0.34 //layer=li \
 //thickness=0.1 //x=3.89 //y=5.375 //x2=3.89 //y2=5.715
r95 (  20 46 ) resistor r=23.2727 //w=0.187 //l=0.34 //layer=li \
 //thickness=0.1 //x=3.01 //y=5.375 //x2=3.01 //y2=5.715
r96 (  17 48 ) resistor r=9.3 //w=0.17 //l=0.17 //layer=mcon //count=1 \
 //x=4.77 //y=6.735 //x2=4.77 //y2=6.735
r97 (  17 18 ) resistor r=0.0997653 //w=0.213 //l=0.17 //layer=m1 \
 //thickness=0.36 //x=4.77 //y=6.735 //x2=4.77 //y2=6.905
r98 (  14 37 ) resistor r=9.3 //w=0.17 //l=0.17 //layer=mcon //count=1 \
 //x=3.89 //y=6.735 //x2=3.89 //y2=6.735
r99 (  14 15 ) resistor r=0.100236 //w=0.212 //l=0.17 //layer=m1 \
 //thickness=0.36 //x=3.89 //y=6.735 //x2=3.89 //y2=6.905
r100 (  12 30 ) resistor r=9.3 //w=0.17 //l=0.17 //layer=mcon //count=1 \
 //x=3.89 //y=5.375 //x2=3.89 //y2=5.375
r101 (  10 12 ) resistor r=0.0965909 //w=0.22 //l=0.17 //layer=m1 \
 //thickness=0.36 //x=3.89 //y=5.205 //x2=3.89 //y2=5.375
r102 (  7 20 ) resistor r=9.3 //w=0.17 //l=0.17 //layer=mcon //count=1 \
 //x=3.01 //y=5.375 //x2=3.01 //y2=5.375
r103 (  5 7 ) resistor r=0.0912017 //w=0.233 //l=0.17 //layer=m1 \
 //thickness=0.36 //x=3.017 //y=5.205 //x2=3.017 //y2=5.375
r104 (  4 15 ) resistor r=0.0208269 //w=0.212 //l=0.115 //layer=m1 \
 //thickness=0.36 //x=4.005 //y=6.905 //x2=3.89 //y2=6.905
r105 (  3 18 ) resistor r=0.0211096 //w=0.213 //l=0.115 //layer=m1 \
 //thickness=0.36 //x=4.655 //y=6.905 //x2=4.77 //y2=6.905
r106 (  3 4 ) resistor r=0.620229 //w=0.131 //l=0.65 //layer=m1 \
 //thickness=0.36 //x=4.655 //y=6.905 //x2=4.005 //y2=6.905
r107 (  2 5 ) resistor r=0.0264833 //w=0.233 //l=0.128 //layer=m1 \
 //thickness=0.36 //x=3.145 //y=5.205 //x2=3.017 //y2=5.205
r108 (  1 10 ) resistor r=0.0230492 //w=0.22 //l=0.12 //layer=m1 \
 //thickness=0.36 //x=3.77 //y=5.205 //x2=3.89 //y2=5.205
r109 (  1 2 ) resistor r=0.596374 //w=0.131 //l=0.625 //layer=m1 \
 //thickness=0.36 //x=3.77 //y=5.205 //x2=3.145 //y2=5.205
ends PM_XOR2X1_PCELL\%noxref_7

subckt PM_XOR2X1_PCELL\%noxref_8 ( 1 3 5 10 14 17 20 30 46 47 48 )
c81 ( 48 0 ) capacitor c=0.0344743f //x=7.955 //y=5.02
c82 ( 46 0 ) capacitor c=0.0123991f //x=6.205 //y=5.02
c83 ( 30 0 ) capacitor c=0.0304667f //x=7.22 //y=5.375
c84 ( 20 0 ) capacitor c=0.0472305f //x=6.34 //y=5.375
c85 ( 17 0 ) capacitor c=0.0161402f //x=8.1 //y=6.735
c86 ( 14 0 ) capacitor c=0.00620376f //x=7.22 //y=6.735
c87 ( 10 0 ) capacitor c=0.0090232f //x=7.22 //y=5.205
c88 ( 5 0 ) capacitor c=0.0125427f //x=6.34 //y=5.205
c89 ( 3 0 ) capacitor c=0.00902211f //x=7.98 //y=6.905
c90 ( 1 0 ) capacitor c=0.0120258f //x=7.105 //y=5.205
r91 (  37 47 ) resistor r=23.2727 //w=0.187 //l=0.34 //layer=li \
 //thickness=0.1 //x=7.22 //y=6.735 //x2=7.22 //y2=6.395
r92 (  30 47 ) resistor r=23.2727 //w=0.187 //l=0.34 //layer=li \
 //thickness=0.1 //x=7.22 //y=5.375 //x2=7.22 //y2=5.715
r93 (  20 46 ) resistor r=23.2727 //w=0.187 //l=0.34 //layer=li \
 //thickness=0.1 //x=6.34 //y=5.375 //x2=6.34 //y2=5.715
r94 (  17 48 ) resistor r=9.3 //w=0.17 //l=0.17 //layer=mcon //count=1 //x=8.1 \
 //y=6.735 //x2=8.1 //y2=6.735
r95 (  17 18 ) resistor r=0.097032 //w=0.219 //l=0.17 //layer=m1 \
 //thickness=0.36 //x=8.097 //y=6.735 //x2=8.097 //y2=6.905
r96 (  14 37 ) resistor r=9.3 //w=0.17 //l=0.17 //layer=mcon //count=1 \
 //x=7.22 //y=6.735 //x2=7.22 //y2=6.735
r97 (  14 15 ) resistor r=0.100236 //w=0.212 //l=0.17 //layer=m1 \
 //thickness=0.36 //x=7.22 //y=6.735 //x2=7.22 //y2=6.905
r98 (  12 30 ) resistor r=9.3 //w=0.17 //l=0.17 //layer=mcon //count=1 \
 //x=7.22 //y=5.375 //x2=7.22 //y2=5.375
r99 (  10 12 ) resistor r=0.100236 //w=0.212 //l=0.17 //layer=m1 \
 //thickness=0.36 //x=7.22 //y=5.205 //x2=7.22 //y2=5.375
r100 (  7 20 ) resistor r=9.3 //w=0.17 //l=0.17 //layer=mcon //count=1 \
 //x=6.34 //y=5.375 //x2=6.34 //y2=5.375
r101 (  5 7 ) resistor r=0.100236 //w=0.212 //l=0.17 //layer=m1 \
 //thickness=0.36 //x=6.34 //y=5.205 //x2=6.34 //y2=5.375
r102 (  4 15 ) resistor r=0.0208269 //w=0.212 //l=0.115 //layer=m1 \
 //thickness=0.36 //x=7.335 //y=6.905 //x2=7.22 //y2=6.905
r103 (  3 18 ) resistor r=0.0227762 //w=0.219 //l=0.117 //layer=m1 \
 //thickness=0.36 //x=7.98 //y=6.905 //x2=8.097 //y2=6.905
r104 (  3 4 ) resistor r=0.615458 //w=0.131 //l=0.645 //layer=m1 \
 //thickness=0.36 //x=7.98 //y=6.905 //x2=7.335 //y2=6.905
r105 (  2 5 ) resistor r=0.0208269 //w=0.212 //l=0.115 //layer=m1 \
 //thickness=0.36 //x=6.455 //y=5.205 //x2=6.34 //y2=5.205
r106 (  1 10 ) resistor r=0.0208269 //w=0.212 //l=0.115 //layer=m1 \
 //thickness=0.36 //x=7.105 //y=5.205 //x2=7.22 //y2=5.205
r107 (  1 2 ) resistor r=0.620229 //w=0.131 //l=0.65 //layer=m1 \
 //thickness=0.36 //x=7.105 //y=5.205 //x2=6.455 //y2=5.205
ends PM_XOR2X1_PCELL\%noxref_8

subckt PM_XOR2X1_PCELL\%noxref_9 ( 1 8 9 16 25 44 48 51 62 75 93 98 102 114 \
 125 126 127 134 141 142 143 144 )
c241 ( 144 0 ) capacitor c=0.0634161f //x=9.375 //y=0.37
c242 ( 143 0 ) capacitor c=0.00839739f //x=6.54 //y=0.87
c243 ( 142 0 ) capacitor c=0.00839739f //x=3.21 //y=0.87
c244 ( 141 0 ) capacitor c=0.0629125f //x=0.495 //y=0.37
c245 ( 134 0 ) capacitor c=0.234259f //x=10.47 //y=0
c246 ( 127 0 ) capacitor c=0.113061f //x=8.88 //y=0
c247 ( 126 0 ) capacitor c=0.111475f //x=5.55 //y=0
c248 ( 125 0 ) capacitor c=0.108345f //x=2.22 //y=0
c249 ( 114 0 ) capacitor c=0.196221f //x=0.63 //y=0
c250 ( 105 0 ) capacitor c=0.00590583f //x=10.47 //y=0.45
c251 ( 102 0 ) capacitor c=0.00599833f //x=10.385 //y=0.535
c252 ( 101 0 ) capacitor c=0.00479851f //x=9.99 //y=0.45
c253 ( 98 0 ) capacitor c=0.0061439f //x=9.905 //y=0.535
c254 ( 93 0 ) capacitor c=0.00589014f //x=9.5 //y=0.45
c255 ( 90 0 ) capacitor c=0.0184079f //x=9.415 //y=0
c256 ( 75 0 ) capacitor c=0.125153f //x=8.71 //y=0
c257 ( 62 0 ) capacitor c=0.124567f //x=5.38 //y=0
c258 ( 57 0 ) capacitor c=0.0360826f //x=1.685 //y=0
c259 ( 56 0 ) capacitor c=0.0184188f //x=2.05 //y=0
c260 ( 51 0 ) capacitor c=0.00589014f //x=1.6 //y=0.45
c261 ( 48 0 ) capacitor c=0.00605867f //x=1.515 //y=0.535
c262 ( 47 0 ) capacitor c=0.00479851f //x=1.11 //y=0.45
c263 ( 44 0 ) capacitor c=0.00645303f //x=1.025 //y=0.535
c264 ( 39 0 ) capacitor c=0.00590583f //x=0.63 //y=0.45
c265 ( 31 0 ) capacitor c=0.00508917f //x=6.73 //y=0
c266 ( 28 0 ) capacitor c=0.00508917f //x=3.33 //y=0
c267 ( 25 0 ) capacitor c=0.16219f //x=10.36 //y=0
c268 ( 16 0 ) capacitor c=0.0338236f //x=6.73 //y=0.845
c269 ( 9 0 ) capacitor c=0.108491f //x=6.645 //y=0
c270 ( 8 0 ) capacitor c=0.0343697f //x=3.4 //y=0.845
c271 ( 1 0 ) capacitor c=0.136062f //x=3.315 //y=0
r272 (  133 134 ) resistor r=3.94398 //w=0.357 //l=0.11 //layer=li \
 //thickness=0.1 //x=10.36 //y=0 //x2=10.47 //y2=0
r273 (  131 133 ) resistor r=13.2661 //w=0.357 //l=0.37 //layer=li \
 //thickness=0.1 //x=9.99 //y=0 //x2=10.36 //y2=0
r274 (  130 131 ) resistor r=13.2661 //w=0.357 //l=0.37 //layer=li \
 //thickness=0.1 //x=9.62 //y=0 //x2=9.99 //y2=0
r275 (  128 130 ) resistor r=4.30252 //w=0.357 //l=0.12 //layer=li \
 //thickness=0.1 //x=9.5 //y=0 //x2=9.62 //y2=0
r276 (  117 118 ) resistor r=17.5686 //w=0.357 //l=0.49 //layer=li \
 //thickness=0.1 //x=1.11 //y=0 //x2=1.6 //y2=0
r277 (  116 117 ) resistor r=13.2661 //w=0.357 //l=0.37 //layer=li \
 //thickness=0.1 //x=0.74 //y=0 //x2=1.11 //y2=0
r278 (  114 116 ) resistor r=3.94398 //w=0.357 //l=0.11 //layer=li \
 //thickness=0.1 //x=0.63 //y=0 //x2=0.74 //y2=0
r279 (  106 144 ) resistor r=5.4201 //w=0.17 //l=0.085 //layer=li \
 //thickness=0.1 //x=10.47 //y=0.62 //x2=10.47 //y2=0.535
r280 (  106 144 ) resistor r=41.4118 //w=0.187 //l=0.605 //layer=li \
 //thickness=0.1 //x=10.47 //y=0.62 //x2=10.47 //y2=1.225
r281 (  105 144 ) resistor r=5.4201 //w=0.17 //l=0.085 //layer=li \
 //thickness=0.1 //x=10.47 //y=0.45 //x2=10.47 //y2=0.535
r282 (  104 134 ) resistor r=5.03728 //w=0.34 //l=0.17 //layer=li \
 //thickness=0.1 //x=10.47 //y=0.17 //x2=10.47 //y2=0
r283 (  104 105 ) resistor r=19.1658 //w=0.187 //l=0.28 //layer=li \
 //thickness=0.1 //x=10.47 //y=0.17 //x2=10.47 //y2=0.45
r284 (  103 144 ) resistor r=5.4201 //w=0.17 //l=0.085 //layer=li \
 //thickness=0.1 //x=10.075 //y=0.535 //x2=9.99 //y2=0.535
r285 (  102 144 ) resistor r=1.40859 //w=0.34 //l=0.085 //layer=li \
 //thickness=0.1 //x=10.385 //y=0.535 //x2=10.47 //y2=0.535
r286 (  102 103 ) resistor r=21.2193 //w=0.187 //l=0.31 //layer=li \
 //thickness=0.1 //x=10.385 //y=0.535 //x2=10.075 //y2=0.535
r287 (  101 144 ) resistor r=1.40859 //w=0.34 //l=0.085 //layer=li \
 //thickness=0.1 //x=9.99 //y=0.45 //x2=9.99 //y2=0.535
r288 (  100 131 ) resistor r=5.03728 //w=0.34 //l=0.17 //layer=li \
 //thickness=0.1 //x=9.99 //y=0.17 //x2=9.99 //y2=0
r289 (  100 101 ) resistor r=19.1658 //w=0.187 //l=0.28 //layer=li \
 //thickness=0.1 //x=9.99 //y=0.17 //x2=9.99 //y2=0.45
r290 (  99 144 ) resistor r=1.40859 //w=0.34 //l=0.085 //layer=li \
 //thickness=0.1 //x=9.585 //y=0.535 //x2=9.5 //y2=0.535
r291 (  98 144 ) resistor r=5.4201 //w=0.17 //l=0.085 //layer=li \
 //thickness=0.1 //x=9.905 //y=0.535 //x2=9.99 //y2=0.535
r292 (  98 99 ) resistor r=21.9037 //w=0.187 //l=0.32 //layer=li \
 //thickness=0.1 //x=9.905 //y=0.535 //x2=9.585 //y2=0.535
r293 (  94 144 ) resistor r=5.4201 //w=0.17 //l=0.085 //layer=li \
 //thickness=0.1 //x=9.5 //y=0.62 //x2=9.5 //y2=0.535
r294 (  94 144 ) resistor r=41.4118 //w=0.187 //l=0.605 //layer=li \
 //thickness=0.1 //x=9.5 //y=0.62 //x2=9.5 //y2=1.225
r295 (  93 144 ) resistor r=5.4201 //w=0.17 //l=0.085 //layer=li \
 //thickness=0.1 //x=9.5 //y=0.45 //x2=9.5 //y2=0.535
r296 (  92 128 ) resistor r=5.03728 //w=0.34 //l=0.17 //layer=li \
 //thickness=0.1 //x=9.5 //y=0.17 //x2=9.5 //y2=0
r297 (  92 93 ) resistor r=19.1658 //w=0.187 //l=0.28 //layer=li \
 //thickness=0.1 //x=9.5 //y=0.17 //x2=9.5 //y2=0.45
r298 (  91 127 ) resistor r=5.4201 //w=0.34 //l=0.17 //layer=li \
 //thickness=0.1 //x=9.05 //y=0 //x2=8.88 //y2=0
r299 (  90 128 ) resistor r=3.04762 //w=0.357 //l=0.085 //layer=li \
 //thickness=0.1 //x=9.415 //y=0 //x2=9.5 //y2=0
r300 (  90 91 ) resistor r=13.0868 //w=0.357 //l=0.365 //layer=li \
 //thickness=0.1 //x=9.415 //y=0 //x2=9.05 //y2=0
r301 (  80 82 ) resistor r=39.7983 //w=0.357 //l=1.11 //layer=li \
 //thickness=0.1 //x=7.03 //y=0 //x2=8.14 //y2=0
r302 (  78 80 ) resistor r=39.7983 //w=0.357 //l=1.11 //layer=li \
 //thickness=0.1 //x=5.92 //y=0 //x2=7.03 //y2=0
r303 (  76 126 ) resistor r=5.4201 //w=0.34 //l=0.17 //layer=li \
 //thickness=0.1 //x=5.72 //y=0 //x2=5.55 //y2=0
r304 (  76 78 ) resistor r=7.17087 //w=0.357 //l=0.2 //layer=li \
 //thickness=0.1 //x=5.72 //y=0 //x2=5.92 //y2=0
r305 (  75 127 ) resistor r=5.4201 //w=0.34 //l=0.17 //layer=li \
 //thickness=0.1 //x=8.71 //y=0 //x2=8.88 //y2=0
r306 (  75 82 ) resistor r=20.437 //w=0.357 //l=0.57 //layer=li \
 //thickness=0.1 //x=8.71 //y=0 //x2=8.14 //y2=0
r307 (  65 67 ) resistor r=39.7983 //w=0.357 //l=1.11 //layer=li \
 //thickness=0.1 //x=3.33 //y=0 //x2=4.44 //y2=0
r308 (  63 125 ) resistor r=5.4201 //w=0.34 //l=0.17 //layer=li \
 //thickness=0.1 //x=2.39 //y=0 //x2=2.22 //y2=0
r309 (  63 65 ) resistor r=33.7031 //w=0.357 //l=0.94 //layer=li \
 //thickness=0.1 //x=2.39 //y=0 //x2=3.33 //y2=0
r310 (  62 126 ) resistor r=5.4201 //w=0.34 //l=0.17 //layer=li \
 //thickness=0.1 //x=5.38 //y=0 //x2=5.55 //y2=0
r311 (  62 67 ) resistor r=33.7031 //w=0.357 //l=0.94 //layer=li \
 //thickness=0.1 //x=5.38 //y=0 //x2=4.44 //y2=0
r312 (  57 118 ) resistor r=3.04762 //w=0.357 //l=0.085 //layer=li \
 //thickness=0.1 //x=1.685 //y=0 //x2=1.6 //y2=0
r313 (  57 59 ) resistor r=5.91597 //w=0.357 //l=0.165 //layer=li \
 //thickness=0.1 //x=1.685 //y=0 //x2=1.85 //y2=0
r314 (  56 125 ) resistor r=5.4201 //w=0.34 //l=0.17 //layer=li \
 //thickness=0.1 //x=2.05 //y=0 //x2=2.22 //y2=0
r315 (  56 59 ) resistor r=7.17087 //w=0.357 //l=0.2 //layer=li \
 //thickness=0.1 //x=2.05 //y=0 //x2=1.85 //y2=0
r316 (  52 141 ) resistor r=5.4201 //w=0.17 //l=0.085 //layer=li \
 //thickness=0.1 //x=1.6 //y=0.62 //x2=1.6 //y2=0.535
r317 (  52 141 ) resistor r=41.4118 //w=0.187 //l=0.605 //layer=li \
 //thickness=0.1 //x=1.6 //y=0.62 //x2=1.6 //y2=1.225
r318 (  51 141 ) resistor r=5.4201 //w=0.17 //l=0.085 //layer=li \
 //thickness=0.1 //x=1.6 //y=0.45 //x2=1.6 //y2=0.535
r319 (  50 118 ) resistor r=5.03728 //w=0.34 //l=0.17 //layer=li \
 //thickness=0.1 //x=1.6 //y=0.17 //x2=1.6 //y2=0
r320 (  50 51 ) resistor r=19.1658 //w=0.187 //l=0.28 //layer=li \
 //thickness=0.1 //x=1.6 //y=0.17 //x2=1.6 //y2=0.45
r321 (  49 141 ) resistor r=5.4201 //w=0.17 //l=0.085 //layer=li \
 //thickness=0.1 //x=1.195 //y=0.535 //x2=1.11 //y2=0.535
r322 (  48 141 ) resistor r=1.40859 //w=0.34 //l=0.085 //layer=li \
 //thickness=0.1 //x=1.515 //y=0.535 //x2=1.6 //y2=0.535
r323 (  48 49 ) resistor r=21.9037 //w=0.187 //l=0.32 //layer=li \
 //thickness=0.1 //x=1.515 //y=0.535 //x2=1.195 //y2=0.535
r324 (  47 141 ) resistor r=1.40859 //w=0.34 //l=0.085 //layer=li \
 //thickness=0.1 //x=1.11 //y=0.45 //x2=1.11 //y2=0.535
r325 (  46 117 ) resistor r=5.03728 //w=0.34 //l=0.17 //layer=li \
 //thickness=0.1 //x=1.11 //y=0.17 //x2=1.11 //y2=0
r326 (  46 47 ) resistor r=19.1658 //w=0.187 //l=0.28 //layer=li \
 //thickness=0.1 //x=1.11 //y=0.17 //x2=1.11 //y2=0.45
r327 (  45 141 ) resistor r=1.40859 //w=0.34 //l=0.085 //layer=li \
 //thickness=0.1 //x=0.715 //y=0.535 //x2=0.63 //y2=0.535
r328 (  44 141 ) resistor r=5.4201 //w=0.17 //l=0.085 //layer=li \
 //thickness=0.1 //x=1.025 //y=0.535 //x2=1.11 //y2=0.535
r329 (  44 45 ) resistor r=21.2193 //w=0.187 //l=0.31 //layer=li \
 //thickness=0.1 //x=1.025 //y=0.535 //x2=0.715 //y2=0.535
r330 (  40 141 ) resistor r=5.4201 //w=0.17 //l=0.085 //layer=li \
 //thickness=0.1 //x=0.63 //y=0.62 //x2=0.63 //y2=0.535
r331 (  40 141 ) resistor r=41.4118 //w=0.187 //l=0.605 //layer=li \
 //thickness=0.1 //x=0.63 //y=0.62 //x2=0.63 //y2=1.225
r332 (  39 141 ) resistor r=5.4201 //w=0.17 //l=0.085 //layer=li \
 //thickness=0.1 //x=0.63 //y=0.45 //x2=0.63 //y2=0.535
r333 (  38 114 ) resistor r=5.03728 //w=0.34 //l=0.17 //layer=li \
 //thickness=0.1 //x=0.63 //y=0.17 //x2=0.63 //y2=0
r334 (  38 39 ) resistor r=19.1658 //w=0.187 //l=0.28 //layer=li \
 //thickness=0.1 //x=0.63 //y=0.17 //x2=0.63 //y2=0.45
r335 (  33 143 ) resistor r=9.3 //w=0.17 //l=0.17 //layer=mcon //count=1 \
 //x=6.73 //y=0.96 //x2=6.73 //y2=0.96
r336 (  30 142 ) resistor r=9.3 //w=0.17 //l=0.17 //layer=mcon //count=1 \
 //x=3.4 //y=0.96 //x2=3.4 //y2=0.96
r337 (  28 65 ) resistor r=3.1 //w=0.17 //l=0.51 //layer=mcon //count=3 \
 //x=3.33 //y=0 //x2=3.33 //y2=0
r338 (  25 133 ) resistor r=4.65 //w=0.17 //l=0.34 //layer=mcon //count=2 \
 //x=10.36 //y=0 //x2=10.36 //y2=0
r339 (  23 130 ) resistor r=3.1 //w=0.17 //l=0.51 //layer=mcon //count=3 \
 //x=9.62 //y=0 //x2=9.62 //y2=0
r340 (  23 25 ) resistor r=0.307309 //w=0.301 //l=0.74 //layer=m1 \
 //thickness=0.36 //x=9.62 //y=0 //x2=10.36 //y2=0
r341 (  21 82 ) resistor r=3.1 //w=0.17 //l=0.51 //layer=mcon //count=3 \
 //x=8.14 //y=0 //x2=8.14 //y2=0
r342 (  21 23 ) resistor r=0.614618 //w=0.301 //l=1.48 //layer=m1 \
 //thickness=0.36 //x=8.14 //y=0 //x2=9.62 //y2=0
r343 (  19 80 ) resistor r=3.1 //w=0.17 //l=0.51 //layer=mcon //count=3 \
 //x=7.03 //y=0 //x2=7.03 //y2=0
r344 (  19 21 ) resistor r=0.460963 //w=0.301 //l=1.11 //layer=m1 \
 //thickness=0.36 //x=7.03 //y=0 //x2=8.14 //y2=0
r345 (  17 31 ) resistor r=0.0287885 //w=0.34 //l=0.085 //layer=m1 \
 //thickness=0.36 //x=6.815 //y=0 //x2=6.73 //y2=0
r346 (  17 19 ) resistor r=0.0892857 //w=0.301 //l=0.215 //layer=m1 \
 //thickness=0.36 //x=6.815 //y=0 //x2=7.03 //y2=0
r347 (  16 33 ) resistor r=0.0717383 //w=0.224 //l=0.115 //layer=m1 \
 //thickness=0.36 //x=6.73 //y=0.845 //x2=6.73 //y2=0.96
r348 (  15 31 ) resistor r=0.0401957 //w=0.68 //l=0.17 //layer=m1 \
 //thickness=0.36 //x=6.73 //y=0.17 //x2=6.73 //y2=0
r349 (  15 16 ) resistor r=0.644084 //w=0.131 //l=0.675 //layer=m1 \
 //thickness=0.36 //x=6.73 //y=0.17 //x2=6.73 //y2=0.845
r350 (  14 78 ) resistor r=3.1 //w=0.17 //l=0.51 //layer=mcon //count=3 \
 //x=5.92 //y=0 //x2=5.92 //y2=0
r351 (  12 67 ) resistor r=3.1 //w=0.17 //l=0.51 //layer=mcon //count=3 \
 //x=4.44 //y=0 //x2=4.44 //y2=0
r352 (  12 14 ) resistor r=0.614618 //w=0.301 //l=1.48 //layer=m1 \
 //thickness=0.36 //x=4.44 //y=0 //x2=5.92 //y2=0
r353 (  10 28 ) resistor r=0.0287885 //w=0.34 //l=0.085 //layer=m1 \
 //thickness=0.36 //x=3.485 //y=0 //x2=3.4 //y2=0
r354 (  10 12 ) resistor r=0.396595 //w=0.301 //l=0.955 //layer=m1 \
 //thickness=0.36 //x=3.485 //y=0 //x2=4.44 //y2=0
r355 (  9 31 ) resistor r=0.0287885 //w=0.34 //l=0.085 //layer=m1 \
 //thickness=0.36 //x=6.645 //y=0 //x2=6.73 //y2=0
r356 (  9 14 ) resistor r=0.30108 //w=0.301 //l=0.725 //layer=m1 \
 //thickness=0.36 //x=6.645 //y=0 //x2=5.92 //y2=0
r357 (  8 30 ) resistor r=0.0713327 //w=0.229 //l=0.115996 //layer=m1 \
 //thickness=0.36 //x=3.4 //y=0.845 //x2=3.402 //y2=0.96
r358 (  7 28 ) resistor r=0.0401957 //w=0.68 //l=0.17 //layer=m1 \
 //thickness=0.36 //x=3.4 //y=0.17 //x2=3.4 //y2=0
r359 (  7 8 ) resistor r=0.644084 //w=0.131 //l=0.675 //layer=m1 \
 //thickness=0.36 //x=3.4 //y=0.17 //x2=3.4 //y2=0.845
r360 (  6 59 ) resistor r=3.1 //w=0.17 //l=0.51 //layer=mcon //count=3 \
 //x=1.85 //y=0 //x2=1.85 //y2=0
r361 (  3 116 ) resistor r=3.1 //w=0.17 //l=0.51 //layer=mcon //count=3 \
 //x=0.74 //y=0 //x2=0.74 //y2=0
r362 (  3 6 ) resistor r=0.460963 //w=0.301 //l=1.11 //layer=m1 \
 //thickness=0.36 //x=0.74 //y=0 //x2=1.85 //y2=0
r363 (  1 28 ) resistor r=0.0287885 //w=0.34 //l=0.085 //layer=m1 \
 //thickness=0.36 //x=3.315 //y=0 //x2=3.4 //y2=0
r364 (  1 6 ) resistor r=0.608389 //w=0.301 //l=1.465 //layer=m1 \
 //thickness=0.36 //x=3.315 //y=0 //x2=1.85 //y2=0
ends PM_XOR2X1_PCELL\%noxref_9

subckt PM_XOR2X1_PCELL\%noxref_10 ( 1 5 9 10 13 17 29 )
c64 ( 29 0 ) capacitor c=0.0666923f //x=2.78 //y=0.37
c65 ( 17 0 ) capacitor c=0.00679669f //x=4.855 //y=0.62
c66 ( 13 0 ) capacitor c=0.0160622f //x=4.77 //y=0.535
c67 ( 10 0 ) capacitor c=0.0074137f //x=3.885 //y=1.5
c68 ( 9 0 ) capacitor c=0.00771051f //x=3.885 //y=0.62
c69 ( 5 0 ) capacitor c=0.0183783f //x=3.8 //y=1.585
c70 ( 1 0 ) capacitor c=0.00784591f //x=2.915 //y=1.5
r71 (  17 29 ) resistor r=3.57586 //w=0.17 //l=0.125 //layer=li \
 //thickness=0.1 //x=4.855 //y=0.62 //x2=4.855 //y2=0.495
r72 (  17 29 ) resistor r=18.139 //w=0.187 //l=0.265 //layer=li \
 //thickness=0.1 //x=4.855 //y=0.62 //x2=4.855 //y2=0.885
r73 (  14 29 ) resistor r=3.57586 //w=0.17 //l=0.103078 //layer=li \
 //thickness=0.1 //x=3.97 //y=0.535 //x2=3.885 //y2=0.495
r74 (  14 29 ) resistor r=27.3797 //w=0.187 //l=0.4 //layer=li //thickness=0.1 \
 //x=3.97 //y=0.535 //x2=4.37 //y2=0.535
r75 (  13 29 ) resistor r=3.57586 //w=0.17 //l=0.103078 //layer=li \
 //thickness=0.1 //x=4.77 //y=0.535 //x2=4.855 //y2=0.495
r76 (  13 29 ) resistor r=27.3797 //w=0.187 //l=0.4 //layer=li //thickness=0.1 \
 //x=4.77 //y=0.535 //x2=4.37 //y2=0.535
r77 (  10 29 ) resistor r=3.57586 //w=0.17 //l=0.125 //layer=li \
 //thickness=0.1 //x=3.885 //y=1.5 //x2=3.885 //y2=1.625
r78 (  10 29 ) resistor r=42.0963 //w=0.187 //l=0.615 //layer=li \
 //thickness=0.1 //x=3.885 //y=1.5 //x2=3.885 //y2=0.885
r79 (  9 29 ) resistor r=3.57586 //w=0.17 //l=0.125 //layer=li //thickness=0.1 \
 //x=3.885 //y=0.62 //x2=3.885 //y2=0.495
r80 (  9 29 ) resistor r=18.139 //w=0.187 //l=0.265 //layer=li //thickness=0.1 \
 //x=3.885 //y=0.62 //x2=3.885 //y2=0.885
r81 (  6 29 ) resistor r=3.57586 //w=0.17 //l=0.103078 //layer=li \
 //thickness=0.1 //x=3 //y=1.585 //x2=2.915 //y2=1.625
r82 (  6 29 ) resistor r=27.3797 //w=0.187 //l=0.4 //layer=li //thickness=0.1 \
 //x=3 //y=1.585 //x2=3.4 //y2=1.585
r83 (  5 29 ) resistor r=3.57586 //w=0.17 //l=0.103078 //layer=li \
 //thickness=0.1 //x=3.8 //y=1.585 //x2=3.885 //y2=1.625
r84 (  5 29 ) resistor r=27.3797 //w=0.187 //l=0.4 //layer=li //thickness=0.1 \
 //x=3.8 //y=1.585 //x2=3.4 //y2=1.585
r85 (  1 29 ) resistor r=3.57586 //w=0.17 //l=0.125 //layer=li //thickness=0.1 \
 //x=2.915 //y=1.5 //x2=2.915 //y2=1.625
r86 (  1 29 ) resistor r=42.0963 //w=0.187 //l=0.615 //layer=li \
 //thickness=0.1 //x=2.915 //y=1.5 //x2=2.915 //y2=0.885
ends PM_XOR2X1_PCELL\%noxref_10

subckt PM_XOR2X1_PCELL\%noxref_11 ( 1 5 9 10 13 17 29 )
c67 ( 29 0 ) capacitor c=0.0670706f //x=6.11 //y=0.37
c68 ( 17 0 ) capacitor c=0.0071081f //x=8.185 //y=0.62
c69 ( 13 0 ) capacitor c=0.0160456f //x=8.1 //y=0.535
c70 ( 10 0 ) capacitor c=0.00742709f //x=7.215 //y=1.5
c71 ( 9 0 ) capacitor c=0.00771051f //x=7.215 //y=0.62
c72 ( 5 0 ) capacitor c=0.0183314f //x=7.13 //y=1.585
c73 ( 1 0 ) capacitor c=0.00772931f //x=6.245 //y=1.5
r74 (  17 29 ) resistor r=3.57586 //w=0.17 //l=0.125 //layer=li \
 //thickness=0.1 //x=8.185 //y=0.62 //x2=8.185 //y2=0.495
r75 (  17 29 ) resistor r=18.139 //w=0.187 //l=0.265 //layer=li \
 //thickness=0.1 //x=8.185 //y=0.62 //x2=8.185 //y2=0.885
r76 (  14 29 ) resistor r=3.57586 //w=0.17 //l=0.103078 //layer=li \
 //thickness=0.1 //x=7.3 //y=0.535 //x2=7.215 //y2=0.495
r77 (  14 29 ) resistor r=27.3797 //w=0.187 //l=0.4 //layer=li //thickness=0.1 \
 //x=7.3 //y=0.535 //x2=7.7 //y2=0.535
r78 (  13 29 ) resistor r=3.57586 //w=0.17 //l=0.103078 //layer=li \
 //thickness=0.1 //x=8.1 //y=0.535 //x2=8.185 //y2=0.495
r79 (  13 29 ) resistor r=27.3797 //w=0.187 //l=0.4 //layer=li //thickness=0.1 \
 //x=8.1 //y=0.535 //x2=7.7 //y2=0.535
r80 (  10 29 ) resistor r=3.57586 //w=0.17 //l=0.125 //layer=li \
 //thickness=0.1 //x=7.215 //y=1.5 //x2=7.215 //y2=1.625
r81 (  10 29 ) resistor r=42.0963 //w=0.187 //l=0.615 //layer=li \
 //thickness=0.1 //x=7.215 //y=1.5 //x2=7.215 //y2=0.885
r82 (  9 29 ) resistor r=3.57586 //w=0.17 //l=0.125 //layer=li //thickness=0.1 \
 //x=7.215 //y=0.62 //x2=7.215 //y2=0.495
r83 (  9 29 ) resistor r=18.139 //w=0.187 //l=0.265 //layer=li //thickness=0.1 \
 //x=7.215 //y=0.62 //x2=7.215 //y2=0.885
r84 (  6 29 ) resistor r=3.57586 //w=0.17 //l=0.103078 //layer=li \
 //thickness=0.1 //x=6.33 //y=1.585 //x2=6.245 //y2=1.625
r85 (  6 29 ) resistor r=27.3797 //w=0.187 //l=0.4 //layer=li //thickness=0.1 \
 //x=6.33 //y=1.585 //x2=6.73 //y2=1.585
r86 (  5 29 ) resistor r=3.57586 //w=0.17 //l=0.103078 //layer=li \
 //thickness=0.1 //x=7.13 //y=1.585 //x2=7.215 //y2=1.625
r87 (  5 29 ) resistor r=27.3797 //w=0.187 //l=0.4 //layer=li //thickness=0.1 \
 //x=7.13 //y=1.585 //x2=6.73 //y2=1.585
r88 (  1 29 ) resistor r=3.57586 //w=0.17 //l=0.125 //layer=li //thickness=0.1 \
 //x=6.245 //y=1.5 //x2=6.245 //y2=1.625
r89 (  1 29 ) resistor r=42.0963 //w=0.187 //l=0.615 //layer=li \
 //thickness=0.1 //x=6.245 //y=1.5 //x2=6.245 //y2=0.885
ends PM_XOR2X1_PCELL\%noxref_11
