// File: dffrnx1_pcell.spi.DFFRNX1_PCELL.pxi
// Created: Thu Jan 22 07:12:41 2026
//
simulator lang=spectre
x_PM_DFFRNX1_PCELL\%noxref_1 ( N_noxref_1_c_24_p N_noxref_1_c_27_p \
 N_noxref_1_c_28_p N_noxref_1_c_29_p N_noxref_1_c_143_p N_noxref_1_c_186_p \
 N_noxref_1_c_8_p N_noxref_1_c_9_p N_noxref_1_c_16_p N_noxref_1_c_2_p \
 N_noxref_1_c_3_p N_noxref_1_c_87_p N_noxref_1_c_155_p N_noxref_1_c_121_p \
 N_noxref_1_c_6_p N_noxref_1_c_5_p N_noxref_1_c_10_p N_noxref_1_c_30_p \
 N_noxref_1_c_39_p N_noxref_1_c_40_p N_noxref_1_c_156_p N_noxref_1_c_164_p \
 N_noxref_1_c_17_p N_noxref_1_c_176_p N_noxref_1_c_11_p N_noxref_1_c_7_p \
 N_noxref_1_c_43_p N_noxref_1_c_31_p N_noxref_1_c_99_p N_noxref_1_c_110_p \
 N_noxref_1_c_108_p N_noxref_1_c_123_p N_noxref_1_c_112_p N_noxref_1_c_18_p \
 N_noxref_1_c_25_p N_noxref_1_c_34_p N_noxref_1_c_142_p N_noxref_1_c_284_p \
 N_noxref_1_c_167_p N_noxref_1_c_180_p N_noxref_1_c_12_p \
 N_noxref_1_M2_noxref_g N_noxref_1_M6_noxref_g N_noxref_1_M20_noxref_g \
 N_noxref_1_M21_noxref_g N_noxref_1_M28_noxref_g N_noxref_1_M29_noxref_g \
 N_noxref_1_c_55_p N_noxref_1_c_56_p N_noxref_1_c_57_p N_noxref_1_c_78_p \
 N_noxref_1_c_79_p N_noxref_1_c_80_p N_noxref_1_c_81_p N_noxref_1_c_258_p \
 N_noxref_1_c_259_p N_noxref_1_c_261_p N_noxref_1_c_236_p N_noxref_1_c_384_p \
 N_noxref_1_c_385_p N_noxref_1_c_260_p N_noxref_1_c_262_p N_noxref_1_c_26_p \
 N_noxref_1_c_61_p N_noxref_1_c_35_p N_noxref_1_c_15_p N_noxref_1_M5_noxref_d \
 N_noxref_1_M22_noxref_d N_noxref_1_M24_noxref_d N_noxref_1_M26_noxref_d )  \
 PM_DFFRNX1_PCELL\%noxref_1
x_PM_DFFRNX1_PCELL\%noxref_2 ( N_noxref_2_c_430_n N_noxref_2_c_431_n \
 N_noxref_2_c_559_p N_noxref_2_c_537_p N_noxref_2_c_432_n N_noxref_2_c_433_n \
 N_noxref_2_c_499_p N_noxref_2_c_435_n N_noxref_2_c_453_p N_noxref_2_c_458_p \
 N_noxref_2_c_459_p N_noxref_2_c_460_p N_noxref_2_c_437_n N_noxref_2_c_472_p \
 N_noxref_2_c_594_p N_noxref_2_c_445_n N_noxref_2_c_446_n N_noxref_2_c_461_p \
 N_noxref_2_c_447_n N_noxref_2_c_462_p N_noxref_2_c_504_p N_noxref_2_c_448_n \
 N_noxref_2_c_558_p N_noxref_2_c_454_p N_noxref_2_c_465_p \
 N_noxref_2_M8_noxref_g N_noxref_2_M32_noxref_g N_noxref_2_M33_noxref_g \
 N_noxref_2_c_484_p N_noxref_2_c_485_p N_noxref_2_c_487_p N_noxref_2_c_455_p \
 N_noxref_2_c_644_p N_noxref_2_c_657_p N_noxref_2_c_486_p N_noxref_2_c_488_p \
 N_noxref_2_c_466_p N_noxref_2_c_467_p N_noxref_2_M7_noxref_d \
 N_noxref_2_M28_noxref_d N_noxref_2_M30_noxref_d )  PM_DFFRNX1_PCELL\%noxref_2
x_PM_DFFRNX1_PCELL\%noxref_3 ( N_noxref_3_c_702_n N_noxref_3_c_705_n \
 N_noxref_3_c_743_n N_noxref_3_c_746_n N_noxref_3_c_711_n N_noxref_3_c_754_n \
 N_noxref_3_c_714_n N_noxref_3_c_760_n N_noxref_3_c_722_n N_noxref_3_c_723_n \
 N_noxref_3_c_727_n N_noxref_3_c_763_n N_noxref_3_c_767_n \
 N_noxref_3_M1_noxref_g N_noxref_3_M9_noxref_g N_noxref_3_M18_noxref_g \
 N_noxref_3_M19_noxref_g N_noxref_3_M34_noxref_g N_noxref_3_M35_noxref_g \
 N_noxref_3_c_912_p N_noxref_3_c_914_p N_noxref_3_c_950_p N_noxref_3_c_951_p \
 N_noxref_3_c_733_n N_noxref_3_c_734_n N_noxref_3_c_735_n N_noxref_3_c_736_n \
 N_noxref_3_c_740_n N_noxref_3_c_774_n N_noxref_3_c_777_n N_noxref_3_c_966_p \
 N_noxref_3_c_967_p N_noxref_3_c_779_n N_noxref_3_c_780_n N_noxref_3_c_781_n \
 N_noxref_3_c_782_n N_noxref_3_c_853_p N_noxref_3_c_741_n N_noxref_3_c_785_n ) \
 PM_DFFRNX1_PCELL\%noxref_3
x_PM_DFFRNX1_PCELL\%noxref_4 ( N_noxref_4_c_1097_n N_noxref_4_c_996_n \
 N_noxref_4_c_998_n N_noxref_4_c_1001_n N_noxref_4_c_1006_n \
 N_noxref_4_c_1013_n N_noxref_4_c_1018_n N_noxref_4_c_1022_n \
 N_noxref_4_c_1024_n N_noxref_4_c_1034_n N_noxref_4_c_1036_n \
 N_noxref_4_c_1039_n N_noxref_4_c_1040_n N_noxref_4_c_1044_n \
 N_noxref_4_c_1045_n N_noxref_4_c_1136_p N_noxref_4_c_1133_p \
 N_noxref_4_c_1141_p N_noxref_4_c_1134_p N_noxref_4_c_1207_p \
 N_noxref_4_c_1108_n N_noxref_4_c_1046_n N_noxref_4_c_1049_n \
 N_noxref_4_c_1327_p N_noxref_4_c_1143_p N_noxref_4_c_1050_n \
 N_noxref_4_c_1052_n N_noxref_4_c_1055_n N_noxref_4_c_1059_n \
 N_noxref_4_c_1063_n N_noxref_4_c_1085_n N_noxref_4_c_1088_n \
 N_noxref_4_c_1091_n N_noxref_4_c_1095_n N_noxref_4_c_1125_n \
 N_noxref_4_c_1144_p N_noxref_4_c_1065_n N_noxref_4_c_1236_p \
 N_noxref_4_c_1126_n N_noxref_4_c_1067_n N_noxref_4_c_1320_p \
 N_noxref_4_c_1276_p N_noxref_4_c_1138_p N_noxref_4_c_1145_p \
 N_noxref_4_M3_noxref_g N_noxref_4_M11_noxref_g N_noxref_4_M22_noxref_g \
 N_noxref_4_M23_noxref_g N_noxref_4_M38_noxref_g N_noxref_4_M39_noxref_g \
 N_noxref_4_c_1344_p N_noxref_4_c_1345_p N_noxref_4_c_1347_p \
 N_noxref_4_c_1321_p N_noxref_4_c_1373_p N_noxref_4_c_1386_p \
 N_noxref_4_c_1346_p N_noxref_4_c_1348_p N_noxref_4_c_1077_n \
 N_noxref_4_c_1277_p N_noxref_4_c_1176_p N_noxref_4_c_1177_p \
 N_noxref_4_c_1179_p N_noxref_4_c_1139_p N_noxref_4_c_1376_p \
 N_noxref_4_c_1396_p N_noxref_4_c_1178_p N_noxref_4_c_1180_p \
 N_noxref_4_c_1146_p N_noxref_4_c_1147_p N_noxref_4_M2_noxref_d \
 N_noxref_4_M16_noxref_d N_noxref_4_M18_noxref_d N_noxref_4_M20_noxref_d )  \
 PM_DFFRNX1_PCELL\%noxref_4
x_PM_DFFRNX1_PCELL\%noxref_5 ( N_noxref_5_c_1453_n N_noxref_5_c_1457_n \
 N_noxref_5_c_1529_n N_noxref_5_c_1515_n N_noxref_5_c_1567_n \
 N_noxref_5_c_1571_n N_noxref_5_c_1467_n N_noxref_5_c_1470_n \
 N_noxref_5_c_1541_n N_noxref_5_c_1589_n N_noxref_5_c_1591_n \
 N_noxref_5_c_1480_n N_noxref_5_c_1481_n N_noxref_5_c_1542_n \
 N_noxref_5_c_1545_n N_noxref_5_c_1597_n N_noxref_5_c_1600_n \
 N_noxref_5_M5_noxref_g N_noxref_5_M10_noxref_g N_noxref_5_M12_noxref_g \
 N_noxref_5_M26_noxref_g N_noxref_5_M27_noxref_g N_noxref_5_M36_noxref_g \
 N_noxref_5_M37_noxref_g N_noxref_5_M40_noxref_g N_noxref_5_M41_noxref_g \
 N_noxref_5_c_1491_n N_noxref_5_c_1493_n N_noxref_5_c_1496_n \
 N_noxref_5_c_1497_n N_noxref_5_c_1499_n N_noxref_5_c_1503_n \
 N_noxref_5_c_1505_n N_noxref_5_c_1551_n N_noxref_5_c_1552_n \
 N_noxref_5_c_1553_n N_noxref_5_c_1634_p N_noxref_5_c_1635_p \
 N_noxref_5_c_1636_p N_noxref_5_c_1637_p N_noxref_5_c_1607_n \
 N_noxref_5_c_1610_n N_noxref_5_c_1764_p N_noxref_5_c_1765_p \
 N_noxref_5_c_1612_n N_noxref_5_c_1613_n N_noxref_5_c_1614_n \
 N_noxref_5_c_1615_n N_noxref_5_c_1799_p N_noxref_5_c_1509_n \
 N_noxref_5_c_1510_n N_noxref_5_c_1512_n N_noxref_5_c_1554_n \
 N_noxref_5_c_1556_n N_noxref_5_c_1557_n N_noxref_5_c_1618_n )  \
 PM_DFFRNX1_PCELL\%noxref_5
x_PM_DFFRNX1_PCELL\%noxref_6 ( N_noxref_6_c_1984_n N_noxref_6_c_1862_n \
 N_noxref_6_c_1989_n N_noxref_6_c_1864_n N_noxref_6_c_1865_n \
 N_noxref_6_c_1873_n N_noxref_6_c_1874_n N_noxref_6_c_1932_n \
 N_noxref_6_c_2004_n N_noxref_6_c_2111_n N_noxref_6_c_2113_n \
 N_noxref_6_c_2117_n N_noxref_6_c_1933_n N_noxref_6_c_2130_n \
 N_noxref_6_c_1934_n N_noxref_6_c_2005_n N_noxref_6_c_2068_n \
 N_noxref_6_c_2006_n N_noxref_6_c_2279_p N_noxref_6_c_2295_p \
 N_noxref_6_c_2280_p N_noxref_6_c_2007_n N_noxref_6_c_1879_n \
 N_noxref_6_c_1880_n N_noxref_6_c_1937_n N_noxref_6_c_2009_n \
 N_noxref_6_c_2147_n N_noxref_6_c_2151_n N_noxref_6_c_2209_p \
 N_noxref_6_c_2286_p N_noxref_6_c_1883_n N_noxref_6_c_1887_n \
 N_noxref_6_c_1888_n N_noxref_6_c_1889_n N_noxref_6_c_1942_n \
 N_noxref_6_c_1890_n N_noxref_6_c_2097_n N_noxref_6_c_2099_n \
 N_noxref_6_c_2026_n N_noxref_6_c_2027_n N_noxref_6_c_2031_n \
 N_noxref_6_c_1894_n N_noxref_6_c_1898_n N_noxref_6_c_1949_n \
 N_noxref_6_c_2034_n N_noxref_6_c_2162_n N_noxref_6_c_2288_p \
 N_noxref_6_c_2210_p N_noxref_6_M0_noxref_g N_noxref_6_M7_noxref_g \
 N_noxref_6_M15_noxref_g N_noxref_6_M16_noxref_g N_noxref_6_M17_noxref_g \
 N_noxref_6_M30_noxref_g N_noxref_6_M31_noxref_g N_noxref_6_M46_noxref_g \
 N_noxref_6_M47_noxref_g N_noxref_6_c_2041_n N_noxref_6_c_2042_n \
 N_noxref_6_c_2043_n N_noxref_6_c_2044_n N_noxref_6_c_2327_p \
 N_noxref_6_c_2342_p N_noxref_6_c_2047_n N_noxref_6_c_2049_n \
 N_noxref_6_c_2052_n N_noxref_6_c_2055_n N_noxref_6_c_1904_n \
 N_noxref_6_c_1907_n N_noxref_6_c_1909_n N_noxref_6_c_1964_n \
 N_noxref_6_c_1967_n N_noxref_6_c_1969_n N_noxref_6_c_1912_n \
 N_noxref_6_c_1913_n N_noxref_6_c_2310_p N_noxref_6_c_2312_p \
 N_noxref_6_c_2313_p N_noxref_6_c_2211_p N_noxref_6_c_2402_p \
 N_noxref_6_c_2379_p N_noxref_6_c_2319_p N_noxref_6_c_2322_p \
 N_noxref_6_c_1914_n N_noxref_6_c_1980_n N_noxref_6_c_1917_n \
 N_noxref_6_c_2289_p N_noxref_6_c_2381_p N_noxref_6_c_2212_p \
 N_noxref_6_M10_noxref_d N_noxref_6_M32_noxref_d N_noxref_6_M34_noxref_d \
 N_noxref_6_M36_noxref_d )  PM_DFFRNX1_PCELL\%noxref_6
x_PM_DFFRNX1_PCELL\%noxref_7 ( N_noxref_7_c_2451_n N_noxref_7_c_2586_n \
 N_noxref_7_c_2588_n N_noxref_7_c_2560_n N_noxref_7_c_2464_n \
 N_noxref_7_c_2599_n N_noxref_7_c_2466_n N_noxref_7_c_2469_n \
 N_noxref_7_c_2473_n N_noxref_7_c_2477_n N_noxref_7_c_2478_n \
 N_noxref_7_c_2522_n N_noxref_7_c_2527_n N_noxref_7_c_2562_n \
 N_noxref_7_c_2641_n N_noxref_7_c_2688_n N_noxref_7_c_2602_n \
 N_noxref_7_c_2643_n N_noxref_7_c_2749_p N_noxref_7_c_2768_p \
 N_noxref_7_c_2794_p N_noxref_7_c_2689_n N_noxref_7_c_2691_n \
 N_noxref_7_c_2481_n N_noxref_7_c_2485_n N_noxref_7_c_2532_n \
 N_noxref_7_c_2610_n N_noxref_7_c_2712_n N_noxref_7_M16_noxref_s \
 N_noxref_7_M17_noxref_d N_noxref_7_M19_noxref_d N_noxref_7_M21_noxref_d \
 N_noxref_7_M22_noxref_s N_noxref_7_M23_noxref_d N_noxref_7_M25_noxref_d \
 N_noxref_7_M27_noxref_d N_noxref_7_M28_noxref_s N_noxref_7_M29_noxref_d \
 N_noxref_7_M31_noxref_d N_noxref_7_M32_noxref_s N_noxref_7_M33_noxref_d \
 N_noxref_7_M35_noxref_d N_noxref_7_M37_noxref_d N_noxref_7_M38_noxref_s \
 N_noxref_7_M39_noxref_d N_noxref_7_M41_noxref_d N_noxref_7_M43_noxref_d \
 N_noxref_7_M44_noxref_s N_noxref_7_M45_noxref_d N_noxref_7_M47_noxref_d )  \
 PM_DFFRNX1_PCELL\%noxref_7
x_PM_DFFRNX1_PCELL\%noxref_8 ( N_noxref_8_c_2854_n N_noxref_8_c_2881_p \
 N_noxref_8_c_2844_n N_noxref_8_c_2883_p N_noxref_8_c_2849_n \
 N_noxref_8_M1_noxref_d N_noxref_8_M2_noxref_s )  PM_DFFRNX1_PCELL\%noxref_8
x_PM_DFFRNX1_PCELL\%noxref_9 ( N_noxref_9_c_2938_p N_noxref_9_c_2948_p \
 N_noxref_9_c_2908_n N_noxref_9_c_2950_p N_noxref_9_c_2911_n \
 N_noxref_9_M4_noxref_d N_noxref_9_M5_noxref_s )  PM_DFFRNX1_PCELL\%noxref_9
x_PM_DFFRNX1_PCELL\%noxref_10 ( N_noxref_10_c_2975_n N_noxref_10_c_2976_n \
 N_noxref_10_c_3008_n N_noxref_10_c_2982_n N_noxref_10_M4_noxref_g \
 N_noxref_10_M24_noxref_g N_noxref_10_M25_noxref_g N_noxref_10_c_3019_n \
 N_noxref_10_c_3022_n N_noxref_10_c_3071_n N_noxref_10_c_3072_n \
 N_noxref_10_c_3024_n N_noxref_10_c_3025_n N_noxref_10_c_3026_n \
 N_noxref_10_c_3027_n N_noxref_10_c_2990_n N_noxref_10_c_2992_n )  \
 PM_DFFRNX1_PCELL\%noxref_10
x_PM_DFFRNX1_PCELL\%noxref_11 ( N_noxref_11_c_3093_n N_noxref_11_c_3134_p \
 N_noxref_11_c_3109_n N_noxref_11_c_3136_p N_noxref_11_c_3114_n \
 N_noxref_11_M9_noxref_d N_noxref_11_M10_noxref_s )  PM_DFFRNX1_PCELL\%noxref_11
x_PM_DFFRNX1_PCELL\%noxref_12 ( N_noxref_12_c_3161_n N_noxref_12_c_3200_p \
 N_noxref_12_c_3179_p N_noxref_12_c_3202_p N_noxref_12_c_3183_p \
 N_noxref_12_M12_noxref_d N_noxref_12_M13_noxref_s )  \
 PM_DFFRNX1_PCELL\%noxref_12
x_PM_DFFRNX1_PCELL\%noxref_13 ( N_noxref_13_c_3229_n N_noxref_13_c_3227_n \
 N_noxref_13_c_3238_n N_noxref_13_c_3241_n N_noxref_13_M13_noxref_g \
 N_noxref_13_M42_noxref_g N_noxref_13_M43_noxref_g N_noxref_13_c_3247_n \
 N_noxref_13_c_3248_n N_noxref_13_c_3249_n N_noxref_13_c_3284_p \
 N_noxref_13_c_3285_p N_noxref_13_c_3272_n N_noxref_13_c_3274_n \
 N_noxref_13_c_3250_n N_noxref_13_c_3253_n N_noxref_13_c_3254_n )  \
 PM_DFFRNX1_PCELL\%noxref_13
x_PM_DFFRNX1_PCELL\%noxref_14 ( N_noxref_14_c_3321_n N_noxref_14_c_3333_n \
 N_noxref_14_c_3361_n N_noxref_14_c_3344_n N_noxref_14_c_3393_n \
 N_noxref_14_c_3396_n N_noxref_14_c_3397_n N_noxref_14_c_3345_n \
 N_noxref_14_c_3334_n N_noxref_14_c_3322_n N_noxref_14_c_3335_n \
 N_noxref_14_c_3427_n N_noxref_14_c_3325_n N_noxref_14_c_3340_n \
 N_noxref_14_c_3387_n N_noxref_14_M13_noxref_d N_noxref_14_M38_noxref_d \
 N_noxref_14_M40_noxref_d N_noxref_14_M42_noxref_d )  \
 PM_DFFRNX1_PCELL\%noxref_14
x_PM_DFFRNX1_PCELL\%noxref_15 ( N_noxref_15_c_3457_n N_noxref_15_c_3461_n \
 N_noxref_15_c_3465_n N_noxref_15_c_3471_n N_noxref_15_c_3475_n \
 N_noxref_15_M14_noxref_g N_noxref_15_M44_noxref_g N_noxref_15_M45_noxref_g \
 N_noxref_15_c_3481_n N_noxref_15_c_3482_n N_noxref_15_c_3483_n \
 N_noxref_15_c_3485_n N_noxref_15_c_3517_p N_noxref_15_c_3518_p \
 N_noxref_15_c_3489_n N_noxref_15_c_3491_n N_noxref_15_c_3494_n )  \
 PM_DFFRNX1_PCELL\%noxref_15
x_PM_DFFRNX1_PCELL\%noxref_16 ( N_noxref_16_c_3891_p N_noxref_16_c_3727_n \
 N_noxref_16_c_3560_n N_noxref_16_c_3647_n N_noxref_16_c_3561_n \
 N_noxref_16_c_3600_n N_noxref_16_c_3604_n N_noxref_16_c_3642_n \
 N_noxref_16_c_3650_n N_noxref_16_c_3712_n N_noxref_16_c_3734_n \
 N_noxref_16_c_3736_n N_noxref_16_c_3653_n N_noxref_16_c_3565_n \
 N_noxref_16_c_3575_n N_noxref_16_c_3610_n N_noxref_16_c_3664_n \
 N_noxref_16_c_3852_n N_noxref_16_c_3865_n N_noxref_16_c_3578_n \
 N_noxref_16_c_3748_n N_noxref_16_c_3579_n N_noxref_16_c_3581_n \
 N_noxref_16_c_3623_n N_noxref_16_c_3676_n N_noxref_16_c_3755_n \
 N_noxref_16_c_3582_n N_noxref_16_c_3585_n N_noxref_16_c_3625_n \
 N_noxref_16_c_3684_n N_noxref_16_c_3764_n N_noxref_16_M0_noxref_d \
 N_noxref_16_M3_noxref_d N_noxref_16_M6_noxref_d N_noxref_16_M8_noxref_d \
 N_noxref_16_M11_noxref_d N_noxref_16_M14_noxref_d )  \
 PM_DFFRNX1_PCELL\%noxref_16
x_PM_DFFRNX1_PCELL\%noxref_17 ( N_noxref_17_c_4015_n N_noxref_17_c_4021_n \
 N_noxref_17_c_4026_n N_noxref_17_c_4027_n N_noxref_17_c_4093_n \
 N_noxref_17_c_4029_n N_noxref_17_c_4040_n N_noxref_17_c_4041_n \
 N_noxref_17_c_4077_n N_noxref_17_c_4044_n N_noxref_17_c_4082_n \
 N_noxref_17_c_4050_n N_noxref_17_M15_noxref_d N_noxref_17_M44_noxref_d \
 N_noxref_17_M46_noxref_d )  PM_DFFRNX1_PCELL\%noxref_17
x_PM_DFFRNX1_PCELL\%noxref_18 ( N_noxref_18_c_4138_n N_noxref_18_c_4139_n \
 N_noxref_18_c_4150_n N_noxref_18_c_4128_n N_noxref_18_c_4130_n \
 N_noxref_18_M0_noxref_s )  PM_DFFRNX1_PCELL\%noxref_18
x_PM_DFFRNX1_PCELL\%noxref_19 ( N_noxref_19_c_4180_n N_noxref_19_c_4181_n \
 N_noxref_19_c_4199_n N_noxref_19_c_4200_n N_noxref_19_c_4183_n \
 N_noxref_19_M3_noxref_s )  PM_DFFRNX1_PCELL\%noxref_19
x_PM_DFFRNX1_PCELL\%noxref_20 ( N_noxref_20_c_4238_n N_noxref_20_c_4239_n \
 N_noxref_20_c_4284_n N_noxref_20_c_4246_n N_noxref_20_c_4251_n \
 N_noxref_20_c_4293_n N_noxref_20_M6_noxref_s )  PM_DFFRNX1_PCELL\%noxref_20
x_PM_DFFRNX1_PCELL\%noxref_21 ( N_noxref_21_c_4306_n N_noxref_21_c_4307_n \
 N_noxref_21_c_4332_n N_noxref_21_c_4318_n N_noxref_21_c_4320_n \
 N_noxref_21_M8_noxref_s )  PM_DFFRNX1_PCELL\%noxref_21
x_PM_DFFRNX1_PCELL\%noxref_22 ( N_noxref_22_c_4365_n N_noxref_22_c_4366_n \
 N_noxref_22_c_4392_n N_noxref_22_c_4379_n N_noxref_22_c_4381_n \
 N_noxref_22_M11_noxref_s )  PM_DFFRNX1_PCELL\%noxref_22
x_PM_DFFRNX1_PCELL\%noxref_23 ( N_noxref_23_c_4436_n N_noxref_23_c_4437_n \
 N_noxref_23_c_4452_n N_noxref_23_c_4422_n N_noxref_23_c_4426_n \
 N_noxref_23_c_4459_n N_noxref_23_M14_noxref_s )  PM_DFFRNX1_PCELL\%noxref_23
cc_1 ( N_noxref_1_M29_noxref_g N_noxref_2_c_430_n ) capacitor c=0.00889217f \
 //x=11.07 //y=6.02 //x2=11.615 //y2=5.2
cc_2 ( N_noxref_1_c_2_p N_noxref_2_c_431_n ) capacitor c=0.00326079f //x=8.395 \
 //y=1.58 //x2=11.77 //y2=1.57
cc_3 ( N_noxref_1_c_3_p N_noxref_2_c_432_n ) capacitor c=0.00218808f //x=8.795 \
 //y=1.665 //x2=11.855 //y2=1.655
cc_4 ( N_noxref_1_c_3_p N_noxref_2_c_433_n ) capacitor c=0.00203766f //x=8.795 \
 //y=1.665 //x2=12.21 //y2=3.175
cc_5 ( N_noxref_1_c_5_p N_noxref_2_c_433_n ) capacitor c=0.00286284f //x=10.73 \
 //y=3.17 //x2=12.21 //y2=3.175
cc_6 ( N_noxref_1_c_6_p N_noxref_2_c_435_n ) capacitor c=0.0028534f //x=8.88 \
 //y=5.07 //x2=12.21 //y2=5.115
cc_7 ( N_noxref_1_c_7_p N_noxref_2_c_435_n ) capacitor c=0.00196578f \
 //x=10.732 //y=4.56 //x2=12.21 //y2=5.115
cc_8 ( N_noxref_1_c_8_p N_noxref_2_c_437_n ) capacitor c=5.58535e-19 //x=8.1 \
 //y=5.38 //x2=10.85 //y2=5.38
cc_9 ( N_noxref_1_c_9_p N_noxref_2_c_437_n ) capacitor c=0.00104762f //x=8.795 \
 //y=5.155 //x2=10.85 //y2=5.38
cc_10 ( N_noxref_1_c_10_p N_noxref_2_c_437_n ) capacitor c=6.37679e-19 \
 //x=10.73 //y=3.49 //x2=10.85 //y2=5.38
cc_11 ( N_noxref_1_c_11_p N_noxref_2_c_437_n ) capacitor c=0.0117744f \
 //x=10.73 //y=4.7 //x2=10.85 //y2=5.38
cc_12 ( N_noxref_1_c_12_p N_noxref_2_c_437_n ) capacitor c=0.00277154f \
 //x=10.73 //y=4.7 //x2=10.85 //y2=5.38
cc_13 ( N_noxref_1_M28_noxref_g N_noxref_2_c_437_n ) capacitor c=0.00201806f \
 //x=10.63 //y=6.02 //x2=10.85 //y2=5.38
cc_14 ( N_noxref_1_M29_noxref_g N_noxref_2_c_437_n ) capacitor c=0.00192712f \
 //x=11.07 //y=6.02 //x2=10.85 //y2=5.38
cc_15 ( N_noxref_1_c_15_p N_noxref_2_c_437_n ) capacitor c=0.00192702f \
 //x=10.73 //y=4.7 //x2=10.85 //y2=5.38
cc_16 ( N_noxref_1_c_16_p N_noxref_2_c_445_n ) capacitor c=6.5615e-19 \
 //x=8.395 //y=1.125 //x2=11.77 //y2=1
cc_17 ( N_noxref_1_c_17_p N_noxref_2_c_446_n ) capacitor c=0.00251357f \
 //x=10.73 //y=3.33 //x2=12.21 //y2=3.33
cc_18 ( N_noxref_1_c_18_p N_noxref_2_c_447_n ) capacitor c=0.00526461f \
 //x=10.73 //y=3.33 //x2=12.37 //y2=3.335
cc_19 ( N_noxref_1_c_11_p N_noxref_2_c_448_n ) capacitor c=0.00104426f \
 //x=10.73 //y=4.7 //x2=10.85 //y2=5.38
cc_20 ( N_noxref_1_c_12_p N_noxref_2_c_448_n ) capacitor c=0.00377369f \
 //x=10.73 //y=4.7 //x2=10.85 //y2=5.38
cc_21 ( N_noxref_1_M28_noxref_g N_noxref_2_c_448_n ) capacitor c=0.0158358f \
 //x=10.63 //y=6.02 //x2=10.85 //y2=5.38
cc_22 ( N_noxref_1_M29_noxref_g N_noxref_2_c_448_n ) capacitor c=0.0178987f \
 //x=11.07 //y=6.02 //x2=10.85 //y2=5.38
cc_23 ( N_noxref_1_c_15_p N_noxref_2_c_448_n ) capacitor c=0.0043218f \
 //x=10.73 //y=4.7 //x2=10.85 //y2=5.38
cc_24 ( N_noxref_1_c_24_p N_noxref_3_c_702_n ) capacitor c=0.0116288f //x=3.33 \
 //y=2.195 //x2=2.22 //y2=2.195
cc_25 ( N_noxref_1_c_25_p N_noxref_3_c_702_n ) capacitor c=5.42289e-19 \
 //x=3.33 //y=2.08 //x2=2.22 //y2=2.195
cc_26 ( N_noxref_1_c_26_p N_noxref_3_c_702_n ) capacitor c=0.00139071f \
 //x=3.33 //y=2.08 //x2=2.22 //y2=2.195
cc_27 ( N_noxref_1_c_27_p N_noxref_3_c_705_n ) capacitor c=0.029075f //x=3.33 \
 //y=3.17 //x2=2.22 //y2=4.495
cc_28 ( N_noxref_1_c_28_p N_noxref_3_c_705_n ) capacitor c=0.00775314f \
 //x=3.33 //y=3.49 //x2=2.22 //y2=4.495
cc_29 ( N_noxref_1_c_29_p N_noxref_3_c_705_n ) capacitor c=0.0245236f //x=3.33 \
 //y=4.57 //x2=2.22 //y2=4.495
cc_30 ( N_noxref_1_c_30_p N_noxref_3_c_705_n ) capacitor c=3.35971e-19 \
 //x=3.33 //y=3.33 //x2=2.22 //y2=4.495
cc_31 ( N_noxref_1_c_31_p N_noxref_3_c_705_n ) capacitor c=0.00508753f \
 //x=3.49 //y=3.33 //x2=2.22 //y2=4.495
cc_32 ( N_noxref_1_c_25_p N_noxref_3_c_705_n ) capacitor c=4.16726e-19 \
 //x=3.33 //y=2.08 //x2=2.22 //y2=4.495
cc_33 ( N_noxref_1_c_29_p N_noxref_3_c_711_n ) capacitor c=0.0082089f //x=3.33 \
 //y=4.57 //x2=2.215 //y2=4.655
cc_34 ( N_noxref_1_c_34_p N_noxref_3_c_711_n ) capacitor c=7.52809e-19 \
 //x=3.33 //y=4.7 //x2=2.215 //y2=4.655
cc_35 ( N_noxref_1_c_35_p N_noxref_3_c_711_n ) capacitor c=0.0013272f //x=3.33 \
 //y=4.7 //x2=2.215 //y2=4.655
cc_36 ( N_noxref_1_c_29_p N_noxref_3_c_714_n ) capacitor c=0.0290574f //x=3.33 \
 //y=4.57 //x2=11.09 //y2=4.44
cc_37 ( N_noxref_1_c_9_p N_noxref_3_c_714_n ) capacitor c=0.0221477f //x=8.795 \
 //y=5.155 //x2=11.09 //y2=4.44
cc_38 ( N_noxref_1_c_6_p N_noxref_3_c_714_n ) capacitor c=0.0300479f //x=8.88 \
 //y=5.07 //x2=11.09 //y2=4.44
cc_39 ( N_noxref_1_c_39_p N_noxref_3_c_714_n ) capacitor c=0.0298474f \
 //x=6.342 //y=5.155 //x2=11.09 //y2=4.44
cc_40 ( N_noxref_1_c_40_p N_noxref_3_c_714_n ) capacitor c=0.040089f //x=7.22 \
 //y=5.155 //x2=11.09 //y2=4.44
cc_41 ( N_noxref_1_c_11_p N_noxref_3_c_714_n ) capacitor c=0.00404699f \
 //x=10.73 //y=4.7 //x2=11.09 //y2=4.44
cc_42 ( N_noxref_1_c_7_p N_noxref_3_c_714_n ) capacitor c=0.0269932f \
 //x=10.732 //y=4.56 //x2=11.09 //y2=4.44
cc_43 ( N_noxref_1_c_43_p N_noxref_3_c_714_n ) capacitor c=0.0021208f //x=3.69 \
 //y=3.33 //x2=11.09 //y2=4.44
cc_44 ( N_noxref_1_c_29_p N_noxref_3_c_722_n ) capacitor c=0.00655852f \
 //x=3.33 //y=4.57 //x2=2.215 //y2=4.44
cc_45 ( N_noxref_1_c_24_p N_noxref_3_c_723_n ) capacitor c=5.39999e-19 \
 //x=3.33 //y=2.195 //x2=2.22 //y2=2.08
cc_46 ( N_noxref_1_c_27_p N_noxref_3_c_723_n ) capacitor c=4.16726e-19 \
 //x=3.33 //y=3.17 //x2=2.22 //y2=2.08
cc_47 ( N_noxref_1_c_25_p N_noxref_3_c_723_n ) capacitor c=0.00125213f \
 //x=3.33 //y=2.08 //x2=2.22 //y2=2.08
cc_48 ( N_noxref_1_c_26_p N_noxref_3_c_723_n ) capacitor c=0.00204868f \
 //x=3.33 //y=2.08 //x2=2.22 //y2=2.08
cc_49 ( N_noxref_1_c_29_p N_noxref_3_c_727_n ) capacitor c=4.56604e-19 \
 //x=3.33 //y=4.57 //x2=2.22 //y2=4.7
cc_50 ( N_noxref_1_c_34_p N_noxref_3_c_727_n ) capacitor c=0.00113671f \
 //x=3.33 //y=4.7 //x2=2.22 //y2=4.7
cc_51 ( N_noxref_1_c_35_p N_noxref_3_c_727_n ) capacitor c=0.00186974f \
 //x=3.33 //y=4.7 //x2=2.22 //y2=4.7
cc_52 ( N_noxref_1_M20_noxref_g N_noxref_3_M18_noxref_g ) capacitor \
 c=0.0101598f //x=3.07 //y=6.02 //x2=2.19 //y2=6.02
cc_53 ( N_noxref_1_M20_noxref_g N_noxref_3_M19_noxref_g ) capacitor \
 c=0.0607518f //x=3.07 //y=6.02 //x2=2.63 //y2=6.02
cc_54 ( N_noxref_1_M21_noxref_g N_noxref_3_M19_noxref_g ) capacitor \
 c=0.0101598f //x=3.51 //y=6.02 //x2=2.63 //y2=6.02
cc_55 ( N_noxref_1_c_55_p N_noxref_3_c_733_n ) capacitor c=0.00456962f \
 //x=3.32 //y=0.915 //x2=2.31 //y2=0.91
cc_56 ( N_noxref_1_c_56_p N_noxref_3_c_734_n ) capacitor c=0.00438372f \
 //x=3.32 //y=1.26 //x2=2.31 //y2=1.22
cc_57 ( N_noxref_1_c_57_p N_noxref_3_c_735_n ) capacitor c=0.00438372f \
 //x=3.32 //y=1.57 //x2=2.31 //y2=1.45
cc_58 ( N_noxref_1_c_24_p N_noxref_3_c_736_n ) capacitor c=0.00141236f \
 //x=3.33 //y=2.195 //x2=2.31 //y2=1.915
cc_59 ( N_noxref_1_c_25_p N_noxref_3_c_736_n ) capacitor c=0.00209664f \
 //x=3.33 //y=2.08 //x2=2.31 //y2=1.915
cc_60 ( N_noxref_1_c_26_p N_noxref_3_c_736_n ) capacitor c=0.00933826f \
 //x=3.33 //y=2.08 //x2=2.31 //y2=1.915
cc_61 ( N_noxref_1_c_61_p N_noxref_3_c_736_n ) capacitor c=0.00438372f \
 //x=3.33 //y=1.915 //x2=2.31 //y2=1.915
cc_62 ( N_noxref_1_c_35_p N_noxref_3_c_740_n ) capacitor c=0.0616777f //x=3.33 \
 //y=4.7 //x2=2.555 //y2=4.79
cc_63 ( N_noxref_1_c_34_p N_noxref_3_c_741_n ) capacitor c=9.77556e-19 \
 //x=3.33 //y=4.7 //x2=2.22 //y2=4.7
cc_64 ( N_noxref_1_c_35_p N_noxref_3_c_741_n ) capacitor c=0.0042693f //x=3.33 \
 //y=4.7 //x2=2.22 //y2=4.7
cc_65 ( N_noxref_1_c_28_p N_noxref_4_c_996_n ) capacitor c=7.46501e-19 \
 //x=3.33 //y=3.49 //x2=3.175 //y2=5.155
cc_66 ( N_noxref_1_M20_noxref_g N_noxref_4_c_996_n ) capacitor c=0.00955829f \
 //x=3.07 //y=6.02 //x2=3.175 //y2=5.155
cc_67 ( N_noxref_1_c_39_p N_noxref_4_c_998_n ) capacitor c=6.09703e-19 \
 //x=6.342 //y=5.155 //x2=3.29 //y2=5.38
cc_68 ( N_noxref_1_M20_noxref_g N_noxref_4_c_998_n ) capacitor c=0.00226521f \
 //x=3.07 //y=6.02 //x2=3.29 //y2=5.38
cc_69 ( N_noxref_1_M21_noxref_g N_noxref_4_c_998_n ) capacitor c=0.00381703f \
 //x=3.51 //y=6.02 //x2=3.29 //y2=5.38
cc_70 ( N_noxref_1_c_28_p N_noxref_4_c_1001_n ) capacitor c=0.00109666f \
 //x=3.33 //y=3.49 //x2=3.985 //y2=5.155
cc_71 ( N_noxref_1_c_29_p N_noxref_4_c_1001_n ) capacitor c=0.00228791f \
 //x=3.33 //y=4.57 //x2=3.985 //y2=5.155
cc_72 ( N_noxref_1_c_39_p N_noxref_4_c_1001_n ) capacitor c=0.00306432f \
 //x=6.342 //y=5.155 //x2=3.985 //y2=5.155
cc_73 ( N_noxref_1_c_34_p N_noxref_4_c_1001_n ) capacitor c=0.00130631f \
 //x=3.33 //y=4.7 //x2=3.985 //y2=5.155
cc_74 ( N_noxref_1_M21_noxref_g N_noxref_4_c_1001_n ) capacitor c=0.0110526f \
 //x=3.51 //y=6.02 //x2=3.985 //y2=5.155
cc_75 ( N_noxref_1_c_28_p N_noxref_4_c_1006_n ) capacitor c=2.41711e-19 \
 //x=3.33 //y=3.49 //x2=3.585 //y2=1.125
cc_76 ( N_noxref_1_c_55_p N_noxref_4_c_1006_n ) capacitor c=4.64015e-19 \
 //x=3.32 //y=0.915 //x2=3.585 //y2=1.125
cc_77 ( N_noxref_1_c_56_p N_noxref_4_c_1006_n ) capacitor c=0.0026012f \
 //x=3.32 //y=1.26 //x2=3.585 //y2=1.125
cc_78 ( N_noxref_1_c_78_p N_noxref_4_c_1006_n ) capacitor c=5.29969e-19 \
 //x=3.695 //y=0.76 //x2=3.585 //y2=1.125
cc_79 ( N_noxref_1_c_79_p N_noxref_4_c_1006_n ) capacitor c=5.01408e-19 \
 //x=3.695 //y=1.415 //x2=3.585 //y2=1.125
cc_80 ( N_noxref_1_c_80_p N_noxref_4_c_1006_n ) capacitor c=5.24634e-19 \
 //x=3.85 //y=0.915 //x2=3.585 //y2=1.125
cc_81 ( N_noxref_1_c_81_p N_noxref_4_c_1006_n ) capacitor c=0.00307978f \
 //x=3.85 //y=1.26 //x2=3.585 //y2=1.125
cc_82 ( N_noxref_1_c_56_p N_noxref_4_c_1013_n ) capacitor c=0.00127432f \
 //x=3.32 //y=1.26 //x2=3.585 //y2=1.58
cc_83 ( N_noxref_1_c_57_p N_noxref_4_c_1013_n ) capacitor c=0.00429966f \
 //x=3.32 //y=1.57 //x2=3.585 //y2=1.58
cc_84 ( N_noxref_1_c_79_p N_noxref_4_c_1013_n ) capacitor c=0.00942306f \
 //x=3.695 //y=1.415 //x2=3.585 //y2=1.58
cc_85 ( N_noxref_1_c_81_p N_noxref_4_c_1013_n ) capacitor c=0.00363411f \
 //x=3.85 //y=1.26 //x2=3.585 //y2=1.58
cc_86 ( N_noxref_1_c_61_p N_noxref_4_c_1013_n ) capacitor c=0.00372124f \
 //x=3.33 //y=1.915 //x2=3.585 //y2=1.58
cc_87 ( N_noxref_1_c_87_p N_noxref_4_c_1018_n ) capacitor c=0.00163399f \
 //x=8.48 //y=1.665 //x2=3.985 //y2=1.665
cc_88 ( N_noxref_1_c_43_p N_noxref_4_c_1018_n ) capacitor c=0.0033552f \
 //x=3.69 //y=3.33 //x2=3.985 //y2=1.665
cc_89 ( N_noxref_1_c_79_p N_noxref_4_c_1018_n ) capacitor c=0.00194716f \
 //x=3.695 //y=1.415 //x2=3.985 //y2=1.665
cc_90 ( N_noxref_1_c_81_p N_noxref_4_c_1018_n ) capacitor c=0.00323576f \
 //x=3.85 //y=1.26 //x2=3.985 //y2=1.665
cc_91 ( N_noxref_1_c_28_p N_noxref_4_c_1022_n ) capacitor c=0.00112398f \
 //x=3.33 //y=3.49 //x2=3.67 //y2=1.665
cc_92 ( N_noxref_1_c_43_p N_noxref_4_c_1022_n ) capacitor c=0.00429262f \
 //x=3.69 //y=3.33 //x2=3.67 //y2=1.665
cc_93 ( N_noxref_1_c_24_p N_noxref_4_c_1024_n ) capacitor c=0.0154269f \
 //x=3.33 //y=2.195 //x2=4.07 //y2=3.545
cc_94 ( N_noxref_1_c_27_p N_noxref_4_c_1024_n ) capacitor c=0.0445642f \
 //x=3.33 //y=3.17 //x2=4.07 //y2=3.545
cc_95 ( N_noxref_1_c_28_p N_noxref_4_c_1024_n ) capacitor c=0.017295f //x=3.33 \
 //y=3.49 //x2=4.07 //y2=3.545
cc_96 ( N_noxref_1_c_29_p N_noxref_4_c_1024_n ) capacitor c=0.00245069f \
 //x=3.33 //y=4.57 //x2=4.07 //y2=3.545
cc_97 ( N_noxref_1_c_30_p N_noxref_4_c_1024_n ) capacitor c=6.78671e-19 \
 //x=3.33 //y=3.33 //x2=4.07 //y2=3.545
cc_98 ( N_noxref_1_c_31_p N_noxref_4_c_1024_n ) capacitor c=0.00313722f \
 //x=3.49 //y=3.33 //x2=4.07 //y2=3.545
cc_99 ( N_noxref_1_c_99_p N_noxref_4_c_1024_n ) capacitor c=0.027698f //x=4.29 \
 //y=3.32 //x2=4.07 //y2=3.545
cc_100 ( N_noxref_1_c_25_p N_noxref_4_c_1024_n ) capacitor c=0.00163444f \
 //x=3.33 //y=2.08 //x2=4.07 //y2=3.545
cc_101 ( N_noxref_1_c_26_p N_noxref_4_c_1024_n ) capacitor c=0.0025845f \
 //x=3.33 //y=2.08 //x2=4.07 //y2=3.545
cc_102 ( N_noxref_1_c_61_p N_noxref_4_c_1024_n ) capacitor c=0.00282067f \
 //x=3.33 //y=1.915 //x2=4.07 //y2=3.545
cc_103 ( N_noxref_1_c_29_p N_noxref_4_c_1034_n ) capacitor c=0.0146933f \
 //x=3.33 //y=4.57 //x2=4.07 //y2=3.865
cc_104 ( N_noxref_1_c_99_p N_noxref_4_c_1034_n ) capacitor c=0.00895951f \
 //x=4.29 //y=3.32 //x2=4.07 //y2=3.865
cc_105 ( N_noxref_1_c_29_p N_noxref_4_c_1036_n ) capacitor c=0.0414151f \
 //x=3.33 //y=4.57 //x2=4.07 //y2=5.07
cc_106 ( N_noxref_1_c_34_p N_noxref_4_c_1036_n ) capacitor c=0.00131258f \
 //x=3.33 //y=4.7 //x2=4.07 //y2=5.07
cc_107 ( N_noxref_1_c_35_p N_noxref_4_c_1036_n ) capacitor c=0.00739875f \
 //x=3.33 //y=4.7 //x2=4.07 //y2=5.07
cc_108 ( N_noxref_1_c_108_p N_noxref_4_c_1039_n ) capacitor c=0.00179329f \
 //x=6.14 //y=3.315 //x2=5.92 //y2=2.195
cc_109 ( N_noxref_1_c_27_p N_noxref_4_c_1040_n ) capacitor c=0.00210705f \
 //x=3.33 //y=3.17 //x2=5.92 //y2=3.54
cc_110 ( N_noxref_1_c_110_p N_noxref_4_c_1040_n ) capacitor c=5.07575e-19 \
 //x=5.54 //y=3.33 //x2=5.92 //y2=3.54
cc_111 ( N_noxref_1_c_108_p N_noxref_4_c_1040_n ) capacitor c=0.0286424f \
 //x=6.14 //y=3.315 //x2=5.92 //y2=3.54
cc_112 ( N_noxref_1_c_112_p N_noxref_4_c_1040_n ) capacitor c=3.74737e-19 \
 //x=9.045 //y=3.33 //x2=5.92 //y2=3.54
cc_113 ( N_noxref_1_c_108_p N_noxref_4_c_1044_n ) capacitor c=0.00797853f \
 //x=6.14 //y=3.315 //x2=5.92 //y2=3.86
cc_114 ( N_noxref_1_c_29_p N_noxref_4_c_1045_n ) capacitor c=8.5348e-19 \
 //x=3.33 //y=4.57 //x2=5.92 //y2=4.575
cc_115 ( N_noxref_1_c_29_p N_noxref_4_c_1046_n ) capacitor c=0.0228808f \
 //x=3.33 //y=4.57 //x2=3.29 //y2=5.155
cc_116 ( N_noxref_1_c_34_p N_noxref_4_c_1046_n ) capacitor c=0.00346456f \
 //x=3.33 //y=4.7 //x2=3.29 //y2=5.155
cc_117 ( N_noxref_1_c_35_p N_noxref_4_c_1046_n ) capacitor c=0.00203307f \
 //x=3.33 //y=4.7 //x2=3.29 //y2=5.155
cc_118 ( N_noxref_1_c_29_p N_noxref_4_c_1049_n ) capacitor c=6.15181e-19 \
 //x=3.33 //y=4.57 //x2=4.07 //y2=3.7
cc_119 ( N_noxref_1_c_99_p N_noxref_4_c_1050_n ) capacitor c=0.133263f \
 //x=4.29 //y=3.32 //x2=5.765 //y2=3.7
cc_120 ( N_noxref_1_c_110_p N_noxref_4_c_1050_n ) capacitor c=0.0126826f \
 //x=5.54 //y=3.33 //x2=5.765 //y2=3.7
cc_121 ( N_noxref_1_c_121_p N_noxref_4_c_1052_n ) capacitor c=0.00771097f \
 //x=8.88 //y=3.49 //x2=9.1 //y2=3.715
cc_122 ( N_noxref_1_c_6_p N_noxref_4_c_1052_n ) capacitor c=0.0226453f \
 //x=8.88 //y=5.07 //x2=9.1 //y2=3.715
cc_123 ( N_noxref_1_c_123_p N_noxref_4_c_1052_n ) capacitor c=0.127201f \
 //x=10.57 //y=3.33 //x2=9.1 //y2=3.715
cc_124 ( N_noxref_1_c_121_p N_noxref_4_c_1055_n ) capacitor c=0.00128047f \
 //x=8.88 //y=3.49 //x2=8.755 //y2=3.715
cc_125 ( N_noxref_1_c_6_p N_noxref_4_c_1055_n ) capacitor c=3.14797e-19 \
 //x=8.88 //y=5.07 //x2=8.755 //y2=3.715
cc_126 ( N_noxref_1_c_108_p N_noxref_4_c_1055_n ) capacitor c=0.0477348f \
 //x=6.14 //y=3.315 //x2=8.755 //y2=3.715
cc_127 ( N_noxref_1_c_112_p N_noxref_4_c_1055_n ) capacitor c=0.256734f \
 //x=9.045 //y=3.33 //x2=8.755 //y2=3.715
cc_128 ( N_noxref_1_c_10_p N_noxref_4_c_1059_n ) capacitor c=0.00339401f \
 //x=10.73 //y=3.49 //x2=10.345 //y2=3.7
cc_129 ( N_noxref_1_c_7_p N_noxref_4_c_1059_n ) capacitor c=5.02752e-19 \
 //x=10.732 //y=4.56 //x2=10.345 //y2=3.7
cc_130 ( N_noxref_1_c_123_p N_noxref_4_c_1059_n ) capacitor c=0.0107648f \
 //x=10.57 //y=3.33 //x2=10.345 //y2=3.7
cc_131 ( N_noxref_1_c_18_p N_noxref_4_c_1059_n ) capacitor c=0.0358254f \
 //x=10.73 //y=3.33 //x2=10.345 //y2=3.7
cc_132 ( N_noxref_1_c_10_p N_noxref_4_c_1063_n ) capacitor c=0.00260425f \
 //x=10.73 //y=3.49 //x2=10.945 //y2=3.715
cc_133 ( N_noxref_1_c_7_p N_noxref_4_c_1063_n ) capacitor c=0.0228372f \
 //x=10.732 //y=4.56 //x2=10.945 //y2=3.715
cc_134 ( N_noxref_1_c_29_p N_noxref_4_c_1065_n ) capacitor c=0.00683433f \
 //x=3.33 //y=4.57 //x2=4.235 //y2=3.705
cc_135 ( N_noxref_1_c_99_p N_noxref_4_c_1065_n ) capacitor c=0.0365231f \
 //x=4.29 //y=3.32 //x2=4.235 //y2=3.705
cc_136 ( N_noxref_1_c_29_p N_noxref_4_c_1067_n ) capacitor c=0.00217653f \
 //x=3.33 //y=4.57 //x2=3.29 //y2=5.38
cc_137 ( N_noxref_1_c_34_p N_noxref_4_c_1067_n ) capacitor c=0.00624059f \
 //x=3.33 //y=4.7 //x2=3.29 //y2=5.38
cc_138 ( N_noxref_1_M20_noxref_g N_noxref_4_c_1067_n ) capacitor c=0.0178885f \
 //x=3.07 //y=6.02 //x2=3.29 //y2=5.38
cc_139 ( N_noxref_1_M21_noxref_g N_noxref_4_c_1067_n ) capacitor c=0.0188608f \
 //x=3.51 //y=6.02 //x2=3.29 //y2=5.38
cc_140 ( N_noxref_1_c_35_p N_noxref_4_c_1067_n ) capacitor c=0.00375636f \
 //x=3.33 //y=4.7 //x2=3.29 //y2=5.38
cc_141 ( N_noxref_1_c_39_p N_noxref_4_M22_noxref_g ) capacitor c=0.00461408f \
 //x=6.342 //y=5.155 //x2=6.12 //y2=6.02
cc_142 ( N_noxref_1_c_142_p N_noxref_4_M22_noxref_g ) capacitor c=0.0162284f \
 //x=6.34 //y=5.38 //x2=6.12 //y2=6.02
cc_143 ( N_noxref_1_c_143_p N_noxref_4_M23_noxref_g ) capacitor c=0.00893512f \
 //x=7.1 //y=5.155 //x2=6.56 //y2=6.02
cc_144 ( N_noxref_1_c_39_p N_noxref_4_M23_noxref_g ) capacitor c=0.00229208f \
 //x=6.342 //y=5.155 //x2=6.56 //y2=6.02
cc_145 ( N_noxref_1_c_142_p N_noxref_4_M23_noxref_g ) capacitor c=0.0179041f \
 //x=6.34 //y=5.38 //x2=6.56 //y2=6.02
cc_146 ( N_noxref_1_c_39_p N_noxref_4_c_1077_n ) capacitor c=0.00171885f \
 //x=6.342 //y=5.155 //x2=6.485 //y2=4.79
cc_147 ( N_noxref_1_c_142_p N_noxref_4_c_1077_n ) capacitor c=0.00291477f \
 //x=6.34 //y=5.38 //x2=6.485 //y2=4.79
cc_148 ( N_noxref_1_c_55_p N_noxref_4_M2_noxref_d ) capacitor c=0.00137165f \
 //x=3.32 //y=0.915 //x2=3.395 //y2=0.915
cc_149 ( N_noxref_1_c_56_p N_noxref_4_M2_noxref_d ) capacitor c=0.00237422f \
 //x=3.32 //y=1.26 //x2=3.395 //y2=0.915
cc_150 ( N_noxref_1_c_78_p N_noxref_4_M2_noxref_d ) capacitor c=0.0020782f \
 //x=3.695 //y=0.76 //x2=3.395 //y2=0.915
cc_151 ( N_noxref_1_c_79_p N_noxref_4_M2_noxref_d ) capacitor c=0.00356097f \
 //x=3.695 //y=1.415 //x2=3.395 //y2=0.915
cc_152 ( N_noxref_1_c_80_p N_noxref_4_M2_noxref_d ) capacitor c=0.00139206f \
 //x=3.85 //y=0.915 //x2=3.395 //y2=0.915
cc_153 ( N_noxref_1_c_81_p N_noxref_4_M2_noxref_d ) capacitor c=0.00237422f \
 //x=3.85 //y=1.26 //x2=3.395 //y2=0.915
cc_154 ( N_noxref_1_c_16_p N_noxref_5_c_1453_n ) capacitor c=5.60322e-19 \
 //x=8.395 //y=1.125 //x2=8.14 //y2=2.285
cc_155 ( N_noxref_1_c_155_p N_noxref_5_c_1453_n ) capacitor c=0.0171187f \
 //x=8.88 //y=3.17 //x2=8.14 //y2=2.285
cc_156 ( N_noxref_1_c_156_p N_noxref_5_c_1453_n ) capacitor c=4.31152e-19 \
 //x=8.1 //y=5.155 //x2=8.14 //y2=2.285
cc_157 ( N_noxref_1_c_112_p N_noxref_5_c_1453_n ) capacitor c=5.48788e-19 \
 //x=9.045 //y=3.33 //x2=8.14 //y2=2.285
cc_158 ( N_noxref_1_c_9_p N_noxref_5_c_1457_n ) capacitor c=0.00228791f \
 //x=8.795 //y=5.155 //x2=8.14 //y2=4.57
cc_159 ( N_noxref_1_c_155_p N_noxref_5_c_1457_n ) capacitor c=0.0405796f \
 //x=8.88 //y=3.17 //x2=8.14 //y2=4.57
cc_160 ( N_noxref_1_c_121_p N_noxref_5_c_1457_n ) capacitor c=0.0144538f \
 //x=8.88 //y=3.49 //x2=8.14 //y2=4.57
cc_161 ( N_noxref_1_c_6_p N_noxref_5_c_1457_n ) capacitor c=0.0564508f \
 //x=8.88 //y=5.07 //x2=8.14 //y2=4.57
cc_162 ( N_noxref_1_c_5_p N_noxref_5_c_1457_n ) capacitor c=0.00190577f \
 //x=10.73 //y=3.17 //x2=8.14 //y2=4.57
cc_163 ( N_noxref_1_c_156_p N_noxref_5_c_1457_n ) capacitor c=0.022916f \
 //x=8.1 //y=5.155 //x2=8.14 //y2=4.57
cc_164 ( N_noxref_1_c_164_p N_noxref_5_c_1457_n ) capacitor c=6.03895e-19 \
 //x=8.88 //y=3.33 //x2=8.14 //y2=4.57
cc_165 ( N_noxref_1_c_7_p N_noxref_5_c_1457_n ) capacitor c=0.00123473f \
 //x=10.732 //y=4.56 //x2=8.14 //y2=4.57
cc_166 ( N_noxref_1_c_112_p N_noxref_5_c_1457_n ) capacitor c=0.0291276f \
 //x=9.045 //y=3.33 //x2=8.14 //y2=4.57
cc_167 ( N_noxref_1_c_167_p N_noxref_5_c_1457_n ) capacitor c=0.00266858f \
 //x=8.1 //y=5.38 //x2=8.14 //y2=4.57
cc_168 ( N_noxref_1_c_16_p N_noxref_5_c_1467_n ) capacitor c=4.13793e-19 \
 //x=8.395 //y=1.125 //x2=8.145 //y2=2.125
cc_169 ( N_noxref_1_c_155_p N_noxref_5_c_1467_n ) capacitor c=0.00372846f \
 //x=8.88 //y=3.17 //x2=8.145 //y2=2.125
cc_170 ( N_noxref_1_c_112_p N_noxref_5_c_1467_n ) capacitor c=0.0213442f \
 //x=9.045 //y=3.33 //x2=8.145 //y2=2.125
cc_171 ( N_noxref_1_c_87_p N_noxref_5_c_1470_n ) capacitor c=0.0215425f \
 //x=8.48 //y=1.665 //x2=16.125 //y2=2.135
cc_172 ( N_noxref_1_c_155_p N_noxref_5_c_1470_n ) capacitor c=0.0315002f \
 //x=8.88 //y=3.17 //x2=16.125 //y2=2.135
cc_173 ( N_noxref_1_c_121_p N_noxref_5_c_1470_n ) capacitor c=0.00347573f \
 //x=8.88 //y=3.49 //x2=16.125 //y2=2.135
cc_174 ( N_noxref_1_c_5_p N_noxref_5_c_1470_n ) capacitor c=0.0166725f \
 //x=10.73 //y=3.17 //x2=16.125 //y2=2.135
cc_175 ( N_noxref_1_c_10_p N_noxref_5_c_1470_n ) capacitor c=0.00298073f \
 //x=10.73 //y=3.49 //x2=16.125 //y2=2.135
cc_176 ( N_noxref_1_c_176_p N_noxref_5_c_1470_n ) capacitor c=0.0177708f \
 //x=10.73 //y=2.08 //x2=16.125 //y2=2.135
cc_177 ( N_noxref_1_c_123_p N_noxref_5_c_1470_n ) capacitor c=0.0483419f \
 //x=10.57 //y=3.33 //x2=16.125 //y2=2.135
cc_178 ( N_noxref_1_c_112_p N_noxref_5_c_1470_n ) capacitor c=0.00812897f \
 //x=9.045 //y=3.33 //x2=16.125 //y2=2.135
cc_179 ( N_noxref_1_c_18_p N_noxref_5_c_1470_n ) capacitor c=0.00840581f \
 //x=10.73 //y=3.33 //x2=16.125 //y2=2.135
cc_180 ( N_noxref_1_c_180_p N_noxref_5_c_1470_n ) capacitor c=2.20453e-19 \
 //x=10.73 //y=2.08 //x2=16.125 //y2=2.135
cc_181 ( N_noxref_1_c_155_p N_noxref_5_c_1480_n ) capacitor c=0.00115564f \
 //x=8.88 //y=3.17 //x2=8.14 //y2=2.08
cc_182 ( N_noxref_1_c_9_p N_noxref_5_c_1481_n ) capacitor c=0.00130631f \
 //x=8.795 //y=5.155 //x2=8.14 //y2=4.7
cc_183 ( N_noxref_1_c_6_p N_noxref_5_c_1481_n ) capacitor c=0.00131258f \
 //x=8.88 //y=5.07 //x2=8.14 //y2=4.7
cc_184 ( N_noxref_1_c_156_p N_noxref_5_c_1481_n ) capacitor c=0.00346017f \
 //x=8.1 //y=5.155 //x2=8.14 //y2=4.7
cc_185 ( N_noxref_1_c_167_p N_noxref_5_c_1481_n ) capacitor c=0.00624059f \
 //x=8.1 //y=5.38 //x2=8.14 //y2=4.7
cc_186 ( N_noxref_1_c_186_p N_noxref_5_M26_noxref_g ) capacitor c=0.00955829f \
 //x=7.985 //y=5.155 //x2=7.88 //y2=6.02
cc_187 ( N_noxref_1_c_8_p N_noxref_5_M26_noxref_g ) capacitor c=0.00226521f \
 //x=8.1 //y=5.38 //x2=7.88 //y2=6.02
cc_188 ( N_noxref_1_c_167_p N_noxref_5_M26_noxref_g ) capacitor c=0.0178885f \
 //x=8.1 //y=5.38 //x2=7.88 //y2=6.02
cc_189 ( N_noxref_1_c_8_p N_noxref_5_M27_noxref_g ) capacitor c=0.00368945f \
 //x=8.1 //y=5.38 //x2=8.32 //y2=6.02
cc_190 ( N_noxref_1_c_9_p N_noxref_5_M27_noxref_g ) capacitor c=0.0108612f \
 //x=8.795 //y=5.155 //x2=8.32 //y2=6.02
cc_191 ( N_noxref_1_c_167_p N_noxref_5_M27_noxref_g ) capacitor c=0.0188608f \
 //x=8.1 //y=5.38 //x2=8.32 //y2=6.02
cc_192 ( N_noxref_1_c_16_p N_noxref_5_c_1491_n ) capacitor c=4.64015e-19 \
 //x=8.395 //y=1.125 //x2=8.13 //y2=0.915
cc_193 ( N_noxref_1_M5_noxref_d N_noxref_5_c_1491_n ) capacitor c=0.00137165f \
 //x=8.205 //y=0.915 //x2=8.13 //y2=0.915
cc_194 ( N_noxref_1_c_16_p N_noxref_5_c_1493_n ) capacitor c=0.0026012f \
 //x=8.395 //y=1.125 //x2=8.13 //y2=1.26
cc_195 ( N_noxref_1_c_2_p N_noxref_5_c_1493_n ) capacitor c=0.00127432f \
 //x=8.395 //y=1.58 //x2=8.13 //y2=1.26
cc_196 ( N_noxref_1_M5_noxref_d N_noxref_5_c_1493_n ) capacitor c=0.00237422f \
 //x=8.205 //y=0.915 //x2=8.13 //y2=1.26
cc_197 ( N_noxref_1_c_2_p N_noxref_5_c_1496_n ) capacitor c=0.00441386f \
 //x=8.395 //y=1.58 //x2=8.13 //y2=1.57
cc_198 ( N_noxref_1_c_16_p N_noxref_5_c_1497_n ) capacitor c=5.29969e-19 \
 //x=8.395 //y=1.125 //x2=8.505 //y2=0.76
cc_199 ( N_noxref_1_M5_noxref_d N_noxref_5_c_1497_n ) capacitor c=0.0020782f \
 //x=8.205 //y=0.915 //x2=8.505 //y2=0.76
cc_200 ( N_noxref_1_c_16_p N_noxref_5_c_1499_n ) capacitor c=4.32061e-19 \
 //x=8.395 //y=1.125 //x2=8.505 //y2=1.415
cc_201 ( N_noxref_1_c_2_p N_noxref_5_c_1499_n ) capacitor c=0.00930387f \
 //x=8.395 //y=1.58 //x2=8.505 //y2=1.415
cc_202 ( N_noxref_1_c_3_p N_noxref_5_c_1499_n ) capacitor c=0.00194716f \
 //x=8.795 //y=1.665 //x2=8.505 //y2=1.415
cc_203 ( N_noxref_1_M5_noxref_d N_noxref_5_c_1499_n ) capacitor c=0.00356097f \
 //x=8.205 //y=0.915 //x2=8.505 //y2=1.415
cc_204 ( N_noxref_1_c_16_p N_noxref_5_c_1503_n ) capacitor c=5.28622e-19 \
 //x=8.395 //y=1.125 //x2=8.66 //y2=0.915
cc_205 ( N_noxref_1_M5_noxref_d N_noxref_5_c_1503_n ) capacitor c=0.00139206f \
 //x=8.205 //y=0.915 //x2=8.66 //y2=0.915
cc_206 ( N_noxref_1_c_16_p N_noxref_5_c_1505_n ) capacitor c=0.00312156f \
 //x=8.395 //y=1.125 //x2=8.66 //y2=1.26
cc_207 ( N_noxref_1_c_2_p N_noxref_5_c_1505_n ) capacitor c=0.00347599f \
 //x=8.395 //y=1.58 //x2=8.66 //y2=1.26
cc_208 ( N_noxref_1_c_3_p N_noxref_5_c_1505_n ) capacitor c=0.00323576f \
 //x=8.795 //y=1.665 //x2=8.66 //y2=1.26
cc_209 ( N_noxref_1_M5_noxref_d N_noxref_5_c_1505_n ) capacitor c=0.00237422f \
 //x=8.205 //y=0.915 //x2=8.66 //y2=1.26
cc_210 ( N_noxref_1_c_155_p N_noxref_5_c_1509_n ) capacitor c=3.96703e-19 \
 //x=8.88 //y=3.17 //x2=8.14 //y2=2.08
cc_211 ( N_noxref_1_c_2_p N_noxref_5_c_1510_n ) capacitor c=0.0036273f \
 //x=8.395 //y=1.58 //x2=8.14 //y2=1.915
cc_212 ( N_noxref_1_c_155_p N_noxref_5_c_1510_n ) capacitor c=0.00282067f \
 //x=8.88 //y=3.17 //x2=8.14 //y2=1.915
cc_213 ( N_noxref_1_c_6_p N_noxref_5_c_1512_n ) capacitor c=0.00739875f \
 //x=8.88 //y=5.07 //x2=8.14 //y2=4.7
cc_214 ( N_noxref_1_c_156_p N_noxref_5_c_1512_n ) capacitor c=0.00203307f \
 //x=8.1 //y=5.155 //x2=8.14 //y2=4.7
cc_215 ( N_noxref_1_c_167_p N_noxref_5_c_1512_n ) capacitor c=0.00375636f \
 //x=8.1 //y=5.38 //x2=8.14 //y2=4.7
cc_216 ( N_noxref_1_c_27_p N_noxref_6_c_1862_n ) capacitor c=0.00142312f \
 //x=3.33 //y=3.17 //x2=1.11 //y2=3.92
cc_217 ( N_noxref_1_c_29_p N_noxref_6_c_1862_n ) capacitor c=8.0808e-19 \
 //x=3.33 //y=4.57 //x2=1.11 //y2=3.92
cc_218 ( N_noxref_1_c_29_p N_noxref_6_c_1864_n ) capacitor c=5.44383e-19 \
 //x=3.33 //y=4.57 //x2=1.11 //y2=4.575
cc_219 ( N_noxref_1_c_155_p N_noxref_6_c_1865_n ) capacitor c=0.00190464f \
 //x=8.88 //y=3.17 //x2=11.47 //y2=3.91
cc_220 ( N_noxref_1_c_6_p N_noxref_6_c_1865_n ) capacitor c=3.12404e-19 \
 //x=8.88 //y=5.07 //x2=11.47 //y2=3.91
cc_221 ( N_noxref_1_c_5_p N_noxref_6_c_1865_n ) capacitor c=0.0415182f \
 //x=10.73 //y=3.17 //x2=11.47 //y2=3.91
cc_222 ( N_noxref_1_c_10_p N_noxref_6_c_1865_n ) capacitor c=0.0148501f \
 //x=10.73 //y=3.49 //x2=11.47 //y2=3.91
cc_223 ( N_noxref_1_c_17_p N_noxref_6_c_1865_n ) capacitor c=5.52402e-19 \
 //x=10.73 //y=3.33 //x2=11.47 //y2=3.91
cc_224 ( N_noxref_1_c_7_p N_noxref_6_c_1865_n ) capacitor c=0.0167029f \
 //x=10.732 //y=4.56 //x2=11.47 //y2=3.91
cc_225 ( N_noxref_1_c_18_p N_noxref_6_c_1865_n ) capacitor c=0.00365413f \
 //x=10.73 //y=3.33 //x2=11.47 //y2=3.91
cc_226 ( N_noxref_1_c_180_p N_noxref_6_c_1865_n ) capacitor c=3.30333e-19 \
 //x=10.73 //y=2.08 //x2=11.47 //y2=3.91
cc_227 ( N_noxref_1_c_7_p N_noxref_6_c_1873_n ) capacitor c=0.0172847f \
 //x=10.732 //y=4.56 //x2=11.47 //y2=4.23
cc_228 ( N_noxref_1_c_6_p N_noxref_6_c_1874_n ) capacitor c=7.60001e-19 \
 //x=8.88 //y=5.07 //x2=11.47 //y2=4.555
cc_229 ( N_noxref_1_c_11_p N_noxref_6_c_1874_n ) capacitor c=0.0172939f \
 //x=10.73 //y=4.7 //x2=11.47 //y2=4.555
cc_230 ( N_noxref_1_c_7_p N_noxref_6_c_1874_n ) capacitor c=0.0117609f \
 //x=10.732 //y=4.56 //x2=11.47 //y2=4.555
cc_231 ( N_noxref_1_c_12_p N_noxref_6_c_1874_n ) capacitor c=7.51041e-19 \
 //x=10.73 //y=4.7 //x2=11.47 //y2=4.555
cc_232 ( N_noxref_1_c_15_p N_noxref_6_c_1874_n ) capacitor c=0.00200732f \
 //x=10.73 //y=4.7 //x2=11.47 //y2=4.555
cc_233 ( N_noxref_1_c_7_p N_noxref_6_c_1879_n ) capacitor c=6.16997e-19 \
 //x=10.732 //y=4.56 //x2=11.47 //y2=4.07
cc_234 ( N_noxref_1_c_176_p N_noxref_6_c_1880_n ) capacitor c=0.0179797f \
 //x=10.73 //y=2.08 //x2=11.47 //y2=2.08
cc_235 ( N_noxref_1_c_180_p N_noxref_6_c_1880_n ) capacitor c=5.16867e-19 \
 //x=10.73 //y=2.08 //x2=11.47 //y2=2.08
cc_236 ( N_noxref_1_c_236_p N_noxref_6_c_1880_n ) capacitor c=0.00161745f \
 //x=10.535 //y=1.915 //x2=11.47 //y2=2.08
cc_237 ( N_noxref_1_c_28_p N_noxref_6_c_1883_n ) capacitor c=0.0032242f \
 //x=3.33 //y=3.49 //x2=3.685 //y2=4.07
cc_238 ( N_noxref_1_c_29_p N_noxref_6_c_1883_n ) capacitor c=0.024687f \
 //x=3.33 //y=4.57 //x2=3.685 //y2=4.07
cc_239 ( N_noxref_1_c_43_p N_noxref_6_c_1883_n ) capacitor c=0.0166732f \
 //x=3.69 //y=3.33 //x2=3.685 //y2=4.07
cc_240 ( N_noxref_1_c_31_p N_noxref_6_c_1883_n ) capacitor c=0.0160572f \
 //x=3.49 //y=3.33 //x2=3.685 //y2=4.07
cc_241 ( N_noxref_1_c_99_p N_noxref_6_c_1887_n ) capacitor c=0.00840658f \
 //x=4.29 //y=3.32 //x2=4.325 //y2=4.09
cc_242 ( N_noxref_1_c_110_p N_noxref_6_c_1888_n ) capacitor c=0.00495213f \
 //x=5.54 //y=3.33 //x2=5.54 //y2=4.07
cc_243 ( N_noxref_1_c_108_p N_noxref_6_c_1889_n ) capacitor c=0.00107119f \
 //x=6.14 //y=3.315 //x2=6.14 //y2=4.085
cc_244 ( N_noxref_1_c_6_p N_noxref_6_c_1890_n ) capacitor c=0.0232184f \
 //x=8.88 //y=5.07 //x2=11.635 //y2=4.07
cc_245 ( N_noxref_1_c_7_p N_noxref_6_c_1890_n ) capacitor c=0.0253737f \
 //x=10.732 //y=4.56 //x2=11.635 //y2=4.07
cc_246 ( N_noxref_1_c_123_p N_noxref_6_c_1890_n ) capacitor c=0.00976061f \
 //x=10.57 //y=3.33 //x2=11.635 //y2=4.07
cc_247 ( N_noxref_1_c_112_p N_noxref_6_c_1890_n ) capacitor c=0.0180945f \
 //x=9.045 //y=3.33 //x2=11.635 //y2=4.07
cc_248 ( N_noxref_1_c_5_p N_noxref_6_c_1894_n ) capacitor c=3.30333e-19 \
 //x=10.73 //y=3.17 //x2=11.47 //y2=2.08
cc_249 ( N_noxref_1_c_176_p N_noxref_6_c_1894_n ) capacitor c=5.24723e-19 \
 //x=10.73 //y=2.08 //x2=11.47 //y2=2.08
cc_250 ( N_noxref_1_c_180_p N_noxref_6_c_1894_n ) capacitor c=0.00525888f \
 //x=10.73 //y=2.08 //x2=11.47 //y2=2.08
cc_251 ( N_noxref_1_c_236_p N_noxref_6_c_1894_n ) capacitor c=0.00190888f \
 //x=10.535 //y=1.915 //x2=11.47 //y2=2.08
cc_252 ( N_noxref_1_c_11_p N_noxref_6_c_1898_n ) capacitor c=4.80626e-19 \
 //x=10.73 //y=4.7 //x2=11.5 //y2=4.7
cc_253 ( N_noxref_1_c_12_p N_noxref_6_c_1898_n ) capacitor c=0.00397338f \
 //x=10.73 //y=4.7 //x2=11.5 //y2=4.7
cc_254 ( N_noxref_1_c_15_p N_noxref_6_c_1898_n ) capacitor c=0.00283894f \
 //x=10.73 //y=4.7 //x2=11.5 //y2=4.7
cc_255 ( N_noxref_1_M28_noxref_g N_noxref_6_M30_noxref_g ) capacitor \
 c=0.0104892f //x=10.63 //y=6.02 //x2=11.51 //y2=6.02
cc_256 ( N_noxref_1_M29_noxref_g N_noxref_6_M30_noxref_g ) capacitor \
 c=0.107636f //x=11.07 //y=6.02 //x2=11.51 //y2=6.02
cc_257 ( N_noxref_1_M29_noxref_g N_noxref_6_M31_noxref_g ) capacitor \
 c=0.0100341f //x=11.07 //y=6.02 //x2=11.95 //y2=6.02
cc_258 ( N_noxref_1_c_258_p N_noxref_6_c_1904_n ) capacitor c=4.86545e-19 \
 //x=10.535 //y=0.865 //x2=11.505 //y2=0.905
cc_259 ( N_noxref_1_c_259_p N_noxref_6_c_1904_n ) capacitor c=0.00152405f \
 //x=10.535 //y=1.21 //x2=11.505 //y2=0.905
cc_260 ( N_noxref_1_c_260_p N_noxref_6_c_1904_n ) capacitor c=0.0151475f \
 //x=11.065 //y=0.865 //x2=11.505 //y2=0.905
cc_261 ( N_noxref_1_c_261_p N_noxref_6_c_1907_n ) capacitor c=0.00109982f \
 //x=10.535 //y=1.52 //x2=11.505 //y2=1.25
cc_262 ( N_noxref_1_c_262_p N_noxref_6_c_1907_n ) capacitor c=0.0111064f \
 //x=11.065 //y=1.21 //x2=11.505 //y2=1.25
cc_263 ( N_noxref_1_c_261_p N_noxref_6_c_1909_n ) capacitor c=9.58243e-19 \
 //x=10.535 //y=1.52 //x2=11.505 //y2=1.56
cc_264 ( N_noxref_1_c_236_p N_noxref_6_c_1909_n ) capacitor c=0.00662747f \
 //x=10.535 //y=1.915 //x2=11.505 //y2=1.56
cc_265 ( N_noxref_1_c_262_p N_noxref_6_c_1909_n ) capacitor c=0.00862358f \
 //x=11.065 //y=1.21 //x2=11.505 //y2=1.56
cc_266 ( N_noxref_1_c_260_p N_noxref_6_c_1912_n ) capacitor c=0.00127211f \
 //x=11.065 //y=0.865 //x2=12.035 //y2=0.905
cc_267 ( N_noxref_1_c_262_p N_noxref_6_c_1913_n ) capacitor c=0.00204774f \
 //x=11.065 //y=1.21 //x2=12.035 //y2=1.25
cc_268 ( N_noxref_1_c_176_p N_noxref_6_c_1914_n ) capacitor c=0.00161167f \
 //x=10.73 //y=2.08 //x2=11.47 //y2=2.08
cc_269 ( N_noxref_1_c_180_p N_noxref_6_c_1914_n ) capacitor c=0.0018937f \
 //x=10.73 //y=2.08 //x2=11.47 //y2=2.08
cc_270 ( N_noxref_1_c_236_p N_noxref_6_c_1914_n ) capacitor c=0.0181449f \
 //x=10.535 //y=1.915 //x2=11.47 //y2=2.08
cc_271 ( N_noxref_1_c_11_p N_noxref_6_c_1917_n ) capacitor c=0.00158715f \
 //x=10.73 //y=4.7 //x2=11.5 //y2=4.7
cc_272 ( N_noxref_1_c_12_p N_noxref_6_c_1917_n ) capacitor c=0.00237977f \
 //x=10.73 //y=4.7 //x2=11.5 //y2=4.7
cc_273 ( N_noxref_1_c_15_p N_noxref_6_c_1917_n ) capacitor c=0.0297875f \
 //x=10.73 //y=4.7 //x2=11.5 //y2=4.7
cc_274 ( N_noxref_1_c_143_p N_noxref_7_c_2451_n ) capacitor c=0.00620651f \
 //x=7.1 //y=5.155 //x2=25.53 //y2=7.4
cc_275 ( N_noxref_1_c_186_p N_noxref_7_c_2451_n ) capacitor c=0.00626474f \
 //x=7.985 //y=5.155 //x2=25.53 //y2=7.4
cc_276 ( N_noxref_1_c_8_p N_noxref_7_c_2451_n ) capacitor c=0.00255604f \
 //x=8.1 //y=5.38 //x2=25.53 //y2=7.4
cc_277 ( N_noxref_1_c_9_p N_noxref_7_c_2451_n ) capacitor c=0.00827856f \
 //x=8.795 //y=5.155 //x2=25.53 //y2=7.4
cc_278 ( N_noxref_1_c_121_p N_noxref_7_c_2451_n ) capacitor c=4.58585e-19 \
 //x=8.88 //y=3.49 //x2=25.53 //y2=7.4
cc_279 ( N_noxref_1_c_10_p N_noxref_7_c_2451_n ) capacitor c=2.00109e-19 \
 //x=10.73 //y=3.49 //x2=25.53 //y2=7.4
cc_280 ( N_noxref_1_c_39_p N_noxref_7_c_2451_n ) capacitor c=0.00261379f \
 //x=6.342 //y=5.155 //x2=25.53 //y2=7.4
cc_281 ( N_noxref_1_c_40_p N_noxref_7_c_2451_n ) capacitor c=0.0026965f \
 //x=7.22 //y=5.155 //x2=25.53 //y2=7.4
cc_282 ( N_noxref_1_c_11_p N_noxref_7_c_2451_n ) capacitor c=9.05427e-19 \
 //x=10.73 //y=4.7 //x2=25.53 //y2=7.4
cc_283 ( N_noxref_1_c_142_p N_noxref_7_c_2451_n ) capacitor c=0.00242194f \
 //x=6.34 //y=5.38 //x2=25.53 //y2=7.4
cc_284 ( N_noxref_1_c_284_p N_noxref_7_c_2451_n ) capacitor c=0.00242194f \
 //x=7.22 //y=5.38 //x2=25.53 //y2=7.4
cc_285 ( N_noxref_1_c_167_p N_noxref_7_c_2451_n ) capacitor c=0.00242194f \
 //x=8.1 //y=5.38 //x2=25.53 //y2=7.4
cc_286 ( N_noxref_1_c_12_p N_noxref_7_c_2451_n ) capacitor c=6.23118e-19 \
 //x=10.73 //y=4.7 //x2=25.53 //y2=7.4
cc_287 ( N_noxref_1_M20_noxref_g N_noxref_7_c_2464_n ) capacitor c=0.00749619f \
 //x=3.07 //y=6.02 //x2=3.645 //y2=7.4
cc_288 ( N_noxref_1_M21_noxref_g N_noxref_7_c_2464_n ) capacitor c=0.00749823f \
 //x=3.51 //y=6.02 //x2=3.645 //y2=7.4
cc_289 ( N_noxref_1_c_143_p N_noxref_7_c_2466_n ) capacitor c=0.00202948f \
 //x=7.1 //y=5.155 //x2=6.695 //y2=7.4
cc_290 ( N_noxref_1_c_39_p N_noxref_7_c_2466_n ) capacitor c=9.37357e-19 \
 //x=6.342 //y=5.155 //x2=6.695 //y2=7.4
cc_291 ( N_noxref_1_c_142_p N_noxref_7_c_2466_n ) capacitor c=0.0137846f \
 //x=6.34 //y=5.38 //x2=6.695 //y2=7.4
cc_292 ( N_noxref_1_c_143_p N_noxref_7_c_2469_n ) capacitor c=0.00177088f \
 //x=7.1 //y=5.155 //x2=7.575 //y2=7.4
cc_293 ( N_noxref_1_c_186_p N_noxref_7_c_2469_n ) capacitor c=0.00202948f \
 //x=7.985 //y=5.155 //x2=7.575 //y2=7.4
cc_294 ( N_noxref_1_c_40_p N_noxref_7_c_2469_n ) capacitor c=9.47876e-19 \
 //x=7.22 //y=5.155 //x2=7.575 //y2=7.4
cc_295 ( N_noxref_1_c_284_p N_noxref_7_c_2469_n ) capacitor c=0.0137846f \
 //x=7.22 //y=5.38 //x2=7.575 //y2=7.4
cc_296 ( N_noxref_1_c_186_p N_noxref_7_c_2473_n ) capacitor c=0.00205929f \
 //x=7.985 //y=5.155 //x2=8.455 //y2=7.4
cc_297 ( N_noxref_1_c_8_p N_noxref_7_c_2473_n ) capacitor c=8.49349e-19 \
 //x=8.1 //y=5.38 //x2=8.455 //y2=7.4
cc_298 ( N_noxref_1_c_9_p N_noxref_7_c_2473_n ) capacitor c=0.00204261f \
 //x=8.795 //y=5.155 //x2=8.455 //y2=7.4
cc_299 ( N_noxref_1_c_167_p N_noxref_7_c_2473_n ) capacitor c=0.0137846f \
 //x=8.1 //y=5.38 //x2=8.455 //y2=7.4
cc_300 ( N_noxref_1_c_9_p N_noxref_7_c_2477_n ) capacitor c=0.00183429f \
 //x=8.795 //y=5.155 //x2=9.45 //y2=7.4
cc_301 ( N_noxref_1_c_11_p N_noxref_7_c_2478_n ) capacitor c=6.28732e-19 \
 //x=10.73 //y=4.7 //x2=11.205 //y2=7.4
cc_302 ( N_noxref_1_M28_noxref_g N_noxref_7_c_2478_n ) capacitor c=0.0072715f \
 //x=10.63 //y=6.02 //x2=11.205 //y2=7.4
cc_303 ( N_noxref_1_M29_noxref_g N_noxref_7_c_2478_n ) capacitor c=0.00749619f \
 //x=11.07 //y=6.02 //x2=11.205 //y2=7.4
cc_304 ( N_noxref_1_c_39_p N_noxref_7_c_2481_n ) capacitor c=0.0022955f \
 //x=6.342 //y=5.155 //x2=4.81 //y2=7.4
cc_305 ( N_noxref_1_c_34_p N_noxref_7_c_2481_n ) capacitor c=0.00224736f \
 //x=3.33 //y=4.7 //x2=4.81 //y2=7.4
cc_306 ( N_noxref_1_c_142_p N_noxref_7_c_2481_n ) capacitor c=0.00509469f \
 //x=6.34 //y=5.38 //x2=4.81 //y2=7.4
cc_307 ( N_noxref_1_c_35_p N_noxref_7_c_2481_n ) capacitor c=2.63786e-19 \
 //x=3.33 //y=4.7 //x2=4.81 //y2=7.4
cc_308 ( N_noxref_1_c_8_p N_noxref_7_c_2485_n ) capacitor c=0.00269779f \
 //x=8.1 //y=5.38 //x2=9.62 //y2=7.4
cc_309 ( N_noxref_1_c_6_p N_noxref_7_c_2485_n ) capacitor c=0.031323f //x=8.88 \
 //y=5.07 //x2=9.62 //y2=7.4
cc_310 ( N_noxref_1_c_11_p N_noxref_7_c_2485_n ) capacitor c=0.00447349f \
 //x=10.73 //y=4.7 //x2=9.62 //y2=7.4
cc_311 ( N_noxref_1_c_7_p N_noxref_7_c_2485_n ) capacitor c=0.00564116f \
 //x=10.732 //y=4.56 //x2=9.62 //y2=7.4
cc_312 ( N_noxref_1_c_167_p N_noxref_7_c_2485_n ) capacitor c=0.00776541f \
 //x=8.1 //y=5.38 //x2=9.62 //y2=7.4
cc_313 ( N_noxref_1_c_12_p N_noxref_7_c_2485_n ) capacitor c=0.00370494f \
 //x=10.73 //y=4.7 //x2=9.62 //y2=7.4
cc_314 ( N_noxref_1_c_15_p N_noxref_7_c_2485_n ) capacitor c=0.0129564f \
 //x=10.73 //y=4.7 //x2=9.62 //y2=7.4
cc_315 ( N_noxref_1_M20_noxref_g N_noxref_7_M19_noxref_d ) capacitor \
 c=0.015318f //x=3.07 //y=6.02 //x2=2.705 //y2=5.02
cc_316 ( N_noxref_1_M21_noxref_g N_noxref_7_M21_noxref_d ) capacitor \
 c=0.0394719f //x=3.51 //y=6.02 //x2=3.585 //y2=5.02
cc_317 ( N_noxref_1_c_39_p N_noxref_7_M22_noxref_s ) capacitor c=0.0441176f \
 //x=6.342 //y=5.155 //x2=5.765 //y2=5.02
cc_318 ( N_noxref_1_c_40_p N_noxref_7_M22_noxref_s ) capacitor c=7.80122e-19 \
 //x=7.22 //y=5.155 //x2=5.765 //y2=5.02
cc_319 ( N_noxref_1_c_142_p N_noxref_7_M22_noxref_s ) capacitor c=0.09305f \
 //x=6.34 //y=5.38 //x2=5.765 //y2=5.02
cc_320 ( N_noxref_1_c_143_p N_noxref_7_M23_noxref_d ) capacitor c=0.00700078f \
 //x=7.1 //y=5.155 //x2=6.635 //y2=5.02
cc_321 ( N_noxref_1_c_142_p N_noxref_7_M23_noxref_d ) capacitor c=0.0674491f \
 //x=6.34 //y=5.38 //x2=6.635 //y2=5.02
cc_322 ( N_noxref_1_c_284_p N_noxref_7_M23_noxref_d ) capacitor c=0.0674762f \
 //x=7.22 //y=5.38 //x2=6.635 //y2=5.02
cc_323 ( N_noxref_1_c_186_p N_noxref_7_M25_noxref_d ) capacitor c=0.00700078f \
 //x=7.985 //y=5.155 //x2=7.515 //y2=5.02
cc_324 ( N_noxref_1_c_284_p N_noxref_7_M25_noxref_d ) capacitor c=0.067493f \
 //x=7.22 //y=5.38 //x2=7.515 //y2=5.02
cc_325 ( N_noxref_1_c_167_p N_noxref_7_M25_noxref_d ) capacitor c=0.0674288f \
 //x=8.1 //y=5.38 //x2=7.515 //y2=5.02
cc_326 ( N_noxref_1_c_9_p N_noxref_7_M27_noxref_d ) capacitor c=0.00700078f \
 //x=8.795 //y=5.155 //x2=8.395 //y2=5.02
cc_327 ( N_noxref_1_c_167_p N_noxref_7_M27_noxref_d ) capacitor c=0.0673824f \
 //x=8.1 //y=5.38 //x2=8.395 //y2=5.02
cc_328 ( N_noxref_1_c_8_p N_noxref_7_M28_noxref_s ) capacitor c=0.00536022f \
 //x=8.1 //y=5.38 //x2=10.275 //y2=5.02
cc_329 ( N_noxref_1_c_9_p N_noxref_7_M28_noxref_s ) capacitor c=0.00211796f \
 //x=8.795 //y=5.155 //x2=10.275 //y2=5.02
cc_330 ( N_noxref_1_c_10_p N_noxref_7_M28_noxref_s ) capacitor c=0.00111275f \
 //x=10.73 //y=3.49 //x2=10.275 //y2=5.02
cc_331 ( N_noxref_1_M28_noxref_g N_noxref_7_M28_noxref_s ) capacitor \
 c=0.0567929f //x=10.63 //y=6.02 //x2=10.275 //y2=5.02
cc_332 ( N_noxref_1_M29_noxref_g N_noxref_7_M29_noxref_d ) capacitor \
 c=0.015318f //x=11.07 //y=6.02 //x2=11.145 //y2=5.02
cc_333 ( N_noxref_1_c_24_p N_noxref_8_c_2844_n ) capacitor c=0.00177186f \
 //x=3.33 //y=2.195 //x2=3.985 //y2=0.54
cc_334 ( N_noxref_1_c_25_p N_noxref_8_c_2844_n ) capacitor c=0.00117306f \
 //x=3.33 //y=2.08 //x2=3.985 //y2=0.54
cc_335 ( N_noxref_1_c_55_p N_noxref_8_c_2844_n ) capacitor c=0.0206349f \
 //x=3.32 //y=0.915 //x2=3.985 //y2=0.54
cc_336 ( N_noxref_1_c_80_p N_noxref_8_c_2844_n ) capacitor c=0.00825432f \
 //x=3.85 //y=0.915 //x2=3.985 //y2=0.54
cc_337 ( N_noxref_1_c_26_p N_noxref_8_c_2844_n ) capacitor c=2.20712e-19 \
 //x=3.33 //y=2.08 //x2=3.985 //y2=0.54
cc_338 ( N_noxref_1_c_56_p N_noxref_8_c_2849_n ) capacitor c=0.0071177f \
 //x=3.32 //y=1.26 //x2=3.1 //y2=0.995
cc_339 ( N_noxref_1_c_55_p N_noxref_8_M2_noxref_s ) capacitor c=0.0071177f \
 //x=3.32 //y=0.915 //x2=2.965 //y2=0.375
cc_340 ( N_noxref_1_c_57_p N_noxref_8_M2_noxref_s ) capacitor c=0.0071177f \
 //x=3.32 //y=1.57 //x2=2.965 //y2=0.375
cc_341 ( N_noxref_1_c_80_p N_noxref_8_M2_noxref_s ) capacitor c=0.015333f \
 //x=3.85 //y=0.915 //x2=2.965 //y2=0.375
cc_342 ( N_noxref_1_c_81_p N_noxref_8_M2_noxref_s ) capacitor c=0.00248746f \
 //x=3.85 //y=1.26 //x2=2.965 //y2=0.375
cc_343 ( N_noxref_1_c_16_p N_noxref_9_c_2908_n ) capacitor c=0.0036878f \
 //x=8.395 //y=1.125 //x2=8.795 //y2=0.54
cc_344 ( N_noxref_1_c_3_p N_noxref_9_c_2908_n ) capacitor c=0.00399931f \
 //x=8.795 //y=1.665 //x2=8.795 //y2=0.54
cc_345 ( N_noxref_1_M5_noxref_d N_noxref_9_c_2908_n ) capacitor c=0.00910163f \
 //x=8.205 //y=0.915 //x2=8.795 //y2=0.54
cc_346 ( N_noxref_1_M5_noxref_d N_noxref_9_c_2911_n ) capacitor c=0.00120711f \
 //x=8.205 //y=0.915 //x2=7.91 //y2=0.995
cc_347 ( N_noxref_1_c_143_p N_noxref_9_M4_noxref_d ) capacitor c=0.00162433f \
 //x=7.1 //y=5.155 //x2=6.67 //y2=0.91
cc_348 ( N_noxref_1_c_16_p N_noxref_9_M4_noxref_d ) capacitor c=0.00802836f \
 //x=8.395 //y=1.125 //x2=6.67 //y2=0.91
cc_349 ( N_noxref_1_c_16_p N_noxref_9_M5_noxref_s ) capacitor c=0.00993092f \
 //x=8.395 //y=1.125 //x2=7.775 //y2=0.375
cc_350 ( N_noxref_1_c_2_p N_noxref_9_M5_noxref_s ) capacitor c=0.0270624f \
 //x=8.395 //y=1.58 //x2=7.775 //y2=0.375
cc_351 ( N_noxref_1_c_3_p N_noxref_9_M5_noxref_s ) capacitor c=0.00871957f \
 //x=8.795 //y=1.665 //x2=7.775 //y2=0.375
cc_352 ( N_noxref_1_c_164_p N_noxref_9_M5_noxref_s ) capacitor c=0.0016218f \
 //x=8.88 //y=3.33 //x2=7.775 //y2=0.375
cc_353 ( N_noxref_1_c_112_p N_noxref_9_M5_noxref_s ) capacitor c=0.00246663f \
 //x=9.045 //y=3.33 //x2=7.775 //y2=0.375
cc_354 ( N_noxref_1_M5_noxref_d N_noxref_9_M5_noxref_s ) capacitor \
 c=0.0279003f //x=8.205 //y=0.915 //x2=7.775 //y2=0.375
cc_355 ( N_noxref_1_c_112_p N_noxref_10_c_2975_n ) capacitor c=0.00242061f \
 //x=9.045 //y=3.33 //x2=7.03 //y2=2.195
cc_356 ( N_noxref_1_c_143_p N_noxref_10_c_2976_n ) capacitor c=0.0213631f \
 //x=7.1 //y=5.155 //x2=7.03 //y2=4.585
cc_357 ( N_noxref_1_c_155_p N_noxref_10_c_2976_n ) capacitor c=0.00172399f \
 //x=8.88 //y=3.17 //x2=7.03 //y2=4.585
cc_358 ( N_noxref_1_c_6_p N_noxref_10_c_2976_n ) capacitor c=0.00135693f \
 //x=8.88 //y=5.07 //x2=7.03 //y2=4.585
cc_359 ( N_noxref_1_c_40_p N_noxref_10_c_2976_n ) capacitor c=0.00239361f \
 //x=7.22 //y=5.155 //x2=7.03 //y2=4.585
cc_360 ( N_noxref_1_c_112_p N_noxref_10_c_2976_n ) capacitor c=0.0289072f \
 //x=9.045 //y=3.33 //x2=7.03 //y2=4.585
cc_361 ( N_noxref_1_c_284_p N_noxref_10_c_2976_n ) capacitor c=7.85344e-19 \
 //x=7.22 //y=5.38 //x2=7.03 //y2=4.585
cc_362 ( N_noxref_1_c_143_p N_noxref_10_c_2982_n ) capacitor c=0.00492634f \
 //x=7.1 //y=5.155 //x2=7.03 //y2=4.7
cc_363 ( N_noxref_1_c_40_p N_noxref_10_c_2982_n ) capacitor c=0.00132214f \
 //x=7.22 //y=5.155 //x2=7.03 //y2=4.7
cc_364 ( N_noxref_1_c_143_p N_noxref_10_M24_noxref_g ) capacitor c=0.00858241f \
 //x=7.1 //y=5.155 //x2=7 //y2=6.02
cc_365 ( N_noxref_1_c_40_p N_noxref_10_M24_noxref_g ) capacitor c=0.00229818f \
 //x=7.22 //y=5.155 //x2=7 //y2=6.02
cc_366 ( N_noxref_1_c_284_p N_noxref_10_M24_noxref_g ) capacitor c=0.0179041f \
 //x=7.22 //y=5.38 //x2=7 //y2=6.02
cc_367 ( N_noxref_1_c_186_p N_noxref_10_M25_noxref_g ) capacitor c=0.00955829f \
 //x=7.985 //y=5.155 //x2=7.44 //y2=6.02
cc_368 ( N_noxref_1_c_40_p N_noxref_10_M25_noxref_g ) capacitor c=0.00230699f \
 //x=7.22 //y=5.155 //x2=7.44 //y2=6.02
cc_369 ( N_noxref_1_c_284_p N_noxref_10_M25_noxref_g ) capacitor c=0.0179041f \
 //x=7.22 //y=5.38 //x2=7.44 //y2=6.02
cc_370 ( N_noxref_1_c_40_p N_noxref_10_c_2990_n ) capacitor c=0.00171075f \
 //x=7.22 //y=5.155 //x2=7.365 //y2=4.79
cc_371 ( N_noxref_1_c_284_p N_noxref_10_c_2990_n ) capacitor c=0.00290085f \
 //x=7.22 //y=5.38 //x2=7.365 //y2=4.79
cc_372 ( N_noxref_1_c_143_p N_noxref_10_c_2992_n ) capacitor c=6.38058e-19 \
 //x=7.1 //y=5.155 //x2=7.03 //y2=4.7
cc_373 ( N_noxref_1_c_24_p N_noxref_16_c_3560_n ) capacitor c=0.00219445f \
 //x=3.33 //y=2.195 //x2=5.8 //y2=0
cc_374 ( N_noxref_1_c_16_p N_noxref_16_c_3561_n ) capacitor c=0.00876454f \
 //x=8.395 //y=1.125 //x2=10.715 //y2=0
cc_375 ( N_noxref_1_c_3_p N_noxref_16_c_3561_n ) capacitor c=0.00661744f \
 //x=8.795 //y=1.665 //x2=10.715 //y2=0
cc_376 ( N_noxref_1_c_121_p N_noxref_16_c_3561_n ) capacitor c=2.94538e-19 \
 //x=8.88 //y=3.49 //x2=10.715 //y2=0
cc_377 ( N_noxref_1_M5_noxref_d N_noxref_16_c_3561_n ) capacitor c=2.94508e-19 \
 //x=8.205 //y=0.915 //x2=10.715 //y2=0
cc_378 ( N_noxref_1_c_16_p N_noxref_16_c_3565_n ) capacitor c=0.00488628f \
 //x=8.395 //y=1.125 //x2=10.8 //y2=0.955
cc_379 ( N_noxref_1_c_176_p N_noxref_16_c_3565_n ) capacitor c=0.00644063f \
 //x=10.73 //y=2.08 //x2=10.8 //y2=0.955
cc_380 ( N_noxref_1_c_180_p N_noxref_16_c_3565_n ) capacitor c=2.13705e-19 \
 //x=10.73 //y=2.08 //x2=10.8 //y2=0.955
cc_381 ( N_noxref_1_c_258_p N_noxref_16_c_3565_n ) capacitor c=0.00176535f \
 //x=10.535 //y=0.865 //x2=10.8 //y2=0.955
cc_382 ( N_noxref_1_c_259_p N_noxref_16_c_3565_n ) capacitor c=0.0036005f \
 //x=10.535 //y=1.21 //x2=10.8 //y2=0.955
cc_383 ( N_noxref_1_c_261_p N_noxref_16_c_3565_n ) capacitor c=4.2764e-19 \
 //x=10.535 //y=1.52 //x2=10.8 //y2=0.955
cc_384 ( N_noxref_1_c_384_p N_noxref_16_c_3565_n ) capacitor c=9.36995e-19 \
 //x=10.91 //y=0.71 //x2=10.8 //y2=0.955
cc_385 ( N_noxref_1_c_385_p N_noxref_16_c_3565_n ) capacitor c=6.27472e-19 \
 //x=10.91 //y=1.365 //x2=10.8 //y2=0.955
cc_386 ( N_noxref_1_c_260_p N_noxref_16_c_3565_n ) capacitor c=0.00171483f \
 //x=11.065 //y=0.865 //x2=10.8 //y2=0.955
cc_387 ( N_noxref_1_c_262_p N_noxref_16_c_3565_n ) capacitor c=0.00296337f \
 //x=11.065 //y=1.21 //x2=10.8 //y2=0.955
cc_388 ( N_noxref_1_c_258_p N_noxref_16_c_3575_n ) capacitor c=3.51399e-19 \
 //x=10.535 //y=0.865 //x2=10.797 //y2=0.825
cc_389 ( N_noxref_1_c_384_p N_noxref_16_c_3575_n ) capacitor c=0.00850809f \
 //x=10.91 //y=0.71 //x2=10.797 //y2=0.825
cc_390 ( N_noxref_1_c_260_p N_noxref_16_c_3575_n ) capacitor c=4.40196e-19 \
 //x=11.065 //y=0.865 //x2=10.797 //y2=0.825
cc_391 ( N_noxref_1_c_24_p N_noxref_16_c_3578_n ) capacitor c=2.01623e-19 \
 //x=3.33 //y=2.195 //x2=4.64 //y2=0
cc_392 ( N_noxref_1_c_3_p N_noxref_16_c_3579_n ) capacitor c=6.86937e-19 \
 //x=8.795 //y=1.665 //x2=9.45 //y2=0
cc_393 ( N_noxref_1_c_121_p N_noxref_16_c_3579_n ) capacitor c=4.03185e-19 \
 //x=8.88 //y=3.49 //x2=9.45 //y2=0
cc_394 ( N_noxref_1_c_258_p N_noxref_16_c_3581_n ) capacitor c=0.00685132f \
 //x=10.535 //y=0.865 //x2=12.78 //y2=0
cc_395 ( N_noxref_1_c_110_p N_noxref_16_c_3582_n ) capacitor c=0.00560353f \
 //x=5.54 //y=3.33 //x2=4.81 //y2=0
cc_396 ( N_noxref_1_c_25_p N_noxref_16_c_3582_n ) capacitor c=0.00246191f \
 //x=3.33 //y=2.08 //x2=4.81 //y2=0
cc_397 ( N_noxref_1_c_81_p N_noxref_16_c_3582_n ) capacitor c=0.00262688f \
 //x=3.85 //y=1.26 //x2=4.81 //y2=0
cc_398 ( N_noxref_1_c_2_p N_noxref_16_c_3585_n ) capacitor c=0.00285697f \
 //x=8.395 //y=1.58 //x2=9.62 //y2=0
cc_399 ( N_noxref_1_c_3_p N_noxref_16_c_3585_n ) capacitor c=0.0329558f \
 //x=8.795 //y=1.665 //x2=9.62 //y2=0
cc_400 ( N_noxref_1_c_5_p N_noxref_16_c_3585_n ) capacitor c=0.00781993f \
 //x=10.73 //y=3.17 //x2=9.62 //y2=0
cc_401 ( N_noxref_1_c_176_p N_noxref_16_c_3585_n ) capacitor c=0.00351582f \
 //x=10.73 //y=2.08 //x2=9.62 //y2=0
cc_402 ( N_noxref_1_c_123_p N_noxref_16_c_3585_n ) capacitor c=0.00391506f \
 //x=10.57 //y=3.33 //x2=9.62 //y2=0
cc_403 ( N_noxref_1_c_180_p N_noxref_16_c_3585_n ) capacitor c=0.00371068f \
 //x=10.73 //y=2.08 //x2=9.62 //y2=0
cc_404 ( N_noxref_1_c_261_p N_noxref_16_c_3585_n ) capacitor c=0.0015404f \
 //x=10.535 //y=1.52 //x2=9.62 //y2=0
cc_405 ( N_noxref_1_c_236_p N_noxref_16_c_3585_n ) capacitor c=0.0093907f \
 //x=10.535 //y=1.915 //x2=9.62 //y2=0
cc_406 ( N_noxref_1_c_176_p N_noxref_16_M6_noxref_d ) capacitor c=2.20438e-19 \
 //x=10.73 //y=2.08 //x2=10.61 //y2=0.865
cc_407 ( N_noxref_1_c_258_p N_noxref_16_M6_noxref_d ) capacitor c=0.00192399f \
 //x=10.535 //y=0.865 //x2=10.61 //y2=0.865
cc_408 ( N_noxref_1_c_259_p N_noxref_16_M6_noxref_d ) capacitor c=0.00210798f \
 //x=10.535 //y=1.21 //x2=10.61 //y2=0.865
cc_409 ( N_noxref_1_c_384_p N_noxref_16_M6_noxref_d ) capacitor c=0.00472259f \
 //x=10.91 //y=0.71 //x2=10.61 //y2=0.865
cc_410 ( N_noxref_1_c_385_p N_noxref_16_M6_noxref_d ) capacitor c=0.00166857f \
 //x=10.91 //y=1.365 //x2=10.61 //y2=0.865
cc_411 ( N_noxref_1_c_260_p N_noxref_16_M6_noxref_d ) capacitor c=0.00230174f \
 //x=11.065 //y=0.865 //x2=10.61 //y2=0.865
cc_412 ( N_noxref_1_c_262_p N_noxref_16_M6_noxref_d ) capacitor c=0.00210798f \
 //x=11.065 //y=1.21 //x2=10.61 //y2=0.865
cc_413 ( N_noxref_1_c_110_p N_noxref_19_c_4180_n ) capacitor c=0.00270802f \
 //x=5.54 //y=3.33 //x2=5.4 //y2=1.505
cc_414 ( N_noxref_1_c_110_p N_noxref_19_c_4181_n ) capacitor c=0.00768002f \
 //x=5.54 //y=3.33 //x2=6.285 //y2=1.59
cc_415 ( N_noxref_1_c_112_p N_noxref_19_c_4181_n ) capacitor c=8.84534e-19 \
 //x=9.045 //y=3.33 //x2=6.285 //y2=1.59
cc_416 ( N_noxref_1_c_112_p N_noxref_19_c_4183_n ) capacitor c=0.00797763f \
 //x=9.045 //y=3.33 //x2=7.255 //y2=1.59
cc_417 ( N_noxref_1_c_112_p N_noxref_19_M3_noxref_s ) capacitor c=0.00523529f \
 //x=9.045 //y=3.33 //x2=5.265 //y2=0.375
cc_418 ( N_noxref_1_c_236_p N_noxref_20_c_4238_n ) capacitor c=0.00262672f \
 //x=10.535 //y=1.915 //x2=10.315 //y2=1.495
cc_419 ( N_noxref_1_c_10_p N_noxref_20_c_4239_n ) capacitor c=0.00406558f \
 //x=10.73 //y=3.49 //x2=11.2 //y2=1.58
cc_420 ( N_noxref_1_c_176_p N_noxref_20_c_4239_n ) capacitor c=0.00509504f \
 //x=10.73 //y=2.08 //x2=11.2 //y2=1.58
cc_421 ( N_noxref_1_c_180_p N_noxref_20_c_4239_n ) capacitor c=0.00763108f \
 //x=10.73 //y=2.08 //x2=11.2 //y2=1.58
cc_422 ( N_noxref_1_c_261_p N_noxref_20_c_4239_n ) capacitor c=0.00697076f \
 //x=10.535 //y=1.52 //x2=11.2 //y2=1.58
cc_423 ( N_noxref_1_c_236_p N_noxref_20_c_4239_n ) capacitor c=0.0170561f \
 //x=10.535 //y=1.915 //x2=11.2 //y2=1.58
cc_424 ( N_noxref_1_c_385_p N_noxref_20_c_4239_n ) capacitor c=0.00723574f \
 //x=10.91 //y=1.365 //x2=11.2 //y2=1.58
cc_425 ( N_noxref_1_c_262_p N_noxref_20_c_4239_n ) capacitor c=0.00339872f \
 //x=11.065 //y=1.21 //x2=11.2 //y2=1.58
cc_426 ( N_noxref_1_c_236_p N_noxref_20_c_4246_n ) capacitor c=6.71402e-19 \
 //x=10.535 //y=1.915 //x2=11.285 //y2=1.495
cc_427 ( N_noxref_1_c_258_p N_noxref_20_M6_noxref_s ) capacitor c=0.0295366f \
 //x=10.535 //y=0.865 //x2=10.18 //y2=0.365
cc_428 ( N_noxref_1_c_261_p N_noxref_20_M6_noxref_s ) capacitor c=3.48408e-19 \
 //x=10.535 //y=1.52 //x2=10.18 //y2=0.365
cc_429 ( N_noxref_1_c_260_p N_noxref_20_M6_noxref_s ) capacitor c=0.0125442f \
 //x=11.065 //y=0.865 //x2=10.18 //y2=0.365
cc_430 ( N_noxref_2_c_453_p N_noxref_3_c_743_n ) capacitor c=0.00894339f \
 //x=14.06 //y=2.195 //x2=15.17 //y2=2.195
cc_431 ( N_noxref_2_c_454_p N_noxref_3_c_743_n ) capacitor c=5.40058e-19 \
 //x=14.06 //y=2.08 //x2=15.17 //y2=2.195
cc_432 ( N_noxref_2_c_455_p N_noxref_3_c_743_n ) capacitor c=0.00142893f \
 //x=13.76 //y=1.915 //x2=15.17 //y2=2.195
cc_433 ( N_noxref_2_c_433_n N_noxref_3_c_746_n ) capacitor c=0.00137941f \
 //x=12.21 //y=3.175 //x2=15.17 //y2=4.355
cc_434 ( N_noxref_2_c_435_n N_noxref_3_c_746_n ) capacitor c=7.56903e-19 \
 //x=12.21 //y=5.115 //x2=15.17 //y2=4.355
cc_435 ( N_noxref_2_c_458_p N_noxref_3_c_746_n ) capacitor c=0.0286724f \
 //x=14.06 //y=3.175 //x2=15.17 //y2=4.355
cc_436 ( N_noxref_2_c_459_p N_noxref_3_c_746_n ) capacitor c=0.00781344f \
 //x=14.06 //y=3.495 //x2=15.17 //y2=4.355
cc_437 ( N_noxref_2_c_460_p N_noxref_3_c_746_n ) capacitor c=0.0204064f \
 //x=14.06 //y=4.575 //x2=15.17 //y2=4.355
cc_438 ( N_noxref_2_c_461_p N_noxref_3_c_746_n ) capacitor c=2.98349e-19 \
 //x=14.06 //y=3.33 //x2=15.17 //y2=4.355
cc_439 ( N_noxref_2_c_462_p N_noxref_3_c_746_n ) capacitor c=0.00510347f \
 //x=14.065 //y=3.335 //x2=15.17 //y2=4.355
cc_440 ( N_noxref_2_c_454_p N_noxref_3_c_746_n ) capacitor c=3.9149e-19 \
 //x=14.06 //y=2.08 //x2=15.17 //y2=4.355
cc_441 ( N_noxref_2_c_460_p N_noxref_3_c_754_n ) capacitor c=0.0128897f \
 //x=14.06 //y=4.575 //x2=15.165 //y2=4.515
cc_442 ( N_noxref_2_c_465_p N_noxref_3_c_754_n ) capacitor c=8.3916e-19 \
 //x=14.06 //y=4.7 //x2=15.165 //y2=4.515
cc_443 ( N_noxref_2_c_466_p N_noxref_3_c_754_n ) capacitor c=7.66769e-19 \
 //x=14.625 //y=4.79 //x2=15.165 //y2=4.515
cc_444 ( N_noxref_2_c_467_p N_noxref_3_c_754_n ) capacitor c=9.07197e-19 \
 //x=14.335 //y=4.79 //x2=15.165 //y2=4.515
cc_445 ( N_noxref_2_c_430_n N_noxref_3_c_714_n ) capacitor c=0.00608733f \
 //x=11.615 //y=5.2 //x2=11.09 //y2=4.44
cc_446 ( N_noxref_2_c_437_n N_noxref_3_c_714_n ) capacitor c=0.0154492f \
 //x=10.85 //y=5.38 //x2=11.09 //y2=4.44
cc_447 ( N_noxref_2_c_435_n N_noxref_3_c_760_n ) capacitor c=0.0290879f \
 //x=12.21 //y=5.115 //x2=11.69 //y2=4.455
cc_448 ( N_noxref_2_c_460_p N_noxref_3_c_760_n ) capacitor c=0.0355055f \
 //x=14.06 //y=4.575 //x2=11.69 //y2=4.455
cc_449 ( N_noxref_2_c_472_p N_noxref_3_c_760_n ) capacitor c=0.0210804f \
 //x=11.73 //y=5.2 //x2=11.69 //y2=4.455
cc_450 ( N_noxref_2_c_453_p N_noxref_3_c_763_n ) capacitor c=5.39999e-19 \
 //x=14.06 //y=2.195 //x2=15.17 //y2=2.08
cc_451 ( N_noxref_2_c_458_p N_noxref_3_c_763_n ) capacitor c=3.9149e-19 \
 //x=14.06 //y=3.175 //x2=15.17 //y2=2.08
cc_452 ( N_noxref_2_c_454_p N_noxref_3_c_763_n ) capacitor c=0.00125213f \
 //x=14.06 //y=2.08 //x2=15.17 //y2=2.08
cc_453 ( N_noxref_2_c_455_p N_noxref_3_c_763_n ) capacitor c=0.00214573f \
 //x=13.76 //y=1.915 //x2=15.17 //y2=2.08
cc_454 ( N_noxref_2_c_460_p N_noxref_3_c_767_n ) capacitor c=5.64453e-19 \
 //x=14.06 //y=4.575 //x2=15.17 //y2=4.7
cc_455 ( N_noxref_2_c_465_p N_noxref_3_c_767_n ) capacitor c=0.00113666f \
 //x=14.06 //y=4.7 //x2=15.17 //y2=4.7
cc_456 ( N_noxref_2_c_466_p N_noxref_3_c_767_n ) capacitor c=0.00116563f \
 //x=14.625 //y=4.79 //x2=15.17 //y2=4.7
cc_457 ( N_noxref_2_c_467_p N_noxref_3_c_767_n ) capacitor c=0.0012974f \
 //x=14.335 //y=4.79 //x2=15.17 //y2=4.7
cc_458 ( N_noxref_2_M32_noxref_g N_noxref_3_M34_noxref_g ) capacitor \
 c=0.0106276f //x=14.26 //y=6.02 //x2=15.14 //y2=6.02
cc_459 ( N_noxref_2_M33_noxref_g N_noxref_3_M34_noxref_g ) capacitor \
 c=0.107144f //x=14.7 //y=6.02 //x2=15.14 //y2=6.02
cc_460 ( N_noxref_2_M33_noxref_g N_noxref_3_M35_noxref_g ) capacitor \
 c=0.0101598f //x=14.7 //y=6.02 //x2=15.58 //y2=6.02
cc_461 ( N_noxref_2_c_484_p N_noxref_3_c_774_n ) capacitor c=5.72528e-19 \
 //x=13.76 //y=0.875 //x2=14.735 //y2=0.91
cc_462 ( N_noxref_2_c_485_p N_noxref_3_c_774_n ) capacitor c=0.00150277f \
 //x=13.76 //y=1.22 //x2=14.735 //y2=0.91
cc_463 ( N_noxref_2_c_486_p N_noxref_3_c_774_n ) capacitor c=0.0160123f \
 //x=14.29 //y=0.875 //x2=14.735 //y2=0.91
cc_464 ( N_noxref_2_c_487_p N_noxref_3_c_777_n ) capacitor c=0.00111227f \
 //x=13.76 //y=1.53 //x2=14.735 //y2=1.22
cc_465 ( N_noxref_2_c_488_p N_noxref_3_c_777_n ) capacitor c=0.0124075f \
 //x=14.29 //y=1.22 //x2=14.735 //y2=1.22
cc_466 ( N_noxref_2_c_486_p N_noxref_3_c_779_n ) capacitor c=9.19165e-19 \
 //x=14.29 //y=0.875 //x2=15.26 //y2=0.91
cc_467 ( N_noxref_2_c_488_p N_noxref_3_c_780_n ) capacitor c=0.0010154f \
 //x=14.29 //y=1.22 //x2=15.26 //y2=1.22
cc_468 ( N_noxref_2_c_488_p N_noxref_3_c_781_n ) capacitor c=9.23422e-19 \
 //x=14.29 //y=1.22 //x2=15.26 //y2=1.45
cc_469 ( N_noxref_2_c_453_p N_noxref_3_c_782_n ) capacitor c=0.00136403f \
 //x=14.06 //y=2.195 //x2=15.26 //y2=1.915
cc_470 ( N_noxref_2_c_454_p N_noxref_3_c_782_n ) capacitor c=0.0020754f \
 //x=14.06 //y=2.08 //x2=15.26 //y2=1.915
cc_471 ( N_noxref_2_c_455_p N_noxref_3_c_782_n ) capacitor c=0.00964411f \
 //x=13.76 //y=1.915 //x2=15.26 //y2=1.915
cc_472 ( N_noxref_2_c_460_p N_noxref_3_c_785_n ) capacitor c=5.7788e-19 \
 //x=14.06 //y=4.575 //x2=15.17 //y2=4.7
cc_473 ( N_noxref_2_c_465_p N_noxref_3_c_785_n ) capacitor c=0.0013104f \
 //x=14.06 //y=4.7 //x2=15.17 //y2=4.7
cc_474 ( N_noxref_2_c_466_p N_noxref_3_c_785_n ) capacitor c=0.0171374f \
 //x=14.625 //y=4.79 //x2=15.17 //y2=4.7
cc_475 ( N_noxref_2_c_467_p N_noxref_3_c_785_n ) capacitor c=0.00419533f \
 //x=14.335 //y=4.79 //x2=15.17 //y2=4.7
cc_476 ( N_noxref_2_c_499_p N_noxref_4_c_1085_n ) capacitor c=0.0013819f \
 //x=12.21 //y=3.495 //x2=11.69 //y2=3.685
cc_477 ( N_noxref_2_c_435_n N_noxref_4_c_1085_n ) capacitor c=0.00102062f \
 //x=12.21 //y=5.115 //x2=11.69 //y2=3.685
cc_478 ( N_noxref_2_c_447_n N_noxref_4_c_1085_n ) capacitor c=0.0358254f \
 //x=12.37 //y=3.335 //x2=11.69 //y2=3.685
cc_479 ( N_noxref_2_c_499_p N_noxref_4_c_1088_n ) capacitor c=0.00765069f \
 //x=12.21 //y=3.495 //x2=12.425 //y2=3.72
cc_480 ( N_noxref_2_c_435_n N_noxref_4_c_1088_n ) capacitor c=0.022395f \
 //x=12.21 //y=5.115 //x2=12.425 //y2=3.72
cc_481 ( N_noxref_2_c_504_p N_noxref_4_c_1088_n ) capacitor c=0.128042f \
 //x=13.905 //y=3.335 //x2=12.425 //y2=3.72
cc_482 ( N_noxref_2_c_459_p N_noxref_4_c_1091_n ) capacitor c=0.00342064f \
 //x=14.06 //y=3.495 //x2=13.68 //y2=3.7
cc_483 ( N_noxref_2_c_460_p N_noxref_4_c_1091_n ) capacitor c=6.75872e-19 \
 //x=14.06 //y=4.575 //x2=13.68 //y2=3.7
cc_484 ( N_noxref_2_c_462_p N_noxref_4_c_1091_n ) capacitor c=0.0358254f \
 //x=14.065 //y=3.335 //x2=13.68 //y2=3.7
cc_485 ( N_noxref_2_c_504_p N_noxref_4_c_1091_n ) capacitor c=0.0106805f \
 //x=13.905 //y=3.335 //x2=13.68 //y2=3.7
cc_486 ( N_noxref_2_c_459_p N_noxref_4_c_1095_n ) capacitor c=0.00292429f \
 //x=14.06 //y=3.495 //x2=14.28 //y2=3.72
cc_487 ( N_noxref_2_c_460_p N_noxref_4_c_1095_n ) capacitor c=0.023831f \
 //x=14.06 //y=4.575 //x2=14.28 //y2=3.72
cc_488 ( N_noxref_2_c_458_p N_noxref_5_c_1515_n ) capacitor c=0.00130368f \
 //x=14.06 //y=3.175 //x2=16.28 //y2=4.57
cc_489 ( N_noxref_2_c_460_p N_noxref_5_c_1515_n ) capacitor c=0.00126605f \
 //x=14.06 //y=4.575 //x2=16.28 //y2=4.57
cc_490 ( N_noxref_2_c_432_n N_noxref_5_c_1470_n ) capacitor c=0.0193939f \
 //x=11.855 //y=1.655 //x2=16.125 //y2=2.135
cc_491 ( N_noxref_2_c_433_n N_noxref_5_c_1470_n ) capacitor c=0.0321972f \
 //x=12.21 //y=3.175 //x2=16.125 //y2=2.135
cc_492 ( N_noxref_2_c_499_p N_noxref_5_c_1470_n ) capacitor c=0.00327078f \
 //x=12.21 //y=3.495 //x2=16.125 //y2=2.135
cc_493 ( N_noxref_2_c_453_p N_noxref_5_c_1470_n ) capacitor c=0.016619f \
 //x=14.06 //y=2.195 //x2=16.125 //y2=2.135
cc_494 ( N_noxref_2_c_458_p N_noxref_5_c_1470_n ) capacitor c=0.018395f \
 //x=14.06 //y=3.175 //x2=16.125 //y2=2.135
cc_495 ( N_noxref_2_c_459_p N_noxref_5_c_1470_n ) capacitor c=0.00342885f \
 //x=14.06 //y=3.495 //x2=16.125 //y2=2.135
cc_496 ( N_noxref_2_c_445_n N_noxref_5_c_1470_n ) capacitor c=7.09092e-19 \
 //x=11.77 //y=1 //x2=16.125 //y2=2.135
cc_497 ( N_noxref_2_c_447_n N_noxref_5_c_1470_n ) capacitor c=0.00806725f \
 //x=12.37 //y=3.335 //x2=16.125 //y2=2.135
cc_498 ( N_noxref_2_c_462_p N_noxref_5_c_1470_n ) capacitor c=0.00830358f \
 //x=14.065 //y=3.335 //x2=16.125 //y2=2.135
cc_499 ( N_noxref_2_c_504_p N_noxref_5_c_1470_n ) capacitor c=0.0483895f \
 //x=13.905 //y=3.335 //x2=16.125 //y2=2.135
cc_500 ( N_noxref_2_c_454_p N_noxref_5_c_1470_n ) capacitor c=5.18204e-19 \
 //x=14.06 //y=2.08 //x2=16.125 //y2=2.135
cc_501 ( N_noxref_2_c_433_n N_noxref_6_c_1865_n ) capacitor c=0.0418808f \
 //x=12.21 //y=3.175 //x2=11.47 //y2=3.91
cc_502 ( N_noxref_2_c_499_p N_noxref_6_c_1865_n ) capacitor c=0.0148501f \
 //x=12.21 //y=3.495 //x2=11.47 //y2=3.91
cc_503 ( N_noxref_2_c_435_n N_noxref_6_c_1865_n ) capacitor c=0.0164753f \
 //x=12.21 //y=5.115 //x2=11.47 //y2=3.91
cc_504 ( N_noxref_2_c_458_p N_noxref_6_c_1865_n ) capacitor c=0.00191767f \
 //x=14.06 //y=3.175 //x2=11.47 //y2=3.91
cc_505 ( N_noxref_2_c_460_p N_noxref_6_c_1865_n ) capacitor c=3.10515e-19 \
 //x=14.06 //y=4.575 //x2=11.47 //y2=3.91
cc_506 ( N_noxref_2_c_446_n N_noxref_6_c_1865_n ) capacitor c=5.57251e-19 \
 //x=12.21 //y=3.33 //x2=11.47 //y2=3.91
cc_507 ( N_noxref_2_c_447_n N_noxref_6_c_1865_n ) capacitor c=0.00365657f \
 //x=12.37 //y=3.335 //x2=11.47 //y2=3.91
cc_508 ( N_noxref_2_c_430_n N_noxref_6_c_1873_n ) capacitor c=0.00424065f \
 //x=11.615 //y=5.2 //x2=11.47 //y2=4.23
cc_509 ( N_noxref_2_c_435_n N_noxref_6_c_1873_n ) capacitor c=0.0147977f \
 //x=12.21 //y=5.115 //x2=11.47 //y2=4.23
cc_510 ( N_noxref_2_c_430_n N_noxref_6_c_1874_n ) capacitor c=0.0215376f \
 //x=11.615 //y=5.2 //x2=11.47 //y2=4.555
cc_511 ( N_noxref_2_c_435_n N_noxref_6_c_1874_n ) capacitor c=0.0284267f \
 //x=12.21 //y=5.115 //x2=11.47 //y2=4.555
cc_512 ( N_noxref_2_c_460_p N_noxref_6_c_1874_n ) capacitor c=4.62211e-19 \
 //x=14.06 //y=4.575 //x2=11.47 //y2=4.555
cc_513 ( N_noxref_2_M33_noxref_g N_noxref_6_c_1932_n ) capacitor c=0.00893512f \
 //x=14.7 //y=6.02 //x2=15.24 //y2=5.155
cc_514 ( N_noxref_2_c_537_p N_noxref_6_c_1933_n ) capacitor c=8.29536e-19 \
 //x=12.125 //y=1.655 //x2=16.535 //y2=1.58
cc_515 ( N_noxref_2_c_433_n N_noxref_6_c_1934_n ) capacitor c=8.29536e-19 \
 //x=12.21 //y=3.175 //x2=16.62 //y2=1.665
cc_516 ( N_noxref_2_c_435_n N_noxref_6_c_1879_n ) capacitor c=6.15063e-19 \
 //x=12.21 //y=5.115 //x2=11.47 //y2=4.07
cc_517 ( N_noxref_2_c_433_n N_noxref_6_c_1880_n ) capacitor c=0.0138368f \
 //x=12.21 //y=3.175 //x2=11.47 //y2=2.08
cc_518 ( N_noxref_2_c_435_n N_noxref_6_c_1937_n ) capacitor c=0.00261914f \
 //x=12.21 //y=5.115 //x2=14.482 //y2=5.155
cc_519 ( N_noxref_2_c_472_p N_noxref_6_c_1937_n ) capacitor c=5.0812e-19 \
 //x=11.73 //y=5.2 //x2=14.482 //y2=5.155
cc_520 ( N_noxref_2_M32_noxref_g N_noxref_6_c_1937_n ) capacitor c=0.00461408f \
 //x=14.26 //y=6.02 //x2=14.482 //y2=5.155
cc_521 ( N_noxref_2_M33_noxref_g N_noxref_6_c_1937_n ) capacitor c=0.00229208f \
 //x=14.7 //y=6.02 //x2=14.482 //y2=5.155
cc_522 ( N_noxref_2_c_466_p N_noxref_6_c_1937_n ) capacitor c=0.00171885f \
 //x=14.625 //y=4.79 //x2=14.482 //y2=5.155
cc_523 ( N_noxref_2_c_435_n N_noxref_6_c_1942_n ) capacitor c=0.022727f \
 //x=12.21 //y=5.115 //x2=16.865 //y2=4.07
cc_524 ( N_noxref_2_c_460_p N_noxref_6_c_1942_n ) capacitor c=0.0246035f \
 //x=14.06 //y=4.575 //x2=16.865 //y2=4.07
cc_525 ( N_noxref_2_c_504_p N_noxref_6_c_1942_n ) capacitor c=0.0093607f \
 //x=13.905 //y=3.335 //x2=16.865 //y2=4.07
cc_526 ( N_noxref_2_c_435_n N_noxref_6_c_1890_n ) capacitor c=0.00328982f \
 //x=12.21 //y=5.115 //x2=11.635 //y2=4.07
cc_527 ( N_noxref_2_c_433_n N_noxref_6_c_1894_n ) capacitor c=9.26054e-19 \
 //x=12.21 //y=3.175 //x2=11.47 //y2=2.08
cc_528 ( N_noxref_2_c_430_n N_noxref_6_c_1898_n ) capacitor c=0.00469257f \
 //x=11.615 //y=5.2 //x2=11.5 //y2=4.7
cc_529 ( N_noxref_2_c_435_n N_noxref_6_c_1898_n ) capacitor c=7.76118e-19 \
 //x=12.21 //y=5.115 //x2=11.5 //y2=4.7
cc_530 ( N_noxref_2_M32_noxref_g N_noxref_6_c_1949_n ) capacitor c=0.0162284f \
 //x=14.26 //y=6.02 //x2=14.48 //y2=5.38
cc_531 ( N_noxref_2_M33_noxref_g N_noxref_6_c_1949_n ) capacitor c=0.0179041f \
 //x=14.7 //y=6.02 //x2=14.48 //y2=5.38
cc_532 ( N_noxref_2_c_466_p N_noxref_6_c_1949_n ) capacitor c=0.00291477f \
 //x=14.625 //y=4.79 //x2=14.48 //y2=5.38
cc_533 ( N_noxref_2_c_430_n N_noxref_6_M30_noxref_g ) capacitor c=0.00842859f \
 //x=11.615 //y=5.2 //x2=11.51 //y2=6.02
cc_534 ( N_noxref_2_c_472_p N_noxref_6_M30_noxref_g ) capacitor c=0.00192712f \
 //x=11.73 //y=5.2 //x2=11.51 //y2=6.02
cc_535 ( N_noxref_2_c_558_p N_noxref_6_M30_noxref_g ) capacitor c=0.0178987f \
 //x=11.73 //y=5.38 //x2=11.51 //y2=6.02
cc_536 ( N_noxref_2_c_559_p N_noxref_6_M31_noxref_g ) capacitor c=0.0106088f \
 //x=12.125 //y=5.2 //x2=11.95 //y2=6.02
cc_537 ( N_noxref_2_c_472_p N_noxref_6_M31_noxref_g ) capacitor c=0.00312463f \
 //x=11.73 //y=5.2 //x2=11.95 //y2=6.02
cc_538 ( N_noxref_2_c_558_p N_noxref_6_M31_noxref_g ) capacitor c=0.0178506f \
 //x=11.73 //y=5.38 //x2=11.95 //y2=6.02
cc_539 ( N_noxref_2_c_445_n N_noxref_6_c_1904_n ) capacitor c=0.00120406f \
 //x=11.77 //y=1 //x2=11.505 //y2=0.905
cc_540 ( N_noxref_2_M7_noxref_d N_noxref_6_c_1904_n ) capacitor c=0.00137165f \
 //x=11.58 //y=0.905 //x2=11.505 //y2=0.905
cc_541 ( N_noxref_2_c_431_n N_noxref_6_c_1907_n ) capacitor c=0.00119302f \
 //x=11.77 //y=1.57 //x2=11.505 //y2=1.25
cc_542 ( N_noxref_2_c_445_n N_noxref_6_c_1907_n ) capacitor c=0.00218772f \
 //x=11.77 //y=1 //x2=11.505 //y2=1.25
cc_543 ( N_noxref_2_M7_noxref_d N_noxref_6_c_1907_n ) capacitor c=0.00237422f \
 //x=11.58 //y=0.905 //x2=11.505 //y2=1.25
cc_544 ( N_noxref_2_c_431_n N_noxref_6_c_1909_n ) capacitor c=0.00439215f \
 //x=11.77 //y=1.57 //x2=11.505 //y2=1.56
cc_545 ( N_noxref_2_c_435_n N_noxref_6_c_1964_n ) capacitor c=0.00845606f \
 //x=12.21 //y=5.115 //x2=11.875 //y2=4.79
cc_546 ( N_noxref_2_c_472_p N_noxref_6_c_1964_n ) capacitor c=0.0020909f \
 //x=11.73 //y=5.2 //x2=11.875 //y2=4.79
cc_547 ( N_noxref_2_c_558_p N_noxref_6_c_1964_n ) capacitor c=0.00291714f \
 //x=11.73 //y=5.38 //x2=11.875 //y2=4.79
cc_548 ( N_noxref_2_c_445_n N_noxref_6_c_1967_n ) capacitor c=5.50523e-19 \
 //x=11.77 //y=1 //x2=11.88 //y2=0.75
cc_549 ( N_noxref_2_M7_noxref_d N_noxref_6_c_1967_n ) capacitor c=0.0020782f \
 //x=11.58 //y=0.905 //x2=11.88 //y2=0.75
cc_550 ( N_noxref_2_c_431_n N_noxref_6_c_1969_n ) capacitor c=0.00929773f \
 //x=11.77 //y=1.57 //x2=11.88 //y2=1.405
cc_551 ( N_noxref_2_c_537_p N_noxref_6_c_1969_n ) capacitor c=0.00194324f \
 //x=12.125 //y=1.655 //x2=11.88 //y2=1.405
cc_552 ( N_noxref_2_c_445_n N_noxref_6_c_1969_n ) capacitor c=5.67071e-19 \
 //x=11.77 //y=1 //x2=11.88 //y2=1.405
cc_553 ( N_noxref_2_M7_noxref_d N_noxref_6_c_1969_n ) capacitor c=0.00356097f \
 //x=11.58 //y=0.905 //x2=11.88 //y2=1.405
cc_554 ( N_noxref_2_c_445_n N_noxref_6_c_1912_n ) capacitor c=0.00108157f \
 //x=11.77 //y=1 //x2=12.035 //y2=0.905
cc_555 ( N_noxref_2_M7_noxref_d N_noxref_6_c_1912_n ) capacitor c=8.50095e-19 \
 //x=11.58 //y=0.905 //x2=12.035 //y2=0.905
cc_556 ( N_noxref_2_c_431_n N_noxref_6_c_1913_n ) capacitor c=0.00341295f \
 //x=11.77 //y=1.57 //x2=12.035 //y2=1.25
cc_557 ( N_noxref_2_c_537_p N_noxref_6_c_1913_n ) capacitor c=0.00323005f \
 //x=12.125 //y=1.655 //x2=12.035 //y2=1.25
cc_558 ( N_noxref_2_c_445_n N_noxref_6_c_1913_n ) capacitor c=0.00312028f \
 //x=11.77 //y=1 //x2=12.035 //y2=1.25
cc_559 ( N_noxref_2_M7_noxref_d N_noxref_6_c_1913_n ) capacitor c=0.00237422f \
 //x=11.58 //y=0.905 //x2=12.035 //y2=1.25
cc_560 ( N_noxref_2_c_433_n N_noxref_6_c_1914_n ) capacitor c=0.00268898f \
 //x=12.21 //y=3.175 //x2=11.47 //y2=2.08
cc_561 ( N_noxref_2_c_431_n N_noxref_6_c_1980_n ) capacitor c=0.00341688f \
 //x=11.77 //y=1.57 //x2=11.47 //y2=1.915
cc_562 ( N_noxref_2_c_433_n N_noxref_6_c_1980_n ) capacitor c=0.00309058f \
 //x=12.21 //y=3.175 //x2=11.47 //y2=1.915
cc_563 ( N_noxref_2_c_430_n N_noxref_6_c_1917_n ) capacitor c=8.42507e-19 \
 //x=11.615 //y=5.2 //x2=11.5 //y2=4.7
cc_564 ( N_noxref_2_c_435_n N_noxref_6_c_1917_n ) capacitor c=0.00142201f \
 //x=12.21 //y=5.115 //x2=11.5 //y2=4.7
cc_565 ( N_noxref_2_c_430_n N_noxref_7_c_2451_n ) capacitor c=0.00647526f \
 //x=11.615 //y=5.2 //x2=25.53 //y2=7.4
cc_566 ( N_noxref_2_c_559_p N_noxref_7_c_2451_n ) capacitor c=0.00491449f \
 //x=12.125 //y=5.2 //x2=25.53 //y2=7.4
cc_567 ( N_noxref_2_c_499_p N_noxref_7_c_2451_n ) capacitor c=4.58386e-19 \
 //x=12.21 //y=3.495 //x2=25.53 //y2=7.4
cc_568 ( N_noxref_2_c_459_p N_noxref_7_c_2451_n ) capacitor c=3.98982e-19 \
 //x=14.06 //y=3.495 //x2=25.53 //y2=7.4
cc_569 ( N_noxref_2_c_437_n N_noxref_7_c_2451_n ) capacitor c=0.00368144f \
 //x=10.85 //y=5.38 //x2=25.53 //y2=7.4
cc_570 ( N_noxref_2_c_472_p N_noxref_7_c_2451_n ) capacitor c=8.41092e-19 \
 //x=11.73 //y=5.2 //x2=25.53 //y2=7.4
cc_571 ( N_noxref_2_c_594_p N_noxref_7_c_2451_n ) capacitor c=0.00285294f \
 //x=11.73 //y=5.38 //x2=25.53 //y2=7.4
cc_572 ( N_noxref_2_c_448_n N_noxref_7_c_2451_n ) capacitor c=0.00224727f \
 //x=10.85 //y=5.38 //x2=25.53 //y2=7.4
cc_573 ( N_noxref_2_c_558_p N_noxref_7_c_2451_n ) capacitor c=0.00224727f \
 //x=11.73 //y=5.38 //x2=25.53 //y2=7.4
cc_574 ( N_noxref_2_c_430_n N_noxref_7_c_2478_n ) capacitor c=0.00208112f \
 //x=11.615 //y=5.2 //x2=11.205 //y2=7.4
cc_575 ( N_noxref_2_c_437_n N_noxref_7_c_2478_n ) capacitor c=9.41091e-19 \
 //x=10.85 //y=5.38 //x2=11.205 //y2=7.4
cc_576 ( N_noxref_2_c_448_n N_noxref_7_c_2478_n ) capacitor c=0.0136475f \
 //x=10.85 //y=5.38 //x2=11.205 //y2=7.4
cc_577 ( N_noxref_2_c_430_n N_noxref_7_c_2522_n ) capacitor c=0.00180744f \
 //x=11.615 //y=5.2 //x2=12.085 //y2=7.4
cc_578 ( N_noxref_2_c_559_p N_noxref_7_c_2522_n ) capacitor c=0.00208112f \
 //x=12.125 //y=5.2 //x2=12.085 //y2=7.4
cc_579 ( N_noxref_2_c_472_p N_noxref_7_c_2522_n ) capacitor c=4.23323e-19 \
 //x=11.73 //y=5.2 //x2=12.085 //y2=7.4
cc_580 ( N_noxref_2_c_594_p N_noxref_7_c_2522_n ) capacitor c=5.78261e-19 \
 //x=11.73 //y=5.38 //x2=12.085 //y2=7.4
cc_581 ( N_noxref_2_c_558_p N_noxref_7_c_2522_n ) capacitor c=0.0136475f \
 //x=11.73 //y=5.38 //x2=12.085 //y2=7.4
cc_582 ( N_noxref_2_M32_noxref_g N_noxref_7_c_2527_n ) capacitor c=0.00749687f \
 //x=14.26 //y=6.02 //x2=14.835 //y2=7.4
cc_583 ( N_noxref_2_M33_noxref_g N_noxref_7_c_2527_n ) capacitor c=0.00749619f \
 //x=14.7 //y=6.02 //x2=14.835 //y2=7.4
cc_584 ( N_noxref_2_c_435_n N_noxref_7_c_2485_n ) capacitor c=0.0013228f \
 //x=12.21 //y=5.115 //x2=9.62 //y2=7.4
cc_585 ( N_noxref_2_c_437_n N_noxref_7_c_2485_n ) capacitor c=4.91377e-19 \
 //x=10.85 //y=5.38 //x2=9.62 //y2=7.4
cc_586 ( N_noxref_2_c_448_n N_noxref_7_c_2485_n ) capacitor c=0.0064135f \
 //x=10.85 //y=5.38 //x2=9.62 //y2=7.4
cc_587 ( N_noxref_2_c_435_n N_noxref_7_c_2532_n ) capacitor c=0.0294123f \
 //x=12.21 //y=5.115 //x2=12.95 //y2=7.4
cc_588 ( N_noxref_2_c_460_p N_noxref_7_c_2532_n ) capacitor c=0.0119111f \
 //x=14.06 //y=4.575 //x2=12.95 //y2=7.4
cc_589 ( N_noxref_2_c_472_p N_noxref_7_c_2532_n ) capacitor c=0.0025639f \
 //x=11.73 //y=5.2 //x2=12.95 //y2=7.4
cc_590 ( N_noxref_2_c_594_p N_noxref_7_c_2532_n ) capacitor c=4.19141e-19 \
 //x=11.73 //y=5.38 //x2=12.95 //y2=7.4
cc_591 ( N_noxref_2_c_558_p N_noxref_7_c_2532_n ) capacitor c=0.0101861f \
 //x=11.73 //y=5.38 //x2=12.95 //y2=7.4
cc_592 ( N_noxref_2_c_465_p N_noxref_7_c_2532_n ) capacitor c=0.00370784f \
 //x=14.06 //y=4.7 //x2=12.95 //y2=7.4
cc_593 ( N_noxref_2_c_467_p N_noxref_7_c_2532_n ) capacitor c=0.00590568f \
 //x=14.335 //y=4.79 //x2=12.95 //y2=7.4
cc_594 ( N_noxref_2_c_437_n N_noxref_7_M28_noxref_s ) capacitor c=0.0611368f \
 //x=10.85 //y=5.38 //x2=10.275 //y2=5.02
cc_595 ( N_noxref_2_c_472_p N_noxref_7_M28_noxref_s ) capacitor c=6.52457e-19 \
 //x=11.73 //y=5.2 //x2=10.275 //y2=5.02
cc_596 ( N_noxref_2_c_448_n N_noxref_7_M28_noxref_s ) capacitor c=0.0887533f \
 //x=10.85 //y=5.38 //x2=10.275 //y2=5.02
cc_597 ( N_noxref_2_c_430_n N_noxref_7_M29_noxref_d ) capacitor c=0.00734028f \
 //x=11.615 //y=5.2 //x2=11.145 //y2=5.02
cc_598 ( N_noxref_2_c_437_n N_noxref_7_M29_noxref_d ) capacitor c=0.0043528f \
 //x=10.85 //y=5.38 //x2=11.145 //y2=5.02
cc_599 ( N_noxref_2_c_594_p N_noxref_7_M29_noxref_d ) capacitor c=0.0043528f \
 //x=11.73 //y=5.38 //x2=11.145 //y2=5.02
cc_600 ( N_noxref_2_c_448_n N_noxref_7_M29_noxref_d ) capacitor c=0.065554f \
 //x=10.85 //y=5.38 //x2=11.145 //y2=5.02
cc_601 ( N_noxref_2_c_558_p N_noxref_7_M29_noxref_d ) capacitor c=0.065554f \
 //x=11.73 //y=5.38 //x2=11.145 //y2=5.02
cc_602 ( N_noxref_2_c_559_p N_noxref_7_M31_noxref_d ) capacitor c=0.00933287f \
 //x=12.125 //y=5.2 //x2=12.025 //y2=5.02
cc_603 ( N_noxref_2_c_594_p N_noxref_7_M31_noxref_d ) capacitor c=0.00955781f \
 //x=11.73 //y=5.38 //x2=12.025 //y2=5.02
cc_604 ( N_noxref_2_c_446_n N_noxref_7_M31_noxref_d ) capacitor c=9.65858e-19 \
 //x=12.21 //y=3.33 //x2=12.025 //y2=5.02
cc_605 ( N_noxref_2_c_558_p N_noxref_7_M31_noxref_d ) capacitor c=0.065554f \
 //x=11.73 //y=5.38 //x2=12.025 //y2=5.02
cc_606 ( N_noxref_2_c_559_p N_noxref_7_M32_noxref_s ) capacitor c=0.00220019f \
 //x=12.125 //y=5.2 //x2=13.905 //y2=5.02
cc_607 ( N_noxref_2_c_459_p N_noxref_7_M32_noxref_s ) capacitor c=6.02115e-19 \
 //x=14.06 //y=3.495 //x2=13.905 //y2=5.02
cc_608 ( N_noxref_2_c_460_p N_noxref_7_M32_noxref_s ) capacitor c=0.0217983f \
 //x=14.06 //y=4.575 //x2=13.905 //y2=5.02
cc_609 ( N_noxref_2_c_472_p N_noxref_7_M32_noxref_s ) capacitor c=0.00371125f \
 //x=11.73 //y=5.2 //x2=13.905 //y2=5.02
cc_610 ( N_noxref_2_c_594_p N_noxref_7_M32_noxref_s ) capacitor c=9.52042e-19 \
 //x=11.73 //y=5.38 //x2=13.905 //y2=5.02
cc_611 ( N_noxref_2_c_465_p N_noxref_7_M32_noxref_s ) capacitor c=0.00983827f \
 //x=14.06 //y=4.7 //x2=13.905 //y2=5.02
cc_612 ( N_noxref_2_M32_noxref_g N_noxref_7_M32_noxref_s ) capacitor \
 c=0.053419f //x=14.26 //y=6.02 //x2=13.905 //y2=5.02
cc_613 ( N_noxref_2_c_467_p N_noxref_7_M32_noxref_s ) capacitor c=0.00606232f \
 //x=14.335 //y=4.79 //x2=13.905 //y2=5.02
cc_614 ( N_noxref_2_M33_noxref_g N_noxref_7_M33_noxref_d ) capacitor \
 c=0.015318f //x=14.7 //y=6.02 //x2=14.775 //y2=5.02
cc_615 ( N_noxref_2_c_445_n N_noxref_11_M9_noxref_d ) capacitor c=3.39394e-19 \
 //x=11.77 //y=1 //x2=14.81 //y2=0.91
cc_616 ( N_noxref_2_c_537_p N_noxref_16_c_3600_n ) capacitor c=0.00607337f \
 //x=12.125 //y=1.655 //x2=13.94 //y2=0
cc_617 ( N_noxref_2_c_499_p N_noxref_16_c_3600_n ) capacitor c=2.71737e-19 \
 //x=12.21 //y=3.495 //x2=13.94 //y2=0
cc_618 ( N_noxref_2_c_445_n N_noxref_16_c_3600_n ) capacitor c=0.00927204f \
 //x=11.77 //y=1 //x2=13.94 //y2=0
cc_619 ( N_noxref_2_M7_noxref_d N_noxref_16_c_3600_n ) capacitor c=3.01654e-19 \
 //x=11.58 //y=0.905 //x2=13.94 //y2=0
cc_620 ( N_noxref_2_c_484_p N_noxref_16_c_3604_n ) capacitor c=3.92414e-19 \
 //x=13.76 //y=0.875 //x2=14.025 //y2=0.835
cc_621 ( N_noxref_2_c_644_p N_noxref_16_c_3604_n ) capacitor c=0.00850983f \
 //x=14.135 //y=0.72 //x2=14.025 //y2=0.835
cc_622 ( N_noxref_2_c_486_p N_noxref_16_c_3604_n ) capacitor c=4.45447e-19 \
 //x=14.29 //y=0.875 //x2=14.025 //y2=0.835
cc_623 ( N_noxref_2_c_437_n N_noxref_16_c_3565_n ) capacitor c=6.80717e-19 \
 //x=10.85 //y=5.38 //x2=10.8 //y2=0.955
cc_624 ( N_noxref_2_c_445_n N_noxref_16_c_3565_n ) capacitor c=0.0140211f \
 //x=11.77 //y=1 //x2=10.8 //y2=0.955
cc_625 ( N_noxref_2_M7_noxref_d N_noxref_16_c_3565_n ) capacitor c=2.93544e-19 \
 //x=11.58 //y=0.905 //x2=10.8 //y2=0.955
cc_626 ( N_noxref_2_c_453_p N_noxref_16_c_3610_n ) capacitor c=0.00772254f \
 //x=14.06 //y=2.195 //x2=14.025 //y2=0.965
cc_627 ( N_noxref_2_c_459_p N_noxref_16_c_3610_n ) capacitor c=7.58935e-19 \
 //x=14.06 //y=3.495 //x2=14.025 //y2=0.965
cc_628 ( N_noxref_2_c_445_n N_noxref_16_c_3610_n ) capacitor c=0.00606355f \
 //x=11.77 //y=1 //x2=14.025 //y2=0.965
cc_629 ( N_noxref_2_c_454_p N_noxref_16_c_3610_n ) capacitor c=2.22861e-19 \
 //x=14.06 //y=2.08 //x2=14.025 //y2=0.965
cc_630 ( N_noxref_2_c_484_p N_noxref_16_c_3610_n ) capacitor c=0.0015128f \
 //x=13.76 //y=0.875 //x2=14.025 //y2=0.965
cc_631 ( N_noxref_2_c_485_p N_noxref_16_c_3610_n ) capacitor c=0.00350108f \
 //x=13.76 //y=1.22 //x2=14.025 //y2=0.965
cc_632 ( N_noxref_2_c_487_p N_noxref_16_c_3610_n ) capacitor c=4.28277e-19 \
 //x=13.76 //y=1.53 //x2=14.025 //y2=0.965
cc_633 ( N_noxref_2_c_644_p N_noxref_16_c_3610_n ) capacitor c=9.36995e-19 \
 //x=14.135 //y=0.72 //x2=14.025 //y2=0.965
cc_634 ( N_noxref_2_c_657_p N_noxref_16_c_3610_n ) capacitor c=5.79535e-19 \
 //x=14.135 //y=1.375 //x2=14.025 //y2=0.965
cc_635 ( N_noxref_2_c_486_p N_noxref_16_c_3610_n ) capacitor c=0.0017438f \
 //x=14.29 //y=0.875 //x2=14.025 //y2=0.965
cc_636 ( N_noxref_2_c_488_p N_noxref_16_c_3610_n ) capacitor c=0.00276804f \
 //x=14.29 //y=1.22 //x2=14.025 //y2=0.965
cc_637 ( N_noxref_2_c_537_p N_noxref_16_c_3581_n ) capacitor c=7.76556e-19 \
 //x=12.125 //y=1.655 //x2=12.78 //y2=0
cc_638 ( N_noxref_2_c_499_p N_noxref_16_c_3581_n ) capacitor c=3.21403e-19 \
 //x=12.21 //y=3.495 //x2=12.78 //y2=0
cc_639 ( N_noxref_2_c_484_p N_noxref_16_c_3623_n ) capacitor c=0.00675103f \
 //x=13.76 //y=0.875 //x2=17.59 //y2=0
cc_640 ( N_noxref_2_c_433_n N_noxref_16_c_3585_n ) capacitor c=9.32616e-19 \
 //x=12.21 //y=3.175 //x2=9.62 //y2=0
cc_641 ( N_noxref_2_c_431_n N_noxref_16_c_3625_n ) capacitor c=0.00460657f \
 //x=11.77 //y=1.57 //x2=12.95 //y2=0
cc_642 ( N_noxref_2_c_537_p N_noxref_16_c_3625_n ) capacitor c=0.0300371f \
 //x=12.125 //y=1.655 //x2=12.95 //y2=0
cc_643 ( N_noxref_2_c_453_p N_noxref_16_c_3625_n ) capacitor c=0.00343139f \
 //x=14.06 //y=2.195 //x2=12.95 //y2=0
cc_644 ( N_noxref_2_c_458_p N_noxref_16_c_3625_n ) capacitor c=0.0109665f \
 //x=14.06 //y=3.175 //x2=12.95 //y2=0
cc_645 ( N_noxref_2_c_504_p N_noxref_16_c_3625_n ) capacitor c=0.00391506f \
 //x=13.905 //y=3.335 //x2=12.95 //y2=0
cc_646 ( N_noxref_2_c_454_p N_noxref_16_c_3625_n ) capacitor c=0.00379568f \
 //x=14.06 //y=2.08 //x2=12.95 //y2=0
cc_647 ( N_noxref_2_c_487_p N_noxref_16_c_3625_n ) capacitor c=0.00170145f \
 //x=13.76 //y=1.53 //x2=12.95 //y2=0
cc_648 ( N_noxref_2_c_455_p N_noxref_16_c_3625_n ) capacitor c=0.0102191f \
 //x=13.76 //y=1.915 //x2=12.95 //y2=0
cc_649 ( N_noxref_2_c_445_n N_noxref_16_M6_noxref_d ) capacitor c=2.82748e-19 \
 //x=11.77 //y=1 //x2=10.61 //y2=0.865
cc_650 ( N_noxref_2_c_453_p N_noxref_16_M8_noxref_d ) capacitor c=4.4417e-19 \
 //x=14.06 //y=2.195 //x2=13.835 //y2=0.875
cc_651 ( N_noxref_2_c_484_p N_noxref_16_M8_noxref_d ) capacitor c=0.00184354f \
 //x=13.76 //y=0.875 //x2=13.835 //y2=0.875
cc_652 ( N_noxref_2_c_485_p N_noxref_16_M8_noxref_d ) capacitor c=0.00210798f \
 //x=13.76 //y=1.22 //x2=13.835 //y2=0.875
cc_653 ( N_noxref_2_c_644_p N_noxref_16_M8_noxref_d ) capacitor c=0.00474029f \
 //x=14.135 //y=0.72 //x2=13.835 //y2=0.875
cc_654 ( N_noxref_2_c_657_p N_noxref_16_M8_noxref_d ) capacitor c=0.00166857f \
 //x=14.135 //y=1.375 //x2=13.835 //y2=0.875
cc_655 ( N_noxref_2_c_486_p N_noxref_16_M8_noxref_d ) capacitor c=0.00230174f \
 //x=14.29 //y=0.875 //x2=13.835 //y2=0.875
cc_656 ( N_noxref_2_c_488_p N_noxref_16_M8_noxref_d ) capacitor c=0.00210798f \
 //x=14.29 //y=1.22 //x2=13.835 //y2=0.875
cc_657 ( N_noxref_2_c_432_n N_noxref_20_c_4246_n ) capacitor c=0.00911405f \
 //x=11.855 //y=1.655 //x2=11.285 //y2=1.495
cc_658 ( N_noxref_2_c_537_p N_noxref_20_c_4251_n ) capacitor c=0.00399245f \
 //x=12.125 //y=1.655 //x2=12.17 //y2=0.53
cc_659 ( N_noxref_2_c_445_n N_noxref_20_c_4251_n ) capacitor c=0.003751f \
 //x=11.77 //y=1 //x2=12.17 //y2=0.53
cc_660 ( N_noxref_2_M7_noxref_d N_noxref_20_c_4251_n ) capacitor c=0.00910163f \
 //x=11.58 //y=0.905 //x2=12.17 //y2=0.53
cc_661 ( N_noxref_2_c_431_n N_noxref_20_M6_noxref_s ) capacitor c=0.0175063f \
 //x=11.77 //y=1.57 //x2=10.18 //y2=0.365
cc_662 ( N_noxref_2_c_537_p N_noxref_20_M6_noxref_s ) capacitor c=0.00640979f \
 //x=12.125 //y=1.655 //x2=10.18 //y2=0.365
cc_663 ( N_noxref_2_c_499_p N_noxref_20_M6_noxref_s ) capacitor c=4.15501e-19 \
 //x=12.21 //y=3.495 //x2=10.18 //y2=0.365
cc_664 ( N_noxref_2_c_445_n N_noxref_20_M6_noxref_s ) capacitor c=0.0089443f \
 //x=11.77 //y=1 //x2=10.18 //y2=0.365
cc_665 ( N_noxref_2_c_446_n N_noxref_20_M6_noxref_s ) capacitor c=0.0010514f \
 //x=12.21 //y=3.33 //x2=10.18 //y2=0.365
cc_666 ( N_noxref_2_M7_noxref_d N_noxref_20_M6_noxref_s ) capacitor \
 c=0.0275552f //x=11.58 //y=0.905 //x2=10.18 //y2=0.365
cc_667 ( N_noxref_2_c_455_p N_noxref_21_c_4306_n ) capacitor c=0.00262672f \
 //x=13.76 //y=1.915 //x2=13.54 //y2=1.505
cc_668 ( N_noxref_2_c_453_p N_noxref_21_c_4307_n ) capacitor c=0.00428451f \
 //x=14.06 //y=2.195 //x2=14.425 //y2=1.59
cc_669 ( N_noxref_2_c_459_p N_noxref_21_c_4307_n ) capacitor c=0.00270049f \
 //x=14.06 //y=3.495 //x2=14.425 //y2=1.59
cc_670 ( N_noxref_2_c_454_p N_noxref_21_c_4307_n ) capacitor c=0.0104666f \
 //x=14.06 //y=2.08 //x2=14.425 //y2=1.59
cc_671 ( N_noxref_2_c_487_p N_noxref_21_c_4307_n ) capacitor c=0.00705077f \
 //x=13.76 //y=1.53 //x2=14.425 //y2=1.59
cc_672 ( N_noxref_2_c_455_p N_noxref_21_c_4307_n ) capacitor c=0.020708f \
 //x=13.76 //y=1.915 //x2=14.425 //y2=1.59
cc_673 ( N_noxref_2_c_657_p N_noxref_21_c_4307_n ) capacitor c=0.00588627f \
 //x=14.135 //y=1.375 //x2=14.425 //y2=1.59
cc_674 ( N_noxref_2_c_488_p N_noxref_21_c_4307_n ) capacitor c=0.00698822f \
 //x=14.29 //y=1.22 //x2=14.425 //y2=1.59
cc_675 ( N_noxref_2_c_484_p N_noxref_21_M8_noxref_s ) capacitor c=0.0295256f \
 //x=13.76 //y=0.875 //x2=13.405 //y2=0.375
cc_676 ( N_noxref_2_c_487_p N_noxref_21_M8_noxref_s ) capacitor c=7.99997e-19 \
 //x=13.76 //y=1.53 //x2=13.405 //y2=0.375
cc_677 ( N_noxref_2_c_455_p N_noxref_21_M8_noxref_s ) capacitor c=0.00122123f \
 //x=13.76 //y=1.915 //x2=13.405 //y2=0.375
cc_678 ( N_noxref_2_c_486_p N_noxref_21_M8_noxref_s ) capacitor c=0.0125924f \
 //x=14.29 //y=0.875 //x2=13.405 //y2=0.375
cc_679 ( N_noxref_3_c_711_n N_noxref_4_c_1097_n ) capacitor c=0.0234972f \
 //x=2.215 //y=4.655 //x2=2.29 //y2=5.155
cc_680 ( N_noxref_3_c_722_n N_noxref_4_c_1097_n ) capacitor c=0.00243571f \
 //x=2.215 //y=4.44 //x2=2.29 //y2=5.155
cc_681 ( N_noxref_3_c_727_n N_noxref_4_c_1097_n ) capacitor c=0.00492634f \
 //x=2.22 //y=4.7 //x2=2.29 //y2=5.155
cc_682 ( N_noxref_3_M18_noxref_g N_noxref_4_c_1097_n ) capacitor c=0.00858222f \
 //x=2.19 //y=6.02 //x2=2.29 //y2=5.155
cc_683 ( N_noxref_3_c_741_n N_noxref_4_c_1097_n ) capacitor c=3.54644e-19 \
 //x=2.22 //y=4.7 //x2=2.29 //y2=5.155
cc_684 ( N_noxref_3_M19_noxref_g N_noxref_4_c_996_n ) capacitor c=0.00955829f \
 //x=2.63 //y=6.02 //x2=3.175 //y2=5.155
cc_685 ( N_noxref_3_c_714_n N_noxref_4_c_1001_n ) capacitor c=0.0206181f \
 //x=11.09 //y=4.44 //x2=3.985 //y2=5.155
cc_686 ( N_noxref_3_c_705_n N_noxref_4_c_1024_n ) capacitor c=0.00286279f \
 //x=2.22 //y=4.495 //x2=4.07 //y2=3.545
cc_687 ( N_noxref_3_c_705_n N_noxref_4_c_1036_n ) capacitor c=9.29639e-19 \
 //x=2.22 //y=4.495 //x2=4.07 //y2=5.07
cc_688 ( N_noxref_3_c_714_n N_noxref_4_c_1036_n ) capacitor c=0.0298618f \
 //x=11.09 //y=4.44 //x2=4.07 //y2=5.07
cc_689 ( N_noxref_3_c_714_n N_noxref_4_c_1045_n ) capacitor c=0.0317543f \
 //x=11.09 //y=4.44 //x2=5.92 //y2=4.575
cc_690 ( N_noxref_3_c_711_n N_noxref_4_c_1108_n ) capacitor c=0.00512107f \
 //x=2.215 //y=4.655 //x2=2.41 //y2=5.155
cc_691 ( N_noxref_3_c_714_n N_noxref_4_c_1108_n ) capacitor c=0.0383042f \
 //x=11.09 //y=4.44 //x2=2.41 //y2=5.155
cc_692 ( N_noxref_3_c_722_n N_noxref_4_c_1108_n ) capacitor c=0.00207204f \
 //x=2.215 //y=4.44 //x2=2.41 //y2=5.155
cc_693 ( N_noxref_3_c_727_n N_noxref_4_c_1108_n ) capacitor c=0.00132214f \
 //x=2.22 //y=4.7 //x2=2.41 //y2=5.155
cc_694 ( N_noxref_3_M18_noxref_g N_noxref_4_c_1108_n ) capacitor c=0.00229818f \
 //x=2.19 //y=6.02 //x2=2.41 //y2=5.155
cc_695 ( N_noxref_3_M19_noxref_g N_noxref_4_c_1108_n ) capacitor c=0.00230699f \
 //x=2.63 //y=6.02 //x2=2.41 //y2=5.155
cc_696 ( N_noxref_3_c_740_n N_noxref_4_c_1108_n ) capacitor c=0.00170733f \
 //x=2.555 //y=4.79 //x2=2.41 //y2=5.155
cc_697 ( N_noxref_3_c_714_n N_noxref_4_c_1050_n ) capacitor c=0.00755818f \
 //x=11.09 //y=4.44 //x2=5.765 //y2=3.7
cc_698 ( N_noxref_3_c_714_n N_noxref_4_c_1052_n ) capacitor c=0.0064996f \
 //x=11.09 //y=4.44 //x2=9.1 //y2=3.715
cc_699 ( N_noxref_3_c_714_n N_noxref_4_c_1055_n ) capacitor c=0.0192463f \
 //x=11.09 //y=4.44 //x2=8.755 //y2=3.715
cc_700 ( N_noxref_3_c_714_n N_noxref_4_c_1059_n ) capacitor c=0.0036897f \
 //x=11.09 //y=4.44 //x2=10.345 //y2=3.7
cc_701 ( N_noxref_3_c_714_n N_noxref_4_c_1063_n ) capacitor c=0.00294091f \
 //x=11.09 //y=4.44 //x2=10.945 //y2=3.715
cc_702 ( N_noxref_3_c_760_n N_noxref_4_c_1085_n ) capacitor c=0.00625686f \
 //x=11.69 //y=4.455 //x2=11.69 //y2=3.685
cc_703 ( N_noxref_3_c_760_n N_noxref_4_c_1088_n ) capacitor c=0.00619486f \
 //x=11.69 //y=4.455 //x2=12.425 //y2=3.72
cc_704 ( N_noxref_3_c_760_n N_noxref_4_c_1091_n ) capacitor c=0.003069f \
 //x=11.69 //y=4.455 //x2=13.68 //y2=3.7
cc_705 ( N_noxref_3_c_746_n N_noxref_4_c_1095_n ) capacitor c=6.63302e-19 \
 //x=15.17 //y=4.355 //x2=14.28 //y2=3.72
cc_706 ( N_noxref_3_c_760_n N_noxref_4_c_1095_n ) capacitor c=0.00554145f \
 //x=11.69 //y=4.455 //x2=14.28 //y2=3.72
cc_707 ( N_noxref_3_c_746_n N_noxref_4_c_1125_n ) capacitor c=0.0287878f \
 //x=15.17 //y=4.355 //x2=16.64 //y2=3.7
cc_708 ( N_noxref_3_c_711_n N_noxref_4_c_1126_n ) capacitor c=0.00134045f \
 //x=2.215 //y=4.655 //x2=2.41 //y2=5.38
cc_709 ( N_noxref_3_M18_noxref_g N_noxref_4_c_1126_n ) capacitor c=0.0179041f \
 //x=2.19 //y=6.02 //x2=2.41 //y2=5.38
cc_710 ( N_noxref_3_M19_noxref_g N_noxref_4_c_1126_n ) capacitor c=0.0179041f \
 //x=2.63 //y=6.02 //x2=2.41 //y2=5.38
cc_711 ( N_noxref_3_c_740_n N_noxref_4_c_1126_n ) capacitor c=0.00293647f \
 //x=2.555 //y=4.79 //x2=2.41 //y2=5.38
cc_712 ( N_noxref_3_c_714_n N_noxref_5_c_1457_n ) capacitor c=0.0287688f \
 //x=11.09 //y=4.44 //x2=8.14 //y2=4.57
cc_713 ( N_noxref_3_c_743_n N_noxref_5_c_1529_n ) capacitor c=0.00675925f \
 //x=15.17 //y=2.195 //x2=16.28 //y2=2.285
cc_714 ( N_noxref_3_c_746_n N_noxref_5_c_1529_n ) capacitor c=0.00158143f \
 //x=15.17 //y=4.355 //x2=16.28 //y2=2.285
cc_715 ( N_noxref_3_c_763_n N_noxref_5_c_1529_n ) capacitor c=9.53526e-19 \
 //x=15.17 //y=2.08 //x2=16.28 //y2=2.285
cc_716 ( N_noxref_3_c_782_n N_noxref_5_c_1529_n ) capacitor c=0.00135583f \
 //x=15.26 //y=1.915 //x2=16.28 //y2=2.285
cc_717 ( N_noxref_3_c_746_n N_noxref_5_c_1515_n ) capacitor c=0.0566825f \
 //x=15.17 //y=4.355 //x2=16.28 //y2=4.57
cc_718 ( N_noxref_3_c_754_n N_noxref_5_c_1515_n ) capacitor c=0.0137107f \
 //x=15.165 //y=4.515 //x2=16.28 //y2=4.57
cc_719 ( N_noxref_3_c_760_n N_noxref_5_c_1515_n ) capacitor c=0.00601472f \
 //x=11.69 //y=4.455 //x2=16.28 //y2=4.57
cc_720 ( N_noxref_3_c_767_n N_noxref_5_c_1515_n ) capacitor c=4.56604e-19 \
 //x=15.17 //y=4.7 //x2=16.28 //y2=4.57
cc_721 ( N_noxref_3_c_785_n N_noxref_5_c_1515_n ) capacitor c=2.32327e-19 \
 //x=15.17 //y=4.7 //x2=16.28 //y2=4.57
cc_722 ( N_noxref_3_c_743_n N_noxref_5_c_1470_n ) capacitor c=0.0167682f \
 //x=15.17 //y=2.195 //x2=16.125 //y2=2.135
cc_723 ( N_noxref_3_c_746_n N_noxref_5_c_1470_n ) capacitor c=0.0189298f \
 //x=15.17 //y=4.355 //x2=16.125 //y2=2.135
cc_724 ( N_noxref_3_c_763_n N_noxref_5_c_1470_n ) capacitor c=2.63835e-19 \
 //x=15.17 //y=2.08 //x2=16.125 //y2=2.135
cc_725 ( N_noxref_3_c_743_n N_noxref_5_c_1541_n ) capacitor c=0.00390832f \
 //x=15.17 //y=2.195 //x2=16.445 //y2=2.135
cc_726 ( N_noxref_3_c_743_n N_noxref_5_c_1542_n ) capacitor c=6.92676e-19 \
 //x=15.17 //y=2.195 //x2=16.28 //y2=2.08
cc_727 ( N_noxref_3_c_763_n N_noxref_5_c_1542_n ) capacitor c=0.00129119f \
 //x=15.17 //y=2.08 //x2=16.28 //y2=2.08
cc_728 ( N_noxref_3_c_782_n N_noxref_5_c_1542_n ) capacitor c=0.00210314f \
 //x=15.26 //y=1.915 //x2=16.28 //y2=2.08
cc_729 ( N_noxref_3_c_754_n N_noxref_5_c_1545_n ) capacitor c=9.59226e-19 \
 //x=15.165 //y=4.515 //x2=16.28 //y2=4.7
cc_730 ( N_noxref_3_c_767_n N_noxref_5_c_1545_n ) capacitor c=0.00113671f \
 //x=15.17 //y=4.7 //x2=16.28 //y2=4.7
cc_731 ( N_noxref_3_c_785_n N_noxref_5_c_1545_n ) capacitor c=0.00104879f \
 //x=15.17 //y=4.7 //x2=16.28 //y2=4.7
cc_732 ( N_noxref_3_M34_noxref_g N_noxref_5_M36_noxref_g ) capacitor \
 c=0.0101598f //x=15.14 //y=6.02 //x2=16.02 //y2=6.02
cc_733 ( N_noxref_3_M35_noxref_g N_noxref_5_M36_noxref_g ) capacitor \
 c=0.0607518f //x=15.58 //y=6.02 //x2=16.02 //y2=6.02
cc_734 ( N_noxref_3_M35_noxref_g N_noxref_5_M37_noxref_g ) capacitor \
 c=0.0101598f //x=15.58 //y=6.02 //x2=16.46 //y2=6.02
cc_735 ( N_noxref_3_c_779_n N_noxref_5_c_1551_n ) capacitor c=0.00456962f \
 //x=15.26 //y=0.91 //x2=16.27 //y2=0.915
cc_736 ( N_noxref_3_c_780_n N_noxref_5_c_1552_n ) capacitor c=0.00438372f \
 //x=15.26 //y=1.22 //x2=16.27 //y2=1.26
cc_737 ( N_noxref_3_c_781_n N_noxref_5_c_1553_n ) capacitor c=0.00438372f \
 //x=15.26 //y=1.45 //x2=16.27 //y2=1.57
cc_738 ( N_noxref_3_c_763_n N_noxref_5_c_1554_n ) capacitor c=0.00155537f \
 //x=15.17 //y=2.08 //x2=16.28 //y2=2.08
cc_739 ( N_noxref_3_c_782_n N_noxref_5_c_1554_n ) capacitor c=0.00831559f \
 //x=15.26 //y=1.915 //x2=16.28 //y2=2.08
cc_740 ( N_noxref_3_c_782_n N_noxref_5_c_1556_n ) capacitor c=0.00438372f \
 //x=15.26 //y=1.915 //x2=16.28 //y2=1.915
cc_741 ( N_noxref_3_c_754_n N_noxref_5_c_1557_n ) capacitor c=0.00139285f \
 //x=15.165 //y=4.515 //x2=16.28 //y2=4.7
cc_742 ( N_noxref_3_c_767_n N_noxref_5_c_1557_n ) capacitor c=0.00186974f \
 //x=15.17 //y=4.7 //x2=16.28 //y2=4.7
cc_743 ( N_noxref_3_c_853_p N_noxref_5_c_1557_n ) capacitor c=0.0616777f \
 //x=15.505 //y=4.79 //x2=16.28 //y2=4.7
cc_744 ( N_noxref_3_c_785_n N_noxref_5_c_1557_n ) capacitor c=0.00440391f \
 //x=15.17 //y=4.7 //x2=16.28 //y2=4.7
cc_745 ( N_noxref_3_c_702_n N_noxref_6_c_1984_n ) capacitor c=0.0115546f \
 //x=2.22 //y=2.195 //x2=1.11 //y2=2.195
cc_746 ( N_noxref_3_c_723_n N_noxref_6_c_1984_n ) capacitor c=0.00375644f \
 //x=2.22 //y=2.08 //x2=1.11 //y2=2.195
cc_747 ( N_noxref_3_c_736_n N_noxref_6_c_1984_n ) capacitor c=0.00140534f \
 //x=2.31 //y=1.915 //x2=1.11 //y2=2.195
cc_748 ( N_noxref_3_c_705_n N_noxref_6_c_1862_n ) capacitor c=0.0544022f \
 //x=2.22 //y=4.495 //x2=1.11 //y2=3.92
cc_749 ( N_noxref_3_c_723_n N_noxref_6_c_1862_n ) capacitor c=4.16726e-19 \
 //x=2.22 //y=2.08 //x2=1.11 //y2=3.92
cc_750 ( N_noxref_3_c_705_n N_noxref_6_c_1989_n ) capacitor c=0.00795617f \
 //x=2.22 //y=4.495 //x2=1.11 //y2=4.24
cc_751 ( N_noxref_3_c_705_n N_noxref_6_c_1864_n ) capacitor c=0.00593778f \
 //x=2.22 //y=4.495 //x2=1.11 //y2=4.575
cc_752 ( N_noxref_3_c_711_n N_noxref_6_c_1864_n ) capacitor c=0.00911997f \
 //x=2.215 //y=4.655 //x2=1.11 //y2=4.575
cc_753 ( N_noxref_3_c_722_n N_noxref_6_c_1864_n ) capacitor c=0.00912377f \
 //x=2.215 //y=4.44 //x2=1.11 //y2=4.575
cc_754 ( N_noxref_3_c_727_n N_noxref_6_c_1864_n ) capacitor c=0.00402042f \
 //x=2.22 //y=4.7 //x2=1.11 //y2=4.575
cc_755 ( N_noxref_3_c_741_n N_noxref_6_c_1864_n ) capacitor c=0.00107711f \
 //x=2.22 //y=4.7 //x2=1.11 //y2=4.575
cc_756 ( N_noxref_3_c_714_n N_noxref_6_c_1873_n ) capacitor c=0.00261296f \
 //x=11.09 //y=4.44 //x2=11.47 //y2=4.23
cc_757 ( N_noxref_3_c_760_n N_noxref_6_c_1873_n ) capacitor c=0.00232919f \
 //x=11.69 //y=4.455 //x2=11.47 //y2=4.23
cc_758 ( N_noxref_3_c_714_n N_noxref_6_c_1874_n ) capacitor c=3.14882e-19 \
 //x=11.09 //y=4.44 //x2=11.47 //y2=4.555
cc_759 ( N_noxref_3_c_760_n N_noxref_6_c_1874_n ) capacitor c=0.0260542f \
 //x=11.69 //y=4.455 //x2=11.47 //y2=4.555
cc_760 ( N_noxref_3_c_754_n N_noxref_6_c_1932_n ) capacitor c=0.0234494f \
 //x=15.165 //y=4.515 //x2=15.24 //y2=5.155
cc_761 ( N_noxref_3_c_760_n N_noxref_6_c_1932_n ) capacitor c=0.00121614f \
 //x=11.69 //y=4.455 //x2=15.24 //y2=5.155
cc_762 ( N_noxref_3_c_767_n N_noxref_6_c_1932_n ) capacitor c=0.00492634f \
 //x=15.17 //y=4.7 //x2=15.24 //y2=5.155
cc_763 ( N_noxref_3_M34_noxref_g N_noxref_6_c_1932_n ) capacitor c=0.00858239f \
 //x=15.14 //y=6.02 //x2=15.24 //y2=5.155
cc_764 ( N_noxref_3_c_785_n N_noxref_6_c_1932_n ) capacitor c=3.77911e-19 \
 //x=15.17 //y=4.7 //x2=15.24 //y2=5.155
cc_765 ( N_noxref_3_M35_noxref_g N_noxref_6_c_2004_n ) capacitor c=0.0103546f \
 //x=15.58 //y=6.02 //x2=16.125 //y2=5.155
cc_766 ( N_noxref_3_c_746_n N_noxref_6_c_2005_n ) capacitor c=0.00296423f \
 //x=15.17 //y=4.355 //x2=17.02 //y2=3.915
cc_767 ( N_noxref_3_c_746_n N_noxref_6_c_2006_n ) capacitor c=2.99109e-19 \
 //x=15.17 //y=4.355 //x2=17.02 //y2=5.07
cc_768 ( N_noxref_3_c_705_n N_noxref_6_c_2007_n ) capacitor c=4.22577e-19 \
 //x=2.22 //y=4.495 //x2=1.11 //y2=4.07
cc_769 ( N_noxref_3_c_760_n N_noxref_6_c_1937_n ) capacitor c=0.0278748f \
 //x=11.69 //y=4.455 //x2=14.482 //y2=5.155
cc_770 ( N_noxref_3_c_754_n N_noxref_6_c_2009_n ) capacitor c=0.00463905f \
 //x=15.165 //y=4.515 //x2=15.36 //y2=5.155
cc_771 ( N_noxref_3_c_760_n N_noxref_6_c_2009_n ) capacitor c=9.74982e-19 \
 //x=11.69 //y=4.455 //x2=15.36 //y2=5.155
cc_772 ( N_noxref_3_c_767_n N_noxref_6_c_2009_n ) capacitor c=0.00132214f \
 //x=15.17 //y=4.7 //x2=15.36 //y2=5.155
cc_773 ( N_noxref_3_M34_noxref_g N_noxref_6_c_2009_n ) capacitor c=0.00229818f \
 //x=15.14 //y=6.02 //x2=15.36 //y2=5.155
cc_774 ( N_noxref_3_M35_noxref_g N_noxref_6_c_2009_n ) capacitor c=0.00230699f \
 //x=15.58 //y=6.02 //x2=15.36 //y2=5.155
cc_775 ( N_noxref_3_c_853_p N_noxref_6_c_2009_n ) capacitor c=0.0017286f \
 //x=15.505 //y=4.79 //x2=15.36 //y2=5.155
cc_776 ( N_noxref_3_c_702_n N_noxref_6_c_1883_n ) capacitor c=0.00154241f \
 //x=2.22 //y=2.195 //x2=3.685 //y2=4.07
cc_777 ( N_noxref_3_c_705_n N_noxref_6_c_1883_n ) capacitor c=0.028849f \
 //x=2.22 //y=4.495 //x2=3.685 //y2=4.07
cc_778 ( N_noxref_3_c_711_n N_noxref_6_c_1883_n ) capacitor c=0.00269476f \
 //x=2.215 //y=4.655 //x2=3.685 //y2=4.07
cc_779 ( N_noxref_3_c_714_n N_noxref_6_c_1883_n ) capacitor c=0.064437f \
 //x=11.09 //y=4.44 //x2=3.685 //y2=4.07
cc_780 ( N_noxref_3_c_722_n N_noxref_6_c_1883_n ) capacitor c=0.155631f \
 //x=2.215 //y=4.44 //x2=3.685 //y2=4.07
cc_781 ( N_noxref_3_c_714_n N_noxref_6_c_1887_n ) capacitor c=0.113902f \
 //x=11.09 //y=4.44 //x2=4.325 //y2=4.09
cc_782 ( N_noxref_3_c_714_n N_noxref_6_c_1888_n ) capacitor c=0.0602971f \
 //x=11.09 //y=4.44 //x2=5.54 //y2=4.07
cc_783 ( N_noxref_3_c_746_n N_noxref_6_c_1942_n ) capacitor c=0.023508f \
 //x=15.17 //y=4.355 //x2=16.865 //y2=4.07
cc_784 ( N_noxref_3_c_754_n N_noxref_6_c_1942_n ) capacitor c=0.00375947f \
 //x=15.165 //y=4.515 //x2=16.865 //y2=4.07
cc_785 ( N_noxref_3_c_760_n N_noxref_6_c_1942_n ) capacitor c=0.33879f \
 //x=11.69 //y=4.455 //x2=16.865 //y2=4.07
cc_786 ( N_noxref_3_c_714_n N_noxref_6_c_1890_n ) capacitor c=0.497523f \
 //x=11.09 //y=4.44 //x2=11.635 //y2=4.07
cc_787 ( N_noxref_3_c_705_n N_noxref_6_c_2026_n ) capacitor c=0.00242466f \
 //x=2.22 //y=4.495 //x2=1.27 //y2=4.08
cc_788 ( N_noxref_3_c_702_n N_noxref_6_c_2027_n ) capacitor c=5.40058e-19 \
 //x=2.22 //y=2.195 //x2=1.11 //y2=2.08
cc_789 ( N_noxref_3_c_705_n N_noxref_6_c_2027_n ) capacitor c=4.16726e-19 \
 //x=2.22 //y=4.495 //x2=1.11 //y2=2.08
cc_790 ( N_noxref_3_c_723_n N_noxref_6_c_2027_n ) capacitor c=0.00125213f \
 //x=2.22 //y=2.08 //x2=1.11 //y2=2.08
cc_791 ( N_noxref_3_c_736_n N_noxref_6_c_2027_n ) capacitor c=0.0020754f \
 //x=2.31 //y=1.915 //x2=1.11 //y2=2.08
cc_792 ( N_noxref_3_c_711_n N_noxref_6_c_2031_n ) capacitor c=6.32742e-19 \
 //x=2.215 //y=4.655 //x2=1.11 //y2=4.7
cc_793 ( N_noxref_3_c_727_n N_noxref_6_c_2031_n ) capacitor c=0.00113666f \
 //x=2.22 //y=4.7 //x2=1.11 //y2=4.7
cc_794 ( N_noxref_3_c_741_n N_noxref_6_c_2031_n ) capacitor c=0.00123917f \
 //x=2.22 //y=4.7 //x2=1.11 //y2=4.7
cc_795 ( N_noxref_3_c_754_n N_noxref_6_c_2034_n ) capacitor c=0.00169377f \
 //x=15.165 //y=4.515 //x2=15.36 //y2=5.38
cc_796 ( N_noxref_3_M34_noxref_g N_noxref_6_c_2034_n ) capacitor c=0.0179041f \
 //x=15.14 //y=6.02 //x2=15.36 //y2=5.38
cc_797 ( N_noxref_3_M35_noxref_g N_noxref_6_c_2034_n ) capacitor c=0.0179041f \
 //x=15.58 //y=6.02 //x2=15.36 //y2=5.38
cc_798 ( N_noxref_3_c_853_p N_noxref_6_c_2034_n ) capacitor c=0.00293647f \
 //x=15.505 //y=4.79 //x2=15.36 //y2=5.38
cc_799 ( N_noxref_3_M18_noxref_g N_noxref_6_M16_noxref_g ) capacitor \
 c=0.0106276f //x=2.19 //y=6.02 //x2=1.31 //y2=6.02
cc_800 ( N_noxref_3_M18_noxref_g N_noxref_6_M17_noxref_g ) capacitor \
 c=0.107144f //x=2.19 //y=6.02 //x2=1.75 //y2=6.02
cc_801 ( N_noxref_3_M19_noxref_g N_noxref_6_M17_noxref_g ) capacitor \
 c=0.0101598f //x=2.63 //y=6.02 //x2=1.75 //y2=6.02
cc_802 ( N_noxref_3_c_912_p N_noxref_6_c_2041_n ) capacitor c=5.72528e-19 \
 //x=1.785 //y=0.91 //x2=0.81 //y2=0.875
cc_803 ( N_noxref_3_c_912_p N_noxref_6_c_2042_n ) capacitor c=0.00150277f \
 //x=1.785 //y=0.91 //x2=0.81 //y2=1.22
cc_804 ( N_noxref_3_c_914_p N_noxref_6_c_2043_n ) capacitor c=0.00111227f \
 //x=1.785 //y=1.22 //x2=0.81 //y2=1.53
cc_805 ( N_noxref_3_c_702_n N_noxref_6_c_2044_n ) capacitor c=0.00147006f \
 //x=2.22 //y=2.195 //x2=0.81 //y2=1.915
cc_806 ( N_noxref_3_c_723_n N_noxref_6_c_2044_n ) capacitor c=0.00214573f \
 //x=2.22 //y=2.08 //x2=0.81 //y2=1.915
cc_807 ( N_noxref_3_c_736_n N_noxref_6_c_2044_n ) capacitor c=0.00964411f \
 //x=2.31 //y=1.915 //x2=0.81 //y2=1.915
cc_808 ( N_noxref_3_c_912_p N_noxref_6_c_2047_n ) capacitor c=0.0160123f \
 //x=1.785 //y=0.91 //x2=1.34 //y2=0.875
cc_809 ( N_noxref_3_c_733_n N_noxref_6_c_2047_n ) capacitor c=9.19165e-19 \
 //x=2.31 //y=0.91 //x2=1.34 //y2=0.875
cc_810 ( N_noxref_3_c_914_p N_noxref_6_c_2049_n ) capacitor c=0.0124075f \
 //x=1.785 //y=1.22 //x2=1.34 //y2=1.22
cc_811 ( N_noxref_3_c_734_n N_noxref_6_c_2049_n ) capacitor c=0.0010154f \
 //x=2.31 //y=1.22 //x2=1.34 //y2=1.22
cc_812 ( N_noxref_3_c_735_n N_noxref_6_c_2049_n ) capacitor c=9.23422e-19 \
 //x=2.31 //y=1.45 //x2=1.34 //y2=1.22
cc_813 ( N_noxref_3_c_711_n N_noxref_6_c_2052_n ) capacitor c=7.15803e-19 \
 //x=2.215 //y=4.655 //x2=1.675 //y2=4.79
cc_814 ( N_noxref_3_c_727_n N_noxref_6_c_2052_n ) capacitor c=0.00116563f \
 //x=2.22 //y=4.7 //x2=1.675 //y2=4.79
cc_815 ( N_noxref_3_c_741_n N_noxref_6_c_2052_n ) capacitor c=0.0169508f \
 //x=2.22 //y=4.7 //x2=1.675 //y2=4.79
cc_816 ( N_noxref_3_c_711_n N_noxref_6_c_2055_n ) capacitor c=8.67242e-19 \
 //x=2.215 //y=4.655 //x2=1.385 //y2=4.79
cc_817 ( N_noxref_3_c_727_n N_noxref_6_c_2055_n ) capacitor c=0.0012974f \
 //x=2.22 //y=4.7 //x2=1.385 //y2=4.79
cc_818 ( N_noxref_3_c_741_n N_noxref_6_c_2055_n ) capacitor c=0.00406071f \
 //x=2.22 //y=4.7 //x2=1.385 //y2=4.79
cc_819 ( N_noxref_3_M18_noxref_g N_noxref_7_c_2560_n ) capacitor c=0.00700336f \
 //x=2.19 //y=6.02 //x2=2.765 //y2=7.4
cc_820 ( N_noxref_3_M19_noxref_g N_noxref_7_c_2560_n ) capacitor c=0.00749619f \
 //x=2.63 //y=6.02 //x2=2.765 //y2=7.4
cc_821 ( N_noxref_3_M34_noxref_g N_noxref_7_c_2562_n ) capacitor c=0.00700336f \
 //x=15.14 //y=6.02 //x2=15.715 //y2=7.4
cc_822 ( N_noxref_3_M35_noxref_g N_noxref_7_c_2562_n ) capacitor c=0.00749619f \
 //x=15.58 //y=6.02 //x2=15.715 //y2=7.4
cc_823 ( N_noxref_3_c_714_n N_noxref_7_c_2481_n ) capacitor c=0.0263783f \
 //x=11.09 //y=4.44 //x2=4.81 //y2=7.4
cc_824 ( N_noxref_3_c_714_n N_noxref_7_c_2485_n ) capacitor c=0.0264951f \
 //x=11.09 //y=4.44 //x2=9.62 //y2=7.4
cc_825 ( N_noxref_3_c_760_n N_noxref_7_c_2532_n ) capacitor c=0.026267f \
 //x=11.69 //y=4.455 //x2=12.95 //y2=7.4
cc_826 ( N_noxref_3_M18_noxref_g N_noxref_7_M17_noxref_d ) capacitor \
 c=0.015318f //x=2.19 //y=6.02 //x2=1.825 //y2=5.02
cc_827 ( N_noxref_3_M19_noxref_g N_noxref_7_M19_noxref_d ) capacitor \
 c=0.015318f //x=2.63 //y=6.02 //x2=2.705 //y2=5.02
cc_828 ( N_noxref_3_c_714_n N_noxref_7_M22_noxref_s ) capacitor c=7.08158e-19 \
 //x=11.09 //y=4.44 //x2=5.765 //y2=5.02
cc_829 ( N_noxref_3_c_714_n N_noxref_7_M28_noxref_s ) capacitor c=0.00765173f \
 //x=11.09 //y=4.44 //x2=10.275 //y2=5.02
cc_830 ( N_noxref_3_c_760_n N_noxref_7_M32_noxref_s ) capacitor c=7.80611e-19 \
 //x=11.69 //y=4.455 //x2=13.905 //y2=5.02
cc_831 ( N_noxref_3_M34_noxref_g N_noxref_7_M33_noxref_d ) capacitor \
 c=0.015318f //x=15.14 //y=6.02 //x2=14.775 //y2=5.02
cc_832 ( N_noxref_3_M35_noxref_g N_noxref_7_M35_noxref_d ) capacitor \
 c=0.015318f //x=15.58 //y=6.02 //x2=15.655 //y2=5.02
cc_833 ( N_noxref_3_c_733_n N_noxref_8_c_2854_n ) capacitor c=0.00123426f \
 //x=2.31 //y=0.91 //x2=3.015 //y2=0.995
cc_834 ( N_noxref_3_c_734_n N_noxref_8_c_2854_n ) capacitor c=0.0129288f \
 //x=2.31 //y=1.22 //x2=3.015 //y2=0.995
cc_835 ( N_noxref_3_c_735_n N_noxref_8_c_2854_n ) capacitor c=0.00132209f \
 //x=2.31 //y=1.45 //x2=3.015 //y2=0.995
cc_836 ( N_noxref_3_c_702_n N_noxref_8_M1_noxref_d ) capacitor c=0.00610652f \
 //x=2.22 //y=2.195 //x2=1.86 //y2=0.91
cc_837 ( N_noxref_3_c_723_n N_noxref_8_M1_noxref_d ) capacitor c=2.2052e-19 \
 //x=2.22 //y=2.08 //x2=1.86 //y2=0.91
cc_838 ( N_noxref_3_c_912_p N_noxref_8_M1_noxref_d ) capacitor c=0.00253592f \
 //x=1.785 //y=0.91 //x2=1.86 //y2=0.91
cc_839 ( N_noxref_3_c_914_p N_noxref_8_M1_noxref_d ) capacitor c=0.00604634f \
 //x=1.785 //y=1.22 //x2=1.86 //y2=0.91
cc_840 ( N_noxref_3_c_950_p N_noxref_8_M1_noxref_d ) capacitor c=0.002686f \
 //x=2.155 //y=0.755 //x2=1.86 //y2=0.91
cc_841 ( N_noxref_3_c_951_p N_noxref_8_M1_noxref_d ) capacitor c=0.00251995f \
 //x=2.155 //y=1.375 //x2=1.86 //y2=0.91
cc_842 ( N_noxref_3_c_733_n N_noxref_8_M1_noxref_d ) capacitor c=0.00314523f \
 //x=2.31 //y=0.91 //x2=1.86 //y2=0.91
cc_843 ( N_noxref_3_c_734_n N_noxref_8_M1_noxref_d ) capacitor c=0.00168289f \
 //x=2.31 //y=1.22 //x2=1.86 //y2=0.91
cc_844 ( N_noxref_3_c_735_n N_noxref_8_M1_noxref_d ) capacitor c=0.00111165f \
 //x=2.31 //y=1.45 //x2=1.86 //y2=0.91
cc_845 ( N_noxref_3_c_733_n N_noxref_8_M2_noxref_s ) capacitor c=7.21316e-19 \
 //x=2.31 //y=0.91 //x2=2.965 //y2=0.375
cc_846 ( N_noxref_3_c_734_n N_noxref_8_M2_noxref_s ) capacitor c=0.00365271f \
 //x=2.31 //y=1.22 //x2=2.965 //y2=0.375
cc_847 ( N_noxref_3_c_736_n N_noxref_8_M2_noxref_s ) capacitor c=9.86711e-19 \
 //x=2.31 //y=1.915 //x2=2.965 //y2=0.375
cc_848 ( N_noxref_3_c_714_n N_noxref_10_c_2976_n ) capacitor c=0.0301831f \
 //x=11.09 //y=4.44 //x2=7.03 //y2=4.585
cc_849 ( N_noxref_3_c_779_n N_noxref_11_c_3093_n ) capacitor c=0.00123426f \
 //x=15.26 //y=0.91 //x2=15.965 //y2=0.995
cc_850 ( N_noxref_3_c_780_n N_noxref_11_c_3093_n ) capacitor c=0.0129288f \
 //x=15.26 //y=1.22 //x2=15.965 //y2=0.995
cc_851 ( N_noxref_3_c_781_n N_noxref_11_c_3093_n ) capacitor c=0.00132209f \
 //x=15.26 //y=1.45 //x2=15.965 //y2=0.995
cc_852 ( N_noxref_3_c_743_n N_noxref_11_M9_noxref_d ) capacitor c=0.00600656f \
 //x=15.17 //y=2.195 //x2=14.81 //y2=0.91
cc_853 ( N_noxref_3_c_763_n N_noxref_11_M9_noxref_d ) capacitor c=2.2052e-19 \
 //x=15.17 //y=2.08 //x2=14.81 //y2=0.91
cc_854 ( N_noxref_3_c_774_n N_noxref_11_M9_noxref_d ) capacitor c=0.00253592f \
 //x=14.735 //y=0.91 //x2=14.81 //y2=0.91
cc_855 ( N_noxref_3_c_777_n N_noxref_11_M9_noxref_d ) capacitor c=0.00604066f \
 //x=14.735 //y=1.22 //x2=14.81 //y2=0.91
cc_856 ( N_noxref_3_c_966_p N_noxref_11_M9_noxref_d ) capacitor c=0.002686f \
 //x=15.105 //y=0.755 //x2=14.81 //y2=0.91
cc_857 ( N_noxref_3_c_967_p N_noxref_11_M9_noxref_d ) capacitor c=0.00251995f \
 //x=15.105 //y=1.375 //x2=14.81 //y2=0.91
cc_858 ( N_noxref_3_c_779_n N_noxref_11_M9_noxref_d ) capacitor c=0.00314523f \
 //x=15.26 //y=0.91 //x2=14.81 //y2=0.91
cc_859 ( N_noxref_3_c_780_n N_noxref_11_M9_noxref_d ) capacitor c=0.00168289f \
 //x=15.26 //y=1.22 //x2=14.81 //y2=0.91
cc_860 ( N_noxref_3_c_781_n N_noxref_11_M9_noxref_d ) capacitor c=0.00111165f \
 //x=15.26 //y=1.45 //x2=14.81 //y2=0.91
cc_861 ( N_noxref_3_c_779_n N_noxref_11_M10_noxref_s ) capacitor c=7.21316e-19 \
 //x=15.26 //y=0.91 //x2=15.915 //y2=0.375
cc_862 ( N_noxref_3_c_780_n N_noxref_11_M10_noxref_s ) capacitor c=0.00365271f \
 //x=15.26 //y=1.22 //x2=15.915 //y2=0.375
cc_863 ( N_noxref_3_c_782_n N_noxref_11_M10_noxref_s ) capacitor c=9.86711e-19 \
 //x=15.26 //y=1.915 //x2=15.915 //y2=0.375
cc_864 ( N_noxref_3_c_702_n N_noxref_16_c_3560_n ) capacitor c=9.14667e-19 \
 //x=2.22 //y=2.195 //x2=5.8 //y2=0
cc_865 ( N_noxref_3_c_743_n N_noxref_16_c_3642_n ) capacitor c=7.98245e-19 \
 //x=15.17 //y=2.195 //x2=18.75 //y2=0
cc_866 ( N_noxref_3_c_912_p N_noxref_18_c_4128_n ) capacitor c=0.0167228f \
 //x=1.785 //y=0.91 //x2=2.445 //y2=0.54
cc_867 ( N_noxref_3_c_733_n N_noxref_18_c_4128_n ) capacitor c=0.00534519f \
 //x=2.31 //y=0.91 //x2=2.445 //y2=0.54
cc_868 ( N_noxref_3_c_702_n N_noxref_18_c_4130_n ) capacitor c=0.00481455f \
 //x=2.22 //y=2.195 //x2=2.445 //y2=1.59
cc_869 ( N_noxref_3_c_711_n N_noxref_18_c_4130_n ) capacitor c=8.72493e-19 \
 //x=2.215 //y=4.655 //x2=2.445 //y2=1.59
cc_870 ( N_noxref_3_c_723_n N_noxref_18_c_4130_n ) capacitor c=0.0105652f \
 //x=2.22 //y=2.08 //x2=2.445 //y2=1.59
cc_871 ( N_noxref_3_c_914_p N_noxref_18_c_4130_n ) capacitor c=0.0153476f \
 //x=1.785 //y=1.22 //x2=2.445 //y2=1.59
cc_872 ( N_noxref_3_c_736_n N_noxref_18_c_4130_n ) capacitor c=0.020563f \
 //x=2.31 //y=1.915 //x2=2.445 //y2=1.59
cc_873 ( N_noxref_3_c_912_p N_noxref_18_M0_noxref_s ) capacitor c=0.00798959f \
 //x=1.785 //y=0.91 //x2=0.455 //y2=0.375
cc_874 ( N_noxref_3_c_735_n N_noxref_18_M0_noxref_s ) capacitor c=0.00212176f \
 //x=2.31 //y=1.45 //x2=0.455 //y2=0.375
cc_875 ( N_noxref_3_c_736_n N_noxref_18_M0_noxref_s ) capacitor c=0.00298115f \
 //x=2.31 //y=1.915 //x2=0.455 //y2=0.375
cc_876 ( N_noxref_3_c_774_n N_noxref_21_c_4318_n ) capacitor c=0.0167228f \
 //x=14.735 //y=0.91 //x2=15.395 //y2=0.54
cc_877 ( N_noxref_3_c_779_n N_noxref_21_c_4318_n ) capacitor c=0.00534519f \
 //x=15.26 //y=0.91 //x2=15.395 //y2=0.54
cc_878 ( N_noxref_3_c_743_n N_noxref_21_c_4320_n ) capacitor c=0.0048147f \
 //x=15.17 //y=2.195 //x2=15.395 //y2=1.59
cc_879 ( N_noxref_3_c_754_n N_noxref_21_c_4320_n ) capacitor c=9.0414e-19 \
 //x=15.165 //y=4.515 //x2=15.395 //y2=1.59
cc_880 ( N_noxref_3_c_763_n N_noxref_21_c_4320_n ) capacitor c=0.0105652f \
 //x=15.17 //y=2.08 //x2=15.395 //y2=1.59
cc_881 ( N_noxref_3_c_777_n N_noxref_21_c_4320_n ) capacitor c=0.0153476f \
 //x=14.735 //y=1.22 //x2=15.395 //y2=1.59
cc_882 ( N_noxref_3_c_782_n N_noxref_21_c_4320_n ) capacitor c=0.0216832f \
 //x=15.26 //y=1.915 //x2=15.395 //y2=1.59
cc_883 ( N_noxref_3_c_774_n N_noxref_21_M8_noxref_s ) capacitor c=0.00798959f \
 //x=14.735 //y=0.91 //x2=13.405 //y2=0.375
cc_884 ( N_noxref_3_c_781_n N_noxref_21_M8_noxref_s ) capacitor c=0.00212176f \
 //x=15.26 //y=1.45 //x2=13.405 //y2=0.375
cc_885 ( N_noxref_3_c_782_n N_noxref_21_M8_noxref_s ) capacitor c=0.00298115f \
 //x=15.26 //y=1.915 //x2=13.405 //y2=0.375
cc_886 ( N_noxref_4_c_1040_n N_noxref_5_c_1457_n ) capacitor c=0.00171866f \
 //x=5.92 //y=3.54 //x2=8.14 //y2=4.57
cc_887 ( N_noxref_4_c_1045_n N_noxref_5_c_1457_n ) capacitor c=5.77971e-19 \
 //x=5.92 //y=4.575 //x2=8.14 //y2=4.57
cc_888 ( N_noxref_4_c_1055_n N_noxref_5_c_1457_n ) capacitor c=0.0223923f \
 //x=8.755 //y=3.715 //x2=8.14 //y2=4.57
cc_889 ( N_noxref_4_c_1133_p N_noxref_5_c_1515_n ) capacitor c=0.00228471f \
 //x=18.87 //y=3.54 //x2=16.28 //y2=4.57
cc_890 ( N_noxref_4_c_1134_p N_noxref_5_c_1515_n ) capacitor c=0.00162605f \
 //x=18.87 //y=4.575 //x2=16.28 //y2=4.57
cc_891 ( N_noxref_4_c_1125_n N_noxref_5_c_1515_n ) capacitor c=0.0275351f \
 //x=16.64 //y=3.7 //x2=16.28 //y2=4.57
cc_892 ( N_noxref_4_c_1136_p N_noxref_5_c_1567_n ) capacitor c=0.00798977f \
 //x=18.87 //y=2.195 //x2=19.98 //y2=2.335
cc_893 ( N_noxref_4_c_1133_p N_noxref_5_c_1567_n ) capacitor c=0.00291253f \
 //x=18.87 //y=3.54 //x2=19.98 //y2=2.335
cc_894 ( N_noxref_4_c_1138_p N_noxref_5_c_1567_n ) capacitor c=0.00120311f \
 //x=18.87 //y=2.08 //x2=19.98 //y2=2.335
cc_895 ( N_noxref_4_c_1139_p N_noxref_5_c_1567_n ) capacitor c=0.00159161f \
 //x=18.57 //y=1.915 //x2=19.98 //y2=2.335
cc_896 ( N_noxref_4_c_1133_p N_noxref_5_c_1571_n ) capacitor c=0.0389462f \
 //x=18.87 //y=3.54 //x2=19.98 //y2=4.585
cc_897 ( N_noxref_4_c_1141_p N_noxref_5_c_1571_n ) capacitor c=0.00763467f \
 //x=18.87 //y=3.86 //x2=19.98 //y2=4.585
cc_898 ( N_noxref_4_c_1134_p N_noxref_5_c_1571_n ) capacitor c=0.0297298f \
 //x=18.87 //y=4.575 //x2=19.98 //y2=4.585
cc_899 ( N_noxref_4_c_1143_p N_noxref_5_c_1571_n ) capacitor c=3.35971e-19 \
 //x=18.86 //y=3.7 //x2=19.98 //y2=4.585
cc_900 ( N_noxref_4_c_1144_p N_noxref_5_c_1571_n ) capacitor c=0.00504644f \
 //x=17.24 //y=3.69 //x2=19.98 //y2=4.585
cc_901 ( N_noxref_4_c_1145_p N_noxref_5_c_1571_n ) capacitor c=6.26008e-19 \
 //x=18.87 //y=4.7 //x2=19.98 //y2=4.585
cc_902 ( N_noxref_4_c_1146_p N_noxref_5_c_1571_n ) capacitor c=7.66769e-19 \
 //x=19.435 //y=4.79 //x2=19.98 //y2=4.585
cc_903 ( N_noxref_4_c_1147_p N_noxref_5_c_1571_n ) capacitor c=7.54501e-19 \
 //x=19.145 //y=4.79 //x2=19.98 //y2=4.585
cc_904 ( N_noxref_4_c_1055_n N_noxref_5_c_1467_n ) capacitor c=0.00212265f \
 //x=8.755 //y=3.715 //x2=8.145 //y2=2.125
cc_905 ( N_noxref_4_c_1052_n N_noxref_5_c_1470_n ) capacitor c=0.00490563f \
 //x=9.1 //y=3.715 //x2=16.125 //y2=2.135
cc_906 ( N_noxref_4_c_1055_n N_noxref_5_c_1470_n ) capacitor c=0.00247263f \
 //x=8.755 //y=3.715 //x2=16.125 //y2=2.135
cc_907 ( N_noxref_4_c_1059_n N_noxref_5_c_1470_n ) capacitor c=0.00531507f \
 //x=10.345 //y=3.7 //x2=16.125 //y2=2.135
cc_908 ( N_noxref_4_c_1063_n N_noxref_5_c_1470_n ) capacitor c=0.0176635f \
 //x=10.945 //y=3.715 //x2=16.125 //y2=2.135
cc_909 ( N_noxref_4_c_1085_n N_noxref_5_c_1470_n ) capacitor c=0.00876106f \
 //x=11.69 //y=3.685 //x2=16.125 //y2=2.135
cc_910 ( N_noxref_4_c_1088_n N_noxref_5_c_1470_n ) capacitor c=0.0052345f \
 //x=12.425 //y=3.72 //x2=16.125 //y2=2.135
cc_911 ( N_noxref_4_c_1091_n N_noxref_5_c_1470_n ) capacitor c=0.00531174f \
 //x=13.68 //y=3.7 //x2=16.125 //y2=2.135
cc_912 ( N_noxref_4_c_1095_n N_noxref_5_c_1470_n ) capacitor c=0.0278905f \
 //x=14.28 //y=3.72 //x2=16.125 //y2=2.135
cc_913 ( N_noxref_4_c_1125_n N_noxref_5_c_1541_n ) capacitor c=0.0278905f \
 //x=16.64 //y=3.7 //x2=16.445 //y2=2.135
cc_914 ( N_noxref_4_c_1136_p N_noxref_5_c_1589_n ) capacitor c=0.00279365f \
 //x=18.87 //y=2.195 //x2=19.935 //y2=2.175
cc_915 ( N_noxref_4_c_1133_p N_noxref_5_c_1589_n ) capacitor c=5.00559e-19 \
 //x=18.87 //y=3.54 //x2=19.935 //y2=2.175
cc_916 ( N_noxref_4_c_1136_p N_noxref_5_c_1591_n ) capacitor c=0.0168121f \
 //x=18.87 //y=2.195 //x2=19.775 //y2=2.175
cc_917 ( N_noxref_4_c_1133_p N_noxref_5_c_1591_n ) capacitor c=0.019227f \
 //x=18.87 //y=3.54 //x2=19.775 //y2=2.175
cc_918 ( N_noxref_4_c_1141_p N_noxref_5_c_1591_n ) capacitor c=0.00255185f \
 //x=18.87 //y=3.86 //x2=19.775 //y2=2.175
cc_919 ( N_noxref_4_c_1125_n N_noxref_5_c_1591_n ) capacitor c=0.0139471f \
 //x=16.64 //y=3.7 //x2=19.775 //y2=2.175
cc_920 ( N_noxref_4_c_1144_p N_noxref_5_c_1591_n ) capacitor c=0.0389454f \
 //x=17.24 //y=3.69 //x2=19.775 //y2=2.175
cc_921 ( N_noxref_4_c_1138_p N_noxref_5_c_1591_n ) capacitor c=2.54369e-19 \
 //x=18.87 //y=2.08 //x2=19.775 //y2=2.175
cc_922 ( N_noxref_4_c_1136_p N_noxref_5_c_1597_n ) capacitor c=5.39999e-19 \
 //x=18.87 //y=2.195 //x2=19.98 //y2=2.08
cc_923 ( N_noxref_4_c_1138_p N_noxref_5_c_1597_n ) capacitor c=0.00124896f \
 //x=18.87 //y=2.08 //x2=19.98 //y2=2.08
cc_924 ( N_noxref_4_c_1139_p N_noxref_5_c_1597_n ) capacitor c=0.00214501f \
 //x=18.57 //y=1.915 //x2=19.98 //y2=2.08
cc_925 ( N_noxref_4_c_1134_p N_noxref_5_c_1600_n ) capacitor c=0.00103399f \
 //x=18.87 //y=4.575 //x2=19.98 //y2=4.7
cc_926 ( N_noxref_4_c_1145_p N_noxref_5_c_1600_n ) capacitor c=0.00113984f \
 //x=18.87 //y=4.7 //x2=19.98 //y2=4.7
cc_927 ( N_noxref_4_c_1146_p N_noxref_5_c_1600_n ) capacitor c=0.00116563f \
 //x=19.435 //y=4.79 //x2=19.98 //y2=4.7
cc_928 ( N_noxref_4_c_1147_p N_noxref_5_c_1600_n ) capacitor c=0.00129812f \
 //x=19.145 //y=4.79 //x2=19.98 //y2=4.7
cc_929 ( N_noxref_4_M38_noxref_g N_noxref_5_M40_noxref_g ) capacitor \
 c=0.0106276f //x=19.07 //y=6.02 //x2=19.95 //y2=6.02
cc_930 ( N_noxref_4_M39_noxref_g N_noxref_5_M40_noxref_g ) capacitor \
 c=0.107144f //x=19.51 //y=6.02 //x2=19.95 //y2=6.02
cc_931 ( N_noxref_4_M39_noxref_g N_noxref_5_M41_noxref_g ) capacitor \
 c=0.0101598f //x=19.51 //y=6.02 //x2=20.39 //y2=6.02
cc_932 ( N_noxref_4_c_1176_p N_noxref_5_c_1607_n ) capacitor c=5.72528e-19 \
 //x=18.57 //y=0.875 //x2=19.545 //y2=0.91
cc_933 ( N_noxref_4_c_1177_p N_noxref_5_c_1607_n ) capacitor c=0.00150277f \
 //x=18.57 //y=1.22 //x2=19.545 //y2=0.91
cc_934 ( N_noxref_4_c_1178_p N_noxref_5_c_1607_n ) capacitor c=0.0160123f \
 //x=19.1 //y=0.875 //x2=19.545 //y2=0.91
cc_935 ( N_noxref_4_c_1179_p N_noxref_5_c_1610_n ) capacitor c=0.00111227f \
 //x=18.57 //y=1.53 //x2=19.545 //y2=1.22
cc_936 ( N_noxref_4_c_1180_p N_noxref_5_c_1610_n ) capacitor c=0.0124075f \
 //x=19.1 //y=1.22 //x2=19.545 //y2=1.22
cc_937 ( N_noxref_4_c_1178_p N_noxref_5_c_1612_n ) capacitor c=9.19165e-19 \
 //x=19.1 //y=0.875 //x2=20.07 //y2=0.91
cc_938 ( N_noxref_4_c_1180_p N_noxref_5_c_1613_n ) capacitor c=0.0010154f \
 //x=19.1 //y=1.22 //x2=20.07 //y2=1.22
cc_939 ( N_noxref_4_c_1180_p N_noxref_5_c_1614_n ) capacitor c=9.23422e-19 \
 //x=19.1 //y=1.22 //x2=20.07 //y2=1.45
cc_940 ( N_noxref_4_c_1136_p N_noxref_5_c_1615_n ) capacitor c=3.54695e-19 \
 //x=18.87 //y=2.195 //x2=20.07 //y2=1.915
cc_941 ( N_noxref_4_c_1138_p N_noxref_5_c_1615_n ) capacitor c=0.00166305f \
 //x=18.87 //y=2.08 //x2=20.07 //y2=1.915
cc_942 ( N_noxref_4_c_1139_p N_noxref_5_c_1615_n ) capacitor c=0.00868554f \
 //x=18.57 //y=1.915 //x2=20.07 //y2=1.915
cc_943 ( N_noxref_4_c_1134_p N_noxref_5_c_1618_n ) capacitor c=0.00116212f \
 //x=18.87 //y=4.575 //x2=19.98 //y2=4.7
cc_944 ( N_noxref_4_c_1145_p N_noxref_5_c_1618_n ) capacitor c=0.00155973f \
 //x=18.87 //y=4.7 //x2=19.98 //y2=4.7
cc_945 ( N_noxref_4_c_1146_p N_noxref_5_c_1618_n ) capacitor c=0.0171374f \
 //x=19.435 //y=4.79 //x2=19.98 //y2=4.7
cc_946 ( N_noxref_4_c_1147_p N_noxref_5_c_1618_n ) capacitor c=0.00484466f \
 //x=19.145 //y=4.79 //x2=19.98 //y2=4.7
cc_947 ( N_noxref_4_c_1063_n N_noxref_6_c_1865_n ) capacitor c=6.09845e-19 \
 //x=10.945 //y=3.715 //x2=11.47 //y2=3.91
cc_948 ( N_noxref_4_c_1085_n N_noxref_6_c_1865_n ) capacitor c=0.0256314f \
 //x=11.69 //y=3.685 //x2=11.47 //y2=3.91
cc_949 ( N_noxref_4_c_1063_n N_noxref_6_c_1873_n ) capacitor c=0.00217342f \
 //x=10.945 //y=3.715 //x2=11.47 //y2=4.23
cc_950 ( N_noxref_4_c_1085_n N_noxref_6_c_1873_n ) capacitor c=0.00450608f \
 //x=11.69 //y=3.685 //x2=11.47 //y2=4.23
cc_951 ( N_noxref_4_c_1136_p N_noxref_6_c_2005_n ) capacitor c=0.00357748f \
 //x=18.87 //y=2.195 //x2=17.02 //y2=3.915
cc_952 ( N_noxref_4_c_1133_p N_noxref_6_c_2005_n ) capacitor c=0.0234717f \
 //x=18.87 //y=3.54 //x2=17.02 //y2=3.915
cc_953 ( N_noxref_4_c_1141_p N_noxref_6_c_2005_n ) capacitor c=0.00257738f \
 //x=18.87 //y=3.86 //x2=17.02 //y2=3.915
cc_954 ( N_noxref_4_c_1134_p N_noxref_6_c_2005_n ) capacitor c=9.84588e-19 \
 //x=18.87 //y=4.575 //x2=17.02 //y2=3.915
cc_955 ( N_noxref_4_c_1125_n N_noxref_6_c_2005_n ) capacitor c=2.09913e-19 \
 //x=16.64 //y=3.7 //x2=17.02 //y2=3.915
cc_956 ( N_noxref_4_c_1144_p N_noxref_6_c_2005_n ) capacitor c=0.0293173f \
 //x=17.24 //y=3.69 //x2=17.02 //y2=3.915
cc_957 ( N_noxref_4_c_1134_p N_noxref_6_c_2068_n ) capacitor c=0.00237452f \
 //x=18.87 //y=4.575 //x2=17.02 //y2=4.235
cc_958 ( N_noxref_4_c_1125_n N_noxref_6_c_2068_n ) capacitor c=0.0018855f \
 //x=16.64 //y=3.7 //x2=17.02 //y2=4.235
cc_959 ( N_noxref_4_c_1144_p N_noxref_6_c_2068_n ) capacitor c=0.00583578f \
 //x=17.24 //y=3.69 //x2=17.02 //y2=4.235
cc_960 ( N_noxref_4_c_1134_p N_noxref_6_c_2006_n ) capacitor c=0.00982178f \
 //x=18.87 //y=4.575 //x2=17.02 //y2=5.07
cc_961 ( N_noxref_4_c_1034_n N_noxref_6_c_1883_n ) capacitor c=0.00118691f \
 //x=4.07 //y=3.865 //x2=3.685 //y2=4.07
cc_962 ( N_noxref_4_c_1036_n N_noxref_6_c_1883_n ) capacitor c=4.26819e-19 \
 //x=4.07 //y=5.07 //x2=3.685 //y2=4.07
cc_963 ( N_noxref_4_c_1207_p N_noxref_6_c_1883_n ) capacitor c=0.0219438f \
 //x=1.532 //y=5.155 //x2=3.685 //y2=4.07
cc_964 ( N_noxref_4_c_1065_n N_noxref_6_c_1883_n ) capacitor c=0.0358254f \
 //x=4.235 //y=3.705 //x2=3.685 //y2=4.07
cc_965 ( N_noxref_4_c_1034_n N_noxref_6_c_1887_n ) capacitor c=0.00757286f \
 //x=4.07 //y=3.865 //x2=4.325 //y2=4.09
cc_966 ( N_noxref_4_c_1036_n N_noxref_6_c_1887_n ) capacitor c=0.022593f \
 //x=4.07 //y=5.07 //x2=4.325 //y2=4.09
cc_967 ( N_noxref_4_c_1050_n N_noxref_6_c_1887_n ) capacitor c=0.128481f \
 //x=5.765 //y=3.7 //x2=4.325 //y2=4.09
cc_968 ( N_noxref_4_c_1044_n N_noxref_6_c_1888_n ) capacitor c=0.00133789f \
 //x=5.92 //y=3.86 //x2=5.54 //y2=4.07
cc_969 ( N_noxref_4_c_1045_n N_noxref_6_c_1888_n ) capacitor c=5.06484e-19 \
 //x=5.92 //y=4.575 //x2=5.54 //y2=4.07
cc_970 ( N_noxref_4_c_1050_n N_noxref_6_c_1888_n ) capacitor c=0.012414f \
 //x=5.765 //y=3.7 //x2=5.54 //y2=4.07
cc_971 ( N_noxref_4_c_1055_n N_noxref_6_c_1888_n ) capacitor c=0.0358254f \
 //x=8.755 //y=3.715 //x2=5.54 //y2=4.07
cc_972 ( N_noxref_4_c_1044_n N_noxref_6_c_1889_n ) capacitor c=0.00678219f \
 //x=5.92 //y=3.86 //x2=6.14 //y2=4.085
cc_973 ( N_noxref_4_c_1045_n N_noxref_6_c_1889_n ) capacitor c=0.0235427f \
 //x=5.92 //y=4.575 //x2=6.14 //y2=4.085
cc_974 ( N_noxref_4_c_1055_n N_noxref_6_c_1889_n ) capacitor c=0.0110198f \
 //x=8.755 //y=3.715 //x2=6.14 //y2=4.085
cc_975 ( N_noxref_4_c_1085_n N_noxref_6_c_1942_n ) capacitor c=0.0821257f \
 //x=11.69 //y=3.685 //x2=16.865 //y2=4.07
cc_976 ( N_noxref_4_c_1088_n N_noxref_6_c_1942_n ) capacitor c=0.112836f \
 //x=12.425 //y=3.72 //x2=16.865 //y2=4.07
cc_977 ( N_noxref_4_c_1091_n N_noxref_6_c_1942_n ) capacitor c=0.0588821f \
 //x=13.68 //y=3.7 //x2=16.865 //y2=4.07
cc_978 ( N_noxref_4_c_1095_n N_noxref_6_c_1942_n ) capacitor c=0.210146f \
 //x=14.28 //y=3.72 //x2=16.865 //y2=4.07
cc_979 ( N_noxref_4_c_1125_n N_noxref_6_c_1942_n ) capacitor c=0.0114505f \
 //x=16.64 //y=3.7 //x2=16.865 //y2=4.07
cc_980 ( N_noxref_4_c_1045_n N_noxref_6_c_1890_n ) capacitor c=3.74821e-19 \
 //x=5.92 //y=4.575 //x2=11.635 //y2=4.07
cc_981 ( N_noxref_4_c_1052_n N_noxref_6_c_1890_n ) capacitor c=0.111435f \
 //x=9.1 //y=3.715 //x2=11.635 //y2=4.07
cc_982 ( N_noxref_4_c_1055_n N_noxref_6_c_1890_n ) capacitor c=0.262245f \
 //x=8.755 //y=3.715 //x2=11.635 //y2=4.07
cc_983 ( N_noxref_4_c_1059_n N_noxref_6_c_1890_n ) capacitor c=0.0568414f \
 //x=10.345 //y=3.7 //x2=11.635 //y2=4.07
cc_984 ( N_noxref_4_c_1063_n N_noxref_6_c_1890_n ) capacitor c=0.0235968f \
 //x=10.945 //y=3.715 //x2=11.635 //y2=4.07
cc_985 ( N_noxref_4_c_1085_n N_noxref_6_c_1890_n ) capacitor c=0.0358686f \
 //x=11.69 //y=3.685 //x2=11.635 //y2=4.07
cc_986 ( N_noxref_4_c_1141_p N_noxref_6_c_2097_n ) capacitor c=0.00296224f \
 //x=18.87 //y=3.86 //x2=19.075 //y2=4.085
cc_987 ( N_noxref_4_c_1134_p N_noxref_6_c_2097_n ) capacitor c=0.0305692f \
 //x=18.87 //y=4.575 //x2=19.075 //y2=4.085
cc_988 ( N_noxref_4_c_1141_p N_noxref_6_c_2099_n ) capacitor c=0.00501225f \
 //x=18.87 //y=3.86 //x2=18.73 //y2=4.085
cc_989 ( N_noxref_4_c_1134_p N_noxref_6_c_2099_n ) capacitor c=0.00195984f \
 //x=18.87 //y=4.575 //x2=18.73 //y2=4.085
cc_990 ( N_noxref_4_c_1144_p N_noxref_6_c_2099_n ) capacitor c=0.213124f \
 //x=17.24 //y=3.69 //x2=18.73 //y2=4.085
cc_991 ( N_noxref_4_c_1207_p N_noxref_6_M16_noxref_g ) capacitor c=0.00501342f \
 //x=1.532 //y=5.155 //x2=1.31 //y2=6.02
cc_992 ( N_noxref_4_c_1236_p N_noxref_6_M16_noxref_g ) capacitor c=0.0162284f \
 //x=1.53 //y=5.38 //x2=1.31 //y2=6.02
cc_993 ( N_noxref_4_c_1097_n N_noxref_6_M17_noxref_g ) capacitor c=0.00973141f \
 //x=2.29 //y=5.155 //x2=1.75 //y2=6.02
cc_994 ( N_noxref_4_c_1207_p N_noxref_6_M17_noxref_g ) capacitor c=0.00229208f \
 //x=1.532 //y=5.155 //x2=1.75 //y2=6.02
cc_995 ( N_noxref_4_c_1236_p N_noxref_6_M17_noxref_g ) capacitor c=0.0179041f \
 //x=1.53 //y=5.38 //x2=1.75 //y2=6.02
cc_996 ( N_noxref_4_c_1207_p N_noxref_6_c_2052_n ) capacitor c=0.00171885f \
 //x=1.532 //y=5.155 //x2=1.675 //y2=4.79
cc_997 ( N_noxref_4_c_1236_p N_noxref_6_c_2052_n ) capacitor c=0.00291477f \
 //x=1.53 //y=5.38 //x2=1.675 //y2=4.79
cc_998 ( N_noxref_4_c_1097_n N_noxref_7_c_2451_n ) capacitor c=0.0062064f \
 //x=2.29 //y=5.155 //x2=25.53 //y2=7.4
cc_999 ( N_noxref_4_c_996_n N_noxref_7_c_2451_n ) capacitor c=0.00626473f \
 //x=3.175 //y=5.155 //x2=25.53 //y2=7.4
cc_1000 ( N_noxref_4_c_998_n N_noxref_7_c_2451_n ) capacitor c=0.00255587f \
 //x=3.29 //y=5.38 //x2=25.53 //y2=7.4
cc_1001 ( N_noxref_4_c_1001_n N_noxref_7_c_2451_n ) capacitor c=0.00827854f \
 //x=3.985 //y=5.155 //x2=25.53 //y2=7.4
cc_1002 ( N_noxref_4_c_1034_n N_noxref_7_c_2451_n ) capacitor c=5.13385e-19 \
 //x=4.07 //y=3.865 //x2=25.53 //y2=7.4
cc_1003 ( N_noxref_4_c_1044_n N_noxref_7_c_2451_n ) capacitor c=3.34278e-19 \
 //x=5.92 //y=3.86 //x2=25.53 //y2=7.4
cc_1004 ( N_noxref_4_c_1141_p N_noxref_7_c_2451_n ) capacitor c=4.06302e-19 \
 //x=18.87 //y=3.86 //x2=25.53 //y2=7.4
cc_1005 ( N_noxref_4_c_1207_p N_noxref_7_c_2451_n ) capacitor c=0.00261379f \
 //x=1.532 //y=5.155 //x2=25.53 //y2=7.4
cc_1006 ( N_noxref_4_c_1108_n N_noxref_7_c_2451_n ) capacitor c=0.0026965f \
 //x=2.41 //y=5.155 //x2=25.53 //y2=7.4
cc_1007 ( N_noxref_4_c_1236_p N_noxref_7_c_2451_n ) capacitor c=0.00242194f \
 //x=1.53 //y=5.38 //x2=25.53 //y2=7.4
cc_1008 ( N_noxref_4_c_1126_n N_noxref_7_c_2451_n ) capacitor c=0.00242194f \
 //x=2.41 //y=5.38 //x2=25.53 //y2=7.4
cc_1009 ( N_noxref_4_c_1067_n N_noxref_7_c_2451_n ) capacitor c=0.00242194f \
 //x=3.29 //y=5.38 //x2=25.53 //y2=7.4
cc_1010 ( N_noxref_4_c_1207_p N_noxref_7_c_2586_n ) capacitor c=0.00331944f \
 //x=1.532 //y=5.155 //x2=0.74 //y2=7.4
cc_1011 ( N_noxref_4_c_1236_p N_noxref_7_c_2586_n ) capacitor c=0.00509469f \
 //x=1.53 //y=5.38 //x2=0.74 //y2=7.4
cc_1012 ( N_noxref_4_c_1097_n N_noxref_7_c_2588_n ) capacitor c=0.00202948f \
 //x=2.29 //y=5.155 //x2=1.885 //y2=7.4
cc_1013 ( N_noxref_4_c_1207_p N_noxref_7_c_2588_n ) capacitor c=9.37357e-19 \
 //x=1.532 //y=5.155 //x2=1.885 //y2=7.4
cc_1014 ( N_noxref_4_c_1236_p N_noxref_7_c_2588_n ) capacitor c=0.0137846f \
 //x=1.53 //y=5.38 //x2=1.885 //y2=7.4
cc_1015 ( N_noxref_4_c_1097_n N_noxref_7_c_2560_n ) capacitor c=0.00177088f \
 //x=2.29 //y=5.155 //x2=2.765 //y2=7.4
cc_1016 ( N_noxref_4_c_996_n N_noxref_7_c_2560_n ) capacitor c=0.00202948f \
 //x=3.175 //y=5.155 //x2=2.765 //y2=7.4
cc_1017 ( N_noxref_4_c_1108_n N_noxref_7_c_2560_n ) capacitor c=9.47876e-19 \
 //x=2.41 //y=5.155 //x2=2.765 //y2=7.4
cc_1018 ( N_noxref_4_c_1126_n N_noxref_7_c_2560_n ) capacitor c=0.0137846f \
 //x=2.41 //y=5.38 //x2=2.765 //y2=7.4
cc_1019 ( N_noxref_4_c_996_n N_noxref_7_c_2464_n ) capacitor c=0.00205929f \
 //x=3.175 //y=5.155 //x2=3.645 //y2=7.4
cc_1020 ( N_noxref_4_c_998_n N_noxref_7_c_2464_n ) capacitor c=8.49349e-19 \
 //x=3.29 //y=5.38 //x2=3.645 //y2=7.4
cc_1021 ( N_noxref_4_c_1001_n N_noxref_7_c_2464_n ) capacitor c=0.00204261f \
 //x=3.985 //y=5.155 //x2=3.645 //y2=7.4
cc_1022 ( N_noxref_4_c_1067_n N_noxref_7_c_2464_n ) capacitor c=0.0137846f \
 //x=3.29 //y=5.38 //x2=3.645 //y2=7.4
cc_1023 ( N_noxref_4_c_1001_n N_noxref_7_c_2599_n ) capacitor c=0.00183429f \
 //x=3.985 //y=5.155 //x2=4.64 //y2=7.4
cc_1024 ( N_noxref_4_M22_noxref_g N_noxref_7_c_2466_n ) capacitor \
 c=0.00749687f //x=6.12 //y=6.02 //x2=6.695 //y2=7.4
cc_1025 ( N_noxref_4_M23_noxref_g N_noxref_7_c_2466_n ) capacitor \
 c=0.00749619f //x=6.56 //y=6.02 //x2=6.695 //y2=7.4
cc_1026 ( N_noxref_4_M38_noxref_g N_noxref_7_c_2602_n ) capacitor \
 c=0.00749687f //x=19.07 //y=6.02 //x2=19.645 //y2=7.4
cc_1027 ( N_noxref_4_M39_noxref_g N_noxref_7_c_2602_n ) capacitor \
 c=0.00749619f //x=19.51 //y=6.02 //x2=19.645 //y2=7.4
cc_1028 ( N_noxref_4_c_998_n N_noxref_7_c_2481_n ) capacitor c=0.00282782f \
 //x=3.29 //y=5.38 //x2=4.81 //y2=7.4
cc_1029 ( N_noxref_4_c_1036_n N_noxref_7_c_2481_n ) capacitor c=0.0325571f \
 //x=4.07 //y=5.07 //x2=4.81 //y2=7.4
cc_1030 ( N_noxref_4_c_1045_n N_noxref_7_c_2481_n ) capacitor c=0.0118976f \
 //x=5.92 //y=4.575 //x2=4.81 //y2=7.4
cc_1031 ( N_noxref_4_c_1067_n N_noxref_7_c_2481_n ) capacitor c=0.00777981f \
 //x=3.29 //y=5.38 //x2=4.81 //y2=7.4
cc_1032 ( N_noxref_4_c_1276_p N_noxref_7_c_2481_n ) capacitor c=0.00370784f \
 //x=5.92 //y=4.7 //x2=4.81 //y2=7.4
cc_1033 ( N_noxref_4_c_1277_p N_noxref_7_c_2481_n ) capacitor c=0.00590568f \
 //x=6.195 //y=4.79 //x2=4.81 //y2=7.4
cc_1034 ( N_noxref_4_c_1134_p N_noxref_7_c_2610_n ) capacitor c=0.0138211f \
 //x=18.87 //y=4.575 //x2=17.76 //y2=7.4
cc_1035 ( N_noxref_4_c_1145_p N_noxref_7_c_2610_n ) capacitor c=0.00370784f \
 //x=18.87 //y=4.7 //x2=17.76 //y2=7.4
cc_1036 ( N_noxref_4_c_1147_p N_noxref_7_c_2610_n ) capacitor c=0.00590568f \
 //x=19.145 //y=4.79 //x2=17.76 //y2=7.4
cc_1037 ( N_noxref_4_c_1207_p N_noxref_7_M16_noxref_s ) capacitor c=0.0453361f \
 //x=1.532 //y=5.155 //x2=0.955 //y2=5.02
cc_1038 ( N_noxref_4_c_1108_n N_noxref_7_M16_noxref_s ) capacitor \
 c=7.80122e-19 //x=2.41 //y=5.155 //x2=0.955 //y2=5.02
cc_1039 ( N_noxref_4_c_1236_p N_noxref_7_M16_noxref_s ) capacitor c=0.09305f \
 //x=1.53 //y=5.38 //x2=0.955 //y2=5.02
cc_1040 ( N_noxref_4_c_1097_n N_noxref_7_M17_noxref_d ) capacitor \
 c=0.00700078f //x=2.29 //y=5.155 //x2=1.825 //y2=5.02
cc_1041 ( N_noxref_4_c_1236_p N_noxref_7_M17_noxref_d ) capacitor c=0.0674491f \
 //x=1.53 //y=5.38 //x2=1.825 //y2=5.02
cc_1042 ( N_noxref_4_c_1126_n N_noxref_7_M17_noxref_d ) capacitor c=0.0674762f \
 //x=2.41 //y=5.38 //x2=1.825 //y2=5.02
cc_1043 ( N_noxref_4_c_996_n N_noxref_7_M19_noxref_d ) capacitor c=0.00700078f \
 //x=3.175 //y=5.155 //x2=2.705 //y2=5.02
cc_1044 ( N_noxref_4_c_1126_n N_noxref_7_M19_noxref_d ) capacitor c=0.067493f \
 //x=2.41 //y=5.38 //x2=2.705 //y2=5.02
cc_1045 ( N_noxref_4_c_1067_n N_noxref_7_M19_noxref_d ) capacitor c=0.0674979f \
 //x=3.29 //y=5.38 //x2=2.705 //y2=5.02
cc_1046 ( N_noxref_4_c_1001_n N_noxref_7_M21_noxref_d ) capacitor \
 c=0.00700078f //x=3.985 //y=5.155 //x2=3.585 //y2=5.02
cc_1047 ( N_noxref_4_c_1067_n N_noxref_7_M21_noxref_d ) capacitor c=0.0675002f \
 //x=3.29 //y=5.38 //x2=3.585 //y2=5.02
cc_1048 ( N_noxref_4_c_998_n N_noxref_7_M22_noxref_s ) capacitor c=0.00492616f \
 //x=3.29 //y=5.38 //x2=5.765 //y2=5.02
cc_1049 ( N_noxref_4_c_1001_n N_noxref_7_M22_noxref_s ) capacitor \
 c=9.42705e-19 //x=3.985 //y=5.155 //x2=5.765 //y2=5.02
cc_1050 ( N_noxref_4_c_1044_n N_noxref_7_M22_noxref_s ) capacitor \
 c=7.08613e-19 //x=5.92 //y=3.86 //x2=5.765 //y2=5.02
cc_1051 ( N_noxref_4_c_1045_n N_noxref_7_M22_noxref_s ) capacitor c=0.0217983f \
 //x=5.92 //y=4.575 //x2=5.765 //y2=5.02
cc_1052 ( N_noxref_4_c_1108_n N_noxref_7_M22_noxref_s ) capacitor \
 c=2.11884e-19 //x=2.41 //y=5.155 //x2=5.765 //y2=5.02
cc_1053 ( N_noxref_4_c_1276_p N_noxref_7_M22_noxref_s ) capacitor \
 c=0.00983827f //x=5.92 //y=4.7 //x2=5.765 //y2=5.02
cc_1054 ( N_noxref_4_M22_noxref_g N_noxref_7_M22_noxref_s ) capacitor \
 c=0.053419f //x=6.12 //y=6.02 //x2=5.765 //y2=5.02
cc_1055 ( N_noxref_4_c_1277_p N_noxref_7_M22_noxref_s ) capacitor \
 c=0.00604406f //x=6.195 //y=4.79 //x2=5.765 //y2=5.02
cc_1056 ( N_noxref_4_M23_noxref_g N_noxref_7_M23_noxref_d ) capacitor \
 c=0.015318f //x=6.56 //y=6.02 //x2=6.635 //y2=5.02
cc_1057 ( N_noxref_4_c_1141_p N_noxref_7_M38_noxref_s ) capacitor c=7.3096e-19 \
 //x=18.87 //y=3.86 //x2=18.715 //y2=5.02
cc_1058 ( N_noxref_4_c_1134_p N_noxref_7_M38_noxref_s ) capacitor c=0.022441f \
 //x=18.87 //y=4.575 //x2=18.715 //y2=5.02
cc_1059 ( N_noxref_4_c_1145_p N_noxref_7_M38_noxref_s ) capacitor \
 c=0.00983393f //x=18.87 //y=4.7 //x2=18.715 //y2=5.02
cc_1060 ( N_noxref_4_M38_noxref_g N_noxref_7_M38_noxref_s ) capacitor \
 c=0.053419f //x=19.07 //y=6.02 //x2=18.715 //y2=5.02
cc_1061 ( N_noxref_4_c_1147_p N_noxref_7_M38_noxref_s ) capacitor \
 c=0.00604406f //x=19.145 //y=4.79 //x2=18.715 //y2=5.02
cc_1062 ( N_noxref_4_M39_noxref_g N_noxref_7_M39_noxref_d ) capacitor \
 c=0.015318f //x=19.51 //y=6.02 //x2=19.585 //y2=5.02
cc_1063 ( N_noxref_4_c_1006_n N_noxref_8_c_2844_n ) capacitor c=0.0036878f \
 //x=3.585 //y=1.125 //x2=3.985 //y2=0.54
cc_1064 ( N_noxref_4_c_1018_n N_noxref_8_c_2844_n ) capacitor c=0.00365967f \
 //x=3.985 //y=1.665 //x2=3.985 //y2=0.54
cc_1065 ( N_noxref_4_M2_noxref_d N_noxref_8_c_2844_n ) capacitor c=0.00949319f \
 //x=3.395 //y=0.915 //x2=3.985 //y2=0.54
cc_1066 ( N_noxref_4_M2_noxref_d N_noxref_8_c_2849_n ) capacitor c=0.00120711f \
 //x=3.395 //y=0.915 //x2=3.1 //y2=0.995
cc_1067 ( N_noxref_4_c_1097_n N_noxref_8_M1_noxref_d ) capacitor c=0.00159405f \
 //x=2.29 //y=5.155 //x2=1.86 //y2=0.91
cc_1068 ( N_noxref_4_c_1006_n N_noxref_8_M1_noxref_d ) capacitor c=0.00802417f \
 //x=3.585 //y=1.125 //x2=1.86 //y2=0.91
cc_1069 ( N_noxref_4_c_1006_n N_noxref_8_M2_noxref_s ) capacitor c=0.0098487f \
 //x=3.585 //y=1.125 //x2=2.965 //y2=0.375
cc_1070 ( N_noxref_4_c_1013_n N_noxref_8_M2_noxref_s ) capacitor c=0.028602f \
 //x=3.585 //y=1.58 //x2=2.965 //y2=0.375
cc_1071 ( N_noxref_4_c_1018_n N_noxref_8_M2_noxref_s ) capacitor c=0.00911719f \
 //x=3.985 //y=1.665 //x2=2.965 //y2=0.375
cc_1072 ( N_noxref_4_c_1049_n N_noxref_8_M2_noxref_s ) capacitor c=0.00129723f \
 //x=4.07 //y=3.7 //x2=2.965 //y2=0.375
cc_1073 ( N_noxref_4_M2_noxref_d N_noxref_8_M2_noxref_s ) capacitor \
 c=0.0279003f //x=3.395 //y=0.915 //x2=2.965 //y2=0.375
cc_1074 ( N_noxref_4_c_1006_n N_noxref_9_M4_noxref_d ) capacitor c=3.20746e-19 \
 //x=3.585 //y=1.125 //x2=6.67 //y2=0.91
cc_1075 ( N_noxref_4_c_1039_n N_noxref_10_c_2975_n ) capacitor c=0.0109668f \
 //x=5.92 //y=2.195 //x2=7.03 //y2=2.195
cc_1076 ( N_noxref_4_c_1320_p N_noxref_10_c_2975_n ) capacitor c=5.40058e-19 \
 //x=5.92 //y=2.08 //x2=7.03 //y2=2.195
cc_1077 ( N_noxref_4_c_1321_p N_noxref_10_c_2975_n ) capacitor c=0.00147006f \
 //x=5.62 //y=1.915 //x2=7.03 //y2=2.195
cc_1078 ( N_noxref_4_c_1024_n N_noxref_10_c_2976_n ) capacitor c=0.0017365f \
 //x=4.07 //y=3.545 //x2=7.03 //y2=4.585
cc_1079 ( N_noxref_4_c_1036_n N_noxref_10_c_2976_n ) capacitor c=6.66489e-19 \
 //x=4.07 //y=5.07 //x2=7.03 //y2=4.585
cc_1080 ( N_noxref_4_c_1040_n N_noxref_10_c_2976_n ) capacitor c=0.038367f \
 //x=5.92 //y=3.54 //x2=7.03 //y2=4.585
cc_1081 ( N_noxref_4_c_1044_n N_noxref_10_c_2976_n ) capacitor c=0.00774769f \
 //x=5.92 //y=3.86 //x2=7.03 //y2=4.585
cc_1082 ( N_noxref_4_c_1045_n N_noxref_10_c_2976_n ) capacitor c=0.0269128f \
 //x=5.92 //y=4.575 //x2=7.03 //y2=4.585
cc_1083 ( N_noxref_4_c_1327_p N_noxref_10_c_2976_n ) capacitor c=2.90818e-19 \
 //x=5.92 //y=3.7 //x2=7.03 //y2=4.585
cc_1084 ( N_noxref_4_c_1055_n N_noxref_10_c_2976_n ) capacitor c=0.0253614f \
 //x=8.755 //y=3.715 //x2=7.03 //y2=4.585
cc_1085 ( N_noxref_4_c_1320_p N_noxref_10_c_2976_n ) capacitor c=4.16726e-19 \
 //x=5.92 //y=2.08 //x2=7.03 //y2=4.585
cc_1086 ( N_noxref_4_c_1276_p N_noxref_10_c_2976_n ) capacitor c=6.26008e-19 \
 //x=5.92 //y=4.7 //x2=7.03 //y2=4.585
cc_1087 ( N_noxref_4_c_1077_n N_noxref_10_c_2976_n ) capacitor c=7.66769e-19 \
 //x=6.485 //y=4.79 //x2=7.03 //y2=4.585
cc_1088 ( N_noxref_4_c_1277_p N_noxref_10_c_2976_n ) capacitor c=7.54501e-19 \
 //x=6.195 //y=4.79 //x2=7.03 //y2=4.585
cc_1089 ( N_noxref_4_c_1039_n N_noxref_10_c_3008_n ) capacitor c=5.39999e-19 \
 //x=5.92 //y=2.195 //x2=7.03 //y2=2.08
cc_1090 ( N_noxref_4_c_1040_n N_noxref_10_c_3008_n ) capacitor c=4.16726e-19 \
 //x=5.92 //y=3.54 //x2=7.03 //y2=2.08
cc_1091 ( N_noxref_4_c_1320_p N_noxref_10_c_3008_n ) capacitor c=0.00125213f \
 //x=5.92 //y=2.08 //x2=7.03 //y2=2.08
cc_1092 ( N_noxref_4_c_1321_p N_noxref_10_c_3008_n ) capacitor c=0.00214573f \
 //x=5.62 //y=1.915 //x2=7.03 //y2=2.08
cc_1093 ( N_noxref_4_c_1045_n N_noxref_10_c_2982_n ) capacitor c=0.00103399f \
 //x=5.92 //y=4.575 //x2=7.03 //y2=4.7
cc_1094 ( N_noxref_4_c_1276_p N_noxref_10_c_2982_n ) capacitor c=0.00113984f \
 //x=5.92 //y=4.7 //x2=7.03 //y2=4.7
cc_1095 ( N_noxref_4_c_1077_n N_noxref_10_c_2982_n ) capacitor c=0.00116563f \
 //x=6.485 //y=4.79 //x2=7.03 //y2=4.7
cc_1096 ( N_noxref_4_c_1277_p N_noxref_10_c_2982_n ) capacitor c=0.00129812f \
 //x=6.195 //y=4.79 //x2=7.03 //y2=4.7
cc_1097 ( N_noxref_4_M22_noxref_g N_noxref_10_M24_noxref_g ) capacitor \
 c=0.0106276f //x=6.12 //y=6.02 //x2=7 //y2=6.02
cc_1098 ( N_noxref_4_M23_noxref_g N_noxref_10_M24_noxref_g ) capacitor \
 c=0.107144f //x=6.56 //y=6.02 //x2=7 //y2=6.02
cc_1099 ( N_noxref_4_M23_noxref_g N_noxref_10_M25_noxref_g ) capacitor \
 c=0.0101598f //x=6.56 //y=6.02 //x2=7.44 //y2=6.02
cc_1100 ( N_noxref_4_c_1344_p N_noxref_10_c_3019_n ) capacitor c=5.72528e-19 \
 //x=5.62 //y=0.875 //x2=6.595 //y2=0.91
cc_1101 ( N_noxref_4_c_1345_p N_noxref_10_c_3019_n ) capacitor c=0.00150277f \
 //x=5.62 //y=1.22 //x2=6.595 //y2=0.91
cc_1102 ( N_noxref_4_c_1346_p N_noxref_10_c_3019_n ) capacitor c=0.0160123f \
 //x=6.15 //y=0.875 //x2=6.595 //y2=0.91
cc_1103 ( N_noxref_4_c_1347_p N_noxref_10_c_3022_n ) capacitor c=0.00111227f \
 //x=5.62 //y=1.53 //x2=6.595 //y2=1.22
cc_1104 ( N_noxref_4_c_1348_p N_noxref_10_c_3022_n ) capacitor c=0.0124075f \
 //x=6.15 //y=1.22 //x2=6.595 //y2=1.22
cc_1105 ( N_noxref_4_c_1346_p N_noxref_10_c_3024_n ) capacitor c=9.19165e-19 \
 //x=6.15 //y=0.875 //x2=7.12 //y2=0.91
cc_1106 ( N_noxref_4_c_1348_p N_noxref_10_c_3025_n ) capacitor c=0.0010154f \
 //x=6.15 //y=1.22 //x2=7.12 //y2=1.22
cc_1107 ( N_noxref_4_c_1348_p N_noxref_10_c_3026_n ) capacitor c=9.23422e-19 \
 //x=6.15 //y=1.22 //x2=7.12 //y2=1.45
cc_1108 ( N_noxref_4_c_1039_n N_noxref_10_c_3027_n ) capacitor c=0.00140534f \
 //x=5.92 //y=2.195 //x2=7.12 //y2=1.915
cc_1109 ( N_noxref_4_c_1320_p N_noxref_10_c_3027_n ) capacitor c=0.0020754f \
 //x=5.92 //y=2.08 //x2=7.12 //y2=1.915
cc_1110 ( N_noxref_4_c_1321_p N_noxref_10_c_3027_n ) capacitor c=0.00964411f \
 //x=5.62 //y=1.915 //x2=7.12 //y2=1.915
cc_1111 ( N_noxref_4_c_1045_n N_noxref_10_c_2992_n ) capacitor c=0.00116212f \
 //x=5.92 //y=4.575 //x2=7.03 //y2=4.7
cc_1112 ( N_noxref_4_c_1276_p N_noxref_10_c_2992_n ) capacitor c=0.00155973f \
 //x=5.92 //y=4.7 //x2=7.03 //y2=4.7
cc_1113 ( N_noxref_4_c_1077_n N_noxref_10_c_2992_n ) capacitor c=0.0171374f \
 //x=6.485 //y=4.79 //x2=7.03 //y2=4.7
cc_1114 ( N_noxref_4_c_1277_p N_noxref_10_c_2992_n ) capacitor c=0.00484466f \
 //x=6.195 //y=4.79 //x2=7.03 //y2=4.7
cc_1115 ( N_noxref_4_c_1133_p N_noxref_13_c_3227_n ) capacitor c=0.00176136f \
 //x=18.87 //y=3.54 //x2=21.09 //y2=4.57
cc_1116 ( N_noxref_4_c_1134_p N_noxref_13_c_3227_n ) capacitor c=9.3994e-19 \
 //x=18.87 //y=4.575 //x2=21.09 //y2=4.57
cc_1117 ( N_noxref_4_M39_noxref_g N_noxref_14_c_3321_n ) capacitor \
 c=0.00973141f //x=19.51 //y=6.02 //x2=20.05 //y2=5.155
cc_1118 ( N_noxref_4_M38_noxref_g N_noxref_14_c_3322_n ) capacitor \
 c=0.00461408f //x=19.07 //y=6.02 //x2=19.292 //y2=5.155
cc_1119 ( N_noxref_4_M39_noxref_g N_noxref_14_c_3322_n ) capacitor \
 c=0.00229208f //x=19.51 //y=6.02 //x2=19.292 //y2=5.155
cc_1120 ( N_noxref_4_c_1146_p N_noxref_14_c_3322_n ) capacitor c=0.00171885f \
 //x=19.435 //y=4.79 //x2=19.292 //y2=5.155
cc_1121 ( N_noxref_4_M38_noxref_g N_noxref_14_c_3325_n ) capacitor \
 c=0.0162284f //x=19.07 //y=6.02 //x2=19.29 //y2=5.38
cc_1122 ( N_noxref_4_M39_noxref_g N_noxref_14_c_3325_n ) capacitor \
 c=0.0179041f //x=19.51 //y=6.02 //x2=19.29 //y2=5.38
cc_1123 ( N_noxref_4_c_1146_p N_noxref_14_c_3325_n ) capacitor c=0.00291477f \
 //x=19.435 //y=4.79 //x2=19.29 //y2=5.38
cc_1124 ( N_noxref_4_c_1006_n N_noxref_16_c_3560_n ) capacitor c=0.00900212f \
 //x=3.585 //y=1.125 //x2=5.8 //y2=0
cc_1125 ( N_noxref_4_c_1018_n N_noxref_16_c_3560_n ) capacitor c=0.00712383f \
 //x=3.985 //y=1.665 //x2=5.8 //y2=0
cc_1126 ( N_noxref_4_c_1034_n N_noxref_16_c_3560_n ) capacitor c=5.12473e-19 \
 //x=4.07 //y=3.865 //x2=5.8 //y2=0
cc_1127 ( N_noxref_4_M2_noxref_d N_noxref_16_c_3560_n ) capacitor \
 c=2.94508e-19 //x=3.395 //y=0.915 //x2=5.8 //y2=0
cc_1128 ( N_noxref_4_c_1344_p N_noxref_16_c_3647_n ) capacitor c=3.97665e-19 \
 //x=5.62 //y=0.875 //x2=5.885 //y2=0.835
cc_1129 ( N_noxref_4_c_1373_p N_noxref_16_c_3647_n ) capacitor c=0.00864609f \
 //x=5.995 //y=0.72 //x2=5.885 //y2=0.835
cc_1130 ( N_noxref_4_c_1346_p N_noxref_16_c_3647_n ) capacitor c=4.45447e-19 \
 //x=6.15 //y=0.875 //x2=5.885 //y2=0.835
cc_1131 ( N_noxref_4_c_1176_p N_noxref_16_c_3650_n ) capacitor c=3.97665e-19 \
 //x=18.57 //y=0.875 //x2=18.835 //y2=0.835
cc_1132 ( N_noxref_4_c_1376_p N_noxref_16_c_3650_n ) capacitor c=0.00864609f \
 //x=18.945 //y=0.72 //x2=18.835 //y2=0.835
cc_1133 ( N_noxref_4_c_1178_p N_noxref_16_c_3650_n ) capacitor c=4.45447e-19 \
 //x=19.1 //y=0.875 //x2=18.835 //y2=0.835
cc_1134 ( N_noxref_4_c_1006_n N_noxref_16_c_3653_n ) capacitor c=0.00543195f \
 //x=3.585 //y=1.125 //x2=5.885 //y2=0.965
cc_1135 ( N_noxref_4_c_1039_n N_noxref_16_c_3653_n ) capacitor c=0.00849484f \
 //x=5.92 //y=2.195 //x2=5.885 //y2=0.965
cc_1136 ( N_noxref_4_c_1044_n N_noxref_16_c_3653_n ) capacitor c=5.53942e-19 \
 //x=5.92 //y=3.86 //x2=5.885 //y2=0.965
cc_1137 ( N_noxref_4_c_1320_p N_noxref_16_c_3653_n ) capacitor c=2.22861e-19 \
 //x=5.92 //y=2.08 //x2=5.885 //y2=0.965
cc_1138 ( N_noxref_4_c_1344_p N_noxref_16_c_3653_n ) capacitor c=0.00156339f \
 //x=5.62 //y=0.875 //x2=5.885 //y2=0.965
cc_1139 ( N_noxref_4_c_1345_p N_noxref_16_c_3653_n ) capacitor c=0.00352472f \
 //x=5.62 //y=1.22 //x2=5.885 //y2=0.965
cc_1140 ( N_noxref_4_c_1347_p N_noxref_16_c_3653_n ) capacitor c=4.63388e-19 \
 //x=5.62 //y=1.53 //x2=5.885 //y2=0.965
cc_1141 ( N_noxref_4_c_1373_p N_noxref_16_c_3653_n ) capacitor c=9.36995e-19 \
 //x=5.995 //y=0.72 //x2=5.885 //y2=0.965
cc_1142 ( N_noxref_4_c_1386_p N_noxref_16_c_3653_n ) capacitor c=5.96388e-19 \
 //x=5.995 //y=1.375 //x2=5.885 //y2=0.965
cc_1143 ( N_noxref_4_c_1346_p N_noxref_16_c_3653_n ) capacitor c=0.0017438f \
 //x=6.15 //y=0.875 //x2=5.885 //y2=0.965
cc_1144 ( N_noxref_4_c_1348_p N_noxref_16_c_3653_n ) capacitor c=0.00276804f \
 //x=6.15 //y=1.22 //x2=5.885 //y2=0.965
cc_1145 ( N_noxref_4_c_1136_p N_noxref_16_c_3664_n ) capacitor c=0.00772254f \
 //x=18.87 //y=2.195 //x2=18.835 //y2=0.965
cc_1146 ( N_noxref_4_c_1141_p N_noxref_16_c_3664_n ) capacitor c=6.67349e-19 \
 //x=18.87 //y=3.86 //x2=18.835 //y2=0.965
cc_1147 ( N_noxref_4_c_1138_p N_noxref_16_c_3664_n ) capacitor c=2.22861e-19 \
 //x=18.87 //y=2.08 //x2=18.835 //y2=0.965
cc_1148 ( N_noxref_4_c_1176_p N_noxref_16_c_3664_n ) capacitor c=0.00156339f \
 //x=18.57 //y=0.875 //x2=18.835 //y2=0.965
cc_1149 ( N_noxref_4_c_1177_p N_noxref_16_c_3664_n ) capacitor c=0.00352472f \
 //x=18.57 //y=1.22 //x2=18.835 //y2=0.965
cc_1150 ( N_noxref_4_c_1179_p N_noxref_16_c_3664_n ) capacitor c=4.40631e-19 \
 //x=18.57 //y=1.53 //x2=18.835 //y2=0.965
cc_1151 ( N_noxref_4_c_1376_p N_noxref_16_c_3664_n ) capacitor c=9.36995e-19 \
 //x=18.945 //y=0.72 //x2=18.835 //y2=0.965
cc_1152 ( N_noxref_4_c_1396_p N_noxref_16_c_3664_n ) capacitor c=5.96388e-19 \
 //x=18.945 //y=1.375 //x2=18.835 //y2=0.965
cc_1153 ( N_noxref_4_c_1178_p N_noxref_16_c_3664_n ) capacitor c=0.0017438f \
 //x=19.1 //y=0.875 //x2=18.835 //y2=0.965
cc_1154 ( N_noxref_4_c_1180_p N_noxref_16_c_3664_n ) capacitor c=0.00276804f \
 //x=19.1 //y=1.22 //x2=18.835 //y2=0.965
cc_1155 ( N_noxref_4_c_1018_n N_noxref_16_c_3578_n ) capacitor c=6.86937e-19 \
 //x=3.985 //y=1.665 //x2=4.64 //y2=0
cc_1156 ( N_noxref_4_c_1344_p N_noxref_16_c_3579_n ) capacitor c=0.00674939f \
 //x=5.62 //y=0.875 //x2=9.45 //y2=0
cc_1157 ( N_noxref_4_c_1176_p N_noxref_16_c_3676_n ) capacitor c=0.00674939f \
 //x=18.57 //y=0.875 //x2=22.4 //y2=0
cc_1158 ( N_noxref_4_c_1013_n N_noxref_16_c_3582_n ) capacitor c=0.0045138f \
 //x=3.585 //y=1.58 //x2=4.81 //y2=0
cc_1159 ( N_noxref_4_c_1018_n N_noxref_16_c_3582_n ) capacitor c=0.0349977f \
 //x=3.985 //y=1.665 //x2=4.81 //y2=0
cc_1160 ( N_noxref_4_c_1039_n N_noxref_16_c_3582_n ) capacitor c=0.00407472f \
 //x=5.92 //y=2.195 //x2=4.81 //y2=0
cc_1161 ( N_noxref_4_c_1040_n N_noxref_16_c_3582_n ) capacitor c=0.0118341f \
 //x=5.92 //y=3.54 //x2=4.81 //y2=0
cc_1162 ( N_noxref_4_c_1320_p N_noxref_16_c_3582_n ) capacitor c=0.00394651f \
 //x=5.92 //y=2.08 //x2=4.81 //y2=0
cc_1163 ( N_noxref_4_c_1347_p N_noxref_16_c_3582_n ) capacitor c=0.00170145f \
 //x=5.62 //y=1.53 //x2=4.81 //y2=0
cc_1164 ( N_noxref_4_c_1321_p N_noxref_16_c_3582_n ) capacitor c=0.0103608f \
 //x=5.62 //y=1.915 //x2=4.81 //y2=0
cc_1165 ( N_noxref_4_c_1136_p N_noxref_16_c_3684_n ) capacitor c=0.00369246f \
 //x=18.87 //y=2.195 //x2=17.76 //y2=0
cc_1166 ( N_noxref_4_c_1133_p N_noxref_16_c_3684_n ) capacitor c=0.0108616f \
 //x=18.87 //y=3.54 //x2=17.76 //y2=0
cc_1167 ( N_noxref_4_c_1144_p N_noxref_16_c_3684_n ) capacitor c=0.00307714f \
 //x=17.24 //y=3.69 //x2=17.76 //y2=0
cc_1168 ( N_noxref_4_c_1138_p N_noxref_16_c_3684_n ) capacitor c=0.00379567f \
 //x=18.87 //y=2.08 //x2=17.76 //y2=0
cc_1169 ( N_noxref_4_c_1179_p N_noxref_16_c_3684_n ) capacitor c=0.00170145f \
 //x=18.57 //y=1.53 //x2=17.76 //y2=0
cc_1170 ( N_noxref_4_c_1139_p N_noxref_16_c_3684_n ) capacitor c=0.0102191f \
 //x=18.57 //y=1.915 //x2=17.76 //y2=0
cc_1171 ( N_noxref_4_c_1039_n N_noxref_16_M3_noxref_d ) capacitor c=4.4417e-19 \
 //x=5.92 //y=2.195 //x2=5.695 //y2=0.875
cc_1172 ( N_noxref_4_c_1344_p N_noxref_16_M3_noxref_d ) capacitor \
 c=0.00184354f //x=5.62 //y=0.875 //x2=5.695 //y2=0.875
cc_1173 ( N_noxref_4_c_1345_p N_noxref_16_M3_noxref_d ) capacitor \
 c=0.00210798f //x=5.62 //y=1.22 //x2=5.695 //y2=0.875
cc_1174 ( N_noxref_4_c_1373_p N_noxref_16_M3_noxref_d ) capacitor \
 c=0.00474029f //x=5.995 //y=0.72 //x2=5.695 //y2=0.875
cc_1175 ( N_noxref_4_c_1386_p N_noxref_16_M3_noxref_d ) capacitor \
 c=0.00166857f //x=5.995 //y=1.375 //x2=5.695 //y2=0.875
cc_1176 ( N_noxref_4_c_1346_p N_noxref_16_M3_noxref_d ) capacitor \
 c=0.00230174f //x=6.15 //y=0.875 //x2=5.695 //y2=0.875
cc_1177 ( N_noxref_4_c_1348_p N_noxref_16_M3_noxref_d ) capacitor \
 c=0.00210798f //x=6.15 //y=1.22 //x2=5.695 //y2=0.875
cc_1178 ( N_noxref_4_c_1136_p N_noxref_16_M11_noxref_d ) capacitor \
 c=4.4417e-19 //x=18.87 //y=2.195 //x2=18.645 //y2=0.875
cc_1179 ( N_noxref_4_c_1176_p N_noxref_16_M11_noxref_d ) capacitor \
 c=0.00184354f //x=18.57 //y=0.875 //x2=18.645 //y2=0.875
cc_1180 ( N_noxref_4_c_1177_p N_noxref_16_M11_noxref_d ) capacitor \
 c=0.00210798f //x=18.57 //y=1.22 //x2=18.645 //y2=0.875
cc_1181 ( N_noxref_4_c_1376_p N_noxref_16_M11_noxref_d ) capacitor \
 c=0.00474029f //x=18.945 //y=0.72 //x2=18.645 //y2=0.875
cc_1182 ( N_noxref_4_c_1396_p N_noxref_16_M11_noxref_d ) capacitor \
 c=0.00166857f //x=18.945 //y=1.375 //x2=18.645 //y2=0.875
cc_1183 ( N_noxref_4_c_1178_p N_noxref_16_M11_noxref_d ) capacitor \
 c=0.00230174f //x=19.1 //y=0.875 //x2=18.645 //y2=0.875
cc_1184 ( N_noxref_4_c_1180_p N_noxref_16_M11_noxref_d ) capacitor \
 c=0.00210798f //x=19.1 //y=1.22 //x2=18.645 //y2=0.875
cc_1185 ( N_noxref_4_c_1321_p N_noxref_19_c_4180_n ) capacitor c=0.00262672f \
 //x=5.62 //y=1.915 //x2=5.4 //y2=1.505
cc_1186 ( N_noxref_4_c_1039_n N_noxref_19_c_4181_n ) capacitor c=0.00428451f \
 //x=5.92 //y=2.195 //x2=6.285 //y2=1.59
cc_1187 ( N_noxref_4_c_1044_n N_noxref_19_c_4181_n ) capacitor c=0.00144481f \
 //x=5.92 //y=3.86 //x2=6.285 //y2=1.59
cc_1188 ( N_noxref_4_c_1320_p N_noxref_19_c_4181_n ) capacitor c=0.0104666f \
 //x=5.92 //y=2.08 //x2=6.285 //y2=1.59
cc_1189 ( N_noxref_4_c_1347_p N_noxref_19_c_4181_n ) capacitor c=0.00705077f \
 //x=5.62 //y=1.53 //x2=6.285 //y2=1.59
cc_1190 ( N_noxref_4_c_1321_p N_noxref_19_c_4181_n ) capacitor c=0.0219597f \
 //x=5.62 //y=1.915 //x2=6.285 //y2=1.59
cc_1191 ( N_noxref_4_c_1386_p N_noxref_19_c_4181_n ) capacitor c=0.00588627f \
 //x=5.995 //y=1.375 //x2=6.285 //y2=1.59
cc_1192 ( N_noxref_4_c_1348_p N_noxref_19_c_4181_n ) capacitor c=0.00698822f \
 //x=6.15 //y=1.22 //x2=6.285 //y2=1.59
cc_1193 ( N_noxref_4_c_1344_p N_noxref_19_M3_noxref_s ) capacitor c=0.0295256f \
 //x=5.62 //y=0.875 //x2=5.265 //y2=0.375
cc_1194 ( N_noxref_4_c_1347_p N_noxref_19_M3_noxref_s ) capacitor \
 c=7.99997e-19 //x=5.62 //y=1.53 //x2=5.265 //y2=0.375
cc_1195 ( N_noxref_4_c_1321_p N_noxref_19_M3_noxref_s ) capacitor \
 c=0.00122123f //x=5.62 //y=1.915 //x2=5.265 //y2=0.375
cc_1196 ( N_noxref_4_c_1346_p N_noxref_19_M3_noxref_s ) capacitor c=0.0125924f \
 //x=6.15 //y=0.875 //x2=5.265 //y2=0.375
cc_1197 ( N_noxref_4_c_1139_p N_noxref_22_c_4365_n ) capacitor c=0.00262672f \
 //x=18.57 //y=1.915 //x2=18.35 //y2=1.505
cc_1198 ( N_noxref_4_c_1136_p N_noxref_22_c_4366_n ) capacitor c=0.00428451f \
 //x=18.87 //y=2.195 //x2=19.235 //y2=1.59
cc_1199 ( N_noxref_4_c_1141_p N_noxref_22_c_4366_n ) capacitor c=0.00205403f \
 //x=18.87 //y=3.86 //x2=19.235 //y2=1.59
cc_1200 ( N_noxref_4_c_1138_p N_noxref_22_c_4366_n ) capacitor c=0.0104666f \
 //x=18.87 //y=2.08 //x2=19.235 //y2=1.59
cc_1201 ( N_noxref_4_c_1179_p N_noxref_22_c_4366_n ) capacitor c=0.00705077f \
 //x=18.57 //y=1.53 //x2=19.235 //y2=1.59
cc_1202 ( N_noxref_4_c_1139_p N_noxref_22_c_4366_n ) capacitor c=0.020708f \
 //x=18.57 //y=1.915 //x2=19.235 //y2=1.59
cc_1203 ( N_noxref_4_c_1396_p N_noxref_22_c_4366_n ) capacitor c=0.00588627f \
 //x=18.945 //y=1.375 //x2=19.235 //y2=1.59
cc_1204 ( N_noxref_4_c_1180_p N_noxref_22_c_4366_n ) capacitor c=0.00698822f \
 //x=19.1 //y=1.22 //x2=19.235 //y2=1.59
cc_1205 ( N_noxref_4_c_1176_p N_noxref_22_M11_noxref_s ) capacitor \
 c=0.0295256f //x=18.57 //y=0.875 //x2=18.215 //y2=0.375
cc_1206 ( N_noxref_4_c_1179_p N_noxref_22_M11_noxref_s ) capacitor \
 c=7.99997e-19 //x=18.57 //y=1.53 //x2=18.215 //y2=0.375
cc_1207 ( N_noxref_4_c_1139_p N_noxref_22_M11_noxref_s ) capacitor \
 c=0.00122123f //x=18.57 //y=1.915 //x2=18.215 //y2=0.375
cc_1208 ( N_noxref_4_c_1178_p N_noxref_22_M11_noxref_s ) capacitor \
 c=0.0125924f //x=19.1 //y=0.875 //x2=18.215 //y2=0.375
cc_1209 ( N_noxref_5_c_1470_n N_noxref_6_c_1865_n ) capacitor c=0.0165827f \
 //x=16.125 //y=2.135 //x2=11.47 //y2=3.91
cc_1210 ( N_noxref_5_M36_noxref_g N_noxref_6_c_2004_n ) capacitor c=0.0103546f \
 //x=16.02 //y=6.02 //x2=16.125 //y2=5.155
cc_1211 ( N_noxref_5_M36_noxref_g N_noxref_6_c_2111_n ) capacitor \
 c=0.00226521f //x=16.02 //y=6.02 //x2=16.24 //y2=5.38
cc_1212 ( N_noxref_5_M37_noxref_g N_noxref_6_c_2111_n ) capacitor \
 c=0.00381703f //x=16.46 //y=6.02 //x2=16.24 //y2=5.38
cc_1213 ( N_noxref_5_c_1529_n N_noxref_6_c_2113_n ) capacitor c=2.13846e-19 \
 //x=16.28 //y=2.285 //x2=16.935 //y2=5.155
cc_1214 ( N_noxref_5_c_1515_n N_noxref_6_c_2113_n ) capacitor c=0.0023499f \
 //x=16.28 //y=4.57 //x2=16.935 //y2=5.155
cc_1215 ( N_noxref_5_c_1545_n N_noxref_6_c_2113_n ) capacitor c=0.00130631f \
 //x=16.28 //y=4.7 //x2=16.935 //y2=5.155
cc_1216 ( N_noxref_5_M37_noxref_g N_noxref_6_c_2113_n ) capacitor c=0.0112553f \
 //x=16.46 //y=6.02 //x2=16.935 //y2=5.155
cc_1217 ( N_noxref_5_c_1529_n N_noxref_6_c_2117_n ) capacitor c=5.60322e-19 \
 //x=16.28 //y=2.285 //x2=16.535 //y2=1.125
cc_1218 ( N_noxref_5_c_1541_n N_noxref_6_c_2117_n ) capacitor c=4.13793e-19 \
 //x=16.445 //y=2.135 //x2=16.535 //y2=1.125
cc_1219 ( N_noxref_5_c_1551_n N_noxref_6_c_2117_n ) capacitor c=4.64015e-19 \
 //x=16.27 //y=0.915 //x2=16.535 //y2=1.125
cc_1220 ( N_noxref_5_c_1552_n N_noxref_6_c_2117_n ) capacitor c=0.0026012f \
 //x=16.27 //y=1.26 //x2=16.535 //y2=1.125
cc_1221 ( N_noxref_5_c_1634_p N_noxref_6_c_2117_n ) capacitor c=5.29969e-19 \
 //x=16.645 //y=0.76 //x2=16.535 //y2=1.125
cc_1222 ( N_noxref_5_c_1635_p N_noxref_6_c_2117_n ) capacitor c=4.32061e-19 \
 //x=16.645 //y=1.415 //x2=16.535 //y2=1.125
cc_1223 ( N_noxref_5_c_1636_p N_noxref_6_c_2117_n ) capacitor c=5.24634e-19 \
 //x=16.8 //y=0.915 //x2=16.535 //y2=1.125
cc_1224 ( N_noxref_5_c_1637_p N_noxref_6_c_2117_n ) capacitor c=0.00307978f \
 //x=16.8 //y=1.26 //x2=16.535 //y2=1.125
cc_1225 ( N_noxref_5_c_1552_n N_noxref_6_c_1933_n ) capacitor c=0.00127432f \
 //x=16.27 //y=1.26 //x2=16.535 //y2=1.58
cc_1226 ( N_noxref_5_c_1553_n N_noxref_6_c_1933_n ) capacitor c=0.00441386f \
 //x=16.27 //y=1.57 //x2=16.535 //y2=1.58
cc_1227 ( N_noxref_5_c_1635_p N_noxref_6_c_1933_n ) capacitor c=0.00942306f \
 //x=16.645 //y=1.415 //x2=16.535 //y2=1.58
cc_1228 ( N_noxref_5_c_1637_p N_noxref_6_c_1933_n ) capacitor c=0.00363411f \
 //x=16.8 //y=1.26 //x2=16.535 //y2=1.58
cc_1229 ( N_noxref_5_c_1556_n N_noxref_6_c_1933_n ) capacitor c=0.00362297f \
 //x=16.28 //y=1.915 //x2=16.535 //y2=1.58
cc_1230 ( N_noxref_5_c_1635_p N_noxref_6_c_2130_n ) capacitor c=0.00194716f \
 //x=16.645 //y=1.415 //x2=16.935 //y2=1.665
cc_1231 ( N_noxref_5_c_1637_p N_noxref_6_c_2130_n ) capacitor c=0.00323576f \
 //x=16.8 //y=1.26 //x2=16.935 //y2=1.665
cc_1232 ( N_noxref_5_c_1591_n N_noxref_6_c_1934_n ) capacitor c=0.021696f \
 //x=19.775 //y=2.175 //x2=16.62 //y2=1.665
cc_1233 ( N_noxref_5_c_1529_n N_noxref_6_c_2005_n ) capacitor c=0.0171385f \
 //x=16.28 //y=2.285 //x2=17.02 //y2=3.915
cc_1234 ( N_noxref_5_c_1515_n N_noxref_6_c_2005_n ) capacitor c=0.0718816f \
 //x=16.28 //y=4.57 //x2=17.02 //y2=3.915
cc_1235 ( N_noxref_5_c_1571_n N_noxref_6_c_2005_n ) capacitor c=0.00223984f \
 //x=19.98 //y=4.585 //x2=17.02 //y2=3.915
cc_1236 ( N_noxref_5_c_1541_n N_noxref_6_c_2005_n ) capacitor c=0.00372846f \
 //x=16.445 //y=2.135 //x2=17.02 //y2=3.915
cc_1237 ( N_noxref_5_c_1591_n N_noxref_6_c_2005_n ) capacitor c=0.0326829f \
 //x=19.775 //y=2.175 //x2=17.02 //y2=3.915
cc_1238 ( N_noxref_5_c_1542_n N_noxref_6_c_2005_n ) capacitor c=0.00115564f \
 //x=16.28 //y=2.08 //x2=17.02 //y2=3.915
cc_1239 ( N_noxref_5_c_1554_n N_noxref_6_c_2005_n ) capacitor c=3.96703e-19 \
 //x=16.28 //y=2.08 //x2=17.02 //y2=3.915
cc_1240 ( N_noxref_5_c_1556_n N_noxref_6_c_2005_n ) capacitor c=0.00282067f \
 //x=16.28 //y=1.915 //x2=17.02 //y2=3.915
cc_1241 ( N_noxref_5_c_1515_n N_noxref_6_c_2068_n ) capacitor c=0.0172847f \
 //x=16.28 //y=4.57 //x2=17.02 //y2=4.235
cc_1242 ( N_noxref_5_c_1515_n N_noxref_6_c_2006_n ) capacitor c=0.029264f \
 //x=16.28 //y=4.57 //x2=17.02 //y2=5.07
cc_1243 ( N_noxref_5_c_1571_n N_noxref_6_c_2006_n ) capacitor c=8.28074e-19 \
 //x=19.98 //y=4.585 //x2=17.02 //y2=5.07
cc_1244 ( N_noxref_5_c_1545_n N_noxref_6_c_2006_n ) capacitor c=0.00131258f \
 //x=16.28 //y=4.7 //x2=17.02 //y2=5.07
cc_1245 ( N_noxref_5_c_1557_n N_noxref_6_c_2006_n ) capacitor c=0.00739875f \
 //x=16.28 //y=4.7 //x2=17.02 //y2=5.07
cc_1246 ( N_noxref_5_c_1470_n N_noxref_6_c_1880_n ) capacitor c=0.0170024f \
 //x=16.125 //y=2.135 //x2=11.47 //y2=2.08
cc_1247 ( N_noxref_5_c_1529_n N_noxref_6_c_2147_n ) capacitor c=4.49075e-19 \
 //x=16.28 //y=2.285 //x2=16.24 //y2=5.155
cc_1248 ( N_noxref_5_c_1515_n N_noxref_6_c_2147_n ) capacitor c=0.0226552f \
 //x=16.28 //y=4.57 //x2=16.24 //y2=5.155
cc_1249 ( N_noxref_5_c_1545_n N_noxref_6_c_2147_n ) capacitor c=0.00346017f \
 //x=16.28 //y=4.7 //x2=16.24 //y2=5.155
cc_1250 ( N_noxref_5_c_1557_n N_noxref_6_c_2147_n ) capacitor c=0.00203307f \
 //x=16.28 //y=4.7 //x2=16.24 //y2=5.155
cc_1251 ( N_noxref_5_c_1515_n N_noxref_6_c_2151_n ) capacitor c=6.89957e-19 \
 //x=16.28 //y=4.57 //x2=17.02 //y2=4.07
cc_1252 ( N_noxref_5_c_1515_n N_noxref_6_c_1942_n ) capacitor c=0.0280264f \
 //x=16.28 //y=4.57 //x2=16.865 //y2=4.07
cc_1253 ( N_noxref_5_c_1470_n N_noxref_6_c_1942_n ) capacitor c=0.00784859f \
 //x=16.125 //y=2.135 //x2=16.865 //y2=4.07
cc_1254 ( N_noxref_5_c_1457_n N_noxref_6_c_1890_n ) capacitor c=0.0220634f \
 //x=8.14 //y=4.57 //x2=11.635 //y2=4.07
cc_1255 ( N_noxref_5_c_1470_n N_noxref_6_c_1890_n ) capacitor c=0.00100647f \
 //x=16.125 //y=2.135 //x2=11.635 //y2=4.07
cc_1256 ( N_noxref_5_c_1567_n N_noxref_6_c_2097_n ) capacitor c=0.00104012f \
 //x=19.98 //y=2.335 //x2=19.075 //y2=4.085
cc_1257 ( N_noxref_5_c_1571_n N_noxref_6_c_2097_n ) capacitor c=0.0367216f \
 //x=19.98 //y=4.585 //x2=19.075 //y2=4.085
cc_1258 ( N_noxref_5_c_1589_n N_noxref_6_c_2097_n ) capacitor c=0.00368627f \
 //x=19.935 //y=2.175 //x2=19.075 //y2=4.085
cc_1259 ( N_noxref_5_c_1591_n N_noxref_6_c_2097_n ) capacitor c=0.0137044f \
 //x=19.775 //y=2.175 //x2=19.075 //y2=4.085
cc_1260 ( N_noxref_5_c_1515_n N_noxref_6_c_2099_n ) capacitor c=0.00325739f \
 //x=16.28 //y=4.57 //x2=18.73 //y2=4.085
cc_1261 ( N_noxref_5_c_1591_n N_noxref_6_c_2099_n ) capacitor c=0.00905576f \
 //x=19.775 //y=2.175 //x2=18.73 //y2=4.085
cc_1262 ( N_noxref_5_c_1515_n N_noxref_6_c_2162_n ) capacitor c=0.00266858f \
 //x=16.28 //y=4.57 //x2=16.24 //y2=5.38
cc_1263 ( N_noxref_5_c_1545_n N_noxref_6_c_2162_n ) capacitor c=0.00624059f \
 //x=16.28 //y=4.7 //x2=16.24 //y2=5.38
cc_1264 ( N_noxref_5_M36_noxref_g N_noxref_6_c_2162_n ) capacitor c=0.0178885f \
 //x=16.02 //y=6.02 //x2=16.24 //y2=5.38
cc_1265 ( N_noxref_5_M37_noxref_g N_noxref_6_c_2162_n ) capacitor c=0.0188608f \
 //x=16.46 //y=6.02 //x2=16.24 //y2=5.38
cc_1266 ( N_noxref_5_c_1557_n N_noxref_6_c_2162_n ) capacitor c=0.00255197f \
 //x=16.28 //y=4.7 //x2=16.24 //y2=5.38
cc_1267 ( N_noxref_5_c_1551_n N_noxref_6_M10_noxref_d ) capacitor \
 c=0.00137165f //x=16.27 //y=0.915 //x2=16.345 //y2=0.915
cc_1268 ( N_noxref_5_c_1552_n N_noxref_6_M10_noxref_d ) capacitor \
 c=0.00237422f //x=16.27 //y=1.26 //x2=16.345 //y2=0.915
cc_1269 ( N_noxref_5_c_1634_p N_noxref_6_M10_noxref_d ) capacitor c=0.0020782f \
 //x=16.645 //y=0.76 //x2=16.345 //y2=0.915
cc_1270 ( N_noxref_5_c_1635_p N_noxref_6_M10_noxref_d ) capacitor \
 c=0.00356097f //x=16.645 //y=1.415 //x2=16.345 //y2=0.915
cc_1271 ( N_noxref_5_c_1636_p N_noxref_6_M10_noxref_d ) capacitor \
 c=0.00139206f //x=16.8 //y=0.915 //x2=16.345 //y2=0.915
cc_1272 ( N_noxref_5_c_1637_p N_noxref_6_M10_noxref_d ) capacitor \
 c=0.00237422f //x=16.8 //y=1.26 //x2=16.345 //y2=0.915
cc_1273 ( N_noxref_5_M26_noxref_g N_noxref_7_c_2473_n ) capacitor \
 c=0.00749619f //x=7.88 //y=6.02 //x2=8.455 //y2=7.4
cc_1274 ( N_noxref_5_M27_noxref_g N_noxref_7_c_2473_n ) capacitor \
 c=0.00749823f //x=8.32 //y=6.02 //x2=8.455 //y2=7.4
cc_1275 ( N_noxref_5_M36_noxref_g N_noxref_7_c_2641_n ) capacitor \
 c=0.00749619f //x=16.02 //y=6.02 //x2=16.595 //y2=7.4
cc_1276 ( N_noxref_5_M37_noxref_g N_noxref_7_c_2641_n ) capacitor \
 c=0.00749823f //x=16.46 //y=6.02 //x2=16.595 //y2=7.4
cc_1277 ( N_noxref_5_M40_noxref_g N_noxref_7_c_2643_n ) capacitor \
 c=0.00700336f //x=19.95 //y=6.02 //x2=20.525 //y2=7.4
cc_1278 ( N_noxref_5_M41_noxref_g N_noxref_7_c_2643_n ) capacitor \
 c=0.00749619f //x=20.39 //y=6.02 //x2=20.525 //y2=7.4
cc_1279 ( N_noxref_5_c_1481_n N_noxref_7_c_2485_n ) capacitor c=0.00224736f \
 //x=8.14 //y=4.7 //x2=9.62 //y2=7.4
cc_1280 ( N_noxref_5_c_1512_n N_noxref_7_c_2485_n ) capacitor c=2.63786e-19 \
 //x=8.14 //y=4.7 //x2=9.62 //y2=7.4
cc_1281 ( N_noxref_5_c_1545_n N_noxref_7_c_2610_n ) capacitor c=0.00224736f \
 //x=16.28 //y=4.7 //x2=17.76 //y2=7.4
cc_1282 ( N_noxref_5_c_1557_n N_noxref_7_c_2610_n ) capacitor c=2.63786e-19 \
 //x=16.28 //y=4.7 //x2=17.76 //y2=7.4
cc_1283 ( N_noxref_5_M26_noxref_g N_noxref_7_M25_noxref_d ) capacitor \
 c=0.015318f //x=7.88 //y=6.02 //x2=7.515 //y2=5.02
cc_1284 ( N_noxref_5_M27_noxref_g N_noxref_7_M27_noxref_d ) capacitor \
 c=0.0394719f //x=8.32 //y=6.02 //x2=8.395 //y2=5.02
cc_1285 ( N_noxref_5_M36_noxref_g N_noxref_7_M35_noxref_d ) capacitor \
 c=0.015318f //x=16.02 //y=6.02 //x2=15.655 //y2=5.02
cc_1286 ( N_noxref_5_M37_noxref_g N_noxref_7_M37_noxref_d ) capacitor \
 c=0.0394719f //x=16.46 //y=6.02 //x2=16.535 //y2=5.02
cc_1287 ( N_noxref_5_M40_noxref_g N_noxref_7_M39_noxref_d ) capacitor \
 c=0.015318f //x=19.95 //y=6.02 //x2=19.585 //y2=5.02
cc_1288 ( N_noxref_5_M41_noxref_g N_noxref_7_M41_noxref_d ) capacitor \
 c=0.015318f //x=20.39 //y=6.02 //x2=20.465 //y2=5.02
cc_1289 ( N_noxref_5_c_1453_n N_noxref_9_c_2908_n ) capacitor c=0.00171044f \
 //x=8.14 //y=2.285 //x2=8.795 //y2=0.54
cc_1290 ( N_noxref_5_c_1480_n N_noxref_9_c_2908_n ) capacitor c=0.00117306f \
 //x=8.14 //y=2.08 //x2=8.795 //y2=0.54
cc_1291 ( N_noxref_5_c_1491_n N_noxref_9_c_2908_n ) capacitor c=0.0206349f \
 //x=8.13 //y=0.915 //x2=8.795 //y2=0.54
cc_1292 ( N_noxref_5_c_1503_n N_noxref_9_c_2908_n ) capacitor c=0.00825432f \
 //x=8.66 //y=0.915 //x2=8.795 //y2=0.54
cc_1293 ( N_noxref_5_c_1509_n N_noxref_9_c_2908_n ) capacitor c=2.20712e-19 \
 //x=8.14 //y=2.08 //x2=8.795 //y2=0.54
cc_1294 ( N_noxref_5_c_1493_n N_noxref_9_c_2911_n ) capacitor c=0.0071177f \
 //x=8.13 //y=1.26 //x2=7.91 //y2=0.995
cc_1295 ( N_noxref_5_c_1453_n N_noxref_9_M5_noxref_s ) capacitor c=4.5489e-19 \
 //x=8.14 //y=2.285 //x2=7.775 //y2=0.375
cc_1296 ( N_noxref_5_c_1491_n N_noxref_9_M5_noxref_s ) capacitor c=0.0071177f \
 //x=8.13 //y=0.915 //x2=7.775 //y2=0.375
cc_1297 ( N_noxref_5_c_1496_n N_noxref_9_M5_noxref_s ) capacitor c=0.0071177f \
 //x=8.13 //y=1.57 //x2=7.775 //y2=0.375
cc_1298 ( N_noxref_5_c_1503_n N_noxref_9_M5_noxref_s ) capacitor c=0.015333f \
 //x=8.66 //y=0.915 //x2=7.775 //y2=0.375
cc_1299 ( N_noxref_5_c_1505_n N_noxref_9_M5_noxref_s ) capacitor c=0.00248746f \
 //x=8.66 //y=1.26 //x2=7.775 //y2=0.375
cc_1300 ( N_noxref_5_c_1453_n N_noxref_10_c_2975_n ) capacitor c=0.00720438f \
 //x=8.14 //y=2.285 //x2=7.03 //y2=2.195
cc_1301 ( N_noxref_5_c_1467_n N_noxref_10_c_2975_n ) capacitor c=0.00526813f \
 //x=8.145 //y=2.125 //x2=7.03 //y2=2.195
cc_1302 ( N_noxref_5_c_1480_n N_noxref_10_c_2975_n ) capacitor c=6.92676e-19 \
 //x=8.14 //y=2.08 //x2=7.03 //y2=2.195
cc_1303 ( N_noxref_5_c_1453_n N_noxref_10_c_2976_n ) capacitor c=0.0020306f \
 //x=8.14 //y=2.285 //x2=7.03 //y2=4.585
cc_1304 ( N_noxref_5_c_1457_n N_noxref_10_c_2976_n ) capacitor c=0.0680936f \
 //x=8.14 //y=4.57 //x2=7.03 //y2=4.585
cc_1305 ( N_noxref_5_c_1467_n N_noxref_10_c_2976_n ) capacitor c=0.00216715f \
 //x=8.145 //y=2.125 //x2=7.03 //y2=4.585
cc_1306 ( N_noxref_5_c_1481_n N_noxref_10_c_2976_n ) capacitor c=7.51101e-19 \
 //x=8.14 //y=4.7 //x2=7.03 //y2=4.585
cc_1307 ( N_noxref_5_c_1512_n N_noxref_10_c_2976_n ) capacitor c=0.00124604f \
 //x=8.14 //y=4.7 //x2=7.03 //y2=4.585
cc_1308 ( N_noxref_5_c_1453_n N_noxref_10_c_3008_n ) capacitor c=9.53526e-19 \
 //x=8.14 //y=2.285 //x2=7.03 //y2=2.08
cc_1309 ( N_noxref_5_c_1480_n N_noxref_10_c_3008_n ) capacitor c=0.00129119f \
 //x=8.14 //y=2.08 //x2=7.03 //y2=2.08
cc_1310 ( N_noxref_5_c_1509_n N_noxref_10_c_3008_n ) capacitor c=0.00155537f \
 //x=8.14 //y=2.08 //x2=7.03 //y2=2.08
cc_1311 ( N_noxref_5_c_1457_n N_noxref_10_c_2982_n ) capacitor c=9.52396e-19 \
 //x=8.14 //y=4.57 //x2=7.03 //y2=4.7
cc_1312 ( N_noxref_5_c_1481_n N_noxref_10_c_2982_n ) capacitor c=0.00113985f \
 //x=8.14 //y=4.7 //x2=7.03 //y2=4.7
cc_1313 ( N_noxref_5_c_1512_n N_noxref_10_c_2982_n ) capacitor c=0.00187046f \
 //x=8.14 //y=4.7 //x2=7.03 //y2=4.7
cc_1314 ( N_noxref_5_M26_noxref_g N_noxref_10_M24_noxref_g ) capacitor \
 c=0.0101598f //x=7.88 //y=6.02 //x2=7 //y2=6.02
cc_1315 ( N_noxref_5_M26_noxref_g N_noxref_10_M25_noxref_g ) capacitor \
 c=0.0607518f //x=7.88 //y=6.02 //x2=7.44 //y2=6.02
cc_1316 ( N_noxref_5_M27_noxref_g N_noxref_10_M25_noxref_g ) capacitor \
 c=0.0101598f //x=8.32 //y=6.02 //x2=7.44 //y2=6.02
cc_1317 ( N_noxref_5_c_1491_n N_noxref_10_c_3024_n ) capacitor c=0.00456962f \
 //x=8.13 //y=0.915 //x2=7.12 //y2=0.91
cc_1318 ( N_noxref_5_c_1493_n N_noxref_10_c_3025_n ) capacitor c=0.00438372f \
 //x=8.13 //y=1.26 //x2=7.12 //y2=1.22
cc_1319 ( N_noxref_5_c_1496_n N_noxref_10_c_3026_n ) capacitor c=0.00438372f \
 //x=8.13 //y=1.57 //x2=7.12 //y2=1.45
cc_1320 ( N_noxref_5_c_1453_n N_noxref_10_c_3027_n ) capacitor c=0.00135583f \
 //x=8.14 //y=2.285 //x2=7.12 //y2=1.915
cc_1321 ( N_noxref_5_c_1480_n N_noxref_10_c_3027_n ) capacitor c=0.00210314f \
 //x=8.14 //y=2.08 //x2=7.12 //y2=1.915
cc_1322 ( N_noxref_5_c_1509_n N_noxref_10_c_3027_n ) capacitor c=0.00831559f \
 //x=8.14 //y=2.08 //x2=7.12 //y2=1.915
cc_1323 ( N_noxref_5_c_1510_n N_noxref_10_c_3027_n ) capacitor c=0.00438372f \
 //x=8.14 //y=1.915 //x2=7.12 //y2=1.915
cc_1324 ( N_noxref_5_c_1512_n N_noxref_10_c_2990_n ) capacitor c=0.0616777f \
 //x=8.14 //y=4.7 //x2=7.365 //y2=4.79
cc_1325 ( N_noxref_5_c_1457_n N_noxref_10_c_2992_n ) capacitor c=8.42568e-19 \
 //x=8.14 //y=4.57 //x2=7.03 //y2=4.7
cc_1326 ( N_noxref_5_c_1481_n N_noxref_10_c_2992_n ) capacitor c=0.00129812f \
 //x=8.14 //y=4.7 //x2=7.03 //y2=4.7
cc_1327 ( N_noxref_5_c_1512_n N_noxref_10_c_2992_n ) capacitor c=0.00487508f \
 //x=8.14 //y=4.7 //x2=7.03 //y2=4.7
cc_1328 ( N_noxref_5_c_1470_n N_noxref_11_c_3093_n ) capacitor c=0.00519491f \
 //x=16.125 //y=2.135 //x2=15.965 //y2=0.995
cc_1329 ( N_noxref_5_c_1529_n N_noxref_11_c_3109_n ) capacitor c=0.00171044f \
 //x=16.28 //y=2.285 //x2=16.935 //y2=0.54
cc_1330 ( N_noxref_5_c_1542_n N_noxref_11_c_3109_n ) capacitor c=0.00117306f \
 //x=16.28 //y=2.08 //x2=16.935 //y2=0.54
cc_1331 ( N_noxref_5_c_1551_n N_noxref_11_c_3109_n ) capacitor c=0.0206349f \
 //x=16.27 //y=0.915 //x2=16.935 //y2=0.54
cc_1332 ( N_noxref_5_c_1636_p N_noxref_11_c_3109_n ) capacitor c=0.00825432f \
 //x=16.8 //y=0.915 //x2=16.935 //y2=0.54
cc_1333 ( N_noxref_5_c_1554_n N_noxref_11_c_3109_n ) capacitor c=2.20712e-19 \
 //x=16.28 //y=2.08 //x2=16.935 //y2=0.54
cc_1334 ( N_noxref_5_c_1552_n N_noxref_11_c_3114_n ) capacitor c=0.0071177f \
 //x=16.27 //y=1.26 //x2=16.05 //y2=0.995
cc_1335 ( N_noxref_5_c_1470_n N_noxref_11_M9_noxref_d ) capacitor \
 c=0.00716163f //x=16.125 //y=2.135 //x2=14.81 //y2=0.91
cc_1336 ( N_noxref_5_c_1529_n N_noxref_11_M10_noxref_s ) capacitor \
 c=4.5489e-19 //x=16.28 //y=2.285 //x2=15.915 //y2=0.375
cc_1337 ( N_noxref_5_c_1470_n N_noxref_11_M10_noxref_s ) capacitor \
 c=0.00417477f //x=16.125 //y=2.135 //x2=15.915 //y2=0.375
cc_1338 ( N_noxref_5_c_1551_n N_noxref_11_M10_noxref_s ) capacitor \
 c=0.0071177f //x=16.27 //y=0.915 //x2=15.915 //y2=0.375
cc_1339 ( N_noxref_5_c_1553_n N_noxref_11_M10_noxref_s ) capacitor \
 c=0.0071177f //x=16.27 //y=1.57 //x2=15.915 //y2=0.375
cc_1340 ( N_noxref_5_c_1636_p N_noxref_11_M10_noxref_s ) capacitor c=0.015333f \
 //x=16.8 //y=0.915 //x2=15.915 //y2=0.375
cc_1341 ( N_noxref_5_c_1637_p N_noxref_11_M10_noxref_s ) capacitor \
 c=0.00248746f //x=16.8 //y=1.26 //x2=15.915 //y2=0.375
cc_1342 ( N_noxref_5_c_1612_n N_noxref_12_c_3161_n ) capacitor c=0.00123426f \
 //x=20.07 //y=0.91 //x2=20.775 //y2=0.995
cc_1343 ( N_noxref_5_c_1613_n N_noxref_12_c_3161_n ) capacitor c=0.0129288f \
 //x=20.07 //y=1.22 //x2=20.775 //y2=0.995
cc_1344 ( N_noxref_5_c_1614_n N_noxref_12_c_3161_n ) capacitor c=0.00132209f \
 //x=20.07 //y=1.45 //x2=20.775 //y2=0.995
cc_1345 ( N_noxref_5_c_1567_n N_noxref_12_M12_noxref_d ) capacitor \
 c=0.00745753f //x=19.98 //y=2.335 //x2=19.62 //y2=0.91
cc_1346 ( N_noxref_5_c_1589_n N_noxref_12_M12_noxref_d ) capacitor \
 c=0.00198091f //x=19.935 //y=2.175 //x2=19.62 //y2=0.91
cc_1347 ( N_noxref_5_c_1591_n N_noxref_12_M12_noxref_d ) capacitor \
 c=0.00369679f //x=19.775 //y=2.175 //x2=19.62 //y2=0.91
cc_1348 ( N_noxref_5_c_1597_n N_noxref_12_M12_noxref_d ) capacitor \
 c=2.2052e-19 //x=19.98 //y=2.08 //x2=19.62 //y2=0.91
cc_1349 ( N_noxref_5_c_1607_n N_noxref_12_M12_noxref_d ) capacitor \
 c=0.00253592f //x=19.545 //y=0.91 //x2=19.62 //y2=0.91
cc_1350 ( N_noxref_5_c_1610_n N_noxref_12_M12_noxref_d ) capacitor \
 c=0.00604087f //x=19.545 //y=1.22 //x2=19.62 //y2=0.91
cc_1351 ( N_noxref_5_c_1764_p N_noxref_12_M12_noxref_d ) capacitor c=0.002686f \
 //x=19.915 //y=0.755 //x2=19.62 //y2=0.91
cc_1352 ( N_noxref_5_c_1765_p N_noxref_12_M12_noxref_d ) capacitor \
 c=0.00251995f //x=19.915 //y=1.375 //x2=19.62 //y2=0.91
cc_1353 ( N_noxref_5_c_1612_n N_noxref_12_M12_noxref_d ) capacitor \
 c=0.00314523f //x=20.07 //y=0.91 //x2=19.62 //y2=0.91
cc_1354 ( N_noxref_5_c_1613_n N_noxref_12_M12_noxref_d ) capacitor \
 c=0.00168289f //x=20.07 //y=1.22 //x2=19.62 //y2=0.91
cc_1355 ( N_noxref_5_c_1614_n N_noxref_12_M12_noxref_d ) capacitor \
 c=0.00111165f //x=20.07 //y=1.45 //x2=19.62 //y2=0.91
cc_1356 ( N_noxref_5_c_1612_n N_noxref_12_M13_noxref_s ) capacitor \
 c=7.21316e-19 //x=20.07 //y=0.91 //x2=20.725 //y2=0.375
cc_1357 ( N_noxref_5_c_1613_n N_noxref_12_M13_noxref_s ) capacitor \
 c=0.00365271f //x=20.07 //y=1.22 //x2=20.725 //y2=0.375
cc_1358 ( N_noxref_5_c_1615_n N_noxref_12_M13_noxref_s ) capacitor \
 c=9.86711e-19 //x=20.07 //y=1.915 //x2=20.725 //y2=0.375
cc_1359 ( N_noxref_5_c_1567_n N_noxref_13_c_3229_n ) capacitor c=0.00770291f \
 //x=19.98 //y=2.335 //x2=21.09 //y2=2.195
cc_1360 ( N_noxref_5_c_1589_n N_noxref_13_c_3229_n ) capacitor c=0.00407348f \
 //x=19.935 //y=2.175 //x2=21.09 //y2=2.195
cc_1361 ( N_noxref_5_c_1597_n N_noxref_13_c_3229_n ) capacitor c=5.39999e-19 \
 //x=19.98 //y=2.08 //x2=21.09 //y2=2.195
cc_1362 ( N_noxref_5_c_1615_n N_noxref_13_c_3229_n ) capacitor c=0.00141318f \
 //x=20.07 //y=1.915 //x2=21.09 //y2=2.195
cc_1363 ( N_noxref_5_c_1567_n N_noxref_13_c_3227_n ) capacitor c=0.00248968f \
 //x=19.98 //y=2.335 //x2=21.09 //y2=4.57
cc_1364 ( N_noxref_5_c_1571_n N_noxref_13_c_3227_n ) capacitor c=0.0765625f \
 //x=19.98 //y=4.585 //x2=21.09 //y2=4.57
cc_1365 ( N_noxref_5_c_1589_n N_noxref_13_c_3227_n ) capacitor c=0.00247598f \
 //x=19.935 //y=2.175 //x2=21.09 //y2=4.57
cc_1366 ( N_noxref_5_c_1600_n N_noxref_13_c_3227_n ) capacitor c=9.52396e-19 \
 //x=19.98 //y=4.7 //x2=21.09 //y2=4.57
cc_1367 ( N_noxref_5_c_1618_n N_noxref_13_c_3227_n ) capacitor c=8.42568e-19 \
 //x=19.98 //y=4.7 //x2=21.09 //y2=4.57
cc_1368 ( N_noxref_5_c_1567_n N_noxref_13_c_3238_n ) capacitor c=8.86271e-19 \
 //x=19.98 //y=2.335 //x2=21.09 //y2=2.08
cc_1369 ( N_noxref_5_c_1597_n N_noxref_13_c_3238_n ) capacitor c=0.00124918f \
 //x=19.98 //y=2.08 //x2=21.09 //y2=2.08
cc_1370 ( N_noxref_5_c_1615_n N_noxref_13_c_3238_n ) capacitor c=0.00209664f \
 //x=20.07 //y=1.915 //x2=21.09 //y2=2.08
cc_1371 ( N_noxref_5_c_1571_n N_noxref_13_c_3241_n ) capacitor c=7.51101e-19 \
 //x=19.98 //y=4.585 //x2=21.09 //y2=4.7
cc_1372 ( N_noxref_5_c_1600_n N_noxref_13_c_3241_n ) capacitor c=0.00113985f \
 //x=19.98 //y=4.7 //x2=21.09 //y2=4.7
cc_1373 ( N_noxref_5_c_1618_n N_noxref_13_c_3241_n ) capacitor c=0.00129812f \
 //x=19.98 //y=4.7 //x2=21.09 //y2=4.7
cc_1374 ( N_noxref_5_M40_noxref_g N_noxref_13_M42_noxref_g ) capacitor \
 c=0.0101598f //x=19.95 //y=6.02 //x2=20.83 //y2=6.02
cc_1375 ( N_noxref_5_M41_noxref_g N_noxref_13_M42_noxref_g ) capacitor \
 c=0.0607518f //x=20.39 //y=6.02 //x2=20.83 //y2=6.02
cc_1376 ( N_noxref_5_M41_noxref_g N_noxref_13_M43_noxref_g ) capacitor \
 c=0.0101598f //x=20.39 //y=6.02 //x2=21.27 //y2=6.02
cc_1377 ( N_noxref_5_c_1612_n N_noxref_13_c_3247_n ) capacitor c=0.00456962f \
 //x=20.07 //y=0.91 //x2=21.08 //y2=0.915
cc_1378 ( N_noxref_5_c_1613_n N_noxref_13_c_3248_n ) capacitor c=0.00438372f \
 //x=20.07 //y=1.22 //x2=21.08 //y2=1.26
cc_1379 ( N_noxref_5_c_1614_n N_noxref_13_c_3249_n ) capacitor c=0.00438372f \
 //x=20.07 //y=1.45 //x2=21.08 //y2=1.57
cc_1380 ( N_noxref_5_c_1567_n N_noxref_13_c_3250_n ) capacitor c=0.00156352f \
 //x=19.98 //y=2.335 //x2=21.09 //y2=2.08
cc_1381 ( N_noxref_5_c_1597_n N_noxref_13_c_3250_n ) capacitor c=0.00204796f \
 //x=19.98 //y=2.08 //x2=21.09 //y2=2.08
cc_1382 ( N_noxref_5_c_1615_n N_noxref_13_c_3250_n ) capacitor c=0.00933826f \
 //x=20.07 //y=1.915 //x2=21.09 //y2=2.08
cc_1383 ( N_noxref_5_c_1615_n N_noxref_13_c_3253_n ) capacitor c=0.00438372f \
 //x=20.07 //y=1.915 //x2=21.09 //y2=1.915
cc_1384 ( N_noxref_5_c_1571_n N_noxref_13_c_3254_n ) capacitor c=0.00124604f \
 //x=19.98 //y=4.585 //x2=21.09 //y2=4.7
cc_1385 ( N_noxref_5_c_1600_n N_noxref_13_c_3254_n ) capacitor c=0.00187046f \
 //x=19.98 //y=4.7 //x2=21.09 //y2=4.7
cc_1386 ( N_noxref_5_c_1799_p N_noxref_13_c_3254_n ) capacitor c=0.0616777f \
 //x=20.315 //y=4.79 //x2=21.09 //y2=4.7
cc_1387 ( N_noxref_5_c_1618_n N_noxref_13_c_3254_n ) capacitor c=0.00487508f \
 //x=19.98 //y=4.7 //x2=21.09 //y2=4.7
cc_1388 ( N_noxref_5_c_1567_n N_noxref_14_c_3321_n ) capacitor c=6.33901e-19 \
 //x=19.98 //y=2.335 //x2=20.05 //y2=5.155
cc_1389 ( N_noxref_5_c_1571_n N_noxref_14_c_3321_n ) capacitor c=0.0218571f \
 //x=19.98 //y=4.585 //x2=20.05 //y2=5.155
cc_1390 ( N_noxref_5_c_1600_n N_noxref_14_c_3321_n ) capacitor c=0.00492634f \
 //x=19.98 //y=4.7 //x2=20.05 //y2=5.155
cc_1391 ( N_noxref_5_M40_noxref_g N_noxref_14_c_3321_n ) capacitor \
 c=0.00858241f //x=19.95 //y=6.02 //x2=20.05 //y2=5.155
cc_1392 ( N_noxref_5_c_1618_n N_noxref_14_c_3321_n ) capacitor c=6.15714e-19 \
 //x=19.98 //y=4.7 //x2=20.05 //y2=5.155
cc_1393 ( N_noxref_5_M41_noxref_g N_noxref_14_c_3333_n ) capacitor \
 c=0.0103546f //x=20.39 //y=6.02 //x2=20.935 //y2=5.155
cc_1394 ( N_noxref_5_c_1571_n N_noxref_14_c_3334_n ) capacitor c=0.00424566f \
 //x=19.98 //y=4.585 //x2=21.83 //y2=5.07
cc_1395 ( N_noxref_5_c_1571_n N_noxref_14_c_3335_n ) capacitor c=0.00244335f \
 //x=19.98 //y=4.585 //x2=20.17 //y2=5.155
cc_1396 ( N_noxref_5_c_1600_n N_noxref_14_c_3335_n ) capacitor c=0.00132214f \
 //x=19.98 //y=4.7 //x2=20.17 //y2=5.155
cc_1397 ( N_noxref_5_M40_noxref_g N_noxref_14_c_3335_n ) capacitor \
 c=0.00229818f //x=19.95 //y=6.02 //x2=20.17 //y2=5.155
cc_1398 ( N_noxref_5_M41_noxref_g N_noxref_14_c_3335_n ) capacitor \
 c=0.00230699f //x=20.39 //y=6.02 //x2=20.17 //y2=5.155
cc_1399 ( N_noxref_5_c_1799_p N_noxref_14_c_3335_n ) capacitor c=0.00171075f \
 //x=20.315 //y=4.79 //x2=20.17 //y2=5.155
cc_1400 ( N_noxref_5_c_1571_n N_noxref_14_c_3340_n ) capacitor c=7.85344e-19 \
 //x=19.98 //y=4.585 //x2=20.17 //y2=5.38
cc_1401 ( N_noxref_5_M40_noxref_g N_noxref_14_c_3340_n ) capacitor \
 c=0.0179041f //x=19.95 //y=6.02 //x2=20.17 //y2=5.38
cc_1402 ( N_noxref_5_M41_noxref_g N_noxref_14_c_3340_n ) capacitor \
 c=0.0179041f //x=20.39 //y=6.02 //x2=20.17 //y2=5.38
cc_1403 ( N_noxref_5_c_1799_p N_noxref_14_c_3340_n ) capacitor c=0.00290085f \
 //x=20.315 //y=4.79 //x2=20.17 //y2=5.38
cc_1404 ( N_noxref_5_c_1453_n N_noxref_16_c_3561_n ) capacitor c=0.00179718f \
 //x=8.14 //y=2.285 //x2=10.715 //y2=0
cc_1405 ( N_noxref_5_c_1467_n N_noxref_16_c_3561_n ) capacitor c=0.00547297f \
 //x=8.145 //y=2.125 //x2=10.715 //y2=0
cc_1406 ( N_noxref_5_c_1470_n N_noxref_16_c_3561_n ) capacitor c=0.0649595f \
 //x=16.125 //y=2.135 //x2=10.715 //y2=0
cc_1407 ( N_noxref_5_c_1470_n N_noxref_16_c_3600_n ) capacitor c=0.0803007f \
 //x=16.125 //y=2.135 //x2=13.94 //y2=0
cc_1408 ( N_noxref_5_c_1529_n N_noxref_16_c_3642_n ) capacitor c=0.00179718f \
 //x=16.28 //y=2.285 //x2=18.75 //y2=0
cc_1409 ( N_noxref_5_c_1470_n N_noxref_16_c_3642_n ) capacitor c=0.0522514f \
 //x=16.125 //y=2.135 //x2=18.75 //y2=0
cc_1410 ( N_noxref_5_c_1541_n N_noxref_16_c_3642_n ) capacitor c=0.00547191f \
 //x=16.445 //y=2.135 //x2=18.75 //y2=0
cc_1411 ( N_noxref_5_c_1591_n N_noxref_16_c_3642_n ) capacitor c=0.0632004f \
 //x=19.775 //y=2.175 //x2=18.75 //y2=0
cc_1412 ( N_noxref_5_c_1567_n N_noxref_16_c_3712_n ) capacitor c=8.01435e-19 \
 //x=19.98 //y=2.335 //x2=23.665 //y2=0
cc_1413 ( N_noxref_5_c_1589_n N_noxref_16_c_3712_n ) capacitor c=0.00258052f \
 //x=19.935 //y=2.175 //x2=23.665 //y2=0
cc_1414 ( N_noxref_5_c_1591_n N_noxref_16_c_3712_n ) capacitor c=0.0200728f \
 //x=19.775 //y=2.175 //x2=23.665 //y2=0
cc_1415 ( N_noxref_5_c_1470_n N_noxref_16_c_3565_n ) capacitor c=0.00555478f \
 //x=16.125 //y=2.135 //x2=10.8 //y2=0.955
cc_1416 ( N_noxref_5_c_1470_n N_noxref_16_c_3610_n ) capacitor c=0.00505125f \
 //x=16.125 //y=2.135 //x2=14.025 //y2=0.965
cc_1417 ( N_noxref_5_c_1591_n N_noxref_16_c_3664_n ) capacitor c=0.0050997f \
 //x=19.775 //y=2.175 //x2=18.835 //y2=0.965
cc_1418 ( N_noxref_5_c_1470_n N_noxref_16_c_3585_n ) capacitor c=0.0221857f \
 //x=16.125 //y=2.135 //x2=9.62 //y2=0
cc_1419 ( N_noxref_5_c_1480_n N_noxref_16_c_3585_n ) capacitor c=0.00224448f \
 //x=8.14 //y=2.08 //x2=9.62 //y2=0
cc_1420 ( N_noxref_5_c_1505_n N_noxref_16_c_3585_n ) capacitor c=0.00262688f \
 //x=8.66 //y=1.26 //x2=9.62 //y2=0
cc_1421 ( N_noxref_5_c_1509_n N_noxref_16_c_3585_n ) capacitor c=2.63786e-19 \
 //x=8.14 //y=2.08 //x2=9.62 //y2=0
cc_1422 ( N_noxref_5_c_1470_n N_noxref_16_c_3625_n ) capacitor c=0.0222613f \
 //x=16.125 //y=2.135 //x2=12.95 //y2=0
cc_1423 ( N_noxref_5_c_1591_n N_noxref_16_c_3684_n ) capacitor c=0.0227826f \
 //x=19.775 //y=2.175 //x2=17.76 //y2=0
cc_1424 ( N_noxref_5_c_1542_n N_noxref_16_c_3684_n ) capacitor c=0.00218156f \
 //x=16.28 //y=2.08 //x2=17.76 //y2=0
cc_1425 ( N_noxref_5_c_1637_p N_noxref_16_c_3684_n ) capacitor c=0.00262688f \
 //x=16.8 //y=1.26 //x2=17.76 //y2=0
cc_1426 ( N_noxref_5_c_1554_n N_noxref_16_c_3684_n ) capacitor c=2.63786e-19 \
 //x=16.28 //y=2.08 //x2=17.76 //y2=0
cc_1427 ( N_noxref_5_c_1470_n N_noxref_20_c_4238_n ) capacitor c=0.00442321f \
 //x=16.125 //y=2.135 //x2=10.315 //y2=1.495
cc_1428 ( N_noxref_5_c_1470_n N_noxref_20_c_4239_n ) capacitor c=0.0127909f \
 //x=16.125 //y=2.135 //x2=11.2 //y2=1.58
cc_1429 ( N_noxref_5_c_1470_n N_noxref_20_c_4246_n ) capacitor c=0.00436444f \
 //x=16.125 //y=2.135 //x2=11.285 //y2=1.495
cc_1430 ( N_noxref_5_c_1470_n N_noxref_20_c_4251_n ) capacitor c=8.17446e-19 \
 //x=16.125 //y=2.135 //x2=12.17 //y2=0.53
cc_1431 ( N_noxref_5_c_1470_n N_noxref_20_M6_noxref_s ) capacitor c=0.0010705f \
 //x=16.125 //y=2.135 //x2=10.18 //y2=0.365
cc_1432 ( N_noxref_5_c_1470_n N_noxref_21_c_4306_n ) capacitor c=0.00444844f \
 //x=16.125 //y=2.135 //x2=13.54 //y2=1.505
cc_1433 ( N_noxref_5_c_1470_n N_noxref_21_c_4307_n ) capacitor c=0.0132119f \
 //x=16.125 //y=2.135 //x2=14.425 //y2=1.59
cc_1434 ( N_noxref_5_c_1470_n N_noxref_21_c_4320_n ) capacitor c=0.0113756f \
 //x=16.125 //y=2.135 //x2=15.395 //y2=1.59
cc_1435 ( N_noxref_5_c_1470_n N_noxref_21_M8_noxref_s ) capacitor \
 c=0.00828583f //x=16.125 //y=2.135 //x2=13.405 //y2=0.375
cc_1436 ( N_noxref_5_c_1591_n N_noxref_22_c_4365_n ) capacitor c=0.00444844f \
 //x=19.775 //y=2.175 //x2=18.35 //y2=1.505
cc_1437 ( N_noxref_5_c_1591_n N_noxref_22_c_4366_n ) capacitor c=0.0131925f \
 //x=19.775 //y=2.175 //x2=19.235 //y2=1.59
cc_1438 ( N_noxref_5_c_1607_n N_noxref_22_c_4379_n ) capacitor c=0.0167228f \
 //x=19.545 //y=0.91 //x2=20.205 //y2=0.54
cc_1439 ( N_noxref_5_c_1612_n N_noxref_22_c_4379_n ) capacitor c=0.00534519f \
 //x=20.07 //y=0.91 //x2=20.205 //y2=0.54
cc_1440 ( N_noxref_5_c_1567_n N_noxref_22_c_4381_n ) capacitor c=0.00739862f \
 //x=19.98 //y=2.335 //x2=20.205 //y2=1.59
cc_1441 ( N_noxref_5_c_1591_n N_noxref_22_c_4381_n ) capacitor c=0.00730092f \
 //x=19.775 //y=2.175 //x2=20.205 //y2=1.59
cc_1442 ( N_noxref_5_c_1597_n N_noxref_22_c_4381_n ) capacitor c=0.0105652f \
 //x=19.98 //y=2.08 //x2=20.205 //y2=1.59
cc_1443 ( N_noxref_5_c_1610_n N_noxref_22_c_4381_n ) capacitor c=0.0155011f \
 //x=19.545 //y=1.22 //x2=20.205 //y2=1.59
cc_1444 ( N_noxref_5_c_1615_n N_noxref_22_c_4381_n ) capacitor c=0.0223685f \
 //x=20.07 //y=1.915 //x2=20.205 //y2=1.59
cc_1445 ( N_noxref_5_c_1591_n N_noxref_22_M11_noxref_s ) capacitor \
 c=0.00419984f //x=19.775 //y=2.175 //x2=18.215 //y2=0.375
cc_1446 ( N_noxref_5_c_1607_n N_noxref_22_M11_noxref_s ) capacitor \
 c=0.00798959f //x=19.545 //y=0.91 //x2=18.215 //y2=0.375
cc_1447 ( N_noxref_5_c_1614_n N_noxref_22_M11_noxref_s ) capacitor \
 c=0.00212176f //x=20.07 //y=1.45 //x2=18.215 //y2=0.375
cc_1448 ( N_noxref_5_c_1615_n N_noxref_22_M11_noxref_s ) capacitor \
 c=0.00298115f //x=20.07 //y=1.915 //x2=18.215 //y2=0.375
cc_1449 ( N_noxref_6_c_1989_n N_noxref_7_c_2451_n ) capacitor c=3.84564e-19 \
 //x=1.11 //y=4.24 //x2=25.53 //y2=7.4
cc_1450 ( N_noxref_6_c_1932_n N_noxref_7_c_2451_n ) capacitor c=0.0062064f \
 //x=15.24 //y=5.155 //x2=25.53 //y2=7.4
cc_1451 ( N_noxref_6_c_2004_n N_noxref_7_c_2451_n ) capacitor c=0.00626474f \
 //x=16.125 //y=5.155 //x2=25.53 //y2=7.4
cc_1452 ( N_noxref_6_c_2111_n N_noxref_7_c_2451_n ) capacitor c=0.00255604f \
 //x=16.24 //y=5.38 //x2=25.53 //y2=7.4
cc_1453 ( N_noxref_6_c_2113_n N_noxref_7_c_2451_n ) capacitor c=0.00827819f \
 //x=16.935 //y=5.155 //x2=25.53 //y2=7.4
cc_1454 ( N_noxref_6_c_2068_n N_noxref_7_c_2451_n ) capacitor c=2.29124e-19 \
 //x=17.02 //y=4.235 //x2=25.53 //y2=7.4
cc_1455 ( N_noxref_6_c_1937_n N_noxref_7_c_2451_n ) capacitor c=0.00261379f \
 //x=14.482 //y=5.155 //x2=25.53 //y2=7.4
cc_1456 ( N_noxref_6_c_2009_n N_noxref_7_c_2451_n ) capacitor c=0.0026965f \
 //x=15.36 //y=5.155 //x2=25.53 //y2=7.4
cc_1457 ( N_noxref_6_c_2151_n N_noxref_7_c_2451_n ) capacitor c=3.94463e-19 \
 //x=17.02 //y=4.07 //x2=25.53 //y2=7.4
cc_1458 ( N_noxref_6_c_1949_n N_noxref_7_c_2451_n ) capacitor c=0.00242194f \
 //x=14.48 //y=5.38 //x2=25.53 //y2=7.4
cc_1459 ( N_noxref_6_c_2034_n N_noxref_7_c_2451_n ) capacitor c=0.00242194f \
 //x=15.36 //y=5.38 //x2=25.53 //y2=7.4
cc_1460 ( N_noxref_6_c_2162_n N_noxref_7_c_2451_n ) capacitor c=0.00242194f \
 //x=16.24 //y=5.38 //x2=25.53 //y2=7.4
cc_1461 ( N_noxref_6_c_1989_n N_noxref_7_c_2586_n ) capacitor c=0.001923f \
 //x=1.11 //y=4.24 //x2=0.74 //y2=7.4
cc_1462 ( N_noxref_6_c_1864_n N_noxref_7_c_2586_n ) capacitor c=0.0157044f \
 //x=1.11 //y=4.575 //x2=0.74 //y2=7.4
cc_1463 ( N_noxref_6_c_2007_n N_noxref_7_c_2586_n ) capacitor c=0.00229603f \
 //x=1.11 //y=4.07 //x2=0.74 //y2=7.4
cc_1464 ( N_noxref_6_c_2031_n N_noxref_7_c_2586_n ) capacitor c=0.00371026f \
 //x=1.11 //y=4.7 //x2=0.74 //y2=7.4
cc_1465 ( N_noxref_6_c_2055_n N_noxref_7_c_2586_n ) capacitor c=0.00594885f \
 //x=1.385 //y=4.79 //x2=0.74 //y2=7.4
cc_1466 ( N_noxref_6_c_1989_n N_noxref_7_c_2588_n ) capacitor c=3.24352e-19 \
 //x=1.11 //y=4.24 //x2=1.885 //y2=7.4
cc_1467 ( N_noxref_6_M16_noxref_g N_noxref_7_c_2588_n ) capacitor \
 c=0.00749687f //x=1.31 //y=6.02 //x2=1.885 //y2=7.4
cc_1468 ( N_noxref_6_M17_noxref_g N_noxref_7_c_2588_n ) capacitor \
 c=0.00749619f //x=1.75 //y=6.02 //x2=1.885 //y2=7.4
cc_1469 ( N_noxref_6_M30_noxref_g N_noxref_7_c_2522_n ) capacitor \
 c=0.00692597f //x=11.51 //y=6.02 //x2=12.085 //y2=7.4
cc_1470 ( N_noxref_6_M31_noxref_g N_noxref_7_c_2522_n ) capacitor \
 c=0.00749619f //x=11.95 //y=6.02 //x2=12.085 //y2=7.4
cc_1471 ( N_noxref_6_c_1932_n N_noxref_7_c_2527_n ) capacitor c=0.00202948f \
 //x=15.24 //y=5.155 //x2=14.835 //y2=7.4
cc_1472 ( N_noxref_6_c_1937_n N_noxref_7_c_2527_n ) capacitor c=9.37357e-19 \
 //x=14.482 //y=5.155 //x2=14.835 //y2=7.4
cc_1473 ( N_noxref_6_c_1949_n N_noxref_7_c_2527_n ) capacitor c=0.0137846f \
 //x=14.48 //y=5.38 //x2=14.835 //y2=7.4
cc_1474 ( N_noxref_6_c_1932_n N_noxref_7_c_2562_n ) capacitor c=0.00177088f \
 //x=15.24 //y=5.155 //x2=15.715 //y2=7.4
cc_1475 ( N_noxref_6_c_2004_n N_noxref_7_c_2562_n ) capacitor c=0.00202948f \
 //x=16.125 //y=5.155 //x2=15.715 //y2=7.4
cc_1476 ( N_noxref_6_c_2009_n N_noxref_7_c_2562_n ) capacitor c=9.47876e-19 \
 //x=15.36 //y=5.155 //x2=15.715 //y2=7.4
cc_1477 ( N_noxref_6_c_2034_n N_noxref_7_c_2562_n ) capacitor c=0.0137846f \
 //x=15.36 //y=5.38 //x2=15.715 //y2=7.4
cc_1478 ( N_noxref_6_c_2004_n N_noxref_7_c_2641_n ) capacitor c=0.00205929f \
 //x=16.125 //y=5.155 //x2=16.595 //y2=7.4
cc_1479 ( N_noxref_6_c_2111_n N_noxref_7_c_2641_n ) capacitor c=8.49349e-19 \
 //x=16.24 //y=5.38 //x2=16.595 //y2=7.4
cc_1480 ( N_noxref_6_c_2113_n N_noxref_7_c_2641_n ) capacitor c=0.00204261f \
 //x=16.935 //y=5.155 //x2=16.595 //y2=7.4
cc_1481 ( N_noxref_6_c_2162_n N_noxref_7_c_2641_n ) capacitor c=0.0137846f \
 //x=16.24 //y=5.38 //x2=16.595 //y2=7.4
cc_1482 ( N_noxref_6_c_2113_n N_noxref_7_c_2688_n ) capacitor c=0.00156968f \
 //x=16.935 //y=5.155 //x2=17.59 //y2=7.4
cc_1483 ( N_noxref_6_M46_noxref_g N_noxref_7_c_2689_n ) capacitor \
 c=0.00692597f //x=24.46 //y=6.02 //x2=25.035 //y2=7.4
cc_1484 ( N_noxref_6_M47_noxref_g N_noxref_7_c_2689_n ) capacitor \
 c=0.00749619f //x=24.9 //y=6.02 //x2=25.035 //y2=7.4
cc_1485 ( N_noxref_6_c_2209_p N_noxref_7_c_2691_n ) capacitor c=0.00143727f \
 //x=24.42 //y=4.07 //x2=25.53 //y2=7.4
cc_1486 ( N_noxref_6_c_2210_p N_noxref_7_c_2691_n ) capacitor c=0.00226427f \
 //x=24.45 //y=4.7 //x2=25.53 //y2=7.4
cc_1487 ( N_noxref_6_c_2211_p N_noxref_7_c_2691_n ) capacitor c=0.0237963f \
 //x=24.825 //y=4.79 //x2=25.53 //y2=7.4
cc_1488 ( N_noxref_6_c_2212_p N_noxref_7_c_2691_n ) capacitor c=2.73429e-19 \
 //x=24.45 //y=4.7 //x2=25.53 //y2=7.4
cc_1489 ( N_noxref_6_c_1887_n N_noxref_7_c_2481_n ) capacitor c=5.71665e-19 \
 //x=4.325 //y=4.09 //x2=4.81 //y2=7.4
cc_1490 ( N_noxref_6_c_1888_n N_noxref_7_c_2481_n ) capacitor c=0.00910495f \
 //x=5.54 //y=4.07 //x2=4.81 //y2=7.4
cc_1491 ( N_noxref_6_c_1879_n N_noxref_7_c_2485_n ) capacitor c=8.4651e-19 \
 //x=11.47 //y=4.07 //x2=9.62 //y2=7.4
cc_1492 ( N_noxref_6_c_1890_n N_noxref_7_c_2485_n ) capacitor c=0.00875046f \
 //x=11.635 //y=4.07 //x2=9.62 //y2=7.4
cc_1493 ( N_noxref_6_c_1879_n N_noxref_7_c_2532_n ) capacitor c=0.00133334f \
 //x=11.47 //y=4.07 //x2=12.95 //y2=7.4
cc_1494 ( N_noxref_6_c_1937_n N_noxref_7_c_2532_n ) capacitor c=0.0022955f \
 //x=14.482 //y=5.155 //x2=12.95 //y2=7.4
cc_1495 ( N_noxref_6_c_1942_n N_noxref_7_c_2532_n ) capacitor c=0.00867114f \
 //x=16.865 //y=4.07 //x2=12.95 //y2=7.4
cc_1496 ( N_noxref_6_c_1898_n N_noxref_7_c_2532_n ) capacitor c=0.00226427f \
 //x=11.5 //y=4.7 //x2=12.95 //y2=7.4
cc_1497 ( N_noxref_6_c_1949_n N_noxref_7_c_2532_n ) capacitor c=0.00508013f \
 //x=14.48 //y=5.38 //x2=12.95 //y2=7.4
cc_1498 ( N_noxref_6_c_1964_n N_noxref_7_c_2532_n ) capacitor c=0.0129149f \
 //x=11.875 //y=4.79 //x2=12.95 //y2=7.4
cc_1499 ( N_noxref_6_c_1917_n N_noxref_7_c_2532_n ) capacitor c=2.73429e-19 \
 //x=11.5 //y=4.7 //x2=12.95 //y2=7.4
cc_1500 ( N_noxref_6_c_2111_n N_noxref_7_c_2610_n ) capacitor c=0.00282782f \
 //x=16.24 //y=5.38 //x2=17.76 //y2=7.4
cc_1501 ( N_noxref_6_c_2068_n N_noxref_7_c_2610_n ) capacitor c=0.00175322f \
 //x=17.02 //y=4.235 //x2=17.76 //y2=7.4
cc_1502 ( N_noxref_6_c_2006_n N_noxref_7_c_2610_n ) capacitor c=0.0309939f \
 //x=17.02 //y=5.07 //x2=17.76 //y2=7.4
cc_1503 ( N_noxref_6_c_2151_n N_noxref_7_c_2610_n ) capacitor c=0.00507985f \
 //x=17.02 //y=4.07 //x2=17.76 //y2=7.4
cc_1504 ( N_noxref_6_c_2099_n N_noxref_7_c_2610_n ) capacitor c=0.0195443f \
 //x=18.73 //y=4.085 //x2=17.76 //y2=7.4
cc_1505 ( N_noxref_6_c_2162_n N_noxref_7_c_2610_n ) capacitor c=0.00777981f \
 //x=16.24 //y=5.38 //x2=17.76 //y2=7.4
cc_1506 ( N_noxref_6_c_2209_p N_noxref_7_c_2712_n ) capacitor c=8.50173e-19 \
 //x=24.42 //y=4.07 //x2=22.57 //y2=7.4
cc_1507 ( N_noxref_6_c_2097_n N_noxref_7_c_2712_n ) capacitor c=0.0194413f \
 //x=19.075 //y=4.085 //x2=22.57 //y2=7.4
cc_1508 ( N_noxref_6_c_1989_n N_noxref_7_M16_noxref_s ) capacitor \
 c=9.65642e-19 //x=1.11 //y=4.24 //x2=0.955 //y2=5.02
cc_1509 ( N_noxref_6_c_1864_n N_noxref_7_M16_noxref_s ) capacitor c=0.0223498f \
 //x=1.11 //y=4.575 //x2=0.955 //y2=5.02
cc_1510 ( N_noxref_6_c_2026_n N_noxref_7_M16_noxref_s ) capacitor \
 c=4.28833e-19 //x=1.27 //y=4.08 //x2=0.955 //y2=5.02
cc_1511 ( N_noxref_6_c_2031_n N_noxref_7_M16_noxref_s ) capacitor \
 c=0.00911304f //x=1.11 //y=4.7 //x2=0.955 //y2=5.02
cc_1512 ( N_noxref_6_M16_noxref_g N_noxref_7_M16_noxref_s ) capacitor \
 c=0.053419f //x=1.31 //y=6.02 //x2=0.955 //y2=5.02
cc_1513 ( N_noxref_6_c_2055_n N_noxref_7_M16_noxref_s ) capacitor \
 c=0.00597586f //x=1.385 //y=4.79 //x2=0.955 //y2=5.02
cc_1514 ( N_noxref_6_M17_noxref_g N_noxref_7_M17_noxref_d ) capacitor \
 c=0.015318f //x=1.75 //y=6.02 //x2=1.825 //y2=5.02
cc_1515 ( N_noxref_6_c_1937_n N_noxref_7_M28_noxref_s ) capacitor \
 c=4.22189e-19 //x=14.482 //y=5.155 //x2=10.275 //y2=5.02
cc_1516 ( N_noxref_6_M30_noxref_g N_noxref_7_M29_noxref_d ) capacitor \
 c=0.015318f //x=11.51 //y=6.02 //x2=11.145 //y2=5.02
cc_1517 ( N_noxref_6_c_1917_n N_noxref_7_M29_noxref_d ) capacitor \
 c=3.50187e-19 //x=11.5 //y=4.7 //x2=11.145 //y2=5.02
cc_1518 ( N_noxref_6_M31_noxref_g N_noxref_7_M31_noxref_d ) capacitor \
 c=0.0430452f //x=11.95 //y=6.02 //x2=12.025 //y2=5.02
cc_1519 ( N_noxref_6_c_1937_n N_noxref_7_M32_noxref_s ) capacitor c=0.0442713f \
 //x=14.482 //y=5.155 //x2=13.905 //y2=5.02
cc_1520 ( N_noxref_6_c_2009_n N_noxref_7_M32_noxref_s ) capacitor \
 c=7.80122e-19 //x=15.36 //y=5.155 //x2=13.905 //y2=5.02
cc_1521 ( N_noxref_6_c_1949_n N_noxref_7_M32_noxref_s ) capacitor c=0.0908457f \
 //x=14.48 //y=5.38 //x2=13.905 //y2=5.02
cc_1522 ( N_noxref_6_c_1932_n N_noxref_7_M33_noxref_d ) capacitor \
 c=0.00700078f //x=15.24 //y=5.155 //x2=14.775 //y2=5.02
cc_1523 ( N_noxref_6_c_1949_n N_noxref_7_M33_noxref_d ) capacitor c=0.0673792f \
 //x=14.48 //y=5.38 //x2=14.775 //y2=5.02
cc_1524 ( N_noxref_6_c_2034_n N_noxref_7_M33_noxref_d ) capacitor c=0.0674762f \
 //x=15.36 //y=5.38 //x2=14.775 //y2=5.02
cc_1525 ( N_noxref_6_c_2004_n N_noxref_7_M35_noxref_d ) capacitor \
 c=0.00700078f //x=16.125 //y=5.155 //x2=15.655 //y2=5.02
cc_1526 ( N_noxref_6_c_2034_n N_noxref_7_M35_noxref_d ) capacitor c=0.067493f \
 //x=15.36 //y=5.38 //x2=15.655 //y2=5.02
cc_1527 ( N_noxref_6_c_2162_n N_noxref_7_M35_noxref_d ) capacitor c=0.0674979f \
 //x=16.24 //y=5.38 //x2=15.655 //y2=5.02
cc_1528 ( N_noxref_6_c_2113_n N_noxref_7_M37_noxref_d ) capacitor \
 c=0.00700078f //x=16.935 //y=5.155 //x2=16.535 //y2=5.02
cc_1529 ( N_noxref_6_c_2162_n N_noxref_7_M37_noxref_d ) capacitor c=0.0675002f \
 //x=16.24 //y=5.38 //x2=16.535 //y2=5.02
cc_1530 ( N_noxref_6_c_2111_n N_noxref_7_M38_noxref_s ) capacitor \
 c=0.00492616f //x=16.24 //y=5.38 //x2=18.715 //y2=5.02
cc_1531 ( N_noxref_6_c_2113_n N_noxref_7_M38_noxref_s ) capacitor \
 c=9.42705e-19 //x=16.935 //y=5.155 //x2=18.715 //y2=5.02
cc_1532 ( N_noxref_6_c_2009_n N_noxref_7_M38_noxref_s ) capacitor \
 c=2.11884e-19 //x=15.36 //y=5.155 //x2=18.715 //y2=5.02
cc_1533 ( N_noxref_6_c_2099_n N_noxref_7_M38_noxref_s ) capacitor \
 c=4.36524e-19 //x=18.73 //y=4.085 //x2=18.715 //y2=5.02
cc_1534 ( N_noxref_6_c_2097_n N_noxref_7_M44_noxref_s ) capacitor \
 c=0.00623384f //x=19.075 //y=4.085 //x2=23.225 //y2=5.02
cc_1535 ( N_noxref_6_M46_noxref_g N_noxref_7_M45_noxref_d ) capacitor \
 c=0.015318f //x=24.46 //y=6.02 //x2=24.095 //y2=5.02
cc_1536 ( N_noxref_6_c_2212_p N_noxref_7_M45_noxref_d ) capacitor \
 c=3.50187e-19 //x=24.45 //y=4.7 //x2=24.095 //y2=5.02
cc_1537 ( N_noxref_6_M47_noxref_g N_noxref_7_M47_noxref_d ) capacitor \
 c=0.0430452f //x=24.9 //y=6.02 //x2=24.975 //y2=5.02
cc_1538 ( N_noxref_6_c_1890_n N_noxref_10_c_2976_n ) capacitor c=0.023924f \
 //x=11.635 //y=4.07 //x2=7.03 //y2=4.585
cc_1539 ( N_noxref_6_c_2117_n N_noxref_11_c_3109_n ) capacitor c=0.0036878f \
 //x=16.535 //y=1.125 //x2=16.935 //y2=0.54
cc_1540 ( N_noxref_6_c_2130_n N_noxref_11_c_3109_n ) capacitor c=0.00399931f \
 //x=16.935 //y=1.665 //x2=16.935 //y2=0.54
cc_1541 ( N_noxref_6_M10_noxref_d N_noxref_11_c_3109_n ) capacitor \
 c=0.00910163f //x=16.345 //y=0.915 //x2=16.935 //y2=0.54
cc_1542 ( N_noxref_6_M10_noxref_d N_noxref_11_c_3114_n ) capacitor \
 c=0.00120711f //x=16.345 //y=0.915 //x2=16.05 //y2=0.995
cc_1543 ( N_noxref_6_c_1932_n N_noxref_11_M9_noxref_d ) capacitor \
 c=0.00143783f //x=15.24 //y=5.155 //x2=14.81 //y2=0.91
cc_1544 ( N_noxref_6_c_2117_n N_noxref_11_M9_noxref_d ) capacitor \
 c=0.00802417f //x=16.535 //y=1.125 //x2=14.81 //y2=0.91
cc_1545 ( N_noxref_6_c_2117_n N_noxref_11_M10_noxref_s ) capacitor \
 c=0.0098487f //x=16.535 //y=1.125 //x2=15.915 //y2=0.375
cc_1546 ( N_noxref_6_c_1933_n N_noxref_11_M10_noxref_s ) capacitor \
 c=0.0283111f //x=16.535 //y=1.58 //x2=15.915 //y2=0.375
cc_1547 ( N_noxref_6_c_2130_n N_noxref_11_M10_noxref_s ) capacitor \
 c=0.00942148f //x=16.935 //y=1.665 //x2=15.915 //y2=0.375
cc_1548 ( N_noxref_6_c_2151_n N_noxref_11_M10_noxref_s ) capacitor \
 c=0.00108527f //x=17.02 //y=4.07 //x2=15.915 //y2=0.375
cc_1549 ( N_noxref_6_M10_noxref_d N_noxref_11_M10_noxref_s ) capacitor \
 c=0.0279003f //x=16.345 //y=0.915 //x2=15.915 //y2=0.375
cc_1550 ( N_noxref_6_c_2117_n N_noxref_12_M12_noxref_d ) capacitor \
 c=3.20746e-19 //x=16.535 //y=1.125 //x2=19.62 //y2=0.91
cc_1551 ( N_noxref_6_c_2097_n N_noxref_13_c_3229_n ) capacitor c=0.00146177f \
 //x=19.075 //y=4.085 //x2=21.09 //y2=2.195
cc_1552 ( N_noxref_6_c_2097_n N_noxref_13_c_3227_n ) capacitor c=0.0352679f \
 //x=19.075 //y=4.085 //x2=21.09 //y2=4.57
cc_1553 ( N_noxref_6_c_2097_n N_noxref_14_c_3344_n ) capacitor c=0.0166822f \
 //x=19.075 //y=4.085 //x2=21.745 //y2=5.155
cc_1554 ( N_noxref_6_c_2130_n N_noxref_14_c_3345_n ) capacitor c=0.00163399f \
 //x=16.935 //y=1.665 //x2=21.43 //y2=1.665
cc_1555 ( N_noxref_6_c_2279_p N_noxref_14_c_3334_n ) capacitor c=0.00290506f \
 //x=24.42 //y=3.915 //x2=21.83 //y2=5.07
cc_1556 ( N_noxref_6_c_2280_p N_noxref_14_c_3334_n ) capacitor c=0.00133526f \
 //x=24.42 //y=4.555 //x2=21.83 //y2=5.07
cc_1557 ( N_noxref_6_c_2097_n N_noxref_14_c_3334_n ) capacitor c=0.0369539f \
 //x=19.075 //y=4.085 //x2=21.83 //y2=5.07
cc_1558 ( N_noxref_6_c_2111_n N_noxref_14_c_3322_n ) capacitor c=6.09703e-19 \
 //x=16.24 //y=5.38 //x2=19.292 //y2=5.155
cc_1559 ( N_noxref_6_c_2113_n N_noxref_14_c_3322_n ) capacitor c=0.00306432f \
 //x=16.935 //y=5.155 //x2=19.292 //y2=5.155
cc_1560 ( N_noxref_6_c_2097_n N_noxref_14_c_3322_n ) capacitor c=0.0233355f \
 //x=19.075 //y=4.085 //x2=19.292 //y2=5.155
cc_1561 ( N_noxref_6_c_2097_n N_noxref_14_c_3335_n ) capacitor c=0.0331894f \
 //x=19.075 //y=4.085 //x2=20.17 //y2=5.155
cc_1562 ( N_noxref_6_c_2286_p N_noxref_15_c_3457_n ) capacitor c=0.0205342f \
 //x=24.42 //y=2.08 //x2=23.68 //y2=2.08
cc_1563 ( N_noxref_6_c_2097_n N_noxref_15_c_3457_n ) capacitor c=0.00180283f \
 //x=19.075 //y=4.085 //x2=23.68 //y2=2.08
cc_1564 ( N_noxref_6_c_2288_p N_noxref_15_c_3457_n ) capacitor c=5.24723e-19 \
 //x=24.42 //y=2.08 //x2=23.68 //y2=2.08
cc_1565 ( N_noxref_6_c_2289_p N_noxref_15_c_3457_n ) capacitor c=0.00167305f \
 //x=24.42 //y=2.08 //x2=23.68 //y2=2.08
cc_1566 ( N_noxref_6_c_2280_p N_noxref_15_c_3461_n ) capacitor c=0.0172939f \
 //x=24.42 //y=4.555 //x2=23.68 //y2=4.7
cc_1567 ( N_noxref_6_c_2097_n N_noxref_15_c_3461_n ) capacitor c=0.00370655f \
 //x=19.075 //y=4.085 //x2=23.68 //y2=4.7
cc_1568 ( N_noxref_6_c_2210_p N_noxref_15_c_3461_n ) capacitor c=4.80626e-19 \
 //x=24.45 //y=4.7 //x2=23.68 //y2=4.7
cc_1569 ( N_noxref_6_c_2212_p N_noxref_15_c_3461_n ) capacitor c=0.00158715f \
 //x=24.45 //y=4.7 //x2=23.68 //y2=4.7
cc_1570 ( N_noxref_6_c_2279_p N_noxref_15_c_3465_n ) capacitor c=0.0784731f \
 //x=24.42 //y=3.915 //x2=23.682 //y2=4.56
cc_1571 ( N_noxref_6_c_2295_p N_noxref_15_c_3465_n ) capacitor c=0.0174568f \
 //x=24.42 //y=4.235 //x2=23.682 //y2=4.56
cc_1572 ( N_noxref_6_c_2280_p N_noxref_15_c_3465_n ) capacitor c=0.0136061f \
 //x=24.42 //y=4.555 //x2=23.682 //y2=4.56
cc_1573 ( N_noxref_6_c_2209_p N_noxref_15_c_3465_n ) capacitor c=6.89957e-19 \
 //x=24.42 //y=4.07 //x2=23.682 //y2=4.56
cc_1574 ( N_noxref_6_c_2097_n N_noxref_15_c_3465_n ) capacitor c=0.0353646f \
 //x=19.075 //y=4.085 //x2=23.682 //y2=4.56
cc_1575 ( N_noxref_6_c_2288_p N_noxref_15_c_3465_n ) capacitor c=3.49899e-19 \
 //x=24.42 //y=2.08 //x2=23.682 //y2=4.56
cc_1576 ( N_noxref_6_c_2279_p N_noxref_15_c_3471_n ) capacitor c=3.49899e-19 \
 //x=24.42 //y=3.915 //x2=23.68 //y2=2.08
cc_1577 ( N_noxref_6_c_2286_p N_noxref_15_c_3471_n ) capacitor c=5.16867e-19 \
 //x=24.42 //y=2.08 //x2=23.68 //y2=2.08
cc_1578 ( N_noxref_6_c_2288_p N_noxref_15_c_3471_n ) capacitor c=0.00445529f \
 //x=24.42 //y=2.08 //x2=23.68 //y2=2.08
cc_1579 ( N_noxref_6_c_2289_p N_noxref_15_c_3471_n ) capacitor c=0.00266443f \
 //x=24.42 //y=2.08 //x2=23.68 //y2=2.08
cc_1580 ( N_noxref_6_c_2280_p N_noxref_15_c_3475_n ) capacitor c=7.76143e-19 \
 //x=24.42 //y=4.555 //x2=23.68 //y2=4.7
cc_1581 ( N_noxref_6_c_2210_p N_noxref_15_c_3475_n ) capacitor c=0.00397338f \
 //x=24.45 //y=4.7 //x2=23.68 //y2=4.7
cc_1582 ( N_noxref_6_c_2212_p N_noxref_15_c_3475_n ) capacitor c=0.00237977f \
 //x=24.45 //y=4.7 //x2=23.68 //y2=4.7
cc_1583 ( N_noxref_6_M46_noxref_g N_noxref_15_M44_noxref_g ) capacitor \
 c=0.0104892f //x=24.46 //y=6.02 //x2=23.58 //y2=6.02
cc_1584 ( N_noxref_6_M46_noxref_g N_noxref_15_M45_noxref_g ) capacitor \
 c=0.107636f //x=24.46 //y=6.02 //x2=24.02 //y2=6.02
cc_1585 ( N_noxref_6_M47_noxref_g N_noxref_15_M45_noxref_g ) capacitor \
 c=0.0100341f //x=24.9 //y=6.02 //x2=24.02 //y2=6.02
cc_1586 ( N_noxref_6_c_2310_p N_noxref_15_c_3481_n ) capacitor c=4.86545e-19 \
 //x=24.455 //y=0.905 //x2=23.485 //y2=0.865
cc_1587 ( N_noxref_6_c_2310_p N_noxref_15_c_3482_n ) capacitor c=0.00152405f \
 //x=24.455 //y=0.905 //x2=23.485 //y2=1.21
cc_1588 ( N_noxref_6_c_2312_p N_noxref_15_c_3483_n ) capacitor c=0.00109982f \
 //x=24.455 //y=1.25 //x2=23.485 //y2=1.52
cc_1589 ( N_noxref_6_c_2313_p N_noxref_15_c_3483_n ) capacitor c=9.58243e-19 \
 //x=24.455 //y=1.56 //x2=23.485 //y2=1.52
cc_1590 ( N_noxref_6_c_2286_p N_noxref_15_c_3485_n ) capacitor c=0.00167888f \
 //x=24.42 //y=2.08 //x2=23.485 //y2=1.915
cc_1591 ( N_noxref_6_c_2288_p N_noxref_15_c_3485_n ) capacitor c=0.00267961f \
 //x=24.42 //y=2.08 //x2=23.485 //y2=1.915
cc_1592 ( N_noxref_6_c_2313_p N_noxref_15_c_3485_n ) capacitor c=0.00662747f \
 //x=24.455 //y=1.56 //x2=23.485 //y2=1.915
cc_1593 ( N_noxref_6_c_2289_p N_noxref_15_c_3485_n ) capacitor c=0.0181449f \
 //x=24.42 //y=2.08 //x2=23.485 //y2=1.915
cc_1594 ( N_noxref_6_c_2310_p N_noxref_15_c_3489_n ) capacitor c=0.0151475f \
 //x=24.455 //y=0.905 //x2=24.015 //y2=0.865
cc_1595 ( N_noxref_6_c_2319_p N_noxref_15_c_3489_n ) capacitor c=0.00127211f \
 //x=24.985 //y=0.905 //x2=24.015 //y2=0.865
cc_1596 ( N_noxref_6_c_2312_p N_noxref_15_c_3491_n ) capacitor c=0.0111064f \
 //x=24.455 //y=1.25 //x2=24.015 //y2=1.21
cc_1597 ( N_noxref_6_c_2313_p N_noxref_15_c_3491_n ) capacitor c=0.00862358f \
 //x=24.455 //y=1.56 //x2=24.015 //y2=1.21
cc_1598 ( N_noxref_6_c_2322_p N_noxref_15_c_3491_n ) capacitor c=0.00204774f \
 //x=24.985 //y=1.25 //x2=24.015 //y2=1.21
cc_1599 ( N_noxref_6_c_2280_p N_noxref_15_c_3494_n ) capacitor c=0.00201171f \
 //x=24.42 //y=4.555 //x2=23.68 //y2=4.7
cc_1600 ( N_noxref_6_c_2210_p N_noxref_15_c_3494_n ) capacitor c=0.00283894f \
 //x=24.45 //y=4.7 //x2=23.68 //y2=4.7
cc_1601 ( N_noxref_6_c_2212_p N_noxref_15_c_3494_n ) capacitor c=0.0297875f \
 //x=24.45 //y=4.7 //x2=23.68 //y2=4.7
cc_1602 ( N_noxref_6_c_2041_n N_noxref_16_c_3727_n ) capacitor c=3.97665e-19 \
 //x=0.81 //y=0.875 //x2=1.075 //y2=0.835
cc_1603 ( N_noxref_6_c_2327_p N_noxref_16_c_3727_n ) capacitor c=0.00864609f \
 //x=1.185 //y=0.72 //x2=1.075 //y2=0.835
cc_1604 ( N_noxref_6_c_2047_n N_noxref_16_c_3727_n ) capacitor c=4.45447e-19 \
 //x=1.34 //y=0.875 //x2=1.075 //y2=0.835
cc_1605 ( N_noxref_6_c_1880_n N_noxref_16_c_3600_n ) capacitor c=0.00210539f \
 //x=11.47 //y=2.08 //x2=13.94 //y2=0
cc_1606 ( N_noxref_6_c_2117_n N_noxref_16_c_3642_n ) capacitor c=0.00876454f \
 //x=16.535 //y=1.125 //x2=18.75 //y2=0
cc_1607 ( N_noxref_6_c_2130_n N_noxref_16_c_3642_n ) capacitor c=0.00661744f \
 //x=16.935 //y=1.665 //x2=18.75 //y2=0
cc_1608 ( N_noxref_6_M10_noxref_d N_noxref_16_c_3642_n ) capacitor \
 c=2.94508e-19 //x=16.345 //y=0.915 //x2=18.75 //y2=0
cc_1609 ( N_noxref_6_c_2295_p N_noxref_16_c_3734_n ) capacitor c=2.49311e-19 \
 //x=24.42 //y=4.235 //x2=25.53 //y2=0
cc_1610 ( N_noxref_6_c_2286_p N_noxref_16_c_3734_n ) capacitor c=0.00234099f \
 //x=24.42 //y=2.08 //x2=25.53 //y2=0
cc_1611 ( N_noxref_6_c_1984_n N_noxref_16_c_3736_n ) capacitor c=0.00849484f \
 //x=1.11 //y=2.195 //x2=1.075 //y2=0.965
cc_1612 ( N_noxref_6_c_1989_n N_noxref_16_c_3736_n ) capacitor c=5.61356e-19 \
 //x=1.11 //y=4.24 //x2=1.075 //y2=0.965
cc_1613 ( N_noxref_6_c_2027_n N_noxref_16_c_3736_n ) capacitor c=2.22861e-19 \
 //x=1.11 //y=2.08 //x2=1.075 //y2=0.965
cc_1614 ( N_noxref_6_c_2041_n N_noxref_16_c_3736_n ) capacitor c=0.00142616f \
 //x=0.81 //y=0.875 //x2=1.075 //y2=0.965
cc_1615 ( N_noxref_6_c_2042_n N_noxref_16_c_3736_n ) capacitor c=0.00411286f \
 //x=0.81 //y=1.22 //x2=1.075 //y2=0.965
cc_1616 ( N_noxref_6_c_2043_n N_noxref_16_c_3736_n ) capacitor c=4.60246e-19 \
 //x=0.81 //y=1.53 //x2=1.075 //y2=0.965
cc_1617 ( N_noxref_6_c_2327_p N_noxref_16_c_3736_n ) capacitor c=7.3749e-19 \
 //x=1.185 //y=0.72 //x2=1.075 //y2=0.965
cc_1618 ( N_noxref_6_c_2342_p N_noxref_16_c_3736_n ) capacitor c=6.09813e-19 \
 //x=1.185 //y=1.375 //x2=1.075 //y2=0.965
cc_1619 ( N_noxref_6_c_2047_n N_noxref_16_c_3736_n ) capacitor c=0.0017438f \
 //x=1.34 //y=0.875 //x2=1.075 //y2=0.965
cc_1620 ( N_noxref_6_c_2049_n N_noxref_16_c_3736_n ) capacitor c=0.00276804f \
 //x=1.34 //y=1.22 //x2=1.075 //y2=0.965
cc_1621 ( N_noxref_6_c_2117_n N_noxref_16_c_3664_n ) capacitor c=0.00543195f \
 //x=16.535 //y=1.125 //x2=18.835 //y2=0.965
cc_1622 ( N_noxref_6_c_2041_n N_noxref_16_c_3578_n ) capacitor c=0.00678001f \
 //x=0.81 //y=0.875 //x2=4.64 //y2=0
cc_1623 ( N_noxref_6_c_1984_n N_noxref_16_c_3748_n ) capacitor c=0.00779049f \
 //x=1.11 //y=2.195 //x2=0.74 //y2=0
cc_1624 ( N_noxref_6_c_1862_n N_noxref_16_c_3748_n ) capacitor c=0.0126319f \
 //x=1.11 //y=3.92 //x2=0.74 //y2=0
cc_1625 ( N_noxref_6_c_2027_n N_noxref_16_c_3748_n ) capacitor c=0.00394776f \
 //x=1.11 //y=2.08 //x2=0.74 //y2=0
cc_1626 ( N_noxref_6_c_2043_n N_noxref_16_c_3748_n ) capacitor c=0.00295461f \
 //x=0.81 //y=1.53 //x2=0.74 //y2=0
cc_1627 ( N_noxref_6_c_2044_n N_noxref_16_c_3748_n ) capacitor c=0.0112432f \
 //x=0.81 //y=1.915 //x2=0.74 //y2=0
cc_1628 ( N_noxref_6_c_1880_n N_noxref_16_c_3581_n ) capacitor c=3.77673e-19 \
 //x=11.47 //y=2.08 //x2=12.78 //y2=0
cc_1629 ( N_noxref_6_c_2130_n N_noxref_16_c_3623_n ) capacitor c=6.86937e-19 \
 //x=16.935 //y=1.665 //x2=17.59 //y2=0
cc_1630 ( N_noxref_6_c_2286_p N_noxref_16_c_3755_n ) capacitor c=3.77673e-19 \
 //x=24.42 //y=2.08 //x2=25.53 //y2=0
cc_1631 ( N_noxref_6_c_2288_p N_noxref_16_c_3755_n ) capacitor c=0.00224736f \
 //x=24.42 //y=2.08 //x2=25.53 //y2=0
cc_1632 ( N_noxref_6_c_2322_p N_noxref_16_c_3755_n ) capacitor c=0.0028807f \
 //x=24.985 //y=1.25 //x2=25.53 //y2=0
cc_1633 ( N_noxref_6_c_2289_p N_noxref_16_c_3755_n ) capacitor c=2.63786e-19 \
 //x=24.42 //y=2.08 //x2=25.53 //y2=0
cc_1634 ( N_noxref_6_c_1894_n N_noxref_16_c_3625_n ) capacitor c=0.00207214f \
 //x=11.47 //y=2.08 //x2=12.95 //y2=0
cc_1635 ( N_noxref_6_c_1913_n N_noxref_16_c_3625_n ) capacitor c=0.00275184f \
 //x=12.035 //y=1.25 //x2=12.95 //y2=0
cc_1636 ( N_noxref_6_c_1914_n N_noxref_16_c_3625_n ) capacitor c=2.63786e-19 \
 //x=11.47 //y=2.08 //x2=12.95 //y2=0
cc_1637 ( N_noxref_6_c_1933_n N_noxref_16_c_3684_n ) capacitor c=0.0045138f \
 //x=16.535 //y=1.58 //x2=17.76 //y2=0
cc_1638 ( N_noxref_6_c_2130_n N_noxref_16_c_3684_n ) capacitor c=0.0337719f \
 //x=16.935 //y=1.665 //x2=17.76 //y2=0
cc_1639 ( N_noxref_6_c_2097_n N_noxref_16_c_3764_n ) capacitor c=0.00353812f \
 //x=19.075 //y=4.085 //x2=22.57 //y2=0
cc_1640 ( N_noxref_6_c_1984_n N_noxref_16_M0_noxref_d ) capacitor c=4.4417e-19 \
 //x=1.11 //y=2.195 //x2=0.885 //y2=0.875
cc_1641 ( N_noxref_6_c_2041_n N_noxref_16_M0_noxref_d ) capacitor \
 c=0.00184354f //x=0.81 //y=0.875 //x2=0.885 //y2=0.875
cc_1642 ( N_noxref_6_c_2042_n N_noxref_16_M0_noxref_d ) capacitor \
 c=0.00210798f //x=0.81 //y=1.22 //x2=0.885 //y2=0.875
cc_1643 ( N_noxref_6_c_2327_p N_noxref_16_M0_noxref_d ) capacitor \
 c=0.00474029f //x=1.185 //y=0.72 //x2=0.885 //y2=0.875
cc_1644 ( N_noxref_6_c_2342_p N_noxref_16_M0_noxref_d ) capacitor \
 c=0.00166857f //x=1.185 //y=1.375 //x2=0.885 //y2=0.875
cc_1645 ( N_noxref_6_c_2047_n N_noxref_16_M0_noxref_d ) capacitor \
 c=0.00230174f //x=1.34 //y=0.875 //x2=0.885 //y2=0.875
cc_1646 ( N_noxref_6_c_2049_n N_noxref_16_M0_noxref_d ) capacitor \
 c=0.00210798f //x=1.34 //y=1.22 //x2=0.885 //y2=0.875
cc_1647 ( N_noxref_6_c_2295_p N_noxref_17_c_4015_n ) capacitor c=0.00405363f \
 //x=24.42 //y=4.235 //x2=24.565 //y2=5.2
cc_1648 ( N_noxref_6_c_2280_p N_noxref_17_c_4015_n ) capacitor c=0.0220515f \
 //x=24.42 //y=4.555 //x2=24.565 //y2=5.2
cc_1649 ( N_noxref_6_c_2097_n N_noxref_17_c_4015_n ) capacitor c=0.00278899f \
 //x=19.075 //y=4.085 //x2=24.565 //y2=5.2
cc_1650 ( N_noxref_6_c_2210_p N_noxref_17_c_4015_n ) capacitor c=0.00469257f \
 //x=24.45 //y=4.7 //x2=24.565 //y2=5.2
cc_1651 ( N_noxref_6_M46_noxref_g N_noxref_17_c_4015_n ) capacitor \
 c=0.00842859f //x=24.46 //y=6.02 //x2=24.565 //y2=5.2
cc_1652 ( N_noxref_6_c_2212_p N_noxref_17_c_4015_n ) capacitor c=8.41897e-19 \
 //x=24.45 //y=4.7 //x2=24.565 //y2=5.2
cc_1653 ( N_noxref_6_c_2312_p N_noxref_17_c_4021_n ) capacitor c=0.00119302f \
 //x=24.455 //y=1.25 //x2=24.72 //y2=1.57
cc_1654 ( N_noxref_6_c_2313_p N_noxref_17_c_4021_n ) capacitor c=0.00439215f \
 //x=24.455 //y=1.56 //x2=24.72 //y2=1.57
cc_1655 ( N_noxref_6_c_2379_p N_noxref_17_c_4021_n ) capacitor c=0.00929773f \
 //x=24.83 //y=1.405 //x2=24.72 //y2=1.57
cc_1656 ( N_noxref_6_c_2322_p N_noxref_17_c_4021_n ) capacitor c=0.00341295f \
 //x=24.985 //y=1.25 //x2=24.72 //y2=1.57
cc_1657 ( N_noxref_6_c_2381_p N_noxref_17_c_4021_n ) capacitor c=0.00341688f \
 //x=24.42 //y=1.915 //x2=24.72 //y2=1.57
cc_1658 ( N_noxref_6_M47_noxref_g N_noxref_17_c_4026_n ) capacitor \
 c=0.0115937f //x=24.9 //y=6.02 //x2=25.075 //y2=5.2
cc_1659 ( N_noxref_6_c_2379_p N_noxref_17_c_4027_n ) capacitor c=0.00194324f \
 //x=24.83 //y=1.405 //x2=25.075 //y2=1.655
cc_1660 ( N_noxref_6_c_2322_p N_noxref_17_c_4027_n ) capacitor c=0.00323005f \
 //x=24.985 //y=1.25 //x2=25.075 //y2=1.655
cc_1661 ( N_noxref_6_c_2279_p N_noxref_17_c_4029_n ) capacitor c=0.0804492f \
 //x=24.42 //y=3.915 //x2=25.16 //y2=5.115
cc_1662 ( N_noxref_6_c_2295_p N_noxref_17_c_4029_n ) capacitor c=0.0146042f \
 //x=24.42 //y=4.235 //x2=25.16 //y2=5.115
cc_1663 ( N_noxref_6_c_2280_p N_noxref_17_c_4029_n ) capacitor c=0.030903f \
 //x=24.42 //y=4.555 //x2=25.16 //y2=5.115
cc_1664 ( N_noxref_6_c_2209_p N_noxref_17_c_4029_n ) capacitor c=0.00468658f \
 //x=24.42 //y=4.07 //x2=25.16 //y2=5.115
cc_1665 ( N_noxref_6_c_2286_p N_noxref_17_c_4029_n ) capacitor c=0.015397f \
 //x=24.42 //y=2.08 //x2=25.16 //y2=5.115
cc_1666 ( N_noxref_6_c_2097_n N_noxref_17_c_4029_n ) capacitor c=0.00680075f \
 //x=19.075 //y=4.085 //x2=25.16 //y2=5.115
cc_1667 ( N_noxref_6_c_2288_p N_noxref_17_c_4029_n ) capacitor c=0.00440663f \
 //x=24.42 //y=2.08 //x2=25.16 //y2=5.115
cc_1668 ( N_noxref_6_c_2210_p N_noxref_17_c_4029_n ) capacitor c=0.00448306f \
 //x=24.45 //y=4.7 //x2=25.16 //y2=5.115
cc_1669 ( N_noxref_6_c_2211_p N_noxref_17_c_4029_n ) capacitor c=0.00461871f \
 //x=24.825 //y=4.79 //x2=25.16 //y2=5.115
cc_1670 ( N_noxref_6_c_2289_p N_noxref_17_c_4029_n ) capacitor c=0.00271446f \
 //x=24.42 //y=2.08 //x2=25.16 //y2=5.115
cc_1671 ( N_noxref_6_c_2212_p N_noxref_17_c_4029_n ) capacitor c=0.00142201f \
 //x=24.45 //y=4.7 //x2=25.16 //y2=5.115
cc_1672 ( N_noxref_6_c_2097_n N_noxref_17_c_4040_n ) capacitor c=0.0138219f \
 //x=19.075 //y=4.085 //x2=23.8 //y2=5.38
cc_1673 ( N_noxref_6_M46_noxref_g N_noxref_17_c_4041_n ) capacitor \
 c=0.00192712f //x=24.46 //y=6.02 //x2=24.68 //y2=5.2
cc_1674 ( N_noxref_6_M47_noxref_g N_noxref_17_c_4041_n ) capacitor \
 c=0.00362563f //x=24.9 //y=6.02 //x2=24.68 //y2=5.2
cc_1675 ( N_noxref_6_c_2211_p N_noxref_17_c_4041_n ) capacitor c=0.0020909f \
 //x=24.825 //y=4.79 //x2=24.68 //y2=5.2
cc_1676 ( N_noxref_6_c_2310_p N_noxref_17_c_4044_n ) capacitor c=0.00120406f \
 //x=24.455 //y=0.905 //x2=24.72 //y2=1
cc_1677 ( N_noxref_6_c_2312_p N_noxref_17_c_4044_n ) capacitor c=0.00218772f \
 //x=24.455 //y=1.25 //x2=24.72 //y2=1
cc_1678 ( N_noxref_6_c_2402_p N_noxref_17_c_4044_n ) capacitor c=5.50523e-19 \
 //x=24.83 //y=0.75 //x2=24.72 //y2=1
cc_1679 ( N_noxref_6_c_2379_p N_noxref_17_c_4044_n ) capacitor c=5.67071e-19 \
 //x=24.83 //y=1.405 //x2=24.72 //y2=1
cc_1680 ( N_noxref_6_c_2319_p N_noxref_17_c_4044_n ) capacitor c=0.00121175f \
 //x=24.985 //y=0.905 //x2=24.72 //y2=1
cc_1681 ( N_noxref_6_c_2322_p N_noxref_17_c_4044_n ) capacitor c=0.00366282f \
 //x=24.985 //y=1.25 //x2=24.72 //y2=1
cc_1682 ( N_noxref_6_M46_noxref_g N_noxref_17_c_4050_n ) capacitor \
 c=0.0178987f //x=24.46 //y=6.02 //x2=24.68 //y2=5.38
cc_1683 ( N_noxref_6_M47_noxref_g N_noxref_17_c_4050_n ) capacitor \
 c=0.0178506f //x=24.9 //y=6.02 //x2=24.68 //y2=5.38
cc_1684 ( N_noxref_6_c_2211_p N_noxref_17_c_4050_n ) capacitor c=0.00291714f \
 //x=24.825 //y=4.79 //x2=24.68 //y2=5.38
cc_1685 ( N_noxref_6_c_2310_p N_noxref_17_M15_noxref_d ) capacitor \
 c=0.00137165f //x=24.455 //y=0.905 //x2=24.53 //y2=0.905
cc_1686 ( N_noxref_6_c_2312_p N_noxref_17_M15_noxref_d ) capacitor \
 c=0.00237422f //x=24.455 //y=1.25 //x2=24.53 //y2=0.905
cc_1687 ( N_noxref_6_c_2402_p N_noxref_17_M15_noxref_d ) capacitor \
 c=0.0020782f //x=24.83 //y=0.75 //x2=24.53 //y2=0.905
cc_1688 ( N_noxref_6_c_2379_p N_noxref_17_M15_noxref_d ) capacitor \
 c=0.00356097f //x=24.83 //y=1.405 //x2=24.53 //y2=0.905
cc_1689 ( N_noxref_6_c_2319_p N_noxref_17_M15_noxref_d ) capacitor \
 c=8.50095e-19 //x=24.985 //y=0.905 //x2=24.53 //y2=0.905
cc_1690 ( N_noxref_6_c_2322_p N_noxref_17_M15_noxref_d ) capacitor \
 c=0.00237422f //x=24.985 //y=1.25 //x2=24.53 //y2=0.905
cc_1691 ( N_noxref_6_c_2044_n N_noxref_18_c_4138_n ) capacitor c=0.00267608f \
 //x=0.81 //y=1.915 //x2=0.59 //y2=1.505
cc_1692 ( N_noxref_6_c_1984_n N_noxref_18_c_4139_n ) capacitor c=0.00428451f \
 //x=1.11 //y=2.195 //x2=1.475 //y2=1.59
cc_1693 ( N_noxref_6_c_1989_n N_noxref_18_c_4139_n ) capacitor c=0.00107729f \
 //x=1.11 //y=4.24 //x2=1.475 //y2=1.59
cc_1694 ( N_noxref_6_c_2027_n N_noxref_18_c_4139_n ) capacitor c=0.0104666f \
 //x=1.11 //y=2.08 //x2=1.475 //y2=1.59
cc_1695 ( N_noxref_6_c_2043_n N_noxref_18_c_4139_n ) capacitor c=0.00703864f \
 //x=0.81 //y=1.53 //x2=1.475 //y2=1.59
cc_1696 ( N_noxref_6_c_2044_n N_noxref_18_c_4139_n ) capacitor c=0.0232409f \
 //x=0.81 //y=1.915 //x2=1.475 //y2=1.59
cc_1697 ( N_noxref_6_c_2342_p N_noxref_18_c_4139_n ) capacitor c=0.00588627f \
 //x=1.185 //y=1.375 //x2=1.475 //y2=1.59
cc_1698 ( N_noxref_6_c_2049_n N_noxref_18_c_4139_n ) capacitor c=0.00698822f \
 //x=1.34 //y=1.22 //x2=1.475 //y2=1.59
cc_1699 ( N_noxref_6_c_2041_n N_noxref_18_M0_noxref_s ) capacitor c=0.0295256f \
 //x=0.81 //y=0.875 //x2=0.455 //y2=0.375
cc_1700 ( N_noxref_6_c_2043_n N_noxref_18_M0_noxref_s ) capacitor \
 c=7.99997e-19 //x=0.81 //y=1.53 //x2=0.455 //y2=0.375
cc_1701 ( N_noxref_6_c_2044_n N_noxref_18_M0_noxref_s ) capacitor \
 c=0.00122123f //x=0.81 //y=1.915 //x2=0.455 //y2=0.375
cc_1702 ( N_noxref_6_c_2047_n N_noxref_18_M0_noxref_s ) capacitor c=0.0125924f \
 //x=1.34 //y=0.875 //x2=0.455 //y2=0.375
cc_1703 ( N_noxref_6_c_1873_n N_noxref_20_c_4246_n ) capacitor c=9.49001e-19 \
 //x=11.47 //y=4.23 //x2=11.285 //y2=1.495
cc_1704 ( N_noxref_6_c_1880_n N_noxref_20_c_4246_n ) capacitor c=7.50092e-19 \
 //x=11.47 //y=2.08 //x2=11.285 //y2=1.495
cc_1705 ( N_noxref_6_c_1909_n N_noxref_20_c_4246_n ) capacitor c=0.00888238f \
 //x=11.505 //y=1.56 //x2=11.285 //y2=1.495
cc_1706 ( N_noxref_6_c_1914_n N_noxref_20_c_4246_n ) capacitor c=0.00175171f \
 //x=11.47 //y=2.08 //x2=11.285 //y2=1.495
cc_1707 ( N_noxref_6_c_1880_n N_noxref_20_c_4251_n ) capacitor c=0.001463f \
 //x=11.47 //y=2.08 //x2=12.17 //y2=0.53
cc_1708 ( N_noxref_6_c_1894_n N_noxref_20_c_4251_n ) capacitor c=8.82141e-19 \
 //x=11.47 //y=2.08 //x2=12.17 //y2=0.53
cc_1709 ( N_noxref_6_c_1904_n N_noxref_20_c_4251_n ) capacitor c=0.0200738f \
 //x=11.505 //y=0.905 //x2=12.17 //y2=0.53
cc_1710 ( N_noxref_6_c_1912_n N_noxref_20_c_4251_n ) capacitor c=0.00825432f \
 //x=12.035 //y=0.905 //x2=12.17 //y2=0.53
cc_1711 ( N_noxref_6_c_1914_n N_noxref_20_c_4251_n ) capacitor c=2.1838e-19 \
 //x=11.47 //y=2.08 //x2=12.17 //y2=0.53
cc_1712 ( N_noxref_6_c_1904_n N_noxref_20_M6_noxref_s ) capacitor \
 c=0.00888238f //x=11.505 //y=0.905 //x2=10.18 //y2=0.365
cc_1713 ( N_noxref_6_c_1912_n N_noxref_20_M6_noxref_s ) capacitor c=0.015333f \
 //x=12.035 //y=0.905 //x2=10.18 //y2=0.365
cc_1714 ( N_noxref_6_c_1913_n N_noxref_20_M6_noxref_s ) capacitor \
 c=0.00248746f //x=12.035 //y=1.25 //x2=10.18 //y2=0.365
cc_1715 ( N_noxref_6_c_2295_p N_noxref_23_c_4422_n ) capacitor c=7.81159e-19 \
 //x=24.42 //y=4.235 //x2=24.235 //y2=1.495
cc_1716 ( N_noxref_6_c_2286_p N_noxref_23_c_4422_n ) capacitor c=7.50092e-19 \
 //x=24.42 //y=2.08 //x2=24.235 //y2=1.495
cc_1717 ( N_noxref_6_c_2313_p N_noxref_23_c_4422_n ) capacitor c=0.00890678f \
 //x=24.455 //y=1.56 //x2=24.235 //y2=1.495
cc_1718 ( N_noxref_6_c_2289_p N_noxref_23_c_4422_n ) capacitor c=0.00175171f \
 //x=24.42 //y=2.08 //x2=24.235 //y2=1.495
cc_1719 ( N_noxref_6_c_2286_p N_noxref_23_c_4426_n ) capacitor c=0.001463f \
 //x=24.42 //y=2.08 //x2=25.12 //y2=0.53
cc_1720 ( N_noxref_6_c_2288_p N_noxref_23_c_4426_n ) capacitor c=8.82141e-19 \
 //x=24.42 //y=2.08 //x2=25.12 //y2=0.53
cc_1721 ( N_noxref_6_c_2310_p N_noxref_23_c_4426_n ) capacitor c=0.0200072f \
 //x=24.455 //y=0.905 //x2=25.12 //y2=0.53
cc_1722 ( N_noxref_6_c_2319_p N_noxref_23_c_4426_n ) capacitor c=0.00825432f \
 //x=24.985 //y=0.905 //x2=25.12 //y2=0.53
cc_1723 ( N_noxref_6_c_2289_p N_noxref_23_c_4426_n ) capacitor c=2.1838e-19 \
 //x=24.42 //y=2.08 //x2=25.12 //y2=0.53
cc_1724 ( N_noxref_6_c_2310_p N_noxref_23_M14_noxref_s ) capacitor \
 c=0.00890678f //x=24.455 //y=0.905 //x2=23.13 //y2=0.365
cc_1725 ( N_noxref_6_c_2319_p N_noxref_23_M14_noxref_s ) capacitor c=0.015333f \
 //x=24.985 //y=0.905 //x2=23.13 //y2=0.365
cc_1726 ( N_noxref_6_c_2322_p N_noxref_23_M14_noxref_s ) capacitor \
 c=0.00248746f //x=24.985 //y=1.25 //x2=23.13 //y2=0.365
cc_1727 ( N_noxref_7_c_2469_n N_noxref_10_M24_noxref_g ) capacitor \
 c=0.00700336f //x=7.575 //y=7.4 //x2=7 //y2=6.02
cc_1728 ( N_noxref_7_M23_noxref_d N_noxref_10_M24_noxref_g ) capacitor \
 c=0.015318f //x=6.635 //y=5.02 //x2=7 //y2=6.02
cc_1729 ( N_noxref_7_c_2469_n N_noxref_10_M25_noxref_g ) capacitor \
 c=0.00749619f //x=7.575 //y=7.4 //x2=7.44 //y2=6.02
cc_1730 ( N_noxref_7_M25_noxref_d N_noxref_10_M25_noxref_g ) capacitor \
 c=0.015318f //x=7.515 //y=5.02 //x2=7.44 //y2=6.02
cc_1731 ( N_noxref_7_c_2712_n N_noxref_13_c_3241_n ) capacitor c=0.00224736f \
 //x=22.57 //y=7.4 //x2=21.09 //y2=4.7
cc_1732 ( N_noxref_7_c_2749_p N_noxref_13_M42_noxref_g ) capacitor \
 c=0.00749619f //x=21.405 //y=7.4 //x2=20.83 //y2=6.02
cc_1733 ( N_noxref_7_M41_noxref_d N_noxref_13_M42_noxref_g ) capacitor \
 c=0.015318f //x=20.465 //y=5.02 //x2=20.83 //y2=6.02
cc_1734 ( N_noxref_7_c_2749_p N_noxref_13_M43_noxref_g ) capacitor \
 c=0.00749823f //x=21.405 //y=7.4 //x2=21.27 //y2=6.02
cc_1735 ( N_noxref_7_M43_noxref_d N_noxref_13_M43_noxref_g ) capacitor \
 c=0.0394719f //x=21.345 //y=5.02 //x2=21.27 //y2=6.02
cc_1736 ( N_noxref_7_c_2712_n N_noxref_13_c_3254_n ) capacitor c=2.63786e-19 \
 //x=22.57 //y=7.4 //x2=21.09 //y2=4.7
cc_1737 ( N_noxref_7_c_2451_n N_noxref_14_c_3321_n ) capacitor c=0.00620651f \
 //x=25.53 //y=7.4 //x2=20.05 //y2=5.155
cc_1738 ( N_noxref_7_c_2602_n N_noxref_14_c_3321_n ) capacitor c=0.00202948f \
 //x=19.645 //y=7.4 //x2=20.05 //y2=5.155
cc_1739 ( N_noxref_7_c_2643_n N_noxref_14_c_3321_n ) capacitor c=0.00177088f \
 //x=20.525 //y=7.4 //x2=20.05 //y2=5.155
cc_1740 ( N_noxref_7_M39_noxref_d N_noxref_14_c_3321_n ) capacitor \
 c=0.00700078f //x=19.585 //y=5.02 //x2=20.05 //y2=5.155
cc_1741 ( N_noxref_7_c_2451_n N_noxref_14_c_3333_n ) capacitor c=0.00626474f \
 //x=25.53 //y=7.4 //x2=20.935 //y2=5.155
cc_1742 ( N_noxref_7_c_2643_n N_noxref_14_c_3333_n ) capacitor c=0.00202948f \
 //x=20.525 //y=7.4 //x2=20.935 //y2=5.155
cc_1743 ( N_noxref_7_c_2749_p N_noxref_14_c_3333_n ) capacitor c=0.00205929f \
 //x=21.405 //y=7.4 //x2=20.935 //y2=5.155
cc_1744 ( N_noxref_7_M41_noxref_d N_noxref_14_c_3333_n ) capacitor \
 c=0.00700078f //x=20.465 //y=5.02 //x2=20.935 //y2=5.155
cc_1745 ( N_noxref_7_c_2451_n N_noxref_14_c_3361_n ) capacitor c=0.00255604f \
 //x=25.53 //y=7.4 //x2=21.05 //y2=5.38
cc_1746 ( N_noxref_7_c_2749_p N_noxref_14_c_3361_n ) capacitor c=8.49349e-19 \
 //x=21.405 //y=7.4 //x2=21.05 //y2=5.38
cc_1747 ( N_noxref_7_c_2712_n N_noxref_14_c_3361_n ) capacitor c=0.00269779f \
 //x=22.57 //y=7.4 //x2=21.05 //y2=5.38
cc_1748 ( N_noxref_7_M44_noxref_s N_noxref_14_c_3361_n ) capacitor \
 c=0.00536022f //x=23.225 //y=5.02 //x2=21.05 //y2=5.38
cc_1749 ( N_noxref_7_c_2451_n N_noxref_14_c_3344_n ) capacitor c=0.00822764f \
 //x=25.53 //y=7.4 //x2=21.745 //y2=5.155
cc_1750 ( N_noxref_7_c_2749_p N_noxref_14_c_3344_n ) capacitor c=0.00204261f \
 //x=21.405 //y=7.4 //x2=21.745 //y2=5.155
cc_1751 ( N_noxref_7_c_2768_p N_noxref_14_c_3344_n ) capacitor c=0.00183429f \
 //x=22.4 //y=7.4 //x2=21.745 //y2=5.155
cc_1752 ( N_noxref_7_M43_noxref_d N_noxref_14_c_3344_n ) capacitor \
 c=0.00700078f //x=21.345 //y=5.02 //x2=21.745 //y2=5.155
cc_1753 ( N_noxref_7_M44_noxref_s N_noxref_14_c_3344_n ) capacitor \
 c=0.00271757f //x=23.225 //y=5.02 //x2=21.745 //y2=5.155
cc_1754 ( N_noxref_7_c_2712_n N_noxref_14_c_3334_n ) capacitor c=0.0363959f \
 //x=22.57 //y=7.4 //x2=21.83 //y2=5.07
cc_1755 ( N_noxref_7_c_2451_n N_noxref_14_c_3322_n ) capacitor c=0.00261379f \
 //x=25.53 //y=7.4 //x2=19.292 //y2=5.155
cc_1756 ( N_noxref_7_c_2602_n N_noxref_14_c_3322_n ) capacitor c=9.37357e-19 \
 //x=19.645 //y=7.4 //x2=19.292 //y2=5.155
cc_1757 ( N_noxref_7_c_2610_n N_noxref_14_c_3322_n ) capacitor c=0.0022955f \
 //x=17.76 //y=7.4 //x2=19.292 //y2=5.155
cc_1758 ( N_noxref_7_M38_noxref_s N_noxref_14_c_3322_n ) capacitor \
 c=0.0441176f //x=18.715 //y=5.02 //x2=19.292 //y2=5.155
cc_1759 ( N_noxref_7_c_2451_n N_noxref_14_c_3335_n ) capacitor c=0.0026965f \
 //x=25.53 //y=7.4 //x2=20.17 //y2=5.155
cc_1760 ( N_noxref_7_c_2643_n N_noxref_14_c_3335_n ) capacitor c=9.47876e-19 \
 //x=20.525 //y=7.4 //x2=20.17 //y2=5.155
cc_1761 ( N_noxref_7_M38_noxref_s N_noxref_14_c_3335_n ) capacitor \
 c=7.80122e-19 //x=18.715 //y=5.02 //x2=20.17 //y2=5.155
cc_1762 ( N_noxref_7_c_2451_n N_noxref_14_c_3325_n ) capacitor c=0.00242194f \
 //x=25.53 //y=7.4 //x2=19.29 //y2=5.38
cc_1763 ( N_noxref_7_c_2602_n N_noxref_14_c_3325_n ) capacitor c=0.0137846f \
 //x=19.645 //y=7.4 //x2=19.29 //y2=5.38
cc_1764 ( N_noxref_7_c_2610_n N_noxref_14_c_3325_n ) capacitor c=0.00509469f \
 //x=17.76 //y=7.4 //x2=19.29 //y2=5.38
cc_1765 ( N_noxref_7_M38_noxref_s N_noxref_14_c_3325_n ) capacitor c=0.09305f \
 //x=18.715 //y=5.02 //x2=19.29 //y2=5.38
cc_1766 ( N_noxref_7_M39_noxref_d N_noxref_14_c_3325_n ) capacitor \
 c=0.0674491f //x=19.585 //y=5.02 //x2=19.29 //y2=5.38
cc_1767 ( N_noxref_7_c_2451_n N_noxref_14_c_3340_n ) capacitor c=0.00242194f \
 //x=25.53 //y=7.4 //x2=20.17 //y2=5.38
cc_1768 ( N_noxref_7_c_2643_n N_noxref_14_c_3340_n ) capacitor c=0.0137846f \
 //x=20.525 //y=7.4 //x2=20.17 //y2=5.38
cc_1769 ( N_noxref_7_M39_noxref_d N_noxref_14_c_3340_n ) capacitor \
 c=0.0674762f //x=19.585 //y=5.02 //x2=20.17 //y2=5.38
cc_1770 ( N_noxref_7_M41_noxref_d N_noxref_14_c_3340_n ) capacitor c=0.067493f \
 //x=20.465 //y=5.02 //x2=20.17 //y2=5.38
cc_1771 ( N_noxref_7_c_2451_n N_noxref_14_c_3387_n ) capacitor c=0.00242194f \
 //x=25.53 //y=7.4 //x2=21.05 //y2=5.38
cc_1772 ( N_noxref_7_c_2749_p N_noxref_14_c_3387_n ) capacitor c=0.0137846f \
 //x=21.405 //y=7.4 //x2=21.05 //y2=5.38
cc_1773 ( N_noxref_7_c_2712_n N_noxref_14_c_3387_n ) capacitor c=0.00776541f \
 //x=22.57 //y=7.4 //x2=21.05 //y2=5.38
cc_1774 ( N_noxref_7_M41_noxref_d N_noxref_14_c_3387_n ) capacitor \
 c=0.0674288f //x=20.465 //y=5.02 //x2=21.05 //y2=5.38
cc_1775 ( N_noxref_7_M43_noxref_d N_noxref_14_c_3387_n ) capacitor \
 c=0.0673824f //x=21.345 //y=5.02 //x2=21.05 //y2=5.38
cc_1776 ( N_noxref_7_c_2451_n N_noxref_15_c_3461_n ) capacitor c=9.05427e-19 \
 //x=25.53 //y=7.4 //x2=23.68 //y2=4.7
cc_1777 ( N_noxref_7_c_2794_p N_noxref_15_c_3461_n ) capacitor c=6.28732e-19 \
 //x=24.155 //y=7.4 //x2=23.68 //y2=4.7
cc_1778 ( N_noxref_7_c_2712_n N_noxref_15_c_3461_n ) capacitor c=0.00447349f \
 //x=22.57 //y=7.4 //x2=23.68 //y2=4.7
cc_1779 ( N_noxref_7_c_2712_n N_noxref_15_c_3465_n ) capacitor c=0.00675188f \
 //x=22.57 //y=7.4 //x2=23.682 //y2=4.56
cc_1780 ( N_noxref_7_c_2451_n N_noxref_15_c_3475_n ) capacitor c=6.23118e-19 \
 //x=25.53 //y=7.4 //x2=23.68 //y2=4.7
cc_1781 ( N_noxref_7_c_2712_n N_noxref_15_c_3475_n ) capacitor c=0.00370494f \
 //x=22.57 //y=7.4 //x2=23.68 //y2=4.7
cc_1782 ( N_noxref_7_c_2794_p N_noxref_15_M44_noxref_g ) capacitor \
 c=0.0072715f //x=24.155 //y=7.4 //x2=23.58 //y2=6.02
cc_1783 ( N_noxref_7_M44_noxref_s N_noxref_15_M44_noxref_g ) capacitor \
 c=0.0567929f //x=23.225 //y=5.02 //x2=23.58 //y2=6.02
cc_1784 ( N_noxref_7_c_2794_p N_noxref_15_M45_noxref_g ) capacitor \
 c=0.00749619f //x=24.155 //y=7.4 //x2=24.02 //y2=6.02
cc_1785 ( N_noxref_7_M45_noxref_d N_noxref_15_M45_noxref_g ) capacitor \
 c=0.015318f //x=24.095 //y=5.02 //x2=24.02 //y2=6.02
cc_1786 ( N_noxref_7_c_2712_n N_noxref_15_c_3494_n ) capacitor c=0.0129564f \
 //x=22.57 //y=7.4 //x2=23.68 //y2=4.7
cc_1787 ( N_noxref_7_c_2586_n N_noxref_16_c_3748_n ) capacitor c=0.00989031f \
 //x=0.74 //y=7.4 //x2=0.74 //y2=0
cc_1788 ( N_noxref_7_c_2691_n N_noxref_16_c_3755_n ) capacitor c=0.00989031f \
 //x=25.53 //y=7.4 //x2=25.53 //y2=0
cc_1789 ( N_noxref_7_c_2481_n N_noxref_16_c_3582_n ) capacitor c=0.00654201f \
 //x=4.81 //y=7.4 //x2=4.81 //y2=0
cc_1790 ( N_noxref_7_c_2485_n N_noxref_16_c_3585_n ) capacitor c=0.00654201f \
 //x=9.62 //y=7.4 //x2=9.62 //y2=0
cc_1791 ( N_noxref_7_c_2532_n N_noxref_16_c_3625_n ) capacitor c=0.00654201f \
 //x=12.95 //y=7.4 //x2=12.95 //y2=0
cc_1792 ( N_noxref_7_c_2610_n N_noxref_16_c_3684_n ) capacitor c=0.00663522f \
 //x=17.76 //y=7.4 //x2=17.76 //y2=0
cc_1793 ( N_noxref_7_c_2712_n N_noxref_16_c_3764_n ) capacitor c=0.00654903f \
 //x=22.57 //y=7.4 //x2=22.57 //y2=0
cc_1794 ( N_noxref_7_c_2451_n N_noxref_17_c_4015_n ) capacitor c=0.00647526f \
 //x=25.53 //y=7.4 //x2=24.565 //y2=5.2
cc_1795 ( N_noxref_7_c_2794_p N_noxref_17_c_4015_n ) capacitor c=0.00208112f \
 //x=24.155 //y=7.4 //x2=24.565 //y2=5.2
cc_1796 ( N_noxref_7_c_2689_n N_noxref_17_c_4015_n ) capacitor c=0.00180744f \
 //x=25.035 //y=7.4 //x2=24.565 //y2=5.2
cc_1797 ( N_noxref_7_M45_noxref_d N_noxref_17_c_4015_n ) capacitor \
 c=0.00734028f //x=24.095 //y=5.02 //x2=24.565 //y2=5.2
cc_1798 ( N_noxref_7_c_2451_n N_noxref_17_c_4026_n ) capacitor c=0.0048744f \
 //x=25.53 //y=7.4 //x2=25.075 //y2=5.2
cc_1799 ( N_noxref_7_c_2689_n N_noxref_17_c_4026_n ) capacitor c=0.00213214f \
 //x=25.035 //y=7.4 //x2=25.075 //y2=5.2
cc_1800 ( N_noxref_7_M47_noxref_d N_noxref_17_c_4026_n ) capacitor \
 c=0.0125278f //x=24.975 //y=5.02 //x2=25.075 //y2=5.2
cc_1801 ( N_noxref_7_c_2691_n N_noxref_17_c_4029_n ) capacitor c=0.0384196f \
 //x=25.53 //y=7.4 //x2=25.16 //y2=5.115
cc_1802 ( N_noxref_7_c_2712_n N_noxref_17_c_4029_n ) capacitor c=6.19352e-19 \
 //x=22.57 //y=7.4 //x2=25.16 //y2=5.115
cc_1803 ( N_noxref_7_c_2451_n N_noxref_17_c_4040_n ) capacitor c=0.00368144f \
 //x=25.53 //y=7.4 //x2=23.8 //y2=5.38
cc_1804 ( N_noxref_7_c_2794_p N_noxref_17_c_4040_n ) capacitor c=9.41091e-19 \
 //x=24.155 //y=7.4 //x2=23.8 //y2=5.38
cc_1805 ( N_noxref_7_c_2712_n N_noxref_17_c_4040_n ) capacitor c=4.91377e-19 \
 //x=22.57 //y=7.4 //x2=23.8 //y2=5.38
cc_1806 ( N_noxref_7_M44_noxref_s N_noxref_17_c_4040_n ) capacitor \
 c=0.0616215f //x=23.225 //y=5.02 //x2=23.8 //y2=5.38
cc_1807 ( N_noxref_7_M45_noxref_d N_noxref_17_c_4040_n ) capacitor \
 c=0.0043528f //x=24.095 //y=5.02 //x2=23.8 //y2=5.38
cc_1808 ( N_noxref_7_c_2451_n N_noxref_17_c_4041_n ) capacitor c=8.41178e-19 \
 //x=25.53 //y=7.4 //x2=24.68 //y2=5.2
cc_1809 ( N_noxref_7_c_2689_n N_noxref_17_c_4041_n ) capacitor c=5.28963e-19 \
 //x=25.035 //y=7.4 //x2=24.68 //y2=5.2
cc_1810 ( N_noxref_7_c_2691_n N_noxref_17_c_4041_n ) capacitor c=0.00379179f \
 //x=25.53 //y=7.4 //x2=24.68 //y2=5.2
cc_1811 ( N_noxref_7_M44_noxref_s N_noxref_17_c_4041_n ) capacitor \
 c=6.52457e-19 //x=23.225 //y=5.02 //x2=24.68 //y2=5.2
cc_1812 ( N_noxref_7_c_2451_n N_noxref_17_c_4077_n ) capacitor c=0.00285294f \
 //x=25.53 //y=7.4 //x2=24.68 //y2=5.38
cc_1813 ( N_noxref_7_c_2689_n N_noxref_17_c_4077_n ) capacitor c=5.78261e-19 \
 //x=25.035 //y=7.4 //x2=24.68 //y2=5.38
cc_1814 ( N_noxref_7_c_2691_n N_noxref_17_c_4077_n ) capacitor c=0.0016115f \
 //x=25.53 //y=7.4 //x2=24.68 //y2=5.38
cc_1815 ( N_noxref_7_M45_noxref_d N_noxref_17_c_4077_n ) capacitor \
 c=0.0043528f //x=24.095 //y=5.02 //x2=24.68 //y2=5.38
cc_1816 ( N_noxref_7_M47_noxref_d N_noxref_17_c_4077_n ) capacitor \
 c=0.00979407f //x=24.975 //y=5.02 //x2=24.68 //y2=5.38
cc_1817 ( N_noxref_7_c_2451_n N_noxref_17_c_4082_n ) capacitor c=0.00224727f \
 //x=25.53 //y=7.4 //x2=23.8 //y2=5.38
cc_1818 ( N_noxref_7_c_2794_p N_noxref_17_c_4082_n ) capacitor c=0.0136475f \
 //x=24.155 //y=7.4 //x2=23.8 //y2=5.38
cc_1819 ( N_noxref_7_c_2712_n N_noxref_17_c_4082_n ) capacitor c=0.0064135f \
 //x=22.57 //y=7.4 //x2=23.8 //y2=5.38
cc_1820 ( N_noxref_7_M44_noxref_s N_noxref_17_c_4082_n ) capacitor \
 c=0.0887533f //x=23.225 //y=5.02 //x2=23.8 //y2=5.38
cc_1821 ( N_noxref_7_M45_noxref_d N_noxref_17_c_4082_n ) capacitor c=0.065554f \
 //x=24.095 //y=5.02 //x2=23.8 //y2=5.38
cc_1822 ( N_noxref_7_c_2451_n N_noxref_17_c_4050_n ) capacitor c=0.00224727f \
 //x=25.53 //y=7.4 //x2=24.68 //y2=5.38
cc_1823 ( N_noxref_7_c_2689_n N_noxref_17_c_4050_n ) capacitor c=0.0136475f \
 //x=25.035 //y=7.4 //x2=24.68 //y2=5.38
cc_1824 ( N_noxref_7_c_2691_n N_noxref_17_c_4050_n ) capacitor c=0.0101867f \
 //x=25.53 //y=7.4 //x2=24.68 //y2=5.38
cc_1825 ( N_noxref_7_M45_noxref_d N_noxref_17_c_4050_n ) capacitor c=0.065554f \
 //x=24.095 //y=5.02 //x2=24.68 //y2=5.38
cc_1826 ( N_noxref_7_M47_noxref_d N_noxref_17_c_4050_n ) capacitor c=0.065554f \
 //x=24.975 //y=5.02 //x2=24.68 //y2=5.38
cc_1827 ( N_noxref_8_c_2854_n N_noxref_16_c_3560_n ) capacitor c=0.00789826f \
 //x=3.015 //y=0.995 //x2=5.8 //y2=0
cc_1828 ( N_noxref_8_c_2881_p N_noxref_16_c_3560_n ) capacitor c=0.00672108f \
 //x=3.1 //y=0.625 //x2=5.8 //y2=0
cc_1829 ( N_noxref_8_c_2844_n N_noxref_16_c_3560_n ) capacitor c=0.00957811f \
 //x=3.985 //y=0.54 //x2=5.8 //y2=0
cc_1830 ( N_noxref_8_c_2883_p N_noxref_16_c_3560_n ) capacitor c=0.00232857f \
 //x=4.07 //y=0.625 //x2=5.8 //y2=0
cc_1831 ( N_noxref_8_M1_noxref_d N_noxref_16_c_3560_n ) capacitor c=0.013411f \
 //x=1.86 //y=0.91 //x2=5.8 //y2=0
cc_1832 ( N_noxref_8_M1_noxref_d N_noxref_16_c_3736_n ) capacitor c=0.0156367f \
 //x=1.86 //y=0.91 //x2=1.075 //y2=0.965
cc_1833 ( N_noxref_8_c_2854_n N_noxref_16_c_3578_n ) capacitor c=0.00807048f \
 //x=3.015 //y=0.995 //x2=4.64 //y2=0
cc_1834 ( N_noxref_8_c_2881_p N_noxref_16_c_3578_n ) capacitor c=0.0140476f \
 //x=3.1 //y=0.625 //x2=4.64 //y2=0
cc_1835 ( N_noxref_8_c_2844_n N_noxref_16_c_3578_n ) capacitor c=0.036459f \
 //x=3.985 //y=0.54 //x2=4.64 //y2=0
cc_1836 ( N_noxref_8_c_2883_p N_noxref_16_c_3578_n ) capacitor c=0.0138658f \
 //x=4.07 //y=0.625 //x2=4.64 //y2=0
cc_1837 ( N_noxref_8_M2_noxref_s N_noxref_16_c_3748_n ) capacitor \
 c=8.16352e-19 //x=2.965 //y=0.375 //x2=0.74 //y2=0
cc_1838 ( N_noxref_8_c_2844_n N_noxref_16_c_3755_n ) capacitor c=0.00189358f \
 //x=3.985 //y=0.54 //x2=25.53 //y2=0
cc_1839 ( N_noxref_8_M1_noxref_d N_noxref_16_c_3755_n ) capacitor c=2.7648e-19 \
 //x=1.86 //y=0.91 //x2=25.53 //y2=0
cc_1840 ( N_noxref_8_c_2883_p N_noxref_16_c_3582_n ) capacitor c=0.037873f \
 //x=4.07 //y=0.625 //x2=4.81 //y2=0
cc_1841 ( N_noxref_8_M2_noxref_s N_noxref_16_c_3582_n ) capacitor c=0.0051897f \
 //x=2.965 //y=0.375 //x2=4.81 //y2=0
cc_1842 ( N_noxref_8_M1_noxref_d N_noxref_16_M0_noxref_d ) capacitor \
 c=3.12752e-19 //x=1.86 //y=0.91 //x2=0.885 //y2=0.875
cc_1843 ( N_noxref_8_c_2881_p N_noxref_18_c_4150_n ) capacitor c=2.15937e-19 \
 //x=3.1 //y=0.625 //x2=1.56 //y2=0.625
cc_1844 ( N_noxref_8_c_2854_n N_noxref_18_c_4128_n ) capacitor c=0.0132582f \
 //x=3.015 //y=0.995 //x2=2.445 //y2=0.54
cc_1845 ( N_noxref_8_M1_noxref_d N_noxref_18_c_4128_n ) capacitor c=0.016458f \
 //x=1.86 //y=0.91 //x2=2.445 //y2=0.54
cc_1846 ( N_noxref_8_c_2854_n N_noxref_18_c_4130_n ) capacitor c=0.00954209f \
 //x=3.015 //y=0.995 //x2=2.445 //y2=1.59
cc_1847 ( N_noxref_8_M1_noxref_d N_noxref_18_c_4130_n ) capacitor c=0.0152674f \
 //x=1.86 //y=0.91 //x2=2.445 //y2=1.59
cc_1848 ( N_noxref_8_c_2854_n N_noxref_18_M0_noxref_s ) capacitor c=0.023368f \
 //x=3.015 //y=0.995 //x2=0.455 //y2=0.375
cc_1849 ( N_noxref_8_c_2881_p N_noxref_18_M0_noxref_s ) capacitor c=0.0175461f \
 //x=3.1 //y=0.625 //x2=0.455 //y2=0.375
cc_1850 ( N_noxref_8_c_2883_p N_noxref_18_M0_noxref_s ) capacitor \
 c=2.98576e-19 //x=4.07 //y=0.625 //x2=0.455 //y2=0.375
cc_1851 ( N_noxref_8_M1_noxref_d N_noxref_18_M0_noxref_s ) capacitor \
 c=0.0187969f //x=1.86 //y=0.91 //x2=0.455 //y2=0.375
cc_1852 ( N_noxref_8_M2_noxref_s N_noxref_18_M0_noxref_s ) capacitor \
 c=0.0210819f //x=2.965 //y=0.375 //x2=0.455 //y2=0.375
cc_1853 ( N_noxref_8_c_2883_p N_noxref_19_M3_noxref_s ) capacitor \
 c=0.00368328f //x=4.07 //y=0.625 //x2=5.265 //y2=0.375
cc_1854 ( N_noxref_8_M2_noxref_s N_noxref_19_M3_noxref_s ) capacitor \
 c=0.00125282f //x=2.965 //y=0.375 //x2=5.265 //y2=0.375
cc_1855 ( N_noxref_9_M4_noxref_d N_noxref_10_c_2975_n ) capacitor \
 c=0.00610736f //x=6.67 //y=0.91 //x2=7.03 //y2=2.195
cc_1856 ( N_noxref_9_M4_noxref_d N_noxref_10_c_3008_n ) capacitor c=2.2052e-19 \
 //x=6.67 //y=0.91 //x2=7.03 //y2=2.08
cc_1857 ( N_noxref_9_M4_noxref_d N_noxref_10_c_3019_n ) capacitor \
 c=0.00253592f //x=6.67 //y=0.91 //x2=6.595 //y2=0.91
cc_1858 ( N_noxref_9_M4_noxref_d N_noxref_10_c_3022_n ) capacitor \
 c=0.00604087f //x=6.67 //y=0.91 //x2=6.595 //y2=1.22
cc_1859 ( N_noxref_9_M4_noxref_d N_noxref_10_c_3071_n ) capacitor c=0.002686f \
 //x=6.67 //y=0.91 //x2=6.965 //y2=0.755
cc_1860 ( N_noxref_9_M4_noxref_d N_noxref_10_c_3072_n ) capacitor \
 c=0.00251995f //x=6.67 //y=0.91 //x2=6.965 //y2=1.375
cc_1861 ( N_noxref_9_c_2938_p N_noxref_10_c_3024_n ) capacitor c=0.00123426f \
 //x=7.825 //y=0.995 //x2=7.12 //y2=0.91
cc_1862 ( N_noxref_9_M4_noxref_d N_noxref_10_c_3024_n ) capacitor \
 c=0.00314523f //x=6.67 //y=0.91 //x2=7.12 //y2=0.91
cc_1863 ( N_noxref_9_M5_noxref_s N_noxref_10_c_3024_n ) capacitor \
 c=7.21316e-19 //x=7.775 //y=0.375 //x2=7.12 //y2=0.91
cc_1864 ( N_noxref_9_c_2938_p N_noxref_10_c_3025_n ) capacitor c=0.0129288f \
 //x=7.825 //y=0.995 //x2=7.12 //y2=1.22
cc_1865 ( N_noxref_9_M4_noxref_d N_noxref_10_c_3025_n ) capacitor \
 c=0.00168289f //x=6.67 //y=0.91 //x2=7.12 //y2=1.22
cc_1866 ( N_noxref_9_M5_noxref_s N_noxref_10_c_3025_n ) capacitor \
 c=0.00365271f //x=7.775 //y=0.375 //x2=7.12 //y2=1.22
cc_1867 ( N_noxref_9_c_2938_p N_noxref_10_c_3026_n ) capacitor c=0.00132209f \
 //x=7.825 //y=0.995 //x2=7.12 //y2=1.45
cc_1868 ( N_noxref_9_M4_noxref_d N_noxref_10_c_3026_n ) capacitor \
 c=0.00111165f //x=6.67 //y=0.91 //x2=7.12 //y2=1.45
cc_1869 ( N_noxref_9_M5_noxref_s N_noxref_10_c_3027_n ) capacitor \
 c=9.86711e-19 //x=7.775 //y=0.375 //x2=7.12 //y2=1.915
cc_1870 ( N_noxref_9_c_2938_p N_noxref_16_c_3561_n ) capacitor c=0.00789826f \
 //x=7.825 //y=0.995 //x2=10.715 //y2=0
cc_1871 ( N_noxref_9_c_2948_p N_noxref_16_c_3561_n ) capacitor c=0.00682383f \
 //x=7.91 //y=0.625 //x2=10.715 //y2=0
cc_1872 ( N_noxref_9_c_2908_n N_noxref_16_c_3561_n ) capacitor c=0.00947894f \
 //x=8.795 //y=0.54 //x2=10.715 //y2=0
cc_1873 ( N_noxref_9_c_2950_p N_noxref_16_c_3561_n ) capacitor c=0.00232857f \
 //x=8.88 //y=0.625 //x2=10.715 //y2=0
cc_1874 ( N_noxref_9_M4_noxref_d N_noxref_16_c_3561_n ) capacitor c=0.013411f \
 //x=6.67 //y=0.91 //x2=10.715 //y2=0
cc_1875 ( N_noxref_9_M4_noxref_d N_noxref_16_c_3653_n ) capacitor c=0.0154456f \
 //x=6.67 //y=0.91 //x2=5.885 //y2=0.965
cc_1876 ( N_noxref_9_c_2938_p N_noxref_16_c_3579_n ) capacitor c=0.00807048f \
 //x=7.825 //y=0.995 //x2=9.45 //y2=0
cc_1877 ( N_noxref_9_c_2948_p N_noxref_16_c_3579_n ) capacitor c=0.0140233f \
 //x=7.91 //y=0.625 //x2=9.45 //y2=0
cc_1878 ( N_noxref_9_c_2908_n N_noxref_16_c_3579_n ) capacitor c=0.0364771f \
 //x=8.795 //y=0.54 //x2=9.45 //y2=0
cc_1879 ( N_noxref_9_c_2950_p N_noxref_16_c_3579_n ) capacitor c=0.0138658f \
 //x=8.88 //y=0.625 //x2=9.45 //y2=0
cc_1880 ( N_noxref_9_c_2908_n N_noxref_16_c_3755_n ) capacitor c=0.00189358f \
 //x=8.795 //y=0.54 //x2=25.53 //y2=0
cc_1881 ( N_noxref_9_M4_noxref_d N_noxref_16_c_3755_n ) capacitor c=2.7648e-19 \
 //x=6.67 //y=0.91 //x2=25.53 //y2=0
cc_1882 ( N_noxref_9_M5_noxref_s N_noxref_16_c_3582_n ) capacitor \
 c=8.16352e-19 //x=7.775 //y=0.375 //x2=4.81 //y2=0
cc_1883 ( N_noxref_9_c_2950_p N_noxref_16_c_3585_n ) capacitor c=0.0374312f \
 //x=8.88 //y=0.625 //x2=9.62 //y2=0
cc_1884 ( N_noxref_9_M5_noxref_s N_noxref_16_c_3585_n ) capacitor \
 c=0.00519576f //x=7.775 //y=0.375 //x2=9.62 //y2=0
cc_1885 ( N_noxref_9_M4_noxref_d N_noxref_16_M3_noxref_d ) capacitor \
 c=3.12752e-19 //x=6.67 //y=0.91 //x2=5.695 //y2=0.875
cc_1886 ( N_noxref_9_c_2948_p N_noxref_19_c_4199_n ) capacitor c=2.15937e-19 \
 //x=7.91 //y=0.625 //x2=6.37 //y2=0.625
cc_1887 ( N_noxref_9_c_2938_p N_noxref_19_c_4200_n ) capacitor c=0.0132582f \
 //x=7.825 //y=0.995 //x2=7.255 //y2=0.54
cc_1888 ( N_noxref_9_M4_noxref_d N_noxref_19_c_4200_n ) capacitor c=0.016458f \
 //x=6.67 //y=0.91 //x2=7.255 //y2=0.54
cc_1889 ( N_noxref_9_c_2938_p N_noxref_19_c_4183_n ) capacitor c=0.00954209f \
 //x=7.825 //y=0.995 //x2=7.255 //y2=1.59
cc_1890 ( N_noxref_9_M4_noxref_d N_noxref_19_c_4183_n ) capacitor c=0.0152939f \
 //x=6.67 //y=0.91 //x2=7.255 //y2=1.59
cc_1891 ( N_noxref_9_c_2938_p N_noxref_19_M3_noxref_s ) capacitor c=0.023368f \
 //x=7.825 //y=0.995 //x2=5.265 //y2=0.375
cc_1892 ( N_noxref_9_c_2948_p N_noxref_19_M3_noxref_s ) capacitor c=0.0175532f \
 //x=7.91 //y=0.625 //x2=5.265 //y2=0.375
cc_1893 ( N_noxref_9_c_2950_p N_noxref_19_M3_noxref_s ) capacitor \
 c=2.98721e-19 //x=8.88 //y=0.625 //x2=5.265 //y2=0.375
cc_1894 ( N_noxref_9_M4_noxref_d N_noxref_19_M3_noxref_s ) capacitor \
 c=0.0187685f //x=6.67 //y=0.91 //x2=5.265 //y2=0.375
cc_1895 ( N_noxref_9_M5_noxref_s N_noxref_19_M3_noxref_s ) capacitor \
 c=0.021082f //x=7.775 //y=0.375 //x2=5.265 //y2=0.375
cc_1896 ( N_noxref_9_c_2950_p N_noxref_20_M6_noxref_s ) capacitor \
 c=0.00370912f //x=8.88 //y=0.625 //x2=10.18 //y2=0.365
cc_1897 ( N_noxref_9_M5_noxref_s N_noxref_20_M6_noxref_s ) capacitor \
 c=0.00101401f //x=7.775 //y=0.375 //x2=10.18 //y2=0.365
cc_1898 ( N_noxref_10_c_2975_n N_noxref_16_c_3561_n ) capacitor c=9.14667e-19 \
 //x=7.03 //y=2.195 //x2=10.715 //y2=0
cc_1899 ( N_noxref_10_c_3019_n N_noxref_19_c_4200_n ) capacitor c=0.0167228f \
 //x=6.595 //y=0.91 //x2=7.255 //y2=0.54
cc_1900 ( N_noxref_10_c_3024_n N_noxref_19_c_4200_n ) capacitor c=0.00534519f \
 //x=7.12 //y=0.91 //x2=7.255 //y2=0.54
cc_1901 ( N_noxref_10_c_2975_n N_noxref_19_c_4183_n ) capacitor c=0.0048147f \
 //x=7.03 //y=2.195 //x2=7.255 //y2=1.59
cc_1902 ( N_noxref_10_c_3008_n N_noxref_19_c_4183_n ) capacitor c=0.0105652f \
 //x=7.03 //y=2.08 //x2=7.255 //y2=1.59
cc_1903 ( N_noxref_10_c_3022_n N_noxref_19_c_4183_n ) capacitor c=0.0153476f \
 //x=6.595 //y=1.22 //x2=7.255 //y2=1.59
cc_1904 ( N_noxref_10_c_3027_n N_noxref_19_c_4183_n ) capacitor c=0.0220606f \
 //x=7.12 //y=1.915 //x2=7.255 //y2=1.59
cc_1905 ( N_noxref_10_c_3019_n N_noxref_19_M3_noxref_s ) capacitor \
 c=0.00798959f //x=6.595 //y=0.91 //x2=5.265 //y2=0.375
cc_1906 ( N_noxref_10_c_3026_n N_noxref_19_M3_noxref_s ) capacitor \
 c=0.00212176f //x=7.12 //y=1.45 //x2=5.265 //y2=0.375
cc_1907 ( N_noxref_10_c_3027_n N_noxref_19_M3_noxref_s ) capacitor \
 c=0.00298115f //x=7.12 //y=1.915 //x2=5.265 //y2=0.375
cc_1908 ( N_noxref_11_c_3093_n N_noxref_16_c_3642_n ) capacitor c=0.00533525f \
 //x=15.965 //y=0.995 //x2=18.75 //y2=0
cc_1909 ( N_noxref_11_c_3134_p N_noxref_16_c_3642_n ) capacitor c=0.00428723f \
 //x=16.05 //y=0.625 //x2=18.75 //y2=0
cc_1910 ( N_noxref_11_c_3109_n N_noxref_16_c_3642_n ) capacitor c=0.00947894f \
 //x=16.935 //y=0.54 //x2=18.75 //y2=0
cc_1911 ( N_noxref_11_c_3136_p N_noxref_16_c_3642_n ) capacitor c=0.00232857f \
 //x=17.02 //y=0.625 //x2=18.75 //y2=0
cc_1912 ( N_noxref_11_M9_noxref_d N_noxref_16_c_3642_n ) capacitor \
 c=0.0130904f //x=14.81 //y=0.91 //x2=18.75 //y2=0
cc_1913 ( N_noxref_11_M9_noxref_d N_noxref_16_c_3610_n ) capacitor \
 c=0.0154456f //x=14.81 //y=0.91 //x2=14.025 //y2=0.965
cc_1914 ( N_noxref_11_c_3093_n N_noxref_16_c_3623_n ) capacitor c=0.00914678f \
 //x=15.965 //y=0.995 //x2=17.59 //y2=0
cc_1915 ( N_noxref_11_c_3134_p N_noxref_16_c_3623_n ) capacitor c=0.0141367f \
 //x=16.05 //y=0.625 //x2=17.59 //y2=0
cc_1916 ( N_noxref_11_c_3109_n N_noxref_16_c_3623_n ) capacitor c=0.0364771f \
 //x=16.935 //y=0.54 //x2=17.59 //y2=0
cc_1917 ( N_noxref_11_c_3136_p N_noxref_16_c_3623_n ) capacitor c=0.0138658f \
 //x=17.02 //y=0.625 //x2=17.59 //y2=0
cc_1918 ( N_noxref_11_c_3109_n N_noxref_16_c_3755_n ) capacitor c=0.00189358f \
 //x=16.935 //y=0.54 //x2=25.53 //y2=0
cc_1919 ( N_noxref_11_M9_noxref_d N_noxref_16_c_3755_n ) capacitor \
 c=2.7648e-19 //x=14.81 //y=0.91 //x2=25.53 //y2=0
cc_1920 ( N_noxref_11_M10_noxref_s N_noxref_16_c_3625_n ) capacitor \
 c=8.16352e-19 //x=15.915 //y=0.375 //x2=12.95 //y2=0
cc_1921 ( N_noxref_11_c_3136_p N_noxref_16_c_3684_n ) capacitor c=0.037873f \
 //x=17.02 //y=0.625 //x2=17.76 //y2=0
cc_1922 ( N_noxref_11_M10_noxref_s N_noxref_16_c_3684_n ) capacitor \
 c=0.0051897f //x=15.915 //y=0.375 //x2=17.76 //y2=0
cc_1923 ( N_noxref_11_M9_noxref_d N_noxref_16_M8_noxref_d ) capacitor \
 c=3.12752e-19 //x=14.81 //y=0.91 //x2=13.835 //y2=0.875
cc_1924 ( N_noxref_11_c_3134_p N_noxref_21_c_4332_n ) capacitor c=2.15937e-19 \
 //x=16.05 //y=0.625 //x2=14.51 //y2=0.625
cc_1925 ( N_noxref_11_c_3093_n N_noxref_21_c_4318_n ) capacitor c=0.0130857f \
 //x=15.965 //y=0.995 //x2=15.395 //y2=0.54
cc_1926 ( N_noxref_11_M9_noxref_d N_noxref_21_c_4318_n ) capacitor \
 c=0.0160925f //x=14.81 //y=0.91 //x2=15.395 //y2=0.54
cc_1927 ( N_noxref_11_c_3093_n N_noxref_21_c_4320_n ) capacitor c=0.00944538f \
 //x=15.965 //y=0.995 //x2=15.395 //y2=1.59
cc_1928 ( N_noxref_11_M9_noxref_d N_noxref_21_c_4320_n ) capacitor \
 c=0.0152605f //x=14.81 //y=0.91 //x2=15.395 //y2=1.59
cc_1929 ( N_noxref_11_c_3093_n N_noxref_21_M8_noxref_s ) capacitor \
 c=0.0223986f //x=15.965 //y=0.995 //x2=13.405 //y2=0.375
cc_1930 ( N_noxref_11_c_3134_p N_noxref_21_M8_noxref_s ) capacitor \
 c=0.0175461f //x=16.05 //y=0.625 //x2=13.405 //y2=0.375
cc_1931 ( N_noxref_11_c_3136_p N_noxref_21_M8_noxref_s ) capacitor \
 c=2.98576e-19 //x=17.02 //y=0.625 //x2=13.405 //y2=0.375
cc_1932 ( N_noxref_11_M9_noxref_d N_noxref_21_M8_noxref_s ) capacitor \
 c=0.0187674f //x=14.81 //y=0.91 //x2=13.405 //y2=0.375
cc_1933 ( N_noxref_11_M10_noxref_s N_noxref_21_M8_noxref_s ) capacitor \
 c=0.0210819f //x=15.915 //y=0.375 //x2=13.405 //y2=0.375
cc_1934 ( N_noxref_11_c_3136_p N_noxref_22_M11_noxref_s ) capacitor \
 c=0.00368328f //x=17.02 //y=0.625 //x2=18.215 //y2=0.375
cc_1935 ( N_noxref_11_M10_noxref_s N_noxref_22_M11_noxref_s ) capacitor \
 c=0.00125282f //x=15.915 //y=0.375 //x2=18.215 //y2=0.375
cc_1936 ( N_noxref_12_c_3179_p N_noxref_13_c_3229_n ) capacitor c=0.00171317f \
 //x=21.745 //y=0.54 //x2=21.09 //y2=2.195
cc_1937 ( N_noxref_12_c_3179_p N_noxref_13_c_3238_n ) capacitor c=0.00117306f \
 //x=21.745 //y=0.54 //x2=21.09 //y2=2.08
cc_1938 ( N_noxref_12_c_3179_p N_noxref_13_c_3247_n ) capacitor c=0.0205874f \
 //x=21.745 //y=0.54 //x2=21.08 //y2=0.915
cc_1939 ( N_noxref_12_M13_noxref_s N_noxref_13_c_3247_n ) capacitor \
 c=0.0071177f //x=20.725 //y=0.375 //x2=21.08 //y2=0.915
cc_1940 ( N_noxref_12_c_3183_p N_noxref_13_c_3248_n ) capacitor c=0.0071177f \
 //x=20.86 //y=0.995 //x2=21.08 //y2=1.26
cc_1941 ( N_noxref_12_M13_noxref_s N_noxref_13_c_3249_n ) capacitor \
 c=0.0071177f //x=20.725 //y=0.375 //x2=21.08 //y2=1.57
cc_1942 ( N_noxref_12_c_3179_p N_noxref_13_c_3272_n ) capacitor c=0.00825432f \
 //x=21.745 //y=0.54 //x2=21.61 //y2=0.915
cc_1943 ( N_noxref_12_M13_noxref_s N_noxref_13_c_3272_n ) capacitor \
 c=0.015333f //x=20.725 //y=0.375 //x2=21.61 //y2=0.915
cc_1944 ( N_noxref_12_M13_noxref_s N_noxref_13_c_3274_n ) capacitor \
 c=0.00248746f //x=20.725 //y=0.375 //x2=21.61 //y2=1.26
cc_1945 ( N_noxref_12_c_3179_p N_noxref_13_c_3250_n ) capacitor c=2.20712e-19 \
 //x=21.745 //y=0.54 //x2=21.09 //y2=2.08
cc_1946 ( N_noxref_12_M12_noxref_d N_noxref_14_c_3321_n ) capacitor \
 c=0.00114684f //x=19.62 //y=0.91 //x2=20.05 //y2=5.155
cc_1947 ( N_noxref_12_c_3179_p N_noxref_14_c_3393_n ) capacitor c=0.00361816f \
 //x=21.745 //y=0.54 //x2=21.345 //y2=1.125
cc_1948 ( N_noxref_12_M12_noxref_d N_noxref_14_c_3393_n ) capacitor \
 c=0.00802836f //x=19.62 //y=0.91 //x2=21.345 //y2=1.125
cc_1949 ( N_noxref_12_M13_noxref_s N_noxref_14_c_3393_n ) capacitor \
 c=0.00993092f //x=20.725 //y=0.375 //x2=21.345 //y2=1.125
cc_1950 ( N_noxref_12_M13_noxref_s N_noxref_14_c_3396_n ) capacitor \
 c=0.0270624f //x=20.725 //y=0.375 //x2=21.345 //y2=1.58
cc_1951 ( N_noxref_12_c_3179_p N_noxref_14_c_3397_n ) capacitor c=0.00362807f \
 //x=21.745 //y=0.54 //x2=21.745 //y2=1.665
cc_1952 ( N_noxref_12_M13_noxref_s N_noxref_14_c_3397_n ) capacitor \
 c=0.0106347f //x=20.725 //y=0.375 //x2=21.745 //y2=1.665
cc_1953 ( N_noxref_12_c_3179_p N_noxref_14_M13_noxref_d ) capacitor \
 c=0.00910163f //x=21.745 //y=0.54 //x2=21.155 //y2=0.915
cc_1954 ( N_noxref_12_c_3183_p N_noxref_14_M13_noxref_d ) capacitor \
 c=0.00120711f //x=20.86 //y=0.995 //x2=21.155 //y2=0.915
cc_1955 ( N_noxref_12_M13_noxref_s N_noxref_14_M13_noxref_d ) capacitor \
 c=0.0279003f //x=20.725 //y=0.375 //x2=21.155 //y2=0.915
cc_1956 ( N_noxref_12_c_3161_n N_noxref_16_c_3712_n ) capacitor c=0.00789826f \
 //x=20.775 //y=0.995 //x2=23.665 //y2=0
cc_1957 ( N_noxref_12_c_3200_p N_noxref_16_c_3712_n ) capacitor c=0.00709506f \
 //x=20.86 //y=0.625 //x2=23.665 //y2=0
cc_1958 ( N_noxref_12_c_3179_p N_noxref_16_c_3712_n ) capacitor c=0.0104298f \
 //x=21.745 //y=0.54 //x2=23.665 //y2=0
cc_1959 ( N_noxref_12_c_3202_p N_noxref_16_c_3712_n ) capacitor c=0.00232857f \
 //x=21.83 //y=0.625 //x2=23.665 //y2=0
cc_1960 ( N_noxref_12_M12_noxref_d N_noxref_16_c_3712_n ) capacitor \
 c=0.0130545f //x=19.62 //y=0.91 //x2=23.665 //y2=0
cc_1961 ( N_noxref_12_M12_noxref_d N_noxref_16_c_3664_n ) capacitor \
 c=0.0154456f //x=19.62 //y=0.91 //x2=18.835 //y2=0.965
cc_1962 ( N_noxref_12_c_3161_n N_noxref_16_c_3676_n ) capacitor c=0.00807048f \
 //x=20.775 //y=0.995 //x2=22.4 //y2=0
cc_1963 ( N_noxref_12_c_3200_p N_noxref_16_c_3676_n ) capacitor c=0.0140218f \
 //x=20.86 //y=0.625 //x2=22.4 //y2=0
cc_1964 ( N_noxref_12_c_3179_p N_noxref_16_c_3676_n ) capacitor c=0.0364204f \
 //x=21.745 //y=0.54 //x2=22.4 //y2=0
cc_1965 ( N_noxref_12_c_3202_p N_noxref_16_c_3676_n ) capacitor c=0.0138658f \
 //x=21.83 //y=0.625 //x2=22.4 //y2=0
cc_1966 ( N_noxref_12_c_3179_p N_noxref_16_c_3755_n ) capacitor c=0.00189358f \
 //x=21.745 //y=0.54 //x2=25.53 //y2=0
cc_1967 ( N_noxref_12_M12_noxref_d N_noxref_16_c_3755_n ) capacitor \
 c=2.7648e-19 //x=19.62 //y=0.91 //x2=25.53 //y2=0
cc_1968 ( N_noxref_12_M13_noxref_s N_noxref_16_c_3684_n ) capacitor \
 c=8.16352e-19 //x=20.725 //y=0.375 //x2=17.76 //y2=0
cc_1969 ( N_noxref_12_c_3202_p N_noxref_16_c_3764_n ) capacitor c=0.0374312f \
 //x=21.83 //y=0.625 //x2=22.57 //y2=0
cc_1970 ( N_noxref_12_M13_noxref_s N_noxref_16_c_3764_n ) capacitor \
 c=0.00519933f //x=20.725 //y=0.375 //x2=22.57 //y2=0
cc_1971 ( N_noxref_12_M12_noxref_d N_noxref_16_M11_noxref_d ) capacitor \
 c=3.12752e-19 //x=19.62 //y=0.91 //x2=18.645 //y2=0.875
cc_1972 ( N_noxref_12_c_3200_p N_noxref_22_c_4392_n ) capacitor c=2.15937e-19 \
 //x=20.86 //y=0.625 //x2=19.32 //y2=0.625
cc_1973 ( N_noxref_12_c_3161_n N_noxref_22_c_4379_n ) capacitor c=0.0132582f \
 //x=20.775 //y=0.995 //x2=20.205 //y2=0.54
cc_1974 ( N_noxref_12_M12_noxref_d N_noxref_22_c_4379_n ) capacitor \
 c=0.0160925f //x=19.62 //y=0.91 //x2=20.205 //y2=0.54
cc_1975 ( N_noxref_12_c_3161_n N_noxref_22_c_4381_n ) capacitor c=0.00954209f \
 //x=20.775 //y=0.995 //x2=20.205 //y2=1.59
cc_1976 ( N_noxref_12_M12_noxref_d N_noxref_22_c_4381_n ) capacitor \
 c=0.014937f //x=19.62 //y=0.91 //x2=20.205 //y2=1.59
cc_1977 ( N_noxref_12_c_3161_n N_noxref_22_M11_noxref_s ) capacitor \
 c=0.023368f //x=20.775 //y=0.995 //x2=18.215 //y2=0.375
cc_1978 ( N_noxref_12_c_3200_p N_noxref_22_M11_noxref_s ) capacitor \
 c=0.0175532f //x=20.86 //y=0.625 //x2=18.215 //y2=0.375
cc_1979 ( N_noxref_12_c_3202_p N_noxref_22_M11_noxref_s ) capacitor \
 c=2.98721e-19 //x=21.83 //y=0.625 //x2=18.215 //y2=0.375
cc_1980 ( N_noxref_12_M12_noxref_d N_noxref_22_M11_noxref_s ) capacitor \
 c=0.0187685f //x=19.62 //y=0.91 //x2=18.215 //y2=0.375
cc_1981 ( N_noxref_12_M13_noxref_s N_noxref_22_M11_noxref_s ) capacitor \
 c=0.0210927f //x=20.725 //y=0.375 //x2=18.215 //y2=0.375
cc_1982 ( N_noxref_12_c_3202_p N_noxref_23_M14_noxref_s ) capacitor \
 c=0.00370912f //x=21.83 //y=0.625 //x2=23.13 //y2=0.365
cc_1983 ( N_noxref_12_M13_noxref_s N_noxref_23_M14_noxref_s ) capacitor \
 c=0.00101401f //x=20.725 //y=0.375 //x2=23.13 //y2=0.365
cc_1984 ( N_noxref_13_M42_noxref_g N_noxref_14_c_3333_n ) capacitor \
 c=0.0103546f //x=20.83 //y=6.02 //x2=20.935 //y2=5.155
cc_1985 ( N_noxref_13_M42_noxref_g N_noxref_14_c_3361_n ) capacitor \
 c=0.00226521f //x=20.83 //y=6.02 //x2=21.05 //y2=5.38
cc_1986 ( N_noxref_13_M43_noxref_g N_noxref_14_c_3361_n ) capacitor \
 c=0.00368945f //x=21.27 //y=6.02 //x2=21.05 //y2=5.38
cc_1987 ( N_noxref_13_c_3227_n N_noxref_14_c_3344_n ) capacitor c=0.0023499f \
 //x=21.09 //y=4.57 //x2=21.745 //y2=5.155
cc_1988 ( N_noxref_13_c_3241_n N_noxref_14_c_3344_n ) capacitor c=0.00130631f \
 //x=21.09 //y=4.7 //x2=21.745 //y2=5.155
cc_1989 ( N_noxref_13_M43_noxref_g N_noxref_14_c_3344_n ) capacitor \
 c=0.0112556f //x=21.27 //y=6.02 //x2=21.745 //y2=5.155
cc_1990 ( N_noxref_13_c_3247_n N_noxref_14_c_3393_n ) capacitor c=4.64015e-19 \
 //x=21.08 //y=0.915 //x2=21.345 //y2=1.125
cc_1991 ( N_noxref_13_c_3248_n N_noxref_14_c_3393_n ) capacitor c=0.0026012f \
 //x=21.08 //y=1.26 //x2=21.345 //y2=1.125
cc_1992 ( N_noxref_13_c_3284_p N_noxref_14_c_3393_n ) capacitor c=5.29969e-19 \
 //x=21.455 //y=0.76 //x2=21.345 //y2=1.125
cc_1993 ( N_noxref_13_c_3285_p N_noxref_14_c_3393_n ) capacitor c=5.54437e-19 \
 //x=21.455 //y=1.415 //x2=21.345 //y2=1.125
cc_1994 ( N_noxref_13_c_3272_n N_noxref_14_c_3393_n ) capacitor c=5.28622e-19 \
 //x=21.61 //y=0.915 //x2=21.345 //y2=1.125
cc_1995 ( N_noxref_13_c_3274_n N_noxref_14_c_3393_n ) capacitor c=0.00312156f \
 //x=21.61 //y=1.26 //x2=21.345 //y2=1.125
cc_1996 ( N_noxref_13_c_3248_n N_noxref_14_c_3396_n ) capacitor c=0.00127432f \
 //x=21.08 //y=1.26 //x2=21.345 //y2=1.58
cc_1997 ( N_noxref_13_c_3249_n N_noxref_14_c_3396_n ) capacitor c=0.00429966f \
 //x=21.08 //y=1.57 //x2=21.345 //y2=1.58
cc_1998 ( N_noxref_13_c_3285_p N_noxref_14_c_3396_n ) capacitor c=0.00930387f \
 //x=21.455 //y=1.415 //x2=21.345 //y2=1.58
cc_1999 ( N_noxref_13_c_3274_n N_noxref_14_c_3396_n ) capacitor c=0.00347599f \
 //x=21.61 //y=1.26 //x2=21.345 //y2=1.58
cc_2000 ( N_noxref_13_c_3253_n N_noxref_14_c_3396_n ) capacitor c=0.0036273f \
 //x=21.09 //y=1.915 //x2=21.345 //y2=1.58
cc_2001 ( N_noxref_13_c_3285_p N_noxref_14_c_3397_n ) capacitor c=0.00194716f \
 //x=21.455 //y=1.415 //x2=21.745 //y2=1.665
cc_2002 ( N_noxref_13_c_3274_n N_noxref_14_c_3397_n ) capacitor c=0.00323576f \
 //x=21.61 //y=1.26 //x2=21.745 //y2=1.665
cc_2003 ( N_noxref_13_c_3229_n N_noxref_14_c_3334_n ) capacitor c=0.0147222f \
 //x=21.09 //y=2.195 //x2=21.83 //y2=5.07
cc_2004 ( N_noxref_13_c_3227_n N_noxref_14_c_3334_n ) capacitor c=0.120999f \
 //x=21.09 //y=4.57 //x2=21.83 //y2=5.07
cc_2005 ( N_noxref_13_c_3238_n N_noxref_14_c_3334_n ) capacitor c=0.00144133f \
 //x=21.09 //y=2.08 //x2=21.83 //y2=5.07
cc_2006 ( N_noxref_13_c_3241_n N_noxref_14_c_3334_n ) capacitor c=0.00131258f \
 //x=21.09 //y=4.7 //x2=21.83 //y2=5.07
cc_2007 ( N_noxref_13_c_3250_n N_noxref_14_c_3334_n ) capacitor c=0.00246559f \
 //x=21.09 //y=2.08 //x2=21.83 //y2=5.07
cc_2008 ( N_noxref_13_c_3254_n N_noxref_14_c_3334_n ) capacitor c=0.0035458f \
 //x=21.09 //y=4.7 //x2=21.83 //y2=5.07
cc_2009 ( N_noxref_13_c_3227_n N_noxref_14_c_3427_n ) capacitor c=0.0225136f \
 //x=21.09 //y=4.57 //x2=21.05 //y2=5.155
cc_2010 ( N_noxref_13_c_3241_n N_noxref_14_c_3427_n ) capacitor c=0.00346456f \
 //x=21.09 //y=4.7 //x2=21.05 //y2=5.155
cc_2011 ( N_noxref_13_c_3254_n N_noxref_14_c_3427_n ) capacitor c=0.00203307f \
 //x=21.09 //y=4.7 //x2=21.05 //y2=5.155
cc_2012 ( N_noxref_13_c_3227_n N_noxref_14_c_3387_n ) capacitor c=0.00266871f \
 //x=21.09 //y=4.57 //x2=21.05 //y2=5.38
cc_2013 ( N_noxref_13_c_3241_n N_noxref_14_c_3387_n ) capacitor c=0.00552343f \
 //x=21.09 //y=4.7 //x2=21.05 //y2=5.38
cc_2014 ( N_noxref_13_M42_noxref_g N_noxref_14_c_3387_n ) capacitor \
 c=0.0178885f //x=20.83 //y=6.02 //x2=21.05 //y2=5.38
cc_2015 ( N_noxref_13_M43_noxref_g N_noxref_14_c_3387_n ) capacitor \
 c=0.0188608f //x=21.27 //y=6.02 //x2=21.05 //y2=5.38
cc_2016 ( N_noxref_13_c_3254_n N_noxref_14_c_3387_n ) capacitor c=0.00375636f \
 //x=21.09 //y=4.7 //x2=21.05 //y2=5.38
cc_2017 ( N_noxref_13_c_3247_n N_noxref_14_M13_noxref_d ) capacitor \
 c=0.00137165f //x=21.08 //y=0.915 //x2=21.155 //y2=0.915
cc_2018 ( N_noxref_13_c_3248_n N_noxref_14_M13_noxref_d ) capacitor \
 c=0.00237422f //x=21.08 //y=1.26 //x2=21.155 //y2=0.915
cc_2019 ( N_noxref_13_c_3284_p N_noxref_14_M13_noxref_d ) capacitor \
 c=0.0020782f //x=21.455 //y=0.76 //x2=21.155 //y2=0.915
cc_2020 ( N_noxref_13_c_3285_p N_noxref_14_M13_noxref_d ) capacitor \
 c=0.00356097f //x=21.455 //y=1.415 //x2=21.155 //y2=0.915
cc_2021 ( N_noxref_13_c_3272_n N_noxref_14_M13_noxref_d ) capacitor \
 c=0.00139206f //x=21.61 //y=0.915 //x2=21.155 //y2=0.915
cc_2022 ( N_noxref_13_c_3274_n N_noxref_14_M13_noxref_d ) capacitor \
 c=0.00237422f //x=21.61 //y=1.26 //x2=21.155 //y2=0.915
cc_2023 ( N_noxref_13_c_3227_n N_noxref_15_c_3465_n ) capacitor c=0.00439471f \
 //x=21.09 //y=4.57 //x2=23.682 //y2=4.56
cc_2024 ( N_noxref_13_c_3229_n N_noxref_16_c_3712_n ) capacitor c=0.00219445f \
 //x=21.09 //y=2.195 //x2=23.665 //y2=0
cc_2025 ( N_noxref_13_c_3229_n N_noxref_16_c_3676_n ) capacitor c=2.01623e-19 \
 //x=21.09 //y=2.195 //x2=22.4 //y2=0
cc_2026 ( N_noxref_13_c_3238_n N_noxref_16_c_3764_n ) capacitor c=0.00239899f \
 //x=21.09 //y=2.08 //x2=22.57 //y2=0
cc_2027 ( N_noxref_13_c_3274_n N_noxref_16_c_3764_n ) capacitor c=0.00262688f \
 //x=21.61 //y=1.26 //x2=22.57 //y2=0
cc_2028 ( N_noxref_13_c_3250_n N_noxref_16_c_3764_n ) capacitor c=2.63786e-19 \
 //x=21.09 //y=2.08 //x2=22.57 //y2=0
cc_2029 ( N_noxref_14_c_3334_n N_noxref_15_c_3457_n ) capacitor c=0.00457386f \
 //x=21.83 //y=5.07 //x2=23.68 //y2=2.08
cc_2030 ( N_noxref_14_c_3334_n N_noxref_15_c_3461_n ) capacitor c=0.00476843f \
 //x=21.83 //y=5.07 //x2=23.68 //y2=4.7
cc_2031 ( N_noxref_14_c_3334_n N_noxref_15_c_3465_n ) capacitor c=0.0404591f \
 //x=21.83 //y=5.07 //x2=23.682 //y2=4.56
cc_2032 ( N_noxref_14_c_3393_n N_noxref_16_c_3712_n ) capacitor c=0.00905765f \
 //x=21.345 //y=1.125 //x2=23.665 //y2=0
cc_2033 ( N_noxref_14_c_3397_n N_noxref_16_c_3712_n ) capacitor c=0.00712383f \
 //x=21.745 //y=1.665 //x2=23.665 //y2=0
cc_2034 ( N_noxref_14_M13_noxref_d N_noxref_16_c_3712_n ) capacitor \
 c=2.94508e-19 //x=21.155 //y=0.915 //x2=23.665 //y2=0
cc_2035 ( N_noxref_14_c_3393_n N_noxref_16_c_3852_n ) capacitor c=0.00488628f \
 //x=21.345 //y=1.125 //x2=23.75 //y2=0.955
cc_2036 ( N_noxref_14_c_3397_n N_noxref_16_c_3676_n ) capacitor c=8.02323e-19 \
 //x=21.745 //y=1.665 //x2=22.4 //y2=0
cc_2037 ( N_noxref_14_c_3396_n N_noxref_16_c_3764_n ) capacitor c=0.00285697f \
 //x=21.345 //y=1.58 //x2=22.57 //y2=0
cc_2038 ( N_noxref_14_c_3397_n N_noxref_16_c_3764_n ) capacitor c=0.0358307f \
 //x=21.745 //y=1.665 //x2=22.57 //y2=0
cc_2039 ( N_noxref_14_c_3396_n N_noxref_17_c_4021_n ) capacitor c=0.00326079f \
 //x=21.345 //y=1.58 //x2=24.72 //y2=1.57
cc_2040 ( N_noxref_14_c_3397_n N_noxref_17_c_4093_n ) capacitor c=0.00259257f \
 //x=21.745 //y=1.665 //x2=24.805 //y2=1.655
cc_2041 ( N_noxref_14_c_3334_n N_noxref_17_c_4029_n ) capacitor c=0.00111682f \
 //x=21.83 //y=5.07 //x2=25.16 //y2=5.115
cc_2042 ( N_noxref_14_c_3361_n N_noxref_17_c_4040_n ) capacitor c=5.58535e-19 \
 //x=21.05 //y=5.38 //x2=23.8 //y2=5.38
cc_2043 ( N_noxref_14_c_3344_n N_noxref_17_c_4040_n ) capacitor c=0.00104762f \
 //x=21.745 //y=5.155 //x2=23.8 //y2=5.38
cc_2044 ( N_noxref_14_c_3393_n N_noxref_17_c_4044_n ) capacitor c=6.5615e-19 \
 //x=21.345 //y=1.125 //x2=24.72 //y2=1
cc_2045 ( N_noxref_15_c_3457_n N_noxref_16_c_3852_n ) capacitor c=0.00709452f \
 //x=23.68 //y=2.08 //x2=23.75 //y2=0.955
cc_2046 ( N_noxref_15_c_3471_n N_noxref_16_c_3852_n ) capacitor c=2.13705e-19 \
 //x=23.68 //y=2.08 //x2=23.75 //y2=0.955
cc_2047 ( N_noxref_15_c_3481_n N_noxref_16_c_3852_n ) capacitor c=0.00176535f \
 //x=23.485 //y=0.865 //x2=23.75 //y2=0.955
cc_2048 ( N_noxref_15_c_3482_n N_noxref_16_c_3852_n ) capacitor c=0.0036005f \
 //x=23.485 //y=1.21 //x2=23.75 //y2=0.955
cc_2049 ( N_noxref_15_c_3483_n N_noxref_16_c_3852_n ) capacitor c=4.2764e-19 \
 //x=23.485 //y=1.52 //x2=23.75 //y2=0.955
cc_2050 ( N_noxref_15_c_3517_p N_noxref_16_c_3852_n ) capacitor c=7.35788e-19 \
 //x=23.86 //y=0.71 //x2=23.75 //y2=0.955
cc_2051 ( N_noxref_15_c_3518_p N_noxref_16_c_3852_n ) capacitor c=6.38426e-19 \
 //x=23.86 //y=1.365 //x2=23.75 //y2=0.955
cc_2052 ( N_noxref_15_c_3489_n N_noxref_16_c_3852_n ) capacitor c=0.00158609f \
 //x=24.015 //y=0.865 //x2=23.75 //y2=0.955
cc_2053 ( N_noxref_15_c_3491_n N_noxref_16_c_3852_n ) capacitor c=0.00296337f \
 //x=24.015 //y=1.21 //x2=23.75 //y2=0.955
cc_2054 ( N_noxref_15_c_3481_n N_noxref_16_c_3865_n ) capacitor c=3.51399e-19 \
 //x=23.485 //y=0.865 //x2=23.747 //y2=0.825
cc_2055 ( N_noxref_15_c_3517_p N_noxref_16_c_3865_n ) capacitor c=0.00864436f \
 //x=23.86 //y=0.71 //x2=23.747 //y2=0.825
cc_2056 ( N_noxref_15_c_3489_n N_noxref_16_c_3865_n ) capacitor c=4.45447e-19 \
 //x=24.015 //y=0.865 //x2=23.747 //y2=0.825
cc_2057 ( N_noxref_15_c_3481_n N_noxref_16_c_3755_n ) capacitor c=0.00689257f \
 //x=23.485 //y=0.865 //x2=25.53 //y2=0
cc_2058 ( N_noxref_15_c_3457_n N_noxref_16_c_3764_n ) capacitor c=0.00427323f \
 //x=23.68 //y=2.08 //x2=22.57 //y2=0
cc_2059 ( N_noxref_15_c_3465_n N_noxref_16_c_3764_n ) capacitor c=0.00829739f \
 //x=23.682 //y=4.56 //x2=22.57 //y2=0
cc_2060 ( N_noxref_15_c_3471_n N_noxref_16_c_3764_n ) capacitor c=0.00369427f \
 //x=23.68 //y=2.08 //x2=22.57 //y2=0
cc_2061 ( N_noxref_15_c_3483_n N_noxref_16_c_3764_n ) capacitor c=0.0015404f \
 //x=23.485 //y=1.52 //x2=22.57 //y2=0
cc_2062 ( N_noxref_15_c_3485_n N_noxref_16_c_3764_n ) capacitor c=0.0095324f \
 //x=23.485 //y=1.915 //x2=22.57 //y2=0
cc_2063 ( N_noxref_15_c_3457_n N_noxref_16_M14_noxref_d ) capacitor \
 c=2.20438e-19 //x=23.68 //y=2.08 //x2=23.56 //y2=0.865
cc_2064 ( N_noxref_15_c_3481_n N_noxref_16_M14_noxref_d ) capacitor \
 c=0.00192399f //x=23.485 //y=0.865 //x2=23.56 //y2=0.865
cc_2065 ( N_noxref_15_c_3482_n N_noxref_16_M14_noxref_d ) capacitor \
 c=0.00210798f //x=23.485 //y=1.21 //x2=23.56 //y2=0.865
cc_2066 ( N_noxref_15_c_3517_p N_noxref_16_M14_noxref_d ) capacitor \
 c=0.00472259f //x=23.86 //y=0.71 //x2=23.56 //y2=0.865
cc_2067 ( N_noxref_15_c_3518_p N_noxref_16_M14_noxref_d ) capacitor \
 c=0.00166857f //x=23.86 //y=1.365 //x2=23.56 //y2=0.865
cc_2068 ( N_noxref_15_c_3489_n N_noxref_16_M14_noxref_d ) capacitor \
 c=0.00230174f //x=24.015 //y=0.865 //x2=23.56 //y2=0.865
cc_2069 ( N_noxref_15_c_3491_n N_noxref_16_M14_noxref_d ) capacitor \
 c=0.00210798f //x=24.015 //y=1.21 //x2=23.56 //y2=0.865
cc_2070 ( N_noxref_15_M45_noxref_g N_noxref_17_c_4015_n ) capacitor \
 c=0.00967396f //x=24.02 //y=6.02 //x2=24.565 //y2=5.2
cc_2071 ( N_noxref_15_c_3465_n N_noxref_17_c_4029_n ) capacitor c=0.00724722f \
 //x=23.682 //y=4.56 //x2=25.16 //y2=5.115
cc_2072 ( N_noxref_15_c_3461_n N_noxref_17_c_4040_n ) capacitor c=0.0118019f \
 //x=23.68 //y=4.7 //x2=23.8 //y2=5.38
cc_2073 ( N_noxref_15_c_3475_n N_noxref_17_c_4040_n ) capacitor c=0.00277154f \
 //x=23.68 //y=4.7 //x2=23.8 //y2=5.38
cc_2074 ( N_noxref_15_M44_noxref_g N_noxref_17_c_4040_n ) capacitor \
 c=0.00201806f //x=23.58 //y=6.02 //x2=23.8 //y2=5.38
cc_2075 ( N_noxref_15_M45_noxref_g N_noxref_17_c_4040_n ) capacitor \
 c=0.00192712f //x=24.02 //y=6.02 //x2=23.8 //y2=5.38
cc_2076 ( N_noxref_15_c_3494_n N_noxref_17_c_4040_n ) capacitor c=0.00207241f \
 //x=23.68 //y=4.7 //x2=23.8 //y2=5.38
cc_2077 ( N_noxref_15_c_3461_n N_noxref_17_c_4082_n ) capacitor c=0.00165549f \
 //x=23.68 //y=4.7 //x2=23.8 //y2=5.38
cc_2078 ( N_noxref_15_c_3475_n N_noxref_17_c_4082_n ) capacitor c=0.00377369f \
 //x=23.68 //y=4.7 //x2=23.8 //y2=5.38
cc_2079 ( N_noxref_15_M44_noxref_g N_noxref_17_c_4082_n ) capacitor \
 c=0.0158358f //x=23.58 //y=6.02 //x2=23.8 //y2=5.38
cc_2080 ( N_noxref_15_M45_noxref_g N_noxref_17_c_4082_n ) capacitor \
 c=0.0178987f //x=24.02 //y=6.02 //x2=23.8 //y2=5.38
cc_2081 ( N_noxref_15_c_3494_n N_noxref_17_c_4082_n ) capacitor c=0.0043218f \
 //x=23.68 //y=4.7 //x2=23.8 //y2=5.38
cc_2082 ( N_noxref_15_c_3485_n N_noxref_23_c_4436_n ) capacitor c=0.00262672f \
 //x=23.485 //y=1.915 //x2=23.265 //y2=1.495
cc_2083 ( N_noxref_15_c_3457_n N_noxref_23_c_4437_n ) capacitor c=0.00509504f \
 //x=23.68 //y=2.08 //x2=24.15 //y2=1.58
cc_2084 ( N_noxref_15_c_3471_n N_noxref_23_c_4437_n ) capacitor c=0.00763108f \
 //x=23.68 //y=2.08 //x2=24.15 //y2=1.58
cc_2085 ( N_noxref_15_c_3483_n N_noxref_23_c_4437_n ) capacitor c=0.00697076f \
 //x=23.485 //y=1.52 //x2=24.15 //y2=1.58
cc_2086 ( N_noxref_15_c_3485_n N_noxref_23_c_4437_n ) capacitor c=0.0193303f \
 //x=23.485 //y=1.915 //x2=24.15 //y2=1.58
cc_2087 ( N_noxref_15_c_3518_p N_noxref_23_c_4437_n ) capacitor c=0.00723574f \
 //x=23.86 //y=1.365 //x2=24.15 //y2=1.58
cc_2088 ( N_noxref_15_c_3491_n N_noxref_23_c_4437_n ) capacitor c=0.00339872f \
 //x=24.015 //y=1.21 //x2=24.15 //y2=1.58
cc_2089 ( N_noxref_15_c_3485_n N_noxref_23_c_4422_n ) capacitor c=6.71402e-19 \
 //x=23.485 //y=1.915 //x2=24.235 //y2=1.495
cc_2090 ( N_noxref_15_c_3481_n N_noxref_23_M14_noxref_s ) capacitor \
 c=0.0295366f //x=23.485 //y=0.865 //x2=23.13 //y2=0.365
cc_2091 ( N_noxref_15_c_3483_n N_noxref_23_M14_noxref_s ) capacitor \
 c=3.48408e-19 //x=23.485 //y=1.52 //x2=23.13 //y2=0.365
cc_2092 ( N_noxref_15_c_3489_n N_noxref_23_M14_noxref_s ) capacitor \
 c=0.0125442f //x=24.015 //y=0.865 //x2=23.13 //y2=0.365
cc_2093 ( N_noxref_16_c_3755_n N_noxref_17_c_4021_n ) capacitor c=0.00528499f \
 //x=25.53 //y=0 //x2=24.72 //y2=1.57
cc_2094 ( N_noxref_16_c_3734_n N_noxref_17_c_4027_n ) capacitor c=0.00651357f \
 //x=25.53 //y=0 //x2=25.075 //y2=1.655
cc_2095 ( N_noxref_16_c_3755_n N_noxref_17_c_4027_n ) capacitor c=0.0406521f \
 //x=25.53 //y=0 //x2=25.075 //y2=1.655
cc_2096 ( N_noxref_16_c_3764_n N_noxref_17_c_4029_n ) capacitor c=3.54807e-19 \
 //x=22.57 //y=0 //x2=25.16 //y2=5.115
cc_2097 ( N_noxref_16_c_3852_n N_noxref_17_c_4040_n ) capacitor c=8.63724e-19 \
 //x=23.75 //y=0.955 //x2=23.8 //y2=5.38
cc_2098 ( N_noxref_16_c_3734_n N_noxref_17_c_4044_n ) capacitor c=0.00963092f \
 //x=25.53 //y=0 //x2=24.72 //y2=1
cc_2099 ( N_noxref_16_c_3852_n N_noxref_17_c_4044_n ) capacitor c=0.0141947f \
 //x=23.75 //y=0.955 //x2=24.72 //y2=1
cc_2100 ( N_noxref_16_M14_noxref_d N_noxref_17_c_4044_n ) capacitor \
 c=2.82748e-19 //x=23.56 //y=0.865 //x2=24.72 //y2=1
cc_2101 ( N_noxref_16_c_3734_n N_noxref_17_M15_noxref_d ) capacitor \
 c=3.01654e-19 //x=25.53 //y=0 //x2=24.53 //y2=0.905
cc_2102 ( N_noxref_16_c_3852_n N_noxref_17_M15_noxref_d ) capacitor \
 c=2.93544e-19 //x=23.75 //y=0.955 //x2=24.53 //y2=0.905
cc_2103 ( N_noxref_16_c_3891_p N_noxref_18_c_4139_n ) capacitor c=0.00294033f \
 //x=0.99 //y=0 //x2=1.475 //y2=1.59
cc_2104 ( N_noxref_16_c_3560_n N_noxref_18_c_4139_n ) capacitor c=7.00327e-19 \
 //x=5.8 //y=0 //x2=1.475 //y2=1.59
cc_2105 ( N_noxref_16_c_3736_n N_noxref_18_c_4139_n ) capacitor c=0.00377512f \
 //x=1.075 //y=0.965 //x2=1.475 //y2=1.59
cc_2106 ( N_noxref_16_c_3578_n N_noxref_18_c_4139_n ) capacitor c=0.00371343f \
 //x=4.64 //y=0 //x2=1.475 //y2=1.59
cc_2107 ( N_noxref_16_M0_noxref_d N_noxref_18_c_4139_n ) capacitor \
 c=0.00578031f //x=0.885 //y=0.875 //x2=1.475 //y2=1.59
cc_2108 ( N_noxref_16_c_3727_n N_noxref_18_c_4150_n ) capacitor c=0.0169052f \
 //x=1.075 //y=0.835 //x2=1.56 //y2=0.625
cc_2109 ( N_noxref_16_c_3560_n N_noxref_18_c_4150_n ) capacitor c=0.00709506f \
 //x=5.8 //y=0 //x2=1.56 //y2=0.625
cc_2110 ( N_noxref_16_c_3578_n N_noxref_18_c_4150_n ) capacitor c=0.0140218f \
 //x=4.64 //y=0 //x2=1.56 //y2=0.625
cc_2111 ( N_noxref_16_c_3748_n N_noxref_18_c_4150_n ) capacitor c=0.00323118f \
 //x=0.74 //y=0 //x2=1.56 //y2=0.625
cc_2112 ( N_noxref_16_c_3560_n N_noxref_18_c_4128_n ) capacitor c=0.0138577f \
 //x=5.8 //y=0 //x2=2.445 //y2=0.54
cc_2113 ( N_noxref_16_c_3578_n N_noxref_18_c_4128_n ) capacitor c=0.0356078f \
 //x=4.64 //y=0 //x2=2.445 //y2=0.54
cc_2114 ( N_noxref_16_c_3755_n N_noxref_18_c_4128_n ) capacitor c=0.00177266f \
 //x=25.53 //y=0 //x2=2.445 //y2=0.54
cc_2115 ( N_noxref_16_c_3891_p N_noxref_18_M0_noxref_s ) capacitor \
 c=0.00709506f //x=0.99 //y=0 //x2=0.455 //y2=0.375
cc_2116 ( N_noxref_16_c_3727_n N_noxref_18_M0_noxref_s ) capacitor \
 c=0.0173062f //x=1.075 //y=0.835 //x2=0.455 //y2=0.375
cc_2117 ( N_noxref_16_c_3560_n N_noxref_18_M0_noxref_s ) capacitor \
 c=0.00682701f //x=5.8 //y=0 //x2=0.455 //y2=0.375
cc_2118 ( N_noxref_16_c_3736_n N_noxref_18_M0_noxref_s ) capacitor \
 c=0.0113024f //x=1.075 //y=0.965 //x2=0.455 //y2=0.375
cc_2119 ( N_noxref_16_c_3578_n N_noxref_18_M0_noxref_s ) capacitor c=0.027164f \
 //x=4.64 //y=0 //x2=0.455 //y2=0.375
cc_2120 ( N_noxref_16_c_3748_n N_noxref_18_M0_noxref_s ) capacitor \
 c=0.0675506f //x=0.74 //y=0 //x2=0.455 //y2=0.375
cc_2121 ( N_noxref_16_c_3582_n N_noxref_18_M0_noxref_s ) capacitor \
 c=0.00166413f //x=4.81 //y=0 //x2=0.455 //y2=0.375
cc_2122 ( N_noxref_16_M0_noxref_d N_noxref_18_M0_noxref_s ) capacitor \
 c=0.0271316f //x=0.885 //y=0.875 //x2=0.455 //y2=0.375
cc_2123 ( N_noxref_16_c_3560_n N_noxref_19_c_4181_n ) capacitor c=0.00113313f \
 //x=5.8 //y=0 //x2=6.285 //y2=1.59
cc_2124 ( N_noxref_16_c_3561_n N_noxref_19_c_4181_n ) capacitor c=6.67673e-19 \
 //x=10.715 //y=0 //x2=6.285 //y2=1.59
cc_2125 ( N_noxref_16_c_3653_n N_noxref_19_c_4181_n ) capacitor c=0.00375827f \
 //x=5.885 //y=0.965 //x2=6.285 //y2=1.59
cc_2126 ( N_noxref_16_c_3579_n N_noxref_19_c_4181_n ) capacitor c=0.00388837f \
 //x=9.45 //y=0 //x2=6.285 //y2=1.59
cc_2127 ( N_noxref_16_M3_noxref_d N_noxref_19_c_4181_n ) capacitor \
 c=0.00578031f //x=5.695 //y=0.875 //x2=6.285 //y2=1.59
cc_2128 ( N_noxref_16_c_3647_n N_noxref_19_c_4199_n ) capacitor c=0.0169052f \
 //x=5.885 //y=0.835 //x2=6.37 //y2=0.625
cc_2129 ( N_noxref_16_c_3561_n N_noxref_19_c_4199_n ) capacitor c=0.00709506f \
 //x=10.715 //y=0 //x2=6.37 //y2=0.625
cc_2130 ( N_noxref_16_c_3579_n N_noxref_19_c_4199_n ) capacitor c=0.0140218f \
 //x=9.45 //y=0 //x2=6.37 //y2=0.625
cc_2131 ( N_noxref_16_c_3582_n N_noxref_19_c_4199_n ) capacitor c=0.00322478f \
 //x=4.81 //y=0 //x2=6.37 //y2=0.625
cc_2132 ( N_noxref_16_c_3561_n N_noxref_19_c_4200_n ) capacitor c=0.0140718f \
 //x=10.715 //y=0 //x2=7.255 //y2=0.54
cc_2133 ( N_noxref_16_c_3579_n N_noxref_19_c_4200_n ) capacitor c=0.0356078f \
 //x=9.45 //y=0 //x2=7.255 //y2=0.54
cc_2134 ( N_noxref_16_c_3755_n N_noxref_19_c_4200_n ) capacitor c=0.00177266f \
 //x=25.53 //y=0 //x2=7.255 //y2=0.54
cc_2135 ( N_noxref_16_c_3560_n N_noxref_19_M3_noxref_s ) capacitor \
 c=0.00709506f //x=5.8 //y=0 //x2=5.265 //y2=0.375
cc_2136 ( N_noxref_16_c_3647_n N_noxref_19_M3_noxref_s ) capacitor \
 c=0.0173062f //x=5.885 //y=0.835 //x2=5.265 //y2=0.375
cc_2137 ( N_noxref_16_c_3561_n N_noxref_19_M3_noxref_s ) capacitor \
 c=0.00682701f //x=10.715 //y=0 //x2=5.265 //y2=0.375
cc_2138 ( N_noxref_16_c_3653_n N_noxref_19_M3_noxref_s ) capacitor \
 c=0.00988958f //x=5.885 //y=0.965 //x2=5.265 //y2=0.375
cc_2139 ( N_noxref_16_c_3579_n N_noxref_19_M3_noxref_s ) capacitor c=0.027164f \
 //x=9.45 //y=0 //x2=5.265 //y2=0.375
cc_2140 ( N_noxref_16_c_3582_n N_noxref_19_M3_noxref_s ) capacitor \
 c=0.0634633f //x=4.81 //y=0 //x2=5.265 //y2=0.375
cc_2141 ( N_noxref_16_c_3585_n N_noxref_19_M3_noxref_s ) capacitor \
 c=0.00166451f //x=9.62 //y=0 //x2=5.265 //y2=0.375
cc_2142 ( N_noxref_16_M3_noxref_d N_noxref_19_M3_noxref_s ) capacitor \
 c=0.0271316f //x=5.695 //y=0.875 //x2=5.265 //y2=0.375
cc_2143 ( N_noxref_16_c_3561_n N_noxref_20_c_4239_n ) capacitor c=9.7972e-19 \
 //x=10.715 //y=0 //x2=11.2 //y2=1.58
cc_2144 ( N_noxref_16_c_3600_n N_noxref_20_c_4239_n ) capacitor c=7.45312e-19 \
 //x=13.94 //y=0 //x2=11.2 //y2=1.58
cc_2145 ( N_noxref_16_c_3565_n N_noxref_20_c_4239_n ) capacitor c=0.00398645f \
 //x=10.8 //y=0.955 //x2=11.2 //y2=1.58
cc_2146 ( N_noxref_16_c_3581_n N_noxref_20_c_4239_n ) capacitor c=0.00395284f \
 //x=12.78 //y=0 //x2=11.2 //y2=1.58
cc_2147 ( N_noxref_16_M6_noxref_d N_noxref_20_c_4239_n ) capacitor \
 c=0.00578453f //x=10.61 //y=0.865 //x2=11.2 //y2=1.58
cc_2148 ( N_noxref_16_c_3600_n N_noxref_20_c_4284_n ) capacitor c=0.00310347f \
 //x=13.94 //y=0 //x2=11.285 //y2=0.615
cc_2149 ( N_noxref_16_c_3575_n N_noxref_20_c_4284_n ) capacitor c=0.0119573f \
 //x=10.797 //y=0.825 //x2=11.285 //y2=0.615
cc_2150 ( N_noxref_16_c_3581_n N_noxref_20_c_4284_n ) capacitor c=0.0147324f \
 //x=12.78 //y=0 //x2=11.285 //y2=0.615
cc_2151 ( N_noxref_16_c_3585_n N_noxref_20_c_4284_n ) capacitor c=0.00282583f \
 //x=9.62 //y=0 //x2=11.285 //y2=0.615
cc_2152 ( N_noxref_16_c_3625_n N_noxref_20_c_4284_n ) capacitor c=2.99181e-19 \
 //x=12.95 //y=0 //x2=11.285 //y2=0.615
cc_2153 ( N_noxref_16_c_3585_n N_noxref_20_c_4246_n ) capacitor c=2.8386e-19 \
 //x=9.62 //y=0 //x2=11.285 //y2=1.495
cc_2154 ( N_noxref_16_c_3600_n N_noxref_20_c_4251_n ) capacitor c=0.00989205f \
 //x=13.94 //y=0 //x2=12.17 //y2=0.53
cc_2155 ( N_noxref_16_c_3581_n N_noxref_20_c_4251_n ) capacitor c=0.0374392f \
 //x=12.78 //y=0 //x2=12.17 //y2=0.53
cc_2156 ( N_noxref_16_c_3755_n N_noxref_20_c_4251_n ) capacitor c=0.00198372f \
 //x=25.53 //y=0 //x2=12.17 //y2=0.53
cc_2157 ( N_noxref_16_c_3600_n N_noxref_20_c_4293_n ) capacitor c=0.00250872f \
 //x=13.94 //y=0 //x2=12.255 //y2=0.615
cc_2158 ( N_noxref_16_c_3581_n N_noxref_20_c_4293_n ) capacitor c=0.0145099f \
 //x=12.78 //y=0 //x2=12.255 //y2=0.615
cc_2159 ( N_noxref_16_c_3625_n N_noxref_20_c_4293_n ) capacitor c=0.0396774f \
 //x=12.95 //y=0 //x2=12.255 //y2=0.615
cc_2160 ( N_noxref_16_c_3561_n N_noxref_20_M6_noxref_s ) capacitor \
 c=0.00451005f //x=10.715 //y=0 //x2=10.18 //y2=0.365
cc_2161 ( N_noxref_16_c_3565_n N_noxref_20_M6_noxref_s ) capacitor \
 c=0.0100945f //x=10.8 //y=0.955 //x2=10.18 //y2=0.365
cc_2162 ( N_noxref_16_c_3575_n N_noxref_20_M6_noxref_s ) capacitor \
 c=0.0170608f //x=10.797 //y=0.825 //x2=10.18 //y2=0.365
cc_2163 ( N_noxref_16_c_3581_n N_noxref_20_M6_noxref_s ) capacitor c=0.014742f \
 //x=12.78 //y=0 //x2=10.18 //y2=0.365
cc_2164 ( N_noxref_16_c_3585_n N_noxref_20_M6_noxref_s ) capacitor \
 c=0.0528206f //x=9.62 //y=0 //x2=10.18 //y2=0.365
cc_2165 ( N_noxref_16_c_3625_n N_noxref_20_M6_noxref_s ) capacitor \
 c=0.00648063f //x=12.95 //y=0 //x2=10.18 //y2=0.365
cc_2166 ( N_noxref_16_M6_noxref_d N_noxref_20_M6_noxref_s ) capacitor \
 c=0.0271276f //x=10.61 //y=0.865 //x2=10.18 //y2=0.365
cc_2167 ( N_noxref_16_c_3600_n N_noxref_21_c_4307_n ) capacitor c=0.00113313f \
 //x=13.94 //y=0 //x2=14.425 //y2=1.59
cc_2168 ( N_noxref_16_c_3642_n N_noxref_21_c_4307_n ) capacitor c=7.40573e-19 \
 //x=18.75 //y=0 //x2=14.425 //y2=1.59
cc_2169 ( N_noxref_16_c_3610_n N_noxref_21_c_4307_n ) capacitor c=0.00365883f \
 //x=14.025 //y=0.965 //x2=14.425 //y2=1.59
cc_2170 ( N_noxref_16_c_3623_n N_noxref_21_c_4307_n ) capacitor c=0.00391745f \
 //x=17.59 //y=0 //x2=14.425 //y2=1.59
cc_2171 ( N_noxref_16_M8_noxref_d N_noxref_21_c_4307_n ) capacitor \
 c=0.00578031f //x=13.835 //y=0.875 //x2=14.425 //y2=1.59
cc_2172 ( N_noxref_16_c_3604_n N_noxref_21_c_4332_n ) capacitor c=0.0169052f \
 //x=14.025 //y=0.835 //x2=14.51 //y2=0.625
cc_2173 ( N_noxref_16_c_3642_n N_noxref_21_c_4332_n ) capacitor c=0.00439992f \
 //x=18.75 //y=0 //x2=14.51 //y2=0.625
cc_2174 ( N_noxref_16_c_3623_n N_noxref_21_c_4332_n ) capacitor c=0.0141422f \
 //x=17.59 //y=0 //x2=14.51 //y2=0.625
cc_2175 ( N_noxref_16_c_3625_n N_noxref_21_c_4332_n ) capacitor c=0.00322442f \
 //x=12.95 //y=0 //x2=14.51 //y2=0.625
cc_2176 ( N_noxref_16_c_3642_n N_noxref_21_c_4318_n ) capacitor c=0.0124355f \
 //x=18.75 //y=0 //x2=15.395 //y2=0.54
cc_2177 ( N_noxref_16_c_3623_n N_noxref_21_c_4318_n ) capacitor c=0.036101f \
 //x=17.59 //y=0 //x2=15.395 //y2=0.54
cc_2178 ( N_noxref_16_c_3755_n N_noxref_21_c_4318_n ) capacitor c=0.00177266f \
 //x=25.53 //y=0 //x2=15.395 //y2=0.54
cc_2179 ( N_noxref_16_c_3600_n N_noxref_21_M8_noxref_s ) capacitor \
 c=0.00439992f //x=13.94 //y=0 //x2=13.405 //y2=0.375
cc_2180 ( N_noxref_16_c_3604_n N_noxref_21_M8_noxref_s ) capacitor \
 c=0.0125586f //x=14.025 //y=0.835 //x2=13.405 //y2=0.375
cc_2181 ( N_noxref_16_c_3642_n N_noxref_21_M8_noxref_s ) capacitor \
 c=0.00444952f //x=18.75 //y=0 //x2=13.405 //y2=0.375
cc_2182 ( N_noxref_16_c_3610_n N_noxref_21_M8_noxref_s ) capacitor \
 c=0.00972044f //x=14.025 //y=0.965 //x2=13.405 //y2=0.375
cc_2183 ( N_noxref_16_c_3623_n N_noxref_21_M8_noxref_s ) capacitor \
 c=0.0273372f //x=17.59 //y=0 //x2=13.405 //y2=0.375
cc_2184 ( N_noxref_16_c_3625_n N_noxref_21_M8_noxref_s ) capacitor \
 c=0.0624873f //x=12.95 //y=0 //x2=13.405 //y2=0.375
cc_2185 ( N_noxref_16_c_3684_n N_noxref_21_M8_noxref_s ) capacitor \
 c=0.00166413f //x=17.76 //y=0 //x2=13.405 //y2=0.375
cc_2186 ( N_noxref_16_M8_noxref_d N_noxref_21_M8_noxref_s ) capacitor \
 c=0.0271316f //x=13.835 //y=0.875 //x2=13.405 //y2=0.375
cc_2187 ( N_noxref_16_c_3642_n N_noxref_22_c_4366_n ) capacitor c=0.00113313f \
 //x=18.75 //y=0 //x2=19.235 //y2=1.59
cc_2188 ( N_noxref_16_c_3712_n N_noxref_22_c_4366_n ) capacitor c=7.40573e-19 \
 //x=23.665 //y=0 //x2=19.235 //y2=1.59
cc_2189 ( N_noxref_16_c_3664_n N_noxref_22_c_4366_n ) capacitor c=0.00371063f \
 //x=18.835 //y=0.965 //x2=19.235 //y2=1.59
cc_2190 ( N_noxref_16_c_3676_n N_noxref_22_c_4366_n ) capacitor c=0.00391745f \
 //x=22.4 //y=0 //x2=19.235 //y2=1.59
cc_2191 ( N_noxref_16_M11_noxref_d N_noxref_22_c_4366_n ) capacitor \
 c=0.00578031f //x=18.645 //y=0.875 //x2=19.235 //y2=1.59
cc_2192 ( N_noxref_16_c_3650_n N_noxref_22_c_4392_n ) capacitor c=0.0169052f \
 //x=18.835 //y=0.835 //x2=19.32 //y2=0.625
cc_2193 ( N_noxref_16_c_3712_n N_noxref_22_c_4392_n ) capacitor c=0.00439992f \
 //x=23.665 //y=0 //x2=19.32 //y2=0.625
cc_2194 ( N_noxref_16_c_3676_n N_noxref_22_c_4392_n ) capacitor c=0.0141422f \
 //x=22.4 //y=0 //x2=19.32 //y2=0.625
cc_2195 ( N_noxref_16_c_3684_n N_noxref_22_c_4392_n ) capacitor c=0.00322478f \
 //x=17.76 //y=0 //x2=19.32 //y2=0.625
cc_2196 ( N_noxref_16_c_3712_n N_noxref_22_c_4379_n ) capacitor c=0.0133345f \
 //x=23.665 //y=0 //x2=20.205 //y2=0.54
cc_2197 ( N_noxref_16_c_3676_n N_noxref_22_c_4379_n ) capacitor c=0.0358643f \
 //x=22.4 //y=0 //x2=20.205 //y2=0.54
cc_2198 ( N_noxref_16_c_3755_n N_noxref_22_c_4379_n ) capacitor c=0.00177266f \
 //x=25.53 //y=0 //x2=20.205 //y2=0.54
cc_2199 ( N_noxref_16_c_3642_n N_noxref_22_M11_noxref_s ) capacitor \
 c=0.00439992f //x=18.75 //y=0 //x2=18.215 //y2=0.375
cc_2200 ( N_noxref_16_c_3650_n N_noxref_22_M11_noxref_s ) capacitor \
 c=0.0173062f //x=18.835 //y=0.835 //x2=18.215 //y2=0.375
cc_2201 ( N_noxref_16_c_3712_n N_noxref_22_M11_noxref_s ) capacitor \
 c=0.00682701f //x=23.665 //y=0 //x2=18.215 //y2=0.375
cc_2202 ( N_noxref_16_c_3664_n N_noxref_22_M11_noxref_s ) capacitor \
 c=0.00988958f //x=18.835 //y=0.965 //x2=18.215 //y2=0.375
cc_2203 ( N_noxref_16_c_3676_n N_noxref_22_M11_noxref_s ) capacitor \
 c=0.0272844f //x=22.4 //y=0 //x2=18.215 //y2=0.375
cc_2204 ( N_noxref_16_c_3684_n N_noxref_22_M11_noxref_s ) capacitor \
 c=0.0634633f //x=17.76 //y=0 //x2=18.215 //y2=0.375
cc_2205 ( N_noxref_16_c_3764_n N_noxref_22_M11_noxref_s ) capacitor \
 c=0.00166514f //x=22.57 //y=0 //x2=18.215 //y2=0.375
cc_2206 ( N_noxref_16_M11_noxref_d N_noxref_22_M11_noxref_s ) capacitor \
 c=0.0271316f //x=18.645 //y=0.875 //x2=18.215 //y2=0.375
cc_2207 ( N_noxref_16_c_3712_n N_noxref_23_c_4437_n ) capacitor c=0.00116473f \
 //x=23.665 //y=0 //x2=24.15 //y2=1.58
cc_2208 ( N_noxref_16_c_3734_n N_noxref_23_c_4437_n ) capacitor c=0.00203715f \
 //x=25.53 //y=0 //x2=24.15 //y2=1.58
cc_2209 ( N_noxref_16_c_3852_n N_noxref_23_c_4437_n ) capacitor c=0.00407704f \
 //x=23.75 //y=0.955 //x2=24.15 //y2=1.58
cc_2210 ( N_noxref_16_c_3755_n N_noxref_23_c_4437_n ) capacitor c=0.00386563f \
 //x=25.53 //y=0 //x2=24.15 //y2=1.58
cc_2211 ( N_noxref_16_M14_noxref_d N_noxref_23_c_4437_n ) capacitor \
 c=0.00578453f //x=23.56 //y=0.865 //x2=24.15 //y2=1.58
cc_2212 ( N_noxref_16_c_3734_n N_noxref_23_c_4452_n ) capacitor c=0.00558769f \
 //x=25.53 //y=0 //x2=24.235 //y2=0.615
cc_2213 ( N_noxref_16_c_3865_n N_noxref_23_c_4452_n ) capacitor c=0.0167642f \
 //x=23.747 //y=0.825 //x2=24.235 //y2=0.615
cc_2214 ( N_noxref_16_c_3755_n N_noxref_23_c_4452_n ) capacitor c=0.0148437f \
 //x=25.53 //y=0 //x2=24.235 //y2=0.615
cc_2215 ( N_noxref_16_c_3764_n N_noxref_23_c_4452_n ) capacitor c=0.00282583f \
 //x=22.57 //y=0 //x2=24.235 //y2=0.615
cc_2216 ( N_noxref_16_c_3764_n N_noxref_23_c_4422_n ) capacitor c=2.84067e-19 \
 //x=22.57 //y=0 //x2=24.235 //y2=1.495
cc_2217 ( N_noxref_16_c_3734_n N_noxref_23_c_4426_n ) capacitor c=0.0100063f \
 //x=25.53 //y=0 //x2=25.12 //y2=0.53
cc_2218 ( N_noxref_16_c_3755_n N_noxref_23_c_4426_n ) capacitor c=0.0395017f \
 //x=25.53 //y=0 //x2=25.12 //y2=0.53
cc_2219 ( N_noxref_16_c_3734_n N_noxref_23_c_4459_n ) capacitor c=0.00364221f \
 //x=25.53 //y=0 //x2=25.205 //y2=0.615
cc_2220 ( N_noxref_16_c_3755_n N_noxref_23_c_4459_n ) capacitor c=0.0567482f \
 //x=25.53 //y=0 //x2=25.205 //y2=0.615
cc_2221 ( N_noxref_16_c_3712_n N_noxref_23_M14_noxref_s ) capacitor \
 c=0.00723598f //x=23.665 //y=0 //x2=23.13 //y2=0.365
cc_2222 ( N_noxref_16_c_3852_n N_noxref_23_M14_noxref_s ) capacitor \
 c=0.0101884f //x=23.75 //y=0.955 //x2=23.13 //y2=0.365
cc_2223 ( N_noxref_16_c_3865_n N_noxref_23_M14_noxref_s ) capacitor \
 c=0.0173062f //x=23.747 //y=0.825 //x2=23.13 //y2=0.365
cc_2224 ( N_noxref_16_c_3755_n N_noxref_23_M14_noxref_s ) capacitor \
 c=0.0212635f //x=25.53 //y=0 //x2=23.13 //y2=0.365
cc_2225 ( N_noxref_16_c_3764_n N_noxref_23_M14_noxref_s ) capacitor \
 c=0.0528222f //x=22.57 //y=0 //x2=23.13 //y2=0.365
cc_2226 ( N_noxref_16_M14_noxref_d N_noxref_23_M14_noxref_s ) capacitor \
 c=0.0271276f //x=23.56 //y=0.865 //x2=23.13 //y2=0.365
cc_2227 ( N_noxref_17_c_4093_n N_noxref_23_c_4422_n ) capacitor c=0.00911405f \
 //x=24.805 //y=1.655 //x2=24.235 //y2=1.495
cc_2228 ( N_noxref_17_c_4027_n N_noxref_23_c_4426_n ) capacitor c=0.00361884f \
 //x=25.075 //y=1.655 //x2=25.12 //y2=0.53
cc_2229 ( N_noxref_17_c_4044_n N_noxref_23_c_4426_n ) capacitor c=0.00367971f \
 //x=24.72 //y=1 //x2=25.12 //y2=0.53
cc_2230 ( N_noxref_17_M15_noxref_d N_noxref_23_c_4426_n ) capacitor \
 c=0.00910163f //x=24.53 //y=0.905 //x2=25.12 //y2=0.53
cc_2231 ( N_noxref_17_c_4021_n N_noxref_23_M14_noxref_s ) capacitor \
 c=0.0175063f //x=24.72 //y=1.57 //x2=23.13 //y2=0.365
cc_2232 ( N_noxref_17_c_4027_n N_noxref_23_M14_noxref_s ) capacitor \
 c=0.0078077f //x=25.075 //y=1.655 //x2=23.13 //y2=0.365
cc_2233 ( N_noxref_17_c_4044_n N_noxref_23_M14_noxref_s ) capacitor \
 c=0.0104675f //x=24.72 //y=1 //x2=23.13 //y2=0.365
cc_2234 ( N_noxref_17_M15_noxref_d N_noxref_23_M14_noxref_s ) capacitor \
 c=0.0275552f //x=24.53 //y=0.905 //x2=23.13 //y2=0.365
cc_2235 ( N_noxref_20_c_4246_n N_noxref_21_c_4306_n ) capacitor c=6.40432e-19 \
 //x=11.285 //y=1.495 //x2=13.54 //y2=1.505
cc_2236 ( N_noxref_20_c_4293_n N_noxref_21_M8_noxref_s ) capacitor \
 c=0.00453771f //x=12.255 //y=0.615 //x2=13.405 //y2=0.375
cc_2237 ( N_noxref_20_M6_noxref_s N_noxref_21_M8_noxref_s ) capacitor \
 c=6.40432e-19 //x=10.18 //y=0.365 //x2=13.405 //y2=0.375
