// File: BUFX1.spi
// Created: Thu Jan 22 07:02:59 2026
// Program "Calibre xRC"
// Version "v2023.2_27.15"
//
simulator lang=spectre
include "/import/yukari1/lrburle/sky130RHBDlib/sky130_rhbd/pex/BUFX1.pex.spice"
subckt BUFX1 (  GND VDD A )
//
// A	A
// VDD	VDD
// GND	GND
M0_noxref ( N_noxref_1_M0_noxref_d N_A_M0_noxref_g N_GND_M0_noxref_s noxref_70 \
 ) NMOS l=0.163346 w=2.31104 m=1
M1_noxref ( N_noxref_5_M1_noxref_d N_noxref_1_M1_noxref_g N_GND_M1_noxref_s \
 noxref_70 ) NMOS l=0.163346 w=2.31104 m=1
M2_noxref ( N_noxref_1_M2_noxref_d N_A_M2_noxref_g N_VDD_M2_noxref_s noxref_68 \
 ) PMOS l=0.15 w=2 ad=0.57 as=0.57 pd=2.57 ps=2.57 nrd=0 nrs=0 m=1
M3_noxref ( N_VDD_M3_noxref_d N_A_M3_noxref_g N_noxref_1_M2_noxref_d noxref_68 \
 ) PMOS l=0.15 w=2 ad=0.56 as=0.56 pd=2.56 ps=2.56 nrd=0 nrs=0 m=1
M4_noxref ( N_noxref_5_M4_noxref_d N_noxref_1_M4_noxref_g N_VDD_M4_noxref_s \
 noxref_68 ) PMOS l=0.15 w=2 ad=0.57 as=0.57 pd=2.57 ps=2.57 nrd=0 nrs=0 m=1
M5_noxref ( N_VDD_M5_noxref_d N_noxref_1_M5_noxref_g N_noxref_5_M4_noxref_d \
 noxref_68 ) PMOS l=0.15 w=2 ad=0.56 as=0.56 pd=2.56 ps=2.56 nrd=0 nrs=0 m=1
//
include "/import/yukari1/lrburle/sky130RHBDlib/sky130_rhbd/pex/BUFX1.pxi.spice"
//
ends BUFX1
//
//
