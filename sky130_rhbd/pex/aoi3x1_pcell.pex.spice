// File: aoi3x1_pcell.spi.pex
// Created: Sun Mar 15 12:48:26 2026
// Program "Calibre xRC"
// Version "v2023.2_27.15"
// Nominal Temperature: 30C
// Circuit Temperature: 30C
//
simulator lang=spectre
subckt PM_AOI3X1_PCELL\%noxref_1 ( 3 8 9 11 12 14 15 16 18 19 20 23 24 27 29 \
 32 35 38 42 44 45 50 53 61 78 83 91 92 93 94 95 96 97 101 103 106 108 109 114 \
 124 126 127 )
c261 ( 124 0 ) capacitor c=0.00878249f //x=1.96 //y=0.905
c262 ( 114 0 ) capacitor c=0.0426341f //x=4.285 //y=4.705
c263 ( 109 0 ) capacitor c=0.0337825f //x=4.775 //y=1.25
c264 ( 108 0 ) capacitor c=0.0183823f //x=4.775 //y=0.905
c265 ( 106 0 ) capacitor c=0.0350928f //x=4.705 //y=4.795
c266 ( 103 0 ) capacitor c=0.013578f //x=4.62 //y=1.405
c267 ( 101 0 ) capacitor c=0.0157803f //x=4.62 //y=0.75
c268 ( 97 0 ) capacitor c=0.0787244f //x=4.245 //y=1.915
c269 ( 96 0 ) capacitor c=0.0230165f //x=4.245 //y=1.56
c270 ( 95 0 ) capacitor c=0.0234348f //x=4.245 //y=1.25
c271 ( 94 0 ) capacitor c=0.019134f //x=4.245 //y=0.905
c272 ( 93 0 ) capacitor c=0.110994f //x=4.78 //y=6.025
c273 ( 92 0 ) capacitor c=0.154777f //x=4.34 //y=6.025
c274 ( 83 0 ) capacitor c=4.74639e-19 //x=4.44 //y=2.08
c275 ( 78 0 ) capacitor c=0.00705226f //x=4.285 //y=4.705
c276 ( 61 0 ) capacitor c=0.0325392f //x=2.11 //y=5.38
c277 ( 53 0 ) capacitor c=0.0291911f //x=1.23 //y=5.38
c278 ( 50 0 ) capacitor c=0.00527867f //x=4.435 //y=2.59
c279 ( 45 0 ) capacitor c=0.00557348f //x=2.75 //y=2.59
c280 ( 44 0 ) capacitor c=0.0774598f //x=4.275 //y=2.59
c281 ( 42 0 ) capacitor c=0.00772583f //x=4.285 //y=4.705
c282 ( 38 0 ) capacitor c=0.00636094f //x=4.44 //y=2.08
c283 ( 35 0 ) capacitor c=0.0143957f //x=4.435 //y=2.59
c284 ( 32 0 ) capacitor c=0.0146565f //x=2.59 //y=2.59
c285 ( 29 0 ) capacitor c=0.011771f //x=2.15 //y=1
c286 ( 27 0 ) capacitor c=6.70882e-19 //x=2.11 //y=5.38
c287 ( 24 0 ) capacitor c=0.0129472f //x=2.11 //y=5.2
c288 ( 23 0 ) capacitor c=0.0106213f //x=1.23 //y=5.38
c289 ( 20 0 ) capacitor c=0.0625282f //x=4.44 //y=4.585
c290 ( 19 0 ) capacitor c=0.0110433f //x=4.44 //y=2.75
c291 ( 18 0 ) capacitor c=0.00430528f //x=4.44 //y=2.43
c292 ( 16 0 ) capacitor c=0.0773577f //x=2.59 //y=5.115
c293 ( 15 0 ) capacitor c=0.0117792f //x=2.59 //y=2.75
c294 ( 14 0 ) capacitor c=0.0185227f //x=2.59 //y=2.43
c295 ( 12 0 ) capacitor c=0.00837358f //x=2.235 //y=1.655
c296 ( 11 0 ) capacitor c=0.0136835f //x=2.505 //y=1.655
c297 ( 9 0 ) capacitor c=0.0123988f //x=2.505 //y=5.2
c298 ( 8 0 ) capacitor c=0.012699f //x=2.15 //y=1.57
c299 ( 3 0 ) capacitor c=0.019362f //x=1.995 //y=5.2
r300 (  116 117 ) resistor r=32.4568 //w=0.214 //l=0.075 //layer=ply \
 //thickness=0.18 //x=4.285 //y=4.795 //x2=4.285 //y2=4.87
r301 (  114 116 ) resistor r=20.271 //w=0.214 //l=0.09 //layer=ply \
 //thickness=0.18 //x=4.285 //y=4.705 //x2=4.285 //y2=4.795
r302 (  109 123 ) resistor r=45.1352 //w=0.168 //l=0.173853 //layer=ply \
 //thickness=0.18 //x=4.775 //y=1.25 //x2=4.735 //y2=1.405
r303 (  108 122 ) resistor r=45.1352 //w=0.168 //l=0.173853 //layer=ply \
 //thickness=0.18 //x=4.775 //y=0.905 //x2=4.735 //y2=0.75
r304 (  108 109 ) resistor r=176.904 //w=0.094 //l=0.345 //layer=ply \
 //thickness=0.18 //x=4.775 //y=0.905 //x2=4.775 //y2=1.25
r305 (  107 116 ) resistor r=16.5046 //w=0.27 //l=0.135 //layer=ply \
 //thickness=0.18 //x=4.42 //y=4.795 //x2=4.285 //y2=4.795
r306 (  106 110 ) resistor r=26.9307 //w=0.15 //l=0.106066 //layer=ply \
 //thickness=0.18 //x=4.705 //y=4.795 //x2=4.78 //y2=4.87
r307 (  106 107 ) resistor r=146.138 //w=0.094 //l=0.285 //layer=ply \
 //thickness=0.18 //x=4.705 //y=4.795 //x2=4.42 //y2=4.795
r308 (  104 121 ) resistor r=10.701 //w=0.21 //l=0.115 //layer=ply \
 //thickness=0.18 //x=4.4 //y=1.405 //x2=4.285 //y2=1.405
r309 (  103 123 ) resistor r=5.52526 //w=0.168 //l=0.115 //layer=ply \
 //thickness=0.18 //x=4.62 //y=1.405 //x2=4.735 //y2=1.405
r310 (  102 120 ) resistor r=5.52526 //w=0.168 //l=0.115 //layer=ply \
 //thickness=0.18 //x=4.4 //y=0.75 //x2=4.285 //y2=0.75
r311 (  101 122 ) resistor r=5.52526 //w=0.168 //l=0.115 //layer=ply \
 //thickness=0.18 //x=4.62 //y=0.75 //x2=4.735 //y2=0.75
r312 (  101 102 ) resistor r=112.809 //w=0.094 //l=0.22 //layer=ply \
 //thickness=0.18 //x=4.62 //y=0.75 //x2=4.4 //y2=0.75
r313 (  97 119 ) resistor r=34.8111 //w=0.27 //l=0.264953 //layer=ply \
 //thickness=0.18 //x=4.245 //y=1.915 //x2=4.44 //y2=2.08
r314 (  96 121 ) resistor r=39.5823 //w=0.21 //l=0.173853 //layer=ply \
 //thickness=0.18 //x=4.245 //y=1.56 //x2=4.285 //y2=1.405
r315 (  96 97 ) resistor r=182.032 //w=0.094 //l=0.355 //layer=ply \
 //thickness=0.18 //x=4.245 //y=1.56 //x2=4.245 //y2=1.915
r316 (  95 121 ) resistor r=39.5823 //w=0.21 //l=0.173853 //layer=ply \
 //thickness=0.18 //x=4.245 //y=1.25 //x2=4.285 //y2=1.405
r317 (  94 120 ) resistor r=45.1352 //w=0.168 //l=0.173853 //layer=ply \
 //thickness=0.18 //x=4.245 //y=0.905 //x2=4.285 //y2=0.75
r318 (  94 95 ) resistor r=176.904 //w=0.094 //l=0.345 //layer=ply \
 //thickness=0.18 //x=4.245 //y=0.905 //x2=4.245 //y2=1.25
r319 (  93 110 ) resistor r=592.245 //w=0.094 //l=1.155 //layer=ply \
 //thickness=0.18 //x=4.78 //y=6.025 //x2=4.78 //y2=4.87
r320 (  92 117 ) resistor r=592.245 //w=0.094 //l=1.155 //layer=ply \
 //thickness=0.18 //x=4.34 //y=6.025 //x2=4.34 //y2=4.87
r321 (  91 103 ) resistor r=56.4043 //w=0.094 //l=0.11 //layer=ply \
 //thickness=0.18 //x=4.51 //y=1.405 //x2=4.62 //y2=1.405
r322 (  91 104 ) resistor r=56.4043 //w=0.094 //l=0.11 //layer=ply \
 //thickness=0.18 //x=4.51 //y=1.405 //x2=4.4 //y2=1.405
r323 (  83 119 ) resistor r=152 //w=0.17 //l=0.17 //layer=licon //count=1 \
 //x=4.44 //y=2.08 //x2=4.44 //y2=2.08
r324 (  78 114 ) resistor r=152 //w=0.17 //l=0.17 //layer=licon //count=1 \
 //x=4.285 //y=4.705 //x2=4.285 //y2=4.705
r325 (  61 127 ) resistor r=23.615 //w=0.187 //l=0.345 //layer=li \
 //thickness=0.1 //x=2.11 //y=5.38 //x2=2.11 //y2=5.725
r326 (  53 126 ) resistor r=23.615 //w=0.187 //l=0.345 //layer=li \
 //thickness=0.1 //x=1.23 //y=5.38 //x2=1.23 //y2=5.725
r327 (  45 47 ) resistor r=0.10734 //w=0.281 //l=0.16 //layer=m2 \
 //thickness=0.36 //x=2.75 //y=2.59 //x2=2.59 //y2=2.59
r328 (  44 50 ) resistor r=0.10734 //w=0.281 //l=0.16 //layer=m2 \
 //thickness=0.36 //x=4.275 //y=2.59 //x2=4.435 //y2=2.59
r329 (  44 45 ) resistor r=1.45515 //w=0.131 //l=1.525 //layer=m2 \
 //thickness=0.36 //x=4.275 //y=2.59 //x2=2.75 //y2=2.59
r330 (  42 78 ) resistor r=9.3 //w=0.17 //l=0.17 //layer=mcon //count=1 \
 //x=4.285 //y=4.705 //x2=4.285 //y2=4.705
r331 (  42 43 ) resistor r=0.0853524 //w=0.227 //l=0.155 //layer=m1 \
 //thickness=0.36 //x=4.285 //y=4.702 //x2=4.44 //y2=4.702
r332 (  38 83 ) resistor r=9.3 //w=0.17 //l=0.17 //layer=mcon //count=1 \
 //x=4.44 //y=2.08 //x2=4.44 //y2=2.08
r333 (  38 40 ) resistor r=0.0985786 //w=0.206 //l=0.135 //layer=m1 \
 //thickness=0.36 //x=4.437 //y=2.08 //x2=4.437 //y2=2.215
r334 (  35 50 ) resistor r=4.5 //w=0.15 //l=0.15 //layer=via1 //count=1 \
 //x=4.435 //y=2.59 //x2=4.435 //y2=2.59
r335 (  32 47 ) resistor r=4.5 //w=0.15 //l=0.15 //layer=via1 //count=1 \
 //x=2.59 //y=2.59 //x2=2.59 //y2=2.59
r336 (  29 124 ) resistor r=9.3 //w=0.17 //l=0.17 //layer=mcon //count=1 \
 //x=2.15 //y=1 //x2=2.15 //y2=1
r337 (  27 61 ) resistor r=9.3 //w=0.17 //l=0.17 //layer=mcon //count=1 \
 //x=2.11 //y=5.38 //x2=2.11 //y2=5.38
r338 (  24 27 ) resistor r=0.117801 //w=0.191 //l=0.18 //layer=m1 \
 //thickness=0.36 //x=2.11 //y=5.2 //x2=2.11 //y2=5.38
r339 (  23 53 ) resistor r=9.3 //w=0.17 //l=0.17 //layer=mcon //count=1 \
 //x=1.23 //y=5.38 //x2=1.23 //y2=5.38
r340 (  21 23 ) resistor r=0.10274 //w=0.219 //l=0.18 //layer=m1 \
 //thickness=0.36 //x=1.23 //y=5.2 //x2=1.23 //y2=5.38
r341 (  20 43 ) resistor r=0.0249239 //w=0.227 //l=0.117 //layer=m1 \
 //thickness=0.36 //x=4.44 //y=4.585 //x2=4.44 //y2=4.702
r342 (  19 35 ) resistor r=0.0910802 //w=0.374 //l=0.185472 //layer=m1 \
 //thickness=0.36 //x=4.44 //y=2.75 //x2=4.385 //y2=2.59
r343 (  19 20 ) resistor r=1.75095 //w=0.131 //l=1.835 //layer=m1 \
 //thickness=0.36 //x=4.44 //y=2.75 //x2=4.44 //y2=4.585
r344 (  18 35 ) resistor r=0.0910802 //w=0.374 //l=0.185472 //layer=m1 \
 //thickness=0.36 //x=4.44 //y=2.43 //x2=4.385 //y2=2.59
r345 (  18 40 ) resistor r=0.205153 //w=0.131 //l=0.215 //layer=m1 \
 //thickness=0.36 //x=4.44 //y=2.43 //x2=4.44 //y2=2.215
r346 (  15 32 ) resistor r=0.0911593 //w=0.376 //l=0.184174 //layer=m1 \
 //thickness=0.36 //x=2.59 //y=2.75 //x2=2.642 //y2=2.59
r347 (  15 16 ) resistor r=2.25668 //w=0.131 //l=2.365 //layer=m1 \
 //thickness=0.36 //x=2.59 //y=2.75 //x2=2.59 //y2=5.115
r348 (  14 32 ) resistor r=0.0911593 //w=0.376 //l=0.184174 //layer=m1 \
 //thickness=0.36 //x=2.59 //y=2.43 //x2=2.642 //y2=2.59
r349 (  13 14 ) resistor r=0.658397 //w=0.131 //l=0.69 //layer=m1 \
 //thickness=0.36 //x=2.59 //y=1.74 //x2=2.59 //y2=2.43
r350 (  11 13 ) resistor r=0.0698411 //w=0.17 //l=0.120208 //layer=m1 \
 //thickness=0.36 //x=2.505 //y=1.655 //x2=2.59 //y2=1.74
r351 (  11 12 ) resistor r=0.257634 //w=0.131 //l=0.27 //layer=m1 \
 //thickness=0.36 //x=2.505 //y=1.655 //x2=2.235 //y2=1.655
r352 (  10 24 ) resistor r=0.0257089 //w=0.23 //l=0.115 //layer=m1 \
 //thickness=0.36 //x=2.225 //y=5.2 //x2=2.11 //y2=5.2
r353 (  9 16 ) resistor r=0.0698411 //w=0.17 //l=0.120208 //layer=m1 \
 //thickness=0.36 //x=2.505 //y=5.2 //x2=2.59 //y2=5.115
r354 (  9 10 ) resistor r=0.267176 //w=0.131 //l=0.28 //layer=m1 \
 //thickness=0.36 //x=2.505 //y=5.2 //x2=2.225 //y2=5.2
r355 (  8 12 ) resistor r=0.0698411 //w=0.17 //l=0.120208 //layer=m1 \
 //thickness=0.36 //x=2.15 //y=1.57 //x2=2.235 //y2=1.655
r356 (  7 29 ) resistor r=0.0913624 //w=0.191 //l=0.12 //layer=m1 \
 //thickness=0.36 //x=2.15 //y=1.12 //x2=2.15 //y2=1
r357 (  7 8 ) resistor r=0.429389 //w=0.131 //l=0.45 //layer=m1 \
 //thickness=0.36 //x=2.15 //y=1.12 //x2=2.15 //y2=1.57
r358 (  4 21 ) resistor r=0.0227762 //w=0.219 //l=0.115 //layer=m1 \
 //thickness=0.36 //x=1.345 //y=5.2 //x2=1.23 //y2=5.2
r359 (  3 24 ) resistor r=0.0257089 //w=0.23 //l=0.115 //layer=m1 \
 //thickness=0.36 //x=1.995 //y=5.2 //x2=2.11 //y2=5.2
r360 (  3 4 ) resistor r=0.620229 //w=0.131 //l=0.65 //layer=m1 \
 //thickness=0.36 //x=1.995 //y=5.2 //x2=1.345 //y2=5.2
ends PM_AOI3X1_PCELL\%noxref_1

subckt PM_AOI3X1_PCELL\%noxref_2 ( 1 11 12 17 36 44 67 78 81 82 83 84 85 )
c123 ( 85 0 ) capacitor c=0.0230411f //x=4.415 //y=5.025
c124 ( 84 0 ) capacitor c=0.0399063f //x=2.405 //y=5.02
c125 ( 83 0 ) capacitor c=0.0247431f //x=1.525 //y=5.02
c126 ( 82 0 ) capacitor c=0.0678024f //x=0.655 //y=5.02
c127 ( 81 0 ) capacitor c=0.126491f //x=3.33 //y=7.4
c128 ( 80 0 ) capacitor c=0.00591168f //x=2.55 //y=7.4
c129 ( 79 0 ) capacitor c=0.00591168f //x=1.67 //y=7.4
c130 ( 78 0 ) capacitor c=0.253139f //x=0.74 //y=7.4
c131 ( 67 0 ) capacitor c=0.353699f //x=6.29 //y=7.4
c132 ( 54 0 ) capacitor c=0.0275781f //x=3.16 //y=7.4
c133 ( 44 0 ) capacitor c=0.0284687f //x=2.465 //y=7.4
c134 ( 36 0 ) capacitor c=0.0288404f //x=1.585 //y=7.4
c135 ( 21 0 ) capacitor c=0.00498911f //x=4.56 //y=7.4
c136 ( 17 0 ) capacitor c=0.0853276f //x=6.29 //y=7.4
c137 ( 12 0 ) capacitor c=0.00916089f //x=4.56 //y=7.23
c138 ( 11 0 ) capacitor c=0.00572492f //x=4.56 //y=6.855
c139 ( 1 0 ) capacitor c=0.17911f //x=4.475 //y=7.4
r140 (  65 67 ) resistor r=26.5322 //w=0.357 //l=0.74 //layer=li \
 //thickness=0.1 //x=5.55 //y=7.4 //x2=6.29 //y2=7.4
r141 (  63 65 ) resistor r=39.7983 //w=0.357 //l=1.11 //layer=li \
 //thickness=0.1 //x=4.44 //y=7.4 //x2=5.55 //y2=7.4
r142 (  61 81 ) resistor r=5.4201 //w=0.34 //l=0.17 //layer=li //thickness=0.1 \
 //x=3.5 //y=7.4 //x2=3.33 //y2=7.4
r143 (  61 63 ) resistor r=33.7031 //w=0.357 //l=0.94 //layer=li \
 //thickness=0.1 //x=3.5 //y=7.4 //x2=4.44 //y2=7.4
r144 (  55 80 ) resistor r=2.94794 //w=0.34 //l=0.085 //layer=li \
 //thickness=0.1 //x=2.635 //y=7.4 //x2=2.55 //y2=7.4
r145 (  55 57 ) resistor r=11.6527 //w=0.357 //l=0.325 //layer=li \
 //thickness=0.1 //x=2.635 //y=7.4 //x2=2.96 //y2=7.4
r146 (  54 81 ) resistor r=5.4201 //w=0.34 //l=0.17 //layer=li //thickness=0.1 \
 //x=3.16 //y=7.4 //x2=3.33 //y2=7.4
r147 (  54 57 ) resistor r=7.17087 //w=0.357 //l=0.2 //layer=li \
 //thickness=0.1 //x=3.16 //y=7.4 //x2=2.96 //y2=7.4
r148 (  48 80 ) resistor r=4.11603 //w=0.68 //l=0.17 //layer=li \
 //thickness=0.1 //x=2.55 //y=7.23 //x2=2.55 //y2=7.4
r149 (  48 84 ) resistor r=33.1979 //w=0.187 //l=0.485 //layer=li \
 //thickness=0.1 //x=2.55 //y=7.23 //x2=2.55 //y2=6.745
r150 (  45 79 ) resistor r=2.94794 //w=0.34 //l=0.085 //layer=li \
 //thickness=0.1 //x=1.755 //y=7.4 //x2=1.67 //y2=7.4
r151 (  45 47 ) resistor r=3.40616 //w=0.357 //l=0.095 //layer=li \
 //thickness=0.1 //x=1.755 //y=7.4 //x2=1.85 //y2=7.4
r152 (  44 80 ) resistor r=2.94794 //w=0.34 //l=0.085 //layer=li \
 //thickness=0.1 //x=2.465 //y=7.4 //x2=2.55 //y2=7.4
r153 (  44 47 ) resistor r=22.0504 //w=0.357 //l=0.615 //layer=li \
 //thickness=0.1 //x=2.465 //y=7.4 //x2=1.85 //y2=7.4
r154 (  38 79 ) resistor r=4.11603 //w=0.68 //l=0.17 //layer=li \
 //thickness=0.1 //x=1.67 //y=7.23 //x2=1.67 //y2=7.4
r155 (  38 83 ) resistor r=33.1979 //w=0.187 //l=0.485 //layer=li \
 //thickness=0.1 //x=1.67 //y=7.23 //x2=1.67 //y2=6.745
r156 (  37 78 ) resistor r=2.94794 //w=0.34 //l=0.085 //layer=li \
 //thickness=0.1 //x=0.875 //y=7.4 //x2=0.79 //y2=7.4
r157 (  36 79 ) resistor r=2.94794 //w=0.34 //l=0.085 //layer=li \
 //thickness=0.1 //x=1.585 //y=7.4 //x2=1.67 //y2=7.4
r158 (  36 37 ) resistor r=25.4566 //w=0.357 //l=0.71 //layer=li \
 //thickness=0.1 //x=1.585 //y=7.4 //x2=0.875 //y2=7.4
r159 (  28 78 ) resistor r=4.11603 //w=0.68 //l=0.17 //layer=li \
 //thickness=0.1 //x=0.79 //y=7.23 //x2=0.79 //y2=7.4
r160 (  28 82 ) resistor r=56.4706 //w=0.187 //l=0.825 //layer=li \
 //thickness=0.1 //x=0.79 //y=7.23 //x2=0.79 //y2=6.405
r161 (  23 85 ) resistor r=9.3 //w=0.17 //l=0.17 //layer=mcon //count=1 \
 //x=4.56 //y=6.74 //x2=4.56 //y2=6.74
r162 (  17 67 ) resistor r=9.3 //w=0.17 //l=0.17 //layer=mcon //count=1 \
 //x=6.29 //y=7.4 //x2=6.29 //y2=7.4
r163 (  15 65 ) resistor r=3.1 //w=0.17 //l=0.51 //layer=mcon //count=3 \
 //x=5.55 //y=7.4 //x2=5.55 //y2=7.4
r164 (  15 17 ) resistor r=0.307309 //w=0.301 //l=0.74 //layer=m1 \
 //thickness=0.36 //x=5.55 //y=7.4 //x2=6.29 //y2=7.4
r165 (  13 21 ) resistor r=0.0287885 //w=0.34 //l=0.085 //layer=m1 \
 //thickness=0.36 //x=4.645 //y=7.4 //x2=4.56 //y2=7.4
r166 (  13 15 ) resistor r=0.375831 //w=0.301 //l=0.905 //layer=m1 \
 //thickness=0.36 //x=4.645 //y=7.4 //x2=5.55 //y2=7.4
r167 (  12 21 ) resistor r=0.0401957 //w=0.68 //l=0.17 //layer=m1 \
 //thickness=0.36 //x=4.56 //y=7.23 //x2=4.56 //y2=7.4
r168 (  11 23 ) resistor r=0.0723371 //w=0.218 //l=0.115 //layer=m1 \
 //thickness=0.36 //x=4.56 //y=6.855 //x2=4.56 //y2=6.74
r169 (  11 12 ) resistor r=0.357824 //w=0.131 //l=0.375 //layer=m1 \
 //thickness=0.36 //x=4.56 //y=6.855 //x2=4.56 //y2=7.23
r170 (  10 63 ) resistor r=3.1 //w=0.17 //l=0.51 //layer=mcon //count=3 \
 //x=4.44 //y=7.4 //x2=4.44 //y2=7.4
r171 (  8 57 ) resistor r=3.1 //w=0.17 //l=0.51 //layer=mcon //count=3 \
 //x=2.96 //y=7.4 //x2=2.96 //y2=7.4
r172 (  8 10 ) resistor r=0.614618 //w=0.301 //l=1.48 //layer=m1 \
 //thickness=0.36 //x=2.96 //y=7.4 //x2=4.44 //y2=7.4
r173 (  6 47 ) resistor r=3.1 //w=0.17 //l=0.51 //layer=mcon //count=3 \
 //x=1.85 //y=7.4 //x2=1.85 //y2=7.4
r174 (  6 8 ) resistor r=0.460963 //w=0.301 //l=1.11 //layer=m1 \
 //thickness=0.36 //x=1.85 //y=7.4 //x2=2.96 //y2=7.4
r175 (  3 78 ) resistor r=3.1 //w=0.17 //l=0.51 //layer=mcon //count=3 \
 //x=0.74 //y=7.4 //x2=0.74 //y2=7.4
r176 (  3 6 ) resistor r=0.460963 //w=0.301 //l=1.11 //layer=m1 \
 //thickness=0.36 //x=0.74 //y=7.4 //x2=1.85 //y2=7.4
r177 (  1 21 ) resistor r=0.0287885 //w=0.34 //l=0.085 //layer=m1 \
 //thickness=0.36 //x=4.475 //y=7.4 //x2=4.56 //y2=7.4
r178 (  1 10 ) resistor r=0.0145349 //w=0.301 //l=0.035 //layer=m1 \
 //thickness=0.36 //x=4.475 //y=7.4 //x2=4.44 //y2=7.4
ends PM_AOI3X1_PCELL\%noxref_2

subckt PM_AOI3X1_PCELL\%noxref_3 ( 4 7 8 11 16 20 21 22 23 24 25 26 30 32 35 \
 36 46 )
c96 ( 46 0 ) capacitor c=0.0682508f //x=1.11 //y=4.7
c97 ( 36 0 ) capacitor c=0.0318956f //x=1.445 //y=1.21
c98 ( 35 0 ) capacitor c=0.0186809f //x=1.445 //y=0.865
c99 ( 32 0 ) capacitor c=0.0141821f //x=1.29 //y=1.365
c100 ( 30 0 ) capacitor c=0.0158553f //x=1.29 //y=0.71
c101 ( 26 0 ) capacitor c=0.088055f //x=0.915 //y=1.915
c102 ( 25 0 ) capacitor c=0.0229235f //x=0.915 //y=1.52
c103 ( 24 0 ) capacitor c=0.0234359f //x=0.915 //y=1.21
c104 ( 23 0 ) capacitor c=0.0198759f //x=0.915 //y=0.865
c105 ( 22 0 ) capacitor c=0.110369f //x=1.45 //y=6.02
c106 ( 21 0 ) capacitor c=0.154619f //x=1.01 //y=6.02
c107 ( 16 0 ) capacitor c=8.13451e-19 //x=1.11 //y=4.7
c108 ( 11 0 ) capacitor c=7.85889e-19 //x=1.11 //y=2.08
c109 ( 8 0 ) capacitor c=0.10646f //x=1.112 //y=4.56
c110 ( 7 0 ) capacitor c=0.0113945f //x=1.11 //y=4.7
c111 ( 4 0 ) capacitor c=0.0108617f //x=1.11 //y=2.08
r112 (  44 46 ) resistor r=20.6867 //w=0.233 //l=0.1 //layer=ply \
 //thickness=0.18 //x=1.01 //y=4.7 //x2=1.11 //y2=4.7
r113 (  37 46 ) resistor r=70.3348 //w=0.233 //l=0.414367 //layer=ply \
 //thickness=0.18 //x=1.45 //y=4.865 //x2=1.11 //y2=4.7
r114 (  36 48 ) resistor r=45.1352 //w=0.168 //l=0.173853 //layer=ply \
 //thickness=0.18 //x=1.445 //y=1.21 //x2=1.405 //y2=1.365
r115 (  35 47 ) resistor r=45.1352 //w=0.168 //l=0.173853 //layer=ply \
 //thickness=0.18 //x=1.445 //y=0.865 //x2=1.405 //y2=0.71
r116 (  35 36 ) resistor r=176.904 //w=0.094 //l=0.345 //layer=ply \
 //thickness=0.18 //x=1.445 //y=0.865 //x2=1.445 //y2=1.21
r117 (  33 43 ) resistor r=10.701 //w=0.21 //l=0.115 //layer=ply \
 //thickness=0.18 //x=1.07 //y=1.365 //x2=0.955 //y2=1.365
r118 (  32 48 ) resistor r=5.52526 //w=0.168 //l=0.115 //layer=ply \
 //thickness=0.18 //x=1.29 //y=1.365 //x2=1.405 //y2=1.365
r119 (  31 42 ) resistor r=5.52526 //w=0.168 //l=0.115 //layer=ply \
 //thickness=0.18 //x=1.07 //y=0.71 //x2=0.955 //y2=0.71
r120 (  30 47 ) resistor r=5.52526 //w=0.168 //l=0.115 //layer=ply \
 //thickness=0.18 //x=1.29 //y=0.71 //x2=1.405 //y2=0.71
r121 (  30 31 ) resistor r=112.809 //w=0.094 //l=0.22 //layer=ply \
 //thickness=0.18 //x=1.29 //y=0.71 //x2=1.07 //y2=0.71
r122 (  27 44 ) resistor r=13.0941 //w=0.233 //l=0.165 //layer=ply \
 //thickness=0.18 //x=1.01 //y=4.865 //x2=1.01 //y2=4.7
r123 (  26 41 ) resistor r=34.8111 //w=0.27 //l=0.264953 //layer=ply \
 //thickness=0.18 //x=0.915 //y=1.915 //x2=1.11 //y2=2.08
r124 (  25 43 ) resistor r=39.5823 //w=0.21 //l=0.173853 //layer=ply \
 //thickness=0.18 //x=0.915 //y=1.52 //x2=0.955 //y2=1.365
r125 (  25 26 ) resistor r=202.543 //w=0.094 //l=0.395 //layer=ply \
 //thickness=0.18 //x=0.915 //y=1.52 //x2=0.915 //y2=1.915
r126 (  24 43 ) resistor r=39.5823 //w=0.21 //l=0.173853 //layer=ply \
 //thickness=0.18 //x=0.915 //y=1.21 //x2=0.955 //y2=1.365
r127 (  23 42 ) resistor r=45.1352 //w=0.168 //l=0.173853 //layer=ply \
 //thickness=0.18 //x=0.915 //y=0.865 //x2=0.955 //y2=0.71
r128 (  23 24 ) resistor r=176.904 //w=0.094 //l=0.345 //layer=ply \
 //thickness=0.18 //x=0.915 //y=0.865 //x2=0.915 //y2=1.21
r129 (  22 37 ) resistor r=592.245 //w=0.094 //l=1.155 //layer=ply \
 //thickness=0.18 //x=1.45 //y=6.02 //x2=1.45 //y2=4.865
r130 (  21 27 ) resistor r=592.245 //w=0.094 //l=1.155 //layer=ply \
 //thickness=0.18 //x=1.01 //y=6.02 //x2=1.01 //y2=4.865
r131 (  20 32 ) resistor r=56.4043 //w=0.094 //l=0.11 //layer=ply \
 //thickness=0.18 //x=1.18 //y=1.365 //x2=1.29 //y2=1.365
r132 (  20 33 ) resistor r=56.4043 //w=0.094 //l=0.11 //layer=ply \
 //thickness=0.18 //x=1.18 //y=1.365 //x2=1.07 //y2=1.365
r133 (  16 46 ) resistor r=152 //w=0.17 //l=0.17 //layer=licon //count=1 \
 //x=1.11 //y=4.7 //x2=1.11 //y2=4.7
r134 (  11 41 ) resistor r=152 //w=0.17 //l=0.17 //layer=licon //count=1 \
 //x=1.11 //y=2.08 //x2=1.11 //y2=2.08
r135 (  7 16 ) resistor r=9.3 //w=0.17 //l=0.17 //layer=mcon //count=1 \
 //x=1.11 //y=4.7 //x2=1.11 //y2=4.7
r136 (  7 8 ) resistor r=0.103207 //w=0.196 //l=0.14 //layer=m1 \
 //thickness=0.36 //x=1.112 //y=4.7 //x2=1.112 //y2=4.56
r137 (  4 11 ) resistor r=9.3 //w=0.17 //l=0.17 //layer=mcon //count=1 \
 //x=1.11 //y=2.08 //x2=1.11 //y2=2.08
r138 (  1 4 ) resistor r=0.0933015 //w=0.201 //l=0.125 //layer=m1 \
 //thickness=0.36 //x=1.11 //y=2.205 //x2=1.11 //y2=2.08
r139 (  1 8 ) resistor r=2.24714 //w=0.131 //l=2.355 //layer=m1 \
 //thickness=0.36 //x=1.11 //y=2.205 //x2=1.11 //y2=4.56
ends PM_AOI3X1_PCELL\%noxref_3

subckt PM_AOI3X1_PCELL\%noxref_4 ( 1 17 20 21 26 29 44 53 67 80 83 93 94 )
c138 ( 94 0 ) capacitor c=0.0750962f //x=3.89 //y=0.365
c139 ( 93 0 ) capacitor c=0.00843555f //x=0.99 //y=0.865
c140 ( 90 0 ) capacitor c=0.00591168f //x=5.965 //y=0
c141 ( 87 0 ) capacitor c=0.00591168f //x=4.995 //y=0
c142 ( 84 0 ) capacitor c=0.00591168f //x=4.025 //y=0
c143 ( 83 0 ) capacitor c=0.112924f //x=3.33 //y=0
c144 ( 80 0 ) capacitor c=0.212661f //x=6.29 //y=0
c145 ( 72 0 ) capacitor c=0.00739123f //x=5.965 //y=0.445
c146 ( 67 0 ) capacitor c=0.0152893f //x=5.88 //y=0.53
c147 ( 63 0 ) capacitor c=0.0253251f //x=5.88 //y=0
c148 ( 58 0 ) capacitor c=0.00726869f //x=4.995 //y=0.445
c149 ( 53 0 ) capacitor c=0.016551f //x=4.91 //y=0.53
c150 ( 49 0 ) capacitor c=0.025309f //x=4.91 //y=0
c151 ( 44 0 ) capacitor c=0.00739123f //x=4.025 //y=0.445
c152 ( 41 0 ) capacitor c=0.0227441f //x=3.94 //y=0
c153 ( 29 0 ) capacitor c=0.183052f //x=0.74 //y=0
c154 ( 26 0 ) capacitor c=0.123925f //x=3.16 //y=0
c155 ( 23 0 ) capacitor c=0.0050875f //x=1.18 //y=0
c156 ( 21 0 ) capacitor c=0.0278993f //x=1.177 //y=0.825
c157 ( 20 0 ) capacitor c=0.0161817f //x=1.18 //y=0.955
c158 ( 17 0 ) capacitor c=0.194695f //x=6.29 //y=0
c159 ( 1 0 ) capacitor c=0.0587616f //x=1.095 //y=0
r160 (  78 90 ) resistor r=2.94794 //w=0.34 //l=0.085 //layer=li \
 //thickness=0.1 //x=6.05 //y=0 //x2=5.965 //y2=0
r161 (  78 80 ) resistor r=8.60504 //w=0.357 //l=0.24 //layer=li \
 //thickness=0.1 //x=6.05 //y=0 //x2=6.29 //y2=0
r162 (  73 94 ) resistor r=5.4201 //w=0.17 //l=0.085 //layer=li \
 //thickness=0.1 //x=5.965 //y=0.615 //x2=5.965 //y2=0.53
r163 (  73 94 ) resistor r=18.139 //w=0.187 //l=0.265 //layer=li \
 //thickness=0.1 //x=5.965 //y=0.615 //x2=5.965 //y2=0.88
r164 (  72 94 ) resistor r=5.4201 //w=0.17 //l=0.085 //layer=li \
 //thickness=0.1 //x=5.965 //y=0.445 //x2=5.965 //y2=0.53
r165 (  71 90 ) resistor r=4.11603 //w=0.68 //l=0.17 //layer=li \
 //thickness=0.1 //x=5.965 //y=0.17 //x2=5.965 //y2=0
r166 (  71 72 ) resistor r=18.8235 //w=0.187 //l=0.275 //layer=li \
 //thickness=0.1 //x=5.965 //y=0.17 //x2=5.965 //y2=0.445
r167 (  68 94 ) resistor r=6.4 //w=0.17 //l=0.085 //layer=li //thickness=0.1 \
 //x=5.08 //y=0.53 //x2=4.995 //y2=0.53
r168 (  68 94 ) resistor r=27.3797 //w=0.187 //l=0.4 //layer=li \
 //thickness=0.1 //x=5.08 //y=0.53 //x2=5.48 //y2=0.53
r169 (  67 94 ) resistor r=1.40859 //w=0.34 //l=0.085 //layer=li \
 //thickness=0.1 //x=5.88 //y=0.53 //x2=5.965 //y2=0.53
r170 (  67 94 ) resistor r=27.3797 //w=0.187 //l=0.4 //layer=li \
 //thickness=0.1 //x=5.88 //y=0.53 //x2=5.48 //y2=0.53
r171 (  64 87 ) resistor r=2.94794 //w=0.34 //l=0.085 //layer=li \
 //thickness=0.1 //x=5.08 //y=0 //x2=4.995 //y2=0
r172 (  64 66 ) resistor r=16.8515 //w=0.357 //l=0.47 //layer=li \
 //thickness=0.1 //x=5.08 //y=0 //x2=5.55 //y2=0
r173 (  63 90 ) resistor r=2.94794 //w=0.34 //l=0.085 //layer=li \
 //thickness=0.1 //x=5.88 //y=0 //x2=5.965 //y2=0
r174 (  63 66 ) resistor r=11.8319 //w=0.357 //l=0.33 //layer=li \
 //thickness=0.1 //x=5.88 //y=0 //x2=5.55 //y2=0
r175 (  59 94 ) resistor r=6.4 //w=0.17 //l=0.085 //layer=li //thickness=0.1 \
 //x=4.995 //y=0.615 //x2=4.995 //y2=0.53
r176 (  59 94 ) resistor r=18.139 //w=0.187 //l=0.265 //layer=li \
 //thickness=0.1 //x=4.995 //y=0.615 //x2=4.995 //y2=0.88
r177 (  58 94 ) resistor r=6.4 //w=0.17 //l=0.085 //layer=li //thickness=0.1 \
 //x=4.995 //y=0.445 //x2=4.995 //y2=0.53
r178 (  57 87 ) resistor r=4.11603 //w=0.68 //l=0.17 //layer=li \
 //thickness=0.1 //x=4.995 //y=0.17 //x2=4.995 //y2=0
r179 (  57 58 ) resistor r=18.8235 //w=0.187 //l=0.275 //layer=li \
 //thickness=0.1 //x=4.995 //y=0.17 //x2=4.995 //y2=0.445
r180 (  54 94 ) resistor r=1.40859 //w=0.34 //l=0.085 //layer=li \
 //thickness=0.1 //x=4.11 //y=0.53 //x2=4.025 //y2=0.53
r181 (  54 94 ) resistor r=27.3797 //w=0.187 //l=0.4 //layer=li \
 //thickness=0.1 //x=4.11 //y=0.53 //x2=4.51 //y2=0.53
r182 (  53 94 ) resistor r=6.4 //w=0.17 //l=0.085 //layer=li //thickness=0.1 \
 //x=4.91 //y=0.53 //x2=4.995 //y2=0.53
r183 (  53 94 ) resistor r=27.3797 //w=0.187 //l=0.4 //layer=li \
 //thickness=0.1 //x=4.91 //y=0.53 //x2=4.51 //y2=0.53
r184 (  50 84 ) resistor r=2.94794 //w=0.34 //l=0.085 //layer=li \
 //thickness=0.1 //x=4.11 //y=0 //x2=4.025 //y2=0
r185 (  50 52 ) resistor r=11.8319 //w=0.357 //l=0.33 //layer=li \
 //thickness=0.1 //x=4.11 //y=0 //x2=4.44 //y2=0
r186 (  49 87 ) resistor r=2.94794 //w=0.34 //l=0.085 //layer=li \
 //thickness=0.1 //x=4.91 //y=0 //x2=4.995 //y2=0
r187 (  49 52 ) resistor r=16.8515 //w=0.357 //l=0.47 //layer=li \
 //thickness=0.1 //x=4.91 //y=0 //x2=4.44 //y2=0
r188 (  45 94 ) resistor r=5.4201 //w=0.17 //l=0.085 //layer=li \
 //thickness=0.1 //x=4.025 //y=0.615 //x2=4.025 //y2=0.53
r189 (  45 94 ) resistor r=41.4118 //w=0.187 //l=0.605 //layer=li \
 //thickness=0.1 //x=4.025 //y=0.615 //x2=4.025 //y2=1.22
r190 (  44 94 ) resistor r=5.4201 //w=0.17 //l=0.085 //layer=li \
 //thickness=0.1 //x=4.025 //y=0.445 //x2=4.025 //y2=0.53
r191 (  43 84 ) resistor r=4.11603 //w=0.68 //l=0.17 //layer=li \
 //thickness=0.1 //x=4.025 //y=0.17 //x2=4.025 //y2=0
r192 (  43 44 ) resistor r=18.8235 //w=0.187 //l=0.275 //layer=li \
 //thickness=0.1 //x=4.025 //y=0.17 //x2=4.025 //y2=0.445
r193 (  42 83 ) resistor r=5.4201 //w=0.34 //l=0.17 //layer=li //thickness=0.1 \
 //x=3.5 //y=0 //x2=3.33 //y2=0
r194 (  41 84 ) resistor r=2.94794 //w=0.34 //l=0.085 //layer=li \
 //thickness=0.1 //x=3.94 //y=0 //x2=4.025 //y2=0
r195 (  41 42 ) resistor r=15.7759 //w=0.357 //l=0.44 //layer=li \
 //thickness=0.1 //x=3.94 //y=0 //x2=3.5 //y2=0
r196 (  31 33 ) resistor r=39.7983 //w=0.357 //l=1.11 //layer=li \
 //thickness=0.1 //x=1.85 //y=0 //x2=2.96 //y2=0
r197 (  29 31 ) resistor r=39.7983 //w=0.357 //l=1.11 //layer=li \
 //thickness=0.1 //x=0.74 //y=0 //x2=1.85 //y2=0
r198 (  26 83 ) resistor r=5.4201 //w=0.34 //l=0.17 //layer=li //thickness=0.1 \
 //x=3.16 //y=0 //x2=3.33 //y2=0
r199 (  26 33 ) resistor r=7.17087 //w=0.357 //l=0.2 //layer=li \
 //thickness=0.1 //x=3.16 //y=0 //x2=2.96 //y2=0
r200 (  20 93 ) resistor r=9.3 //w=0.17 //l=0.17 //layer=mcon //count=1 \
 //x=1.18 //y=0.955 //x2=1.18 //y2=0.955
r201 (  20 21 ) resistor r=0.0939994 //w=0.226 //l=0.13 //layer=m1 \
 //thickness=0.36 //x=1.177 //y=0.955 //x2=1.177 //y2=0.825
r202 (  17 80 ) resistor r=9.3 //w=0.17 //l=0.17 //layer=mcon //count=1 \
 //x=6.29 //y=0 //x2=6.29 //y2=0
r203 (  15 66 ) resistor r=3.1 //w=0.17 //l=0.51 //layer=mcon //count=3 \
 //x=5.55 //y=0 //x2=5.55 //y2=0
r204 (  15 17 ) resistor r=0.307309 //w=0.301 //l=0.74 //layer=m1 \
 //thickness=0.36 //x=5.55 //y=0 //x2=6.29 //y2=0
r205 (  13 52 ) resistor r=3.1 //w=0.17 //l=0.51 //layer=mcon //count=3 \
 //x=4.44 //y=0 //x2=4.44 //y2=0
r206 (  13 15 ) resistor r=0.460963 //w=0.301 //l=1.11 //layer=m1 \
 //thickness=0.36 //x=4.44 //y=0 //x2=5.55 //y2=0
r207 (  11 33 ) resistor r=3.1 //w=0.17 //l=0.51 //layer=mcon //count=3 \
 //x=2.96 //y=0 //x2=2.96 //y2=0
r208 (  11 13 ) resistor r=0.614618 //w=0.301 //l=1.48 //layer=m1 \
 //thickness=0.36 //x=2.96 //y=0 //x2=4.44 //y2=0
r209 (  9 31 ) resistor r=3.1 //w=0.17 //l=0.51 //layer=mcon //count=3 \
 //x=1.85 //y=0 //x2=1.85 //y2=0
r210 (  9 11 ) resistor r=0.460963 //w=0.301 //l=1.11 //layer=m1 \
 //thickness=0.36 //x=1.85 //y=0 //x2=2.96 //y2=0
r211 (  7 23 ) resistor r=0.0287885 //w=0.34 //l=0.085 //layer=m1 \
 //thickness=0.36 //x=1.265 //y=0 //x2=1.18 //y2=0
r212 (  7 9 ) resistor r=0.24294 //w=0.301 //l=0.585 //layer=m1 \
 //thickness=0.36 //x=1.265 //y=0 //x2=1.85 //y2=0
r213 (  5 23 ) resistor r=0.0401957 //w=0.68 //l=0.17 //layer=m1 \
 //thickness=0.36 //x=1.18 //y=0.17 //x2=1.18 //y2=0
r214 (  5 21 ) resistor r=0.625 //w=0.131 //l=0.655 //layer=m1 \
 //thickness=0.36 //x=1.18 //y=0.17 //x2=1.18 //y2=0.825
r215 (  3 29 ) resistor r=3.1 //w=0.17 //l=0.51 //layer=mcon //count=3 \
 //x=0.74 //y=0 //x2=0.74 //y2=0
r216 (  1 23 ) resistor r=0.0287885 //w=0.34 //l=0.085 //layer=m1 \
 //thickness=0.36 //x=1.095 //y=0 //x2=1.18 //y2=0
r217 (  1 3 ) resistor r=0.147425 //w=0.301 //l=0.355 //layer=m1 \
 //thickness=0.36 //x=1.095 //y=0 //x2=0.74 //y2=0
ends PM_AOI3X1_PCELL\%noxref_4

subckt PM_AOI3X1_PCELL\%noxref_5 ( 2 4 10 15 19 20 21 22 23 24 29 31 33 39 40 \
 42 43 46 )
c104 ( 46 0 ) capacitor c=0.0393541f //x=1.88 //y=4.7
c105 ( 43 0 ) capacitor c=0.0284095f //x=1.85 //y=1.915
c106 ( 42 0 ) capacitor c=0.0476356f //x=1.85 //y=2.08
c107 ( 40 0 ) capacitor c=0.0439708f //x=2.415 //y=1.25
c108 ( 39 0 ) capacitor c=0.0192582f //x=2.415 //y=0.905
c109 ( 33 0 ) capacitor c=0.0162526f //x=2.26 //y=1.405
c110 ( 31 0 ) capacitor c=0.0157807f //x=2.26 //y=0.75
c111 ( 29 0 ) capacitor c=0.0372668f //x=2.255 //y=4.79
c112 ( 24 0 ) capacitor c=0.0210762f //x=1.885 //y=1.56
c113 ( 23 0 ) capacitor c=0.0168511f //x=1.885 //y=1.25
c114 ( 22 0 ) capacitor c=0.0175485f //x=1.885 //y=0.905
c115 ( 21 0 ) capacitor c=0.155269f //x=2.33 //y=6.02
c116 ( 20 0 ) capacitor c=0.110375f //x=1.89 //y=6.02
c117 ( 15 0 ) capacitor c=8.9038e-19 //x=1.88 //y=4.7
c118 ( 10 0 ) capacitor c=7.72439e-19 //x=1.85 //y=2.08
c119 ( 4 0 ) capacitor c=0.00687137f //x=1.85 //y=2.08
c120 ( 2 0 ) capacitor c=0.0640231f //x=1.85 //y=4.555
r121 (  48 49 ) resistor r=32.4568 //w=0.214 //l=0.075 //layer=ply \
 //thickness=0.18 //x=1.88 //y=4.79 //x2=1.88 //y2=4.865
r122 (  46 48 ) resistor r=20.271 //w=0.214 //l=0.09 //layer=ply \
 //thickness=0.18 //x=1.88 //y=4.7 //x2=1.88 //y2=4.79
r123 (  42 43 ) resistor r=52.7279 //w=0.214 //l=0.165 //layer=ply \
 //thickness=0.18 //x=1.85 //y=2.08 //x2=1.85 //y2=1.915
r124 (  40 53 ) resistor r=45.1352 //w=0.168 //l=0.173853 //layer=ply \
 //thickness=0.18 //x=2.415 //y=1.25 //x2=2.375 //y2=1.405
r125 (  39 52 ) resistor r=45.1352 //w=0.168 //l=0.173853 //layer=ply \
 //thickness=0.18 //x=2.415 //y=0.905 //x2=2.375 //y2=0.75
r126 (  39 40 ) resistor r=176.904 //w=0.094 //l=0.345 //layer=ply \
 //thickness=0.18 //x=2.415 //y=0.905 //x2=2.415 //y2=1.25
r127 (  34 51 ) resistor r=10.701 //w=0.21 //l=0.115 //layer=ply \
 //thickness=0.18 //x=2.04 //y=1.405 //x2=1.925 //y2=1.405
r128 (  33 53 ) resistor r=5.52526 //w=0.168 //l=0.115 //layer=ply \
 //thickness=0.18 //x=2.26 //y=1.405 //x2=2.375 //y2=1.405
r129 (  32 50 ) resistor r=5.52526 //w=0.168 //l=0.115 //layer=ply \
 //thickness=0.18 //x=2.04 //y=0.75 //x2=1.925 //y2=0.75
r130 (  31 52 ) resistor r=5.52526 //w=0.168 //l=0.115 //layer=ply \
 //thickness=0.18 //x=2.26 //y=0.75 //x2=2.375 //y2=0.75
r131 (  31 32 ) resistor r=112.809 //w=0.094 //l=0.22 //layer=ply \
 //thickness=0.18 //x=2.26 //y=0.75 //x2=2.04 //y2=0.75
r132 (  30 48 ) resistor r=16.5046 //w=0.27 //l=0.135 //layer=ply \
 //thickness=0.18 //x=2.015 //y=4.79 //x2=1.88 //y2=4.79
r133 (  29 36 ) resistor r=26.9307 //w=0.15 //l=0.106066 //layer=ply \
 //thickness=0.18 //x=2.255 //y=4.79 //x2=2.33 //y2=4.865
r134 (  29 30 ) resistor r=123.064 //w=0.094 //l=0.24 //layer=ply \
 //thickness=0.18 //x=2.255 //y=4.79 //x2=2.015 //y2=4.79
r135 (  24 51 ) resistor r=39.5823 //w=0.21 //l=0.173853 //layer=ply \
 //thickness=0.18 //x=1.885 //y=1.56 //x2=1.925 //y2=1.405
r136 (  24 43 ) resistor r=182.032 //w=0.094 //l=0.355 //layer=ply \
 //thickness=0.18 //x=1.885 //y=1.56 //x2=1.885 //y2=1.915
r137 (  23 51 ) resistor r=39.5823 //w=0.21 //l=0.173853 //layer=ply \
 //thickness=0.18 //x=1.885 //y=1.25 //x2=1.925 //y2=1.405
r138 (  22 50 ) resistor r=45.1352 //w=0.168 //l=0.173853 //layer=ply \
 //thickness=0.18 //x=1.885 //y=0.905 //x2=1.925 //y2=0.75
r139 (  22 23 ) resistor r=176.904 //w=0.094 //l=0.345 //layer=ply \
 //thickness=0.18 //x=1.885 //y=0.905 //x2=1.885 //y2=1.25
r140 (  21 36 ) resistor r=592.245 //w=0.094 //l=1.155 //layer=ply \
 //thickness=0.18 //x=2.33 //y=6.02 //x2=2.33 //y2=4.865
r141 (  20 49 ) resistor r=592.245 //w=0.094 //l=1.155 //layer=ply \
 //thickness=0.18 //x=1.89 //y=6.02 //x2=1.89 //y2=4.865
r142 (  19 33 ) resistor r=56.4043 //w=0.094 //l=0.11 //layer=ply \
 //thickness=0.18 //x=2.15 //y=1.405 //x2=2.26 //y2=1.405
r143 (  19 34 ) resistor r=56.4043 //w=0.094 //l=0.11 //layer=ply \
 //thickness=0.18 //x=2.15 //y=1.405 //x2=2.04 //y2=1.405
r144 (  15 46 ) resistor r=152 //w=0.17 //l=0.17 //layer=licon //count=1 \
 //x=1.88 //y=4.7 //x2=1.88 //y2=4.7
r145 (  10 42 ) resistor r=152 //w=0.17 //l=0.17 //layer=licon //count=1 \
 //x=1.85 //y=2.08 //x2=1.85 //y2=2.08
r146 (  8 15 ) resistor r=9.3 //w=0.17 //l=0.17 //layer=mcon //count=1 \
 //x=1.88 //y=4.7 //x2=1.88 //y2=4.7
r147 (  4 10 ) resistor r=9.3 //w=0.17 //l=0.17 //layer=mcon //count=1 \
 //x=1.85 //y=2.08 //x2=1.85 //y2=2.08
r148 (  4 6 ) resistor r=0.0936408 //w=0.196 //l=0.125 //layer=m1 \
 //thickness=0.36 //x=1.852 //y=2.08 //x2=1.852 //y2=2.205
r149 (  2 8 ) resistor r=0.0878548 //w=0.228 //l=0.159295 //layer=m1 \
 //thickness=0.36 //x=1.85 //y=4.555 //x2=1.88 //y2=4.7
r150 (  2 6 ) resistor r=2.24237 //w=0.131 //l=2.35 //layer=m1 \
 //thickness=0.36 //x=1.85 //y=4.555 //x2=1.85 //y2=2.205
ends PM_AOI3X1_PCELL\%noxref_5

subckt PM_AOI3X1_PCELL\%noxref_6 ( 1 3 5 10 14 17 20 30 46 47 48 )
c83 ( 48 0 ) capacitor c=0.0347532f //x=5.735 //y=5.025
c84 ( 46 0 ) capacitor c=0.0118024f //x=3.985 //y=5.025
c85 ( 30 0 ) capacitor c=0.0303063f //x=5 //y=5.38
c86 ( 20 0 ) capacitor c=0.045655f //x=4.12 //y=5.38
c87 ( 17 0 ) capacitor c=0.0164155f //x=5.88 //y=6.74
c88 ( 14 0 ) capacitor c=0.00604334f //x=5 //y=6.74
c89 ( 10 0 ) capacitor c=0.0111807f //x=5 //y=5.21
c90 ( 5 0 ) capacitor c=0.012947f //x=4.12 //y=5.21
c91 ( 3 0 ) capacitor c=0.00694548f //x=5.75 //y=6.91
c92 ( 1 0 ) capacitor c=0.0131347f //x=4.88 //y=5.21
r93 (  37 47 ) resistor r=23.2727 //w=0.187 //l=0.34 //layer=li \
 //thickness=0.1 //x=5 //y=6.74 //x2=5 //y2=6.4
r94 (  30 47 ) resistor r=23.2727 //w=0.187 //l=0.34 //layer=li \
 //thickness=0.1 //x=5 //y=5.38 //x2=5 //y2=5.72
r95 (  20 46 ) resistor r=23.2727 //w=0.187 //l=0.34 //layer=li \
 //thickness=0.1 //x=4.12 //y=5.38 //x2=4.12 //y2=5.72
r96 (  17 48 ) resistor r=9.3 //w=0.17 //l=0.17 //layer=mcon //count=1 \
 //x=5.88 //y=6.74 //x2=5.88 //y2=6.74
r97 (  17 18 ) resistor r=0.0932018 //w=0.228 //l=0.17 //layer=m1 \
 //thickness=0.36 //x=5.872 //y=6.74 //x2=5.872 //y2=6.91
r98 (  14 37 ) resistor r=9.3 //w=0.17 //l=0.17 //layer=mcon //count=1 //x=5 \
 //y=6.74 //x2=5 //y2=6.74
r99 (  14 15 ) resistor r=0.0992991 //w=0.214 //l=0.17 //layer=m1 \
 //thickness=0.36 //x=5 //y=6.74 //x2=5 //y2=6.91
r100 (  12 30 ) resistor r=9.3 //w=0.17 //l=0.17 //layer=mcon //count=1 //x=5 \
 //y=5.38 //x2=5 //y2=5.38
r101 (  10 12 ) resistor r=0.097032 //w=0.219 //l=0.17 //layer=m1 \
 //thickness=0.36 //x=5 //y=5.21 //x2=5 //y2=5.38
r102 (  7 20 ) resistor r=9.3 //w=0.17 //l=0.17 //layer=mcon //count=1 \
 //x=4.12 //y=5.38 //x2=4.12 //y2=5.38
r103 (  5 7 ) resistor r=0.0997653 //w=0.213 //l=0.17 //layer=m1 \
 //thickness=0.36 //x=4.12 //y=5.21 //x2=4.12 //y2=5.38
r104 (  4 15 ) resistor r=0.0213909 //w=0.214 //l=0.115 //layer=m1 \
 //thickness=0.36 //x=5.115 //y=6.91 //x2=5 //y2=6.91
r105 (  3 18 ) resistor r=0.0251868 //w=0.228 //l=0.122 //layer=m1 \
 //thickness=0.36 //x=5.75 //y=6.91 //x2=5.872 //y2=6.91
r106 (  3 4 ) resistor r=0.605916 //w=0.131 //l=0.635 //layer=m1 \
 //thickness=0.36 //x=5.75 //y=6.91 //x2=5.115 //y2=6.91
r107 (  2 5 ) resistor r=0.0211096 //w=0.213 //l=0.115 //layer=m1 \
 //thickness=0.36 //x=4.235 //y=5.21 //x2=4.12 //y2=5.21
r108 (  1 10 ) resistor r=0.0227762 //w=0.219 //l=0.12 //layer=m1 \
 //thickness=0.36 //x=4.88 //y=5.21 //x2=5 //y2=5.21
r109 (  1 2 ) resistor r=0.615458 //w=0.131 //l=0.645 //layer=m1 \
 //thickness=0.36 //x=4.88 //y=5.21 //x2=4.235 //y2=5.21
ends PM_AOI3X1_PCELL\%noxref_6

subckt PM_AOI3X1_PCELL\%noxref_7 ( 4 8 9 12 17 21 22 23 24 25 26 31 33 35 41 \
 42 44 45 48 )
c112 ( 48 0 ) capacitor c=0.0404287f //x=5.215 //y=4.705
c113 ( 45 0 ) capacitor c=0.0312349f //x=5.18 //y=1.915
c114 ( 44 0 ) capacitor c=0.0469143f //x=5.18 //y=2.08
c115 ( 42 0 ) capacitor c=0.0237765f //x=5.745 //y=1.255
c116 ( 41 0 ) capacitor c=0.0191782f //x=5.745 //y=0.905
c117 ( 35 0 ) capacitor c=0.035988f //x=5.59 //y=1.405
c118 ( 33 0 ) capacitor c=0.0157803f //x=5.59 //y=0.75
c119 ( 31 0 ) capacitor c=0.036638f //x=5.585 //y=4.795
c120 ( 26 0 ) capacitor c=0.0206674f //x=5.215 //y=1.56
c121 ( 25 0 ) capacitor c=0.0169638f //x=5.215 //y=1.255
c122 ( 24 0 ) capacitor c=0.0185462f //x=5.215 //y=0.905
c123 ( 23 0 ) capacitor c=0.155887f //x=5.66 //y=6.025
c124 ( 22 0 ) capacitor c=0.110534f //x=5.22 //y=6.025
c125 ( 17 0 ) capacitor c=0.00113117f //x=5.215 //y=4.705
c126 ( 12 0 ) capacitor c=9.45497e-19 //x=5.18 //y=2.08
c127 ( 9 0 ) capacitor c=0.0587901f //x=5.215 //y=4.56
c128 ( 8 0 ) capacitor c=0.0061903f //x=5.215 //y=4.705
c129 ( 4 0 ) capacitor c=0.00573992f //x=5.18 //y=2.08
r130 (  50 51 ) resistor r=32.4568 //w=0.214 //l=0.075 //layer=ply \
 //thickness=0.18 //x=5.215 //y=4.795 //x2=5.215 //y2=4.87
r131 (  48 50 ) resistor r=20.271 //w=0.214 //l=0.09 //layer=ply \
 //thickness=0.18 //x=5.215 //y=4.705 //x2=5.215 //y2=4.795
r132 (  44 45 ) resistor r=52.7279 //w=0.214 //l=0.165 //layer=ply \
 //thickness=0.18 //x=5.18 //y=2.08 //x2=5.18 //y2=1.915
r133 (  42 55 ) resistor r=4.95774 //w=0.164 //l=0.112 //layer=ply \
 //thickness=0.18 //x=5.745 //y=1.255 //x2=5.745 //y2=1.367
r134 (  41 54 ) resistor r=45.1352 //w=0.168 //l=0.173853 //layer=ply \
 //thickness=0.18 //x=5.745 //y=0.905 //x2=5.705 //y2=0.75
r135 (  41 42 ) resistor r=179.468 //w=0.094 //l=0.35 //layer=ply \
 //thickness=0.18 //x=5.745 //y=0.905 //x2=5.745 //y2=1.255
r136 (  36 53 ) resistor r=10.8103 //w=0.211 //l=0.115 //layer=ply \
 //thickness=0.18 //x=5.37 //y=1.405 //x2=5.255 //y2=1.405
r137 (  35 55 ) resistor r=45.9962 //w=0.164 //l=0.17296 //layer=ply \
 //thickness=0.18 //x=5.59 //y=1.405 //x2=5.745 //y2=1.367
r138 (  34 52 ) resistor r=5.52526 //w=0.168 //l=0.115 //layer=ply \
 //thickness=0.18 //x=5.37 //y=0.75 //x2=5.255 //y2=0.75
r139 (  33 54 ) resistor r=5.52526 //w=0.168 //l=0.115 //layer=ply \
 //thickness=0.18 //x=5.59 //y=0.75 //x2=5.705 //y2=0.75
r140 (  33 34 ) resistor r=112.809 //w=0.094 //l=0.22 //layer=ply \
 //thickness=0.18 //x=5.59 //y=0.75 //x2=5.37 //y2=0.75
r141 (  32 50 ) resistor r=16.5046 //w=0.27 //l=0.135 //layer=ply \
 //thickness=0.18 //x=5.35 //y=4.795 //x2=5.215 //y2=4.795
r142 (  31 38 ) resistor r=26.9307 //w=0.15 //l=0.106066 //layer=ply \
 //thickness=0.18 //x=5.585 //y=4.795 //x2=5.66 //y2=4.87
r143 (  31 32 ) resistor r=120.5 //w=0.094 //l=0.235 //layer=ply \
 //thickness=0.18 //x=5.585 //y=4.795 //x2=5.35 //y2=4.795
r144 (  26 53 ) resistor r=39.5036 //w=0.211 //l=0.173853 //layer=ply \
 //thickness=0.18 //x=5.215 //y=1.56 //x2=5.255 //y2=1.405
r145 (  26 45 ) resistor r=182.032 //w=0.094 //l=0.355 //layer=ply \
 //thickness=0.18 //x=5.215 //y=1.56 //x2=5.215 //y2=1.915
r146 (  25 53 ) resistor r=38.3614 //w=0.211 //l=0.168819 //layer=ply \
 //thickness=0.18 //x=5.215 //y=1.255 //x2=5.255 //y2=1.405
r147 (  24 52 ) resistor r=45.1352 //w=0.168 //l=0.173853 //layer=ply \
 //thickness=0.18 //x=5.215 //y=0.905 //x2=5.255 //y2=0.75
r148 (  24 25 ) resistor r=179.468 //w=0.094 //l=0.35 //layer=ply \
 //thickness=0.18 //x=5.215 //y=0.905 //x2=5.215 //y2=1.255
r149 (  23 38 ) resistor r=592.245 //w=0.094 //l=1.155 //layer=ply \
 //thickness=0.18 //x=5.66 //y=6.025 //x2=5.66 //y2=4.87
r150 (  22 51 ) resistor r=592.245 //w=0.094 //l=1.155 //layer=ply \
 //thickness=0.18 //x=5.22 //y=6.025 //x2=5.22 //y2=4.87
r151 (  21 35 ) resistor r=56.4043 //w=0.094 //l=0.11 //layer=ply \
 //thickness=0.18 //x=5.48 //y=1.405 //x2=5.59 //y2=1.405
r152 (  21 36 ) resistor r=56.4043 //w=0.094 //l=0.11 //layer=ply \
 //thickness=0.18 //x=5.48 //y=1.405 //x2=5.37 //y2=1.405
r153 (  17 48 ) resistor r=152 //w=0.17 //l=0.17 //layer=licon //count=1 \
 //x=5.215 //y=4.705 //x2=5.215 //y2=4.705
r154 (  12 44 ) resistor r=152 //w=0.17 //l=0.17 //layer=licon //count=1 \
 //x=5.18 //y=2.08 //x2=5.18 //y2=2.08
r155 (  8 17 ) resistor r=9.3 //w=0.17 //l=0.17 //layer=mcon //count=1 \
 //x=5.215 //y=4.705 //x2=5.215 //y2=4.705
r156 (  8 9 ) resistor r=0.105739 //w=0.201 //l=0.145 //layer=m1 \
 //thickness=0.36 //x=5.215 //y=4.705 //x2=5.215 //y2=4.56
r157 (  6 9 ) resistor r=2.2376 //w=0.131 //l=2.345 //layer=m1 \
 //thickness=0.36 //x=5.18 //y=2.215 //x2=5.18 //y2=4.56
r158 (  4 12 ) resistor r=9.3 //w=0.17 //l=0.17 //layer=mcon //count=1 \
 //x=5.18 //y=2.08 //x2=5.18 //y2=2.08
r159 (  4 6 ) resistor r=0.0977888 //w=0.216 //l=0.135 //layer=m1 \
 //thickness=0.36 //x=5.177 //y=2.08 //x2=5.177 //y2=2.215
ends PM_AOI3X1_PCELL\%noxref_7

subckt PM_AOI3X1_PCELL\%noxref_8 ( 1 2 3 4 5 6 7 9 12 16 27 39 40 43 )
c124 ( 40 0 ) capacitor c=0.00901091f //x=5.29 //y=0.905
c125 ( 39 0 ) capacitor c=0.00876479f //x=4.32 //y=0.905
c126 ( 27 0 ) capacitor c=0.0246221f //x=5.44 //y=5.38
c127 ( 16 0 ) capacitor c=0.0166901f //x=5.435 //y=5.21
c128 ( 15 0 ) capacitor c=0.00513603f //x=5.48 //y=1.655
c129 ( 12 0 ) capacitor c=0.13426f //x=5.92 //y=5.125
c130 ( 9 0 ) capacitor c=0.0166762f //x=5.835 //y=1.655
c131 ( 7 0 ) capacitor c=0.0133104f //x=5.835 //y=5.21
c132 ( 6 0 ) capacitor c=0.0111615f //x=5.48 //y=1.57
c133 ( 5 0 ) capacitor c=0.0117607f //x=5.48 //y=1.12
c134 ( 4 0 ) capacitor c=0.0023108f //x=4.595 //y=1.655
c135 ( 3 0 ) capacitor c=0.0217217f //x=5.395 //y=1.655
c136 ( 2 0 ) capacitor c=0.00638036f //x=4.51 //y=1.57
c137 ( 1 0 ) capacitor c=0.00806926f //x=4.51 //y=1.125
r138 (  27 43 ) resistor r=23.2727 //w=0.187 //l=0.34 //layer=li \
 //thickness=0.1 //x=5.44 //y=5.38 //x2=5.44 //y2=5.72
r139 (  20 40 ) resistor r=9.3 //w=0.17 //l=0.17 //layer=mcon //count=1 \
 //x=5.48 //y=1 //x2=5.48 //y2=1
r140 (  18 27 ) resistor r=9.3 //w=0.17 //l=0.17 //layer=mcon //count=1 \
 //x=5.44 //y=5.38 //x2=5.44 //y2=5.38
r141 (  16 18 ) resistor r=0.0974771 //w=0.218 //l=0.17 //layer=m1 \
 //thickness=0.36 //x=5.435 //y=5.21 //x2=5.435 //y2=5.38
r142 (  14 39 ) resistor r=9.3 //w=0.17 //l=0.17 //layer=mcon //count=1 \
 //x=4.51 //y=1 //x2=4.51 //y2=1
r143 (  11 12 ) resistor r=3.22996 //w=0.131 //l=3.385 //layer=m1 \
 //thickness=0.36 //x=5.92 //y=1.74 //x2=5.92 //y2=5.125
r144 (  10 15 ) resistor r=0.0529306 //w=0.17 //l=0.085 //layer=m1 \
 //thickness=0.36 //x=5.565 //y=1.655 //x2=5.48 //y2=1.655
r145 (  9 11 ) resistor r=0.0698411 //w=0.17 //l=0.120208 //layer=m1 \
 //thickness=0.36 //x=5.835 //y=1.655 //x2=5.92 //y2=1.74
r146 (  9 10 ) resistor r=0.257634 //w=0.131 //l=0.27 //layer=m1 \
 //thickness=0.36 //x=5.835 //y=1.655 //x2=5.565 //y2=1.655
r147 (  8 16 ) resistor r=0.0225019 //w=0.218 //l=0.12 //layer=m1 \
 //thickness=0.36 //x=5.555 //y=5.21 //x2=5.435 //y2=5.21
r148 (  7 12 ) resistor r=0.0698411 //w=0.17 //l=0.120208 //layer=m1 \
 //thickness=0.36 //x=5.835 //y=5.21 //x2=5.92 //y2=5.125
r149 (  7 8 ) resistor r=0.267176 //w=0.131 //l=0.28 //layer=m1 \
 //thickness=0.36 //x=5.835 //y=5.21 //x2=5.555 //y2=5.21
r150 (  6 15 ) resistor r=0.0137558 //w=0.34 //l=0.085 //layer=m1 \
 //thickness=0.36 //x=5.48 //y=1.57 //x2=5.48 //y2=1.655
r151 (  5 20 ) resistor r=0.0728765 //w=0.25 //l=0.121491 //layer=m1 \
 //thickness=0.36 //x=5.48 //y=1.12 //x2=5.477 //y2=1
r152 (  5 6 ) resistor r=0.429389 //w=0.131 //l=0.45 //layer=m1 \
 //thickness=0.36 //x=5.48 //y=1.12 //x2=5.48 //y2=1.57
r153 (  3 15 ) resistor r=0.0529306 //w=0.17 //l=0.085 //layer=m1 \
 //thickness=0.36 //x=5.395 //y=1.655 //x2=5.48 //y2=1.655
r154 (  3 4 ) resistor r=0.763359 //w=0.131 //l=0.8 //layer=m1 \
 //thickness=0.36 //x=5.395 //y=1.655 //x2=4.595 //y2=1.655
r155 (  2 4 ) resistor r=0.0698411 //w=0.17 //l=0.120208 //layer=m1 \
 //thickness=0.36 //x=4.51 //y=1.57 //x2=4.595 //y2=1.655
r156 (  1 14 ) resistor r=0.0764279 //w=0.233 //l=0.126491 //layer=m1 \
 //thickness=0.36 //x=4.51 //y=1.125 //x2=4.507 //y2=1
r157 (  1 2 ) resistor r=0.424618 //w=0.131 //l=0.445 //layer=m1 \
 //thickness=0.36 //x=4.51 //y=1.125 //x2=4.51 //y2=1.57
ends PM_AOI3X1_PCELL\%noxref_8

subckt PM_AOI3X1_PCELL\%noxref_9 ( 1 5 9 10 13 17 29 )
c61 ( 29 0 ) capacitor c=0.0672377f //x=0.56 //y=0.365
c62 ( 17 0 ) capacitor c=0.00709791f //x=2.635 //y=0.615
c63 ( 13 0 ) capacitor c=0.0157877f //x=2.55 //y=0.53
c64 ( 10 0 ) capacitor c=0.00963509f //x=1.665 //y=1.495
c65 ( 9 0 ) capacitor c=0.00770028f //x=1.665 //y=0.615
c66 ( 5 0 ) capacitor c=0.024493f //x=1.58 //y=1.58
c67 ( 1 0 ) capacitor c=0.0115037f //x=0.695 //y=1.495
r68 (  17 29 ) resistor r=3.57586 //w=0.17 //l=0.125 //layer=li \
 //thickness=0.1 //x=2.635 //y=0.615 //x2=2.635 //y2=0.49
r69 (  17 29 ) resistor r=18.139 //w=0.187 //l=0.265 //layer=li \
 //thickness=0.1 //x=2.635 //y=0.615 //x2=2.635 //y2=0.88
r70 (  14 29 ) resistor r=3.57586 //w=0.17 //l=0.103078 //layer=li \
 //thickness=0.1 //x=1.75 //y=0.53 //x2=1.665 //y2=0.49
r71 (  14 29 ) resistor r=27.3797 //w=0.187 //l=0.4 //layer=li //thickness=0.1 \
 //x=1.75 //y=0.53 //x2=2.15 //y2=0.53
r72 (  13 29 ) resistor r=3.57586 //w=0.17 //l=0.103078 //layer=li \
 //thickness=0.1 //x=2.55 //y=0.53 //x2=2.635 //y2=0.49
r73 (  13 29 ) resistor r=27.3797 //w=0.187 //l=0.4 //layer=li //thickness=0.1 \
 //x=2.55 //y=0.53 //x2=2.15 //y2=0.53
r74 (  10 29 ) resistor r=3.57586 //w=0.17 //l=0.125 //layer=li \
 //thickness=0.1 //x=1.665 //y=1.495 //x2=1.665 //y2=1.62
r75 (  10 29 ) resistor r=42.0963 //w=0.187 //l=0.615 //layer=li \
 //thickness=0.1 //x=1.665 //y=1.495 //x2=1.665 //y2=0.88
r76 (  9 29 ) resistor r=3.57586 //w=0.17 //l=0.125 //layer=li //thickness=0.1 \
 //x=1.665 //y=0.615 //x2=1.665 //y2=0.49
r77 (  9 29 ) resistor r=18.139 //w=0.187 //l=0.265 //layer=li //thickness=0.1 \
 //x=1.665 //y=0.615 //x2=1.665 //y2=0.88
r78 (  6 29 ) resistor r=3.57586 //w=0.17 //l=0.103078 //layer=li \
 //thickness=0.1 //x=0.78 //y=1.58 //x2=0.695 //y2=1.62
r79 (  6 29 ) resistor r=27.3797 //w=0.187 //l=0.4 //layer=li //thickness=0.1 \
 //x=0.78 //y=1.58 //x2=1.18 //y2=1.58
r80 (  5 29 ) resistor r=3.57586 //w=0.17 //l=0.103078 //layer=li \
 //thickness=0.1 //x=1.58 //y=1.58 //x2=1.665 //y2=1.62
r81 (  5 29 ) resistor r=27.3797 //w=0.187 //l=0.4 //layer=li //thickness=0.1 \
 //x=1.58 //y=1.58 //x2=1.18 //y2=1.58
r82 (  1 29 ) resistor r=3.57586 //w=0.17 //l=0.125 //layer=li //thickness=0.1 \
 //x=0.695 //y=1.495 //x2=0.695 //y2=1.62
r83 (  1 29 ) resistor r=42.0963 //w=0.187 //l=0.615 //layer=li \
 //thickness=0.1 //x=0.695 //y=1.495 //x2=0.695 //y2=0.88
ends PM_AOI3X1_PCELL\%noxref_9
