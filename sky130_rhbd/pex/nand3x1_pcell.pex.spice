// File: nand3x1_pcell.spi.pex
// Created: Sun Mar 15 12:50:22 2026
// Program "Calibre xRC"
// Version "v2023.2_27.15"
// Nominal Temperature: 30C
// Circuit Temperature: 30C
//
simulator lang=spectre
subckt PM_NAND3X1_PCELL\%noxref_1 ( 9 18 27 37 45 58 65 66 67 68 )
c62 ( 68 0 ) capacitor c=0.0466888f //x=3.585 //y=5.02
c63 ( 67 0 ) capacitor c=0.025619f //x=2.705 //y=5.02
c64 ( 66 0 ) capacitor c=0.0256111f //x=1.825 //y=5.02
c65 ( 65 0 ) capacitor c=0.0696958f //x=0.955 //y=5.02
c66 ( 64 0 ) capacitor c=0.00591168f //x=3.73 //y=7.4
c67 ( 63 0 ) capacitor c=0.00591168f //x=2.85 //y=7.4
c68 ( 62 0 ) capacitor c=0.00591168f //x=1.97 //y=7.4
c69 ( 61 0 ) capacitor c=0.00591168f //x=1.09 //y=7.4
c70 ( 58 0 ) capacitor c=0.275834f //x=4.07 //y=7.4
c71 ( 45 0 ) capacitor c=0.0286174f //x=3.645 //y=7.4
c72 ( 37 0 ) capacitor c=0.0286648f //x=2.765 //y=7.4
c73 ( 27 0 ) capacitor c=0.0287602f //x=1.885 //y=7.4
c74 ( 18 0 ) capacitor c=0.235596f //x=0.74 //y=7.4
c75 ( 15 0 ) capacitor c=0.0452081f //x=1.005 //y=7.4
c76 ( 9 0 ) capacitor c=0.205167f //x=4.07 //y=7.4
r77 (  56 64 ) resistor r=2.94794 //w=0.34 //l=0.085 //layer=li \
 //thickness=0.1 //x=3.815 //y=7.4 //x2=3.73 //y2=7.4
r78 (  56 58 ) resistor r=9.14286 //w=0.357 //l=0.255 //layer=li \
 //thickness=0.1 //x=3.815 //y=7.4 //x2=4.07 //y2=7.4
r79 (  49 64 ) resistor r=4.11603 //w=0.68 //l=0.17 //layer=li //thickness=0.1 \
 //x=3.73 //y=7.23 //x2=3.73 //y2=7.4
r80 (  49 68 ) resistor r=33.1979 //w=0.187 //l=0.485 //layer=li \
 //thickness=0.1 //x=3.73 //y=7.23 //x2=3.73 //y2=6.745
r81 (  46 63 ) resistor r=2.94794 //w=0.34 //l=0.085 //layer=li \
 //thickness=0.1 //x=2.935 //y=7.4 //x2=2.85 //y2=7.4
r82 (  46 48 ) resistor r=0.896359 //w=0.357 //l=0.025 //layer=li \
 //thickness=0.1 //x=2.935 //y=7.4 //x2=2.96 //y2=7.4
r83 (  45 64 ) resistor r=2.94794 //w=0.34 //l=0.085 //layer=li \
 //thickness=0.1 //x=3.645 //y=7.4 //x2=3.73 //y2=7.4
r84 (  45 48 ) resistor r=24.5602 //w=0.357 //l=0.685 //layer=li \
 //thickness=0.1 //x=3.645 //y=7.4 //x2=2.96 //y2=7.4
r85 (  39 63 ) resistor r=4.11603 //w=0.68 //l=0.17 //layer=li //thickness=0.1 \
 //x=2.85 //y=7.23 //x2=2.85 //y2=7.4
r86 (  39 67 ) resistor r=33.1979 //w=0.187 //l=0.485 //layer=li \
 //thickness=0.1 //x=2.85 //y=7.23 //x2=2.85 //y2=6.745
r87 (  38 62 ) resistor r=2.94794 //w=0.34 //l=0.085 //layer=li \
 //thickness=0.1 //x=2.055 //y=7.4 //x2=1.97 //y2=7.4
r88 (  37 63 ) resistor r=2.94794 //w=0.34 //l=0.085 //layer=li \
 //thickness=0.1 //x=2.765 //y=7.4 //x2=2.85 //y2=7.4
r89 (  37 38 ) resistor r=25.4566 //w=0.357 //l=0.71 //layer=li \
 //thickness=0.1 //x=2.765 //y=7.4 //x2=2.055 //y2=7.4
r90 (  31 62 ) resistor r=4.11603 //w=0.68 //l=0.17 //layer=li //thickness=0.1 \
 //x=1.97 //y=7.23 //x2=1.97 //y2=7.4
r91 (  31 66 ) resistor r=33.1979 //w=0.187 //l=0.485 //layer=li \
 //thickness=0.1 //x=1.97 //y=7.23 //x2=1.97 //y2=6.745
r92 (  28 61 ) resistor r=2.94794 //w=0.34 //l=0.085 //layer=li \
 //thickness=0.1 //x=1.175 //y=7.4 //x2=1.09 //y2=7.4
r93 (  28 30 ) resistor r=24.2017 //w=0.357 //l=0.675 //layer=li \
 //thickness=0.1 //x=1.175 //y=7.4 //x2=1.85 //y2=7.4
r94 (  27 62 ) resistor r=2.94794 //w=0.34 //l=0.085 //layer=li \
 //thickness=0.1 //x=1.885 //y=7.4 //x2=1.97 //y2=7.4
r95 (  27 30 ) resistor r=1.2549 //w=0.357 //l=0.035 //layer=li \
 //thickness=0.1 //x=1.885 //y=7.4 //x2=1.85 //y2=7.4
r96 (  19 61 ) resistor r=4.11603 //w=0.68 //l=0.17 //layer=li //thickness=0.1 \
 //x=1.09 //y=7.23 //x2=1.09 //y2=7.4
r97 (  19 65 ) resistor r=56.4706 //w=0.187 //l=0.825 //layer=li \
 //thickness=0.1 //x=1.09 //y=7.23 //x2=1.09 //y2=6.405
r98 (  15 61 ) resistor r=2.94794 //w=0.34 //l=0.085 //layer=li \
 //thickness=0.1 //x=1.005 //y=7.4 //x2=1.09 //y2=7.4
r99 (  15 18 ) resistor r=9.5014 //w=0.357 //l=0.265 //layer=li \
 //thickness=0.1 //x=1.005 //y=7.4 //x2=0.74 //y2=7.4
r100 (  9 58 ) resistor r=3.1 //w=0.17 //l=0.51 //layer=mcon //count=3 \
 //x=4.07 //y=7.4 //x2=4.07 //y2=7.4
r101 (  7 48 ) resistor r=3.1 //w=0.17 //l=0.51 //layer=mcon //count=3 \
 //x=2.96 //y=7.4 //x2=2.96 //y2=7.4
r102 (  7 9 ) resistor r=0.460963 //w=0.301 //l=1.11 //layer=m1 \
 //thickness=0.36 //x=2.96 //y=7.4 //x2=4.07 //y2=7.4
r103 (  5 30 ) resistor r=3.1 //w=0.17 //l=0.51 //layer=mcon //count=3 \
 //x=1.85 //y=7.4 //x2=1.85 //y2=7.4
r104 (  5 7 ) resistor r=0.460963 //w=0.301 //l=1.11 //layer=m1 \
 //thickness=0.36 //x=1.85 //y=7.4 //x2=2.96 //y2=7.4
r105 (  2 18 ) resistor r=3.1 //w=0.17 //l=0.51 //layer=mcon //count=3 \
 //x=0.74 //y=7.4 //x2=0.74 //y2=7.4
r106 (  2 5 ) resistor r=0.460963 //w=0.301 //l=1.11 //layer=m1 \
 //thickness=0.36 //x=0.74 //y=7.4 //x2=1.85 //y2=7.4
ends PM_NAND3X1_PCELL\%noxref_1

subckt PM_NAND3X1_PCELL\%noxref_3 ( 1 2 8 13 17 18 19 20 21 22 23 24 26 32 33 \
 34 35 )
c75 ( 35 0 ) capacitor c=0.0612936f //x=1.385 //y=4.79
c76 ( 34 0 ) capacitor c=0.0376642f //x=1.675 //y=4.79
c77 ( 33 0 ) capacitor c=0.0346489f //x=1.34 //y=1.22
c78 ( 32 0 ) capacitor c=0.018692f //x=1.34 //y=0.875
c79 ( 26 0 ) capacitor c=0.0137077f //x=1.185 //y=1.375
c80 ( 24 0 ) capacitor c=0.0158585f //x=1.185 //y=0.72
c81 ( 23 0 ) capacitor c=0.103534f //x=0.81 //y=1.915
c82 ( 22 0 ) capacitor c=0.0229444f //x=0.81 //y=1.53
c83 ( 21 0 ) capacitor c=0.0234359f //x=0.81 //y=1.22
c84 ( 20 0 ) capacitor c=0.019815f //x=0.81 //y=0.875
c85 ( 19 0 ) capacitor c=0.110208f //x=1.75 //y=6.02
c86 ( 18 0 ) capacitor c=0.158957f //x=1.31 //y=6.02
c87 ( 13 0 ) capacitor c=0.0014751f //x=1.11 //y=4.7
c88 ( 8 0 ) capacitor c=0.0012618f //x=1.11 //y=2.08
c89 ( 2 0 ) capacitor c=0.131796f //x=1.11 //y=4.575
c90 ( 1 0 ) capacitor c=0.0113399f //x=1.11 //y=2.195
r91 (  34 36 ) resistor r=26.9307 //w=0.15 //l=0.106066 //layer=ply \
 //thickness=0.18 //x=1.675 //y=4.79 //x2=1.75 //y2=4.865
r92 (  34 35 ) resistor r=148.702 //w=0.094 //l=0.29 //layer=ply \
 //thickness=0.18 //x=1.675 //y=4.79 //x2=1.385 //y2=4.79
r93 (  33 46 ) resistor r=45.1352 //w=0.168 //l=0.173853 //layer=ply \
 //thickness=0.18 //x=1.34 //y=1.22 //x2=1.3 //y2=1.375
r94 (  32 45 ) resistor r=45.1352 //w=0.168 //l=0.173853 //layer=ply \
 //thickness=0.18 //x=1.34 //y=0.875 //x2=1.3 //y2=0.72
r95 (  32 33 ) resistor r=176.904 //w=0.094 //l=0.345 //layer=ply \
 //thickness=0.18 //x=1.34 //y=0.875 //x2=1.34 //y2=1.22
r96 (  29 35 ) resistor r=22.7971 //w=0.269 //l=0.106066 //layer=ply \
 //thickness=0.18 //x=1.31 //y=4.865 //x2=1.385 //y2=4.79
r97 (  29 44 ) resistor r=35.8364 //w=0.269 //l=0.270185 //layer=ply \
 //thickness=0.18 //x=1.31 //y=4.865 //x2=1.11 //y2=4.7
r98 (  27 40 ) resistor r=10.701 //w=0.21 //l=0.115 //layer=ply \
 //thickness=0.18 //x=0.965 //y=1.375 //x2=0.85 //y2=1.375
r99 (  26 46 ) resistor r=5.52526 //w=0.168 //l=0.115 //layer=ply \
 //thickness=0.18 //x=1.185 //y=1.375 //x2=1.3 //y2=1.375
r100 (  25 39 ) resistor r=5.52526 //w=0.168 //l=0.115 //layer=ply \
 //thickness=0.18 //x=0.965 //y=0.72 //x2=0.85 //y2=0.72
r101 (  24 45 ) resistor r=5.52526 //w=0.168 //l=0.115 //layer=ply \
 //thickness=0.18 //x=1.185 //y=0.72 //x2=1.3 //y2=0.72
r102 (  24 25 ) resistor r=112.809 //w=0.094 //l=0.22 //layer=ply \
 //thickness=0.18 //x=1.185 //y=0.72 //x2=0.965 //y2=0.72
r103 (  23 42 ) resistor r=58.7805 //w=0.246 //l=0.373497 //layer=ply \
 //thickness=0.18 //x=0.81 //y=1.915 //x2=1.11 //y2=2.08
r104 (  22 40 ) resistor r=39.5823 //w=0.21 //l=0.173853 //layer=ply \
 //thickness=0.18 //x=0.81 //y=1.53 //x2=0.85 //y2=1.375
r105 (  22 23 ) resistor r=197.415 //w=0.094 //l=0.385 //layer=ply \
 //thickness=0.18 //x=0.81 //y=1.53 //x2=0.81 //y2=1.915
r106 (  21 40 ) resistor r=39.5823 //w=0.21 //l=0.173853 //layer=ply \
 //thickness=0.18 //x=0.81 //y=1.22 //x2=0.85 //y2=1.375
r107 (  20 39 ) resistor r=45.1352 //w=0.168 //l=0.173853 //layer=ply \
 //thickness=0.18 //x=0.81 //y=0.875 //x2=0.85 //y2=0.72
r108 (  20 21 ) resistor r=176.904 //w=0.094 //l=0.345 //layer=ply \
 //thickness=0.18 //x=0.81 //y=0.875 //x2=0.81 //y2=1.22
r109 (  19 36 ) resistor r=592.245 //w=0.094 //l=1.155 //layer=ply \
 //thickness=0.18 //x=1.75 //y=6.02 //x2=1.75 //y2=4.865
r110 (  18 29 ) resistor r=592.245 //w=0.094 //l=1.155 //layer=ply \
 //thickness=0.18 //x=1.31 //y=6.02 //x2=1.31 //y2=4.865
r111 (  17 26 ) resistor r=56.4043 //w=0.094 //l=0.11 //layer=ply \
 //thickness=0.18 //x=1.075 //y=1.375 //x2=1.185 //y2=1.375
r112 (  17 27 ) resistor r=56.4043 //w=0.094 //l=0.11 //layer=ply \
 //thickness=0.18 //x=1.075 //y=1.375 //x2=0.965 //y2=1.375
r113 (  13 44 ) resistor r=152 //w=0.17 //l=0.17 //layer=licon //count=1 \
 //x=1.11 //y=4.7 //x2=1.11 //y2=4.7
r114 (  8 42 ) resistor r=152 //w=0.17 //l=0.17 //layer=licon //count=1 \
 //x=1.11 //y=2.08 //x2=1.11 //y2=2.08
r115 (  6 13 ) resistor r=9.3 //w=0.17 //l=0.17 //layer=mcon //count=1 \
 //x=1.11 //y=4.7 //x2=1.11 //y2=4.7
r116 (  4 8 ) resistor r=9.3 //w=0.17 //l=0.17 //layer=mcon //count=1 //x=1.11 \
 //y=2.08 //x2=1.11 //y2=2.08
r117 (  2 6 ) resistor r=0.0760407 //w=0.238 //l=0.125 //layer=m1 \
 //thickness=0.36 //x=1.11 //y=4.575 //x2=1.11 //y2=4.7
r118 (  1 4 ) resistor r=0.0719237 //w=0.222 //l=0.115 //layer=m1 \
 //thickness=0.36 //x=1.11 //y=2.195 //x2=1.11 //y2=2.08
r119 (  1 2 ) resistor r=2.27099 //w=0.131 //l=2.38 //layer=m1 \
 //thickness=0.36 //x=1.11 //y=2.195 //x2=1.11 //y2=4.575
ends PM_NAND3X1_PCELL\%noxref_3

subckt PM_NAND3X1_PCELL\%noxref_4 ( 5 7 15 19 30 33 34 )
c50 ( 34 0 ) capacitor c=0.048983f //x=2.965 //y=0.375
c51 ( 33 0 ) capacitor c=0.0198261f //x=1.86 //y=0.91
c52 ( 30 0 ) capacitor c=0.00141302f //x=3.1 //y=0.995
c53 ( 19 0 ) capacitor c=0.00745448f //x=4.07 //y=0.625
c54 ( 15 0 ) capacitor c=0.0155041f //x=3.985 //y=0.54
c55 ( 7 0 ) capacitor c=0.00681713f //x=3.1 //y=0.625
c56 ( 5 0 ) capacitor c=0.0288646f //x=3.015 //y=0.995
r57 (  19 34 ) resistor r=3.57586 //w=0.17 //l=0.125 //layer=li \
 //thickness=0.1 //x=4.07 //y=0.625 //x2=4.07 //y2=0.5
r58 (  19 34 ) resistor r=18.139 //w=0.187 //l=0.265 //layer=li \
 //thickness=0.1 //x=4.07 //y=0.625 //x2=4.07 //y2=0.89
r59 (  16 34 ) resistor r=3.57586 //w=0.17 //l=0.103078 //layer=li \
 //thickness=0.1 //x=3.185 //y=0.54 //x2=3.1 //y2=0.5
r60 (  16 34 ) resistor r=27.3797 //w=0.187 //l=0.4 //layer=li //thickness=0.1 \
 //x=3.185 //y=0.54 //x2=3.585 //y2=0.54
r61 (  15 34 ) resistor r=3.57586 //w=0.17 //l=0.103078 //layer=li \
 //thickness=0.1 //x=3.985 //y=0.54 //x2=4.07 //y2=0.5
r62 (  15 34 ) resistor r=27.3797 //w=0.187 //l=0.4 //layer=li //thickness=0.1 \
 //x=3.985 //y=0.54 //x2=3.585 //y2=0.54
r63 (  11 30 ) resistor r=5.4201 //w=0.17 //l=0.085 //layer=li //thickness=0.1 \
 //x=3.1 //y=1.08 //x2=3.1 //y2=0.995
r64 (  11 34 ) resistor r=10.2674 //w=0.187 //l=0.15 //layer=li \
 //thickness=0.1 //x=3.1 //y=1.08 //x2=3.1 //y2=1.23
r65 (  8 30 ) resistor r=5.4201 //w=0.17 //l=0.085 //layer=li //thickness=0.1 \
 //x=3.1 //y=0.91 //x2=3.1 //y2=0.995
r66 (  8 34 ) resistor r=1.36898 //w=0.187 //l=0.02 //layer=li //thickness=0.1 \
 //x=3.1 //y=0.91 //x2=3.1 //y2=0.89
r67 (  7 34 ) resistor r=3.57586 //w=0.17 //l=0.125 //layer=li //thickness=0.1 \
 //x=3.1 //y=0.625 //x2=3.1 //y2=0.5
r68 (  7 34 ) resistor r=18.139 //w=0.187 //l=0.265 //layer=li //thickness=0.1 \
 //x=3.1 //y=0.625 //x2=3.1 //y2=0.89
r69 (  6 33 ) resistor r=0.751729 //w=0.17 //l=0.085 //layer=li \
 //thickness=0.1 //x=2.135 //y=0.995 //x2=2.05 //y2=0.995
r70 (  5 30 ) resistor r=1.40859 //w=0.34 //l=0.085 //layer=li //thickness=0.1 \
 //x=3.015 //y=0.995 //x2=3.1 //y2=0.995
r71 (  5 6 ) resistor r=60.2353 //w=0.187 //l=0.88 //layer=li //thickness=0.1 \
 //x=3.015 //y=0.995 //x2=2.135 //y2=0.995
ends PM_NAND3X1_PCELL\%noxref_4

subckt PM_NAND3X1_PCELL\%noxref_5 ( 1 2 8 13 17 18 19 20 21 22 24 30 31 32 33 \
 34 42 )
c106 ( 42 0 ) capacitor c=0.0369044f //x=2.22 //y=4.7
c107 ( 34 0 ) capacitor c=0.0309248f //x=2.555 //y=4.79
c108 ( 33 0 ) capacitor c=0.0863671f //x=2.31 //y=1.915
c109 ( 32 0 ) capacitor c=0.0170266f //x=2.31 //y=1.45
c110 ( 31 0 ) capacitor c=0.018609f //x=2.31 //y=1.22
c111 ( 30 0 ) capacitor c=0.0186599f //x=2.31 //y=0.91
c112 ( 24 0 ) capacitor c=0.0146988f //x=2.155 //y=1.375
c113 ( 22 0 ) capacitor c=0.0148531f //x=2.155 //y=0.755
c114 ( 21 0 ) capacitor c=0.0334406f //x=1.785 //y=1.22
c115 ( 20 0 ) capacitor c=0.0173191f //x=1.785 //y=0.91
c116 ( 19 0 ) capacitor c=0.110208f //x=2.63 //y=6.02
c117 ( 18 0 ) capacitor c=0.110214f //x=2.19 //y=6.02
c118 ( 13 0 ) capacitor c=0.00129934f //x=2.22 //y=4.7
c119 ( 8 0 ) capacitor c=0.00121786f //x=2.22 //y=2.08
c120 ( 2 0 ) capacitor c=0.0848666f //x=2.22 //y=4.585
c121 ( 1 0 ) capacitor c=0.00579363f //x=2.22 //y=2.195
r122 (  44 45 ) resistor r=32.4568 //w=0.214 //l=0.075 //layer=ply \
 //thickness=0.18 //x=2.22 //y=4.79 //x2=2.22 //y2=4.865
r123 (  42 44 ) resistor r=20.271 //w=0.214 //l=0.09 //layer=ply \
 //thickness=0.18 //x=2.22 //y=4.7 //x2=2.22 //y2=4.79
r124 (  35 44 ) resistor r=16.5046 //w=0.27 //l=0.135 //layer=ply \
 //thickness=0.18 //x=2.355 //y=4.79 //x2=2.22 //y2=4.79
r125 (  34 36 ) resistor r=26.9307 //w=0.15 //l=0.106066 //layer=ply \
 //thickness=0.18 //x=2.555 //y=4.79 //x2=2.63 //y2=4.865
r126 (  34 35 ) resistor r=102.553 //w=0.094 //l=0.2 //layer=ply \
 //thickness=0.18 //x=2.555 //y=4.79 //x2=2.355 //y2=4.79
r127 (  33 49 ) resistor r=38.6777 //w=0.284 //l=0.198997 //layer=ply \
 //thickness=0.18 //x=2.31 //y=1.915 //x2=2.235 //y2=2.08
r128 (  32 47 ) resistor r=21.2976 //w=0.217 //l=0.0928709 //layer=ply \
 //thickness=0.18 //x=2.31 //y=1.45 //x2=2.27 //y2=1.375
r129 (  32 33 ) resistor r=238.436 //w=0.094 //l=0.465 //layer=ply \
 //thickness=0.18 //x=2.31 //y=1.45 //x2=2.31 //y2=1.915
r130 (  31 47 ) resistor r=39.0671 //w=0.217 //l=0.173853 //layer=ply \
 //thickness=0.18 //x=2.31 //y=1.22 //x2=2.27 //y2=1.375
r131 (  30 46 ) resistor r=45.1352 //w=0.168 //l=0.173853 //layer=ply \
 //thickness=0.18 //x=2.31 //y=0.91 //x2=2.27 //y2=0.755
r132 (  30 31 ) resistor r=158.957 //w=0.094 //l=0.31 //layer=ply \
 //thickness=0.18 //x=2.31 //y=0.91 //x2=2.31 //y2=1.22
r133 (  25 40 ) resistor r=5.52526 //w=0.168 //l=0.115 //layer=ply \
 //thickness=0.18 //x=1.94 //y=1.375 //x2=1.825 //y2=1.375
r134 (  24 47 ) resistor r=11.4558 //w=0.217 //l=0.115 //layer=ply \
 //thickness=0.18 //x=2.155 //y=1.375 //x2=2.27 //y2=1.375
r135 (  23 39 ) resistor r=5.52526 //w=0.168 //l=0.115 //layer=ply \
 //thickness=0.18 //x=1.94 //y=0.755 //x2=1.825 //y2=0.755
r136 (  22 46 ) resistor r=5.52526 //w=0.168 //l=0.115 //layer=ply \
 //thickness=0.18 //x=2.155 //y=0.755 //x2=2.27 //y2=0.755
r137 (  22 23 ) resistor r=110.245 //w=0.094 //l=0.215 //layer=ply \
 //thickness=0.18 //x=2.155 //y=0.755 //x2=1.94 //y2=0.755
r138 (  21 40 ) resistor r=45.1352 //w=0.168 //l=0.173853 //layer=ply \
 //thickness=0.18 //x=1.785 //y=1.22 //x2=1.825 //y2=1.375
r139 (  20 39 ) resistor r=45.1352 //w=0.168 //l=0.173853 //layer=ply \
 //thickness=0.18 //x=1.785 //y=0.91 //x2=1.825 //y2=0.755
r140 (  20 21 ) resistor r=158.957 //w=0.094 //l=0.31 //layer=ply \
 //thickness=0.18 //x=1.785 //y=0.91 //x2=1.785 //y2=1.22
r141 (  19 36 ) resistor r=592.245 //w=0.094 //l=1.155 //layer=ply \
 //thickness=0.18 //x=2.63 //y=6.02 //x2=2.63 //y2=4.865
r142 (  18 45 ) resistor r=592.245 //w=0.094 //l=1.155 //layer=ply \
 //thickness=0.18 //x=2.19 //y=6.02 //x2=2.19 //y2=4.865
r143 (  17 24 ) resistor r=55.3787 //w=0.094 //l=0.108 //layer=ply \
 //thickness=0.18 //x=2.047 //y=1.375 //x2=2.155 //y2=1.375
r144 (  17 25 ) resistor r=54.866 //w=0.094 //l=0.107 //layer=ply \
 //thickness=0.18 //x=2.047 //y=1.375 //x2=1.94 //y2=1.375
r145 (  13 42 ) resistor r=152 //w=0.17 //l=0.17 //layer=licon //count=1 \
 //x=2.22 //y=4.7 //x2=2.22 //y2=4.7
r146 (  8 49 ) resistor r=152 //w=0.17 //l=0.17 //layer=licon //count=1 \
 //x=2.22 //y=2.08 //x2=2.22 //y2=2.08
r147 (  6 13 ) resistor r=9.3 //w=0.17 //l=0.17 //layer=mcon //count=1 \
 //x=2.22 //y=4.7 //x2=2.22 //y2=4.7
r148 (  4 8 ) resistor r=9.3 //w=0.17 //l=0.17 //layer=mcon //count=1 //x=2.22 \
 //y=2.08 //x2=2.22 //y2=2.08
r149 (  2 6 ) resistor r=0.0717383 //w=0.224 //l=0.115 //layer=m1 \
 //thickness=0.36 //x=2.22 //y=4.585 //x2=2.22 //y2=4.7
r150 (  1 4 ) resistor r=0.0715665 //w=0.226 //l=0.115996 //layer=m1 \
 //thickness=0.36 //x=2.22 //y=2.195 //x2=2.222 //y2=2.08
r151 (  1 2 ) resistor r=2.28053 //w=0.131 //l=2.39 //layer=m1 \
 //thickness=0.36 //x=2.22 //y=2.195 //x2=2.22 //y2=4.585
ends PM_NAND3X1_PCELL\%noxref_5

subckt PM_NAND3X1_PCELL\%noxref_6 ( 1 2 8 13 17 18 19 23 24 25 30 32 35 36 38 \
 39 44 )
c87 ( 44 0 ) capacitor c=0.0710579f //x=3.33 //y=4.7
c88 ( 39 0 ) capacitor c=0.0296417f //x=3.33 //y=1.915
c89 ( 38 0 ) capacitor c=0.0504963f //x=3.33 //y=2.08
c90 ( 36 0 ) capacitor c=0.0443175f //x=3.85 //y=1.26
c91 ( 35 0 ) capacitor c=0.0199703f //x=3.85 //y=0.915
c92 ( 32 0 ) capacitor c=0.0162526f //x=3.695 //y=1.415
c93 ( 30 0 ) capacitor c=0.0157807f //x=3.695 //y=0.76
c94 ( 25 0 ) capacitor c=0.0220935f //x=3.32 //y=1.57
c95 ( 24 0 ) capacitor c=0.0207489f //x=3.32 //y=1.26
c96 ( 23 0 ) capacitor c=0.0194091f //x=3.32 //y=0.915
c97 ( 19 0 ) capacitor c=0.161796f //x=3.51 //y=6.02
c98 ( 18 0 ) capacitor c=0.110208f //x=3.07 //y=6.02
c99 ( 13 0 ) capacitor c=7.74199e-19 //x=3.33 //y=4.7
c100 ( 8 0 ) capacitor c=0.00101179f //x=3.33 //y=2.08
c101 ( 2 0 ) capacitor c=0.0757348f //x=3.33 //y=4.57
c102 ( 1 0 ) capacitor c=0.00758489f //x=3.33 //y=2.195
r103 (  38 39 ) resistor r=52.7279 //w=0.214 //l=0.165 //layer=ply \
 //thickness=0.18 //x=3.33 //y=2.08 //x2=3.33 //y2=1.915
r104 (  36 46 ) resistor r=45.1352 //w=0.168 //l=0.173853 //layer=ply \
 //thickness=0.18 //x=3.85 //y=1.26 //x2=3.81 //y2=1.415
r105 (  35 45 ) resistor r=45.1352 //w=0.168 //l=0.173853 //layer=ply \
 //thickness=0.18 //x=3.85 //y=0.915 //x2=3.81 //y2=0.76
r106 (  35 36 ) resistor r=176.904 //w=0.094 //l=0.345 //layer=ply \
 //thickness=0.18 //x=3.85 //y=0.915 //x2=3.85 //y2=1.26
r107 (  33 42 ) resistor r=10.701 //w=0.21 //l=0.115 //layer=ply \
 //thickness=0.18 //x=3.475 //y=1.415 //x2=3.36 //y2=1.415
r108 (  32 46 ) resistor r=5.52526 //w=0.168 //l=0.115 //layer=ply \
 //thickness=0.18 //x=3.695 //y=1.415 //x2=3.81 //y2=1.415
r109 (  31 41 ) resistor r=5.52526 //w=0.168 //l=0.115 //layer=ply \
 //thickness=0.18 //x=3.475 //y=0.76 //x2=3.36 //y2=0.76
r110 (  30 45 ) resistor r=5.52526 //w=0.168 //l=0.115 //layer=ply \
 //thickness=0.18 //x=3.695 //y=0.76 //x2=3.81 //y2=0.76
r111 (  30 31 ) resistor r=112.809 //w=0.094 //l=0.22 //layer=ply \
 //thickness=0.18 //x=3.695 //y=0.76 //x2=3.475 //y2=0.76
r112 (  27 44 ) resistor r=37.236 //w=0.233 //l=0.249199 //layer=ply \
 //thickness=0.18 //x=3.51 //y=4.865 //x2=3.33 //y2=4.7
r113 (  25 42 ) resistor r=39.5823 //w=0.21 //l=0.173853 //layer=ply \
 //thickness=0.18 //x=3.32 //y=1.57 //x2=3.36 //y2=1.415
r114 (  25 39 ) resistor r=176.904 //w=0.094 //l=0.345 //layer=ply \
 //thickness=0.18 //x=3.32 //y=1.57 //x2=3.32 //y2=1.915
r115 (  24 42 ) resistor r=39.5823 //w=0.21 //l=0.173853 //layer=ply \
 //thickness=0.18 //x=3.32 //y=1.26 //x2=3.36 //y2=1.415
r116 (  23 41 ) resistor r=45.1352 //w=0.168 //l=0.173853 //layer=ply \
 //thickness=0.18 //x=3.32 //y=0.915 //x2=3.36 //y2=0.76
r117 (  23 24 ) resistor r=176.904 //w=0.094 //l=0.345 //layer=ply \
 //thickness=0.18 //x=3.32 //y=0.915 //x2=3.32 //y2=1.26
r118 (  20 44 ) resistor r=53.7854 //w=0.233 //l=0.332415 //layer=ply \
 //thickness=0.18 //x=3.07 //y=4.865 //x2=3.33 //y2=4.7
r119 (  19 27 ) resistor r=592.245 //w=0.094 //l=1.155 //layer=ply \
 //thickness=0.18 //x=3.51 //y=6.02 //x2=3.51 //y2=4.865
r120 (  18 20 ) resistor r=592.245 //w=0.094 //l=1.155 //layer=ply \
 //thickness=0.18 //x=3.07 //y=6.02 //x2=3.07 //y2=4.865
r121 (  17 32 ) resistor r=56.4043 //w=0.094 //l=0.11 //layer=ply \
 //thickness=0.18 //x=3.585 //y=1.415 //x2=3.695 //y2=1.415
r122 (  17 33 ) resistor r=56.4043 //w=0.094 //l=0.11 //layer=ply \
 //thickness=0.18 //x=3.585 //y=1.415 //x2=3.475 //y2=1.415
r123 (  13 44 ) resistor r=152 //w=0.17 //l=0.17 //layer=licon //count=1 \
 //x=3.33 //y=4.7 //x2=3.33 //y2=4.7
r124 (  8 38 ) resistor r=152 //w=0.17 //l=0.17 //layer=licon //count=1 \
 //x=3.33 //y=2.08 //x2=3.33 //y2=2.08
r125 (  6 13 ) resistor r=9.3 //w=0.17 //l=0.17 //layer=mcon //count=1 \
 //x=3.33 //y=4.7 //x2=3.33 //y2=4.7
r126 (  4 8 ) resistor r=9.3 //w=0.17 //l=0.17 //layer=mcon //count=1 //x=3.33 \
 //y=2.08 //x2=3.33 //y2=2.08
r127 (  2 6 ) resistor r=0.0801089 //w=0.224 //l=0.13 //layer=m1 \
 //thickness=0.36 //x=3.33 //y=4.57 //x2=3.33 //y2=4.7
r128 (  1 4 ) resistor r=0.0719237 //w=0.222 //l=0.115 //layer=m1 \
 //thickness=0.36 //x=3.33 //y=2.195 //x2=3.33 //y2=2.08
r129 (  1 2 ) resistor r=2.26622 //w=0.131 //l=2.375 //layer=m1 \
 //thickness=0.36 //x=3.33 //y=2.195 //x2=3.33 //y2=4.57
ends PM_NAND3X1_PCELL\%noxref_6

subckt PM_NAND3X1_PCELL\%noxref_7 ( 1 3 6 7 9 10 11 14 15 18 21 27 35 43 55 57 \
 58 59 )
c114 ( 55 0 ) capacitor c=0.00885916f //x=3.395 //y=0.915
c115 ( 43 0 ) capacitor c=0.0293839f //x=3.29 //y=5.38
c116 ( 35 0 ) capacitor c=0.029443f //x=2.41 //y=5.38
c117 ( 27 0 ) capacitor c=0.0282179f //x=1.53 //y=5.38
c118 ( 21 0 ) capacitor c=0.00222577f //x=3.29 //y=5.155
c119 ( 18 0 ) capacitor c=0.0107124f //x=2.41 //y=5.155
c120 ( 15 0 ) capacitor c=0.0155037f //x=1.532 //y=5.155
c121 ( 14 0 ) capacitor c=0.136162f //x=4.07 //y=5.07
c122 ( 12 0 ) capacitor c=0.0083417f //x=3.67 //y=1.665
c123 ( 11 0 ) capacitor c=0.018414f //x=3.985 //y=1.665
c124 ( 10 0 ) capacitor c=0.0167992f //x=3.585 //y=1.58
c125 ( 9 0 ) capacitor c=0.0142938f //x=3.585 //y=1.125
c126 ( 7 0 ) capacitor c=0.0299212f //x=3.985 //y=5.155
c127 ( 6 0 ) capacitor c=0.0124512f //x=3.29 //y=5.38
c128 ( 3 0 ) capacitor c=0.0255081f //x=3.175 //y=5.155
c129 ( 1 0 ) capacitor c=0.0190573f //x=2.29 //y=5.155
r130 (  43 59 ) resistor r=23.615 //w=0.187 //l=0.345 //layer=li \
 //thickness=0.1 //x=3.29 //y=5.38 //x2=3.29 //y2=5.725
r131 (  35 58 ) resistor r=23.615 //w=0.187 //l=0.345 //layer=li \
 //thickness=0.1 //x=2.41 //y=5.38 //x2=2.41 //y2=5.725
r132 (  27 57 ) resistor r=23.615 //w=0.187 //l=0.345 //layer=li \
 //thickness=0.1 //x=1.53 //y=5.38 //x2=1.53 //y2=5.725
r133 (  25 55 ) resistor r=9.3 //w=0.17 //l=0.17 //layer=mcon //count=1 \
 //x=3.585 //y=1.01 //x2=3.585 //y2=1.01
r134 (  23 43 ) resistor r=9.3 //w=0.17 //l=0.17 //layer=mcon //count=1 \
 //x=3.29 //y=5.38 //x2=3.29 //y2=5.38
r135 (  20 35 ) resistor r=9.3 //w=0.17 //l=0.17 //layer=mcon //count=1 \
 //x=2.41 //y=5.38 //x2=2.41 //y2=5.38
r136 (  18 20 ) resistor r=0.121228 //w=0.232 //l=0.225 //layer=m1 \
 //thickness=0.36 //x=2.41 //y=5.155 //x2=2.41 //y2=5.38
r137 (  17 27 ) resistor r=9.3 //w=0.17 //l=0.17 //layer=mcon //count=1 \
 //x=1.53 //y=5.38 //x2=1.53 //y2=5.38
r138 (  15 17 ) resistor r=0.129608 //w=0.217 //l=0.225 //layer=m1 \
 //thickness=0.36 //x=1.532 //y=5.155 //x2=1.532 //y2=5.38
r139 (  13 14 ) resistor r=3.16794 //w=0.131 //l=3.32 //layer=m1 \
 //thickness=0.36 //x=4.07 //y=1.75 //x2=4.07 //y2=5.07
r140 (  11 13 ) resistor r=0.0698411 //w=0.17 //l=0.120208 //layer=m1 \
 //thickness=0.36 //x=3.985 //y=1.665 //x2=4.07 //y2=1.75
r141 (  11 12 ) resistor r=0.300573 //w=0.131 //l=0.315 //layer=m1 \
 //thickness=0.36 //x=3.985 //y=1.665 //x2=3.67 //y2=1.665
r142 (  10 12 ) resistor r=0.0698411 //w=0.17 //l=0.120208 //layer=m1 \
 //thickness=0.36 //x=3.585 //y=1.58 //x2=3.67 //y2=1.665
r143 (  9 25 ) resistor r=0.0717383 //w=0.224 //l=0.115 //layer=m1 \
 //thickness=0.36 //x=3.585 //y=1.125 //x2=3.585 //y2=1.01
r144 (  9 10 ) resistor r=0.43416 //w=0.131 //l=0.455 //layer=m1 \
 //thickness=0.36 //x=3.585 //y=1.125 //x2=3.585 //y2=1.58
r145 (  8 21 ) resistor r=0.0675342 //w=0.23 //l=0.115 //layer=m1 \
 //thickness=0.36 //x=3.405 //y=5.155 //x2=3.29 //y2=5.155
r146 (  7 14 ) resistor r=0.0698411 //w=0.17 //l=0.120208 //layer=m1 \
 //thickness=0.36 //x=3.985 //y=5.155 //x2=4.07 //y2=5.07
r147 (  7 8 ) resistor r=0.553435 //w=0.131 //l=0.58 //layer=m1 \
 //thickness=0.36 //x=3.985 //y=5.155 //x2=3.405 //y2=5.155
r148 (  6 23 ) resistor r=0.00118313 //w=0.23 //layer=m1 //thickness=0.36 \
 //x=3.29 //y=5.38 //x2=3.29 //y2=5.38
r149 (  5 21 ) resistor r=0.002872 //w=0.34 //l=0.085 //layer=m1 \
 //thickness=0.36 //x=3.29 //y=5.24 //x2=3.29 //y2=5.155
r150 (  5 6 ) resistor r=0.091623 //w=0.191 //l=0.14 //layer=m1 \
 //thickness=0.36 //x=3.29 //y=5.24 //x2=3.29 //y2=5.38
r151 (  4 18 ) resistor r=0.0262263 //w=0.232 //l=0.12 //layer=m1 \
 //thickness=0.36 //x=2.53 //y=5.155 //x2=2.41 //y2=5.155
r152 (  3 21 ) resistor r=0.0675342 //w=0.23 //l=0.115 //layer=m1 \
 //thickness=0.36 //x=3.175 //y=5.155 //x2=3.29 //y2=5.155
r153 (  3 4 ) resistor r=0.615458 //w=0.131 //l=0.645 //layer=m1 \
 //thickness=0.36 //x=3.175 //y=5.155 //x2=2.53 //y2=5.155
r154 (  2 15 ) resistor r=0.0222262 //w=0.217 //l=0.118 //layer=m1 \
 //thickness=0.36 //x=1.65 //y=5.155 //x2=1.532 //y2=5.155
r155 (  1 18 ) resistor r=0.0262263 //w=0.232 //l=0.12 //layer=m1 \
 //thickness=0.36 //x=2.29 //y=5.155 //x2=2.41 //y2=5.155
r156 (  1 2 ) resistor r=0.610687 //w=0.131 //l=0.64 //layer=m1 \
 //thickness=0.36 //x=2.29 //y=5.155 //x2=1.65 //y2=5.155
ends PM_NAND3X1_PCELL\%noxref_7

subckt PM_NAND3X1_PCELL\%noxref_8 ( 1 5 9 13 17 35 )
c34 ( 35 0 ) capacitor c=0.0765427f //x=0.455 //y=0.375
c35 ( 17 0 ) capacitor c=0.026218f //x=2.445 //y=1.59
c36 ( 13 0 ) capacitor c=0.0153941f //x=2.445 //y=0.54
c37 ( 9 0 ) capacitor c=0.00772076f //x=1.56 //y=0.625
c38 ( 5 0 ) capacitor c=0.0224109f //x=1.475 //y=1.59
c39 ( 1 0 ) capacitor c=0.0109947f //x=0.59 //y=1.505
r40 (  18 35 ) resistor r=5.4201 //w=0.17 //l=0.103078 //layer=li \
 //thickness=0.1 //x=1.645 //y=1.59 //x2=1.56 //y2=1.63
r41 (  18 35 ) resistor r=27.3797 //w=0.187 //l=0.4 //layer=li //thickness=0.1 \
 //x=1.645 //y=1.59 //x2=2.045 //y2=1.59
r42 (  17 35 ) resistor r=0.751729 //w=0.17 //l=0.085 //layer=li \
 //thickness=0.1 //x=2.445 //y=1.59 //x2=2.53 //y2=1.59
r43 (  17 35 ) resistor r=27.3797 //w=0.187 //l=0.4 //layer=li //thickness=0.1 \
 //x=2.445 //y=1.59 //x2=2.045 //y2=1.59
r44 (  14 35 ) resistor r=3.57586 //w=0.17 //l=0.103078 //layer=li \
 //thickness=0.1 //x=1.645 //y=0.54 //x2=1.56 //y2=0.5
r45 (  14 35 ) resistor r=27.3797 //w=0.187 //l=0.4 //layer=li //thickness=0.1 \
 //x=1.645 //y=0.54 //x2=2.045 //y2=0.54
r46 (  13 35 ) resistor r=0.751729 //w=0.17 //l=0.085 //layer=li \
 //thickness=0.1 //x=2.445 //y=0.54 //x2=2.53 //y2=0.54
r47 (  13 35 ) resistor r=27.3797 //w=0.187 //l=0.4 //layer=li //thickness=0.1 \
 //x=2.445 //y=0.54 //x2=2.045 //y2=0.54
r48 (  10 35 ) resistor r=1.40859 //w=0.34 //l=0.125 //layer=li \
 //thickness=0.1 //x=1.56 //y=1.505 //x2=1.56 //y2=1.63
r49 (  10 35 ) resistor r=42.0963 //w=0.187 //l=0.615 //layer=li \
 //thickness=0.1 //x=1.56 //y=1.505 //x2=1.56 //y2=0.89
r50 (  9 35 ) resistor r=3.57586 //w=0.17 //l=0.125 //layer=li //thickness=0.1 \
 //x=1.56 //y=0.625 //x2=1.56 //y2=0.5
r51 (  9 35 ) resistor r=18.139 //w=0.187 //l=0.265 //layer=li //thickness=0.1 \
 //x=1.56 //y=0.625 //x2=1.56 //y2=0.89
r52 (  6 35 ) resistor r=3.57586 //w=0.17 //l=0.103078 //layer=li \
 //thickness=0.1 //x=0.675 //y=1.59 //x2=0.59 //y2=1.63
r53 (  6 35 ) resistor r=27.3797 //w=0.187 //l=0.4 //layer=li //thickness=0.1 \
 //x=0.675 //y=1.59 //x2=1.075 //y2=1.59
r54 (  5 35 ) resistor r=5.4201 //w=0.17 //l=0.103078 //layer=li \
 //thickness=0.1 //x=1.475 //y=1.59 //x2=1.56 //y2=1.63
r55 (  5 35 ) resistor r=27.3797 //w=0.187 //l=0.4 //layer=li //thickness=0.1 \
 //x=1.475 //y=1.59 //x2=1.075 //y2=1.59
r56 (  1 35 ) resistor r=3.57586 //w=0.17 //l=0.125 //layer=li //thickness=0.1 \
 //x=0.59 //y=1.505 //x2=0.59 //y2=1.63
r57 (  1 35 ) resistor r=42.0963 //w=0.187 //l=0.615 //layer=li \
 //thickness=0.1 //x=0.59 //y=1.505 //x2=0.59 //y2=0.89
ends PM_NAND3X1_PCELL\%noxref_8
