// File: TMRDFFQNX1.spi.pex
// Created: Sun Apr 12 08:36:02 2026
// Program "Calibre xRC"
// Version "v2023.2_27.15"
// Nominal Temperature: 30C
// Circuit Temperature: 30C
//
simulator lang=spectre
subckt PM_TMRDFFQNX1\%noxref_1 ( 1 2 3 4 7 12 13 15 16 18 19 20 22 23 30 34 35 \
 38 40 43 48 50 53 54 56 57 58 60 62 65 72 73 76 85 90 98 115 124 128 129 130 \
 131 132 133 137 138 139 144 146 149 150 151 152 153 154 158 160 163 164 169 \
 170 175 184 187 189 190 )
c431 ( 187 0 ) capacitor c=0.00878249f //x=7.26 //y=1.085
c432 ( 184 0 ) capacitor c=0.0682508f //x=9.74 //y=4.88
c433 ( 175 0 ) capacitor c=0.0710066f //x=3.82 //y=4.88
c434 ( 170 0 ) capacitor c=0.0278202f //x=3.82 //y=2.095
c435 ( 169 0 ) capacitor c=0.0479324f //x=3.82 //y=2.26
c436 ( 164 0 ) capacitor c=0.0318956f //x=10.075 //y=1.39
c437 ( 163 0 ) capacitor c=0.0186809f //x=10.075 //y=1.045
c438 ( 160 0 ) capacitor c=0.0141821f //x=9.92 //y=1.545
c439 ( 158 0 ) capacitor c=0.0158553f //x=9.92 //y=0.89
c440 ( 154 0 ) capacitor c=0.0854171f //x=9.545 //y=2.095
c441 ( 153 0 ) capacitor c=0.0229235f //x=9.545 //y=1.7
c442 ( 152 0 ) capacitor c=0.0234359f //x=9.545 //y=1.39
c443 ( 151 0 ) capacitor c=0.0198759f //x=9.545 //y=1.045
c444 ( 150 0 ) capacitor c=0.0443175f //x=4.34 //y=1.44
c445 ( 149 0 ) capacitor c=0.0199703f //x=4.34 //y=1.095
c446 ( 146 0 ) capacitor c=0.0162526f //x=4.185 //y=1.595
c447 ( 144 0 ) capacitor c=0.0157807f //x=4.185 //y=0.94
c448 ( 139 0 ) capacitor c=0.0220935f //x=3.81 //y=1.75
c449 ( 138 0 ) capacitor c=0.0207489f //x=3.81 //y=1.44
c450 ( 137 0 ) capacitor c=0.0194091f //x=3.81 //y=1.095
c451 ( 133 0 ) capacitor c=0.110369f //x=10.08 //y=6.2
c452 ( 132 0 ) capacitor c=0.154619f //x=9.64 //y=6.2
c453 ( 131 0 ) capacitor c=0.159671f //x=4 //y=6.2
c454 ( 130 0 ) capacitor c=0.110208f //x=3.56 //y=6.2
c455 ( 124 0 ) capacitor c=8.13425e-19 //x=9.74 //y=4.88
c456 ( 115 0 ) capacitor c=7.85889e-19 //x=9.74 //y=2.26
c457 ( 98 0 ) capacitor c=0.0322017f //x=7.41 //y=5.56
c458 ( 90 0 ) capacitor c=0.0290186f //x=6.53 //y=5.56
c459 ( 85 0 ) capacitor c=8.10944e-19 //x=3.82 //y=4.88
c460 ( 76 0 ) capacitor c=0.00101179f //x=3.82 //y=2.26
c461 ( 73 0 ) capacitor c=0.0244175f //x=9.575 //y=3.505
c462 ( 72 0 ) capacitor c=5.48521e-19 //x=9.735 //y=3.505
c463 ( 65 0 ) capacitor c=0.0150626f //x=8.045 //y=3.51
c464 ( 62 0 ) capacitor c=0.00684519f //x=6.62 //y=3.495
c465 ( 60 0 ) capacitor c=0.0382613f //x=6.02 //y=3.51
c466 ( 58 0 ) capacitor c=0.018822f //x=4.775 //y=3.495
c467 ( 57 0 ) capacitor c=0.00325528f //x=3.985 //y=3.51
c468 ( 56 0 ) capacitor c=0.00673568f //x=4.175 //y=3.51
c469 ( 54 0 ) capacitor c=0.0267491f //x=9.742 //y=4.74
c470 ( 53 0 ) capacitor c=0.00611287f //x=9.74 //y=4.88
c471 ( 50 0 ) capacitor c=0.0064096f //x=9.74 //y=2.26
c472 ( 48 0 ) capacitor c=0.0163473f //x=9.74 //y=3.51
c473 ( 43 0 ) capacitor c=0.0170489f //x=7.885 //y=3.51
c474 ( 40 0 ) capacitor c=0.0111664f //x=7.45 //y=1.18
c475 ( 38 0 ) capacitor c=5.78613e-19 //x=7.41 //y=5.56
c476 ( 35 0 ) capacitor c=0.011587f //x=7.41 //y=5.38
c477 ( 34 0 ) capacitor c=0.00923791f //x=6.53 //y=5.56
c478 ( 30 0 ) capacitor c=0.0148558f //x=3.82 //y=3.51
c479 ( 23 0 ) capacitor c=0.0131975f //x=9.74 //y=3.665
c480 ( 22 0 ) capacitor c=0.0281931f //x=9.74 //y=3.345
c481 ( 20 0 ) capacitor c=0.0405845f //x=7.89 //y=5.295
c482 ( 19 0 ) capacitor c=0.0134427f //x=7.89 //y=3.67
c483 ( 18 0 ) capacitor c=0.0380709f //x=7.89 //y=3.35
c484 ( 16 0 ) capacitor c=0.00504728f //x=7.535 //y=1.835
c485 ( 15 0 ) capacitor c=0.0126369f //x=7.805 //y=1.835
c486 ( 13 0 ) capacitor c=0.0108105f //x=7.805 //y=5.38
c487 ( 12 0 ) capacitor c=0.0102514f //x=7.45 //y=1.75
c488 ( 7 0 ) capacitor c=0.01471f //x=7.295 //y=5.38
c489 ( 4 0 ) capacitor c=0.0286377f //x=3.82 //y=4.75
c490 ( 3 0 ) capacitor c=0.0126137f //x=3.82 //y=3.67
c491 ( 2 0 ) capacitor c=0.0274183f //x=3.82 //y=3.35
c492 ( 1 0 ) capacitor c=0.00685053f //x=3.82 //y=2.375
r493 (  182 184 ) resistor r=20.6867 //w=0.233 //l=0.1 //layer=ply \
 //thickness=0.18 //x=9.64 //y=4.88 //x2=9.74 //y2=4.88
r494 (  169 170 ) resistor r=52.7279 //w=0.214 //l=0.165 //layer=ply \
 //thickness=0.18 //x=3.82 //y=2.26 //x2=3.82 //y2=2.095
r495 (  165 184 ) resistor r=70.3348 //w=0.233 //l=0.414367 //layer=ply \
 //thickness=0.18 //x=10.08 //y=5.045 //x2=9.74 //y2=4.88
r496 (  164 186 ) resistor r=45.1352 //w=0.168 //l=0.173853 //layer=ply \
 //thickness=0.18 //x=10.075 //y=1.39 //x2=10.035 //y2=1.545
r497 (  163 185 ) resistor r=45.1352 //w=0.168 //l=0.173853 //layer=ply \
 //thickness=0.18 //x=10.075 //y=1.045 //x2=10.035 //y2=0.89
r498 (  163 164 ) resistor r=176.904 //w=0.094 //l=0.345 //layer=ply \
 //thickness=0.18 //x=10.075 //y=1.045 //x2=10.075 //y2=1.39
r499 (  161 181 ) resistor r=10.701 //w=0.21 //l=0.115 //layer=ply \
 //thickness=0.18 //x=9.7 //y=1.545 //x2=9.585 //y2=1.545
r500 (  160 186 ) resistor r=5.52526 //w=0.168 //l=0.115 //layer=ply \
 //thickness=0.18 //x=9.92 //y=1.545 //x2=10.035 //y2=1.545
r501 (  159 180 ) resistor r=5.52526 //w=0.168 //l=0.115 //layer=ply \
 //thickness=0.18 //x=9.7 //y=0.89 //x2=9.585 //y2=0.89
r502 (  158 185 ) resistor r=5.52526 //w=0.168 //l=0.115 //layer=ply \
 //thickness=0.18 //x=9.92 //y=0.89 //x2=10.035 //y2=0.89
r503 (  158 159 ) resistor r=112.809 //w=0.094 //l=0.22 //layer=ply \
 //thickness=0.18 //x=9.92 //y=0.89 //x2=9.7 //y2=0.89
r504 (  155 182 ) resistor r=13.0941 //w=0.233 //l=0.165 //layer=ply \
 //thickness=0.18 //x=9.64 //y=5.045 //x2=9.64 //y2=4.88
r505 (  154 179 ) resistor r=34.8111 //w=0.27 //l=0.264953 //layer=ply \
 //thickness=0.18 //x=9.545 //y=2.095 //x2=9.74 //y2=2.26
r506 (  153 181 ) resistor r=39.5823 //w=0.21 //l=0.173853 //layer=ply \
 //thickness=0.18 //x=9.545 //y=1.7 //x2=9.585 //y2=1.545
r507 (  153 154 ) resistor r=202.543 //w=0.094 //l=0.395 //layer=ply \
 //thickness=0.18 //x=9.545 //y=1.7 //x2=9.545 //y2=2.095
r508 (  152 181 ) resistor r=39.5823 //w=0.21 //l=0.173853 //layer=ply \
 //thickness=0.18 //x=9.545 //y=1.39 //x2=9.585 //y2=1.545
r509 (  151 180 ) resistor r=45.1352 //w=0.168 //l=0.173853 //layer=ply \
 //thickness=0.18 //x=9.545 //y=1.045 //x2=9.585 //y2=0.89
r510 (  151 152 ) resistor r=176.904 //w=0.094 //l=0.345 //layer=ply \
 //thickness=0.18 //x=9.545 //y=1.045 //x2=9.545 //y2=1.39
r511 (  150 177 ) resistor r=45.1352 //w=0.168 //l=0.173853 //layer=ply \
 //thickness=0.18 //x=4.34 //y=1.44 //x2=4.3 //y2=1.595
r512 (  149 176 ) resistor r=45.1352 //w=0.168 //l=0.173853 //layer=ply \
 //thickness=0.18 //x=4.34 //y=1.095 //x2=4.3 //y2=0.94
r513 (  149 150 ) resistor r=176.904 //w=0.094 //l=0.345 //layer=ply \
 //thickness=0.18 //x=4.34 //y=1.095 //x2=4.34 //y2=1.44
r514 (  147 173 ) resistor r=10.701 //w=0.21 //l=0.115 //layer=ply \
 //thickness=0.18 //x=3.965 //y=1.595 //x2=3.85 //y2=1.595
r515 (  146 177 ) resistor r=5.52526 //w=0.168 //l=0.115 //layer=ply \
 //thickness=0.18 //x=4.185 //y=1.595 //x2=4.3 //y2=1.595
r516 (  145 172 ) resistor r=5.52526 //w=0.168 //l=0.115 //layer=ply \
 //thickness=0.18 //x=3.965 //y=0.94 //x2=3.85 //y2=0.94
r517 (  144 176 ) resistor r=5.52526 //w=0.168 //l=0.115 //layer=ply \
 //thickness=0.18 //x=4.185 //y=0.94 //x2=4.3 //y2=0.94
r518 (  144 145 ) resistor r=112.809 //w=0.094 //l=0.22 //layer=ply \
 //thickness=0.18 //x=4.185 //y=0.94 //x2=3.965 //y2=0.94
r519 (  141 175 ) resistor r=37.236 //w=0.233 //l=0.249199 //layer=ply \
 //thickness=0.18 //x=4 //y=5.045 //x2=3.82 //y2=4.88
r520 (  139 173 ) resistor r=39.5823 //w=0.21 //l=0.173853 //layer=ply \
 //thickness=0.18 //x=3.81 //y=1.75 //x2=3.85 //y2=1.595
r521 (  139 170 ) resistor r=176.904 //w=0.094 //l=0.345 //layer=ply \
 //thickness=0.18 //x=3.81 //y=1.75 //x2=3.81 //y2=2.095
r522 (  138 173 ) resistor r=39.5823 //w=0.21 //l=0.173853 //layer=ply \
 //thickness=0.18 //x=3.81 //y=1.44 //x2=3.85 //y2=1.595
r523 (  137 172 ) resistor r=45.1352 //w=0.168 //l=0.173853 //layer=ply \
 //thickness=0.18 //x=3.81 //y=1.095 //x2=3.85 //y2=0.94
r524 (  137 138 ) resistor r=176.904 //w=0.094 //l=0.345 //layer=ply \
 //thickness=0.18 //x=3.81 //y=1.095 //x2=3.81 //y2=1.44
r525 (  134 175 ) resistor r=53.7854 //w=0.233 //l=0.332415 //layer=ply \
 //thickness=0.18 //x=3.56 //y=5.045 //x2=3.82 //y2=4.88
r526 (  133 165 ) resistor r=592.245 //w=0.094 //l=1.155 //layer=ply \
 //thickness=0.18 //x=10.08 //y=6.2 //x2=10.08 //y2=5.045
r527 (  132 155 ) resistor r=592.245 //w=0.094 //l=1.155 //layer=ply \
 //thickness=0.18 //x=9.64 //y=6.2 //x2=9.64 //y2=5.045
r528 (  131 141 ) resistor r=592.245 //w=0.094 //l=1.155 //layer=ply \
 //thickness=0.18 //x=4 //y=6.2 //x2=4 //y2=5.045
r529 (  130 134 ) resistor r=592.245 //w=0.094 //l=1.155 //layer=ply \
 //thickness=0.18 //x=3.56 //y=6.2 //x2=3.56 //y2=5.045
r530 (  129 160 ) resistor r=56.4043 //w=0.094 //l=0.11 //layer=ply \
 //thickness=0.18 //x=9.81 //y=1.545 //x2=9.92 //y2=1.545
r531 (  129 161 ) resistor r=56.4043 //w=0.094 //l=0.11 //layer=ply \
 //thickness=0.18 //x=9.81 //y=1.545 //x2=9.7 //y2=1.545
r532 (  128 146 ) resistor r=56.4043 //w=0.094 //l=0.11 //layer=ply \
 //thickness=0.18 //x=4.075 //y=1.595 //x2=4.185 //y2=1.595
r533 (  128 147 ) resistor r=56.4043 //w=0.094 //l=0.11 //layer=ply \
 //thickness=0.18 //x=4.075 //y=1.595 //x2=3.965 //y2=1.595
r534 (  124 184 ) resistor r=152 //w=0.17 //l=0.17 //layer=licon //count=1 \
 //x=9.74 //y=4.88 //x2=9.74 //y2=4.88
r535 (  115 179 ) resistor r=152 //w=0.17 //l=0.17 //layer=licon //count=1 \
 //x=9.74 //y=2.26 //x2=9.74 //y2=2.26
r536 (  98 190 ) resistor r=23.615 //w=0.187 //l=0.345 //layer=li \
 //thickness=0.1 //x=7.41 //y=5.56 //x2=7.41 //y2=5.905
r537 (  90 189 ) resistor r=23.615 //w=0.187 //l=0.345 //layer=li \
 //thickness=0.1 //x=6.53 //y=5.56 //x2=6.53 //y2=5.905
r538 (  85 175 ) resistor r=152 //w=0.17 //l=0.17 //layer=licon //count=1 \
 //x=3.82 //y=4.88 //x2=3.82 //y2=4.88
r539 (  76 169 ) resistor r=152 //w=0.17 //l=0.17 //layer=licon //count=1 \
 //x=3.82 //y=2.26 //x2=3.82 //y2=2.26
r540 (  72 73 ) resistor r=0.10734 //w=0.281 //l=0.16 //layer=m2 \
 //thickness=0.36 //x=9.735 //y=3.505 //x2=9.575 //y2=3.505
r541 (  65 70 ) resistor r=0.10188 //w=0.204 //l=0.16 //layer=m2 \
 //thickness=0.36 //x=8.045 //y=3.51 //x2=7.885 //y2=3.51
r542 (  65 73 ) resistor r=1.45992 //w=0.131 //l=1.53 //layer=m2 \
 //thickness=0.36 //x=8.045 //y=3.51 //x2=9.575 //y2=3.51
r543 (  62 70 ) resistor r=0.778963 //w=0.204 //l=1.27248 //layer=m2 \
 //thickness=0.36 //x=6.62 //y=3.495 //x2=7.885 //y2=3.51
r544 (  62 63 ) resistor r=0.410305 //w=0.131 //l=0.43 //layer=m2 \
 //thickness=0.36 //x=6.62 //y=3.495 //x2=6.19 //y2=3.495
r545 (  60 63 ) resistor r=0.125 //w=0.17 //l=0.177341 //layer=m2 \
 //thickness=0.36 //x=6.02 //y=3.51 //x2=6.19 //y2=3.495
r546 (  60 61 ) resistor r=0.944656 //w=0.131 //l=0.99 //layer=m2 \
 //thickness=0.36 //x=6.02 //y=3.51 //x2=5.03 //y2=3.51
r547 (  58 61 ) resistor r=0.1875 //w=0.17 //l=0.262393 //layer=m2 \
 //thickness=0.36 //x=4.775 //y=3.495 //x2=5.03 //y2=3.51
r548 (  58 59 ) resistor r=0.410305 //w=0.131 //l=0.43 //layer=m2 \
 //thickness=0.36 //x=4.775 //y=3.495 //x2=4.345 //y2=3.495
r549 (  57 67 ) resistor r=0.10734 //w=0.281 //l=0.16 //layer=m2 \
 //thickness=0.36 //x=3.985 //y=3.51 //x2=3.825 //y2=3.51
r550 (  56 59 ) resistor r=0.125 //w=0.17 //l=0.177341 //layer=m2 \
 //thickness=0.36 //x=4.175 //y=3.51 //x2=4.345 //y2=3.495
r551 (  56 57 ) resistor r=0.181298 //w=0.131 //l=0.19 //layer=m2 \
 //thickness=0.36 //x=4.175 //y=3.51 //x2=3.985 //y2=3.51
r552 (  53 124 ) resistor r=9.3 //w=0.17 //l=0.17 //layer=mcon //count=1 \
 //x=9.74 //y=4.88 //x2=9.74 //y2=4.88
r553 (  53 54 ) resistor r=0.103207 //w=0.196 //l=0.14 //layer=m1 \
 //thickness=0.36 //x=9.742 //y=4.88 //x2=9.742 //y2=4.74
r554 (  50 115 ) resistor r=9.3 //w=0.17 //l=0.17 //layer=mcon //count=1 \
 //x=9.74 //y=2.26 //x2=9.74 //y2=2.26
r555 (  46 72 ) resistor r=4.5 //w=0.15 //l=0.15 //layer=via1 //count=1 \
 //x=9.735 //y=3.505 //x2=9.735 //y2=3.505
r556 (  46 48 ) resistor r=0.00167112 //w=0.374 //l=0.005 //layer=m1 \
 //thickness=0.36 //x=9.685 //y=3.505 //x2=9.685 //y2=3.51
r557 (  43 70 ) resistor r=4.5 //w=0.15 //l=0.15 //layer=via1 //count=1 \
 //x=7.885 //y=3.51 //x2=7.885 //y2=3.51
r558 (  40 187 ) resistor r=9.3 //w=0.17 //l=0.17 //layer=mcon //count=1 \
 //x=7.45 //y=1.18 //x2=7.45 //y2=1.18
r559 (  38 98 ) resistor r=9.3 //w=0.17 //l=0.17 //layer=mcon //count=1 \
 //x=7.41 //y=5.56 //x2=7.41 //y2=5.56
r560 (  35 38 ) resistor r=0.117801 //w=0.191 //l=0.18 //layer=m1 \
 //thickness=0.36 //x=7.41 //y=5.38 //x2=7.41 //y2=5.56
r561 (  34 90 ) resistor r=9.3 //w=0.17 //l=0.17 //layer=mcon //count=1 \
 //x=6.53 //y=5.56 //x2=6.53 //y2=5.56
r562 (  32 34 ) resistor r=0.10274 //w=0.219 //l=0.18 //layer=m1 \
 //thickness=0.36 //x=6.53 //y=5.38 //x2=6.53 //y2=5.56
r563 (  30 67 ) resistor r=4.5 //w=0.15 //l=0.15 //layer=via1 //count=1 \
 //x=3.825 //y=3.51 //x2=3.825 //y2=3.51
r564 (  28 85 ) resistor r=9.3 //w=0.17 //l=0.17 //layer=mcon //count=1 \
 //x=3.82 //y=4.88 //x2=3.82 //y2=4.88
r565 (  26 76 ) resistor r=9.3 //w=0.17 //l=0.17 //layer=mcon //count=1 \
 //x=3.82 //y=2.26 //x2=3.82 //y2=2.26
r566 (  23 48 ) resistor r=0.089409 //w=0.374 //l=0.180416 //layer=m1 \
 //thickness=0.36 //x=9.74 //y=3.665 //x2=9.685 //y2=3.51
r567 (  23 54 ) resistor r=1.02576 //w=0.131 //l=1.075 //layer=m1 \
 //thickness=0.36 //x=9.74 //y=3.665 //x2=9.74 //y2=4.74
r568 (  22 46 ) resistor r=0.0910802 //w=0.374 //l=0.185472 //layer=m1 \
 //thickness=0.36 //x=9.74 //y=3.345 //x2=9.685 //y2=3.505
r569 (  21 50 ) resistor r=0.0933015 //w=0.201 //l=0.125 //layer=m1 \
 //thickness=0.36 //x=9.74 //y=2.385 //x2=9.74 //y2=2.26
r570 (  21 22 ) resistor r=0.916031 //w=0.131 //l=0.96 //layer=m1 \
 //thickness=0.36 //x=9.74 //y=2.385 //x2=9.74 //y2=3.345
r571 (  19 43 ) resistor r=0.0910802 //w=0.374 //l=0.185472 //layer=m1 \
 //thickness=0.36 //x=7.89 //y=3.67 //x2=7.835 //y2=3.51
r572 (  19 20 ) resistor r=1.55057 //w=0.131 //l=1.625 //layer=m1 \
 //thickness=0.36 //x=7.89 //y=3.67 //x2=7.89 //y2=5.295
r573 (  18 43 ) resistor r=0.0910802 //w=0.374 //l=0.185472 //layer=m1 \
 //thickness=0.36 //x=7.89 //y=3.35 //x2=7.835 //y2=3.51
r574 (  17 18 ) resistor r=1.3645 //w=0.131 //l=1.43 //layer=m1 \
 //thickness=0.36 //x=7.89 //y=1.92 //x2=7.89 //y2=3.35
r575 (  15 17 ) resistor r=0.0698411 //w=0.17 //l=0.120208 //layer=m1 \
 //thickness=0.36 //x=7.805 //y=1.835 //x2=7.89 //y2=1.92
r576 (  15 16 ) resistor r=0.257634 //w=0.131 //l=0.27 //layer=m1 \
 //thickness=0.36 //x=7.805 //y=1.835 //x2=7.535 //y2=1.835
r577 (  14 35 ) resistor r=0.0257089 //w=0.23 //l=0.115 //layer=m1 \
 //thickness=0.36 //x=7.525 //y=5.38 //x2=7.41 //y2=5.38
r578 (  13 20 ) resistor r=0.0698411 //w=0.17 //l=0.120208 //layer=m1 \
 //thickness=0.36 //x=7.805 //y=5.38 //x2=7.89 //y2=5.295
r579 (  13 14 ) resistor r=0.267176 //w=0.131 //l=0.28 //layer=m1 \
 //thickness=0.36 //x=7.805 //y=5.38 //x2=7.525 //y2=5.38
r580 (  12 16 ) resistor r=0.0698411 //w=0.17 //l=0.120208 //layer=m1 \
 //thickness=0.36 //x=7.45 //y=1.75 //x2=7.535 //y2=1.835
r581 (  11 40 ) resistor r=0.0913624 //w=0.191 //l=0.12 //layer=m1 \
 //thickness=0.36 //x=7.45 //y=1.3 //x2=7.45 //y2=1.18
r582 (  11 12 ) resistor r=0.429389 //w=0.131 //l=0.45 //layer=m1 \
 //thickness=0.36 //x=7.45 //y=1.3 //x2=7.45 //y2=1.75
r583 (  8 32 ) resistor r=0.0227762 //w=0.219 //l=0.115 //layer=m1 \
 //thickness=0.36 //x=6.645 //y=5.38 //x2=6.53 //y2=5.38
r584 (  7 35 ) resistor r=0.0257089 //w=0.23 //l=0.115 //layer=m1 \
 //thickness=0.36 //x=7.295 //y=5.38 //x2=7.41 //y2=5.38
r585 (  7 8 ) resistor r=0.620229 //w=0.131 //l=0.65 //layer=m1 \
 //thickness=0.36 //x=7.295 //y=5.38 //x2=6.645 //y2=5.38
r586 (  4 28 ) resistor r=0.0801089 //w=0.224 //l=0.13 //layer=m1 \
 //thickness=0.36 //x=3.82 //y=4.75 //x2=3.82 //y2=4.88
r587 (  3 30 ) resistor r=0.0910802 //w=0.374 //l=0.185472 //layer=m1 \
 //thickness=0.36 //x=3.82 //y=3.67 //x2=3.875 //y2=3.51
r588 (  3 4 ) resistor r=1.03053 //w=0.131 //l=1.08 //layer=m1 \
 //thickness=0.36 //x=3.82 //y=3.67 //x2=3.82 //y2=4.75
r589 (  2 30 ) resistor r=0.0910802 //w=0.374 //l=0.185472 //layer=m1 \
 //thickness=0.36 //x=3.82 //y=3.35 //x2=3.875 //y2=3.51
r590 (  1 26 ) resistor r=0.0719237 //w=0.222 //l=0.115 //layer=m1 \
 //thickness=0.36 //x=3.82 //y=2.375 //x2=3.82 //y2=2.26
r591 (  1 2 ) resistor r=0.930344 //w=0.131 //l=0.975 //layer=m1 \
 //thickness=0.36 //x=3.82 //y=2.375 //x2=3.82 //y2=3.35
ends PM_TMRDFFQNX1\%noxref_1

subckt PM_TMRDFFQNX1\%noxref_2 ( 3 8 9 11 12 14 15 16 18 19 23 24 27 29 32 35 \
 38 41 42 44 45 50 53 61 78 87 91 92 93 94 95 96 97 101 103 106 107 117 120 \
 122 123 )
c282 ( 120 0 ) capacitor c=0.00878249f //x=10.59 //y=1.085
c283 ( 117 0 ) capacitor c=0.0682508f //x=13.07 //y=4.88
c284 ( 107 0 ) capacitor c=0.0318956f //x=13.405 //y=1.39
c285 ( 106 0 ) capacitor c=0.0186809f //x=13.405 //y=1.045
c286 ( 103 0 ) capacitor c=0.0141821f //x=13.25 //y=1.545
c287 ( 101 0 ) capacitor c=0.0158553f //x=13.25 //y=0.89
c288 ( 97 0 ) capacitor c=0.0854195f //x=12.875 //y=2.095
c289 ( 96 0 ) capacitor c=0.0229235f //x=12.875 //y=1.7
c290 ( 95 0 ) capacitor c=0.0234359f //x=12.875 //y=1.39
c291 ( 94 0 ) capacitor c=0.0198759f //x=12.875 //y=1.045
c292 ( 93 0 ) capacitor c=0.110369f //x=13.41 //y=6.2
c293 ( 92 0 ) capacitor c=0.154619f //x=12.97 //y=6.2
c294 ( 87 0 ) capacitor c=8.13425e-19 //x=13.07 //y=4.88
c295 ( 78 0 ) capacitor c=7.85889e-19 //x=13.07 //y=2.26
c296 ( 61 0 ) capacitor c=0.0322017f //x=10.74 //y=5.56
c297 ( 53 0 ) capacitor c=0.0291714f //x=9.86 //y=5.56
c298 ( 50 0 ) capacitor c=5.49021e-19 //x=13.065 //y=3.51
c299 ( 45 0 ) capacitor c=8.73927e-19 //x=11.385 //y=3.51
c300 ( 44 0 ) capacitor c=0.0228166f //x=12.905 //y=3.51
c301 ( 42 0 ) capacitor c=0.0270852f //x=13.072 //y=4.74
c302 ( 41 0 ) capacitor c=0.0060492f //x=13.07 //y=4.88
c303 ( 38 0 ) capacitor c=0.00641145f //x=13.07 //y=2.26
c304 ( 35 0 ) capacitor c=0.0164425f //x=13.065 //y=3.51
c305 ( 32 0 ) capacitor c=0.0167895f //x=11.22 //y=3.51
c306 ( 29 0 ) capacitor c=0.0113735f //x=10.78 //y=1.18
c307 ( 27 0 ) capacitor c=5.78613e-19 //x=10.74 //y=5.56
c308 ( 24 0 ) capacitor c=0.0103127f //x=10.74 //y=5.38
c309 ( 23 0 ) capacitor c=0.00933334f //x=9.86 //y=5.56
c310 ( 19 0 ) capacitor c=0.0131458f //x=13.07 //y=3.67
c311 ( 18 0 ) capacitor c=0.0282897f //x=13.07 //y=3.35
c312 ( 16 0 ) capacitor c=0.0402141f //x=11.22 //y=5.295
c313 ( 15 0 ) capacitor c=0.0132742f //x=11.22 //y=3.67
c314 ( 14 0 ) capacitor c=0.0395638f //x=11.22 //y=3.35
c315 ( 12 0 ) capacitor c=0.00560492f //x=10.865 //y=1.835
c316 ( 11 0 ) capacitor c=0.0129728f //x=11.135 //y=1.835
c317 ( 9 0 ) capacitor c=0.0112475f //x=11.135 //y=5.38
c318 ( 8 0 ) capacitor c=0.0101547f //x=10.78 //y=1.75
c319 ( 3 0 ) capacitor c=0.0134484f //x=10.625 //y=5.38
r320 (  115 117 ) resistor r=20.6867 //w=0.233 //l=0.1 //layer=ply \
 //thickness=0.18 //x=12.97 //y=4.88 //x2=13.07 //y2=4.88
r321 (  108 117 ) resistor r=70.3348 //w=0.233 //l=0.414367 //layer=ply \
 //thickness=0.18 //x=13.41 //y=5.045 //x2=13.07 //y2=4.88
r322 (  107 119 ) resistor r=45.1352 //w=0.168 //l=0.173853 //layer=ply \
 //thickness=0.18 //x=13.405 //y=1.39 //x2=13.365 //y2=1.545
r323 (  106 118 ) resistor r=45.1352 //w=0.168 //l=0.173853 //layer=ply \
 //thickness=0.18 //x=13.405 //y=1.045 //x2=13.365 //y2=0.89
r324 (  106 107 ) resistor r=176.904 //w=0.094 //l=0.345 //layer=ply \
 //thickness=0.18 //x=13.405 //y=1.045 //x2=13.405 //y2=1.39
r325 (  104 114 ) resistor r=10.701 //w=0.21 //l=0.115 //layer=ply \
 //thickness=0.18 //x=13.03 //y=1.545 //x2=12.915 //y2=1.545
r326 (  103 119 ) resistor r=5.52526 //w=0.168 //l=0.115 //layer=ply \
 //thickness=0.18 //x=13.25 //y=1.545 //x2=13.365 //y2=1.545
r327 (  102 113 ) resistor r=5.52526 //w=0.168 //l=0.115 //layer=ply \
 //thickness=0.18 //x=13.03 //y=0.89 //x2=12.915 //y2=0.89
r328 (  101 118 ) resistor r=5.52526 //w=0.168 //l=0.115 //layer=ply \
 //thickness=0.18 //x=13.25 //y=0.89 //x2=13.365 //y2=0.89
r329 (  101 102 ) resistor r=112.809 //w=0.094 //l=0.22 //layer=ply \
 //thickness=0.18 //x=13.25 //y=0.89 //x2=13.03 //y2=0.89
r330 (  98 115 ) resistor r=13.0941 //w=0.233 //l=0.165 //layer=ply \
 //thickness=0.18 //x=12.97 //y=5.045 //x2=12.97 //y2=4.88
r331 (  97 112 ) resistor r=34.8111 //w=0.27 //l=0.264953 //layer=ply \
 //thickness=0.18 //x=12.875 //y=2.095 //x2=13.07 //y2=2.26
r332 (  96 114 ) resistor r=39.5823 //w=0.21 //l=0.173853 //layer=ply \
 //thickness=0.18 //x=12.875 //y=1.7 //x2=12.915 //y2=1.545
r333 (  96 97 ) resistor r=202.543 //w=0.094 //l=0.395 //layer=ply \
 //thickness=0.18 //x=12.875 //y=1.7 //x2=12.875 //y2=2.095
r334 (  95 114 ) resistor r=39.5823 //w=0.21 //l=0.173853 //layer=ply \
 //thickness=0.18 //x=12.875 //y=1.39 //x2=12.915 //y2=1.545
r335 (  94 113 ) resistor r=45.1352 //w=0.168 //l=0.173853 //layer=ply \
 //thickness=0.18 //x=12.875 //y=1.045 //x2=12.915 //y2=0.89
r336 (  94 95 ) resistor r=176.904 //w=0.094 //l=0.345 //layer=ply \
 //thickness=0.18 //x=12.875 //y=1.045 //x2=12.875 //y2=1.39
r337 (  93 108 ) resistor r=592.245 //w=0.094 //l=1.155 //layer=ply \
 //thickness=0.18 //x=13.41 //y=6.2 //x2=13.41 //y2=5.045
r338 (  92 98 ) resistor r=592.245 //w=0.094 //l=1.155 //layer=ply \
 //thickness=0.18 //x=12.97 //y=6.2 //x2=12.97 //y2=5.045
r339 (  91 103 ) resistor r=56.4043 //w=0.094 //l=0.11 //layer=ply \
 //thickness=0.18 //x=13.14 //y=1.545 //x2=13.25 //y2=1.545
r340 (  91 104 ) resistor r=56.4043 //w=0.094 //l=0.11 //layer=ply \
 //thickness=0.18 //x=13.14 //y=1.545 //x2=13.03 //y2=1.545
r341 (  87 117 ) resistor r=152 //w=0.17 //l=0.17 //layer=licon //count=1 \
 //x=13.07 //y=4.88 //x2=13.07 //y2=4.88
r342 (  78 112 ) resistor r=152 //w=0.17 //l=0.17 //layer=licon //count=1 \
 //x=13.07 //y=2.26 //x2=13.07 //y2=2.26
r343 (  61 123 ) resistor r=23.615 //w=0.187 //l=0.345 //layer=li \
 //thickness=0.1 //x=10.74 //y=5.56 //x2=10.74 //y2=5.905
r344 (  53 122 ) resistor r=23.615 //w=0.187 //l=0.345 //layer=li \
 //thickness=0.1 //x=9.86 //y=5.56 //x2=9.86 //y2=5.905
r345 (  45 47 ) resistor r=0.10734 //w=0.281 //l=0.16 //layer=m2 \
 //thickness=0.36 //x=11.385 //y=3.51 //x2=11.225 //y2=3.51
r346 (  44 50 ) resistor r=0.10734 //w=0.281 //l=0.16 //layer=m2 \
 //thickness=0.36 //x=12.905 //y=3.51 //x2=13.065 //y2=3.51
r347 (  44 45 ) resistor r=1.45038 //w=0.131 //l=1.52 //layer=m2 \
 //thickness=0.36 //x=12.905 //y=3.51 //x2=11.385 //y2=3.51
r348 (  41 87 ) resistor r=9.3 //w=0.17 //l=0.17 //layer=mcon //count=1 \
 //x=13.07 //y=4.88 //x2=13.07 //y2=4.88
r349 (  41 42 ) resistor r=0.103207 //w=0.196 //l=0.14 //layer=m1 \
 //thickness=0.36 //x=13.072 //y=4.88 //x2=13.072 //y2=4.74
r350 (  38 78 ) resistor r=9.3 //w=0.17 //l=0.17 //layer=mcon //count=1 \
 //x=13.07 //y=2.26 //x2=13.07 //y2=2.26
r351 (  35 50 ) resistor r=4.5 //w=0.15 //l=0.15 //layer=via1 //count=1 \
 //x=13.065 //y=3.51 //x2=13.065 //y2=3.51
r352 (  32 47 ) resistor r=4.5 //w=0.15 //l=0.15 //layer=via1 //count=1 \
 //x=11.225 //y=3.51 //x2=11.225 //y2=3.51
r353 (  29 120 ) resistor r=9.3 //w=0.17 //l=0.17 //layer=mcon //count=1 \
 //x=10.78 //y=1.18 //x2=10.78 //y2=1.18
r354 (  27 61 ) resistor r=9.3 //w=0.17 //l=0.17 //layer=mcon //count=1 \
 //x=10.74 //y=5.56 //x2=10.74 //y2=5.56
r355 (  24 27 ) resistor r=0.117801 //w=0.191 //l=0.18 //layer=m1 \
 //thickness=0.36 //x=10.74 //y=5.38 //x2=10.74 //y2=5.56
r356 (  23 53 ) resistor r=9.3 //w=0.17 //l=0.17 //layer=mcon //count=1 \
 //x=9.86 //y=5.56 //x2=9.86 //y2=5.56
r357 (  21 23 ) resistor r=0.10274 //w=0.219 //l=0.18 //layer=m1 \
 //thickness=0.36 //x=9.86 //y=5.38 //x2=9.86 //y2=5.56
r358 (  19 35 ) resistor r=0.0910802 //w=0.374 //l=0.185472 //layer=m1 \
 //thickness=0.36 //x=13.07 //y=3.67 //x2=13.015 //y2=3.51
r359 (  19 42 ) resistor r=1.02099 //w=0.131 //l=1.07 //layer=m1 \
 //thickness=0.36 //x=13.07 //y=3.67 //x2=13.07 //y2=4.74
r360 (  18 35 ) resistor r=0.0910802 //w=0.374 //l=0.185472 //layer=m1 \
 //thickness=0.36 //x=13.07 //y=3.35 //x2=13.015 //y2=3.51
r361 (  17 38 ) resistor r=0.0933015 //w=0.201 //l=0.125 //layer=m1 \
 //thickness=0.36 //x=13.07 //y=2.385 //x2=13.07 //y2=2.26
r362 (  17 18 ) resistor r=0.920802 //w=0.131 //l=0.965 //layer=m1 \
 //thickness=0.36 //x=13.07 //y=2.385 //x2=13.07 //y2=3.35
r363 (  15 32 ) resistor r=0.0910802 //w=0.374 //l=0.185472 //layer=m1 \
 //thickness=0.36 //x=11.22 //y=3.67 //x2=11.275 //y2=3.51
r364 (  15 16 ) resistor r=1.55057 //w=0.131 //l=1.625 //layer=m1 \
 //thickness=0.36 //x=11.22 //y=3.67 //x2=11.22 //y2=5.295
r365 (  14 32 ) resistor r=0.0910802 //w=0.374 //l=0.185472 //layer=m1 \
 //thickness=0.36 //x=11.22 //y=3.35 //x2=11.275 //y2=3.51
r366 (  13 14 ) resistor r=1.3645 //w=0.131 //l=1.43 //layer=m1 \
 //thickness=0.36 //x=11.22 //y=1.92 //x2=11.22 //y2=3.35
r367 (  11 13 ) resistor r=0.0698411 //w=0.17 //l=0.120208 //layer=m1 \
 //thickness=0.36 //x=11.135 //y=1.835 //x2=11.22 //y2=1.92
r368 (  11 12 ) resistor r=0.257634 //w=0.131 //l=0.27 //layer=m1 \
 //thickness=0.36 //x=11.135 //y=1.835 //x2=10.865 //y2=1.835
r369 (  10 24 ) resistor r=0.0257089 //w=0.23 //l=0.115 //layer=m1 \
 //thickness=0.36 //x=10.855 //y=5.38 //x2=10.74 //y2=5.38
r370 (  9 16 ) resistor r=0.0698411 //w=0.17 //l=0.120208 //layer=m1 \
 //thickness=0.36 //x=11.135 //y=5.38 //x2=11.22 //y2=5.295
r371 (  9 10 ) resistor r=0.267176 //w=0.131 //l=0.28 //layer=m1 \
 //thickness=0.36 //x=11.135 //y=5.38 //x2=10.855 //y2=5.38
r372 (  8 12 ) resistor r=0.0698411 //w=0.17 //l=0.120208 //layer=m1 \
 //thickness=0.36 //x=10.78 //y=1.75 //x2=10.865 //y2=1.835
r373 (  7 29 ) resistor r=0.0913624 //w=0.191 //l=0.12 //layer=m1 \
 //thickness=0.36 //x=10.78 //y=1.3 //x2=10.78 //y2=1.18
r374 (  7 8 ) resistor r=0.429389 //w=0.131 //l=0.45 //layer=m1 \
 //thickness=0.36 //x=10.78 //y=1.3 //x2=10.78 //y2=1.75
r375 (  4 21 ) resistor r=0.0227762 //w=0.219 //l=0.115 //layer=m1 \
 //thickness=0.36 //x=9.975 //y=5.38 //x2=9.86 //y2=5.38
r376 (  3 24 ) resistor r=0.0257089 //w=0.23 //l=0.115 //layer=m1 \
 //thickness=0.36 //x=10.625 //y=5.38 //x2=10.74 //y2=5.38
r377 (  3 4 ) resistor r=0.620229 //w=0.131 //l=0.65 //layer=m1 \
 //thickness=0.36 //x=10.625 //y=5.38 //x2=9.975 //y2=5.38
ends PM_TMRDFFQNX1\%noxref_2

subckt PM_TMRDFFQNX1\%noxref_3 ( 1 3 6 7 9 10 11 12 14 15 16 18 19 22 23 25 28 \
 31 37 40 43 46 47 50 54 57 58 60 61 62 63 64 66 68 70 72 74 84 92 100 117 126 \
 131 140 144 145 146 147 148 149 150 151 152 153 157 159 162 163 167 168 169 \
 170 174 176 179 180 190 199 202 204 205 206 )
c481 ( 202 0 ) capacitor c=0.00885916f //x=3.885 //y=1.095
c482 ( 199 0 ) capacitor c=0.0645411f //x=16.4 //y=4.88
c483 ( 190 0 ) capacitor c=0.0645923f //x=6.41 //y=4.88
c484 ( 180 0 ) capacitor c=0.0318956f //x=16.735 //y=1.39
c485 ( 179 0 ) capacitor c=0.0186809f //x=16.735 //y=1.045
c486 ( 176 0 ) capacitor c=0.0141821f //x=16.58 //y=1.545
c487 ( 174 0 ) capacitor c=0.0158553f //x=16.58 //y=0.89
c488 ( 170 0 ) capacitor c=0.088055f //x=16.205 //y=2.095
c489 ( 169 0 ) capacitor c=0.0229235f //x=16.205 //y=1.7
c490 ( 168 0 ) capacitor c=0.0234359f //x=16.205 //y=1.39
c491 ( 167 0 ) capacitor c=0.0198759f //x=16.205 //y=1.045
c492 ( 163 0 ) capacitor c=0.0318956f //x=6.745 //y=1.39
c493 ( 162 0 ) capacitor c=0.0186809f //x=6.745 //y=1.045
c494 ( 159 0 ) capacitor c=0.0141821f //x=6.59 //y=1.545
c495 ( 157 0 ) capacitor c=0.0158553f //x=6.59 //y=0.89
c496 ( 153 0 ) capacitor c=0.088055f //x=6.215 //y=2.095
c497 ( 152 0 ) capacitor c=0.0229235f //x=6.215 //y=1.7
c498 ( 151 0 ) capacitor c=0.0234359f //x=6.215 //y=1.39
c499 ( 150 0 ) capacitor c=0.0198759f //x=6.215 //y=1.045
c500 ( 149 0 ) capacitor c=0.110369f //x=16.74 //y=6.2
c501 ( 148 0 ) capacitor c=0.154619f //x=16.3 //y=6.2
c502 ( 147 0 ) capacitor c=0.110369f //x=6.75 //y=6.2
c503 ( 146 0 ) capacitor c=0.154619f //x=6.31 //y=6.2
c504 ( 140 0 ) capacitor c=8.13425e-19 //x=16.4 //y=4.88
c505 ( 131 0 ) capacitor c=7.85889e-19 //x=16.4 //y=2.26
c506 ( 126 0 ) capacitor c=8.13425e-19 //x=6.41 //y=4.88
c507 ( 117 0 ) capacitor c=7.85889e-19 //x=6.41 //y=2.26
c508 ( 100 0 ) capacitor c=0.0293071f //x=3.78 //y=5.56
c509 ( 92 0 ) capacitor c=0.029137f //x=2.9 //y=5.56
c510 ( 84 0 ) capacitor c=0.0278099f //x=2.02 //y=5.56
c511 ( 74 0 ) capacitor c=0.0461327f //x=13.28 //y=3.895
c512 ( 72 0 ) capacitor c=0.0175525f //x=12.68 //y=3.88
c513 ( 70 0 ) capacitor c=0.00418974f //x=11.44 //y=3.895
c514 ( 68 0 ) capacitor c=0.00891578f //x=10.7 //y=3.87
c515 ( 66 0 ) capacitor c=0.00615582f //x=9.95 //y=3.89
c516 ( 64 0 ) capacitor c=0.0178779f //x=9.35 //y=3.88
c517 ( 63 0 ) capacitor c=0.00993053f //x=7.755 //y=3.895
c518 ( 62 0 ) capacitor c=0.00477746f //x=8.1 //y=3.895
c519 ( 61 0 ) capacitor c=7.05145e-19 //x=4.72 //y=3.88
c520 ( 60 0 ) capacitor c=0.0193144f //x=6.245 //y=3.88
c521 ( 58 0 ) capacitor c=0.0161336f //x=16.402 //y=4.74
c522 ( 57 0 ) capacitor c=0.00598189f //x=16.4 //y=4.88
c523 ( 54 0 ) capacitor c=0.00654828f //x=16.4 //y=2.26
c524 ( 50 0 ) capacitor c=0.0159231f //x=16.4 //y=3.88
c525 ( 47 0 ) capacitor c=0.0172769f //x=6.412 //y=4.74
c526 ( 46 0 ) capacitor c=0.00598357f //x=6.41 //y=4.88
c527 ( 43 0 ) capacitor c=0.00654649f //x=6.41 //y=2.26
c528 ( 40 0 ) capacitor c=0.0163193f //x=6.405 //y=3.88
c529 ( 37 0 ) capacitor c=0.0170864f //x=4.56 //y=3.88
c530 ( 31 0 ) capacitor c=9.55882e-19 //x=3.78 //y=5.335
c531 ( 28 0 ) capacitor c=0.00753245f //x=2.9 //y=5.335
c532 ( 25 0 ) capacitor c=0.0123281f //x=2.022 //y=5.335
c533 ( 23 0 ) capacitor c=0.012588f //x=16.4 //y=4.045
c534 ( 22 0 ) capacitor c=0.0390293f //x=16.4 //y=3.725
c535 ( 19 0 ) capacitor c=0.0124546f //x=6.41 //y=4.04
c536 ( 18 0 ) capacitor c=0.0366873f //x=6.41 //y=3.72
c537 ( 16 0 ) capacitor c=0.0309857f //x=4.56 //y=5.25
c538 ( 15 0 ) capacitor c=0.0132732f //x=4.56 //y=4.04
c539 ( 14 0 ) capacitor c=0.0506888f //x=4.56 //y=3.72
c540 ( 12 0 ) capacitor c=0.00686157f //x=4.16 //y=1.845
c541 ( 11 0 ) capacitor c=0.0159771f //x=4.475 //y=1.845
c542 ( 10 0 ) capacitor c=0.0136149f //x=4.075 //y=1.76
c543 ( 9 0 ) capacitor c=0.011255f //x=4.075 //y=1.305
c544 ( 7 0 ) capacitor c=0.0228253f //x=4.475 //y=5.335
c545 ( 6 0 ) capacitor c=0.00906713f //x=3.78 //y=5.56
c546 ( 3 0 ) capacitor c=0.019596f //x=3.665 //y=5.335
c547 ( 1 0 ) capacitor c=0.0150747f //x=2.78 //y=5.335
r548 (  197 199 ) resistor r=20.6867 //w=0.233 //l=0.1 //layer=ply \
 //thickness=0.18 //x=16.3 //y=4.88 //x2=16.4 //y2=4.88
r549 (  188 190 ) resistor r=20.6867 //w=0.233 //l=0.1 //layer=ply \
 //thickness=0.18 //x=6.31 //y=4.88 //x2=6.41 //y2=4.88
r550 (  181 199 ) resistor r=70.3348 //w=0.233 //l=0.414367 //layer=ply \
 //thickness=0.18 //x=16.74 //y=5.045 //x2=16.4 //y2=4.88
r551 (  180 201 ) resistor r=45.1352 //w=0.168 //l=0.173853 //layer=ply \
 //thickness=0.18 //x=16.735 //y=1.39 //x2=16.695 //y2=1.545
r552 (  179 200 ) resistor r=45.1352 //w=0.168 //l=0.173853 //layer=ply \
 //thickness=0.18 //x=16.735 //y=1.045 //x2=16.695 //y2=0.89
r553 (  179 180 ) resistor r=176.904 //w=0.094 //l=0.345 //layer=ply \
 //thickness=0.18 //x=16.735 //y=1.045 //x2=16.735 //y2=1.39
r554 (  177 196 ) resistor r=10.701 //w=0.21 //l=0.115 //layer=ply \
 //thickness=0.18 //x=16.36 //y=1.545 //x2=16.245 //y2=1.545
r555 (  176 201 ) resistor r=5.52526 //w=0.168 //l=0.115 //layer=ply \
 //thickness=0.18 //x=16.58 //y=1.545 //x2=16.695 //y2=1.545
r556 (  175 195 ) resistor r=5.52526 //w=0.168 //l=0.115 //layer=ply \
 //thickness=0.18 //x=16.36 //y=0.89 //x2=16.245 //y2=0.89
r557 (  174 200 ) resistor r=5.52526 //w=0.168 //l=0.115 //layer=ply \
 //thickness=0.18 //x=16.58 //y=0.89 //x2=16.695 //y2=0.89
r558 (  174 175 ) resistor r=112.809 //w=0.094 //l=0.22 //layer=ply \
 //thickness=0.18 //x=16.58 //y=0.89 //x2=16.36 //y2=0.89
r559 (  171 197 ) resistor r=13.0941 //w=0.233 //l=0.165 //layer=ply \
 //thickness=0.18 //x=16.3 //y=5.045 //x2=16.3 //y2=4.88
r560 (  170 194 ) resistor r=34.8111 //w=0.27 //l=0.264953 //layer=ply \
 //thickness=0.18 //x=16.205 //y=2.095 //x2=16.4 //y2=2.26
r561 (  169 196 ) resistor r=39.5823 //w=0.21 //l=0.173853 //layer=ply \
 //thickness=0.18 //x=16.205 //y=1.7 //x2=16.245 //y2=1.545
r562 (  169 170 ) resistor r=202.543 //w=0.094 //l=0.395 //layer=ply \
 //thickness=0.18 //x=16.205 //y=1.7 //x2=16.205 //y2=2.095
r563 (  168 196 ) resistor r=39.5823 //w=0.21 //l=0.173853 //layer=ply \
 //thickness=0.18 //x=16.205 //y=1.39 //x2=16.245 //y2=1.545
r564 (  167 195 ) resistor r=45.1352 //w=0.168 //l=0.173853 //layer=ply \
 //thickness=0.18 //x=16.205 //y=1.045 //x2=16.245 //y2=0.89
r565 (  167 168 ) resistor r=176.904 //w=0.094 //l=0.345 //layer=ply \
 //thickness=0.18 //x=16.205 //y=1.045 //x2=16.205 //y2=1.39
r566 (  164 190 ) resistor r=70.3348 //w=0.233 //l=0.414367 //layer=ply \
 //thickness=0.18 //x=6.75 //y=5.045 //x2=6.41 //y2=4.88
r567 (  163 192 ) resistor r=45.1352 //w=0.168 //l=0.173853 //layer=ply \
 //thickness=0.18 //x=6.745 //y=1.39 //x2=6.705 //y2=1.545
r568 (  162 191 ) resistor r=45.1352 //w=0.168 //l=0.173853 //layer=ply \
 //thickness=0.18 //x=6.745 //y=1.045 //x2=6.705 //y2=0.89
r569 (  162 163 ) resistor r=176.904 //w=0.094 //l=0.345 //layer=ply \
 //thickness=0.18 //x=6.745 //y=1.045 //x2=6.745 //y2=1.39
r570 (  160 187 ) resistor r=10.701 //w=0.21 //l=0.115 //layer=ply \
 //thickness=0.18 //x=6.37 //y=1.545 //x2=6.255 //y2=1.545
r571 (  159 192 ) resistor r=5.52526 //w=0.168 //l=0.115 //layer=ply \
 //thickness=0.18 //x=6.59 //y=1.545 //x2=6.705 //y2=1.545
r572 (  158 186 ) resistor r=5.52526 //w=0.168 //l=0.115 //layer=ply \
 //thickness=0.18 //x=6.37 //y=0.89 //x2=6.255 //y2=0.89
r573 (  157 191 ) resistor r=5.52526 //w=0.168 //l=0.115 //layer=ply \
 //thickness=0.18 //x=6.59 //y=0.89 //x2=6.705 //y2=0.89
r574 (  157 158 ) resistor r=112.809 //w=0.094 //l=0.22 //layer=ply \
 //thickness=0.18 //x=6.59 //y=0.89 //x2=6.37 //y2=0.89
r575 (  154 188 ) resistor r=13.0941 //w=0.233 //l=0.165 //layer=ply \
 //thickness=0.18 //x=6.31 //y=5.045 //x2=6.31 //y2=4.88
r576 (  153 185 ) resistor r=34.8111 //w=0.27 //l=0.264953 //layer=ply \
 //thickness=0.18 //x=6.215 //y=2.095 //x2=6.41 //y2=2.26
r577 (  152 187 ) resistor r=39.5823 //w=0.21 //l=0.173853 //layer=ply \
 //thickness=0.18 //x=6.215 //y=1.7 //x2=6.255 //y2=1.545
r578 (  152 153 ) resistor r=202.543 //w=0.094 //l=0.395 //layer=ply \
 //thickness=0.18 //x=6.215 //y=1.7 //x2=6.215 //y2=2.095
r579 (  151 187 ) resistor r=39.5823 //w=0.21 //l=0.173853 //layer=ply \
 //thickness=0.18 //x=6.215 //y=1.39 //x2=6.255 //y2=1.545
r580 (  150 186 ) resistor r=45.1352 //w=0.168 //l=0.173853 //layer=ply \
 //thickness=0.18 //x=6.215 //y=1.045 //x2=6.255 //y2=0.89
r581 (  150 151 ) resistor r=176.904 //w=0.094 //l=0.345 //layer=ply \
 //thickness=0.18 //x=6.215 //y=1.045 //x2=6.215 //y2=1.39
r582 (  149 181 ) resistor r=592.245 //w=0.094 //l=1.155 //layer=ply \
 //thickness=0.18 //x=16.74 //y=6.2 //x2=16.74 //y2=5.045
r583 (  148 171 ) resistor r=592.245 //w=0.094 //l=1.155 //layer=ply \
 //thickness=0.18 //x=16.3 //y=6.2 //x2=16.3 //y2=5.045
r584 (  147 164 ) resistor r=592.245 //w=0.094 //l=1.155 //layer=ply \
 //thickness=0.18 //x=6.75 //y=6.2 //x2=6.75 //y2=5.045
r585 (  146 154 ) resistor r=592.245 //w=0.094 //l=1.155 //layer=ply \
 //thickness=0.18 //x=6.31 //y=6.2 //x2=6.31 //y2=5.045
r586 (  145 176 ) resistor r=56.4043 //w=0.094 //l=0.11 //layer=ply \
 //thickness=0.18 //x=16.47 //y=1.545 //x2=16.58 //y2=1.545
r587 (  145 177 ) resistor r=56.4043 //w=0.094 //l=0.11 //layer=ply \
 //thickness=0.18 //x=16.47 //y=1.545 //x2=16.36 //y2=1.545
r588 (  144 159 ) resistor r=56.4043 //w=0.094 //l=0.11 //layer=ply \
 //thickness=0.18 //x=6.48 //y=1.545 //x2=6.59 //y2=1.545
r589 (  144 160 ) resistor r=56.4043 //w=0.094 //l=0.11 //layer=ply \
 //thickness=0.18 //x=6.48 //y=1.545 //x2=6.37 //y2=1.545
r590 (  140 199 ) resistor r=152 //w=0.17 //l=0.17 //layer=licon //count=1 \
 //x=16.4 //y=4.88 //x2=16.4 //y2=4.88
r591 (  131 194 ) resistor r=152 //w=0.17 //l=0.17 //layer=licon //count=1 \
 //x=16.4 //y=2.26 //x2=16.4 //y2=2.26
r592 (  126 190 ) resistor r=152 //w=0.17 //l=0.17 //layer=licon //count=1 \
 //x=6.41 //y=4.88 //x2=6.41 //y2=4.88
r593 (  117 185 ) resistor r=152 //w=0.17 //l=0.17 //layer=licon //count=1 \
 //x=6.41 //y=2.26 //x2=6.41 //y2=2.26
r594 (  100 206 ) resistor r=23.615 //w=0.187 //l=0.345 //layer=li \
 //thickness=0.1 //x=3.78 //y=5.56 //x2=3.78 //y2=5.905
r595 (  92 205 ) resistor r=23.615 //w=0.187 //l=0.345 //layer=li \
 //thickness=0.1 //x=2.9 //y=5.56 //x2=2.9 //y2=5.905
r596 (  84 204 ) resistor r=23.615 //w=0.187 //l=0.345 //layer=li \
 //thickness=0.1 //x=2.02 //y=5.56 //x2=2.02 //y2=5.905
r597 (  74 82 ) resistor r=2.10915 //w=0.185 //l=3.125 //layer=m2 \
 //thickness=0.36 //x=13.28 //y=3.895 //x2=16.4 //y2=3.885
r598 (  74 75 ) resistor r=0.329198 //w=0.131 //l=0.345 //layer=m2 \
 //thickness=0.36 //x=13.28 //y=3.895 //x2=12.935 //y2=3.895
r599 (  72 75 ) resistor r=0.1875 //w=0.17 //l=0.262393 //layer=m2 \
 //thickness=0.36 //x=12.68 //y=3.88 //x2=12.935 //y2=3.895
r600 (  72 73 ) resistor r=1.02099 //w=0.131 //l=1.07 //layer=m2 \
 //thickness=0.36 //x=12.68 //y=3.88 //x2=11.61 //y2=3.88
r601 (  70 73 ) resistor r=0.125 //w=0.17 //l=0.177341 //layer=m2 \
 //thickness=0.36 //x=11.44 //y=3.895 //x2=11.61 //y2=3.88
r602 (  70 71 ) resistor r=0.329198 //w=0.131 //l=0.345 //layer=m2 \
 //thickness=0.36 //x=11.44 //y=3.895 //x2=11.095 //y2=3.895
r603 (  68 71 ) resistor r=0.290441 //w=0.17 //l=0.407308 //layer=m2 \
 //thickness=0.36 //x=10.7 //y=3.87 //x2=11.095 //y2=3.895
r604 (  68 69 ) resistor r=0.410305 //w=0.131 //l=0.43 //layer=m2 \
 //thickness=0.36 //x=10.7 //y=3.87 //x2=10.27 //y2=3.87
r605 (  66 69 ) resistor r=0.235294 //w=0.17 //l=0.329848 //layer=m2 \
 //thickness=0.36 //x=9.95 //y=3.89 //x2=10.27 //y2=3.87
r606 (  66 67 ) resistor r=0.329198 //w=0.131 //l=0.345 //layer=m2 \
 //thickness=0.36 //x=9.95 //y=3.89 //x2=9.605 //y2=3.89
r607 (  64 67 ) resistor r=0.1875 //w=0.17 //l=0.259952 //layer=m2 \
 //thickness=0.36 //x=9.35 //y=3.88 //x2=9.605 //y2=3.89
r608 (  64 65 ) resistor r=1.03053 //w=0.131 //l=1.08 //layer=m2 \
 //thickness=0.36 //x=9.35 //y=3.88 //x2=8.27 //y2=3.88
r609 (  63 80 ) resistor r=0.838898 //w=0.202 //l=1.35748 //layer=m2 \
 //thickness=0.36 //x=7.755 //y=3.895 //x2=6.405 //y2=3.88
r610 (  62 65 ) resistor r=0.125 //w=0.17 //l=0.177341 //layer=m2 \
 //thickness=0.36 //x=8.1 //y=3.895 //x2=8.27 //y2=3.88
r611 (  62 63 ) resistor r=0.329198 //w=0.131 //l=0.345 //layer=m2 \
 //thickness=0.36 //x=8.1 //y=3.895 //x2=7.755 //y2=3.895
r612 (  61 77 ) resistor r=0.10734 //w=0.281 //l=0.16 //layer=m2 \
 //thickness=0.36 //x=4.72 //y=3.88 //x2=4.56 //y2=3.88
r613 (  60 80 ) resistor r=0.102512 //w=0.202 //l=0.16 //layer=m2 \
 //thickness=0.36 //x=6.245 //y=3.88 //x2=6.405 //y2=3.88
r614 (  60 61 ) resistor r=1.45515 //w=0.131 //l=1.525 //layer=m2 \
 //thickness=0.36 //x=6.245 //y=3.88 //x2=4.72 //y2=3.88
r615 (  57 140 ) resistor r=9.3 //w=0.17 //l=0.17 //layer=mcon //count=1 \
 //x=16.4 //y=4.88 //x2=16.4 //y2=4.88
r616 (  57 58 ) resistor r=0.103207 //w=0.196 //l=0.14 //layer=m1 \
 //thickness=0.36 //x=16.402 //y=4.88 //x2=16.402 //y2=4.74
r617 (  54 131 ) resistor r=9.3 //w=0.17 //l=0.17 //layer=mcon //count=1 \
 //x=16.4 //y=2.26 //x2=16.4 //y2=2.26
r618 (  52 82 ) resistor r=4.5 //w=0.15 //l=0.15 //layer=via1 //count=1 \
 //x=16.4 //y=3.885 //x2=16.4 //y2=3.885
r619 (  50 52 ) resistor r=0.00166223 //w=0.376 //l=0.005 //layer=m1 \
 //thickness=0.36 //x=16.347 //y=3.88 //x2=16.347 //y2=3.885
r620 (  46 126 ) resistor r=9.3 //w=0.17 //l=0.17 //layer=mcon //count=1 \
 //x=6.41 //y=4.88 //x2=6.41 //y2=4.88
r621 (  46 47 ) resistor r=0.103207 //w=0.196 //l=0.14 //layer=m1 \
 //thickness=0.36 //x=6.412 //y=4.88 //x2=6.412 //y2=4.74
r622 (  43 117 ) resistor r=9.3 //w=0.17 //l=0.17 //layer=mcon //count=1 \
 //x=6.41 //y=2.26 //x2=6.41 //y2=2.26
r623 (  40 80 ) resistor r=4.5 //w=0.15 //l=0.15 //layer=via1 //count=1 \
 //x=6.405 //y=3.88 //x2=6.405 //y2=3.88
r624 (  37 77 ) resistor r=4.5 //w=0.15 //l=0.15 //layer=via1 //count=1 \
 //x=4.56 //y=3.88 //x2=4.56 //y2=3.88
r625 (  35 202 ) resistor r=9.3 //w=0.17 //l=0.17 //layer=mcon //count=1 \
 //x=4.075 //y=1.19 //x2=4.075 //y2=1.19
r626 (  33 100 ) resistor r=9.3 //w=0.17 //l=0.17 //layer=mcon //count=1 \
 //x=3.78 //y=5.56 //x2=3.78 //y2=5.56
r627 (  30 92 ) resistor r=9.3 //w=0.17 //l=0.17 //layer=mcon //count=1 \
 //x=2.9 //y=5.56 //x2=2.9 //y2=5.56
r628 (  28 30 ) resistor r=0.121228 //w=0.232 //l=0.225 //layer=m1 \
 //thickness=0.36 //x=2.9 //y=5.335 //x2=2.9 //y2=5.56
r629 (  27 84 ) resistor r=9.3 //w=0.17 //l=0.17 //layer=mcon //count=1 \
 //x=2.02 //y=5.56 //x2=2.02 //y2=5.56
r630 (  25 27 ) resistor r=0.129608 //w=0.217 //l=0.225 //layer=m1 \
 //thickness=0.36 //x=2.022 //y=5.335 //x2=2.022 //y2=5.56
r631 (  23 52 ) resistor r=0.0911593 //w=0.376 //l=0.184608 //layer=m1 \
 //thickness=0.36 //x=16.4 //y=4.045 //x2=16.347 //y2=3.885
r632 (  23 58 ) resistor r=0.663168 //w=0.131 //l=0.695 //layer=m1 \
 //thickness=0.36 //x=16.4 //y=4.045 //x2=16.4 //y2=4.74
r633 (  22 50 ) resistor r=0.0894971 //w=0.376 //l=0.179555 //layer=m1 \
 //thickness=0.36 //x=16.4 //y=3.725 //x2=16.347 //y2=3.88
r634 (  21 54 ) resistor r=0.0933015 //w=0.201 //l=0.125 //layer=m1 \
 //thickness=0.36 //x=16.4 //y=2.385 //x2=16.4 //y2=2.26
r635 (  21 22 ) resistor r=1.27863 //w=0.131 //l=1.34 //layer=m1 \
 //thickness=0.36 //x=16.4 //y=2.385 //x2=16.4 //y2=3.725
r636 (  19 40 ) resistor r=0.0910802 //w=0.374 //l=0.185472 //layer=m1 \
 //thickness=0.36 //x=6.41 //y=4.04 //x2=6.355 //y2=3.88
r637 (  19 47 ) resistor r=0.667939 //w=0.131 //l=0.7 //layer=m1 \
 //thickness=0.36 //x=6.41 //y=4.04 //x2=6.41 //y2=4.74
r638 (  18 40 ) resistor r=0.0910802 //w=0.374 //l=0.185472 //layer=m1 \
 //thickness=0.36 //x=6.41 //y=3.72 //x2=6.355 //y2=3.88
r639 (  17 43 ) resistor r=0.0933015 //w=0.201 //l=0.125 //layer=m1 \
 //thickness=0.36 //x=6.41 //y=2.385 //x2=6.41 //y2=2.26
r640 (  17 18 ) resistor r=1.27385 //w=0.131 //l=1.335 //layer=m1 \
 //thickness=0.36 //x=6.41 //y=2.385 //x2=6.41 //y2=3.72
r641 (  15 37 ) resistor r=0.0911593 //w=0.376 //l=0.184174 //layer=m1 \
 //thickness=0.36 //x=4.56 //y=4.04 //x2=4.612 //y2=3.88
r642 (  15 16 ) resistor r=1.15458 //w=0.131 //l=1.21 //layer=m1 \
 //thickness=0.36 //x=4.56 //y=4.04 //x2=4.56 //y2=5.25
r643 (  14 37 ) resistor r=0.0911593 //w=0.376 //l=0.184174 //layer=m1 \
 //thickness=0.36 //x=4.56 //y=3.72 //x2=4.612 //y2=3.88
r644 (  13 14 ) resistor r=1.70802 //w=0.131 //l=1.79 //layer=m1 \
 //thickness=0.36 //x=4.56 //y=1.93 //x2=4.56 //y2=3.72
r645 (  11 13 ) resistor r=0.0698411 //w=0.17 //l=0.120208 //layer=m1 \
 //thickness=0.36 //x=4.475 //y=1.845 //x2=4.56 //y2=1.93
r646 (  11 12 ) resistor r=0.300573 //w=0.131 //l=0.315 //layer=m1 \
 //thickness=0.36 //x=4.475 //y=1.845 //x2=4.16 //y2=1.845
r647 (  10 12 ) resistor r=0.0698411 //w=0.17 //l=0.120208 //layer=m1 \
 //thickness=0.36 //x=4.075 //y=1.76 //x2=4.16 //y2=1.845
r648 (  9 35 ) resistor r=0.0717383 //w=0.224 //l=0.115 //layer=m1 \
 //thickness=0.36 //x=4.075 //y=1.305 //x2=4.075 //y2=1.19
r649 (  9 10 ) resistor r=0.43416 //w=0.131 //l=0.455 //layer=m1 \
 //thickness=0.36 //x=4.075 //y=1.305 //x2=4.075 //y2=1.76
r650 (  8 31 ) resistor r=0.0675342 //w=0.23 //l=0.115 //layer=m1 \
 //thickness=0.36 //x=3.895 //y=5.335 //x2=3.78 //y2=5.335
r651 (  7 16 ) resistor r=0.0698411 //w=0.17 //l=0.120208 //layer=m1 \
 //thickness=0.36 //x=4.475 //y=5.335 //x2=4.56 //y2=5.25
r652 (  7 8 ) resistor r=0.553435 //w=0.131 //l=0.58 //layer=m1 \
 //thickness=0.36 //x=4.475 //y=5.335 //x2=3.895 //y2=5.335
r653 (  6 33 ) resistor r=0.00118313 //w=0.23 //layer=m1 //thickness=0.36 \
 //x=3.78 //y=5.56 //x2=3.78 //y2=5.56
r654 (  5 31 ) resistor r=0.002872 //w=0.34 //l=0.085 //layer=m1 \
 //thickness=0.36 //x=3.78 //y=5.42 //x2=3.78 //y2=5.335
r655 (  5 6 ) resistor r=0.091623 //w=0.191 //l=0.14 //layer=m1 \
 //thickness=0.36 //x=3.78 //y=5.42 //x2=3.78 //y2=5.56
r656 (  4 28 ) resistor r=0.0262263 //w=0.232 //l=0.12 //layer=m1 \
 //thickness=0.36 //x=3.02 //y=5.335 //x2=2.9 //y2=5.335
r657 (  3 31 ) resistor r=0.0675342 //w=0.23 //l=0.115 //layer=m1 \
 //thickness=0.36 //x=3.665 //y=5.335 //x2=3.78 //y2=5.335
r658 (  3 4 ) resistor r=0.615458 //w=0.131 //l=0.645 //layer=m1 \
 //thickness=0.36 //x=3.665 //y=5.335 //x2=3.02 //y2=5.335
r659 (  2 25 ) resistor r=0.0222262 //w=0.217 //l=0.118 //layer=m1 \
 //thickness=0.36 //x=2.14 //y=5.335 //x2=2.022 //y2=5.335
r660 (  1 28 ) resistor r=0.0262263 //w=0.232 //l=0.12 //layer=m1 \
 //thickness=0.36 //x=2.78 //y=5.335 //x2=2.9 //y2=5.335
r661 (  1 2 ) resistor r=0.610687 //w=0.131 //l=0.64 //layer=m1 \
 //thickness=0.36 //x=2.78 //y=5.335 //x2=2.14 //y2=5.335
ends PM_TMRDFFQNX1\%noxref_3

subckt PM_TMRDFFQNX1\%noxref_4 ( 3 8 9 11 12 14 15 16 18 19 23 24 27 29 34 38 \
 40 43 44 51 53 54 57 65 82 91 95 96 97 98 99 100 101 105 107 110 111 121 124 \
 126 127 )
c283 ( 124 0 ) capacitor c=0.00878249f //x=17.25 //y=1.085
c284 ( 121 0 ) capacitor c=0.0646505f //x=19.73 //y=4.88
c285 ( 111 0 ) capacitor c=0.0318956f //x=20.065 //y=1.39
c286 ( 110 0 ) capacitor c=0.0186809f //x=20.065 //y=1.045
c287 ( 107 0 ) capacitor c=0.0141821f //x=19.91 //y=1.545
c288 ( 105 0 ) capacitor c=0.0158553f //x=19.91 //y=0.89
c289 ( 101 0 ) capacitor c=0.088055f //x=19.535 //y=2.095
c290 ( 100 0 ) capacitor c=0.0229235f //x=19.535 //y=1.7
c291 ( 99 0 ) capacitor c=0.0234359f //x=19.535 //y=1.39
c292 ( 98 0 ) capacitor c=0.0198759f //x=19.535 //y=1.045
c293 ( 97 0 ) capacitor c=0.110369f //x=20.07 //y=6.2
c294 ( 96 0 ) capacitor c=0.154619f //x=19.63 //y=6.2
c295 ( 91 0 ) capacitor c=8.13425e-19 //x=19.73 //y=4.88
c296 ( 82 0 ) capacitor c=7.85889e-19 //x=19.73 //y=2.26
c297 ( 65 0 ) capacitor c=0.0322017f //x=17.4 //y=5.56
c298 ( 57 0 ) capacitor c=0.0290186f //x=16.52 //y=5.56
c299 ( 54 0 ) capacitor c=0.0234059f //x=19.56 //y=3.865
c300 ( 53 0 ) capacitor c=9.01343e-19 //x=19.72 //y=3.865
c301 ( 51 0 ) capacitor c=7.86339e-19 //x=18.035 //y=3.86
c302 ( 44 0 ) capacitor c=0.0158653f //x=19.732 //y=4.74
c303 ( 43 0 ) capacitor c=0.00598864f //x=19.73 //y=4.88
c304 ( 40 0 ) capacitor c=0.00654113f //x=19.73 //y=2.26
c305 ( 38 0 ) capacitor c=0.0165935f //x=19.73 //y=3.88
c306 ( 34 0 ) capacitor c=0.0169294f //x=17.88 //y=3.88
c307 ( 29 0 ) capacitor c=0.0111921f //x=17.44 //y=1.18
c308 ( 27 0 ) capacitor c=5.78613e-19 //x=17.4 //y=5.56
c309 ( 24 0 ) capacitor c=0.0114023f //x=17.4 //y=5.38
c310 ( 23 0 ) capacitor c=0.00917153f //x=16.52 //y=5.56
c311 ( 19 0 ) capacitor c=0.0123523f //x=19.73 //y=4.025
c312 ( 18 0 ) capacitor c=0.0377485f //x=19.73 //y=3.705
c313 ( 16 0 ) capacitor c=0.0305025f //x=17.88 //y=5.295
c314 ( 15 0 ) capacitor c=0.0137264f //x=17.88 //y=4.02
c315 ( 14 0 ) capacitor c=0.0483954f //x=17.88 //y=3.7
c316 ( 12 0 ) capacitor c=0.00515315f //x=17.525 //y=1.835
c317 ( 11 0 ) capacitor c=0.0130656f //x=17.795 //y=1.835
c318 ( 9 0 ) capacitor c=0.0111099f //x=17.795 //y=5.38
c319 ( 8 0 ) capacitor c=0.0101547f //x=17.44 //y=1.75
c320 ( 3 0 ) capacitor c=0.014556f //x=17.285 //y=5.38
r321 (  119 121 ) resistor r=20.6867 //w=0.233 //l=0.1 //layer=ply \
 //thickness=0.18 //x=19.63 //y=4.88 //x2=19.73 //y2=4.88
r322 (  112 121 ) resistor r=70.3348 //w=0.233 //l=0.414367 //layer=ply \
 //thickness=0.18 //x=20.07 //y=5.045 //x2=19.73 //y2=4.88
r323 (  111 123 ) resistor r=45.1352 //w=0.168 //l=0.173853 //layer=ply \
 //thickness=0.18 //x=20.065 //y=1.39 //x2=20.025 //y2=1.545
r324 (  110 122 ) resistor r=45.1352 //w=0.168 //l=0.173853 //layer=ply \
 //thickness=0.18 //x=20.065 //y=1.045 //x2=20.025 //y2=0.89
r325 (  110 111 ) resistor r=176.904 //w=0.094 //l=0.345 //layer=ply \
 //thickness=0.18 //x=20.065 //y=1.045 //x2=20.065 //y2=1.39
r326 (  108 118 ) resistor r=10.701 //w=0.21 //l=0.115 //layer=ply \
 //thickness=0.18 //x=19.69 //y=1.545 //x2=19.575 //y2=1.545
r327 (  107 123 ) resistor r=5.52526 //w=0.168 //l=0.115 //layer=ply \
 //thickness=0.18 //x=19.91 //y=1.545 //x2=20.025 //y2=1.545
r328 (  106 117 ) resistor r=5.52526 //w=0.168 //l=0.115 //layer=ply \
 //thickness=0.18 //x=19.69 //y=0.89 //x2=19.575 //y2=0.89
r329 (  105 122 ) resistor r=5.52526 //w=0.168 //l=0.115 //layer=ply \
 //thickness=0.18 //x=19.91 //y=0.89 //x2=20.025 //y2=0.89
r330 (  105 106 ) resistor r=112.809 //w=0.094 //l=0.22 //layer=ply \
 //thickness=0.18 //x=19.91 //y=0.89 //x2=19.69 //y2=0.89
r331 (  102 119 ) resistor r=13.0941 //w=0.233 //l=0.165 //layer=ply \
 //thickness=0.18 //x=19.63 //y=5.045 //x2=19.63 //y2=4.88
r332 (  101 116 ) resistor r=34.8111 //w=0.27 //l=0.264953 //layer=ply \
 //thickness=0.18 //x=19.535 //y=2.095 //x2=19.73 //y2=2.26
r333 (  100 118 ) resistor r=39.5823 //w=0.21 //l=0.173853 //layer=ply \
 //thickness=0.18 //x=19.535 //y=1.7 //x2=19.575 //y2=1.545
r334 (  100 101 ) resistor r=202.543 //w=0.094 //l=0.395 //layer=ply \
 //thickness=0.18 //x=19.535 //y=1.7 //x2=19.535 //y2=2.095
r335 (  99 118 ) resistor r=39.5823 //w=0.21 //l=0.173853 //layer=ply \
 //thickness=0.18 //x=19.535 //y=1.39 //x2=19.575 //y2=1.545
r336 (  98 117 ) resistor r=45.1352 //w=0.168 //l=0.173853 //layer=ply \
 //thickness=0.18 //x=19.535 //y=1.045 //x2=19.575 //y2=0.89
r337 (  98 99 ) resistor r=176.904 //w=0.094 //l=0.345 //layer=ply \
 //thickness=0.18 //x=19.535 //y=1.045 //x2=19.535 //y2=1.39
r338 (  97 112 ) resistor r=592.245 //w=0.094 //l=1.155 //layer=ply \
 //thickness=0.18 //x=20.07 //y=6.2 //x2=20.07 //y2=5.045
r339 (  96 102 ) resistor r=592.245 //w=0.094 //l=1.155 //layer=ply \
 //thickness=0.18 //x=19.63 //y=6.2 //x2=19.63 //y2=5.045
r340 (  95 107 ) resistor r=56.4043 //w=0.094 //l=0.11 //layer=ply \
 //thickness=0.18 //x=19.8 //y=1.545 //x2=19.91 //y2=1.545
r341 (  95 108 ) resistor r=56.4043 //w=0.094 //l=0.11 //layer=ply \
 //thickness=0.18 //x=19.8 //y=1.545 //x2=19.69 //y2=1.545
r342 (  91 121 ) resistor r=152 //w=0.17 //l=0.17 //layer=licon //count=1 \
 //x=19.73 //y=4.88 //x2=19.73 //y2=4.88
r343 (  82 116 ) resistor r=152 //w=0.17 //l=0.17 //layer=licon //count=1 \
 //x=19.73 //y=2.26 //x2=19.73 //y2=2.26
r344 (  65 127 ) resistor r=23.615 //w=0.187 //l=0.345 //layer=li \
 //thickness=0.1 //x=17.4 //y=5.56 //x2=17.4 //y2=5.905
r345 (  57 126 ) resistor r=23.615 //w=0.187 //l=0.345 //layer=li \
 //thickness=0.1 //x=16.52 //y=5.56 //x2=16.52 //y2=5.905
r346 (  53 54 ) resistor r=0.10734 //w=0.281 //l=0.16 //layer=m2 \
 //thickness=0.36 //x=19.72 //y=3.865 //x2=19.56 //y2=3.865
r347 (  51 54 ) resistor r=1.45515 //w=0.131 //l=1.525 //layer=m2 \
 //thickness=0.36 //x=18.035 //y=3.88 //x2=19.56 //y2=3.88
r348 (  49 51 ) resistor r=0.10734 //w=0.281 //l=0.16 //layer=m2 \
 //thickness=0.36 //x=17.875 //y=3.86 //x2=18.035 //y2=3.86
r349 (  43 91 ) resistor r=9.3 //w=0.17 //l=0.17 //layer=mcon //count=1 \
 //x=19.73 //y=4.88 //x2=19.73 //y2=4.88
r350 (  43 44 ) resistor r=0.103207 //w=0.196 //l=0.14 //layer=m1 \
 //thickness=0.36 //x=19.732 //y=4.88 //x2=19.732 //y2=4.74
r351 (  40 82 ) resistor r=9.3 //w=0.17 //l=0.17 //layer=mcon //count=1 \
 //x=19.73 //y=2.26 //x2=19.73 //y2=2.26
r352 (  36 53 ) resistor r=4.5 //w=0.15 //l=0.15 //layer=via1 //count=1 \
 //x=19.72 //y=3.865 //x2=19.72 //y2=3.865
r353 (  36 38 ) resistor r=0.00505391 //w=0.371 //l=0.015 //layer=m1 \
 //thickness=0.36 //x=19.672 //y=3.865 //x2=19.672 //y2=3.88
r354 (  32 49 ) resistor r=4.5 //w=0.15 //l=0.15 //layer=via1 //count=1 \
 //x=17.875 //y=3.86 //x2=17.875 //y2=3.86
r355 (  32 34 ) resistor r=0.00659631 //w=0.379 //l=0.02 //layer=m1 \
 //thickness=0.36 //x=17.93 //y=3.86 //x2=17.93 //y2=3.88
r356 (  29 124 ) resistor r=9.3 //w=0.17 //l=0.17 //layer=mcon //count=1 \
 //x=17.44 //y=1.18 //x2=17.44 //y2=1.18
r357 (  27 65 ) resistor r=9.3 //w=0.17 //l=0.17 //layer=mcon //count=1 \
 //x=17.4 //y=5.56 //x2=17.4 //y2=5.56
r358 (  24 27 ) resistor r=0.117801 //w=0.191 //l=0.18 //layer=m1 \
 //thickness=0.36 //x=17.4 //y=5.38 //x2=17.4 //y2=5.56
r359 (  23 57 ) resistor r=9.3 //w=0.17 //l=0.17 //layer=mcon //count=1 \
 //x=16.52 //y=5.56 //x2=16.52 //y2=5.56
r360 (  21 23 ) resistor r=0.10274 //w=0.219 //l=0.18 //layer=m1 \
 //thickness=0.36 //x=16.52 //y=5.38 //x2=16.52 //y2=5.56
r361 (  19 38 ) resistor r=0.0859108 //w=0.371 //l=0.171566 //layer=m1 \
 //thickness=0.36 //x=19.73 //y=4.025 //x2=19.672 //y2=3.88
r362 (  19 44 ) resistor r=0.682252 //w=0.131 //l=0.715 //layer=m1 \
 //thickness=0.36 //x=19.73 //y=4.025 //x2=19.73 //y2=4.74
r363 (  18 36 ) resistor r=0.0909648 //w=0.371 //l=0.186762 //layer=m1 \
 //thickness=0.36 //x=19.73 //y=3.705 //x2=19.672 //y2=3.865
r364 (  17 40 ) resistor r=0.0933015 //w=0.201 //l=0.125 //layer=m1 \
 //thickness=0.36 //x=19.73 //y=2.385 //x2=19.73 //y2=2.26
r365 (  17 18 ) resistor r=1.25954 //w=0.131 //l=1.32 //layer=m1 \
 //thickness=0.36 //x=19.73 //y=2.385 //x2=19.73 //y2=3.705
r366 (  15 34 ) resistor r=0.0846851 //w=0.379 //l=0.163095 //layer=m1 \
 //thickness=0.36 //x=17.88 //y=4.02 //x2=17.93 //y2=3.88
r367 (  15 16 ) resistor r=1.2166 //w=0.131 //l=1.275 //layer=m1 \
 //thickness=0.36 //x=17.88 //y=4.02 //x2=17.88 //y2=5.295
r368 (  14 32 ) resistor r=0.0912814 //w=0.379 //l=0.183303 //layer=m1 \
 //thickness=0.36 //x=17.88 //y=3.7 //x2=17.93 //y2=3.86
r369 (  13 14 ) resistor r=1.69847 //w=0.131 //l=1.78 //layer=m1 \
 //thickness=0.36 //x=17.88 //y=1.92 //x2=17.88 //y2=3.7
r370 (  11 13 ) resistor r=0.0698411 //w=0.17 //l=0.120208 //layer=m1 \
 //thickness=0.36 //x=17.795 //y=1.835 //x2=17.88 //y2=1.92
r371 (  11 12 ) resistor r=0.257634 //w=0.131 //l=0.27 //layer=m1 \
 //thickness=0.36 //x=17.795 //y=1.835 //x2=17.525 //y2=1.835
r372 (  10 24 ) resistor r=0.0257089 //w=0.23 //l=0.115 //layer=m1 \
 //thickness=0.36 //x=17.515 //y=5.38 //x2=17.4 //y2=5.38
r373 (  9 16 ) resistor r=0.0698411 //w=0.17 //l=0.120208 //layer=m1 \
 //thickness=0.36 //x=17.795 //y=5.38 //x2=17.88 //y2=5.295
r374 (  9 10 ) resistor r=0.267176 //w=0.131 //l=0.28 //layer=m1 \
 //thickness=0.36 //x=17.795 //y=5.38 //x2=17.515 //y2=5.38
r375 (  8 12 ) resistor r=0.0698411 //w=0.17 //l=0.120208 //layer=m1 \
 //thickness=0.36 //x=17.44 //y=1.75 //x2=17.525 //y2=1.835
r376 (  7 29 ) resistor r=0.0913624 //w=0.191 //l=0.12 //layer=m1 \
 //thickness=0.36 //x=17.44 //y=1.3 //x2=17.44 //y2=1.18
r377 (  7 8 ) resistor r=0.429389 //w=0.131 //l=0.45 //layer=m1 \
 //thickness=0.36 //x=17.44 //y=1.3 //x2=17.44 //y2=1.75
r378 (  4 21 ) resistor r=0.0227762 //w=0.219 //l=0.115 //layer=m1 \
 //thickness=0.36 //x=16.635 //y=5.38 //x2=16.52 //y2=5.38
r379 (  3 24 ) resistor r=0.0257089 //w=0.23 //l=0.115 //layer=m1 \
 //thickness=0.36 //x=17.285 //y=5.38 //x2=17.4 //y2=5.38
r380 (  3 4 ) resistor r=0.620229 //w=0.131 //l=0.65 //layer=m1 \
 //thickness=0.36 //x=17.285 //y=5.38 //x2=16.635 //y2=5.38
ends PM_TMRDFFQNX1\%noxref_4

subckt PM_TMRDFFQNX1\%noxref_5 ( 1 2 3 4 6 7 8 11 16 17 19 20 22 23 24 26 27 \
 28 34 38 42 49 50 53 55 58 62 65 70 72 74 76 78 79 80 81 85 93 102 107 116 \
 121 129 146 155 159 160 161 162 163 164 165 166 167 168 169 170 171 172 174 \
 180 181 182 183 187 188 189 194 196 198 204 205 206 207 208 213 215 217 223 \
 224 234 235 238 247 248 251 259 261 262 )
c613 ( 259 0 ) capacitor c=0.00878249f //x=13.92 //y=1.085
c614 ( 251 0 ) capacitor c=0.0356006f //x=20.5 //y=4.88
c615 ( 248 0 ) capacitor c=0.0284095f //x=20.47 //y=2.095
c616 ( 247 0 ) capacitor c=0.0476356f //x=20.47 //y=2.26
c617 ( 238 0 ) capacitor c=0.0354915f //x=10.51 //y=4.88
c618 ( 235 0 ) capacitor c=0.0284095f //x=10.48 //y=2.095
c619 ( 234 0 ) capacitor c=0.0476356f //x=10.48 //y=2.26
c620 ( 224 0 ) capacitor c=0.0439708f //x=21.035 //y=1.43
c621 ( 223 0 ) capacitor c=0.0192582f //x=21.035 //y=1.085
c622 ( 217 0 ) capacitor c=0.0162526f //x=20.88 //y=1.585
c623 ( 215 0 ) capacitor c=0.0157807f //x=20.88 //y=0.93
c624 ( 213 0 ) capacitor c=0.0372668f //x=20.875 //y=4.97
c625 ( 208 0 ) capacitor c=0.0210762f //x=20.505 //y=1.74
c626 ( 207 0 ) capacitor c=0.0168511f //x=20.505 //y=1.43
c627 ( 206 0 ) capacitor c=0.0175485f //x=20.505 //y=1.085
c628 ( 205 0 ) capacitor c=0.0439708f //x=11.045 //y=1.43
c629 ( 204 0 ) capacitor c=0.0192582f //x=11.045 //y=1.085
c630 ( 198 0 ) capacitor c=0.0162526f //x=10.89 //y=1.585
c631 ( 196 0 ) capacitor c=0.0157807f //x=10.89 //y=0.93
c632 ( 194 0 ) capacitor c=0.0372668f //x=10.885 //y=4.97
c633 ( 189 0 ) capacitor c=0.0210762f //x=10.515 //y=1.74
c634 ( 188 0 ) capacitor c=0.0168511f //x=10.515 //y=1.43
c635 ( 187 0 ) capacitor c=0.0175485f //x=10.515 //y=1.085
c636 ( 183 0 ) capacitor c=0.0551643f //x=1.875 //y=4.97
c637 ( 182 0 ) capacitor c=0.0376038f //x=2.165 //y=4.97
c638 ( 181 0 ) capacitor c=0.0346489f //x=1.83 //y=1.4
c639 ( 180 0 ) capacitor c=0.018692f //x=1.83 //y=1.055
c640 ( 174 0 ) capacitor c=0.0137077f //x=1.675 //y=1.555
c641 ( 172 0 ) capacitor c=0.0158585f //x=1.675 //y=0.9
c642 ( 171 0 ) capacitor c=0.103534f //x=1.3 //y=2.095
c643 ( 170 0 ) capacitor c=0.0229444f //x=1.3 //y=1.71
c644 ( 169 0 ) capacitor c=0.0234359f //x=1.3 //y=1.4
c645 ( 168 0 ) capacitor c=0.019815f //x=1.3 //y=1.055
c646 ( 167 0 ) capacitor c=0.155269f //x=20.95 //y=6.2
c647 ( 166 0 ) capacitor c=0.110375f //x=20.51 //y=6.2
c648 ( 165 0 ) capacitor c=0.155269f //x=10.96 //y=6.2
c649 ( 164 0 ) capacitor c=0.110375f //x=10.52 //y=6.2
c650 ( 163 0 ) capacitor c=0.110208f //x=2.24 //y=6.2
c651 ( 162 0 ) capacitor c=0.158957f //x=1.8 //y=6.2
c652 ( 155 0 ) capacitor c=5.80994e-19 //x=20.5 //y=4.88
c653 ( 146 0 ) capacitor c=5.78095e-19 //x=20.47 //y=2.26
c654 ( 129 0 ) capacitor c=0.0319332f //x=14.07 //y=5.56
c655 ( 121 0 ) capacitor c=0.0291719f //x=13.19 //y=5.56
c656 ( 116 0 ) capacitor c=5.80994e-19 //x=10.51 //y=4.88
c657 ( 107 0 ) capacitor c=5.78095e-19 //x=10.48 //y=2.26
c658 ( 102 0 ) capacitor c=0.0012433f //x=1.6 //y=4.88
c659 ( 93 0 ) capacitor c=0.0012618f //x=1.6 //y=2.26
c660 ( 85 0 ) capacitor c=0.0110688f //x=1.765 //y=4.255
c661 ( 81 0 ) capacitor c=0.0200835f //x=16.27 //y=4.27
c662 ( 80 0 ) capacitor c=0.040866f //x=16.615 //y=4.27
c663 ( 79 0 ) capacitor c=0.0344794f //x=10.645 //y=4.25
c664 ( 78 0 ) capacitor c=0.0338322f //x=14.38 //y=4.25
c665 ( 76 0 ) capacitor c=0.00147451f //x=6.62 //y=4.265
c666 ( 74 0 ) capacitor c=0.0153988f //x=6.02 //y=4.25
c667 ( 72 0 ) capacitor c=0.00416722f //x=4.775 //y=4.265
c668 ( 70 0 ) capacitor c=0.0677407f //x=4.175 //y=4.25
c669 ( 65 0 ) capacitor c=0.0066236f //x=20.47 //y=2.26
c670 ( 62 0 ) capacitor c=0.0150367f //x=20.47 //y=4.25
c671 ( 58 0 ) capacitor c=0.015184f //x=14.55 //y=4.25
c672 ( 55 0 ) capacitor c=0.0113735f //x=14.11 //y=1.18
c673 ( 53 0 ) capacitor c=5.78613e-19 //x=14.07 //y=5.56
c674 ( 50 0 ) capacitor c=0.00999937f //x=14.07 //y=5.38
c675 ( 49 0 ) capacitor c=0.00933207f //x=13.19 //y=5.56
c676 ( 42 0 ) capacitor c=0.00662515f //x=10.48 //y=2.26
c677 ( 38 0 ) capacitor c=0.0143744f //x=10.48 //y=4.25
c678 ( 34 0 ) capacitor c=0.0160407f //x=1.6 //y=4.25
c679 ( 28 0 ) capacitor c=0.00917813f //x=20.47 //y=4.735
c680 ( 27 0 ) capacitor c=0.00984584f //x=20.47 //y=4.41
c681 ( 26 0 ) capacitor c=0.0376116f //x=20.47 //y=4.09
c682 ( 24 0 ) capacitor c=0.019055f //x=14.55 //y=5.295
c683 ( 23 0 ) capacitor c=0.012741f //x=14.55 //y=4.425
c684 ( 22 0 ) capacitor c=0.0596558f //x=14.55 //y=4.105
c685 ( 20 0 ) capacitor c=0.00560492f //x=14.195 //y=1.835
c686 ( 19 0 ) capacitor c=0.0131084f //x=14.465 //y=1.835
c687 ( 17 0 ) capacitor c=0.0101176f //x=14.465 //y=5.38
c688 ( 16 0 ) capacitor c=0.0101547f //x=14.11 //y=1.75
c689 ( 11 0 ) capacitor c=0.0142466f //x=13.955 //y=5.38
c690 ( 8 0 ) capacitor c=0.00908133f //x=10.48 //y=4.735
c691 ( 7 0 ) capacitor c=0.00995231f //x=10.48 //y=4.415
c692 ( 6 0 ) capacitor c=0.0361105f //x=10.48 //y=4.095
c693 ( 4 0 ) capacitor c=0.0228118f //x=1.6 //y=4.755
c694 ( 3 0 ) capacitor c=0.0128906f //x=1.6 //y=4.415
c695 ( 2 0 ) capacitor c=0.0862595f //x=1.6 //y=4.095
c696 ( 1 0 ) capacitor c=0.0113406f //x=1.6 //y=2.375
r697 (  253 254 ) resistor r=32.4568 //w=0.214 //l=0.075 //layer=ply \
 //thickness=0.18 //x=20.5 //y=4.97 //x2=20.5 //y2=5.045
r698 (  251 253 ) resistor r=20.271 //w=0.214 //l=0.09 //layer=ply \
 //thickness=0.18 //x=20.5 //y=4.88 //x2=20.5 //y2=4.97
r699 (  247 248 ) resistor r=52.7279 //w=0.214 //l=0.165 //layer=ply \
 //thickness=0.18 //x=20.47 //y=2.26 //x2=20.47 //y2=2.095
r700 (  240 241 ) resistor r=32.4568 //w=0.214 //l=0.075 //layer=ply \
 //thickness=0.18 //x=10.51 //y=4.97 //x2=10.51 //y2=5.045
r701 (  238 240 ) resistor r=20.271 //w=0.214 //l=0.09 //layer=ply \
 //thickness=0.18 //x=10.51 //y=4.88 //x2=10.51 //y2=4.97
r702 (  234 235 ) resistor r=52.7279 //w=0.214 //l=0.165 //layer=ply \
 //thickness=0.18 //x=10.48 //y=2.26 //x2=10.48 //y2=2.095
r703 (  224 258 ) resistor r=45.1352 //w=0.168 //l=0.173853 //layer=ply \
 //thickness=0.18 //x=21.035 //y=1.43 //x2=20.995 //y2=1.585
r704 (  223 257 ) resistor r=45.1352 //w=0.168 //l=0.173853 //layer=ply \
 //thickness=0.18 //x=21.035 //y=1.085 //x2=20.995 //y2=0.93
r705 (  223 224 ) resistor r=176.904 //w=0.094 //l=0.345 //layer=ply \
 //thickness=0.18 //x=21.035 //y=1.085 //x2=21.035 //y2=1.43
r706 (  218 256 ) resistor r=10.701 //w=0.21 //l=0.115 //layer=ply \
 //thickness=0.18 //x=20.66 //y=1.585 //x2=20.545 //y2=1.585
r707 (  217 258 ) resistor r=5.52526 //w=0.168 //l=0.115 //layer=ply \
 //thickness=0.18 //x=20.88 //y=1.585 //x2=20.995 //y2=1.585
r708 (  216 255 ) resistor r=5.52526 //w=0.168 //l=0.115 //layer=ply \
 //thickness=0.18 //x=20.66 //y=0.93 //x2=20.545 //y2=0.93
r709 (  215 257 ) resistor r=5.52526 //w=0.168 //l=0.115 //layer=ply \
 //thickness=0.18 //x=20.88 //y=0.93 //x2=20.995 //y2=0.93
r710 (  215 216 ) resistor r=112.809 //w=0.094 //l=0.22 //layer=ply \
 //thickness=0.18 //x=20.88 //y=0.93 //x2=20.66 //y2=0.93
r711 (  214 253 ) resistor r=16.5046 //w=0.27 //l=0.135 //layer=ply \
 //thickness=0.18 //x=20.635 //y=4.97 //x2=20.5 //y2=4.97
r712 (  213 220 ) resistor r=26.9307 //w=0.15 //l=0.106066 //layer=ply \
 //thickness=0.18 //x=20.875 //y=4.97 //x2=20.95 //y2=5.045
r713 (  213 214 ) resistor r=123.064 //w=0.094 //l=0.24 //layer=ply \
 //thickness=0.18 //x=20.875 //y=4.97 //x2=20.635 //y2=4.97
r714 (  208 256 ) resistor r=39.5823 //w=0.21 //l=0.173853 //layer=ply \
 //thickness=0.18 //x=20.505 //y=1.74 //x2=20.545 //y2=1.585
r715 (  208 248 ) resistor r=182.032 //w=0.094 //l=0.355 //layer=ply \
 //thickness=0.18 //x=20.505 //y=1.74 //x2=20.505 //y2=2.095
r716 (  207 256 ) resistor r=39.5823 //w=0.21 //l=0.173853 //layer=ply \
 //thickness=0.18 //x=20.505 //y=1.43 //x2=20.545 //y2=1.585
r717 (  206 255 ) resistor r=45.1352 //w=0.168 //l=0.173853 //layer=ply \
 //thickness=0.18 //x=20.505 //y=1.085 //x2=20.545 //y2=0.93
r718 (  206 207 ) resistor r=176.904 //w=0.094 //l=0.345 //layer=ply \
 //thickness=0.18 //x=20.505 //y=1.085 //x2=20.505 //y2=1.43
r719 (  205 245 ) resistor r=45.1352 //w=0.168 //l=0.173853 //layer=ply \
 //thickness=0.18 //x=11.045 //y=1.43 //x2=11.005 //y2=1.585
r720 (  204 244 ) resistor r=45.1352 //w=0.168 //l=0.173853 //layer=ply \
 //thickness=0.18 //x=11.045 //y=1.085 //x2=11.005 //y2=0.93
r721 (  204 205 ) resistor r=176.904 //w=0.094 //l=0.345 //layer=ply \
 //thickness=0.18 //x=11.045 //y=1.085 //x2=11.045 //y2=1.43
r722 (  199 243 ) resistor r=10.701 //w=0.21 //l=0.115 //layer=ply \
 //thickness=0.18 //x=10.67 //y=1.585 //x2=10.555 //y2=1.585
r723 (  198 245 ) resistor r=5.52526 //w=0.168 //l=0.115 //layer=ply \
 //thickness=0.18 //x=10.89 //y=1.585 //x2=11.005 //y2=1.585
r724 (  197 242 ) resistor r=5.52526 //w=0.168 //l=0.115 //layer=ply \
 //thickness=0.18 //x=10.67 //y=0.93 //x2=10.555 //y2=0.93
r725 (  196 244 ) resistor r=5.52526 //w=0.168 //l=0.115 //layer=ply \
 //thickness=0.18 //x=10.89 //y=0.93 //x2=11.005 //y2=0.93
r726 (  196 197 ) resistor r=112.809 //w=0.094 //l=0.22 //layer=ply \
 //thickness=0.18 //x=10.89 //y=0.93 //x2=10.67 //y2=0.93
r727 (  195 240 ) resistor r=16.5046 //w=0.27 //l=0.135 //layer=ply \
 //thickness=0.18 //x=10.645 //y=4.97 //x2=10.51 //y2=4.97
r728 (  194 201 ) resistor r=26.9307 //w=0.15 //l=0.106066 //layer=ply \
 //thickness=0.18 //x=10.885 //y=4.97 //x2=10.96 //y2=5.045
r729 (  194 195 ) resistor r=123.064 //w=0.094 //l=0.24 //layer=ply \
 //thickness=0.18 //x=10.885 //y=4.97 //x2=10.645 //y2=4.97
r730 (  189 243 ) resistor r=39.5823 //w=0.21 //l=0.173853 //layer=ply \
 //thickness=0.18 //x=10.515 //y=1.74 //x2=10.555 //y2=1.585
r731 (  189 235 ) resistor r=182.032 //w=0.094 //l=0.355 //layer=ply \
 //thickness=0.18 //x=10.515 //y=1.74 //x2=10.515 //y2=2.095
r732 (  188 243 ) resistor r=39.5823 //w=0.21 //l=0.173853 //layer=ply \
 //thickness=0.18 //x=10.515 //y=1.43 //x2=10.555 //y2=1.585
r733 (  187 242 ) resistor r=45.1352 //w=0.168 //l=0.173853 //layer=ply \
 //thickness=0.18 //x=10.515 //y=1.085 //x2=10.555 //y2=0.93
r734 (  187 188 ) resistor r=176.904 //w=0.094 //l=0.345 //layer=ply \
 //thickness=0.18 //x=10.515 //y=1.085 //x2=10.515 //y2=1.43
r735 (  182 184 ) resistor r=26.9307 //w=0.15 //l=0.106066 //layer=ply \
 //thickness=0.18 //x=2.165 //y=4.97 //x2=2.24 //y2=5.045
r736 (  182 183 ) resistor r=148.702 //w=0.094 //l=0.29 //layer=ply \
 //thickness=0.18 //x=2.165 //y=4.97 //x2=1.875 //y2=4.97
r737 (  181 232 ) resistor r=45.1352 //w=0.168 //l=0.173853 //layer=ply \
 //thickness=0.18 //x=1.83 //y=1.4 //x2=1.79 //y2=1.555
r738 (  180 231 ) resistor r=45.1352 //w=0.168 //l=0.173853 //layer=ply \
 //thickness=0.18 //x=1.83 //y=1.055 //x2=1.79 //y2=0.9
r739 (  180 181 ) resistor r=176.904 //w=0.094 //l=0.345 //layer=ply \
 //thickness=0.18 //x=1.83 //y=1.055 //x2=1.83 //y2=1.4
r740 (  177 183 ) resistor r=22.7971 //w=0.269 //l=0.106066 //layer=ply \
 //thickness=0.18 //x=1.8 //y=5.045 //x2=1.875 //y2=4.97
r741 (  177 230 ) resistor r=35.8364 //w=0.269 //l=0.270185 //layer=ply \
 //thickness=0.18 //x=1.8 //y=5.045 //x2=1.6 //y2=4.88
r742 (  175 226 ) resistor r=10.701 //w=0.21 //l=0.115 //layer=ply \
 //thickness=0.18 //x=1.455 //y=1.555 //x2=1.34 //y2=1.555
r743 (  174 232 ) resistor r=5.52526 //w=0.168 //l=0.115 //layer=ply \
 //thickness=0.18 //x=1.675 //y=1.555 //x2=1.79 //y2=1.555
r744 (  173 225 ) resistor r=5.52526 //w=0.168 //l=0.115 //layer=ply \
 //thickness=0.18 //x=1.455 //y=0.9 //x2=1.34 //y2=0.9
r745 (  172 231 ) resistor r=5.52526 //w=0.168 //l=0.115 //layer=ply \
 //thickness=0.18 //x=1.675 //y=0.9 //x2=1.79 //y2=0.9
r746 (  172 173 ) resistor r=112.809 //w=0.094 //l=0.22 //layer=ply \
 //thickness=0.18 //x=1.675 //y=0.9 //x2=1.455 //y2=0.9
r747 (  171 228 ) resistor r=58.7805 //w=0.246 //l=0.373497 //layer=ply \
 //thickness=0.18 //x=1.3 //y=2.095 //x2=1.6 //y2=2.26
r748 (  170 226 ) resistor r=39.5823 //w=0.21 //l=0.173853 //layer=ply \
 //thickness=0.18 //x=1.3 //y=1.71 //x2=1.34 //y2=1.555
r749 (  170 171 ) resistor r=197.415 //w=0.094 //l=0.385 //layer=ply \
 //thickness=0.18 //x=1.3 //y=1.71 //x2=1.3 //y2=2.095
r750 (  169 226 ) resistor r=39.5823 //w=0.21 //l=0.173853 //layer=ply \
 //thickness=0.18 //x=1.3 //y=1.4 //x2=1.34 //y2=1.555
r751 (  168 225 ) resistor r=45.1352 //w=0.168 //l=0.173853 //layer=ply \
 //thickness=0.18 //x=1.3 //y=1.055 //x2=1.34 //y2=0.9
r752 (  168 169 ) resistor r=176.904 //w=0.094 //l=0.345 //layer=ply \
 //thickness=0.18 //x=1.3 //y=1.055 //x2=1.3 //y2=1.4
r753 (  167 220 ) resistor r=592.245 //w=0.094 //l=1.155 //layer=ply \
 //thickness=0.18 //x=20.95 //y=6.2 //x2=20.95 //y2=5.045
r754 (  166 254 ) resistor r=592.245 //w=0.094 //l=1.155 //layer=ply \
 //thickness=0.18 //x=20.51 //y=6.2 //x2=20.51 //y2=5.045
r755 (  165 201 ) resistor r=592.245 //w=0.094 //l=1.155 //layer=ply \
 //thickness=0.18 //x=10.96 //y=6.2 //x2=10.96 //y2=5.045
r756 (  164 241 ) resistor r=592.245 //w=0.094 //l=1.155 //layer=ply \
 //thickness=0.18 //x=10.52 //y=6.2 //x2=10.52 //y2=5.045
r757 (  163 184 ) resistor r=592.245 //w=0.094 //l=1.155 //layer=ply \
 //thickness=0.18 //x=2.24 //y=6.2 //x2=2.24 //y2=5.045
r758 (  162 177 ) resistor r=592.245 //w=0.094 //l=1.155 //layer=ply \
 //thickness=0.18 //x=1.8 //y=6.2 //x2=1.8 //y2=5.045
r759 (  161 217 ) resistor r=56.4043 //w=0.094 //l=0.11 //layer=ply \
 //thickness=0.18 //x=20.77 //y=1.585 //x2=20.88 //y2=1.585
r760 (  161 218 ) resistor r=56.4043 //w=0.094 //l=0.11 //layer=ply \
 //thickness=0.18 //x=20.77 //y=1.585 //x2=20.66 //y2=1.585
r761 (  160 198 ) resistor r=56.4043 //w=0.094 //l=0.11 //layer=ply \
 //thickness=0.18 //x=10.78 //y=1.585 //x2=10.89 //y2=1.585
r762 (  160 199 ) resistor r=56.4043 //w=0.094 //l=0.11 //layer=ply \
 //thickness=0.18 //x=10.78 //y=1.585 //x2=10.67 //y2=1.585
r763 (  159 174 ) resistor r=56.4043 //w=0.094 //l=0.11 //layer=ply \
 //thickness=0.18 //x=1.565 //y=1.555 //x2=1.675 //y2=1.555
r764 (  159 175 ) resistor r=56.4043 //w=0.094 //l=0.11 //layer=ply \
 //thickness=0.18 //x=1.565 //y=1.555 //x2=1.455 //y2=1.555
r765 (  155 251 ) resistor r=152 //w=0.17 //l=0.17 //layer=licon //count=1 \
 //x=20.5 //y=4.88 //x2=20.5 //y2=4.88
r766 (  146 247 ) resistor r=152 //w=0.17 //l=0.17 //layer=licon //count=1 \
 //x=20.47 //y=2.26 //x2=20.47 //y2=2.26
r767 (  129 262 ) resistor r=23.615 //w=0.187 //l=0.345 //layer=li \
 //thickness=0.1 //x=14.07 //y=5.56 //x2=14.07 //y2=5.905
r768 (  121 261 ) resistor r=23.615 //w=0.187 //l=0.345 //layer=li \
 //thickness=0.1 //x=13.19 //y=5.56 //x2=13.19 //y2=5.905
r769 (  116 238 ) resistor r=152 //w=0.17 //l=0.17 //layer=licon //count=1 \
 //x=10.51 //y=4.88 //x2=10.51 //y2=4.88
r770 (  107 234 ) resistor r=152 //w=0.17 //l=0.17 //layer=licon //count=1 \
 //x=10.48 //y=2.26 //x2=10.48 //y2=2.26
r771 (  102 230 ) resistor r=152 //w=0.17 //l=0.17 //layer=licon //count=1 \
 //x=1.6 //y=4.88 //x2=1.6 //y2=4.88
r772 (  93 228 ) resistor r=152 //w=0.17 //l=0.17 //layer=licon //count=1 \
 //x=1.6 //y=2.26 //x2=1.6 //y2=2.26
r773 (  83 85 ) resistor r=0.10734 //w=0.281 //l=0.16 //layer=m2 \
 //thickness=0.36 //x=1.605 //y=4.255 //x2=1.765 //y2=4.255
r774 (  81 89 ) resistor r=1.10585 //w=0.196 //l=1.7325 //layer=m2 \
 //thickness=0.36 //x=16.27 //y=4.27 //x2=14.54 //y2=4.265
r775 (  80 91 ) resistor r=2.64838 //w=0.182 //l=3.86499 //layer=m2 \
 //thickness=0.36 //x=16.615 //y=4.27 //x2=20.47 //y2=4.25
r776 (  80 81 ) resistor r=0.329198 //w=0.131 //l=0.345 //layer=m2 \
 //thickness=0.36 //x=16.615 //y=4.27 //x2=16.27 //y2=4.27
r777 (  79 87 ) resistor r=0.110608 //w=0.182 //l=0.162481 //layer=m2 \
 //thickness=0.36 //x=10.645 //y=4.25 //x2=10.485 //y2=4.255
r778 (  78 89 ) resistor r=0.104578 //w=0.196 //l=0.167332 //layer=m2 \
 //thickness=0.36 //x=14.38 //y=4.25 //x2=14.54 //y2=4.265
r779 (  78 79 ) resistor r=3.56393 //w=0.131 //l=3.735 //layer=m2 \
 //thickness=0.36 //x=14.38 //y=4.25 //x2=10.645 //y2=4.25
r780 (  76 87 ) resistor r=2.65525 //w=0.182 //l=3.87 //layer=m2 \
 //thickness=0.36 //x=6.62 //y=4.265 //x2=10.485 //y2=4.255
r781 (  76 77 ) resistor r=0.329198 //w=0.131 //l=0.345 //layer=m2 \
 //thickness=0.36 //x=6.62 //y=4.265 //x2=6.275 //y2=4.265
r782 (  74 77 ) resistor r=0.1875 //w=0.17 //l=0.262393 //layer=m2 \
 //thickness=0.36 //x=6.02 //y=4.25 //x2=6.275 //y2=4.265
r783 (  74 75 ) resistor r=1.02576 //w=0.131 //l=1.075 //layer=m2 \
 //thickness=0.36 //x=6.02 //y=4.25 //x2=4.945 //y2=4.25
r784 (  72 75 ) resistor r=0.125 //w=0.17 //l=0.177341 //layer=m2 \
 //thickness=0.36 //x=4.775 //y=4.265 //x2=4.945 //y2=4.25
r785 (  72 73 ) resistor r=0.329198 //w=0.131 //l=0.345 //layer=m2 \
 //thickness=0.36 //x=4.775 //y=4.265 //x2=4.43 //y2=4.265
r786 (  70 73 ) resistor r=0.1875 //w=0.17 //l=0.262393 //layer=m2 \
 //thickness=0.36 //x=4.175 //y=4.25 //x2=4.43 //y2=4.265
r787 (  70 85 ) resistor r=2.29962 //w=0.131 //l=2.41 //layer=m2 \
 //thickness=0.36 //x=4.175 //y=4.25 //x2=1.765 //y2=4.25
r788 (  69 155 ) resistor r=9.3 //w=0.17 //l=0.17 //layer=mcon //count=1 \
 //x=20.5 //y=4.88 //x2=20.5 //y2=4.88
r789 (  65 146 ) resistor r=9.3 //w=0.17 //l=0.17 //layer=mcon //count=1 \
 //x=20.47 //y=2.26 //x2=20.47 //y2=2.26
r790 (  65 67 ) resistor r=0.0936408 //w=0.196 //l=0.125 //layer=m1 \
 //thickness=0.36 //x=20.472 //y=2.26 //x2=20.472 //y2=2.385
r791 (  62 91 ) resistor r=4.5 //w=0.15 //l=0.15 //layer=via1 //count=1 \
 //x=20.47 //y=4.25 //x2=20.47 //y2=4.25
r792 (  60 89 ) resistor r=4.5 //w=0.15 //l=0.15 //layer=via1 //count=1 \
 //x=14.54 //y=4.265 //x2=14.54 //y2=4.265
r793 (  58 60 ) resistor r=0.00505391 //w=0.371 //l=0.015 //layer=m1 \
 //thickness=0.36 //x=14.492 //y=4.25 //x2=14.492 //y2=4.265
r794 (  55 259 ) resistor r=9.3 //w=0.17 //l=0.17 //layer=mcon //count=1 \
 //x=14.11 //y=1.18 //x2=14.11 //y2=1.18
r795 (  53 129 ) resistor r=9.3 //w=0.17 //l=0.17 //layer=mcon //count=1 \
 //x=14.07 //y=5.56 //x2=14.07 //y2=5.56
r796 (  50 53 ) resistor r=0.117801 //w=0.191 //l=0.18 //layer=m1 \
 //thickness=0.36 //x=14.07 //y=5.38 //x2=14.07 //y2=5.56
r797 (  49 121 ) resistor r=9.3 //w=0.17 //l=0.17 //layer=mcon //count=1 \
 //x=13.19 //y=5.56 //x2=13.19 //y2=5.56
r798 (  47 49 ) resistor r=0.10274 //w=0.219 //l=0.18 //layer=m1 \
 //thickness=0.36 //x=13.19 //y=5.38 //x2=13.19 //y2=5.56
r799 (  46 116 ) resistor r=9.3 //w=0.17 //l=0.17 //layer=mcon //count=1 \
 //x=10.51 //y=4.88 //x2=10.51 //y2=4.88
r800 (  42 107 ) resistor r=9.3 //w=0.17 //l=0.17 //layer=mcon //count=1 \
 //x=10.48 //y=2.26 //x2=10.48 //y2=2.26
r801 (  42 44 ) resistor r=0.0936408 //w=0.196 //l=0.125 //layer=m1 \
 //thickness=0.36 //x=10.482 //y=2.26 //x2=10.482 //y2=2.385
r802 (  40 87 ) resistor r=4.5 //w=0.15 //l=0.15 //layer=via1 //count=1 \
 //x=10.485 //y=4.255 //x2=10.485 //y2=4.255
r803 (  38 40 ) resistor r=0.00164908 //w=0.379 //l=0.005 //layer=m1 \
 //thickness=0.36 //x=10.43 //y=4.25 //x2=10.43 //y2=4.255
r804 (  36 83 ) resistor r=4.5 //w=0.15 //l=0.15 //layer=via1 //count=1 \
 //x=1.605 //y=4.255 //x2=1.605 //y2=4.255
r805 (  34 36 ) resistor r=0.00167112 //w=0.374 //l=0.005 //layer=m1 \
 //thickness=0.36 //x=1.655 //y=4.25 //x2=1.655 //y2=4.255
r806 (  32 102 ) resistor r=9.3 //w=0.17 //l=0.17 //layer=mcon //count=1 \
 //x=1.6 //y=4.88 //x2=1.6 //y2=4.88
r807 (  30 93 ) resistor r=9.3 //w=0.17 //l=0.17 //layer=mcon //count=1 \
 //x=1.6 //y=2.26 //x2=1.6 //y2=2.26
r808 (  28 69 ) resistor r=0.0878548 //w=0.228 //l=0.159295 //layer=m1 \
 //thickness=0.36 //x=20.47 //y=4.735 //x2=20.5 //y2=4.88
r809 (  27 62 ) resistor r=0.0911593 //w=0.376 //l=0.184608 //layer=m1 \
 //thickness=0.36 //x=20.47 //y=4.41 //x2=20.417 //y2=4.25
r810 (  27 28 ) resistor r=0.310115 //w=0.131 //l=0.325 //layer=m1 \
 //thickness=0.36 //x=20.47 //y=4.41 //x2=20.47 //y2=4.735
r811 (  26 62 ) resistor r=0.0911593 //w=0.376 //l=0.184608 //layer=m1 \
 //thickness=0.36 //x=20.47 //y=4.09 //x2=20.417 //y2=4.25
r812 (  26 67 ) resistor r=1.62691 //w=0.131 //l=1.705 //layer=m1 \
 //thickness=0.36 //x=20.47 //y=4.09 //x2=20.47 //y2=2.385
r813 (  23 60 ) resistor r=0.0909648 //w=0.371 //l=0.186762 //layer=m1 \
 //thickness=0.36 //x=14.55 //y=4.425 //x2=14.492 //y2=4.265
r814 (  23 24 ) resistor r=0.830153 //w=0.131 //l=0.87 //layer=m1 \
 //thickness=0.36 //x=14.55 //y=4.425 //x2=14.55 //y2=5.295
r815 (  22 58 ) resistor r=0.0859108 //w=0.371 //l=0.171566 //layer=m1 \
 //thickness=0.36 //x=14.55 //y=4.105 //x2=14.492 //y2=4.25
r816 (  21 22 ) resistor r=2.08492 //w=0.131 //l=2.185 //layer=m1 \
 //thickness=0.36 //x=14.55 //y=1.92 //x2=14.55 //y2=4.105
r817 (  19 21 ) resistor r=0.0698411 //w=0.17 //l=0.120208 //layer=m1 \
 //thickness=0.36 //x=14.465 //y=1.835 //x2=14.55 //y2=1.92
r818 (  19 20 ) resistor r=0.257634 //w=0.131 //l=0.27 //layer=m1 \
 //thickness=0.36 //x=14.465 //y=1.835 //x2=14.195 //y2=1.835
r819 (  18 50 ) resistor r=0.0257089 //w=0.23 //l=0.115 //layer=m1 \
 //thickness=0.36 //x=14.185 //y=5.38 //x2=14.07 //y2=5.38
r820 (  17 24 ) resistor r=0.0698411 //w=0.17 //l=0.120208 //layer=m1 \
 //thickness=0.36 //x=14.465 //y=5.38 //x2=14.55 //y2=5.295
r821 (  17 18 ) resistor r=0.267176 //w=0.131 //l=0.28 //layer=m1 \
 //thickness=0.36 //x=14.465 //y=5.38 //x2=14.185 //y2=5.38
r822 (  16 20 ) resistor r=0.0698411 //w=0.17 //l=0.120208 //layer=m1 \
 //thickness=0.36 //x=14.11 //y=1.75 //x2=14.195 //y2=1.835
r823 (  15 55 ) resistor r=0.0913624 //w=0.191 //l=0.12 //layer=m1 \
 //thickness=0.36 //x=14.11 //y=1.3 //x2=14.11 //y2=1.18
r824 (  15 16 ) resistor r=0.429389 //w=0.131 //l=0.45 //layer=m1 \
 //thickness=0.36 //x=14.11 //y=1.3 //x2=14.11 //y2=1.75
r825 (  12 47 ) resistor r=0.0227762 //w=0.219 //l=0.115 //layer=m1 \
 //thickness=0.36 //x=13.305 //y=5.38 //x2=13.19 //y2=5.38
r826 (  11 50 ) resistor r=0.0257089 //w=0.23 //l=0.115 //layer=m1 \
 //thickness=0.36 //x=13.955 //y=5.38 //x2=14.07 //y2=5.38
r827 (  11 12 ) resistor r=0.620229 //w=0.131 //l=0.65 //layer=m1 \
 //thickness=0.36 //x=13.955 //y=5.38 //x2=13.305 //y2=5.38
r828 (  8 46 ) resistor r=0.0878548 //w=0.228 //l=0.159295 //layer=m1 \
 //thickness=0.36 //x=10.48 //y=4.735 //x2=10.51 //y2=4.88
r829 (  7 40 ) resistor r=0.0912814 //w=0.379 //l=0.183303 //layer=m1 \
 //thickness=0.36 //x=10.48 //y=4.415 //x2=10.43 //y2=4.255
r830 (  7 8 ) resistor r=0.305344 //w=0.131 //l=0.32 //layer=m1 \
 //thickness=0.36 //x=10.48 //y=4.415 //x2=10.48 //y2=4.735
r831 (  6 38 ) resistor r=0.0896323 //w=0.379 //l=0.178255 //layer=m1 \
 //thickness=0.36 //x=10.48 //y=4.095 //x2=10.43 //y2=4.25
r832 (  6 44 ) resistor r=1.63168 //w=0.131 //l=1.71 //layer=m1 \
 //thickness=0.36 //x=10.48 //y=4.095 //x2=10.48 //y2=2.385
r833 (  4 32 ) resistor r=0.0760407 //w=0.238 //l=0.125 //layer=m1 \
 //thickness=0.36 //x=1.6 //y=4.755 //x2=1.6 //y2=4.88
r834 (  3 36 ) resistor r=0.0910802 //w=0.374 //l=0.185472 //layer=m1 \
 //thickness=0.36 //x=1.6 //y=4.415 //x2=1.655 //y2=4.255
r835 (  3 4 ) resistor r=0.324427 //w=0.131 //l=0.34 //layer=m1 \
 //thickness=0.36 //x=1.6 //y=4.415 //x2=1.6 //y2=4.755
r836 (  2 34 ) resistor r=0.089409 //w=0.374 //l=0.180416 //layer=m1 \
 //thickness=0.36 //x=1.6 //y=4.095 //x2=1.655 //y2=4.25
r837 (  1 30 ) resistor r=0.0719237 //w=0.222 //l=0.115 //layer=m1 \
 //thickness=0.36 //x=1.6 //y=2.375 //x2=1.6 //y2=2.26
r838 (  1 2 ) resistor r=1.64122 //w=0.131 //l=1.72 //layer=m1 \
 //thickness=0.36 //x=1.6 //y=2.375 //x2=1.6 //y2=4.095
ends PM_TMRDFFQNX1\%noxref_5

subckt PM_TMRDFFQNX1\%D ( 1 2 3 4 6 7 8 11 12 13 15 16 17 19 32 38 46 53 54 57 \
 66 71 80 85 94 98 99 100 101 102 103 104 105 106 107 108 109 114 116 118 124 \
 125 126 127 128 133 135 137 143 144 145 146 147 152 154 156 162 163 165 166 \
 169 178 179 182 191 192 195 )
c611 ( 195 0 ) capacitor c=0.0393541f //x=50.1 //y=4.88
c612 ( 192 0 ) capacitor c=0.0284095f //x=50.07 //y=2.095
c613 ( 191 0 ) capacitor c=0.043902f //x=50.07 //y=2.26
c614 ( 182 0 ) capacitor c=0.0393541f //x=28.64 //y=4.88
c615 ( 179 0 ) capacitor c=0.0284095f //x=28.61 //y=2.095
c616 ( 178 0 ) capacitor c=0.0438885f //x=28.61 //y=2.26
c617 ( 169 0 ) capacitor c=0.0393541f //x=7.18 //y=4.88
c618 ( 166 0 ) capacitor c=0.0284095f //x=7.15 //y=2.095
c619 ( 165 0 ) capacitor c=0.0438909f //x=7.15 //y=2.26
c620 ( 163 0 ) capacitor c=0.0439708f //x=50.635 //y=1.43
c621 ( 162 0 ) capacitor c=0.0192582f //x=50.635 //y=1.085
c622 ( 156 0 ) capacitor c=0.0162526f //x=50.48 //y=1.585
c623 ( 154 0 ) capacitor c=0.0157807f //x=50.48 //y=0.93
c624 ( 152 0 ) capacitor c=0.0372668f //x=50.475 //y=4.97
c625 ( 147 0 ) capacitor c=0.0209669f //x=50.105 //y=1.74
c626 ( 146 0 ) capacitor c=0.0168511f //x=50.105 //y=1.43
c627 ( 145 0 ) capacitor c=0.0175485f //x=50.105 //y=1.085
c628 ( 144 0 ) capacitor c=0.0439708f //x=29.175 //y=1.43
c629 ( 143 0 ) capacitor c=0.0192582f //x=29.175 //y=1.085
c630 ( 137 0 ) capacitor c=0.0162526f //x=29.02 //y=1.585
c631 ( 135 0 ) capacitor c=0.0157807f //x=29.02 //y=0.93
c632 ( 133 0 ) capacitor c=0.0372668f //x=29.015 //y=4.97
c633 ( 128 0 ) capacitor c=0.0210762f //x=28.645 //y=1.74
c634 ( 127 0 ) capacitor c=0.0168511f //x=28.645 //y=1.43
c635 ( 126 0 ) capacitor c=0.0175485f //x=28.645 //y=1.085
c636 ( 125 0 ) capacitor c=0.0439708f //x=7.715 //y=1.43
c637 ( 124 0 ) capacitor c=0.0192582f //x=7.715 //y=1.085
c638 ( 118 0 ) capacitor c=0.0162526f //x=7.56 //y=1.585
c639 ( 116 0 ) capacitor c=0.0157807f //x=7.56 //y=0.93
c640 ( 114 0 ) capacitor c=0.0372668f //x=7.555 //y=4.97
c641 ( 109 0 ) capacitor c=0.0210762f //x=7.185 //y=1.74
c642 ( 108 0 ) capacitor c=0.0168511f //x=7.185 //y=1.43
c643 ( 107 0 ) capacitor c=0.0175485f //x=7.185 //y=1.085
c644 ( 106 0 ) capacitor c=0.155269f //x=50.55 //y=6.2
c645 ( 105 0 ) capacitor c=0.110375f //x=50.11 //y=6.2
c646 ( 104 0 ) capacitor c=0.155269f //x=29.09 //y=6.2
c647 ( 103 0 ) capacitor c=0.110375f //x=28.65 //y=6.2
c648 ( 102 0 ) capacitor c=0.155269f //x=7.63 //y=6.2
c649 ( 101 0 ) capacitor c=0.110375f //x=7.19 //y=6.2
c650 ( 94 0 ) capacitor c=8.90417e-19 //x=50.1 //y=4.88
c651 ( 85 0 ) capacitor c=3.09518e-19 //x=50.07 //y=2.26
c652 ( 80 0 ) capacitor c=8.90417e-19 //x=28.64 //y=4.88
c653 ( 71 0 ) capacitor c=3.09518e-19 //x=28.61 //y=2.26
c654 ( 66 0 ) capacitor c=8.90417e-19 //x=7.18 //y=4.88
c655 ( 57 0 ) capacitor c=3.09518e-19 //x=7.15 //y=2.26
c656 ( 54 0 ) capacitor c=0.481746f //x=28.44 //y=2.755
c657 ( 53 0 ) capacitor c=0.317802f //x=28.6 //y=2.755
c658 ( 46 0 ) capacitor c=0.00370144f //x=7.315 //y=2.77
c659 ( 38 0 ) capacitor c=0.00504845f //x=50.07 //y=2.26
c660 ( 32 0 ) capacitor c=0.0061635f //x=28.61 //y=2.26
c661 ( 19 0 ) capacitor c=0.00616453f //x=7.15 //y=2.26
c662 ( 17 0 ) capacitor c=0.0419441f //x=50.07 //y=4.735
c663 ( 16 0 ) capacitor c=0.00971788f //x=50.07 //y=2.885
c664 ( 15 0 ) capacitor c=0.00314276f //x=50.07 //y=2.655
c665 ( 13 0 ) capacitor c=0.0416626f //x=28.61 //y=4.735
c666 ( 12 0 ) capacitor c=0.00990692f //x=28.61 //y=2.915
c667 ( 11 0 ) capacitor c=0.00309543f //x=28.61 //y=2.595
c668 ( 8 0 ) capacitor c=0.00455387f //x=7.15 //y=4.735
c669 ( 7 0 ) capacitor c=0.00998398f //x=7.15 //y=2.93
c670 ( 6 0 ) capacitor c=0.0032814f //x=7.15 //y=2.61
c671 ( 4 0 ) capacitor c=0.0138315f //x=50.07 //y=2.77
c672 ( 3 0 ) capacitor c=0.0140837f //x=28.61 //y=2.77
c673 ( 2 0 ) capacitor c=0.0138441f //x=7.15 //y=2.77
c674 ( 1 0 ) capacitor c=0.0390329f //x=7.15 //y=3.14
r675 (  197 198 ) resistor r=32.4568 //w=0.214 //l=0.075 //layer=ply \
 //thickness=0.18 //x=50.1 //y=4.97 //x2=50.1 //y2=5.045
r676 (  195 197 ) resistor r=20.271 //w=0.214 //l=0.09 //layer=ply \
 //thickness=0.18 //x=50.1 //y=4.88 //x2=50.1 //y2=4.97
r677 (  191 192 ) resistor r=52.7279 //w=0.214 //l=0.165 //layer=ply \
 //thickness=0.18 //x=50.07 //y=2.26 //x2=50.07 //y2=2.095
r678 (  184 185 ) resistor r=32.4568 //w=0.214 //l=0.075 //layer=ply \
 //thickness=0.18 //x=28.64 //y=4.97 //x2=28.64 //y2=5.045
r679 (  182 184 ) resistor r=20.271 //w=0.214 //l=0.09 //layer=ply \
 //thickness=0.18 //x=28.64 //y=4.88 //x2=28.64 //y2=4.97
r680 (  178 179 ) resistor r=52.7279 //w=0.214 //l=0.165 //layer=ply \
 //thickness=0.18 //x=28.61 //y=2.26 //x2=28.61 //y2=2.095
r681 (  171 172 ) resistor r=32.4568 //w=0.214 //l=0.075 //layer=ply \
 //thickness=0.18 //x=7.18 //y=4.97 //x2=7.18 //y2=5.045
r682 (  169 171 ) resistor r=20.271 //w=0.214 //l=0.09 //layer=ply \
 //thickness=0.18 //x=7.18 //y=4.88 //x2=7.18 //y2=4.97
r683 (  165 166 ) resistor r=52.7279 //w=0.214 //l=0.165 //layer=ply \
 //thickness=0.18 //x=7.15 //y=2.26 //x2=7.15 //y2=2.095
r684 (  163 202 ) resistor r=45.1352 //w=0.168 //l=0.173853 //layer=ply \
 //thickness=0.18 //x=50.635 //y=1.43 //x2=50.595 //y2=1.585
r685 (  162 201 ) resistor r=45.1352 //w=0.168 //l=0.173853 //layer=ply \
 //thickness=0.18 //x=50.635 //y=1.085 //x2=50.595 //y2=0.93
r686 (  162 163 ) resistor r=176.904 //w=0.094 //l=0.345 //layer=ply \
 //thickness=0.18 //x=50.635 //y=1.085 //x2=50.635 //y2=1.43
r687 (  157 200 ) resistor r=10.701 //w=0.21 //l=0.115 //layer=ply \
 //thickness=0.18 //x=50.26 //y=1.585 //x2=50.145 //y2=1.585
r688 (  156 202 ) resistor r=5.52526 //w=0.168 //l=0.115 //layer=ply \
 //thickness=0.18 //x=50.48 //y=1.585 //x2=50.595 //y2=1.585
r689 (  155 199 ) resistor r=5.52526 //w=0.168 //l=0.115 //layer=ply \
 //thickness=0.18 //x=50.26 //y=0.93 //x2=50.145 //y2=0.93
r690 (  154 201 ) resistor r=5.52526 //w=0.168 //l=0.115 //layer=ply \
 //thickness=0.18 //x=50.48 //y=0.93 //x2=50.595 //y2=0.93
r691 (  154 155 ) resistor r=112.809 //w=0.094 //l=0.22 //layer=ply \
 //thickness=0.18 //x=50.48 //y=0.93 //x2=50.26 //y2=0.93
r692 (  153 197 ) resistor r=16.5046 //w=0.27 //l=0.135 //layer=ply \
 //thickness=0.18 //x=50.235 //y=4.97 //x2=50.1 //y2=4.97
r693 (  152 159 ) resistor r=26.9307 //w=0.15 //l=0.106066 //layer=ply \
 //thickness=0.18 //x=50.475 //y=4.97 //x2=50.55 //y2=5.045
r694 (  152 153 ) resistor r=123.064 //w=0.094 //l=0.24 //layer=ply \
 //thickness=0.18 //x=50.475 //y=4.97 //x2=50.235 //y2=4.97
r695 (  147 200 ) resistor r=39.5823 //w=0.21 //l=0.173853 //layer=ply \
 //thickness=0.18 //x=50.105 //y=1.74 //x2=50.145 //y2=1.585
r696 (  147 192 ) resistor r=182.032 //w=0.094 //l=0.355 //layer=ply \
 //thickness=0.18 //x=50.105 //y=1.74 //x2=50.105 //y2=2.095
r697 (  146 200 ) resistor r=39.5823 //w=0.21 //l=0.173853 //layer=ply \
 //thickness=0.18 //x=50.105 //y=1.43 //x2=50.145 //y2=1.585
r698 (  145 199 ) resistor r=45.1352 //w=0.168 //l=0.173853 //layer=ply \
 //thickness=0.18 //x=50.105 //y=1.085 //x2=50.145 //y2=0.93
r699 (  145 146 ) resistor r=176.904 //w=0.094 //l=0.345 //layer=ply \
 //thickness=0.18 //x=50.105 //y=1.085 //x2=50.105 //y2=1.43
r700 (  144 189 ) resistor r=45.1352 //w=0.168 //l=0.173853 //layer=ply \
 //thickness=0.18 //x=29.175 //y=1.43 //x2=29.135 //y2=1.585
r701 (  143 188 ) resistor r=45.1352 //w=0.168 //l=0.173853 //layer=ply \
 //thickness=0.18 //x=29.175 //y=1.085 //x2=29.135 //y2=0.93
r702 (  143 144 ) resistor r=176.904 //w=0.094 //l=0.345 //layer=ply \
 //thickness=0.18 //x=29.175 //y=1.085 //x2=29.175 //y2=1.43
r703 (  138 187 ) resistor r=10.701 //w=0.21 //l=0.115 //layer=ply \
 //thickness=0.18 //x=28.8 //y=1.585 //x2=28.685 //y2=1.585
r704 (  137 189 ) resistor r=5.52526 //w=0.168 //l=0.115 //layer=ply \
 //thickness=0.18 //x=29.02 //y=1.585 //x2=29.135 //y2=1.585
r705 (  136 186 ) resistor r=5.52526 //w=0.168 //l=0.115 //layer=ply \
 //thickness=0.18 //x=28.8 //y=0.93 //x2=28.685 //y2=0.93
r706 (  135 188 ) resistor r=5.52526 //w=0.168 //l=0.115 //layer=ply \
 //thickness=0.18 //x=29.02 //y=0.93 //x2=29.135 //y2=0.93
r707 (  135 136 ) resistor r=112.809 //w=0.094 //l=0.22 //layer=ply \
 //thickness=0.18 //x=29.02 //y=0.93 //x2=28.8 //y2=0.93
r708 (  134 184 ) resistor r=16.5046 //w=0.27 //l=0.135 //layer=ply \
 //thickness=0.18 //x=28.775 //y=4.97 //x2=28.64 //y2=4.97
r709 (  133 140 ) resistor r=26.9307 //w=0.15 //l=0.106066 //layer=ply \
 //thickness=0.18 //x=29.015 //y=4.97 //x2=29.09 //y2=5.045
r710 (  133 134 ) resistor r=123.064 //w=0.094 //l=0.24 //layer=ply \
 //thickness=0.18 //x=29.015 //y=4.97 //x2=28.775 //y2=4.97
r711 (  128 187 ) resistor r=39.5823 //w=0.21 //l=0.173853 //layer=ply \
 //thickness=0.18 //x=28.645 //y=1.74 //x2=28.685 //y2=1.585
r712 (  128 179 ) resistor r=182.032 //w=0.094 //l=0.355 //layer=ply \
 //thickness=0.18 //x=28.645 //y=1.74 //x2=28.645 //y2=2.095
r713 (  127 187 ) resistor r=39.5823 //w=0.21 //l=0.173853 //layer=ply \
 //thickness=0.18 //x=28.645 //y=1.43 //x2=28.685 //y2=1.585
r714 (  126 186 ) resistor r=45.1352 //w=0.168 //l=0.173853 //layer=ply \
 //thickness=0.18 //x=28.645 //y=1.085 //x2=28.685 //y2=0.93
r715 (  126 127 ) resistor r=176.904 //w=0.094 //l=0.345 //layer=ply \
 //thickness=0.18 //x=28.645 //y=1.085 //x2=28.645 //y2=1.43
r716 (  125 176 ) resistor r=45.1352 //w=0.168 //l=0.173853 //layer=ply \
 //thickness=0.18 //x=7.715 //y=1.43 //x2=7.675 //y2=1.585
r717 (  124 175 ) resistor r=45.1352 //w=0.168 //l=0.173853 //layer=ply \
 //thickness=0.18 //x=7.715 //y=1.085 //x2=7.675 //y2=0.93
r718 (  124 125 ) resistor r=176.904 //w=0.094 //l=0.345 //layer=ply \
 //thickness=0.18 //x=7.715 //y=1.085 //x2=7.715 //y2=1.43
r719 (  119 174 ) resistor r=10.701 //w=0.21 //l=0.115 //layer=ply \
 //thickness=0.18 //x=7.34 //y=1.585 //x2=7.225 //y2=1.585
r720 (  118 176 ) resistor r=5.52526 //w=0.168 //l=0.115 //layer=ply \
 //thickness=0.18 //x=7.56 //y=1.585 //x2=7.675 //y2=1.585
r721 (  117 173 ) resistor r=5.52526 //w=0.168 //l=0.115 //layer=ply \
 //thickness=0.18 //x=7.34 //y=0.93 //x2=7.225 //y2=0.93
r722 (  116 175 ) resistor r=5.52526 //w=0.168 //l=0.115 //layer=ply \
 //thickness=0.18 //x=7.56 //y=0.93 //x2=7.675 //y2=0.93
r723 (  116 117 ) resistor r=112.809 //w=0.094 //l=0.22 //layer=ply \
 //thickness=0.18 //x=7.56 //y=0.93 //x2=7.34 //y2=0.93
r724 (  115 171 ) resistor r=16.5046 //w=0.27 //l=0.135 //layer=ply \
 //thickness=0.18 //x=7.315 //y=4.97 //x2=7.18 //y2=4.97
r725 (  114 121 ) resistor r=26.9307 //w=0.15 //l=0.106066 //layer=ply \
 //thickness=0.18 //x=7.555 //y=4.97 //x2=7.63 //y2=5.045
r726 (  114 115 ) resistor r=123.064 //w=0.094 //l=0.24 //layer=ply \
 //thickness=0.18 //x=7.555 //y=4.97 //x2=7.315 //y2=4.97
r727 (  109 174 ) resistor r=39.5823 //w=0.21 //l=0.173853 //layer=ply \
 //thickness=0.18 //x=7.185 //y=1.74 //x2=7.225 //y2=1.585
r728 (  109 166 ) resistor r=182.032 //w=0.094 //l=0.355 //layer=ply \
 //thickness=0.18 //x=7.185 //y=1.74 //x2=7.185 //y2=2.095
r729 (  108 174 ) resistor r=39.5823 //w=0.21 //l=0.173853 //layer=ply \
 //thickness=0.18 //x=7.185 //y=1.43 //x2=7.225 //y2=1.585
r730 (  107 173 ) resistor r=45.1352 //w=0.168 //l=0.173853 //layer=ply \
 //thickness=0.18 //x=7.185 //y=1.085 //x2=7.225 //y2=0.93
r731 (  107 108 ) resistor r=176.904 //w=0.094 //l=0.345 //layer=ply \
 //thickness=0.18 //x=7.185 //y=1.085 //x2=7.185 //y2=1.43
r732 (  106 159 ) resistor r=592.245 //w=0.094 //l=1.155 //layer=ply \
 //thickness=0.18 //x=50.55 //y=6.2 //x2=50.55 //y2=5.045
r733 (  105 198 ) resistor r=592.245 //w=0.094 //l=1.155 //layer=ply \
 //thickness=0.18 //x=50.11 //y=6.2 //x2=50.11 //y2=5.045
r734 (  104 140 ) resistor r=592.245 //w=0.094 //l=1.155 //layer=ply \
 //thickness=0.18 //x=29.09 //y=6.2 //x2=29.09 //y2=5.045
r735 (  103 185 ) resistor r=592.245 //w=0.094 //l=1.155 //layer=ply \
 //thickness=0.18 //x=28.65 //y=6.2 //x2=28.65 //y2=5.045
r736 (  102 121 ) resistor r=592.245 //w=0.094 //l=1.155 //layer=ply \
 //thickness=0.18 //x=7.63 //y=6.2 //x2=7.63 //y2=5.045
r737 (  101 172 ) resistor r=592.245 //w=0.094 //l=1.155 //layer=ply \
 //thickness=0.18 //x=7.19 //y=6.2 //x2=7.19 //y2=5.045
r738 (  100 156 ) resistor r=56.4043 //w=0.094 //l=0.11 //layer=ply \
 //thickness=0.18 //x=50.37 //y=1.585 //x2=50.48 //y2=1.585
r739 (  100 157 ) resistor r=56.4043 //w=0.094 //l=0.11 //layer=ply \
 //thickness=0.18 //x=50.37 //y=1.585 //x2=50.26 //y2=1.585
r740 (  99 137 ) resistor r=56.4043 //w=0.094 //l=0.11 //layer=ply \
 //thickness=0.18 //x=28.91 //y=1.585 //x2=29.02 //y2=1.585
r741 (  99 138 ) resistor r=56.4043 //w=0.094 //l=0.11 //layer=ply \
 //thickness=0.18 //x=28.91 //y=1.585 //x2=28.8 //y2=1.585
r742 (  98 118 ) resistor r=56.4043 //w=0.094 //l=0.11 //layer=ply \
 //thickness=0.18 //x=7.45 //y=1.585 //x2=7.56 //y2=1.585
r743 (  98 119 ) resistor r=56.4043 //w=0.094 //l=0.11 //layer=ply \
 //thickness=0.18 //x=7.45 //y=1.585 //x2=7.34 //y2=1.585
r744 (  94 195 ) resistor r=152 //w=0.17 //l=0.17 //layer=licon //count=1 \
 //x=50.1 //y=4.88 //x2=50.1 //y2=4.88
r745 (  85 191 ) resistor r=152 //w=0.17 //l=0.17 //layer=licon //count=1 \
 //x=50.07 //y=2.26 //x2=50.07 //y2=2.26
r746 (  80 182 ) resistor r=152 //w=0.17 //l=0.17 //layer=licon //count=1 \
 //x=28.64 //y=4.88 //x2=28.64 //y2=4.88
r747 (  71 178 ) resistor r=152 //w=0.17 //l=0.17 //layer=licon //count=1 \
 //x=28.61 //y=2.26 //x2=28.61 //y2=2.26
r748 (  66 169 ) resistor r=152 //w=0.17 //l=0.17 //layer=licon //count=1 \
 //x=7.18 //y=4.88 //x2=7.18 //y2=4.88
r749 (  57 165 ) resistor r=152 //w=0.17 //l=0.17 //layer=licon //count=1 \
 //x=7.15 //y=2.26 //x2=7.15 //y2=2.26
r750 (  53 54 ) resistor r=0.10734 //w=0.281 //l=0.16 //layer=m2 \
 //thickness=0.36 //x=28.6 //y=2.755 //x2=28.44 //y2=2.755
r751 (  46 50 ) resistor r=0.10734 //w=0.281 //l=0.16 //layer=m2 \
 //thickness=0.36 //x=7.315 //y=2.77 //x2=7.155 //y2=2.77
r752 (  46 54 ) resistor r=20.1574 //w=0.131 //l=21.125 //layer=m2 \
 //thickness=0.36 //x=7.315 //y=2.77 //x2=28.44 //y2=2.77
r753 (  44 94 ) resistor r=9.3 //w=0.17 //l=0.17 //layer=mcon //count=1 \
 //x=50.1 //y=4.88 //x2=50.1 //y2=4.88
r754 (  38 85 ) resistor r=9.3 //w=0.17 //l=0.17 //layer=mcon //count=1 \
 //x=50.07 //y=2.26 //x2=50.07 //y2=2.26
r755 (  38 40 ) resistor r=0.0936408 //w=0.196 //l=0.125 //layer=m1 \
 //thickness=0.36 //x=50.072 //y=2.26 //x2=50.072 //y2=2.385
r756 (  36 80 ) resistor r=9.3 //w=0.17 //l=0.17 //layer=mcon //count=1 \
 //x=28.64 //y=4.88 //x2=28.64 //y2=4.88
r757 (  32 71 ) resistor r=9.3 //w=0.17 //l=0.17 //layer=mcon //count=1 \
 //x=28.61 //y=2.26 //x2=28.61 //y2=2.26
r758 (  32 34 ) resistor r=0.0936408 //w=0.196 //l=0.125 //layer=m1 \
 //thickness=0.36 //x=28.612 //y=2.26 //x2=28.612 //y2=2.385
r759 (  28 53 ) resistor r=4.5 //w=0.15 //l=0.15 //layer=via1 //count=1 \
 //x=28.6 //y=2.755 //x2=28.6 //y2=2.755
r760 (  23 66 ) resistor r=9.3 //w=0.17 //l=0.17 //layer=mcon //count=1 \
 //x=7.18 //y=4.88 //x2=7.18 //y2=4.88
r761 (  19 57 ) resistor r=9.3 //w=0.17 //l=0.17 //layer=mcon //count=1 \
 //x=7.15 //y=2.26 //x2=7.15 //y2=2.26
r762 (  19 21 ) resistor r=0.0936408 //w=0.196 //l=0.125 //layer=m1 \
 //thickness=0.36 //x=7.152 //y=2.26 //x2=7.152 //y2=2.385
r763 (  17 44 ) resistor r=0.0878548 //w=0.228 //l=0.159295 //layer=m1 \
 //thickness=0.36 //x=50.07 //y=4.735 //x2=50.1 //y2=4.88
r764 (  16 17 ) resistor r=1.76527 //w=0.131 //l=1.85 //layer=m1 \
 //thickness=0.36 //x=50.07 //y=2.885 //x2=50.07 //y2=4.735
r765 (  15 40 ) resistor r=0.257634 //w=0.131 //l=0.27 //layer=m1 \
 //thickness=0.36 //x=50.07 //y=2.655 //x2=50.07 //y2=2.385
r766 (  13 36 ) resistor r=0.0878548 //w=0.228 //l=0.159295 //layer=m1 \
 //thickness=0.36 //x=28.61 //y=4.735 //x2=28.64 //y2=4.88
r767 (  12 13 ) resistor r=1.73664 //w=0.131 //l=1.82 //layer=m1 \
 //thickness=0.36 //x=28.61 //y=2.915 //x2=28.61 //y2=4.735
r768 (  11 28 ) resistor r=0.0909648 //w=0.371 //l=0.186762 //layer=m1 \
 //thickness=0.36 //x=28.61 //y=2.595 //x2=28.552 //y2=2.755
r769 (  11 34 ) resistor r=0.200382 //w=0.131 //l=0.21 //layer=m1 \
 //thickness=0.36 //x=28.61 //y=2.595 //x2=28.61 //y2=2.385
r770 (  8 23 ) resistor r=0.0878548 //w=0.228 //l=0.159295 //layer=m1 \
 //thickness=0.36 //x=7.15 //y=4.735 //x2=7.18 //y2=4.88
r771 (  6 21 ) resistor r=0.214695 //w=0.131 //l=0.225 //layer=m1 \
 //thickness=0.36 //x=7.15 //y=2.61 //x2=7.15 //y2=2.385
r772 (  4 16 ) resistor r=0.0752589 //w=0.364 //l=0.141863 //layer=m1 \
 //thickness=0.36 //x=50.01 //y=2.77 //x2=50.07 //y2=2.885
r773 (  4 15 ) resistor r=0.0752589 //w=0.364 //l=0.141863 //layer=m1 \
 //thickness=0.36 //x=50.01 //y=2.77 //x2=50.07 //y2=2.655
r774 (  3 12 ) resistor r=0.0859108 //w=0.371 //l=0.171566 //layer=m1 \
 //thickness=0.36 //x=28.552 //y=2.77 //x2=28.61 //y2=2.915
r775 (  3 28 ) resistor r=0.00505391 //w=0.371 //l=0.015 //layer=m1 \
 //thickness=0.36 //x=28.552 //y=2.77 //x2=28.552 //y2=2.755
r776 (  2 50 ) resistor r=4.5 //w=0.15 //l=0.15 //layer=via1 //count=1 \
 //x=7.155 //y=2.77 //x2=7.155 //y2=2.77
r777 (  2 7 ) resistor r=0.0910802 //w=0.374 //l=0.185472 //layer=m1 \
 //thickness=0.36 //x=7.205 //y=2.77 //x2=7.15 //y2=2.93
r778 (  2 6 ) resistor r=0.0910802 //w=0.374 //l=0.185472 //layer=m1 \
 //thickness=0.36 //x=7.205 //y=2.77 //x2=7.15 //y2=2.61
r779 (  1 8 ) resistor r=1.52195 //w=0.131 //l=1.595 //layer=m1 \
 //thickness=0.36 //x=7.15 //y=3.14 //x2=7.15 //y2=4.735
r780 (  1 7 ) resistor r=0.200382 //w=0.131 //l=0.21 //layer=m1 \
 //thickness=0.36 //x=7.15 //y=3.14 //x2=7.15 //y2=2.93
ends PM_TMRDFFQNX1\%D

subckt PM_TMRDFFQNX1\%noxref_7 ( 1 2 3 4 7 12 13 15 16 18 19 20 22 23 30 34 35 \
 38 40 43 48 50 53 54 56 57 58 60 62 65 72 73 76 85 90 98 115 124 128 129 130 \
 131 132 133 137 138 139 144 146 149 150 151 152 153 154 158 160 163 164 169 \
 170 175 184 187 189 190 )
c434 ( 187 0 ) capacitor c=0.00878249f //x=28.72 //y=1.085
c435 ( 184 0 ) capacitor c=0.0682508f //x=31.2 //y=4.88
c436 ( 175 0 ) capacitor c=0.0710066f //x=25.28 //y=4.88
c437 ( 170 0 ) capacitor c=0.0278202f //x=25.28 //y=2.095
c438 ( 169 0 ) capacitor c=0.0479324f //x=25.28 //y=2.26
c439 ( 164 0 ) capacitor c=0.0318956f //x=31.535 //y=1.39
c440 ( 163 0 ) capacitor c=0.0186809f //x=31.535 //y=1.045
c441 ( 160 0 ) capacitor c=0.0141821f //x=31.38 //y=1.545
c442 ( 158 0 ) capacitor c=0.0158553f //x=31.38 //y=0.89
c443 ( 154 0 ) capacitor c=0.0854171f //x=31.005 //y=2.095
c444 ( 153 0 ) capacitor c=0.0229235f //x=31.005 //y=1.7
c445 ( 152 0 ) capacitor c=0.0234359f //x=31.005 //y=1.39
c446 ( 151 0 ) capacitor c=0.0198759f //x=31.005 //y=1.045
c447 ( 150 0 ) capacitor c=0.0443175f //x=25.8 //y=1.44
c448 ( 149 0 ) capacitor c=0.0199703f //x=25.8 //y=1.095
c449 ( 146 0 ) capacitor c=0.0162526f //x=25.645 //y=1.595
c450 ( 144 0 ) capacitor c=0.0157807f //x=25.645 //y=0.94
c451 ( 139 0 ) capacitor c=0.0220935f //x=25.27 //y=1.75
c452 ( 138 0 ) capacitor c=0.0207489f //x=25.27 //y=1.44
c453 ( 137 0 ) capacitor c=0.0194091f //x=25.27 //y=1.095
c454 ( 133 0 ) capacitor c=0.110369f //x=31.54 //y=6.2
c455 ( 132 0 ) capacitor c=0.154619f //x=31.1 //y=6.2
c456 ( 131 0 ) capacitor c=0.159671f //x=25.46 //y=6.2
c457 ( 130 0 ) capacitor c=0.110208f //x=25.02 //y=6.2
c458 ( 124 0 ) capacitor c=8.13425e-19 //x=31.2 //y=4.88
c459 ( 115 0 ) capacitor c=7.85889e-19 //x=31.2 //y=2.26
c460 ( 98 0 ) capacitor c=0.0322017f //x=28.87 //y=5.56
c461 ( 90 0 ) capacitor c=0.0290186f //x=27.99 //y=5.56
c462 ( 85 0 ) capacitor c=8.10944e-19 //x=25.28 //y=4.88
c463 ( 76 0 ) capacitor c=0.00101179f //x=25.28 //y=2.26
c464 ( 73 0 ) capacitor c=0.0202533f //x=31.035 //y=3.505
c465 ( 72 0 ) capacitor c=4.79889e-19 //x=31.195 //y=3.505
c466 ( 65 0 ) capacitor c=0.00861177f //x=29.505 //y=3.51
c467 ( 62 0 ) capacitor c=0.00209252f //x=28.08 //y=3.495
c468 ( 60 0 ) capacitor c=0.0155233f //x=27.48 //y=3.51
c469 ( 58 0 ) capacitor c=0.00615643f //x=26.235 //y=3.495
c470 ( 57 0 ) capacitor c=6.32236e-19 //x=25.445 //y=3.51
c471 ( 56 0 ) capacitor c=0.00294384f //x=25.635 //y=3.51
c472 ( 54 0 ) capacitor c=0.0267491f //x=31.202 //y=4.74
c473 ( 53 0 ) capacitor c=0.00611287f //x=31.2 //y=4.88
c474 ( 50 0 ) capacitor c=0.0064096f //x=31.2 //y=2.26
c475 ( 48 0 ) capacitor c=0.0163473f //x=31.2 //y=3.51
c476 ( 43 0 ) capacitor c=0.0170489f //x=29.345 //y=3.51
c477 ( 40 0 ) capacitor c=0.0113769f //x=28.91 //y=1.18
c478 ( 38 0 ) capacitor c=5.78613e-19 //x=28.87 //y=5.56
c479 ( 35 0 ) capacitor c=0.0105174f //x=28.87 //y=5.38
c480 ( 34 0 ) capacitor c=0.00923791f //x=27.99 //y=5.56
c481 ( 30 0 ) capacitor c=0.0148558f //x=25.28 //y=3.51
c482 ( 23 0 ) capacitor c=0.0131975f //x=31.2 //y=3.665
c483 ( 22 0 ) capacitor c=0.0254865f //x=31.2 //y=3.345
c484 ( 20 0 ) capacitor c=0.0405845f //x=29.35 //y=5.295
c485 ( 19 0 ) capacitor c=0.0134427f //x=29.35 //y=3.67
c486 ( 18 0 ) capacitor c=0.0355824f //x=29.35 //y=3.35
c487 ( 16 0 ) capacitor c=0.0056118f //x=28.995 //y=1.835
c488 ( 15 0 ) capacitor c=0.0126369f //x=29.265 //y=1.835
c489 ( 13 0 ) capacitor c=0.0108105f //x=29.265 //y=5.38
c490 ( 12 0 ) capacitor c=0.0102514f //x=28.91 //y=1.75
c491 ( 7 0 ) capacitor c=0.014318f //x=28.755 //y=5.38
c492 ( 4 0 ) capacitor c=0.0286377f //x=25.28 //y=4.75
c493 ( 3 0 ) capacitor c=0.0126097f //x=25.28 //y=3.67
c494 ( 2 0 ) capacitor c=0.023917f //x=25.28 //y=3.35
c495 ( 1 0 ) capacitor c=0.00685053f //x=25.28 //y=2.375
r496 (  182 184 ) resistor r=20.6867 //w=0.233 //l=0.1 //layer=ply \
 //thickness=0.18 //x=31.1 //y=4.88 //x2=31.2 //y2=4.88
r497 (  169 170 ) resistor r=52.7279 //w=0.214 //l=0.165 //layer=ply \
 //thickness=0.18 //x=25.28 //y=2.26 //x2=25.28 //y2=2.095
r498 (  165 184 ) resistor r=70.3348 //w=0.233 //l=0.414367 //layer=ply \
 //thickness=0.18 //x=31.54 //y=5.045 //x2=31.2 //y2=4.88
r499 (  164 186 ) resistor r=45.1352 //w=0.168 //l=0.173853 //layer=ply \
 //thickness=0.18 //x=31.535 //y=1.39 //x2=31.495 //y2=1.545
r500 (  163 185 ) resistor r=45.1352 //w=0.168 //l=0.173853 //layer=ply \
 //thickness=0.18 //x=31.535 //y=1.045 //x2=31.495 //y2=0.89
r501 (  163 164 ) resistor r=176.904 //w=0.094 //l=0.345 //layer=ply \
 //thickness=0.18 //x=31.535 //y=1.045 //x2=31.535 //y2=1.39
r502 (  161 181 ) resistor r=10.701 //w=0.21 //l=0.115 //layer=ply \
 //thickness=0.18 //x=31.16 //y=1.545 //x2=31.045 //y2=1.545
r503 (  160 186 ) resistor r=5.52526 //w=0.168 //l=0.115 //layer=ply \
 //thickness=0.18 //x=31.38 //y=1.545 //x2=31.495 //y2=1.545
r504 (  159 180 ) resistor r=5.52526 //w=0.168 //l=0.115 //layer=ply \
 //thickness=0.18 //x=31.16 //y=0.89 //x2=31.045 //y2=0.89
r505 (  158 185 ) resistor r=5.52526 //w=0.168 //l=0.115 //layer=ply \
 //thickness=0.18 //x=31.38 //y=0.89 //x2=31.495 //y2=0.89
r506 (  158 159 ) resistor r=112.809 //w=0.094 //l=0.22 //layer=ply \
 //thickness=0.18 //x=31.38 //y=0.89 //x2=31.16 //y2=0.89
r507 (  155 182 ) resistor r=13.0941 //w=0.233 //l=0.165 //layer=ply \
 //thickness=0.18 //x=31.1 //y=5.045 //x2=31.1 //y2=4.88
r508 (  154 179 ) resistor r=34.8111 //w=0.27 //l=0.264953 //layer=ply \
 //thickness=0.18 //x=31.005 //y=2.095 //x2=31.2 //y2=2.26
r509 (  153 181 ) resistor r=39.5823 //w=0.21 //l=0.173853 //layer=ply \
 //thickness=0.18 //x=31.005 //y=1.7 //x2=31.045 //y2=1.545
r510 (  153 154 ) resistor r=202.543 //w=0.094 //l=0.395 //layer=ply \
 //thickness=0.18 //x=31.005 //y=1.7 //x2=31.005 //y2=2.095
r511 (  152 181 ) resistor r=39.5823 //w=0.21 //l=0.173853 //layer=ply \
 //thickness=0.18 //x=31.005 //y=1.39 //x2=31.045 //y2=1.545
r512 (  151 180 ) resistor r=45.1352 //w=0.168 //l=0.173853 //layer=ply \
 //thickness=0.18 //x=31.005 //y=1.045 //x2=31.045 //y2=0.89
r513 (  151 152 ) resistor r=176.904 //w=0.094 //l=0.345 //layer=ply \
 //thickness=0.18 //x=31.005 //y=1.045 //x2=31.005 //y2=1.39
r514 (  150 177 ) resistor r=45.1352 //w=0.168 //l=0.173853 //layer=ply \
 //thickness=0.18 //x=25.8 //y=1.44 //x2=25.76 //y2=1.595
r515 (  149 176 ) resistor r=45.1352 //w=0.168 //l=0.173853 //layer=ply \
 //thickness=0.18 //x=25.8 //y=1.095 //x2=25.76 //y2=0.94
r516 (  149 150 ) resistor r=176.904 //w=0.094 //l=0.345 //layer=ply \
 //thickness=0.18 //x=25.8 //y=1.095 //x2=25.8 //y2=1.44
r517 (  147 173 ) resistor r=10.701 //w=0.21 //l=0.115 //layer=ply \
 //thickness=0.18 //x=25.425 //y=1.595 //x2=25.31 //y2=1.595
r518 (  146 177 ) resistor r=5.52526 //w=0.168 //l=0.115 //layer=ply \
 //thickness=0.18 //x=25.645 //y=1.595 //x2=25.76 //y2=1.595
r519 (  145 172 ) resistor r=5.52526 //w=0.168 //l=0.115 //layer=ply \
 //thickness=0.18 //x=25.425 //y=0.94 //x2=25.31 //y2=0.94
r520 (  144 176 ) resistor r=5.52526 //w=0.168 //l=0.115 //layer=ply \
 //thickness=0.18 //x=25.645 //y=0.94 //x2=25.76 //y2=0.94
r521 (  144 145 ) resistor r=112.809 //w=0.094 //l=0.22 //layer=ply \
 //thickness=0.18 //x=25.645 //y=0.94 //x2=25.425 //y2=0.94
r522 (  141 175 ) resistor r=37.236 //w=0.233 //l=0.249199 //layer=ply \
 //thickness=0.18 //x=25.46 //y=5.045 //x2=25.28 //y2=4.88
r523 (  139 173 ) resistor r=39.5823 //w=0.21 //l=0.173853 //layer=ply \
 //thickness=0.18 //x=25.27 //y=1.75 //x2=25.31 //y2=1.595
r524 (  139 170 ) resistor r=176.904 //w=0.094 //l=0.345 //layer=ply \
 //thickness=0.18 //x=25.27 //y=1.75 //x2=25.27 //y2=2.095
r525 (  138 173 ) resistor r=39.5823 //w=0.21 //l=0.173853 //layer=ply \
 //thickness=0.18 //x=25.27 //y=1.44 //x2=25.31 //y2=1.595
r526 (  137 172 ) resistor r=45.1352 //w=0.168 //l=0.173853 //layer=ply \
 //thickness=0.18 //x=25.27 //y=1.095 //x2=25.31 //y2=0.94
r527 (  137 138 ) resistor r=176.904 //w=0.094 //l=0.345 //layer=ply \
 //thickness=0.18 //x=25.27 //y=1.095 //x2=25.27 //y2=1.44
r528 (  134 175 ) resistor r=53.7854 //w=0.233 //l=0.332415 //layer=ply \
 //thickness=0.18 //x=25.02 //y=5.045 //x2=25.28 //y2=4.88
r529 (  133 165 ) resistor r=592.245 //w=0.094 //l=1.155 //layer=ply \
 //thickness=0.18 //x=31.54 //y=6.2 //x2=31.54 //y2=5.045
r530 (  132 155 ) resistor r=592.245 //w=0.094 //l=1.155 //layer=ply \
 //thickness=0.18 //x=31.1 //y=6.2 //x2=31.1 //y2=5.045
r531 (  131 141 ) resistor r=592.245 //w=0.094 //l=1.155 //layer=ply \
 //thickness=0.18 //x=25.46 //y=6.2 //x2=25.46 //y2=5.045
r532 (  130 134 ) resistor r=592.245 //w=0.094 //l=1.155 //layer=ply \
 //thickness=0.18 //x=25.02 //y=6.2 //x2=25.02 //y2=5.045
r533 (  129 160 ) resistor r=56.4043 //w=0.094 //l=0.11 //layer=ply \
 //thickness=0.18 //x=31.27 //y=1.545 //x2=31.38 //y2=1.545
r534 (  129 161 ) resistor r=56.4043 //w=0.094 //l=0.11 //layer=ply \
 //thickness=0.18 //x=31.27 //y=1.545 //x2=31.16 //y2=1.545
r535 (  128 146 ) resistor r=56.4043 //w=0.094 //l=0.11 //layer=ply \
 //thickness=0.18 //x=25.535 //y=1.595 //x2=25.645 //y2=1.595
r536 (  128 147 ) resistor r=56.4043 //w=0.094 //l=0.11 //layer=ply \
 //thickness=0.18 //x=25.535 //y=1.595 //x2=25.425 //y2=1.595
r537 (  124 184 ) resistor r=152 //w=0.17 //l=0.17 //layer=licon //count=1 \
 //x=31.2 //y=4.88 //x2=31.2 //y2=4.88
r538 (  115 179 ) resistor r=152 //w=0.17 //l=0.17 //layer=licon //count=1 \
 //x=31.2 //y=2.26 //x2=31.2 //y2=2.26
r539 (  98 190 ) resistor r=23.615 //w=0.187 //l=0.345 //layer=li \
 //thickness=0.1 //x=28.87 //y=5.56 //x2=28.87 //y2=5.905
r540 (  90 189 ) resistor r=23.615 //w=0.187 //l=0.345 //layer=li \
 //thickness=0.1 //x=27.99 //y=5.56 //x2=27.99 //y2=5.905
r541 (  85 175 ) resistor r=152 //w=0.17 //l=0.17 //layer=licon //count=1 \
 //x=25.28 //y=4.88 //x2=25.28 //y2=4.88
r542 (  76 169 ) resistor r=152 //w=0.17 //l=0.17 //layer=licon //count=1 \
 //x=25.28 //y=2.26 //x2=25.28 //y2=2.26
r543 (  72 73 ) resistor r=0.10734 //w=0.281 //l=0.16 //layer=m2 \
 //thickness=0.36 //x=31.195 //y=3.505 //x2=31.035 //y2=3.505
r544 (  65 70 ) resistor r=0.10188 //w=0.204 //l=0.16 //layer=m2 \
 //thickness=0.36 //x=29.505 //y=3.51 //x2=29.345 //y2=3.51
r545 (  65 73 ) resistor r=1.45992 //w=0.131 //l=1.53 //layer=m2 \
 //thickness=0.36 //x=29.505 //y=3.51 //x2=31.035 //y2=3.51
r546 (  62 70 ) resistor r=0.778963 //w=0.204 //l=1.27248 //layer=m2 \
 //thickness=0.36 //x=28.08 //y=3.495 //x2=29.345 //y2=3.51
r547 (  62 63 ) resistor r=0.410305 //w=0.131 //l=0.43 //layer=m2 \
 //thickness=0.36 //x=28.08 //y=3.495 //x2=27.65 //y2=3.495
r548 (  60 63 ) resistor r=0.125 //w=0.17 //l=0.177341 //layer=m2 \
 //thickness=0.36 //x=27.48 //y=3.51 //x2=27.65 //y2=3.495
r549 (  60 61 ) resistor r=0.944656 //w=0.131 //l=0.99 //layer=m2 \
 //thickness=0.36 //x=27.48 //y=3.51 //x2=26.49 //y2=3.51
r550 (  58 61 ) resistor r=0.1875 //w=0.17 //l=0.262393 //layer=m2 \
 //thickness=0.36 //x=26.235 //y=3.495 //x2=26.49 //y2=3.51
r551 (  58 59 ) resistor r=0.410305 //w=0.131 //l=0.43 //layer=m2 \
 //thickness=0.36 //x=26.235 //y=3.495 //x2=25.805 //y2=3.495
r552 (  57 67 ) resistor r=0.10734 //w=0.281 //l=0.16 //layer=m2 \
 //thickness=0.36 //x=25.445 //y=3.51 //x2=25.285 //y2=3.51
r553 (  56 59 ) resistor r=0.125 //w=0.17 //l=0.177341 //layer=m2 \
 //thickness=0.36 //x=25.635 //y=3.51 //x2=25.805 //y2=3.495
r554 (  56 57 ) resistor r=0.181298 //w=0.131 //l=0.19 //layer=m2 \
 //thickness=0.36 //x=25.635 //y=3.51 //x2=25.445 //y2=3.51
r555 (  53 124 ) resistor r=9.3 //w=0.17 //l=0.17 //layer=mcon //count=1 \
 //x=31.2 //y=4.88 //x2=31.2 //y2=4.88
r556 (  53 54 ) resistor r=0.103207 //w=0.196 //l=0.14 //layer=m1 \
 //thickness=0.36 //x=31.202 //y=4.88 //x2=31.202 //y2=4.74
r557 (  50 115 ) resistor r=9.3 //w=0.17 //l=0.17 //layer=mcon //count=1 \
 //x=31.2 //y=2.26 //x2=31.2 //y2=2.26
r558 (  46 72 ) resistor r=4.5 //w=0.15 //l=0.15 //layer=via1 //count=1 \
 //x=31.195 //y=3.505 //x2=31.195 //y2=3.505
r559 (  46 48 ) resistor r=0.00167112 //w=0.374 //l=0.005 //layer=m1 \
 //thickness=0.36 //x=31.145 //y=3.505 //x2=31.145 //y2=3.51
r560 (  43 70 ) resistor r=4.5 //w=0.15 //l=0.15 //layer=via1 //count=1 \
 //x=29.345 //y=3.51 //x2=29.345 //y2=3.51
r561 (  40 187 ) resistor r=9.3 //w=0.17 //l=0.17 //layer=mcon //count=1 \
 //x=28.91 //y=1.18 //x2=28.91 //y2=1.18
r562 (  38 98 ) resistor r=9.3 //w=0.17 //l=0.17 //layer=mcon //count=1 \
 //x=28.87 //y=5.56 //x2=28.87 //y2=5.56
r563 (  35 38 ) resistor r=0.117801 //w=0.191 //l=0.18 //layer=m1 \
 //thickness=0.36 //x=28.87 //y=5.38 //x2=28.87 //y2=5.56
r564 (  34 90 ) resistor r=9.3 //w=0.17 //l=0.17 //layer=mcon //count=1 \
 //x=27.99 //y=5.56 //x2=27.99 //y2=5.56
r565 (  32 34 ) resistor r=0.10274 //w=0.219 //l=0.18 //layer=m1 \
 //thickness=0.36 //x=27.99 //y=5.38 //x2=27.99 //y2=5.56
r566 (  30 67 ) resistor r=4.5 //w=0.15 //l=0.15 //layer=via1 //count=1 \
 //x=25.285 //y=3.51 //x2=25.285 //y2=3.51
r567 (  28 85 ) resistor r=9.3 //w=0.17 //l=0.17 //layer=mcon //count=1 \
 //x=25.28 //y=4.88 //x2=25.28 //y2=4.88
r568 (  26 76 ) resistor r=9.3 //w=0.17 //l=0.17 //layer=mcon //count=1 \
 //x=25.28 //y=2.26 //x2=25.28 //y2=2.26
r569 (  23 48 ) resistor r=0.089409 //w=0.374 //l=0.180416 //layer=m1 \
 //thickness=0.36 //x=31.2 //y=3.665 //x2=31.145 //y2=3.51
r570 (  23 54 ) resistor r=1.02576 //w=0.131 //l=1.075 //layer=m1 \
 //thickness=0.36 //x=31.2 //y=3.665 //x2=31.2 //y2=4.74
r571 (  22 46 ) resistor r=0.0910802 //w=0.374 //l=0.185472 //layer=m1 \
 //thickness=0.36 //x=31.2 //y=3.345 //x2=31.145 //y2=3.505
r572 (  21 50 ) resistor r=0.0933015 //w=0.201 //l=0.125 //layer=m1 \
 //thickness=0.36 //x=31.2 //y=2.385 //x2=31.2 //y2=2.26
r573 (  21 22 ) resistor r=0.916031 //w=0.131 //l=0.96 //layer=m1 \
 //thickness=0.36 //x=31.2 //y=2.385 //x2=31.2 //y2=3.345
r574 (  19 43 ) resistor r=0.0910802 //w=0.374 //l=0.185472 //layer=m1 \
 //thickness=0.36 //x=29.35 //y=3.67 //x2=29.295 //y2=3.51
r575 (  19 20 ) resistor r=1.55057 //w=0.131 //l=1.625 //layer=m1 \
 //thickness=0.36 //x=29.35 //y=3.67 //x2=29.35 //y2=5.295
r576 (  18 43 ) resistor r=0.0910802 //w=0.374 //l=0.185472 //layer=m1 \
 //thickness=0.36 //x=29.35 //y=3.35 //x2=29.295 //y2=3.51
r577 (  17 18 ) resistor r=1.3645 //w=0.131 //l=1.43 //layer=m1 \
 //thickness=0.36 //x=29.35 //y=1.92 //x2=29.35 //y2=3.35
r578 (  15 17 ) resistor r=0.0698411 //w=0.17 //l=0.120208 //layer=m1 \
 //thickness=0.36 //x=29.265 //y=1.835 //x2=29.35 //y2=1.92
r579 (  15 16 ) resistor r=0.257634 //w=0.131 //l=0.27 //layer=m1 \
 //thickness=0.36 //x=29.265 //y=1.835 //x2=28.995 //y2=1.835
r580 (  14 35 ) resistor r=0.0257089 //w=0.23 //l=0.115 //layer=m1 \
 //thickness=0.36 //x=28.985 //y=5.38 //x2=28.87 //y2=5.38
r581 (  13 20 ) resistor r=0.0698411 //w=0.17 //l=0.120208 //layer=m1 \
 //thickness=0.36 //x=29.265 //y=5.38 //x2=29.35 //y2=5.295
r582 (  13 14 ) resistor r=0.267176 //w=0.131 //l=0.28 //layer=m1 \
 //thickness=0.36 //x=29.265 //y=5.38 //x2=28.985 //y2=5.38
r583 (  12 16 ) resistor r=0.0698411 //w=0.17 //l=0.120208 //layer=m1 \
 //thickness=0.36 //x=28.91 //y=1.75 //x2=28.995 //y2=1.835
r584 (  11 40 ) resistor r=0.0913624 //w=0.191 //l=0.12 //layer=m1 \
 //thickness=0.36 //x=28.91 //y=1.3 //x2=28.91 //y2=1.18
r585 (  11 12 ) resistor r=0.429389 //w=0.131 //l=0.45 //layer=m1 \
 //thickness=0.36 //x=28.91 //y=1.3 //x2=28.91 //y2=1.75
r586 (  8 32 ) resistor r=0.0227762 //w=0.219 //l=0.115 //layer=m1 \
 //thickness=0.36 //x=28.105 //y=5.38 //x2=27.99 //y2=5.38
r587 (  7 35 ) resistor r=0.0257089 //w=0.23 //l=0.115 //layer=m1 \
 //thickness=0.36 //x=28.755 //y=5.38 //x2=28.87 //y2=5.38
r588 (  7 8 ) resistor r=0.620229 //w=0.131 //l=0.65 //layer=m1 \
 //thickness=0.36 //x=28.755 //y=5.38 //x2=28.105 //y2=5.38
r589 (  4 28 ) resistor r=0.0801089 //w=0.224 //l=0.13 //layer=m1 \
 //thickness=0.36 //x=25.28 //y=4.75 //x2=25.28 //y2=4.88
r590 (  3 30 ) resistor r=0.0910802 //w=0.374 //l=0.185472 //layer=m1 \
 //thickness=0.36 //x=25.28 //y=3.67 //x2=25.335 //y2=3.51
r591 (  3 4 ) resistor r=1.03053 //w=0.131 //l=1.08 //layer=m1 \
 //thickness=0.36 //x=25.28 //y=3.67 //x2=25.28 //y2=4.75
r592 (  2 30 ) resistor r=0.0910802 //w=0.374 //l=0.185472 //layer=m1 \
 //thickness=0.36 //x=25.28 //y=3.35 //x2=25.335 //y2=3.51
r593 (  1 26 ) resistor r=0.0719237 //w=0.222 //l=0.115 //layer=m1 \
 //thickness=0.36 //x=25.28 //y=2.375 //x2=25.28 //y2=2.26
r594 (  1 2 ) resistor r=0.930344 //w=0.131 //l=0.975 //layer=m1 \
 //thickness=0.36 //x=25.28 //y=2.375 //x2=25.28 //y2=3.35
ends PM_TMRDFFQNX1\%noxref_7

subckt PM_TMRDFFQNX1\%noxref_8 ( 3 8 9 11 12 14 15 16 18 19 23 24 27 29 32 35 \
 38 41 42 44 45 50 53 61 78 87 91 92 93 94 95 96 97 101 103 106 107 117 120 \
 122 123 )
c288 ( 120 0 ) capacitor c=0.00878249f //x=32.05 //y=1.085
c289 ( 117 0 ) capacitor c=0.0682508f //x=34.53 //y=4.88
c290 ( 107 0 ) capacitor c=0.0318956f //x=34.865 //y=1.39
c291 ( 106 0 ) capacitor c=0.0186809f //x=34.865 //y=1.045
c292 ( 103 0 ) capacitor c=0.0141821f //x=34.71 //y=1.545
c293 ( 101 0 ) capacitor c=0.0158553f //x=34.71 //y=0.89
c294 ( 97 0 ) capacitor c=0.0854195f //x=34.335 //y=2.095
c295 ( 96 0 ) capacitor c=0.0229235f //x=34.335 //y=1.7
c296 ( 95 0 ) capacitor c=0.0234359f //x=34.335 //y=1.39
c297 ( 94 0 ) capacitor c=0.0198759f //x=34.335 //y=1.045
c298 ( 93 0 ) capacitor c=0.110369f //x=34.87 //y=6.2
c299 ( 92 0 ) capacitor c=0.154619f //x=34.43 //y=6.2
c300 ( 87 0 ) capacitor c=8.13425e-19 //x=34.53 //y=4.88
c301 ( 78 0 ) capacitor c=7.85889e-19 //x=34.53 //y=2.26
c302 ( 61 0 ) capacitor c=0.0322017f //x=32.2 //y=5.56
c303 ( 53 0 ) capacitor c=0.0291714f //x=31.32 //y=5.56
c304 ( 50 0 ) capacitor c=4.79804e-19 //x=34.525 //y=3.51
c305 ( 45 0 ) capacitor c=7.23354e-19 //x=32.845 //y=3.51
c306 ( 44 0 ) capacitor c=0.018923f //x=34.365 //y=3.51
c307 ( 42 0 ) capacitor c=0.0270852f //x=34.532 //y=4.74
c308 ( 41 0 ) capacitor c=0.0060492f //x=34.53 //y=4.88
c309 ( 38 0 ) capacitor c=0.00641145f //x=34.53 //y=2.26
c310 ( 35 0 ) capacitor c=0.0164425f //x=34.525 //y=3.51
c311 ( 32 0 ) capacitor c=0.0167895f //x=32.68 //y=3.51
c312 ( 29 0 ) capacitor c=0.0113735f //x=32.24 //y=1.18
c313 ( 27 0 ) capacitor c=5.78613e-19 //x=32.2 //y=5.56
c314 ( 24 0 ) capacitor c=0.0103127f //x=32.2 //y=5.38
c315 ( 23 0 ) capacitor c=0.00933334f //x=31.32 //y=5.56
c316 ( 19 0 ) capacitor c=0.0131458f //x=34.53 //y=3.67
c317 ( 18 0 ) capacitor c=0.0255439f //x=34.53 //y=3.35
c318 ( 16 0 ) capacitor c=0.0402141f //x=32.68 //y=5.295
c319 ( 15 0 ) capacitor c=0.0132742f //x=32.68 //y=3.67
c320 ( 14 0 ) capacitor c=0.0368956f //x=32.68 //y=3.35
c321 ( 12 0 ) capacitor c=0.00560492f //x=32.325 //y=1.835
c322 ( 11 0 ) capacitor c=0.0129728f //x=32.595 //y=1.835
c323 ( 9 0 ) capacitor c=0.0112475f //x=32.595 //y=5.38
c324 ( 8 0 ) capacitor c=0.0101547f //x=32.24 //y=1.75
c325 ( 3 0 ) capacitor c=0.0134484f //x=32.085 //y=5.38
r326 (  115 117 ) resistor r=20.6867 //w=0.233 //l=0.1 //layer=ply \
 //thickness=0.18 //x=34.43 //y=4.88 //x2=34.53 //y2=4.88
r327 (  108 117 ) resistor r=70.3348 //w=0.233 //l=0.414367 //layer=ply \
 //thickness=0.18 //x=34.87 //y=5.045 //x2=34.53 //y2=4.88
r328 (  107 119 ) resistor r=45.1352 //w=0.168 //l=0.173853 //layer=ply \
 //thickness=0.18 //x=34.865 //y=1.39 //x2=34.825 //y2=1.545
r329 (  106 118 ) resistor r=45.1352 //w=0.168 //l=0.173853 //layer=ply \
 //thickness=0.18 //x=34.865 //y=1.045 //x2=34.825 //y2=0.89
r330 (  106 107 ) resistor r=176.904 //w=0.094 //l=0.345 //layer=ply \
 //thickness=0.18 //x=34.865 //y=1.045 //x2=34.865 //y2=1.39
r331 (  104 114 ) resistor r=10.701 //w=0.21 //l=0.115 //layer=ply \
 //thickness=0.18 //x=34.49 //y=1.545 //x2=34.375 //y2=1.545
r332 (  103 119 ) resistor r=5.52526 //w=0.168 //l=0.115 //layer=ply \
 //thickness=0.18 //x=34.71 //y=1.545 //x2=34.825 //y2=1.545
r333 (  102 113 ) resistor r=5.52526 //w=0.168 //l=0.115 //layer=ply \
 //thickness=0.18 //x=34.49 //y=0.89 //x2=34.375 //y2=0.89
r334 (  101 118 ) resistor r=5.52526 //w=0.168 //l=0.115 //layer=ply \
 //thickness=0.18 //x=34.71 //y=0.89 //x2=34.825 //y2=0.89
r335 (  101 102 ) resistor r=112.809 //w=0.094 //l=0.22 //layer=ply \
 //thickness=0.18 //x=34.71 //y=0.89 //x2=34.49 //y2=0.89
r336 (  98 115 ) resistor r=13.0941 //w=0.233 //l=0.165 //layer=ply \
 //thickness=0.18 //x=34.43 //y=5.045 //x2=34.43 //y2=4.88
r337 (  97 112 ) resistor r=34.8111 //w=0.27 //l=0.264953 //layer=ply \
 //thickness=0.18 //x=34.335 //y=2.095 //x2=34.53 //y2=2.26
r338 (  96 114 ) resistor r=39.5823 //w=0.21 //l=0.173853 //layer=ply \
 //thickness=0.18 //x=34.335 //y=1.7 //x2=34.375 //y2=1.545
r339 (  96 97 ) resistor r=202.543 //w=0.094 //l=0.395 //layer=ply \
 //thickness=0.18 //x=34.335 //y=1.7 //x2=34.335 //y2=2.095
r340 (  95 114 ) resistor r=39.5823 //w=0.21 //l=0.173853 //layer=ply \
 //thickness=0.18 //x=34.335 //y=1.39 //x2=34.375 //y2=1.545
r341 (  94 113 ) resistor r=45.1352 //w=0.168 //l=0.173853 //layer=ply \
 //thickness=0.18 //x=34.335 //y=1.045 //x2=34.375 //y2=0.89
r342 (  94 95 ) resistor r=176.904 //w=0.094 //l=0.345 //layer=ply \
 //thickness=0.18 //x=34.335 //y=1.045 //x2=34.335 //y2=1.39
r343 (  93 108 ) resistor r=592.245 //w=0.094 //l=1.155 //layer=ply \
 //thickness=0.18 //x=34.87 //y=6.2 //x2=34.87 //y2=5.045
r344 (  92 98 ) resistor r=592.245 //w=0.094 //l=1.155 //layer=ply \
 //thickness=0.18 //x=34.43 //y=6.2 //x2=34.43 //y2=5.045
r345 (  91 103 ) resistor r=56.4043 //w=0.094 //l=0.11 //layer=ply \
 //thickness=0.18 //x=34.6 //y=1.545 //x2=34.71 //y2=1.545
r346 (  91 104 ) resistor r=56.4043 //w=0.094 //l=0.11 //layer=ply \
 //thickness=0.18 //x=34.6 //y=1.545 //x2=34.49 //y2=1.545
r347 (  87 117 ) resistor r=152 //w=0.17 //l=0.17 //layer=licon //count=1 \
 //x=34.53 //y=4.88 //x2=34.53 //y2=4.88
r348 (  78 112 ) resistor r=152 //w=0.17 //l=0.17 //layer=licon //count=1 \
 //x=34.53 //y=2.26 //x2=34.53 //y2=2.26
r349 (  61 123 ) resistor r=23.615 //w=0.187 //l=0.345 //layer=li \
 //thickness=0.1 //x=32.2 //y=5.56 //x2=32.2 //y2=5.905
r350 (  53 122 ) resistor r=23.615 //w=0.187 //l=0.345 //layer=li \
 //thickness=0.1 //x=31.32 //y=5.56 //x2=31.32 //y2=5.905
r351 (  45 47 ) resistor r=0.10734 //w=0.281 //l=0.16 //layer=m2 \
 //thickness=0.36 //x=32.845 //y=3.51 //x2=32.685 //y2=3.51
r352 (  44 50 ) resistor r=0.10734 //w=0.281 //l=0.16 //layer=m2 \
 //thickness=0.36 //x=34.365 //y=3.51 //x2=34.525 //y2=3.51
r353 (  44 45 ) resistor r=1.45038 //w=0.131 //l=1.52 //layer=m2 \
 //thickness=0.36 //x=34.365 //y=3.51 //x2=32.845 //y2=3.51
r354 (  41 87 ) resistor r=9.3 //w=0.17 //l=0.17 //layer=mcon //count=1 \
 //x=34.53 //y=4.88 //x2=34.53 //y2=4.88
r355 (  41 42 ) resistor r=0.103207 //w=0.196 //l=0.14 //layer=m1 \
 //thickness=0.36 //x=34.532 //y=4.88 //x2=34.532 //y2=4.74
r356 (  38 78 ) resistor r=9.3 //w=0.17 //l=0.17 //layer=mcon //count=1 \
 //x=34.53 //y=2.26 //x2=34.53 //y2=2.26
r357 (  35 50 ) resistor r=4.5 //w=0.15 //l=0.15 //layer=via1 //count=1 \
 //x=34.525 //y=3.51 //x2=34.525 //y2=3.51
r358 (  32 47 ) resistor r=4.5 //w=0.15 //l=0.15 //layer=via1 //count=1 \
 //x=32.685 //y=3.51 //x2=32.685 //y2=3.51
r359 (  29 120 ) resistor r=9.3 //w=0.17 //l=0.17 //layer=mcon //count=1 \
 //x=32.24 //y=1.18 //x2=32.24 //y2=1.18
r360 (  27 61 ) resistor r=9.3 //w=0.17 //l=0.17 //layer=mcon //count=1 \
 //x=32.2 //y=5.56 //x2=32.2 //y2=5.56
r361 (  24 27 ) resistor r=0.117801 //w=0.191 //l=0.18 //layer=m1 \
 //thickness=0.36 //x=32.2 //y=5.38 //x2=32.2 //y2=5.56
r362 (  23 53 ) resistor r=9.3 //w=0.17 //l=0.17 //layer=mcon //count=1 \
 //x=31.32 //y=5.56 //x2=31.32 //y2=5.56
r363 (  21 23 ) resistor r=0.10274 //w=0.219 //l=0.18 //layer=m1 \
 //thickness=0.36 //x=31.32 //y=5.38 //x2=31.32 //y2=5.56
r364 (  19 35 ) resistor r=0.0910802 //w=0.374 //l=0.185472 //layer=m1 \
 //thickness=0.36 //x=34.53 //y=3.67 //x2=34.475 //y2=3.51
r365 (  19 42 ) resistor r=1.02099 //w=0.131 //l=1.07 //layer=m1 \
 //thickness=0.36 //x=34.53 //y=3.67 //x2=34.53 //y2=4.74
r366 (  18 35 ) resistor r=0.0910802 //w=0.374 //l=0.185472 //layer=m1 \
 //thickness=0.36 //x=34.53 //y=3.35 //x2=34.475 //y2=3.51
r367 (  17 38 ) resistor r=0.0933015 //w=0.201 //l=0.125 //layer=m1 \
 //thickness=0.36 //x=34.53 //y=2.385 //x2=34.53 //y2=2.26
r368 (  17 18 ) resistor r=0.920802 //w=0.131 //l=0.965 //layer=m1 \
 //thickness=0.36 //x=34.53 //y=2.385 //x2=34.53 //y2=3.35
r369 (  15 32 ) resistor r=0.0910802 //w=0.374 //l=0.185472 //layer=m1 \
 //thickness=0.36 //x=32.68 //y=3.67 //x2=32.735 //y2=3.51
r370 (  15 16 ) resistor r=1.55057 //w=0.131 //l=1.625 //layer=m1 \
 //thickness=0.36 //x=32.68 //y=3.67 //x2=32.68 //y2=5.295
r371 (  14 32 ) resistor r=0.0910802 //w=0.374 //l=0.185472 //layer=m1 \
 //thickness=0.36 //x=32.68 //y=3.35 //x2=32.735 //y2=3.51
r372 (  13 14 ) resistor r=1.3645 //w=0.131 //l=1.43 //layer=m1 \
 //thickness=0.36 //x=32.68 //y=1.92 //x2=32.68 //y2=3.35
r373 (  11 13 ) resistor r=0.0698411 //w=0.17 //l=0.120208 //layer=m1 \
 //thickness=0.36 //x=32.595 //y=1.835 //x2=32.68 //y2=1.92
r374 (  11 12 ) resistor r=0.257634 //w=0.131 //l=0.27 //layer=m1 \
 //thickness=0.36 //x=32.595 //y=1.835 //x2=32.325 //y2=1.835
r375 (  10 24 ) resistor r=0.0257089 //w=0.23 //l=0.115 //layer=m1 \
 //thickness=0.36 //x=32.315 //y=5.38 //x2=32.2 //y2=5.38
r376 (  9 16 ) resistor r=0.0698411 //w=0.17 //l=0.120208 //layer=m1 \
 //thickness=0.36 //x=32.595 //y=5.38 //x2=32.68 //y2=5.295
r377 (  9 10 ) resistor r=0.267176 //w=0.131 //l=0.28 //layer=m1 \
 //thickness=0.36 //x=32.595 //y=5.38 //x2=32.315 //y2=5.38
r378 (  8 12 ) resistor r=0.0698411 //w=0.17 //l=0.120208 //layer=m1 \
 //thickness=0.36 //x=32.24 //y=1.75 //x2=32.325 //y2=1.835
r379 (  7 29 ) resistor r=0.0913624 //w=0.191 //l=0.12 //layer=m1 \
 //thickness=0.36 //x=32.24 //y=1.3 //x2=32.24 //y2=1.18
r380 (  7 8 ) resistor r=0.429389 //w=0.131 //l=0.45 //layer=m1 \
 //thickness=0.36 //x=32.24 //y=1.3 //x2=32.24 //y2=1.75
r381 (  4 21 ) resistor r=0.0227762 //w=0.219 //l=0.115 //layer=m1 \
 //thickness=0.36 //x=31.435 //y=5.38 //x2=31.32 //y2=5.38
r382 (  3 24 ) resistor r=0.0257089 //w=0.23 //l=0.115 //layer=m1 \
 //thickness=0.36 //x=32.085 //y=5.38 //x2=32.2 //y2=5.38
r383 (  3 4 ) resistor r=0.620229 //w=0.131 //l=0.65 //layer=m1 \
 //thickness=0.36 //x=32.085 //y=5.38 //x2=31.435 //y2=5.38
ends PM_TMRDFFQNX1\%noxref_8

subckt PM_TMRDFFQNX1\%noxref_9 ( 1 3 6 7 9 10 11 12 14 15 16 18 19 22 23 25 28 \
 31 37 40 43 46 47 50 54 57 58 60 61 62 63 64 66 68 70 72 74 84 92 100 117 126 \
 131 140 144 145 146 147 148 149 150 151 152 153 157 159 162 163 167 168 169 \
 170 174 176 179 180 190 199 202 204 205 206 )
c490 ( 202 0 ) capacitor c=0.00885916f //x=25.345 //y=1.095
c491 ( 199 0 ) capacitor c=0.0645411f //x=37.86 //y=4.88
c492 ( 190 0 ) capacitor c=0.0645923f //x=27.87 //y=4.88
c493 ( 180 0 ) capacitor c=0.0318956f //x=38.195 //y=1.39
c494 ( 179 0 ) capacitor c=0.0186809f //x=38.195 //y=1.045
c495 ( 176 0 ) capacitor c=0.0141821f //x=38.04 //y=1.545
c496 ( 174 0 ) capacitor c=0.0158553f //x=38.04 //y=0.89
c497 ( 170 0 ) capacitor c=0.088055f //x=37.665 //y=2.095
c498 ( 169 0 ) capacitor c=0.0229235f //x=37.665 //y=1.7
c499 ( 168 0 ) capacitor c=0.0234359f //x=37.665 //y=1.39
c500 ( 167 0 ) capacitor c=0.0198759f //x=37.665 //y=1.045
c501 ( 163 0 ) capacitor c=0.0318956f //x=28.205 //y=1.39
c502 ( 162 0 ) capacitor c=0.0186809f //x=28.205 //y=1.045
c503 ( 159 0 ) capacitor c=0.0141821f //x=28.05 //y=1.545
c504 ( 157 0 ) capacitor c=0.0158553f //x=28.05 //y=0.89
c505 ( 153 0 ) capacitor c=0.088055f //x=27.675 //y=2.095
c506 ( 152 0 ) capacitor c=0.0229235f //x=27.675 //y=1.7
c507 ( 151 0 ) capacitor c=0.0234359f //x=27.675 //y=1.39
c508 ( 150 0 ) capacitor c=0.0198759f //x=27.675 //y=1.045
c509 ( 149 0 ) capacitor c=0.110369f //x=38.2 //y=6.2
c510 ( 148 0 ) capacitor c=0.154619f //x=37.76 //y=6.2
c511 ( 147 0 ) capacitor c=0.110369f //x=28.21 //y=6.2
c512 ( 146 0 ) capacitor c=0.154619f //x=27.77 //y=6.2
c513 ( 140 0 ) capacitor c=8.13425e-19 //x=37.86 //y=4.88
c514 ( 131 0 ) capacitor c=7.85889e-19 //x=37.86 //y=2.26
c515 ( 126 0 ) capacitor c=8.13425e-19 //x=27.87 //y=4.88
c516 ( 117 0 ) capacitor c=7.85889e-19 //x=27.87 //y=2.26
c517 ( 100 0 ) capacitor c=0.0293071f //x=25.24 //y=5.56
c518 ( 92 0 ) capacitor c=0.029137f //x=24.36 //y=5.56
c519 ( 84 0 ) capacitor c=0.0277605f //x=23.48 //y=5.56
c520 ( 74 0 ) capacitor c=0.0403878f //x=34.74 //y=3.895
c521 ( 72 0 ) capacitor c=0.0175525f //x=34.14 //y=3.88
c522 ( 70 0 ) capacitor c=0.00418974f //x=32.9 //y=3.895
c523 ( 68 0 ) capacitor c=0.00769994f //x=32.16 //y=3.87
c524 ( 66 0 ) capacitor c=0.005471f //x=31.41 //y=3.89
c525 ( 64 0 ) capacitor c=0.0178779f //x=30.81 //y=3.88
c526 ( 63 0 ) capacitor c=0.0100722f //x=29.215 //y=3.895
c527 ( 62 0 ) capacitor c=0.00477746f //x=29.56 //y=3.895
c528 ( 61 0 ) capacitor c=7.05145e-19 //x=26.18 //y=3.88
c529 ( 60 0 ) capacitor c=0.0193144f //x=27.705 //y=3.88
c530 ( 58 0 ) capacitor c=0.0161369f //x=37.862 //y=4.74
c531 ( 57 0 ) capacitor c=0.00598189f //x=37.86 //y=4.88
c532 ( 54 0 ) capacitor c=0.00648848f //x=37.86 //y=2.26
c533 ( 50 0 ) capacitor c=0.0159231f //x=37.86 //y=3.88
c534 ( 47 0 ) capacitor c=0.0172769f //x=27.872 //y=4.74
c535 ( 46 0 ) capacitor c=0.00598357f //x=27.87 //y=4.88
c536 ( 43 0 ) capacitor c=0.00654649f //x=27.87 //y=2.26
c537 ( 40 0 ) capacitor c=0.0163193f //x=27.865 //y=3.88
c538 ( 37 0 ) capacitor c=0.0170864f //x=26.02 //y=3.88
c539 ( 31 0 ) capacitor c=9.55882e-19 //x=25.24 //y=5.335
c540 ( 28 0 ) capacitor c=0.00753245f //x=24.36 //y=5.335
c541 ( 25 0 ) capacitor c=0.0112819f //x=23.482 //y=5.335
c542 ( 23 0 ) capacitor c=0.0125875f //x=37.86 //y=4.045
c543 ( 22 0 ) capacitor c=0.0393416f //x=37.86 //y=3.725
c544 ( 19 0 ) capacitor c=0.0123877f //x=27.87 //y=4.04
c545 ( 18 0 ) capacitor c=0.0342437f //x=27.87 //y=3.72
c546 ( 16 0 ) capacitor c=0.0309857f //x=26.02 //y=5.25
c547 ( 15 0 ) capacitor c=0.0132732f //x=26.02 //y=4.04
c548 ( 14 0 ) capacitor c=0.047407f //x=26.02 //y=3.72
c549 ( 12 0 ) capacitor c=0.00521328f //x=25.62 //y=1.845
c550 ( 11 0 ) capacitor c=0.0145678f //x=25.935 //y=1.845
c551 ( 10 0 ) capacitor c=0.013549f //x=25.535 //y=1.76
c552 ( 9 0 ) capacitor c=0.0111993f //x=25.535 //y=1.305
c553 ( 7 0 ) capacitor c=0.0228253f //x=25.935 //y=5.335
c554 ( 6 0 ) capacitor c=0.00906713f //x=25.24 //y=5.56
c555 ( 3 0 ) capacitor c=0.019596f //x=25.125 //y=5.335
c556 ( 1 0 ) capacitor c=0.014788f //x=24.24 //y=5.335
r557 (  197 199 ) resistor r=20.6867 //w=0.233 //l=0.1 //layer=ply \
 //thickness=0.18 //x=37.76 //y=4.88 //x2=37.86 //y2=4.88
r558 (  188 190 ) resistor r=20.6867 //w=0.233 //l=0.1 //layer=ply \
 //thickness=0.18 //x=27.77 //y=4.88 //x2=27.87 //y2=4.88
r559 (  181 199 ) resistor r=70.3348 //w=0.233 //l=0.414367 //layer=ply \
 //thickness=0.18 //x=38.2 //y=5.045 //x2=37.86 //y2=4.88
r560 (  180 201 ) resistor r=45.1352 //w=0.168 //l=0.173853 //layer=ply \
 //thickness=0.18 //x=38.195 //y=1.39 //x2=38.155 //y2=1.545
r561 (  179 200 ) resistor r=45.1352 //w=0.168 //l=0.173853 //layer=ply \
 //thickness=0.18 //x=38.195 //y=1.045 //x2=38.155 //y2=0.89
r562 (  179 180 ) resistor r=176.904 //w=0.094 //l=0.345 //layer=ply \
 //thickness=0.18 //x=38.195 //y=1.045 //x2=38.195 //y2=1.39
r563 (  177 196 ) resistor r=10.701 //w=0.21 //l=0.115 //layer=ply \
 //thickness=0.18 //x=37.82 //y=1.545 //x2=37.705 //y2=1.545
r564 (  176 201 ) resistor r=5.52526 //w=0.168 //l=0.115 //layer=ply \
 //thickness=0.18 //x=38.04 //y=1.545 //x2=38.155 //y2=1.545
r565 (  175 195 ) resistor r=5.52526 //w=0.168 //l=0.115 //layer=ply \
 //thickness=0.18 //x=37.82 //y=0.89 //x2=37.705 //y2=0.89
r566 (  174 200 ) resistor r=5.52526 //w=0.168 //l=0.115 //layer=ply \
 //thickness=0.18 //x=38.04 //y=0.89 //x2=38.155 //y2=0.89
r567 (  174 175 ) resistor r=112.809 //w=0.094 //l=0.22 //layer=ply \
 //thickness=0.18 //x=38.04 //y=0.89 //x2=37.82 //y2=0.89
r568 (  171 197 ) resistor r=13.0941 //w=0.233 //l=0.165 //layer=ply \
 //thickness=0.18 //x=37.76 //y=5.045 //x2=37.76 //y2=4.88
r569 (  170 194 ) resistor r=34.8111 //w=0.27 //l=0.264953 //layer=ply \
 //thickness=0.18 //x=37.665 //y=2.095 //x2=37.86 //y2=2.26
r570 (  169 196 ) resistor r=39.5823 //w=0.21 //l=0.173853 //layer=ply \
 //thickness=0.18 //x=37.665 //y=1.7 //x2=37.705 //y2=1.545
r571 (  169 170 ) resistor r=202.543 //w=0.094 //l=0.395 //layer=ply \
 //thickness=0.18 //x=37.665 //y=1.7 //x2=37.665 //y2=2.095
r572 (  168 196 ) resistor r=39.5823 //w=0.21 //l=0.173853 //layer=ply \
 //thickness=0.18 //x=37.665 //y=1.39 //x2=37.705 //y2=1.545
r573 (  167 195 ) resistor r=45.1352 //w=0.168 //l=0.173853 //layer=ply \
 //thickness=0.18 //x=37.665 //y=1.045 //x2=37.705 //y2=0.89
r574 (  167 168 ) resistor r=176.904 //w=0.094 //l=0.345 //layer=ply \
 //thickness=0.18 //x=37.665 //y=1.045 //x2=37.665 //y2=1.39
r575 (  164 190 ) resistor r=70.3348 //w=0.233 //l=0.414367 //layer=ply \
 //thickness=0.18 //x=28.21 //y=5.045 //x2=27.87 //y2=4.88
r576 (  163 192 ) resistor r=45.1352 //w=0.168 //l=0.173853 //layer=ply \
 //thickness=0.18 //x=28.205 //y=1.39 //x2=28.165 //y2=1.545
r577 (  162 191 ) resistor r=45.1352 //w=0.168 //l=0.173853 //layer=ply \
 //thickness=0.18 //x=28.205 //y=1.045 //x2=28.165 //y2=0.89
r578 (  162 163 ) resistor r=176.904 //w=0.094 //l=0.345 //layer=ply \
 //thickness=0.18 //x=28.205 //y=1.045 //x2=28.205 //y2=1.39
r579 (  160 187 ) resistor r=10.701 //w=0.21 //l=0.115 //layer=ply \
 //thickness=0.18 //x=27.83 //y=1.545 //x2=27.715 //y2=1.545
r580 (  159 192 ) resistor r=5.52526 //w=0.168 //l=0.115 //layer=ply \
 //thickness=0.18 //x=28.05 //y=1.545 //x2=28.165 //y2=1.545
r581 (  158 186 ) resistor r=5.52526 //w=0.168 //l=0.115 //layer=ply \
 //thickness=0.18 //x=27.83 //y=0.89 //x2=27.715 //y2=0.89
r582 (  157 191 ) resistor r=5.52526 //w=0.168 //l=0.115 //layer=ply \
 //thickness=0.18 //x=28.05 //y=0.89 //x2=28.165 //y2=0.89
r583 (  157 158 ) resistor r=112.809 //w=0.094 //l=0.22 //layer=ply \
 //thickness=0.18 //x=28.05 //y=0.89 //x2=27.83 //y2=0.89
r584 (  154 188 ) resistor r=13.0941 //w=0.233 //l=0.165 //layer=ply \
 //thickness=0.18 //x=27.77 //y=5.045 //x2=27.77 //y2=4.88
r585 (  153 185 ) resistor r=34.8111 //w=0.27 //l=0.264953 //layer=ply \
 //thickness=0.18 //x=27.675 //y=2.095 //x2=27.87 //y2=2.26
r586 (  152 187 ) resistor r=39.5823 //w=0.21 //l=0.173853 //layer=ply \
 //thickness=0.18 //x=27.675 //y=1.7 //x2=27.715 //y2=1.545
r587 (  152 153 ) resistor r=202.543 //w=0.094 //l=0.395 //layer=ply \
 //thickness=0.18 //x=27.675 //y=1.7 //x2=27.675 //y2=2.095
r588 (  151 187 ) resistor r=39.5823 //w=0.21 //l=0.173853 //layer=ply \
 //thickness=0.18 //x=27.675 //y=1.39 //x2=27.715 //y2=1.545
r589 (  150 186 ) resistor r=45.1352 //w=0.168 //l=0.173853 //layer=ply \
 //thickness=0.18 //x=27.675 //y=1.045 //x2=27.715 //y2=0.89
r590 (  150 151 ) resistor r=176.904 //w=0.094 //l=0.345 //layer=ply \
 //thickness=0.18 //x=27.675 //y=1.045 //x2=27.675 //y2=1.39
r591 (  149 181 ) resistor r=592.245 //w=0.094 //l=1.155 //layer=ply \
 //thickness=0.18 //x=38.2 //y=6.2 //x2=38.2 //y2=5.045
r592 (  148 171 ) resistor r=592.245 //w=0.094 //l=1.155 //layer=ply \
 //thickness=0.18 //x=37.76 //y=6.2 //x2=37.76 //y2=5.045
r593 (  147 164 ) resistor r=592.245 //w=0.094 //l=1.155 //layer=ply \
 //thickness=0.18 //x=28.21 //y=6.2 //x2=28.21 //y2=5.045
r594 (  146 154 ) resistor r=592.245 //w=0.094 //l=1.155 //layer=ply \
 //thickness=0.18 //x=27.77 //y=6.2 //x2=27.77 //y2=5.045
r595 (  145 176 ) resistor r=56.4043 //w=0.094 //l=0.11 //layer=ply \
 //thickness=0.18 //x=37.93 //y=1.545 //x2=38.04 //y2=1.545
r596 (  145 177 ) resistor r=56.4043 //w=0.094 //l=0.11 //layer=ply \
 //thickness=0.18 //x=37.93 //y=1.545 //x2=37.82 //y2=1.545
r597 (  144 159 ) resistor r=56.4043 //w=0.094 //l=0.11 //layer=ply \
 //thickness=0.18 //x=27.94 //y=1.545 //x2=28.05 //y2=1.545
r598 (  144 160 ) resistor r=56.4043 //w=0.094 //l=0.11 //layer=ply \
 //thickness=0.18 //x=27.94 //y=1.545 //x2=27.83 //y2=1.545
r599 (  140 199 ) resistor r=152 //w=0.17 //l=0.17 //layer=licon //count=1 \
 //x=37.86 //y=4.88 //x2=37.86 //y2=4.88
r600 (  131 194 ) resistor r=152 //w=0.17 //l=0.17 //layer=licon //count=1 \
 //x=37.86 //y=2.26 //x2=37.86 //y2=2.26
r601 (  126 190 ) resistor r=152 //w=0.17 //l=0.17 //layer=licon //count=1 \
 //x=27.87 //y=4.88 //x2=27.87 //y2=4.88
r602 (  117 185 ) resistor r=152 //w=0.17 //l=0.17 //layer=licon //count=1 \
 //x=27.87 //y=2.26 //x2=27.87 //y2=2.26
r603 (  100 206 ) resistor r=23.615 //w=0.187 //l=0.345 //layer=li \
 //thickness=0.1 //x=25.24 //y=5.56 //x2=25.24 //y2=5.905
r604 (  92 205 ) resistor r=23.615 //w=0.187 //l=0.345 //layer=li \
 //thickness=0.1 //x=24.36 //y=5.56 //x2=24.36 //y2=5.905
r605 (  84 204 ) resistor r=23.615 //w=0.187 //l=0.345 //layer=li \
 //thickness=0.1 //x=23.48 //y=5.56 //x2=23.48 //y2=5.905
r606 (  74 82 ) resistor r=2.10915 //w=0.185 //l=3.125 //layer=m2 \
 //thickness=0.36 //x=34.74 //y=3.895 //x2=37.86 //y2=3.885
r607 (  74 75 ) resistor r=0.329198 //w=0.131 //l=0.345 //layer=m2 \
 //thickness=0.36 //x=34.74 //y=3.895 //x2=34.395 //y2=3.895
r608 (  72 75 ) resistor r=0.1875 //w=0.17 //l=0.262393 //layer=m2 \
 //thickness=0.36 //x=34.14 //y=3.88 //x2=34.395 //y2=3.895
r609 (  72 73 ) resistor r=1.02099 //w=0.131 //l=1.07 //layer=m2 \
 //thickness=0.36 //x=34.14 //y=3.88 //x2=33.07 //y2=3.88
r610 (  70 73 ) resistor r=0.125 //w=0.17 //l=0.177341 //layer=m2 \
 //thickness=0.36 //x=32.9 //y=3.895 //x2=33.07 //y2=3.88
r611 (  70 71 ) resistor r=0.329198 //w=0.131 //l=0.345 //layer=m2 \
 //thickness=0.36 //x=32.9 //y=3.895 //x2=32.555 //y2=3.895
r612 (  68 71 ) resistor r=0.290441 //w=0.17 //l=0.407308 //layer=m2 \
 //thickness=0.36 //x=32.16 //y=3.87 //x2=32.555 //y2=3.895
r613 (  68 69 ) resistor r=0.410305 //w=0.131 //l=0.43 //layer=m2 \
 //thickness=0.36 //x=32.16 //y=3.87 //x2=31.73 //y2=3.87
r614 (  66 69 ) resistor r=0.235294 //w=0.17 //l=0.329848 //layer=m2 \
 //thickness=0.36 //x=31.41 //y=3.89 //x2=31.73 //y2=3.87
r615 (  66 67 ) resistor r=0.329198 //w=0.131 //l=0.345 //layer=m2 \
 //thickness=0.36 //x=31.41 //y=3.89 //x2=31.065 //y2=3.89
r616 (  64 67 ) resistor r=0.1875 //w=0.17 //l=0.259952 //layer=m2 \
 //thickness=0.36 //x=30.81 //y=3.88 //x2=31.065 //y2=3.89
r617 (  64 65 ) resistor r=1.03053 //w=0.131 //l=1.08 //layer=m2 \
 //thickness=0.36 //x=30.81 //y=3.88 //x2=29.73 //y2=3.88
r618 (  63 80 ) resistor r=0.838898 //w=0.202 //l=1.35748 //layer=m2 \
 //thickness=0.36 //x=29.215 //y=3.895 //x2=27.865 //y2=3.88
r619 (  62 65 ) resistor r=0.125 //w=0.17 //l=0.177341 //layer=m2 \
 //thickness=0.36 //x=29.56 //y=3.895 //x2=29.73 //y2=3.88
r620 (  62 63 ) resistor r=0.329198 //w=0.131 //l=0.345 //layer=m2 \
 //thickness=0.36 //x=29.56 //y=3.895 //x2=29.215 //y2=3.895
r621 (  61 77 ) resistor r=0.10734 //w=0.281 //l=0.16 //layer=m2 \
 //thickness=0.36 //x=26.18 //y=3.88 //x2=26.02 //y2=3.88
r622 (  60 80 ) resistor r=0.102512 //w=0.202 //l=0.16 //layer=m2 \
 //thickness=0.36 //x=27.705 //y=3.88 //x2=27.865 //y2=3.88
r623 (  60 61 ) resistor r=1.45515 //w=0.131 //l=1.525 //layer=m2 \
 //thickness=0.36 //x=27.705 //y=3.88 //x2=26.18 //y2=3.88
r624 (  57 140 ) resistor r=9.3 //w=0.17 //l=0.17 //layer=mcon //count=1 \
 //x=37.86 //y=4.88 //x2=37.86 //y2=4.88
r625 (  57 58 ) resistor r=0.103207 //w=0.196 //l=0.14 //layer=m1 \
 //thickness=0.36 //x=37.862 //y=4.88 //x2=37.862 //y2=4.74
r626 (  54 131 ) resistor r=9.3 //w=0.17 //l=0.17 //layer=mcon //count=1 \
 //x=37.86 //y=2.26 //x2=37.86 //y2=2.26
r627 (  52 82 ) resistor r=4.5 //w=0.15 //l=0.15 //layer=via1 //count=1 \
 //x=37.86 //y=3.885 //x2=37.86 //y2=3.885
r628 (  50 52 ) resistor r=0.00166223 //w=0.376 //l=0.005 //layer=m1 \
 //thickness=0.36 //x=37.807 //y=3.88 //x2=37.807 //y2=3.885
r629 (  46 126 ) resistor r=9.3 //w=0.17 //l=0.17 //layer=mcon //count=1 \
 //x=27.87 //y=4.88 //x2=27.87 //y2=4.88
r630 (  46 47 ) resistor r=0.103207 //w=0.196 //l=0.14 //layer=m1 \
 //thickness=0.36 //x=27.872 //y=4.88 //x2=27.872 //y2=4.74
r631 (  43 117 ) resistor r=9.3 //w=0.17 //l=0.17 //layer=mcon //count=1 \
 //x=27.87 //y=2.26 //x2=27.87 //y2=2.26
r632 (  40 80 ) resistor r=4.5 //w=0.15 //l=0.15 //layer=via1 //count=1 \
 //x=27.865 //y=3.88 //x2=27.865 //y2=3.88
r633 (  37 77 ) resistor r=4.5 //w=0.15 //l=0.15 //layer=via1 //count=1 \
 //x=26.02 //y=3.88 //x2=26.02 //y2=3.88
r634 (  35 202 ) resistor r=9.3 //w=0.17 //l=0.17 //layer=mcon //count=1 \
 //x=25.535 //y=1.19 //x2=25.535 //y2=1.19
r635 (  33 100 ) resistor r=9.3 //w=0.17 //l=0.17 //layer=mcon //count=1 \
 //x=25.24 //y=5.56 //x2=25.24 //y2=5.56
r636 (  30 92 ) resistor r=9.3 //w=0.17 //l=0.17 //layer=mcon //count=1 \
 //x=24.36 //y=5.56 //x2=24.36 //y2=5.56
r637 (  28 30 ) resistor r=0.121228 //w=0.232 //l=0.225 //layer=m1 \
 //thickness=0.36 //x=24.36 //y=5.335 //x2=24.36 //y2=5.56
r638 (  27 84 ) resistor r=9.3 //w=0.17 //l=0.17 //layer=mcon //count=1 \
 //x=23.48 //y=5.56 //x2=23.48 //y2=5.56
r639 (  25 27 ) resistor r=0.129608 //w=0.217 //l=0.225 //layer=m1 \
 //thickness=0.36 //x=23.482 //y=5.335 //x2=23.482 //y2=5.56
r640 (  23 52 ) resistor r=0.0911593 //w=0.376 //l=0.184608 //layer=m1 \
 //thickness=0.36 //x=37.86 //y=4.045 //x2=37.807 //y2=3.885
r641 (  23 58 ) resistor r=0.663168 //w=0.131 //l=0.695 //layer=m1 \
 //thickness=0.36 //x=37.86 //y=4.045 //x2=37.86 //y2=4.74
r642 (  22 50 ) resistor r=0.0894971 //w=0.376 //l=0.179555 //layer=m1 \
 //thickness=0.36 //x=37.86 //y=3.725 //x2=37.807 //y2=3.88
r643 (  21 54 ) resistor r=0.0933015 //w=0.201 //l=0.125 //layer=m1 \
 //thickness=0.36 //x=37.86 //y=2.385 //x2=37.86 //y2=2.26
r644 (  21 22 ) resistor r=1.27863 //w=0.131 //l=1.34 //layer=m1 \
 //thickness=0.36 //x=37.86 //y=2.385 //x2=37.86 //y2=3.725
r645 (  19 40 ) resistor r=0.0910802 //w=0.374 //l=0.185472 //layer=m1 \
 //thickness=0.36 //x=27.87 //y=4.04 //x2=27.815 //y2=3.88
r646 (  19 47 ) resistor r=0.667939 //w=0.131 //l=0.7 //layer=m1 \
 //thickness=0.36 //x=27.87 //y=4.04 //x2=27.87 //y2=4.74
r647 (  18 40 ) resistor r=0.0910802 //w=0.374 //l=0.185472 //layer=m1 \
 //thickness=0.36 //x=27.87 //y=3.72 //x2=27.815 //y2=3.88
r648 (  17 43 ) resistor r=0.0933015 //w=0.201 //l=0.125 //layer=m1 \
 //thickness=0.36 //x=27.87 //y=2.385 //x2=27.87 //y2=2.26
r649 (  17 18 ) resistor r=1.27385 //w=0.131 //l=1.335 //layer=m1 \
 //thickness=0.36 //x=27.87 //y=2.385 //x2=27.87 //y2=3.72
r650 (  15 37 ) resistor r=0.0911593 //w=0.376 //l=0.184174 //layer=m1 \
 //thickness=0.36 //x=26.02 //y=4.04 //x2=26.072 //y2=3.88
r651 (  15 16 ) resistor r=1.15458 //w=0.131 //l=1.21 //layer=m1 \
 //thickness=0.36 //x=26.02 //y=4.04 //x2=26.02 //y2=5.25
r652 (  14 37 ) resistor r=0.0911593 //w=0.376 //l=0.184174 //layer=m1 \
 //thickness=0.36 //x=26.02 //y=3.72 //x2=26.072 //y2=3.88
r653 (  13 14 ) resistor r=1.70802 //w=0.131 //l=1.79 //layer=m1 \
 //thickness=0.36 //x=26.02 //y=1.93 //x2=26.02 //y2=3.72
r654 (  11 13 ) resistor r=0.0698411 //w=0.17 //l=0.120208 //layer=m1 \
 //thickness=0.36 //x=25.935 //y=1.845 //x2=26.02 //y2=1.93
r655 (  11 12 ) resistor r=0.300573 //w=0.131 //l=0.315 //layer=m1 \
 //thickness=0.36 //x=25.935 //y=1.845 //x2=25.62 //y2=1.845
r656 (  10 12 ) resistor r=0.0698411 //w=0.17 //l=0.120208 //layer=m1 \
 //thickness=0.36 //x=25.535 //y=1.76 //x2=25.62 //y2=1.845
r657 (  9 35 ) resistor r=0.0717383 //w=0.224 //l=0.115 //layer=m1 \
 //thickness=0.36 //x=25.535 //y=1.305 //x2=25.535 //y2=1.19
r658 (  9 10 ) resistor r=0.43416 //w=0.131 //l=0.455 //layer=m1 \
 //thickness=0.36 //x=25.535 //y=1.305 //x2=25.535 //y2=1.76
r659 (  8 31 ) resistor r=0.0675342 //w=0.23 //l=0.115 //layer=m1 \
 //thickness=0.36 //x=25.355 //y=5.335 //x2=25.24 //y2=5.335
r660 (  7 16 ) resistor r=0.0698411 //w=0.17 //l=0.120208 //layer=m1 \
 //thickness=0.36 //x=25.935 //y=5.335 //x2=26.02 //y2=5.25
r661 (  7 8 ) resistor r=0.553435 //w=0.131 //l=0.58 //layer=m1 \
 //thickness=0.36 //x=25.935 //y=5.335 //x2=25.355 //y2=5.335
r662 (  6 33 ) resistor r=0.00118313 //w=0.23 //layer=m1 //thickness=0.36 \
 //x=25.24 //y=5.56 //x2=25.24 //y2=5.56
r663 (  5 31 ) resistor r=0.002872 //w=0.34 //l=0.085 //layer=m1 \
 //thickness=0.36 //x=25.24 //y=5.42 //x2=25.24 //y2=5.335
r664 (  5 6 ) resistor r=0.091623 //w=0.191 //l=0.14 //layer=m1 \
 //thickness=0.36 //x=25.24 //y=5.42 //x2=25.24 //y2=5.56
r665 (  4 28 ) resistor r=0.0262263 //w=0.232 //l=0.12 //layer=m1 \
 //thickness=0.36 //x=24.48 //y=5.335 //x2=24.36 //y2=5.335
r666 (  3 31 ) resistor r=0.0675342 //w=0.23 //l=0.115 //layer=m1 \
 //thickness=0.36 //x=25.125 //y=5.335 //x2=25.24 //y2=5.335
r667 (  3 4 ) resistor r=0.615458 //w=0.131 //l=0.645 //layer=m1 \
 //thickness=0.36 //x=25.125 //y=5.335 //x2=24.48 //y2=5.335
r668 (  2 25 ) resistor r=0.0222262 //w=0.217 //l=0.118 //layer=m1 \
 //thickness=0.36 //x=23.6 //y=5.335 //x2=23.482 //y2=5.335
r669 (  1 28 ) resistor r=0.0262263 //w=0.232 //l=0.12 //layer=m1 \
 //thickness=0.36 //x=24.24 //y=5.335 //x2=24.36 //y2=5.335
r670 (  1 2 ) resistor r=0.610687 //w=0.131 //l=0.64 //layer=m1 \
 //thickness=0.36 //x=24.24 //y=5.335 //x2=23.6 //y2=5.335
ends PM_TMRDFFQNX1\%noxref_9

subckt PM_TMRDFFQNX1\%noxref_10 ( 3 8 9 11 12 14 15 16 18 19 23 24 27 29 34 38 \
 40 43 44 51 53 54 57 65 82 91 95 96 97 98 99 100 101 105 107 110 111 121 124 \
 126 127 )
c277 ( 124 0 ) capacitor c=0.00878249f //x=38.71 //y=1.085
c278 ( 121 0 ) capacitor c=0.0646505f //x=41.19 //y=4.88
c279 ( 111 0 ) capacitor c=0.0318956f //x=41.525 //y=1.39
c280 ( 110 0 ) capacitor c=0.0186809f //x=41.525 //y=1.045
c281 ( 107 0 ) capacitor c=0.0141821f //x=41.37 //y=1.545
c282 ( 105 0 ) capacitor c=0.0158553f //x=41.37 //y=0.89
c283 ( 101 0 ) capacitor c=0.088055f //x=40.995 //y=2.095
c284 ( 100 0 ) capacitor c=0.0229235f //x=40.995 //y=1.7
c285 ( 99 0 ) capacitor c=0.0234359f //x=40.995 //y=1.39
c286 ( 98 0 ) capacitor c=0.0198759f //x=40.995 //y=1.045
c287 ( 97 0 ) capacitor c=0.110369f //x=41.53 //y=6.2
c288 ( 96 0 ) capacitor c=0.154619f //x=41.09 //y=6.2
c289 ( 91 0 ) capacitor c=8.13425e-19 //x=41.19 //y=4.88
c290 ( 82 0 ) capacitor c=8.01091e-19 //x=41.19 //y=2.26
c291 ( 65 0 ) capacitor c=0.0322017f //x=38.86 //y=5.56
c292 ( 57 0 ) capacitor c=0.0290186f //x=37.98 //y=5.56
c293 ( 54 0 ) capacitor c=0.0234059f //x=41.02 //y=3.865
c294 ( 53 0 ) capacitor c=9.01343e-19 //x=41.18 //y=3.865
c295 ( 51 0 ) capacitor c=7.85706e-19 //x=39.495 //y=3.865
c296 ( 44 0 ) capacitor c=0.0158653f //x=41.192 //y=4.74
c297 ( 43 0 ) capacitor c=0.00598864f //x=41.19 //y=4.88
c298 ( 40 0 ) capacitor c=0.00463527f //x=41.19 //y=2.26
c299 ( 38 0 ) capacitor c=0.0165932f //x=41.19 //y=3.88
c300 ( 34 0 ) capacitor c=0.0170469f //x=39.34 //y=3.88
c301 ( 29 0 ) capacitor c=0.0113259f //x=38.9 //y=1.18
c302 ( 27 0 ) capacitor c=5.78613e-19 //x=38.86 //y=5.56
c303 ( 24 0 ) capacitor c=0.0105334f //x=38.86 //y=5.38
c304 ( 23 0 ) capacitor c=0.00917086f //x=37.98 //y=5.56
c305 ( 19 0 ) capacitor c=0.0123403f //x=41.19 //y=4.025
c306 ( 18 0 ) capacitor c=0.03862f //x=41.19 //y=3.705
c307 ( 16 0 ) capacitor c=0.0304799f //x=39.34 //y=5.295
c308 ( 15 0 ) capacitor c=0.0137248f //x=39.34 //y=4.025
c309 ( 14 0 ) capacitor c=0.0505785f //x=39.34 //y=3.705
c310 ( 12 0 ) capacitor c=0.00465779f //x=38.985 //y=1.835
c311 ( 11 0 ) capacitor c=0.0117762f //x=39.255 //y=1.835
c312 ( 9 0 ) capacitor c=0.0111076f //x=39.255 //y=5.38
c313 ( 8 0 ) capacitor c=0.0101547f //x=38.9 //y=1.75
c314 ( 3 0 ) capacitor c=0.0147352f //x=38.745 //y=5.38
r315 (  119 121 ) resistor r=20.6867 //w=0.233 //l=0.1 //layer=ply \
 //thickness=0.18 //x=41.09 //y=4.88 //x2=41.19 //y2=4.88
r316 (  112 121 ) resistor r=70.3348 //w=0.233 //l=0.414367 //layer=ply \
 //thickness=0.18 //x=41.53 //y=5.045 //x2=41.19 //y2=4.88
r317 (  111 123 ) resistor r=45.1352 //w=0.168 //l=0.173853 //layer=ply \
 //thickness=0.18 //x=41.525 //y=1.39 //x2=41.485 //y2=1.545
r318 (  110 122 ) resistor r=45.1352 //w=0.168 //l=0.173853 //layer=ply \
 //thickness=0.18 //x=41.525 //y=1.045 //x2=41.485 //y2=0.89
r319 (  110 111 ) resistor r=176.904 //w=0.094 //l=0.345 //layer=ply \
 //thickness=0.18 //x=41.525 //y=1.045 //x2=41.525 //y2=1.39
r320 (  108 118 ) resistor r=10.701 //w=0.21 //l=0.115 //layer=ply \
 //thickness=0.18 //x=41.15 //y=1.545 //x2=41.035 //y2=1.545
r321 (  107 123 ) resistor r=5.52526 //w=0.168 //l=0.115 //layer=ply \
 //thickness=0.18 //x=41.37 //y=1.545 //x2=41.485 //y2=1.545
r322 (  106 117 ) resistor r=5.52526 //w=0.168 //l=0.115 //layer=ply \
 //thickness=0.18 //x=41.15 //y=0.89 //x2=41.035 //y2=0.89
r323 (  105 122 ) resistor r=5.52526 //w=0.168 //l=0.115 //layer=ply \
 //thickness=0.18 //x=41.37 //y=0.89 //x2=41.485 //y2=0.89
r324 (  105 106 ) resistor r=112.809 //w=0.094 //l=0.22 //layer=ply \
 //thickness=0.18 //x=41.37 //y=0.89 //x2=41.15 //y2=0.89
r325 (  102 119 ) resistor r=13.0941 //w=0.233 //l=0.165 //layer=ply \
 //thickness=0.18 //x=41.09 //y=5.045 //x2=41.09 //y2=4.88
r326 (  101 116 ) resistor r=34.8111 //w=0.27 //l=0.264953 //layer=ply \
 //thickness=0.18 //x=40.995 //y=2.095 //x2=41.19 //y2=2.26
r327 (  100 118 ) resistor r=39.5823 //w=0.21 //l=0.173853 //layer=ply \
 //thickness=0.18 //x=40.995 //y=1.7 //x2=41.035 //y2=1.545
r328 (  100 101 ) resistor r=202.543 //w=0.094 //l=0.395 //layer=ply \
 //thickness=0.18 //x=40.995 //y=1.7 //x2=40.995 //y2=2.095
r329 (  99 118 ) resistor r=39.5823 //w=0.21 //l=0.173853 //layer=ply \
 //thickness=0.18 //x=40.995 //y=1.39 //x2=41.035 //y2=1.545
r330 (  98 117 ) resistor r=45.1352 //w=0.168 //l=0.173853 //layer=ply \
 //thickness=0.18 //x=40.995 //y=1.045 //x2=41.035 //y2=0.89
r331 (  98 99 ) resistor r=176.904 //w=0.094 //l=0.345 //layer=ply \
 //thickness=0.18 //x=40.995 //y=1.045 //x2=40.995 //y2=1.39
r332 (  97 112 ) resistor r=592.245 //w=0.094 //l=1.155 //layer=ply \
 //thickness=0.18 //x=41.53 //y=6.2 //x2=41.53 //y2=5.045
r333 (  96 102 ) resistor r=592.245 //w=0.094 //l=1.155 //layer=ply \
 //thickness=0.18 //x=41.09 //y=6.2 //x2=41.09 //y2=5.045
r334 (  95 107 ) resistor r=56.4043 //w=0.094 //l=0.11 //layer=ply \
 //thickness=0.18 //x=41.26 //y=1.545 //x2=41.37 //y2=1.545
r335 (  95 108 ) resistor r=56.4043 //w=0.094 //l=0.11 //layer=ply \
 //thickness=0.18 //x=41.26 //y=1.545 //x2=41.15 //y2=1.545
r336 (  91 121 ) resistor r=152 //w=0.17 //l=0.17 //layer=licon //count=1 \
 //x=41.19 //y=4.88 //x2=41.19 //y2=4.88
r337 (  82 116 ) resistor r=152 //w=0.17 //l=0.17 //layer=licon //count=1 \
 //x=41.19 //y=2.26 //x2=41.19 //y2=2.26
r338 (  65 127 ) resistor r=23.615 //w=0.187 //l=0.345 //layer=li \
 //thickness=0.1 //x=38.86 //y=5.56 //x2=38.86 //y2=5.905
r339 (  57 126 ) resistor r=23.615 //w=0.187 //l=0.345 //layer=li \
 //thickness=0.1 //x=37.98 //y=5.56 //x2=37.98 //y2=5.905
r340 (  53 54 ) resistor r=0.10734 //w=0.281 //l=0.16 //layer=m2 \
 //thickness=0.36 //x=41.18 //y=3.865 //x2=41.02 //y2=3.865
r341 (  51 54 ) resistor r=1.45515 //w=0.131 //l=1.525 //layer=m2 \
 //thickness=0.36 //x=39.495 //y=3.88 //x2=41.02 //y2=3.88
r342 (  49 51 ) resistor r=0.10734 //w=0.281 //l=0.16 //layer=m2 \
 //thickness=0.36 //x=39.335 //y=3.865 //x2=39.495 //y2=3.865
r343 (  43 91 ) resistor r=9.3 //w=0.17 //l=0.17 //layer=mcon //count=1 \
 //x=41.19 //y=4.88 //x2=41.19 //y2=4.88
r344 (  43 44 ) resistor r=0.103207 //w=0.196 //l=0.14 //layer=m1 \
 //thickness=0.36 //x=41.192 //y=4.88 //x2=41.192 //y2=4.74
r345 (  40 82 ) resistor r=9.3 //w=0.17 //l=0.17 //layer=mcon //count=1 \
 //x=41.19 //y=2.26 //x2=41.19 //y2=2.26
r346 (  36 53 ) resistor r=4.5 //w=0.15 //l=0.15 //layer=via1 //count=1 \
 //x=41.18 //y=3.865 //x2=41.18 //y2=3.865
r347 (  36 38 ) resistor r=0.00505391 //w=0.371 //l=0.015 //layer=m1 \
 //thickness=0.36 //x=41.132 //y=3.865 //x2=41.132 //y2=3.88
r348 (  32 49 ) resistor r=4.5 //w=0.15 //l=0.15 //layer=via1 //count=1 \
 //x=39.335 //y=3.865 //x2=39.335 //y2=3.865
r349 (  32 34 ) resistor r=0.00494723 //w=0.379 //l=0.015 //layer=m1 \
 //thickness=0.36 //x=39.39 //y=3.865 //x2=39.39 //y2=3.88
r350 (  29 124 ) resistor r=9.3 //w=0.17 //l=0.17 //layer=mcon //count=1 \
 //x=38.9 //y=1.18 //x2=38.9 //y2=1.18
r351 (  27 65 ) resistor r=9.3 //w=0.17 //l=0.17 //layer=mcon //count=1 \
 //x=38.86 //y=5.56 //x2=38.86 //y2=5.56
r352 (  24 27 ) resistor r=0.117801 //w=0.191 //l=0.18 //layer=m1 \
 //thickness=0.36 //x=38.86 //y=5.38 //x2=38.86 //y2=5.56
r353 (  23 57 ) resistor r=9.3 //w=0.17 //l=0.17 //layer=mcon //count=1 \
 //x=37.98 //y=5.56 //x2=37.98 //y2=5.56
r354 (  21 23 ) resistor r=0.10274 //w=0.219 //l=0.18 //layer=m1 \
 //thickness=0.36 //x=37.98 //y=5.38 //x2=37.98 //y2=5.56
r355 (  19 38 ) resistor r=0.0859108 //w=0.371 //l=0.171566 //layer=m1 \
 //thickness=0.36 //x=41.19 //y=4.025 //x2=41.132 //y2=3.88
r356 (  19 44 ) resistor r=0.682252 //w=0.131 //l=0.715 //layer=m1 \
 //thickness=0.36 //x=41.19 //y=4.025 //x2=41.19 //y2=4.74
r357 (  18 36 ) resistor r=0.0909648 //w=0.371 //l=0.186762 //layer=m1 \
 //thickness=0.36 //x=41.19 //y=3.705 //x2=41.132 //y2=3.865
r358 (  17 40 ) resistor r=0.0933015 //w=0.201 //l=0.125 //layer=m1 \
 //thickness=0.36 //x=41.19 //y=2.385 //x2=41.19 //y2=2.26
r359 (  17 18 ) resistor r=1.25954 //w=0.131 //l=1.32 //layer=m1 \
 //thickness=0.36 //x=41.19 //y=2.385 //x2=41.19 //y2=3.705
r360 (  15 34 ) resistor r=0.0863342 //w=0.379 //l=0.168152 //layer=m1 \
 //thickness=0.36 //x=39.34 //y=4.025 //x2=39.39 //y2=3.88
r361 (  15 16 ) resistor r=1.21183 //w=0.131 //l=1.27 //layer=m1 \
 //thickness=0.36 //x=39.34 //y=4.025 //x2=39.34 //y2=5.295
r362 (  14 32 ) resistor r=0.0912814 //w=0.379 //l=0.183303 //layer=m1 \
 //thickness=0.36 //x=39.34 //y=3.705 //x2=39.39 //y2=3.865
r363 (  13 14 ) resistor r=1.70324 //w=0.131 //l=1.785 //layer=m1 \
 //thickness=0.36 //x=39.34 //y=1.92 //x2=39.34 //y2=3.705
r364 (  11 13 ) resistor r=0.0698411 //w=0.17 //l=0.120208 //layer=m1 \
 //thickness=0.36 //x=39.255 //y=1.835 //x2=39.34 //y2=1.92
r365 (  11 12 ) resistor r=0.257634 //w=0.131 //l=0.27 //layer=m1 \
 //thickness=0.36 //x=39.255 //y=1.835 //x2=38.985 //y2=1.835
r366 (  10 24 ) resistor r=0.0257089 //w=0.23 //l=0.115 //layer=m1 \
 //thickness=0.36 //x=38.975 //y=5.38 //x2=38.86 //y2=5.38
r367 (  9 16 ) resistor r=0.0698411 //w=0.17 //l=0.120208 //layer=m1 \
 //thickness=0.36 //x=39.255 //y=5.38 //x2=39.34 //y2=5.295
r368 (  9 10 ) resistor r=0.267176 //w=0.131 //l=0.28 //layer=m1 \
 //thickness=0.36 //x=39.255 //y=5.38 //x2=38.975 //y2=5.38
r369 (  8 12 ) resistor r=0.0698411 //w=0.17 //l=0.120208 //layer=m1 \
 //thickness=0.36 //x=38.9 //y=1.75 //x2=38.985 //y2=1.835
r370 (  7 29 ) resistor r=0.0913624 //w=0.191 //l=0.12 //layer=m1 \
 //thickness=0.36 //x=38.9 //y=1.3 //x2=38.9 //y2=1.18
r371 (  7 8 ) resistor r=0.429389 //w=0.131 //l=0.45 //layer=m1 \
 //thickness=0.36 //x=38.9 //y=1.3 //x2=38.9 //y2=1.75
r372 (  4 21 ) resistor r=0.0227762 //w=0.219 //l=0.115 //layer=m1 \
 //thickness=0.36 //x=38.095 //y=5.38 //x2=37.98 //y2=5.38
r373 (  3 24 ) resistor r=0.0257089 //w=0.23 //l=0.115 //layer=m1 \
 //thickness=0.36 //x=38.745 //y=5.38 //x2=38.86 //y2=5.38
r374 (  3 4 ) resistor r=0.620229 //w=0.131 //l=0.65 //layer=m1 \
 //thickness=0.36 //x=38.745 //y=5.38 //x2=38.095 //y2=5.38
ends PM_TMRDFFQNX1\%noxref_10

subckt PM_TMRDFFQNX1\%noxref_11 ( 1 2 3 4 6 7 8 11 16 17 19 20 22 23 24 26 27 \
 28 34 38 42 49 50 53 55 58 62 65 70 72 74 76 78 79 80 81 85 93 102 107 116 \
 121 129 146 155 159 160 161 162 163 164 165 166 167 168 169 170 171 172 174 \
 180 181 182 183 187 188 189 194 196 198 204 205 206 207 208 213 215 217 223 \
 224 234 235 238 247 248 251 259 261 262 )
c636 ( 259 0 ) capacitor c=0.00878249f //x=35.38 //y=1.085
c637 ( 251 0 ) capacitor c=0.0356006f //x=41.96 //y=4.88
c638 ( 248 0 ) capacitor c=0.0284095f //x=41.93 //y=2.095
c639 ( 247 0 ) capacitor c=0.046061f //x=41.93 //y=2.26
c640 ( 238 0 ) capacitor c=0.0354915f //x=31.97 //y=4.88
c641 ( 235 0 ) capacitor c=0.0284095f //x=31.94 //y=2.095
c642 ( 234 0 ) capacitor c=0.0476356f //x=31.94 //y=2.26
c643 ( 224 0 ) capacitor c=0.0439015f //x=42.495 //y=1.43
c644 ( 223 0 ) capacitor c=0.0192582f //x=42.495 //y=1.085
c645 ( 217 0 ) capacitor c=0.0162526f //x=42.34 //y=1.585
c646 ( 215 0 ) capacitor c=0.0157807f //x=42.34 //y=0.93
c647 ( 213 0 ) capacitor c=0.0372668f //x=42.335 //y=4.97
c648 ( 208 0 ) capacitor c=0.0210762f //x=41.965 //y=1.74
c649 ( 207 0 ) capacitor c=0.0168511f //x=41.965 //y=1.43
c650 ( 206 0 ) capacitor c=0.0175485f //x=41.965 //y=1.085
c651 ( 205 0 ) capacitor c=0.0439708f //x=32.505 //y=1.43
c652 ( 204 0 ) capacitor c=0.0192582f //x=32.505 //y=1.085
c653 ( 198 0 ) capacitor c=0.0162526f //x=32.35 //y=1.585
c654 ( 196 0 ) capacitor c=0.0157807f //x=32.35 //y=0.93
c655 ( 194 0 ) capacitor c=0.0372668f //x=32.345 //y=4.97
c656 ( 189 0 ) capacitor c=0.0210762f //x=31.975 //y=1.74
c657 ( 188 0 ) capacitor c=0.0168511f //x=31.975 //y=1.43
c658 ( 187 0 ) capacitor c=0.0175485f //x=31.975 //y=1.085
c659 ( 183 0 ) capacitor c=0.0552496f //x=23.335 //y=4.97
c660 ( 182 0 ) capacitor c=0.0376038f //x=23.625 //y=4.97
c661 ( 181 0 ) capacitor c=0.0346489f //x=23.29 //y=1.4
c662 ( 180 0 ) capacitor c=0.018692f //x=23.29 //y=1.055
c663 ( 174 0 ) capacitor c=0.0137077f //x=23.135 //y=1.555
c664 ( 172 0 ) capacitor c=0.0158585f //x=23.135 //y=0.9
c665 ( 171 0 ) capacitor c=0.103534f //x=22.76 //y=2.095
c666 ( 170 0 ) capacitor c=0.0229444f //x=22.76 //y=1.71
c667 ( 169 0 ) capacitor c=0.0234359f //x=22.76 //y=1.4
c668 ( 168 0 ) capacitor c=0.019815f //x=22.76 //y=1.055
c669 ( 167 0 ) capacitor c=0.155269f //x=42.41 //y=6.2
c670 ( 166 0 ) capacitor c=0.110375f //x=41.97 //y=6.2
c671 ( 165 0 ) capacitor c=0.155269f //x=32.42 //y=6.2
c672 ( 164 0 ) capacitor c=0.110375f //x=31.98 //y=6.2
c673 ( 163 0 ) capacitor c=0.110208f //x=23.7 //y=6.2
c674 ( 162 0 ) capacitor c=0.158957f //x=23.26 //y=6.2
c675 ( 155 0 ) capacitor c=5.80994e-19 //x=41.96 //y=4.88
c676 ( 146 0 ) capacitor c=5.78095e-19 //x=41.93 //y=2.26
c677 ( 129 0 ) capacitor c=0.0319332f //x=35.53 //y=5.56
c678 ( 121 0 ) capacitor c=0.0291719f //x=34.65 //y=5.56
c679 ( 116 0 ) capacitor c=5.80994e-19 //x=31.97 //y=4.88
c680 ( 107 0 ) capacitor c=5.78095e-19 //x=31.94 //y=2.26
c681 ( 102 0 ) capacitor c=0.00129098f //x=23.06 //y=4.88
c682 ( 93 0 ) capacitor c=0.0012618f //x=23.06 //y=2.26
c683 ( 85 0 ) capacitor c=0.00112471f //x=23.225 //y=4.255
c684 ( 81 0 ) capacitor c=0.0199655f //x=37.73 //y=4.27
c685 ( 80 0 ) capacitor c=0.0412176f //x=38.075 //y=4.27
c686 ( 79 0 ) capacitor c=0.0346005f //x=32.105 //y=4.25
c687 ( 78 0 ) capacitor c=0.0338287f //x=35.84 //y=4.25
c688 ( 76 0 ) capacitor c=0.00147451f //x=28.08 //y=4.265
c689 ( 74 0 ) capacitor c=0.0153988f //x=27.48 //y=4.25
c690 ( 72 0 ) capacitor c=0.00416722f //x=26.235 //y=4.265
c691 ( 70 0 ) capacitor c=0.0313219f //x=25.635 //y=4.25
c692 ( 65 0 ) capacitor c=0.00504418f //x=41.93 //y=2.26
c693 ( 62 0 ) capacitor c=0.0150367f //x=41.93 //y=4.25
c694 ( 58 0 ) capacitor c=0.015184f //x=36.01 //y=4.25
c695 ( 55 0 ) capacitor c=0.0113735f //x=35.57 //y=1.18
c696 ( 53 0 ) capacitor c=5.78613e-19 //x=35.53 //y=5.56
c697 ( 50 0 ) capacitor c=0.00999937f //x=35.53 //y=5.38
c698 ( 49 0 ) capacitor c=0.00933207f //x=34.65 //y=5.56
c699 ( 42 0 ) capacitor c=0.00662515f //x=31.94 //y=2.26
c700 ( 38 0 ) capacitor c=0.0143744f //x=31.94 //y=4.25
c701 ( 34 0 ) capacitor c=0.0159434f //x=23.06 //y=4.25
c702 ( 28 0 ) capacitor c=0.00917813f //x=41.93 //y=4.735
c703 ( 27 0 ) capacitor c=0.00983725f //x=41.93 //y=4.41
c704 ( 26 0 ) capacitor c=0.0388832f //x=41.93 //y=4.09
c705 ( 24 0 ) capacitor c=0.0191047f //x=36.01 //y=5.295
c706 ( 23 0 ) capacitor c=0.012741f //x=36.01 //y=4.425
c707 ( 22 0 ) capacitor c=0.058651f //x=36.01 //y=4.105
c708 ( 20 0 ) capacitor c=0.00560492f //x=35.655 //y=1.835
c709 ( 19 0 ) capacitor c=0.0131084f //x=35.925 //y=1.835
c710 ( 17 0 ) capacitor c=0.0101152f //x=35.925 //y=5.38
c711 ( 16 0 ) capacitor c=0.0101547f //x=35.57 //y=1.75
c712 ( 11 0 ) capacitor c=0.0142466f //x=35.415 //y=5.38
c713 ( 8 0 ) capacitor c=0.00908133f //x=31.94 //y=4.735
c714 ( 7 0 ) capacitor c=0.00995231f //x=31.94 //y=4.415
c715 ( 6 0 ) capacitor c=0.033867f //x=31.94 //y=4.095
c716 ( 4 0 ) capacitor c=0.0140142f //x=23.06 //y=4.755
c717 ( 3 0 ) capacitor c=0.0125872f //x=23.06 //y=4.415
c718 ( 2 0 ) capacitor c=0.0562682f //x=23.06 //y=4.095
c719 ( 1 0 ) capacitor c=0.00681376f //x=23.06 //y=2.375
r720 (  253 254 ) resistor r=32.4568 //w=0.214 //l=0.075 //layer=ply \
 //thickness=0.18 //x=41.96 //y=4.97 //x2=41.96 //y2=5.045
r721 (  251 253 ) resistor r=20.271 //w=0.214 //l=0.09 //layer=ply \
 //thickness=0.18 //x=41.96 //y=4.88 //x2=41.96 //y2=4.97
r722 (  247 248 ) resistor r=52.7279 //w=0.214 //l=0.165 //layer=ply \
 //thickness=0.18 //x=41.93 //y=2.26 //x2=41.93 //y2=2.095
r723 (  240 241 ) resistor r=32.4568 //w=0.214 //l=0.075 //layer=ply \
 //thickness=0.18 //x=31.97 //y=4.97 //x2=31.97 //y2=5.045
r724 (  238 240 ) resistor r=20.271 //w=0.214 //l=0.09 //layer=ply \
 //thickness=0.18 //x=31.97 //y=4.88 //x2=31.97 //y2=4.97
r725 (  234 235 ) resistor r=52.7279 //w=0.214 //l=0.165 //layer=ply \
 //thickness=0.18 //x=31.94 //y=2.26 //x2=31.94 //y2=2.095
r726 (  224 258 ) resistor r=45.1352 //w=0.168 //l=0.173853 //layer=ply \
 //thickness=0.18 //x=42.495 //y=1.43 //x2=42.455 //y2=1.585
r727 (  223 257 ) resistor r=45.1352 //w=0.168 //l=0.173853 //layer=ply \
 //thickness=0.18 //x=42.495 //y=1.085 //x2=42.455 //y2=0.93
r728 (  223 224 ) resistor r=176.904 //w=0.094 //l=0.345 //layer=ply \
 //thickness=0.18 //x=42.495 //y=1.085 //x2=42.495 //y2=1.43
r729 (  218 256 ) resistor r=10.701 //w=0.21 //l=0.115 //layer=ply \
 //thickness=0.18 //x=42.12 //y=1.585 //x2=42.005 //y2=1.585
r730 (  217 258 ) resistor r=5.52526 //w=0.168 //l=0.115 //layer=ply \
 //thickness=0.18 //x=42.34 //y=1.585 //x2=42.455 //y2=1.585
r731 (  216 255 ) resistor r=5.52526 //w=0.168 //l=0.115 //layer=ply \
 //thickness=0.18 //x=42.12 //y=0.93 //x2=42.005 //y2=0.93
r732 (  215 257 ) resistor r=5.52526 //w=0.168 //l=0.115 //layer=ply \
 //thickness=0.18 //x=42.34 //y=0.93 //x2=42.455 //y2=0.93
r733 (  215 216 ) resistor r=112.809 //w=0.094 //l=0.22 //layer=ply \
 //thickness=0.18 //x=42.34 //y=0.93 //x2=42.12 //y2=0.93
r734 (  214 253 ) resistor r=16.5046 //w=0.27 //l=0.135 //layer=ply \
 //thickness=0.18 //x=42.095 //y=4.97 //x2=41.96 //y2=4.97
r735 (  213 220 ) resistor r=26.9307 //w=0.15 //l=0.106066 //layer=ply \
 //thickness=0.18 //x=42.335 //y=4.97 //x2=42.41 //y2=5.045
r736 (  213 214 ) resistor r=123.064 //w=0.094 //l=0.24 //layer=ply \
 //thickness=0.18 //x=42.335 //y=4.97 //x2=42.095 //y2=4.97
r737 (  208 256 ) resistor r=39.5823 //w=0.21 //l=0.173853 //layer=ply \
 //thickness=0.18 //x=41.965 //y=1.74 //x2=42.005 //y2=1.585
r738 (  208 248 ) resistor r=182.032 //w=0.094 //l=0.355 //layer=ply \
 //thickness=0.18 //x=41.965 //y=1.74 //x2=41.965 //y2=2.095
r739 (  207 256 ) resistor r=39.5823 //w=0.21 //l=0.173853 //layer=ply \
 //thickness=0.18 //x=41.965 //y=1.43 //x2=42.005 //y2=1.585
r740 (  206 255 ) resistor r=45.1352 //w=0.168 //l=0.173853 //layer=ply \
 //thickness=0.18 //x=41.965 //y=1.085 //x2=42.005 //y2=0.93
r741 (  206 207 ) resistor r=176.904 //w=0.094 //l=0.345 //layer=ply \
 //thickness=0.18 //x=41.965 //y=1.085 //x2=41.965 //y2=1.43
r742 (  205 245 ) resistor r=45.1352 //w=0.168 //l=0.173853 //layer=ply \
 //thickness=0.18 //x=32.505 //y=1.43 //x2=32.465 //y2=1.585
r743 (  204 244 ) resistor r=45.1352 //w=0.168 //l=0.173853 //layer=ply \
 //thickness=0.18 //x=32.505 //y=1.085 //x2=32.465 //y2=0.93
r744 (  204 205 ) resistor r=176.904 //w=0.094 //l=0.345 //layer=ply \
 //thickness=0.18 //x=32.505 //y=1.085 //x2=32.505 //y2=1.43
r745 (  199 243 ) resistor r=10.701 //w=0.21 //l=0.115 //layer=ply \
 //thickness=0.18 //x=32.13 //y=1.585 //x2=32.015 //y2=1.585
r746 (  198 245 ) resistor r=5.52526 //w=0.168 //l=0.115 //layer=ply \
 //thickness=0.18 //x=32.35 //y=1.585 //x2=32.465 //y2=1.585
r747 (  197 242 ) resistor r=5.52526 //w=0.168 //l=0.115 //layer=ply \
 //thickness=0.18 //x=32.13 //y=0.93 //x2=32.015 //y2=0.93
r748 (  196 244 ) resistor r=5.52526 //w=0.168 //l=0.115 //layer=ply \
 //thickness=0.18 //x=32.35 //y=0.93 //x2=32.465 //y2=0.93
r749 (  196 197 ) resistor r=112.809 //w=0.094 //l=0.22 //layer=ply \
 //thickness=0.18 //x=32.35 //y=0.93 //x2=32.13 //y2=0.93
r750 (  195 240 ) resistor r=16.5046 //w=0.27 //l=0.135 //layer=ply \
 //thickness=0.18 //x=32.105 //y=4.97 //x2=31.97 //y2=4.97
r751 (  194 201 ) resistor r=26.9307 //w=0.15 //l=0.106066 //layer=ply \
 //thickness=0.18 //x=32.345 //y=4.97 //x2=32.42 //y2=5.045
r752 (  194 195 ) resistor r=123.064 //w=0.094 //l=0.24 //layer=ply \
 //thickness=0.18 //x=32.345 //y=4.97 //x2=32.105 //y2=4.97
r753 (  189 243 ) resistor r=39.5823 //w=0.21 //l=0.173853 //layer=ply \
 //thickness=0.18 //x=31.975 //y=1.74 //x2=32.015 //y2=1.585
r754 (  189 235 ) resistor r=182.032 //w=0.094 //l=0.355 //layer=ply \
 //thickness=0.18 //x=31.975 //y=1.74 //x2=31.975 //y2=2.095
r755 (  188 243 ) resistor r=39.5823 //w=0.21 //l=0.173853 //layer=ply \
 //thickness=0.18 //x=31.975 //y=1.43 //x2=32.015 //y2=1.585
r756 (  187 242 ) resistor r=45.1352 //w=0.168 //l=0.173853 //layer=ply \
 //thickness=0.18 //x=31.975 //y=1.085 //x2=32.015 //y2=0.93
r757 (  187 188 ) resistor r=176.904 //w=0.094 //l=0.345 //layer=ply \
 //thickness=0.18 //x=31.975 //y=1.085 //x2=31.975 //y2=1.43
r758 (  182 184 ) resistor r=26.9307 //w=0.15 //l=0.106066 //layer=ply \
 //thickness=0.18 //x=23.625 //y=4.97 //x2=23.7 //y2=5.045
r759 (  182 183 ) resistor r=148.702 //w=0.094 //l=0.29 //layer=ply \
 //thickness=0.18 //x=23.625 //y=4.97 //x2=23.335 //y2=4.97
r760 (  181 232 ) resistor r=45.1352 //w=0.168 //l=0.173853 //layer=ply \
 //thickness=0.18 //x=23.29 //y=1.4 //x2=23.25 //y2=1.555
r761 (  180 231 ) resistor r=45.1352 //w=0.168 //l=0.173853 //layer=ply \
 //thickness=0.18 //x=23.29 //y=1.055 //x2=23.25 //y2=0.9
r762 (  180 181 ) resistor r=176.904 //w=0.094 //l=0.345 //layer=ply \
 //thickness=0.18 //x=23.29 //y=1.055 //x2=23.29 //y2=1.4
r763 (  177 183 ) resistor r=22.7971 //w=0.269 //l=0.106066 //layer=ply \
 //thickness=0.18 //x=23.26 //y=5.045 //x2=23.335 //y2=4.97
r764 (  177 230 ) resistor r=35.8364 //w=0.269 //l=0.270185 //layer=ply \
 //thickness=0.18 //x=23.26 //y=5.045 //x2=23.06 //y2=4.88
r765 (  175 226 ) resistor r=10.701 //w=0.21 //l=0.115 //layer=ply \
 //thickness=0.18 //x=22.915 //y=1.555 //x2=22.8 //y2=1.555
r766 (  174 232 ) resistor r=5.52526 //w=0.168 //l=0.115 //layer=ply \
 //thickness=0.18 //x=23.135 //y=1.555 //x2=23.25 //y2=1.555
r767 (  173 225 ) resistor r=5.52526 //w=0.168 //l=0.115 //layer=ply \
 //thickness=0.18 //x=22.915 //y=0.9 //x2=22.8 //y2=0.9
r768 (  172 231 ) resistor r=5.52526 //w=0.168 //l=0.115 //layer=ply \
 //thickness=0.18 //x=23.135 //y=0.9 //x2=23.25 //y2=0.9
r769 (  172 173 ) resistor r=112.809 //w=0.094 //l=0.22 //layer=ply \
 //thickness=0.18 //x=23.135 //y=0.9 //x2=22.915 //y2=0.9
r770 (  171 228 ) resistor r=58.7805 //w=0.246 //l=0.373497 //layer=ply \
 //thickness=0.18 //x=22.76 //y=2.095 //x2=23.06 //y2=2.26
r771 (  170 226 ) resistor r=39.5823 //w=0.21 //l=0.173853 //layer=ply \
 //thickness=0.18 //x=22.76 //y=1.71 //x2=22.8 //y2=1.555
r772 (  170 171 ) resistor r=197.415 //w=0.094 //l=0.385 //layer=ply \
 //thickness=0.18 //x=22.76 //y=1.71 //x2=22.76 //y2=2.095
r773 (  169 226 ) resistor r=39.5823 //w=0.21 //l=0.173853 //layer=ply \
 //thickness=0.18 //x=22.76 //y=1.4 //x2=22.8 //y2=1.555
r774 (  168 225 ) resistor r=45.1352 //w=0.168 //l=0.173853 //layer=ply \
 //thickness=0.18 //x=22.76 //y=1.055 //x2=22.8 //y2=0.9
r775 (  168 169 ) resistor r=176.904 //w=0.094 //l=0.345 //layer=ply \
 //thickness=0.18 //x=22.76 //y=1.055 //x2=22.76 //y2=1.4
r776 (  167 220 ) resistor r=592.245 //w=0.094 //l=1.155 //layer=ply \
 //thickness=0.18 //x=42.41 //y=6.2 //x2=42.41 //y2=5.045
r777 (  166 254 ) resistor r=592.245 //w=0.094 //l=1.155 //layer=ply \
 //thickness=0.18 //x=41.97 //y=6.2 //x2=41.97 //y2=5.045
r778 (  165 201 ) resistor r=592.245 //w=0.094 //l=1.155 //layer=ply \
 //thickness=0.18 //x=32.42 //y=6.2 //x2=32.42 //y2=5.045
r779 (  164 241 ) resistor r=592.245 //w=0.094 //l=1.155 //layer=ply \
 //thickness=0.18 //x=31.98 //y=6.2 //x2=31.98 //y2=5.045
r780 (  163 184 ) resistor r=592.245 //w=0.094 //l=1.155 //layer=ply \
 //thickness=0.18 //x=23.7 //y=6.2 //x2=23.7 //y2=5.045
r781 (  162 177 ) resistor r=592.245 //w=0.094 //l=1.155 //layer=ply \
 //thickness=0.18 //x=23.26 //y=6.2 //x2=23.26 //y2=5.045
r782 (  161 217 ) resistor r=56.4043 //w=0.094 //l=0.11 //layer=ply \
 //thickness=0.18 //x=42.23 //y=1.585 //x2=42.34 //y2=1.585
r783 (  161 218 ) resistor r=56.4043 //w=0.094 //l=0.11 //layer=ply \
 //thickness=0.18 //x=42.23 //y=1.585 //x2=42.12 //y2=1.585
r784 (  160 198 ) resistor r=56.4043 //w=0.094 //l=0.11 //layer=ply \
 //thickness=0.18 //x=32.24 //y=1.585 //x2=32.35 //y2=1.585
r785 (  160 199 ) resistor r=56.4043 //w=0.094 //l=0.11 //layer=ply \
 //thickness=0.18 //x=32.24 //y=1.585 //x2=32.13 //y2=1.585
r786 (  159 174 ) resistor r=56.4043 //w=0.094 //l=0.11 //layer=ply \
 //thickness=0.18 //x=23.025 //y=1.555 //x2=23.135 //y2=1.555
r787 (  159 175 ) resistor r=56.4043 //w=0.094 //l=0.11 //layer=ply \
 //thickness=0.18 //x=23.025 //y=1.555 //x2=22.915 //y2=1.555
r788 (  155 251 ) resistor r=152 //w=0.17 //l=0.17 //layer=licon //count=1 \
 //x=41.96 //y=4.88 //x2=41.96 //y2=4.88
r789 (  146 247 ) resistor r=152 //w=0.17 //l=0.17 //layer=licon //count=1 \
 //x=41.93 //y=2.26 //x2=41.93 //y2=2.26
r790 (  129 262 ) resistor r=23.615 //w=0.187 //l=0.345 //layer=li \
 //thickness=0.1 //x=35.53 //y=5.56 //x2=35.53 //y2=5.905
r791 (  121 261 ) resistor r=23.615 //w=0.187 //l=0.345 //layer=li \
 //thickness=0.1 //x=34.65 //y=5.56 //x2=34.65 //y2=5.905
r792 (  116 238 ) resistor r=152 //w=0.17 //l=0.17 //layer=licon //count=1 \
 //x=31.97 //y=4.88 //x2=31.97 //y2=4.88
r793 (  107 234 ) resistor r=152 //w=0.17 //l=0.17 //layer=licon //count=1 \
 //x=31.94 //y=2.26 //x2=31.94 //y2=2.26
r794 (  102 230 ) resistor r=152 //w=0.17 //l=0.17 //layer=licon //count=1 \
 //x=23.06 //y=4.88 //x2=23.06 //y2=4.88
r795 (  93 228 ) resistor r=152 //w=0.17 //l=0.17 //layer=licon //count=1 \
 //x=23.06 //y=2.26 //x2=23.06 //y2=2.26
r796 (  83 85 ) resistor r=0.10734 //w=0.281 //l=0.16 //layer=m2 \
 //thickness=0.36 //x=23.065 //y=4.255 //x2=23.225 //y2=4.255
r797 (  81 89 ) resistor r=1.10585 //w=0.196 //l=1.7325 //layer=m2 \
 //thickness=0.36 //x=37.73 //y=4.27 //x2=36 //y2=4.265
r798 (  80 91 ) resistor r=2.64838 //w=0.182 //l=3.86499 //layer=m2 \
 //thickness=0.36 //x=38.075 //y=4.27 //x2=41.93 //y2=4.25
r799 (  80 81 ) resistor r=0.329198 //w=0.131 //l=0.345 //layer=m2 \
 //thickness=0.36 //x=38.075 //y=4.27 //x2=37.73 //y2=4.27
r800 (  79 87 ) resistor r=0.110608 //w=0.182 //l=0.162481 //layer=m2 \
 //thickness=0.36 //x=32.105 //y=4.25 //x2=31.945 //y2=4.255
r801 (  78 89 ) resistor r=0.104578 //w=0.196 //l=0.167332 //layer=m2 \
 //thickness=0.36 //x=35.84 //y=4.25 //x2=36 //y2=4.265
r802 (  78 79 ) resistor r=3.56393 //w=0.131 //l=3.735 //layer=m2 \
 //thickness=0.36 //x=35.84 //y=4.25 //x2=32.105 //y2=4.25
r803 (  76 87 ) resistor r=2.65525 //w=0.182 //l=3.87 //layer=m2 \
 //thickness=0.36 //x=28.08 //y=4.265 //x2=31.945 //y2=4.255
r804 (  76 77 ) resistor r=0.329198 //w=0.131 //l=0.345 //layer=m2 \
 //thickness=0.36 //x=28.08 //y=4.265 //x2=27.735 //y2=4.265
r805 (  74 77 ) resistor r=0.1875 //w=0.17 //l=0.262393 //layer=m2 \
 //thickness=0.36 //x=27.48 //y=4.25 //x2=27.735 //y2=4.265
r806 (  74 75 ) resistor r=1.02576 //w=0.131 //l=1.075 //layer=m2 \
 //thickness=0.36 //x=27.48 //y=4.25 //x2=26.405 //y2=4.25
r807 (  72 75 ) resistor r=0.125 //w=0.17 //l=0.177341 //layer=m2 \
 //thickness=0.36 //x=26.235 //y=4.265 //x2=26.405 //y2=4.25
r808 (  72 73 ) resistor r=0.329198 //w=0.131 //l=0.345 //layer=m2 \
 //thickness=0.36 //x=26.235 //y=4.265 //x2=25.89 //y2=4.265
r809 (  70 73 ) resistor r=0.1875 //w=0.17 //l=0.262393 //layer=m2 \
 //thickness=0.36 //x=25.635 //y=4.25 //x2=25.89 //y2=4.265
r810 (  70 85 ) resistor r=2.29962 //w=0.131 //l=2.41 //layer=m2 \
 //thickness=0.36 //x=25.635 //y=4.25 //x2=23.225 //y2=4.25
r811 (  69 155 ) resistor r=9.3 //w=0.17 //l=0.17 //layer=mcon //count=1 \
 //x=41.96 //y=4.88 //x2=41.96 //y2=4.88
r812 (  65 146 ) resistor r=9.3 //w=0.17 //l=0.17 //layer=mcon //count=1 \
 //x=41.93 //y=2.26 //x2=41.93 //y2=2.26
r813 (  65 67 ) resistor r=0.0936408 //w=0.196 //l=0.125 //layer=m1 \
 //thickness=0.36 //x=41.932 //y=2.26 //x2=41.932 //y2=2.385
r814 (  62 91 ) resistor r=4.5 //w=0.15 //l=0.15 //layer=via1 //count=1 \
 //x=41.93 //y=4.25 //x2=41.93 //y2=4.25
r815 (  60 89 ) resistor r=4.5 //w=0.15 //l=0.15 //layer=via1 //count=1 //x=36 \
 //y=4.265 //x2=36 //y2=4.265
r816 (  58 60 ) resistor r=0.00505391 //w=0.371 //l=0.015 //layer=m1 \
 //thickness=0.36 //x=35.952 //y=4.25 //x2=35.952 //y2=4.265
r817 (  55 259 ) resistor r=9.3 //w=0.17 //l=0.17 //layer=mcon //count=1 \
 //x=35.57 //y=1.18 //x2=35.57 //y2=1.18
r818 (  53 129 ) resistor r=9.3 //w=0.17 //l=0.17 //layer=mcon //count=1 \
 //x=35.53 //y=5.56 //x2=35.53 //y2=5.56
r819 (  50 53 ) resistor r=0.117801 //w=0.191 //l=0.18 //layer=m1 \
 //thickness=0.36 //x=35.53 //y=5.38 //x2=35.53 //y2=5.56
r820 (  49 121 ) resistor r=9.3 //w=0.17 //l=0.17 //layer=mcon //count=1 \
 //x=34.65 //y=5.56 //x2=34.65 //y2=5.56
r821 (  47 49 ) resistor r=0.10274 //w=0.219 //l=0.18 //layer=m1 \
 //thickness=0.36 //x=34.65 //y=5.38 //x2=34.65 //y2=5.56
r822 (  46 116 ) resistor r=9.3 //w=0.17 //l=0.17 //layer=mcon //count=1 \
 //x=31.97 //y=4.88 //x2=31.97 //y2=4.88
r823 (  42 107 ) resistor r=9.3 //w=0.17 //l=0.17 //layer=mcon //count=1 \
 //x=31.94 //y=2.26 //x2=31.94 //y2=2.26
r824 (  42 44 ) resistor r=0.0936408 //w=0.196 //l=0.125 //layer=m1 \
 //thickness=0.36 //x=31.942 //y=2.26 //x2=31.942 //y2=2.385
r825 (  40 87 ) resistor r=4.5 //w=0.15 //l=0.15 //layer=via1 //count=1 \
 //x=31.945 //y=4.255 //x2=31.945 //y2=4.255
r826 (  38 40 ) resistor r=0.00164908 //w=0.379 //l=0.005 //layer=m1 \
 //thickness=0.36 //x=31.89 //y=4.25 //x2=31.89 //y2=4.255
r827 (  36 83 ) resistor r=4.5 //w=0.15 //l=0.15 //layer=via1 //count=1 \
 //x=23.065 //y=4.255 //x2=23.065 //y2=4.255
r828 (  34 36 ) resistor r=0.00167112 //w=0.374 //l=0.005 //layer=m1 \
 //thickness=0.36 //x=23.115 //y=4.25 //x2=23.115 //y2=4.255
r829 (  32 102 ) resistor r=9.3 //w=0.17 //l=0.17 //layer=mcon //count=1 \
 //x=23.06 //y=4.88 //x2=23.06 //y2=4.88
r830 (  30 93 ) resistor r=9.3 //w=0.17 //l=0.17 //layer=mcon //count=1 \
 //x=23.06 //y=2.26 //x2=23.06 //y2=2.26
r831 (  28 69 ) resistor r=0.0878548 //w=0.228 //l=0.159295 //layer=m1 \
 //thickness=0.36 //x=41.93 //y=4.735 //x2=41.96 //y2=4.88
r832 (  27 62 ) resistor r=0.0911593 //w=0.376 //l=0.184608 //layer=m1 \
 //thickness=0.36 //x=41.93 //y=4.41 //x2=41.877 //y2=4.25
r833 (  27 28 ) resistor r=0.310115 //w=0.131 //l=0.325 //layer=m1 \
 //thickness=0.36 //x=41.93 //y=4.41 //x2=41.93 //y2=4.735
r834 (  26 62 ) resistor r=0.0911593 //w=0.376 //l=0.184608 //layer=m1 \
 //thickness=0.36 //x=41.93 //y=4.09 //x2=41.877 //y2=4.25
r835 (  26 67 ) resistor r=1.62691 //w=0.131 //l=1.705 //layer=m1 \
 //thickness=0.36 //x=41.93 //y=4.09 //x2=41.93 //y2=2.385
r836 (  23 60 ) resistor r=0.0909648 //w=0.371 //l=0.186762 //layer=m1 \
 //thickness=0.36 //x=36.01 //y=4.425 //x2=35.952 //y2=4.265
r837 (  23 24 ) resistor r=0.830153 //w=0.131 //l=0.87 //layer=m1 \
 //thickness=0.36 //x=36.01 //y=4.425 //x2=36.01 //y2=5.295
r838 (  22 58 ) resistor r=0.0859108 //w=0.371 //l=0.171566 //layer=m1 \
 //thickness=0.36 //x=36.01 //y=4.105 //x2=35.952 //y2=4.25
r839 (  21 22 ) resistor r=2.08492 //w=0.131 //l=2.185 //layer=m1 \
 //thickness=0.36 //x=36.01 //y=1.92 //x2=36.01 //y2=4.105
r840 (  19 21 ) resistor r=0.0698411 //w=0.17 //l=0.120208 //layer=m1 \
 //thickness=0.36 //x=35.925 //y=1.835 //x2=36.01 //y2=1.92
r841 (  19 20 ) resistor r=0.257634 //w=0.131 //l=0.27 //layer=m1 \
 //thickness=0.36 //x=35.925 //y=1.835 //x2=35.655 //y2=1.835
r842 (  18 50 ) resistor r=0.0257089 //w=0.23 //l=0.115 //layer=m1 \
 //thickness=0.36 //x=35.645 //y=5.38 //x2=35.53 //y2=5.38
r843 (  17 24 ) resistor r=0.0698411 //w=0.17 //l=0.120208 //layer=m1 \
 //thickness=0.36 //x=35.925 //y=5.38 //x2=36.01 //y2=5.295
r844 (  17 18 ) resistor r=0.267176 //w=0.131 //l=0.28 //layer=m1 \
 //thickness=0.36 //x=35.925 //y=5.38 //x2=35.645 //y2=5.38
r845 (  16 20 ) resistor r=0.0698411 //w=0.17 //l=0.120208 //layer=m1 \
 //thickness=0.36 //x=35.57 //y=1.75 //x2=35.655 //y2=1.835
r846 (  15 55 ) resistor r=0.0913624 //w=0.191 //l=0.12 //layer=m1 \
 //thickness=0.36 //x=35.57 //y=1.3 //x2=35.57 //y2=1.18
r847 (  15 16 ) resistor r=0.429389 //w=0.131 //l=0.45 //layer=m1 \
 //thickness=0.36 //x=35.57 //y=1.3 //x2=35.57 //y2=1.75
r848 (  12 47 ) resistor r=0.0227762 //w=0.219 //l=0.115 //layer=m1 \
 //thickness=0.36 //x=34.765 //y=5.38 //x2=34.65 //y2=5.38
r849 (  11 50 ) resistor r=0.0257089 //w=0.23 //l=0.115 //layer=m1 \
 //thickness=0.36 //x=35.415 //y=5.38 //x2=35.53 //y2=5.38
r850 (  11 12 ) resistor r=0.620229 //w=0.131 //l=0.65 //layer=m1 \
 //thickness=0.36 //x=35.415 //y=5.38 //x2=34.765 //y2=5.38
r851 (  8 46 ) resistor r=0.0878548 //w=0.228 //l=0.159295 //layer=m1 \
 //thickness=0.36 //x=31.94 //y=4.735 //x2=31.97 //y2=4.88
r852 (  7 40 ) resistor r=0.0912814 //w=0.379 //l=0.183303 //layer=m1 \
 //thickness=0.36 //x=31.94 //y=4.415 //x2=31.89 //y2=4.255
r853 (  7 8 ) resistor r=0.305344 //w=0.131 //l=0.32 //layer=m1 \
 //thickness=0.36 //x=31.94 //y=4.415 //x2=31.94 //y2=4.735
r854 (  6 38 ) resistor r=0.0896323 //w=0.379 //l=0.178255 //layer=m1 \
 //thickness=0.36 //x=31.94 //y=4.095 //x2=31.89 //y2=4.25
r855 (  6 44 ) resistor r=1.63168 //w=0.131 //l=1.71 //layer=m1 \
 //thickness=0.36 //x=31.94 //y=4.095 //x2=31.94 //y2=2.385
r856 (  4 32 ) resistor r=0.0760407 //w=0.238 //l=0.125 //layer=m1 \
 //thickness=0.36 //x=23.06 //y=4.755 //x2=23.06 //y2=4.88
r857 (  3 36 ) resistor r=0.0910802 //w=0.374 //l=0.185472 //layer=m1 \
 //thickness=0.36 //x=23.06 //y=4.415 //x2=23.115 //y2=4.255
r858 (  3 4 ) resistor r=0.324427 //w=0.131 //l=0.34 //layer=m1 \
 //thickness=0.36 //x=23.06 //y=4.415 //x2=23.06 //y2=4.755
r859 (  2 34 ) resistor r=0.089409 //w=0.374 //l=0.180416 //layer=m1 \
 //thickness=0.36 //x=23.06 //y=4.095 //x2=23.115 //y2=4.25
r860 (  1 30 ) resistor r=0.0719237 //w=0.222 //l=0.115 //layer=m1 \
 //thickness=0.36 //x=23.06 //y=2.375 //x2=23.06 //y2=2.26
r861 (  1 2 ) resistor r=1.64122 //w=0.131 //l=1.72 //layer=m1 \
 //thickness=0.36 //x=23.06 //y=2.375 //x2=23.06 //y2=4.095
ends PM_TMRDFFQNX1\%noxref_11

subckt PM_TMRDFFQNX1\%noxref_12 ( 1 2 3 4 7 12 13 15 16 18 19 20 22 23 30 34 \
 35 38 40 43 48 50 53 54 56 57 58 60 62 65 72 73 76 85 90 98 115 124 128 129 \
 130 131 132 133 137 138 139 144 146 149 150 151 152 153 154 158 160 163 164 \
 169 170 175 184 187 189 190 )
c440 ( 187 0 ) capacitor c=0.00878249f //x=50.18 //y=1.085
c441 ( 184 0 ) capacitor c=0.0682508f //x=52.66 //y=4.88
c442 ( 175 0 ) capacitor c=0.0710066f //x=46.74 //y=4.88
c443 ( 170 0 ) capacitor c=0.0278202f //x=46.74 //y=2.095
c444 ( 169 0 ) capacitor c=0.0479324f //x=46.74 //y=2.26
c445 ( 164 0 ) capacitor c=0.0318956f //x=52.995 //y=1.39
c446 ( 163 0 ) capacitor c=0.0186809f //x=52.995 //y=1.045
c447 ( 160 0 ) capacitor c=0.0141821f //x=52.84 //y=1.545
c448 ( 158 0 ) capacitor c=0.0158553f //x=52.84 //y=0.89
c449 ( 154 0 ) capacitor c=0.0854171f //x=52.465 //y=2.095
c450 ( 153 0 ) capacitor c=0.0229235f //x=52.465 //y=1.7
c451 ( 152 0 ) capacitor c=0.0234359f //x=52.465 //y=1.39
c452 ( 151 0 ) capacitor c=0.0198759f //x=52.465 //y=1.045
c453 ( 150 0 ) capacitor c=0.0443175f //x=47.26 //y=1.44
c454 ( 149 0 ) capacitor c=0.0199703f //x=47.26 //y=1.095
c455 ( 146 0 ) capacitor c=0.0162526f //x=47.105 //y=1.595
c456 ( 144 0 ) capacitor c=0.0157807f //x=47.105 //y=0.94
c457 ( 139 0 ) capacitor c=0.0220935f //x=46.73 //y=1.75
c458 ( 138 0 ) capacitor c=0.0207489f //x=46.73 //y=1.44
c459 ( 137 0 ) capacitor c=0.0194091f //x=46.73 //y=1.095
c460 ( 133 0 ) capacitor c=0.110369f //x=53 //y=6.2
c461 ( 132 0 ) capacitor c=0.154619f //x=52.56 //y=6.2
c462 ( 131 0 ) capacitor c=0.159671f //x=46.92 //y=6.2
c463 ( 130 0 ) capacitor c=0.110208f //x=46.48 //y=6.2
c464 ( 124 0 ) capacitor c=8.13425e-19 //x=52.66 //y=4.88
c465 ( 115 0 ) capacitor c=7.85889e-19 //x=52.66 //y=2.26
c466 ( 98 0 ) capacitor c=0.0322017f //x=50.33 //y=5.56
c467 ( 90 0 ) capacitor c=0.0290186f //x=49.45 //y=5.56
c468 ( 85 0 ) capacitor c=8.10944e-19 //x=46.74 //y=4.88
c469 ( 76 0 ) capacitor c=0.00101179f //x=46.74 //y=2.26
c470 ( 73 0 ) capacitor c=0.0202533f //x=52.495 //y=3.505
c471 ( 72 0 ) capacitor c=4.79889e-19 //x=52.655 //y=3.505
c472 ( 65 0 ) capacitor c=0.00865094f //x=50.965 //y=3.51
c473 ( 62 0 ) capacitor c=0.00209252f //x=49.54 //y=3.495
c474 ( 60 0 ) capacitor c=0.0155233f //x=48.94 //y=3.51
c475 ( 58 0 ) capacitor c=0.00615643f //x=47.695 //y=3.495
c476 ( 57 0 ) capacitor c=6.32236e-19 //x=46.905 //y=3.51
c477 ( 56 0 ) capacitor c=0.00294384f //x=47.095 //y=3.51
c478 ( 54 0 ) capacitor c=0.0267491f //x=52.662 //y=4.74
c479 ( 53 0 ) capacitor c=0.00611287f //x=52.66 //y=4.88
c480 ( 50 0 ) capacitor c=0.00463527f //x=52.66 //y=2.26
c481 ( 48 0 ) capacitor c=0.0163473f //x=52.66 //y=3.51
c482 ( 43 0 ) capacitor c=0.0170489f //x=50.805 //y=3.51
c483 ( 40 0 ) capacitor c=0.0113293f //x=50.37 //y=1.18
c484 ( 38 0 ) capacitor c=5.78613e-19 //x=50.33 //y=5.56
c485 ( 35 0 ) capacitor c=0.0105334f //x=50.33 //y=5.38
c486 ( 34 0 ) capacitor c=0.00923791f //x=49.45 //y=5.56
c487 ( 30 0 ) capacitor c=0.0148558f //x=46.74 //y=3.51
c488 ( 23 0 ) capacitor c=0.0131821f //x=52.66 //y=3.665
c489 ( 22 0 ) capacitor c=0.0254325f //x=52.66 //y=3.345
c490 ( 20 0 ) capacitor c=0.0405845f //x=50.81 //y=5.295
c491 ( 19 0 ) capacitor c=0.0134364f //x=50.81 //y=3.67
c492 ( 18 0 ) capacitor c=0.0353731f //x=50.81 //y=3.35
c493 ( 16 0 ) capacitor c=0.00466468f //x=50.455 //y=1.835
c494 ( 15 0 ) capacitor c=0.0117367f //x=50.725 //y=1.835
c495 ( 13 0 ) capacitor c=0.0108105f //x=50.725 //y=5.38
c496 ( 12 0 ) capacitor c=0.0102514f //x=50.37 //y=1.75
c497 ( 7 0 ) capacitor c=0.0143298f //x=50.215 //y=5.38
c498 ( 4 0 ) capacitor c=0.0286377f //x=46.74 //y=4.75
c499 ( 3 0 ) capacitor c=0.012605f //x=46.74 //y=3.67
c500 ( 2 0 ) capacitor c=0.0228533f //x=46.74 //y=3.35
c501 ( 1 0 ) capacitor c=0.00556102f //x=46.74 //y=2.375
r502 (  182 184 ) resistor r=20.6867 //w=0.233 //l=0.1 //layer=ply \
 //thickness=0.18 //x=52.56 //y=4.88 //x2=52.66 //y2=4.88
r503 (  169 170 ) resistor r=52.7279 //w=0.214 //l=0.165 //layer=ply \
 //thickness=0.18 //x=46.74 //y=2.26 //x2=46.74 //y2=2.095
r504 (  165 184 ) resistor r=70.3348 //w=0.233 //l=0.414367 //layer=ply \
 //thickness=0.18 //x=53 //y=5.045 //x2=52.66 //y2=4.88
r505 (  164 186 ) resistor r=45.1352 //w=0.168 //l=0.173853 //layer=ply \
 //thickness=0.18 //x=52.995 //y=1.39 //x2=52.955 //y2=1.545
r506 (  163 185 ) resistor r=45.1352 //w=0.168 //l=0.173853 //layer=ply \
 //thickness=0.18 //x=52.995 //y=1.045 //x2=52.955 //y2=0.89
r507 (  163 164 ) resistor r=176.904 //w=0.094 //l=0.345 //layer=ply \
 //thickness=0.18 //x=52.995 //y=1.045 //x2=52.995 //y2=1.39
r508 (  161 181 ) resistor r=10.701 //w=0.21 //l=0.115 //layer=ply \
 //thickness=0.18 //x=52.62 //y=1.545 //x2=52.505 //y2=1.545
r509 (  160 186 ) resistor r=5.52526 //w=0.168 //l=0.115 //layer=ply \
 //thickness=0.18 //x=52.84 //y=1.545 //x2=52.955 //y2=1.545
r510 (  159 180 ) resistor r=5.52526 //w=0.168 //l=0.115 //layer=ply \
 //thickness=0.18 //x=52.62 //y=0.89 //x2=52.505 //y2=0.89
r511 (  158 185 ) resistor r=5.52526 //w=0.168 //l=0.115 //layer=ply \
 //thickness=0.18 //x=52.84 //y=0.89 //x2=52.955 //y2=0.89
r512 (  158 159 ) resistor r=112.809 //w=0.094 //l=0.22 //layer=ply \
 //thickness=0.18 //x=52.84 //y=0.89 //x2=52.62 //y2=0.89
r513 (  155 182 ) resistor r=13.0941 //w=0.233 //l=0.165 //layer=ply \
 //thickness=0.18 //x=52.56 //y=5.045 //x2=52.56 //y2=4.88
r514 (  154 179 ) resistor r=34.8111 //w=0.27 //l=0.264953 //layer=ply \
 //thickness=0.18 //x=52.465 //y=2.095 //x2=52.66 //y2=2.26
r515 (  153 181 ) resistor r=39.5823 //w=0.21 //l=0.173853 //layer=ply \
 //thickness=0.18 //x=52.465 //y=1.7 //x2=52.505 //y2=1.545
r516 (  153 154 ) resistor r=202.543 //w=0.094 //l=0.395 //layer=ply \
 //thickness=0.18 //x=52.465 //y=1.7 //x2=52.465 //y2=2.095
r517 (  152 181 ) resistor r=39.5823 //w=0.21 //l=0.173853 //layer=ply \
 //thickness=0.18 //x=52.465 //y=1.39 //x2=52.505 //y2=1.545
r518 (  151 180 ) resistor r=45.1352 //w=0.168 //l=0.173853 //layer=ply \
 //thickness=0.18 //x=52.465 //y=1.045 //x2=52.505 //y2=0.89
r519 (  151 152 ) resistor r=176.904 //w=0.094 //l=0.345 //layer=ply \
 //thickness=0.18 //x=52.465 //y=1.045 //x2=52.465 //y2=1.39
r520 (  150 177 ) resistor r=45.1352 //w=0.168 //l=0.173853 //layer=ply \
 //thickness=0.18 //x=47.26 //y=1.44 //x2=47.22 //y2=1.595
r521 (  149 176 ) resistor r=45.1352 //w=0.168 //l=0.173853 //layer=ply \
 //thickness=0.18 //x=47.26 //y=1.095 //x2=47.22 //y2=0.94
r522 (  149 150 ) resistor r=176.904 //w=0.094 //l=0.345 //layer=ply \
 //thickness=0.18 //x=47.26 //y=1.095 //x2=47.26 //y2=1.44
r523 (  147 173 ) resistor r=10.701 //w=0.21 //l=0.115 //layer=ply \
 //thickness=0.18 //x=46.885 //y=1.595 //x2=46.77 //y2=1.595
r524 (  146 177 ) resistor r=5.52526 //w=0.168 //l=0.115 //layer=ply \
 //thickness=0.18 //x=47.105 //y=1.595 //x2=47.22 //y2=1.595
r525 (  145 172 ) resistor r=5.52526 //w=0.168 //l=0.115 //layer=ply \
 //thickness=0.18 //x=46.885 //y=0.94 //x2=46.77 //y2=0.94
r526 (  144 176 ) resistor r=5.52526 //w=0.168 //l=0.115 //layer=ply \
 //thickness=0.18 //x=47.105 //y=0.94 //x2=47.22 //y2=0.94
r527 (  144 145 ) resistor r=112.809 //w=0.094 //l=0.22 //layer=ply \
 //thickness=0.18 //x=47.105 //y=0.94 //x2=46.885 //y2=0.94
r528 (  141 175 ) resistor r=37.236 //w=0.233 //l=0.249199 //layer=ply \
 //thickness=0.18 //x=46.92 //y=5.045 //x2=46.74 //y2=4.88
r529 (  139 173 ) resistor r=39.5823 //w=0.21 //l=0.173853 //layer=ply \
 //thickness=0.18 //x=46.73 //y=1.75 //x2=46.77 //y2=1.595
r530 (  139 170 ) resistor r=176.904 //w=0.094 //l=0.345 //layer=ply \
 //thickness=0.18 //x=46.73 //y=1.75 //x2=46.73 //y2=2.095
r531 (  138 173 ) resistor r=39.5823 //w=0.21 //l=0.173853 //layer=ply \
 //thickness=0.18 //x=46.73 //y=1.44 //x2=46.77 //y2=1.595
r532 (  137 172 ) resistor r=45.1352 //w=0.168 //l=0.173853 //layer=ply \
 //thickness=0.18 //x=46.73 //y=1.095 //x2=46.77 //y2=0.94
r533 (  137 138 ) resistor r=176.904 //w=0.094 //l=0.345 //layer=ply \
 //thickness=0.18 //x=46.73 //y=1.095 //x2=46.73 //y2=1.44
r534 (  134 175 ) resistor r=53.7854 //w=0.233 //l=0.332415 //layer=ply \
 //thickness=0.18 //x=46.48 //y=5.045 //x2=46.74 //y2=4.88
r535 (  133 165 ) resistor r=592.245 //w=0.094 //l=1.155 //layer=ply \
 //thickness=0.18 //x=53 //y=6.2 //x2=53 //y2=5.045
r536 (  132 155 ) resistor r=592.245 //w=0.094 //l=1.155 //layer=ply \
 //thickness=0.18 //x=52.56 //y=6.2 //x2=52.56 //y2=5.045
r537 (  131 141 ) resistor r=592.245 //w=0.094 //l=1.155 //layer=ply \
 //thickness=0.18 //x=46.92 //y=6.2 //x2=46.92 //y2=5.045
r538 (  130 134 ) resistor r=592.245 //w=0.094 //l=1.155 //layer=ply \
 //thickness=0.18 //x=46.48 //y=6.2 //x2=46.48 //y2=5.045
r539 (  129 160 ) resistor r=56.4043 //w=0.094 //l=0.11 //layer=ply \
 //thickness=0.18 //x=52.73 //y=1.545 //x2=52.84 //y2=1.545
r540 (  129 161 ) resistor r=56.4043 //w=0.094 //l=0.11 //layer=ply \
 //thickness=0.18 //x=52.73 //y=1.545 //x2=52.62 //y2=1.545
r541 (  128 146 ) resistor r=56.4043 //w=0.094 //l=0.11 //layer=ply \
 //thickness=0.18 //x=46.995 //y=1.595 //x2=47.105 //y2=1.595
r542 (  128 147 ) resistor r=56.4043 //w=0.094 //l=0.11 //layer=ply \
 //thickness=0.18 //x=46.995 //y=1.595 //x2=46.885 //y2=1.595
r543 (  124 184 ) resistor r=152 //w=0.17 //l=0.17 //layer=licon //count=1 \
 //x=52.66 //y=4.88 //x2=52.66 //y2=4.88
r544 (  115 179 ) resistor r=152 //w=0.17 //l=0.17 //layer=licon //count=1 \
 //x=52.66 //y=2.26 //x2=52.66 //y2=2.26
r545 (  98 190 ) resistor r=23.615 //w=0.187 //l=0.345 //layer=li \
 //thickness=0.1 //x=50.33 //y=5.56 //x2=50.33 //y2=5.905
r546 (  90 189 ) resistor r=23.615 //w=0.187 //l=0.345 //layer=li \
 //thickness=0.1 //x=49.45 //y=5.56 //x2=49.45 //y2=5.905
r547 (  85 175 ) resistor r=152 //w=0.17 //l=0.17 //layer=licon //count=1 \
 //x=46.74 //y=4.88 //x2=46.74 //y2=4.88
r548 (  76 169 ) resistor r=152 //w=0.17 //l=0.17 //layer=licon //count=1 \
 //x=46.74 //y=2.26 //x2=46.74 //y2=2.26
r549 (  72 73 ) resistor r=0.10734 //w=0.281 //l=0.16 //layer=m2 \
 //thickness=0.36 //x=52.655 //y=3.505 //x2=52.495 //y2=3.505
r550 (  65 70 ) resistor r=0.10188 //w=0.204 //l=0.16 //layer=m2 \
 //thickness=0.36 //x=50.965 //y=3.51 //x2=50.805 //y2=3.51
r551 (  65 73 ) resistor r=1.45992 //w=0.131 //l=1.53 //layer=m2 \
 //thickness=0.36 //x=50.965 //y=3.51 //x2=52.495 //y2=3.51
r552 (  62 70 ) resistor r=0.778963 //w=0.204 //l=1.27248 //layer=m2 \
 //thickness=0.36 //x=49.54 //y=3.495 //x2=50.805 //y2=3.51
r553 (  62 63 ) resistor r=0.410305 //w=0.131 //l=0.43 //layer=m2 \
 //thickness=0.36 //x=49.54 //y=3.495 //x2=49.11 //y2=3.495
r554 (  60 63 ) resistor r=0.125 //w=0.17 //l=0.177341 //layer=m2 \
 //thickness=0.36 //x=48.94 //y=3.51 //x2=49.11 //y2=3.495
r555 (  60 61 ) resistor r=0.944656 //w=0.131 //l=0.99 //layer=m2 \
 //thickness=0.36 //x=48.94 //y=3.51 //x2=47.95 //y2=3.51
r556 (  58 61 ) resistor r=0.1875 //w=0.17 //l=0.262393 //layer=m2 \
 //thickness=0.36 //x=47.695 //y=3.495 //x2=47.95 //y2=3.51
r557 (  58 59 ) resistor r=0.410305 //w=0.131 //l=0.43 //layer=m2 \
 //thickness=0.36 //x=47.695 //y=3.495 //x2=47.265 //y2=3.495
r558 (  57 67 ) resistor r=0.10734 //w=0.281 //l=0.16 //layer=m2 \
 //thickness=0.36 //x=46.905 //y=3.51 //x2=46.745 //y2=3.51
r559 (  56 59 ) resistor r=0.125 //w=0.17 //l=0.177341 //layer=m2 \
 //thickness=0.36 //x=47.095 //y=3.51 //x2=47.265 //y2=3.495
r560 (  56 57 ) resistor r=0.181298 //w=0.131 //l=0.19 //layer=m2 \
 //thickness=0.36 //x=47.095 //y=3.51 //x2=46.905 //y2=3.51
r561 (  53 124 ) resistor r=9.3 //w=0.17 //l=0.17 //layer=mcon //count=1 \
 //x=52.66 //y=4.88 //x2=52.66 //y2=4.88
r562 (  53 54 ) resistor r=0.103207 //w=0.196 //l=0.14 //layer=m1 \
 //thickness=0.36 //x=52.662 //y=4.88 //x2=52.662 //y2=4.74
r563 (  50 115 ) resistor r=9.3 //w=0.17 //l=0.17 //layer=mcon //count=1 \
 //x=52.66 //y=2.26 //x2=52.66 //y2=2.26
r564 (  46 72 ) resistor r=4.5 //w=0.15 //l=0.15 //layer=via1 //count=1 \
 //x=52.655 //y=3.505 //x2=52.655 //y2=3.505
r565 (  46 48 ) resistor r=0.00167112 //w=0.374 //l=0.005 //layer=m1 \
 //thickness=0.36 //x=52.605 //y=3.505 //x2=52.605 //y2=3.51
r566 (  43 70 ) resistor r=4.5 //w=0.15 //l=0.15 //layer=via1 //count=1 \
 //x=50.805 //y=3.51 //x2=50.805 //y2=3.51
r567 (  40 187 ) resistor r=9.3 //w=0.17 //l=0.17 //layer=mcon //count=1 \
 //x=50.37 //y=1.18 //x2=50.37 //y2=1.18
r568 (  38 98 ) resistor r=9.3 //w=0.17 //l=0.17 //layer=mcon //count=1 \
 //x=50.33 //y=5.56 //x2=50.33 //y2=5.56
r569 (  35 38 ) resistor r=0.117801 //w=0.191 //l=0.18 //layer=m1 \
 //thickness=0.36 //x=50.33 //y=5.38 //x2=50.33 //y2=5.56
r570 (  34 90 ) resistor r=9.3 //w=0.17 //l=0.17 //layer=mcon //count=1 \
 //x=49.45 //y=5.56 //x2=49.45 //y2=5.56
r571 (  32 34 ) resistor r=0.10274 //w=0.219 //l=0.18 //layer=m1 \
 //thickness=0.36 //x=49.45 //y=5.38 //x2=49.45 //y2=5.56
r572 (  30 67 ) resistor r=4.5 //w=0.15 //l=0.15 //layer=via1 //count=1 \
 //x=46.745 //y=3.51 //x2=46.745 //y2=3.51
r573 (  28 85 ) resistor r=9.3 //w=0.17 //l=0.17 //layer=mcon //count=1 \
 //x=46.74 //y=4.88 //x2=46.74 //y2=4.88
r574 (  26 76 ) resistor r=9.3 //w=0.17 //l=0.17 //layer=mcon //count=1 \
 //x=46.74 //y=2.26 //x2=46.74 //y2=2.26
r575 (  23 48 ) resistor r=0.089409 //w=0.374 //l=0.180416 //layer=m1 \
 //thickness=0.36 //x=52.66 //y=3.665 //x2=52.605 //y2=3.51
r576 (  23 54 ) resistor r=1.02576 //w=0.131 //l=1.075 //layer=m1 \
 //thickness=0.36 //x=52.66 //y=3.665 //x2=52.66 //y2=4.74
r577 (  22 46 ) resistor r=0.0910802 //w=0.374 //l=0.185472 //layer=m1 \
 //thickness=0.36 //x=52.66 //y=3.345 //x2=52.605 //y2=3.505
r578 (  21 50 ) resistor r=0.0933015 //w=0.201 //l=0.125 //layer=m1 \
 //thickness=0.36 //x=52.66 //y=2.385 //x2=52.66 //y2=2.26
r579 (  21 22 ) resistor r=0.916031 //w=0.131 //l=0.96 //layer=m1 \
 //thickness=0.36 //x=52.66 //y=2.385 //x2=52.66 //y2=3.345
r580 (  19 43 ) resistor r=0.0910802 //w=0.374 //l=0.185472 //layer=m1 \
 //thickness=0.36 //x=50.81 //y=3.67 //x2=50.755 //y2=3.51
r581 (  19 20 ) resistor r=1.55057 //w=0.131 //l=1.625 //layer=m1 \
 //thickness=0.36 //x=50.81 //y=3.67 //x2=50.81 //y2=5.295
r582 (  18 43 ) resistor r=0.0910802 //w=0.374 //l=0.185472 //layer=m1 \
 //thickness=0.36 //x=50.81 //y=3.35 //x2=50.755 //y2=3.51
r583 (  17 18 ) resistor r=1.3645 //w=0.131 //l=1.43 //layer=m1 \
 //thickness=0.36 //x=50.81 //y=1.92 //x2=50.81 //y2=3.35
r584 (  15 17 ) resistor r=0.0698411 //w=0.17 //l=0.120208 //layer=m1 \
 //thickness=0.36 //x=50.725 //y=1.835 //x2=50.81 //y2=1.92
r585 (  15 16 ) resistor r=0.257634 //w=0.131 //l=0.27 //layer=m1 \
 //thickness=0.36 //x=50.725 //y=1.835 //x2=50.455 //y2=1.835
r586 (  14 35 ) resistor r=0.0257089 //w=0.23 //l=0.115 //layer=m1 \
 //thickness=0.36 //x=50.445 //y=5.38 //x2=50.33 //y2=5.38
r587 (  13 20 ) resistor r=0.0698411 //w=0.17 //l=0.120208 //layer=m1 \
 //thickness=0.36 //x=50.725 //y=5.38 //x2=50.81 //y2=5.295
r588 (  13 14 ) resistor r=0.267176 //w=0.131 //l=0.28 //layer=m1 \
 //thickness=0.36 //x=50.725 //y=5.38 //x2=50.445 //y2=5.38
r589 (  12 16 ) resistor r=0.0698411 //w=0.17 //l=0.120208 //layer=m1 \
 //thickness=0.36 //x=50.37 //y=1.75 //x2=50.455 //y2=1.835
r590 (  11 40 ) resistor r=0.0913624 //w=0.191 //l=0.12 //layer=m1 \
 //thickness=0.36 //x=50.37 //y=1.3 //x2=50.37 //y2=1.18
r591 (  11 12 ) resistor r=0.429389 //w=0.131 //l=0.45 //layer=m1 \
 //thickness=0.36 //x=50.37 //y=1.3 //x2=50.37 //y2=1.75
r592 (  8 32 ) resistor r=0.0227762 //w=0.219 //l=0.115 //layer=m1 \
 //thickness=0.36 //x=49.565 //y=5.38 //x2=49.45 //y2=5.38
r593 (  7 35 ) resistor r=0.0257089 //w=0.23 //l=0.115 //layer=m1 \
 //thickness=0.36 //x=50.215 //y=5.38 //x2=50.33 //y2=5.38
r594 (  7 8 ) resistor r=0.620229 //w=0.131 //l=0.65 //layer=m1 \
 //thickness=0.36 //x=50.215 //y=5.38 //x2=49.565 //y2=5.38
r595 (  4 28 ) resistor r=0.0801089 //w=0.224 //l=0.13 //layer=m1 \
 //thickness=0.36 //x=46.74 //y=4.75 //x2=46.74 //y2=4.88
r596 (  3 30 ) resistor r=0.0910802 //w=0.374 //l=0.185472 //layer=m1 \
 //thickness=0.36 //x=46.74 //y=3.67 //x2=46.795 //y2=3.51
r597 (  3 4 ) resistor r=1.03053 //w=0.131 //l=1.08 //layer=m1 \
 //thickness=0.36 //x=46.74 //y=3.67 //x2=46.74 //y2=4.75
r598 (  2 30 ) resistor r=0.0910802 //w=0.374 //l=0.185472 //layer=m1 \
 //thickness=0.36 //x=46.74 //y=3.35 //x2=46.795 //y2=3.51
r599 (  1 26 ) resistor r=0.0719237 //w=0.222 //l=0.115 //layer=m1 \
 //thickness=0.36 //x=46.74 //y=2.375 //x2=46.74 //y2=2.26
r600 (  1 2 ) resistor r=0.930344 //w=0.131 //l=0.975 //layer=m1 \
 //thickness=0.36 //x=46.74 //y=2.375 //x2=46.74 //y2=3.35
ends PM_TMRDFFQNX1\%noxref_12

subckt PM_TMRDFFQNX1\%noxref_13 ( 3 8 9 11 12 14 15 16 18 19 23 24 27 29 32 35 \
 38 41 42 44 45 50 53 61 78 87 91 92 93 94 95 96 97 101 103 106 107 117 120 \
 122 123 )
c289 ( 120 0 ) capacitor c=0.00878249f //x=53.51 //y=1.085
c290 ( 117 0 ) capacitor c=0.0682508f //x=55.99 //y=4.88
c291 ( 107 0 ) capacitor c=0.0318956f //x=56.325 //y=1.39
c292 ( 106 0 ) capacitor c=0.0186809f //x=56.325 //y=1.045
c293 ( 103 0 ) capacitor c=0.0141821f //x=56.17 //y=1.545
c294 ( 101 0 ) capacitor c=0.0158553f //x=56.17 //y=0.89
c295 ( 97 0 ) capacitor c=0.0854195f //x=55.795 //y=2.095
c296 ( 96 0 ) capacitor c=0.0229235f //x=55.795 //y=1.7
c297 ( 95 0 ) capacitor c=0.0234359f //x=55.795 //y=1.39
c298 ( 94 0 ) capacitor c=0.0198759f //x=55.795 //y=1.045
c299 ( 93 0 ) capacitor c=0.110369f //x=56.33 //y=6.2
c300 ( 92 0 ) capacitor c=0.154619f //x=55.89 //y=6.2
c301 ( 87 0 ) capacitor c=8.13425e-19 //x=55.99 //y=4.88
c302 ( 78 0 ) capacitor c=7.85889e-19 //x=55.99 //y=2.26
c303 ( 61 0 ) capacitor c=0.0322017f //x=53.66 //y=5.56
c304 ( 53 0 ) capacitor c=0.0291714f //x=52.78 //y=5.56
c305 ( 50 0 ) capacitor c=4.79804e-19 //x=55.985 //y=3.51
c306 ( 45 0 ) capacitor c=7.23354e-19 //x=54.305 //y=3.51
c307 ( 44 0 ) capacitor c=0.018923f //x=55.825 //y=3.51
c308 ( 42 0 ) capacitor c=0.0270852f //x=55.992 //y=4.74
c309 ( 41 0 ) capacitor c=0.0060492f //x=55.99 //y=4.88
c310 ( 38 0 ) capacitor c=0.00463527f //x=55.99 //y=2.26
c311 ( 35 0 ) capacitor c=0.0164425f //x=55.985 //y=3.51
c312 ( 32 0 ) capacitor c=0.0167895f //x=54.14 //y=3.51
c313 ( 29 0 ) capacitor c=0.0113259f //x=53.7 //y=1.18
c314 ( 27 0 ) capacitor c=5.78613e-19 //x=53.66 //y=5.56
c315 ( 24 0 ) capacitor c=0.0103127f //x=53.66 //y=5.38
c316 ( 23 0 ) capacitor c=0.00933334f //x=52.78 //y=5.56
c317 ( 19 0 ) capacitor c=0.0131304f //x=55.99 //y=3.67
c318 ( 18 0 ) capacitor c=0.0254889f //x=55.99 //y=3.35
c319 ( 16 0 ) capacitor c=0.0402141f //x=54.14 //y=5.295
c320 ( 15 0 ) capacitor c=0.0132742f //x=54.14 //y=3.67
c321 ( 14 0 ) capacitor c=0.0374345f //x=54.14 //y=3.35
c322 ( 12 0 ) capacitor c=0.00465779f //x=53.785 //y=1.835
c323 ( 11 0 ) capacitor c=0.0117221f //x=54.055 //y=1.835
c324 ( 9 0 ) capacitor c=0.0112475f //x=54.055 //y=5.38
c325 ( 8 0 ) capacitor c=0.0101547f //x=53.7 //y=1.75
c326 ( 3 0 ) capacitor c=0.0134484f //x=53.545 //y=5.38
r327 (  115 117 ) resistor r=20.6867 //w=0.233 //l=0.1 //layer=ply \
 //thickness=0.18 //x=55.89 //y=4.88 //x2=55.99 //y2=4.88
r328 (  108 117 ) resistor r=70.3348 //w=0.233 //l=0.414367 //layer=ply \
 //thickness=0.18 //x=56.33 //y=5.045 //x2=55.99 //y2=4.88
r329 (  107 119 ) resistor r=45.1352 //w=0.168 //l=0.173853 //layer=ply \
 //thickness=0.18 //x=56.325 //y=1.39 //x2=56.285 //y2=1.545
r330 (  106 118 ) resistor r=45.1352 //w=0.168 //l=0.173853 //layer=ply \
 //thickness=0.18 //x=56.325 //y=1.045 //x2=56.285 //y2=0.89
r331 (  106 107 ) resistor r=176.904 //w=0.094 //l=0.345 //layer=ply \
 //thickness=0.18 //x=56.325 //y=1.045 //x2=56.325 //y2=1.39
r332 (  104 114 ) resistor r=10.701 //w=0.21 //l=0.115 //layer=ply \
 //thickness=0.18 //x=55.95 //y=1.545 //x2=55.835 //y2=1.545
r333 (  103 119 ) resistor r=5.52526 //w=0.168 //l=0.115 //layer=ply \
 //thickness=0.18 //x=56.17 //y=1.545 //x2=56.285 //y2=1.545
r334 (  102 113 ) resistor r=5.52526 //w=0.168 //l=0.115 //layer=ply \
 //thickness=0.18 //x=55.95 //y=0.89 //x2=55.835 //y2=0.89
r335 (  101 118 ) resistor r=5.52526 //w=0.168 //l=0.115 //layer=ply \
 //thickness=0.18 //x=56.17 //y=0.89 //x2=56.285 //y2=0.89
r336 (  101 102 ) resistor r=112.809 //w=0.094 //l=0.22 //layer=ply \
 //thickness=0.18 //x=56.17 //y=0.89 //x2=55.95 //y2=0.89
r337 (  98 115 ) resistor r=13.0941 //w=0.233 //l=0.165 //layer=ply \
 //thickness=0.18 //x=55.89 //y=5.045 //x2=55.89 //y2=4.88
r338 (  97 112 ) resistor r=34.8111 //w=0.27 //l=0.264953 //layer=ply \
 //thickness=0.18 //x=55.795 //y=2.095 //x2=55.99 //y2=2.26
r339 (  96 114 ) resistor r=39.5823 //w=0.21 //l=0.173853 //layer=ply \
 //thickness=0.18 //x=55.795 //y=1.7 //x2=55.835 //y2=1.545
r340 (  96 97 ) resistor r=202.543 //w=0.094 //l=0.395 //layer=ply \
 //thickness=0.18 //x=55.795 //y=1.7 //x2=55.795 //y2=2.095
r341 (  95 114 ) resistor r=39.5823 //w=0.21 //l=0.173853 //layer=ply \
 //thickness=0.18 //x=55.795 //y=1.39 //x2=55.835 //y2=1.545
r342 (  94 113 ) resistor r=45.1352 //w=0.168 //l=0.173853 //layer=ply \
 //thickness=0.18 //x=55.795 //y=1.045 //x2=55.835 //y2=0.89
r343 (  94 95 ) resistor r=176.904 //w=0.094 //l=0.345 //layer=ply \
 //thickness=0.18 //x=55.795 //y=1.045 //x2=55.795 //y2=1.39
r344 (  93 108 ) resistor r=592.245 //w=0.094 //l=1.155 //layer=ply \
 //thickness=0.18 //x=56.33 //y=6.2 //x2=56.33 //y2=5.045
r345 (  92 98 ) resistor r=592.245 //w=0.094 //l=1.155 //layer=ply \
 //thickness=0.18 //x=55.89 //y=6.2 //x2=55.89 //y2=5.045
r346 (  91 103 ) resistor r=56.4043 //w=0.094 //l=0.11 //layer=ply \
 //thickness=0.18 //x=56.06 //y=1.545 //x2=56.17 //y2=1.545
r347 (  91 104 ) resistor r=56.4043 //w=0.094 //l=0.11 //layer=ply \
 //thickness=0.18 //x=56.06 //y=1.545 //x2=55.95 //y2=1.545
r348 (  87 117 ) resistor r=152 //w=0.17 //l=0.17 //layer=licon //count=1 \
 //x=55.99 //y=4.88 //x2=55.99 //y2=4.88
r349 (  78 112 ) resistor r=152 //w=0.17 //l=0.17 //layer=licon //count=1 \
 //x=55.99 //y=2.26 //x2=55.99 //y2=2.26
r350 (  61 123 ) resistor r=23.615 //w=0.187 //l=0.345 //layer=li \
 //thickness=0.1 //x=53.66 //y=5.56 //x2=53.66 //y2=5.905
r351 (  53 122 ) resistor r=23.615 //w=0.187 //l=0.345 //layer=li \
 //thickness=0.1 //x=52.78 //y=5.56 //x2=52.78 //y2=5.905
r352 (  45 47 ) resistor r=0.10734 //w=0.281 //l=0.16 //layer=m2 \
 //thickness=0.36 //x=54.305 //y=3.51 //x2=54.145 //y2=3.51
r353 (  44 50 ) resistor r=0.10734 //w=0.281 //l=0.16 //layer=m2 \
 //thickness=0.36 //x=55.825 //y=3.51 //x2=55.985 //y2=3.51
r354 (  44 45 ) resistor r=1.45038 //w=0.131 //l=1.52 //layer=m2 \
 //thickness=0.36 //x=55.825 //y=3.51 //x2=54.305 //y2=3.51
r355 (  41 87 ) resistor r=9.3 //w=0.17 //l=0.17 //layer=mcon //count=1 \
 //x=55.99 //y=4.88 //x2=55.99 //y2=4.88
r356 (  41 42 ) resistor r=0.103207 //w=0.196 //l=0.14 //layer=m1 \
 //thickness=0.36 //x=55.992 //y=4.88 //x2=55.992 //y2=4.74
r357 (  38 78 ) resistor r=9.3 //w=0.17 //l=0.17 //layer=mcon //count=1 \
 //x=55.99 //y=2.26 //x2=55.99 //y2=2.26
r358 (  35 50 ) resistor r=4.5 //w=0.15 //l=0.15 //layer=via1 //count=1 \
 //x=55.985 //y=3.51 //x2=55.985 //y2=3.51
r359 (  32 47 ) resistor r=4.5 //w=0.15 //l=0.15 //layer=via1 //count=1 \
 //x=54.145 //y=3.51 //x2=54.145 //y2=3.51
r360 (  29 120 ) resistor r=9.3 //w=0.17 //l=0.17 //layer=mcon //count=1 \
 //x=53.7 //y=1.18 //x2=53.7 //y2=1.18
r361 (  27 61 ) resistor r=9.3 //w=0.17 //l=0.17 //layer=mcon //count=1 \
 //x=53.66 //y=5.56 //x2=53.66 //y2=5.56
r362 (  24 27 ) resistor r=0.117801 //w=0.191 //l=0.18 //layer=m1 \
 //thickness=0.36 //x=53.66 //y=5.38 //x2=53.66 //y2=5.56
r363 (  23 53 ) resistor r=9.3 //w=0.17 //l=0.17 //layer=mcon //count=1 \
 //x=52.78 //y=5.56 //x2=52.78 //y2=5.56
r364 (  21 23 ) resistor r=0.10274 //w=0.219 //l=0.18 //layer=m1 \
 //thickness=0.36 //x=52.78 //y=5.38 //x2=52.78 //y2=5.56
r365 (  19 35 ) resistor r=0.0910802 //w=0.374 //l=0.185472 //layer=m1 \
 //thickness=0.36 //x=55.99 //y=3.67 //x2=55.935 //y2=3.51
r366 (  19 42 ) resistor r=1.02099 //w=0.131 //l=1.07 //layer=m1 \
 //thickness=0.36 //x=55.99 //y=3.67 //x2=55.99 //y2=4.74
r367 (  18 35 ) resistor r=0.0910802 //w=0.374 //l=0.185472 //layer=m1 \
 //thickness=0.36 //x=55.99 //y=3.35 //x2=55.935 //y2=3.51
r368 (  17 38 ) resistor r=0.0933015 //w=0.201 //l=0.125 //layer=m1 \
 //thickness=0.36 //x=55.99 //y=2.385 //x2=55.99 //y2=2.26
r369 (  17 18 ) resistor r=0.920802 //w=0.131 //l=0.965 //layer=m1 \
 //thickness=0.36 //x=55.99 //y=2.385 //x2=55.99 //y2=3.35
r370 (  15 32 ) resistor r=0.0910802 //w=0.374 //l=0.185472 //layer=m1 \
 //thickness=0.36 //x=54.14 //y=3.67 //x2=54.195 //y2=3.51
r371 (  15 16 ) resistor r=1.55057 //w=0.131 //l=1.625 //layer=m1 \
 //thickness=0.36 //x=54.14 //y=3.67 //x2=54.14 //y2=5.295
r372 (  14 32 ) resistor r=0.0910802 //w=0.374 //l=0.185472 //layer=m1 \
 //thickness=0.36 //x=54.14 //y=3.35 //x2=54.195 //y2=3.51
r373 (  13 14 ) resistor r=1.3645 //w=0.131 //l=1.43 //layer=m1 \
 //thickness=0.36 //x=54.14 //y=1.92 //x2=54.14 //y2=3.35
r374 (  11 13 ) resistor r=0.0698411 //w=0.17 //l=0.120208 //layer=m1 \
 //thickness=0.36 //x=54.055 //y=1.835 //x2=54.14 //y2=1.92
r375 (  11 12 ) resistor r=0.257634 //w=0.131 //l=0.27 //layer=m1 \
 //thickness=0.36 //x=54.055 //y=1.835 //x2=53.785 //y2=1.835
r376 (  10 24 ) resistor r=0.0257089 //w=0.23 //l=0.115 //layer=m1 \
 //thickness=0.36 //x=53.775 //y=5.38 //x2=53.66 //y2=5.38
r377 (  9 16 ) resistor r=0.0698411 //w=0.17 //l=0.120208 //layer=m1 \
 //thickness=0.36 //x=54.055 //y=5.38 //x2=54.14 //y2=5.295
r378 (  9 10 ) resistor r=0.267176 //w=0.131 //l=0.28 //layer=m1 \
 //thickness=0.36 //x=54.055 //y=5.38 //x2=53.775 //y2=5.38
r379 (  8 12 ) resistor r=0.0698411 //w=0.17 //l=0.120208 //layer=m1 \
 //thickness=0.36 //x=53.7 //y=1.75 //x2=53.785 //y2=1.835
r380 (  7 29 ) resistor r=0.0913624 //w=0.191 //l=0.12 //layer=m1 \
 //thickness=0.36 //x=53.7 //y=1.3 //x2=53.7 //y2=1.18
r381 (  7 8 ) resistor r=0.429389 //w=0.131 //l=0.45 //layer=m1 \
 //thickness=0.36 //x=53.7 //y=1.3 //x2=53.7 //y2=1.75
r382 (  4 21 ) resistor r=0.0227762 //w=0.219 //l=0.115 //layer=m1 \
 //thickness=0.36 //x=52.895 //y=5.38 //x2=52.78 //y2=5.38
r383 (  3 24 ) resistor r=0.0257089 //w=0.23 //l=0.115 //layer=m1 \
 //thickness=0.36 //x=53.545 //y=5.38 //x2=53.66 //y2=5.38
r384 (  3 4 ) resistor r=0.620229 //w=0.131 //l=0.65 //layer=m1 \
 //thickness=0.36 //x=53.545 //y=5.38 //x2=52.895 //y2=5.38
ends PM_TMRDFFQNX1\%noxref_13

subckt PM_TMRDFFQNX1\%CLK ( 1 2 3 4 5 6 7 8 9 10 11 12 13 14 15 16 17 18 19 20 \
 32 41 52 58 64 68 74 80 84 90 96 99 101 103 104 107 108 109 111 113 117 119 \
 120 121 122 123 125 127 129 133 135 136 137 142 150 155 160 165 170 175 180 \
 185 190 195 200 205 209 210 211 212 213 214 215 216 217 218 219 220 221 222 \
 223 224 225 226 227 228 229 231 237 238 239 240 241 246 247 248 253 255 257 \
 263 264 265 266 267 269 275 276 277 278 279 284 285 286 291 293 295 301 302 \
 303 304 305 307 313 314 315 316 317 322 323 324 329 331 333 339 340 344 353 \
 354 357 368 377 378 381 392 401 402 405 )
c998 ( 405 0 ) capacitor c=0.0366322f //x=56.76 //y=4.88
c999 ( 402 0 ) capacitor c=0.0284095f //x=56.73 //y=2.095
c1000 ( 401 0 ) capacitor c=0.0476356f //x=56.73 //y=2.26
c1001 ( 392 0 ) capacitor c=0.0372825f //x=45.63 //y=4.88
c1002 ( 381 0 ) capacitor c=0.0366322f //x=35.3 //y=4.88
c1003 ( 378 0 ) capacitor c=0.0284095f //x=35.27 //y=2.095
c1004 ( 377 0 ) capacitor c=0.0476356f //x=35.27 //y=2.26
c1005 ( 368 0 ) capacitor c=0.0372825f //x=24.17 //y=4.88
c1006 ( 357 0 ) capacitor c=0.0366322f //x=13.84 //y=4.88
c1007 ( 354 0 ) capacitor c=0.0284095f //x=13.81 //y=2.095
c1008 ( 353 0 ) capacitor c=0.0476356f //x=13.81 //y=2.26
c1009 ( 344 0 ) capacitor c=0.0372825f //x=2.71 //y=4.88
c1010 ( 340 0 ) capacitor c=0.0439708f //x=57.295 //y=1.43
c1011 ( 339 0 ) capacitor c=0.0192582f //x=57.295 //y=1.085
c1012 ( 333 0 ) capacitor c=0.0162526f //x=57.14 //y=1.585
c1013 ( 331 0 ) capacitor c=0.0157807f //x=57.14 //y=0.93
c1014 ( 329 0 ) capacitor c=0.0353784f //x=57.135 //y=4.97
c1015 ( 324 0 ) capacitor c=0.0210762f //x=56.765 //y=1.74
c1016 ( 323 0 ) capacitor c=0.0168511f //x=56.765 //y=1.43
c1017 ( 322 0 ) capacitor c=0.0175485f //x=56.765 //y=1.085
c1018 ( 317 0 ) capacitor c=0.0305913f //x=45.965 //y=4.97
c1019 ( 316 0 ) capacitor c=0.0863671f //x=45.72 //y=2.095
c1020 ( 315 0 ) capacitor c=0.0170266f //x=45.72 //y=1.63
c1021 ( 314 0 ) capacitor c=0.018609f //x=45.72 //y=1.4
c1022 ( 313 0 ) capacitor c=0.0186599f //x=45.72 //y=1.09
c1023 ( 307 0 ) capacitor c=0.0146988f //x=45.565 //y=1.555
c1024 ( 305 0 ) capacitor c=0.0148531f //x=45.565 //y=0.935
c1025 ( 304 0 ) capacitor c=0.0334406f //x=45.195 //y=1.4
c1026 ( 303 0 ) capacitor c=0.0173191f //x=45.195 //y=1.09
c1027 ( 302 0 ) capacitor c=0.0439708f //x=35.835 //y=1.43
c1028 ( 301 0 ) capacitor c=0.0192582f //x=35.835 //y=1.085
c1029 ( 295 0 ) capacitor c=0.0162526f //x=35.68 //y=1.585
c1030 ( 293 0 ) capacitor c=0.0157807f //x=35.68 //y=0.93
c1031 ( 291 0 ) capacitor c=0.0353784f //x=35.675 //y=4.97
c1032 ( 286 0 ) capacitor c=0.0210762f //x=35.305 //y=1.74
c1033 ( 285 0 ) capacitor c=0.0168511f //x=35.305 //y=1.43
c1034 ( 284 0 ) capacitor c=0.0175485f //x=35.305 //y=1.085
c1035 ( 279 0 ) capacitor c=0.0305913f //x=24.505 //y=4.97
c1036 ( 278 0 ) capacitor c=0.0863671f //x=24.26 //y=2.095
c1037 ( 277 0 ) capacitor c=0.0170266f //x=24.26 //y=1.63
c1038 ( 276 0 ) capacitor c=0.018609f //x=24.26 //y=1.4
c1039 ( 275 0 ) capacitor c=0.0186599f //x=24.26 //y=1.09
c1040 ( 269 0 ) capacitor c=0.0146988f //x=24.105 //y=1.555
c1041 ( 267 0 ) capacitor c=0.0148531f //x=24.105 //y=0.935
c1042 ( 266 0 ) capacitor c=0.0334406f //x=23.735 //y=1.4
c1043 ( 265 0 ) capacitor c=0.0173191f //x=23.735 //y=1.09
c1044 ( 264 0 ) capacitor c=0.0439708f //x=14.375 //y=1.43
c1045 ( 263 0 ) capacitor c=0.0192582f //x=14.375 //y=1.085
c1046 ( 257 0 ) capacitor c=0.0162526f //x=14.22 //y=1.585
c1047 ( 255 0 ) capacitor c=0.0157807f //x=14.22 //y=0.93
c1048 ( 253 0 ) capacitor c=0.0353784f //x=14.215 //y=4.97
c1049 ( 248 0 ) capacitor c=0.0210762f //x=13.845 //y=1.74
c1050 ( 247 0 ) capacitor c=0.0168511f //x=13.845 //y=1.43
c1051 ( 246 0 ) capacitor c=0.0175485f //x=13.845 //y=1.085
c1052 ( 241 0 ) capacitor c=0.0305913f //x=3.045 //y=4.97
c1053 ( 240 0 ) capacitor c=0.0863671f //x=2.8 //y=2.095
c1054 ( 239 0 ) capacitor c=0.0170266f //x=2.8 //y=1.63
c1055 ( 238 0 ) capacitor c=0.018609f //x=2.8 //y=1.4
c1056 ( 237 0 ) capacitor c=0.0186599f //x=2.8 //y=1.09
c1057 ( 231 0 ) capacitor c=0.0146988f //x=2.645 //y=1.555
c1058 ( 229 0 ) capacitor c=0.0148531f //x=2.645 //y=0.935
c1059 ( 228 0 ) capacitor c=0.0334406f //x=2.275 //y=1.4
c1060 ( 227 0 ) capacitor c=0.0173191f //x=2.275 //y=1.09
c1061 ( 226 0 ) capacitor c=0.155269f //x=57.21 //y=6.2
c1062 ( 225 0 ) capacitor c=0.110375f //x=56.77 //y=6.2
c1063 ( 224 0 ) capacitor c=0.110208f //x=46.04 //y=6.2
c1064 ( 223 0 ) capacitor c=0.110214f //x=45.6 //y=6.2
c1065 ( 222 0 ) capacitor c=0.155269f //x=35.75 //y=6.2
c1066 ( 221 0 ) capacitor c=0.110375f //x=35.31 //y=6.2
c1067 ( 220 0 ) capacitor c=0.110208f //x=24.58 //y=6.2
c1068 ( 219 0 ) capacitor c=0.110214f //x=24.14 //y=6.2
c1069 ( 218 0 ) capacitor c=0.155269f //x=14.29 //y=6.2
c1070 ( 217 0 ) capacitor c=0.110375f //x=13.85 //y=6.2
c1071 ( 216 0 ) capacitor c=0.110208f //x=3.12 //y=6.2
c1072 ( 215 0 ) capacitor c=0.110214f //x=2.68 //y=6.2
c1073 ( 205 0 ) capacitor c=8.63406e-19 //x=56.76 //y=4.88
c1074 ( 200 0 ) capacitor c=7.72439e-19 //x=56.73 //y=2.26
c1075 ( 195 0 ) capacitor c=0.00143828f //x=45.63 //y=4.88
c1076 ( 190 0 ) capacitor c=0.00121786f //x=45.63 //y=2.26
c1077 ( 185 0 ) capacitor c=8.63406e-19 //x=35.3 //y=4.88
c1078 ( 180 0 ) capacitor c=7.72439e-19 //x=35.27 //y=2.26
c1079 ( 175 0 ) capacitor c=0.00143828f //x=24.17 //y=4.88
c1080 ( 170 0 ) capacitor c=0.00121786f //x=24.17 //y=2.26
c1081 ( 165 0 ) capacitor c=8.63406e-19 //x=13.84 //y=4.88
c1082 ( 160 0 ) capacitor c=7.72439e-19 //x=13.81 //y=2.26
c1083 ( 155 0 ) capacitor c=0.00143828f //x=2.71 //y=4.88
c1084 ( 150 0 ) capacitor c=0.00121786f //x=2.71 //y=2.26
c1085 ( 142 0 ) capacitor c=0.0530028f //x=17.235 //y=4.62
c1086 ( 137 0 ) capacitor c=0.00230753f //x=2.71 //y=4.62
c1087 ( 136 0 ) capacitor c=0.197194f //x=53.275 //y=4.64
c1088 ( 135 0 ) capacitor c=0.087787f //x=53.62 //y=4.64
c1089 ( 133 0 ) capacitor c=0.00147048f //x=45.63 //y=4.88
c1090 ( 129 0 ) capacitor c=0.00744552f //x=44.74 //y=4.64
c1091 ( 127 0 ) capacitor c=0.0761212f //x=44.14 //y=4.62
c1092 ( 125 0 ) capacitor c=0.0105203f //x=42.145 //y=4.635
c1093 ( 123 0 ) capacitor c=0.132089f //x=41.545 //y=4.62
c1094 ( 122 0 ) capacitor c=0.0847646f //x=35.87 //y=4.65
c1095 ( 121 0 ) capacitor c=0.0146011f //x=36.215 //y=4.65
c1096 ( 120 0 ) capacitor c=0.197171f //x=31.815 //y=4.64
c1097 ( 119 0 ) capacitor c=0.00468492f //x=32.16 //y=4.64
c1098 ( 117 0 ) capacitor c=0.00147048f //x=24.17 //y=4.88
c1099 ( 113 0 ) capacitor c=0.00744552f //x=23.28 //y=4.64
c1100 ( 111 0 ) capacitor c=0.0753491f //x=22.68 //y=4.62
c1101 ( 109 0 ) capacitor c=0.0105203f //x=20.685 //y=4.635
c1102 ( 108 0 ) capacitor c=0.0016693f //x=17.32 //y=4.62
c1103 ( 107 0 ) capacitor c=0.0744588f //x=20.085 //y=4.62
c1104 ( 104 0 ) capacitor c=0.0846383f //x=14.395 //y=4.642
c1105 ( 103 0 ) capacitor c=0.0167938f //x=14.763 //y=4.642
c1106 ( 101 0 ) capacitor c=0.00468492f //x=10.7 //y=4.64
c1107 ( 99 0 ) capacitor c=0.178409f //x=10.1 //y=4.62
c1108 ( 96 0 ) capacitor c=0.00504845f //x=56.73 //y=2.26
c1109 ( 90 0 ) capacitor c=0.00618093f //x=56.755 //y=4.865
c1110 ( 84 0 ) capacitor c=0.00543381f //x=45.63 //y=4.88
c1111 ( 80 0 ) capacitor c=0.00680024f //x=35.27 //y=2.26
c1112 ( 74 0 ) capacitor c=0.00618409f //x=35.295 //y=4.865
c1113 ( 68 0 ) capacitor c=0.00543901f //x=24.17 //y=4.88
c1114 ( 64 0 ) capacitor c=0.00680024f //x=13.81 //y=2.26
c1115 ( 58 0 ) capacitor c=0.00618409f //x=13.835 //y=4.865
c1116 ( 52 0 ) capacitor c=0.00551512f //x=2.71 //y=4.88
c1117 ( 41 0 ) capacitor c=0.00380207f //x=45.63 //y=2.375
c1118 ( 32 0 ) capacitor c=0.00565957f //x=24.17 //y=2.375
c1119 ( 20 0 ) capacitor c=0.00565957f //x=2.71 //y=2.375
c1120 ( 17 0 ) capacitor c=0.0480079f //x=56.73 //y=2.77
c1121 ( 14 0 ) capacitor c=0.062747f //x=45.63 //y=3.51
c1122 ( 12 0 ) capacitor c=0.0479032f //x=35.27 //y=3.51
c1123 ( 9 0 ) capacitor c=0.0635391f //x=24.17 //y=3.51
c1124 ( 6 0 ) capacitor c=0.0494096f //x=13.81 //y=3.14
c1125 ( 1 0 ) capacitor c=0.0678123f //x=2.71 //y=2.77
r1126 (  407 408 ) resistor r=32.4568 //w=0.214 //l=0.075 //layer=ply \
 //thickness=0.18 //x=56.76 //y=4.97 //x2=56.76 //y2=5.045
r1127 (  405 407 ) resistor r=20.271 //w=0.214 //l=0.09 //layer=ply \
 //thickness=0.18 //x=56.76 //y=4.88 //x2=56.76 //y2=4.97
r1128 (  401 402 ) resistor r=52.7279 //w=0.214 //l=0.165 //layer=ply \
 //thickness=0.18 //x=56.73 //y=2.26 //x2=56.73 //y2=2.095
r1129 (  394 395 ) resistor r=32.4568 //w=0.214 //l=0.075 //layer=ply \
 //thickness=0.18 //x=45.63 //y=4.97 //x2=45.63 //y2=5.045
r1130 (  392 394 ) resistor r=20.271 //w=0.214 //l=0.09 //layer=ply \
 //thickness=0.18 //x=45.63 //y=4.88 //x2=45.63 //y2=4.97
r1131 (  383 384 ) resistor r=32.4568 //w=0.214 //l=0.075 //layer=ply \
 //thickness=0.18 //x=35.3 //y=4.97 //x2=35.3 //y2=5.045
r1132 (  381 383 ) resistor r=20.271 //w=0.214 //l=0.09 //layer=ply \
 //thickness=0.18 //x=35.3 //y=4.88 //x2=35.3 //y2=4.97
r1133 (  377 378 ) resistor r=52.7279 //w=0.214 //l=0.165 //layer=ply \
 //thickness=0.18 //x=35.27 //y=2.26 //x2=35.27 //y2=2.095
r1134 (  370 371 ) resistor r=32.4568 //w=0.214 //l=0.075 //layer=ply \
 //thickness=0.18 //x=24.17 //y=4.97 //x2=24.17 //y2=5.045
r1135 (  368 370 ) resistor r=20.271 //w=0.214 //l=0.09 //layer=ply \
 //thickness=0.18 //x=24.17 //y=4.88 //x2=24.17 //y2=4.97
r1136 (  359 360 ) resistor r=32.4568 //w=0.214 //l=0.075 //layer=ply \
 //thickness=0.18 //x=13.84 //y=4.97 //x2=13.84 //y2=5.045
r1137 (  357 359 ) resistor r=20.271 //w=0.214 //l=0.09 //layer=ply \
 //thickness=0.18 //x=13.84 //y=4.88 //x2=13.84 //y2=4.97
r1138 (  353 354 ) resistor r=52.7279 //w=0.214 //l=0.165 //layer=ply \
 //thickness=0.18 //x=13.81 //y=2.26 //x2=13.81 //y2=2.095
r1139 (  346 347 ) resistor r=32.4568 //w=0.214 //l=0.075 //layer=ply \
 //thickness=0.18 //x=2.71 //y=4.97 //x2=2.71 //y2=5.045
r1140 (  344 346 ) resistor r=20.271 //w=0.214 //l=0.09 //layer=ply \
 //thickness=0.18 //x=2.71 //y=4.88 //x2=2.71 //y2=4.97
r1141 (  340 412 ) resistor r=45.1352 //w=0.168 //l=0.173853 //layer=ply \
 //thickness=0.18 //x=57.295 //y=1.43 //x2=57.255 //y2=1.585
r1142 (  339 411 ) resistor r=45.1352 //w=0.168 //l=0.173853 //layer=ply \
 //thickness=0.18 //x=57.295 //y=1.085 //x2=57.255 //y2=0.93
r1143 (  339 340 ) resistor r=176.904 //w=0.094 //l=0.345 //layer=ply \
 //thickness=0.18 //x=57.295 //y=1.085 //x2=57.295 //y2=1.43
r1144 (  334 410 ) resistor r=10.701 //w=0.21 //l=0.115 //layer=ply \
 //thickness=0.18 //x=56.92 //y=1.585 //x2=56.805 //y2=1.585
r1145 (  333 412 ) resistor r=5.52526 //w=0.168 //l=0.115 //layer=ply \
 //thickness=0.18 //x=57.14 //y=1.585 //x2=57.255 //y2=1.585
r1146 (  332 409 ) resistor r=5.52526 //w=0.168 //l=0.115 //layer=ply \
 //thickness=0.18 //x=56.92 //y=0.93 //x2=56.805 //y2=0.93
r1147 (  331 411 ) resistor r=5.52526 //w=0.168 //l=0.115 //layer=ply \
 //thickness=0.18 //x=57.14 //y=0.93 //x2=57.255 //y2=0.93
r1148 (  331 332 ) resistor r=112.809 //w=0.094 //l=0.22 //layer=ply \
 //thickness=0.18 //x=57.14 //y=0.93 //x2=56.92 //y2=0.93
r1149 (  330 407 ) resistor r=16.5046 //w=0.27 //l=0.135 //layer=ply \
 //thickness=0.18 //x=56.895 //y=4.97 //x2=56.76 //y2=4.97
r1150 (  329 336 ) resistor r=26.9307 //w=0.15 //l=0.106066 //layer=ply \
 //thickness=0.18 //x=57.135 //y=4.97 //x2=57.21 //y2=5.045
r1151 (  329 330 ) resistor r=123.064 //w=0.094 //l=0.24 //layer=ply \
 //thickness=0.18 //x=57.135 //y=4.97 //x2=56.895 //y2=4.97
r1152 (  324 410 ) resistor r=39.5823 //w=0.21 //l=0.173853 //layer=ply \
 //thickness=0.18 //x=56.765 //y=1.74 //x2=56.805 //y2=1.585
r1153 (  324 402 ) resistor r=182.032 //w=0.094 //l=0.355 //layer=ply \
 //thickness=0.18 //x=56.765 //y=1.74 //x2=56.765 //y2=2.095
r1154 (  323 410 ) resistor r=39.5823 //w=0.21 //l=0.173853 //layer=ply \
 //thickness=0.18 //x=56.765 //y=1.43 //x2=56.805 //y2=1.585
r1155 (  322 409 ) resistor r=45.1352 //w=0.168 //l=0.173853 //layer=ply \
 //thickness=0.18 //x=56.765 //y=1.085 //x2=56.805 //y2=0.93
r1156 (  322 323 ) resistor r=176.904 //w=0.094 //l=0.345 //layer=ply \
 //thickness=0.18 //x=56.765 //y=1.085 //x2=56.765 //y2=1.43
r1157 (  318 394 ) resistor r=16.5046 //w=0.27 //l=0.135 //layer=ply \
 //thickness=0.18 //x=45.765 //y=4.97 //x2=45.63 //y2=4.97
r1158 (  317 319 ) resistor r=26.9307 //w=0.15 //l=0.106066 //layer=ply \
 //thickness=0.18 //x=45.965 //y=4.97 //x2=46.04 //y2=5.045
r1159 (  317 318 ) resistor r=102.553 //w=0.094 //l=0.2 //layer=ply \
 //thickness=0.18 //x=45.965 //y=4.97 //x2=45.765 //y2=4.97
r1160 (  316 399 ) resistor r=38.6777 //w=0.284 //l=0.198997 //layer=ply \
 //thickness=0.18 //x=45.72 //y=2.095 //x2=45.645 //y2=2.26
r1161 (  315 397 ) resistor r=21.2976 //w=0.217 //l=0.0928709 //layer=ply \
 //thickness=0.18 //x=45.72 //y=1.63 //x2=45.68 //y2=1.555
r1162 (  315 316 ) resistor r=238.436 //w=0.094 //l=0.465 //layer=ply \
 //thickness=0.18 //x=45.72 //y=1.63 //x2=45.72 //y2=2.095
r1163 (  314 397 ) resistor r=39.0671 //w=0.217 //l=0.173853 //layer=ply \
 //thickness=0.18 //x=45.72 //y=1.4 //x2=45.68 //y2=1.555
r1164 (  313 396 ) resistor r=45.1352 //w=0.168 //l=0.173853 //layer=ply \
 //thickness=0.18 //x=45.72 //y=1.09 //x2=45.68 //y2=0.935
r1165 (  313 314 ) resistor r=158.957 //w=0.094 //l=0.31 //layer=ply \
 //thickness=0.18 //x=45.72 //y=1.09 //x2=45.72 //y2=1.4
r1166 (  308 390 ) resistor r=5.52526 //w=0.168 //l=0.115 //layer=ply \
 //thickness=0.18 //x=45.35 //y=1.555 //x2=45.235 //y2=1.555
r1167 (  307 397 ) resistor r=11.4558 //w=0.217 //l=0.115 //layer=ply \
 //thickness=0.18 //x=45.565 //y=1.555 //x2=45.68 //y2=1.555
r1168 (  306 389 ) resistor r=5.52526 //w=0.168 //l=0.115 //layer=ply \
 //thickness=0.18 //x=45.35 //y=0.935 //x2=45.235 //y2=0.935
r1169 (  305 396 ) resistor r=5.52526 //w=0.168 //l=0.115 //layer=ply \
 //thickness=0.18 //x=45.565 //y=0.935 //x2=45.68 //y2=0.935
r1170 (  305 306 ) resistor r=110.245 //w=0.094 //l=0.215 //layer=ply \
 //thickness=0.18 //x=45.565 //y=0.935 //x2=45.35 //y2=0.935
r1171 (  304 390 ) resistor r=45.1352 //w=0.168 //l=0.173853 //layer=ply \
 //thickness=0.18 //x=45.195 //y=1.4 //x2=45.235 //y2=1.555
r1172 (  303 389 ) resistor r=45.1352 //w=0.168 //l=0.173853 //layer=ply \
 //thickness=0.18 //x=45.195 //y=1.09 //x2=45.235 //y2=0.935
r1173 (  303 304 ) resistor r=158.957 //w=0.094 //l=0.31 //layer=ply \
 //thickness=0.18 //x=45.195 //y=1.09 //x2=45.195 //y2=1.4
r1174 (  302 388 ) resistor r=45.1352 //w=0.168 //l=0.173853 //layer=ply \
 //thickness=0.18 //x=35.835 //y=1.43 //x2=35.795 //y2=1.585
r1175 (  301 387 ) resistor r=45.1352 //w=0.168 //l=0.173853 //layer=ply \
 //thickness=0.18 //x=35.835 //y=1.085 //x2=35.795 //y2=0.93
r1176 (  301 302 ) resistor r=176.904 //w=0.094 //l=0.345 //layer=ply \
 //thickness=0.18 //x=35.835 //y=1.085 //x2=35.835 //y2=1.43
r1177 (  296 386 ) resistor r=10.701 //w=0.21 //l=0.115 //layer=ply \
 //thickness=0.18 //x=35.46 //y=1.585 //x2=35.345 //y2=1.585
r1178 (  295 388 ) resistor r=5.52526 //w=0.168 //l=0.115 //layer=ply \
 //thickness=0.18 //x=35.68 //y=1.585 //x2=35.795 //y2=1.585
r1179 (  294 385 ) resistor r=5.52526 //w=0.168 //l=0.115 //layer=ply \
 //thickness=0.18 //x=35.46 //y=0.93 //x2=35.345 //y2=0.93
r1180 (  293 387 ) resistor r=5.52526 //w=0.168 //l=0.115 //layer=ply \
 //thickness=0.18 //x=35.68 //y=0.93 //x2=35.795 //y2=0.93
r1181 (  293 294 ) resistor r=112.809 //w=0.094 //l=0.22 //layer=ply \
 //thickness=0.18 //x=35.68 //y=0.93 //x2=35.46 //y2=0.93
r1182 (  292 383 ) resistor r=16.5046 //w=0.27 //l=0.135 //layer=ply \
 //thickness=0.18 //x=35.435 //y=4.97 //x2=35.3 //y2=4.97
r1183 (  291 298 ) resistor r=26.9307 //w=0.15 //l=0.106066 //layer=ply \
 //thickness=0.18 //x=35.675 //y=4.97 //x2=35.75 //y2=5.045
r1184 (  291 292 ) resistor r=123.064 //w=0.094 //l=0.24 //layer=ply \
 //thickness=0.18 //x=35.675 //y=4.97 //x2=35.435 //y2=4.97
r1185 (  286 386 ) resistor r=39.5823 //w=0.21 //l=0.173853 //layer=ply \
 //thickness=0.18 //x=35.305 //y=1.74 //x2=35.345 //y2=1.585
r1186 (  286 378 ) resistor r=182.032 //w=0.094 //l=0.355 //layer=ply \
 //thickness=0.18 //x=35.305 //y=1.74 //x2=35.305 //y2=2.095
r1187 (  285 386 ) resistor r=39.5823 //w=0.21 //l=0.173853 //layer=ply \
 //thickness=0.18 //x=35.305 //y=1.43 //x2=35.345 //y2=1.585
r1188 (  284 385 ) resistor r=45.1352 //w=0.168 //l=0.173853 //layer=ply \
 //thickness=0.18 //x=35.305 //y=1.085 //x2=35.345 //y2=0.93
r1189 (  284 285 ) resistor r=176.904 //w=0.094 //l=0.345 //layer=ply \
 //thickness=0.18 //x=35.305 //y=1.085 //x2=35.305 //y2=1.43
r1190 (  280 370 ) resistor r=16.5046 //w=0.27 //l=0.135 //layer=ply \
 //thickness=0.18 //x=24.305 //y=4.97 //x2=24.17 //y2=4.97
r1191 (  279 281 ) resistor r=26.9307 //w=0.15 //l=0.106066 //layer=ply \
 //thickness=0.18 //x=24.505 //y=4.97 //x2=24.58 //y2=5.045
r1192 (  279 280 ) resistor r=102.553 //w=0.094 //l=0.2 //layer=ply \
 //thickness=0.18 //x=24.505 //y=4.97 //x2=24.305 //y2=4.97
r1193 (  278 375 ) resistor r=38.6777 //w=0.284 //l=0.198997 //layer=ply \
 //thickness=0.18 //x=24.26 //y=2.095 //x2=24.185 //y2=2.26
r1194 (  277 373 ) resistor r=21.2976 //w=0.217 //l=0.0928709 //layer=ply \
 //thickness=0.18 //x=24.26 //y=1.63 //x2=24.22 //y2=1.555
r1195 (  277 278 ) resistor r=238.436 //w=0.094 //l=0.465 //layer=ply \
 //thickness=0.18 //x=24.26 //y=1.63 //x2=24.26 //y2=2.095
r1196 (  276 373 ) resistor r=39.0671 //w=0.217 //l=0.173853 //layer=ply \
 //thickness=0.18 //x=24.26 //y=1.4 //x2=24.22 //y2=1.555
r1197 (  275 372 ) resistor r=45.1352 //w=0.168 //l=0.173853 //layer=ply \
 //thickness=0.18 //x=24.26 //y=1.09 //x2=24.22 //y2=0.935
r1198 (  275 276 ) resistor r=158.957 //w=0.094 //l=0.31 //layer=ply \
 //thickness=0.18 //x=24.26 //y=1.09 //x2=24.26 //y2=1.4
r1199 (  270 366 ) resistor r=5.52526 //w=0.168 //l=0.115 //layer=ply \
 //thickness=0.18 //x=23.89 //y=1.555 //x2=23.775 //y2=1.555
r1200 (  269 373 ) resistor r=11.4558 //w=0.217 //l=0.115 //layer=ply \
 //thickness=0.18 //x=24.105 //y=1.555 //x2=24.22 //y2=1.555
r1201 (  268 365 ) resistor r=5.52526 //w=0.168 //l=0.115 //layer=ply \
 //thickness=0.18 //x=23.89 //y=0.935 //x2=23.775 //y2=0.935
r1202 (  267 372 ) resistor r=5.52526 //w=0.168 //l=0.115 //layer=ply \
 //thickness=0.18 //x=24.105 //y=0.935 //x2=24.22 //y2=0.935
r1203 (  267 268 ) resistor r=110.245 //w=0.094 //l=0.215 //layer=ply \
 //thickness=0.18 //x=24.105 //y=0.935 //x2=23.89 //y2=0.935
r1204 (  266 366 ) resistor r=45.1352 //w=0.168 //l=0.173853 //layer=ply \
 //thickness=0.18 //x=23.735 //y=1.4 //x2=23.775 //y2=1.555
r1205 (  265 365 ) resistor r=45.1352 //w=0.168 //l=0.173853 //layer=ply \
 //thickness=0.18 //x=23.735 //y=1.09 //x2=23.775 //y2=0.935
r1206 (  265 266 ) resistor r=158.957 //w=0.094 //l=0.31 //layer=ply \
 //thickness=0.18 //x=23.735 //y=1.09 //x2=23.735 //y2=1.4
r1207 (  264 364 ) resistor r=45.1352 //w=0.168 //l=0.173853 //layer=ply \
 //thickness=0.18 //x=14.375 //y=1.43 //x2=14.335 //y2=1.585
r1208 (  263 363 ) resistor r=45.1352 //w=0.168 //l=0.173853 //layer=ply \
 //thickness=0.18 //x=14.375 //y=1.085 //x2=14.335 //y2=0.93
r1209 (  263 264 ) resistor r=176.904 //w=0.094 //l=0.345 //layer=ply \
 //thickness=0.18 //x=14.375 //y=1.085 //x2=14.375 //y2=1.43
r1210 (  258 362 ) resistor r=10.701 //w=0.21 //l=0.115 //layer=ply \
 //thickness=0.18 //x=14 //y=1.585 //x2=13.885 //y2=1.585
r1211 (  257 364 ) resistor r=5.52526 //w=0.168 //l=0.115 //layer=ply \
 //thickness=0.18 //x=14.22 //y=1.585 //x2=14.335 //y2=1.585
r1212 (  256 361 ) resistor r=5.52526 //w=0.168 //l=0.115 //layer=ply \
 //thickness=0.18 //x=14 //y=0.93 //x2=13.885 //y2=0.93
r1213 (  255 363 ) resistor r=5.52526 //w=0.168 //l=0.115 //layer=ply \
 //thickness=0.18 //x=14.22 //y=0.93 //x2=14.335 //y2=0.93
r1214 (  255 256 ) resistor r=112.809 //w=0.094 //l=0.22 //layer=ply \
 //thickness=0.18 //x=14.22 //y=0.93 //x2=14 //y2=0.93
r1215 (  254 359 ) resistor r=16.5046 //w=0.27 //l=0.135 //layer=ply \
 //thickness=0.18 //x=13.975 //y=4.97 //x2=13.84 //y2=4.97
r1216 (  253 260 ) resistor r=26.9307 //w=0.15 //l=0.106066 //layer=ply \
 //thickness=0.18 //x=14.215 //y=4.97 //x2=14.29 //y2=5.045
r1217 (  253 254 ) resistor r=123.064 //w=0.094 //l=0.24 //layer=ply \
 //thickness=0.18 //x=14.215 //y=4.97 //x2=13.975 //y2=4.97
r1218 (  248 362 ) resistor r=39.5823 //w=0.21 //l=0.173853 //layer=ply \
 //thickness=0.18 //x=13.845 //y=1.74 //x2=13.885 //y2=1.585
r1219 (  248 354 ) resistor r=182.032 //w=0.094 //l=0.355 //layer=ply \
 //thickness=0.18 //x=13.845 //y=1.74 //x2=13.845 //y2=2.095
r1220 (  247 362 ) resistor r=39.5823 //w=0.21 //l=0.173853 //layer=ply \
 //thickness=0.18 //x=13.845 //y=1.43 //x2=13.885 //y2=1.585
r1221 (  246 361 ) resistor r=45.1352 //w=0.168 //l=0.173853 //layer=ply \
 //thickness=0.18 //x=13.845 //y=1.085 //x2=13.885 //y2=0.93
r1222 (  246 247 ) resistor r=176.904 //w=0.094 //l=0.345 //layer=ply \
 //thickness=0.18 //x=13.845 //y=1.085 //x2=13.845 //y2=1.43
r1223 (  242 346 ) resistor r=16.5046 //w=0.27 //l=0.135 //layer=ply \
 //thickness=0.18 //x=2.845 //y=4.97 //x2=2.71 //y2=4.97
r1224 (  241 243 ) resistor r=26.9307 //w=0.15 //l=0.106066 //layer=ply \
 //thickness=0.18 //x=3.045 //y=4.97 //x2=3.12 //y2=5.045
r1225 (  241 242 ) resistor r=102.553 //w=0.094 //l=0.2 //layer=ply \
 //thickness=0.18 //x=3.045 //y=4.97 //x2=2.845 //y2=4.97
r1226 (  240 351 ) resistor r=38.6777 //w=0.284 //l=0.198997 //layer=ply \
 //thickness=0.18 //x=2.8 //y=2.095 //x2=2.725 //y2=2.26
r1227 (  239 349 ) resistor r=21.2976 //w=0.217 //l=0.0928709 //layer=ply \
 //thickness=0.18 //x=2.8 //y=1.63 //x2=2.76 //y2=1.555
r1228 (  239 240 ) resistor r=238.436 //w=0.094 //l=0.465 //layer=ply \
 //thickness=0.18 //x=2.8 //y=1.63 //x2=2.8 //y2=2.095
r1229 (  238 349 ) resistor r=39.0671 //w=0.217 //l=0.173853 //layer=ply \
 //thickness=0.18 //x=2.8 //y=1.4 //x2=2.76 //y2=1.555
r1230 (  237 348 ) resistor r=45.1352 //w=0.168 //l=0.173853 //layer=ply \
 //thickness=0.18 //x=2.8 //y=1.09 //x2=2.76 //y2=0.935
r1231 (  237 238 ) resistor r=158.957 //w=0.094 //l=0.31 //layer=ply \
 //thickness=0.18 //x=2.8 //y=1.09 //x2=2.8 //y2=1.4
r1232 (  232 342 ) resistor r=5.52526 //w=0.168 //l=0.115 //layer=ply \
 //thickness=0.18 //x=2.43 //y=1.555 //x2=2.315 //y2=1.555
r1233 (  231 349 ) resistor r=11.4558 //w=0.217 //l=0.115 //layer=ply \
 //thickness=0.18 //x=2.645 //y=1.555 //x2=2.76 //y2=1.555
r1234 (  230 341 ) resistor r=5.52526 //w=0.168 //l=0.115 //layer=ply \
 //thickness=0.18 //x=2.43 //y=0.935 //x2=2.315 //y2=0.935
r1235 (  229 348 ) resistor r=5.52526 //w=0.168 //l=0.115 //layer=ply \
 //thickness=0.18 //x=2.645 //y=0.935 //x2=2.76 //y2=0.935
r1236 (  229 230 ) resistor r=110.245 //w=0.094 //l=0.215 //layer=ply \
 //thickness=0.18 //x=2.645 //y=0.935 //x2=2.43 //y2=0.935
r1237 (  228 342 ) resistor r=45.1352 //w=0.168 //l=0.173853 //layer=ply \
 //thickness=0.18 //x=2.275 //y=1.4 //x2=2.315 //y2=1.555
r1238 (  227 341 ) resistor r=45.1352 //w=0.168 //l=0.173853 //layer=ply \
 //thickness=0.18 //x=2.275 //y=1.09 //x2=2.315 //y2=0.935
r1239 (  227 228 ) resistor r=158.957 //w=0.094 //l=0.31 //layer=ply \
 //thickness=0.18 //x=2.275 //y=1.09 //x2=2.275 //y2=1.4
r1240 (  226 336 ) resistor r=592.245 //w=0.094 //l=1.155 //layer=ply \
 //thickness=0.18 //x=57.21 //y=6.2 //x2=57.21 //y2=5.045
r1241 (  225 408 ) resistor r=592.245 //w=0.094 //l=1.155 //layer=ply \
 //thickness=0.18 //x=56.77 //y=6.2 //x2=56.77 //y2=5.045
r1242 (  224 319 ) resistor r=592.245 //w=0.094 //l=1.155 //layer=ply \
 //thickness=0.18 //x=46.04 //y=6.2 //x2=46.04 //y2=5.045
r1243 (  223 395 ) resistor r=592.245 //w=0.094 //l=1.155 //layer=ply \
 //thickness=0.18 //x=45.6 //y=6.2 //x2=45.6 //y2=5.045
r1244 (  222 298 ) resistor r=592.245 //w=0.094 //l=1.155 //layer=ply \
 //thickness=0.18 //x=35.75 //y=6.2 //x2=35.75 //y2=5.045
r1245 (  221 384 ) resistor r=592.245 //w=0.094 //l=1.155 //layer=ply \
 //thickness=0.18 //x=35.31 //y=6.2 //x2=35.31 //y2=5.045
r1246 (  220 281 ) resistor r=592.245 //w=0.094 //l=1.155 //layer=ply \
 //thickness=0.18 //x=24.58 //y=6.2 //x2=24.58 //y2=5.045
r1247 (  219 371 ) resistor r=592.245 //w=0.094 //l=1.155 //layer=ply \
 //thickness=0.18 //x=24.14 //y=6.2 //x2=24.14 //y2=5.045
r1248 (  218 260 ) resistor r=592.245 //w=0.094 //l=1.155 //layer=ply \
 //thickness=0.18 //x=14.29 //y=6.2 //x2=14.29 //y2=5.045
r1249 (  217 360 ) resistor r=592.245 //w=0.094 //l=1.155 //layer=ply \
 //thickness=0.18 //x=13.85 //y=6.2 //x2=13.85 //y2=5.045
r1250 (  216 243 ) resistor r=592.245 //w=0.094 //l=1.155 //layer=ply \
 //thickness=0.18 //x=3.12 //y=6.2 //x2=3.12 //y2=5.045
r1251 (  215 347 ) resistor r=592.245 //w=0.094 //l=1.155 //layer=ply \
 //thickness=0.18 //x=2.68 //y=6.2 //x2=2.68 //y2=5.045
r1252 (  214 333 ) resistor r=56.4043 //w=0.094 //l=0.11 //layer=ply \
 //thickness=0.18 //x=57.03 //y=1.585 //x2=57.14 //y2=1.585
r1253 (  214 334 ) resistor r=56.4043 //w=0.094 //l=0.11 //layer=ply \
 //thickness=0.18 //x=57.03 //y=1.585 //x2=56.92 //y2=1.585
r1254 (  213 307 ) resistor r=55.3787 //w=0.094 //l=0.108 //layer=ply \
 //thickness=0.18 //x=45.457 //y=1.555 //x2=45.565 //y2=1.555
r1255 (  213 308 ) resistor r=54.866 //w=0.094 //l=0.107 //layer=ply \
 //thickness=0.18 //x=45.457 //y=1.555 //x2=45.35 //y2=1.555
r1256 (  212 295 ) resistor r=56.4043 //w=0.094 //l=0.11 //layer=ply \
 //thickness=0.18 //x=35.57 //y=1.585 //x2=35.68 //y2=1.585
r1257 (  212 296 ) resistor r=56.4043 //w=0.094 //l=0.11 //layer=ply \
 //thickness=0.18 //x=35.57 //y=1.585 //x2=35.46 //y2=1.585
r1258 (  211 269 ) resistor r=55.3787 //w=0.094 //l=0.108 //layer=ply \
 //thickness=0.18 //x=23.997 //y=1.555 //x2=24.105 //y2=1.555
r1259 (  211 270 ) resistor r=54.866 //w=0.094 //l=0.107 //layer=ply \
 //thickness=0.18 //x=23.997 //y=1.555 //x2=23.89 //y2=1.555
r1260 (  210 257 ) resistor r=56.4043 //w=0.094 //l=0.11 //layer=ply \
 //thickness=0.18 //x=14.11 //y=1.585 //x2=14.22 //y2=1.585
r1261 (  210 258 ) resistor r=56.4043 //w=0.094 //l=0.11 //layer=ply \
 //thickness=0.18 //x=14.11 //y=1.585 //x2=14 //y2=1.585
r1262 (  209 231 ) resistor r=55.3787 //w=0.094 //l=0.108 //layer=ply \
 //thickness=0.18 //x=2.537 //y=1.555 //x2=2.645 //y2=1.555
r1263 (  209 232 ) resistor r=54.866 //w=0.094 //l=0.107 //layer=ply \
 //thickness=0.18 //x=2.537 //y=1.555 //x2=2.43 //y2=1.555
r1264 (  205 405 ) resistor r=152 //w=0.17 //l=0.17 //layer=licon //count=1 \
 //x=56.76 //y=4.88 //x2=56.76 //y2=4.88
r1265 (  200 401 ) resistor r=152 //w=0.17 //l=0.17 //layer=licon //count=1 \
 //x=56.73 //y=2.26 //x2=56.73 //y2=2.26
r1266 (  195 392 ) resistor r=152 //w=0.17 //l=0.17 //layer=licon //count=1 \
 //x=45.63 //y=4.88 //x2=45.63 //y2=4.88
r1267 (  190 399 ) resistor r=152 //w=0.17 //l=0.17 //layer=licon //count=1 \
 //x=45.63 //y=2.26 //x2=45.63 //y2=2.26
r1268 (  185 381 ) resistor r=152 //w=0.17 //l=0.17 //layer=licon //count=1 \
 //x=35.3 //y=4.88 //x2=35.3 //y2=4.88
r1269 (  180 377 ) resistor r=152 //w=0.17 //l=0.17 //layer=licon //count=1 \
 //x=35.27 //y=2.26 //x2=35.27 //y2=2.26
r1270 (  175 368 ) resistor r=152 //w=0.17 //l=0.17 //layer=licon //count=1 \
 //x=24.17 //y=4.88 //x2=24.17 //y2=4.88
r1271 (  170 375 ) resistor r=152 //w=0.17 //l=0.17 //layer=licon //count=1 \
 //x=24.17 //y=2.26 //x2=24.17 //y2=2.26
r1272 (  165 357 ) resistor r=152 //w=0.17 //l=0.17 //layer=licon //count=1 \
 //x=13.84 //y=4.88 //x2=13.84 //y2=4.88
r1273 (  160 353 ) resistor r=152 //w=0.17 //l=0.17 //layer=licon //count=1 \
 //x=13.81 //y=2.26 //x2=13.81 //y2=2.26
r1274 (  155 344 ) resistor r=152 //w=0.17 //l=0.17 //layer=licon //count=1 \
 //x=2.71 //y=4.88 //x2=2.71 //y2=4.88
r1275 (  150 351 ) resistor r=152 //w=0.17 //l=0.17 //layer=licon //count=1 \
 //x=2.71 //y=2.26 //x2=2.71 //y2=2.26
r1276 (  137 139 ) resistor r=0.110922 //w=0.293 //l=0.26 //layer=m2 \
 //thickness=0.36 //x=2.71 //y=4.62 //x2=2.71 //y2=4.88
r1277 (  135 148 ) resistor r=1.98202 //w=0.198 //l=3.16733 //layer=m2 \
 //thickness=0.36 //x=53.62 //y=4.64 //x2=56.755 //y2=4.705
r1278 (  135 136 ) resistor r=0.329198 //w=0.131 //l=0.345 //layer=m2 \
 //thickness=0.36 //x=53.62 //y=4.64 //x2=53.275 //y2=4.64
r1279 (  131 136 ) resistor r=5.62132 //w=0.17 //l=7.65 //layer=m2 \
 //thickness=0.36 //x=45.63 //y=4.63 //x2=53.275 //y2=4.64
r1280 (  131 133 ) resistor r=0.077847 //w=0.281 //l=0.175 //layer=m2 \
 //thickness=0.36 //x=45.63 //y=4.705 //x2=45.63 //y2=4.88
r1281 (  129 131 ) resistor r=0.654412 //w=0.17 //l=0.894986 //layer=m2 \
 //thickness=0.36 //x=44.74 //y=4.64 //x2=45.63 //y2=4.63
r1282 (  129 130 ) resistor r=0.329198 //w=0.131 //l=0.345 //layer=m2 \
 //thickness=0.36 //x=44.74 //y=4.64 //x2=44.395 //y2=4.64
r1283 (  127 130 ) resistor r=0.1875 //w=0.17 //l=0.264811 //layer=m2 \
 //thickness=0.36 //x=44.14 //y=4.62 //x2=44.395 //y2=4.64
r1284 (  127 128 ) resistor r=1.74141 //w=0.131 //l=1.825 //layer=m2 \
 //thickness=0.36 //x=44.14 //y=4.62 //x2=42.315 //y2=4.62
r1285 (  125 128 ) resistor r=0.125 //w=0.17 //l=0.177341 //layer=m2 \
 //thickness=0.36 //x=42.145 //y=4.635 //x2=42.315 //y2=4.62
r1286 (  125 126 ) resistor r=0.329198 //w=0.131 //l=0.345 //layer=m2 \
 //thickness=0.36 //x=42.145 //y=4.635 //x2=41.8 //y2=4.635
r1287 (  123 126 ) resistor r=0.1875 //w=0.17 //l=0.262393 //layer=m2 \
 //thickness=0.36 //x=41.545 //y=4.62 //x2=41.8 //y2=4.635
r1288 (  123 124 ) resistor r=4.92366 //w=0.131 //l=5.16 //layer=m2 \
 //thickness=0.36 //x=41.545 //y=4.62 //x2=36.385 //y2=4.62
r1289 (  122 145 ) resistor r=0.365854 //w=0.198 //l=0.601872 //layer=m2 \
 //thickness=0.36 //x=35.87 //y=4.65 //x2=35.295 //y2=4.705
r1290 (  121 124 ) resistor r=0.125 //w=0.17 //l=0.184391 //layer=m2 \
 //thickness=0.36 //x=36.215 //y=4.65 //x2=36.385 //y2=4.62
r1291 (  121 122 ) resistor r=0.329198 //w=0.131 //l=0.345 //layer=m2 \
 //thickness=0.36 //x=36.215 //y=4.65 //x2=35.87 //y2=4.65
r1292 (  119 145 ) resistor r=1.98202 //w=0.198 //l=3.16733 //layer=m2 \
 //thickness=0.36 //x=32.16 //y=4.64 //x2=35.295 //y2=4.705
r1293 (  119 120 ) resistor r=0.329198 //w=0.131 //l=0.345 //layer=m2 \
 //thickness=0.36 //x=32.16 //y=4.64 //x2=31.815 //y2=4.64
r1294 (  115 120 ) resistor r=5.62132 //w=0.17 //l=7.65 //layer=m2 \
 //thickness=0.36 //x=24.17 //y=4.63 //x2=31.815 //y2=4.64
r1295 (  115 117 ) resistor r=0.077847 //w=0.281 //l=0.175 //layer=m2 \
 //thickness=0.36 //x=24.17 //y=4.705 //x2=24.17 //y2=4.88
r1296 (  113 115 ) resistor r=0.654412 //w=0.17 //l=0.894986 //layer=m2 \
 //thickness=0.36 //x=23.28 //y=4.64 //x2=24.17 //y2=4.63
r1297 (  113 114 ) resistor r=0.329198 //w=0.131 //l=0.345 //layer=m2 \
 //thickness=0.36 //x=23.28 //y=4.64 //x2=22.935 //y2=4.64
r1298 (  111 114 ) resistor r=0.1875 //w=0.17 //l=0.264811 //layer=m2 \
 //thickness=0.36 //x=22.68 //y=4.62 //x2=22.935 //y2=4.64
r1299 (  111 112 ) resistor r=1.74141 //w=0.131 //l=1.825 //layer=m2 \
 //thickness=0.36 //x=22.68 //y=4.62 //x2=20.855 //y2=4.62
r1300 (  109 112 ) resistor r=0.125 //w=0.17 //l=0.177341 //layer=m2 \
 //thickness=0.36 //x=20.685 //y=4.635 //x2=20.855 //y2=4.62
r1301 (  109 110 ) resistor r=0.329198 //w=0.131 //l=0.345 //layer=m2 \
 //thickness=0.36 //x=20.685 //y=4.635 //x2=20.34 //y2=4.635
r1302 (  108 142 ) resistor r=0.0821511 //w=0.131 //l=0.085 //layer=m2 \
 //thickness=0.36 //x=17.32 //y=4.62 //x2=17.235 //y2=4.62
r1303 (  107 110 ) resistor r=0.1875 //w=0.17 //l=0.262393 //layer=m2 \
 //thickness=0.36 //x=20.085 //y=4.62 //x2=20.34 //y2=4.635
r1304 (  107 108 ) resistor r=2.63836 //w=0.131 //l=2.765 //layer=m2 \
 //thickness=0.36 //x=20.085 //y=4.62 //x2=17.32 //y2=4.62
r1305 (  106 142 ) resistor r=2.42996 //w=0.116 //l=2.255 //layer=m2 \
 //thickness=0.36 //x=14.98 //y=4.622 //x2=17.235 //y2=4.622
r1306 (  104 141 ) resistor r=0.361358 //w=0.197 //l=0.590661 //layer=m2 \
 //thickness=0.36 //x=14.395 //y=4.642 //x2=13.835 //y2=4.705
r1307 (  103 106 ) resistor r=0.167438 //w=0.162 //l=0.22678 //layer=m2 \
 //thickness=0.36 //x=14.763 //y=4.642 //x2=14.98 //y2=4.622
r1308 (  103 104 ) resistor r=0.396552 //w=0.116 //l=0.368 //layer=m2 \
 //thickness=0.36 //x=14.763 //y=4.642 //x2=14.395 //y2=4.642
r1309 (  101 141 ) resistor r=1.99191 //w=0.197 //l=3.16733 //layer=m2 \
 //thickness=0.36 //x=10.7 //y=4.64 //x2=13.835 //y2=4.705
r1310 (  101 102 ) resistor r=0.329198 //w=0.131 //l=0.345 //layer=m2 \
 //thickness=0.36 //x=10.7 //y=4.64 //x2=10.355 //y2=4.64
r1311 (  100 137 ) resistor r=0.040188 //w=0.293 //l=0.16 //layer=m2 \
 //thickness=0.36 //x=2.87 //y=4.62 //x2=2.71 //y2=4.62
r1312 (  99 102 ) resistor r=0.1875 //w=0.17 //l=0.264811 //layer=m2 \
 //thickness=0.36 //x=10.1 //y=4.62 //x2=10.355 //y2=4.64
r1313 (  99 100 ) resistor r=6.89885 //w=0.131 //l=7.23 //layer=m2 \
 //thickness=0.36 //x=10.1 //y=4.62 //x2=2.87 //y2=4.62
r1314 (  96 200 ) resistor r=9.3 //w=0.17 //l=0.17 //layer=mcon //count=1 \
 //x=56.73 //y=2.26 //x2=56.73 //y2=2.26
r1315 (  96 98 ) resistor r=0.0936408 //w=0.196 //l=0.125 //layer=m1 \
 //thickness=0.36 //x=56.732 //y=2.26 //x2=56.732 //y2=2.385
r1316 (  93 205 ) resistor r=9.3 //w=0.17 //l=0.17 //layer=mcon //count=1 \
 //x=56.76 //y=4.88 //x2=56.76 //y2=4.88
r1317 (  90 148 ) resistor r=4.5 //w=0.15 //l=0.15 //layer=via1 //count=1 \
 //x=56.755 //y=4.865 //x2=56.755 //y2=4.865
r1318 (  90 93 ) resistor r=0.0066726 //w=0.281 //l=0.015 //layer=m1 \
 //thickness=0.36 //x=56.755 //y=4.865 //x2=56.755 //y2=4.88
r1319 (  90 91 ) resistor r=0.10734 //w=0.281 //l=0.16 //layer=m1 \
 //thickness=0.36 //x=56.755 //y=4.865 //x2=56.755 //y2=4.705
r1320 (  88 190 ) resistor r=9.3 //w=0.17 //l=0.17 //layer=mcon //count=1 \
 //x=45.63 //y=2.26 //x2=45.63 //y2=2.26
r1321 (  84 195 ) resistor r=9.3 //w=0.17 //l=0.17 //layer=mcon //count=1 \
 //x=45.63 //y=4.88 //x2=45.63 //y2=4.88
r1322 (  84 133 ) resistor r=4.5 //w=0.15 //l=0.15 //layer=via1 //count=1 \
 //x=45.63 //y=4.88 //x2=45.63 //y2=4.88
r1323 (  80 180 ) resistor r=9.3 //w=0.17 //l=0.17 //layer=mcon //count=1 \
 //x=35.27 //y=2.26 //x2=35.27 //y2=2.26
r1324 (  80 82 ) resistor r=0.0936408 //w=0.196 //l=0.125 //layer=m1 \
 //thickness=0.36 //x=35.272 //y=2.26 //x2=35.272 //y2=2.385
r1325 (  77 185 ) resistor r=9.3 //w=0.17 //l=0.17 //layer=mcon //count=1 \
 //x=35.3 //y=4.88 //x2=35.3 //y2=4.88
r1326 (  74 145 ) resistor r=4.5 //w=0.15 //l=0.15 //layer=via1 //count=1 \
 //x=35.295 //y=4.865 //x2=35.295 //y2=4.865
r1327 (  74 77 ) resistor r=0.0066726 //w=0.281 //l=0.015 //layer=m1 \
 //thickness=0.36 //x=35.295 //y=4.865 //x2=35.295 //y2=4.88
r1328 (  74 75 ) resistor r=0.10734 //w=0.281 //l=0.16 //layer=m1 \
 //thickness=0.36 //x=35.295 //y=4.865 //x2=35.295 //y2=4.705
r1329 (  72 170 ) resistor r=9.3 //w=0.17 //l=0.17 //layer=mcon //count=1 \
 //x=24.17 //y=2.26 //x2=24.17 //y2=2.26
r1330 (  68 175 ) resistor r=9.3 //w=0.17 //l=0.17 //layer=mcon //count=1 \
 //x=24.17 //y=4.88 //x2=24.17 //y2=4.88
r1331 (  68 117 ) resistor r=4.5 //w=0.15 //l=0.15 //layer=via1 //count=1 \
 //x=24.17 //y=4.88 //x2=24.17 //y2=4.88
r1332 (  64 160 ) resistor r=9.3 //w=0.17 //l=0.17 //layer=mcon //count=1 \
 //x=13.81 //y=2.26 //x2=13.81 //y2=2.26
r1333 (  64 66 ) resistor r=0.0936408 //w=0.196 //l=0.125 //layer=m1 \
 //thickness=0.36 //x=13.812 //y=2.26 //x2=13.812 //y2=2.385
r1334 (  61 165 ) resistor r=9.3 //w=0.17 //l=0.17 //layer=mcon //count=1 \
 //x=13.84 //y=4.88 //x2=13.84 //y2=4.88
r1335 (  58 141 ) resistor r=4.5 //w=0.15 //l=0.15 //layer=via1 //count=1 \
 //x=13.835 //y=4.865 //x2=13.835 //y2=4.865
r1336 (  58 61 ) resistor r=0.0066726 //w=0.281 //l=0.015 //layer=m1 \
 //thickness=0.36 //x=13.835 //y=4.865 //x2=13.835 //y2=4.88
r1337 (  58 59 ) resistor r=0.10734 //w=0.281 //l=0.16 //layer=m1 \
 //thickness=0.36 //x=13.835 //y=4.865 //x2=13.835 //y2=4.705
r1338 (  56 150 ) resistor r=9.3 //w=0.17 //l=0.17 //layer=mcon //count=1 \
 //x=2.71 //y=2.26 //x2=2.71 //y2=2.26
r1339 (  52 155 ) resistor r=9.3 //w=0.17 //l=0.17 //layer=mcon //count=1 \
 //x=2.71 //y=4.88 //x2=2.71 //y2=4.88
r1340 (  52 139 ) resistor r=4.5 //w=0.15 //l=0.15 //layer=via1 //count=1 \
 //x=2.71 //y=4.88 //x2=2.71 //y2=4.88
r1341 (  42 84 ) resistor r=0.10734 //w=0.281 //l=0.16 //layer=m1 \
 //thickness=0.36 //x=45.63 //y=4.72 //x2=45.63 //y2=4.88
r1342 (  41 88 ) resistor r=0.0715665 //w=0.226 //l=0.115996 //layer=m1 \
 //thickness=0.36 //x=45.63 //y=2.375 //x2=45.632 //y2=2.26
r1343 (  33 68 ) resistor r=0.10734 //w=0.281 //l=0.16 //layer=m1 \
 //thickness=0.36 //x=24.17 //y=4.72 //x2=24.17 //y2=4.88
r1344 (  32 72 ) resistor r=0.0715665 //w=0.226 //l=0.115996 //layer=m1 \
 //thickness=0.36 //x=24.17 //y=2.375 //x2=24.172 //y2=2.26
r1345 (  21 52 ) resistor r=0.10734 //w=0.281 //l=0.16 //layer=m1 \
 //thickness=0.36 //x=2.71 //y=4.72 //x2=2.71 //y2=4.88
r1346 (  20 56 ) resistor r=0.0715665 //w=0.226 //l=0.115996 //layer=m1 \
 //thickness=0.36 //x=2.71 //y=2.375 //x2=2.712 //y2=2.26
r1347 (  19 91 ) resistor r=0.0811069 //w=0.131 //l=0.085 //layer=m1 \
 //thickness=0.36 //x=56.73 //y=4.62 //x2=56.73 //y2=4.705
r1348 (  18 19 ) resistor r=1.05916 //w=0.131 //l=1.11 //layer=m1 \
 //thickness=0.36 //x=56.73 //y=3.51 //x2=56.73 //y2=4.62
r1349 (  17 18 ) resistor r=0.706107 //w=0.131 //l=0.74 //layer=m1 \
 //thickness=0.36 //x=56.73 //y=2.77 //x2=56.73 //y2=3.51
r1350 (  17 98 ) resistor r=0.367366 //w=0.131 //l=0.385 //layer=m1 \
 //thickness=0.36 //x=56.73 //y=2.77 //x2=56.73 //y2=2.385
r1351 (  16 42 ) resistor r=0.0954198 //w=0.131 //l=0.1 //layer=m1 \
 //thickness=0.36 //x=45.63 //y=4.62 //x2=45.63 //y2=4.72
r1352 (  15 16 ) resistor r=0.706107 //w=0.131 //l=0.74 //layer=m1 \
 //thickness=0.36 //x=45.63 //y=3.88 //x2=45.63 //y2=4.62
r1353 (  14 15 ) resistor r=0.353053 //w=0.131 //l=0.37 //layer=m1 \
 //thickness=0.36 //x=45.63 //y=3.51 //x2=45.63 //y2=3.88
r1354 (  14 41 ) resistor r=1.08302 //w=0.131 //l=1.135 //layer=m1 \
 //thickness=0.36 //x=45.63 //y=3.51 //x2=45.63 //y2=2.375
r1355 (  13 75 ) resistor r=0.0811069 //w=0.131 //l=0.085 //layer=m1 \
 //thickness=0.36 //x=35.27 //y=4.62 //x2=35.27 //y2=4.705
r1356 (  12 13 ) resistor r=1.05916 //w=0.131 //l=1.11 //layer=m1 \
 //thickness=0.36 //x=35.27 //y=3.51 //x2=35.27 //y2=4.62
r1357 (  12 82 ) resistor r=1.07347 //w=0.131 //l=1.125 //layer=m1 \
 //thickness=0.36 //x=35.27 //y=3.51 //x2=35.27 //y2=2.385
r1358 (  11 33 ) resistor r=0.0954198 //w=0.131 //l=0.1 //layer=m1 \
 //thickness=0.36 //x=24.17 //y=4.62 //x2=24.17 //y2=4.72
r1359 (  10 11 ) resistor r=0.706107 //w=0.131 //l=0.74 //layer=m1 \
 //thickness=0.36 //x=24.17 //y=3.88 //x2=24.17 //y2=4.62
r1360 (  9 10 ) resistor r=0.353053 //w=0.131 //l=0.37 //layer=m1 \
 //thickness=0.36 //x=24.17 //y=3.51 //x2=24.17 //y2=3.88
r1361 (  9 32 ) resistor r=1.08302 //w=0.131 //l=1.135 //layer=m1 \
 //thickness=0.36 //x=24.17 //y=3.51 //x2=24.17 //y2=2.375
r1362 (  8 59 ) resistor r=0.0811069 //w=0.131 //l=0.085 //layer=m1 \
 //thickness=0.36 //x=13.81 //y=4.62 //x2=13.81 //y2=4.705
r1363 (  7 8 ) resistor r=1.05916 //w=0.131 //l=1.11 //layer=m1 \
 //thickness=0.36 //x=13.81 //y=3.51 //x2=13.81 //y2=4.62
r1364 (  6 7 ) resistor r=0.353053 //w=0.131 //l=0.37 //layer=m1 \
 //thickness=0.36 //x=13.81 //y=3.14 //x2=13.81 //y2=3.51
r1365 (  6 66 ) resistor r=0.72042 //w=0.131 //l=0.755 //layer=m1 \
 //thickness=0.36 //x=13.81 //y=3.14 //x2=13.81 //y2=2.385
r1366 (  5 21 ) resistor r=0.0954198 //w=0.131 //l=0.1 //layer=m1 \
 //thickness=0.36 //x=2.71 //y=4.62 //x2=2.71 //y2=4.72
r1367 (  4 5 ) resistor r=0.706107 //w=0.131 //l=0.74 //layer=m1 \
 //thickness=0.36 //x=2.71 //y=3.88 //x2=2.71 //y2=4.62
r1368 (  3 4 ) resistor r=0.353053 //w=0.131 //l=0.37 //layer=m1 \
 //thickness=0.36 //x=2.71 //y=3.51 //x2=2.71 //y2=3.88
r1369 (  2 3 ) resistor r=0.353053 //w=0.131 //l=0.37 //layer=m1 \
 //thickness=0.36 //x=2.71 //y=3.14 //x2=2.71 //y2=3.51
r1370 (  1 2 ) resistor r=0.353053 //w=0.131 //l=0.37 //layer=m1 \
 //thickness=0.36 //x=2.71 //y=2.77 //x2=2.71 //y2=3.14
r1371 (  1 20 ) resistor r=0.376908 //w=0.131 //l=0.395 //layer=m1 \
 //thickness=0.36 //x=2.71 //y=2.77 //x2=2.71 //y2=2.375
ends PM_TMRDFFQNX1\%CLK

subckt PM_TMRDFFQNX1\%noxref_15 ( 1 3 6 7 9 10 11 12 14 15 16 18 19 22 23 25 \
 28 31 37 40 43 46 47 50 54 57 58 60 61 62 63 64 66 68 70 72 74 84 92 100 117 \
 126 131 140 144 145 146 147 148 149 150 151 152 153 157 159 162 163 167 168 \
 169 170 174 176 179 180 190 199 202 204 205 206 )
c495 ( 202 0 ) capacitor c=0.00885916f //x=46.805 //y=1.095
c496 ( 199 0 ) capacitor c=0.0645411f //x=59.32 //y=4.88
c497 ( 190 0 ) capacitor c=0.0645923f //x=49.33 //y=4.88
c498 ( 180 0 ) capacitor c=0.0318956f //x=59.655 //y=1.39
c499 ( 179 0 ) capacitor c=0.0186809f //x=59.655 //y=1.045
c500 ( 176 0 ) capacitor c=0.0141821f //x=59.5 //y=1.545
c501 ( 174 0 ) capacitor c=0.0158553f //x=59.5 //y=0.89
c502 ( 170 0 ) capacitor c=0.088055f //x=59.125 //y=2.095
c503 ( 169 0 ) capacitor c=0.0229235f //x=59.125 //y=1.7
c504 ( 168 0 ) capacitor c=0.0234359f //x=59.125 //y=1.39
c505 ( 167 0 ) capacitor c=0.0198759f //x=59.125 //y=1.045
c506 ( 163 0 ) capacitor c=0.0318956f //x=49.665 //y=1.39
c507 ( 162 0 ) capacitor c=0.0186809f //x=49.665 //y=1.045
c508 ( 159 0 ) capacitor c=0.0141821f //x=49.51 //y=1.545
c509 ( 157 0 ) capacitor c=0.0158553f //x=49.51 //y=0.89
c510 ( 153 0 ) capacitor c=0.088055f //x=49.135 //y=2.095
c511 ( 152 0 ) capacitor c=0.0229235f //x=49.135 //y=1.7
c512 ( 151 0 ) capacitor c=0.0234359f //x=49.135 //y=1.39
c513 ( 150 0 ) capacitor c=0.0198759f //x=49.135 //y=1.045
c514 ( 149 0 ) capacitor c=0.110369f //x=59.66 //y=6.2
c515 ( 148 0 ) capacitor c=0.154619f //x=59.22 //y=6.2
c516 ( 147 0 ) capacitor c=0.110369f //x=49.67 //y=6.2
c517 ( 146 0 ) capacitor c=0.154619f //x=49.23 //y=6.2
c518 ( 140 0 ) capacitor c=8.13425e-19 //x=59.32 //y=4.88
c519 ( 131 0 ) capacitor c=7.85889e-19 //x=59.32 //y=2.26
c520 ( 126 0 ) capacitor c=8.13425e-19 //x=49.33 //y=4.88
c521 ( 117 0 ) capacitor c=7.85889e-19 //x=49.33 //y=2.26
c522 ( 100 0 ) capacitor c=0.0293071f //x=46.7 //y=5.56
c523 ( 92 0 ) capacitor c=0.029137f //x=45.82 //y=5.56
c524 ( 84 0 ) capacitor c=0.0277605f //x=44.94 //y=5.56
c525 ( 74 0 ) capacitor c=0.0403878f //x=56.2 //y=3.895
c526 ( 72 0 ) capacitor c=0.0175525f //x=55.6 //y=3.88
c527 ( 70 0 ) capacitor c=0.00418974f //x=54.36 //y=3.895
c528 ( 68 0 ) capacitor c=0.00769994f //x=53.62 //y=3.87
c529 ( 66 0 ) capacitor c=0.005471f //x=52.87 //y=3.89
c530 ( 64 0 ) capacitor c=0.0178779f //x=52.27 //y=3.88
c531 ( 63 0 ) capacitor c=0.0101058f //x=50.675 //y=3.895
c532 ( 62 0 ) capacitor c=0.00477746f //x=51.02 //y=3.895
c533 ( 61 0 ) capacitor c=7.05145e-19 //x=47.64 //y=3.88
c534 ( 60 0 ) capacitor c=0.0193144f //x=49.165 //y=3.88
c535 ( 58 0 ) capacitor c=0.0152609f //x=59.322 //y=4.74
c536 ( 57 0 ) capacitor c=0.00598189f //x=59.32 //y=4.88
c537 ( 54 0 ) capacitor c=0.00463527f //x=59.32 //y=2.26
c538 ( 50 0 ) capacitor c=0.0143013f //x=59.32 //y=3.88
c539 ( 47 0 ) capacitor c=0.0172769f //x=49.332 //y=4.74
c540 ( 46 0 ) capacitor c=0.00598357f //x=49.33 //y=4.88
c541 ( 43 0 ) capacitor c=0.00463527f //x=49.33 //y=2.26
c542 ( 40 0 ) capacitor c=0.0163193f //x=49.325 //y=3.88
c543 ( 37 0 ) capacitor c=0.0170864f //x=47.48 //y=3.88
c544 ( 31 0 ) capacitor c=9.55882e-19 //x=46.7 //y=5.335
c545 ( 28 0 ) capacitor c=0.00753245f //x=45.82 //y=5.335
c546 ( 25 0 ) capacitor c=0.0112819f //x=44.942 //y=5.335
c547 ( 23 0 ) capacitor c=0.0123785f //x=59.32 //y=4.045
c548 ( 22 0 ) capacitor c=0.0394594f //x=59.32 //y=3.725
c549 ( 19 0 ) capacitor c=0.0123756f //x=49.33 //y=4.04
c550 ( 18 0 ) capacitor c=0.033905f //x=49.33 //y=3.72
c551 ( 16 0 ) capacitor c=0.0309857f //x=47.48 //y=5.25
c552 ( 15 0 ) capacitor c=0.0132732f //x=47.48 //y=4.04
c553 ( 14 0 ) capacitor c=0.0477101f //x=47.48 //y=3.72
c554 ( 12 0 ) capacitor c=0.0047266f //x=47.08 //y=1.845
c555 ( 11 0 ) capacitor c=0.01299f //x=47.395 //y=1.845
c556 ( 10 0 ) capacitor c=0.013549f //x=46.995 //y=1.76
c557 ( 9 0 ) capacitor c=0.0111876f //x=46.995 //y=1.305
c558 ( 7 0 ) capacitor c=0.0228253f //x=47.395 //y=5.335
c559 ( 6 0 ) capacitor c=0.00906713f //x=46.7 //y=5.56
c560 ( 3 0 ) capacitor c=0.019596f //x=46.585 //y=5.335
c561 ( 1 0 ) capacitor c=0.014788f //x=45.7 //y=5.335
r562 (  197 199 ) resistor r=20.6867 //w=0.233 //l=0.1 //layer=ply \
 //thickness=0.18 //x=59.22 //y=4.88 //x2=59.32 //y2=4.88
r563 (  188 190 ) resistor r=20.6867 //w=0.233 //l=0.1 //layer=ply \
 //thickness=0.18 //x=49.23 //y=4.88 //x2=49.33 //y2=4.88
r564 (  181 199 ) resistor r=70.3348 //w=0.233 //l=0.414367 //layer=ply \
 //thickness=0.18 //x=59.66 //y=5.045 //x2=59.32 //y2=4.88
r565 (  180 201 ) resistor r=45.1352 //w=0.168 //l=0.173853 //layer=ply \
 //thickness=0.18 //x=59.655 //y=1.39 //x2=59.615 //y2=1.545
r566 (  179 200 ) resistor r=45.1352 //w=0.168 //l=0.173853 //layer=ply \
 //thickness=0.18 //x=59.655 //y=1.045 //x2=59.615 //y2=0.89
r567 (  179 180 ) resistor r=176.904 //w=0.094 //l=0.345 //layer=ply \
 //thickness=0.18 //x=59.655 //y=1.045 //x2=59.655 //y2=1.39
r568 (  177 196 ) resistor r=10.701 //w=0.21 //l=0.115 //layer=ply \
 //thickness=0.18 //x=59.28 //y=1.545 //x2=59.165 //y2=1.545
r569 (  176 201 ) resistor r=5.52526 //w=0.168 //l=0.115 //layer=ply \
 //thickness=0.18 //x=59.5 //y=1.545 //x2=59.615 //y2=1.545
r570 (  175 195 ) resistor r=5.52526 //w=0.168 //l=0.115 //layer=ply \
 //thickness=0.18 //x=59.28 //y=0.89 //x2=59.165 //y2=0.89
r571 (  174 200 ) resistor r=5.52526 //w=0.168 //l=0.115 //layer=ply \
 //thickness=0.18 //x=59.5 //y=0.89 //x2=59.615 //y2=0.89
r572 (  174 175 ) resistor r=112.809 //w=0.094 //l=0.22 //layer=ply \
 //thickness=0.18 //x=59.5 //y=0.89 //x2=59.28 //y2=0.89
r573 (  171 197 ) resistor r=13.0941 //w=0.233 //l=0.165 //layer=ply \
 //thickness=0.18 //x=59.22 //y=5.045 //x2=59.22 //y2=4.88
r574 (  170 194 ) resistor r=34.8111 //w=0.27 //l=0.264953 //layer=ply \
 //thickness=0.18 //x=59.125 //y=2.095 //x2=59.32 //y2=2.26
r575 (  169 196 ) resistor r=39.5823 //w=0.21 //l=0.173853 //layer=ply \
 //thickness=0.18 //x=59.125 //y=1.7 //x2=59.165 //y2=1.545
r576 (  169 170 ) resistor r=202.543 //w=0.094 //l=0.395 //layer=ply \
 //thickness=0.18 //x=59.125 //y=1.7 //x2=59.125 //y2=2.095
r577 (  168 196 ) resistor r=39.5823 //w=0.21 //l=0.173853 //layer=ply \
 //thickness=0.18 //x=59.125 //y=1.39 //x2=59.165 //y2=1.545
r578 (  167 195 ) resistor r=45.1352 //w=0.168 //l=0.173853 //layer=ply \
 //thickness=0.18 //x=59.125 //y=1.045 //x2=59.165 //y2=0.89
r579 (  167 168 ) resistor r=176.904 //w=0.094 //l=0.345 //layer=ply \
 //thickness=0.18 //x=59.125 //y=1.045 //x2=59.125 //y2=1.39
r580 (  164 190 ) resistor r=70.3348 //w=0.233 //l=0.414367 //layer=ply \
 //thickness=0.18 //x=49.67 //y=5.045 //x2=49.33 //y2=4.88
r581 (  163 192 ) resistor r=45.1352 //w=0.168 //l=0.173853 //layer=ply \
 //thickness=0.18 //x=49.665 //y=1.39 //x2=49.625 //y2=1.545
r582 (  162 191 ) resistor r=45.1352 //w=0.168 //l=0.173853 //layer=ply \
 //thickness=0.18 //x=49.665 //y=1.045 //x2=49.625 //y2=0.89
r583 (  162 163 ) resistor r=176.904 //w=0.094 //l=0.345 //layer=ply \
 //thickness=0.18 //x=49.665 //y=1.045 //x2=49.665 //y2=1.39
r584 (  160 187 ) resistor r=10.701 //w=0.21 //l=0.115 //layer=ply \
 //thickness=0.18 //x=49.29 //y=1.545 //x2=49.175 //y2=1.545
r585 (  159 192 ) resistor r=5.52526 //w=0.168 //l=0.115 //layer=ply \
 //thickness=0.18 //x=49.51 //y=1.545 //x2=49.625 //y2=1.545
r586 (  158 186 ) resistor r=5.52526 //w=0.168 //l=0.115 //layer=ply \
 //thickness=0.18 //x=49.29 //y=0.89 //x2=49.175 //y2=0.89
r587 (  157 191 ) resistor r=5.52526 //w=0.168 //l=0.115 //layer=ply \
 //thickness=0.18 //x=49.51 //y=0.89 //x2=49.625 //y2=0.89
r588 (  157 158 ) resistor r=112.809 //w=0.094 //l=0.22 //layer=ply \
 //thickness=0.18 //x=49.51 //y=0.89 //x2=49.29 //y2=0.89
r589 (  154 188 ) resistor r=13.0941 //w=0.233 //l=0.165 //layer=ply \
 //thickness=0.18 //x=49.23 //y=5.045 //x2=49.23 //y2=4.88
r590 (  153 185 ) resistor r=34.8111 //w=0.27 //l=0.264953 //layer=ply \
 //thickness=0.18 //x=49.135 //y=2.095 //x2=49.33 //y2=2.26
r591 (  152 187 ) resistor r=39.5823 //w=0.21 //l=0.173853 //layer=ply \
 //thickness=0.18 //x=49.135 //y=1.7 //x2=49.175 //y2=1.545
r592 (  152 153 ) resistor r=202.543 //w=0.094 //l=0.395 //layer=ply \
 //thickness=0.18 //x=49.135 //y=1.7 //x2=49.135 //y2=2.095
r593 (  151 187 ) resistor r=39.5823 //w=0.21 //l=0.173853 //layer=ply \
 //thickness=0.18 //x=49.135 //y=1.39 //x2=49.175 //y2=1.545
r594 (  150 186 ) resistor r=45.1352 //w=0.168 //l=0.173853 //layer=ply \
 //thickness=0.18 //x=49.135 //y=1.045 //x2=49.175 //y2=0.89
r595 (  150 151 ) resistor r=176.904 //w=0.094 //l=0.345 //layer=ply \
 //thickness=0.18 //x=49.135 //y=1.045 //x2=49.135 //y2=1.39
r596 (  149 181 ) resistor r=592.245 //w=0.094 //l=1.155 //layer=ply \
 //thickness=0.18 //x=59.66 //y=6.2 //x2=59.66 //y2=5.045
r597 (  148 171 ) resistor r=592.245 //w=0.094 //l=1.155 //layer=ply \
 //thickness=0.18 //x=59.22 //y=6.2 //x2=59.22 //y2=5.045
r598 (  147 164 ) resistor r=592.245 //w=0.094 //l=1.155 //layer=ply \
 //thickness=0.18 //x=49.67 //y=6.2 //x2=49.67 //y2=5.045
r599 (  146 154 ) resistor r=592.245 //w=0.094 //l=1.155 //layer=ply \
 //thickness=0.18 //x=49.23 //y=6.2 //x2=49.23 //y2=5.045
r600 (  145 176 ) resistor r=56.4043 //w=0.094 //l=0.11 //layer=ply \
 //thickness=0.18 //x=59.39 //y=1.545 //x2=59.5 //y2=1.545
r601 (  145 177 ) resistor r=56.4043 //w=0.094 //l=0.11 //layer=ply \
 //thickness=0.18 //x=59.39 //y=1.545 //x2=59.28 //y2=1.545
r602 (  144 159 ) resistor r=56.4043 //w=0.094 //l=0.11 //layer=ply \
 //thickness=0.18 //x=49.4 //y=1.545 //x2=49.51 //y2=1.545
r603 (  144 160 ) resistor r=56.4043 //w=0.094 //l=0.11 //layer=ply \
 //thickness=0.18 //x=49.4 //y=1.545 //x2=49.29 //y2=1.545
r604 (  140 199 ) resistor r=152 //w=0.17 //l=0.17 //layer=licon //count=1 \
 //x=59.32 //y=4.88 //x2=59.32 //y2=4.88
r605 (  131 194 ) resistor r=152 //w=0.17 //l=0.17 //layer=licon //count=1 \
 //x=59.32 //y=2.26 //x2=59.32 //y2=2.26
r606 (  126 190 ) resistor r=152 //w=0.17 //l=0.17 //layer=licon //count=1 \
 //x=49.33 //y=4.88 //x2=49.33 //y2=4.88
r607 (  117 185 ) resistor r=152 //w=0.17 //l=0.17 //layer=licon //count=1 \
 //x=49.33 //y=2.26 //x2=49.33 //y2=2.26
r608 (  100 206 ) resistor r=23.615 //w=0.187 //l=0.345 //layer=li \
 //thickness=0.1 //x=46.7 //y=5.56 //x2=46.7 //y2=5.905
r609 (  92 205 ) resistor r=23.615 //w=0.187 //l=0.345 //layer=li \
 //thickness=0.1 //x=45.82 //y=5.56 //x2=45.82 //y2=5.905
r610 (  84 204 ) resistor r=23.615 //w=0.187 //l=0.345 //layer=li \
 //thickness=0.1 //x=44.94 //y=5.56 //x2=44.94 //y2=5.905
r611 (  74 82 ) resistor r=2.10915 //w=0.185 //l=3.125 //layer=m2 \
 //thickness=0.36 //x=56.2 //y=3.895 //x2=59.32 //y2=3.885
r612 (  74 75 ) resistor r=0.329198 //w=0.131 //l=0.345 //layer=m2 \
 //thickness=0.36 //x=56.2 //y=3.895 //x2=55.855 //y2=3.895
r613 (  72 75 ) resistor r=0.1875 //w=0.17 //l=0.262393 //layer=m2 \
 //thickness=0.36 //x=55.6 //y=3.88 //x2=55.855 //y2=3.895
r614 (  72 73 ) resistor r=1.02099 //w=0.131 //l=1.07 //layer=m2 \
 //thickness=0.36 //x=55.6 //y=3.88 //x2=54.53 //y2=3.88
r615 (  70 73 ) resistor r=0.125 //w=0.17 //l=0.177341 //layer=m2 \
 //thickness=0.36 //x=54.36 //y=3.895 //x2=54.53 //y2=3.88
r616 (  70 71 ) resistor r=0.329198 //w=0.131 //l=0.345 //layer=m2 \
 //thickness=0.36 //x=54.36 //y=3.895 //x2=54.015 //y2=3.895
r617 (  68 71 ) resistor r=0.290441 //w=0.17 //l=0.407308 //layer=m2 \
 //thickness=0.36 //x=53.62 //y=3.87 //x2=54.015 //y2=3.895
r618 (  68 69 ) resistor r=0.410305 //w=0.131 //l=0.43 //layer=m2 \
 //thickness=0.36 //x=53.62 //y=3.87 //x2=53.19 //y2=3.87
r619 (  66 69 ) resistor r=0.235294 //w=0.17 //l=0.329848 //layer=m2 \
 //thickness=0.36 //x=52.87 //y=3.89 //x2=53.19 //y2=3.87
r620 (  66 67 ) resistor r=0.329198 //w=0.131 //l=0.345 //layer=m2 \
 //thickness=0.36 //x=52.87 //y=3.89 //x2=52.525 //y2=3.89
r621 (  64 67 ) resistor r=0.1875 //w=0.17 //l=0.259952 //layer=m2 \
 //thickness=0.36 //x=52.27 //y=3.88 //x2=52.525 //y2=3.89
r622 (  64 65 ) resistor r=1.03053 //w=0.131 //l=1.08 //layer=m2 \
 //thickness=0.36 //x=52.27 //y=3.88 //x2=51.19 //y2=3.88
r623 (  63 80 ) resistor r=0.838898 //w=0.202 //l=1.35748 //layer=m2 \
 //thickness=0.36 //x=50.675 //y=3.895 //x2=49.325 //y2=3.88
r624 (  62 65 ) resistor r=0.125 //w=0.17 //l=0.177341 //layer=m2 \
 //thickness=0.36 //x=51.02 //y=3.895 //x2=51.19 //y2=3.88
r625 (  62 63 ) resistor r=0.329198 //w=0.131 //l=0.345 //layer=m2 \
 //thickness=0.36 //x=51.02 //y=3.895 //x2=50.675 //y2=3.895
r626 (  61 77 ) resistor r=0.10734 //w=0.281 //l=0.16 //layer=m2 \
 //thickness=0.36 //x=47.64 //y=3.88 //x2=47.48 //y2=3.88
r627 (  60 80 ) resistor r=0.102512 //w=0.202 //l=0.16 //layer=m2 \
 //thickness=0.36 //x=49.165 //y=3.88 //x2=49.325 //y2=3.88
r628 (  60 61 ) resistor r=1.45515 //w=0.131 //l=1.525 //layer=m2 \
 //thickness=0.36 //x=49.165 //y=3.88 //x2=47.64 //y2=3.88
r629 (  57 140 ) resistor r=9.3 //w=0.17 //l=0.17 //layer=mcon //count=1 \
 //x=59.32 //y=4.88 //x2=59.32 //y2=4.88
r630 (  57 58 ) resistor r=0.103207 //w=0.196 //l=0.14 //layer=m1 \
 //thickness=0.36 //x=59.322 //y=4.88 //x2=59.322 //y2=4.74
r631 (  54 131 ) resistor r=9.3 //w=0.17 //l=0.17 //layer=mcon //count=1 \
 //x=59.32 //y=2.26 //x2=59.32 //y2=2.26
r632 (  52 82 ) resistor r=4.5 //w=0.15 //l=0.15 //layer=via1 //count=1 \
 //x=59.32 //y=3.885 //x2=59.32 //y2=3.885
r633 (  50 52 ) resistor r=0.00166223 //w=0.376 //l=0.005 //layer=m1 \
 //thickness=0.36 //x=59.267 //y=3.88 //x2=59.267 //y2=3.885
r634 (  46 126 ) resistor r=9.3 //w=0.17 //l=0.17 //layer=mcon //count=1 \
 //x=49.33 //y=4.88 //x2=49.33 //y2=4.88
r635 (  46 47 ) resistor r=0.103207 //w=0.196 //l=0.14 //layer=m1 \
 //thickness=0.36 //x=49.332 //y=4.88 //x2=49.332 //y2=4.74
r636 (  43 117 ) resistor r=9.3 //w=0.17 //l=0.17 //layer=mcon //count=1 \
 //x=49.33 //y=2.26 //x2=49.33 //y2=2.26
r637 (  40 80 ) resistor r=4.5 //w=0.15 //l=0.15 //layer=via1 //count=1 \
 //x=49.325 //y=3.88 //x2=49.325 //y2=3.88
r638 (  37 77 ) resistor r=4.5 //w=0.15 //l=0.15 //layer=via1 //count=1 \
 //x=47.48 //y=3.88 //x2=47.48 //y2=3.88
r639 (  35 202 ) resistor r=9.3 //w=0.17 //l=0.17 //layer=mcon //count=1 \
 //x=46.995 //y=1.19 //x2=46.995 //y2=1.19
r640 (  33 100 ) resistor r=9.3 //w=0.17 //l=0.17 //layer=mcon //count=1 \
 //x=46.7 //y=5.56 //x2=46.7 //y2=5.56
r641 (  30 92 ) resistor r=9.3 //w=0.17 //l=0.17 //layer=mcon //count=1 \
 //x=45.82 //y=5.56 //x2=45.82 //y2=5.56
r642 (  28 30 ) resistor r=0.121228 //w=0.232 //l=0.225 //layer=m1 \
 //thickness=0.36 //x=45.82 //y=5.335 //x2=45.82 //y2=5.56
r643 (  27 84 ) resistor r=9.3 //w=0.17 //l=0.17 //layer=mcon //count=1 \
 //x=44.94 //y=5.56 //x2=44.94 //y2=5.56
r644 (  25 27 ) resistor r=0.129608 //w=0.217 //l=0.225 //layer=m1 \
 //thickness=0.36 //x=44.942 //y=5.335 //x2=44.942 //y2=5.56
r645 (  23 52 ) resistor r=0.0911593 //w=0.376 //l=0.184608 //layer=m1 \
 //thickness=0.36 //x=59.32 //y=4.045 //x2=59.267 //y2=3.885
r646 (  23 58 ) resistor r=0.663168 //w=0.131 //l=0.695 //layer=m1 \
 //thickness=0.36 //x=59.32 //y=4.045 //x2=59.32 //y2=4.74
r647 (  22 50 ) resistor r=0.0894971 //w=0.376 //l=0.179555 //layer=m1 \
 //thickness=0.36 //x=59.32 //y=3.725 //x2=59.267 //y2=3.88
r648 (  21 54 ) resistor r=0.0933015 //w=0.201 //l=0.125 //layer=m1 \
 //thickness=0.36 //x=59.32 //y=2.385 //x2=59.32 //y2=2.26
r649 (  21 22 ) resistor r=1.27863 //w=0.131 //l=1.34 //layer=m1 \
 //thickness=0.36 //x=59.32 //y=2.385 //x2=59.32 //y2=3.725
r650 (  19 40 ) resistor r=0.0910802 //w=0.374 //l=0.185472 //layer=m1 \
 //thickness=0.36 //x=49.33 //y=4.04 //x2=49.275 //y2=3.88
r651 (  19 47 ) resistor r=0.667939 //w=0.131 //l=0.7 //layer=m1 \
 //thickness=0.36 //x=49.33 //y=4.04 //x2=49.33 //y2=4.74
r652 (  18 40 ) resistor r=0.0910802 //w=0.374 //l=0.185472 //layer=m1 \
 //thickness=0.36 //x=49.33 //y=3.72 //x2=49.275 //y2=3.88
r653 (  17 43 ) resistor r=0.0933015 //w=0.201 //l=0.125 //layer=m1 \
 //thickness=0.36 //x=49.33 //y=2.385 //x2=49.33 //y2=2.26
r654 (  17 18 ) resistor r=1.27385 //w=0.131 //l=1.335 //layer=m1 \
 //thickness=0.36 //x=49.33 //y=2.385 //x2=49.33 //y2=3.72
r655 (  15 37 ) resistor r=0.0911593 //w=0.376 //l=0.184174 //layer=m1 \
 //thickness=0.36 //x=47.48 //y=4.04 //x2=47.532 //y2=3.88
r656 (  15 16 ) resistor r=1.15458 //w=0.131 //l=1.21 //layer=m1 \
 //thickness=0.36 //x=47.48 //y=4.04 //x2=47.48 //y2=5.25
r657 (  14 37 ) resistor r=0.0911593 //w=0.376 //l=0.184174 //layer=m1 \
 //thickness=0.36 //x=47.48 //y=3.72 //x2=47.532 //y2=3.88
r658 (  13 14 ) resistor r=1.70802 //w=0.131 //l=1.79 //layer=m1 \
 //thickness=0.36 //x=47.48 //y=1.93 //x2=47.48 //y2=3.72
r659 (  11 13 ) resistor r=0.0698411 //w=0.17 //l=0.120208 //layer=m1 \
 //thickness=0.36 //x=47.395 //y=1.845 //x2=47.48 //y2=1.93
r660 (  11 12 ) resistor r=0.300573 //w=0.131 //l=0.315 //layer=m1 \
 //thickness=0.36 //x=47.395 //y=1.845 //x2=47.08 //y2=1.845
r661 (  10 12 ) resistor r=0.0698411 //w=0.17 //l=0.120208 //layer=m1 \
 //thickness=0.36 //x=46.995 //y=1.76 //x2=47.08 //y2=1.845
r662 (  9 35 ) resistor r=0.0717383 //w=0.224 //l=0.115 //layer=m1 \
 //thickness=0.36 //x=46.995 //y=1.305 //x2=46.995 //y2=1.19
r663 (  9 10 ) resistor r=0.43416 //w=0.131 //l=0.455 //layer=m1 \
 //thickness=0.36 //x=46.995 //y=1.305 //x2=46.995 //y2=1.76
r664 (  8 31 ) resistor r=0.0675342 //w=0.23 //l=0.115 //layer=m1 \
 //thickness=0.36 //x=46.815 //y=5.335 //x2=46.7 //y2=5.335
r665 (  7 16 ) resistor r=0.0698411 //w=0.17 //l=0.120208 //layer=m1 \
 //thickness=0.36 //x=47.395 //y=5.335 //x2=47.48 //y2=5.25
r666 (  7 8 ) resistor r=0.553435 //w=0.131 //l=0.58 //layer=m1 \
 //thickness=0.36 //x=47.395 //y=5.335 //x2=46.815 //y2=5.335
r667 (  6 33 ) resistor r=0.00118313 //w=0.23 //layer=m1 //thickness=0.36 \
 //x=46.7 //y=5.56 //x2=46.7 //y2=5.56
r668 (  5 31 ) resistor r=0.002872 //w=0.34 //l=0.085 //layer=m1 \
 //thickness=0.36 //x=46.7 //y=5.42 //x2=46.7 //y2=5.335
r669 (  5 6 ) resistor r=0.091623 //w=0.191 //l=0.14 //layer=m1 \
 //thickness=0.36 //x=46.7 //y=5.42 //x2=46.7 //y2=5.56
r670 (  4 28 ) resistor r=0.0262263 //w=0.232 //l=0.12 //layer=m1 \
 //thickness=0.36 //x=45.94 //y=5.335 //x2=45.82 //y2=5.335
r671 (  3 31 ) resistor r=0.0675342 //w=0.23 //l=0.115 //layer=m1 \
 //thickness=0.36 //x=46.585 //y=5.335 //x2=46.7 //y2=5.335
r672 (  3 4 ) resistor r=0.615458 //w=0.131 //l=0.645 //layer=m1 \
 //thickness=0.36 //x=46.585 //y=5.335 //x2=45.94 //y2=5.335
r673 (  2 25 ) resistor r=0.0222262 //w=0.217 //l=0.118 //layer=m1 \
 //thickness=0.36 //x=45.06 //y=5.335 //x2=44.942 //y2=5.335
r674 (  1 28 ) resistor r=0.0262263 //w=0.232 //l=0.12 //layer=m1 \
 //thickness=0.36 //x=45.7 //y=5.335 //x2=45.82 //y2=5.335
r675 (  1 2 ) resistor r=0.610687 //w=0.131 //l=0.64 //layer=m1 \
 //thickness=0.36 //x=45.7 //y=5.335 //x2=45.06 //y2=5.335
ends PM_TMRDFFQNX1\%noxref_15

subckt PM_TMRDFFQNX1\%noxref_16 ( 3 8 9 11 12 14 15 16 18 21 22 25 27 30 34 37 \
 40 45 46 50 58 75 80 84 85 86 87 88 89 90 94 96 99 100 110 113 115 116 )
c278 ( 113 0 ) capacitor c=0.00878249f //x=60.17 //y=1.085
c279 ( 110 0 ) capacitor c=0.0653069f //x=62.65 //y=4.88
c280 ( 100 0 ) capacitor c=0.0318956f //x=62.985 //y=1.39
c281 ( 99 0 ) capacitor c=0.0186809f //x=62.985 //y=1.045
c282 ( 96 0 ) capacitor c=0.0141821f //x=62.83 //y=1.545
c283 ( 94 0 ) capacitor c=0.0158553f //x=62.83 //y=0.89
c284 ( 90 0 ) capacitor c=0.088055f //x=62.455 //y=2.095
c285 ( 89 0 ) capacitor c=0.0229235f //x=62.455 //y=1.7
c286 ( 88 0 ) capacitor c=0.0234359f //x=62.455 //y=1.39
c287 ( 87 0 ) capacitor c=0.0198759f //x=62.455 //y=1.045
c288 ( 86 0 ) capacitor c=0.110369f //x=62.99 //y=6.2
c289 ( 85 0 ) capacitor c=0.154619f //x=62.55 //y=6.2
c290 ( 80 0 ) capacitor c=8.13425e-19 //x=62.65 //y=4.88
c291 ( 75 0 ) capacitor c=7.85889e-19 //x=62.65 //y=2.26
c292 ( 58 0 ) capacitor c=0.0322017f //x=60.32 //y=5.56
c293 ( 50 0 ) capacitor c=0.0290186f //x=59.44 //y=5.56
c294 ( 46 0 ) capacitor c=0.00676038f //x=62.64 //y=4.62
c295 ( 45 0 ) capacitor c=0.00390716f //x=60.955 //y=4.635
c296 ( 40 0 ) capacitor c=0.0431654f //x=62.48 //y=4.62
c297 ( 37 0 ) capacitor c=0.00739828f //x=62.64 //y=4.825
c298 ( 34 0 ) capacitor c=0.00463527f //x=62.65 //y=2.26
c299 ( 30 0 ) capacitor c=0.0146089f //x=60.8 //y=4.62
c300 ( 27 0 ) capacitor c=0.0114161f //x=60.36 //y=1.18
c301 ( 25 0 ) capacitor c=5.78613e-19 //x=60.32 //y=5.56
c302 ( 22 0 ) capacitor c=0.0112561f //x=60.32 //y=5.38
c303 ( 21 0 ) capacitor c=0.00921781f //x=59.44 //y=5.56
c304 ( 18 0 ) capacitor c=0.0632966f //x=62.65 //y=4.665
c305 ( 16 0 ) capacitor c=0.0117904f //x=60.8 //y=5.295
c306 ( 15 0 ) capacitor c=0.013383f //x=60.8 //y=4.795
c307 ( 14 0 ) capacitor c=0.0705722f //x=60.8 //y=4.475
c308 ( 12 0 ) capacitor c=0.00462494f //x=60.445 //y=1.835
c309 ( 11 0 ) capacitor c=0.0117867f //x=60.715 //y=1.835
c310 ( 9 0 ) capacitor c=0.0107674f //x=60.715 //y=5.38
c311 ( 8 0 ) capacitor c=0.0101547f //x=60.36 //y=1.75
c312 ( 3 0 ) capacitor c=0.0148501f //x=60.205 //y=5.38
r313 (  108 110 ) resistor r=20.6867 //w=0.233 //l=0.1 //layer=ply \
 //thickness=0.18 //x=62.55 //y=4.88 //x2=62.65 //y2=4.88
r314 (  101 110 ) resistor r=70.3348 //w=0.233 //l=0.414367 //layer=ply \
 //thickness=0.18 //x=62.99 //y=5.045 //x2=62.65 //y2=4.88
r315 (  100 112 ) resistor r=45.1352 //w=0.168 //l=0.173853 //layer=ply \
 //thickness=0.18 //x=62.985 //y=1.39 //x2=62.945 //y2=1.545
r316 (  99 111 ) resistor r=45.1352 //w=0.168 //l=0.173853 //layer=ply \
 //thickness=0.18 //x=62.985 //y=1.045 //x2=62.945 //y2=0.89
r317 (  99 100 ) resistor r=176.904 //w=0.094 //l=0.345 //layer=ply \
 //thickness=0.18 //x=62.985 //y=1.045 //x2=62.985 //y2=1.39
r318 (  97 107 ) resistor r=10.701 //w=0.21 //l=0.115 //layer=ply \
 //thickness=0.18 //x=62.61 //y=1.545 //x2=62.495 //y2=1.545
r319 (  96 112 ) resistor r=5.52526 //w=0.168 //l=0.115 //layer=ply \
 //thickness=0.18 //x=62.83 //y=1.545 //x2=62.945 //y2=1.545
r320 (  95 106 ) resistor r=5.52526 //w=0.168 //l=0.115 //layer=ply \
 //thickness=0.18 //x=62.61 //y=0.89 //x2=62.495 //y2=0.89
r321 (  94 111 ) resistor r=5.52526 //w=0.168 //l=0.115 //layer=ply \
 //thickness=0.18 //x=62.83 //y=0.89 //x2=62.945 //y2=0.89
r322 (  94 95 ) resistor r=112.809 //w=0.094 //l=0.22 //layer=ply \
 //thickness=0.18 //x=62.83 //y=0.89 //x2=62.61 //y2=0.89
r323 (  91 108 ) resistor r=13.0941 //w=0.233 //l=0.165 //layer=ply \
 //thickness=0.18 //x=62.55 //y=5.045 //x2=62.55 //y2=4.88
r324 (  90 105 ) resistor r=34.8111 //w=0.27 //l=0.264953 //layer=ply \
 //thickness=0.18 //x=62.455 //y=2.095 //x2=62.65 //y2=2.26
r325 (  89 107 ) resistor r=39.5823 //w=0.21 //l=0.173853 //layer=ply \
 //thickness=0.18 //x=62.455 //y=1.7 //x2=62.495 //y2=1.545
r326 (  89 90 ) resistor r=202.543 //w=0.094 //l=0.395 //layer=ply \
 //thickness=0.18 //x=62.455 //y=1.7 //x2=62.455 //y2=2.095
r327 (  88 107 ) resistor r=39.5823 //w=0.21 //l=0.173853 //layer=ply \
 //thickness=0.18 //x=62.455 //y=1.39 //x2=62.495 //y2=1.545
r328 (  87 106 ) resistor r=45.1352 //w=0.168 //l=0.173853 //layer=ply \
 //thickness=0.18 //x=62.455 //y=1.045 //x2=62.495 //y2=0.89
r329 (  87 88 ) resistor r=176.904 //w=0.094 //l=0.345 //layer=ply \
 //thickness=0.18 //x=62.455 //y=1.045 //x2=62.455 //y2=1.39
r330 (  86 101 ) resistor r=592.245 //w=0.094 //l=1.155 //layer=ply \
 //thickness=0.18 //x=62.99 //y=6.2 //x2=62.99 //y2=5.045
r331 (  85 91 ) resistor r=592.245 //w=0.094 //l=1.155 //layer=ply \
 //thickness=0.18 //x=62.55 //y=6.2 //x2=62.55 //y2=5.045
r332 (  84 96 ) resistor r=56.4043 //w=0.094 //l=0.11 //layer=ply \
 //thickness=0.18 //x=62.72 //y=1.545 //x2=62.83 //y2=1.545
r333 (  84 97 ) resistor r=56.4043 //w=0.094 //l=0.11 //layer=ply \
 //thickness=0.18 //x=62.72 //y=1.545 //x2=62.61 //y2=1.545
r334 (  80 110 ) resistor r=152 //w=0.17 //l=0.17 //layer=licon //count=1 \
 //x=62.65 //y=4.88 //x2=62.65 //y2=4.88
r335 (  75 105 ) resistor r=152 //w=0.17 //l=0.17 //layer=licon //count=1 \
 //x=62.65 //y=2.26 //x2=62.65 //y2=2.26
r336 (  58 116 ) resistor r=23.615 //w=0.187 //l=0.345 //layer=li \
 //thickness=0.1 //x=60.32 //y=5.56 //x2=60.32 //y2=5.905
r337 (  50 115 ) resistor r=23.615 //w=0.187 //l=0.345 //layer=li \
 //thickness=0.1 //x=59.44 //y=5.56 //x2=59.44 //y2=5.905
r338 (  46 48 ) resistor r=0.084571 //w=0.303 //l=0.205 //layer=m2 \
 //thickness=0.36 //x=62.64 //y=4.62 //x2=62.64 //y2=4.825
r339 (  43 45 ) resistor r=0.10734 //w=0.281 //l=0.16 //layer=m2 \
 //thickness=0.36 //x=60.795 //y=4.635 //x2=60.955 //y2=4.635
r340 (  40 46 ) resistor r=0.0422082 //w=0.303 //l=0.16 //layer=m2 \
 //thickness=0.36 //x=62.48 //y=4.62 //x2=62.64 //y2=4.62
r341 (  40 45 ) resistor r=1.45515 //w=0.131 //l=1.525 //layer=m2 \
 //thickness=0.36 //x=62.48 //y=4.62 //x2=60.955 //y2=4.62
r342 (  39 80 ) resistor r=9.3 //w=0.17 //l=0.17 //layer=mcon //count=1 \
 //x=62.65 //y=4.88 //x2=62.65 //y2=4.88
r343 (  37 48 ) resistor r=4.5 //w=0.15 //l=0.15 //layer=via1 //count=1 \
 //x=62.64 //y=4.825 //x2=62.64 //y2=4.825
r344 (  37 39 ) resistor r=0.0221061 //w=0.311 //l=0.055 //layer=m1 \
 //thickness=0.36 //x=62.64 //y=4.825 //x2=62.64 //y2=4.88
r345 (  34 75 ) resistor r=9.3 //w=0.17 //l=0.17 //layer=mcon //count=1 \
 //x=62.65 //y=2.26 //x2=62.65 //y2=2.26
r346 (  32 43 ) resistor r=4.5 //w=0.15 //l=0.15 //layer=via1 //count=1 \
 //x=60.795 //y=4.635 //x2=60.795 //y2=4.635
r347 (  30 32 ) resistor r=0.00494723 //w=0.379 //l=0.015 //layer=m1 \
 //thickness=0.36 //x=60.85 //y=4.62 //x2=60.85 //y2=4.635
r348 (  27 113 ) resistor r=9.3 //w=0.17 //l=0.17 //layer=mcon //count=1 \
 //x=60.36 //y=1.18 //x2=60.36 //y2=1.18
r349 (  25 58 ) resistor r=9.3 //w=0.17 //l=0.17 //layer=mcon //count=1 \
 //x=60.32 //y=5.56 //x2=60.32 //y2=5.56
r350 (  22 25 ) resistor r=0.117801 //w=0.191 //l=0.18 //layer=m1 \
 //thickness=0.36 //x=60.32 //y=5.38 //x2=60.32 //y2=5.56
r351 (  21 50 ) resistor r=9.3 //w=0.17 //l=0.17 //layer=mcon //count=1 \
 //x=59.44 //y=5.56 //x2=59.44 //y2=5.56
r352 (  19 21 ) resistor r=0.10274 //w=0.219 //l=0.18 //layer=m1 \
 //thickness=0.36 //x=59.44 //y=5.38 //x2=59.44 //y2=5.56
r353 (  18 37 ) resistor r=0.0898186 //w=0.311 //l=0.164924 //layer=m1 \
 //thickness=0.36 //x=62.65 //y=4.665 //x2=62.64 //y2=4.825
r354 (  17 34 ) resistor r=0.0933015 //w=0.201 //l=0.125 //layer=m1 \
 //thickness=0.36 //x=62.65 //y=2.385 //x2=62.65 //y2=2.26
r355 (  17 18 ) resistor r=2.17557 //w=0.131 //l=2.28 //layer=m1 \
 //thickness=0.36 //x=62.65 //y=2.385 //x2=62.65 //y2=4.665
r356 (  15 32 ) resistor r=0.0912814 //w=0.379 //l=0.183303 //layer=m1 \
 //thickness=0.36 //x=60.8 //y=4.795 //x2=60.85 //y2=4.635
r357 (  15 16 ) resistor r=0.477099 //w=0.131 //l=0.5 //layer=m1 \
 //thickness=0.36 //x=60.8 //y=4.795 //x2=60.8 //y2=5.295
r358 (  14 30 ) resistor r=0.0863342 //w=0.379 //l=0.168152 //layer=m1 \
 //thickness=0.36 //x=60.8 //y=4.475 //x2=60.85 //y2=4.62
r359 (  13 14 ) resistor r=2.43798 //w=0.131 //l=2.555 //layer=m1 \
 //thickness=0.36 //x=60.8 //y=1.92 //x2=60.8 //y2=4.475
r360 (  11 13 ) resistor r=0.0698411 //w=0.17 //l=0.120208 //layer=m1 \
 //thickness=0.36 //x=60.715 //y=1.835 //x2=60.8 //y2=1.92
r361 (  11 12 ) resistor r=0.257634 //w=0.131 //l=0.27 //layer=m1 \
 //thickness=0.36 //x=60.715 //y=1.835 //x2=60.445 //y2=1.835
r362 (  10 22 ) resistor r=0.0257089 //w=0.23 //l=0.115 //layer=m1 \
 //thickness=0.36 //x=60.435 //y=5.38 //x2=60.32 //y2=5.38
r363 (  9 16 ) resistor r=0.0698411 //w=0.17 //l=0.120208 //layer=m1 \
 //thickness=0.36 //x=60.715 //y=5.38 //x2=60.8 //y2=5.295
r364 (  9 10 ) resistor r=0.267176 //w=0.131 //l=0.28 //layer=m1 \
 //thickness=0.36 //x=60.715 //y=5.38 //x2=60.435 //y2=5.38
r365 (  8 12 ) resistor r=0.0698411 //w=0.17 //l=0.120208 //layer=m1 \
 //thickness=0.36 //x=60.36 //y=1.75 //x2=60.445 //y2=1.835
r366 (  7 27 ) resistor r=0.0913624 //w=0.191 //l=0.12 //layer=m1 \
 //thickness=0.36 //x=60.36 //y=1.3 //x2=60.36 //y2=1.18
r367 (  7 8 ) resistor r=0.429389 //w=0.131 //l=0.45 //layer=m1 \
 //thickness=0.36 //x=60.36 //y=1.3 //x2=60.36 //y2=1.75
r368 (  4 19 ) resistor r=0.0227762 //w=0.219 //l=0.115 //layer=m1 \
 //thickness=0.36 //x=59.555 //y=5.38 //x2=59.44 //y2=5.38
r369 (  3 22 ) resistor r=0.0257089 //w=0.23 //l=0.115 //layer=m1 \
 //thickness=0.36 //x=60.205 //y=5.38 //x2=60.32 //y2=5.38
r370 (  3 4 ) resistor r=0.620229 //w=0.131 //l=0.65 //layer=m1 \
 //thickness=0.36 //x=60.205 //y=5.38 //x2=59.555 //y2=5.38
ends PM_TMRDFFQNX1\%noxref_16

subckt PM_TMRDFFQNX1\%noxref_17 ( 1 2 3 4 6 7 8 11 16 17 19 20 22 23 24 26 27 \
 28 34 38 42 49 50 53 55 58 62 65 70 72 74 76 78 79 80 81 85 93 102 107 116 \
 121 129 146 155 159 160 161 162 163 164 165 166 167 168 169 170 171 172 174 \
 180 181 182 183 187 188 189 194 196 198 204 205 206 207 208 213 215 217 223 \
 224 234 235 238 247 248 251 259 261 262 )
c628 ( 259 0 ) capacitor c=0.00878249f //x=56.84 //y=1.085
c629 ( 251 0 ) capacitor c=0.0356006f //x=63.42 //y=4.88
c630 ( 248 0 ) capacitor c=0.0284095f //x=63.39 //y=2.095
c631 ( 247 0 ) capacitor c=0.0476356f //x=63.39 //y=2.26
c632 ( 238 0 ) capacitor c=0.0354915f //x=53.43 //y=4.88
c633 ( 235 0 ) capacitor c=0.0284095f //x=53.4 //y=2.095
c634 ( 234 0 ) capacitor c=0.0476356f //x=53.4 //y=2.26
c635 ( 224 0 ) capacitor c=0.0439708f //x=63.955 //y=1.43
c636 ( 223 0 ) capacitor c=0.0192582f //x=63.955 //y=1.085
c637 ( 217 0 ) capacitor c=0.0162526f //x=63.8 //y=1.585
c638 ( 215 0 ) capacitor c=0.0157807f //x=63.8 //y=0.93
c639 ( 213 0 ) capacitor c=0.0373491f //x=63.795 //y=4.97
c640 ( 208 0 ) capacitor c=0.0210762f //x=63.425 //y=1.74
c641 ( 207 0 ) capacitor c=0.0168511f //x=63.425 //y=1.43
c642 ( 206 0 ) capacitor c=0.0175485f //x=63.425 //y=1.085
c643 ( 205 0 ) capacitor c=0.0439708f //x=53.965 //y=1.43
c644 ( 204 0 ) capacitor c=0.0192582f //x=53.965 //y=1.085
c645 ( 198 0 ) capacitor c=0.0162526f //x=53.81 //y=1.585
c646 ( 196 0 ) capacitor c=0.0157807f //x=53.81 //y=0.93
c647 ( 194 0 ) capacitor c=0.0372668f //x=53.805 //y=4.97
c648 ( 189 0 ) capacitor c=0.0210762f //x=53.435 //y=1.74
c649 ( 188 0 ) capacitor c=0.0168511f //x=53.435 //y=1.43
c650 ( 187 0 ) capacitor c=0.0175485f //x=53.435 //y=1.085
c651 ( 183 0 ) capacitor c=0.0552496f //x=44.795 //y=4.97
c652 ( 182 0 ) capacitor c=0.0376038f //x=45.085 //y=4.97
c653 ( 181 0 ) capacitor c=0.0346489f //x=44.75 //y=1.4
c654 ( 180 0 ) capacitor c=0.018692f //x=44.75 //y=1.055
c655 ( 174 0 ) capacitor c=0.0137077f //x=44.595 //y=1.555
c656 ( 172 0 ) capacitor c=0.0158585f //x=44.595 //y=0.9
c657 ( 171 0 ) capacitor c=0.103534f //x=44.22 //y=2.095
c658 ( 170 0 ) capacitor c=0.0229444f //x=44.22 //y=1.71
c659 ( 169 0 ) capacitor c=0.0234359f //x=44.22 //y=1.4
c660 ( 168 0 ) capacitor c=0.019815f //x=44.22 //y=1.055
c661 ( 167 0 ) capacitor c=0.155269f //x=63.87 //y=6.2
c662 ( 166 0 ) capacitor c=0.110375f //x=63.43 //y=6.2
c663 ( 165 0 ) capacitor c=0.155269f //x=53.88 //y=6.2
c664 ( 164 0 ) capacitor c=0.110375f //x=53.44 //y=6.2
c665 ( 163 0 ) capacitor c=0.110208f //x=45.16 //y=6.2
c666 ( 162 0 ) capacitor c=0.158957f //x=44.72 //y=6.2
c667 ( 155 0 ) capacitor c=5.80994e-19 //x=63.42 //y=4.88
c668 ( 146 0 ) capacitor c=5.78095e-19 //x=63.39 //y=2.26
c669 ( 129 0 ) capacitor c=0.0319332f //x=56.99 //y=5.56
c670 ( 121 0 ) capacitor c=0.0291719f //x=56.11 //y=5.56
c671 ( 116 0 ) capacitor c=5.80994e-19 //x=53.43 //y=4.88
c672 ( 107 0 ) capacitor c=5.78095e-19 //x=53.4 //y=2.26
c673 ( 102 0 ) capacitor c=0.00129098f //x=44.52 //y=4.88
c674 ( 93 0 ) capacitor c=0.0012618f //x=44.52 //y=2.26
c675 ( 85 0 ) capacitor c=0.00112471f //x=44.685 //y=4.255
c676 ( 81 0 ) capacitor c=0.0512985f //x=59.19 //y=4.27
c677 ( 80 0 ) capacitor c=0.0605061f //x=59.535 //y=4.27
c678 ( 79 0 ) capacitor c=0.0346285f //x=53.565 //y=4.25
c679 ( 78 0 ) capacitor c=0.0376552f //x=57.3 //y=4.25
c680 ( 76 0 ) capacitor c=0.00147451f //x=49.54 //y=4.265
c681 ( 74 0 ) capacitor c=0.0153988f //x=48.94 //y=4.25
c682 ( 72 0 ) capacitor c=0.00416722f //x=47.695 //y=4.265
c683 ( 70 0 ) capacitor c=0.0313219f //x=47.095 //y=4.25
c684 ( 65 0 ) capacitor c=0.00504845f //x=63.39 //y=2.26
c685 ( 62 0 ) capacitor c=0.0152588f //x=63.39 //y=4.25
c686 ( 58 0 ) capacitor c=0.015184f //x=57.47 //y=4.25
c687 ( 55 0 ) capacitor c=0.0113259f //x=57.03 //y=1.18
c688 ( 53 0 ) capacitor c=5.78613e-19 //x=56.99 //y=5.56
c689 ( 50 0 ) capacitor c=0.0106343f //x=56.99 //y=5.38
c690 ( 49 0 ) capacitor c=0.00933207f //x=56.11 //y=5.56
c691 ( 42 0 ) capacitor c=0.00504845f //x=53.4 //y=2.26
c692 ( 38 0 ) capacitor c=0.0143744f //x=53.4 //y=4.25
c693 ( 34 0 ) capacitor c=0.0159434f //x=44.52 //y=4.25
c694 ( 28 0 ) capacitor c=0.00891153f //x=63.39 //y=4.735
c695 ( 27 0 ) capacitor c=0.00982913f //x=63.39 //y=4.41
c696 ( 26 0 ) capacitor c=0.0388779f //x=63.39 //y=4.09
c697 ( 24 0 ) capacitor c=0.0186539f //x=57.47 //y=5.295
c698 ( 23 0 ) capacitor c=0.0126302f //x=57.47 //y=4.425
c699 ( 22 0 ) capacitor c=0.0598543f //x=57.47 //y=4.105
c700 ( 20 0 ) capacitor c=0.00465779f //x=57.115 //y=1.835
c701 ( 19 0 ) capacitor c=0.0118867f //x=57.385 //y=1.835
c702 ( 17 0 ) capacitor c=0.0102685f //x=57.385 //y=5.38
c703 ( 16 0 ) capacitor c=0.0101547f //x=57.03 //y=1.75
c704 ( 11 0 ) capacitor c=0.0142466f //x=56.875 //y=5.38
c705 ( 8 0 ) capacitor c=0.00908133f //x=53.4 //y=4.735
c706 ( 7 0 ) capacitor c=0.0099435f //x=53.4 //y=4.415
c707 ( 6 0 ) capacitor c=0.0339717f //x=53.4 //y=4.095
c708 ( 4 0 ) capacitor c=0.0140142f //x=44.52 //y=4.755
c709 ( 3 0 ) capacitor c=0.0125845f //x=44.52 //y=4.415
c710 ( 2 0 ) capacitor c=0.0563317f //x=44.52 //y=4.095
c711 ( 1 0 ) capacitor c=0.00494847f //x=44.52 //y=2.375
r712 (  253 254 ) resistor r=32.4568 //w=0.214 //l=0.075 //layer=ply \
 //thickness=0.18 //x=63.42 //y=4.97 //x2=63.42 //y2=5.045
r713 (  251 253 ) resistor r=20.271 //w=0.214 //l=0.09 //layer=ply \
 //thickness=0.18 //x=63.42 //y=4.88 //x2=63.42 //y2=4.97
r714 (  247 248 ) resistor r=52.7279 //w=0.214 //l=0.165 //layer=ply \
 //thickness=0.18 //x=63.39 //y=2.26 //x2=63.39 //y2=2.095
r715 (  240 241 ) resistor r=32.4568 //w=0.214 //l=0.075 //layer=ply \
 //thickness=0.18 //x=53.43 //y=4.97 //x2=53.43 //y2=5.045
r716 (  238 240 ) resistor r=20.271 //w=0.214 //l=0.09 //layer=ply \
 //thickness=0.18 //x=53.43 //y=4.88 //x2=53.43 //y2=4.97
r717 (  234 235 ) resistor r=52.7279 //w=0.214 //l=0.165 //layer=ply \
 //thickness=0.18 //x=53.4 //y=2.26 //x2=53.4 //y2=2.095
r718 (  224 258 ) resistor r=45.1352 //w=0.168 //l=0.173853 //layer=ply \
 //thickness=0.18 //x=63.955 //y=1.43 //x2=63.915 //y2=1.585
r719 (  223 257 ) resistor r=45.1352 //w=0.168 //l=0.173853 //layer=ply \
 //thickness=0.18 //x=63.955 //y=1.085 //x2=63.915 //y2=0.93
r720 (  223 224 ) resistor r=176.904 //w=0.094 //l=0.345 //layer=ply \
 //thickness=0.18 //x=63.955 //y=1.085 //x2=63.955 //y2=1.43
r721 (  218 256 ) resistor r=10.701 //w=0.21 //l=0.115 //layer=ply \
 //thickness=0.18 //x=63.58 //y=1.585 //x2=63.465 //y2=1.585
r722 (  217 258 ) resistor r=5.52526 //w=0.168 //l=0.115 //layer=ply \
 //thickness=0.18 //x=63.8 //y=1.585 //x2=63.915 //y2=1.585
r723 (  216 255 ) resistor r=5.52526 //w=0.168 //l=0.115 //layer=ply \
 //thickness=0.18 //x=63.58 //y=0.93 //x2=63.465 //y2=0.93
r724 (  215 257 ) resistor r=5.52526 //w=0.168 //l=0.115 //layer=ply \
 //thickness=0.18 //x=63.8 //y=0.93 //x2=63.915 //y2=0.93
r725 (  215 216 ) resistor r=112.809 //w=0.094 //l=0.22 //layer=ply \
 //thickness=0.18 //x=63.8 //y=0.93 //x2=63.58 //y2=0.93
r726 (  214 253 ) resistor r=16.5046 //w=0.27 //l=0.135 //layer=ply \
 //thickness=0.18 //x=63.555 //y=4.97 //x2=63.42 //y2=4.97
r727 (  213 220 ) resistor r=26.9307 //w=0.15 //l=0.106066 //layer=ply \
 //thickness=0.18 //x=63.795 //y=4.97 //x2=63.87 //y2=5.045
r728 (  213 214 ) resistor r=123.064 //w=0.094 //l=0.24 //layer=ply \
 //thickness=0.18 //x=63.795 //y=4.97 //x2=63.555 //y2=4.97
r729 (  208 256 ) resistor r=39.5823 //w=0.21 //l=0.173853 //layer=ply \
 //thickness=0.18 //x=63.425 //y=1.74 //x2=63.465 //y2=1.585
r730 (  208 248 ) resistor r=182.032 //w=0.094 //l=0.355 //layer=ply \
 //thickness=0.18 //x=63.425 //y=1.74 //x2=63.425 //y2=2.095
r731 (  207 256 ) resistor r=39.5823 //w=0.21 //l=0.173853 //layer=ply \
 //thickness=0.18 //x=63.425 //y=1.43 //x2=63.465 //y2=1.585
r732 (  206 255 ) resistor r=45.1352 //w=0.168 //l=0.173853 //layer=ply \
 //thickness=0.18 //x=63.425 //y=1.085 //x2=63.465 //y2=0.93
r733 (  206 207 ) resistor r=176.904 //w=0.094 //l=0.345 //layer=ply \
 //thickness=0.18 //x=63.425 //y=1.085 //x2=63.425 //y2=1.43
r734 (  205 245 ) resistor r=45.1352 //w=0.168 //l=0.173853 //layer=ply \
 //thickness=0.18 //x=53.965 //y=1.43 //x2=53.925 //y2=1.585
r735 (  204 244 ) resistor r=45.1352 //w=0.168 //l=0.173853 //layer=ply \
 //thickness=0.18 //x=53.965 //y=1.085 //x2=53.925 //y2=0.93
r736 (  204 205 ) resistor r=176.904 //w=0.094 //l=0.345 //layer=ply \
 //thickness=0.18 //x=53.965 //y=1.085 //x2=53.965 //y2=1.43
r737 (  199 243 ) resistor r=10.701 //w=0.21 //l=0.115 //layer=ply \
 //thickness=0.18 //x=53.59 //y=1.585 //x2=53.475 //y2=1.585
r738 (  198 245 ) resistor r=5.52526 //w=0.168 //l=0.115 //layer=ply \
 //thickness=0.18 //x=53.81 //y=1.585 //x2=53.925 //y2=1.585
r739 (  197 242 ) resistor r=5.52526 //w=0.168 //l=0.115 //layer=ply \
 //thickness=0.18 //x=53.59 //y=0.93 //x2=53.475 //y2=0.93
r740 (  196 244 ) resistor r=5.52526 //w=0.168 //l=0.115 //layer=ply \
 //thickness=0.18 //x=53.81 //y=0.93 //x2=53.925 //y2=0.93
r741 (  196 197 ) resistor r=112.809 //w=0.094 //l=0.22 //layer=ply \
 //thickness=0.18 //x=53.81 //y=0.93 //x2=53.59 //y2=0.93
r742 (  195 240 ) resistor r=16.5046 //w=0.27 //l=0.135 //layer=ply \
 //thickness=0.18 //x=53.565 //y=4.97 //x2=53.43 //y2=4.97
r743 (  194 201 ) resistor r=26.9307 //w=0.15 //l=0.106066 //layer=ply \
 //thickness=0.18 //x=53.805 //y=4.97 //x2=53.88 //y2=5.045
r744 (  194 195 ) resistor r=123.064 //w=0.094 //l=0.24 //layer=ply \
 //thickness=0.18 //x=53.805 //y=4.97 //x2=53.565 //y2=4.97
r745 (  189 243 ) resistor r=39.5823 //w=0.21 //l=0.173853 //layer=ply \
 //thickness=0.18 //x=53.435 //y=1.74 //x2=53.475 //y2=1.585
r746 (  189 235 ) resistor r=182.032 //w=0.094 //l=0.355 //layer=ply \
 //thickness=0.18 //x=53.435 //y=1.74 //x2=53.435 //y2=2.095
r747 (  188 243 ) resistor r=39.5823 //w=0.21 //l=0.173853 //layer=ply \
 //thickness=0.18 //x=53.435 //y=1.43 //x2=53.475 //y2=1.585
r748 (  187 242 ) resistor r=45.1352 //w=0.168 //l=0.173853 //layer=ply \
 //thickness=0.18 //x=53.435 //y=1.085 //x2=53.475 //y2=0.93
r749 (  187 188 ) resistor r=176.904 //w=0.094 //l=0.345 //layer=ply \
 //thickness=0.18 //x=53.435 //y=1.085 //x2=53.435 //y2=1.43
r750 (  182 184 ) resistor r=26.9307 //w=0.15 //l=0.106066 //layer=ply \
 //thickness=0.18 //x=45.085 //y=4.97 //x2=45.16 //y2=5.045
r751 (  182 183 ) resistor r=148.702 //w=0.094 //l=0.29 //layer=ply \
 //thickness=0.18 //x=45.085 //y=4.97 //x2=44.795 //y2=4.97
r752 (  181 232 ) resistor r=45.1352 //w=0.168 //l=0.173853 //layer=ply \
 //thickness=0.18 //x=44.75 //y=1.4 //x2=44.71 //y2=1.555
r753 (  180 231 ) resistor r=45.1352 //w=0.168 //l=0.173853 //layer=ply \
 //thickness=0.18 //x=44.75 //y=1.055 //x2=44.71 //y2=0.9
r754 (  180 181 ) resistor r=176.904 //w=0.094 //l=0.345 //layer=ply \
 //thickness=0.18 //x=44.75 //y=1.055 //x2=44.75 //y2=1.4
r755 (  177 183 ) resistor r=22.7971 //w=0.269 //l=0.106066 //layer=ply \
 //thickness=0.18 //x=44.72 //y=5.045 //x2=44.795 //y2=4.97
r756 (  177 230 ) resistor r=35.8364 //w=0.269 //l=0.270185 //layer=ply \
 //thickness=0.18 //x=44.72 //y=5.045 //x2=44.52 //y2=4.88
r757 (  175 226 ) resistor r=10.701 //w=0.21 //l=0.115 //layer=ply \
 //thickness=0.18 //x=44.375 //y=1.555 //x2=44.26 //y2=1.555
r758 (  174 232 ) resistor r=5.52526 //w=0.168 //l=0.115 //layer=ply \
 //thickness=0.18 //x=44.595 //y=1.555 //x2=44.71 //y2=1.555
r759 (  173 225 ) resistor r=5.52526 //w=0.168 //l=0.115 //layer=ply \
 //thickness=0.18 //x=44.375 //y=0.9 //x2=44.26 //y2=0.9
r760 (  172 231 ) resistor r=5.52526 //w=0.168 //l=0.115 //layer=ply \
 //thickness=0.18 //x=44.595 //y=0.9 //x2=44.71 //y2=0.9
r761 (  172 173 ) resistor r=112.809 //w=0.094 //l=0.22 //layer=ply \
 //thickness=0.18 //x=44.595 //y=0.9 //x2=44.375 //y2=0.9
r762 (  171 228 ) resistor r=58.7805 //w=0.246 //l=0.373497 //layer=ply \
 //thickness=0.18 //x=44.22 //y=2.095 //x2=44.52 //y2=2.26
r763 (  170 226 ) resistor r=39.5823 //w=0.21 //l=0.173853 //layer=ply \
 //thickness=0.18 //x=44.22 //y=1.71 //x2=44.26 //y2=1.555
r764 (  170 171 ) resistor r=197.415 //w=0.094 //l=0.385 //layer=ply \
 //thickness=0.18 //x=44.22 //y=1.71 //x2=44.22 //y2=2.095
r765 (  169 226 ) resistor r=39.5823 //w=0.21 //l=0.173853 //layer=ply \
 //thickness=0.18 //x=44.22 //y=1.4 //x2=44.26 //y2=1.555
r766 (  168 225 ) resistor r=45.1352 //w=0.168 //l=0.173853 //layer=ply \
 //thickness=0.18 //x=44.22 //y=1.055 //x2=44.26 //y2=0.9
r767 (  168 169 ) resistor r=176.904 //w=0.094 //l=0.345 //layer=ply \
 //thickness=0.18 //x=44.22 //y=1.055 //x2=44.22 //y2=1.4
r768 (  167 220 ) resistor r=592.245 //w=0.094 //l=1.155 //layer=ply \
 //thickness=0.18 //x=63.87 //y=6.2 //x2=63.87 //y2=5.045
r769 (  166 254 ) resistor r=592.245 //w=0.094 //l=1.155 //layer=ply \
 //thickness=0.18 //x=63.43 //y=6.2 //x2=63.43 //y2=5.045
r770 (  165 201 ) resistor r=592.245 //w=0.094 //l=1.155 //layer=ply \
 //thickness=0.18 //x=53.88 //y=6.2 //x2=53.88 //y2=5.045
r771 (  164 241 ) resistor r=592.245 //w=0.094 //l=1.155 //layer=ply \
 //thickness=0.18 //x=53.44 //y=6.2 //x2=53.44 //y2=5.045
r772 (  163 184 ) resistor r=592.245 //w=0.094 //l=1.155 //layer=ply \
 //thickness=0.18 //x=45.16 //y=6.2 //x2=45.16 //y2=5.045
r773 (  162 177 ) resistor r=592.245 //w=0.094 //l=1.155 //layer=ply \
 //thickness=0.18 //x=44.72 //y=6.2 //x2=44.72 //y2=5.045
r774 (  161 217 ) resistor r=56.4043 //w=0.094 //l=0.11 //layer=ply \
 //thickness=0.18 //x=63.69 //y=1.585 //x2=63.8 //y2=1.585
r775 (  161 218 ) resistor r=56.4043 //w=0.094 //l=0.11 //layer=ply \
 //thickness=0.18 //x=63.69 //y=1.585 //x2=63.58 //y2=1.585
r776 (  160 198 ) resistor r=56.4043 //w=0.094 //l=0.11 //layer=ply \
 //thickness=0.18 //x=53.7 //y=1.585 //x2=53.81 //y2=1.585
r777 (  160 199 ) resistor r=56.4043 //w=0.094 //l=0.11 //layer=ply \
 //thickness=0.18 //x=53.7 //y=1.585 //x2=53.59 //y2=1.585
r778 (  159 174 ) resistor r=56.4043 //w=0.094 //l=0.11 //layer=ply \
 //thickness=0.18 //x=44.485 //y=1.555 //x2=44.595 //y2=1.555
r779 (  159 175 ) resistor r=56.4043 //w=0.094 //l=0.11 //layer=ply \
 //thickness=0.18 //x=44.485 //y=1.555 //x2=44.375 //y2=1.555
r780 (  155 251 ) resistor r=152 //w=0.17 //l=0.17 //layer=licon //count=1 \
 //x=63.42 //y=4.88 //x2=63.42 //y2=4.88
r781 (  146 247 ) resistor r=152 //w=0.17 //l=0.17 //layer=licon //count=1 \
 //x=63.39 //y=2.26 //x2=63.39 //y2=2.26
r782 (  129 262 ) resistor r=23.615 //w=0.187 //l=0.345 //layer=li \
 //thickness=0.1 //x=56.99 //y=5.56 //x2=56.99 //y2=5.905
r783 (  121 261 ) resistor r=23.615 //w=0.187 //l=0.345 //layer=li \
 //thickness=0.1 //x=56.11 //y=5.56 //x2=56.11 //y2=5.905
r784 (  116 238 ) resistor r=152 //w=0.17 //l=0.17 //layer=licon //count=1 \
 //x=53.43 //y=4.88 //x2=53.43 //y2=4.88
r785 (  107 234 ) resistor r=152 //w=0.17 //l=0.17 //layer=licon //count=1 \
 //x=53.4 //y=2.26 //x2=53.4 //y2=2.26
r786 (  102 230 ) resistor r=152 //w=0.17 //l=0.17 //layer=licon //count=1 \
 //x=44.52 //y=4.88 //x2=44.52 //y2=4.88
r787 (  93 228 ) resistor r=152 //w=0.17 //l=0.17 //layer=licon //count=1 \
 //x=44.52 //y=2.26 //x2=44.52 //y2=2.26
r788 (  83 85 ) resistor r=0.10734 //w=0.281 //l=0.16 //layer=m2 \
 //thickness=0.36 //x=44.525 //y=4.255 //x2=44.685 //y2=4.255
r789 (  81 89 ) resistor r=1.10585 //w=0.196 //l=1.7325 //layer=m2 \
 //thickness=0.36 //x=59.19 //y=4.27 //x2=57.46 //y2=4.265
r790 (  80 91 ) resistor r=2.64838 //w=0.182 //l=3.86499 //layer=m2 \
 //thickness=0.36 //x=59.535 //y=4.27 //x2=63.39 //y2=4.25
r791 (  80 81 ) resistor r=0.329198 //w=0.131 //l=0.345 //layer=m2 \
 //thickness=0.36 //x=59.535 //y=4.27 //x2=59.19 //y2=4.27
r792 (  79 87 ) resistor r=0.110608 //w=0.182 //l=0.162481 //layer=m2 \
 //thickness=0.36 //x=53.565 //y=4.25 //x2=53.405 //y2=4.255
r793 (  78 89 ) resistor r=0.104578 //w=0.196 //l=0.167332 //layer=m2 \
 //thickness=0.36 //x=57.3 //y=4.25 //x2=57.46 //y2=4.265
r794 (  78 79 ) resistor r=3.56393 //w=0.131 //l=3.735 //layer=m2 \
 //thickness=0.36 //x=57.3 //y=4.25 //x2=53.565 //y2=4.25
r795 (  76 87 ) resistor r=2.65525 //w=0.182 //l=3.87 //layer=m2 \
 //thickness=0.36 //x=49.54 //y=4.265 //x2=53.405 //y2=4.255
r796 (  76 77 ) resistor r=0.329198 //w=0.131 //l=0.345 //layer=m2 \
 //thickness=0.36 //x=49.54 //y=4.265 //x2=49.195 //y2=4.265
r797 (  74 77 ) resistor r=0.1875 //w=0.17 //l=0.262393 //layer=m2 \
 //thickness=0.36 //x=48.94 //y=4.25 //x2=49.195 //y2=4.265
r798 (  74 75 ) resistor r=1.02576 //w=0.131 //l=1.075 //layer=m2 \
 //thickness=0.36 //x=48.94 //y=4.25 //x2=47.865 //y2=4.25
r799 (  72 75 ) resistor r=0.125 //w=0.17 //l=0.177341 //layer=m2 \
 //thickness=0.36 //x=47.695 //y=4.265 //x2=47.865 //y2=4.25
r800 (  72 73 ) resistor r=0.329198 //w=0.131 //l=0.345 //layer=m2 \
 //thickness=0.36 //x=47.695 //y=4.265 //x2=47.35 //y2=4.265
r801 (  70 73 ) resistor r=0.1875 //w=0.17 //l=0.262393 //layer=m2 \
 //thickness=0.36 //x=47.095 //y=4.25 //x2=47.35 //y2=4.265
r802 (  70 85 ) resistor r=2.29962 //w=0.131 //l=2.41 //layer=m2 \
 //thickness=0.36 //x=47.095 //y=4.25 //x2=44.685 //y2=4.25
r803 (  69 155 ) resistor r=9.3 //w=0.17 //l=0.17 //layer=mcon //count=1 \
 //x=63.42 //y=4.88 //x2=63.42 //y2=4.88
r804 (  65 146 ) resistor r=9.3 //w=0.17 //l=0.17 //layer=mcon //count=1 \
 //x=63.39 //y=2.26 //x2=63.39 //y2=2.26
r805 (  65 67 ) resistor r=0.0936408 //w=0.196 //l=0.125 //layer=m1 \
 //thickness=0.36 //x=63.392 //y=2.26 //x2=63.392 //y2=2.385
r806 (  62 91 ) resistor r=4.5 //w=0.15 //l=0.15 //layer=via1 //count=1 \
 //x=63.39 //y=4.25 //x2=63.39 //y2=4.25
r807 (  60 89 ) resistor r=4.5 //w=0.15 //l=0.15 //layer=via1 //count=1 \
 //x=57.46 //y=4.265 //x2=57.46 //y2=4.265
r808 (  58 60 ) resistor r=0.00505391 //w=0.371 //l=0.015 //layer=m1 \
 //thickness=0.36 //x=57.412 //y=4.25 //x2=57.412 //y2=4.265
r809 (  55 259 ) resistor r=9.3 //w=0.17 //l=0.17 //layer=mcon //count=1 \
 //x=57.03 //y=1.18 //x2=57.03 //y2=1.18
r810 (  53 129 ) resistor r=9.3 //w=0.17 //l=0.17 //layer=mcon //count=1 \
 //x=56.99 //y=5.56 //x2=56.99 //y2=5.56
r811 (  50 53 ) resistor r=0.117801 //w=0.191 //l=0.18 //layer=m1 \
 //thickness=0.36 //x=56.99 //y=5.38 //x2=56.99 //y2=5.56
r812 (  49 121 ) resistor r=9.3 //w=0.17 //l=0.17 //layer=mcon //count=1 \
 //x=56.11 //y=5.56 //x2=56.11 //y2=5.56
r813 (  47 49 ) resistor r=0.10274 //w=0.219 //l=0.18 //layer=m1 \
 //thickness=0.36 //x=56.11 //y=5.38 //x2=56.11 //y2=5.56
r814 (  46 116 ) resistor r=9.3 //w=0.17 //l=0.17 //layer=mcon //count=1 \
 //x=53.43 //y=4.88 //x2=53.43 //y2=4.88
r815 (  42 107 ) resistor r=9.3 //w=0.17 //l=0.17 //layer=mcon //count=1 \
 //x=53.4 //y=2.26 //x2=53.4 //y2=2.26
r816 (  42 44 ) resistor r=0.0936408 //w=0.196 //l=0.125 //layer=m1 \
 //thickness=0.36 //x=53.402 //y=2.26 //x2=53.402 //y2=2.385
r817 (  40 87 ) resistor r=4.5 //w=0.15 //l=0.15 //layer=via1 //count=1 \
 //x=53.405 //y=4.255 //x2=53.405 //y2=4.255
r818 (  38 40 ) resistor r=0.00164908 //w=0.379 //l=0.005 //layer=m1 \
 //thickness=0.36 //x=53.35 //y=4.25 //x2=53.35 //y2=4.255
r819 (  36 83 ) resistor r=4.5 //w=0.15 //l=0.15 //layer=via1 //count=1 \
 //x=44.525 //y=4.255 //x2=44.525 //y2=4.255
r820 (  34 36 ) resistor r=0.00167112 //w=0.374 //l=0.005 //layer=m1 \
 //thickness=0.36 //x=44.575 //y=4.25 //x2=44.575 //y2=4.255
r821 (  32 102 ) resistor r=9.3 //w=0.17 //l=0.17 //layer=mcon //count=1 \
 //x=44.52 //y=4.88 //x2=44.52 //y2=4.88
r822 (  30 93 ) resistor r=9.3 //w=0.17 //l=0.17 //layer=mcon //count=1 \
 //x=44.52 //y=2.26 //x2=44.52 //y2=2.26
r823 (  28 69 ) resistor r=0.0878548 //w=0.228 //l=0.159295 //layer=m1 \
 //thickness=0.36 //x=63.39 //y=4.735 //x2=63.42 //y2=4.88
r824 (  27 62 ) resistor r=0.0911593 //w=0.376 //l=0.184608 //layer=m1 \
 //thickness=0.36 //x=63.39 //y=4.41 //x2=63.337 //y2=4.25
r825 (  27 28 ) resistor r=0.310115 //w=0.131 //l=0.325 //layer=m1 \
 //thickness=0.36 //x=63.39 //y=4.41 //x2=63.39 //y2=4.735
r826 (  26 62 ) resistor r=0.0911593 //w=0.376 //l=0.184608 //layer=m1 \
 //thickness=0.36 //x=63.39 //y=4.09 //x2=63.337 //y2=4.25
r827 (  26 67 ) resistor r=1.62691 //w=0.131 //l=1.705 //layer=m1 \
 //thickness=0.36 //x=63.39 //y=4.09 //x2=63.39 //y2=2.385
r828 (  23 60 ) resistor r=0.0909648 //w=0.371 //l=0.186762 //layer=m1 \
 //thickness=0.36 //x=57.47 //y=4.425 //x2=57.412 //y2=4.265
r829 (  23 24 ) resistor r=0.830153 //w=0.131 //l=0.87 //layer=m1 \
 //thickness=0.36 //x=57.47 //y=4.425 //x2=57.47 //y2=5.295
r830 (  22 58 ) resistor r=0.0859108 //w=0.371 //l=0.171566 //layer=m1 \
 //thickness=0.36 //x=57.47 //y=4.105 //x2=57.412 //y2=4.25
r831 (  21 22 ) resistor r=2.08492 //w=0.131 //l=2.185 //layer=m1 \
 //thickness=0.36 //x=57.47 //y=1.92 //x2=57.47 //y2=4.105
r832 (  19 21 ) resistor r=0.0698411 //w=0.17 //l=0.120208 //layer=m1 \
 //thickness=0.36 //x=57.385 //y=1.835 //x2=57.47 //y2=1.92
r833 (  19 20 ) resistor r=0.257634 //w=0.131 //l=0.27 //layer=m1 \
 //thickness=0.36 //x=57.385 //y=1.835 //x2=57.115 //y2=1.835
r834 (  18 50 ) resistor r=0.0257089 //w=0.23 //l=0.115 //layer=m1 \
 //thickness=0.36 //x=57.105 //y=5.38 //x2=56.99 //y2=5.38
r835 (  17 24 ) resistor r=0.0698411 //w=0.17 //l=0.120208 //layer=m1 \
 //thickness=0.36 //x=57.385 //y=5.38 //x2=57.47 //y2=5.295
r836 (  17 18 ) resistor r=0.267176 //w=0.131 //l=0.28 //layer=m1 \
 //thickness=0.36 //x=57.385 //y=5.38 //x2=57.105 //y2=5.38
r837 (  16 20 ) resistor r=0.0698411 //w=0.17 //l=0.120208 //layer=m1 \
 //thickness=0.36 //x=57.03 //y=1.75 //x2=57.115 //y2=1.835
r838 (  15 55 ) resistor r=0.0913624 //w=0.191 //l=0.12 //layer=m1 \
 //thickness=0.36 //x=57.03 //y=1.3 //x2=57.03 //y2=1.18
r839 (  15 16 ) resistor r=0.429389 //w=0.131 //l=0.45 //layer=m1 \
 //thickness=0.36 //x=57.03 //y=1.3 //x2=57.03 //y2=1.75
r840 (  12 47 ) resistor r=0.0227762 //w=0.219 //l=0.115 //layer=m1 \
 //thickness=0.36 //x=56.225 //y=5.38 //x2=56.11 //y2=5.38
r841 (  11 50 ) resistor r=0.0257089 //w=0.23 //l=0.115 //layer=m1 \
 //thickness=0.36 //x=56.875 //y=5.38 //x2=56.99 //y2=5.38
r842 (  11 12 ) resistor r=0.620229 //w=0.131 //l=0.65 //layer=m1 \
 //thickness=0.36 //x=56.875 //y=5.38 //x2=56.225 //y2=5.38
r843 (  8 46 ) resistor r=0.0878548 //w=0.228 //l=0.159295 //layer=m1 \
 //thickness=0.36 //x=53.4 //y=4.735 //x2=53.43 //y2=4.88
r844 (  7 40 ) resistor r=0.0912814 //w=0.379 //l=0.183303 //layer=m1 \
 //thickness=0.36 //x=53.4 //y=4.415 //x2=53.35 //y2=4.255
r845 (  7 8 ) resistor r=0.305344 //w=0.131 //l=0.32 //layer=m1 \
 //thickness=0.36 //x=53.4 //y=4.415 //x2=53.4 //y2=4.735
r846 (  6 38 ) resistor r=0.0896323 //w=0.379 //l=0.178255 //layer=m1 \
 //thickness=0.36 //x=53.4 //y=4.095 //x2=53.35 //y2=4.25
r847 (  6 44 ) resistor r=1.63168 //w=0.131 //l=1.71 //layer=m1 \
 //thickness=0.36 //x=53.4 //y=4.095 //x2=53.4 //y2=2.385
r848 (  4 32 ) resistor r=0.0760407 //w=0.238 //l=0.125 //layer=m1 \
 //thickness=0.36 //x=44.52 //y=4.755 //x2=44.52 //y2=4.88
r849 (  3 36 ) resistor r=0.0910802 //w=0.374 //l=0.185472 //layer=m1 \
 //thickness=0.36 //x=44.52 //y=4.415 //x2=44.575 //y2=4.255
r850 (  3 4 ) resistor r=0.324427 //w=0.131 //l=0.34 //layer=m1 \
 //thickness=0.36 //x=44.52 //y=4.415 //x2=44.52 //y2=4.755
r851 (  2 34 ) resistor r=0.089409 //w=0.374 //l=0.180416 //layer=m1 \
 //thickness=0.36 //x=44.52 //y=4.095 //x2=44.575 //y2=4.25
r852 (  1 30 ) resistor r=0.0719237 //w=0.222 //l=0.115 //layer=m1 \
 //thickness=0.36 //x=44.52 //y=2.375 //x2=44.52 //y2=2.26
r853 (  1 2 ) resistor r=1.64122 //w=0.131 //l=1.72 //layer=m1 \
 //thickness=0.36 //x=44.52 //y=2.375 //x2=44.52 //y2=4.095
ends PM_TMRDFFQNX1\%noxref_17

subckt PM_TMRDFFQNX1\%noxref_18 ( 2 3 4 7 12 13 15 16 18 19 20 21 22 23 24 25 \
 26 28 36 39 40 43 45 48 54 58 61 66 68 71 73 77 81 82 88 89 92 101 106 114 \
 131 140 146 151 156 157 158 159 160 161 162 163 164 165 166 167 172 174 176 \
 182 183 184 185 186 187 191 193 196 197 198 199 203 204 205 206 210 212 218 \
 219 221 222 225 234 247 250 252 253 )
c556 ( 250 0 ) capacitor c=0.00878249f //x=63.5 //y=1.085
c557 ( 247 0 ) capacitor c=0.0692896f //x=69.31 //y=4.885
c558 ( 234 0 ) capacitor c=0.0603371f //x=65.61 //y=2.26
c559 ( 225 0 ) capacitor c=0.0363169f //x=60.09 //y=4.88
c560 ( 222 0 ) capacitor c=0.0284095f //x=60.06 //y=2.095
c561 ( 221 0 ) capacitor c=0.0476356f //x=60.06 //y=2.26
c562 ( 219 0 ) capacitor c=0.0344584f //x=69.645 //y=1.39
c563 ( 218 0 ) capacitor c=0.0186809f //x=69.645 //y=1.045
c564 ( 212 0 ) capacitor c=0.0141797f //x=69.49 //y=1.545
c565 ( 210 0 ) capacitor c=0.0158553f //x=69.49 //y=0.89
c566 ( 206 0 ) capacitor c=0.103881f //x=69.115 //y=2.095
c567 ( 205 0 ) capacitor c=0.0227978f //x=69.115 //y=1.7
c568 ( 204 0 ) capacitor c=0.0234352f //x=69.115 //y=1.39
c569 ( 203 0 ) capacitor c=0.0198759f //x=69.115 //y=1.045
c570 ( 199 0 ) capacitor c=0.0318956f //x=66.315 //y=1.39
c571 ( 198 0 ) capacitor c=0.0186809f //x=66.315 //y=1.045
c572 ( 197 0 ) capacitor c=0.061583f //x=65.955 //y=4.975
c573 ( 196 0 ) capacitor c=0.0375163f //x=66.245 //y=4.975
c574 ( 193 0 ) capacitor c=0.0157936f //x=66.16 //y=1.545
c575 ( 191 0 ) capacitor c=0.0158553f //x=66.16 //y=0.89
c576 ( 187 0 ) capacitor c=0.0302441f //x=65.785 //y=2.095
c577 ( 186 0 ) capacitor c=0.0238107f //x=65.785 //y=1.7
c578 ( 185 0 ) capacitor c=0.0234359f //x=65.785 //y=1.39
c579 ( 184 0 ) capacitor c=0.0199332f //x=65.785 //y=1.045
c580 ( 183 0 ) capacitor c=0.0439708f //x=60.625 //y=1.43
c581 ( 182 0 ) capacitor c=0.0192582f //x=60.625 //y=1.085
c582 ( 176 0 ) capacitor c=0.0162526f //x=60.47 //y=1.585
c583 ( 174 0 ) capacitor c=0.0157807f //x=60.47 //y=0.93
c584 ( 172 0 ) capacitor c=0.0359568f //x=60.465 //y=4.97
c585 ( 167 0 ) capacitor c=0.0210762f //x=60.095 //y=1.74
c586 ( 166 0 ) capacitor c=0.0168511f //x=60.095 //y=1.43
c587 ( 165 0 ) capacitor c=0.0175485f //x=60.095 //y=1.085
c588 ( 164 0 ) capacitor c=0.110525f //x=69.64 //y=6.205
c589 ( 163 0 ) capacitor c=0.154978f //x=69.2 //y=6.205
c590 ( 162 0 ) capacitor c=0.110282f //x=66.32 //y=6.205
c591 ( 161 0 ) capacitor c=0.155219f //x=65.88 //y=6.205
c592 ( 160 0 ) capacitor c=0.155269f //x=60.54 //y=6.2
c593 ( 159 0 ) capacitor c=0.110375f //x=60.1 //y=6.2
c594 ( 151 0 ) capacitor c=0.0156601f //x=69.31 //y=4.62
c595 ( 146 0 ) capacitor c=0.00126053f //x=69.31 //y=2.26
c596 ( 140 0 ) capacitor c=0.0117308f //x=65.61 //y=4.62
c597 ( 131 0 ) capacitor c=9.32025e-19 //x=65.61 //y=2.26
c598 ( 114 0 ) capacitor c=0.0320929f //x=63.65 //y=5.56
c599 ( 106 0 ) capacitor c=0.028968f //x=62.77 //y=5.56
c600 ( 101 0 ) capacitor c=0.00106022f //x=60.09 //y=4.88
c601 ( 92 0 ) capacitor c=5.78095e-19 //x=60.06 //y=2.26
c602 ( 89 0 ) capacitor c=0.0746006f //x=69.155 //y=4.64
c603 ( 88 0 ) capacitor c=0.00642399f //x=69.315 //y=4.64
c604 ( 82 0 ) capacitor c=0.0405506f //x=65.445 //y=3.875
c605 ( 81 0 ) capacitor c=0.00110297f //x=65.605 //y=3.875
c606 ( 77 0 ) capacitor c=7.51531e-19 //x=60.225 //y=3.865
c607 ( 73 0 ) capacitor c=0.00530263f //x=65.775 //y=4.62
c608 ( 71 0 ) capacitor c=0.0128334f //x=64.295 //y=3.88
c609 ( 68 0 ) capacitor c=0.00389639f //x=63.605 //y=3.865
c610 ( 66 0 ) capacitor c=0.0378686f //x=63.005 //y=3.88
c611 ( 61 0 ) capacitor c=0.0127992f //x=69.31 //y=4.62
c612 ( 58 0 ) capacitor c=0.012633f //x=65.61 //y=4.62
c613 ( 54 0 ) capacitor c=0.0159207f //x=65.61 //y=3.88
c614 ( 48 0 ) capacitor c=0.0168648f //x=64.13 //y=3.88
c615 ( 45 0 ) capacitor c=0.0113351f //x=63.69 //y=1.18
c616 ( 43 0 ) capacitor c=5.78613e-19 //x=63.65 //y=5.56
c617 ( 40 0 ) capacitor c=0.0114734f //x=63.65 //y=5.38
c618 ( 39 0 ) capacitor c=0.00905827f //x=62.77 //y=5.56
c619 ( 36 0 ) capacitor c=0.0139575f //x=60.06 //y=3.88
c620 ( 28 0 ) capacitor c=0.00504845f //x=60.06 //y=2.26
c621 ( 26 0 ) capacitor c=0.0794553f //x=69.31 //y=4.475
c622 ( 25 0 ) capacitor c=0.00874002f //x=69.31 //y=2.385
c623 ( 24 0 ) capacitor c=0.0093317f //x=65.61 //y=4.46
c624 ( 23 0 ) capacitor c=0.0121808f //x=65.61 //y=4.035
c625 ( 22 0 ) capacitor c=0.0399584f //x=65.61 //y=3.715
c626 ( 21 0 ) capacitor c=0.00385573f //x=65.61 //y=2.375
c627 ( 20 0 ) capacitor c=0.0289425f //x=64.13 //y=5.295
c628 ( 19 0 ) capacitor c=0.0121867f //x=64.13 //y=4.045
c629 ( 18 0 ) capacitor c=0.0500716f //x=64.13 //y=3.725
c630 ( 16 0 ) capacitor c=0.00465779f //x=63.775 //y=1.835
c631 ( 15 0 ) capacitor c=0.013041f //x=64.045 //y=1.835
c632 ( 13 0 ) capacitor c=0.0116118f //x=64.045 //y=5.38
c633 ( 12 0 ) capacitor c=0.0115202f //x=63.69 //y=1.75
c634 ( 7 0 ) capacitor c=0.0136628f //x=63.535 //y=5.38
c635 ( 4 0 ) capacitor c=0.0165616f //x=60.06 //y=4.735
c636 ( 3 0 ) capacitor c=0.00981203f //x=60.06 //y=4.025
c637 ( 2 0 ) capacitor c=0.0313844f //x=60.06 //y=3.705
r638 (  245 247 ) resistor r=22.7554 //w=0.233 //l=0.11 //layer=ply \
 //thickness=0.18 //x=69.2 //y=4.885 //x2=69.31 //y2=4.885
r639 (  227 228 ) resistor r=32.4568 //w=0.214 //l=0.075 //layer=ply \
 //thickness=0.18 //x=60.09 //y=4.97 //x2=60.09 //y2=5.045
r640 (  225 227 ) resistor r=20.271 //w=0.214 //l=0.09 //layer=ply \
 //thickness=0.18 //x=60.09 //y=4.88 //x2=60.09 //y2=4.97
r641 (  221 222 ) resistor r=52.7279 //w=0.214 //l=0.165 //layer=ply \
 //thickness=0.18 //x=60.06 //y=2.26 //x2=60.06 //y2=2.095
r642 (  219 249 ) resistor r=45.1352 //w=0.168 //l=0.173853 //layer=ply \
 //thickness=0.18 //x=69.645 //y=1.39 //x2=69.605 //y2=1.545
r643 (  218 248 ) resistor r=45.1352 //w=0.168 //l=0.173853 //layer=ply \
 //thickness=0.18 //x=69.645 //y=1.045 //x2=69.605 //y2=0.89
r644 (  218 219 ) resistor r=176.904 //w=0.094 //l=0.345 //layer=ply \
 //thickness=0.18 //x=69.645 //y=1.045 //x2=69.645 //y2=1.39
r645 (  215 247 ) resistor r=68.2661 //w=0.233 //l=0.404166 //layer=ply \
 //thickness=0.18 //x=69.64 //y=5.05 //x2=69.31 //y2=4.885
r646 (  213 244 ) resistor r=10.701 //w=0.21 //l=0.115 //layer=ply \
 //thickness=0.18 //x=69.27 //y=1.545 //x2=69.155 //y2=1.545
r647 (  212 249 ) resistor r=5.52526 //w=0.168 //l=0.115 //layer=ply \
 //thickness=0.18 //x=69.49 //y=1.545 //x2=69.605 //y2=1.545
r648 (  211 243 ) resistor r=5.52526 //w=0.168 //l=0.115 //layer=ply \
 //thickness=0.18 //x=69.27 //y=0.89 //x2=69.155 //y2=0.89
r649 (  210 248 ) resistor r=5.52526 //w=0.168 //l=0.115 //layer=ply \
 //thickness=0.18 //x=69.49 //y=0.89 //x2=69.605 //y2=0.89
r650 (  210 211 ) resistor r=112.809 //w=0.094 //l=0.22 //layer=ply \
 //thickness=0.18 //x=69.49 //y=0.89 //x2=69.27 //y2=0.89
r651 (  207 245 ) resistor r=13.0941 //w=0.233 //l=0.165 //layer=ply \
 //thickness=0.18 //x=69.2 //y=5.05 //x2=69.2 //y2=4.885
r652 (  206 242 ) resistor r=34.8111 //w=0.27 //l=0.264953 //layer=ply \
 //thickness=0.18 //x=69.115 //y=2.095 //x2=69.31 //y2=2.26
r653 (  205 244 ) resistor r=39.5823 //w=0.21 //l=0.173853 //layer=ply \
 //thickness=0.18 //x=69.115 //y=1.7 //x2=69.155 //y2=1.545
r654 (  205 206 ) resistor r=202.543 //w=0.094 //l=0.395 //layer=ply \
 //thickness=0.18 //x=69.115 //y=1.7 //x2=69.115 //y2=2.095
r655 (  204 244 ) resistor r=39.5823 //w=0.21 //l=0.173853 //layer=ply \
 //thickness=0.18 //x=69.115 //y=1.39 //x2=69.155 //y2=1.545
r656 (  203 243 ) resistor r=45.1352 //w=0.168 //l=0.173853 //layer=ply \
 //thickness=0.18 //x=69.115 //y=1.045 //x2=69.155 //y2=0.89
r657 (  203 204 ) resistor r=176.904 //w=0.094 //l=0.345 //layer=ply \
 //thickness=0.18 //x=69.115 //y=1.045 //x2=69.115 //y2=1.39
r658 (  199 240 ) resistor r=45.1352 //w=0.168 //l=0.173853 //layer=ply \
 //thickness=0.18 //x=66.315 //y=1.39 //x2=66.275 //y2=1.545
r659 (  198 239 ) resistor r=45.1352 //w=0.168 //l=0.173853 //layer=ply \
 //thickness=0.18 //x=66.315 //y=1.045 //x2=66.275 //y2=0.89
r660 (  198 199 ) resistor r=176.904 //w=0.094 //l=0.345 //layer=ply \
 //thickness=0.18 //x=66.315 //y=1.045 //x2=66.315 //y2=1.39
r661 (  196 200 ) resistor r=26.9307 //w=0.15 //l=0.106066 //layer=ply \
 //thickness=0.18 //x=66.245 //y=4.975 //x2=66.32 //y2=5.05
r662 (  196 197 ) resistor r=148.702 //w=0.094 //l=0.29 //layer=ply \
 //thickness=0.18 //x=66.245 //y=4.975 //x2=65.955 //y2=4.975
r663 (  194 238 ) resistor r=10.701 //w=0.21 //l=0.115 //layer=ply \
 //thickness=0.18 //x=65.94 //y=1.545 //x2=65.825 //y2=1.545
r664 (  193 240 ) resistor r=5.52526 //w=0.168 //l=0.115 //layer=ply \
 //thickness=0.18 //x=66.16 //y=1.545 //x2=66.275 //y2=1.545
r665 (  192 237 ) resistor r=5.52526 //w=0.168 //l=0.115 //layer=ply \
 //thickness=0.18 //x=65.94 //y=0.89 //x2=65.825 //y2=0.89
r666 (  191 239 ) resistor r=5.52526 //w=0.168 //l=0.115 //layer=ply \
 //thickness=0.18 //x=66.16 //y=0.89 //x2=66.275 //y2=0.89
r667 (  191 192 ) resistor r=112.809 //w=0.094 //l=0.22 //layer=ply \
 //thickness=0.18 //x=66.16 //y=0.89 //x2=65.94 //y2=0.89
r668 (  188 197 ) resistor r=22.1787 //w=0.252 //l=0.106066 //layer=ply \
 //thickness=0.18 //x=65.88 //y=5.05 //x2=65.955 //y2=4.975
r669 (  188 236 ) resistor r=51.6429 //w=0.252 //l=0.34271 //layer=ply \
 //thickness=0.18 //x=65.88 //y=5.05 //x2=65.61 //y2=4.885
r670 (  187 234 ) resistor r=30.4513 //w=0.277 //l=0.243926 //layer=ply \
 //thickness=0.18 //x=65.785 //y=2.095 //x2=65.61 //y2=2.26
r671 (  186 238 ) resistor r=39.5823 //w=0.21 //l=0.173853 //layer=ply \
 //thickness=0.18 //x=65.785 //y=1.7 //x2=65.825 //y2=1.545
r672 (  186 187 ) resistor r=202.543 //w=0.094 //l=0.395 //layer=ply \
 //thickness=0.18 //x=65.785 //y=1.7 //x2=65.785 //y2=2.095
r673 (  185 238 ) resistor r=39.5823 //w=0.21 //l=0.173853 //layer=ply \
 //thickness=0.18 //x=65.785 //y=1.39 //x2=65.825 //y2=1.545
r674 (  184 237 ) resistor r=45.1352 //w=0.168 //l=0.173853 //layer=ply \
 //thickness=0.18 //x=65.785 //y=1.045 //x2=65.825 //y2=0.89
r675 (  184 185 ) resistor r=176.904 //w=0.094 //l=0.345 //layer=ply \
 //thickness=0.18 //x=65.785 //y=1.045 //x2=65.785 //y2=1.39
r676 (  183 232 ) resistor r=45.1352 //w=0.168 //l=0.173853 //layer=ply \
 //thickness=0.18 //x=60.625 //y=1.43 //x2=60.585 //y2=1.585
r677 (  182 231 ) resistor r=45.1352 //w=0.168 //l=0.173853 //layer=ply \
 //thickness=0.18 //x=60.625 //y=1.085 //x2=60.585 //y2=0.93
r678 (  182 183 ) resistor r=176.904 //w=0.094 //l=0.345 //layer=ply \
 //thickness=0.18 //x=60.625 //y=1.085 //x2=60.625 //y2=1.43
r679 (  177 230 ) resistor r=10.701 //w=0.21 //l=0.115 //layer=ply \
 //thickness=0.18 //x=60.25 //y=1.585 //x2=60.135 //y2=1.585
r680 (  176 232 ) resistor r=5.52526 //w=0.168 //l=0.115 //layer=ply \
 //thickness=0.18 //x=60.47 //y=1.585 //x2=60.585 //y2=1.585
r681 (  175 229 ) resistor r=5.52526 //w=0.168 //l=0.115 //layer=ply \
 //thickness=0.18 //x=60.25 //y=0.93 //x2=60.135 //y2=0.93
r682 (  174 231 ) resistor r=5.52526 //w=0.168 //l=0.115 //layer=ply \
 //thickness=0.18 //x=60.47 //y=0.93 //x2=60.585 //y2=0.93
r683 (  174 175 ) resistor r=112.809 //w=0.094 //l=0.22 //layer=ply \
 //thickness=0.18 //x=60.47 //y=0.93 //x2=60.25 //y2=0.93
r684 (  173 227 ) resistor r=16.5046 //w=0.27 //l=0.135 //layer=ply \
 //thickness=0.18 //x=60.225 //y=4.97 //x2=60.09 //y2=4.97
r685 (  172 179 ) resistor r=26.9307 //w=0.15 //l=0.106066 //layer=ply \
 //thickness=0.18 //x=60.465 //y=4.97 //x2=60.54 //y2=5.045
r686 (  172 173 ) resistor r=123.064 //w=0.094 //l=0.24 //layer=ply \
 //thickness=0.18 //x=60.465 //y=4.97 //x2=60.225 //y2=4.97
r687 (  167 230 ) resistor r=39.5823 //w=0.21 //l=0.173853 //layer=ply \
 //thickness=0.18 //x=60.095 //y=1.74 //x2=60.135 //y2=1.585
r688 (  167 222 ) resistor r=182.032 //w=0.094 //l=0.355 //layer=ply \
 //thickness=0.18 //x=60.095 //y=1.74 //x2=60.095 //y2=2.095
r689 (  166 230 ) resistor r=39.5823 //w=0.21 //l=0.173853 //layer=ply \
 //thickness=0.18 //x=60.095 //y=1.43 //x2=60.135 //y2=1.585
r690 (  165 229 ) resistor r=45.1352 //w=0.168 //l=0.173853 //layer=ply \
 //thickness=0.18 //x=60.095 //y=1.085 //x2=60.135 //y2=0.93
r691 (  165 166 ) resistor r=176.904 //w=0.094 //l=0.345 //layer=ply \
 //thickness=0.18 //x=60.095 //y=1.085 //x2=60.095 //y2=1.43
r692 (  164 215 ) resistor r=592.245 //w=0.094 //l=1.155 //layer=ply \
 //thickness=0.18 //x=69.64 //y=6.205 //x2=69.64 //y2=5.05
r693 (  163 207 ) resistor r=592.245 //w=0.094 //l=1.155 //layer=ply \
 //thickness=0.18 //x=69.2 //y=6.205 //x2=69.2 //y2=5.05
r694 (  162 200 ) resistor r=592.245 //w=0.094 //l=1.155 //layer=ply \
 //thickness=0.18 //x=66.32 //y=6.205 //x2=66.32 //y2=5.05
r695 (  161 188 ) resistor r=592.245 //w=0.094 //l=1.155 //layer=ply \
 //thickness=0.18 //x=65.88 //y=6.205 //x2=65.88 //y2=5.05
r696 (  160 179 ) resistor r=592.245 //w=0.094 //l=1.155 //layer=ply \
 //thickness=0.18 //x=60.54 //y=6.2 //x2=60.54 //y2=5.045
r697 (  159 228 ) resistor r=592.245 //w=0.094 //l=1.155 //layer=ply \
 //thickness=0.18 //x=60.1 //y=6.2 //x2=60.1 //y2=5.045
r698 (  158 212 ) resistor r=56.4043 //w=0.094 //l=0.11 //layer=ply \
 //thickness=0.18 //x=69.38 //y=1.545 //x2=69.49 //y2=1.545
r699 (  158 213 ) resistor r=56.4043 //w=0.094 //l=0.11 //layer=ply \
 //thickness=0.18 //x=69.38 //y=1.545 //x2=69.27 //y2=1.545
r700 (  157 193 ) resistor r=56.4043 //w=0.094 //l=0.11 //layer=ply \
 //thickness=0.18 //x=66.05 //y=1.545 //x2=66.16 //y2=1.545
r701 (  157 194 ) resistor r=56.4043 //w=0.094 //l=0.11 //layer=ply \
 //thickness=0.18 //x=66.05 //y=1.545 //x2=65.94 //y2=1.545
r702 (  156 176 ) resistor r=56.4043 //w=0.094 //l=0.11 //layer=ply \
 //thickness=0.18 //x=60.36 //y=1.585 //x2=60.47 //y2=1.585
r703 (  156 177 ) resistor r=56.4043 //w=0.094 //l=0.11 //layer=ply \
 //thickness=0.18 //x=60.36 //y=1.585 //x2=60.25 //y2=1.585
r704 (  154 247 ) resistor r=152 //w=0.17 //l=0.17 //layer=licon //count=1 \
 //x=69.31 //y=4.885 //x2=69.31 //y2=4.885
r705 (  151 154 ) resistor r=18.139 //w=0.187 //l=0.265 //layer=li \
 //thickness=0.1 //x=69.31 //y=4.62 //x2=69.31 //y2=4.885
r706 (  146 242 ) resistor r=152 //w=0.17 //l=0.17 //layer=licon //count=1 \
 //x=69.31 //y=2.26 //x2=69.31 //y2=2.26
r707 (  143 236 ) resistor r=152 //w=0.17 //l=0.17 //layer=licon //count=1 \
 //x=65.61 //y=4.885 //x2=65.61 //y2=4.885
r708 (  140 143 ) resistor r=18.139 //w=0.187 //l=0.265 //layer=li \
 //thickness=0.1 //x=65.61 //y=4.62 //x2=65.61 //y2=4.885
r709 (  131 234 ) resistor r=152 //w=0.17 //l=0.17 //layer=licon //count=1 \
 //x=65.61 //y=2.26 //x2=65.61 //y2=2.26
r710 (  114 253 ) resistor r=23.615 //w=0.187 //l=0.345 //layer=li \
 //thickness=0.1 //x=63.65 //y=5.56 //x2=63.65 //y2=5.905
r711 (  106 252 ) resistor r=23.615 //w=0.187 //l=0.345 //layer=li \
 //thickness=0.1 //x=62.77 //y=5.56 //x2=62.77 //y2=5.905
r712 (  101 225 ) resistor r=152 //w=0.17 //l=0.17 //layer=licon //count=1 \
 //x=60.09 //y=4.88 //x2=60.09 //y2=4.88
r713 (  92 221 ) resistor r=152 //w=0.17 //l=0.17 //layer=licon //count=1 \
 //x=60.06 //y=2.26 //x2=60.06 //y2=2.26
r714 (  88 89 ) resistor r=0.10734 //w=0.281 //l=0.16 //layer=m2 \
 //thickness=0.36 //x=69.315 //y=4.64 //x2=69.155 //y2=4.64
r715 (  81 82 ) resistor r=0.10734 //w=0.281 //l=0.16 //layer=m2 \
 //thickness=0.36 //x=65.605 //y=3.875 //x2=65.445 //y2=3.875
r716 (  75 77 ) resistor r=0.10734 //w=0.281 //l=0.16 //layer=m2 \
 //thickness=0.36 //x=60.065 //y=3.865 //x2=60.225 //y2=3.865
r717 (  73 85 ) resistor r=0.10734 //w=0.281 //l=0.16 //layer=m2 \
 //thickness=0.36 //x=65.775 //y=4.62 //x2=65.615 //y2=4.62
r718 (  73 89 ) resistor r=3.22519 //w=0.131 //l=3.38 //layer=m2 \
 //thickness=0.36 //x=65.775 //y=4.62 //x2=69.155 //y2=4.62
r719 (  71 79 ) resistor r=0.0941343 //w=0.24 //l=0.162481 //layer=m2 \
 //thickness=0.36 //x=64.295 //y=3.88 //x2=64.135 //y2=3.885
r720 (  71 82 ) resistor r=1.09733 //w=0.131 //l=1.15 //layer=m2 \
 //thickness=0.36 //x=64.295 //y=3.88 //x2=65.445 //y2=3.88
r721 (  68 79 ) resistor r=0.286843 //w=0.24 //l=0.539907 //layer=m2 \
 //thickness=0.36 //x=63.605 //y=3.865 //x2=64.135 //y2=3.885
r722 (  68 69 ) resistor r=0.410305 //w=0.131 //l=0.43 //layer=m2 \
 //thickness=0.36 //x=63.605 //y=3.865 //x2=63.175 //y2=3.865
r723 (  66 69 ) resistor r=0.125 //w=0.17 //l=0.177341 //layer=m2 \
 //thickness=0.36 //x=63.005 //y=3.88 //x2=63.175 //y2=3.865
r724 (  66 77 ) resistor r=2.65267 //w=0.131 //l=2.78 //layer=m2 \
 //thickness=0.36 //x=63.005 //y=3.88 //x2=60.225 //y2=3.88
r725 (  65 146 ) resistor r=9.3 //w=0.17 //l=0.17 //layer=mcon //count=1 \
 //x=69.31 //y=2.26 //x2=69.31 //y2=2.26
r726 (  63 88 ) resistor r=4.5 //w=0.15 //l=0.15 //layer=via1 //count=1 \
 //x=69.315 //y=4.64 //x2=69.315 //y2=4.64
r727 (  61 151 ) resistor r=9.3 //w=0.17 //l=0.17 //layer=mcon //count=1 \
 //x=69.31 //y=4.62 //x2=69.31 //y2=4.62
r728 (  61 63 ) resistor r=0.00659631 //w=0.379 //l=0.02 //layer=m1 \
 //thickness=0.36 //x=69.26 //y=4.62 //x2=69.26 //y2=4.64
r729 (  58 140 ) resistor r=9.3 //w=0.17 //l=0.17 //layer=mcon //count=1 \
 //x=65.61 //y=4.62 //x2=65.61 //y2=4.62
r730 (  58 85 ) resistor r=4.5 //w=0.15 //l=0.15 //layer=via1 //count=1 \
 //x=65.615 //y=4.62 //x2=65.615 //y2=4.62
r731 (  56 131 ) resistor r=9.3 //w=0.17 //l=0.17 //layer=mcon //count=1 \
 //x=65.61 //y=2.26 //x2=65.61 //y2=2.26
r732 (  52 81 ) resistor r=4.5 //w=0.15 //l=0.15 //layer=via1 //count=1 \
 //x=65.605 //y=3.875 //x2=65.605 //y2=3.875
r733 (  52 54 ) resistor r=0.00167112 //w=0.374 //l=0.005 //layer=m1 \
 //thickness=0.36 //x=65.555 //y=3.875 //x2=65.555 //y2=3.88
r734 (  50 79 ) resistor r=4.5 //w=0.15 //l=0.15 //layer=via1 //count=1 \
 //x=64.135 //y=3.885 //x2=64.135 //y2=3.885
r735 (  48 50 ) resistor r=0.00167112 //w=0.374 //l=0.005 //layer=m1 \
 //thickness=0.36 //x=64.185 //y=3.88 //x2=64.185 //y2=3.885
r736 (  45 250 ) resistor r=9.3 //w=0.17 //l=0.17 //layer=mcon //count=1 \
 //x=63.69 //y=1.18 //x2=63.69 //y2=1.18
r737 (  43 114 ) resistor r=9.3 //w=0.17 //l=0.17 //layer=mcon //count=1 \
 //x=63.65 //y=5.56 //x2=63.65 //y2=5.56
r738 (  40 43 ) resistor r=0.117801 //w=0.191 //l=0.18 //layer=m1 \
 //thickness=0.36 //x=63.65 //y=5.38 //x2=63.65 //y2=5.56
r739 (  39 106 ) resistor r=9.3 //w=0.17 //l=0.17 //layer=mcon //count=1 \
 //x=62.77 //y=5.56 //x2=62.77 //y2=5.56
r740 (  37 39 ) resistor r=0.10274 //w=0.219 //l=0.18 //layer=m1 \
 //thickness=0.36 //x=62.77 //y=5.38 //x2=62.77 //y2=5.56
r741 (  34 75 ) resistor r=4.5 //w=0.15 //l=0.15 //layer=via1 //count=1 \
 //x=60.065 //y=3.865 //x2=60.065 //y2=3.865
r742 (  34 36 ) resistor r=0.00501337 //w=0.374 //l=0.015 //layer=m1 \
 //thickness=0.36 //x=60.115 //y=3.865 //x2=60.115 //y2=3.88
r743 (  32 101 ) resistor r=9.3 //w=0.17 //l=0.17 //layer=mcon //count=1 \
 //x=60.09 //y=4.88 //x2=60.09 //y2=4.88
r744 (  28 92 ) resistor r=9.3 //w=0.17 //l=0.17 //layer=mcon //count=1 \
 //x=60.06 //y=2.26 //x2=60.06 //y2=2.26
r745 (  28 30 ) resistor r=0.0936408 //w=0.196 //l=0.125 //layer=m1 \
 //thickness=0.36 //x=60.062 //y=2.26 //x2=60.062 //y2=2.385
r746 (  26 61 ) resistor r=0.0863342 //w=0.379 //l=0.168152 //layer=m1 \
 //thickness=0.36 //x=69.31 //y=4.475 //x2=69.26 //y2=4.62
r747 (  25 65 ) resistor r=0.0761125 //w=0.237 //l=0.126491 //layer=m1 \
 //thickness=0.36 //x=69.31 //y=2.385 //x2=69.307 //y2=2.26
r748 (  25 26 ) resistor r=1.99427 //w=0.131 //l=2.09 //layer=m1 \
 //thickness=0.36 //x=69.31 //y=2.385 //x2=69.31 //y2=4.475
r749 (  24 58 ) resistor r=0.0898201 //w=0.322 //l=0.185472 //layer=m1 \
 //thickness=0.36 //x=65.61 //y=4.46 //x2=65.665 //y2=4.62
r750 (  23 54 ) resistor r=0.089409 //w=0.374 //l=0.180416 //layer=m1 \
 //thickness=0.36 //x=65.61 //y=4.035 //x2=65.555 //y2=3.88
r751 (  23 24 ) resistor r=0.405534 //w=0.131 //l=0.425 //layer=m1 \
 //thickness=0.36 //x=65.61 //y=4.035 //x2=65.61 //y2=4.46
r752 (  22 52 ) resistor r=0.0910802 //w=0.374 //l=0.185472 //layer=m1 \
 //thickness=0.36 //x=65.61 //y=3.715 //x2=65.555 //y2=3.875
r753 (  21 56 ) resistor r=0.0717383 //w=0.224 //l=0.115 //layer=m1 \
 //thickness=0.36 //x=65.61 //y=2.375 //x2=65.61 //y2=2.26
r754 (  21 22 ) resistor r=1.27863 //w=0.131 //l=1.34 //layer=m1 \
 //thickness=0.36 //x=65.61 //y=2.375 //x2=65.61 //y2=3.715
r755 (  19 50 ) resistor r=0.0910802 //w=0.374 //l=0.185472 //layer=m1 \
 //thickness=0.36 //x=64.13 //y=4.045 //x2=64.185 //y2=3.885
r756 (  19 20 ) resistor r=1.19275 //w=0.131 //l=1.25 //layer=m1 \
 //thickness=0.36 //x=64.13 //y=4.045 //x2=64.13 //y2=5.295
r757 (  18 48 ) resistor r=0.089409 //w=0.374 //l=0.180416 //layer=m1 \
 //thickness=0.36 //x=64.13 //y=3.725 //x2=64.185 //y2=3.88
r758 (  17 18 ) resistor r=1.72233 //w=0.131 //l=1.805 //layer=m1 \
 //thickness=0.36 //x=64.13 //y=1.92 //x2=64.13 //y2=3.725
r759 (  15 17 ) resistor r=0.0698411 //w=0.17 //l=0.120208 //layer=m1 \
 //thickness=0.36 //x=64.045 //y=1.835 //x2=64.13 //y2=1.92
r760 (  15 16 ) resistor r=0.257634 //w=0.131 //l=0.27 //layer=m1 \
 //thickness=0.36 //x=64.045 //y=1.835 //x2=63.775 //y2=1.835
r761 (  14 40 ) resistor r=0.0257089 //w=0.23 //l=0.115 //layer=m1 \
 //thickness=0.36 //x=63.765 //y=5.38 //x2=63.65 //y2=5.38
r762 (  13 20 ) resistor r=0.0698411 //w=0.17 //l=0.120208 //layer=m1 \
 //thickness=0.36 //x=64.045 //y=5.38 //x2=64.13 //y2=5.295
r763 (  13 14 ) resistor r=0.267176 //w=0.131 //l=0.28 //layer=m1 \
 //thickness=0.36 //x=64.045 //y=5.38 //x2=63.765 //y2=5.38
r764 (  12 16 ) resistor r=0.0698411 //w=0.17 //l=0.120208 //layer=m1 \
 //thickness=0.36 //x=63.69 //y=1.75 //x2=63.775 //y2=1.835
r765 (  11 45 ) resistor r=0.0913624 //w=0.191 //l=0.12 //layer=m1 \
 //thickness=0.36 //x=63.69 //y=1.3 //x2=63.69 //y2=1.18
r766 (  11 12 ) resistor r=0.429389 //w=0.131 //l=0.45 //layer=m1 \
 //thickness=0.36 //x=63.69 //y=1.3 //x2=63.69 //y2=1.75
r767 (  8 37 ) resistor r=0.0227762 //w=0.219 //l=0.115 //layer=m1 \
 //thickness=0.36 //x=62.885 //y=5.38 //x2=62.77 //y2=5.38
r768 (  7 40 ) resistor r=0.0257089 //w=0.23 //l=0.115 //layer=m1 \
 //thickness=0.36 //x=63.535 //y=5.38 //x2=63.65 //y2=5.38
r769 (  7 8 ) resistor r=0.620229 //w=0.131 //l=0.65 //layer=m1 \
 //thickness=0.36 //x=63.535 //y=5.38 //x2=62.885 //y2=5.38
r770 (  4 32 ) resistor r=0.0878548 //w=0.228 //l=0.159295 //layer=m1 \
 //thickness=0.36 //x=60.06 //y=4.735 //x2=60.09 //y2=4.88
r771 (  3 36 ) resistor r=0.0860668 //w=0.374 //l=0.170294 //layer=m1 \
 //thickness=0.36 //x=60.06 //y=4.025 //x2=60.115 //y2=3.88
r772 (  3 4 ) resistor r=0.677481 //w=0.131 //l=0.71 //layer=m1 \
 //thickness=0.36 //x=60.06 //y=4.025 //x2=60.06 //y2=4.735
r773 (  2 34 ) resistor r=0.0910802 //w=0.374 //l=0.185472 //layer=m1 \
 //thickness=0.36 //x=60.06 //y=3.705 //x2=60.115 //y2=3.865
r774 (  2 30 ) resistor r=1.25954 //w=0.131 //l=1.32 //layer=m1 \
 //thickness=0.36 //x=60.06 //y=3.705 //x2=60.06 //y2=2.385
ends PM_TMRDFFQNX1\%noxref_18

subckt PM_TMRDFFQNX1\%noxref_19 ( 1 2 3 4 5 6 7 8 9 10 26 30 35 40 45 52 54 55 \
 58 63 68 77 82 91 95 96 97 98 99 100 101 102 103 104 105 106 111 113 115 121 \
 122 123 124 125 130 132 134 140 141 142 143 144 149 151 153 159 160 162 163 \
 166 175 176 179 187 188 191 )
c575 ( 191 0 ) capacitor c=0.0370698f //x=73.4 //y=4.885
c576 ( 188 0 ) capacitor c=0.030265f //x=73.38 //y=2.095
c577 ( 187 0 ) capacitor c=0.0512002f //x=73.38 //y=2.26
c578 ( 179 0 ) capacitor c=0.0387879f //x=66.76 //y=4.885
c579 ( 176 0 ) capacitor c=0.0300885f //x=66.72 //y=2.095
c580 ( 175 0 ) capacitor c=0.0506604f //x=66.72 //y=2.26
c581 ( 166 0 ) capacitor c=0.0393541f //x=38.63 //y=4.88
c582 ( 163 0 ) capacitor c=0.0284095f //x=38.6 //y=2.095
c583 ( 162 0 ) capacitor c=0.0451185f //x=38.6 //y=2.26
c584 ( 160 0 ) capacitor c=0.0237734f //x=73.945 //y=1.435
c585 ( 159 0 ) capacitor c=0.0191782f //x=73.945 //y=1.085
c586 ( 153 0 ) capacitor c=0.0361171f //x=73.79 //y=1.585
c587 ( 151 0 ) capacitor c=0.0157803f //x=73.79 //y=0.93
c588 ( 149 0 ) capacitor c=0.0376354f //x=73.785 //y=4.975
c589 ( 144 0 ) capacitor c=0.020493f //x=73.415 //y=1.74
c590 ( 143 0 ) capacitor c=0.0167049f //x=73.415 //y=1.435
c591 ( 142 0 ) capacitor c=0.0174993f //x=73.415 //y=1.085
c592 ( 141 0 ) capacitor c=0.0443648f //x=67.285 //y=1.43
c593 ( 140 0 ) capacitor c=0.0192211f //x=67.285 //y=1.085
c594 ( 134 0 ) capacitor c=0.0186579f //x=67.13 //y=1.585
c595 ( 132 0 ) capacitor c=0.0157795f //x=67.13 //y=0.93
c596 ( 130 0 ) capacitor c=0.0351351f //x=67.125 //y=4.975
c597 ( 125 0 ) capacitor c=0.0209124f //x=66.755 //y=1.74
c598 ( 124 0 ) capacitor c=0.016848f //x=66.755 //y=1.43
c599 ( 123 0 ) capacitor c=0.0174777f //x=66.755 //y=1.085
c600 ( 122 0 ) capacitor c=0.0439708f //x=39.165 //y=1.43
c601 ( 121 0 ) capacitor c=0.0192582f //x=39.165 //y=1.085
c602 ( 115 0 ) capacitor c=0.0162526f //x=39.01 //y=1.585
c603 ( 113 0 ) capacitor c=0.0157807f //x=39.01 //y=0.93
c604 ( 111 0 ) capacitor c=0.0372668f //x=39.005 //y=4.97
c605 ( 106 0 ) capacitor c=0.0210762f //x=38.635 //y=1.74
c606 ( 105 0 ) capacitor c=0.0168511f //x=38.635 //y=1.43
c607 ( 104 0 ) capacitor c=0.0175485f //x=38.635 //y=1.085
c608 ( 103 0 ) capacitor c=0.155887f //x=73.86 //y=6.205
c609 ( 102 0 ) capacitor c=0.1106f //x=73.42 //y=6.205
c610 ( 101 0 ) capacitor c=0.154859f //x=67.2 //y=6.205
c611 ( 100 0 ) capacitor c=0.110573f //x=66.76 //y=6.205
c612 ( 99 0 ) capacitor c=0.155269f //x=39.08 //y=6.2
c613 ( 98 0 ) capacitor c=0.110375f //x=38.64 //y=6.2
c614 ( 91 0 ) capacitor c=8.10734e-19 //x=73.4 //y=4.885
c615 ( 82 0 ) capacitor c=0.00105273f //x=73.38 //y=2.26
c616 ( 77 0 ) capacitor c=0.00173056f //x=66.76 //y=4.885
c617 ( 68 0 ) capacitor c=0.00152737f //x=66.72 //y=2.26
c618 ( 63 0 ) capacitor c=8.90417e-19 //x=38.63 //y=4.88
c619 ( 58 0 ) capacitor c=7.72439e-19 //x=38.6 //y=2.26
c620 ( 55 0 ) capacitor c=0.147351f //x=73.235 //y=4.21
c621 ( 54 0 ) capacitor c=0.00479868f //x=73.395 //y=4.21
c622 ( 52 0 ) capacitor c=0.00305949f //x=66.88 //y=4.205
c623 ( 45 0 ) capacitor c=0.00555957f //x=66.72 //y=2.325
c624 ( 40 0 ) capacitor c=0.0057541f //x=38.585 //y=2.325
c625 ( 35 0 ) capacitor c=0.659681f //x=66.56 //y=2.4
c626 ( 30 0 ) capacitor c=0.0148587f //x=73.38 //y=4.25
c627 ( 26 0 ) capacitor c=0.0166522f //x=66.72 //y=4.25
c628 ( 10 0 ) capacitor c=0.0124358f //x=73.38 //y=4.74
c629 ( 9 0 ) capacitor c=0.0110536f //x=73.38 //y=4.37
c630 ( 8 0 ) capacitor c=0.0479887f //x=73.38 //y=4.05
c631 ( 7 0 ) capacitor c=0.00651439f //x=73.38 //y=2.38
c632 ( 6 0 ) capacitor c=0.0169891f //x=66.72 //y=4.71
c633 ( 5 0 ) capacitor c=0.0128079f //x=66.72 //y=4.365
c634 ( 4 0 ) capacitor c=0.0585918f //x=66.72 //y=4.045
c635 ( 3 0 ) capacitor c=0.0128954f //x=66.72 //y=2.485
c636 ( 2 0 ) capacitor c=0.0522941f //x=38.6 //y=4.735
c637 ( 1 0 ) capacitor c=0.010091f //x=38.6 //y=2.485
r638 (  193 194 ) resistor r=32.4568 //w=0.214 //l=0.075 //layer=ply \
 //thickness=0.18 //x=73.4 //y=4.975 //x2=73.4 //y2=5.05
r639 (  191 193 ) resistor r=20.271 //w=0.214 //l=0.09 //layer=ply \
 //thickness=0.18 //x=73.4 //y=4.885 //x2=73.4 //y2=4.975
r640 (  187 188 ) resistor r=52.7279 //w=0.214 //l=0.165 //layer=ply \
 //thickness=0.18 //x=73.38 //y=2.26 //x2=73.38 //y2=2.095
r641 (  179 181 ) resistor r=20.271 //w=0.214 //l=0.09 //layer=ply \
 //thickness=0.18 //x=66.76 //y=4.885 //x2=66.76 //y2=4.975
r642 (  175 176 ) resistor r=52.7279 //w=0.214 //l=0.165 //layer=ply \
 //thickness=0.18 //x=66.72 //y=2.26 //x2=66.72 //y2=2.095
r643 (  168 169 ) resistor r=32.4568 //w=0.214 //l=0.075 //layer=ply \
 //thickness=0.18 //x=38.63 //y=4.97 //x2=38.63 //y2=5.045
r644 (  166 168 ) resistor r=20.271 //w=0.214 //l=0.09 //layer=ply \
 //thickness=0.18 //x=38.63 //y=4.88 //x2=38.63 //y2=4.97
r645 (  162 163 ) resistor r=52.7279 //w=0.214 //l=0.165 //layer=ply \
 //thickness=0.18 //x=38.6 //y=2.26 //x2=38.6 //y2=2.095
r646 (  160 198 ) resistor r=4.95774 //w=0.164 //l=0.112 //layer=ply \
 //thickness=0.18 //x=73.945 //y=1.435 //x2=73.945 //y2=1.547
r647 (  159 197 ) resistor r=45.1352 //w=0.168 //l=0.173853 //layer=ply \
 //thickness=0.18 //x=73.945 //y=1.085 //x2=73.905 //y2=0.93
r648 (  159 160 ) resistor r=179.468 //w=0.094 //l=0.35 //layer=ply \
 //thickness=0.18 //x=73.945 //y=1.085 //x2=73.945 //y2=1.435
r649 (  154 196 ) resistor r=10.8103 //w=0.211 //l=0.115 //layer=ply \
 //thickness=0.18 //x=73.57 //y=1.585 //x2=73.455 //y2=1.585
r650 (  153 198 ) resistor r=45.9962 //w=0.164 //l=0.17296 //layer=ply \
 //thickness=0.18 //x=73.79 //y=1.585 //x2=73.945 //y2=1.547
r651 (  152 195 ) resistor r=5.52526 //w=0.168 //l=0.115 //layer=ply \
 //thickness=0.18 //x=73.57 //y=0.93 //x2=73.455 //y2=0.93
r652 (  151 197 ) resistor r=5.52526 //w=0.168 //l=0.115 //layer=ply \
 //thickness=0.18 //x=73.79 //y=0.93 //x2=73.905 //y2=0.93
r653 (  151 152 ) resistor r=112.809 //w=0.094 //l=0.22 //layer=ply \
 //thickness=0.18 //x=73.79 //y=0.93 //x2=73.57 //y2=0.93
r654 (  150 193 ) resistor r=16.5046 //w=0.27 //l=0.135 //layer=ply \
 //thickness=0.18 //x=73.535 //y=4.975 //x2=73.4 //y2=4.975
r655 (  149 156 ) resistor r=26.9307 //w=0.15 //l=0.106066 //layer=ply \
 //thickness=0.18 //x=73.785 //y=4.975 //x2=73.86 //y2=5.05
r656 (  149 150 ) resistor r=128.191 //w=0.094 //l=0.25 //layer=ply \
 //thickness=0.18 //x=73.785 //y=4.975 //x2=73.535 //y2=4.975
r657 (  144 196 ) resistor r=39.5036 //w=0.211 //l=0.173853 //layer=ply \
 //thickness=0.18 //x=73.415 //y=1.74 //x2=73.455 //y2=1.585
r658 (  144 188 ) resistor r=182.032 //w=0.094 //l=0.355 //layer=ply \
 //thickness=0.18 //x=73.415 //y=1.74 //x2=73.415 //y2=2.095
r659 (  143 196 ) resistor r=38.3614 //w=0.211 //l=0.168819 //layer=ply \
 //thickness=0.18 //x=73.415 //y=1.435 //x2=73.455 //y2=1.585
r660 (  142 195 ) resistor r=45.1352 //w=0.168 //l=0.173853 //layer=ply \
 //thickness=0.18 //x=73.415 //y=1.085 //x2=73.455 //y2=0.93
r661 (  142 143 ) resistor r=179.468 //w=0.094 //l=0.35 //layer=ply \
 //thickness=0.18 //x=73.415 //y=1.085 //x2=73.415 //y2=1.435
r662 (  141 185 ) resistor r=45.1352 //w=0.168 //l=0.173853 //layer=ply \
 //thickness=0.18 //x=67.285 //y=1.43 //x2=67.245 //y2=1.585
r663 (  140 184 ) resistor r=45.1352 //w=0.168 //l=0.173853 //layer=ply \
 //thickness=0.18 //x=67.285 //y=1.085 //x2=67.245 //y2=0.93
r664 (  140 141 ) resistor r=176.904 //w=0.094 //l=0.345 //layer=ply \
 //thickness=0.18 //x=67.285 //y=1.085 //x2=67.285 //y2=1.43
r665 (  135 183 ) resistor r=10.701 //w=0.21 //l=0.115 //layer=ply \
 //thickness=0.18 //x=66.91 //y=1.585 //x2=66.795 //y2=1.585
r666 (  134 185 ) resistor r=5.52526 //w=0.168 //l=0.115 //layer=ply \
 //thickness=0.18 //x=67.13 //y=1.585 //x2=67.245 //y2=1.585
r667 (  133 182 ) resistor r=5.52526 //w=0.168 //l=0.115 //layer=ply \
 //thickness=0.18 //x=66.91 //y=0.93 //x2=66.795 //y2=0.93
r668 (  132 184 ) resistor r=5.52526 //w=0.168 //l=0.115 //layer=ply \
 //thickness=0.18 //x=67.13 //y=0.93 //x2=67.245 //y2=0.93
r669 (  132 133 ) resistor r=112.809 //w=0.094 //l=0.22 //layer=ply \
 //thickness=0.18 //x=67.13 //y=0.93 //x2=66.91 //y2=0.93
r670 (  131 181 ) resistor r=16.5046 //w=0.27 //l=0.135 //layer=ply \
 //thickness=0.18 //x=66.895 //y=4.975 //x2=66.76 //y2=4.975
r671 (  130 137 ) resistor r=26.9307 //w=0.15 //l=0.106066 //layer=ply \
 //thickness=0.18 //x=67.125 //y=4.975 //x2=67.2 //y2=5.05
r672 (  130 131 ) resistor r=117.936 //w=0.094 //l=0.23 //layer=ply \
 //thickness=0.18 //x=67.125 //y=4.975 //x2=66.895 //y2=4.975
r673 (  127 181 ) resistor r=32.4568 //w=0.214 //l=0.075 //layer=ply \
 //thickness=0.18 //x=66.76 //y=5.05 //x2=66.76 //y2=4.975
r674 (  125 183 ) resistor r=39.5823 //w=0.21 //l=0.173853 //layer=ply \
 //thickness=0.18 //x=66.755 //y=1.74 //x2=66.795 //y2=1.585
r675 (  125 176 ) resistor r=182.032 //w=0.094 //l=0.355 //layer=ply \
 //thickness=0.18 //x=66.755 //y=1.74 //x2=66.755 //y2=2.095
r676 (  124 183 ) resistor r=39.5823 //w=0.21 //l=0.173853 //layer=ply \
 //thickness=0.18 //x=66.755 //y=1.43 //x2=66.795 //y2=1.585
r677 (  123 182 ) resistor r=45.1352 //w=0.168 //l=0.173853 //layer=ply \
 //thickness=0.18 //x=66.755 //y=1.085 //x2=66.795 //y2=0.93
r678 (  123 124 ) resistor r=176.904 //w=0.094 //l=0.345 //layer=ply \
 //thickness=0.18 //x=66.755 //y=1.085 //x2=66.755 //y2=1.43
r679 (  122 173 ) resistor r=45.1352 //w=0.168 //l=0.173853 //layer=ply \
 //thickness=0.18 //x=39.165 //y=1.43 //x2=39.125 //y2=1.585
r680 (  121 172 ) resistor r=45.1352 //w=0.168 //l=0.173853 //layer=ply \
 //thickness=0.18 //x=39.165 //y=1.085 //x2=39.125 //y2=0.93
r681 (  121 122 ) resistor r=176.904 //w=0.094 //l=0.345 //layer=ply \
 //thickness=0.18 //x=39.165 //y=1.085 //x2=39.165 //y2=1.43
r682 (  116 171 ) resistor r=10.701 //w=0.21 //l=0.115 //layer=ply \
 //thickness=0.18 //x=38.79 //y=1.585 //x2=38.675 //y2=1.585
r683 (  115 173 ) resistor r=5.52526 //w=0.168 //l=0.115 //layer=ply \
 //thickness=0.18 //x=39.01 //y=1.585 //x2=39.125 //y2=1.585
r684 (  114 170 ) resistor r=5.52526 //w=0.168 //l=0.115 //layer=ply \
 //thickness=0.18 //x=38.79 //y=0.93 //x2=38.675 //y2=0.93
r685 (  113 172 ) resistor r=5.52526 //w=0.168 //l=0.115 //layer=ply \
 //thickness=0.18 //x=39.01 //y=0.93 //x2=39.125 //y2=0.93
r686 (  113 114 ) resistor r=112.809 //w=0.094 //l=0.22 //layer=ply \
 //thickness=0.18 //x=39.01 //y=0.93 //x2=38.79 //y2=0.93
r687 (  112 168 ) resistor r=16.5046 //w=0.27 //l=0.135 //layer=ply \
 //thickness=0.18 //x=38.765 //y=4.97 //x2=38.63 //y2=4.97
r688 (  111 118 ) resistor r=26.9307 //w=0.15 //l=0.106066 //layer=ply \
 //thickness=0.18 //x=39.005 //y=4.97 //x2=39.08 //y2=5.045
r689 (  111 112 ) resistor r=123.064 //w=0.094 //l=0.24 //layer=ply \
 //thickness=0.18 //x=39.005 //y=4.97 //x2=38.765 //y2=4.97
r690 (  106 171 ) resistor r=39.5823 //w=0.21 //l=0.173853 //layer=ply \
 //thickness=0.18 //x=38.635 //y=1.74 //x2=38.675 //y2=1.585
r691 (  106 163 ) resistor r=182.032 //w=0.094 //l=0.355 //layer=ply \
 //thickness=0.18 //x=38.635 //y=1.74 //x2=38.635 //y2=2.095
r692 (  105 171 ) resistor r=39.5823 //w=0.21 //l=0.173853 //layer=ply \
 //thickness=0.18 //x=38.635 //y=1.43 //x2=38.675 //y2=1.585
r693 (  104 170 ) resistor r=45.1352 //w=0.168 //l=0.173853 //layer=ply \
 //thickness=0.18 //x=38.635 //y=1.085 //x2=38.675 //y2=0.93
r694 (  104 105 ) resistor r=176.904 //w=0.094 //l=0.345 //layer=ply \
 //thickness=0.18 //x=38.635 //y=1.085 //x2=38.635 //y2=1.43
r695 (  103 156 ) resistor r=592.245 //w=0.094 //l=1.155 //layer=ply \
 //thickness=0.18 //x=73.86 //y=6.205 //x2=73.86 //y2=5.05
r696 (  102 194 ) resistor r=592.245 //w=0.094 //l=1.155 //layer=ply \
 //thickness=0.18 //x=73.42 //y=6.205 //x2=73.42 //y2=5.05
r697 (  101 137 ) resistor r=592.245 //w=0.094 //l=1.155 //layer=ply \
 //thickness=0.18 //x=67.2 //y=6.205 //x2=67.2 //y2=5.05
r698 (  100 127 ) resistor r=592.245 //w=0.094 //l=1.155 //layer=ply \
 //thickness=0.18 //x=66.76 //y=6.205 //x2=66.76 //y2=5.05
r699 (  99 118 ) resistor r=592.245 //w=0.094 //l=1.155 //layer=ply \
 //thickness=0.18 //x=39.08 //y=6.2 //x2=39.08 //y2=5.045
r700 (  98 169 ) resistor r=592.245 //w=0.094 //l=1.155 //layer=ply \
 //thickness=0.18 //x=38.64 //y=6.2 //x2=38.64 //y2=5.045
r701 (  97 153 ) resistor r=56.4043 //w=0.094 //l=0.11 //layer=ply \
 //thickness=0.18 //x=73.68 //y=1.585 //x2=73.79 //y2=1.585
r702 (  97 154 ) resistor r=56.4043 //w=0.094 //l=0.11 //layer=ply \
 //thickness=0.18 //x=73.68 //y=1.585 //x2=73.57 //y2=1.585
r703 (  96 134 ) resistor r=56.4043 //w=0.094 //l=0.11 //layer=ply \
 //thickness=0.18 //x=67.02 //y=1.585 //x2=67.13 //y2=1.585
r704 (  96 135 ) resistor r=56.4043 //w=0.094 //l=0.11 //layer=ply \
 //thickness=0.18 //x=67.02 //y=1.585 //x2=66.91 //y2=1.585
r705 (  95 115 ) resistor r=56.4043 //w=0.094 //l=0.11 //layer=ply \
 //thickness=0.18 //x=38.9 //y=1.585 //x2=39.01 //y2=1.585
r706 (  95 116 ) resistor r=56.4043 //w=0.094 //l=0.11 //layer=ply \
 //thickness=0.18 //x=38.9 //y=1.585 //x2=38.79 //y2=1.585
r707 (  91 191 ) resistor r=152 //w=0.17 //l=0.17 //layer=licon //count=1 \
 //x=73.4 //y=4.885 //x2=73.4 //y2=4.885
r708 (  82 187 ) resistor r=152 //w=0.17 //l=0.17 //layer=licon //count=1 \
 //x=73.38 //y=2.26 //x2=73.38 //y2=2.26
r709 (  77 179 ) resistor r=152 //w=0.17 //l=0.17 //layer=licon //count=1 \
 //x=66.76 //y=4.885 //x2=66.76 //y2=4.885
r710 (  68 175 ) resistor r=152 //w=0.17 //l=0.17 //layer=licon //count=1 \
 //x=66.72 //y=2.26 //x2=66.72 //y2=2.26
r711 (  63 166 ) resistor r=152 //w=0.17 //l=0.17 //layer=licon //count=1 \
 //x=38.63 //y=4.88 //x2=38.63 //y2=4.88
r712 (  58 162 ) resistor r=152 //w=0.17 //l=0.17 //layer=licon //count=1 \
 //x=38.6 //y=2.26 //x2=38.6 //y2=2.26
r713 (  54 55 ) resistor r=0.104807 //w=0.281 //l=0.16 //layer=m2 \
 //thickness=0.36 //x=73.395 //y=4.21 //x2=73.235 //y2=4.21
r714 (  52 55 ) resistor r=5.84099 //w=0.136 //l=6.355 //layer=m2 \
 //thickness=0.36 //x=66.88 //y=4.252 //x2=73.235 //y2=4.252
r715 (  50 52 ) resistor r=0.104807 //w=0.281 //l=0.16 //layer=m2 \
 //thickness=0.36 //x=66.72 //y=4.205 //x2=66.88 //y2=4.205
r716 (  45 47 ) resistor r=0.033363 //w=0.281 //l=0.075 //layer=m2 \
 //thickness=0.36 //x=66.72 //y=2.325 //x2=66.72 //y2=2.4
r717 (  40 42 ) resistor r=0.033363 //w=0.281 //l=0.075 //layer=m2 \
 //thickness=0.36 //x=38.585 //y=2.325 //x2=38.585 //y2=2.4
r718 (  36 42 ) resistor r=0.0455071 //w=0.32 //l=0.16 //layer=m2 \
 //thickness=0.36 //x=38.745 //y=2.4 //x2=38.585 //y2=2.4
r719 (  35 47 ) resistor r=0.0455071 //w=0.32 //l=0.16 //layer=m2 \
 //thickness=0.36 //x=66.56 //y=2.4 //x2=66.72 //y2=2.4
r720 (  35 36 ) resistor r=26.541 //w=0.131 //l=27.815 //layer=m2 \
 //thickness=0.36 //x=66.56 //y=2.4 //x2=38.745 //y2=2.4
r721 (  34 91 ) resistor r=9.3 //w=0.17 //l=0.17 //layer=mcon //count=1 \
 //x=73.4 //y=4.885 //x2=73.4 //y2=4.885
r722 (  32 82 ) resistor r=9.3 //w=0.17 //l=0.17 //layer=mcon //count=1 \
 //x=73.38 //y=2.26 //x2=73.38 //y2=2.26
r723 (  28 54 ) resistor r=4.5 //w=0.15 //l=0.15 //layer=via1 //count=1 \
 //x=73.395 //y=4.21 //x2=73.395 //y2=4.21
r724 (  28 30 ) resistor r=0.0130208 //w=0.384 //l=0.04 //layer=m1 \
 //thickness=0.36 //x=73.335 //y=4.21 //x2=73.335 //y2=4.25
r725 (  24 50 ) resistor r=4.5 //w=0.15 //l=0.15 //layer=via1 //count=1 \
 //x=66.72 //y=4.205 //x2=66.72 //y2=4.205
r726 (  24 26 ) resistor r=0.0149601 //w=0.376 //l=0.045 //layer=m1 \
 //thickness=0.36 //x=66.772 //y=4.205 //x2=66.772 //y2=4.25
r727 (  22 77 ) resistor r=9.3 //w=0.17 //l=0.17 //layer=mcon //count=1 \
 //x=66.76 //y=4.885 //x2=66.76 //y2=4.885
r728 (  20 45 ) resistor r=4.5 //w=0.15 //l=0.15 //layer=via1 //count=1 \
 //x=66.72 //y=2.325 //x2=66.72 //y2=2.325
r729 (  18 68 ) resistor r=9.3 //w=0.17 //l=0.17 //layer=mcon //count=1 \
 //x=66.72 //y=2.26 //x2=66.72 //y2=2.26
r730 (  18 20 ) resistor r=0.0268152 //w=0.303 //l=0.065 //layer=m1 \
 //thickness=0.36 //x=66.72 //y=2.26 //x2=66.72 //y2=2.325
r731 (  16 63 ) resistor r=9.3 //w=0.17 //l=0.17 //layer=mcon //count=1 \
 //x=38.63 //y=4.88 //x2=38.63 //y2=4.88
r732 (  14 40 ) resistor r=4.5 //w=0.15 //l=0.15 //layer=via1 //count=1 \
 //x=38.585 //y=2.325 //x2=38.585 //y2=2.325
r733 (  12 58 ) resistor r=9.3 //w=0.17 //l=0.17 //layer=mcon //count=1 \
 //x=38.6 //y=2.26 //x2=38.6 //y2=2.26
r734 (  12 14 ) resistor r=0.0262945 //w=0.309 //l=0.065 //layer=m1 \
 //thickness=0.36 //x=38.585 //y=2.26 //x2=38.585 //y2=2.325
r735 (  10 34 ) resistor r=0.0893515 //w=0.219 //l=0.154677 //layer=m1 \
 //thickness=0.36 //x=73.38 //y=4.74 //x2=73.4 //y2=4.885
r736 (  9 30 ) resistor r=0.0784723 //w=0.384 //l=0.140712 //layer=m1 \
 //thickness=0.36 //x=73.38 //y=4.37 //x2=73.335 //y2=4.25
r737 (  9 10 ) resistor r=0.353053 //w=0.131 //l=0.37 //layer=m1 \
 //thickness=0.36 //x=73.38 //y=4.37 //x2=73.38 //y2=4.74
r738 (  8 28 ) resistor r=0.0914932 //w=0.384 //l=0.181108 //layer=m1 \
 //thickness=0.36 //x=73.38 //y=4.05 //x2=73.335 //y2=4.21
r739 (  7 32 ) resistor r=0.0744285 //w=0.225 //l=0.12 //layer=m1 \
 //thickness=0.36 //x=73.38 //y=2.38 //x2=73.38 //y2=2.26
r740 (  7 8 ) resistor r=1.59351 //w=0.131 //l=1.67 //layer=m1 \
 //thickness=0.36 //x=73.38 //y=2.38 //x2=73.38 //y2=4.05
r741 (  6 22 ) resistor r=0.100665 //w=0.248 //l=0.193972 //layer=m1 \
 //thickness=0.36 //x=66.72 //y=4.71 //x2=66.76 //y2=4.885
r742 (  5 26 ) resistor r=0.0761992 //w=0.376 //l=0.138582 //layer=m1 \
 //thickness=0.36 //x=66.72 //y=4.365 //x2=66.772 //y2=4.25
r743 (  5 6 ) resistor r=0.329198 //w=0.131 //l=0.345 //layer=m1 \
 //thickness=0.36 //x=66.72 //y=4.365 //x2=66.72 //y2=4.71
r744 (  4 24 ) resistor r=0.0911593 //w=0.376 //l=0.184174 //layer=m1 \
 //thickness=0.36 //x=66.72 //y=4.045 //x2=66.772 //y2=4.205
r745 (  3 20 ) resistor r=0.0898969 //w=0.303 //l=0.16 //layer=m1 \
 //thickness=0.36 //x=66.72 //y=2.485 //x2=66.72 //y2=2.325
r746 (  3 4 ) resistor r=1.48855 //w=0.131 //l=1.56 //layer=m1 \
 //thickness=0.36 //x=66.72 //y=2.485 //x2=66.72 //y2=4.045
r747 (  2 16 ) resistor r=0.0878548 //w=0.228 //l=0.159295 //layer=m1 \
 //thickness=0.36 //x=38.6 //y=4.735 //x2=38.63 //y2=4.88
r748 (  1 14 ) resistor r=0.0898315 //w=0.309 //l=0.167332 //layer=m1 \
 //thickness=0.36 //x=38.6 //y=2.485 //x2=38.585 //y2=2.325
r749 (  1 2 ) resistor r=2.14695 //w=0.131 //l=2.25 //layer=m1 \
 //thickness=0.36 //x=38.6 //y=2.485 //x2=38.6 //y2=4.735
ends PM_TMRDFFQNX1\%noxref_19

subckt PM_TMRDFFQNX1\%noxref_20 ( 2 3 4 7 12 13 15 16 18 19 20 21 22 23 24 25 \
 26 28 34 39 40 43 45 48 52 66 68 69 70 72 74 76 78 80 82 84 86 88 90 92 94 96 \
 98 100 102 104 111 119 121 122 125 134 139 147 164 173 178 183 187 188 189 \
 190 191 192 193 194 195 196 197 198 203 205 207 213 214 218 219 220 221 222 \
 224 227 230 231 232 233 234 235 236 237 241 243 246 247 248 249 254 255 258 \
 275 282 284 285 )
c756 ( 282 0 ) capacitor c=0.00878249f //x=20.58 //y=1.085
c757 ( 275 0 ) capacitor c=0.0586737f //x=72.27 //y=2.26
c758 ( 258 0 ) capacitor c=0.0393541f //x=17.17 //y=4.88
c759 ( 255 0 ) capacitor c=0.0284095f //x=17.14 //y=2.095
c760 ( 254 0 ) capacitor c=0.0440152f //x=17.14 //y=2.26
c761 ( 249 0 ) capacitor c=0.0318956f //x=72.975 //y=1.39
c762 ( 248 0 ) capacitor c=0.0186809f //x=72.975 //y=1.045
c763 ( 247 0 ) capacitor c=0.0659968f //x=72.615 //y=4.975
c764 ( 246 0 ) capacitor c=0.0373387f //x=72.905 //y=4.975
c765 ( 243 0 ) capacitor c=0.0157936f //x=72.82 //y=1.545
c766 ( 241 0 ) capacitor c=0.0158553f //x=72.82 //y=0.89
c767 ( 237 0 ) capacitor c=0.0302441f //x=72.445 //y=2.095
c768 ( 236 0 ) capacitor c=0.0238107f //x=72.445 //y=1.7
c769 ( 235 0 ) capacitor c=0.0234359f //x=72.445 //y=1.39
c770 ( 234 0 ) capacitor c=0.0199332f //x=72.445 //y=1.045
c771 ( 233 0 ) capacitor c=0.0927643f //x=70.615 //y=2.095
c772 ( 232 0 ) capacitor c=0.0251353f //x=70.615 //y=1.74
c773 ( 231 0 ) capacitor c=0.0234318f //x=70.615 //y=1.43
c774 ( 230 0 ) capacitor c=0.0192547f //x=70.615 //y=1.085
c775 ( 227 0 ) capacitor c=0.0714656f //x=70.52 //y=5.05
c776 ( 224 0 ) capacitor c=0.0186579f //x=70.46 //y=1.585
c777 ( 222 0 ) capacitor c=0.0157803f //x=70.46 //y=0.93
c778 ( 221 0 ) capacitor c=0.0134011f //x=70.155 //y=4.975
c779 ( 220 0 ) capacitor c=0.0243282f //x=70.445 //y=4.975
c780 ( 219 0 ) capacitor c=0.0364928f //x=70.085 //y=1.43
c781 ( 218 0 ) capacitor c=0.0174823f //x=70.085 //y=1.085
c782 ( 214 0 ) capacitor c=0.0439708f //x=17.705 //y=1.43
c783 ( 213 0 ) capacitor c=0.0192582f //x=17.705 //y=1.085
c784 ( 207 0 ) capacitor c=0.0162526f //x=17.55 //y=1.585
c785 ( 205 0 ) capacitor c=0.0157807f //x=17.55 //y=0.93
c786 ( 203 0 ) capacitor c=0.0372668f //x=17.545 //y=4.97
c787 ( 198 0 ) capacitor c=0.0210762f //x=17.175 //y=1.74
c788 ( 197 0 ) capacitor c=0.0168511f //x=17.175 //y=1.43
c789 ( 196 0 ) capacitor c=0.0175485f //x=17.175 //y=1.085
c790 ( 195 0 ) capacitor c=0.11081f //x=72.98 //y=6.205
c791 ( 194 0 ) capacitor c=0.154997f //x=72.54 //y=6.205
c792 ( 193 0 ) capacitor c=0.155934f //x=70.52 //y=6.205
c793 ( 192 0 ) capacitor c=0.110593f //x=70.08 //y=6.205
c794 ( 191 0 ) capacitor c=0.155269f //x=17.62 //y=6.2
c795 ( 190 0 ) capacitor c=0.110375f //x=17.18 //y=6.2
c796 ( 183 0 ) capacitor c=7.7962e-19 //x=72.27 //y=4.885
c797 ( 178 0 ) capacitor c=7.89145e-19 //x=72.27 //y=2.26
c798 ( 173 0 ) capacitor c=7.79163e-19 //x=70.79 //y=4.885
c799 ( 164 0 ) capacitor c=4.74639e-19 //x=70.79 //y=2.26
c800 ( 147 0 ) capacitor c=0.0322017f //x=20.73 //y=5.56
c801 ( 139 0 ) capacitor c=0.0291951f //x=19.85 //y=5.56
c802 ( 134 0 ) capacitor c=8.90417e-19 //x=17.17 //y=4.88
c803 ( 125 0 ) capacitor c=3.09518e-19 //x=17.14 //y=2.26
c804 ( 122 0 ) capacitor c=0.0208859f //x=72.105 //y=2.27
c805 ( 121 0 ) capacitor c=0.00241177f //x=72.265 //y=2.27
c806 ( 119 0 ) capacitor c=0.00130247f //x=70.955 //y=2.27
c807 ( 111 0 ) capacitor c=5.28937e-19 //x=17.29 //y=3.17
c808 ( 104 0 ) capacitor c=0.236665f //x=56.2 //y=3.125
c809 ( 102 0 ) capacitor c=0.0185676f //x=55.6 //y=3.14
c810 ( 100 0 ) capacitor c=0.00772414f //x=54.36 //y=3.125
c811 ( 98 0 ) capacitor c=0.00821162f //x=53.76 //y=3.14
c812 ( 96 0 ) capacitor c=0.00628936f //x=52.87 //y=3.12
c813 ( 94 0 ) capacitor c=0.0191737f //x=52.27 //y=3.14
c814 ( 92 0 ) capacitor c=0.008025f //x=51.02 //y=3.125
c815 ( 90 0 ) capacitor c=0.0344568f //x=50.42 //y=3.14
c816 ( 88 0 ) capacitor c=0.00477105f //x=46.96 //y=3.125
c817 ( 86 0 ) capacitor c=0.155804f //x=46.36 //y=3.14
c818 ( 84 0 ) capacitor c=0.00540847f //x=34.74 //y=3.125
c819 ( 82 0 ) capacitor c=0.0155693f //x=34.14 //y=3.14
c820 ( 80 0 ) capacitor c=0.00607094f //x=32.9 //y=3.125
c821 ( 78 0 ) capacitor c=0.00706942f //x=32.3 //y=3.14
c822 ( 76 0 ) capacitor c=0.00531214f //x=31.41 //y=3.12
c823 ( 74 0 ) capacitor c=0.0161377f //x=30.81 //y=3.14
c824 ( 72 0 ) capacitor c=0.00639434f //x=29.56 //y=3.125
c825 ( 70 0 ) capacitor c=0.0334894f //x=28.96 //y=3.14
c826 ( 69 0 ) capacitor c=0.0594065f //x=25.07 //y=3.125
c827 ( 68 0 ) capacitor c=0.00477105f //x=25.5 //y=3.125
c828 ( 66 0 ) capacitor c=0.0467641f //x=21.04 //y=3.14
c829 ( 52 0 ) capacitor c=0.0148135f //x=70.785 //y=3.14
c830 ( 48 0 ) capacitor c=0.0158166f //x=21.21 //y=3.14
c831 ( 45 0 ) capacitor c=0.0112857f //x=20.77 //y=1.18
c832 ( 43 0 ) capacitor c=5.78613e-19 //x=20.73 //y=5.56
c833 ( 40 0 ) capacitor c=0.0107082f //x=20.73 //y=5.38
c834 ( 39 0 ) capacitor c=0.00929664f //x=19.85 //y=5.56
c835 ( 34 0 ) capacitor c=0.0141141f //x=17.14 //y=3.14
c836 ( 28 0 ) capacitor c=0.00626461f //x=17.14 //y=2.26
c837 ( 26 0 ) capacitor c=0.0768193f //x=72.27 //y=4.755
c838 ( 25 0 ) capacitor c=0.00995077f //x=72.27 //y=2.43
c839 ( 24 0 ) capacitor c=0.0562407f //x=70.79 //y=4.76
c840 ( 23 0 ) capacitor c=0.0138761f //x=70.79 //y=3.3
c841 ( 22 0 ) capacitor c=0.0154555f //x=70.79 //y=2.98
c842 ( 21 0 ) capacitor c=0.0100761f //x=70.79 //y=2.43
c843 ( 20 0 ) capacitor c=0.0547024f //x=21.21 //y=5.295
c844 ( 19 0 ) capacitor c=0.0141904f //x=21.21 //y=3.315
c845 ( 18 0 ) capacitor c=0.0269376f //x=21.21 //y=2.995
c846 ( 16 0 ) capacitor c=0.00560492f //x=20.855 //y=1.835
c847 ( 15 0 ) capacitor c=0.0130605f //x=21.125 //y=1.835
c848 ( 13 0 ) capacitor c=0.0117187f //x=21.125 //y=5.38
c849 ( 12 0 ) capacitor c=0.0133876f //x=20.77 //y=1.75
c850 ( 7 0 ) capacitor c=0.0134497f //x=20.615 //y=5.38
c851 ( 4 0 ) capacitor c=0.0326431f //x=17.14 //y=4.735
c852 ( 3 0 ) capacitor c=0.0107871f //x=17.14 //y=3.33
c853 ( 2 0 ) capacitor c=0.0116216f //x=17.14 //y=3.01
r854 (  260 261 ) resistor r=32.4568 //w=0.214 //l=0.075 //layer=ply \
 //thickness=0.18 //x=17.17 //y=4.97 //x2=17.17 //y2=5.045
r855 (  258 260 ) resistor r=20.271 //w=0.214 //l=0.09 //layer=ply \
 //thickness=0.18 //x=17.17 //y=4.88 //x2=17.17 //y2=4.97
r856 (  254 255 ) resistor r=52.7279 //w=0.214 //l=0.165 //layer=ply \
 //thickness=0.18 //x=17.14 //y=2.26 //x2=17.14 //y2=2.095
r857 (  249 281 ) resistor r=45.1352 //w=0.168 //l=0.173853 //layer=ply \
 //thickness=0.18 //x=72.975 //y=1.39 //x2=72.935 //y2=1.545
r858 (  248 280 ) resistor r=45.1352 //w=0.168 //l=0.173853 //layer=ply \
 //thickness=0.18 //x=72.975 //y=1.045 //x2=72.935 //y2=0.89
r859 (  248 249 ) resistor r=176.904 //w=0.094 //l=0.345 //layer=ply \
 //thickness=0.18 //x=72.975 //y=1.045 //x2=72.975 //y2=1.39
r860 (  246 250 ) resistor r=26.9307 //w=0.15 //l=0.106066 //layer=ply \
 //thickness=0.18 //x=72.905 //y=4.975 //x2=72.98 //y2=5.05
r861 (  246 247 ) resistor r=148.702 //w=0.094 //l=0.29 //layer=ply \
 //thickness=0.18 //x=72.905 //y=4.975 //x2=72.615 //y2=4.975
r862 (  244 279 ) resistor r=10.701 //w=0.21 //l=0.115 //layer=ply \
 //thickness=0.18 //x=72.6 //y=1.545 //x2=72.485 //y2=1.545
r863 (  243 281 ) resistor r=5.52526 //w=0.168 //l=0.115 //layer=ply \
 //thickness=0.18 //x=72.82 //y=1.545 //x2=72.935 //y2=1.545
r864 (  242 278 ) resistor r=5.52526 //w=0.168 //l=0.115 //layer=ply \
 //thickness=0.18 //x=72.6 //y=0.89 //x2=72.485 //y2=0.89
r865 (  241 280 ) resistor r=5.52526 //w=0.168 //l=0.115 //layer=ply \
 //thickness=0.18 //x=72.82 //y=0.89 //x2=72.935 //y2=0.89
r866 (  241 242 ) resistor r=112.809 //w=0.094 //l=0.22 //layer=ply \
 //thickness=0.18 //x=72.82 //y=0.89 //x2=72.6 //y2=0.89
r867 (  238 247 ) resistor r=22.1787 //w=0.252 //l=0.106066 //layer=ply \
 //thickness=0.18 //x=72.54 //y=5.05 //x2=72.615 //y2=4.975
r868 (  238 277 ) resistor r=51.6429 //w=0.252 //l=0.34271 //layer=ply \
 //thickness=0.18 //x=72.54 //y=5.05 //x2=72.27 //y2=4.885
r869 (  237 275 ) resistor r=30.4513 //w=0.277 //l=0.243926 //layer=ply \
 //thickness=0.18 //x=72.445 //y=2.095 //x2=72.27 //y2=2.26
r870 (  236 279 ) resistor r=39.5823 //w=0.21 //l=0.173853 //layer=ply \
 //thickness=0.18 //x=72.445 //y=1.7 //x2=72.485 //y2=1.545
r871 (  236 237 ) resistor r=202.543 //w=0.094 //l=0.395 //layer=ply \
 //thickness=0.18 //x=72.445 //y=1.7 //x2=72.445 //y2=2.095
r872 (  235 279 ) resistor r=39.5823 //w=0.21 //l=0.173853 //layer=ply \
 //thickness=0.18 //x=72.445 //y=1.39 //x2=72.485 //y2=1.545
r873 (  234 278 ) resistor r=45.1352 //w=0.168 //l=0.173853 //layer=ply \
 //thickness=0.18 //x=72.445 //y=1.045 //x2=72.485 //y2=0.89
r874 (  234 235 ) resistor r=176.904 //w=0.094 //l=0.345 //layer=ply \
 //thickness=0.18 //x=72.445 //y=1.045 //x2=72.445 //y2=1.39
r875 (  233 271 ) resistor r=30.4513 //w=0.277 //l=0.243926 //layer=ply \
 //thickness=0.18 //x=70.615 //y=2.095 //x2=70.79 //y2=2.26
r876 (  232 269 ) resistor r=39.5823 //w=0.21 //l=0.173853 //layer=ply \
 //thickness=0.18 //x=70.615 //y=1.74 //x2=70.575 //y2=1.585
r877 (  232 233 ) resistor r=182.032 //w=0.094 //l=0.355 //layer=ply \
 //thickness=0.18 //x=70.615 //y=1.74 //x2=70.615 //y2=2.095
r878 (  231 269 ) resistor r=39.5823 //w=0.21 //l=0.173853 //layer=ply \
 //thickness=0.18 //x=70.615 //y=1.43 //x2=70.575 //y2=1.585
r879 (  230 268 ) resistor r=45.1352 //w=0.168 //l=0.173853 //layer=ply \
 //thickness=0.18 //x=70.615 //y=1.085 //x2=70.575 //y2=0.93
r880 (  230 231 ) resistor r=176.904 //w=0.094 //l=0.345 //layer=ply \
 //thickness=0.18 //x=70.615 //y=1.085 //x2=70.615 //y2=1.43
r881 (  227 273 ) resistor r=51.6429 //w=0.252 //l=0.34271 //layer=ply \
 //thickness=0.18 //x=70.52 //y=5.05 //x2=70.79 //y2=4.885
r882 (  225 267 ) resistor r=5.52526 //w=0.168 //l=0.115 //layer=ply \
 //thickness=0.18 //x=70.24 //y=1.585 //x2=70.125 //y2=1.585
r883 (  224 269 ) resistor r=10.701 //w=0.21 //l=0.115 //layer=ply \
 //thickness=0.18 //x=70.46 //y=1.585 //x2=70.575 //y2=1.585
r884 (  223 266 ) resistor r=5.52526 //w=0.168 //l=0.115 //layer=ply \
 //thickness=0.18 //x=70.24 //y=0.93 //x2=70.125 //y2=0.93
r885 (  222 268 ) resistor r=5.52526 //w=0.168 //l=0.115 //layer=ply \
 //thickness=0.18 //x=70.46 //y=0.93 //x2=70.575 //y2=0.93
r886 (  222 223 ) resistor r=112.809 //w=0.094 //l=0.22 //layer=ply \
 //thickness=0.18 //x=70.46 //y=0.93 //x2=70.24 //y2=0.93
r887 (  220 227 ) resistor r=22.1787 //w=0.252 //l=0.106066 //layer=ply \
 //thickness=0.18 //x=70.445 //y=4.975 //x2=70.52 //y2=5.05
r888 (  220 221 ) resistor r=148.702 //w=0.094 //l=0.29 //layer=ply \
 //thickness=0.18 //x=70.445 //y=4.975 //x2=70.155 //y2=4.975
r889 (  219 267 ) resistor r=45.1352 //w=0.168 //l=0.173853 //layer=ply \
 //thickness=0.18 //x=70.085 //y=1.43 //x2=70.125 //y2=1.585
r890 (  218 266 ) resistor r=45.1352 //w=0.168 //l=0.173853 //layer=ply \
 //thickness=0.18 //x=70.085 //y=1.085 //x2=70.125 //y2=0.93
r891 (  218 219 ) resistor r=176.904 //w=0.094 //l=0.345 //layer=ply \
 //thickness=0.18 //x=70.085 //y=1.085 //x2=70.085 //y2=1.43
r892 (  215 221 ) resistor r=26.9307 //w=0.15 //l=0.106066 //layer=ply \
 //thickness=0.18 //x=70.08 //y=5.05 //x2=70.155 //y2=4.975
r893 (  214 265 ) resistor r=45.1352 //w=0.168 //l=0.173853 //layer=ply \
 //thickness=0.18 //x=17.705 //y=1.43 //x2=17.665 //y2=1.585
r894 (  213 264 ) resistor r=45.1352 //w=0.168 //l=0.173853 //layer=ply \
 //thickness=0.18 //x=17.705 //y=1.085 //x2=17.665 //y2=0.93
r895 (  213 214 ) resistor r=176.904 //w=0.094 //l=0.345 //layer=ply \
 //thickness=0.18 //x=17.705 //y=1.085 //x2=17.705 //y2=1.43
r896 (  208 263 ) resistor r=10.701 //w=0.21 //l=0.115 //layer=ply \
 //thickness=0.18 //x=17.33 //y=1.585 //x2=17.215 //y2=1.585
r897 (  207 265 ) resistor r=5.52526 //w=0.168 //l=0.115 //layer=ply \
 //thickness=0.18 //x=17.55 //y=1.585 //x2=17.665 //y2=1.585
r898 (  206 262 ) resistor r=5.52526 //w=0.168 //l=0.115 //layer=ply \
 //thickness=0.18 //x=17.33 //y=0.93 //x2=17.215 //y2=0.93
r899 (  205 264 ) resistor r=5.52526 //w=0.168 //l=0.115 //layer=ply \
 //thickness=0.18 //x=17.55 //y=0.93 //x2=17.665 //y2=0.93
r900 (  205 206 ) resistor r=112.809 //w=0.094 //l=0.22 //layer=ply \
 //thickness=0.18 //x=17.55 //y=0.93 //x2=17.33 //y2=0.93
r901 (  204 260 ) resistor r=16.5046 //w=0.27 //l=0.135 //layer=ply \
 //thickness=0.18 //x=17.305 //y=4.97 //x2=17.17 //y2=4.97
r902 (  203 210 ) resistor r=26.9307 //w=0.15 //l=0.106066 //layer=ply \
 //thickness=0.18 //x=17.545 //y=4.97 //x2=17.62 //y2=5.045
r903 (  203 204 ) resistor r=123.064 //w=0.094 //l=0.24 //layer=ply \
 //thickness=0.18 //x=17.545 //y=4.97 //x2=17.305 //y2=4.97
r904 (  198 263 ) resistor r=39.5823 //w=0.21 //l=0.173853 //layer=ply \
 //thickness=0.18 //x=17.175 //y=1.74 //x2=17.215 //y2=1.585
r905 (  198 255 ) resistor r=182.032 //w=0.094 //l=0.355 //layer=ply \
 //thickness=0.18 //x=17.175 //y=1.74 //x2=17.175 //y2=2.095
r906 (  197 263 ) resistor r=39.5823 //w=0.21 //l=0.173853 //layer=ply \
 //thickness=0.18 //x=17.175 //y=1.43 //x2=17.215 //y2=1.585
r907 (  196 262 ) resistor r=45.1352 //w=0.168 //l=0.173853 //layer=ply \
 //thickness=0.18 //x=17.175 //y=1.085 //x2=17.215 //y2=0.93
r908 (  196 197 ) resistor r=176.904 //w=0.094 //l=0.345 //layer=ply \
 //thickness=0.18 //x=17.175 //y=1.085 //x2=17.175 //y2=1.43
r909 (  195 250 ) resistor r=592.245 //w=0.094 //l=1.155 //layer=ply \
 //thickness=0.18 //x=72.98 //y=6.205 //x2=72.98 //y2=5.05
r910 (  194 238 ) resistor r=592.245 //w=0.094 //l=1.155 //layer=ply \
 //thickness=0.18 //x=72.54 //y=6.205 //x2=72.54 //y2=5.05
r911 (  193 227 ) resistor r=592.245 //w=0.094 //l=1.155 //layer=ply \
 //thickness=0.18 //x=70.52 //y=6.205 //x2=70.52 //y2=5.05
r912 (  192 215 ) resistor r=592.245 //w=0.094 //l=1.155 //layer=ply \
 //thickness=0.18 //x=70.08 //y=6.205 //x2=70.08 //y2=5.05
r913 (  191 210 ) resistor r=592.245 //w=0.094 //l=1.155 //layer=ply \
 //thickness=0.18 //x=17.62 //y=6.2 //x2=17.62 //y2=5.045
r914 (  190 261 ) resistor r=592.245 //w=0.094 //l=1.155 //layer=ply \
 //thickness=0.18 //x=17.18 //y=6.2 //x2=17.18 //y2=5.045
r915 (  189 243 ) resistor r=56.4043 //w=0.094 //l=0.11 //layer=ply \
 //thickness=0.18 //x=72.71 //y=1.545 //x2=72.82 //y2=1.545
r916 (  189 244 ) resistor r=56.4043 //w=0.094 //l=0.11 //layer=ply \
 //thickness=0.18 //x=72.71 //y=1.545 //x2=72.6 //y2=1.545
r917 (  188 224 ) resistor r=56.4043 //w=0.094 //l=0.11 //layer=ply \
 //thickness=0.18 //x=70.35 //y=1.585 //x2=70.46 //y2=1.585
r918 (  188 225 ) resistor r=56.4043 //w=0.094 //l=0.11 //layer=ply \
 //thickness=0.18 //x=70.35 //y=1.585 //x2=70.24 //y2=1.585
r919 (  187 207 ) resistor r=56.4043 //w=0.094 //l=0.11 //layer=ply \
 //thickness=0.18 //x=17.44 //y=1.585 //x2=17.55 //y2=1.585
r920 (  187 208 ) resistor r=56.4043 //w=0.094 //l=0.11 //layer=ply \
 //thickness=0.18 //x=17.44 //y=1.585 //x2=17.33 //y2=1.585
r921 (  183 277 ) resistor r=152 //w=0.17 //l=0.17 //layer=licon //count=1 \
 //x=72.27 //y=4.885 //x2=72.27 //y2=4.885
r922 (  178 275 ) resistor r=152 //w=0.17 //l=0.17 //layer=licon //count=1 \
 //x=72.27 //y=2.26 //x2=72.27 //y2=2.26
r923 (  173 273 ) resistor r=152 //w=0.17 //l=0.17 //layer=licon //count=1 \
 //x=70.79 //y=4.885 //x2=70.79 //y2=4.885
r924 (  164 271 ) resistor r=152 //w=0.17 //l=0.17 //layer=licon //count=1 \
 //x=70.79 //y=2.26 //x2=70.79 //y2=2.26
r925 (  147 285 ) resistor r=23.615 //w=0.187 //l=0.345 //layer=li \
 //thickness=0.1 //x=20.73 //y=5.56 //x2=20.73 //y2=5.905
r926 (  139 284 ) resistor r=23.615 //w=0.187 //l=0.345 //layer=li \
 //thickness=0.1 //x=19.85 //y=5.56 //x2=19.85 //y2=5.905
r927 (  134 258 ) resistor r=152 //w=0.17 //l=0.17 //layer=licon //count=1 \
 //x=17.17 //y=4.88 //x2=17.17 //y2=4.88
r928 (  125 254 ) resistor r=152 //w=0.17 //l=0.17 //layer=licon //count=1 \
 //x=17.14 //y=2.26 //x2=17.14 //y2=2.26
r929 (  121 122 ) resistor r=0.10734 //w=0.281 //l=0.16 //layer=m2 \
 //thickness=0.36 //x=72.265 //y=2.27 //x2=72.105 //y2=2.27
r930 (  119 122 ) resistor r=1.09733 //w=0.131 //l=1.15 //layer=m2 \
 //thickness=0.36 //x=70.955 //y=2.26 //x2=72.105 //y2=2.26
r931 (  117 119 ) resistor r=0.10734 //w=0.281 //l=0.16 //layer=m2 \
 //thickness=0.36 //x=70.795 //y=2.27 //x2=70.955 //y2=2.27
r932 (  109 111 ) resistor r=0.10734 //w=0.281 //l=0.16 //layer=m2 \
 //thickness=0.36 //x=17.13 //y=3.17 //x2=17.29 //y2=3.17
r933 (  104 115 ) resistor r=10.4777 //w=0.174 //l=14.5925 //layer=m2 \
 //thickness=0.36 //x=56.2 //y=3.125 //x2=70.785 //y2=3.14
r934 (  104 105 ) resistor r=0.410305 //w=0.131 //l=0.43 //layer=m2 \
 //thickness=0.36 //x=56.2 //y=3.125 //x2=55.77 //y2=3.125
r935 (  102 105 ) resistor r=0.125 //w=0.17 //l=0.177341 //layer=m2 \
 //thickness=0.36 //x=55.6 //y=3.14 //x2=55.77 //y2=3.125
r936 (  102 103 ) resistor r=0.939885 //w=0.131 //l=0.985 //layer=m2 \
 //thickness=0.36 //x=55.6 //y=3.14 //x2=54.615 //y2=3.14
r937 (  100 103 ) resistor r=0.1875 //w=0.17 //l=0.262393 //layer=m2 \
 //thickness=0.36 //x=54.36 //y=3.125 //x2=54.615 //y2=3.14
r938 (  100 101 ) resistor r=0.410305 //w=0.131 //l=0.43 //layer=m2 \
 //thickness=0.36 //x=54.36 //y=3.125 //x2=53.93 //y2=3.125
r939 (  98 101 ) resistor r=0.125 //w=0.17 //l=0.177341 //layer=m2 \
 //thickness=0.36 //x=53.76 //y=3.14 //x2=53.93 //y2=3.125
r940 (  98 99 ) resistor r=0.605916 //w=0.131 //l=0.635 //layer=m2 \
 //thickness=0.36 //x=53.76 //y=3.14 //x2=53.125 //y2=3.14
r941 (  96 99 ) resistor r=0.1875 //w=0.17 //l=0.264811 //layer=m2 \
 //thickness=0.36 //x=52.87 //y=3.12 //x2=53.125 //y2=3.14
r942 (  96 97 ) resistor r=0.410305 //w=0.131 //l=0.43 //layer=m2 \
 //thickness=0.36 //x=52.87 //y=3.12 //x2=52.44 //y2=3.12
r943 (  94 97 ) resistor r=0.125 //w=0.17 //l=0.179722 //layer=m2 \
 //thickness=0.36 //x=52.27 //y=3.14 //x2=52.44 //y2=3.12
r944 (  94 95 ) resistor r=0.949427 //w=0.131 //l=0.995 //layer=m2 \
 //thickness=0.36 //x=52.27 //y=3.14 //x2=51.275 //y2=3.14
r945 (  92 95 ) resistor r=0.1875 //w=0.17 //l=0.262393 //layer=m2 \
 //thickness=0.36 //x=51.02 //y=3.125 //x2=51.275 //y2=3.14
r946 (  92 93 ) resistor r=0.410305 //w=0.131 //l=0.43 //layer=m2 \
 //thickness=0.36 //x=51.02 //y=3.125 //x2=50.59 //y2=3.125
r947 (  90 93 ) resistor r=0.125 //w=0.17 //l=0.177341 //layer=m2 \
 //thickness=0.36 //x=50.42 //y=3.14 //x2=50.59 //y2=3.125
r948 (  90 91 ) resistor r=3.05821 //w=0.131 //l=3.205 //layer=m2 \
 //thickness=0.36 //x=50.42 //y=3.14 //x2=47.215 //y2=3.14
r949 (  88 91 ) resistor r=0.1875 //w=0.17 //l=0.262393 //layer=m2 \
 //thickness=0.36 //x=46.96 //y=3.125 //x2=47.215 //y2=3.14
r950 (  88 89 ) resistor r=0.410305 //w=0.131 //l=0.43 //layer=m2 \
 //thickness=0.36 //x=46.96 //y=3.125 //x2=46.53 //y2=3.125
r951 (  86 89 ) resistor r=0.125 //w=0.17 //l=0.177341 //layer=m2 \
 //thickness=0.36 //x=46.36 //y=3.14 //x2=46.53 //y2=3.125
r952 (  86 87 ) resistor r=10.8445 //w=0.131 //l=11.365 //layer=m2 \
 //thickness=0.36 //x=46.36 //y=3.14 //x2=34.995 //y2=3.14
r953 (  84 87 ) resistor r=0.1875 //w=0.17 //l=0.262393 //layer=m2 \
 //thickness=0.36 //x=34.74 //y=3.125 //x2=34.995 //y2=3.14
r954 (  84 85 ) resistor r=0.410305 //w=0.131 //l=0.43 //layer=m2 \
 //thickness=0.36 //x=34.74 //y=3.125 //x2=34.31 //y2=3.125
r955 (  82 85 ) resistor r=0.125 //w=0.17 //l=0.177341 //layer=m2 \
 //thickness=0.36 //x=34.14 //y=3.14 //x2=34.31 //y2=3.125
r956 (  82 83 ) resistor r=0.939885 //w=0.131 //l=0.985 //layer=m2 \
 //thickness=0.36 //x=34.14 //y=3.14 //x2=33.155 //y2=3.14
r957 (  80 83 ) resistor r=0.1875 //w=0.17 //l=0.262393 //layer=m2 \
 //thickness=0.36 //x=32.9 //y=3.125 //x2=33.155 //y2=3.14
r958 (  80 81 ) resistor r=0.410305 //w=0.131 //l=0.43 //layer=m2 \
 //thickness=0.36 //x=32.9 //y=3.125 //x2=32.47 //y2=3.125
r959 (  78 81 ) resistor r=0.125 //w=0.17 //l=0.177341 //layer=m2 \
 //thickness=0.36 //x=32.3 //y=3.14 //x2=32.47 //y2=3.125
r960 (  78 79 ) resistor r=0.605916 //w=0.131 //l=0.635 //layer=m2 \
 //thickness=0.36 //x=32.3 //y=3.14 //x2=31.665 //y2=3.14
r961 (  76 79 ) resistor r=0.1875 //w=0.17 //l=0.264811 //layer=m2 \
 //thickness=0.36 //x=31.41 //y=3.12 //x2=31.665 //y2=3.14
r962 (  76 77 ) resistor r=0.410305 //w=0.131 //l=0.43 //layer=m2 \
 //thickness=0.36 //x=31.41 //y=3.12 //x2=30.98 //y2=3.12
r963 (  74 77 ) resistor r=0.125 //w=0.17 //l=0.179722 //layer=m2 \
 //thickness=0.36 //x=30.81 //y=3.14 //x2=30.98 //y2=3.12
r964 (  74 75 ) resistor r=0.949427 //w=0.131 //l=0.995 //layer=m2 \
 //thickness=0.36 //x=30.81 //y=3.14 //x2=29.815 //y2=3.14
r965 (  72 75 ) resistor r=0.1875 //w=0.17 //l=0.262393 //layer=m2 \
 //thickness=0.36 //x=29.56 //y=3.125 //x2=29.815 //y2=3.14
r966 (  72 73 ) resistor r=0.410305 //w=0.131 //l=0.43 //layer=m2 \
 //thickness=0.36 //x=29.56 //y=3.125 //x2=29.13 //y2=3.125
r967 (  70 73 ) resistor r=0.125 //w=0.17 //l=0.177341 //layer=m2 \
 //thickness=0.36 //x=28.96 //y=3.14 //x2=29.13 //y2=3.125
r968 (  70 71 ) resistor r=3.05821 //w=0.131 //l=3.205 //layer=m2 \
 //thickness=0.36 //x=28.96 //y=3.14 //x2=25.755 //y2=3.14
r969 (  69 113 ) resistor r=2.65869 //w=0.182 //l=3.88497 //layer=m2 \
 //thickness=0.36 //x=25.07 //y=3.125 //x2=21.2 //y2=3.155
r970 (  68 71 ) resistor r=0.1875 //w=0.17 //l=0.262393 //layer=m2 \
 //thickness=0.36 //x=25.5 //y=3.125 //x2=25.755 //y2=3.14
r971 (  68 69 ) resistor r=0.410305 //w=0.131 //l=0.43 //layer=m2 \
 //thickness=0.36 //x=25.5 //y=3.125 //x2=25.07 //y2=3.125
r972 (  66 113 ) resistor r=0.110608 //w=0.182 //l=0.167332 //layer=m2 \
 //thickness=0.36 //x=21.04 //y=3.14 //x2=21.2 //y2=3.155
r973 (  66 111 ) resistor r=3.57824 //w=0.131 //l=3.75 //layer=m2 \
 //thickness=0.36 //x=21.04 //y=3.14 //x2=17.29 //y2=3.14
r974 (  65 183 ) resistor r=9.3 //w=0.17 //l=0.17 //layer=mcon //count=1 \
 //x=72.27 //y=4.885 //x2=72.27 //y2=4.885
r975 (  63 121 ) resistor r=4.5 //w=0.15 //l=0.15 //layer=via1 //count=1 \
 //x=72.265 //y=2.27 //x2=72.265 //y2=2.27
r976 (  61 178 ) resistor r=9.3 //w=0.17 //l=0.17 //layer=mcon //count=1 \
 //x=72.27 //y=2.26 //x2=72.27 //y2=2.26
r977 (  61 63 ) resistor r=0.00334225 //w=0.374 //l=0.01 //layer=m1 \
 //thickness=0.36 //x=72.215 //y=2.26 //x2=72.215 //y2=2.27
r978 (  59 117 ) resistor r=4.5 //w=0.15 //l=0.15 //layer=via1 //count=1 \
 //x=70.795 //y=2.27 //x2=70.795 //y2=2.27
r979 (  57 164 ) resistor r=9.3 //w=0.17 //l=0.17 //layer=mcon //count=1 \
 //x=70.79 //y=2.26 //x2=70.79 //y2=2.26
r980 (  57 59 ) resistor r=0.00334225 //w=0.374 //l=0.01 //layer=m1 \
 //thickness=0.36 //x=70.845 //y=2.26 //x2=70.845 //y2=2.27
r981 (  55 173 ) resistor r=9.3 //w=0.17 //l=0.17 //layer=mcon //count=1 \
 //x=70.79 //y=4.885 //x2=70.79 //y2=4.885
r982 (  52 115 ) resistor r=4.5 //w=0.15 //l=0.15 //layer=via1 //count=1 \
 //x=70.785 //y=3.14 //x2=70.785 //y2=3.14
r983 (  50 113 ) resistor r=4.5 //w=0.15 //l=0.15 //layer=via1 //count=1 \
 //x=21.2 //y=3.155 //x2=21.2 //y2=3.155
r984 (  48 50 ) resistor r=0.00490838 //w=0.382 //l=0.015 //layer=m1 \
 //thickness=0.36 //x=21.257 //y=3.14 //x2=21.257 //y2=3.155
r985 (  45 282 ) resistor r=9.3 //w=0.17 //l=0.17 //layer=mcon //count=1 \
 //x=20.77 //y=1.18 //x2=20.77 //y2=1.18
r986 (  43 147 ) resistor r=9.3 //w=0.17 //l=0.17 //layer=mcon //count=1 \
 //x=20.73 //y=5.56 //x2=20.73 //y2=5.56
r987 (  40 43 ) resistor r=0.117801 //w=0.191 //l=0.18 //layer=m1 \
 //thickness=0.36 //x=20.73 //y=5.38 //x2=20.73 //y2=5.56
r988 (  39 139 ) resistor r=9.3 //w=0.17 //l=0.17 //layer=mcon //count=1 \
 //x=19.85 //y=5.56 //x2=19.85 //y2=5.56
r989 (  37 39 ) resistor r=0.10274 //w=0.219 //l=0.18 //layer=m1 \
 //thickness=0.36 //x=19.85 //y=5.38 //x2=19.85 //y2=5.56
r990 (  36 109 ) resistor r=4.5 //w=0.15 //l=0.15 //layer=via1 //count=1 \
 //x=17.13 //y=3.17 //x2=17.13 //y2=3.17
r991 (  34 36 ) resistor r=0.00981675 //w=0.382 //l=0.03 //layer=m1 \
 //thickness=0.36 //x=17.187 //y=3.14 //x2=17.187 //y2=3.17
r992 (  32 134 ) resistor r=9.3 //w=0.17 //l=0.17 //layer=mcon //count=1 \
 //x=17.17 //y=4.88 //x2=17.17 //y2=4.88
r993 (  28 125 ) resistor r=9.3 //w=0.17 //l=0.17 //layer=mcon //count=1 \
 //x=17.14 //y=2.26 //x2=17.14 //y2=2.26
r994 (  28 30 ) resistor r=0.0936408 //w=0.196 //l=0.125 //layer=m1 \
 //thickness=0.36 //x=17.142 //y=2.26 //x2=17.142 //y2=2.385
r995 (  26 65 ) resistor r=0.0777782 //w=0.252 //l=0.131491 //layer=m1 \
 //thickness=0.36 //x=72.27 //y=4.755 //x2=72.267 //y2=4.885
r996 (  25 63 ) resistor r=0.0910802 //w=0.374 //l=0.185472 //layer=m1 \
 //thickness=0.36 //x=72.27 //y=2.43 //x2=72.215 //y2=2.27
r997 (  25 26 ) resistor r=2.21851 //w=0.131 //l=2.325 //layer=m1 \
 //thickness=0.36 //x=72.27 //y=2.43 //x2=72.27 //y2=4.755
r998 (  24 55 ) resistor r=0.075298 //w=0.252 //l=0.125 //layer=m1 \
 //thickness=0.36 //x=70.79 //y=4.76 //x2=70.79 //y2=4.885
r999 (  23 52 ) resistor r=0.0910802 //w=0.374 //l=0.185472 //layer=m1 \
 //thickness=0.36 //x=70.79 //y=3.3 //x2=70.735 //y2=3.14
r1000 (  23 24 ) resistor r=1.39313 //w=0.131 //l=1.46 //layer=m1 \
 //thickness=0.36 //x=70.79 //y=3.3 //x2=70.79 //y2=4.76
r1001 (  22 52 ) resistor r=0.0910802 //w=0.374 //l=0.185472 //layer=m1 \
 //thickness=0.36 //x=70.79 //y=2.98 //x2=70.735 //y2=3.14
r1002 (  21 59 ) resistor r=0.0910802 //w=0.374 //l=0.185472 //layer=m1 \
 //thickness=0.36 //x=70.79 //y=2.43 //x2=70.845 //y2=2.27
r1003 (  21 22 ) resistor r=0.524809 //w=0.131 //l=0.55 //layer=m1 \
 //thickness=0.36 //x=70.79 //y=2.43 //x2=70.79 //y2=2.98
r1004 (  19 50 ) resistor r=0.0914072 //w=0.382 //l=0.181989 //layer=m1 \
 //thickness=0.36 //x=21.21 //y=3.315 //x2=21.257 //y2=3.155
r1005 (  19 20 ) resistor r=1.88931 //w=0.131 //l=1.98 //layer=m1 \
 //thickness=0.36 //x=21.21 //y=3.315 //x2=21.21 //y2=5.295
r1006 (  18 48 ) resistor r=0.0864989 //w=0.382 //l=0.166853 //layer=m1 \
 //thickness=0.36 //x=21.21 //y=2.995 //x2=21.257 //y2=3.14
r1007 (  17 18 ) resistor r=1.02576 //w=0.131 //l=1.075 //layer=m1 \
 //thickness=0.36 //x=21.21 //y=1.92 //x2=21.21 //y2=2.995
r1008 (  15 17 ) resistor r=0.0698411 //w=0.17 //l=0.120208 //layer=m1 \
 //thickness=0.36 //x=21.125 //y=1.835 //x2=21.21 //y2=1.92
r1009 (  15 16 ) resistor r=0.257634 //w=0.131 //l=0.27 //layer=m1 \
 //thickness=0.36 //x=21.125 //y=1.835 //x2=20.855 //y2=1.835
r1010 (  14 40 ) resistor r=0.0257089 //w=0.23 //l=0.115 //layer=m1 \
 //thickness=0.36 //x=20.845 //y=5.38 //x2=20.73 //y2=5.38
r1011 (  13 20 ) resistor r=0.0698411 //w=0.17 //l=0.120208 //layer=m1 \
 //thickness=0.36 //x=21.125 //y=5.38 //x2=21.21 //y2=5.295
r1012 (  13 14 ) resistor r=0.267176 //w=0.131 //l=0.28 //layer=m1 \
 //thickness=0.36 //x=21.125 //y=5.38 //x2=20.845 //y2=5.38
r1013 (  12 16 ) resistor r=0.0698411 //w=0.17 //l=0.120208 //layer=m1 \
 //thickness=0.36 //x=20.77 //y=1.75 //x2=20.855 //y2=1.835
r1014 (  11 45 ) resistor r=0.0913624 //w=0.191 //l=0.12 //layer=m1 \
 //thickness=0.36 //x=20.77 //y=1.3 //x2=20.77 //y2=1.18
r1015 (  11 12 ) resistor r=0.429389 //w=0.131 //l=0.45 //layer=m1 \
 //thickness=0.36 //x=20.77 //y=1.3 //x2=20.77 //y2=1.75
r1016 (  8 37 ) resistor r=0.0227762 //w=0.219 //l=0.115 //layer=m1 \
 //thickness=0.36 //x=19.965 //y=5.38 //x2=19.85 //y2=5.38
r1017 (  7 40 ) resistor r=0.0257089 //w=0.23 //l=0.115 //layer=m1 \
 //thickness=0.36 //x=20.615 //y=5.38 //x2=20.73 //y2=5.38
r1018 (  7 8 ) resistor r=0.620229 //w=0.131 //l=0.65 //layer=m1 \
 //thickness=0.36 //x=20.615 //y=5.38 //x2=19.965 //y2=5.38
r1019 (  4 32 ) resistor r=0.0878548 //w=0.228 //l=0.159295 //layer=m1 \
 //thickness=0.36 //x=17.14 //y=4.735 //x2=17.17 //y2=4.88
r1020 (  3 36 ) resistor r=0.0914072 //w=0.382 //l=0.181989 //layer=m1 \
 //thickness=0.36 //x=17.14 //y=3.33 //x2=17.187 //y2=3.17
r1021 (  3 4 ) resistor r=1.34065 //w=0.131 //l=1.405 //layer=m1 \
 //thickness=0.36 //x=17.14 //y=3.33 //x2=17.14 //y2=4.735
r1022 (  2 34 ) resistor r=0.0815905 //w=0.382 //l=0.15169 //layer=m1 \
 //thickness=0.36 //x=17.14 //y=3.01 //x2=17.187 //y2=3.14
r1023 (  2 30 ) resistor r=0.596374 //w=0.131 //l=0.625 //layer=m1 \
 //thickness=0.36 //x=17.14 //y=3.01 //x2=17.14 //y2=2.385
ends PM_TMRDFFQNX1\%noxref_20

subckt PM_TMRDFFQNX1\%QN ( 1 2 3 4 5 6 7 8 9 11 12 13 15 16 28 32 35 38 52 55 \
 56 58 59 68 76 93 94 95 99 100 )
c215 ( 95 0 ) capacitor c=0.009897f //x=73.49 //y=1.085
c216 ( 94 0 ) capacitor c=0.0108932f //x=70.16 //y=1.085
c217 ( 93 0 ) capacitor c=0.0110392f //x=66.83 //y=1.085
c218 ( 76 0 ) capacitor c=0.0265472f //x=73.64 //y=5.56
c219 ( 68 0 ) capacitor c=0.0232072f //x=72.76 //y=5.56
c220 ( 59 0 ) capacitor c=0.0846636f //x=73.515 //y=1.405
c221 ( 58 0 ) capacitor c=0.0257508f //x=73.675 //y=1.405
c222 ( 56 0 ) capacitor c=0.00731967f //x=70.48 //y=1.405
c223 ( 55 0 ) capacitor c=0.0836263f //x=70.22 //y=1.405
c224 ( 52 0 ) capacitor c=0.00313402f //x=67.185 //y=1.405
c225 ( 38 0 ) capacitor c=0.01557f //x=73.637 //y=5.39
c226 ( 35 0 ) capacitor c=0.0155006f //x=72.76 //y=5.39
c227 ( 32 0 ) capacitor c=0.00904904f //x=70.35 //y=1.36
c228 ( 28 0 ) capacitor c=0.00604613f //x=67.02 //y=1.36
c229 ( 16 0 ) capacitor c=0.00834076f //x=73.765 //y=1.825
c230 ( 15 0 ) capacitor c=0.0162177f //x=74.035 //y=1.825
c231 ( 13 0 ) capacitor c=0.0128896f //x=74.035 //y=5.39
c232 ( 12 0 ) capacitor c=0.00871794f //x=73.68 //y=1.74
c233 ( 11 0 ) capacitor c=0.00698506f //x=73.68 //y=1.535
c234 ( 9 0 ) capacitor c=0.0116295f //x=73.515 //y=5.39
c235 ( 1 0 ) capacitor c=0.132496f //x=74.12 //y=2.4
r236 (  92 93 ) resistor r=13.3953 //w=0.172 //l=0.18 //layer=li \
 //thickness=0.1 //x=67.017 //y=1.36 //x2=67.017 //y2=1.18
r237 (  87 95 ) resistor r=12.3209 //w=0.187 //l=0.18 //layer=li \
 //thickness=0.1 //x=73.68 //y=1.36 //x2=73.68 //y2=1.18
r238 (  76 100 ) resistor r=23.2727 //w=0.187 //l=0.34 //layer=li \
 //thickness=0.1 //x=73.64 //y=5.56 //x2=73.64 //y2=5.9
r239 (  68 99 ) resistor r=23.2727 //w=0.187 //l=0.34 //layer=li \
 //thickness=0.1 //x=72.76 //y=5.56 //x2=72.76 //y2=5.9
r240 (  65 94 ) resistor r=12.3209 //w=0.187 //l=0.18 //layer=li \
 //thickness=0.1 //x=70.35 //y=1.36 //x2=70.35 //y2=1.18
r241 (  58 59 ) resistor r=0.10734 //w=0.281 //l=0.16 //layer=m2 \
 //thickness=0.36 //x=73.675 //y=1.405 //x2=73.515 //y2=1.405
r242 (  56 59 ) resistor r=2.89599 //w=0.131 //l=3.035 //layer=m2 \
 //thickness=0.36 //x=70.48 //y=1.36 //x2=73.515 //y2=1.36
r243 (  54 56 ) resistor r=0.0942778 //w=0.221 //l=0.13 //layer=m2 \
 //thickness=0.36 //x=70.35 //y=1.405 //x2=70.48 //y2=1.405
r244 (  54 55 ) resistor r=0.0942778 //w=0.221 //l=0.13 //layer=m2 \
 //thickness=0.36 //x=70.35 //y=1.405 //x2=70.22 //y2=1.405
r245 (  52 55 ) resistor r=2.89599 //w=0.131 //l=3.035 //layer=m2 \
 //thickness=0.36 //x=67.185 //y=1.36 //x2=70.22 //y2=1.36
r246 (  50 52 ) resistor r=0.10734 //w=0.281 //l=0.16 //layer=m2 \
 //thickness=0.36 //x=67.025 //y=1.405 //x2=67.185 //y2=1.405
r247 (  44 58 ) resistor r=4.5 //w=0.15 //l=0.15 //layer=via1 //count=1 \
 //x=73.675 //y=1.405 //x2=73.675 //y2=1.405
r248 (  42 87 ) resistor r=9.3 //w=0.17 //l=0.17 //layer=mcon //count=1 \
 //x=73.68 //y=1.36 //x2=73.68 //y2=1.36
r249 (  42 44 ) resistor r=0.0163043 //w=0.345 //l=0.045 //layer=m1 \
 //thickness=0.36 //x=73.62 //y=1.36 //x2=73.62 //y2=1.405
r250 (  40 76 ) resistor r=9.3 //w=0.17 //l=0.17 //layer=mcon //count=1 \
 //x=73.64 //y=5.56 //x2=73.64 //y2=5.56
r251 (  38 40 ) resistor r=0.0944444 //w=0.225 //l=0.17 //layer=m1 \
 //thickness=0.36 //x=73.637 //y=5.39 //x2=73.637 //y2=5.56
r252 (  37 68 ) resistor r=9.3 //w=0.17 //l=0.17 //layer=mcon //count=1 \
 //x=72.76 //y=5.56 //x2=72.76 //y2=5.56
r253 (  35 37 ) resistor r=0.0936123 //w=0.227 //l=0.17 //layer=m1 \
 //thickness=0.36 //x=72.76 //y=5.39 //x2=72.76 //y2=5.56
r254 (  34 54 ) resistor r=4.5 //w=0.15 //l=0.15 //layer=via1 //count=1 \
 //x=70.35 //y=1.405 //x2=70.35 //y2=1.405
r255 (  32 65 ) resistor r=9.3 //w=0.17 //l=0.17 //layer=mcon //count=1 \
 //x=70.35 //y=1.36 //x2=70.35 //y2=1.36
r256 (  32 34 ) resistor r=0.0163043 //w=0.345 //l=0.045 //layer=m1 \
 //thickness=0.36 //x=70.29 //y=1.36 //x2=70.29 //y2=1.405
r257 (  30 50 ) resistor r=4.5 //w=0.15 //l=0.15 //layer=via1 //count=1 \
 //x=67.025 //y=1.405 //x2=67.025 //y2=1.405
r258 (  28 92 ) resistor r=9.3 //w=0.17 //l=0.17 //layer=mcon //count=1 \
 //x=67.02 //y=1.36 //x2=67.02 //y2=1.36
r259 (  28 30 ) resistor r=0.0150401 //w=0.374 //l=0.045 //layer=m1 \
 //thickness=0.36 //x=67.075 //y=1.36 //x2=67.075 //y2=1.405
r260 (  15 17 ) resistor r=0.0698411 //w=0.17 //l=0.120208 //layer=m1 \
 //thickness=0.36 //x=74.035 //y=1.825 //x2=74.12 //y2=1.91
r261 (  15 16 ) resistor r=0.257634 //w=0.131 //l=0.27 //layer=m1 \
 //thickness=0.36 //x=74.035 //y=1.825 //x2=73.765 //y2=1.825
r262 (  14 38 ) resistor r=0.0243946 //w=0.225 //l=0.123 //layer=m1 \
 //thickness=0.36 //x=73.76 //y=5.39 //x2=73.637 //y2=5.39
r263 (  13 18 ) resistor r=0.0698411 //w=0.17 //l=0.120208 //layer=m1 \
 //thickness=0.36 //x=74.035 //y=5.39 //x2=74.12 //y2=5.305
r264 (  13 14 ) resistor r=0.262405 //w=0.131 //l=0.275 //layer=m1 \
 //thickness=0.36 //x=74.035 //y=5.39 //x2=73.76 //y2=5.39
r265 (  12 16 ) resistor r=0.0698411 //w=0.17 //l=0.120208 //layer=m1 \
 //thickness=0.36 //x=73.68 //y=1.74 //x2=73.765 //y2=1.825
r266 (  11 44 ) resistor r=0.0792909 //w=0.345 //l=0.157162 //layer=m1 \
 //thickness=0.36 //x=73.68 //y=1.535 //x2=73.62 //y2=1.405
r267 (  11 12 ) resistor r=0.195611 //w=0.131 //l=0.205 //layer=m1 \
 //thickness=0.36 //x=73.68 //y=1.535 //x2=73.68 //y2=1.74
r268 (  10 35 ) resistor r=0.0249239 //w=0.227 //l=0.125 //layer=m1 \
 //thickness=0.36 //x=72.885 //y=5.39 //x2=72.76 //y2=5.39
r269 (  9 38 ) resistor r=0.0243946 //w=0.225 //l=0.122 //layer=m1 \
 //thickness=0.36 //x=73.515 //y=5.39 //x2=73.637 //y2=5.39
r270 (  9 10 ) resistor r=0.601145 //w=0.131 //l=0.63 //layer=m1 \
 //thickness=0.36 //x=73.515 //y=5.39 //x2=72.885 //y2=5.39
r271 (  8 18 ) resistor r=0.300573 //w=0.131 //l=0.315 //layer=m1 \
 //thickness=0.36 //x=74.12 //y=4.99 //x2=74.12 //y2=5.305
r272 (  7 8 ) resistor r=0.353053 //w=0.131 //l=0.37 //layer=m1 \
 //thickness=0.36 //x=74.12 //y=4.62 //x2=74.12 //y2=4.99
r273 (  6 7 ) resistor r=0.353053 //w=0.131 //l=0.37 //layer=m1 \
 //thickness=0.36 //x=74.12 //y=4.25 //x2=74.12 //y2=4.62
r274 (  5 6 ) resistor r=0.353053 //w=0.131 //l=0.37 //layer=m1 \
 //thickness=0.36 //x=74.12 //y=3.88 //x2=74.12 //y2=4.25
r275 (  4 5 ) resistor r=0.353053 //w=0.131 //l=0.37 //layer=m1 \
 //thickness=0.36 //x=74.12 //y=3.51 //x2=74.12 //y2=3.88
r276 (  3 4 ) resistor r=0.353053 //w=0.131 //l=0.37 //layer=m1 \
 //thickness=0.36 //x=74.12 //y=3.14 //x2=74.12 //y2=3.51
r277 (  2 3 ) resistor r=0.353053 //w=0.131 //l=0.37 //layer=m1 \
 //thickness=0.36 //x=74.12 //y=2.77 //x2=74.12 //y2=3.14
r278 (  1 2 ) resistor r=0.353053 //w=0.131 //l=0.37 //layer=m1 \
 //thickness=0.36 //x=74.12 //y=2.4 //x2=74.12 //y2=2.77
r279 (  1 17 ) resistor r=0.467557 //w=0.131 //l=0.49 //layer=m1 \
 //thickness=0.36 //x=74.12 //y=2.4 //x2=74.12 //y2=1.91
ends PM_TMRDFFQNX1\%QN

subckt PM_TMRDFFQNX1\%VDD ( 1 2 109 110 111 113 114 115 119 120 133 188 197 \
 207 215 225 241 249 275 285 311 321 343 351 377 387 413 423 433 441 457 467 \
 489 497 523 533 559 569 591 599 625 633 643 653 669 679 705 715 737 745 771 \
 781 791 807 817 829 864 879 886 891 895 900 905 909 915 920 925 929 934 939 \
 945 949 954 959 963 968 969 970 971 972 973 974 975 976 977 978 979 980 981 \
 982 983 984 985 986 987 988 989 990 991 992 993 994 995 996 997 998 999 1000 \
 1001 1002 1003 1004 1005 1006 1007 1008 1009 1010 1011 1012 1013 1014 1015 \
 1016 1017 1018 1019 1020 1021 1022 1023 1024 1025 1026 1027 1028 1029 1030 )
c1355 ( 1030 0 ) capacitor c=0.0424825f //x=67.275 //y=5.205
c1356 ( 1029 0 ) capacitor c=0.0223606f //x=66.395 //y=5.205
c1357 ( 1028 0 ) capacitor c=0.0508965f //x=65.525 //y=5.205
c1358 ( 1027 0 ) capacitor c=0.0393089f //x=63.945 //y=5.2
c1359 ( 1026 0 ) capacitor c=0.0247431f //x=63.065 //y=5.2
c1360 ( 1025 0 ) capacitor c=0.0622781f //x=62.195 //y=5.2
c1361 ( 1024 0 ) capacitor c=0.0386927f //x=60.615 //y=5.2
c1362 ( 1023 0 ) capacitor c=0.0248174f //x=59.735 //y=5.2
c1363 ( 1022 0 ) capacitor c=0.062487f //x=58.865 //y=5.2
c1364 ( 1021 0 ) capacitor c=0.0390282f //x=57.285 //y=5.2
c1365 ( 1020 0 ) capacitor c=0.0248174f //x=56.405 //y=5.2
c1366 ( 1019 0 ) capacitor c=0.0623361f //x=55.535 //y=5.2
c1367 ( 1018 0 ) capacitor c=0.039544f //x=53.955 //y=5.2
c1368 ( 1017 0 ) capacitor c=0.0248174f //x=53.075 //y=5.2
c1369 ( 1016 0 ) capacitor c=0.0623361f //x=52.205 //y=5.2
c1370 ( 1015 0 ) capacitor c=0.039544f //x=50.625 //y=5.2
c1371 ( 1014 0 ) capacitor c=0.0248174f //x=49.745 //y=5.2
c1372 ( 1013 0 ) capacitor c=0.0627254f //x=48.875 //y=5.2
c1373 ( 1012 0 ) capacitor c=0.0466891f //x=46.995 //y=5.2
c1374 ( 1011 0 ) capacitor c=0.0255836f //x=46.115 //y=5.2
c1375 ( 1010 0 ) capacitor c=0.0255777f //x=45.235 //y=5.2
c1376 ( 1009 0 ) capacitor c=0.0674366f //x=44.365 //y=5.2
c1377 ( 1008 0 ) capacitor c=0.0400462f //x=42.485 //y=5.2
c1378 ( 1007 0 ) capacitor c=0.0248174f //x=41.605 //y=5.2
c1379 ( 1006 0 ) capacitor c=0.0622502f //x=40.735 //y=5.2
c1380 ( 1005 0 ) capacitor c=0.0393089f //x=39.155 //y=5.2
c1381 ( 1004 0 ) capacitor c=0.0248174f //x=38.275 //y=5.2
c1382 ( 1003 0 ) capacitor c=0.0622502f //x=37.405 //y=5.2
c1383 ( 1002 0 ) capacitor c=0.0390282f //x=35.825 //y=5.2
c1384 ( 1001 0 ) capacitor c=0.0248174f //x=34.945 //y=5.2
c1385 ( 1000 0 ) capacitor c=0.0623361f //x=34.075 //y=5.2
c1386 ( 999 0 ) capacitor c=0.039544f //x=32.495 //y=5.2
c1387 ( 998 0 ) capacitor c=0.0248174f //x=31.615 //y=5.2
c1388 ( 997 0 ) capacitor c=0.0623361f //x=30.745 //y=5.2
c1389 ( 996 0 ) capacitor c=0.039544f //x=29.165 //y=5.2
c1390 ( 995 0 ) capacitor c=0.0248174f //x=28.285 //y=5.2
c1391 ( 994 0 ) capacitor c=0.0627254f //x=27.415 //y=5.2
c1392 ( 993 0 ) capacitor c=0.0466891f //x=25.535 //y=5.2
c1393 ( 992 0 ) capacitor c=0.0255836f //x=24.655 //y=5.2
c1394 ( 991 0 ) capacitor c=0.0255777f //x=23.775 //y=5.2
c1395 ( 990 0 ) capacitor c=0.067437f //x=22.905 //y=5.2
c1396 ( 989 0 ) capacitor c=0.0397412f //x=21.025 //y=5.2
c1397 ( 988 0 ) capacitor c=0.0248174f //x=20.145 //y=5.2
c1398 ( 987 0 ) capacitor c=0.0622502f //x=19.275 //y=5.2
c1399 ( 986 0 ) capacitor c=0.0393089f //x=17.695 //y=5.2
c1400 ( 985 0 ) capacitor c=0.0248174f //x=16.815 //y=5.2
c1401 ( 984 0 ) capacitor c=0.0622535f //x=15.945 //y=5.2
c1402 ( 983 0 ) capacitor c=0.0390282f //x=14.365 //y=5.2
c1403 ( 982 0 ) capacitor c=0.0248174f //x=13.485 //y=5.2
c1404 ( 981 0 ) capacitor c=0.0623361f //x=12.615 //y=5.2
c1405 ( 980 0 ) capacitor c=0.039544f //x=11.035 //y=5.2
c1406 ( 979 0 ) capacitor c=0.0248174f //x=10.155 //y=5.2
c1407 ( 978 0 ) capacitor c=0.0623361f //x=9.285 //y=5.2
c1408 ( 977 0 ) capacitor c=0.039544f //x=7.705 //y=5.2
c1409 ( 976 0 ) capacitor c=0.0248174f //x=6.825 //y=5.2
c1410 ( 975 0 ) capacitor c=0.0627254f //x=5.955 //y=5.2
c1411 ( 974 0 ) capacitor c=0.0466891f //x=4.075 //y=5.2
c1412 ( 973 0 ) capacitor c=0.0255836f //x=3.195 //y=5.2
c1413 ( 972 0 ) capacitor c=0.0256114f //x=2.315 //y=5.2
c1414 ( 971 0 ) capacitor c=0.0693239f //x=1.445 //y=5.2
c1415 ( 970 0 ) capacitor c=0.120833f //x=71.53 //y=7.585
c1416 ( 969 0 ) capacitor c=0.125864f //x=68.2 //y=7.585
c1417 ( 968 0 ) capacitor c=0.123835f //x=64.87 //y=7.585
c1418 ( 967 0 ) capacitor c=0.00597439f //x=64.13 //y=7.58
c1419 ( 965 0 ) capacitor c=0.00597439f //x=63.21 //y=7.585
c1420 ( 964 0 ) capacitor c=0.00597439f //x=62.33 //y=7.585
c1421 ( 963 0 ) capacitor c=0.123626f //x=61.54 //y=7.585
c1422 ( 962 0 ) capacitor c=0.00597439f //x=60.76 //y=7.585
c1423 ( 961 0 ) capacitor c=0.00597439f //x=59.88 //y=7.585
c1424 ( 960 0 ) capacitor c=0.00597439f //x=59 //y=7.585
c1425 ( 959 0 ) capacitor c=0.126753f //x=58.21 //y=7.585
c1426 ( 958 0 ) capacitor c=0.00597439f //x=57.43 //y=7.585
c1427 ( 957 0 ) capacitor c=0.00597439f //x=56.55 //y=7.585
c1428 ( 956 0 ) capacitor c=0.00597439f //x=55.62 //y=7.58
c1429 ( 954 0 ) capacitor c=0.126609f //x=54.88 //y=7.585
c1430 ( 953 0 ) capacitor c=0.00597439f //x=54.14 //y=7.58
c1431 ( 951 0 ) capacitor c=0.00597439f //x=53.22 //y=7.585
c1432 ( 950 0 ) capacitor c=0.00597439f //x=52.34 //y=7.585
c1433 ( 949 0 ) capacitor c=0.126767f //x=51.55 //y=7.585
c1434 ( 948 0 ) capacitor c=0.00597439f //x=50.77 //y=7.585
c1435 ( 947 0 ) capacitor c=0.00597439f //x=49.89 //y=7.585
c1436 ( 946 0 ) capacitor c=0.00597439f //x=49.01 //y=7.585
c1437 ( 945 0 ) capacitor c=0.145722f //x=48.22 //y=7.585
c1438 ( 944 0 ) capacitor c=0.00597439f //x=47.14 //y=7.585
c1439 ( 943 0 ) capacitor c=0.00597439f //x=46.26 //y=7.585
c1440 ( 942 0 ) capacitor c=0.00597439f //x=45.38 //y=7.585
c1441 ( 941 0 ) capacitor c=0.00597439f //x=44.52 //y=7.58
c1442 ( 939 0 ) capacitor c=0.145674f //x=43.41 //y=7.585
c1443 ( 938 0 ) capacitor c=0.00597439f //x=42.63 //y=7.585
c1444 ( 937 0 ) capacitor c=0.00597439f //x=41.75 //y=7.585
c1445 ( 936 0 ) capacitor c=0.00597439f //x=40.82 //y=7.58
c1446 ( 934 0 ) capacitor c=0.126767f //x=40.08 //y=7.585
c1447 ( 933 0 ) capacitor c=0.00597439f //x=39.34 //y=7.58
c1448 ( 931 0 ) capacitor c=0.00597439f //x=38.42 //y=7.585
c1449 ( 930 0 ) capacitor c=0.00597439f //x=37.54 //y=7.585
c1450 ( 929 0 ) capacitor c=0.125969f //x=36.75 //y=7.585
c1451 ( 928 0 ) capacitor c=0.00597439f //x=35.97 //y=7.585
c1452 ( 927 0 ) capacitor c=0.00597439f //x=35.09 //y=7.585
c1453 ( 926 0 ) capacitor c=0.00597439f //x=34.21 //y=7.585
c1454 ( 925 0 ) capacitor c=0.126609f //x=33.42 //y=7.585
c1455 ( 924 0 ) capacitor c=0.00597439f //x=32.64 //y=7.585
c1456 ( 923 0 ) capacitor c=0.00597439f //x=31.76 //y=7.585
c1457 ( 922 0 ) capacitor c=0.00597439f //x=30.83 //y=7.58
c1458 ( 920 0 ) capacitor c=0.126767f //x=30.09 //y=7.585
c1459 ( 919 0 ) capacitor c=0.00597439f //x=29.35 //y=7.58
c1460 ( 917 0 ) capacitor c=0.00597439f //x=28.43 //y=7.585
c1461 ( 916 0 ) capacitor c=0.00597439f //x=27.55 //y=7.585
c1462 ( 915 0 ) capacitor c=0.145722f //x=26.76 //y=7.585
c1463 ( 914 0 ) capacitor c=0.00597439f //x=25.65 //y=7.58
c1464 ( 912 0 ) capacitor c=0.00597439f //x=24.8 //y=7.585
c1465 ( 911 0 ) capacitor c=0.00597439f //x=23.92 //y=7.585
c1466 ( 910 0 ) capacitor c=0.00597439f //x=23.04 //y=7.585
c1467 ( 909 0 ) capacitor c=0.145674f //x=21.95 //y=7.585
c1468 ( 908 0 ) capacitor c=0.00597439f //x=21.17 //y=7.585
c1469 ( 907 0 ) capacitor c=0.00597439f //x=20.29 //y=7.585
c1470 ( 906 0 ) capacitor c=0.00597439f //x=19.41 //y=7.585
c1471 ( 905 0 ) capacitor c=0.126767f //x=18.62 //y=7.585
c1472 ( 904 0 ) capacitor c=0.00597439f //x=17.84 //y=7.585
c1473 ( 903 0 ) capacitor c=0.00597439f //x=16.96 //y=7.585
c1474 ( 902 0 ) capacitor c=0.00597439f //x=16.03 //y=7.58
c1475 ( 900 0 ) capacitor c=0.126076f //x=15.29 //y=7.585
c1476 ( 899 0 ) capacitor c=0.00597439f //x=14.55 //y=7.58
c1477 ( 897 0 ) capacitor c=0.00597439f //x=13.63 //y=7.585
c1478 ( 896 0 ) capacitor c=0.00597439f //x=12.75 //y=7.585
c1479 ( 895 0 ) capacitor c=0.126609f //x=11.96 //y=7.585
c1480 ( 894 0 ) capacitor c=0.00597439f //x=11.18 //y=7.585
c1481 ( 893 0 ) capacitor c=0.00597439f //x=10.3 //y=7.585
c1482 ( 892 0 ) capacitor c=0.00597439f //x=9.42 //y=7.585
c1483 ( 891 0 ) capacitor c=0.126767f //x=8.63 //y=7.585
c1484 ( 890 0 ) capacitor c=0.00597439f //x=7.85 //y=7.585
c1485 ( 889 0 ) capacitor c=0.00597439f //x=6.97 //y=7.585
c1486 ( 888 0 ) capacitor c=0.00597439f //x=6.04 //y=7.58
c1487 ( 886 0 ) capacitor c=0.145722f //x=5.3 //y=7.585
c1488 ( 885 0 ) capacitor c=0.00597439f //x=4.22 //y=7.585
c1489 ( 884 0 ) capacitor c=0.00597439f //x=3.34 //y=7.585
c1490 ( 883 0 ) capacitor c=0.00597439f //x=2.46 //y=7.585
c1491 ( 882 0 ) capacitor c=0.00597439f //x=1.58 //y=7.585
c1492 ( 879 0 ) capacitor c=0.369119f //x=74.12 //y=7.58
c1493 ( 864 0 ) capacitor c=0.131873f //x=71.36 //y=7.585
c1494 ( 829 0 ) capacitor c=0.133054f //x=68.03 //y=7.585
c1495 ( 825 0 ) capacitor c=0.0277785f //x=64.7 //y=7.585
c1496 ( 817 0 ) capacitor c=0.0287376f //x=64.005 //y=7.585
c1497 ( 807 0 ) capacitor c=0.0291078f //x=63.125 //y=7.585
c1498 ( 795 0 ) capacitor c=0.0283511f //x=62.245 //y=7.585
c1499 ( 791 0 ) capacitor c=0.0261965f //x=61.37 //y=7.585
c1500 ( 781 0 ) capacitor c=0.0287375f //x=60.675 //y=7.585
c1501 ( 771 0 ) capacitor c=0.0291078f //x=59.795 //y=7.585
c1502 ( 761 0 ) capacitor c=0.0283511f //x=58.915 //y=7.585
c1503 ( 755 0 ) capacitor c=0.0273918f //x=58.04 //y=7.585
c1504 ( 745 0 ) capacitor c=0.0287377f //x=57.345 //y=7.585
c1505 ( 737 0 ) capacitor c=0.0291078f //x=56.465 //y=7.585
c1506 ( 727 0 ) capacitor c=0.0283511f //x=55.585 //y=7.585
c1507 ( 723 0 ) capacitor c=0.0277785f //x=54.71 //y=7.585
c1508 ( 715 0 ) capacitor c=0.0287376f //x=54.015 //y=7.585
c1509 ( 705 0 ) capacitor c=0.0291078f //x=53.135 //y=7.585
c1510 ( 693 0 ) capacitor c=0.0283511f //x=52.255 //y=7.585
c1511 ( 689 0 ) capacitor c=0.0277785f //x=51.38 //y=7.585
c1512 ( 679 0 ) capacitor c=0.0287375f //x=50.685 //y=7.585
c1513 ( 669 0 ) capacitor c=0.0291078f //x=49.805 //y=7.585
c1514 ( 659 0 ) capacitor c=0.0283511f //x=48.925 //y=7.585
c1515 ( 653 0 ) capacitor c=0.042257f //x=48.05 //y=7.585
c1516 ( 643 0 ) capacitor c=0.0288858f //x=47.055 //y=7.585
c1517 ( 633 0 ) capacitor c=0.0288441f //x=46.175 //y=7.585
c1518 ( 625 0 ) capacitor c=0.0289834f //x=45.295 //y=7.585
c1519 ( 615 0 ) capacitor c=0.0455283f //x=44.415 //y=7.585
c1520 ( 609 0 ) capacitor c=0.0277785f //x=43.24 //y=7.585
c1521 ( 599 0 ) capacitor c=0.0287376f //x=42.545 //y=7.585
c1522 ( 591 0 ) capacitor c=0.0291078f //x=41.665 //y=7.585
c1523 ( 581 0 ) capacitor c=0.0283511f //x=40.785 //y=7.585
c1524 ( 577 0 ) capacitor c=0.0277785f //x=39.91 //y=7.585
c1525 ( 569 0 ) capacitor c=0.0287375f //x=39.215 //y=7.585
c1526 ( 559 0 ) capacitor c=0.0291078f //x=38.335 //y=7.585
c1527 ( 547 0 ) capacitor c=0.0283511f //x=37.455 //y=7.585
c1528 ( 543 0 ) capacitor c=0.0273918f //x=36.58 //y=7.585
c1529 ( 533 0 ) capacitor c=0.0287377f //x=35.885 //y=7.585
c1530 ( 523 0 ) capacitor c=0.0291078f //x=35.005 //y=7.585
c1531 ( 513 0 ) capacitor c=0.0283511f //x=34.125 //y=7.585
c1532 ( 507 0 ) capacitor c=0.0277785f //x=33.25 //y=7.585
c1533 ( 497 0 ) capacitor c=0.0287376f //x=32.555 //y=7.585
c1534 ( 489 0 ) capacitor c=0.0291078f //x=31.675 //y=7.585
c1535 ( 479 0 ) capacitor c=0.0283511f //x=30.795 //y=7.585
c1536 ( 475 0 ) capacitor c=0.0277785f //x=29.92 //y=7.585
c1537 ( 467 0 ) capacitor c=0.0287375f //x=29.225 //y=7.585
c1538 ( 457 0 ) capacitor c=0.0291078f //x=28.345 //y=7.585
c1539 ( 445 0 ) capacitor c=0.0283511f //x=27.465 //y=7.585
c1540 ( 441 0 ) capacitor c=0.042257f //x=26.59 //y=7.585
c1541 ( 433 0 ) capacitor c=0.0288858f //x=25.595 //y=7.585
c1542 ( 423 0 ) capacitor c=0.0288441f //x=24.715 //y=7.585
c1543 ( 413 0 ) capacitor c=0.0289834f //x=23.835 //y=7.585
c1544 ( 401 0 ) capacitor c=0.0455283f //x=22.955 //y=7.585
c1545 ( 397 0 ) capacitor c=0.0277785f //x=21.78 //y=7.585
c1546 ( 387 0 ) capacitor c=0.0287376f //x=21.085 //y=7.585
c1547 ( 377 0 ) capacitor c=0.0291078f //x=20.205 //y=7.585
c1548 ( 367 0 ) capacitor c=0.0283511f //x=19.325 //y=7.585
c1549 ( 361 0 ) capacitor c=0.0277785f //x=18.45 //y=7.585
c1550 ( 351 0 ) capacitor c=0.0287375f //x=17.755 //y=7.585
c1551 ( 343 0 ) capacitor c=0.0291078f //x=16.875 //y=7.585
c1552 ( 333 0 ) capacitor c=0.0283511f //x=15.995 //y=7.585
c1553 ( 329 0 ) capacitor c=0.0273918f //x=15.12 //y=7.585
c1554 ( 321 0 ) capacitor c=0.0287377f //x=14.425 //y=7.585
c1555 ( 311 0 ) capacitor c=0.0291078f //x=13.545 //y=7.585
c1556 ( 299 0 ) capacitor c=0.0283511f //x=12.665 //y=7.585
c1557 ( 295 0 ) capacitor c=0.0277785f //x=11.79 //y=7.585
c1558 ( 285 0 ) capacitor c=0.0287376f //x=11.095 //y=7.585
c1559 ( 275 0 ) capacitor c=0.0291078f //x=10.215 //y=7.585
c1560 ( 265 0 ) capacitor c=0.0283511f //x=9.335 //y=7.585
c1561 ( 259 0 ) capacitor c=0.0277785f //x=8.46 //y=7.585
c1562 ( 249 0 ) capacitor c=0.0287375f //x=7.765 //y=7.585
c1563 ( 241 0 ) capacitor c=0.0291078f //x=6.885 //y=7.585
c1564 ( 231 0 ) capacitor c=0.0283511f //x=6.005 //y=7.585
c1565 ( 225 0 ) capacitor c=0.042257f //x=5.13 //y=7.585
c1566 ( 215 0 ) capacitor c=0.0288858f //x=4.135 //y=7.585
c1567 ( 207 0 ) capacitor c=0.0288441f //x=3.255 //y=7.585
c1568 ( 197 0 ) capacitor c=0.0289834f //x=2.375 //y=7.585
c1569 ( 188 0 ) capacitor c=0.253472f //x=1.23 //y=7.58
c1570 ( 185 0 ) capacitor c=0.0455283f //x=1.495 //y=7.585
c1571 ( 180 0 ) capacitor c=0.00499323f //x=67.42 //y=7.585
c1572 ( 177 0 ) capacitor c=0.00499323f //x=66.54 //y=7.585
c1573 ( 172 0 ) capacitor c=0.00499323f //x=65.61 //y=7.58
c1574 ( 133 0 ) capacitor c=0.270843f //x=74.12 //y=7.58
c1575 ( 120 0 ) capacitor c=0.00657976f //x=67.42 //y=7.41
c1576 ( 119 0 ) capacitor c=0.00827249f //x=67.42 //y=7.035
c1577 ( 115 0 ) capacitor c=0.0220779f //x=67.335 //y=7.585
c1578 ( 114 0 ) capacitor c=0.00369726f //x=66.54 //y=7.41
c1579 ( 113 0 ) capacitor c=0.00650208f //x=66.54 //y=7.035
c1580 ( 111 0 ) capacitor c=0.02242f //x=66.455 //y=7.585
c1581 ( 110 0 ) capacitor c=0.0090067f //x=65.66 //y=7.41
c1582 ( 109 0 ) capacitor c=0.0125184f //x=65.66 //y=7.035
c1583 ( 2 0 ) capacitor c=2.32864f //x=65.575 //y=7.585
r1584 (  877 879 ) resistor r=38.7139 //w=0.367 //l=1.11 //layer=li \
 //thickness=0.1 //x=73.01 //y=7.585 //x2=74.12 //y2=7.585
r1585 (  875 877 ) resistor r=38.7139 //w=0.367 //l=1.11 //layer=li \
 //thickness=0.1 //x=71.9 //y=7.585 //x2=73.01 //y2=7.585
r1586 (  873 970 ) resistor r=5.29055 //w=0.35 //l=0.17 //layer=li \
 //thickness=0.1 //x=71.7 //y=7.585 //x2=71.53 //y2=7.585
r1587 (  873 875 ) resistor r=6.97548 //w=0.367 //l=0.2 //layer=li \
 //thickness=0.1 //x=71.7 //y=7.585 //x2=71.9 //y2=7.585
r1588 (  867 869 ) resistor r=38.7139 //w=0.367 //l=1.11 //layer=li \
 //thickness=0.1 //x=69.31 //y=7.585 //x2=70.42 //y2=7.585
r1589 (  865 969 ) resistor r=5.29055 //w=0.35 //l=0.17 //layer=li \
 //thickness=0.1 //x=68.37 //y=7.585 //x2=68.2 //y2=7.585
r1590 (  865 867 ) resistor r=32.7847 //w=0.367 //l=0.94 //layer=li \
 //thickness=0.1 //x=68.37 //y=7.585 //x2=69.31 //y2=7.585
r1591 (  864 970 ) resistor r=5.29055 //w=0.35 //l=0.17 //layer=li \
 //thickness=0.1 //x=71.36 //y=7.585 //x2=71.53 //y2=7.585
r1592 (  864 869 ) resistor r=32.7847 //w=0.367 //l=0.94 //layer=li \
 //thickness=0.1 //x=71.36 //y=7.585 //x2=70.42 //y2=7.585
r1593 (  860 1030 ) resistor r=23.2727 //w=0.187 //l=0.34 //layer=li \
 //thickness=0.1 //x=67.42 //y=6.92 //x2=67.42 //y2=6.58
r1594 (  845 1028 ) resistor r=23.2727 //w=0.187 //l=0.34 //layer=li \
 //thickness=0.1 //x=65.66 //y=6.92 //x2=65.66 //y2=6.58
r1595 (  834 836 ) resistor r=38.7139 //w=0.367 //l=1.11 //layer=li \
 //thickness=0.1 //x=66.72 //y=7.585 //x2=67.83 //y2=7.585
r1596 (  832 834 ) resistor r=38.7139 //w=0.367 //l=1.11 //layer=li \
 //thickness=0.1 //x=65.61 //y=7.585 //x2=66.72 //y2=7.585
r1597 (  830 968 ) resistor r=5.29055 //w=0.35 //l=0.17 //layer=li \
 //thickness=0.1 //x=65.04 //y=7.585 //x2=64.87 //y2=7.585
r1598 (  830 832 ) resistor r=19.8801 //w=0.367 //l=0.57 //layer=li \
 //thickness=0.1 //x=65.04 //y=7.585 //x2=65.61 //y2=7.585
r1599 (  829 969 ) resistor r=5.29055 //w=0.35 //l=0.17 //layer=li \
 //thickness=0.1 //x=68.03 //y=7.585 //x2=68.2 //y2=7.585
r1600 (  829 836 ) resistor r=6.97548 //w=0.367 //l=0.2 //layer=li \
 //thickness=0.1 //x=68.03 //y=7.585 //x2=67.83 //y2=7.585
r1601 (  826 967 ) resistor r=2.87058 //w=0.35 //l=0.085 //layer=li \
 //thickness=0.1 //x=64.175 //y=7.585 //x2=64.09 //y2=7.585
r1602 (  825 968 ) resistor r=5.29055 //w=0.35 //l=0.17 //layer=li \
 //thickness=0.1 //x=64.7 //y=7.585 //x2=64.87 //y2=7.585
r1603 (  825 826 ) resistor r=18.3106 //w=0.367 //l=0.525 //layer=li \
 //thickness=0.1 //x=64.7 //y=7.585 //x2=64.175 //y2=7.585
r1604 (  819 967 ) resistor r=4.23183 //w=0.7 //l=0.175 //layer=li \
 //thickness=0.1 //x=64.09 //y=7.41 //x2=64.09 //y2=7.585
r1605 (  819 1027 ) resistor r=33.1979 //w=0.187 //l=0.485 //layer=li \
 //thickness=0.1 //x=64.09 //y=7.41 //x2=64.09 //y2=6.925
r1606 (  818 965 ) resistor r=2.87058 //w=0.35 //l=0.085 //layer=li \
 //thickness=0.1 //x=63.295 //y=7.585 //x2=63.21 //y2=7.585
r1607 (  817 967 ) resistor r=2.87058 //w=0.35 //l=0.085 //layer=li \
 //thickness=0.1 //x=64.005 //y=7.585 //x2=64.09 //y2=7.585
r1608 (  817 818 ) resistor r=24.7629 //w=0.367 //l=0.71 //layer=li \
 //thickness=0.1 //x=64.005 //y=7.585 //x2=63.295 //y2=7.585
r1609 (  811 965 ) resistor r=4.23183 //w=0.7 //l=0.175 //layer=li \
 //thickness=0.1 //x=63.21 //y=7.41 //x2=63.21 //y2=7.585
r1610 (  811 1026 ) resistor r=33.1979 //w=0.187 //l=0.485 //layer=li \
 //thickness=0.1 //x=63.21 //y=7.41 //x2=63.21 //y2=6.925
r1611 (  808 964 ) resistor r=2.87058 //w=0.35 //l=0.085 //layer=li \
 //thickness=0.1 //x=62.415 //y=7.585 //x2=62.33 //y2=7.585
r1612 (  808 810 ) resistor r=21.1008 //w=0.367 //l=0.605 //layer=li \
 //thickness=0.1 //x=62.415 //y=7.585 //x2=63.02 //y2=7.585
r1613 (  807 965 ) resistor r=2.87058 //w=0.35 //l=0.085 //layer=li \
 //thickness=0.1 //x=63.125 //y=7.585 //x2=63.21 //y2=7.585
r1614 (  807 810 ) resistor r=3.66213 //w=0.367 //l=0.105 //layer=li \
 //thickness=0.1 //x=63.125 //y=7.585 //x2=63.02 //y2=7.585
r1615 (  799 964 ) resistor r=4.23183 //w=0.7 //l=0.175 //layer=li \
 //thickness=0.1 //x=62.33 //y=7.41 //x2=62.33 //y2=7.585
r1616 (  799 1025 ) resistor r=56.4706 //w=0.187 //l=0.825 //layer=li \
 //thickness=0.1 //x=62.33 //y=7.41 //x2=62.33 //y2=6.585
r1617 (  796 963 ) resistor r=5.29055 //w=0.35 //l=0.17 //layer=li \
 //thickness=0.1 //x=61.71 //y=7.585 //x2=61.54 //y2=7.585
r1618 (  796 798 ) resistor r=6.97548 //w=0.367 //l=0.2 //layer=li \
 //thickness=0.1 //x=61.71 //y=7.585 //x2=61.91 //y2=7.585
r1619 (  795 964 ) resistor r=2.87058 //w=0.35 //l=0.085 //layer=li \
 //thickness=0.1 //x=62.245 //y=7.585 //x2=62.33 //y2=7.585
r1620 (  795 798 ) resistor r=11.6839 //w=0.367 //l=0.335 //layer=li \
 //thickness=0.1 //x=62.245 //y=7.585 //x2=61.91 //y2=7.585
r1621 (  792 962 ) resistor r=2.87058 //w=0.35 //l=0.085 //layer=li \
 //thickness=0.1 //x=60.845 //y=7.585 //x2=60.76 //y2=7.585
r1622 (  791 963 ) resistor r=5.29055 //w=0.35 //l=0.17 //layer=li \
 //thickness=0.1 //x=61.37 //y=7.585 //x2=61.54 //y2=7.585
r1623 (  791 792 ) resistor r=18.3106 //w=0.367 //l=0.525 //layer=li \
 //thickness=0.1 //x=61.37 //y=7.585 //x2=60.845 //y2=7.585
r1624 (  785 962 ) resistor r=4.23183 //w=0.7 //l=0.175 //layer=li \
 //thickness=0.1 //x=60.76 //y=7.41 //x2=60.76 //y2=7.585
r1625 (  785 1024 ) resistor r=33.1979 //w=0.187 //l=0.485 //layer=li \
 //thickness=0.1 //x=60.76 //y=7.41 //x2=60.76 //y2=6.925
r1626 (  782 961 ) resistor r=2.87058 //w=0.35 //l=0.085 //layer=li \
 //thickness=0.1 //x=59.965 //y=7.585 //x2=59.88 //y2=7.585
r1627 (  782 784 ) resistor r=16.218 //w=0.367 //l=0.465 //layer=li \
 //thickness=0.1 //x=59.965 //y=7.585 //x2=60.43 //y2=7.585
r1628 (  781 962 ) resistor r=2.87058 //w=0.35 //l=0.085 //layer=li \
 //thickness=0.1 //x=60.675 //y=7.585 //x2=60.76 //y2=7.585
r1629 (  781 784 ) resistor r=8.54496 //w=0.367 //l=0.245 //layer=li \
 //thickness=0.1 //x=60.675 //y=7.585 //x2=60.43 //y2=7.585
r1630 (  775 961 ) resistor r=4.23183 //w=0.7 //l=0.175 //layer=li \
 //thickness=0.1 //x=59.88 //y=7.41 //x2=59.88 //y2=7.585
r1631 (  775 1023 ) resistor r=33.1979 //w=0.187 //l=0.485 //layer=li \
 //thickness=0.1 //x=59.88 //y=7.41 //x2=59.88 //y2=6.925
r1632 (  772 960 ) resistor r=2.87058 //w=0.35 //l=0.085 //layer=li \
 //thickness=0.1 //x=59.085 //y=7.585 //x2=59 //y2=7.585
r1633 (  772 774 ) resistor r=8.19619 //w=0.367 //l=0.235 //layer=li \
 //thickness=0.1 //x=59.085 //y=7.585 //x2=59.32 //y2=7.585
r1634 (  771 961 ) resistor r=2.87058 //w=0.35 //l=0.085 //layer=li \
 //thickness=0.1 //x=59.795 //y=7.585 //x2=59.88 //y2=7.585
r1635 (  771 774 ) resistor r=16.5668 //w=0.367 //l=0.475 //layer=li \
 //thickness=0.1 //x=59.795 //y=7.585 //x2=59.32 //y2=7.585
r1636 (  763 960 ) resistor r=4.23183 //w=0.7 //l=0.175 //layer=li \
 //thickness=0.1 //x=59 //y=7.41 //x2=59 //y2=7.585
r1637 (  763 1022 ) resistor r=56.4706 //w=0.187 //l=0.825 //layer=li \
 //thickness=0.1 //x=59 //y=7.41 //x2=59 //y2=6.585
r1638 (  762 959 ) resistor r=5.29055 //w=0.35 //l=0.17 //layer=li \
 //thickness=0.1 //x=58.38 //y=7.585 //x2=58.21 //y2=7.585
r1639 (  761 960 ) resistor r=2.87058 //w=0.35 //l=0.085 //layer=li \
 //thickness=0.1 //x=58.915 //y=7.585 //x2=59 //y2=7.585
r1640 (  761 762 ) resistor r=18.6594 //w=0.367 //l=0.535 //layer=li \
 //thickness=0.1 //x=58.915 //y=7.585 //x2=58.38 //y2=7.585
r1641 (  756 958 ) resistor r=2.87058 //w=0.35 //l=0.085 //layer=li \
 //thickness=0.1 //x=57.515 //y=7.585 //x2=57.43 //y2=7.585
r1642 (  756 758 ) resistor r=11.3351 //w=0.367 //l=0.325 //layer=li \
 //thickness=0.1 //x=57.515 //y=7.585 //x2=57.84 //y2=7.585
r1643 (  755 959 ) resistor r=5.29055 //w=0.35 //l=0.17 //layer=li \
 //thickness=0.1 //x=58.04 //y=7.585 //x2=58.21 //y2=7.585
r1644 (  755 758 ) resistor r=6.97548 //w=0.367 //l=0.2 //layer=li \
 //thickness=0.1 //x=58.04 //y=7.585 //x2=57.84 //y2=7.585
r1645 (  749 958 ) resistor r=4.23183 //w=0.7 //l=0.175 //layer=li \
 //thickness=0.1 //x=57.43 //y=7.41 //x2=57.43 //y2=7.585
r1646 (  749 1021 ) resistor r=33.1979 //w=0.187 //l=0.485 //layer=li \
 //thickness=0.1 //x=57.43 //y=7.41 //x2=57.43 //y2=6.925
r1647 (  746 957 ) resistor r=2.87058 //w=0.35 //l=0.085 //layer=li \
 //thickness=0.1 //x=56.635 //y=7.585 //x2=56.55 //y2=7.585
r1648 (  746 748 ) resistor r=3.31335 //w=0.367 //l=0.095 //layer=li \
 //thickness=0.1 //x=56.635 //y=7.585 //x2=56.73 //y2=7.585
r1649 (  745 958 ) resistor r=2.87058 //w=0.35 //l=0.085 //layer=li \
 //thickness=0.1 //x=57.345 //y=7.585 //x2=57.43 //y2=7.585
r1650 (  745 748 ) resistor r=21.4496 //w=0.367 //l=0.615 //layer=li \
 //thickness=0.1 //x=57.345 //y=7.585 //x2=56.73 //y2=7.585
r1651 (  739 957 ) resistor r=4.23183 //w=0.7 //l=0.175 //layer=li \
 //thickness=0.1 //x=56.55 //y=7.41 //x2=56.55 //y2=7.585
r1652 (  739 1020 ) resistor r=33.1979 //w=0.187 //l=0.485 //layer=li \
 //thickness=0.1 //x=56.55 //y=7.41 //x2=56.55 //y2=6.925
r1653 (  738 956 ) resistor r=2.87058 //w=0.35 //l=0.085 //layer=li \
 //thickness=0.1 //x=55.755 //y=7.585 //x2=55.67 //y2=7.585
r1654 (  737 957 ) resistor r=2.87058 //w=0.35 //l=0.085 //layer=li \
 //thickness=0.1 //x=56.465 //y=7.585 //x2=56.55 //y2=7.585
r1655 (  737 738 ) resistor r=24.7629 //w=0.367 //l=0.71 //layer=li \
 //thickness=0.1 //x=56.465 //y=7.585 //x2=55.755 //y2=7.585
r1656 (  729 956 ) resistor r=4.23183 //w=0.7 //l=0.175 //layer=li \
 //thickness=0.1 //x=55.67 //y=7.41 //x2=55.67 //y2=7.585
r1657 (  729 1019 ) resistor r=56.4706 //w=0.187 //l=0.825 //layer=li \
 //thickness=0.1 //x=55.67 //y=7.41 //x2=55.67 //y2=6.585
r1658 (  728 954 ) resistor r=5.29055 //w=0.35 //l=0.17 //layer=li \
 //thickness=0.1 //x=55.05 //y=7.585 //x2=54.88 //y2=7.585
r1659 (  727 956 ) resistor r=2.87058 //w=0.35 //l=0.085 //layer=li \
 //thickness=0.1 //x=55.585 //y=7.585 //x2=55.67 //y2=7.585
r1660 (  727 728 ) resistor r=18.6594 //w=0.367 //l=0.535 //layer=li \
 //thickness=0.1 //x=55.585 //y=7.585 //x2=55.05 //y2=7.585
r1661 (  724 953 ) resistor r=2.87058 //w=0.35 //l=0.085 //layer=li \
 //thickness=0.1 //x=54.185 //y=7.585 //x2=54.1 //y2=7.585
r1662 (  723 954 ) resistor r=5.29055 //w=0.35 //l=0.17 //layer=li \
 //thickness=0.1 //x=54.71 //y=7.585 //x2=54.88 //y2=7.585
r1663 (  723 724 ) resistor r=18.3106 //w=0.367 //l=0.525 //layer=li \
 //thickness=0.1 //x=54.71 //y=7.585 //x2=54.185 //y2=7.585
r1664 (  717 953 ) resistor r=4.23183 //w=0.7 //l=0.175 //layer=li \
 //thickness=0.1 //x=54.1 //y=7.41 //x2=54.1 //y2=7.585
r1665 (  717 1018 ) resistor r=33.1979 //w=0.187 //l=0.485 //layer=li \
 //thickness=0.1 //x=54.1 //y=7.41 //x2=54.1 //y2=6.925
r1666 (  716 951 ) resistor r=2.87058 //w=0.35 //l=0.085 //layer=li \
 //thickness=0.1 //x=53.305 //y=7.585 //x2=53.22 //y2=7.585
r1667 (  715 953 ) resistor r=2.87058 //w=0.35 //l=0.085 //layer=li \
 //thickness=0.1 //x=54.015 //y=7.585 //x2=54.1 //y2=7.585
r1668 (  715 716 ) resistor r=24.7629 //w=0.367 //l=0.71 //layer=li \
 //thickness=0.1 //x=54.015 //y=7.585 //x2=53.305 //y2=7.585
r1669 (  709 951 ) resistor r=4.23183 //w=0.7 //l=0.175 //layer=li \
 //thickness=0.1 //x=53.22 //y=7.41 //x2=53.22 //y2=7.585
r1670 (  709 1017 ) resistor r=33.1979 //w=0.187 //l=0.485 //layer=li \
 //thickness=0.1 //x=53.22 //y=7.41 //x2=53.22 //y2=6.925
r1671 (  706 950 ) resistor r=2.87058 //w=0.35 //l=0.085 //layer=li \
 //thickness=0.1 //x=52.425 //y=7.585 //x2=52.34 //y2=7.585
r1672 (  706 708 ) resistor r=21.1008 //w=0.367 //l=0.605 //layer=li \
 //thickness=0.1 //x=52.425 //y=7.585 //x2=53.03 //y2=7.585
r1673 (  705 951 ) resistor r=2.87058 //w=0.35 //l=0.085 //layer=li \
 //thickness=0.1 //x=53.135 //y=7.585 //x2=53.22 //y2=7.585
r1674 (  705 708 ) resistor r=3.66213 //w=0.367 //l=0.105 //layer=li \
 //thickness=0.1 //x=53.135 //y=7.585 //x2=53.03 //y2=7.585
r1675 (  697 950 ) resistor r=4.23183 //w=0.7 //l=0.175 //layer=li \
 //thickness=0.1 //x=52.34 //y=7.41 //x2=52.34 //y2=7.585
r1676 (  697 1016 ) resistor r=56.4706 //w=0.187 //l=0.825 //layer=li \
 //thickness=0.1 //x=52.34 //y=7.41 //x2=52.34 //y2=6.585
r1677 (  694 949 ) resistor r=5.29055 //w=0.35 //l=0.17 //layer=li \
 //thickness=0.1 //x=51.72 //y=7.585 //x2=51.55 //y2=7.585
r1678 (  694 696 ) resistor r=6.97548 //w=0.367 //l=0.2 //layer=li \
 //thickness=0.1 //x=51.72 //y=7.585 //x2=51.92 //y2=7.585
r1679 (  693 950 ) resistor r=2.87058 //w=0.35 //l=0.085 //layer=li \
 //thickness=0.1 //x=52.255 //y=7.585 //x2=52.34 //y2=7.585
r1680 (  693 696 ) resistor r=11.6839 //w=0.367 //l=0.335 //layer=li \
 //thickness=0.1 //x=52.255 //y=7.585 //x2=51.92 //y2=7.585
r1681 (  690 948 ) resistor r=2.87058 //w=0.35 //l=0.085 //layer=li \
 //thickness=0.1 //x=50.855 //y=7.585 //x2=50.77 //y2=7.585
r1682 (  689 949 ) resistor r=5.29055 //w=0.35 //l=0.17 //layer=li \
 //thickness=0.1 //x=51.38 //y=7.585 //x2=51.55 //y2=7.585
r1683 (  689 690 ) resistor r=18.3106 //w=0.367 //l=0.525 //layer=li \
 //thickness=0.1 //x=51.38 //y=7.585 //x2=50.855 //y2=7.585
r1684 (  683 948 ) resistor r=4.23183 //w=0.7 //l=0.175 //layer=li \
 //thickness=0.1 //x=50.77 //y=7.41 //x2=50.77 //y2=7.585
r1685 (  683 1015 ) resistor r=33.1979 //w=0.187 //l=0.485 //layer=li \
 //thickness=0.1 //x=50.77 //y=7.41 //x2=50.77 //y2=6.925
r1686 (  680 947 ) resistor r=2.87058 //w=0.35 //l=0.085 //layer=li \
 //thickness=0.1 //x=49.975 //y=7.585 //x2=49.89 //y2=7.585
r1687 (  680 682 ) resistor r=16.218 //w=0.367 //l=0.465 //layer=li \
 //thickness=0.1 //x=49.975 //y=7.585 //x2=50.44 //y2=7.585
r1688 (  679 948 ) resistor r=2.87058 //w=0.35 //l=0.085 //layer=li \
 //thickness=0.1 //x=50.685 //y=7.585 //x2=50.77 //y2=7.585
r1689 (  679 682 ) resistor r=8.54496 //w=0.367 //l=0.245 //layer=li \
 //thickness=0.1 //x=50.685 //y=7.585 //x2=50.44 //y2=7.585
r1690 (  673 947 ) resistor r=4.23183 //w=0.7 //l=0.175 //layer=li \
 //thickness=0.1 //x=49.89 //y=7.41 //x2=49.89 //y2=7.585
r1691 (  673 1014 ) resistor r=33.1979 //w=0.187 //l=0.485 //layer=li \
 //thickness=0.1 //x=49.89 //y=7.41 //x2=49.89 //y2=6.925
r1692 (  670 946 ) resistor r=2.87058 //w=0.35 //l=0.085 //layer=li \
 //thickness=0.1 //x=49.095 //y=7.585 //x2=49.01 //y2=7.585
r1693 (  670 672 ) resistor r=8.19619 //w=0.367 //l=0.235 //layer=li \
 //thickness=0.1 //x=49.095 //y=7.585 //x2=49.33 //y2=7.585
r1694 (  669 947 ) resistor r=2.87058 //w=0.35 //l=0.085 //layer=li \
 //thickness=0.1 //x=49.805 //y=7.585 //x2=49.89 //y2=7.585
r1695 (  669 672 ) resistor r=16.5668 //w=0.367 //l=0.475 //layer=li \
 //thickness=0.1 //x=49.805 //y=7.585 //x2=49.33 //y2=7.585
r1696 (  661 946 ) resistor r=4.23183 //w=0.7 //l=0.175 //layer=li \
 //thickness=0.1 //x=49.01 //y=7.41 //x2=49.01 //y2=7.585
r1697 (  661 1013 ) resistor r=56.4706 //w=0.187 //l=0.825 //layer=li \
 //thickness=0.1 //x=49.01 //y=7.41 //x2=49.01 //y2=6.585
r1698 (  660 945 ) resistor r=5.29055 //w=0.35 //l=0.17 //layer=li \
 //thickness=0.1 //x=48.39 //y=7.585 //x2=48.22 //y2=7.585
r1699 (  659 946 ) resistor r=2.87058 //w=0.35 //l=0.085 //layer=li \
 //thickness=0.1 //x=48.925 //y=7.585 //x2=49.01 //y2=7.585
r1700 (  659 660 ) resistor r=18.6594 //w=0.367 //l=0.535 //layer=li \
 //thickness=0.1 //x=48.925 //y=7.585 //x2=48.39 //y2=7.585
r1701 (  654 944 ) resistor r=2.87058 //w=0.35 //l=0.085 //layer=li \
 //thickness=0.1 //x=47.225 //y=7.585 //x2=47.14 //y2=7.585
r1702 (  654 656 ) resistor r=21.7984 //w=0.367 //l=0.625 //layer=li \
 //thickness=0.1 //x=47.225 //y=7.585 //x2=47.85 //y2=7.585
r1703 (  653 945 ) resistor r=5.29055 //w=0.35 //l=0.17 //layer=li \
 //thickness=0.1 //x=48.05 //y=7.585 //x2=48.22 //y2=7.585
r1704 (  653 656 ) resistor r=6.97548 //w=0.367 //l=0.2 //layer=li \
 //thickness=0.1 //x=48.05 //y=7.585 //x2=47.85 //y2=7.585
r1705 (  647 944 ) resistor r=4.23183 //w=0.7 //l=0.175 //layer=li \
 //thickness=0.1 //x=47.14 //y=7.41 //x2=47.14 //y2=7.585
r1706 (  647 1012 ) resistor r=33.1979 //w=0.187 //l=0.485 //layer=li \
 //thickness=0.1 //x=47.14 //y=7.41 //x2=47.14 //y2=6.925
r1707 (  644 943 ) resistor r=2.87058 //w=0.35 //l=0.085 //layer=li \
 //thickness=0.1 //x=46.345 //y=7.585 //x2=46.26 //y2=7.585
r1708 (  644 646 ) resistor r=13.7766 //w=0.367 //l=0.395 //layer=li \
 //thickness=0.1 //x=46.345 //y=7.585 //x2=46.74 //y2=7.585
r1709 (  643 944 ) resistor r=2.87058 //w=0.35 //l=0.085 //layer=li \
 //thickness=0.1 //x=47.055 //y=7.585 //x2=47.14 //y2=7.585
r1710 (  643 646 ) resistor r=10.9864 //w=0.367 //l=0.315 //layer=li \
 //thickness=0.1 //x=47.055 //y=7.585 //x2=46.74 //y2=7.585
r1711 (  637 943 ) resistor r=4.23183 //w=0.7 //l=0.175 //layer=li \
 //thickness=0.1 //x=46.26 //y=7.41 //x2=46.26 //y2=7.585
r1712 (  637 1011 ) resistor r=33.1979 //w=0.187 //l=0.485 //layer=li \
 //thickness=0.1 //x=46.26 //y=7.41 //x2=46.26 //y2=6.925
r1713 (  634 942 ) resistor r=2.87058 //w=0.35 //l=0.085 //layer=li \
 //thickness=0.1 //x=45.465 //y=7.585 //x2=45.38 //y2=7.585
r1714 (  634 636 ) resistor r=5.75477 //w=0.367 //l=0.165 //layer=li \
 //thickness=0.1 //x=45.465 //y=7.585 //x2=45.63 //y2=7.585
r1715 (  633 943 ) resistor r=2.87058 //w=0.35 //l=0.085 //layer=li \
 //thickness=0.1 //x=46.175 //y=7.585 //x2=46.26 //y2=7.585
r1716 (  633 636 ) resistor r=19.0082 //w=0.367 //l=0.545 //layer=li \
 //thickness=0.1 //x=46.175 //y=7.585 //x2=45.63 //y2=7.585
r1717 (  627 942 ) resistor r=4.23183 //w=0.7 //l=0.175 //layer=li \
 //thickness=0.1 //x=45.38 //y=7.41 //x2=45.38 //y2=7.585
r1718 (  627 1010 ) resistor r=33.1979 //w=0.187 //l=0.485 //layer=li \
 //thickness=0.1 //x=45.38 //y=7.41 //x2=45.38 //y2=6.925
r1719 (  626 941 ) resistor r=2.87058 //w=0.35 //l=0.085 //layer=li \
 //thickness=0.1 //x=44.585 //y=7.585 //x2=44.5 //y2=7.585
r1720 (  625 942 ) resistor r=2.87058 //w=0.35 //l=0.085 //layer=li \
 //thickness=0.1 //x=45.295 //y=7.585 //x2=45.38 //y2=7.585
r1721 (  625 626 ) resistor r=24.7629 //w=0.367 //l=0.71 //layer=li \
 //thickness=0.1 //x=45.295 //y=7.585 //x2=44.585 //y2=7.585
r1722 (  617 941 ) resistor r=4.23183 //w=0.7 //l=0.175 //layer=li \
 //thickness=0.1 //x=44.5 //y=7.41 //x2=44.5 //y2=7.585
r1723 (  617 1009 ) resistor r=56.4706 //w=0.187 //l=0.825 //layer=li \
 //thickness=0.1 //x=44.5 //y=7.41 //x2=44.5 //y2=6.585
r1724 (  616 939 ) resistor r=5.29055 //w=0.35 //l=0.17 //layer=li \
 //thickness=0.1 //x=43.58 //y=7.585 //x2=43.41 //y2=7.585
r1725 (  615 941 ) resistor r=2.87058 //w=0.35 //l=0.085 //layer=li \
 //thickness=0.1 //x=44.415 //y=7.585 //x2=44.5 //y2=7.585
r1726 (  615 616 ) resistor r=29.1226 //w=0.367 //l=0.835 //layer=li \
 //thickness=0.1 //x=44.415 //y=7.585 //x2=43.58 //y2=7.585
r1727 (  610 938 ) resistor r=2.87058 //w=0.35 //l=0.085 //layer=li \
 //thickness=0.1 //x=42.715 //y=7.585 //x2=42.63 //y2=7.585
r1728 (  610 612 ) resistor r=11.3351 //w=0.367 //l=0.325 //layer=li \
 //thickness=0.1 //x=42.715 //y=7.585 //x2=43.04 //y2=7.585
r1729 (  609 939 ) resistor r=5.29055 //w=0.35 //l=0.17 //layer=li \
 //thickness=0.1 //x=43.24 //y=7.585 //x2=43.41 //y2=7.585
r1730 (  609 612 ) resistor r=6.97548 //w=0.367 //l=0.2 //layer=li \
 //thickness=0.1 //x=43.24 //y=7.585 //x2=43.04 //y2=7.585
r1731 (  603 938 ) resistor r=4.23183 //w=0.7 //l=0.175 //layer=li \
 //thickness=0.1 //x=42.63 //y=7.41 //x2=42.63 //y2=7.585
r1732 (  603 1008 ) resistor r=33.1979 //w=0.187 //l=0.485 //layer=li \
 //thickness=0.1 //x=42.63 //y=7.41 //x2=42.63 //y2=6.925
r1733 (  600 937 ) resistor r=2.87058 //w=0.35 //l=0.085 //layer=li \
 //thickness=0.1 //x=41.835 //y=7.585 //x2=41.75 //y2=7.585
r1734 (  600 602 ) resistor r=3.31335 //w=0.367 //l=0.095 //layer=li \
 //thickness=0.1 //x=41.835 //y=7.585 //x2=41.93 //y2=7.585
r1735 (  599 938 ) resistor r=2.87058 //w=0.35 //l=0.085 //layer=li \
 //thickness=0.1 //x=42.545 //y=7.585 //x2=42.63 //y2=7.585
r1736 (  599 602 ) resistor r=21.4496 //w=0.367 //l=0.615 //layer=li \
 //thickness=0.1 //x=42.545 //y=7.585 //x2=41.93 //y2=7.585
r1737 (  593 937 ) resistor r=4.23183 //w=0.7 //l=0.175 //layer=li \
 //thickness=0.1 //x=41.75 //y=7.41 //x2=41.75 //y2=7.585
r1738 (  593 1007 ) resistor r=33.1979 //w=0.187 //l=0.485 //layer=li \
 //thickness=0.1 //x=41.75 //y=7.41 //x2=41.75 //y2=6.925
r1739 (  592 936 ) resistor r=2.87058 //w=0.35 //l=0.085 //layer=li \
 //thickness=0.1 //x=40.955 //y=7.585 //x2=40.87 //y2=7.585
r1740 (  591 937 ) resistor r=2.87058 //w=0.35 //l=0.085 //layer=li \
 //thickness=0.1 //x=41.665 //y=7.585 //x2=41.75 //y2=7.585
r1741 (  591 592 ) resistor r=24.7629 //w=0.367 //l=0.71 //layer=li \
 //thickness=0.1 //x=41.665 //y=7.585 //x2=40.955 //y2=7.585
r1742 (  583 936 ) resistor r=4.23183 //w=0.7 //l=0.175 //layer=li \
 //thickness=0.1 //x=40.87 //y=7.41 //x2=40.87 //y2=7.585
r1743 (  583 1006 ) resistor r=56.4706 //w=0.187 //l=0.825 //layer=li \
 //thickness=0.1 //x=40.87 //y=7.41 //x2=40.87 //y2=6.585
r1744 (  582 934 ) resistor r=5.29055 //w=0.35 //l=0.17 //layer=li \
 //thickness=0.1 //x=40.25 //y=7.585 //x2=40.08 //y2=7.585
r1745 (  581 936 ) resistor r=2.87058 //w=0.35 //l=0.085 //layer=li \
 //thickness=0.1 //x=40.785 //y=7.585 //x2=40.87 //y2=7.585
r1746 (  581 582 ) resistor r=18.6594 //w=0.367 //l=0.535 //layer=li \
 //thickness=0.1 //x=40.785 //y=7.585 //x2=40.25 //y2=7.585
r1747 (  578 933 ) resistor r=2.87058 //w=0.35 //l=0.085 //layer=li \
 //thickness=0.1 //x=39.385 //y=7.585 //x2=39.3 //y2=7.585
r1748 (  577 934 ) resistor r=5.29055 //w=0.35 //l=0.17 //layer=li \
 //thickness=0.1 //x=39.91 //y=7.585 //x2=40.08 //y2=7.585
r1749 (  577 578 ) resistor r=18.3106 //w=0.367 //l=0.525 //layer=li \
 //thickness=0.1 //x=39.91 //y=7.585 //x2=39.385 //y2=7.585
r1750 (  571 933 ) resistor r=4.23183 //w=0.7 //l=0.175 //layer=li \
 //thickness=0.1 //x=39.3 //y=7.41 //x2=39.3 //y2=7.585
r1751 (  571 1005 ) resistor r=33.1979 //w=0.187 //l=0.485 //layer=li \
 //thickness=0.1 //x=39.3 //y=7.41 //x2=39.3 //y2=6.925
r1752 (  570 931 ) resistor r=2.87058 //w=0.35 //l=0.085 //layer=li \
 //thickness=0.1 //x=38.505 //y=7.585 //x2=38.42 //y2=7.585
r1753 (  569 933 ) resistor r=2.87058 //w=0.35 //l=0.085 //layer=li \
 //thickness=0.1 //x=39.215 //y=7.585 //x2=39.3 //y2=7.585
r1754 (  569 570 ) resistor r=24.7629 //w=0.367 //l=0.71 //layer=li \
 //thickness=0.1 //x=39.215 //y=7.585 //x2=38.505 //y2=7.585
r1755 (  563 931 ) resistor r=4.23183 //w=0.7 //l=0.175 //layer=li \
 //thickness=0.1 //x=38.42 //y=7.41 //x2=38.42 //y2=7.585
r1756 (  563 1004 ) resistor r=33.1979 //w=0.187 //l=0.485 //layer=li \
 //thickness=0.1 //x=38.42 //y=7.41 //x2=38.42 //y2=6.925
r1757 (  560 930 ) resistor r=2.87058 //w=0.35 //l=0.085 //layer=li \
 //thickness=0.1 //x=37.625 //y=7.585 //x2=37.54 //y2=7.585
r1758 (  560 562 ) resistor r=21.1008 //w=0.367 //l=0.605 //layer=li \
 //thickness=0.1 //x=37.625 //y=7.585 //x2=38.23 //y2=7.585
r1759 (  559 931 ) resistor r=2.87058 //w=0.35 //l=0.085 //layer=li \
 //thickness=0.1 //x=38.335 //y=7.585 //x2=38.42 //y2=7.585
r1760 (  559 562 ) resistor r=3.66213 //w=0.367 //l=0.105 //layer=li \
 //thickness=0.1 //x=38.335 //y=7.585 //x2=38.23 //y2=7.585
r1761 (  551 930 ) resistor r=4.23183 //w=0.7 //l=0.175 //layer=li \
 //thickness=0.1 //x=37.54 //y=7.41 //x2=37.54 //y2=7.585
r1762 (  551 1003 ) resistor r=56.4706 //w=0.187 //l=0.825 //layer=li \
 //thickness=0.1 //x=37.54 //y=7.41 //x2=37.54 //y2=6.585
r1763 (  548 929 ) resistor r=5.29055 //w=0.35 //l=0.17 //layer=li \
 //thickness=0.1 //x=36.92 //y=7.585 //x2=36.75 //y2=7.585
r1764 (  548 550 ) resistor r=6.97548 //w=0.367 //l=0.2 //layer=li \
 //thickness=0.1 //x=36.92 //y=7.585 //x2=37.12 //y2=7.585
r1765 (  547 930 ) resistor r=2.87058 //w=0.35 //l=0.085 //layer=li \
 //thickness=0.1 //x=37.455 //y=7.585 //x2=37.54 //y2=7.585
r1766 (  547 550 ) resistor r=11.6839 //w=0.367 //l=0.335 //layer=li \
 //thickness=0.1 //x=37.455 //y=7.585 //x2=37.12 //y2=7.585
r1767 (  544 928 ) resistor r=2.87058 //w=0.35 //l=0.085 //layer=li \
 //thickness=0.1 //x=36.055 //y=7.585 //x2=35.97 //y2=7.585
r1768 (  543 929 ) resistor r=5.29055 //w=0.35 //l=0.17 //layer=li \
 //thickness=0.1 //x=36.58 //y=7.585 //x2=36.75 //y2=7.585
r1769 (  543 544 ) resistor r=18.3106 //w=0.367 //l=0.525 //layer=li \
 //thickness=0.1 //x=36.58 //y=7.585 //x2=36.055 //y2=7.585
r1770 (  537 928 ) resistor r=4.23183 //w=0.7 //l=0.175 //layer=li \
 //thickness=0.1 //x=35.97 //y=7.41 //x2=35.97 //y2=7.585
r1771 (  537 1002 ) resistor r=33.1979 //w=0.187 //l=0.485 //layer=li \
 //thickness=0.1 //x=35.97 //y=7.41 //x2=35.97 //y2=6.925
r1772 (  534 927 ) resistor r=2.87058 //w=0.35 //l=0.085 //layer=li \
 //thickness=0.1 //x=35.175 //y=7.585 //x2=35.09 //y2=7.585
r1773 (  534 536 ) resistor r=16.218 //w=0.367 //l=0.465 //layer=li \
 //thickness=0.1 //x=35.175 //y=7.585 //x2=35.64 //y2=7.585
r1774 (  533 928 ) resistor r=2.87058 //w=0.35 //l=0.085 //layer=li \
 //thickness=0.1 //x=35.885 //y=7.585 //x2=35.97 //y2=7.585
r1775 (  533 536 ) resistor r=8.54496 //w=0.367 //l=0.245 //layer=li \
 //thickness=0.1 //x=35.885 //y=7.585 //x2=35.64 //y2=7.585
r1776 (  527 927 ) resistor r=4.23183 //w=0.7 //l=0.175 //layer=li \
 //thickness=0.1 //x=35.09 //y=7.41 //x2=35.09 //y2=7.585
r1777 (  527 1001 ) resistor r=33.1979 //w=0.187 //l=0.485 //layer=li \
 //thickness=0.1 //x=35.09 //y=7.41 //x2=35.09 //y2=6.925
r1778 (  524 926 ) resistor r=2.87058 //w=0.35 //l=0.085 //layer=li \
 //thickness=0.1 //x=34.295 //y=7.585 //x2=34.21 //y2=7.585
r1779 (  524 526 ) resistor r=8.19619 //w=0.367 //l=0.235 //layer=li \
 //thickness=0.1 //x=34.295 //y=7.585 //x2=34.53 //y2=7.585
r1780 (  523 927 ) resistor r=2.87058 //w=0.35 //l=0.085 //layer=li \
 //thickness=0.1 //x=35.005 //y=7.585 //x2=35.09 //y2=7.585
r1781 (  523 526 ) resistor r=16.5668 //w=0.367 //l=0.475 //layer=li \
 //thickness=0.1 //x=35.005 //y=7.585 //x2=34.53 //y2=7.585
r1782 (  515 926 ) resistor r=4.23183 //w=0.7 //l=0.175 //layer=li \
 //thickness=0.1 //x=34.21 //y=7.41 //x2=34.21 //y2=7.585
r1783 (  515 1000 ) resistor r=56.4706 //w=0.187 //l=0.825 //layer=li \
 //thickness=0.1 //x=34.21 //y=7.41 //x2=34.21 //y2=6.585
r1784 (  514 925 ) resistor r=5.29055 //w=0.35 //l=0.17 //layer=li \
 //thickness=0.1 //x=33.59 //y=7.585 //x2=33.42 //y2=7.585
r1785 (  513 926 ) resistor r=2.87058 //w=0.35 //l=0.085 //layer=li \
 //thickness=0.1 //x=34.125 //y=7.585 //x2=34.21 //y2=7.585
r1786 (  513 514 ) resistor r=18.6594 //w=0.367 //l=0.535 //layer=li \
 //thickness=0.1 //x=34.125 //y=7.585 //x2=33.59 //y2=7.585
r1787 (  508 924 ) resistor r=2.87058 //w=0.35 //l=0.085 //layer=li \
 //thickness=0.1 //x=32.725 //y=7.585 //x2=32.64 //y2=7.585
r1788 (  508 510 ) resistor r=11.3351 //w=0.367 //l=0.325 //layer=li \
 //thickness=0.1 //x=32.725 //y=7.585 //x2=33.05 //y2=7.585
r1789 (  507 925 ) resistor r=5.29055 //w=0.35 //l=0.17 //layer=li \
 //thickness=0.1 //x=33.25 //y=7.585 //x2=33.42 //y2=7.585
r1790 (  507 510 ) resistor r=6.97548 //w=0.367 //l=0.2 //layer=li \
 //thickness=0.1 //x=33.25 //y=7.585 //x2=33.05 //y2=7.585
r1791 (  501 924 ) resistor r=4.23183 //w=0.7 //l=0.175 //layer=li \
 //thickness=0.1 //x=32.64 //y=7.41 //x2=32.64 //y2=7.585
r1792 (  501 999 ) resistor r=33.1979 //w=0.187 //l=0.485 //layer=li \
 //thickness=0.1 //x=32.64 //y=7.41 //x2=32.64 //y2=6.925
r1793 (  498 923 ) resistor r=2.87058 //w=0.35 //l=0.085 //layer=li \
 //thickness=0.1 //x=31.845 //y=7.585 //x2=31.76 //y2=7.585
r1794 (  498 500 ) resistor r=3.31335 //w=0.367 //l=0.095 //layer=li \
 //thickness=0.1 //x=31.845 //y=7.585 //x2=31.94 //y2=7.585
r1795 (  497 924 ) resistor r=2.87058 //w=0.35 //l=0.085 //layer=li \
 //thickness=0.1 //x=32.555 //y=7.585 //x2=32.64 //y2=7.585
r1796 (  497 500 ) resistor r=21.4496 //w=0.367 //l=0.615 //layer=li \
 //thickness=0.1 //x=32.555 //y=7.585 //x2=31.94 //y2=7.585
r1797 (  491 923 ) resistor r=4.23183 //w=0.7 //l=0.175 //layer=li \
 //thickness=0.1 //x=31.76 //y=7.41 //x2=31.76 //y2=7.585
r1798 (  491 998 ) resistor r=33.1979 //w=0.187 //l=0.485 //layer=li \
 //thickness=0.1 //x=31.76 //y=7.41 //x2=31.76 //y2=6.925
r1799 (  490 922 ) resistor r=2.87058 //w=0.35 //l=0.085 //layer=li \
 //thickness=0.1 //x=30.965 //y=7.585 //x2=30.88 //y2=7.585
r1800 (  489 923 ) resistor r=2.87058 //w=0.35 //l=0.085 //layer=li \
 //thickness=0.1 //x=31.675 //y=7.585 //x2=31.76 //y2=7.585
r1801 (  489 490 ) resistor r=24.7629 //w=0.367 //l=0.71 //layer=li \
 //thickness=0.1 //x=31.675 //y=7.585 //x2=30.965 //y2=7.585
r1802 (  481 922 ) resistor r=4.23183 //w=0.7 //l=0.175 //layer=li \
 //thickness=0.1 //x=30.88 //y=7.41 //x2=30.88 //y2=7.585
r1803 (  481 997 ) resistor r=56.4706 //w=0.187 //l=0.825 //layer=li \
 //thickness=0.1 //x=30.88 //y=7.41 //x2=30.88 //y2=6.585
r1804 (  480 920 ) resistor r=5.29055 //w=0.35 //l=0.17 //layer=li \
 //thickness=0.1 //x=30.26 //y=7.585 //x2=30.09 //y2=7.585
r1805 (  479 922 ) resistor r=2.87058 //w=0.35 //l=0.085 //layer=li \
 //thickness=0.1 //x=30.795 //y=7.585 //x2=30.88 //y2=7.585
r1806 (  479 480 ) resistor r=18.6594 //w=0.367 //l=0.535 //layer=li \
 //thickness=0.1 //x=30.795 //y=7.585 //x2=30.26 //y2=7.585
r1807 (  476 919 ) resistor r=2.87058 //w=0.35 //l=0.085 //layer=li \
 //thickness=0.1 //x=29.395 //y=7.585 //x2=29.31 //y2=7.585
r1808 (  475 920 ) resistor r=5.29055 //w=0.35 //l=0.17 //layer=li \
 //thickness=0.1 //x=29.92 //y=7.585 //x2=30.09 //y2=7.585
r1809 (  475 476 ) resistor r=18.3106 //w=0.367 //l=0.525 //layer=li \
 //thickness=0.1 //x=29.92 //y=7.585 //x2=29.395 //y2=7.585
r1810 (  469 919 ) resistor r=4.23183 //w=0.7 //l=0.175 //layer=li \
 //thickness=0.1 //x=29.31 //y=7.41 //x2=29.31 //y2=7.585
r1811 (  469 996 ) resistor r=33.1979 //w=0.187 //l=0.485 //layer=li \
 //thickness=0.1 //x=29.31 //y=7.41 //x2=29.31 //y2=6.925
r1812 (  468 917 ) resistor r=2.87058 //w=0.35 //l=0.085 //layer=li \
 //thickness=0.1 //x=28.515 //y=7.585 //x2=28.43 //y2=7.585
r1813 (  467 919 ) resistor r=2.87058 //w=0.35 //l=0.085 //layer=li \
 //thickness=0.1 //x=29.225 //y=7.585 //x2=29.31 //y2=7.585
r1814 (  467 468 ) resistor r=24.7629 //w=0.367 //l=0.71 //layer=li \
 //thickness=0.1 //x=29.225 //y=7.585 //x2=28.515 //y2=7.585
r1815 (  461 917 ) resistor r=4.23183 //w=0.7 //l=0.175 //layer=li \
 //thickness=0.1 //x=28.43 //y=7.41 //x2=28.43 //y2=7.585
r1816 (  461 995 ) resistor r=33.1979 //w=0.187 //l=0.485 //layer=li \
 //thickness=0.1 //x=28.43 //y=7.41 //x2=28.43 //y2=6.925
r1817 (  458 916 ) resistor r=2.87058 //w=0.35 //l=0.085 //layer=li \
 //thickness=0.1 //x=27.635 //y=7.585 //x2=27.55 //y2=7.585
r1818 (  458 460 ) resistor r=21.1008 //w=0.367 //l=0.605 //layer=li \
 //thickness=0.1 //x=27.635 //y=7.585 //x2=28.24 //y2=7.585
r1819 (  457 917 ) resistor r=2.87058 //w=0.35 //l=0.085 //layer=li \
 //thickness=0.1 //x=28.345 //y=7.585 //x2=28.43 //y2=7.585
r1820 (  457 460 ) resistor r=3.66213 //w=0.367 //l=0.105 //layer=li \
 //thickness=0.1 //x=28.345 //y=7.585 //x2=28.24 //y2=7.585
r1821 (  449 916 ) resistor r=4.23183 //w=0.7 //l=0.175 //layer=li \
 //thickness=0.1 //x=27.55 //y=7.41 //x2=27.55 //y2=7.585
r1822 (  449 994 ) resistor r=56.4706 //w=0.187 //l=0.825 //layer=li \
 //thickness=0.1 //x=27.55 //y=7.41 //x2=27.55 //y2=6.585
r1823 (  446 915 ) resistor r=5.29055 //w=0.35 //l=0.17 //layer=li \
 //thickness=0.1 //x=26.93 //y=7.585 //x2=26.76 //y2=7.585
r1824 (  446 448 ) resistor r=6.97548 //w=0.367 //l=0.2 //layer=li \
 //thickness=0.1 //x=26.93 //y=7.585 //x2=27.13 //y2=7.585
r1825 (  445 916 ) resistor r=2.87058 //w=0.35 //l=0.085 //layer=li \
 //thickness=0.1 //x=27.465 //y=7.585 //x2=27.55 //y2=7.585
r1826 (  445 448 ) resistor r=11.6839 //w=0.367 //l=0.335 //layer=li \
 //thickness=0.1 //x=27.465 //y=7.585 //x2=27.13 //y2=7.585
r1827 (  442 914 ) resistor r=2.87058 //w=0.35 //l=0.085 //layer=li \
 //thickness=0.1 //x=25.765 //y=7.585 //x2=25.68 //y2=7.585
r1828 (  441 915 ) resistor r=5.29055 //w=0.35 //l=0.17 //layer=li \
 //thickness=0.1 //x=26.59 //y=7.585 //x2=26.76 //y2=7.585
r1829 (  441 442 ) resistor r=28.7738 //w=0.367 //l=0.825 //layer=li \
 //thickness=0.1 //x=26.59 //y=7.585 //x2=25.765 //y2=7.585
r1830 (  435 914 ) resistor r=4.23183 //w=0.7 //l=0.175 //layer=li \
 //thickness=0.1 //x=25.68 //y=7.41 //x2=25.68 //y2=7.585
r1831 (  435 993 ) resistor r=33.1979 //w=0.187 //l=0.485 //layer=li \
 //thickness=0.1 //x=25.68 //y=7.41 //x2=25.68 //y2=6.925
r1832 (  434 912 ) resistor r=2.87058 //w=0.35 //l=0.085 //layer=li \
 //thickness=0.1 //x=24.885 //y=7.585 //x2=24.8 //y2=7.585
r1833 (  433 914 ) resistor r=2.87058 //w=0.35 //l=0.085 //layer=li \
 //thickness=0.1 //x=25.595 //y=7.585 //x2=25.68 //y2=7.585
r1834 (  433 434 ) resistor r=24.7629 //w=0.367 //l=0.71 //layer=li \
 //thickness=0.1 //x=25.595 //y=7.585 //x2=24.885 //y2=7.585
r1835 (  427 912 ) resistor r=4.23183 //w=0.7 //l=0.175 //layer=li \
 //thickness=0.1 //x=24.8 //y=7.41 //x2=24.8 //y2=7.585
r1836 (  427 992 ) resistor r=33.1979 //w=0.187 //l=0.485 //layer=li \
 //thickness=0.1 //x=24.8 //y=7.41 //x2=24.8 //y2=6.925
r1837 (  424 911 ) resistor r=2.87058 //w=0.35 //l=0.085 //layer=li \
 //thickness=0.1 //x=24.005 //y=7.585 //x2=23.92 //y2=7.585
r1838 (  424 426 ) resistor r=18.6594 //w=0.367 //l=0.535 //layer=li \
 //thickness=0.1 //x=24.005 //y=7.585 //x2=24.54 //y2=7.585
r1839 (  423 912 ) resistor r=2.87058 //w=0.35 //l=0.085 //layer=li \
 //thickness=0.1 //x=24.715 //y=7.585 //x2=24.8 //y2=7.585
r1840 (  423 426 ) resistor r=6.10354 //w=0.367 //l=0.175 //layer=li \
 //thickness=0.1 //x=24.715 //y=7.585 //x2=24.54 //y2=7.585
r1841 (  417 911 ) resistor r=4.23183 //w=0.7 //l=0.175 //layer=li \
 //thickness=0.1 //x=23.92 //y=7.41 //x2=23.92 //y2=7.585
r1842 (  417 991 ) resistor r=33.1979 //w=0.187 //l=0.485 //layer=li \
 //thickness=0.1 //x=23.92 //y=7.41 //x2=23.92 //y2=6.925
r1843 (  414 910 ) resistor r=2.87058 //w=0.35 //l=0.085 //layer=li \
 //thickness=0.1 //x=23.125 //y=7.585 //x2=23.04 //y2=7.585
r1844 (  414 416 ) resistor r=10.6376 //w=0.367 //l=0.305 //layer=li \
 //thickness=0.1 //x=23.125 //y=7.585 //x2=23.43 //y2=7.585
r1845 (  413 911 ) resistor r=2.87058 //w=0.35 //l=0.085 //layer=li \
 //thickness=0.1 //x=23.835 //y=7.585 //x2=23.92 //y2=7.585
r1846 (  413 416 ) resistor r=14.1253 //w=0.367 //l=0.405 //layer=li \
 //thickness=0.1 //x=23.835 //y=7.585 //x2=23.43 //y2=7.585
r1847 (  405 910 ) resistor r=4.23183 //w=0.7 //l=0.175 //layer=li \
 //thickness=0.1 //x=23.04 //y=7.41 //x2=23.04 //y2=7.585
r1848 (  405 990 ) resistor r=56.4706 //w=0.187 //l=0.825 //layer=li \
 //thickness=0.1 //x=23.04 //y=7.41 //x2=23.04 //y2=6.585
r1849 (  402 909 ) resistor r=5.29055 //w=0.35 //l=0.17 //layer=li \
 //thickness=0.1 //x=22.12 //y=7.585 //x2=21.95 //y2=7.585
r1850 (  402 404 ) resistor r=6.97548 //w=0.367 //l=0.2 //layer=li \
 //thickness=0.1 //x=22.12 //y=7.585 //x2=22.32 //y2=7.585
r1851 (  401 910 ) resistor r=2.87058 //w=0.35 //l=0.085 //layer=li \
 //thickness=0.1 //x=22.955 //y=7.585 //x2=23.04 //y2=7.585
r1852 (  401 404 ) resistor r=22.1471 //w=0.367 //l=0.635 //layer=li \
 //thickness=0.1 //x=22.955 //y=7.585 //x2=22.32 //y2=7.585
r1853 (  398 908 ) resistor r=2.87058 //w=0.35 //l=0.085 //layer=li \
 //thickness=0.1 //x=21.255 //y=7.585 //x2=21.17 //y2=7.585
r1854 (  397 909 ) resistor r=5.29055 //w=0.35 //l=0.17 //layer=li \
 //thickness=0.1 //x=21.78 //y=7.585 //x2=21.95 //y2=7.585
r1855 (  397 398 ) resistor r=18.3106 //w=0.367 //l=0.525 //layer=li \
 //thickness=0.1 //x=21.78 //y=7.585 //x2=21.255 //y2=7.585
r1856 (  391 908 ) resistor r=4.23183 //w=0.7 //l=0.175 //layer=li \
 //thickness=0.1 //x=21.17 //y=7.41 //x2=21.17 //y2=7.585
r1857 (  391 989 ) resistor r=33.1979 //w=0.187 //l=0.485 //layer=li \
 //thickness=0.1 //x=21.17 //y=7.41 //x2=21.17 //y2=6.925
r1858 (  388 907 ) resistor r=2.87058 //w=0.35 //l=0.085 //layer=li \
 //thickness=0.1 //x=20.375 //y=7.585 //x2=20.29 //y2=7.585
r1859 (  388 390 ) resistor r=16.218 //w=0.367 //l=0.465 //layer=li \
 //thickness=0.1 //x=20.375 //y=7.585 //x2=20.84 //y2=7.585
r1860 (  387 908 ) resistor r=2.87058 //w=0.35 //l=0.085 //layer=li \
 //thickness=0.1 //x=21.085 //y=7.585 //x2=21.17 //y2=7.585
r1861 (  387 390 ) resistor r=8.54496 //w=0.367 //l=0.245 //layer=li \
 //thickness=0.1 //x=21.085 //y=7.585 //x2=20.84 //y2=7.585
r1862 (  381 907 ) resistor r=4.23183 //w=0.7 //l=0.175 //layer=li \
 //thickness=0.1 //x=20.29 //y=7.41 //x2=20.29 //y2=7.585
r1863 (  381 988 ) resistor r=33.1979 //w=0.187 //l=0.485 //layer=li \
 //thickness=0.1 //x=20.29 //y=7.41 //x2=20.29 //y2=6.925
r1864 (  378 906 ) resistor r=2.87058 //w=0.35 //l=0.085 //layer=li \
 //thickness=0.1 //x=19.495 //y=7.585 //x2=19.41 //y2=7.585
r1865 (  378 380 ) resistor r=8.19619 //w=0.367 //l=0.235 //layer=li \
 //thickness=0.1 //x=19.495 //y=7.585 //x2=19.73 //y2=7.585
r1866 (  377 907 ) resistor r=2.87058 //w=0.35 //l=0.085 //layer=li \
 //thickness=0.1 //x=20.205 //y=7.585 //x2=20.29 //y2=7.585
r1867 (  377 380 ) resistor r=16.5668 //w=0.367 //l=0.475 //layer=li \
 //thickness=0.1 //x=20.205 //y=7.585 //x2=19.73 //y2=7.585
r1868 (  369 906 ) resistor r=4.23183 //w=0.7 //l=0.175 //layer=li \
 //thickness=0.1 //x=19.41 //y=7.41 //x2=19.41 //y2=7.585
r1869 (  369 987 ) resistor r=56.4706 //w=0.187 //l=0.825 //layer=li \
 //thickness=0.1 //x=19.41 //y=7.41 //x2=19.41 //y2=6.585
r1870 (  368 905 ) resistor r=5.29055 //w=0.35 //l=0.17 //layer=li \
 //thickness=0.1 //x=18.79 //y=7.585 //x2=18.62 //y2=7.585
r1871 (  367 906 ) resistor r=2.87058 //w=0.35 //l=0.085 //layer=li \
 //thickness=0.1 //x=19.325 //y=7.585 //x2=19.41 //y2=7.585
r1872 (  367 368 ) resistor r=18.6594 //w=0.367 //l=0.535 //layer=li \
 //thickness=0.1 //x=19.325 //y=7.585 //x2=18.79 //y2=7.585
r1873 (  362 904 ) resistor r=2.87058 //w=0.35 //l=0.085 //layer=li \
 //thickness=0.1 //x=17.925 //y=7.585 //x2=17.84 //y2=7.585
r1874 (  362 364 ) resistor r=11.3351 //w=0.367 //l=0.325 //layer=li \
 //thickness=0.1 //x=17.925 //y=7.585 //x2=18.25 //y2=7.585
r1875 (  361 905 ) resistor r=5.29055 //w=0.35 //l=0.17 //layer=li \
 //thickness=0.1 //x=18.45 //y=7.585 //x2=18.62 //y2=7.585
r1876 (  361 364 ) resistor r=6.97548 //w=0.367 //l=0.2 //layer=li \
 //thickness=0.1 //x=18.45 //y=7.585 //x2=18.25 //y2=7.585
r1877 (  355 904 ) resistor r=4.23183 //w=0.7 //l=0.175 //layer=li \
 //thickness=0.1 //x=17.84 //y=7.41 //x2=17.84 //y2=7.585
r1878 (  355 986 ) resistor r=33.1979 //w=0.187 //l=0.485 //layer=li \
 //thickness=0.1 //x=17.84 //y=7.41 //x2=17.84 //y2=6.925
r1879 (  352 903 ) resistor r=2.87058 //w=0.35 //l=0.085 //layer=li \
 //thickness=0.1 //x=17.045 //y=7.585 //x2=16.96 //y2=7.585
r1880 (  352 354 ) resistor r=3.31335 //w=0.367 //l=0.095 //layer=li \
 //thickness=0.1 //x=17.045 //y=7.585 //x2=17.14 //y2=7.585
r1881 (  351 904 ) resistor r=2.87058 //w=0.35 //l=0.085 //layer=li \
 //thickness=0.1 //x=17.755 //y=7.585 //x2=17.84 //y2=7.585
r1882 (  351 354 ) resistor r=21.4496 //w=0.367 //l=0.615 //layer=li \
 //thickness=0.1 //x=17.755 //y=7.585 //x2=17.14 //y2=7.585
r1883 (  345 903 ) resistor r=4.23183 //w=0.7 //l=0.175 //layer=li \
 //thickness=0.1 //x=16.96 //y=7.41 //x2=16.96 //y2=7.585
r1884 (  345 985 ) resistor r=33.1979 //w=0.187 //l=0.485 //layer=li \
 //thickness=0.1 //x=16.96 //y=7.41 //x2=16.96 //y2=6.925
r1885 (  344 902 ) resistor r=2.87058 //w=0.35 //l=0.085 //layer=li \
 //thickness=0.1 //x=16.165 //y=7.585 //x2=16.08 //y2=7.585
r1886 (  343 903 ) resistor r=2.87058 //w=0.35 //l=0.085 //layer=li \
 //thickness=0.1 //x=16.875 //y=7.585 //x2=16.96 //y2=7.585
r1887 (  343 344 ) resistor r=24.7629 //w=0.367 //l=0.71 //layer=li \
 //thickness=0.1 //x=16.875 //y=7.585 //x2=16.165 //y2=7.585
r1888 (  335 902 ) resistor r=4.23183 //w=0.7 //l=0.175 //layer=li \
 //thickness=0.1 //x=16.08 //y=7.41 //x2=16.08 //y2=7.585
r1889 (  335 984 ) resistor r=56.4706 //w=0.187 //l=0.825 //layer=li \
 //thickness=0.1 //x=16.08 //y=7.41 //x2=16.08 //y2=6.585
r1890 (  334 900 ) resistor r=5.29055 //w=0.35 //l=0.17 //layer=li \
 //thickness=0.1 //x=15.46 //y=7.585 //x2=15.29 //y2=7.585
r1891 (  333 902 ) resistor r=2.87058 //w=0.35 //l=0.085 //layer=li \
 //thickness=0.1 //x=15.995 //y=7.585 //x2=16.08 //y2=7.585
r1892 (  333 334 ) resistor r=18.6594 //w=0.367 //l=0.535 //layer=li \
 //thickness=0.1 //x=15.995 //y=7.585 //x2=15.46 //y2=7.585
r1893 (  330 899 ) resistor r=2.87058 //w=0.35 //l=0.085 //layer=li \
 //thickness=0.1 //x=14.595 //y=7.585 //x2=14.51 //y2=7.585
r1894 (  329 900 ) resistor r=5.29055 //w=0.35 //l=0.17 //layer=li \
 //thickness=0.1 //x=15.12 //y=7.585 //x2=15.29 //y2=7.585
r1895 (  329 330 ) resistor r=18.3106 //w=0.367 //l=0.525 //layer=li \
 //thickness=0.1 //x=15.12 //y=7.585 //x2=14.595 //y2=7.585
r1896 (  323 899 ) resistor r=4.23183 //w=0.7 //l=0.175 //layer=li \
 //thickness=0.1 //x=14.51 //y=7.41 //x2=14.51 //y2=7.585
r1897 (  323 983 ) resistor r=33.1979 //w=0.187 //l=0.485 //layer=li \
 //thickness=0.1 //x=14.51 //y=7.41 //x2=14.51 //y2=6.925
r1898 (  322 897 ) resistor r=2.87058 //w=0.35 //l=0.085 //layer=li \
 //thickness=0.1 //x=13.715 //y=7.585 //x2=13.63 //y2=7.585
r1899 (  321 899 ) resistor r=2.87058 //w=0.35 //l=0.085 //layer=li \
 //thickness=0.1 //x=14.425 //y=7.585 //x2=14.51 //y2=7.585
r1900 (  321 322 ) resistor r=24.7629 //w=0.367 //l=0.71 //layer=li \
 //thickness=0.1 //x=14.425 //y=7.585 //x2=13.715 //y2=7.585
r1901 (  315 897 ) resistor r=4.23183 //w=0.7 //l=0.175 //layer=li \
 //thickness=0.1 //x=13.63 //y=7.41 //x2=13.63 //y2=7.585
r1902 (  315 982 ) resistor r=33.1979 //w=0.187 //l=0.485 //layer=li \
 //thickness=0.1 //x=13.63 //y=7.41 //x2=13.63 //y2=6.925
r1903 (  312 896 ) resistor r=2.87058 //w=0.35 //l=0.085 //layer=li \
 //thickness=0.1 //x=12.835 //y=7.585 //x2=12.75 //y2=7.585
r1904 (  312 314 ) resistor r=21.1008 //w=0.367 //l=0.605 //layer=li \
 //thickness=0.1 //x=12.835 //y=7.585 //x2=13.44 //y2=7.585
r1905 (  311 897 ) resistor r=2.87058 //w=0.35 //l=0.085 //layer=li \
 //thickness=0.1 //x=13.545 //y=7.585 //x2=13.63 //y2=7.585
r1906 (  311 314 ) resistor r=3.66213 //w=0.367 //l=0.105 //layer=li \
 //thickness=0.1 //x=13.545 //y=7.585 //x2=13.44 //y2=7.585
r1907 (  303 896 ) resistor r=4.23183 //w=0.7 //l=0.175 //layer=li \
 //thickness=0.1 //x=12.75 //y=7.41 //x2=12.75 //y2=7.585
r1908 (  303 981 ) resistor r=56.4706 //w=0.187 //l=0.825 //layer=li \
 //thickness=0.1 //x=12.75 //y=7.41 //x2=12.75 //y2=6.585
r1909 (  300 895 ) resistor r=5.29055 //w=0.35 //l=0.17 //layer=li \
 //thickness=0.1 //x=12.13 //y=7.585 //x2=11.96 //y2=7.585
r1910 (  300 302 ) resistor r=6.97548 //w=0.367 //l=0.2 //layer=li \
 //thickness=0.1 //x=12.13 //y=7.585 //x2=12.33 //y2=7.585
r1911 (  299 896 ) resistor r=2.87058 //w=0.35 //l=0.085 //layer=li \
 //thickness=0.1 //x=12.665 //y=7.585 //x2=12.75 //y2=7.585
r1912 (  299 302 ) resistor r=11.6839 //w=0.367 //l=0.335 //layer=li \
 //thickness=0.1 //x=12.665 //y=7.585 //x2=12.33 //y2=7.585
r1913 (  296 894 ) resistor r=2.87058 //w=0.35 //l=0.085 //layer=li \
 //thickness=0.1 //x=11.265 //y=7.585 //x2=11.18 //y2=7.585
r1914 (  295 895 ) resistor r=5.29055 //w=0.35 //l=0.17 //layer=li \
 //thickness=0.1 //x=11.79 //y=7.585 //x2=11.96 //y2=7.585
r1915 (  295 296 ) resistor r=18.3106 //w=0.367 //l=0.525 //layer=li \
 //thickness=0.1 //x=11.79 //y=7.585 //x2=11.265 //y2=7.585
r1916 (  289 894 ) resistor r=4.23183 //w=0.7 //l=0.175 //layer=li \
 //thickness=0.1 //x=11.18 //y=7.41 //x2=11.18 //y2=7.585
r1917 (  289 980 ) resistor r=33.1979 //w=0.187 //l=0.485 //layer=li \
 //thickness=0.1 //x=11.18 //y=7.41 //x2=11.18 //y2=6.925
r1918 (  286 893 ) resistor r=2.87058 //w=0.35 //l=0.085 //layer=li \
 //thickness=0.1 //x=10.385 //y=7.585 //x2=10.3 //y2=7.585
r1919 (  286 288 ) resistor r=16.218 //w=0.367 //l=0.465 //layer=li \
 //thickness=0.1 //x=10.385 //y=7.585 //x2=10.85 //y2=7.585
r1920 (  285 894 ) resistor r=2.87058 //w=0.35 //l=0.085 //layer=li \
 //thickness=0.1 //x=11.095 //y=7.585 //x2=11.18 //y2=7.585
r1921 (  285 288 ) resistor r=8.54496 //w=0.367 //l=0.245 //layer=li \
 //thickness=0.1 //x=11.095 //y=7.585 //x2=10.85 //y2=7.585
r1922 (  279 893 ) resistor r=4.23183 //w=0.7 //l=0.175 //layer=li \
 //thickness=0.1 //x=10.3 //y=7.41 //x2=10.3 //y2=7.585
r1923 (  279 979 ) resistor r=33.1979 //w=0.187 //l=0.485 //layer=li \
 //thickness=0.1 //x=10.3 //y=7.41 //x2=10.3 //y2=6.925
r1924 (  276 892 ) resistor r=2.87058 //w=0.35 //l=0.085 //layer=li \
 //thickness=0.1 //x=9.505 //y=7.585 //x2=9.42 //y2=7.585
r1925 (  276 278 ) resistor r=8.19619 //w=0.367 //l=0.235 //layer=li \
 //thickness=0.1 //x=9.505 //y=7.585 //x2=9.74 //y2=7.585
r1926 (  275 893 ) resistor r=2.87058 //w=0.35 //l=0.085 //layer=li \
 //thickness=0.1 //x=10.215 //y=7.585 //x2=10.3 //y2=7.585
r1927 (  275 278 ) resistor r=16.5668 //w=0.367 //l=0.475 //layer=li \
 //thickness=0.1 //x=10.215 //y=7.585 //x2=9.74 //y2=7.585
r1928 (  267 892 ) resistor r=4.23183 //w=0.7 //l=0.175 //layer=li \
 //thickness=0.1 //x=9.42 //y=7.41 //x2=9.42 //y2=7.585
r1929 (  267 978 ) resistor r=56.4706 //w=0.187 //l=0.825 //layer=li \
 //thickness=0.1 //x=9.42 //y=7.41 //x2=9.42 //y2=6.585
r1930 (  266 891 ) resistor r=5.29055 //w=0.35 //l=0.17 //layer=li \
 //thickness=0.1 //x=8.8 //y=7.585 //x2=8.63 //y2=7.585
r1931 (  265 892 ) resistor r=2.87058 //w=0.35 //l=0.085 //layer=li \
 //thickness=0.1 //x=9.335 //y=7.585 //x2=9.42 //y2=7.585
r1932 (  265 266 ) resistor r=18.6594 //w=0.367 //l=0.535 //layer=li \
 //thickness=0.1 //x=9.335 //y=7.585 //x2=8.8 //y2=7.585
r1933 (  260 890 ) resistor r=2.87058 //w=0.35 //l=0.085 //layer=li \
 //thickness=0.1 //x=7.935 //y=7.585 //x2=7.85 //y2=7.585
r1934 (  260 262 ) resistor r=11.3351 //w=0.367 //l=0.325 //layer=li \
 //thickness=0.1 //x=7.935 //y=7.585 //x2=8.26 //y2=7.585
r1935 (  259 891 ) resistor r=5.29055 //w=0.35 //l=0.17 //layer=li \
 //thickness=0.1 //x=8.46 //y=7.585 //x2=8.63 //y2=7.585
r1936 (  259 262 ) resistor r=6.97548 //w=0.367 //l=0.2 //layer=li \
 //thickness=0.1 //x=8.46 //y=7.585 //x2=8.26 //y2=7.585
r1937 (  253 890 ) resistor r=4.23183 //w=0.7 //l=0.175 //layer=li \
 //thickness=0.1 //x=7.85 //y=7.41 //x2=7.85 //y2=7.585
r1938 (  253 977 ) resistor r=33.1979 //w=0.187 //l=0.485 //layer=li \
 //thickness=0.1 //x=7.85 //y=7.41 //x2=7.85 //y2=6.925
r1939 (  250 889 ) resistor r=2.87058 //w=0.35 //l=0.085 //layer=li \
 //thickness=0.1 //x=7.055 //y=7.585 //x2=6.97 //y2=7.585
r1940 (  250 252 ) resistor r=3.31335 //w=0.367 //l=0.095 //layer=li \
 //thickness=0.1 //x=7.055 //y=7.585 //x2=7.15 //y2=7.585
r1941 (  249 890 ) resistor r=2.87058 //w=0.35 //l=0.085 //layer=li \
 //thickness=0.1 //x=7.765 //y=7.585 //x2=7.85 //y2=7.585
r1942 (  249 252 ) resistor r=21.4496 //w=0.367 //l=0.615 //layer=li \
 //thickness=0.1 //x=7.765 //y=7.585 //x2=7.15 //y2=7.585
r1943 (  243 889 ) resistor r=4.23183 //w=0.7 //l=0.175 //layer=li \
 //thickness=0.1 //x=6.97 //y=7.41 //x2=6.97 //y2=7.585
r1944 (  243 976 ) resistor r=33.1979 //w=0.187 //l=0.485 //layer=li \
 //thickness=0.1 //x=6.97 //y=7.41 //x2=6.97 //y2=6.925
r1945 (  242 888 ) resistor r=2.87058 //w=0.35 //l=0.085 //layer=li \
 //thickness=0.1 //x=6.175 //y=7.585 //x2=6.09 //y2=7.585
r1946 (  241 889 ) resistor r=2.87058 //w=0.35 //l=0.085 //layer=li \
 //thickness=0.1 //x=6.885 //y=7.585 //x2=6.97 //y2=7.585
r1947 (  241 242 ) resistor r=24.7629 //w=0.367 //l=0.71 //layer=li \
 //thickness=0.1 //x=6.885 //y=7.585 //x2=6.175 //y2=7.585
r1948 (  233 888 ) resistor r=4.23183 //w=0.7 //l=0.175 //layer=li \
 //thickness=0.1 //x=6.09 //y=7.41 //x2=6.09 //y2=7.585
r1949 (  233 975 ) resistor r=56.4706 //w=0.187 //l=0.825 //layer=li \
 //thickness=0.1 //x=6.09 //y=7.41 //x2=6.09 //y2=6.585
r1950 (  232 886 ) resistor r=5.29055 //w=0.35 //l=0.17 //layer=li \
 //thickness=0.1 //x=5.47 //y=7.585 //x2=5.3 //y2=7.585
r1951 (  231 888 ) resistor r=2.87058 //w=0.35 //l=0.085 //layer=li \
 //thickness=0.1 //x=6.005 //y=7.585 //x2=6.09 //y2=7.585
r1952 (  231 232 ) resistor r=18.6594 //w=0.367 //l=0.535 //layer=li \
 //thickness=0.1 //x=6.005 //y=7.585 //x2=5.47 //y2=7.585
r1953 (  226 885 ) resistor r=2.87058 //w=0.35 //l=0.085 //layer=li \
 //thickness=0.1 //x=4.305 //y=7.585 //x2=4.22 //y2=7.585
r1954 (  226 228 ) resistor r=8.89373 //w=0.367 //l=0.255 //layer=li \
 //thickness=0.1 //x=4.305 //y=7.585 //x2=4.56 //y2=7.585
r1955 (  225 886 ) resistor r=5.29055 //w=0.35 //l=0.17 //layer=li \
 //thickness=0.1 //x=5.13 //y=7.585 //x2=5.3 //y2=7.585
r1956 (  225 228 ) resistor r=19.8801 //w=0.367 //l=0.57 //layer=li \
 //thickness=0.1 //x=5.13 //y=7.585 //x2=4.56 //y2=7.585
r1957 (  219 885 ) resistor r=4.23183 //w=0.7 //l=0.175 //layer=li \
 //thickness=0.1 //x=4.22 //y=7.41 //x2=4.22 //y2=7.585
r1958 (  219 974 ) resistor r=33.1979 //w=0.187 //l=0.485 //layer=li \
 //thickness=0.1 //x=4.22 //y=7.41 //x2=4.22 //y2=6.925
r1959 (  216 884 ) resistor r=2.87058 //w=0.35 //l=0.085 //layer=li \
 //thickness=0.1 //x=3.425 //y=7.585 //x2=3.34 //y2=7.585
r1960 (  216 218 ) resistor r=0.871935 //w=0.367 //l=0.025 //layer=li \
 //thickness=0.1 //x=3.425 //y=7.585 //x2=3.45 //y2=7.585
r1961 (  215 885 ) resistor r=2.87058 //w=0.35 //l=0.085 //layer=li \
 //thickness=0.1 //x=4.135 //y=7.585 //x2=4.22 //y2=7.585
r1962 (  215 218 ) resistor r=23.891 //w=0.367 //l=0.685 //layer=li \
 //thickness=0.1 //x=4.135 //y=7.585 //x2=3.45 //y2=7.585
r1963 (  209 884 ) resistor r=4.23183 //w=0.7 //l=0.175 //layer=li \
 //thickness=0.1 //x=3.34 //y=7.41 //x2=3.34 //y2=7.585
r1964 (  209 973 ) resistor r=33.1979 //w=0.187 //l=0.485 //layer=li \
 //thickness=0.1 //x=3.34 //y=7.41 //x2=3.34 //y2=6.925
r1965 (  208 883 ) resistor r=2.87058 //w=0.35 //l=0.085 //layer=li \
 //thickness=0.1 //x=2.545 //y=7.585 //x2=2.46 //y2=7.585
r1966 (  207 884 ) resistor r=2.87058 //w=0.35 //l=0.085 //layer=li \
 //thickness=0.1 //x=3.255 //y=7.585 //x2=3.34 //y2=7.585
r1967 (  207 208 ) resistor r=24.7629 //w=0.367 //l=0.71 //layer=li \
 //thickness=0.1 //x=3.255 //y=7.585 //x2=2.545 //y2=7.585
r1968 (  201 883 ) resistor r=4.23183 //w=0.7 //l=0.175 //layer=li \
 //thickness=0.1 //x=2.46 //y=7.41 //x2=2.46 //y2=7.585
r1969 (  201 972 ) resistor r=33.1979 //w=0.187 //l=0.485 //layer=li \
 //thickness=0.1 //x=2.46 //y=7.41 //x2=2.46 //y2=6.925
r1970 (  198 882 ) resistor r=2.87058 //w=0.35 //l=0.085 //layer=li \
 //thickness=0.1 //x=1.665 //y=7.585 //x2=1.58 //y2=7.585
r1971 (  198 200 ) resistor r=23.5422 //w=0.367 //l=0.675 //layer=li \
 //thickness=0.1 //x=1.665 //y=7.585 //x2=2.34 //y2=7.585
r1972 (  197 883 ) resistor r=2.87058 //w=0.35 //l=0.085 //layer=li \
 //thickness=0.1 //x=2.375 //y=7.585 //x2=2.46 //y2=7.585
r1973 (  197 200 ) resistor r=1.22071 //w=0.367 //l=0.035 //layer=li \
 //thickness=0.1 //x=2.375 //y=7.585 //x2=2.34 //y2=7.585
r1974 (  189 882 ) resistor r=4.23183 //w=0.7 //l=0.175 //layer=li \
 //thickness=0.1 //x=1.58 //y=7.41 //x2=1.58 //y2=7.585
r1975 (  189 971 ) resistor r=56.4706 //w=0.187 //l=0.825 //layer=li \
 //thickness=0.1 //x=1.58 //y=7.41 //x2=1.58 //y2=6.585
r1976 (  185 882 ) resistor r=2.87058 //w=0.35 //l=0.085 //layer=li \
 //thickness=0.1 //x=1.495 //y=7.585 //x2=1.58 //y2=7.585
r1977 (  185 188 ) resistor r=9.24251 //w=0.367 //l=0.265 //layer=li \
 //thickness=0.1 //x=1.495 //y=7.585 //x2=1.23 //y2=7.585
r1978 (  182 860 ) resistor r=9.3 //w=0.17 //l=0.17 //layer=mcon //count=1 \
 //x=67.42 //y=6.92 //x2=67.42 //y2=6.92
r1979 (  179 1029 ) resistor r=9.3 //w=0.17 //l=0.17 //layer=mcon //count=1 \
 //x=66.54 //y=6.92 //x2=66.54 //y2=6.92
r1980 (  176 845 ) resistor r=9.3 //w=0.17 //l=0.17 //layer=mcon //count=1 \
 //x=65.66 //y=6.92 //x2=65.66 //y2=6.92
r1981 (  172 832 ) resistor r=3.1 //w=0.17 //l=0.51 //layer=mcon //count=3 \
 //x=65.61 //y=7.58 //x2=65.61 //y2=7.58
r1982 (  133 879 ) resistor r=3.1 //w=0.17 //l=0.51 //layer=mcon //count=3 \
 //x=74.12 //y=7.58 //x2=74.12 //y2=7.58
r1983 (  131 877 ) resistor r=3.1 //w=0.17 //l=0.51 //layer=mcon //count=3 \
 //x=73.01 //y=7.58 //x2=73.01 //y2=7.58
r1984 (  131 133 ) resistor r=0.446141 //w=0.311 //l=1.11 //layer=m1 \
 //thickness=0.36 //x=73.01 //y=7.585 //x2=74.12 //y2=7.585
r1985 (  129 875 ) resistor r=3.1 //w=0.17 //l=0.51 //layer=mcon //count=3 \
 //x=71.9 //y=7.58 //x2=71.9 //y2=7.58
r1986 (  129 131 ) resistor r=0.446141 //w=0.311 //l=1.11 //layer=m1 \
 //thickness=0.36 //x=71.9 //y=7.585 //x2=73.01 //y2=7.585
r1987 (  127 869 ) resistor r=3.1 //w=0.17 //l=0.51 //layer=mcon //count=3 \
 //x=70.42 //y=7.58 //x2=70.42 //y2=7.58
r1988 (  127 129 ) resistor r=0.594855 //w=0.311 //l=1.48 //layer=m1 \
 //thickness=0.36 //x=70.42 //y=7.585 //x2=71.9 //y2=7.585
r1989 (  125 867 ) resistor r=3.1 //w=0.17 //l=0.51 //layer=mcon //count=3 \
 //x=69.31 //y=7.58 //x2=69.31 //y2=7.58
r1990 (  125 127 ) resistor r=0.446141 //w=0.311 //l=1.11 //layer=m1 \
 //thickness=0.36 //x=69.31 //y=7.585 //x2=70.42 //y2=7.585
r1991 (  123 836 ) resistor r=3.1 //w=0.17 //l=0.51 //layer=mcon //count=3 \
 //x=67.83 //y=7.58 //x2=67.83 //y2=7.58
r1992 (  123 125 ) resistor r=0.594855 //w=0.311 //l=1.48 //layer=m1 \
 //thickness=0.36 //x=67.83 //y=7.585 //x2=69.31 //y2=7.585
r1993 (  121 180 ) resistor r=0.028033 //w=0.35 //l=0.085 //layer=m1 \
 //thickness=0.36 //x=67.505 //y=7.585 //x2=67.42 //y2=7.585
r1994 (  121 123 ) resistor r=0.130627 //w=0.311 //l=0.325 //layer=m1 \
 //thickness=0.36 //x=67.505 //y=7.585 //x2=67.83 //y2=7.585
r1995 (  120 180 ) resistor r=0.0413265 //w=0.7 //l=0.175 //layer=m1 \
 //thickness=0.36 //x=67.42 //y=7.41 //x2=67.42 //y2=7.585
r1996 (  119 182 ) resistor r=0.0715665 //w=0.226 //l=0.115 //layer=m1 \
 //thickness=0.36 //x=67.42 //y=7.035 //x2=67.42 //y2=6.92
r1997 (  119 120 ) resistor r=0.357824 //w=0.131 //l=0.375 //layer=m1 \
 //thickness=0.36 //x=67.42 //y=7.035 //x2=67.42 //y2=7.41
r1998 (  118 834 ) resistor r=3.1 //w=0.17 //l=0.51 //layer=mcon //count=3 \
 //x=66.72 //y=7.58 //x2=66.72 //y2=7.58
r1999 (  116 177 ) resistor r=0.028033 //w=0.35 //l=0.085 //layer=m1 \
 //thickness=0.36 //x=66.625 //y=7.585 //x2=66.54 //y2=7.585
r2000 (  116 118 ) resistor r=0.0381833 //w=0.311 //l=0.095 //layer=m1 \
 //thickness=0.36 //x=66.625 //y=7.585 //x2=66.72 //y2=7.585
r2001 (  115 180 ) resistor r=0.028033 //w=0.35 //l=0.085 //layer=m1 \
 //thickness=0.36 //x=67.335 //y=7.585 //x2=67.42 //y2=7.585
r2002 (  115 118 ) resistor r=0.247186 //w=0.311 //l=0.615 //layer=m1 \
 //thickness=0.36 //x=67.335 //y=7.585 //x2=66.72 //y2=7.585
r2003 (  114 177 ) resistor r=0.0413265 //w=0.7 //l=0.175 //layer=m1 \
 //thickness=0.36 //x=66.54 //y=7.41 //x2=66.54 //y2=7.585
r2004 (  113 179 ) resistor r=0.0715665 //w=0.226 //l=0.117473 //layer=m1 \
 //thickness=0.36 //x=66.54 //y=7.035 //x2=66.545 //y2=6.92
r2005 (  113 114 ) resistor r=0.357824 //w=0.131 //l=0.375 //layer=m1 \
 //thickness=0.36 //x=66.54 //y=7.035 //x2=66.54 //y2=7.41
r2006 (  112 172 ) resistor r=0.028033 //w=0.35 //l=0.085 //layer=m1 \
 //thickness=0.36 //x=65.745 //y=7.585 //x2=65.66 //y2=7.585
r2007 (  111 177 ) resistor r=0.028033 //w=0.35 //l=0.085 //layer=m1 \
 //thickness=0.36 //x=66.455 //y=7.585 //x2=66.54 //y2=7.585
r2008 (  111 112 ) resistor r=0.28537 //w=0.311 //l=0.71 //layer=m1 \
 //thickness=0.36 //x=66.455 //y=7.585 //x2=65.745 //y2=7.585
r2009 (  110 172 ) resistor r=0.0413265 //w=0.7 //l=0.175 //layer=m1 \
 //thickness=0.36 //x=65.66 //y=7.41 //x2=65.66 //y2=7.585
r2010 (  109 176 ) resistor r=0.0712609 //w=0.23 //l=0.11649 //layer=m1 \
 //thickness=0.36 //x=65.66 //y=7.035 //x2=65.657 //y2=6.92
r2011 (  109 110 ) resistor r=0.357824 //w=0.131 //l=0.375 //layer=m1 \
 //thickness=0.36 //x=65.66 //y=7.035 //x2=65.66 //y2=7.41
r2012 (  108 967 ) resistor r=3.1 //w=0.17 //l=0.51 //layer=mcon //count=3 \
 //x=64.13 //y=7.58 //x2=64.13 //y2=7.58
r2013 (  106 810 ) resistor r=3.1 //w=0.17 //l=0.51 //layer=mcon //count=3 \
 //x=63.02 //y=7.58 //x2=63.02 //y2=7.58
r2014 (  106 108 ) resistor r=0.446141 //w=0.311 //l=1.11 //layer=m1 \
 //thickness=0.36 //x=63.02 //y=7.585 //x2=64.13 //y2=7.585
r2015 (  104 798 ) resistor r=3.1 //w=0.17 //l=0.51 //layer=mcon //count=3 \
 //x=61.91 //y=7.58 //x2=61.91 //y2=7.58
r2016 (  104 106 ) resistor r=0.446141 //w=0.311 //l=1.11 //layer=m1 \
 //thickness=0.36 //x=61.91 //y=7.585 //x2=63.02 //y2=7.585
r2017 (  102 784 ) resistor r=3.1 //w=0.17 //l=0.51 //layer=mcon //count=3 \
 //x=60.43 //y=7.58 //x2=60.43 //y2=7.58
r2018 (  102 104 ) resistor r=0.594855 //w=0.311 //l=1.48 //layer=m1 \
 //thickness=0.36 //x=60.43 //y=7.585 //x2=61.91 //y2=7.585
r2019 (  100 774 ) resistor r=3.1 //w=0.17 //l=0.51 //layer=mcon //count=3 \
 //x=59.32 //y=7.58 //x2=59.32 //y2=7.58
r2020 (  100 102 ) resistor r=0.446141 //w=0.311 //l=1.11 //layer=m1 \
 //thickness=0.36 //x=59.32 //y=7.585 //x2=60.43 //y2=7.585
r2021 (  98 758 ) resistor r=3.1 //w=0.17 //l=0.51 //layer=mcon //count=3 \
 //x=57.84 //y=7.58 //x2=57.84 //y2=7.58
r2022 (  98 100 ) resistor r=0.594855 //w=0.311 //l=1.48 //layer=m1 \
 //thickness=0.36 //x=57.84 //y=7.585 //x2=59.32 //y2=7.585
r2023 (  96 748 ) resistor r=3.1 //w=0.17 //l=0.51 //layer=mcon //count=3 \
 //x=56.73 //y=7.58 //x2=56.73 //y2=7.58
r2024 (  96 98 ) resistor r=0.446141 //w=0.311 //l=1.11 //layer=m1 \
 //thickness=0.36 //x=56.73 //y=7.585 //x2=57.84 //y2=7.585
r2025 (  94 956 ) resistor r=3.1 //w=0.17 //l=0.51 //layer=mcon //count=3 \
 //x=55.62 //y=7.58 //x2=55.62 //y2=7.58
r2026 (  94 96 ) resistor r=0.446141 //w=0.311 //l=1.11 //layer=m1 \
 //thickness=0.36 //x=55.62 //y=7.585 //x2=56.73 //y2=7.585
r2027 (  92 953 ) resistor r=3.1 //w=0.17 //l=0.51 //layer=mcon //count=3 \
 //x=54.14 //y=7.58 //x2=54.14 //y2=7.58
r2028 (  92 94 ) resistor r=0.594855 //w=0.311 //l=1.48 //layer=m1 \
 //thickness=0.36 //x=54.14 //y=7.585 //x2=55.62 //y2=7.585
r2029 (  90 708 ) resistor r=3.1 //w=0.17 //l=0.51 //layer=mcon //count=3 \
 //x=53.03 //y=7.58 //x2=53.03 //y2=7.58
r2030 (  90 92 ) resistor r=0.446141 //w=0.311 //l=1.11 //layer=m1 \
 //thickness=0.36 //x=53.03 //y=7.585 //x2=54.14 //y2=7.585
r2031 (  88 696 ) resistor r=3.1 //w=0.17 //l=0.51 //layer=mcon //count=3 \
 //x=51.92 //y=7.58 //x2=51.92 //y2=7.58
r2032 (  88 90 ) resistor r=0.446141 //w=0.311 //l=1.11 //layer=m1 \
 //thickness=0.36 //x=51.92 //y=7.585 //x2=53.03 //y2=7.585
r2033 (  86 682 ) resistor r=3.1 //w=0.17 //l=0.51 //layer=mcon //count=3 \
 //x=50.44 //y=7.58 //x2=50.44 //y2=7.58
r2034 (  86 88 ) resistor r=0.594855 //w=0.311 //l=1.48 //layer=m1 \
 //thickness=0.36 //x=50.44 //y=7.585 //x2=51.92 //y2=7.585
r2035 (  84 672 ) resistor r=3.1 //w=0.17 //l=0.51 //layer=mcon //count=3 \
 //x=49.33 //y=7.58 //x2=49.33 //y2=7.58
r2036 (  84 86 ) resistor r=0.446141 //w=0.311 //l=1.11 //layer=m1 \
 //thickness=0.36 //x=49.33 //y=7.585 //x2=50.44 //y2=7.585
r2037 (  82 656 ) resistor r=3.1 //w=0.17 //l=0.51 //layer=mcon //count=3 \
 //x=47.85 //y=7.58 //x2=47.85 //y2=7.58
r2038 (  82 84 ) resistor r=0.594855 //w=0.311 //l=1.48 //layer=m1 \
 //thickness=0.36 //x=47.85 //y=7.585 //x2=49.33 //y2=7.585
r2039 (  80 646 ) resistor r=3.1 //w=0.17 //l=0.51 //layer=mcon //count=3 \
 //x=46.74 //y=7.58 //x2=46.74 //y2=7.58
r2040 (  80 82 ) resistor r=0.446141 //w=0.311 //l=1.11 //layer=m1 \
 //thickness=0.36 //x=46.74 //y=7.585 //x2=47.85 //y2=7.585
r2041 (  78 636 ) resistor r=3.1 //w=0.17 //l=0.51 //layer=mcon //count=3 \
 //x=45.63 //y=7.58 //x2=45.63 //y2=7.58
r2042 (  78 80 ) resistor r=0.446141 //w=0.311 //l=1.11 //layer=m1 \
 //thickness=0.36 //x=45.63 //y=7.585 //x2=46.74 //y2=7.585
r2043 (  76 941 ) resistor r=3.1 //w=0.17 //l=0.51 //layer=mcon //count=3 \
 //x=44.52 //y=7.58 //x2=44.52 //y2=7.58
r2044 (  76 78 ) resistor r=0.446141 //w=0.311 //l=1.11 //layer=m1 \
 //thickness=0.36 //x=44.52 //y=7.585 //x2=45.63 //y2=7.585
r2045 (  74 612 ) resistor r=3.1 //w=0.17 //l=0.51 //layer=mcon //count=3 \
 //x=43.04 //y=7.58 //x2=43.04 //y2=7.58
r2046 (  74 76 ) resistor r=0.594855 //w=0.311 //l=1.48 //layer=m1 \
 //thickness=0.36 //x=43.04 //y=7.585 //x2=44.52 //y2=7.585
r2047 (  72 602 ) resistor r=3.1 //w=0.17 //l=0.51 //layer=mcon //count=3 \
 //x=41.93 //y=7.58 //x2=41.93 //y2=7.58
r2048 (  72 74 ) resistor r=0.446141 //w=0.311 //l=1.11 //layer=m1 \
 //thickness=0.36 //x=41.93 //y=7.585 //x2=43.04 //y2=7.585
r2049 (  70 936 ) resistor r=3.1 //w=0.17 //l=0.51 //layer=mcon //count=3 \
 //x=40.82 //y=7.58 //x2=40.82 //y2=7.58
r2050 (  70 72 ) resistor r=0.446141 //w=0.311 //l=1.11 //layer=m1 \
 //thickness=0.36 //x=40.82 //y=7.585 //x2=41.93 //y2=7.585
r2051 (  68 933 ) resistor r=3.1 //w=0.17 //l=0.51 //layer=mcon //count=3 \
 //x=39.34 //y=7.58 //x2=39.34 //y2=7.58
r2052 (  68 70 ) resistor r=0.594855 //w=0.311 //l=1.48 //layer=m1 \
 //thickness=0.36 //x=39.34 //y=7.585 //x2=40.82 //y2=7.585
r2053 (  66 562 ) resistor r=3.1 //w=0.17 //l=0.51 //layer=mcon //count=3 \
 //x=38.23 //y=7.58 //x2=38.23 //y2=7.58
r2054 (  66 68 ) resistor r=0.446141 //w=0.311 //l=1.11 //layer=m1 \
 //thickness=0.36 //x=38.23 //y=7.585 //x2=39.34 //y2=7.585
r2055 (  63 550 ) resistor r=3.1 //w=0.17 //l=0.51 //layer=mcon //count=3 \
 //x=37.12 //y=7.58 //x2=37.12 //y2=7.58
r2056 (  61 536 ) resistor r=3.1 //w=0.17 //l=0.51 //layer=mcon //count=3 \
 //x=35.64 //y=7.58 //x2=35.64 //y2=7.58
r2057 (  61 63 ) resistor r=0.594855 //w=0.311 //l=1.48 //layer=m1 \
 //thickness=0.36 //x=35.64 //y=7.585 //x2=37.12 //y2=7.585
r2058 (  59 526 ) resistor r=3.1 //w=0.17 //l=0.51 //layer=mcon //count=3 \
 //x=34.53 //y=7.58 //x2=34.53 //y2=7.58
r2059 (  59 61 ) resistor r=0.446141 //w=0.311 //l=1.11 //layer=m1 \
 //thickness=0.36 //x=34.53 //y=7.585 //x2=35.64 //y2=7.585
r2060 (  57 510 ) resistor r=3.1 //w=0.17 //l=0.51 //layer=mcon //count=3 \
 //x=33.05 //y=7.58 //x2=33.05 //y2=7.58
r2061 (  57 59 ) resistor r=0.594855 //w=0.311 //l=1.48 //layer=m1 \
 //thickness=0.36 //x=33.05 //y=7.585 //x2=34.53 //y2=7.585
r2062 (  55 500 ) resistor r=3.1 //w=0.17 //l=0.51 //layer=mcon //count=3 \
 //x=31.94 //y=7.58 //x2=31.94 //y2=7.58
r2063 (  55 57 ) resistor r=0.446141 //w=0.311 //l=1.11 //layer=m1 \
 //thickness=0.36 //x=31.94 //y=7.585 //x2=33.05 //y2=7.585
r2064 (  53 922 ) resistor r=3.1 //w=0.17 //l=0.51 //layer=mcon //count=3 \
 //x=30.83 //y=7.58 //x2=30.83 //y2=7.58
r2065 (  53 55 ) resistor r=0.446141 //w=0.311 //l=1.11 //layer=m1 \
 //thickness=0.36 //x=30.83 //y=7.585 //x2=31.94 //y2=7.585
r2066 (  51 919 ) resistor r=3.1 //w=0.17 //l=0.51 //layer=mcon //count=3 \
 //x=29.35 //y=7.58 //x2=29.35 //y2=7.58
r2067 (  51 53 ) resistor r=0.594855 //w=0.311 //l=1.48 //layer=m1 \
 //thickness=0.36 //x=29.35 //y=7.585 //x2=30.83 //y2=7.585
r2068 (  49 460 ) resistor r=3.1 //w=0.17 //l=0.51 //layer=mcon //count=3 \
 //x=28.24 //y=7.58 //x2=28.24 //y2=7.58
r2069 (  49 51 ) resistor r=0.446141 //w=0.311 //l=1.11 //layer=m1 \
 //thickness=0.36 //x=28.24 //y=7.585 //x2=29.35 //y2=7.585
r2070 (  47 448 ) resistor r=3.1 //w=0.17 //l=0.51 //layer=mcon //count=3 \
 //x=27.13 //y=7.58 //x2=27.13 //y2=7.58
r2071 (  47 49 ) resistor r=0.446141 //w=0.311 //l=1.11 //layer=m1 \
 //thickness=0.36 //x=27.13 //y=7.585 //x2=28.24 //y2=7.585
r2072 (  45 914 ) resistor r=3.1 //w=0.17 //l=0.51 //layer=mcon //count=3 \
 //x=25.65 //y=7.58 //x2=25.65 //y2=7.58
r2073 (  45 47 ) resistor r=0.594855 //w=0.311 //l=1.48 //layer=m1 \
 //thickness=0.36 //x=25.65 //y=7.585 //x2=27.13 //y2=7.585
r2074 (  43 426 ) resistor r=3.1 //w=0.17 //l=0.51 //layer=mcon //count=3 \
 //x=24.54 //y=7.58 //x2=24.54 //y2=7.58
r2075 (  43 45 ) resistor r=0.446141 //w=0.311 //l=1.11 //layer=m1 \
 //thickness=0.36 //x=24.54 //y=7.585 //x2=25.65 //y2=7.585
r2076 (  41 416 ) resistor r=3.1 //w=0.17 //l=0.51 //layer=mcon //count=3 \
 //x=23.43 //y=7.58 //x2=23.43 //y2=7.58
r2077 (  41 43 ) resistor r=0.446141 //w=0.311 //l=1.11 //layer=m1 \
 //thickness=0.36 //x=23.43 //y=7.585 //x2=24.54 //y2=7.585
r2078 (  39 404 ) resistor r=3.1 //w=0.17 //l=0.51 //layer=mcon //count=3 \
 //x=22.32 //y=7.58 //x2=22.32 //y2=7.58
r2079 (  39 41 ) resistor r=0.446141 //w=0.311 //l=1.11 //layer=m1 \
 //thickness=0.36 //x=22.32 //y=7.585 //x2=23.43 //y2=7.585
r2080 (  37 390 ) resistor r=3.1 //w=0.17 //l=0.51 //layer=mcon //count=3 \
 //x=20.84 //y=7.58 //x2=20.84 //y2=7.58
r2081 (  37 39 ) resistor r=0.594855 //w=0.311 //l=1.48 //layer=m1 \
 //thickness=0.36 //x=20.84 //y=7.585 //x2=22.32 //y2=7.585
r2082 (  35 380 ) resistor r=3.1 //w=0.17 //l=0.51 //layer=mcon //count=3 \
 //x=19.73 //y=7.58 //x2=19.73 //y2=7.58
r2083 (  35 37 ) resistor r=0.446141 //w=0.311 //l=1.11 //layer=m1 \
 //thickness=0.36 //x=19.73 //y=7.585 //x2=20.84 //y2=7.585
r2084 (  33 364 ) resistor r=3.1 //w=0.17 //l=0.51 //layer=mcon //count=3 \
 //x=18.25 //y=7.58 //x2=18.25 //y2=7.58
r2085 (  33 35 ) resistor r=0.594855 //w=0.311 //l=1.48 //layer=m1 \
 //thickness=0.36 //x=18.25 //y=7.585 //x2=19.73 //y2=7.585
r2086 (  31 354 ) resistor r=3.1 //w=0.17 //l=0.51 //layer=mcon //count=3 \
 //x=17.14 //y=7.58 //x2=17.14 //y2=7.58
r2087 (  31 33 ) resistor r=0.446141 //w=0.311 //l=1.11 //layer=m1 \
 //thickness=0.36 //x=17.14 //y=7.585 //x2=18.25 //y2=7.585
r2088 (  29 902 ) resistor r=3.1 //w=0.17 //l=0.51 //layer=mcon //count=3 \
 //x=16.03 //y=7.58 //x2=16.03 //y2=7.58
r2089 (  29 31 ) resistor r=0.446141 //w=0.311 //l=1.11 //layer=m1 \
 //thickness=0.36 //x=16.03 //y=7.585 //x2=17.14 //y2=7.585
r2090 (  27 899 ) resistor r=3.1 //w=0.17 //l=0.51 //layer=mcon //count=3 \
 //x=14.55 //y=7.58 //x2=14.55 //y2=7.58
r2091 (  27 29 ) resistor r=0.594855 //w=0.311 //l=1.48 //layer=m1 \
 //thickness=0.36 //x=14.55 //y=7.585 //x2=16.03 //y2=7.585
r2092 (  25 314 ) resistor r=3.1 //w=0.17 //l=0.51 //layer=mcon //count=3 \
 //x=13.44 //y=7.58 //x2=13.44 //y2=7.58
r2093 (  25 27 ) resistor r=0.446141 //w=0.311 //l=1.11 //layer=m1 \
 //thickness=0.36 //x=13.44 //y=7.585 //x2=14.55 //y2=7.585
r2094 (  23 302 ) resistor r=3.1 //w=0.17 //l=0.51 //layer=mcon //count=3 \
 //x=12.33 //y=7.58 //x2=12.33 //y2=7.58
r2095 (  23 25 ) resistor r=0.446141 //w=0.311 //l=1.11 //layer=m1 \
 //thickness=0.36 //x=12.33 //y=7.585 //x2=13.44 //y2=7.585
r2096 (  21 288 ) resistor r=3.1 //w=0.17 //l=0.51 //layer=mcon //count=3 \
 //x=10.85 //y=7.58 //x2=10.85 //y2=7.58
r2097 (  21 23 ) resistor r=0.594855 //w=0.311 //l=1.48 //layer=m1 \
 //thickness=0.36 //x=10.85 //y=7.585 //x2=12.33 //y2=7.585
r2098 (  19 278 ) resistor r=3.1 //w=0.17 //l=0.51 //layer=mcon //count=3 \
 //x=9.74 //y=7.58 //x2=9.74 //y2=7.58
r2099 (  19 21 ) resistor r=0.446141 //w=0.311 //l=1.11 //layer=m1 \
 //thickness=0.36 //x=9.74 //y=7.585 //x2=10.85 //y2=7.585
r2100 (  17 262 ) resistor r=3.1 //w=0.17 //l=0.51 //layer=mcon //count=3 \
 //x=8.26 //y=7.58 //x2=8.26 //y2=7.58
r2101 (  17 19 ) resistor r=0.594855 //w=0.311 //l=1.48 //layer=m1 \
 //thickness=0.36 //x=8.26 //y=7.585 //x2=9.74 //y2=7.585
r2102 (  15 252 ) resistor r=3.1 //w=0.17 //l=0.51 //layer=mcon //count=3 \
 //x=7.15 //y=7.58 //x2=7.15 //y2=7.58
r2103 (  15 17 ) resistor r=0.446141 //w=0.311 //l=1.11 //layer=m1 \
 //thickness=0.36 //x=7.15 //y=7.585 //x2=8.26 //y2=7.585
r2104 (  13 888 ) resistor r=3.1 //w=0.17 //l=0.51 //layer=mcon //count=3 \
 //x=6.04 //y=7.58 //x2=6.04 //y2=7.58
r2105 (  13 15 ) resistor r=0.446141 //w=0.311 //l=1.11 //layer=m1 \
 //thickness=0.36 //x=6.04 //y=7.585 //x2=7.15 //y2=7.585
r2106 (  11 228 ) resistor r=3.1 //w=0.17 //l=0.51 //layer=mcon //count=3 \
 //x=4.56 //y=7.58 //x2=4.56 //y2=7.58
r2107 (  11 13 ) resistor r=0.594855 //w=0.311 //l=1.48 //layer=m1 \
 //thickness=0.36 //x=4.56 //y=7.585 //x2=6.04 //y2=7.585
r2108 (  9 218 ) resistor r=3.1 //w=0.17 //l=0.51 //layer=mcon //count=3 \
 //x=3.45 //y=7.58 //x2=3.45 //y2=7.58
r2109 (  9 11 ) resistor r=0.446141 //w=0.311 //l=1.11 //layer=m1 \
 //thickness=0.36 //x=3.45 //y=7.585 //x2=4.56 //y2=7.585
r2110 (  7 200 ) resistor r=3.1 //w=0.17 //l=0.51 //layer=mcon //count=3 \
 //x=2.34 //y=7.58 //x2=2.34 //y2=7.58
r2111 (  7 9 ) resistor r=0.446141 //w=0.311 //l=1.11 //layer=m1 \
 //thickness=0.36 //x=2.34 //y=7.585 //x2=3.45 //y2=7.585
r2112 (  4 188 ) resistor r=3.1 //w=0.17 //l=0.51 //layer=mcon //count=3 \
 //x=1.23 //y=7.58 //x2=1.23 //y2=7.58
r2113 (  4 7 ) resistor r=0.446141 //w=0.311 //l=1.11 //layer=m1 \
 //thickness=0.36 //x=1.23 //y=7.585 //x2=2.34 //y2=7.585
r2114 (  2 172 ) resistor r=0.028033 //w=0.35 //l=0.085 //layer=m1 \
 //thickness=0.36 //x=65.575 //y=7.585 //x2=65.66 //y2=7.585
r2115 (  2 108 ) resistor r=0.580788 //w=0.311 //l=1.445 //layer=m1 \
 //thickness=0.36 //x=65.575 //y=7.585 //x2=64.13 //y2=7.585
r2116 (  1 66 ) resistor r=0.223071 //w=0.311 //l=0.555 //layer=m1 \
 //thickness=0.36 //x=37.675 //y=7.585 //x2=38.23 //y2=7.585
r2117 (  1 63 ) resistor r=0.223071 //w=0.311 //l=0.555 //layer=m1 \
 //thickness=0.36 //x=37.675 //y=7.585 //x2=37.12 //y2=7.585
ends PM_TMRDFFQNX1\%VDD

subckt PM_TMRDFFQNX1\%noxref_23 ( 5 7 15 19 30 33 34 )
c64 ( 34 0 ) capacitor c=0.0463677f //x=3.455 //y=0.555
c65 ( 33 0 ) capacitor c=0.0198746f //x=2.35 //y=1.09
c66 ( 30 0 ) capacitor c=0.00141302f //x=3.59 //y=1.175
c67 ( 19 0 ) capacitor c=0.00695768f //x=4.56 //y=0.805
c68 ( 15 0 ) capacitor c=0.0154966f //x=4.475 //y=0.72
c69 ( 7 0 ) capacitor c=0.00689476f //x=3.59 //y=0.805
c70 ( 5 0 ) capacitor c=0.0288646f //x=3.505 //y=1.175
r71 (  19 34 ) resistor r=3.57586 //w=0.17 //l=0.125 //layer=li \
 //thickness=0.1 //x=4.56 //y=0.805 //x2=4.56 //y2=0.68
r72 (  19 34 ) resistor r=18.139 //w=0.187 //l=0.265 //layer=li \
 //thickness=0.1 //x=4.56 //y=0.805 //x2=4.56 //y2=1.07
r73 (  16 34 ) resistor r=3.57586 //w=0.17 //l=0.103078 //layer=li \
 //thickness=0.1 //x=3.675 //y=0.72 //x2=3.59 //y2=0.68
r74 (  16 34 ) resistor r=27.3797 //w=0.187 //l=0.4 //layer=li //thickness=0.1 \
 //x=3.675 //y=0.72 //x2=4.075 //y2=0.72
r75 (  15 34 ) resistor r=3.57586 //w=0.17 //l=0.103078 //layer=li \
 //thickness=0.1 //x=4.475 //y=0.72 //x2=4.56 //y2=0.68
r76 (  15 34 ) resistor r=27.3797 //w=0.187 //l=0.4 //layer=li //thickness=0.1 \
 //x=4.475 //y=0.72 //x2=4.075 //y2=0.72
r77 (  11 30 ) resistor r=5.4201 //w=0.17 //l=0.085 //layer=li //thickness=0.1 \
 //x=3.59 //y=1.26 //x2=3.59 //y2=1.175
r78 (  11 34 ) resistor r=10.2674 //w=0.187 //l=0.15 //layer=li \
 //thickness=0.1 //x=3.59 //y=1.26 //x2=3.59 //y2=1.41
r79 (  8 30 ) resistor r=5.4201 //w=0.17 //l=0.085 //layer=li //thickness=0.1 \
 //x=3.59 //y=1.09 //x2=3.59 //y2=1.175
r80 (  8 34 ) resistor r=1.36898 //w=0.187 //l=0.02 //layer=li //thickness=0.1 \
 //x=3.59 //y=1.09 //x2=3.59 //y2=1.07
r81 (  7 34 ) resistor r=3.57586 //w=0.17 //l=0.125 //layer=li //thickness=0.1 \
 //x=3.59 //y=0.805 //x2=3.59 //y2=0.68
r82 (  7 34 ) resistor r=18.139 //w=0.187 //l=0.265 //layer=li //thickness=0.1 \
 //x=3.59 //y=0.805 //x2=3.59 //y2=1.07
r83 (  6 33 ) resistor r=0.751729 //w=0.17 //l=0.085 //layer=li \
 //thickness=0.1 //x=2.625 //y=1.175 //x2=2.54 //y2=1.175
r84 (  5 30 ) resistor r=1.40859 //w=0.34 //l=0.085 //layer=li //thickness=0.1 \
 //x=3.505 //y=1.175 //x2=3.59 //y2=1.175
r85 (  5 6 ) resistor r=60.2353 //w=0.187 //l=0.88 //layer=li //thickness=0.1 \
 //x=3.505 //y=1.175 //x2=2.625 //y2=1.175
ends PM_TMRDFFQNX1\%noxref_23

subckt PM_TMRDFFQNX1\%noxref_24 ( 5 7 15 19 30 33 34 )
c68 ( 34 0 ) capacitor c=0.0455191f //x=24.915 //y=0.555
c69 ( 33 0 ) capacitor c=0.0195173f //x=23.81 //y=1.09
c70 ( 30 0 ) capacitor c=0.00141302f //x=25.05 //y=1.175
c71 ( 19 0 ) capacitor c=0.00695768f //x=26.02 //y=0.805
c72 ( 15 0 ) capacitor c=0.0155183f //x=25.935 //y=0.72
c73 ( 7 0 ) capacitor c=0.00689476f //x=25.05 //y=0.805
c74 ( 5 0 ) capacitor c=0.0241875f //x=24.965 //y=1.175
r75 (  19 34 ) resistor r=3.57586 //w=0.17 //l=0.125 //layer=li \
 //thickness=0.1 //x=26.02 //y=0.805 //x2=26.02 //y2=0.68
r76 (  19 34 ) resistor r=18.139 //w=0.187 //l=0.265 //layer=li \
 //thickness=0.1 //x=26.02 //y=0.805 //x2=26.02 //y2=1.07
r77 (  16 34 ) resistor r=3.57586 //w=0.17 //l=0.103078 //layer=li \
 //thickness=0.1 //x=25.135 //y=0.72 //x2=25.05 //y2=0.68
r78 (  16 34 ) resistor r=27.3797 //w=0.187 //l=0.4 //layer=li //thickness=0.1 \
 //x=25.135 //y=0.72 //x2=25.535 //y2=0.72
r79 (  15 34 ) resistor r=3.57586 //w=0.17 //l=0.103078 //layer=li \
 //thickness=0.1 //x=25.935 //y=0.72 //x2=26.02 //y2=0.68
r80 (  15 34 ) resistor r=27.3797 //w=0.187 //l=0.4 //layer=li //thickness=0.1 \
 //x=25.935 //y=0.72 //x2=25.535 //y2=0.72
r81 (  11 30 ) resistor r=5.4201 //w=0.17 //l=0.085 //layer=li //thickness=0.1 \
 //x=25.05 //y=1.26 //x2=25.05 //y2=1.175
r82 (  11 34 ) resistor r=10.2674 //w=0.187 //l=0.15 //layer=li \
 //thickness=0.1 //x=25.05 //y=1.26 //x2=25.05 //y2=1.41
r83 (  8 30 ) resistor r=5.4201 //w=0.17 //l=0.085 //layer=li //thickness=0.1 \
 //x=25.05 //y=1.09 //x2=25.05 //y2=1.175
r84 (  8 34 ) resistor r=1.36898 //w=0.187 //l=0.02 //layer=li //thickness=0.1 \
 //x=25.05 //y=1.09 //x2=25.05 //y2=1.07
r85 (  7 34 ) resistor r=3.57586 //w=0.17 //l=0.125 //layer=li //thickness=0.1 \
 //x=25.05 //y=0.805 //x2=25.05 //y2=0.68
r86 (  7 34 ) resistor r=18.139 //w=0.187 //l=0.265 //layer=li //thickness=0.1 \
 //x=25.05 //y=0.805 //x2=25.05 //y2=1.07
r87 (  6 33 ) resistor r=0.751729 //w=0.17 //l=0.085 //layer=li \
 //thickness=0.1 //x=24.085 //y=1.175 //x2=24 //y2=1.175
r88 (  5 30 ) resistor r=1.40859 //w=0.34 //l=0.085 //layer=li //thickness=0.1 \
 //x=24.965 //y=1.175 //x2=25.05 //y2=1.175
r89 (  5 6 ) resistor r=60.2353 //w=0.187 //l=0.88 //layer=li //thickness=0.1 \
 //x=24.965 //y=1.175 //x2=24.085 //y2=1.175
ends PM_TMRDFFQNX1\%noxref_24

subckt PM_TMRDFFQNX1\%noxref_25 ( 3 8 9 11 12 14 15 16 19 20 23 25 28 30 38 54 \
 56 57 )
c165 ( 54 0 ) capacitor c=0.00878249f //x=42.04 //y=1.085
c166 ( 38 0 ) capacitor c=0.0322017f //x=42.19 //y=5.56
c167 ( 30 0 ) capacitor c=0.0291951f //x=41.31 //y=5.56
c168 ( 28 0 ) capacitor c=0.0141761f //x=42.67 //y=2.4
c169 ( 25 0 ) capacitor c=0.0112381f //x=42.23 //y=1.18
c170 ( 23 0 ) capacitor c=5.78613e-19 //x=42.19 //y=5.56
c171 ( 20 0 ) capacitor c=0.0107082f //x=42.19 //y=5.38
c172 ( 19 0 ) capacitor c=0.00929664f //x=41.31 //y=5.56
c173 ( 16 0 ) capacitor c=0.076069f //x=42.67 //y=5.295
c174 ( 15 0 ) capacitor c=0.0115456f //x=42.67 //y=2.515
c175 ( 14 0 ) capacitor c=0.00923189f //x=42.67 //y=2.285
c176 ( 12 0 ) capacitor c=0.00465779f //x=42.315 //y=1.835
c177 ( 11 0 ) capacitor c=0.0106899f //x=42.585 //y=1.835
c178 ( 9 0 ) capacitor c=0.0116477f //x=42.585 //y=5.38
c179 ( 8 0 ) capacitor c=0.0133876f //x=42.23 //y=1.75
c180 ( 3 0 ) capacitor c=0.0134497f //x=42.075 //y=5.38
r181 (  38 57 ) resistor r=23.615 //w=0.187 //l=0.345 //layer=li \
 //thickness=0.1 //x=42.19 //y=5.56 //x2=42.19 //y2=5.905
r182 (  30 56 ) resistor r=23.615 //w=0.187 //l=0.345 //layer=li \
 //thickness=0.1 //x=41.31 //y=5.56 //x2=41.31 //y2=5.905
r183 (  25 54 ) resistor r=9.3 //w=0.17 //l=0.17 //layer=mcon //count=1 \
 //x=42.23 //y=1.18 //x2=42.23 //y2=1.18
r184 (  23 38 ) resistor r=9.3 //w=0.17 //l=0.17 //layer=mcon //count=1 \
 //x=42.19 //y=5.56 //x2=42.19 //y2=5.56
r185 (  20 23 ) resistor r=0.117801 //w=0.191 //l=0.18 //layer=m1 \
 //thickness=0.36 //x=42.19 //y=5.38 //x2=42.19 //y2=5.56
r186 (  19 30 ) resistor r=9.3 //w=0.17 //l=0.17 //layer=mcon //count=1 \
 //x=41.31 //y=5.56 //x2=41.31 //y2=5.56
r187 (  17 19 ) resistor r=0.10274 //w=0.219 //l=0.18 //layer=m1 \
 //thickness=0.36 //x=41.31 //y=5.38 //x2=41.31 //y2=5.56
r188 (  15 28 ) resistor r=0.0752589 //w=0.364 //l=0.141863 //layer=m1 \
 //thickness=0.36 //x=42.67 //y=2.515 //x2=42.61 //y2=2.4
r189 (  15 16 ) resistor r=2.65267 //w=0.131 //l=2.78 //layer=m1 \
 //thickness=0.36 //x=42.67 //y=2.515 //x2=42.67 //y2=5.295
r190 (  14 28 ) resistor r=0.0752589 //w=0.364 //l=0.141863 //layer=m1 \
 //thickness=0.36 //x=42.67 //y=2.285 //x2=42.61 //y2=2.4
r191 (  13 14 ) resistor r=0.348282 //w=0.131 //l=0.365 //layer=m1 \
 //thickness=0.36 //x=42.67 //y=1.92 //x2=42.67 //y2=2.285
r192 (  11 13 ) resistor r=0.0698411 //w=0.17 //l=0.120208 //layer=m1 \
 //thickness=0.36 //x=42.585 //y=1.835 //x2=42.67 //y2=1.92
r193 (  11 12 ) resistor r=0.257634 //w=0.131 //l=0.27 //layer=m1 \
 //thickness=0.36 //x=42.585 //y=1.835 //x2=42.315 //y2=1.835
r194 (  10 20 ) resistor r=0.0257089 //w=0.23 //l=0.115 //layer=m1 \
 //thickness=0.36 //x=42.305 //y=5.38 //x2=42.19 //y2=5.38
r195 (  9 16 ) resistor r=0.0698411 //w=0.17 //l=0.120208 //layer=m1 \
 //thickness=0.36 //x=42.585 //y=5.38 //x2=42.67 //y2=5.295
r196 (  9 10 ) resistor r=0.267176 //w=0.131 //l=0.28 //layer=m1 \
 //thickness=0.36 //x=42.585 //y=5.38 //x2=42.305 //y2=5.38
r197 (  8 12 ) resistor r=0.0698411 //w=0.17 //l=0.120208 //layer=m1 \
 //thickness=0.36 //x=42.23 //y=1.75 //x2=42.315 //y2=1.835
r198 (  7 25 ) resistor r=0.0913624 //w=0.191 //l=0.12 //layer=m1 \
 //thickness=0.36 //x=42.23 //y=1.3 //x2=42.23 //y2=1.18
r199 (  7 8 ) resistor r=0.429389 //w=0.131 //l=0.45 //layer=m1 \
 //thickness=0.36 //x=42.23 //y=1.3 //x2=42.23 //y2=1.75
r200 (  4 17 ) resistor r=0.0227762 //w=0.219 //l=0.115 //layer=m1 \
 //thickness=0.36 //x=41.425 //y=5.38 //x2=41.31 //y2=5.38
r201 (  3 20 ) resistor r=0.0257089 //w=0.23 //l=0.115 //layer=m1 \
 //thickness=0.36 //x=42.075 //y=5.38 //x2=42.19 //y2=5.38
r202 (  3 4 ) resistor r=0.620229 //w=0.131 //l=0.65 //layer=m1 \
 //thickness=0.36 //x=42.075 //y=5.38 //x2=41.425 //y2=5.38
ends PM_TMRDFFQNX1\%noxref_25

subckt PM_TMRDFFQNX1\%noxref_26 ( 5 7 15 19 30 33 34 )
c68 ( 34 0 ) capacitor c=0.0453527f //x=46.375 //y=0.555
c69 ( 33 0 ) capacitor c=0.0194867f //x=45.27 //y=1.09
c70 ( 30 0 ) capacitor c=0.00141302f //x=46.51 //y=1.175
c71 ( 19 0 ) capacitor c=0.00695768f //x=47.48 //y=0.805
c72 ( 15 0 ) capacitor c=0.0155081f //x=47.395 //y=0.72
c73 ( 7 0 ) capacitor c=0.00689476f //x=46.51 //y=0.805
c74 ( 5 0 ) capacitor c=0.0235962f //x=46.425 //y=1.175
r75 (  19 34 ) resistor r=3.57586 //w=0.17 //l=0.125 //layer=li \
 //thickness=0.1 //x=47.48 //y=0.805 //x2=47.48 //y2=0.68
r76 (  19 34 ) resistor r=18.139 //w=0.187 //l=0.265 //layer=li \
 //thickness=0.1 //x=47.48 //y=0.805 //x2=47.48 //y2=1.07
r77 (  16 34 ) resistor r=3.57586 //w=0.17 //l=0.103078 //layer=li \
 //thickness=0.1 //x=46.595 //y=0.72 //x2=46.51 //y2=0.68
r78 (  16 34 ) resistor r=27.3797 //w=0.187 //l=0.4 //layer=li //thickness=0.1 \
 //x=46.595 //y=0.72 //x2=46.995 //y2=0.72
r79 (  15 34 ) resistor r=3.57586 //w=0.17 //l=0.103078 //layer=li \
 //thickness=0.1 //x=47.395 //y=0.72 //x2=47.48 //y2=0.68
r80 (  15 34 ) resistor r=27.3797 //w=0.187 //l=0.4 //layer=li //thickness=0.1 \
 //x=47.395 //y=0.72 //x2=46.995 //y2=0.72
r81 (  11 30 ) resistor r=5.4201 //w=0.17 //l=0.085 //layer=li //thickness=0.1 \
 //x=46.51 //y=1.26 //x2=46.51 //y2=1.175
r82 (  11 34 ) resistor r=10.2674 //w=0.187 //l=0.15 //layer=li \
 //thickness=0.1 //x=46.51 //y=1.26 //x2=46.51 //y2=1.41
r83 (  8 30 ) resistor r=5.4201 //w=0.17 //l=0.085 //layer=li //thickness=0.1 \
 //x=46.51 //y=1.09 //x2=46.51 //y2=1.175
r84 (  8 34 ) resistor r=1.36898 //w=0.187 //l=0.02 //layer=li //thickness=0.1 \
 //x=46.51 //y=1.09 //x2=46.51 //y2=1.07
r85 (  7 34 ) resistor r=3.57586 //w=0.17 //l=0.125 //layer=li //thickness=0.1 \
 //x=46.51 //y=0.805 //x2=46.51 //y2=0.68
r86 (  7 34 ) resistor r=18.139 //w=0.187 //l=0.265 //layer=li //thickness=0.1 \
 //x=46.51 //y=0.805 //x2=46.51 //y2=1.07
r87 (  6 33 ) resistor r=0.751729 //w=0.17 //l=0.085 //layer=li \
 //thickness=0.1 //x=45.545 //y=1.175 //x2=45.46 //y2=1.175
r88 (  5 30 ) resistor r=1.40859 //w=0.34 //l=0.085 //layer=li //thickness=0.1 \
 //x=46.425 //y=1.175 //x2=46.51 //y2=1.175
r89 (  5 6 ) resistor r=60.2353 //w=0.187 //l=0.88 //layer=li //thickness=0.1 \
 //x=46.425 //y=1.175 //x2=45.545 //y2=1.175
ends PM_TMRDFFQNX1\%noxref_26

subckt PM_TMRDFFQNX1\%noxref_27 ( 1 3 4 5 7 9 19 25 27 30 40 49 71 72 73 74 75 )
c160 ( 75 0 ) capacitor c=0.0354016f //x=70.595 //y=5.205
c161 ( 74 0 ) capacitor c=0.0241107f //x=69.715 //y=5.205
c162 ( 72 0 ) capacitor c=0.00544792f //x=66.835 //y=5.205
c163 ( 71 0 ) capacitor c=0.00516996f //x=65.955 //y=5.205
c164 ( 49 0 ) capacitor c=0.0509795f //x=68.98 //y=5.39
c165 ( 40 0 ) capacitor c=0.0362911f //x=66.98 //y=5.39
c166 ( 30 0 ) capacitor c=0.0293961f //x=66.1 //y=5.56
c167 ( 27 0 ) capacitor c=0.00984489f //x=70.74 //y=6.92
c168 ( 25 0 ) capacitor c=0.0059844f //x=69.857 //y=7.09
c169 ( 19 0 ) capacitor c=0.00975753f //x=68.98 //y=6.92
c170 ( 9 0 ) capacitor c=0.014892f //x=66.102 //y=5.39
c171 ( 7 0 ) capacitor c=0.00787288f //x=70.625 //y=7.09
c172 ( 5 0 ) capacitor c=0.00659042f //x=69.74 //y=7.09
c173 ( 4 0 ) capacitor c=0.0054878f //x=67.095 //y=5.39
c174 ( 3 0 ) capacitor c=0.0636102f //x=68.865 //y=5.39
c175 ( 1 0 ) capacitor c=0.0145996f //x=66.865 //y=5.39
r176 (  49 73 ) resistor r=58.1818 //w=0.187 //l=0.85 //layer=li \
 //thickness=0.1 //x=68.98 //y=5.39 //x2=68.98 //y2=6.24
r177 (  40 72 ) resistor r=58.1818 //w=0.187 //l=0.85 //layer=li \
 //thickness=0.1 //x=66.98 //y=5.39 //x2=66.98 //y2=6.24
r178 (  30 71 ) resistor r=23.2727 //w=0.187 //l=0.34 //layer=li \
 //thickness=0.1 //x=66.1 //y=5.56 //x2=66.1 //y2=5.9
r179 (  27 75 ) resistor r=9.3 //w=0.17 //l=0.17 //layer=mcon //count=1 \
 //x=70.74 //y=6.92 //x2=70.74 //y2=6.92
r180 (  27 28 ) resistor r=0.0988372 //w=0.215 //l=0.17 //layer=m1 \
 //thickness=0.36 //x=70.742 //y=6.92 //x2=70.742 //y2=7.09
r181 (  24 74 ) resistor r=9.3 //w=0.17 //l=0.17 //layer=mcon //count=1 \
 //x=69.86 //y=6.92 //x2=69.86 //y2=6.92
r182 (  24 25 ) resistor r=0.0940266 //w=0.226 //l=0.17 //layer=m1 \
 //thickness=0.36 //x=69.857 //y=6.92 //x2=69.857 //y2=7.09
r183 (  22 49 ) resistor r=9.3 //w=0.17 //l=0.17 //layer=mcon //count=1 \
 //x=68.98 //y=5.39 //x2=68.98 //y2=5.39
r184 (  19 73 ) resistor r=9.3 //w=0.17 //l=0.17 //layer=mcon //count=1 \
 //x=68.98 //y=6.92 //x2=68.98 //y2=6.92
r185 (  19 20 ) resistor r=0.0979263 //w=0.217 //l=0.17 //layer=m1 \
 //thickness=0.36 //x=68.982 //y=6.92 //x2=68.982 //y2=7.09
r186 (  15 40 ) resistor r=9.3 //w=0.17 //l=0.17 //layer=mcon //count=1 \
 //x=66.98 //y=5.39 //x2=66.98 //y2=5.39
r187 (  11 30 ) resistor r=9.3 //w=0.17 //l=0.17 //layer=mcon //count=1 \
 //x=66.1 //y=5.56 //x2=66.1 //y2=5.56
r188 (  9 11 ) resistor r=0.0944444 //w=0.225 //l=0.17 //layer=m1 \
 //thickness=0.36 //x=66.102 //y=5.39 //x2=66.102 //y2=5.56
r189 (  8 25 ) resistor r=0.0246599 //w=0.226 //l=0.118 //layer=m1 \
 //thickness=0.36 //x=69.975 //y=7.09 //x2=69.857 //y2=7.09
r190 (  7 28 ) resistor r=0.0216707 //w=0.215 //l=0.117 //layer=m1 \
 //thickness=0.36 //x=70.625 //y=7.09 //x2=70.742 //y2=7.09
r191 (  7 8 ) resistor r=0.620229 //w=0.131 //l=0.65 //layer=m1 \
 //thickness=0.36 //x=70.625 //y=7.09 //x2=69.975 //y2=7.09
r192 (  6 20 ) resistor r=0.0222262 //w=0.217 //l=0.118 //layer=m1 \
 //thickness=0.36 //x=69.1 //y=7.09 //x2=68.982 //y2=7.09
r193 (  5 25 ) resistor r=0.0246599 //w=0.226 //l=0.117 //layer=m1 \
 //thickness=0.36 //x=69.74 //y=7.09 //x2=69.857 //y2=7.09
r194 (  5 6 ) resistor r=0.610687 //w=0.131 //l=0.64 //layer=m1 \
 //thickness=0.36 //x=69.74 //y=7.09 //x2=69.1 //y2=7.09
r195 (  4 15 ) resistor r=0.0880901 //w=0.191 //l=0.115 //layer=m1 \
 //thickness=0.36 //x=67.095 //y=5.39 //x2=66.98 //y2=5.39
r196 (  3 22 ) resistor r=0.0717383 //w=0.224 //l=0.115 //layer=m1 \
 //thickness=0.36 //x=68.865 //y=5.39 //x2=68.98 //y2=5.39
r197 (  3 4 ) resistor r=1.68893 //w=0.131 //l=1.77 //layer=m1 \
 //thickness=0.36 //x=68.865 //y=5.39 //x2=67.095 //y2=5.39
r198 (  2 9 ) resistor r=0.0243946 //w=0.225 //l=0.123 //layer=m1 \
 //thickness=0.36 //x=66.225 //y=5.39 //x2=66.102 //y2=5.39
r199 (  1 15 ) resistor r=0.0880901 //w=0.191 //l=0.115 //layer=m1 \
 //thickness=0.36 //x=66.865 //y=5.39 //x2=66.98 //y2=5.39
r200 (  1 2 ) resistor r=0.610687 //w=0.131 //l=0.64 //layer=m1 \
 //thickness=0.36 //x=66.865 //y=5.39 //x2=66.225 //y2=5.39
ends PM_TMRDFFQNX1\%noxref_27

subckt PM_TMRDFFQNX1\%noxref_28 ( 1 3 4 5 7 9 15 21 23 26 34 40 62 63 64 65 66 )
c123 ( 66 0 ) capacitor c=0.0346626f //x=73.935 //y=5.205
c124 ( 65 0 ) capacitor c=0.0239063f //x=73.055 //y=5.205
c125 ( 40 0 ) capacitor c=0.0496943f //x=72.32 //y=5.39
c126 ( 34 0 ) capacitor c=0.0324071f //x=70.3 //y=5.39
c127 ( 26 0 ) capacitor c=0.0224248f //x=69.42 //y=5.56
c128 ( 23 0 ) capacitor c=0.0159821f //x=74.08 //y=6.92
c129 ( 21 0 ) capacitor c=0.00566376f //x=73.2 //y=7.09
c130 ( 15 0 ) capacitor c=0.00945187f //x=72.32 //y=6.92
c131 ( 9 0 ) capacitor c=0.0153382f //x=69.42 //y=5.39
c132 ( 7 0 ) capacitor c=0.0068287f //x=73.95 //y=7.09
c133 ( 5 0 ) capacitor c=0.00878908f //x=73.085 //y=7.09
c134 ( 4 0 ) capacitor c=0.00709931f //x=70.415 //y=5.39
c135 ( 3 0 ) capacitor c=0.0564646f //x=72.205 //y=5.39
c136 ( 1 0 ) capacitor c=0.0183136f //x=70.185 //y=5.39
r137 (  40 64 ) resistor r=58.1818 //w=0.187 //l=0.85 //layer=li \
 //thickness=0.1 //x=72.32 //y=5.39 //x2=72.32 //y2=6.24
r138 (  34 63 ) resistor r=58.1818 //w=0.187 //l=0.85 //layer=li \
 //thickness=0.1 //x=70.3 //y=5.39 //x2=70.3 //y2=6.24
r139 (  26 62 ) resistor r=23.2727 //w=0.187 //l=0.34 //layer=li \
 //thickness=0.1 //x=69.42 //y=5.56 //x2=69.42 //y2=5.9
r140 (  23 66 ) resistor r=9.3 //w=0.17 //l=0.17 //layer=mcon //count=1 \
 //x=74.08 //y=6.92 //x2=74.08 //y2=6.92
r141 (  23 24 ) resistor r=0.0923913 //w=0.23 //l=0.17 //layer=m1 \
 //thickness=0.36 //x=74.075 //y=6.92 //x2=74.075 //y2=7.09
r142 (  20 65 ) resistor r=9.3 //w=0.17 //l=0.17 //layer=mcon //count=1 \
 //x=73.2 //y=6.92 //x2=73.2 //y2=6.92
r143 (  20 21 ) resistor r=0.0957207 //w=0.222 //l=0.17 //layer=m1 \
 //thickness=0.36 //x=73.2 //y=6.92 //x2=73.2 //y2=7.09
r144 (  18 40 ) resistor r=9.3 //w=0.17 //l=0.17 //layer=mcon //count=1 \
 //x=72.32 //y=5.39 //x2=72.32 //y2=5.39
r145 (  15 64 ) resistor r=9.3 //w=0.17 //l=0.17 //layer=mcon //count=1 \
 //x=72.32 //y=6.92 //x2=72.32 //y2=6.92
r146 (  15 16 ) resistor r=0.100236 //w=0.212 //l=0.17 //layer=m1 \
 //thickness=0.36 //x=72.32 //y=6.92 //x2=72.32 //y2=7.09
r147 (  13 34 ) resistor r=9.3 //w=0.17 //l=0.17 //layer=mcon //count=1 \
 //x=70.3 //y=5.39 //x2=70.3 //y2=5.39
r148 (  11 26 ) resistor r=9.3 //w=0.17 //l=0.17 //layer=mcon //count=1 \
 //x=69.42 //y=5.56 //x2=69.42 //y2=5.56
r149 (  9 11 ) resistor r=0.100236 //w=0.212 //l=0.17 //layer=m1 \
 //thickness=0.36 //x=69.42 //y=5.39 //x2=69.42 //y2=5.56
r150 (  8 21 ) resistor r=0.0235912 //w=0.222 //l=0.115 //layer=m1 \
 //thickness=0.36 //x=73.315 //y=7.09 //x2=73.2 //y2=7.09
r151 (  7 24 ) resistor r=0.0257089 //w=0.23 //l=0.125 //layer=m1 \
 //thickness=0.36 //x=73.95 //y=7.09 //x2=74.075 //y2=7.09
r152 (  7 8 ) resistor r=0.605916 //w=0.131 //l=0.635 //layer=m1 \
 //thickness=0.36 //x=73.95 //y=7.09 //x2=73.315 //y2=7.09
r153 (  6 16 ) resistor r=0.0208269 //w=0.212 //l=0.115 //layer=m1 \
 //thickness=0.36 //x=72.435 //y=7.09 //x2=72.32 //y2=7.09
r154 (  5 21 ) resistor r=0.0235912 //w=0.222 //l=0.115 //layer=m1 \
 //thickness=0.36 //x=73.085 //y=7.09 //x2=73.2 //y2=7.09
r155 (  5 6 ) resistor r=0.620229 //w=0.131 //l=0.65 //layer=m1 \
 //thickness=0.36 //x=73.085 //y=7.09 //x2=72.435 //y2=7.09
r156 (  4 13 ) resistor r=0.0880901 //w=0.191 //l=0.115 //layer=m1 \
 //thickness=0.36 //x=70.415 //y=5.39 //x2=70.3 //y2=5.39
r157 (  3 18 ) resistor r=0.0717383 //w=0.224 //l=0.115 //layer=m1 \
 //thickness=0.36 //x=72.205 //y=5.39 //x2=72.32 //y2=5.39
r158 (  3 4 ) resistor r=1.70802 //w=0.131 //l=1.79 //layer=m1 \
 //thickness=0.36 //x=72.205 //y=5.39 //x2=70.415 //y2=5.39
r159 (  2 9 ) resistor r=0.0208269 //w=0.212 //l=0.115 //layer=m1 \
 //thickness=0.36 //x=69.535 //y=5.39 //x2=69.42 //y2=5.39
r160 (  1 13 ) resistor r=0.0880901 //w=0.191 //l=0.115 //layer=m1 \
 //thickness=0.36 //x=70.185 //y=5.39 //x2=70.3 //y2=5.39
r161 (  1 2 ) resistor r=0.620229 //w=0.131 //l=0.65 //layer=m1 \
 //thickness=0.36 //x=70.185 //y=5.39 //x2=69.535 //y2=5.39
ends PM_TMRDFFQNX1\%noxref_28

subckt PM_TMRDFFQNX1\%GND ( 1 2 6 7 19 27 35 45 53 60 61 73 83 91 100 110 117 \
 118 128 136 146 154 162 171 172 179 180 187 192 195 199 200 204 205 210 211 \
 215 216 220 221 226 230 231 235 236 240 241 246 247 251 252 256 261 262 267 \
 268 272 273 277 278 283 284 299 302 316 331 344 359 374 387 404 419 434 447 \
 462 477 494 507 522 537 550 565 580 600 608 609 610 611 612 613 614 615 616 \
 617 618 619 620 621 622 623 624 625 626 627 628 629 630 631 632 633 634 635 \
 636 637 638 639 640 641 642 643 644 645 646 647 648 )
c1531 ( 648 0 ) capacitor c=0.00828027f //x=72.52 //y=1.045
c1532 ( 647 0 ) capacitor c=0.00863093f //x=69.19 //y=1.045
c1533 ( 646 0 ) capacitor c=0.00828027f //x=65.86 //y=1.045
c1534 ( 645 0 ) capacitor c=0.00843555f //x=62.53 //y=1.045
c1535 ( 644 0 ) capacitor c=0.00843555f //x=59.2 //y=1.045
c1536 ( 643 0 ) capacitor c=0.00843555f //x=55.87 //y=1.045
c1537 ( 642 0 ) capacitor c=0.00843555f //x=52.54 //y=1.045
c1538 ( 641 0 ) capacitor c=0.00843555f //x=49.21 //y=1.045
c1539 ( 640 0 ) capacitor c=0.00840423f //x=44.295 //y=1.055
c1540 ( 639 0 ) capacitor c=0.00843555f //x=41.07 //y=1.045
c1541 ( 638 0 ) capacitor c=0.00843555f //x=37.74 //y=1.045
c1542 ( 637 0 ) capacitor c=0.00843555f //x=34.41 //y=1.045
c1543 ( 636 0 ) capacitor c=0.00843555f //x=31.08 //y=1.045
c1544 ( 635 0 ) capacitor c=0.00843555f //x=27.75 //y=1.045
c1545 ( 634 0 ) capacitor c=0.00840423f //x=22.835 //y=1.055
c1546 ( 633 0 ) capacitor c=0.00843555f //x=19.61 //y=1.045
c1547 ( 632 0 ) capacitor c=0.00843555f //x=16.28 //y=1.045
c1548 ( 631 0 ) capacitor c=0.00843555f //x=12.95 //y=1.045
c1549 ( 630 0 ) capacitor c=0.00843555f //x=9.62 //y=1.045
c1550 ( 629 0 ) capacitor c=0.00843555f //x=6.29 //y=1.045
c1551 ( 628 0 ) capacitor c=0.00840423f //x=1.375 //y=1.055
c1552 ( 627 0 ) capacitor c=0.110293f //x=71.53 //y=0.175
c1553 ( 626 0 ) capacitor c=0.123584f //x=68.2 //y=0.175
c1554 ( 625 0 ) capacitor c=0.114864f //x=64.87 //y=0.175
c1555 ( 624 0 ) capacitor c=0.117679f //x=61.54 //y=0.175
c1556 ( 623 0 ) capacitor c=0.117679f //x=58.21 //y=0.175
c1557 ( 622 0 ) capacitor c=0.117679f //x=54.88 //y=0.175
c1558 ( 621 0 ) capacitor c=0.116385f //x=51.55 //y=0.175
c1559 ( 620 0 ) capacitor c=0.117187f //x=48.22 //y=0.175
c1560 ( 619 0 ) capacitor c=0.109921f //x=43.41 //y=0.175
c1561 ( 618 0 ) capacitor c=0.116305f //x=40.08 //y=0.175
c1562 ( 617 0 ) capacitor c=0.116325f //x=36.75 //y=0.175
c1563 ( 616 0 ) capacitor c=0.116325f //x=33.42 //y=0.175
c1564 ( 615 0 ) capacitor c=0.115127f //x=30.09 //y=0.175
c1565 ( 614 0 ) capacitor c=0.116893f //x=26.76 //y=0.175
c1566 ( 613 0 ) capacitor c=0.112091f //x=21.95 //y=0.175
c1567 ( 612 0 ) capacitor c=0.116325f //x=18.62 //y=0.175
c1568 ( 611 0 ) capacitor c=0.116718f //x=15.29 //y=0.175
c1569 ( 610 0 ) capacitor c=0.116479f //x=11.96 //y=0.175
c1570 ( 609 0 ) capacitor c=0.115281f //x=8.63 //y=0.175
c1571 ( 608 0 ) capacitor c=0.117311f //x=5.3 //y=0.175
c1572 ( 600 0 ) capacitor c=0.332498f //x=74.12 //y=0.18
c1573 ( 580 0 ) capacitor c=0.118812f //x=71.36 //y=0.175
c1574 ( 565 0 ) capacitor c=0.119086f //x=68.03 //y=0.175
c1575 ( 550 0 ) capacitor c=0.118923f //x=64.7 //y=0.175
c1576 ( 537 0 ) capacitor c=0.118923f //x=61.37 //y=0.175
c1577 ( 522 0 ) capacitor c=0.118923f //x=58.04 //y=0.175
c1578 ( 507 0 ) capacitor c=0.118923f //x=54.71 //y=0.175
c1579 ( 494 0 ) capacitor c=0.119f //x=51.38 //y=0.175
c1580 ( 477 0 ) capacitor c=0.176412f //x=48.05 //y=0.175
c1581 ( 462 0 ) capacitor c=0.118995f //x=43.24 //y=0.175
c1582 ( 447 0 ) capacitor c=0.118939f //x=39.91 //y=0.175
c1583 ( 434 0 ) capacitor c=0.11895f //x=36.58 //y=0.175
c1584 ( 419 0 ) capacitor c=0.11895f //x=33.25 //y=0.175
c1585 ( 404 0 ) capacitor c=0.119058f //x=29.92 //y=0.175
c1586 ( 387 0 ) capacitor c=0.176537f //x=26.59 //y=0.175
c1587 ( 374 0 ) capacitor c=0.11895f //x=21.78 //y=0.175
c1588 ( 359 0 ) capacitor c=0.11895f //x=18.45 //y=0.175
c1589 ( 344 0 ) capacitor c=0.11895f //x=15.12 //y=0.175
c1590 ( 331 0 ) capacitor c=0.11895f //x=11.79 //y=0.175
c1591 ( 316 0 ) capacitor c=0.123047f //x=8.46 //y=0.175
c1592 ( 302 0 ) capacitor c=0.197064f //x=1.23 //y=0.18
c1593 ( 299 0 ) capacitor c=0.181445f //x=5.13 //y=0.175
c1594 ( 294 0 ) capacitor c=0.00509083f //x=72.71 //y=0.175
c1595 ( 291 0 ) capacitor c=0.00510068f //x=69.31 //y=0.18
c1596 ( 287 0 ) capacitor c=0.00509083f //x=66.05 //y=0.175
c1597 ( 286 0 ) capacitor c=0.00509083f //x=62.72 //y=0.175
c1598 ( 284 0 ) capacitor c=0.0188922f //x=62.717 //y=1.005
c1599 ( 283 0 ) capacitor c=0.0124323f //x=62.72 //y=1.135
c1600 ( 281 0 ) capacitor c=0.00509083f //x=59.32 //y=0.18
c1601 ( 278 0 ) capacitor c=0.0188922f //x=59.387 //y=1.005
c1602 ( 277 0 ) capacitor c=0.0124377f //x=59.39 //y=1.135
c1603 ( 275 0 ) capacitor c=0.00509083f //x=56.06 //y=0.175
c1604 ( 273 0 ) capacitor c=0.0188922f //x=56.057 //y=1.005
c1605 ( 272 0 ) capacitor c=0.0124753f //x=56.06 //y=1.135
c1606 ( 270 0 ) capacitor c=0.00509083f //x=52.73 //y=0.175
c1607 ( 268 0 ) capacitor c=0.0188922f //x=52.727 //y=1.005
c1608 ( 267 0 ) capacitor c=0.0124757f //x=52.73 //y=1.135
c1609 ( 265 0 ) capacitor c=0.00509083f //x=49.33 //y=0.18
c1610 ( 262 0 ) capacitor c=0.0235363f //x=49.397 //y=1.005
c1611 ( 261 0 ) capacitor c=0.0135231f //x=49.4 //y=1.135
c1612 ( 259 0 ) capacitor c=0.00509414f //x=44.52 //y=0.18
c1613 ( 256 0 ) capacitor c=0.0131977f //x=44.485 //y=1.145
c1614 ( 254 0 ) capacitor c=0.00509083f //x=41.26 //y=0.175
c1615 ( 252 0 ) capacitor c=0.0187613f //x=41.257 //y=1.005
c1616 ( 251 0 ) capacitor c=0.0124467f //x=41.26 //y=1.135
c1617 ( 249 0 ) capacitor c=0.00509083f //x=37.93 //y=0.175
c1618 ( 247 0 ) capacitor c=0.0188922f //x=37.927 //y=1.005
c1619 ( 246 0 ) capacitor c=0.0124697f //x=37.93 //y=1.135
c1620 ( 244 0 ) capacitor c=0.00509083f //x=34.53 //y=0.18
c1621 ( 241 0 ) capacitor c=0.0188922f //x=34.597 //y=1.005
c1622 ( 240 0 ) capacitor c=0.0125083f //x=34.6 //y=1.135
c1623 ( 238 0 ) capacitor c=0.00509083f //x=31.27 //y=0.175
c1624 ( 236 0 ) capacitor c=0.0188922f //x=31.267 //y=1.005
c1625 ( 235 0 ) capacitor c=0.0125087f //x=31.27 //y=1.135
c1626 ( 233 0 ) capacitor c=0.00509083f //x=27.94 //y=0.175
c1627 ( 231 0 ) capacitor c=0.0235363f //x=27.937 //y=1.005
c1628 ( 230 0 ) capacitor c=0.0135538f //x=27.94 //y=1.135
c1629 ( 228 0 ) capacitor c=0.00509414f //x=23.025 //y=0.175
c1630 ( 226 0 ) capacitor c=0.0132217f //x=23.025 //y=1.145
c1631 ( 224 0 ) capacitor c=0.00509083f //x=19.73 //y=0.18
c1632 ( 221 0 ) capacitor c=0.0187613f //x=19.797 //y=1.005
c1633 ( 220 0 ) capacitor c=0.0124767f //x=19.8 //y=1.135
c1634 ( 218 0 ) capacitor c=0.00509083f //x=16.47 //y=0.175
c1635 ( 216 0 ) capacitor c=0.0188922f //x=16.467 //y=1.005
c1636 ( 215 0 ) capacitor c=0.0124697f //x=16.47 //y=1.135
c1637 ( 213 0 ) capacitor c=0.00509083f //x=13.14 //y=0.175
c1638 ( 211 0 ) capacitor c=0.0188922f //x=13.137 //y=1.005
c1639 ( 210 0 ) capacitor c=0.0125083f //x=13.14 //y=1.135
c1640 ( 208 0 ) capacitor c=0.00509083f //x=9.74 //y=0.18
c1641 ( 205 0 ) capacitor c=0.0188922f //x=9.807 //y=1.005
c1642 ( 204 0 ) capacitor c=0.0125087f //x=9.81 //y=1.135
c1643 ( 202 0 ) capacitor c=0.00509083f //x=6.48 //y=0.175
c1644 ( 200 0 ) capacitor c=0.0235363f //x=6.477 //y=1.005
c1645 ( 199 0 ) capacitor c=0.013606f //x=6.48 //y=1.135
c1646 ( 197 0 ) capacitor c=0.00509414f //x=1.565 //y=0.175
c1647 ( 195 0 ) capacitor c=0.017081f //x=1.565 //y=1.145
c1648 ( 192 0 ) capacitor c=0.102594f //x=74.12 //y=0.18
c1649 ( 187 0 ) capacitor c=0.0371542f //x=72.71 //y=1.02
c1650 ( 180 0 ) capacitor c=0.107453f //x=72.625 //y=0.175
c1651 ( 179 0 ) capacitor c=0.0279684f //x=69.38 //y=1.01
c1652 ( 172 0 ) capacitor c=0.112278f //x=69.295 //y=0.175
c1653 ( 171 0 ) capacitor c=0.0293669f //x=66.05 //y=1.015
c1654 ( 162 0 ) capacitor c=0.108942f //x=65.965 //y=0.175
c1655 ( 154 0 ) capacitor c=0.111086f //x=62.635 //y=0.175
c1656 ( 146 0 ) capacitor c=0.112269f //x=59.305 //y=0.175
c1657 ( 136 0 ) capacitor c=0.111001f //x=55.975 //y=0.175
c1658 ( 128 0 ) capacitor c=0.112145f //x=52.645 //y=0.175
c1659 ( 118 0 ) capacitor c=0.15471f //x=49.315 //y=0.175
c1660 ( 117 0 ) capacitor c=0.0253397f //x=44.485 //y=1.015
c1661 ( 110 0 ) capacitor c=0.106819f //x=44.4 //y=0.175
c1662 ( 100 0 ) capacitor c=0.110831f //x=41.175 //y=0.175
c1663 ( 91 0 ) capacitor c=0.112282f //x=37.845 //y=0.175
c1664 ( 83 0 ) capacitor c=0.111017f //x=34.515 //y=0.175
c1665 ( 73 0 ) capacitor c=0.112159f //x=31.185 //y=0.175
c1666 ( 61 0 ) capacitor c=0.154725f //x=27.855 //y=0.175
c1667 ( 60 0 ) capacitor c=0.0253397f //x=23.025 //y=1.015
c1668 ( 53 0 ) capacitor c=0.105402f //x=22.94 //y=0.175
c1669 ( 45 0 ) capacitor c=0.11102f //x=19.715 //y=0.175
c1670 ( 35 0 ) capacitor c=0.112282f //x=16.385 //y=0.175
c1671 ( 27 0 ) capacitor c=0.111017f //x=13.055 //y=0.175
c1672 ( 19 0 ) capacitor c=0.112159f //x=9.725 //y=0.175
c1673 ( 7 0 ) capacitor c=0.154867f //x=6.395 //y=0.175
c1674 ( 6 0 ) capacitor c=0.0302305f //x=1.565 //y=1.015
c1675 ( 2 0 ) capacitor c=0.0710427f //x=1.48 //y=0.175
r1676 (  598 600 ) resistor r=38.7139 //w=0.367 //l=1.11 //layer=li \
 //thickness=0.1 //x=73.01 //y=0.175 //x2=74.12 //y2=0.175
r1677 (  596 598 ) resistor r=38.7139 //w=0.367 //l=1.11 //layer=li \
 //thickness=0.1 //x=71.9 //y=0.175 //x2=73.01 //y2=0.175
r1678 (  594 627 ) resistor r=5.29055 //w=0.35 //l=0.17 //layer=li \
 //thickness=0.1 //x=71.7 //y=0.175 //x2=71.53 //y2=0.175
r1679 (  594 596 ) resistor r=6.97548 //w=0.367 //l=0.2 //layer=li \
 //thickness=0.1 //x=71.7 //y=0.175 //x2=71.9 //y2=0.175
r1680 (  583 585 ) resistor r=38.7139 //w=0.367 //l=1.11 //layer=li \
 //thickness=0.1 //x=69.31 //y=0.175 //x2=70.42 //y2=0.175
r1681 (  581 626 ) resistor r=5.29055 //w=0.35 //l=0.17 //layer=li \
 //thickness=0.1 //x=68.37 //y=0.175 //x2=68.2 //y2=0.175
r1682 (  581 583 ) resistor r=32.7847 //w=0.367 //l=0.94 //layer=li \
 //thickness=0.1 //x=68.37 //y=0.175 //x2=69.31 //y2=0.175
r1683 (  580 627 ) resistor r=5.29055 //w=0.35 //l=0.17 //layer=li \
 //thickness=0.1 //x=71.36 //y=0.175 //x2=71.53 //y2=0.175
r1684 (  580 585 ) resistor r=32.7847 //w=0.367 //l=0.94 //layer=li \
 //thickness=0.1 //x=71.36 //y=0.175 //x2=70.42 //y2=0.175
r1685 (  570 572 ) resistor r=38.7139 //w=0.367 //l=1.11 //layer=li \
 //thickness=0.1 //x=66.72 //y=0.175 //x2=67.83 //y2=0.175
r1686 (  568 570 ) resistor r=38.7139 //w=0.367 //l=1.11 //layer=li \
 //thickness=0.1 //x=65.61 //y=0.175 //x2=66.72 //y2=0.175
r1687 (  566 625 ) resistor r=5.29055 //w=0.35 //l=0.17 //layer=li \
 //thickness=0.1 //x=65.04 //y=0.175 //x2=64.87 //y2=0.175
r1688 (  566 568 ) resistor r=19.8801 //w=0.367 //l=0.57 //layer=li \
 //thickness=0.1 //x=65.04 //y=0.175 //x2=65.61 //y2=0.175
r1689 (  565 626 ) resistor r=5.29055 //w=0.35 //l=0.17 //layer=li \
 //thickness=0.1 //x=68.03 //y=0.175 //x2=68.2 //y2=0.175
r1690 (  565 572 ) resistor r=6.97548 //w=0.367 //l=0.2 //layer=li \
 //thickness=0.1 //x=68.03 //y=0.175 //x2=67.83 //y2=0.175
r1691 (  555 557 ) resistor r=38.7139 //w=0.367 //l=1.11 //layer=li \
 //thickness=0.1 //x=63.02 //y=0.175 //x2=64.13 //y2=0.175
r1692 (  553 555 ) resistor r=38.7139 //w=0.367 //l=1.11 //layer=li \
 //thickness=0.1 //x=61.91 //y=0.175 //x2=63.02 //y2=0.175
r1693 (  551 624 ) resistor r=5.29055 //w=0.35 //l=0.17 //layer=li \
 //thickness=0.1 //x=61.71 //y=0.175 //x2=61.54 //y2=0.175
r1694 (  551 553 ) resistor r=6.97548 //w=0.367 //l=0.2 //layer=li \
 //thickness=0.1 //x=61.71 //y=0.175 //x2=61.91 //y2=0.175
r1695 (  550 625 ) resistor r=5.29055 //w=0.35 //l=0.17 //layer=li \
 //thickness=0.1 //x=64.7 //y=0.175 //x2=64.87 //y2=0.175
r1696 (  550 557 ) resistor r=19.8801 //w=0.367 //l=0.57 //layer=li \
 //thickness=0.1 //x=64.7 //y=0.175 //x2=64.13 //y2=0.175
r1697 (  540 542 ) resistor r=38.7139 //w=0.367 //l=1.11 //layer=li \
 //thickness=0.1 //x=59.32 //y=0.175 //x2=60.43 //y2=0.175
r1698 (  538 623 ) resistor r=5.29055 //w=0.35 //l=0.17 //layer=li \
 //thickness=0.1 //x=58.38 //y=0.175 //x2=58.21 //y2=0.175
r1699 (  538 540 ) resistor r=32.7847 //w=0.367 //l=0.94 //layer=li \
 //thickness=0.1 //x=58.38 //y=0.175 //x2=59.32 //y2=0.175
r1700 (  537 624 ) resistor r=5.29055 //w=0.35 //l=0.17 //layer=li \
 //thickness=0.1 //x=61.37 //y=0.175 //x2=61.54 //y2=0.175
r1701 (  537 542 ) resistor r=32.7847 //w=0.367 //l=0.94 //layer=li \
 //thickness=0.1 //x=61.37 //y=0.175 //x2=60.43 //y2=0.175
r1702 (  527 529 ) resistor r=38.7139 //w=0.367 //l=1.11 //layer=li \
 //thickness=0.1 //x=56.73 //y=0.175 //x2=57.84 //y2=0.175
r1703 (  525 527 ) resistor r=38.7139 //w=0.367 //l=1.11 //layer=li \
 //thickness=0.1 //x=55.62 //y=0.175 //x2=56.73 //y2=0.175
r1704 (  523 622 ) resistor r=5.29055 //w=0.35 //l=0.17 //layer=li \
 //thickness=0.1 //x=55.05 //y=0.175 //x2=54.88 //y2=0.175
r1705 (  523 525 ) resistor r=19.8801 //w=0.367 //l=0.57 //layer=li \
 //thickness=0.1 //x=55.05 //y=0.175 //x2=55.62 //y2=0.175
r1706 (  522 623 ) resistor r=5.29055 //w=0.35 //l=0.17 //layer=li \
 //thickness=0.1 //x=58.04 //y=0.175 //x2=58.21 //y2=0.175
r1707 (  522 529 ) resistor r=6.97548 //w=0.367 //l=0.2 //layer=li \
 //thickness=0.1 //x=58.04 //y=0.175 //x2=57.84 //y2=0.175
r1708 (  512 514 ) resistor r=38.7139 //w=0.367 //l=1.11 //layer=li \
 //thickness=0.1 //x=53.03 //y=0.175 //x2=54.14 //y2=0.175
r1709 (  510 512 ) resistor r=38.7139 //w=0.367 //l=1.11 //layer=li \
 //thickness=0.1 //x=51.92 //y=0.175 //x2=53.03 //y2=0.175
r1710 (  508 621 ) resistor r=5.29055 //w=0.35 //l=0.17 //layer=li \
 //thickness=0.1 //x=51.72 //y=0.175 //x2=51.55 //y2=0.175
r1711 (  508 510 ) resistor r=6.97548 //w=0.367 //l=0.2 //layer=li \
 //thickness=0.1 //x=51.72 //y=0.175 //x2=51.92 //y2=0.175
r1712 (  507 622 ) resistor r=5.29055 //w=0.35 //l=0.17 //layer=li \
 //thickness=0.1 //x=54.71 //y=0.175 //x2=54.88 //y2=0.175
r1713 (  507 514 ) resistor r=19.8801 //w=0.367 //l=0.57 //layer=li \
 //thickness=0.1 //x=54.71 //y=0.175 //x2=54.14 //y2=0.175
r1714 (  497 499 ) resistor r=38.7139 //w=0.367 //l=1.11 //layer=li \
 //thickness=0.1 //x=49.33 //y=0.175 //x2=50.44 //y2=0.175
r1715 (  495 620 ) resistor r=5.29055 //w=0.35 //l=0.17 //layer=li \
 //thickness=0.1 //x=48.39 //y=0.175 //x2=48.22 //y2=0.175
r1716 (  495 497 ) resistor r=32.7847 //w=0.367 //l=0.94 //layer=li \
 //thickness=0.1 //x=48.39 //y=0.175 //x2=49.33 //y2=0.175
r1717 (  494 621 ) resistor r=5.29055 //w=0.35 //l=0.17 //layer=li \
 //thickness=0.1 //x=51.38 //y=0.175 //x2=51.55 //y2=0.175
r1718 (  494 499 ) resistor r=32.7847 //w=0.367 //l=0.94 //layer=li \
 //thickness=0.1 //x=51.38 //y=0.175 //x2=50.44 //y2=0.175
r1719 (  484 486 ) resistor r=38.7139 //w=0.367 //l=1.11 //layer=li \
 //thickness=0.1 //x=46.74 //y=0.175 //x2=47.85 //y2=0.175
r1720 (  482 484 ) resistor r=38.7139 //w=0.367 //l=1.11 //layer=li \
 //thickness=0.1 //x=45.63 //y=0.175 //x2=46.74 //y2=0.175
r1721 (  480 482 ) resistor r=38.7139 //w=0.367 //l=1.11 //layer=li \
 //thickness=0.1 //x=44.52 //y=0.175 //x2=45.63 //y2=0.175
r1722 (  478 619 ) resistor r=5.29055 //w=0.35 //l=0.17 //layer=li \
 //thickness=0.1 //x=43.58 //y=0.175 //x2=43.41 //y2=0.175
r1723 (  478 480 ) resistor r=32.7847 //w=0.367 //l=0.94 //layer=li \
 //thickness=0.1 //x=43.58 //y=0.175 //x2=44.52 //y2=0.175
r1724 (  477 620 ) resistor r=5.29055 //w=0.35 //l=0.17 //layer=li \
 //thickness=0.1 //x=48.05 //y=0.175 //x2=48.22 //y2=0.175
r1725 (  477 486 ) resistor r=6.97548 //w=0.367 //l=0.2 //layer=li \
 //thickness=0.1 //x=48.05 //y=0.175 //x2=47.85 //y2=0.175
r1726 (  467 469 ) resistor r=38.7139 //w=0.367 //l=1.11 //layer=li \
 //thickness=0.1 //x=41.93 //y=0.175 //x2=43.04 //y2=0.175
r1727 (  465 467 ) resistor r=38.7139 //w=0.367 //l=1.11 //layer=li \
 //thickness=0.1 //x=40.82 //y=0.175 //x2=41.93 //y2=0.175
r1728 (  463 618 ) resistor r=5.29055 //w=0.35 //l=0.17 //layer=li \
 //thickness=0.1 //x=40.25 //y=0.175 //x2=40.08 //y2=0.175
r1729 (  463 465 ) resistor r=19.8801 //w=0.367 //l=0.57 //layer=li \
 //thickness=0.1 //x=40.25 //y=0.175 //x2=40.82 //y2=0.175
r1730 (  462 619 ) resistor r=5.29055 //w=0.35 //l=0.17 //layer=li \
 //thickness=0.1 //x=43.24 //y=0.175 //x2=43.41 //y2=0.175
r1731 (  462 469 ) resistor r=6.97548 //w=0.367 //l=0.2 //layer=li \
 //thickness=0.1 //x=43.24 //y=0.175 //x2=43.04 //y2=0.175
r1732 (  452 454 ) resistor r=38.7139 //w=0.367 //l=1.11 //layer=li \
 //thickness=0.1 //x=38.23 //y=0.175 //x2=39.34 //y2=0.175
r1733 (  450 452 ) resistor r=38.7139 //w=0.367 //l=1.11 //layer=li \
 //thickness=0.1 //x=37.12 //y=0.175 //x2=38.23 //y2=0.175
r1734 (  448 617 ) resistor r=5.29055 //w=0.35 //l=0.17 //layer=li \
 //thickness=0.1 //x=36.92 //y=0.175 //x2=36.75 //y2=0.175
r1735 (  448 450 ) resistor r=6.97548 //w=0.367 //l=0.2 //layer=li \
 //thickness=0.1 //x=36.92 //y=0.175 //x2=37.12 //y2=0.175
r1736 (  447 618 ) resistor r=5.29055 //w=0.35 //l=0.17 //layer=li \
 //thickness=0.1 //x=39.91 //y=0.175 //x2=40.08 //y2=0.175
r1737 (  447 454 ) resistor r=19.8801 //w=0.367 //l=0.57 //layer=li \
 //thickness=0.1 //x=39.91 //y=0.175 //x2=39.34 //y2=0.175
r1738 (  437 439 ) resistor r=38.7139 //w=0.367 //l=1.11 //layer=li \
 //thickness=0.1 //x=34.53 //y=0.175 //x2=35.64 //y2=0.175
r1739 (  435 616 ) resistor r=5.29055 //w=0.35 //l=0.17 //layer=li \
 //thickness=0.1 //x=33.59 //y=0.175 //x2=33.42 //y2=0.175
r1740 (  435 437 ) resistor r=32.7847 //w=0.367 //l=0.94 //layer=li \
 //thickness=0.1 //x=33.59 //y=0.175 //x2=34.53 //y2=0.175
r1741 (  434 617 ) resistor r=5.29055 //w=0.35 //l=0.17 //layer=li \
 //thickness=0.1 //x=36.58 //y=0.175 //x2=36.75 //y2=0.175
r1742 (  434 439 ) resistor r=32.7847 //w=0.367 //l=0.94 //layer=li \
 //thickness=0.1 //x=36.58 //y=0.175 //x2=35.64 //y2=0.175
r1743 (  424 426 ) resistor r=38.7139 //w=0.367 //l=1.11 //layer=li \
 //thickness=0.1 //x=31.94 //y=0.175 //x2=33.05 //y2=0.175
r1744 (  422 424 ) resistor r=38.7139 //w=0.367 //l=1.11 //layer=li \
 //thickness=0.1 //x=30.83 //y=0.175 //x2=31.94 //y2=0.175
r1745 (  420 615 ) resistor r=5.29055 //w=0.35 //l=0.17 //layer=li \
 //thickness=0.1 //x=30.26 //y=0.175 //x2=30.09 //y2=0.175
r1746 (  420 422 ) resistor r=19.8801 //w=0.367 //l=0.57 //layer=li \
 //thickness=0.1 //x=30.26 //y=0.175 //x2=30.83 //y2=0.175
r1747 (  419 616 ) resistor r=5.29055 //w=0.35 //l=0.17 //layer=li \
 //thickness=0.1 //x=33.25 //y=0.175 //x2=33.42 //y2=0.175
r1748 (  419 426 ) resistor r=6.97548 //w=0.367 //l=0.2 //layer=li \
 //thickness=0.1 //x=33.25 //y=0.175 //x2=33.05 //y2=0.175
r1749 (  409 411 ) resistor r=38.7139 //w=0.367 //l=1.11 //layer=li \
 //thickness=0.1 //x=28.24 //y=0.175 //x2=29.35 //y2=0.175
r1750 (  407 409 ) resistor r=38.7139 //w=0.367 //l=1.11 //layer=li \
 //thickness=0.1 //x=27.13 //y=0.175 //x2=28.24 //y2=0.175
r1751 (  405 614 ) resistor r=5.29055 //w=0.35 //l=0.17 //layer=li \
 //thickness=0.1 //x=26.93 //y=0.175 //x2=26.76 //y2=0.175
r1752 (  405 407 ) resistor r=6.97548 //w=0.367 //l=0.2 //layer=li \
 //thickness=0.1 //x=26.93 //y=0.175 //x2=27.13 //y2=0.175
r1753 (  404 615 ) resistor r=5.29055 //w=0.35 //l=0.17 //layer=li \
 //thickness=0.1 //x=29.92 //y=0.175 //x2=30.09 //y2=0.175
r1754 (  404 411 ) resistor r=19.8801 //w=0.367 //l=0.57 //layer=li \
 //thickness=0.1 //x=29.92 //y=0.175 //x2=29.35 //y2=0.175
r1755 (  394 396 ) resistor r=38.7139 //w=0.367 //l=1.11 //layer=li \
 //thickness=0.1 //x=24.54 //y=0.175 //x2=25.65 //y2=0.175
r1756 (  392 394 ) resistor r=38.7139 //w=0.367 //l=1.11 //layer=li \
 //thickness=0.1 //x=23.43 //y=0.175 //x2=24.54 //y2=0.175
r1757 (  390 392 ) resistor r=38.7139 //w=0.367 //l=1.11 //layer=li \
 //thickness=0.1 //x=22.32 //y=0.175 //x2=23.43 //y2=0.175
r1758 (  388 613 ) resistor r=5.29055 //w=0.35 //l=0.17 //layer=li \
 //thickness=0.1 //x=22.12 //y=0.175 //x2=21.95 //y2=0.175
r1759 (  388 390 ) resistor r=6.97548 //w=0.367 //l=0.2 //layer=li \
 //thickness=0.1 //x=22.12 //y=0.175 //x2=22.32 //y2=0.175
r1760 (  387 614 ) resistor r=5.29055 //w=0.35 //l=0.17 //layer=li \
 //thickness=0.1 //x=26.59 //y=0.175 //x2=26.76 //y2=0.175
r1761 (  387 396 ) resistor r=32.7847 //w=0.367 //l=0.94 //layer=li \
 //thickness=0.1 //x=26.59 //y=0.175 //x2=25.65 //y2=0.175
r1762 (  377 379 ) resistor r=38.7139 //w=0.367 //l=1.11 //layer=li \
 //thickness=0.1 //x=19.73 //y=0.175 //x2=20.84 //y2=0.175
r1763 (  375 612 ) resistor r=5.29055 //w=0.35 //l=0.17 //layer=li \
 //thickness=0.1 //x=18.79 //y=0.175 //x2=18.62 //y2=0.175
r1764 (  375 377 ) resistor r=32.7847 //w=0.367 //l=0.94 //layer=li \
 //thickness=0.1 //x=18.79 //y=0.175 //x2=19.73 //y2=0.175
r1765 (  374 613 ) resistor r=5.29055 //w=0.35 //l=0.17 //layer=li \
 //thickness=0.1 //x=21.78 //y=0.175 //x2=21.95 //y2=0.175
r1766 (  374 379 ) resistor r=32.7847 //w=0.367 //l=0.94 //layer=li \
 //thickness=0.1 //x=21.78 //y=0.175 //x2=20.84 //y2=0.175
r1767 (  364 366 ) resistor r=38.7139 //w=0.367 //l=1.11 //layer=li \
 //thickness=0.1 //x=17.14 //y=0.175 //x2=18.25 //y2=0.175
r1768 (  362 364 ) resistor r=38.7139 //w=0.367 //l=1.11 //layer=li \
 //thickness=0.1 //x=16.03 //y=0.175 //x2=17.14 //y2=0.175
r1769 (  360 611 ) resistor r=5.29055 //w=0.35 //l=0.17 //layer=li \
 //thickness=0.1 //x=15.46 //y=0.175 //x2=15.29 //y2=0.175
r1770 (  360 362 ) resistor r=19.8801 //w=0.367 //l=0.57 //layer=li \
 //thickness=0.1 //x=15.46 //y=0.175 //x2=16.03 //y2=0.175
r1771 (  359 612 ) resistor r=5.29055 //w=0.35 //l=0.17 //layer=li \
 //thickness=0.1 //x=18.45 //y=0.175 //x2=18.62 //y2=0.175
r1772 (  359 366 ) resistor r=6.97548 //w=0.367 //l=0.2 //layer=li \
 //thickness=0.1 //x=18.45 //y=0.175 //x2=18.25 //y2=0.175
r1773 (  349 351 ) resistor r=38.7139 //w=0.367 //l=1.11 //layer=li \
 //thickness=0.1 //x=13.44 //y=0.175 //x2=14.55 //y2=0.175
r1774 (  347 349 ) resistor r=38.7139 //w=0.367 //l=1.11 //layer=li \
 //thickness=0.1 //x=12.33 //y=0.175 //x2=13.44 //y2=0.175
r1775 (  345 610 ) resistor r=5.29055 //w=0.35 //l=0.17 //layer=li \
 //thickness=0.1 //x=12.13 //y=0.175 //x2=11.96 //y2=0.175
r1776 (  345 347 ) resistor r=6.97548 //w=0.367 //l=0.2 //layer=li \
 //thickness=0.1 //x=12.13 //y=0.175 //x2=12.33 //y2=0.175
r1777 (  344 611 ) resistor r=5.29055 //w=0.35 //l=0.17 //layer=li \
 //thickness=0.1 //x=15.12 //y=0.175 //x2=15.29 //y2=0.175
r1778 (  344 351 ) resistor r=19.8801 //w=0.367 //l=0.57 //layer=li \
 //thickness=0.1 //x=15.12 //y=0.175 //x2=14.55 //y2=0.175
r1779 (  334 336 ) resistor r=38.7139 //w=0.367 //l=1.11 //layer=li \
 //thickness=0.1 //x=9.74 //y=0.175 //x2=10.85 //y2=0.175
r1780 (  332 609 ) resistor r=5.29055 //w=0.35 //l=0.17 //layer=li \
 //thickness=0.1 //x=8.8 //y=0.175 //x2=8.63 //y2=0.175
r1781 (  332 334 ) resistor r=32.7847 //w=0.367 //l=0.94 //layer=li \
 //thickness=0.1 //x=8.8 //y=0.175 //x2=9.74 //y2=0.175
r1782 (  331 610 ) resistor r=5.29055 //w=0.35 //l=0.17 //layer=li \
 //thickness=0.1 //x=11.79 //y=0.175 //x2=11.96 //y2=0.175
r1783 (  331 336 ) resistor r=32.7847 //w=0.367 //l=0.94 //layer=li \
 //thickness=0.1 //x=11.79 //y=0.175 //x2=10.85 //y2=0.175
r1784 (  321 323 ) resistor r=38.7139 //w=0.367 //l=1.11 //layer=li \
 //thickness=0.1 //x=7.15 //y=0.175 //x2=8.26 //y2=0.175
r1785 (  319 321 ) resistor r=38.7139 //w=0.367 //l=1.11 //layer=li \
 //thickness=0.1 //x=6.04 //y=0.175 //x2=7.15 //y2=0.175
r1786 (  317 608 ) resistor r=5.29055 //w=0.35 //l=0.17 //layer=li \
 //thickness=0.1 //x=5.47 //y=0.175 //x2=5.3 //y2=0.175
r1787 (  317 319 ) resistor r=19.8801 //w=0.367 //l=0.57 //layer=li \
 //thickness=0.1 //x=5.47 //y=0.175 //x2=6.04 //y2=0.175
r1788 (  316 609 ) resistor r=5.29055 //w=0.35 //l=0.17 //layer=li \
 //thickness=0.1 //x=8.46 //y=0.175 //x2=8.63 //y2=0.175
r1789 (  316 323 ) resistor r=6.97548 //w=0.367 //l=0.2 //layer=li \
 //thickness=0.1 //x=8.46 //y=0.175 //x2=8.26 //y2=0.175
r1790 (  306 308 ) resistor r=38.7139 //w=0.367 //l=1.11 //layer=li \
 //thickness=0.1 //x=3.45 //y=0.175 //x2=4.56 //y2=0.175
r1791 (  304 306 ) resistor r=38.7139 //w=0.367 //l=1.11 //layer=li \
 //thickness=0.1 //x=2.34 //y=0.175 //x2=3.45 //y2=0.175
r1792 (  302 304 ) resistor r=38.7139 //w=0.367 //l=1.11 //layer=li \
 //thickness=0.1 //x=1.23 //y=0.175 //x2=2.34 //y2=0.175
r1793 (  299 608 ) resistor r=5.29055 //w=0.35 //l=0.17 //layer=li \
 //thickness=0.1 //x=5.13 //y=0.175 //x2=5.3 //y2=0.175
r1794 (  299 308 ) resistor r=19.8801 //w=0.367 //l=0.57 //layer=li \
 //thickness=0.1 //x=5.13 //y=0.175 //x2=4.56 //y2=0.175
r1795 (  296 648 ) resistor r=9.3 //w=0.17 //l=0.17 //layer=mcon //count=1 \
 //x=72.71 //y=1.135 //x2=72.71 //y2=1.135
r1796 (  293 647 ) resistor r=9.3 //w=0.17 //l=0.17 //layer=mcon //count=1 \
 //x=69.38 //y=1.135 //x2=69.38 //y2=1.135
r1797 (  291 583 ) resistor r=3.1 //w=0.17 //l=0.51 //layer=mcon //count=3 \
 //x=69.31 //y=0.18 //x2=69.31 //y2=0.18
r1798 (  289 646 ) resistor r=9.3 //w=0.17 //l=0.17 //layer=mcon //count=1 \
 //x=66.05 //y=1.135 //x2=66.05 //y2=1.135
r1799 (  283 645 ) resistor r=9.3 //w=0.17 //l=0.17 //layer=mcon //count=1 \
 //x=62.72 //y=1.135 //x2=62.72 //y2=1.135
r1800 (  283 284 ) resistor r=0.0939994 //w=0.226 //l=0.13 //layer=m1 \
 //thickness=0.36 //x=62.717 //y=1.135 //x2=62.717 //y2=1.005
r1801 (  281 540 ) resistor r=3.1 //w=0.17 //l=0.51 //layer=mcon //count=3 \
 //x=59.32 //y=0.18 //x2=59.32 //y2=0.18
r1802 (  277 644 ) resistor r=9.3 //w=0.17 //l=0.17 //layer=mcon //count=1 \
 //x=59.39 //y=1.135 //x2=59.39 //y2=1.135
r1803 (  277 278 ) resistor r=0.0939994 //w=0.226 //l=0.13 //layer=m1 \
 //thickness=0.36 //x=59.387 //y=1.135 //x2=59.387 //y2=1.005
r1804 (  272 643 ) resistor r=9.3 //w=0.17 //l=0.17 //layer=mcon //count=1 \
 //x=56.06 //y=1.135 //x2=56.06 //y2=1.135
r1805 (  272 273 ) resistor r=0.0939994 //w=0.226 //l=0.13 //layer=m1 \
 //thickness=0.36 //x=56.057 //y=1.135 //x2=56.057 //y2=1.005
r1806 (  267 642 ) resistor r=9.3 //w=0.17 //l=0.17 //layer=mcon //count=1 \
 //x=52.73 //y=1.135 //x2=52.73 //y2=1.135
r1807 (  267 268 ) resistor r=0.0939994 //w=0.226 //l=0.13 //layer=m1 \
 //thickness=0.36 //x=52.727 //y=1.135 //x2=52.727 //y2=1.005
r1808 (  265 497 ) resistor r=3.1 //w=0.17 //l=0.51 //layer=mcon //count=3 \
 //x=49.33 //y=0.18 //x2=49.33 //y2=0.18
r1809 (  261 641 ) resistor r=9.3 //w=0.17 //l=0.17 //layer=mcon //count=1 \
 //x=49.4 //y=1.135 //x2=49.4 //y2=1.135
r1810 (  261 262 ) resistor r=0.0939994 //w=0.226 //l=0.13 //layer=m1 \
 //thickness=0.36 //x=49.397 //y=1.135 //x2=49.397 //y2=1.005
r1811 (  259 480 ) resistor r=3.1 //w=0.17 //l=0.51 //layer=mcon //count=3 \
 //x=44.52 //y=0.18 //x2=44.52 //y2=0.18
r1812 (  256 640 ) resistor r=9.3 //w=0.17 //l=0.17 //layer=mcon //count=1 \
 //x=44.485 //y=1.145 //x2=44.485 //y2=1.145
r1813 (  251 639 ) resistor r=9.3 //w=0.17 //l=0.17 //layer=mcon //count=1 \
 //x=41.26 //y=1.135 //x2=41.26 //y2=1.135
r1814 (  251 252 ) resistor r=0.0939994 //w=0.226 //l=0.13 //layer=m1 \
 //thickness=0.36 //x=41.257 //y=1.135 //x2=41.257 //y2=1.005
r1815 (  246 638 ) resistor r=9.3 //w=0.17 //l=0.17 //layer=mcon //count=1 \
 //x=37.93 //y=1.135 //x2=37.93 //y2=1.135
r1816 (  246 247 ) resistor r=0.0939994 //w=0.226 //l=0.13 //layer=m1 \
 //thickness=0.36 //x=37.927 //y=1.135 //x2=37.927 //y2=1.005
r1817 (  244 437 ) resistor r=3.1 //w=0.17 //l=0.51 //layer=mcon //count=3 \
 //x=34.53 //y=0.18 //x2=34.53 //y2=0.18
r1818 (  240 637 ) resistor r=9.3 //w=0.17 //l=0.17 //layer=mcon //count=1 \
 //x=34.6 //y=1.135 //x2=34.6 //y2=1.135
r1819 (  240 241 ) resistor r=0.0939994 //w=0.226 //l=0.13 //layer=m1 \
 //thickness=0.36 //x=34.597 //y=1.135 //x2=34.597 //y2=1.005
r1820 (  235 636 ) resistor r=9.3 //w=0.17 //l=0.17 //layer=mcon //count=1 \
 //x=31.27 //y=1.135 //x2=31.27 //y2=1.135
r1821 (  235 236 ) resistor r=0.0939994 //w=0.226 //l=0.13 //layer=m1 \
 //thickness=0.36 //x=31.267 //y=1.135 //x2=31.267 //y2=1.005
r1822 (  230 635 ) resistor r=9.3 //w=0.17 //l=0.17 //layer=mcon //count=1 \
 //x=27.94 //y=1.135 //x2=27.94 //y2=1.135
r1823 (  230 231 ) resistor r=0.0939994 //w=0.226 //l=0.13 //layer=m1 \
 //thickness=0.36 //x=27.937 //y=1.135 //x2=27.937 //y2=1.005
r1824 (  226 634 ) resistor r=9.3 //w=0.17 //l=0.17 //layer=mcon //count=1 \
 //x=23.025 //y=1.145 //x2=23.025 //y2=1.145
r1825 (  224 377 ) resistor r=3.1 //w=0.17 //l=0.51 //layer=mcon //count=3 \
 //x=19.73 //y=0.18 //x2=19.73 //y2=0.18
r1826 (  220 633 ) resistor r=9.3 //w=0.17 //l=0.17 //layer=mcon //count=1 \
 //x=19.8 //y=1.135 //x2=19.8 //y2=1.135
r1827 (  220 221 ) resistor r=0.0939994 //w=0.226 //l=0.13 //layer=m1 \
 //thickness=0.36 //x=19.797 //y=1.135 //x2=19.797 //y2=1.005
r1828 (  215 632 ) resistor r=9.3 //w=0.17 //l=0.17 //layer=mcon //count=1 \
 //x=16.47 //y=1.135 //x2=16.47 //y2=1.135
r1829 (  215 216 ) resistor r=0.0939994 //w=0.226 //l=0.13 //layer=m1 \
 //thickness=0.36 //x=16.467 //y=1.135 //x2=16.467 //y2=1.005
r1830 (  210 631 ) resistor r=9.3 //w=0.17 //l=0.17 //layer=mcon //count=1 \
 //x=13.14 //y=1.135 //x2=13.14 //y2=1.135
r1831 (  210 211 ) resistor r=0.0939994 //w=0.226 //l=0.13 //layer=m1 \
 //thickness=0.36 //x=13.137 //y=1.135 //x2=13.137 //y2=1.005
r1832 (  208 334 ) resistor r=3.1 //w=0.17 //l=0.51 //layer=mcon //count=3 \
 //x=9.74 //y=0.18 //x2=9.74 //y2=0.18
r1833 (  204 630 ) resistor r=9.3 //w=0.17 //l=0.17 //layer=mcon //count=1 \
 //x=9.81 //y=1.135 //x2=9.81 //y2=1.135
r1834 (  204 205 ) resistor r=0.0939994 //w=0.226 //l=0.13 //layer=m1 \
 //thickness=0.36 //x=9.807 //y=1.135 //x2=9.807 //y2=1.005
r1835 (  199 629 ) resistor r=9.3 //w=0.17 //l=0.17 //layer=mcon //count=1 \
 //x=6.48 //y=1.135 //x2=6.48 //y2=1.135
r1836 (  199 200 ) resistor r=0.0939994 //w=0.226 //l=0.13 //layer=m1 \
 //thickness=0.36 //x=6.477 //y=1.135 //x2=6.477 //y2=1.005
r1837 (  195 628 ) resistor r=9.3 //w=0.17 //l=0.17 //layer=mcon //count=1 \
 //x=1.565 //y=1.145 //x2=1.565 //y2=1.145
r1838 (  192 600 ) resistor r=3.1 //w=0.17 //l=0.51 //layer=mcon //count=3 \
 //x=74.12 //y=0.18 //x2=74.12 //y2=0.18
r1839 (  190 598 ) resistor r=3.1 //w=0.17 //l=0.51 //layer=mcon //count=3 \
 //x=73.01 //y=0.18 //x2=73.01 //y2=0.18
r1840 (  190 192 ) resistor r=0.446141 //w=0.311 //l=1.11 //layer=m1 \
 //thickness=0.36 //x=73.01 //y=0.175 //x2=74.12 //y2=0.175
r1841 (  188 294 ) resistor r=0.028033 //w=0.35 //l=0.085 //layer=m1 \
 //thickness=0.36 //x=72.795 //y=0.175 //x2=72.71 //y2=0.175
r1842 (  188 190 ) resistor r=0.0864148 //w=0.311 //l=0.215 //layer=m1 \
 //thickness=0.36 //x=72.795 //y=0.175 //x2=73.01 //y2=0.175
r1843 (  187 296 ) resistor r=0.0703067 //w=0.254 //l=0.11649 //layer=m1 \
 //thickness=0.36 //x=72.71 //y=1.02 //x2=72.707 //y2=1.135
r1844 (  186 294 ) resistor r=0.0413265 //w=0.7 //l=0.175 //layer=m1 \
 //thickness=0.36 //x=72.71 //y=0.35 //x2=72.71 //y2=0.175
r1845 (  186 187 ) resistor r=0.639313 //w=0.131 //l=0.67 //layer=m1 \
 //thickness=0.36 //x=72.71 //y=0.35 //x2=72.71 //y2=1.02
r1846 (  185 596 ) resistor r=3.1 //w=0.17 //l=0.51 //layer=mcon //count=3 \
 //x=71.9 //y=0.18 //x2=71.9 //y2=0.18
r1847 (  183 585 ) resistor r=3.1 //w=0.17 //l=0.51 //layer=mcon //count=3 \
 //x=70.42 //y=0.18 //x2=70.42 //y2=0.18
r1848 (  183 185 ) resistor r=0.594855 //w=0.311 //l=1.48 //layer=m1 \
 //thickness=0.36 //x=70.42 //y=0.175 //x2=71.9 //y2=0.175
r1849 (  181 291 ) resistor r=0.028033 //w=0.35 //l=0.085 //layer=m1 \
 //thickness=0.36 //x=69.465 //y=0.175 //x2=69.38 //y2=0.175
r1850 (  181 183 ) resistor r=0.383842 //w=0.311 //l=0.955 //layer=m1 \
 //thickness=0.36 //x=69.465 //y=0.175 //x2=70.42 //y2=0.175
r1851 (  180 294 ) resistor r=0.028033 //w=0.35 //l=0.085 //layer=m1 \
 //thickness=0.36 //x=72.625 //y=0.175 //x2=72.71 //y2=0.175
r1852 (  180 185 ) resistor r=0.291399 //w=0.311 //l=0.725 //layer=m1 \
 //thickness=0.36 //x=72.625 //y=0.175 //x2=71.9 //y2=0.175
r1853 (  179 293 ) resistor r=0.0754636 //w=0.248 //l=0.126491 //layer=m1 \
 //thickness=0.36 //x=69.38 //y=1.01 //x2=69.377 //y2=1.135
r1854 (  178 291 ) resistor r=0.0413265 //w=0.7 //l=0.175 //layer=m1 \
 //thickness=0.36 //x=69.38 //y=0.35 //x2=69.38 //y2=0.175
r1855 (  178 179 ) resistor r=0.629771 //w=0.131 //l=0.66 //layer=m1 \
 //thickness=0.36 //x=69.38 //y=0.35 //x2=69.38 //y2=1.01
r1856 (  177 572 ) resistor r=3.1 //w=0.17 //l=0.51 //layer=mcon //count=3 \
 //x=67.83 //y=0.18 //x2=67.83 //y2=0.18
r1857 (  175 570 ) resistor r=3.1 //w=0.17 //l=0.51 //layer=mcon //count=3 \
 //x=66.72 //y=0.18 //x2=66.72 //y2=0.18
r1858 (  175 177 ) resistor r=0.446141 //w=0.311 //l=1.11 //layer=m1 \
 //thickness=0.36 //x=66.72 //y=0.175 //x2=67.83 //y2=0.175
r1859 (  173 287 ) resistor r=0.028033 //w=0.35 //l=0.085 //layer=m1 \
 //thickness=0.36 //x=66.135 //y=0.175 //x2=66.05 //y2=0.175
r1860 (  173 175 ) resistor r=0.235129 //w=0.311 //l=0.585 //layer=m1 \
 //thickness=0.36 //x=66.135 //y=0.175 //x2=66.72 //y2=0.175
r1861 (  172 291 ) resistor r=0.028033 //w=0.35 //l=0.085 //layer=m1 \
 //thickness=0.36 //x=69.295 //y=0.175 //x2=69.38 //y2=0.175
r1862 (  172 177 ) resistor r=0.588826 //w=0.311 //l=1.465 //layer=m1 \
 //thickness=0.36 //x=69.295 //y=0.175 //x2=67.83 //y2=0.175
r1863 (  171 289 ) resistor r=0.0729089 //w=0.249 //l=0.120996 //layer=m1 \
 //thickness=0.36 //x=66.05 //y=1.015 //x2=66.052 //y2=1.135
r1864 (  170 287 ) resistor r=0.0413265 //w=0.7 //l=0.175 //layer=m1 \
 //thickness=0.36 //x=66.05 //y=0.35 //x2=66.05 //y2=0.175
r1865 (  170 171 ) resistor r=0.634542 //w=0.131 //l=0.665 //layer=m1 \
 //thickness=0.36 //x=66.05 //y=0.35 //x2=66.05 //y2=1.015
r1866 (  169 568 ) resistor r=3.1 //w=0.17 //l=0.51 //layer=mcon //count=3 \
 //x=65.61 //y=0.18 //x2=65.61 //y2=0.18
r1867 (  167 557 ) resistor r=3.1 //w=0.17 //l=0.51 //layer=mcon //count=3 \
 //x=64.13 //y=0.18 //x2=64.13 //y2=0.18
r1868 (  167 169 ) resistor r=0.594855 //w=0.311 //l=1.48 //layer=m1 \
 //thickness=0.36 //x=64.13 //y=0.175 //x2=65.61 //y2=0.175
r1869 (  165 555 ) resistor r=3.1 //w=0.17 //l=0.51 //layer=mcon //count=3 \
 //x=63.02 //y=0.18 //x2=63.02 //y2=0.18
r1870 (  165 167 ) resistor r=0.446141 //w=0.311 //l=1.11 //layer=m1 \
 //thickness=0.36 //x=63.02 //y=0.175 //x2=64.13 //y2=0.175
r1871 (  163 286 ) resistor r=0.028033 //w=0.35 //l=0.085 //layer=m1 \
 //thickness=0.36 //x=62.805 //y=0.175 //x2=62.72 //y2=0.175
r1872 (  163 165 ) resistor r=0.0864148 //w=0.311 //l=0.215 //layer=m1 \
 //thickness=0.36 //x=62.805 //y=0.175 //x2=63.02 //y2=0.175
r1873 (  162 287 ) resistor r=0.028033 //w=0.35 //l=0.085 //layer=m1 \
 //thickness=0.36 //x=65.965 //y=0.175 //x2=66.05 //y2=0.175
r1874 (  162 169 ) resistor r=0.142685 //w=0.311 //l=0.355 //layer=m1 \
 //thickness=0.36 //x=65.965 //y=0.175 //x2=65.61 //y2=0.175
r1875 (  160 286 ) resistor r=0.0413265 //w=0.7 //l=0.175 //layer=m1 \
 //thickness=0.36 //x=62.72 //y=0.35 //x2=62.72 //y2=0.175
r1876 (  160 284 ) resistor r=0.625 //w=0.131 //l=0.655 //layer=m1 \
 //thickness=0.36 //x=62.72 //y=0.35 //x2=62.72 //y2=1.005
r1877 (  159 553 ) resistor r=3.1 //w=0.17 //l=0.51 //layer=mcon //count=3 \
 //x=61.91 //y=0.18 //x2=61.91 //y2=0.18
r1878 (  157 542 ) resistor r=3.1 //w=0.17 //l=0.51 //layer=mcon //count=3 \
 //x=60.43 //y=0.18 //x2=60.43 //y2=0.18
r1879 (  157 159 ) resistor r=0.594855 //w=0.311 //l=1.48 //layer=m1 \
 //thickness=0.36 //x=60.43 //y=0.175 //x2=61.91 //y2=0.175
r1880 (  155 281 ) resistor r=0.028033 //w=0.35 //l=0.085 //layer=m1 \
 //thickness=0.36 //x=59.475 //y=0.175 //x2=59.39 //y2=0.175
r1881 (  155 157 ) resistor r=0.383842 //w=0.311 //l=0.955 //layer=m1 \
 //thickness=0.36 //x=59.475 //y=0.175 //x2=60.43 //y2=0.175
r1882 (  154 286 ) resistor r=0.028033 //w=0.35 //l=0.085 //layer=m1 \
 //thickness=0.36 //x=62.635 //y=0.175 //x2=62.72 //y2=0.175
r1883 (  154 159 ) resistor r=0.291399 //w=0.311 //l=0.725 //layer=m1 \
 //thickness=0.36 //x=62.635 //y=0.175 //x2=61.91 //y2=0.175
r1884 (  152 281 ) resistor r=0.0413265 //w=0.7 //l=0.175 //layer=m1 \
 //thickness=0.36 //x=59.39 //y=0.35 //x2=59.39 //y2=0.175
r1885 (  152 278 ) resistor r=0.625 //w=0.131 //l=0.655 //layer=m1 \
 //thickness=0.36 //x=59.39 //y=0.35 //x2=59.39 //y2=1.005
r1886 (  151 529 ) resistor r=3.1 //w=0.17 //l=0.51 //layer=mcon //count=3 \
 //x=57.84 //y=0.18 //x2=57.84 //y2=0.18
r1887 (  149 527 ) resistor r=3.1 //w=0.17 //l=0.51 //layer=mcon //count=3 \
 //x=56.73 //y=0.18 //x2=56.73 //y2=0.18
r1888 (  149 151 ) resistor r=0.446141 //w=0.311 //l=1.11 //layer=m1 \
 //thickness=0.36 //x=56.73 //y=0.175 //x2=57.84 //y2=0.175
r1889 (  147 275 ) resistor r=0.028033 //w=0.35 //l=0.085 //layer=m1 \
 //thickness=0.36 //x=56.145 //y=0.175 //x2=56.06 //y2=0.175
r1890 (  147 149 ) resistor r=0.235129 //w=0.311 //l=0.585 //layer=m1 \
 //thickness=0.36 //x=56.145 //y=0.175 //x2=56.73 //y2=0.175
r1891 (  146 281 ) resistor r=0.028033 //w=0.35 //l=0.085 //layer=m1 \
 //thickness=0.36 //x=59.305 //y=0.175 //x2=59.39 //y2=0.175
r1892 (  146 151 ) resistor r=0.588826 //w=0.311 //l=1.465 //layer=m1 \
 //thickness=0.36 //x=59.305 //y=0.175 //x2=57.84 //y2=0.175
r1893 (  144 275 ) resistor r=0.0413265 //w=0.7 //l=0.175 //layer=m1 \
 //thickness=0.36 //x=56.06 //y=0.35 //x2=56.06 //y2=0.175
r1894 (  144 273 ) resistor r=0.625 //w=0.131 //l=0.655 //layer=m1 \
 //thickness=0.36 //x=56.06 //y=0.35 //x2=56.06 //y2=1.005
r1895 (  143 525 ) resistor r=3.1 //w=0.17 //l=0.51 //layer=mcon //count=3 \
 //x=55.62 //y=0.18 //x2=55.62 //y2=0.18
r1896 (  141 514 ) resistor r=3.1 //w=0.17 //l=0.51 //layer=mcon //count=3 \
 //x=54.14 //y=0.18 //x2=54.14 //y2=0.18
r1897 (  141 143 ) resistor r=0.594855 //w=0.311 //l=1.48 //layer=m1 \
 //thickness=0.36 //x=54.14 //y=0.175 //x2=55.62 //y2=0.175
r1898 (  139 512 ) resistor r=3.1 //w=0.17 //l=0.51 //layer=mcon //count=3 \
 //x=53.03 //y=0.18 //x2=53.03 //y2=0.18
r1899 (  139 141 ) resistor r=0.446141 //w=0.311 //l=1.11 //layer=m1 \
 //thickness=0.36 //x=53.03 //y=0.175 //x2=54.14 //y2=0.175
r1900 (  137 270 ) resistor r=0.028033 //w=0.35 //l=0.085 //layer=m1 \
 //thickness=0.36 //x=52.815 //y=0.175 //x2=52.73 //y2=0.175
r1901 (  137 139 ) resistor r=0.0864148 //w=0.311 //l=0.215 //layer=m1 \
 //thickness=0.36 //x=52.815 //y=0.175 //x2=53.03 //y2=0.175
r1902 (  136 275 ) resistor r=0.028033 //w=0.35 //l=0.085 //layer=m1 \
 //thickness=0.36 //x=55.975 //y=0.175 //x2=56.06 //y2=0.175
r1903 (  136 143 ) resistor r=0.142685 //w=0.311 //l=0.355 //layer=m1 \
 //thickness=0.36 //x=55.975 //y=0.175 //x2=55.62 //y2=0.175
r1904 (  134 270 ) resistor r=0.0413265 //w=0.7 //l=0.175 //layer=m1 \
 //thickness=0.36 //x=52.73 //y=0.35 //x2=52.73 //y2=0.175
r1905 (  134 268 ) resistor r=0.625 //w=0.131 //l=0.655 //layer=m1 \
 //thickness=0.36 //x=52.73 //y=0.35 //x2=52.73 //y2=1.005
r1906 (  133 510 ) resistor r=3.1 //w=0.17 //l=0.51 //layer=mcon //count=3 \
 //x=51.92 //y=0.18 //x2=51.92 //y2=0.18
r1907 (  131 499 ) resistor r=3.1 //w=0.17 //l=0.51 //layer=mcon //count=3 \
 //x=50.44 //y=0.18 //x2=50.44 //y2=0.18
r1908 (  131 133 ) resistor r=0.594855 //w=0.311 //l=1.48 //layer=m1 \
 //thickness=0.36 //x=50.44 //y=0.175 //x2=51.92 //y2=0.175
r1909 (  129 265 ) resistor r=0.028033 //w=0.35 //l=0.085 //layer=m1 \
 //thickness=0.36 //x=49.485 //y=0.175 //x2=49.4 //y2=0.175
r1910 (  129 131 ) resistor r=0.383842 //w=0.311 //l=0.955 //layer=m1 \
 //thickness=0.36 //x=49.485 //y=0.175 //x2=50.44 //y2=0.175
r1911 (  128 270 ) resistor r=0.028033 //w=0.35 //l=0.085 //layer=m1 \
 //thickness=0.36 //x=52.645 //y=0.175 //x2=52.73 //y2=0.175
r1912 (  128 133 ) resistor r=0.291399 //w=0.311 //l=0.725 //layer=m1 \
 //thickness=0.36 //x=52.645 //y=0.175 //x2=51.92 //y2=0.175
r1913 (  126 265 ) resistor r=0.0413265 //w=0.7 //l=0.175 //layer=m1 \
 //thickness=0.36 //x=49.4 //y=0.35 //x2=49.4 //y2=0.175
r1914 (  126 262 ) resistor r=0.625 //w=0.131 //l=0.655 //layer=m1 \
 //thickness=0.36 //x=49.4 //y=0.35 //x2=49.4 //y2=1.005
r1915 (  125 486 ) resistor r=3.1 //w=0.17 //l=0.51 //layer=mcon //count=3 \
 //x=47.85 //y=0.18 //x2=47.85 //y2=0.18
r1916 (  123 484 ) resistor r=3.1 //w=0.17 //l=0.51 //layer=mcon //count=3 \
 //x=46.74 //y=0.18 //x2=46.74 //y2=0.18
r1917 (  123 125 ) resistor r=0.446141 //w=0.311 //l=1.11 //layer=m1 \
 //thickness=0.36 //x=46.74 //y=0.175 //x2=47.85 //y2=0.175
r1918 (  121 482 ) resistor r=3.1 //w=0.17 //l=0.51 //layer=mcon //count=3 \
 //x=45.63 //y=0.18 //x2=45.63 //y2=0.18
r1919 (  121 123 ) resistor r=0.446141 //w=0.311 //l=1.11 //layer=m1 \
 //thickness=0.36 //x=45.63 //y=0.175 //x2=46.74 //y2=0.175
r1920 (  119 259 ) resistor r=0.028033 //w=0.35 //l=0.085 //layer=m1 \
 //thickness=0.36 //x=44.57 //y=0.175 //x2=44.485 //y2=0.175
r1921 (  119 121 ) resistor r=0.426045 //w=0.311 //l=1.06 //layer=m1 \
 //thickness=0.36 //x=44.57 //y=0.175 //x2=45.63 //y2=0.175
r1922 (  118 265 ) resistor r=0.028033 //w=0.35 //l=0.085 //layer=m1 \
 //thickness=0.36 //x=49.315 //y=0.175 //x2=49.4 //y2=0.175
r1923 (  118 125 ) resistor r=0.588826 //w=0.311 //l=1.465 //layer=m1 \
 //thickness=0.36 //x=49.315 //y=0.175 //x2=47.85 //y2=0.175
r1924 (  117 256 ) resistor r=0.0942778 //w=0.221 //l=0.13 //layer=m1 \
 //thickness=0.36 //x=44.485 //y=1.015 //x2=44.485 //y2=1.145
r1925 (  116 259 ) resistor r=0.0413265 //w=0.7 //l=0.175 //layer=m1 \
 //thickness=0.36 //x=44.485 //y=0.35 //x2=44.485 //y2=0.175
r1926 (  116 117 ) resistor r=0.634542 //w=0.131 //l=0.665 //layer=m1 \
 //thickness=0.36 //x=44.485 //y=0.35 //x2=44.485 //y2=1.015
r1927 (  115 469 ) resistor r=3.1 //w=0.17 //l=0.51 //layer=mcon //count=3 \
 //x=43.04 //y=0.18 //x2=43.04 //y2=0.18
r1928 (  113 467 ) resistor r=3.1 //w=0.17 //l=0.51 //layer=mcon //count=3 \
 //x=41.93 //y=0.18 //x2=41.93 //y2=0.18
r1929 (  113 115 ) resistor r=0.446141 //w=0.311 //l=1.11 //layer=m1 \
 //thickness=0.36 //x=41.93 //y=0.175 //x2=43.04 //y2=0.175
r1930 (  111 254 ) resistor r=0.028033 //w=0.35 //l=0.085 //layer=m1 \
 //thickness=0.36 //x=41.345 //y=0.175 //x2=41.26 //y2=0.175
r1931 (  111 113 ) resistor r=0.235129 //w=0.311 //l=0.585 //layer=m1 \
 //thickness=0.36 //x=41.345 //y=0.175 //x2=41.93 //y2=0.175
r1932 (  110 259 ) resistor r=0.028033 //w=0.35 //l=0.085 //layer=m1 \
 //thickness=0.36 //x=44.4 //y=0.175 //x2=44.485 //y2=0.175
r1933 (  110 115 ) resistor r=0.546624 //w=0.311 //l=1.36 //layer=m1 \
 //thickness=0.36 //x=44.4 //y=0.175 //x2=43.04 //y2=0.175
r1934 (  108 254 ) resistor r=0.0413265 //w=0.7 //l=0.175 //layer=m1 \
 //thickness=0.36 //x=41.26 //y=0.35 //x2=41.26 //y2=0.175
r1935 (  108 252 ) resistor r=0.625 //w=0.131 //l=0.655 //layer=m1 \
 //thickness=0.36 //x=41.26 //y=0.35 //x2=41.26 //y2=1.005
r1936 (  107 465 ) resistor r=3.1 //w=0.17 //l=0.51 //layer=mcon //count=3 \
 //x=40.82 //y=0.18 //x2=40.82 //y2=0.18
r1937 (  105 454 ) resistor r=3.1 //w=0.17 //l=0.51 //layer=mcon //count=3 \
 //x=39.34 //y=0.18 //x2=39.34 //y2=0.18
r1938 (  105 107 ) resistor r=0.594855 //w=0.311 //l=1.48 //layer=m1 \
 //thickness=0.36 //x=39.34 //y=0.175 //x2=40.82 //y2=0.175
r1939 (  103 452 ) resistor r=3.1 //w=0.17 //l=0.51 //layer=mcon //count=3 \
 //x=38.23 //y=0.18 //x2=38.23 //y2=0.18
r1940 (  103 105 ) resistor r=0.446141 //w=0.311 //l=1.11 //layer=m1 \
 //thickness=0.36 //x=38.23 //y=0.175 //x2=39.34 //y2=0.175
r1941 (  101 249 ) resistor r=0.028033 //w=0.35 //l=0.085 //layer=m1 \
 //thickness=0.36 //x=38.015 //y=0.175 //x2=37.93 //y2=0.175
r1942 (  101 103 ) resistor r=0.0864148 //w=0.311 //l=0.215 //layer=m1 \
 //thickness=0.36 //x=38.015 //y=0.175 //x2=38.23 //y2=0.175
r1943 (  100 254 ) resistor r=0.028033 //w=0.35 //l=0.085 //layer=m1 \
 //thickness=0.36 //x=41.175 //y=0.175 //x2=41.26 //y2=0.175
r1944 (  100 107 ) resistor r=0.142685 //w=0.311 //l=0.355 //layer=m1 \
 //thickness=0.36 //x=41.175 //y=0.175 //x2=40.82 //y2=0.175
r1945 (  98 249 ) resistor r=0.0413265 //w=0.7 //l=0.175 //layer=m1 \
 //thickness=0.36 //x=37.93 //y=0.35 //x2=37.93 //y2=0.175
r1946 (  98 247 ) resistor r=0.625 //w=0.131 //l=0.655 //layer=m1 \
 //thickness=0.36 //x=37.93 //y=0.35 //x2=37.93 //y2=1.005
r1947 (  96 450 ) resistor r=3.1 //w=0.17 //l=0.51 //layer=mcon //count=3 \
 //x=37.12 //y=0.18 //x2=37.12 //y2=0.18
r1948 (  94 439 ) resistor r=3.1 //w=0.17 //l=0.51 //layer=mcon //count=3 \
 //x=35.64 //y=0.18 //x2=35.64 //y2=0.18
r1949 (  94 96 ) resistor r=0.594855 //w=0.311 //l=1.48 //layer=m1 \
 //thickness=0.36 //x=35.64 //y=0.175 //x2=37.12 //y2=0.175
r1950 (  92 244 ) resistor r=0.028033 //w=0.35 //l=0.085 //layer=m1 \
 //thickness=0.36 //x=34.685 //y=0.175 //x2=34.6 //y2=0.175
r1951 (  92 94 ) resistor r=0.383842 //w=0.311 //l=0.955 //layer=m1 \
 //thickness=0.36 //x=34.685 //y=0.175 //x2=35.64 //y2=0.175
r1952 (  91 249 ) resistor r=0.028033 //w=0.35 //l=0.085 //layer=m1 \
 //thickness=0.36 //x=37.845 //y=0.175 //x2=37.93 //y2=0.175
r1953 (  89 244 ) resistor r=0.0413265 //w=0.7 //l=0.175 //layer=m1 \
 //thickness=0.36 //x=34.6 //y=0.35 //x2=34.6 //y2=0.175
r1954 (  89 241 ) resistor r=0.625 //w=0.131 //l=0.655 //layer=m1 \
 //thickness=0.36 //x=34.6 //y=0.35 //x2=34.6 //y2=1.005
r1955 (  88 426 ) resistor r=3.1 //w=0.17 //l=0.51 //layer=mcon //count=3 \
 //x=33.05 //y=0.18 //x2=33.05 //y2=0.18
r1956 (  86 424 ) resistor r=3.1 //w=0.17 //l=0.51 //layer=mcon //count=3 \
 //x=31.94 //y=0.18 //x2=31.94 //y2=0.18
r1957 (  86 88 ) resistor r=0.446141 //w=0.311 //l=1.11 //layer=m1 \
 //thickness=0.36 //x=31.94 //y=0.175 //x2=33.05 //y2=0.175
r1958 (  84 238 ) resistor r=0.028033 //w=0.35 //l=0.085 //layer=m1 \
 //thickness=0.36 //x=31.355 //y=0.175 //x2=31.27 //y2=0.175
r1959 (  84 86 ) resistor r=0.235129 //w=0.311 //l=0.585 //layer=m1 \
 //thickness=0.36 //x=31.355 //y=0.175 //x2=31.94 //y2=0.175
r1960 (  83 244 ) resistor r=0.028033 //w=0.35 //l=0.085 //layer=m1 \
 //thickness=0.36 //x=34.515 //y=0.175 //x2=34.6 //y2=0.175
r1961 (  83 88 ) resistor r=0.588826 //w=0.311 //l=1.465 //layer=m1 \
 //thickness=0.36 //x=34.515 //y=0.175 //x2=33.05 //y2=0.175
r1962 (  81 238 ) resistor r=0.0413265 //w=0.7 //l=0.175 //layer=m1 \
 //thickness=0.36 //x=31.27 //y=0.35 //x2=31.27 //y2=0.175
r1963 (  81 236 ) resistor r=0.625 //w=0.131 //l=0.655 //layer=m1 \
 //thickness=0.36 //x=31.27 //y=0.35 //x2=31.27 //y2=1.005
r1964 (  80 422 ) resistor r=3.1 //w=0.17 //l=0.51 //layer=mcon //count=3 \
 //x=30.83 //y=0.18 //x2=30.83 //y2=0.18
r1965 (  78 411 ) resistor r=3.1 //w=0.17 //l=0.51 //layer=mcon //count=3 \
 //x=29.35 //y=0.18 //x2=29.35 //y2=0.18
r1966 (  78 80 ) resistor r=0.594855 //w=0.311 //l=1.48 //layer=m1 \
 //thickness=0.36 //x=29.35 //y=0.175 //x2=30.83 //y2=0.175
r1967 (  76 409 ) resistor r=3.1 //w=0.17 //l=0.51 //layer=mcon //count=3 \
 //x=28.24 //y=0.18 //x2=28.24 //y2=0.18
r1968 (  76 78 ) resistor r=0.446141 //w=0.311 //l=1.11 //layer=m1 \
 //thickness=0.36 //x=28.24 //y=0.175 //x2=29.35 //y2=0.175
r1969 (  74 233 ) resistor r=0.028033 //w=0.35 //l=0.085 //layer=m1 \
 //thickness=0.36 //x=28.025 //y=0.175 //x2=27.94 //y2=0.175
r1970 (  74 76 ) resistor r=0.0864148 //w=0.311 //l=0.215 //layer=m1 \
 //thickness=0.36 //x=28.025 //y=0.175 //x2=28.24 //y2=0.175
r1971 (  73 238 ) resistor r=0.028033 //w=0.35 //l=0.085 //layer=m1 \
 //thickness=0.36 //x=31.185 //y=0.175 //x2=31.27 //y2=0.175
r1972 (  73 80 ) resistor r=0.142685 //w=0.311 //l=0.355 //layer=m1 \
 //thickness=0.36 //x=31.185 //y=0.175 //x2=30.83 //y2=0.175
r1973 (  71 233 ) resistor r=0.0413265 //w=0.7 //l=0.175 //layer=m1 \
 //thickness=0.36 //x=27.94 //y=0.35 //x2=27.94 //y2=0.175
r1974 (  71 231 ) resistor r=0.625 //w=0.131 //l=0.655 //layer=m1 \
 //thickness=0.36 //x=27.94 //y=0.35 //x2=27.94 //y2=1.005
r1975 (  70 407 ) resistor r=3.1 //w=0.17 //l=0.51 //layer=mcon //count=3 \
 //x=27.13 //y=0.18 //x2=27.13 //y2=0.18
r1976 (  68 396 ) resistor r=3.1 //w=0.17 //l=0.51 //layer=mcon //count=3 \
 //x=25.65 //y=0.18 //x2=25.65 //y2=0.18
r1977 (  68 70 ) resistor r=0.594855 //w=0.311 //l=1.48 //layer=m1 \
 //thickness=0.36 //x=25.65 //y=0.175 //x2=27.13 //y2=0.175
r1978 (  66 394 ) resistor r=3.1 //w=0.17 //l=0.51 //layer=mcon //count=3 \
 //x=24.54 //y=0.18 //x2=24.54 //y2=0.18
r1979 (  66 68 ) resistor r=0.446141 //w=0.311 //l=1.11 //layer=m1 \
 //thickness=0.36 //x=24.54 //y=0.175 //x2=25.65 //y2=0.175
r1980 (  64 392 ) resistor r=3.1 //w=0.17 //l=0.51 //layer=mcon //count=3 \
 //x=23.43 //y=0.18 //x2=23.43 //y2=0.18
r1981 (  64 66 ) resistor r=0.446141 //w=0.311 //l=1.11 //layer=m1 \
 //thickness=0.36 //x=23.43 //y=0.175 //x2=24.54 //y2=0.175
r1982 (  62 228 ) resistor r=0.028033 //w=0.35 //l=0.085 //layer=m1 \
 //thickness=0.36 //x=23.11 //y=0.175 //x2=23.025 //y2=0.175
r1983 (  62 64 ) resistor r=0.128617 //w=0.311 //l=0.32 //layer=m1 \
 //thickness=0.36 //x=23.11 //y=0.175 //x2=23.43 //y2=0.175
r1984 (  61 233 ) resistor r=0.028033 //w=0.35 //l=0.085 //layer=m1 \
 //thickness=0.36 //x=27.855 //y=0.175 //x2=27.94 //y2=0.175
r1985 (  61 70 ) resistor r=0.291399 //w=0.311 //l=0.725 //layer=m1 \
 //thickness=0.36 //x=27.855 //y=0.175 //x2=27.13 //y2=0.175
r1986 (  60 226 ) resistor r=0.0942778 //w=0.221 //l=0.13 //layer=m1 \
 //thickness=0.36 //x=23.025 //y=1.015 //x2=23.025 //y2=1.145
r1987 (  59 228 ) resistor r=0.0413265 //w=0.7 //l=0.175 //layer=m1 \
 //thickness=0.36 //x=23.025 //y=0.35 //x2=23.025 //y2=0.175
r1988 (  59 60 ) resistor r=0.634542 //w=0.131 //l=0.665 //layer=m1 \
 //thickness=0.36 //x=23.025 //y=0.35 //x2=23.025 //y2=1.015
r1989 (  58 390 ) resistor r=3.1 //w=0.17 //l=0.51 //layer=mcon //count=3 \
 //x=22.32 //y=0.18 //x2=22.32 //y2=0.18
r1990 (  56 379 ) resistor r=3.1 //w=0.17 //l=0.51 //layer=mcon //count=3 \
 //x=20.84 //y=0.18 //x2=20.84 //y2=0.18
r1991 (  56 58 ) resistor r=0.594855 //w=0.311 //l=1.48 //layer=m1 \
 //thickness=0.36 //x=20.84 //y=0.175 //x2=22.32 //y2=0.175
r1992 (  54 224 ) resistor r=0.028033 //w=0.35 //l=0.085 //layer=m1 \
 //thickness=0.36 //x=19.885 //y=0.175 //x2=19.8 //y2=0.175
r1993 (  54 56 ) resistor r=0.383842 //w=0.311 //l=0.955 //layer=m1 \
 //thickness=0.36 //x=19.885 //y=0.175 //x2=20.84 //y2=0.175
r1994 (  53 228 ) resistor r=0.028033 //w=0.35 //l=0.085 //layer=m1 \
 //thickness=0.36 //x=22.94 //y=0.175 //x2=23.025 //y2=0.175
r1995 (  53 58 ) resistor r=0.249196 //w=0.311 //l=0.62 //layer=m1 \
 //thickness=0.36 //x=22.94 //y=0.175 //x2=22.32 //y2=0.175
r1996 (  51 224 ) resistor r=0.0413265 //w=0.7 //l=0.175 //layer=m1 \
 //thickness=0.36 //x=19.8 //y=0.35 //x2=19.8 //y2=0.175
r1997 (  51 221 ) resistor r=0.625 //w=0.131 //l=0.655 //layer=m1 \
 //thickness=0.36 //x=19.8 //y=0.35 //x2=19.8 //y2=1.005
r1998 (  50 366 ) resistor r=3.1 //w=0.17 //l=0.51 //layer=mcon //count=3 \
 //x=18.25 //y=0.18 //x2=18.25 //y2=0.18
r1999 (  48 364 ) resistor r=3.1 //w=0.17 //l=0.51 //layer=mcon //count=3 \
 //x=17.14 //y=0.18 //x2=17.14 //y2=0.18
r2000 (  48 50 ) resistor r=0.446141 //w=0.311 //l=1.11 //layer=m1 \
 //thickness=0.36 //x=17.14 //y=0.175 //x2=18.25 //y2=0.175
r2001 (  46 218 ) resistor r=0.028033 //w=0.35 //l=0.085 //layer=m1 \
 //thickness=0.36 //x=16.555 //y=0.175 //x2=16.47 //y2=0.175
r2002 (  46 48 ) resistor r=0.235129 //w=0.311 //l=0.585 //layer=m1 \
 //thickness=0.36 //x=16.555 //y=0.175 //x2=17.14 //y2=0.175
r2003 (  45 224 ) resistor r=0.028033 //w=0.35 //l=0.085 //layer=m1 \
 //thickness=0.36 //x=19.715 //y=0.175 //x2=19.8 //y2=0.175
r2004 (  45 50 ) resistor r=0.588826 //w=0.311 //l=1.465 //layer=m1 \
 //thickness=0.36 //x=19.715 //y=0.175 //x2=18.25 //y2=0.175
r2005 (  43 218 ) resistor r=0.0413265 //w=0.7 //l=0.175 //layer=m1 \
 //thickness=0.36 //x=16.47 //y=0.35 //x2=16.47 //y2=0.175
r2006 (  43 216 ) resistor r=0.625 //w=0.131 //l=0.655 //layer=m1 \
 //thickness=0.36 //x=16.47 //y=0.35 //x2=16.47 //y2=1.005
r2007 (  42 362 ) resistor r=3.1 //w=0.17 //l=0.51 //layer=mcon //count=3 \
 //x=16.03 //y=0.18 //x2=16.03 //y2=0.18
r2008 (  40 351 ) resistor r=3.1 //w=0.17 //l=0.51 //layer=mcon //count=3 \
 //x=14.55 //y=0.18 //x2=14.55 //y2=0.18
r2009 (  40 42 ) resistor r=0.594855 //w=0.311 //l=1.48 //layer=m1 \
 //thickness=0.36 //x=14.55 //y=0.175 //x2=16.03 //y2=0.175
r2010 (  38 349 ) resistor r=3.1 //w=0.17 //l=0.51 //layer=mcon //count=3 \
 //x=13.44 //y=0.18 //x2=13.44 //y2=0.18
r2011 (  38 40 ) resistor r=0.446141 //w=0.311 //l=1.11 //layer=m1 \
 //thickness=0.36 //x=13.44 //y=0.175 //x2=14.55 //y2=0.175
r2012 (  36 213 ) resistor r=0.028033 //w=0.35 //l=0.085 //layer=m1 \
 //thickness=0.36 //x=13.225 //y=0.175 //x2=13.14 //y2=0.175
r2013 (  36 38 ) resistor r=0.0864148 //w=0.311 //l=0.215 //layer=m1 \
 //thickness=0.36 //x=13.225 //y=0.175 //x2=13.44 //y2=0.175
r2014 (  35 218 ) resistor r=0.028033 //w=0.35 //l=0.085 //layer=m1 \
 //thickness=0.36 //x=16.385 //y=0.175 //x2=16.47 //y2=0.175
r2015 (  35 42 ) resistor r=0.142685 //w=0.311 //l=0.355 //layer=m1 \
 //thickness=0.36 //x=16.385 //y=0.175 //x2=16.03 //y2=0.175
r2016 (  33 213 ) resistor r=0.0413265 //w=0.7 //l=0.175 //layer=m1 \
 //thickness=0.36 //x=13.14 //y=0.35 //x2=13.14 //y2=0.175
r2017 (  33 211 ) resistor r=0.625 //w=0.131 //l=0.655 //layer=m1 \
 //thickness=0.36 //x=13.14 //y=0.35 //x2=13.14 //y2=1.005
r2018 (  32 347 ) resistor r=3.1 //w=0.17 //l=0.51 //layer=mcon //count=3 \
 //x=12.33 //y=0.18 //x2=12.33 //y2=0.18
r2019 (  30 336 ) resistor r=3.1 //w=0.17 //l=0.51 //layer=mcon //count=3 \
 //x=10.85 //y=0.18 //x2=10.85 //y2=0.18
r2020 (  30 32 ) resistor r=0.594855 //w=0.311 //l=1.48 //layer=m1 \
 //thickness=0.36 //x=10.85 //y=0.175 //x2=12.33 //y2=0.175
r2021 (  28 208 ) resistor r=0.028033 //w=0.35 //l=0.085 //layer=m1 \
 //thickness=0.36 //x=9.895 //y=0.175 //x2=9.81 //y2=0.175
r2022 (  28 30 ) resistor r=0.383842 //w=0.311 //l=0.955 //layer=m1 \
 //thickness=0.36 //x=9.895 //y=0.175 //x2=10.85 //y2=0.175
r2023 (  27 213 ) resistor r=0.028033 //w=0.35 //l=0.085 //layer=m1 \
 //thickness=0.36 //x=13.055 //y=0.175 //x2=13.14 //y2=0.175
r2024 (  27 32 ) resistor r=0.291399 //w=0.311 //l=0.725 //layer=m1 \
 //thickness=0.36 //x=13.055 //y=0.175 //x2=12.33 //y2=0.175
r2025 (  25 208 ) resistor r=0.0413265 //w=0.7 //l=0.175 //layer=m1 \
 //thickness=0.36 //x=9.81 //y=0.35 //x2=9.81 //y2=0.175
r2026 (  25 205 ) resistor r=0.625 //w=0.131 //l=0.655 //layer=m1 \
 //thickness=0.36 //x=9.81 //y=0.35 //x2=9.81 //y2=1.005
r2027 (  24 323 ) resistor r=3.1 //w=0.17 //l=0.51 //layer=mcon //count=3 \
 //x=8.26 //y=0.18 //x2=8.26 //y2=0.18
r2028 (  22 321 ) resistor r=3.1 //w=0.17 //l=0.51 //layer=mcon //count=3 \
 //x=7.15 //y=0.18 //x2=7.15 //y2=0.18
r2029 (  22 24 ) resistor r=0.446141 //w=0.311 //l=1.11 //layer=m1 \
 //thickness=0.36 //x=7.15 //y=0.175 //x2=8.26 //y2=0.175
r2030 (  20 202 ) resistor r=0.028033 //w=0.35 //l=0.085 //layer=m1 \
 //thickness=0.36 //x=6.565 //y=0.175 //x2=6.48 //y2=0.175
r2031 (  20 22 ) resistor r=0.235129 //w=0.311 //l=0.585 //layer=m1 \
 //thickness=0.36 //x=6.565 //y=0.175 //x2=7.15 //y2=0.175
r2032 (  19 208 ) resistor r=0.028033 //w=0.35 //l=0.085 //layer=m1 \
 //thickness=0.36 //x=9.725 //y=0.175 //x2=9.81 //y2=0.175
r2033 (  19 24 ) resistor r=0.588826 //w=0.311 //l=1.465 //layer=m1 \
 //thickness=0.36 //x=9.725 //y=0.175 //x2=8.26 //y2=0.175
r2034 (  17 202 ) resistor r=0.0413265 //w=0.7 //l=0.175 //layer=m1 \
 //thickness=0.36 //x=6.48 //y=0.35 //x2=6.48 //y2=0.175
r2035 (  17 200 ) resistor r=0.625 //w=0.131 //l=0.655 //layer=m1 \
 //thickness=0.36 //x=6.48 //y=0.35 //x2=6.48 //y2=1.005
r2036 (  16 319 ) resistor r=3.1 //w=0.17 //l=0.51 //layer=mcon //count=3 \
 //x=6.04 //y=0.18 //x2=6.04 //y2=0.18
r2037 (  14 308 ) resistor r=3.1 //w=0.17 //l=0.51 //layer=mcon //count=3 \
 //x=4.56 //y=0.18 //x2=4.56 //y2=0.18
r2038 (  14 16 ) resistor r=0.594855 //w=0.311 //l=1.48 //layer=m1 \
 //thickness=0.36 //x=4.56 //y=0.175 //x2=6.04 //y2=0.175
r2039 (  12 306 ) resistor r=3.1 //w=0.17 //l=0.51 //layer=mcon //count=3 \
 //x=3.45 //y=0.18 //x2=3.45 //y2=0.18
r2040 (  12 14 ) resistor r=0.446141 //w=0.311 //l=1.11 //layer=m1 \
 //thickness=0.36 //x=3.45 //y=0.175 //x2=4.56 //y2=0.175
r2041 (  10 304 ) resistor r=3.1 //w=0.17 //l=0.51 //layer=mcon //count=3 \
 //x=2.34 //y=0.18 //x2=2.34 //y2=0.18
r2042 (  10 12 ) resistor r=0.446141 //w=0.311 //l=1.11 //layer=m1 \
 //thickness=0.36 //x=2.34 //y=0.175 //x2=3.45 //y2=0.175
r2043 (  8 197 ) resistor r=0.028033 //w=0.35 //l=0.085 //layer=m1 \
 //thickness=0.36 //x=1.65 //y=0.175 //x2=1.565 //y2=0.175
r2044 (  8 10 ) resistor r=0.277331 //w=0.311 //l=0.69 //layer=m1 \
 //thickness=0.36 //x=1.65 //y=0.175 //x2=2.34 //y2=0.175
r2045 (  7 202 ) resistor r=0.028033 //w=0.35 //l=0.085 //layer=m1 \
 //thickness=0.36 //x=6.395 //y=0.175 //x2=6.48 //y2=0.175
r2046 (  7 16 ) resistor r=0.142685 //w=0.311 //l=0.355 //layer=m1 \
 //thickness=0.36 //x=6.395 //y=0.175 //x2=6.04 //y2=0.175
r2047 (  6 195 ) resistor r=0.0942778 //w=0.221 //l=0.13 //layer=m1 \
 //thickness=0.36 //x=1.565 //y=1.015 //x2=1.565 //y2=1.145
r2048 (  5 197 ) resistor r=0.0413265 //w=0.7 //l=0.175 //layer=m1 \
 //thickness=0.36 //x=1.565 //y=0.35 //x2=1.565 //y2=0.175
r2049 (  5 6 ) resistor r=0.634542 //w=0.131 //l=0.665 //layer=m1 \
 //thickness=0.36 //x=1.565 //y=0.35 //x2=1.565 //y2=1.015
r2050 (  4 302 ) resistor r=3.1 //w=0.17 //l=0.51 //layer=mcon //count=3 \
 //x=1.23 //y=0.18 //x2=1.23 //y2=0.18
r2051 (  2 197 ) resistor r=0.028033 //w=0.35 //l=0.085 //layer=m1 \
 //thickness=0.36 //x=1.48 //y=0.175 //x2=1.565 //y2=0.175
r2052 (  2 4 ) resistor r=0.0892857 //w=0.35 //l=0.25 //layer=m1 \
 //thickness=0.36 //x=1.48 //y=0.175 //x2=1.23 //y2=0.175
r2053 (  1 91 ) resistor r=0.068328 //w=0.311 //l=0.17 //layer=m1 \
 //thickness=0.36 //x=37.675 //y=0.175 //x2=37.845 //y2=0.175
r2054 (  1 96 ) resistor r=0.223071 //w=0.311 //l=0.555 //layer=m1 \
 //thickness=0.36 //x=37.675 //y=0.175 //x2=37.12 //y2=0.175
ends PM_TMRDFFQNX1\%GND

subckt PM_TMRDFFQNX1\%noxref_30 ( 1 5 9 13 17 35 )
c55 ( 35 0 ) capacitor c=0.0721035f //x=0.945 //y=0.555
c56 ( 17 0 ) capacitor c=0.0221074f //x=2.935 //y=1.77
c57 ( 13 0 ) capacitor c=0.0153941f //x=2.935 //y=0.72
c58 ( 9 0 ) capacitor c=0.00772076f //x=2.05 //y=0.805
c59 ( 5 0 ) capacitor c=0.0198571f //x=1.965 //y=1.77
c60 ( 1 0 ) capacitor c=0.0109947f //x=1.08 //y=1.685
r61 (  18 35 ) resistor r=5.4201 //w=0.17 //l=0.103078 //layer=li \
 //thickness=0.1 //x=2.135 //y=1.77 //x2=2.05 //y2=1.81
r62 (  18 35 ) resistor r=27.3797 //w=0.187 //l=0.4 //layer=li //thickness=0.1 \
 //x=2.135 //y=1.77 //x2=2.535 //y2=1.77
r63 (  17 35 ) resistor r=0.751729 //w=0.17 //l=0.085 //layer=li \
 //thickness=0.1 //x=2.935 //y=1.77 //x2=3.02 //y2=1.77
r64 (  17 35 ) resistor r=27.3797 //w=0.187 //l=0.4 //layer=li //thickness=0.1 \
 //x=2.935 //y=1.77 //x2=2.535 //y2=1.77
r65 (  14 35 ) resistor r=3.57586 //w=0.17 //l=0.103078 //layer=li \
 //thickness=0.1 //x=2.135 //y=0.72 //x2=2.05 //y2=0.68
r66 (  14 35 ) resistor r=27.3797 //w=0.187 //l=0.4 //layer=li //thickness=0.1 \
 //x=2.135 //y=0.72 //x2=2.535 //y2=0.72
r67 (  13 35 ) resistor r=0.751729 //w=0.17 //l=0.085 //layer=li \
 //thickness=0.1 //x=2.935 //y=0.72 //x2=3.02 //y2=0.72
r68 (  13 35 ) resistor r=27.3797 //w=0.187 //l=0.4 //layer=li //thickness=0.1 \
 //x=2.935 //y=0.72 //x2=2.535 //y2=0.72
r69 (  10 35 ) resistor r=1.40859 //w=0.34 //l=0.125 //layer=li \
 //thickness=0.1 //x=2.05 //y=1.685 //x2=2.05 //y2=1.81
r70 (  10 35 ) resistor r=42.0963 //w=0.187 //l=0.615 //layer=li \
 //thickness=0.1 //x=2.05 //y=1.685 //x2=2.05 //y2=1.07
r71 (  9 35 ) resistor r=3.57586 //w=0.17 //l=0.125 //layer=li //thickness=0.1 \
 //x=2.05 //y=0.805 //x2=2.05 //y2=0.68
r72 (  9 35 ) resistor r=18.139 //w=0.187 //l=0.265 //layer=li //thickness=0.1 \
 //x=2.05 //y=0.805 //x2=2.05 //y2=1.07
r73 (  6 35 ) resistor r=3.57586 //w=0.17 //l=0.103078 //layer=li \
 //thickness=0.1 //x=1.165 //y=1.77 //x2=1.08 //y2=1.81
r74 (  6 35 ) resistor r=27.3797 //w=0.187 //l=0.4 //layer=li //thickness=0.1 \
 //x=1.165 //y=1.77 //x2=1.565 //y2=1.77
r75 (  5 35 ) resistor r=5.4201 //w=0.17 //l=0.103078 //layer=li \
 //thickness=0.1 //x=1.965 //y=1.77 //x2=2.05 //y2=1.81
r76 (  5 35 ) resistor r=27.3797 //w=0.187 //l=0.4 //layer=li //thickness=0.1 \
 //x=1.965 //y=1.77 //x2=1.565 //y2=1.77
r77 (  1 35 ) resistor r=3.57586 //w=0.17 //l=0.125 //layer=li //thickness=0.1 \
 //x=1.08 //y=1.685 //x2=1.08 //y2=1.81
r78 (  1 35 ) resistor r=42.0963 //w=0.187 //l=0.615 //layer=li \
 //thickness=0.1 //x=1.08 //y=1.685 //x2=1.08 //y2=1.07
ends PM_TMRDFFQNX1\%noxref_30

subckt PM_TMRDFFQNX1\%noxref_31 ( 1 5 9 10 13 17 29 )
c69 ( 29 0 ) capacitor c=0.0670401f //x=5.86 //y=0.545
c70 ( 17 0 ) capacitor c=0.0067865f //x=7.935 //y=0.795
c71 ( 13 0 ) capacitor c=0.0155034f //x=7.85 //y=0.71
c72 ( 10 0 ) capacitor c=0.0071084f //x=6.965 //y=1.675
c73 ( 9 0 ) capacitor c=0.00770028f //x=6.965 //y=0.795
c74 ( 5 0 ) capacitor c=0.0193892f //x=6.88 //y=1.76
c75 ( 1 0 ) capacitor c=0.00822695f //x=5.995 //y=1.675
r76 (  17 29 ) resistor r=3.57586 //w=0.17 //l=0.125 //layer=li \
 //thickness=0.1 //x=7.935 //y=0.795 //x2=7.935 //y2=0.67
r77 (  17 29 ) resistor r=18.139 //w=0.187 //l=0.265 //layer=li \
 //thickness=0.1 //x=7.935 //y=0.795 //x2=7.935 //y2=1.06
r78 (  14 29 ) resistor r=3.57586 //w=0.17 //l=0.103078 //layer=li \
 //thickness=0.1 //x=7.05 //y=0.71 //x2=6.965 //y2=0.67
r79 (  14 29 ) resistor r=27.3797 //w=0.187 //l=0.4 //layer=li //thickness=0.1 \
 //x=7.05 //y=0.71 //x2=7.45 //y2=0.71
r80 (  13 29 ) resistor r=3.57586 //w=0.17 //l=0.103078 //layer=li \
 //thickness=0.1 //x=7.85 //y=0.71 //x2=7.935 //y2=0.67
r81 (  13 29 ) resistor r=27.3797 //w=0.187 //l=0.4 //layer=li //thickness=0.1 \
 //x=7.85 //y=0.71 //x2=7.45 //y2=0.71
r82 (  10 29 ) resistor r=3.57586 //w=0.17 //l=0.125 //layer=li \
 //thickness=0.1 //x=6.965 //y=1.675 //x2=6.965 //y2=1.8
r83 (  10 29 ) resistor r=42.0963 //w=0.187 //l=0.615 //layer=li \
 //thickness=0.1 //x=6.965 //y=1.675 //x2=6.965 //y2=1.06
r84 (  9 29 ) resistor r=3.57586 //w=0.17 //l=0.125 //layer=li //thickness=0.1 \
 //x=6.965 //y=0.795 //x2=6.965 //y2=0.67
r85 (  9 29 ) resistor r=18.139 //w=0.187 //l=0.265 //layer=li //thickness=0.1 \
 //x=6.965 //y=0.795 //x2=6.965 //y2=1.06
r86 (  6 29 ) resistor r=3.57586 //w=0.17 //l=0.103078 //layer=li \
 //thickness=0.1 //x=6.08 //y=1.76 //x2=5.995 //y2=1.8
r87 (  6 29 ) resistor r=27.3797 //w=0.187 //l=0.4 //layer=li //thickness=0.1 \
 //x=6.08 //y=1.76 //x2=6.48 //y2=1.76
r88 (  5 29 ) resistor r=3.57586 //w=0.17 //l=0.103078 //layer=li \
 //thickness=0.1 //x=6.88 //y=1.76 //x2=6.965 //y2=1.8
r89 (  5 29 ) resistor r=27.3797 //w=0.187 //l=0.4 //layer=li //thickness=0.1 \
 //x=6.88 //y=1.76 //x2=6.48 //y2=1.76
r90 (  1 29 ) resistor r=3.57586 //w=0.17 //l=0.125 //layer=li //thickness=0.1 \
 //x=5.995 //y=1.675 //x2=5.995 //y2=1.8
r91 (  1 29 ) resistor r=42.0963 //w=0.187 //l=0.615 //layer=li \
 //thickness=0.1 //x=5.995 //y=1.675 //x2=5.995 //y2=1.06
ends PM_TMRDFFQNX1\%noxref_31

subckt PM_TMRDFFQNX1\%noxref_32 ( 1 5 9 10 13 17 29 )
c69 ( 29 0 ) capacitor c=0.0667368f //x=9.19 //y=0.545
c70 ( 17 0 ) capacitor c=0.0067865f //x=11.265 //y=0.795
c71 ( 13 0 ) capacitor c=0.0156591f //x=11.18 //y=0.71
c72 ( 10 0 ) capacitor c=0.00687366f //x=10.295 //y=1.675
c73 ( 9 0 ) capacitor c=0.00770028f //x=10.295 //y=0.795
c74 ( 5 0 ) capacitor c=0.0183675f //x=10.21 //y=1.76
c75 ( 1 0 ) capacitor c=0.00776954f //x=9.325 //y=1.675
r76 (  17 29 ) resistor r=3.57586 //w=0.17 //l=0.125 //layer=li \
 //thickness=0.1 //x=11.265 //y=0.795 //x2=11.265 //y2=0.67
r77 (  17 29 ) resistor r=18.139 //w=0.187 //l=0.265 //layer=li \
 //thickness=0.1 //x=11.265 //y=0.795 //x2=11.265 //y2=1.06
r78 (  14 29 ) resistor r=3.57586 //w=0.17 //l=0.103078 //layer=li \
 //thickness=0.1 //x=10.38 //y=0.71 //x2=10.295 //y2=0.67
r79 (  14 29 ) resistor r=27.3797 //w=0.187 //l=0.4 //layer=li //thickness=0.1 \
 //x=10.38 //y=0.71 //x2=10.78 //y2=0.71
r80 (  13 29 ) resistor r=3.57586 //w=0.17 //l=0.103078 //layer=li \
 //thickness=0.1 //x=11.18 //y=0.71 //x2=11.265 //y2=0.67
r81 (  13 29 ) resistor r=27.3797 //w=0.187 //l=0.4 //layer=li //thickness=0.1 \
 //x=11.18 //y=0.71 //x2=10.78 //y2=0.71
r82 (  10 29 ) resistor r=3.57586 //w=0.17 //l=0.125 //layer=li \
 //thickness=0.1 //x=10.295 //y=1.675 //x2=10.295 //y2=1.8
r83 (  10 29 ) resistor r=42.0963 //w=0.187 //l=0.615 //layer=li \
 //thickness=0.1 //x=10.295 //y=1.675 //x2=10.295 //y2=1.06
r84 (  9 29 ) resistor r=3.57586 //w=0.17 //l=0.125 //layer=li //thickness=0.1 \
 //x=10.295 //y=0.795 //x2=10.295 //y2=0.67
r85 (  9 29 ) resistor r=18.139 //w=0.187 //l=0.265 //layer=li //thickness=0.1 \
 //x=10.295 //y=0.795 //x2=10.295 //y2=1.06
r86 (  6 29 ) resistor r=3.57586 //w=0.17 //l=0.103078 //layer=li \
 //thickness=0.1 //x=9.41 //y=1.76 //x2=9.325 //y2=1.8
r87 (  6 29 ) resistor r=27.3797 //w=0.187 //l=0.4 //layer=li //thickness=0.1 \
 //x=9.41 //y=1.76 //x2=9.81 //y2=1.76
r88 (  5 29 ) resistor r=3.57586 //w=0.17 //l=0.103078 //layer=li \
 //thickness=0.1 //x=10.21 //y=1.76 //x2=10.295 //y2=1.8
r89 (  5 29 ) resistor r=27.3797 //w=0.187 //l=0.4 //layer=li //thickness=0.1 \
 //x=10.21 //y=1.76 //x2=9.81 //y2=1.76
r90 (  1 29 ) resistor r=3.57586 //w=0.17 //l=0.125 //layer=li //thickness=0.1 \
 //x=9.325 //y=1.675 //x2=9.325 //y2=1.8
r91 (  1 29 ) resistor r=42.0963 //w=0.187 //l=0.615 //layer=li \
 //thickness=0.1 //x=9.325 //y=1.675 //x2=9.325 //y2=1.06
ends PM_TMRDFFQNX1\%noxref_32

subckt PM_TMRDFFQNX1\%noxref_33 ( 1 5 9 10 13 17 29 )
c68 ( 29 0 ) capacitor c=0.0671104f //x=12.52 //y=0.545
c69 ( 17 0 ) capacitor c=0.0067865f //x=14.595 //y=0.795
c70 ( 13 0 ) capacitor c=0.0155242f //x=14.51 //y=0.71
c71 ( 10 0 ) capacitor c=0.0069736f //x=13.625 //y=1.675
c72 ( 9 0 ) capacitor c=0.00770028f //x=13.625 //y=0.795
c73 ( 5 0 ) capacitor c=0.0183675f //x=13.54 //y=1.76
c74 ( 1 0 ) capacitor c=0.00776954f //x=12.655 //y=1.675
r75 (  17 29 ) resistor r=3.57586 //w=0.17 //l=0.125 //layer=li \
 //thickness=0.1 //x=14.595 //y=0.795 //x2=14.595 //y2=0.67
r76 (  17 29 ) resistor r=18.139 //w=0.187 //l=0.265 //layer=li \
 //thickness=0.1 //x=14.595 //y=0.795 //x2=14.595 //y2=1.06
r77 (  14 29 ) resistor r=3.57586 //w=0.17 //l=0.103078 //layer=li \
 //thickness=0.1 //x=13.71 //y=0.71 //x2=13.625 //y2=0.67
r78 (  14 29 ) resistor r=27.3797 //w=0.187 //l=0.4 //layer=li //thickness=0.1 \
 //x=13.71 //y=0.71 //x2=14.11 //y2=0.71
r79 (  13 29 ) resistor r=3.57586 //w=0.17 //l=0.103078 //layer=li \
 //thickness=0.1 //x=14.51 //y=0.71 //x2=14.595 //y2=0.67
r80 (  13 29 ) resistor r=27.3797 //w=0.187 //l=0.4 //layer=li //thickness=0.1 \
 //x=14.51 //y=0.71 //x2=14.11 //y2=0.71
r81 (  10 29 ) resistor r=3.57586 //w=0.17 //l=0.125 //layer=li \
 //thickness=0.1 //x=13.625 //y=1.675 //x2=13.625 //y2=1.8
r82 (  10 29 ) resistor r=42.0963 //w=0.187 //l=0.615 //layer=li \
 //thickness=0.1 //x=13.625 //y=1.675 //x2=13.625 //y2=1.06
r83 (  9 29 ) resistor r=3.57586 //w=0.17 //l=0.125 //layer=li //thickness=0.1 \
 //x=13.625 //y=0.795 //x2=13.625 //y2=0.67
r84 (  9 29 ) resistor r=18.139 //w=0.187 //l=0.265 //layer=li //thickness=0.1 \
 //x=13.625 //y=0.795 //x2=13.625 //y2=1.06
r85 (  6 29 ) resistor r=3.57586 //w=0.17 //l=0.103078 //layer=li \
 //thickness=0.1 //x=12.74 //y=1.76 //x2=12.655 //y2=1.8
r86 (  6 29 ) resistor r=27.3797 //w=0.187 //l=0.4 //layer=li //thickness=0.1 \
 //x=12.74 //y=1.76 //x2=13.14 //y2=1.76
r87 (  5 29 ) resistor r=3.57586 //w=0.17 //l=0.103078 //layer=li \
 //thickness=0.1 //x=13.54 //y=1.76 //x2=13.625 //y2=1.8
r88 (  5 29 ) resistor r=27.3797 //w=0.187 //l=0.4 //layer=li //thickness=0.1 \
 //x=13.54 //y=1.76 //x2=13.14 //y2=1.76
r89 (  1 29 ) resistor r=3.57586 //w=0.17 //l=0.125 //layer=li //thickness=0.1 \
 //x=12.655 //y=1.675 //x2=12.655 //y2=1.8
r90 (  1 29 ) resistor r=42.0963 //w=0.187 //l=0.615 //layer=li \
 //thickness=0.1 //x=12.655 //y=1.675 //x2=12.655 //y2=1.06
ends PM_TMRDFFQNX1\%noxref_33

subckt PM_TMRDFFQNX1\%noxref_34 ( 1 5 9 10 13 17 29 )
c70 ( 29 0 ) capacitor c=0.0669409f //x=15.85 //y=0.545
c71 ( 17 0 ) capacitor c=0.0067865f //x=17.925 //y=0.795
c72 ( 13 0 ) capacitor c=0.0155242f //x=17.84 //y=0.71
c73 ( 10 0 ) capacitor c=0.00685308f //x=16.955 //y=1.675
c74 ( 9 0 ) capacitor c=0.00770028f //x=16.955 //y=0.795
c75 ( 5 0 ) capacitor c=0.0183675f //x=16.87 //y=1.76
c76 ( 1 0 ) capacitor c=0.00776954f //x=15.985 //y=1.675
r77 (  17 29 ) resistor r=3.57586 //w=0.17 //l=0.125 //layer=li \
 //thickness=0.1 //x=17.925 //y=0.795 //x2=17.925 //y2=0.67
r78 (  17 29 ) resistor r=18.139 //w=0.187 //l=0.265 //layer=li \
 //thickness=0.1 //x=17.925 //y=0.795 //x2=17.925 //y2=1.06
r79 (  14 29 ) resistor r=3.57586 //w=0.17 //l=0.103078 //layer=li \
 //thickness=0.1 //x=17.04 //y=0.71 //x2=16.955 //y2=0.67
r80 (  14 29 ) resistor r=27.3797 //w=0.187 //l=0.4 //layer=li //thickness=0.1 \
 //x=17.04 //y=0.71 //x2=17.44 //y2=0.71
r81 (  13 29 ) resistor r=3.57586 //w=0.17 //l=0.103078 //layer=li \
 //thickness=0.1 //x=17.84 //y=0.71 //x2=17.925 //y2=0.67
r82 (  13 29 ) resistor r=27.3797 //w=0.187 //l=0.4 //layer=li //thickness=0.1 \
 //x=17.84 //y=0.71 //x2=17.44 //y2=0.71
r83 (  10 29 ) resistor r=3.57586 //w=0.17 //l=0.125 //layer=li \
 //thickness=0.1 //x=16.955 //y=1.675 //x2=16.955 //y2=1.8
r84 (  10 29 ) resistor r=42.0963 //w=0.187 //l=0.615 //layer=li \
 //thickness=0.1 //x=16.955 //y=1.675 //x2=16.955 //y2=1.06
r85 (  9 29 ) resistor r=3.57586 //w=0.17 //l=0.125 //layer=li //thickness=0.1 \
 //x=16.955 //y=0.795 //x2=16.955 //y2=0.67
r86 (  9 29 ) resistor r=18.139 //w=0.187 //l=0.265 //layer=li //thickness=0.1 \
 //x=16.955 //y=0.795 //x2=16.955 //y2=1.06
r87 (  6 29 ) resistor r=3.57586 //w=0.17 //l=0.103078 //layer=li \
 //thickness=0.1 //x=16.07 //y=1.76 //x2=15.985 //y2=1.8
r88 (  6 29 ) resistor r=27.3797 //w=0.187 //l=0.4 //layer=li //thickness=0.1 \
 //x=16.07 //y=1.76 //x2=16.47 //y2=1.76
r89 (  5 29 ) resistor r=3.57586 //w=0.17 //l=0.103078 //layer=li \
 //thickness=0.1 //x=16.87 //y=1.76 //x2=16.955 //y2=1.8
r90 (  5 29 ) resistor r=27.3797 //w=0.187 //l=0.4 //layer=li //thickness=0.1 \
 //x=16.87 //y=1.76 //x2=16.47 //y2=1.76
r91 (  1 29 ) resistor r=3.57586 //w=0.17 //l=0.125 //layer=li //thickness=0.1 \
 //x=15.985 //y=1.675 //x2=15.985 //y2=1.8
r92 (  1 29 ) resistor r=42.0963 //w=0.187 //l=0.615 //layer=li \
 //thickness=0.1 //x=15.985 //y=1.675 //x2=15.985 //y2=1.06
ends PM_TMRDFFQNX1\%noxref_34

subckt PM_TMRDFFQNX1\%noxref_35 ( 1 5 9 10 13 17 29 )
c69 ( 29 0 ) capacitor c=0.0665675f //x=19.18 //y=0.545
c70 ( 17 0 ) capacitor c=0.00675704f //x=21.255 //y=0.795
c71 ( 13 0 ) capacitor c=0.0156444f //x=21.17 //y=0.71
c72 ( 10 0 ) capacitor c=0.00687366f //x=20.285 //y=1.675
c73 ( 9 0 ) capacitor c=0.00770028f //x=20.285 //y=0.795
c74 ( 5 0 ) capacitor c=0.0183675f //x=20.2 //y=1.76
c75 ( 1 0 ) capacitor c=0.00776954f //x=19.315 //y=1.675
r76 (  17 29 ) resistor r=3.57586 //w=0.17 //l=0.125 //layer=li \
 //thickness=0.1 //x=21.255 //y=0.795 //x2=21.255 //y2=0.67
r77 (  17 29 ) resistor r=18.139 //w=0.187 //l=0.265 //layer=li \
 //thickness=0.1 //x=21.255 //y=0.795 //x2=21.255 //y2=1.06
r78 (  14 29 ) resistor r=3.57586 //w=0.17 //l=0.103078 //layer=li \
 //thickness=0.1 //x=20.37 //y=0.71 //x2=20.285 //y2=0.67
r79 (  14 29 ) resistor r=27.3797 //w=0.187 //l=0.4 //layer=li //thickness=0.1 \
 //x=20.37 //y=0.71 //x2=20.77 //y2=0.71
r80 (  13 29 ) resistor r=3.57586 //w=0.17 //l=0.103078 //layer=li \
 //thickness=0.1 //x=21.17 //y=0.71 //x2=21.255 //y2=0.67
r81 (  13 29 ) resistor r=27.3797 //w=0.187 //l=0.4 //layer=li //thickness=0.1 \
 //x=21.17 //y=0.71 //x2=20.77 //y2=0.71
r82 (  10 29 ) resistor r=3.57586 //w=0.17 //l=0.125 //layer=li \
 //thickness=0.1 //x=20.285 //y=1.675 //x2=20.285 //y2=1.8
r83 (  10 29 ) resistor r=42.0963 //w=0.187 //l=0.615 //layer=li \
 //thickness=0.1 //x=20.285 //y=1.675 //x2=20.285 //y2=1.06
r84 (  9 29 ) resistor r=3.57586 //w=0.17 //l=0.125 //layer=li //thickness=0.1 \
 //x=20.285 //y=0.795 //x2=20.285 //y2=0.67
r85 (  9 29 ) resistor r=18.139 //w=0.187 //l=0.265 //layer=li //thickness=0.1 \
 //x=20.285 //y=0.795 //x2=20.285 //y2=1.06
r86 (  6 29 ) resistor r=3.57586 //w=0.17 //l=0.103078 //layer=li \
 //thickness=0.1 //x=19.4 //y=1.76 //x2=19.315 //y2=1.8
r87 (  6 29 ) resistor r=27.3797 //w=0.187 //l=0.4 //layer=li //thickness=0.1 \
 //x=19.4 //y=1.76 //x2=19.8 //y2=1.76
r88 (  5 29 ) resistor r=3.57586 //w=0.17 //l=0.103078 //layer=li \
 //thickness=0.1 //x=20.2 //y=1.76 //x2=20.285 //y2=1.8
r89 (  5 29 ) resistor r=27.3797 //w=0.187 //l=0.4 //layer=li //thickness=0.1 \
 //x=20.2 //y=1.76 //x2=19.8 //y2=1.76
r90 (  1 29 ) resistor r=3.57586 //w=0.17 //l=0.125 //layer=li //thickness=0.1 \
 //x=19.315 //y=1.675 //x2=19.315 //y2=1.8
r91 (  1 29 ) resistor r=42.0963 //w=0.187 //l=0.615 //layer=li \
 //thickness=0.1 //x=19.315 //y=1.675 //x2=19.315 //y2=1.06
ends PM_TMRDFFQNX1\%noxref_35

subckt PM_TMRDFFQNX1\%noxref_36 ( 1 5 9 13 17 35 )
c59 ( 35 0 ) capacitor c=0.0692064f //x=22.405 //y=0.555
c60 ( 17 0 ) capacitor c=0.0195855f //x=24.395 //y=1.77
c61 ( 13 0 ) capacitor c=0.015342f //x=24.395 //y=0.72
c62 ( 9 0 ) capacitor c=0.00772076f //x=23.51 //y=0.805
c63 ( 5 0 ) capacitor c=0.0171871f //x=23.425 //y=1.77
c64 ( 1 0 ) capacitor c=0.00726193f //x=22.54 //y=1.685
r65 (  18 35 ) resistor r=5.4201 //w=0.17 //l=0.103078 //layer=li \
 //thickness=0.1 //x=23.595 //y=1.77 //x2=23.51 //y2=1.81
r66 (  18 35 ) resistor r=27.3797 //w=0.187 //l=0.4 //layer=li //thickness=0.1 \
 //x=23.595 //y=1.77 //x2=23.995 //y2=1.77
r67 (  17 35 ) resistor r=0.751729 //w=0.17 //l=0.085 //layer=li \
 //thickness=0.1 //x=24.395 //y=1.77 //x2=24.48 //y2=1.77
r68 (  17 35 ) resistor r=27.3797 //w=0.187 //l=0.4 //layer=li //thickness=0.1 \
 //x=24.395 //y=1.77 //x2=23.995 //y2=1.77
r69 (  14 35 ) resistor r=3.57586 //w=0.17 //l=0.103078 //layer=li \
 //thickness=0.1 //x=23.595 //y=0.72 //x2=23.51 //y2=0.68
r70 (  14 35 ) resistor r=27.3797 //w=0.187 //l=0.4 //layer=li //thickness=0.1 \
 //x=23.595 //y=0.72 //x2=23.995 //y2=0.72
r71 (  13 35 ) resistor r=0.751729 //w=0.17 //l=0.085 //layer=li \
 //thickness=0.1 //x=24.395 //y=0.72 //x2=24.48 //y2=0.72
r72 (  13 35 ) resistor r=27.3797 //w=0.187 //l=0.4 //layer=li //thickness=0.1 \
 //x=24.395 //y=0.72 //x2=23.995 //y2=0.72
r73 (  10 35 ) resistor r=1.40859 //w=0.34 //l=0.125 //layer=li \
 //thickness=0.1 //x=23.51 //y=1.685 //x2=23.51 //y2=1.81
r74 (  10 35 ) resistor r=42.0963 //w=0.187 //l=0.615 //layer=li \
 //thickness=0.1 //x=23.51 //y=1.685 //x2=23.51 //y2=1.07
r75 (  9 35 ) resistor r=3.57586 //w=0.17 //l=0.125 //layer=li //thickness=0.1 \
 //x=23.51 //y=0.805 //x2=23.51 //y2=0.68
r76 (  9 35 ) resistor r=18.139 //w=0.187 //l=0.265 //layer=li //thickness=0.1 \
 //x=23.51 //y=0.805 //x2=23.51 //y2=1.07
r77 (  6 35 ) resistor r=3.57586 //w=0.17 //l=0.103078 //layer=li \
 //thickness=0.1 //x=22.625 //y=1.77 //x2=22.54 //y2=1.81
r78 (  6 35 ) resistor r=27.3797 //w=0.187 //l=0.4 //layer=li //thickness=0.1 \
 //x=22.625 //y=1.77 //x2=23.025 //y2=1.77
r79 (  5 35 ) resistor r=5.4201 //w=0.17 //l=0.103078 //layer=li \
 //thickness=0.1 //x=23.425 //y=1.77 //x2=23.51 //y2=1.81
r80 (  5 35 ) resistor r=27.3797 //w=0.187 //l=0.4 //layer=li //thickness=0.1 \
 //x=23.425 //y=1.77 //x2=23.025 //y2=1.77
r81 (  1 35 ) resistor r=3.57586 //w=0.17 //l=0.125 //layer=li //thickness=0.1 \
 //x=22.54 //y=1.685 //x2=22.54 //y2=1.81
r82 (  1 35 ) resistor r=42.0963 //w=0.187 //l=0.615 //layer=li \
 //thickness=0.1 //x=22.54 //y=1.685 //x2=22.54 //y2=1.07
ends PM_TMRDFFQNX1\%noxref_36

subckt PM_TMRDFFQNX1\%noxref_37 ( 1 5 9 10 13 17 29 )
c68 ( 29 0 ) capacitor c=0.0670401f //x=27.32 //y=0.545
c69 ( 17 0 ) capacitor c=0.0067865f //x=29.395 //y=0.795
c70 ( 13 0 ) capacitor c=0.0155132f //x=29.31 //y=0.71
c71 ( 10 0 ) capacitor c=0.00666387f //x=28.425 //y=1.675
c72 ( 9 0 ) capacitor c=0.00770028f //x=28.425 //y=0.795
c73 ( 5 0 ) capacitor c=0.0183675f //x=28.34 //y=1.76
c74 ( 1 0 ) capacitor c=0.00777933f //x=27.455 //y=1.675
r75 (  17 29 ) resistor r=3.57586 //w=0.17 //l=0.125 //layer=li \
 //thickness=0.1 //x=29.395 //y=0.795 //x2=29.395 //y2=0.67
r76 (  17 29 ) resistor r=18.139 //w=0.187 //l=0.265 //layer=li \
 //thickness=0.1 //x=29.395 //y=0.795 //x2=29.395 //y2=1.06
r77 (  14 29 ) resistor r=3.57586 //w=0.17 //l=0.103078 //layer=li \
 //thickness=0.1 //x=28.51 //y=0.71 //x2=28.425 //y2=0.67
r78 (  14 29 ) resistor r=27.3797 //w=0.187 //l=0.4 //layer=li //thickness=0.1 \
 //x=28.51 //y=0.71 //x2=28.91 //y2=0.71
r79 (  13 29 ) resistor r=3.57586 //w=0.17 //l=0.103078 //layer=li \
 //thickness=0.1 //x=29.31 //y=0.71 //x2=29.395 //y2=0.67
r80 (  13 29 ) resistor r=27.3797 //w=0.187 //l=0.4 //layer=li //thickness=0.1 \
 //x=29.31 //y=0.71 //x2=28.91 //y2=0.71
r81 (  10 29 ) resistor r=3.57586 //w=0.17 //l=0.125 //layer=li \
 //thickness=0.1 //x=28.425 //y=1.675 //x2=28.425 //y2=1.8
r82 (  10 29 ) resistor r=42.0963 //w=0.187 //l=0.615 //layer=li \
 //thickness=0.1 //x=28.425 //y=1.675 //x2=28.425 //y2=1.06
r83 (  9 29 ) resistor r=3.57586 //w=0.17 //l=0.125 //layer=li //thickness=0.1 \
 //x=28.425 //y=0.795 //x2=28.425 //y2=0.67
r84 (  9 29 ) resistor r=18.139 //w=0.187 //l=0.265 //layer=li //thickness=0.1 \
 //x=28.425 //y=0.795 //x2=28.425 //y2=1.06
r85 (  6 29 ) resistor r=3.57586 //w=0.17 //l=0.103078 //layer=li \
 //thickness=0.1 //x=27.54 //y=1.76 //x2=27.455 //y2=1.8
r86 (  6 29 ) resistor r=27.3797 //w=0.187 //l=0.4 //layer=li //thickness=0.1 \
 //x=27.54 //y=1.76 //x2=27.94 //y2=1.76
r87 (  5 29 ) resistor r=3.57586 //w=0.17 //l=0.103078 //layer=li \
 //thickness=0.1 //x=28.34 //y=1.76 //x2=28.425 //y2=1.8
r88 (  5 29 ) resistor r=27.3797 //w=0.187 //l=0.4 //layer=li //thickness=0.1 \
 //x=28.34 //y=1.76 //x2=27.94 //y2=1.76
r89 (  1 29 ) resistor r=3.57586 //w=0.17 //l=0.125 //layer=li //thickness=0.1 \
 //x=27.455 //y=1.675 //x2=27.455 //y2=1.8
r90 (  1 29 ) resistor r=42.0963 //w=0.187 //l=0.615 //layer=li \
 //thickness=0.1 //x=27.455 //y=1.675 //x2=27.455 //y2=1.06
ends PM_TMRDFFQNX1\%noxref_37

subckt PM_TMRDFFQNX1\%noxref_38 ( 1 5 9 10 13 17 29 )
c69 ( 29 0 ) capacitor c=0.0667368f //x=30.65 //y=0.545
c70 ( 17 0 ) capacitor c=0.0067865f //x=32.725 //y=0.795
c71 ( 13 0 ) capacitor c=0.0156591f //x=32.64 //y=0.71
c72 ( 10 0 ) capacitor c=0.00687366f //x=31.755 //y=1.675
c73 ( 9 0 ) capacitor c=0.00770028f //x=31.755 //y=0.795
c74 ( 5 0 ) capacitor c=0.0183675f //x=31.67 //y=1.76
c75 ( 1 0 ) capacitor c=0.00776954f //x=30.785 //y=1.675
r76 (  17 29 ) resistor r=3.57586 //w=0.17 //l=0.125 //layer=li \
 //thickness=0.1 //x=32.725 //y=0.795 //x2=32.725 //y2=0.67
r77 (  17 29 ) resistor r=18.139 //w=0.187 //l=0.265 //layer=li \
 //thickness=0.1 //x=32.725 //y=0.795 //x2=32.725 //y2=1.06
r78 (  14 29 ) resistor r=3.57586 //w=0.17 //l=0.103078 //layer=li \
 //thickness=0.1 //x=31.84 //y=0.71 //x2=31.755 //y2=0.67
r79 (  14 29 ) resistor r=27.3797 //w=0.187 //l=0.4 //layer=li //thickness=0.1 \
 //x=31.84 //y=0.71 //x2=32.24 //y2=0.71
r80 (  13 29 ) resistor r=3.57586 //w=0.17 //l=0.103078 //layer=li \
 //thickness=0.1 //x=32.64 //y=0.71 //x2=32.725 //y2=0.67
r81 (  13 29 ) resistor r=27.3797 //w=0.187 //l=0.4 //layer=li //thickness=0.1 \
 //x=32.64 //y=0.71 //x2=32.24 //y2=0.71
r82 (  10 29 ) resistor r=3.57586 //w=0.17 //l=0.125 //layer=li \
 //thickness=0.1 //x=31.755 //y=1.675 //x2=31.755 //y2=1.8
r83 (  10 29 ) resistor r=42.0963 //w=0.187 //l=0.615 //layer=li \
 //thickness=0.1 //x=31.755 //y=1.675 //x2=31.755 //y2=1.06
r84 (  9 29 ) resistor r=3.57586 //w=0.17 //l=0.125 //layer=li //thickness=0.1 \
 //x=31.755 //y=0.795 //x2=31.755 //y2=0.67
r85 (  9 29 ) resistor r=18.139 //w=0.187 //l=0.265 //layer=li //thickness=0.1 \
 //x=31.755 //y=0.795 //x2=31.755 //y2=1.06
r86 (  6 29 ) resistor r=3.57586 //w=0.17 //l=0.103078 //layer=li \
 //thickness=0.1 //x=30.87 //y=1.76 //x2=30.785 //y2=1.8
r87 (  6 29 ) resistor r=27.3797 //w=0.187 //l=0.4 //layer=li //thickness=0.1 \
 //x=30.87 //y=1.76 //x2=31.27 //y2=1.76
r88 (  5 29 ) resistor r=3.57586 //w=0.17 //l=0.103078 //layer=li \
 //thickness=0.1 //x=31.67 //y=1.76 //x2=31.755 //y2=1.8
r89 (  5 29 ) resistor r=27.3797 //w=0.187 //l=0.4 //layer=li //thickness=0.1 \
 //x=31.67 //y=1.76 //x2=31.27 //y2=1.76
r90 (  1 29 ) resistor r=3.57586 //w=0.17 //l=0.125 //layer=li //thickness=0.1 \
 //x=30.785 //y=1.675 //x2=30.785 //y2=1.8
r91 (  1 29 ) resistor r=42.0963 //w=0.187 //l=0.615 //layer=li \
 //thickness=0.1 //x=30.785 //y=1.675 //x2=30.785 //y2=1.06
ends PM_TMRDFFQNX1\%noxref_38

subckt PM_TMRDFFQNX1\%noxref_39 ( 1 5 9 10 13 17 29 )
c68 ( 29 0 ) capacitor c=0.0671104f //x=33.98 //y=0.545
c69 ( 17 0 ) capacitor c=0.0067865f //x=36.055 //y=0.795
c70 ( 13 0 ) capacitor c=0.0155242f //x=35.97 //y=0.71
c71 ( 10 0 ) capacitor c=0.0069736f //x=35.085 //y=1.675
c72 ( 9 0 ) capacitor c=0.00770028f //x=35.085 //y=0.795
c73 ( 5 0 ) capacitor c=0.0183675f //x=35 //y=1.76
c74 ( 1 0 ) capacitor c=0.00776954f //x=34.115 //y=1.675
r75 (  17 29 ) resistor r=3.57586 //w=0.17 //l=0.125 //layer=li \
 //thickness=0.1 //x=36.055 //y=0.795 //x2=36.055 //y2=0.67
r76 (  17 29 ) resistor r=18.139 //w=0.187 //l=0.265 //layer=li \
 //thickness=0.1 //x=36.055 //y=0.795 //x2=36.055 //y2=1.06
r77 (  14 29 ) resistor r=3.57586 //w=0.17 //l=0.103078 //layer=li \
 //thickness=0.1 //x=35.17 //y=0.71 //x2=35.085 //y2=0.67
r78 (  14 29 ) resistor r=27.3797 //w=0.187 //l=0.4 //layer=li //thickness=0.1 \
 //x=35.17 //y=0.71 //x2=35.57 //y2=0.71
r79 (  13 29 ) resistor r=3.57586 //w=0.17 //l=0.103078 //layer=li \
 //thickness=0.1 //x=35.97 //y=0.71 //x2=36.055 //y2=0.67
r80 (  13 29 ) resistor r=27.3797 //w=0.187 //l=0.4 //layer=li //thickness=0.1 \
 //x=35.97 //y=0.71 //x2=35.57 //y2=0.71
r81 (  10 29 ) resistor r=3.57586 //w=0.17 //l=0.125 //layer=li \
 //thickness=0.1 //x=35.085 //y=1.675 //x2=35.085 //y2=1.8
r82 (  10 29 ) resistor r=42.0963 //w=0.187 //l=0.615 //layer=li \
 //thickness=0.1 //x=35.085 //y=1.675 //x2=35.085 //y2=1.06
r83 (  9 29 ) resistor r=3.57586 //w=0.17 //l=0.125 //layer=li //thickness=0.1 \
 //x=35.085 //y=0.795 //x2=35.085 //y2=0.67
r84 (  9 29 ) resistor r=18.139 //w=0.187 //l=0.265 //layer=li //thickness=0.1 \
 //x=35.085 //y=0.795 //x2=35.085 //y2=1.06
r85 (  6 29 ) resistor r=3.57586 //w=0.17 //l=0.103078 //layer=li \
 //thickness=0.1 //x=34.2 //y=1.76 //x2=34.115 //y2=1.8
r86 (  6 29 ) resistor r=27.3797 //w=0.187 //l=0.4 //layer=li //thickness=0.1 \
 //x=34.2 //y=1.76 //x2=34.6 //y2=1.76
r87 (  5 29 ) resistor r=3.57586 //w=0.17 //l=0.103078 //layer=li \
 //thickness=0.1 //x=35 //y=1.76 //x2=35.085 //y2=1.8
r88 (  5 29 ) resistor r=27.3797 //w=0.187 //l=0.4 //layer=li //thickness=0.1 \
 //x=35 //y=1.76 //x2=34.6 //y2=1.76
r89 (  1 29 ) resistor r=3.57586 //w=0.17 //l=0.125 //layer=li //thickness=0.1 \
 //x=34.115 //y=1.675 //x2=34.115 //y2=1.8
r90 (  1 29 ) resistor r=42.0963 //w=0.187 //l=0.615 //layer=li \
 //thickness=0.1 //x=34.115 //y=1.675 //x2=34.115 //y2=1.06
ends PM_TMRDFFQNX1\%noxref_39

subckt PM_TMRDFFQNX1\%noxref_40 ( 1 5 9 10 13 17 29 )
c68 ( 29 0 ) capacitor c=0.0668841f //x=37.31 //y=0.545
c69 ( 17 0 ) capacitor c=0.0067865f //x=39.385 //y=0.795
c70 ( 13 0 ) capacitor c=0.0154839f //x=39.3 //y=0.71
c71 ( 10 0 ) capacitor c=0.00665309f //x=38.415 //y=1.675
c72 ( 9 0 ) capacitor c=0.00770028f //x=38.415 //y=0.795
c73 ( 5 0 ) capacitor c=0.0183675f //x=38.33 //y=1.76
c74 ( 1 0 ) capacitor c=0.00776954f //x=37.445 //y=1.675
r75 (  17 29 ) resistor r=3.57586 //w=0.17 //l=0.125 //layer=li \
 //thickness=0.1 //x=39.385 //y=0.795 //x2=39.385 //y2=0.67
r76 (  17 29 ) resistor r=18.139 //w=0.187 //l=0.265 //layer=li \
 //thickness=0.1 //x=39.385 //y=0.795 //x2=39.385 //y2=1.06
r77 (  14 29 ) resistor r=3.57586 //w=0.17 //l=0.103078 //layer=li \
 //thickness=0.1 //x=38.5 //y=0.71 //x2=38.415 //y2=0.67
r78 (  14 29 ) resistor r=27.3797 //w=0.187 //l=0.4 //layer=li //thickness=0.1 \
 //x=38.5 //y=0.71 //x2=38.9 //y2=0.71
r79 (  13 29 ) resistor r=3.57586 //w=0.17 //l=0.103078 //layer=li \
 //thickness=0.1 //x=39.3 //y=0.71 //x2=39.385 //y2=0.67
r80 (  13 29 ) resistor r=27.3797 //w=0.187 //l=0.4 //layer=li //thickness=0.1 \
 //x=39.3 //y=0.71 //x2=38.9 //y2=0.71
r81 (  10 29 ) resistor r=3.57586 //w=0.17 //l=0.125 //layer=li \
 //thickness=0.1 //x=38.415 //y=1.675 //x2=38.415 //y2=1.8
r82 (  10 29 ) resistor r=42.0963 //w=0.187 //l=0.615 //layer=li \
 //thickness=0.1 //x=38.415 //y=1.675 //x2=38.415 //y2=1.06
r83 (  9 29 ) resistor r=3.57586 //w=0.17 //l=0.125 //layer=li //thickness=0.1 \
 //x=38.415 //y=0.795 //x2=38.415 //y2=0.67
r84 (  9 29 ) resistor r=18.139 //w=0.187 //l=0.265 //layer=li //thickness=0.1 \
 //x=38.415 //y=0.795 //x2=38.415 //y2=1.06
r85 (  6 29 ) resistor r=3.57586 //w=0.17 //l=0.103078 //layer=li \
 //thickness=0.1 //x=37.53 //y=1.76 //x2=37.445 //y2=1.8
r86 (  6 29 ) resistor r=27.3797 //w=0.187 //l=0.4 //layer=li //thickness=0.1 \
 //x=37.53 //y=1.76 //x2=37.93 //y2=1.76
r87 (  5 29 ) resistor r=3.57586 //w=0.17 //l=0.103078 //layer=li \
 //thickness=0.1 //x=38.33 //y=1.76 //x2=38.415 //y2=1.8
r88 (  5 29 ) resistor r=27.3797 //w=0.187 //l=0.4 //layer=li //thickness=0.1 \
 //x=38.33 //y=1.76 //x2=37.93 //y2=1.76
r89 (  1 29 ) resistor r=3.57586 //w=0.17 //l=0.125 //layer=li //thickness=0.1 \
 //x=37.445 //y=1.675 //x2=37.445 //y2=1.8
r90 (  1 29 ) resistor r=42.0963 //w=0.187 //l=0.615 //layer=li \
 //thickness=0.1 //x=37.445 //y=1.675 //x2=37.445 //y2=1.06
ends PM_TMRDFFQNX1\%noxref_40

subckt PM_TMRDFFQNX1\%noxref_41 ( 1 5 9 10 13 17 29 )
c68 ( 29 0 ) capacitor c=0.0657587f //x=40.64 //y=0.545
c69 ( 17 0 ) capacitor c=0.00675704f //x=42.715 //y=0.795
c70 ( 13 0 ) capacitor c=0.0156179f //x=42.63 //y=0.71
c71 ( 10 0 ) capacitor c=0.00673372f //x=41.745 //y=1.675
c72 ( 9 0 ) capacitor c=0.00770028f //x=41.745 //y=0.795
c73 ( 5 0 ) capacitor c=0.0179513f //x=41.66 //y=1.76
c74 ( 1 0 ) capacitor c=0.0076012f //x=40.775 //y=1.675
r75 (  17 29 ) resistor r=3.57586 //w=0.17 //l=0.125 //layer=li \
 //thickness=0.1 //x=42.715 //y=0.795 //x2=42.715 //y2=0.67
r76 (  17 29 ) resistor r=18.139 //w=0.187 //l=0.265 //layer=li \
 //thickness=0.1 //x=42.715 //y=0.795 //x2=42.715 //y2=1.06
r77 (  14 29 ) resistor r=3.57586 //w=0.17 //l=0.103078 //layer=li \
 //thickness=0.1 //x=41.83 //y=0.71 //x2=41.745 //y2=0.67
r78 (  14 29 ) resistor r=27.3797 //w=0.187 //l=0.4 //layer=li //thickness=0.1 \
 //x=41.83 //y=0.71 //x2=42.23 //y2=0.71
r79 (  13 29 ) resistor r=3.57586 //w=0.17 //l=0.103078 //layer=li \
 //thickness=0.1 //x=42.63 //y=0.71 //x2=42.715 //y2=0.67
r80 (  13 29 ) resistor r=27.3797 //w=0.187 //l=0.4 //layer=li //thickness=0.1 \
 //x=42.63 //y=0.71 //x2=42.23 //y2=0.71
r81 (  10 29 ) resistor r=3.57586 //w=0.17 //l=0.125 //layer=li \
 //thickness=0.1 //x=41.745 //y=1.675 //x2=41.745 //y2=1.8
r82 (  10 29 ) resistor r=42.0963 //w=0.187 //l=0.615 //layer=li \
 //thickness=0.1 //x=41.745 //y=1.675 //x2=41.745 //y2=1.06
r83 (  9 29 ) resistor r=3.57586 //w=0.17 //l=0.125 //layer=li //thickness=0.1 \
 //x=41.745 //y=0.795 //x2=41.745 //y2=0.67
r84 (  9 29 ) resistor r=18.139 //w=0.187 //l=0.265 //layer=li //thickness=0.1 \
 //x=41.745 //y=0.795 //x2=41.745 //y2=1.06
r85 (  6 29 ) resistor r=3.57586 //w=0.17 //l=0.103078 //layer=li \
 //thickness=0.1 //x=40.86 //y=1.76 //x2=40.775 //y2=1.8
r86 (  6 29 ) resistor r=27.3797 //w=0.187 //l=0.4 //layer=li //thickness=0.1 \
 //x=40.86 //y=1.76 //x2=41.26 //y2=1.76
r87 (  5 29 ) resistor r=3.57586 //w=0.17 //l=0.103078 //layer=li \
 //thickness=0.1 //x=41.66 //y=1.76 //x2=41.745 //y2=1.8
r88 (  5 29 ) resistor r=27.3797 //w=0.187 //l=0.4 //layer=li //thickness=0.1 \
 //x=41.66 //y=1.76 //x2=41.26 //y2=1.76
r89 (  1 29 ) resistor r=3.57586 //w=0.17 //l=0.125 //layer=li //thickness=0.1 \
 //x=40.775 //y=1.675 //x2=40.775 //y2=1.8
r90 (  1 29 ) resistor r=42.0963 //w=0.187 //l=0.615 //layer=li \
 //thickness=0.1 //x=40.775 //y=1.675 //x2=40.775 //y2=1.06
ends PM_TMRDFFQNX1\%noxref_41

subckt PM_TMRDFFQNX1\%noxref_42 ( 1 5 9 13 17 35 )
c59 ( 35 0 ) capacitor c=0.0688411f //x=43.865 //y=0.555
c60 ( 17 0 ) capacitor c=0.0190725f //x=45.855 //y=1.77
c61 ( 13 0 ) capacitor c=0.015325f //x=45.855 //y=0.72
c62 ( 9 0 ) capacitor c=0.00772076f //x=44.97 //y=0.805
c63 ( 5 0 ) capacitor c=0.0168501f //x=44.885 //y=1.77
c64 ( 1 0 ) capacitor c=0.00709556f //x=44 //y=1.685
r65 (  18 35 ) resistor r=5.4201 //w=0.17 //l=0.103078 //layer=li \
 //thickness=0.1 //x=45.055 //y=1.77 //x2=44.97 //y2=1.81
r66 (  18 35 ) resistor r=27.3797 //w=0.187 //l=0.4 //layer=li //thickness=0.1 \
 //x=45.055 //y=1.77 //x2=45.455 //y2=1.77
r67 (  17 35 ) resistor r=0.751729 //w=0.17 //l=0.085 //layer=li \
 //thickness=0.1 //x=45.855 //y=1.77 //x2=45.94 //y2=1.77
r68 (  17 35 ) resistor r=27.3797 //w=0.187 //l=0.4 //layer=li //thickness=0.1 \
 //x=45.855 //y=1.77 //x2=45.455 //y2=1.77
r69 (  14 35 ) resistor r=3.57586 //w=0.17 //l=0.103078 //layer=li \
 //thickness=0.1 //x=45.055 //y=0.72 //x2=44.97 //y2=0.68
r70 (  14 35 ) resistor r=27.3797 //w=0.187 //l=0.4 //layer=li //thickness=0.1 \
 //x=45.055 //y=0.72 //x2=45.455 //y2=0.72
r71 (  13 35 ) resistor r=0.751729 //w=0.17 //l=0.085 //layer=li \
 //thickness=0.1 //x=45.855 //y=0.72 //x2=45.94 //y2=0.72
r72 (  13 35 ) resistor r=27.3797 //w=0.187 //l=0.4 //layer=li //thickness=0.1 \
 //x=45.855 //y=0.72 //x2=45.455 //y2=0.72
r73 (  10 35 ) resistor r=1.40859 //w=0.34 //l=0.125 //layer=li \
 //thickness=0.1 //x=44.97 //y=1.685 //x2=44.97 //y2=1.81
r74 (  10 35 ) resistor r=42.0963 //w=0.187 //l=0.615 //layer=li \
 //thickness=0.1 //x=44.97 //y=1.685 //x2=44.97 //y2=1.07
r75 (  9 35 ) resistor r=3.57586 //w=0.17 //l=0.125 //layer=li //thickness=0.1 \
 //x=44.97 //y=0.805 //x2=44.97 //y2=0.68
r76 (  9 35 ) resistor r=18.139 //w=0.187 //l=0.265 //layer=li //thickness=0.1 \
 //x=44.97 //y=0.805 //x2=44.97 //y2=1.07
r77 (  6 35 ) resistor r=3.57586 //w=0.17 //l=0.103078 //layer=li \
 //thickness=0.1 //x=44.085 //y=1.77 //x2=44 //y2=1.81
r78 (  6 35 ) resistor r=27.3797 //w=0.187 //l=0.4 //layer=li //thickness=0.1 \
 //x=44.085 //y=1.77 //x2=44.485 //y2=1.77
r79 (  5 35 ) resistor r=5.4201 //w=0.17 //l=0.103078 //layer=li \
 //thickness=0.1 //x=44.885 //y=1.77 //x2=44.97 //y2=1.81
r80 (  5 35 ) resistor r=27.3797 //w=0.187 //l=0.4 //layer=li //thickness=0.1 \
 //x=44.885 //y=1.77 //x2=44.485 //y2=1.77
r81 (  1 35 ) resistor r=3.57586 //w=0.17 //l=0.125 //layer=li //thickness=0.1 \
 //x=44 //y=1.685 //x2=44 //y2=1.81
r82 (  1 35 ) resistor r=42.0963 //w=0.187 //l=0.615 //layer=li \
 //thickness=0.1 //x=44 //y=1.685 //x2=44 //y2=1.07
ends PM_TMRDFFQNX1\%noxref_42

subckt PM_TMRDFFQNX1\%noxref_43 ( 1 5 9 10 13 17 29 )
c69 ( 29 0 ) capacitor c=0.0669833f //x=48.78 //y=0.545
c70 ( 17 0 ) capacitor c=0.0067865f //x=50.855 //y=0.795
c71 ( 13 0 ) capacitor c=0.0154977f //x=50.77 //y=0.71
c72 ( 10 0 ) capacitor c=0.00657046f //x=49.885 //y=1.675
c73 ( 9 0 ) capacitor c=0.00770028f //x=49.885 //y=0.795
c74 ( 5 0 ) capacitor c=0.0179513f //x=49.8 //y=1.76
c75 ( 1 0 ) capacitor c=0.00761099f //x=48.915 //y=1.675
r76 (  17 29 ) resistor r=3.57586 //w=0.17 //l=0.125 //layer=li \
 //thickness=0.1 //x=50.855 //y=0.795 //x2=50.855 //y2=0.67
r77 (  17 29 ) resistor r=18.139 //w=0.187 //l=0.265 //layer=li \
 //thickness=0.1 //x=50.855 //y=0.795 //x2=50.855 //y2=1.06
r78 (  14 29 ) resistor r=3.57586 //w=0.17 //l=0.103078 //layer=li \
 //thickness=0.1 //x=49.97 //y=0.71 //x2=49.885 //y2=0.67
r79 (  14 29 ) resistor r=27.3797 //w=0.187 //l=0.4 //layer=li //thickness=0.1 \
 //x=49.97 //y=0.71 //x2=50.37 //y2=0.71
r80 (  13 29 ) resistor r=3.57586 //w=0.17 //l=0.103078 //layer=li \
 //thickness=0.1 //x=50.77 //y=0.71 //x2=50.855 //y2=0.67
r81 (  13 29 ) resistor r=27.3797 //w=0.187 //l=0.4 //layer=li //thickness=0.1 \
 //x=50.77 //y=0.71 //x2=50.37 //y2=0.71
r82 (  10 29 ) resistor r=3.57586 //w=0.17 //l=0.125 //layer=li \
 //thickness=0.1 //x=49.885 //y=1.675 //x2=49.885 //y2=1.8
r83 (  10 29 ) resistor r=42.0963 //w=0.187 //l=0.615 //layer=li \
 //thickness=0.1 //x=49.885 //y=1.675 //x2=49.885 //y2=1.06
r84 (  9 29 ) resistor r=3.57586 //w=0.17 //l=0.125 //layer=li //thickness=0.1 \
 //x=49.885 //y=0.795 //x2=49.885 //y2=0.67
r85 (  9 29 ) resistor r=18.139 //w=0.187 //l=0.265 //layer=li //thickness=0.1 \
 //x=49.885 //y=0.795 //x2=49.885 //y2=1.06
r86 (  6 29 ) resistor r=3.57586 //w=0.17 //l=0.103078 //layer=li \
 //thickness=0.1 //x=49 //y=1.76 //x2=48.915 //y2=1.8
r87 (  6 29 ) resistor r=27.3797 //w=0.187 //l=0.4 //layer=li //thickness=0.1 \
 //x=49 //y=1.76 //x2=49.4 //y2=1.76
r88 (  5 29 ) resistor r=3.57586 //w=0.17 //l=0.103078 //layer=li \
 //thickness=0.1 //x=49.8 //y=1.76 //x2=49.885 //y2=1.8
r89 (  5 29 ) resistor r=27.3797 //w=0.187 //l=0.4 //layer=li //thickness=0.1 \
 //x=49.8 //y=1.76 //x2=49.4 //y2=1.76
r90 (  1 29 ) resistor r=3.57586 //w=0.17 //l=0.125 //layer=li //thickness=0.1 \
 //x=48.915 //y=1.675 //x2=48.915 //y2=1.8
r91 (  1 29 ) resistor r=42.0963 //w=0.187 //l=0.615 //layer=li \
 //thickness=0.1 //x=48.915 //y=1.675 //x2=48.915 //y2=1.06
ends PM_TMRDFFQNX1\%noxref_43

subckt PM_TMRDFFQNX1\%noxref_44 ( 1 5 9 10 13 17 29 )
c69 ( 29 0 ) capacitor c=0.06668f //x=52.11 //y=0.545
c70 ( 17 0 ) capacitor c=0.0067865f //x=54.185 //y=0.795
c71 ( 13 0 ) capacitor c=0.0156326f //x=54.1 //y=0.71
c72 ( 10 0 ) capacitor c=0.00673372f //x=53.215 //y=1.675
c73 ( 9 0 ) capacitor c=0.00770028f //x=53.215 //y=0.795
c74 ( 5 0 ) capacitor c=0.0179513f //x=53.13 //y=1.76
c75 ( 1 0 ) capacitor c=0.0076012f //x=52.245 //y=1.675
r76 (  17 29 ) resistor r=3.57586 //w=0.17 //l=0.125 //layer=li \
 //thickness=0.1 //x=54.185 //y=0.795 //x2=54.185 //y2=0.67
r77 (  17 29 ) resistor r=18.139 //w=0.187 //l=0.265 //layer=li \
 //thickness=0.1 //x=54.185 //y=0.795 //x2=54.185 //y2=1.06
r78 (  14 29 ) resistor r=3.57586 //w=0.17 //l=0.103078 //layer=li \
 //thickness=0.1 //x=53.3 //y=0.71 //x2=53.215 //y2=0.67
r79 (  14 29 ) resistor r=27.3797 //w=0.187 //l=0.4 //layer=li //thickness=0.1 \
 //x=53.3 //y=0.71 //x2=53.7 //y2=0.71
r80 (  13 29 ) resistor r=3.57586 //w=0.17 //l=0.103078 //layer=li \
 //thickness=0.1 //x=54.1 //y=0.71 //x2=54.185 //y2=0.67
r81 (  13 29 ) resistor r=27.3797 //w=0.187 //l=0.4 //layer=li //thickness=0.1 \
 //x=54.1 //y=0.71 //x2=53.7 //y2=0.71
r82 (  10 29 ) resistor r=3.57586 //w=0.17 //l=0.125 //layer=li \
 //thickness=0.1 //x=53.215 //y=1.675 //x2=53.215 //y2=1.8
r83 (  10 29 ) resistor r=42.0963 //w=0.187 //l=0.615 //layer=li \
 //thickness=0.1 //x=53.215 //y=1.675 //x2=53.215 //y2=1.06
r84 (  9 29 ) resistor r=3.57586 //w=0.17 //l=0.125 //layer=li //thickness=0.1 \
 //x=53.215 //y=0.795 //x2=53.215 //y2=0.67
r85 (  9 29 ) resistor r=18.139 //w=0.187 //l=0.265 //layer=li //thickness=0.1 \
 //x=53.215 //y=0.795 //x2=53.215 //y2=1.06
r86 (  6 29 ) resistor r=3.57586 //w=0.17 //l=0.103078 //layer=li \
 //thickness=0.1 //x=52.33 //y=1.76 //x2=52.245 //y2=1.8
r87 (  6 29 ) resistor r=27.3797 //w=0.187 //l=0.4 //layer=li //thickness=0.1 \
 //x=52.33 //y=1.76 //x2=52.73 //y2=1.76
r88 (  5 29 ) resistor r=3.57586 //w=0.17 //l=0.103078 //layer=li \
 //thickness=0.1 //x=53.13 //y=1.76 //x2=53.215 //y2=1.8
r89 (  5 29 ) resistor r=27.3797 //w=0.187 //l=0.4 //layer=li //thickness=0.1 \
 //x=53.13 //y=1.76 //x2=52.73 //y2=1.76
r90 (  1 29 ) resistor r=3.57586 //w=0.17 //l=0.125 //layer=li //thickness=0.1 \
 //x=52.245 //y=1.675 //x2=52.245 //y2=1.8
r91 (  1 29 ) resistor r=42.0963 //w=0.187 //l=0.615 //layer=li \
 //thickness=0.1 //x=52.245 //y=1.675 //x2=52.245 //y2=1.06
ends PM_TMRDFFQNX1\%noxref_44

subckt PM_TMRDFFQNX1\%noxref_45 ( 1 5 9 10 13 17 29 )
c68 ( 29 0 ) capacitor c=0.0670536f //x=55.44 //y=0.545
c69 ( 17 0 ) capacitor c=0.0067865f //x=57.515 //y=0.795
c70 ( 13 0 ) capacitor c=0.0154977f //x=57.43 //y=0.71
c71 ( 10 0 ) capacitor c=0.00683366f //x=56.545 //y=1.675
c72 ( 9 0 ) capacitor c=0.00770028f //x=56.545 //y=0.795
c73 ( 5 0 ) capacitor c=0.0179513f //x=56.46 //y=1.76
c74 ( 1 0 ) capacitor c=0.0076012f //x=55.575 //y=1.675
r75 (  17 29 ) resistor r=3.57586 //w=0.17 //l=0.125 //layer=li \
 //thickness=0.1 //x=57.515 //y=0.795 //x2=57.515 //y2=0.67
r76 (  17 29 ) resistor r=18.139 //w=0.187 //l=0.265 //layer=li \
 //thickness=0.1 //x=57.515 //y=0.795 //x2=57.515 //y2=1.06
r77 (  14 29 ) resistor r=3.57586 //w=0.17 //l=0.103078 //layer=li \
 //thickness=0.1 //x=56.63 //y=0.71 //x2=56.545 //y2=0.67
r78 (  14 29 ) resistor r=27.3797 //w=0.187 //l=0.4 //layer=li //thickness=0.1 \
 //x=56.63 //y=0.71 //x2=57.03 //y2=0.71
r79 (  13 29 ) resistor r=3.57586 //w=0.17 //l=0.103078 //layer=li \
 //thickness=0.1 //x=57.43 //y=0.71 //x2=57.515 //y2=0.67
r80 (  13 29 ) resistor r=27.3797 //w=0.187 //l=0.4 //layer=li //thickness=0.1 \
 //x=57.43 //y=0.71 //x2=57.03 //y2=0.71
r81 (  10 29 ) resistor r=3.57586 //w=0.17 //l=0.125 //layer=li \
 //thickness=0.1 //x=56.545 //y=1.675 //x2=56.545 //y2=1.8
r82 (  10 29 ) resistor r=42.0963 //w=0.187 //l=0.615 //layer=li \
 //thickness=0.1 //x=56.545 //y=1.675 //x2=56.545 //y2=1.06
r83 (  9 29 ) resistor r=3.57586 //w=0.17 //l=0.125 //layer=li //thickness=0.1 \
 //x=56.545 //y=0.795 //x2=56.545 //y2=0.67
r84 (  9 29 ) resistor r=18.139 //w=0.187 //l=0.265 //layer=li //thickness=0.1 \
 //x=56.545 //y=0.795 //x2=56.545 //y2=1.06
r85 (  6 29 ) resistor r=3.57586 //w=0.17 //l=0.103078 //layer=li \
 //thickness=0.1 //x=55.66 //y=1.76 //x2=55.575 //y2=1.8
r86 (  6 29 ) resistor r=27.3797 //w=0.187 //l=0.4 //layer=li //thickness=0.1 \
 //x=55.66 //y=1.76 //x2=56.06 //y2=1.76
r87 (  5 29 ) resistor r=3.57586 //w=0.17 //l=0.103078 //layer=li \
 //thickness=0.1 //x=56.46 //y=1.76 //x2=56.545 //y2=1.8
r88 (  5 29 ) resistor r=27.3797 //w=0.187 //l=0.4 //layer=li //thickness=0.1 \
 //x=56.46 //y=1.76 //x2=56.06 //y2=1.76
r89 (  1 29 ) resistor r=3.57586 //w=0.17 //l=0.125 //layer=li //thickness=0.1 \
 //x=55.575 //y=1.675 //x2=55.575 //y2=1.8
r90 (  1 29 ) resistor r=42.0963 //w=0.187 //l=0.615 //layer=li \
 //thickness=0.1 //x=55.575 //y=1.675 //x2=55.575 //y2=1.06
ends PM_TMRDFFQNX1\%noxref_45

subckt PM_TMRDFFQNX1\%noxref_46 ( 1 5 9 10 13 17 29 )
c70 ( 29 0 ) capacitor c=0.0671946f //x=58.77 //y=0.545
c71 ( 17 0 ) capacitor c=0.0067865f //x=60.845 //y=0.795
c72 ( 13 0 ) capacitor c=0.0154977f //x=60.76 //y=0.71
c73 ( 10 0 ) capacitor c=0.00673372f //x=59.875 //y=1.675
c74 ( 9 0 ) capacitor c=0.00770028f //x=59.875 //y=0.795
c75 ( 5 0 ) capacitor c=0.0179513f //x=59.79 //y=1.76
c76 ( 1 0 ) capacitor c=0.0076012f //x=58.905 //y=1.675
r77 (  17 29 ) resistor r=3.57586 //w=0.17 //l=0.125 //layer=li \
 //thickness=0.1 //x=60.845 //y=0.795 //x2=60.845 //y2=0.67
r78 (  17 29 ) resistor r=18.139 //w=0.187 //l=0.265 //layer=li \
 //thickness=0.1 //x=60.845 //y=0.795 //x2=60.845 //y2=1.06
r79 (  14 29 ) resistor r=3.57586 //w=0.17 //l=0.103078 //layer=li \
 //thickness=0.1 //x=59.96 //y=0.71 //x2=59.875 //y2=0.67
r80 (  14 29 ) resistor r=27.3797 //w=0.187 //l=0.4 //layer=li //thickness=0.1 \
 //x=59.96 //y=0.71 //x2=60.36 //y2=0.71
r81 (  13 29 ) resistor r=3.57586 //w=0.17 //l=0.103078 //layer=li \
 //thickness=0.1 //x=60.76 //y=0.71 //x2=60.845 //y2=0.67
r82 (  13 29 ) resistor r=27.3797 //w=0.187 //l=0.4 //layer=li //thickness=0.1 \
 //x=60.76 //y=0.71 //x2=60.36 //y2=0.71
r83 (  10 29 ) resistor r=3.57586 //w=0.17 //l=0.125 //layer=li \
 //thickness=0.1 //x=59.875 //y=1.675 //x2=59.875 //y2=1.8
r84 (  10 29 ) resistor r=42.0963 //w=0.187 //l=0.615 //layer=li \
 //thickness=0.1 //x=59.875 //y=1.675 //x2=59.875 //y2=1.06
r85 (  9 29 ) resistor r=3.57586 //w=0.17 //l=0.125 //layer=li //thickness=0.1 \
 //x=59.875 //y=0.795 //x2=59.875 //y2=0.67
r86 (  9 29 ) resistor r=18.139 //w=0.187 //l=0.265 //layer=li //thickness=0.1 \
 //x=59.875 //y=0.795 //x2=59.875 //y2=1.06
r87 (  6 29 ) resistor r=3.57586 //w=0.17 //l=0.103078 //layer=li \
 //thickness=0.1 //x=58.99 //y=1.76 //x2=58.905 //y2=1.8
r88 (  6 29 ) resistor r=27.3797 //w=0.187 //l=0.4 //layer=li //thickness=0.1 \
 //x=58.99 //y=1.76 //x2=59.39 //y2=1.76
r89 (  5 29 ) resistor r=3.57586 //w=0.17 //l=0.103078 //layer=li \
 //thickness=0.1 //x=59.79 //y=1.76 //x2=59.875 //y2=1.8
r90 (  5 29 ) resistor r=27.3797 //w=0.187 //l=0.4 //layer=li //thickness=0.1 \
 //x=59.79 //y=1.76 //x2=59.39 //y2=1.76
r91 (  1 29 ) resistor r=3.57586 //w=0.17 //l=0.125 //layer=li //thickness=0.1 \
 //x=58.905 //y=1.675 //x2=58.905 //y2=1.8
r92 (  1 29 ) resistor r=42.0963 //w=0.187 //l=0.615 //layer=li \
 //thickness=0.1 //x=58.905 //y=1.675 //x2=58.905 //y2=1.06
ends PM_TMRDFFQNX1\%noxref_46

subckt PM_TMRDFFQNX1\%noxref_47 ( 1 5 9 10 13 17 29 )
c69 ( 29 0 ) capacitor c=0.0668792f //x=62.1 //y=0.545
c70 ( 17 0 ) capacitor c=0.0067865f //x=64.175 //y=0.795
c71 ( 13 0 ) capacitor c=0.0156179f //x=64.09 //y=0.71
c72 ( 10 0 ) capacitor c=0.00673372f //x=63.205 //y=1.675
c73 ( 9 0 ) capacitor c=0.00770028f //x=63.205 //y=0.795
c74 ( 5 0 ) capacitor c=0.0179513f //x=63.12 //y=1.76
c75 ( 1 0 ) capacitor c=0.0076012f //x=62.235 //y=1.675
r76 (  17 29 ) resistor r=3.57586 //w=0.17 //l=0.125 //layer=li \
 //thickness=0.1 //x=64.175 //y=0.795 //x2=64.175 //y2=0.67
r77 (  17 29 ) resistor r=18.139 //w=0.187 //l=0.265 //layer=li \
 //thickness=0.1 //x=64.175 //y=0.795 //x2=64.175 //y2=1.06
r78 (  14 29 ) resistor r=3.57586 //w=0.17 //l=0.103078 //layer=li \
 //thickness=0.1 //x=63.29 //y=0.71 //x2=63.205 //y2=0.67
r79 (  14 29 ) resistor r=27.3797 //w=0.187 //l=0.4 //layer=li //thickness=0.1 \
 //x=63.29 //y=0.71 //x2=63.69 //y2=0.71
r80 (  13 29 ) resistor r=3.57586 //w=0.17 //l=0.103078 //layer=li \
 //thickness=0.1 //x=64.09 //y=0.71 //x2=64.175 //y2=0.67
r81 (  13 29 ) resistor r=27.3797 //w=0.187 //l=0.4 //layer=li //thickness=0.1 \
 //x=64.09 //y=0.71 //x2=63.69 //y2=0.71
r82 (  10 29 ) resistor r=3.57586 //w=0.17 //l=0.125 //layer=li \
 //thickness=0.1 //x=63.205 //y=1.675 //x2=63.205 //y2=1.8
r83 (  10 29 ) resistor r=42.0963 //w=0.187 //l=0.615 //layer=li \
 //thickness=0.1 //x=63.205 //y=1.675 //x2=63.205 //y2=1.06
r84 (  9 29 ) resistor r=3.57586 //w=0.17 //l=0.125 //layer=li //thickness=0.1 \
 //x=63.205 //y=0.795 //x2=63.205 //y2=0.67
r85 (  9 29 ) resistor r=18.139 //w=0.187 //l=0.265 //layer=li //thickness=0.1 \
 //x=63.205 //y=0.795 //x2=63.205 //y2=1.06
r86 (  6 29 ) resistor r=3.57586 //w=0.17 //l=0.103078 //layer=li \
 //thickness=0.1 //x=62.32 //y=1.76 //x2=62.235 //y2=1.8
r87 (  6 29 ) resistor r=27.3797 //w=0.187 //l=0.4 //layer=li //thickness=0.1 \
 //x=62.32 //y=1.76 //x2=62.72 //y2=1.76
r88 (  5 29 ) resistor r=3.57586 //w=0.17 //l=0.103078 //layer=li \
 //thickness=0.1 //x=63.12 //y=1.76 //x2=63.205 //y2=1.8
r89 (  5 29 ) resistor r=27.3797 //w=0.187 //l=0.4 //layer=li //thickness=0.1 \
 //x=63.12 //y=1.76 //x2=62.72 //y2=1.76
r90 (  1 29 ) resistor r=3.57586 //w=0.17 //l=0.125 //layer=li //thickness=0.1 \
 //x=62.235 //y=1.675 //x2=62.235 //y2=1.8
r91 (  1 29 ) resistor r=42.0963 //w=0.187 //l=0.615 //layer=li \
 //thickness=0.1 //x=62.235 //y=1.675 //x2=62.235 //y2=1.06
ends PM_TMRDFFQNX1\%noxref_47

subckt PM_TMRDFFQNX1\%noxref_48 ( 1 5 9 10 13 17 29 )
c68 ( 29 0 ) capacitor c=0.0765021f //x=65.43 //y=0.545
c69 ( 17 0 ) capacitor c=0.00678917f //x=67.505 //y=0.795
c70 ( 13 0 ) capacitor c=0.0152971f //x=67.42 //y=0.71
c71 ( 10 0 ) capacitor c=0.0073629f //x=66.535 //y=1.675
c72 ( 9 0 ) capacitor c=0.00770028f //x=66.535 //y=0.795
c73 ( 5 0 ) capacitor c=0.0203276f //x=66.45 //y=1.76
c74 ( 1 0 ) capacitor c=0.00458599f //x=65.565 //y=1.675
r75 (  17 29 ) resistor r=3.57586 //w=0.17 //l=0.125 //layer=li \
 //thickness=0.1 //x=67.505 //y=0.795 //x2=67.505 //y2=0.67
r76 (  17 29 ) resistor r=41.4118 //w=0.187 //l=0.605 //layer=li \
 //thickness=0.1 //x=67.505 //y=0.795 //x2=67.505 //y2=1.4
r77 (  14 29 ) resistor r=3.57586 //w=0.17 //l=0.103078 //layer=li \
 //thickness=0.1 //x=66.62 //y=0.71 //x2=66.535 //y2=0.67
r78 (  14 29 ) resistor r=27.0374 //w=0.187 //l=0.395 //layer=li \
 //thickness=0.1 //x=66.62 //y=0.71 //x2=67.015 //y2=0.71
r79 (  13 29 ) resistor r=3.57586 //w=0.17 //l=0.103078 //layer=li \
 //thickness=0.1 //x=67.42 //y=0.71 //x2=67.505 //y2=0.67
r80 (  13 29 ) resistor r=27.7219 //w=0.187 //l=0.405 //layer=li \
 //thickness=0.1 //x=67.42 //y=0.71 //x2=67.015 //y2=0.71
r81 (  10 29 ) resistor r=3.57586 //w=0.17 //l=0.125 //layer=li \
 //thickness=0.1 //x=66.535 //y=1.675 //x2=66.535 //y2=1.8
r82 (  10 29 ) resistor r=42.0963 //w=0.187 //l=0.615 //layer=li \
 //thickness=0.1 //x=66.535 //y=1.675 //x2=66.535 //y2=1.06
r83 (  9 29 ) resistor r=3.57586 //w=0.17 //l=0.125 //layer=li //thickness=0.1 \
 //x=66.535 //y=0.795 //x2=66.535 //y2=0.67
r84 (  9 29 ) resistor r=18.139 //w=0.187 //l=0.265 //layer=li //thickness=0.1 \
 //x=66.535 //y=0.795 //x2=66.535 //y2=1.06
r85 (  6 29 ) resistor r=3.57586 //w=0.17 //l=0.103078 //layer=li \
 //thickness=0.1 //x=65.65 //y=1.76 //x2=65.565 //y2=1.8
r86 (  6 29 ) resistor r=27.3797 //w=0.187 //l=0.4 //layer=li //thickness=0.1 \
 //x=65.65 //y=1.76 //x2=66.05 //y2=1.76
r87 (  5 29 ) resistor r=3.57586 //w=0.17 //l=0.103078 //layer=li \
 //thickness=0.1 //x=66.45 //y=1.76 //x2=66.535 //y2=1.8
r88 (  5 29 ) resistor r=27.3797 //w=0.187 //l=0.4 //layer=li //thickness=0.1 \
 //x=66.45 //y=1.76 //x2=66.05 //y2=1.76
r89 (  1 29 ) resistor r=3.57586 //w=0.17 //l=0.125 //layer=li //thickness=0.1 \
 //x=65.565 //y=1.675 //x2=65.565 //y2=1.8
r90 (  1 29 ) resistor r=42.0963 //w=0.187 //l=0.615 //layer=li \
 //thickness=0.1 //x=65.565 //y=1.675 //x2=65.565 //y2=1.06
ends PM_TMRDFFQNX1\%noxref_48

subckt PM_TMRDFFQNX1\%noxref_49 ( 1 5 9 10 13 17 29 )
c64 ( 29 0 ) capacitor c=0.0738251f //x=68.76 //y=0.545
c65 ( 17 0 ) capacitor c=0.00678917f //x=70.835 //y=0.795
c66 ( 13 0 ) capacitor c=0.0158009f //x=70.75 //y=0.71
c67 ( 10 0 ) capacitor c=0.00903204f //x=69.865 //y=1.675
c68 ( 9 0 ) capacitor c=0.00770028f //x=69.865 //y=0.795
c69 ( 5 0 ) capacitor c=0.018606f //x=69.78 //y=1.76
c70 ( 1 0 ) capacitor c=0.00881929f //x=68.895 //y=1.675
r71 (  17 29 ) resistor r=3.57586 //w=0.17 //l=0.125 //layer=li \
 //thickness=0.1 //x=70.835 //y=0.795 //x2=70.835 //y2=0.67
r72 (  17 29 ) resistor r=41.4118 //w=0.187 //l=0.605 //layer=li \
 //thickness=0.1 //x=70.835 //y=0.795 //x2=70.835 //y2=1.4
r73 (  14 29 ) resistor r=3.57586 //w=0.17 //l=0.103078 //layer=li \
 //thickness=0.1 //x=69.95 //y=0.71 //x2=69.865 //y2=0.67
r74 (  14 29 ) resistor r=27.3797 //w=0.187 //l=0.4 //layer=li //thickness=0.1 \
 //x=69.95 //y=0.71 //x2=70.35 //y2=0.71
r75 (  13 29 ) resistor r=3.57586 //w=0.17 //l=0.103078 //layer=li \
 //thickness=0.1 //x=70.75 //y=0.71 //x2=70.835 //y2=0.67
r76 (  13 29 ) resistor r=27.3797 //w=0.187 //l=0.4 //layer=li //thickness=0.1 \
 //x=70.75 //y=0.71 //x2=70.35 //y2=0.71
r77 (  10 29 ) resistor r=3.57586 //w=0.17 //l=0.125 //layer=li \
 //thickness=0.1 //x=69.865 //y=1.675 //x2=69.865 //y2=1.8
r78 (  10 29 ) resistor r=42.0963 //w=0.187 //l=0.615 //layer=li \
 //thickness=0.1 //x=69.865 //y=1.675 //x2=69.865 //y2=1.06
r79 (  9 29 ) resistor r=3.57586 //w=0.17 //l=0.125 //layer=li //thickness=0.1 \
 //x=69.865 //y=0.795 //x2=69.865 //y2=0.67
r80 (  9 29 ) resistor r=18.139 //w=0.187 //l=0.265 //layer=li //thickness=0.1 \
 //x=69.865 //y=0.795 //x2=69.865 //y2=1.06
r81 (  6 29 ) resistor r=3.57586 //w=0.17 //l=0.103078 //layer=li \
 //thickness=0.1 //x=68.98 //y=1.76 //x2=68.895 //y2=1.8
r82 (  6 29 ) resistor r=27.3797 //w=0.187 //l=0.4 //layer=li //thickness=0.1 \
 //x=68.98 //y=1.76 //x2=69.38 //y2=1.76
r83 (  5 29 ) resistor r=3.57586 //w=0.17 //l=0.103078 //layer=li \
 //thickness=0.1 //x=69.78 //y=1.76 //x2=69.865 //y2=1.8
r84 (  5 29 ) resistor r=27.3797 //w=0.187 //l=0.4 //layer=li //thickness=0.1 \
 //x=69.78 //y=1.76 //x2=69.38 //y2=1.76
r85 (  1 29 ) resistor r=3.57586 //w=0.17 //l=0.125 //layer=li //thickness=0.1 \
 //x=68.895 //y=1.675 //x2=68.895 //y2=1.8
r86 (  1 29 ) resistor r=42.0963 //w=0.187 //l=0.615 //layer=li \
 //thickness=0.1 //x=68.895 //y=1.675 //x2=68.895 //y2=1.06
ends PM_TMRDFFQNX1\%noxref_49

subckt PM_TMRDFFQNX1\%noxref_50 ( 1 5 9 10 13 17 29 )
c62 ( 29 0 ) capacitor c=0.068598f //x=72.09 //y=0.545
c63 ( 17 0 ) capacitor c=0.00709795f //x=74.165 //y=0.795
c64 ( 13 0 ) capacitor c=0.0152565f //x=74.08 //y=0.71
c65 ( 10 0 ) capacitor c=0.0075177f //x=73.195 //y=1.675
c66 ( 9 0 ) capacitor c=0.00770028f //x=73.195 //y=0.795
c67 ( 5 0 ) capacitor c=0.0236235f //x=73.11 //y=1.76
c68 ( 1 0 ) capacitor c=0.00498306f //x=72.225 //y=1.675
r69 (  17 29 ) resistor r=3.57586 //w=0.17 //l=0.125 //layer=li \
 //thickness=0.1 //x=74.165 //y=0.795 //x2=74.165 //y2=0.67
r70 (  17 29 ) resistor r=18.139 //w=0.187 //l=0.265 //layer=li \
 //thickness=0.1 //x=74.165 //y=0.795 //x2=74.165 //y2=1.06
r71 (  14 29 ) resistor r=3.57586 //w=0.17 //l=0.103078 //layer=li \
 //thickness=0.1 //x=73.28 //y=0.71 //x2=73.195 //y2=0.67
r72 (  14 29 ) resistor r=27.3797 //w=0.187 //l=0.4 //layer=li //thickness=0.1 \
 //x=73.28 //y=0.71 //x2=73.68 //y2=0.71
r73 (  13 29 ) resistor r=3.57586 //w=0.17 //l=0.103078 //layer=li \
 //thickness=0.1 //x=74.08 //y=0.71 //x2=74.165 //y2=0.67
r74 (  13 29 ) resistor r=27.3797 //w=0.187 //l=0.4 //layer=li //thickness=0.1 \
 //x=74.08 //y=0.71 //x2=73.68 //y2=0.71
r75 (  10 29 ) resistor r=3.57586 //w=0.17 //l=0.125 //layer=li \
 //thickness=0.1 //x=73.195 //y=1.675 //x2=73.195 //y2=1.8
r76 (  10 29 ) resistor r=42.0963 //w=0.187 //l=0.615 //layer=li \
 //thickness=0.1 //x=73.195 //y=1.675 //x2=73.195 //y2=1.06
r77 (  9 29 ) resistor r=3.57586 //w=0.17 //l=0.125 //layer=li //thickness=0.1 \
 //x=73.195 //y=0.795 //x2=73.195 //y2=0.67
r78 (  9 29 ) resistor r=18.139 //w=0.187 //l=0.265 //layer=li //thickness=0.1 \
 //x=73.195 //y=0.795 //x2=73.195 //y2=1.06
r79 (  6 29 ) resistor r=3.57586 //w=0.17 //l=0.103078 //layer=li \
 //thickness=0.1 //x=72.31 //y=1.76 //x2=72.225 //y2=1.8
r80 (  6 29 ) resistor r=27.3797 //w=0.187 //l=0.4 //layer=li //thickness=0.1 \
 //x=72.31 //y=1.76 //x2=72.71 //y2=1.76
r81 (  5 29 ) resistor r=3.57586 //w=0.17 //l=0.103078 //layer=li \
 //thickness=0.1 //x=73.11 //y=1.76 //x2=73.195 //y2=1.8
r82 (  5 29 ) resistor r=27.3797 //w=0.187 //l=0.4 //layer=li //thickness=0.1 \
 //x=73.11 //y=1.76 //x2=72.71 //y2=1.76
r83 (  1 29 ) resistor r=3.57586 //w=0.17 //l=0.125 //layer=li //thickness=0.1 \
 //x=72.225 //y=1.675 //x2=72.225 //y2=1.8
r84 (  1 29 ) resistor r=42.0963 //w=0.187 //l=0.615 //layer=li \
 //thickness=0.1 //x=72.225 //y=1.675 //x2=72.225 //y2=1.06
ends PM_TMRDFFQNX1\%noxref_50
