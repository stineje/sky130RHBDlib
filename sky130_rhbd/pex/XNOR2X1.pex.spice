// File: XNOR2X1.spi.pex
// Created: Thu Jan 22 07:10:53 2026
// Program "Calibre xRC"
// Version "v2023.2_27.15"
// Nominal Temperature: 30C
// Circuit Temperature: 30C
//
simulator lang=spectre
subckt PM_XNOR2X1\%A ( 1 2 3 4 5 6 7 8 9 10 11 12 19 20 22 28 29 32 53 55 56 \
 59 68 73 82 86 87 88 89 90 91 92 93 94 95 99 100 101 103 109 110 111 112 113 \
 114 118 120 123 124 129 143 )
c235 ( 143 0 ) capacitor c=0.0663048f //x=3.82 //y=4.88
c236 ( 129 0 ) capacitor c=0.0564228f //x=1.23 //y=2.265
c237 ( 124 0 ) capacitor c=0.0318948f //x=4.155 //y=1.39
c238 ( 123 0 ) capacitor c=0.0186809f //x=4.155 //y=1.045
c239 ( 120 0 ) capacitor c=0.0141797f //x=4 //y=1.545
c240 ( 118 0 ) capacitor c=0.0158553f //x=4 //y=0.89
c241 ( 114 0 ) capacitor c=0.0900748f //x=3.625 //y=2.095
c242 ( 113 0 ) capacitor c=0.0230011f //x=3.625 //y=1.7
c243 ( 112 0 ) capacitor c=0.0234352f //x=3.625 //y=1.39
c244 ( 111 0 ) capacitor c=0.0198759f //x=3.625 //y=1.045
c245 ( 110 0 ) capacitor c=0.0439576f //x=1.87 //y=1.435
c246 ( 109 0 ) capacitor c=0.0201087f //x=1.87 //y=1.09
c247 ( 103 0 ) capacitor c=0.0161986f //x=1.715 //y=1.59
c248 ( 101 0 ) capacitor c=0.0157807f //x=1.715 //y=0.935
c249 ( 100 0 ) capacitor c=0.0497169f //x=1.46 //y=4.97
c250 ( 99 0 ) capacitor c=0.0399032f //x=1.75 //y=4.97
c251 ( 95 0 ) capacitor c=0.0301471f //x=1.34 //y=2.1
c252 ( 94 0 ) capacitor c=0.0255349f //x=1.34 //y=1.745
c253 ( 93 0 ) capacitor c=0.0234346f //x=1.34 //y=1.435
c254 ( 92 0 ) capacitor c=0.02013f //x=1.34 //y=1.09
c255 ( 91 0 ) capacitor c=0.110998f //x=4.16 //y=6.2
c256 ( 90 0 ) capacitor c=0.155254f //x=3.72 //y=6.2
c257 ( 89 0 ) capacitor c=0.153944f //x=1.825 //y=6.2
c258 ( 88 0 ) capacitor c=0.154411f //x=1.385 //y=6.2
c259 ( 82 0 ) capacitor c=0.00101672f //x=3.82 //y=4.88
c260 ( 73 0 ) capacitor c=0.00138823f //x=3.82 //y=2.26
c261 ( 68 0 ) capacitor c=6.76693e-19 //x=1.23 //y=4.88
c262 ( 59 0 ) capacitor c=9.11699e-19 //x=1.23 //y=2.265
c263 ( 56 0 ) capacitor c=0.0793451f //x=3.665 //y=4.295
c264 ( 55 0 ) capacitor c=0.00273286f //x=3.825 //y=4.295
c265 ( 53 0 ) capacitor c=0.00910418f //x=1.39 //y=4.295
c266 ( 32 0 ) capacitor c=0.0139435f //x=1.23 //y=2.265
c267 ( 29 0 ) capacitor c=0.00558876f //x=3.82 //y=4.76
c268 ( 28 0 ) capacitor c=0.0121823f //x=3.82 //y=4.455
c269 ( 22 0 ) capacitor c=0.00730363f //x=3.82 //y=2.41
c270 ( 20 0 ) capacitor c=0.00945256f //x=1.23 //y=4.76
c271 ( 19 0 ) capacitor c=0.0119694f //x=1.23 //y=4.455
c272 ( 12 0 ) capacitor c=0.0152048f //x=3.82 //y=4.25
c273 ( 11 0 ) capacitor c=0.0155885f //x=1.23 //y=4.25
c274 ( 10 0 ) capacitor c=0.00741602f //x=3.82 //y=4.62
c275 ( 6 0 ) capacitor c=0.0568426f //x=3.82 //y=2.77
c276 ( 5 0 ) capacitor c=0.00773131f //x=1.23 //y=4.62
c277 ( 1 0 ) capacitor c=0.077535f //x=1.23 //y=2.77
r278 (  141 143 ) resistor r=20.6867 //w=0.233 //l=0.1 //layer=ply \
 //thickness=0.18 //x=3.72 //y=4.88 //x2=3.82 //y2=4.88
r279 (  129 130 ) resistor r=17.5563 //w=0.302 //l=0.11 //layer=ply \
 //thickness=0.18 //x=1.23 //y=2.265 //x2=1.34 //y2=2.265
r280 (  125 143 ) resistor r=70.3348 //w=0.233 //l=0.414367 //layer=ply \
 //thickness=0.18 //x=4.16 //y=5.045 //x2=3.82 //y2=4.88
r281 (  124 145 ) resistor r=45.1352 //w=0.168 //l=0.173853 //layer=ply \
 //thickness=0.18 //x=4.155 //y=1.39 //x2=4.115 //y2=1.545
r282 (  123 144 ) resistor r=45.1352 //w=0.168 //l=0.173853 //layer=ply \
 //thickness=0.18 //x=4.155 //y=1.045 //x2=4.115 //y2=0.89
r283 (  123 124 ) resistor r=176.904 //w=0.094 //l=0.345 //layer=ply \
 //thickness=0.18 //x=4.155 //y=1.045 //x2=4.155 //y2=1.39
r284 (  121 140 ) resistor r=10.701 //w=0.21 //l=0.115 //layer=ply \
 //thickness=0.18 //x=3.78 //y=1.545 //x2=3.665 //y2=1.545
r285 (  120 145 ) resistor r=5.52526 //w=0.168 //l=0.115 //layer=ply \
 //thickness=0.18 //x=4 //y=1.545 //x2=4.115 //y2=1.545
r286 (  119 139 ) resistor r=5.52526 //w=0.168 //l=0.115 //layer=ply \
 //thickness=0.18 //x=3.78 //y=0.89 //x2=3.665 //y2=0.89
r287 (  118 144 ) resistor r=5.52526 //w=0.168 //l=0.115 //layer=ply \
 //thickness=0.18 //x=4 //y=0.89 //x2=4.115 //y2=0.89
r288 (  118 119 ) resistor r=112.809 //w=0.094 //l=0.22 //layer=ply \
 //thickness=0.18 //x=4 //y=0.89 //x2=3.78 //y2=0.89
r289 (  115 141 ) resistor r=13.0941 //w=0.233 //l=0.165 //layer=ply \
 //thickness=0.18 //x=3.72 //y=5.045 //x2=3.72 //y2=4.88
r290 (  114 138 ) resistor r=34.8111 //w=0.27 //l=0.264953 //layer=ply \
 //thickness=0.18 //x=3.625 //y=2.095 //x2=3.82 //y2=2.26
r291 (  113 140 ) resistor r=39.5823 //w=0.21 //l=0.173853 //layer=ply \
 //thickness=0.18 //x=3.625 //y=1.7 //x2=3.665 //y2=1.545
r292 (  113 114 ) resistor r=202.543 //w=0.094 //l=0.395 //layer=ply \
 //thickness=0.18 //x=3.625 //y=1.7 //x2=3.625 //y2=2.095
r293 (  112 140 ) resistor r=39.5823 //w=0.21 //l=0.173853 //layer=ply \
 //thickness=0.18 //x=3.625 //y=1.39 //x2=3.665 //y2=1.545
r294 (  111 139 ) resistor r=45.1352 //w=0.168 //l=0.173853 //layer=ply \
 //thickness=0.18 //x=3.625 //y=1.045 //x2=3.665 //y2=0.89
r295 (  111 112 ) resistor r=176.904 //w=0.094 //l=0.345 //layer=ply \
 //thickness=0.18 //x=3.625 //y=1.045 //x2=3.625 //y2=1.39
r296 (  110 136 ) resistor r=45.1352 //w=0.168 //l=0.173853 //layer=ply \
 //thickness=0.18 //x=1.87 //y=1.435 //x2=1.83 //y2=1.59
r297 (  109 135 ) resistor r=45.1352 //w=0.168 //l=0.173853 //layer=ply \
 //thickness=0.18 //x=1.87 //y=1.09 //x2=1.83 //y2=0.935
r298 (  109 110 ) resistor r=176.904 //w=0.094 //l=0.345 //layer=ply \
 //thickness=0.18 //x=1.87 //y=1.09 //x2=1.87 //y2=1.435
r299 (  104 134 ) resistor r=10.701 //w=0.21 //l=0.115 //layer=ply \
 //thickness=0.18 //x=1.495 //y=1.59 //x2=1.38 //y2=1.59
r300 (  103 136 ) resistor r=5.52526 //w=0.168 //l=0.115 //layer=ply \
 //thickness=0.18 //x=1.715 //y=1.59 //x2=1.83 //y2=1.59
r301 (  102 133 ) resistor r=5.52526 //w=0.168 //l=0.115 //layer=ply \
 //thickness=0.18 //x=1.495 //y=0.935 //x2=1.38 //y2=0.935
r302 (  101 135 ) resistor r=5.52526 //w=0.168 //l=0.115 //layer=ply \
 //thickness=0.18 //x=1.715 //y=0.935 //x2=1.83 //y2=0.935
r303 (  101 102 ) resistor r=112.809 //w=0.094 //l=0.22 //layer=ply \
 //thickness=0.18 //x=1.715 //y=0.935 //x2=1.495 //y2=0.935
r304 (  99 106 ) resistor r=26.9307 //w=0.15 //l=0.106066 //layer=ply \
 //thickness=0.18 //x=1.75 //y=4.97 //x2=1.825 //y2=5.045
r305 (  99 100 ) resistor r=148.702 //w=0.094 //l=0.29 //layer=ply \
 //thickness=0.18 //x=1.75 //y=4.97 //x2=1.46 //y2=4.97
r306 (  96 100 ) resistor r=23.403 //w=0.284 //l=0.106066 //layer=ply \
 //thickness=0.18 //x=1.385 //y=5.045 //x2=1.46 //y2=4.97
r307 (  96 132 ) resistor r=26.3063 //w=0.284 //l=0.229783 //layer=ply \
 //thickness=0.18 //x=1.385 //y=5.045 //x2=1.23 //y2=4.88
r308 (  95 130 ) resistor r=19.1248 //w=0.302 //l=0.165 //layer=ply \
 //thickness=0.18 //x=1.34 //y=2.1 //x2=1.34 //y2=2.265
r309 (  94 134 ) resistor r=39.5823 //w=0.21 //l=0.173853 //layer=ply \
 //thickness=0.18 //x=1.34 //y=1.745 //x2=1.38 //y2=1.59
r310 (  94 95 ) resistor r=182.032 //w=0.094 //l=0.355 //layer=ply \
 //thickness=0.18 //x=1.34 //y=1.745 //x2=1.34 //y2=2.1
r311 (  93 134 ) resistor r=39.5823 //w=0.21 //l=0.173853 //layer=ply \
 //thickness=0.18 //x=1.34 //y=1.435 //x2=1.38 //y2=1.59
r312 (  92 133 ) resistor r=45.1352 //w=0.168 //l=0.173853 //layer=ply \
 //thickness=0.18 //x=1.34 //y=1.09 //x2=1.38 //y2=0.935
r313 (  92 93 ) resistor r=176.904 //w=0.094 //l=0.345 //layer=ply \
 //thickness=0.18 //x=1.34 //y=1.09 //x2=1.34 //y2=1.435
r314 (  91 125 ) resistor r=592.245 //w=0.094 //l=1.155 //layer=ply \
 //thickness=0.18 //x=4.16 //y=6.2 //x2=4.16 //y2=5.045
r315 (  90 115 ) resistor r=592.245 //w=0.094 //l=1.155 //layer=ply \
 //thickness=0.18 //x=3.72 //y=6.2 //x2=3.72 //y2=5.045
r316 (  89 106 ) resistor r=592.245 //w=0.094 //l=1.155 //layer=ply \
 //thickness=0.18 //x=1.825 //y=6.2 //x2=1.825 //y2=5.045
r317 (  88 96 ) resistor r=592.245 //w=0.094 //l=1.155 //layer=ply \
 //thickness=0.18 //x=1.385 //y=6.2 //x2=1.385 //y2=5.045
r318 (  87 120 ) resistor r=56.4043 //w=0.094 //l=0.11 //layer=ply \
 //thickness=0.18 //x=3.89 //y=1.545 //x2=4 //y2=1.545
r319 (  87 121 ) resistor r=56.4043 //w=0.094 //l=0.11 //layer=ply \
 //thickness=0.18 //x=3.89 //y=1.545 //x2=3.78 //y2=1.545
r320 (  86 103 ) resistor r=56.4043 //w=0.094 //l=0.11 //layer=ply \
 //thickness=0.18 //x=1.605 //y=1.59 //x2=1.715 //y2=1.59
r321 (  86 104 ) resistor r=56.4043 //w=0.094 //l=0.11 //layer=ply \
 //thickness=0.18 //x=1.605 //y=1.59 //x2=1.495 //y2=1.59
r322 (  82 143 ) resistor r=152 //w=0.17 //l=0.17 //layer=licon //count=1 \
 //x=3.82 //y=4.88 //x2=3.82 //y2=4.88
r323 (  73 138 ) resistor r=152 //w=0.17 //l=0.17 //layer=licon //count=1 \
 //x=3.82 //y=2.26 //x2=3.82 //y2=2.26
r324 (  68 132 ) resistor r=152 //w=0.17 //l=0.17 //layer=licon //count=1 \
 //x=1.23 //y=4.88 //x2=1.23 //y2=4.88
r325 (  59 129 ) resistor r=152 //w=0.17 //l=0.17 //layer=licon //count=1 \
 //x=1.23 //y=2.265 //x2=1.23 //y2=2.265
r326 (  55 56 ) resistor r=0.10734 //w=0.281 //l=0.16 //layer=m2 \
 //thickness=0.36 //x=3.825 //y=4.295 //x2=3.665 //y2=4.295
r327 (  53 56 ) resistor r=2.1708 //w=0.131 //l=2.275 //layer=m2 \
 //thickness=0.36 //x=1.39 //y=4.25 //x2=3.665 //y2=4.25
r328 (  51 53 ) resistor r=0.10734 //w=0.281 //l=0.16 //layer=m2 \
 //thickness=0.36 //x=1.23 //y=4.295 //x2=1.39 //y2=4.295
r329 (  47 82 ) resistor r=9.3 //w=0.17 //l=0.17 //layer=mcon //count=1 \
 //x=3.82 //y=4.88 //x2=3.82 //y2=4.88
r330 (  45 73 ) resistor r=9.3 //w=0.17 //l=0.17 //layer=mcon //count=1 \
 //x=3.82 //y=2.26 //x2=3.82 //y2=2.26
r331 (  43 55 ) resistor r=4.5 //w=0.15 //l=0.15 //layer=via1 //count=1 \
 //x=3.825 //y=4.295 //x2=3.825 //y2=4.295
r332 (  39 51 ) resistor r=4.5 //w=0.15 //l=0.15 //layer=via1 //count=1 \
 //x=1.23 //y=4.295 //x2=1.23 //y2=4.295
r333 (  35 68 ) resistor r=9.3 //w=0.17 //l=0.17 //layer=mcon //count=1 \
 //x=1.23 //y=4.88 //x2=1.23 //y2=4.88
r334 (  32 59 ) resistor r=9.3 //w=0.17 //l=0.17 //layer=mcon //count=1 \
 //x=1.23 //y=2.265 //x2=1.23 //y2=2.265
r335 (  29 47 ) resistor r=0.0745285 //w=0.224 //l=0.12 //layer=m1 \
 //thickness=0.36 //x=3.82 //y=4.76 //x2=3.82 //y2=4.88
r336 (  28 43 ) resistor r=0.0912814 //w=0.379 //l=0.183303 //layer=m1 \
 //thickness=0.36 //x=3.82 //y=4.455 //x2=3.77 //y2=4.295
r337 (  22 45 ) resistor r=0.0882629 //w=0.246 //l=0.15 //layer=m1 \
 //thickness=0.36 //x=3.82 //y=2.41 //x2=3.82 //y2=2.26
r338 (  20 35 ) resistor r=0.0730601 //w=0.245 //l=0.120996 //layer=m1 \
 //thickness=0.36 //x=1.23 //y=4.76 //x2=1.232 //y2=4.88
r339 (  19 39 ) resistor r=0.0911593 //w=0.376 //l=0.184174 //layer=m1 \
 //thickness=0.36 //x=1.23 //y=4.455 //x2=1.282 //y2=4.295
r340 (  13 32 ) resistor r=0.116051 //w=0.211 //l=0.165 //layer=m1 \
 //thickness=0.36 //x=1.23 //y=2.43 //x2=1.23 //y2=2.265
r341 (  12 43 ) resistor r=0.0148417 //w=0.379 //l=0.045 //layer=m1 \
 //thickness=0.36 //x=3.77 //y=4.25 //x2=3.77 //y2=4.295
r342 (  12 23 ) resistor r=0.0764397 //w=0.379 //l=0.13775 //layer=m1 \
 //thickness=0.36 //x=3.77 //y=4.25 //x2=3.82 //y2=4.135
r343 (  11 39 ) resistor r=0.0149601 //w=0.376 //l=0.045 //layer=m1 \
 //thickness=0.36 //x=1.282 //y=4.25 //x2=1.282 //y2=4.295
r344 (  11 14 ) resistor r=0.0761992 //w=0.376 //l=0.138582 //layer=m1 \
 //thickness=0.36 //x=1.282 //y=4.25 //x2=1.23 //y2=4.135
r345 (  10 29 ) resistor r=0.133588 //w=0.131 //l=0.14 //layer=m1 \
 //thickness=0.36 //x=3.82 //y=4.62 //x2=3.82 //y2=4.76
r346 (  10 28 ) resistor r=0.157443 //w=0.131 //l=0.165 //layer=m1 \
 //thickness=0.36 //x=3.82 //y=4.62 //x2=3.82 //y2=4.455
r347 (  9 23 ) resistor r=0.243321 //w=0.131 //l=0.255 //layer=m1 \
 //thickness=0.36 //x=3.82 //y=3.88 //x2=3.82 //y2=4.135
r348 (  8 9 ) resistor r=0.353053 //w=0.131 //l=0.37 //layer=m1 \
 //thickness=0.36 //x=3.82 //y=3.51 //x2=3.82 //y2=3.88
r349 (  7 8 ) resistor r=0.353053 //w=0.131 //l=0.37 //layer=m1 \
 //thickness=0.36 //x=3.82 //y=3.14 //x2=3.82 //y2=3.51
r350 (  6 7 ) resistor r=0.353053 //w=0.131 //l=0.37 //layer=m1 \
 //thickness=0.36 //x=3.82 //y=2.77 //x2=3.82 //y2=3.14
r351 (  6 22 ) resistor r=0.343511 //w=0.131 //l=0.36 //layer=m1 \
 //thickness=0.36 //x=3.82 //y=2.77 //x2=3.82 //y2=2.41
r352 (  5 20 ) resistor r=0.133588 //w=0.131 //l=0.14 //layer=m1 \
 //thickness=0.36 //x=1.23 //y=4.62 //x2=1.23 //y2=4.76
r353 (  5 19 ) resistor r=0.157443 //w=0.131 //l=0.165 //layer=m1 \
 //thickness=0.36 //x=1.23 //y=4.62 //x2=1.23 //y2=4.455
r354 (  4 14 ) resistor r=0.243321 //w=0.131 //l=0.255 //layer=m1 \
 //thickness=0.36 //x=1.23 //y=3.88 //x2=1.23 //y2=4.135
r355 (  3 4 ) resistor r=0.353053 //w=0.131 //l=0.37 //layer=m1 \
 //thickness=0.36 //x=1.23 //y=3.51 //x2=1.23 //y2=3.88
r356 (  2 3 ) resistor r=0.353053 //w=0.131 //l=0.37 //layer=m1 \
 //thickness=0.36 //x=1.23 //y=3.14 //x2=1.23 //y2=3.51
r357 (  1 2 ) resistor r=0.353053 //w=0.131 //l=0.37 //layer=m1 \
 //thickness=0.36 //x=1.23 //y=2.77 //x2=1.23 //y2=3.14
r358 (  1 13 ) resistor r=0.324427 //w=0.131 //l=0.34 //layer=m1 \
 //thickness=0.36 //x=1.23 //y=2.77 //x2=1.23 //y2=2.43
ends PM_XNOR2X1\%A

subckt PM_XNOR2X1\%noxref_2 ( 2 4 5 6 7 8 10 11 12 13 14 15 16 18 23 29 39 41 \
 42 50 62 71 75 76 77 78 79 80 81 85 87 93 94 102 104 106 )
c284 ( 104 0 ) capacitor c=0.00869746f //x=1.415 //y=1.09
c285 ( 102 0 ) capacitor c=0.0661533f //x=8.26 //y=4.88
c286 ( 94 0 ) capacitor c=0.0423887f //x=8.455 //y=1.43
c287 ( 93 0 ) capacitor c=0.0192208f //x=8.455 //y=1.085
c288 ( 87 0 ) capacitor c=0.0125357f //x=8.3 //y=1.585
c289 ( 85 0 ) capacitor c=0.0157803f //x=8.3 //y=0.93
c290 ( 81 0 ) capacitor c=0.095836f //x=7.925 //y=2.095
c291 ( 80 0 ) capacitor c=0.0197088f //x=7.925 //y=1.74
c292 ( 79 0 ) capacitor c=0.0168511f //x=7.925 //y=1.43
c293 ( 78 0 ) capacitor c=0.0174345f //x=7.925 //y=1.085
c294 ( 77 0 ) capacitor c=0.155893f //x=8.37 //y=6.2
c295 ( 76 0 ) capacitor c=0.110547f //x=7.93 //y=6.2
c296 ( 71 0 ) capacitor c=8.03439e-19 //x=8.26 //y=4.88
c297 ( 62 0 ) capacitor c=4.74639e-19 //x=8.26 //y=2.26
c298 ( 50 0 ) capacitor c=0.0261406f //x=1.605 //y=5.56
c299 ( 42 0 ) capacitor c=0.179922f //x=8.085 //y=2.75
c300 ( 41 0 ) capacitor c=0.00407109f //x=8.245 //y=2.75
c301 ( 39 0 ) capacitor c=0.00289295f //x=2.135 //y=2.775
c302 ( 29 0 ) capacitor c=0.0158078f //x=8.26 //y=2.77
c303 ( 23 0 ) capacitor c=0.014269f //x=1.97 //y=2.77
c304 ( 18 0 ) capacitor c=0.0192628f //x=1.6 //y=1.185
c305 ( 16 0 ) capacitor c=0.0032951f //x=8.26 //y=2.595
c306 ( 15 0 ) capacitor c=0.00425871f //x=8.26 //y=2.385
c307 ( 14 0 ) capacitor c=0.0486702f //x=8.13 //y=4.625
c308 ( 13 0 ) capacitor c=0.00890972f //x=8.13 //y=2.915
c309 ( 12 0 ) capacitor c=0.0605081f //x=1.97 //y=5.055
c310 ( 11 0 ) capacitor c=0.0125216f //x=1.97 //y=2.935
c311 ( 10 0 ) capacitor c=0.00942962f //x=1.97 //y=2.615
c312 ( 8 0 ) capacitor c=0.00632795f //x=1.69 //y=5.14
c313 ( 7 0 ) capacitor c=0.00770988f //x=1.885 //y=5.14
c314 ( 6 0 ) capacitor c=0.00882254f //x=1.685 //y=2.02
c315 ( 5 0 ) capacitor c=0.012185f //x=1.885 //y=2.02
c316 ( 4 0 ) capacitor c=0.0119286f //x=1.605 //y=5.42
c317 ( 2 0 ) capacitor c=0.0185185f //x=1.6 //y=1.935
r318 (  102 103 ) resistor r=22.7554 //w=0.233 //l=0.11 //layer=ply \
 //thickness=0.18 //x=8.26 //y=4.88 //x2=8.37 //y2=4.88
r319 (  94 100 ) resistor r=45.1352 //w=0.168 //l=0.173853 //layer=ply \
 //thickness=0.18 //x=8.455 //y=1.43 //x2=8.415 //y2=1.585
r320 (  93 99 ) resistor r=45.1352 //w=0.168 //l=0.173853 //layer=ply \
 //thickness=0.18 //x=8.455 //y=1.085 //x2=8.415 //y2=0.93
r321 (  93 94 ) resistor r=176.904 //w=0.094 //l=0.345 //layer=ply \
 //thickness=0.18 //x=8.455 //y=1.085 //x2=8.455 //y2=1.43
r322 (  90 103 ) resistor r=13.0941 //w=0.233 //l=0.165 //layer=ply \
 //thickness=0.18 //x=8.37 //y=5.045 //x2=8.37 //y2=4.88
r323 (  88 96 ) resistor r=10.701 //w=0.21 //l=0.115 //layer=ply \
 //thickness=0.18 //x=8.08 //y=1.585 //x2=7.965 //y2=1.585
r324 (  87 100 ) resistor r=5.52526 //w=0.168 //l=0.115 //layer=ply \
 //thickness=0.18 //x=8.3 //y=1.585 //x2=8.415 //y2=1.585
r325 (  86 95 ) resistor r=5.52526 //w=0.168 //l=0.115 //layer=ply \
 //thickness=0.18 //x=8.08 //y=0.93 //x2=7.965 //y2=0.93
r326 (  85 99 ) resistor r=5.52526 //w=0.168 //l=0.115 //layer=ply \
 //thickness=0.18 //x=8.3 //y=0.93 //x2=8.415 //y2=0.93
r327 (  85 86 ) resistor r=112.809 //w=0.094 //l=0.22 //layer=ply \
 //thickness=0.18 //x=8.3 //y=0.93 //x2=8.08 //y2=0.93
r328 (  82 102 ) resistor r=68.2661 //w=0.233 //l=0.404166 //layer=ply \
 //thickness=0.18 //x=7.93 //y=5.045 //x2=8.26 //y2=4.88
r329 (  81 98 ) resistor r=67.2792 //w=0.24 //l=0.438891 //layer=ply \
 //thickness=0.18 //x=7.925 //y=2.095 //x2=8.26 //y2=2.335
r330 (  80 96 ) resistor r=39.5823 //w=0.21 //l=0.173853 //layer=ply \
 //thickness=0.18 //x=7.925 //y=1.74 //x2=7.965 //y2=1.585
r331 (  80 81 ) resistor r=182.032 //w=0.094 //l=0.355 //layer=ply \
 //thickness=0.18 //x=7.925 //y=1.74 //x2=7.925 //y2=2.095
r332 (  79 96 ) resistor r=39.5823 //w=0.21 //l=0.173853 //layer=ply \
 //thickness=0.18 //x=7.925 //y=1.43 //x2=7.965 //y2=1.585
r333 (  78 95 ) resistor r=45.1352 //w=0.168 //l=0.173853 //layer=ply \
 //thickness=0.18 //x=7.925 //y=1.085 //x2=7.965 //y2=0.93
r334 (  78 79 ) resistor r=176.904 //w=0.094 //l=0.345 //layer=ply \
 //thickness=0.18 //x=7.925 //y=1.085 //x2=7.925 //y2=1.43
r335 (  77 90 ) resistor r=592.245 //w=0.094 //l=1.155 //layer=ply \
 //thickness=0.18 //x=8.37 //y=6.2 //x2=8.37 //y2=5.045
r336 (  76 82 ) resistor r=592.245 //w=0.094 //l=1.155 //layer=ply \
 //thickness=0.18 //x=7.93 //y=6.2 //x2=7.93 //y2=5.045
r337 (  75 87 ) resistor r=56.4043 //w=0.094 //l=0.11 //layer=ply \
 //thickness=0.18 //x=8.19 //y=1.585 //x2=8.3 //y2=1.585
r338 (  75 88 ) resistor r=56.4043 //w=0.094 //l=0.11 //layer=ply \
 //thickness=0.18 //x=8.19 //y=1.585 //x2=8.08 //y2=1.585
r339 (  71 102 ) resistor r=152 //w=0.17 //l=0.17 //layer=licon //count=1 \
 //x=8.26 //y=4.88 //x2=8.26 //y2=4.88
r340 (  62 98 ) resistor r=152 //w=0.17 //l=0.17 //layer=licon //count=1 \
 //x=8.26 //y=2.26 //x2=8.26 //y2=2.26
r341 (  50 106 ) resistor r=23.615 //w=0.187 //l=0.345 //layer=li \
 //thickness=0.1 //x=1.605 //y=5.56 //x2=1.605 //y2=5.905
r342 (  41 42 ) resistor r=0.10734 //w=0.281 //l=0.16 //layer=m2 \
 //thickness=0.36 //x=8.245 //y=2.75 //x2=8.085 //y2=2.75
r343 (  39 42 ) resistor r=5.67748 //w=0.131 //l=5.95 //layer=m2 \
 //thickness=0.36 //x=2.135 //y=2.77 //x2=8.085 //y2=2.77
r344 (  37 39 ) resistor r=0.10734 //w=0.281 //l=0.16 //layer=m2 \
 //thickness=0.36 //x=1.975 //y=2.775 //x2=2.135 //y2=2.775
r345 (  33 71 ) resistor r=9.3 //w=0.17 //l=0.17 //layer=mcon //count=1 \
 //x=8.26 //y=4.88 //x2=8.26 //y2=4.88
r346 (  31 62 ) resistor r=9.3 //w=0.17 //l=0.17 //layer=mcon //count=1 \
 //x=8.26 //y=2.26 //x2=8.26 //y2=2.26
r347 (  27 41 ) resistor r=4.5 //w=0.15 //l=0.15 //layer=via1 //count=1 \
 //x=8.245 //y=2.75 //x2=8.245 //y2=2.75
r348 (  27 29 ) resistor r=0.00664894 //w=0.376 //l=0.02 //layer=m1 \
 //thickness=0.36 //x=8.2 //y=2.75 //x2=8.2 //y2=2.77
r349 (  25 37 ) resistor r=4.5 //w=0.15 //l=0.15 //layer=via1 //count=1 \
 //x=1.975 //y=2.775 //x2=1.975 //y2=2.775
r350 (  23 25 ) resistor r=0.00167112 //w=0.374 //l=0.005 //layer=m1 \
 //thickness=0.36 //x=2.025 //y=2.77 //x2=2.025 //y2=2.775
r351 (  21 50 ) resistor r=9.3 //w=0.17 //l=0.17 //layer=mcon //count=1 \
 //x=1.605 //y=5.56 //x2=1.605 //y2=5.56
r352 (  18 104 ) resistor r=9.3 //w=0.17 //l=0.17 //layer=mcon //count=1 \
 //x=1.6 //y=1.185 //x2=1.6 //y2=1.185
r353 (  16 27 ) resistor r=0.0894971 //w=0.376 //l=0.182551 //layer=m1 \
 //thickness=0.36 //x=8.26 //y=2.595 //x2=8.2 //y2=2.75
r354 (  15 31 ) resistor r=0.0759051 //w=0.24 //l=0.125996 //layer=m1 \
 //thickness=0.36 //x=8.26 //y=2.385 //x2=8.262 //y2=2.26
r355 (  15 16 ) resistor r=0.200382 //w=0.131 //l=0.21 //layer=m1 \
 //thickness=0.36 //x=8.26 //y=2.385 //x2=8.26 //y2=2.595
r356 (  14 33 ) resistor r=0.125974 //w=0.329 //l=0.298747 //layer=m1 \
 //thickness=0.36 //x=8.13 //y=4.625 //x2=8.225 //y2=4.88
r357 (  13 29 ) resistor r=0.0861726 //w=0.376 //l=0.176564 //layer=m1 \
 //thickness=0.36 //x=8.13 //y=2.915 //x2=8.2 //y2=2.77
r358 (  13 14 ) resistor r=1.63168 //w=0.131 //l=1.71 //layer=m1 \
 //thickness=0.36 //x=8.13 //y=2.915 //x2=8.13 //y2=4.625
r359 (  11 25 ) resistor r=0.0910802 //w=0.374 //l=0.185472 //layer=m1 \
 //thickness=0.36 //x=1.97 //y=2.935 //x2=2.025 //y2=2.775
r360 (  11 12 ) resistor r=2.0229 //w=0.131 //l=2.12 //layer=m1 \
 //thickness=0.36 //x=1.97 //y=2.935 //x2=1.97 //y2=5.055
r361 (  10 23 ) resistor r=0.089409 //w=0.374 //l=0.180416 //layer=m1 \
 //thickness=0.36 //x=1.97 //y=2.615 //x2=2.025 //y2=2.77
r362 (  9 10 ) resistor r=0.486641 //w=0.131 //l=0.51 //layer=m1 \
 //thickness=0.36 //x=1.97 //y=2.105 //x2=1.97 //y2=2.615
r363 (  7 12 ) resistor r=0.0698411 //w=0.17 //l=0.120208 //layer=m1 \
 //thickness=0.36 //x=1.885 //y=5.14 //x2=1.97 //y2=5.055
r364 (  7 8 ) resistor r=0.186069 //w=0.131 //l=0.195 //layer=m1 \
 //thickness=0.36 //x=1.885 //y=5.14 //x2=1.69 //y2=5.14
r365 (  5 9 ) resistor r=0.0698411 //w=0.17 //l=0.120208 //layer=m1 \
 //thickness=0.36 //x=1.885 //y=2.02 //x2=1.97 //y2=2.105
r366 (  5 6 ) resistor r=0.19084 //w=0.131 //l=0.2 //layer=m1 //thickness=0.36 \
 //x=1.885 //y=2.02 //x2=1.685 //y2=2.02
r367 (  4 21 ) resistor r=0.086672 //w=0.218 //l=0.14 //layer=m1 \
 //thickness=0.36 //x=1.605 //y=5.42 //x2=1.605 //y2=5.56
r368 (  3 8 ) resistor r=0.0698411 //w=0.17 //l=0.120208 //layer=m1 \
 //thickness=0.36 //x=1.605 //y=5.225 //x2=1.69 //y2=5.14
r369 (  3 4 ) resistor r=0.186069 //w=0.131 //l=0.195 //layer=m1 \
 //thickness=0.36 //x=1.605 //y=5.225 //x2=1.605 //y2=5.42
r370 (  2 6 ) resistor r=0.0698411 //w=0.17 //l=0.120208 //layer=m1 \
 //thickness=0.36 //x=1.6 //y=1.935 //x2=1.685 //y2=2.02
r371 (  1 18 ) resistor r=0.105739 //w=0.201 //l=0.145 //layer=m1 \
 //thickness=0.36 //x=1.6 //y=1.33 //x2=1.6 //y2=1.185
r372 (  1 2 ) resistor r=0.57729 //w=0.131 //l=0.605 //layer=m1 \
 //thickness=0.36 //x=1.6 //y=1.33 //x2=1.6 //y2=1.935
ends PM_XNOR2X1\%noxref_2

subckt PM_XNOR2X1\%Y ( 1 2 3 4 5 6 7 8 9 10 11 13 14 22 23 24 26 27 32 35 44 \
 45 59 61 62 65 82 98 99 102 103 )
c299 ( 99 0 ) capacitor c=0.00878775f //x=8 //y=1.085
c300 ( 98 0 ) capacitor c=0.00878477f //x=4.67 //y=1.085
c301 ( 82 0 ) capacitor c=0.0232331f //x=8.15 //y=5.555
c302 ( 65 0 ) capacitor c=0.023334f //x=4.82 //y=5.555
c303 ( 62 0 ) capacitor c=0.0358959f //x=8.485 //y=3.925
c304 ( 61 0 ) capacitor c=0.0016551f //x=8.675 //y=3.925
c305 ( 59 0 ) capacitor c=0.00430973f //x=5.465 //y=3.835
c306 ( 45 0 ) capacitor c=0.0107636f //x=8.15 //y=5.385
c307 ( 44 0 ) capacitor c=0.0166974f //x=5.42 //y=3.82
c308 ( 35 0 ) capacitor c=0.0119948f //x=4.82 //y=5.385
c309 ( 32 0 ) capacitor c=0.01496f //x=8.63 //y=4.115
c310 ( 27 0 ) capacitor c=0.00235357f //x=8.275 //y=1.83
c311 ( 26 0 ) capacitor c=0.0103668f //x=8.545 //y=1.83
c312 ( 24 0 ) capacitor c=0.00777561f //x=8.545 //y=5.385
c313 ( 23 0 ) capacitor c=0.00892846f //x=8.19 //y=1.745
c314 ( 22 0 ) capacitor c=0.0102374f //x=8.19 //y=1.3
c315 ( 14 0 ) capacitor c=0.00263815f //x=4.945 //y=1.83
c316 ( 13 0 ) capacitor c=0.0132291f //x=5.335 //y=1.83
c317 ( 11 0 ) capacitor c=0.0116035f //x=5.335 //y=5.385
c318 ( 10 0 ) capacitor c=0.0100535f //x=4.86 //y=1.745
c319 ( 9 0 ) capacitor c=0.010024f //x=4.86 //y=1.295
c320 ( 8 0 ) capacitor c=0.0170468f //x=8.63 //y=3.88
c321 ( 7 0 ) capacitor c=0.0205013f //x=5.305 //y=3.88
c322 ( 6 0 ) capacitor c=0.0228299f //x=8.63 //y=4.99
c323 ( 4 0 ) capacitor c=0.0358494f //x=8.63 //y=2.4
c324 ( 2 0 ) capacitor c=0.0289117f //x=5.425 //y=4.62
c325 ( 1 0 ) capacitor c=0.0424909f //x=5.425 //y=2.4
r326 (  82 103 ) resistor r=23.2727 //w=0.187 //l=0.34 //layer=li \
 //thickness=0.1 //x=8.15 //y=5.555 //x2=8.15 //y2=5.895
r327 (  65 102 ) resistor r=23.2727 //w=0.187 //l=0.34 //layer=li \
 //thickness=0.1 //x=4.82 //y=5.555 //x2=4.82 //y2=5.895
r328 (  61 62 ) resistor r=0.119352 //w=0.341 //l=0.19 //layer=m2 \
 //thickness=0.36 //x=8.675 //y=3.925 //x2=8.485 //y2=3.925
r329 (  59 62 ) resistor r=2.88168 //w=0.131 //l=3.02 //layer=m2 \
 //thickness=0.36 //x=5.465 //y=3.905 //x2=8.485 //y2=3.905
r330 (  57 59 ) resistor r=0.10734 //w=0.281 //l=0.16 //layer=m2 \
 //thickness=0.36 //x=5.305 //y=3.835 //x2=5.465 //y2=3.835
r331 (  53 61 ) resistor r=4.5 //w=0.15 //l=0.15 //layer=via1 //count=1 \
 //x=8.675 //y=3.925 //x2=8.675 //y2=3.925
r332 (  49 99 ) resistor r=9.3 //w=0.17 //l=0.17 //layer=mcon //count=1 \
 //x=8.19 //y=1.18 //x2=8.19 //y2=1.18
r333 (  47 82 ) resistor r=9.3 //w=0.17 //l=0.17 //layer=mcon //count=1 \
 //x=8.15 //y=5.555 //x2=8.15 //y2=5.555
r334 (  45 47 ) resistor r=0.0957207 //w=0.222 //l=0.17 //layer=m1 \
 //thickness=0.36 //x=8.15 //y=5.385 //x2=8.15 //y2=5.555
r335 (  39 98 ) resistor r=9.3 //w=0.17 //l=0.17 //layer=mcon //count=1 \
 //x=4.86 //y=1.18 //x2=4.86 //y2=1.18
r336 (  37 65 ) resistor r=9.3 //w=0.17 //l=0.17 //layer=mcon //count=1 \
 //x=4.82 //y=5.555 //x2=4.82 //y2=5.555
r337 (  35 37 ) resistor r=0.0997653 //w=0.213 //l=0.17 //layer=m1 \
 //thickness=0.36 //x=4.82 //y=5.385 //x2=4.82 //y2=5.555
r338 (  32 53 ) resistor r=0.102702 //w=0.434 //l=0.197358 //layer=m1 \
 //thickness=0.36 //x=8.63 //y=4.115 //x2=8.615 //y2=3.925
r339 (  26 28 ) resistor r=0.0698411 //w=0.17 //l=0.120208 //layer=m1 \
 //thickness=0.36 //x=8.545 //y=1.83 //x2=8.63 //y2=1.915
r340 (  26 27 ) resistor r=0.257634 //w=0.131 //l=0.27 //layer=m1 \
 //thickness=0.36 //x=8.545 //y=1.83 //x2=8.275 //y2=1.83
r341 (  25 45 ) resistor r=0.0235912 //w=0.222 //l=0.12 //layer=m1 \
 //thickness=0.36 //x=8.27 //y=5.385 //x2=8.15 //y2=5.385
r342 (  24 33 ) resistor r=0.0698411 //w=0.17 //l=0.120208 //layer=m1 \
 //thickness=0.36 //x=8.545 //y=5.385 //x2=8.63 //y2=5.3
r343 (  24 25 ) resistor r=0.262405 //w=0.131 //l=0.275 //layer=m1 \
 //thickness=0.36 //x=8.545 //y=5.385 //x2=8.27 //y2=5.385
r344 (  23 27 ) resistor r=0.0698411 //w=0.17 //l=0.120208 //layer=m1 \
 //thickness=0.36 //x=8.19 //y=1.745 //x2=8.275 //y2=1.83
r345 (  22 49 ) resistor r=0.0743319 //w=0.226 //l=0.121491 //layer=m1 \
 //thickness=0.36 //x=8.19 //y=1.3 //x2=8.187 //y2=1.18
r346 (  22 23 ) resistor r=0.424618 //w=0.131 //l=0.445 //layer=m1 \
 //thickness=0.36 //x=8.19 //y=1.3 //x2=8.19 //y2=1.745
r347 (  19 44 ) resistor r=0.0455071 //w=0.32 //l=0.175 //layer=m1 \
 //thickness=0.36 //x=5.42 //y=3.995 //x2=5.42 //y2=3.82
r348 (  16 44 ) resistor r=0.0455071 //w=0.32 //l=0.175 //layer=m1 \
 //thickness=0.36 //x=5.42 //y=3.645 //x2=5.42 //y2=3.82
r349 (  13 15 ) resistor r=0.0698411 //w=0.17 //l=0.120208 //layer=m1 \
 //thickness=0.36 //x=5.335 //y=1.83 //x2=5.42 //y2=1.915
r350 (  13 14 ) resistor r=0.372137 //w=0.131 //l=0.39 //layer=m1 \
 //thickness=0.36 //x=5.335 //y=1.83 //x2=4.945 //y2=1.83
r351 (  12 35 ) resistor r=0.0211096 //w=0.213 //l=0.115 //layer=m1 \
 //thickness=0.36 //x=4.935 //y=5.385 //x2=4.82 //y2=5.385
r352 (  11 20 ) resistor r=0.0698411 //w=0.17 //l=0.120208 //layer=m1 \
 //thickness=0.36 //x=5.335 //y=5.385 //x2=5.42 //y2=5.3
r353 (  11 12 ) resistor r=0.381679 //w=0.131 //l=0.4 //layer=m1 \
 //thickness=0.36 //x=5.335 //y=5.385 //x2=4.935 //y2=5.385
r354 (  10 14 ) resistor r=0.0698411 //w=0.17 //l=0.120208 //layer=m1 \
 //thickness=0.36 //x=4.86 //y=1.745 //x2=4.945 //y2=1.83
r355 (  9 39 ) resistor r=0.0721231 //w=0.22 //l=0.115 //layer=m1 \
 //thickness=0.36 //x=4.86 //y=1.295 //x2=4.86 //y2=1.18
r356 (  9 10 ) resistor r=0.429389 //w=0.131 //l=0.45 //layer=m1 \
 //thickness=0.36 //x=4.86 //y=1.295 //x2=4.86 //y2=1.745
r357 (  8 53 ) resistor r=0.0129608 //w=0.434 //l=0.045 //layer=m1 \
 //thickness=0.36 //x=8.615 //y=3.88 //x2=8.615 //y2=3.925
r358 (  8 29 ) resistor r=0.0897413 //w=0.434 //l=0.152315 //layer=m1 \
 //thickness=0.36 //x=8.615 //y=3.88 //x2=8.63 //y2=3.735
r359 (  7 57 ) resistor r=4.5 //w=0.15 //l=0.15 //layer=via1 //count=1 \
 //x=5.305 //y=3.835 //x2=5.305 //y2=3.835
r360 (  7 44 ) resistor r=0.0449219 //w=0.32 //l=0.115 //layer=m1 \
 //thickness=0.36 //x=5.305 //y=3.82 //x2=5.42 //y2=3.82
r361 (  6 33 ) resistor r=0.295802 //w=0.131 //l=0.31 //layer=m1 \
 //thickness=0.36 //x=8.63 //y=4.99 //x2=8.63 //y2=5.3
r362 (  6 32 ) resistor r=0.834924 //w=0.131 //l=0.875 //layer=m1 \
 //thickness=0.36 //x=8.63 //y=4.99 //x2=8.63 //y2=4.115
r363 (  5 29 ) resistor r=0.920802 //w=0.131 //l=0.965 //layer=m1 \
 //thickness=0.36 //x=8.63 //y=2.77 //x2=8.63 //y2=3.735
r364 (  4 5 ) resistor r=0.353053 //w=0.131 //l=0.37 //layer=m1 \
 //thickness=0.36 //x=8.63 //y=2.4 //x2=8.63 //y2=2.77
r365 (  4 28 ) resistor r=0.462786 //w=0.131 //l=0.485 //layer=m1 \
 //thickness=0.36 //x=8.63 //y=2.4 //x2=8.63 //y2=1.915
r366 (  3 16 ) resistor r=0.128817 //w=0.131 //l=0.135 //layer=m1 \
 //thickness=0.36 //x=5.42 //y=3.51 //x2=5.42 //y2=3.645
r367 (  2 20 ) resistor r=0.648855 //w=0.131 //l=0.68 //layer=m1 \
 //thickness=0.36 //x=5.42 //y=4.62 //x2=5.42 //y2=5.3
r368 (  2 19 ) resistor r=0.596374 //w=0.131 //l=0.625 //layer=m1 \
 //thickness=0.36 //x=5.42 //y=4.62 //x2=5.42 //y2=3.995
r369 (  1 3 ) resistor r=1.05916 //w=0.131 //l=1.11 //layer=m1 \
 //thickness=0.36 //x=5.42 //y=2.4 //x2=5.42 //y2=3.51
r370 (  1 15 ) resistor r=0.462786 //w=0.131 //l=0.485 //layer=m1 \
 //thickness=0.36 //x=5.42 //y=2.4 //x2=5.42 //y2=1.915
ends PM_XNOR2X1\%Y

subckt PM_XNOR2X1\%noxref_4 ( 1 2 4 5 6 7 8 9 10 11 12 14 16 20 24 30 32 36 42 \
 47 48 53 59 60 63 72 86 98 99 100 101 102 103 104 105 107 110 111 126 127 129 )
c299 ( 127 0 ) capacitor c=0.00869746f //x=10.285 //y=1.09
c300 ( 126 0 ) capacitor c=0.0658232f //x=7.15 //y=4.88
c301 ( 111 0 ) capacitor c=0.0423886f //x=5.125 //y=1.43
c302 ( 110 0 ) capacitor c=0.0191211f //x=5.125 //y=1.085
c303 ( 107 0 ) capacitor c=0.0126237f //x=4.97 //y=1.585
c304 ( 105 0 ) capacitor c=0.0157803f //x=4.97 //y=0.93
c305 ( 104 0 ) capacitor c=0.097402f //x=4.595 //y=2.095
c306 ( 103 0 ) capacitor c=0.0197088f //x=4.595 //y=1.74
c307 ( 102 0 ) capacitor c=0.0168511f //x=4.595 //y=1.43
c308 ( 101 0 ) capacitor c=0.0173426f //x=4.595 //y=1.085
c309 ( 100 0 ) capacitor c=0.110998f //x=7.49 //y=6.2
c310 ( 99 0 ) capacitor c=0.155253f //x=7.05 //y=6.2
c311 ( 86 0 ) capacitor c=0.0261678f //x=10.475 //y=5.56
c312 ( 72 0 ) capacitor c=0.0141498f //x=7.15 //y=4.62
c313 ( 63 0 ) capacitor c=5.96869e-19 //x=4.93 //y=2.26
c314 ( 60 0 ) capacitor c=0.0827697f //x=9.96 //y=3.125
c315 ( 59 0 ) capacitor c=0.00173132f //x=10.12 //y=3.125
c316 ( 53 0 ) capacitor c=0.0031317f //x=10.11 //y=4.677
c317 ( 48 0 ) capacitor c=0.00102402f //x=7.135 //y=4.677
c318 ( 47 0 ) capacitor c=2.37898e-19 //x=5.075 //y=3.185
c319 ( 42 0 ) capacitor c=0.0678476f //x=9.95 //y=4.677
c320 ( 36 0 ) capacitor c=0.019133f //x=10.48 //y=1.185
c321 ( 32 0 ) capacitor c=0.0135181f //x=10.11 //y=4.62
c322 ( 30 0 ) capacitor c=0.0156817f //x=10.11 //y=3.14
c323 ( 24 0 ) capacitor c=0.0156038f //x=7.15 //y=4.62
c324 ( 20 0 ) capacitor c=0.0273419f //x=4.93 //y=3.14
c325 ( 16 0 ) capacitor c=0.017004f //x=10.48 //y=1.935
c326 ( 14 0 ) capacitor c=0.0117612f //x=10.475 //y=5.42
c327 ( 12 0 ) capacitor c=0.00253297f //x=10.195 //y=5.14
c328 ( 11 0 ) capacitor c=0.0096638f //x=10.39 //y=5.14
c329 ( 10 0 ) capacitor c=0.0044385f //x=10.195 //y=2.02
c330 ( 9 0 ) capacitor c=0.0152095f //x=10.395 //y=2.02
c331 ( 8 0 ) capacitor c=0.00197769f //x=10.11 //y=5.055
c332 ( 7 0 ) capacitor c=0.0126627f //x=10.11 //y=4.915
c333 ( 6 0 ) capacitor c=0.0258899f //x=10.11 //y=4.505
c334 ( 5 0 ) capacitor c=0.0128651f //x=10.11 //y=3.29
c335 ( 4 0 ) capacitor c=0.0163669f //x=10.11 //y=2.965
c336 ( 2 0 ) capacitor c=0.0124279f //x=4.93 //y=3.025
c337 ( 1 0 ) capacitor c=0.00444577f //x=4.93 //y=2.385
r338 (  124 126 ) resistor r=20.6867 //w=0.233 //l=0.1 //layer=ply \
 //thickness=0.18 //x=7.05 //y=4.88 //x2=7.15 //y2=4.88
r339 (  115 126 ) resistor r=70.3348 //w=0.233 //l=0.414367 //layer=ply \
 //thickness=0.18 //x=7.49 //y=5.045 //x2=7.15 //y2=4.88
r340 (  112 124 ) resistor r=13.0941 //w=0.233 //l=0.165 //layer=ply \
 //thickness=0.18 //x=7.05 //y=5.045 //x2=7.05 //y2=4.88
r341 (  111 123 ) resistor r=45.1352 //w=0.168 //l=0.173853 //layer=ply \
 //thickness=0.18 //x=5.125 //y=1.43 //x2=5.085 //y2=1.585
r342 (  110 122 ) resistor r=45.1352 //w=0.168 //l=0.173853 //layer=ply \
 //thickness=0.18 //x=5.125 //y=1.085 //x2=5.085 //y2=0.93
r343 (  110 111 ) resistor r=176.904 //w=0.094 //l=0.345 //layer=ply \
 //thickness=0.18 //x=5.125 //y=1.085 //x2=5.125 //y2=1.43
r344 (  108 119 ) resistor r=10.701 //w=0.21 //l=0.115 //layer=ply \
 //thickness=0.18 //x=4.75 //y=1.585 //x2=4.635 //y2=1.585
r345 (  107 123 ) resistor r=5.52526 //w=0.168 //l=0.115 //layer=ply \
 //thickness=0.18 //x=4.97 //y=1.585 //x2=5.085 //y2=1.585
r346 (  106 118 ) resistor r=5.52526 //w=0.168 //l=0.115 //layer=ply \
 //thickness=0.18 //x=4.75 //y=0.93 //x2=4.635 //y2=0.93
r347 (  105 122 ) resistor r=5.52526 //w=0.168 //l=0.115 //layer=ply \
 //thickness=0.18 //x=4.97 //y=0.93 //x2=5.085 //y2=0.93
r348 (  105 106 ) resistor r=112.809 //w=0.094 //l=0.22 //layer=ply \
 //thickness=0.18 //x=4.97 //y=0.93 //x2=4.75 //y2=0.93
r349 (  104 121 ) resistor r=67.2792 //w=0.24 //l=0.438891 //layer=ply \
 //thickness=0.18 //x=4.595 //y=2.095 //x2=4.93 //y2=2.335
r350 (  103 119 ) resistor r=39.5823 //w=0.21 //l=0.173853 //layer=ply \
 //thickness=0.18 //x=4.595 //y=1.74 //x2=4.635 //y2=1.585
r351 (  103 104 ) resistor r=182.032 //w=0.094 //l=0.355 //layer=ply \
 //thickness=0.18 //x=4.595 //y=1.74 //x2=4.595 //y2=2.095
r352 (  102 119 ) resistor r=39.5823 //w=0.21 //l=0.173853 //layer=ply \
 //thickness=0.18 //x=4.595 //y=1.43 //x2=4.635 //y2=1.585
r353 (  101 118 ) resistor r=45.1352 //w=0.168 //l=0.173853 //layer=ply \
 //thickness=0.18 //x=4.595 //y=1.085 //x2=4.635 //y2=0.93
r354 (  101 102 ) resistor r=176.904 //w=0.094 //l=0.345 //layer=ply \
 //thickness=0.18 //x=4.595 //y=1.085 //x2=4.595 //y2=1.43
r355 (  100 115 ) resistor r=592.245 //w=0.094 //l=1.155 //layer=ply \
 //thickness=0.18 //x=7.49 //y=6.2 //x2=7.49 //y2=5.045
r356 (  99 112 ) resistor r=592.245 //w=0.094 //l=1.155 //layer=ply \
 //thickness=0.18 //x=7.05 //y=6.2 //x2=7.05 //y2=5.045
r357 (  98 107 ) resistor r=56.4043 //w=0.094 //l=0.11 //layer=ply \
 //thickness=0.18 //x=4.86 //y=1.585 //x2=4.97 //y2=1.585
r358 (  98 108 ) resistor r=56.4043 //w=0.094 //l=0.11 //layer=ply \
 //thickness=0.18 //x=4.86 //y=1.585 //x2=4.75 //y2=1.585
r359 (  86 129 ) resistor r=23.615 //w=0.187 //l=0.345 //layer=li \
 //thickness=0.1 //x=10.475 //y=5.56 //x2=10.475 //y2=5.905
r360 (  75 126 ) resistor r=152 //w=0.17 //l=0.17 //layer=licon //count=1 \
 //x=7.15 //y=4.88 //x2=7.15 //y2=4.88
r361 (  72 75 ) resistor r=17.7968 //w=0.187 //l=0.26 //layer=li \
 //thickness=0.1 //x=7.15 //y=4.62 //x2=7.15 //y2=4.88
r362 (  63 121 ) resistor r=152 //w=0.17 //l=0.17 //layer=licon //count=1 \
 //x=4.93 //y=2.26 //x2=4.93 //y2=2.26
r363 (  59 60 ) resistor r=0.10734 //w=0.281 //l=0.16 //layer=m2 \
 //thickness=0.36 //x=10.12 //y=3.125 //x2=9.96 //y2=3.125
r364 (  53 56 ) resistor r=0.0346975 //w=0.281 //l=0.078 //layer=m2 \
 //thickness=0.36 //x=10.11 //y=4.677 //x2=10.11 //y2=4.755
r365 (  48 51 ) resistor r=0.0346975 //w=0.281 //l=0.078 //layer=m2 \
 //thickness=0.36 //x=7.135 //y=4.677 //x2=7.135 //y2=4.755
r366 (  47 60 ) resistor r=4.66126 //w=0.131 //l=4.885 //layer=m2 \
 //thickness=0.36 //x=5.075 //y=3.135 //x2=9.96 //y2=3.135
r367 (  45 47 ) resistor r=0.10734 //w=0.281 //l=0.16 //layer=m2 \
 //thickness=0.36 //x=4.915 //y=3.185 //x2=5.075 //y2=3.185
r368 (  43 48 ) resistor r=0.047514 //w=0.32 //l=0.16 //layer=m2 \
 //thickness=0.36 //x=7.295 //y=4.677 //x2=7.135 //y2=4.677
r369 (  42 53 ) resistor r=0.047514 //w=0.32 //l=0.16 //layer=m2 \
 //thickness=0.36 //x=9.95 //y=4.677 //x2=10.11 //y2=4.677
r370 (  42 43 ) resistor r=2.63393 //w=0.126 //l=2.655 //layer=m2 \
 //thickness=0.36 //x=9.95 //y=4.677 //x2=7.295 //y2=4.677
r371 (  39 86 ) resistor r=9.3 //w=0.17 //l=0.17 //layer=mcon //count=1 \
 //x=10.475 //y=5.56 //x2=10.475 //y2=5.56
r372 (  36 127 ) resistor r=9.3 //w=0.17 //l=0.17 //layer=mcon //count=1 \
 //x=10.48 //y=1.185 //x2=10.48 //y2=1.185
r373 (  34 56 ) resistor r=4.5 //w=0.15 //l=0.15 //layer=via1 //count=1 \
 //x=10.11 //y=4.755 //x2=10.11 //y2=4.755
r374 (  32 34 ) resistor r=0.0475352 //w=0.355 //l=0.135 //layer=m1 \
 //thickness=0.36 //x=10.057 //y=4.62 //x2=10.057 //y2=4.755
r375 (  28 59 ) resistor r=4.5 //w=0.15 //l=0.15 //layer=via1 //count=1 \
 //x=10.12 //y=3.125 //x2=10.12 //y2=3.125
r376 (  28 30 ) resistor r=0.00492126 //w=0.381 //l=0.015 //layer=m1 \
 //thickness=0.36 //x=10.062 //y=3.125 //x2=10.062 //y2=3.14
r377 (  26 51 ) resistor r=4.5 //w=0.15 //l=0.15 //layer=via1 //count=1 \
 //x=7.135 //y=4.755 //x2=7.135 //y2=4.755
r378 (  24 72 ) resistor r=9.3 //w=0.17 //l=0.17 //layer=mcon //count=1 \
 //x=7.15 //y=4.62 //x2=7.15 //y2=4.62
r379 (  24 26 ) resistor r=0.0478045 //w=0.353 //l=0.135 //layer=m1 \
 //thickness=0.36 //x=7.195 //y=4.62 //x2=7.195 //y2=4.755
r380 (  22 45 ) resistor r=4.5 //w=0.15 //l=0.15 //layer=via1 //count=1 \
 //x=4.915 //y=3.185 //x2=4.915 //y2=3.185
r381 (  20 22 ) resistor r=0.0146484 //w=0.384 //l=0.045 //layer=m1 \
 //thickness=0.36 //x=4.975 //y=3.14 //x2=4.975 //y2=3.185
r382 (  18 63 ) resistor r=9.3 //w=0.17 //l=0.17 //layer=mcon //count=1 \
 //x=4.93 //y=2.26 //x2=4.93 //y2=2.26
r383 (  15 36 ) resistor r=0.105739 //w=0.201 //l=0.145 //layer=m1 \
 //thickness=0.36 //x=10.48 //y=1.33 //x2=10.48 //y2=1.185
r384 (  15 16 ) resistor r=0.57729 //w=0.131 //l=0.605 //layer=m1 \
 //thickness=0.36 //x=10.48 //y=1.33 //x2=10.48 //y2=1.935
r385 (  14 39 ) resistor r=0.086672 //w=0.218 //l=0.14 //layer=m1 \
 //thickness=0.36 //x=10.475 //y=5.42 //x2=10.475 //y2=5.56
r386 (  13 14 ) resistor r=0.186069 //w=0.131 //l=0.195 //layer=m1 \
 //thickness=0.36 //x=10.475 //y=5.225 //x2=10.475 //y2=5.42
r387 (  11 13 ) resistor r=0.0698411 //w=0.17 //l=0.120208 //layer=m1 \
 //thickness=0.36 //x=10.39 //y=5.14 //x2=10.475 //y2=5.225
r388 (  11 12 ) resistor r=0.186069 //w=0.131 //l=0.195 //layer=m1 \
 //thickness=0.36 //x=10.39 //y=5.14 //x2=10.195 //y2=5.14
r389 (  9 16 ) resistor r=0.0698411 //w=0.17 //l=0.120208 //layer=m1 \
 //thickness=0.36 //x=10.395 //y=2.02 //x2=10.48 //y2=1.935
r390 (  9 10 ) resistor r=0.19084 //w=0.131 //l=0.2 //layer=m1 \
 //thickness=0.36 //x=10.395 //y=2.02 //x2=10.195 //y2=2.02
r391 (  8 12 ) resistor r=0.0698411 //w=0.17 //l=0.120208 //layer=m1 \
 //thickness=0.36 //x=10.11 //y=5.055 //x2=10.195 //y2=5.14
r392 (  7 34 ) resistor r=0.0904246 //w=0.355 //l=0.184608 //layer=m1 \
 //thickness=0.36 //x=10.11 //y=4.915 //x2=10.057 //y2=4.755
r393 (  7 8 ) resistor r=0.133588 //w=0.131 //l=0.14 //layer=m1 \
 //thickness=0.36 //x=10.11 //y=4.915 //x2=10.11 //y2=5.055
r394 (  6 32 ) resistor r=0.0745796 //w=0.355 //l=0.138996 //layer=m1 \
 //thickness=0.36 //x=10.11 //y=4.505 //x2=10.057 //y2=4.62
r395 (  5 30 ) resistor r=0.088084 //w=0.381 //l=0.172337 //layer=m1 \
 //thickness=0.36 //x=10.11 //y=3.29 //x2=10.062 //y2=3.14
r396 (  5 6 ) resistor r=1.15935 //w=0.131 //l=1.215 //layer=m1 \
 //thickness=0.36 //x=10.11 //y=3.29 //x2=10.11 //y2=4.505
r397 (  4 28 ) resistor r=0.0913649 //w=0.381 //l=0.182428 //layer=m1 \
 //thickness=0.36 //x=10.11 //y=2.965 //x2=10.062 //y2=3.125
r398 (  3 10 ) resistor r=0.0698411 //w=0.17 //l=0.120208 //layer=m1 \
 //thickness=0.36 //x=10.11 //y=2.105 //x2=10.195 //y2=2.02
r399 (  3 4 ) resistor r=0.820611 //w=0.131 //l=0.86 //layer=m1 \
 //thickness=0.36 //x=10.11 //y=2.105 //x2=10.11 //y2=2.965
r400 (  2 20 ) resistor r=0.0768447 //w=0.384 //l=0.135647 //layer=m1 \
 //thickness=0.36 //x=4.93 //y=3.025 //x2=4.975 //y2=3.14
r401 (  1 18 ) resistor r=0.0774347 //w=0.223 //l=0.125 //layer=m1 \
 //thickness=0.36 //x=4.93 //y=2.385 //x2=4.93 //y2=2.26
r402 (  1 2 ) resistor r=0.610687 //w=0.131 //l=0.64 //layer=m1 \
 //thickness=0.36 //x=4.93 //y=2.385 //x2=4.93 //y2=3.025
ends PM_XNOR2X1\%noxref_4

subckt PM_XNOR2X1\%B ( 1 2 3 4 5 6 7 8 9 10 12 14 24 25 44 52 56 60 66 71 76 \
 77 80 81 88 93 102 115 119 120 121 122 123 124 131 132 133 134 135 137 140 \
 141 142 143 147 148 149 151 154 157 158 159 160 162 174 )
c304 ( 174 0 ) capacitor c=0.0548337f //x=10.74 //y=2.265
c305 ( 162 0 ) capacitor c=0.0647438f //x=4.93 //y=4.88
c306 ( 160 0 ) capacitor c=0.0301471f //x=10.74 //y=2.1
c307 ( 159 0 ) capacitor c=0.0255528f //x=10.74 //y=1.745
c308 ( 158 0 ) capacitor c=0.0234346f //x=10.74 //y=1.435
c309 ( 157 0 ) capacitor c=0.0201416f //x=10.74 //y=1.09
c310 ( 154 0 ) capacitor c=0.0495014f //x=10.695 //y=5.045
c311 ( 151 0 ) capacitor c=0.0161986f //x=10.585 //y=1.59
c312 ( 149 0 ) capacitor c=0.0157807f //x=10.585 //y=0.935
c313 ( 148 0 ) capacitor c=0.014758f //x=10.33 //y=4.97
c314 ( 147 0 ) capacitor c=0.023722f //x=10.62 //y=4.97
c315 ( 143 0 ) capacitor c=0.0439428f //x=10.21 //y=1.435
c316 ( 142 0 ) capacitor c=0.020097f //x=10.21 //y=1.09
c317 ( 141 0 ) capacitor c=0.0318948f //x=7.485 //y=1.39
c318 ( 140 0 ) capacitor c=0.0186809f //x=7.485 //y=1.045
c319 ( 137 0 ) capacitor c=0.0141797f //x=7.33 //y=1.545
c320 ( 135 0 ) capacitor c=0.0158553f //x=7.33 //y=0.89
c321 ( 134 0 ) capacitor c=0.0868912f //x=6.955 //y=2.095
c322 ( 133 0 ) capacitor c=0.0229235f //x=6.955 //y=1.7
c323 ( 132 0 ) capacitor c=0.0234352f //x=6.955 //y=1.39
c324 ( 131 0 ) capacitor c=0.0198759f //x=6.955 //y=1.045
c325 ( 124 0 ) capacitor c=0.154411f //x=10.695 //y=6.2
c326 ( 123 0 ) capacitor c=0.153944f //x=10.255 //y=6.2
c327 ( 122 0 ) capacitor c=0.155893f //x=5.04 //y=6.2
c328 ( 121 0 ) capacitor c=0.110553f //x=4.6 //y=6.2
c329 ( 115 0 ) capacitor c=6.76693e-19 //x=10.85 //y=4.88
c330 ( 102 0 ) capacitor c=9.11699e-19 //x=10.85 //y=2.265
c331 ( 93 0 ) capacitor c=0.00126053f //x=7.15 //y=2.26
c332 ( 88 0 ) capacitor c=5.34577e-19 //x=4.93 //y=4.88
c333 ( 81 0 ) capacitor c=0.0370531f //x=10.735 //y=3.585
c334 ( 80 0 ) capacitor c=0.0142494f //x=10.925 //y=3.585
c335 ( 77 0 ) capacitor c=0.0190311f //x=10.71 //y=4.295
c336 ( 76 0 ) capacitor c=0.00631628f //x=10.87 //y=4.295
c337 ( 71 0 ) capacitor c=0.00344324f //x=9.092 //y=4.25
c338 ( 66 0 ) capacitor c=0.00136452f //x=7.315 //y=3.52
c339 ( 60 0 ) capacitor c=0.00331146f //x=4.91 //y=4.25
c340 ( 56 0 ) capacitor c=0.00478613f //x=9.005 //y=4.34
c341 ( 52 0 ) capacitor c=0.0619454f //x=8.205 //y=4.25
c342 ( 44 0 ) capacitor c=0.0136371f //x=10.85 //y=2.265
c343 ( 25 0 ) capacitor c=0.00932005f //x=10.85 //y=4.76
c344 ( 24 0 ) capacitor c=0.01235f //x=10.85 //y=4.455
c345 ( 14 0 ) capacitor c=0.00713372f //x=7.15 //y=2.385
c346 ( 12 0 ) capacitor c=0.00377807f //x=4.93 //y=4.76
c347 ( 10 0 ) capacitor c=0.0134312f //x=10.85 //y=4.25
c348 ( 9 0 ) capacitor c=0.0339188f //x=10.85 //y=3.51
c349 ( 8 0 ) capacitor c=0.0284167f //x=7.15 //y=3.51
c350 ( 7 0 ) capacitor c=0.0279093f //x=4.93 //y=4.25
c351 ( 6 0 ) capacitor c=0.00650403f //x=10.85 //y=4.62
c352 ( 5 0 ) capacitor c=0.0160546f //x=10.85 //y=3.88
c353 ( 3 0 ) capacitor c=0.0360642f //x=10.85 //y=2.77
c354 ( 2 0 ) capacitor c=0.0251755f //x=7.15 //y=2.4
c355 ( 1 0 ) capacitor c=0.00482351f //x=4.93 //y=4.62
r356 (  174 176 ) resistor r=17.5563 //w=0.302 //l=0.11 //layer=ply \
 //thickness=0.18 //x=10.74 //y=2.265 //x2=10.85 //y2=2.265
r357 (  162 163 ) resistor r=22.7554 //w=0.233 //l=0.11 //layer=ply \
 //thickness=0.18 //x=4.93 //y=4.88 //x2=5.04 //y2=4.88
r358 (  160 174 ) resistor r=19.1248 //w=0.302 //l=0.165 //layer=ply \
 //thickness=0.18 //x=10.74 //y=2.1 //x2=10.74 //y2=2.265
r359 (  159 173 ) resistor r=39.5823 //w=0.21 //l=0.173853 //layer=ply \
 //thickness=0.18 //x=10.74 //y=1.745 //x2=10.7 //y2=1.59
r360 (  159 160 ) resistor r=182.032 //w=0.094 //l=0.355 //layer=ply \
 //thickness=0.18 //x=10.74 //y=1.745 //x2=10.74 //y2=2.1
r361 (  158 173 ) resistor r=39.5823 //w=0.21 //l=0.173853 //layer=ply \
 //thickness=0.18 //x=10.74 //y=1.435 //x2=10.7 //y2=1.59
r362 (  157 172 ) resistor r=45.1352 //w=0.168 //l=0.173853 //layer=ply \
 //thickness=0.18 //x=10.74 //y=1.09 //x2=10.7 //y2=0.935
r363 (  157 158 ) resistor r=176.904 //w=0.094 //l=0.345 //layer=ply \
 //thickness=0.18 //x=10.74 //y=1.09 //x2=10.74 //y2=1.435
r364 (  154 178 ) resistor r=26.3063 //w=0.284 //l=0.229783 //layer=ply \
 //thickness=0.18 //x=10.695 //y=5.045 //x2=10.85 //y2=4.88
r365 (  152 171 ) resistor r=5.52526 //w=0.168 //l=0.115 //layer=ply \
 //thickness=0.18 //x=10.365 //y=1.59 //x2=10.25 //y2=1.59
r366 (  151 173 ) resistor r=10.701 //w=0.21 //l=0.115 //layer=ply \
 //thickness=0.18 //x=10.585 //y=1.59 //x2=10.7 //y2=1.59
r367 (  150 170 ) resistor r=5.52526 //w=0.168 //l=0.115 //layer=ply \
 //thickness=0.18 //x=10.365 //y=0.935 //x2=10.25 //y2=0.935
r368 (  149 172 ) resistor r=5.52526 //w=0.168 //l=0.115 //layer=ply \
 //thickness=0.18 //x=10.585 //y=0.935 //x2=10.7 //y2=0.935
r369 (  149 150 ) resistor r=112.809 //w=0.094 //l=0.22 //layer=ply \
 //thickness=0.18 //x=10.585 //y=0.935 //x2=10.365 //y2=0.935
r370 (  147 154 ) resistor r=23.403 //w=0.284 //l=0.106066 //layer=ply \
 //thickness=0.18 //x=10.62 //y=4.97 //x2=10.695 //y2=5.045
r371 (  147 148 ) resistor r=148.702 //w=0.094 //l=0.29 //layer=ply \
 //thickness=0.18 //x=10.62 //y=4.97 //x2=10.33 //y2=4.97
r372 (  144 148 ) resistor r=26.9307 //w=0.15 //l=0.106066 //layer=ply \
 //thickness=0.18 //x=10.255 //y=5.045 //x2=10.33 //y2=4.97
r373 (  143 171 ) resistor r=45.1352 //w=0.168 //l=0.173853 //layer=ply \
 //thickness=0.18 //x=10.21 //y=1.435 //x2=10.25 //y2=1.59
r374 (  142 170 ) resistor r=45.1352 //w=0.168 //l=0.173853 //layer=ply \
 //thickness=0.18 //x=10.21 //y=1.09 //x2=10.25 //y2=0.935
r375 (  142 143 ) resistor r=176.904 //w=0.094 //l=0.345 //layer=ply \
 //thickness=0.18 //x=10.21 //y=1.09 //x2=10.21 //y2=1.435
r376 (  141 169 ) resistor r=45.1352 //w=0.168 //l=0.173853 //layer=ply \
 //thickness=0.18 //x=7.485 //y=1.39 //x2=7.445 //y2=1.545
r377 (  140 168 ) resistor r=45.1352 //w=0.168 //l=0.173853 //layer=ply \
 //thickness=0.18 //x=7.485 //y=1.045 //x2=7.445 //y2=0.89
r378 (  140 141 ) resistor r=176.904 //w=0.094 //l=0.345 //layer=ply \
 //thickness=0.18 //x=7.485 //y=1.045 //x2=7.485 //y2=1.39
r379 (  138 167 ) resistor r=10.701 //w=0.21 //l=0.115 //layer=ply \
 //thickness=0.18 //x=7.11 //y=1.545 //x2=6.995 //y2=1.545
r380 (  137 169 ) resistor r=5.52526 //w=0.168 //l=0.115 //layer=ply \
 //thickness=0.18 //x=7.33 //y=1.545 //x2=7.445 //y2=1.545
r381 (  136 166 ) resistor r=5.52526 //w=0.168 //l=0.115 //layer=ply \
 //thickness=0.18 //x=7.11 //y=0.89 //x2=6.995 //y2=0.89
r382 (  135 168 ) resistor r=5.52526 //w=0.168 //l=0.115 //layer=ply \
 //thickness=0.18 //x=7.33 //y=0.89 //x2=7.445 //y2=0.89
r383 (  135 136 ) resistor r=112.809 //w=0.094 //l=0.22 //layer=ply \
 //thickness=0.18 //x=7.33 //y=0.89 //x2=7.11 //y2=0.89
r384 (  134 165 ) resistor r=34.8111 //w=0.27 //l=0.264953 //layer=ply \
 //thickness=0.18 //x=6.955 //y=2.095 //x2=7.15 //y2=2.26
r385 (  133 167 ) resistor r=39.5823 //w=0.21 //l=0.173853 //layer=ply \
 //thickness=0.18 //x=6.955 //y=1.7 //x2=6.995 //y2=1.545
r386 (  133 134 ) resistor r=202.543 //w=0.094 //l=0.395 //layer=ply \
 //thickness=0.18 //x=6.955 //y=1.7 //x2=6.955 //y2=2.095
r387 (  132 167 ) resistor r=39.5823 //w=0.21 //l=0.173853 //layer=ply \
 //thickness=0.18 //x=6.955 //y=1.39 //x2=6.995 //y2=1.545
r388 (  131 166 ) resistor r=45.1352 //w=0.168 //l=0.173853 //layer=ply \
 //thickness=0.18 //x=6.955 //y=1.045 //x2=6.995 //y2=0.89
r389 (  131 132 ) resistor r=176.904 //w=0.094 //l=0.345 //layer=ply \
 //thickness=0.18 //x=6.955 //y=1.045 //x2=6.955 //y2=1.39
r390 (  128 163 ) resistor r=13.0941 //w=0.233 //l=0.165 //layer=ply \
 //thickness=0.18 //x=5.04 //y=5.045 //x2=5.04 //y2=4.88
r391 (  125 162 ) resistor r=68.2661 //w=0.233 //l=0.404166 //layer=ply \
 //thickness=0.18 //x=4.6 //y=5.045 //x2=4.93 //y2=4.88
r392 (  124 154 ) resistor r=592.245 //w=0.094 //l=1.155 //layer=ply \
 //thickness=0.18 //x=10.695 //y=6.2 //x2=10.695 //y2=5.045
r393 (  123 144 ) resistor r=592.245 //w=0.094 //l=1.155 //layer=ply \
 //thickness=0.18 //x=10.255 //y=6.2 //x2=10.255 //y2=5.045
r394 (  122 128 ) resistor r=592.245 //w=0.094 //l=1.155 //layer=ply \
 //thickness=0.18 //x=5.04 //y=6.2 //x2=5.04 //y2=5.045
r395 (  121 125 ) resistor r=592.245 //w=0.094 //l=1.155 //layer=ply \
 //thickness=0.18 //x=4.6 //y=6.2 //x2=4.6 //y2=5.045
r396 (  120 151 ) resistor r=56.4043 //w=0.094 //l=0.11 //layer=ply \
 //thickness=0.18 //x=10.475 //y=1.59 //x2=10.585 //y2=1.59
r397 (  120 152 ) resistor r=56.4043 //w=0.094 //l=0.11 //layer=ply \
 //thickness=0.18 //x=10.475 //y=1.59 //x2=10.365 //y2=1.59
r398 (  119 137 ) resistor r=56.4043 //w=0.094 //l=0.11 //layer=ply \
 //thickness=0.18 //x=7.22 //y=1.545 //x2=7.33 //y2=1.545
r399 (  119 138 ) resistor r=56.4043 //w=0.094 //l=0.11 //layer=ply \
 //thickness=0.18 //x=7.22 //y=1.545 //x2=7.11 //y2=1.545
r400 (  115 178 ) resistor r=152 //w=0.17 //l=0.17 //layer=licon //count=1 \
 //x=10.85 //y=4.88 //x2=10.85 //y2=4.88
r401 (  102 176 ) resistor r=152 //w=0.17 //l=0.17 //layer=licon //count=1 \
 //x=10.85 //y=2.265 //x2=10.85 //y2=2.265
r402 (  93 165 ) resistor r=152 //w=0.17 //l=0.17 //layer=licon //count=1 \
 //x=7.15 //y=2.26 //x2=7.15 //y2=2.26
r403 (  88 162 ) resistor r=152 //w=0.17 //l=0.17 //layer=licon //count=1 \
 //x=4.93 //y=4.88 //x2=4.93 //y2=4.88
r404 (  80 81 ) resistor r=0.119352 //w=0.341 //l=0.19 //layer=m2 \
 //thickness=0.36 //x=10.925 //y=3.585 //x2=10.735 //y2=3.585
r405 (  76 77 ) resistor r=0.10734 //w=0.281 //l=0.16 //layer=m2 \
 //thickness=0.36 //x=10.87 //y=4.295 //x2=10.71 //y2=4.295
r406 (  71 73 ) resistor r=0.0827206 //w=0.136 //l=0.09 //layer=m2 \
 //thickness=0.36 //x=9.092 //y=4.25 //x2=9.092 //y2=4.34
r407 (  66 81 ) resistor r=3.26336 //w=0.131 //l=3.42 //layer=m2 \
 //thickness=0.36 //x=7.315 //y=3.51 //x2=10.735 //y2=3.51
r408 (  64 66 ) resistor r=0.10734 //w=0.281 //l=0.16 //layer=m2 \
 //thickness=0.36 //x=7.155 //y=3.52 //x2=7.315 //y2=3.52
r409 (  60 62 ) resistor r=0.0316456 //w=0.316 //l=0.08 //layer=m2 \
 //thickness=0.36 //x=4.91 //y=4.25 //x2=4.91 //y2=4.33
r410 (  59 71 ) resistor r=0.0091459 //w=0.175 //l=0.088 //layer=m2 \
 //thickness=0.36 //x=9.18 //y=4.25 //x2=9.092 //y2=4.25
r411 (  59 77 ) resistor r=1.45992 //w=0.131 //l=1.53 //layer=m2 \
 //thickness=0.36 //x=9.18 //y=4.25 //x2=10.71 //y2=4.25
r412 (  56 73 ) resistor r=0.0091459 //w=0.175 //l=0.087 //layer=m2 \
 //thickness=0.36 //x=9.005 //y=4.34 //x2=9.092 //y2=4.34
r413 (  56 57 ) resistor r=0.629771 //w=0.131 //l=0.66 //layer=m2 \
 //thickness=0.36 //x=9.005 //y=4.34 //x2=8.345 //y2=4.34
r414 (  53 60 ) resistor r=0.0447454 //w=0.316 //l=0.16 //layer=m2 \
 //thickness=0.36 //x=5.07 //y=4.25 //x2=4.91 //y2=4.25
r415 (  52 57 ) resistor r=0.111386 //w=0.101 //l=0.09 //layer=m2 \
 //thickness=0.36 //x=8.275 //y=4.25 //x2=8.275 //y2=4.34
r416 (  52 53 ) resistor r=2.99141 //w=0.131 //l=3.135 //layer=m2 \
 //thickness=0.36 //x=8.205 //y=4.25 //x2=5.07 //y2=4.25
r417 (  51 115 ) resistor r=9.3 //w=0.17 //l=0.17 //layer=mcon //count=1 \
 //x=10.85 //y=4.88 //x2=10.85 //y2=4.88
r418 (  49 80 ) resistor r=4.5 //w=0.15 //l=0.15 //layer=via1 //count=1 \
 //x=10.925 //y=3.585 //x2=10.925 //y2=3.585
r419 (  44 102 ) resistor r=9.3 //w=0.17 //l=0.17 //layer=mcon //count=1 \
 //x=10.85 //y=2.265 //x2=10.85 //y2=2.265
r420 (  42 76 ) resistor r=4.5 //w=0.15 //l=0.15 //layer=via1 //count=1 \
 //x=10.87 //y=4.295 //x2=10.87 //y2=4.295
r421 (  38 64 ) resistor r=4.5 //w=0.15 //l=0.15 //layer=via1 //count=1 \
 //x=7.155 //y=3.52 //x2=7.155 //y2=3.52
r422 (  34 93 ) resistor r=9.3 //w=0.17 //l=0.17 //layer=mcon //count=1 \
 //x=7.15 //y=2.26 //x2=7.15 //y2=2.26
r423 (  30 62 ) resistor r=4.5 //w=0.15 //l=0.15 //layer=via1 //count=1 \
 //x=4.91 //y=4.33 //x2=4.91 //y2=4.33
r424 (  28 88 ) resistor r=9.3 //w=0.17 //l=0.17 //layer=mcon //count=1 \
 //x=4.93 //y=4.88 //x2=4.93 //y2=4.88
r425 (  25 51 ) resistor r=0.0732479 //w=0.241 //l=0.122474 //layer=m1 \
 //thickness=0.36 //x=10.85 //y=4.76 //x2=10.845 //y2=4.88
r426 (  24 42 ) resistor r=0.091625 //w=0.387 //l=0.180222 //layer=m1 \
 //thickness=0.36 //x=10.85 //y=4.455 //x2=10.807 //y2=4.295
r427 (  17 44 ) resistor r=0.116051 //w=0.211 //l=0.165 //layer=m1 \
 //thickness=0.36 //x=10.85 //y=2.43 //x2=10.85 //y2=2.265
r428 (  14 34 ) resistor r=0.0773187 //w=0.224 //l=0.126491 //layer=m1 \
 //thickness=0.36 //x=7.15 //y=2.385 //x2=7.147 //y2=2.26
r429 (  12 28 ) resistor r=0.0745285 //w=0.224 //l=0.12 //layer=m1 \
 //thickness=0.36 //x=4.93 //y=4.76 //x2=4.93 //y2=4.88
r430 (  10 42 ) resistor r=0.0145349 //w=0.387 //l=0.045 //layer=m1 \
 //thickness=0.36 //x=10.807 //y=4.25 //x2=10.807 //y2=4.295
r431 (  10 22 ) resistor r=0.0770901 //w=0.387 //l=0.134796 //layer=m1 \
 //thickness=0.36 //x=10.807 //y=4.25 //x2=10.85 //y2=4.135
r432 (  9 49 ) resistor r=0.0292056 //w=0.321 //l=0.075 //layer=m1 \
 //thickness=0.36 //x=10.85 //y=3.585 //x2=10.925 //y2=3.585
r433 (  9 21 ) resistor r=0.0456961 //w=0.321 //l=0.19 //layer=m1 \
 //thickness=0.36 //x=10.85 //y=3.585 //x2=10.85 //y2=3.775
r434 (  9 18 ) resistor r=0.0456961 //w=0.321 //l=0.19 //layer=m1 \
 //thickness=0.36 //x=10.85 //y=3.585 //x2=10.85 //y2=3.395
r435 (  8 38 ) resistor r=0.00334225 //w=0.374 //l=0.01 //layer=m1 \
 //thickness=0.36 //x=7.205 //y=3.51 //x2=7.205 //y2=3.52
r436 (  8 15 ) resistor r=0.0877379 //w=0.374 //l=0.175357 //layer=m1 \
 //thickness=0.36 //x=7.205 //y=3.51 //x2=7.15 //y2=3.36
r437 (  7 11 ) resistor r=0.0410036 //w=0.297 //l=0.178 //layer=m1 \
 //thickness=0.36 //x=4.93 //y=4.312 //x2=4.93 //y2=4.49
r438 (  7 30 ) resistor r=0.00841751 //w=0.297 //l=0.02 //layer=m1 \
 //thickness=0.36 //x=4.93 //y=4.312 //x2=4.91 //y2=4.312
r439 (  6 25 ) resistor r=0.133588 //w=0.131 //l=0.14 //layer=m1 \
 //thickness=0.36 //x=10.85 //y=4.62 //x2=10.85 //y2=4.76
r440 (  6 24 ) resistor r=0.157443 //w=0.131 //l=0.165 //layer=m1 \
 //thickness=0.36 //x=10.85 //y=4.62 //x2=10.85 //y2=4.455
r441 (  5 22 ) resistor r=0.243321 //w=0.131 //l=0.255 //layer=m1 \
 //thickness=0.36 //x=10.85 //y=3.88 //x2=10.85 //y2=4.135
r442 (  5 21 ) resistor r=0.100191 //w=0.131 //l=0.105 //layer=m1 \
 //thickness=0.36 //x=10.85 //y=3.88 //x2=10.85 //y2=3.775
r443 (  4 18 ) resistor r=0.243321 //w=0.131 //l=0.255 //layer=m1 \
 //thickness=0.36 //x=10.85 //y=3.14 //x2=10.85 //y2=3.395
r444 (  3 4 ) resistor r=0.353053 //w=0.131 //l=0.37 //layer=m1 \
 //thickness=0.36 //x=10.85 //y=2.77 //x2=10.85 //y2=3.14
r445 (  3 17 ) resistor r=0.324427 //w=0.131 //l=0.34 //layer=m1 \
 //thickness=0.36 //x=10.85 //y=2.77 //x2=10.85 //y2=2.43
r446 (  2 15 ) resistor r=0.916031 //w=0.131 //l=0.96 //layer=m1 \
 //thickness=0.36 //x=7.15 //y=2.4 //x2=7.15 //y2=3.36
r447 (  2 14 ) resistor r=0.014313 //w=0.131 //l=0.015 //layer=m1 \
 //thickness=0.36 //x=7.15 //y=2.4 //x2=7.15 //y2=2.385
r448 (  1 12 ) resistor r=0.133588 //w=0.131 //l=0.14 //layer=m1 \
 //thickness=0.36 //x=4.93 //y=4.62 //x2=4.93 //y2=4.76
r449 (  1 11 ) resistor r=0.124046 //w=0.131 //l=0.13 //layer=m1 \
 //thickness=0.36 //x=4.93 //y=4.62 //x2=4.93 //y2=4.49
ends PM_XNOR2X1\%B

subckt PM_XNOR2X1\%VDD ( 1 2 10 11 12 19 20 29 57 73 87 113 128 130 131 132 \
 136 137 138 139 140 141 142 )
c257 ( 142 0 ) capacitor c=0.0601985f //x=10.77 //y=5.2
c258 ( 141 0 ) capacitor c=0.0569691f //x=9.91 //y=5.2
c259 ( 140 0 ) capacitor c=0.0168731f //x=7.125 //y=5.2
c260 ( 139 0 ) capacitor c=0.0171993f //x=3.795 //y=5.2
c261 ( 138 0 ) capacitor c=0.0586341f //x=1.9 //y=5.2
c262 ( 137 0 ) capacitor c=0.0605153f //x=1.03 //y=5.2
c263 ( 136 0 ) capacitor c=0.255236f //x=10.85 //y=7.58
c264 ( 134 0 ) capacitor c=0.00597439f //x=10.11 //y=7.58
c265 ( 132 0 ) capacitor c=0.116372f //x=9.37 //y=7.585
c266 ( 131 0 ) capacitor c=0.119053f //x=6.04 //y=7.585
c267 ( 130 0 ) capacitor c=0.121869f //x=2.71 //y=7.585
c268 ( 129 0 ) capacitor c=0.00597439f //x=2.045 //y=7.585
c269 ( 128 0 ) capacitor c=0.256392f //x=1.23 //y=7.58
c270 ( 113 0 ) capacitor c=0.0287942f //x=10.83 //y=7.585
c271 ( 103 0 ) capacitor c=0.02083f //x=9.95 //y=7.585
c272 ( 87 0 ) capacitor c=0.138549f //x=9.2 //y=7.585
c273 ( 73 0 ) capacitor c=0.138968f //x=5.87 //y=7.585
c274 ( 67 0 ) capacitor c=0.0211939f //x=2.54 //y=7.585
c275 ( 57 0 ) capacitor c=0.0287132f //x=1.96 //y=7.585
c276 ( 38 0 ) capacitor c=0.00510714f //x=7.27 //y=7.585
c277 ( 35 0 ) capacitor c=0.00510714f //x=3.94 //y=7.585
c278 ( 29 0 ) capacitor c=0.179756f //x=10.85 //y=7.58
c279 ( 20 0 ) capacitor c=0.0146332f //x=7.27 //y=7.41
c280 ( 19 0 ) capacitor c=0.0128249f //x=7.27 //y=6.69
c281 ( 12 0 ) capacitor c=0.112443f //x=7.185 //y=7.585
c282 ( 11 0 ) capacitor c=0.0155487f //x=3.94 //y=7.41
c283 ( 10 0 ) capacitor c=0.0138066f //x=3.94 //y=6.7
c284 ( 2 0 ) capacitor c=0.158711f //x=3.855 //y=7.585
r285 (  115 136 ) resistor r=4.23183 //w=0.7 //l=0.175 //layer=li \
 //thickness=0.1 //x=10.915 //y=7.41 //x2=10.915 //y2=7.585
r286 (  115 142 ) resistor r=56.4706 //w=0.187 //l=0.825 //layer=li \
 //thickness=0.1 //x=10.915 //y=7.41 //x2=10.915 //y2=6.585
r287 (  114 134 ) resistor r=2.87058 //w=0.35 //l=0.085 //layer=li \
 //thickness=0.1 //x=10.12 //y=7.585 //x2=10.035 //y2=7.585
r288 (  113 136 ) resistor r=2.87058 //w=0.35 //l=0.085 //layer=li \
 //thickness=0.1 //x=10.83 //y=7.585 //x2=10.915 //y2=7.585
r289 (  113 114 ) resistor r=24.7629 //w=0.367 //l=0.71 //layer=li \
 //thickness=0.1 //x=10.83 //y=7.585 //x2=10.12 //y2=7.585
r290 (  105 134 ) resistor r=4.23183 //w=0.7 //l=0.175 //layer=li \
 //thickness=0.1 //x=10.035 //y=7.41 //x2=10.035 //y2=7.585
r291 (  105 141 ) resistor r=56.4706 //w=0.187 //l=0.825 //layer=li \
 //thickness=0.1 //x=10.035 //y=7.41 //x2=10.035 //y2=6.585
r292 (  104 132 ) resistor r=5.29055 //w=0.35 //l=0.17 //layer=li \
 //thickness=0.1 //x=9.54 //y=7.585 //x2=9.37 //y2=7.585
r293 (  103 134 ) resistor r=2.87058 //w=0.35 //l=0.085 //layer=li \
 //thickness=0.1 //x=9.95 //y=7.585 //x2=10.035 //y2=7.585
r294 (  103 104 ) resistor r=14.2997 //w=0.367 //l=0.41 //layer=li \
 //thickness=0.1 //x=9.95 //y=7.585 //x2=9.54 //y2=7.585
r295 (  99 140 ) resistor r=23.2727 //w=0.187 //l=0.34 //layer=li \
 //thickness=0.1 //x=7.27 //y=6.575 //x2=7.27 //y2=6.235
r296 (  92 94 ) resistor r=38.7139 //w=0.367 //l=1.11 //layer=li \
 //thickness=0.1 //x=7.52 //y=7.585 //x2=8.63 //y2=7.585
r297 (  90 92 ) resistor r=38.7139 //w=0.367 //l=1.11 //layer=li \
 //thickness=0.1 //x=6.41 //y=7.585 //x2=7.52 //y2=7.585
r298 (  88 131 ) resistor r=5.29055 //w=0.35 //l=0.17 //layer=li \
 //thickness=0.1 //x=6.21 //y=7.585 //x2=6.04 //y2=7.585
r299 (  88 90 ) resistor r=6.97548 //w=0.367 //l=0.2 //layer=li \
 //thickness=0.1 //x=6.21 //y=7.585 //x2=6.41 //y2=7.585
r300 (  87 132 ) resistor r=5.29055 //w=0.35 //l=0.17 //layer=li \
 //thickness=0.1 //x=9.2 //y=7.585 //x2=9.37 //y2=7.585
r301 (  87 94 ) resistor r=19.8801 //w=0.367 //l=0.57 //layer=li \
 //thickness=0.1 //x=9.2 //y=7.585 //x2=8.63 //y2=7.585
r302 (  83 139 ) resistor r=23.2727 //w=0.187 //l=0.34 //layer=li \
 //thickness=0.1 //x=3.94 //y=6.575 //x2=3.94 //y2=6.235
r303 (  76 78 ) resistor r=38.7139 //w=0.367 //l=1.11 //layer=li \
 //thickness=0.1 //x=3.82 //y=7.585 //x2=4.93 //y2=7.585
r304 (  74 130 ) resistor r=5.29055 //w=0.35 //l=0.17 //layer=li \
 //thickness=0.1 //x=2.88 //y=7.585 //x2=2.71 //y2=7.585
r305 (  74 76 ) resistor r=32.7847 //w=0.367 //l=0.94 //layer=li \
 //thickness=0.1 //x=2.88 //y=7.585 //x2=3.82 //y2=7.585
r306 (  73 131 ) resistor r=5.29055 //w=0.35 //l=0.17 //layer=li \
 //thickness=0.1 //x=5.87 //y=7.585 //x2=6.04 //y2=7.585
r307 (  73 78 ) resistor r=32.7847 //w=0.367 //l=0.94 //layer=li \
 //thickness=0.1 //x=5.87 //y=7.585 //x2=4.93 //y2=7.585
r308 (  68 129 ) resistor r=2.87058 //w=0.35 //l=0.085 //layer=li \
 //thickness=0.1 //x=2.13 //y=7.585 //x2=2.045 //y2=7.585
r309 (  68 70 ) resistor r=7.32425 //w=0.367 //l=0.21 //layer=li \
 //thickness=0.1 //x=2.13 //y=7.585 //x2=2.34 //y2=7.585
r310 (  67 130 ) resistor r=5.29055 //w=0.35 //l=0.17 //layer=li \
 //thickness=0.1 //x=2.54 //y=7.585 //x2=2.71 //y2=7.585
r311 (  67 70 ) resistor r=6.97548 //w=0.367 //l=0.2 //layer=li \
 //thickness=0.1 //x=2.54 //y=7.585 //x2=2.34 //y2=7.585
r312 (  59 129 ) resistor r=4.23183 //w=0.7 //l=0.175 //layer=li \
 //thickness=0.1 //x=2.045 //y=7.41 //x2=2.045 //y2=7.585
r313 (  59 138 ) resistor r=56.4706 //w=0.187 //l=0.825 //layer=li \
 //thickness=0.1 //x=2.045 //y=7.41 //x2=2.045 //y2=6.585
r314 (  58 128 ) resistor r=2.87058 //w=0.35 //l=0.085 //layer=li \
 //thickness=0.1 //x=1.25 //y=7.585 //x2=1.165 //y2=7.585
r315 (  57 129 ) resistor r=2.87058 //w=0.35 //l=0.085 //layer=li \
 //thickness=0.1 //x=1.96 //y=7.585 //x2=2.045 //y2=7.585
r316 (  57 58 ) resistor r=24.7629 //w=0.367 //l=0.71 //layer=li \
 //thickness=0.1 //x=1.96 //y=7.585 //x2=1.25 //y2=7.585
r317 (  49 128 ) resistor r=4.23183 //w=0.7 //l=0.175 //layer=li \
 //thickness=0.1 //x=1.165 //y=7.41 //x2=1.165 //y2=7.585
r318 (  49 137 ) resistor r=56.4706 //w=0.187 //l=0.825 //layer=li \
 //thickness=0.1 //x=1.165 //y=7.41 //x2=1.165 //y2=6.585
r319 (  40 99 ) resistor r=9.3 //w=0.17 //l=0.17 //layer=mcon //count=1 \
 //x=7.27 //y=6.575 //x2=7.27 //y2=6.575
r320 (  37 83 ) resistor r=9.3 //w=0.17 //l=0.17 //layer=mcon //count=1 \
 //x=3.94 //y=6.575 //x2=3.94 //y2=6.575
r321 (  29 136 ) resistor r=4.65 //w=0.17 //l=0.34 //layer=mcon //count=2 \
 //x=10.85 //y=7.58 //x2=10.85 //y2=7.58
r322 (  27 134 ) resistor r=3.1 //w=0.17 //l=0.51 //layer=mcon //count=3 \
 //x=10.11 //y=7.58 //x2=10.11 //y2=7.58
r323 (  27 29 ) resistor r=0.297428 //w=0.311 //l=0.74 //layer=m1 \
 //thickness=0.36 //x=10.11 //y=7.585 //x2=10.85 //y2=7.585
r324 (  25 94 ) resistor r=3.1 //w=0.17 //l=0.51 //layer=mcon //count=3 \
 //x=8.63 //y=7.58 //x2=8.63 //y2=7.58
r325 (  25 27 ) resistor r=0.594855 //w=0.311 //l=1.48 //layer=m1 \
 //thickness=0.36 //x=8.63 //y=7.585 //x2=10.11 //y2=7.585
r326 (  23 92 ) resistor r=3.1 //w=0.17 //l=0.51 //layer=mcon //count=3 \
 //x=7.52 //y=7.58 //x2=7.52 //y2=7.58
r327 (  23 25 ) resistor r=0.446141 //w=0.311 //l=1.11 //layer=m1 \
 //thickness=0.36 //x=7.52 //y=7.585 //x2=8.63 //y2=7.585
r328 (  21 38 ) resistor r=0.028033 //w=0.35 //l=0.085 //layer=m1 \
 //thickness=0.36 //x=7.355 //y=7.585 //x2=7.27 //y2=7.585
r329 (  21 23 ) resistor r=0.0663183 //w=0.311 //l=0.165 //layer=m1 \
 //thickness=0.36 //x=7.355 //y=7.585 //x2=7.52 //y2=7.585
r330 (  20 38 ) resistor r=0.0413265 //w=0.7 //l=0.175 //layer=m1 \
 //thickness=0.36 //x=7.27 //y=7.41 //x2=7.27 //y2=7.585
r331 (  19 40 ) resistor r=0.0714075 //w=0.228 //l=0.115996 //layer=m1 \
 //thickness=0.36 //x=7.27 //y=6.69 //x2=7.272 //y2=6.575
r332 (  19 20 ) resistor r=0.687023 //w=0.131 //l=0.72 //layer=m1 \
 //thickness=0.36 //x=7.27 //y=6.69 //x2=7.27 //y2=7.41
r333 (  18 90 ) resistor r=3.1 //w=0.17 //l=0.51 //layer=mcon //count=3 \
 //x=6.41 //y=7.58 //x2=6.41 //y2=7.58
r334 (  15 78 ) resistor r=3.1 //w=0.17 //l=0.51 //layer=mcon //count=3 \
 //x=4.93 //y=7.58 //x2=4.93 //y2=7.58
r335 (  13 35 ) resistor r=0.028033 //w=0.35 //l=0.085 //layer=m1 \
 //thickness=0.36 //x=4.025 //y=7.585 //x2=3.94 //y2=7.585
r336 (  13 15 ) resistor r=0.363746 //w=0.311 //l=0.905 //layer=m1 \
 //thickness=0.36 //x=4.025 //y=7.585 //x2=4.93 //y2=7.585
r337 (  12 38 ) resistor r=0.028033 //w=0.35 //l=0.085 //layer=m1 \
 //thickness=0.36 //x=7.185 //y=7.585 //x2=7.27 //y2=7.585
r338 (  12 18 ) resistor r=0.311495 //w=0.311 //l=0.775 //layer=m1 \
 //thickness=0.36 //x=7.185 //y=7.585 //x2=6.41 //y2=7.585
r339 (  11 35 ) resistor r=0.0413265 //w=0.7 //l=0.175 //layer=m1 \
 //thickness=0.36 //x=3.94 //y=7.41 //x2=3.94 //y2=7.585
r340 (  10 37 ) resistor r=0.0770974 //w=0.226 //l=0.125 //layer=m1 \
 //thickness=0.36 //x=3.94 //y=6.7 //x2=3.94 //y2=6.575
r341 (  10 11 ) resistor r=0.677481 //w=0.131 //l=0.71 //layer=m1 \
 //thickness=0.36 //x=3.94 //y=6.7 //x2=3.94 //y2=7.41
r342 (  9 76 ) resistor r=3.1 //w=0.17 //l=0.51 //layer=mcon //count=3 \
 //x=3.82 //y=7.58 //x2=3.82 //y2=7.58
r343 (  7 70 ) resistor r=3.1 //w=0.17 //l=0.51 //layer=mcon //count=3 \
 //x=2.34 //y=7.58 //x2=2.34 //y2=7.58
r344 (  7 9 ) resistor r=0.594855 //w=0.311 //l=1.48 //layer=m1 \
 //thickness=0.36 //x=2.34 //y=7.585 //x2=3.82 //y2=7.585
r345 (  4 128 ) resistor r=3.1 //w=0.17 //l=0.51 //layer=mcon //count=3 \
 //x=1.23 //y=7.58 //x2=1.23 //y2=7.58
r346 (  4 7 ) resistor r=0.446141 //w=0.311 //l=1.11 //layer=m1 \
 //thickness=0.36 //x=1.23 //y=7.585 //x2=2.34 //y2=7.585
r347 (  2 35 ) resistor r=0.028033 //w=0.35 //l=0.085 //layer=m1 \
 //thickness=0.36 //x=3.855 //y=7.585 //x2=3.94 //y2=7.585
r348 (  2 9 ) resistor r=0.0140675 //w=0.311 //l=0.035 //layer=m1 \
 //thickness=0.36 //x=3.855 //y=7.585 //x2=3.82 //y2=7.585
r349 (  1 18 ) resistor r=0.148714 //w=0.311 //l=0.37 //layer=m1 \
 //thickness=0.36 //x=6.04 //y=7.585 //x2=6.41 //y2=7.585
r350 (  1 15 ) resistor r=0.446141 //w=0.311 //l=1.11 //layer=m1 \
 //thickness=0.36 //x=6.04 //y=7.585 //x2=4.93 //y2=7.585
ends PM_XNOR2X1\%VDD

subckt PM_XNOR2X1\%noxref_7 ( 1 3 5 10 14 17 20 30 46 47 48 )
c85 ( 48 0 ) capacitor c=0.0366849f //x=5.115 //y=5.2
c86 ( 46 0 ) capacitor c=0.0157071f //x=3.365 //y=5.2
c87 ( 30 0 ) capacitor c=0.0316068f //x=4.38 //y=5.555
c88 ( 20 0 ) capacitor c=0.0445825f //x=3.5 //y=5.555
c89 ( 17 0 ) capacitor c=0.0102161f //x=5.26 //y=6.915
c90 ( 14 0 ) capacitor c=0.00639419f //x=4.38 //y=6.915
c91 ( 10 0 ) capacitor c=0.011815f //x=4.382 //y=5.385
c92 ( 5 0 ) capacitor c=0.0130216f //x=3.505 //y=5.385
c93 ( 3 0 ) capacitor c=0.00875915f //x=5.14 //y=7.085
c94 ( 1 0 ) capacitor c=0.0146195f //x=4.265 //y=5.385
r95 (  37 47 ) resistor r=23.2727 //w=0.187 //l=0.34 //layer=li \
 //thickness=0.1 //x=4.38 //y=6.915 //x2=4.38 //y2=6.575
r96 (  30 47 ) resistor r=23.2727 //w=0.187 //l=0.34 //layer=li \
 //thickness=0.1 //x=4.38 //y=5.555 //x2=4.38 //y2=5.895
r97 (  20 46 ) resistor r=23.2727 //w=0.187 //l=0.34 //layer=li \
 //thickness=0.1 //x=3.5 //y=5.555 //x2=3.5 //y2=5.895
r98 (  17 48 ) resistor r=9.3 //w=0.17 //l=0.17 //layer=mcon //count=1 \
 //x=5.26 //y=6.915 //x2=5.26 //y2=6.915
r99 (  17 18 ) resistor r=0.0974771 //w=0.218 //l=0.17 //layer=m1 \
 //thickness=0.36 //x=5.257 //y=6.915 //x2=5.257 //y2=7.085
r100 (  14 37 ) resistor r=9.3 //w=0.17 //l=0.17 //layer=mcon //count=1 \
 //x=4.38 //y=6.915 //x2=4.38 //y2=6.915
r101 (  14 15 ) resistor r=0.0974771 //w=0.218 //l=0.17 //layer=m1 \
 //thickness=0.36 //x=4.382 //y=6.915 //x2=4.382 //y2=7.085
r102 (  12 30 ) resistor r=9.3 //w=0.17 //l=0.17 //layer=mcon //count=1 \
 //x=4.38 //y=5.555 //x2=4.38 //y2=5.555
r103 (  10 12 ) resistor r=0.0983796 //w=0.216 //l=0.17 //layer=m1 \
 //thickness=0.36 //x=4.382 //y=5.385 //x2=4.382 //y2=5.555
r104 (  7 20 ) resistor r=9.3 //w=0.17 //l=0.17 //layer=mcon //count=1 //x=3.5 \
 //y=5.555 //x2=3.5 //y2=5.555
r105 (  5 7 ) resistor r=0.0940266 //w=0.226 //l=0.17 //layer=m1 \
 //thickness=0.36 //x=3.505 //y=5.385 //x2=3.505 //y2=5.555
r106 (  4 15 ) resistor r=0.0225019 //w=0.218 //l=0.118 //layer=m1 \
 //thickness=0.36 //x=4.5 //y=7.085 //x2=4.382 //y2=7.085
r107 (  3 18 ) resistor r=0.0225019 //w=0.218 //l=0.117 //layer=m1 \
 //thickness=0.36 //x=5.14 //y=7.085 //x2=5.257 //y2=7.085
r108 (  3 4 ) resistor r=0.610687 //w=0.131 //l=0.64 //layer=m1 \
 //thickness=0.36 //x=5.14 //y=7.085 //x2=4.5 //y2=7.085
r109 (  2 5 ) resistor r=0.0246599 //w=0.226 //l=0.12 //layer=m1 \
 //thickness=0.36 //x=3.625 //y=5.385 //x2=3.505 //y2=5.385
r110 (  1 10 ) resistor r=0.0219491 //w=0.216 //l=0.117 //layer=m1 \
 //thickness=0.36 //x=4.265 //y=5.385 //x2=4.382 //y2=5.385
r111 (  1 2 ) resistor r=0.610687 //w=0.131 //l=0.64 //layer=m1 \
 //thickness=0.36 //x=4.265 //y=5.385 //x2=3.625 //y2=5.385
ends PM_XNOR2X1\%noxref_7

subckt PM_XNOR2X1\%noxref_8 ( 1 3 5 10 14 17 20 30 46 47 48 )
c86 ( 48 0 ) capacitor c=0.0344738f //x=8.445 //y=5.2
c87 ( 46 0 ) capacitor c=0.0127345f //x=6.695 //y=5.2
c88 ( 30 0 ) capacitor c=0.030608f //x=7.71 //y=5.555
c89 ( 20 0 ) capacitor c=0.0473129f //x=6.83 //y=5.555
c90 ( 17 0 ) capacitor c=0.0159288f //x=8.59 //y=6.915
c91 ( 14 0 ) capacitor c=0.00658277f //x=7.71 //y=6.915
c92 ( 10 0 ) capacitor c=0.00948335f //x=7.71 //y=5.385
c93 ( 5 0 ) capacitor c=0.0131065f //x=6.83 //y=5.385
c94 ( 3 0 ) capacitor c=0.00848034f //x=8.47 //y=7.085
c95 ( 1 0 ) capacitor c=0.0112017f //x=7.59 //y=5.385
r96 (  37 47 ) resistor r=23.2727 //w=0.187 //l=0.34 //layer=li \
 //thickness=0.1 //x=7.71 //y=6.915 //x2=7.71 //y2=6.575
r97 (  30 47 ) resistor r=23.2727 //w=0.187 //l=0.34 //layer=li \
 //thickness=0.1 //x=7.71 //y=5.555 //x2=7.71 //y2=5.895
r98 (  20 46 ) resistor r=23.2727 //w=0.187 //l=0.34 //layer=li \
 //thickness=0.1 //x=6.83 //y=5.555 //x2=6.83 //y2=5.895
r99 (  17 48 ) resistor r=9.3 //w=0.17 //l=0.17 //layer=mcon //count=1 \
 //x=8.59 //y=6.915 //x2=8.59 //y2=6.915
r100 (  17 18 ) resistor r=0.0957207 //w=0.222 //l=0.17 //layer=m1 \
 //thickness=0.36 //x=8.59 //y=6.915 //x2=8.59 //y2=7.085
r101 (  14 37 ) resistor r=9.3 //w=0.17 //l=0.17 //layer=mcon //count=1 \
 //x=7.71 //y=6.915 //x2=7.71 //y2=6.915
r102 (  14 15 ) resistor r=0.0957207 //w=0.222 //l=0.17 //layer=m1 \
 //thickness=0.36 //x=7.71 //y=6.915 //x2=7.71 //y2=7.085
r103 (  12 30 ) resistor r=9.3 //w=0.17 //l=0.17 //layer=mcon //count=1 \
 //x=7.71 //y=5.555 //x2=7.71 //y2=5.555
r104 (  10 12 ) resistor r=0.0957207 //w=0.222 //l=0.17 //layer=m1 \
 //thickness=0.36 //x=7.71 //y=5.385 //x2=7.71 //y2=5.555
r105 (  7 20 ) resistor r=9.3 //w=0.17 //l=0.17 //layer=mcon //count=1 \
 //x=6.83 //y=5.555 //x2=6.83 //y2=5.555
r106 (  5 7 ) resistor r=0.0988372 //w=0.215 //l=0.17 //layer=m1 \
 //thickness=0.36 //x=6.83 //y=5.385 //x2=6.83 //y2=5.555
r107 (  4 15 ) resistor r=0.0235912 //w=0.222 //l=0.12 //layer=m1 \
 //thickness=0.36 //x=7.83 //y=7.085 //x2=7.71 //y2=7.085
r108 (  3 18 ) resistor r=0.0235912 //w=0.222 //l=0.12 //layer=m1 \
 //thickness=0.36 //x=8.47 //y=7.085 //x2=8.59 //y2=7.085
r109 (  3 4 ) resistor r=0.610687 //w=0.131 //l=0.64 //layer=m1 \
 //thickness=0.36 //x=8.47 //y=7.085 //x2=7.83 //y2=7.085
r110 (  2 5 ) resistor r=0.0216707 //w=0.215 //l=0.115 //layer=m1 \
 //thickness=0.36 //x=6.945 //y=5.385 //x2=6.83 //y2=5.385
r111 (  1 10 ) resistor r=0.0235912 //w=0.222 //l=0.12 //layer=m1 \
 //thickness=0.36 //x=7.59 //y=5.385 //x2=7.71 //y2=5.385
r112 (  1 2 ) resistor r=0.615458 //w=0.131 //l=0.645 //layer=m1 \
 //thickness=0.36 //x=7.59 //y=5.385 //x2=6.945 //y2=5.385
ends PM_XNOR2X1\%noxref_8

subckt PM_XNOR2X1\%GND ( 1 2 9 10 18 27 46 50 53 64 77 95 100 104 116 127 128 \
 129 136 143 144 145 146 )
c243 ( 146 0 ) capacitor c=0.0625277f //x=9.865 //y=0.55
c244 ( 145 0 ) capacitor c=0.00869869f //x=7.03 //y=1.045
c245 ( 144 0 ) capacitor c=0.00869869f //x=3.7 //y=1.045
c246 ( 143 0 ) capacitor c=0.0629186f //x=0.985 //y=0.55
c247 ( 136 0 ) capacitor c=0.253488f //x=10.96 //y=0.175
c248 ( 129 0 ) capacitor c=0.113041f //x=9.37 //y=0.175
c249 ( 128 0 ) capacitor c=0.111218f //x=6.04 //y=0.175
c250 ( 127 0 ) capacitor c=0.108505f //x=2.71 //y=0.175
c251 ( 116 0 ) capacitor c=0.215034f //x=1.12 //y=0.175
c252 ( 107 0 ) capacitor c=0.00586769f //x=10.96 //y=0.63
c253 ( 104 0 ) capacitor c=0.00605241f //x=10.875 //y=0.715
c254 ( 103 0 ) capacitor c=0.00479851f //x=10.48 //y=0.63
c255 ( 100 0 ) capacitor c=0.00610579f //x=10.395 //y=0.715
c256 ( 95 0 ) capacitor c=0.00585268f //x=9.99 //y=0.63
c257 ( 92 0 ) capacitor c=0.0185511f //x=9.905 //y=0.175
c258 ( 77 0 ) capacitor c=0.126312f //x=9.2 //y=0.175
c259 ( 64 0 ) capacitor c=0.125678f //x=5.87 //y=0.175
c260 ( 59 0 ) capacitor c=0.0366946f //x=2.175 //y=0.175
c261 ( 58 0 ) capacitor c=0.0185573f //x=2.54 //y=0.175
c262 ( 53 0 ) capacitor c=0.00585268f //x=2.09 //y=0.63
c263 ( 50 0 ) capacitor c=0.00605867f //x=2.005 //y=0.715
c264 ( 49 0 ) capacitor c=0.00479851f //x=1.6 //y=0.63
c265 ( 46 0 ) capacitor c=0.0064899f //x=1.515 //y=0.715
c266 ( 41 0 ) capacitor c=0.00590583f //x=1.12 //y=0.63
c267 ( 33 0 ) capacitor c=0.00509742f //x=7.22 //y=0.175
c268 ( 30 0 ) capacitor c=0.00509742f //x=3.82 //y=0.18
c269 ( 27 0 ) capacitor c=0.179012f //x=10.85 //y=0.18
c270 ( 18 0 ) capacitor c=0.0338689f //x=7.22 //y=1.02
c271 ( 10 0 ) capacitor c=0.110413f //x=7.135 //y=0.175
c272 ( 9 0 ) capacitor c=0.0342153f //x=3.89 //y=1.02
c273 ( 2 0 ) capacitor c=0.153908f //x=3.805 //y=0.175
r274 (  135 136 ) resistor r=3.83651 //w=0.367 //l=0.11 //layer=li \
 //thickness=0.1 //x=10.85 //y=0.175 //x2=10.96 //y2=0.175
r275 (  133 135 ) resistor r=12.9046 //w=0.367 //l=0.37 //layer=li \
 //thickness=0.1 //x=10.48 //y=0.175 //x2=10.85 //y2=0.175
r276 (  132 133 ) resistor r=12.9046 //w=0.367 //l=0.37 //layer=li \
 //thickness=0.1 //x=10.11 //y=0.175 //x2=10.48 //y2=0.175
r277 (  130 132 ) resistor r=4.18529 //w=0.367 //l=0.12 //layer=li \
 //thickness=0.1 //x=9.99 //y=0.175 //x2=10.11 //y2=0.175
r278 (  119 120 ) resistor r=17.0899 //w=0.367 //l=0.49 //layer=li \
 //thickness=0.1 //x=1.6 //y=0.175 //x2=2.09 //y2=0.175
r279 (  118 119 ) resistor r=12.9046 //w=0.367 //l=0.37 //layer=li \
 //thickness=0.1 //x=1.23 //y=0.175 //x2=1.6 //y2=0.175
r280 (  116 118 ) resistor r=3.83651 //w=0.367 //l=0.11 //layer=li \
 //thickness=0.1 //x=1.12 //y=0.175 //x2=1.23 //y2=0.175
r281 (  108 146 ) resistor r=5.4201 //w=0.17 //l=0.085 //layer=li \
 //thickness=0.1 //x=10.96 //y=0.8 //x2=10.96 //y2=0.715
r282 (  108 146 ) resistor r=41.4118 //w=0.187 //l=0.605 //layer=li \
 //thickness=0.1 //x=10.96 //y=0.8 //x2=10.96 //y2=1.405
r283 (  107 146 ) resistor r=5.4201 //w=0.17 //l=0.085 //layer=li \
 //thickness=0.1 //x=10.96 //y=0.63 //x2=10.96 //y2=0.715
r284 (  106 136 ) resistor r=5.21862 //w=0.35 //l=0.175 //layer=li \
 //thickness=0.1 //x=10.96 //y=0.35 //x2=10.96 //y2=0.175
r285 (  106 107 ) resistor r=19.1658 //w=0.187 //l=0.28 //layer=li \
 //thickness=0.1 //x=10.96 //y=0.35 //x2=10.96 //y2=0.63
r286 (  105 146 ) resistor r=5.4201 //w=0.17 //l=0.085 //layer=li \
 //thickness=0.1 //x=10.565 //y=0.715 //x2=10.48 //y2=0.715
r287 (  104 146 ) resistor r=1.40859 //w=0.34 //l=0.085 //layer=li \
 //thickness=0.1 //x=10.875 //y=0.715 //x2=10.96 //y2=0.715
r288 (  104 105 ) resistor r=21.2193 //w=0.187 //l=0.31 //layer=li \
 //thickness=0.1 //x=10.875 //y=0.715 //x2=10.565 //y2=0.715
r289 (  103 146 ) resistor r=1.40859 //w=0.34 //l=0.085 //layer=li \
 //thickness=0.1 //x=10.48 //y=0.63 //x2=10.48 //y2=0.715
r290 (  102 133 ) resistor r=5.21862 //w=0.35 //l=0.175 //layer=li \
 //thickness=0.1 //x=10.48 //y=0.35 //x2=10.48 //y2=0.175
r291 (  102 103 ) resistor r=19.1658 //w=0.187 //l=0.28 //layer=li \
 //thickness=0.1 //x=10.48 //y=0.35 //x2=10.48 //y2=0.63
r292 (  101 146 ) resistor r=1.40859 //w=0.34 //l=0.085 //layer=li \
 //thickness=0.1 //x=10.075 //y=0.715 //x2=9.99 //y2=0.715
r293 (  100 146 ) resistor r=5.4201 //w=0.17 //l=0.085 //layer=li \
 //thickness=0.1 //x=10.395 //y=0.715 //x2=10.48 //y2=0.715
r294 (  100 101 ) resistor r=21.9037 //w=0.187 //l=0.32 //layer=li \
 //thickness=0.1 //x=10.395 //y=0.715 //x2=10.075 //y2=0.715
r295 (  96 146 ) resistor r=5.4201 //w=0.17 //l=0.085 //layer=li \
 //thickness=0.1 //x=9.99 //y=0.8 //x2=9.99 //y2=0.715
r296 (  96 146 ) resistor r=41.4118 //w=0.187 //l=0.605 //layer=li \
 //thickness=0.1 //x=9.99 //y=0.8 //x2=9.99 //y2=1.405
r297 (  95 146 ) resistor r=5.4201 //w=0.17 //l=0.085 //layer=li \
 //thickness=0.1 //x=9.99 //y=0.63 //x2=9.99 //y2=0.715
r298 (  94 130 ) resistor r=5.21862 //w=0.35 //l=0.175 //layer=li \
 //thickness=0.1 //x=9.99 //y=0.35 //x2=9.99 //y2=0.175
r299 (  94 95 ) resistor r=19.1658 //w=0.187 //l=0.28 //layer=li \
 //thickness=0.1 //x=9.99 //y=0.35 //x2=9.99 //y2=0.63
r300 (  93 129 ) resistor r=5.29055 //w=0.35 //l=0.17 //layer=li \
 //thickness=0.1 //x=9.54 //y=0.175 //x2=9.37 //y2=0.175
r301 (  92 130 ) resistor r=2.96458 //w=0.367 //l=0.085 //layer=li \
 //thickness=0.1 //x=9.905 //y=0.175 //x2=9.99 //y2=0.175
r302 (  92 93 ) resistor r=12.7302 //w=0.367 //l=0.365 //layer=li \
 //thickness=0.1 //x=9.905 //y=0.175 //x2=9.54 //y2=0.175
r303 (  82 84 ) resistor r=38.7139 //w=0.367 //l=1.11 //layer=li \
 //thickness=0.1 //x=7.52 //y=0.175 //x2=8.63 //y2=0.175
r304 (  80 82 ) resistor r=38.7139 //w=0.367 //l=1.11 //layer=li \
 //thickness=0.1 //x=6.41 //y=0.175 //x2=7.52 //y2=0.175
r305 (  78 128 ) resistor r=5.29055 //w=0.35 //l=0.17 //layer=li \
 //thickness=0.1 //x=6.21 //y=0.175 //x2=6.04 //y2=0.175
r306 (  78 80 ) resistor r=6.97548 //w=0.367 //l=0.2 //layer=li \
 //thickness=0.1 //x=6.21 //y=0.175 //x2=6.41 //y2=0.175
r307 (  77 129 ) resistor r=5.29055 //w=0.35 //l=0.17 //layer=li \
 //thickness=0.1 //x=9.2 //y=0.175 //x2=9.37 //y2=0.175
r308 (  77 84 ) resistor r=19.8801 //w=0.367 //l=0.57 //layer=li \
 //thickness=0.1 //x=9.2 //y=0.175 //x2=8.63 //y2=0.175
r309 (  67 69 ) resistor r=38.7139 //w=0.367 //l=1.11 //layer=li \
 //thickness=0.1 //x=3.82 //y=0.175 //x2=4.93 //y2=0.175
r310 (  65 127 ) resistor r=5.29055 //w=0.35 //l=0.17 //layer=li \
 //thickness=0.1 //x=2.88 //y=0.175 //x2=2.71 //y2=0.175
r311 (  65 67 ) resistor r=32.7847 //w=0.367 //l=0.94 //layer=li \
 //thickness=0.1 //x=2.88 //y=0.175 //x2=3.82 //y2=0.175
r312 (  64 128 ) resistor r=5.29055 //w=0.35 //l=0.17 //layer=li \
 //thickness=0.1 //x=5.87 //y=0.175 //x2=6.04 //y2=0.175
r313 (  64 69 ) resistor r=32.7847 //w=0.367 //l=0.94 //layer=li \
 //thickness=0.1 //x=5.87 //y=0.175 //x2=4.93 //y2=0.175
r314 (  59 120 ) resistor r=2.96458 //w=0.367 //l=0.085 //layer=li \
 //thickness=0.1 //x=2.175 //y=0.175 //x2=2.09 //y2=0.175
r315 (  59 61 ) resistor r=5.75477 //w=0.367 //l=0.165 //layer=li \
 //thickness=0.1 //x=2.175 //y=0.175 //x2=2.34 //y2=0.175
r316 (  58 127 ) resistor r=5.29055 //w=0.35 //l=0.17 //layer=li \
 //thickness=0.1 //x=2.54 //y=0.175 //x2=2.71 //y2=0.175
r317 (  58 61 ) resistor r=6.97548 //w=0.367 //l=0.2 //layer=li \
 //thickness=0.1 //x=2.54 //y=0.175 //x2=2.34 //y2=0.175
r318 (  54 143 ) resistor r=5.4201 //w=0.17 //l=0.085 //layer=li \
 //thickness=0.1 //x=2.09 //y=0.8 //x2=2.09 //y2=0.715
r319 (  54 143 ) resistor r=41.4118 //w=0.187 //l=0.605 //layer=li \
 //thickness=0.1 //x=2.09 //y=0.8 //x2=2.09 //y2=1.405
r320 (  53 143 ) resistor r=5.4201 //w=0.17 //l=0.085 //layer=li \
 //thickness=0.1 //x=2.09 //y=0.63 //x2=2.09 //y2=0.715
r321 (  52 120 ) resistor r=5.21862 //w=0.35 //l=0.175 //layer=li \
 //thickness=0.1 //x=2.09 //y=0.35 //x2=2.09 //y2=0.175
r322 (  52 53 ) resistor r=19.1658 //w=0.187 //l=0.28 //layer=li \
 //thickness=0.1 //x=2.09 //y=0.35 //x2=2.09 //y2=0.63
r323 (  51 143 ) resistor r=5.4201 //w=0.17 //l=0.085 //layer=li \
 //thickness=0.1 //x=1.685 //y=0.715 //x2=1.6 //y2=0.715
r324 (  50 143 ) resistor r=1.40859 //w=0.34 //l=0.085 //layer=li \
 //thickness=0.1 //x=2.005 //y=0.715 //x2=2.09 //y2=0.715
r325 (  50 51 ) resistor r=21.9037 //w=0.187 //l=0.32 //layer=li \
 //thickness=0.1 //x=2.005 //y=0.715 //x2=1.685 //y2=0.715
r326 (  49 143 ) resistor r=1.40859 //w=0.34 //l=0.085 //layer=li \
 //thickness=0.1 //x=1.6 //y=0.63 //x2=1.6 //y2=0.715
r327 (  48 119 ) resistor r=5.21862 //w=0.35 //l=0.175 //layer=li \
 //thickness=0.1 //x=1.6 //y=0.35 //x2=1.6 //y2=0.175
r328 (  48 49 ) resistor r=19.1658 //w=0.187 //l=0.28 //layer=li \
 //thickness=0.1 //x=1.6 //y=0.35 //x2=1.6 //y2=0.63
r329 (  47 143 ) resistor r=1.40859 //w=0.34 //l=0.085 //layer=li \
 //thickness=0.1 //x=1.205 //y=0.715 //x2=1.12 //y2=0.715
r330 (  46 143 ) resistor r=5.4201 //w=0.17 //l=0.085 //layer=li \
 //thickness=0.1 //x=1.515 //y=0.715 //x2=1.6 //y2=0.715
r331 (  46 47 ) resistor r=21.2193 //w=0.187 //l=0.31 //layer=li \
 //thickness=0.1 //x=1.515 //y=0.715 //x2=1.205 //y2=0.715
r332 (  42 143 ) resistor r=5.4201 //w=0.17 //l=0.085 //layer=li \
 //thickness=0.1 //x=1.12 //y=0.8 //x2=1.12 //y2=0.715
r333 (  42 143 ) resistor r=41.4118 //w=0.187 //l=0.605 //layer=li \
 //thickness=0.1 //x=1.12 //y=0.8 //x2=1.12 //y2=1.405
r334 (  41 143 ) resistor r=5.4201 //w=0.17 //l=0.085 //layer=li \
 //thickness=0.1 //x=1.12 //y=0.63 //x2=1.12 //y2=0.715
r335 (  40 116 ) resistor r=5.21862 //w=0.35 //l=0.175 //layer=li \
 //thickness=0.1 //x=1.12 //y=0.35 //x2=1.12 //y2=0.175
r336 (  40 41 ) resistor r=19.1658 //w=0.187 //l=0.28 //layer=li \
 //thickness=0.1 //x=1.12 //y=0.35 //x2=1.12 //y2=0.63
r337 (  35 145 ) resistor r=9.3 //w=0.17 //l=0.17 //layer=mcon //count=1 \
 //x=7.22 //y=1.135 //x2=7.22 //y2=1.135
r338 (  32 144 ) resistor r=9.3 //w=0.17 //l=0.17 //layer=mcon //count=1 \
 //x=3.89 //y=1.135 //x2=3.89 //y2=1.135
r339 (  30 67 ) resistor r=3.1 //w=0.17 //l=0.51 //layer=mcon //count=3 \
 //x=3.82 //y=0.18 //x2=3.82 //y2=0.18
r340 (  27 135 ) resistor r=4.65 //w=0.17 //l=0.34 //layer=mcon //count=2 \
 //x=10.85 //y=0.18 //x2=10.85 //y2=0.18
r341 (  25 132 ) resistor r=3.1 //w=0.17 //l=0.51 //layer=mcon //count=3 \
 //x=10.11 //y=0.18 //x2=10.11 //y2=0.18
r342 (  25 27 ) resistor r=0.297428 //w=0.311 //l=0.74 //layer=m1 \
 //thickness=0.36 //x=10.11 //y=0.175 //x2=10.85 //y2=0.175
r343 (  23 84 ) resistor r=3.1 //w=0.17 //l=0.51 //layer=mcon //count=3 \
 //x=8.63 //y=0.18 //x2=8.63 //y2=0.18
r344 (  23 25 ) resistor r=0.594855 //w=0.311 //l=1.48 //layer=m1 \
 //thickness=0.36 //x=8.63 //y=0.175 //x2=10.11 //y2=0.175
r345 (  21 82 ) resistor r=3.1 //w=0.17 //l=0.51 //layer=mcon //count=3 \
 //x=7.52 //y=0.18 //x2=7.52 //y2=0.18
r346 (  21 23 ) resistor r=0.446141 //w=0.311 //l=1.11 //layer=m1 \
 //thickness=0.36 //x=7.52 //y=0.175 //x2=8.63 //y2=0.175
r347 (  19 33 ) resistor r=0.028033 //w=0.35 //l=0.085 //layer=m1 \
 //thickness=0.36 //x=7.305 //y=0.175 //x2=7.22 //y2=0.175
r348 (  19 21 ) resistor r=0.0864148 //w=0.311 //l=0.215 //layer=m1 \
 //thickness=0.36 //x=7.305 //y=0.175 //x2=7.52 //y2=0.175
r349 (  18 35 ) resistor r=0.0706968 //w=0.24 //l=0.115996 //layer=m1 \
 //thickness=0.36 //x=7.22 //y=1.02 //x2=7.222 //y2=1.135
r350 (  17 33 ) resistor r=0.0413265 //w=0.7 //l=0.175 //layer=m1 \
 //thickness=0.36 //x=7.22 //y=0.35 //x2=7.22 //y2=0.175
r351 (  17 18 ) resistor r=0.639313 //w=0.131 //l=0.67 //layer=m1 \
 //thickness=0.36 //x=7.22 //y=0.35 //x2=7.22 //y2=1.02
r352 (  16 80 ) resistor r=3.1 //w=0.17 //l=0.51 //layer=mcon //count=3 \
 //x=6.41 //y=0.18 //x2=6.41 //y2=0.18
r353 (  13 69 ) resistor r=3.1 //w=0.17 //l=0.51 //layer=mcon //count=3 \
 //x=4.93 //y=0.18 //x2=4.93 //y2=0.18
r354 (  11 30 ) resistor r=0.028033 //w=0.35 //l=0.085 //layer=m1 \
 //thickness=0.36 //x=3.975 //y=0.175 //x2=3.89 //y2=0.175
r355 (  11 13 ) resistor r=0.383842 //w=0.311 //l=0.955 //layer=m1 \
 //thickness=0.36 //x=3.975 //y=0.175 //x2=4.93 //y2=0.175
r356 (  10 33 ) resistor r=0.028033 //w=0.35 //l=0.085 //layer=m1 \
 //thickness=0.36 //x=7.135 //y=0.175 //x2=7.22 //y2=0.175
r357 (  10 16 ) resistor r=0.291399 //w=0.311 //l=0.725 //layer=m1 \
 //thickness=0.36 //x=7.135 //y=0.175 //x2=6.41 //y2=0.175
r358 (  9 32 ) resistor r=0.0717383 //w=0.224 //l=0.115996 //layer=m1 \
 //thickness=0.36 //x=3.89 //y=1.02 //x2=3.892 //y2=1.135
r359 (  8 30 ) resistor r=0.0413265 //w=0.7 //l=0.175 //layer=m1 \
 //thickness=0.36 //x=3.89 //y=0.35 //x2=3.89 //y2=0.175
r360 (  8 9 ) resistor r=0.639313 //w=0.131 //l=0.67 //layer=m1 \
 //thickness=0.36 //x=3.89 //y=0.35 //x2=3.89 //y2=1.02
r361 (  7 61 ) resistor r=3.1 //w=0.17 //l=0.51 //layer=mcon //count=3 \
 //x=2.34 //y=0.18 //x2=2.34 //y2=0.18
r362 (  4 118 ) resistor r=3.1 //w=0.17 //l=0.51 //layer=mcon //count=3 \
 //x=1.23 //y=0.18 //x2=1.23 //y2=0.18
r363 (  4 7 ) resistor r=0.446141 //w=0.311 //l=1.11 //layer=m1 \
 //thickness=0.36 //x=1.23 //y=0.175 //x2=2.34 //y2=0.175
r364 (  2 30 ) resistor r=0.028033 //w=0.35 //l=0.085 //layer=m1 \
 //thickness=0.36 //x=3.805 //y=0.175 //x2=3.89 //y2=0.175
r365 (  2 7 ) resistor r=0.588826 //w=0.311 //l=1.465 //layer=m1 \
 //thickness=0.36 //x=3.805 //y=0.175 //x2=2.34 //y2=0.175
r366 (  1 16 ) resistor r=0.148714 //w=0.311 //l=0.37 //layer=m1 \
 //thickness=0.36 //x=6.04 //y=0.175 //x2=6.41 //y2=0.175
r367 (  1 13 ) resistor r=0.446141 //w=0.311 //l=1.11 //layer=m1 \
 //thickness=0.36 //x=6.04 //y=0.175 //x2=4.93 //y2=0.175
ends PM_XNOR2X1\%GND

subckt PM_XNOR2X1\%noxref_10 ( 1 5 9 10 13 17 29 )
c64 ( 29 0 ) capacitor c=0.0663009f //x=3.27 //y=0.545
c65 ( 17 0 ) capacitor c=0.0067865f //x=5.345 //y=0.795
c66 ( 13 0 ) capacitor c=0.0160083f //x=5.26 //y=0.71
c67 ( 10 0 ) capacitor c=0.0074164f //x=4.375 //y=1.675
c68 ( 9 0 ) capacitor c=0.00770028f //x=4.375 //y=0.795
c69 ( 5 0 ) capacitor c=0.0183582f //x=4.29 //y=1.76
c70 ( 1 0 ) capacitor c=0.00784861f //x=3.405 //y=1.675
r71 (  17 29 ) resistor r=3.57586 //w=0.17 //l=0.125 //layer=li \
 //thickness=0.1 //x=5.345 //y=0.795 //x2=5.345 //y2=0.67
r72 (  17 29 ) resistor r=18.139 //w=0.187 //l=0.265 //layer=li \
 //thickness=0.1 //x=5.345 //y=0.795 //x2=5.345 //y2=1.06
r73 (  14 29 ) resistor r=3.57586 //w=0.17 //l=0.103078 //layer=li \
 //thickness=0.1 //x=4.46 //y=0.71 //x2=4.375 //y2=0.67
r74 (  14 29 ) resistor r=27.3797 //w=0.187 //l=0.4 //layer=li //thickness=0.1 \
 //x=4.46 //y=0.71 //x2=4.86 //y2=0.71
r75 (  13 29 ) resistor r=3.57586 //w=0.17 //l=0.103078 //layer=li \
 //thickness=0.1 //x=5.26 //y=0.71 //x2=5.345 //y2=0.67
r76 (  13 29 ) resistor r=27.3797 //w=0.187 //l=0.4 //layer=li //thickness=0.1 \
 //x=5.26 //y=0.71 //x2=4.86 //y2=0.71
r77 (  10 29 ) resistor r=3.57586 //w=0.17 //l=0.125 //layer=li \
 //thickness=0.1 //x=4.375 //y=1.675 //x2=4.375 //y2=1.8
r78 (  10 29 ) resistor r=42.0963 //w=0.187 //l=0.615 //layer=li \
 //thickness=0.1 //x=4.375 //y=1.675 //x2=4.375 //y2=1.06
r79 (  9 29 ) resistor r=3.57586 //w=0.17 //l=0.125 //layer=li //thickness=0.1 \
 //x=4.375 //y=0.795 //x2=4.375 //y2=0.67
r80 (  9 29 ) resistor r=18.139 //w=0.187 //l=0.265 //layer=li //thickness=0.1 \
 //x=4.375 //y=0.795 //x2=4.375 //y2=1.06
r81 (  6 29 ) resistor r=3.57586 //w=0.17 //l=0.103078 //layer=li \
 //thickness=0.1 //x=3.49 //y=1.76 //x2=3.405 //y2=1.8
r82 (  6 29 ) resistor r=27.3797 //w=0.187 //l=0.4 //layer=li //thickness=0.1 \
 //x=3.49 //y=1.76 //x2=3.89 //y2=1.76
r83 (  5 29 ) resistor r=3.57586 //w=0.17 //l=0.103078 //layer=li \
 //thickness=0.1 //x=4.29 //y=1.76 //x2=4.375 //y2=1.8
r84 (  5 29 ) resistor r=27.3797 //w=0.187 //l=0.4 //layer=li //thickness=0.1 \
 //x=4.29 //y=1.76 //x2=3.89 //y2=1.76
r85 (  1 29 ) resistor r=3.57586 //w=0.17 //l=0.125 //layer=li //thickness=0.1 \
 //x=3.405 //y=1.675 //x2=3.405 //y2=1.8
r86 (  1 29 ) resistor r=42.0963 //w=0.187 //l=0.615 //layer=li \
 //thickness=0.1 //x=3.405 //y=1.675 //x2=3.405 //y2=1.06
ends PM_XNOR2X1\%noxref_10

subckt PM_XNOR2X1\%noxref_11 ( 1 5 9 10 13 17 29 )
c68 ( 29 0 ) capacitor c=0.0663668f //x=6.6 //y=0.545
c69 ( 17 0 ) capacitor c=0.00709791f //x=8.675 //y=0.795
c70 ( 13 0 ) capacitor c=0.0159758f //x=8.59 //y=0.71
c71 ( 10 0 ) capacitor c=0.00742979f //x=7.705 //y=1.675
c72 ( 9 0 ) capacitor c=0.00770028f //x=7.705 //y=0.795
c73 ( 5 0 ) capacitor c=0.0182764f //x=7.62 //y=1.76
c74 ( 1 0 ) capacitor c=0.00773201f //x=6.735 //y=1.675
r75 (  17 29 ) resistor r=3.57586 //w=0.17 //l=0.125 //layer=li \
 //thickness=0.1 //x=8.675 //y=0.795 //x2=8.675 //y2=0.67
r76 (  17 29 ) resistor r=18.139 //w=0.187 //l=0.265 //layer=li \
 //thickness=0.1 //x=8.675 //y=0.795 //x2=8.675 //y2=1.06
r77 (  14 29 ) resistor r=3.57586 //w=0.17 //l=0.103078 //layer=li \
 //thickness=0.1 //x=7.79 //y=0.71 //x2=7.705 //y2=0.67
r78 (  14 29 ) resistor r=27.3797 //w=0.187 //l=0.4 //layer=li //thickness=0.1 \
 //x=7.79 //y=0.71 //x2=8.19 //y2=0.71
r79 (  13 29 ) resistor r=3.57586 //w=0.17 //l=0.103078 //layer=li \
 //thickness=0.1 //x=8.59 //y=0.71 //x2=8.675 //y2=0.67
r80 (  13 29 ) resistor r=27.3797 //w=0.187 //l=0.4 //layer=li //thickness=0.1 \
 //x=8.59 //y=0.71 //x2=8.19 //y2=0.71
r81 (  10 29 ) resistor r=3.57586 //w=0.17 //l=0.125 //layer=li \
 //thickness=0.1 //x=7.705 //y=1.675 //x2=7.705 //y2=1.8
r82 (  10 29 ) resistor r=42.0963 //w=0.187 //l=0.615 //layer=li \
 //thickness=0.1 //x=7.705 //y=1.675 //x2=7.705 //y2=1.06
r83 (  9 29 ) resistor r=3.57586 //w=0.17 //l=0.125 //layer=li //thickness=0.1 \
 //x=7.705 //y=0.795 //x2=7.705 //y2=0.67
r84 (  9 29 ) resistor r=18.139 //w=0.187 //l=0.265 //layer=li //thickness=0.1 \
 //x=7.705 //y=0.795 //x2=7.705 //y2=1.06
r85 (  6 29 ) resistor r=3.57586 //w=0.17 //l=0.103078 //layer=li \
 //thickness=0.1 //x=6.82 //y=1.76 //x2=6.735 //y2=1.8
r86 (  6 29 ) resistor r=27.3797 //w=0.187 //l=0.4 //layer=li //thickness=0.1 \
 //x=6.82 //y=1.76 //x2=7.22 //y2=1.76
r87 (  5 29 ) resistor r=3.57586 //w=0.17 //l=0.103078 //layer=li \
 //thickness=0.1 //x=7.62 //y=1.76 //x2=7.705 //y2=1.8
r88 (  5 29 ) resistor r=27.3797 //w=0.187 //l=0.4 //layer=li //thickness=0.1 \
 //x=7.62 //y=1.76 //x2=7.22 //y2=1.76
r89 (  1 29 ) resistor r=3.57586 //w=0.17 //l=0.125 //layer=li //thickness=0.1 \
 //x=6.735 //y=1.675 //x2=6.735 //y2=1.8
r90 (  1 29 ) resistor r=42.0963 //w=0.187 //l=0.615 //layer=li \
 //thickness=0.1 //x=6.735 //y=1.675 //x2=6.735 //y2=1.06
ends PM_XNOR2X1\%noxref_11
