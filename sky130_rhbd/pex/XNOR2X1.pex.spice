// File: XNOR2X1.spi.pex
// Created: Tue Apr 29 10:47:03 2025
// Program "Calibre xRC"
// Version "v2023.2_27.15"
// Nominal Temperature: 30C
// Circuit Temperature: 30C
//
simulator lang=spectre
subckt PM_XNOR2X1\%GND ( 1 21 33 37 40 45 51 57 63 71 79 82 87 91 103 114 117 \
 119 126 133 134 135 136 )
c167 ( 136 0 ) capacitor c=0.0584538f //x=9.865 //y=0.55
c168 ( 135 0 ) capacitor c=0.0207675f //x=7.03 //y=1.045
c169 ( 134 0 ) capacitor c=0.0207675f //x=3.7 //y=1.045
c170 ( 133 0 ) capacitor c=0.0582171f //x=0.985 //y=0.55
c171 ( 126 0 ) capacitor c=0.248641f //x=10.96 //y=0.175
c172 ( 119 0 ) capacitor c=0.103675f //x=9.37 //y=0.175
c173 ( 118 0 ) capacitor c=0.00446416f //x=7.22 //y=0.175
c174 ( 117 0 ) capacitor c=0.104652f //x=6.04 //y=0.175
c175 ( 116 0 ) capacitor c=0.00446416f //x=3.82 //y=0.18
c176 ( 114 0 ) capacitor c=0.102529f //x=2.71 //y=0.175
c177 ( 103 0 ) capacitor c=0.211321f //x=1.12 //y=0.175
c178 ( 94 0 ) capacitor c=0.00588377f //x=10.96 //y=0.63
c179 ( 91 0 ) capacitor c=0.00649591f //x=10.875 //y=0.715
c180 ( 90 0 ) capacitor c=0.00479856f //x=10.475 //y=0.63
c181 ( 87 0 ) capacitor c=0.00533045f //x=10.39 //y=0.715
c182 ( 82 0 ) capacitor c=0.00583665f //x=9.99 //y=0.63
c183 ( 79 0 ) capacitor c=0.0161513f //x=9.905 //y=0.175
c184 ( 71 0 ) capacitor c=0.0727615f //x=9.2 //y=0.175
c185 ( 63 0 ) capacitor c=0.0392556f //x=7.135 //y=0.175
c186 ( 57 0 ) capacitor c=0.0727453f //x=5.87 //y=0.175
c187 ( 51 0 ) capacitor c=0.0392556f //x=3.805 //y=0.175
c188 ( 46 0 ) capacitor c=0.0366794f //x=2.175 //y=0.175
c189 ( 45 0 ) capacitor c=0.0161513f //x=2.54 //y=0.175
c190 ( 40 0 ) capacitor c=0.00583665f //x=2.09 //y=0.63
c191 ( 37 0 ) capacitor c=0.0053436f //x=2.005 //y=0.715
c192 ( 36 0 ) capacitor c=0.00479856f //x=1.605 //y=0.63
c193 ( 33 0 ) capacitor c=0.00707849f //x=1.52 //y=0.715
c194 ( 28 0 ) capacitor c=0.00592191f //x=1.12 //y=0.63
c195 ( 21 0 ) capacitor c=0.424344f //x=10.85 //y=0.18
r196 (  125 126 ) resistor r=3.83651 //w=0.367 //l=0.11 //layer=li \
 //thickness=0.1 //x=10.85 //y=0.175 //x2=10.96 //y2=0.175
r197 (  123 125 ) resistor r=13.079 //w=0.367 //l=0.375 //layer=li \
 //thickness=0.1 //x=10.475 //y=0.175 //x2=10.85 //y2=0.175
r198 (  122 123 ) resistor r=12.7302 //w=0.367 //l=0.365 //layer=li \
 //thickness=0.1 //x=10.11 //y=0.175 //x2=10.475 //y2=0.175
r199 (  120 122 ) resistor r=4.18529 //w=0.367 //l=0.12 //layer=li \
 //thickness=0.1 //x=9.99 //y=0.175 //x2=10.11 //y2=0.175
r200 (  106 107 ) resistor r=16.9155 //w=0.367 //l=0.485 //layer=li \
 //thickness=0.1 //x=1.605 //y=0.175 //x2=2.09 //y2=0.175
r201 (  105 106 ) resistor r=13.079 //w=0.367 //l=0.375 //layer=li \
 //thickness=0.1 //x=1.23 //y=0.175 //x2=1.605 //y2=0.175
r202 (  103 105 ) resistor r=3.83651 //w=0.367 //l=0.11 //layer=li \
 //thickness=0.1 //x=1.12 //y=0.175 //x2=1.23 //y2=0.175
r203 (  95 136 ) resistor r=5.4201 //w=0.17 //l=0.085 //layer=li \
 //thickness=0.1 //x=10.96 //y=0.8 //x2=10.96 //y2=0.715
r204 (  95 136 ) resistor r=41.4118 //w=0.187 //l=0.605 //layer=li \
 //thickness=0.1 //x=10.96 //y=0.8 //x2=10.96 //y2=1.405
r205 (  94 136 ) resistor r=5.4201 //w=0.17 //l=0.085 //layer=li \
 //thickness=0.1 //x=10.96 //y=0.63 //x2=10.96 //y2=0.715
r206 (  93 126 ) resistor r=5.21862 //w=0.35 //l=0.175 //layer=li \
 //thickness=0.1 //x=10.96 //y=0.35 //x2=10.96 //y2=0.175
r207 (  93 94 ) resistor r=19.1658 //w=0.187 //l=0.28 //layer=li \
 //thickness=0.1 //x=10.96 //y=0.35 //x2=10.96 //y2=0.63
r208 (  92 136 ) resistor r=5.4201 //w=0.17 //l=0.085 //layer=li \
 //thickness=0.1 //x=10.56 //y=0.715 //x2=10.475 //y2=0.715
r209 (  91 136 ) resistor r=1.40859 //w=0.34 //l=0.085 //layer=li \
 //thickness=0.1 //x=10.875 //y=0.715 //x2=10.96 //y2=0.715
r210 (  91 92 ) resistor r=21.5615 //w=0.187 //l=0.315 //layer=li \
 //thickness=0.1 //x=10.875 //y=0.715 //x2=10.56 //y2=0.715
r211 (  90 136 ) resistor r=1.40859 //w=0.34 //l=0.085 //layer=li \
 //thickness=0.1 //x=10.475 //y=0.63 //x2=10.475 //y2=0.715
r212 (  89 123 ) resistor r=5.21862 //w=0.35 //l=0.175 //layer=li \
 //thickness=0.1 //x=10.475 //y=0.35 //x2=10.475 //y2=0.175
r213 (  89 90 ) resistor r=19.1658 //w=0.187 //l=0.28 //layer=li \
 //thickness=0.1 //x=10.475 //y=0.35 //x2=10.475 //y2=0.63
r214 (  88 136 ) resistor r=1.40859 //w=0.34 //l=0.085 //layer=li \
 //thickness=0.1 //x=10.075 //y=0.715 //x2=9.99 //y2=0.715
r215 (  87 136 ) resistor r=5.4201 //w=0.17 //l=0.085 //layer=li \
 //thickness=0.1 //x=10.39 //y=0.715 //x2=10.475 //y2=0.715
r216 (  87 88 ) resistor r=21.5615 //w=0.187 //l=0.315 //layer=li \
 //thickness=0.1 //x=10.39 //y=0.715 //x2=10.075 //y2=0.715
r217 (  83 136 ) resistor r=5.4201 //w=0.17 //l=0.085 //layer=li \
 //thickness=0.1 //x=9.99 //y=0.8 //x2=9.99 //y2=0.715
r218 (  83 136 ) resistor r=41.4118 //w=0.187 //l=0.605 //layer=li \
 //thickness=0.1 //x=9.99 //y=0.8 //x2=9.99 //y2=1.405
r219 (  82 136 ) resistor r=5.4201 //w=0.17 //l=0.085 //layer=li \
 //thickness=0.1 //x=9.99 //y=0.63 //x2=9.99 //y2=0.715
r220 (  81 120 ) resistor r=5.21862 //w=0.35 //l=0.175 //layer=li \
 //thickness=0.1 //x=9.99 //y=0.35 //x2=9.99 //y2=0.175
r221 (  81 82 ) resistor r=19.1658 //w=0.187 //l=0.28 //layer=li \
 //thickness=0.1 //x=9.99 //y=0.35 //x2=9.99 //y2=0.63
r222 (  80 119 ) resistor r=5.29055 //w=0.35 //l=0.17 //layer=li \
 //thickness=0.1 //x=9.54 //y=0.175 //x2=9.37 //y2=0.175
r223 (  79 120 ) resistor r=2.96458 //w=0.367 //l=0.085 //layer=li \
 //thickness=0.1 //x=9.905 //y=0.175 //x2=9.99 //y2=0.175
r224 (  79 80 ) resistor r=12.7302 //w=0.367 //l=0.365 //layer=li \
 //thickness=0.1 //x=9.905 //y=0.175 //x2=9.54 //y2=0.175
r225 (  74 76 ) resistor r=38.7139 //w=0.367 //l=1.11 //layer=li \
 //thickness=0.1 //x=7.52 //y=0.175 //x2=8.63 //y2=0.175
r226 (  72 118 ) resistor r=2.87058 //w=0.35 //l=0.085 //layer=li \
 //thickness=0.1 //x=7.305 //y=0.175 //x2=7.22 //y2=0.175
r227 (  72 74 ) resistor r=7.49864 //w=0.367 //l=0.215 //layer=li \
 //thickness=0.1 //x=7.305 //y=0.175 //x2=7.52 //y2=0.175
r228 (  71 119 ) resistor r=5.29055 //w=0.35 //l=0.17 //layer=li \
 //thickness=0.1 //x=9.2 //y=0.175 //x2=9.37 //y2=0.175
r229 (  71 76 ) resistor r=19.8801 //w=0.367 //l=0.57 //layer=li \
 //thickness=0.1 //x=9.2 //y=0.175 //x2=8.63 //y2=0.175
r230 (  67 118 ) resistor r=4.23183 //w=0.7 //l=0.175 //layer=li \
 //thickness=0.1 //x=7.22 //y=0.35 //x2=7.22 //y2=0.175
r231 (  67 135 ) resistor r=53.7326 //w=0.187 //l=0.785 //layer=li \
 //thickness=0.1 //x=7.22 //y=0.35 //x2=7.22 //y2=1.135
r232 (  64 117 ) resistor r=5.29055 //w=0.35 //l=0.17 //layer=li \
 //thickness=0.1 //x=6.21 //y=0.175 //x2=6.04 //y2=0.175
r233 (  64 66 ) resistor r=6.97548 //w=0.367 //l=0.2 //layer=li \
 //thickness=0.1 //x=6.21 //y=0.175 //x2=6.41 //y2=0.175
r234 (  63 118 ) resistor r=2.87058 //w=0.35 //l=0.085 //layer=li \
 //thickness=0.1 //x=7.135 //y=0.175 //x2=7.22 //y2=0.175
r235 (  63 66 ) resistor r=25.2861 //w=0.367 //l=0.725 //layer=li \
 //thickness=0.1 //x=7.135 //y=0.175 //x2=6.41 //y2=0.175
r236 (  58 116 ) resistor r=2.87058 //w=0.35 //l=0.085 //layer=li \
 //thickness=0.1 //x=3.975 //y=0.175 //x2=3.89 //y2=0.175
r237 (  58 60 ) resistor r=33.3079 //w=0.367 //l=0.955 //layer=li \
 //thickness=0.1 //x=3.975 //y=0.175 //x2=4.93 //y2=0.175
r238 (  57 117 ) resistor r=5.29055 //w=0.35 //l=0.17 //layer=li \
 //thickness=0.1 //x=5.87 //y=0.175 //x2=6.04 //y2=0.175
r239 (  57 60 ) resistor r=32.7847 //w=0.367 //l=0.94 //layer=li \
 //thickness=0.1 //x=5.87 //y=0.175 //x2=4.93 //y2=0.175
r240 (  53 116 ) resistor r=4.23183 //w=0.7 //l=0.175 //layer=li \
 //thickness=0.1 //x=3.89 //y=0.35 //x2=3.89 //y2=0.175
r241 (  53 134 ) resistor r=53.7326 //w=0.187 //l=0.785 //layer=li \
 //thickness=0.1 //x=3.89 //y=0.35 //x2=3.89 //y2=1.135
r242 (  52 114 ) resistor r=5.29055 //w=0.35 //l=0.17 //layer=li \
 //thickness=0.1 //x=2.88 //y=0.175 //x2=2.71 //y2=0.175
r243 (  51 116 ) resistor r=2.87058 //w=0.35 //l=0.085 //layer=li \
 //thickness=0.1 //x=3.805 //y=0.175 //x2=3.89 //y2=0.175
r244 (  51 52 ) resistor r=32.2616 //w=0.367 //l=0.925 //layer=li \
 //thickness=0.1 //x=3.805 //y=0.175 //x2=2.88 //y2=0.175
r245 (  46 107 ) resistor r=2.96458 //w=0.367 //l=0.085 //layer=li \
 //thickness=0.1 //x=2.175 //y=0.175 //x2=2.09 //y2=0.175
r246 (  46 48 ) resistor r=5.75477 //w=0.367 //l=0.165 //layer=li \
 //thickness=0.1 //x=2.175 //y=0.175 //x2=2.34 //y2=0.175
r247 (  45 114 ) resistor r=5.29055 //w=0.35 //l=0.17 //layer=li \
 //thickness=0.1 //x=2.54 //y=0.175 //x2=2.71 //y2=0.175
r248 (  45 48 ) resistor r=6.97548 //w=0.367 //l=0.2 //layer=li \
 //thickness=0.1 //x=2.54 //y=0.175 //x2=2.34 //y2=0.175
r249 (  41 133 ) resistor r=5.4201 //w=0.17 //l=0.085 //layer=li \
 //thickness=0.1 //x=2.09 //y=0.8 //x2=2.09 //y2=0.715
r250 (  41 133 ) resistor r=41.4118 //w=0.187 //l=0.605 //layer=li \
 //thickness=0.1 //x=2.09 //y=0.8 //x2=2.09 //y2=1.405
r251 (  40 133 ) resistor r=5.4201 //w=0.17 //l=0.085 //layer=li \
 //thickness=0.1 //x=2.09 //y=0.63 //x2=2.09 //y2=0.715
r252 (  39 107 ) resistor r=5.21862 //w=0.35 //l=0.175 //layer=li \
 //thickness=0.1 //x=2.09 //y=0.35 //x2=2.09 //y2=0.175
r253 (  39 40 ) resistor r=19.1658 //w=0.187 //l=0.28 //layer=li \
 //thickness=0.1 //x=2.09 //y=0.35 //x2=2.09 //y2=0.63
r254 (  38 133 ) resistor r=5.4201 //w=0.17 //l=0.085 //layer=li \
 //thickness=0.1 //x=1.69 //y=0.715 //x2=1.605 //y2=0.715
r255 (  37 133 ) resistor r=1.40859 //w=0.34 //l=0.085 //layer=li \
 //thickness=0.1 //x=2.005 //y=0.715 //x2=2.09 //y2=0.715
r256 (  37 38 ) resistor r=21.5615 //w=0.187 //l=0.315 //layer=li \
 //thickness=0.1 //x=2.005 //y=0.715 //x2=1.69 //y2=0.715
r257 (  36 133 ) resistor r=1.40859 //w=0.34 //l=0.085 //layer=li \
 //thickness=0.1 //x=1.605 //y=0.63 //x2=1.605 //y2=0.715
r258 (  35 106 ) resistor r=5.21862 //w=0.35 //l=0.175 //layer=li \
 //thickness=0.1 //x=1.605 //y=0.35 //x2=1.605 //y2=0.175
r259 (  35 36 ) resistor r=19.1658 //w=0.187 //l=0.28 //layer=li \
 //thickness=0.1 //x=1.605 //y=0.35 //x2=1.605 //y2=0.63
r260 (  34 133 ) resistor r=1.40859 //w=0.34 //l=0.085 //layer=li \
 //thickness=0.1 //x=1.205 //y=0.715 //x2=1.12 //y2=0.715
r261 (  33 133 ) resistor r=5.4201 //w=0.17 //l=0.085 //layer=li \
 //thickness=0.1 //x=1.52 //y=0.715 //x2=1.605 //y2=0.715
r262 (  33 34 ) resistor r=21.5615 //w=0.187 //l=0.315 //layer=li \
 //thickness=0.1 //x=1.52 //y=0.715 //x2=1.205 //y2=0.715
r263 (  29 133 ) resistor r=5.4201 //w=0.17 //l=0.085 //layer=li \
 //thickness=0.1 //x=1.12 //y=0.8 //x2=1.12 //y2=0.715
r264 (  29 133 ) resistor r=41.4118 //w=0.187 //l=0.605 //layer=li \
 //thickness=0.1 //x=1.12 //y=0.8 //x2=1.12 //y2=1.405
r265 (  28 133 ) resistor r=5.4201 //w=0.17 //l=0.085 //layer=li \
 //thickness=0.1 //x=1.12 //y=0.63 //x2=1.12 //y2=0.715
r266 (  27 103 ) resistor r=5.21862 //w=0.35 //l=0.175 //layer=li \
 //thickness=0.1 //x=1.12 //y=0.35 //x2=1.12 //y2=0.175
r267 (  27 28 ) resistor r=19.1658 //w=0.187 //l=0.28 //layer=li \
 //thickness=0.1 //x=1.12 //y=0.35 //x2=1.12 //y2=0.63
r268 (  21 125 ) resistor r=4.65 //w=0.17 //l=0.34 //layer=mcon //count=2 \
 //x=10.85 //y=0.18 //x2=10.85 //y2=0.18
r269 (  19 122 ) resistor r=3.1 //w=0.17 //l=0.51 //layer=mcon //count=3 \
 //x=10.11 //y=0.18 //x2=10.11 //y2=0.18
r270 (  19 21 ) resistor r=0.297428 //w=0.311 //l=0.74 //layer=m1 \
 //thickness=0.36 //x=10.11 //y=0.175 //x2=10.85 //y2=0.175
r271 (  17 76 ) resistor r=3.1 //w=0.17 //l=0.51 //layer=mcon //count=3 \
 //x=8.63 //y=0.18 //x2=8.63 //y2=0.18
r272 (  17 19 ) resistor r=0.594855 //w=0.311 //l=1.48 //layer=m1 \
 //thickness=0.36 //x=8.63 //y=0.175 //x2=10.11 //y2=0.175
r273 (  15 74 ) resistor r=3.1 //w=0.17 //l=0.51 //layer=mcon //count=3 \
 //x=7.52 //y=0.18 //x2=7.52 //y2=0.18
r274 (  15 17 ) resistor r=0.446141 //w=0.311 //l=1.11 //layer=m1 \
 //thickness=0.36 //x=7.52 //y=0.175 //x2=8.63 //y2=0.175
r275 (  13 66 ) resistor r=3.1 //w=0.17 //l=0.51 //layer=mcon //count=3 \
 //x=6.41 //y=0.18 //x2=6.41 //y2=0.18
r276 (  13 15 ) resistor r=0.446141 //w=0.311 //l=1.11 //layer=m1 \
 //thickness=0.36 //x=6.41 //y=0.175 //x2=7.52 //y2=0.175
r277 (  10 60 ) resistor r=3.1 //w=0.17 //l=0.51 //layer=mcon //count=3 \
 //x=4.93 //y=0.18 //x2=4.93 //y2=0.18
r278 (  8 116 ) resistor r=3.1 //w=0.17 //l=0.51 //layer=mcon //count=3 \
 //x=3.82 //y=0.18 //x2=3.82 //y2=0.18
r279 (  8 10 ) resistor r=0.446141 //w=0.311 //l=1.11 //layer=m1 \
 //thickness=0.36 //x=3.82 //y=0.175 //x2=4.93 //y2=0.175
r280 (  6 48 ) resistor r=3.1 //w=0.17 //l=0.51 //layer=mcon //count=3 \
 //x=2.34 //y=0.18 //x2=2.34 //y2=0.18
r281 (  6 8 ) resistor r=0.594855 //w=0.311 //l=1.48 //layer=m1 \
 //thickness=0.36 //x=2.34 //y=0.175 //x2=3.82 //y2=0.175
r282 (  3 105 ) resistor r=3.1 //w=0.17 //l=0.51 //layer=mcon //count=3 \
 //x=1.23 //y=0.18 //x2=1.23 //y2=0.18
r283 (  3 6 ) resistor r=0.446141 //w=0.311 //l=1.11 //layer=m1 \
 //thickness=0.36 //x=1.23 //y=0.175 //x2=2.34 //y2=0.175
r284 (  1 13 ) resistor r=0.148714 //w=0.311 //l=0.37 //layer=m1 \
 //thickness=0.36 //x=6.04 //y=0.175 //x2=6.41 //y2=0.175
r285 (  1 10 ) resistor r=0.446141 //w=0.311 //l=1.11 //layer=m1 \
 //thickness=0.36 //x=6.04 //y=0.175 //x2=4.93 //y2=0.175
ends PM_XNOR2X1\%GND

subckt PM_XNOR2X1\%VDD ( 1 21 33 41 47 55 61 69 77 85 98 100 102 104 108 109 \
 110 111 112 113 114 )
c158 ( 114 0 ) capacitor c=0.0421444f //x=10.77 //y=5.2
c159 ( 113 0 ) capacitor c=0.0432441f //x=9.91 //y=5.2
c160 ( 112 0 ) capacitor c=0.0266033f //x=7.125 //y=5.2
c161 ( 111 0 ) capacitor c=0.0265297f //x=3.795 //y=5.2
c162 ( 110 0 ) capacitor c=0.0432965f //x=1.9 //y=5.2
c163 ( 109 0 ) capacitor c=0.0421444f //x=1.03 //y=5.2
c164 ( 108 0 ) capacitor c=0.251732f //x=10.85 //y=7.58
c165 ( 106 0 ) capacitor c=0.00597439f //x=10.11 //y=7.58
c166 ( 104 0 ) capacitor c=0.105769f //x=9.37 //y=7.585
c167 ( 103 0 ) capacitor c=0.00597439f //x=7.27 //y=7.585
c168 ( 102 0 ) capacitor c=0.111887f //x=6.04 //y=7.585
c169 ( 101 0 ) capacitor c=0.00597439f //x=3.94 //y=7.585
c170 ( 100 0 ) capacitor c=0.111682f //x=2.71 //y=7.585
c171 ( 99 0 ) capacitor c=0.00597439f //x=2.045 //y=7.585
c172 ( 98 0 ) capacitor c=0.25188f //x=1.23 //y=7.58
c173 ( 85 0 ) capacitor c=0.0292264f //x=10.83 //y=7.585
c174 ( 77 0 ) capacitor c=0.0183091f //x=9.95 //y=7.585
c175 ( 69 0 ) capacitor c=0.075456f //x=9.2 //y=7.585
c176 ( 61 0 ) capacitor c=0.0432521f //x=7.185 //y=7.585
c177 ( 55 0 ) capacitor c=0.0753262f //x=5.87 //y=7.585
c178 ( 47 0 ) capacitor c=0.0432541f //x=3.855 //y=7.585
c179 ( 41 0 ) capacitor c=0.0183091f //x=2.54 //y=7.585
c180 ( 33 0 ) capacitor c=0.0293728f //x=1.96 //y=7.585
c181 ( 21 0 ) capacitor c=0.436375f //x=10.85 //y=7.58
r182 (  87 108 ) resistor r=4.23183 //w=0.7 //l=0.175 //layer=li \
 //thickness=0.1 //x=10.915 //y=7.41 //x2=10.915 //y2=7.585
r183 (  87 114 ) resistor r=56.4706 //w=0.187 //l=0.825 //layer=li \
 //thickness=0.1 //x=10.915 //y=7.41 //x2=10.915 //y2=6.585
r184 (  86 106 ) resistor r=2.87058 //w=0.35 //l=0.085 //layer=li \
 //thickness=0.1 //x=10.12 //y=7.585 //x2=10.035 //y2=7.585
r185 (  85 108 ) resistor r=2.87058 //w=0.35 //l=0.085 //layer=li \
 //thickness=0.1 //x=10.83 //y=7.585 //x2=10.915 //y2=7.585
r186 (  85 86 ) resistor r=24.7629 //w=0.367 //l=0.71 //layer=li \
 //thickness=0.1 //x=10.83 //y=7.585 //x2=10.12 //y2=7.585
r187 (  79 106 ) resistor r=4.23183 //w=0.7 //l=0.175 //layer=li \
 //thickness=0.1 //x=10.035 //y=7.41 //x2=10.035 //y2=7.585
r188 (  79 113 ) resistor r=56.4706 //w=0.187 //l=0.825 //layer=li \
 //thickness=0.1 //x=10.035 //y=7.41 //x2=10.035 //y2=6.585
r189 (  78 104 ) resistor r=5.29055 //w=0.35 //l=0.17 //layer=li \
 //thickness=0.1 //x=9.54 //y=7.585 //x2=9.37 //y2=7.585
r190 (  77 106 ) resistor r=2.87058 //w=0.35 //l=0.085 //layer=li \
 //thickness=0.1 //x=9.95 //y=7.585 //x2=10.035 //y2=7.585
r191 (  77 78 ) resistor r=14.2997 //w=0.367 //l=0.41 //layer=li \
 //thickness=0.1 //x=9.95 //y=7.585 //x2=9.54 //y2=7.585
r192 (  72 74 ) resistor r=38.7139 //w=0.367 //l=1.11 //layer=li \
 //thickness=0.1 //x=7.52 //y=7.585 //x2=8.63 //y2=7.585
r193 (  70 103 ) resistor r=2.87058 //w=0.35 //l=0.085 //layer=li \
 //thickness=0.1 //x=7.355 //y=7.585 //x2=7.27 //y2=7.585
r194 (  70 72 ) resistor r=5.75477 //w=0.367 //l=0.165 //layer=li \
 //thickness=0.1 //x=7.355 //y=7.585 //x2=7.52 //y2=7.585
r195 (  69 104 ) resistor r=5.29055 //w=0.35 //l=0.17 //layer=li \
 //thickness=0.1 //x=9.2 //y=7.585 //x2=9.37 //y2=7.585
r196 (  69 74 ) resistor r=19.8801 //w=0.367 //l=0.57 //layer=li \
 //thickness=0.1 //x=9.2 //y=7.585 //x2=8.63 //y2=7.585
r197 (  65 103 ) resistor r=4.23183 //w=0.7 //l=0.175 //layer=li \
 //thickness=0.1 //x=7.27 //y=7.41 //x2=7.27 //y2=7.585
r198 (  65 112 ) resistor r=80.4278 //w=0.187 //l=1.175 //layer=li \
 //thickness=0.1 //x=7.27 //y=7.41 //x2=7.27 //y2=6.235
r199 (  62 102 ) resistor r=5.29055 //w=0.35 //l=0.17 //layer=li \
 //thickness=0.1 //x=6.21 //y=7.585 //x2=6.04 //y2=7.585
r200 (  62 64 ) resistor r=6.97548 //w=0.367 //l=0.2 //layer=li \
 //thickness=0.1 //x=6.21 //y=7.585 //x2=6.41 //y2=7.585
r201 (  61 103 ) resistor r=2.87058 //w=0.35 //l=0.085 //layer=li \
 //thickness=0.1 //x=7.185 //y=7.585 //x2=7.27 //y2=7.585
r202 (  61 64 ) resistor r=27.03 //w=0.367 //l=0.775 //layer=li \
 //thickness=0.1 //x=7.185 //y=7.585 //x2=6.41 //y2=7.585
r203 (  56 101 ) resistor r=2.87058 //w=0.35 //l=0.085 //layer=li \
 //thickness=0.1 //x=4.025 //y=7.585 //x2=3.94 //y2=7.585
r204 (  56 58 ) resistor r=31.564 //w=0.367 //l=0.905 //layer=li \
 //thickness=0.1 //x=4.025 //y=7.585 //x2=4.93 //y2=7.585
r205 (  55 102 ) resistor r=5.29055 //w=0.35 //l=0.17 //layer=li \
 //thickness=0.1 //x=5.87 //y=7.585 //x2=6.04 //y2=7.585
r206 (  55 58 ) resistor r=32.7847 //w=0.367 //l=0.94 //layer=li \
 //thickness=0.1 //x=5.87 //y=7.585 //x2=4.93 //y2=7.585
r207 (  51 101 ) resistor r=4.23183 //w=0.7 //l=0.175 //layer=li \
 //thickness=0.1 //x=3.94 //y=7.41 //x2=3.94 //y2=7.585
r208 (  51 111 ) resistor r=80.4278 //w=0.187 //l=1.175 //layer=li \
 //thickness=0.1 //x=3.94 //y=7.41 //x2=3.94 //y2=6.235
r209 (  48 100 ) resistor r=5.29055 //w=0.35 //l=0.17 //layer=li \
 //thickness=0.1 //x=2.88 //y=7.585 //x2=2.71 //y2=7.585
r210 (  48 50 ) resistor r=32.7847 //w=0.367 //l=0.94 //layer=li \
 //thickness=0.1 //x=2.88 //y=7.585 //x2=3.82 //y2=7.585
r211 (  47 101 ) resistor r=2.87058 //w=0.35 //l=0.085 //layer=li \
 //thickness=0.1 //x=3.855 //y=7.585 //x2=3.94 //y2=7.585
r212 (  47 50 ) resistor r=1.22071 //w=0.367 //l=0.035 //layer=li \
 //thickness=0.1 //x=3.855 //y=7.585 //x2=3.82 //y2=7.585
r213 (  42 99 ) resistor r=2.87058 //w=0.35 //l=0.085 //layer=li \
 //thickness=0.1 //x=2.13 //y=7.585 //x2=2.045 //y2=7.585
r214 (  42 44 ) resistor r=7.32425 //w=0.367 //l=0.21 //layer=li \
 //thickness=0.1 //x=2.13 //y=7.585 //x2=2.34 //y2=7.585
r215 (  41 100 ) resistor r=5.29055 //w=0.35 //l=0.17 //layer=li \
 //thickness=0.1 //x=2.54 //y=7.585 //x2=2.71 //y2=7.585
r216 (  41 44 ) resistor r=6.97548 //w=0.367 //l=0.2 //layer=li \
 //thickness=0.1 //x=2.54 //y=7.585 //x2=2.34 //y2=7.585
r217 (  35 99 ) resistor r=4.23183 //w=0.7 //l=0.175 //layer=li \
 //thickness=0.1 //x=2.045 //y=7.41 //x2=2.045 //y2=7.585
r218 (  35 110 ) resistor r=56.4706 //w=0.187 //l=0.825 //layer=li \
 //thickness=0.1 //x=2.045 //y=7.41 //x2=2.045 //y2=6.585
r219 (  34 98 ) resistor r=2.87058 //w=0.35 //l=0.085 //layer=li \
 //thickness=0.1 //x=1.25 //y=7.585 //x2=1.165 //y2=7.585
r220 (  33 99 ) resistor r=2.87058 //w=0.35 //l=0.085 //layer=li \
 //thickness=0.1 //x=1.96 //y=7.585 //x2=2.045 //y2=7.585
r221 (  33 34 ) resistor r=24.7629 //w=0.367 //l=0.71 //layer=li \
 //thickness=0.1 //x=1.96 //y=7.585 //x2=1.25 //y2=7.585
r222 (  27 98 ) resistor r=4.23183 //w=0.7 //l=0.175 //layer=li \
 //thickness=0.1 //x=1.165 //y=7.41 //x2=1.165 //y2=7.585
r223 (  27 109 ) resistor r=56.4706 //w=0.187 //l=0.825 //layer=li \
 //thickness=0.1 //x=1.165 //y=7.41 //x2=1.165 //y2=6.585
r224 (  21 108 ) resistor r=4.65 //w=0.17 //l=0.34 //layer=mcon //count=2 \
 //x=10.85 //y=7.58 //x2=10.85 //y2=7.58
r225 (  19 106 ) resistor r=3.1 //w=0.17 //l=0.51 //layer=mcon //count=3 \
 //x=10.11 //y=7.58 //x2=10.11 //y2=7.58
r226 (  19 21 ) resistor r=0.297428 //w=0.311 //l=0.74 //layer=m1 \
 //thickness=0.36 //x=10.11 //y=7.585 //x2=10.85 //y2=7.585
r227 (  17 74 ) resistor r=3.1 //w=0.17 //l=0.51 //layer=mcon //count=3 \
 //x=8.63 //y=7.58 //x2=8.63 //y2=7.58
r228 (  17 19 ) resistor r=0.594855 //w=0.311 //l=1.48 //layer=m1 \
 //thickness=0.36 //x=8.63 //y=7.585 //x2=10.11 //y2=7.585
r229 (  15 72 ) resistor r=3.1 //w=0.17 //l=0.51 //layer=mcon //count=3 \
 //x=7.52 //y=7.58 //x2=7.52 //y2=7.58
r230 (  15 17 ) resistor r=0.446141 //w=0.311 //l=1.11 //layer=m1 \
 //thickness=0.36 //x=7.52 //y=7.585 //x2=8.63 //y2=7.585
r231 (  13 64 ) resistor r=3.1 //w=0.17 //l=0.51 //layer=mcon //count=3 \
 //x=6.41 //y=7.58 //x2=6.41 //y2=7.58
r232 (  13 15 ) resistor r=0.446141 //w=0.311 //l=1.11 //layer=m1 \
 //thickness=0.36 //x=6.41 //y=7.585 //x2=7.52 //y2=7.585
r233 (  10 58 ) resistor r=3.1 //w=0.17 //l=0.51 //layer=mcon //count=3 \
 //x=4.93 //y=7.58 //x2=4.93 //y2=7.58
r234 (  8 50 ) resistor r=3.1 //w=0.17 //l=0.51 //layer=mcon //count=3 \
 //x=3.82 //y=7.58 //x2=3.82 //y2=7.58
r235 (  8 10 ) resistor r=0.446141 //w=0.311 //l=1.11 //layer=m1 \
 //thickness=0.36 //x=3.82 //y=7.585 //x2=4.93 //y2=7.585
r236 (  6 44 ) resistor r=3.1 //w=0.17 //l=0.51 //layer=mcon //count=3 \
 //x=2.34 //y=7.58 //x2=2.34 //y2=7.58
r237 (  6 8 ) resistor r=0.594855 //w=0.311 //l=1.48 //layer=m1 \
 //thickness=0.36 //x=2.34 //y=7.585 //x2=3.82 //y2=7.585
r238 (  3 98 ) resistor r=3.1 //w=0.17 //l=0.51 //layer=mcon //count=3 \
 //x=1.23 //y=7.58 //x2=1.23 //y2=7.58
r239 (  3 6 ) resistor r=0.446141 //w=0.311 //l=1.11 //layer=m1 \
 //thickness=0.36 //x=1.23 //y=7.585 //x2=2.34 //y2=7.585
r240 (  1 13 ) resistor r=0.148714 //w=0.311 //l=0.37 //layer=m1 \
 //thickness=0.36 //x=6.04 //y=7.585 //x2=6.41 //y2=7.585
r241 (  1 10 ) resistor r=0.446141 //w=0.311 //l=1.11 //layer=m1 \
 //thickness=0.36 //x=6.04 //y=7.585 //x2=4.93 //y2=7.585
ends PM_XNOR2X1\%VDD

subckt PM_XNOR2X1\%A ( 1 2 7 8 9 10 11 12 13 14 15 16 17 18 20 33 45 46 47 48 \
 49 50 51 52 53 54 58 59 60 62 68 69 70 71 72 73 77 79 82 83 88 102 )
c133 ( 102 0 ) capacitor c=0.0661295f //x=3.82 //y=4.88
c134 ( 88 0 ) capacitor c=0.0537799f //x=1.23 //y=2.265
c135 ( 83 0 ) capacitor c=0.0318948f //x=4.155 //y=1.39
c136 ( 82 0 ) capacitor c=0.0187384f //x=4.155 //y=1.045
c137 ( 79 0 ) capacitor c=0.0141798f //x=4 //y=1.545
c138 ( 77 0 ) capacitor c=0.0149844f //x=4 //y=0.89
c139 ( 73 0 ) capacitor c=0.0836842f //x=3.625 //y=2.095
c140 ( 72 0 ) capacitor c=0.0229722f //x=3.625 //y=1.7
c141 ( 71 0 ) capacitor c=0.0234352f //x=3.625 //y=1.39
c142 ( 70 0 ) capacitor c=0.0199343f //x=3.625 //y=1.045
c143 ( 69 0 ) capacitor c=0.0435629f //x=1.87 //y=1.435
c144 ( 68 0 ) capacitor c=0.0200386f //x=1.87 //y=1.09
c145 ( 62 0 ) capacitor c=0.0152946f //x=1.715 //y=1.59
c146 ( 60 0 ) capacitor c=0.0157804f //x=1.715 //y=0.935
c147 ( 59 0 ) capacitor c=0.048995f //x=1.46 //y=4.97
c148 ( 58 0 ) capacitor c=0.0303096f //x=1.75 //y=4.97
c149 ( 54 0 ) capacitor c=0.0290017f //x=1.34 //y=2.1
c150 ( 53 0 ) capacitor c=0.0250027f //x=1.34 //y=1.745
c151 ( 52 0 ) capacitor c=0.0234316f //x=1.34 //y=1.435
c152 ( 51 0 ) capacitor c=0.0200596f //x=1.34 //y=1.09
c153 ( 50 0 ) capacitor c=0.110797f //x=4.16 //y=6.2
c154 ( 49 0 ) capacitor c=0.154322f //x=3.72 //y=6.2
c155 ( 48 0 ) capacitor c=0.154218f //x=1.825 //y=6.2
c156 ( 47 0 ) capacitor c=0.154243f //x=1.385 //y=6.2
c157 ( 33 0 ) capacitor c=0.109824f //x=3.82 //y=2.26
c158 ( 20 0 ) capacitor c=0.11095f //x=1.23 //y=2.265
c159 ( 2 0 ) capacitor c=0.0144526f //x=1.345 //y=4.25
c160 ( 1 0 ) capacitor c=0.0971907f //x=3.705 //y=4.25
r161 (  100 102 ) resistor r=20.6867 //w=0.233 //l=0.1 //layer=ply \
 //thickness=0.18 //x=3.72 //y=4.88 //x2=3.82 //y2=4.88
r162 (  88 89 ) resistor r=17.5563 //w=0.302 //l=0.11 //layer=ply \
 //thickness=0.18 //x=1.23 //y=2.265 //x2=1.34 //y2=2.265
r163 (  84 102 ) resistor r=70.3348 //w=0.233 //l=0.414367 //layer=ply \
 //thickness=0.18 //x=4.16 //y=5.045 //x2=3.82 //y2=4.88
r164 (  83 104 ) resistor r=45.1352 //w=0.168 //l=0.173853 //layer=ply \
 //thickness=0.18 //x=4.155 //y=1.39 //x2=4.115 //y2=1.545
r165 (  82 103 ) resistor r=45.1352 //w=0.168 //l=0.173853 //layer=ply \
 //thickness=0.18 //x=4.155 //y=1.045 //x2=4.115 //y2=0.89
r166 (  82 83 ) resistor r=176.904 //w=0.094 //l=0.345 //layer=ply \
 //thickness=0.18 //x=4.155 //y=1.045 //x2=4.155 //y2=1.39
r167 (  80 99 ) resistor r=10.701 //w=0.21 //l=0.115 //layer=ply \
 //thickness=0.18 //x=3.78 //y=1.545 //x2=3.665 //y2=1.545
r168 (  79 104 ) resistor r=5.52526 //w=0.168 //l=0.115 //layer=ply \
 //thickness=0.18 //x=4 //y=1.545 //x2=4.115 //y2=1.545
r169 (  78 98 ) resistor r=5.52526 //w=0.168 //l=0.115 //layer=ply \
 //thickness=0.18 //x=3.78 //y=0.89 //x2=3.665 //y2=0.89
r170 (  77 103 ) resistor r=5.52526 //w=0.168 //l=0.115 //layer=ply \
 //thickness=0.18 //x=4 //y=0.89 //x2=4.115 //y2=0.89
r171 (  77 78 ) resistor r=112.809 //w=0.094 //l=0.22 //layer=ply \
 //thickness=0.18 //x=4 //y=0.89 //x2=3.78 //y2=0.89
r172 (  74 100 ) resistor r=13.0941 //w=0.233 //l=0.165 //layer=ply \
 //thickness=0.18 //x=3.72 //y=5.045 //x2=3.72 //y2=4.88
r173 (  73 97 ) resistor r=34.8111 //w=0.27 //l=0.264953 //layer=ply \
 //thickness=0.18 //x=3.625 //y=2.095 //x2=3.82 //y2=2.26
r174 (  72 99 ) resistor r=39.5823 //w=0.21 //l=0.173853 //layer=ply \
 //thickness=0.18 //x=3.625 //y=1.7 //x2=3.665 //y2=1.545
r175 (  72 73 ) resistor r=202.543 //w=0.094 //l=0.395 //layer=ply \
 //thickness=0.18 //x=3.625 //y=1.7 //x2=3.625 //y2=2.095
r176 (  71 99 ) resistor r=39.5823 //w=0.21 //l=0.173853 //layer=ply \
 //thickness=0.18 //x=3.625 //y=1.39 //x2=3.665 //y2=1.545
r177 (  70 98 ) resistor r=45.1352 //w=0.168 //l=0.173853 //layer=ply \
 //thickness=0.18 //x=3.625 //y=1.045 //x2=3.665 //y2=0.89
r178 (  70 71 ) resistor r=176.904 //w=0.094 //l=0.345 //layer=ply \
 //thickness=0.18 //x=3.625 //y=1.045 //x2=3.625 //y2=1.39
r179 (  69 95 ) resistor r=45.1352 //w=0.168 //l=0.173853 //layer=ply \
 //thickness=0.18 //x=1.87 //y=1.435 //x2=1.83 //y2=1.59
r180 (  68 94 ) resistor r=45.1352 //w=0.168 //l=0.173853 //layer=ply \
 //thickness=0.18 //x=1.87 //y=1.09 //x2=1.83 //y2=0.935
r181 (  68 69 ) resistor r=176.904 //w=0.094 //l=0.345 //layer=ply \
 //thickness=0.18 //x=1.87 //y=1.09 //x2=1.87 //y2=1.435
r182 (  63 93 ) resistor r=10.701 //w=0.21 //l=0.115 //layer=ply \
 //thickness=0.18 //x=1.495 //y=1.59 //x2=1.38 //y2=1.59
r183 (  62 95 ) resistor r=5.52526 //w=0.168 //l=0.115 //layer=ply \
 //thickness=0.18 //x=1.715 //y=1.59 //x2=1.83 //y2=1.59
r184 (  61 92 ) resistor r=5.52526 //w=0.168 //l=0.115 //layer=ply \
 //thickness=0.18 //x=1.495 //y=0.935 //x2=1.38 //y2=0.935
r185 (  60 94 ) resistor r=5.52526 //w=0.168 //l=0.115 //layer=ply \
 //thickness=0.18 //x=1.715 //y=0.935 //x2=1.83 //y2=0.935
r186 (  60 61 ) resistor r=112.809 //w=0.094 //l=0.22 //layer=ply \
 //thickness=0.18 //x=1.715 //y=0.935 //x2=1.495 //y2=0.935
r187 (  58 65 ) resistor r=26.9307 //w=0.15 //l=0.106066 //layer=ply \
 //thickness=0.18 //x=1.75 //y=4.97 //x2=1.825 //y2=5.045
r188 (  58 59 ) resistor r=148.702 //w=0.094 //l=0.29 //layer=ply \
 //thickness=0.18 //x=1.75 //y=4.97 //x2=1.46 //y2=4.97
r189 (  55 59 ) resistor r=23.403 //w=0.284 //l=0.106066 //layer=ply \
 //thickness=0.18 //x=1.385 //y=5.045 //x2=1.46 //y2=4.97
r190 (  55 91 ) resistor r=26.3063 //w=0.284 //l=0.229783 //layer=ply \
 //thickness=0.18 //x=1.385 //y=5.045 //x2=1.23 //y2=4.88
r191 (  54 89 ) resistor r=19.1248 //w=0.302 //l=0.165 //layer=ply \
 //thickness=0.18 //x=1.34 //y=2.1 //x2=1.34 //y2=2.265
r192 (  53 93 ) resistor r=39.5823 //w=0.21 //l=0.173853 //layer=ply \
 //thickness=0.18 //x=1.34 //y=1.745 //x2=1.38 //y2=1.59
r193 (  53 54 ) resistor r=182.032 //w=0.094 //l=0.355 //layer=ply \
 //thickness=0.18 //x=1.34 //y=1.745 //x2=1.34 //y2=2.1
r194 (  52 93 ) resistor r=39.5823 //w=0.21 //l=0.173853 //layer=ply \
 //thickness=0.18 //x=1.34 //y=1.435 //x2=1.38 //y2=1.59
r195 (  51 92 ) resistor r=45.1352 //w=0.168 //l=0.173853 //layer=ply \
 //thickness=0.18 //x=1.34 //y=1.09 //x2=1.38 //y2=0.935
r196 (  51 52 ) resistor r=176.904 //w=0.094 //l=0.345 //layer=ply \
 //thickness=0.18 //x=1.34 //y=1.09 //x2=1.34 //y2=1.435
r197 (  50 84 ) resistor r=592.245 //w=0.094 //l=1.155 //layer=ply \
 //thickness=0.18 //x=4.16 //y=6.2 //x2=4.16 //y2=5.045
r198 (  49 74 ) resistor r=592.245 //w=0.094 //l=1.155 //layer=ply \
 //thickness=0.18 //x=3.72 //y=6.2 //x2=3.72 //y2=5.045
r199 (  48 65 ) resistor r=592.245 //w=0.094 //l=1.155 //layer=ply \
 //thickness=0.18 //x=1.825 //y=6.2 //x2=1.825 //y2=5.045
r200 (  47 55 ) resistor r=592.245 //w=0.094 //l=1.155 //layer=ply \
 //thickness=0.18 //x=1.385 //y=6.2 //x2=1.385 //y2=5.045
r201 (  46 79 ) resistor r=56.4043 //w=0.094 //l=0.11 //layer=ply \
 //thickness=0.18 //x=3.89 //y=1.545 //x2=4 //y2=1.545
r202 (  46 80 ) resistor r=56.4043 //w=0.094 //l=0.11 //layer=ply \
 //thickness=0.18 //x=3.89 //y=1.545 //x2=3.78 //y2=1.545
r203 (  45 62 ) resistor r=56.4043 //w=0.094 //l=0.11 //layer=ply \
 //thickness=0.18 //x=1.605 //y=1.59 //x2=1.715 //y2=1.59
r204 (  45 63 ) resistor r=56.4043 //w=0.094 //l=0.11 //layer=ply \
 //thickness=0.18 //x=1.605 //y=1.59 //x2=1.495 //y2=1.59
r205 (  43 102 ) resistor r=152 //w=0.17 //l=0.17 //layer=licon //count=1 \
 //x=3.82 //y=4.88 //x2=3.82 //y2=4.88
r206 (  33 97 ) resistor r=152 //w=0.17 //l=0.17 //layer=licon //count=1 \
 //x=3.82 //y=2.26 //x2=3.82 //y2=2.26
r207 (  30 91 ) resistor r=152 //w=0.17 //l=0.17 //layer=licon //count=1 \
 //x=1.23 //y=4.88 //x2=1.23 //y2=4.88
r208 (  20 88 ) resistor r=152 //w=0.17 //l=0.17 //layer=licon //count=1 \
 //x=1.23 //y=2.265 //x2=1.23 //y2=2.265
r209 (  18 43 ) resistor r=17.7968 //w=0.187 //l=0.26 //layer=li \
 //thickness=0.1 //x=3.82 //y=4.62 //x2=3.82 //y2=4.88
r210 (  17 18 ) resistor r=25.3262 //w=0.187 //l=0.37 //layer=li \
 //thickness=0.1 //x=3.82 //y=4.25 //x2=3.82 //y2=4.62
r211 (  16 17 ) resistor r=25.3262 //w=0.187 //l=0.37 //layer=li \
 //thickness=0.1 //x=3.82 //y=3.88 //x2=3.82 //y2=4.25
r212 (  15 16 ) resistor r=25.3262 //w=0.187 //l=0.37 //layer=li \
 //thickness=0.1 //x=3.82 //y=3.51 //x2=3.82 //y2=3.88
r213 (  14 15 ) resistor r=25.3262 //w=0.187 //l=0.37 //layer=li \
 //thickness=0.1 //x=3.82 //y=3.14 //x2=3.82 //y2=3.51
r214 (  13 14 ) resistor r=25.3262 //w=0.187 //l=0.37 //layer=li \
 //thickness=0.1 //x=3.82 //y=2.77 //x2=3.82 //y2=3.14
r215 (  13 33 ) resistor r=34.9091 //w=0.187 //l=0.51 //layer=li \
 //thickness=0.1 //x=3.82 //y=2.77 //x2=3.82 //y2=2.26
r216 (  12 30 ) resistor r=17.7968 //w=0.187 //l=0.26 //layer=li \
 //thickness=0.1 //x=1.23 //y=4.62 //x2=1.23 //y2=4.88
r217 (  11 12 ) resistor r=25.3262 //w=0.187 //l=0.37 //layer=li \
 //thickness=0.1 //x=1.23 //y=4.25 //x2=1.23 //y2=4.62
r218 (  10 11 ) resistor r=25.3262 //w=0.187 //l=0.37 //layer=li \
 //thickness=0.1 //x=1.23 //y=3.88 //x2=1.23 //y2=4.25
r219 (  9 10 ) resistor r=25.3262 //w=0.187 //l=0.37 //layer=li \
 //thickness=0.1 //x=1.23 //y=3.51 //x2=1.23 //y2=3.88
r220 (  8 9 ) resistor r=25.3262 //w=0.187 //l=0.37 //layer=li //thickness=0.1 \
 //x=1.23 //y=3.14 //x2=1.23 //y2=3.51
r221 (  7 8 ) resistor r=25.3262 //w=0.187 //l=0.37 //layer=li //thickness=0.1 \
 //x=1.23 //y=2.77 //x2=1.23 //y2=3.14
r222 (  7 20 ) resistor r=34.5668 //w=0.187 //l=0.505 //layer=li \
 //thickness=0.1 //x=1.23 //y=2.77 //x2=1.23 //y2=2.265
r223 (  6 17 ) resistor r=9.3 //w=0.17 //l=0.17 //layer=mcon //count=1 \
 //x=3.82 //y=4.25 //x2=3.82 //y2=4.25
r224 (  4 11 ) resistor r=9.3 //w=0.17 //l=0.17 //layer=mcon //count=1 \
 //x=1.23 //y=4.25 //x2=1.23 //y2=4.25
r225 (  2 4 ) resistor r=0.0717383 //w=0.224 //l=0.115 //layer=m1 \
 //thickness=0.36 //x=1.345 //y=4.25 //x2=1.23 //y2=4.25
r226 (  1 6 ) resistor r=0.0717383 //w=0.224 //l=0.115 //layer=m1 \
 //thickness=0.36 //x=3.705 //y=4.25 //x2=3.82 //y2=4.25
r227 (  1 2 ) resistor r=2.25191 //w=0.131 //l=2.36 //layer=m1 \
 //thickness=0.36 //x=3.705 //y=4.25 //x2=1.345 //y2=4.25
ends PM_XNOR2X1\%A

subckt PM_XNOR2X1\%noxref_4 ( 1 2 17 18 19 20 24 26 33 34 35 36 37 38 39 43 45 \
 51 52 60 62 64 )
c169 ( 64 0 ) capacitor c=0.0288629f //x=1.46 //y=5.2
c170 ( 62 0 ) capacitor c=0.0173218f //x=1.415 //y=1.09
c171 ( 60 0 ) capacitor c=0.058476f //x=8.26 //y=4.88
c172 ( 52 0 ) capacitor c=0.0417768f //x=8.455 //y=1.43
c173 ( 51 0 ) capacitor c=0.0192208f //x=8.455 //y=1.085
c174 ( 45 0 ) capacitor c=0.0124204f //x=8.3 //y=1.585
c175 ( 43 0 ) capacitor c=0.0157803f //x=8.3 //y=0.93
c176 ( 39 0 ) capacitor c=0.0903346f //x=7.925 //y=2.095
c177 ( 38 0 ) capacitor c=0.0194674f //x=7.925 //y=1.74
c178 ( 37 0 ) capacitor c=0.0168481f //x=7.925 //y=1.43
c179 ( 36 0 ) capacitor c=0.0174345f //x=7.925 //y=1.085
c180 ( 35 0 ) capacitor c=0.153255f //x=8.37 //y=6.2
c181 ( 34 0 ) capacitor c=0.110227f //x=7.93 //y=6.2
c182 ( 26 0 ) capacitor c=0.0739231f //x=8.26 //y=2.26
c183 ( 24 0 ) capacitor c=0.0868472f //x=1.97 //y=2.77
c184 ( 20 0 ) capacitor c=0.00417404f //x=1.69 //y=4.76
c185 ( 19 0 ) capacitor c=0.0118896f //x=1.885 //y=4.76
c186 ( 18 0 ) capacitor c=0.00621372f //x=1.685 //y=2.26
c187 ( 17 0 ) capacitor c=0.013454f //x=1.885 //y=2.26
c188 ( 2 0 ) capacitor c=0.0163395f //x=2.085 //y=2.77
c189 ( 1 0 ) capacitor c=0.188491f //x=8.145 //y=2.77
r190 (  60 61 ) resistor r=22.7554 //w=0.233 //l=0.11 //layer=ply \
 //thickness=0.18 //x=8.26 //y=4.88 //x2=8.37 //y2=4.88
r191 (  52 58 ) resistor r=45.1352 //w=0.168 //l=0.173853 //layer=ply \
 //thickness=0.18 //x=8.455 //y=1.43 //x2=8.415 //y2=1.585
r192 (  51 57 ) resistor r=45.1352 //w=0.168 //l=0.173853 //layer=ply \
 //thickness=0.18 //x=8.455 //y=1.085 //x2=8.415 //y2=0.93
r193 (  51 52 ) resistor r=176.904 //w=0.094 //l=0.345 //layer=ply \
 //thickness=0.18 //x=8.455 //y=1.085 //x2=8.455 //y2=1.43
r194 (  48 61 ) resistor r=13.0941 //w=0.233 //l=0.165 //layer=ply \
 //thickness=0.18 //x=8.37 //y=5.045 //x2=8.37 //y2=4.88
r195 (  46 54 ) resistor r=10.701 //w=0.21 //l=0.115 //layer=ply \
 //thickness=0.18 //x=8.08 //y=1.585 //x2=7.965 //y2=1.585
r196 (  45 58 ) resistor r=5.52526 //w=0.168 //l=0.115 //layer=ply \
 //thickness=0.18 //x=8.3 //y=1.585 //x2=8.415 //y2=1.585
r197 (  44 53 ) resistor r=5.52526 //w=0.168 //l=0.115 //layer=ply \
 //thickness=0.18 //x=8.08 //y=0.93 //x2=7.965 //y2=0.93
r198 (  43 57 ) resistor r=5.52526 //w=0.168 //l=0.115 //layer=ply \
 //thickness=0.18 //x=8.3 //y=0.93 //x2=8.415 //y2=0.93
r199 (  43 44 ) resistor r=112.809 //w=0.094 //l=0.22 //layer=ply \
 //thickness=0.18 //x=8.3 //y=0.93 //x2=8.08 //y2=0.93
r200 (  40 60 ) resistor r=68.2661 //w=0.233 //l=0.404166 //layer=ply \
 //thickness=0.18 //x=7.93 //y=5.045 //x2=8.26 //y2=4.88
r201 (  39 56 ) resistor r=67.2792 //w=0.24 //l=0.438891 //layer=ply \
 //thickness=0.18 //x=7.925 //y=2.095 //x2=8.26 //y2=2.335
r202 (  38 54 ) resistor r=39.5823 //w=0.21 //l=0.173853 //layer=ply \
 //thickness=0.18 //x=7.925 //y=1.74 //x2=7.965 //y2=1.585
r203 (  38 39 ) resistor r=182.032 //w=0.094 //l=0.355 //layer=ply \
 //thickness=0.18 //x=7.925 //y=1.74 //x2=7.925 //y2=2.095
r204 (  37 54 ) resistor r=39.5823 //w=0.21 //l=0.173853 //layer=ply \
 //thickness=0.18 //x=7.925 //y=1.43 //x2=7.965 //y2=1.585
r205 (  36 53 ) resistor r=45.1352 //w=0.168 //l=0.173853 //layer=ply \
 //thickness=0.18 //x=7.925 //y=1.085 //x2=7.965 //y2=0.93
r206 (  36 37 ) resistor r=176.904 //w=0.094 //l=0.345 //layer=ply \
 //thickness=0.18 //x=7.925 //y=1.085 //x2=7.925 //y2=1.43
r207 (  35 48 ) resistor r=592.245 //w=0.094 //l=1.155 //layer=ply \
 //thickness=0.18 //x=8.37 //y=6.2 //x2=8.37 //y2=5.045
r208 (  34 40 ) resistor r=592.245 //w=0.094 //l=1.155 //layer=ply \
 //thickness=0.18 //x=7.93 //y=6.2 //x2=7.93 //y2=5.045
r209 (  33 45 ) resistor r=56.4043 //w=0.094 //l=0.11 //layer=ply \
 //thickness=0.18 //x=8.19 //y=1.585 //x2=8.3 //y2=1.585
r210 (  33 46 ) resistor r=56.4043 //w=0.094 //l=0.11 //layer=ply \
 //thickness=0.18 //x=8.19 //y=1.585 //x2=8.08 //y2=1.585
r211 (  31 60 ) resistor r=152 //w=0.17 //l=0.17 //layer=licon //count=1 \
 //x=8.26 //y=4.88 //x2=8.26 //y2=4.88
r212 (  29 31 ) resistor r=144.428 //w=0.187 //l=2.11 //layer=li \
 //thickness=0.1 //x=8.26 //y=2.77 //x2=8.26 //y2=4.88
r213 (  26 56 ) resistor r=152 //w=0.17 //l=0.17 //layer=licon //count=1 \
 //x=8.26 //y=2.26 //x2=8.26 //y2=2.26
r214 (  26 29 ) resistor r=34.9091 //w=0.187 //l=0.51 //layer=li \
 //thickness=0.1 //x=8.26 //y=2.26 //x2=8.26 //y2=2.77
r215 (  22 24 ) resistor r=130.396 //w=0.187 //l=1.905 //layer=li \
 //thickness=0.1 //x=1.97 //y=4.675 //x2=1.97 //y2=2.77
r216 (  21 24 ) resistor r=29.0909 //w=0.187 //l=0.425 //layer=li \
 //thickness=0.1 //x=1.97 //y=2.345 //x2=1.97 //y2=2.77
r217 (  19 22 ) resistor r=7.15173 //w=0.17 //l=0.120208 //layer=li \
 //thickness=0.1 //x=1.885 //y=4.76 //x2=1.97 //y2=4.675
r218 (  19 20 ) resistor r=13.3476 //w=0.187 //l=0.195 //layer=li \
 //thickness=0.1 //x=1.885 //y=4.76 //x2=1.69 //y2=4.76
r219 (  17 21 ) resistor r=7.15173 //w=0.17 //l=0.120208 //layer=li \
 //thickness=0.1 //x=1.885 //y=2.26 //x2=1.97 //y2=2.345
r220 (  17 18 ) resistor r=13.6898 //w=0.187 //l=0.2 //layer=li \
 //thickness=0.1 //x=1.885 //y=2.26 //x2=1.685 //y2=2.26
r221 (  11 20 ) resistor r=7.15173 //w=0.17 //l=0.120208 //layer=li \
 //thickness=0.1 //x=1.605 //y=4.845 //x2=1.69 //y2=4.76
r222 (  11 64 ) resistor r=72.5562 //w=0.187 //l=1.06 //layer=li \
 //thickness=0.1 //x=1.605 //y=4.845 //x2=1.605 //y2=5.905
r223 (  7 18 ) resistor r=7.15173 //w=0.17 //l=0.120208 //layer=li \
 //thickness=0.1 //x=1.6 //y=2.175 //x2=1.685 //y2=2.26
r224 (  7 62 ) resistor r=67.7647 //w=0.187 //l=0.99 //layer=li \
 //thickness=0.1 //x=1.6 //y=2.175 //x2=1.6 //y2=1.185
r225 (  6 29 ) resistor r=9.3 //w=0.17 //l=0.17 //layer=mcon //count=1 \
 //x=8.26 //y=2.77 //x2=8.26 //y2=2.77
r226 (  4 24 ) resistor r=9.3 //w=0.17 //l=0.17 //layer=mcon //count=1 \
 //x=1.97 //y=2.77 //x2=1.97 //y2=2.77
r227 (  2 4 ) resistor r=0.0717383 //w=0.224 //l=0.115 //layer=m1 \
 //thickness=0.36 //x=2.085 //y=2.77 //x2=1.97 //y2=2.77
r228 (  1 6 ) resistor r=0.0717383 //w=0.224 //l=0.115 //layer=m1 \
 //thickness=0.36 //x=8.145 //y=2.77 //x2=8.26 //y2=2.77
r229 (  1 2 ) resistor r=5.78244 //w=0.131 //l=6.06 //layer=m1 \
 //thickness=0.36 //x=8.145 //y=2.77 //x2=2.085 //y2=2.77
ends PM_XNOR2X1\%noxref_4

subckt PM_XNOR2X1\%Y ( 1 2 7 8 9 10 11 12 13 14 25 26 27 28 46 47 48 49 57 58 \
 61 62 )
c149 ( 62 0 ) capacitor c=0.0159588f //x=8.005 //y=5.2
c150 ( 61 0 ) capacitor c=0.0159588f //x=4.675 //y=5.2
c151 ( 58 0 ) capacitor c=0.00827883f //x=8 //y=1.085
c152 ( 57 0 ) capacitor c=0.00846843f //x=4.67 //y=1.085
c153 ( 49 0 ) capacitor c=0.00178403f //x=8.275 //y=1.83
c154 ( 48 0 ) capacitor c=0.0112028f //x=8.545 //y=1.83
c155 ( 47 0 ) capacitor c=0.00235465f //x=8.235 //y=5.385
c156 ( 46 0 ) capacitor c=0.0121398f //x=8.545 //y=5.385
c157 ( 28 0 ) capacitor c=0.00178686f //x=4.945 //y=1.83
c158 ( 27 0 ) capacitor c=0.0109587f //x=5.215 //y=1.83
c159 ( 26 0 ) capacitor c=0.0027221f //x=4.905 //y=5.385
c160 ( 25 0 ) capacitor c=0.0121702f //x=5.215 //y=5.385
c161 ( 11 0 ) capacitor c=0.0893739f //x=8.63 //y=2.4
c162 ( 7 0 ) capacitor c=0.105734f //x=5.3 //y=2.4
c163 ( 2 0 ) capacitor c=0.0132458f //x=5.415 //y=3.88
c164 ( 1 0 ) capacitor c=0.0664354f //x=8.515 //y=3.88
r165 (  48 50 ) resistor r=7.15173 //w=0.17 //l=0.120208 //layer=li \
 //thickness=0.1 //x=8.545 //y=1.83 //x2=8.63 //y2=1.915
r166 (  48 49 ) resistor r=18.4813 //w=0.187 //l=0.27 //layer=li \
 //thickness=0.1 //x=8.545 //y=1.83 //x2=8.275 //y2=1.83
r167 (  46 51 ) resistor r=7.15173 //w=0.17 //l=0.120208 //layer=li \
 //thickness=0.1 //x=8.545 //y=5.385 //x2=8.63 //y2=5.3
r168 (  46 47 ) resistor r=21.2193 //w=0.187 //l=0.31 //layer=li \
 //thickness=0.1 //x=8.545 //y=5.385 //x2=8.235 //y2=5.385
r169 (  42 49 ) resistor r=7.15173 //w=0.17 //l=0.120208 //layer=li \
 //thickness=0.1 //x=8.19 //y=1.745 //x2=8.275 //y2=1.83
r170 (  42 58 ) resistor r=38.6738 //w=0.187 //l=0.565 //layer=li \
 //thickness=0.1 //x=8.19 //y=1.745 //x2=8.19 //y2=1.18
r171 (  36 47 ) resistor r=7.15173 //w=0.17 //l=0.120208 //layer=li \
 //thickness=0.1 //x=8.15 //y=5.47 //x2=8.235 //y2=5.385
r172 (  36 62 ) resistor r=29.0909 //w=0.187 //l=0.425 //layer=li \
 //thickness=0.1 //x=8.15 //y=5.47 //x2=8.15 //y2=5.895
r173 (  27 29 ) resistor r=7.15173 //w=0.17 //l=0.120208 //layer=li \
 //thickness=0.1 //x=5.215 //y=1.83 //x2=5.3 //y2=1.915
r174 (  27 28 ) resistor r=18.4813 //w=0.187 //l=0.27 //layer=li \
 //thickness=0.1 //x=5.215 //y=1.83 //x2=4.945 //y2=1.83
r175 (  25 30 ) resistor r=7.15173 //w=0.17 //l=0.120208 //layer=li \
 //thickness=0.1 //x=5.215 //y=5.385 //x2=5.3 //y2=5.3
r176 (  25 26 ) resistor r=21.2193 //w=0.187 //l=0.31 //layer=li \
 //thickness=0.1 //x=5.215 //y=5.385 //x2=4.905 //y2=5.385
r177 (  21 28 ) resistor r=7.15173 //w=0.17 //l=0.120208 //layer=li \
 //thickness=0.1 //x=4.86 //y=1.745 //x2=4.945 //y2=1.83
r178 (  21 57 ) resistor r=38.6738 //w=0.187 //l=0.565 //layer=li \
 //thickness=0.1 //x=4.86 //y=1.745 //x2=4.86 //y2=1.18
r179 (  15 26 ) resistor r=7.15173 //w=0.17 //l=0.120208 //layer=li \
 //thickness=0.1 //x=4.82 //y=5.47 //x2=4.905 //y2=5.385
r180 (  15 61 ) resistor r=29.0909 //w=0.187 //l=0.425 //layer=li \
 //thickness=0.1 //x=4.82 //y=5.47 //x2=4.82 //y2=5.895
r181 (  14 51 ) resistor r=21.2193 //w=0.187 //l=0.31 //layer=li \
 //thickness=0.1 //x=8.63 //y=4.99 //x2=8.63 //y2=5.3
r182 (  13 14 ) resistor r=75.9786 //w=0.187 //l=1.11 //layer=li \
 //thickness=0.1 //x=8.63 //y=3.88 //x2=8.63 //y2=4.99
r183 (  12 13 ) resistor r=75.9786 //w=0.187 //l=1.11 //layer=li \
 //thickness=0.1 //x=8.63 //y=2.77 //x2=8.63 //y2=3.88
r184 (  11 12 ) resistor r=25.3262 //w=0.187 //l=0.37 //layer=li \
 //thickness=0.1 //x=8.63 //y=2.4 //x2=8.63 //y2=2.77
r185 (  11 50 ) resistor r=33.1979 //w=0.187 //l=0.485 //layer=li \
 //thickness=0.1 //x=8.63 //y=2.4 //x2=8.63 //y2=1.915
r186 (  10 30 ) resistor r=46.5455 //w=0.187 //l=0.68 //layer=li \
 //thickness=0.1 //x=5.3 //y=4.62 //x2=5.3 //y2=5.3
r187 (  9 10 ) resistor r=50.6524 //w=0.187 //l=0.74 //layer=li \
 //thickness=0.1 //x=5.3 //y=3.88 //x2=5.3 //y2=4.62
r188 (  8 9 ) resistor r=25.3262 //w=0.187 //l=0.37 //layer=li //thickness=0.1 \
 //x=5.3 //y=3.51 //x2=5.3 //y2=3.88
r189 (  7 8 ) resistor r=75.9786 //w=0.187 //l=1.11 //layer=li //thickness=0.1 \
 //x=5.3 //y=2.4 //x2=5.3 //y2=3.51
r190 (  7 29 ) resistor r=33.1979 //w=0.187 //l=0.485 //layer=li \
 //thickness=0.1 //x=5.3 //y=2.4 //x2=5.3 //y2=1.915
r191 (  6 13 ) resistor r=9.3 //w=0.17 //l=0.17 //layer=mcon //count=1 \
 //x=8.63 //y=3.88 //x2=8.63 //y2=3.88
r192 (  4 9 ) resistor r=9.3 //w=0.17 //l=0.17 //layer=mcon //count=1 //x=5.3 \
 //y=3.88 //x2=5.3 //y2=3.88
r193 (  2 4 ) resistor r=0.0717383 //w=0.224 //l=0.115 //layer=m1 \
 //thickness=0.36 //x=5.415 //y=3.88 //x2=5.3 //y2=3.88
r194 (  1 6 ) resistor r=0.0717383 //w=0.224 //l=0.115 //layer=m1 \
 //thickness=0.36 //x=8.515 //y=3.88 //x2=8.63 //y2=3.88
r195 (  1 2 ) resistor r=2.95802 //w=0.131 //l=3.1 //layer=m1 //thickness=0.36 \
 //x=8.515 //y=3.88 //x2=5.415 //y2=3.88
ends PM_XNOR2X1\%Y

subckt PM_XNOR2X1\%noxref_6 ( 1 2 3 4 14 20 28 31 32 33 34 45 46 47 48 49 50 \
 51 52 54 57 58 73 74 76 )
c170 ( 76 0 ) capacitor c=0.028734f //x=10.33 //y=5.2
c171 ( 74 0 ) capacitor c=0.0173218f //x=10.285 //y=1.09
c172 ( 73 0 ) capacitor c=0.0606915f //x=7.15 //y=4.88
c173 ( 58 0 ) capacitor c=0.0417768f //x=5.125 //y=1.43
c174 ( 57 0 ) capacitor c=0.0192208f //x=5.125 //y=1.085
c175 ( 54 0 ) capacitor c=0.0124204f //x=4.97 //y=1.585
c176 ( 52 0 ) capacitor c=0.0157803f //x=4.97 //y=0.93
c177 ( 51 0 ) capacitor c=0.0903385f //x=4.595 //y=2.095
c178 ( 50 0 ) capacitor c=0.0194674f //x=4.595 //y=1.74
c179 ( 49 0 ) capacitor c=0.0168481f //x=4.595 //y=1.43
c180 ( 48 0 ) capacitor c=0.0174345f //x=4.595 //y=1.085
c181 ( 47 0 ) capacitor c=0.110797f //x=7.49 //y=6.2
c182 ( 46 0 ) capacitor c=0.154322f //x=7.05 //y=6.2
c183 ( 34 0 ) capacitor c=0.00677679f //x=10.195 //y=4.76
c184 ( 33 0 ) capacitor c=0.0108929f //x=10.39 //y=4.76
c185 ( 32 0 ) capacitor c=0.00580686f //x=10.195 //y=2.26
c186 ( 31 0 ) capacitor c=0.0136419f //x=10.395 //y=2.26
c187 ( 28 0 ) capacitor c=0.0776979f //x=10.11 //y=3.14
c188 ( 20 0 ) capacitor c=0.0151654f //x=7.15 //y=4.62
c189 ( 14 0 ) capacitor c=0.0307811f //x=4.93 //y=2.26
c190 ( 4 0 ) capacitor c=0.0147835f //x=7.265 //y=4.62
c191 ( 3 0 ) capacitor c=0.0734001f //x=9.995 //y=4.62
c192 ( 2 0 ) capacitor c=0.015418f //x=5.045 //y=3.14
c193 ( 1 0 ) capacitor c=0.112479f //x=9.995 //y=3.14
r194 (  71 73 ) resistor r=20.6867 //w=0.233 //l=0.1 //layer=ply \
 //thickness=0.18 //x=7.05 //y=4.88 //x2=7.15 //y2=4.88
r195 (  62 73 ) resistor r=70.3348 //w=0.233 //l=0.414367 //layer=ply \
 //thickness=0.18 //x=7.49 //y=5.045 //x2=7.15 //y2=4.88
r196 (  59 71 ) resistor r=13.0941 //w=0.233 //l=0.165 //layer=ply \
 //thickness=0.18 //x=7.05 //y=5.045 //x2=7.05 //y2=4.88
r197 (  58 70 ) resistor r=45.1352 //w=0.168 //l=0.173853 //layer=ply \
 //thickness=0.18 //x=5.125 //y=1.43 //x2=5.085 //y2=1.585
r198 (  57 69 ) resistor r=45.1352 //w=0.168 //l=0.173853 //layer=ply \
 //thickness=0.18 //x=5.125 //y=1.085 //x2=5.085 //y2=0.93
r199 (  57 58 ) resistor r=176.904 //w=0.094 //l=0.345 //layer=ply \
 //thickness=0.18 //x=5.125 //y=1.085 //x2=5.125 //y2=1.43
r200 (  55 66 ) resistor r=10.701 //w=0.21 //l=0.115 //layer=ply \
 //thickness=0.18 //x=4.75 //y=1.585 //x2=4.635 //y2=1.585
r201 (  54 70 ) resistor r=5.52526 //w=0.168 //l=0.115 //layer=ply \
 //thickness=0.18 //x=4.97 //y=1.585 //x2=5.085 //y2=1.585
r202 (  53 65 ) resistor r=5.52526 //w=0.168 //l=0.115 //layer=ply \
 //thickness=0.18 //x=4.75 //y=0.93 //x2=4.635 //y2=0.93
r203 (  52 69 ) resistor r=5.52526 //w=0.168 //l=0.115 //layer=ply \
 //thickness=0.18 //x=4.97 //y=0.93 //x2=5.085 //y2=0.93
r204 (  52 53 ) resistor r=112.809 //w=0.094 //l=0.22 //layer=ply \
 //thickness=0.18 //x=4.97 //y=0.93 //x2=4.75 //y2=0.93
r205 (  51 68 ) resistor r=67.2792 //w=0.24 //l=0.438891 //layer=ply \
 //thickness=0.18 //x=4.595 //y=2.095 //x2=4.93 //y2=2.335
r206 (  50 66 ) resistor r=39.5823 //w=0.21 //l=0.173853 //layer=ply \
 //thickness=0.18 //x=4.595 //y=1.74 //x2=4.635 //y2=1.585
r207 (  50 51 ) resistor r=182.032 //w=0.094 //l=0.355 //layer=ply \
 //thickness=0.18 //x=4.595 //y=1.74 //x2=4.595 //y2=2.095
r208 (  49 66 ) resistor r=39.5823 //w=0.21 //l=0.173853 //layer=ply \
 //thickness=0.18 //x=4.595 //y=1.43 //x2=4.635 //y2=1.585
r209 (  48 65 ) resistor r=45.1352 //w=0.168 //l=0.173853 //layer=ply \
 //thickness=0.18 //x=4.595 //y=1.085 //x2=4.635 //y2=0.93
r210 (  48 49 ) resistor r=176.904 //w=0.094 //l=0.345 //layer=ply \
 //thickness=0.18 //x=4.595 //y=1.085 //x2=4.595 //y2=1.43
r211 (  47 62 ) resistor r=592.245 //w=0.094 //l=1.155 //layer=ply \
 //thickness=0.18 //x=7.49 //y=6.2 //x2=7.49 //y2=5.045
r212 (  46 59 ) resistor r=592.245 //w=0.094 //l=1.155 //layer=ply \
 //thickness=0.18 //x=7.05 //y=6.2 //x2=7.05 //y2=5.045
r213 (  45 54 ) resistor r=56.4043 //w=0.094 //l=0.11 //layer=ply \
 //thickness=0.18 //x=4.86 //y=1.585 //x2=4.97 //y2=1.585
r214 (  45 55 ) resistor r=56.4043 //w=0.094 //l=0.11 //layer=ply \
 //thickness=0.18 //x=4.86 //y=1.585 //x2=4.75 //y2=1.585
r215 (  41 74 ) resistor r=67.7647 //w=0.187 //l=0.99 //layer=li \
 //thickness=0.1 //x=10.48 //y=2.175 //x2=10.48 //y2=1.185
r216 (  35 76 ) resistor r=72.5562 //w=0.187 //l=1.06 //layer=li \
 //thickness=0.1 //x=10.475 //y=4.845 //x2=10.475 //y2=5.905
r217 (  33 35 ) resistor r=7.15173 //w=0.17 //l=0.120208 //layer=li \
 //thickness=0.1 //x=10.39 //y=4.76 //x2=10.475 //y2=4.845
r218 (  33 34 ) resistor r=13.3476 //w=0.187 //l=0.195 //layer=li \
 //thickness=0.1 //x=10.39 //y=4.76 //x2=10.195 //y2=4.76
r219 (  31 41 ) resistor r=7.15173 //w=0.17 //l=0.120208 //layer=li \
 //thickness=0.1 //x=10.395 //y=2.26 //x2=10.48 //y2=2.175
r220 (  31 32 ) resistor r=13.6898 //w=0.187 //l=0.2 //layer=li \
 //thickness=0.1 //x=10.395 //y=2.26 //x2=10.195 //y2=2.26
r221 (  28 30 ) resistor r=101.305 //w=0.187 //l=1.48 //layer=li \
 //thickness=0.1 //x=10.11 //y=3.14 //x2=10.11 //y2=4.62
r222 (  26 34 ) resistor r=7.15173 //w=0.17 //l=0.120208 //layer=li \
 //thickness=0.1 //x=10.11 //y=4.675 //x2=10.195 //y2=4.76
r223 (  26 30 ) resistor r=3.76471 //w=0.187 //l=0.055 //layer=li \
 //thickness=0.1 //x=10.11 //y=4.675 //x2=10.11 //y2=4.62
r224 (  25 32 ) resistor r=7.15173 //w=0.17 //l=0.120208 //layer=li \
 //thickness=0.1 //x=10.11 //y=2.345 //x2=10.195 //y2=2.26
r225 (  25 28 ) resistor r=54.4171 //w=0.187 //l=0.795 //layer=li \
 //thickness=0.1 //x=10.11 //y=2.345 //x2=10.11 //y2=3.14
r226 (  23 73 ) resistor r=152 //w=0.17 //l=0.17 //layer=licon //count=1 \
 //x=7.15 //y=4.88 //x2=7.15 //y2=4.88
r227 (  20 23 ) resistor r=17.7968 //w=0.187 //l=0.26 //layer=li \
 //thickness=0.1 //x=7.15 //y=4.62 //x2=7.15 //y2=4.88
r228 (  14 68 ) resistor r=152 //w=0.17 //l=0.17 //layer=licon //count=1 \
 //x=4.93 //y=2.26 //x2=4.93 //y2=2.26
r229 (  14 17 ) resistor r=60.2353 //w=0.187 //l=0.88 //layer=li \
 //thickness=0.1 //x=4.93 //y=2.26 //x2=4.93 //y2=3.14
r230 (  12 30 ) resistor r=9.3 //w=0.17 //l=0.17 //layer=mcon //count=1 \
 //x=10.11 //y=4.62 //x2=10.11 //y2=4.62
r231 (  10 28 ) resistor r=9.3 //w=0.17 //l=0.17 //layer=mcon //count=1 \
 //x=10.11 //y=3.14 //x2=10.11 //y2=3.14
r232 (  8 20 ) resistor r=9.3 //w=0.17 //l=0.17 //layer=mcon //count=1 \
 //x=7.15 //y=4.62 //x2=7.15 //y2=4.62
r233 (  6 17 ) resistor r=9.3 //w=0.17 //l=0.17 //layer=mcon //count=1 \
 //x=4.93 //y=3.14 //x2=4.93 //y2=3.14
r234 (  4 8 ) resistor r=0.0717383 //w=0.224 //l=0.115 //layer=m1 \
 //thickness=0.36 //x=7.265 //y=4.62 //x2=7.15 //y2=4.62
r235 (  3 12 ) resistor r=0.0717383 //w=0.224 //l=0.115 //layer=m1 \
 //thickness=0.36 //x=9.995 //y=4.62 //x2=10.11 //y2=4.62
r236 (  3 4 ) resistor r=2.60496 //w=0.131 //l=2.73 //layer=m1 \
 //thickness=0.36 //x=9.995 //y=4.62 //x2=7.265 //y2=4.62
r237 (  2 6 ) resistor r=0.0717383 //w=0.224 //l=0.115 //layer=m1 \
 //thickness=0.36 //x=5.045 //y=3.14 //x2=4.93 //y2=3.14
r238 (  1 10 ) resistor r=0.0717383 //w=0.224 //l=0.115 //layer=m1 \
 //thickness=0.36 //x=9.995 //y=3.14 //x2=10.11 //y2=3.14
r239 (  1 2 ) resistor r=4.72328 //w=0.131 //l=4.95 //layer=m1 \
 //thickness=0.36 //x=9.995 //y=3.14 //x2=5.045 //y2=3.14
ends PM_XNOR2X1\%noxref_6

subckt PM_XNOR2X1\%B ( 1 2 3 4 13 14 15 16 17 18 19 20 21 22 31 38 51 52 53 54 \
 55 56 63 64 65 66 67 69 72 73 74 75 79 80 81 83 86 89 90 91 92 94 106 )
c172 ( 106 0 ) capacitor c=0.0528806f //x=10.74 //y=2.265
c173 ( 94 0 ) capacitor c=0.0636249f //x=4.93 //y=4.88
c174 ( 92 0 ) capacitor c=0.0290017f //x=10.74 //y=2.1
c175 ( 91 0 ) capacitor c=0.0250171f //x=10.74 //y=1.745
c176 ( 90 0 ) capacitor c=0.0234316f //x=10.74 //y=1.435
c177 ( 89 0 ) capacitor c=0.0200712f //x=10.74 //y=1.09
c178 ( 86 0 ) capacitor c=0.048995f //x=10.695 //y=5.045
c179 ( 83 0 ) capacitor c=0.0152946f //x=10.585 //y=1.59
c180 ( 81 0 ) capacitor c=0.0157804f //x=10.585 //y=0.935
c181 ( 80 0 ) capacitor c=0.0129718f //x=10.33 //y=4.97
c182 ( 79 0 ) capacitor c=0.0173378f //x=10.62 //y=4.97
c183 ( 75 0 ) capacitor c=0.0435512f //x=10.21 //y=1.435
c184 ( 74 0 ) capacitor c=0.0200269f //x=10.21 //y=1.09
c185 ( 73 0 ) capacitor c=0.0318948f //x=7.485 //y=1.39
c186 ( 72 0 ) capacitor c=0.0187384f //x=7.485 //y=1.045
c187 ( 69 0 ) capacitor c=0.0141798f //x=7.33 //y=1.545
c188 ( 67 0 ) capacitor c=0.0149844f //x=7.33 //y=0.89
c189 ( 66 0 ) capacitor c=0.0836842f //x=6.955 //y=2.095
c190 ( 65 0 ) capacitor c=0.0229722f //x=6.955 //y=1.7
c191 ( 64 0 ) capacitor c=0.0234352f //x=6.955 //y=1.39
c192 ( 63 0 ) capacitor c=0.0199343f //x=6.955 //y=1.045
c193 ( 56 0 ) capacitor c=0.154243f //x=10.695 //y=6.2
c194 ( 55 0 ) capacitor c=0.154218f //x=10.255 //y=6.2
c195 ( 54 0 ) capacitor c=0.153255f //x=5.04 //y=6.2
c196 ( 53 0 ) capacitor c=0.110227f //x=4.6 //y=6.2
c197 ( 38 0 ) capacitor c=0.105618f //x=10.85 //y=2.265
c198 ( 31 0 ) capacitor c=0.0551304f //x=7.15 //y=2.26
c199 ( 13 0 ) capacitor c=0.024985f //x=4.93 //y=4.25
c200 ( 4 0 ) capacitor c=0.0128852f //x=7.265 //y=3.51
c201 ( 3 0 ) capacitor c=0.0700854f //x=10.735 //y=3.51
c202 ( 2 0 ) capacitor c=0.0109109f //x=5.045 //y=4.25
c203 ( 1 0 ) capacitor c=0.123037f //x=10.735 //y=4.25
r204 (  106 108 ) resistor r=17.5563 //w=0.302 //l=0.11 //layer=ply \
 //thickness=0.18 //x=10.74 //y=2.265 //x2=10.85 //y2=2.265
r205 (  94 95 ) resistor r=22.7554 //w=0.233 //l=0.11 //layer=ply \
 //thickness=0.18 //x=4.93 //y=4.88 //x2=5.04 //y2=4.88
r206 (  92 106 ) resistor r=19.1248 //w=0.302 //l=0.165 //layer=ply \
 //thickness=0.18 //x=10.74 //y=2.1 //x2=10.74 //y2=2.265
r207 (  91 105 ) resistor r=39.5823 //w=0.21 //l=0.173853 //layer=ply \
 //thickness=0.18 //x=10.74 //y=1.745 //x2=10.7 //y2=1.59
r208 (  91 92 ) resistor r=182.032 //w=0.094 //l=0.355 //layer=ply \
 //thickness=0.18 //x=10.74 //y=1.745 //x2=10.74 //y2=2.1
r209 (  90 105 ) resistor r=39.5823 //w=0.21 //l=0.173853 //layer=ply \
 //thickness=0.18 //x=10.74 //y=1.435 //x2=10.7 //y2=1.59
r210 (  89 104 ) resistor r=45.1352 //w=0.168 //l=0.173853 //layer=ply \
 //thickness=0.18 //x=10.74 //y=1.09 //x2=10.7 //y2=0.935
r211 (  89 90 ) resistor r=176.904 //w=0.094 //l=0.345 //layer=ply \
 //thickness=0.18 //x=10.74 //y=1.09 //x2=10.74 //y2=1.435
r212 (  86 110 ) resistor r=26.3063 //w=0.284 //l=0.229783 //layer=ply \
 //thickness=0.18 //x=10.695 //y=5.045 //x2=10.85 //y2=4.88
r213 (  84 103 ) resistor r=5.52526 //w=0.168 //l=0.115 //layer=ply \
 //thickness=0.18 //x=10.365 //y=1.59 //x2=10.25 //y2=1.59
r214 (  83 105 ) resistor r=10.701 //w=0.21 //l=0.115 //layer=ply \
 //thickness=0.18 //x=10.585 //y=1.59 //x2=10.7 //y2=1.59
r215 (  82 102 ) resistor r=5.52526 //w=0.168 //l=0.115 //layer=ply \
 //thickness=0.18 //x=10.365 //y=0.935 //x2=10.25 //y2=0.935
r216 (  81 104 ) resistor r=5.52526 //w=0.168 //l=0.115 //layer=ply \
 //thickness=0.18 //x=10.585 //y=0.935 //x2=10.7 //y2=0.935
r217 (  81 82 ) resistor r=112.809 //w=0.094 //l=0.22 //layer=ply \
 //thickness=0.18 //x=10.585 //y=0.935 //x2=10.365 //y2=0.935
r218 (  79 86 ) resistor r=23.403 //w=0.284 //l=0.106066 //layer=ply \
 //thickness=0.18 //x=10.62 //y=4.97 //x2=10.695 //y2=5.045
r219 (  79 80 ) resistor r=148.702 //w=0.094 //l=0.29 //layer=ply \
 //thickness=0.18 //x=10.62 //y=4.97 //x2=10.33 //y2=4.97
r220 (  76 80 ) resistor r=26.9307 //w=0.15 //l=0.106066 //layer=ply \
 //thickness=0.18 //x=10.255 //y=5.045 //x2=10.33 //y2=4.97
r221 (  75 103 ) resistor r=45.1352 //w=0.168 //l=0.173853 //layer=ply \
 //thickness=0.18 //x=10.21 //y=1.435 //x2=10.25 //y2=1.59
r222 (  74 102 ) resistor r=45.1352 //w=0.168 //l=0.173853 //layer=ply \
 //thickness=0.18 //x=10.21 //y=1.09 //x2=10.25 //y2=0.935
r223 (  74 75 ) resistor r=176.904 //w=0.094 //l=0.345 //layer=ply \
 //thickness=0.18 //x=10.21 //y=1.09 //x2=10.21 //y2=1.435
r224 (  73 101 ) resistor r=45.1352 //w=0.168 //l=0.173853 //layer=ply \
 //thickness=0.18 //x=7.485 //y=1.39 //x2=7.445 //y2=1.545
r225 (  72 100 ) resistor r=45.1352 //w=0.168 //l=0.173853 //layer=ply \
 //thickness=0.18 //x=7.485 //y=1.045 //x2=7.445 //y2=0.89
r226 (  72 73 ) resistor r=176.904 //w=0.094 //l=0.345 //layer=ply \
 //thickness=0.18 //x=7.485 //y=1.045 //x2=7.485 //y2=1.39
r227 (  70 99 ) resistor r=10.701 //w=0.21 //l=0.115 //layer=ply \
 //thickness=0.18 //x=7.11 //y=1.545 //x2=6.995 //y2=1.545
r228 (  69 101 ) resistor r=5.52526 //w=0.168 //l=0.115 //layer=ply \
 //thickness=0.18 //x=7.33 //y=1.545 //x2=7.445 //y2=1.545
r229 (  68 98 ) resistor r=5.52526 //w=0.168 //l=0.115 //layer=ply \
 //thickness=0.18 //x=7.11 //y=0.89 //x2=6.995 //y2=0.89
r230 (  67 100 ) resistor r=5.52526 //w=0.168 //l=0.115 //layer=ply \
 //thickness=0.18 //x=7.33 //y=0.89 //x2=7.445 //y2=0.89
r231 (  67 68 ) resistor r=112.809 //w=0.094 //l=0.22 //layer=ply \
 //thickness=0.18 //x=7.33 //y=0.89 //x2=7.11 //y2=0.89
r232 (  66 97 ) resistor r=34.8111 //w=0.27 //l=0.264953 //layer=ply \
 //thickness=0.18 //x=6.955 //y=2.095 //x2=7.15 //y2=2.26
r233 (  65 99 ) resistor r=39.5823 //w=0.21 //l=0.173853 //layer=ply \
 //thickness=0.18 //x=6.955 //y=1.7 //x2=6.995 //y2=1.545
r234 (  65 66 ) resistor r=202.543 //w=0.094 //l=0.395 //layer=ply \
 //thickness=0.18 //x=6.955 //y=1.7 //x2=6.955 //y2=2.095
r235 (  64 99 ) resistor r=39.5823 //w=0.21 //l=0.173853 //layer=ply \
 //thickness=0.18 //x=6.955 //y=1.39 //x2=6.995 //y2=1.545
r236 (  63 98 ) resistor r=45.1352 //w=0.168 //l=0.173853 //layer=ply \
 //thickness=0.18 //x=6.955 //y=1.045 //x2=6.995 //y2=0.89
r237 (  63 64 ) resistor r=176.904 //w=0.094 //l=0.345 //layer=ply \
 //thickness=0.18 //x=6.955 //y=1.045 //x2=6.955 //y2=1.39
r238 (  60 95 ) resistor r=13.0941 //w=0.233 //l=0.165 //layer=ply \
 //thickness=0.18 //x=5.04 //y=5.045 //x2=5.04 //y2=4.88
r239 (  57 94 ) resistor r=68.2661 //w=0.233 //l=0.404166 //layer=ply \
 //thickness=0.18 //x=4.6 //y=5.045 //x2=4.93 //y2=4.88
r240 (  56 86 ) resistor r=592.245 //w=0.094 //l=1.155 //layer=ply \
 //thickness=0.18 //x=10.695 //y=6.2 //x2=10.695 //y2=5.045
r241 (  55 76 ) resistor r=592.245 //w=0.094 //l=1.155 //layer=ply \
 //thickness=0.18 //x=10.255 //y=6.2 //x2=10.255 //y2=5.045
r242 (  54 60 ) resistor r=592.245 //w=0.094 //l=1.155 //layer=ply \
 //thickness=0.18 //x=5.04 //y=6.2 //x2=5.04 //y2=5.045
r243 (  53 57 ) resistor r=592.245 //w=0.094 //l=1.155 //layer=ply \
 //thickness=0.18 //x=4.6 //y=6.2 //x2=4.6 //y2=5.045
r244 (  52 83 ) resistor r=56.4043 //w=0.094 //l=0.11 //layer=ply \
 //thickness=0.18 //x=10.475 //y=1.59 //x2=10.585 //y2=1.59
r245 (  52 84 ) resistor r=56.4043 //w=0.094 //l=0.11 //layer=ply \
 //thickness=0.18 //x=10.475 //y=1.59 //x2=10.365 //y2=1.59
r246 (  51 69 ) resistor r=56.4043 //w=0.094 //l=0.11 //layer=ply \
 //thickness=0.18 //x=7.22 //y=1.545 //x2=7.33 //y2=1.545
r247 (  51 70 ) resistor r=56.4043 //w=0.094 //l=0.11 //layer=ply \
 //thickness=0.18 //x=7.22 //y=1.545 //x2=7.11 //y2=1.545
r248 (  49 110 ) resistor r=152 //w=0.17 //l=0.17 //layer=licon //count=1 \
 //x=10.85 //y=4.88 //x2=10.85 //y2=4.88
r249 (  38 108 ) resistor r=152 //w=0.17 //l=0.17 //layer=licon //count=1 \
 //x=10.85 //y=2.265 //x2=10.85 //y2=2.265
r250 (  31 97 ) resistor r=152 //w=0.17 //l=0.17 //layer=licon //count=1 \
 //x=7.15 //y=2.26 //x2=7.15 //y2=2.26
r251 (  28 94 ) resistor r=152 //w=0.17 //l=0.17 //layer=licon //count=1 \
 //x=4.93 //y=4.88 //x2=4.93 //y2=4.88
r252 (  22 49 ) resistor r=17.7968 //w=0.187 //l=0.26 //layer=li \
 //thickness=0.1 //x=10.85 //y=4.62 //x2=10.85 //y2=4.88
r253 (  21 22 ) resistor r=25.3262 //w=0.187 //l=0.37 //layer=li \
 //thickness=0.1 //x=10.85 //y=4.25 //x2=10.85 //y2=4.62
r254 (  20 21 ) resistor r=25.3262 //w=0.187 //l=0.37 //layer=li \
 //thickness=0.1 //x=10.85 //y=3.88 //x2=10.85 //y2=4.25
r255 (  19 20 ) resistor r=25.3262 //w=0.187 //l=0.37 //layer=li \
 //thickness=0.1 //x=10.85 //y=3.51 //x2=10.85 //y2=3.88
r256 (  18 19 ) resistor r=25.3262 //w=0.187 //l=0.37 //layer=li \
 //thickness=0.1 //x=10.85 //y=3.14 //x2=10.85 //y2=3.51
r257 (  17 18 ) resistor r=25.3262 //w=0.187 //l=0.37 //layer=li \
 //thickness=0.1 //x=10.85 //y=2.77 //x2=10.85 //y2=3.14
r258 (  17 38 ) resistor r=34.5668 //w=0.187 //l=0.505 //layer=li \
 //thickness=0.1 //x=10.85 //y=2.77 //x2=10.85 //y2=2.265
r259 (  15 16 ) resistor r=75.9786 //w=0.187 //l=1.11 //layer=li \
 //thickness=0.1 //x=7.15 //y=2.4 //x2=7.15 //y2=3.51
r260 (  15 31 ) resistor r=9.58289 //w=0.187 //l=0.14 //layer=li \
 //thickness=0.1 //x=7.15 //y=2.4 //x2=7.15 //y2=2.26
r261 (  14 28 ) resistor r=17.7968 //w=0.187 //l=0.26 //layer=li \
 //thickness=0.1 //x=4.93 //y=4.62 //x2=4.93 //y2=4.88
r262 (  13 14 ) resistor r=25.3262 //w=0.187 //l=0.37 //layer=li \
 //thickness=0.1 //x=4.93 //y=4.25 //x2=4.93 //y2=4.62
r263 (  12 21 ) resistor r=9.3 //w=0.17 //l=0.17 //layer=mcon //count=1 \
 //x=10.85 //y=4.25 //x2=10.85 //y2=4.25
r264 (  10 19 ) resistor r=9.3 //w=0.17 //l=0.17 //layer=mcon //count=1 \
 //x=10.85 //y=3.51 //x2=10.85 //y2=3.51
r265 (  8 16 ) resistor r=9.3 //w=0.17 //l=0.17 //layer=mcon //count=1 \
 //x=7.15 //y=3.51 //x2=7.15 //y2=3.51
r266 (  6 13 ) resistor r=9.3 //w=0.17 //l=0.17 //layer=mcon //count=1 \
 //x=4.93 //y=4.25 //x2=4.93 //y2=4.25
r267 (  4 8 ) resistor r=0.0717383 //w=0.224 //l=0.115 //layer=m1 \
 //thickness=0.36 //x=7.265 //y=3.51 //x2=7.15 //y2=3.51
r268 (  3 10 ) resistor r=0.0717383 //w=0.224 //l=0.115 //layer=m1 \
 //thickness=0.36 //x=10.735 //y=3.51 //x2=10.85 //y2=3.51
r269 (  3 4 ) resistor r=3.31107 //w=0.131 //l=3.47 //layer=m1 \
 //thickness=0.36 //x=10.735 //y=3.51 //x2=7.265 //y2=3.51
r270 (  2 6 ) resistor r=0.0717383 //w=0.224 //l=0.115 //layer=m1 \
 //thickness=0.36 //x=5.045 //y=4.25 //x2=4.93 //y2=4.25
r271 (  1 12 ) resistor r=0.0717383 //w=0.224 //l=0.115 //layer=m1 \
 //thickness=0.36 //x=10.735 //y=4.25 //x2=10.85 //y2=4.25
r272 (  1 2 ) resistor r=5.42939 //w=0.131 //l=5.69 //layer=m1 \
 //thickness=0.36 //x=10.735 //y=4.25 //x2=5.045 //y2=4.25
ends PM_XNOR2X1\%B

subckt PM_XNOR2X1\%noxref_8 ( 7 8 15 16 23 24 25 )
c40 ( 25 0 ) capacitor c=0.0306618f //x=5.115 //y=5.2
c41 ( 24 0 ) capacitor c=0.0185379f //x=4.235 //y=5.2
c42 ( 23 0 ) capacitor c=0.0384176f //x=3.365 //y=5.2
c43 ( 16 0 ) capacitor c=0.00194711f //x=4.465 //y=7.085
c44 ( 15 0 ) capacitor c=0.014216f //x=5.175 //y=7.085
c45 ( 8 0 ) capacitor c=0.00644339f //x=3.585 //y=5.385
c46 ( 7 0 ) capacitor c=0.0212224f //x=4.295 //y=5.385
r47 (  17 25 ) resistor r=5.81818 //w=0.187 //l=0.085 //layer=li \
 //thickness=0.1 //x=5.26 //y=7 //x2=5.26 //y2=6.915
r48 (  15 17 ) resistor r=7.15173 //w=0.17 //l=0.120208 //layer=li \
 //thickness=0.1 //x=5.175 //y=7.085 //x2=5.26 //y2=7
r49 (  15 16 ) resistor r=48.5989 //w=0.187 //l=0.71 //layer=li \
 //thickness=0.1 //x=5.175 //y=7.085 //x2=4.465 //y2=7.085
r50 (  10 16 ) resistor r=7.15173 //w=0.17 //l=0.120208 //layer=li \
 //thickness=0.1 //x=4.38 //y=7 //x2=4.465 //y2=7.085
r51 (  10 24 ) resistor r=29.0909 //w=0.187 //l=0.425 //layer=li \
 //thickness=0.1 //x=4.38 //y=7 //x2=4.38 //y2=6.575
r52 (  9 24 ) resistor r=29.0909 //w=0.187 //l=0.425 //layer=li \
 //thickness=0.1 //x=4.38 //y=5.47 //x2=4.38 //y2=5.895
r53 (  7 9 ) resistor r=7.15173 //w=0.17 //l=0.120208 //layer=li \
 //thickness=0.1 //x=4.295 //y=5.385 //x2=4.38 //y2=5.47
r54 (  7 8 ) resistor r=48.5989 //w=0.187 //l=0.71 //layer=li //thickness=0.1 \
 //x=4.295 //y=5.385 //x2=3.585 //y2=5.385
r55 (  1 8 ) resistor r=7.15173 //w=0.17 //l=0.120208 //layer=li \
 //thickness=0.1 //x=3.5 //y=5.47 //x2=3.585 //y2=5.385
r56 (  1 23 ) resistor r=29.0909 //w=0.187 //l=0.425 //layer=li \
 //thickness=0.1 //x=3.5 //y=5.47 //x2=3.5 //y2=5.895
ends PM_XNOR2X1\%noxref_8

subckt PM_XNOR2X1\%noxref_9 ( 1 5 9 10 13 17 29 )
c52 ( 29 0 ) capacitor c=0.0631075f //x=3.27 //y=0.545
c53 ( 17 0 ) capacitor c=0.00722223f //x=5.345 //y=0.795
c54 ( 13 0 ) capacitor c=0.0153021f //x=5.26 //y=0.71
c55 ( 10 0 ) capacitor c=0.00657137f //x=4.375 //y=1.675
c56 ( 9 0 ) capacitor c=0.006761f //x=4.375 //y=0.795
c57 ( 5 0 ) capacitor c=0.0181202f //x=4.29 //y=1.76
c58 ( 1 0 ) capacitor c=0.00765941f //x=3.405 //y=1.675
r59 (  17 29 ) resistor r=3.57586 //w=0.17 //l=0.125 //layer=li \
 //thickness=0.1 //x=5.345 //y=0.795 //x2=5.345 //y2=0.67
r60 (  17 29 ) resistor r=18.139 //w=0.187 //l=0.265 //layer=li \
 //thickness=0.1 //x=5.345 //y=0.795 //x2=5.345 //y2=1.06
r61 (  14 29 ) resistor r=3.57586 //w=0.17 //l=0.103078 //layer=li \
 //thickness=0.1 //x=4.46 //y=0.71 //x2=4.375 //y2=0.67
r62 (  14 29 ) resistor r=27.3797 //w=0.187 //l=0.4 //layer=li //thickness=0.1 \
 //x=4.46 //y=0.71 //x2=4.86 //y2=0.71
r63 (  13 29 ) resistor r=3.57586 //w=0.17 //l=0.103078 //layer=li \
 //thickness=0.1 //x=5.26 //y=0.71 //x2=5.345 //y2=0.67
r64 (  13 29 ) resistor r=27.3797 //w=0.187 //l=0.4 //layer=li //thickness=0.1 \
 //x=5.26 //y=0.71 //x2=4.86 //y2=0.71
r65 (  10 29 ) resistor r=3.57586 //w=0.17 //l=0.125 //layer=li \
 //thickness=0.1 //x=4.375 //y=1.675 //x2=4.375 //y2=1.8
r66 (  10 29 ) resistor r=42.0963 //w=0.187 //l=0.615 //layer=li \
 //thickness=0.1 //x=4.375 //y=1.675 //x2=4.375 //y2=1.06
r67 (  9 29 ) resistor r=3.57586 //w=0.17 //l=0.125 //layer=li //thickness=0.1 \
 //x=4.375 //y=0.795 //x2=4.375 //y2=0.67
r68 (  9 29 ) resistor r=18.139 //w=0.187 //l=0.265 //layer=li //thickness=0.1 \
 //x=4.375 //y=0.795 //x2=4.375 //y2=1.06
r69 (  6 29 ) resistor r=3.57586 //w=0.17 //l=0.103078 //layer=li \
 //thickness=0.1 //x=3.49 //y=1.76 //x2=3.405 //y2=1.8
r70 (  6 29 ) resistor r=27.3797 //w=0.187 //l=0.4 //layer=li //thickness=0.1 \
 //x=3.49 //y=1.76 //x2=3.89 //y2=1.76
r71 (  5 29 ) resistor r=3.57586 //w=0.17 //l=0.103078 //layer=li \
 //thickness=0.1 //x=4.29 //y=1.76 //x2=4.375 //y2=1.8
r72 (  5 29 ) resistor r=27.3797 //w=0.187 //l=0.4 //layer=li //thickness=0.1 \
 //x=4.29 //y=1.76 //x2=3.89 //y2=1.76
r73 (  1 29 ) resistor r=3.57586 //w=0.17 //l=0.125 //layer=li //thickness=0.1 \
 //x=3.405 //y=1.675 //x2=3.405 //y2=1.8
r74 (  1 29 ) resistor r=42.0963 //w=0.187 //l=0.615 //layer=li \
 //thickness=0.1 //x=3.405 //y=1.675 //x2=3.405 //y2=1.06
ends PM_XNOR2X1\%noxref_9

subckt PM_XNOR2X1\%noxref_10 ( 7 8 15 16 23 24 25 )
c43 ( 25 0 ) capacitor c=0.0305804f //x=8.445 //y=5.2
c44 ( 24 0 ) capacitor c=0.0185379f //x=7.565 //y=5.2
c45 ( 23 0 ) capacitor c=0.0384176f //x=6.695 //y=5.2
c46 ( 16 0 ) capacitor c=0.00194711f //x=7.795 //y=7.085
c47 ( 15 0 ) capacitor c=0.0133643f //x=8.505 //y=7.085
c48 ( 8 0 ) capacitor c=0.00631451f //x=6.915 //y=5.385
c49 ( 7 0 ) capacitor c=0.0183784f //x=7.625 //y=5.385
r50 (  17 25 ) resistor r=5.81818 //w=0.187 //l=0.085 //layer=li \
 //thickness=0.1 //x=8.59 //y=7 //x2=8.59 //y2=6.915
r51 (  15 17 ) resistor r=7.15173 //w=0.17 //l=0.120208 //layer=li \
 //thickness=0.1 //x=8.505 //y=7.085 //x2=8.59 //y2=7
r52 (  15 16 ) resistor r=48.5989 //w=0.187 //l=0.71 //layer=li \
 //thickness=0.1 //x=8.505 //y=7.085 //x2=7.795 //y2=7.085
r53 (  10 16 ) resistor r=7.15173 //w=0.17 //l=0.120208 //layer=li \
 //thickness=0.1 //x=7.71 //y=7 //x2=7.795 //y2=7.085
r54 (  10 24 ) resistor r=29.0909 //w=0.187 //l=0.425 //layer=li \
 //thickness=0.1 //x=7.71 //y=7 //x2=7.71 //y2=6.575
r55 (  9 24 ) resistor r=29.0909 //w=0.187 //l=0.425 //layer=li \
 //thickness=0.1 //x=7.71 //y=5.47 //x2=7.71 //y2=5.895
r56 (  7 9 ) resistor r=7.15173 //w=0.17 //l=0.120208 //layer=li \
 //thickness=0.1 //x=7.625 //y=5.385 //x2=7.71 //y2=5.47
r57 (  7 8 ) resistor r=48.5989 //w=0.187 //l=0.71 //layer=li //thickness=0.1 \
 //x=7.625 //y=5.385 //x2=6.915 //y2=5.385
r58 (  1 8 ) resistor r=7.15173 //w=0.17 //l=0.120208 //layer=li \
 //thickness=0.1 //x=6.83 //y=5.47 //x2=6.915 //y2=5.385
r59 (  1 23 ) resistor r=29.0909 //w=0.187 //l=0.425 //layer=li \
 //thickness=0.1 //x=6.83 //y=5.47 //x2=6.83 //y2=5.895
ends PM_XNOR2X1\%noxref_10

subckt PM_XNOR2X1\%noxref_11 ( 1 5 9 10 13 17 29 )
c53 ( 29 0 ) capacitor c=0.0633115f //x=6.6 //y=0.545
c54 ( 17 0 ) capacitor c=0.00722223f //x=8.675 //y=0.795
c55 ( 13 0 ) capacitor c=0.015319f //x=8.59 //y=0.71
c56 ( 10 0 ) capacitor c=0.00657137f //x=7.705 //y=1.675
c57 ( 9 0 ) capacitor c=0.006761f //x=7.705 //y=0.795
c58 ( 5 0 ) capacitor c=0.0181202f //x=7.62 //y=1.76
c59 ( 1 0 ) capacitor c=0.00765941f //x=6.735 //y=1.675
r60 (  17 29 ) resistor r=3.57586 //w=0.17 //l=0.125 //layer=li \
 //thickness=0.1 //x=8.675 //y=0.795 //x2=8.675 //y2=0.67
r61 (  17 29 ) resistor r=18.139 //w=0.187 //l=0.265 //layer=li \
 //thickness=0.1 //x=8.675 //y=0.795 //x2=8.675 //y2=1.06
r62 (  14 29 ) resistor r=3.57586 //w=0.17 //l=0.103078 //layer=li \
 //thickness=0.1 //x=7.79 //y=0.71 //x2=7.705 //y2=0.67
r63 (  14 29 ) resistor r=27.3797 //w=0.187 //l=0.4 //layer=li //thickness=0.1 \
 //x=7.79 //y=0.71 //x2=8.19 //y2=0.71
r64 (  13 29 ) resistor r=3.57586 //w=0.17 //l=0.103078 //layer=li \
 //thickness=0.1 //x=8.59 //y=0.71 //x2=8.675 //y2=0.67
r65 (  13 29 ) resistor r=27.3797 //w=0.187 //l=0.4 //layer=li //thickness=0.1 \
 //x=8.59 //y=0.71 //x2=8.19 //y2=0.71
r66 (  10 29 ) resistor r=3.57586 //w=0.17 //l=0.125 //layer=li \
 //thickness=0.1 //x=7.705 //y=1.675 //x2=7.705 //y2=1.8
r67 (  10 29 ) resistor r=42.0963 //w=0.187 //l=0.615 //layer=li \
 //thickness=0.1 //x=7.705 //y=1.675 //x2=7.705 //y2=1.06
r68 (  9 29 ) resistor r=3.57586 //w=0.17 //l=0.125 //layer=li //thickness=0.1 \
 //x=7.705 //y=0.795 //x2=7.705 //y2=0.67
r69 (  9 29 ) resistor r=18.139 //w=0.187 //l=0.265 //layer=li //thickness=0.1 \
 //x=7.705 //y=0.795 //x2=7.705 //y2=1.06
r70 (  6 29 ) resistor r=3.57586 //w=0.17 //l=0.103078 //layer=li \
 //thickness=0.1 //x=6.82 //y=1.76 //x2=6.735 //y2=1.8
r71 (  6 29 ) resistor r=27.3797 //w=0.187 //l=0.4 //layer=li //thickness=0.1 \
 //x=6.82 //y=1.76 //x2=7.22 //y2=1.76
r72 (  5 29 ) resistor r=3.57586 //w=0.17 //l=0.103078 //layer=li \
 //thickness=0.1 //x=7.62 //y=1.76 //x2=7.705 //y2=1.8
r73 (  5 29 ) resistor r=27.3797 //w=0.187 //l=0.4 //layer=li //thickness=0.1 \
 //x=7.62 //y=1.76 //x2=7.22 //y2=1.76
r74 (  1 29 ) resistor r=3.57586 //w=0.17 //l=0.125 //layer=li //thickness=0.1 \
 //x=6.735 //y=1.675 //x2=6.735 //y2=1.8
r75 (  1 29 ) resistor r=42.0963 //w=0.187 //l=0.615 //layer=li \
 //thickness=0.1 //x=6.735 //y=1.675 //x2=6.735 //y2=1.06
ends PM_XNOR2X1\%noxref_11
