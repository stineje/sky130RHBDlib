// File: VOTERN3X1.spi.VOTERN3X1.pxi
// Created: Tue Apr 29 10:46:51 2025
//
simulator lang=spectre
x_PM_VOTERN3X1\%GND ( GND N_GND_c_5_p N_GND_c_10_p N_GND_c_2_p N_GND_c_17_p \
 N_GND_c_20_p N_GND_c_26_p N_GND_c_36_p N_GND_c_1_p N_GND_c_3_p N_GND_c_4_p \
 N_GND_M0_noxref_d N_GND_M2_noxref_d N_GND_M4_noxref_d )  PM_VOTERN3X1\%GND
x_PM_VOTERN3X1\%VDD ( VDD N_VDD_c_159_p N_VDD_c_148_p N_VDD_c_149_p \
 N_VDD_c_160_p N_VDD_c_139_n N_VDD_c_140_n N_VDD_c_141_n N_VDD_c_142_n \
 N_VDD_M6_noxref_s N_VDD_M7_noxref_d N_VDD_M9_noxref_d )  PM_VOTERN3X1\%VDD
x_PM_VOTERN3X1\%noxref_3 ( N_noxref_3_c_245_n N_noxref_3_c_247_n \
 N_noxref_3_c_250_n N_noxref_3_c_253_n N_noxref_3_c_255_n N_noxref_3_c_258_n \
 N_noxref_3_c_260_n N_noxref_3_c_261_n N_noxref_3_c_264_n N_noxref_3_c_265_n \
 N_noxref_3_M6_noxref_d N_noxref_3_M8_noxref_d N_noxref_3_M10_noxref_s \
 N_noxref_3_M11_noxref_d N_noxref_3_M13_noxref_d )  PM_VOTERN3X1\%noxref_3
x_PM_VOTERN3X1\%B ( N_B_c_361_n N_B_c_364_n B B B B B B B B B B B N_B_c_336_n \
 N_B_c_339_n N_B_M0_noxref_g N_B_M2_noxref_g N_B_M6_noxref_g N_B_M7_noxref_g \
 N_B_M10_noxref_g N_B_M11_noxref_g N_B_c_341_n N_B_c_343_n N_B_c_344_n \
 N_B_c_345_n N_B_c_346_n N_B_c_347_n N_B_c_397_n N_B_c_379_n N_B_c_348_n \
 N_B_c_350_n N_B_c_351_n N_B_c_353_n N_B_c_410_p N_B_c_354_n N_B_c_355_n \
 N_B_c_356_n N_B_c_357_n N_B_c_359_n N_B_c_360_n N_B_c_381_n )  PM_VOTERN3X1\%B
x_PM_VOTERN3X1\%C ( N_C_c_489_n N_C_c_490_n C C C C C C C C C C N_C_c_491_n \
 N_C_c_493_n N_C_M3_noxref_g N_C_M4_noxref_g N_C_M12_noxref_g N_C_M13_noxref_g \
 N_C_M14_noxref_g N_C_M15_noxref_g N_C_c_531_n N_C_c_534_n N_C_c_556_p \
 N_C_c_536_n N_C_c_612_p N_C_c_613_p N_C_c_514_n N_C_c_540_n N_C_c_541_n \
 N_C_c_542_n N_C_c_494_n N_C_c_495_n N_C_c_497_n N_C_c_584_p N_C_c_498_n \
 N_C_c_499_n N_C_c_500_n N_C_c_575_p N_C_c_515_n N_C_c_501_n N_C_c_503_n \
 N_C_c_504_n )  PM_VOTERN3X1\%C
x_PM_VOTERN3X1\%noxref_6 ( N_noxref_6_c_654_n N_noxref_6_c_655_n \
 N_noxref_6_c_673_n N_noxref_6_c_656_n N_noxref_6_c_657_n N_noxref_6_c_658_n \
 N_noxref_6_c_660_n N_noxref_6_c_661_n N_noxref_6_c_663_n N_noxref_6_c_664_n \
 N_noxref_6_M10_noxref_d N_noxref_6_M12_noxref_d N_noxref_6_M14_noxref_s \
 N_noxref_6_M15_noxref_d N_noxref_6_M17_noxref_d )  PM_VOTERN3X1\%noxref_6
x_PM_VOTERN3X1\%A ( N_A_c_740_n N_A_c_749_n A A A A A A A A A A A N_A_c_750_n \
 N_A_c_742_n N_A_c_744_n N_A_c_820_n N_A_M1_noxref_g N_A_M5_noxref_g \
 N_A_M8_noxref_g N_A_M9_noxref_g N_A_M16_noxref_g N_A_M17_noxref_g N_A_c_792_n \
 N_A_c_795_n N_A_c_797_n N_A_c_761_n N_A_c_856_p N_A_c_857_p N_A_c_801_n \
 N_A_c_802_n N_A_c_825_n N_A_c_828_n N_A_c_829_n N_A_c_871_p N_A_c_863_p \
 N_A_c_832_n N_A_c_833_n N_A_c_834_n N_A_c_746_n N_A_c_910_p N_A_c_762_n \
 N_A_c_835_n N_A_c_873_p N_A_c_838_n )  PM_VOTERN3X1\%A
x_PM_VOTERN3X1\%YN ( N_YN_c_920_n N_YN_c_927_n N_YN_c_928_n N_YN_c_934_n YN YN \
 YN YN YN YN YN YN N_YN_c_979_n N_YN_c_949_n N_YN_c_950_n N_YN_c_936_n \
 N_YN_c_1036_n N_YN_c_1037_n N_YN_M1_noxref_d N_YN_M3_noxref_d \
 N_YN_M5_noxref_d N_YN_M14_noxref_d N_YN_M16_noxref_d )  PM_VOTERN3X1\%YN
x_PM_VOTERN3X1\%noxref_9 ( N_noxref_9_c_1100_n N_noxref_9_c_1078_n \
 N_noxref_9_c_1082_n N_noxref_9_c_1086_n N_noxref_9_c_1087_n \
 N_noxref_9_c_1090_n N_noxref_9_M0_noxref_s )  PM_VOTERN3X1\%noxref_9
x_PM_VOTERN3X1\%noxref_10 ( N_noxref_10_c_1153_n N_noxref_10_c_1132_n \
 N_noxref_10_c_1135_n N_noxref_10_c_1139_n N_noxref_10_c_1140_n \
 N_noxref_10_c_1143_n N_noxref_10_M2_noxref_s )  PM_VOTERN3X1\%noxref_10
x_PM_VOTERN3X1\%noxref_11 ( N_noxref_11_c_1204_n N_noxref_11_c_1188_n \
 N_noxref_11_c_1191_n N_noxref_11_c_1194_n N_noxref_11_c_1195_n \
 N_noxref_11_c_1197_n N_noxref_11_M4_noxref_s )  PM_VOTERN3X1\%noxref_11
cc_1 ( N_GND_c_1_p N_VDD_c_139_n ) capacitor c=0.00989514f //x=9.74 //y=0.18 \
 //x2=9.74 //y2=7.58
cc_2 ( N_GND_c_2_p N_VDD_c_140_n ) capacitor c=0.00989514f //x=1.23 //y=0.18 \
 //x2=1.23 //y2=7.58
cc_3 ( N_GND_c_3_p N_VDD_c_141_n ) capacitor c=0.00528576f //x=3.82 //y=0.175 \
 //x2=3.82 //y2=7.585
cc_4 ( N_GND_c_4_p N_VDD_c_142_n ) capacitor c=0.00528576f //x=7.15 //y=0.175 \
 //x2=7.15 //y2=7.585
cc_5 ( N_GND_c_5_p N_B_c_336_n ) capacitor c=3.77975e-19 //x=9.74 //y=0.18 \
 //x2=1.23 //y2=2.26
cc_6 ( N_GND_c_2_p N_B_c_336_n ) capacitor c=0.0295726f //x=1.23 //y=0.18 \
 //x2=1.23 //y2=2.26
cc_7 ( N_GND_c_3_p N_B_c_336_n ) capacitor c=3.10504e-19 //x=3.82 //y=0.175 \
 //x2=1.23 //y2=2.26
cc_8 ( N_GND_c_3_p N_B_c_339_n ) capacitor c=0.0179404f //x=3.82 //y=0.175 \
 //x2=4.93 //y2=2.26
cc_9 ( N_GND_c_4_p N_B_c_339_n ) capacitor c=7.87427e-19 //x=7.15 //y=0.175 \
 //x2=4.93 //y2=2.26
cc_10 ( N_GND_c_10_p N_B_c_341_n ) capacitor c=0.00139494f //x=1.585 //y=0.175 \
 //x2=1.405 //y2=1.045
cc_11 ( N_GND_M0_noxref_d N_B_c_341_n ) capacitor c=0.00220047f //x=1.48 \
 //y=1.045 //x2=1.405 //y2=1.045
cc_12 ( N_GND_M0_noxref_d N_B_c_343_n ) capacitor c=0.00255985f //x=1.48 \
 //y=1.045 //x2=1.405 //y2=1.39
cc_13 ( N_GND_c_2_p N_B_c_344_n ) capacitor c=0.00264481f //x=1.23 //y=0.18 \
 //x2=1.405 //y2=1.7
cc_14 ( N_GND_c_2_p N_B_c_345_n ) capacitor c=0.00440632f //x=1.23 //y=0.18 \
 //x2=1.405 //y2=2.095
cc_15 ( N_GND_M0_noxref_d N_B_c_346_n ) capacitor c=0.0131374f //x=1.48 \
 //y=1.045 //x2=1.78 //y2=0.89
cc_16 ( N_GND_M0_noxref_d N_B_c_347_n ) capacitor c=0.00193146f //x=1.48 \
 //y=1.045 //x2=1.78 //y2=1.545
cc_17 ( N_GND_c_17_p N_B_c_348_n ) capacitor c=0.00131234f //x=3.65 //y=0.175 \
 //x2=1.935 //y2=1.045
cc_18 ( N_GND_M0_noxref_d N_B_c_348_n ) capacitor c=0.00257848f //x=1.48 \
 //y=1.045 //x2=1.935 //y2=1.045
cc_19 ( N_GND_M0_noxref_d N_B_c_350_n ) capacitor c=0.00255985f //x=1.48 \
 //y=1.045 //x2=1.935 //y2=1.39
cc_20 ( N_GND_c_20_p N_B_c_351_n ) capacitor c=0.00135783f //x=4.915 //y=0.175 \
 //x2=4.735 //y2=1.045
cc_21 ( N_GND_M2_noxref_d N_B_c_351_n ) capacitor c=0.00220047f //x=4.81 \
 //y=1.045 //x2=4.735 //y2=1.045
cc_22 ( N_GND_M2_noxref_d N_B_c_353_n ) capacitor c=0.00272336f //x=4.81 \
 //y=1.045 //x2=4.735 //y2=1.39
cc_23 ( N_GND_c_3_p N_B_c_354_n ) capacitor c=0.0114904f //x=3.82 //y=0.175 \
 //x2=4.735 //y2=2.095
cc_24 ( N_GND_M2_noxref_d N_B_c_355_n ) capacitor c=0.0131374f //x=4.81 \
 //y=1.045 //x2=5.11 //y2=0.89
cc_25 ( N_GND_M2_noxref_d N_B_c_356_n ) capacitor c=0.00167506f //x=4.81 \
 //y=1.045 //x2=5.11 //y2=1.545
cc_26 ( N_GND_c_26_p N_B_c_357_n ) capacitor c=0.00131234f //x=6.98 //y=0.175 \
 //x2=5.265 //y2=1.045
cc_27 ( N_GND_M2_noxref_d N_B_c_357_n ) capacitor c=0.00257848f //x=4.81 \
 //y=1.045 //x2=5.265 //y2=1.045
cc_28 ( N_GND_M2_noxref_d N_B_c_359_n ) capacitor c=0.00272336f //x=4.81 \
 //y=1.045 //x2=5.265 //y2=1.39
cc_29 ( N_GND_c_2_p N_B_c_360_n ) capacitor c=0.01092f //x=1.23 //y=0.18 \
 //x2=1.23 //y2=2.26
cc_30 ( N_GND_c_4_p N_C_c_489_n ) capacitor c=0.0396311f //x=7.15 //y=0.175 \
 //x2=7.775 //y2=2.26
cc_31 ( N_GND_c_4_p N_C_c_490_n ) capacitor c=0.00128384f //x=7.15 //y=0.175 \
 //x2=6.525 //y2=2.26
cc_32 ( N_GND_c_3_p N_C_c_491_n ) capacitor c=7.01065e-19 //x=3.82 //y=0.175 \
 //x2=6.41 //y2=2.26
cc_33 ( N_GND_c_4_p N_C_c_491_n ) capacitor c=0.0266762f //x=7.15 //y=0.175 \
 //x2=6.41 //y2=2.26
cc_34 ( N_GND_c_4_p N_C_c_493_n ) capacitor c=0.0266762f //x=7.15 //y=0.175 \
 //x2=7.89 //y2=2.26
cc_35 ( N_GND_c_4_p N_C_c_494_n ) capacitor c=0.0103285f //x=7.15 //y=0.175 \
 //x2=6.235 //y2=2.095
cc_36 ( N_GND_c_36_p N_C_c_495_n ) capacitor c=0.00139494f //x=8.245 //y=0.175 \
 //x2=8.065 //y2=1.045
cc_37 ( N_GND_M4_noxref_d N_C_c_495_n ) capacitor c=0.00220047f //x=8.14 \
 //y=1.045 //x2=8.065 //y2=1.045
cc_38 ( N_GND_M4_noxref_d N_C_c_497_n ) capacitor c=0.00272336f //x=8.14 \
 //y=1.045 //x2=8.065 //y2=1.39
cc_39 ( N_GND_c_4_p N_C_c_498_n ) capacitor c=0.00369763f //x=7.15 //y=0.175 \
 //x2=8.065 //y2=2.095
cc_40 ( N_GND_M4_noxref_d N_C_c_499_n ) capacitor c=0.0131374f //x=8.14 \
 //y=1.045 //x2=8.44 //y2=0.89
cc_41 ( N_GND_M4_noxref_d N_C_c_500_n ) capacitor c=0.00167506f //x=8.14 \
 //y=1.045 //x2=8.44 //y2=1.545
cc_42 ( N_GND_c_1_p N_C_c_501_n ) capacitor c=0.00131234f //x=9.74 //y=0.18 \
 //x2=8.595 //y2=1.045
cc_43 ( N_GND_M4_noxref_d N_C_c_501_n ) capacitor c=0.00257848f //x=8.14 \
 //y=1.045 //x2=8.595 //y2=1.045
cc_44 ( N_GND_M4_noxref_d N_C_c_503_n ) capacitor c=0.00272336f //x=8.14 \
 //y=1.045 //x2=8.595 //y2=1.39
cc_45 ( N_GND_c_4_p N_C_c_504_n ) capacitor c=0.00662863f //x=7.15 //y=0.175 \
 //x2=7.89 //y2=2.26
cc_46 ( N_GND_c_3_p N_A_c_740_n ) capacitor c=0.00361476f //x=3.82 //y=0.175 \
 //x2=8.885 //y2=4.25
cc_47 ( N_GND_c_4_p N_A_c_740_n ) capacitor c=0.00281239f //x=7.15 //y=0.175 \
 //x2=8.885 //y2=4.25
cc_48 ( N_GND_c_2_p N_A_c_742_n ) capacitor c=0.00123238f //x=1.23 //y=0.18 \
 //x2=2.34 //y2=2.26
cc_49 ( N_GND_c_3_p N_A_c_742_n ) capacitor c=0.0125771f //x=3.82 //y=0.175 \
 //x2=2.34 //y2=2.26
cc_50 ( N_GND_c_1_p N_A_c_744_n ) capacitor c=9.53263e-19 //x=9.74 //y=0.18 \
 //x2=9 //y2=2.26
cc_51 ( N_GND_c_4_p N_A_c_744_n ) capacitor c=8.50308e-19 //x=7.15 //y=0.175 \
 //x2=9 //y2=2.26
cc_52 ( N_GND_c_3_p N_A_c_746_n ) capacitor c=2.63786e-19 //x=3.82 //y=0.175 \
 //x2=2.34 //y2=2.26
cc_53 ( N_GND_c_5_p N_YN_c_920_n ) capacitor c=0.0697377f //x=9.74 //y=0.18 \
 //x2=5.855 //y2=1.36
cc_54 ( N_GND_c_17_p N_YN_c_920_n ) capacitor c=0.00814751f //x=3.65 //y=0.175 \
 //x2=5.855 //y2=1.36
cc_55 ( N_GND_c_20_p N_YN_c_920_n ) capacitor c=0.0102062f //x=4.915 //y=0.175 \
 //x2=5.855 //y2=1.36
cc_56 ( N_GND_c_26_p N_YN_c_920_n ) capacitor c=0.00469109f //x=6.98 //y=0.175 \
 //x2=5.855 //y2=1.36
cc_57 ( N_GND_c_1_p N_YN_c_920_n ) capacitor c=0.00131287f //x=9.74 //y=0.18 \
 //x2=5.855 //y2=1.36
cc_58 ( N_GND_c_3_p N_YN_c_920_n ) capacitor c=0.0453089f //x=3.82 //y=0.175 \
 //x2=5.855 //y2=1.36
cc_59 ( N_GND_M2_noxref_d N_YN_c_920_n ) capacitor c=0.00960943f //x=4.81 \
 //y=1.045 //x2=5.855 //y2=1.36
cc_60 ( N_GND_c_5_p N_YN_c_927_n ) capacitor c=0.00727348f //x=9.74 //y=0.18 \
 //x2=2.755 //y2=1.36
cc_61 ( N_GND_c_5_p N_YN_c_928_n ) capacitor c=0.0770022f //x=9.74 //y=0.18 \
 //x2=9.185 //y2=1.36
cc_62 ( N_GND_c_26_p N_YN_c_928_n ) capacitor c=0.00789201f //x=6.98 //y=0.175 \
 //x2=9.185 //y2=1.36
cc_63 ( N_GND_c_36_p N_YN_c_928_n ) capacitor c=0.00975575f //x=8.245 \
 //y=0.175 //x2=9.185 //y2=1.36
cc_64 ( N_GND_c_1_p N_YN_c_928_n ) capacitor c=0.00595158f //x=9.74 //y=0.18 \
 //x2=9.185 //y2=1.36
cc_65 ( N_GND_c_4_p N_YN_c_928_n ) capacitor c=0.0384314f //x=7.15 //y=0.175 \
 //x2=9.185 //y2=1.36
cc_66 ( N_GND_M4_noxref_d N_YN_c_928_n ) capacitor c=0.00960943f //x=8.14 \
 //y=1.045 //x2=9.185 //y2=1.36
cc_67 ( N_GND_c_5_p N_YN_c_934_n ) capacitor c=0.00665153f //x=9.74 //y=0.18 \
 //x2=6.085 //y2=1.36
cc_68 ( N_GND_c_4_p YN ) capacitor c=0.00109945f //x=7.15 //y=0.175 //x2=9.74 \
 //y2=2.4
cc_69 ( N_GND_c_1_p N_YN_c_936_n ) capacitor c=0.0472554f //x=9.74 //y=0.18 \
 //x2=9.655 //y2=1.825
cc_70 ( N_GND_c_5_p N_YN_M1_noxref_d ) capacitor c=2.01013e-19 //x=9.74 \
 //y=0.18 //x2=2.45 //y2=1.085
cc_71 ( N_GND_c_3_p N_YN_M1_noxref_d ) capacitor c=0.00141366f //x=3.82 \
 //y=0.175 //x2=2.45 //y2=1.085
cc_72 ( N_GND_M0_noxref_d N_YN_M1_noxref_d ) capacitor c=0.00128667f //x=1.48 \
 //y=1.045 //x2=2.45 //y2=1.085
cc_73 ( N_GND_c_5_p N_YN_M3_noxref_d ) capacitor c=2.01013e-19 //x=9.74 \
 //y=0.18 //x2=5.78 //y2=1.085
cc_74 ( N_GND_c_4_p N_YN_M3_noxref_d ) capacitor c=0.0014176f //x=7.15 \
 //y=0.175 //x2=5.78 //y2=1.085
cc_75 ( N_GND_M2_noxref_d N_YN_M3_noxref_d ) capacitor c=0.0012247f //x=4.81 \
 //y=1.045 //x2=5.78 //y2=1.085
cc_76 ( N_GND_c_5_p N_YN_M5_noxref_d ) capacitor c=2.01013e-19 //x=9.74 \
 //y=0.18 //x2=9.11 //y2=1.085
cc_77 ( N_GND_c_1_p N_YN_M5_noxref_d ) capacitor c=0.00524992f //x=9.74 \
 //y=0.18 //x2=9.11 //y2=1.085
cc_78 ( N_GND_c_4_p N_YN_M5_noxref_d ) capacitor c=8.62423e-19 //x=7.15 \
 //y=0.175 //x2=9.11 //y2=1.085
cc_79 ( N_GND_M4_noxref_d N_YN_M5_noxref_d ) capacitor c=0.0012247f //x=8.14 \
 //y=1.045 //x2=9.11 //y2=1.085
cc_80 ( N_GND_c_5_p N_noxref_9_c_1078_n ) capacitor c=0.00712328f //x=9.74 \
 //y=0.18 //x2=2.07 //y2=1.76
cc_81 ( N_GND_c_10_p N_noxref_9_c_1078_n ) capacitor c=0.00111556f //x=1.585 \
 //y=0.175 //x2=2.07 //y2=1.76
cc_82 ( N_GND_c_17_p N_noxref_9_c_1078_n ) capacitor c=0.00181083f //x=3.65 \
 //y=0.175 //x2=2.07 //y2=1.76
cc_83 ( N_GND_M0_noxref_d N_noxref_9_c_1078_n ) capacitor c=0.00942654f \
 //x=1.48 //y=1.045 //x2=2.07 //y2=1.76
cc_84 ( N_GND_c_5_p N_noxref_9_c_1082_n ) capacitor c=0.00724992f //x=9.74 \
 //y=0.18 //x2=2.155 //y2=0.795
cc_85 ( N_GND_c_17_p N_noxref_9_c_1082_n ) capacitor c=0.014661f //x=3.65 \
 //y=0.175 //x2=2.155 //y2=0.795
cc_86 ( N_GND_c_1_p N_noxref_9_c_1082_n ) capacitor c=0.00145873f //x=9.74 \
 //y=0.18 //x2=2.155 //y2=0.795
cc_87 ( N_GND_M0_noxref_d N_noxref_9_c_1082_n ) capacitor c=0.0336822f \
 //x=1.48 //y=1.045 //x2=2.155 //y2=0.795
cc_88 ( N_GND_c_2_p N_noxref_9_c_1086_n ) capacitor c=2.91423e-19 //x=1.23 \
 //y=0.18 //x2=2.155 //y2=1.675
cc_89 ( N_GND_c_5_p N_noxref_9_c_1087_n ) capacitor c=0.012705f //x=9.74 \
 //y=0.18 //x2=3.04 //y2=0.71
cc_90 ( N_GND_c_17_p N_noxref_9_c_1087_n ) capacitor c=0.0373475f //x=3.65 \
 //y=0.175 //x2=3.04 //y2=0.71
cc_91 ( N_GND_c_1_p N_noxref_9_c_1087_n ) capacitor c=0.00198596f //x=9.74 \
 //y=0.18 //x2=3.04 //y2=0.71
cc_92 ( N_GND_c_5_p N_noxref_9_c_1090_n ) capacitor c=0.00212802f //x=9.74 \
 //y=0.18 //x2=3.125 //y2=0.795
cc_93 ( N_GND_c_17_p N_noxref_9_c_1090_n ) capacitor c=0.0143399f //x=3.65 \
 //y=0.175 //x2=3.125 //y2=0.795
cc_94 ( N_GND_c_1_p N_noxref_9_c_1090_n ) capacitor c=0.00145873f //x=9.74 \
 //y=0.18 //x2=3.125 //y2=0.795
cc_95 ( N_GND_c_3_p N_noxref_9_c_1090_n ) capacitor c=0.0555325f //x=3.82 \
 //y=0.175 //x2=3.125 //y2=0.795
cc_96 ( N_GND_c_5_p N_noxref_9_M0_noxref_s ) capacitor c=0.00724992f //x=9.74 \
 //y=0.18 //x2=1.05 //y2=0.545
cc_97 ( N_GND_c_10_p N_noxref_9_M0_noxref_s ) capacitor c=0.0145823f //x=1.585 \
 //y=0.175 //x2=1.05 //y2=0.545
cc_98 ( N_GND_c_2_p N_noxref_9_M0_noxref_s ) capacitor c=0.0598652f //x=1.23 \
 //y=0.18 //x2=1.05 //y2=0.545
cc_99 ( N_GND_c_1_p N_noxref_9_M0_noxref_s ) capacitor c=0.00145873f //x=9.74 \
 //y=0.18 //x2=1.05 //y2=0.545
cc_100 ( N_GND_c_3_p N_noxref_9_M0_noxref_s ) capacitor c=0.00181744f //x=3.82 \
 //y=0.175 //x2=1.05 //y2=0.545
cc_101 ( N_GND_M0_noxref_d N_noxref_9_M0_noxref_s ) capacitor c=0.0333456f \
 //x=1.48 //y=1.045 //x2=1.05 //y2=0.545
cc_102 ( N_GND_c_20_p N_noxref_10_c_1132_n ) capacitor c=8.02712e-19 //x=4.915 \
 //y=0.175 //x2=5.4 //y2=1.76
cc_103 ( N_GND_c_26_p N_noxref_10_c_1132_n ) capacitor c=0.00161731f //x=6.98 \
 //y=0.175 //x2=5.4 //y2=1.76
cc_104 ( N_GND_M2_noxref_d N_noxref_10_c_1132_n ) capacitor c=0.00732825f \
 //x=4.81 //y=1.045 //x2=5.4 //y2=1.76
cc_105 ( N_GND_c_5_p N_noxref_10_c_1135_n ) capacitor c=0.00212802f //x=9.74 \
 //y=0.18 //x2=5.485 //y2=0.795
cc_106 ( N_GND_c_26_p N_noxref_10_c_1135_n ) capacitor c=0.0143399f //x=6.98 \
 //y=0.175 //x2=5.485 //y2=0.795
cc_107 ( N_GND_c_1_p N_noxref_10_c_1135_n ) capacitor c=0.00145873f //x=9.74 \
 //y=0.18 //x2=5.485 //y2=0.795
cc_108 ( N_GND_M2_noxref_d N_noxref_10_c_1135_n ) capacitor c=0.0336662f \
 //x=4.81 //y=1.045 //x2=5.485 //y2=0.795
cc_109 ( N_GND_c_3_p N_noxref_10_c_1139_n ) capacitor c=2.91423e-19 //x=3.82 \
 //y=0.175 //x2=5.485 //y2=1.675
cc_110 ( N_GND_c_5_p N_noxref_10_c_1140_n ) capacitor c=0.00884626f //x=9.74 \
 //y=0.18 //x2=6.37 //y2=0.71
cc_111 ( N_GND_c_26_p N_noxref_10_c_1140_n ) capacitor c=0.0374067f //x=6.98 \
 //y=0.175 //x2=6.37 //y2=0.71
cc_112 ( N_GND_c_1_p N_noxref_10_c_1140_n ) capacitor c=0.00198596f //x=9.74 \
 //y=0.18 //x2=6.37 //y2=0.71
cc_113 ( N_GND_c_5_p N_noxref_10_c_1143_n ) capacitor c=0.00212802f //x=9.74 \
 //y=0.18 //x2=6.455 //y2=0.795
cc_114 ( N_GND_c_26_p N_noxref_10_c_1143_n ) capacitor c=0.0143399f //x=6.98 \
 //y=0.175 //x2=6.455 //y2=0.795
cc_115 ( N_GND_c_1_p N_noxref_10_c_1143_n ) capacitor c=0.00145873f //x=9.74 \
 //y=0.18 //x2=6.455 //y2=0.795
cc_116 ( N_GND_c_4_p N_noxref_10_c_1143_n ) capacitor c=0.054903f //x=7.15 \
 //y=0.175 //x2=6.455 //y2=0.795
cc_117 ( N_GND_c_5_p N_noxref_10_M2_noxref_s ) capacitor c=0.00212802f \
 //x=9.74 //y=0.18 //x2=4.38 //y2=0.545
cc_118 ( N_GND_c_20_p N_noxref_10_M2_noxref_s ) capacitor c=0.0143399f \
 //x=4.915 //y=0.175 //x2=4.38 //y2=0.545
cc_119 ( N_GND_c_1_p N_noxref_10_M2_noxref_s ) capacitor c=0.00145873f \
 //x=9.74 //y=0.18 //x2=4.38 //y2=0.545
cc_120 ( N_GND_c_3_p N_noxref_10_M2_noxref_s ) capacitor c=0.0561199f //x=3.82 \
 //y=0.175 //x2=4.38 //y2=0.545
cc_121 ( N_GND_c_4_p N_noxref_10_M2_noxref_s ) capacitor c=0.0022128f //x=7.15 \
 //y=0.175 //x2=4.38 //y2=0.545
cc_122 ( N_GND_M2_noxref_d N_noxref_10_M2_noxref_s ) capacitor c=0.0333038f \
 //x=4.81 //y=1.045 //x2=4.38 //y2=0.545
cc_123 ( N_GND_c_36_p N_noxref_11_c_1188_n ) capacitor c=8.02719e-19 //x=8.245 \
 //y=0.175 //x2=8.73 //y2=1.76
cc_124 ( N_GND_c_1_p N_noxref_11_c_1188_n ) capacitor c=0.00161731f //x=9.74 \
 //y=0.18 //x2=8.73 //y2=1.76
cc_125 ( N_GND_M4_noxref_d N_noxref_11_c_1188_n ) capacitor c=0.00734886f \
 //x=8.14 //y=1.045 //x2=8.73 //y2=1.76
cc_126 ( N_GND_c_5_p N_noxref_11_c_1191_n ) capacitor c=0.00212802f //x=9.74 \
 //y=0.18 //x2=8.815 //y2=0.795
cc_127 ( N_GND_c_1_p N_noxref_11_c_1191_n ) capacitor c=0.0157986f //x=9.74 \
 //y=0.18 //x2=8.815 //y2=0.795
cc_128 ( N_GND_M4_noxref_d N_noxref_11_c_1191_n ) capacitor c=0.0336662f \
 //x=8.14 //y=1.045 //x2=8.815 //y2=0.795
cc_129 ( N_GND_c_4_p N_noxref_11_c_1194_n ) capacitor c=2.91423e-19 //x=7.15 \
 //y=0.175 //x2=8.815 //y2=1.675
cc_130 ( N_GND_c_5_p N_noxref_11_c_1195_n ) capacitor c=0.01271f //x=9.74 \
 //y=0.18 //x2=9.7 //y2=0.71
cc_131 ( N_GND_c_1_p N_noxref_11_c_1195_n ) capacitor c=0.0392089f //x=9.74 \
 //y=0.18 //x2=9.7 //y2=0.71
cc_132 ( N_GND_c_5_p N_noxref_11_c_1197_n ) capacitor c=0.00720956f //x=9.74 \
 //y=0.18 //x2=9.785 //y2=0.795
cc_133 ( N_GND_c_1_p N_noxref_11_c_1197_n ) capacitor c=0.0596732f //x=9.74 \
 //y=0.18 //x2=9.785 //y2=0.795
cc_134 ( N_GND_c_5_p N_noxref_11_M4_noxref_s ) capacitor c=0.00212802f \
 //x=9.74 //y=0.18 //x2=7.71 //y2=0.545
cc_135 ( N_GND_c_36_p N_noxref_11_M4_noxref_s ) capacitor c=0.0143399f \
 //x=8.245 //y=0.175 //x2=7.71 //y2=0.545
cc_136 ( N_GND_c_1_p N_noxref_11_M4_noxref_s ) capacitor c=0.00348141f \
 //x=9.74 //y=0.18 //x2=7.71 //y2=0.545
cc_137 ( N_GND_c_4_p N_noxref_11_M4_noxref_s ) capacitor c=0.0555232f //x=7.15 \
 //y=0.175 //x2=7.71 //y2=0.545
cc_138 ( N_GND_M4_noxref_d N_noxref_11_M4_noxref_s ) capacitor c=0.0333038f \
 //x=8.14 //y=1.045 //x2=7.71 //y2=0.545
cc_139 ( N_VDD_c_141_n N_noxref_3_c_245_n ) capacitor c=0.0450989f //x=3.82 \
 //y=7.585 //x2=4.485 //y2=5.39
cc_140 ( N_VDD_M9_noxref_d N_noxref_3_c_245_n ) capacitor c=0.0208274f \
 //x=2.895 //y=5.205 //x2=4.485 //y2=5.39
cc_141 ( N_VDD_c_140_n N_noxref_3_c_247_n ) capacitor c=2.85394e-19 //x=1.23 \
 //y=7.58 //x2=2.715 //y2=5.39
cc_142 ( N_VDD_c_141_n N_noxref_3_c_247_n ) capacitor c=3.35418e-19 //x=3.82 \
 //y=7.585 //x2=2.715 //y2=5.39
cc_143 ( N_VDD_M9_noxref_d N_noxref_3_c_247_n ) capacitor c=6.02701e-19 \
 //x=2.895 //y=5.205 //x2=2.715 //y2=5.39
cc_144 ( N_VDD_c_148_p N_noxref_3_c_250_n ) capacitor c=5.82208e-19 //x=2.075 \
 //y=7.585 //x2=2.515 //y2=5.39
cc_145 ( N_VDD_c_149_p N_noxref_3_c_250_n ) capacitor c=5.3326e-19 //x=2.955 \
 //y=7.585 //x2=2.515 //y2=5.39
cc_146 ( N_VDD_M7_noxref_d N_noxref_3_c_250_n ) capacitor c=0.0129514f \
 //x=2.015 //y=5.205 //x2=2.515 //y2=5.39
cc_147 ( N_VDD_c_140_n N_noxref_3_c_253_n ) capacitor c=0.00914165f //x=1.23 \
 //y=7.58 //x2=1.805 //y2=5.39
cc_148 ( N_VDD_M6_noxref_s N_noxref_3_c_253_n ) capacitor c=0.0872987f \
 //x=1.145 //y=5.205 //x2=1.805 //y2=5.39
cc_149 ( N_VDD_c_140_n N_noxref_3_c_255_n ) capacitor c=6.65559e-19 //x=1.23 \
 //y=7.58 //x2=2.6 //y2=5.475
cc_150 ( N_VDD_c_141_n N_noxref_3_c_255_n ) capacitor c=0.00985441f //x=3.82 \
 //y=7.585 //x2=2.6 //y2=5.475
cc_151 ( N_VDD_M9_noxref_d N_noxref_3_c_255_n ) capacitor c=0.0873334f \
 //x=2.895 //y=5.205 //x2=2.6 //y2=5.475
cc_152 ( N_VDD_c_141_n N_noxref_3_c_258_n ) capacitor c=0.0674112f //x=3.82 \
 //y=7.585 //x2=4.6 //y2=5.39
cc_153 ( N_VDD_M9_noxref_d N_noxref_3_c_258_n ) capacitor c=0.00235009f \
 //x=2.895 //y=5.205 //x2=4.6 //y2=5.39
cc_154 ( N_VDD_c_139_n N_noxref_3_c_260_n ) capacitor c=0.0024144f //x=9.74 \
 //y=7.58 //x2=5.395 //y2=7.09
cc_155 ( N_VDD_c_159_p N_noxref_3_c_261_n ) capacitor c=0.0565188f //x=9.74 \
 //y=7.58 //x2=4.685 //y2=7.09
cc_156 ( N_VDD_c_160_p N_noxref_3_c_261_n ) capacitor c=0.104862f //x=6.98 \
 //y=7.585 //x2=4.685 //y2=7.09
cc_157 ( N_VDD_c_139_n N_noxref_3_c_261_n ) capacitor c=0.00118756f //x=9.74 \
 //y=7.58 //x2=4.685 //y2=7.09
cc_158 ( N_VDD_c_139_n N_noxref_3_c_264_n ) capacitor c=0.00359767f //x=9.74 \
 //y=7.58 //x2=6.275 //y2=7.09
cc_159 ( N_VDD_c_139_n N_noxref_3_c_265_n ) capacitor c=0.00118056f //x=9.74 \
 //y=7.58 //x2=5.48 //y2=7.09
cc_160 ( N_VDD_c_159_p N_noxref_3_M6_noxref_d ) capacitor c=0.00736176f \
 //x=9.74 //y=7.58 //x2=1.575 //y2=5.205
cc_161 ( N_VDD_c_148_p N_noxref_3_M6_noxref_d ) capacitor c=0.01289f //x=2.075 \
 //y=7.585 //x2=1.575 //y2=5.205
cc_162 ( N_VDD_c_139_n N_noxref_3_M6_noxref_d ) capacitor c=0.00118659f \
 //x=9.74 //y=7.58 //x2=1.575 //y2=5.205
cc_163 ( N_VDD_M7_noxref_d N_noxref_3_M6_noxref_d ) capacitor c=0.067695f \
 //x=2.015 //y=5.205 //x2=1.575 //y2=5.205
cc_164 ( N_VDD_M9_noxref_d N_noxref_3_M6_noxref_d ) capacitor c=0.00105738f \
 //x=2.895 //y=5.205 //x2=1.575 //y2=5.205
cc_165 ( N_VDD_c_159_p N_noxref_3_M8_noxref_d ) capacitor c=0.00423571f \
 //x=9.74 //y=7.58 //x2=2.455 //y2=5.205
cc_166 ( N_VDD_c_149_p N_noxref_3_M8_noxref_d ) capacitor c=0.0126856f \
 //x=2.955 //y=7.585 //x2=2.455 //y2=5.205
cc_167 ( N_VDD_c_139_n N_noxref_3_M8_noxref_d ) capacitor c=0.00118756f \
 //x=9.74 //y=7.58 //x2=2.455 //y2=5.205
cc_168 ( N_VDD_M6_noxref_s N_noxref_3_M8_noxref_d ) capacitor c=0.00103189f \
 //x=1.145 //y=5.205 //x2=2.455 //y2=5.205
cc_169 ( N_VDD_M7_noxref_d N_noxref_3_M8_noxref_d ) capacitor c=0.0653408f \
 //x=2.015 //y=5.205 //x2=2.455 //y2=5.205
cc_170 ( N_VDD_c_141_n N_noxref_3_M11_noxref_d ) capacitor c=8.96067e-19 \
 //x=3.82 //y=7.585 //x2=5.335 //y2=5.205
cc_171 ( N_VDD_c_142_n N_noxref_3_M11_noxref_d ) capacitor c=8.88629e-19 \
 //x=7.15 //y=7.585 //x2=5.335 //y2=5.205
cc_172 ( N_VDD_c_142_n N_noxref_3_M13_noxref_d ) capacitor c=0.0575594f \
 //x=7.15 //y=7.585 //x2=6.215 //y2=5.205
cc_173 ( N_VDD_c_141_n N_B_c_361_n ) capacitor c=0.0345509f //x=3.82 //y=7.585 \
 //x2=4.815 //y2=4.62
cc_174 ( N_VDD_M6_noxref_s N_B_c_361_n ) capacitor c=5.85666e-19 //x=1.145 \
 //y=5.205 //x2=4.815 //y2=4.62
cc_175 ( N_VDD_M9_noxref_d N_B_c_361_n ) capacitor c=0.00369843f //x=2.895 \
 //y=5.205 //x2=4.815 //y2=4.62
cc_176 ( N_VDD_c_140_n N_B_c_364_n ) capacitor c=0.00752464f //x=1.23 //y=7.58 \
 //x2=1.345 //y2=4.62
cc_177 ( N_VDD_M6_noxref_s N_B_c_364_n ) capacitor c=0.00298204f //x=1.145 \
 //y=5.205 //x2=1.345 //y2=4.62
cc_178 ( N_VDD_c_140_n N_B_c_336_n ) capacitor c=0.0253776f //x=1.23 //y=7.58 \
 //x2=1.23 //y2=2.26
cc_179 ( N_VDD_c_141_n N_B_c_336_n ) capacitor c=3.72488e-19 //x=3.82 \
 //y=7.585 //x2=1.23 //y2=2.26
cc_180 ( N_VDD_M6_noxref_s N_B_c_336_n ) capacitor c=0.0117223f //x=1.145 \
 //y=5.205 //x2=1.23 //y2=2.26
cc_181 ( N_VDD_c_141_n N_B_c_339_n ) capacitor c=0.0132049f //x=3.82 //y=7.585 \
 //x2=4.93 //y2=2.26
cc_182 ( N_VDD_c_142_n N_B_c_339_n ) capacitor c=0.00104034f //x=7.15 \
 //y=7.585 //x2=4.93 //y2=2.26
cc_183 ( N_VDD_c_148_p N_B_M6_noxref_g ) capacitor c=0.00760847f //x=2.075 \
 //y=7.585 //x2=1.5 //y2=6.205
cc_184 ( N_VDD_c_140_n N_B_M6_noxref_g ) capacitor c=0.0202257f //x=1.23 \
 //y=7.58 //x2=1.5 //y2=6.205
cc_185 ( N_VDD_M6_noxref_s N_B_M6_noxref_g ) capacitor c=0.0547553f //x=1.145 \
 //y=5.205 //x2=1.5 //y2=6.205
cc_186 ( N_VDD_c_148_p N_B_M7_noxref_g ) capacitor c=0.0068279f //x=2.075 \
 //y=7.585 //x2=1.94 //y2=6.205
cc_187 ( N_VDD_M7_noxref_d N_B_M7_noxref_g ) capacitor c=0.015501f //x=2.015 \
 //y=5.205 //x2=1.94 //y2=6.205
cc_188 ( N_VDD_c_160_p N_B_M10_noxref_g ) capacitor c=0.00516635f //x=6.98 \
 //y=7.585 //x2=4.82 //y2=6.205
cc_189 ( N_VDD_c_141_n N_B_M10_noxref_g ) capacitor c=0.00316281f //x=3.82 \
 //y=7.585 //x2=4.82 //y2=6.205
cc_190 ( N_VDD_c_160_p N_B_M11_noxref_g ) capacitor c=0.00515938f //x=6.98 \
 //y=7.585 //x2=5.26 //y2=6.205
cc_191 ( N_VDD_c_140_n N_B_c_379_n ) capacitor c=0.0110236f //x=1.23 //y=7.58 \
 //x2=1.575 //y2=4.975
cc_192 ( N_VDD_M6_noxref_s N_B_c_379_n ) capacitor c=0.00597381f //x=1.145 \
 //y=5.205 //x2=1.575 //y2=4.975
cc_193 ( N_VDD_c_141_n N_B_c_381_n ) capacitor c=0.0115029f //x=3.82 //y=7.585 \
 //x2=4.93 //y2=4.885
cc_194 ( N_VDD_c_141_n N_C_c_491_n ) capacitor c=7.57423e-19 //x=3.82 \
 //y=7.585 //x2=6.41 //y2=2.26
cc_195 ( N_VDD_c_142_n N_C_c_491_n ) capacitor c=0.0267895f //x=7.15 //y=7.585 \
 //x2=6.41 //y2=2.26
cc_196 ( N_VDD_c_142_n N_C_c_493_n ) capacitor c=0.0267241f //x=7.15 //y=7.585 \
 //x2=7.89 //y2=2.26
cc_197 ( N_VDD_c_160_p N_C_M12_noxref_g ) capacitor c=0.00515938f //x=6.98 \
 //y=7.585 //x2=5.7 //y2=6.205
cc_198 ( N_VDD_c_160_p N_C_M13_noxref_g ) capacitor c=0.00515938f //x=6.98 \
 //y=7.585 //x2=6.14 //y2=6.205
cc_199 ( N_VDD_c_142_n N_C_M13_noxref_g ) capacitor c=0.010355f //x=7.15 \
 //y=7.585 //x2=6.14 //y2=6.205
cc_200 ( N_VDD_c_139_n N_C_M14_noxref_g ) capacitor c=0.00515938f //x=9.74 \
 //y=7.58 //x2=8.16 //y2=6.205
cc_201 ( N_VDD_c_142_n N_C_M14_noxref_g ) capacitor c=0.00767856f //x=7.15 \
 //y=7.585 //x2=8.16 //y2=6.205
cc_202 ( N_VDD_c_139_n N_C_M15_noxref_g ) capacitor c=0.00515938f //x=9.74 \
 //y=7.58 //x2=8.6 //y2=6.205
cc_203 ( N_VDD_c_142_n N_C_c_514_n ) capacitor c=0.00803198f //x=7.15 \
 //y=7.585 //x2=6.14 //y2=5.05
cc_204 ( N_VDD_c_142_n N_C_c_515_n ) capacitor c=0.00803198f //x=7.15 \
 //y=7.585 //x2=8.235 //y2=4.975
cc_205 ( N_VDD_c_142_n N_noxref_6_c_654_n ) capacitor c=0.0494078f //x=7.15 \
 //y=7.585 //x2=7.825 //y2=5.39
cc_206 ( N_VDD_c_142_n N_noxref_6_c_655_n ) capacitor c=6.67754e-19 //x=7.15 \
 //y=7.585 //x2=6.035 //y2=5.39
cc_207 ( N_VDD_c_141_n N_noxref_6_c_656_n ) capacitor c=0.00662411f //x=3.82 \
 //y=7.585 //x2=5.125 //y2=5.39
cc_208 ( N_VDD_c_142_n N_noxref_6_c_657_n ) capacitor c=0.00999961f //x=7.15 \
 //y=7.585 //x2=5.92 //y2=5.475
cc_209 ( N_VDD_c_139_n N_noxref_6_c_658_n ) capacitor c=6.6489e-19 //x=9.74 \
 //y=7.58 //x2=7.94 //y2=5.39
cc_210 ( N_VDD_c_142_n N_noxref_6_c_658_n ) capacitor c=0.0664301f //x=7.15 \
 //y=7.585 //x2=7.94 //y2=5.39
cc_211 ( N_VDD_c_139_n N_noxref_6_c_660_n ) capacitor c=0.0024144f //x=9.74 \
 //y=7.58 //x2=8.735 //y2=7.09
cc_212 ( N_VDD_c_159_p N_noxref_6_c_661_n ) capacitor c=0.0636013f //x=9.74 \
 //y=7.58 //x2=8.025 //y2=7.09
cc_213 ( N_VDD_c_139_n N_noxref_6_c_661_n ) capacitor c=0.105896f //x=9.74 \
 //y=7.58 //x2=8.025 //y2=7.09
cc_214 ( N_VDD_c_139_n N_noxref_6_c_663_n ) capacitor c=0.00359496f //x=9.74 \
 //y=7.58 //x2=9.615 //y2=7.09
cc_215 ( N_VDD_c_139_n N_noxref_6_c_664_n ) capacitor c=0.00118056f //x=9.74 \
 //y=7.58 //x2=8.82 //y2=7.09
cc_216 ( N_VDD_c_139_n N_noxref_6_M15_noxref_d ) capacitor c=8.96067e-19 \
 //x=9.74 //y=7.58 //x2=8.675 //y2=5.205
cc_217 ( N_VDD_c_142_n N_noxref_6_M15_noxref_d ) capacitor c=8.88629e-19 \
 //x=7.15 //y=7.585 //x2=8.675 //y2=5.205
cc_218 ( N_VDD_c_139_n N_noxref_6_M17_noxref_d ) capacitor c=0.0529764f \
 //x=9.74 //y=7.58 //x2=9.555 //y2=5.205
cc_219 ( N_VDD_c_141_n N_A_c_740_n ) capacitor c=0.0177125f //x=3.82 //y=7.585 \
 //x2=8.885 //y2=4.25
cc_220 ( N_VDD_c_142_n N_A_c_740_n ) capacitor c=0.0248101f //x=7.15 //y=7.585 \
 //x2=8.885 //y2=4.25
cc_221 ( N_VDD_c_141_n N_A_c_749_n ) capacitor c=4.48866e-19 //x=3.82 \
 //y=7.585 //x2=2.455 //y2=4.25
cc_222 ( N_VDD_c_141_n N_A_c_750_n ) capacitor c=0.0049541f //x=3.82 //y=7.585 \
 //x2=2.34 //y2=4.72
cc_223 ( N_VDD_c_140_n N_A_c_742_n ) capacitor c=0.00113585f //x=1.23 //y=7.58 \
 //x2=2.34 //y2=2.26
cc_224 ( N_VDD_c_141_n N_A_c_742_n ) capacitor c=0.00433782f //x=3.82 \
 //y=7.585 //x2=2.34 //y2=2.26
cc_225 ( N_VDD_c_139_n N_A_c_744_n ) capacitor c=6.69172e-19 //x=9.74 //y=7.58 \
 //x2=9 //y2=2.26
cc_226 ( N_VDD_c_142_n N_A_c_744_n ) capacitor c=0.00116377f //x=7.15 \
 //y=7.585 //x2=9 //y2=2.26
cc_227 ( N_VDD_c_149_p N_A_M8_noxref_g ) capacitor c=0.00683851f //x=2.955 \
 //y=7.585 //x2=2.38 //y2=6.205
cc_228 ( N_VDD_M7_noxref_d N_A_M8_noxref_g ) capacitor c=0.015526f //x=2.015 \
 //y=5.205 //x2=2.38 //y2=6.205
cc_229 ( N_VDD_c_149_p N_A_M9_noxref_g ) capacitor c=0.00760847f //x=2.955 \
 //y=7.585 //x2=2.82 //y2=6.205
cc_230 ( N_VDD_M9_noxref_d N_A_M9_noxref_g ) capacitor c=0.0537676f //x=2.895 \
 //y=5.205 //x2=2.82 //y2=6.205
cc_231 ( N_VDD_c_139_n N_A_M16_noxref_g ) capacitor c=0.00516984f //x=9.74 \
 //y=7.58 //x2=9.04 //y2=6.205
cc_232 ( N_VDD_c_139_n N_A_M17_noxref_g ) capacitor c=0.0322716f //x=9.74 \
 //y=7.58 //x2=9.48 //y2=6.205
cc_233 ( N_VDD_c_141_n N_A_c_761_n ) capacitor c=0.00985898f //x=3.82 \
 //y=7.585 //x2=2.745 //y2=4.975
cc_234 ( N_VDD_c_141_n N_A_c_762_n ) capacitor c=2.76772e-19 //x=3.82 \
 //y=7.585 //x2=2.38 //y2=4.885
cc_235 ( N_VDD_c_139_n YN ) capacitor c=0.0470618f //x=9.74 //y=7.58 //x2=9.74 \
 //y2=2.4
cc_236 ( N_VDD_c_142_n YN ) capacitor c=0.00147633f //x=7.15 //y=7.585 \
 //x2=9.74 //y2=2.4
cc_237 ( N_VDD_c_142_n N_YN_c_949_n ) capacitor c=0.00660621f //x=7.15 \
 //y=7.585 //x2=8.465 //y2=5.39
cc_238 ( N_VDD_c_139_n N_YN_c_950_n ) capacitor c=9.6632e-19 //x=9.74 //y=7.58 \
 //x2=9.655 //y2=5.39
cc_239 ( N_VDD_c_139_n N_YN_M14_noxref_d ) capacitor c=6.68683e-19 //x=9.74 \
 //y=7.58 //x2=8.235 //y2=5.205
cc_240 ( N_VDD_c_139_n N_YN_M16_noxref_d ) capacitor c=0.00991513f //x=9.74 \
 //y=7.58 //x2=9.115 //y2=5.205
cc_241 ( N_noxref_3_c_245_n N_B_c_361_n ) capacitor c=0.0899391f //x=4.485 \
 //y=5.39 //x2=4.815 //y2=4.62
cc_242 ( N_noxref_3_c_247_n N_B_c_361_n ) capacitor c=0.0136092f //x=2.715 \
 //y=5.39 //x2=4.815 //y2=4.62
cc_243 ( N_noxref_3_c_250_n N_B_c_361_n ) capacitor c=0.00225564f //x=2.515 \
 //y=5.39 //x2=4.815 //y2=4.62
cc_244 ( N_noxref_3_c_253_n N_B_c_361_n ) capacitor c=0.0201699f //x=1.805 \
 //y=5.39 //x2=4.815 //y2=4.62
cc_245 ( N_noxref_3_c_255_n N_B_c_361_n ) capacitor c=0.00455774f //x=2.6 \
 //y=5.475 //x2=4.815 //y2=4.62
cc_246 ( N_noxref_3_c_258_n N_B_c_361_n ) capacitor c=0.00561407f //x=4.6 \
 //y=5.39 //x2=4.815 //y2=4.62
cc_247 ( N_noxref_3_c_260_n N_B_c_339_n ) capacitor c=9.51989e-19 //x=5.395 \
 //y=7.09 //x2=4.93 //y2=2.26
cc_248 ( N_noxref_3_c_253_n N_B_M6_noxref_g ) capacitor c=0.0172236f //x=1.805 \
 //y=5.39 //x2=1.5 //y2=6.205
cc_249 ( N_noxref_3_c_250_n N_B_M7_noxref_g ) capacitor c=0.0170073f //x=2.515 \
 //y=5.39 //x2=1.94 //y2=6.205
cc_250 ( N_noxref_3_M6_noxref_d N_B_M7_noxref_g ) capacitor c=0.0169879f \
 //x=1.575 //y=5.205 //x2=1.94 //y2=6.205
cc_251 ( N_noxref_3_c_245_n N_B_M10_noxref_g ) capacitor c=0.00503498f \
 //x=4.485 //y=5.39 //x2=4.82 //y2=6.205
cc_252 ( N_noxref_3_c_258_n N_B_M10_noxref_g ) capacitor c=0.0481665f //x=4.6 \
 //y=5.39 //x2=4.82 //y2=6.205
cc_253 ( N_noxref_3_c_260_n N_B_M10_noxref_g ) capacitor c=0.0168192f \
 //x=5.395 //y=7.09 //x2=4.82 //y2=6.205
cc_254 ( N_noxref_3_c_260_n N_B_M11_noxref_g ) capacitor c=0.0150109f \
 //x=5.395 //y=7.09 //x2=5.26 //y2=6.205
cc_255 ( N_noxref_3_M11_noxref_d N_B_M11_noxref_g ) capacitor c=0.0130327f \
 //x=5.335 //y=5.205 //x2=5.26 //y2=6.205
cc_256 ( N_noxref_3_c_253_n N_B_c_397_n ) capacitor c=0.00356914f //x=1.805 \
 //y=5.39 //x2=1.865 //y2=4.975
cc_257 ( N_noxref_3_M13_noxref_d N_C_c_491_n ) capacitor c=0.00493463f \
 //x=6.215 //y=5.205 //x2=6.41 //y2=2.26
cc_258 ( N_noxref_3_c_264_n N_C_M12_noxref_g ) capacitor c=0.0150109f \
 //x=6.275 //y=7.09 //x2=5.7 //y2=6.205
cc_259 ( N_noxref_3_M11_noxref_d N_C_M12_noxref_g ) capacitor c=0.0130327f \
 //x=5.335 //y=5.205 //x2=5.7 //y2=6.205
cc_260 ( N_noxref_3_c_264_n N_C_M13_noxref_g ) capacitor c=0.0155183f \
 //x=6.275 //y=7.09 //x2=6.14 //y2=6.205
cc_261 ( N_noxref_3_M13_noxref_d N_C_M13_noxref_g ) capacitor c=0.0398886f \
 //x=6.215 //y=5.205 //x2=6.14 //y2=6.205
cc_262 ( N_noxref_3_M13_noxref_d N_C_c_514_n ) capacitor c=0.00411435f \
 //x=6.215 //y=5.205 //x2=6.14 //y2=5.05
cc_263 ( N_noxref_3_c_264_n N_noxref_6_c_654_n ) capacitor c=0.00749783f \
 //x=6.275 //y=7.09 //x2=7.825 //y2=5.39
cc_264 ( N_noxref_3_M13_noxref_d N_noxref_6_c_654_n ) capacitor c=0.00712464f \
 //x=6.215 //y=5.205 //x2=7.825 //y2=5.39
cc_265 ( N_noxref_3_c_245_n N_noxref_6_c_655_n ) capacitor c=0.00871657f \
 //x=4.485 //y=5.39 //x2=6.035 //y2=5.39
cc_266 ( N_noxref_3_c_258_n N_noxref_6_c_655_n ) capacitor c=3.31723e-19 \
 //x=4.6 //y=5.39 //x2=6.035 //y2=5.39
cc_267 ( N_noxref_3_c_264_n N_noxref_6_c_655_n ) capacitor c=0.00115931f \
 //x=6.275 //y=7.09 //x2=6.035 //y2=5.39
cc_268 ( N_noxref_3_c_260_n N_noxref_6_c_673_n ) capacitor c=0.00128698f \
 //x=5.395 //y=7.09 //x2=5.835 //y2=5.39
cc_269 ( N_noxref_3_c_264_n N_noxref_6_c_673_n ) capacitor c=0.0012288f \
 //x=6.275 //y=7.09 //x2=5.835 //y2=5.39
cc_270 ( N_noxref_3_M11_noxref_d N_noxref_6_c_673_n ) capacitor c=0.0128739f \
 //x=5.335 //y=5.205 //x2=5.835 //y2=5.39
cc_271 ( N_noxref_3_c_245_n N_noxref_6_c_656_n ) capacitor c=0.00630448f \
 //x=4.485 //y=5.39 //x2=5.125 //y2=5.39
cc_272 ( N_noxref_3_c_258_n N_noxref_6_c_656_n ) capacitor c=0.0682565f \
 //x=4.6 //y=5.39 //x2=5.125 //y2=5.39
cc_273 ( N_noxref_3_c_245_n N_noxref_6_c_657_n ) capacitor c=3.31706e-19 \
 //x=4.485 //y=5.39 //x2=5.92 //y2=5.475
cc_274 ( N_noxref_3_c_258_n N_noxref_6_c_657_n ) capacitor c=9.46973e-19 \
 //x=4.6 //y=5.39 //x2=5.92 //y2=5.475
cc_275 ( N_noxref_3_M13_noxref_d N_noxref_6_c_658_n ) capacitor c=0.001104f \
 //x=6.215 //y=5.205 //x2=7.94 //y2=5.39
cc_276 ( N_noxref_3_c_264_n N_noxref_6_c_661_n ) capacitor c=0.001104f \
 //x=6.275 //y=7.09 //x2=8.025 //y2=7.09
cc_277 ( N_noxref_3_c_245_n N_noxref_6_M10_noxref_d ) capacitor c=4.76678e-19 \
 //x=4.485 //y=5.39 //x2=4.895 //y2=5.205
cc_278 ( N_noxref_3_c_260_n N_noxref_6_M10_noxref_d ) capacitor c=0.0117256f \
 //x=5.395 //y=7.09 //x2=4.895 //y2=5.205
cc_279 ( N_noxref_3_M11_noxref_d N_noxref_6_M10_noxref_d ) capacitor \
 c=0.0458293f //x=5.335 //y=5.205 //x2=4.895 //y2=5.205
cc_280 ( N_noxref_3_M13_noxref_d N_noxref_6_M10_noxref_d ) capacitor \
 c=7.47391e-19 //x=6.215 //y=5.205 //x2=4.895 //y2=5.205
cc_281 ( N_noxref_3_c_258_n N_noxref_6_M12_noxref_d ) capacitor c=9.55e-19 \
 //x=4.6 //y=5.39 //x2=5.775 //y2=5.205
cc_282 ( N_noxref_3_c_264_n N_noxref_6_M12_noxref_d ) capacitor c=0.0115693f \
 //x=6.275 //y=7.09 //x2=5.775 //y2=5.205
cc_283 ( N_noxref_3_M11_noxref_d N_noxref_6_M12_noxref_d ) capacitor \
 c=0.0458293f //x=5.335 //y=5.205 //x2=5.775 //y2=5.205
cc_284 ( N_noxref_3_M13_noxref_d N_noxref_6_M12_noxref_d ) capacitor \
 c=0.0550393f //x=6.215 //y=5.205 //x2=5.775 //y2=5.205
cc_285 ( N_noxref_3_c_245_n N_A_c_740_n ) capacitor c=0.00621254f //x=4.485 \
 //y=5.39 //x2=8.885 //y2=4.25
cc_286 ( N_noxref_3_c_247_n N_A_c_740_n ) capacitor c=0.0012098f //x=2.715 \
 //y=5.39 //x2=8.885 //y2=4.25
cc_287 ( N_noxref_3_c_250_n N_A_c_750_n ) capacitor c=0.0125744f //x=2.515 \
 //y=5.39 //x2=2.34 //y2=4.72
cc_288 ( N_noxref_3_c_247_n N_A_M8_noxref_g ) capacitor c=0.0010118f //x=2.715 \
 //y=5.39 //x2=2.38 //y2=6.205
cc_289 ( N_noxref_3_c_250_n N_A_M8_noxref_g ) capacitor c=0.0161883f //x=2.515 \
 //y=5.39 //x2=2.38 //y2=6.205
cc_290 ( N_noxref_3_c_255_n N_A_M8_noxref_g ) capacitor c=0.00226657f //x=2.6 \
 //y=5.475 //x2=2.38 //y2=6.205
cc_291 ( N_noxref_3_M8_noxref_d N_A_M8_noxref_g ) capacitor c=0.016914f \
 //x=2.455 //y=5.205 //x2=2.38 //y2=6.205
cc_292 ( N_noxref_3_c_245_n N_A_M9_noxref_g ) capacitor c=0.0122278f //x=4.485 \
 //y=5.39 //x2=2.82 //y2=6.205
cc_293 ( N_noxref_3_c_247_n N_A_M9_noxref_g ) capacitor c=8.30848e-19 \
 //x=2.715 //y=5.39 //x2=2.82 //y2=6.205
cc_294 ( N_noxref_3_c_255_n N_A_M9_noxref_g ) capacitor c=0.0197448f //x=2.6 \
 //y=5.475 //x2=2.82 //y2=6.205
cc_295 ( N_noxref_3_c_255_n N_A_c_761_n ) capacitor c=0.00458101f //x=2.6 \
 //y=5.475 //x2=2.745 //y2=4.975
cc_296 ( N_noxref_3_c_250_n N_A_c_762_n ) capacitor c=0.00303555f //x=2.515 \
 //y=5.39 //x2=2.38 //y2=4.885
cc_297 ( N_noxref_3_c_258_n N_noxref_10_c_1153_n ) capacitor c=0.00113611f \
 //x=4.6 //y=5.39 //x2=4.515 //y2=1.675
cc_298 ( N_B_c_339_n N_C_c_490_n ) capacitor c=0.00592091f //x=4.93 //y=2.26 \
 //x2=6.525 //y2=2.26
cc_299 ( N_B_c_361_n N_C_c_491_n ) capacitor c=0.00342554f //x=4.815 //y=4.62 \
 //x2=6.41 //y2=2.26
cc_300 ( N_B_c_339_n N_C_c_491_n ) capacitor c=0.0367672f //x=4.93 //y=2.26 \
 //x2=6.41 //y2=2.26
cc_301 ( N_B_c_354_n N_C_c_491_n ) capacitor c=2.35599e-19 //x=4.735 //y=2.095 \
 //x2=6.41 //y2=2.26
cc_302 ( N_B_c_381_n N_C_c_491_n ) capacitor c=2.35599e-19 //x=4.93 //y=4.885 \
 //x2=6.41 //y2=2.26
cc_303 ( N_B_c_339_n N_C_c_493_n ) capacitor c=4.31424e-19 //x=4.93 //y=2.26 \
 //x2=7.89 //y2=2.26
cc_304 ( N_B_M10_noxref_g N_C_M12_noxref_g ) capacitor c=0.009459f //x=4.82 \
 //y=6.205 //x2=5.7 //y2=6.205
cc_305 ( N_B_M11_noxref_g N_C_M12_noxref_g ) capacitor c=0.0626756f //x=5.26 \
 //y=6.205 //x2=5.7 //y2=6.205
cc_306 ( N_B_M11_noxref_g N_C_M13_noxref_g ) capacitor c=0.00899012f //x=5.26 \
 //y=6.205 //x2=6.14 //y2=6.205
cc_307 ( N_B_c_351_n N_C_c_531_n ) capacitor c=4.86506e-19 //x=4.735 //y=1.045 \
 //x2=5.705 //y2=1.085
cc_308 ( N_B_c_353_n N_C_c_531_n ) capacitor c=0.00101233f //x=4.735 //y=1.39 \
 //x2=5.705 //y2=1.085
cc_309 ( N_B_c_357_n N_C_c_531_n ) capacitor c=0.0168844f //x=5.265 //y=1.045 \
 //x2=5.705 //y2=1.085
cc_310 ( N_B_c_410_p N_C_c_534_n ) capacitor c=7.88071e-19 //x=4.735 //y=1.7 \
 //x2=5.705 //y2=1.43
cc_311 ( N_B_c_359_n N_C_c_534_n ) capacitor c=0.0168218f //x=5.265 //y=1.39 \
 //x2=5.705 //y2=1.43
cc_312 ( N_B_c_339_n N_C_c_536_n ) capacitor c=9.39431e-19 //x=4.93 //y=2.26 \
 //x2=5.775 //y2=4.975
cc_313 ( N_B_c_381_n N_C_c_536_n ) capacitor c=0.0634092f //x=4.93 //y=4.885 \
 //x2=5.775 //y2=4.975
cc_314 ( N_B_c_339_n N_C_c_514_n ) capacitor c=2.35599e-19 //x=4.93 //y=2.26 \
 //x2=6.14 //y2=5.05
cc_315 ( N_B_c_381_n N_C_c_514_n ) capacitor c=5.35364e-19 //x=4.93 //y=4.885 \
 //x2=6.14 //y2=5.05
cc_316 ( N_B_c_357_n N_C_c_540_n ) capacitor c=0.00124821f //x=5.265 //y=1.045 \
 //x2=6.235 //y2=1.085
cc_317 ( N_B_c_359_n N_C_c_541_n ) capacitor c=8.19575e-19 //x=5.265 //y=1.39 \
 //x2=6.235 //y2=1.43
cc_318 ( N_B_c_359_n N_C_c_542_n ) capacitor c=3.60397e-19 //x=5.265 //y=1.39 \
 //x2=6.235 //y2=1.74
cc_319 ( N_B_c_339_n N_C_c_494_n ) capacitor c=2.35599e-19 //x=4.93 //y=2.26 \
 //x2=6.235 //y2=2.095
cc_320 ( N_B_c_354_n N_C_c_494_n ) capacitor c=4.61972e-19 //x=4.735 //y=2.095 \
 //x2=6.235 //y2=2.095
cc_321 ( N_B_M11_noxref_g N_noxref_6_c_673_n ) capacitor c=0.0179352f //x=5.26 \
 //y=6.205 //x2=5.835 //y2=5.39
cc_322 ( N_B_c_361_n N_noxref_6_c_656_n ) capacitor c=0.00235358f //x=4.815 \
 //y=4.62 //x2=5.125 //y2=5.39
cc_323 ( N_B_c_339_n N_noxref_6_c_656_n ) capacitor c=0.00555094f //x=4.93 \
 //y=2.26 //x2=5.125 //y2=5.39
cc_324 ( N_B_M10_noxref_g N_noxref_6_c_656_n ) capacitor c=0.0132827f //x=4.82 \
 //y=6.205 //x2=5.125 //y2=5.39
cc_325 ( N_B_c_381_n N_noxref_6_c_656_n ) capacitor c=0.00516077f //x=4.93 \
 //y=4.885 //x2=5.125 //y2=5.39
cc_326 ( N_B_M11_noxref_g N_noxref_6_M10_noxref_d ) capacitor c=0.0130327f \
 //x=5.26 //y=6.205 //x2=4.895 //y2=5.205
cc_327 ( N_B_c_361_n N_A_c_740_n ) capacitor c=0.250504f //x=4.815 //y=4.62 \
 //x2=8.885 //y2=4.25
cc_328 ( N_B_c_339_n N_A_c_740_n ) capacitor c=0.0287724f //x=4.93 //y=2.26 \
 //x2=8.885 //y2=4.25
cc_329 ( N_B_c_381_n N_A_c_740_n ) capacitor c=0.00421906f //x=4.93 //y=4.885 \
 //x2=8.885 //y2=4.25
cc_330 ( N_B_c_361_n N_A_c_749_n ) capacitor c=0.0306989f //x=4.815 //y=4.62 \
 //x2=2.455 //y2=4.25
cc_331 ( N_B_c_336_n N_A_c_749_n ) capacitor c=0.00461728f //x=1.23 //y=2.26 \
 //x2=2.455 //y2=4.25
cc_332 ( N_B_c_361_n N_A_c_750_n ) capacitor c=0.00209876f //x=4.815 //y=4.62 \
 //x2=2.34 //y2=4.72
cc_333 ( N_B_c_336_n N_A_c_750_n ) capacitor c=0.00227044f //x=1.23 //y=2.26 \
 //x2=2.34 //y2=4.72
cc_334 ( N_B_c_397_n N_A_c_750_n ) capacitor c=0.00155256f //x=1.865 //y=4.975 \
 //x2=2.34 //y2=4.72
cc_335 ( N_B_c_379_n N_A_c_750_n ) capacitor c=0.00180548f //x=1.575 //y=4.975 \
 //x2=2.34 //y2=4.72
cc_336 ( N_B_c_361_n N_A_c_742_n ) capacitor c=0.0231643f //x=4.815 //y=4.62 \
 //x2=2.34 //y2=2.26
cc_337 ( N_B_c_364_n N_A_c_742_n ) capacitor c=0.00129139f //x=1.345 //y=4.62 \
 //x2=2.34 //y2=2.26
cc_338 ( N_B_c_336_n N_A_c_742_n ) capacitor c=0.0521142f //x=1.23 //y=2.26 \
 //x2=2.34 //y2=2.26
cc_339 ( N_B_c_339_n N_A_c_742_n ) capacitor c=0.0108828f //x=4.93 //y=2.26 \
 //x2=2.34 //y2=2.26
cc_340 ( N_B_c_360_n N_A_c_742_n ) capacitor c=0.00236728f //x=1.23 //y=2.26 \
 //x2=2.34 //y2=2.26
cc_341 ( N_B_M6_noxref_g N_A_M8_noxref_g ) capacitor c=0.010584f //x=1.5 \
 //y=6.205 //x2=2.38 //y2=6.205
cc_342 ( N_B_M7_noxref_g N_A_M8_noxref_g ) capacitor c=0.106414f //x=1.94 \
 //y=6.205 //x2=2.38 //y2=6.205
cc_343 ( N_B_M7_noxref_g N_A_M9_noxref_g ) capacitor c=0.0102479f //x=1.94 \
 //y=6.205 //x2=2.82 //y2=6.205
cc_344 ( N_B_c_341_n N_A_c_792_n ) capacitor c=4.86506e-19 //x=1.405 //y=1.045 \
 //x2=2.375 //y2=1.085
cc_345 ( N_B_c_343_n N_A_c_792_n ) capacitor c=0.00152104f //x=1.405 //y=1.39 \
 //x2=2.375 //y2=1.085
cc_346 ( N_B_c_348_n N_A_c_792_n ) capacitor c=0.0151475f //x=1.935 //y=1.045 \
 //x2=2.375 //y2=1.085
cc_347 ( N_B_c_344_n N_A_c_795_n ) capacitor c=0.00109982f //x=1.405 //y=1.7 \
 //x2=2.375 //y2=1.43
cc_348 ( N_B_c_350_n N_A_c_795_n ) capacitor c=0.0111064f //x=1.935 //y=1.39 \
 //x2=2.375 //y2=1.43
cc_349 ( N_B_c_344_n N_A_c_797_n ) capacitor c=0.00179029f //x=1.405 //y=1.7 \
 //x2=2.375 //y2=1.74
cc_350 ( N_B_c_345_n N_A_c_797_n ) capacitor c=0.00662747f //x=1.405 //y=2.095 \
 //x2=2.375 //y2=1.74
cc_351 ( N_B_c_350_n N_A_c_797_n ) capacitor c=0.00862358f //x=1.935 //y=1.39 \
 //x2=2.375 //y2=1.74
cc_352 ( N_B_c_361_n N_A_c_761_n ) capacitor c=0.00823362f //x=4.815 //y=4.62 \
 //x2=2.745 //y2=4.975
cc_353 ( N_B_c_348_n N_A_c_801_n ) capacitor c=0.00124846f //x=1.935 //y=1.045 \
 //x2=2.905 //y2=1.085
cc_354 ( N_B_c_350_n N_A_c_802_n ) capacitor c=0.00168739f //x=1.935 //y=1.39 \
 //x2=2.905 //y2=1.43
cc_355 ( N_B_c_336_n N_A_c_746_n ) capacitor c=0.00224607f //x=1.23 //y=2.26 \
 //x2=2.34 //y2=2.26
cc_356 ( N_B_c_360_n N_A_c_746_n ) capacitor c=0.00942627f //x=1.23 //y=2.26 \
 //x2=2.34 //y2=2.26
cc_357 ( N_B_c_361_n N_A_c_762_n ) capacitor c=0.00135772f //x=4.815 //y=4.62 \
 //x2=2.38 //y2=4.885
cc_358 ( N_B_c_336_n N_A_c_762_n ) capacitor c=0.00228787f //x=1.23 //y=2.26 \
 //x2=2.38 //y2=4.885
cc_359 ( N_B_c_397_n N_A_c_762_n ) capacitor c=0.0201611f //x=1.865 //y=4.975 \
 //x2=2.38 //y2=4.885
cc_360 ( N_B_c_379_n N_A_c_762_n ) capacitor c=0.00447195f //x=1.575 //y=4.975 \
 //x2=2.38 //y2=4.885
cc_361 ( N_B_c_353_n N_YN_c_920_n ) capacitor c=0.00500281f //x=4.735 //y=1.39 \
 //x2=5.855 //y2=1.36
cc_362 ( N_B_c_410_p N_YN_c_920_n ) capacitor c=0.00417656f //x=4.735 //y=1.7 \
 //x2=5.855 //y2=1.36
cc_363 ( N_B_c_355_n N_YN_c_920_n ) capacitor c=4.02408e-19 //x=5.11 //y=0.89 \
 //x2=5.855 //y2=1.36
cc_364 ( N_B_c_356_n N_YN_c_920_n ) capacitor c=0.00394544f //x=5.11 //y=1.545 \
 //x2=5.855 //y2=1.36
cc_365 ( N_B_c_359_n N_YN_c_920_n ) capacitor c=0.00800691f //x=5.265 //y=1.39 \
 //x2=5.855 //y2=1.36
cc_366 ( N_B_c_336_n N_noxref_9_c_1100_n ) capacitor c=0.0175385f //x=1.23 \
 //y=2.26 //x2=1.185 //y2=1.675
cc_367 ( N_B_c_345_n N_noxref_9_c_1100_n ) capacitor c=0.0034165f //x=1.405 \
 //y=2.095 //x2=1.185 //y2=1.675
cc_368 ( N_B_c_360_n N_noxref_9_c_1100_n ) capacitor c=0.00779838f //x=1.23 \
 //y=2.26 //x2=1.185 //y2=1.675
cc_369 ( N_B_c_336_n N_noxref_9_c_1078_n ) capacitor c=0.00527044f //x=1.23 \
 //y=2.26 //x2=2.07 //y2=1.76
cc_370 ( N_B_c_344_n N_noxref_9_c_1078_n ) capacitor c=0.00720513f //x=1.405 \
 //y=1.7 //x2=2.07 //y2=1.76
cc_371 ( N_B_c_345_n N_noxref_9_c_1078_n ) capacitor c=0.0159231f //x=1.405 \
 //y=2.095 //x2=2.07 //y2=1.76
cc_372 ( N_B_c_347_n N_noxref_9_c_1078_n ) capacitor c=0.0100869f //x=1.78 \
 //y=1.545 //x2=2.07 //y2=1.76
cc_373 ( N_B_c_350_n N_noxref_9_c_1078_n ) capacitor c=0.00339872f //x=1.935 \
 //y=1.39 //x2=2.07 //y2=1.76
cc_374 ( N_B_c_360_n N_noxref_9_c_1078_n ) capacitor c=0.00324321f //x=1.23 \
 //y=2.26 //x2=2.07 //y2=1.76
cc_375 ( N_B_c_345_n N_noxref_9_c_1086_n ) capacitor c=6.71402e-19 //x=1.405 \
 //y=2.095 //x2=2.155 //y2=1.675
cc_376 ( N_B_c_341_n N_noxref_9_M0_noxref_s ) capacitor c=0.0324729f //x=1.405 \
 //y=1.045 //x2=1.05 //y2=0.545
cc_377 ( N_B_c_344_n N_noxref_9_M0_noxref_s ) capacitor c=0.00110192f \
 //x=1.405 //y=1.7 //x2=1.05 //y2=0.545
cc_378 ( N_B_c_348_n N_noxref_9_M0_noxref_s ) capacitor c=0.0120759f //x=1.935 \
 //y=1.045 //x2=1.05 //y2=0.545
cc_379 ( N_B_c_354_n N_noxref_10_c_1153_n ) capacitor c=0.0034165f //x=4.735 \
 //y=2.095 //x2=4.515 //y2=1.675
cc_380 ( N_B_c_339_n N_noxref_10_c_1132_n ) capacitor c=0.0114681f //x=4.93 \
 //y=2.26 //x2=5.4 //y2=1.76
cc_381 ( N_B_c_410_p N_noxref_10_c_1132_n ) capacitor c=0.00598984f //x=4.735 \
 //y=1.7 //x2=5.4 //y2=1.76
cc_382 ( N_B_c_354_n N_noxref_10_c_1132_n ) capacitor c=0.0216843f //x=4.735 \
 //y=2.095 //x2=5.4 //y2=1.76
cc_383 ( N_B_c_356_n N_noxref_10_c_1132_n ) capacitor c=0.00767729f //x=5.11 \
 //y=1.545 //x2=5.4 //y2=1.76
cc_384 ( N_B_c_359_n N_noxref_10_c_1132_n ) capacitor c=0.0059368f //x=5.265 \
 //y=1.39 //x2=5.4 //y2=1.76
cc_385 ( N_B_c_354_n N_noxref_10_c_1139_n ) capacitor c=0.00122123f //x=4.735 \
 //y=2.095 //x2=5.485 //y2=1.675
cc_386 ( N_B_c_351_n N_noxref_10_M2_noxref_s ) capacitor c=0.0312776f \
 //x=4.735 //y=1.045 //x2=4.38 //y2=0.545
cc_387 ( N_B_c_410_p N_noxref_10_M2_noxref_s ) capacitor c=3.48408e-19 \
 //x=4.735 //y=1.7 //x2=4.38 //y2=0.545
cc_388 ( N_B_c_357_n N_noxref_10_M2_noxref_s ) capacitor c=0.0132463f \
 //x=5.265 //y=1.045 //x2=4.38 //y2=0.545
cc_389 ( N_C_c_491_n N_noxref_6_c_654_n ) capacitor c=0.00390164f //x=6.41 \
 //y=2.26 //x2=7.825 //y2=5.39
cc_390 ( N_C_c_493_n N_noxref_6_c_654_n ) capacitor c=0.00306605f //x=7.89 \
 //y=2.26 //x2=7.825 //y2=5.39
cc_391 ( N_C_M13_noxref_g N_noxref_6_c_654_n ) capacitor c=0.0116529f //x=6.14 \
 //y=6.205 //x2=7.825 //y2=5.39
cc_392 ( N_C_M14_noxref_g N_noxref_6_c_654_n ) capacitor c=0.00645933f \
 //x=8.16 //y=6.205 //x2=7.825 //y2=5.39
cc_393 ( N_C_c_514_n N_noxref_6_c_654_n ) capacitor c=0.00322986f //x=6.14 \
 //y=5.05 //x2=7.825 //y2=5.39
cc_394 ( N_C_c_515_n N_noxref_6_c_654_n ) capacitor c=0.00230229f //x=8.235 \
 //y=4.975 //x2=7.825 //y2=5.39
cc_395 ( N_C_M12_noxref_g N_noxref_6_c_655_n ) capacitor c=6.87102e-19 //x=5.7 \
 //y=6.205 //x2=6.035 //y2=5.39
cc_396 ( N_C_M13_noxref_g N_noxref_6_c_655_n ) capacitor c=8.33934e-19 \
 //x=6.14 //y=6.205 //x2=6.035 //y2=5.39
cc_397 ( N_C_M12_noxref_g N_noxref_6_c_673_n ) capacitor c=0.0179352f //x=5.7 \
 //y=6.205 //x2=5.835 //y2=5.39
cc_398 ( N_C_M12_noxref_g N_noxref_6_c_657_n ) capacitor c=0.0019882f //x=5.7 \
 //y=6.205 //x2=5.92 //y2=5.475
cc_399 ( N_C_M13_noxref_g N_noxref_6_c_657_n ) capacitor c=0.0159381f //x=6.14 \
 //y=6.205 //x2=5.92 //y2=5.475
cc_400 ( N_C_c_556_p N_noxref_6_c_657_n ) capacitor c=0.00456817f //x=6.065 \
 //y=4.975 //x2=5.92 //y2=5.475
cc_401 ( N_C_c_493_n N_noxref_6_c_658_n ) capacitor c=0.0184695f //x=7.89 \
 //y=2.26 //x2=7.94 //y2=5.39
cc_402 ( N_C_M14_noxref_g N_noxref_6_c_658_n ) capacitor c=0.0484795f //x=8.16 \
 //y=6.205 //x2=7.94 //y2=5.39
cc_403 ( N_C_c_515_n N_noxref_6_c_658_n ) capacitor c=0.0078825f //x=8.235 \
 //y=4.975 //x2=7.94 //y2=5.39
cc_404 ( N_C_M14_noxref_g N_noxref_6_c_660_n ) capacitor c=0.0168877f //x=8.16 \
 //y=6.205 //x2=8.735 //y2=7.09
cc_405 ( N_C_M15_noxref_g N_noxref_6_c_660_n ) capacitor c=0.0150109f //x=8.6 \
 //y=6.205 //x2=8.735 //y2=7.09
cc_406 ( N_C_M12_noxref_g N_noxref_6_M12_noxref_d ) capacitor c=0.0129738f \
 //x=5.7 //y=6.205 //x2=5.775 //y2=5.205
cc_407 ( N_C_M15_noxref_g N_noxref_6_M15_noxref_d ) capacitor c=0.0130327f \
 //x=8.6 //y=6.205 //x2=8.675 //y2=5.205
cc_408 ( N_C_c_489_n N_A_c_740_n ) capacitor c=0.0241346f //x=7.775 //y=2.26 \
 //x2=8.885 //y2=4.25
cc_409 ( N_C_c_490_n N_A_c_740_n ) capacitor c=0.00320786f //x=6.525 //y=2.26 \
 //x2=8.885 //y2=4.25
cc_410 ( N_C_c_491_n N_A_c_740_n ) capacitor c=0.02782f //x=6.41 //y=2.26 \
 //x2=8.885 //y2=4.25
cc_411 ( N_C_c_493_n N_A_c_740_n ) capacitor c=0.0284677f //x=7.89 //y=2.26 \
 //x2=8.885 //y2=4.25
cc_412 ( N_C_c_536_n N_A_c_740_n ) capacitor c=0.00895531f //x=5.775 //y=4.975 \
 //x2=8.885 //y2=4.25
cc_413 ( N_C_c_514_n N_A_c_740_n ) capacitor c=0.00173309f //x=6.14 //y=5.05 \
 //x2=8.885 //y2=4.25
cc_414 ( N_C_c_515_n N_A_c_740_n ) capacitor c=0.0121514f //x=8.235 //y=4.975 \
 //x2=8.885 //y2=4.25
cc_415 ( N_C_c_489_n N_A_c_744_n ) capacitor c=0.00668632f //x=7.775 //y=2.26 \
 //x2=9 //y2=2.26
cc_416 ( N_C_c_491_n N_A_c_744_n ) capacitor c=5.81684e-19 //x=6.41 //y=2.26 \
 //x2=9 //y2=2.26
cc_417 ( N_C_c_493_n N_A_c_744_n ) capacitor c=0.0540771f //x=7.89 //y=2.26 \
 //x2=9 //y2=2.26
cc_418 ( N_C_c_504_n N_A_c_744_n ) capacitor c=0.00218919f //x=7.89 //y=2.26 \
 //x2=9 //y2=2.26
cc_419 ( N_C_c_575_p N_A_c_820_n ) capacitor c=0.00168516f //x=8.525 //y=4.975 \
 //x2=9.02 //y2=4.885
cc_420 ( N_C_c_515_n N_A_c_820_n ) capacitor c=0.00143876f //x=8.235 //y=4.975 \
 //x2=9.02 //y2=4.885
cc_421 ( N_C_M14_noxref_g N_A_M16_noxref_g ) capacitor c=0.00932631f //x=8.16 \
 //y=6.205 //x2=9.04 //y2=6.205
cc_422 ( N_C_M15_noxref_g N_A_M16_noxref_g ) capacitor c=0.110179f //x=8.6 \
 //y=6.205 //x2=9.04 //y2=6.205
cc_423 ( N_C_M15_noxref_g N_A_M17_noxref_g ) capacitor c=0.00876656f //x=8.6 \
 //y=6.205 //x2=9.48 //y2=6.205
cc_424 ( N_C_c_495_n N_A_c_825_n ) capacitor c=4.86506e-19 //x=8.065 //y=1.045 \
 //x2=9.035 //y2=1.085
cc_425 ( N_C_c_497_n N_A_c_825_n ) capacitor c=0.00101233f //x=8.065 //y=1.39 \
 //x2=9.035 //y2=1.085
cc_426 ( N_C_c_501_n N_A_c_825_n ) capacitor c=0.0161138f //x=8.595 //y=1.045 \
 //x2=9.035 //y2=1.085
cc_427 ( N_C_c_503_n N_A_c_828_n ) capacitor c=0.0120728f //x=8.595 //y=1.39 \
 //x2=9.035 //y2=1.435
cc_428 ( N_C_c_584_p N_A_c_829_n ) capacitor c=0.00257836f //x=8.065 //y=1.7 \
 //x2=9.035 //y2=1.74
cc_429 ( N_C_c_498_n N_A_c_829_n ) capacitor c=0.00662747f //x=8.065 //y=2.095 \
 //x2=9.035 //y2=1.74
cc_430 ( N_C_c_503_n N_A_c_829_n ) capacitor c=0.00862358f //x=8.595 //y=1.39 \
 //x2=9.035 //y2=1.74
cc_431 ( N_C_c_503_n N_A_c_832_n ) capacitor c=4.4593e-19 //x=8.595 //y=1.39 \
 //x2=9.41 //y2=1.585
cc_432 ( N_C_c_501_n N_A_c_833_n ) capacitor c=0.00130607f //x=8.595 //y=1.045 \
 //x2=9.565 //y2=1.085
cc_433 ( N_C_c_503_n N_A_c_834_n ) capacitor c=0.00111855f //x=8.595 //y=1.39 \
 //x2=9.565 //y2=1.435
cc_434 ( N_C_c_489_n N_A_c_835_n ) capacitor c=0.00319611f //x=7.775 //y=2.26 \
 //x2=9 //y2=2.26
cc_435 ( N_C_c_493_n N_A_c_835_n ) capacitor c=0.00207994f //x=7.89 //y=2.26 \
 //x2=9 //y2=2.26
cc_436 ( N_C_c_504_n N_A_c_835_n ) capacitor c=0.00908973f //x=7.89 //y=2.26 \
 //x2=9 //y2=2.26
cc_437 ( N_C_c_493_n N_A_c_838_n ) capacitor c=0.00196222f //x=7.89 //y=2.26 \
 //x2=9.02 //y2=4.885
cc_438 ( N_C_c_575_p N_A_c_838_n ) capacitor c=0.0225854f //x=8.525 //y=4.975 \
 //x2=9.02 //y2=4.885
cc_439 ( N_C_c_515_n N_A_c_838_n ) capacitor c=0.00469886f //x=8.235 //y=4.975 \
 //x2=9.02 //y2=4.885
cc_440 ( N_C_c_531_n N_YN_c_920_n ) capacitor c=5.17481e-19 //x=5.705 \
 //y=1.085 //x2=5.855 //y2=1.36
cc_441 ( N_C_c_534_n N_YN_c_920_n ) capacitor c=0.0060729f //x=5.705 //y=1.43 \
 //x2=5.855 //y2=1.36
cc_442 ( N_C_c_489_n N_YN_c_928_n ) capacitor c=0.0537395f //x=7.775 //y=2.26 \
 //x2=9.185 //y2=1.36
cc_443 ( N_C_c_490_n N_YN_c_928_n ) capacitor c=0.010332f //x=6.525 //y=2.26 \
 //x2=9.185 //y2=1.36
cc_444 ( N_C_c_491_n N_YN_c_928_n ) capacitor c=0.00189559f //x=6.41 //y=2.26 \
 //x2=9.185 //y2=1.36
cc_445 ( N_C_c_493_n N_YN_c_928_n ) capacitor c=0.00134607f //x=7.89 //y=2.26 \
 //x2=9.185 //y2=1.36
cc_446 ( N_C_c_540_n N_YN_c_928_n ) capacitor c=4.67724e-19 //x=6.235 \
 //y=1.085 //x2=9.185 //y2=1.36
cc_447 ( N_C_c_541_n N_YN_c_928_n ) capacitor c=0.00591245f //x=6.235 //y=1.43 \
 //x2=9.185 //y2=1.36
cc_448 ( N_C_c_542_n N_YN_c_928_n ) capacitor c=0.00536755f //x=6.235 //y=1.74 \
 //x2=9.185 //y2=1.36
cc_449 ( N_C_c_494_n N_YN_c_928_n ) capacitor c=2.04565e-19 //x=6.235 \
 //y=2.095 //x2=9.185 //y2=1.36
cc_450 ( N_C_c_497_n N_YN_c_928_n ) capacitor c=0.00500281f //x=8.065 //y=1.39 \
 //x2=9.185 //y2=1.36
cc_451 ( N_C_c_584_p N_YN_c_928_n ) capacitor c=0.00402142f //x=8.065 //y=1.7 \
 //x2=9.185 //y2=1.36
cc_452 ( N_C_c_499_n N_YN_c_928_n ) capacitor c=4.02408e-19 //x=8.44 //y=0.89 \
 //x2=9.185 //y2=1.36
cc_453 ( N_C_c_500_n N_YN_c_928_n ) capacitor c=0.00394544f //x=8.44 //y=1.545 \
 //x2=9.185 //y2=1.36
cc_454 ( N_C_c_503_n N_YN_c_928_n ) capacitor c=0.00800691f //x=8.595 //y=1.39 \
 //x2=9.185 //y2=1.36
cc_455 ( N_C_c_534_n N_YN_c_934_n ) capacitor c=0.00160903f //x=5.705 //y=1.43 \
 //x2=6.085 //y2=1.36
cc_456 ( N_C_c_612_p N_YN_c_934_n ) capacitor c=4.52813e-19 //x=6.08 //y=0.93 \
 //x2=6.085 //y2=1.36
cc_457 ( N_C_c_613_p N_YN_c_934_n ) capacitor c=7.60541e-19 //x=6.08 //y=1.585 \
 //x2=6.085 //y2=1.36
cc_458 ( N_C_c_541_n N_YN_c_934_n ) capacitor c=5.11592e-19 //x=6.235 //y=1.43 \
 //x2=6.085 //y2=1.36
cc_459 ( N_C_c_542_n N_YN_c_934_n ) capacitor c=9.97045e-19 //x=6.235 //y=1.74 \
 //x2=6.085 //y2=1.36
cc_460 ( N_C_c_493_n YN ) capacitor c=0.00342847f //x=7.89 //y=2.26 //x2=9.74 \
 //y2=2.4
cc_461 ( N_C_M15_noxref_g N_YN_c_979_n ) capacitor c=0.0179352f //x=8.6 \
 //y=6.205 //x2=9.175 //y2=5.39
cc_462 ( N_C_M14_noxref_g N_YN_c_949_n ) capacitor c=0.0132916f //x=8.16 \
 //y=6.205 //x2=8.465 //y2=5.39
cc_463 ( N_C_c_575_p N_YN_c_949_n ) capacitor c=0.00362585f //x=8.525 \
 //y=4.975 //x2=8.465 //y2=5.39
cc_464 ( N_C_c_531_n N_YN_M3_noxref_d ) capacitor c=0.00217566f //x=5.705 \
 //y=1.085 //x2=5.78 //y2=1.085
cc_465 ( N_C_c_534_n N_YN_M3_noxref_d ) capacitor c=0.00711747f //x=5.705 \
 //y=1.43 //x2=5.78 //y2=1.085
cc_466 ( N_C_c_612_p N_YN_M3_noxref_d ) capacitor c=0.00234223f //x=6.08 \
 //y=0.93 //x2=5.78 //y2=1.085
cc_467 ( N_C_c_613_p N_YN_M3_noxref_d ) capacitor c=0.00602848f //x=6.08 \
 //y=1.585 //x2=5.78 //y2=1.085
cc_468 ( N_C_c_540_n N_YN_M3_noxref_d ) capacitor c=0.00132245f //x=6.235 \
 //y=1.085 //x2=5.78 //y2=1.085
cc_469 ( N_C_c_541_n N_YN_M3_noxref_d ) capacitor c=0.004434f //x=6.235 \
 //y=1.43 //x2=5.78 //y2=1.085
cc_470 ( N_C_c_542_n N_YN_M3_noxref_d ) capacitor c=0.00270197f //x=6.235 \
 //y=1.74 //x2=5.78 //y2=1.085
cc_471 ( N_C_M15_noxref_g N_YN_M14_noxref_d ) capacitor c=0.0130327f //x=8.6 \
 //y=6.205 //x2=8.235 //y2=5.205
cc_472 ( N_C_c_494_n N_noxref_10_c_1139_n ) capacitor c=0.0028747f //x=6.235 \
 //y=2.095 //x2=5.485 //y2=1.675
cc_473 ( N_C_c_531_n N_noxref_10_c_1140_n ) capacitor c=0.021566f //x=5.705 \
 //y=1.085 //x2=6.37 //y2=0.71
cc_474 ( N_C_c_540_n N_noxref_10_c_1140_n ) capacitor c=0.00781103f //x=6.235 \
 //y=1.085 //x2=6.37 //y2=0.71
cc_475 ( N_C_c_489_n N_noxref_10_M2_noxref_s ) capacitor c=5.04823e-19 \
 //x=7.775 //y=2.26 //x2=4.38 //y2=0.545
cc_476 ( N_C_c_490_n N_noxref_10_M2_noxref_s ) capacitor c=0.00110901f \
 //x=6.525 //y=2.26 //x2=4.38 //y2=0.545
cc_477 ( N_C_c_491_n N_noxref_10_M2_noxref_s ) capacitor c=0.0156825f //x=6.41 \
 //y=2.26 //x2=4.38 //y2=0.545
cc_478 ( N_C_c_531_n N_noxref_10_M2_noxref_s ) capacitor c=0.0064603f \
 //x=5.705 //y=1.085 //x2=4.38 //y2=0.545
cc_479 ( N_C_c_534_n N_noxref_10_M2_noxref_s ) capacitor c=0.00602248f \
 //x=5.705 //y=1.43 //x2=4.38 //y2=0.545
cc_480 ( N_C_c_540_n N_noxref_10_M2_noxref_s ) capacitor c=0.0321601f \
 //x=6.235 //y=1.085 //x2=4.38 //y2=0.545
cc_481 ( N_C_c_542_n N_noxref_10_M2_noxref_s ) capacitor c=0.00239072f \
 //x=6.235 //y=1.74 //x2=4.38 //y2=0.545
cc_482 ( N_C_c_494_n N_noxref_10_M2_noxref_s ) capacitor c=0.00784558f \
 //x=6.235 //y=2.095 //x2=4.38 //y2=0.545
cc_483 ( N_C_c_489_n N_noxref_11_c_1204_n ) capacitor c=0.00161383f //x=7.775 \
 //y=2.26 //x2=7.845 //y2=1.675
cc_484 ( N_C_c_493_n N_noxref_11_c_1204_n ) capacitor c=0.0149616f //x=7.89 \
 //y=2.26 //x2=7.845 //y2=1.675
cc_485 ( N_C_c_498_n N_noxref_11_c_1204_n ) capacitor c=0.0034165f //x=8.065 \
 //y=2.095 //x2=7.845 //y2=1.675
cc_486 ( N_C_c_504_n N_noxref_11_c_1204_n ) capacitor c=0.00784558f //x=7.89 \
 //y=2.26 //x2=7.845 //y2=1.675
cc_487 ( N_C_c_489_n N_noxref_11_c_1188_n ) capacitor c=0.00219246f //x=7.775 \
 //y=2.26 //x2=8.73 //y2=1.76
cc_488 ( N_C_c_493_n N_noxref_11_c_1188_n ) capacitor c=0.00587766f //x=7.89 \
 //y=2.26 //x2=8.73 //y2=1.76
cc_489 ( N_C_c_584_p N_noxref_11_c_1188_n ) capacitor c=0.0061593f //x=8.065 \
 //y=1.7 //x2=8.73 //y2=1.76
cc_490 ( N_C_c_498_n N_noxref_11_c_1188_n ) capacitor c=0.014638f //x=8.065 \
 //y=2.095 //x2=8.73 //y2=1.76
cc_491 ( N_C_c_500_n N_noxref_11_c_1188_n ) capacitor c=0.00991953f //x=8.44 \
 //y=1.545 //x2=8.73 //y2=1.76
cc_492 ( N_C_c_503_n N_noxref_11_c_1188_n ) capacitor c=0.00339872f //x=8.595 \
 //y=1.39 //x2=8.73 //y2=1.76
cc_493 ( N_C_c_504_n N_noxref_11_c_1188_n ) capacitor c=0.00147967f //x=7.89 \
 //y=2.26 //x2=8.73 //y2=1.76
cc_494 ( N_C_c_498_n N_noxref_11_c_1194_n ) capacitor c=6.71402e-19 //x=8.065 \
 //y=2.095 //x2=8.815 //y2=1.675
cc_495 ( N_C_c_495_n N_noxref_11_M4_noxref_s ) capacitor c=0.0314164f \
 //x=8.065 //y=1.045 //x2=7.71 //y2=0.545
cc_496 ( N_C_c_584_p N_noxref_11_M4_noxref_s ) capacitor c=0.00110192f \
 //x=8.065 //y=1.7 //x2=7.71 //y2=0.545
cc_497 ( N_C_c_501_n N_noxref_11_M4_noxref_s ) capacitor c=0.0132463f \
 //x=8.595 //y=1.045 //x2=7.71 //y2=0.545
cc_498 ( N_noxref_6_c_654_n N_A_c_740_n ) capacitor c=0.05762f //x=7.825 \
 //y=5.39 //x2=8.885 //y2=4.25
cc_499 ( N_noxref_6_c_655_n N_A_c_740_n ) capacitor c=0.00859229f //x=6.035 \
 //y=5.39 //x2=8.885 //y2=4.25
cc_500 ( N_noxref_6_c_673_n N_A_c_740_n ) capacitor c=6.02755e-19 //x=5.835 \
 //y=5.39 //x2=8.885 //y2=4.25
cc_501 ( N_noxref_6_c_656_n N_A_c_740_n ) capacitor c=0.0192405f //x=5.125 \
 //y=5.39 //x2=8.885 //y2=4.25
cc_502 ( N_noxref_6_c_657_n N_A_c_740_n ) capacitor c=0.0029599f //x=5.92 \
 //y=5.475 //x2=8.885 //y2=4.25
cc_503 ( N_noxref_6_c_658_n N_A_c_740_n ) capacitor c=0.00100252f //x=7.94 \
 //y=5.39 //x2=8.885 //y2=4.25
cc_504 ( N_noxref_6_c_663_n N_A_M16_noxref_g ) capacitor c=0.0150109f \
 //x=9.615 //y=7.09 //x2=9.04 //y2=6.205
cc_505 ( N_noxref_6_M15_noxref_d N_A_M16_noxref_g ) capacitor c=0.0130327f \
 //x=8.675 //y=5.205 //x2=9.04 //y2=6.205
cc_506 ( N_noxref_6_c_663_n N_A_M17_noxref_g ) capacitor c=0.0163361f \
 //x=9.615 //y=7.09 //x2=9.48 //y2=6.205
cc_507 ( N_noxref_6_M17_noxref_d N_A_M17_noxref_g ) capacitor c=0.0351101f \
 //x=9.555 //y=5.205 //x2=9.48 //y2=6.205
cc_508 ( N_noxref_6_c_658_n YN ) capacitor c=3.02032e-19 //x=7.94 //y=5.39 \
 //x2=9.74 //y2=2.4
cc_509 ( N_noxref_6_c_660_n N_YN_c_979_n ) capacitor c=0.00128698f //x=8.735 \
 //y=7.09 //x2=9.175 //y2=5.39
cc_510 ( N_noxref_6_c_663_n N_YN_c_979_n ) capacitor c=0.00128587f //x=9.615 \
 //y=7.09 //x2=9.175 //y2=5.39
cc_511 ( N_noxref_6_M15_noxref_d N_YN_c_979_n ) capacitor c=0.0128167f \
 //x=8.675 //y=5.205 //x2=9.175 //y2=5.39
cc_512 ( N_noxref_6_c_654_n N_YN_c_949_n ) capacitor c=0.00597302f //x=7.825 \
 //y=5.39 //x2=8.465 //y2=5.39
cc_513 ( N_noxref_6_c_658_n N_YN_c_949_n ) capacitor c=0.0683084f //x=7.94 \
 //y=5.39 //x2=8.465 //y2=5.39
cc_514 ( N_noxref_6_c_663_n N_YN_c_950_n ) capacitor c=0.00194034f //x=9.615 \
 //y=7.09 //x2=9.655 //y2=5.39
cc_515 ( N_noxref_6_M17_noxref_d N_YN_c_950_n ) capacitor c=0.0164227f \
 //x=9.555 //y=5.205 //x2=9.655 //y2=5.39
cc_516 ( N_noxref_6_c_654_n N_YN_M14_noxref_d ) capacitor c=8.04912e-19 \
 //x=7.825 //y=5.39 //x2=8.235 //y2=5.205
cc_517 ( N_noxref_6_c_660_n N_YN_M14_noxref_d ) capacitor c=0.0118172f \
 //x=8.735 //y=7.09 //x2=8.235 //y2=5.205
cc_518 ( N_noxref_6_M15_noxref_d N_YN_M14_noxref_d ) capacitor c=0.0458293f \
 //x=8.675 //y=5.205 //x2=8.235 //y2=5.205
cc_519 ( N_noxref_6_c_658_n N_YN_M16_noxref_d ) capacitor c=9.91979e-19 \
 //x=7.94 //y=5.39 //x2=9.115 //y2=5.205
cc_520 ( N_noxref_6_c_663_n N_YN_M16_noxref_d ) capacitor c=0.0118172f \
 //x=9.615 //y=7.09 //x2=9.115 //y2=5.205
cc_521 ( N_noxref_6_M15_noxref_d N_YN_M16_noxref_d ) capacitor c=0.0458293f \
 //x=8.675 //y=5.205 //x2=9.115 //y2=5.205
cc_522 ( N_noxref_6_M17_noxref_d N_YN_M16_noxref_d ) capacitor c=0.0458293f \
 //x=9.555 //y=5.205 //x2=9.115 //y2=5.205
cc_523 ( N_A_c_801_n N_YN_c_920_n ) capacitor c=4.67724e-19 //x=2.905 \
 //y=1.085 //x2=5.855 //y2=1.36
cc_524 ( N_A_c_802_n N_YN_c_920_n ) capacitor c=0.00730272f //x=2.905 //y=1.43 \
 //x2=5.855 //y2=1.36
cc_525 ( N_A_c_792_n N_YN_c_927_n ) capacitor c=3.66947e-19 //x=2.375 \
 //y=1.085 //x2=2.755 //y2=1.36
cc_526 ( N_A_c_795_n N_YN_c_927_n ) capacitor c=0.00353233f //x=2.375 //y=1.43 \
 //x2=2.755 //y2=1.36
cc_527 ( N_A_c_797_n N_YN_c_927_n ) capacitor c=0.00289888f //x=2.375 //y=1.74 \
 //x2=2.755 //y2=1.36
cc_528 ( N_A_c_856_p N_YN_c_927_n ) capacitor c=4.06815e-19 //x=2.75 //y=0.93 \
 //x2=2.755 //y2=1.36
cc_529 ( N_A_c_857_p N_YN_c_927_n ) capacitor c=7.44677e-19 //x=2.75 //y=1.585 \
 //x2=2.755 //y2=1.36
cc_530 ( N_A_c_802_n N_YN_c_927_n ) capacitor c=0.00140418f //x=2.905 //y=1.43 \
 //x2=2.755 //y2=1.36
cc_531 ( N_A_c_744_n N_YN_c_928_n ) capacitor c=0.00623394f //x=9 //y=2.26 \
 //x2=9.185 //y2=1.36
cc_532 ( N_A_c_825_n N_YN_c_928_n ) capacitor c=6.33948e-19 //x=9.035 \
 //y=1.085 //x2=9.185 //y2=1.36
cc_533 ( N_A_c_828_n N_YN_c_928_n ) capacitor c=0.00436559f //x=9.035 \
 //y=1.435 //x2=9.185 //y2=1.36
cc_534 ( N_A_c_829_n N_YN_c_928_n ) capacitor c=0.00510347f //x=9.035 //y=1.74 \
 //x2=9.185 //y2=1.36
cc_535 ( N_A_c_863_p N_YN_c_928_n ) capacitor c=4.52813e-19 //x=9.41 //y=0.93 \
 //x2=9.185 //y2=1.36
cc_536 ( N_A_c_832_n N_YN_c_928_n ) capacitor c=0.00296491f //x=9.41 //y=1.585 \
 //x2=9.185 //y2=1.36
cc_537 ( N_A_c_833_n N_YN_c_928_n ) capacitor c=2.65983e-19 //x=9.565 \
 //y=1.085 //x2=9.185 //y2=1.36
cc_538 ( N_A_c_834_n N_YN_c_928_n ) capacitor c=0.00362989f //x=9.565 \
 //y=1.435 //x2=9.185 //y2=1.36
cc_539 ( N_A_c_835_n N_YN_c_928_n ) capacitor c=6.36117e-19 //x=9 //y=2.26 \
 //x2=9.185 //y2=1.36
cc_540 ( N_A_c_740_n YN ) capacitor c=0.00642908f //x=8.885 //y=4.25 //x2=9.74 \
 //y2=2.4
cc_541 ( N_A_c_744_n YN ) capacitor c=0.0819612f //x=9 //y=2.26 //x2=9.74 \
 //y2=2.4
cc_542 ( N_A_c_820_n YN ) capacitor c=0.00998395f //x=9.02 //y=4.885 //x2=9.74 \
 //y2=2.4
cc_543 ( N_A_c_871_p YN ) capacitor c=0.0143966f //x=9.405 //y=4.975 //x2=9.74 \
 //y2=2.4
cc_544 ( N_A_c_835_n YN ) capacitor c=0.00704374f //x=9 //y=2.26 //x2=9.74 \
 //y2=2.4
cc_545 ( N_A_c_873_p YN ) capacitor c=0.0033061f //x=9 //y=2.095 //x2=9.74 \
 //y2=2.4
cc_546 ( N_A_c_838_n YN ) capacitor c=0.00526987f //x=9.02 //y=4.885 //x2=9.74 \
 //y2=2.4
cc_547 ( N_A_c_740_n N_YN_c_979_n ) capacitor c=0.00163628f //x=8.885 //y=4.25 \
 //x2=9.175 //y2=5.39
cc_548 ( N_A_c_820_n N_YN_c_979_n ) capacitor c=0.0124762f //x=9.02 //y=4.885 \
 //x2=9.175 //y2=5.39
cc_549 ( N_A_M16_noxref_g N_YN_c_979_n ) capacitor c=0.0167361f //x=9.04 \
 //y=6.205 //x2=9.175 //y2=5.39
cc_550 ( N_A_c_838_n N_YN_c_979_n ) capacitor c=0.00357687f //x=9.02 //y=4.885 \
 //x2=9.175 //y2=5.39
cc_551 ( N_A_c_740_n N_YN_c_949_n ) capacitor c=0.0147333f //x=8.885 //y=4.25 \
 //x2=8.465 //y2=5.39
cc_552 ( N_A_M17_noxref_g N_YN_c_950_n ) capacitor c=0.0223003f //x=9.48 \
 //y=6.205 //x2=9.655 //y2=5.39
cc_553 ( N_A_c_832_n N_YN_c_936_n ) capacitor c=0.00810194f //x=9.41 //y=1.585 \
 //x2=9.655 //y2=1.825
cc_554 ( N_A_c_873_p N_YN_c_1036_n ) capacitor c=0.00671029f //x=9 //y=2.095 \
 //x2=9.385 //y2=1.825
cc_555 ( N_A_c_871_p N_YN_c_1037_n ) capacitor c=0.00417892f //x=9.405 \
 //y=4.975 //x2=9.26 //y2=5.39
cc_556 ( N_A_c_792_n N_YN_M1_noxref_d ) capacitor c=0.00218556f //x=2.375 \
 //y=1.085 //x2=2.45 //y2=1.085
cc_557 ( N_A_c_795_n N_YN_M1_noxref_d ) capacitor c=0.00327871f //x=2.375 \
 //y=1.43 //x2=2.45 //y2=1.085
cc_558 ( N_A_c_797_n N_YN_M1_noxref_d ) capacitor c=0.00292542f //x=2.375 \
 //y=1.74 //x2=2.45 //y2=1.085
cc_559 ( N_A_c_856_p N_YN_M1_noxref_d ) capacitor c=0.00235569f //x=2.75 \
 //y=0.93 //x2=2.45 //y2=1.085
cc_560 ( N_A_c_857_p N_YN_M1_noxref_d ) capacitor c=0.00613695f //x=2.75 \
 //y=1.585 //x2=2.45 //y2=1.085
cc_561 ( N_A_c_801_n N_YN_M1_noxref_d ) capacitor c=0.00131413f //x=2.905 \
 //y=1.085 //x2=2.45 //y2=1.085
cc_562 ( N_A_c_802_n N_YN_M1_noxref_d ) capacitor c=0.00676348f //x=2.905 \
 //y=1.43 //x2=2.45 //y2=1.085
cc_563 ( N_A_c_825_n N_YN_M5_noxref_d ) capacitor c=0.00226395f //x=9.035 \
 //y=1.085 //x2=9.11 //y2=1.085
cc_564 ( N_A_c_828_n N_YN_M5_noxref_d ) capacitor c=0.004517f //x=9.035 \
 //y=1.435 //x2=9.11 //y2=1.085
cc_565 ( N_A_c_829_n N_YN_M5_noxref_d ) capacitor c=0.00655125f //x=9.035 \
 //y=1.74 //x2=9.11 //y2=1.085
cc_566 ( N_A_c_863_p N_YN_M5_noxref_d ) capacitor c=0.00241003f //x=9.41 \
 //y=0.93 //x2=9.11 //y2=1.085
cc_567 ( N_A_c_832_n N_YN_M5_noxref_d ) capacitor c=0.0159024f //x=9.41 \
 //y=1.585 //x2=9.11 //y2=1.085
cc_568 ( N_A_c_833_n N_YN_M5_noxref_d ) capacitor c=0.00132831f //x=9.565 \
 //y=1.085 //x2=9.11 //y2=1.085
cc_569 ( N_A_c_834_n N_YN_M5_noxref_d ) capacitor c=0.00330743f //x=9.565 \
 //y=1.435 //x2=9.11 //y2=1.085
cc_570 ( N_A_M16_noxref_g N_YN_M16_noxref_d ) capacitor c=0.0130327f //x=9.04 \
 //y=6.205 //x2=9.115 //y2=5.205
cc_571 ( N_A_M17_noxref_g N_YN_M16_noxref_d ) capacitor c=0.0136385f //x=9.48 \
 //y=6.205 //x2=9.115 //y2=5.205
cc_572 ( N_A_c_797_n N_noxref_9_c_1086_n ) capacitor c=0.00746306f //x=2.375 \
 //y=1.74 //x2=2.155 //y2=1.675
cc_573 ( N_A_c_746_n N_noxref_9_c_1086_n ) capacitor c=0.00172768f //x=2.34 \
 //y=2.26 //x2=2.155 //y2=1.675
cc_574 ( N_A_c_742_n N_noxref_9_c_1087_n ) capacitor c=0.00161844f //x=2.34 \
 //y=2.26 //x2=3.04 //y2=0.71
cc_575 ( N_A_c_792_n N_noxref_9_c_1087_n ) capacitor c=0.019862f //x=2.375 \
 //y=1.085 //x2=3.04 //y2=0.71
cc_576 ( N_A_c_801_n N_noxref_9_c_1087_n ) capacitor c=0.00825432f //x=2.905 \
 //y=1.085 //x2=3.04 //y2=0.71
cc_577 ( N_A_c_746_n N_noxref_9_c_1087_n ) capacitor c=2.1838e-19 //x=2.34 \
 //y=2.26 //x2=3.04 //y2=0.71
cc_578 ( N_A_c_792_n N_noxref_9_M0_noxref_s ) capacitor c=0.00746306f \
 //x=2.375 //y=1.085 //x2=1.05 //y2=0.545
cc_579 ( N_A_c_797_n N_noxref_9_M0_noxref_s ) capacitor c=0.00211573f \
 //x=2.375 //y=1.74 //x2=1.05 //y2=0.545
cc_580 ( N_A_c_801_n N_noxref_9_M0_noxref_s ) capacitor c=0.0133026f //x=2.905 \
 //y=1.085 //x2=1.05 //y2=0.545
cc_581 ( N_A_c_802_n N_noxref_9_M0_noxref_s ) capacitor c=0.00793126f \
 //x=2.905 //y=1.43 //x2=1.05 //y2=0.545
cc_582 ( N_A_c_910_p N_noxref_9_M0_noxref_s ) capacitor c=0.00392195f //x=2.34 \
 //y=2.095 //x2=1.05 //y2=0.545
cc_583 ( N_A_c_829_n N_noxref_11_c_1194_n ) capacitor c=0.00698471f //x=9.035 \
 //y=1.74 //x2=8.815 //y2=1.675
cc_584 ( N_A_c_835_n N_noxref_11_c_1194_n ) capacitor c=0.00159618f //x=9 \
 //y=2.26 //x2=8.815 //y2=1.675
cc_585 ( N_A_c_744_n N_noxref_11_c_1195_n ) capacitor c=0.00118117f //x=9 \
 //y=2.26 //x2=9.7 //y2=0.71
cc_586 ( N_A_c_825_n N_noxref_11_c_1195_n ) capacitor c=0.0191024f //x=9.035 \
 //y=1.085 //x2=9.7 //y2=0.71
cc_587 ( N_A_c_833_n N_noxref_11_c_1195_n ) capacitor c=0.00655165f //x=9.565 \
 //y=1.085 //x2=9.7 //y2=0.71
cc_588 ( N_A_c_835_n N_noxref_11_c_1195_n ) capacitor c=2.1838e-19 //x=9 \
 //y=2.26 //x2=9.7 //y2=0.71
cc_589 ( N_A_c_825_n N_noxref_11_M4_noxref_s ) capacitor c=0.00698471f \
 //x=9.035 //y=1.085 //x2=7.71 //y2=0.545
cc_590 ( N_A_c_832_n N_noxref_11_M4_noxref_s ) capacitor c=0.00316186f \
 //x=9.41 //y=1.585 //x2=7.71 //y2=0.545
cc_591 ( N_A_c_833_n N_noxref_11_M4_noxref_s ) capacitor c=0.0142835f \
 //x=9.565 //y=1.085 //x2=7.71 //y2=0.545
cc_592 ( N_YN_c_920_n N_noxref_9_c_1087_n ) capacitor c=0.00594456f //x=5.855 \
 //y=1.36 //x2=3.04 //y2=0.71
cc_593 ( N_YN_c_927_n N_noxref_9_c_1087_n ) capacitor c=0.002029f //x=2.755 \
 //y=1.36 //x2=3.04 //y2=0.71
cc_594 ( N_YN_M1_noxref_d N_noxref_9_c_1087_n ) capacitor c=0.0136817f \
 //x=2.45 //y=1.085 //x2=3.04 //y2=0.71
cc_595 ( N_YN_c_920_n N_noxref_9_M0_noxref_s ) capacitor c=0.024188f //x=5.855 \
 //y=1.36 //x2=1.05 //y2=0.545
cc_596 ( N_YN_c_927_n N_noxref_9_M0_noxref_s ) capacitor c=0.00821826f \
 //x=2.755 //y=1.36 //x2=1.05 //y2=0.545
cc_597 ( N_YN_M1_noxref_d N_noxref_9_M0_noxref_s ) capacitor c=0.0458734f \
 //x=2.45 //y=1.085 //x2=1.05 //y2=0.545
cc_598 ( N_YN_c_920_n N_noxref_10_c_1132_n ) capacitor c=0.0276954f //x=5.855 \
 //y=1.36 //x2=5.4 //y2=1.76
cc_599 ( N_YN_c_920_n N_noxref_10_c_1140_n ) capacitor c=0.00594456f //x=5.855 \
 //y=1.36 //x2=6.37 //y2=0.71
cc_600 ( N_YN_c_928_n N_noxref_10_c_1140_n ) capacitor c=0.00605524f //x=9.185 \
 //y=1.36 //x2=6.37 //y2=0.71
cc_601 ( N_YN_c_934_n N_noxref_10_c_1140_n ) capacitor c=0.00146466f //x=6.085 \
 //y=1.36 //x2=6.37 //y2=0.71
cc_602 ( N_YN_M3_noxref_d N_noxref_10_c_1140_n ) capacitor c=0.0130616f \
 //x=5.78 //y=1.085 //x2=6.37 //y2=0.71
cc_603 ( N_YN_c_920_n N_noxref_10_M2_noxref_s ) capacitor c=0.0511698f \
 //x=5.855 //y=1.36 //x2=4.38 //y2=0.545
cc_604 ( N_YN_c_928_n N_noxref_10_M2_noxref_s ) capacitor c=0.019112f \
 //x=9.185 //y=1.36 //x2=4.38 //y2=0.545
cc_605 ( N_YN_c_934_n N_noxref_10_M2_noxref_s ) capacitor c=0.00314418f \
 //x=6.085 //y=1.36 //x2=4.38 //y2=0.545
cc_606 ( N_YN_M3_noxref_d N_noxref_10_M2_noxref_s ) capacitor c=0.0444718f \
 //x=5.78 //y=1.085 //x2=4.38 //y2=0.545
cc_607 ( N_YN_c_1036_n N_noxref_11_c_1204_n ) capacitor c=2.73698e-19 \
 //x=9.385 //y=1.825 //x2=7.845 //y2=1.675
cc_608 ( N_YN_c_928_n N_noxref_11_c_1188_n ) capacitor c=0.0270688f //x=9.185 \
 //y=1.36 //x2=8.73 //y2=1.76
cc_609 ( N_YN_c_1036_n N_noxref_11_c_1194_n ) capacitor c=0.0195484f //x=9.385 \
 //y=1.825 //x2=8.815 //y2=1.675
cc_610 ( N_YN_c_928_n N_noxref_11_c_1195_n ) capacitor c=0.0069137f //x=9.185 \
 //y=1.36 //x2=9.7 //y2=0.71
cc_611 ( N_YN_c_936_n N_noxref_11_c_1195_n ) capacitor c=0.00458011f //x=9.655 \
 //y=1.825 //x2=9.7 //y2=0.71
cc_612 ( N_YN_M5_noxref_d N_noxref_11_c_1195_n ) capacitor c=0.0132979f \
 //x=9.11 //y=1.085 //x2=9.7 //y2=0.71
cc_613 ( N_YN_c_928_n N_noxref_11_M4_noxref_s ) capacitor c=0.0539315f \
 //x=9.185 //y=1.36 //x2=7.71 //y2=0.545
cc_614 ( N_YN_c_936_n N_noxref_11_M4_noxref_s ) capacitor c=0.0155576f \
 //x=9.655 //y=1.825 //x2=7.71 //y2=0.545
cc_615 ( N_YN_M5_noxref_d N_noxref_11_M4_noxref_s ) capacitor c=0.0438441f \
 //x=9.11 //y=1.085 //x2=7.71 //y2=0.545
cc_616 ( N_noxref_9_M0_noxref_s N_noxref_10_c_1153_n ) capacitor c=0.00108866f \
 //x=1.05 //y=0.545 //x2=4.515 //y2=1.675
cc_617 ( N_noxref_9_c_1090_n N_noxref_10_M2_noxref_s ) capacitor c=0.00108866f \
 //x=3.125 //y=0.795 //x2=4.38 //y2=0.545
cc_618 ( N_noxref_10_M2_noxref_s N_noxref_11_c_1204_n ) capacitor \
 c=0.00108866f //x=4.38 //y=0.545 //x2=7.845 //y2=1.675
cc_619 ( N_noxref_10_c_1143_n N_noxref_11_M4_noxref_s ) capacitor \
 c=0.00108866f //x=6.455 //y=0.795 //x2=7.71 //y2=0.545
