// File: VOTERN3X1.spi.VOTERN3X1.pxi
// Created: Sun Apr 12 08:38:00 2026
//
simulator lang=spectre
x_PM_VOTERN3X1\%B ( B B B B B B B B B B B N_B_c_43_p N_B_c_7_p N_B_c_54_p \
 N_B_c_3_p N_B_c_49_p N_B_c_41_p N_B_c_57_p N_B_c_8_p N_B_c_4_p \
 N_B_M0_noxref_g N_B_M2_noxref_g N_B_M6_noxref_g N_B_M7_noxref_g \
 N_B_M10_noxref_g N_B_M11_noxref_g N_B_c_79_p N_B_c_80_p N_B_c_82_p N_B_c_85_p \
 N_B_c_174_p N_B_c_175_p N_B_c_58_p N_B_c_59_p N_B_c_81_p N_B_c_83_p \
 N_B_c_25_p N_B_c_26_p N_B_c_28_p N_B_c_18_p N_B_c_183_p N_B_c_184_p \
 N_B_c_27_p N_B_c_29_p N_B_c_46_p N_B_c_12_p )  PM_VOTERN3X1\%B
x_PM_VOTERN3X1\%C ( C C C C C C C C C C N_C_c_245_n N_C_c_248_n N_C_c_281_p \
 N_C_c_295_p N_C_c_252_n N_C_c_282_p N_C_c_308_p N_C_c_254_n N_C_c_258_n \
 N_C_c_292_p N_C_c_285_p N_C_M3_noxref_g N_C_M4_noxref_g N_C_M12_noxref_g \
 N_C_M13_noxref_g N_C_M14_noxref_g N_C_M15_noxref_g N_C_c_264_n N_C_c_267_n \
 N_C_c_413_p N_C_c_269_n N_C_c_343_p N_C_c_344_p N_C_c_271_n N_C_c_273_n \
 N_C_c_274_n N_C_c_275_n N_C_c_276_n N_C_c_319_p N_C_c_320_p N_C_c_322_p \
 N_C_c_325_p N_C_c_425_p N_C_c_426_p N_C_c_297_p N_C_c_286_p N_C_c_321_p \
 N_C_c_323_p N_C_c_293_p )  PM_VOTERN3X1\%C
x_PM_VOTERN3X1\%A ( A A A A A A A A A A A N_A_c_480_n N_A_c_484_n N_A_c_487_n \
 N_A_c_545_n N_A_c_549_n N_A_c_550_n N_A_c_497_n N_A_c_554_n N_A_c_500_n \
 N_A_c_505_n N_A_c_509_n N_A_c_564_n N_A_c_567_n N_A_M1_noxref_g \
 N_A_M5_noxref_g N_A_M8_noxref_g N_A_M9_noxref_g N_A_M16_noxref_g \
 N_A_M17_noxref_g N_A_c_516_n N_A_c_519_n N_A_c_521_n N_A_c_680_p N_A_c_629_p \
 N_A_c_630_p N_A_c_524_n N_A_c_525_n N_A_c_574_n N_A_c_577_n N_A_c_579_n \
 N_A_c_601_p N_A_c_616_p N_A_c_582_n N_A_c_583_n N_A_c_584_n N_A_c_526_n \
 N_A_c_743_p N_A_c_529_n N_A_c_585_n N_A_c_625_p N_A_c_588_n )  PM_VOTERN3X1\%A
x_PM_VOTERN3X1\%YN ( YN YN YN YN YN YN YN YN N_YN_c_767_n N_YN_c_818_n \
 N_YN_c_828_n N_YN_c_830_n N_YN_c_831_n N_YN_c_832_n N_YN_c_833_n N_YN_c_768_n \
 N_YN_c_775_n N_YN_c_841_n N_YN_c_901_p N_YN_c_760_n N_YN_c_914_p N_YN_c_846_n \
 N_YN_c_779_n N_YN_c_789_n N_YN_c_851_n N_YN_M1_noxref_d N_YN_M3_noxref_d \
 N_YN_M5_noxref_d N_YN_M14_noxref_d N_YN_M16_noxref_d )  PM_VOTERN3X1\%YN
x_PM_VOTERN3X1\%VDD ( VDD N_VDD_c_967_n N_VDD_c_968_n N_VDD_c_1045_p \
 N_VDD_c_969_n N_VDD_c_970_n N_VDD_c_1047_p N_VDD_c_1012_n N_VDD_c_1013_n \
 N_VDD_c_1037_n N_VDD_c_971_n N_VDD_c_972_n N_VDD_c_975_n N_VDD_c_980_n \
 N_VDD_c_998_n N_VDD_c_983_n N_VDD_c_989_n N_VDD_M6_noxref_s N_VDD_M7_noxref_d \
 N_VDD_M9_noxref_d )  PM_VOTERN3X1\%VDD
x_PM_VOTERN3X1\%noxref_6 ( N_noxref_6_c_1157_n N_noxref_6_c_1159_n \
 N_noxref_6_c_1162_n N_noxref_6_c_1163_n N_noxref_6_c_1185_n \
 N_noxref_6_c_1169_n N_noxref_6_c_1173_n N_noxref_6_c_1174_n \
 N_noxref_6_c_1188_n N_noxref_6_c_1175_n N_noxref_6_c_1178_n \
 N_noxref_6_c_1179_n N_noxref_6_M6_noxref_d N_noxref_6_M8_noxref_d \
 N_noxref_6_M10_noxref_s N_noxref_6_M11_noxref_d N_noxref_6_M13_noxref_d )  \
 PM_VOTERN3X1\%noxref_6
x_PM_VOTERN3X1\%noxref_7 ( N_noxref_7_c_1322_n N_noxref_7_c_1335_n \
 N_noxref_7_c_1345_n N_noxref_7_c_1347_n N_noxref_7_c_1361_n \
 N_noxref_7_c_1323_n N_noxref_7_c_1349_n N_noxref_7_c_1350_n \
 N_noxref_7_c_1365_n N_noxref_7_c_1329_n N_noxref_7_c_1351_n \
 N_noxref_7_c_1354_n N_noxref_7_M10_noxref_d N_noxref_7_M12_noxref_d \
 N_noxref_7_M14_noxref_s N_noxref_7_M15_noxref_d N_noxref_7_M17_noxref_d )  \
 PM_VOTERN3X1\%noxref_7
x_PM_VOTERN3X1\%GND ( GND N_GND_c_1448_n N_GND_c_1450_n N_GND_c_1522_n \
 N_GND_c_1457_n N_GND_c_1491_n N_GND_c_1494_n N_GND_c_1523_n N_GND_c_1466_n \
 N_GND_c_1467_n N_GND_c_1473_n N_GND_c_1502_n N_GND_c_1474_n N_GND_c_1506_n \
 N_GND_M0_noxref_d N_GND_M2_noxref_d N_GND_M4_noxref_d )  PM_VOTERN3X1\%GND
x_PM_VOTERN3X1\%noxref_9 ( N_noxref_9_c_1652_n N_noxref_9_c_1656_n \
 N_noxref_9_c_1694_n N_noxref_9_c_1664_n N_noxref_9_c_1672_n \
 N_noxref_9_c_1704_n N_noxref_9_M0_noxref_s )  PM_VOTERN3X1\%noxref_9
x_PM_VOTERN3X1\%noxref_10 ( N_noxref_10_c_1717_n N_noxref_10_c_1718_n \
 N_noxref_10_c_1758_n N_noxref_10_c_1725_n N_noxref_10_c_1730_n \
 N_noxref_10_c_1768_n N_noxref_10_M2_noxref_s )  PM_VOTERN3X1\%noxref_10
x_PM_VOTERN3X1\%noxref_11 ( N_noxref_11_c_1783_n N_noxref_11_c_1787_n \
 N_noxref_11_c_1829_n N_noxref_11_c_1794_n N_noxref_11_c_1803_n \
 N_noxref_11_c_1836_n N_noxref_11_M4_noxref_s )  PM_VOTERN3X1\%noxref_11
cc_1 ( B C ) capacitor c=0.0454386f //x=4.93 //y=2.77 //x2=6.41 //y2=2.77
cc_2 ( B C ) capacitor c=0.00392254f //x=4.93 //y=4.62 //x2=6.41 //y2=2.77
cc_3 ( N_B_c_3_p C ) capacitor c=0.00381786f //x=4.935 //y=4.64 //x2=6.41 \
 //y2=2.77
cc_4 ( N_B_c_4_p C ) capacitor c=2.47556e-19 //x=4.93 //y=4.62 //x2=6.41 \
 //y2=2.77
cc_5 ( B C ) capacitor c=0.00213544f //x=4.93 //y=2.77 //x2=7.89 //y2=2.77
cc_6 ( B N_C_c_245_n ) capacitor c=5.52227e-19 //x=4.93 //y=2.77 //x2=6.41 \
 //y2=2.43
cc_7 ( N_B_c_7_p N_C_c_245_n ) capacitor c=0.0033801f //x=4.93 //y=2.385 \
 //x2=6.41 //y2=2.43
cc_8 ( N_B_c_8_p N_C_c_245_n ) capacitor c=5.86738e-19 //x=4.93 //y=2.26 \
 //x2=6.41 //y2=2.43
cc_9 ( B N_C_c_248_n ) capacitor c=8.44065e-19 //x=4.93 //y=4.62 //x2=6.41 \
 //y2=4.76
cc_10 ( N_B_c_3_p N_C_c_248_n ) capacitor c=0.00106101f //x=4.935 //y=4.64 \
 //x2=6.41 //y2=4.76
cc_11 ( N_B_c_4_p N_C_c_248_n ) capacitor c=0.00389513f //x=4.93 //y=4.62 \
 //x2=6.41 //y2=4.76
cc_12 ( N_B_c_12_p N_C_c_248_n ) capacitor c=5.58186e-19 //x=4.93 //y=4.885 \
 //x2=6.41 //y2=4.76
cc_13 ( B N_C_c_252_n ) capacitor c=8.70657e-19 //x=4.93 //y=2.77 //x2=6.575 \
 //y2=2.27
cc_14 ( N_B_c_7_p N_C_c_252_n ) capacitor c=0.00564826f //x=4.93 //y=2.385 \
 //x2=6.575 //y2=2.27
cc_15 ( B N_C_c_254_n ) capacitor c=3.10803e-19 //x=4.93 //y=2.77 //x2=6.41 \
 //y2=2.26
cc_16 ( N_B_c_7_p N_C_c_254_n ) capacitor c=0.00362942f //x=4.93 //y=2.385 \
 //x2=6.41 //y2=2.26
cc_17 ( N_B_c_8_p N_C_c_254_n ) capacitor c=3.19688e-19 //x=4.93 //y=2.26 \
 //x2=6.41 //y2=2.26
cc_18 ( N_B_c_18_p N_C_c_254_n ) capacitor c=2.35599e-19 //x=4.735 //y=2.095 \
 //x2=6.41 //y2=2.26
cc_19 ( B N_C_c_258_n ) capacitor c=5.34267e-19 //x=4.93 //y=4.62 //x2=6.41 \
 //y2=4.885
cc_20 ( N_B_c_4_p N_C_c_258_n ) capacitor c=8.5191e-19 //x=4.93 //y=4.62 \
 //x2=6.41 //y2=4.885
cc_21 ( N_B_c_12_p N_C_c_258_n ) capacitor c=2.35599e-19 //x=4.93 //y=4.885 \
 //x2=6.41 //y2=4.885
cc_22 ( N_B_M10_noxref_g N_C_M12_noxref_g ) capacitor c=0.00948424f //x=4.82 \
 //y=6.205 //x2=5.7 //y2=6.205
cc_23 ( N_B_M11_noxref_g N_C_M12_noxref_g ) capacitor c=0.0633522f //x=5.26 \
 //y=6.205 //x2=5.7 //y2=6.205
cc_24 ( N_B_M11_noxref_g N_C_M13_noxref_g ) capacitor c=0.00899012f //x=5.26 \
 //y=6.205 //x2=6.14 //y2=6.205
cc_25 ( N_B_c_25_p N_C_c_264_n ) capacitor c=4.86545e-19 //x=4.735 //y=1.045 \
 //x2=5.705 //y2=1.085
cc_26 ( N_B_c_26_p N_C_c_264_n ) capacitor c=0.00152104f //x=4.735 //y=1.39 \
 //x2=5.705 //y2=1.085
cc_27 ( N_B_c_27_p N_C_c_264_n ) capacitor c=0.0159151f //x=5.265 //y=1.045 \
 //x2=5.705 //y2=1.085
cc_28 ( N_B_c_28_p N_C_c_267_n ) capacitor c=0.00109982f //x=4.735 //y=1.7 \
 //x2=5.705 //y2=1.43
cc_29 ( N_B_c_29_p N_C_c_267_n ) capacitor c=0.0158526f //x=5.265 //y=1.39 \
 //x2=5.705 //y2=1.43
cc_30 ( N_B_c_4_p N_C_c_269_n ) capacitor c=0.00110488f //x=4.93 //y=4.62 \
 //x2=5.775 //y2=4.975
cc_31 ( N_B_c_12_p N_C_c_269_n ) capacitor c=0.0640858f //x=4.93 //y=4.885 \
 //x2=5.775 //y2=4.975
cc_32 ( N_B_c_4_p N_C_c_271_n ) capacitor c=2.35599e-19 //x=4.93 //y=4.62 \
 //x2=6.14 //y2=5.05
cc_33 ( N_B_c_12_p N_C_c_271_n ) capacitor c=5.35364e-19 //x=4.93 //y=4.885 \
 //x2=6.14 //y2=5.05
cc_34 ( N_B_c_27_p N_C_c_273_n ) capacitor c=0.00124821f //x=5.265 //y=1.045 \
 //x2=6.235 //y2=1.085
cc_35 ( N_B_c_29_p N_C_c_274_n ) capacitor c=0.00150765f //x=5.265 //y=1.39 \
 //x2=6.235 //y2=1.43
cc_36 ( N_B_c_29_p N_C_c_275_n ) capacitor c=4.38654e-19 //x=5.265 //y=1.39 \
 //x2=6.235 //y2=1.74
cc_37 ( N_B_c_8_p N_C_c_276_n ) capacitor c=2.35599e-19 //x=4.93 //y=2.26 \
 //x2=6.235 //y2=2.095
cc_38 ( N_B_c_18_p N_C_c_276_n ) capacitor c=4.61972e-19 //x=4.735 //y=2.095 \
 //x2=6.235 //y2=2.095
cc_39 ( B A ) capacitor c=0.0532443f //x=1.23 //y=2.77 //x2=2.34 //y2=2.77
cc_40 ( B A ) capacitor c=0.0220468f //x=4.93 //y=2.77 //x2=2.34 //y2=2.77
cc_41 ( N_B_c_41_p A ) capacitor c=4.16726e-19 //x=1.23 //y=2.26 //x2=2.34 \
 //y2=2.77
cc_42 ( B A ) capacitor c=0.00334158f //x=1.23 //y=2.77 //x2=2.34 //y2=4.25
cc_43 ( N_B_c_43_p N_A_c_480_n ) capacitor c=0.0110499f //x=1.23 //y=2.375 \
 //x2=2.34 //y2=2.375
cc_44 ( N_B_c_7_p N_A_c_480_n ) capacitor c=0.00273775f //x=4.93 //y=2.385 \
 //x2=2.34 //y2=2.375
cc_45 ( N_B_c_41_p N_A_c_480_n ) capacitor c=0.00353903f //x=1.23 //y=2.26 \
 //x2=2.34 //y2=2.375
cc_46 ( N_B_c_46_p N_A_c_480_n ) capacitor c=0.00140055f //x=1.23 //y=2.26 \
 //x2=2.34 //y2=2.375
cc_47 ( B N_A_c_484_n ) capacitor c=0.00785479f //x=1.23 //y=2.77 //x2=2.34 \
 //y2=4.365
cc_48 ( B N_A_c_484_n ) capacitor c=0.00149249f //x=4.93 //y=2.77 //x2=2.34 \
 //y2=4.365
cc_49 ( N_B_c_49_p N_A_c_484_n ) capacitor c=0.00452722f //x=4.775 //y=4.64 \
 //x2=2.34 //y2=4.365
cc_50 ( B N_A_c_487_n ) capacitor c=0.00241857f //x=1.23 //y=2.77 //x2=2.34 \
 //y2=4.71
cc_51 ( B N_A_c_487_n ) capacitor c=0.00106529f //x=4.93 //y=2.77 //x2=2.34 \
 //y2=4.71
cc_52 ( B N_A_c_487_n ) capacitor c=0.0102434f //x=1.23 //y=4.62 //x2=2.34 \
 //y2=4.71
cc_53 ( B N_A_c_487_n ) capacitor c=0.00146299f //x=4.93 //y=4.62 //x2=2.34 \
 //y2=4.71
cc_54 ( N_B_c_54_p N_A_c_487_n ) capacitor c=0.00282641f //x=1.395 //y=4.62 \
 //x2=2.34 //y2=4.71
cc_55 ( N_B_c_3_p N_A_c_487_n ) capacitor c=0.00206738f //x=4.935 //y=4.64 \
 //x2=2.34 //y2=4.71
cc_56 ( N_B_c_49_p N_A_c_487_n ) capacitor c=0.0312701f //x=4.775 //y=4.64 \
 //x2=2.34 //y2=4.71
cc_57 ( N_B_c_57_p N_A_c_487_n ) capacitor c=0.00868816f //x=1.23 //y=4.62 \
 //x2=2.34 //y2=4.71
cc_58 ( N_B_c_58_p N_A_c_487_n ) capacitor c=0.00144251f //x=1.865 //y=4.975 \
 //x2=2.34 //y2=4.71
cc_59 ( N_B_c_59_p N_A_c_487_n ) capacitor c=0.00105471f //x=1.575 //y=4.975 \
 //x2=2.34 //y2=4.71
cc_60 ( B N_A_c_497_n ) capacitor c=0.00529413f //x=1.23 //y=2.77 //x2=2.5 \
 //y2=4.205
cc_61 ( B N_A_c_497_n ) capacitor c=0.00110824f //x=4.93 //y=2.77 //x2=2.5 \
 //y2=4.205
cc_62 ( N_B_c_49_p N_A_c_497_n ) capacitor c=0.0345719f //x=4.775 //y=4.64 \
 //x2=2.5 //y2=4.205
cc_63 ( B N_A_c_500_n ) capacitor c=0.0312902f //x=4.93 //y=2.77 //x2=8.855 \
 //y2=4.21
cc_64 ( B N_A_c_500_n ) capacitor c=0.0102464f //x=4.93 //y=4.62 //x2=8.855 \
 //y2=4.21
cc_65 ( N_B_c_7_p N_A_c_500_n ) capacitor c=0.00179095f //x=4.93 //y=2.385 \
 //x2=8.855 //y2=4.21
cc_66 ( N_B_c_3_p N_A_c_500_n ) capacitor c=0.0375626f //x=4.935 //y=4.64 \
 //x2=8.855 //y2=4.21
cc_67 ( N_B_c_49_p N_A_c_500_n ) capacitor c=0.215316f //x=4.775 //y=4.64 \
 //x2=8.855 //y2=4.21
cc_68 ( B N_A_c_505_n ) capacitor c=4.16726e-19 //x=1.23 //y=2.77 //x2=2.34 \
 //y2=2.26
cc_69 ( N_B_c_43_p N_A_c_505_n ) capacitor c=0.00353903f //x=1.23 //y=2.375 \
 //x2=2.34 //y2=2.26
cc_70 ( N_B_c_41_p N_A_c_505_n ) capacitor c=0.0012665f //x=1.23 //y=2.26 \
 //x2=2.34 //y2=2.26
cc_71 ( N_B_c_46_p N_A_c_505_n ) capacitor c=0.00163906f //x=1.23 //y=2.26 \
 //x2=2.34 //y2=2.26
cc_72 ( B N_A_c_509_n ) capacitor c=0.00154972f //x=1.23 //y=4.62 //x2=2.38 \
 //y2=4.885
cc_73 ( N_B_c_57_p N_A_c_509_n ) capacitor c=0.00133991f //x=1.23 //y=4.62 \
 //x2=2.38 //y2=4.885
cc_74 ( N_B_c_58_p N_A_c_509_n ) capacitor c=0.00122675f //x=1.865 //y=4.975 \
 //x2=2.38 //y2=4.885
cc_75 ( N_B_c_59_p N_A_c_509_n ) capacitor c=0.00114302f //x=1.575 //y=4.975 \
 //x2=2.38 //y2=4.885
cc_76 ( N_B_M6_noxref_g N_A_M8_noxref_g ) capacitor c=0.0106808f //x=1.5 \
 //y=6.205 //x2=2.38 //y2=6.205
cc_77 ( N_B_M7_noxref_g N_A_M8_noxref_g ) capacitor c=0.108153f //x=1.94 \
 //y=6.205 //x2=2.38 //y2=6.205
cc_78 ( N_B_M7_noxref_g N_A_M9_noxref_g ) capacitor c=0.0103194f //x=1.94 \
 //y=6.205 //x2=2.82 //y2=6.205
cc_79 ( N_B_c_79_p N_A_c_516_n ) capacitor c=4.86545e-19 //x=1.405 //y=1.045 \
 //x2=2.375 //y2=1.085
cc_80 ( N_B_c_80_p N_A_c_516_n ) capacitor c=0.00152405f //x=1.405 //y=1.39 \
 //x2=2.375 //y2=1.085
cc_81 ( N_B_c_81_p N_A_c_516_n ) capacitor c=0.0151475f //x=1.935 //y=1.045 \
 //x2=2.375 //y2=1.085
cc_82 ( N_B_c_82_p N_A_c_519_n ) capacitor c=0.00109982f //x=1.405 //y=1.7 \
 //x2=2.375 //y2=1.43
cc_83 ( N_B_c_83_p N_A_c_519_n ) capacitor c=0.0111064f //x=1.935 //y=1.39 \
 //x2=2.375 //y2=1.43
cc_84 ( N_B_c_82_p N_A_c_521_n ) capacitor c=0.00179029f //x=1.405 //y=1.7 \
 //x2=2.375 //y2=1.74
cc_85 ( N_B_c_85_p N_A_c_521_n ) capacitor c=0.00662747f //x=1.405 //y=2.095 \
 //x2=2.375 //y2=1.74
cc_86 ( N_B_c_83_p N_A_c_521_n ) capacitor c=0.00862358f //x=1.935 //y=1.39 \
 //x2=2.375 //y2=1.74
cc_87 ( N_B_c_81_p N_A_c_524_n ) capacitor c=0.00124846f //x=1.935 //y=1.045 \
 //x2=2.905 //y2=1.085
cc_88 ( N_B_c_83_p N_A_c_525_n ) capacitor c=0.00161183f //x=1.935 //y=1.39 \
 //x2=2.905 //y2=1.43
cc_89 ( N_B_c_43_p N_A_c_526_n ) capacitor c=0.00130136f //x=1.23 //y=2.375 \
 //x2=2.34 //y2=2.26
cc_90 ( N_B_c_41_p N_A_c_526_n ) capacitor c=0.00191372f //x=1.23 //y=2.26 \
 //x2=2.34 //y2=2.26
cc_91 ( N_B_c_46_p N_A_c_526_n ) capacitor c=0.00949697f //x=1.23 //y=2.26 \
 //x2=2.34 //y2=2.26
cc_92 ( B N_A_c_529_n ) capacitor c=2.84639e-19 //x=1.23 //y=4.62 //x2=2.38 \
 //y2=4.885
cc_93 ( N_B_c_57_p N_A_c_529_n ) capacitor c=0.00197201f //x=1.23 //y=4.62 \
 //x2=2.38 //y2=4.885
cc_94 ( N_B_c_58_p N_A_c_529_n ) capacitor c=0.0203213f //x=1.865 //y=4.975 \
 //x2=2.38 //y2=4.885
cc_95 ( N_B_c_59_p N_A_c_529_n ) capacitor c=0.00427779f //x=1.575 //y=4.975 \
 //x2=2.38 //y2=4.885
cc_96 ( N_B_c_7_p N_YN_c_760_n ) capacitor c=0.0108541f //x=4.93 //y=2.385 \
 //x2=5.84 //y2=1.405
cc_97 ( N_B_c_26_p N_YN_c_760_n ) capacitor c=0.00242807f //x=4.735 //y=1.39 \
 //x2=5.84 //y2=1.405
cc_98 ( N_B_c_28_p N_YN_c_760_n ) capacitor c=0.0026623f //x=4.735 //y=1.7 \
 //x2=5.84 //y2=1.405
cc_99 ( N_B_c_29_p N_YN_c_760_n ) capacitor c=0.00413582f //x=5.265 //y=1.39 \
 //x2=5.84 //y2=1.405
cc_100 ( N_B_M6_noxref_g N_VDD_c_967_n ) capacitor c=0.00374549f //x=1.5 \
 //y=6.205 //x2=1.28 //y2=7.035
cc_101 ( N_B_M6_noxref_g N_VDD_c_968_n ) capacitor c=0.00441594f //x=1.5 \
 //y=6.205 //x2=1.28 //y2=7.41
cc_102 ( N_B_M7_noxref_g N_VDD_c_969_n ) capacitor c=0.00123273f //x=1.94 \
 //y=6.205 //x2=2.16 //y2=7.035
cc_103 ( N_B_M7_noxref_g N_VDD_c_970_n ) capacitor c=0.00137209f //x=1.94 \
 //y=6.205 //x2=2.16 //y2=7.41
cc_104 ( B N_VDD_c_971_n ) capacitor c=2.89886e-19 //x=1.23 //y=4.62 //x2=1.23 \
 //y2=7.58
cc_105 ( B N_VDD_c_972_n ) capacitor c=5.35585e-19 //x=1.23 //y=4.62 //x2=3.65 \
 //y2=7.585
cc_106 ( N_B_M6_noxref_g N_VDD_c_972_n ) capacitor c=0.00778439f //x=1.5 \
 //y=6.205 //x2=3.65 //y2=7.585
cc_107 ( N_B_M7_noxref_g N_VDD_c_972_n ) capacitor c=0.00778439f //x=1.94 \
 //y=6.205 //x2=3.65 //y2=7.585
cc_108 ( B N_VDD_c_975_n ) capacitor c=0.00519253f //x=1.23 //y=2.77 //x2=1.23 \
 //y2=7.58
cc_109 ( B N_VDD_c_975_n ) capacitor c=0.008788f //x=1.23 //y=4.62 //x2=1.23 \
 //y2=7.58
cc_110 ( N_B_c_57_p N_VDD_c_975_n ) capacitor c=0.0174085f //x=1.23 //y=4.62 \
 //x2=1.23 //y2=7.58
cc_111 ( N_B_M6_noxref_g N_VDD_c_975_n ) capacitor c=0.0191171f //x=1.5 \
 //y=6.205 //x2=1.23 //y2=7.58
cc_112 ( N_B_c_59_p N_VDD_c_975_n ) capacitor c=0.0079396f //x=1.575 //y=4.975 \
 //x2=1.23 //y2=7.58
cc_113 ( N_B_c_4_p N_VDD_c_980_n ) capacitor c=2.11259e-19 //x=4.93 //y=4.62 \
 //x2=6.98 //y2=7.585
cc_114 ( N_B_M10_noxref_g N_VDD_c_980_n ) capacitor c=0.00763665f //x=4.82 \
 //y=6.205 //x2=6.98 //y2=7.585
cc_115 ( N_B_M11_noxref_g N_VDD_c_980_n ) capacitor c=0.00782837f //x=5.26 \
 //y=6.205 //x2=6.98 //y2=7.585
cc_116 ( B N_VDD_c_983_n ) capacitor c=0.00285166f //x=4.93 //y=2.77 //x2=3.82 \
 //y2=7.585
cc_117 ( B N_VDD_c_983_n ) capacitor c=0.00331684f //x=4.93 //y=4.62 //x2=3.82 \
 //y2=7.585
cc_118 ( N_B_c_49_p N_VDD_c_983_n ) capacitor c=0.0167947f //x=4.775 //y=4.64 \
 //x2=3.82 //y2=7.585
cc_119 ( N_B_c_57_p N_VDD_c_983_n ) capacitor c=0.00117386f //x=1.23 //y=4.62 \
 //x2=3.82 //y2=7.585
cc_120 ( N_B_c_4_p N_VDD_c_983_n ) capacitor c=0.0104424f //x=4.93 //y=4.62 \
 //x2=3.82 //y2=7.585
cc_121 ( N_B_c_12_p N_VDD_c_983_n ) capacitor c=0.0137051f //x=4.93 //y=4.885 \
 //x2=3.82 //y2=7.585
cc_122 ( N_B_c_4_p N_VDD_c_989_n ) capacitor c=0.00221916f //x=4.93 //y=4.62 \
 //x2=7.15 //y2=7.585
cc_123 ( B N_VDD_M6_noxref_s ) capacitor c=0.0166208f //x=1.23 //y=4.62 \
 //x2=1.145 //y2=5.205
cc_124 ( N_B_c_54_p N_VDD_M6_noxref_s ) capacitor c=0.00180521f //x=1.395 \
 //y=4.62 //x2=1.145 //y2=5.205
cc_125 ( N_B_c_57_p N_VDD_M6_noxref_s ) capacitor c=0.0122195f //x=1.23 \
 //y=4.62 //x2=1.145 //y2=5.205
cc_126 ( N_B_M6_noxref_g N_VDD_M6_noxref_s ) capacitor c=0.0510401f //x=1.5 \
 //y=6.205 //x2=1.145 //y2=5.205
cc_127 ( N_B_c_59_p N_VDD_M6_noxref_s ) capacitor c=0.00621646f //x=1.575 \
 //y=4.975 //x2=1.145 //y2=5.205
cc_128 ( N_B_M7_noxref_g N_VDD_M7_noxref_d ) capacitor c=0.0127979f //x=1.94 \
 //y=6.205 //x2=2.015 //y2=5.205
cc_129 ( N_B_c_49_p N_noxref_6_c_1157_n ) capacitor c=0.00314988f //x=4.775 \
 //y=4.64 //x2=2.485 //y2=5.39
cc_130 ( N_B_M7_noxref_g N_noxref_6_c_1157_n ) capacitor c=0.00962216f \
 //x=1.94 //y=6.205 //x2=2.485 //y2=5.39
cc_131 ( B N_noxref_6_c_1159_n ) capacitor c=0.00378061f //x=4.93 //y=4.62 \
 //x2=4.485 //y2=5.39
cc_132 ( N_B_c_49_p N_noxref_6_c_1159_n ) capacitor c=0.0894443f //x=4.775 \
 //y=4.64 //x2=4.485 //y2=5.39
cc_133 ( N_B_M10_noxref_g N_noxref_6_c_1159_n ) capacitor c=0.00366801f \
 //x=4.82 //y=6.205 //x2=4.485 //y2=5.39
cc_134 ( N_B_c_49_p N_noxref_6_c_1162_n ) capacitor c=0.00878121f //x=4.775 \
 //y=4.64 //x2=2.715 //y2=5.39
cc_135 ( B N_noxref_6_c_1163_n ) capacitor c=8.16607e-19 //x=4.93 //y=4.62 \
 //x2=5.36 //y2=7.09
cc_136 ( N_B_c_3_p N_noxref_6_c_1163_n ) capacitor c=0.00566393f //x=4.935 \
 //y=4.64 //x2=5.36 //y2=7.09
cc_137 ( N_B_c_49_p N_noxref_6_c_1163_n ) capacitor c=5.18143e-19 //x=4.775 \
 //y=4.64 //x2=5.36 //y2=7.09
cc_138 ( N_B_c_4_p N_noxref_6_c_1163_n ) capacitor c=0.00134225f //x=4.93 \
 //y=4.62 //x2=5.36 //y2=7.09
cc_139 ( N_B_M10_noxref_g N_noxref_6_c_1163_n ) capacitor c=0.00985075f \
 //x=4.82 //y=6.205 //x2=5.36 //y2=7.09
cc_140 ( N_B_M11_noxref_g N_noxref_6_c_1163_n ) capacitor c=0.00814026f \
 //x=5.26 //y=6.205 //x2=5.36 //y2=7.09
cc_141 ( N_B_c_49_p N_noxref_6_c_1169_n ) capacitor c=0.0271892f //x=4.775 \
 //y=4.64 //x2=1.722 //y2=5.39
cc_142 ( N_B_M6_noxref_g N_noxref_6_c_1169_n ) capacitor c=0.0018075f //x=1.5 \
 //y=6.205 //x2=1.722 //y2=5.39
cc_143 ( N_B_M7_noxref_g N_noxref_6_c_1169_n ) capacitor c=0.00310294f \
 //x=1.94 //y=6.205 //x2=1.722 //y2=5.39
cc_144 ( N_B_c_58_p N_noxref_6_c_1169_n ) capacitor c=0.00218288f //x=1.865 \
 //y=4.975 //x2=1.722 //y2=5.39
cc_145 ( N_B_M10_noxref_g N_noxref_6_c_1173_n ) capacitor c=0.00395967f \
 //x=4.82 //y=6.205 //x2=4.6 //y2=6.92
cc_146 ( N_B_M11_noxref_g N_noxref_6_c_1174_n ) capacitor c=0.00179771f \
 //x=5.26 //y=6.205 //x2=5.477 //y2=7.09
cc_147 ( N_B_M6_noxref_g N_noxref_6_c_1175_n ) capacitor c=0.0161645f //x=1.5 \
 //y=6.205 //x2=1.72 //y2=5.56
cc_148 ( N_B_M7_noxref_g N_noxref_6_c_1175_n ) capacitor c=0.0177598f //x=1.94 \
 //y=6.205 //x2=1.72 //y2=5.56
cc_149 ( N_B_c_58_p N_noxref_6_c_1175_n ) capacitor c=0.00293723f //x=1.865 \
 //y=4.975 //x2=1.72 //y2=5.56
cc_150 ( N_B_c_49_p N_noxref_6_c_1178_n ) capacitor c=0.00371683f //x=4.775 \
 //y=4.64 //x2=2.6 //y2=5.39
cc_151 ( B N_noxref_6_c_1179_n ) capacitor c=8.93089e-19 //x=4.93 //y=4.62 \
 //x2=4.6 //y2=5.39
cc_152 ( N_B_c_49_p N_noxref_6_c_1179_n ) capacitor c=0.00277723f //x=4.775 \
 //y=4.64 //x2=4.6 //y2=5.39
cc_153 ( N_B_M10_noxref_g N_noxref_6_c_1179_n ) capacitor c=0.0503042f \
 //x=4.82 //y=6.205 //x2=4.6 //y2=5.39
cc_154 ( N_B_M6_noxref_g N_noxref_6_M6_noxref_d ) capacitor c=0.00124621f \
 //x=1.5 //y=6.205 //x2=1.575 //y2=5.205
cc_155 ( N_B_M7_noxref_g N_noxref_6_M6_noxref_d ) capacitor c=0.00125665f \
 //x=1.94 //y=6.205 //x2=1.575 //y2=5.205
cc_156 ( N_B_M11_noxref_g N_noxref_6_M11_noxref_d ) capacitor c=0.0142133f \
 //x=5.26 //y=6.205 //x2=5.335 //y2=5.205
cc_157 ( N_B_M11_noxref_g N_noxref_7_c_1322_n ) capacitor c=0.00969072f \
 //x=5.26 //y=6.205 //x2=5.805 //y2=5.39
cc_158 ( B N_noxref_7_c_1323_n ) capacitor c=0.00879697f //x=4.93 //y=4.62 \
 //x2=5.04 //y2=5.39
cc_159 ( N_B_c_3_p N_noxref_7_c_1323_n ) capacitor c=0.00708476f //x=4.935 \
 //y=4.64 //x2=5.04 //y2=5.39
cc_160 ( N_B_c_4_p N_noxref_7_c_1323_n ) capacitor c=0.00212816f //x=4.93 \
 //y=4.62 //x2=5.04 //y2=5.39
cc_161 ( N_B_M10_noxref_g N_noxref_7_c_1323_n ) capacitor c=0.00349804f \
 //x=4.82 //y=6.205 //x2=5.04 //y2=5.39
cc_162 ( N_B_M11_noxref_g N_noxref_7_c_1323_n ) capacitor c=0.00297228f \
 //x=5.26 //y=6.205 //x2=5.04 //y2=5.39
cc_163 ( N_B_c_12_p N_noxref_7_c_1323_n ) capacitor c=0.00149603f //x=4.93 \
 //y=4.885 //x2=5.04 //y2=5.39
cc_164 ( B N_noxref_7_c_1329_n ) capacitor c=0.0012994f //x=4.93 //y=4.62 \
 //x2=5.04 //y2=5.56
cc_165 ( N_B_c_4_p N_noxref_7_c_1329_n ) capacitor c=0.00447469f //x=4.93 \
 //y=4.62 //x2=5.04 //y2=5.56
cc_166 ( N_B_M10_noxref_g N_noxref_7_c_1329_n ) capacitor c=0.0120591f \
 //x=4.82 //y=6.205 //x2=5.04 //y2=5.56
cc_167 ( N_B_M11_noxref_g N_noxref_7_c_1329_n ) capacitor c=0.0142133f \
 //x=5.26 //y=6.205 //x2=5.04 //y2=5.56
cc_168 ( N_B_c_12_p N_noxref_7_c_1329_n ) capacitor c=0.00417478f //x=4.93 \
 //y=4.885 //x2=5.04 //y2=5.56
cc_169 ( B N_GND_c_1448_n ) capacitor c=3.48111e-19 //x=1.23 //y=4.62 \
 //x2=1.585 //y2=0.175
cc_170 ( N_B_c_43_p N_GND_c_1448_n ) capacitor c=0.00181546f //x=1.23 \
 //y=2.375 //x2=1.585 //y2=0.175
cc_171 ( N_B_c_79_p N_GND_c_1450_n ) capacitor c=0.00166913f //x=1.405 \
 //y=1.045 //x2=1.67 //y2=1.015
cc_172 ( N_B_c_80_p N_GND_c_1450_n ) capacitor c=0.00373916f //x=1.405 \
 //y=1.39 //x2=1.67 //y2=1.015
cc_173 ( N_B_c_82_p N_GND_c_1450_n ) capacitor c=3.46977e-19 //x=1.405 //y=1.7 \
 //x2=1.67 //y2=1.015
cc_174 ( N_B_c_174_p N_GND_c_1450_n ) capacitor c=0.00924177f //x=1.78 \
 //y=0.89 //x2=1.67 //y2=1.015
cc_175 ( N_B_c_175_p N_GND_c_1450_n ) capacitor c=7.91264e-19 //x=1.78 \
 //y=1.545 //x2=1.67 //y2=1.015
cc_176 ( N_B_c_81_p N_GND_c_1450_n ) capacitor c=0.00205853f //x=1.935 \
 //y=1.045 //x2=1.67 //y2=1.015
cc_177 ( N_B_c_83_p N_GND_c_1450_n ) capacitor c=0.00402706f //x=1.935 \
 //y=1.39 //x2=1.67 //y2=1.015
cc_178 ( N_B_c_7_p N_GND_c_1457_n ) capacitor c=0.00456909f //x=4.93 //y=2.385 \
 //x2=5 //y2=1.015
cc_179 ( N_B_c_8_p N_GND_c_1457_n ) capacitor c=4.35087e-19 //x=4.93 //y=2.26 \
 //x2=5 //y2=1.015
cc_180 ( N_B_c_25_p N_GND_c_1457_n ) capacitor c=0.00174776f //x=4.735 \
 //y=1.045 //x2=5 //y2=1.015
cc_181 ( N_B_c_26_p N_GND_c_1457_n ) capacitor c=0.00349898f //x=4.735 \
 //y=1.39 //x2=5 //y2=1.015
cc_182 ( N_B_c_28_p N_GND_c_1457_n ) capacitor c=2.39384e-19 //x=4.735 //y=1.7 \
 //x2=5 //y2=1.015
cc_183 ( N_B_c_183_p N_GND_c_1457_n ) capacitor c=0.00936969f //x=5.11 \
 //y=0.89 //x2=5 //y2=1.015
cc_184 ( N_B_c_184_p N_GND_c_1457_n ) capacitor c=0.00220551f //x=5.11 \
 //y=1.545 //x2=5 //y2=1.015
cc_185 ( N_B_c_27_p N_GND_c_1457_n ) capacitor c=0.00190243f //x=5.265 \
 //y=1.045 //x2=5 //y2=1.015
cc_186 ( N_B_c_29_p N_GND_c_1457_n ) capacitor c=0.00369501f //x=5.265 \
 //y=1.39 //x2=5 //y2=1.015
cc_187 ( N_B_c_79_p N_GND_c_1466_n ) capacitor c=0.00696333f //x=1.405 \
 //y=1.045 //x2=3.65 //y2=0.175
cc_188 ( B N_GND_c_1467_n ) capacitor c=0.0172054f //x=1.23 //y=2.77 //x2=1.23 \
 //y2=0.18
cc_189 ( N_B_c_43_p N_GND_c_1467_n ) capacitor c=0.00793669f //x=1.23 \
 //y=2.375 //x2=1.23 //y2=0.18
cc_190 ( N_B_c_41_p N_GND_c_1467_n ) capacitor c=0.00791319f //x=1.23 //y=2.26 \
 //x2=1.23 //y2=0.18
cc_191 ( N_B_c_82_p N_GND_c_1467_n ) capacitor c=0.00264481f //x=1.405 //y=1.7 \
 //x2=1.23 //y2=0.18
cc_192 ( N_B_c_85_p N_GND_c_1467_n ) capacitor c=0.00440632f //x=1.405 \
 //y=2.095 //x2=1.23 //y2=0.18
cc_193 ( N_B_c_46_p N_GND_c_1467_n ) capacitor c=0.00706746f //x=1.23 //y=2.26 \
 //x2=1.23 //y2=0.18
cc_194 ( N_B_c_25_p N_GND_c_1473_n ) capacitor c=0.00688488f //x=4.735 \
 //y=1.045 //x2=6.98 //y2=0.175
cc_195 ( B N_GND_c_1474_n ) capacitor c=0.00917348f //x=4.93 //y=2.77 \
 //x2=3.82 //y2=0.175
cc_196 ( N_B_c_7_p N_GND_c_1474_n ) capacitor c=0.00537602f //x=4.93 //y=2.385 \
 //x2=3.82 //y2=0.175
cc_197 ( N_B_c_8_p N_GND_c_1474_n ) capacitor c=0.00369534f //x=4.93 //y=2.26 \
 //x2=3.82 //y2=0.175
cc_198 ( N_B_c_18_p N_GND_c_1474_n ) capacitor c=0.00956283f //x=4.735 \
 //y=2.095 //x2=3.82 //y2=0.175
cc_199 ( N_B_c_79_p N_GND_M0_noxref_d ) capacitor c=0.00192399f //x=1.405 \
 //y=1.045 //x2=1.48 //y2=1.045
cc_200 ( N_B_c_80_p N_GND_M0_noxref_d ) capacitor c=0.00210798f //x=1.405 \
 //y=1.39 //x2=1.48 //y2=1.045
cc_201 ( N_B_c_174_p N_GND_M0_noxref_d ) capacitor c=0.00472259f //x=1.78 \
 //y=0.89 //x2=1.48 //y2=1.045
cc_202 ( N_B_c_175_p N_GND_M0_noxref_d ) capacitor c=0.00166857f //x=1.78 \
 //y=1.545 //x2=1.48 //y2=1.045
cc_203 ( N_B_c_81_p N_GND_M0_noxref_d ) capacitor c=0.00230174f //x=1.935 \
 //y=1.045 //x2=1.48 //y2=1.045
cc_204 ( N_B_c_83_p N_GND_M0_noxref_d ) capacitor c=0.00210798f //x=1.935 \
 //y=1.39 //x2=1.48 //y2=1.045
cc_205 ( N_B_c_7_p N_GND_M2_noxref_d ) capacitor c=4.20217e-19 //x=4.93 \
 //y=2.385 //x2=4.81 //y2=1.045
cc_206 ( N_B_c_25_p N_GND_M2_noxref_d ) capacitor c=0.00192399f //x=4.735 \
 //y=1.045 //x2=4.81 //y2=1.045
cc_207 ( N_B_c_26_p N_GND_M2_noxref_d ) capacitor c=0.00228784f //x=4.735 \
 //y=1.39 //x2=4.81 //y2=1.045
cc_208 ( N_B_c_183_p N_GND_M2_noxref_d ) capacitor c=0.0047434f //x=5.11 \
 //y=0.89 //x2=4.81 //y2=1.045
cc_209 ( N_B_c_184_p N_GND_M2_noxref_d ) capacitor c=0.00172481f //x=5.11 \
 //y=1.545 //x2=4.81 //y2=1.045
cc_210 ( N_B_c_27_p N_GND_M2_noxref_d ) capacitor c=0.00230174f //x=5.265 \
 //y=1.045 //x2=4.81 //y2=1.045
cc_211 ( N_B_c_29_p N_GND_M2_noxref_d ) capacitor c=0.00228784f //x=5.265 \
 //y=1.39 //x2=4.81 //y2=1.045
cc_212 ( N_B_c_43_p N_noxref_9_c_1652_n ) capacitor c=0.0033606f //x=1.23 \
 //y=2.375 //x2=1.185 //y2=1.675
cc_213 ( N_B_c_41_p N_noxref_9_c_1652_n ) capacitor c=0.0101841f //x=1.23 \
 //y=2.26 //x2=1.185 //y2=1.675
cc_214 ( N_B_c_85_p N_noxref_9_c_1652_n ) capacitor c=0.0034165f //x=1.405 \
 //y=2.095 //x2=1.185 //y2=1.675
cc_215 ( N_B_c_46_p N_noxref_9_c_1652_n ) capacitor c=0.00545516f //x=1.23 \
 //y=2.26 //x2=1.185 //y2=1.675
cc_216 ( B N_noxref_9_c_1656_n ) capacitor c=0.00272432f //x=1.23 //y=4.62 \
 //x2=2.07 //y2=1.76
cc_217 ( N_B_c_43_p N_noxref_9_c_1656_n ) capacitor c=0.00202154f //x=1.23 \
 //y=2.375 //x2=2.07 //y2=1.76
cc_218 ( N_B_c_41_p N_noxref_9_c_1656_n ) capacitor c=0.00302338f //x=1.23 \
 //y=2.26 //x2=2.07 //y2=1.76
cc_219 ( N_B_c_82_p N_noxref_9_c_1656_n ) capacitor c=0.00720513f //x=1.405 \
 //y=1.7 //x2=2.07 //y2=1.76
cc_220 ( N_B_c_85_p N_noxref_9_c_1656_n ) capacitor c=0.0151009f //x=1.405 \
 //y=2.095 //x2=2.07 //y2=1.76
cc_221 ( N_B_c_175_p N_noxref_9_c_1656_n ) capacitor c=0.0094838f //x=1.78 \
 //y=1.545 //x2=2.07 //y2=1.76
cc_222 ( N_B_c_83_p N_noxref_9_c_1656_n ) capacitor c=0.00399755f //x=1.935 \
 //y=1.39 //x2=2.07 //y2=1.76
cc_223 ( N_B_c_46_p N_noxref_9_c_1656_n ) capacitor c=0.00168953f //x=1.23 \
 //y=2.26 //x2=2.07 //y2=1.76
cc_224 ( N_B_c_85_p N_noxref_9_c_1664_n ) capacitor c=6.71402e-19 //x=1.405 \
 //y=2.095 //x2=2.155 //y2=1.675
cc_225 ( N_B_c_79_p N_noxref_9_M0_noxref_s ) capacitor c=0.030618f //x=1.405 \
 //y=1.045 //x2=1.05 //y2=0.545
cc_226 ( N_B_c_82_p N_noxref_9_M0_noxref_s ) capacitor c=0.00110192f //x=1.405 \
 //y=1.7 //x2=1.05 //y2=0.545
cc_227 ( N_B_c_81_p N_noxref_9_M0_noxref_s ) capacitor c=0.0125442f //x=1.935 \
 //y=1.045 //x2=1.05 //y2=0.545
cc_228 ( N_B_c_18_p N_noxref_10_c_1717_n ) capacitor c=0.0034165f //x=4.735 \
 //y=2.095 //x2=4.515 //y2=1.675
cc_229 ( B N_noxref_10_c_1718_n ) capacitor c=0.00299239f //x=4.93 //y=4.62 \
 //x2=5.4 //y2=1.76
cc_230 ( N_B_c_7_p N_noxref_10_c_1718_n ) capacitor c=0.00541004f //x=4.93 \
 //y=2.385 //x2=5.4 //y2=1.76
cc_231 ( N_B_c_8_p N_noxref_10_c_1718_n ) capacitor c=0.00763108f //x=4.93 \
 //y=2.26 //x2=5.4 //y2=1.76
cc_232 ( N_B_c_28_p N_noxref_10_c_1718_n ) capacitor c=0.00688171f //x=4.735 \
 //y=1.7 //x2=5.4 //y2=1.76
cc_233 ( N_B_c_18_p N_noxref_10_c_1718_n ) capacitor c=0.0192505f //x=4.735 \
 //y=2.095 //x2=5.4 //y2=1.76
cc_234 ( N_B_c_184_p N_noxref_10_c_1718_n ) capacitor c=0.00720053f //x=5.11 \
 //y=1.545 //x2=5.4 //y2=1.76
cc_235 ( N_B_c_29_p N_noxref_10_c_1718_n ) capacitor c=0.0059368f //x=5.265 \
 //y=1.39 //x2=5.4 //y2=1.76
cc_236 ( N_B_c_18_p N_noxref_10_c_1725_n ) capacitor c=0.00122123f //x=4.735 \
 //y=2.095 //x2=5.485 //y2=1.675
cc_237 ( N_B_c_25_p N_noxref_10_M2_noxref_s ) capacitor c=0.0303347f //x=4.735 \
 //y=1.045 //x2=4.38 //y2=0.545
cc_238 ( N_B_c_28_p N_noxref_10_M2_noxref_s ) capacitor c=3.48408e-19 \
 //x=4.735 //y=1.7 //x2=4.38 //y2=0.545
cc_239 ( N_B_c_27_p N_noxref_10_M2_noxref_s ) capacitor c=0.012348f //x=5.265 \
 //y=1.045 //x2=4.38 //y2=0.545
cc_240 ( C A ) capacitor c=0.0013225f //x=6.41 //y=2.77 //x2=2.34 //y2=2.77
cc_241 ( C A ) capacitor c=0.0021622f //x=6.41 //y=2.77 //x2=9 //y2=2.77
cc_242 ( C A ) capacitor c=0.0512448f //x=7.89 //y=2.77 //x2=9 //y2=2.77
cc_243 ( N_C_c_281_p A ) capacitor c=0.0011922f //x=7.89 //y=2.43 //x2=9 \
 //y2=2.77
cc_244 ( N_C_c_282_p A ) capacitor c=0.00107415f //x=7.885 //y=2.27 //x2=9 \
 //y2=2.77
cc_245 ( C A ) capacitor c=9.13182e-19 //x=6.41 //y=2.77 //x2=9 //y2=4.62
cc_246 ( C A ) capacitor c=0.010245f //x=7.89 //y=2.77 //x2=9 //y2=4.62
cc_247 ( N_C_c_285_p A ) capacitor c=4.72208e-19 //x=7.89 //y=4.885 //x2=9 \
 //y2=4.62
cc_248 ( N_C_c_286_p A ) capacitor c=2.82097e-19 //x=8.235 //y=4.975 //x2=9 \
 //y2=4.62
cc_249 ( C A ) capacitor c=5.15538e-19 //x=7.89 //y=2.77 //x2=9 //y2=4.25
cc_250 ( C N_A_c_487_n ) capacitor c=3.22024e-19 //x=6.41 //y=2.77 //x2=2.34 \
 //y2=4.71
cc_251 ( N_C_c_248_n N_A_c_487_n ) capacitor c=0.00134435f //x=6.41 //y=4.76 \
 //x2=2.34 //y2=4.71
cc_252 ( N_C_c_281_p N_A_c_545_n ) capacitor c=0.0061363f //x=7.89 //y=2.43 \
 //x2=9 //y2=2.38
cc_253 ( N_C_c_282_p N_A_c_545_n ) capacitor c=0.00602448f //x=7.885 //y=2.27 \
 //x2=9 //y2=2.38
cc_254 ( N_C_c_292_p N_A_c_545_n ) capacitor c=2.06418e-19 //x=7.89 //y=2.26 \
 //x2=9 //y2=2.38
cc_255 ( N_C_c_293_p N_A_c_545_n ) capacitor c=6.73725e-19 //x=7.89 //y=2.26 \
 //x2=9 //y2=2.38
cc_256 ( C N_A_c_549_n ) capacitor c=0.00771726f //x=7.89 //y=2.77 //x2=9 \
 //y2=4.37
cc_257 ( N_C_c_295_p N_A_c_550_n ) capacitor c=0.011624f //x=7.89 //y=4.755 \
 //x2=9 //y2=4.74
cc_258 ( N_C_c_285_p N_A_c_550_n ) capacitor c=3.34205e-19 //x=7.89 //y=4.885 \
 //x2=9 //y2=4.74
cc_259 ( N_C_c_297_p N_A_c_550_n ) capacitor c=0.00125146f //x=8.525 //y=4.975 \
 //x2=9 //y2=4.74
cc_260 ( N_C_c_286_p N_A_c_550_n ) capacitor c=7.4985e-19 //x=8.235 //y=4.975 \
 //x2=9 //y2=4.74
cc_261 ( C N_A_c_554_n ) capacitor c=0.00250167f //x=7.89 //y=2.77 //x2=9.015 \
 //y2=4.21
cc_262 ( C N_A_c_500_n ) capacitor c=0.0355227f //x=6.41 //y=2.77 //x2=8.855 \
 //y2=4.21
cc_263 ( C N_A_c_500_n ) capacitor c=0.0340275f //x=7.89 //y=2.77 //x2=8.855 \
 //y2=4.21
cc_264 ( N_C_c_245_n N_A_c_500_n ) capacitor c=0.00231224f //x=6.41 //y=2.43 \
 //x2=8.855 //y2=4.21
cc_265 ( N_C_c_248_n N_A_c_500_n ) capacitor c=0.00500803f //x=6.41 //y=4.76 \
 //x2=8.855 //y2=4.21
cc_266 ( N_C_c_281_p N_A_c_500_n ) capacitor c=0.00231693f //x=7.89 //y=2.43 \
 //x2=8.855 //y2=4.21
cc_267 ( N_C_c_295_p N_A_c_500_n ) capacitor c=0.00475839f //x=7.89 //y=4.755 \
 //x2=8.855 //y2=4.21
cc_268 ( N_C_c_252_n N_A_c_500_n ) capacitor c=0.00472291f //x=6.575 //y=2.27 \
 //x2=8.855 //y2=4.21
cc_269 ( N_C_c_282_p N_A_c_500_n ) capacitor c=0.00472291f //x=7.885 //y=2.27 \
 //x2=8.855 //y2=4.21
cc_270 ( N_C_c_308_p N_A_c_500_n ) capacitor c=0.0202481f //x=7.725 //y=2.27 \
 //x2=8.855 //y2=4.21
cc_271 ( N_C_c_281_p N_A_c_564_n ) capacitor c=7.58956e-19 //x=7.89 //y=2.43 \
 //x2=9 //y2=2.26
cc_272 ( N_C_c_292_p N_A_c_564_n ) capacitor c=0.00113671f //x=7.89 //y=2.26 \
 //x2=9 //y2=2.26
cc_273 ( N_C_c_293_p N_A_c_564_n ) capacitor c=0.00169858f //x=7.89 //y=2.26 \
 //x2=9 //y2=2.26
cc_274 ( N_C_c_295_p N_A_c_567_n ) capacitor c=2.02321e-19 //x=7.89 //y=4.755 \
 //x2=9.02 //y2=4.885
cc_275 ( N_C_c_285_p N_A_c_567_n ) capacitor c=0.00106454f //x=7.89 //y=4.885 \
 //x2=9.02 //y2=4.885
cc_276 ( N_C_c_297_p N_A_c_567_n ) capacitor c=0.00147609f //x=8.525 //y=4.975 \
 //x2=9.02 //y2=4.885
cc_277 ( N_C_c_286_p N_A_c_567_n ) capacitor c=0.00127381f //x=8.235 //y=4.975 \
 //x2=9.02 //y2=4.885
cc_278 ( N_C_M14_noxref_g N_A_M16_noxref_g ) capacitor c=0.00935155f //x=8.16 \
 //y=6.205 //x2=9.04 //y2=6.205
cc_279 ( N_C_M15_noxref_g N_A_M16_noxref_g ) capacitor c=0.111828f //x=8.6 \
 //y=6.205 //x2=9.04 //y2=6.205
cc_280 ( N_C_M15_noxref_g N_A_M17_noxref_g ) capacitor c=0.00876656f //x=8.6 \
 //y=6.205 //x2=9.48 //y2=6.205
cc_281 ( N_C_c_319_p N_A_c_574_n ) capacitor c=4.86545e-19 //x=8.065 //y=1.045 \
 //x2=9.035 //y2=1.085
cc_282 ( N_C_c_320_p N_A_c_574_n ) capacitor c=0.00152405f //x=8.065 //y=1.39 \
 //x2=9.035 //y2=1.085
cc_283 ( N_C_c_321_p N_A_c_574_n ) capacitor c=0.0151424f //x=8.595 //y=1.045 \
 //x2=9.035 //y2=1.085
cc_284 ( N_C_c_322_p N_A_c_577_n ) capacitor c=0.00109722f //x=8.065 //y=1.7 \
 //x2=9.035 //y2=1.435
cc_285 ( N_C_c_323_p N_A_c_577_n ) capacitor c=0.0111013f //x=8.595 //y=1.39 \
 //x2=9.035 //y2=1.435
cc_286 ( N_C_c_322_p N_A_c_579_n ) capacitor c=0.00179029f //x=8.065 //y=1.7 \
 //x2=9.035 //y2=1.74
cc_287 ( N_C_c_325_p N_A_c_579_n ) capacitor c=0.00662747f //x=8.065 //y=2.095 \
 //x2=9.035 //y2=1.74
cc_288 ( N_C_c_323_p N_A_c_579_n ) capacitor c=0.00862358f //x=8.595 //y=1.39 \
 //x2=9.035 //y2=1.74
cc_289 ( N_C_c_323_p N_A_c_582_n ) capacitor c=4.75927e-19 //x=8.595 //y=1.39 \
 //x2=9.41 //y2=1.585
cc_290 ( N_C_c_321_p N_A_c_583_n ) capacitor c=0.00130607f //x=8.595 //y=1.045 \
 //x2=9.565 //y2=1.085
cc_291 ( N_C_c_323_p N_A_c_584_n ) capacitor c=0.00153205f //x=8.595 //y=1.39 \
 //x2=9.565 //y2=1.435
cc_292 ( N_C_c_281_p N_A_c_585_n ) capacitor c=0.00157228f //x=7.89 //y=2.43 \
 //x2=9 //y2=2.26
cc_293 ( N_C_c_292_p N_A_c_585_n ) capacitor c=0.00194209f //x=7.89 //y=2.26 \
 //x2=9 //y2=2.26
cc_294 ( N_C_c_293_p N_A_c_585_n ) capacitor c=0.00887988f //x=7.89 //y=2.26 \
 //x2=9 //y2=2.26
cc_295 ( N_C_c_295_p N_A_c_588_n ) capacitor c=0.00132485f //x=7.89 //y=4.755 \
 //x2=9.02 //y2=4.885
cc_296 ( N_C_c_285_p N_A_c_588_n ) capacitor c=0.00167042f //x=7.89 //y=4.885 \
 //x2=9.02 //y2=4.885
cc_297 ( N_C_c_297_p N_A_c_588_n ) capacitor c=0.022796f //x=8.525 //y=4.975 \
 //x2=9.02 //y2=4.885
cc_298 ( N_C_c_286_p N_A_c_588_n ) capacitor c=0.00470299f //x=8.235 //y=4.975 \
 //x2=9.02 //y2=4.885
cc_299 ( C YN ) capacitor c=0.00603034f //x=7.89 //y=2.77 //x2=9.74 //y2=2.4
cc_300 ( N_C_c_281_p YN ) capacitor c=8.05281e-19 //x=7.89 //y=2.43 //x2=9.74 \
 //y2=2.4
cc_301 ( N_C_c_282_p YN ) capacitor c=5.18701e-19 //x=7.885 //y=2.27 //x2=9.74 \
 //y2=2.4
cc_302 ( N_C_M15_noxref_g N_YN_c_767_n ) capacitor c=0.00969448f //x=8.6 \
 //y=6.205 //x2=9.135 //y2=5.39
cc_303 ( N_C_c_264_n N_YN_c_768_n ) capacitor c=5.10033e-19 //x=5.705 \
 //y=1.085 //x2=5.97 //y2=1.36
cc_304 ( N_C_c_267_n N_YN_c_768_n ) capacitor c=0.00606934f //x=5.705 //y=1.43 \
 //x2=5.97 //y2=1.36
cc_305 ( N_C_c_343_p N_YN_c_768_n ) capacitor c=4.65567e-19 //x=6.08 //y=0.93 \
 //x2=5.97 //y2=1.36
cc_306 ( N_C_c_344_p N_YN_c_768_n ) capacitor c=0.00247382f //x=6.08 //y=1.585 \
 //x2=5.97 //y2=1.36
cc_307 ( N_C_c_273_n N_YN_c_768_n ) capacitor c=2.15736e-19 //x=6.235 \
 //y=1.085 //x2=5.97 //y2=1.36
cc_308 ( N_C_c_274_n N_YN_c_768_n ) capacitor c=0.00259159f //x=6.235 //y=1.43 \
 //x2=5.97 //y2=1.36
cc_309 ( N_C_c_275_n N_YN_c_768_n ) capacitor c=0.00150348f //x=6.235 //y=1.74 \
 //x2=5.97 //y2=1.36
cc_310 ( N_C_M14_noxref_g N_YN_c_775_n ) capacitor c=0.00363978f //x=8.16 \
 //y=6.205 //x2=8.38 //y2=5.39
cc_311 ( N_C_M15_noxref_g N_YN_c_775_n ) capacitor c=0.00185829f //x=8.6 \
 //y=6.205 //x2=8.38 //y2=5.39
cc_312 ( N_C_c_297_p N_YN_c_775_n ) capacitor c=0.0021827f //x=8.525 //y=4.975 \
 //x2=8.38 //y2=5.39
cc_313 ( N_C_c_267_n N_YN_c_760_n ) capacitor c=0.00147665f //x=5.705 //y=1.43 \
 //x2=5.84 //y2=1.405
cc_314 ( N_C_c_245_n N_YN_c_779_n ) capacitor c=0.00831552f //x=6.41 //y=2.43 \
 //x2=9.135 //y2=1.405
cc_315 ( N_C_c_281_p N_YN_c_779_n ) capacitor c=0.00831552f //x=7.89 //y=2.43 \
 //x2=9.135 //y2=1.405
cc_316 ( N_C_c_252_n N_YN_c_779_n ) capacitor c=0.0128605f //x=6.575 //y=2.27 \
 //x2=9.135 //y2=1.405
cc_317 ( N_C_c_282_p N_YN_c_779_n ) capacitor c=0.0128597f //x=7.885 //y=2.27 \
 //x2=9.135 //y2=1.405
cc_318 ( N_C_c_308_p N_YN_c_779_n ) capacitor c=0.0434154f //x=7.725 //y=2.27 \
 //x2=9.135 //y2=1.405
cc_319 ( N_C_c_274_n N_YN_c_779_n ) capacitor c=0.00215337f //x=6.235 //y=1.43 \
 //x2=9.135 //y2=1.405
cc_320 ( N_C_c_275_n N_YN_c_779_n ) capacitor c=0.00349699f //x=6.235 //y=1.74 \
 //x2=9.135 //y2=1.405
cc_321 ( N_C_c_320_p N_YN_c_779_n ) capacitor c=0.00277413f //x=8.065 //y=1.39 \
 //x2=9.135 //y2=1.405
cc_322 ( N_C_c_322_p N_YN_c_779_n ) capacitor c=0.00245466f //x=8.065 //y=1.7 \
 //x2=9.135 //y2=1.405
cc_323 ( N_C_c_323_p N_YN_c_779_n ) capacitor c=0.00460244f //x=8.595 //y=1.39 \
 //x2=9.135 //y2=1.405
cc_324 ( N_C_M14_noxref_g N_YN_c_789_n ) capacitor c=0.0120591f //x=8.16 \
 //y=6.205 //x2=8.38 //y2=5.56
cc_325 ( N_C_M15_noxref_g N_YN_c_789_n ) capacitor c=0.0142133f //x=8.6 \
 //y=6.205 //x2=8.38 //y2=5.56
cc_326 ( N_C_c_297_p N_YN_c_789_n ) capacitor c=0.00293135f //x=8.525 \
 //y=4.975 //x2=8.38 //y2=5.56
cc_327 ( N_C_c_264_n N_YN_M3_noxref_d ) capacitor c=0.00217566f //x=5.705 \
 //y=1.085 //x2=5.78 //y2=1.085
cc_328 ( N_C_c_267_n N_YN_M3_noxref_d ) capacitor c=0.00693963f //x=5.705 \
 //y=1.43 //x2=5.78 //y2=1.085
cc_329 ( N_C_c_343_p N_YN_M3_noxref_d ) capacitor c=0.00234223f //x=6.08 \
 //y=0.93 //x2=5.78 //y2=1.085
cc_330 ( N_C_c_344_p N_YN_M3_noxref_d ) capacitor c=0.00513213f //x=6.08 \
 //y=1.585 //x2=5.78 //y2=1.085
cc_331 ( N_C_c_273_n N_YN_M3_noxref_d ) capacitor c=0.00132245f //x=6.235 \
 //y=1.085 //x2=5.78 //y2=1.085
cc_332 ( N_C_c_274_n N_YN_M3_noxref_d ) capacitor c=0.00326247f //x=6.235 \
 //y=1.43 //x2=5.78 //y2=1.085
cc_333 ( N_C_c_275_n N_YN_M3_noxref_d ) capacitor c=0.00231463f //x=6.235 \
 //y=1.74 //x2=5.78 //y2=1.085
cc_334 ( N_C_M12_noxref_g N_VDD_c_980_n ) capacitor c=0.00782837f //x=5.7 \
 //y=6.205 //x2=6.98 //y2=7.585
cc_335 ( N_C_M13_noxref_g N_VDD_c_980_n ) capacitor c=0.00782837f //x=6.14 \
 //y=6.205 //x2=6.98 //y2=7.585
cc_336 ( N_C_M14_noxref_g N_VDD_c_998_n ) capacitor c=0.00782837f //x=8.16 \
 //y=6.205 //x2=9.74 //y2=7.58
cc_337 ( N_C_M15_noxref_g N_VDD_c_998_n ) capacitor c=0.00782837f //x=8.6 \
 //y=6.205 //x2=9.74 //y2=7.58
cc_338 ( C N_VDD_c_989_n ) capacitor c=0.0100754f //x=6.41 //y=2.77 //x2=7.15 \
 //y2=7.585
cc_339 ( C N_VDD_c_989_n ) capacitor c=0.0104042f //x=7.89 //y=2.77 //x2=7.15 \
 //y2=7.585
cc_340 ( N_C_c_248_n N_VDD_c_989_n ) capacitor c=0.00552497f //x=6.41 //y=4.76 \
 //x2=7.15 //y2=7.585
cc_341 ( N_C_c_295_p N_VDD_c_989_n ) capacitor c=0.00593694f //x=7.89 \
 //y=4.755 //x2=7.15 //y2=7.585
cc_342 ( N_C_c_258_n N_VDD_c_989_n ) capacitor c=0.00790417f //x=6.41 \
 //y=4.885 //x2=7.15 //y2=7.585
cc_343 ( N_C_c_285_p N_VDD_c_989_n ) capacitor c=0.00734519f //x=7.89 \
 //y=4.885 //x2=7.15 //y2=7.585
cc_344 ( N_C_M13_noxref_g N_VDD_c_989_n ) capacitor c=0.01358f //x=6.14 \
 //y=6.205 //x2=7.15 //y2=7.585
cc_345 ( N_C_M14_noxref_g N_VDD_c_989_n ) capacitor c=0.00895835f //x=8.16 \
 //y=6.205 //x2=7.15 //y2=7.585
cc_346 ( N_C_c_271_n N_VDD_c_989_n ) capacitor c=0.00722671f //x=6.14 //y=5.05 \
 //x2=7.15 //y2=7.585
cc_347 ( N_C_c_286_p N_VDD_c_989_n ) capacitor c=0.00818208f //x=8.235 \
 //y=4.975 //x2=7.15 //y2=7.585
cc_348 ( N_C_M12_noxref_g N_noxref_6_c_1185_n ) capacitor c=0.00814026f \
 //x=5.7 //y=6.205 //x2=6.245 //y2=7.09
cc_349 ( N_C_M13_noxref_g N_noxref_6_c_1185_n ) capacitor c=0.00937408f \
 //x=6.14 //y=6.205 //x2=6.245 //y2=7.09
cc_350 ( N_C_M12_noxref_g N_noxref_6_c_1174_n ) capacitor c=0.0017976f //x=5.7 \
 //y=6.205 //x2=5.477 //y2=7.09
cc_351 ( N_C_M13_noxref_g N_noxref_6_c_1188_n ) capacitor c=0.00395674f \
 //x=6.14 //y=6.205 //x2=6.36 //y2=6.92
cc_352 ( N_C_M12_noxref_g N_noxref_6_M11_noxref_d ) capacitor c=0.0142133f \
 //x=5.7 //y=6.205 //x2=5.335 //y2=5.205
cc_353 ( N_C_c_258_n N_noxref_6_M13_noxref_d ) capacitor c=0.00256087f \
 //x=6.41 //y=4.885 //x2=6.215 //y2=5.205
cc_354 ( N_C_M13_noxref_g N_noxref_6_M13_noxref_d ) capacitor c=0.0365939f \
 //x=6.14 //y=6.205 //x2=6.215 //y2=5.205
cc_355 ( N_C_c_271_n N_noxref_6_M13_noxref_d ) capacitor c=0.00447202f \
 //x=6.14 //y=5.05 //x2=6.215 //y2=5.205
cc_356 ( N_C_M12_noxref_g N_noxref_7_c_1322_n ) capacitor c=0.00998198f \
 //x=5.7 //y=6.205 //x2=5.805 //y2=5.39
cc_357 ( N_C_c_245_n N_noxref_7_c_1335_n ) capacitor c=0.00143791f //x=6.41 \
 //y=2.43 //x2=7.825 //y2=5.39
cc_358 ( N_C_c_248_n N_noxref_7_c_1335_n ) capacitor c=0.0227143f //x=6.41 \
 //y=4.76 //x2=7.825 //y2=5.39
cc_359 ( N_C_c_281_p N_noxref_7_c_1335_n ) capacitor c=0.00141341f //x=7.89 \
 //y=2.43 //x2=7.825 //y2=5.39
cc_360 ( N_C_c_295_p N_noxref_7_c_1335_n ) capacitor c=0.0274606f //x=7.89 \
 //y=4.755 //x2=7.825 //y2=5.39
cc_361 ( N_C_c_258_n N_noxref_7_c_1335_n ) capacitor c=0.0035251f //x=6.41 \
 //y=4.885 //x2=7.825 //y2=5.39
cc_362 ( N_C_c_285_p N_noxref_7_c_1335_n ) capacitor c=0.00429429f //x=7.89 \
 //y=4.885 //x2=7.825 //y2=5.39
cc_363 ( N_C_M13_noxref_g N_noxref_7_c_1335_n ) capacitor c=0.0119434f \
 //x=6.14 //y=6.205 //x2=7.825 //y2=5.39
cc_364 ( N_C_M14_noxref_g N_noxref_7_c_1335_n ) capacitor c=0.00383041f \
 //x=8.16 //y=6.205 //x2=7.825 //y2=5.39
cc_365 ( N_C_c_271_n N_noxref_7_c_1335_n ) capacitor c=0.00500633f //x=6.14 \
 //y=5.05 //x2=7.825 //y2=5.39
cc_366 ( N_C_c_286_p N_noxref_7_c_1335_n ) capacitor c=0.00243015f //x=8.235 \
 //y=4.975 //x2=7.825 //y2=5.39
cc_367 ( N_C_M12_noxref_g N_noxref_7_c_1345_n ) capacitor c=6.12451e-19 \
 //x=5.7 //y=6.205 //x2=6.035 //y2=5.39
cc_368 ( N_C_M13_noxref_g N_noxref_7_c_1345_n ) capacitor c=8.33934e-19 \
 //x=6.14 //y=6.205 //x2=6.035 //y2=5.39
cc_369 ( N_C_M14_noxref_g N_noxref_7_c_1347_n ) capacitor c=0.0109238f \
 //x=8.16 //y=6.205 //x2=8.705 //y2=7.09
cc_370 ( N_C_M15_noxref_g N_noxref_7_c_1347_n ) capacitor c=0.00814026f \
 //x=8.6 //y=6.205 //x2=8.705 //y2=7.09
cc_371 ( N_C_M14_noxref_g N_noxref_7_c_1349_n ) capacitor c=0.00394587f \
 //x=8.16 //y=6.205 //x2=7.94 //y2=6.92
cc_372 ( N_C_M15_noxref_g N_noxref_7_c_1350_n ) capacitor c=0.00179267f \
 //x=8.6 //y=6.205 //x2=8.82 //y2=7.09
cc_373 ( N_C_M12_noxref_g N_noxref_7_c_1351_n ) capacitor c=0.0179771f //x=5.7 \
 //y=6.205 //x2=5.92 //y2=5.39
cc_374 ( N_C_M13_noxref_g N_noxref_7_c_1351_n ) capacitor c=0.0171712f \
 //x=6.14 //y=6.205 //x2=5.92 //y2=5.39
cc_375 ( N_C_c_413_p N_noxref_7_c_1351_n ) capacitor c=0.00438178f //x=6.065 \
 //y=4.975 //x2=5.92 //y2=5.39
cc_376 ( N_C_c_295_p N_noxref_7_c_1354_n ) capacitor c=0.00533094f //x=7.89 \
 //y=4.755 //x2=7.94 //y2=5.39
cc_377 ( N_C_c_285_p N_noxref_7_c_1354_n ) capacitor c=0.013929f //x=7.89 \
 //y=4.885 //x2=7.94 //y2=5.39
cc_378 ( N_C_M14_noxref_g N_noxref_7_c_1354_n ) capacitor c=0.0510602f \
 //x=8.16 //y=6.205 //x2=7.94 //y2=5.39
cc_379 ( N_C_c_286_p N_noxref_7_c_1354_n ) capacitor c=0.00827092f //x=8.235 \
 //y=4.975 //x2=7.94 //y2=5.39
cc_380 ( N_C_M15_noxref_g N_noxref_7_M15_noxref_d ) capacitor c=0.0142133f \
 //x=8.6 //y=6.205 //x2=8.675 //y2=5.205
cc_381 ( N_C_c_245_n N_GND_c_1491_n ) capacitor c=9.61971e-19 //x=6.41 \
 //y=2.43 //x2=8.245 //y2=0.175
cc_382 ( N_C_c_281_p N_GND_c_1491_n ) capacitor c=0.00100426f //x=7.89 \
 //y=2.43 //x2=8.245 //y2=0.175
cc_383 ( N_C_c_292_p N_GND_c_1491_n ) capacitor c=2.64659e-19 //x=7.89 \
 //y=2.26 //x2=8.245 //y2=0.175
cc_384 ( N_C_c_319_p N_GND_c_1494_n ) capacitor c=0.00175529f //x=8.065 \
 //y=1.045 //x2=8.33 //y2=1.02
cc_385 ( N_C_c_320_p N_GND_c_1494_n ) capacitor c=0.00373063f //x=8.065 \
 //y=1.39 //x2=8.33 //y2=1.02
cc_386 ( N_C_c_322_p N_GND_c_1494_n ) capacitor c=3.99385e-19 //x=8.065 \
 //y=1.7 //x2=8.33 //y2=1.02
cc_387 ( N_C_c_425_p N_GND_c_1494_n ) capacitor c=0.00924233f //x=8.44 \
 //y=0.89 //x2=8.33 //y2=1.02
cc_388 ( N_C_c_426_p N_GND_c_1494_n ) capacitor c=6.20182e-19 //x=8.44 \
 //y=1.545 //x2=8.33 //y2=1.02
cc_389 ( N_C_c_321_p N_GND_c_1494_n ) capacitor c=0.00181958f //x=8.595 \
 //y=1.045 //x2=8.33 //y2=1.02
cc_390 ( N_C_c_323_p N_GND_c_1494_n ) capacitor c=0.00417834f //x=8.595 \
 //y=1.39 //x2=8.33 //y2=1.02
cc_391 ( N_C_c_245_n N_GND_c_1473_n ) capacitor c=9.4179e-19 //x=6.41 //y=2.43 \
 //x2=6.98 //y2=0.175
cc_392 ( N_C_c_281_p N_GND_c_1502_n ) capacitor c=6.59434e-19 //x=7.89 \
 //y=2.43 //x2=9.74 //y2=0.18
cc_393 ( N_C_c_292_p N_GND_c_1502_n ) capacitor c=2.74348e-19 //x=7.89 \
 //y=2.26 //x2=9.74 //y2=0.18
cc_394 ( N_C_c_319_p N_GND_c_1502_n ) capacitor c=0.00698682f //x=8.065 \
 //y=1.045 //x2=9.74 //y2=0.18
cc_395 ( N_C_c_254_n N_GND_c_1474_n ) capacitor c=3.88707e-19 //x=6.41 \
 //y=2.26 //x2=3.82 //y2=0.175
cc_396 ( C N_GND_c_1506_n ) capacitor c=0.0117547f //x=6.41 //y=2.77 //x2=7.15 \
 //y2=0.175
cc_397 ( C N_GND_c_1506_n ) capacitor c=0.0117547f //x=7.89 //y=2.77 //x2=7.15 \
 //y2=0.175
cc_398 ( N_C_c_245_n N_GND_c_1506_n ) capacitor c=0.00414357f //x=6.41 \
 //y=2.43 //x2=7.15 //y2=0.175
cc_399 ( N_C_c_281_p N_GND_c_1506_n ) capacitor c=0.00414357f //x=7.89 \
 //y=2.43 //x2=7.15 //y2=0.175
cc_400 ( N_C_c_308_p N_GND_c_1506_n ) capacitor c=0.0153655f //x=7.725 \
 //y=2.27 //x2=7.15 //y2=0.175
cc_401 ( N_C_c_254_n N_GND_c_1506_n ) capacitor c=0.00780676f //x=6.41 \
 //y=2.26 //x2=7.15 //y2=0.175
cc_402 ( N_C_c_292_p N_GND_c_1506_n ) capacitor c=0.00780676f //x=7.89 \
 //y=2.26 //x2=7.15 //y2=0.175
cc_403 ( N_C_c_276_n N_GND_c_1506_n ) capacitor c=0.00989164f //x=6.235 \
 //y=2.095 //x2=7.15 //y2=0.175
cc_404 ( N_C_c_325_p N_GND_c_1506_n ) capacitor c=0.00369332f //x=8.065 \
 //y=2.095 //x2=7.15 //y2=0.175
cc_405 ( N_C_c_293_p N_GND_c_1506_n ) capacitor c=0.00619832f //x=7.89 \
 //y=2.26 //x2=7.15 //y2=0.175
cc_406 ( N_C_c_319_p N_GND_M4_noxref_d ) capacitor c=0.00192399f //x=8.065 \
 //y=1.045 //x2=8.14 //y2=1.045
cc_407 ( N_C_c_320_p N_GND_M4_noxref_d ) capacitor c=0.00210798f //x=8.065 \
 //y=1.39 //x2=8.14 //y2=1.045
cc_408 ( N_C_c_425_p N_GND_M4_noxref_d ) capacitor c=0.00472259f //x=8.44 \
 //y=0.89 //x2=8.14 //y2=1.045
cc_409 ( N_C_c_426_p N_GND_M4_noxref_d ) capacitor c=0.00166857f //x=8.44 \
 //y=1.545 //x2=8.14 //y2=1.045
cc_410 ( N_C_c_321_p N_GND_M4_noxref_d ) capacitor c=0.00230174f //x=8.595 \
 //y=1.045 //x2=8.14 //y2=1.045
cc_411 ( N_C_c_323_p N_GND_M4_noxref_d ) capacitor c=0.00210798f //x=8.595 \
 //y=1.39 //x2=8.14 //y2=1.045
cc_412 ( N_C_c_276_n N_noxref_10_c_1725_n ) capacitor c=0.0028747f //x=6.235 \
 //y=2.095 //x2=5.485 //y2=1.675
cc_413 ( N_C_c_245_n N_noxref_10_c_1730_n ) capacitor c=7.24043e-19 //x=6.41 \
 //y=2.43 //x2=6.37 //y2=0.71
cc_414 ( N_C_c_264_n N_noxref_10_c_1730_n ) capacitor c=0.0214576f //x=5.705 \
 //y=1.085 //x2=6.37 //y2=0.71
cc_415 ( N_C_c_273_n N_noxref_10_c_1730_n ) capacitor c=0.00781103f //x=6.235 \
 //y=1.085 //x2=6.37 //y2=0.71
cc_416 ( N_C_c_245_n N_noxref_10_M2_noxref_s ) capacitor c=0.00472586f \
 //x=6.41 //y=2.43 //x2=4.38 //y2=0.545
cc_417 ( N_C_c_254_n N_noxref_10_M2_noxref_s ) capacitor c=0.010408f //x=6.41 \
 //y=2.26 //x2=4.38 //y2=0.545
cc_418 ( N_C_c_264_n N_noxref_10_M2_noxref_s ) capacitor c=0.00506846f \
 //x=5.705 //y=1.085 //x2=4.38 //y2=0.545
cc_419 ( N_C_c_267_n N_noxref_10_M2_noxref_s ) capacitor c=0.00602248f \
 //x=5.705 //y=1.43 //x2=4.38 //y2=0.545
cc_420 ( N_C_c_273_n N_noxref_10_M2_noxref_s ) capacitor c=0.0291051f \
 //x=6.235 //y=1.085 //x2=4.38 //y2=0.545
cc_421 ( N_C_c_275_n N_noxref_10_M2_noxref_s ) capacitor c=0.00369225f \
 //x=6.235 //y=1.74 //x2=4.38 //y2=0.545
cc_422 ( N_C_c_276_n N_noxref_10_M2_noxref_s ) capacitor c=0.00797698f \
 //x=6.235 //y=2.095 //x2=4.38 //y2=0.545
cc_423 ( N_C_c_281_p N_noxref_11_c_1783_n ) capacitor c=0.00472586f //x=7.89 \
 //y=2.43 //x2=7.845 //y2=1.675
cc_424 ( N_C_c_292_p N_noxref_11_c_1783_n ) capacitor c=0.010408f //x=7.89 \
 //y=2.26 //x2=7.845 //y2=1.675
cc_425 ( N_C_c_325_p N_noxref_11_c_1783_n ) capacitor c=0.0027748f //x=8.065 \
 //y=2.095 //x2=7.845 //y2=1.675
cc_426 ( N_C_c_293_p N_noxref_11_c_1783_n ) capacitor c=0.00544234f //x=7.89 \
 //y=2.26 //x2=7.845 //y2=1.675
cc_427 ( N_C_c_281_p N_noxref_11_c_1787_n ) capacitor c=0.00350518f //x=7.89 \
 //y=2.43 //x2=8.73 //y2=1.76
cc_428 ( N_C_c_292_p N_noxref_11_c_1787_n ) capacitor c=0.00305795f //x=7.89 \
 //y=2.26 //x2=8.73 //y2=1.76
cc_429 ( N_C_c_322_p N_noxref_11_c_1787_n ) capacitor c=0.00712798f //x=8.065 \
 //y=1.7 //x2=8.73 //y2=1.76
cc_430 ( N_C_c_325_p N_noxref_11_c_1787_n ) capacitor c=0.013968f //x=8.065 \
 //y=2.095 //x2=8.73 //y2=1.76
cc_431 ( N_C_c_426_p N_noxref_11_c_1787_n ) capacitor c=0.00948889f //x=8.44 \
 //y=1.545 //x2=8.73 //y2=1.76
cc_432 ( N_C_c_323_p N_noxref_11_c_1787_n ) capacitor c=0.00339872f //x=8.595 \
 //y=1.39 //x2=8.73 //y2=1.76
cc_433 ( N_C_c_293_p N_noxref_11_c_1787_n ) capacitor c=0.00168631f //x=7.89 \
 //y=2.26 //x2=8.73 //y2=1.76
cc_434 ( N_C_c_325_p N_noxref_11_c_1794_n ) capacitor c=6.71402e-19 //x=8.065 \
 //y=2.095 //x2=8.815 //y2=1.675
cc_435 ( N_C_c_319_p N_noxref_11_M4_noxref_s ) capacitor c=0.0293163f \
 //x=8.065 //y=1.045 //x2=7.71 //y2=0.545
cc_436 ( N_C_c_322_p N_noxref_11_M4_noxref_s ) capacitor c=0.00110192f \
 //x=8.065 //y=1.7 //x2=7.71 //y2=0.545
cc_437 ( N_C_c_321_p N_noxref_11_M4_noxref_s ) capacitor c=0.0123625f \
 //x=8.595 //y=1.045 //x2=7.71 //y2=0.545
cc_438 ( A YN ) capacitor c=0.0785159f //x=9 //y=2.77 //x2=9.74 //y2=2.4
cc_439 ( A YN ) capacitor c=0.0159587f //x=9 //y=4.62 //x2=9.74 //y2=2.4
cc_440 ( A YN ) capacitor c=0.00458619f //x=9 //y=4.25 //x2=9.74 //y2=2.4
cc_441 ( N_A_c_545_n YN ) capacitor c=0.0146548f //x=9 //y=2.38 //x2=9.74 \
 //y2=2.4
cc_442 ( N_A_c_549_n YN ) capacitor c=0.0157342f //x=9 //y=4.37 //x2=9.74 \
 //y2=2.4
cc_443 ( N_A_c_550_n YN ) capacitor c=0.017079f //x=9 //y=4.74 //x2=9.74 \
 //y2=2.4
cc_444 ( N_A_c_554_n YN ) capacitor c=0.00730952f //x=9.015 //y=4.21 //x2=9.74 \
 //y2=2.4
cc_445 ( N_A_c_564_n YN ) capacitor c=0.00442101f //x=9 //y=2.26 //x2=9.74 \
 //y2=2.4
cc_446 ( N_A_c_567_n YN ) capacitor c=0.00472529f //x=9.02 //y=4.885 //x2=9.74 \
 //y2=2.4
cc_447 ( N_A_c_601_p YN ) capacitor c=0.00472303f //x=9.405 //y=4.975 \
 //x2=9.74 //y2=2.4
cc_448 ( N_A_c_585_n YN ) capacitor c=0.00284078f //x=9 //y=2.26 //x2=9.74 \
 //y2=2.4
cc_449 ( N_A_c_588_n YN ) capacitor c=0.00141883f //x=9.02 //y=4.885 //x2=9.74 \
 //y2=2.4
cc_450 ( N_A_c_549_n N_YN_c_767_n ) capacitor c=0.00435926f //x=9 //y=4.37 \
 //x2=9.135 //y2=5.39
cc_451 ( N_A_c_550_n N_YN_c_767_n ) capacitor c=0.0223378f //x=9 //y=4.74 \
 //x2=9.135 //y2=5.39
cc_452 ( N_A_c_554_n N_YN_c_767_n ) capacitor c=7.70643e-19 //x=9.015 //y=4.21 \
 //x2=9.135 //y2=5.39
cc_453 ( N_A_c_500_n N_YN_c_767_n ) capacitor c=0.0017832f //x=8.855 //y=4.21 \
 //x2=9.135 //y2=5.39
cc_454 ( N_A_c_567_n N_YN_c_767_n ) capacitor c=0.00459858f //x=9.02 //y=4.885 \
 //x2=9.135 //y2=5.39
cc_455 ( N_A_M16_noxref_g N_YN_c_767_n ) capacitor c=0.00846675f //x=9.04 \
 //y=6.205 //x2=9.135 //y2=5.39
cc_456 ( N_A_c_588_n N_YN_c_767_n ) capacitor c=7.28626e-19 //x=9.02 //y=4.885 \
 //x2=9.135 //y2=5.39
cc_457 ( N_A_c_545_n N_YN_c_818_n ) capacitor c=0.00233055f //x=9 //y=2.38 \
 //x2=9.3 //y2=1.535
cc_458 ( N_A_c_564_n N_YN_c_818_n ) capacitor c=8.15893e-19 //x=9 //y=2.26 \
 //x2=9.3 //y2=1.535
cc_459 ( N_A_c_574_n N_YN_c_818_n ) capacitor c=5.01861e-19 //x=9.035 \
 //y=1.085 //x2=9.3 //y2=1.535
cc_460 ( N_A_c_577_n N_YN_c_818_n ) capacitor c=0.00397521f //x=9.035 \
 //y=1.435 //x2=9.3 //y2=1.535
cc_461 ( N_A_c_579_n N_YN_c_818_n ) capacitor c=0.00205332f //x=9.035 //y=1.74 \
 //x2=9.3 //y2=1.535
cc_462 ( N_A_c_616_p N_YN_c_818_n ) capacitor c=3.72732e-19 //x=9.41 //y=0.93 \
 //x2=9.3 //y2=1.535
cc_463 ( N_A_c_582_n N_YN_c_818_n ) capacitor c=0.00194493f //x=9.41 //y=1.585 \
 //x2=9.3 //y2=1.535
cc_464 ( N_A_c_583_n N_YN_c_818_n ) capacitor c=2.0901e-19 //x=9.565 //y=1.085 \
 //x2=9.3 //y2=1.535
cc_465 ( N_A_c_584_n N_YN_c_818_n ) capacitor c=0.00271521f //x=9.565 \
 //y=1.435 //x2=9.3 //y2=1.535
cc_466 ( N_A_c_585_n N_YN_c_818_n ) capacitor c=2.48891e-19 //x=9 //y=2.26 \
 //x2=9.3 //y2=1.535
cc_467 ( N_A_c_579_n N_YN_c_828_n ) capacitor c=0.0018678f //x=9.035 //y=1.74 \
 //x2=9.3 //y2=1.74
cc_468 ( N_A_c_582_n N_YN_c_828_n ) capacitor c=0.0061514f //x=9.41 //y=1.585 \
 //x2=9.3 //y2=1.74
cc_469 ( N_A_M17_noxref_g N_YN_c_830_n ) capacitor c=0.0116091f //x=9.48 \
 //y=6.205 //x2=9.655 //y2=5.39
cc_470 ( N_A_c_582_n N_YN_c_831_n ) capacitor c=0.0048413f //x=9.41 //y=1.585 \
 //x2=9.655 //y2=1.825
cc_471 ( N_A_c_625_p N_YN_c_832_n ) capacitor c=0.00368358f //x=9 //y=2.095 \
 //x2=9.385 //y2=1.825
cc_472 ( N_A_c_516_n N_YN_c_833_n ) capacitor c=3.77121e-19 //x=2.375 \
 //y=1.085 //x2=2.64 //y2=1.36
cc_473 ( N_A_c_519_n N_YN_c_833_n ) capacitor c=0.00250809f //x=2.375 //y=1.43 \
 //x2=2.64 //y2=1.36
cc_474 ( N_A_c_521_n N_YN_c_833_n ) capacitor c=0.00152089f //x=2.375 //y=1.74 \
 //x2=2.64 //y2=1.36
cc_475 ( N_A_c_629_p N_YN_c_833_n ) capacitor c=3.38306e-19 //x=2.75 //y=0.93 \
 //x2=2.64 //y2=1.36
cc_476 ( N_A_c_630_p N_YN_c_833_n ) capacitor c=0.0022369f //x=2.75 //y=1.585 \
 //x2=2.64 //y2=1.36
cc_477 ( N_A_c_524_n N_YN_c_833_n ) capacitor c=3.16128e-19 //x=2.905 \
 //y=1.085 //x2=2.64 //y2=1.36
cc_478 ( N_A_c_525_n N_YN_c_833_n ) capacitor c=0.00792546f //x=2.905 //y=1.43 \
 //x2=2.64 //y2=1.36
cc_479 ( N_A_c_500_n N_YN_c_775_n ) capacitor c=0.0169094f //x=8.855 //y=4.21 \
 //x2=8.38 //y2=5.39
cc_480 ( N_A_c_554_n N_YN_c_841_n ) capacitor c=6.25661e-19 //x=9.015 //y=4.21 \
 //x2=9.257 //y2=5.39
cc_481 ( N_A_M16_noxref_g N_YN_c_841_n ) capacitor c=0.00180711f //x=9.04 \
 //y=6.205 //x2=9.257 //y2=5.39
cc_482 ( N_A_M17_noxref_g N_YN_c_841_n ) capacitor c=0.00341268f //x=9.48 \
 //y=6.205 //x2=9.257 //y2=5.39
cc_483 ( N_A_c_601_p N_YN_c_841_n ) capacitor c=0.00216603f //x=9.405 \
 //y=4.975 //x2=9.257 //y2=5.39
cc_484 ( N_A_c_525_n N_YN_c_760_n ) capacitor c=0.00147665f //x=2.905 //y=1.43 \
 //x2=5.84 //y2=1.405
cc_485 ( N_A_c_579_n N_YN_c_846_n ) capacitor c=0.00131018f //x=9.035 //y=1.74 \
 //x2=9.295 //y2=1.405
cc_486 ( N_A_c_582_n N_YN_c_846_n ) capacitor c=0.00184285f //x=9.41 //y=1.585 \
 //x2=9.295 //y2=1.405
cc_487 ( N_A_c_545_n N_YN_c_779_n ) capacitor c=0.00997796f //x=9 //y=2.38 \
 //x2=9.135 //y2=1.405
cc_488 ( N_A_c_577_n N_YN_c_779_n ) capacitor c=0.00107668f //x=9.035 \
 //y=1.435 //x2=9.135 //y2=1.405
cc_489 ( N_A_c_579_n N_YN_c_779_n ) capacitor c=8.64037e-19 //x=9.035 //y=1.74 \
 //x2=9.135 //y2=1.405
cc_490 ( N_A_M16_noxref_g N_YN_c_851_n ) capacitor c=0.0141401f //x=9.04 \
 //y=6.205 //x2=9.26 //y2=5.56
cc_491 ( N_A_M17_noxref_g N_YN_c_851_n ) capacitor c=0.0139971f //x=9.48 \
 //y=6.205 //x2=9.26 //y2=5.56
cc_492 ( N_A_c_601_p N_YN_c_851_n ) capacitor c=0.00293135f //x=9.405 \
 //y=4.975 //x2=9.26 //y2=5.56
cc_493 ( N_A_c_516_n N_YN_M1_noxref_d ) capacitor c=0.00218556f //x=2.375 \
 //y=1.085 //x2=2.45 //y2=1.085
cc_494 ( N_A_c_519_n N_YN_M1_noxref_d ) capacitor c=0.00327871f //x=2.375 \
 //y=1.43 //x2=2.45 //y2=1.085
cc_495 ( N_A_c_521_n N_YN_M1_noxref_d ) capacitor c=0.00254845f //x=2.375 \
 //y=1.74 //x2=2.45 //y2=1.085
cc_496 ( N_A_c_629_p N_YN_M1_noxref_d ) capacitor c=0.00235569f //x=2.75 \
 //y=0.93 //x2=2.45 //y2=1.085
cc_497 ( N_A_c_630_p N_YN_M1_noxref_d ) capacitor c=0.00523156f //x=2.75 \
 //y=1.585 //x2=2.45 //y2=1.085
cc_498 ( N_A_c_524_n N_YN_M1_noxref_d ) capacitor c=0.00131413f //x=2.905 \
 //y=1.085 //x2=2.45 //y2=1.085
cc_499 ( N_A_c_525_n N_YN_M1_noxref_d ) capacitor c=0.0065758f //x=2.905 \
 //y=1.43 //x2=2.45 //y2=1.085
cc_500 ( N_A_c_574_n N_YN_M5_noxref_d ) capacitor c=0.00226395f //x=9.035 \
 //y=1.085 //x2=9.11 //y2=1.085
cc_501 ( N_A_c_577_n N_YN_M5_noxref_d ) capacitor c=0.004517f //x=9.035 \
 //y=1.435 //x2=9.11 //y2=1.085
cc_502 ( N_A_c_579_n N_YN_M5_noxref_d ) capacitor c=0.00275912f //x=9.035 \
 //y=1.74 //x2=9.11 //y2=1.085
cc_503 ( N_A_c_616_p N_YN_M5_noxref_d ) capacitor c=0.00234223f //x=9.41 \
 //y=0.93 //x2=9.11 //y2=1.085
cc_504 ( N_A_c_582_n N_YN_M5_noxref_d ) capacitor c=0.00707878f //x=9.41 \
 //y=1.585 //x2=9.11 //y2=1.085
cc_505 ( N_A_c_583_n N_YN_M5_noxref_d ) capacitor c=0.00132831f //x=9.565 \
 //y=1.085 //x2=9.11 //y2=1.085
cc_506 ( N_A_c_584_n N_YN_M5_noxref_d ) capacitor c=0.00330743f //x=9.565 \
 //y=1.435 //x2=9.11 //y2=1.085
cc_507 ( N_A_M8_noxref_g N_VDD_c_969_n ) capacitor c=0.00125343f //x=2.38 \
 //y=6.205 //x2=2.16 //y2=7.035
cc_508 ( N_A_M8_noxref_g N_VDD_c_970_n ) capacitor c=0.00137209f //x=2.38 \
 //y=6.205 //x2=2.16 //y2=7.41
cc_509 ( N_A_M9_noxref_g N_VDD_c_1012_n ) capacitor c=0.00373588f //x=2.82 \
 //y=6.205 //x2=3.04 //y2=7.035
cc_510 ( N_A_M9_noxref_g N_VDD_c_1013_n ) capacitor c=0.00300944f //x=2.82 \
 //y=6.205 //x2=3.04 //y2=7.41
cc_511 ( N_A_M8_noxref_g N_VDD_c_972_n ) capacitor c=0.007206f //x=2.38 \
 //y=6.205 //x2=3.65 //y2=7.585
cc_512 ( N_A_M9_noxref_g N_VDD_c_972_n ) capacitor c=0.00778439f //x=2.82 \
 //y=6.205 //x2=3.65 //y2=7.585
cc_513 ( A N_VDD_c_975_n ) capacitor c=9.52781e-19 //x=2.34 //y=4.25 //x2=1.23 \
 //y2=7.58
cc_514 ( N_A_c_487_n N_VDD_c_975_n ) capacitor c=2.16363e-19 //x=2.34 //y=4.71 \
 //x2=1.23 //y2=7.58
cc_515 ( A N_VDD_c_998_n ) capacitor c=0.00143077f //x=9 //y=4.25 //x2=9.74 \
 //y2=7.58
cc_516 ( N_A_c_567_n N_VDD_c_998_n ) capacitor c=0.00237807f //x=9.02 \
 //y=4.885 //x2=9.74 //y2=7.58
cc_517 ( N_A_M16_noxref_g N_VDD_c_998_n ) capacitor c=0.00728344f //x=9.04 \
 //y=6.205 //x2=9.74 //y2=7.58
cc_518 ( N_A_M17_noxref_g N_VDD_c_998_n ) capacitor c=0.00782837f //x=9.48 \
 //y=6.205 //x2=9.74 //y2=7.58
cc_519 ( N_A_c_601_p N_VDD_c_998_n ) capacitor c=0.025943f //x=9.405 //y=4.975 \
 //x2=9.74 //y2=7.58
cc_520 ( N_A_c_588_n N_VDD_c_998_n ) capacitor c=2.70151e-19 //x=9.02 \
 //y=4.885 //x2=9.74 //y2=7.58
cc_521 ( A N_VDD_c_983_n ) capacitor c=0.00144593f //x=2.34 //y=4.25 //x2=3.82 \
 //y2=7.585
cc_522 ( N_A_c_484_n N_VDD_c_983_n ) capacitor c=5.31543e-19 //x=2.34 \
 //y=4.365 //x2=3.82 //y2=7.585
cc_523 ( N_A_c_487_n N_VDD_c_983_n ) capacitor c=0.00746843f //x=2.34 //y=4.71 \
 //x2=3.82 //y2=7.585
cc_524 ( N_A_c_500_n N_VDD_c_983_n ) capacitor c=0.00801328f //x=8.855 \
 //y=4.21 //x2=3.82 //y2=7.585
cc_525 ( N_A_c_509_n N_VDD_c_983_n ) capacitor c=0.00250302f //x=2.38 \
 //y=4.885 //x2=3.82 //y2=7.585
cc_526 ( N_A_c_680_p N_VDD_c_983_n ) capacitor c=0.0117152f //x=2.745 \
 //y=4.975 //x2=3.82 //y2=7.585
cc_527 ( N_A_c_529_n N_VDD_c_983_n ) capacitor c=2.76772e-19 //x=2.38 \
 //y=4.885 //x2=3.82 //y2=7.585
cc_528 ( A N_VDD_c_989_n ) capacitor c=8.21577e-19 //x=9 //y=4.25 //x2=7.15 \
 //y2=7.585
cc_529 ( N_A_c_550_n N_VDD_c_989_n ) capacitor c=5.18027e-19 //x=9 //y=4.74 \
 //x2=7.15 //y2=7.585
cc_530 ( N_A_c_500_n N_VDD_c_989_n ) capacitor c=0.0135112f //x=8.855 //y=4.21 \
 //x2=7.15 //y2=7.585
cc_531 ( N_A_c_567_n N_VDD_c_989_n ) capacitor c=6.64651e-19 //x=9.02 \
 //y=4.885 //x2=7.15 //y2=7.585
cc_532 ( N_A_M8_noxref_g N_VDD_M7_noxref_d ) capacitor c=0.0127979f //x=2.38 \
 //y=6.205 //x2=2.015 //y2=5.205
cc_533 ( N_A_M9_noxref_g N_VDD_M9_noxref_d ) capacitor c=0.0463918f //x=2.82 \
 //y=6.205 //x2=2.895 //y2=5.205
cc_534 ( A N_noxref_6_c_1157_n ) capacitor c=3.71828e-19 //x=2.34 //y=4.25 \
 //x2=2.485 //y2=5.39
cc_535 ( N_A_c_484_n N_noxref_6_c_1157_n ) capacitor c=0.00150537f //x=2.34 \
 //y=4.365 //x2=2.485 //y2=5.39
cc_536 ( N_A_c_487_n N_noxref_6_c_1157_n ) capacitor c=0.0211744f //x=2.34 \
 //y=4.71 //x2=2.485 //y2=5.39
cc_537 ( N_A_c_509_n N_noxref_6_c_1157_n ) capacitor c=0.004587f //x=2.38 \
 //y=4.885 //x2=2.485 //y2=5.39
cc_538 ( N_A_M8_noxref_g N_noxref_6_c_1157_n ) capacitor c=0.00913391f \
 //x=2.38 //y=6.205 //x2=2.485 //y2=5.39
cc_539 ( N_A_c_529_n N_noxref_6_c_1157_n ) capacitor c=6.87087e-19 //x=2.38 \
 //y=4.885 //x2=2.485 //y2=5.39
cc_540 ( N_A_M9_noxref_g N_noxref_6_c_1159_n ) capacitor c=0.011434f //x=2.82 \
 //y=6.205 //x2=4.485 //y2=5.39
cc_541 ( N_A_c_484_n N_noxref_6_c_1162_n ) capacitor c=0.00145195f //x=2.34 \
 //y=4.365 //x2=2.715 //y2=5.39
cc_542 ( N_A_c_487_n N_noxref_6_c_1162_n ) capacitor c=0.00252287f //x=2.34 \
 //y=4.71 //x2=2.715 //y2=5.39
cc_543 ( N_A_M8_noxref_g N_noxref_6_c_1162_n ) capacitor c=7.72756e-19 \
 //x=2.38 //y=6.205 //x2=2.715 //y2=5.39
cc_544 ( N_A_M9_noxref_g N_noxref_6_c_1162_n ) capacitor c=8.30848e-19 \
 //x=2.82 //y=6.205 //x2=2.715 //y2=5.39
cc_545 ( N_A_c_484_n N_noxref_6_c_1178_n ) capacitor c=0.00167023f //x=2.34 \
 //y=4.365 //x2=2.6 //y2=5.39
cc_546 ( N_A_M8_noxref_g N_noxref_6_c_1178_n ) capacitor c=0.021802f //x=2.38 \
 //y=6.205 //x2=2.6 //y2=5.39
cc_547 ( N_A_M9_noxref_g N_noxref_6_c_1178_n ) capacitor c=0.0189969f //x=2.82 \
 //y=6.205 //x2=2.6 //y2=5.39
cc_548 ( N_A_c_680_p N_noxref_6_c_1178_n ) capacitor c=0.00449628f //x=2.745 \
 //y=4.975 //x2=2.6 //y2=5.39
cc_549 ( N_A_M8_noxref_g N_noxref_6_M8_noxref_d ) capacitor c=0.00122946f \
 //x=2.38 //y=6.205 //x2=2.455 //y2=5.205
cc_550 ( N_A_M9_noxref_g N_noxref_6_M8_noxref_d ) capacitor c=0.00123972f \
 //x=2.82 //y=6.205 //x2=2.455 //y2=5.205
cc_551 ( N_A_c_500_n N_noxref_7_c_1335_n ) capacitor c=0.0620335f //x=8.855 \
 //y=4.21 //x2=7.825 //y2=5.39
cc_552 ( N_A_c_500_n N_noxref_7_c_1345_n ) capacitor c=0.00869836f //x=8.855 \
 //y=4.21 //x2=6.035 //y2=5.39
cc_553 ( N_A_M16_noxref_g N_noxref_7_c_1361_n ) capacitor c=0.00793695f \
 //x=9.04 //y=6.205 //x2=9.57 //y2=7.09
cc_554 ( N_A_M17_noxref_g N_noxref_7_c_1361_n ) capacitor c=0.00937408f \
 //x=9.48 //y=6.205 //x2=9.57 //y2=7.09
cc_555 ( N_A_c_500_n N_noxref_7_c_1323_n ) capacitor c=0.0270459f //x=8.855 \
 //y=4.21 //x2=5.04 //y2=5.39
cc_556 ( N_A_M16_noxref_g N_noxref_7_c_1350_n ) capacitor c=0.00177216f \
 //x=9.04 //y=6.205 //x2=8.82 //y2=7.09
cc_557 ( N_A_M17_noxref_g N_noxref_7_c_1365_n ) capacitor c=0.00422002f \
 //x=9.48 //y=6.205 //x2=9.7 //y2=6.92
cc_558 ( N_A_c_500_n N_noxref_7_c_1351_n ) capacitor c=0.00183347f //x=8.855 \
 //y=4.21 //x2=5.92 //y2=5.39
cc_559 ( N_A_c_500_n N_noxref_7_c_1354_n ) capacitor c=2.11035e-19 //x=8.855 \
 //y=4.21 //x2=7.94 //y2=5.39
cc_560 ( N_A_M16_noxref_g N_noxref_7_M15_noxref_d ) capacitor c=0.0142133f \
 //x=9.04 //y=6.205 //x2=8.675 //y2=5.205
cc_561 ( N_A_c_588_n N_noxref_7_M15_noxref_d ) capacitor c=6.61209e-19 \
 //x=9.02 //y=4.885 //x2=8.675 //y2=5.205
cc_562 ( N_A_M17_noxref_g N_noxref_7_M17_noxref_d ) capacitor c=0.0365939f \
 //x=9.48 //y=6.205 //x2=9.555 //y2=5.205
cc_563 ( N_A_c_480_n N_GND_c_1522_n ) capacitor c=0.00214826f //x=2.34 \
 //y=2.375 //x2=4.915 //y2=0.175
cc_564 ( N_A_c_545_n N_GND_c_1523_n ) capacitor c=4.6307e-19 //x=9 //y=2.38 \
 //x2=9.74 //y2=0.18
cc_565 ( N_A_c_480_n N_GND_c_1466_n ) capacitor c=3.76947e-19 //x=2.34 \
 //y=2.375 //x2=3.65 //y2=0.175
cc_566 ( N_A_c_545_n N_GND_c_1502_n ) capacitor c=3.29013e-19 //x=9 //y=2.38 \
 //x2=9.74 //y2=0.18
cc_567 ( N_A_c_564_n N_GND_c_1502_n ) capacitor c=0.00231028f //x=9 //y=2.26 \
 //x2=9.74 //y2=0.18
cc_568 ( N_A_c_582_n N_GND_c_1502_n ) capacitor c=0.00278719f //x=9.41 \
 //y=1.585 //x2=9.74 //y2=0.18
cc_569 ( A N_GND_c_1474_n ) capacitor c=0.00617359f //x=2.34 //y=2.77 \
 //x2=3.82 //y2=0.175
cc_570 ( N_A_c_480_n N_GND_c_1474_n ) capacitor c=0.00295886f //x=2.34 \
 //y=2.375 //x2=3.82 //y2=0.175
cc_571 ( N_A_c_500_n N_GND_c_1474_n ) capacitor c=0.00357341f //x=8.855 \
 //y=4.21 //x2=3.82 //y2=0.175
cc_572 ( N_A_c_505_n N_GND_c_1474_n ) capacitor c=0.00245228f //x=2.34 \
 //y=2.26 //x2=3.82 //y2=0.175
cc_573 ( N_A_c_526_n N_GND_c_1474_n ) capacitor c=2.63786e-19 //x=2.34 \
 //y=2.26 //x2=3.82 //y2=0.175
cc_574 ( N_A_c_500_n N_GND_c_1506_n ) capacitor c=0.0025451f //x=8.855 \
 //y=4.21 //x2=7.15 //y2=0.175
cc_575 ( N_A_c_480_n N_noxref_9_c_1664_n ) capacitor c=7.20375e-19 //x=2.34 \
 //y=2.375 //x2=2.155 //y2=1.675
cc_576 ( N_A_c_484_n N_noxref_9_c_1664_n ) capacitor c=3.32532e-19 //x=2.34 \
 //y=4.365 //x2=2.155 //y2=1.675
cc_577 ( N_A_c_521_n N_noxref_9_c_1664_n ) capacitor c=0.00746306f //x=2.375 \
 //y=1.74 //x2=2.155 //y2=1.675
cc_578 ( N_A_c_526_n N_noxref_9_c_1664_n ) capacitor c=0.00175173f //x=2.34 \
 //y=2.26 //x2=2.155 //y2=1.675
cc_579 ( N_A_c_480_n N_noxref_9_c_1672_n ) capacitor c=0.00135256f //x=2.34 \
 //y=2.375 //x2=3.04 //y2=0.71
cc_580 ( N_A_c_505_n N_noxref_9_c_1672_n ) capacitor c=8.82141e-19 //x=2.34 \
 //y=2.26 //x2=3.04 //y2=0.71
cc_581 ( N_A_c_516_n N_noxref_9_c_1672_n ) capacitor c=0.0200392f //x=2.375 \
 //y=1.085 //x2=3.04 //y2=0.71
cc_582 ( N_A_c_524_n N_noxref_9_c_1672_n ) capacitor c=0.00825432f //x=2.905 \
 //y=1.085 //x2=3.04 //y2=0.71
cc_583 ( N_A_c_526_n N_noxref_9_c_1672_n ) capacitor c=2.1838e-19 //x=2.34 \
 //y=2.26 //x2=3.04 //y2=0.71
cc_584 ( N_A_c_500_n N_noxref_9_M0_noxref_s ) capacitor c=0.00170283f \
 //x=8.855 //y=4.21 //x2=1.05 //y2=0.545
cc_585 ( N_A_c_516_n N_noxref_9_M0_noxref_s ) capacitor c=0.00746306f \
 //x=2.375 //y=1.085 //x2=1.05 //y2=0.545
cc_586 ( N_A_c_521_n N_noxref_9_M0_noxref_s ) capacitor c=0.00211573f \
 //x=2.375 //y=1.74 //x2=1.05 //y2=0.545
cc_587 ( N_A_c_524_n N_noxref_9_M0_noxref_s ) capacitor c=0.014227f //x=2.905 \
 //y=1.085 //x2=1.05 //y2=0.545
cc_588 ( N_A_c_525_n N_noxref_9_M0_noxref_s ) capacitor c=0.00733269f \
 //x=2.905 //y=1.43 //x2=1.05 //y2=0.545
cc_589 ( N_A_c_743_p N_noxref_9_M0_noxref_s ) capacitor c=0.00392195f //x=2.34 \
 //y=2.095 //x2=1.05 //y2=0.545
cc_590 ( N_A_c_500_n N_noxref_10_c_1717_n ) capacitor c=0.00155386f //x=8.855 \
 //y=4.21 //x2=4.515 //y2=1.675
cc_591 ( N_A_c_500_n N_noxref_10_c_1718_n ) capacitor c=0.00692346f //x=8.855 \
 //y=4.21 //x2=5.4 //y2=1.76
cc_592 ( N_A_c_500_n N_noxref_10_c_1725_n ) capacitor c=0.00170283f //x=8.855 \
 //y=4.21 //x2=5.485 //y2=1.675
cc_593 ( N_A_c_500_n N_noxref_11_c_1787_n ) capacitor c=0.00782785f //x=8.855 \
 //y=4.21 //x2=8.73 //y2=1.76
cc_594 ( N_A_c_545_n N_noxref_11_c_1794_n ) capacitor c=7.26555e-19 //x=9 \
 //y=2.38 //x2=8.815 //y2=1.675
cc_595 ( N_A_c_549_n N_noxref_11_c_1794_n ) capacitor c=9.42734e-19 //x=9 \
 //y=4.37 //x2=8.815 //y2=1.675
cc_596 ( N_A_c_579_n N_noxref_11_c_1794_n ) capacitor c=0.00838141f //x=9.035 \
 //y=1.74 //x2=8.815 //y2=1.675
cc_597 ( N_A_c_585_n N_noxref_11_c_1794_n ) capacitor c=0.00175172f //x=9 \
 //y=2.26 //x2=8.815 //y2=1.675
cc_598 ( N_A_c_545_n N_noxref_11_c_1803_n ) capacitor c=5.72205e-19 //x=9 \
 //y=2.38 //x2=9.7 //y2=0.71
cc_599 ( N_A_c_564_n N_noxref_11_c_1803_n ) capacitor c=8.37879e-19 //x=9 \
 //y=2.26 //x2=9.7 //y2=0.71
cc_600 ( N_A_c_574_n N_noxref_11_c_1803_n ) capacitor c=0.0202024f //x=9.035 \
 //y=1.085 //x2=9.7 //y2=0.71
cc_601 ( N_A_c_583_n N_noxref_11_c_1803_n ) capacitor c=0.00825432f //x=9.565 \
 //y=1.085 //x2=9.7 //y2=0.71
cc_602 ( N_A_c_585_n N_noxref_11_c_1803_n ) capacitor c=2.1838e-19 //x=9 \
 //y=2.26 //x2=9.7 //y2=0.71
cc_603 ( N_A_c_574_n N_noxref_11_M4_noxref_s ) capacitor c=0.00838141f \
 //x=9.035 //y=1.085 //x2=7.71 //y2=0.545
cc_604 ( N_A_c_582_n N_noxref_11_M4_noxref_s ) capacitor c=0.00271091f \
 //x=9.41 //y=1.585 //x2=7.71 //y2=0.545
cc_605 ( N_A_c_583_n N_noxref_11_M4_noxref_s ) capacitor c=0.0142835f \
 //x=9.565 //y=1.085 //x2=7.71 //y2=0.545
cc_606 ( N_YN_c_830_n N_VDD_c_1037_n ) capacitor c=2.2621e-19 //x=9.655 \
 //y=5.39 //x2=9.74 //y2=7.58
cc_607 ( YN N_VDD_c_998_n ) capacitor c=0.0384099f //x=9.74 //y=2.4 //x2=9.74 \
 //y2=7.58
cc_608 ( N_YN_c_830_n N_VDD_c_998_n ) capacitor c=0.00158608f //x=9.655 \
 //y=5.39 //x2=9.74 //y2=7.58
cc_609 ( N_YN_c_841_n N_VDD_c_998_n ) capacitor c=0.00443612f //x=9.257 \
 //y=5.39 //x2=9.74 //y2=7.58
cc_610 ( N_YN_c_789_n N_VDD_c_998_n ) capacitor c=0.00512083f //x=8.38 \
 //y=5.56 //x2=9.74 //y2=7.58
cc_611 ( N_YN_c_851_n N_VDD_c_998_n ) capacitor c=0.0143625f //x=9.26 //y=5.56 \
 //x2=9.74 //y2=7.58
cc_612 ( YN N_VDD_c_989_n ) capacitor c=7.29276e-19 //x=9.74 //y=2.4 //x2=7.15 \
 //y2=7.585
cc_613 ( N_YN_c_789_n N_VDD_c_989_n ) capacitor c=0.00535462f //x=8.38 \
 //y=5.56 //x2=7.15 //y2=7.585
cc_614 ( N_YN_c_833_n N_noxref_6_c_1159_n ) capacitor c=2.92364e-19 //x=2.64 \
 //y=1.36 //x2=4.485 //y2=5.39
cc_615 ( N_YN_c_833_n N_noxref_6_c_1162_n ) capacitor c=3.81263e-19 //x=2.64 \
 //y=1.36 //x2=2.715 //y2=5.39
cc_616 ( N_YN_c_775_n N_noxref_7_c_1335_n ) capacitor c=0.0327245f //x=8.38 \
 //y=5.39 //x2=7.825 //y2=5.39
cc_617 ( N_YN_c_789_n N_noxref_7_c_1335_n ) capacitor c=0.00238429f //x=8.38 \
 //y=5.56 //x2=7.825 //y2=5.39
cc_618 ( N_YN_c_768_n N_noxref_7_c_1345_n ) capacitor c=7.85501e-19 //x=5.97 \
 //y=1.36 //x2=6.035 //y2=5.39
cc_619 ( N_YN_c_767_n N_noxref_7_c_1347_n ) capacitor c=0.00311493f //x=9.135 \
 //y=5.39 //x2=8.705 //y2=7.09
cc_620 ( N_YN_c_775_n N_noxref_7_c_1347_n ) capacitor c=0.00538798f //x=8.38 \
 //y=5.39 //x2=8.705 //y2=7.09
cc_621 ( N_YN_c_789_n N_noxref_7_c_1347_n ) capacitor c=0.00406191f //x=8.38 \
 //y=5.56 //x2=8.705 //y2=7.09
cc_622 ( N_YN_c_767_n N_noxref_7_c_1361_n ) capacitor c=0.00305195f //x=9.135 \
 //y=5.39 //x2=9.57 //y2=7.09
cc_623 ( N_YN_c_830_n N_noxref_7_c_1361_n ) capacitor c=0.00291085f //x=9.655 \
 //y=5.39 //x2=9.57 //y2=7.09
cc_624 ( N_YN_c_841_n N_noxref_7_c_1361_n ) capacitor c=0.00559082f //x=9.257 \
 //y=5.39 //x2=9.57 //y2=7.09
cc_625 ( N_YN_c_851_n N_noxref_7_c_1361_n ) capacitor c=0.00396177f //x=9.26 \
 //y=5.56 //x2=9.57 //y2=7.09
cc_626 ( N_YN_c_775_n N_noxref_7_c_1323_n ) capacitor c=0.00239626f //x=8.38 \
 //y=5.39 //x2=5.04 //y2=5.39
cc_627 ( N_YN_c_767_n N_noxref_7_c_1350_n ) capacitor c=0.00459659f //x=9.135 \
 //y=5.39 //x2=8.82 //y2=7.09
cc_628 ( N_YN_c_830_n N_noxref_7_c_1365_n ) capacitor c=0.00582813f //x=9.655 \
 //y=5.39 //x2=9.7 //y2=6.92
cc_629 ( N_YN_c_775_n N_noxref_7_c_1354_n ) capacitor c=0.010446f //x=8.38 \
 //y=5.39 //x2=7.94 //y2=5.39
cc_630 ( N_YN_c_789_n N_noxref_7_c_1354_n ) capacitor c=0.0649815f //x=8.38 \
 //y=5.56 //x2=7.94 //y2=5.39
cc_631 ( N_YN_c_767_n N_noxref_7_M15_noxref_d ) capacitor c=0.00678641f \
 //x=9.135 //y=5.39 //x2=8.675 //y2=5.205
cc_632 ( N_YN_c_841_n N_noxref_7_M15_noxref_d ) capacitor c=0.00184359f \
 //x=9.257 //y=5.39 //x2=8.675 //y2=5.205
cc_633 ( N_YN_c_789_n N_noxref_7_M15_noxref_d ) capacitor c=0.0476949f \
 //x=8.38 //y=5.56 //x2=8.675 //y2=5.205
cc_634 ( N_YN_c_851_n N_noxref_7_M15_noxref_d ) capacitor c=0.0473507f \
 //x=9.26 //y=5.56 //x2=8.675 //y2=5.205
cc_635 ( N_YN_c_830_n N_noxref_7_M17_noxref_d ) capacitor c=0.00936945f \
 //x=9.655 //y=5.39 //x2=9.555 //y2=5.205
cc_636 ( N_YN_c_841_n N_noxref_7_M17_noxref_d ) capacitor c=0.00184359f \
 //x=9.257 //y=5.39 //x2=9.555 //y2=5.205
cc_637 ( N_YN_c_851_n N_noxref_7_M17_noxref_d ) capacitor c=0.0473507f \
 //x=9.26 //y=5.56 //x2=9.555 //y2=5.205
cc_638 ( N_YN_c_833_n N_GND_c_1450_n ) capacitor c=0.00185513f //x=2.64 \
 //y=1.36 //x2=1.67 //y2=1.015
cc_639 ( N_YN_c_901_p N_GND_c_1450_n ) capacitor c=7.42708e-19 //x=2.805 \
 //y=1.405 //x2=1.67 //y2=1.015
cc_640 ( N_YN_M1_noxref_d N_GND_c_1450_n ) capacitor c=2.62581e-19 //x=2.45 \
 //y=1.085 //x2=1.67 //y2=1.015
cc_641 ( N_YN_c_833_n N_GND_c_1522_n ) capacitor c=0.00560741f //x=2.64 \
 //y=1.36 //x2=4.915 //y2=0.175
cc_642 ( N_YN_c_901_p N_GND_c_1522_n ) capacitor c=0.00701775f //x=2.805 \
 //y=1.405 //x2=4.915 //y2=0.175
cc_643 ( N_YN_c_760_n N_GND_c_1522_n ) capacitor c=0.113183f //x=5.84 \
 //y=1.405 //x2=4.915 //y2=0.175
cc_644 ( N_YN_M1_noxref_d N_GND_c_1522_n ) capacitor c=2.01013e-19 //x=2.45 \
 //y=1.085 //x2=4.915 //y2=0.175
cc_645 ( N_YN_c_833_n N_GND_c_1457_n ) capacitor c=3.05541e-19 //x=2.64 \
 //y=1.36 //x2=5 //y2=1.015
cc_646 ( N_YN_c_768_n N_GND_c_1457_n ) capacitor c=0.00263562f //x=5.97 \
 //y=1.36 //x2=5 //y2=1.015
cc_647 ( N_YN_c_901_p N_GND_c_1457_n ) capacitor c=4.33523e-19 //x=2.805 \
 //y=1.405 //x2=5 //y2=1.015
cc_648 ( N_YN_c_760_n N_GND_c_1457_n ) capacitor c=0.0203963f //x=5.84 \
 //y=1.405 //x2=5 //y2=1.015
cc_649 ( N_YN_M3_noxref_d N_GND_c_1457_n ) capacitor c=2.62581e-19 //x=5.78 \
 //y=1.085 //x2=5 //y2=1.015
cc_650 ( N_YN_c_768_n N_GND_c_1491_n ) capacitor c=0.00848351f //x=5.97 \
 //y=1.36 //x2=8.245 //y2=0.175
cc_651 ( N_YN_c_760_n N_GND_c_1491_n ) capacitor c=0.0330907f //x=5.84 \
 //y=1.405 //x2=8.245 //y2=0.175
cc_652 ( N_YN_c_914_p N_GND_c_1491_n ) capacitor c=0.00561615f //x=6.1 \
 //y=1.405 //x2=8.245 //y2=0.175
cc_653 ( N_YN_c_779_n N_GND_c_1491_n ) capacitor c=0.105627f //x=9.135 \
 //y=1.405 //x2=8.245 //y2=0.175
cc_654 ( N_YN_M3_noxref_d N_GND_c_1491_n ) capacitor c=2.01013e-19 //x=5.78 \
 //y=1.085 //x2=8.245 //y2=0.175
cc_655 ( N_YN_c_818_n N_GND_c_1494_n ) capacitor c=0.00199135f //x=9.3 \
 //y=1.535 //x2=8.33 //y2=1.02
cc_656 ( N_YN_c_768_n N_GND_c_1494_n ) capacitor c=8.32974e-19 //x=5.97 \
 //y=1.36 //x2=8.33 //y2=1.02
cc_657 ( N_YN_c_775_n N_GND_c_1494_n ) capacitor c=9.01285e-19 //x=8.38 \
 //y=5.39 //x2=8.33 //y2=1.02
cc_658 ( N_YN_c_846_n N_GND_c_1494_n ) capacitor c=8.08914e-19 //x=9.295 \
 //y=1.405 //x2=8.33 //y2=1.02
cc_659 ( N_YN_c_779_n N_GND_c_1494_n ) capacitor c=0.0204811f //x=9.135 \
 //y=1.405 //x2=8.33 //y2=1.02
cc_660 ( N_YN_M5_noxref_d N_GND_c_1494_n ) capacitor c=2.62581e-19 //x=9.11 \
 //y=1.085 //x2=8.33 //y2=1.02
cc_661 ( N_YN_c_818_n N_GND_c_1523_n ) capacitor c=0.00524308f //x=9.3 \
 //y=1.535 //x2=9.74 //y2=0.18
cc_662 ( N_YN_c_831_n N_GND_c_1523_n ) capacitor c=0.00622216f //x=9.655 \
 //y=1.825 //x2=9.74 //y2=0.18
cc_663 ( N_YN_c_846_n N_GND_c_1523_n ) capacitor c=0.00777895f //x=9.295 \
 //y=1.405 //x2=9.74 //y2=0.18
cc_664 ( N_YN_c_779_n N_GND_c_1523_n ) capacitor c=0.038217f //x=9.135 \
 //y=1.405 //x2=9.74 //y2=0.18
cc_665 ( N_YN_M5_noxref_d N_GND_c_1523_n ) capacitor c=2.01013e-19 //x=9.11 \
 //y=1.085 //x2=9.74 //y2=0.18
cc_666 ( N_YN_c_818_n N_GND_c_1502_n ) capacitor c=3.45583e-19 //x=9.3 \
 //y=1.535 //x2=9.74 //y2=0.18
cc_667 ( N_YN_c_828_n N_GND_c_1502_n ) capacitor c=0.00453826f //x=9.3 \
 //y=1.74 //x2=9.74 //y2=0.18
cc_668 ( N_YN_c_831_n N_GND_c_1502_n ) capacitor c=0.0412969f //x=9.655 \
 //y=1.825 //x2=9.74 //y2=0.18
cc_669 ( N_YN_c_833_n N_GND_c_1502_n ) capacitor c=3.45814e-19 //x=2.64 \
 //y=1.36 //x2=9.74 //y2=0.18
cc_670 ( N_YN_c_768_n N_GND_c_1502_n ) capacitor c=3.45583e-19 //x=5.97 \
 //y=1.36 //x2=9.74 //y2=0.18
cc_671 ( N_YN_M5_noxref_d N_GND_c_1502_n ) capacitor c=0.00166394f //x=9.11 \
 //y=1.085 //x2=9.74 //y2=0.18
cc_672 ( N_YN_c_760_n N_GND_c_1474_n ) capacitor c=0.0248964f //x=5.84 \
 //y=1.405 //x2=3.82 //y2=0.175
cc_673 ( N_YN_M1_noxref_d N_GND_c_1474_n ) capacitor c=0.00128657f //x=2.45 \
 //y=1.085 //x2=3.82 //y2=0.175
cc_674 ( YN N_GND_c_1506_n ) capacitor c=4.27507e-19 //x=9.74 //y=2.4 \
 //x2=7.15 //y2=0.175
cc_675 ( N_YN_c_779_n N_GND_c_1506_n ) capacitor c=0.0183315f //x=9.135 \
 //y=1.405 //x2=7.15 //y2=0.175
cc_676 ( N_YN_M3_noxref_d N_GND_c_1506_n ) capacitor c=0.00129152f //x=5.78 \
 //y=1.085 //x2=7.15 //y2=0.175
cc_677 ( N_YN_c_833_n N_noxref_9_c_1672_n ) capacitor c=0.00587436f //x=2.64 \
 //y=1.36 //x2=3.04 //y2=0.71
cc_678 ( N_YN_c_760_n N_noxref_9_c_1672_n ) capacitor c=0.00185906f //x=5.84 \
 //y=1.405 //x2=3.04 //y2=0.71
cc_679 ( N_YN_M1_noxref_d N_noxref_9_c_1672_n ) capacitor c=0.0136817f \
 //x=2.45 //y=1.085 //x2=3.04 //y2=0.71
cc_680 ( N_YN_c_833_n N_noxref_9_M0_noxref_s ) capacitor c=0.0131763f //x=2.64 \
 //y=1.36 //x2=1.05 //y2=0.545
cc_681 ( N_YN_c_760_n N_noxref_9_M0_noxref_s ) capacitor c=0.0123961f //x=5.84 \
 //y=1.405 //x2=1.05 //y2=0.545
cc_682 ( N_YN_M1_noxref_d N_noxref_9_M0_noxref_s ) capacitor c=0.0446285f \
 //x=2.45 //y=1.085 //x2=1.05 //y2=0.545
cc_683 ( N_YN_c_760_n N_noxref_10_c_1718_n ) capacitor c=0.0151405f //x=5.84 \
 //y=1.405 //x2=5.4 //y2=1.76
cc_684 ( N_YN_c_768_n N_noxref_10_c_1730_n ) capacitor c=0.0057298f //x=5.97 \
 //y=1.36 //x2=6.37 //y2=0.71
cc_685 ( N_YN_c_760_n N_noxref_10_c_1730_n ) capacitor c=0.00185906f //x=5.84 \
 //y=1.405 //x2=6.37 //y2=0.71
cc_686 ( N_YN_c_779_n N_noxref_10_c_1730_n ) capacitor c=0.00454743f //x=9.135 \
 //y=1.405 //x2=6.37 //y2=0.71
cc_687 ( N_YN_M3_noxref_d N_noxref_10_c_1730_n ) capacitor c=0.0130616f \
 //x=5.78 //y=1.085 //x2=6.37 //y2=0.71
cc_688 ( N_YN_c_768_n N_noxref_10_M2_noxref_s ) capacitor c=0.0103808f \
 //x=5.97 //y=1.36 //x2=4.38 //y2=0.545
cc_689 ( N_YN_c_760_n N_noxref_10_M2_noxref_s ) capacitor c=0.0271564f \
 //x=5.84 //y=1.405 //x2=4.38 //y2=0.545
cc_690 ( N_YN_c_779_n N_noxref_10_M2_noxref_s ) capacitor c=0.00742061f \
 //x=9.135 //y=1.405 //x2=4.38 //y2=0.545
cc_691 ( N_YN_M3_noxref_d N_noxref_10_M2_noxref_s ) capacitor c=0.0441243f \
 //x=5.78 //y=1.085 //x2=4.38 //y2=0.545
cc_692 ( N_YN_c_779_n N_noxref_11_c_1787_n ) capacitor c=0.0135245f //x=9.135 \
 //y=1.405 //x2=8.73 //y2=1.76
cc_693 ( N_YN_c_832_n N_noxref_11_c_1794_n ) capacitor c=0.00714695f //x=9.385 \
 //y=1.825 //x2=8.815 //y2=1.675
cc_694 ( N_YN_c_818_n N_noxref_11_c_1803_n ) capacitor c=0.00515582f //x=9.3 \
 //y=1.535 //x2=9.7 //y2=0.71
cc_695 ( N_YN_c_831_n N_noxref_11_c_1803_n ) capacitor c=0.00321358f //x=9.655 \
 //y=1.825 //x2=9.7 //y2=0.71
cc_696 ( N_YN_c_846_n N_noxref_11_c_1803_n ) capacitor c=0.00224828f //x=9.295 \
 //y=1.405 //x2=9.7 //y2=0.71
cc_697 ( N_YN_c_779_n N_noxref_11_c_1803_n ) capacitor c=0.00185838f //x=9.135 \
 //y=1.405 //x2=9.7 //y2=0.71
cc_698 ( N_YN_M5_noxref_d N_noxref_11_c_1803_n ) capacitor c=0.0135038f \
 //x=9.11 //y=1.085 //x2=9.7 //y2=0.71
cc_699 ( N_YN_c_818_n N_noxref_11_M4_noxref_s ) capacitor c=0.0117929f //x=9.3 \
 //y=1.535 //x2=7.71 //y2=0.545
cc_700 ( N_YN_c_828_n N_noxref_11_M4_noxref_s ) capacitor c=0.00791783f \
 //x=9.3 //y=1.74 //x2=7.71 //y2=0.545
cc_701 ( N_YN_c_831_n N_noxref_11_M4_noxref_s ) capacitor c=0.00794955f \
 //x=9.655 //y=1.825 //x2=7.71 //y2=0.545
cc_702 ( N_YN_c_846_n N_noxref_11_M4_noxref_s ) capacitor c=0.0090031f \
 //x=9.295 //y=1.405 //x2=7.71 //y2=0.545
cc_703 ( N_YN_c_779_n N_noxref_11_M4_noxref_s ) capacitor c=0.0219823f \
 //x=9.135 //y=1.405 //x2=7.71 //y2=0.545
cc_704 ( N_YN_M5_noxref_d N_noxref_11_M4_noxref_s ) capacitor c=0.0432761f \
 //x=9.11 //y=1.085 //x2=7.71 //y2=0.545
cc_705 ( N_VDD_c_1045_p N_noxref_6_c_1157_n ) capacitor c=4.78686e-19 \
 //x=2.075 //y=7.585 //x2=2.485 //y2=5.39
cc_706 ( N_VDD_c_969_n N_noxref_6_c_1157_n ) capacitor c=0.00476346f //x=2.16 \
 //y=7.035 //x2=2.485 //y2=5.39
cc_707 ( N_VDD_c_1047_p N_noxref_6_c_1157_n ) capacitor c=5.98042e-19 \
 //x=2.955 //y=7.585 //x2=2.485 //y2=5.39
cc_708 ( N_VDD_c_972_n N_noxref_6_c_1157_n ) capacitor c=0.00734603f //x=3.65 \
 //y=7.585 //x2=2.485 //y2=5.39
cc_709 ( N_VDD_M7_noxref_d N_noxref_6_c_1157_n ) capacitor c=0.00679741f \
 //x=2.015 //y=5.205 //x2=2.485 //y2=5.39
cc_710 ( N_VDD_c_1047_p N_noxref_6_c_1159_n ) capacitor c=5.52065e-19 \
 //x=2.955 //y=7.585 //x2=4.485 //y2=5.39
cc_711 ( N_VDD_c_1012_n N_noxref_6_c_1159_n ) capacitor c=0.0040485f //x=3.04 \
 //y=7.035 //x2=4.485 //y2=5.39
cc_712 ( N_VDD_c_1037_n N_noxref_6_c_1159_n ) capacitor c=0.0140204f //x=9.74 \
 //y=7.58 //x2=4.485 //y2=5.39
cc_713 ( N_VDD_c_972_n N_noxref_6_c_1159_n ) capacitor c=0.00703326f //x=3.65 \
 //y=7.585 //x2=4.485 //y2=5.39
cc_714 ( N_VDD_c_980_n N_noxref_6_c_1159_n ) capacitor c=0.00273146f //x=6.98 \
 //y=7.585 //x2=4.485 //y2=5.39
cc_715 ( N_VDD_c_983_n N_noxref_6_c_1159_n ) capacitor c=0.039327f //x=3.82 \
 //y=7.585 //x2=4.485 //y2=5.39
cc_716 ( N_VDD_M9_noxref_d N_noxref_6_c_1159_n ) capacitor c=0.0138307f \
 //x=2.895 //y=5.205 //x2=4.485 //y2=5.39
cc_717 ( N_VDD_c_975_n N_noxref_6_c_1162_n ) capacitor c=2.89592e-19 //x=1.23 \
 //y=7.58 //x2=2.715 //y2=5.39
cc_718 ( N_VDD_c_983_n N_noxref_6_c_1162_n ) capacitor c=3.35418e-19 //x=3.82 \
 //y=7.585 //x2=2.715 //y2=5.39
cc_719 ( N_VDD_M9_noxref_d N_noxref_6_c_1162_n ) capacitor c=6.02701e-19 \
 //x=2.895 //y=5.205 //x2=2.715 //y2=5.39
cc_720 ( N_VDD_c_998_n N_noxref_6_c_1163_n ) capacitor c=0.00222653f //x=9.74 \
 //y=7.58 //x2=5.36 //y2=7.09
cc_721 ( N_VDD_c_998_n N_noxref_6_c_1185_n ) capacitor c=0.00222653f //x=9.74 \
 //y=7.58 //x2=6.245 //y2=7.09
cc_722 ( N_VDD_M6_noxref_s N_noxref_6_c_1169_n ) capacitor c=0.0567031f \
 //x=1.145 //y=5.205 //x2=1.722 //y2=5.39
cc_723 ( N_VDD_c_1012_n N_noxref_6_c_1173_n ) capacitor c=0.00979658f //x=3.04 \
 //y=7.035 //x2=4.6 //y2=6.92
cc_724 ( N_VDD_c_1013_n N_noxref_6_c_1173_n ) capacitor c=0.00197255f //x=3.04 \
 //y=7.41 //x2=4.6 //y2=6.92
cc_725 ( N_VDD_c_1037_n N_noxref_6_c_1173_n ) capacitor c=0.172093f //x=9.74 \
 //y=7.58 //x2=4.6 //y2=6.92
cc_726 ( N_VDD_c_980_n N_noxref_6_c_1173_n ) capacitor c=0.0401324f //x=6.98 \
 //y=7.585 //x2=4.6 //y2=6.92
cc_727 ( N_VDD_c_998_n N_noxref_6_c_1173_n ) capacitor c=0.00112916f //x=9.74 \
 //y=7.58 //x2=4.6 //y2=6.92
cc_728 ( N_VDD_c_983_n N_noxref_6_c_1173_n ) capacitor c=0.00739076f //x=3.82 \
 //y=7.585 //x2=4.6 //y2=6.92
cc_729 ( N_VDD_c_998_n N_noxref_6_c_1174_n ) capacitor c=0.00112693f //x=9.74 \
 //y=7.58 //x2=5.477 //y2=7.09
cc_730 ( N_VDD_c_1037_n N_noxref_6_c_1188_n ) capacitor c=0.0021469f //x=9.74 \
 //y=7.58 //x2=6.36 //y2=6.92
cc_731 ( N_VDD_c_980_n N_noxref_6_c_1188_n ) capacitor c=4.35699e-19 //x=6.98 \
 //y=7.585 //x2=6.36 //y2=6.92
cc_732 ( N_VDD_c_998_n N_noxref_6_c_1188_n ) capacitor c=0.00112693f //x=9.74 \
 //y=7.58 //x2=6.36 //y2=6.92
cc_733 ( N_VDD_c_989_n N_noxref_6_c_1188_n ) capacitor c=0.00733935f //x=7.15 \
 //y=7.585 //x2=6.36 //y2=6.92
cc_734 ( N_VDD_c_967_n N_noxref_6_c_1175_n ) capacitor c=0.0041288f //x=1.28 \
 //y=7.035 //x2=1.72 //y2=5.56
cc_735 ( N_VDD_c_968_n N_noxref_6_c_1175_n ) capacitor c=0.00145923f //x=1.28 \
 //y=7.41 //x2=1.72 //y2=5.56
cc_736 ( N_VDD_c_1045_p N_noxref_6_c_1175_n ) capacitor c=0.00233559f \
 //x=2.075 //y=7.585 //x2=1.72 //y2=5.56
cc_737 ( N_VDD_c_969_n N_noxref_6_c_1175_n ) capacitor c=0.00220869f //x=2.16 \
 //y=7.035 //x2=1.72 //y2=5.56
cc_738 ( N_VDD_c_970_n N_noxref_6_c_1175_n ) capacitor c=0.00130452f //x=2.16 \
 //y=7.41 //x2=1.72 //y2=5.56
cc_739 ( N_VDD_c_972_n N_noxref_6_c_1175_n ) capacitor c=0.0112616f //x=3.65 \
 //y=7.585 //x2=1.72 //y2=5.56
cc_740 ( N_VDD_c_975_n N_noxref_6_c_1175_n ) capacitor c=0.00724623f //x=1.23 \
 //y=7.58 //x2=1.72 //y2=5.56
cc_741 ( N_VDD_c_998_n N_noxref_6_c_1175_n ) capacitor c=0.00141431f //x=9.74 \
 //y=7.58 //x2=1.72 //y2=5.56
cc_742 ( N_VDD_M6_noxref_s N_noxref_6_c_1175_n ) capacitor c=0.0916487f \
 //x=1.145 //y=5.205 //x2=1.72 //y2=5.56
cc_743 ( N_VDD_M7_noxref_d N_noxref_6_c_1175_n ) capacitor c=0.0724825f \
 //x=2.015 //y=5.205 //x2=1.72 //y2=5.56
cc_744 ( N_VDD_c_969_n N_noxref_6_c_1178_n ) capacitor c=0.00230229f //x=2.16 \
 //y=7.035 //x2=2.6 //y2=5.39
cc_745 ( N_VDD_c_970_n N_noxref_6_c_1178_n ) capacitor c=0.00130452f //x=2.16 \
 //y=7.41 //x2=2.6 //y2=5.39
cc_746 ( N_VDD_c_1047_p N_noxref_6_c_1178_n ) capacitor c=0.00233409f \
 //x=2.955 //y=7.585 //x2=2.6 //y2=5.39
cc_747 ( N_VDD_c_1012_n N_noxref_6_c_1178_n ) capacitor c=0.00225444f //x=3.04 \
 //y=7.035 //x2=2.6 //y2=5.39
cc_748 ( N_VDD_c_1013_n N_noxref_6_c_1178_n ) capacitor c=0.00130452f //x=3.04 \
 //y=7.41 //x2=2.6 //y2=5.39
cc_749 ( N_VDD_c_972_n N_noxref_6_c_1178_n ) capacitor c=0.0112507f //x=3.65 \
 //y=7.585 //x2=2.6 //y2=5.39
cc_750 ( N_VDD_c_975_n N_noxref_6_c_1178_n ) capacitor c=0.00105746f //x=1.23 \
 //y=7.58 //x2=2.6 //y2=5.39
cc_751 ( N_VDD_c_998_n N_noxref_6_c_1178_n ) capacitor c=0.00141642f //x=9.74 \
 //y=7.58 //x2=2.6 //y2=5.39
cc_752 ( N_VDD_c_983_n N_noxref_6_c_1178_n ) capacitor c=0.00924237f //x=3.82 \
 //y=7.585 //x2=2.6 //y2=5.39
cc_753 ( N_VDD_M6_noxref_s N_noxref_6_c_1178_n ) capacitor c=0.00151756f \
 //x=1.145 //y=5.205 //x2=2.6 //y2=5.39
cc_754 ( N_VDD_M7_noxref_d N_noxref_6_c_1178_n ) capacitor c=0.0724825f \
 //x=2.015 //y=5.205 //x2=2.6 //y2=5.39
cc_755 ( N_VDD_M9_noxref_d N_noxref_6_c_1178_n ) capacitor c=0.0886704f \
 //x=2.895 //y=5.205 //x2=2.6 //y2=5.39
cc_756 ( N_VDD_c_1037_n N_noxref_6_c_1179_n ) capacitor c=0.00204931f //x=9.74 \
 //y=7.58 //x2=4.6 //y2=5.39
cc_757 ( N_VDD_c_980_n N_noxref_6_c_1179_n ) capacitor c=0.00853641f //x=6.98 \
 //y=7.585 //x2=4.6 //y2=5.39
cc_758 ( N_VDD_c_998_n N_noxref_6_c_1179_n ) capacitor c=0.00100974f //x=9.74 \
 //y=7.58 //x2=4.6 //y2=5.39
cc_759 ( N_VDD_c_983_n N_noxref_6_c_1179_n ) capacitor c=0.0602194f //x=3.82 \
 //y=7.585 //x2=4.6 //y2=5.39
cc_760 ( N_VDD_M9_noxref_d N_noxref_6_c_1179_n ) capacitor c=0.00230512f \
 //x=2.895 //y=5.205 //x2=4.6 //y2=5.39
cc_761 ( N_VDD_c_967_n N_noxref_6_M6_noxref_d ) capacitor c=0.0391448f \
 //x=1.28 //y=7.035 //x2=1.575 //y2=5.205
cc_762 ( N_VDD_c_968_n N_noxref_6_M6_noxref_d ) capacitor c=0.00985747f \
 //x=1.28 //y=7.41 //x2=1.575 //y2=5.205
cc_763 ( N_VDD_c_1045_p N_noxref_6_M6_noxref_d ) capacitor c=0.0238892f \
 //x=2.075 //y=7.585 //x2=1.575 //y2=5.205
cc_764 ( N_VDD_c_969_n N_noxref_6_M6_noxref_d ) capacitor c=0.0380657f \
 //x=2.16 //y=7.035 //x2=1.575 //y2=5.205
cc_765 ( N_VDD_c_970_n N_noxref_6_M6_noxref_d ) capacitor c=0.0100015f \
 //x=2.16 //y=7.41 //x2=1.575 //y2=5.205
cc_766 ( N_VDD_c_972_n N_noxref_6_M6_noxref_d ) capacitor c=0.00302682f \
 //x=3.65 //y=7.585 //x2=1.575 //y2=5.205
cc_767 ( N_VDD_c_998_n N_noxref_6_M6_noxref_d ) capacitor c=0.00112916f \
 //x=9.74 //y=7.58 //x2=1.575 //y2=5.205
cc_768 ( N_VDD_M6_noxref_s N_noxref_6_M6_noxref_d ) capacitor c=0.00271779f \
 //x=1.145 //y=5.205 //x2=1.575 //y2=5.205
cc_769 ( N_VDD_M7_noxref_d N_noxref_6_M6_noxref_d ) capacitor c=0.00360728f \
 //x=2.015 //y=5.205 //x2=1.575 //y2=5.205
cc_770 ( N_VDD_c_969_n N_noxref_6_M8_noxref_d ) capacitor c=0.0379915f \
 //x=2.16 //y=7.035 //x2=2.455 //y2=5.205
cc_771 ( N_VDD_c_970_n N_noxref_6_M8_noxref_d ) capacitor c=0.0100015f \
 //x=2.16 //y=7.41 //x2=2.455 //y2=5.205
cc_772 ( N_VDD_c_1047_p N_noxref_6_M8_noxref_d ) capacitor c=0.0230655f \
 //x=2.955 //y=7.585 //x2=2.455 //y2=5.205
cc_773 ( N_VDD_c_1012_n N_noxref_6_M8_noxref_d ) capacitor c=0.0379915f \
 //x=3.04 //y=7.035 //x2=2.455 //y2=5.205
cc_774 ( N_VDD_c_1013_n N_noxref_6_M8_noxref_d ) capacitor c=0.0100015f \
 //x=3.04 //y=7.41 //x2=2.455 //y2=5.205
cc_775 ( N_VDD_c_972_n N_noxref_6_M8_noxref_d ) capacitor c=0.00283306f \
 //x=3.65 //y=7.585 //x2=2.455 //y2=5.205
cc_776 ( N_VDD_c_998_n N_noxref_6_M8_noxref_d ) capacitor c=0.00112916f \
 //x=9.74 //y=7.58 //x2=2.455 //y2=5.205
cc_777 ( N_VDD_M7_noxref_d N_noxref_6_M8_noxref_d ) capacitor c=0.00351276f \
 //x=2.015 //y=5.205 //x2=2.455 //y2=5.205
cc_778 ( N_VDD_M9_noxref_d N_noxref_6_M8_noxref_d ) capacitor c=0.00355849f \
 //x=2.895 //y=5.205 //x2=2.455 //y2=5.205
cc_779 ( N_VDD_c_1037_n N_noxref_6_M11_noxref_d ) capacitor c=0.00206569f \
 //x=9.74 //y=7.58 //x2=5.335 //y2=5.205
cc_780 ( N_VDD_c_980_n N_noxref_6_M11_noxref_d ) capacitor c=0.00856914f \
 //x=6.98 //y=7.585 //x2=5.335 //y2=5.205
cc_781 ( N_VDD_c_998_n N_noxref_6_M11_noxref_d ) capacitor c=0.00100487f \
 //x=9.74 //y=7.58 //x2=5.335 //y2=5.205
cc_782 ( N_VDD_c_1037_n N_noxref_6_M13_noxref_d ) capacitor c=0.00206569f \
 //x=9.74 //y=7.58 //x2=6.215 //y2=5.205
cc_783 ( N_VDD_c_980_n N_noxref_6_M13_noxref_d ) capacitor c=0.00856914f \
 //x=6.98 //y=7.585 //x2=6.215 //y2=5.205
cc_784 ( N_VDD_c_998_n N_noxref_6_M13_noxref_d ) capacitor c=0.00100487f \
 //x=9.74 //y=7.58 //x2=6.215 //y2=5.205
cc_785 ( N_VDD_c_989_n N_noxref_6_M13_noxref_d ) capacitor c=0.0448255f \
 //x=7.15 //y=7.585 //x2=6.215 //y2=5.205
cc_786 ( N_VDD_c_1037_n N_noxref_7_c_1335_n ) capacitor c=0.0143613f //x=9.74 \
 //y=7.58 //x2=7.825 //y2=5.39
cc_787 ( N_VDD_c_980_n N_noxref_7_c_1335_n ) capacitor c=0.00398048f //x=6.98 \
 //y=7.585 //x2=7.825 //y2=5.39
cc_788 ( N_VDD_c_998_n N_noxref_7_c_1335_n ) capacitor c=0.00275849f //x=9.74 \
 //y=7.58 //x2=7.825 //y2=5.39
cc_789 ( N_VDD_c_989_n N_noxref_7_c_1335_n ) capacitor c=0.042287f //x=7.15 \
 //y=7.585 //x2=7.825 //y2=5.39
cc_790 ( N_VDD_c_989_n N_noxref_7_c_1345_n ) capacitor c=6.67754e-19 //x=7.15 \
 //y=7.585 //x2=6.035 //y2=5.39
cc_791 ( N_VDD_c_998_n N_noxref_7_c_1347_n ) capacitor c=0.00222653f //x=9.74 \
 //y=7.58 //x2=8.705 //y2=7.09
cc_792 ( N_VDD_c_998_n N_noxref_7_c_1361_n ) capacitor c=0.00222653f //x=9.74 \
 //y=7.58 //x2=9.57 //y2=7.09
cc_793 ( N_VDD_M6_noxref_s N_noxref_7_c_1323_n ) capacitor c=4.98377e-19 \
 //x=1.145 //y=5.205 //x2=5.04 //y2=5.39
cc_794 ( N_VDD_c_1037_n N_noxref_7_c_1349_n ) capacitor c=0.172182f //x=9.74 \
 //y=7.58 //x2=7.94 //y2=6.92
cc_795 ( N_VDD_c_998_n N_noxref_7_c_1349_n ) capacitor c=0.0403896f //x=9.74 \
 //y=7.58 //x2=7.94 //y2=6.92
cc_796 ( N_VDD_c_989_n N_noxref_7_c_1349_n ) capacitor c=0.00730382f //x=7.15 \
 //y=7.585 //x2=7.94 //y2=6.92
cc_797 ( N_VDD_c_998_n N_noxref_7_c_1350_n ) capacitor c=0.00112693f //x=9.74 \
 //y=7.58 //x2=8.82 //y2=7.09
cc_798 ( N_VDD_c_1037_n N_noxref_7_c_1365_n ) capacitor c=0.00215296f //x=9.74 \
 //y=7.58 //x2=9.7 //y2=6.92
cc_799 ( N_VDD_c_998_n N_noxref_7_c_1365_n ) capacitor c=0.0120669f //x=9.74 \
 //y=7.58 //x2=9.7 //y2=6.92
cc_800 ( N_VDD_c_980_n N_noxref_7_c_1329_n ) capacitor c=0.00475693f //x=6.98 \
 //y=7.585 //x2=5.04 //y2=5.56
cc_801 ( N_VDD_c_998_n N_noxref_7_c_1329_n ) capacitor c=2.32853e-19 //x=9.74 \
 //y=7.58 //x2=5.04 //y2=5.56
cc_802 ( N_VDD_c_983_n N_noxref_7_c_1329_n ) capacitor c=0.00539528f //x=3.82 \
 //y=7.585 //x2=5.04 //y2=5.56
cc_803 ( N_VDD_c_980_n N_noxref_7_c_1351_n ) capacitor c=0.00489838f //x=6.98 \
 //y=7.585 //x2=5.92 //y2=5.39
cc_804 ( N_VDD_c_998_n N_noxref_7_c_1351_n ) capacitor c=2.33392e-19 //x=9.74 \
 //y=7.58 //x2=5.92 //y2=5.39
cc_805 ( N_VDD_c_989_n N_noxref_7_c_1351_n ) capacitor c=0.0122289f //x=7.15 \
 //y=7.585 //x2=5.92 //y2=5.39
cc_806 ( N_VDD_c_1037_n N_noxref_7_c_1354_n ) capacitor c=0.00204931f //x=9.74 \
 //y=7.58 //x2=7.94 //y2=5.39
cc_807 ( N_VDD_c_998_n N_noxref_7_c_1354_n ) capacitor c=0.0105666f //x=9.74 \
 //y=7.58 //x2=7.94 //y2=5.39
cc_808 ( N_VDD_c_989_n N_noxref_7_c_1354_n ) capacitor c=0.0592579f //x=7.15 \
 //y=7.585 //x2=7.94 //y2=5.39
cc_809 ( N_VDD_c_1037_n N_noxref_7_M15_noxref_d ) capacitor c=0.00206569f \
 //x=9.74 //y=7.58 //x2=8.675 //y2=5.205
cc_810 ( N_VDD_c_998_n N_noxref_7_M15_noxref_d ) capacitor c=0.00957401f \
 //x=9.74 //y=7.58 //x2=8.675 //y2=5.205
cc_811 ( N_VDD_c_1037_n N_noxref_7_M17_noxref_d ) capacitor c=0.00206569f \
 //x=9.74 //y=7.58 //x2=9.555 //y2=5.205
cc_812 ( N_VDD_c_998_n N_noxref_7_M17_noxref_d ) capacitor c=0.0547f //x=9.74 \
 //y=7.58 //x2=9.555 //y2=5.205
cc_813 ( N_VDD_c_975_n N_GND_c_1467_n ) capacitor c=0.00989514f //x=1.23 \
 //y=7.58 //x2=1.23 //y2=0.18
cc_814 ( N_VDD_c_998_n N_GND_c_1502_n ) capacitor c=0.00989514f //x=9.74 \
 //y=7.58 //x2=9.74 //y2=0.18
cc_815 ( N_VDD_c_983_n N_GND_c_1474_n ) capacitor c=0.00655202f //x=3.82 \
 //y=7.585 //x2=3.82 //y2=0.175
cc_816 ( N_VDD_c_989_n N_GND_c_1506_n ) capacitor c=0.00684375f //x=7.15 \
 //y=7.585 //x2=7.15 //y2=0.175
cc_817 ( N_noxref_6_c_1163_n N_noxref_7_c_1322_n ) capacitor c=0.00321697f \
 //x=5.36 //y=7.09 //x2=5.805 //y2=5.39
cc_818 ( N_noxref_6_c_1185_n N_noxref_7_c_1322_n ) capacitor c=0.00331901f \
 //x=6.245 //y=7.09 //x2=5.805 //y2=5.39
cc_819 ( N_noxref_6_c_1174_n N_noxref_7_c_1322_n ) capacitor c=0.0047685f \
 //x=5.477 //y=7.09 //x2=5.805 //y2=5.39
cc_820 ( N_noxref_6_M11_noxref_d N_noxref_7_c_1322_n ) capacitor c=0.00678641f \
 //x=5.335 //y=5.205 //x2=5.805 //y2=5.39
cc_821 ( N_noxref_6_c_1185_n N_noxref_7_c_1335_n ) capacitor c=0.00331901f \
 //x=6.245 //y=7.09 //x2=7.825 //y2=5.39
cc_822 ( N_noxref_6_c_1188_n N_noxref_7_c_1335_n ) capacitor c=0.00466077f \
 //x=6.36 //y=6.92 //x2=7.825 //y2=5.39
cc_823 ( N_noxref_6_M13_noxref_d N_noxref_7_c_1335_n ) capacitor c=0.00491419f \
 //x=6.215 //y=5.205 //x2=7.825 //y2=5.39
cc_824 ( N_noxref_6_c_1159_n N_noxref_7_c_1345_n ) capacitor c=9.81e-19 \
 //x=4.485 //y=5.39 //x2=6.035 //y2=5.39
cc_825 ( N_noxref_6_c_1185_n N_noxref_7_c_1345_n ) capacitor c=0.00460276f \
 //x=6.245 //y=7.09 //x2=6.035 //y2=5.39
cc_826 ( N_noxref_6_c_1159_n N_noxref_7_c_1323_n ) capacitor c=0.033638f \
 //x=4.485 //y=5.39 //x2=5.04 //y2=5.39
cc_827 ( N_noxref_6_c_1163_n N_noxref_7_c_1323_n ) capacitor c=0.0048075f \
 //x=5.36 //y=7.09 //x2=5.04 //y2=5.39
cc_828 ( N_noxref_6_c_1169_n N_noxref_7_c_1323_n ) capacitor c=0.00241473f \
 //x=1.722 //y=5.39 //x2=5.04 //y2=5.39
cc_829 ( N_noxref_6_c_1179_n N_noxref_7_c_1323_n ) capacitor c=0.0100239f \
 //x=4.6 //y=5.39 //x2=5.04 //y2=5.39
cc_830 ( N_noxref_6_c_1174_n N_noxref_7_c_1349_n ) capacitor c=2.01993e-19 \
 //x=5.477 //y=7.09 //x2=7.94 //y2=6.92
cc_831 ( N_noxref_6_c_1188_n N_noxref_7_c_1349_n ) capacitor c=0.0130503f \
 //x=6.36 //y=6.92 //x2=7.94 //y2=6.92
cc_832 ( N_noxref_6_c_1188_n N_noxref_7_c_1350_n ) capacitor c=2.01769e-19 \
 //x=6.36 //y=6.92 //x2=8.82 //y2=7.09
cc_833 ( N_noxref_6_c_1159_n N_noxref_7_c_1329_n ) capacitor c=0.00238961f \
 //x=4.485 //y=5.39 //x2=5.04 //y2=5.56
cc_834 ( N_noxref_6_c_1163_n N_noxref_7_c_1329_n ) capacitor c=0.00406191f \
 //x=5.36 //y=7.09 //x2=5.04 //y2=5.56
cc_835 ( N_noxref_6_c_1179_n N_noxref_7_c_1329_n ) capacitor c=0.0651197f \
 //x=4.6 //y=5.39 //x2=5.04 //y2=5.56
cc_836 ( N_noxref_6_M11_noxref_d N_noxref_7_c_1329_n ) capacitor c=0.0479141f \
 //x=5.335 //y=5.205 //x2=5.04 //y2=5.56
cc_837 ( N_noxref_6_c_1159_n N_noxref_7_c_1351_n ) capacitor c=5.61108e-19 \
 //x=4.485 //y=5.39 //x2=5.92 //y2=5.39
cc_838 ( N_noxref_6_c_1185_n N_noxref_7_c_1351_n ) capacitor c=0.00424767f \
 //x=6.245 //y=7.09 //x2=5.92 //y2=5.39
cc_839 ( N_noxref_6_c_1179_n N_noxref_7_c_1351_n ) capacitor c=0.00287683f \
 //x=4.6 //y=5.39 //x2=5.92 //y2=5.39
cc_840 ( N_noxref_6_M11_noxref_d N_noxref_7_c_1351_n ) capacitor c=0.0479141f \
 //x=5.335 //y=5.205 //x2=5.92 //y2=5.39
cc_841 ( N_noxref_6_M13_noxref_d N_noxref_7_c_1351_n ) capacitor c=0.0479025f \
 //x=6.215 //y=5.205 //x2=5.92 //y2=5.39
cc_842 ( N_noxref_6_M13_noxref_d N_noxref_7_c_1354_n ) capacitor c=0.00143256f \
 //x=6.215 //y=5.205 //x2=7.94 //y2=5.39
cc_843 ( N_noxref_6_c_1169_n N_GND_c_1450_n ) capacitor c=0.00133245f \
 //x=1.722 //y=5.39 //x2=1.67 //y2=1.015
cc_844 ( N_noxref_6_c_1159_n N_GND_c_1474_n ) capacitor c=0.00146427f \
 //x=4.485 //y=5.39 //x2=3.82 //y2=0.175
cc_845 ( N_noxref_6_c_1179_n N_noxref_10_c_1717_n ) capacitor c=0.00112302f \
 //x=4.6 //y=5.39 //x2=4.515 //y2=1.675
cc_846 ( N_noxref_7_c_1323_n N_GND_c_1457_n ) capacitor c=2.10485e-19 //x=5.04 \
 //y=5.39 //x2=5 //y2=1.015
cc_847 ( N_noxref_7_c_1335_n N_GND_c_1506_n ) capacitor c=0.00146427f \
 //x=7.825 //y=5.39 //x2=7.15 //y2=0.175
cc_848 ( N_GND_c_1448_n N_noxref_9_c_1656_n ) capacitor c=0.00260651f \
 //x=1.585 //y=0.175 //x2=2.07 //y2=1.76
cc_849 ( N_GND_c_1450_n N_noxref_9_c_1656_n ) capacitor c=0.0049241f //x=1.67 \
 //y=1.015 //x2=2.07 //y2=1.76
cc_850 ( N_GND_c_1522_n N_noxref_9_c_1656_n ) capacitor c=7.74325e-19 \
 //x=4.915 //y=0.175 //x2=2.07 //y2=1.76
cc_851 ( N_GND_c_1466_n N_noxref_9_c_1656_n ) capacitor c=0.0040842f //x=3.65 \
 //y=0.175 //x2=2.07 //y2=1.76
cc_852 ( N_GND_M0_noxref_d N_noxref_9_c_1656_n ) capacitor c=0.00579662f \
 //x=1.48 //y=1.045 //x2=2.07 //y2=1.76
cc_853 ( N_GND_c_1450_n N_noxref_9_c_1694_n ) capacitor c=0.0120153f //x=1.67 \
 //y=1.015 //x2=2.155 //y2=0.795
cc_854 ( N_GND_c_1522_n N_noxref_9_c_1694_n ) capacitor c=0.00645839f \
 //x=4.915 //y=0.175 //x2=2.155 //y2=0.795
cc_855 ( N_GND_c_1466_n N_noxref_9_c_1694_n ) capacitor c=0.0146613f //x=3.65 \
 //y=0.175 //x2=2.155 //y2=0.795
cc_856 ( N_GND_c_1467_n N_noxref_9_c_1694_n ) capacitor c=0.00283732f //x=1.23 \
 //y=0.18 //x2=2.155 //y2=0.795
cc_857 ( N_GND_c_1502_n N_noxref_9_c_1694_n ) capacitor c=0.00145873f //x=9.74 \
 //y=0.18 //x2=2.155 //y2=0.795
cc_858 ( N_GND_c_1474_n N_noxref_9_c_1694_n ) capacitor c=2.99356e-19 //x=3.82 \
 //y=0.175 //x2=2.155 //y2=0.795
cc_859 ( N_GND_c_1467_n N_noxref_9_c_1664_n ) capacitor c=2.91423e-19 //x=1.23 \
 //y=0.18 //x2=2.155 //y2=1.675
cc_860 ( N_GND_c_1522_n N_noxref_9_c_1672_n ) capacitor c=0.0109835f //x=4.915 \
 //y=0.175 //x2=3.04 //y2=0.71
cc_861 ( N_GND_c_1466_n N_noxref_9_c_1672_n ) capacitor c=0.0375489f //x=3.65 \
 //y=0.175 //x2=3.04 //y2=0.71
cc_862 ( N_GND_c_1502_n N_noxref_9_c_1672_n ) capacitor c=0.00198596f //x=9.74 \
 //y=0.18 //x2=3.04 //y2=0.71
cc_863 ( N_GND_c_1522_n N_noxref_9_c_1704_n ) capacitor c=0.0045077f //x=4.915 \
 //y=0.175 //x2=3.125 //y2=0.795
cc_864 ( N_GND_c_1466_n N_noxref_9_c_1704_n ) capacitor c=0.0144994f //x=3.65 \
 //y=0.175 //x2=3.125 //y2=0.795
cc_865 ( N_GND_c_1502_n N_noxref_9_c_1704_n ) capacitor c=0.00145873f //x=9.74 \
 //y=0.18 //x2=3.125 //y2=0.795
cc_866 ( N_GND_c_1474_n N_noxref_9_c_1704_n ) capacitor c=0.0540895f //x=3.82 \
 //y=0.175 //x2=3.125 //y2=0.795
cc_867 ( N_GND_c_1448_n N_noxref_9_M0_noxref_s ) capacitor c=0.00282008f \
 //x=1.585 //y=0.175 //x2=1.05 //y2=0.545
cc_868 ( N_GND_c_1450_n N_noxref_9_M0_noxref_s ) capacitor c=0.0302994f \
 //x=1.67 //y=1.015 //x2=1.05 //y2=0.545
cc_869 ( N_GND_c_1466_n N_noxref_9_M0_noxref_s ) capacitor c=0.014658f \
 //x=3.65 //y=0.175 //x2=1.05 //y2=0.545
cc_870 ( N_GND_c_1467_n N_noxref_9_M0_noxref_s ) capacitor c=0.0568002f \
 //x=1.23 //y=0.18 //x2=1.05 //y2=0.545
cc_871 ( N_GND_c_1502_n N_noxref_9_M0_noxref_s ) capacitor c=0.00145873f \
 //x=9.74 //y=0.18 //x2=1.05 //y2=0.545
cc_872 ( N_GND_c_1474_n N_noxref_9_M0_noxref_s ) capacitor c=0.00250794f \
 //x=3.82 //y=0.175 //x2=1.05 //y2=0.545
cc_873 ( N_GND_M0_noxref_d N_noxref_9_M0_noxref_s ) capacitor c=0.0271433f \
 //x=1.48 //y=1.045 //x2=1.05 //y2=0.545
cc_874 ( N_GND_c_1522_n N_noxref_10_c_1718_n ) capacitor c=0.0010065f \
 //x=4.915 //y=0.175 //x2=5.4 //y2=1.76
cc_875 ( N_GND_c_1457_n N_noxref_10_c_1718_n ) capacitor c=0.00375883f //x=5 \
 //y=1.015 //x2=5.4 //y2=1.76
cc_876 ( N_GND_c_1491_n N_noxref_10_c_1718_n ) capacitor c=7.45647e-19 \
 //x=8.245 //y=0.175 //x2=5.4 //y2=1.76
cc_877 ( N_GND_c_1473_n N_noxref_10_c_1718_n ) capacitor c=0.00358266f \
 //x=6.98 //y=0.175 //x2=5.4 //y2=1.76
cc_878 ( N_GND_M2_noxref_d N_noxref_10_c_1718_n ) capacitor c=0.00750663f \
 //x=4.81 //y=1.045 //x2=5.4 //y2=1.76
cc_879 ( N_GND_c_1457_n N_noxref_10_c_1758_n ) capacitor c=0.0120153f //x=5 \
 //y=1.015 //x2=5.485 //y2=0.795
cc_880 ( N_GND_c_1491_n N_noxref_10_c_1758_n ) capacitor c=0.0045077f \
 //x=8.245 //y=0.175 //x2=5.485 //y2=0.795
cc_881 ( N_GND_c_1473_n N_noxref_10_c_1758_n ) capacitor c=0.0144994f //x=6.98 \
 //y=0.175 //x2=5.485 //y2=0.795
cc_882 ( N_GND_c_1502_n N_noxref_10_c_1758_n ) capacitor c=0.00145873f \
 //x=9.74 //y=0.18 //x2=5.485 //y2=0.795
cc_883 ( N_GND_c_1474_n N_noxref_10_c_1758_n ) capacitor c=0.00226009f \
 //x=3.82 //y=0.175 //x2=5.485 //y2=0.795
cc_884 ( N_GND_c_1506_n N_noxref_10_c_1758_n ) capacitor c=2.99356e-19 \
 //x=7.15 //y=0.175 //x2=5.485 //y2=0.795
cc_885 ( N_GND_c_1474_n N_noxref_10_c_1725_n ) capacitor c=2.91423e-19 \
 //x=3.82 //y=0.175 //x2=5.485 //y2=1.675
cc_886 ( N_GND_c_1491_n N_noxref_10_c_1730_n ) capacitor c=0.0122738f \
 //x=8.245 //y=0.175 //x2=6.37 //y2=0.71
cc_887 ( N_GND_c_1473_n N_noxref_10_c_1730_n ) capacitor c=0.0374965f //x=6.98 \
 //y=0.175 //x2=6.37 //y2=0.71
cc_888 ( N_GND_c_1502_n N_noxref_10_c_1730_n ) capacitor c=0.00198596f \
 //x=9.74 //y=0.18 //x2=6.37 //y2=0.71
cc_889 ( N_GND_c_1491_n N_noxref_10_c_1768_n ) capacitor c=0.00251499f \
 //x=8.245 //y=0.175 //x2=6.455 //y2=0.795
cc_890 ( N_GND_c_1473_n N_noxref_10_c_1768_n ) capacitor c=0.0144994f //x=6.98 \
 //y=0.175 //x2=6.455 //y2=0.795
cc_891 ( N_GND_c_1502_n N_noxref_10_c_1768_n ) capacitor c=0.00145873f \
 //x=9.74 //y=0.18 //x2=6.455 //y2=0.795
cc_892 ( N_GND_c_1506_n N_noxref_10_c_1768_n ) capacitor c=0.0528624f //x=7.15 \
 //y=0.175 //x2=6.455 //y2=0.795
cc_893 ( N_GND_c_1522_n N_noxref_10_M2_noxref_s ) capacitor c=0.0045077f \
 //x=4.915 //y=0.175 //x2=4.38 //y2=0.545
cc_894 ( N_GND_c_1457_n N_noxref_10_M2_noxref_s ) capacitor c=0.0251079f //x=5 \
 //y=1.015 //x2=4.38 //y2=0.545
cc_895 ( N_GND_c_1473_n N_noxref_10_M2_noxref_s ) capacitor c=0.0144994f \
 //x=6.98 //y=0.175 //x2=4.38 //y2=0.545
cc_896 ( N_GND_c_1502_n N_noxref_10_M2_noxref_s ) capacitor c=0.00145873f \
 //x=9.74 //y=0.18 //x2=4.38 //y2=0.545
cc_897 ( N_GND_c_1474_n N_noxref_10_M2_noxref_s ) capacitor c=0.0536459f \
 //x=3.82 //y=0.175 //x2=4.38 //y2=0.545
cc_898 ( N_GND_c_1506_n N_noxref_10_M2_noxref_s ) capacitor c=0.00291802f \
 //x=7.15 //y=0.175 //x2=4.38 //y2=0.545
cc_899 ( N_GND_M2_noxref_d N_noxref_10_M2_noxref_s ) capacitor c=0.0296569f \
 //x=4.81 //y=1.045 //x2=4.38 //y2=0.545
cc_900 ( N_GND_c_1491_n N_noxref_11_c_1787_n ) capacitor c=9.5216e-19 \
 //x=8.245 //y=0.175 //x2=8.73 //y2=1.76
cc_901 ( N_GND_c_1494_n N_noxref_11_c_1787_n ) capacitor c=0.0048201f //x=8.33 \
 //y=1.02 //x2=8.73 //y2=1.76
cc_902 ( N_GND_c_1523_n N_noxref_11_c_1787_n ) capacitor c=0.00204479f \
 //x=9.74 //y=0.18 //x2=8.73 //y2=1.76
cc_903 ( N_GND_c_1502_n N_noxref_11_c_1787_n ) capacitor c=0.00357558f \
 //x=9.74 //y=0.18 //x2=8.73 //y2=1.76
cc_904 ( N_GND_M4_noxref_d N_noxref_11_c_1787_n ) capacitor c=0.00579662f \
 //x=8.14 //y=1.045 //x2=8.73 //y2=1.76
cc_905 ( N_GND_c_1494_n N_noxref_11_c_1829_n ) capacitor c=0.0167642f //x=8.33 \
 //y=1.02 //x2=8.815 //y2=0.795
cc_906 ( N_GND_c_1523_n N_noxref_11_c_1829_n ) capacitor c=0.00310354f \
 //x=9.74 //y=0.18 //x2=8.815 //y2=0.795
cc_907 ( N_GND_c_1502_n N_noxref_11_c_1829_n ) capacitor c=0.0161799f //x=9.74 \
 //y=0.18 //x2=8.815 //y2=0.795
cc_908 ( N_GND_c_1506_n N_noxref_11_c_1829_n ) capacitor c=0.00225073f \
 //x=7.15 //y=0.175 //x2=8.815 //y2=0.795
cc_909 ( N_GND_c_1506_n N_noxref_11_c_1794_n ) capacitor c=2.86846e-19 \
 //x=7.15 //y=0.175 //x2=8.815 //y2=1.675
cc_910 ( N_GND_c_1523_n N_noxref_11_c_1803_n ) capacitor c=0.00940517f \
 //x=9.74 //y=0.18 //x2=9.7 //y2=0.71
cc_911 ( N_GND_c_1502_n N_noxref_11_c_1803_n ) capacitor c=0.0395033f //x=9.74 \
 //y=0.18 //x2=9.7 //y2=0.71
cc_912 ( N_GND_c_1523_n N_noxref_11_c_1836_n ) capacitor c=0.00364318f \
 //x=9.74 //y=0.18 //x2=9.785 //y2=0.795
cc_913 ( N_GND_c_1502_n N_noxref_11_c_1836_n ) capacitor c=0.058641f //x=9.74 \
 //y=0.18 //x2=9.785 //y2=0.795
cc_914 ( N_GND_c_1491_n N_noxref_11_M4_noxref_s ) capacitor c=0.00251499f \
 //x=8.245 //y=0.175 //x2=7.71 //y2=0.545
cc_915 ( N_GND_c_1494_n N_noxref_11_M4_noxref_s ) capacitor c=0.0256947f \
 //x=8.33 //y=1.02 //x2=7.71 //y2=0.545
cc_916 ( N_GND_c_1502_n N_noxref_11_M4_noxref_s ) capacitor c=0.0219857f \
 //x=9.74 //y=0.18 //x2=7.71 //y2=0.545
cc_917 ( N_GND_c_1506_n N_noxref_11_M4_noxref_s ) capacitor c=0.0528977f \
 //x=7.15 //y=0.175 //x2=7.71 //y2=0.545
cc_918 ( N_GND_M4_noxref_d N_noxref_11_M4_noxref_s ) capacitor c=0.0272383f \
 //x=8.14 //y=1.045 //x2=7.71 //y2=0.545
cc_919 ( N_noxref_9_M0_noxref_s N_noxref_10_c_1717_n ) capacitor c=0.00220044f \
 //x=1.05 //y=0.545 //x2=4.515 //y2=1.675
cc_920 ( N_noxref_9_c_1704_n N_noxref_10_M2_noxref_s ) capacitor c=0.00220044f \
 //x=3.125 //y=0.795 //x2=4.38 //y2=0.545
cc_921 ( N_noxref_10_M2_noxref_s N_noxref_11_c_1783_n ) capacitor \
 c=0.00243895f //x=4.38 //y=0.545 //x2=7.845 //y2=1.675
cc_922 ( N_noxref_10_c_1768_n N_noxref_11_M4_noxref_s ) capacitor \
 c=0.00243895f //x=6.455 //y=0.795 //x2=7.71 //y2=0.545
