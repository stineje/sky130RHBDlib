// File: FA.spi.pex
// Created: Thu Jan 22 07:06:06 2026
// Program "Calibre xRC"
// Version "v2023.2_27.15"
// Nominal Temperature: 30C
// Circuit Temperature: 30C
//
simulator lang=spectre
subckt PM_FA\%A ( 1 2 3 4 5 6 7 8 9 10 11 12 13 14 15 16 17 18 25 26 33 34 37 \
 44 71 72 78 79 81 84 88 97 102 111 116 121 125 126 127 128 129 130 131 132 \
 133 134 135 136 137 141 142 143 145 151 152 153 154 155 156 160 162 165 166 \
 170 171 172 177 179 181 187 188 190 204 208 209 212 )
c483 ( 212 0 ) capacitor c=0.0392901f //x=30.12 //y=4.88
c484 ( 209 0 ) capacitor c=0.0284095f //x=30.09 //y=2.095
c485 ( 208 0 ) capacitor c=0.0451431f //x=30.09 //y=2.26
c486 ( 204 0 ) capacitor c=0.066434f //x=3.82 //y=4.88
c487 ( 190 0 ) capacitor c=0.0564228f //x=1.23 //y=2.265
c488 ( 188 0 ) capacitor c=0.0439708f //x=30.655 //y=1.43
c489 ( 187 0 ) capacitor c=0.0192582f //x=30.655 //y=1.085
c490 ( 181 0 ) capacitor c=0.0162526f //x=30.5 //y=1.585
c491 ( 179 0 ) capacitor c=0.0157807f //x=30.5 //y=0.93
c492 ( 177 0 ) capacitor c=0.0373491f //x=30.495 //y=4.97
c493 ( 172 0 ) capacitor c=0.0210762f //x=30.125 //y=1.74
c494 ( 171 0 ) capacitor c=0.0168511f //x=30.125 //y=1.43
c495 ( 170 0 ) capacitor c=0.0175485f //x=30.125 //y=1.085
c496 ( 166 0 ) capacitor c=0.0318956f //x=4.155 //y=1.395
c497 ( 165 0 ) capacitor c=0.0186836f //x=4.155 //y=1.05
c498 ( 162 0 ) capacitor c=0.0141821f //x=4 //y=1.55
c499 ( 160 0 ) capacitor c=0.0158569f //x=4 //y=0.895
c500 ( 156 0 ) capacitor c=0.0878415f //x=3.625 //y=2.1
c501 ( 155 0 ) capacitor c=0.0230018f //x=3.625 //y=1.705
c502 ( 154 0 ) capacitor c=0.0234359f //x=3.625 //y=1.395
c503 ( 153 0 ) capacitor c=0.0198787f //x=3.625 //y=1.05
c504 ( 152 0 ) capacitor c=0.0439576f //x=1.87 //y=1.435
c505 ( 151 0 ) capacitor c=0.0201087f //x=1.87 //y=1.09
c506 ( 145 0 ) capacitor c=0.0161986f //x=1.715 //y=1.59
c507 ( 143 0 ) capacitor c=0.0157807f //x=1.715 //y=0.935
c508 ( 142 0 ) capacitor c=0.0497323f //x=1.46 //y=4.97
c509 ( 141 0 ) capacitor c=0.0399032f //x=1.75 //y=4.97
c510 ( 137 0 ) capacitor c=0.0301471f //x=1.34 //y=2.1
c511 ( 136 0 ) capacitor c=0.0255349f //x=1.34 //y=1.745
c512 ( 135 0 ) capacitor c=0.0234346f //x=1.34 //y=1.435
c513 ( 134 0 ) capacitor c=0.02013f //x=1.34 //y=1.09
c514 ( 133 0 ) capacitor c=0.155269f //x=30.57 //y=6.2
c515 ( 132 0 ) capacitor c=0.110214f //x=30.13 //y=6.2
c516 ( 131 0 ) capacitor c=0.110998f //x=4.16 //y=6.2
c517 ( 130 0 ) capacitor c=0.155253f //x=3.72 //y=6.2
c518 ( 129 0 ) capacitor c=0.153944f //x=1.825 //y=6.2
c519 ( 128 0 ) capacitor c=0.154411f //x=1.385 //y=6.2
c520 ( 121 0 ) capacitor c=8.90417e-19 //x=30.12 //y=4.88
c521 ( 116 0 ) capacitor c=7.72439e-19 //x=30.09 //y=2.26
c522 ( 111 0 ) capacitor c=0.00101672f //x=3.82 //y=4.88
c523 ( 102 0 ) capacitor c=0.00130848f //x=3.82 //y=2.265
c524 ( 97 0 ) capacitor c=6.76693e-19 //x=1.23 //y=4.88
c525 ( 88 0 ) capacitor c=9.11699e-19 //x=1.23 //y=2.265
c526 ( 84 0 ) capacitor c=0.00777531f //x=30.09 //y=2.03
c527 ( 81 0 ) capacitor c=0.00764662f //x=3.815 //y=2.03
c528 ( 79 0 ) capacitor c=0.0790837f //x=3.655 //y=4.255
c529 ( 78 0 ) capacitor c=0.00201561f //x=3.815 //y=4.255
c530 ( 72 0 ) capacitor c=0.614274f //x=29.93 //y=2.03
c531 ( 71 0 ) capacitor c=0.0100228f //x=1.39 //y=4.25
c532 ( 44 0 ) capacitor c=0.0139259f //x=1.23 //y=2.265
c533 ( 37 0 ) capacitor c=0.00463995f //x=30.09 //y=4.735
c534 ( 34 0 ) capacitor c=0.00548543f //x=3.82 //y=4.765
c535 ( 33 0 ) capacitor c=0.0121207f //x=3.82 //y=4.415
c536 ( 26 0 ) capacitor c=0.00952436f //x=1.23 //y=4.76
c537 ( 25 0 ) capacitor c=0.0121029f //x=1.23 //y=4.41
c538 ( 18 0 ) capacitor c=0.00692667f //x=30.09 //y=2.4
c539 ( 17 0 ) capacitor c=0.0152624f //x=3.82 //y=4.25
c540 ( 16 0 ) capacitor c=0.00621861f //x=3.82 //y=2.4
c541 ( 15 0 ) capacitor c=0.0154384f //x=1.23 //y=4.25
c542 ( 10 0 ) capacitor c=0.0540689f //x=30.09 //y=2.77
c543 ( 9 0 ) capacitor c=0.00786414f //x=3.82 //y=4.62
c544 ( 6 0 ) capacitor c=0.0566073f //x=3.82 //y=3.14
c545 ( 5 0 ) capacitor c=0.00884265f //x=1.23 //y=4.62
c546 ( 1 0 ) capacitor c=0.0758948f //x=1.23 //y=2.77
r547 (  214 215 ) resistor r=32.4568 //w=0.214 //l=0.075 //layer=ply \
 //thickness=0.18 //x=30.12 //y=4.97 //x2=30.12 //y2=5.045
r548 (  212 214 ) resistor r=20.271 //w=0.214 //l=0.09 //layer=ply \
 //thickness=0.18 //x=30.12 //y=4.88 //x2=30.12 //y2=4.97
r549 (  208 209 ) resistor r=52.7279 //w=0.214 //l=0.165 //layer=ply \
 //thickness=0.18 //x=30.09 //y=2.26 //x2=30.09 //y2=2.095
r550 (  202 204 ) resistor r=20.6867 //w=0.233 //l=0.1 //layer=ply \
 //thickness=0.18 //x=3.72 //y=4.88 //x2=3.82 //y2=4.88
r551 (  190 191 ) resistor r=17.5563 //w=0.302 //l=0.11 //layer=ply \
 //thickness=0.18 //x=1.23 //y=2.265 //x2=1.34 //y2=2.265
r552 (  188 219 ) resistor r=45.1352 //w=0.168 //l=0.173853 //layer=ply \
 //thickness=0.18 //x=30.655 //y=1.43 //x2=30.615 //y2=1.585
r553 (  187 218 ) resistor r=45.1352 //w=0.168 //l=0.173853 //layer=ply \
 //thickness=0.18 //x=30.655 //y=1.085 //x2=30.615 //y2=0.93
r554 (  187 188 ) resistor r=176.904 //w=0.094 //l=0.345 //layer=ply \
 //thickness=0.18 //x=30.655 //y=1.085 //x2=30.655 //y2=1.43
r555 (  182 217 ) resistor r=10.701 //w=0.21 //l=0.115 //layer=ply \
 //thickness=0.18 //x=30.28 //y=1.585 //x2=30.165 //y2=1.585
r556 (  181 219 ) resistor r=5.52526 //w=0.168 //l=0.115 //layer=ply \
 //thickness=0.18 //x=30.5 //y=1.585 //x2=30.615 //y2=1.585
r557 (  180 216 ) resistor r=5.52526 //w=0.168 //l=0.115 //layer=ply \
 //thickness=0.18 //x=30.28 //y=0.93 //x2=30.165 //y2=0.93
r558 (  179 218 ) resistor r=5.52526 //w=0.168 //l=0.115 //layer=ply \
 //thickness=0.18 //x=30.5 //y=0.93 //x2=30.615 //y2=0.93
r559 (  179 180 ) resistor r=112.809 //w=0.094 //l=0.22 //layer=ply \
 //thickness=0.18 //x=30.5 //y=0.93 //x2=30.28 //y2=0.93
r560 (  178 214 ) resistor r=16.5046 //w=0.27 //l=0.135 //layer=ply \
 //thickness=0.18 //x=30.255 //y=4.97 //x2=30.12 //y2=4.97
r561 (  177 184 ) resistor r=26.9307 //w=0.15 //l=0.106066 //layer=ply \
 //thickness=0.18 //x=30.495 //y=4.97 //x2=30.57 //y2=5.045
r562 (  177 178 ) resistor r=123.064 //w=0.094 //l=0.24 //layer=ply \
 //thickness=0.18 //x=30.495 //y=4.97 //x2=30.255 //y2=4.97
r563 (  172 217 ) resistor r=39.5823 //w=0.21 //l=0.173853 //layer=ply \
 //thickness=0.18 //x=30.125 //y=1.74 //x2=30.165 //y2=1.585
r564 (  172 209 ) resistor r=182.032 //w=0.094 //l=0.355 //layer=ply \
 //thickness=0.18 //x=30.125 //y=1.74 //x2=30.125 //y2=2.095
r565 (  171 217 ) resistor r=39.5823 //w=0.21 //l=0.173853 //layer=ply \
 //thickness=0.18 //x=30.125 //y=1.43 //x2=30.165 //y2=1.585
r566 (  170 216 ) resistor r=45.1352 //w=0.168 //l=0.173853 //layer=ply \
 //thickness=0.18 //x=30.125 //y=1.085 //x2=30.165 //y2=0.93
r567 (  170 171 ) resistor r=176.904 //w=0.094 //l=0.345 //layer=ply \
 //thickness=0.18 //x=30.125 //y=1.085 //x2=30.125 //y2=1.43
r568 (  167 204 ) resistor r=70.3348 //w=0.233 //l=0.414367 //layer=ply \
 //thickness=0.18 //x=4.16 //y=5.045 //x2=3.82 //y2=4.88
r569 (  166 206 ) resistor r=45.1352 //w=0.168 //l=0.173853 //layer=ply \
 //thickness=0.18 //x=4.155 //y=1.395 //x2=4.115 //y2=1.55
r570 (  165 205 ) resistor r=45.1352 //w=0.168 //l=0.173853 //layer=ply \
 //thickness=0.18 //x=4.155 //y=1.05 //x2=4.115 //y2=0.895
r571 (  165 166 ) resistor r=176.904 //w=0.094 //l=0.345 //layer=ply \
 //thickness=0.18 //x=4.155 //y=1.05 //x2=4.155 //y2=1.395
r572 (  163 201 ) resistor r=10.701 //w=0.21 //l=0.115 //layer=ply \
 //thickness=0.18 //x=3.78 //y=1.55 //x2=3.665 //y2=1.55
r573 (  162 206 ) resistor r=5.52526 //w=0.168 //l=0.115 //layer=ply \
 //thickness=0.18 //x=4 //y=1.55 //x2=4.115 //y2=1.55
r574 (  161 200 ) resistor r=5.52526 //w=0.168 //l=0.115 //layer=ply \
 //thickness=0.18 //x=3.78 //y=0.895 //x2=3.665 //y2=0.895
r575 (  160 205 ) resistor r=5.52526 //w=0.168 //l=0.115 //layer=ply \
 //thickness=0.18 //x=4 //y=0.895 //x2=4.115 //y2=0.895
r576 (  160 161 ) resistor r=112.809 //w=0.094 //l=0.22 //layer=ply \
 //thickness=0.18 //x=4 //y=0.895 //x2=3.78 //y2=0.895
r577 (  157 202 ) resistor r=13.0941 //w=0.233 //l=0.165 //layer=ply \
 //thickness=0.18 //x=3.72 //y=5.045 //x2=3.72 //y2=4.88
r578 (  156 199 ) resistor r=34.8111 //w=0.27 //l=0.264953 //layer=ply \
 //thickness=0.18 //x=3.625 //y=2.1 //x2=3.82 //y2=2.265
r579 (  155 201 ) resistor r=39.5823 //w=0.21 //l=0.173853 //layer=ply \
 //thickness=0.18 //x=3.625 //y=1.705 //x2=3.665 //y2=1.55
r580 (  155 156 ) resistor r=202.543 //w=0.094 //l=0.395 //layer=ply \
 //thickness=0.18 //x=3.625 //y=1.705 //x2=3.625 //y2=2.1
r581 (  154 201 ) resistor r=39.5823 //w=0.21 //l=0.173853 //layer=ply \
 //thickness=0.18 //x=3.625 //y=1.395 //x2=3.665 //y2=1.55
r582 (  153 200 ) resistor r=45.1352 //w=0.168 //l=0.173853 //layer=ply \
 //thickness=0.18 //x=3.625 //y=1.05 //x2=3.665 //y2=0.895
r583 (  153 154 ) resistor r=176.904 //w=0.094 //l=0.345 //layer=ply \
 //thickness=0.18 //x=3.625 //y=1.05 //x2=3.625 //y2=1.395
r584 (  152 197 ) resistor r=45.1352 //w=0.168 //l=0.173853 //layer=ply \
 //thickness=0.18 //x=1.87 //y=1.435 //x2=1.83 //y2=1.59
r585 (  151 196 ) resistor r=45.1352 //w=0.168 //l=0.173853 //layer=ply \
 //thickness=0.18 //x=1.87 //y=1.09 //x2=1.83 //y2=0.935
r586 (  151 152 ) resistor r=176.904 //w=0.094 //l=0.345 //layer=ply \
 //thickness=0.18 //x=1.87 //y=1.09 //x2=1.87 //y2=1.435
r587 (  146 195 ) resistor r=10.701 //w=0.21 //l=0.115 //layer=ply \
 //thickness=0.18 //x=1.495 //y=1.59 //x2=1.38 //y2=1.59
r588 (  145 197 ) resistor r=5.52526 //w=0.168 //l=0.115 //layer=ply \
 //thickness=0.18 //x=1.715 //y=1.59 //x2=1.83 //y2=1.59
r589 (  144 194 ) resistor r=5.52526 //w=0.168 //l=0.115 //layer=ply \
 //thickness=0.18 //x=1.495 //y=0.935 //x2=1.38 //y2=0.935
r590 (  143 196 ) resistor r=5.52526 //w=0.168 //l=0.115 //layer=ply \
 //thickness=0.18 //x=1.715 //y=0.935 //x2=1.83 //y2=0.935
r591 (  143 144 ) resistor r=112.809 //w=0.094 //l=0.22 //layer=ply \
 //thickness=0.18 //x=1.715 //y=0.935 //x2=1.495 //y2=0.935
r592 (  141 148 ) resistor r=26.9307 //w=0.15 //l=0.106066 //layer=ply \
 //thickness=0.18 //x=1.75 //y=4.97 //x2=1.825 //y2=5.045
r593 (  141 142 ) resistor r=148.702 //w=0.094 //l=0.29 //layer=ply \
 //thickness=0.18 //x=1.75 //y=4.97 //x2=1.46 //y2=4.97
r594 (  138 142 ) resistor r=23.403 //w=0.284 //l=0.106066 //layer=ply \
 //thickness=0.18 //x=1.385 //y=5.045 //x2=1.46 //y2=4.97
r595 (  138 193 ) resistor r=26.3063 //w=0.284 //l=0.229783 //layer=ply \
 //thickness=0.18 //x=1.385 //y=5.045 //x2=1.23 //y2=4.88
r596 (  137 191 ) resistor r=19.1248 //w=0.302 //l=0.165 //layer=ply \
 //thickness=0.18 //x=1.34 //y=2.1 //x2=1.34 //y2=2.265
r597 (  136 195 ) resistor r=39.5823 //w=0.21 //l=0.173853 //layer=ply \
 //thickness=0.18 //x=1.34 //y=1.745 //x2=1.38 //y2=1.59
r598 (  136 137 ) resistor r=182.032 //w=0.094 //l=0.355 //layer=ply \
 //thickness=0.18 //x=1.34 //y=1.745 //x2=1.34 //y2=2.1
r599 (  135 195 ) resistor r=39.5823 //w=0.21 //l=0.173853 //layer=ply \
 //thickness=0.18 //x=1.34 //y=1.435 //x2=1.38 //y2=1.59
r600 (  134 194 ) resistor r=45.1352 //w=0.168 //l=0.173853 //layer=ply \
 //thickness=0.18 //x=1.34 //y=1.09 //x2=1.38 //y2=0.935
r601 (  134 135 ) resistor r=176.904 //w=0.094 //l=0.345 //layer=ply \
 //thickness=0.18 //x=1.34 //y=1.09 //x2=1.34 //y2=1.435
r602 (  133 184 ) resistor r=592.245 //w=0.094 //l=1.155 //layer=ply \
 //thickness=0.18 //x=30.57 //y=6.2 //x2=30.57 //y2=5.045
r603 (  132 215 ) resistor r=592.245 //w=0.094 //l=1.155 //layer=ply \
 //thickness=0.18 //x=30.13 //y=6.2 //x2=30.13 //y2=5.045
r604 (  131 167 ) resistor r=592.245 //w=0.094 //l=1.155 //layer=ply \
 //thickness=0.18 //x=4.16 //y=6.2 //x2=4.16 //y2=5.045
r605 (  130 157 ) resistor r=592.245 //w=0.094 //l=1.155 //layer=ply \
 //thickness=0.18 //x=3.72 //y=6.2 //x2=3.72 //y2=5.045
r606 (  129 148 ) resistor r=592.245 //w=0.094 //l=1.155 //layer=ply \
 //thickness=0.18 //x=1.825 //y=6.2 //x2=1.825 //y2=5.045
r607 (  128 138 ) resistor r=592.245 //w=0.094 //l=1.155 //layer=ply \
 //thickness=0.18 //x=1.385 //y=6.2 //x2=1.385 //y2=5.045
r608 (  127 181 ) resistor r=56.4043 //w=0.094 //l=0.11 //layer=ply \
 //thickness=0.18 //x=30.39 //y=1.585 //x2=30.5 //y2=1.585
r609 (  127 182 ) resistor r=56.4043 //w=0.094 //l=0.11 //layer=ply \
 //thickness=0.18 //x=30.39 //y=1.585 //x2=30.28 //y2=1.585
r610 (  126 162 ) resistor r=56.4043 //w=0.094 //l=0.11 //layer=ply \
 //thickness=0.18 //x=3.89 //y=1.55 //x2=4 //y2=1.55
r611 (  126 163 ) resistor r=56.4043 //w=0.094 //l=0.11 //layer=ply \
 //thickness=0.18 //x=3.89 //y=1.55 //x2=3.78 //y2=1.55
r612 (  125 145 ) resistor r=56.4043 //w=0.094 //l=0.11 //layer=ply \
 //thickness=0.18 //x=1.605 //y=1.59 //x2=1.715 //y2=1.59
r613 (  125 146 ) resistor r=56.4043 //w=0.094 //l=0.11 //layer=ply \
 //thickness=0.18 //x=1.605 //y=1.59 //x2=1.495 //y2=1.59
r614 (  121 212 ) resistor r=152 //w=0.17 //l=0.17 //layer=licon //count=1 \
 //x=30.12 //y=4.88 //x2=30.12 //y2=4.88
r615 (  116 208 ) resistor r=152 //w=0.17 //l=0.17 //layer=licon //count=1 \
 //x=30.09 //y=2.26 //x2=30.09 //y2=2.26
r616 (  111 204 ) resistor r=152 //w=0.17 //l=0.17 //layer=licon //count=1 \
 //x=3.82 //y=4.88 //x2=3.82 //y2=4.88
r617 (  102 199 ) resistor r=152 //w=0.17 //l=0.17 //layer=licon //count=1 \
 //x=3.82 //y=2.265 //x2=3.82 //y2=2.265
r618 (  97 193 ) resistor r=152 //w=0.17 //l=0.17 //layer=licon //count=1 \
 //x=1.23 //y=4.88 //x2=1.23 //y2=4.88
r619 (  88 190 ) resistor r=152 //w=0.17 //l=0.17 //layer=licon //count=1 \
 //x=1.23 //y=2.265 //x2=1.23 //y2=2.265
r620 (  84 86 ) resistor r=0.104167 //w=0.294 //l=0.245 //layer=m2 \
 //thickness=0.36 //x=30.09 //y=2.03 //x2=30.09 //y2=2.275
r621 (  81 83 ) resistor r=0.104522 //w=0.293 //l=0.245 //layer=m2 \
 //thickness=0.36 //x=3.815 //y=2.03 //x2=3.815 //y2=2.275
r622 (  78 79 ) resistor r=0.10734 //w=0.281 //l=0.16 //layer=m2 \
 //thickness=0.36 //x=3.815 //y=4.255 //x2=3.655 //y2=4.255
r623 (  73 81 ) resistor r=0.040188 //w=0.293 //l=0.16 //layer=m2 \
 //thickness=0.36 //x=3.975 //y=2.03 //x2=3.815 //y2=2.03
r624 (  72 84 ) resistor r=0.0403928 //w=0.294 //l=0.16 //layer=m2 \
 //thickness=0.36 //x=29.93 //y=2.03 //x2=30.09 //y2=2.03
r625 (  72 73 ) resistor r=24.7662 //w=0.131 //l=25.955 //layer=m2 \
 //thickness=0.36 //x=29.93 //y=2.03 //x2=3.975 //y2=2.03
r626 (  71 75 ) resistor r=0.10734 //w=0.281 //l=0.16 //layer=m2 \
 //thickness=0.36 //x=1.39 //y=4.25 //x2=1.23 //y2=4.25
r627 (  71 79 ) resistor r=2.16126 //w=0.131 //l=2.265 //layer=m2 \
 //thickness=0.36 //x=1.39 //y=4.25 //x2=3.655 //y2=4.25
r628 (  69 121 ) resistor r=9.3 //w=0.17 //l=0.17 //layer=mcon //count=1 \
 //x=30.12 //y=4.88 //x2=30.12 //y2=4.88
r629 (  62 111 ) resistor r=9.3 //w=0.17 //l=0.17 //layer=mcon //count=1 \
 //x=3.82 //y=4.88 //x2=3.82 //y2=4.88
r630 (  60 78 ) resistor r=4.5 //w=0.15 //l=0.15 //layer=via1 //count=1 \
 //x=3.815 //y=4.255 //x2=3.815 //y2=4.255
r631 (  52 83 ) resistor r=4.5 //w=0.15 //l=0.15 //layer=via1 //count=1 \
 //x=3.815 //y=2.275 //x2=3.815 //y2=2.275
r632 (  47 97 ) resistor r=9.3 //w=0.17 //l=0.17 //layer=mcon //count=1 \
 //x=1.23 //y=4.88 //x2=1.23 //y2=4.88
r633 (  44 88 ) resistor r=9.3 //w=0.17 //l=0.17 //layer=mcon //count=1 \
 //x=1.23 //y=2.265 //x2=1.23 //y2=2.265
r634 (  37 69 ) resistor r=0.0878548 //w=0.228 //l=0.159295 //layer=m1 \
 //thickness=0.36 //x=30.09 //y=4.735 //x2=30.12 //y2=4.88
r635 (  34 62 ) resistor r=0.0717383 //w=0.224 //l=0.115 //layer=m1 \
 //thickness=0.36 //x=3.82 //y=4.765 //x2=3.82 //y2=4.88
r636 (  33 60 ) resistor r=0.0910802 //w=0.374 //l=0.185472 //layer=m1 \
 //thickness=0.36 //x=3.82 //y=4.415 //x2=3.765 //y2=4.255
r637 (  26 47 ) resistor r=0.0731974 //w=0.242 //l=0.122474 //layer=m1 \
 //thickness=0.36 //x=1.23 //y=4.76 //x2=1.235 //y2=4.88
r638 (  19 44 ) resistor r=0.116051 //w=0.211 //l=0.165 //layer=m1 \
 //thickness=0.36 //x=1.23 //y=2.43 //x2=1.23 //y2=2.265
r639 (  18 116 ) resistor r=9.3 //w=0.17 //l=0.17 //layer=mcon //count=1 \
 //x=30.09 //y=2.26 //x2=30.09 //y2=2.26
r640 (  18 86 ) resistor r=4.5 //w=0.15 //l=0.15 //layer=via1 //count=1 \
 //x=30.09 //y=2.275 //x2=30.09 //y2=2.275
r641 (  18 36 ) resistor r=0.0455071 //w=0.32 //l=0.16 //layer=m1 \
 //thickness=0.36 //x=30.09 //y=2.275 //x2=30.09 //y2=2.435
r642 (  17 60 ) resistor r=0.00167112 //w=0.374 //l=0.005 //layer=m1 \
 //thickness=0.36 //x=3.765 //y=4.25 //x2=3.765 //y2=4.255
r643 (  17 29 ) resistor r=0.089409 //w=0.374 //l=0.180416 //layer=m1 \
 //thickness=0.36 //x=3.765 //y=4.25 //x2=3.82 //y2=4.095
r644 (  16 102 ) resistor r=9.3 //w=0.17 //l=0.17 //layer=mcon //count=1 \
 //x=3.82 //y=2.265 //x2=3.82 //y2=2.265
r645 (  16 28 ) resistor r=0.0455071 //w=0.32 //l=0.16 //layer=m1 \
 //thickness=0.36 //x=3.82 //y=2.275 //x2=3.82 //y2=2.435
r646 (  16 52 ) resistor r=0.0022242 //w=0.281 //l=0.005 //layer=m1 \
 //thickness=0.36 //x=3.82 //y=2.275 //x2=3.815 //y2=2.275
r647 (  15 75 ) resistor r=4.5 //w=0.15 //l=0.15 //layer=via1 //count=1 \
 //x=1.23 //y=4.25 //x2=1.23 //y2=4.25
r648 (  15 25 ) resistor r=0.0911593 //w=0.376 //l=0.184174 //layer=m1 \
 //thickness=0.36 //x=1.282 //y=4.25 //x2=1.23 //y2=4.41
r649 (  15 20 ) resistor r=0.0911593 //w=0.376 //l=0.184174 //layer=m1 \
 //thickness=0.36 //x=1.282 //y=4.25 //x2=1.23 //y2=4.09
r650 (  14 37 ) resistor r=0.109733 //w=0.131 //l=0.115 //layer=m1 \
 //thickness=0.36 //x=30.09 //y=4.62 //x2=30.09 //y2=4.735
r651 (  13 14 ) resistor r=0.353053 //w=0.131 //l=0.37 //layer=m1 \
 //thickness=0.36 //x=30.09 //y=4.25 //x2=30.09 //y2=4.62
r652 (  12 13 ) resistor r=0.353053 //w=0.131 //l=0.37 //layer=m1 \
 //thickness=0.36 //x=30.09 //y=3.88 //x2=30.09 //y2=4.25
r653 (  11 12 ) resistor r=0.353053 //w=0.131 //l=0.37 //layer=m1 \
 //thickness=0.36 //x=30.09 //y=3.51 //x2=30.09 //y2=3.88
r654 (  10 11 ) resistor r=0.706107 //w=0.131 //l=0.74 //layer=m1 \
 //thickness=0.36 //x=30.09 //y=2.77 //x2=30.09 //y2=3.51
r655 (  10 36 ) resistor r=0.319656 //w=0.131 //l=0.335 //layer=m1 \
 //thickness=0.36 //x=30.09 //y=2.77 //x2=30.09 //y2=2.435
r656 (  9 34 ) resistor r=0.138359 //w=0.131 //l=0.145 //layer=m1 \
 //thickness=0.36 //x=3.82 //y=4.62 //x2=3.82 //y2=4.765
r657 (  9 33 ) resistor r=0.195611 //w=0.131 //l=0.205 //layer=m1 \
 //thickness=0.36 //x=3.82 //y=4.62 //x2=3.82 //y2=4.415
r658 (  8 29 ) resistor r=0.205153 //w=0.131 //l=0.215 //layer=m1 \
 //thickness=0.36 //x=3.82 //y=3.88 //x2=3.82 //y2=4.095
r659 (  7 8 ) resistor r=0.353053 //w=0.131 //l=0.37 //layer=m1 \
 //thickness=0.36 //x=3.82 //y=3.51 //x2=3.82 //y2=3.88
r660 (  6 7 ) resistor r=0.353053 //w=0.131 //l=0.37 //layer=m1 \
 //thickness=0.36 //x=3.82 //y=3.14 //x2=3.82 //y2=3.51
r661 (  6 28 ) resistor r=0.67271 //w=0.131 //l=0.705 //layer=m1 \
 //thickness=0.36 //x=3.82 //y=3.14 //x2=3.82 //y2=2.435
r662 (  5 26 ) resistor r=0.133588 //w=0.131 //l=0.14 //layer=m1 \
 //thickness=0.36 //x=1.23 //y=4.62 //x2=1.23 //y2=4.76
r663 (  5 25 ) resistor r=0.200382 //w=0.131 //l=0.21 //layer=m1 \
 //thickness=0.36 //x=1.23 //y=4.62 //x2=1.23 //y2=4.41
r664 (  4 20 ) resistor r=0.200382 //w=0.131 //l=0.21 //layer=m1 \
 //thickness=0.36 //x=1.23 //y=3.88 //x2=1.23 //y2=4.09
r665 (  3 4 ) resistor r=0.353053 //w=0.131 //l=0.37 //layer=m1 \
 //thickness=0.36 //x=1.23 //y=3.51 //x2=1.23 //y2=3.88
r666 (  2 3 ) resistor r=0.353053 //w=0.131 //l=0.37 //layer=m1 \
 //thickness=0.36 //x=1.23 //y=3.14 //x2=1.23 //y2=3.51
r667 (  1 2 ) resistor r=0.353053 //w=0.131 //l=0.37 //layer=m1 \
 //thickness=0.36 //x=1.23 //y=2.77 //x2=1.23 //y2=3.14
r668 (  1 19 ) resistor r=0.324427 //w=0.131 //l=0.34 //layer=m1 \
 //thickness=0.36 //x=1.23 //y=2.77 //x2=1.23 //y2=2.43
ends PM_FA\%A

subckt PM_FA\%noxref_2 ( 2 4 5 6 7 8 10 11 12 13 14 15 16 18 23 28 31 35 40 41 \
 49 61 70 74 75 76 77 78 79 80 84 86 92 93 101 103 105 )
c279 ( 103 0 ) capacitor c=0.00875839f //x=1.415 //y=1.09
c280 ( 101 0 ) capacitor c=0.069457f //x=8.26 //y=4.88
c281 ( 93 0 ) capacitor c=0.0423887f //x=8.455 //y=1.435
c282 ( 92 0 ) capacitor c=0.0191585f //x=8.455 //y=1.09
c283 ( 86 0 ) capacitor c=0.0125357f //x=8.3 //y=1.59
c284 ( 84 0 ) capacitor c=0.0157807f //x=8.3 //y=0.935
c285 ( 80 0 ) capacitor c=0.0959389f //x=7.925 //y=2.1
c286 ( 79 0 ) capacitor c=0.0197088f //x=7.925 //y=1.745
c287 ( 78 0 ) capacitor c=0.0168511f //x=7.925 //y=1.435
c288 ( 77 0 ) capacitor c=0.0174128f //x=7.925 //y=1.09
c289 ( 76 0 ) capacitor c=0.155893f //x=8.37 //y=6.2
c290 ( 75 0 ) capacitor c=0.110553f //x=7.93 //y=6.2
c291 ( 70 0 ) capacitor c=8.33342e-19 //x=8.26 //y=4.88
c292 ( 61 0 ) capacitor c=6.44043e-19 //x=8.26 //y=2.265
c293 ( 49 0 ) capacitor c=0.0261398f //x=1.605 //y=5.56
c294 ( 41 0 ) capacitor c=0.123305f //x=8.085 //y=2.755
c295 ( 40 0 ) capacitor c=0.00173329f //x=8.245 //y=2.755
c296 ( 35 0 ) capacitor c=0.00290249f //x=2.13 //y=2.77
c297 ( 31 0 ) capacitor c=0.00861163f //x=8.14 //y=4.877
c298 ( 28 0 ) capacitor c=0.0149988f //x=8.26 //y=2.77
c299 ( 23 0 ) capacitor c=0.0140935f //x=1.97 //y=2.77
c300 ( 18 0 ) capacitor c=0.0191391f //x=1.6 //y=1.185
c301 ( 16 0 ) capacitor c=0.00313372f //x=8.26 //y=2.595
c302 ( 15 0 ) capacitor c=0.00460007f //x=8.26 //y=2.41
c303 ( 14 0 ) capacitor c=0.0399807f //x=8.14 //y=4.73
c304 ( 13 0 ) capacitor c=0.00886466f //x=8.14 //y=2.915
c305 ( 12 0 ) capacitor c=0.0612378f //x=1.97 //y=5.055
c306 ( 11 0 ) capacitor c=0.0126342f //x=1.97 //y=2.93
c307 ( 10 0 ) capacitor c=0.00861366f //x=1.97 //y=2.61
c308 ( 8 0 ) capacitor c=0.00632795f //x=1.69 //y=5.14
c309 ( 7 0 ) capacitor c=0.00769652f //x=1.885 //y=5.14
c310 ( 6 0 ) capacitor c=0.00882254f //x=1.685 //y=2.02
c311 ( 5 0 ) capacitor c=0.0115318f //x=1.885 //y=2.02
c312 ( 4 0 ) capacitor c=0.0119286f //x=1.605 //y=5.42
c313 ( 2 0 ) capacitor c=0.0184592f //x=1.6 //y=1.935
r314 (  101 102 ) resistor r=22.7554 //w=0.233 //l=0.11 //layer=ply \
 //thickness=0.18 //x=8.26 //y=4.88 //x2=8.37 //y2=4.88
r315 (  93 99 ) resistor r=45.1352 //w=0.168 //l=0.173853 //layer=ply \
 //thickness=0.18 //x=8.455 //y=1.435 //x2=8.415 //y2=1.59
r316 (  92 98 ) resistor r=45.1352 //w=0.168 //l=0.173853 //layer=ply \
 //thickness=0.18 //x=8.455 //y=1.09 //x2=8.415 //y2=0.935
r317 (  92 93 ) resistor r=176.904 //w=0.094 //l=0.345 //layer=ply \
 //thickness=0.18 //x=8.455 //y=1.09 //x2=8.455 //y2=1.435
r318 (  89 102 ) resistor r=13.0941 //w=0.233 //l=0.165 //layer=ply \
 //thickness=0.18 //x=8.37 //y=5.045 //x2=8.37 //y2=4.88
r319 (  87 95 ) resistor r=10.701 //w=0.21 //l=0.115 //layer=ply \
 //thickness=0.18 //x=8.08 //y=1.59 //x2=7.965 //y2=1.59
r320 (  86 99 ) resistor r=5.52526 //w=0.168 //l=0.115 //layer=ply \
 //thickness=0.18 //x=8.3 //y=1.59 //x2=8.415 //y2=1.59
r321 (  85 94 ) resistor r=5.52526 //w=0.168 //l=0.115 //layer=ply \
 //thickness=0.18 //x=8.08 //y=0.935 //x2=7.965 //y2=0.935
r322 (  84 98 ) resistor r=5.52526 //w=0.168 //l=0.115 //layer=ply \
 //thickness=0.18 //x=8.3 //y=0.935 //x2=8.415 //y2=0.935
r323 (  84 85 ) resistor r=112.809 //w=0.094 //l=0.22 //layer=ply \
 //thickness=0.18 //x=8.3 //y=0.935 //x2=8.08 //y2=0.935
r324 (  81 101 ) resistor r=68.2661 //w=0.233 //l=0.404166 //layer=ply \
 //thickness=0.18 //x=7.93 //y=5.045 //x2=8.26 //y2=4.88
r325 (  80 97 ) resistor r=67.2792 //w=0.24 //l=0.438891 //layer=ply \
 //thickness=0.18 //x=7.925 //y=2.1 //x2=8.26 //y2=2.34
r326 (  79 95 ) resistor r=39.5823 //w=0.21 //l=0.173853 //layer=ply \
 //thickness=0.18 //x=7.925 //y=1.745 //x2=7.965 //y2=1.59
r327 (  79 80 ) resistor r=182.032 //w=0.094 //l=0.355 //layer=ply \
 //thickness=0.18 //x=7.925 //y=1.745 //x2=7.925 //y2=2.1
r328 (  78 95 ) resistor r=39.5823 //w=0.21 //l=0.173853 //layer=ply \
 //thickness=0.18 //x=7.925 //y=1.435 //x2=7.965 //y2=1.59
r329 (  77 94 ) resistor r=45.1352 //w=0.168 //l=0.173853 //layer=ply \
 //thickness=0.18 //x=7.925 //y=1.09 //x2=7.965 //y2=0.935
r330 (  77 78 ) resistor r=176.904 //w=0.094 //l=0.345 //layer=ply \
 //thickness=0.18 //x=7.925 //y=1.09 //x2=7.925 //y2=1.435
r331 (  76 89 ) resistor r=592.245 //w=0.094 //l=1.155 //layer=ply \
 //thickness=0.18 //x=8.37 //y=6.2 //x2=8.37 //y2=5.045
r332 (  75 81 ) resistor r=592.245 //w=0.094 //l=1.155 //layer=ply \
 //thickness=0.18 //x=7.93 //y=6.2 //x2=7.93 //y2=5.045
r333 (  74 86 ) resistor r=56.4043 //w=0.094 //l=0.11 //layer=ply \
 //thickness=0.18 //x=8.19 //y=1.59 //x2=8.3 //y2=1.59
r334 (  74 87 ) resistor r=56.4043 //w=0.094 //l=0.11 //layer=ply \
 //thickness=0.18 //x=8.19 //y=1.59 //x2=8.08 //y2=1.59
r335 (  70 101 ) resistor r=152 //w=0.17 //l=0.17 //layer=licon //count=1 \
 //x=8.26 //y=4.88 //x2=8.26 //y2=4.88
r336 (  61 97 ) resistor r=152 //w=0.17 //l=0.17 //layer=licon //count=1 \
 //x=8.26 //y=2.265 //x2=8.26 //y2=2.265
r337 (  49 105 ) resistor r=23.615 //w=0.187 //l=0.345 //layer=li \
 //thickness=0.1 //x=1.605 //y=5.56 //x2=1.605 //y2=5.905
r338 (  40 41 ) resistor r=0.10734 //w=0.281 //l=0.16 //layer=m2 \
 //thickness=0.36 //x=8.245 //y=2.755 //x2=8.085 //y2=2.755
r339 (  35 37 ) resistor r=0.10734 //w=0.281 //l=0.16 //layer=m2 \
 //thickness=0.36 //x=2.13 //y=2.77 //x2=1.97 //y2=2.77
r340 (  35 41 ) resistor r=5.68225 //w=0.131 //l=5.955 //layer=m2 \
 //thickness=0.36 //x=2.13 //y=2.77 //x2=8.085 //y2=2.77
r341 (  33 70 ) resistor r=9.3 //w=0.17 //l=0.17 //layer=mcon //count=1 \
 //x=8.26 //y=4.88 //x2=8.26 //y2=4.88
r342 (  31 33 ) resistor r=0.0528169 //w=0.284 //l=0.12 //layer=m1 \
 //thickness=0.36 //x=8.14 //y=4.877 //x2=8.26 //y2=4.877
r343 (  30 61 ) resistor r=9.3 //w=0.17 //l=0.17 //layer=mcon //count=1 \
 //x=8.26 //y=2.265 //x2=8.26 //y2=2.265
r344 (  26 40 ) resistor r=4.5 //w=0.15 //l=0.15 //layer=via1 //count=1 \
 //x=8.245 //y=2.755 //x2=8.245 //y2=2.755
r345 (  26 28 ) resistor r=0.00501337 //w=0.374 //l=0.015 //layer=m1 \
 //thickness=0.36 //x=8.2 //y=2.755 //x2=8.2 //y2=2.77
r346 (  23 37 ) resistor r=4.5 //w=0.15 //l=0.15 //layer=via1 //count=1 \
 //x=1.97 //y=2.77 //x2=1.97 //y2=2.77
r347 (  21 49 ) resistor r=9.3 //w=0.17 //l=0.17 //layer=mcon //count=1 \
 //x=1.605 //y=5.56 //x2=1.605 //y2=5.56
r348 (  18 103 ) resistor r=9.3 //w=0.17 //l=0.17 //layer=mcon //count=1 \
 //x=1.6 //y=1.185 //x2=1.6 //y2=1.185
r349 (  16 26 ) resistor r=0.0910802 //w=0.374 //l=0.187617 //layer=m1 \
 //thickness=0.36 //x=8.26 //y=2.595 //x2=8.2 //y2=2.755
r350 (  15 30 ) resistor r=0.0853765 //w=0.25 //l=0.146492 //layer=m1 \
 //thickness=0.36 //x=8.26 //y=2.41 //x2=8.257 //y2=2.265
r351 (  15 16 ) resistor r=0.176527 //w=0.131 //l=0.185 //layer=m1 \
 //thickness=0.36 //x=8.26 //y=2.41 //x2=8.26 //y2=2.595
r352 (  14 31 ) resistor r=0.0383145 //w=0.284 //l=0.147 //layer=m1 \
 //thickness=0.36 //x=8.14 //y=4.73 //x2=8.14 //y2=4.877
r353 (  13 28 ) resistor r=0.0860668 //w=0.374 //l=0.172409 //layer=m1 \
 //thickness=0.36 //x=8.14 //y=2.915 //x2=8.2 //y2=2.77
r354 (  13 14 ) resistor r=1.73187 //w=0.131 //l=1.815 //layer=m1 \
 //thickness=0.36 //x=8.14 //y=2.915 //x2=8.14 //y2=4.73
r355 (  11 23 ) resistor r=0.0911593 //w=0.376 //l=0.184174 //layer=m1 \
 //thickness=0.36 //x=1.97 //y=2.93 //x2=2.022 //y2=2.77
r356 (  11 12 ) resistor r=2.02767 //w=0.131 //l=2.125 //layer=m1 \
 //thickness=0.36 //x=1.97 //y=2.93 //x2=1.97 //y2=5.055
r357 (  10 23 ) resistor r=0.0911593 //w=0.376 //l=0.184174 //layer=m1 \
 //thickness=0.36 //x=1.97 //y=2.61 //x2=2.022 //y2=2.77
r358 (  9 10 ) resistor r=0.48187 //w=0.131 //l=0.505 //layer=m1 \
 //thickness=0.36 //x=1.97 //y=2.105 //x2=1.97 //y2=2.61
r359 (  7 12 ) resistor r=0.0698411 //w=0.17 //l=0.120208 //layer=m1 \
 //thickness=0.36 //x=1.885 //y=5.14 //x2=1.97 //y2=5.055
r360 (  7 8 ) resistor r=0.186069 //w=0.131 //l=0.195 //layer=m1 \
 //thickness=0.36 //x=1.885 //y=5.14 //x2=1.69 //y2=5.14
r361 (  5 9 ) resistor r=0.0698411 //w=0.17 //l=0.120208 //layer=m1 \
 //thickness=0.36 //x=1.885 //y=2.02 //x2=1.97 //y2=2.105
r362 (  5 6 ) resistor r=0.19084 //w=0.131 //l=0.2 //layer=m1 //thickness=0.36 \
 //x=1.885 //y=2.02 //x2=1.685 //y2=2.02
r363 (  4 21 ) resistor r=0.086672 //w=0.218 //l=0.14 //layer=m1 \
 //thickness=0.36 //x=1.605 //y=5.42 //x2=1.605 //y2=5.56
r364 (  3 8 ) resistor r=0.0698411 //w=0.17 //l=0.120208 //layer=m1 \
 //thickness=0.36 //x=1.605 //y=5.225 //x2=1.69 //y2=5.14
r365 (  3 4 ) resistor r=0.186069 //w=0.131 //l=0.195 //layer=m1 \
 //thickness=0.36 //x=1.605 //y=5.225 //x2=1.605 //y2=5.42
r366 (  2 6 ) resistor r=0.0698411 //w=0.17 //l=0.120208 //layer=m1 \
 //thickness=0.36 //x=1.6 //y=1.935 //x2=1.685 //y2=2.02
r367 (  1 18 ) resistor r=0.105739 //w=0.201 //l=0.145 //layer=m1 \
 //thickness=0.36 //x=1.6 //y=1.33 //x2=1.6 //y2=1.185
r368 (  1 2 ) resistor r=0.57729 //w=0.131 //l=0.605 //layer=m1 \
 //thickness=0.36 //x=1.6 //y=1.33 //x2=1.6 //y2=1.935
ends PM_FA\%noxref_2

subckt PM_FA\%noxref_3 ( 1 2 3 4 6 7 8 9 10 11 12 13 14 16 18 24 28 34 36 40 \
 48 54 56 57 60 61 68 73 90 102 103 104 111 112 113 114 115 117 120 121 123 \
 131 133 )
c317 ( 131 0 ) capacitor c=0.00849916f //x=10.285 //y=1.09
c318 ( 123 0 ) capacitor c=0.0652604f //x=4.93 //y=4.88
c319 ( 121 0 ) capacitor c=0.0318956f //x=7.485 //y=1.395
c320 ( 120 0 ) capacitor c=0.0186836f //x=7.485 //y=1.05
c321 ( 117 0 ) capacitor c=0.0141821f //x=7.33 //y=1.55
c322 ( 115 0 ) capacitor c=0.0158569f //x=7.33 //y=0.895
c323 ( 114 0 ) capacitor c=0.0874759f //x=6.955 //y=2.1
c324 ( 113 0 ) capacitor c=0.0230012f //x=6.955 //y=1.705
c325 ( 112 0 ) capacitor c=0.0234359f //x=6.955 //y=1.395
c326 ( 111 0 ) capacitor c=0.0198787f //x=6.955 //y=1.05
c327 ( 104 0 ) capacitor c=0.155893f //x=5.04 //y=6.2
c328 ( 103 0 ) capacitor c=0.110553f //x=4.6 //y=6.2
c329 ( 90 0 ) capacitor c=0.0261623f //x=10.475 //y=5.56
c330 ( 73 0 ) capacitor c=0.00142446f //x=7.15 //y=2.265
c331 ( 68 0 ) capacitor c=5.34577e-19 //x=4.93 //y=4.88
c332 ( 61 0 ) capacitor c=0.0249554f //x=9.985 //y=3.495
c333 ( 60 0 ) capacitor c=1.25685e-19 //x=10.145 //y=3.495
c334 ( 57 0 ) capacitor c=0.0768672f //x=9.955 //y=4.27
c335 ( 56 0 ) capacitor c=0.003463f //x=10.115 //y=4.27
c336 ( 54 0 ) capacitor c=0.00256557f //x=7.31 //y=3.525
c337 ( 48 0 ) capacitor c=0.00536919f //x=4.975 //y=4.28
c338 ( 40 0 ) capacitor c=0.0149639f //x=10.48 //y=1.185
c339 ( 36 0 ) capacitor c=0.0144667f //x=10.11 //y=4.25
c340 ( 34 0 ) capacitor c=0.0166119f //x=10.11 //y=3.51
c341 ( 28 0 ) capacitor c=0.031103f //x=7.15 //y=3.51
c342 ( 24 0 ) capacitor c=0.0153143f //x=4.975 //y=4.415
c343 ( 18 0 ) capacitor c=0.0108502f //x=10.48 //y=1.935
c344 ( 16 0 ) capacitor c=0.0105389f //x=10.475 //y=5.42
c345 ( 14 0 ) capacitor c=0.00262672f //x=10.195 //y=5.14
c346 ( 13 0 ) capacitor c=0.00723592f //x=10.39 //y=5.14
c347 ( 12 0 ) capacitor c=0.00446437f //x=10.195 //y=2.02
c348 ( 11 0 ) capacitor c=0.0118567f //x=10.395 //y=2.02
c349 ( 10 0 ) capacitor c=0.00897222f //x=10.11 //y=5.055
c350 ( 9 0 ) capacitor c=0.0114124f //x=10.11 //y=4.43
c351 ( 8 0 ) capacitor c=0.0100049f //x=10.11 //y=4.135
c352 ( 7 0 ) capacitor c=0.0126242f //x=10.11 //y=3.655
c353 ( 6 0 ) capacitor c=0.0247218f //x=10.11 //y=3.335
c354 ( 4 0 ) capacitor c=0.0259221f //x=7.15 //y=3.385
c355 ( 3 0 ) capacitor c=0.00668061f //x=7.15 //y=2.385
c356 ( 2 0 ) capacitor c=0.00688284f //x=4.93 //y=4.765
c357 ( 1 0 ) capacitor c=0.0149275f //x=4.93 //y=4.575
r358 (  123 124 ) resistor r=22.7554 //w=0.233 //l=0.11 //layer=ply \
 //thickness=0.18 //x=4.93 //y=4.88 //x2=5.04 //y2=4.88
r359 (  121 130 ) resistor r=45.1352 //w=0.168 //l=0.173853 //layer=ply \
 //thickness=0.18 //x=7.485 //y=1.395 //x2=7.445 //y2=1.55
r360 (  120 129 ) resistor r=45.1352 //w=0.168 //l=0.173853 //layer=ply \
 //thickness=0.18 //x=7.485 //y=1.05 //x2=7.445 //y2=0.895
r361 (  120 121 ) resistor r=176.904 //w=0.094 //l=0.345 //layer=ply \
 //thickness=0.18 //x=7.485 //y=1.05 //x2=7.485 //y2=1.395
r362 (  118 128 ) resistor r=10.701 //w=0.21 //l=0.115 //layer=ply \
 //thickness=0.18 //x=7.11 //y=1.55 //x2=6.995 //y2=1.55
r363 (  117 130 ) resistor r=5.52526 //w=0.168 //l=0.115 //layer=ply \
 //thickness=0.18 //x=7.33 //y=1.55 //x2=7.445 //y2=1.55
r364 (  116 127 ) resistor r=5.52526 //w=0.168 //l=0.115 //layer=ply \
 //thickness=0.18 //x=7.11 //y=0.895 //x2=6.995 //y2=0.895
r365 (  115 129 ) resistor r=5.52526 //w=0.168 //l=0.115 //layer=ply \
 //thickness=0.18 //x=7.33 //y=0.895 //x2=7.445 //y2=0.895
r366 (  115 116 ) resistor r=112.809 //w=0.094 //l=0.22 //layer=ply \
 //thickness=0.18 //x=7.33 //y=0.895 //x2=7.11 //y2=0.895
r367 (  114 126 ) resistor r=34.8111 //w=0.27 //l=0.264953 //layer=ply \
 //thickness=0.18 //x=6.955 //y=2.1 //x2=7.15 //y2=2.265
r368 (  113 128 ) resistor r=39.5823 //w=0.21 //l=0.173853 //layer=ply \
 //thickness=0.18 //x=6.955 //y=1.705 //x2=6.995 //y2=1.55
r369 (  113 114 ) resistor r=202.543 //w=0.094 //l=0.395 //layer=ply \
 //thickness=0.18 //x=6.955 //y=1.705 //x2=6.955 //y2=2.1
r370 (  112 128 ) resistor r=39.5823 //w=0.21 //l=0.173853 //layer=ply \
 //thickness=0.18 //x=6.955 //y=1.395 //x2=6.995 //y2=1.55
r371 (  111 127 ) resistor r=45.1352 //w=0.168 //l=0.173853 //layer=ply \
 //thickness=0.18 //x=6.955 //y=1.05 //x2=6.995 //y2=0.895
r372 (  111 112 ) resistor r=176.904 //w=0.094 //l=0.345 //layer=ply \
 //thickness=0.18 //x=6.955 //y=1.05 //x2=6.955 //y2=1.395
r373 (  108 124 ) resistor r=13.0941 //w=0.233 //l=0.165 //layer=ply \
 //thickness=0.18 //x=5.04 //y=5.045 //x2=5.04 //y2=4.88
r374 (  105 123 ) resistor r=68.2661 //w=0.233 //l=0.404166 //layer=ply \
 //thickness=0.18 //x=4.6 //y=5.045 //x2=4.93 //y2=4.88
r375 (  104 108 ) resistor r=592.245 //w=0.094 //l=1.155 //layer=ply \
 //thickness=0.18 //x=5.04 //y=6.2 //x2=5.04 //y2=5.045
r376 (  103 105 ) resistor r=592.245 //w=0.094 //l=1.155 //layer=ply \
 //thickness=0.18 //x=4.6 //y=6.2 //x2=4.6 //y2=5.045
r377 (  102 117 ) resistor r=56.4043 //w=0.094 //l=0.11 //layer=ply \
 //thickness=0.18 //x=7.22 //y=1.55 //x2=7.33 //y2=1.55
r378 (  102 118 ) resistor r=56.4043 //w=0.094 //l=0.11 //layer=ply \
 //thickness=0.18 //x=7.22 //y=1.55 //x2=7.11 //y2=1.55
r379 (  90 133 ) resistor r=23.615 //w=0.187 //l=0.345 //layer=li \
 //thickness=0.1 //x=10.475 //y=5.56 //x2=10.475 //y2=5.905
r380 (  73 126 ) resistor r=152 //w=0.17 //l=0.17 //layer=licon //count=1 \
 //x=7.15 //y=2.265 //x2=7.15 //y2=2.265
r381 (  68 123 ) resistor r=152 //w=0.17 //l=0.17 //layer=licon //count=1 \
 //x=4.93 //y=4.88 //x2=4.93 //y2=4.88
r382 (  60 61 ) resistor r=0.10734 //w=0.281 //l=0.16 //layer=m2 \
 //thickness=0.36 //x=10.145 //y=3.495 //x2=9.985 //y2=3.495
r383 (  56 57 ) resistor r=0.10734 //w=0.281 //l=0.16 //layer=m2 \
 //thickness=0.36 //x=10.115 //y=4.27 //x2=9.955 //y2=4.27
r384 (  54 61 ) resistor r=2.55248 //w=0.131 //l=2.675 //layer=m2 \
 //thickness=0.36 //x=7.31 //y=3.51 //x2=9.985 //y2=3.51
r385 (  52 54 ) resistor r=0.10734 //w=0.281 //l=0.16 //layer=m2 \
 //thickness=0.36 //x=7.15 //y=3.525 //x2=7.31 //y2=3.525
r386 (  48 50 ) resistor r=0.0539137 //w=0.313 //l=0.135 //layer=m2 \
 //thickness=0.36 //x=4.975 //y=4.28 //x2=4.975 //y2=4.415
r387 (  45 48 ) resistor r=0.0441684 //w=0.313 //l=0.16 //layer=m2 \
 //thickness=0.36 //x=5.135 //y=4.28 //x2=4.975 //y2=4.28
r388 (  45 57 ) resistor r=4.59924 //w=0.131 //l=4.82 //layer=m2 \
 //thickness=0.36 //x=5.135 //y=4.28 //x2=9.955 //y2=4.28
r389 (  43 90 ) resistor r=9.3 //w=0.17 //l=0.17 //layer=mcon //count=1 \
 //x=10.475 //y=5.56 //x2=10.475 //y2=5.56
r390 (  40 131 ) resistor r=9.3 //w=0.17 //l=0.17 //layer=mcon //count=1 \
 //x=10.48 //y=1.185 //x2=10.48 //y2=1.185
r391 (  38 56 ) resistor r=4.5 //w=0.15 //l=0.15 //layer=via1 //count=1 \
 //x=10.115 //y=4.27 //x2=10.115 //y2=4.27
r392 (  36 38 ) resistor r=0.0065445 //w=0.382 //l=0.02 //layer=m1 \
 //thickness=0.36 //x=10.06 //y=4.25 //x2=10.06 //y2=4.27
r393 (  32 60 ) resistor r=4.5 //w=0.15 //l=0.15 //layer=via1 //count=1 \
 //x=10.145 //y=3.495 //x2=10.145 //y2=3.495
r394 (  32 34 ) resistor r=0.00474684 //w=0.395 //l=0.015 //layer=m1 \
 //thickness=0.36 //x=10.075 //y=3.495 //x2=10.075 //y2=3.51
r395 (  30 52 ) resistor r=4.5 //w=0.15 //l=0.15 //layer=via1 //count=1 \
 //x=7.15 //y=3.525 //x2=7.15 //y2=3.525
r396 (  28 30 ) resistor r=0.00493421 //w=0.38 //l=0.015 //layer=m1 \
 //thickness=0.36 //x=7.202 //y=3.51 //x2=7.202 //y2=3.525
r397 (  26 73 ) resistor r=9.3 //w=0.17 //l=0.17 //layer=mcon //count=1 \
 //x=7.15 //y=2.265 //x2=7.15 //y2=2.265
r398 (  24 50 ) resistor r=4.5 //w=0.15 //l=0.15 //layer=via1 //count=1 \
 //x=4.975 //y=4.415 //x2=4.975 //y2=4.415
r399 (  20 68 ) resistor r=9.3 //w=0.17 //l=0.17 //layer=mcon //count=1 \
 //x=4.93 //y=4.88 //x2=4.93 //y2=4.88
r400 (  17 40 ) resistor r=0.105739 //w=0.201 //l=0.145 //layer=m1 \
 //thickness=0.36 //x=10.48 //y=1.33 //x2=10.48 //y2=1.185
r401 (  17 18 ) resistor r=0.57729 //w=0.131 //l=0.605 //layer=m1 \
 //thickness=0.36 //x=10.48 //y=1.33 //x2=10.48 //y2=1.935
r402 (  16 43 ) resistor r=0.086672 //w=0.218 //l=0.14 //layer=m1 \
 //thickness=0.36 //x=10.475 //y=5.42 //x2=10.475 //y2=5.56
r403 (  15 16 ) resistor r=0.186069 //w=0.131 //l=0.195 //layer=m1 \
 //thickness=0.36 //x=10.475 //y=5.225 //x2=10.475 //y2=5.42
r404 (  13 15 ) resistor r=0.0698411 //w=0.17 //l=0.120208 //layer=m1 \
 //thickness=0.36 //x=10.39 //y=5.14 //x2=10.475 //y2=5.225
r405 (  13 14 ) resistor r=0.186069 //w=0.131 //l=0.195 //layer=m1 \
 //thickness=0.36 //x=10.39 //y=5.14 //x2=10.195 //y2=5.14
r406 (  11 18 ) resistor r=0.0698411 //w=0.17 //l=0.120208 //layer=m1 \
 //thickness=0.36 //x=10.395 //y=2.02 //x2=10.48 //y2=1.935
r407 (  11 12 ) resistor r=0.19084 //w=0.131 //l=0.2 //layer=m1 \
 //thickness=0.36 //x=10.395 //y=2.02 //x2=10.195 //y2=2.02
r408 (  10 14 ) resistor r=0.0698411 //w=0.17 //l=0.120208 //layer=m1 \
 //thickness=0.36 //x=10.11 //y=5.055 //x2=10.195 //y2=5.14
r409 (  9 38 ) resistor r=0.0914072 //w=0.382 //l=0.183303 //layer=m1 \
 //thickness=0.36 //x=10.11 //y=4.43 //x2=10.06 //y2=4.27
r410 (  9 10 ) resistor r=0.596374 //w=0.131 //l=0.625 //layer=m1 \
 //thickness=0.36 //x=10.11 //y=4.43 //x2=10.11 //y2=5.055
r411 (  8 36 ) resistor r=0.0766821 //w=0.382 //l=0.13775 //layer=m1 \
 //thickness=0.36 //x=10.11 //y=4.135 //x2=10.06 //y2=4.25
r412 (  7 34 ) resistor r=0.087246 //w=0.395 //l=0.161555 //layer=m1 \
 //thickness=0.36 //x=10.11 //y=3.655 //x2=10.075 //y2=3.51
r413 (  7 8 ) resistor r=0.458015 //w=0.131 //l=0.48 //layer=m1 \
 //thickness=0.36 //x=10.11 //y=3.655 //x2=10.11 //y2=4.135
r414 (  6 32 ) resistor r=0.0919929 //w=0.395 //l=0.176635 //layer=m1 \
 //thickness=0.36 //x=10.11 //y=3.335 //x2=10.075 //y2=3.495
r415 (  5 12 ) resistor r=0.0698411 //w=0.17 //l=0.120208 //layer=m1 \
 //thickness=0.36 //x=10.11 //y=2.105 //x2=10.195 //y2=2.02
r416 (  5 6 ) resistor r=1.17366 //w=0.131 //l=1.23 //layer=m1 \
 //thickness=0.36 //x=10.11 //y=2.105 //x2=10.11 //y2=3.335
r417 (  4 28 ) resistor r=0.0798098 //w=0.38 //l=0.148745 //layer=m1 \
 //thickness=0.36 //x=7.15 //y=3.385 //x2=7.202 //y2=3.51
r418 (  3 26 ) resistor r=0.0736049 //w=0.235 //l=0.12 //layer=m1 \
 //thickness=0.36 //x=7.15 //y=2.385 //x2=7.15 //y2=2.265
r419 (  3 4 ) resistor r=0.954198 //w=0.131 //l=1 //layer=m1 //thickness=0.36 \
 //x=7.15 //y=2.385 //x2=7.15 //y2=3.385
r420 (  2 20 ) resistor r=0.0704783 //w=0.246 //l=0.115 //layer=m1 \
 //thickness=0.36 //x=4.93 //y=4.765 //x2=4.93 //y2=4.88
r421 (  1 24 ) resistor r=0.0902587 //w=0.349 //l=0.187617 //layer=m1 \
 //thickness=0.36 //x=4.93 //y=4.575 //x2=4.99 //y2=4.415
r422 (  1 2 ) resistor r=0.181298 //w=0.131 //l=0.19 //layer=m1 \
 //thickness=0.36 //x=4.93 //y=4.575 //x2=4.93 //y2=4.765
ends PM_FA\%noxref_3

subckt PM_FA\%B ( 1 2 3 4 5 6 7 8 9 10 11 12 13 14 15 16 17 21 48 55 60 62 64 \
 65 66 67 69 70 71 73 74 75 77 78 79 81 82 83 84 89 99 108 114 123 128 133 137 \
 138 139 140 141 142 143 144 145 146 147 148 149 150 152 155 156 163 164 168 \
 169 170 172 175 178 179 180 181 182 183 184 185 189 191 194 195 207 212 223 )
c544 ( 223 0 ) capacitor c=0.06693f //x=29.35 //y=4.88
c545 ( 212 0 ) capacitor c=0.052693f //x=10.74 //y=2.265
c546 ( 207 0 ) capacitor c=0.0660028f //x=7.15 //y=4.88
c547 ( 195 0 ) capacitor c=0.0318956f //x=29.685 //y=1.39
c548 ( 194 0 ) capacitor c=0.0186809f //x=29.685 //y=1.045
c549 ( 191 0 ) capacitor c=0.0141821f //x=29.53 //y=1.545
c550 ( 189 0 ) capacitor c=0.0158553f //x=29.53 //y=0.89
c551 ( 185 0 ) capacitor c=0.088055f //x=29.155 //y=2.095
c552 ( 184 0 ) capacitor c=0.0229235f //x=29.155 //y=1.7
c553 ( 183 0 ) capacitor c=0.0234359f //x=29.155 //y=1.39
c554 ( 182 0 ) capacitor c=0.0198759f //x=29.155 //y=1.045
c555 ( 181 0 ) capacitor c=0.0301471f //x=10.74 //y=2.1
c556 ( 180 0 ) capacitor c=0.0255528f //x=10.74 //y=1.745
c557 ( 179 0 ) capacitor c=0.0234346f //x=10.74 //y=1.435
c558 ( 178 0 ) capacitor c=0.0201416f //x=10.74 //y=1.09
c559 ( 175 0 ) capacitor c=0.0550305f //x=10.695 //y=5.045
c560 ( 172 0 ) capacitor c=0.0161993f //x=10.585 //y=1.59
c561 ( 170 0 ) capacitor c=0.0157807f //x=10.585 //y=0.935
c562 ( 169 0 ) capacitor c=0.0146709f //x=10.33 //y=4.97
c563 ( 168 0 ) capacitor c=0.0244235f //x=10.62 //y=4.97
c564 ( 164 0 ) capacitor c=0.0439448f //x=10.21 //y=1.435
c565 ( 163 0 ) capacitor c=0.0200047f //x=10.21 //y=1.09
c566 ( 156 0 ) capacitor c=0.0423887f //x=5.125 //y=1.435
c567 ( 155 0 ) capacitor c=0.0192582f //x=5.125 //y=1.09
c568 ( 152 0 ) capacitor c=0.0126237f //x=4.97 //y=1.59
c569 ( 150 0 ) capacitor c=0.0157807f //x=4.97 //y=0.935
c570 ( 149 0 ) capacitor c=0.0975112f //x=4.595 //y=2.1
c571 ( 148 0 ) capacitor c=0.0197088f //x=4.595 //y=1.745
c572 ( 147 0 ) capacitor c=0.0168511f //x=4.595 //y=1.435
c573 ( 146 0 ) capacitor c=0.0175047f //x=4.595 //y=1.09
c574 ( 145 0 ) capacitor c=0.110369f //x=29.69 //y=6.2
c575 ( 144 0 ) capacitor c=0.154476f //x=29.25 //y=6.2
c576 ( 143 0 ) capacitor c=0.154365f //x=10.695 //y=6.2
c577 ( 142 0 ) capacitor c=0.153909f //x=10.255 //y=6.2
c578 ( 141 0 ) capacitor c=0.110998f //x=7.49 //y=6.2
c579 ( 140 0 ) capacitor c=0.155254f //x=7.05 //y=6.2
c580 ( 133 0 ) capacitor c=8.16096e-19 //x=29.35 //y=4.88
c581 ( 128 0 ) capacitor c=7.85889e-19 //x=29.35 //y=2.26
c582 ( 123 0 ) capacitor c=0.00107023f //x=10.85 //y=4.88
c583 ( 114 0 ) capacitor c=6.58323e-19 //x=10.85 //y=2.265
c584 ( 108 0 ) capacitor c=0.0143211f //x=7.15 //y=4.62
c585 ( 99 0 ) capacitor c=4.74639e-19 //x=4.93 //y=2.265
c586 ( 89 0 ) capacitor c=3.76718e-19 //x=5.09 //y=3.155
c587 ( 84 0 ) capacitor c=0.209121f //x=24.01 //y=5.01
c588 ( 83 0 ) capacitor c=0.00189046f //x=22.495 //y=4.99
c589 ( 82 0 ) capacitor c=0.0304778f //x=23.41 //y=4.99
c590 ( 81 0 ) capacitor c=0.00265485f //x=22.41 //y=5.215
c591 ( 79 0 ) capacitor c=0.00614522f //x=21.51 //y=5.3
c592 ( 78 0 ) capacitor c=0.0248343f //x=22.325 //y=5.3
c593 ( 77 0 ) capacitor c=0.00285705f //x=21.425 //y=5.215
c594 ( 75 0 ) capacitor c=0.00198639f //x=18.72 //y=4.99
c595 ( 74 0 ) capacitor c=0.0684859f //x=21.34 //y=4.99
c596 ( 73 0 ) capacitor c=0.00305178f //x=18.635 //y=5.215
c597 ( 71 0 ) capacitor c=0.00742108f //x=17.95 //y=5.3
c598 ( 70 0 ) capacitor c=0.0233654f //x=18.55 //y=5.3
c599 ( 69 0 ) capacitor c=0.0031605f //x=17.865 //y=5.215
c600 ( 67 0 ) capacitor c=0.0169704f //x=11.02 //y=4.99
c601 ( 66 0 ) capacitor c=0.206373f //x=17.78 //y=4.99
c602 ( 65 0 ) capacitor c=0.0641543f //x=9.985 //y=4.655
c603 ( 64 0 ) capacitor c=0.00515745f //x=10.33 //y=4.655
c604 ( 62 0 ) capacitor c=0.00744607f //x=10.36 //y=3.11
c605 ( 60 0 ) capacitor c=0.0628251f //x=9.76 //y=3.14
c606 ( 55 0 ) capacitor c=0.00614452f //x=29.35 //y=2.26
c607 ( 48 0 ) capacitor c=0.00740115f //x=10.85 //y=2.265
c608 ( 21 0 ) capacitor c=0.0132913f //x=10.85 //y=3.3
c609 ( 17 0 ) capacitor c=0.0114489f //x=4.93 //y=2.995
c610 ( 16 0 ) capacitor c=0.00466272f //x=4.93 //y=2.415
c611 ( 15 0 ) capacitor c=0.00630066f //x=29.35 //y=4.99
c612 ( 14 0 ) capacitor c=0.00695062f //x=10.85 //y=4.99
c613 ( 13 0 ) capacitor c=0.0145274f //x=10.85 //y=3.14
c614 ( 12 0 ) capacitor c=0.013641f //x=7.15 //y=4.62
c615 ( 11 0 ) capacitor c=0.0271572f //x=4.93 //y=3.14
c616 ( 5 0 ) capacitor c=0.0692545f //x=29.35 //y=2.77
c617 ( 2 0 ) capacitor c=0.0298825f //x=10.85 //y=3.51
c618 ( 1 0 ) capacitor c=0.0100326f //x=10.85 //y=2.77
r619 (  221 223 ) resistor r=20.6867 //w=0.233 //l=0.1 //layer=ply \
 //thickness=0.18 //x=29.25 //y=4.88 //x2=29.35 //y2=4.88
r620 (  212 214 ) resistor r=17.5563 //w=0.302 //l=0.11 //layer=ply \
 //thickness=0.18 //x=10.74 //y=2.265 //x2=10.85 //y2=2.265
r621 (  205 207 ) resistor r=20.6867 //w=0.233 //l=0.1 //layer=ply \
 //thickness=0.18 //x=7.05 //y=4.88 //x2=7.15 //y2=4.88
r622 (  196 223 ) resistor r=70.3348 //w=0.233 //l=0.414367 //layer=ply \
 //thickness=0.18 //x=29.69 //y=5.045 //x2=29.35 //y2=4.88
r623 (  195 225 ) resistor r=45.1352 //w=0.168 //l=0.173853 //layer=ply \
 //thickness=0.18 //x=29.685 //y=1.39 //x2=29.645 //y2=1.545
r624 (  194 224 ) resistor r=45.1352 //w=0.168 //l=0.173853 //layer=ply \
 //thickness=0.18 //x=29.685 //y=1.045 //x2=29.645 //y2=0.89
r625 (  194 195 ) resistor r=176.904 //w=0.094 //l=0.345 //layer=ply \
 //thickness=0.18 //x=29.685 //y=1.045 //x2=29.685 //y2=1.39
r626 (  192 220 ) resistor r=10.701 //w=0.21 //l=0.115 //layer=ply \
 //thickness=0.18 //x=29.31 //y=1.545 //x2=29.195 //y2=1.545
r627 (  191 225 ) resistor r=5.52526 //w=0.168 //l=0.115 //layer=ply \
 //thickness=0.18 //x=29.53 //y=1.545 //x2=29.645 //y2=1.545
r628 (  190 219 ) resistor r=5.52526 //w=0.168 //l=0.115 //layer=ply \
 //thickness=0.18 //x=29.31 //y=0.89 //x2=29.195 //y2=0.89
r629 (  189 224 ) resistor r=5.52526 //w=0.168 //l=0.115 //layer=ply \
 //thickness=0.18 //x=29.53 //y=0.89 //x2=29.645 //y2=0.89
r630 (  189 190 ) resistor r=112.809 //w=0.094 //l=0.22 //layer=ply \
 //thickness=0.18 //x=29.53 //y=0.89 //x2=29.31 //y2=0.89
r631 (  186 221 ) resistor r=13.0941 //w=0.233 //l=0.165 //layer=ply \
 //thickness=0.18 //x=29.25 //y=5.045 //x2=29.25 //y2=4.88
r632 (  185 218 ) resistor r=34.8111 //w=0.27 //l=0.264953 //layer=ply \
 //thickness=0.18 //x=29.155 //y=2.095 //x2=29.35 //y2=2.26
r633 (  184 220 ) resistor r=39.5823 //w=0.21 //l=0.173853 //layer=ply \
 //thickness=0.18 //x=29.155 //y=1.7 //x2=29.195 //y2=1.545
r634 (  184 185 ) resistor r=202.543 //w=0.094 //l=0.395 //layer=ply \
 //thickness=0.18 //x=29.155 //y=1.7 //x2=29.155 //y2=2.095
r635 (  183 220 ) resistor r=39.5823 //w=0.21 //l=0.173853 //layer=ply \
 //thickness=0.18 //x=29.155 //y=1.39 //x2=29.195 //y2=1.545
r636 (  182 219 ) resistor r=45.1352 //w=0.168 //l=0.173853 //layer=ply \
 //thickness=0.18 //x=29.155 //y=1.045 //x2=29.195 //y2=0.89
r637 (  182 183 ) resistor r=176.904 //w=0.094 //l=0.345 //layer=ply \
 //thickness=0.18 //x=29.155 //y=1.045 //x2=29.155 //y2=1.39
r638 (  181 212 ) resistor r=19.1248 //w=0.302 //l=0.165 //layer=ply \
 //thickness=0.18 //x=10.74 //y=2.1 //x2=10.74 //y2=2.265
r639 (  180 211 ) resistor r=39.5823 //w=0.21 //l=0.173853 //layer=ply \
 //thickness=0.18 //x=10.74 //y=1.745 //x2=10.7 //y2=1.59
r640 (  180 181 ) resistor r=182.032 //w=0.094 //l=0.355 //layer=ply \
 //thickness=0.18 //x=10.74 //y=1.745 //x2=10.74 //y2=2.1
r641 (  179 211 ) resistor r=39.5823 //w=0.21 //l=0.173853 //layer=ply \
 //thickness=0.18 //x=10.74 //y=1.435 //x2=10.7 //y2=1.59
r642 (  178 210 ) resistor r=45.1352 //w=0.168 //l=0.173853 //layer=ply \
 //thickness=0.18 //x=10.74 //y=1.09 //x2=10.7 //y2=0.935
r643 (  178 179 ) resistor r=176.904 //w=0.094 //l=0.345 //layer=ply \
 //thickness=0.18 //x=10.74 //y=1.09 //x2=10.74 //y2=1.435
r644 (  175 216 ) resistor r=26.3063 //w=0.284 //l=0.229783 //layer=ply \
 //thickness=0.18 //x=10.695 //y=5.045 //x2=10.85 //y2=4.88
r645 (  173 209 ) resistor r=5.52526 //w=0.168 //l=0.115 //layer=ply \
 //thickness=0.18 //x=10.365 //y=1.59 //x2=10.25 //y2=1.59
r646 (  172 211 ) resistor r=10.701 //w=0.21 //l=0.115 //layer=ply \
 //thickness=0.18 //x=10.585 //y=1.59 //x2=10.7 //y2=1.59
r647 (  171 208 ) resistor r=5.52526 //w=0.168 //l=0.115 //layer=ply \
 //thickness=0.18 //x=10.365 //y=0.935 //x2=10.25 //y2=0.935
r648 (  170 210 ) resistor r=5.52526 //w=0.168 //l=0.115 //layer=ply \
 //thickness=0.18 //x=10.585 //y=0.935 //x2=10.7 //y2=0.935
r649 (  170 171 ) resistor r=112.809 //w=0.094 //l=0.22 //layer=ply \
 //thickness=0.18 //x=10.585 //y=0.935 //x2=10.365 //y2=0.935
r650 (  168 175 ) resistor r=23.403 //w=0.284 //l=0.106066 //layer=ply \
 //thickness=0.18 //x=10.62 //y=4.97 //x2=10.695 //y2=5.045
r651 (  168 169 ) resistor r=148.702 //w=0.094 //l=0.29 //layer=ply \
 //thickness=0.18 //x=10.62 //y=4.97 //x2=10.33 //y2=4.97
r652 (  165 169 ) resistor r=26.9307 //w=0.15 //l=0.106066 //layer=ply \
 //thickness=0.18 //x=10.255 //y=5.045 //x2=10.33 //y2=4.97
r653 (  164 209 ) resistor r=45.1352 //w=0.168 //l=0.173853 //layer=ply \
 //thickness=0.18 //x=10.21 //y=1.435 //x2=10.25 //y2=1.59
r654 (  163 208 ) resistor r=45.1352 //w=0.168 //l=0.173853 //layer=ply \
 //thickness=0.18 //x=10.21 //y=1.09 //x2=10.25 //y2=0.935
r655 (  163 164 ) resistor r=176.904 //w=0.094 //l=0.345 //layer=ply \
 //thickness=0.18 //x=10.21 //y=1.09 //x2=10.21 //y2=1.435
r656 (  160 207 ) resistor r=70.3348 //w=0.233 //l=0.414367 //layer=ply \
 //thickness=0.18 //x=7.49 //y=5.045 //x2=7.15 //y2=4.88
r657 (  157 205 ) resistor r=13.0941 //w=0.233 //l=0.165 //layer=ply \
 //thickness=0.18 //x=7.05 //y=5.045 //x2=7.05 //y2=4.88
r658 (  156 204 ) resistor r=45.1352 //w=0.168 //l=0.173853 //layer=ply \
 //thickness=0.18 //x=5.125 //y=1.435 //x2=5.085 //y2=1.59
r659 (  155 203 ) resistor r=45.1352 //w=0.168 //l=0.173853 //layer=ply \
 //thickness=0.18 //x=5.125 //y=1.09 //x2=5.085 //y2=0.935
r660 (  155 156 ) resistor r=176.904 //w=0.094 //l=0.345 //layer=ply \
 //thickness=0.18 //x=5.125 //y=1.09 //x2=5.125 //y2=1.435
r661 (  153 200 ) resistor r=10.701 //w=0.21 //l=0.115 //layer=ply \
 //thickness=0.18 //x=4.75 //y=1.59 //x2=4.635 //y2=1.59
r662 (  152 204 ) resistor r=5.52526 //w=0.168 //l=0.115 //layer=ply \
 //thickness=0.18 //x=4.97 //y=1.59 //x2=5.085 //y2=1.59
r663 (  151 199 ) resistor r=5.52526 //w=0.168 //l=0.115 //layer=ply \
 //thickness=0.18 //x=4.75 //y=0.935 //x2=4.635 //y2=0.935
r664 (  150 203 ) resistor r=5.52526 //w=0.168 //l=0.115 //layer=ply \
 //thickness=0.18 //x=4.97 //y=0.935 //x2=5.085 //y2=0.935
r665 (  150 151 ) resistor r=112.809 //w=0.094 //l=0.22 //layer=ply \
 //thickness=0.18 //x=4.97 //y=0.935 //x2=4.75 //y2=0.935
r666 (  149 202 ) resistor r=67.2792 //w=0.24 //l=0.438891 //layer=ply \
 //thickness=0.18 //x=4.595 //y=2.1 //x2=4.93 //y2=2.34
r667 (  148 200 ) resistor r=39.5823 //w=0.21 //l=0.173853 //layer=ply \
 //thickness=0.18 //x=4.595 //y=1.745 //x2=4.635 //y2=1.59
r668 (  148 149 ) resistor r=182.032 //w=0.094 //l=0.355 //layer=ply \
 //thickness=0.18 //x=4.595 //y=1.745 //x2=4.595 //y2=2.1
r669 (  147 200 ) resistor r=39.5823 //w=0.21 //l=0.173853 //layer=ply \
 //thickness=0.18 //x=4.595 //y=1.435 //x2=4.635 //y2=1.59
r670 (  146 199 ) resistor r=45.1352 //w=0.168 //l=0.173853 //layer=ply \
 //thickness=0.18 //x=4.595 //y=1.09 //x2=4.635 //y2=0.935
r671 (  146 147 ) resistor r=176.904 //w=0.094 //l=0.345 //layer=ply \
 //thickness=0.18 //x=4.595 //y=1.09 //x2=4.595 //y2=1.435
r672 (  145 196 ) resistor r=592.245 //w=0.094 //l=1.155 //layer=ply \
 //thickness=0.18 //x=29.69 //y=6.2 //x2=29.69 //y2=5.045
r673 (  144 186 ) resistor r=592.245 //w=0.094 //l=1.155 //layer=ply \
 //thickness=0.18 //x=29.25 //y=6.2 //x2=29.25 //y2=5.045
r674 (  143 175 ) resistor r=592.245 //w=0.094 //l=1.155 //layer=ply \
 //thickness=0.18 //x=10.695 //y=6.2 //x2=10.695 //y2=5.045
r675 (  142 165 ) resistor r=592.245 //w=0.094 //l=1.155 //layer=ply \
 //thickness=0.18 //x=10.255 //y=6.2 //x2=10.255 //y2=5.045
r676 (  141 160 ) resistor r=592.245 //w=0.094 //l=1.155 //layer=ply \
 //thickness=0.18 //x=7.49 //y=6.2 //x2=7.49 //y2=5.045
r677 (  140 157 ) resistor r=592.245 //w=0.094 //l=1.155 //layer=ply \
 //thickness=0.18 //x=7.05 //y=6.2 //x2=7.05 //y2=5.045
r678 (  139 191 ) resistor r=56.4043 //w=0.094 //l=0.11 //layer=ply \
 //thickness=0.18 //x=29.42 //y=1.545 //x2=29.53 //y2=1.545
r679 (  139 192 ) resistor r=56.4043 //w=0.094 //l=0.11 //layer=ply \
 //thickness=0.18 //x=29.42 //y=1.545 //x2=29.31 //y2=1.545
r680 (  138 172 ) resistor r=56.4043 //w=0.094 //l=0.11 //layer=ply \
 //thickness=0.18 //x=10.475 //y=1.59 //x2=10.585 //y2=1.59
r681 (  138 173 ) resistor r=56.4043 //w=0.094 //l=0.11 //layer=ply \
 //thickness=0.18 //x=10.475 //y=1.59 //x2=10.365 //y2=1.59
r682 (  137 152 ) resistor r=56.4043 //w=0.094 //l=0.11 //layer=ply \
 //thickness=0.18 //x=4.86 //y=1.59 //x2=4.97 //y2=1.59
r683 (  137 153 ) resistor r=56.4043 //w=0.094 //l=0.11 //layer=ply \
 //thickness=0.18 //x=4.86 //y=1.59 //x2=4.75 //y2=1.59
r684 (  133 223 ) resistor r=152 //w=0.17 //l=0.17 //layer=licon //count=1 \
 //x=29.35 //y=4.88 //x2=29.35 //y2=4.88
r685 (  128 218 ) resistor r=152 //w=0.17 //l=0.17 //layer=licon //count=1 \
 //x=29.35 //y=2.26 //x2=29.35 //y2=2.26
r686 (  123 216 ) resistor r=152 //w=0.17 //l=0.17 //layer=licon //count=1 \
 //x=10.85 //y=4.88 //x2=10.85 //y2=4.88
r687 (  114 214 ) resistor r=152 //w=0.17 //l=0.17 //layer=licon //count=1 \
 //x=10.85 //y=2.265 //x2=10.85 //y2=2.265
r688 (  111 207 ) resistor r=152 //w=0.17 //l=0.17 //layer=licon //count=1 \
 //x=7.15 //y=4.88 //x2=7.15 //y2=4.88
r689 (  108 111 ) resistor r=17.7968 //w=0.187 //l=0.26 //layer=li \
 //thickness=0.1 //x=7.15 //y=4.62 //x2=7.15 //y2=4.88
r690 (  99 202 ) resistor r=152 //w=0.17 //l=0.17 //layer=licon //count=1 \
 //x=4.93 //y=2.265 //x2=4.93 //y2=2.265
r691 (  87 89 ) resistor r=0.10734 //w=0.281 //l=0.16 //layer=m2 \
 //thickness=0.36 //x=4.93 //y=3.155 //x2=5.09 //y2=3.155
r692 (  84 97 ) resistor r=3.72949 //w=0.179 //l=5.3724 //layer=m2 \
 //thickness=0.36 //x=24.01 //y=5.01 //x2=29.35 //y2=4.945
r693 (  84 85 ) resistor r=0.329198 //w=0.131 //l=0.345 //layer=m2 \
 //thickness=0.36 //x=24.01 //y=5.01 //x2=23.665 //y2=5.01
r694 (  82 85 ) resistor r=0.1875 //w=0.17 //l=0.264811 //layer=m2 \
 //thickness=0.36 //x=23.41 //y=4.99 //x2=23.665 //y2=5.01
r695 (  82 83 ) resistor r=0.873092 //w=0.131 //l=0.915 //layer=m2 \
 //thickness=0.36 //x=23.41 //y=4.99 //x2=22.495 //y2=4.99
r696 (  80 83 ) resistor r=0.0698411 //w=0.17 //l=0.120208 //layer=m2 \
 //thickness=0.36 //x=22.41 //y=5.075 //x2=22.495 //y2=4.99
r697 (  80 81 ) resistor r=0.133588 //w=0.131 //l=0.14 //layer=m2 \
 //thickness=0.36 //x=22.41 //y=5.075 //x2=22.41 //y2=5.215
r698 (  78 81 ) resistor r=0.0698411 //w=0.17 //l=0.120208 //layer=m2 \
 //thickness=0.36 //x=22.325 //y=5.3 //x2=22.41 //y2=5.215
r699 (  78 79 ) resistor r=0.777672 //w=0.131 //l=0.815 //layer=m2 \
 //thickness=0.36 //x=22.325 //y=5.3 //x2=21.51 //y2=5.3
r700 (  77 79 ) resistor r=0.0698411 //w=0.17 //l=0.120208 //layer=m2 \
 //thickness=0.36 //x=21.425 //y=5.215 //x2=21.51 //y2=5.3
r701 (  76 77 ) resistor r=0.133588 //w=0.131 //l=0.14 //layer=m2 \
 //thickness=0.36 //x=21.425 //y=5.075 //x2=21.425 //y2=5.215
r702 (  74 76 ) resistor r=0.0698411 //w=0.17 //l=0.120208 //layer=m2 \
 //thickness=0.36 //x=21.34 //y=4.99 //x2=21.425 //y2=5.075
r703 (  74 75 ) resistor r=2.5 //w=0.131 //l=2.62 //layer=m2 //thickness=0.36 \
 //x=21.34 //y=4.99 //x2=18.72 //y2=4.99
r704 (  72 75 ) resistor r=0.0698411 //w=0.17 //l=0.120208 //layer=m2 \
 //thickness=0.36 //x=18.635 //y=5.075 //x2=18.72 //y2=4.99
r705 (  72 73 ) resistor r=0.133588 //w=0.131 //l=0.14 //layer=m2 \
 //thickness=0.36 //x=18.635 //y=5.075 //x2=18.635 //y2=5.215
r706 (  70 73 ) resistor r=0.0698411 //w=0.17 //l=0.120208 //layer=m2 \
 //thickness=0.36 //x=18.55 //y=5.3 //x2=18.635 //y2=5.215
r707 (  70 71 ) resistor r=0.572519 //w=0.131 //l=0.6 //layer=m2 \
 //thickness=0.36 //x=18.55 //y=5.3 //x2=17.95 //y2=5.3
r708 (  69 71 ) resistor r=0.0698411 //w=0.17 //l=0.120208 //layer=m2 \
 //thickness=0.36 //x=17.865 //y=5.215 //x2=17.95 //y2=5.3
r709 (  68 69 ) resistor r=0.133588 //w=0.131 //l=0.14 //layer=m2 \
 //thickness=0.36 //x=17.865 //y=5.075 //x2=17.865 //y2=5.215
r710 (  67 95 ) resistor r=0.0898186 //w=0.311 //l=0.209762 //layer=m2 \
 //thickness=0.36 //x=11.02 //y=4.99 //x2=10.86 //y2=4.875
r711 (  66 68 ) resistor r=0.0698411 //w=0.17 //l=0.120208 //layer=m2 \
 //thickness=0.36 //x=17.78 //y=4.99 //x2=17.865 //y2=5.075
r712 (  66 67 ) resistor r=6.45038 //w=0.131 //l=6.76 //layer=m2 \
 //thickness=0.36 //x=17.78 //y=4.99 //x2=11.02 //y2=4.99
r713 (  65 91 ) resistor r=1.89634 //w=0.187 //l=2.8584 //layer=m2 \
 //thickness=0.36 //x=9.985 //y=4.655 //x2=7.15 //y2=4.702
r714 (  64 95 ) resistor r=0.238532 //w=0.311 //l=0.630476 //layer=m2 \
 //thickness=0.36 //x=10.33 //y=4.655 //x2=10.86 //y2=4.875
r715 (  64 65 ) resistor r=0.329198 //w=0.131 //l=0.345 //layer=m2 \
 //thickness=0.36 //x=10.33 //y=4.655 //x2=9.985 //y2=4.655
r716 (  62 93 ) resistor r=0.259285 //w=0.245 //l=0.499775 //layer=m2 \
 //thickness=0.36 //x=10.36 //y=3.11 //x2=10.845 //y2=3.14
r717 (  62 63 ) resistor r=0.410305 //w=0.131 //l=0.43 //layer=m2 \
 //thickness=0.36 //x=10.36 //y=3.11 //x2=9.93 //y2=3.11
r718 (  60 63 ) resistor r=0.125 //w=0.17 //l=0.184391 //layer=m2 \
 //thickness=0.36 //x=9.76 //y=3.14 //x2=9.93 //y2=3.11
r719 (  60 89 ) resistor r=4.45611 //w=0.131 //l=4.67 //layer=m2 \
 //thickness=0.36 //x=9.76 //y=3.14 //x2=5.09 //y2=3.14
r720 (  55 128 ) resistor r=9.3 //w=0.17 //l=0.17 //layer=mcon //count=1 \
 //x=29.35 //y=2.26 //x2=29.35 //y2=2.26
r721 (  53 95 ) resistor r=4.5 //w=0.15 //l=0.15 //layer=via1 //count=1 \
 //x=10.86 //y=4.885 //x2=10.86 //y2=4.885
r722 (  48 114 ) resistor r=9.3 //w=0.17 //l=0.17 //layer=mcon //count=1 \
 //x=10.85 //y=2.265 //x2=10.85 //y2=2.265
r723 (  43 91 ) resistor r=4.5 //w=0.15 //l=0.15 //layer=via1 //count=1 \
 //x=7.15 //y=4.71 //x2=7.15 //y2=4.71
r724 (  39 87 ) resistor r=4.5 //w=0.15 //l=0.15 //layer=via1 //count=1 \
 //x=4.93 //y=3.155 //x2=4.93 //y2=3.155
r725 (  34 99 ) resistor r=9.3 //w=0.17 //l=0.17 //layer=mcon //count=1 \
 //x=4.93 //y=2.265 //x2=4.93 //y2=2.265
r726 (  26 55 ) resistor r=0.0933015 //w=0.201 //l=0.125 //layer=m1 \
 //thickness=0.36 //x=29.35 //y=2.385 //x2=29.35 //y2=2.26
r727 (  18 48 ) resistor r=0.116051 //w=0.211 //l=0.165 //layer=m1 \
 //thickness=0.36 //x=10.85 //y=2.43 //x2=10.85 //y2=2.265
r728 (  16 17 ) resistor r=0.553435 //w=0.131 //l=0.58 //layer=m1 \
 //thickness=0.36 //x=4.93 //y=2.415 //x2=4.93 //y2=2.995
r729 (  15 133 ) resistor r=9.3 //w=0.17 //l=0.17 //layer=mcon //count=1 \
 //x=29.35 //y=4.88 //x2=29.35 //y2=4.88
r730 (  15 97 ) resistor r=4.5 //w=0.15 //l=0.15 //layer=via1 //count=1 \
 //x=29.35 //y=4.945 //x2=29.35 //y2=4.945
r731 (  15 27 ) resistor r=0.051659 //w=0.354 //l=0.182 //layer=m1 \
 //thickness=0.36 //x=29.35 //y=4.922 //x2=29.35 //y2=4.74
r732 (  14 123 ) resistor r=9.3 //w=0.17 //l=0.17 //layer=mcon //count=1 \
 //x=10.85 //y=4.88 //x2=10.85 //y2=4.88
r733 (  14 53 ) resistor r=0.00372024 //w=0.336 //l=0.01 //layer=m1 \
 //thickness=0.36 //x=10.85 //y=4.9 //x2=10.86 //y2=4.9
r734 (  14 22 ) resistor r=0.0484709 //w=0.336 //l=0.175 //layer=m1 \
 //thickness=0.36 //x=10.85 //y=4.9 //x2=10.85 //y2=4.725
r735 (  13 93 ) resistor r=4.5 //w=0.15 //l=0.15 //layer=via1 //count=1 \
 //x=10.845 //y=3.14 //x2=10.845 //y2=3.14
r736 (  13 21 ) resistor r=0.0910802 //w=0.374 //l=0.185472 //layer=m1 \
 //thickness=0.36 //x=10.795 //y=3.14 //x2=10.85 //y2=3.3
r737 (  13 19 ) resistor r=0.0910802 //w=0.374 //l=0.185472 //layer=m1 \
 //thickness=0.36 //x=10.795 //y=3.14 //x2=10.85 //y2=2.98
r738 (  12 108 ) resistor r=9.3 //w=0.17 //l=0.17 //layer=mcon //count=1 \
 //x=7.15 //y=4.62 //x2=7.15 //y2=4.62
r739 (  12 43 ) resistor r=0.0317797 //w=0.354 //l=0.09 //layer=m1 \
 //thickness=0.36 //x=7.202 //y=4.62 //x2=7.202 //y2=4.71
r740 (  11 39 ) resistor r=0.0049867 //w=0.376 //l=0.015 //layer=m1 \
 //thickness=0.36 //x=4.982 //y=3.14 //x2=4.982 //y2=3.155
r741 (  11 17 ) resistor r=0.0861726 //w=0.376 //l=0.169012 //layer=m1 \
 //thickness=0.36 //x=4.982 //y=3.14 //x2=4.93 //y2=2.995
r742 (  10 16 ) resistor r=0.0182676 //w=0.238 //l=0.0164317 //layer=m1 \
 //thickness=0.36 //x=4.927 //y=2.4 //x2=4.93 //y2=2.415
r743 (  10 34 ) resistor r=0.0709034 //w=0.238 //l=0.135 //layer=m1 \
 //thickness=0.36 //x=4.927 //y=2.4 //x2=4.927 //y2=2.265
r744 (  9 27 ) resistor r=0.114504 //w=0.131 //l=0.12 //layer=m1 \
 //thickness=0.36 //x=29.35 //y=4.62 //x2=29.35 //y2=4.74
r745 (  8 9 ) resistor r=0.353053 //w=0.131 //l=0.37 //layer=m1 \
 //thickness=0.36 //x=29.35 //y=4.25 //x2=29.35 //y2=4.62
r746 (  7 8 ) resistor r=0.353053 //w=0.131 //l=0.37 //layer=m1 \
 //thickness=0.36 //x=29.35 //y=3.88 //x2=29.35 //y2=4.25
r747 (  6 7 ) resistor r=0.353053 //w=0.131 //l=0.37 //layer=m1 \
 //thickness=0.36 //x=29.35 //y=3.51 //x2=29.35 //y2=3.88
r748 (  5 6 ) resistor r=0.706107 //w=0.131 //l=0.74 //layer=m1 \
 //thickness=0.36 //x=29.35 //y=2.77 //x2=29.35 //y2=3.51
r749 (  5 26 ) resistor r=0.367366 //w=0.131 //l=0.385 //layer=m1 \
 //thickness=0.36 //x=29.35 //y=2.77 //x2=29.35 //y2=2.385
r750 (  4 22 ) resistor r=0.100191 //w=0.131 //l=0.105 //layer=m1 \
 //thickness=0.36 //x=10.85 //y=4.62 //x2=10.85 //y2=4.725
r751 (  3 4 ) resistor r=0.353053 //w=0.131 //l=0.37 //layer=m1 \
 //thickness=0.36 //x=10.85 //y=4.25 //x2=10.85 //y2=4.62
r752 (  2 3 ) resistor r=0.706107 //w=0.131 //l=0.74 //layer=m1 \
 //thickness=0.36 //x=10.85 //y=3.51 //x2=10.85 //y2=4.25
r753 (  2 21 ) resistor r=0.200382 //w=0.131 //l=0.21 //layer=m1 \
 //thickness=0.36 //x=10.85 //y=3.51 //x2=10.85 //y2=3.3
r754 (  1 19 ) resistor r=0.200382 //w=0.131 //l=0.21 //layer=m1 \
 //thickness=0.36 //x=10.85 //y=2.77 //x2=10.85 //y2=2.98
r755 (  1 18 ) resistor r=0.324427 //w=0.131 //l=0.34 //layer=m1 \
 //thickness=0.36 //x=10.85 //y=2.77 //x2=10.85 //y2=2.43
ends PM_FA\%B

subckt PM_FA\%noxref_5 ( 1 2 3 5 6 8 9 10 11 12 13 15 16 18 19 20 21 22 23 24 \
 25 26 27 28 29 30 31 32 33 39 42 48 52 62 65 85 86 88 90 92 97 100 101 102 \
 103 110 112 113 116 117 122 139 156 169 174 183 188 193 197 198 199 200 201 \
 202 203 204 205 206 207 208 209 213 214 215 217 223 224 225 226 227 228 232 \
 234 237 238 242 243 244 249 251 253 259 260 262 276 280 281 284 292 293 296 \
 297 )
c735 ( 293 0 ) capacitor c=0.00849198f //x=8 //y=1.09
c736 ( 292 0 ) capacitor c=0.00849198f //x=4.67 //y=1.09
c737 ( 284 0 ) capacitor c=0.0393541f //x=24.57 //y=4.88
c738 ( 281 0 ) capacitor c=0.0284095f //x=24.54 //y=2.095
c739 ( 280 0 ) capacitor c=0.0455897f //x=24.54 //y=2.26
c740 ( 276 0 ) capacitor c=0.066434f //x=14.92 //y=4.88
c741 ( 262 0 ) capacitor c=0.0550826f //x=12.33 //y=2.265
c742 ( 260 0 ) capacitor c=0.0439708f //x=25.105 //y=1.43
c743 ( 259 0 ) capacitor c=0.0192582f //x=25.105 //y=1.085
c744 ( 253 0 ) capacitor c=0.0162526f //x=24.95 //y=1.585
c745 ( 251 0 ) capacitor c=0.0157807f //x=24.95 //y=0.93
c746 ( 249 0 ) capacitor c=0.0373491f //x=24.945 //y=4.97
c747 ( 244 0 ) capacitor c=0.0210762f //x=24.575 //y=1.74
c748 ( 243 0 ) capacitor c=0.0168511f //x=24.575 //y=1.43
c749 ( 242 0 ) capacitor c=0.0175485f //x=24.575 //y=1.085
c750 ( 238 0 ) capacitor c=0.0318956f //x=15.255 //y=1.395
c751 ( 237 0 ) capacitor c=0.0186836f //x=15.255 //y=1.05
c752 ( 234 0 ) capacitor c=0.0141821f //x=15.1 //y=1.55
c753 ( 232 0 ) capacitor c=0.0158569f //x=15.1 //y=0.895
c754 ( 228 0 ) capacitor c=0.0900967f //x=14.725 //y=2.1
c755 ( 227 0 ) capacitor c=0.0230021f //x=14.725 //y=1.705
c756 ( 226 0 ) capacitor c=0.0234359f //x=14.725 //y=1.395
c757 ( 225 0 ) capacitor c=0.0198787f //x=14.725 //y=1.05
c758 ( 224 0 ) capacitor c=0.0439596f //x=12.97 //y=1.435
c759 ( 223 0 ) capacitor c=0.0200164f //x=12.97 //y=1.09
c760 ( 217 0 ) capacitor c=0.0161993f //x=12.815 //y=1.59
c761 ( 215 0 ) capacitor c=0.0157807f //x=12.815 //y=0.935
c762 ( 214 0 ) capacitor c=0.0497323f //x=12.56 //y=4.97
c763 ( 213 0 ) capacitor c=0.0399032f //x=12.85 //y=4.97
c764 ( 209 0 ) capacitor c=0.0301471f //x=12.44 //y=2.1
c765 ( 208 0 ) capacitor c=0.0255349f //x=12.44 //y=1.745
c766 ( 207 0 ) capacitor c=0.0234346f //x=12.44 //y=1.435
c767 ( 206 0 ) capacitor c=0.02013f //x=12.44 //y=1.09
c768 ( 205 0 ) capacitor c=0.155269f //x=25.02 //y=6.2
c769 ( 204 0 ) capacitor c=0.110375f //x=24.58 //y=6.2
c770 ( 203 0 ) capacitor c=0.110998f //x=15.26 //y=6.2
c771 ( 202 0 ) capacitor c=0.155253f //x=14.82 //y=6.2
c772 ( 201 0 ) capacitor c=0.153906f //x=12.925 //y=6.2
c773 ( 200 0 ) capacitor c=0.154399f //x=12.485 //y=6.2
c774 ( 193 0 ) capacitor c=8.90417e-19 //x=24.57 //y=4.88
c775 ( 188 0 ) capacitor c=7.72439e-19 //x=24.54 //y=2.26
c776 ( 183 0 ) capacitor c=9.9544e-19 //x=14.92 //y=4.88
c777 ( 174 0 ) capacitor c=0.00134139f //x=14.92 //y=2.265
c778 ( 169 0 ) capacitor c=8.02993e-19 //x=12.33 //y=4.88
c779 ( 156 0 ) capacitor c=0.00102889f //x=12.33 //y=2.265
c780 ( 139 0 ) capacitor c=0.0232369f //x=8.15 //y=5.555
c781 ( 122 0 ) capacitor c=0.0235809f //x=4.82 //y=5.555
c782 ( 117 0 ) capacitor c=0.0425613f //x=14.755 //y=4.255
c783 ( 116 0 ) capacitor c=6.79304e-19 //x=14.915 //y=4.255
c784 ( 113 0 ) capacitor c=0.00734787f //x=12.175 //y=3.76
c785 ( 112 0 ) capacitor c=0.00169282f //x=12.335 //y=3.76
c786 ( 110 0 ) capacitor c=6.88683e-19 //x=12.495 //y=2.415
c787 ( 103 0 ) capacitor c=0.00627802f //x=11.905 //y=3.842
c788 ( 102 0 ) capacitor c=0.041995f //x=11.765 //y=3.842
c789 ( 101 0 ) capacitor c=0.00703747f //x=8.805 //y=3.895
c790 ( 100 0 ) capacitor c=0.0332019f //x=8.485 //y=3.895
c791 ( 97 0 ) capacitor c=0.00571035f //x=5.625 //y=3.895
c792 ( 92 0 ) capacitor c=0.0824652f //x=19.56 //y=2.37
c793 ( 90 0 ) capacitor c=0.0536503f //x=18.96 //y=2.4
c794 ( 88 0 ) capacitor c=0.00521237f //x=13.285 //y=2.385
c795 ( 86 0 ) capacitor c=0.00638602f //x=12.685 //y=2.4
c796 ( 85 0 ) capacitor c=2.21869e-19 //x=12.49 //y=4.25
c797 ( 65 0 ) capacitor c=0.0152624f //x=14.92 //y=4.25
c798 ( 62 0 ) capacitor c=0.0128004f //x=12.33 //y=4.25
c799 ( 52 0 ) capacitor c=0.014229f //x=12.33 //y=3.715
c800 ( 48 0 ) capacitor c=0.0170398f //x=8.63 //y=3.88
c801 ( 42 0 ) capacitor c=0.01028f //x=8.15 //y=5.385
c802 ( 39 0 ) capacitor c=0.0184853f //x=5.47 //y=3.88
c803 ( 33 0 ) capacitor c=0.0123291f //x=4.82 //y=5.385
c804 ( 32 0 ) capacitor c=0.0534108f //x=24.54 //y=4.735
c805 ( 31 0 ) capacitor c=0.00849859f //x=24.54 //y=2.575
c806 ( 30 0 ) capacitor c=0.0108377f //x=14.92 //y=4.765
c807 ( 29 0 ) capacitor c=0.0121359f //x=14.92 //y=4.415
c808 ( 28 0 ) capacitor c=0.055529f //x=14.92 //y=4.095
c809 ( 27 0 ) capacitor c=0.00507729f //x=14.92 //y=2.42
c810 ( 26 0 ) capacitor c=0.00775954f //x=12.33 //y=4.76
c811 ( 25 0 ) capacitor c=0.0109688f //x=12.33 //y=4.41
c812 ( 24 0 ) capacitor c=0.00512393f //x=12.33 //y=4.09
c813 ( 23 0 ) capacitor c=0.0136717f //x=12.33 //y=3.92
c814 ( 22 0 ) capacitor c=0.0238103f //x=12.33 //y=3.6
c815 ( 21 0 ) capacitor c=0.0126485f //x=12.33 //y=2.575
c816 ( 20 0 ) capacitor c=0.0240149f //x=8.63 //y=5.3
c817 ( 19 0 ) capacitor c=0.0121721f //x=8.63 //y=4.055
c818 ( 18 0 ) capacitor c=0.0357111f //x=8.63 //y=3.735
c819 ( 16 0 ) capacitor c=0.00230224f //x=8.275 //y=1.835
c820 ( 15 0 ) capacitor c=0.0133049f //x=8.545 //y=1.835
c821 ( 13 0 ) capacitor c=0.00837307f //x=8.545 //y=5.385
c822 ( 12 0 ) capacitor c=0.00892846f //x=8.19 //y=1.75
c823 ( 11 0 ) capacitor c=0.00943266f //x=8.19 //y=1.3
c824 ( 10 0 ) capacitor c=0.0269411f //x=5.42 //y=5.3
c825 ( 9 0 ) capacitor c=0.0170141f //x=5.42 //y=4.055
c826 ( 8 0 ) capacitor c=0.0453184f //x=5.42 //y=3.735
c827 ( 6 0 ) capacitor c=0.00262307f //x=4.945 //y=1.835
c828 ( 5 0 ) capacitor c=0.0172538f //x=5.335 //y=1.835
c829 ( 3 0 ) capacitor c=0.0126655f //x=5.335 //y=5.385
c830 ( 2 0 ) capacitor c=0.00993239f //x=4.86 //y=1.75
c831 ( 1 0 ) capacitor c=0.0100508f //x=4.86 //y=1.305
r832 (  286 287 ) resistor r=32.4568 //w=0.214 //l=0.075 //layer=ply \
 //thickness=0.18 //x=24.57 //y=4.97 //x2=24.57 //y2=5.045
r833 (  284 286 ) resistor r=20.271 //w=0.214 //l=0.09 //layer=ply \
 //thickness=0.18 //x=24.57 //y=4.88 //x2=24.57 //y2=4.97
r834 (  280 281 ) resistor r=52.7279 //w=0.214 //l=0.165 //layer=ply \
 //thickness=0.18 //x=24.54 //y=2.26 //x2=24.54 //y2=2.095
r835 (  274 276 ) resistor r=20.6867 //w=0.233 //l=0.1 //layer=ply \
 //thickness=0.18 //x=14.82 //y=4.88 //x2=14.92 //y2=4.88
r836 (  262 263 ) resistor r=17.5563 //w=0.302 //l=0.11 //layer=ply \
 //thickness=0.18 //x=12.33 //y=2.265 //x2=12.44 //y2=2.265
r837 (  260 291 ) resistor r=45.1352 //w=0.168 //l=0.173853 //layer=ply \
 //thickness=0.18 //x=25.105 //y=1.43 //x2=25.065 //y2=1.585
r838 (  259 290 ) resistor r=45.1352 //w=0.168 //l=0.173853 //layer=ply \
 //thickness=0.18 //x=25.105 //y=1.085 //x2=25.065 //y2=0.93
r839 (  259 260 ) resistor r=176.904 //w=0.094 //l=0.345 //layer=ply \
 //thickness=0.18 //x=25.105 //y=1.085 //x2=25.105 //y2=1.43
r840 (  254 289 ) resistor r=10.701 //w=0.21 //l=0.115 //layer=ply \
 //thickness=0.18 //x=24.73 //y=1.585 //x2=24.615 //y2=1.585
r841 (  253 291 ) resistor r=5.52526 //w=0.168 //l=0.115 //layer=ply \
 //thickness=0.18 //x=24.95 //y=1.585 //x2=25.065 //y2=1.585
r842 (  252 288 ) resistor r=5.52526 //w=0.168 //l=0.115 //layer=ply \
 //thickness=0.18 //x=24.73 //y=0.93 //x2=24.615 //y2=0.93
r843 (  251 290 ) resistor r=5.52526 //w=0.168 //l=0.115 //layer=ply \
 //thickness=0.18 //x=24.95 //y=0.93 //x2=25.065 //y2=0.93
r844 (  251 252 ) resistor r=112.809 //w=0.094 //l=0.22 //layer=ply \
 //thickness=0.18 //x=24.95 //y=0.93 //x2=24.73 //y2=0.93
r845 (  250 286 ) resistor r=16.5046 //w=0.27 //l=0.135 //layer=ply \
 //thickness=0.18 //x=24.705 //y=4.97 //x2=24.57 //y2=4.97
r846 (  249 256 ) resistor r=26.9307 //w=0.15 //l=0.106066 //layer=ply \
 //thickness=0.18 //x=24.945 //y=4.97 //x2=25.02 //y2=5.045
r847 (  249 250 ) resistor r=123.064 //w=0.094 //l=0.24 //layer=ply \
 //thickness=0.18 //x=24.945 //y=4.97 //x2=24.705 //y2=4.97
r848 (  244 289 ) resistor r=39.5823 //w=0.21 //l=0.173853 //layer=ply \
 //thickness=0.18 //x=24.575 //y=1.74 //x2=24.615 //y2=1.585
r849 (  244 281 ) resistor r=182.032 //w=0.094 //l=0.355 //layer=ply \
 //thickness=0.18 //x=24.575 //y=1.74 //x2=24.575 //y2=2.095
r850 (  243 289 ) resistor r=39.5823 //w=0.21 //l=0.173853 //layer=ply \
 //thickness=0.18 //x=24.575 //y=1.43 //x2=24.615 //y2=1.585
r851 (  242 288 ) resistor r=45.1352 //w=0.168 //l=0.173853 //layer=ply \
 //thickness=0.18 //x=24.575 //y=1.085 //x2=24.615 //y2=0.93
r852 (  242 243 ) resistor r=176.904 //w=0.094 //l=0.345 //layer=ply \
 //thickness=0.18 //x=24.575 //y=1.085 //x2=24.575 //y2=1.43
r853 (  239 276 ) resistor r=70.3348 //w=0.233 //l=0.414367 //layer=ply \
 //thickness=0.18 //x=15.26 //y=5.045 //x2=14.92 //y2=4.88
r854 (  238 278 ) resistor r=45.1352 //w=0.168 //l=0.173853 //layer=ply \
 //thickness=0.18 //x=15.255 //y=1.395 //x2=15.215 //y2=1.55
r855 (  237 277 ) resistor r=45.1352 //w=0.168 //l=0.173853 //layer=ply \
 //thickness=0.18 //x=15.255 //y=1.05 //x2=15.215 //y2=0.895
r856 (  237 238 ) resistor r=176.904 //w=0.094 //l=0.345 //layer=ply \
 //thickness=0.18 //x=15.255 //y=1.05 //x2=15.255 //y2=1.395
r857 (  235 273 ) resistor r=10.701 //w=0.21 //l=0.115 //layer=ply \
 //thickness=0.18 //x=14.88 //y=1.55 //x2=14.765 //y2=1.55
r858 (  234 278 ) resistor r=5.52526 //w=0.168 //l=0.115 //layer=ply \
 //thickness=0.18 //x=15.1 //y=1.55 //x2=15.215 //y2=1.55
r859 (  233 272 ) resistor r=5.52526 //w=0.168 //l=0.115 //layer=ply \
 //thickness=0.18 //x=14.88 //y=0.895 //x2=14.765 //y2=0.895
r860 (  232 277 ) resistor r=5.52526 //w=0.168 //l=0.115 //layer=ply \
 //thickness=0.18 //x=15.1 //y=0.895 //x2=15.215 //y2=0.895
r861 (  232 233 ) resistor r=112.809 //w=0.094 //l=0.22 //layer=ply \
 //thickness=0.18 //x=15.1 //y=0.895 //x2=14.88 //y2=0.895
r862 (  229 274 ) resistor r=13.0941 //w=0.233 //l=0.165 //layer=ply \
 //thickness=0.18 //x=14.82 //y=5.045 //x2=14.82 //y2=4.88
r863 (  228 271 ) resistor r=34.8111 //w=0.27 //l=0.264953 //layer=ply \
 //thickness=0.18 //x=14.725 //y=2.1 //x2=14.92 //y2=2.265
r864 (  227 273 ) resistor r=39.5823 //w=0.21 //l=0.173853 //layer=ply \
 //thickness=0.18 //x=14.725 //y=1.705 //x2=14.765 //y2=1.55
r865 (  227 228 ) resistor r=202.543 //w=0.094 //l=0.395 //layer=ply \
 //thickness=0.18 //x=14.725 //y=1.705 //x2=14.725 //y2=2.1
r866 (  226 273 ) resistor r=39.5823 //w=0.21 //l=0.173853 //layer=ply \
 //thickness=0.18 //x=14.725 //y=1.395 //x2=14.765 //y2=1.55
r867 (  225 272 ) resistor r=45.1352 //w=0.168 //l=0.173853 //layer=ply \
 //thickness=0.18 //x=14.725 //y=1.05 //x2=14.765 //y2=0.895
r868 (  225 226 ) resistor r=176.904 //w=0.094 //l=0.345 //layer=ply \
 //thickness=0.18 //x=14.725 //y=1.05 //x2=14.725 //y2=1.395
r869 (  224 269 ) resistor r=45.1352 //w=0.168 //l=0.173853 //layer=ply \
 //thickness=0.18 //x=12.97 //y=1.435 //x2=12.93 //y2=1.59
r870 (  223 268 ) resistor r=45.1352 //w=0.168 //l=0.173853 //layer=ply \
 //thickness=0.18 //x=12.97 //y=1.09 //x2=12.93 //y2=0.935
r871 (  223 224 ) resistor r=176.904 //w=0.094 //l=0.345 //layer=ply \
 //thickness=0.18 //x=12.97 //y=1.09 //x2=12.97 //y2=1.435
r872 (  218 267 ) resistor r=10.701 //w=0.21 //l=0.115 //layer=ply \
 //thickness=0.18 //x=12.595 //y=1.59 //x2=12.48 //y2=1.59
r873 (  217 269 ) resistor r=5.52526 //w=0.168 //l=0.115 //layer=ply \
 //thickness=0.18 //x=12.815 //y=1.59 //x2=12.93 //y2=1.59
r874 (  216 266 ) resistor r=5.52526 //w=0.168 //l=0.115 //layer=ply \
 //thickness=0.18 //x=12.595 //y=0.935 //x2=12.48 //y2=0.935
r875 (  215 268 ) resistor r=5.52526 //w=0.168 //l=0.115 //layer=ply \
 //thickness=0.18 //x=12.815 //y=0.935 //x2=12.93 //y2=0.935
r876 (  215 216 ) resistor r=112.809 //w=0.094 //l=0.22 //layer=ply \
 //thickness=0.18 //x=12.815 //y=0.935 //x2=12.595 //y2=0.935
r877 (  213 220 ) resistor r=26.9307 //w=0.15 //l=0.106066 //layer=ply \
 //thickness=0.18 //x=12.85 //y=4.97 //x2=12.925 //y2=5.045
r878 (  213 214 ) resistor r=148.702 //w=0.094 //l=0.29 //layer=ply \
 //thickness=0.18 //x=12.85 //y=4.97 //x2=12.56 //y2=4.97
r879 (  210 214 ) resistor r=23.403 //w=0.284 //l=0.106066 //layer=ply \
 //thickness=0.18 //x=12.485 //y=5.045 //x2=12.56 //y2=4.97
r880 (  210 265 ) resistor r=26.3063 //w=0.284 //l=0.229783 //layer=ply \
 //thickness=0.18 //x=12.485 //y=5.045 //x2=12.33 //y2=4.88
r881 (  209 263 ) resistor r=19.1248 //w=0.302 //l=0.165 //layer=ply \
 //thickness=0.18 //x=12.44 //y=2.1 //x2=12.44 //y2=2.265
r882 (  208 267 ) resistor r=39.5823 //w=0.21 //l=0.173853 //layer=ply \
 //thickness=0.18 //x=12.44 //y=1.745 //x2=12.48 //y2=1.59
r883 (  208 209 ) resistor r=182.032 //w=0.094 //l=0.355 //layer=ply \
 //thickness=0.18 //x=12.44 //y=1.745 //x2=12.44 //y2=2.1
r884 (  207 267 ) resistor r=39.5823 //w=0.21 //l=0.173853 //layer=ply \
 //thickness=0.18 //x=12.44 //y=1.435 //x2=12.48 //y2=1.59
r885 (  206 266 ) resistor r=45.1352 //w=0.168 //l=0.173853 //layer=ply \
 //thickness=0.18 //x=12.44 //y=1.09 //x2=12.48 //y2=0.935
r886 (  206 207 ) resistor r=176.904 //w=0.094 //l=0.345 //layer=ply \
 //thickness=0.18 //x=12.44 //y=1.09 //x2=12.44 //y2=1.435
r887 (  205 256 ) resistor r=592.245 //w=0.094 //l=1.155 //layer=ply \
 //thickness=0.18 //x=25.02 //y=6.2 //x2=25.02 //y2=5.045
r888 (  204 287 ) resistor r=592.245 //w=0.094 //l=1.155 //layer=ply \
 //thickness=0.18 //x=24.58 //y=6.2 //x2=24.58 //y2=5.045
r889 (  203 239 ) resistor r=592.245 //w=0.094 //l=1.155 //layer=ply \
 //thickness=0.18 //x=15.26 //y=6.2 //x2=15.26 //y2=5.045
r890 (  202 229 ) resistor r=592.245 //w=0.094 //l=1.155 //layer=ply \
 //thickness=0.18 //x=14.82 //y=6.2 //x2=14.82 //y2=5.045
r891 (  201 220 ) resistor r=592.245 //w=0.094 //l=1.155 //layer=ply \
 //thickness=0.18 //x=12.925 //y=6.2 //x2=12.925 //y2=5.045
r892 (  200 210 ) resistor r=592.245 //w=0.094 //l=1.155 //layer=ply \
 //thickness=0.18 //x=12.485 //y=6.2 //x2=12.485 //y2=5.045
r893 (  199 253 ) resistor r=56.4043 //w=0.094 //l=0.11 //layer=ply \
 //thickness=0.18 //x=24.84 //y=1.585 //x2=24.95 //y2=1.585
r894 (  199 254 ) resistor r=56.4043 //w=0.094 //l=0.11 //layer=ply \
 //thickness=0.18 //x=24.84 //y=1.585 //x2=24.73 //y2=1.585
r895 (  198 234 ) resistor r=56.4043 //w=0.094 //l=0.11 //layer=ply \
 //thickness=0.18 //x=14.99 //y=1.55 //x2=15.1 //y2=1.55
r896 (  198 235 ) resistor r=56.4043 //w=0.094 //l=0.11 //layer=ply \
 //thickness=0.18 //x=14.99 //y=1.55 //x2=14.88 //y2=1.55
r897 (  197 217 ) resistor r=56.4043 //w=0.094 //l=0.11 //layer=ply \
 //thickness=0.18 //x=12.705 //y=1.59 //x2=12.815 //y2=1.59
r898 (  197 218 ) resistor r=56.4043 //w=0.094 //l=0.11 //layer=ply \
 //thickness=0.18 //x=12.705 //y=1.59 //x2=12.595 //y2=1.59
r899 (  193 284 ) resistor r=152 //w=0.17 //l=0.17 //layer=licon //count=1 \
 //x=24.57 //y=4.88 //x2=24.57 //y2=4.88
r900 (  188 280 ) resistor r=152 //w=0.17 //l=0.17 //layer=licon //count=1 \
 //x=24.54 //y=2.26 //x2=24.54 //y2=2.26
r901 (  183 276 ) resistor r=152 //w=0.17 //l=0.17 //layer=licon //count=1 \
 //x=14.92 //y=4.88 //x2=14.92 //y2=4.88
r902 (  174 271 ) resistor r=152 //w=0.17 //l=0.17 //layer=licon //count=1 \
 //x=14.92 //y=2.265 //x2=14.92 //y2=2.265
r903 (  169 265 ) resistor r=152 //w=0.17 //l=0.17 //layer=licon //count=1 \
 //x=12.33 //y=4.88 //x2=12.33 //y2=4.88
r904 (  156 262 ) resistor r=152 //w=0.17 //l=0.17 //layer=licon //count=1 \
 //x=12.33 //y=2.265 //x2=12.33 //y2=2.265
r905 (  139 297 ) resistor r=23.2727 //w=0.187 //l=0.34 //layer=li \
 //thickness=0.1 //x=8.15 //y=5.555 //x2=8.15 //y2=5.895
r906 (  122 296 ) resistor r=23.2727 //w=0.187 //l=0.34 //layer=li \
 //thickness=0.1 //x=4.82 //y=5.555 //x2=4.82 //y2=5.895
r907 (  116 117 ) resistor r=0.10734 //w=0.281 //l=0.16 //layer=m2 \
 //thickness=0.36 //x=14.915 //y=4.255 //x2=14.755 //y2=4.255
r908 (  112 113 ) resistor r=0.10734 //w=0.281 //l=0.16 //layer=m2 \
 //thickness=0.36 //x=12.335 //y=3.76 //x2=12.175 //y2=3.76
r909 (  108 110 ) resistor r=0.10734 //w=0.281 //l=0.16 //layer=m2 \
 //thickness=0.36 //x=12.335 //y=2.415 //x2=12.495 //y2=2.415
r910 (  103 113 ) resistor r=0.257634 //w=0.131 //l=0.27 //layer=m2 \
 //thickness=0.36 //x=11.905 //y=3.805 //x2=12.175 //y2=3.805
r911 (  102 103 ) resistor r=0.0847561 //w=0.206 //l=0.14 //layer=m2 \
 //thickness=0.36 //x=11.765 //y=3.842 //x2=11.905 //y2=3.842
r912 (  101 102 ) resistor r=2.82443 //w=0.131 //l=2.96 //layer=m2 \
 //thickness=0.36 //x=8.805 //y=3.88 //x2=11.765 //y2=3.88
r913 (  99 101 ) resistor r=0.10734 //w=0.281 //l=0.16 //layer=m2 \
 //thickness=0.36 //x=8.645 //y=3.895 //x2=8.805 //y2=3.895
r914 (  99 100 ) resistor r=0.10734 //w=0.281 //l=0.16 //layer=m2 \
 //thickness=0.36 //x=8.645 //y=3.895 //x2=8.485 //y2=3.895
r915 (  97 100 ) resistor r=2.72901 //w=0.131 //l=2.86 //layer=m2 \
 //thickness=0.36 //x=5.625 //y=3.91 //x2=8.485 //y2=3.91
r916 (  95 97 ) resistor r=0.10734 //w=0.281 //l=0.16 //layer=m2 \
 //thickness=0.36 //x=5.465 //y=3.895 //x2=5.625 //y2=3.895
r917 (  92 120 ) resistor r=3.45539 //w=0.18 //l=4.99745 //layer=m2 \
 //thickness=0.36 //x=19.56 //y=2.37 //x2=24.535 //y2=2.415
r918 (  92 93 ) resistor r=0.410305 //w=0.131 //l=0.43 //layer=m2 \
 //thickness=0.36 //x=19.56 //y=2.37 //x2=19.13 //y2=2.37
r919 (  90 93 ) resistor r=0.125 //w=0.17 //l=0.184391 //layer=m2 \
 //thickness=0.36 //x=18.96 //y=2.4 //x2=19.13 //y2=2.37
r920 (  90 91 ) resistor r=5.17176 //w=0.131 //l=5.42 //layer=m2 \
 //thickness=0.36 //x=18.96 //y=2.4 //x2=13.54 //y2=2.4
r921 (  88 91 ) resistor r=0.1875 //w=0.17 //l=0.262393 //layer=m2 \
 //thickness=0.36 //x=13.285 //y=2.385 //x2=13.54 //y2=2.4
r922 (  88 89 ) resistor r=0.410305 //w=0.131 //l=0.43 //layer=m2 \
 //thickness=0.36 //x=13.285 //y=2.385 //x2=12.855 //y2=2.385
r923 (  86 89 ) resistor r=0.125 //w=0.17 //l=0.177341 //layer=m2 \
 //thickness=0.36 //x=12.685 //y=2.4 //x2=12.855 //y2=2.385
r924 (  86 110 ) resistor r=0.181298 //w=0.131 //l=0.19 //layer=m2 \
 //thickness=0.36 //x=12.685 //y=2.4 //x2=12.495 //y2=2.4
r925 (  85 105 ) resistor r=0.10734 //w=0.281 //l=0.16 //layer=m2 \
 //thickness=0.36 //x=12.49 //y=4.25 //x2=12.33 //y2=4.25
r926 (  85 117 ) resistor r=2.16126 //w=0.131 //l=2.265 //layer=m2 \
 //thickness=0.36 //x=12.49 //y=4.25 //x2=14.755 //y2=4.25
r927 (  77 193 ) resistor r=9.3 //w=0.17 //l=0.17 //layer=mcon //count=1 \
 //x=24.57 //y=4.88 //x2=24.57 //y2=4.88
r928 (  75 120 ) resistor r=4.5 //w=0.15 //l=0.15 //layer=via1 //count=1 \
 //x=24.535 //y=2.415 //x2=24.535 //y2=2.415
r929 (  73 188 ) resistor r=9.3 //w=0.17 //l=0.17 //layer=mcon //count=1 \
 //x=24.54 //y=2.26 //x2=24.54 //y2=2.26
r930 (  73 75 ) resistor r=0.065678 //w=0.295 //l=0.155 //layer=m1 \
 //thickness=0.36 //x=24.535 //y=2.26 //x2=24.535 //y2=2.415
r931 (  71 183 ) resistor r=9.3 //w=0.17 //l=0.17 //layer=mcon //count=1 \
 //x=14.92 //y=4.88 //x2=14.92 //y2=4.88
r932 (  69 174 ) resistor r=9.3 //w=0.17 //l=0.17 //layer=mcon //count=1 \
 //x=14.92 //y=2.265 //x2=14.92 //y2=2.265
r933 (  67 116 ) resistor r=4.5 //w=0.15 //l=0.15 //layer=via1 //count=1 \
 //x=14.915 //y=4.255 //x2=14.915 //y2=4.255
r934 (  65 67 ) resistor r=0.00167112 //w=0.374 //l=0.005 //layer=m1 \
 //thickness=0.36 //x=14.865 //y=4.25 //x2=14.865 //y2=4.255
r935 (  62 105 ) resistor r=4.5 //w=0.15 //l=0.15 //layer=via1 //count=1 \
 //x=12.33 //y=4.25 //x2=12.33 //y2=4.25
r936 (  60 108 ) resistor r=4.5 //w=0.15 //l=0.15 //layer=via1 //count=1 \
 //x=12.335 //y=2.415 //x2=12.335 //y2=2.415
r937 (  58 156 ) resistor r=9.3 //w=0.17 //l=0.17 //layer=mcon //count=1 \
 //x=12.33 //y=2.265 //x2=12.33 //y2=2.265
r938 (  58 60 ) resistor r=0.0625 //w=0.3 //l=0.15 //layer=m1 //thickness=0.36 \
 //x=12.335 //y=2.265 //x2=12.335 //y2=2.415
r939 (  56 169 ) resistor r=9.3 //w=0.17 //l=0.17 //layer=mcon //count=1 \
 //x=12.33 //y=4.88 //x2=12.33 //y2=4.88
r940 (  54 112 ) resistor r=4.5 //w=0.15 //l=0.15 //layer=via1 //count=1 \
 //x=12.335 //y=3.76 //x2=12.335 //y2=3.76
r941 (  52 54 ) resistor r=0.0148417 //w=0.379 //l=0.045 //layer=m1 \
 //thickness=0.36 //x=12.28 //y=3.715 //x2=12.28 //y2=3.76
r942 (  50 99 ) resistor r=4.5 //w=0.15 //l=0.15 //layer=via1 //count=1 \
 //x=8.645 //y=3.895 //x2=8.645 //y2=3.895
r943 (  48 50 ) resistor r=0.00501337 //w=0.374 //l=0.015 //layer=m1 \
 //thickness=0.36 //x=8.58 //y=3.88 //x2=8.58 //y2=3.895
r944 (  46 293 ) resistor r=9.3 //w=0.17 //l=0.17 //layer=mcon //count=1 \
 //x=8.19 //y=1.185 //x2=8.19 //y2=1.185
r945 (  44 139 ) resistor r=9.3 //w=0.17 //l=0.17 //layer=mcon //count=1 \
 //x=8.15 //y=5.555 //x2=8.15 //y2=5.555
r946 (  42 44 ) resistor r=0.100236 //w=0.212 //l=0.17 //layer=m1 \
 //thickness=0.36 //x=8.15 //y=5.385 //x2=8.15 //y2=5.555
r947 (  41 95 ) resistor r=4.5 //w=0.15 //l=0.15 //layer=via1 //count=1 \
 //x=5.465 //y=3.895 //x2=5.465 //y2=3.895
r948 (  39 41 ) resistor r=0.0049867 //w=0.376 //l=0.015 //layer=m1 \
 //thickness=0.36 //x=5.52 //y=3.88 //x2=5.52 //y2=3.895
r949 (  37 292 ) resistor r=9.3 //w=0.17 //l=0.17 //layer=mcon //count=1 \
 //x=4.86 //y=1.185 //x2=4.86 //y2=1.185
r950 (  35 122 ) resistor r=9.3 //w=0.17 //l=0.17 //layer=mcon //count=1 \
 //x=4.82 //y=5.555 //x2=4.82 //y2=5.555
r951 (  33 35 ) resistor r=0.100236 //w=0.212 //l=0.17 //layer=m1 \
 //thickness=0.36 //x=4.82 //y=5.385 //x2=4.82 //y2=5.555
r952 (  32 77 ) resistor r=0.0878548 //w=0.228 //l=0.159295 //layer=m1 \
 //thickness=0.36 //x=24.54 //y=4.735 //x2=24.57 //y2=4.88
r953 (  31 75 ) resistor r=0.0900514 //w=0.295 //l=0.162481 //layer=m1 \
 //thickness=0.36 //x=24.54 //y=2.575 //x2=24.535 //y2=2.415
r954 (  31 32 ) resistor r=2.06107 //w=0.131 //l=2.16 //layer=m1 \
 //thickness=0.36 //x=24.54 //y=2.575 //x2=24.54 //y2=4.735
r955 (  30 71 ) resistor r=0.0717383 //w=0.224 //l=0.115 //layer=m1 \
 //thickness=0.36 //x=14.92 //y=4.765 //x2=14.92 //y2=4.88
r956 (  29 67 ) resistor r=0.0910802 //w=0.374 //l=0.185472 //layer=m1 \
 //thickness=0.36 //x=14.92 //y=4.415 //x2=14.865 //y2=4.255
r957 (  29 30 ) resistor r=0.333969 //w=0.131 //l=0.35 //layer=m1 \
 //thickness=0.36 //x=14.92 //y=4.415 //x2=14.92 //y2=4.765
r958 (  28 65 ) resistor r=0.089409 //w=0.374 //l=0.180416 //layer=m1 \
 //thickness=0.36 //x=14.92 //y=4.095 //x2=14.865 //y2=4.25
r959 (  27 69 ) resistor r=0.0916619 //w=0.239 //l=0.156493 //layer=m1 \
 //thickness=0.36 //x=14.92 //y=2.42 //x2=14.917 //y2=2.265
r960 (  27 28 ) resistor r=1.59828 //w=0.131 //l=1.675 //layer=m1 \
 //thickness=0.36 //x=14.92 //y=2.42 //x2=14.92 //y2=4.095
r961 (  26 56 ) resistor r=0.0731974 //w=0.242 //l=0.122474 //layer=m1 \
 //thickness=0.36 //x=12.33 //y=4.76 //x2=12.335 //y2=4.88
r962 (  25 62 ) resistor r=0.0911593 //w=0.376 //l=0.184174 //layer=m1 \
 //thickness=0.36 //x=12.33 //y=4.41 //x2=12.382 //y2=4.25
r963 (  25 26 ) resistor r=0.333969 //w=0.131 //l=0.35 //layer=m1 \
 //thickness=0.36 //x=12.33 //y=4.41 //x2=12.33 //y2=4.76
r964 (  24 62 ) resistor r=0.0911593 //w=0.376 //l=0.184174 //layer=m1 \
 //thickness=0.36 //x=12.33 //y=4.09 //x2=12.382 //y2=4.25
r965 (  23 54 ) resistor r=0.0912814 //w=0.379 //l=0.183303 //layer=m1 \
 //thickness=0.36 //x=12.33 //y=3.92 //x2=12.28 //y2=3.76
r966 (  23 24 ) resistor r=0.162214 //w=0.131 //l=0.17 //layer=m1 \
 //thickness=0.36 //x=12.33 //y=3.92 //x2=12.33 //y2=4.09
r967 (  22 52 ) resistor r=0.0764397 //w=0.379 //l=0.13775 //layer=m1 \
 //thickness=0.36 //x=12.33 //y=3.6 //x2=12.28 //y2=3.715
r968 (  21 60 ) resistor r=0.0899455 //w=0.3 //l=0.162481 //layer=m1 \
 //thickness=0.36 //x=12.33 //y=2.575 //x2=12.335 //y2=2.415
r969 (  21 22 ) resistor r=0.978053 //w=0.131 //l=1.025 //layer=m1 \
 //thickness=0.36 //x=12.33 //y=2.575 //x2=12.33 //y2=3.6
r970 (  19 50 ) resistor r=0.0910802 //w=0.374 //l=0.183303 //layer=m1 \
 //thickness=0.36 //x=8.63 //y=4.055 //x2=8.58 //y2=3.895
r971 (  19 20 ) resistor r=1.18798 //w=0.131 //l=1.245 //layer=m1 \
 //thickness=0.36 //x=8.63 //y=4.055 //x2=8.63 //y2=5.3
r972 (  18 48 ) resistor r=0.0860668 //w=0.374 //l=0.168152 //layer=m1 \
 //thickness=0.36 //x=8.63 //y=3.735 //x2=8.58 //y2=3.88
r973 (  17 18 ) resistor r=1.73187 //w=0.131 //l=1.815 //layer=m1 \
 //thickness=0.36 //x=8.63 //y=1.92 //x2=8.63 //y2=3.735
r974 (  15 17 ) resistor r=0.0698411 //w=0.17 //l=0.120208 //layer=m1 \
 //thickness=0.36 //x=8.545 //y=1.835 //x2=8.63 //y2=1.92
r975 (  15 16 ) resistor r=0.257634 //w=0.131 //l=0.27 //layer=m1 \
 //thickness=0.36 //x=8.545 //y=1.835 //x2=8.275 //y2=1.835
r976 (  14 42 ) resistor r=0.0208269 //w=0.212 //l=0.115 //layer=m1 \
 //thickness=0.36 //x=8.265 //y=5.385 //x2=8.15 //y2=5.385
r977 (  13 20 ) resistor r=0.0698411 //w=0.17 //l=0.120208 //layer=m1 \
 //thickness=0.36 //x=8.545 //y=5.385 //x2=8.63 //y2=5.3
r978 (  13 14 ) resistor r=0.267176 //w=0.131 //l=0.28 //layer=m1 \
 //thickness=0.36 //x=8.545 //y=5.385 //x2=8.265 //y2=5.385
r979 (  12 16 ) resistor r=0.0698411 //w=0.17 //l=0.120208 //layer=m1 \
 //thickness=0.36 //x=8.19 //y=1.75 //x2=8.275 //y2=1.835
r980 (  11 46 ) resistor r=0.0717383 //w=0.224 //l=0.115 //layer=m1 \
 //thickness=0.36 //x=8.19 //y=1.3 //x2=8.19 //y2=1.185
r981 (  11 12 ) resistor r=0.429389 //w=0.131 //l=0.45 //layer=m1 \
 //thickness=0.36 //x=8.19 //y=1.3 //x2=8.19 //y2=1.75
r982 (  9 41 ) resistor r=0.0911593 //w=0.376 //l=0.203961 //layer=m1 \
 //thickness=0.36 //x=5.42 //y=4.055 //x2=5.52 //y2=3.895
r983 (  9 10 ) resistor r=1.18798 //w=0.131 //l=1.245 //layer=m1 \
 //thickness=0.36 //x=5.42 //y=4.055 //x2=5.42 //y2=5.3
r984 (  8 39 ) resistor r=0.0861726 //w=0.376 //l=0.188481 //layer=m1 \
 //thickness=0.36 //x=5.42 //y=3.735 //x2=5.52 //y2=3.88
r985 (  7 8 ) resistor r=1.73187 //w=0.131 //l=1.815 //layer=m1 \
 //thickness=0.36 //x=5.42 //y=1.92 //x2=5.42 //y2=3.735
r986 (  5 7 ) resistor r=0.0698411 //w=0.17 //l=0.120208 //layer=m1 \
 //thickness=0.36 //x=5.335 //y=1.835 //x2=5.42 //y2=1.92
r987 (  5 6 ) resistor r=0.372137 //w=0.131 //l=0.39 //layer=m1 \
 //thickness=0.36 //x=5.335 //y=1.835 //x2=4.945 //y2=1.835
r988 (  4 33 ) resistor r=0.0208269 //w=0.212 //l=0.115 //layer=m1 \
 //thickness=0.36 //x=4.935 //y=5.385 //x2=4.82 //y2=5.385
r989 (  3 10 ) resistor r=0.0698411 //w=0.17 //l=0.120208 //layer=m1 \
 //thickness=0.36 //x=5.335 //y=5.385 //x2=5.42 //y2=5.3
r990 (  3 4 ) resistor r=0.381679 //w=0.131 //l=0.4 //layer=m1 \
 //thickness=0.36 //x=5.335 //y=5.385 //x2=4.935 //y2=5.385
r991 (  2 6 ) resistor r=0.0698411 //w=0.17 //l=0.120208 //layer=m1 \
 //thickness=0.36 //x=4.86 //y=1.75 //x2=4.945 //y2=1.835
r992 (  1 37 ) resistor r=0.0740619 //w=0.229 //l=0.120996 //layer=m1 \
 //thickness=0.36 //x=4.86 //y=1.305 //x2=4.862 //y2=1.185
r993 (  1 2 ) resistor r=0.424618 //w=0.131 //l=0.445 //layer=m1 \
 //thickness=0.36 //x=4.86 //y=1.305 //x2=4.86 //y2=1.75
ends PM_FA\%noxref_5

subckt PM_FA\%noxref_6 ( 2 4 5 6 7 8 10 11 12 13 14 15 16 18 23 28 31 35 40 41 \
 49 61 70 74 75 76 77 78 79 80 84 86 92 93 101 103 105 )
c302 ( 103 0 ) capacitor c=0.00846452f //x=12.515 //y=1.09
c303 ( 101 0 ) capacitor c=0.069457f //x=19.36 //y=4.88
c304 ( 93 0 ) capacitor c=0.0423887f //x=19.555 //y=1.435
c305 ( 92 0 ) capacitor c=0.0191585f //x=19.555 //y=1.09
c306 ( 86 0 ) capacitor c=0.0125357f //x=19.4 //y=1.59
c307 ( 84 0 ) capacitor c=0.0157807f //x=19.4 //y=0.935
c308 ( 80 0 ) capacitor c=0.0959389f //x=19.025 //y=2.1
c309 ( 79 0 ) capacitor c=0.0197088f //x=19.025 //y=1.745
c310 ( 78 0 ) capacitor c=0.0168511f //x=19.025 //y=1.435
c311 ( 77 0 ) capacitor c=0.0174128f //x=19.025 //y=1.09
c312 ( 76 0 ) capacitor c=0.155893f //x=19.47 //y=6.2
c313 ( 75 0 ) capacitor c=0.110553f //x=19.03 //y=6.2
c314 ( 70 0 ) capacitor c=9.59877e-19 //x=19.36 //y=4.88
c315 ( 61 0 ) capacitor c=7.21687e-19 //x=19.36 //y=2.265
c316 ( 49 0 ) capacitor c=0.0261338f //x=12.705 //y=5.56
c317 ( 41 0 ) capacitor c=0.080698f //x=19.185 //y=2.755
c318 ( 40 0 ) capacitor c=0.0015998f //x=19.345 //y=2.755
c319 ( 35 0 ) capacitor c=9.89014e-19 //x=13.23 //y=2.77
c320 ( 31 0 ) capacitor c=0.00562139f //x=19.24 //y=4.877
c321 ( 28 0 ) capacitor c=0.0149988f //x=19.36 //y=2.77
c322 ( 23 0 ) capacitor c=0.0140935f //x=13.07 //y=2.77
c323 ( 18 0 ) capacitor c=0.0149562f //x=12.7 //y=1.185
c324 ( 16 0 ) capacitor c=0.00261136f //x=19.36 //y=2.595
c325 ( 15 0 ) capacitor c=0.00264746f //x=19.36 //y=2.41
c326 ( 14 0 ) capacitor c=0.0399807f //x=19.24 //y=4.73
c327 ( 13 0 ) capacitor c=0.00888124f //x=19.24 //y=2.915
c328 ( 12 0 ) capacitor c=0.054862f //x=13.07 //y=5.055
c329 ( 11 0 ) capacitor c=0.0128726f //x=13.07 //y=2.93
c330 ( 10 0 ) capacitor c=0.009542f //x=13.07 //y=2.61
c331 ( 8 0 ) capacitor c=0.00504489f //x=12.79 //y=5.14
c332 ( 7 0 ) capacitor c=0.00632064f //x=12.985 //y=5.14
c333 ( 6 0 ) capacitor c=0.00566598f //x=12.785 //y=2.02
c334 ( 5 0 ) capacitor c=0.0110646f //x=12.985 //y=2.02
c335 ( 4 0 ) capacitor c=0.0104482f //x=12.705 //y=5.42
c336 ( 2 0 ) capacitor c=0.0124848f //x=12.7 //y=1.935
r337 (  101 102 ) resistor r=22.7554 //w=0.233 //l=0.11 //layer=ply \
 //thickness=0.18 //x=19.36 //y=4.88 //x2=19.47 //y2=4.88
r338 (  93 99 ) resistor r=45.1352 //w=0.168 //l=0.173853 //layer=ply \
 //thickness=0.18 //x=19.555 //y=1.435 //x2=19.515 //y2=1.59
r339 (  92 98 ) resistor r=45.1352 //w=0.168 //l=0.173853 //layer=ply \
 //thickness=0.18 //x=19.555 //y=1.09 //x2=19.515 //y2=0.935
r340 (  92 93 ) resistor r=176.904 //w=0.094 //l=0.345 //layer=ply \
 //thickness=0.18 //x=19.555 //y=1.09 //x2=19.555 //y2=1.435
r341 (  89 102 ) resistor r=13.0941 //w=0.233 //l=0.165 //layer=ply \
 //thickness=0.18 //x=19.47 //y=5.045 //x2=19.47 //y2=4.88
r342 (  87 95 ) resistor r=10.701 //w=0.21 //l=0.115 //layer=ply \
 //thickness=0.18 //x=19.18 //y=1.59 //x2=19.065 //y2=1.59
r343 (  86 99 ) resistor r=5.52526 //w=0.168 //l=0.115 //layer=ply \
 //thickness=0.18 //x=19.4 //y=1.59 //x2=19.515 //y2=1.59
r344 (  85 94 ) resistor r=5.52526 //w=0.168 //l=0.115 //layer=ply \
 //thickness=0.18 //x=19.18 //y=0.935 //x2=19.065 //y2=0.935
r345 (  84 98 ) resistor r=5.52526 //w=0.168 //l=0.115 //layer=ply \
 //thickness=0.18 //x=19.4 //y=0.935 //x2=19.515 //y2=0.935
r346 (  84 85 ) resistor r=112.809 //w=0.094 //l=0.22 //layer=ply \
 //thickness=0.18 //x=19.4 //y=0.935 //x2=19.18 //y2=0.935
r347 (  81 101 ) resistor r=68.2661 //w=0.233 //l=0.404166 //layer=ply \
 //thickness=0.18 //x=19.03 //y=5.045 //x2=19.36 //y2=4.88
r348 (  80 97 ) resistor r=67.2792 //w=0.24 //l=0.438891 //layer=ply \
 //thickness=0.18 //x=19.025 //y=2.1 //x2=19.36 //y2=2.34
r349 (  79 95 ) resistor r=39.5823 //w=0.21 //l=0.173853 //layer=ply \
 //thickness=0.18 //x=19.025 //y=1.745 //x2=19.065 //y2=1.59
r350 (  79 80 ) resistor r=182.032 //w=0.094 //l=0.355 //layer=ply \
 //thickness=0.18 //x=19.025 //y=1.745 //x2=19.025 //y2=2.1
r351 (  78 95 ) resistor r=39.5823 //w=0.21 //l=0.173853 //layer=ply \
 //thickness=0.18 //x=19.025 //y=1.435 //x2=19.065 //y2=1.59
r352 (  77 94 ) resistor r=45.1352 //w=0.168 //l=0.173853 //layer=ply \
 //thickness=0.18 //x=19.025 //y=1.09 //x2=19.065 //y2=0.935
r353 (  77 78 ) resistor r=176.904 //w=0.094 //l=0.345 //layer=ply \
 //thickness=0.18 //x=19.025 //y=1.09 //x2=19.025 //y2=1.435
r354 (  76 89 ) resistor r=592.245 //w=0.094 //l=1.155 //layer=ply \
 //thickness=0.18 //x=19.47 //y=6.2 //x2=19.47 //y2=5.045
r355 (  75 81 ) resistor r=592.245 //w=0.094 //l=1.155 //layer=ply \
 //thickness=0.18 //x=19.03 //y=6.2 //x2=19.03 //y2=5.045
r356 (  74 86 ) resistor r=56.4043 //w=0.094 //l=0.11 //layer=ply \
 //thickness=0.18 //x=19.29 //y=1.59 //x2=19.4 //y2=1.59
r357 (  74 87 ) resistor r=56.4043 //w=0.094 //l=0.11 //layer=ply \
 //thickness=0.18 //x=19.29 //y=1.59 //x2=19.18 //y2=1.59
r358 (  70 101 ) resistor r=152 //w=0.17 //l=0.17 //layer=licon //count=1 \
 //x=19.36 //y=4.88 //x2=19.36 //y2=4.88
r359 (  61 97 ) resistor r=152 //w=0.17 //l=0.17 //layer=licon //count=1 \
 //x=19.36 //y=2.265 //x2=19.36 //y2=2.265
r360 (  49 105 ) resistor r=23.615 //w=0.187 //l=0.345 //layer=li \
 //thickness=0.1 //x=12.705 //y=5.56 //x2=12.705 //y2=5.905
r361 (  40 41 ) resistor r=0.10734 //w=0.281 //l=0.16 //layer=m2 \
 //thickness=0.36 //x=19.345 //y=2.755 //x2=19.185 //y2=2.755
r362 (  35 37 ) resistor r=0.10734 //w=0.281 //l=0.16 //layer=m2 \
 //thickness=0.36 //x=13.23 //y=2.77 //x2=13.07 //y2=2.77
r363 (  35 41 ) resistor r=5.68225 //w=0.131 //l=5.955 //layer=m2 \
 //thickness=0.36 //x=13.23 //y=2.77 //x2=19.185 //y2=2.77
r364 (  33 70 ) resistor r=9.3 //w=0.17 //l=0.17 //layer=mcon //count=1 \
 //x=19.36 //y=4.88 //x2=19.36 //y2=4.88
r365 (  31 33 ) resistor r=0.0528169 //w=0.284 //l=0.12 //layer=m1 \
 //thickness=0.36 //x=19.24 //y=4.877 //x2=19.36 //y2=4.877
r366 (  30 61 ) resistor r=9.3 //w=0.17 //l=0.17 //layer=mcon //count=1 \
 //x=19.36 //y=2.265 //x2=19.36 //y2=2.265
r367 (  26 40 ) resistor r=4.5 //w=0.15 //l=0.15 //layer=via1 //count=1 \
 //x=19.345 //y=2.755 //x2=19.345 //y2=2.755
r368 (  26 28 ) resistor r=0.00501337 //w=0.374 //l=0.015 //layer=m1 \
 //thickness=0.36 //x=19.3 //y=2.755 //x2=19.3 //y2=2.77
r369 (  23 37 ) resistor r=4.5 //w=0.15 //l=0.15 //layer=via1 //count=1 \
 //x=13.07 //y=2.77 //x2=13.07 //y2=2.77
r370 (  21 49 ) resistor r=9.3 //w=0.17 //l=0.17 //layer=mcon //count=1 \
 //x=12.705 //y=5.56 //x2=12.705 //y2=5.56
r371 (  18 103 ) resistor r=9.3 //w=0.17 //l=0.17 //layer=mcon //count=1 \
 //x=12.7 //y=1.185 //x2=12.7 //y2=1.185
r372 (  16 26 ) resistor r=0.0910802 //w=0.374 //l=0.187617 //layer=m1 \
 //thickness=0.36 //x=19.36 //y=2.595 //x2=19.3 //y2=2.755
r373 (  15 30 ) resistor r=0.0853765 //w=0.25 //l=0.146492 //layer=m1 \
 //thickness=0.36 //x=19.36 //y=2.41 //x2=19.357 //y2=2.265
r374 (  15 16 ) resistor r=0.176527 //w=0.131 //l=0.185 //layer=m1 \
 //thickness=0.36 //x=19.36 //y=2.41 //x2=19.36 //y2=2.595
r375 (  14 31 ) resistor r=0.0383145 //w=0.284 //l=0.147 //layer=m1 \
 //thickness=0.36 //x=19.24 //y=4.73 //x2=19.24 //y2=4.877
r376 (  13 28 ) resistor r=0.0860668 //w=0.374 //l=0.172409 //layer=m1 \
 //thickness=0.36 //x=19.24 //y=2.915 //x2=19.3 //y2=2.77
r377 (  13 14 ) resistor r=1.73187 //w=0.131 //l=1.815 //layer=m1 \
 //thickness=0.36 //x=19.24 //y=2.915 //x2=19.24 //y2=4.73
r378 (  11 23 ) resistor r=0.0911593 //w=0.376 //l=0.184174 //layer=m1 \
 //thickness=0.36 //x=13.07 //y=2.93 //x2=13.122 //y2=2.77
r379 (  11 12 ) resistor r=2.02767 //w=0.131 //l=2.125 //layer=m1 \
 //thickness=0.36 //x=13.07 //y=2.93 //x2=13.07 //y2=5.055
r380 (  10 23 ) resistor r=0.0911593 //w=0.376 //l=0.184174 //layer=m1 \
 //thickness=0.36 //x=13.07 //y=2.61 //x2=13.122 //y2=2.77
r381 (  9 10 ) resistor r=0.48187 //w=0.131 //l=0.505 //layer=m1 \
 //thickness=0.36 //x=13.07 //y=2.105 //x2=13.07 //y2=2.61
r382 (  7 12 ) resistor r=0.0698411 //w=0.17 //l=0.120208 //layer=m1 \
 //thickness=0.36 //x=12.985 //y=5.14 //x2=13.07 //y2=5.055
r383 (  7 8 ) resistor r=0.186069 //w=0.131 //l=0.195 //layer=m1 \
 //thickness=0.36 //x=12.985 //y=5.14 //x2=12.79 //y2=5.14
r384 (  5 9 ) resistor r=0.0698411 //w=0.17 //l=0.120208 //layer=m1 \
 //thickness=0.36 //x=12.985 //y=2.02 //x2=13.07 //y2=2.105
r385 (  5 6 ) resistor r=0.19084 //w=0.131 //l=0.2 //layer=m1 //thickness=0.36 \
 //x=12.985 //y=2.02 //x2=12.785 //y2=2.02
r386 (  4 21 ) resistor r=0.086672 //w=0.218 //l=0.14 //layer=m1 \
 //thickness=0.36 //x=12.705 //y=5.42 //x2=12.705 //y2=5.56
r387 (  3 8 ) resistor r=0.0698411 //w=0.17 //l=0.120208 //layer=m1 \
 //thickness=0.36 //x=12.705 //y=5.225 //x2=12.79 //y2=5.14
r388 (  3 4 ) resistor r=0.186069 //w=0.131 //l=0.195 //layer=m1 \
 //thickness=0.36 //x=12.705 //y=5.225 //x2=12.705 //y2=5.42
r389 (  2 6 ) resistor r=0.0698411 //w=0.17 //l=0.120208 //layer=m1 \
 //thickness=0.36 //x=12.7 //y=1.935 //x2=12.785 //y2=2.02
r390 (  1 18 ) resistor r=0.105739 //w=0.201 //l=0.145 //layer=m1 \
 //thickness=0.36 //x=12.7 //y=1.33 //x2=12.7 //y2=1.185
r391 (  1 2 ) resistor r=0.57729 //w=0.131 //l=0.605 //layer=m1 \
 //thickness=0.36 //x=12.7 //y=1.33 //x2=12.7 //y2=1.935
ends PM_FA\%noxref_6

subckt PM_FA\%SUM ( 1 2 3 4 5 6 7 8 10 11 15 18 19 20 22 23 27 28 29 38 52 54 \
 55 58 75 91 92 95 96 )
c300 ( 92 0 ) capacitor c=0.00849198f //x=19.1 //y=1.09
c301 ( 91 0 ) capacitor c=0.00849198f //x=15.77 //y=1.09
c302 ( 75 0 ) capacitor c=0.0232369f //x=19.25 //y=5.555
c303 ( 58 0 ) capacitor c=0.0233505f //x=15.92 //y=5.555
c304 ( 55 0 ) capacitor c=0.0329765f //x=19.585 //y=3.895
c305 ( 54 0 ) capacitor c=0.0137849f //x=19.745 //y=3.895
c306 ( 52 0 ) capacitor c=0.00571035f //x=16.725 //y=3.895
c307 ( 38 0 ) capacitor c=0.0100884f //x=19.25 //y=5.385
c308 ( 29 0 ) capacitor c=0.0110948f //x=15.92 //y=5.385
c309 ( 28 0 ) capacitor c=0.0235291f //x=19.73 //y=5.3
c310 ( 27 0 ) capacitor c=0.0121721f //x=19.73 //y=4.055
c311 ( 23 0 ) capacitor c=0.00230224f //x=19.375 //y=1.835
c312 ( 22 0 ) capacitor c=0.0131308f //x=19.645 //y=1.835
c313 ( 20 0 ) capacitor c=0.00796246f //x=19.645 //y=5.385
c314 ( 19 0 ) capacitor c=0.00892846f //x=19.29 //y=1.75
c315 ( 18 0 ) capacitor c=0.00942754f //x=19.29 //y=1.3
c316 ( 15 0 ) capacitor c=0.0170141f //x=16.52 //y=4.055
c317 ( 11 0 ) capacitor c=0.00262307f //x=16.045 //y=1.835
c318 ( 10 0 ) capacitor c=0.0172538f //x=16.435 //y=1.835
c319 ( 8 0 ) capacitor c=0.011154f //x=16.435 //y=5.385
c320 ( 7 0 ) capacitor c=0.00993239f //x=15.96 //y=1.75
c321 ( 6 0 ) capacitor c=0.0100508f //x=15.96 //y=1.305
c322 ( 5 0 ) capacitor c=0.0170398f //x=19.73 //y=3.88
c323 ( 4 0 ) capacitor c=0.0184853f //x=16.57 //y=3.88
c324 ( 3 0 ) capacitor c=0.0361996f //x=19.73 //y=2.77
c325 ( 2 0 ) capacitor c=0.0268816f //x=16.52 //y=4.62
c326 ( 1 0 ) capacitor c=0.0461735f //x=16.52 //y=3.51
r327 (  75 96 ) resistor r=23.2727 //w=0.187 //l=0.34 //layer=li \
 //thickness=0.1 //x=19.25 //y=5.555 //x2=19.25 //y2=5.895
r328 (  58 95 ) resistor r=23.2727 //w=0.187 //l=0.34 //layer=li \
 //thickness=0.1 //x=15.92 //y=5.555 //x2=15.92 //y2=5.895
r329 (  54 55 ) resistor r=0.10734 //w=0.281 //l=0.16 //layer=m2 \
 //thickness=0.36 //x=19.745 //y=3.895 //x2=19.585 //y2=3.895
r330 (  52 55 ) resistor r=2.72901 //w=0.131 //l=2.86 //layer=m2 \
 //thickness=0.36 //x=16.725 //y=3.91 //x2=19.585 //y2=3.91
r331 (  50 52 ) resistor r=0.10734 //w=0.281 //l=0.16 //layer=m2 \
 //thickness=0.36 //x=16.565 //y=3.895 //x2=16.725 //y2=3.895
r332 (  46 54 ) resistor r=4.5 //w=0.15 //l=0.15 //layer=via1 //count=1 \
 //x=19.745 //y=3.895 //x2=19.745 //y2=3.895
r333 (  42 92 ) resistor r=9.3 //w=0.17 //l=0.17 //layer=mcon //count=1 \
 //x=19.29 //y=1.185 //x2=19.29 //y2=1.185
r334 (  40 75 ) resistor r=9.3 //w=0.17 //l=0.17 //layer=mcon //count=1 \
 //x=19.25 //y=5.555 //x2=19.25 //y2=5.555
r335 (  38 40 ) resistor r=0.100236 //w=0.212 //l=0.17 //layer=m1 \
 //thickness=0.36 //x=19.25 //y=5.385 //x2=19.25 //y2=5.555
r336 (  37 50 ) resistor r=4.5 //w=0.15 //l=0.15 //layer=via1 //count=1 \
 //x=16.565 //y=3.895 //x2=16.565 //y2=3.895
r337 (  33 91 ) resistor r=9.3 //w=0.17 //l=0.17 //layer=mcon //count=1 \
 //x=15.96 //y=1.185 //x2=15.96 //y2=1.185
r338 (  31 58 ) resistor r=9.3 //w=0.17 //l=0.17 //layer=mcon //count=1 \
 //x=15.92 //y=5.555 //x2=15.92 //y2=5.555
r339 (  29 31 ) resistor r=0.100236 //w=0.212 //l=0.17 //layer=m1 \
 //thickness=0.36 //x=15.92 //y=5.385 //x2=15.92 //y2=5.555
r340 (  27 46 ) resistor r=0.0910802 //w=0.374 //l=0.183303 //layer=m1 \
 //thickness=0.36 //x=19.73 //y=4.055 //x2=19.68 //y2=3.895
r341 (  27 28 ) resistor r=1.18798 //w=0.131 //l=1.245 //layer=m1 \
 //thickness=0.36 //x=19.73 //y=4.055 //x2=19.73 //y2=5.3
r342 (  22 24 ) resistor r=0.0698411 //w=0.17 //l=0.120208 //layer=m1 \
 //thickness=0.36 //x=19.645 //y=1.835 //x2=19.73 //y2=1.92
r343 (  22 23 ) resistor r=0.257634 //w=0.131 //l=0.27 //layer=m1 \
 //thickness=0.36 //x=19.645 //y=1.835 //x2=19.375 //y2=1.835
r344 (  21 38 ) resistor r=0.0208269 //w=0.212 //l=0.115 //layer=m1 \
 //thickness=0.36 //x=19.365 //y=5.385 //x2=19.25 //y2=5.385
r345 (  20 28 ) resistor r=0.0698411 //w=0.17 //l=0.120208 //layer=m1 \
 //thickness=0.36 //x=19.645 //y=5.385 //x2=19.73 //y2=5.3
r346 (  20 21 ) resistor r=0.267176 //w=0.131 //l=0.28 //layer=m1 \
 //thickness=0.36 //x=19.645 //y=5.385 //x2=19.365 //y2=5.385
r347 (  19 23 ) resistor r=0.0698411 //w=0.17 //l=0.120208 //layer=m1 \
 //thickness=0.36 //x=19.29 //y=1.75 //x2=19.375 //y2=1.835
r348 (  18 42 ) resistor r=0.0717383 //w=0.224 //l=0.115 //layer=m1 \
 //thickness=0.36 //x=19.29 //y=1.3 //x2=19.29 //y2=1.185
r349 (  18 19 ) resistor r=0.429389 //w=0.131 //l=0.45 //layer=m1 \
 //thickness=0.36 //x=19.29 //y=1.3 //x2=19.29 //y2=1.75
r350 (  15 37 ) resistor r=0.0911593 //w=0.376 //l=0.203961 //layer=m1 \
 //thickness=0.36 //x=16.52 //y=4.055 //x2=16.62 //y2=3.895
r351 (  10 12 ) resistor r=0.0698411 //w=0.17 //l=0.120208 //layer=m1 \
 //thickness=0.36 //x=16.435 //y=1.835 //x2=16.52 //y2=1.92
r352 (  10 11 ) resistor r=0.372137 //w=0.131 //l=0.39 //layer=m1 \
 //thickness=0.36 //x=16.435 //y=1.835 //x2=16.045 //y2=1.835
r353 (  9 29 ) resistor r=0.0208269 //w=0.212 //l=0.115 //layer=m1 \
 //thickness=0.36 //x=16.035 //y=5.385 //x2=15.92 //y2=5.385
r354 (  8 16 ) resistor r=0.0698411 //w=0.17 //l=0.120208 //layer=m1 \
 //thickness=0.36 //x=16.435 //y=5.385 //x2=16.52 //y2=5.3
r355 (  8 9 ) resistor r=0.381679 //w=0.131 //l=0.4 //layer=m1 \
 //thickness=0.36 //x=16.435 //y=5.385 //x2=16.035 //y2=5.385
r356 (  7 11 ) resistor r=0.0698411 //w=0.17 //l=0.120208 //layer=m1 \
 //thickness=0.36 //x=15.96 //y=1.75 //x2=16.045 //y2=1.835
r357 (  6 33 ) resistor r=0.0740619 //w=0.229 //l=0.120996 //layer=m1 \
 //thickness=0.36 //x=15.96 //y=1.305 //x2=15.962 //y2=1.185
r358 (  6 7 ) resistor r=0.424618 //w=0.131 //l=0.445 //layer=m1 \
 //thickness=0.36 //x=15.96 //y=1.305 //x2=15.96 //y2=1.75
r359 (  5 46 ) resistor r=0.00501337 //w=0.374 //l=0.015 //layer=m1 \
 //thickness=0.36 //x=19.68 //y=3.88 //x2=19.68 //y2=3.895
r360 (  5 25 ) resistor r=0.0860668 //w=0.374 //l=0.168152 //layer=m1 \
 //thickness=0.36 //x=19.68 //y=3.88 //x2=19.73 //y2=3.735
r361 (  4 37 ) resistor r=0.0049867 //w=0.376 //l=0.015 //layer=m1 \
 //thickness=0.36 //x=16.62 //y=3.88 //x2=16.62 //y2=3.895
r362 (  4 13 ) resistor r=0.0861726 //w=0.376 //l=0.188481 //layer=m1 \
 //thickness=0.36 //x=16.62 //y=3.88 //x2=16.52 //y2=3.735
r363 (  3 25 ) resistor r=0.920802 //w=0.131 //l=0.965 //layer=m1 \
 //thickness=0.36 //x=19.73 //y=2.77 //x2=19.73 //y2=3.735
r364 (  3 24 ) resistor r=0.811069 //w=0.131 //l=0.85 //layer=m1 \
 //thickness=0.36 //x=19.73 //y=2.77 //x2=19.73 //y2=1.92
r365 (  2 16 ) resistor r=0.648855 //w=0.131 //l=0.68 //layer=m1 \
 //thickness=0.36 //x=16.52 //y=4.62 //x2=16.52 //y2=5.3
r366 (  2 15 ) resistor r=0.539122 //w=0.131 //l=0.565 //layer=m1 \
 //thickness=0.36 //x=16.52 //y=4.62 //x2=16.52 //y2=4.055
r367 (  1 13 ) resistor r=0.214695 //w=0.131 //l=0.225 //layer=m1 \
 //thickness=0.36 //x=16.52 //y=3.51 //x2=16.52 //y2=3.735
r368 (  1 12 ) resistor r=1.51718 //w=0.131 //l=1.59 //layer=m1 \
 //thickness=0.36 //x=16.52 //y=3.51 //x2=16.52 //y2=1.92
ends PM_FA\%SUM

subckt PM_FA\%noxref_8 ( 1 2 3 4 6 7 8 9 10 11 12 13 14 16 18 24 28 34 36 40 \
 48 54 56 57 60 61 68 73 90 102 103 104 111 112 113 114 115 117 120 121 123 \
 131 133 )
c322 ( 131 0 ) capacitor c=0.00849916f //x=21.385 //y=1.09
c323 ( 123 0 ) capacitor c=0.0652604f //x=16.03 //y=4.88
c324 ( 121 0 ) capacitor c=0.0318956f //x=18.585 //y=1.395
c325 ( 120 0 ) capacitor c=0.0186836f //x=18.585 //y=1.05
c326 ( 117 0 ) capacitor c=0.0141821f //x=18.43 //y=1.55
c327 ( 115 0 ) capacitor c=0.0158569f //x=18.43 //y=0.895
c328 ( 114 0 ) capacitor c=0.0874759f //x=18.055 //y=2.1
c329 ( 113 0 ) capacitor c=0.0230012f //x=18.055 //y=1.705
c330 ( 112 0 ) capacitor c=0.0234359f //x=18.055 //y=1.395
c331 ( 111 0 ) capacitor c=0.0198787f //x=18.055 //y=1.05
c332 ( 104 0 ) capacitor c=0.155893f //x=16.14 //y=6.2
c333 ( 103 0 ) capacitor c=0.110553f //x=15.7 //y=6.2
c334 ( 90 0 ) capacitor c=0.026097f //x=21.575 //y=5.56
c335 ( 73 0 ) capacitor c=0.00141467f //x=18.25 //y=2.265
c336 ( 68 0 ) capacitor c=6.22522e-19 //x=16.03 //y=4.88
c337 ( 61 0 ) capacitor c=0.0255221f //x=21.085 //y=3.495
c338 ( 60 0 ) capacitor c=1.71282e-19 //x=21.245 //y=3.495
c339 ( 57 0 ) capacitor c=0.0506786f //x=21.055 //y=4.27
c340 ( 56 0 ) capacitor c=0.00326455f //x=21.215 //y=4.27
c341 ( 54 0 ) capacitor c=0.00256557f //x=18.41 //y=3.525
c342 ( 48 0 ) capacitor c=0.00298913f //x=16.075 //y=4.28
c343 ( 40 0 ) capacitor c=0.0151629f //x=21.58 //y=1.185
c344 ( 36 0 ) capacitor c=0.0136176f //x=21.21 //y=4.25
c345 ( 34 0 ) capacitor c=0.0164437f //x=21.21 //y=3.51
c346 ( 28 0 ) capacitor c=0.031103f //x=18.25 //y=3.51
c347 ( 24 0 ) capacitor c=0.0153143f //x=16.075 //y=4.415
c348 ( 18 0 ) capacitor c=0.0120692f //x=21.58 //y=1.935
c349 ( 16 0 ) capacitor c=0.0101393f //x=21.575 //y=5.42
c350 ( 14 0 ) capacitor c=0.00474259f //x=21.295 //y=5.14
c351 ( 13 0 ) capacitor c=0.00878825f //x=21.49 //y=5.14
c352 ( 12 0 ) capacitor c=0.00446437f //x=21.295 //y=2.02
c353 ( 11 0 ) capacitor c=0.0118756f //x=21.495 //y=2.02
c354 ( 10 0 ) capacitor c=0.00972581f //x=21.21 //y=5.055
c355 ( 9 0 ) capacitor c=0.0114708f //x=21.21 //y=4.43
c356 ( 8 0 ) capacitor c=0.0112194f //x=21.21 //y=4.135
c357 ( 7 0 ) capacitor c=0.0126935f //x=21.21 //y=3.655
c358 ( 6 0 ) capacitor c=0.0257827f //x=21.21 //y=3.335
c359 ( 4 0 ) capacitor c=0.0248715f //x=18.25 //y=3.385
c360 ( 3 0 ) capacitor c=0.00480725f //x=18.25 //y=2.385
c361 ( 2 0 ) capacitor c=0.00515427f //x=16.03 //y=4.765
c362 ( 1 0 ) capacitor c=0.0148605f //x=16.03 //y=4.575
r363 (  123 124 ) resistor r=22.7554 //w=0.233 //l=0.11 //layer=ply \
 //thickness=0.18 //x=16.03 //y=4.88 //x2=16.14 //y2=4.88
r364 (  121 130 ) resistor r=45.1352 //w=0.168 //l=0.173853 //layer=ply \
 //thickness=0.18 //x=18.585 //y=1.395 //x2=18.545 //y2=1.55
r365 (  120 129 ) resistor r=45.1352 //w=0.168 //l=0.173853 //layer=ply \
 //thickness=0.18 //x=18.585 //y=1.05 //x2=18.545 //y2=0.895
r366 (  120 121 ) resistor r=176.904 //w=0.094 //l=0.345 //layer=ply \
 //thickness=0.18 //x=18.585 //y=1.05 //x2=18.585 //y2=1.395
r367 (  118 128 ) resistor r=10.701 //w=0.21 //l=0.115 //layer=ply \
 //thickness=0.18 //x=18.21 //y=1.55 //x2=18.095 //y2=1.55
r368 (  117 130 ) resistor r=5.52526 //w=0.168 //l=0.115 //layer=ply \
 //thickness=0.18 //x=18.43 //y=1.55 //x2=18.545 //y2=1.55
r369 (  116 127 ) resistor r=5.52526 //w=0.168 //l=0.115 //layer=ply \
 //thickness=0.18 //x=18.21 //y=0.895 //x2=18.095 //y2=0.895
r370 (  115 129 ) resistor r=5.52526 //w=0.168 //l=0.115 //layer=ply \
 //thickness=0.18 //x=18.43 //y=0.895 //x2=18.545 //y2=0.895
r371 (  115 116 ) resistor r=112.809 //w=0.094 //l=0.22 //layer=ply \
 //thickness=0.18 //x=18.43 //y=0.895 //x2=18.21 //y2=0.895
r372 (  114 126 ) resistor r=34.8111 //w=0.27 //l=0.264953 //layer=ply \
 //thickness=0.18 //x=18.055 //y=2.1 //x2=18.25 //y2=2.265
r373 (  113 128 ) resistor r=39.5823 //w=0.21 //l=0.173853 //layer=ply \
 //thickness=0.18 //x=18.055 //y=1.705 //x2=18.095 //y2=1.55
r374 (  113 114 ) resistor r=202.543 //w=0.094 //l=0.395 //layer=ply \
 //thickness=0.18 //x=18.055 //y=1.705 //x2=18.055 //y2=2.1
r375 (  112 128 ) resistor r=39.5823 //w=0.21 //l=0.173853 //layer=ply \
 //thickness=0.18 //x=18.055 //y=1.395 //x2=18.095 //y2=1.55
r376 (  111 127 ) resistor r=45.1352 //w=0.168 //l=0.173853 //layer=ply \
 //thickness=0.18 //x=18.055 //y=1.05 //x2=18.095 //y2=0.895
r377 (  111 112 ) resistor r=176.904 //w=0.094 //l=0.345 //layer=ply \
 //thickness=0.18 //x=18.055 //y=1.05 //x2=18.055 //y2=1.395
r378 (  108 124 ) resistor r=13.0941 //w=0.233 //l=0.165 //layer=ply \
 //thickness=0.18 //x=16.14 //y=5.045 //x2=16.14 //y2=4.88
r379 (  105 123 ) resistor r=68.2661 //w=0.233 //l=0.404166 //layer=ply \
 //thickness=0.18 //x=15.7 //y=5.045 //x2=16.03 //y2=4.88
r380 (  104 108 ) resistor r=592.245 //w=0.094 //l=1.155 //layer=ply \
 //thickness=0.18 //x=16.14 //y=6.2 //x2=16.14 //y2=5.045
r381 (  103 105 ) resistor r=592.245 //w=0.094 //l=1.155 //layer=ply \
 //thickness=0.18 //x=15.7 //y=6.2 //x2=15.7 //y2=5.045
r382 (  102 117 ) resistor r=56.4043 //w=0.094 //l=0.11 //layer=ply \
 //thickness=0.18 //x=18.32 //y=1.55 //x2=18.43 //y2=1.55
r383 (  102 118 ) resistor r=56.4043 //w=0.094 //l=0.11 //layer=ply \
 //thickness=0.18 //x=18.32 //y=1.55 //x2=18.21 //y2=1.55
r384 (  90 133 ) resistor r=23.615 //w=0.187 //l=0.345 //layer=li \
 //thickness=0.1 //x=21.575 //y=5.56 //x2=21.575 //y2=5.905
r385 (  73 126 ) resistor r=152 //w=0.17 //l=0.17 //layer=licon //count=1 \
 //x=18.25 //y=2.265 //x2=18.25 //y2=2.265
r386 (  68 123 ) resistor r=152 //w=0.17 //l=0.17 //layer=licon //count=1 \
 //x=16.03 //y=4.88 //x2=16.03 //y2=4.88
r387 (  60 61 ) resistor r=0.10734 //w=0.281 //l=0.16 //layer=m2 \
 //thickness=0.36 //x=21.245 //y=3.495 //x2=21.085 //y2=3.495
r388 (  56 57 ) resistor r=0.10734 //w=0.281 //l=0.16 //layer=m2 \
 //thickness=0.36 //x=21.215 //y=4.27 //x2=21.055 //y2=4.27
r389 (  54 61 ) resistor r=2.55248 //w=0.131 //l=2.675 //layer=m2 \
 //thickness=0.36 //x=18.41 //y=3.51 //x2=21.085 //y2=3.51
r390 (  52 54 ) resistor r=0.10734 //w=0.281 //l=0.16 //layer=m2 \
 //thickness=0.36 //x=18.25 //y=3.525 //x2=18.41 //y2=3.525
r391 (  48 50 ) resistor r=0.0539137 //w=0.313 //l=0.135 //layer=m2 \
 //thickness=0.36 //x=16.075 //y=4.28 //x2=16.075 //y2=4.415
r392 (  45 48 ) resistor r=0.0441684 //w=0.313 //l=0.16 //layer=m2 \
 //thickness=0.36 //x=16.235 //y=4.28 //x2=16.075 //y2=4.28
r393 (  45 57 ) resistor r=4.59924 //w=0.131 //l=4.82 //layer=m2 \
 //thickness=0.36 //x=16.235 //y=4.28 //x2=21.055 //y2=4.28
r394 (  43 90 ) resistor r=9.3 //w=0.17 //l=0.17 //layer=mcon //count=1 \
 //x=21.575 //y=5.56 //x2=21.575 //y2=5.56
r395 (  40 131 ) resistor r=9.3 //w=0.17 //l=0.17 //layer=mcon //count=1 \
 //x=21.58 //y=1.185 //x2=21.58 //y2=1.185
r396 (  38 56 ) resistor r=4.5 //w=0.15 //l=0.15 //layer=via1 //count=1 \
 //x=21.215 //y=4.27 //x2=21.215 //y2=4.27
r397 (  36 38 ) resistor r=0.0065445 //w=0.382 //l=0.02 //layer=m1 \
 //thickness=0.36 //x=21.16 //y=4.25 //x2=21.16 //y2=4.27
r398 (  32 60 ) resistor r=4.5 //w=0.15 //l=0.15 //layer=via1 //count=1 \
 //x=21.245 //y=3.495 //x2=21.245 //y2=3.495
r399 (  32 34 ) resistor r=0.00474684 //w=0.395 //l=0.015 //layer=m1 \
 //thickness=0.36 //x=21.175 //y=3.495 //x2=21.175 //y2=3.51
r400 (  30 52 ) resistor r=4.5 //w=0.15 //l=0.15 //layer=via1 //count=1 \
 //x=18.25 //y=3.525 //x2=18.25 //y2=3.525
r401 (  28 30 ) resistor r=0.00493421 //w=0.38 //l=0.015 //layer=m1 \
 //thickness=0.36 //x=18.302 //y=3.51 //x2=18.302 //y2=3.525
r402 (  26 73 ) resistor r=9.3 //w=0.17 //l=0.17 //layer=mcon //count=1 \
 //x=18.25 //y=2.265 //x2=18.25 //y2=2.265
r403 (  24 50 ) resistor r=4.5 //w=0.15 //l=0.15 //layer=via1 //count=1 \
 //x=16.075 //y=4.415 //x2=16.075 //y2=4.415
r404 (  20 68 ) resistor r=9.3 //w=0.17 //l=0.17 //layer=mcon //count=1 \
 //x=16.03 //y=4.88 //x2=16.03 //y2=4.88
r405 (  17 40 ) resistor r=0.105739 //w=0.201 //l=0.145 //layer=m1 \
 //thickness=0.36 //x=21.58 //y=1.33 //x2=21.58 //y2=1.185
r406 (  17 18 ) resistor r=0.57729 //w=0.131 //l=0.605 //layer=m1 \
 //thickness=0.36 //x=21.58 //y=1.33 //x2=21.58 //y2=1.935
r407 (  16 43 ) resistor r=0.086672 //w=0.218 //l=0.14 //layer=m1 \
 //thickness=0.36 //x=21.575 //y=5.42 //x2=21.575 //y2=5.56
r408 (  15 16 ) resistor r=0.186069 //w=0.131 //l=0.195 //layer=m1 \
 //thickness=0.36 //x=21.575 //y=5.225 //x2=21.575 //y2=5.42
r409 (  13 15 ) resistor r=0.0698411 //w=0.17 //l=0.120208 //layer=m1 \
 //thickness=0.36 //x=21.49 //y=5.14 //x2=21.575 //y2=5.225
r410 (  13 14 ) resistor r=0.186069 //w=0.131 //l=0.195 //layer=m1 \
 //thickness=0.36 //x=21.49 //y=5.14 //x2=21.295 //y2=5.14
r411 (  11 18 ) resistor r=0.0698411 //w=0.17 //l=0.120208 //layer=m1 \
 //thickness=0.36 //x=21.495 //y=2.02 //x2=21.58 //y2=1.935
r412 (  11 12 ) resistor r=0.19084 //w=0.131 //l=0.2 //layer=m1 \
 //thickness=0.36 //x=21.495 //y=2.02 //x2=21.295 //y2=2.02
r413 (  10 14 ) resistor r=0.0698411 //w=0.17 //l=0.120208 //layer=m1 \
 //thickness=0.36 //x=21.21 //y=5.055 //x2=21.295 //y2=5.14
r414 (  9 38 ) resistor r=0.0914072 //w=0.382 //l=0.183303 //layer=m1 \
 //thickness=0.36 //x=21.21 //y=4.43 //x2=21.16 //y2=4.27
r415 (  9 10 ) resistor r=0.596374 //w=0.131 //l=0.625 //layer=m1 \
 //thickness=0.36 //x=21.21 //y=4.43 //x2=21.21 //y2=5.055
r416 (  8 36 ) resistor r=0.0766821 //w=0.382 //l=0.13775 //layer=m1 \
 //thickness=0.36 //x=21.21 //y=4.135 //x2=21.16 //y2=4.25
r417 (  7 34 ) resistor r=0.087246 //w=0.395 //l=0.161555 //layer=m1 \
 //thickness=0.36 //x=21.21 //y=3.655 //x2=21.175 //y2=3.51
r418 (  7 8 ) resistor r=0.458015 //w=0.131 //l=0.48 //layer=m1 \
 //thickness=0.36 //x=21.21 //y=3.655 //x2=21.21 //y2=4.135
r419 (  6 32 ) resistor r=0.0919929 //w=0.395 //l=0.176635 //layer=m1 \
 //thickness=0.36 //x=21.21 //y=3.335 //x2=21.175 //y2=3.495
r420 (  5 12 ) resistor r=0.0698411 //w=0.17 //l=0.120208 //layer=m1 \
 //thickness=0.36 //x=21.21 //y=2.105 //x2=21.295 //y2=2.02
r421 (  5 6 ) resistor r=1.17366 //w=0.131 //l=1.23 //layer=m1 \
 //thickness=0.36 //x=21.21 //y=2.105 //x2=21.21 //y2=3.335
r422 (  4 28 ) resistor r=0.0798098 //w=0.38 //l=0.148745 //layer=m1 \
 //thickness=0.36 //x=18.25 //y=3.385 //x2=18.302 //y2=3.51
r423 (  3 26 ) resistor r=0.0736049 //w=0.235 //l=0.12 //layer=m1 \
 //thickness=0.36 //x=18.25 //y=2.385 //x2=18.25 //y2=2.265
r424 (  3 4 ) resistor r=0.954198 //w=0.131 //l=1 //layer=m1 //thickness=0.36 \
 //x=18.25 //y=2.385 //x2=18.25 //y2=3.385
r425 (  2 20 ) resistor r=0.0704783 //w=0.246 //l=0.115 //layer=m1 \
 //thickness=0.36 //x=16.03 //y=4.765 //x2=16.03 //y2=4.88
r426 (  1 24 ) resistor r=0.0902587 //w=0.349 //l=0.187617 //layer=m1 \
 //thickness=0.36 //x=16.03 //y=4.575 //x2=16.09 //y2=4.415
r427 (  1 2 ) resistor r=0.181298 //w=0.131 //l=0.19 //layer=m1 \
 //thickness=0.36 //x=16.03 //y=4.575 //x2=16.03 //y2=4.765
ends PM_FA\%noxref_8

subckt PM_FA\%CIN ( 1 2 3 4 5 6 7 8 9 10 11 12 13 14 15 16 20 47 53 56 62 64 \
 66 67 70 73 77 84 85 88 97 103 112 117 122 127 128 129 130 131 132 133 134 \
 135 136 137 138 139 140 142 145 146 153 154 158 159 160 162 165 168 169 170 \
 171 172 173 174 175 179 181 184 185 197 202 213 )
c408 ( 213 0 ) capacitor c=0.0649657f //x=23.8 //y=4.88
c409 ( 202 0 ) capacitor c=0.052693f //x=21.84 //y=2.265
c410 ( 197 0 ) capacitor c=0.0660028f //x=18.25 //y=4.88
c411 ( 185 0 ) capacitor c=0.0318956f //x=24.135 //y=1.39
c412 ( 184 0 ) capacitor c=0.0186809f //x=24.135 //y=1.045
c413 ( 181 0 ) capacitor c=0.0141821f //x=23.98 //y=1.545
c414 ( 179 0 ) capacitor c=0.0158553f //x=23.98 //y=0.89
c415 ( 175 0 ) capacitor c=0.088055f //x=23.605 //y=2.095
c416 ( 174 0 ) capacitor c=0.0229235f //x=23.605 //y=1.7
c417 ( 173 0 ) capacitor c=0.0234359f //x=23.605 //y=1.39
c418 ( 172 0 ) capacitor c=0.0198759f //x=23.605 //y=1.045
c419 ( 171 0 ) capacitor c=0.0301471f //x=21.84 //y=2.1
c420 ( 170 0 ) capacitor c=0.0255528f //x=21.84 //y=1.745
c421 ( 169 0 ) capacitor c=0.0234346f //x=21.84 //y=1.435
c422 ( 168 0 ) capacitor c=0.0201416f //x=21.84 //y=1.09
c423 ( 165 0 ) capacitor c=0.0551924f //x=21.795 //y=5.045
c424 ( 162 0 ) capacitor c=0.0161993f //x=21.685 //y=1.59
c425 ( 160 0 ) capacitor c=0.0157807f //x=21.685 //y=0.935
c426 ( 159 0 ) capacitor c=0.0146709f //x=21.43 //y=4.97
c427 ( 158 0 ) capacitor c=0.0244235f //x=21.72 //y=4.97
c428 ( 154 0 ) capacitor c=0.0439448f //x=21.31 //y=1.435
c429 ( 153 0 ) capacitor c=0.0200047f //x=21.31 //y=1.09
c430 ( 146 0 ) capacitor c=0.0423887f //x=16.225 //y=1.435
c431 ( 145 0 ) capacitor c=0.0192582f //x=16.225 //y=1.09
c432 ( 142 0 ) capacitor c=0.0126237f //x=16.07 //y=1.59
c433 ( 140 0 ) capacitor c=0.0157807f //x=16.07 //y=0.935
c434 ( 139 0 ) capacitor c=0.0975376f //x=15.695 //y=2.1
c435 ( 138 0 ) capacitor c=0.0197088f //x=15.695 //y=1.745
c436 ( 137 0 ) capacitor c=0.0168511f //x=15.695 //y=1.435
c437 ( 136 0 ) capacitor c=0.0175047f //x=15.695 //y=1.09
c438 ( 135 0 ) capacitor c=0.110369f //x=24.14 //y=6.2
c439 ( 134 0 ) capacitor c=0.154619f //x=23.7 //y=6.2
c440 ( 133 0 ) capacitor c=0.15441f //x=21.795 //y=6.2
c441 ( 132 0 ) capacitor c=0.153916f //x=21.355 //y=6.2
c442 ( 131 0 ) capacitor c=0.110998f //x=18.59 //y=6.2
c443 ( 130 0 ) capacitor c=0.155254f //x=18.15 //y=6.2
c444 ( 122 0 ) capacitor c=0.0105623f //x=23.8 //y=4.62
c445 ( 117 0 ) capacitor c=7.85889e-19 //x=23.8 //y=2.26
c446 ( 112 0 ) capacitor c=9.45224e-19 //x=21.95 //y=4.88
c447 ( 103 0 ) capacitor c=6.43121e-19 //x=21.95 //y=2.265
c448 ( 97 0 ) capacitor c=0.0143211f //x=18.25 //y=4.62
c449 ( 88 0 ) capacitor c=6.09166e-19 //x=16.03 //y=2.265
c450 ( 85 0 ) capacitor c=0.0338634f //x=23.635 //y=4.625
c451 ( 84 0 ) capacitor c=0.0014314f //x=23.795 //y=4.625
c452 ( 77 0 ) capacitor c=2.37657e-19 //x=16.19 //y=3.155
c453 ( 73 0 ) capacitor c=0.00792237f //x=22.12 //y=4.62
c454 ( 70 0 ) capacitor c=4.53335e-19 //x=21.96 //y=4.885
c455 ( 67 0 ) capacitor c=0.0227819f //x=21.085 //y=4.655
c456 ( 66 0 ) capacitor c=0.00148463f //x=21.43 //y=4.655
c457 ( 64 0 ) capacitor c=0.00763309f //x=21.46 //y=3.11
c458 ( 62 0 ) capacitor c=0.0597546f //x=20.86 //y=3.14
c459 ( 56 0 ) capacitor c=0.00392539f //x=23.8 //y=2.26
c460 ( 53 0 ) capacitor c=0.00544519f //x=21.95 //y=2.265
c461 ( 47 0 ) capacitor c=0.00603316f //x=21.95 //y=4.88
c462 ( 20 0 ) capacitor c=0.0137388f //x=21.95 //y=3.3
c463 ( 16 0 ) capacitor c=0.0112271f //x=16.03 //y=2.995
c464 ( 15 0 ) capacitor c=0.00301344f //x=16.03 //y=2.415
c465 ( 14 0 ) capacitor c=0.0133355f //x=23.8 //y=4.62
c466 ( 13 0 ) capacitor c=0.0143297f //x=21.95 //y=3.14
c467 ( 12 0 ) capacitor c=0.013641f //x=18.25 //y=4.62
c468 ( 11 0 ) capacitor c=0.0272601f //x=16.03 //y=3.14
c469 ( 6 0 ) capacitor c=0.0633199f //x=23.8 //y=2.77
c470 ( 2 0 ) capacitor c=0.0374632f //x=21.95 //y=3.51
c471 ( 1 0 ) capacitor c=0.0120031f //x=21.95 //y=2.77
r472 (  211 213 ) resistor r=20.6867 //w=0.233 //l=0.1 //layer=ply \
 //thickness=0.18 //x=23.7 //y=4.88 //x2=23.8 //y2=4.88
r473 (  202 204 ) resistor r=17.5563 //w=0.302 //l=0.11 //layer=ply \
 //thickness=0.18 //x=21.84 //y=2.265 //x2=21.95 //y2=2.265
r474 (  195 197 ) resistor r=20.6867 //w=0.233 //l=0.1 //layer=ply \
 //thickness=0.18 //x=18.15 //y=4.88 //x2=18.25 //y2=4.88
r475 (  186 213 ) resistor r=70.3348 //w=0.233 //l=0.414367 //layer=ply \
 //thickness=0.18 //x=24.14 //y=5.045 //x2=23.8 //y2=4.88
r476 (  185 215 ) resistor r=45.1352 //w=0.168 //l=0.173853 //layer=ply \
 //thickness=0.18 //x=24.135 //y=1.39 //x2=24.095 //y2=1.545
r477 (  184 214 ) resistor r=45.1352 //w=0.168 //l=0.173853 //layer=ply \
 //thickness=0.18 //x=24.135 //y=1.045 //x2=24.095 //y2=0.89
r478 (  184 185 ) resistor r=176.904 //w=0.094 //l=0.345 //layer=ply \
 //thickness=0.18 //x=24.135 //y=1.045 //x2=24.135 //y2=1.39
r479 (  182 210 ) resistor r=10.701 //w=0.21 //l=0.115 //layer=ply \
 //thickness=0.18 //x=23.76 //y=1.545 //x2=23.645 //y2=1.545
r480 (  181 215 ) resistor r=5.52526 //w=0.168 //l=0.115 //layer=ply \
 //thickness=0.18 //x=23.98 //y=1.545 //x2=24.095 //y2=1.545
r481 (  180 209 ) resistor r=5.52526 //w=0.168 //l=0.115 //layer=ply \
 //thickness=0.18 //x=23.76 //y=0.89 //x2=23.645 //y2=0.89
r482 (  179 214 ) resistor r=5.52526 //w=0.168 //l=0.115 //layer=ply \
 //thickness=0.18 //x=23.98 //y=0.89 //x2=24.095 //y2=0.89
r483 (  179 180 ) resistor r=112.809 //w=0.094 //l=0.22 //layer=ply \
 //thickness=0.18 //x=23.98 //y=0.89 //x2=23.76 //y2=0.89
r484 (  176 211 ) resistor r=13.0941 //w=0.233 //l=0.165 //layer=ply \
 //thickness=0.18 //x=23.7 //y=5.045 //x2=23.7 //y2=4.88
r485 (  175 208 ) resistor r=34.8111 //w=0.27 //l=0.264953 //layer=ply \
 //thickness=0.18 //x=23.605 //y=2.095 //x2=23.8 //y2=2.26
r486 (  174 210 ) resistor r=39.5823 //w=0.21 //l=0.173853 //layer=ply \
 //thickness=0.18 //x=23.605 //y=1.7 //x2=23.645 //y2=1.545
r487 (  174 175 ) resistor r=202.543 //w=0.094 //l=0.395 //layer=ply \
 //thickness=0.18 //x=23.605 //y=1.7 //x2=23.605 //y2=2.095
r488 (  173 210 ) resistor r=39.5823 //w=0.21 //l=0.173853 //layer=ply \
 //thickness=0.18 //x=23.605 //y=1.39 //x2=23.645 //y2=1.545
r489 (  172 209 ) resistor r=45.1352 //w=0.168 //l=0.173853 //layer=ply \
 //thickness=0.18 //x=23.605 //y=1.045 //x2=23.645 //y2=0.89
r490 (  172 173 ) resistor r=176.904 //w=0.094 //l=0.345 //layer=ply \
 //thickness=0.18 //x=23.605 //y=1.045 //x2=23.605 //y2=1.39
r491 (  171 202 ) resistor r=19.1248 //w=0.302 //l=0.165 //layer=ply \
 //thickness=0.18 //x=21.84 //y=2.1 //x2=21.84 //y2=2.265
r492 (  170 201 ) resistor r=39.5823 //w=0.21 //l=0.173853 //layer=ply \
 //thickness=0.18 //x=21.84 //y=1.745 //x2=21.8 //y2=1.59
r493 (  170 171 ) resistor r=182.032 //w=0.094 //l=0.355 //layer=ply \
 //thickness=0.18 //x=21.84 //y=1.745 //x2=21.84 //y2=2.1
r494 (  169 201 ) resistor r=39.5823 //w=0.21 //l=0.173853 //layer=ply \
 //thickness=0.18 //x=21.84 //y=1.435 //x2=21.8 //y2=1.59
r495 (  168 200 ) resistor r=45.1352 //w=0.168 //l=0.173853 //layer=ply \
 //thickness=0.18 //x=21.84 //y=1.09 //x2=21.8 //y2=0.935
r496 (  168 169 ) resistor r=176.904 //w=0.094 //l=0.345 //layer=ply \
 //thickness=0.18 //x=21.84 //y=1.09 //x2=21.84 //y2=1.435
r497 (  165 206 ) resistor r=26.3063 //w=0.284 //l=0.229783 //layer=ply \
 //thickness=0.18 //x=21.795 //y=5.045 //x2=21.95 //y2=4.88
r498 (  163 199 ) resistor r=5.52526 //w=0.168 //l=0.115 //layer=ply \
 //thickness=0.18 //x=21.465 //y=1.59 //x2=21.35 //y2=1.59
r499 (  162 201 ) resistor r=10.701 //w=0.21 //l=0.115 //layer=ply \
 //thickness=0.18 //x=21.685 //y=1.59 //x2=21.8 //y2=1.59
r500 (  161 198 ) resistor r=5.52526 //w=0.168 //l=0.115 //layer=ply \
 //thickness=0.18 //x=21.465 //y=0.935 //x2=21.35 //y2=0.935
r501 (  160 200 ) resistor r=5.52526 //w=0.168 //l=0.115 //layer=ply \
 //thickness=0.18 //x=21.685 //y=0.935 //x2=21.8 //y2=0.935
r502 (  160 161 ) resistor r=112.809 //w=0.094 //l=0.22 //layer=ply \
 //thickness=0.18 //x=21.685 //y=0.935 //x2=21.465 //y2=0.935
r503 (  158 165 ) resistor r=23.403 //w=0.284 //l=0.106066 //layer=ply \
 //thickness=0.18 //x=21.72 //y=4.97 //x2=21.795 //y2=5.045
r504 (  158 159 ) resistor r=148.702 //w=0.094 //l=0.29 //layer=ply \
 //thickness=0.18 //x=21.72 //y=4.97 //x2=21.43 //y2=4.97
r505 (  155 159 ) resistor r=26.9307 //w=0.15 //l=0.106066 //layer=ply \
 //thickness=0.18 //x=21.355 //y=5.045 //x2=21.43 //y2=4.97
r506 (  154 199 ) resistor r=45.1352 //w=0.168 //l=0.173853 //layer=ply \
 //thickness=0.18 //x=21.31 //y=1.435 //x2=21.35 //y2=1.59
r507 (  153 198 ) resistor r=45.1352 //w=0.168 //l=0.173853 //layer=ply \
 //thickness=0.18 //x=21.31 //y=1.09 //x2=21.35 //y2=0.935
r508 (  153 154 ) resistor r=176.904 //w=0.094 //l=0.345 //layer=ply \
 //thickness=0.18 //x=21.31 //y=1.09 //x2=21.31 //y2=1.435
r509 (  150 197 ) resistor r=70.3348 //w=0.233 //l=0.414367 //layer=ply \
 //thickness=0.18 //x=18.59 //y=5.045 //x2=18.25 //y2=4.88
r510 (  147 195 ) resistor r=13.0941 //w=0.233 //l=0.165 //layer=ply \
 //thickness=0.18 //x=18.15 //y=5.045 //x2=18.15 //y2=4.88
r511 (  146 194 ) resistor r=45.1352 //w=0.168 //l=0.173853 //layer=ply \
 //thickness=0.18 //x=16.225 //y=1.435 //x2=16.185 //y2=1.59
r512 (  145 193 ) resistor r=45.1352 //w=0.168 //l=0.173853 //layer=ply \
 //thickness=0.18 //x=16.225 //y=1.09 //x2=16.185 //y2=0.935
r513 (  145 146 ) resistor r=176.904 //w=0.094 //l=0.345 //layer=ply \
 //thickness=0.18 //x=16.225 //y=1.09 //x2=16.225 //y2=1.435
r514 (  143 190 ) resistor r=10.701 //w=0.21 //l=0.115 //layer=ply \
 //thickness=0.18 //x=15.85 //y=1.59 //x2=15.735 //y2=1.59
r515 (  142 194 ) resistor r=5.52526 //w=0.168 //l=0.115 //layer=ply \
 //thickness=0.18 //x=16.07 //y=1.59 //x2=16.185 //y2=1.59
r516 (  141 189 ) resistor r=5.52526 //w=0.168 //l=0.115 //layer=ply \
 //thickness=0.18 //x=15.85 //y=0.935 //x2=15.735 //y2=0.935
r517 (  140 193 ) resistor r=5.52526 //w=0.168 //l=0.115 //layer=ply \
 //thickness=0.18 //x=16.07 //y=0.935 //x2=16.185 //y2=0.935
r518 (  140 141 ) resistor r=112.809 //w=0.094 //l=0.22 //layer=ply \
 //thickness=0.18 //x=16.07 //y=0.935 //x2=15.85 //y2=0.935
r519 (  139 192 ) resistor r=67.2792 //w=0.24 //l=0.438891 //layer=ply \
 //thickness=0.18 //x=15.695 //y=2.1 //x2=16.03 //y2=2.34
r520 (  138 190 ) resistor r=39.5823 //w=0.21 //l=0.173853 //layer=ply \
 //thickness=0.18 //x=15.695 //y=1.745 //x2=15.735 //y2=1.59
r521 (  138 139 ) resistor r=182.032 //w=0.094 //l=0.355 //layer=ply \
 //thickness=0.18 //x=15.695 //y=1.745 //x2=15.695 //y2=2.1
r522 (  137 190 ) resistor r=39.5823 //w=0.21 //l=0.173853 //layer=ply \
 //thickness=0.18 //x=15.695 //y=1.435 //x2=15.735 //y2=1.59
r523 (  136 189 ) resistor r=45.1352 //w=0.168 //l=0.173853 //layer=ply \
 //thickness=0.18 //x=15.695 //y=1.09 //x2=15.735 //y2=0.935
r524 (  136 137 ) resistor r=176.904 //w=0.094 //l=0.345 //layer=ply \
 //thickness=0.18 //x=15.695 //y=1.09 //x2=15.695 //y2=1.435
r525 (  135 186 ) resistor r=592.245 //w=0.094 //l=1.155 //layer=ply \
 //thickness=0.18 //x=24.14 //y=6.2 //x2=24.14 //y2=5.045
r526 (  134 176 ) resistor r=592.245 //w=0.094 //l=1.155 //layer=ply \
 //thickness=0.18 //x=23.7 //y=6.2 //x2=23.7 //y2=5.045
r527 (  133 165 ) resistor r=592.245 //w=0.094 //l=1.155 //layer=ply \
 //thickness=0.18 //x=21.795 //y=6.2 //x2=21.795 //y2=5.045
r528 (  132 155 ) resistor r=592.245 //w=0.094 //l=1.155 //layer=ply \
 //thickness=0.18 //x=21.355 //y=6.2 //x2=21.355 //y2=5.045
r529 (  131 150 ) resistor r=592.245 //w=0.094 //l=1.155 //layer=ply \
 //thickness=0.18 //x=18.59 //y=6.2 //x2=18.59 //y2=5.045
r530 (  130 147 ) resistor r=592.245 //w=0.094 //l=1.155 //layer=ply \
 //thickness=0.18 //x=18.15 //y=6.2 //x2=18.15 //y2=5.045
r531 (  129 181 ) resistor r=56.4043 //w=0.094 //l=0.11 //layer=ply \
 //thickness=0.18 //x=23.87 //y=1.545 //x2=23.98 //y2=1.545
r532 (  129 182 ) resistor r=56.4043 //w=0.094 //l=0.11 //layer=ply \
 //thickness=0.18 //x=23.87 //y=1.545 //x2=23.76 //y2=1.545
r533 (  128 162 ) resistor r=56.4043 //w=0.094 //l=0.11 //layer=ply \
 //thickness=0.18 //x=21.575 //y=1.59 //x2=21.685 //y2=1.59
r534 (  128 163 ) resistor r=56.4043 //w=0.094 //l=0.11 //layer=ply \
 //thickness=0.18 //x=21.575 //y=1.59 //x2=21.465 //y2=1.59
r535 (  127 142 ) resistor r=56.4043 //w=0.094 //l=0.11 //layer=ply \
 //thickness=0.18 //x=15.96 //y=1.59 //x2=16.07 //y2=1.59
r536 (  127 143 ) resistor r=56.4043 //w=0.094 //l=0.11 //layer=ply \
 //thickness=0.18 //x=15.96 //y=1.59 //x2=15.85 //y2=1.59
r537 (  125 213 ) resistor r=152 //w=0.17 //l=0.17 //layer=licon //count=1 \
 //x=23.8 //y=4.88 //x2=23.8 //y2=4.88
r538 (  122 125 ) resistor r=17.7968 //w=0.187 //l=0.26 //layer=li \
 //thickness=0.1 //x=23.8 //y=4.62 //x2=23.8 //y2=4.88
r539 (  117 208 ) resistor r=152 //w=0.17 //l=0.17 //layer=licon //count=1 \
 //x=23.8 //y=2.26 //x2=23.8 //y2=2.26
r540 (  112 206 ) resistor r=152 //w=0.17 //l=0.17 //layer=licon //count=1 \
 //x=21.95 //y=4.88 //x2=21.95 //y2=4.88
r541 (  103 204 ) resistor r=152 //w=0.17 //l=0.17 //layer=licon //count=1 \
 //x=21.95 //y=2.265 //x2=21.95 //y2=2.265
r542 (  100 197 ) resistor r=152 //w=0.17 //l=0.17 //layer=licon //count=1 \
 //x=18.25 //y=4.88 //x2=18.25 //y2=4.88
r543 (  97 100 ) resistor r=17.7968 //w=0.187 //l=0.26 //layer=li \
 //thickness=0.1 //x=18.25 //y=4.62 //x2=18.25 //y2=4.88
r544 (  88 192 ) resistor r=152 //w=0.17 //l=0.17 //layer=licon //count=1 \
 //x=16.03 //y=2.265 //x2=16.03 //y2=2.265
r545 (  84 85 ) resistor r=0.10734 //w=0.281 //l=0.16 //layer=m2 \
 //thickness=0.36 //x=23.795 //y=4.625 //x2=23.635 //y2=4.625
r546 (  75 77 ) resistor r=0.10734 //w=0.281 //l=0.16 //layer=m2 \
 //thickness=0.36 //x=16.03 //y=3.155 //x2=16.19 //y2=3.155
r547 (  73 85 ) resistor r=1.44561 //w=0.131 //l=1.515 //layer=m2 \
 //thickness=0.36 //x=22.12 //y=4.62 //x2=23.635 //y2=4.62
r548 (  68 73 ) resistor r=0.116279 //w=0.172 //l=0.168285 //layer=m2 \
 //thickness=0.36 //x=21.96 //y=4.637 //x2=22.12 //y2=4.62
r549 (  68 70 ) resistor r=0.0800712 //w=0.281 //l=0.18 //layer=m2 \
 //thickness=0.36 //x=21.96 //y=4.705 //x2=21.96 //y2=4.885
r550 (  67 79 ) resistor r=1.89634 //w=0.187 //l=2.8584 //layer=m2 \
 //thickness=0.36 //x=21.085 //y=4.655 //x2=18.25 //y2=4.702
r551 (  66 68 ) resistor r=0.385174 //w=0.172 //l=0.538925 //layer=m2 \
 //thickness=0.36 //x=21.43 //y=4.655 //x2=21.96 //y2=4.637
r552 (  66 67 ) resistor r=0.329198 //w=0.131 //l=0.345 //layer=m2 \
 //thickness=0.36 //x=21.43 //y=4.655 //x2=21.085 //y2=4.655
r553 (  64 82 ) resistor r=0.259285 //w=0.245 //l=0.499775 //layer=m2 \
 //thickness=0.36 //x=21.46 //y=3.11 //x2=21.945 //y2=3.14
r554 (  64 65 ) resistor r=0.410305 //w=0.131 //l=0.43 //layer=m2 \
 //thickness=0.36 //x=21.46 //y=3.11 //x2=21.03 //y2=3.11
r555 (  62 65 ) resistor r=0.125 //w=0.17 //l=0.184391 //layer=m2 \
 //thickness=0.36 //x=20.86 //y=3.14 //x2=21.03 //y2=3.11
r556 (  62 77 ) resistor r=4.45611 //w=0.131 //l=4.67 //layer=m2 \
 //thickness=0.36 //x=20.86 //y=3.14 //x2=16.19 //y2=3.14
r557 (  61 84 ) resistor r=4.5 //w=0.15 //l=0.15 //layer=via1 //count=1 \
 //x=23.795 //y=4.625 //x2=23.795 //y2=4.625
r558 (  56 117 ) resistor r=9.3 //w=0.17 //l=0.17 //layer=mcon //count=1 \
 //x=23.8 //y=2.26 //x2=23.8 //y2=2.26
r559 (  53 103 ) resistor r=9.3 //w=0.17 //l=0.17 //layer=mcon //count=1 \
 //x=21.95 //y=2.265 //x2=21.95 //y2=2.265
r560 (  50 70 ) resistor r=4.5 //w=0.15 //l=0.15 //layer=via1 //count=1 \
 //x=21.96 //y=4.885 //x2=21.96 //y2=4.885
r561 (  47 112 ) resistor r=9.3 //w=0.17 //l=0.17 //layer=mcon //count=1 \
 //x=21.95 //y=4.88 //x2=21.95 //y2=4.88
r562 (  47 50 ) resistor r=0.0022242 //w=0.281 //l=0.005 //layer=m1 \
 //thickness=0.36 //x=21.96 //y=4.88 //x2=21.96 //y2=4.885
r563 (  47 48 ) resistor r=0.105116 //w=0.281 //l=0.155 //layer=m1 \
 //thickness=0.36 //x=21.96 //y=4.88 //x2=21.96 //y2=4.725
r564 (  42 79 ) resistor r=4.5 //w=0.15 //l=0.15 //layer=via1 //count=1 \
 //x=18.25 //y=4.71 //x2=18.25 //y2=4.71
r565 (  38 75 ) resistor r=4.5 //w=0.15 //l=0.15 //layer=via1 //count=1 \
 //x=16.03 //y=3.155 //x2=16.03 //y2=3.155
r566 (  34 88 ) resistor r=9.3 //w=0.17 //l=0.17 //layer=mcon //count=1 \
 //x=16.03 //y=2.265 //x2=16.03 //y2=2.265
r567 (  26 56 ) resistor r=0.0933015 //w=0.201 //l=0.125 //layer=m1 \
 //thickness=0.36 //x=23.8 //y=2.385 //x2=23.8 //y2=2.26
r568 (  17 53 ) resistor r=0.116051 //w=0.211 //l=0.165 //layer=m1 \
 //thickness=0.36 //x=21.95 //y=2.43 //x2=21.95 //y2=2.265
r569 (  15 34 ) resistor r=0.0891709 //w=0.238 //l=0.151493 //layer=m1 \
 //thickness=0.36 //x=16.03 //y=2.415 //x2=16.027 //y2=2.265
r570 (  15 16 ) resistor r=0.553435 //w=0.131 //l=0.58 //layer=m1 \
 //thickness=0.36 //x=16.03 //y=2.415 //x2=16.03 //y2=2.995
r571 (  14 122 ) resistor r=4.65 //w=0.17 //l=0.34 //layer=mcon //count=2 \
 //x=23.8 //y=4.62 //x2=23.8 //y2=4.62
r572 (  14 61 ) resistor r=0.00199045 //w=0.314 //l=0.005 //layer=m1 \
 //thickness=0.36 //x=23.745 //y=4.62 //x2=23.745 //y2=4.625
r573 (  14 27 ) resistor r=0.0878167 //w=0.314 //l=0.180416 //layer=m1 \
 //thickness=0.36 //x=23.745 //y=4.62 //x2=23.8 //y2=4.465
r574 (  13 82 ) resistor r=4.5 //w=0.15 //l=0.15 //layer=via1 //count=1 \
 //x=21.945 //y=3.14 //x2=21.945 //y2=3.14
r575 (  13 20 ) resistor r=0.0910802 //w=0.374 //l=0.185472 //layer=m1 \
 //thickness=0.36 //x=21.895 //y=3.14 //x2=21.95 //y2=3.3
r576 (  13 18 ) resistor r=0.0910802 //w=0.374 //l=0.185472 //layer=m1 \
 //thickness=0.36 //x=21.895 //y=3.14 //x2=21.95 //y2=2.98
r577 (  12 97 ) resistor r=9.3 //w=0.17 //l=0.17 //layer=mcon //count=1 \
 //x=18.25 //y=4.62 //x2=18.25 //y2=4.62
r578 (  12 42 ) resistor r=0.0317797 //w=0.354 //l=0.09 //layer=m1 \
 //thickness=0.36 //x=18.302 //y=4.62 //x2=18.302 //y2=4.71
r579 (  11 38 ) resistor r=0.0049867 //w=0.376 //l=0.015 //layer=m1 \
 //thickness=0.36 //x=16.082 //y=3.14 //x2=16.082 //y2=3.155
r580 (  11 16 ) resistor r=0.0861726 //w=0.376 //l=0.169012 //layer=m1 \
 //thickness=0.36 //x=16.082 //y=3.14 //x2=16.03 //y2=2.995
r581 (  10 27 ) resistor r=0.205153 //w=0.131 //l=0.215 //layer=m1 \
 //thickness=0.36 //x=23.8 //y=4.25 //x2=23.8 //y2=4.465
r582 (  9 10 ) resistor r=0.353053 //w=0.131 //l=0.37 //layer=m1 \
 //thickness=0.36 //x=23.8 //y=3.88 //x2=23.8 //y2=4.25
r583 (  8 9 ) resistor r=0.353053 //w=0.131 //l=0.37 //layer=m1 \
 //thickness=0.36 //x=23.8 //y=3.51 //x2=23.8 //y2=3.88
r584 (  7 8 ) resistor r=0.353053 //w=0.131 //l=0.37 //layer=m1 \
 //thickness=0.36 //x=23.8 //y=3.14 //x2=23.8 //y2=3.51
r585 (  6 7 ) resistor r=0.353053 //w=0.131 //l=0.37 //layer=m1 \
 //thickness=0.36 //x=23.8 //y=2.77 //x2=23.8 //y2=3.14
r586 (  6 26 ) resistor r=0.367366 //w=0.131 //l=0.385 //layer=m1 \
 //thickness=0.36 //x=23.8 //y=2.77 //x2=23.8 //y2=2.385
r587 (  5 48 ) resistor r=0.100191 //w=0.131 //l=0.105 //layer=m1 \
 //thickness=0.36 //x=21.95 //y=4.62 //x2=21.95 //y2=4.725
r588 (  4 5 ) resistor r=0.353053 //w=0.131 //l=0.37 //layer=m1 \
 //thickness=0.36 //x=21.95 //y=4.25 //x2=21.95 //y2=4.62
r589 (  3 4 ) resistor r=0.353053 //w=0.131 //l=0.37 //layer=m1 \
 //thickness=0.36 //x=21.95 //y=3.88 //x2=21.95 //y2=4.25
r590 (  2 3 ) resistor r=0.353053 //w=0.131 //l=0.37 //layer=m1 \
 //thickness=0.36 //x=21.95 //y=3.51 //x2=21.95 //y2=3.88
r591 (  2 20 ) resistor r=0.200382 //w=0.131 //l=0.21 //layer=m1 \
 //thickness=0.36 //x=21.95 //y=3.51 //x2=21.95 //y2=3.3
r592 (  1 18 ) resistor r=0.200382 //w=0.131 //l=0.21 //layer=m1 \
 //thickness=0.36 //x=21.95 //y=2.77 //x2=21.95 //y2=2.98
r593 (  1 17 ) resistor r=0.324427 //w=0.131 //l=0.34 //layer=m1 \
 //thickness=0.36 //x=21.95 //y=2.77 //x2=21.95 //y2=2.43
ends PM_FA\%CIN

subckt PM_FA\%noxref_10 ( 3 8 9 11 12 14 15 16 18 19 20 23 24 27 29 32 35 38 \
 42 43 48 51 59 76 85 89 90 91 92 93 94 95 99 100 101 103 109 110 112 120 122 \
 123 )
c247 ( 120 0 ) capacitor c=0.00878249f //x=24.65 //y=1.085
c248 ( 112 0 ) capacitor c=0.0545922f //x=26.76 //y=2.265
c249 ( 110 0 ) capacitor c=0.0439596f //x=27.4 //y=1.435
c250 ( 109 0 ) capacitor c=0.0200164f //x=27.4 //y=1.09
c251 ( 103 0 ) capacitor c=0.0161993f //x=27.245 //y=1.59
c252 ( 101 0 ) capacitor c=0.0157807f //x=27.245 //y=0.935
c253 ( 100 0 ) capacitor c=0.055513f //x=26.99 //y=4.97
c254 ( 99 0 ) capacitor c=0.0406047f //x=27.28 //y=4.97
c255 ( 95 0 ) capacitor c=0.0301471f //x=26.87 //y=2.1
c256 ( 94 0 ) capacitor c=0.0255349f //x=26.87 //y=1.745
c257 ( 93 0 ) capacitor c=0.0234346f //x=26.87 //y=1.435
c258 ( 92 0 ) capacitor c=0.02013f //x=26.87 //y=1.09
c259 ( 91 0 ) capacitor c=0.153906f //x=27.355 //y=6.2
c260 ( 90 0 ) capacitor c=0.154399f //x=26.915 //y=6.2
c261 ( 85 0 ) capacitor c=9.4527e-19 //x=26.76 //y=4.88
c262 ( 76 0 ) capacitor c=9.11699e-19 //x=26.76 //y=2.265
c263 ( 59 0 ) capacitor c=0.0321204f //x=24.8 //y=5.56
c264 ( 51 0 ) capacitor c=0.0289608f //x=23.92 //y=5.56
c265 ( 48 0 ) capacitor c=7.25653e-19 //x=26.755 //y=3.51
c266 ( 43 0 ) capacitor c=0.00146389f //x=25.44 //y=3.51
c267 ( 42 0 ) capacitor c=0.0283196f //x=26.595 //y=3.51
c268 ( 38 0 ) capacitor c=0.00754811f //x=26.76 //y=2.265
c269 ( 35 0 ) capacitor c=0.0159873f //x=26.755 //y=3.51
c270 ( 32 0 ) capacitor c=0.0165963f //x=25.28 //y=3.51
c271 ( 29 0 ) capacitor c=0.011292f //x=24.84 //y=1.18
c272 ( 27 0 ) capacitor c=7.81299e-19 //x=24.8 //y=5.56
c273 ( 24 0 ) capacitor c=0.00940334f //x=24.8 //y=5.38
c274 ( 23 0 ) capacitor c=0.00901015f //x=23.92 //y=5.56
c275 ( 20 0 ) capacitor c=0.0324719f //x=26.76 //y=4.76
c276 ( 19 0 ) capacitor c=0.0130356f //x=26.76 //y=3.67
c277 ( 18 0 ) capacitor c=0.0208229f //x=26.76 //y=3.35
c278 ( 16 0 ) capacitor c=0.042403f //x=25.28 //y=5.295
c279 ( 15 0 ) capacitor c=0.0132287f //x=25.28 //y=3.67
c280 ( 14 0 ) capacitor c=0.0344505f //x=25.28 //y=3.35
c281 ( 12 0 ) capacitor c=0.00384891f //x=24.925 //y=1.835
c282 ( 11 0 ) capacitor c=0.0140404f //x=25.195 //y=1.835
c283 ( 9 0 ) capacitor c=0.0107537f //x=25.195 //y=5.38
c284 ( 8 0 ) capacitor c=0.0090797f //x=24.84 //y=1.75
c285 ( 3 0 ) capacitor c=0.014446f //x=24.685 //y=5.38
r286 (  112 113 ) resistor r=17.5563 //w=0.302 //l=0.11 //layer=ply \
 //thickness=0.18 //x=26.76 //y=2.265 //x2=26.87 //y2=2.265
r287 (  110 119 ) resistor r=45.1352 //w=0.168 //l=0.173853 //layer=ply \
 //thickness=0.18 //x=27.4 //y=1.435 //x2=27.36 //y2=1.59
r288 (  109 118 ) resistor r=45.1352 //w=0.168 //l=0.173853 //layer=ply \
 //thickness=0.18 //x=27.4 //y=1.09 //x2=27.36 //y2=0.935
r289 (  109 110 ) resistor r=176.904 //w=0.094 //l=0.345 //layer=ply \
 //thickness=0.18 //x=27.4 //y=1.09 //x2=27.4 //y2=1.435
r290 (  104 117 ) resistor r=10.701 //w=0.21 //l=0.115 //layer=ply \
 //thickness=0.18 //x=27.025 //y=1.59 //x2=26.91 //y2=1.59
r291 (  103 119 ) resistor r=5.52526 //w=0.168 //l=0.115 //layer=ply \
 //thickness=0.18 //x=27.245 //y=1.59 //x2=27.36 //y2=1.59
r292 (  102 116 ) resistor r=5.52526 //w=0.168 //l=0.115 //layer=ply \
 //thickness=0.18 //x=27.025 //y=0.935 //x2=26.91 //y2=0.935
r293 (  101 118 ) resistor r=5.52526 //w=0.168 //l=0.115 //layer=ply \
 //thickness=0.18 //x=27.245 //y=0.935 //x2=27.36 //y2=0.935
r294 (  101 102 ) resistor r=112.809 //w=0.094 //l=0.22 //layer=ply \
 //thickness=0.18 //x=27.245 //y=0.935 //x2=27.025 //y2=0.935
r295 (  99 106 ) resistor r=26.9307 //w=0.15 //l=0.106066 //layer=ply \
 //thickness=0.18 //x=27.28 //y=4.97 //x2=27.355 //y2=5.045
r296 (  99 100 ) resistor r=148.702 //w=0.094 //l=0.29 //layer=ply \
 //thickness=0.18 //x=27.28 //y=4.97 //x2=26.99 //y2=4.97
r297 (  96 100 ) resistor r=23.403 //w=0.284 //l=0.106066 //layer=ply \
 //thickness=0.18 //x=26.915 //y=5.045 //x2=26.99 //y2=4.97
r298 (  96 115 ) resistor r=26.3063 //w=0.284 //l=0.229783 //layer=ply \
 //thickness=0.18 //x=26.915 //y=5.045 //x2=26.76 //y2=4.88
r299 (  95 113 ) resistor r=19.1248 //w=0.302 //l=0.165 //layer=ply \
 //thickness=0.18 //x=26.87 //y=2.1 //x2=26.87 //y2=2.265
r300 (  94 117 ) resistor r=39.5823 //w=0.21 //l=0.173853 //layer=ply \
 //thickness=0.18 //x=26.87 //y=1.745 //x2=26.91 //y2=1.59
r301 (  94 95 ) resistor r=182.032 //w=0.094 //l=0.355 //layer=ply \
 //thickness=0.18 //x=26.87 //y=1.745 //x2=26.87 //y2=2.1
r302 (  93 117 ) resistor r=39.5823 //w=0.21 //l=0.173853 //layer=ply \
 //thickness=0.18 //x=26.87 //y=1.435 //x2=26.91 //y2=1.59
r303 (  92 116 ) resistor r=45.1352 //w=0.168 //l=0.173853 //layer=ply \
 //thickness=0.18 //x=26.87 //y=1.09 //x2=26.91 //y2=0.935
r304 (  92 93 ) resistor r=176.904 //w=0.094 //l=0.345 //layer=ply \
 //thickness=0.18 //x=26.87 //y=1.09 //x2=26.87 //y2=1.435
r305 (  91 106 ) resistor r=592.245 //w=0.094 //l=1.155 //layer=ply \
 //thickness=0.18 //x=27.355 //y=6.2 //x2=27.355 //y2=5.045
r306 (  90 96 ) resistor r=592.245 //w=0.094 //l=1.155 //layer=ply \
 //thickness=0.18 //x=26.915 //y=6.2 //x2=26.915 //y2=5.045
r307 (  89 103 ) resistor r=56.4043 //w=0.094 //l=0.11 //layer=ply \
 //thickness=0.18 //x=27.135 //y=1.59 //x2=27.245 //y2=1.59
r308 (  89 104 ) resistor r=56.4043 //w=0.094 //l=0.11 //layer=ply \
 //thickness=0.18 //x=27.135 //y=1.59 //x2=27.025 //y2=1.59
r309 (  85 115 ) resistor r=152 //w=0.17 //l=0.17 //layer=licon //count=1 \
 //x=26.76 //y=4.88 //x2=26.76 //y2=4.88
r310 (  76 112 ) resistor r=152 //w=0.17 //l=0.17 //layer=licon //count=1 \
 //x=26.76 //y=2.265 //x2=26.76 //y2=2.265
r311 (  59 123 ) resistor r=23.615 //w=0.187 //l=0.345 //layer=li \
 //thickness=0.1 //x=24.8 //y=5.56 //x2=24.8 //y2=5.905
r312 (  51 122 ) resistor r=23.615 //w=0.187 //l=0.345 //layer=li \
 //thickness=0.1 //x=23.92 //y=5.56 //x2=23.92 //y2=5.905
r313 (  43 45 ) resistor r=0.10734 //w=0.281 //l=0.16 //layer=m2 \
 //thickness=0.36 //x=25.44 //y=3.51 //x2=25.28 //y2=3.51
r314 (  42 48 ) resistor r=0.10734 //w=0.281 //l=0.16 //layer=m2 \
 //thickness=0.36 //x=26.595 //y=3.51 //x2=26.755 //y2=3.51
r315 (  42 43 ) resistor r=1.1021 //w=0.131 //l=1.155 //layer=m2 \
 //thickness=0.36 //x=26.595 //y=3.51 //x2=25.44 //y2=3.51
r316 (  41 85 ) resistor r=9.3 //w=0.17 //l=0.17 //layer=mcon //count=1 \
 //x=26.76 //y=4.88 //x2=26.76 //y2=4.88
r317 (  38 76 ) resistor r=9.3 //w=0.17 //l=0.17 //layer=mcon //count=1 \
 //x=26.76 //y=2.265 //x2=26.76 //y2=2.265
r318 (  35 48 ) resistor r=4.5 //w=0.15 //l=0.15 //layer=via1 //count=1 \
 //x=26.755 //y=3.51 //x2=26.755 //y2=3.51
r319 (  32 45 ) resistor r=4.5 //w=0.15 //l=0.15 //layer=via1 //count=1 \
 //x=25.28 //y=3.51 //x2=25.28 //y2=3.51
r320 (  29 120 ) resistor r=9.3 //w=0.17 //l=0.17 //layer=mcon //count=1 \
 //x=24.84 //y=1.18 //x2=24.84 //y2=1.18
r321 (  27 59 ) resistor r=9.3 //w=0.17 //l=0.17 //layer=mcon //count=1 \
 //x=24.8 //y=5.56 //x2=24.8 //y2=5.56
r322 (  24 27 ) resistor r=0.117801 //w=0.191 //l=0.18 //layer=m1 \
 //thickness=0.36 //x=24.8 //y=5.38 //x2=24.8 //y2=5.56
r323 (  23 51 ) resistor r=9.3 //w=0.17 //l=0.17 //layer=mcon //count=1 \
 //x=23.92 //y=5.56 //x2=23.92 //y2=5.56
r324 (  21 23 ) resistor r=0.10274 //w=0.219 //l=0.18 //layer=m1 \
 //thickness=0.36 //x=23.92 //y=5.38 //x2=23.92 //y2=5.56
r325 (  20 41 ) resistor r=0.0732479 //w=0.241 //l=0.122474 //layer=m1 \
 //thickness=0.36 //x=26.76 //y=4.76 //x2=26.765 //y2=4.88
r326 (  19 35 ) resistor r=0.0910802 //w=0.374 //l=0.185472 //layer=m1 \
 //thickness=0.36 //x=26.76 //y=3.67 //x2=26.705 //y2=3.51
r327 (  19 20 ) resistor r=1.04008 //w=0.131 //l=1.09 //layer=m1 \
 //thickness=0.36 //x=26.76 //y=3.67 //x2=26.76 //y2=4.76
r328 (  18 35 ) resistor r=0.0910802 //w=0.374 //l=0.185472 //layer=m1 \
 //thickness=0.36 //x=26.76 //y=3.35 //x2=26.705 //y2=3.51
r329 (  17 38 ) resistor r=0.116051 //w=0.211 //l=0.165 //layer=m1 \
 //thickness=0.36 //x=26.76 //y=2.43 //x2=26.76 //y2=2.265
r330 (  17 18 ) resistor r=0.877863 //w=0.131 //l=0.92 //layer=m1 \
 //thickness=0.36 //x=26.76 //y=2.43 //x2=26.76 //y2=3.35
r331 (  15 32 ) resistor r=0.0911593 //w=0.376 //l=0.184174 //layer=m1 \
 //thickness=0.36 //x=25.28 //y=3.67 //x2=25.332 //y2=3.51
r332 (  15 16 ) resistor r=1.55057 //w=0.131 //l=1.625 //layer=m1 \
 //thickness=0.36 //x=25.28 //y=3.67 //x2=25.28 //y2=5.295
r333 (  14 32 ) resistor r=0.0911593 //w=0.376 //l=0.184174 //layer=m1 \
 //thickness=0.36 //x=25.28 //y=3.35 //x2=25.332 //y2=3.51
r334 (  13 14 ) resistor r=1.3645 //w=0.131 //l=1.43 //layer=m1 \
 //thickness=0.36 //x=25.28 //y=1.92 //x2=25.28 //y2=3.35
r335 (  11 13 ) resistor r=0.0698411 //w=0.17 //l=0.120208 //layer=m1 \
 //thickness=0.36 //x=25.195 //y=1.835 //x2=25.28 //y2=1.92
r336 (  11 12 ) resistor r=0.257634 //w=0.131 //l=0.27 //layer=m1 \
 //thickness=0.36 //x=25.195 //y=1.835 //x2=24.925 //y2=1.835
r337 (  10 24 ) resistor r=0.0257089 //w=0.23 //l=0.115 //layer=m1 \
 //thickness=0.36 //x=24.915 //y=5.38 //x2=24.8 //y2=5.38
r338 (  9 16 ) resistor r=0.0698411 //w=0.17 //l=0.120208 //layer=m1 \
 //thickness=0.36 //x=25.195 //y=5.38 //x2=25.28 //y2=5.295
r339 (  9 10 ) resistor r=0.267176 //w=0.131 //l=0.28 //layer=m1 \
 //thickness=0.36 //x=25.195 //y=5.38 //x2=24.915 //y2=5.38
r340 (  8 12 ) resistor r=0.0698411 //w=0.17 //l=0.120208 //layer=m1 \
 //thickness=0.36 //x=24.84 //y=1.75 //x2=24.925 //y2=1.835
r341 (  7 29 ) resistor r=0.0913624 //w=0.191 //l=0.12 //layer=m1 \
 //thickness=0.36 //x=24.84 //y=1.3 //x2=24.84 //y2=1.18
r342 (  7 8 ) resistor r=0.429389 //w=0.131 //l=0.45 //layer=m1 \
 //thickness=0.36 //x=24.84 //y=1.3 //x2=24.84 //y2=1.75
r343 (  4 21 ) resistor r=0.0227762 //w=0.219 //l=0.115 //layer=m1 \
 //thickness=0.36 //x=24.035 //y=5.38 //x2=23.92 //y2=5.38
r344 (  3 24 ) resistor r=0.0257089 //w=0.23 //l=0.115 //layer=m1 \
 //thickness=0.36 //x=24.685 //y=5.38 //x2=24.8 //y2=5.38
r345 (  3 4 ) resistor r=0.620229 //w=0.131 //l=0.65 //layer=m1 \
 //thickness=0.36 //x=24.685 //y=5.38 //x2=24.035 //y2=5.38
ends PM_FA\%noxref_10

subckt PM_FA\%noxref_11 ( 3 8 9 11 12 14 15 16 18 19 20 23 24 27 29 32 35 38 \
 42 43 48 51 59 76 85 89 90 91 92 93 94 95 99 100 101 103 109 110 112 120 122 \
 123 )
c249 ( 120 0 ) capacitor c=0.00878249f //x=30.2 //y=1.085
c250 ( 112 0 ) capacitor c=0.0545922f //x=32.31 //y=2.265
c251 ( 110 0 ) capacitor c=0.0439576f //x=32.95 //y=1.435
c252 ( 109 0 ) capacitor c=0.0201087f //x=32.95 //y=1.09
c253 ( 103 0 ) capacitor c=0.0161986f //x=32.795 //y=1.59
c254 ( 101 0 ) capacitor c=0.0157807f //x=32.795 //y=0.935
c255 ( 100 0 ) capacitor c=0.055513f //x=32.54 //y=4.97
c256 ( 99 0 ) capacitor c=0.0406753f //x=32.83 //y=4.97
c257 ( 95 0 ) capacitor c=0.0301471f //x=32.42 //y=2.1
c258 ( 94 0 ) capacitor c=0.0255349f //x=32.42 //y=1.745
c259 ( 93 0 ) capacitor c=0.0234346f //x=32.42 //y=1.435
c260 ( 92 0 ) capacitor c=0.02013f //x=32.42 //y=1.09
c261 ( 91 0 ) capacitor c=0.153927f //x=32.905 //y=6.2
c262 ( 90 0 ) capacitor c=0.154397f //x=32.465 //y=6.2
c263 ( 85 0 ) capacitor c=9.4527e-19 //x=32.31 //y=4.88
c264 ( 76 0 ) capacitor c=9.11699e-19 //x=32.31 //y=2.265
c265 ( 59 0 ) capacitor c=0.0325662f //x=30.35 //y=5.56
c266 ( 51 0 ) capacitor c=0.0291726f //x=29.47 //y=5.56
c267 ( 48 0 ) capacitor c=0.00203029f //x=32.305 //y=3.51
c268 ( 43 0 ) capacitor c=0.00298232f //x=30.99 //y=3.51
c269 ( 42 0 ) capacitor c=0.0374823f //x=32.145 //y=3.51
c270 ( 38 0 ) capacitor c=0.00754811f //x=32.31 //y=2.265
c271 ( 35 0 ) capacitor c=0.0142574f //x=32.305 //y=3.51
c272 ( 32 0 ) capacitor c=0.0166071f //x=30.83 //y=3.51
c273 ( 29 0 ) capacitor c=0.0114052f //x=30.39 //y=1.18
c274 ( 27 0 ) capacitor c=7.81299e-19 //x=30.35 //y=5.56
c275 ( 24 0 ) capacitor c=0.0124043f //x=30.35 //y=5.38
c276 ( 23 0 ) capacitor c=0.00931929f //x=29.47 //y=5.56
c277 ( 20 0 ) capacitor c=0.0342316f //x=32.31 //y=4.76
c278 ( 19 0 ) capacitor c=0.0113859f //x=32.31 //y=3.67
c279 ( 18 0 ) capacitor c=0.0215674f //x=32.31 //y=3.35
c280 ( 16 0 ) capacitor c=0.0421201f //x=30.83 //y=5.295
c281 ( 15 0 ) capacitor c=0.0116283f //x=30.83 //y=3.67
c282 ( 14 0 ) capacitor c=0.0328048f //x=30.83 //y=3.35
c283 ( 12 0 ) capacitor c=0.00628231f //x=30.475 //y=1.835
c284 ( 11 0 ) capacitor c=0.0132448f //x=30.745 //y=1.835
c285 ( 9 0 ) capacitor c=0.0121041f //x=30.745 //y=5.38
c286 ( 8 0 ) capacitor c=0.0090797f //x=30.39 //y=1.75
c287 ( 3 0 ) capacitor c=0.0189115f //x=30.235 //y=5.38
r288 (  112 113 ) resistor r=17.5563 //w=0.302 //l=0.11 //layer=ply \
 //thickness=0.18 //x=32.31 //y=2.265 //x2=32.42 //y2=2.265
r289 (  110 119 ) resistor r=45.1352 //w=0.168 //l=0.173853 //layer=ply \
 //thickness=0.18 //x=32.95 //y=1.435 //x2=32.91 //y2=1.59
r290 (  109 118 ) resistor r=45.1352 //w=0.168 //l=0.173853 //layer=ply \
 //thickness=0.18 //x=32.95 //y=1.09 //x2=32.91 //y2=0.935
r291 (  109 110 ) resistor r=176.904 //w=0.094 //l=0.345 //layer=ply \
 //thickness=0.18 //x=32.95 //y=1.09 //x2=32.95 //y2=1.435
r292 (  104 117 ) resistor r=10.701 //w=0.21 //l=0.115 //layer=ply \
 //thickness=0.18 //x=32.575 //y=1.59 //x2=32.46 //y2=1.59
r293 (  103 119 ) resistor r=5.52526 //w=0.168 //l=0.115 //layer=ply \
 //thickness=0.18 //x=32.795 //y=1.59 //x2=32.91 //y2=1.59
r294 (  102 116 ) resistor r=5.52526 //w=0.168 //l=0.115 //layer=ply \
 //thickness=0.18 //x=32.575 //y=0.935 //x2=32.46 //y2=0.935
r295 (  101 118 ) resistor r=5.52526 //w=0.168 //l=0.115 //layer=ply \
 //thickness=0.18 //x=32.795 //y=0.935 //x2=32.91 //y2=0.935
r296 (  101 102 ) resistor r=112.809 //w=0.094 //l=0.22 //layer=ply \
 //thickness=0.18 //x=32.795 //y=0.935 //x2=32.575 //y2=0.935
r297 (  99 106 ) resistor r=26.9307 //w=0.15 //l=0.106066 //layer=ply \
 //thickness=0.18 //x=32.83 //y=4.97 //x2=32.905 //y2=5.045
r298 (  99 100 ) resistor r=148.702 //w=0.094 //l=0.29 //layer=ply \
 //thickness=0.18 //x=32.83 //y=4.97 //x2=32.54 //y2=4.97
r299 (  96 100 ) resistor r=23.403 //w=0.284 //l=0.106066 //layer=ply \
 //thickness=0.18 //x=32.465 //y=5.045 //x2=32.54 //y2=4.97
r300 (  96 115 ) resistor r=26.3063 //w=0.284 //l=0.229783 //layer=ply \
 //thickness=0.18 //x=32.465 //y=5.045 //x2=32.31 //y2=4.88
r301 (  95 113 ) resistor r=19.1248 //w=0.302 //l=0.165 //layer=ply \
 //thickness=0.18 //x=32.42 //y=2.1 //x2=32.42 //y2=2.265
r302 (  94 117 ) resistor r=39.5823 //w=0.21 //l=0.173853 //layer=ply \
 //thickness=0.18 //x=32.42 //y=1.745 //x2=32.46 //y2=1.59
r303 (  94 95 ) resistor r=182.032 //w=0.094 //l=0.355 //layer=ply \
 //thickness=0.18 //x=32.42 //y=1.745 //x2=32.42 //y2=2.1
r304 (  93 117 ) resistor r=39.5823 //w=0.21 //l=0.173853 //layer=ply \
 //thickness=0.18 //x=32.42 //y=1.435 //x2=32.46 //y2=1.59
r305 (  92 116 ) resistor r=45.1352 //w=0.168 //l=0.173853 //layer=ply \
 //thickness=0.18 //x=32.42 //y=1.09 //x2=32.46 //y2=0.935
r306 (  92 93 ) resistor r=176.904 //w=0.094 //l=0.345 //layer=ply \
 //thickness=0.18 //x=32.42 //y=1.09 //x2=32.42 //y2=1.435
r307 (  91 106 ) resistor r=592.245 //w=0.094 //l=1.155 //layer=ply \
 //thickness=0.18 //x=32.905 //y=6.2 //x2=32.905 //y2=5.045
r308 (  90 96 ) resistor r=592.245 //w=0.094 //l=1.155 //layer=ply \
 //thickness=0.18 //x=32.465 //y=6.2 //x2=32.465 //y2=5.045
r309 (  89 103 ) resistor r=56.4043 //w=0.094 //l=0.11 //layer=ply \
 //thickness=0.18 //x=32.685 //y=1.59 //x2=32.795 //y2=1.59
r310 (  89 104 ) resistor r=56.4043 //w=0.094 //l=0.11 //layer=ply \
 //thickness=0.18 //x=32.685 //y=1.59 //x2=32.575 //y2=1.59
r311 (  85 115 ) resistor r=152 //w=0.17 //l=0.17 //layer=licon //count=1 \
 //x=32.31 //y=4.88 //x2=32.31 //y2=4.88
r312 (  76 112 ) resistor r=152 //w=0.17 //l=0.17 //layer=licon //count=1 \
 //x=32.31 //y=2.265 //x2=32.31 //y2=2.265
r313 (  59 123 ) resistor r=23.615 //w=0.187 //l=0.345 //layer=li \
 //thickness=0.1 //x=30.35 //y=5.56 //x2=30.35 //y2=5.905
r314 (  51 122 ) resistor r=23.615 //w=0.187 //l=0.345 //layer=li \
 //thickness=0.1 //x=29.47 //y=5.56 //x2=29.47 //y2=5.905
r315 (  43 45 ) resistor r=0.10734 //w=0.281 //l=0.16 //layer=m2 \
 //thickness=0.36 //x=30.99 //y=3.51 //x2=30.83 //y2=3.51
r316 (  42 48 ) resistor r=0.10734 //w=0.281 //l=0.16 //layer=m2 \
 //thickness=0.36 //x=32.145 //y=3.51 //x2=32.305 //y2=3.51
r317 (  42 43 ) resistor r=1.1021 //w=0.131 //l=1.155 //layer=m2 \
 //thickness=0.36 //x=32.145 //y=3.51 //x2=30.99 //y2=3.51
r318 (  41 85 ) resistor r=9.3 //w=0.17 //l=0.17 //layer=mcon //count=1 \
 //x=32.31 //y=4.88 //x2=32.31 //y2=4.88
r319 (  38 76 ) resistor r=9.3 //w=0.17 //l=0.17 //layer=mcon //count=1 \
 //x=32.31 //y=2.265 //x2=32.31 //y2=2.265
r320 (  35 48 ) resistor r=4.5 //w=0.15 //l=0.15 //layer=via1 //count=1 \
 //x=32.305 //y=3.51 //x2=32.305 //y2=3.51
r321 (  32 45 ) resistor r=4.5 //w=0.15 //l=0.15 //layer=via1 //count=1 \
 //x=30.83 //y=3.51 //x2=30.83 //y2=3.51
r322 (  29 120 ) resistor r=9.3 //w=0.17 //l=0.17 //layer=mcon //count=1 \
 //x=30.39 //y=1.18 //x2=30.39 //y2=1.18
r323 (  27 59 ) resistor r=9.3 //w=0.17 //l=0.17 //layer=mcon //count=1 \
 //x=30.35 //y=5.56 //x2=30.35 //y2=5.56
r324 (  24 27 ) resistor r=0.117801 //w=0.191 //l=0.18 //layer=m1 \
 //thickness=0.36 //x=30.35 //y=5.38 //x2=30.35 //y2=5.56
r325 (  23 51 ) resistor r=9.3 //w=0.17 //l=0.17 //layer=mcon //count=1 \
 //x=29.47 //y=5.56 //x2=29.47 //y2=5.56
r326 (  21 23 ) resistor r=0.10274 //w=0.219 //l=0.18 //layer=m1 \
 //thickness=0.36 //x=29.47 //y=5.38 //x2=29.47 //y2=5.56
r327 (  20 41 ) resistor r=0.0732479 //w=0.241 //l=0.122474 //layer=m1 \
 //thickness=0.36 //x=32.31 //y=4.76 //x2=32.315 //y2=4.88
r328 (  19 35 ) resistor r=0.0910802 //w=0.374 //l=0.185472 //layer=m1 \
 //thickness=0.36 //x=32.31 //y=3.67 //x2=32.255 //y2=3.51
r329 (  19 20 ) resistor r=1.04008 //w=0.131 //l=1.09 //layer=m1 \
 //thickness=0.36 //x=32.31 //y=3.67 //x2=32.31 //y2=4.76
r330 (  18 35 ) resistor r=0.0910802 //w=0.374 //l=0.185472 //layer=m1 \
 //thickness=0.36 //x=32.31 //y=3.35 //x2=32.255 //y2=3.51
r331 (  17 38 ) resistor r=0.116051 //w=0.211 //l=0.165 //layer=m1 \
 //thickness=0.36 //x=32.31 //y=2.43 //x2=32.31 //y2=2.265
r332 (  17 18 ) resistor r=0.877863 //w=0.131 //l=0.92 //layer=m1 \
 //thickness=0.36 //x=32.31 //y=2.43 //x2=32.31 //y2=3.35
r333 (  15 32 ) resistor r=0.0911593 //w=0.376 //l=0.184174 //layer=m1 \
 //thickness=0.36 //x=30.83 //y=3.67 //x2=30.882 //y2=3.51
r334 (  15 16 ) resistor r=1.55057 //w=0.131 //l=1.625 //layer=m1 \
 //thickness=0.36 //x=30.83 //y=3.67 //x2=30.83 //y2=5.295
r335 (  14 32 ) resistor r=0.0911593 //w=0.376 //l=0.184174 //layer=m1 \
 //thickness=0.36 //x=30.83 //y=3.35 //x2=30.882 //y2=3.51
r336 (  13 14 ) resistor r=1.3645 //w=0.131 //l=1.43 //layer=m1 \
 //thickness=0.36 //x=30.83 //y=1.92 //x2=30.83 //y2=3.35
r337 (  11 13 ) resistor r=0.0698411 //w=0.17 //l=0.120208 //layer=m1 \
 //thickness=0.36 //x=30.745 //y=1.835 //x2=30.83 //y2=1.92
r338 (  11 12 ) resistor r=0.257634 //w=0.131 //l=0.27 //layer=m1 \
 //thickness=0.36 //x=30.745 //y=1.835 //x2=30.475 //y2=1.835
r339 (  10 24 ) resistor r=0.0257089 //w=0.23 //l=0.115 //layer=m1 \
 //thickness=0.36 //x=30.465 //y=5.38 //x2=30.35 //y2=5.38
r340 (  9 16 ) resistor r=0.0698411 //w=0.17 //l=0.120208 //layer=m1 \
 //thickness=0.36 //x=30.745 //y=5.38 //x2=30.83 //y2=5.295
r341 (  9 10 ) resistor r=0.267176 //w=0.131 //l=0.28 //layer=m1 \
 //thickness=0.36 //x=30.745 //y=5.38 //x2=30.465 //y2=5.38
r342 (  8 12 ) resistor r=0.0698411 //w=0.17 //l=0.120208 //layer=m1 \
 //thickness=0.36 //x=30.39 //y=1.75 //x2=30.475 //y2=1.835
r343 (  7 29 ) resistor r=0.0913624 //w=0.191 //l=0.12 //layer=m1 \
 //thickness=0.36 //x=30.39 //y=1.3 //x2=30.39 //y2=1.18
r344 (  7 8 ) resistor r=0.429389 //w=0.131 //l=0.45 //layer=m1 \
 //thickness=0.36 //x=30.39 //y=1.3 //x2=30.39 //y2=1.75
r345 (  4 21 ) resistor r=0.0227762 //w=0.219 //l=0.115 //layer=m1 \
 //thickness=0.36 //x=29.585 //y=5.38 //x2=29.47 //y2=5.38
r346 (  3 24 ) resistor r=0.0257089 //w=0.23 //l=0.115 //layer=m1 \
 //thickness=0.36 //x=30.235 //y=5.38 //x2=30.35 //y2=5.38
r347 (  3 4 ) resistor r=0.620229 //w=0.131 //l=0.65 //layer=m1 \
 //thickness=0.36 //x=30.235 //y=5.38 //x2=29.585 //y2=5.38
ends PM_FA\%noxref_11

subckt PM_FA\%noxref_12 ( 2 4 5 6 7 8 10 11 12 14 15 16 18 23 29 31 35 37 39 \
 41 43 45 50 59 71 76 84 85 86 87 88 89 90 94 96 99 101 102 107 117 119 )
c302 ( 117 0 ) capacitor c=0.00849916f //x=26.945 //y=1.09
c303 ( 107 0 ) capacitor c=0.0427047f //x=34.745 //y=4.885
c304 ( 102 0 ) capacitor c=0.0337825f //x=35.235 //y=1.43
c305 ( 101 0 ) capacitor c=0.0183823f //x=35.235 //y=1.085
c306 ( 99 0 ) capacitor c=0.0350928f //x=35.165 //y=4.975
c307 ( 96 0 ) capacitor c=0.013578f //x=35.08 //y=1.585
c308 ( 94 0 ) capacitor c=0.0157803f //x=35.08 //y=0.93
c309 ( 90 0 ) capacitor c=0.079037f //x=34.705 //y=2.095
c310 ( 89 0 ) capacitor c=0.0230165f //x=34.705 //y=1.74
c311 ( 88 0 ) capacitor c=0.0234348f //x=34.705 //y=1.43
c312 ( 87 0 ) capacitor c=0.019134f //x=34.705 //y=1.085
c313 ( 86 0 ) capacitor c=0.110994f //x=35.24 //y=6.205
c314 ( 85 0 ) capacitor c=0.154777f //x=34.8 //y=6.205
c315 ( 76 0 ) capacitor c=4.74639e-19 //x=34.9 //y=2.26
c316 ( 71 0 ) capacitor c=0.0070524f //x=34.745 //y=4.885
c317 ( 59 0 ) capacitor c=0.0261756f //x=27.135 //y=5.56
c318 ( 50 0 ) capacitor c=7.8817e-19 //x=27.66 //y=3.15
c319 ( 45 0 ) capacitor c=0.0607979f //x=33.26 //y=3.125
c320 ( 43 0 ) capacitor c=0.0232261f //x=32.52 //y=3.125
c321 ( 41 0 ) capacitor c=0.0260387f //x=31.92 //y=3.14
c322 ( 39 0 ) capacitor c=0.0196339f //x=31.045 //y=3.125
c323 ( 37 0 ) capacitor c=0.0869661f //x=30.445 //y=3.14
c324 ( 35 0 ) capacitor c=0.00991214f //x=34.745 //y=4.885
c325 ( 31 0 ) capacitor c=0.00645756f //x=34.9 //y=2.26
c326 ( 29 0 ) capacitor c=0.0148568f //x=34.9 //y=3.14
c327 ( 23 0 ) capacitor c=0.0159592f //x=27.5 //y=3.14
c328 ( 18 0 ) capacitor c=0.0151067f //x=27.13 //y=1.185
c329 ( 16 0 ) capacitor c=0.0437937f //x=34.9 //y=4.765
c330 ( 15 0 ) capacitor c=0.0116191f //x=34.9 //y=3.285
c331 ( 14 0 ) capacitor c=0.0142334f //x=34.9 //y=2.965
c332 ( 12 0 ) capacitor c=0.0470123f //x=27.5 //y=5.055
c333 ( 11 0 ) capacitor c=0.013616f //x=27.5 //y=3.31
c334 ( 10 0 ) capacitor c=0.01874f //x=27.5 //y=2.99
c335 ( 8 0 ) capacitor c=0.00434076f //x=27.22 //y=5.14
c336 ( 7 0 ) capacitor c=0.00564223f //x=27.415 //y=5.14
c337 ( 6 0 ) capacitor c=0.00541265f //x=27.215 //y=2.02
c338 ( 5 0 ) capacitor c=0.0103468f //x=27.415 //y=2.02
c339 ( 4 0 ) capacitor c=0.0102877f //x=27.135 //y=5.42
c340 ( 2 0 ) capacitor c=0.0122563f //x=27.13 //y=1.935
r341 (  109 110 ) resistor r=32.4568 //w=0.214 //l=0.075 //layer=ply \
 //thickness=0.18 //x=34.745 //y=4.975 //x2=34.745 //y2=5.05
r342 (  107 109 ) resistor r=20.271 //w=0.214 //l=0.09 //layer=ply \
 //thickness=0.18 //x=34.745 //y=4.885 //x2=34.745 //y2=4.975
r343 (  102 116 ) resistor r=45.1352 //w=0.168 //l=0.173853 //layer=ply \
 //thickness=0.18 //x=35.235 //y=1.43 //x2=35.195 //y2=1.585
r344 (  101 115 ) resistor r=45.1352 //w=0.168 //l=0.173853 //layer=ply \
 //thickness=0.18 //x=35.235 //y=1.085 //x2=35.195 //y2=0.93
r345 (  101 102 ) resistor r=176.904 //w=0.094 //l=0.345 //layer=ply \
 //thickness=0.18 //x=35.235 //y=1.085 //x2=35.235 //y2=1.43
r346 (  100 109 ) resistor r=16.5046 //w=0.27 //l=0.135 //layer=ply \
 //thickness=0.18 //x=34.88 //y=4.975 //x2=34.745 //y2=4.975
r347 (  99 103 ) resistor r=26.9307 //w=0.15 //l=0.106066 //layer=ply \
 //thickness=0.18 //x=35.165 //y=4.975 //x2=35.24 //y2=5.05
r348 (  99 100 ) resistor r=146.138 //w=0.094 //l=0.285 //layer=ply \
 //thickness=0.18 //x=35.165 //y=4.975 //x2=34.88 //y2=4.975
r349 (  97 114 ) resistor r=10.701 //w=0.21 //l=0.115 //layer=ply \
 //thickness=0.18 //x=34.86 //y=1.585 //x2=34.745 //y2=1.585
r350 (  96 116 ) resistor r=5.52526 //w=0.168 //l=0.115 //layer=ply \
 //thickness=0.18 //x=35.08 //y=1.585 //x2=35.195 //y2=1.585
r351 (  95 113 ) resistor r=5.52526 //w=0.168 //l=0.115 //layer=ply \
 //thickness=0.18 //x=34.86 //y=0.93 //x2=34.745 //y2=0.93
r352 (  94 115 ) resistor r=5.52526 //w=0.168 //l=0.115 //layer=ply \
 //thickness=0.18 //x=35.08 //y=0.93 //x2=35.195 //y2=0.93
r353 (  94 95 ) resistor r=112.809 //w=0.094 //l=0.22 //layer=ply \
 //thickness=0.18 //x=35.08 //y=0.93 //x2=34.86 //y2=0.93
r354 (  90 112 ) resistor r=34.8111 //w=0.27 //l=0.264953 //layer=ply \
 //thickness=0.18 //x=34.705 //y=2.095 //x2=34.9 //y2=2.26
r355 (  89 114 ) resistor r=39.5823 //w=0.21 //l=0.173853 //layer=ply \
 //thickness=0.18 //x=34.705 //y=1.74 //x2=34.745 //y2=1.585
r356 (  89 90 ) resistor r=182.032 //w=0.094 //l=0.355 //layer=ply \
 //thickness=0.18 //x=34.705 //y=1.74 //x2=34.705 //y2=2.095
r357 (  88 114 ) resistor r=39.5823 //w=0.21 //l=0.173853 //layer=ply \
 //thickness=0.18 //x=34.705 //y=1.43 //x2=34.745 //y2=1.585
r358 (  87 113 ) resistor r=45.1352 //w=0.168 //l=0.173853 //layer=ply \
 //thickness=0.18 //x=34.705 //y=1.085 //x2=34.745 //y2=0.93
r359 (  87 88 ) resistor r=176.904 //w=0.094 //l=0.345 //layer=ply \
 //thickness=0.18 //x=34.705 //y=1.085 //x2=34.705 //y2=1.43
r360 (  86 103 ) resistor r=592.245 //w=0.094 //l=1.155 //layer=ply \
 //thickness=0.18 //x=35.24 //y=6.205 //x2=35.24 //y2=5.05
r361 (  85 110 ) resistor r=592.245 //w=0.094 //l=1.155 //layer=ply \
 //thickness=0.18 //x=34.8 //y=6.205 //x2=34.8 //y2=5.05
r362 (  84 96 ) resistor r=56.4043 //w=0.094 //l=0.11 //layer=ply \
 //thickness=0.18 //x=34.97 //y=1.585 //x2=35.08 //y2=1.585
r363 (  84 97 ) resistor r=56.4043 //w=0.094 //l=0.11 //layer=ply \
 //thickness=0.18 //x=34.97 //y=1.585 //x2=34.86 //y2=1.585
r364 (  76 112 ) resistor r=152 //w=0.17 //l=0.17 //layer=licon //count=1 \
 //x=34.9 //y=2.26 //x2=34.9 //y2=2.26
r365 (  71 107 ) resistor r=152 //w=0.17 //l=0.17 //layer=licon //count=1 \
 //x=34.745 //y=4.885 //x2=34.745 //y2=4.885
r366 (  59 119 ) resistor r=23.615 //w=0.187 //l=0.345 //layer=li \
 //thickness=0.1 //x=27.135 //y=5.56 //x2=27.135 //y2=5.905
r367 (  48 50 ) resistor r=0.10734 //w=0.281 //l=0.16 //layer=m2 \
 //thickness=0.36 //x=27.5 //y=3.15 //x2=27.66 //y2=3.15
r368 (  45 52 ) resistor r=1.04013 //w=0.197 //l=1.635 //layer=m2 \
 //thickness=0.36 //x=33.26 //y=3.125 //x2=34.895 //y2=3.125
r369 (  45 46 ) resistor r=0.410305 //w=0.131 //l=0.43 //layer=m2 \
 //thickness=0.36 //x=33.26 //y=3.125 //x2=32.83 //y2=3.125
r370 (  43 46 ) resistor r=0.227941 //w=0.17 //l=0.31 //layer=m2 \
 //thickness=0.36 //x=32.52 //y=3.125 //x2=32.83 //y2=3.125
r371 (  43 44 ) resistor r=0.410305 //w=0.131 //l=0.43 //layer=m2 \
 //thickness=0.36 //x=32.52 //y=3.125 //x2=32.09 //y2=3.125
r372 (  41 44 ) resistor r=0.125 //w=0.17 //l=0.177341 //layer=m2 \
 //thickness=0.36 //x=31.92 //y=3.14 //x2=32.09 //y2=3.125
r373 (  41 42 ) resistor r=0.591603 //w=0.131 //l=0.62 //layer=m2 \
 //thickness=0.36 //x=31.92 //y=3.14 //x2=31.3 //y2=3.14
r374 (  39 42 ) resistor r=0.1875 //w=0.17 //l=0.262393 //layer=m2 \
 //thickness=0.36 //x=31.045 //y=3.125 //x2=31.3 //y2=3.14
r375 (  39 40 ) resistor r=0.410305 //w=0.131 //l=0.43 //layer=m2 \
 //thickness=0.36 //x=31.045 //y=3.125 //x2=30.615 //y2=3.125
r376 (  37 40 ) resistor r=0.125 //w=0.17 //l=0.177341 //layer=m2 \
 //thickness=0.36 //x=30.445 //y=3.14 //x2=30.615 //y2=3.125
r377 (  37 50 ) resistor r=2.65744 //w=0.131 //l=2.785 //layer=m2 \
 //thickness=0.36 //x=30.445 //y=3.14 //x2=27.66 //y2=3.14
r378 (  35 71 ) resistor r=9.3 //w=0.17 //l=0.17 //layer=mcon //count=1 \
 //x=34.745 //y=4.885 //x2=34.745 //y2=4.885
r379 (  35 36 ) resistor r=0.0853524 //w=0.227 //l=0.155 //layer=m1 \
 //thickness=0.36 //x=34.745 //y=4.882 //x2=34.9 //y2=4.882
r380 (  31 76 ) resistor r=9.3 //w=0.17 //l=0.17 //layer=mcon //count=1 \
 //x=34.9 //y=2.26 //x2=34.9 //y2=2.26
r381 (  31 33 ) resistor r=0.0985786 //w=0.206 //l=0.135 //layer=m1 \
 //thickness=0.36 //x=34.897 //y=2.26 //x2=34.897 //y2=2.395
r382 (  27 52 ) resistor r=4.5 //w=0.15 //l=0.15 //layer=via1 //count=1 \
 //x=34.895 //y=3.125 //x2=34.895 //y2=3.125
r383 (  27 29 ) resistor r=0.00501337 //w=0.374 //l=0.015 //layer=m1 \
 //thickness=0.36 //x=34.845 //y=3.125 //x2=34.845 //y2=3.14
r384 (  25 48 ) resistor r=4.5 //w=0.15 //l=0.15 //layer=via1 //count=1 \
 //x=27.5 //y=3.15 //x2=27.5 //y2=3.15
r385 (  23 25 ) resistor r=0.00332447 //w=0.376 //l=0.01 //layer=m1 \
 //thickness=0.36 //x=27.552 //y=3.14 //x2=27.552 //y2=3.15
r386 (  21 59 ) resistor r=9.3 //w=0.17 //l=0.17 //layer=mcon //count=1 \
 //x=27.135 //y=5.56 //x2=27.135 //y2=5.56
r387 (  18 117 ) resistor r=9.3 //w=0.17 //l=0.17 //layer=mcon //count=1 \
 //x=27.13 //y=1.185 //x2=27.13 //y2=1.185
r388 (  16 36 ) resistor r=0.0249239 //w=0.227 //l=0.117 //layer=m1 \
 //thickness=0.36 //x=34.9 //y=4.765 //x2=34.9 //y2=4.882
r389 (  15 29 ) resistor r=0.0860668 //w=0.374 //l=0.170294 //layer=m1 \
 //thickness=0.36 //x=34.9 //y=3.285 //x2=34.845 //y2=3.14
r390 (  15 16 ) resistor r=1.41221 //w=0.131 //l=1.48 //layer=m1 \
 //thickness=0.36 //x=34.9 //y=3.285 //x2=34.9 //y2=4.765
r391 (  14 27 ) resistor r=0.0910802 //w=0.374 //l=0.185472 //layer=m1 \
 //thickness=0.36 //x=34.9 //y=2.965 //x2=34.845 //y2=3.125
r392 (  14 33 ) resistor r=0.543893 //w=0.131 //l=0.57 //layer=m1 \
 //thickness=0.36 //x=34.9 //y=2.965 //x2=34.9 //y2=2.395
r393 (  11 25 ) resistor r=0.0911593 //w=0.376 //l=0.184174 //layer=m1 \
 //thickness=0.36 //x=27.5 //y=3.31 //x2=27.552 //y2=3.15
r394 (  11 12 ) resistor r=1.66508 //w=0.131 //l=1.745 //layer=m1 \
 //thickness=0.36 //x=27.5 //y=3.31 //x2=27.5 //y2=5.055
r395 (  10 23 ) resistor r=0.0878349 //w=0.376 //l=0.174069 //layer=m1 \
 //thickness=0.36 //x=27.5 //y=2.99 //x2=27.552 //y2=3.14
r396 (  9 10 ) resistor r=0.844466 //w=0.131 //l=0.885 //layer=m1 \
 //thickness=0.36 //x=27.5 //y=2.105 //x2=27.5 //y2=2.99
r397 (  7 12 ) resistor r=0.0698411 //w=0.17 //l=0.120208 //layer=m1 \
 //thickness=0.36 //x=27.415 //y=5.14 //x2=27.5 //y2=5.055
r398 (  7 8 ) resistor r=0.186069 //w=0.131 //l=0.195 //layer=m1 \
 //thickness=0.36 //x=27.415 //y=5.14 //x2=27.22 //y2=5.14
r399 (  5 9 ) resistor r=0.0698411 //w=0.17 //l=0.120208 //layer=m1 \
 //thickness=0.36 //x=27.415 //y=2.02 //x2=27.5 //y2=2.105
r400 (  5 6 ) resistor r=0.19084 //w=0.131 //l=0.2 //layer=m1 //thickness=0.36 \
 //x=27.415 //y=2.02 //x2=27.215 //y2=2.02
r401 (  4 21 ) resistor r=0.086672 //w=0.218 //l=0.14 //layer=m1 \
 //thickness=0.36 //x=27.135 //y=5.42 //x2=27.135 //y2=5.56
r402 (  3 8 ) resistor r=0.0698411 //w=0.17 //l=0.120208 //layer=m1 \
 //thickness=0.36 //x=27.135 //y=5.225 //x2=27.22 //y2=5.14
r403 (  3 4 ) resistor r=0.186069 //w=0.131 //l=0.195 //layer=m1 \
 //thickness=0.36 //x=27.135 //y=5.225 //x2=27.135 //y2=5.42
r404 (  2 6 ) resistor r=0.0698411 //w=0.17 //l=0.120208 //layer=m1 \
 //thickness=0.36 //x=27.13 //y=1.935 //x2=27.215 //y2=2.02
r405 (  1 18 ) resistor r=0.105739 //w=0.201 //l=0.145 //layer=m1 \
 //thickness=0.36 //x=27.13 //y=1.33 //x2=27.13 //y2=1.185
r406 (  1 2 ) resistor r=0.57729 //w=0.131 //l=0.605 //layer=m1 \
 //thickness=0.36 //x=27.13 //y=1.33 //x2=27.13 //y2=1.935
ends PM_FA\%noxref_12

subckt PM_FA\%noxref_13 ( 2 4 5 6 7 8 10 11 12 14 15 18 23 26 29 33 34 36 37 \
 42 50 62 71 75 76 77 78 79 80 85 87 89 95 96 98 99 102 110 112 )
c254 ( 110 0 ) capacitor c=0.00875839f //x=32.495 //y=1.09
c255 ( 102 0 ) capacitor c=0.0404287f //x=35.675 //y=4.885
c256 ( 99 0 ) capacitor c=0.0292709f //x=35.64 //y=2.095
c257 ( 98 0 ) capacitor c=0.0442677f //x=35.64 //y=2.26
c258 ( 96 0 ) capacitor c=0.0237765f //x=36.205 //y=1.435
c259 ( 95 0 ) capacitor c=0.0191782f //x=36.205 //y=1.085
c260 ( 89 0 ) capacitor c=0.035988f //x=36.05 //y=1.585
c261 ( 87 0 ) capacitor c=0.0157803f //x=36.05 //y=0.93
c262 ( 85 0 ) capacitor c=0.0367203f //x=36.045 //y=4.975
c263 ( 80 0 ) capacitor c=0.0206674f //x=35.675 //y=1.74
c264 ( 79 0 ) capacitor c=0.0169638f //x=35.675 //y=1.435
c265 ( 78 0 ) capacitor c=0.0185462f //x=35.675 //y=1.085
c266 ( 77 0 ) capacitor c=0.155887f //x=36.12 //y=6.205
c267 ( 76 0 ) capacitor c=0.110534f //x=35.68 //y=6.205
c268 ( 71 0 ) capacitor c=0.0011312f //x=35.675 //y=4.885
c269 ( 62 0 ) capacitor c=7.18762e-19 //x=35.64 //y=2.26
c270 ( 50 0 ) capacitor c=0.0261198f //x=32.685 //y=5.56
c271 ( 42 0 ) capacitor c=0.0026672f //x=35.635 //y=3.51
c272 ( 37 0 ) capacitor c=0.0012616f //x=33.205 //y=3.51
c273 ( 36 0 ) capacitor c=0.0667285f //x=35.475 //y=3.51
c274 ( 34 0 ) capacitor c=0.0272421f //x=35.675 //y=4.74
c275 ( 33 0 ) capacitor c=0.00570577f //x=35.675 //y=4.885
c276 ( 29 0 ) capacitor c=0.005072f //x=35.64 //y=2.26
c277 ( 26 0 ) capacitor c=0.0142007f //x=35.635 //y=3.51
c278 ( 23 0 ) capacitor c=0.0156794f //x=33.045 //y=3.51
c279 ( 18 0 ) capacitor c=0.015273f //x=32.68 //y=1.185
c280 ( 15 0 ) capacitor c=0.00936174f //x=35.64 //y=3.67
c281 ( 14 0 ) capacitor c=0.0196773f //x=35.64 //y=3.35
c282 ( 12 0 ) capacitor c=0.0371808f //x=33.05 //y=5.055
c283 ( 11 0 ) capacitor c=0.0121096f //x=33.05 //y=3.67
c284 ( 10 0 ) capacitor c=0.0285886f //x=33.05 //y=3.35
c285 ( 8 0 ) capacitor c=0.00545906f //x=32.77 //y=5.14
c286 ( 7 0 ) capacitor c=0.00774241f //x=32.965 //y=5.14
c287 ( 6 0 ) capacitor c=0.00649675f //x=32.765 //y=2.02
c288 ( 5 0 ) capacitor c=0.0120297f //x=32.965 //y=2.02
c289 ( 4 0 ) capacitor c=0.0108114f //x=32.685 //y=5.42
c290 ( 2 0 ) capacitor c=0.0111267f //x=32.68 //y=1.935
r291 (  104 105 ) resistor r=32.4568 //w=0.214 //l=0.075 //layer=ply \
 //thickness=0.18 //x=35.675 //y=4.975 //x2=35.675 //y2=5.05
r292 (  102 104 ) resistor r=20.271 //w=0.214 //l=0.09 //layer=ply \
 //thickness=0.18 //x=35.675 //y=4.885 //x2=35.675 //y2=4.975
r293 (  98 99 ) resistor r=52.7279 //w=0.214 //l=0.165 //layer=ply \
 //thickness=0.18 //x=35.64 //y=2.26 //x2=35.64 //y2=2.095
r294 (  96 109 ) resistor r=4.95774 //w=0.164 //l=0.112 //layer=ply \
 //thickness=0.18 //x=36.205 //y=1.435 //x2=36.205 //y2=1.547
r295 (  95 108 ) resistor r=45.1352 //w=0.168 //l=0.173853 //layer=ply \
 //thickness=0.18 //x=36.205 //y=1.085 //x2=36.165 //y2=0.93
r296 (  95 96 ) resistor r=179.468 //w=0.094 //l=0.35 //layer=ply \
 //thickness=0.18 //x=36.205 //y=1.085 //x2=36.205 //y2=1.435
r297 (  90 107 ) resistor r=10.8103 //w=0.211 //l=0.115 //layer=ply \
 //thickness=0.18 //x=35.83 //y=1.585 //x2=35.715 //y2=1.585
r298 (  89 109 ) resistor r=45.9962 //w=0.164 //l=0.17296 //layer=ply \
 //thickness=0.18 //x=36.05 //y=1.585 //x2=36.205 //y2=1.547
r299 (  88 106 ) resistor r=5.52526 //w=0.168 //l=0.115 //layer=ply \
 //thickness=0.18 //x=35.83 //y=0.93 //x2=35.715 //y2=0.93
r300 (  87 108 ) resistor r=5.52526 //w=0.168 //l=0.115 //layer=ply \
 //thickness=0.18 //x=36.05 //y=0.93 //x2=36.165 //y2=0.93
r301 (  87 88 ) resistor r=112.809 //w=0.094 //l=0.22 //layer=ply \
 //thickness=0.18 //x=36.05 //y=0.93 //x2=35.83 //y2=0.93
r302 (  86 104 ) resistor r=16.5046 //w=0.27 //l=0.135 //layer=ply \
 //thickness=0.18 //x=35.81 //y=4.975 //x2=35.675 //y2=4.975
r303 (  85 92 ) resistor r=26.9307 //w=0.15 //l=0.106066 //layer=ply \
 //thickness=0.18 //x=36.045 //y=4.975 //x2=36.12 //y2=5.05
r304 (  85 86 ) resistor r=120.5 //w=0.094 //l=0.235 //layer=ply \
 //thickness=0.18 //x=36.045 //y=4.975 //x2=35.81 //y2=4.975
r305 (  80 107 ) resistor r=39.5036 //w=0.211 //l=0.173853 //layer=ply \
 //thickness=0.18 //x=35.675 //y=1.74 //x2=35.715 //y2=1.585
r306 (  80 99 ) resistor r=182.032 //w=0.094 //l=0.355 //layer=ply \
 //thickness=0.18 //x=35.675 //y=1.74 //x2=35.675 //y2=2.095
r307 (  79 107 ) resistor r=38.3614 //w=0.211 //l=0.168819 //layer=ply \
 //thickness=0.18 //x=35.675 //y=1.435 //x2=35.715 //y2=1.585
r308 (  78 106 ) resistor r=45.1352 //w=0.168 //l=0.173853 //layer=ply \
 //thickness=0.18 //x=35.675 //y=1.085 //x2=35.715 //y2=0.93
r309 (  78 79 ) resistor r=179.468 //w=0.094 //l=0.35 //layer=ply \
 //thickness=0.18 //x=35.675 //y=1.085 //x2=35.675 //y2=1.435
r310 (  77 92 ) resistor r=592.245 //w=0.094 //l=1.155 //layer=ply \
 //thickness=0.18 //x=36.12 //y=6.205 //x2=36.12 //y2=5.05
r311 (  76 105 ) resistor r=592.245 //w=0.094 //l=1.155 //layer=ply \
 //thickness=0.18 //x=35.68 //y=6.205 //x2=35.68 //y2=5.05
r312 (  75 89 ) resistor r=56.4043 //w=0.094 //l=0.11 //layer=ply \
 //thickness=0.18 //x=35.94 //y=1.585 //x2=36.05 //y2=1.585
r313 (  75 90 ) resistor r=56.4043 //w=0.094 //l=0.11 //layer=ply \
 //thickness=0.18 //x=35.94 //y=1.585 //x2=35.83 //y2=1.585
r314 (  71 102 ) resistor r=152 //w=0.17 //l=0.17 //layer=licon //count=1 \
 //x=35.675 //y=4.885 //x2=35.675 //y2=4.885
r315 (  62 98 ) resistor r=152 //w=0.17 //l=0.17 //layer=licon //count=1 \
 //x=35.64 //y=2.26 //x2=35.64 //y2=2.26
r316 (  50 112 ) resistor r=23.615 //w=0.187 //l=0.345 //layer=li \
 //thickness=0.1 //x=32.685 //y=5.56 //x2=32.685 //y2=5.905
r317 (  37 39 ) resistor r=0.10734 //w=0.281 //l=0.16 //layer=m2 \
 //thickness=0.36 //x=33.205 //y=3.51 //x2=33.045 //y2=3.51
r318 (  36 42 ) resistor r=0.10734 //w=0.281 //l=0.16 //layer=m2 \
 //thickness=0.36 //x=35.475 //y=3.51 //x2=35.635 //y2=3.51
r319 (  36 37 ) resistor r=2.16603 //w=0.131 //l=2.27 //layer=m2 \
 //thickness=0.36 //x=35.475 //y=3.51 //x2=33.205 //y2=3.51
r320 (  33 71 ) resistor r=9.3 //w=0.17 //l=0.17 //layer=mcon //count=1 \
 //x=35.675 //y=4.885 //x2=35.675 //y2=4.885
r321 (  33 34 ) resistor r=0.105739 //w=0.201 //l=0.145 //layer=m1 \
 //thickness=0.36 //x=35.675 //y=4.885 //x2=35.675 //y2=4.74
r322 (  29 62 ) resistor r=9.3 //w=0.17 //l=0.17 //layer=mcon //count=1 \
 //x=35.64 //y=2.26 //x2=35.64 //y2=2.26
r323 (  29 31 ) resistor r=0.0977888 //w=0.216 //l=0.135 //layer=m1 \
 //thickness=0.36 //x=35.637 //y=2.26 //x2=35.637 //y2=2.395
r324 (  26 42 ) resistor r=4.5 //w=0.15 //l=0.15 //layer=via1 //count=1 \
 //x=35.635 //y=3.51 //x2=35.635 //y2=3.51
r325 (  23 39 ) resistor r=4.5 //w=0.15 //l=0.15 //layer=via1 //count=1 \
 //x=33.045 //y=3.51 //x2=33.045 //y2=3.51
r326 (  21 50 ) resistor r=9.3 //w=0.17 //l=0.17 //layer=mcon //count=1 \
 //x=32.685 //y=5.56 //x2=32.685 //y2=5.56
r327 (  18 110 ) resistor r=9.3 //w=0.17 //l=0.17 //layer=mcon //count=1 \
 //x=32.68 //y=1.185 //x2=32.68 //y2=1.185
r328 (  15 26 ) resistor r=0.0910802 //w=0.374 //l=0.185472 //layer=m1 \
 //thickness=0.36 //x=35.64 //y=3.67 //x2=35.585 //y2=3.51
r329 (  15 34 ) resistor r=1.02099 //w=0.131 //l=1.07 //layer=m1 \
 //thickness=0.36 //x=35.64 //y=3.67 //x2=35.64 //y2=4.74
r330 (  14 26 ) resistor r=0.0910802 //w=0.374 //l=0.185472 //layer=m1 \
 //thickness=0.36 //x=35.64 //y=3.35 //x2=35.585 //y2=3.51
r331 (  14 31 ) resistor r=0.91126 //w=0.131 //l=0.955 //layer=m1 \
 //thickness=0.36 //x=35.64 //y=3.35 //x2=35.64 //y2=2.395
r332 (  11 23 ) resistor r=0.0912814 //w=0.379 //l=0.183303 //layer=m1 \
 //thickness=0.36 //x=33.05 //y=3.67 //x2=33.1 //y2=3.51
r333 (  11 12 ) resistor r=1.32156 //w=0.131 //l=1.385 //layer=m1 \
 //thickness=0.36 //x=33.05 //y=3.67 //x2=33.05 //y2=5.055
r334 (  10 23 ) resistor r=0.0912814 //w=0.379 //l=0.183303 //layer=m1 \
 //thickness=0.36 //x=33.05 //y=3.35 //x2=33.1 //y2=3.51
r335 (  9 10 ) resistor r=1.18798 //w=0.131 //l=1.245 //layer=m1 \
 //thickness=0.36 //x=33.05 //y=2.105 //x2=33.05 //y2=3.35
r336 (  7 12 ) resistor r=0.0698411 //w=0.17 //l=0.120208 //layer=m1 \
 //thickness=0.36 //x=32.965 //y=5.14 //x2=33.05 //y2=5.055
r337 (  7 8 ) resistor r=0.186069 //w=0.131 //l=0.195 //layer=m1 \
 //thickness=0.36 //x=32.965 //y=5.14 //x2=32.77 //y2=5.14
r338 (  5 9 ) resistor r=0.0698411 //w=0.17 //l=0.120208 //layer=m1 \
 //thickness=0.36 //x=32.965 //y=2.02 //x2=33.05 //y2=2.105
r339 (  5 6 ) resistor r=0.19084 //w=0.131 //l=0.2 //layer=m1 //thickness=0.36 \
 //x=32.965 //y=2.02 //x2=32.765 //y2=2.02
r340 (  4 21 ) resistor r=0.086672 //w=0.218 //l=0.14 //layer=m1 \
 //thickness=0.36 //x=32.685 //y=5.42 //x2=32.685 //y2=5.56
r341 (  3 8 ) resistor r=0.0698411 //w=0.17 //l=0.120208 //layer=m1 \
 //thickness=0.36 //x=32.685 //y=5.225 //x2=32.77 //y2=5.14
r342 (  3 4 ) resistor r=0.186069 //w=0.131 //l=0.195 //layer=m1 \
 //thickness=0.36 //x=32.685 //y=5.225 //x2=32.685 //y2=5.42
r343 (  2 6 ) resistor r=0.0698411 //w=0.17 //l=0.120208 //layer=m1 \
 //thickness=0.36 //x=32.68 //y=1.935 //x2=32.765 //y2=2.02
r344 (  1 18 ) resistor r=0.105739 //w=0.201 //l=0.145 //layer=m1 \
 //thickness=0.36 //x=32.68 //y=1.33 //x2=32.68 //y2=1.185
r345 (  1 2 ) resistor r=0.57729 //w=0.131 //l=0.605 //layer=m1 \
 //thickness=0.36 //x=32.68 //y=1.33 //x2=32.68 //y2=1.935
ends PM_FA\%noxref_13

subckt PM_FA\%noxref_14 ( 1 2 3 4 5 6 7 9 12 13 14 16 17 18 22 28 32 36 45 47 \
 48 56 73 82 86 87 88 89 90 91 92 96 97 98 100 106 107 109 117 118 121 )
c247 ( 118 0 ) capacitor c=0.00901091f //x=35.75 //y=1.085
c248 ( 117 0 ) capacitor c=0.00876479f //x=34.78 //y=1.085
c249 ( 109 0 ) capacitor c=0.0569816f //x=37.86 //y=2.265
c250 ( 107 0 ) capacitor c=0.0439576f //x=38.5 //y=1.435
c251 ( 106 0 ) capacitor c=0.0201087f //x=38.5 //y=1.09
c252 ( 100 0 ) capacitor c=0.0161986f //x=38.345 //y=1.59
c253 ( 98 0 ) capacitor c=0.0157807f //x=38.345 //y=0.935
c254 ( 97 0 ) capacitor c=0.0557689f //x=38.09 //y=4.97
c255 ( 96 0 ) capacitor c=0.0406047f //x=38.38 //y=4.97
c256 ( 92 0 ) capacitor c=0.0301471f //x=37.97 //y=2.1
c257 ( 91 0 ) capacitor c=0.0255349f //x=37.97 //y=1.745
c258 ( 90 0 ) capacitor c=0.0234346f //x=37.97 //y=1.435
c259 ( 89 0 ) capacitor c=0.02013f //x=37.97 //y=1.09
c260 ( 88 0 ) capacitor c=0.153839f //x=38.455 //y=6.2
c261 ( 87 0 ) capacitor c=0.15434f //x=38.015 //y=6.2
c262 ( 82 0 ) capacitor c=9.4527e-19 //x=37.86 //y=4.88
c263 ( 73 0 ) capacitor c=9.11699e-19 //x=37.86 //y=2.265
c264 ( 56 0 ) capacitor c=0.0246369f //x=35.9 //y=5.56
c265 ( 48 0 ) capacitor c=0.0605885f //x=37.7 //y=3.515
c266 ( 47 0 ) capacitor c=0.00395551f //x=37.86 //y=3.515
c267 ( 45 0 ) capacitor c=0.00546015f //x=36.54 //y=3.515
c268 ( 36 0 ) capacitor c=0.0113219f //x=37.86 //y=2.265
c269 ( 32 0 ) capacitor c=0.0161318f //x=37.86 //y=3.51
c270 ( 28 0 ) capacitor c=0.0149636f //x=36.38 //y=3.51
c271 ( 22 0 ) capacitor c=0.0134246f //x=35.895 //y=5.39
c272 ( 21 0 ) capacitor c=0.00513603f //x=35.94 //y=1.835
c273 ( 18 0 ) capacitor c=0.0346423f //x=37.86 //y=4.76
c274 ( 17 0 ) capacitor c=0.0115809f //x=37.86 //y=3.675
c275 ( 16 0 ) capacitor c=0.0238148f //x=37.86 //y=3.355
c276 ( 14 0 ) capacitor c=0.0434269f //x=36.38 //y=5.305
c277 ( 13 0 ) capacitor c=0.0116169f //x=36.38 //y=3.675
c278 ( 12 0 ) capacitor c=0.0350765f //x=36.38 //y=3.355
c279 ( 9 0 ) capacitor c=0.014332f //x=36.295 //y=1.835
c280 ( 7 0 ) capacitor c=0.0108096f //x=36.295 //y=5.39
c281 ( 6 0 ) capacitor c=0.00690516f //x=35.94 //y=1.75
c282 ( 5 0 ) capacitor c=0.008435f //x=35.94 //y=1.3
c283 ( 4 0 ) capacitor c=0.00254452f //x=35.055 //y=1.835
c284 ( 3 0 ) capacitor c=0.0171069f //x=35.855 //y=1.835
c285 ( 2 0 ) capacitor c=0.00630911f //x=34.97 //y=1.75
c286 ( 1 0 ) capacitor c=0.00820148f //x=34.97 //y=1.305
r287 (  109 110 ) resistor r=17.5563 //w=0.302 //l=0.11 //layer=ply \
 //thickness=0.18 //x=37.86 //y=2.265 //x2=37.97 //y2=2.265
r288 (  107 116 ) resistor r=45.1352 //w=0.168 //l=0.173853 //layer=ply \
 //thickness=0.18 //x=38.5 //y=1.435 //x2=38.46 //y2=1.59
r289 (  106 115 ) resistor r=45.1352 //w=0.168 //l=0.173853 //layer=ply \
 //thickness=0.18 //x=38.5 //y=1.09 //x2=38.46 //y2=0.935
r290 (  106 107 ) resistor r=176.904 //w=0.094 //l=0.345 //layer=ply \
 //thickness=0.18 //x=38.5 //y=1.09 //x2=38.5 //y2=1.435
r291 (  101 114 ) resistor r=10.701 //w=0.21 //l=0.115 //layer=ply \
 //thickness=0.18 //x=38.125 //y=1.59 //x2=38.01 //y2=1.59
r292 (  100 116 ) resistor r=5.52526 //w=0.168 //l=0.115 //layer=ply \
 //thickness=0.18 //x=38.345 //y=1.59 //x2=38.46 //y2=1.59
r293 (  99 113 ) resistor r=5.52526 //w=0.168 //l=0.115 //layer=ply \
 //thickness=0.18 //x=38.125 //y=0.935 //x2=38.01 //y2=0.935
r294 (  98 115 ) resistor r=5.52526 //w=0.168 //l=0.115 //layer=ply \
 //thickness=0.18 //x=38.345 //y=0.935 //x2=38.46 //y2=0.935
r295 (  98 99 ) resistor r=112.809 //w=0.094 //l=0.22 //layer=ply \
 //thickness=0.18 //x=38.345 //y=0.935 //x2=38.125 //y2=0.935
r296 (  96 103 ) resistor r=26.9307 //w=0.15 //l=0.106066 //layer=ply \
 //thickness=0.18 //x=38.38 //y=4.97 //x2=38.455 //y2=5.045
r297 (  96 97 ) resistor r=148.702 //w=0.094 //l=0.29 //layer=ply \
 //thickness=0.18 //x=38.38 //y=4.97 //x2=38.09 //y2=4.97
r298 (  93 97 ) resistor r=23.403 //w=0.284 //l=0.106066 //layer=ply \
 //thickness=0.18 //x=38.015 //y=5.045 //x2=38.09 //y2=4.97
r299 (  93 112 ) resistor r=26.3063 //w=0.284 //l=0.229783 //layer=ply \
 //thickness=0.18 //x=38.015 //y=5.045 //x2=37.86 //y2=4.88
r300 (  92 110 ) resistor r=19.1248 //w=0.302 //l=0.165 //layer=ply \
 //thickness=0.18 //x=37.97 //y=2.1 //x2=37.97 //y2=2.265
r301 (  91 114 ) resistor r=39.5823 //w=0.21 //l=0.173853 //layer=ply \
 //thickness=0.18 //x=37.97 //y=1.745 //x2=38.01 //y2=1.59
r302 (  91 92 ) resistor r=182.032 //w=0.094 //l=0.355 //layer=ply \
 //thickness=0.18 //x=37.97 //y=1.745 //x2=37.97 //y2=2.1
r303 (  90 114 ) resistor r=39.5823 //w=0.21 //l=0.173853 //layer=ply \
 //thickness=0.18 //x=37.97 //y=1.435 //x2=38.01 //y2=1.59
r304 (  89 113 ) resistor r=45.1352 //w=0.168 //l=0.173853 //layer=ply \
 //thickness=0.18 //x=37.97 //y=1.09 //x2=38.01 //y2=0.935
r305 (  89 90 ) resistor r=176.904 //w=0.094 //l=0.345 //layer=ply \
 //thickness=0.18 //x=37.97 //y=1.09 //x2=37.97 //y2=1.435
r306 (  88 103 ) resistor r=592.245 //w=0.094 //l=1.155 //layer=ply \
 //thickness=0.18 //x=38.455 //y=6.2 //x2=38.455 //y2=5.045
r307 (  87 93 ) resistor r=592.245 //w=0.094 //l=1.155 //layer=ply \
 //thickness=0.18 //x=38.015 //y=6.2 //x2=38.015 //y2=5.045
r308 (  86 100 ) resistor r=56.4043 //w=0.094 //l=0.11 //layer=ply \
 //thickness=0.18 //x=38.235 //y=1.59 //x2=38.345 //y2=1.59
r309 (  86 101 ) resistor r=56.4043 //w=0.094 //l=0.11 //layer=ply \
 //thickness=0.18 //x=38.235 //y=1.59 //x2=38.125 //y2=1.59
r310 (  82 112 ) resistor r=152 //w=0.17 //l=0.17 //layer=licon //count=1 \
 //x=37.86 //y=4.88 //x2=37.86 //y2=4.88
r311 (  73 109 ) resistor r=152 //w=0.17 //l=0.17 //layer=licon //count=1 \
 //x=37.86 //y=2.265 //x2=37.86 //y2=2.265
r312 (  56 121 ) resistor r=23.2727 //w=0.187 //l=0.34 //layer=li \
 //thickness=0.1 //x=35.9 //y=5.56 //x2=35.9 //y2=5.9
r313 (  47 48 ) resistor r=0.10734 //w=0.281 //l=0.16 //layer=m2 \
 //thickness=0.36 //x=37.86 //y=3.515 //x2=37.7 //y2=3.515
r314 (  45 48 ) resistor r=1.10687 //w=0.131 //l=1.16 //layer=m2 \
 //thickness=0.36 //x=36.54 //y=3.51 //x2=37.7 //y2=3.51
r315 (  43 45 ) resistor r=0.10734 //w=0.281 //l=0.16 //layer=m2 \
 //thickness=0.36 //x=36.38 //y=3.515 //x2=36.54 //y2=3.515
r316 (  39 82 ) resistor r=9.3 //w=0.17 //l=0.17 //layer=mcon //count=1 \
 //x=37.86 //y=4.88 //x2=37.86 //y2=4.88
r317 (  36 73 ) resistor r=9.3 //w=0.17 //l=0.17 //layer=mcon //count=1 \
 //x=37.86 //y=2.265 //x2=37.86 //y2=2.265
r318 (  34 47 ) resistor r=4.5 //w=0.15 //l=0.15 //layer=via1 //count=1 \
 //x=37.86 //y=3.515 //x2=37.86 //y2=3.515
r319 (  32 34 ) resistor r=0.00166223 //w=0.376 //l=0.005 //layer=m1 \
 //thickness=0.36 //x=37.807 //y=3.51 //x2=37.807 //y2=3.515
r320 (  30 43 ) resistor r=4.5 //w=0.15 //l=0.15 //layer=via1 //count=1 \
 //x=36.38 //y=3.515 //x2=36.38 //y2=3.515
r321 (  28 30 ) resistor r=0.00166223 //w=0.376 //l=0.005 //layer=m1 \
 //thickness=0.36 //x=36.432 //y=3.51 //x2=36.432 //y2=3.515
r322 (  26 118 ) resistor r=9.3 //w=0.17 //l=0.17 //layer=mcon //count=1 \
 //x=35.94 //y=1.18 //x2=35.94 //y2=1.18
r323 (  24 56 ) resistor r=9.3 //w=0.17 //l=0.17 //layer=mcon //count=1 \
 //x=35.9 //y=5.56 //x2=35.9 //y2=5.56
r324 (  22 24 ) resistor r=0.0974771 //w=0.218 //l=0.17 //layer=m1 \
 //thickness=0.36 //x=35.895 //y=5.39 //x2=35.895 //y2=5.56
r325 (  20 117 ) resistor r=9.3 //w=0.17 //l=0.17 //layer=mcon //count=1 \
 //x=34.97 //y=1.18 //x2=34.97 //y2=1.18
r326 (  18 39 ) resistor r=0.0732479 //w=0.241 //l=0.122474 //layer=m1 \
 //thickness=0.36 //x=37.86 //y=4.76 //x2=37.865 //y2=4.88
r327 (  17 34 ) resistor r=0.0911593 //w=0.376 //l=0.184608 //layer=m1 \
 //thickness=0.36 //x=37.86 //y=3.675 //x2=37.807 //y2=3.515
r328 (  17 18 ) resistor r=1.03531 //w=0.131 //l=1.085 //layer=m1 \
 //thickness=0.36 //x=37.86 //y=3.675 //x2=37.86 //y2=4.76
r329 (  16 32 ) resistor r=0.0894971 //w=0.376 //l=0.179555 //layer=m1 \
 //thickness=0.36 //x=37.86 //y=3.355 //x2=37.807 //y2=3.51
r330 (  15 36 ) resistor r=0.116051 //w=0.211 //l=0.165 //layer=m1 \
 //thickness=0.36 //x=37.86 //y=2.43 //x2=37.86 //y2=2.265
r331 (  15 16 ) resistor r=0.882634 //w=0.131 //l=0.925 //layer=m1 \
 //thickness=0.36 //x=37.86 //y=2.43 //x2=37.86 //y2=3.355
r332 (  13 30 ) resistor r=0.0911593 //w=0.376 //l=0.184174 //layer=m1 \
 //thickness=0.36 //x=36.38 //y=3.675 //x2=36.432 //y2=3.515
r333 (  13 14 ) resistor r=1.55534 //w=0.131 //l=1.63 //layer=m1 \
 //thickness=0.36 //x=36.38 //y=3.675 //x2=36.38 //y2=5.305
r334 (  12 28 ) resistor r=0.0894971 //w=0.376 //l=0.179123 //layer=m1 \
 //thickness=0.36 //x=36.38 //y=3.355 //x2=36.432 //y2=3.51
r335 (  11 12 ) resistor r=1.36927 //w=0.131 //l=1.435 //layer=m1 \
 //thickness=0.36 //x=36.38 //y=1.92 //x2=36.38 //y2=3.355
r336 (  10 21 ) resistor r=0.0529306 //w=0.17 //l=0.085 //layer=m1 \
 //thickness=0.36 //x=36.025 //y=1.835 //x2=35.94 //y2=1.835
r337 (  9 11 ) resistor r=0.0698411 //w=0.17 //l=0.120208 //layer=m1 \
 //thickness=0.36 //x=36.295 //y=1.835 //x2=36.38 //y2=1.92
r338 (  9 10 ) resistor r=0.257634 //w=0.131 //l=0.27 //layer=m1 \
 //thickness=0.36 //x=36.295 //y=1.835 //x2=36.025 //y2=1.835
r339 (  8 22 ) resistor r=0.0225019 //w=0.218 //l=0.12 //layer=m1 \
 //thickness=0.36 //x=36.015 //y=5.39 //x2=35.895 //y2=5.39
r340 (  7 14 ) resistor r=0.0698411 //w=0.17 //l=0.120208 //layer=m1 \
 //thickness=0.36 //x=36.295 //y=5.39 //x2=36.38 //y2=5.305
r341 (  7 8 ) resistor r=0.267176 //w=0.131 //l=0.28 //layer=m1 \
 //thickness=0.36 //x=36.295 //y=5.39 //x2=36.015 //y2=5.39
r342 (  6 21 ) resistor r=0.0137558 //w=0.34 //l=0.085 //layer=m1 \
 //thickness=0.36 //x=35.94 //y=1.75 //x2=35.94 //y2=1.835
r343 (  5 26 ) resistor r=0.0728765 //w=0.25 //l=0.121491 //layer=m1 \
 //thickness=0.36 //x=35.94 //y=1.3 //x2=35.937 //y2=1.18
r344 (  5 6 ) resistor r=0.429389 //w=0.131 //l=0.45 //layer=m1 \
 //thickness=0.36 //x=35.94 //y=1.3 //x2=35.94 //y2=1.75
r345 (  3 21 ) resistor r=0.0529306 //w=0.17 //l=0.085 //layer=m1 \
 //thickness=0.36 //x=35.855 //y=1.835 //x2=35.94 //y2=1.835
r346 (  3 4 ) resistor r=0.763359 //w=0.131 //l=0.8 //layer=m1 \
 //thickness=0.36 //x=35.855 //y=1.835 //x2=35.055 //y2=1.835
r347 (  2 4 ) resistor r=0.0698411 //w=0.17 //l=0.120208 //layer=m1 \
 //thickness=0.36 //x=34.97 //y=1.75 //x2=35.055 //y2=1.835
r348 (  1 20 ) resistor r=0.0764279 //w=0.233 //l=0.126491 //layer=m1 \
 //thickness=0.36 //x=34.97 //y=1.305 //x2=34.967 //y2=1.18
r349 (  1 2 ) resistor r=0.424618 //w=0.131 //l=0.445 //layer=m1 \
 //thickness=0.36 //x=34.97 //y=1.305 //x2=34.97 //y2=1.75
ends PM_FA\%noxref_14

subckt PM_FA\%VDD ( 1 2 10 11 12 18 19 20 34 35 36 44 45 46 75 76 85 146 162 \
 176 202 228 244 260 286 314 324 346 372 382 408 422 449 464 468 470 471 472 \
 476 479 480 481 484 489 493 497 501 502 505 506 507 508 509 510 511 512 513 \
 514 515 516 517 518 519 520 521 522 523 524 525 526 527 528 529 )
c812 ( 529 0 ) capacitor c=0.0631392f //x=38.53 //y=5.2
c813 ( 528 0 ) capacitor c=0.0577411f //x=37.66 //y=5.2
c814 ( 527 0 ) capacitor c=0.0230428f //x=34.875 //y=5.205
c815 ( 526 0 ) capacitor c=0.0581268f //x=32.98 //y=5.2
c816 ( 525 0 ) capacitor c=0.0580443f //x=32.11 //y=5.2
c817 ( 524 0 ) capacitor c=0.039544f //x=30.645 //y=5.2
c818 ( 523 0 ) capacitor c=0.0248174f //x=29.765 //y=5.2
c819 ( 522 0 ) capacitor c=0.0585707f //x=28.895 //y=5.2
c820 ( 521 0 ) capacitor c=0.0548569f //x=27.43 //y=5.2
c821 ( 520 0 ) capacitor c=0.0578288f //x=26.56 //y=5.2
c822 ( 519 0 ) capacitor c=0.039544f //x=25.095 //y=5.2
c823 ( 518 0 ) capacitor c=0.0248174f //x=24.215 //y=5.2
c824 ( 517 0 ) capacitor c=0.0579419f //x=23.345 //y=5.2
c825 ( 516 0 ) capacitor c=0.051806f //x=21.87 //y=5.2
c826 ( 515 0 ) capacitor c=0.0577892f //x=21.01 //y=5.2
c827 ( 514 0 ) capacitor c=0.0170134f //x=18.225 //y=5.2
c828 ( 513 0 ) capacitor c=0.0170965f //x=14.895 //y=5.2
c829 ( 512 0 ) capacitor c=0.0585652f //x=13 //y=5.2
c830 ( 511 0 ) capacitor c=0.052709f //x=12.13 //y=5.2
c831 ( 510 0 ) capacitor c=0.0524059f //x=10.77 //y=5.2
c832 ( 509 0 ) capacitor c=0.0577654f //x=9.91 //y=5.2
c833 ( 508 0 ) capacitor c=0.0170134f //x=7.125 //y=5.2
c834 ( 507 0 ) capacitor c=0.0170965f //x=3.795 //y=5.2
c835 ( 506 0 ) capacitor c=0.0586397f //x=1.9 //y=5.2
c836 ( 505 0 ) capacitor c=0.0605586f //x=1.03 //y=5.2
c837 ( 504 0 ) capacitor c=0.00597439f //x=38.675 //y=7.585
c838 ( 503 0 ) capacitor c=0.00597439f //x=37.795 //y=7.585
c839 ( 502 0 ) capacitor c=0.12252f //x=37.12 //y=7.585
c840 ( 501 0 ) capacitor c=0.12374f //x=33.79 //y=7.585
c841 ( 500 0 ) capacitor c=0.00597439f //x=33.05 //y=7.58
c842 ( 498 0 ) capacitor c=0.00597439f //x=32.245 //y=7.585
c843 ( 497 0 ) capacitor c=0.122964f //x=31.57 //y=7.585
c844 ( 496 0 ) capacitor c=0.00597439f //x=30.79 //y=7.585
c845 ( 495 0 ) capacitor c=0.00597439f //x=29.91 //y=7.585
c846 ( 494 0 ) capacitor c=0.00597439f //x=29.03 //y=7.585
c847 ( 493 0 ) capacitor c=0.130157f //x=28.24 //y=7.585
c848 ( 492 0 ) capacitor c=0.00597439f //x=27.575 //y=7.585
c849 ( 491 0 ) capacitor c=0.00597439f //x=26.76 //y=7.58
c850 ( 489 0 ) capacitor c=0.12486f //x=26.02 //y=7.585
c851 ( 488 0 ) capacitor c=0.00597439f //x=25.28 //y=7.58
c852 ( 486 0 ) capacitor c=0.00597439f //x=24.36 //y=7.585
c853 ( 485 0 ) capacitor c=0.00597439f //x=23.48 //y=7.585
c854 ( 484 0 ) capacitor c=0.124032f //x=22.69 //y=7.585
c855 ( 483 0 ) capacitor c=0.00597439f //x=22.015 //y=7.585
c856 ( 482 0 ) capacitor c=0.00597439f //x=21.135 //y=7.585
c857 ( 481 0 ) capacitor c=0.120582f //x=20.47 //y=7.585
c858 ( 480 0 ) capacitor c=0.120084f //x=17.14 //y=7.585
c859 ( 479 0 ) capacitor c=0.123749f //x=13.81 //y=7.585
c860 ( 478 0 ) capacitor c=0.00597439f //x=13.145 //y=7.585
c861 ( 477 0 ) capacitor c=0.00597439f //x=12.265 //y=7.585
c862 ( 476 0 ) capacitor c=0.11791f //x=11.59 //y=7.585
c863 ( 475 0 ) capacitor c=0.00597439f //x=10.915 //y=7.585
c864 ( 474 0 ) capacitor c=0.00597439f //x=10.11 //y=7.58
c865 ( 472 0 ) capacitor c=0.118121f //x=9.37 //y=7.585
c866 ( 471 0 ) capacitor c=0.118893f //x=6.04 //y=7.585
c867 ( 470 0 ) capacitor c=0.121818f //x=2.71 //y=7.585
c868 ( 469 0 ) capacitor c=0.00597439f //x=2.045 //y=7.585
c869 ( 468 0 ) capacitor c=0.25643f //x=1.23 //y=7.58
c870 ( 464 0 ) capacitor c=0.253559f //x=38.97 //y=7.58
c871 ( 449 0 ) capacitor c=0.0289924f //x=38.59 //y=7.585
c872 ( 439 0 ) capacitor c=0.0217664f //x=37.71 //y=7.585
c873 ( 422 0 ) capacitor c=0.139031f //x=36.95 //y=7.585
c874 ( 418 0 ) capacitor c=0.0211939f //x=33.62 //y=7.585
c875 ( 408 0 ) capacitor c=0.0289924f //x=33.04 //y=7.585
c876 ( 396 0 ) capacitor c=0.0217664f //x=32.16 //y=7.585
c877 ( 392 0 ) capacitor c=0.0277785f //x=31.4 //y=7.585
c878 ( 382 0 ) capacitor c=0.0287375f //x=30.705 //y=7.585
c879 ( 372 0 ) capacitor c=0.0291079f //x=29.825 //y=7.585
c880 ( 362 0 ) capacitor c=0.0283511f //x=28.945 //y=7.585
c881 ( 356 0 ) capacitor c=0.0211939f //x=28.07 //y=7.585
c882 ( 346 0 ) capacitor c=0.0291626f //x=27.49 //y=7.585
c883 ( 336 0 ) capacitor c=0.0217664f //x=26.61 //y=7.585
c884 ( 332 0 ) capacitor c=0.0277785f //x=25.85 //y=7.585
c885 ( 324 0 ) capacitor c=0.0287375f //x=25.155 //y=7.585
c886 ( 314 0 ) capacitor c=0.0290143f //x=24.275 //y=7.585
c887 ( 302 0 ) capacitor c=0.0283511f //x=23.395 //y=7.585
c888 ( 298 0 ) capacitor c=0.0187886f //x=22.52 //y=7.585
c889 ( 286 0 ) capacitor c=0.0287889f //x=21.93 //y=7.585
c890 ( 276 0 ) capacitor c=0.0208042f //x=21.05 //y=7.585
c891 ( 260 0 ) capacitor c=0.139643f //x=20.3 //y=7.585
c892 ( 244 0 ) capacitor c=0.138716f //x=16.97 //y=7.585
c893 ( 240 0 ) capacitor c=0.0211939f //x=13.64 //y=7.585
c894 ( 228 0 ) capacitor c=0.0288836f //x=13.06 //y=7.585
c895 ( 218 0 ) capacitor c=0.0217664f //x=12.18 //y=7.585
c896 ( 212 0 ) capacitor c=0.0217664f //x=11.42 //y=7.585
c897 ( 202 0 ) capacitor c=0.0290689f //x=10.83 //y=7.585
c898 ( 192 0 ) capacitor c=0.0208042f //x=9.95 //y=7.585
c899 ( 176 0 ) capacitor c=0.139876f //x=9.2 //y=7.585
c900 ( 162 0 ) capacitor c=0.1391f //x=5.87 //y=7.585
c901 ( 156 0 ) capacitor c=0.0211939f //x=2.54 //y=7.585
c902 ( 146 0 ) capacitor c=0.0287132f //x=1.96 //y=7.585
c903 ( 127 0 ) capacitor c=0.00499323f //x=35.02 //y=7.585
c904 ( 108 0 ) capacitor c=0.00510714f //x=18.37 //y=7.585
c905 ( 105 0 ) capacitor c=0.00510714f //x=15.04 //y=7.585
c906 ( 94 0 ) capacitor c=0.00510714f //x=7.27 //y=7.585
c907 ( 91 0 ) capacitor c=0.00510714f //x=3.94 //y=7.585
c908 ( 85 0 ) capacitor c=0.180718f //x=38.97 //y=7.58
c909 ( 76 0 ) capacitor c=0.00916089f //x=35.02 //y=7.41
c910 ( 75 0 ) capacitor c=0.00617159f //x=35.02 //y=7.035
c911 ( 46 0 ) capacitor c=0.584505f //x=34.935 //y=7.585
c912 ( 45 0 ) capacitor c=0.0147928f //x=18.37 //y=7.41
c913 ( 44 0 ) capacitor c=0.0130915f //x=18.37 //y=6.69
c914 ( 36 0 ) capacitor c=0.110467f //x=18.285 //y=7.585
c915 ( 35 0 ) capacitor c=0.0153981f //x=15.04 //y=7.41
c916 ( 34 0 ) capacitor c=0.0135752f //x=15.04 //y=6.7
c917 ( 20 0 ) capacitor c=0.272075f //x=14.955 //y=7.585
c918 ( 19 0 ) capacitor c=0.0147928f //x=7.27 //y=7.41
c919 ( 18 0 ) capacitor c=0.0131315f //x=7.27 //y=6.69
c920 ( 12 0 ) capacitor c=0.110467f //x=7.185 //y=7.585
c921 ( 11 0 ) capacitor c=0.0153981f //x=3.94 //y=7.41
c922 ( 10 0 ) capacitor c=0.013349f //x=3.94 //y=6.7
c923 ( 2 0 ) capacitor c=0.158536f //x=3.855 //y=7.585
r924 (  462 504 ) resistor r=2.87058 //w=0.35 //l=0.085 //layer=li \
 //thickness=0.1 //x=38.76 //y=7.585 //x2=38.675 //y2=7.585
r925 (  462 464 ) resistor r=7.32425 //w=0.367 //l=0.21 //layer=li \
 //thickness=0.1 //x=38.76 //y=7.585 //x2=38.97 //y2=7.585
r926 (  453 504 ) resistor r=4.23183 //w=0.7 //l=0.175 //layer=li \
 //thickness=0.1 //x=38.675 //y=7.41 //x2=38.675 //y2=7.585
r927 (  453 529 ) resistor r=56.4706 //w=0.187 //l=0.825 //layer=li \
 //thickness=0.1 //x=38.675 //y=7.41 //x2=38.675 //y2=6.585
r928 (  450 503 ) resistor r=2.87058 //w=0.35 //l=0.085 //layer=li \
 //thickness=0.1 //x=37.88 //y=7.585 //x2=37.795 //y2=7.585
r929 (  450 452 ) resistor r=12.2071 //w=0.367 //l=0.35 //layer=li \
 //thickness=0.1 //x=37.88 //y=7.585 //x2=38.23 //y2=7.585
r930 (  449 504 ) resistor r=2.87058 //w=0.35 //l=0.085 //layer=li \
 //thickness=0.1 //x=38.59 //y=7.585 //x2=38.675 //y2=7.585
r931 (  449 452 ) resistor r=12.5559 //w=0.367 //l=0.36 //layer=li \
 //thickness=0.1 //x=38.59 //y=7.585 //x2=38.23 //y2=7.585
r932 (  441 503 ) resistor r=4.23183 //w=0.7 //l=0.175 //layer=li \
 //thickness=0.1 //x=37.795 //y=7.41 //x2=37.795 //y2=7.585
r933 (  441 528 ) resistor r=56.4706 //w=0.187 //l=0.825 //layer=li \
 //thickness=0.1 //x=37.795 //y=7.41 //x2=37.795 //y2=6.585
r934 (  440 502 ) resistor r=5.29055 //w=0.35 //l=0.17 //layer=li \
 //thickness=0.1 //x=37.29 //y=7.585 //x2=37.12 //y2=7.585
r935 (  439 503 ) resistor r=2.87058 //w=0.35 //l=0.085 //layer=li \
 //thickness=0.1 //x=37.71 //y=7.585 //x2=37.795 //y2=7.585
r936 (  439 440 ) resistor r=14.6485 //w=0.367 //l=0.42 //layer=li \
 //thickness=0.1 //x=37.71 //y=7.585 //x2=37.29 //y2=7.585
r937 (  427 429 ) resistor r=38.7139 //w=0.367 //l=1.11 //layer=li \
 //thickness=0.1 //x=35.64 //y=7.585 //x2=36.75 //y2=7.585
r938 (  425 427 ) resistor r=38.7139 //w=0.367 //l=1.11 //layer=li \
 //thickness=0.1 //x=34.53 //y=7.585 //x2=35.64 //y2=7.585
r939 (  423 501 ) resistor r=5.29055 //w=0.35 //l=0.17 //layer=li \
 //thickness=0.1 //x=33.96 //y=7.585 //x2=33.79 //y2=7.585
r940 (  423 425 ) resistor r=19.8801 //w=0.367 //l=0.57 //layer=li \
 //thickness=0.1 //x=33.96 //y=7.585 //x2=34.53 //y2=7.585
r941 (  422 502 ) resistor r=5.29055 //w=0.35 //l=0.17 //layer=li \
 //thickness=0.1 //x=36.95 //y=7.585 //x2=37.12 //y2=7.585
r942 (  422 429 ) resistor r=6.97548 //w=0.367 //l=0.2 //layer=li \
 //thickness=0.1 //x=36.95 //y=7.585 //x2=36.75 //y2=7.585
r943 (  419 500 ) resistor r=2.87058 //w=0.35 //l=0.085 //layer=li \
 //thickness=0.1 //x=33.21 //y=7.585 //x2=33.125 //y2=7.585
r944 (  418 501 ) resistor r=5.29055 //w=0.35 //l=0.17 //layer=li \
 //thickness=0.1 //x=33.62 //y=7.585 //x2=33.79 //y2=7.585
r945 (  418 419 ) resistor r=14.2997 //w=0.367 //l=0.41 //layer=li \
 //thickness=0.1 //x=33.62 //y=7.585 //x2=33.21 //y2=7.585
r946 (  410 500 ) resistor r=4.23183 //w=0.7 //l=0.175 //layer=li \
 //thickness=0.1 //x=33.125 //y=7.41 //x2=33.125 //y2=7.585
r947 (  410 526 ) resistor r=56.4706 //w=0.187 //l=0.825 //layer=li \
 //thickness=0.1 //x=33.125 //y=7.41 //x2=33.125 //y2=6.585
r948 (  409 498 ) resistor r=2.87058 //w=0.35 //l=0.085 //layer=li \
 //thickness=0.1 //x=32.33 //y=7.585 //x2=32.245 //y2=7.585
r949 (  408 500 ) resistor r=2.87058 //w=0.35 //l=0.085 //layer=li \
 //thickness=0.1 //x=33.04 //y=7.585 //x2=33.125 //y2=7.585
r950 (  408 409 ) resistor r=24.7629 //w=0.367 //l=0.71 //layer=li \
 //thickness=0.1 //x=33.04 //y=7.585 //x2=32.33 //y2=7.585
r951 (  400 498 ) resistor r=4.23183 //w=0.7 //l=0.175 //layer=li \
 //thickness=0.1 //x=32.245 //y=7.41 //x2=32.245 //y2=7.585
r952 (  400 525 ) resistor r=56.4706 //w=0.187 //l=0.825 //layer=li \
 //thickness=0.1 //x=32.245 //y=7.41 //x2=32.245 //y2=6.585
r953 (  397 497 ) resistor r=5.29055 //w=0.35 //l=0.17 //layer=li \
 //thickness=0.1 //x=31.74 //y=7.585 //x2=31.57 //y2=7.585
r954 (  397 399 ) resistor r=6.97548 //w=0.367 //l=0.2 //layer=li \
 //thickness=0.1 //x=31.74 //y=7.585 //x2=31.94 //y2=7.585
r955 (  396 498 ) resistor r=2.87058 //w=0.35 //l=0.085 //layer=li \
 //thickness=0.1 //x=32.16 //y=7.585 //x2=32.245 //y2=7.585
r956 (  396 399 ) resistor r=7.67302 //w=0.367 //l=0.22 //layer=li \
 //thickness=0.1 //x=32.16 //y=7.585 //x2=31.94 //y2=7.585
r957 (  393 496 ) resistor r=2.87058 //w=0.35 //l=0.085 //layer=li \
 //thickness=0.1 //x=30.875 //y=7.585 //x2=30.79 //y2=7.585
r958 (  392 497 ) resistor r=5.29055 //w=0.35 //l=0.17 //layer=li \
 //thickness=0.1 //x=31.4 //y=7.585 //x2=31.57 //y2=7.585
r959 (  392 393 ) resistor r=18.3106 //w=0.367 //l=0.525 //layer=li \
 //thickness=0.1 //x=31.4 //y=7.585 //x2=30.875 //y2=7.585
r960 (  386 496 ) resistor r=4.23183 //w=0.7 //l=0.175 //layer=li \
 //thickness=0.1 //x=30.79 //y=7.41 //x2=30.79 //y2=7.585
r961 (  386 524 ) resistor r=33.1979 //w=0.187 //l=0.485 //layer=li \
 //thickness=0.1 //x=30.79 //y=7.41 //x2=30.79 //y2=6.925
r962 (  383 495 ) resistor r=2.87058 //w=0.35 //l=0.085 //layer=li \
 //thickness=0.1 //x=29.995 //y=7.585 //x2=29.91 //y2=7.585
r963 (  383 385 ) resistor r=16.218 //w=0.367 //l=0.465 //layer=li \
 //thickness=0.1 //x=29.995 //y=7.585 //x2=30.46 //y2=7.585
r964 (  382 496 ) resistor r=2.87058 //w=0.35 //l=0.085 //layer=li \
 //thickness=0.1 //x=30.705 //y=7.585 //x2=30.79 //y2=7.585
r965 (  382 385 ) resistor r=8.54496 //w=0.367 //l=0.245 //layer=li \
 //thickness=0.1 //x=30.705 //y=7.585 //x2=30.46 //y2=7.585
r966 (  376 495 ) resistor r=4.23183 //w=0.7 //l=0.175 //layer=li \
 //thickness=0.1 //x=29.91 //y=7.41 //x2=29.91 //y2=7.585
r967 (  376 523 ) resistor r=33.1979 //w=0.187 //l=0.485 //layer=li \
 //thickness=0.1 //x=29.91 //y=7.41 //x2=29.91 //y2=6.925
r968 (  373 494 ) resistor r=2.87058 //w=0.35 //l=0.085 //layer=li \
 //thickness=0.1 //x=29.115 //y=7.585 //x2=29.03 //y2=7.585
r969 (  373 375 ) resistor r=8.19619 //w=0.367 //l=0.235 //layer=li \
 //thickness=0.1 //x=29.115 //y=7.585 //x2=29.35 //y2=7.585
r970 (  372 495 ) resistor r=2.87058 //w=0.35 //l=0.085 //layer=li \
 //thickness=0.1 //x=29.825 //y=7.585 //x2=29.91 //y2=7.585
r971 (  372 375 ) resistor r=16.5668 //w=0.367 //l=0.475 //layer=li \
 //thickness=0.1 //x=29.825 //y=7.585 //x2=29.35 //y2=7.585
r972 (  364 494 ) resistor r=4.23183 //w=0.7 //l=0.175 //layer=li \
 //thickness=0.1 //x=29.03 //y=7.41 //x2=29.03 //y2=7.585
r973 (  364 522 ) resistor r=56.4706 //w=0.187 //l=0.825 //layer=li \
 //thickness=0.1 //x=29.03 //y=7.41 //x2=29.03 //y2=6.585
r974 (  363 493 ) resistor r=5.29055 //w=0.35 //l=0.17 //layer=li \
 //thickness=0.1 //x=28.41 //y=7.585 //x2=28.24 //y2=7.585
r975 (  362 494 ) resistor r=2.87058 //w=0.35 //l=0.085 //layer=li \
 //thickness=0.1 //x=28.945 //y=7.585 //x2=29.03 //y2=7.585
r976 (  362 363 ) resistor r=18.6594 //w=0.367 //l=0.535 //layer=li \
 //thickness=0.1 //x=28.945 //y=7.585 //x2=28.41 //y2=7.585
r977 (  357 492 ) resistor r=2.87058 //w=0.35 //l=0.085 //layer=li \
 //thickness=0.1 //x=27.66 //y=7.585 //x2=27.575 //y2=7.585
r978 (  357 359 ) resistor r=7.32425 //w=0.367 //l=0.21 //layer=li \
 //thickness=0.1 //x=27.66 //y=7.585 //x2=27.87 //y2=7.585
r979 (  356 493 ) resistor r=5.29055 //w=0.35 //l=0.17 //layer=li \
 //thickness=0.1 //x=28.07 //y=7.585 //x2=28.24 //y2=7.585
r980 (  356 359 ) resistor r=6.97548 //w=0.367 //l=0.2 //layer=li \
 //thickness=0.1 //x=28.07 //y=7.585 //x2=27.87 //y2=7.585
r981 (  348 492 ) resistor r=4.23183 //w=0.7 //l=0.175 //layer=li \
 //thickness=0.1 //x=27.575 //y=7.41 //x2=27.575 //y2=7.585
r982 (  348 521 ) resistor r=56.4706 //w=0.187 //l=0.825 //layer=li \
 //thickness=0.1 //x=27.575 //y=7.41 //x2=27.575 //y2=6.585
r983 (  347 491 ) resistor r=2.87058 //w=0.35 //l=0.085 //layer=li \
 //thickness=0.1 //x=26.78 //y=7.585 //x2=26.695 //y2=7.585
r984 (  346 492 ) resistor r=2.87058 //w=0.35 //l=0.085 //layer=li \
 //thickness=0.1 //x=27.49 //y=7.585 //x2=27.575 //y2=7.585
r985 (  346 347 ) resistor r=24.7629 //w=0.367 //l=0.71 //layer=li \
 //thickness=0.1 //x=27.49 //y=7.585 //x2=26.78 //y2=7.585
r986 (  338 491 ) resistor r=4.23183 //w=0.7 //l=0.175 //layer=li \
 //thickness=0.1 //x=26.695 //y=7.41 //x2=26.695 //y2=7.585
r987 (  338 520 ) resistor r=56.4706 //w=0.187 //l=0.825 //layer=li \
 //thickness=0.1 //x=26.695 //y=7.41 //x2=26.695 //y2=6.585
r988 (  337 489 ) resistor r=5.29055 //w=0.35 //l=0.17 //layer=li \
 //thickness=0.1 //x=26.19 //y=7.585 //x2=26.02 //y2=7.585
r989 (  336 491 ) resistor r=2.87058 //w=0.35 //l=0.085 //layer=li \
 //thickness=0.1 //x=26.61 //y=7.585 //x2=26.695 //y2=7.585
r990 (  336 337 ) resistor r=14.6485 //w=0.367 //l=0.42 //layer=li \
 //thickness=0.1 //x=26.61 //y=7.585 //x2=26.19 //y2=7.585
r991 (  333 488 ) resistor r=2.87058 //w=0.35 //l=0.085 //layer=li \
 //thickness=0.1 //x=25.325 //y=7.585 //x2=25.24 //y2=7.585
r992 (  332 489 ) resistor r=5.29055 //w=0.35 //l=0.17 //layer=li \
 //thickness=0.1 //x=25.85 //y=7.585 //x2=26.02 //y2=7.585
r993 (  332 333 ) resistor r=18.3106 //w=0.367 //l=0.525 //layer=li \
 //thickness=0.1 //x=25.85 //y=7.585 //x2=25.325 //y2=7.585
r994 (  326 488 ) resistor r=4.23183 //w=0.7 //l=0.175 //layer=li \
 //thickness=0.1 //x=25.24 //y=7.41 //x2=25.24 //y2=7.585
r995 (  326 519 ) resistor r=33.1979 //w=0.187 //l=0.485 //layer=li \
 //thickness=0.1 //x=25.24 //y=7.41 //x2=25.24 //y2=6.925
r996 (  325 486 ) resistor r=2.87058 //w=0.35 //l=0.085 //layer=li \
 //thickness=0.1 //x=24.445 //y=7.585 //x2=24.36 //y2=7.585
r997 (  324 488 ) resistor r=2.87058 //w=0.35 //l=0.085 //layer=li \
 //thickness=0.1 //x=25.155 //y=7.585 //x2=25.24 //y2=7.585
r998 (  324 325 ) resistor r=24.7629 //w=0.367 //l=0.71 //layer=li \
 //thickness=0.1 //x=25.155 //y=7.585 //x2=24.445 //y2=7.585
r999 (  318 486 ) resistor r=4.23183 //w=0.7 //l=0.175 //layer=li \
 //thickness=0.1 //x=24.36 //y=7.41 //x2=24.36 //y2=7.585
r1000 (  318 518 ) resistor r=33.1979 //w=0.187 //l=0.485 //layer=li \
 //thickness=0.1 //x=24.36 //y=7.41 //x2=24.36 //y2=6.925
r1001 (  315 485 ) resistor r=2.87058 //w=0.35 //l=0.085 //layer=li \
 //thickness=0.1 //x=23.565 //y=7.585 //x2=23.48 //y2=7.585
r1002 (  315 317 ) resistor r=21.1008 //w=0.367 //l=0.605 //layer=li \
 //thickness=0.1 //x=23.565 //y=7.585 //x2=24.17 //y2=7.585
r1003 (  314 486 ) resistor r=2.87058 //w=0.35 //l=0.085 //layer=li \
 //thickness=0.1 //x=24.275 //y=7.585 //x2=24.36 //y2=7.585
r1004 (  314 317 ) resistor r=3.66213 //w=0.367 //l=0.105 //layer=li \
 //thickness=0.1 //x=24.275 //y=7.585 //x2=24.17 //y2=7.585
r1005 (  306 485 ) resistor r=4.23183 //w=0.7 //l=0.175 //layer=li \
 //thickness=0.1 //x=23.48 //y=7.41 //x2=23.48 //y2=7.585
r1006 (  306 517 ) resistor r=56.4706 //w=0.187 //l=0.825 //layer=li \
 //thickness=0.1 //x=23.48 //y=7.41 //x2=23.48 //y2=6.585
r1007 (  303 484 ) resistor r=5.29055 //w=0.35 //l=0.17 //layer=li \
 //thickness=0.1 //x=22.86 //y=7.585 //x2=22.69 //y2=7.585
r1008 (  303 305 ) resistor r=6.97548 //w=0.367 //l=0.2 //layer=li \
 //thickness=0.1 //x=22.86 //y=7.585 //x2=23.06 //y2=7.585
r1009 (  302 485 ) resistor r=2.87058 //w=0.35 //l=0.085 //layer=li \
 //thickness=0.1 //x=23.395 //y=7.585 //x2=23.48 //y2=7.585
r1010 (  302 305 ) resistor r=11.6839 //w=0.367 //l=0.335 //layer=li \
 //thickness=0.1 //x=23.395 //y=7.585 //x2=23.06 //y2=7.585
r1011 (  299 483 ) resistor r=2.87058 //w=0.35 //l=0.085 //layer=li \
 //thickness=0.1 //x=22.1 //y=7.585 //x2=22.015 //y2=7.585
r1012 (  298 484 ) resistor r=5.29055 //w=0.35 //l=0.17 //layer=li \
 //thickness=0.1 //x=22.52 //y=7.585 //x2=22.69 //y2=7.585
r1013 (  298 299 ) resistor r=14.6485 //w=0.367 //l=0.42 //layer=li \
 //thickness=0.1 //x=22.52 //y=7.585 //x2=22.1 //y2=7.585
r1014 (  290 483 ) resistor r=4.23183 //w=0.7 //l=0.175 //layer=li \
 //thickness=0.1 //x=22.015 //y=7.41 //x2=22.015 //y2=7.585
r1015 (  290 516 ) resistor r=56.4706 //w=0.187 //l=0.825 //layer=li \
 //thickness=0.1 //x=22.015 //y=7.41 //x2=22.015 //y2=6.585
r1016 (  287 482 ) resistor r=2.87058 //w=0.35 //l=0.085 //layer=li \
 //thickness=0.1 //x=21.22 //y=7.585 //x2=21.135 //y2=7.585
r1017 (  287 289 ) resistor r=12.5559 //w=0.367 //l=0.36 //layer=li \
 //thickness=0.1 //x=21.22 //y=7.585 //x2=21.58 //y2=7.585
r1018 (  286 483 ) resistor r=2.87058 //w=0.35 //l=0.085 //layer=li \
 //thickness=0.1 //x=21.93 //y=7.585 //x2=22.015 //y2=7.585
r1019 (  286 289 ) resistor r=12.2071 //w=0.367 //l=0.35 //layer=li \
 //thickness=0.1 //x=21.93 //y=7.585 //x2=21.58 //y2=7.585
r1020 (  278 482 ) resistor r=4.23183 //w=0.7 //l=0.175 //layer=li \
 //thickness=0.1 //x=21.135 //y=7.41 //x2=21.135 //y2=7.585
r1021 (  278 515 ) resistor r=56.4706 //w=0.187 //l=0.825 //layer=li \
 //thickness=0.1 //x=21.135 //y=7.41 //x2=21.135 //y2=6.585
r1022 (  277 481 ) resistor r=5.29055 //w=0.35 //l=0.17 //layer=li \
 //thickness=0.1 //x=20.64 //y=7.585 //x2=20.47 //y2=7.585
r1023 (  276 482 ) resistor r=2.87058 //w=0.35 //l=0.085 //layer=li \
 //thickness=0.1 //x=21.05 //y=7.585 //x2=21.135 //y2=7.585
r1024 (  276 277 ) resistor r=14.2997 //w=0.367 //l=0.41 //layer=li \
 //thickness=0.1 //x=21.05 //y=7.585 //x2=20.64 //y2=7.585
r1025 (  272 514 ) resistor r=23.2727 //w=0.187 //l=0.34 //layer=li \
 //thickness=0.1 //x=18.37 //y=6.575 //x2=18.37 //y2=6.235
r1026 (  265 267 ) resistor r=38.7139 //w=0.367 //l=1.11 //layer=li \
 //thickness=0.1 //x=18.99 //y=7.585 //x2=20.1 //y2=7.585
r1027 (  263 265 ) resistor r=38.7139 //w=0.367 //l=1.11 //layer=li \
 //thickness=0.1 //x=17.88 //y=7.585 //x2=18.99 //y2=7.585
r1028 (  261 480 ) resistor r=5.29055 //w=0.35 //l=0.17 //layer=li \
 //thickness=0.1 //x=17.31 //y=7.585 //x2=17.14 //y2=7.585
r1029 (  261 263 ) resistor r=19.8801 //w=0.367 //l=0.57 //layer=li \
 //thickness=0.1 //x=17.31 //y=7.585 //x2=17.88 //y2=7.585
r1030 (  260 481 ) resistor r=5.29055 //w=0.35 //l=0.17 //layer=li \
 //thickness=0.1 //x=20.3 //y=7.585 //x2=20.47 //y2=7.585
r1031 (  260 267 ) resistor r=6.97548 //w=0.367 //l=0.2 //layer=li \
 //thickness=0.1 //x=20.3 //y=7.585 //x2=20.1 //y2=7.585
r1032 (  256 513 ) resistor r=23.2727 //w=0.187 //l=0.34 //layer=li \
 //thickness=0.1 //x=15.04 //y=6.575 //x2=15.04 //y2=6.235
r1033 (  249 251 ) resistor r=38.7139 //w=0.367 //l=1.11 //layer=li \
 //thickness=0.1 //x=15.29 //y=7.585 //x2=16.4 //y2=7.585
r1034 (  247 249 ) resistor r=38.7139 //w=0.367 //l=1.11 //layer=li \
 //thickness=0.1 //x=14.18 //y=7.585 //x2=15.29 //y2=7.585
r1035 (  245 479 ) resistor r=5.29055 //w=0.35 //l=0.17 //layer=li \
 //thickness=0.1 //x=13.98 //y=7.585 //x2=13.81 //y2=7.585
r1036 (  245 247 ) resistor r=6.97548 //w=0.367 //l=0.2 //layer=li \
 //thickness=0.1 //x=13.98 //y=7.585 //x2=14.18 //y2=7.585
r1037 (  244 480 ) resistor r=5.29055 //w=0.35 //l=0.17 //layer=li \
 //thickness=0.1 //x=16.97 //y=7.585 //x2=17.14 //y2=7.585
r1038 (  244 251 ) resistor r=19.8801 //w=0.367 //l=0.57 //layer=li \
 //thickness=0.1 //x=16.97 //y=7.585 //x2=16.4 //y2=7.585
r1039 (  241 478 ) resistor r=2.87058 //w=0.35 //l=0.085 //layer=li \
 //thickness=0.1 //x=13.23 //y=7.585 //x2=13.145 //y2=7.585
r1040 (  240 479 ) resistor r=5.29055 //w=0.35 //l=0.17 //layer=li \
 //thickness=0.1 //x=13.64 //y=7.585 //x2=13.81 //y2=7.585
r1041 (  240 241 ) resistor r=14.2997 //w=0.367 //l=0.41 //layer=li \
 //thickness=0.1 //x=13.64 //y=7.585 //x2=13.23 //y2=7.585
r1042 (  232 478 ) resistor r=4.23183 //w=0.7 //l=0.175 //layer=li \
 //thickness=0.1 //x=13.145 //y=7.41 //x2=13.145 //y2=7.585
r1043 (  232 512 ) resistor r=56.4706 //w=0.187 //l=0.825 //layer=li \
 //thickness=0.1 //x=13.145 //y=7.41 //x2=13.145 //y2=6.585
r1044 (  229 477 ) resistor r=2.87058 //w=0.35 //l=0.085 //layer=li \
 //thickness=0.1 //x=12.35 //y=7.585 //x2=12.265 //y2=7.585
r1045 (  229 231 ) resistor r=12.2071 //w=0.367 //l=0.35 //layer=li \
 //thickness=0.1 //x=12.35 //y=7.585 //x2=12.7 //y2=7.585
r1046 (  228 478 ) resistor r=2.87058 //w=0.35 //l=0.085 //layer=li \
 //thickness=0.1 //x=13.06 //y=7.585 //x2=13.145 //y2=7.585
r1047 (  228 231 ) resistor r=12.5559 //w=0.367 //l=0.36 //layer=li \
 //thickness=0.1 //x=13.06 //y=7.585 //x2=12.7 //y2=7.585
r1048 (  220 477 ) resistor r=4.23183 //w=0.7 //l=0.175 //layer=li \
 //thickness=0.1 //x=12.265 //y=7.41 //x2=12.265 //y2=7.585
r1049 (  220 511 ) resistor r=56.4706 //w=0.187 //l=0.825 //layer=li \
 //thickness=0.1 //x=12.265 //y=7.41 //x2=12.265 //y2=6.585
r1050 (  219 476 ) resistor r=5.29055 //w=0.35 //l=0.17 //layer=li \
 //thickness=0.1 //x=11.76 //y=7.585 //x2=11.59 //y2=7.585
r1051 (  218 477 ) resistor r=2.87058 //w=0.35 //l=0.085 //layer=li \
 //thickness=0.1 //x=12.18 //y=7.585 //x2=12.265 //y2=7.585
r1052 (  218 219 ) resistor r=14.6485 //w=0.367 //l=0.42 //layer=li \
 //thickness=0.1 //x=12.18 //y=7.585 //x2=11.76 //y2=7.585
r1053 (  213 475 ) resistor r=2.87058 //w=0.35 //l=0.085 //layer=li \
 //thickness=0.1 //x=11 //y=7.585 //x2=10.915 //y2=7.585
r1054 (  213 215 ) resistor r=7.67302 //w=0.367 //l=0.22 //layer=li \
 //thickness=0.1 //x=11 //y=7.585 //x2=11.22 //y2=7.585
r1055 (  212 476 ) resistor r=5.29055 //w=0.35 //l=0.17 //layer=li \
 //thickness=0.1 //x=11.42 //y=7.585 //x2=11.59 //y2=7.585
r1056 (  212 215 ) resistor r=6.97548 //w=0.367 //l=0.2 //layer=li \
 //thickness=0.1 //x=11.42 //y=7.585 //x2=11.22 //y2=7.585
r1057 (  204 475 ) resistor r=4.23183 //w=0.7 //l=0.175 //layer=li \
 //thickness=0.1 //x=10.915 //y=7.41 //x2=10.915 //y2=7.585
r1058 (  204 510 ) resistor r=56.4706 //w=0.187 //l=0.825 //layer=li \
 //thickness=0.1 //x=10.915 //y=7.41 //x2=10.915 //y2=6.585
r1059 (  203 474 ) resistor r=2.87058 //w=0.35 //l=0.085 //layer=li \
 //thickness=0.1 //x=10.12 //y=7.585 //x2=10.035 //y2=7.585
r1060 (  202 475 ) resistor r=2.87058 //w=0.35 //l=0.085 //layer=li \
 //thickness=0.1 //x=10.83 //y=7.585 //x2=10.915 //y2=7.585
r1061 (  202 203 ) resistor r=24.7629 //w=0.367 //l=0.71 //layer=li \
 //thickness=0.1 //x=10.83 //y=7.585 //x2=10.12 //y2=7.585
r1062 (  194 474 ) resistor r=4.23183 //w=0.7 //l=0.175 //layer=li \
 //thickness=0.1 //x=10.035 //y=7.41 //x2=10.035 //y2=7.585
r1063 (  194 509 ) resistor r=56.4706 //w=0.187 //l=0.825 //layer=li \
 //thickness=0.1 //x=10.035 //y=7.41 //x2=10.035 //y2=6.585
r1064 (  193 472 ) resistor r=5.29055 //w=0.35 //l=0.17 //layer=li \
 //thickness=0.1 //x=9.54 //y=7.585 //x2=9.37 //y2=7.585
r1065 (  192 474 ) resistor r=2.87058 //w=0.35 //l=0.085 //layer=li \
 //thickness=0.1 //x=9.95 //y=7.585 //x2=10.035 //y2=7.585
r1066 (  192 193 ) resistor r=14.2997 //w=0.367 //l=0.41 //layer=li \
 //thickness=0.1 //x=9.95 //y=7.585 //x2=9.54 //y2=7.585
r1067 (  188 508 ) resistor r=23.2727 //w=0.187 //l=0.34 //layer=li \
 //thickness=0.1 //x=7.27 //y=6.575 //x2=7.27 //y2=6.235
r1068 (  181 183 ) resistor r=38.7139 //w=0.367 //l=1.11 //layer=li \
 //thickness=0.1 //x=7.52 //y=7.585 //x2=8.63 //y2=7.585
r1069 (  179 181 ) resistor r=38.7139 //w=0.367 //l=1.11 //layer=li \
 //thickness=0.1 //x=6.41 //y=7.585 //x2=7.52 //y2=7.585
r1070 (  177 471 ) resistor r=5.29055 //w=0.35 //l=0.17 //layer=li \
 //thickness=0.1 //x=6.21 //y=7.585 //x2=6.04 //y2=7.585
r1071 (  177 179 ) resistor r=6.97548 //w=0.367 //l=0.2 //layer=li \
 //thickness=0.1 //x=6.21 //y=7.585 //x2=6.41 //y2=7.585
r1072 (  176 472 ) resistor r=5.29055 //w=0.35 //l=0.17 //layer=li \
 //thickness=0.1 //x=9.2 //y=7.585 //x2=9.37 //y2=7.585
r1073 (  176 183 ) resistor r=19.8801 //w=0.367 //l=0.57 //layer=li \
 //thickness=0.1 //x=9.2 //y=7.585 //x2=8.63 //y2=7.585
r1074 (  172 507 ) resistor r=23.2727 //w=0.187 //l=0.34 //layer=li \
 //thickness=0.1 //x=3.94 //y=6.575 //x2=3.94 //y2=6.235
r1075 (  165 167 ) resistor r=38.7139 //w=0.367 //l=1.11 //layer=li \
 //thickness=0.1 //x=3.82 //y=7.585 //x2=4.93 //y2=7.585
r1076 (  163 470 ) resistor r=5.29055 //w=0.35 //l=0.17 //layer=li \
 //thickness=0.1 //x=2.88 //y=7.585 //x2=2.71 //y2=7.585
r1077 (  163 165 ) resistor r=32.7847 //w=0.367 //l=0.94 //layer=li \
 //thickness=0.1 //x=2.88 //y=7.585 //x2=3.82 //y2=7.585
r1078 (  162 471 ) resistor r=5.29055 //w=0.35 //l=0.17 //layer=li \
 //thickness=0.1 //x=5.87 //y=7.585 //x2=6.04 //y2=7.585
r1079 (  162 167 ) resistor r=32.7847 //w=0.367 //l=0.94 //layer=li \
 //thickness=0.1 //x=5.87 //y=7.585 //x2=4.93 //y2=7.585
r1080 (  157 469 ) resistor r=2.87058 //w=0.35 //l=0.085 //layer=li \
 //thickness=0.1 //x=2.13 //y=7.585 //x2=2.045 //y2=7.585
r1081 (  157 159 ) resistor r=7.32425 //w=0.367 //l=0.21 //layer=li \
 //thickness=0.1 //x=2.13 //y=7.585 //x2=2.34 //y2=7.585
r1082 (  156 470 ) resistor r=5.29055 //w=0.35 //l=0.17 //layer=li \
 //thickness=0.1 //x=2.54 //y=7.585 //x2=2.71 //y2=7.585
r1083 (  156 159 ) resistor r=6.97548 //w=0.367 //l=0.2 //layer=li \
 //thickness=0.1 //x=2.54 //y=7.585 //x2=2.34 //y2=7.585
r1084 (  148 469 ) resistor r=4.23183 //w=0.7 //l=0.175 //layer=li \
 //thickness=0.1 //x=2.045 //y=7.41 //x2=2.045 //y2=7.585
r1085 (  148 506 ) resistor r=56.4706 //w=0.187 //l=0.825 //layer=li \
 //thickness=0.1 //x=2.045 //y=7.41 //x2=2.045 //y2=6.585
r1086 (  147 468 ) resistor r=2.87058 //w=0.35 //l=0.085 //layer=li \
 //thickness=0.1 //x=1.25 //y=7.585 //x2=1.165 //y2=7.585
r1087 (  146 469 ) resistor r=2.87058 //w=0.35 //l=0.085 //layer=li \
 //thickness=0.1 //x=1.96 //y=7.585 //x2=2.045 //y2=7.585
r1088 (  146 147 ) resistor r=24.7629 //w=0.367 //l=0.71 //layer=li \
 //thickness=0.1 //x=1.96 //y=7.585 //x2=1.25 //y2=7.585
r1089 (  138 468 ) resistor r=4.23183 //w=0.7 //l=0.175 //layer=li \
 //thickness=0.1 //x=1.165 //y=7.41 //x2=1.165 //y2=7.585
r1090 (  138 505 ) resistor r=56.4706 //w=0.187 //l=0.825 //layer=li \
 //thickness=0.1 //x=1.165 //y=7.41 //x2=1.165 //y2=6.585
r1091 (  129 527 ) resistor r=9.3 //w=0.17 //l=0.17 //layer=mcon //count=1 \
 //x=35.02 //y=6.92 //x2=35.02 //y2=6.92
r1092 (  110 272 ) resistor r=9.3 //w=0.17 //l=0.17 //layer=mcon //count=1 \
 //x=18.37 //y=6.575 //x2=18.37 //y2=6.575
r1093 (  107 256 ) resistor r=9.3 //w=0.17 //l=0.17 //layer=mcon //count=1 \
 //x=15.04 //y=6.575 //x2=15.04 //y2=6.575
r1094 (  96 188 ) resistor r=9.3 //w=0.17 //l=0.17 //layer=mcon //count=1 \
 //x=7.27 //y=6.575 //x2=7.27 //y2=6.575
r1095 (  93 172 ) resistor r=9.3 //w=0.17 //l=0.17 //layer=mcon //count=1 \
 //x=3.94 //y=6.575 //x2=3.94 //y2=6.575
r1096 (  85 464 ) resistor r=9.3 //w=0.17 //l=0.17 //layer=mcon //count=1 \
 //x=38.97 //y=7.58 //x2=38.97 //y2=7.58
r1097 (  83 452 ) resistor r=3.1 //w=0.17 //l=0.51 //layer=mcon //count=3 \
 //x=38.23 //y=7.58 //x2=38.23 //y2=7.58
r1098 (  83 85 ) resistor r=0.297428 //w=0.311 //l=0.74 //layer=m1 \
 //thickness=0.36 //x=38.23 //y=7.585 //x2=38.97 //y2=7.585
r1099 (  81 429 ) resistor r=3.1 //w=0.17 //l=0.51 //layer=mcon //count=3 \
 //x=36.75 //y=7.58 //x2=36.75 //y2=7.58
r1100 (  81 83 ) resistor r=0.594855 //w=0.311 //l=1.48 //layer=m1 \
 //thickness=0.36 //x=36.75 //y=7.585 //x2=38.23 //y2=7.585
r1101 (  79 427 ) resistor r=3.1 //w=0.17 //l=0.51 //layer=mcon //count=3 \
 //x=35.64 //y=7.58 //x2=35.64 //y2=7.58
r1102 (  79 81 ) resistor r=0.446141 //w=0.311 //l=1.11 //layer=m1 \
 //thickness=0.36 //x=35.64 //y=7.585 //x2=36.75 //y2=7.585
r1103 (  77 127 ) resistor r=0.028033 //w=0.35 //l=0.085 //layer=m1 \
 //thickness=0.36 //x=35.105 //y=7.585 //x2=35.02 //y2=7.585
r1104 (  77 79 ) resistor r=0.215032 //w=0.311 //l=0.535 //layer=m1 \
 //thickness=0.36 //x=35.105 //y=7.585 //x2=35.64 //y2=7.585
r1105 (  76 127 ) resistor r=0.0413265 //w=0.7 //l=0.175 //layer=m1 \
 //thickness=0.36 //x=35.02 //y=7.41 //x2=35.02 //y2=7.585
r1106 (  75 129 ) resistor r=0.0723371 //w=0.218 //l=0.115 //layer=m1 \
 //thickness=0.36 //x=35.02 //y=7.035 //x2=35.02 //y2=6.92
r1107 (  75 76 ) resistor r=0.357824 //w=0.131 //l=0.375 //layer=m1 \
 //thickness=0.36 //x=35.02 //y=7.035 //x2=35.02 //y2=7.41
r1108 (  74 425 ) resistor r=3.1 //w=0.17 //l=0.51 //layer=mcon //count=3 \
 //x=34.53 //y=7.58 //x2=34.53 //y2=7.58
r1109 (  72 500 ) resistor r=3.1 //w=0.17 //l=0.51 //layer=mcon //count=3 \
 //x=33.05 //y=7.58 //x2=33.05 //y2=7.58
r1110 (  72 74 ) resistor r=0.594855 //w=0.311 //l=1.48 //layer=m1 \
 //thickness=0.36 //x=33.05 //y=7.585 //x2=34.53 //y2=7.585
r1111 (  70 399 ) resistor r=3.1 //w=0.17 //l=0.51 //layer=mcon //count=3 \
 //x=31.94 //y=7.58 //x2=31.94 //y2=7.58
r1112 (  70 72 ) resistor r=0.446141 //w=0.311 //l=1.11 //layer=m1 \
 //thickness=0.36 //x=31.94 //y=7.585 //x2=33.05 //y2=7.585
r1113 (  68 385 ) resistor r=3.1 //w=0.17 //l=0.51 //layer=mcon //count=3 \
 //x=30.46 //y=7.58 //x2=30.46 //y2=7.58
r1114 (  68 70 ) resistor r=0.594855 //w=0.311 //l=1.48 //layer=m1 \
 //thickness=0.36 //x=30.46 //y=7.585 //x2=31.94 //y2=7.585
r1115 (  66 375 ) resistor r=3.1 //w=0.17 //l=0.51 //layer=mcon //count=3 \
 //x=29.35 //y=7.58 //x2=29.35 //y2=7.58
r1116 (  66 68 ) resistor r=0.446141 //w=0.311 //l=1.11 //layer=m1 \
 //thickness=0.36 //x=29.35 //y=7.585 //x2=30.46 //y2=7.585
r1117 (  64 359 ) resistor r=3.1 //w=0.17 //l=0.51 //layer=mcon //count=3 \
 //x=27.87 //y=7.58 //x2=27.87 //y2=7.58
r1118 (  64 66 ) resistor r=0.594855 //w=0.311 //l=1.48 //layer=m1 \
 //thickness=0.36 //x=27.87 //y=7.585 //x2=29.35 //y2=7.585
r1119 (  62 491 ) resistor r=3.1 //w=0.17 //l=0.51 //layer=mcon //count=3 \
 //x=26.76 //y=7.58 //x2=26.76 //y2=7.58
r1120 (  62 64 ) resistor r=0.446141 //w=0.311 //l=1.11 //layer=m1 \
 //thickness=0.36 //x=26.76 //y=7.585 //x2=27.87 //y2=7.585
r1121 (  60 488 ) resistor r=3.1 //w=0.17 //l=0.51 //layer=mcon //count=3 \
 //x=25.28 //y=7.58 //x2=25.28 //y2=7.58
r1122 (  60 62 ) resistor r=0.594855 //w=0.311 //l=1.48 //layer=m1 \
 //thickness=0.36 //x=25.28 //y=7.585 //x2=26.76 //y2=7.585
r1123 (  58 317 ) resistor r=3.1 //w=0.17 //l=0.51 //layer=mcon //count=3 \
 //x=24.17 //y=7.58 //x2=24.17 //y2=7.58
r1124 (  58 60 ) resistor r=0.446141 //w=0.311 //l=1.11 //layer=m1 \
 //thickness=0.36 //x=24.17 //y=7.585 //x2=25.28 //y2=7.585
r1125 (  56 305 ) resistor r=3.1 //w=0.17 //l=0.51 //layer=mcon //count=3 \
 //x=23.06 //y=7.58 //x2=23.06 //y2=7.58
r1126 (  56 58 ) resistor r=0.446141 //w=0.311 //l=1.11 //layer=m1 \
 //thickness=0.36 //x=23.06 //y=7.585 //x2=24.17 //y2=7.585
r1127 (  54 289 ) resistor r=3.1 //w=0.17 //l=0.51 //layer=mcon //count=3 \
 //x=21.58 //y=7.58 //x2=21.58 //y2=7.58
r1128 (  54 56 ) resistor r=0.594855 //w=0.311 //l=1.48 //layer=m1 \
 //thickness=0.36 //x=21.58 //y=7.585 //x2=23.06 //y2=7.585
r1129 (  52 267 ) resistor r=3.1 //w=0.17 //l=0.51 //layer=mcon //count=3 \
 //x=20.1 //y=7.58 //x2=20.1 //y2=7.58
r1130 (  52 54 ) resistor r=0.594855 //w=0.311 //l=1.48 //layer=m1 \
 //thickness=0.36 //x=20.1 //y=7.585 //x2=21.58 //y2=7.585
r1131 (  49 265 ) resistor r=3.1 //w=0.17 //l=0.51 //layer=mcon //count=3 \
 //x=18.99 //y=7.58 //x2=18.99 //y2=7.58
r1132 (  47 108 ) resistor r=0.028033 //w=0.35 //l=0.085 //layer=m1 \
 //thickness=0.36 //x=18.455 //y=7.585 //x2=18.37 //y2=7.585
r1133 (  47 49 ) resistor r=0.215032 //w=0.311 //l=0.535 //layer=m1 \
 //thickness=0.36 //x=18.455 //y=7.585 //x2=18.99 //y2=7.585
r1134 (  46 127 ) resistor r=0.028033 //w=0.35 //l=0.085 //layer=m1 \
 //thickness=0.36 //x=34.935 //y=7.585 //x2=35.02 //y2=7.585
r1135 (  46 74 ) resistor r=0.162781 //w=0.311 //l=0.405 //layer=m1 \
 //thickness=0.36 //x=34.935 //y=7.585 //x2=34.53 //y2=7.585
r1136 (  45 108 ) resistor r=0.0413265 //w=0.7 //l=0.175 //layer=m1 \
 //thickness=0.36 //x=18.37 //y=7.41 //x2=18.37 //y2=7.585
r1137 (  44 110 ) resistor r=0.0717383 //w=0.224 //l=0.115 //layer=m1 \
 //thickness=0.36 //x=18.37 //y=6.69 //x2=18.37 //y2=6.575
r1138 (  44 45 ) resistor r=0.687023 //w=0.131 //l=0.72 //layer=m1 \
 //thickness=0.36 //x=18.37 //y=6.69 //x2=18.37 //y2=7.41
r1139 (  43 263 ) resistor r=3.1 //w=0.17 //l=0.51 //layer=mcon //count=3 \
 //x=17.88 //y=7.58 //x2=17.88 //y2=7.58
r1140 (  41 251 ) resistor r=3.1 //w=0.17 //l=0.51 //layer=mcon //count=3 \
 //x=16.4 //y=7.58 //x2=16.4 //y2=7.58
r1141 (  41 43 ) resistor r=0.594855 //w=0.311 //l=1.48 //layer=m1 \
 //thickness=0.36 //x=16.4 //y=7.585 //x2=17.88 //y2=7.585
r1142 (  39 249 ) resistor r=3.1 //w=0.17 //l=0.51 //layer=mcon //count=3 \
 //x=15.29 //y=7.58 //x2=15.29 //y2=7.58
r1143 (  39 41 ) resistor r=0.446141 //w=0.311 //l=1.11 //layer=m1 \
 //thickness=0.36 //x=15.29 //y=7.585 //x2=16.4 //y2=7.585
r1144 (  37 105 ) resistor r=0.028033 //w=0.35 //l=0.085 //layer=m1 \
 //thickness=0.36 //x=15.125 //y=7.585 //x2=15.04 //y2=7.585
r1145 (  37 39 ) resistor r=0.0663183 //w=0.311 //l=0.165 //layer=m1 \
 //thickness=0.36 //x=15.125 //y=7.585 //x2=15.29 //y2=7.585
r1146 (  36 108 ) resistor r=0.028033 //w=0.35 //l=0.085 //layer=m1 \
 //thickness=0.36 //x=18.285 //y=7.585 //x2=18.37 //y2=7.585
r1147 (  36 43 ) resistor r=0.162781 //w=0.311 //l=0.405 //layer=m1 \
 //thickness=0.36 //x=18.285 //y=7.585 //x2=17.88 //y2=7.585
r1148 (  35 105 ) resistor r=0.0413265 //w=0.7 //l=0.175 //layer=m1 \
 //thickness=0.36 //x=15.04 //y=7.41 //x2=15.04 //y2=7.585
r1149 (  34 107 ) resistor r=0.0773187 //w=0.224 //l=0.125 //layer=m1 \
 //thickness=0.36 //x=15.04 //y=6.7 //x2=15.04 //y2=6.575
r1150 (  34 35 ) resistor r=0.677481 //w=0.131 //l=0.71 //layer=m1 \
 //thickness=0.36 //x=15.04 //y=6.7 //x2=15.04 //y2=7.41
r1151 (  33 247 ) resistor r=3.1 //w=0.17 //l=0.51 //layer=mcon //count=3 \
 //x=14.18 //y=7.58 //x2=14.18 //y2=7.58
r1152 (  31 231 ) resistor r=3.1 //w=0.17 //l=0.51 //layer=mcon //count=3 \
 //x=12.7 //y=7.58 //x2=12.7 //y2=7.58
r1153 (  31 33 ) resistor r=0.594855 //w=0.311 //l=1.48 //layer=m1 \
 //thickness=0.36 //x=12.7 //y=7.585 //x2=14.18 //y2=7.585
r1154 (  29 215 ) resistor r=3.1 //w=0.17 //l=0.51 //layer=mcon //count=3 \
 //x=11.22 //y=7.58 //x2=11.22 //y2=7.58
r1155 (  29 31 ) resistor r=0.594855 //w=0.311 //l=1.48 //layer=m1 \
 //thickness=0.36 //x=11.22 //y=7.585 //x2=12.7 //y2=7.585
r1156 (  27 474 ) resistor r=3.1 //w=0.17 //l=0.51 //layer=mcon //count=3 \
 //x=10.11 //y=7.58 //x2=10.11 //y2=7.58
r1157 (  27 29 ) resistor r=0.446141 //w=0.311 //l=1.11 //layer=m1 \
 //thickness=0.36 //x=10.11 //y=7.585 //x2=11.22 //y2=7.585
r1158 (  25 183 ) resistor r=3.1 //w=0.17 //l=0.51 //layer=mcon //count=3 \
 //x=8.63 //y=7.58 //x2=8.63 //y2=7.58
r1159 (  25 27 ) resistor r=0.594855 //w=0.311 //l=1.48 //layer=m1 \
 //thickness=0.36 //x=8.63 //y=7.585 //x2=10.11 //y2=7.585
r1160 (  23 181 ) resistor r=3.1 //w=0.17 //l=0.51 //layer=mcon //count=3 \
 //x=7.52 //y=7.58 //x2=7.52 //y2=7.58
r1161 (  23 25 ) resistor r=0.446141 //w=0.311 //l=1.11 //layer=m1 \
 //thickness=0.36 //x=7.52 //y=7.585 //x2=8.63 //y2=7.585
r1162 (  21 94 ) resistor r=0.028033 //w=0.35 //l=0.085 //layer=m1 \
 //thickness=0.36 //x=7.355 //y=7.585 //x2=7.27 //y2=7.585
r1163 (  21 23 ) resistor r=0.0663183 //w=0.311 //l=0.165 //layer=m1 \
 //thickness=0.36 //x=7.355 //y=7.585 //x2=7.52 //y2=7.585
r1164 (  20 105 ) resistor r=0.028033 //w=0.35 //l=0.085 //layer=m1 \
 //thickness=0.36 //x=14.955 //y=7.585 //x2=15.04 //y2=7.585
r1165 (  20 33 ) resistor r=0.311495 //w=0.311 //l=0.775 //layer=m1 \
 //thickness=0.36 //x=14.955 //y=7.585 //x2=14.18 //y2=7.585
r1166 (  19 94 ) resistor r=0.0413265 //w=0.7 //l=0.175 //layer=m1 \
 //thickness=0.36 //x=7.27 //y=7.41 //x2=7.27 //y2=7.585
r1167 (  18 96 ) resistor r=0.0717383 //w=0.224 //l=0.115 //layer=m1 \
 //thickness=0.36 //x=7.27 //y=6.69 //x2=7.27 //y2=6.575
r1168 (  18 19 ) resistor r=0.687023 //w=0.131 //l=0.72 //layer=m1 \
 //thickness=0.36 //x=7.27 //y=6.69 //x2=7.27 //y2=7.41
r1169 (  17 179 ) resistor r=3.1 //w=0.17 //l=0.51 //layer=mcon //count=3 \
 //x=6.41 //y=7.58 //x2=6.41 //y2=7.58
r1170 (  15 167 ) resistor r=3.1 //w=0.17 //l=0.51 //layer=mcon //count=3 \
 //x=4.93 //y=7.58 //x2=4.93 //y2=7.58
r1171 (  15 17 ) resistor r=0.594855 //w=0.311 //l=1.48 //layer=m1 \
 //thickness=0.36 //x=4.93 //y=7.585 //x2=6.41 //y2=7.585
r1172 (  13 91 ) resistor r=0.028033 //w=0.35 //l=0.085 //layer=m1 \
 //thickness=0.36 //x=4.025 //y=7.585 //x2=3.94 //y2=7.585
r1173 (  13 15 ) resistor r=0.363746 //w=0.311 //l=0.905 //layer=m1 \
 //thickness=0.36 //x=4.025 //y=7.585 //x2=4.93 //y2=7.585
r1174 (  12 94 ) resistor r=0.028033 //w=0.35 //l=0.085 //layer=m1 \
 //thickness=0.36 //x=7.185 //y=7.585 //x2=7.27 //y2=7.585
r1175 (  12 17 ) resistor r=0.311495 //w=0.311 //l=0.775 //layer=m1 \
 //thickness=0.36 //x=7.185 //y=7.585 //x2=6.41 //y2=7.585
r1176 (  11 91 ) resistor r=0.0413265 //w=0.7 //l=0.175 //layer=m1 \
 //thickness=0.36 //x=3.94 //y=7.41 //x2=3.94 //y2=7.585
r1177 (  10 93 ) resistor r=0.0773187 //w=0.224 //l=0.125 //layer=m1 \
 //thickness=0.36 //x=3.94 //y=6.7 //x2=3.94 //y2=6.575
r1178 (  10 11 ) resistor r=0.677481 //w=0.131 //l=0.71 //layer=m1 \
 //thickness=0.36 //x=3.94 //y=6.7 //x2=3.94 //y2=7.41
r1179 (  9 165 ) resistor r=3.1 //w=0.17 //l=0.51 //layer=mcon //count=3 \
 //x=3.82 //y=7.58 //x2=3.82 //y2=7.58
r1180 (  7 159 ) resistor r=3.1 //w=0.17 //l=0.51 //layer=mcon //count=3 \
 //x=2.34 //y=7.58 //x2=2.34 //y2=7.58
r1181 (  7 9 ) resistor r=0.594855 //w=0.311 //l=1.48 //layer=m1 \
 //thickness=0.36 //x=2.34 //y=7.585 //x2=3.82 //y2=7.585
r1182 (  4 468 ) resistor r=3.1 //w=0.17 //l=0.51 //layer=mcon //count=3 \
 //x=1.23 //y=7.58 //x2=1.23 //y2=7.58
r1183 (  4 7 ) resistor r=0.446141 //w=0.311 //l=1.11 //layer=m1 \
 //thickness=0.36 //x=1.23 //y=7.585 //x2=2.34 //y2=7.585
r1184 (  2 91 ) resistor r=0.028033 //w=0.35 //l=0.085 //layer=m1 \
 //thickness=0.36 //x=3.855 //y=7.585 //x2=3.94 //y2=7.585
r1185 (  2 9 ) resistor r=0.0140675 //w=0.311 //l=0.035 //layer=m1 \
 //thickness=0.36 //x=3.855 //y=7.585 //x2=3.82 //y2=7.585
r1186 (  1 52 ) resistor r=0.0743569 //w=0.311 //l=0.185 //layer=m1 \
 //thickness=0.36 //x=19.915 //y=7.585 //x2=20.1 //y2=7.585
r1187 (  1 49 ) resistor r=0.371785 //w=0.311 //l=0.925 //layer=m1 \
 //thickness=0.36 //x=19.915 //y=7.585 //x2=18.99 //y2=7.585
ends PM_FA\%VDD

subckt PM_FA\%noxref_16 ( 1 3 5 10 14 17 20 30 46 47 48 )
c80 ( 48 0 ) capacitor c=0.0367727f //x=5.115 //y=5.2
c81 ( 46 0 ) capacitor c=0.0184616f //x=3.365 //y=5.2
c82 ( 30 0 ) capacitor c=0.0317225f //x=4.38 //y=5.555
c83 ( 20 0 ) capacitor c=0.0447371f //x=3.5 //y=5.555
c84 ( 17 0 ) capacitor c=0.0100496f //x=5.26 //y=6.915
c85 ( 14 0 ) capacitor c=0.00636436f //x=4.38 //y=6.915
c86 ( 10 0 ) capacitor c=0.0123428f //x=4.38 //y=5.385
c87 ( 5 0 ) capacitor c=0.0123915f //x=3.507 //y=5.385
c88 ( 3 0 ) capacitor c=0.00891704f //x=5.145 //y=7.085
c89 ( 1 0 ) capacitor c=0.0141892f //x=4.26 //y=5.385
r90 (  37 47 ) resistor r=23.2727 //w=0.187 //l=0.34 //layer=li \
 //thickness=0.1 //x=4.38 //y=6.915 //x2=4.38 //y2=6.575
r91 (  30 47 ) resistor r=23.2727 //w=0.187 //l=0.34 //layer=li \
 //thickness=0.1 //x=4.38 //y=5.555 //x2=4.38 //y2=5.895
r92 (  20 46 ) resistor r=23.2727 //w=0.187 //l=0.34 //layer=li \
 //thickness=0.1 //x=3.5 //y=5.555 //x2=3.5 //y2=5.895
r93 (  17 48 ) resistor r=9.3 //w=0.17 //l=0.17 //layer=mcon //count=1 \
 //x=5.26 //y=6.915 //x2=5.26 //y2=6.915
r94 (  17 18 ) resistor r=0.0997653 //w=0.213 //l=0.17 //layer=m1 \
 //thickness=0.36 //x=5.26 //y=6.915 //x2=5.26 //y2=7.085
r95 (  14 37 ) resistor r=9.3 //w=0.17 //l=0.17 //layer=mcon //count=1 \
 //x=4.38 //y=6.915 //x2=4.38 //y2=6.915
r96 (  14 15 ) resistor r=0.100236 //w=0.212 //l=0.17 //layer=m1 \
 //thickness=0.36 //x=4.38 //y=6.915 //x2=4.38 //y2=7.085
r97 (  12 30 ) resistor r=9.3 //w=0.17 //l=0.17 //layer=mcon //count=1 \
 //x=4.38 //y=5.555 //x2=4.38 //y2=5.555
r98 (  10 12 ) resistor r=0.0965909 //w=0.22 //l=0.17 //layer=m1 \
 //thickness=0.36 //x=4.38 //y=5.385 //x2=4.38 //y2=5.555
r99 (  7 20 ) resistor r=9.3 //w=0.17 //l=0.17 //layer=mcon //count=1 //x=3.5 \
 //y=5.555 //x2=3.5 //y2=5.555
r100 (  5 7 ) resistor r=0.0912017 //w=0.233 //l=0.17 //layer=m1 \
 //thickness=0.36 //x=3.507 //y=5.385 //x2=3.507 //y2=5.555
r101 (  4 15 ) resistor r=0.0208269 //w=0.212 //l=0.115 //layer=m1 \
 //thickness=0.36 //x=4.495 //y=7.085 //x2=4.38 //y2=7.085
r102 (  3 18 ) resistor r=0.0211096 //w=0.213 //l=0.115 //layer=m1 \
 //thickness=0.36 //x=5.145 //y=7.085 //x2=5.26 //y2=7.085
r103 (  3 4 ) resistor r=0.620229 //w=0.131 //l=0.65 //layer=m1 \
 //thickness=0.36 //x=5.145 //y=7.085 //x2=4.495 //y2=7.085
r104 (  2 5 ) resistor r=0.0264833 //w=0.233 //l=0.128 //layer=m1 \
 //thickness=0.36 //x=3.635 //y=5.385 //x2=3.507 //y2=5.385
r105 (  1 10 ) resistor r=0.0230492 //w=0.22 //l=0.12 //layer=m1 \
 //thickness=0.36 //x=4.26 //y=5.385 //x2=4.38 //y2=5.385
r106 (  1 2 ) resistor r=0.596374 //w=0.131 //l=0.625 //layer=m1 \
 //thickness=0.36 //x=4.26 //y=5.385 //x2=3.635 //y2=5.385
ends PM_FA\%noxref_16

subckt PM_FA\%noxref_17 ( 1 3 5 10 14 17 20 30 46 47 48 )
c78 ( 48 0 ) capacitor c=0.0344743f //x=8.445 //y=5.2
c79 ( 46 0 ) capacitor c=0.0123991f //x=6.695 //y=5.2
c80 ( 30 0 ) capacitor c=0.0304667f //x=7.71 //y=5.555
c81 ( 20 0 ) capacitor c=0.0472305f //x=6.83 //y=5.555
c82 ( 17 0 ) capacitor c=0.0161402f //x=8.59 //y=6.915
c83 ( 14 0 ) capacitor c=0.00620376f //x=7.71 //y=6.915
c84 ( 10 0 ) capacitor c=0.0090232f //x=7.71 //y=5.385
c85 ( 5 0 ) capacitor c=0.0125427f //x=6.83 //y=5.385
c86 ( 3 0 ) capacitor c=0.00902211f //x=8.47 //y=7.085
c87 ( 1 0 ) capacitor c=0.012948f //x=7.595 //y=5.385
r88 (  37 47 ) resistor r=23.2727 //w=0.187 //l=0.34 //layer=li \
 //thickness=0.1 //x=7.71 //y=6.915 //x2=7.71 //y2=6.575
r89 (  30 47 ) resistor r=23.2727 //w=0.187 //l=0.34 //layer=li \
 //thickness=0.1 //x=7.71 //y=5.555 //x2=7.71 //y2=5.895
r90 (  20 46 ) resistor r=23.2727 //w=0.187 //l=0.34 //layer=li \
 //thickness=0.1 //x=6.83 //y=5.555 //x2=6.83 //y2=5.895
r91 (  17 48 ) resistor r=9.3 //w=0.17 //l=0.17 //layer=mcon //count=1 \
 //x=8.59 //y=6.915 //x2=8.59 //y2=6.915
r92 (  17 18 ) resistor r=0.097032 //w=0.219 //l=0.17 //layer=m1 \
 //thickness=0.36 //x=8.587 //y=6.915 //x2=8.587 //y2=7.085
r93 (  14 37 ) resistor r=9.3 //w=0.17 //l=0.17 //layer=mcon //count=1 \
 //x=7.71 //y=6.915 //x2=7.71 //y2=6.915
r94 (  14 15 ) resistor r=0.100236 //w=0.212 //l=0.17 //layer=m1 \
 //thickness=0.36 //x=7.71 //y=6.915 //x2=7.71 //y2=7.085
r95 (  12 30 ) resistor r=9.3 //w=0.17 //l=0.17 //layer=mcon //count=1 \
 //x=7.71 //y=5.555 //x2=7.71 //y2=5.555
r96 (  10 12 ) resistor r=0.100236 //w=0.212 //l=0.17 //layer=m1 \
 //thickness=0.36 //x=7.71 //y=5.385 //x2=7.71 //y2=5.555
r97 (  7 20 ) resistor r=9.3 //w=0.17 //l=0.17 //layer=mcon //count=1 //x=6.83 \
 //y=5.555 //x2=6.83 //y2=5.555
r98 (  5 7 ) resistor r=0.100236 //w=0.212 //l=0.17 //layer=m1 \
 //thickness=0.36 //x=6.83 //y=5.385 //x2=6.83 //y2=5.555
r99 (  4 15 ) resistor r=0.0208269 //w=0.212 //l=0.115 //layer=m1 \
 //thickness=0.36 //x=7.825 //y=7.085 //x2=7.71 //y2=7.085
r100 (  3 18 ) resistor r=0.0227762 //w=0.219 //l=0.117 //layer=m1 \
 //thickness=0.36 //x=8.47 //y=7.085 //x2=8.587 //y2=7.085
r101 (  3 4 ) resistor r=0.615458 //w=0.131 //l=0.645 //layer=m1 \
 //thickness=0.36 //x=8.47 //y=7.085 //x2=7.825 //y2=7.085
r102 (  2 5 ) resistor r=0.0208269 //w=0.212 //l=0.115 //layer=m1 \
 //thickness=0.36 //x=6.945 //y=5.385 //x2=6.83 //y2=5.385
r103 (  1 10 ) resistor r=0.0208269 //w=0.212 //l=0.115 //layer=m1 \
 //thickness=0.36 //x=7.595 //y=5.385 //x2=7.71 //y2=5.385
r104 (  1 2 ) resistor r=0.620229 //w=0.131 //l=0.65 //layer=m1 \
 //thickness=0.36 //x=7.595 //y=5.385 //x2=6.945 //y2=5.385
ends PM_FA\%noxref_17

subckt PM_FA\%noxref_18 ( 1 3 5 10 14 17 20 30 46 47 48 )
c81 ( 48 0 ) capacitor c=0.0367727f //x=16.215 //y=5.2
c82 ( 46 0 ) capacitor c=0.0184614f //x=14.465 //y=5.2
c83 ( 30 0 ) capacitor c=0.0304314f //x=15.48 //y=5.555
c84 ( 20 0 ) capacitor c=0.0447371f //x=14.6 //y=5.555
c85 ( 17 0 ) capacitor c=0.00971874f //x=16.36 //y=6.915
c86 ( 14 0 ) capacitor c=0.00636412f //x=15.48 //y=6.915
c87 ( 10 0 ) capacitor c=0.00927198f //x=15.48 //y=5.385
c88 ( 5 0 ) capacitor c=0.012022f //x=14.607 //y=5.385
c89 ( 3 0 ) capacitor c=0.00737158f //x=16.245 //y=7.085
c90 ( 1 0 ) capacitor c=0.0129451f //x=15.36 //y=5.385
r91 (  37 47 ) resistor r=23.2727 //w=0.187 //l=0.34 //layer=li \
 //thickness=0.1 //x=15.48 //y=6.915 //x2=15.48 //y2=6.575
r92 (  30 47 ) resistor r=23.2727 //w=0.187 //l=0.34 //layer=li \
 //thickness=0.1 //x=15.48 //y=5.555 //x2=15.48 //y2=5.895
r93 (  20 46 ) resistor r=23.2727 //w=0.187 //l=0.34 //layer=li \
 //thickness=0.1 //x=14.6 //y=5.555 //x2=14.6 //y2=5.895
r94 (  17 48 ) resistor r=9.3 //w=0.17 //l=0.17 //layer=mcon //count=1 \
 //x=16.36 //y=6.915 //x2=16.36 //y2=6.915
r95 (  17 18 ) resistor r=0.0997653 //w=0.213 //l=0.17 //layer=m1 \
 //thickness=0.36 //x=16.36 //y=6.915 //x2=16.36 //y2=7.085
r96 (  14 37 ) resistor r=9.3 //w=0.17 //l=0.17 //layer=mcon //count=1 \
 //x=15.48 //y=6.915 //x2=15.48 //y2=6.915
r97 (  14 15 ) resistor r=0.100236 //w=0.212 //l=0.17 //layer=m1 \
 //thickness=0.36 //x=15.48 //y=6.915 //x2=15.48 //y2=7.085
r98 (  12 30 ) resistor r=9.3 //w=0.17 //l=0.17 //layer=mcon //count=1 \
 //x=15.48 //y=5.555 //x2=15.48 //y2=5.555
r99 (  10 12 ) resistor r=0.0965909 //w=0.22 //l=0.17 //layer=m1 \
 //thickness=0.36 //x=15.48 //y=5.385 //x2=15.48 //y2=5.555
r100 (  7 20 ) resistor r=9.3 //w=0.17 //l=0.17 //layer=mcon //count=1 \
 //x=14.6 //y=5.555 //x2=14.6 //y2=5.555
r101 (  5 7 ) resistor r=0.0912017 //w=0.233 //l=0.17 //layer=m1 \
 //thickness=0.36 //x=14.607 //y=5.385 //x2=14.607 //y2=5.555
r102 (  4 15 ) resistor r=0.0208269 //w=0.212 //l=0.115 //layer=m1 \
 //thickness=0.36 //x=15.595 //y=7.085 //x2=15.48 //y2=7.085
r103 (  3 18 ) resistor r=0.0211096 //w=0.213 //l=0.115 //layer=m1 \
 //thickness=0.36 //x=16.245 //y=7.085 //x2=16.36 //y2=7.085
r104 (  3 4 ) resistor r=0.620229 //w=0.131 //l=0.65 //layer=m1 \
 //thickness=0.36 //x=16.245 //y=7.085 //x2=15.595 //y2=7.085
r105 (  2 5 ) resistor r=0.0264833 //w=0.233 //l=0.128 //layer=m1 \
 //thickness=0.36 //x=14.735 //y=5.385 //x2=14.607 //y2=5.385
r106 (  1 10 ) resistor r=0.0230492 //w=0.22 //l=0.12 //layer=m1 \
 //thickness=0.36 //x=15.36 //y=5.385 //x2=15.48 //y2=5.385
r107 (  1 2 ) resistor r=0.596374 //w=0.131 //l=0.625 //layer=m1 \
 //thickness=0.36 //x=15.36 //y=5.385 //x2=14.735 //y2=5.385
ends PM_FA\%noxref_18

subckt PM_FA\%noxref_19 ( 1 3 5 10 14 17 20 30 46 47 48 )
c81 ( 48 0 ) capacitor c=0.0344743f //x=19.545 //y=5.2
c82 ( 46 0 ) capacitor c=0.0122389f //x=17.795 //y=5.2
c83 ( 30 0 ) capacitor c=0.0304667f //x=18.81 //y=5.555
c84 ( 20 0 ) capacitor c=0.0472305f //x=17.93 //y=5.555
c85 ( 17 0 ) capacitor c=0.0158135f //x=19.69 //y=6.915
c86 ( 14 0 ) capacitor c=0.0062032f //x=18.81 //y=6.915
c87 ( 10 0 ) capacitor c=0.00888865f //x=18.81 //y=5.385
c88 ( 5 0 ) capacitor c=0.0110127f //x=17.93 //y=5.385
c89 ( 3 0 ) capacitor c=0.00764555f //x=19.57 //y=7.085
c90 ( 1 0 ) capacitor c=0.014139f //x=18.695 //y=5.385
r91 (  37 47 ) resistor r=23.2727 //w=0.187 //l=0.34 //layer=li \
 //thickness=0.1 //x=18.81 //y=6.915 //x2=18.81 //y2=6.575
r92 (  30 47 ) resistor r=23.2727 //w=0.187 //l=0.34 //layer=li \
 //thickness=0.1 //x=18.81 //y=5.555 //x2=18.81 //y2=5.895
r93 (  20 46 ) resistor r=23.2727 //w=0.187 //l=0.34 //layer=li \
 //thickness=0.1 //x=17.93 //y=5.555 //x2=17.93 //y2=5.895
r94 (  17 48 ) resistor r=9.3 //w=0.17 //l=0.17 //layer=mcon //count=1 \
 //x=19.69 //y=6.915 //x2=19.69 //y2=6.915
r95 (  17 18 ) resistor r=0.097032 //w=0.219 //l=0.17 //layer=m1 \
 //thickness=0.36 //x=19.687 //y=6.915 //x2=19.687 //y2=7.085
r96 (  14 37 ) resistor r=9.3 //w=0.17 //l=0.17 //layer=mcon //count=1 \
 //x=18.81 //y=6.915 //x2=18.81 //y2=6.915
r97 (  14 15 ) resistor r=0.100236 //w=0.212 //l=0.17 //layer=m1 \
 //thickness=0.36 //x=18.81 //y=6.915 //x2=18.81 //y2=7.085
r98 (  12 30 ) resistor r=9.3 //w=0.17 //l=0.17 //layer=mcon //count=1 \
 //x=18.81 //y=5.555 //x2=18.81 //y2=5.555
r99 (  10 12 ) resistor r=0.100236 //w=0.212 //l=0.17 //layer=m1 \
 //thickness=0.36 //x=18.81 //y=5.385 //x2=18.81 //y2=5.555
r100 (  7 20 ) resistor r=9.3 //w=0.17 //l=0.17 //layer=mcon //count=1 \
 //x=17.93 //y=5.555 //x2=17.93 //y2=5.555
r101 (  5 7 ) resistor r=0.100236 //w=0.212 //l=0.17 //layer=m1 \
 //thickness=0.36 //x=17.93 //y=5.385 //x2=17.93 //y2=5.555
r102 (  4 15 ) resistor r=0.0208269 //w=0.212 //l=0.115 //layer=m1 \
 //thickness=0.36 //x=18.925 //y=7.085 //x2=18.81 //y2=7.085
r103 (  3 18 ) resistor r=0.0227762 //w=0.219 //l=0.117 //layer=m1 \
 //thickness=0.36 //x=19.57 //y=7.085 //x2=19.687 //y2=7.085
r104 (  3 4 ) resistor r=0.615458 //w=0.131 //l=0.645 //layer=m1 \
 //thickness=0.36 //x=19.57 //y=7.085 //x2=18.925 //y2=7.085
r105 (  2 5 ) resistor r=0.0208269 //w=0.212 //l=0.115 //layer=m1 \
 //thickness=0.36 //x=18.045 //y=5.385 //x2=17.93 //y2=5.385
r106 (  1 10 ) resistor r=0.0208269 //w=0.212 //l=0.115 //layer=m1 \
 //thickness=0.36 //x=18.695 //y=5.385 //x2=18.81 //y2=5.385
r107 (  1 2 ) resistor r=0.620229 //w=0.131 //l=0.65 //layer=m1 \
 //thickness=0.36 //x=18.695 //y=5.385 //x2=18.045 //y2=5.385
ends PM_FA\%noxref_19

subckt PM_FA\%GND ( 1 2 9 10 17 18 33 34 43 44 57 85 101 102 106 107 121 125 \
 128 139 152 170 175 179 201 205 208 217 232 250 255 259 262 271 289 294 298 \
 301 312 330 335 339 361 375 399 403 414 417 428 429 430 442 453 454 455 466 \
 467 479 480 492 503 514 515 516 517 518 519 520 521 522 523 524 525 526 527 )
c818 ( 527 0 ) capacitor c=0.0652492f //x=37.615 //y=0.55
c819 ( 526 0 ) capacitor c=0.0743401f //x=34.35 //y=0.545
c820 ( 525 0 ) capacitor c=0.0628411f //x=32.065 //y=0.55
c821 ( 524 0 ) capacitor c=0.00843555f //x=29.23 //y=1.045
c822 ( 523 0 ) capacitor c=0.0622486f //x=26.515 //y=0.55
c823 ( 522 0 ) capacitor c=0.00843555f //x=23.68 //y=1.045
c824 ( 521 0 ) capacitor c=0.0624422f //x=20.965 //y=0.55
c825 ( 520 0 ) capacitor c=0.00839739f //x=18.13 //y=1.05
c826 ( 519 0 ) capacitor c=0.00839739f //x=14.8 //y=1.05
c827 ( 518 0 ) capacitor c=0.0619055f //x=12.085 //y=0.55
c828 ( 517 0 ) capacitor c=0.0624422f //x=9.865 //y=0.55
c829 ( 516 0 ) capacitor c=0.00839739f //x=7.03 //y=1.05
c830 ( 515 0 ) capacitor c=0.00839739f //x=3.7 //y=1.05
c831 ( 514 0 ) capacitor c=0.0629136f //x=0.985 //y=0.55
c832 ( 503 0 ) capacitor c=0.112947f //x=37.12 //y=0.175
c833 ( 500 0 ) capacitor c=0.00597439f //x=36.425 //y=0.175
c834 ( 497 0 ) capacitor c=0.00597439f //x=35.455 //y=0.175
c835 ( 494 0 ) capacitor c=0.00597439f //x=34.53 //y=0.18
c836 ( 492 0 ) capacitor c=0.112757f //x=33.79 //y=0.175
c837 ( 480 0 ) capacitor c=0.112889f //x=31.57 //y=0.175
c838 ( 479 0 ) capacitor c=0.111663f //x=28.24 //y=0.175
c839 ( 467 0 ) capacitor c=0.113139f //x=26.02 //y=0.175
c840 ( 466 0 ) capacitor c=0.108664f //x=22.69 //y=0.175
c841 ( 455 0 ) capacitor c=0.112874f //x=20.47 //y=0.175
c842 ( 454 0 ) capacitor c=0.112865f //x=17.14 //y=0.175
c843 ( 453 0 ) capacitor c=0.10786f //x=13.81 //y=0.175
c844 ( 442 0 ) capacitor c=0.101567f //x=11.59 //y=0.175
c845 ( 430 0 ) capacitor c=0.112483f //x=9.37 //y=0.175
c846 ( 429 0 ) capacitor c=0.11171f //x=6.04 //y=0.175
c847 ( 428 0 ) capacitor c=0.108092f //x=2.71 //y=0.175
c848 ( 417 0 ) capacitor c=0.215034f //x=1.12 //y=0.175
c849 ( 414 0 ) capacitor c=0.222704f //x=38.97 //y=0.18
c850 ( 412 0 ) capacitor c=0.0366946f //x=38.805 //y=0.175
c851 ( 406 0 ) capacitor c=0.00589014f //x=38.72 //y=0.63
c852 ( 403 0 ) capacitor c=0.00625302f //x=38.635 //y=0.715
c853 ( 402 0 ) capacitor c=0.00479851f //x=38.23 //y=0.63
c854 ( 399 0 ) capacitor c=0.00647662f //x=38.145 //y=0.715
c855 ( 394 0 ) capacitor c=0.00590583f //x=37.75 //y=0.63
c856 ( 391 0 ) capacitor c=0.0190482f //x=37.665 //y=0.175
c857 ( 385 0 ) capacitor c=0.0223094f //x=36.95 //y=0.175
c858 ( 380 0 ) capacitor c=0.00739123f //x=36.425 //y=0.625
c859 ( 375 0 ) capacitor c=0.015183f //x=36.34 //y=0.71
c860 ( 371 0 ) capacitor c=0.0258125f //x=36.34 //y=0.175
c861 ( 366 0 ) capacitor c=0.00726869f //x=35.455 //y=0.625
c862 ( 361 0 ) capacitor c=0.0165856f //x=35.37 //y=0.71
c863 ( 359 0 ) capacitor c=0.0257966f //x=35.37 //y=0.175
c864 ( 354 0 ) capacitor c=0.00739123f //x=34.485 //y=0.625
c865 ( 351 0 ) capacitor c=0.0229116f //x=34.4 //y=0.175
c866 ( 348 0 ) capacitor c=0.0366946f //x=33.255 //y=0.175
c867 ( 347 0 ) capacitor c=0.0185464f //x=33.62 //y=0.175
c868 ( 342 0 ) capacitor c=0.00585268f //x=33.17 //y=0.63
c869 ( 339 0 ) capacitor c=0.0061439f //x=33.085 //y=0.715
c870 ( 338 0 ) capacitor c=0.00479851f //x=32.68 //y=0.63
c871 ( 335 0 ) capacitor c=0.00647872f //x=32.595 //y=0.715
c872 ( 330 0 ) capacitor c=0.00586769f //x=32.2 //y=0.63
c873 ( 325 0 ) capacitor c=0.0190482f //x=32.115 //y=0.175
c874 ( 312 0 ) capacitor c=0.121274f //x=31.4 //y=0.175
c875 ( 307 0 ) capacitor c=0.0366947f //x=27.705 //y=0.175
c876 ( 306 0 ) capacitor c=0.0161782f //x=28.07 //y=0.175
c877 ( 301 0 ) capacitor c=0.00585268f //x=27.62 //y=0.63
c878 ( 298 0 ) capacitor c=0.00610932f //x=27.535 //y=0.715
c879 ( 297 0 ) capacitor c=0.00479851f //x=27.13 //y=0.63
c880 ( 294 0 ) capacitor c=0.00601263f //x=27.045 //y=0.715
c881 ( 289 0 ) capacitor c=0.00586769f //x=26.65 //y=0.63
c882 ( 286 0 ) capacitor c=0.0166752f //x=26.565 //y=0.175
c883 ( 271 0 ) capacitor c=0.118892f //x=25.85 //y=0.175
c884 ( 268 0 ) capacitor c=0.0366947f //x=22.145 //y=0.175
c885 ( 267 0 ) capacitor c=0.0166308f //x=22.52 //y=0.175
c886 ( 262 0 ) capacitor c=0.00586769f //x=22.06 //y=0.63
c887 ( 259 0 ) capacitor c=0.00587399f //x=21.975 //y=0.715
c888 ( 258 0 ) capacitor c=0.00479851f //x=21.58 //y=0.63
c889 ( 255 0 ) capacitor c=0.00614749f //x=21.495 //y=0.715
c890 ( 250 0 ) capacitor c=0.00589014f //x=21.09 //y=0.63
c891 ( 247 0 ) capacitor c=0.0161735f //x=21.005 //y=0.175
c892 ( 232 0 ) capacitor c=0.119064f //x=20.3 //y=0.175
c893 ( 217 0 ) capacitor c=0.119106f //x=16.97 //y=0.175
c894 ( 214 0 ) capacitor c=0.0366947f //x=13.275 //y=0.175
c895 ( 213 0 ) capacitor c=0.0161843f //x=13.64 //y=0.175
c896 ( 208 0 ) capacitor c=0.00589014f //x=13.19 //y=0.63
c897 ( 205 0 ) capacitor c=0.00606212f //x=13.105 //y=0.715
c898 ( 204 0 ) capacitor c=0.00479851f //x=12.7 //y=0.63
c899 ( 201 0 ) capacitor c=0.0058736f //x=12.615 //y=0.715
c900 ( 196 0 ) capacitor c=0.00590583f //x=12.22 //y=0.63
c901 ( 193 0 ) capacitor c=0.0166939f //x=12.135 //y=0.175
c902 ( 188 0 ) capacitor c=0.0366947f //x=11.045 //y=0.175
c903 ( 187 0 ) capacitor c=0.0166308f //x=11.42 //y=0.175
c904 ( 182 0 ) capacitor c=0.00590583f //x=10.96 //y=0.63
c905 ( 179 0 ) capacitor c=0.00587399f //x=10.875 //y=0.715
c906 ( 178 0 ) capacitor c=0.00479851f //x=10.48 //y=0.63
c907 ( 175 0 ) capacitor c=0.00614749f //x=10.395 //y=0.715
c908 ( 170 0 ) capacitor c=0.00589014f //x=9.99 //y=0.63
c909 ( 167 0 ) capacitor c=0.0161735f //x=9.905 //y=0.175
c910 ( 152 0 ) capacitor c=0.119064f //x=9.2 //y=0.175
c911 ( 139 0 ) capacitor c=0.122899f //x=5.87 //y=0.175
c912 ( 134 0 ) capacitor c=0.0366946f //x=2.175 //y=0.175
c913 ( 133 0 ) capacitor c=0.0185573f //x=2.54 //y=0.175
c914 ( 128 0 ) capacitor c=0.00589014f //x=2.09 //y=0.63
c915 ( 125 0 ) capacitor c=0.00605867f //x=2.005 //y=0.715
c916 ( 124 0 ) capacitor c=0.00479851f //x=1.6 //y=0.63
c917 ( 121 0 ) capacitor c=0.00645303f //x=1.515 //y=0.715
c918 ( 116 0 ) capacitor c=0.00590583f //x=1.12 //y=0.63
c919 ( 110 0 ) capacitor c=0.00509083f //x=29.35 //y=0.18
c920 ( 107 0 ) capacitor c=0.0278993f //x=29.417 //y=1.005
c921 ( 106 0 ) capacitor c=0.0137957f //x=29.42 //y=1.135
c922 ( 104 0 ) capacitor c=0.00509083f //x=23.87 //y=0.175
c923 ( 102 0 ) capacitor c=0.0278993f //x=23.867 //y=1.005
c924 ( 101 0 ) capacitor c=0.0143538f //x=23.87 //y=1.135
c925 ( 97 0 ) capacitor c=0.00509249f //x=18.32 //y=0.175
c926 ( 94 0 ) capacitor c=0.00509249f //x=14.99 //y=0.175
c927 ( 91 0 ) capacitor c=0.00509249f //x=7.22 //y=0.175
c928 ( 88 0 ) capacitor c=0.00509249f //x=3.82 //y=0.18
c929 ( 85 0 ) capacitor c=0.366768f //x=38.97 //y=0.18
c930 ( 57 0 ) capacitor c=0.187876f //x=29.335 //y=0.175
c931 ( 44 0 ) capacitor c=0.189798f //x=23.785 //y=0.175
c932 ( 43 0 ) capacitor c=0.0341515f //x=18.32 //y=1.025
c933 ( 34 0 ) capacitor c=0.108721f //x=18.235 //y=0.175
c934 ( 33 0 ) capacitor c=0.0347758f //x=14.99 //y=1.025
c935 ( 18 0 ) capacitor c=0.267059f //x=14.905 //y=0.175
c936 ( 17 0 ) capacitor c=0.0341515f //x=7.22 //y=1.025
c937 ( 10 0 ) capacitor c=0.108721f //x=7.135 //y=0.175
c938 ( 9 0 ) capacitor c=0.0342572f //x=3.89 //y=1.025
c939 ( 2 0 ) capacitor c=0.154102f //x=3.805 //y=0.175
r940 (  506 507 ) resistor r=17.0899 //w=0.367 //l=0.49 //layer=li \
 //thickness=0.1 //x=38.23 //y=0.175 //x2=38.72 //y2=0.175
r941 (  504 506 ) resistor r=16.7411 //w=0.367 //l=0.48 //layer=li \
 //thickness=0.1 //x=37.75 //y=0.175 //x2=38.23 //y2=0.175
r942 (  484 485 ) resistor r=4.18529 //w=0.367 //l=0.12 //layer=li \
 //thickness=0.1 //x=33.05 //y=0.175 //x2=33.17 //y2=0.175
r943 (  482 484 ) resistor r=12.9046 //w=0.367 //l=0.37 //layer=li \
 //thickness=0.1 //x=32.68 //y=0.175 //x2=33.05 //y2=0.175
r944 (  481 482 ) resistor r=16.7411 //w=0.367 //l=0.48 //layer=li \
 //thickness=0.1 //x=32.2 //y=0.175 //x2=32.68 //y2=0.175
r945 (  471 472 ) resistor r=17.0899 //w=0.367 //l=0.49 //layer=li \
 //thickness=0.1 //x=27.13 //y=0.175 //x2=27.62 //y2=0.175
r946 (  470 471 ) resistor r=12.9046 //w=0.367 //l=0.37 //layer=li \
 //thickness=0.1 //x=26.76 //y=0.175 //x2=27.13 //y2=0.175
r947 (  468 470 ) resistor r=3.83651 //w=0.367 //l=0.11 //layer=li \
 //thickness=0.1 //x=26.65 //y=0.175 //x2=26.76 //y2=0.175
r948 (  458 459 ) resistor r=16.7411 //w=0.367 //l=0.48 //layer=li \
 //thickness=0.1 //x=21.58 //y=0.175 //x2=22.06 //y2=0.175
r949 (  456 458 ) resistor r=17.0899 //w=0.367 //l=0.49 //layer=li \
 //thickness=0.1 //x=21.09 //y=0.175 //x2=21.58 //y2=0.175
r950 (  445 446 ) resistor r=17.0899 //w=0.367 //l=0.49 //layer=li \
 //thickness=0.1 //x=12.7 //y=0.175 //x2=13.19 //y2=0.175
r951 (  443 445 ) resistor r=16.7411 //w=0.367 //l=0.48 //layer=li \
 //thickness=0.1 //x=12.22 //y=0.175 //x2=12.7 //y2=0.175
r952 (  434 435 ) resistor r=16.7411 //w=0.367 //l=0.48 //layer=li \
 //thickness=0.1 //x=10.48 //y=0.175 //x2=10.96 //y2=0.175
r953 (  433 434 ) resistor r=12.9046 //w=0.367 //l=0.37 //layer=li \
 //thickness=0.1 //x=10.11 //y=0.175 //x2=10.48 //y2=0.175
r954 (  431 433 ) resistor r=4.18529 //w=0.367 //l=0.12 //layer=li \
 //thickness=0.1 //x=9.99 //y=0.175 //x2=10.11 //y2=0.175
r955 (  420 421 ) resistor r=17.0899 //w=0.367 //l=0.49 //layer=li \
 //thickness=0.1 //x=1.6 //y=0.175 //x2=2.09 //y2=0.175
r956 (  419 420 ) resistor r=12.9046 //w=0.367 //l=0.37 //layer=li \
 //thickness=0.1 //x=1.23 //y=0.175 //x2=1.6 //y2=0.175
r957 (  417 419 ) resistor r=3.83651 //w=0.367 //l=0.11 //layer=li \
 //thickness=0.1 //x=1.12 //y=0.175 //x2=1.23 //y2=0.175
r958 (  412 507 ) resistor r=2.96458 //w=0.367 //l=0.085 //layer=li \
 //thickness=0.1 //x=38.805 //y=0.175 //x2=38.72 //y2=0.175
r959 (  412 414 ) resistor r=5.75477 //w=0.367 //l=0.165 //layer=li \
 //thickness=0.1 //x=38.805 //y=0.175 //x2=38.97 //y2=0.175
r960 (  407 527 ) resistor r=5.4201 //w=0.17 //l=0.085 //layer=li \
 //thickness=0.1 //x=38.72 //y=0.8 //x2=38.72 //y2=0.715
r961 (  407 527 ) resistor r=41.4118 //w=0.187 //l=0.605 //layer=li \
 //thickness=0.1 //x=38.72 //y=0.8 //x2=38.72 //y2=1.405
r962 (  406 527 ) resistor r=5.4201 //w=0.17 //l=0.085 //layer=li \
 //thickness=0.1 //x=38.72 //y=0.63 //x2=38.72 //y2=0.715
r963 (  405 507 ) resistor r=5.21862 //w=0.35 //l=0.175 //layer=li \
 //thickness=0.1 //x=38.72 //y=0.35 //x2=38.72 //y2=0.175
r964 (  405 406 ) resistor r=19.1658 //w=0.187 //l=0.28 //layer=li \
 //thickness=0.1 //x=38.72 //y=0.35 //x2=38.72 //y2=0.63
r965 (  404 527 ) resistor r=5.4201 //w=0.17 //l=0.085 //layer=li \
 //thickness=0.1 //x=38.315 //y=0.715 //x2=38.23 //y2=0.715
r966 (  403 527 ) resistor r=1.40859 //w=0.34 //l=0.085 //layer=li \
 //thickness=0.1 //x=38.635 //y=0.715 //x2=38.72 //y2=0.715
r967 (  403 404 ) resistor r=21.9037 //w=0.187 //l=0.32 //layer=li \
 //thickness=0.1 //x=38.635 //y=0.715 //x2=38.315 //y2=0.715
r968 (  402 527 ) resistor r=1.40859 //w=0.34 //l=0.085 //layer=li \
 //thickness=0.1 //x=38.23 //y=0.63 //x2=38.23 //y2=0.715
r969 (  401 506 ) resistor r=5.21862 //w=0.35 //l=0.175 //layer=li \
 //thickness=0.1 //x=38.23 //y=0.35 //x2=38.23 //y2=0.175
r970 (  401 402 ) resistor r=19.1658 //w=0.187 //l=0.28 //layer=li \
 //thickness=0.1 //x=38.23 //y=0.35 //x2=38.23 //y2=0.63
r971 (  400 527 ) resistor r=1.40859 //w=0.34 //l=0.085 //layer=li \
 //thickness=0.1 //x=37.835 //y=0.715 //x2=37.75 //y2=0.715
r972 (  399 527 ) resistor r=5.4201 //w=0.17 //l=0.085 //layer=li \
 //thickness=0.1 //x=38.145 //y=0.715 //x2=38.23 //y2=0.715
r973 (  399 400 ) resistor r=21.2193 //w=0.187 //l=0.31 //layer=li \
 //thickness=0.1 //x=38.145 //y=0.715 //x2=37.835 //y2=0.715
r974 (  395 527 ) resistor r=5.4201 //w=0.17 //l=0.085 //layer=li \
 //thickness=0.1 //x=37.75 //y=0.8 //x2=37.75 //y2=0.715
r975 (  395 527 ) resistor r=41.4118 //w=0.187 //l=0.605 //layer=li \
 //thickness=0.1 //x=37.75 //y=0.8 //x2=37.75 //y2=1.405
r976 (  394 527 ) resistor r=5.4201 //w=0.17 //l=0.085 //layer=li \
 //thickness=0.1 //x=37.75 //y=0.63 //x2=37.75 //y2=0.715
r977 (  393 504 ) resistor r=5.21862 //w=0.35 //l=0.175 //layer=li \
 //thickness=0.1 //x=37.75 //y=0.35 //x2=37.75 //y2=0.175
r978 (  393 394 ) resistor r=19.1658 //w=0.187 //l=0.28 //layer=li \
 //thickness=0.1 //x=37.75 //y=0.35 //x2=37.75 //y2=0.63
r979 (  392 503 ) resistor r=5.29055 //w=0.35 //l=0.17 //layer=li \
 //thickness=0.1 //x=37.29 //y=0.175 //x2=37.12 //y2=0.175
r980 (  391 504 ) resistor r=2.96458 //w=0.367 //l=0.085 //layer=li \
 //thickness=0.1 //x=37.665 //y=0.175 //x2=37.75 //y2=0.175
r981 (  391 392 ) resistor r=13.079 //w=0.367 //l=0.375 //layer=li \
 //thickness=0.1 //x=37.665 //y=0.175 //x2=37.29 //y2=0.175
r982 (  386 500 ) resistor r=2.87058 //w=0.35 //l=0.085 //layer=li \
 //thickness=0.1 //x=36.51 //y=0.175 //x2=36.425 //y2=0.175
r983 (  386 388 ) resistor r=8.37057 //w=0.367 //l=0.24 //layer=li \
 //thickness=0.1 //x=36.51 //y=0.175 //x2=36.75 //y2=0.175
r984 (  385 503 ) resistor r=5.29055 //w=0.35 //l=0.17 //layer=li \
 //thickness=0.1 //x=36.95 //y=0.175 //x2=37.12 //y2=0.175
r985 (  385 388 ) resistor r=6.97548 //w=0.367 //l=0.2 //layer=li \
 //thickness=0.1 //x=36.95 //y=0.175 //x2=36.75 //y2=0.175
r986 (  381 526 ) resistor r=5.4201 //w=0.17 //l=0.085 //layer=li \
 //thickness=0.1 //x=36.425 //y=0.795 //x2=36.425 //y2=0.71
r987 (  381 526 ) resistor r=18.139 //w=0.187 //l=0.265 //layer=li \
 //thickness=0.1 //x=36.425 //y=0.795 //x2=36.425 //y2=1.06
r988 (  380 526 ) resistor r=5.4201 //w=0.17 //l=0.085 //layer=li \
 //thickness=0.1 //x=36.425 //y=0.625 //x2=36.425 //y2=0.71
r989 (  379 500 ) resistor r=4.23183 //w=0.7 //l=0.175 //layer=li \
 //thickness=0.1 //x=36.425 //y=0.35 //x2=36.425 //y2=0.175
r990 (  379 380 ) resistor r=18.8235 //w=0.187 //l=0.275 //layer=li \
 //thickness=0.1 //x=36.425 //y=0.35 //x2=36.425 //y2=0.625
r991 (  376 526 ) resistor r=6.4 //w=0.17 //l=0.085 //layer=li //thickness=0.1 \
 //x=35.54 //y=0.71 //x2=35.455 //y2=0.71
r992 (  376 526 ) resistor r=27.3797 //w=0.187 //l=0.4 //layer=li \
 //thickness=0.1 //x=35.54 //y=0.71 //x2=35.94 //y2=0.71
r993 (  375 526 ) resistor r=1.40859 //w=0.34 //l=0.085 //layer=li \
 //thickness=0.1 //x=36.34 //y=0.71 //x2=36.425 //y2=0.71
r994 (  375 526 ) resistor r=27.3797 //w=0.187 //l=0.4 //layer=li \
 //thickness=0.1 //x=36.34 //y=0.71 //x2=35.94 //y2=0.71
r995 (  372 497 ) resistor r=2.87058 //w=0.35 //l=0.085 //layer=li \
 //thickness=0.1 //x=35.54 //y=0.175 //x2=35.455 //y2=0.175
r996 (  372 374 ) resistor r=3.48774 //w=0.367 //l=0.1 //layer=li \
 //thickness=0.1 //x=35.54 //y=0.175 //x2=35.64 //y2=0.175
r997 (  371 500 ) resistor r=2.87058 //w=0.35 //l=0.085 //layer=li \
 //thickness=0.1 //x=36.34 //y=0.175 //x2=36.425 //y2=0.175
r998 (  371 374 ) resistor r=24.4142 //w=0.367 //l=0.7 //layer=li \
 //thickness=0.1 //x=36.34 //y=0.175 //x2=35.64 //y2=0.175
r999 (  367 526 ) resistor r=6.4 //w=0.17 //l=0.085 //layer=li //thickness=0.1 \
 //x=35.455 //y=0.795 //x2=35.455 //y2=0.71
r1000 (  367 526 ) resistor r=18.139 //w=0.187 //l=0.265 //layer=li \
 //thickness=0.1 //x=35.455 //y=0.795 //x2=35.455 //y2=1.06
r1001 (  366 526 ) resistor r=6.4 //w=0.17 //l=0.085 //layer=li \
 //thickness=0.1 //x=35.455 //y=0.625 //x2=35.455 //y2=0.71
r1002 (  365 497 ) resistor r=4.23183 //w=0.7 //l=0.175 //layer=li \
 //thickness=0.1 //x=35.455 //y=0.35 //x2=35.455 //y2=0.175
r1003 (  365 366 ) resistor r=18.8235 //w=0.187 //l=0.275 //layer=li \
 //thickness=0.1 //x=35.455 //y=0.35 //x2=35.455 //y2=0.625
r1004 (  362 526 ) resistor r=1.40859 //w=0.34 //l=0.085 //layer=li \
 //thickness=0.1 //x=34.57 //y=0.71 //x2=34.485 //y2=0.71
r1005 (  362 526 ) resistor r=27.3797 //w=0.187 //l=0.4 //layer=li \
 //thickness=0.1 //x=34.57 //y=0.71 //x2=34.97 //y2=0.71
r1006 (  361 526 ) resistor r=6.4 //w=0.17 //l=0.085 //layer=li \
 //thickness=0.1 //x=35.37 //y=0.71 //x2=35.455 //y2=0.71
r1007 (  361 526 ) resistor r=27.3797 //w=0.187 //l=0.4 //layer=li \
 //thickness=0.1 //x=35.37 //y=0.71 //x2=34.97 //y2=0.71
r1008 (  360 494 ) resistor r=2.87058 //w=0.35 //l=0.085 //layer=li \
 //thickness=0.1 //x=34.57 //y=0.175 //x2=34.485 //y2=0.175
r1009 (  359 497 ) resistor r=2.87058 //w=0.35 //l=0.085 //layer=li \
 //thickness=0.1 //x=35.37 //y=0.175 //x2=35.455 //y2=0.175
r1010 (  359 360 ) resistor r=27.9019 //w=0.367 //l=0.8 //layer=li \
 //thickness=0.1 //x=35.37 //y=0.175 //x2=34.57 //y2=0.175
r1011 (  355 526 ) resistor r=5.4201 //w=0.17 //l=0.085 //layer=li \
 //thickness=0.1 //x=34.485 //y=0.795 //x2=34.485 //y2=0.71
r1012 (  355 526 ) resistor r=41.4118 //w=0.187 //l=0.605 //layer=li \
 //thickness=0.1 //x=34.485 //y=0.795 //x2=34.485 //y2=1.4
r1013 (  354 526 ) resistor r=5.4201 //w=0.17 //l=0.085 //layer=li \
 //thickness=0.1 //x=34.485 //y=0.625 //x2=34.485 //y2=0.71
r1014 (  353 494 ) resistor r=4.23183 //w=0.7 //l=0.175 //layer=li \
 //thickness=0.1 //x=34.485 //y=0.35 //x2=34.485 //y2=0.175
r1015 (  353 354 ) resistor r=18.8235 //w=0.187 //l=0.275 //layer=li \
 //thickness=0.1 //x=34.485 //y=0.35 //x2=34.485 //y2=0.625
r1016 (  352 492 ) resistor r=5.29055 //w=0.35 //l=0.17 //layer=li \
 //thickness=0.1 //x=33.96 //y=0.175 //x2=33.79 //y2=0.175
r1017 (  351 494 ) resistor r=2.87058 //w=0.35 //l=0.085 //layer=li \
 //thickness=0.1 //x=34.4 //y=0.175 //x2=34.485 //y2=0.175
r1018 (  351 352 ) resistor r=15.346 //w=0.367 //l=0.44 //layer=li \
 //thickness=0.1 //x=34.4 //y=0.175 //x2=33.96 //y2=0.175
r1019 (  348 485 ) resistor r=2.96458 //w=0.367 //l=0.085 //layer=li \
 //thickness=0.1 //x=33.255 //y=0.175 //x2=33.17 //y2=0.175
r1020 (  347 492 ) resistor r=5.29055 //w=0.35 //l=0.17 //layer=li \
 //thickness=0.1 //x=33.62 //y=0.175 //x2=33.79 //y2=0.175
r1021 (  347 348 ) resistor r=12.7302 //w=0.367 //l=0.365 //layer=li \
 //thickness=0.1 //x=33.62 //y=0.175 //x2=33.255 //y2=0.175
r1022 (  343 525 ) resistor r=5.4201 //w=0.17 //l=0.085 //layer=li \
 //thickness=0.1 //x=33.17 //y=0.8 //x2=33.17 //y2=0.715
r1023 (  343 525 ) resistor r=41.4118 //w=0.187 //l=0.605 //layer=li \
 //thickness=0.1 //x=33.17 //y=0.8 //x2=33.17 //y2=1.405
r1024 (  342 525 ) resistor r=5.4201 //w=0.17 //l=0.085 //layer=li \
 //thickness=0.1 //x=33.17 //y=0.63 //x2=33.17 //y2=0.715
r1025 (  341 485 ) resistor r=5.21862 //w=0.35 //l=0.175 //layer=li \
 //thickness=0.1 //x=33.17 //y=0.35 //x2=33.17 //y2=0.175
r1026 (  341 342 ) resistor r=19.1658 //w=0.187 //l=0.28 //layer=li \
 //thickness=0.1 //x=33.17 //y=0.35 //x2=33.17 //y2=0.63
r1027 (  340 525 ) resistor r=5.4201 //w=0.17 //l=0.085 //layer=li \
 //thickness=0.1 //x=32.765 //y=0.715 //x2=32.68 //y2=0.715
r1028 (  339 525 ) resistor r=1.40859 //w=0.34 //l=0.085 //layer=li \
 //thickness=0.1 //x=33.085 //y=0.715 //x2=33.17 //y2=0.715
r1029 (  339 340 ) resistor r=21.9037 //w=0.187 //l=0.32 //layer=li \
 //thickness=0.1 //x=33.085 //y=0.715 //x2=32.765 //y2=0.715
r1030 (  338 525 ) resistor r=1.40859 //w=0.34 //l=0.085 //layer=li \
 //thickness=0.1 //x=32.68 //y=0.63 //x2=32.68 //y2=0.715
r1031 (  337 482 ) resistor r=5.21862 //w=0.35 //l=0.175 //layer=li \
 //thickness=0.1 //x=32.68 //y=0.35 //x2=32.68 //y2=0.175
r1032 (  337 338 ) resistor r=19.1658 //w=0.187 //l=0.28 //layer=li \
 //thickness=0.1 //x=32.68 //y=0.35 //x2=32.68 //y2=0.63
r1033 (  336 525 ) resistor r=1.40859 //w=0.34 //l=0.085 //layer=li \
 //thickness=0.1 //x=32.285 //y=0.715 //x2=32.2 //y2=0.715
r1034 (  335 525 ) resistor r=5.4201 //w=0.17 //l=0.085 //layer=li \
 //thickness=0.1 //x=32.595 //y=0.715 //x2=32.68 //y2=0.715
r1035 (  335 336 ) resistor r=21.2193 //w=0.187 //l=0.31 //layer=li \
 //thickness=0.1 //x=32.595 //y=0.715 //x2=32.285 //y2=0.715
r1036 (  331 525 ) resistor r=5.4201 //w=0.17 //l=0.085 //layer=li \
 //thickness=0.1 //x=32.2 //y=0.8 //x2=32.2 //y2=0.715
r1037 (  331 525 ) resistor r=41.4118 //w=0.187 //l=0.605 //layer=li \
 //thickness=0.1 //x=32.2 //y=0.8 //x2=32.2 //y2=1.405
r1038 (  330 525 ) resistor r=5.4201 //w=0.17 //l=0.085 //layer=li \
 //thickness=0.1 //x=32.2 //y=0.63 //x2=32.2 //y2=0.715
r1039 (  329 481 ) resistor r=5.21862 //w=0.35 //l=0.175 //layer=li \
 //thickness=0.1 //x=32.2 //y=0.35 //x2=32.2 //y2=0.175
r1040 (  329 330 ) resistor r=19.1658 //w=0.187 //l=0.28 //layer=li \
 //thickness=0.1 //x=32.2 //y=0.35 //x2=32.2 //y2=0.63
r1041 (  326 480 ) resistor r=5.29055 //w=0.35 //l=0.17 //layer=li \
 //thickness=0.1 //x=31.74 //y=0.175 //x2=31.57 //y2=0.175
r1042 (  326 328 ) resistor r=6.97548 //w=0.367 //l=0.2 //layer=li \
 //thickness=0.1 //x=31.74 //y=0.175 //x2=31.94 //y2=0.175
r1043 (  325 481 ) resistor r=2.96458 //w=0.367 //l=0.085 //layer=li \
 //thickness=0.1 //x=32.115 //y=0.175 //x2=32.2 //y2=0.175
r1044 (  325 328 ) resistor r=6.10354 //w=0.367 //l=0.175 //layer=li \
 //thickness=0.1 //x=32.115 //y=0.175 //x2=31.94 //y2=0.175
r1045 (  315 317 ) resistor r=38.7139 //w=0.367 //l=1.11 //layer=li \
 //thickness=0.1 //x=29.35 //y=0.175 //x2=30.46 //y2=0.175
r1046 (  313 479 ) resistor r=5.29055 //w=0.35 //l=0.17 //layer=li \
 //thickness=0.1 //x=28.41 //y=0.175 //x2=28.24 //y2=0.175
r1047 (  313 315 ) resistor r=32.7847 //w=0.367 //l=0.94 //layer=li \
 //thickness=0.1 //x=28.41 //y=0.175 //x2=29.35 //y2=0.175
r1048 (  312 480 ) resistor r=5.29055 //w=0.35 //l=0.17 //layer=li \
 //thickness=0.1 //x=31.4 //y=0.175 //x2=31.57 //y2=0.175
r1049 (  312 317 ) resistor r=32.7847 //w=0.367 //l=0.94 //layer=li \
 //thickness=0.1 //x=31.4 //y=0.175 //x2=30.46 //y2=0.175
r1050 (  307 472 ) resistor r=2.96458 //w=0.367 //l=0.085 //layer=li \
 //thickness=0.1 //x=27.705 //y=0.175 //x2=27.62 //y2=0.175
r1051 (  307 309 ) resistor r=5.75477 //w=0.367 //l=0.165 //layer=li \
 //thickness=0.1 //x=27.705 //y=0.175 //x2=27.87 //y2=0.175
r1052 (  306 479 ) resistor r=5.29055 //w=0.35 //l=0.17 //layer=li \
 //thickness=0.1 //x=28.07 //y=0.175 //x2=28.24 //y2=0.175
r1053 (  306 309 ) resistor r=6.97548 //w=0.367 //l=0.2 //layer=li \
 //thickness=0.1 //x=28.07 //y=0.175 //x2=27.87 //y2=0.175
r1054 (  302 523 ) resistor r=5.4201 //w=0.17 //l=0.085 //layer=li \
 //thickness=0.1 //x=27.62 //y=0.8 //x2=27.62 //y2=0.715
r1055 (  302 523 ) resistor r=41.4118 //w=0.187 //l=0.605 //layer=li \
 //thickness=0.1 //x=27.62 //y=0.8 //x2=27.62 //y2=1.405
r1056 (  301 523 ) resistor r=5.4201 //w=0.17 //l=0.085 //layer=li \
 //thickness=0.1 //x=27.62 //y=0.63 //x2=27.62 //y2=0.715
r1057 (  300 472 ) resistor r=5.21862 //w=0.35 //l=0.175 //layer=li \
 //thickness=0.1 //x=27.62 //y=0.35 //x2=27.62 //y2=0.175
r1058 (  300 301 ) resistor r=19.1658 //w=0.187 //l=0.28 //layer=li \
 //thickness=0.1 //x=27.62 //y=0.35 //x2=27.62 //y2=0.63
r1059 (  299 523 ) resistor r=5.4201 //w=0.17 //l=0.085 //layer=li \
 //thickness=0.1 //x=27.215 //y=0.715 //x2=27.13 //y2=0.715
r1060 (  298 523 ) resistor r=1.40859 //w=0.34 //l=0.085 //layer=li \
 //thickness=0.1 //x=27.535 //y=0.715 //x2=27.62 //y2=0.715
r1061 (  298 299 ) resistor r=21.9037 //w=0.187 //l=0.32 //layer=li \
 //thickness=0.1 //x=27.535 //y=0.715 //x2=27.215 //y2=0.715
r1062 (  297 523 ) resistor r=1.40859 //w=0.34 //l=0.085 //layer=li \
 //thickness=0.1 //x=27.13 //y=0.63 //x2=27.13 //y2=0.715
r1063 (  296 471 ) resistor r=5.21862 //w=0.35 //l=0.175 //layer=li \
 //thickness=0.1 //x=27.13 //y=0.35 //x2=27.13 //y2=0.175
r1064 (  296 297 ) resistor r=19.1658 //w=0.187 //l=0.28 //layer=li \
 //thickness=0.1 //x=27.13 //y=0.35 //x2=27.13 //y2=0.63
r1065 (  295 523 ) resistor r=1.40859 //w=0.34 //l=0.085 //layer=li \
 //thickness=0.1 //x=26.735 //y=0.715 //x2=26.65 //y2=0.715
r1066 (  294 523 ) resistor r=5.4201 //w=0.17 //l=0.085 //layer=li \
 //thickness=0.1 //x=27.045 //y=0.715 //x2=27.13 //y2=0.715
r1067 (  294 295 ) resistor r=21.2193 //w=0.187 //l=0.31 //layer=li \
 //thickness=0.1 //x=27.045 //y=0.715 //x2=26.735 //y2=0.715
r1068 (  290 523 ) resistor r=5.4201 //w=0.17 //l=0.085 //layer=li \
 //thickness=0.1 //x=26.65 //y=0.8 //x2=26.65 //y2=0.715
r1069 (  290 523 ) resistor r=41.4118 //w=0.187 //l=0.605 //layer=li \
 //thickness=0.1 //x=26.65 //y=0.8 //x2=26.65 //y2=1.405
r1070 (  289 523 ) resistor r=5.4201 //w=0.17 //l=0.085 //layer=li \
 //thickness=0.1 //x=26.65 //y=0.63 //x2=26.65 //y2=0.715
r1071 (  288 468 ) resistor r=5.21862 //w=0.35 //l=0.175 //layer=li \
 //thickness=0.1 //x=26.65 //y=0.35 //x2=26.65 //y2=0.175
r1072 (  288 289 ) resistor r=19.1658 //w=0.187 //l=0.28 //layer=li \
 //thickness=0.1 //x=26.65 //y=0.35 //x2=26.65 //y2=0.63
r1073 (  287 467 ) resistor r=5.29055 //w=0.35 //l=0.17 //layer=li \
 //thickness=0.1 //x=26.19 //y=0.175 //x2=26.02 //y2=0.175
r1074 (  286 468 ) resistor r=2.96458 //w=0.367 //l=0.085 //layer=li \
 //thickness=0.1 //x=26.565 //y=0.175 //x2=26.65 //y2=0.175
r1075 (  286 287 ) resistor r=13.079 //w=0.367 //l=0.375 //layer=li \
 //thickness=0.1 //x=26.565 //y=0.175 //x2=26.19 //y2=0.175
r1076 (  276 278 ) resistor r=38.7139 //w=0.367 //l=1.11 //layer=li \
 //thickness=0.1 //x=24.17 //y=0.175 //x2=25.28 //y2=0.175
r1077 (  274 276 ) resistor r=38.7139 //w=0.367 //l=1.11 //layer=li \
 //thickness=0.1 //x=23.06 //y=0.175 //x2=24.17 //y2=0.175
r1078 (  272 466 ) resistor r=5.29055 //w=0.35 //l=0.17 //layer=li \
 //thickness=0.1 //x=22.86 //y=0.175 //x2=22.69 //y2=0.175
r1079 (  272 274 ) resistor r=6.97548 //w=0.367 //l=0.2 //layer=li \
 //thickness=0.1 //x=22.86 //y=0.175 //x2=23.06 //y2=0.175
r1080 (  271 467 ) resistor r=5.29055 //w=0.35 //l=0.17 //layer=li \
 //thickness=0.1 //x=25.85 //y=0.175 //x2=26.02 //y2=0.175
r1081 (  271 278 ) resistor r=19.8801 //w=0.367 //l=0.57 //layer=li \
 //thickness=0.1 //x=25.85 //y=0.175 //x2=25.28 //y2=0.175
r1082 (  268 459 ) resistor r=2.96458 //w=0.367 //l=0.085 //layer=li \
 //thickness=0.1 //x=22.145 //y=0.175 //x2=22.06 //y2=0.175
r1083 (  267 466 ) resistor r=5.29055 //w=0.35 //l=0.17 //layer=li \
 //thickness=0.1 //x=22.52 //y=0.175 //x2=22.69 //y2=0.175
r1084 (  267 268 ) resistor r=13.079 //w=0.367 //l=0.375 //layer=li \
 //thickness=0.1 //x=22.52 //y=0.175 //x2=22.145 //y2=0.175
r1085 (  263 521 ) resistor r=5.4201 //w=0.17 //l=0.085 //layer=li \
 //thickness=0.1 //x=22.06 //y=0.8 //x2=22.06 //y2=0.715
r1086 (  263 521 ) resistor r=41.4118 //w=0.187 //l=0.605 //layer=li \
 //thickness=0.1 //x=22.06 //y=0.8 //x2=22.06 //y2=1.405
r1087 (  262 521 ) resistor r=5.4201 //w=0.17 //l=0.085 //layer=li \
 //thickness=0.1 //x=22.06 //y=0.63 //x2=22.06 //y2=0.715
r1088 (  261 459 ) resistor r=5.21862 //w=0.35 //l=0.175 //layer=li \
 //thickness=0.1 //x=22.06 //y=0.35 //x2=22.06 //y2=0.175
r1089 (  261 262 ) resistor r=19.1658 //w=0.187 //l=0.28 //layer=li \
 //thickness=0.1 //x=22.06 //y=0.35 //x2=22.06 //y2=0.63
r1090 (  260 521 ) resistor r=5.4201 //w=0.17 //l=0.085 //layer=li \
 //thickness=0.1 //x=21.665 //y=0.715 //x2=21.58 //y2=0.715
r1091 (  259 521 ) resistor r=1.40859 //w=0.34 //l=0.085 //layer=li \
 //thickness=0.1 //x=21.975 //y=0.715 //x2=22.06 //y2=0.715
r1092 (  259 260 ) resistor r=21.2193 //w=0.187 //l=0.31 //layer=li \
 //thickness=0.1 //x=21.975 //y=0.715 //x2=21.665 //y2=0.715
r1093 (  258 521 ) resistor r=1.40859 //w=0.34 //l=0.085 //layer=li \
 //thickness=0.1 //x=21.58 //y=0.63 //x2=21.58 //y2=0.715
r1094 (  257 458 ) resistor r=5.21862 //w=0.35 //l=0.175 //layer=li \
 //thickness=0.1 //x=21.58 //y=0.35 //x2=21.58 //y2=0.175
r1095 (  257 258 ) resistor r=19.1658 //w=0.187 //l=0.28 //layer=li \
 //thickness=0.1 //x=21.58 //y=0.35 //x2=21.58 //y2=0.63
r1096 (  256 521 ) resistor r=1.40859 //w=0.34 //l=0.085 //layer=li \
 //thickness=0.1 //x=21.175 //y=0.715 //x2=21.09 //y2=0.715
r1097 (  255 521 ) resistor r=5.4201 //w=0.17 //l=0.085 //layer=li \
 //thickness=0.1 //x=21.495 //y=0.715 //x2=21.58 //y2=0.715
r1098 (  255 256 ) resistor r=21.9037 //w=0.187 //l=0.32 //layer=li \
 //thickness=0.1 //x=21.495 //y=0.715 //x2=21.175 //y2=0.715
r1099 (  251 521 ) resistor r=5.4201 //w=0.17 //l=0.085 //layer=li \
 //thickness=0.1 //x=21.09 //y=0.8 //x2=21.09 //y2=0.715
r1100 (  251 521 ) resistor r=41.4118 //w=0.187 //l=0.605 //layer=li \
 //thickness=0.1 //x=21.09 //y=0.8 //x2=21.09 //y2=1.405
r1101 (  250 521 ) resistor r=5.4201 //w=0.17 //l=0.085 //layer=li \
 //thickness=0.1 //x=21.09 //y=0.63 //x2=21.09 //y2=0.715
r1102 (  249 456 ) resistor r=5.21862 //w=0.35 //l=0.175 //layer=li \
 //thickness=0.1 //x=21.09 //y=0.35 //x2=21.09 //y2=0.175
r1103 (  249 250 ) resistor r=19.1658 //w=0.187 //l=0.28 //layer=li \
 //thickness=0.1 //x=21.09 //y=0.35 //x2=21.09 //y2=0.63
r1104 (  248 455 ) resistor r=5.29055 //w=0.35 //l=0.17 //layer=li \
 //thickness=0.1 //x=20.64 //y=0.175 //x2=20.47 //y2=0.175
r1105 (  247 456 ) resistor r=2.96458 //w=0.367 //l=0.085 //layer=li \
 //thickness=0.1 //x=21.005 //y=0.175 //x2=21.09 //y2=0.175
r1106 (  247 248 ) resistor r=12.7302 //w=0.367 //l=0.365 //layer=li \
 //thickness=0.1 //x=21.005 //y=0.175 //x2=20.64 //y2=0.175
r1107 (  237 239 ) resistor r=38.7139 //w=0.367 //l=1.11 //layer=li \
 //thickness=0.1 //x=18.99 //y=0.175 //x2=20.1 //y2=0.175
r1108 (  235 237 ) resistor r=38.7139 //w=0.367 //l=1.11 //layer=li \
 //thickness=0.1 //x=17.88 //y=0.175 //x2=18.99 //y2=0.175
r1109 (  233 454 ) resistor r=5.29055 //w=0.35 //l=0.17 //layer=li \
 //thickness=0.1 //x=17.31 //y=0.175 //x2=17.14 //y2=0.175
r1110 (  233 235 ) resistor r=19.8801 //w=0.367 //l=0.57 //layer=li \
 //thickness=0.1 //x=17.31 //y=0.175 //x2=17.88 //y2=0.175
r1111 (  232 455 ) resistor r=5.29055 //w=0.35 //l=0.17 //layer=li \
 //thickness=0.1 //x=20.3 //y=0.175 //x2=20.47 //y2=0.175
r1112 (  232 239 ) resistor r=6.97548 //w=0.367 //l=0.2 //layer=li \
 //thickness=0.1 //x=20.3 //y=0.175 //x2=20.1 //y2=0.175
r1113 (  222 224 ) resistor r=38.7139 //w=0.367 //l=1.11 //layer=li \
 //thickness=0.1 //x=15.29 //y=0.175 //x2=16.4 //y2=0.175
r1114 (  220 222 ) resistor r=38.7139 //w=0.367 //l=1.11 //layer=li \
 //thickness=0.1 //x=14.18 //y=0.175 //x2=15.29 //y2=0.175
r1115 (  218 453 ) resistor r=5.29055 //w=0.35 //l=0.17 //layer=li \
 //thickness=0.1 //x=13.98 //y=0.175 //x2=13.81 //y2=0.175
r1116 (  218 220 ) resistor r=6.97548 //w=0.367 //l=0.2 //layer=li \
 //thickness=0.1 //x=13.98 //y=0.175 //x2=14.18 //y2=0.175
r1117 (  217 454 ) resistor r=5.29055 //w=0.35 //l=0.17 //layer=li \
 //thickness=0.1 //x=16.97 //y=0.175 //x2=17.14 //y2=0.175
r1118 (  217 224 ) resistor r=19.8801 //w=0.367 //l=0.57 //layer=li \
 //thickness=0.1 //x=16.97 //y=0.175 //x2=16.4 //y2=0.175
r1119 (  214 446 ) resistor r=2.96458 //w=0.367 //l=0.085 //layer=li \
 //thickness=0.1 //x=13.275 //y=0.175 //x2=13.19 //y2=0.175
r1120 (  213 453 ) resistor r=5.29055 //w=0.35 //l=0.17 //layer=li \
 //thickness=0.1 //x=13.64 //y=0.175 //x2=13.81 //y2=0.175
r1121 (  213 214 ) resistor r=12.7302 //w=0.367 //l=0.365 //layer=li \
 //thickness=0.1 //x=13.64 //y=0.175 //x2=13.275 //y2=0.175
r1122 (  209 518 ) resistor r=5.4201 //w=0.17 //l=0.085 //layer=li \
 //thickness=0.1 //x=13.19 //y=0.8 //x2=13.19 //y2=0.715
r1123 (  209 518 ) resistor r=41.4118 //w=0.187 //l=0.605 //layer=li \
 //thickness=0.1 //x=13.19 //y=0.8 //x2=13.19 //y2=1.405
r1124 (  208 518 ) resistor r=5.4201 //w=0.17 //l=0.085 //layer=li \
 //thickness=0.1 //x=13.19 //y=0.63 //x2=13.19 //y2=0.715
r1125 (  207 446 ) resistor r=5.21862 //w=0.35 //l=0.175 //layer=li \
 //thickness=0.1 //x=13.19 //y=0.35 //x2=13.19 //y2=0.175
r1126 (  207 208 ) resistor r=19.1658 //w=0.187 //l=0.28 //layer=li \
 //thickness=0.1 //x=13.19 //y=0.35 //x2=13.19 //y2=0.63
r1127 (  206 518 ) resistor r=5.4201 //w=0.17 //l=0.085 //layer=li \
 //thickness=0.1 //x=12.785 //y=0.715 //x2=12.7 //y2=0.715
r1128 (  205 518 ) resistor r=1.40859 //w=0.34 //l=0.085 //layer=li \
 //thickness=0.1 //x=13.105 //y=0.715 //x2=13.19 //y2=0.715
r1129 (  205 206 ) resistor r=21.9037 //w=0.187 //l=0.32 //layer=li \
 //thickness=0.1 //x=13.105 //y=0.715 //x2=12.785 //y2=0.715
r1130 (  204 518 ) resistor r=1.40859 //w=0.34 //l=0.085 //layer=li \
 //thickness=0.1 //x=12.7 //y=0.63 //x2=12.7 //y2=0.715
r1131 (  203 445 ) resistor r=5.21862 //w=0.35 //l=0.175 //layer=li \
 //thickness=0.1 //x=12.7 //y=0.35 //x2=12.7 //y2=0.175
r1132 (  203 204 ) resistor r=19.1658 //w=0.187 //l=0.28 //layer=li \
 //thickness=0.1 //x=12.7 //y=0.35 //x2=12.7 //y2=0.63
r1133 (  202 518 ) resistor r=1.40859 //w=0.34 //l=0.085 //layer=li \
 //thickness=0.1 //x=12.305 //y=0.715 //x2=12.22 //y2=0.715
r1134 (  201 518 ) resistor r=5.4201 //w=0.17 //l=0.085 //layer=li \
 //thickness=0.1 //x=12.615 //y=0.715 //x2=12.7 //y2=0.715
r1135 (  201 202 ) resistor r=21.2193 //w=0.187 //l=0.31 //layer=li \
 //thickness=0.1 //x=12.615 //y=0.715 //x2=12.305 //y2=0.715
r1136 (  197 518 ) resistor r=5.4201 //w=0.17 //l=0.085 //layer=li \
 //thickness=0.1 //x=12.22 //y=0.8 //x2=12.22 //y2=0.715
r1137 (  197 518 ) resistor r=41.4118 //w=0.187 //l=0.605 //layer=li \
 //thickness=0.1 //x=12.22 //y=0.8 //x2=12.22 //y2=1.405
r1138 (  196 518 ) resistor r=5.4201 //w=0.17 //l=0.085 //layer=li \
 //thickness=0.1 //x=12.22 //y=0.63 //x2=12.22 //y2=0.715
r1139 (  195 443 ) resistor r=5.21862 //w=0.35 //l=0.175 //layer=li \
 //thickness=0.1 //x=12.22 //y=0.35 //x2=12.22 //y2=0.175
r1140 (  195 196 ) resistor r=19.1658 //w=0.187 //l=0.28 //layer=li \
 //thickness=0.1 //x=12.22 //y=0.35 //x2=12.22 //y2=0.63
r1141 (  194 442 ) resistor r=5.29055 //w=0.35 //l=0.17 //layer=li \
 //thickness=0.1 //x=11.76 //y=0.175 //x2=11.59 //y2=0.175
r1142 (  193 443 ) resistor r=2.96458 //w=0.367 //l=0.085 //layer=li \
 //thickness=0.1 //x=12.135 //y=0.175 //x2=12.22 //y2=0.175
r1143 (  193 194 ) resistor r=13.079 //w=0.367 //l=0.375 //layer=li \
 //thickness=0.1 //x=12.135 //y=0.175 //x2=11.76 //y2=0.175
r1144 (  188 435 ) resistor r=2.96458 //w=0.367 //l=0.085 //layer=li \
 //thickness=0.1 //x=11.045 //y=0.175 //x2=10.96 //y2=0.175
r1145 (  188 190 ) resistor r=6.10354 //w=0.367 //l=0.175 //layer=li \
 //thickness=0.1 //x=11.045 //y=0.175 //x2=11.22 //y2=0.175
r1146 (  187 442 ) resistor r=5.29055 //w=0.35 //l=0.17 //layer=li \
 //thickness=0.1 //x=11.42 //y=0.175 //x2=11.59 //y2=0.175
r1147 (  187 190 ) resistor r=6.97548 //w=0.367 //l=0.2 //layer=li \
 //thickness=0.1 //x=11.42 //y=0.175 //x2=11.22 //y2=0.175
r1148 (  183 517 ) resistor r=5.4201 //w=0.17 //l=0.085 //layer=li \
 //thickness=0.1 //x=10.96 //y=0.8 //x2=10.96 //y2=0.715
r1149 (  183 517 ) resistor r=41.4118 //w=0.187 //l=0.605 //layer=li \
 //thickness=0.1 //x=10.96 //y=0.8 //x2=10.96 //y2=1.405
r1150 (  182 517 ) resistor r=5.4201 //w=0.17 //l=0.085 //layer=li \
 //thickness=0.1 //x=10.96 //y=0.63 //x2=10.96 //y2=0.715
r1151 (  181 435 ) resistor r=5.21862 //w=0.35 //l=0.175 //layer=li \
 //thickness=0.1 //x=10.96 //y=0.35 //x2=10.96 //y2=0.175
r1152 (  181 182 ) resistor r=19.1658 //w=0.187 //l=0.28 //layer=li \
 //thickness=0.1 //x=10.96 //y=0.35 //x2=10.96 //y2=0.63
r1153 (  180 517 ) resistor r=5.4201 //w=0.17 //l=0.085 //layer=li \
 //thickness=0.1 //x=10.565 //y=0.715 //x2=10.48 //y2=0.715
r1154 (  179 517 ) resistor r=1.40859 //w=0.34 //l=0.085 //layer=li \
 //thickness=0.1 //x=10.875 //y=0.715 //x2=10.96 //y2=0.715
r1155 (  179 180 ) resistor r=21.2193 //w=0.187 //l=0.31 //layer=li \
 //thickness=0.1 //x=10.875 //y=0.715 //x2=10.565 //y2=0.715
r1156 (  178 517 ) resistor r=1.40859 //w=0.34 //l=0.085 //layer=li \
 //thickness=0.1 //x=10.48 //y=0.63 //x2=10.48 //y2=0.715
r1157 (  177 434 ) resistor r=5.21862 //w=0.35 //l=0.175 //layer=li \
 //thickness=0.1 //x=10.48 //y=0.35 //x2=10.48 //y2=0.175
r1158 (  177 178 ) resistor r=19.1658 //w=0.187 //l=0.28 //layer=li \
 //thickness=0.1 //x=10.48 //y=0.35 //x2=10.48 //y2=0.63
r1159 (  176 517 ) resistor r=1.40859 //w=0.34 //l=0.085 //layer=li \
 //thickness=0.1 //x=10.075 //y=0.715 //x2=9.99 //y2=0.715
r1160 (  175 517 ) resistor r=5.4201 //w=0.17 //l=0.085 //layer=li \
 //thickness=0.1 //x=10.395 //y=0.715 //x2=10.48 //y2=0.715
r1161 (  175 176 ) resistor r=21.9037 //w=0.187 //l=0.32 //layer=li \
 //thickness=0.1 //x=10.395 //y=0.715 //x2=10.075 //y2=0.715
r1162 (  171 517 ) resistor r=5.4201 //w=0.17 //l=0.085 //layer=li \
 //thickness=0.1 //x=9.99 //y=0.8 //x2=9.99 //y2=0.715
r1163 (  171 517 ) resistor r=41.4118 //w=0.187 //l=0.605 //layer=li \
 //thickness=0.1 //x=9.99 //y=0.8 //x2=9.99 //y2=1.405
r1164 (  170 517 ) resistor r=5.4201 //w=0.17 //l=0.085 //layer=li \
 //thickness=0.1 //x=9.99 //y=0.63 //x2=9.99 //y2=0.715
r1165 (  169 431 ) resistor r=5.21862 //w=0.35 //l=0.175 //layer=li \
 //thickness=0.1 //x=9.99 //y=0.35 //x2=9.99 //y2=0.175
r1166 (  169 170 ) resistor r=19.1658 //w=0.187 //l=0.28 //layer=li \
 //thickness=0.1 //x=9.99 //y=0.35 //x2=9.99 //y2=0.63
r1167 (  168 430 ) resistor r=5.29055 //w=0.35 //l=0.17 //layer=li \
 //thickness=0.1 //x=9.54 //y=0.175 //x2=9.37 //y2=0.175
r1168 (  167 431 ) resistor r=2.96458 //w=0.367 //l=0.085 //layer=li \
 //thickness=0.1 //x=9.905 //y=0.175 //x2=9.99 //y2=0.175
r1169 (  167 168 ) resistor r=12.7302 //w=0.367 //l=0.365 //layer=li \
 //thickness=0.1 //x=9.905 //y=0.175 //x2=9.54 //y2=0.175
r1170 (  157 159 ) resistor r=38.7139 //w=0.367 //l=1.11 //layer=li \
 //thickness=0.1 //x=7.52 //y=0.175 //x2=8.63 //y2=0.175
r1171 (  155 157 ) resistor r=38.7139 //w=0.367 //l=1.11 //layer=li \
 //thickness=0.1 //x=6.41 //y=0.175 //x2=7.52 //y2=0.175
r1172 (  153 429 ) resistor r=5.29055 //w=0.35 //l=0.17 //layer=li \
 //thickness=0.1 //x=6.21 //y=0.175 //x2=6.04 //y2=0.175
r1173 (  153 155 ) resistor r=6.97548 //w=0.367 //l=0.2 //layer=li \
 //thickness=0.1 //x=6.21 //y=0.175 //x2=6.41 //y2=0.175
r1174 (  152 430 ) resistor r=5.29055 //w=0.35 //l=0.17 //layer=li \
 //thickness=0.1 //x=9.2 //y=0.175 //x2=9.37 //y2=0.175
r1175 (  152 159 ) resistor r=19.8801 //w=0.367 //l=0.57 //layer=li \
 //thickness=0.1 //x=9.2 //y=0.175 //x2=8.63 //y2=0.175
r1176 (  142 144 ) resistor r=38.7139 //w=0.367 //l=1.11 //layer=li \
 //thickness=0.1 //x=3.82 //y=0.175 //x2=4.93 //y2=0.175
r1177 (  140 428 ) resistor r=5.29055 //w=0.35 //l=0.17 //layer=li \
 //thickness=0.1 //x=2.88 //y=0.175 //x2=2.71 //y2=0.175
r1178 (  140 142 ) resistor r=32.7847 //w=0.367 //l=0.94 //layer=li \
 //thickness=0.1 //x=2.88 //y=0.175 //x2=3.82 //y2=0.175
r1179 (  139 429 ) resistor r=5.29055 //w=0.35 //l=0.17 //layer=li \
 //thickness=0.1 //x=5.87 //y=0.175 //x2=6.04 //y2=0.175
r1180 (  139 144 ) resistor r=32.7847 //w=0.367 //l=0.94 //layer=li \
 //thickness=0.1 //x=5.87 //y=0.175 //x2=4.93 //y2=0.175
r1181 (  134 421 ) resistor r=2.96458 //w=0.367 //l=0.085 //layer=li \
 //thickness=0.1 //x=2.175 //y=0.175 //x2=2.09 //y2=0.175
r1182 (  134 136 ) resistor r=5.75477 //w=0.367 //l=0.165 //layer=li \
 //thickness=0.1 //x=2.175 //y=0.175 //x2=2.34 //y2=0.175
r1183 (  133 428 ) resistor r=5.29055 //w=0.35 //l=0.17 //layer=li \
 //thickness=0.1 //x=2.54 //y=0.175 //x2=2.71 //y2=0.175
r1184 (  133 136 ) resistor r=6.97548 //w=0.367 //l=0.2 //layer=li \
 //thickness=0.1 //x=2.54 //y=0.175 //x2=2.34 //y2=0.175
r1185 (  129 514 ) resistor r=5.4201 //w=0.17 //l=0.085 //layer=li \
 //thickness=0.1 //x=2.09 //y=0.8 //x2=2.09 //y2=0.715
r1186 (  129 514 ) resistor r=41.4118 //w=0.187 //l=0.605 //layer=li \
 //thickness=0.1 //x=2.09 //y=0.8 //x2=2.09 //y2=1.405
r1187 (  128 514 ) resistor r=5.4201 //w=0.17 //l=0.085 //layer=li \
 //thickness=0.1 //x=2.09 //y=0.63 //x2=2.09 //y2=0.715
r1188 (  127 421 ) resistor r=5.21862 //w=0.35 //l=0.175 //layer=li \
 //thickness=0.1 //x=2.09 //y=0.35 //x2=2.09 //y2=0.175
r1189 (  127 128 ) resistor r=19.1658 //w=0.187 //l=0.28 //layer=li \
 //thickness=0.1 //x=2.09 //y=0.35 //x2=2.09 //y2=0.63
r1190 (  126 514 ) resistor r=5.4201 //w=0.17 //l=0.085 //layer=li \
 //thickness=0.1 //x=1.685 //y=0.715 //x2=1.6 //y2=0.715
r1191 (  125 514 ) resistor r=1.40859 //w=0.34 //l=0.085 //layer=li \
 //thickness=0.1 //x=2.005 //y=0.715 //x2=2.09 //y2=0.715
r1192 (  125 126 ) resistor r=21.9037 //w=0.187 //l=0.32 //layer=li \
 //thickness=0.1 //x=2.005 //y=0.715 //x2=1.685 //y2=0.715
r1193 (  124 514 ) resistor r=1.40859 //w=0.34 //l=0.085 //layer=li \
 //thickness=0.1 //x=1.6 //y=0.63 //x2=1.6 //y2=0.715
r1194 (  123 420 ) resistor r=5.21862 //w=0.35 //l=0.175 //layer=li \
 //thickness=0.1 //x=1.6 //y=0.35 //x2=1.6 //y2=0.175
r1195 (  123 124 ) resistor r=19.1658 //w=0.187 //l=0.28 //layer=li \
 //thickness=0.1 //x=1.6 //y=0.35 //x2=1.6 //y2=0.63
r1196 (  122 514 ) resistor r=1.40859 //w=0.34 //l=0.085 //layer=li \
 //thickness=0.1 //x=1.205 //y=0.715 //x2=1.12 //y2=0.715
r1197 (  121 514 ) resistor r=5.4201 //w=0.17 //l=0.085 //layer=li \
 //thickness=0.1 //x=1.515 //y=0.715 //x2=1.6 //y2=0.715
r1198 (  121 122 ) resistor r=21.2193 //w=0.187 //l=0.31 //layer=li \
 //thickness=0.1 //x=1.515 //y=0.715 //x2=1.205 //y2=0.715
r1199 (  117 514 ) resistor r=5.4201 //w=0.17 //l=0.085 //layer=li \
 //thickness=0.1 //x=1.12 //y=0.8 //x2=1.12 //y2=0.715
r1200 (  117 514 ) resistor r=41.4118 //w=0.187 //l=0.605 //layer=li \
 //thickness=0.1 //x=1.12 //y=0.8 //x2=1.12 //y2=1.405
r1201 (  116 514 ) resistor r=5.4201 //w=0.17 //l=0.085 //layer=li \
 //thickness=0.1 //x=1.12 //y=0.63 //x2=1.12 //y2=0.715
r1202 (  115 417 ) resistor r=5.21862 //w=0.35 //l=0.175 //layer=li \
 //thickness=0.1 //x=1.12 //y=0.35 //x2=1.12 //y2=0.175
r1203 (  115 116 ) resistor r=19.1658 //w=0.187 //l=0.28 //layer=li \
 //thickness=0.1 //x=1.12 //y=0.35 //x2=1.12 //y2=0.63
r1204 (  110 315 ) resistor r=3.1 //w=0.17 //l=0.51 //layer=mcon //count=3 \
 //x=29.35 //y=0.18 //x2=29.35 //y2=0.18
r1205 (  106 524 ) resistor r=9.3 //w=0.17 //l=0.17 //layer=mcon //count=1 \
 //x=29.42 //y=1.135 //x2=29.42 //y2=1.135
r1206 (  106 107 ) resistor r=0.0939994 //w=0.226 //l=0.13 //layer=m1 \
 //thickness=0.36 //x=29.417 //y=1.135 //x2=29.417 //y2=1.005
r1207 (  101 522 ) resistor r=9.3 //w=0.17 //l=0.17 //layer=mcon //count=1 \
 //x=23.87 //y=1.135 //x2=23.87 //y2=1.135
r1208 (  101 102 ) resistor r=0.0939994 //w=0.226 //l=0.13 //layer=m1 \
 //thickness=0.36 //x=23.867 //y=1.135 //x2=23.867 //y2=1.005
r1209 (  99 520 ) resistor r=9.3 //w=0.17 //l=0.17 //layer=mcon //count=1 \
 //x=18.32 //y=1.14 //x2=18.32 //y2=1.14
r1210 (  96 519 ) resistor r=9.3 //w=0.17 //l=0.17 //layer=mcon //count=1 \
 //x=14.99 //y=1.14 //x2=14.99 //y2=1.14
r1211 (  93 516 ) resistor r=9.3 //w=0.17 //l=0.17 //layer=mcon //count=1 \
 //x=7.22 //y=1.14 //x2=7.22 //y2=1.14
r1212 (  90 515 ) resistor r=9.3 //w=0.17 //l=0.17 //layer=mcon //count=1 \
 //x=3.89 //y=1.14 //x2=3.89 //y2=1.14
r1213 (  88 142 ) resistor r=3.1 //w=0.17 //l=0.51 //layer=mcon //count=3 \
 //x=3.82 //y=0.18 //x2=3.82 //y2=0.18
r1214 (  85 414 ) resistor r=9.3 //w=0.17 //l=0.17 //layer=mcon //count=1 \
 //x=38.97 //y=0.18 //x2=38.97 //y2=0.18
r1215 (  83 506 ) resistor r=3.1 //w=0.17 //l=0.51 //layer=mcon //count=3 \
 //x=38.23 //y=0.18 //x2=38.23 //y2=0.18
r1216 (  83 85 ) resistor r=0.297428 //w=0.311 //l=0.74 //layer=m1 \
 //thickness=0.36 //x=38.23 //y=0.175 //x2=38.97 //y2=0.175
r1217 (  81 388 ) resistor r=3.1 //w=0.17 //l=0.51 //layer=mcon //count=3 \
 //x=36.75 //y=0.18 //x2=36.75 //y2=0.18
r1218 (  81 83 ) resistor r=0.594855 //w=0.311 //l=1.48 //layer=m1 \
 //thickness=0.36 //x=36.75 //y=0.175 //x2=38.23 //y2=0.175
r1219 (  79 374 ) resistor r=3.1 //w=0.17 //l=0.51 //layer=mcon //count=3 \
 //x=35.64 //y=0.18 //x2=35.64 //y2=0.18
r1220 (  79 81 ) resistor r=0.446141 //w=0.311 //l=1.11 //layer=m1 \
 //thickness=0.36 //x=35.64 //y=0.175 //x2=36.75 //y2=0.175
r1221 (  77 494 ) resistor r=3.1 //w=0.17 //l=0.51 //layer=mcon //count=3 \
 //x=34.53 //y=0.18 //x2=34.53 //y2=0.18
r1222 (  77 79 ) resistor r=0.446141 //w=0.311 //l=1.11 //layer=m1 \
 //thickness=0.36 //x=34.53 //y=0.175 //x2=35.64 //y2=0.175
r1223 (  75 484 ) resistor r=3.1 //w=0.17 //l=0.51 //layer=mcon //count=3 \
 //x=33.05 //y=0.18 //x2=33.05 //y2=0.18
r1224 (  75 77 ) resistor r=0.594855 //w=0.311 //l=1.48 //layer=m1 \
 //thickness=0.36 //x=33.05 //y=0.175 //x2=34.53 //y2=0.175
r1225 (  73 328 ) resistor r=3.1 //w=0.17 //l=0.51 //layer=mcon //count=3 \
 //x=31.94 //y=0.18 //x2=31.94 //y2=0.18
r1226 (  73 75 ) resistor r=0.446141 //w=0.311 //l=1.11 //layer=m1 \
 //thickness=0.36 //x=31.94 //y=0.175 //x2=33.05 //y2=0.175
r1227 (  71 317 ) resistor r=3.1 //w=0.17 //l=0.51 //layer=mcon //count=3 \
 //x=30.46 //y=0.18 //x2=30.46 //y2=0.18
r1228 (  71 73 ) resistor r=0.594855 //w=0.311 //l=1.48 //layer=m1 \
 //thickness=0.36 //x=30.46 //y=0.175 //x2=31.94 //y2=0.175
r1229 (  69 110 ) resistor r=0.028033 //w=0.35 //l=0.085 //layer=m1 \
 //thickness=0.36 //x=29.505 //y=0.175 //x2=29.42 //y2=0.175
r1230 (  69 71 ) resistor r=0.383842 //w=0.311 //l=0.955 //layer=m1 \
 //thickness=0.36 //x=29.505 //y=0.175 //x2=30.46 //y2=0.175
r1231 (  67 110 ) resistor r=0.0413265 //w=0.7 //l=0.175 //layer=m1 \
 //thickness=0.36 //x=29.42 //y=0.35 //x2=29.42 //y2=0.175
r1232 (  67 107 ) resistor r=0.625 //w=0.131 //l=0.655 //layer=m1 \
 //thickness=0.36 //x=29.42 //y=0.35 //x2=29.42 //y2=1.005
r1233 (  66 309 ) resistor r=3.1 //w=0.17 //l=0.51 //layer=mcon //count=3 \
 //x=27.87 //y=0.18 //x2=27.87 //y2=0.18
r1234 (  64 470 ) resistor r=3.1 //w=0.17 //l=0.51 //layer=mcon //count=3 \
 //x=26.76 //y=0.18 //x2=26.76 //y2=0.18
r1235 (  64 66 ) resistor r=0.446141 //w=0.311 //l=1.11 //layer=m1 \
 //thickness=0.36 //x=26.76 //y=0.175 //x2=27.87 //y2=0.175
r1236 (  62 278 ) resistor r=3.1 //w=0.17 //l=0.51 //layer=mcon //count=3 \
 //x=25.28 //y=0.18 //x2=25.28 //y2=0.18
r1237 (  62 64 ) resistor r=0.594855 //w=0.311 //l=1.48 //layer=m1 \
 //thickness=0.36 //x=25.28 //y=0.175 //x2=26.76 //y2=0.175
r1238 (  60 276 ) resistor r=3.1 //w=0.17 //l=0.51 //layer=mcon //count=3 \
 //x=24.17 //y=0.18 //x2=24.17 //y2=0.18
r1239 (  60 62 ) resistor r=0.446141 //w=0.311 //l=1.11 //layer=m1 \
 //thickness=0.36 //x=24.17 //y=0.175 //x2=25.28 //y2=0.175
r1240 (  58 104 ) resistor r=0.028033 //w=0.35 //l=0.085 //layer=m1 \
 //thickness=0.36 //x=23.955 //y=0.175 //x2=23.87 //y2=0.175
r1241 (  58 60 ) resistor r=0.0864148 //w=0.311 //l=0.215 //layer=m1 \
 //thickness=0.36 //x=23.955 //y=0.175 //x2=24.17 //y2=0.175
r1242 (  57 110 ) resistor r=0.028033 //w=0.35 //l=0.085 //layer=m1 \
 //thickness=0.36 //x=29.335 //y=0.175 //x2=29.42 //y2=0.175
r1243 (  57 66 ) resistor r=0.588826 //w=0.311 //l=1.465 //layer=m1 \
 //thickness=0.36 //x=29.335 //y=0.175 //x2=27.87 //y2=0.175
r1244 (  55 104 ) resistor r=0.0413265 //w=0.7 //l=0.175 //layer=m1 \
 //thickness=0.36 //x=23.87 //y=0.35 //x2=23.87 //y2=0.175
r1245 (  55 102 ) resistor r=0.625 //w=0.131 //l=0.655 //layer=m1 \
 //thickness=0.36 //x=23.87 //y=0.35 //x2=23.87 //y2=1.005
r1246 (  54 274 ) resistor r=3.1 //w=0.17 //l=0.51 //layer=mcon //count=3 \
 //x=23.06 //y=0.18 //x2=23.06 //y2=0.18
r1247 (  52 458 ) resistor r=3.1 //w=0.17 //l=0.51 //layer=mcon //count=3 \
 //x=21.58 //y=0.18 //x2=21.58 //y2=0.18
r1248 (  52 54 ) resistor r=0.594855 //w=0.311 //l=1.48 //layer=m1 \
 //thickness=0.36 //x=21.58 //y=0.175 //x2=23.06 //y2=0.175
r1249 (  50 239 ) resistor r=3.1 //w=0.17 //l=0.51 //layer=mcon //count=3 \
 //x=20.1 //y=0.18 //x2=20.1 //y2=0.18
r1250 (  50 52 ) resistor r=0.594855 //w=0.311 //l=1.48 //layer=m1 \
 //thickness=0.36 //x=20.1 //y=0.175 //x2=21.58 //y2=0.175
r1251 (  47 237 ) resistor r=3.1 //w=0.17 //l=0.51 //layer=mcon //count=3 \
 //x=18.99 //y=0.18 //x2=18.99 //y2=0.18
r1252 (  45 97 ) resistor r=0.028033 //w=0.35 //l=0.085 //layer=m1 \
 //thickness=0.36 //x=18.405 //y=0.175 //x2=18.32 //y2=0.175
r1253 (  45 47 ) resistor r=0.235129 //w=0.311 //l=0.585 //layer=m1 \
 //thickness=0.36 //x=18.405 //y=0.175 //x2=18.99 //y2=0.175
r1254 (  44 104 ) resistor r=0.028033 //w=0.35 //l=0.085 //layer=m1 \
 //thickness=0.36 //x=23.785 //y=0.175 //x2=23.87 //y2=0.175
r1255 (  44 54 ) resistor r=0.291399 //w=0.311 //l=0.725 //layer=m1 \
 //thickness=0.36 //x=23.785 //y=0.175 //x2=23.06 //y2=0.175
r1256 (  43 99 ) resistor r=0.0717383 //w=0.224 //l=0.115 //layer=m1 \
 //thickness=0.36 //x=18.32 //y=1.025 //x2=18.32 //y2=1.14
r1257 (  42 97 ) resistor r=0.0413265 //w=0.7 //l=0.175 //layer=m1 \
 //thickness=0.36 //x=18.32 //y=0.35 //x2=18.32 //y2=0.175
r1258 (  42 43 ) resistor r=0.644084 //w=0.131 //l=0.675 //layer=m1 \
 //thickness=0.36 //x=18.32 //y=0.35 //x2=18.32 //y2=1.025
r1259 (  41 235 ) resistor r=3.1 //w=0.17 //l=0.51 //layer=mcon //count=3 \
 //x=17.88 //y=0.18 //x2=17.88 //y2=0.18
r1260 (  39 224 ) resistor r=3.1 //w=0.17 //l=0.51 //layer=mcon //count=3 \
 //x=16.4 //y=0.18 //x2=16.4 //y2=0.18
r1261 (  39 41 ) resistor r=0.594855 //w=0.311 //l=1.48 //layer=m1 \
 //thickness=0.36 //x=16.4 //y=0.175 //x2=17.88 //y2=0.175
r1262 (  37 222 ) resistor r=3.1 //w=0.17 //l=0.51 //layer=mcon //count=3 \
 //x=15.29 //y=0.18 //x2=15.29 //y2=0.18
r1263 (  37 39 ) resistor r=0.446141 //w=0.311 //l=1.11 //layer=m1 \
 //thickness=0.36 //x=15.29 //y=0.175 //x2=16.4 //y2=0.175
r1264 (  35 94 ) resistor r=0.028033 //w=0.35 //l=0.085 //layer=m1 \
 //thickness=0.36 //x=15.075 //y=0.175 //x2=14.99 //y2=0.175
r1265 (  35 37 ) resistor r=0.0864148 //w=0.311 //l=0.215 //layer=m1 \
 //thickness=0.36 //x=15.075 //y=0.175 //x2=15.29 //y2=0.175
r1266 (  34 97 ) resistor r=0.028033 //w=0.35 //l=0.085 //layer=m1 \
 //thickness=0.36 //x=18.235 //y=0.175 //x2=18.32 //y2=0.175
r1267 (  34 41 ) resistor r=0.142685 //w=0.311 //l=0.355 //layer=m1 \
 //thickness=0.36 //x=18.235 //y=0.175 //x2=17.88 //y2=0.175
r1268 (  33 96 ) resistor r=0.0713327 //w=0.229 //l=0.115996 //layer=m1 \
 //thickness=0.36 //x=14.99 //y=1.025 //x2=14.992 //y2=1.14
r1269 (  32 94 ) resistor r=0.0413265 //w=0.7 //l=0.175 //layer=m1 \
 //thickness=0.36 //x=14.99 //y=0.35 //x2=14.99 //y2=0.175
r1270 (  32 33 ) resistor r=0.644084 //w=0.131 //l=0.675 //layer=m1 \
 //thickness=0.36 //x=14.99 //y=0.35 //x2=14.99 //y2=1.025
r1271 (  31 220 ) resistor r=3.1 //w=0.17 //l=0.51 //layer=mcon //count=3 \
 //x=14.18 //y=0.18 //x2=14.18 //y2=0.18
r1272 (  29 445 ) resistor r=3.1 //w=0.17 //l=0.51 //layer=mcon //count=3 \
 //x=12.7 //y=0.18 //x2=12.7 //y2=0.18
r1273 (  29 31 ) resistor r=0.594855 //w=0.311 //l=1.48 //layer=m1 \
 //thickness=0.36 //x=12.7 //y=0.175 //x2=14.18 //y2=0.175
r1274 (  27 190 ) resistor r=3.1 //w=0.17 //l=0.51 //layer=mcon //count=3 \
 //x=11.22 //y=0.18 //x2=11.22 //y2=0.18
r1275 (  27 29 ) resistor r=0.594855 //w=0.311 //l=1.48 //layer=m1 \
 //thickness=0.36 //x=11.22 //y=0.175 //x2=12.7 //y2=0.175
r1276 (  25 433 ) resistor r=3.1 //w=0.17 //l=0.51 //layer=mcon //count=3 \
 //x=10.11 //y=0.18 //x2=10.11 //y2=0.18
r1277 (  25 27 ) resistor r=0.446141 //w=0.311 //l=1.11 //layer=m1 \
 //thickness=0.36 //x=10.11 //y=0.175 //x2=11.22 //y2=0.175
r1278 (  23 159 ) resistor r=3.1 //w=0.17 //l=0.51 //layer=mcon //count=3 \
 //x=8.63 //y=0.18 //x2=8.63 //y2=0.18
r1279 (  23 25 ) resistor r=0.594855 //w=0.311 //l=1.48 //layer=m1 \
 //thickness=0.36 //x=8.63 //y=0.175 //x2=10.11 //y2=0.175
r1280 (  21 157 ) resistor r=3.1 //w=0.17 //l=0.51 //layer=mcon //count=3 \
 //x=7.52 //y=0.18 //x2=7.52 //y2=0.18
r1281 (  21 23 ) resistor r=0.446141 //w=0.311 //l=1.11 //layer=m1 \
 //thickness=0.36 //x=7.52 //y=0.175 //x2=8.63 //y2=0.175
r1282 (  19 91 ) resistor r=0.028033 //w=0.35 //l=0.085 //layer=m1 \
 //thickness=0.36 //x=7.305 //y=0.175 //x2=7.22 //y2=0.175
r1283 (  19 21 ) resistor r=0.0864148 //w=0.311 //l=0.215 //layer=m1 \
 //thickness=0.36 //x=7.305 //y=0.175 //x2=7.52 //y2=0.175
r1284 (  18 94 ) resistor r=0.028033 //w=0.35 //l=0.085 //layer=m1 \
 //thickness=0.36 //x=14.905 //y=0.175 //x2=14.99 //y2=0.175
r1285 (  18 31 ) resistor r=0.291399 //w=0.311 //l=0.725 //layer=m1 \
 //thickness=0.36 //x=14.905 //y=0.175 //x2=14.18 //y2=0.175
r1286 (  17 93 ) resistor r=0.0717383 //w=0.224 //l=0.115 //layer=m1 \
 //thickness=0.36 //x=7.22 //y=1.025 //x2=7.22 //y2=1.14
r1287 (  16 91 ) resistor r=0.0413265 //w=0.7 //l=0.175 //layer=m1 \
 //thickness=0.36 //x=7.22 //y=0.35 //x2=7.22 //y2=0.175
r1288 (  16 17 ) resistor r=0.644084 //w=0.131 //l=0.675 //layer=m1 \
 //thickness=0.36 //x=7.22 //y=0.35 //x2=7.22 //y2=1.025
r1289 (  15 155 ) resistor r=3.1 //w=0.17 //l=0.51 //layer=mcon //count=3 \
 //x=6.41 //y=0.18 //x2=6.41 //y2=0.18
r1290 (  13 144 ) resistor r=3.1 //w=0.17 //l=0.51 //layer=mcon //count=3 \
 //x=4.93 //y=0.18 //x2=4.93 //y2=0.18
r1291 (  13 15 ) resistor r=0.594855 //w=0.311 //l=1.48 //layer=m1 \
 //thickness=0.36 //x=4.93 //y=0.175 //x2=6.41 //y2=0.175
r1292 (  11 88 ) resistor r=0.028033 //w=0.35 //l=0.085 //layer=m1 \
 //thickness=0.36 //x=3.975 //y=0.175 //x2=3.89 //y2=0.175
r1293 (  11 13 ) resistor r=0.383842 //w=0.311 //l=0.955 //layer=m1 \
 //thickness=0.36 //x=3.975 //y=0.175 //x2=4.93 //y2=0.175
r1294 (  10 91 ) resistor r=0.028033 //w=0.35 //l=0.085 //layer=m1 \
 //thickness=0.36 //x=7.135 //y=0.175 //x2=7.22 //y2=0.175
r1295 (  10 15 ) resistor r=0.291399 //w=0.311 //l=0.725 //layer=m1 \
 //thickness=0.36 //x=7.135 //y=0.175 //x2=6.41 //y2=0.175
r1296 (  9 90 ) resistor r=0.0713327 //w=0.229 //l=0.115996 //layer=m1 \
 //thickness=0.36 //x=3.89 //y=1.025 //x2=3.892 //y2=1.14
r1297 (  8 88 ) resistor r=0.0413265 //w=0.7 //l=0.175 //layer=m1 \
 //thickness=0.36 //x=3.89 //y=0.35 //x2=3.89 //y2=0.175
r1298 (  8 9 ) resistor r=0.644084 //w=0.131 //l=0.675 //layer=m1 \
 //thickness=0.36 //x=3.89 //y=0.35 //x2=3.89 //y2=1.025
r1299 (  7 136 ) resistor r=3.1 //w=0.17 //l=0.51 //layer=mcon //count=3 \
 //x=2.34 //y=0.18 //x2=2.34 //y2=0.18
r1300 (  4 419 ) resistor r=3.1 //w=0.17 //l=0.51 //layer=mcon //count=3 \
 //x=1.23 //y=0.18 //x2=1.23 //y2=0.18
r1301 (  4 7 ) resistor r=0.446141 //w=0.311 //l=1.11 //layer=m1 \
 //thickness=0.36 //x=1.23 //y=0.175 //x2=2.34 //y2=0.175
r1302 (  2 88 ) resistor r=0.028033 //w=0.35 //l=0.085 //layer=m1 \
 //thickness=0.36 //x=3.805 //y=0.175 //x2=3.89 //y2=0.175
r1303 (  2 7 ) resistor r=0.588826 //w=0.311 //l=1.465 //layer=m1 \
 //thickness=0.36 //x=3.805 //y=0.175 //x2=2.34 //y2=0.175
r1304 (  1 50 ) resistor r=0.0743569 //w=0.311 //l=0.185 //layer=m1 \
 //thickness=0.36 //x=19.915 //y=0.175 //x2=20.1 //y2=0.175
r1305 (  1 47 ) resistor r=0.371785 //w=0.311 //l=0.925 //layer=m1 \
 //thickness=0.36 //x=19.915 //y=0.175 //x2=18.99 //y2=0.175
ends PM_FA\%GND

subckt PM_FA\%noxref_21 ( 1 3 5 10 14 17 20 30 46 47 48 )
c95 ( 48 0 ) capacitor c=0.0349673f //x=36.195 //y=5.205
c96 ( 46 0 ) capacitor c=0.0118024f //x=34.445 //y=5.205
c97 ( 30 0 ) capacitor c=0.0293098f //x=35.46 //y=5.56
c98 ( 20 0 ) capacitor c=0.0452975f //x=34.58 //y=5.56
c99 ( 17 0 ) capacitor c=0.0163612f //x=36.34 //y=6.92
c100 ( 14 0 ) capacitor c=0.00603088f //x=35.46 //y=6.92
c101 ( 10 0 ) capacitor c=0.0095276f //x=35.46 //y=5.39
c102 ( 5 0 ) capacitor c=0.0113293f //x=34.58 //y=5.39
c103 ( 3 0 ) capacitor c=0.00694548f //x=36.21 //y=7.09
c104 ( 1 0 ) capacitor c=0.0125072f //x=35.34 //y=5.39
r105 (  37 47 ) resistor r=23.2727 //w=0.187 //l=0.34 //layer=li \
 //thickness=0.1 //x=35.46 //y=6.92 //x2=35.46 //y2=6.58
r106 (  30 47 ) resistor r=23.2727 //w=0.187 //l=0.34 //layer=li \
 //thickness=0.1 //x=35.46 //y=5.56 //x2=35.46 //y2=5.9
r107 (  20 46 ) resistor r=23.2727 //w=0.187 //l=0.34 //layer=li \
 //thickness=0.1 //x=34.58 //y=5.56 //x2=34.58 //y2=5.9
r108 (  17 48 ) resistor r=9.3 //w=0.17 //l=0.17 //layer=mcon //count=1 \
 //x=36.34 //y=6.92 //x2=36.34 //y2=6.92
r109 (  17 18 ) resistor r=0.0932018 //w=0.228 //l=0.17 //layer=m1 \
 //thickness=0.36 //x=36.332 //y=6.92 //x2=36.332 //y2=7.09
r110 (  14 37 ) resistor r=9.3 //w=0.17 //l=0.17 //layer=mcon //count=1 \
 //x=35.46 //y=6.92 //x2=35.46 //y2=6.92
r111 (  14 15 ) resistor r=0.0992991 //w=0.214 //l=0.17 //layer=m1 \
 //thickness=0.36 //x=35.46 //y=6.92 //x2=35.46 //y2=7.09
r112 (  12 30 ) resistor r=9.3 //w=0.17 //l=0.17 //layer=mcon //count=1 \
 //x=35.46 //y=5.56 //x2=35.46 //y2=5.56
r113 (  10 12 ) resistor r=0.097032 //w=0.219 //l=0.17 //layer=m1 \
 //thickness=0.36 //x=35.46 //y=5.39 //x2=35.46 //y2=5.56
r114 (  7 20 ) resistor r=9.3 //w=0.17 //l=0.17 //layer=mcon //count=1 \
 //x=34.58 //y=5.56 //x2=34.58 //y2=5.56
r115 (  5 7 ) resistor r=0.0997653 //w=0.213 //l=0.17 //layer=m1 \
 //thickness=0.36 //x=34.58 //y=5.39 //x2=34.58 //y2=5.56
r116 (  4 15 ) resistor r=0.0213909 //w=0.214 //l=0.115 //layer=m1 \
 //thickness=0.36 //x=35.575 //y=7.09 //x2=35.46 //y2=7.09
r117 (  3 18 ) resistor r=0.0251868 //w=0.228 //l=0.122 //layer=m1 \
 //thickness=0.36 //x=36.21 //y=7.09 //x2=36.332 //y2=7.09
r118 (  3 4 ) resistor r=0.605916 //w=0.131 //l=0.635 //layer=m1 \
 //thickness=0.36 //x=36.21 //y=7.09 //x2=35.575 //y2=7.09
r119 (  2 5 ) resistor r=0.0211096 //w=0.213 //l=0.115 //layer=m1 \
 //thickness=0.36 //x=34.695 //y=5.39 //x2=34.58 //y2=5.39
r120 (  1 10 ) resistor r=0.0227762 //w=0.219 //l=0.12 //layer=m1 \
 //thickness=0.36 //x=35.34 //y=5.39 //x2=35.46 //y2=5.39
r121 (  1 2 ) resistor r=0.615458 //w=0.131 //l=0.645 //layer=m1 \
 //thickness=0.36 //x=35.34 //y=5.39 //x2=34.695 //y2=5.39
ends PM_FA\%noxref_21

subckt PM_FA\%COUT ( 1 2 3 4 5 6 7 9 11 12 13 14 15 26 36 43 45 )
c79 ( 43 0 ) capacitor c=0.00875839f //x=38.045 //y=1.09
c80 ( 36 0 ) capacitor c=0.0261959f //x=38.235 //y=5.56
c81 ( 26 0 ) capacitor c=0.0191272f //x=38.23 //y=1.185
c82 ( 15 0 ) capacitor c=0.00557311f //x=38.32 //y=5.14
c83 ( 14 0 ) capacitor c=0.00944012f //x=38.515 //y=5.14
c84 ( 13 0 ) capacitor c=0.00724565f //x=38.315 //y=2.02
c85 ( 12 0 ) capacitor c=0.0145753f //x=38.515 //y=2.02
c86 ( 11 0 ) capacitor c=0.0117594f //x=38.235 //y=5.42
c87 ( 9 0 ) capacitor c=0.0170096f //x=38.23 //y=1.935
c88 ( 1 0 ) capacitor c=0.115689f //x=38.6 //y=2.4
r89 (  36 45 ) resistor r=23.615 //w=0.187 //l=0.345 //layer=li \
 //thickness=0.1 //x=38.235 //y=5.56 //x2=38.235 //y2=5.905
r90 (  29 36 ) resistor r=9.3 //w=0.17 //l=0.17 //layer=mcon //count=1 \
 //x=38.235 //y=5.56 //x2=38.235 //y2=5.56
r91 (  26 43 ) resistor r=9.3 //w=0.17 //l=0.17 //layer=mcon //count=1 \
 //x=38.23 //y=1.185 //x2=38.23 //y2=1.185
r92 (  14 17 ) resistor r=0.0698411 //w=0.17 //l=0.120208 //layer=m1 \
 //thickness=0.36 //x=38.515 //y=5.14 //x2=38.6 //y2=5.055
r93 (  14 15 ) resistor r=0.186069 //w=0.131 //l=0.195 //layer=m1 \
 //thickness=0.36 //x=38.515 //y=5.14 //x2=38.32 //y2=5.14
r94 (  12 16 ) resistor r=0.0698411 //w=0.17 //l=0.120208 //layer=m1 \
 //thickness=0.36 //x=38.515 //y=2.02 //x2=38.6 //y2=2.105
r95 (  12 13 ) resistor r=0.19084 //w=0.131 //l=0.2 //layer=m1 \
 //thickness=0.36 //x=38.515 //y=2.02 //x2=38.315 //y2=2.02
r96 (  11 29 ) resistor r=0.086672 //w=0.218 //l=0.14 //layer=m1 \
 //thickness=0.36 //x=38.235 //y=5.42 //x2=38.235 //y2=5.56
r97 (  10 15 ) resistor r=0.0698411 //w=0.17 //l=0.120208 //layer=m1 \
 //thickness=0.36 //x=38.235 //y=5.225 //x2=38.32 //y2=5.14
r98 (  10 11 ) resistor r=0.186069 //w=0.131 //l=0.195 //layer=m1 \
 //thickness=0.36 //x=38.235 //y=5.225 //x2=38.235 //y2=5.42
r99 (  9 13 ) resistor r=0.0698411 //w=0.17 //l=0.120208 //layer=m1 \
 //thickness=0.36 //x=38.23 //y=1.935 //x2=38.315 //y2=2.02
r100 (  8 26 ) resistor r=0.105739 //w=0.201 //l=0.145 //layer=m1 \
 //thickness=0.36 //x=38.23 //y=1.33 //x2=38.23 //y2=1.185
r101 (  8 9 ) resistor r=0.57729 //w=0.131 //l=0.605 //layer=m1 \
 //thickness=0.36 //x=38.23 //y=1.33 //x2=38.23 //y2=1.935
r102 (  7 17 ) resistor r=0.415076 //w=0.131 //l=0.435 //layer=m1 \
 //thickness=0.36 //x=38.6 //y=4.62 //x2=38.6 //y2=5.055
r103 (  6 7 ) resistor r=0.353053 //w=0.131 //l=0.37 //layer=m1 \
 //thickness=0.36 //x=38.6 //y=4.25 //x2=38.6 //y2=4.62
r104 (  5 6 ) resistor r=0.353053 //w=0.131 //l=0.37 //layer=m1 \
 //thickness=0.36 //x=38.6 //y=3.88 //x2=38.6 //y2=4.25
r105 (  4 5 ) resistor r=0.353053 //w=0.131 //l=0.37 //layer=m1 \
 //thickness=0.36 //x=38.6 //y=3.51 //x2=38.6 //y2=3.88
r106 (  3 4 ) resistor r=0.353053 //w=0.131 //l=0.37 //layer=m1 \
 //thickness=0.36 //x=38.6 //y=3.14 //x2=38.6 //y2=3.51
r107 (  2 3 ) resistor r=0.353053 //w=0.131 //l=0.37 //layer=m1 \
 //thickness=0.36 //x=38.6 //y=2.77 //x2=38.6 //y2=3.14
r108 (  1 2 ) resistor r=0.353053 //w=0.131 //l=0.37 //layer=m1 \
 //thickness=0.36 //x=38.6 //y=2.4 //x2=38.6 //y2=2.77
r109 (  1 16 ) resistor r=0.281489 //w=0.131 //l=0.295 //layer=m1 \
 //thickness=0.36 //x=38.6 //y=2.4 //x2=38.6 //y2=2.105
ends PM_FA\%COUT

subckt PM_FA\%noxref_23 ( 1 5 9 10 13 17 29 )
c62 ( 29 0 ) capacitor c=0.0666923f //x=3.27 //y=0.55
c63 ( 17 0 ) capacitor c=0.00679669f //x=5.345 //y=0.8
c64 ( 13 0 ) capacitor c=0.0158488f //x=5.26 //y=0.715
c65 ( 10 0 ) capacitor c=0.00717747f //x=4.375 //y=1.68
c66 ( 9 0 ) capacitor c=0.00771051f //x=4.375 //y=0.8
c67 ( 5 0 ) capacitor c=0.0177631f //x=4.29 //y=1.765
c68 ( 1 0 ) capacitor c=0.00784591f //x=3.405 //y=1.68
r69 (  17 29 ) resistor r=3.57586 //w=0.17 //l=0.125 //layer=li \
 //thickness=0.1 //x=5.345 //y=0.8 //x2=5.345 //y2=0.675
r70 (  17 29 ) resistor r=18.139 //w=0.187 //l=0.265 //layer=li \
 //thickness=0.1 //x=5.345 //y=0.8 //x2=5.345 //y2=1.065
r71 (  14 29 ) resistor r=3.57586 //w=0.17 //l=0.103078 //layer=li \
 //thickness=0.1 //x=4.46 //y=0.715 //x2=4.375 //y2=0.675
r72 (  14 29 ) resistor r=27.3797 //w=0.187 //l=0.4 //layer=li //thickness=0.1 \
 //x=4.46 //y=0.715 //x2=4.86 //y2=0.715
r73 (  13 29 ) resistor r=3.57586 //w=0.17 //l=0.103078 //layer=li \
 //thickness=0.1 //x=5.26 //y=0.715 //x2=5.345 //y2=0.675
r74 (  13 29 ) resistor r=27.3797 //w=0.187 //l=0.4 //layer=li //thickness=0.1 \
 //x=5.26 //y=0.715 //x2=4.86 //y2=0.715
r75 (  10 29 ) resistor r=3.57586 //w=0.17 //l=0.125 //layer=li \
 //thickness=0.1 //x=4.375 //y=1.68 //x2=4.375 //y2=1.805
r76 (  10 29 ) resistor r=42.0963 //w=0.187 //l=0.615 //layer=li \
 //thickness=0.1 //x=4.375 //y=1.68 //x2=4.375 //y2=1.065
r77 (  9 29 ) resistor r=3.57586 //w=0.17 //l=0.125 //layer=li //thickness=0.1 \
 //x=4.375 //y=0.8 //x2=4.375 //y2=0.675
r78 (  9 29 ) resistor r=18.139 //w=0.187 //l=0.265 //layer=li //thickness=0.1 \
 //x=4.375 //y=0.8 //x2=4.375 //y2=1.065
r79 (  6 29 ) resistor r=3.57586 //w=0.17 //l=0.103078 //layer=li \
 //thickness=0.1 //x=3.49 //y=1.765 //x2=3.405 //y2=1.805
r80 (  6 29 ) resistor r=27.3797 //w=0.187 //l=0.4 //layer=li //thickness=0.1 \
 //x=3.49 //y=1.765 //x2=3.89 //y2=1.765
r81 (  5 29 ) resistor r=3.57586 //w=0.17 //l=0.103078 //layer=li \
 //thickness=0.1 //x=4.29 //y=1.765 //x2=4.375 //y2=1.805
r82 (  5 29 ) resistor r=27.3797 //w=0.187 //l=0.4 //layer=li //thickness=0.1 \
 //x=4.29 //y=1.765 //x2=3.89 //y2=1.765
r83 (  1 29 ) resistor r=3.57586 //w=0.17 //l=0.125 //layer=li //thickness=0.1 \
 //x=3.405 //y=1.68 //x2=3.405 //y2=1.805
r84 (  1 29 ) resistor r=42.0963 //w=0.187 //l=0.615 //layer=li \
 //thickness=0.1 //x=3.405 //y=1.68 //x2=3.405 //y2=1.065
ends PM_FA\%noxref_23

subckt PM_FA\%noxref_24 ( 1 5 9 10 13 17 29 )
c64 ( 29 0 ) capacitor c=0.0669098f //x=6.6 //y=0.55
c65 ( 17 0 ) capacitor c=0.0071081f //x=8.675 //y=0.8
c66 ( 13 0 ) capacitor c=0.0158527f //x=8.59 //y=0.715
c67 ( 10 0 ) capacitor c=0.00719086f //x=7.705 //y=1.68
c68 ( 9 0 ) capacitor c=0.00771051f //x=7.705 //y=0.8
c69 ( 5 0 ) capacitor c=0.0178223f //x=7.62 //y=1.765
c70 ( 1 0 ) capacitor c=0.00749308f //x=6.735 //y=1.68
r71 (  17 29 ) resistor r=3.57586 //w=0.17 //l=0.125 //layer=li \
 //thickness=0.1 //x=8.675 //y=0.8 //x2=8.675 //y2=0.675
r72 (  17 29 ) resistor r=18.139 //w=0.187 //l=0.265 //layer=li \
 //thickness=0.1 //x=8.675 //y=0.8 //x2=8.675 //y2=1.065
r73 (  14 29 ) resistor r=3.57586 //w=0.17 //l=0.103078 //layer=li \
 //thickness=0.1 //x=7.79 //y=0.715 //x2=7.705 //y2=0.675
r74 (  14 29 ) resistor r=27.3797 //w=0.187 //l=0.4 //layer=li //thickness=0.1 \
 //x=7.79 //y=0.715 //x2=8.19 //y2=0.715
r75 (  13 29 ) resistor r=3.57586 //w=0.17 //l=0.103078 //layer=li \
 //thickness=0.1 //x=8.59 //y=0.715 //x2=8.675 //y2=0.675
r76 (  13 29 ) resistor r=27.3797 //w=0.187 //l=0.4 //layer=li //thickness=0.1 \
 //x=8.59 //y=0.715 //x2=8.19 //y2=0.715
r77 (  10 29 ) resistor r=3.57586 //w=0.17 //l=0.125 //layer=li \
 //thickness=0.1 //x=7.705 //y=1.68 //x2=7.705 //y2=1.805
r78 (  10 29 ) resistor r=42.0963 //w=0.187 //l=0.615 //layer=li \
 //thickness=0.1 //x=7.705 //y=1.68 //x2=7.705 //y2=1.065
r79 (  9 29 ) resistor r=3.57586 //w=0.17 //l=0.125 //layer=li //thickness=0.1 \
 //x=7.705 //y=0.8 //x2=7.705 //y2=0.675
r80 (  9 29 ) resistor r=18.139 //w=0.187 //l=0.265 //layer=li //thickness=0.1 \
 //x=7.705 //y=0.8 //x2=7.705 //y2=1.065
r81 (  6 29 ) resistor r=3.57586 //w=0.17 //l=0.103078 //layer=li \
 //thickness=0.1 //x=6.82 //y=1.765 //x2=6.735 //y2=1.805
r82 (  6 29 ) resistor r=27.3797 //w=0.187 //l=0.4 //layer=li //thickness=0.1 \
 //x=6.82 //y=1.765 //x2=7.22 //y2=1.765
r83 (  5 29 ) resistor r=3.57586 //w=0.17 //l=0.103078 //layer=li \
 //thickness=0.1 //x=7.62 //y=1.765 //x2=7.705 //y2=1.805
r84 (  5 29 ) resistor r=27.3797 //w=0.187 //l=0.4 //layer=li //thickness=0.1 \
 //x=7.62 //y=1.765 //x2=7.22 //y2=1.765
r85 (  1 29 ) resistor r=3.57586 //w=0.17 //l=0.125 //layer=li //thickness=0.1 \
 //x=6.735 //y=1.68 //x2=6.735 //y2=1.805
r86 (  1 29 ) resistor r=42.0963 //w=0.187 //l=0.615 //layer=li \
 //thickness=0.1 //x=6.735 //y=1.68 //x2=6.735 //y2=1.065
ends PM_FA\%noxref_24

subckt PM_FA\%noxref_25 ( 1 5 9 10 13 17 29 )
c61 ( 29 0 ) capacitor c=0.0666923f //x=14.37 //y=0.55
c62 ( 17 0 ) capacitor c=0.00679669f //x=16.445 //y=0.8
c63 ( 13 0 ) capacitor c=0.0158488f //x=16.36 //y=0.715
c64 ( 10 0 ) capacitor c=0.00717747f //x=15.475 //y=1.68
c65 ( 9 0 ) capacitor c=0.00771051f //x=15.475 //y=0.8
c66 ( 5 0 ) capacitor c=0.0178141f //x=15.39 //y=1.765
c67 ( 1 0 ) capacitor c=0.00760967f //x=14.505 //y=1.68
r68 (  17 29 ) resistor r=3.57586 //w=0.17 //l=0.125 //layer=li \
 //thickness=0.1 //x=16.445 //y=0.8 //x2=16.445 //y2=0.675
r69 (  17 29 ) resistor r=18.139 //w=0.187 //l=0.265 //layer=li \
 //thickness=0.1 //x=16.445 //y=0.8 //x2=16.445 //y2=1.065
r70 (  14 29 ) resistor r=3.57586 //w=0.17 //l=0.103078 //layer=li \
 //thickness=0.1 //x=15.56 //y=0.715 //x2=15.475 //y2=0.675
r71 (  14 29 ) resistor r=27.3797 //w=0.187 //l=0.4 //layer=li //thickness=0.1 \
 //x=15.56 //y=0.715 //x2=15.96 //y2=0.715
r72 (  13 29 ) resistor r=3.57586 //w=0.17 //l=0.103078 //layer=li \
 //thickness=0.1 //x=16.36 //y=0.715 //x2=16.445 //y2=0.675
r73 (  13 29 ) resistor r=27.3797 //w=0.187 //l=0.4 //layer=li //thickness=0.1 \
 //x=16.36 //y=0.715 //x2=15.96 //y2=0.715
r74 (  10 29 ) resistor r=3.57586 //w=0.17 //l=0.125 //layer=li \
 //thickness=0.1 //x=15.475 //y=1.68 //x2=15.475 //y2=1.805
r75 (  10 29 ) resistor r=42.0963 //w=0.187 //l=0.615 //layer=li \
 //thickness=0.1 //x=15.475 //y=1.68 //x2=15.475 //y2=1.065
r76 (  9 29 ) resistor r=3.57586 //w=0.17 //l=0.125 //layer=li //thickness=0.1 \
 //x=15.475 //y=0.8 //x2=15.475 //y2=0.675
r77 (  9 29 ) resistor r=18.139 //w=0.187 //l=0.265 //layer=li //thickness=0.1 \
 //x=15.475 //y=0.8 //x2=15.475 //y2=1.065
r78 (  6 29 ) resistor r=3.57586 //w=0.17 //l=0.103078 //layer=li \
 //thickness=0.1 //x=14.59 //y=1.765 //x2=14.505 //y2=1.805
r79 (  6 29 ) resistor r=27.3797 //w=0.187 //l=0.4 //layer=li //thickness=0.1 \
 //x=14.59 //y=1.765 //x2=14.99 //y2=1.765
r80 (  5 29 ) resistor r=3.57586 //w=0.17 //l=0.103078 //layer=li \
 //thickness=0.1 //x=15.39 //y=1.765 //x2=15.475 //y2=1.805
r81 (  5 29 ) resistor r=27.3797 //w=0.187 //l=0.4 //layer=li //thickness=0.1 \
 //x=15.39 //y=1.765 //x2=14.99 //y2=1.765
r82 (  1 29 ) resistor r=3.57586 //w=0.17 //l=0.125 //layer=li //thickness=0.1 \
 //x=14.505 //y=1.68 //x2=14.505 //y2=1.805
r83 (  1 29 ) resistor r=42.0963 //w=0.187 //l=0.615 //layer=li \
 //thickness=0.1 //x=14.505 //y=1.68 //x2=14.505 //y2=1.065
ends PM_FA\%noxref_25

subckt PM_FA\%noxref_26 ( 1 5 9 10 13 17 29 )
c64 ( 29 0 ) capacitor c=0.0669098f //x=17.7 //y=0.55
c65 ( 17 0 ) capacitor c=0.0071081f //x=19.775 //y=0.8
c66 ( 13 0 ) capacitor c=0.0158527f //x=19.69 //y=0.715
c67 ( 10 0 ) capacitor c=0.00719086f //x=18.805 //y=1.68
c68 ( 9 0 ) capacitor c=0.00771051f //x=18.805 //y=0.8
c69 ( 5 0 ) capacitor c=0.0178223f //x=18.72 //y=1.765
c70 ( 1 0 ) capacitor c=0.00749308f //x=17.835 //y=1.68
r71 (  17 29 ) resistor r=3.57586 //w=0.17 //l=0.125 //layer=li \
 //thickness=0.1 //x=19.775 //y=0.8 //x2=19.775 //y2=0.675
r72 (  17 29 ) resistor r=18.139 //w=0.187 //l=0.265 //layer=li \
 //thickness=0.1 //x=19.775 //y=0.8 //x2=19.775 //y2=1.065
r73 (  14 29 ) resistor r=3.57586 //w=0.17 //l=0.103078 //layer=li \
 //thickness=0.1 //x=18.89 //y=0.715 //x2=18.805 //y2=0.675
r74 (  14 29 ) resistor r=27.3797 //w=0.187 //l=0.4 //layer=li //thickness=0.1 \
 //x=18.89 //y=0.715 //x2=19.29 //y2=0.715
r75 (  13 29 ) resistor r=3.57586 //w=0.17 //l=0.103078 //layer=li \
 //thickness=0.1 //x=19.69 //y=0.715 //x2=19.775 //y2=0.675
r76 (  13 29 ) resistor r=27.3797 //w=0.187 //l=0.4 //layer=li //thickness=0.1 \
 //x=19.69 //y=0.715 //x2=19.29 //y2=0.715
r77 (  10 29 ) resistor r=3.57586 //w=0.17 //l=0.125 //layer=li \
 //thickness=0.1 //x=18.805 //y=1.68 //x2=18.805 //y2=1.805
r78 (  10 29 ) resistor r=42.0963 //w=0.187 //l=0.615 //layer=li \
 //thickness=0.1 //x=18.805 //y=1.68 //x2=18.805 //y2=1.065
r79 (  9 29 ) resistor r=3.57586 //w=0.17 //l=0.125 //layer=li //thickness=0.1 \
 //x=18.805 //y=0.8 //x2=18.805 //y2=0.675
r80 (  9 29 ) resistor r=18.139 //w=0.187 //l=0.265 //layer=li //thickness=0.1 \
 //x=18.805 //y=0.8 //x2=18.805 //y2=1.065
r81 (  6 29 ) resistor r=3.57586 //w=0.17 //l=0.103078 //layer=li \
 //thickness=0.1 //x=17.92 //y=1.765 //x2=17.835 //y2=1.805
r82 (  6 29 ) resistor r=27.3797 //w=0.187 //l=0.4 //layer=li //thickness=0.1 \
 //x=17.92 //y=1.765 //x2=18.32 //y2=1.765
r83 (  5 29 ) resistor r=3.57586 //w=0.17 //l=0.103078 //layer=li \
 //thickness=0.1 //x=18.72 //y=1.765 //x2=18.805 //y2=1.805
r84 (  5 29 ) resistor r=27.3797 //w=0.187 //l=0.4 //layer=li //thickness=0.1 \
 //x=18.72 //y=1.765 //x2=18.32 //y2=1.765
r85 (  1 29 ) resistor r=3.57586 //w=0.17 //l=0.125 //layer=li //thickness=0.1 \
 //x=17.835 //y=1.68 //x2=17.835 //y2=1.805
r86 (  1 29 ) resistor r=42.0963 //w=0.187 //l=0.615 //layer=li \
 //thickness=0.1 //x=17.835 //y=1.68 //x2=17.835 //y2=1.065
ends PM_FA\%noxref_26

subckt PM_FA\%noxref_27 ( 1 5 9 10 13 17 29 )
c66 ( 29 0 ) capacitor c=0.0666771f //x=23.25 //y=0.545
c67 ( 17 0 ) capacitor c=0.00709791f //x=25.325 //y=0.795
c68 ( 13 0 ) capacitor c=0.0154704f //x=25.24 //y=0.71
c69 ( 10 0 ) capacitor c=0.00656886f //x=24.355 //y=1.675
c70 ( 9 0 ) capacitor c=0.00770028f //x=24.355 //y=0.795
c71 ( 5 0 ) capacitor c=0.0177333f //x=24.27 //y=1.76
c72 ( 1 0 ) capacitor c=0.0076108f //x=23.385 //y=1.675
r73 (  17 29 ) resistor r=3.57586 //w=0.17 //l=0.125 //layer=li \
 //thickness=0.1 //x=25.325 //y=0.795 //x2=25.325 //y2=0.67
r74 (  17 29 ) resistor r=18.139 //w=0.187 //l=0.265 //layer=li \
 //thickness=0.1 //x=25.325 //y=0.795 //x2=25.325 //y2=1.06
r75 (  14 29 ) resistor r=3.57586 //w=0.17 //l=0.103078 //layer=li \
 //thickness=0.1 //x=24.44 //y=0.71 //x2=24.355 //y2=0.67
r76 (  14 29 ) resistor r=27.3797 //w=0.187 //l=0.4 //layer=li //thickness=0.1 \
 //x=24.44 //y=0.71 //x2=24.84 //y2=0.71
r77 (  13 29 ) resistor r=3.57586 //w=0.17 //l=0.103078 //layer=li \
 //thickness=0.1 //x=25.24 //y=0.71 //x2=25.325 //y2=0.67
r78 (  13 29 ) resistor r=27.3797 //w=0.187 //l=0.4 //layer=li //thickness=0.1 \
 //x=25.24 //y=0.71 //x2=24.84 //y2=0.71
r79 (  10 29 ) resistor r=3.57586 //w=0.17 //l=0.125 //layer=li \
 //thickness=0.1 //x=24.355 //y=1.675 //x2=24.355 //y2=1.8
r80 (  10 29 ) resistor r=42.0963 //w=0.187 //l=0.615 //layer=li \
 //thickness=0.1 //x=24.355 //y=1.675 //x2=24.355 //y2=1.06
r81 (  9 29 ) resistor r=3.57586 //w=0.17 //l=0.125 //layer=li //thickness=0.1 \
 //x=24.355 //y=0.795 //x2=24.355 //y2=0.67
r82 (  9 29 ) resistor r=18.139 //w=0.187 //l=0.265 //layer=li //thickness=0.1 \
 //x=24.355 //y=0.795 //x2=24.355 //y2=1.06
r83 (  6 29 ) resistor r=3.57586 //w=0.17 //l=0.103078 //layer=li \
 //thickness=0.1 //x=23.47 //y=1.76 //x2=23.385 //y2=1.8
r84 (  6 29 ) resistor r=27.3797 //w=0.187 //l=0.4 //layer=li //thickness=0.1 \
 //x=23.47 //y=1.76 //x2=23.87 //y2=1.76
r85 (  5 29 ) resistor r=3.57586 //w=0.17 //l=0.103078 //layer=li \
 //thickness=0.1 //x=24.27 //y=1.76 //x2=24.355 //y2=1.8
r86 (  5 29 ) resistor r=27.3797 //w=0.187 //l=0.4 //layer=li //thickness=0.1 \
 //x=24.27 //y=1.76 //x2=23.87 //y2=1.76
r87 (  1 29 ) resistor r=3.57586 //w=0.17 //l=0.125 //layer=li //thickness=0.1 \
 //x=23.385 //y=1.675 //x2=23.385 //y2=1.8
r88 (  1 29 ) resistor r=42.0963 //w=0.187 //l=0.615 //layer=li \
 //thickness=0.1 //x=23.385 //y=1.675 //x2=23.385 //y2=1.06
ends PM_FA\%noxref_27

subckt PM_FA\%noxref_28 ( 1 5 9 10 13 17 29 )
c66 ( 29 0 ) capacitor c=0.0668358f //x=28.8 //y=0.545
c67 ( 17 0 ) capacitor c=0.00709791f //x=30.875 //y=0.795
c68 ( 13 0 ) capacitor c=0.0155842f //x=30.79 //y=0.71
c69 ( 10 0 ) capacitor c=0.00656649f //x=29.905 //y=1.675
c70 ( 9 0 ) capacitor c=0.00770028f //x=29.905 //y=0.795
c71 ( 5 0 ) capacitor c=0.017625f //x=29.82 //y=1.76
c72 ( 1 0 ) capacitor c=0.0076108f //x=28.935 //y=1.675
r73 (  17 29 ) resistor r=3.57586 //w=0.17 //l=0.125 //layer=li \
 //thickness=0.1 //x=30.875 //y=0.795 //x2=30.875 //y2=0.67
r74 (  17 29 ) resistor r=18.139 //w=0.187 //l=0.265 //layer=li \
 //thickness=0.1 //x=30.875 //y=0.795 //x2=30.875 //y2=1.06
r75 (  14 29 ) resistor r=3.57586 //w=0.17 //l=0.103078 //layer=li \
 //thickness=0.1 //x=29.99 //y=0.71 //x2=29.905 //y2=0.67
r76 (  14 29 ) resistor r=27.3797 //w=0.187 //l=0.4 //layer=li //thickness=0.1 \
 //x=29.99 //y=0.71 //x2=30.39 //y2=0.71
r77 (  13 29 ) resistor r=3.57586 //w=0.17 //l=0.103078 //layer=li \
 //thickness=0.1 //x=30.79 //y=0.71 //x2=30.875 //y2=0.67
r78 (  13 29 ) resistor r=27.3797 //w=0.187 //l=0.4 //layer=li //thickness=0.1 \
 //x=30.79 //y=0.71 //x2=30.39 //y2=0.71
r79 (  10 29 ) resistor r=3.57586 //w=0.17 //l=0.125 //layer=li \
 //thickness=0.1 //x=29.905 //y=1.675 //x2=29.905 //y2=1.8
r80 (  10 29 ) resistor r=42.0963 //w=0.187 //l=0.615 //layer=li \
 //thickness=0.1 //x=29.905 //y=1.675 //x2=29.905 //y2=1.06
r81 (  9 29 ) resistor r=3.57586 //w=0.17 //l=0.125 //layer=li //thickness=0.1 \
 //x=29.905 //y=0.795 //x2=29.905 //y2=0.67
r82 (  9 29 ) resistor r=18.139 //w=0.187 //l=0.265 //layer=li //thickness=0.1 \
 //x=29.905 //y=0.795 //x2=29.905 //y2=1.06
r83 (  6 29 ) resistor r=3.57586 //w=0.17 //l=0.103078 //layer=li \
 //thickness=0.1 //x=29.02 //y=1.76 //x2=28.935 //y2=1.8
r84 (  6 29 ) resistor r=27.3797 //w=0.187 //l=0.4 //layer=li //thickness=0.1 \
 //x=29.02 //y=1.76 //x2=29.42 //y2=1.76
r85 (  5 29 ) resistor r=3.57586 //w=0.17 //l=0.103078 //layer=li \
 //thickness=0.1 //x=29.82 //y=1.76 //x2=29.905 //y2=1.8
r86 (  5 29 ) resistor r=27.3797 //w=0.187 //l=0.4 //layer=li //thickness=0.1 \
 //x=29.82 //y=1.76 //x2=29.42 //y2=1.76
r87 (  1 29 ) resistor r=3.57586 //w=0.17 //l=0.125 //layer=li //thickness=0.1 \
 //x=28.935 //y=1.675 //x2=28.935 //y2=1.8
r88 (  1 29 ) resistor r=42.0963 //w=0.187 //l=0.615 //layer=li \
 //thickness=0.1 //x=28.935 //y=1.675 //x2=28.935 //y2=1.06
ends PM_FA\%noxref_28
