// File: FA.spi.pex
// Created: Tue Apr 29 10:42:19 2025
// Program "Calibre xRC"
// Version "v2023.2_27.15"
// Nominal Temperature: 30C
// Circuit Temperature: 30C
//
simulator lang=spectre
subckt PM_FA\%GND ( 1 65 77 81 84 89 95 101 107 115 123 126 131 135 143 149 \
 157 161 164 169 173 181 189 197 205 208 213 217 220 225 229 237 245 248 253 \
 257 260 265 271 277 283 288 293 297 305 309 317 321 329 333 341 347 355 359 \
 370 373 384 387 389 401 413 415 417 429 431 443 446 458 478 490 491 492 493 \
 494 495 496 497 498 499 500 501 502 503 )
c557 ( 503 0 ) capacitor c=0.0600351f //x=37.615 //y=0.55
c558 ( 502 0 ) capacitor c=0.0699417f //x=34.35 //y=0.545
c559 ( 501 0 ) capacitor c=0.0572698f //x=32.065 //y=0.55
c560 ( 500 0 ) capacitor c=0.0207059f //x=29.23 //y=1.045
c561 ( 499 0 ) capacitor c=0.0562172f //x=26.515 //y=0.55
c562 ( 498 0 ) capacitor c=0.0207059f //x=23.68 //y=1.045
c563 ( 497 0 ) capacitor c=0.0561337f //x=20.965 //y=0.55
c564 ( 496 0 ) capacitor c=0.0209533f //x=18.13 //y=1.05
c565 ( 495 0 ) capacitor c=0.0209533f //x=14.8 //y=1.05
c566 ( 494 0 ) capacitor c=0.0561337f //x=12.085 //y=0.55
c567 ( 493 0 ) capacitor c=0.0561337f //x=9.865 //y=0.55
c568 ( 492 0 ) capacitor c=0.0209533f //x=7.03 //y=1.05
c569 ( 491 0 ) capacitor c=0.0209533f //x=3.7 //y=1.05
c570 ( 490 0 ) capacitor c=0.0582171f //x=0.985 //y=0.55
c571 ( 478 0 ) capacitor c=0.0993634f //x=37.12 //y=0.175
c572 ( 458 0 ) capacitor c=0.102886f //x=33.79 //y=0.175
c573 ( 446 0 ) capacitor c=0.099911f //x=31.57 //y=0.175
c574 ( 445 0 ) capacitor c=0.00446416f //x=29.35 //y=0.18
c575 ( 443 0 ) capacitor c=0.100523f //x=28.24 //y=0.175
c576 ( 431 0 ) capacitor c=0.100735f //x=26.02 //y=0.175
c577 ( 430 0 ) capacitor c=0.00446416f //x=23.87 //y=0.175
c578 ( 429 0 ) capacitor c=0.0987836f //x=22.69 //y=0.175
c579 ( 417 0 ) capacitor c=0.100557f //x=20.47 //y=0.175
c580 ( 416 0 ) capacitor c=0.0044644f //x=18.32 //y=0.175
c581 ( 415 0 ) capacitor c=0.103551f //x=17.14 //y=0.175
c582 ( 414 0 ) capacitor c=0.0044644f //x=14.99 //y=0.175
c583 ( 413 0 ) capacitor c=0.100023f //x=13.81 //y=0.175
c584 ( 401 0 ) capacitor c=0.092299f //x=11.59 //y=0.175
c585 ( 389 0 ) capacitor c=0.101518f //x=9.37 //y=0.175
c586 ( 388 0 ) capacitor c=0.0044644f //x=7.22 //y=0.175
c587 ( 387 0 ) capacitor c=0.103596f //x=6.04 //y=0.175
c588 ( 386 0 ) capacitor c=0.0044644f //x=3.82 //y=0.18
c589 ( 384 0 ) capacitor c=0.101054f //x=2.71 //y=0.175
c590 ( 373 0 ) capacitor c=0.211195f //x=1.12 //y=0.175
c591 ( 370 0 ) capacitor c=0.217003f //x=38.97 //y=0.18
c592 ( 368 0 ) capacitor c=0.036681f //x=38.805 //y=0.175
c593 ( 362 0 ) capacitor c=0.00587411f //x=38.72 //y=0.63
c594 ( 359 0 ) capacitor c=0.00542565f //x=38.635 //y=0.715
c595 ( 358 0 ) capacitor c=0.00479856f //x=38.235 //y=0.63
c596 ( 355 0 ) capacitor c=0.0068422f //x=38.15 //y=0.715
c597 ( 350 0 ) capacitor c=0.00592191f //x=37.75 //y=0.63
c598 ( 347 0 ) capacitor c=0.0166308f //x=37.665 //y=0.175
c599 ( 342 0 ) capacitor c=0.0671735f //x=36.51 //y=0.175
c600 ( 341 0 ) capacitor c=0.0197476f //x=36.95 //y=0.175
c601 ( 336 0 ) capacitor c=0.00609805f //x=36.425 //y=0.625
c602 ( 333 0 ) capacitor c=0.00508472f //x=36.34 //y=0.71
c603 ( 332 0 ) capacitor c=0.00468234f //x=35.94 //y=0.625
c604 ( 329 0 ) capacitor c=0.00551137f //x=35.855 //y=0.71
c605 ( 324 0 ) capacitor c=0.00468234f //x=35.455 //y=0.625
c606 ( 321 0 ) capacitor c=0.00533847f //x=35.37 //y=0.71
c607 ( 320 0 ) capacitor c=0.00468234f //x=34.97 //y=0.625
c608 ( 317 0 ) capacitor c=0.00625038f //x=34.885 //y=0.71
c609 ( 312 0 ) capacitor c=0.00609805f //x=34.485 //y=0.625
c610 ( 309 0 ) capacitor c=0.0197476f //x=34.4 //y=0.175
c611 ( 306 0 ) capacitor c=0.0367f //x=33.255 //y=0.175
c612 ( 305 0 ) capacitor c=0.0161513f //x=33.62 //y=0.175
c613 ( 300 0 ) capacitor c=0.00583665f //x=33.17 //y=0.63
c614 ( 297 0 ) capacitor c=0.00531815f //x=33.085 //y=0.715
c615 ( 296 0 ) capacitor c=0.00479856f //x=32.685 //y=0.63
c616 ( 293 0 ) capacitor c=0.006266f //x=32.6 //y=0.715
c617 ( 288 0 ) capacitor c=0.00588377f //x=32.2 //y=0.63
c618 ( 283 0 ) capacitor c=0.0166308f //x=32.115 //y=0.175
c619 ( 277 0 ) capacitor c=0.0727159f //x=31.4 //y=0.175
c620 ( 271 0 ) capacitor c=0.0392227f //x=29.335 //y=0.175
c621 ( 266 0 ) capacitor c=0.0366941f //x=27.705 //y=0.175
c622 ( 265 0 ) capacitor c=0.0161513f //x=28.07 //y=0.175
c623 ( 260 0 ) capacitor c=0.00583665f //x=27.62 //y=0.63
c624 ( 257 0 ) capacitor c=0.00514646f //x=27.535 //y=0.715
c625 ( 256 0 ) capacitor c=0.00479856f //x=27.135 //y=0.63
c626 ( 253 0 ) capacitor c=0.00591695f //x=27.05 //y=0.715
c627 ( 248 0 ) capacitor c=0.00588377f //x=26.65 //y=0.63
c628 ( 245 0 ) capacitor c=0.0166308f //x=26.565 //y=0.175
c629 ( 237 0 ) capacitor c=0.0726593f //x=25.85 //y=0.175
c630 ( 229 0 ) capacitor c=0.0392227f //x=23.785 //y=0.175
c631 ( 226 0 ) capacitor c=0.0366941f //x=22.145 //y=0.175
c632 ( 225 0 ) capacitor c=0.0166308f //x=22.52 //y=0.175
c633 ( 220 0 ) capacitor c=0.00588377f //x=22.06 //y=0.63
c634 ( 217 0 ) capacitor c=0.00591695f //x=21.975 //y=0.715
c635 ( 216 0 ) capacitor c=0.00479856f //x=21.575 //y=0.63
c636 ( 213 0 ) capacitor c=0.00514646f //x=21.49 //y=0.715
c637 ( 208 0 ) capacitor c=0.00587411f //x=21.09 //y=0.63
c638 ( 205 0 ) capacitor c=0.0161513f //x=21.005 //y=0.175
c639 ( 197 0 ) capacitor c=0.0728506f //x=20.3 //y=0.175
c640 ( 189 0 ) capacitor c=0.0392414f //x=18.235 //y=0.175
c641 ( 181 0 ) capacitor c=0.0728506f //x=16.97 //y=0.175
c642 ( 173 0 ) capacitor c=0.0392414f //x=14.905 //y=0.175
c643 ( 170 0 ) capacitor c=0.0366941f //x=13.275 //y=0.175
c644 ( 169 0 ) capacitor c=0.0161513f //x=13.64 //y=0.175
c645 ( 164 0 ) capacitor c=0.00587411f //x=13.19 //y=0.63
c646 ( 161 0 ) capacitor c=0.00514646f //x=13.105 //y=0.715
c647 ( 160 0 ) capacitor c=0.00479856f //x=12.705 //y=0.63
c648 ( 157 0 ) capacitor c=0.00591695f //x=12.62 //y=0.715
c649 ( 152 0 ) capacitor c=0.00592191f //x=12.22 //y=0.63
c650 ( 149 0 ) capacitor c=0.0166308f //x=12.135 //y=0.175
c651 ( 144 0 ) capacitor c=0.0366941f //x=11.045 //y=0.175
c652 ( 143 0 ) capacitor c=0.0166308f //x=11.42 //y=0.175
c653 ( 138 0 ) capacitor c=0.00592191f //x=10.96 //y=0.63
c654 ( 135 0 ) capacitor c=0.00591695f //x=10.875 //y=0.715
c655 ( 134 0 ) capacitor c=0.00479856f //x=10.475 //y=0.63
c656 ( 131 0 ) capacitor c=0.00514646f //x=10.39 //y=0.715
c657 ( 126 0 ) capacitor c=0.00587411f //x=9.99 //y=0.63
c658 ( 123 0 ) capacitor c=0.0161513f //x=9.905 //y=0.175
c659 ( 115 0 ) capacitor c=0.0728506f //x=9.2 //y=0.175
c660 ( 107 0 ) capacitor c=0.0392414f //x=7.135 //y=0.175
c661 ( 101 0 ) capacitor c=0.0728506f //x=5.87 //y=0.175
c662 ( 95 0 ) capacitor c=0.0392748f //x=3.805 //y=0.175
c663 ( 90 0 ) capacitor c=0.0366794f //x=2.175 //y=0.175
c664 ( 89 0 ) capacitor c=0.0161513f //x=2.54 //y=0.175
c665 ( 84 0 ) capacitor c=0.00587411f //x=2.09 //y=0.63
c666 ( 81 0 ) capacitor c=0.0053436f //x=2.005 //y=0.715
c667 ( 80 0 ) capacitor c=0.00479856f //x=1.605 //y=0.63
c668 ( 77 0 ) capacitor c=0.00707849f //x=1.52 //y=0.715
c669 ( 72 0 ) capacitor c=0.00592191f //x=1.12 //y=0.63
c670 ( 65 0 ) capacitor c=1.27069f //x=38.97 //y=0.18
r671 (  482 483 ) resistor r=16.9155 //w=0.367 //l=0.485 //layer=li \
 //thickness=0.1 //x=38.235 //y=0.175 //x2=38.72 //y2=0.175
r672 (  481 482 ) resistor r=0.174387 //w=0.367 //l=0.005 //layer=li \
 //thickness=0.1 //x=38.23 //y=0.175 //x2=38.235 //y2=0.175
r673 (  479 481 ) resistor r=16.7411 //w=0.367 //l=0.48 //layer=li \
 //thickness=0.1 //x=37.75 //y=0.175 //x2=38.23 //y2=0.175
r674 (  466 467 ) resistor r=16.9155 //w=0.367 //l=0.485 //layer=li \
 //thickness=0.1 //x=35.94 //y=0.175 //x2=36.425 //y2=0.175
r675 (  465 466 ) resistor r=10.4632 //w=0.367 //l=0.3 //layer=li \
 //thickness=0.1 //x=35.64 //y=0.175 //x2=35.94 //y2=0.175
r676 (  463 465 ) resistor r=6.45232 //w=0.367 //l=0.185 //layer=li \
 //thickness=0.1 //x=35.455 //y=0.175 //x2=35.64 //y2=0.175
r677 (  462 463 ) resistor r=16.9155 //w=0.367 //l=0.485 //layer=li \
 //thickness=0.1 //x=34.97 //y=0.175 //x2=35.455 //y2=0.175
r678 (  461 462 ) resistor r=15.346 //w=0.367 //l=0.44 //layer=li \
 //thickness=0.1 //x=34.53 //y=0.175 //x2=34.97 //y2=0.175
r679 (  459 461 ) resistor r=1.56948 //w=0.367 //l=0.045 //layer=li \
 //thickness=0.1 //x=34.485 //y=0.175 //x2=34.53 //y2=0.175
r680 (  450 451 ) resistor r=4.18529 //w=0.367 //l=0.12 //layer=li \
 //thickness=0.1 //x=33.05 //y=0.175 //x2=33.17 //y2=0.175
r681 (  448 450 ) resistor r=12.7302 //w=0.367 //l=0.365 //layer=li \
 //thickness=0.1 //x=32.685 //y=0.175 //x2=33.05 //y2=0.175
r682 (  447 448 ) resistor r=16.9155 //w=0.367 //l=0.485 //layer=li \
 //thickness=0.1 //x=32.2 //y=0.175 //x2=32.685 //y2=0.175
r683 (  435 436 ) resistor r=16.9155 //w=0.367 //l=0.485 //layer=li \
 //thickness=0.1 //x=27.135 //y=0.175 //x2=27.62 //y2=0.175
r684 (  434 435 ) resistor r=13.079 //w=0.367 //l=0.375 //layer=li \
 //thickness=0.1 //x=26.76 //y=0.175 //x2=27.135 //y2=0.175
r685 (  432 434 ) resistor r=3.83651 //w=0.367 //l=0.11 //layer=li \
 //thickness=0.1 //x=26.65 //y=0.175 //x2=26.76 //y2=0.175
r686 (  421 422 ) resistor r=16.7411 //w=0.367 //l=0.48 //layer=li \
 //thickness=0.1 //x=21.58 //y=0.175 //x2=22.06 //y2=0.175
r687 (  419 421 ) resistor r=0.174387 //w=0.367 //l=0.005 //layer=li \
 //thickness=0.1 //x=21.575 //y=0.175 //x2=21.58 //y2=0.175
r688 (  418 419 ) resistor r=16.9155 //w=0.367 //l=0.485 //layer=li \
 //thickness=0.1 //x=21.09 //y=0.175 //x2=21.575 //y2=0.175
r689 (  405 406 ) resistor r=16.9155 //w=0.367 //l=0.485 //layer=li \
 //thickness=0.1 //x=12.705 //y=0.175 //x2=13.19 //y2=0.175
r690 (  404 405 ) resistor r=0.174387 //w=0.367 //l=0.005 //layer=li \
 //thickness=0.1 //x=12.7 //y=0.175 //x2=12.705 //y2=0.175
r691 (  402 404 ) resistor r=16.7411 //w=0.367 //l=0.48 //layer=li \
 //thickness=0.1 //x=12.22 //y=0.175 //x2=12.7 //y2=0.175
r692 (  393 394 ) resistor r=16.9155 //w=0.367 //l=0.485 //layer=li \
 //thickness=0.1 //x=10.475 //y=0.175 //x2=10.96 //y2=0.175
r693 (  392 393 ) resistor r=12.7302 //w=0.367 //l=0.365 //layer=li \
 //thickness=0.1 //x=10.11 //y=0.175 //x2=10.475 //y2=0.175
r694 (  390 392 ) resistor r=4.18529 //w=0.367 //l=0.12 //layer=li \
 //thickness=0.1 //x=9.99 //y=0.175 //x2=10.11 //y2=0.175
r695 (  376 377 ) resistor r=16.9155 //w=0.367 //l=0.485 //layer=li \
 //thickness=0.1 //x=1.605 //y=0.175 //x2=2.09 //y2=0.175
r696 (  375 376 ) resistor r=13.079 //w=0.367 //l=0.375 //layer=li \
 //thickness=0.1 //x=1.23 //y=0.175 //x2=1.605 //y2=0.175
r697 (  373 375 ) resistor r=3.83651 //w=0.367 //l=0.11 //layer=li \
 //thickness=0.1 //x=1.12 //y=0.175 //x2=1.23 //y2=0.175
r698 (  368 483 ) resistor r=2.96458 //w=0.367 //l=0.085 //layer=li \
 //thickness=0.1 //x=38.805 //y=0.175 //x2=38.72 //y2=0.175
r699 (  368 370 ) resistor r=5.75477 //w=0.367 //l=0.165 //layer=li \
 //thickness=0.1 //x=38.805 //y=0.175 //x2=38.97 //y2=0.175
r700 (  363 503 ) resistor r=5.4201 //w=0.17 //l=0.085 //layer=li \
 //thickness=0.1 //x=38.72 //y=0.8 //x2=38.72 //y2=0.715
r701 (  363 503 ) resistor r=41.4118 //w=0.187 //l=0.605 //layer=li \
 //thickness=0.1 //x=38.72 //y=0.8 //x2=38.72 //y2=1.405
r702 (  362 503 ) resistor r=5.4201 //w=0.17 //l=0.085 //layer=li \
 //thickness=0.1 //x=38.72 //y=0.63 //x2=38.72 //y2=0.715
r703 (  361 483 ) resistor r=5.21862 //w=0.35 //l=0.175 //layer=li \
 //thickness=0.1 //x=38.72 //y=0.35 //x2=38.72 //y2=0.175
r704 (  361 362 ) resistor r=19.1658 //w=0.187 //l=0.28 //layer=li \
 //thickness=0.1 //x=38.72 //y=0.35 //x2=38.72 //y2=0.63
r705 (  360 503 ) resistor r=5.4201 //w=0.17 //l=0.085 //layer=li \
 //thickness=0.1 //x=38.32 //y=0.715 //x2=38.235 //y2=0.715
r706 (  359 503 ) resistor r=1.40859 //w=0.34 //l=0.085 //layer=li \
 //thickness=0.1 //x=38.635 //y=0.715 //x2=38.72 //y2=0.715
r707 (  359 360 ) resistor r=21.5615 //w=0.187 //l=0.315 //layer=li \
 //thickness=0.1 //x=38.635 //y=0.715 //x2=38.32 //y2=0.715
r708 (  358 503 ) resistor r=1.40859 //w=0.34 //l=0.085 //layer=li \
 //thickness=0.1 //x=38.235 //y=0.63 //x2=38.235 //y2=0.715
r709 (  357 482 ) resistor r=5.21862 //w=0.35 //l=0.175 //layer=li \
 //thickness=0.1 //x=38.235 //y=0.35 //x2=38.235 //y2=0.175
r710 (  357 358 ) resistor r=19.1658 //w=0.187 //l=0.28 //layer=li \
 //thickness=0.1 //x=38.235 //y=0.35 //x2=38.235 //y2=0.63
r711 (  356 503 ) resistor r=1.40859 //w=0.34 //l=0.085 //layer=li \
 //thickness=0.1 //x=37.835 //y=0.715 //x2=37.75 //y2=0.715
r712 (  355 503 ) resistor r=5.4201 //w=0.17 //l=0.085 //layer=li \
 //thickness=0.1 //x=38.15 //y=0.715 //x2=38.235 //y2=0.715
r713 (  355 356 ) resistor r=21.5615 //w=0.187 //l=0.315 //layer=li \
 //thickness=0.1 //x=38.15 //y=0.715 //x2=37.835 //y2=0.715
r714 (  351 503 ) resistor r=5.4201 //w=0.17 //l=0.085 //layer=li \
 //thickness=0.1 //x=37.75 //y=0.8 //x2=37.75 //y2=0.715
r715 (  351 503 ) resistor r=41.4118 //w=0.187 //l=0.605 //layer=li \
 //thickness=0.1 //x=37.75 //y=0.8 //x2=37.75 //y2=1.405
r716 (  350 503 ) resistor r=5.4201 //w=0.17 //l=0.085 //layer=li \
 //thickness=0.1 //x=37.75 //y=0.63 //x2=37.75 //y2=0.715
r717 (  349 479 ) resistor r=5.21862 //w=0.35 //l=0.175 //layer=li \
 //thickness=0.1 //x=37.75 //y=0.35 //x2=37.75 //y2=0.175
r718 (  349 350 ) resistor r=19.1658 //w=0.187 //l=0.28 //layer=li \
 //thickness=0.1 //x=37.75 //y=0.35 //x2=37.75 //y2=0.63
r719 (  348 478 ) resistor r=5.29055 //w=0.35 //l=0.17 //layer=li \
 //thickness=0.1 //x=37.29 //y=0.175 //x2=37.12 //y2=0.175
r720 (  347 479 ) resistor r=2.96458 //w=0.367 //l=0.085 //layer=li \
 //thickness=0.1 //x=37.665 //y=0.175 //x2=37.75 //y2=0.175
r721 (  347 348 ) resistor r=13.079 //w=0.367 //l=0.375 //layer=li \
 //thickness=0.1 //x=37.665 //y=0.175 //x2=37.29 //y2=0.175
r722 (  342 467 ) resistor r=2.96458 //w=0.367 //l=0.085 //layer=li \
 //thickness=0.1 //x=36.51 //y=0.175 //x2=36.425 //y2=0.175
r723 (  342 344 ) resistor r=8.37057 //w=0.367 //l=0.24 //layer=li \
 //thickness=0.1 //x=36.51 //y=0.175 //x2=36.75 //y2=0.175
r724 (  341 478 ) resistor r=5.29055 //w=0.35 //l=0.17 //layer=li \
 //thickness=0.1 //x=36.95 //y=0.175 //x2=37.12 //y2=0.175
r725 (  341 344 ) resistor r=6.97548 //w=0.367 //l=0.2 //layer=li \
 //thickness=0.1 //x=36.95 //y=0.175 //x2=36.75 //y2=0.175
r726 (  337 502 ) resistor r=5.4201 //w=0.17 //l=0.085 //layer=li \
 //thickness=0.1 //x=36.425 //y=0.795 //x2=36.425 //y2=0.71
r727 (  337 502 ) resistor r=18.139 //w=0.187 //l=0.265 //layer=li \
 //thickness=0.1 //x=36.425 //y=0.795 //x2=36.425 //y2=1.06
r728 (  336 502 ) resistor r=5.4201 //w=0.17 //l=0.085 //layer=li \
 //thickness=0.1 //x=36.425 //y=0.625 //x2=36.425 //y2=0.71
r729 (  335 467 ) resistor r=5.21862 //w=0.35 //l=0.175 //layer=li \
 //thickness=0.1 //x=36.425 //y=0.35 //x2=36.425 //y2=0.175
r730 (  335 336 ) resistor r=18.8235 //w=0.187 //l=0.275 //layer=li \
 //thickness=0.1 //x=36.425 //y=0.35 //x2=36.425 //y2=0.625
r731 (  334 502 ) resistor r=5.4201 //w=0.17 //l=0.085 //layer=li \
 //thickness=0.1 //x=36.025 //y=0.71 //x2=35.94 //y2=0.71
r732 (  333 502 ) resistor r=1.40859 //w=0.34 //l=0.085 //layer=li \
 //thickness=0.1 //x=36.34 //y=0.71 //x2=36.425 //y2=0.71
r733 (  333 334 ) resistor r=21.5615 //w=0.187 //l=0.315 //layer=li \
 //thickness=0.1 //x=36.34 //y=0.71 //x2=36.025 //y2=0.71
r734 (  332 502 ) resistor r=1.40859 //w=0.34 //l=0.085 //layer=li \
 //thickness=0.1 //x=35.94 //y=0.625 //x2=35.94 //y2=0.71
r735 (  331 466 ) resistor r=5.21862 //w=0.35 //l=0.175 //layer=li \
 //thickness=0.1 //x=35.94 //y=0.35 //x2=35.94 //y2=0.175
r736 (  331 332 ) resistor r=18.8235 //w=0.187 //l=0.275 //layer=li \
 //thickness=0.1 //x=35.94 //y=0.35 //x2=35.94 //y2=0.625
r737 (  330 502 ) resistor r=6.4 //w=0.17 //l=0.085 //layer=li //thickness=0.1 \
 //x=35.54 //y=0.71 //x2=35.455 //y2=0.71
r738 (  329 502 ) resistor r=5.4201 //w=0.17 //l=0.085 //layer=li \
 //thickness=0.1 //x=35.855 //y=0.71 //x2=35.94 //y2=0.71
r739 (  329 330 ) resistor r=21.5615 //w=0.187 //l=0.315 //layer=li \
 //thickness=0.1 //x=35.855 //y=0.71 //x2=35.54 //y2=0.71
r740 (  325 502 ) resistor r=6.4 //w=0.17 //l=0.085 //layer=li //thickness=0.1 \
 //x=35.455 //y=0.795 //x2=35.455 //y2=0.71
r741 (  325 502 ) resistor r=18.139 //w=0.187 //l=0.265 //layer=li \
 //thickness=0.1 //x=35.455 //y=0.795 //x2=35.455 //y2=1.06
r742 (  324 502 ) resistor r=6.4 //w=0.17 //l=0.085 //layer=li //thickness=0.1 \
 //x=35.455 //y=0.625 //x2=35.455 //y2=0.71
r743 (  323 463 ) resistor r=5.21862 //w=0.35 //l=0.175 //layer=li \
 //thickness=0.1 //x=35.455 //y=0.35 //x2=35.455 //y2=0.175
r744 (  323 324 ) resistor r=18.8235 //w=0.187 //l=0.275 //layer=li \
 //thickness=0.1 //x=35.455 //y=0.35 //x2=35.455 //y2=0.625
r745 (  322 502 ) resistor r=5.4201 //w=0.17 //l=0.085 //layer=li \
 //thickness=0.1 //x=35.055 //y=0.71 //x2=34.97 //y2=0.71
r746 (  321 502 ) resistor r=6.4 //w=0.17 //l=0.085 //layer=li //thickness=0.1 \
 //x=35.37 //y=0.71 //x2=35.455 //y2=0.71
r747 (  321 322 ) resistor r=21.5615 //w=0.187 //l=0.315 //layer=li \
 //thickness=0.1 //x=35.37 //y=0.71 //x2=35.055 //y2=0.71
r748 (  320 502 ) resistor r=1.40859 //w=0.34 //l=0.085 //layer=li \
 //thickness=0.1 //x=34.97 //y=0.625 //x2=34.97 //y2=0.71
r749 (  319 462 ) resistor r=5.21862 //w=0.35 //l=0.175 //layer=li \
 //thickness=0.1 //x=34.97 //y=0.35 //x2=34.97 //y2=0.175
r750 (  319 320 ) resistor r=18.8235 //w=0.187 //l=0.275 //layer=li \
 //thickness=0.1 //x=34.97 //y=0.35 //x2=34.97 //y2=0.625
r751 (  318 502 ) resistor r=1.40859 //w=0.34 //l=0.085 //layer=li \
 //thickness=0.1 //x=34.57 //y=0.71 //x2=34.485 //y2=0.71
r752 (  317 502 ) resistor r=5.4201 //w=0.17 //l=0.085 //layer=li \
 //thickness=0.1 //x=34.885 //y=0.71 //x2=34.97 //y2=0.71
r753 (  317 318 ) resistor r=21.5615 //w=0.187 //l=0.315 //layer=li \
 //thickness=0.1 //x=34.885 //y=0.71 //x2=34.57 //y2=0.71
r754 (  313 502 ) resistor r=5.4201 //w=0.17 //l=0.085 //layer=li \
 //thickness=0.1 //x=34.485 //y=0.795 //x2=34.485 //y2=0.71
r755 (  313 502 ) resistor r=41.4118 //w=0.187 //l=0.605 //layer=li \
 //thickness=0.1 //x=34.485 //y=0.795 //x2=34.485 //y2=1.4
r756 (  312 502 ) resistor r=5.4201 //w=0.17 //l=0.085 //layer=li \
 //thickness=0.1 //x=34.485 //y=0.625 //x2=34.485 //y2=0.71
r757 (  311 459 ) resistor r=5.21862 //w=0.35 //l=0.175 //layer=li \
 //thickness=0.1 //x=34.485 //y=0.35 //x2=34.485 //y2=0.175
r758 (  311 312 ) resistor r=18.8235 //w=0.187 //l=0.275 //layer=li \
 //thickness=0.1 //x=34.485 //y=0.35 //x2=34.485 //y2=0.625
r759 (  310 458 ) resistor r=5.29055 //w=0.35 //l=0.17 //layer=li \
 //thickness=0.1 //x=33.96 //y=0.175 //x2=33.79 //y2=0.175
r760 (  309 459 ) resistor r=2.96458 //w=0.367 //l=0.085 //layer=li \
 //thickness=0.1 //x=34.4 //y=0.175 //x2=34.485 //y2=0.175
r761 (  309 310 ) resistor r=15.346 //w=0.367 //l=0.44 //layer=li \
 //thickness=0.1 //x=34.4 //y=0.175 //x2=33.96 //y2=0.175
r762 (  306 451 ) resistor r=2.96458 //w=0.367 //l=0.085 //layer=li \
 //thickness=0.1 //x=33.255 //y=0.175 //x2=33.17 //y2=0.175
r763 (  305 458 ) resistor r=5.29055 //w=0.35 //l=0.17 //layer=li \
 //thickness=0.1 //x=33.62 //y=0.175 //x2=33.79 //y2=0.175
r764 (  305 306 ) resistor r=12.7302 //w=0.367 //l=0.365 //layer=li \
 //thickness=0.1 //x=33.62 //y=0.175 //x2=33.255 //y2=0.175
r765 (  301 501 ) resistor r=5.4201 //w=0.17 //l=0.085 //layer=li \
 //thickness=0.1 //x=33.17 //y=0.8 //x2=33.17 //y2=0.715
r766 (  301 501 ) resistor r=41.4118 //w=0.187 //l=0.605 //layer=li \
 //thickness=0.1 //x=33.17 //y=0.8 //x2=33.17 //y2=1.405
r767 (  300 501 ) resistor r=5.4201 //w=0.17 //l=0.085 //layer=li \
 //thickness=0.1 //x=33.17 //y=0.63 //x2=33.17 //y2=0.715
r768 (  299 451 ) resistor r=5.21862 //w=0.35 //l=0.175 //layer=li \
 //thickness=0.1 //x=33.17 //y=0.35 //x2=33.17 //y2=0.175
r769 (  299 300 ) resistor r=19.1658 //w=0.187 //l=0.28 //layer=li \
 //thickness=0.1 //x=33.17 //y=0.35 //x2=33.17 //y2=0.63
r770 (  298 501 ) resistor r=5.4201 //w=0.17 //l=0.085 //layer=li \
 //thickness=0.1 //x=32.77 //y=0.715 //x2=32.685 //y2=0.715
r771 (  297 501 ) resistor r=1.40859 //w=0.34 //l=0.085 //layer=li \
 //thickness=0.1 //x=33.085 //y=0.715 //x2=33.17 //y2=0.715
r772 (  297 298 ) resistor r=21.5615 //w=0.187 //l=0.315 //layer=li \
 //thickness=0.1 //x=33.085 //y=0.715 //x2=32.77 //y2=0.715
r773 (  296 501 ) resistor r=1.40859 //w=0.34 //l=0.085 //layer=li \
 //thickness=0.1 //x=32.685 //y=0.63 //x2=32.685 //y2=0.715
r774 (  295 448 ) resistor r=5.21862 //w=0.35 //l=0.175 //layer=li \
 //thickness=0.1 //x=32.685 //y=0.35 //x2=32.685 //y2=0.175
r775 (  295 296 ) resistor r=19.1658 //w=0.187 //l=0.28 //layer=li \
 //thickness=0.1 //x=32.685 //y=0.35 //x2=32.685 //y2=0.63
r776 (  294 501 ) resistor r=1.40859 //w=0.34 //l=0.085 //layer=li \
 //thickness=0.1 //x=32.285 //y=0.715 //x2=32.2 //y2=0.715
r777 (  293 501 ) resistor r=5.4201 //w=0.17 //l=0.085 //layer=li \
 //thickness=0.1 //x=32.6 //y=0.715 //x2=32.685 //y2=0.715
r778 (  293 294 ) resistor r=21.5615 //w=0.187 //l=0.315 //layer=li \
 //thickness=0.1 //x=32.6 //y=0.715 //x2=32.285 //y2=0.715
r779 (  289 501 ) resistor r=5.4201 //w=0.17 //l=0.085 //layer=li \
 //thickness=0.1 //x=32.2 //y=0.8 //x2=32.2 //y2=0.715
r780 (  289 501 ) resistor r=41.4118 //w=0.187 //l=0.605 //layer=li \
 //thickness=0.1 //x=32.2 //y=0.8 //x2=32.2 //y2=1.405
r781 (  288 501 ) resistor r=5.4201 //w=0.17 //l=0.085 //layer=li \
 //thickness=0.1 //x=32.2 //y=0.63 //x2=32.2 //y2=0.715
r782 (  287 447 ) resistor r=5.21862 //w=0.35 //l=0.175 //layer=li \
 //thickness=0.1 //x=32.2 //y=0.35 //x2=32.2 //y2=0.175
r783 (  287 288 ) resistor r=19.1658 //w=0.187 //l=0.28 //layer=li \
 //thickness=0.1 //x=32.2 //y=0.35 //x2=32.2 //y2=0.63
r784 (  284 446 ) resistor r=5.29055 //w=0.35 //l=0.17 //layer=li \
 //thickness=0.1 //x=31.74 //y=0.175 //x2=31.57 //y2=0.175
r785 (  284 286 ) resistor r=6.97548 //w=0.367 //l=0.2 //layer=li \
 //thickness=0.1 //x=31.74 //y=0.175 //x2=31.94 //y2=0.175
r786 (  283 447 ) resistor r=2.96458 //w=0.367 //l=0.085 //layer=li \
 //thickness=0.1 //x=32.115 //y=0.175 //x2=32.2 //y2=0.175
r787 (  283 286 ) resistor r=6.10354 //w=0.367 //l=0.175 //layer=li \
 //thickness=0.1 //x=32.115 //y=0.175 //x2=31.94 //y2=0.175
r788 (  278 445 ) resistor r=2.87058 //w=0.35 //l=0.085 //layer=li \
 //thickness=0.1 //x=29.505 //y=0.175 //x2=29.42 //y2=0.175
r789 (  278 280 ) resistor r=33.3079 //w=0.367 //l=0.955 //layer=li \
 //thickness=0.1 //x=29.505 //y=0.175 //x2=30.46 //y2=0.175
r790 (  277 446 ) resistor r=5.29055 //w=0.35 //l=0.17 //layer=li \
 //thickness=0.1 //x=31.4 //y=0.175 //x2=31.57 //y2=0.175
r791 (  277 280 ) resistor r=32.7847 //w=0.367 //l=0.94 //layer=li \
 //thickness=0.1 //x=31.4 //y=0.175 //x2=30.46 //y2=0.175
r792 (  273 445 ) resistor r=4.23183 //w=0.7 //l=0.175 //layer=li \
 //thickness=0.1 //x=29.42 //y=0.35 //x2=29.42 //y2=0.175
r793 (  273 500 ) resistor r=53.7326 //w=0.187 //l=0.785 //layer=li \
 //thickness=0.1 //x=29.42 //y=0.35 //x2=29.42 //y2=1.135
r794 (  272 443 ) resistor r=5.29055 //w=0.35 //l=0.17 //layer=li \
 //thickness=0.1 //x=28.41 //y=0.175 //x2=28.24 //y2=0.175
r795 (  271 445 ) resistor r=2.87058 //w=0.35 //l=0.085 //layer=li \
 //thickness=0.1 //x=29.335 //y=0.175 //x2=29.42 //y2=0.175
r796 (  271 272 ) resistor r=32.2616 //w=0.367 //l=0.925 //layer=li \
 //thickness=0.1 //x=29.335 //y=0.175 //x2=28.41 //y2=0.175
r797 (  266 436 ) resistor r=2.96458 //w=0.367 //l=0.085 //layer=li \
 //thickness=0.1 //x=27.705 //y=0.175 //x2=27.62 //y2=0.175
r798 (  266 268 ) resistor r=5.75477 //w=0.367 //l=0.165 //layer=li \
 //thickness=0.1 //x=27.705 //y=0.175 //x2=27.87 //y2=0.175
r799 (  265 443 ) resistor r=5.29055 //w=0.35 //l=0.17 //layer=li \
 //thickness=0.1 //x=28.07 //y=0.175 //x2=28.24 //y2=0.175
r800 (  265 268 ) resistor r=6.97548 //w=0.367 //l=0.2 //layer=li \
 //thickness=0.1 //x=28.07 //y=0.175 //x2=27.87 //y2=0.175
r801 (  261 499 ) resistor r=5.4201 //w=0.17 //l=0.085 //layer=li \
 //thickness=0.1 //x=27.62 //y=0.8 //x2=27.62 //y2=0.715
r802 (  261 499 ) resistor r=41.4118 //w=0.187 //l=0.605 //layer=li \
 //thickness=0.1 //x=27.62 //y=0.8 //x2=27.62 //y2=1.405
r803 (  260 499 ) resistor r=5.4201 //w=0.17 //l=0.085 //layer=li \
 //thickness=0.1 //x=27.62 //y=0.63 //x2=27.62 //y2=0.715
r804 (  259 436 ) resistor r=5.21862 //w=0.35 //l=0.175 //layer=li \
 //thickness=0.1 //x=27.62 //y=0.35 //x2=27.62 //y2=0.175
r805 (  259 260 ) resistor r=19.1658 //w=0.187 //l=0.28 //layer=li \
 //thickness=0.1 //x=27.62 //y=0.35 //x2=27.62 //y2=0.63
r806 (  258 499 ) resistor r=5.4201 //w=0.17 //l=0.085 //layer=li \
 //thickness=0.1 //x=27.22 //y=0.715 //x2=27.135 //y2=0.715
r807 (  257 499 ) resistor r=1.40859 //w=0.34 //l=0.085 //layer=li \
 //thickness=0.1 //x=27.535 //y=0.715 //x2=27.62 //y2=0.715
r808 (  257 258 ) resistor r=21.5615 //w=0.187 //l=0.315 //layer=li \
 //thickness=0.1 //x=27.535 //y=0.715 //x2=27.22 //y2=0.715
r809 (  256 499 ) resistor r=1.40859 //w=0.34 //l=0.085 //layer=li \
 //thickness=0.1 //x=27.135 //y=0.63 //x2=27.135 //y2=0.715
r810 (  255 435 ) resistor r=5.21862 //w=0.35 //l=0.175 //layer=li \
 //thickness=0.1 //x=27.135 //y=0.35 //x2=27.135 //y2=0.175
r811 (  255 256 ) resistor r=19.1658 //w=0.187 //l=0.28 //layer=li \
 //thickness=0.1 //x=27.135 //y=0.35 //x2=27.135 //y2=0.63
r812 (  254 499 ) resistor r=1.40859 //w=0.34 //l=0.085 //layer=li \
 //thickness=0.1 //x=26.735 //y=0.715 //x2=26.65 //y2=0.715
r813 (  253 499 ) resistor r=5.4201 //w=0.17 //l=0.085 //layer=li \
 //thickness=0.1 //x=27.05 //y=0.715 //x2=27.135 //y2=0.715
r814 (  253 254 ) resistor r=21.5615 //w=0.187 //l=0.315 //layer=li \
 //thickness=0.1 //x=27.05 //y=0.715 //x2=26.735 //y2=0.715
r815 (  249 499 ) resistor r=5.4201 //w=0.17 //l=0.085 //layer=li \
 //thickness=0.1 //x=26.65 //y=0.8 //x2=26.65 //y2=0.715
r816 (  249 499 ) resistor r=41.4118 //w=0.187 //l=0.605 //layer=li \
 //thickness=0.1 //x=26.65 //y=0.8 //x2=26.65 //y2=1.405
r817 (  248 499 ) resistor r=5.4201 //w=0.17 //l=0.085 //layer=li \
 //thickness=0.1 //x=26.65 //y=0.63 //x2=26.65 //y2=0.715
r818 (  247 432 ) resistor r=5.21862 //w=0.35 //l=0.175 //layer=li \
 //thickness=0.1 //x=26.65 //y=0.35 //x2=26.65 //y2=0.175
r819 (  247 248 ) resistor r=19.1658 //w=0.187 //l=0.28 //layer=li \
 //thickness=0.1 //x=26.65 //y=0.35 //x2=26.65 //y2=0.63
r820 (  246 431 ) resistor r=5.29055 //w=0.35 //l=0.17 //layer=li \
 //thickness=0.1 //x=26.19 //y=0.175 //x2=26.02 //y2=0.175
r821 (  245 432 ) resistor r=2.96458 //w=0.367 //l=0.085 //layer=li \
 //thickness=0.1 //x=26.565 //y=0.175 //x2=26.65 //y2=0.175
r822 (  245 246 ) resistor r=13.079 //w=0.367 //l=0.375 //layer=li \
 //thickness=0.1 //x=26.565 //y=0.175 //x2=26.19 //y2=0.175
r823 (  240 242 ) resistor r=38.7139 //w=0.367 //l=1.11 //layer=li \
 //thickness=0.1 //x=24.17 //y=0.175 //x2=25.28 //y2=0.175
r824 (  238 430 ) resistor r=2.87058 //w=0.35 //l=0.085 //layer=li \
 //thickness=0.1 //x=23.955 //y=0.175 //x2=23.87 //y2=0.175
r825 (  238 240 ) resistor r=7.49864 //w=0.367 //l=0.215 //layer=li \
 //thickness=0.1 //x=23.955 //y=0.175 //x2=24.17 //y2=0.175
r826 (  237 431 ) resistor r=5.29055 //w=0.35 //l=0.17 //layer=li \
 //thickness=0.1 //x=25.85 //y=0.175 //x2=26.02 //y2=0.175
r827 (  237 242 ) resistor r=19.8801 //w=0.367 //l=0.57 //layer=li \
 //thickness=0.1 //x=25.85 //y=0.175 //x2=25.28 //y2=0.175
r828 (  233 430 ) resistor r=4.23183 //w=0.7 //l=0.175 //layer=li \
 //thickness=0.1 //x=23.87 //y=0.35 //x2=23.87 //y2=0.175
r829 (  233 498 ) resistor r=53.7326 //w=0.187 //l=0.785 //layer=li \
 //thickness=0.1 //x=23.87 //y=0.35 //x2=23.87 //y2=1.135
r830 (  230 429 ) resistor r=5.29055 //w=0.35 //l=0.17 //layer=li \
 //thickness=0.1 //x=22.86 //y=0.175 //x2=22.69 //y2=0.175
r831 (  230 232 ) resistor r=6.97548 //w=0.367 //l=0.2 //layer=li \
 //thickness=0.1 //x=22.86 //y=0.175 //x2=23.06 //y2=0.175
r832 (  229 430 ) resistor r=2.87058 //w=0.35 //l=0.085 //layer=li \
 //thickness=0.1 //x=23.785 //y=0.175 //x2=23.87 //y2=0.175
r833 (  229 232 ) resistor r=25.2861 //w=0.367 //l=0.725 //layer=li \
 //thickness=0.1 //x=23.785 //y=0.175 //x2=23.06 //y2=0.175
r834 (  226 422 ) resistor r=2.96458 //w=0.367 //l=0.085 //layer=li \
 //thickness=0.1 //x=22.145 //y=0.175 //x2=22.06 //y2=0.175
r835 (  225 429 ) resistor r=5.29055 //w=0.35 //l=0.17 //layer=li \
 //thickness=0.1 //x=22.52 //y=0.175 //x2=22.69 //y2=0.175
r836 (  225 226 ) resistor r=13.079 //w=0.367 //l=0.375 //layer=li \
 //thickness=0.1 //x=22.52 //y=0.175 //x2=22.145 //y2=0.175
r837 (  221 497 ) resistor r=5.4201 //w=0.17 //l=0.085 //layer=li \
 //thickness=0.1 //x=22.06 //y=0.8 //x2=22.06 //y2=0.715
r838 (  221 497 ) resistor r=41.4118 //w=0.187 //l=0.605 //layer=li \
 //thickness=0.1 //x=22.06 //y=0.8 //x2=22.06 //y2=1.405
r839 (  220 497 ) resistor r=5.4201 //w=0.17 //l=0.085 //layer=li \
 //thickness=0.1 //x=22.06 //y=0.63 //x2=22.06 //y2=0.715
r840 (  219 422 ) resistor r=5.21862 //w=0.35 //l=0.175 //layer=li \
 //thickness=0.1 //x=22.06 //y=0.35 //x2=22.06 //y2=0.175
r841 (  219 220 ) resistor r=19.1658 //w=0.187 //l=0.28 //layer=li \
 //thickness=0.1 //x=22.06 //y=0.35 //x2=22.06 //y2=0.63
r842 (  218 497 ) resistor r=5.4201 //w=0.17 //l=0.085 //layer=li \
 //thickness=0.1 //x=21.66 //y=0.715 //x2=21.575 //y2=0.715
r843 (  217 497 ) resistor r=1.40859 //w=0.34 //l=0.085 //layer=li \
 //thickness=0.1 //x=21.975 //y=0.715 //x2=22.06 //y2=0.715
r844 (  217 218 ) resistor r=21.5615 //w=0.187 //l=0.315 //layer=li \
 //thickness=0.1 //x=21.975 //y=0.715 //x2=21.66 //y2=0.715
r845 (  216 497 ) resistor r=1.40859 //w=0.34 //l=0.085 //layer=li \
 //thickness=0.1 //x=21.575 //y=0.63 //x2=21.575 //y2=0.715
r846 (  215 419 ) resistor r=5.21862 //w=0.35 //l=0.175 //layer=li \
 //thickness=0.1 //x=21.575 //y=0.35 //x2=21.575 //y2=0.175
r847 (  215 216 ) resistor r=19.1658 //w=0.187 //l=0.28 //layer=li \
 //thickness=0.1 //x=21.575 //y=0.35 //x2=21.575 //y2=0.63
r848 (  214 497 ) resistor r=1.40859 //w=0.34 //l=0.085 //layer=li \
 //thickness=0.1 //x=21.175 //y=0.715 //x2=21.09 //y2=0.715
r849 (  213 497 ) resistor r=5.4201 //w=0.17 //l=0.085 //layer=li \
 //thickness=0.1 //x=21.49 //y=0.715 //x2=21.575 //y2=0.715
r850 (  213 214 ) resistor r=21.5615 //w=0.187 //l=0.315 //layer=li \
 //thickness=0.1 //x=21.49 //y=0.715 //x2=21.175 //y2=0.715
r851 (  209 497 ) resistor r=5.4201 //w=0.17 //l=0.085 //layer=li \
 //thickness=0.1 //x=21.09 //y=0.8 //x2=21.09 //y2=0.715
r852 (  209 497 ) resistor r=41.4118 //w=0.187 //l=0.605 //layer=li \
 //thickness=0.1 //x=21.09 //y=0.8 //x2=21.09 //y2=1.405
r853 (  208 497 ) resistor r=5.4201 //w=0.17 //l=0.085 //layer=li \
 //thickness=0.1 //x=21.09 //y=0.63 //x2=21.09 //y2=0.715
r854 (  207 418 ) resistor r=5.21862 //w=0.35 //l=0.175 //layer=li \
 //thickness=0.1 //x=21.09 //y=0.35 //x2=21.09 //y2=0.175
r855 (  207 208 ) resistor r=19.1658 //w=0.187 //l=0.28 //layer=li \
 //thickness=0.1 //x=21.09 //y=0.35 //x2=21.09 //y2=0.63
r856 (  206 417 ) resistor r=5.29055 //w=0.35 //l=0.17 //layer=li \
 //thickness=0.1 //x=20.64 //y=0.175 //x2=20.47 //y2=0.175
r857 (  205 418 ) resistor r=2.96458 //w=0.367 //l=0.085 //layer=li \
 //thickness=0.1 //x=21.005 //y=0.175 //x2=21.09 //y2=0.175
r858 (  205 206 ) resistor r=12.7302 //w=0.367 //l=0.365 //layer=li \
 //thickness=0.1 //x=21.005 //y=0.175 //x2=20.64 //y2=0.175
r859 (  200 202 ) resistor r=38.7139 //w=0.367 //l=1.11 //layer=li \
 //thickness=0.1 //x=18.99 //y=0.175 //x2=20.1 //y2=0.175
r860 (  198 416 ) resistor r=2.87058 //w=0.35 //l=0.085 //layer=li \
 //thickness=0.1 //x=18.405 //y=0.175 //x2=18.32 //y2=0.175
r861 (  198 200 ) resistor r=20.4033 //w=0.367 //l=0.585 //layer=li \
 //thickness=0.1 //x=18.405 //y=0.175 //x2=18.99 //y2=0.175
r862 (  197 417 ) resistor r=5.29055 //w=0.35 //l=0.17 //layer=li \
 //thickness=0.1 //x=20.3 //y=0.175 //x2=20.47 //y2=0.175
r863 (  197 202 ) resistor r=6.97548 //w=0.367 //l=0.2 //layer=li \
 //thickness=0.1 //x=20.3 //y=0.175 //x2=20.1 //y2=0.175
r864 (  193 416 ) resistor r=4.23183 //w=0.7 //l=0.175 //layer=li \
 //thickness=0.1 //x=18.32 //y=0.35 //x2=18.32 //y2=0.175
r865 (  193 496 ) resistor r=54.0749 //w=0.187 //l=0.79 //layer=li \
 //thickness=0.1 //x=18.32 //y=0.35 //x2=18.32 //y2=1.14
r866 (  190 415 ) resistor r=5.29055 //w=0.35 //l=0.17 //layer=li \
 //thickness=0.1 //x=17.31 //y=0.175 //x2=17.14 //y2=0.175
r867 (  190 192 ) resistor r=19.8801 //w=0.367 //l=0.57 //layer=li \
 //thickness=0.1 //x=17.31 //y=0.175 //x2=17.88 //y2=0.175
r868 (  189 416 ) resistor r=2.87058 //w=0.35 //l=0.085 //layer=li \
 //thickness=0.1 //x=18.235 //y=0.175 //x2=18.32 //y2=0.175
r869 (  189 192 ) resistor r=12.3815 //w=0.367 //l=0.355 //layer=li \
 //thickness=0.1 //x=18.235 //y=0.175 //x2=17.88 //y2=0.175
r870 (  184 186 ) resistor r=38.7139 //w=0.367 //l=1.11 //layer=li \
 //thickness=0.1 //x=15.29 //y=0.175 //x2=16.4 //y2=0.175
r871 (  182 414 ) resistor r=2.87058 //w=0.35 //l=0.085 //layer=li \
 //thickness=0.1 //x=15.075 //y=0.175 //x2=14.99 //y2=0.175
r872 (  182 184 ) resistor r=7.49864 //w=0.367 //l=0.215 //layer=li \
 //thickness=0.1 //x=15.075 //y=0.175 //x2=15.29 //y2=0.175
r873 (  181 415 ) resistor r=5.29055 //w=0.35 //l=0.17 //layer=li \
 //thickness=0.1 //x=16.97 //y=0.175 //x2=17.14 //y2=0.175
r874 (  181 186 ) resistor r=19.8801 //w=0.367 //l=0.57 //layer=li \
 //thickness=0.1 //x=16.97 //y=0.175 //x2=16.4 //y2=0.175
r875 (  177 414 ) resistor r=4.23183 //w=0.7 //l=0.175 //layer=li \
 //thickness=0.1 //x=14.99 //y=0.35 //x2=14.99 //y2=0.175
r876 (  177 495 ) resistor r=54.0749 //w=0.187 //l=0.79 //layer=li \
 //thickness=0.1 //x=14.99 //y=0.35 //x2=14.99 //y2=1.14
r877 (  174 413 ) resistor r=5.29055 //w=0.35 //l=0.17 //layer=li \
 //thickness=0.1 //x=13.98 //y=0.175 //x2=13.81 //y2=0.175
r878 (  174 176 ) resistor r=6.97548 //w=0.367 //l=0.2 //layer=li \
 //thickness=0.1 //x=13.98 //y=0.175 //x2=14.18 //y2=0.175
r879 (  173 414 ) resistor r=2.87058 //w=0.35 //l=0.085 //layer=li \
 //thickness=0.1 //x=14.905 //y=0.175 //x2=14.99 //y2=0.175
r880 (  173 176 ) resistor r=25.2861 //w=0.367 //l=0.725 //layer=li \
 //thickness=0.1 //x=14.905 //y=0.175 //x2=14.18 //y2=0.175
r881 (  170 406 ) resistor r=2.96458 //w=0.367 //l=0.085 //layer=li \
 //thickness=0.1 //x=13.275 //y=0.175 //x2=13.19 //y2=0.175
r882 (  169 413 ) resistor r=5.29055 //w=0.35 //l=0.17 //layer=li \
 //thickness=0.1 //x=13.64 //y=0.175 //x2=13.81 //y2=0.175
r883 (  169 170 ) resistor r=12.7302 //w=0.367 //l=0.365 //layer=li \
 //thickness=0.1 //x=13.64 //y=0.175 //x2=13.275 //y2=0.175
r884 (  165 494 ) resistor r=5.4201 //w=0.17 //l=0.085 //layer=li \
 //thickness=0.1 //x=13.19 //y=0.8 //x2=13.19 //y2=0.715
r885 (  165 494 ) resistor r=41.4118 //w=0.187 //l=0.605 //layer=li \
 //thickness=0.1 //x=13.19 //y=0.8 //x2=13.19 //y2=1.405
r886 (  164 494 ) resistor r=5.4201 //w=0.17 //l=0.085 //layer=li \
 //thickness=0.1 //x=13.19 //y=0.63 //x2=13.19 //y2=0.715
r887 (  163 406 ) resistor r=5.21862 //w=0.35 //l=0.175 //layer=li \
 //thickness=0.1 //x=13.19 //y=0.35 //x2=13.19 //y2=0.175
r888 (  163 164 ) resistor r=19.1658 //w=0.187 //l=0.28 //layer=li \
 //thickness=0.1 //x=13.19 //y=0.35 //x2=13.19 //y2=0.63
r889 (  162 494 ) resistor r=5.4201 //w=0.17 //l=0.085 //layer=li \
 //thickness=0.1 //x=12.79 //y=0.715 //x2=12.705 //y2=0.715
r890 (  161 494 ) resistor r=1.40859 //w=0.34 //l=0.085 //layer=li \
 //thickness=0.1 //x=13.105 //y=0.715 //x2=13.19 //y2=0.715
r891 (  161 162 ) resistor r=21.5615 //w=0.187 //l=0.315 //layer=li \
 //thickness=0.1 //x=13.105 //y=0.715 //x2=12.79 //y2=0.715
r892 (  160 494 ) resistor r=1.40859 //w=0.34 //l=0.085 //layer=li \
 //thickness=0.1 //x=12.705 //y=0.63 //x2=12.705 //y2=0.715
r893 (  159 405 ) resistor r=5.21862 //w=0.35 //l=0.175 //layer=li \
 //thickness=0.1 //x=12.705 //y=0.35 //x2=12.705 //y2=0.175
r894 (  159 160 ) resistor r=19.1658 //w=0.187 //l=0.28 //layer=li \
 //thickness=0.1 //x=12.705 //y=0.35 //x2=12.705 //y2=0.63
r895 (  158 494 ) resistor r=1.40859 //w=0.34 //l=0.085 //layer=li \
 //thickness=0.1 //x=12.305 //y=0.715 //x2=12.22 //y2=0.715
r896 (  157 494 ) resistor r=5.4201 //w=0.17 //l=0.085 //layer=li \
 //thickness=0.1 //x=12.62 //y=0.715 //x2=12.705 //y2=0.715
r897 (  157 158 ) resistor r=21.5615 //w=0.187 //l=0.315 //layer=li \
 //thickness=0.1 //x=12.62 //y=0.715 //x2=12.305 //y2=0.715
r898 (  153 494 ) resistor r=5.4201 //w=0.17 //l=0.085 //layer=li \
 //thickness=0.1 //x=12.22 //y=0.8 //x2=12.22 //y2=0.715
r899 (  153 494 ) resistor r=41.4118 //w=0.187 //l=0.605 //layer=li \
 //thickness=0.1 //x=12.22 //y=0.8 //x2=12.22 //y2=1.405
r900 (  152 494 ) resistor r=5.4201 //w=0.17 //l=0.085 //layer=li \
 //thickness=0.1 //x=12.22 //y=0.63 //x2=12.22 //y2=0.715
r901 (  151 402 ) resistor r=5.21862 //w=0.35 //l=0.175 //layer=li \
 //thickness=0.1 //x=12.22 //y=0.35 //x2=12.22 //y2=0.175
r902 (  151 152 ) resistor r=19.1658 //w=0.187 //l=0.28 //layer=li \
 //thickness=0.1 //x=12.22 //y=0.35 //x2=12.22 //y2=0.63
r903 (  150 401 ) resistor r=5.29055 //w=0.35 //l=0.17 //layer=li \
 //thickness=0.1 //x=11.76 //y=0.175 //x2=11.59 //y2=0.175
r904 (  149 402 ) resistor r=2.96458 //w=0.367 //l=0.085 //layer=li \
 //thickness=0.1 //x=12.135 //y=0.175 //x2=12.22 //y2=0.175
r905 (  149 150 ) resistor r=13.079 //w=0.367 //l=0.375 //layer=li \
 //thickness=0.1 //x=12.135 //y=0.175 //x2=11.76 //y2=0.175
r906 (  144 394 ) resistor r=2.96458 //w=0.367 //l=0.085 //layer=li \
 //thickness=0.1 //x=11.045 //y=0.175 //x2=10.96 //y2=0.175
r907 (  144 146 ) resistor r=6.10354 //w=0.367 //l=0.175 //layer=li \
 //thickness=0.1 //x=11.045 //y=0.175 //x2=11.22 //y2=0.175
r908 (  143 401 ) resistor r=5.29055 //w=0.35 //l=0.17 //layer=li \
 //thickness=0.1 //x=11.42 //y=0.175 //x2=11.59 //y2=0.175
r909 (  143 146 ) resistor r=6.97548 //w=0.367 //l=0.2 //layer=li \
 //thickness=0.1 //x=11.42 //y=0.175 //x2=11.22 //y2=0.175
r910 (  139 493 ) resistor r=5.4201 //w=0.17 //l=0.085 //layer=li \
 //thickness=0.1 //x=10.96 //y=0.8 //x2=10.96 //y2=0.715
r911 (  139 493 ) resistor r=41.4118 //w=0.187 //l=0.605 //layer=li \
 //thickness=0.1 //x=10.96 //y=0.8 //x2=10.96 //y2=1.405
r912 (  138 493 ) resistor r=5.4201 //w=0.17 //l=0.085 //layer=li \
 //thickness=0.1 //x=10.96 //y=0.63 //x2=10.96 //y2=0.715
r913 (  137 394 ) resistor r=5.21862 //w=0.35 //l=0.175 //layer=li \
 //thickness=0.1 //x=10.96 //y=0.35 //x2=10.96 //y2=0.175
r914 (  137 138 ) resistor r=19.1658 //w=0.187 //l=0.28 //layer=li \
 //thickness=0.1 //x=10.96 //y=0.35 //x2=10.96 //y2=0.63
r915 (  136 493 ) resistor r=5.4201 //w=0.17 //l=0.085 //layer=li \
 //thickness=0.1 //x=10.56 //y=0.715 //x2=10.475 //y2=0.715
r916 (  135 493 ) resistor r=1.40859 //w=0.34 //l=0.085 //layer=li \
 //thickness=0.1 //x=10.875 //y=0.715 //x2=10.96 //y2=0.715
r917 (  135 136 ) resistor r=21.5615 //w=0.187 //l=0.315 //layer=li \
 //thickness=0.1 //x=10.875 //y=0.715 //x2=10.56 //y2=0.715
r918 (  134 493 ) resistor r=1.40859 //w=0.34 //l=0.085 //layer=li \
 //thickness=0.1 //x=10.475 //y=0.63 //x2=10.475 //y2=0.715
r919 (  133 393 ) resistor r=5.21862 //w=0.35 //l=0.175 //layer=li \
 //thickness=0.1 //x=10.475 //y=0.35 //x2=10.475 //y2=0.175
r920 (  133 134 ) resistor r=19.1658 //w=0.187 //l=0.28 //layer=li \
 //thickness=0.1 //x=10.475 //y=0.35 //x2=10.475 //y2=0.63
r921 (  132 493 ) resistor r=1.40859 //w=0.34 //l=0.085 //layer=li \
 //thickness=0.1 //x=10.075 //y=0.715 //x2=9.99 //y2=0.715
r922 (  131 493 ) resistor r=5.4201 //w=0.17 //l=0.085 //layer=li \
 //thickness=0.1 //x=10.39 //y=0.715 //x2=10.475 //y2=0.715
r923 (  131 132 ) resistor r=21.5615 //w=0.187 //l=0.315 //layer=li \
 //thickness=0.1 //x=10.39 //y=0.715 //x2=10.075 //y2=0.715
r924 (  127 493 ) resistor r=5.4201 //w=0.17 //l=0.085 //layer=li \
 //thickness=0.1 //x=9.99 //y=0.8 //x2=9.99 //y2=0.715
r925 (  127 493 ) resistor r=41.4118 //w=0.187 //l=0.605 //layer=li \
 //thickness=0.1 //x=9.99 //y=0.8 //x2=9.99 //y2=1.405
r926 (  126 493 ) resistor r=5.4201 //w=0.17 //l=0.085 //layer=li \
 //thickness=0.1 //x=9.99 //y=0.63 //x2=9.99 //y2=0.715
r927 (  125 390 ) resistor r=5.21862 //w=0.35 //l=0.175 //layer=li \
 //thickness=0.1 //x=9.99 //y=0.35 //x2=9.99 //y2=0.175
r928 (  125 126 ) resistor r=19.1658 //w=0.187 //l=0.28 //layer=li \
 //thickness=0.1 //x=9.99 //y=0.35 //x2=9.99 //y2=0.63
r929 (  124 389 ) resistor r=5.29055 //w=0.35 //l=0.17 //layer=li \
 //thickness=0.1 //x=9.54 //y=0.175 //x2=9.37 //y2=0.175
r930 (  123 390 ) resistor r=2.96458 //w=0.367 //l=0.085 //layer=li \
 //thickness=0.1 //x=9.905 //y=0.175 //x2=9.99 //y2=0.175
r931 (  123 124 ) resistor r=12.7302 //w=0.367 //l=0.365 //layer=li \
 //thickness=0.1 //x=9.905 //y=0.175 //x2=9.54 //y2=0.175
r932 (  118 120 ) resistor r=38.7139 //w=0.367 //l=1.11 //layer=li \
 //thickness=0.1 //x=7.52 //y=0.175 //x2=8.63 //y2=0.175
r933 (  116 388 ) resistor r=2.87058 //w=0.35 //l=0.085 //layer=li \
 //thickness=0.1 //x=7.305 //y=0.175 //x2=7.22 //y2=0.175
r934 (  116 118 ) resistor r=7.49864 //w=0.367 //l=0.215 //layer=li \
 //thickness=0.1 //x=7.305 //y=0.175 //x2=7.52 //y2=0.175
r935 (  115 389 ) resistor r=5.29055 //w=0.35 //l=0.17 //layer=li \
 //thickness=0.1 //x=9.2 //y=0.175 //x2=9.37 //y2=0.175
r936 (  115 120 ) resistor r=19.8801 //w=0.367 //l=0.57 //layer=li \
 //thickness=0.1 //x=9.2 //y=0.175 //x2=8.63 //y2=0.175
r937 (  111 388 ) resistor r=4.23183 //w=0.7 //l=0.175 //layer=li \
 //thickness=0.1 //x=7.22 //y=0.35 //x2=7.22 //y2=0.175
r938 (  111 492 ) resistor r=54.0749 //w=0.187 //l=0.79 //layer=li \
 //thickness=0.1 //x=7.22 //y=0.35 //x2=7.22 //y2=1.14
r939 (  108 387 ) resistor r=5.29055 //w=0.35 //l=0.17 //layer=li \
 //thickness=0.1 //x=6.21 //y=0.175 //x2=6.04 //y2=0.175
r940 (  108 110 ) resistor r=6.97548 //w=0.367 //l=0.2 //layer=li \
 //thickness=0.1 //x=6.21 //y=0.175 //x2=6.41 //y2=0.175
r941 (  107 388 ) resistor r=2.87058 //w=0.35 //l=0.085 //layer=li \
 //thickness=0.1 //x=7.135 //y=0.175 //x2=7.22 //y2=0.175
r942 (  107 110 ) resistor r=25.2861 //w=0.367 //l=0.725 //layer=li \
 //thickness=0.1 //x=7.135 //y=0.175 //x2=6.41 //y2=0.175
r943 (  102 386 ) resistor r=2.87058 //w=0.35 //l=0.085 //layer=li \
 //thickness=0.1 //x=3.975 //y=0.175 //x2=3.89 //y2=0.175
r944 (  102 104 ) resistor r=33.3079 //w=0.367 //l=0.955 //layer=li \
 //thickness=0.1 //x=3.975 //y=0.175 //x2=4.93 //y2=0.175
r945 (  101 387 ) resistor r=5.29055 //w=0.35 //l=0.17 //layer=li \
 //thickness=0.1 //x=5.87 //y=0.175 //x2=6.04 //y2=0.175
r946 (  101 104 ) resistor r=32.7847 //w=0.367 //l=0.94 //layer=li \
 //thickness=0.1 //x=5.87 //y=0.175 //x2=4.93 //y2=0.175
r947 (  97 386 ) resistor r=4.23183 //w=0.7 //l=0.175 //layer=li \
 //thickness=0.1 //x=3.89 //y=0.35 //x2=3.89 //y2=0.175
r948 (  97 491 ) resistor r=54.0749 //w=0.187 //l=0.79 //layer=li \
 //thickness=0.1 //x=3.89 //y=0.35 //x2=3.89 //y2=1.14
r949 (  96 384 ) resistor r=5.29055 //w=0.35 //l=0.17 //layer=li \
 //thickness=0.1 //x=2.88 //y=0.175 //x2=2.71 //y2=0.175
r950 (  95 386 ) resistor r=2.87058 //w=0.35 //l=0.085 //layer=li \
 //thickness=0.1 //x=3.805 //y=0.175 //x2=3.89 //y2=0.175
r951 (  95 96 ) resistor r=32.2616 //w=0.367 //l=0.925 //layer=li \
 //thickness=0.1 //x=3.805 //y=0.175 //x2=2.88 //y2=0.175
r952 (  90 377 ) resistor r=2.96458 //w=0.367 //l=0.085 //layer=li \
 //thickness=0.1 //x=2.175 //y=0.175 //x2=2.09 //y2=0.175
r953 (  90 92 ) resistor r=5.75477 //w=0.367 //l=0.165 //layer=li \
 //thickness=0.1 //x=2.175 //y=0.175 //x2=2.34 //y2=0.175
r954 (  89 384 ) resistor r=5.29055 //w=0.35 //l=0.17 //layer=li \
 //thickness=0.1 //x=2.54 //y=0.175 //x2=2.71 //y2=0.175
r955 (  89 92 ) resistor r=6.97548 //w=0.367 //l=0.2 //layer=li \
 //thickness=0.1 //x=2.54 //y=0.175 //x2=2.34 //y2=0.175
r956 (  85 490 ) resistor r=5.4201 //w=0.17 //l=0.085 //layer=li \
 //thickness=0.1 //x=2.09 //y=0.8 //x2=2.09 //y2=0.715
r957 (  85 490 ) resistor r=41.4118 //w=0.187 //l=0.605 //layer=li \
 //thickness=0.1 //x=2.09 //y=0.8 //x2=2.09 //y2=1.405
r958 (  84 490 ) resistor r=5.4201 //w=0.17 //l=0.085 //layer=li \
 //thickness=0.1 //x=2.09 //y=0.63 //x2=2.09 //y2=0.715
r959 (  83 377 ) resistor r=5.21862 //w=0.35 //l=0.175 //layer=li \
 //thickness=0.1 //x=2.09 //y=0.35 //x2=2.09 //y2=0.175
r960 (  83 84 ) resistor r=19.1658 //w=0.187 //l=0.28 //layer=li \
 //thickness=0.1 //x=2.09 //y=0.35 //x2=2.09 //y2=0.63
r961 (  82 490 ) resistor r=5.4201 //w=0.17 //l=0.085 //layer=li \
 //thickness=0.1 //x=1.69 //y=0.715 //x2=1.605 //y2=0.715
r962 (  81 490 ) resistor r=1.40859 //w=0.34 //l=0.085 //layer=li \
 //thickness=0.1 //x=2.005 //y=0.715 //x2=2.09 //y2=0.715
r963 (  81 82 ) resistor r=21.5615 //w=0.187 //l=0.315 //layer=li \
 //thickness=0.1 //x=2.005 //y=0.715 //x2=1.69 //y2=0.715
r964 (  80 490 ) resistor r=1.40859 //w=0.34 //l=0.085 //layer=li \
 //thickness=0.1 //x=1.605 //y=0.63 //x2=1.605 //y2=0.715
r965 (  79 376 ) resistor r=5.21862 //w=0.35 //l=0.175 //layer=li \
 //thickness=0.1 //x=1.605 //y=0.35 //x2=1.605 //y2=0.175
r966 (  79 80 ) resistor r=19.1658 //w=0.187 //l=0.28 //layer=li \
 //thickness=0.1 //x=1.605 //y=0.35 //x2=1.605 //y2=0.63
r967 (  78 490 ) resistor r=1.40859 //w=0.34 //l=0.085 //layer=li \
 //thickness=0.1 //x=1.205 //y=0.715 //x2=1.12 //y2=0.715
r968 (  77 490 ) resistor r=5.4201 //w=0.17 //l=0.085 //layer=li \
 //thickness=0.1 //x=1.52 //y=0.715 //x2=1.605 //y2=0.715
r969 (  77 78 ) resistor r=21.5615 //w=0.187 //l=0.315 //layer=li \
 //thickness=0.1 //x=1.52 //y=0.715 //x2=1.205 //y2=0.715
r970 (  73 490 ) resistor r=5.4201 //w=0.17 //l=0.085 //layer=li \
 //thickness=0.1 //x=1.12 //y=0.8 //x2=1.12 //y2=0.715
r971 (  73 490 ) resistor r=41.4118 //w=0.187 //l=0.605 //layer=li \
 //thickness=0.1 //x=1.12 //y=0.8 //x2=1.12 //y2=1.405
r972 (  72 490 ) resistor r=5.4201 //w=0.17 //l=0.085 //layer=li \
 //thickness=0.1 //x=1.12 //y=0.63 //x2=1.12 //y2=0.715
r973 (  71 373 ) resistor r=5.21862 //w=0.35 //l=0.175 //layer=li \
 //thickness=0.1 //x=1.12 //y=0.35 //x2=1.12 //y2=0.175
r974 (  71 72 ) resistor r=19.1658 //w=0.187 //l=0.28 //layer=li \
 //thickness=0.1 //x=1.12 //y=0.35 //x2=1.12 //y2=0.63
r975 (  65 370 ) resistor r=9.3 //w=0.17 //l=0.17 //layer=mcon //count=1 \
 //x=38.97 //y=0.18 //x2=38.97 //y2=0.18
r976 (  63 481 ) resistor r=3.1 //w=0.17 //l=0.51 //layer=mcon //count=3 \
 //x=38.23 //y=0.18 //x2=38.23 //y2=0.18
r977 (  63 65 ) resistor r=0.297428 //w=0.311 //l=0.74 //layer=m1 \
 //thickness=0.36 //x=38.23 //y=0.175 //x2=38.97 //y2=0.175
r978 (  61 344 ) resistor r=3.1 //w=0.17 //l=0.51 //layer=mcon //count=3 \
 //x=36.75 //y=0.18 //x2=36.75 //y2=0.18
r979 (  61 63 ) resistor r=0.594855 //w=0.311 //l=1.48 //layer=m1 \
 //thickness=0.36 //x=36.75 //y=0.175 //x2=38.23 //y2=0.175
r980 (  59 465 ) resistor r=3.1 //w=0.17 //l=0.51 //layer=mcon //count=3 \
 //x=35.64 //y=0.18 //x2=35.64 //y2=0.18
r981 (  59 61 ) resistor r=0.446141 //w=0.311 //l=1.11 //layer=m1 \
 //thickness=0.36 //x=35.64 //y=0.175 //x2=36.75 //y2=0.175
r982 (  57 461 ) resistor r=3.1 //w=0.17 //l=0.51 //layer=mcon //count=3 \
 //x=34.53 //y=0.18 //x2=34.53 //y2=0.18
r983 (  57 59 ) resistor r=0.446141 //w=0.311 //l=1.11 //layer=m1 \
 //thickness=0.36 //x=34.53 //y=0.175 //x2=35.64 //y2=0.175
r984 (  55 450 ) resistor r=3.1 //w=0.17 //l=0.51 //layer=mcon //count=3 \
 //x=33.05 //y=0.18 //x2=33.05 //y2=0.18
r985 (  55 57 ) resistor r=0.594855 //w=0.311 //l=1.48 //layer=m1 \
 //thickness=0.36 //x=33.05 //y=0.175 //x2=34.53 //y2=0.175
r986 (  53 286 ) resistor r=3.1 //w=0.17 //l=0.51 //layer=mcon //count=3 \
 //x=31.94 //y=0.18 //x2=31.94 //y2=0.18
r987 (  53 55 ) resistor r=0.446141 //w=0.311 //l=1.11 //layer=m1 \
 //thickness=0.36 //x=31.94 //y=0.175 //x2=33.05 //y2=0.175
r988 (  51 280 ) resistor r=3.1 //w=0.17 //l=0.51 //layer=mcon //count=3 \
 //x=30.46 //y=0.18 //x2=30.46 //y2=0.18
r989 (  51 53 ) resistor r=0.594855 //w=0.311 //l=1.48 //layer=m1 \
 //thickness=0.36 //x=30.46 //y=0.175 //x2=31.94 //y2=0.175
r990 (  49 445 ) resistor r=3.1 //w=0.17 //l=0.51 //layer=mcon //count=3 \
 //x=29.35 //y=0.18 //x2=29.35 //y2=0.18
r991 (  49 51 ) resistor r=0.446141 //w=0.311 //l=1.11 //layer=m1 \
 //thickness=0.36 //x=29.35 //y=0.175 //x2=30.46 //y2=0.175
r992 (  47 268 ) resistor r=3.1 //w=0.17 //l=0.51 //layer=mcon //count=3 \
 //x=27.87 //y=0.18 //x2=27.87 //y2=0.18
r993 (  47 49 ) resistor r=0.594855 //w=0.311 //l=1.48 //layer=m1 \
 //thickness=0.36 //x=27.87 //y=0.175 //x2=29.35 //y2=0.175
r994 (  45 434 ) resistor r=3.1 //w=0.17 //l=0.51 //layer=mcon //count=3 \
 //x=26.76 //y=0.18 //x2=26.76 //y2=0.18
r995 (  45 47 ) resistor r=0.446141 //w=0.311 //l=1.11 //layer=m1 \
 //thickness=0.36 //x=26.76 //y=0.175 //x2=27.87 //y2=0.175
r996 (  43 242 ) resistor r=3.1 //w=0.17 //l=0.51 //layer=mcon //count=3 \
 //x=25.28 //y=0.18 //x2=25.28 //y2=0.18
r997 (  43 45 ) resistor r=0.594855 //w=0.311 //l=1.48 //layer=m1 \
 //thickness=0.36 //x=25.28 //y=0.175 //x2=26.76 //y2=0.175
r998 (  41 240 ) resistor r=3.1 //w=0.17 //l=0.51 //layer=mcon //count=3 \
 //x=24.17 //y=0.18 //x2=24.17 //y2=0.18
r999 (  41 43 ) resistor r=0.446141 //w=0.311 //l=1.11 //layer=m1 \
 //thickness=0.36 //x=24.17 //y=0.175 //x2=25.28 //y2=0.175
r1000 (  39 232 ) resistor r=3.1 //w=0.17 //l=0.51 //layer=mcon //count=3 \
 //x=23.06 //y=0.18 //x2=23.06 //y2=0.18
r1001 (  39 41 ) resistor r=0.446141 //w=0.311 //l=1.11 //layer=m1 \
 //thickness=0.36 //x=23.06 //y=0.175 //x2=24.17 //y2=0.175
r1002 (  37 421 ) resistor r=3.1 //w=0.17 //l=0.51 //layer=mcon //count=3 \
 //x=21.58 //y=0.18 //x2=21.58 //y2=0.18
r1003 (  37 39 ) resistor r=0.594855 //w=0.311 //l=1.48 //layer=m1 \
 //thickness=0.36 //x=21.58 //y=0.175 //x2=23.06 //y2=0.175
r1004 (  35 202 ) resistor r=3.1 //w=0.17 //l=0.51 //layer=mcon //count=3 \
 //x=20.1 //y=0.18 //x2=20.1 //y2=0.18
r1005 (  35 37 ) resistor r=0.594855 //w=0.311 //l=1.48 //layer=m1 \
 //thickness=0.36 //x=20.1 //y=0.175 //x2=21.58 //y2=0.175
r1006 (  32 200 ) resistor r=3.1 //w=0.17 //l=0.51 //layer=mcon //count=3 \
 //x=18.99 //y=0.18 //x2=18.99 //y2=0.18
r1007 (  30 192 ) resistor r=3.1 //w=0.17 //l=0.51 //layer=mcon //count=3 \
 //x=17.88 //y=0.18 //x2=17.88 //y2=0.18
r1008 (  30 32 ) resistor r=0.446141 //w=0.311 //l=1.11 //layer=m1 \
 //thickness=0.36 //x=17.88 //y=0.175 //x2=18.99 //y2=0.175
r1009 (  28 186 ) resistor r=3.1 //w=0.17 //l=0.51 //layer=mcon //count=3 \
 //x=16.4 //y=0.18 //x2=16.4 //y2=0.18
r1010 (  28 30 ) resistor r=0.594855 //w=0.311 //l=1.48 //layer=m1 \
 //thickness=0.36 //x=16.4 //y=0.175 //x2=17.88 //y2=0.175
r1011 (  26 184 ) resistor r=3.1 //w=0.17 //l=0.51 //layer=mcon //count=3 \
 //x=15.29 //y=0.18 //x2=15.29 //y2=0.18
r1012 (  26 28 ) resistor r=0.446141 //w=0.311 //l=1.11 //layer=m1 \
 //thickness=0.36 //x=15.29 //y=0.175 //x2=16.4 //y2=0.175
r1013 (  24 176 ) resistor r=3.1 //w=0.17 //l=0.51 //layer=mcon //count=3 \
 //x=14.18 //y=0.18 //x2=14.18 //y2=0.18
r1014 (  24 26 ) resistor r=0.446141 //w=0.311 //l=1.11 //layer=m1 \
 //thickness=0.36 //x=14.18 //y=0.175 //x2=15.29 //y2=0.175
r1015 (  22 404 ) resistor r=3.1 //w=0.17 //l=0.51 //layer=mcon //count=3 \
 //x=12.7 //y=0.18 //x2=12.7 //y2=0.18
r1016 (  22 24 ) resistor r=0.594855 //w=0.311 //l=1.48 //layer=m1 \
 //thickness=0.36 //x=12.7 //y=0.175 //x2=14.18 //y2=0.175
r1017 (  20 146 ) resistor r=3.1 //w=0.17 //l=0.51 //layer=mcon //count=3 \
 //x=11.22 //y=0.18 //x2=11.22 //y2=0.18
r1018 (  20 22 ) resistor r=0.594855 //w=0.311 //l=1.48 //layer=m1 \
 //thickness=0.36 //x=11.22 //y=0.175 //x2=12.7 //y2=0.175
r1019 (  18 392 ) resistor r=3.1 //w=0.17 //l=0.51 //layer=mcon //count=3 \
 //x=10.11 //y=0.18 //x2=10.11 //y2=0.18
r1020 (  18 20 ) resistor r=0.446141 //w=0.311 //l=1.11 //layer=m1 \
 //thickness=0.36 //x=10.11 //y=0.175 //x2=11.22 //y2=0.175
r1021 (  16 120 ) resistor r=3.1 //w=0.17 //l=0.51 //layer=mcon //count=3 \
 //x=8.63 //y=0.18 //x2=8.63 //y2=0.18
r1022 (  16 18 ) resistor r=0.594855 //w=0.311 //l=1.48 //layer=m1 \
 //thickness=0.36 //x=8.63 //y=0.175 //x2=10.11 //y2=0.175
r1023 (  14 118 ) resistor r=3.1 //w=0.17 //l=0.51 //layer=mcon //count=3 \
 //x=7.52 //y=0.18 //x2=7.52 //y2=0.18
r1024 (  14 16 ) resistor r=0.446141 //w=0.311 //l=1.11 //layer=m1 \
 //thickness=0.36 //x=7.52 //y=0.175 //x2=8.63 //y2=0.175
r1025 (  12 110 ) resistor r=3.1 //w=0.17 //l=0.51 //layer=mcon //count=3 \
 //x=6.41 //y=0.18 //x2=6.41 //y2=0.18
r1026 (  12 14 ) resistor r=0.446141 //w=0.311 //l=1.11 //layer=m1 \
 //thickness=0.36 //x=6.41 //y=0.175 //x2=7.52 //y2=0.175
r1027 (  10 104 ) resistor r=3.1 //w=0.17 //l=0.51 //layer=mcon //count=3 \
 //x=4.93 //y=0.18 //x2=4.93 //y2=0.18
r1028 (  10 12 ) resistor r=0.594855 //w=0.311 //l=1.48 //layer=m1 \
 //thickness=0.36 //x=4.93 //y=0.175 //x2=6.41 //y2=0.175
r1029 (  8 386 ) resistor r=3.1 //w=0.17 //l=0.51 //layer=mcon //count=3 \
 //x=3.82 //y=0.18 //x2=3.82 //y2=0.18
r1030 (  8 10 ) resistor r=0.446141 //w=0.311 //l=1.11 //layer=m1 \
 //thickness=0.36 //x=3.82 //y=0.175 //x2=4.93 //y2=0.175
r1031 (  6 92 ) resistor r=3.1 //w=0.17 //l=0.51 //layer=mcon //count=3 \
 //x=2.34 //y=0.18 //x2=2.34 //y2=0.18
r1032 (  6 8 ) resistor r=0.594855 //w=0.311 //l=1.48 //layer=m1 \
 //thickness=0.36 //x=2.34 //y=0.175 //x2=3.82 //y2=0.175
r1033 (  3 375 ) resistor r=3.1 //w=0.17 //l=0.51 //layer=mcon //count=3 \
 //x=1.23 //y=0.18 //x2=1.23 //y2=0.18
r1034 (  3 6 ) resistor r=0.446141 //w=0.311 //l=1.11 //layer=m1 \
 //thickness=0.36 //x=1.23 //y=0.175 //x2=2.34 //y2=0.175
r1035 (  1 35 ) resistor r=0.0743569 //w=0.311 //l=0.185 //layer=m1 \
 //thickness=0.36 //x=19.915 //y=0.175 //x2=20.1 //y2=0.175
r1036 (  1 32 ) resistor r=0.371785 //w=0.311 //l=0.925 //layer=m1 \
 //thickness=0.36 //x=19.915 //y=0.175 //x2=18.99 //y2=0.175
ends PM_FA\%GND

subckt PM_FA\%VDD ( 1 65 77 85 91 99 105 113 121 129 137 143 151 161 165 173 \
 181 189 197 205 215 219 229 239 247 251 259 267 273 281 291 315 327 337 353 \
 366 370 372 374 376 380 383 385 387 390 395 399 403 407 409 412 413 414 415 \
 416 417 418 419 420 421 422 423 424 425 426 427 428 429 430 431 432 433 434 \
 435 436 )
c530 ( 436 0 ) capacitor c=0.0451938f //x=38.53 //y=5.2
c531 ( 435 0 ) capacitor c=0.0423715f //x=37.66 //y=5.2
c532 ( 434 0 ) capacitor c=0.0256053f //x=34.875 //y=5.205
c533 ( 433 0 ) capacitor c=0.0436619f //x=32.98 //y=5.2
c534 ( 432 0 ) capacitor c=0.0423621f //x=32.11 //y=5.2
c535 ( 431 0 ) capacitor c=0.0382537f //x=30.645 //y=5.2
c536 ( 430 0 ) capacitor c=0.0242221f //x=29.765 //y=5.2
c537 ( 429 0 ) capacitor c=0.0488155f //x=28.895 //y=5.2
c538 ( 428 0 ) capacitor c=0.0428353f //x=27.43 //y=5.2
c539 ( 427 0 ) capacitor c=0.0420515f //x=26.56 //y=5.2
c540 ( 426 0 ) capacitor c=0.0379601f //x=25.095 //y=5.2
c541 ( 425 0 ) capacitor c=0.0239038f //x=24.215 //y=5.2
c542 ( 424 0 ) capacitor c=0.0488148f //x=23.345 //y=5.2
c543 ( 423 0 ) capacitor c=0.0418662f //x=21.87 //y=5.2
c544 ( 422 0 ) capacitor c=0.0431309f //x=21.01 //y=5.2
c545 ( 421 0 ) capacitor c=0.0265379f //x=18.225 //y=5.2
c546 ( 420 0 ) capacitor c=0.026371f //x=14.895 //y=5.2
c547 ( 419 0 ) capacitor c=0.0428353f //x=13 //y=5.2
c548 ( 418 0 ) capacitor c=0.0418662f //x=12.13 //y=5.2
c549 ( 417 0 ) capacitor c=0.0418242f //x=10.77 //y=5.2
c550 ( 416 0 ) capacitor c=0.0433635f //x=9.91 //y=5.2
c551 ( 415 0 ) capacitor c=0.0266033f //x=7.125 //y=5.2
c552 ( 414 0 ) capacitor c=0.0265297f //x=3.795 //y=5.2
c553 ( 413 0 ) capacitor c=0.0432965f //x=1.9 //y=5.2
c554 ( 412 0 ) capacitor c=0.0421444f //x=1.03 //y=5.2
c555 ( 411 0 ) capacitor c=0.00597439f //x=38.675 //y=7.585
c556 ( 410 0 ) capacitor c=0.00597439f //x=37.795 //y=7.585
c557 ( 409 0 ) capacitor c=0.109902f //x=37.12 //y=7.585
c558 ( 408 0 ) capacitor c=0.00597439f //x=35.02 //y=7.585
c559 ( 407 0 ) capacitor c=0.112824f //x=33.79 //y=7.585
c560 ( 406 0 ) capacitor c=0.00597439f //x=33.05 //y=7.58
c561 ( 404 0 ) capacitor c=0.00597439f //x=32.245 //y=7.585
c562 ( 403 0 ) capacitor c=0.110587f //x=31.57 //y=7.585
c563 ( 402 0 ) capacitor c=0.00597439f //x=30.79 //y=7.585
c564 ( 401 0 ) capacitor c=0.00597439f //x=29.91 //y=7.585
c565 ( 400 0 ) capacitor c=0.00597439f //x=29.03 //y=7.585
c566 ( 399 0 ) capacitor c=0.117751f //x=28.24 //y=7.585
c567 ( 398 0 ) capacitor c=0.00597439f //x=27.575 //y=7.585
c568 ( 397 0 ) capacitor c=0.00597439f //x=26.76 //y=7.58
c569 ( 395 0 ) capacitor c=0.111408f //x=26.02 //y=7.585
c570 ( 394 0 ) capacitor c=0.00597439f //x=25.28 //y=7.58
c571 ( 392 0 ) capacitor c=0.00597439f //x=24.36 //y=7.585
c572 ( 391 0 ) capacitor c=0.00597439f //x=23.48 //y=7.585
c573 ( 390 0 ) capacitor c=0.115232f //x=22.69 //y=7.585
c574 ( 389 0 ) capacitor c=0.00597439f //x=22.015 //y=7.585
c575 ( 388 0 ) capacitor c=0.00597439f //x=21.135 //y=7.585
c576 ( 387 0 ) capacitor c=0.1066f //x=20.47 //y=7.585
c577 ( 386 0 ) capacitor c=0.00597439f //x=18.37 //y=7.585
c578 ( 385 0 ) capacitor c=0.112449f //x=17.14 //y=7.585
c579 ( 384 0 ) capacitor c=0.00597439f //x=15.04 //y=7.585
c580 ( 383 0 ) capacitor c=0.112312f //x=13.81 //y=7.585
c581 ( 382 0 ) capacitor c=0.00597439f //x=13.145 //y=7.585
c582 ( 381 0 ) capacitor c=0.00597439f //x=12.265 //y=7.585
c583 ( 380 0 ) capacitor c=0.105534f //x=11.59 //y=7.585
c584 ( 379 0 ) capacitor c=0.00597439f //x=10.915 //y=7.585
c585 ( 378 0 ) capacitor c=0.00597439f //x=10.11 //y=7.58
c586 ( 376 0 ) capacitor c=0.105353f //x=9.37 //y=7.585
c587 ( 375 0 ) capacitor c=0.00597439f //x=7.27 //y=7.585
c588 ( 374 0 ) capacitor c=0.111887f //x=6.04 //y=7.585
c589 ( 373 0 ) capacitor c=0.00597439f //x=3.94 //y=7.585
c590 ( 372 0 ) capacitor c=0.111682f //x=2.71 //y=7.585
c591 ( 371 0 ) capacitor c=0.00597439f //x=2.045 //y=7.585
c592 ( 370 0 ) capacitor c=0.25188f //x=1.23 //y=7.58
c593 ( 366 0 ) capacitor c=0.247693f //x=38.97 //y=7.58
c594 ( 353 0 ) capacitor c=0.0289916f //x=38.59 //y=7.585
c595 ( 345 0 ) capacitor c=0.0217664f //x=37.71 //y=7.585
c596 ( 337 0 ) capacitor c=0.0785214f //x=36.95 //y=7.585
c597 ( 327 0 ) capacitor c=0.046953f //x=34.935 //y=7.585
c598 ( 323 0 ) capacitor c=0.0211939f //x=33.62 //y=7.585
c599 ( 315 0 ) capacitor c=0.0289916f //x=33.04 //y=7.585
c600 ( 305 0 ) capacitor c=0.0217664f //x=32.16 //y=7.585
c601 ( 301 0 ) capacitor c=0.0277785f //x=31.4 //y=7.585
c602 ( 291 0 ) capacitor c=0.0287734f //x=30.705 //y=7.585
c603 ( 281 0 ) capacitor c=0.0294348f //x=29.825 //y=7.585
c604 ( 273 0 ) capacitor c=0.024303f //x=28.945 //y=7.585
c605 ( 267 0 ) capacitor c=0.0183091f //x=28.07 //y=7.585
c606 ( 259 0 ) capacitor c=0.029133f //x=27.49 //y=7.585
c607 ( 251 0 ) capacitor c=0.0187886f //x=26.61 //y=7.585
c608 ( 247 0 ) capacitor c=0.0238235f //x=25.85 //y=7.585
c609 ( 239 0 ) capacitor c=0.0290692f //x=25.155 //y=7.585
c610 ( 229 0 ) capacitor c=0.0291459f //x=24.275 //y=7.585
c611 ( 219 0 ) capacitor c=0.024303f //x=23.395 //y=7.585
c612 ( 215 0 ) capacitor c=0.0187886f //x=22.52 //y=7.585
c613 ( 205 0 ) capacitor c=0.029133f //x=21.93 //y=7.585
c614 ( 197 0 ) capacitor c=0.0183091f //x=21.05 //y=7.585
c615 ( 189 0 ) capacitor c=0.0753895f //x=20.3 //y=7.585
c616 ( 181 0 ) capacitor c=0.0432153f //x=18.285 //y=7.585
c617 ( 173 0 ) capacitor c=0.0753895f //x=16.97 //y=7.585
c618 ( 165 0 ) capacitor c=0.0432153f //x=14.955 //y=7.585
c619 ( 161 0 ) capacitor c=0.0183091f //x=13.64 //y=7.585
c620 ( 151 0 ) capacitor c=0.029133f //x=13.06 //y=7.585
c621 ( 143 0 ) capacitor c=0.0187886f //x=12.18 //y=7.585
c622 ( 137 0 ) capacitor c=0.0187886f //x=11.42 //y=7.585
c623 ( 129 0 ) capacitor c=0.0292706f //x=10.83 //y=7.585
c624 ( 121 0 ) capacitor c=0.0183091f //x=9.95 //y=7.585
c625 ( 113 0 ) capacitor c=0.075456f //x=9.2 //y=7.585
c626 ( 105 0 ) capacitor c=0.0432521f //x=7.185 //y=7.585
c627 ( 99 0 ) capacitor c=0.0753262f //x=5.87 //y=7.585
c628 ( 91 0 ) capacitor c=0.0432541f //x=3.855 //y=7.585
c629 ( 85 0 ) capacitor c=0.0183091f //x=2.54 //y=7.585
c630 ( 77 0 ) capacitor c=0.0293728f //x=1.96 //y=7.585
c631 ( 65 0 ) capacitor c=1.33199f //x=38.97 //y=7.58
r632 (  364 411 ) resistor r=2.87058 //w=0.35 //l=0.085 //layer=li \
 //thickness=0.1 //x=38.76 //y=7.585 //x2=38.675 //y2=7.585
r633 (  364 366 ) resistor r=7.32425 //w=0.367 //l=0.21 //layer=li \
 //thickness=0.1 //x=38.76 //y=7.585 //x2=38.97 //y2=7.585
r634 (  357 411 ) resistor r=4.23183 //w=0.7 //l=0.175 //layer=li \
 //thickness=0.1 //x=38.675 //y=7.41 //x2=38.675 //y2=7.585
r635 (  357 436 ) resistor r=56.4706 //w=0.187 //l=0.825 //layer=li \
 //thickness=0.1 //x=38.675 //y=7.41 //x2=38.675 //y2=6.585
r636 (  354 410 ) resistor r=2.87058 //w=0.35 //l=0.085 //layer=li \
 //thickness=0.1 //x=37.88 //y=7.585 //x2=37.795 //y2=7.585
r637 (  354 356 ) resistor r=12.2071 //w=0.367 //l=0.35 //layer=li \
 //thickness=0.1 //x=37.88 //y=7.585 //x2=38.23 //y2=7.585
r638 (  353 411 ) resistor r=2.87058 //w=0.35 //l=0.085 //layer=li \
 //thickness=0.1 //x=38.59 //y=7.585 //x2=38.675 //y2=7.585
r639 (  353 356 ) resistor r=12.5559 //w=0.367 //l=0.36 //layer=li \
 //thickness=0.1 //x=38.59 //y=7.585 //x2=38.23 //y2=7.585
r640 (  347 410 ) resistor r=4.23183 //w=0.7 //l=0.175 //layer=li \
 //thickness=0.1 //x=37.795 //y=7.41 //x2=37.795 //y2=7.585
r641 (  347 435 ) resistor r=56.4706 //w=0.187 //l=0.825 //layer=li \
 //thickness=0.1 //x=37.795 //y=7.41 //x2=37.795 //y2=6.585
r642 (  346 409 ) resistor r=5.29055 //w=0.35 //l=0.17 //layer=li \
 //thickness=0.1 //x=37.29 //y=7.585 //x2=37.12 //y2=7.585
r643 (  345 410 ) resistor r=2.87058 //w=0.35 //l=0.085 //layer=li \
 //thickness=0.1 //x=37.71 //y=7.585 //x2=37.795 //y2=7.585
r644 (  345 346 ) resistor r=14.6485 //w=0.367 //l=0.42 //layer=li \
 //thickness=0.1 //x=37.71 //y=7.585 //x2=37.29 //y2=7.585
r645 (  340 342 ) resistor r=38.7139 //w=0.367 //l=1.11 //layer=li \
 //thickness=0.1 //x=35.64 //y=7.585 //x2=36.75 //y2=7.585
r646 (  338 408 ) resistor r=2.87058 //w=0.35 //l=0.085 //layer=li \
 //thickness=0.1 //x=35.105 //y=7.585 //x2=35.02 //y2=7.585
r647 (  338 340 ) resistor r=18.6594 //w=0.367 //l=0.535 //layer=li \
 //thickness=0.1 //x=35.105 //y=7.585 //x2=35.64 //y2=7.585
r648 (  337 409 ) resistor r=5.29055 //w=0.35 //l=0.17 //layer=li \
 //thickness=0.1 //x=36.95 //y=7.585 //x2=37.12 //y2=7.585
r649 (  337 342 ) resistor r=6.97548 //w=0.367 //l=0.2 //layer=li \
 //thickness=0.1 //x=36.95 //y=7.585 //x2=36.75 //y2=7.585
r650 (  331 408 ) resistor r=4.23183 //w=0.7 //l=0.175 //layer=li \
 //thickness=0.1 //x=35.02 //y=7.41 //x2=35.02 //y2=7.585
r651 (  331 434 ) resistor r=33.5401 //w=0.187 //l=0.49 //layer=li \
 //thickness=0.1 //x=35.02 //y=7.41 //x2=35.02 //y2=6.92
r652 (  328 407 ) resistor r=5.29055 //w=0.35 //l=0.17 //layer=li \
 //thickness=0.1 //x=33.96 //y=7.585 //x2=33.79 //y2=7.585
r653 (  328 330 ) resistor r=19.8801 //w=0.367 //l=0.57 //layer=li \
 //thickness=0.1 //x=33.96 //y=7.585 //x2=34.53 //y2=7.585
r654 (  327 408 ) resistor r=2.87058 //w=0.35 //l=0.085 //layer=li \
 //thickness=0.1 //x=34.935 //y=7.585 //x2=35.02 //y2=7.585
r655 (  327 330 ) resistor r=14.1253 //w=0.367 //l=0.405 //layer=li \
 //thickness=0.1 //x=34.935 //y=7.585 //x2=34.53 //y2=7.585
r656 (  324 406 ) resistor r=2.87058 //w=0.35 //l=0.085 //layer=li \
 //thickness=0.1 //x=33.21 //y=7.585 //x2=33.125 //y2=7.585
r657 (  323 407 ) resistor r=5.29055 //w=0.35 //l=0.17 //layer=li \
 //thickness=0.1 //x=33.62 //y=7.585 //x2=33.79 //y2=7.585
r658 (  323 324 ) resistor r=14.2997 //w=0.367 //l=0.41 //layer=li \
 //thickness=0.1 //x=33.62 //y=7.585 //x2=33.21 //y2=7.585
r659 (  317 406 ) resistor r=4.23183 //w=0.7 //l=0.175 //layer=li \
 //thickness=0.1 //x=33.125 //y=7.41 //x2=33.125 //y2=7.585
r660 (  317 433 ) resistor r=56.4706 //w=0.187 //l=0.825 //layer=li \
 //thickness=0.1 //x=33.125 //y=7.41 //x2=33.125 //y2=6.585
r661 (  316 404 ) resistor r=2.87058 //w=0.35 //l=0.085 //layer=li \
 //thickness=0.1 //x=32.33 //y=7.585 //x2=32.245 //y2=7.585
r662 (  315 406 ) resistor r=2.87058 //w=0.35 //l=0.085 //layer=li \
 //thickness=0.1 //x=33.04 //y=7.585 //x2=33.125 //y2=7.585
r663 (  315 316 ) resistor r=24.7629 //w=0.367 //l=0.71 //layer=li \
 //thickness=0.1 //x=33.04 //y=7.585 //x2=32.33 //y2=7.585
r664 (  309 404 ) resistor r=4.23183 //w=0.7 //l=0.175 //layer=li \
 //thickness=0.1 //x=32.245 //y=7.41 //x2=32.245 //y2=7.585
r665 (  309 432 ) resistor r=56.4706 //w=0.187 //l=0.825 //layer=li \
 //thickness=0.1 //x=32.245 //y=7.41 //x2=32.245 //y2=6.585
r666 (  306 403 ) resistor r=5.29055 //w=0.35 //l=0.17 //layer=li \
 //thickness=0.1 //x=31.74 //y=7.585 //x2=31.57 //y2=7.585
r667 (  306 308 ) resistor r=6.97548 //w=0.367 //l=0.2 //layer=li \
 //thickness=0.1 //x=31.74 //y=7.585 //x2=31.94 //y2=7.585
r668 (  305 404 ) resistor r=2.87058 //w=0.35 //l=0.085 //layer=li \
 //thickness=0.1 //x=32.16 //y=7.585 //x2=32.245 //y2=7.585
r669 (  305 308 ) resistor r=7.67302 //w=0.367 //l=0.22 //layer=li \
 //thickness=0.1 //x=32.16 //y=7.585 //x2=31.94 //y2=7.585
r670 (  302 402 ) resistor r=2.87058 //w=0.35 //l=0.085 //layer=li \
 //thickness=0.1 //x=30.875 //y=7.585 //x2=30.79 //y2=7.585
r671 (  301 403 ) resistor r=5.29055 //w=0.35 //l=0.17 //layer=li \
 //thickness=0.1 //x=31.4 //y=7.585 //x2=31.57 //y2=7.585
r672 (  301 302 ) resistor r=18.3106 //w=0.367 //l=0.525 //layer=li \
 //thickness=0.1 //x=31.4 //y=7.585 //x2=30.875 //y2=7.585
r673 (  295 402 ) resistor r=4.23183 //w=0.7 //l=0.175 //layer=li \
 //thickness=0.1 //x=30.79 //y=7.41 //x2=30.79 //y2=7.585
r674 (  295 431 ) resistor r=33.1979 //w=0.187 //l=0.485 //layer=li \
 //thickness=0.1 //x=30.79 //y=7.41 //x2=30.79 //y2=6.925
r675 (  292 401 ) resistor r=2.87058 //w=0.35 //l=0.085 //layer=li \
 //thickness=0.1 //x=29.995 //y=7.585 //x2=29.91 //y2=7.585
r676 (  292 294 ) resistor r=16.218 //w=0.367 //l=0.465 //layer=li \
 //thickness=0.1 //x=29.995 //y=7.585 //x2=30.46 //y2=7.585
r677 (  291 402 ) resistor r=2.87058 //w=0.35 //l=0.085 //layer=li \
 //thickness=0.1 //x=30.705 //y=7.585 //x2=30.79 //y2=7.585
r678 (  291 294 ) resistor r=8.54496 //w=0.367 //l=0.245 //layer=li \
 //thickness=0.1 //x=30.705 //y=7.585 //x2=30.46 //y2=7.585
r679 (  285 401 ) resistor r=4.23183 //w=0.7 //l=0.175 //layer=li \
 //thickness=0.1 //x=29.91 //y=7.41 //x2=29.91 //y2=7.585
r680 (  285 430 ) resistor r=33.1979 //w=0.187 //l=0.485 //layer=li \
 //thickness=0.1 //x=29.91 //y=7.41 //x2=29.91 //y2=6.925
r681 (  282 400 ) resistor r=2.87058 //w=0.35 //l=0.085 //layer=li \
 //thickness=0.1 //x=29.115 //y=7.585 //x2=29.03 //y2=7.585
r682 (  282 284 ) resistor r=8.19619 //w=0.367 //l=0.235 //layer=li \
 //thickness=0.1 //x=29.115 //y=7.585 //x2=29.35 //y2=7.585
r683 (  281 401 ) resistor r=2.87058 //w=0.35 //l=0.085 //layer=li \
 //thickness=0.1 //x=29.825 //y=7.585 //x2=29.91 //y2=7.585
r684 (  281 284 ) resistor r=16.5668 //w=0.367 //l=0.475 //layer=li \
 //thickness=0.1 //x=29.825 //y=7.585 //x2=29.35 //y2=7.585
r685 (  275 400 ) resistor r=4.23183 //w=0.7 //l=0.175 //layer=li \
 //thickness=0.1 //x=29.03 //y=7.41 //x2=29.03 //y2=7.585
r686 (  275 429 ) resistor r=56.4706 //w=0.187 //l=0.825 //layer=li \
 //thickness=0.1 //x=29.03 //y=7.41 //x2=29.03 //y2=6.585
r687 (  274 399 ) resistor r=5.29055 //w=0.35 //l=0.17 //layer=li \
 //thickness=0.1 //x=28.41 //y=7.585 //x2=28.24 //y2=7.585
r688 (  273 400 ) resistor r=2.87058 //w=0.35 //l=0.085 //layer=li \
 //thickness=0.1 //x=28.945 //y=7.585 //x2=29.03 //y2=7.585
r689 (  273 274 ) resistor r=18.6594 //w=0.367 //l=0.535 //layer=li \
 //thickness=0.1 //x=28.945 //y=7.585 //x2=28.41 //y2=7.585
r690 (  268 398 ) resistor r=2.87058 //w=0.35 //l=0.085 //layer=li \
 //thickness=0.1 //x=27.66 //y=7.585 //x2=27.575 //y2=7.585
r691 (  268 270 ) resistor r=7.32425 //w=0.367 //l=0.21 //layer=li \
 //thickness=0.1 //x=27.66 //y=7.585 //x2=27.87 //y2=7.585
r692 (  267 399 ) resistor r=5.29055 //w=0.35 //l=0.17 //layer=li \
 //thickness=0.1 //x=28.07 //y=7.585 //x2=28.24 //y2=7.585
r693 (  267 270 ) resistor r=6.97548 //w=0.367 //l=0.2 //layer=li \
 //thickness=0.1 //x=28.07 //y=7.585 //x2=27.87 //y2=7.585
r694 (  261 398 ) resistor r=4.23183 //w=0.7 //l=0.175 //layer=li \
 //thickness=0.1 //x=27.575 //y=7.41 //x2=27.575 //y2=7.585
r695 (  261 428 ) resistor r=56.4706 //w=0.187 //l=0.825 //layer=li \
 //thickness=0.1 //x=27.575 //y=7.41 //x2=27.575 //y2=6.585
r696 (  260 397 ) resistor r=2.87058 //w=0.35 //l=0.085 //layer=li \
 //thickness=0.1 //x=26.78 //y=7.585 //x2=26.695 //y2=7.585
r697 (  259 398 ) resistor r=2.87058 //w=0.35 //l=0.085 //layer=li \
 //thickness=0.1 //x=27.49 //y=7.585 //x2=27.575 //y2=7.585
r698 (  259 260 ) resistor r=24.7629 //w=0.367 //l=0.71 //layer=li \
 //thickness=0.1 //x=27.49 //y=7.585 //x2=26.78 //y2=7.585
r699 (  253 397 ) resistor r=4.23183 //w=0.7 //l=0.175 //layer=li \
 //thickness=0.1 //x=26.695 //y=7.41 //x2=26.695 //y2=7.585
r700 (  253 427 ) resistor r=56.4706 //w=0.187 //l=0.825 //layer=li \
 //thickness=0.1 //x=26.695 //y=7.41 //x2=26.695 //y2=6.585
r701 (  252 395 ) resistor r=5.29055 //w=0.35 //l=0.17 //layer=li \
 //thickness=0.1 //x=26.19 //y=7.585 //x2=26.02 //y2=7.585
r702 (  251 397 ) resistor r=2.87058 //w=0.35 //l=0.085 //layer=li \
 //thickness=0.1 //x=26.61 //y=7.585 //x2=26.695 //y2=7.585
r703 (  251 252 ) resistor r=14.6485 //w=0.367 //l=0.42 //layer=li \
 //thickness=0.1 //x=26.61 //y=7.585 //x2=26.19 //y2=7.585
r704 (  248 394 ) resistor r=2.87058 //w=0.35 //l=0.085 //layer=li \
 //thickness=0.1 //x=25.325 //y=7.585 //x2=25.24 //y2=7.585
r705 (  247 395 ) resistor r=5.29055 //w=0.35 //l=0.17 //layer=li \
 //thickness=0.1 //x=25.85 //y=7.585 //x2=26.02 //y2=7.585
r706 (  247 248 ) resistor r=18.3106 //w=0.367 //l=0.525 //layer=li \
 //thickness=0.1 //x=25.85 //y=7.585 //x2=25.325 //y2=7.585
r707 (  241 394 ) resistor r=4.23183 //w=0.7 //l=0.175 //layer=li \
 //thickness=0.1 //x=25.24 //y=7.41 //x2=25.24 //y2=7.585
r708 (  241 426 ) resistor r=33.1979 //w=0.187 //l=0.485 //layer=li \
 //thickness=0.1 //x=25.24 //y=7.41 //x2=25.24 //y2=6.925
r709 (  240 392 ) resistor r=2.87058 //w=0.35 //l=0.085 //layer=li \
 //thickness=0.1 //x=24.445 //y=7.585 //x2=24.36 //y2=7.585
r710 (  239 394 ) resistor r=2.87058 //w=0.35 //l=0.085 //layer=li \
 //thickness=0.1 //x=25.155 //y=7.585 //x2=25.24 //y2=7.585
r711 (  239 240 ) resistor r=24.7629 //w=0.367 //l=0.71 //layer=li \
 //thickness=0.1 //x=25.155 //y=7.585 //x2=24.445 //y2=7.585
r712 (  233 392 ) resistor r=4.23183 //w=0.7 //l=0.175 //layer=li \
 //thickness=0.1 //x=24.36 //y=7.41 //x2=24.36 //y2=7.585
r713 (  233 425 ) resistor r=33.1979 //w=0.187 //l=0.485 //layer=li \
 //thickness=0.1 //x=24.36 //y=7.41 //x2=24.36 //y2=6.925
r714 (  230 391 ) resistor r=2.87058 //w=0.35 //l=0.085 //layer=li \
 //thickness=0.1 //x=23.565 //y=7.585 //x2=23.48 //y2=7.585
r715 (  230 232 ) resistor r=21.1008 //w=0.367 //l=0.605 //layer=li \
 //thickness=0.1 //x=23.565 //y=7.585 //x2=24.17 //y2=7.585
r716 (  229 392 ) resistor r=2.87058 //w=0.35 //l=0.085 //layer=li \
 //thickness=0.1 //x=24.275 //y=7.585 //x2=24.36 //y2=7.585
r717 (  229 232 ) resistor r=3.66213 //w=0.367 //l=0.105 //layer=li \
 //thickness=0.1 //x=24.275 //y=7.585 //x2=24.17 //y2=7.585
r718 (  223 391 ) resistor r=4.23183 //w=0.7 //l=0.175 //layer=li \
 //thickness=0.1 //x=23.48 //y=7.41 //x2=23.48 //y2=7.585
r719 (  223 424 ) resistor r=56.4706 //w=0.187 //l=0.825 //layer=li \
 //thickness=0.1 //x=23.48 //y=7.41 //x2=23.48 //y2=6.585
r720 (  220 390 ) resistor r=5.29055 //w=0.35 //l=0.17 //layer=li \
 //thickness=0.1 //x=22.86 //y=7.585 //x2=22.69 //y2=7.585
r721 (  220 222 ) resistor r=6.97548 //w=0.367 //l=0.2 //layer=li \
 //thickness=0.1 //x=22.86 //y=7.585 //x2=23.06 //y2=7.585
r722 (  219 391 ) resistor r=2.87058 //w=0.35 //l=0.085 //layer=li \
 //thickness=0.1 //x=23.395 //y=7.585 //x2=23.48 //y2=7.585
r723 (  219 222 ) resistor r=11.6839 //w=0.367 //l=0.335 //layer=li \
 //thickness=0.1 //x=23.395 //y=7.585 //x2=23.06 //y2=7.585
r724 (  216 389 ) resistor r=2.87058 //w=0.35 //l=0.085 //layer=li \
 //thickness=0.1 //x=22.1 //y=7.585 //x2=22.015 //y2=7.585
r725 (  215 390 ) resistor r=5.29055 //w=0.35 //l=0.17 //layer=li \
 //thickness=0.1 //x=22.52 //y=7.585 //x2=22.69 //y2=7.585
r726 (  215 216 ) resistor r=14.6485 //w=0.367 //l=0.42 //layer=li \
 //thickness=0.1 //x=22.52 //y=7.585 //x2=22.1 //y2=7.585
r727 (  209 389 ) resistor r=4.23183 //w=0.7 //l=0.175 //layer=li \
 //thickness=0.1 //x=22.015 //y=7.41 //x2=22.015 //y2=7.585
r728 (  209 423 ) resistor r=56.4706 //w=0.187 //l=0.825 //layer=li \
 //thickness=0.1 //x=22.015 //y=7.41 //x2=22.015 //y2=6.585
r729 (  206 388 ) resistor r=2.87058 //w=0.35 //l=0.085 //layer=li \
 //thickness=0.1 //x=21.22 //y=7.585 //x2=21.135 //y2=7.585
r730 (  206 208 ) resistor r=12.5559 //w=0.367 //l=0.36 //layer=li \
 //thickness=0.1 //x=21.22 //y=7.585 //x2=21.58 //y2=7.585
r731 (  205 389 ) resistor r=2.87058 //w=0.35 //l=0.085 //layer=li \
 //thickness=0.1 //x=21.93 //y=7.585 //x2=22.015 //y2=7.585
r732 (  205 208 ) resistor r=12.2071 //w=0.367 //l=0.35 //layer=li \
 //thickness=0.1 //x=21.93 //y=7.585 //x2=21.58 //y2=7.585
r733 (  199 388 ) resistor r=4.23183 //w=0.7 //l=0.175 //layer=li \
 //thickness=0.1 //x=21.135 //y=7.41 //x2=21.135 //y2=7.585
r734 (  199 422 ) resistor r=56.4706 //w=0.187 //l=0.825 //layer=li \
 //thickness=0.1 //x=21.135 //y=7.41 //x2=21.135 //y2=6.585
r735 (  198 387 ) resistor r=5.29055 //w=0.35 //l=0.17 //layer=li \
 //thickness=0.1 //x=20.64 //y=7.585 //x2=20.47 //y2=7.585
r736 (  197 388 ) resistor r=2.87058 //w=0.35 //l=0.085 //layer=li \
 //thickness=0.1 //x=21.05 //y=7.585 //x2=21.135 //y2=7.585
r737 (  197 198 ) resistor r=14.2997 //w=0.367 //l=0.41 //layer=li \
 //thickness=0.1 //x=21.05 //y=7.585 //x2=20.64 //y2=7.585
r738 (  192 194 ) resistor r=38.7139 //w=0.367 //l=1.11 //layer=li \
 //thickness=0.1 //x=18.99 //y=7.585 //x2=20.1 //y2=7.585
r739 (  190 386 ) resistor r=2.87058 //w=0.35 //l=0.085 //layer=li \
 //thickness=0.1 //x=18.455 //y=7.585 //x2=18.37 //y2=7.585
r740 (  190 192 ) resistor r=18.6594 //w=0.367 //l=0.535 //layer=li \
 //thickness=0.1 //x=18.455 //y=7.585 //x2=18.99 //y2=7.585
r741 (  189 387 ) resistor r=5.29055 //w=0.35 //l=0.17 //layer=li \
 //thickness=0.1 //x=20.3 //y=7.585 //x2=20.47 //y2=7.585
r742 (  189 194 ) resistor r=6.97548 //w=0.367 //l=0.2 //layer=li \
 //thickness=0.1 //x=20.3 //y=7.585 //x2=20.1 //y2=7.585
r743 (  185 386 ) resistor r=4.23183 //w=0.7 //l=0.175 //layer=li \
 //thickness=0.1 //x=18.37 //y=7.41 //x2=18.37 //y2=7.585
r744 (  185 421 ) resistor r=80.4278 //w=0.187 //l=1.175 //layer=li \
 //thickness=0.1 //x=18.37 //y=7.41 //x2=18.37 //y2=6.235
r745 (  182 385 ) resistor r=5.29055 //w=0.35 //l=0.17 //layer=li \
 //thickness=0.1 //x=17.31 //y=7.585 //x2=17.14 //y2=7.585
r746 (  182 184 ) resistor r=19.8801 //w=0.367 //l=0.57 //layer=li \
 //thickness=0.1 //x=17.31 //y=7.585 //x2=17.88 //y2=7.585
r747 (  181 386 ) resistor r=2.87058 //w=0.35 //l=0.085 //layer=li \
 //thickness=0.1 //x=18.285 //y=7.585 //x2=18.37 //y2=7.585
r748 (  181 184 ) resistor r=14.1253 //w=0.367 //l=0.405 //layer=li \
 //thickness=0.1 //x=18.285 //y=7.585 //x2=17.88 //y2=7.585
r749 (  176 178 ) resistor r=38.7139 //w=0.367 //l=1.11 //layer=li \
 //thickness=0.1 //x=15.29 //y=7.585 //x2=16.4 //y2=7.585
r750 (  174 384 ) resistor r=2.87058 //w=0.35 //l=0.085 //layer=li \
 //thickness=0.1 //x=15.125 //y=7.585 //x2=15.04 //y2=7.585
r751 (  174 176 ) resistor r=5.75477 //w=0.367 //l=0.165 //layer=li \
 //thickness=0.1 //x=15.125 //y=7.585 //x2=15.29 //y2=7.585
r752 (  173 385 ) resistor r=5.29055 //w=0.35 //l=0.17 //layer=li \
 //thickness=0.1 //x=16.97 //y=7.585 //x2=17.14 //y2=7.585
r753 (  173 178 ) resistor r=19.8801 //w=0.367 //l=0.57 //layer=li \
 //thickness=0.1 //x=16.97 //y=7.585 //x2=16.4 //y2=7.585
r754 (  169 384 ) resistor r=4.23183 //w=0.7 //l=0.175 //layer=li \
 //thickness=0.1 //x=15.04 //y=7.41 //x2=15.04 //y2=7.585
r755 (  169 420 ) resistor r=80.4278 //w=0.187 //l=1.175 //layer=li \
 //thickness=0.1 //x=15.04 //y=7.41 //x2=15.04 //y2=6.235
r756 (  166 383 ) resistor r=5.29055 //w=0.35 //l=0.17 //layer=li \
 //thickness=0.1 //x=13.98 //y=7.585 //x2=13.81 //y2=7.585
r757 (  166 168 ) resistor r=6.97548 //w=0.367 //l=0.2 //layer=li \
 //thickness=0.1 //x=13.98 //y=7.585 //x2=14.18 //y2=7.585
r758 (  165 384 ) resistor r=2.87058 //w=0.35 //l=0.085 //layer=li \
 //thickness=0.1 //x=14.955 //y=7.585 //x2=15.04 //y2=7.585
r759 (  165 168 ) resistor r=27.03 //w=0.367 //l=0.775 //layer=li \
 //thickness=0.1 //x=14.955 //y=7.585 //x2=14.18 //y2=7.585
r760 (  162 382 ) resistor r=2.87058 //w=0.35 //l=0.085 //layer=li \
 //thickness=0.1 //x=13.23 //y=7.585 //x2=13.145 //y2=7.585
r761 (  161 383 ) resistor r=5.29055 //w=0.35 //l=0.17 //layer=li \
 //thickness=0.1 //x=13.64 //y=7.585 //x2=13.81 //y2=7.585
r762 (  161 162 ) resistor r=14.2997 //w=0.367 //l=0.41 //layer=li \
 //thickness=0.1 //x=13.64 //y=7.585 //x2=13.23 //y2=7.585
r763 (  155 382 ) resistor r=4.23183 //w=0.7 //l=0.175 //layer=li \
 //thickness=0.1 //x=13.145 //y=7.41 //x2=13.145 //y2=7.585
r764 (  155 419 ) resistor r=56.4706 //w=0.187 //l=0.825 //layer=li \
 //thickness=0.1 //x=13.145 //y=7.41 //x2=13.145 //y2=6.585
r765 (  152 381 ) resistor r=2.87058 //w=0.35 //l=0.085 //layer=li \
 //thickness=0.1 //x=12.35 //y=7.585 //x2=12.265 //y2=7.585
r766 (  152 154 ) resistor r=12.2071 //w=0.367 //l=0.35 //layer=li \
 //thickness=0.1 //x=12.35 //y=7.585 //x2=12.7 //y2=7.585
r767 (  151 382 ) resistor r=2.87058 //w=0.35 //l=0.085 //layer=li \
 //thickness=0.1 //x=13.06 //y=7.585 //x2=13.145 //y2=7.585
r768 (  151 154 ) resistor r=12.5559 //w=0.367 //l=0.36 //layer=li \
 //thickness=0.1 //x=13.06 //y=7.585 //x2=12.7 //y2=7.585
r769 (  145 381 ) resistor r=4.23183 //w=0.7 //l=0.175 //layer=li \
 //thickness=0.1 //x=12.265 //y=7.41 //x2=12.265 //y2=7.585
r770 (  145 418 ) resistor r=56.4706 //w=0.187 //l=0.825 //layer=li \
 //thickness=0.1 //x=12.265 //y=7.41 //x2=12.265 //y2=6.585
r771 (  144 380 ) resistor r=5.29055 //w=0.35 //l=0.17 //layer=li \
 //thickness=0.1 //x=11.76 //y=7.585 //x2=11.59 //y2=7.585
r772 (  143 381 ) resistor r=2.87058 //w=0.35 //l=0.085 //layer=li \
 //thickness=0.1 //x=12.18 //y=7.585 //x2=12.265 //y2=7.585
r773 (  143 144 ) resistor r=14.6485 //w=0.367 //l=0.42 //layer=li \
 //thickness=0.1 //x=12.18 //y=7.585 //x2=11.76 //y2=7.585
r774 (  138 379 ) resistor r=2.87058 //w=0.35 //l=0.085 //layer=li \
 //thickness=0.1 //x=11 //y=7.585 //x2=10.915 //y2=7.585
r775 (  138 140 ) resistor r=7.67302 //w=0.367 //l=0.22 //layer=li \
 //thickness=0.1 //x=11 //y=7.585 //x2=11.22 //y2=7.585
r776 (  137 380 ) resistor r=5.29055 //w=0.35 //l=0.17 //layer=li \
 //thickness=0.1 //x=11.42 //y=7.585 //x2=11.59 //y2=7.585
r777 (  137 140 ) resistor r=6.97548 //w=0.367 //l=0.2 //layer=li \
 //thickness=0.1 //x=11.42 //y=7.585 //x2=11.22 //y2=7.585
r778 (  131 379 ) resistor r=4.23183 //w=0.7 //l=0.175 //layer=li \
 //thickness=0.1 //x=10.915 //y=7.41 //x2=10.915 //y2=7.585
r779 (  131 417 ) resistor r=56.4706 //w=0.187 //l=0.825 //layer=li \
 //thickness=0.1 //x=10.915 //y=7.41 //x2=10.915 //y2=6.585
r780 (  130 378 ) resistor r=2.87058 //w=0.35 //l=0.085 //layer=li \
 //thickness=0.1 //x=10.12 //y=7.585 //x2=10.035 //y2=7.585
r781 (  129 379 ) resistor r=2.87058 //w=0.35 //l=0.085 //layer=li \
 //thickness=0.1 //x=10.83 //y=7.585 //x2=10.915 //y2=7.585
r782 (  129 130 ) resistor r=24.7629 //w=0.367 //l=0.71 //layer=li \
 //thickness=0.1 //x=10.83 //y=7.585 //x2=10.12 //y2=7.585
r783 (  123 378 ) resistor r=4.23183 //w=0.7 //l=0.175 //layer=li \
 //thickness=0.1 //x=10.035 //y=7.41 //x2=10.035 //y2=7.585
r784 (  123 416 ) resistor r=56.4706 //w=0.187 //l=0.825 //layer=li \
 //thickness=0.1 //x=10.035 //y=7.41 //x2=10.035 //y2=6.585
r785 (  122 376 ) resistor r=5.29055 //w=0.35 //l=0.17 //layer=li \
 //thickness=0.1 //x=9.54 //y=7.585 //x2=9.37 //y2=7.585
r786 (  121 378 ) resistor r=2.87058 //w=0.35 //l=0.085 //layer=li \
 //thickness=0.1 //x=9.95 //y=7.585 //x2=10.035 //y2=7.585
r787 (  121 122 ) resistor r=14.2997 //w=0.367 //l=0.41 //layer=li \
 //thickness=0.1 //x=9.95 //y=7.585 //x2=9.54 //y2=7.585
r788 (  116 118 ) resistor r=38.7139 //w=0.367 //l=1.11 //layer=li \
 //thickness=0.1 //x=7.52 //y=7.585 //x2=8.63 //y2=7.585
r789 (  114 375 ) resistor r=2.87058 //w=0.35 //l=0.085 //layer=li \
 //thickness=0.1 //x=7.355 //y=7.585 //x2=7.27 //y2=7.585
r790 (  114 116 ) resistor r=5.75477 //w=0.367 //l=0.165 //layer=li \
 //thickness=0.1 //x=7.355 //y=7.585 //x2=7.52 //y2=7.585
r791 (  113 376 ) resistor r=5.29055 //w=0.35 //l=0.17 //layer=li \
 //thickness=0.1 //x=9.2 //y=7.585 //x2=9.37 //y2=7.585
r792 (  113 118 ) resistor r=19.8801 //w=0.367 //l=0.57 //layer=li \
 //thickness=0.1 //x=9.2 //y=7.585 //x2=8.63 //y2=7.585
r793 (  109 375 ) resistor r=4.23183 //w=0.7 //l=0.175 //layer=li \
 //thickness=0.1 //x=7.27 //y=7.41 //x2=7.27 //y2=7.585
r794 (  109 415 ) resistor r=80.4278 //w=0.187 //l=1.175 //layer=li \
 //thickness=0.1 //x=7.27 //y=7.41 //x2=7.27 //y2=6.235
r795 (  106 374 ) resistor r=5.29055 //w=0.35 //l=0.17 //layer=li \
 //thickness=0.1 //x=6.21 //y=7.585 //x2=6.04 //y2=7.585
r796 (  106 108 ) resistor r=6.97548 //w=0.367 //l=0.2 //layer=li \
 //thickness=0.1 //x=6.21 //y=7.585 //x2=6.41 //y2=7.585
r797 (  105 375 ) resistor r=2.87058 //w=0.35 //l=0.085 //layer=li \
 //thickness=0.1 //x=7.185 //y=7.585 //x2=7.27 //y2=7.585
r798 (  105 108 ) resistor r=27.03 //w=0.367 //l=0.775 //layer=li \
 //thickness=0.1 //x=7.185 //y=7.585 //x2=6.41 //y2=7.585
r799 (  100 373 ) resistor r=2.87058 //w=0.35 //l=0.085 //layer=li \
 //thickness=0.1 //x=4.025 //y=7.585 //x2=3.94 //y2=7.585
r800 (  100 102 ) resistor r=31.564 //w=0.367 //l=0.905 //layer=li \
 //thickness=0.1 //x=4.025 //y=7.585 //x2=4.93 //y2=7.585
r801 (  99 374 ) resistor r=5.29055 //w=0.35 //l=0.17 //layer=li \
 //thickness=0.1 //x=5.87 //y=7.585 //x2=6.04 //y2=7.585
r802 (  99 102 ) resistor r=32.7847 //w=0.367 //l=0.94 //layer=li \
 //thickness=0.1 //x=5.87 //y=7.585 //x2=4.93 //y2=7.585
r803 (  95 373 ) resistor r=4.23183 //w=0.7 //l=0.175 //layer=li \
 //thickness=0.1 //x=3.94 //y=7.41 //x2=3.94 //y2=7.585
r804 (  95 414 ) resistor r=80.4278 //w=0.187 //l=1.175 //layer=li \
 //thickness=0.1 //x=3.94 //y=7.41 //x2=3.94 //y2=6.235
r805 (  92 372 ) resistor r=5.29055 //w=0.35 //l=0.17 //layer=li \
 //thickness=0.1 //x=2.88 //y=7.585 //x2=2.71 //y2=7.585
r806 (  92 94 ) resistor r=32.7847 //w=0.367 //l=0.94 //layer=li \
 //thickness=0.1 //x=2.88 //y=7.585 //x2=3.82 //y2=7.585
r807 (  91 373 ) resistor r=2.87058 //w=0.35 //l=0.085 //layer=li \
 //thickness=0.1 //x=3.855 //y=7.585 //x2=3.94 //y2=7.585
r808 (  91 94 ) resistor r=1.22071 //w=0.367 //l=0.035 //layer=li \
 //thickness=0.1 //x=3.855 //y=7.585 //x2=3.82 //y2=7.585
r809 (  86 371 ) resistor r=2.87058 //w=0.35 //l=0.085 //layer=li \
 //thickness=0.1 //x=2.13 //y=7.585 //x2=2.045 //y2=7.585
r810 (  86 88 ) resistor r=7.32425 //w=0.367 //l=0.21 //layer=li \
 //thickness=0.1 //x=2.13 //y=7.585 //x2=2.34 //y2=7.585
r811 (  85 372 ) resistor r=5.29055 //w=0.35 //l=0.17 //layer=li \
 //thickness=0.1 //x=2.54 //y=7.585 //x2=2.71 //y2=7.585
r812 (  85 88 ) resistor r=6.97548 //w=0.367 //l=0.2 //layer=li \
 //thickness=0.1 //x=2.54 //y=7.585 //x2=2.34 //y2=7.585
r813 (  79 371 ) resistor r=4.23183 //w=0.7 //l=0.175 //layer=li \
 //thickness=0.1 //x=2.045 //y=7.41 //x2=2.045 //y2=7.585
r814 (  79 413 ) resistor r=56.4706 //w=0.187 //l=0.825 //layer=li \
 //thickness=0.1 //x=2.045 //y=7.41 //x2=2.045 //y2=6.585
r815 (  78 370 ) resistor r=2.87058 //w=0.35 //l=0.085 //layer=li \
 //thickness=0.1 //x=1.25 //y=7.585 //x2=1.165 //y2=7.585
r816 (  77 371 ) resistor r=2.87058 //w=0.35 //l=0.085 //layer=li \
 //thickness=0.1 //x=1.96 //y=7.585 //x2=2.045 //y2=7.585
r817 (  77 78 ) resistor r=24.7629 //w=0.367 //l=0.71 //layer=li \
 //thickness=0.1 //x=1.96 //y=7.585 //x2=1.25 //y2=7.585
r818 (  71 370 ) resistor r=4.23183 //w=0.7 //l=0.175 //layer=li \
 //thickness=0.1 //x=1.165 //y=7.41 //x2=1.165 //y2=7.585
r819 (  71 412 ) resistor r=56.4706 //w=0.187 //l=0.825 //layer=li \
 //thickness=0.1 //x=1.165 //y=7.41 //x2=1.165 //y2=6.585
r820 (  65 366 ) resistor r=9.3 //w=0.17 //l=0.17 //layer=mcon //count=1 \
 //x=38.97 //y=7.58 //x2=38.97 //y2=7.58
r821 (  63 356 ) resistor r=3.1 //w=0.17 //l=0.51 //layer=mcon //count=3 \
 //x=38.23 //y=7.58 //x2=38.23 //y2=7.58
r822 (  63 65 ) resistor r=0.297428 //w=0.311 //l=0.74 //layer=m1 \
 //thickness=0.36 //x=38.23 //y=7.585 //x2=38.97 //y2=7.585
r823 (  61 342 ) resistor r=3.1 //w=0.17 //l=0.51 //layer=mcon //count=3 \
 //x=36.75 //y=7.58 //x2=36.75 //y2=7.58
r824 (  61 63 ) resistor r=0.594855 //w=0.311 //l=1.48 //layer=m1 \
 //thickness=0.36 //x=36.75 //y=7.585 //x2=38.23 //y2=7.585
r825 (  59 340 ) resistor r=3.1 //w=0.17 //l=0.51 //layer=mcon //count=3 \
 //x=35.64 //y=7.58 //x2=35.64 //y2=7.58
r826 (  59 61 ) resistor r=0.446141 //w=0.311 //l=1.11 //layer=m1 \
 //thickness=0.36 //x=35.64 //y=7.585 //x2=36.75 //y2=7.585
r827 (  57 330 ) resistor r=3.1 //w=0.17 //l=0.51 //layer=mcon //count=3 \
 //x=34.53 //y=7.58 //x2=34.53 //y2=7.58
r828 (  57 59 ) resistor r=0.446141 //w=0.311 //l=1.11 //layer=m1 \
 //thickness=0.36 //x=34.53 //y=7.585 //x2=35.64 //y2=7.585
r829 (  55 406 ) resistor r=3.1 //w=0.17 //l=0.51 //layer=mcon //count=3 \
 //x=33.05 //y=7.58 //x2=33.05 //y2=7.58
r830 (  55 57 ) resistor r=0.594855 //w=0.311 //l=1.48 //layer=m1 \
 //thickness=0.36 //x=33.05 //y=7.585 //x2=34.53 //y2=7.585
r831 (  53 308 ) resistor r=3.1 //w=0.17 //l=0.51 //layer=mcon //count=3 \
 //x=31.94 //y=7.58 //x2=31.94 //y2=7.58
r832 (  53 55 ) resistor r=0.446141 //w=0.311 //l=1.11 //layer=m1 \
 //thickness=0.36 //x=31.94 //y=7.585 //x2=33.05 //y2=7.585
r833 (  51 294 ) resistor r=3.1 //w=0.17 //l=0.51 //layer=mcon //count=3 \
 //x=30.46 //y=7.58 //x2=30.46 //y2=7.58
r834 (  51 53 ) resistor r=0.594855 //w=0.311 //l=1.48 //layer=m1 \
 //thickness=0.36 //x=30.46 //y=7.585 //x2=31.94 //y2=7.585
r835 (  49 284 ) resistor r=3.1 //w=0.17 //l=0.51 //layer=mcon //count=3 \
 //x=29.35 //y=7.58 //x2=29.35 //y2=7.58
r836 (  49 51 ) resistor r=0.446141 //w=0.311 //l=1.11 //layer=m1 \
 //thickness=0.36 //x=29.35 //y=7.585 //x2=30.46 //y2=7.585
r837 (  47 270 ) resistor r=3.1 //w=0.17 //l=0.51 //layer=mcon //count=3 \
 //x=27.87 //y=7.58 //x2=27.87 //y2=7.58
r838 (  47 49 ) resistor r=0.594855 //w=0.311 //l=1.48 //layer=m1 \
 //thickness=0.36 //x=27.87 //y=7.585 //x2=29.35 //y2=7.585
r839 (  45 397 ) resistor r=3.1 //w=0.17 //l=0.51 //layer=mcon //count=3 \
 //x=26.76 //y=7.58 //x2=26.76 //y2=7.58
r840 (  45 47 ) resistor r=0.446141 //w=0.311 //l=1.11 //layer=m1 \
 //thickness=0.36 //x=26.76 //y=7.585 //x2=27.87 //y2=7.585
r841 (  43 394 ) resistor r=3.1 //w=0.17 //l=0.51 //layer=mcon //count=3 \
 //x=25.28 //y=7.58 //x2=25.28 //y2=7.58
r842 (  43 45 ) resistor r=0.594855 //w=0.311 //l=1.48 //layer=m1 \
 //thickness=0.36 //x=25.28 //y=7.585 //x2=26.76 //y2=7.585
r843 (  41 232 ) resistor r=3.1 //w=0.17 //l=0.51 //layer=mcon //count=3 \
 //x=24.17 //y=7.58 //x2=24.17 //y2=7.58
r844 (  41 43 ) resistor r=0.446141 //w=0.311 //l=1.11 //layer=m1 \
 //thickness=0.36 //x=24.17 //y=7.585 //x2=25.28 //y2=7.585
r845 (  39 222 ) resistor r=3.1 //w=0.17 //l=0.51 //layer=mcon //count=3 \
 //x=23.06 //y=7.58 //x2=23.06 //y2=7.58
r846 (  39 41 ) resistor r=0.446141 //w=0.311 //l=1.11 //layer=m1 \
 //thickness=0.36 //x=23.06 //y=7.585 //x2=24.17 //y2=7.585
r847 (  37 208 ) resistor r=3.1 //w=0.17 //l=0.51 //layer=mcon //count=3 \
 //x=21.58 //y=7.58 //x2=21.58 //y2=7.58
r848 (  37 39 ) resistor r=0.594855 //w=0.311 //l=1.48 //layer=m1 \
 //thickness=0.36 //x=21.58 //y=7.585 //x2=23.06 //y2=7.585
r849 (  35 194 ) resistor r=3.1 //w=0.17 //l=0.51 //layer=mcon //count=3 \
 //x=20.1 //y=7.58 //x2=20.1 //y2=7.58
r850 (  35 37 ) resistor r=0.594855 //w=0.311 //l=1.48 //layer=m1 \
 //thickness=0.36 //x=20.1 //y=7.585 //x2=21.58 //y2=7.585
r851 (  32 192 ) resistor r=3.1 //w=0.17 //l=0.51 //layer=mcon //count=3 \
 //x=18.99 //y=7.58 //x2=18.99 //y2=7.58
r852 (  30 184 ) resistor r=3.1 //w=0.17 //l=0.51 //layer=mcon //count=3 \
 //x=17.88 //y=7.58 //x2=17.88 //y2=7.58
r853 (  30 32 ) resistor r=0.446141 //w=0.311 //l=1.11 //layer=m1 \
 //thickness=0.36 //x=17.88 //y=7.585 //x2=18.99 //y2=7.585
r854 (  28 178 ) resistor r=3.1 //w=0.17 //l=0.51 //layer=mcon //count=3 \
 //x=16.4 //y=7.58 //x2=16.4 //y2=7.58
r855 (  28 30 ) resistor r=0.594855 //w=0.311 //l=1.48 //layer=m1 \
 //thickness=0.36 //x=16.4 //y=7.585 //x2=17.88 //y2=7.585
r856 (  26 176 ) resistor r=3.1 //w=0.17 //l=0.51 //layer=mcon //count=3 \
 //x=15.29 //y=7.58 //x2=15.29 //y2=7.58
r857 (  26 28 ) resistor r=0.446141 //w=0.311 //l=1.11 //layer=m1 \
 //thickness=0.36 //x=15.29 //y=7.585 //x2=16.4 //y2=7.585
r858 (  24 168 ) resistor r=3.1 //w=0.17 //l=0.51 //layer=mcon //count=3 \
 //x=14.18 //y=7.58 //x2=14.18 //y2=7.58
r859 (  24 26 ) resistor r=0.446141 //w=0.311 //l=1.11 //layer=m1 \
 //thickness=0.36 //x=14.18 //y=7.585 //x2=15.29 //y2=7.585
r860 (  22 154 ) resistor r=3.1 //w=0.17 //l=0.51 //layer=mcon //count=3 \
 //x=12.7 //y=7.58 //x2=12.7 //y2=7.58
r861 (  22 24 ) resistor r=0.594855 //w=0.311 //l=1.48 //layer=m1 \
 //thickness=0.36 //x=12.7 //y=7.585 //x2=14.18 //y2=7.585
r862 (  20 140 ) resistor r=3.1 //w=0.17 //l=0.51 //layer=mcon //count=3 \
 //x=11.22 //y=7.58 //x2=11.22 //y2=7.58
r863 (  20 22 ) resistor r=0.594855 //w=0.311 //l=1.48 //layer=m1 \
 //thickness=0.36 //x=11.22 //y=7.585 //x2=12.7 //y2=7.585
r864 (  18 378 ) resistor r=3.1 //w=0.17 //l=0.51 //layer=mcon //count=3 \
 //x=10.11 //y=7.58 //x2=10.11 //y2=7.58
r865 (  18 20 ) resistor r=0.446141 //w=0.311 //l=1.11 //layer=m1 \
 //thickness=0.36 //x=10.11 //y=7.585 //x2=11.22 //y2=7.585
r866 (  16 118 ) resistor r=3.1 //w=0.17 //l=0.51 //layer=mcon //count=3 \
 //x=8.63 //y=7.58 //x2=8.63 //y2=7.58
r867 (  16 18 ) resistor r=0.594855 //w=0.311 //l=1.48 //layer=m1 \
 //thickness=0.36 //x=8.63 //y=7.585 //x2=10.11 //y2=7.585
r868 (  14 116 ) resistor r=3.1 //w=0.17 //l=0.51 //layer=mcon //count=3 \
 //x=7.52 //y=7.58 //x2=7.52 //y2=7.58
r869 (  14 16 ) resistor r=0.446141 //w=0.311 //l=1.11 //layer=m1 \
 //thickness=0.36 //x=7.52 //y=7.585 //x2=8.63 //y2=7.585
r870 (  12 108 ) resistor r=3.1 //w=0.17 //l=0.51 //layer=mcon //count=3 \
 //x=6.41 //y=7.58 //x2=6.41 //y2=7.58
r871 (  12 14 ) resistor r=0.446141 //w=0.311 //l=1.11 //layer=m1 \
 //thickness=0.36 //x=6.41 //y=7.585 //x2=7.52 //y2=7.585
r872 (  10 102 ) resistor r=3.1 //w=0.17 //l=0.51 //layer=mcon //count=3 \
 //x=4.93 //y=7.58 //x2=4.93 //y2=7.58
r873 (  10 12 ) resistor r=0.594855 //w=0.311 //l=1.48 //layer=m1 \
 //thickness=0.36 //x=4.93 //y=7.585 //x2=6.41 //y2=7.585
r874 (  8 94 ) resistor r=3.1 //w=0.17 //l=0.51 //layer=mcon //count=3 \
 //x=3.82 //y=7.58 //x2=3.82 //y2=7.58
r875 (  8 10 ) resistor r=0.446141 //w=0.311 //l=1.11 //layer=m1 \
 //thickness=0.36 //x=3.82 //y=7.585 //x2=4.93 //y2=7.585
r876 (  6 88 ) resistor r=3.1 //w=0.17 //l=0.51 //layer=mcon //count=3 \
 //x=2.34 //y=7.58 //x2=2.34 //y2=7.58
r877 (  6 8 ) resistor r=0.594855 //w=0.311 //l=1.48 //layer=m1 \
 //thickness=0.36 //x=2.34 //y=7.585 //x2=3.82 //y2=7.585
r878 (  3 370 ) resistor r=3.1 //w=0.17 //l=0.51 //layer=mcon //count=3 \
 //x=1.23 //y=7.58 //x2=1.23 //y2=7.58
r879 (  3 6 ) resistor r=0.446141 //w=0.311 //l=1.11 //layer=m1 \
 //thickness=0.36 //x=1.23 //y=7.585 //x2=2.34 //y2=7.585
r880 (  1 35 ) resistor r=0.0743569 //w=0.311 //l=0.185 //layer=m1 \
 //thickness=0.36 //x=19.915 //y=7.585 //x2=20.1 //y2=7.585
r881 (  1 32 ) resistor r=0.371785 //w=0.311 //l=0.925 //layer=m1 \
 //thickness=0.36 //x=19.915 //y=7.585 //x2=18.99 //y2=7.585
ends PM_FA\%VDD

subckt PM_FA\%A ( 1 2 4 5 6 8 17 18 19 20 21 22 23 24 25 26 27 28 29 30 31 32 \
 33 34 36 59 73 74 75 76 77 78 79 80 81 82 83 84 85 89 90 91 93 99 100 101 102 \
 103 104 108 110 113 114 118 119 120 125 127 129 135 136 138 152 156 157 160 )
c377 ( 160 0 ) capacitor c=0.0347334f //x=30.12 //y=4.88
c378 ( 157 0 ) capacitor c=0.0273722f //x=30.09 //y=2.095
c379 ( 156 0 ) capacitor c=0.0405821f //x=30.09 //y=2.26
c380 ( 152 0 ) capacitor c=0.0661295f //x=3.82 //y=4.88
c381 ( 138 0 ) capacitor c=0.0537799f //x=1.23 //y=2.265
c382 ( 136 0 ) capacitor c=0.0429696f //x=30.655 //y=1.43
c383 ( 135 0 ) capacitor c=0.0192208f //x=30.655 //y=1.085
c384 ( 129 0 ) capacitor c=0.0158629f //x=30.5 //y=1.585
c385 ( 127 0 ) capacitor c=0.0157803f //x=30.5 //y=0.93
c386 ( 125 0 ) capacitor c=0.0367015f //x=30.495 //y=4.97
c387 ( 120 0 ) capacitor c=0.0205163f //x=30.125 //y=1.74
c388 ( 119 0 ) capacitor c=0.0168481f //x=30.125 //y=1.43
c389 ( 118 0 ) capacitor c=0.0174142f //x=30.125 //y=1.085
c390 ( 114 0 ) capacitor c=0.0318948f //x=4.155 //y=1.395
c391 ( 113 0 ) capacitor c=0.0186029f //x=4.155 //y=1.05
c392 ( 110 0 ) capacitor c=0.0141798f //x=4 //y=1.55
c393 ( 108 0 ) capacitor c=0.0149852f //x=4 //y=0.895
c394 ( 104 0 ) capacitor c=0.0809667f //x=3.625 //y=2.1
c395 ( 103 0 ) capacitor c=0.0229153f //x=3.625 //y=1.705
c396 ( 102 0 ) capacitor c=0.0234352f //x=3.625 //y=1.395
c397 ( 101 0 ) capacitor c=0.0197989f //x=3.625 //y=1.05
c398 ( 100 0 ) capacitor c=0.0435629f //x=1.87 //y=1.435
c399 ( 99 0 ) capacitor c=0.0200386f //x=1.87 //y=1.09
c400 ( 93 0 ) capacitor c=0.0152946f //x=1.715 //y=1.59
c401 ( 91 0 ) capacitor c=0.0157804f //x=1.715 //y=0.935
c402 ( 90 0 ) capacitor c=0.048995f //x=1.46 //y=4.97
c403 ( 89 0 ) capacitor c=0.0303096f //x=1.75 //y=4.97
c404 ( 85 0 ) capacitor c=0.0290017f //x=1.34 //y=2.1
c405 ( 84 0 ) capacitor c=0.0250027f //x=1.34 //y=1.745
c406 ( 83 0 ) capacitor c=0.0234316f //x=1.34 //y=1.435
c407 ( 82 0 ) capacitor c=0.0200596f //x=1.34 //y=1.09
c408 ( 81 0 ) capacitor c=0.15358f //x=30.57 //y=6.2
c409 ( 80 0 ) capacitor c=0.110184f //x=30.13 //y=6.2
c410 ( 79 0 ) capacitor c=0.110797f //x=4.16 //y=6.2
c411 ( 78 0 ) capacitor c=0.154322f //x=3.72 //y=6.2
c412 ( 77 0 ) capacitor c=0.154218f //x=1.825 //y=6.2
c413 ( 76 0 ) capacitor c=0.154243f //x=1.385 //y=6.2
c414 ( 59 0 ) capacitor c=0.00415003f //x=30.09 //y=4.715
c415 ( 36 0 ) capacitor c=0.110862f //x=1.23 //y=2.265
c416 ( 34 0 ) capacitor c=0.00913498f //x=30.09 //y=2.4
c417 ( 33 0 ) capacitor c=0.0103502f //x=3.82 //y=2.4
c418 ( 28 0 ) capacitor c=0.0719211f //x=30.09 //y=2.77
c419 ( 23 0 ) capacitor c=0.101802f //x=3.82 //y=3.14
c420 ( 8 0 ) capacitor c=0.0133532f //x=30.09 //y=2.285
c421 ( 6 0 ) capacitor c=0.0050701f //x=3.905 //y=2.03
c422 ( 5 0 ) capacitor c=0.487085f //x=30.005 //y=2.03
c423 ( 4 0 ) capacitor c=0.0229105f //x=3.82 //y=2.285
c424 ( 2 0 ) capacitor c=0.0144526f //x=1.345 //y=4.25
c425 ( 1 0 ) capacitor c=0.0967174f //x=3.705 //y=4.25
r426 (  162 163 ) resistor r=32.4568 //w=0.214 //l=0.075 //layer=ply \
 //thickness=0.18 //x=30.12 //y=4.97 //x2=30.12 //y2=5.045
r427 (  160 162 ) resistor r=20.271 //w=0.214 //l=0.09 //layer=ply \
 //thickness=0.18 //x=30.12 //y=4.88 //x2=30.12 //y2=4.97
r428 (  156 157 ) resistor r=52.7279 //w=0.214 //l=0.165 //layer=ply \
 //thickness=0.18 //x=30.09 //y=2.26 //x2=30.09 //y2=2.095
r429 (  150 152 ) resistor r=20.6867 //w=0.233 //l=0.1 //layer=ply \
 //thickness=0.18 //x=3.72 //y=4.88 //x2=3.82 //y2=4.88
r430 (  138 139 ) resistor r=17.5563 //w=0.302 //l=0.11 //layer=ply \
 //thickness=0.18 //x=1.23 //y=2.265 //x2=1.34 //y2=2.265
r431 (  136 167 ) resistor r=45.1352 //w=0.168 //l=0.173853 //layer=ply \
 //thickness=0.18 //x=30.655 //y=1.43 //x2=30.615 //y2=1.585
r432 (  135 166 ) resistor r=45.1352 //w=0.168 //l=0.173853 //layer=ply \
 //thickness=0.18 //x=30.655 //y=1.085 //x2=30.615 //y2=0.93
r433 (  135 136 ) resistor r=176.904 //w=0.094 //l=0.345 //layer=ply \
 //thickness=0.18 //x=30.655 //y=1.085 //x2=30.655 //y2=1.43
r434 (  130 165 ) resistor r=10.701 //w=0.21 //l=0.115 //layer=ply \
 //thickness=0.18 //x=30.28 //y=1.585 //x2=30.165 //y2=1.585
r435 (  129 167 ) resistor r=5.52526 //w=0.168 //l=0.115 //layer=ply \
 //thickness=0.18 //x=30.5 //y=1.585 //x2=30.615 //y2=1.585
r436 (  128 164 ) resistor r=5.52526 //w=0.168 //l=0.115 //layer=ply \
 //thickness=0.18 //x=30.28 //y=0.93 //x2=30.165 //y2=0.93
r437 (  127 166 ) resistor r=5.52526 //w=0.168 //l=0.115 //layer=ply \
 //thickness=0.18 //x=30.5 //y=0.93 //x2=30.615 //y2=0.93
r438 (  127 128 ) resistor r=112.809 //w=0.094 //l=0.22 //layer=ply \
 //thickness=0.18 //x=30.5 //y=0.93 //x2=30.28 //y2=0.93
r439 (  126 162 ) resistor r=16.5046 //w=0.27 //l=0.135 //layer=ply \
 //thickness=0.18 //x=30.255 //y=4.97 //x2=30.12 //y2=4.97
r440 (  125 132 ) resistor r=26.9307 //w=0.15 //l=0.106066 //layer=ply \
 //thickness=0.18 //x=30.495 //y=4.97 //x2=30.57 //y2=5.045
r441 (  125 126 ) resistor r=123.064 //w=0.094 //l=0.24 //layer=ply \
 //thickness=0.18 //x=30.495 //y=4.97 //x2=30.255 //y2=4.97
r442 (  120 165 ) resistor r=39.5823 //w=0.21 //l=0.173853 //layer=ply \
 //thickness=0.18 //x=30.125 //y=1.74 //x2=30.165 //y2=1.585
r443 (  120 157 ) resistor r=182.032 //w=0.094 //l=0.355 //layer=ply \
 //thickness=0.18 //x=30.125 //y=1.74 //x2=30.125 //y2=2.095
r444 (  119 165 ) resistor r=39.5823 //w=0.21 //l=0.173853 //layer=ply \
 //thickness=0.18 //x=30.125 //y=1.43 //x2=30.165 //y2=1.585
r445 (  118 164 ) resistor r=45.1352 //w=0.168 //l=0.173853 //layer=ply \
 //thickness=0.18 //x=30.125 //y=1.085 //x2=30.165 //y2=0.93
r446 (  118 119 ) resistor r=176.904 //w=0.094 //l=0.345 //layer=ply \
 //thickness=0.18 //x=30.125 //y=1.085 //x2=30.125 //y2=1.43
r447 (  115 152 ) resistor r=70.3348 //w=0.233 //l=0.414367 //layer=ply \
 //thickness=0.18 //x=4.16 //y=5.045 //x2=3.82 //y2=4.88
r448 (  114 154 ) resistor r=45.1352 //w=0.168 //l=0.173853 //layer=ply \
 //thickness=0.18 //x=4.155 //y=1.395 //x2=4.115 //y2=1.55
r449 (  113 153 ) resistor r=45.1352 //w=0.168 //l=0.173853 //layer=ply \
 //thickness=0.18 //x=4.155 //y=1.05 //x2=4.115 //y2=0.895
r450 (  113 114 ) resistor r=176.904 //w=0.094 //l=0.345 //layer=ply \
 //thickness=0.18 //x=4.155 //y=1.05 //x2=4.155 //y2=1.395
r451 (  111 149 ) resistor r=10.701 //w=0.21 //l=0.115 //layer=ply \
 //thickness=0.18 //x=3.78 //y=1.55 //x2=3.665 //y2=1.55
r452 (  110 154 ) resistor r=5.52526 //w=0.168 //l=0.115 //layer=ply \
 //thickness=0.18 //x=4 //y=1.55 //x2=4.115 //y2=1.55
r453 (  109 148 ) resistor r=5.52526 //w=0.168 //l=0.115 //layer=ply \
 //thickness=0.18 //x=3.78 //y=0.895 //x2=3.665 //y2=0.895
r454 (  108 153 ) resistor r=5.52526 //w=0.168 //l=0.115 //layer=ply \
 //thickness=0.18 //x=4 //y=0.895 //x2=4.115 //y2=0.895
r455 (  108 109 ) resistor r=112.809 //w=0.094 //l=0.22 //layer=ply \
 //thickness=0.18 //x=4 //y=0.895 //x2=3.78 //y2=0.895
r456 (  105 150 ) resistor r=13.0941 //w=0.233 //l=0.165 //layer=ply \
 //thickness=0.18 //x=3.72 //y=5.045 //x2=3.72 //y2=4.88
r457 (  104 147 ) resistor r=34.8111 //w=0.27 //l=0.264953 //layer=ply \
 //thickness=0.18 //x=3.625 //y=2.1 //x2=3.82 //y2=2.265
r458 (  103 149 ) resistor r=39.5823 //w=0.21 //l=0.173853 //layer=ply \
 //thickness=0.18 //x=3.625 //y=1.705 //x2=3.665 //y2=1.55
r459 (  103 104 ) resistor r=202.543 //w=0.094 //l=0.395 //layer=ply \
 //thickness=0.18 //x=3.625 //y=1.705 //x2=3.625 //y2=2.1
r460 (  102 149 ) resistor r=39.5823 //w=0.21 //l=0.173853 //layer=ply \
 //thickness=0.18 //x=3.625 //y=1.395 //x2=3.665 //y2=1.55
r461 (  101 148 ) resistor r=45.1352 //w=0.168 //l=0.173853 //layer=ply \
 //thickness=0.18 //x=3.625 //y=1.05 //x2=3.665 //y2=0.895
r462 (  101 102 ) resistor r=176.904 //w=0.094 //l=0.345 //layer=ply \
 //thickness=0.18 //x=3.625 //y=1.05 //x2=3.625 //y2=1.395
r463 (  100 145 ) resistor r=45.1352 //w=0.168 //l=0.173853 //layer=ply \
 //thickness=0.18 //x=1.87 //y=1.435 //x2=1.83 //y2=1.59
r464 (  99 144 ) resistor r=45.1352 //w=0.168 //l=0.173853 //layer=ply \
 //thickness=0.18 //x=1.87 //y=1.09 //x2=1.83 //y2=0.935
r465 (  99 100 ) resistor r=176.904 //w=0.094 //l=0.345 //layer=ply \
 //thickness=0.18 //x=1.87 //y=1.09 //x2=1.87 //y2=1.435
r466 (  94 143 ) resistor r=10.701 //w=0.21 //l=0.115 //layer=ply \
 //thickness=0.18 //x=1.495 //y=1.59 //x2=1.38 //y2=1.59
r467 (  93 145 ) resistor r=5.52526 //w=0.168 //l=0.115 //layer=ply \
 //thickness=0.18 //x=1.715 //y=1.59 //x2=1.83 //y2=1.59
r468 (  92 142 ) resistor r=5.52526 //w=0.168 //l=0.115 //layer=ply \
 //thickness=0.18 //x=1.495 //y=0.935 //x2=1.38 //y2=0.935
r469 (  91 144 ) resistor r=5.52526 //w=0.168 //l=0.115 //layer=ply \
 //thickness=0.18 //x=1.715 //y=0.935 //x2=1.83 //y2=0.935
r470 (  91 92 ) resistor r=112.809 //w=0.094 //l=0.22 //layer=ply \
 //thickness=0.18 //x=1.715 //y=0.935 //x2=1.495 //y2=0.935
r471 (  89 96 ) resistor r=26.9307 //w=0.15 //l=0.106066 //layer=ply \
 //thickness=0.18 //x=1.75 //y=4.97 //x2=1.825 //y2=5.045
r472 (  89 90 ) resistor r=148.702 //w=0.094 //l=0.29 //layer=ply \
 //thickness=0.18 //x=1.75 //y=4.97 //x2=1.46 //y2=4.97
r473 (  86 90 ) resistor r=23.403 //w=0.284 //l=0.106066 //layer=ply \
 //thickness=0.18 //x=1.385 //y=5.045 //x2=1.46 //y2=4.97
r474 (  86 141 ) resistor r=26.3063 //w=0.284 //l=0.229783 //layer=ply \
 //thickness=0.18 //x=1.385 //y=5.045 //x2=1.23 //y2=4.88
r475 (  85 139 ) resistor r=19.1248 //w=0.302 //l=0.165 //layer=ply \
 //thickness=0.18 //x=1.34 //y=2.1 //x2=1.34 //y2=2.265
r476 (  84 143 ) resistor r=39.5823 //w=0.21 //l=0.173853 //layer=ply \
 //thickness=0.18 //x=1.34 //y=1.745 //x2=1.38 //y2=1.59
r477 (  84 85 ) resistor r=182.032 //w=0.094 //l=0.355 //layer=ply \
 //thickness=0.18 //x=1.34 //y=1.745 //x2=1.34 //y2=2.1
r478 (  83 143 ) resistor r=39.5823 //w=0.21 //l=0.173853 //layer=ply \
 //thickness=0.18 //x=1.34 //y=1.435 //x2=1.38 //y2=1.59
r479 (  82 142 ) resistor r=45.1352 //w=0.168 //l=0.173853 //layer=ply \
 //thickness=0.18 //x=1.34 //y=1.09 //x2=1.38 //y2=0.935
r480 (  82 83 ) resistor r=176.904 //w=0.094 //l=0.345 //layer=ply \
 //thickness=0.18 //x=1.34 //y=1.09 //x2=1.34 //y2=1.435
r481 (  81 132 ) resistor r=592.245 //w=0.094 //l=1.155 //layer=ply \
 //thickness=0.18 //x=30.57 //y=6.2 //x2=30.57 //y2=5.045
r482 (  80 163 ) resistor r=592.245 //w=0.094 //l=1.155 //layer=ply \
 //thickness=0.18 //x=30.13 //y=6.2 //x2=30.13 //y2=5.045
r483 (  79 115 ) resistor r=592.245 //w=0.094 //l=1.155 //layer=ply \
 //thickness=0.18 //x=4.16 //y=6.2 //x2=4.16 //y2=5.045
r484 (  78 105 ) resistor r=592.245 //w=0.094 //l=1.155 //layer=ply \
 //thickness=0.18 //x=3.72 //y=6.2 //x2=3.72 //y2=5.045
r485 (  77 96 ) resistor r=592.245 //w=0.094 //l=1.155 //layer=ply \
 //thickness=0.18 //x=1.825 //y=6.2 //x2=1.825 //y2=5.045
r486 (  76 86 ) resistor r=592.245 //w=0.094 //l=1.155 //layer=ply \
 //thickness=0.18 //x=1.385 //y=6.2 //x2=1.385 //y2=5.045
r487 (  75 129 ) resistor r=56.4043 //w=0.094 //l=0.11 //layer=ply \
 //thickness=0.18 //x=30.39 //y=1.585 //x2=30.5 //y2=1.585
r488 (  75 130 ) resistor r=56.4043 //w=0.094 //l=0.11 //layer=ply \
 //thickness=0.18 //x=30.39 //y=1.585 //x2=30.28 //y2=1.585
r489 (  74 110 ) resistor r=56.4043 //w=0.094 //l=0.11 //layer=ply \
 //thickness=0.18 //x=3.89 //y=1.55 //x2=4 //y2=1.55
r490 (  74 111 ) resistor r=56.4043 //w=0.094 //l=0.11 //layer=ply \
 //thickness=0.18 //x=3.89 //y=1.55 //x2=3.78 //y2=1.55
r491 (  73 93 ) resistor r=56.4043 //w=0.094 //l=0.11 //layer=ply \
 //thickness=0.18 //x=1.605 //y=1.59 //x2=1.715 //y2=1.59
r492 (  73 94 ) resistor r=56.4043 //w=0.094 //l=0.11 //layer=ply \
 //thickness=0.18 //x=1.605 //y=1.59 //x2=1.495 //y2=1.59
r493 (  69 160 ) resistor r=152 //w=0.17 //l=0.17 //layer=licon //count=1 \
 //x=30.12 //y=4.88 //x2=30.12 //y2=4.88
r494 (  59 69 ) resistor r=11.4737 //w=0.186 //l=0.172337 //layer=li \
 //thickness=0.1 //x=30.09 //y=4.715 //x2=30.105 //y2=4.88
r495 (  56 152 ) resistor r=152 //w=0.17 //l=0.17 //layer=licon //count=1 \
 //x=3.82 //y=4.88 //x2=3.82 //y2=4.88
r496 (  46 141 ) resistor r=152 //w=0.17 //l=0.17 //layer=licon //count=1 \
 //x=1.23 //y=4.88 //x2=1.23 //y2=4.88
r497 (  36 138 ) resistor r=152 //w=0.17 //l=0.17 //layer=licon //count=1 \
 //x=1.23 //y=2.265 //x2=1.23 //y2=2.265
r498 (  34 156 ) resistor r=152 //w=0.17 //l=0.17 //layer=licon //count=1 \
 //x=30.09 //y=2.26 //x2=30.09 //y2=2.26
r499 (  34 58 ) resistor r=3.9234 //w=0.284 //l=0.195 //layer=li \
 //thickness=0.1 //x=30.09 //y=2.29 //x2=30.09 //y2=2.485
r500 (  33 147 ) resistor r=152 //w=0.17 //l=0.17 //layer=licon //count=1 \
 //x=3.82 //y=2.265 //x2=3.82 //y2=2.265
r501 (  33 48 ) resistor r=3.85819 //w=0.281 //l=0.193 //layer=li \
 //thickness=0.1 //x=3.82 //y=2.292 //x2=3.82 //y2=2.485
r502 (  32 59 ) resistor r=6.50267 //w=0.187 //l=0.095 //layer=li \
 //thickness=0.1 //x=30.09 //y=4.62 //x2=30.09 //y2=4.715
r503 (  31 32 ) resistor r=25.3262 //w=0.187 //l=0.37 //layer=li \
 //thickness=0.1 //x=30.09 //y=4.25 //x2=30.09 //y2=4.62
r504 (  30 31 ) resistor r=25.3262 //w=0.187 //l=0.37 //layer=li \
 //thickness=0.1 //x=30.09 //y=3.88 //x2=30.09 //y2=4.25
r505 (  29 30 ) resistor r=25.3262 //w=0.187 //l=0.37 //layer=li \
 //thickness=0.1 //x=30.09 //y=3.51 //x2=30.09 //y2=3.88
r506 (  28 29 ) resistor r=50.6524 //w=0.187 //l=0.74 //layer=li \
 //thickness=0.1 //x=30.09 //y=2.77 //x2=30.09 //y2=3.51
r507 (  28 58 ) resistor r=19.508 //w=0.187 //l=0.285 //layer=li \
 //thickness=0.1 //x=30.09 //y=2.77 //x2=30.09 //y2=2.485
r508 (  27 56 ) resistor r=17.7968 //w=0.187 //l=0.26 //layer=li \
 //thickness=0.1 //x=3.82 //y=4.62 //x2=3.82 //y2=4.88
r509 (  26 27 ) resistor r=25.3262 //w=0.187 //l=0.37 //layer=li \
 //thickness=0.1 //x=3.82 //y=4.25 //x2=3.82 //y2=4.62
r510 (  25 26 ) resistor r=25.3262 //w=0.187 //l=0.37 //layer=li \
 //thickness=0.1 //x=3.82 //y=3.88 //x2=3.82 //y2=4.25
r511 (  24 25 ) resistor r=25.3262 //w=0.187 //l=0.37 //layer=li \
 //thickness=0.1 //x=3.82 //y=3.51 //x2=3.82 //y2=3.88
r512 (  23 24 ) resistor r=25.3262 //w=0.187 //l=0.37 //layer=li \
 //thickness=0.1 //x=3.82 //y=3.14 //x2=3.82 //y2=3.51
r513 (  23 48 ) resistor r=44.8342 //w=0.187 //l=0.655 //layer=li \
 //thickness=0.1 //x=3.82 //y=3.14 //x2=3.82 //y2=2.485
r514 (  22 46 ) resistor r=17.7968 //w=0.187 //l=0.26 //layer=li \
 //thickness=0.1 //x=1.23 //y=4.62 //x2=1.23 //y2=4.88
r515 (  21 22 ) resistor r=25.3262 //w=0.187 //l=0.37 //layer=li \
 //thickness=0.1 //x=1.23 //y=4.25 //x2=1.23 //y2=4.62
r516 (  20 21 ) resistor r=25.3262 //w=0.187 //l=0.37 //layer=li \
 //thickness=0.1 //x=1.23 //y=3.88 //x2=1.23 //y2=4.25
r517 (  19 20 ) resistor r=25.3262 //w=0.187 //l=0.37 //layer=li \
 //thickness=0.1 //x=1.23 //y=3.51 //x2=1.23 //y2=3.88
r518 (  18 19 ) resistor r=25.3262 //w=0.187 //l=0.37 //layer=li \
 //thickness=0.1 //x=1.23 //y=3.14 //x2=1.23 //y2=3.51
r519 (  17 18 ) resistor r=25.3262 //w=0.187 //l=0.37 //layer=li \
 //thickness=0.1 //x=1.23 //y=2.77 //x2=1.23 //y2=3.14
r520 (  17 36 ) resistor r=34.5668 //w=0.187 //l=0.505 //layer=li \
 //thickness=0.1 //x=1.23 //y=2.77 //x2=1.23 //y2=2.265
r521 (  16 34 ) resistor r=9.3 //w=0.17 //l=0.17 //layer=mcon //count=1 \
 //x=30.09 //y=2.4 //x2=30.09 //y2=2.4
r522 (  14 26 ) resistor r=9.3 //w=0.17 //l=0.17 //layer=mcon //count=1 \
 //x=3.82 //y=4.25 //x2=3.82 //y2=4.25
r523 (  12 33 ) resistor r=9.3 //w=0.17 //l=0.17 //layer=mcon //count=1 \
 //x=3.82 //y=2.4 //x2=3.82 //y2=2.4
r524 (  10 21 ) resistor r=9.3 //w=0.17 //l=0.17 //layer=mcon //count=1 \
 //x=1.23 //y=4.25 //x2=1.23 //y2=4.25
r525 (  8 16 ) resistor r=0.0717383 //w=0.224 //l=0.115 //layer=m1 \
 //thickness=0.36 //x=30.09 //y=2.285 //x2=30.09 //y2=2.4
r526 (  7 8 ) resistor r=0.162214 //w=0.131 //l=0.17 //layer=m1 \
 //thickness=0.36 //x=30.09 //y=2.115 //x2=30.09 //y2=2.285
r527 (  5 7 ) resistor r=0.0698411 //w=0.17 //l=0.120208 //layer=m1 \
 //thickness=0.36 //x=30.005 //y=2.03 //x2=30.09 //y2=2.115
r528 (  5 6 ) resistor r=24.9046 //w=0.131 //l=26.1 //layer=m1 \
 //thickness=0.36 //x=30.005 //y=2.03 //x2=3.905 //y2=2.03
r529 (  4 12 ) resistor r=0.0717383 //w=0.224 //l=0.115 //layer=m1 \
 //thickness=0.36 //x=3.82 //y=2.285 //x2=3.82 //y2=2.4
r530 (  3 6 ) resistor r=0.0698411 //w=0.17 //l=0.120208 //layer=m1 \
 //thickness=0.36 //x=3.82 //y=2.115 //x2=3.905 //y2=2.03
r531 (  3 4 ) resistor r=0.162214 //w=0.131 //l=0.17 //layer=m1 \
 //thickness=0.36 //x=3.82 //y=2.115 //x2=3.82 //y2=2.285
r532 (  2 10 ) resistor r=0.0717383 //w=0.224 //l=0.115 //layer=m1 \
 //thickness=0.36 //x=1.345 //y=4.25 //x2=1.23 //y2=4.25
r533 (  1 14 ) resistor r=0.0717383 //w=0.224 //l=0.115 //layer=m1 \
 //thickness=0.36 //x=3.705 //y=4.25 //x2=3.82 //y2=4.25
r534 (  1 2 ) resistor r=2.25191 //w=0.131 //l=2.36 //layer=m1 \
 //thickness=0.36 //x=3.705 //y=4.25 //x2=1.345 //y2=4.25
ends PM_FA\%A

subckt PM_FA\%noxref_4 ( 1 2 17 18 19 20 24 26 33 34 35 36 37 38 39 43 45 51 \
 52 60 62 64 )
c161 ( 64 0 ) capacitor c=0.0288629f //x=1.46 //y=5.2
c162 ( 62 0 ) capacitor c=0.0170302f //x=1.415 //y=1.09
c163 ( 60 0 ) capacitor c=0.058481f //x=8.26 //y=4.88
c164 ( 52 0 ) capacitor c=0.0417768f //x=8.455 //y=1.435
c165 ( 51 0 ) capacitor c=0.01899f //x=8.455 //y=1.09
c166 ( 45 0 ) capacitor c=0.0124204f //x=8.3 //y=1.59
c167 ( 43 0 ) capacitor c=0.0157803f //x=8.3 //y=0.935
c168 ( 39 0 ) capacitor c=0.0889632f //x=7.925 //y=2.1
c169 ( 38 0 ) capacitor c=0.0194674f //x=7.925 //y=1.745
c170 ( 37 0 ) capacitor c=0.0168481f //x=7.925 //y=1.435
c171 ( 36 0 ) capacitor c=0.0173364f //x=7.925 //y=1.09
c172 ( 35 0 ) capacitor c=0.153255f //x=8.37 //y=6.2
c173 ( 34 0 ) capacitor c=0.110227f //x=7.93 //y=6.2
c174 ( 26 0 ) capacitor c=0.0735823f //x=8.26 //y=2.265
c175 ( 24 0 ) capacitor c=0.0865771f //x=1.97 //y=2.77
c176 ( 20 0 ) capacitor c=0.00417404f //x=1.69 //y=4.76
c177 ( 19 0 ) capacitor c=0.0118896f //x=1.885 //y=4.76
c178 ( 18 0 ) capacitor c=0.00621372f //x=1.685 //y=2.26
c179 ( 17 0 ) capacitor c=0.0132255f //x=1.885 //y=2.26
c180 ( 2 0 ) capacitor c=0.0163395f //x=2.085 //y=2.77
c181 ( 1 0 ) capacitor c=0.155274f //x=8.145 //y=2.77
r182 (  60 61 ) resistor r=22.7554 //w=0.233 //l=0.11 //layer=ply \
 //thickness=0.18 //x=8.26 //y=4.88 //x2=8.37 //y2=4.88
r183 (  52 58 ) resistor r=45.1352 //w=0.168 //l=0.173853 //layer=ply \
 //thickness=0.18 //x=8.455 //y=1.435 //x2=8.415 //y2=1.59
r184 (  51 57 ) resistor r=45.1352 //w=0.168 //l=0.173853 //layer=ply \
 //thickness=0.18 //x=8.455 //y=1.09 //x2=8.415 //y2=0.935
r185 (  51 52 ) resistor r=176.904 //w=0.094 //l=0.345 //layer=ply \
 //thickness=0.18 //x=8.455 //y=1.09 //x2=8.455 //y2=1.435
r186 (  48 61 ) resistor r=13.0941 //w=0.233 //l=0.165 //layer=ply \
 //thickness=0.18 //x=8.37 //y=5.045 //x2=8.37 //y2=4.88
r187 (  46 54 ) resistor r=10.701 //w=0.21 //l=0.115 //layer=ply \
 //thickness=0.18 //x=8.08 //y=1.59 //x2=7.965 //y2=1.59
r188 (  45 58 ) resistor r=5.52526 //w=0.168 //l=0.115 //layer=ply \
 //thickness=0.18 //x=8.3 //y=1.59 //x2=8.415 //y2=1.59
r189 (  44 53 ) resistor r=5.52526 //w=0.168 //l=0.115 //layer=ply \
 //thickness=0.18 //x=8.08 //y=0.935 //x2=7.965 //y2=0.935
r190 (  43 57 ) resistor r=5.52526 //w=0.168 //l=0.115 //layer=ply \
 //thickness=0.18 //x=8.3 //y=0.935 //x2=8.415 //y2=0.935
r191 (  43 44 ) resistor r=112.809 //w=0.094 //l=0.22 //layer=ply \
 //thickness=0.18 //x=8.3 //y=0.935 //x2=8.08 //y2=0.935
r192 (  40 60 ) resistor r=68.2661 //w=0.233 //l=0.404166 //layer=ply \
 //thickness=0.18 //x=7.93 //y=5.045 //x2=8.26 //y2=4.88
r193 (  39 56 ) resistor r=67.2792 //w=0.24 //l=0.438891 //layer=ply \
 //thickness=0.18 //x=7.925 //y=2.1 //x2=8.26 //y2=2.34
r194 (  38 54 ) resistor r=39.5823 //w=0.21 //l=0.173853 //layer=ply \
 //thickness=0.18 //x=7.925 //y=1.745 //x2=7.965 //y2=1.59
r195 (  38 39 ) resistor r=182.032 //w=0.094 //l=0.355 //layer=ply \
 //thickness=0.18 //x=7.925 //y=1.745 //x2=7.925 //y2=2.1
r196 (  37 54 ) resistor r=39.5823 //w=0.21 //l=0.173853 //layer=ply \
 //thickness=0.18 //x=7.925 //y=1.435 //x2=7.965 //y2=1.59
r197 (  36 53 ) resistor r=45.1352 //w=0.168 //l=0.173853 //layer=ply \
 //thickness=0.18 //x=7.925 //y=1.09 //x2=7.965 //y2=0.935
r198 (  36 37 ) resistor r=176.904 //w=0.094 //l=0.345 //layer=ply \
 //thickness=0.18 //x=7.925 //y=1.09 //x2=7.925 //y2=1.435
r199 (  35 48 ) resistor r=592.245 //w=0.094 //l=1.155 //layer=ply \
 //thickness=0.18 //x=8.37 //y=6.2 //x2=8.37 //y2=5.045
r200 (  34 40 ) resistor r=592.245 //w=0.094 //l=1.155 //layer=ply \
 //thickness=0.18 //x=7.93 //y=6.2 //x2=7.93 //y2=5.045
r201 (  33 45 ) resistor r=56.4043 //w=0.094 //l=0.11 //layer=ply \
 //thickness=0.18 //x=8.19 //y=1.59 //x2=8.3 //y2=1.59
r202 (  33 46 ) resistor r=56.4043 //w=0.094 //l=0.11 //layer=ply \
 //thickness=0.18 //x=8.19 //y=1.59 //x2=8.08 //y2=1.59
r203 (  31 60 ) resistor r=152 //w=0.17 //l=0.17 //layer=licon //count=1 \
 //x=8.26 //y=4.88 //x2=8.26 //y2=4.88
r204 (  29 31 ) resistor r=144.428 //w=0.187 //l=2.11 //layer=li \
 //thickness=0.1 //x=8.26 //y=2.77 //x2=8.26 //y2=4.88
r205 (  26 56 ) resistor r=152 //w=0.17 //l=0.17 //layer=licon //count=1 \
 //x=8.26 //y=2.265 //x2=8.26 //y2=2.265
r206 (  26 29 ) resistor r=34.5668 //w=0.187 //l=0.505 //layer=li \
 //thickness=0.1 //x=8.26 //y=2.265 //x2=8.26 //y2=2.77
r207 (  22 24 ) resistor r=130.396 //w=0.187 //l=1.905 //layer=li \
 //thickness=0.1 //x=1.97 //y=4.675 //x2=1.97 //y2=2.77
r208 (  21 24 ) resistor r=29.0909 //w=0.187 //l=0.425 //layer=li \
 //thickness=0.1 //x=1.97 //y=2.345 //x2=1.97 //y2=2.77
r209 (  19 22 ) resistor r=7.15173 //w=0.17 //l=0.120208 //layer=li \
 //thickness=0.1 //x=1.885 //y=4.76 //x2=1.97 //y2=4.675
r210 (  19 20 ) resistor r=13.3476 //w=0.187 //l=0.195 //layer=li \
 //thickness=0.1 //x=1.885 //y=4.76 //x2=1.69 //y2=4.76
r211 (  17 21 ) resistor r=7.15173 //w=0.17 //l=0.120208 //layer=li \
 //thickness=0.1 //x=1.885 //y=2.26 //x2=1.97 //y2=2.345
r212 (  17 18 ) resistor r=13.6898 //w=0.187 //l=0.2 //layer=li \
 //thickness=0.1 //x=1.885 //y=2.26 //x2=1.685 //y2=2.26
r213 (  11 20 ) resistor r=7.15173 //w=0.17 //l=0.120208 //layer=li \
 //thickness=0.1 //x=1.605 //y=4.845 //x2=1.69 //y2=4.76
r214 (  11 64 ) resistor r=72.5562 //w=0.187 //l=1.06 //layer=li \
 //thickness=0.1 //x=1.605 //y=4.845 //x2=1.605 //y2=5.905
r215 (  7 18 ) resistor r=7.15173 //w=0.17 //l=0.120208 //layer=li \
 //thickness=0.1 //x=1.6 //y=2.175 //x2=1.685 //y2=2.26
r216 (  7 62 ) resistor r=67.7647 //w=0.187 //l=0.99 //layer=li \
 //thickness=0.1 //x=1.6 //y=2.175 //x2=1.6 //y2=1.185
r217 (  6 29 ) resistor r=9.3 //w=0.17 //l=0.17 //layer=mcon //count=1 \
 //x=8.26 //y=2.77 //x2=8.26 //y2=2.77
r218 (  4 24 ) resistor r=9.3 //w=0.17 //l=0.17 //layer=mcon //count=1 \
 //x=1.97 //y=2.77 //x2=1.97 //y2=2.77
r219 (  2 4 ) resistor r=0.0717383 //w=0.224 //l=0.115 //layer=m1 \
 //thickness=0.36 //x=2.085 //y=2.77 //x2=1.97 //y2=2.77
r220 (  1 6 ) resistor r=0.0717383 //w=0.224 //l=0.115 //layer=m1 \
 //thickness=0.36 //x=8.145 //y=2.77 //x2=8.26 //y2=2.77
r221 (  1 2 ) resistor r=5.78244 //w=0.131 //l=6.06 //layer=m1 \
 //thickness=0.36 //x=8.145 //y=2.77 //x2=2.085 //y2=2.77
ends PM_FA\%noxref_4

subckt PM_FA\%noxref_5 ( 1 2 3 4 14 20 28 31 32 33 34 45 46 47 54 55 56 57 58 \
 60 63 64 66 74 76 )
c175 ( 76 0 ) capacitor c=0.0284262f //x=10.33 //y=5.2
c176 ( 74 0 ) capacitor c=0.0170943f //x=10.285 //y=1.09
c177 ( 66 0 ) capacitor c=0.0636249f //x=4.93 //y=4.88
c178 ( 64 0 ) capacitor c=0.0318948f //x=7.485 //y=1.395
c179 ( 63 0 ) capacitor c=0.0186029f //x=7.485 //y=1.05
c180 ( 60 0 ) capacitor c=0.0141798f //x=7.33 //y=1.55
c181 ( 58 0 ) capacitor c=0.0149852f //x=7.33 //y=0.895
c182 ( 57 0 ) capacitor c=0.0827875f //x=6.955 //y=2.1
c183 ( 56 0 ) capacitor c=0.0229212f //x=6.955 //y=1.705
c184 ( 55 0 ) capacitor c=0.0234352f //x=6.955 //y=1.395
c185 ( 54 0 ) capacitor c=0.0197989f //x=6.955 //y=1.05
c186 ( 47 0 ) capacitor c=0.153255f //x=5.04 //y=6.2
c187 ( 46 0 ) capacitor c=0.110227f //x=4.6 //y=6.2
c188 ( 34 0 ) capacitor c=0.00670488f //x=10.195 //y=4.76
c189 ( 33 0 ) capacitor c=0.0136086f //x=10.39 //y=4.76
c190 ( 32 0 ) capacitor c=0.00507261f //x=10.195 //y=2.26
c191 ( 31 0 ) capacitor c=0.0124351f //x=10.395 //y=2.26
c192 ( 28 0 ) capacitor c=0.0754875f //x=10.11 //y=3.51
c193 ( 20 0 ) capacitor c=0.0548742f //x=7.15 //y=2.265
c194 ( 14 0 ) capacitor c=0.024985f //x=4.93 //y=4.25
c195 ( 4 0 ) capacitor c=0.0126928f //x=7.265 //y=3.51
c196 ( 3 0 ) capacitor c=0.0521532f //x=9.995 //y=3.51
c197 ( 2 0 ) capacitor c=0.01091f //x=5.045 //y=4.25
c198 ( 1 0 ) capacitor c=0.10314f //x=9.995 //y=4.25
r199 (  66 67 ) resistor r=22.7554 //w=0.233 //l=0.11 //layer=ply \
 //thickness=0.18 //x=4.93 //y=4.88 //x2=5.04 //y2=4.88
r200 (  64 73 ) resistor r=45.1352 //w=0.168 //l=0.173853 //layer=ply \
 //thickness=0.18 //x=7.485 //y=1.395 //x2=7.445 //y2=1.55
r201 (  63 72 ) resistor r=45.1352 //w=0.168 //l=0.173853 //layer=ply \
 //thickness=0.18 //x=7.485 //y=1.05 //x2=7.445 //y2=0.895
r202 (  63 64 ) resistor r=176.904 //w=0.094 //l=0.345 //layer=ply \
 //thickness=0.18 //x=7.485 //y=1.05 //x2=7.485 //y2=1.395
r203 (  61 71 ) resistor r=10.701 //w=0.21 //l=0.115 //layer=ply \
 //thickness=0.18 //x=7.11 //y=1.55 //x2=6.995 //y2=1.55
r204 (  60 73 ) resistor r=5.52526 //w=0.168 //l=0.115 //layer=ply \
 //thickness=0.18 //x=7.33 //y=1.55 //x2=7.445 //y2=1.55
r205 (  59 70 ) resistor r=5.52526 //w=0.168 //l=0.115 //layer=ply \
 //thickness=0.18 //x=7.11 //y=0.895 //x2=6.995 //y2=0.895
r206 (  58 72 ) resistor r=5.52526 //w=0.168 //l=0.115 //layer=ply \
 //thickness=0.18 //x=7.33 //y=0.895 //x2=7.445 //y2=0.895
r207 (  58 59 ) resistor r=112.809 //w=0.094 //l=0.22 //layer=ply \
 //thickness=0.18 //x=7.33 //y=0.895 //x2=7.11 //y2=0.895
r208 (  57 69 ) resistor r=34.8111 //w=0.27 //l=0.264953 //layer=ply \
 //thickness=0.18 //x=6.955 //y=2.1 //x2=7.15 //y2=2.265
r209 (  56 71 ) resistor r=39.5823 //w=0.21 //l=0.173853 //layer=ply \
 //thickness=0.18 //x=6.955 //y=1.705 //x2=6.995 //y2=1.55
r210 (  56 57 ) resistor r=202.543 //w=0.094 //l=0.395 //layer=ply \
 //thickness=0.18 //x=6.955 //y=1.705 //x2=6.955 //y2=2.1
r211 (  55 71 ) resistor r=39.5823 //w=0.21 //l=0.173853 //layer=ply \
 //thickness=0.18 //x=6.955 //y=1.395 //x2=6.995 //y2=1.55
r212 (  54 70 ) resistor r=45.1352 //w=0.168 //l=0.173853 //layer=ply \
 //thickness=0.18 //x=6.955 //y=1.05 //x2=6.995 //y2=0.895
r213 (  54 55 ) resistor r=176.904 //w=0.094 //l=0.345 //layer=ply \
 //thickness=0.18 //x=6.955 //y=1.05 //x2=6.955 //y2=1.395
r214 (  51 67 ) resistor r=13.0941 //w=0.233 //l=0.165 //layer=ply \
 //thickness=0.18 //x=5.04 //y=5.045 //x2=5.04 //y2=4.88
r215 (  48 66 ) resistor r=68.2661 //w=0.233 //l=0.404166 //layer=ply \
 //thickness=0.18 //x=4.6 //y=5.045 //x2=4.93 //y2=4.88
r216 (  47 51 ) resistor r=592.245 //w=0.094 //l=1.155 //layer=ply \
 //thickness=0.18 //x=5.04 //y=6.2 //x2=5.04 //y2=5.045
r217 (  46 48 ) resistor r=592.245 //w=0.094 //l=1.155 //layer=ply \
 //thickness=0.18 //x=4.6 //y=6.2 //x2=4.6 //y2=5.045
r218 (  45 60 ) resistor r=56.4043 //w=0.094 //l=0.11 //layer=ply \
 //thickness=0.18 //x=7.22 //y=1.55 //x2=7.33 //y2=1.55
r219 (  45 61 ) resistor r=56.4043 //w=0.094 //l=0.11 //layer=ply \
 //thickness=0.18 //x=7.22 //y=1.55 //x2=7.11 //y2=1.55
r220 (  41 74 ) resistor r=67.7647 //w=0.187 //l=0.99 //layer=li \
 //thickness=0.1 //x=10.48 //y=2.175 //x2=10.48 //y2=1.185
r221 (  35 76 ) resistor r=72.5562 //w=0.187 //l=1.06 //layer=li \
 //thickness=0.1 //x=10.475 //y=4.845 //x2=10.475 //y2=5.905
r222 (  33 35 ) resistor r=7.15173 //w=0.17 //l=0.120208 //layer=li \
 //thickness=0.1 //x=10.39 //y=4.76 //x2=10.475 //y2=4.845
r223 (  33 34 ) resistor r=13.3476 //w=0.187 //l=0.195 //layer=li \
 //thickness=0.1 //x=10.39 //y=4.76 //x2=10.195 //y2=4.76
r224 (  31 41 ) resistor r=7.15173 //w=0.17 //l=0.120208 //layer=li \
 //thickness=0.1 //x=10.395 //y=2.26 //x2=10.48 //y2=2.175
r225 (  31 32 ) resistor r=13.6898 //w=0.187 //l=0.2 //layer=li \
 //thickness=0.1 //x=10.395 //y=2.26 //x2=10.195 //y2=2.26
r226 (  28 30 ) resistor r=50.6524 //w=0.187 //l=0.74 //layer=li \
 //thickness=0.1 //x=10.11 //y=3.51 //x2=10.11 //y2=4.25
r227 (  26 34 ) resistor r=7.15173 //w=0.17 //l=0.120208 //layer=li \
 //thickness=0.1 //x=10.11 //y=4.675 //x2=10.195 //y2=4.76
r228 (  26 30 ) resistor r=29.0909 //w=0.187 //l=0.425 //layer=li \
 //thickness=0.1 //x=10.11 //y=4.675 //x2=10.11 //y2=4.25
r229 (  25 32 ) resistor r=7.15173 //w=0.17 //l=0.120208 //layer=li \
 //thickness=0.1 //x=10.11 //y=2.345 //x2=10.195 //y2=2.26
r230 (  25 28 ) resistor r=79.7433 //w=0.187 //l=1.165 //layer=li \
 //thickness=0.1 //x=10.11 //y=2.345 //x2=10.11 //y2=3.51
r231 (  20 69 ) resistor r=152 //w=0.17 //l=0.17 //layer=licon //count=1 \
 //x=7.15 //y=2.265 //x2=7.15 //y2=2.265
r232 (  20 23 ) resistor r=85.2193 //w=0.187 //l=1.245 //layer=li \
 //thickness=0.1 //x=7.15 //y=2.265 //x2=7.15 //y2=3.51
r233 (  17 66 ) resistor r=152 //w=0.17 //l=0.17 //layer=licon //count=1 \
 //x=4.93 //y=4.88 //x2=4.93 //y2=4.88
r234 (  14 17 ) resistor r=43.123 //w=0.187 //l=0.63 //layer=li \
 //thickness=0.1 //x=4.93 //y=4.25 //x2=4.93 //y2=4.88
r235 (  12 30 ) resistor r=9.3 //w=0.17 //l=0.17 //layer=mcon //count=1 \
 //x=10.11 //y=4.25 //x2=10.11 //y2=4.25
r236 (  10 28 ) resistor r=9.3 //w=0.17 //l=0.17 //layer=mcon //count=1 \
 //x=10.11 //y=3.51 //x2=10.11 //y2=3.51
r237 (  8 23 ) resistor r=9.3 //w=0.17 //l=0.17 //layer=mcon //count=1 \
 //x=7.15 //y=3.51 //x2=7.15 //y2=3.51
r238 (  6 14 ) resistor r=9.3 //w=0.17 //l=0.17 //layer=mcon //count=1 \
 //x=4.93 //y=4.25 //x2=4.93 //y2=4.25
r239 (  4 8 ) resistor r=0.0717383 //w=0.224 //l=0.115 //layer=m1 \
 //thickness=0.36 //x=7.265 //y=3.51 //x2=7.15 //y2=3.51
r240 (  3 10 ) resistor r=0.0717383 //w=0.224 //l=0.115 //layer=m1 \
 //thickness=0.36 //x=9.995 //y=3.51 //x2=10.11 //y2=3.51
r241 (  3 4 ) resistor r=2.60496 //w=0.131 //l=2.73 //layer=m1 \
 //thickness=0.36 //x=9.995 //y=3.51 //x2=7.265 //y2=3.51
r242 (  2 6 ) resistor r=0.0717383 //w=0.224 //l=0.115 //layer=m1 \
 //thickness=0.36 //x=5.045 //y=4.25 //x2=4.93 //y2=4.25
r243 (  1 12 ) resistor r=0.0717383 //w=0.224 //l=0.115 //layer=m1 \
 //thickness=0.36 //x=9.995 //y=4.25 //x2=10.11 //y2=4.25
r244 (  1 2 ) resistor r=4.72328 //w=0.131 //l=4.95 //layer=m1 \
 //thickness=0.36 //x=9.995 //y=4.25 //x2=5.045 //y2=4.25
ends PM_FA\%noxref_5

subckt PM_FA\%B ( 1 2 3 4 5 6 18 20 21 22 23 24 25 26 27 28 29 30 31 32 33 34 \
 36 49 65 75 76 77 78 79 80 81 82 83 84 85 86 87 88 90 93 94 101 102 106 107 \
 108 110 113 116 117 118 119 120 121 122 123 127 129 132 133 145 150 161 )
c381 ( 161 0 ) capacitor c=0.0627475f //x=29.35 //y=4.88
c382 ( 150 0 ) capacitor c=0.0513056f //x=10.74 //y=2.265
c383 ( 145 0 ) capacitor c=0.0606915f //x=7.15 //y=4.88
c384 ( 133 0 ) capacitor c=0.0318948f //x=29.685 //y=1.39
c385 ( 132 0 ) capacitor c=0.0187384f //x=29.685 //y=1.045
c386 ( 129 0 ) capacitor c=0.0141798f //x=29.53 //y=1.545
c387 ( 127 0 ) capacitor c=0.0149844f //x=29.53 //y=0.89
c388 ( 123 0 ) capacitor c=0.0811005f //x=29.155 //y=2.095
c389 ( 122 0 ) capacitor c=0.0229212f //x=29.155 //y=1.7
c390 ( 121 0 ) capacitor c=0.0234352f //x=29.155 //y=1.39
c391 ( 120 0 ) capacitor c=0.0199343f //x=29.155 //y=1.045
c392 ( 119 0 ) capacitor c=0.0293214f //x=10.74 //y=2.1
c393 ( 118 0 ) capacitor c=0.0250171f //x=10.74 //y=1.745
c394 ( 117 0 ) capacitor c=0.0234316f //x=10.74 //y=1.435
c395 ( 116 0 ) capacitor c=0.0199789f //x=10.74 //y=1.09
c396 ( 113 0 ) capacitor c=0.0488408f //x=10.695 //y=5.045
c397 ( 110 0 ) capacitor c=0.0148979f //x=10.585 //y=1.59
c398 ( 108 0 ) capacitor c=0.0157804f //x=10.585 //y=0.935
c399 ( 107 0 ) capacitor c=0.0129718f //x=10.33 //y=4.97
c400 ( 106 0 ) capacitor c=0.0172687f //x=10.62 //y=4.97
c401 ( 102 0 ) capacitor c=0.0435512f //x=10.21 //y=1.435
c402 ( 101 0 ) capacitor c=0.0199346f //x=10.21 //y=1.09
c403 ( 94 0 ) capacitor c=0.0417768f //x=5.125 //y=1.435
c404 ( 93 0 ) capacitor c=0.01899f //x=5.125 //y=1.09
c405 ( 90 0 ) capacitor c=0.0124204f //x=4.97 //y=1.59
c406 ( 88 0 ) capacitor c=0.0157803f //x=4.97 //y=0.935
c407 ( 87 0 ) capacitor c=0.0889343f //x=4.595 //y=2.1
c408 ( 86 0 ) capacitor c=0.0194674f //x=4.595 //y=1.745
c409 ( 85 0 ) capacitor c=0.0168481f //x=4.595 //y=1.435
c410 ( 84 0 ) capacitor c=0.0173364f //x=4.595 //y=1.09
c411 ( 83 0 ) capacitor c=0.110274f //x=29.69 //y=6.2
c412 ( 82 0 ) capacitor c=0.154186f //x=29.25 //y=6.2
c413 ( 81 0 ) capacitor c=0.1536f //x=10.695 //y=6.2
c414 ( 80 0 ) capacitor c=0.154218f //x=10.255 //y=6.2
c415 ( 79 0 ) capacitor c=0.110797f //x=7.49 //y=6.2
c416 ( 78 0 ) capacitor c=0.154322f //x=7.05 //y=6.2
c417 ( 65 0 ) capacitor c=0.0938005f //x=29.35 //y=2.26
c418 ( 49 0 ) capacitor c=0.0850507f //x=10.85 //y=2.265
c419 ( 36 0 ) capacitor c=0.029964f //x=4.93 //y=2.265
c420 ( 34 0 ) capacitor c=0.00995653f //x=29.35 //y=4.99
c421 ( 22 0 ) capacitor c=0.0150587f //x=7.15 //y=4.62
c422 ( 18 0 ) capacitor c=0.0148476f //x=29.35 //y=4.81
c423 ( 6 0 ) capacitor c=0.0111878f //x=10.965 //y=4.99
c424 ( 5 0 ) capacitor c=0.430557f //x=29.235 //y=4.99
c425 ( 4 0 ) capacitor c=0.015004f //x=7.265 //y=4.62
c426 ( 3 0 ) capacitor c=0.0883217f //x=10.735 //y=4.62
c427 ( 2 0 ) capacitor c=0.0154186f //x=5.045 //y=3.14
c428 ( 1 0 ) capacitor c=0.113504f //x=10.735 //y=3.14
r429 (  159 161 ) resistor r=20.6867 //w=0.233 //l=0.1 //layer=ply \
 //thickness=0.18 //x=29.25 //y=4.88 //x2=29.35 //y2=4.88
r430 (  150 152 ) resistor r=17.5563 //w=0.302 //l=0.11 //layer=ply \
 //thickness=0.18 //x=10.74 //y=2.265 //x2=10.85 //y2=2.265
r431 (  143 145 ) resistor r=20.6867 //w=0.233 //l=0.1 //layer=ply \
 //thickness=0.18 //x=7.05 //y=4.88 //x2=7.15 //y2=4.88
r432 (  134 161 ) resistor r=70.3348 //w=0.233 //l=0.414367 //layer=ply \
 //thickness=0.18 //x=29.69 //y=5.045 //x2=29.35 //y2=4.88
r433 (  133 163 ) resistor r=45.1352 //w=0.168 //l=0.173853 //layer=ply \
 //thickness=0.18 //x=29.685 //y=1.39 //x2=29.645 //y2=1.545
r434 (  132 162 ) resistor r=45.1352 //w=0.168 //l=0.173853 //layer=ply \
 //thickness=0.18 //x=29.685 //y=1.045 //x2=29.645 //y2=0.89
r435 (  132 133 ) resistor r=176.904 //w=0.094 //l=0.345 //layer=ply \
 //thickness=0.18 //x=29.685 //y=1.045 //x2=29.685 //y2=1.39
r436 (  130 158 ) resistor r=10.701 //w=0.21 //l=0.115 //layer=ply \
 //thickness=0.18 //x=29.31 //y=1.545 //x2=29.195 //y2=1.545
r437 (  129 163 ) resistor r=5.52526 //w=0.168 //l=0.115 //layer=ply \
 //thickness=0.18 //x=29.53 //y=1.545 //x2=29.645 //y2=1.545
r438 (  128 157 ) resistor r=5.52526 //w=0.168 //l=0.115 //layer=ply \
 //thickness=0.18 //x=29.31 //y=0.89 //x2=29.195 //y2=0.89
r439 (  127 162 ) resistor r=5.52526 //w=0.168 //l=0.115 //layer=ply \
 //thickness=0.18 //x=29.53 //y=0.89 //x2=29.645 //y2=0.89
r440 (  127 128 ) resistor r=112.809 //w=0.094 //l=0.22 //layer=ply \
 //thickness=0.18 //x=29.53 //y=0.89 //x2=29.31 //y2=0.89
r441 (  124 159 ) resistor r=13.0941 //w=0.233 //l=0.165 //layer=ply \
 //thickness=0.18 //x=29.25 //y=5.045 //x2=29.25 //y2=4.88
r442 (  123 156 ) resistor r=34.8111 //w=0.27 //l=0.264953 //layer=ply \
 //thickness=0.18 //x=29.155 //y=2.095 //x2=29.35 //y2=2.26
r443 (  122 158 ) resistor r=39.5823 //w=0.21 //l=0.173853 //layer=ply \
 //thickness=0.18 //x=29.155 //y=1.7 //x2=29.195 //y2=1.545
r444 (  122 123 ) resistor r=202.543 //w=0.094 //l=0.395 //layer=ply \
 //thickness=0.18 //x=29.155 //y=1.7 //x2=29.155 //y2=2.095
r445 (  121 158 ) resistor r=39.5823 //w=0.21 //l=0.173853 //layer=ply \
 //thickness=0.18 //x=29.155 //y=1.39 //x2=29.195 //y2=1.545
r446 (  120 157 ) resistor r=45.1352 //w=0.168 //l=0.173853 //layer=ply \
 //thickness=0.18 //x=29.155 //y=1.045 //x2=29.195 //y2=0.89
r447 (  120 121 ) resistor r=176.904 //w=0.094 //l=0.345 //layer=ply \
 //thickness=0.18 //x=29.155 //y=1.045 //x2=29.155 //y2=1.39
r448 (  119 150 ) resistor r=19.1248 //w=0.302 //l=0.165 //layer=ply \
 //thickness=0.18 //x=10.74 //y=2.1 //x2=10.74 //y2=2.265
r449 (  118 149 ) resistor r=39.5823 //w=0.21 //l=0.173853 //layer=ply \
 //thickness=0.18 //x=10.74 //y=1.745 //x2=10.7 //y2=1.59
r450 (  118 119 ) resistor r=182.032 //w=0.094 //l=0.355 //layer=ply \
 //thickness=0.18 //x=10.74 //y=1.745 //x2=10.74 //y2=2.1
r451 (  117 149 ) resistor r=39.5823 //w=0.21 //l=0.173853 //layer=ply \
 //thickness=0.18 //x=10.74 //y=1.435 //x2=10.7 //y2=1.59
r452 (  116 148 ) resistor r=45.1352 //w=0.168 //l=0.173853 //layer=ply \
 //thickness=0.18 //x=10.74 //y=1.09 //x2=10.7 //y2=0.935
r453 (  116 117 ) resistor r=176.904 //w=0.094 //l=0.345 //layer=ply \
 //thickness=0.18 //x=10.74 //y=1.09 //x2=10.74 //y2=1.435
r454 (  113 154 ) resistor r=26.3063 //w=0.284 //l=0.229783 //layer=ply \
 //thickness=0.18 //x=10.695 //y=5.045 //x2=10.85 //y2=4.88
r455 (  111 147 ) resistor r=5.52526 //w=0.168 //l=0.115 //layer=ply \
 //thickness=0.18 //x=10.365 //y=1.59 //x2=10.25 //y2=1.59
r456 (  110 149 ) resistor r=10.701 //w=0.21 //l=0.115 //layer=ply \
 //thickness=0.18 //x=10.585 //y=1.59 //x2=10.7 //y2=1.59
r457 (  109 146 ) resistor r=5.52526 //w=0.168 //l=0.115 //layer=ply \
 //thickness=0.18 //x=10.365 //y=0.935 //x2=10.25 //y2=0.935
r458 (  108 148 ) resistor r=5.52526 //w=0.168 //l=0.115 //layer=ply \
 //thickness=0.18 //x=10.585 //y=0.935 //x2=10.7 //y2=0.935
r459 (  108 109 ) resistor r=112.809 //w=0.094 //l=0.22 //layer=ply \
 //thickness=0.18 //x=10.585 //y=0.935 //x2=10.365 //y2=0.935
r460 (  106 113 ) resistor r=23.403 //w=0.284 //l=0.106066 //layer=ply \
 //thickness=0.18 //x=10.62 //y=4.97 //x2=10.695 //y2=5.045
r461 (  106 107 ) resistor r=148.702 //w=0.094 //l=0.29 //layer=ply \
 //thickness=0.18 //x=10.62 //y=4.97 //x2=10.33 //y2=4.97
r462 (  103 107 ) resistor r=26.9307 //w=0.15 //l=0.106066 //layer=ply \
 //thickness=0.18 //x=10.255 //y=5.045 //x2=10.33 //y2=4.97
r463 (  102 147 ) resistor r=45.1352 //w=0.168 //l=0.173853 //layer=ply \
 //thickness=0.18 //x=10.21 //y=1.435 //x2=10.25 //y2=1.59
r464 (  101 146 ) resistor r=45.1352 //w=0.168 //l=0.173853 //layer=ply \
 //thickness=0.18 //x=10.21 //y=1.09 //x2=10.25 //y2=0.935
r465 (  101 102 ) resistor r=176.904 //w=0.094 //l=0.345 //layer=ply \
 //thickness=0.18 //x=10.21 //y=1.09 //x2=10.21 //y2=1.435
r466 (  98 145 ) resistor r=70.3348 //w=0.233 //l=0.414367 //layer=ply \
 //thickness=0.18 //x=7.49 //y=5.045 //x2=7.15 //y2=4.88
r467 (  95 143 ) resistor r=13.0941 //w=0.233 //l=0.165 //layer=ply \
 //thickness=0.18 //x=7.05 //y=5.045 //x2=7.05 //y2=4.88
r468 (  94 142 ) resistor r=45.1352 //w=0.168 //l=0.173853 //layer=ply \
 //thickness=0.18 //x=5.125 //y=1.435 //x2=5.085 //y2=1.59
r469 (  93 141 ) resistor r=45.1352 //w=0.168 //l=0.173853 //layer=ply \
 //thickness=0.18 //x=5.125 //y=1.09 //x2=5.085 //y2=0.935
r470 (  93 94 ) resistor r=176.904 //w=0.094 //l=0.345 //layer=ply \
 //thickness=0.18 //x=5.125 //y=1.09 //x2=5.125 //y2=1.435
r471 (  91 138 ) resistor r=10.701 //w=0.21 //l=0.115 //layer=ply \
 //thickness=0.18 //x=4.75 //y=1.59 //x2=4.635 //y2=1.59
r472 (  90 142 ) resistor r=5.52526 //w=0.168 //l=0.115 //layer=ply \
 //thickness=0.18 //x=4.97 //y=1.59 //x2=5.085 //y2=1.59
r473 (  89 137 ) resistor r=5.52526 //w=0.168 //l=0.115 //layer=ply \
 //thickness=0.18 //x=4.75 //y=0.935 //x2=4.635 //y2=0.935
r474 (  88 141 ) resistor r=5.52526 //w=0.168 //l=0.115 //layer=ply \
 //thickness=0.18 //x=4.97 //y=0.935 //x2=5.085 //y2=0.935
r475 (  88 89 ) resistor r=112.809 //w=0.094 //l=0.22 //layer=ply \
 //thickness=0.18 //x=4.97 //y=0.935 //x2=4.75 //y2=0.935
r476 (  87 140 ) resistor r=67.2792 //w=0.24 //l=0.438891 //layer=ply \
 //thickness=0.18 //x=4.595 //y=2.1 //x2=4.93 //y2=2.34
r477 (  86 138 ) resistor r=39.5823 //w=0.21 //l=0.173853 //layer=ply \
 //thickness=0.18 //x=4.595 //y=1.745 //x2=4.635 //y2=1.59
r478 (  86 87 ) resistor r=182.032 //w=0.094 //l=0.355 //layer=ply \
 //thickness=0.18 //x=4.595 //y=1.745 //x2=4.595 //y2=2.1
r479 (  85 138 ) resistor r=39.5823 //w=0.21 //l=0.173853 //layer=ply \
 //thickness=0.18 //x=4.595 //y=1.435 //x2=4.635 //y2=1.59
r480 (  84 137 ) resistor r=45.1352 //w=0.168 //l=0.173853 //layer=ply \
 //thickness=0.18 //x=4.595 //y=1.09 //x2=4.635 //y2=0.935
r481 (  84 85 ) resistor r=176.904 //w=0.094 //l=0.345 //layer=ply \
 //thickness=0.18 //x=4.595 //y=1.09 //x2=4.595 //y2=1.435
r482 (  83 134 ) resistor r=592.245 //w=0.094 //l=1.155 //layer=ply \
 //thickness=0.18 //x=29.69 //y=6.2 //x2=29.69 //y2=5.045
r483 (  82 124 ) resistor r=592.245 //w=0.094 //l=1.155 //layer=ply \
 //thickness=0.18 //x=29.25 //y=6.2 //x2=29.25 //y2=5.045
r484 (  81 113 ) resistor r=592.245 //w=0.094 //l=1.155 //layer=ply \
 //thickness=0.18 //x=10.695 //y=6.2 //x2=10.695 //y2=5.045
r485 (  80 103 ) resistor r=592.245 //w=0.094 //l=1.155 //layer=ply \
 //thickness=0.18 //x=10.255 //y=6.2 //x2=10.255 //y2=5.045
r486 (  79 98 ) resistor r=592.245 //w=0.094 //l=1.155 //layer=ply \
 //thickness=0.18 //x=7.49 //y=6.2 //x2=7.49 //y2=5.045
r487 (  78 95 ) resistor r=592.245 //w=0.094 //l=1.155 //layer=ply \
 //thickness=0.18 //x=7.05 //y=6.2 //x2=7.05 //y2=5.045
r488 (  77 129 ) resistor r=56.4043 //w=0.094 //l=0.11 //layer=ply \
 //thickness=0.18 //x=29.42 //y=1.545 //x2=29.53 //y2=1.545
r489 (  77 130 ) resistor r=56.4043 //w=0.094 //l=0.11 //layer=ply \
 //thickness=0.18 //x=29.42 //y=1.545 //x2=29.31 //y2=1.545
r490 (  76 110 ) resistor r=56.4043 //w=0.094 //l=0.11 //layer=ply \
 //thickness=0.18 //x=10.475 //y=1.59 //x2=10.585 //y2=1.59
r491 (  76 111 ) resistor r=56.4043 //w=0.094 //l=0.11 //layer=ply \
 //thickness=0.18 //x=10.475 //y=1.59 //x2=10.365 //y2=1.59
r492 (  75 90 ) resistor r=56.4043 //w=0.094 //l=0.11 //layer=ply \
 //thickness=0.18 //x=4.86 //y=1.59 //x2=4.97 //y2=1.59
r493 (  75 91 ) resistor r=56.4043 //w=0.094 //l=0.11 //layer=ply \
 //thickness=0.18 //x=4.86 //y=1.59 //x2=4.75 //y2=1.59
r494 (  65 156 ) resistor r=152 //w=0.17 //l=0.17 //layer=licon //count=1 \
 //x=29.35 //y=2.26 //x2=29.35 //y2=2.26
r495 (  59 154 ) resistor r=152 //w=0.17 //l=0.17 //layer=licon //count=1 \
 //x=10.85 //y=4.88 //x2=10.85 //y2=4.88
r496 (  49 152 ) resistor r=152 //w=0.17 //l=0.17 //layer=licon //count=1 \
 //x=10.85 //y=2.265 //x2=10.85 //y2=2.265
r497 (  46 145 ) resistor r=152 //w=0.17 //l=0.17 //layer=licon //count=1 \
 //x=7.15 //y=4.88 //x2=7.15 //y2=4.88
r498 (  36 140 ) resistor r=152 //w=0.17 //l=0.17 //layer=licon //count=1 \
 //x=4.93 //y=2.265 //x2=4.93 //y2=2.265
r499 (  34 161 ) resistor r=152 //w=0.17 //l=0.17 //layer=licon //count=1 \
 //x=29.35 //y=4.88 //x2=29.35 //y2=4.88
r500 (  34 63 ) resistor r=3.4525 //w=0.263 //l=0.175 //layer=li \
 //thickness=0.1 //x=29.35 //y=4.9 //x2=29.35 //y2=4.725
r501 (  33 63 ) resistor r=7.18717 //w=0.187 //l=0.105 //layer=li \
 //thickness=0.1 //x=29.35 //y=4.62 //x2=29.35 //y2=4.725
r502 (  32 33 ) resistor r=25.3262 //w=0.187 //l=0.37 //layer=li \
 //thickness=0.1 //x=29.35 //y=4.25 //x2=29.35 //y2=4.62
r503 (  31 32 ) resistor r=25.3262 //w=0.187 //l=0.37 //layer=li \
 //thickness=0.1 //x=29.35 //y=3.88 //x2=29.35 //y2=4.25
r504 (  30 31 ) resistor r=25.3262 //w=0.187 //l=0.37 //layer=li \
 //thickness=0.1 //x=29.35 //y=3.51 //x2=29.35 //y2=3.88
r505 (  29 30 ) resistor r=50.6524 //w=0.187 //l=0.74 //layer=li \
 //thickness=0.1 //x=29.35 //y=2.77 //x2=29.35 //y2=3.51
r506 (  29 65 ) resistor r=34.9091 //w=0.187 //l=0.51 //layer=li \
 //thickness=0.1 //x=29.35 //y=2.77 //x2=29.35 //y2=2.26
r507 (  28 59 ) resistor r=7.52941 //w=0.187 //l=0.11 //layer=li \
 //thickness=0.1 //x=10.85 //y=4.99 //x2=10.85 //y2=4.88
r508 (  27 59 ) resistor r=17.7968 //w=0.187 //l=0.26 //layer=li \
 //thickness=0.1 //x=10.85 //y=4.62 //x2=10.85 //y2=4.88
r509 (  26 27 ) resistor r=25.3262 //w=0.187 //l=0.37 //layer=li \
 //thickness=0.1 //x=10.85 //y=4.25 //x2=10.85 //y2=4.62
r510 (  25 26 ) resistor r=50.6524 //w=0.187 //l=0.74 //layer=li \
 //thickness=0.1 //x=10.85 //y=3.51 //x2=10.85 //y2=4.25
r511 (  24 25 ) resistor r=25.3262 //w=0.187 //l=0.37 //layer=li \
 //thickness=0.1 //x=10.85 //y=3.14 //x2=10.85 //y2=3.51
r512 (  23 24 ) resistor r=25.3262 //w=0.187 //l=0.37 //layer=li \
 //thickness=0.1 //x=10.85 //y=2.77 //x2=10.85 //y2=3.14
r513 (  23 49 ) resistor r=34.5668 //w=0.187 //l=0.505 //layer=li \
 //thickness=0.1 //x=10.85 //y=2.77 //x2=10.85 //y2=2.265
r514 (  22 46 ) resistor r=17.7968 //w=0.187 //l=0.26 //layer=li \
 //thickness=0.1 //x=7.15 //y=4.62 //x2=7.15 //y2=4.88
r515 (  20 21 ) resistor r=50.6524 //w=0.187 //l=0.74 //layer=li \
 //thickness=0.1 //x=4.93 //y=2.4 //x2=4.93 //y2=3.14
r516 (  20 36 ) resistor r=9.24064 //w=0.187 //l=0.135 //layer=li \
 //thickness=0.1 //x=4.93 //y=2.4 //x2=4.93 //y2=2.265
r517 (  18 34 ) resistor r=9.3 //w=0.17 //l=0.17 //layer=mcon //count=1 \
 //x=29.35 //y=4.81 //x2=29.35 //y2=4.81
r518 (  18 19 ) resistor r=0.104651 //w=0.215 //l=0.18 //layer=m1 \
 //thickness=0.36 //x=29.35 //y=4.81 //x2=29.35 //y2=4.99
r519 (  16 27 ) resistor r=9.3 //w=0.17 //l=0.17 //layer=mcon //count=1 \
 //x=10.85 //y=4.62 //x2=10.85 //y2=4.62
r520 (  14 24 ) resistor r=9.3 //w=0.17 //l=0.17 //layer=mcon //count=1 \
 //x=10.85 //y=3.14 //x2=10.85 //y2=3.14
r521 (  12 28 ) resistor r=9.3 //w=0.17 //l=0.17 //layer=mcon //count=1 \
 //x=10.85 //y=4.99 //x2=10.85 //y2=4.99
r522 (  10 22 ) resistor r=9.3 //w=0.17 //l=0.17 //layer=mcon //count=1 \
 //x=7.15 //y=4.62 //x2=7.15 //y2=4.62
r523 (  8 21 ) resistor r=9.3 //w=0.17 //l=0.17 //layer=mcon //count=1 \
 //x=4.93 //y=3.14 //x2=4.93 //y2=3.14
r524 (  6 12 ) resistor r=0.0717383 //w=0.224 //l=0.115 //layer=m1 \
 //thickness=0.36 //x=10.965 //y=4.99 //x2=10.85 //y2=4.99
r525 (  5 19 ) resistor r=0.0216707 //w=0.215 //l=0.115 //layer=m1 \
 //thickness=0.36 //x=29.235 //y=4.99 //x2=29.35 //y2=4.99
r526 (  5 6 ) resistor r=17.4332 //w=0.131 //l=18.27 //layer=m1 \
 //thickness=0.36 //x=29.235 //y=4.99 //x2=10.965 //y2=4.99
r527 (  4 10 ) resistor r=0.0717383 //w=0.224 //l=0.115 //layer=m1 \
 //thickness=0.36 //x=7.265 //y=4.62 //x2=7.15 //y2=4.62
r528 (  3 16 ) resistor r=0.0717383 //w=0.224 //l=0.115 //layer=m1 \
 //thickness=0.36 //x=10.735 //y=4.62 //x2=10.85 //y2=4.62
r529 (  3 4 ) resistor r=3.31107 //w=0.131 //l=3.47 //layer=m1 \
 //thickness=0.36 //x=10.735 //y=4.62 //x2=7.265 //y2=4.62
r530 (  2 8 ) resistor r=0.0717383 //w=0.224 //l=0.115 //layer=m1 \
 //thickness=0.36 //x=5.045 //y=3.14 //x2=4.93 //y2=3.14
r531 (  1 14 ) resistor r=0.0717383 //w=0.224 //l=0.115 //layer=m1 \
 //thickness=0.36 //x=10.735 //y=3.14 //x2=10.85 //y2=3.14
r532 (  1 2 ) resistor r=5.42939 //w=0.131 //l=5.69 //layer=m1 \
 //thickness=0.36 //x=10.735 //y=3.14 //x2=5.045 //y2=3.14
ends PM_FA\%B

subckt PM_FA\%noxref_7 ( 1 2 3 4 5 6 7 8 33 34 35 36 40 51 52 53 54 58 60 72 \
 79 81 87 88 89 90 91 92 93 94 95 96 97 98 99 103 104 105 107 113 114 115 116 \
 117 118 122 124 127 128 132 133 134 139 141 143 149 150 152 166 170 171 174 \
 182 183 186 187 )
c420 ( 187 0 ) capacitor c=0.0159588f //x=8.005 //y=5.2
c421 ( 186 0 ) capacitor c=0.0159588f //x=4.675 //y=5.2
c422 ( 183 0 ) capacitor c=0.00827922f //x=8 //y=1.09
c423 ( 182 0 ) capacitor c=0.00846882f //x=4.67 //y=1.09
c424 ( 174 0 ) capacitor c=0.0347773f //x=24.57 //y=4.88
c425 ( 171 0 ) capacitor c=0.0270331f //x=24.54 //y=2.095
c426 ( 170 0 ) capacitor c=0.0423789f //x=24.54 //y=2.26
c427 ( 166 0 ) capacitor c=0.06601f //x=14.92 //y=4.88
c428 ( 152 0 ) capacitor c=0.0505038f //x=12.33 //y=2.265
c429 ( 150 0 ) capacitor c=0.0429696f //x=25.105 //y=1.43
c430 ( 149 0 ) capacitor c=0.0190738f //x=25.105 //y=1.085
c431 ( 143 0 ) capacitor c=0.0148572f //x=24.95 //y=1.585
c432 ( 141 0 ) capacitor c=0.0157803f //x=24.95 //y=0.93
c433 ( 139 0 ) capacitor c=0.037277f //x=24.945 //y=4.97
c434 ( 134 0 ) capacitor c=0.0205163f //x=24.575 //y=1.74
c435 ( 133 0 ) capacitor c=0.0168481f //x=24.575 //y=1.43
c436 ( 132 0 ) capacitor c=0.0174142f //x=24.575 //y=1.085
c437 ( 128 0 ) capacitor c=0.0318948f //x=15.255 //y=1.395
c438 ( 127 0 ) capacitor c=0.0186029f //x=15.255 //y=1.05
c439 ( 124 0 ) capacitor c=0.0141798f //x=15.1 //y=1.55
c440 ( 122 0 ) capacitor c=0.0149852f //x=15.1 //y=0.895
c441 ( 118 0 ) capacitor c=0.0823795f //x=14.725 //y=2.1
c442 ( 117 0 ) capacitor c=0.0229212f //x=14.725 //y=1.705
c443 ( 116 0 ) capacitor c=0.0234352f //x=14.725 //y=1.395
c444 ( 115 0 ) capacitor c=0.0197989f //x=14.725 //y=1.05
c445 ( 114 0 ) capacitor c=0.0435629f //x=12.97 //y=1.435
c446 ( 113 0 ) capacitor c=0.0199463f //x=12.97 //y=1.09
c447 ( 107 0 ) capacitor c=0.0148979f //x=12.815 //y=1.59
c448 ( 105 0 ) capacitor c=0.0157804f //x=12.815 //y=0.935
c449 ( 104 0 ) capacitor c=0.049215f //x=12.56 //y=4.97
c450 ( 103 0 ) capacitor c=0.030248f //x=12.85 //y=4.97
c451 ( 99 0 ) capacitor c=0.0293214f //x=12.44 //y=2.1
c452 ( 98 0 ) capacitor c=0.0250027f //x=12.44 //y=1.745
c453 ( 97 0 ) capacitor c=0.0234316f //x=12.44 //y=1.435
c454 ( 96 0 ) capacitor c=0.0199673f //x=12.44 //y=1.09
c455 ( 95 0 ) capacitor c=0.15358f //x=25.02 //y=6.2
c456 ( 94 0 ) capacitor c=0.110117f //x=24.58 //y=6.2
c457 ( 93 0 ) capacitor c=0.110632f //x=15.26 //y=6.2
c458 ( 92 0 ) capacitor c=0.154209f //x=14.82 //y=6.2
c459 ( 91 0 ) capacitor c=0.154131f //x=12.925 //y=6.2
c460 ( 90 0 ) capacitor c=0.154154f //x=12.485 //y=6.2
c461 ( 81 0 ) capacitor c=0.0762812f //x=24.54 //y=2.26
c462 ( 79 0 ) capacitor c=0.00307329f //x=24.54 //y=4.715
c463 ( 72 0 ) capacitor c=0.104556f //x=14.92 //y=2.265
c464 ( 60 0 ) capacitor c=0.0826372f //x=12.33 //y=2.265
c465 ( 58 0 ) capacitor c=0.0885032f //x=8.63 //y=3.88
c466 ( 54 0 ) capacitor c=0.0016874f //x=8.275 //y=1.835
c467 ( 53 0 ) capacitor c=0.014358f //x=8.545 //y=1.835
c468 ( 52 0 ) capacitor c=0.00235465f //x=8.235 //y=5.385
c469 ( 51 0 ) capacitor c=0.0121398f //x=8.545 //y=5.385
c470 ( 40 0 ) capacitor c=0.104613f //x=5.3 //y=3.88
c471 ( 36 0 ) capacitor c=0.0016874f //x=4.945 //y=1.835
c472 ( 35 0 ) capacitor c=0.014358f //x=5.215 //y=1.835
c473 ( 34 0 ) capacitor c=0.0027221f //x=4.905 //y=5.385
c474 ( 33 0 ) capacitor c=0.0121701f //x=5.215 //y=5.385
c475 ( 8 0 ) capacitor c=0.00719749f //x=12.445 //y=4.25
c476 ( 7 0 ) capacitor c=0.0689485f //x=14.805 //y=4.25
c477 ( 6 0 ) capacitor c=0.0140175f //x=12.445 //y=2.4
c478 ( 5 0 ) capacitor c=0.201199f //x=24.425 //y=2.4
c479 ( 4 0 ) capacitor c=0.00275131f //x=8.745 //y=3.88
c480 ( 3 0 ) capacitor c=0.0880917f //x=12.215 //y=3.88
c481 ( 2 0 ) capacitor c=0.0134265f //x=5.415 //y=3.88
c482 ( 1 0 ) capacitor c=0.0544718f //x=8.515 //y=3.88
r483 (  176 177 ) resistor r=32.4568 //w=0.214 //l=0.075 //layer=ply \
 //thickness=0.18 //x=24.57 //y=4.97 //x2=24.57 //y2=5.045
r484 (  174 176 ) resistor r=20.271 //w=0.214 //l=0.09 //layer=ply \
 //thickness=0.18 //x=24.57 //y=4.88 //x2=24.57 //y2=4.97
r485 (  170 171 ) resistor r=52.7279 //w=0.214 //l=0.165 //layer=ply \
 //thickness=0.18 //x=24.54 //y=2.26 //x2=24.54 //y2=2.095
r486 (  164 166 ) resistor r=20.6867 //w=0.233 //l=0.1 //layer=ply \
 //thickness=0.18 //x=14.82 //y=4.88 //x2=14.92 //y2=4.88
r487 (  152 153 ) resistor r=17.5563 //w=0.302 //l=0.11 //layer=ply \
 //thickness=0.18 //x=12.33 //y=2.265 //x2=12.44 //y2=2.265
r488 (  150 181 ) resistor r=45.1352 //w=0.168 //l=0.173853 //layer=ply \
 //thickness=0.18 //x=25.105 //y=1.43 //x2=25.065 //y2=1.585
r489 (  149 180 ) resistor r=45.1352 //w=0.168 //l=0.173853 //layer=ply \
 //thickness=0.18 //x=25.105 //y=1.085 //x2=25.065 //y2=0.93
r490 (  149 150 ) resistor r=176.904 //w=0.094 //l=0.345 //layer=ply \
 //thickness=0.18 //x=25.105 //y=1.085 //x2=25.105 //y2=1.43
r491 (  144 179 ) resistor r=10.701 //w=0.21 //l=0.115 //layer=ply \
 //thickness=0.18 //x=24.73 //y=1.585 //x2=24.615 //y2=1.585
r492 (  143 181 ) resistor r=5.52526 //w=0.168 //l=0.115 //layer=ply \
 //thickness=0.18 //x=24.95 //y=1.585 //x2=25.065 //y2=1.585
r493 (  142 178 ) resistor r=5.52526 //w=0.168 //l=0.115 //layer=ply \
 //thickness=0.18 //x=24.73 //y=0.93 //x2=24.615 //y2=0.93
r494 (  141 180 ) resistor r=5.52526 //w=0.168 //l=0.115 //layer=ply \
 //thickness=0.18 //x=24.95 //y=0.93 //x2=25.065 //y2=0.93
r495 (  141 142 ) resistor r=112.809 //w=0.094 //l=0.22 //layer=ply \
 //thickness=0.18 //x=24.95 //y=0.93 //x2=24.73 //y2=0.93
r496 (  140 176 ) resistor r=16.5046 //w=0.27 //l=0.135 //layer=ply \
 //thickness=0.18 //x=24.705 //y=4.97 //x2=24.57 //y2=4.97
r497 (  139 146 ) resistor r=26.9307 //w=0.15 //l=0.106066 //layer=ply \
 //thickness=0.18 //x=24.945 //y=4.97 //x2=25.02 //y2=5.045
r498 (  139 140 ) resistor r=123.064 //w=0.094 //l=0.24 //layer=ply \
 //thickness=0.18 //x=24.945 //y=4.97 //x2=24.705 //y2=4.97
r499 (  134 179 ) resistor r=39.5823 //w=0.21 //l=0.173853 //layer=ply \
 //thickness=0.18 //x=24.575 //y=1.74 //x2=24.615 //y2=1.585
r500 (  134 171 ) resistor r=182.032 //w=0.094 //l=0.355 //layer=ply \
 //thickness=0.18 //x=24.575 //y=1.74 //x2=24.575 //y2=2.095
r501 (  133 179 ) resistor r=39.5823 //w=0.21 //l=0.173853 //layer=ply \
 //thickness=0.18 //x=24.575 //y=1.43 //x2=24.615 //y2=1.585
r502 (  132 178 ) resistor r=45.1352 //w=0.168 //l=0.173853 //layer=ply \
 //thickness=0.18 //x=24.575 //y=1.085 //x2=24.615 //y2=0.93
r503 (  132 133 ) resistor r=176.904 //w=0.094 //l=0.345 //layer=ply \
 //thickness=0.18 //x=24.575 //y=1.085 //x2=24.575 //y2=1.43
r504 (  129 166 ) resistor r=70.3348 //w=0.233 //l=0.414367 //layer=ply \
 //thickness=0.18 //x=15.26 //y=5.045 //x2=14.92 //y2=4.88
r505 (  128 168 ) resistor r=45.1352 //w=0.168 //l=0.173853 //layer=ply \
 //thickness=0.18 //x=15.255 //y=1.395 //x2=15.215 //y2=1.55
r506 (  127 167 ) resistor r=45.1352 //w=0.168 //l=0.173853 //layer=ply \
 //thickness=0.18 //x=15.255 //y=1.05 //x2=15.215 //y2=0.895
r507 (  127 128 ) resistor r=176.904 //w=0.094 //l=0.345 //layer=ply \
 //thickness=0.18 //x=15.255 //y=1.05 //x2=15.255 //y2=1.395
r508 (  125 163 ) resistor r=10.701 //w=0.21 //l=0.115 //layer=ply \
 //thickness=0.18 //x=14.88 //y=1.55 //x2=14.765 //y2=1.55
r509 (  124 168 ) resistor r=5.52526 //w=0.168 //l=0.115 //layer=ply \
 //thickness=0.18 //x=15.1 //y=1.55 //x2=15.215 //y2=1.55
r510 (  123 162 ) resistor r=5.52526 //w=0.168 //l=0.115 //layer=ply \
 //thickness=0.18 //x=14.88 //y=0.895 //x2=14.765 //y2=0.895
r511 (  122 167 ) resistor r=5.52526 //w=0.168 //l=0.115 //layer=ply \
 //thickness=0.18 //x=15.1 //y=0.895 //x2=15.215 //y2=0.895
r512 (  122 123 ) resistor r=112.809 //w=0.094 //l=0.22 //layer=ply \
 //thickness=0.18 //x=15.1 //y=0.895 //x2=14.88 //y2=0.895
r513 (  119 164 ) resistor r=13.0941 //w=0.233 //l=0.165 //layer=ply \
 //thickness=0.18 //x=14.82 //y=5.045 //x2=14.82 //y2=4.88
r514 (  118 161 ) resistor r=34.8111 //w=0.27 //l=0.264953 //layer=ply \
 //thickness=0.18 //x=14.725 //y=2.1 //x2=14.92 //y2=2.265
r515 (  117 163 ) resistor r=39.5823 //w=0.21 //l=0.173853 //layer=ply \
 //thickness=0.18 //x=14.725 //y=1.705 //x2=14.765 //y2=1.55
r516 (  117 118 ) resistor r=202.543 //w=0.094 //l=0.395 //layer=ply \
 //thickness=0.18 //x=14.725 //y=1.705 //x2=14.725 //y2=2.1
r517 (  116 163 ) resistor r=39.5823 //w=0.21 //l=0.173853 //layer=ply \
 //thickness=0.18 //x=14.725 //y=1.395 //x2=14.765 //y2=1.55
r518 (  115 162 ) resistor r=45.1352 //w=0.168 //l=0.173853 //layer=ply \
 //thickness=0.18 //x=14.725 //y=1.05 //x2=14.765 //y2=0.895
r519 (  115 116 ) resistor r=176.904 //w=0.094 //l=0.345 //layer=ply \
 //thickness=0.18 //x=14.725 //y=1.05 //x2=14.725 //y2=1.395
r520 (  114 159 ) resistor r=45.1352 //w=0.168 //l=0.173853 //layer=ply \
 //thickness=0.18 //x=12.97 //y=1.435 //x2=12.93 //y2=1.59
r521 (  113 158 ) resistor r=45.1352 //w=0.168 //l=0.173853 //layer=ply \
 //thickness=0.18 //x=12.97 //y=1.09 //x2=12.93 //y2=0.935
r522 (  113 114 ) resistor r=176.904 //w=0.094 //l=0.345 //layer=ply \
 //thickness=0.18 //x=12.97 //y=1.09 //x2=12.97 //y2=1.435
r523 (  108 157 ) resistor r=10.701 //w=0.21 //l=0.115 //layer=ply \
 //thickness=0.18 //x=12.595 //y=1.59 //x2=12.48 //y2=1.59
r524 (  107 159 ) resistor r=5.52526 //w=0.168 //l=0.115 //layer=ply \
 //thickness=0.18 //x=12.815 //y=1.59 //x2=12.93 //y2=1.59
r525 (  106 156 ) resistor r=5.52526 //w=0.168 //l=0.115 //layer=ply \
 //thickness=0.18 //x=12.595 //y=0.935 //x2=12.48 //y2=0.935
r526 (  105 158 ) resistor r=5.52526 //w=0.168 //l=0.115 //layer=ply \
 //thickness=0.18 //x=12.815 //y=0.935 //x2=12.93 //y2=0.935
r527 (  105 106 ) resistor r=112.809 //w=0.094 //l=0.22 //layer=ply \
 //thickness=0.18 //x=12.815 //y=0.935 //x2=12.595 //y2=0.935
r528 (  103 110 ) resistor r=26.9307 //w=0.15 //l=0.106066 //layer=ply \
 //thickness=0.18 //x=12.85 //y=4.97 //x2=12.925 //y2=5.045
r529 (  103 104 ) resistor r=148.702 //w=0.094 //l=0.29 //layer=ply \
 //thickness=0.18 //x=12.85 //y=4.97 //x2=12.56 //y2=4.97
r530 (  100 104 ) resistor r=23.403 //w=0.284 //l=0.106066 //layer=ply \
 //thickness=0.18 //x=12.485 //y=5.045 //x2=12.56 //y2=4.97
r531 (  100 155 ) resistor r=26.3063 //w=0.284 //l=0.229783 //layer=ply \
 //thickness=0.18 //x=12.485 //y=5.045 //x2=12.33 //y2=4.88
r532 (  99 153 ) resistor r=19.1248 //w=0.302 //l=0.165 //layer=ply \
 //thickness=0.18 //x=12.44 //y=2.1 //x2=12.44 //y2=2.265
r533 (  98 157 ) resistor r=39.5823 //w=0.21 //l=0.173853 //layer=ply \
 //thickness=0.18 //x=12.44 //y=1.745 //x2=12.48 //y2=1.59
r534 (  98 99 ) resistor r=182.032 //w=0.094 //l=0.355 //layer=ply \
 //thickness=0.18 //x=12.44 //y=1.745 //x2=12.44 //y2=2.1
r535 (  97 157 ) resistor r=39.5823 //w=0.21 //l=0.173853 //layer=ply \
 //thickness=0.18 //x=12.44 //y=1.435 //x2=12.48 //y2=1.59
r536 (  96 156 ) resistor r=45.1352 //w=0.168 //l=0.173853 //layer=ply \
 //thickness=0.18 //x=12.44 //y=1.09 //x2=12.48 //y2=0.935
r537 (  96 97 ) resistor r=176.904 //w=0.094 //l=0.345 //layer=ply \
 //thickness=0.18 //x=12.44 //y=1.09 //x2=12.44 //y2=1.435
r538 (  95 146 ) resistor r=592.245 //w=0.094 //l=1.155 //layer=ply \
 //thickness=0.18 //x=25.02 //y=6.2 //x2=25.02 //y2=5.045
r539 (  94 177 ) resistor r=592.245 //w=0.094 //l=1.155 //layer=ply \
 //thickness=0.18 //x=24.58 //y=6.2 //x2=24.58 //y2=5.045
r540 (  93 129 ) resistor r=592.245 //w=0.094 //l=1.155 //layer=ply \
 //thickness=0.18 //x=15.26 //y=6.2 //x2=15.26 //y2=5.045
r541 (  92 119 ) resistor r=592.245 //w=0.094 //l=1.155 //layer=ply \
 //thickness=0.18 //x=14.82 //y=6.2 //x2=14.82 //y2=5.045
r542 (  91 110 ) resistor r=592.245 //w=0.094 //l=1.155 //layer=ply \
 //thickness=0.18 //x=12.925 //y=6.2 //x2=12.925 //y2=5.045
r543 (  90 100 ) resistor r=592.245 //w=0.094 //l=1.155 //layer=ply \
 //thickness=0.18 //x=12.485 //y=6.2 //x2=12.485 //y2=5.045
r544 (  89 143 ) resistor r=56.4043 //w=0.094 //l=0.11 //layer=ply \
 //thickness=0.18 //x=24.84 //y=1.585 //x2=24.95 //y2=1.585
r545 (  89 144 ) resistor r=56.4043 //w=0.094 //l=0.11 //layer=ply \
 //thickness=0.18 //x=24.84 //y=1.585 //x2=24.73 //y2=1.585
r546 (  88 124 ) resistor r=56.4043 //w=0.094 //l=0.11 //layer=ply \
 //thickness=0.18 //x=14.99 //y=1.55 //x2=15.1 //y2=1.55
r547 (  88 125 ) resistor r=56.4043 //w=0.094 //l=0.11 //layer=ply \
 //thickness=0.18 //x=14.99 //y=1.55 //x2=14.88 //y2=1.55
r548 (  87 107 ) resistor r=56.4043 //w=0.094 //l=0.11 //layer=ply \
 //thickness=0.18 //x=12.705 //y=1.59 //x2=12.815 //y2=1.59
r549 (  87 108 ) resistor r=56.4043 //w=0.094 //l=0.11 //layer=ply \
 //thickness=0.18 //x=12.705 //y=1.59 //x2=12.595 //y2=1.59
r550 (  86 174 ) resistor r=152 //w=0.17 //l=0.17 //layer=licon //count=1 \
 //x=24.57 //y=4.88 //x2=24.57 //y2=4.88
r551 (  81 170 ) resistor r=152 //w=0.17 //l=0.17 //layer=licon //count=1 \
 //x=24.54 //y=2.26 //x2=24.54 //y2=2.26
r552 (  81 84 ) resistor r=9.58289 //w=0.187 //l=0.14 //layer=li \
 //thickness=0.1 //x=24.54 //y=2.26 //x2=24.54 //y2=2.4
r553 (  79 86 ) resistor r=11.4737 //w=0.186 //l=0.172337 //layer=li \
 //thickness=0.1 //x=24.54 //y=4.715 //x2=24.555 //y2=4.88
r554 (  79 84 ) resistor r=158.46 //w=0.187 //l=2.315 //layer=li \
 //thickness=0.1 //x=24.54 //y=4.715 //x2=24.54 //y2=2.4
r555 (  77 166 ) resistor r=152 //w=0.17 //l=0.17 //layer=licon //count=1 \
 //x=14.92 //y=4.88 //x2=14.92 //y2=4.88
r556 (  75 77 ) resistor r=43.123 //w=0.187 //l=0.63 //layer=li \
 //thickness=0.1 //x=14.92 //y=4.25 //x2=14.92 //y2=4.88
r557 (  72 161 ) resistor r=152 //w=0.17 //l=0.17 //layer=licon //count=1 \
 //x=14.92 //y=2.265 //x2=14.92 //y2=2.265
r558 (  72 75 ) resistor r=135.872 //w=0.187 //l=1.985 //layer=li \
 //thickness=0.1 //x=14.92 //y=2.265 //x2=14.92 //y2=4.25
r559 (  69 155 ) resistor r=152 //w=0.17 //l=0.17 //layer=licon //count=1 \
 //x=12.33 //y=4.88 //x2=12.33 //y2=4.88
r560 (  67 69 ) resistor r=43.123 //w=0.187 //l=0.63 //layer=li \
 //thickness=0.1 //x=12.33 //y=4.25 //x2=12.33 //y2=4.88
r561 (  65 67 ) resistor r=25.3262 //w=0.187 //l=0.37 //layer=li \
 //thickness=0.1 //x=12.33 //y=3.88 //x2=12.33 //y2=4.25
r562 (  63 65 ) resistor r=101.305 //w=0.187 //l=1.48 //layer=li \
 //thickness=0.1 //x=12.33 //y=2.4 //x2=12.33 //y2=3.88
r563 (  60 152 ) resistor r=152 //w=0.17 //l=0.17 //layer=licon //count=1 \
 //x=12.33 //y=2.265 //x2=12.33 //y2=2.265
r564 (  60 63 ) resistor r=9.24064 //w=0.187 //l=0.135 //layer=li \
 //thickness=0.1 //x=12.33 //y=2.265 //x2=12.33 //y2=2.4
r565 (  56 58 ) resistor r=97.1979 //w=0.187 //l=1.42 //layer=li \
 //thickness=0.1 //x=8.63 //y=5.3 //x2=8.63 //y2=3.88
r566 (  55 58 ) resistor r=134.16 //w=0.187 //l=1.96 //layer=li \
 //thickness=0.1 //x=8.63 //y=1.92 //x2=8.63 //y2=3.88
r567 (  53 55 ) resistor r=7.15173 //w=0.17 //l=0.120208 //layer=li \
 //thickness=0.1 //x=8.545 //y=1.835 //x2=8.63 //y2=1.92
r568 (  53 54 ) resistor r=18.4813 //w=0.187 //l=0.27 //layer=li \
 //thickness=0.1 //x=8.545 //y=1.835 //x2=8.275 //y2=1.835
r569 (  51 56 ) resistor r=7.15173 //w=0.17 //l=0.120208 //layer=li \
 //thickness=0.1 //x=8.545 //y=5.385 //x2=8.63 //y2=5.3
r570 (  51 52 ) resistor r=21.2193 //w=0.187 //l=0.31 //layer=li \
 //thickness=0.1 //x=8.545 //y=5.385 //x2=8.235 //y2=5.385
r571 (  47 54 ) resistor r=7.15173 //w=0.17 //l=0.120208 //layer=li \
 //thickness=0.1 //x=8.19 //y=1.75 //x2=8.275 //y2=1.835
r572 (  47 183 ) resistor r=38.6738 //w=0.187 //l=0.565 //layer=li \
 //thickness=0.1 //x=8.19 //y=1.75 //x2=8.19 //y2=1.185
r573 (  41 52 ) resistor r=7.15173 //w=0.17 //l=0.120208 //layer=li \
 //thickness=0.1 //x=8.15 //y=5.47 //x2=8.235 //y2=5.385
r574 (  41 187 ) resistor r=29.0909 //w=0.187 //l=0.425 //layer=li \
 //thickness=0.1 //x=8.15 //y=5.47 //x2=8.15 //y2=5.895
r575 (  38 40 ) resistor r=97.1979 //w=0.187 //l=1.42 //layer=li \
 //thickness=0.1 //x=5.3 //y=5.3 //x2=5.3 //y2=3.88
r576 (  37 40 ) resistor r=134.16 //w=0.187 //l=1.96 //layer=li \
 //thickness=0.1 //x=5.3 //y=1.92 //x2=5.3 //y2=3.88
r577 (  35 37 ) resistor r=7.15173 //w=0.17 //l=0.120208 //layer=li \
 //thickness=0.1 //x=5.215 //y=1.835 //x2=5.3 //y2=1.92
r578 (  35 36 ) resistor r=18.4813 //w=0.187 //l=0.27 //layer=li \
 //thickness=0.1 //x=5.215 //y=1.835 //x2=4.945 //y2=1.835
r579 (  33 38 ) resistor r=7.15173 //w=0.17 //l=0.120208 //layer=li \
 //thickness=0.1 //x=5.215 //y=5.385 //x2=5.3 //y2=5.3
r580 (  33 34 ) resistor r=21.2193 //w=0.187 //l=0.31 //layer=li \
 //thickness=0.1 //x=5.215 //y=5.385 //x2=4.905 //y2=5.385
r581 (  29 36 ) resistor r=7.15173 //w=0.17 //l=0.120208 //layer=li \
 //thickness=0.1 //x=4.86 //y=1.75 //x2=4.945 //y2=1.835
r582 (  29 182 ) resistor r=38.6738 //w=0.187 //l=0.565 //layer=li \
 //thickness=0.1 //x=4.86 //y=1.75 //x2=4.86 //y2=1.185
r583 (  23 34 ) resistor r=7.15173 //w=0.17 //l=0.120208 //layer=li \
 //thickness=0.1 //x=4.82 //y=5.47 //x2=4.905 //y2=5.385
r584 (  23 186 ) resistor r=29.0909 //w=0.187 //l=0.425 //layer=li \
 //thickness=0.1 //x=4.82 //y=5.47 //x2=4.82 //y2=5.895
r585 (  22 84 ) resistor r=9.3 //w=0.17 //l=0.17 //layer=mcon //count=1 \
 //x=24.54 //y=2.4 //x2=24.54 //y2=2.4
r586 (  20 75 ) resistor r=9.3 //w=0.17 //l=0.17 //layer=mcon //count=1 \
 //x=14.92 //y=4.25 //x2=14.92 //y2=4.25
r587 (  18 65 ) resistor r=9.3 //w=0.17 //l=0.17 //layer=mcon //count=1 \
 //x=12.33 //y=3.88 //x2=12.33 //y2=3.88
r588 (  16 67 ) resistor r=9.3 //w=0.17 //l=0.17 //layer=mcon //count=1 \
 //x=12.33 //y=4.25 //x2=12.33 //y2=4.25
r589 (  14 63 ) resistor r=9.3 //w=0.17 //l=0.17 //layer=mcon //count=1 \
 //x=12.33 //y=2.4 //x2=12.33 //y2=2.4
r590 (  12 58 ) resistor r=9.3 //w=0.17 //l=0.17 //layer=mcon //count=1 \
 //x=8.63 //y=3.88 //x2=8.63 //y2=3.88
r591 (  10 40 ) resistor r=9.3 //w=0.17 //l=0.17 //layer=mcon //count=1 \
 //x=5.3 //y=3.88 //x2=5.3 //y2=3.88
r592 (  8 16 ) resistor r=0.0717383 //w=0.224 //l=0.115 //layer=m1 \
 //thickness=0.36 //x=12.445 //y=4.25 //x2=12.33 //y2=4.25
r593 (  7 20 ) resistor r=0.0717383 //w=0.224 //l=0.115 //layer=m1 \
 //thickness=0.36 //x=14.805 //y=4.25 //x2=14.92 //y2=4.25
r594 (  7 8 ) resistor r=2.25191 //w=0.131 //l=2.36 //layer=m1 \
 //thickness=0.36 //x=14.805 //y=4.25 //x2=12.445 //y2=4.25
r595 (  6 14 ) resistor r=0.0717383 //w=0.224 //l=0.115 //layer=m1 \
 //thickness=0.36 //x=12.445 //y=2.4 //x2=12.33 //y2=2.4
r596 (  5 22 ) resistor r=0.0717383 //w=0.224 //l=0.115 //layer=m1 \
 //thickness=0.36 //x=24.425 //y=2.4 //x2=24.54 //y2=2.4
r597 (  5 6 ) resistor r=11.4313 //w=0.131 //l=11.98 //layer=m1 \
 //thickness=0.36 //x=24.425 //y=2.4 //x2=12.445 //y2=2.4
r598 (  4 12 ) resistor r=0.0880901 //w=0.191 //l=0.115 //layer=m1 \
 //thickness=0.36 //x=8.745 //y=3.88 //x2=8.63 //y2=3.88
r599 (  3 18 ) resistor r=0.0717383 //w=0.224 //l=0.115 //layer=m1 \
 //thickness=0.36 //x=12.215 //y=3.88 //x2=12.33 //y2=3.88
r600 (  3 4 ) resistor r=3.31107 //w=0.131 //l=3.47 //layer=m1 \
 //thickness=0.36 //x=12.215 //y=3.88 //x2=8.745 //y2=3.88
r601 (  2 10 ) resistor r=0.0717383 //w=0.224 //l=0.115 //layer=m1 \
 //thickness=0.36 //x=5.415 //y=3.88 //x2=5.3 //y2=3.88
r602 (  1 12 ) resistor r=0.0880901 //w=0.191 //l=0.115 //layer=m1 \
 //thickness=0.36 //x=8.515 //y=3.88 //x2=8.63 //y2=3.88
r603 (  1 2 ) resistor r=2.95802 //w=0.131 //l=3.1 //layer=m1 //thickness=0.36 \
 //x=8.515 //y=3.88 //x2=5.415 //y2=3.88
ends PM_FA\%noxref_7

subckt PM_FA\%noxref_8 ( 1 2 17 18 19 20 24 26 33 34 35 36 37 38 39 43 45 51 \
 52 60 62 64 )
c163 ( 64 0 ) capacitor c=0.0280624f //x=12.56 //y=5.2
c164 ( 62 0 ) capacitor c=0.0170084f //x=12.515 //y=1.09
c165 ( 60 0 ) capacitor c=0.0588976f //x=19.36 //y=4.88
c166 ( 52 0 ) capacitor c=0.0417768f //x=19.555 //y=1.435
c167 ( 51 0 ) capacitor c=0.01899f //x=19.555 //y=1.09
c168 ( 45 0 ) capacitor c=0.0124204f //x=19.4 //y=1.59
c169 ( 43 0 ) capacitor c=0.0157803f //x=19.4 //y=0.935
c170 ( 39 0 ) capacitor c=0.0889138f //x=19.025 //y=2.1
c171 ( 38 0 ) capacitor c=0.0194674f //x=19.025 //y=1.745
c172 ( 37 0 ) capacitor c=0.0168481f //x=19.025 //y=1.435
c173 ( 36 0 ) capacitor c=0.0173364f //x=19.025 //y=1.09
c174 ( 35 0 ) capacitor c=0.153256f //x=19.47 //y=6.2
c175 ( 34 0 ) capacitor c=0.110062f //x=19.03 //y=6.2
c176 ( 26 0 ) capacitor c=0.0699117f //x=19.36 //y=2.265
c177 ( 24 0 ) capacitor c=0.0843781f //x=13.07 //y=2.77
c178 ( 20 0 ) capacitor c=0.00413007f //x=12.79 //y=4.76
c179 ( 19 0 ) capacitor c=0.0103938f //x=12.985 //y=4.76
c180 ( 18 0 ) capacitor c=0.00476658f //x=12.785 //y=2.26
c181 ( 17 0 ) capacitor c=0.0155174f //x=12.985 //y=2.26
c182 ( 2 0 ) capacitor c=0.0146857f //x=13.185 //y=2.77
c183 ( 1 0 ) capacitor c=0.121614f //x=19.245 //y=2.77
r184 (  60 61 ) resistor r=22.7554 //w=0.233 //l=0.11 //layer=ply \
 //thickness=0.18 //x=19.36 //y=4.88 //x2=19.47 //y2=4.88
r185 (  52 58 ) resistor r=45.1352 //w=0.168 //l=0.173853 //layer=ply \
 //thickness=0.18 //x=19.555 //y=1.435 //x2=19.515 //y2=1.59
r186 (  51 57 ) resistor r=45.1352 //w=0.168 //l=0.173853 //layer=ply \
 //thickness=0.18 //x=19.555 //y=1.09 //x2=19.515 //y2=0.935
r187 (  51 52 ) resistor r=176.904 //w=0.094 //l=0.345 //layer=ply \
 //thickness=0.18 //x=19.555 //y=1.09 //x2=19.555 //y2=1.435
r188 (  48 61 ) resistor r=13.0941 //w=0.233 //l=0.165 //layer=ply \
 //thickness=0.18 //x=19.47 //y=5.045 //x2=19.47 //y2=4.88
r189 (  46 54 ) resistor r=10.701 //w=0.21 //l=0.115 //layer=ply \
 //thickness=0.18 //x=19.18 //y=1.59 //x2=19.065 //y2=1.59
r190 (  45 58 ) resistor r=5.52526 //w=0.168 //l=0.115 //layer=ply \
 //thickness=0.18 //x=19.4 //y=1.59 //x2=19.515 //y2=1.59
r191 (  44 53 ) resistor r=5.52526 //w=0.168 //l=0.115 //layer=ply \
 //thickness=0.18 //x=19.18 //y=0.935 //x2=19.065 //y2=0.935
r192 (  43 57 ) resistor r=5.52526 //w=0.168 //l=0.115 //layer=ply \
 //thickness=0.18 //x=19.4 //y=0.935 //x2=19.515 //y2=0.935
r193 (  43 44 ) resistor r=112.809 //w=0.094 //l=0.22 //layer=ply \
 //thickness=0.18 //x=19.4 //y=0.935 //x2=19.18 //y2=0.935
r194 (  40 60 ) resistor r=68.2661 //w=0.233 //l=0.404166 //layer=ply \
 //thickness=0.18 //x=19.03 //y=5.045 //x2=19.36 //y2=4.88
r195 (  39 56 ) resistor r=67.2792 //w=0.24 //l=0.438891 //layer=ply \
 //thickness=0.18 //x=19.025 //y=2.1 //x2=19.36 //y2=2.34
r196 (  38 54 ) resistor r=39.5823 //w=0.21 //l=0.173853 //layer=ply \
 //thickness=0.18 //x=19.025 //y=1.745 //x2=19.065 //y2=1.59
r197 (  38 39 ) resistor r=182.032 //w=0.094 //l=0.355 //layer=ply \
 //thickness=0.18 //x=19.025 //y=1.745 //x2=19.025 //y2=2.1
r198 (  37 54 ) resistor r=39.5823 //w=0.21 //l=0.173853 //layer=ply \
 //thickness=0.18 //x=19.025 //y=1.435 //x2=19.065 //y2=1.59
r199 (  36 53 ) resistor r=45.1352 //w=0.168 //l=0.173853 //layer=ply \
 //thickness=0.18 //x=19.025 //y=1.09 //x2=19.065 //y2=0.935
r200 (  36 37 ) resistor r=176.904 //w=0.094 //l=0.345 //layer=ply \
 //thickness=0.18 //x=19.025 //y=1.09 //x2=19.025 //y2=1.435
r201 (  35 48 ) resistor r=592.245 //w=0.094 //l=1.155 //layer=ply \
 //thickness=0.18 //x=19.47 //y=6.2 //x2=19.47 //y2=5.045
r202 (  34 40 ) resistor r=592.245 //w=0.094 //l=1.155 //layer=ply \
 //thickness=0.18 //x=19.03 //y=6.2 //x2=19.03 //y2=5.045
r203 (  33 45 ) resistor r=56.4043 //w=0.094 //l=0.11 //layer=ply \
 //thickness=0.18 //x=19.29 //y=1.59 //x2=19.4 //y2=1.59
r204 (  33 46 ) resistor r=56.4043 //w=0.094 //l=0.11 //layer=ply \
 //thickness=0.18 //x=19.29 //y=1.59 //x2=19.18 //y2=1.59
r205 (  31 60 ) resistor r=152 //w=0.17 //l=0.17 //layer=licon //count=1 \
 //x=19.36 //y=4.88 //x2=19.36 //y2=4.88
r206 (  29 31 ) resistor r=144.428 //w=0.187 //l=2.11 //layer=li \
 //thickness=0.1 //x=19.36 //y=2.77 //x2=19.36 //y2=4.88
r207 (  26 56 ) resistor r=152 //w=0.17 //l=0.17 //layer=licon //count=1 \
 //x=19.36 //y=2.265 //x2=19.36 //y2=2.265
r208 (  26 29 ) resistor r=34.5668 //w=0.187 //l=0.505 //layer=li \
 //thickness=0.1 //x=19.36 //y=2.265 //x2=19.36 //y2=2.77
r209 (  22 24 ) resistor r=130.396 //w=0.187 //l=1.905 //layer=li \
 //thickness=0.1 //x=13.07 //y=4.675 //x2=13.07 //y2=2.77
r210 (  21 24 ) resistor r=29.0909 //w=0.187 //l=0.425 //layer=li \
 //thickness=0.1 //x=13.07 //y=2.345 //x2=13.07 //y2=2.77
r211 (  19 22 ) resistor r=7.15173 //w=0.17 //l=0.120208 //layer=li \
 //thickness=0.1 //x=12.985 //y=4.76 //x2=13.07 //y2=4.675
r212 (  19 20 ) resistor r=13.3476 //w=0.187 //l=0.195 //layer=li \
 //thickness=0.1 //x=12.985 //y=4.76 //x2=12.79 //y2=4.76
r213 (  17 21 ) resistor r=7.15173 //w=0.17 //l=0.120208 //layer=li \
 //thickness=0.1 //x=12.985 //y=2.26 //x2=13.07 //y2=2.345
r214 (  17 18 ) resistor r=13.6898 //w=0.187 //l=0.2 //layer=li \
 //thickness=0.1 //x=12.985 //y=2.26 //x2=12.785 //y2=2.26
r215 (  11 20 ) resistor r=7.15173 //w=0.17 //l=0.120208 //layer=li \
 //thickness=0.1 //x=12.705 //y=4.845 //x2=12.79 //y2=4.76
r216 (  11 64 ) resistor r=72.5562 //w=0.187 //l=1.06 //layer=li \
 //thickness=0.1 //x=12.705 //y=4.845 //x2=12.705 //y2=5.905
r217 (  7 18 ) resistor r=7.15173 //w=0.17 //l=0.120208 //layer=li \
 //thickness=0.1 //x=12.7 //y=2.175 //x2=12.785 //y2=2.26
r218 (  7 62 ) resistor r=67.7647 //w=0.187 //l=0.99 //layer=li \
 //thickness=0.1 //x=12.7 //y=2.175 //x2=12.7 //y2=1.185
r219 (  6 29 ) resistor r=9.3 //w=0.17 //l=0.17 //layer=mcon //count=1 \
 //x=19.36 //y=2.77 //x2=19.36 //y2=2.77
r220 (  4 24 ) resistor r=9.3 //w=0.17 //l=0.17 //layer=mcon //count=1 \
 //x=13.07 //y=2.77 //x2=13.07 //y2=2.77
r221 (  2 4 ) resistor r=0.0717383 //w=0.224 //l=0.115 //layer=m1 \
 //thickness=0.36 //x=13.185 //y=2.77 //x2=13.07 //y2=2.77
r222 (  1 6 ) resistor r=0.0717383 //w=0.224 //l=0.115 //layer=m1 \
 //thickness=0.36 //x=19.245 //y=2.77 //x2=19.36 //y2=2.77
r223 (  1 2 ) resistor r=5.78244 //w=0.131 //l=6.06 //layer=m1 \
 //thickness=0.36 //x=19.245 //y=2.77 //x2=13.185 //y2=2.77
ends PM_FA\%noxref_8

subckt PM_FA\%SUM ( 1 2 7 8 9 10 11 22 23 24 25 42 43 44 45 51 52 55 56 )
c148 ( 56 0 ) capacitor c=0.0159588f //x=19.105 //y=5.2
c149 ( 55 0 ) capacitor c=0.0159588f //x=15.775 //y=5.2
c150 ( 52 0 ) capacitor c=0.00827922f //x=19.1 //y=1.09
c151 ( 51 0 ) capacitor c=0.00846882f //x=15.77 //y=1.09
c152 ( 45 0 ) capacitor c=0.0016874f //x=19.375 //y=1.835
c153 ( 44 0 ) capacitor c=0.014358f //x=19.645 //y=1.835
c154 ( 43 0 ) capacitor c=0.00222879f //x=19.335 //y=5.385
c155 ( 42 0 ) capacitor c=0.011934f //x=19.645 //y=5.385
c156 ( 25 0 ) capacitor c=0.0016874f //x=16.045 //y=1.835
c157 ( 24 0 ) capacitor c=0.014358f //x=16.315 //y=1.835
c158 ( 23 0 ) capacitor c=0.00222879f //x=16.005 //y=5.385
c159 ( 22 0 ) capacitor c=0.0117456f //x=16.315 //y=5.385
c160 ( 10 0 ) capacitor c=0.0870285f //x=19.73 //y=2.77
c161 ( 7 0 ) capacitor c=0.103261f //x=16.4 //y=3.51
c162 ( 2 0 ) capacitor c=0.0103701f //x=16.515 //y=3.88
c163 ( 1 0 ) capacitor c=0.0661877f //x=19.615 //y=3.88
r164 (  44 46 ) resistor r=7.15173 //w=0.17 //l=0.120208 //layer=li \
 //thickness=0.1 //x=19.645 //y=1.835 //x2=19.73 //y2=1.92
r165 (  44 45 ) resistor r=18.4813 //w=0.187 //l=0.27 //layer=li \
 //thickness=0.1 //x=19.645 //y=1.835 //x2=19.375 //y2=1.835
r166 (  42 47 ) resistor r=7.15173 //w=0.17 //l=0.120208 //layer=li \
 //thickness=0.1 //x=19.645 //y=5.385 //x2=19.73 //y2=5.3
r167 (  42 43 ) resistor r=21.2193 //w=0.187 //l=0.31 //layer=li \
 //thickness=0.1 //x=19.645 //y=5.385 //x2=19.335 //y2=5.385
r168 (  38 45 ) resistor r=7.15173 //w=0.17 //l=0.120208 //layer=li \
 //thickness=0.1 //x=19.29 //y=1.75 //x2=19.375 //y2=1.835
r169 (  38 52 ) resistor r=38.6738 //w=0.187 //l=0.565 //layer=li \
 //thickness=0.1 //x=19.29 //y=1.75 //x2=19.29 //y2=1.185
r170 (  32 43 ) resistor r=7.15173 //w=0.17 //l=0.120208 //layer=li \
 //thickness=0.1 //x=19.25 //y=5.47 //x2=19.335 //y2=5.385
r171 (  32 56 ) resistor r=29.0909 //w=0.187 //l=0.425 //layer=li \
 //thickness=0.1 //x=19.25 //y=5.47 //x2=19.25 //y2=5.895
r172 (  24 26 ) resistor r=7.15173 //w=0.17 //l=0.120208 //layer=li \
 //thickness=0.1 //x=16.315 //y=1.835 //x2=16.4 //y2=1.92
r173 (  24 25 ) resistor r=18.4813 //w=0.187 //l=0.27 //layer=li \
 //thickness=0.1 //x=16.315 //y=1.835 //x2=16.045 //y2=1.835
r174 (  22 27 ) resistor r=7.15173 //w=0.17 //l=0.120208 //layer=li \
 //thickness=0.1 //x=16.315 //y=5.385 //x2=16.4 //y2=5.3
r175 (  22 23 ) resistor r=21.2193 //w=0.187 //l=0.31 //layer=li \
 //thickness=0.1 //x=16.315 //y=5.385 //x2=16.005 //y2=5.385
r176 (  18 25 ) resistor r=7.15173 //w=0.17 //l=0.120208 //layer=li \
 //thickness=0.1 //x=15.96 //y=1.75 //x2=16.045 //y2=1.835
r177 (  18 51 ) resistor r=38.6738 //w=0.187 //l=0.565 //layer=li \
 //thickness=0.1 //x=15.96 //y=1.75 //x2=15.96 //y2=1.185
r178 (  12 23 ) resistor r=7.15173 //w=0.17 //l=0.120208 //layer=li \
 //thickness=0.1 //x=15.92 //y=5.47 //x2=16.005 //y2=5.385
r179 (  12 55 ) resistor r=29.0909 //w=0.187 //l=0.425 //layer=li \
 //thickness=0.1 //x=15.92 //y=5.47 //x2=15.92 //y2=5.895
r180 (  11 47 ) resistor r=97.1979 //w=0.187 //l=1.42 //layer=li \
 //thickness=0.1 //x=19.73 //y=3.88 //x2=19.73 //y2=5.3
r181 (  10 11 ) resistor r=75.9786 //w=0.187 //l=1.11 //layer=li \
 //thickness=0.1 //x=19.73 //y=2.77 //x2=19.73 //y2=3.88
r182 (  10 46 ) resistor r=58.1818 //w=0.187 //l=0.85 //layer=li \
 //thickness=0.1 //x=19.73 //y=2.77 //x2=19.73 //y2=1.92
r183 (  9 27 ) resistor r=46.5455 //w=0.187 //l=0.68 //layer=li \
 //thickness=0.1 //x=16.4 //y=4.62 //x2=16.4 //y2=5.3
r184 (  8 9 ) resistor r=50.6524 //w=0.187 //l=0.74 //layer=li //thickness=0.1 \
 //x=16.4 //y=3.88 //x2=16.4 //y2=4.62
r185 (  7 8 ) resistor r=25.3262 //w=0.187 //l=0.37 //layer=li //thickness=0.1 \
 //x=16.4 //y=3.51 //x2=16.4 //y2=3.88
r186 (  7 26 ) resistor r=108.834 //w=0.187 //l=1.59 //layer=li \
 //thickness=0.1 //x=16.4 //y=3.51 //x2=16.4 //y2=1.92
r187 (  6 11 ) resistor r=9.3 //w=0.17 //l=0.17 //layer=mcon //count=1 \
 //x=19.73 //y=3.88 //x2=19.73 //y2=3.88
r188 (  4 8 ) resistor r=9.3 //w=0.17 //l=0.17 //layer=mcon //count=1 //x=16.4 \
 //y=3.88 //x2=16.4 //y2=3.88
r189 (  2 4 ) resistor r=0.0717383 //w=0.224 //l=0.115 //layer=m1 \
 //thickness=0.36 //x=16.515 //y=3.88 //x2=16.4 //y2=3.88
r190 (  1 6 ) resistor r=0.0717383 //w=0.224 //l=0.115 //layer=m1 \
 //thickness=0.36 //x=19.615 //y=3.88 //x2=19.73 //y2=3.88
r191 (  1 2 ) resistor r=2.95802 //w=0.131 //l=3.1 //layer=m1 //thickness=0.36 \
 //x=19.615 //y=3.88 //x2=16.515 //y2=3.88
ends PM_FA\%SUM

subckt PM_FA\%noxref_10 ( 1 2 3 4 14 20 28 31 32 33 34 45 46 47 54 55 56 57 58 \
 60 63 64 66 74 76 )
c172 ( 76 0 ) capacitor c=0.0279647f //x=21.43 //y=5.2
c173 ( 74 0 ) capacitor c=0.0170596f //x=21.385 //y=1.09
c174 ( 66 0 ) capacitor c=0.0640415f //x=16.03 //y=4.88
c175 ( 64 0 ) capacitor c=0.0318948f //x=18.585 //y=1.395
c176 ( 63 0 ) capacitor c=0.0186029f //x=18.585 //y=1.05
c177 ( 60 0 ) capacitor c=0.0141798f //x=18.43 //y=1.55
c178 ( 58 0 ) capacitor c=0.0149852f //x=18.43 //y=0.895
c179 ( 57 0 ) capacitor c=0.0823795f //x=18.055 //y=2.1
c180 ( 56 0 ) capacitor c=0.0229212f //x=18.055 //y=1.705
c181 ( 55 0 ) capacitor c=0.0234352f //x=18.055 //y=1.395
c182 ( 54 0 ) capacitor c=0.0197989f //x=18.055 //y=1.05
c183 ( 47 0 ) capacitor c=0.153256f //x=16.14 //y=6.2
c184 ( 46 0 ) capacitor c=0.110062f //x=15.7 //y=6.2
c185 ( 34 0 ) capacitor c=0.00614759f //x=21.295 //y=4.76
c186 ( 33 0 ) capacitor c=0.0137356f //x=21.49 //y=4.76
c187 ( 32 0 ) capacitor c=0.00618684f //x=21.295 //y=2.26
c188 ( 31 0 ) capacitor c=0.0139695f //x=21.495 //y=2.26
c189 ( 28 0 ) capacitor c=0.0765759f //x=21.21 //y=3.51
c190 ( 20 0 ) capacitor c=0.0523393f //x=18.25 //y=2.265
c191 ( 14 0 ) capacitor c=0.0234413f //x=16.03 //y=4.25
c192 ( 4 0 ) capacitor c=0.0126928f //x=18.365 //y=3.51
c193 ( 3 0 ) capacitor c=0.0515075f //x=21.095 //y=3.51
c194 ( 2 0 ) capacitor c=0.00869386f //x=16.145 //y=4.25
c195 ( 1 0 ) capacitor c=0.0895659f //x=21.095 //y=4.25
r196 (  66 67 ) resistor r=22.7554 //w=0.233 //l=0.11 //layer=ply \
 //thickness=0.18 //x=16.03 //y=4.88 //x2=16.14 //y2=4.88
r197 (  64 73 ) resistor r=45.1352 //w=0.168 //l=0.173853 //layer=ply \
 //thickness=0.18 //x=18.585 //y=1.395 //x2=18.545 //y2=1.55
r198 (  63 72 ) resistor r=45.1352 //w=0.168 //l=0.173853 //layer=ply \
 //thickness=0.18 //x=18.585 //y=1.05 //x2=18.545 //y2=0.895
r199 (  63 64 ) resistor r=176.904 //w=0.094 //l=0.345 //layer=ply \
 //thickness=0.18 //x=18.585 //y=1.05 //x2=18.585 //y2=1.395
r200 (  61 71 ) resistor r=10.701 //w=0.21 //l=0.115 //layer=ply \
 //thickness=0.18 //x=18.21 //y=1.55 //x2=18.095 //y2=1.55
r201 (  60 73 ) resistor r=5.52526 //w=0.168 //l=0.115 //layer=ply \
 //thickness=0.18 //x=18.43 //y=1.55 //x2=18.545 //y2=1.55
r202 (  59 70 ) resistor r=5.52526 //w=0.168 //l=0.115 //layer=ply \
 //thickness=0.18 //x=18.21 //y=0.895 //x2=18.095 //y2=0.895
r203 (  58 72 ) resistor r=5.52526 //w=0.168 //l=0.115 //layer=ply \
 //thickness=0.18 //x=18.43 //y=0.895 //x2=18.545 //y2=0.895
r204 (  58 59 ) resistor r=112.809 //w=0.094 //l=0.22 //layer=ply \
 //thickness=0.18 //x=18.43 //y=0.895 //x2=18.21 //y2=0.895
r205 (  57 69 ) resistor r=34.8111 //w=0.27 //l=0.264953 //layer=ply \
 //thickness=0.18 //x=18.055 //y=2.1 //x2=18.25 //y2=2.265
r206 (  56 71 ) resistor r=39.5823 //w=0.21 //l=0.173853 //layer=ply \
 //thickness=0.18 //x=18.055 //y=1.705 //x2=18.095 //y2=1.55
r207 (  56 57 ) resistor r=202.543 //w=0.094 //l=0.395 //layer=ply \
 //thickness=0.18 //x=18.055 //y=1.705 //x2=18.055 //y2=2.1
r208 (  55 71 ) resistor r=39.5823 //w=0.21 //l=0.173853 //layer=ply \
 //thickness=0.18 //x=18.055 //y=1.395 //x2=18.095 //y2=1.55
r209 (  54 70 ) resistor r=45.1352 //w=0.168 //l=0.173853 //layer=ply \
 //thickness=0.18 //x=18.055 //y=1.05 //x2=18.095 //y2=0.895
r210 (  54 55 ) resistor r=176.904 //w=0.094 //l=0.345 //layer=ply \
 //thickness=0.18 //x=18.055 //y=1.05 //x2=18.055 //y2=1.395
r211 (  51 67 ) resistor r=13.0941 //w=0.233 //l=0.165 //layer=ply \
 //thickness=0.18 //x=16.14 //y=5.045 //x2=16.14 //y2=4.88
r212 (  48 66 ) resistor r=68.2661 //w=0.233 //l=0.404166 //layer=ply \
 //thickness=0.18 //x=15.7 //y=5.045 //x2=16.03 //y2=4.88
r213 (  47 51 ) resistor r=592.245 //w=0.094 //l=1.155 //layer=ply \
 //thickness=0.18 //x=16.14 //y=6.2 //x2=16.14 //y2=5.045
r214 (  46 48 ) resistor r=592.245 //w=0.094 //l=1.155 //layer=ply \
 //thickness=0.18 //x=15.7 //y=6.2 //x2=15.7 //y2=5.045
r215 (  45 60 ) resistor r=56.4043 //w=0.094 //l=0.11 //layer=ply \
 //thickness=0.18 //x=18.32 //y=1.55 //x2=18.43 //y2=1.55
r216 (  45 61 ) resistor r=56.4043 //w=0.094 //l=0.11 //layer=ply \
 //thickness=0.18 //x=18.32 //y=1.55 //x2=18.21 //y2=1.55
r217 (  41 74 ) resistor r=67.7647 //w=0.187 //l=0.99 //layer=li \
 //thickness=0.1 //x=21.58 //y=2.175 //x2=21.58 //y2=1.185
r218 (  35 76 ) resistor r=72.5562 //w=0.187 //l=1.06 //layer=li \
 //thickness=0.1 //x=21.575 //y=4.845 //x2=21.575 //y2=5.905
r219 (  33 35 ) resistor r=7.15173 //w=0.17 //l=0.120208 //layer=li \
 //thickness=0.1 //x=21.49 //y=4.76 //x2=21.575 //y2=4.845
r220 (  33 34 ) resistor r=13.3476 //w=0.187 //l=0.195 //layer=li \
 //thickness=0.1 //x=21.49 //y=4.76 //x2=21.295 //y2=4.76
r221 (  31 41 ) resistor r=7.15173 //w=0.17 //l=0.120208 //layer=li \
 //thickness=0.1 //x=21.495 //y=2.26 //x2=21.58 //y2=2.175
r222 (  31 32 ) resistor r=13.6898 //w=0.187 //l=0.2 //layer=li \
 //thickness=0.1 //x=21.495 //y=2.26 //x2=21.295 //y2=2.26
r223 (  28 30 ) resistor r=50.6524 //w=0.187 //l=0.74 //layer=li \
 //thickness=0.1 //x=21.21 //y=3.51 //x2=21.21 //y2=4.25
r224 (  26 34 ) resistor r=7.15173 //w=0.17 //l=0.120208 //layer=li \
 //thickness=0.1 //x=21.21 //y=4.675 //x2=21.295 //y2=4.76
r225 (  26 30 ) resistor r=29.0909 //w=0.187 //l=0.425 //layer=li \
 //thickness=0.1 //x=21.21 //y=4.675 //x2=21.21 //y2=4.25
r226 (  25 32 ) resistor r=7.15173 //w=0.17 //l=0.120208 //layer=li \
 //thickness=0.1 //x=21.21 //y=2.345 //x2=21.295 //y2=2.26
r227 (  25 28 ) resistor r=79.7433 //w=0.187 //l=1.165 //layer=li \
 //thickness=0.1 //x=21.21 //y=2.345 //x2=21.21 //y2=3.51
r228 (  20 69 ) resistor r=152 //w=0.17 //l=0.17 //layer=licon //count=1 \
 //x=18.25 //y=2.265 //x2=18.25 //y2=2.265
r229 (  20 23 ) resistor r=85.2193 //w=0.187 //l=1.245 //layer=li \
 //thickness=0.1 //x=18.25 //y=2.265 //x2=18.25 //y2=3.51
r230 (  17 66 ) resistor r=152 //w=0.17 //l=0.17 //layer=licon //count=1 \
 //x=16.03 //y=4.88 //x2=16.03 //y2=4.88
r231 (  14 17 ) resistor r=43.123 //w=0.187 //l=0.63 //layer=li \
 //thickness=0.1 //x=16.03 //y=4.25 //x2=16.03 //y2=4.88
r232 (  12 30 ) resistor r=9.3 //w=0.17 //l=0.17 //layer=mcon //count=1 \
 //x=21.21 //y=4.25 //x2=21.21 //y2=4.25
r233 (  10 28 ) resistor r=9.3 //w=0.17 //l=0.17 //layer=mcon //count=1 \
 //x=21.21 //y=3.51 //x2=21.21 //y2=3.51
r234 (  8 23 ) resistor r=9.3 //w=0.17 //l=0.17 //layer=mcon //count=1 \
 //x=18.25 //y=3.51 //x2=18.25 //y2=3.51
r235 (  6 14 ) resistor r=9.3 //w=0.17 //l=0.17 //layer=mcon //count=1 \
 //x=16.03 //y=4.25 //x2=16.03 //y2=4.25
r236 (  4 8 ) resistor r=0.0717383 //w=0.224 //l=0.115 //layer=m1 \
 //thickness=0.36 //x=18.365 //y=3.51 //x2=18.25 //y2=3.51
r237 (  3 10 ) resistor r=0.0717383 //w=0.224 //l=0.115 //layer=m1 \
 //thickness=0.36 //x=21.095 //y=3.51 //x2=21.21 //y2=3.51
r238 (  3 4 ) resistor r=2.60496 //w=0.131 //l=2.73 //layer=m1 \
 //thickness=0.36 //x=21.095 //y=3.51 //x2=18.365 //y2=3.51
r239 (  2 6 ) resistor r=0.0717383 //w=0.224 //l=0.115 //layer=m1 \
 //thickness=0.36 //x=16.145 //y=4.25 //x2=16.03 //y2=4.25
r240 (  1 12 ) resistor r=0.0717383 //w=0.224 //l=0.115 //layer=m1 \
 //thickness=0.36 //x=21.095 //y=4.25 //x2=21.21 //y2=4.25
r241 (  1 2 ) resistor r=4.72328 //w=0.131 //l=4.95 //layer=m1 \
 //thickness=0.36 //x=21.095 //y=4.25 //x2=16.145 //y2=4.25
ends PM_FA\%noxref_10

subckt PM_FA\%CIN ( 1 2 3 4 5 6 17 18 19 20 21 22 23 24 25 26 27 28 29 30 32 \
 44 58 70 71 72 73 74 75 76 77 78 79 80 81 82 83 85 88 89 96 97 101 102 103 \
 105 108 111 112 113 114 115 116 117 118 122 124 127 128 140 145 156 )
c251 ( 156 0 ) capacitor c=0.064035f //x=23.8 //y=4.88
c252 ( 145 0 ) capacitor c=0.0503242f //x=21.84 //y=2.265
c253 ( 140 0 ) capacitor c=0.0605721f //x=18.25 //y=4.88
c254 ( 128 0 ) capacitor c=0.0318948f //x=24.135 //y=1.39
c255 ( 127 0 ) capacitor c=0.0187384f //x=24.135 //y=1.045
c256 ( 124 0 ) capacitor c=0.0141798f //x=23.98 //y=1.545
c257 ( 122 0 ) capacitor c=0.0149844f //x=23.98 //y=0.89
c258 ( 118 0 ) capacitor c=0.0804766f //x=23.605 //y=2.095
c259 ( 117 0 ) capacitor c=0.0229212f //x=23.605 //y=1.7
c260 ( 116 0 ) capacitor c=0.0234352f //x=23.605 //y=1.39
c261 ( 115 0 ) capacitor c=0.0199343f //x=23.605 //y=1.045
c262 ( 114 0 ) capacitor c=0.0293214f //x=21.84 //y=2.1
c263 ( 113 0 ) capacitor c=0.0250171f //x=21.84 //y=1.745
c264 ( 112 0 ) capacitor c=0.0234316f //x=21.84 //y=1.435
c265 ( 111 0 ) capacitor c=0.0199789f //x=21.84 //y=1.09
c266 ( 108 0 ) capacitor c=0.0490825f //x=21.795 //y=5.045
c267 ( 105 0 ) capacitor c=0.0148979f //x=21.685 //y=1.59
c268 ( 103 0 ) capacitor c=0.0157804f //x=21.685 //y=0.935
c269 ( 102 0 ) capacitor c=0.0129101f //x=21.43 //y=4.97
c270 ( 101 0 ) capacitor c=0.0173472f //x=21.72 //y=4.97
c271 ( 97 0 ) capacitor c=0.0435512f //x=21.31 //y=1.435
c272 ( 96 0 ) capacitor c=0.0199346f //x=21.31 //y=1.09
c273 ( 89 0 ) capacitor c=0.0417768f //x=16.225 //y=1.435
c274 ( 88 0 ) capacitor c=0.01899f //x=16.225 //y=1.09
c275 ( 85 0 ) capacitor c=0.0124204f //x=16.07 //y=1.59
c276 ( 83 0 ) capacitor c=0.0157803f //x=16.07 //y=0.935
c277 ( 82 0 ) capacitor c=0.0889138f //x=15.695 //y=2.1
c278 ( 81 0 ) capacitor c=0.0194674f //x=15.695 //y=1.745
c279 ( 80 0 ) capacitor c=0.0168481f //x=15.695 //y=1.435
c280 ( 79 0 ) capacitor c=0.0173364f //x=15.695 //y=1.09
c281 ( 78 0 ) capacitor c=0.11011f //x=24.14 //y=6.2
c282 ( 77 0 ) capacitor c=0.154192f //x=23.7 //y=6.2
c283 ( 76 0 ) capacitor c=0.154154f //x=21.795 //y=6.2
c284 ( 75 0 ) capacitor c=0.154131f //x=21.355 //y=6.2
c285 ( 74 0 ) capacitor c=0.110632f //x=18.59 //y=6.2
c286 ( 73 0 ) capacitor c=0.154209f //x=18.15 //y=6.2
c287 ( 58 0 ) capacitor c=0.095771f //x=23.8 //y=2.26
c288 ( 44 0 ) capacitor c=0.0865219f //x=21.95 //y=2.265
c289 ( 32 0 ) capacitor c=0.0283262f //x=16.03 //y=2.265
c290 ( 18 0 ) capacitor c=0.0131564f //x=18.25 //y=4.62
c291 ( 6 0 ) capacitor c=0.0027479f //x=22.065 //y=4.62
c292 ( 5 0 ) capacitor c=0.0578447f //x=23.685 //y=4.62
c293 ( 4 0 ) capacitor c=0.0125654f //x=18.365 //y=4.62
c294 ( 3 0 ) capacitor c=0.0440536f //x=21.835 //y=4.62
c295 ( 2 0 ) capacitor c=0.0154186f //x=16.145 //y=3.14
c296 ( 1 0 ) capacitor c=0.110748f //x=21.835 //y=3.14
r297 (  154 156 ) resistor r=20.6867 //w=0.233 //l=0.1 //layer=ply \
 //thickness=0.18 //x=23.7 //y=4.88 //x2=23.8 //y2=4.88
r298 (  145 147 ) resistor r=17.5563 //w=0.302 //l=0.11 //layer=ply \
 //thickness=0.18 //x=21.84 //y=2.265 //x2=21.95 //y2=2.265
r299 (  138 140 ) resistor r=20.6867 //w=0.233 //l=0.1 //layer=ply \
 //thickness=0.18 //x=18.15 //y=4.88 //x2=18.25 //y2=4.88
r300 (  129 156 ) resistor r=70.3348 //w=0.233 //l=0.414367 //layer=ply \
 //thickness=0.18 //x=24.14 //y=5.045 //x2=23.8 //y2=4.88
r301 (  128 158 ) resistor r=45.1352 //w=0.168 //l=0.173853 //layer=ply \
 //thickness=0.18 //x=24.135 //y=1.39 //x2=24.095 //y2=1.545
r302 (  127 157 ) resistor r=45.1352 //w=0.168 //l=0.173853 //layer=ply \
 //thickness=0.18 //x=24.135 //y=1.045 //x2=24.095 //y2=0.89
r303 (  127 128 ) resistor r=176.904 //w=0.094 //l=0.345 //layer=ply \
 //thickness=0.18 //x=24.135 //y=1.045 //x2=24.135 //y2=1.39
r304 (  125 153 ) resistor r=10.701 //w=0.21 //l=0.115 //layer=ply \
 //thickness=0.18 //x=23.76 //y=1.545 //x2=23.645 //y2=1.545
r305 (  124 158 ) resistor r=5.52526 //w=0.168 //l=0.115 //layer=ply \
 //thickness=0.18 //x=23.98 //y=1.545 //x2=24.095 //y2=1.545
r306 (  123 152 ) resistor r=5.52526 //w=0.168 //l=0.115 //layer=ply \
 //thickness=0.18 //x=23.76 //y=0.89 //x2=23.645 //y2=0.89
r307 (  122 157 ) resistor r=5.52526 //w=0.168 //l=0.115 //layer=ply \
 //thickness=0.18 //x=23.98 //y=0.89 //x2=24.095 //y2=0.89
r308 (  122 123 ) resistor r=112.809 //w=0.094 //l=0.22 //layer=ply \
 //thickness=0.18 //x=23.98 //y=0.89 //x2=23.76 //y2=0.89
r309 (  119 154 ) resistor r=13.0941 //w=0.233 //l=0.165 //layer=ply \
 //thickness=0.18 //x=23.7 //y=5.045 //x2=23.7 //y2=4.88
r310 (  118 151 ) resistor r=34.8111 //w=0.27 //l=0.264953 //layer=ply \
 //thickness=0.18 //x=23.605 //y=2.095 //x2=23.8 //y2=2.26
r311 (  117 153 ) resistor r=39.5823 //w=0.21 //l=0.173853 //layer=ply \
 //thickness=0.18 //x=23.605 //y=1.7 //x2=23.645 //y2=1.545
r312 (  117 118 ) resistor r=202.543 //w=0.094 //l=0.395 //layer=ply \
 //thickness=0.18 //x=23.605 //y=1.7 //x2=23.605 //y2=2.095
r313 (  116 153 ) resistor r=39.5823 //w=0.21 //l=0.173853 //layer=ply \
 //thickness=0.18 //x=23.605 //y=1.39 //x2=23.645 //y2=1.545
r314 (  115 152 ) resistor r=45.1352 //w=0.168 //l=0.173853 //layer=ply \
 //thickness=0.18 //x=23.605 //y=1.045 //x2=23.645 //y2=0.89
r315 (  115 116 ) resistor r=176.904 //w=0.094 //l=0.345 //layer=ply \
 //thickness=0.18 //x=23.605 //y=1.045 //x2=23.605 //y2=1.39
r316 (  114 145 ) resistor r=19.1248 //w=0.302 //l=0.165 //layer=ply \
 //thickness=0.18 //x=21.84 //y=2.1 //x2=21.84 //y2=2.265
r317 (  113 144 ) resistor r=39.5823 //w=0.21 //l=0.173853 //layer=ply \
 //thickness=0.18 //x=21.84 //y=1.745 //x2=21.8 //y2=1.59
r318 (  113 114 ) resistor r=182.032 //w=0.094 //l=0.355 //layer=ply \
 //thickness=0.18 //x=21.84 //y=1.745 //x2=21.84 //y2=2.1
r319 (  112 144 ) resistor r=39.5823 //w=0.21 //l=0.173853 //layer=ply \
 //thickness=0.18 //x=21.84 //y=1.435 //x2=21.8 //y2=1.59
r320 (  111 143 ) resistor r=45.1352 //w=0.168 //l=0.173853 //layer=ply \
 //thickness=0.18 //x=21.84 //y=1.09 //x2=21.8 //y2=0.935
r321 (  111 112 ) resistor r=176.904 //w=0.094 //l=0.345 //layer=ply \
 //thickness=0.18 //x=21.84 //y=1.09 //x2=21.84 //y2=1.435
r322 (  108 149 ) resistor r=26.3063 //w=0.284 //l=0.229783 //layer=ply \
 //thickness=0.18 //x=21.795 //y=5.045 //x2=21.95 //y2=4.88
r323 (  106 142 ) resistor r=5.52526 //w=0.168 //l=0.115 //layer=ply \
 //thickness=0.18 //x=21.465 //y=1.59 //x2=21.35 //y2=1.59
r324 (  105 144 ) resistor r=10.701 //w=0.21 //l=0.115 //layer=ply \
 //thickness=0.18 //x=21.685 //y=1.59 //x2=21.8 //y2=1.59
r325 (  104 141 ) resistor r=5.52526 //w=0.168 //l=0.115 //layer=ply \
 //thickness=0.18 //x=21.465 //y=0.935 //x2=21.35 //y2=0.935
r326 (  103 143 ) resistor r=5.52526 //w=0.168 //l=0.115 //layer=ply \
 //thickness=0.18 //x=21.685 //y=0.935 //x2=21.8 //y2=0.935
r327 (  103 104 ) resistor r=112.809 //w=0.094 //l=0.22 //layer=ply \
 //thickness=0.18 //x=21.685 //y=0.935 //x2=21.465 //y2=0.935
r328 (  101 108 ) resistor r=23.403 //w=0.284 //l=0.106066 //layer=ply \
 //thickness=0.18 //x=21.72 //y=4.97 //x2=21.795 //y2=5.045
r329 (  101 102 ) resistor r=148.702 //w=0.094 //l=0.29 //layer=ply \
 //thickness=0.18 //x=21.72 //y=4.97 //x2=21.43 //y2=4.97
r330 (  98 102 ) resistor r=26.9307 //w=0.15 //l=0.106066 //layer=ply \
 //thickness=0.18 //x=21.355 //y=5.045 //x2=21.43 //y2=4.97
r331 (  97 142 ) resistor r=45.1352 //w=0.168 //l=0.173853 //layer=ply \
 //thickness=0.18 //x=21.31 //y=1.435 //x2=21.35 //y2=1.59
r332 (  96 141 ) resistor r=45.1352 //w=0.168 //l=0.173853 //layer=ply \
 //thickness=0.18 //x=21.31 //y=1.09 //x2=21.35 //y2=0.935
r333 (  96 97 ) resistor r=176.904 //w=0.094 //l=0.345 //layer=ply \
 //thickness=0.18 //x=21.31 //y=1.09 //x2=21.31 //y2=1.435
r334 (  93 140 ) resistor r=70.3348 //w=0.233 //l=0.414367 //layer=ply \
 //thickness=0.18 //x=18.59 //y=5.045 //x2=18.25 //y2=4.88
r335 (  90 138 ) resistor r=13.0941 //w=0.233 //l=0.165 //layer=ply \
 //thickness=0.18 //x=18.15 //y=5.045 //x2=18.15 //y2=4.88
r336 (  89 137 ) resistor r=45.1352 //w=0.168 //l=0.173853 //layer=ply \
 //thickness=0.18 //x=16.225 //y=1.435 //x2=16.185 //y2=1.59
r337 (  88 136 ) resistor r=45.1352 //w=0.168 //l=0.173853 //layer=ply \
 //thickness=0.18 //x=16.225 //y=1.09 //x2=16.185 //y2=0.935
r338 (  88 89 ) resistor r=176.904 //w=0.094 //l=0.345 //layer=ply \
 //thickness=0.18 //x=16.225 //y=1.09 //x2=16.225 //y2=1.435
r339 (  86 133 ) resistor r=10.701 //w=0.21 //l=0.115 //layer=ply \
 //thickness=0.18 //x=15.85 //y=1.59 //x2=15.735 //y2=1.59
r340 (  85 137 ) resistor r=5.52526 //w=0.168 //l=0.115 //layer=ply \
 //thickness=0.18 //x=16.07 //y=1.59 //x2=16.185 //y2=1.59
r341 (  84 132 ) resistor r=5.52526 //w=0.168 //l=0.115 //layer=ply \
 //thickness=0.18 //x=15.85 //y=0.935 //x2=15.735 //y2=0.935
r342 (  83 136 ) resistor r=5.52526 //w=0.168 //l=0.115 //layer=ply \
 //thickness=0.18 //x=16.07 //y=0.935 //x2=16.185 //y2=0.935
r343 (  83 84 ) resistor r=112.809 //w=0.094 //l=0.22 //layer=ply \
 //thickness=0.18 //x=16.07 //y=0.935 //x2=15.85 //y2=0.935
r344 (  82 135 ) resistor r=67.2792 //w=0.24 //l=0.438891 //layer=ply \
 //thickness=0.18 //x=15.695 //y=2.1 //x2=16.03 //y2=2.34
r345 (  81 133 ) resistor r=39.5823 //w=0.21 //l=0.173853 //layer=ply \
 //thickness=0.18 //x=15.695 //y=1.745 //x2=15.735 //y2=1.59
r346 (  81 82 ) resistor r=182.032 //w=0.094 //l=0.355 //layer=ply \
 //thickness=0.18 //x=15.695 //y=1.745 //x2=15.695 //y2=2.1
r347 (  80 133 ) resistor r=39.5823 //w=0.21 //l=0.173853 //layer=ply \
 //thickness=0.18 //x=15.695 //y=1.435 //x2=15.735 //y2=1.59
r348 (  79 132 ) resistor r=45.1352 //w=0.168 //l=0.173853 //layer=ply \
 //thickness=0.18 //x=15.695 //y=1.09 //x2=15.735 //y2=0.935
r349 (  79 80 ) resistor r=176.904 //w=0.094 //l=0.345 //layer=ply \
 //thickness=0.18 //x=15.695 //y=1.09 //x2=15.695 //y2=1.435
r350 (  78 129 ) resistor r=592.245 //w=0.094 //l=1.155 //layer=ply \
 //thickness=0.18 //x=24.14 //y=6.2 //x2=24.14 //y2=5.045
r351 (  77 119 ) resistor r=592.245 //w=0.094 //l=1.155 //layer=ply \
 //thickness=0.18 //x=23.7 //y=6.2 //x2=23.7 //y2=5.045
r352 (  76 108 ) resistor r=592.245 //w=0.094 //l=1.155 //layer=ply \
 //thickness=0.18 //x=21.795 //y=6.2 //x2=21.795 //y2=5.045
r353 (  75 98 ) resistor r=592.245 //w=0.094 //l=1.155 //layer=ply \
 //thickness=0.18 //x=21.355 //y=6.2 //x2=21.355 //y2=5.045
r354 (  74 93 ) resistor r=592.245 //w=0.094 //l=1.155 //layer=ply \
 //thickness=0.18 //x=18.59 //y=6.2 //x2=18.59 //y2=5.045
r355 (  73 90 ) resistor r=592.245 //w=0.094 //l=1.155 //layer=ply \
 //thickness=0.18 //x=18.15 //y=6.2 //x2=18.15 //y2=5.045
r356 (  72 124 ) resistor r=56.4043 //w=0.094 //l=0.11 //layer=ply \
 //thickness=0.18 //x=23.87 //y=1.545 //x2=23.98 //y2=1.545
r357 (  72 125 ) resistor r=56.4043 //w=0.094 //l=0.11 //layer=ply \
 //thickness=0.18 //x=23.87 //y=1.545 //x2=23.76 //y2=1.545
r358 (  71 105 ) resistor r=56.4043 //w=0.094 //l=0.11 //layer=ply \
 //thickness=0.18 //x=21.575 //y=1.59 //x2=21.685 //y2=1.59
r359 (  71 106 ) resistor r=56.4043 //w=0.094 //l=0.11 //layer=ply \
 //thickness=0.18 //x=21.575 //y=1.59 //x2=21.465 //y2=1.59
r360 (  70 85 ) resistor r=56.4043 //w=0.094 //l=0.11 //layer=ply \
 //thickness=0.18 //x=15.96 //y=1.59 //x2=16.07 //y2=1.59
r361 (  70 86 ) resistor r=56.4043 //w=0.094 //l=0.11 //layer=ply \
 //thickness=0.18 //x=15.96 //y=1.59 //x2=15.85 //y2=1.59
r362 (  68 156 ) resistor r=152 //w=0.17 //l=0.17 //layer=licon //count=1 \
 //x=23.8 //y=4.88 //x2=23.8 //y2=4.88
r363 (  58 151 ) resistor r=152 //w=0.17 //l=0.17 //layer=licon //count=1 \
 //x=23.8 //y=2.26 //x2=23.8 //y2=2.26
r364 (  55 149 ) resistor r=152 //w=0.17 //l=0.17 //layer=licon //count=1 \
 //x=21.95 //y=4.88 //x2=21.95 //y2=4.88
r365 (  44 147 ) resistor r=152 //w=0.17 //l=0.17 //layer=licon //count=1 \
 //x=21.95 //y=2.265 //x2=21.95 //y2=2.265
r366 (  41 140 ) resistor r=152 //w=0.17 //l=0.17 //layer=licon //count=1 \
 //x=18.25 //y=4.88 //x2=18.25 //y2=4.88
r367 (  32 135 ) resistor r=152 //w=0.17 //l=0.17 //layer=licon //count=1 \
 //x=16.03 //y=2.265 //x2=16.03 //y2=2.265
r368 (  30 68 ) resistor r=17.7968 //w=0.187 //l=0.26 //layer=li \
 //thickness=0.1 //x=23.8 //y=4.62 //x2=23.8 //y2=4.88
r369 (  29 30 ) resistor r=25.3262 //w=0.187 //l=0.37 //layer=li \
 //thickness=0.1 //x=23.8 //y=4.25 //x2=23.8 //y2=4.62
r370 (  28 29 ) resistor r=25.3262 //w=0.187 //l=0.37 //layer=li \
 //thickness=0.1 //x=23.8 //y=3.88 //x2=23.8 //y2=4.25
r371 (  27 28 ) resistor r=25.3262 //w=0.187 //l=0.37 //layer=li \
 //thickness=0.1 //x=23.8 //y=3.51 //x2=23.8 //y2=3.88
r372 (  26 27 ) resistor r=25.3262 //w=0.187 //l=0.37 //layer=li \
 //thickness=0.1 //x=23.8 //y=3.14 //x2=23.8 //y2=3.51
r373 (  25 26 ) resistor r=25.3262 //w=0.187 //l=0.37 //layer=li \
 //thickness=0.1 //x=23.8 //y=2.77 //x2=23.8 //y2=3.14
r374 (  25 58 ) resistor r=34.9091 //w=0.187 //l=0.51 //layer=li \
 //thickness=0.1 //x=23.8 //y=2.77 //x2=23.8 //y2=2.26
r375 (  24 55 ) resistor r=17.7968 //w=0.187 //l=0.26 //layer=li \
 //thickness=0.1 //x=21.95 //y=4.62 //x2=21.95 //y2=4.88
r376 (  23 24 ) resistor r=25.3262 //w=0.187 //l=0.37 //layer=li \
 //thickness=0.1 //x=21.95 //y=4.25 //x2=21.95 //y2=4.62
r377 (  22 23 ) resistor r=25.3262 //w=0.187 //l=0.37 //layer=li \
 //thickness=0.1 //x=21.95 //y=3.88 //x2=21.95 //y2=4.25
r378 (  21 22 ) resistor r=25.3262 //w=0.187 //l=0.37 //layer=li \
 //thickness=0.1 //x=21.95 //y=3.51 //x2=21.95 //y2=3.88
r379 (  20 21 ) resistor r=25.3262 //w=0.187 //l=0.37 //layer=li \
 //thickness=0.1 //x=21.95 //y=3.14 //x2=21.95 //y2=3.51
r380 (  19 20 ) resistor r=25.3262 //w=0.187 //l=0.37 //layer=li \
 //thickness=0.1 //x=21.95 //y=2.77 //x2=21.95 //y2=3.14
r381 (  19 44 ) resistor r=34.5668 //w=0.187 //l=0.505 //layer=li \
 //thickness=0.1 //x=21.95 //y=2.77 //x2=21.95 //y2=2.265
r382 (  18 41 ) resistor r=17.7968 //w=0.187 //l=0.26 //layer=li \
 //thickness=0.1 //x=18.25 //y=4.62 //x2=18.25 //y2=4.88
r383 (  17 32 ) resistor r=59.893 //w=0.187 //l=0.875 //layer=li \
 //thickness=0.1 //x=16.03 //y=3.14 //x2=16.03 //y2=2.265
r384 (  16 30 ) resistor r=9.3 //w=0.17 //l=0.17 //layer=mcon //count=1 \
 //x=23.8 //y=4.62 //x2=23.8 //y2=4.62
r385 (  14 20 ) resistor r=9.3 //w=0.17 //l=0.17 //layer=mcon //count=1 \
 //x=21.95 //y=3.14 //x2=21.95 //y2=3.14
r386 (  12 24 ) resistor r=9.3 //w=0.17 //l=0.17 //layer=mcon //count=1 \
 //x=21.95 //y=4.62 //x2=21.95 //y2=4.62
r387 (  10 18 ) resistor r=9.3 //w=0.17 //l=0.17 //layer=mcon //count=1 \
 //x=18.25 //y=4.62 //x2=18.25 //y2=4.62
r388 (  8 17 ) resistor r=9.3 //w=0.17 //l=0.17 //layer=mcon //count=1 \
 //x=16.03 //y=3.14 //x2=16.03 //y2=3.14
r389 (  6 12 ) resistor r=0.0880901 //w=0.191 //l=0.115 //layer=m1 \
 //thickness=0.36 //x=22.065 //y=4.62 //x2=21.95 //y2=4.62
r390 (  5 16 ) resistor r=0.0717383 //w=0.224 //l=0.115 //layer=m1 \
 //thickness=0.36 //x=23.685 //y=4.62 //x2=23.8 //y2=4.62
r391 (  5 6 ) resistor r=1.5458 //w=0.131 //l=1.62 //layer=m1 //thickness=0.36 \
 //x=23.685 //y=4.62 //x2=22.065 //y2=4.62
r392 (  4 10 ) resistor r=0.0717383 //w=0.224 //l=0.115 //layer=m1 \
 //thickness=0.36 //x=18.365 //y=4.62 //x2=18.25 //y2=4.62
r393 (  3 12 ) resistor r=0.0880901 //w=0.191 //l=0.115 //layer=m1 \
 //thickness=0.36 //x=21.835 //y=4.62 //x2=21.95 //y2=4.62
r394 (  3 4 ) resistor r=3.31107 //w=0.131 //l=3.47 //layer=m1 \
 //thickness=0.36 //x=21.835 //y=4.62 //x2=18.365 //y2=4.62
r395 (  2 8 ) resistor r=0.0717383 //w=0.224 //l=0.115 //layer=m1 \
 //thickness=0.36 //x=16.145 //y=3.14 //x2=16.03 //y2=3.14
r396 (  1 14 ) resistor r=0.0717383 //w=0.224 //l=0.115 //layer=m1 \
 //thickness=0.36 //x=21.835 //y=3.14 //x2=21.95 //y2=3.14
r397 (  1 2 ) resistor r=5.42939 //w=0.131 //l=5.69 //layer=m1 \
 //thickness=0.36 //x=21.835 //y=3.14 //x2=16.145 //y2=3.14
ends PM_FA\%CIN

subckt PM_FA\%noxref_12 ( 1 2 13 14 25 27 28 32 34 41 42 43 44 45 46 47 48 52 \
 53 54 56 62 63 65 73 75 76 )
c139 ( 76 0 ) capacitor c=0.0220291f //x=24.655 //y=5.2
c140 ( 75 0 ) capacitor c=0.0217503f //x=23.775 //y=5.2
c141 ( 73 0 ) capacitor c=0.0084702f //x=24.65 //y=1.085
c142 ( 65 0 ) capacitor c=0.0530483f //x=26.76 //y=2.265
c143 ( 63 0 ) capacitor c=0.0435629f //x=27.4 //y=1.435
c144 ( 62 0 ) capacitor c=0.0199463f //x=27.4 //y=1.09
c145 ( 56 0 ) capacitor c=0.0148979f //x=27.245 //y=1.59
c146 ( 54 0 ) capacitor c=0.0157804f //x=27.245 //y=0.935
c147 ( 53 0 ) capacitor c=0.0527191f //x=26.99 //y=4.97
c148 ( 52 0 ) capacitor c=0.0322367f //x=27.28 //y=4.97
c149 ( 48 0 ) capacitor c=0.0293214f //x=26.87 //y=2.1
c150 ( 47 0 ) capacitor c=0.0250027f //x=26.87 //y=1.745
c151 ( 46 0 ) capacitor c=0.0234316f //x=26.87 //y=1.435
c152 ( 45 0 ) capacitor c=0.0199673f //x=26.87 //y=1.09
c153 ( 44 0 ) capacitor c=0.154131f //x=27.355 //y=6.2
c154 ( 43 0 ) capacitor c=0.154154f //x=26.915 //y=6.2
c155 ( 41 0 ) capacitor c=0.00194742f //x=24.8 //y=5.38
c156 ( 34 0 ) capacitor c=0.088828f //x=26.76 //y=2.265
c157 ( 32 0 ) capacitor c=0.110774f //x=25.28 //y=3.51
c158 ( 28 0 ) capacitor c=0.00384212f //x=24.925 //y=1.835
c159 ( 27 0 ) capacitor c=0.0158293f //x=25.195 //y=1.835
c160 ( 25 0 ) capacitor c=0.013629f //x=25.195 //y=5.38
c161 ( 14 0 ) capacitor c=0.00238935f //x=24.005 //y=5.38
c162 ( 13 0 ) capacitor c=0.0136432f //x=24.715 //y=5.38
c163 ( 2 0 ) capacitor c=0.0111187f //x=25.395 //y=3.51
c164 ( 1 0 ) capacitor c=0.0546065f //x=26.645 //y=3.51
r165 (  65 66 ) resistor r=17.5563 //w=0.302 //l=0.11 //layer=ply \
 //thickness=0.18 //x=26.76 //y=2.265 //x2=26.87 //y2=2.265
r166 (  63 72 ) resistor r=45.1352 //w=0.168 //l=0.173853 //layer=ply \
 //thickness=0.18 //x=27.4 //y=1.435 //x2=27.36 //y2=1.59
r167 (  62 71 ) resistor r=45.1352 //w=0.168 //l=0.173853 //layer=ply \
 //thickness=0.18 //x=27.4 //y=1.09 //x2=27.36 //y2=0.935
r168 (  62 63 ) resistor r=176.904 //w=0.094 //l=0.345 //layer=ply \
 //thickness=0.18 //x=27.4 //y=1.09 //x2=27.4 //y2=1.435
r169 (  57 70 ) resistor r=10.701 //w=0.21 //l=0.115 //layer=ply \
 //thickness=0.18 //x=27.025 //y=1.59 //x2=26.91 //y2=1.59
r170 (  56 72 ) resistor r=5.52526 //w=0.168 //l=0.115 //layer=ply \
 //thickness=0.18 //x=27.245 //y=1.59 //x2=27.36 //y2=1.59
r171 (  55 69 ) resistor r=5.52526 //w=0.168 //l=0.115 //layer=ply \
 //thickness=0.18 //x=27.025 //y=0.935 //x2=26.91 //y2=0.935
r172 (  54 71 ) resistor r=5.52526 //w=0.168 //l=0.115 //layer=ply \
 //thickness=0.18 //x=27.245 //y=0.935 //x2=27.36 //y2=0.935
r173 (  54 55 ) resistor r=112.809 //w=0.094 //l=0.22 //layer=ply \
 //thickness=0.18 //x=27.245 //y=0.935 //x2=27.025 //y2=0.935
r174 (  52 59 ) resistor r=26.9307 //w=0.15 //l=0.106066 //layer=ply \
 //thickness=0.18 //x=27.28 //y=4.97 //x2=27.355 //y2=5.045
r175 (  52 53 ) resistor r=148.702 //w=0.094 //l=0.29 //layer=ply \
 //thickness=0.18 //x=27.28 //y=4.97 //x2=26.99 //y2=4.97
r176 (  49 53 ) resistor r=23.403 //w=0.284 //l=0.106066 //layer=ply \
 //thickness=0.18 //x=26.915 //y=5.045 //x2=26.99 //y2=4.97
r177 (  49 68 ) resistor r=26.3063 //w=0.284 //l=0.229783 //layer=ply \
 //thickness=0.18 //x=26.915 //y=5.045 //x2=26.76 //y2=4.88
r178 (  48 66 ) resistor r=19.1248 //w=0.302 //l=0.165 //layer=ply \
 //thickness=0.18 //x=26.87 //y=2.1 //x2=26.87 //y2=2.265
r179 (  47 70 ) resistor r=39.5823 //w=0.21 //l=0.173853 //layer=ply \
 //thickness=0.18 //x=26.87 //y=1.745 //x2=26.91 //y2=1.59
r180 (  47 48 ) resistor r=182.032 //w=0.094 //l=0.355 //layer=ply \
 //thickness=0.18 //x=26.87 //y=1.745 //x2=26.87 //y2=2.1
r181 (  46 70 ) resistor r=39.5823 //w=0.21 //l=0.173853 //layer=ply \
 //thickness=0.18 //x=26.87 //y=1.435 //x2=26.91 //y2=1.59
r182 (  45 69 ) resistor r=45.1352 //w=0.168 //l=0.173853 //layer=ply \
 //thickness=0.18 //x=26.87 //y=1.09 //x2=26.91 //y2=0.935
r183 (  45 46 ) resistor r=176.904 //w=0.094 //l=0.345 //layer=ply \
 //thickness=0.18 //x=26.87 //y=1.09 //x2=26.87 //y2=1.435
r184 (  44 59 ) resistor r=592.245 //w=0.094 //l=1.155 //layer=ply \
 //thickness=0.18 //x=27.355 //y=6.2 //x2=27.355 //y2=5.045
r185 (  43 49 ) resistor r=592.245 //w=0.094 //l=1.155 //layer=ply \
 //thickness=0.18 //x=26.915 //y=6.2 //x2=26.915 //y2=5.045
r186 (  42 56 ) resistor r=56.4043 //w=0.094 //l=0.11 //layer=ply \
 //thickness=0.18 //x=27.135 //y=1.59 //x2=27.245 //y2=1.59
r187 (  42 57 ) resistor r=56.4043 //w=0.094 //l=0.11 //layer=ply \
 //thickness=0.18 //x=27.135 //y=1.59 //x2=27.025 //y2=1.59
r188 (  39 68 ) resistor r=152 //w=0.17 //l=0.17 //layer=licon //count=1 \
 //x=26.76 //y=4.88 //x2=26.76 //y2=4.88
r189 (  37 39 ) resistor r=93.7754 //w=0.187 //l=1.37 //layer=li \
 //thickness=0.1 //x=26.76 //y=3.51 //x2=26.76 //y2=4.88
r190 (  34 65 ) resistor r=152 //w=0.17 //l=0.17 //layer=licon //count=1 \
 //x=26.76 //y=2.265 //x2=26.76 //y2=2.265
r191 (  34 37 ) resistor r=85.2193 //w=0.187 //l=1.245 //layer=li \
 //thickness=0.1 //x=26.76 //y=2.265 //x2=26.76 //y2=3.51
r192 (  30 32 ) resistor r=122.182 //w=0.187 //l=1.785 //layer=li \
 //thickness=0.1 //x=25.28 //y=5.295 //x2=25.28 //y2=3.51
r193 (  29 32 ) resistor r=108.834 //w=0.187 //l=1.59 //layer=li \
 //thickness=0.1 //x=25.28 //y=1.92 //x2=25.28 //y2=3.51
r194 (  27 29 ) resistor r=7.15173 //w=0.17 //l=0.120208 //layer=li \
 //thickness=0.1 //x=25.195 //y=1.835 //x2=25.28 //y2=1.92
r195 (  27 28 ) resistor r=18.4813 //w=0.187 //l=0.27 //layer=li \
 //thickness=0.1 //x=25.195 //y=1.835 //x2=24.925 //y2=1.835
r196 (  26 41 ) resistor r=5.4201 //w=0.17 //l=0.085 //layer=li \
 //thickness=0.1 //x=24.885 //y=5.38 //x2=24.8 //y2=5.38
r197 (  25 30 ) resistor r=7.15173 //w=0.17 //l=0.120208 //layer=li \
 //thickness=0.1 //x=25.195 //y=5.38 //x2=25.28 //y2=5.295
r198 (  25 26 ) resistor r=21.2193 //w=0.187 //l=0.31 //layer=li \
 //thickness=0.1 //x=25.195 //y=5.38 //x2=24.885 //y2=5.38
r199 (  21 28 ) resistor r=7.15173 //w=0.17 //l=0.120208 //layer=li \
 //thickness=0.1 //x=24.84 //y=1.75 //x2=24.925 //y2=1.835
r200 (  21 73 ) resistor r=39.016 //w=0.187 //l=0.57 //layer=li \
 //thickness=0.1 //x=24.84 //y=1.75 //x2=24.84 //y2=1.18
r201 (  15 41 ) resistor r=1.40859 //w=0.34 //l=0.085 //layer=li \
 //thickness=0.1 //x=24.8 //y=5.465 //x2=24.8 //y2=5.38
r202 (  15 76 ) resistor r=30.1176 //w=0.187 //l=0.44 //layer=li \
 //thickness=0.1 //x=24.8 //y=5.465 //x2=24.8 //y2=5.905
r203 (  13 41 ) resistor r=5.4201 //w=0.17 //l=0.085 //layer=li \
 //thickness=0.1 //x=24.715 //y=5.38 //x2=24.8 //y2=5.38
r204 (  13 14 ) resistor r=48.5989 //w=0.187 //l=0.71 //layer=li \
 //thickness=0.1 //x=24.715 //y=5.38 //x2=24.005 //y2=5.38
r205 (  7 14 ) resistor r=7.15173 //w=0.17 //l=0.120208 //layer=li \
 //thickness=0.1 //x=23.92 //y=5.465 //x2=24.005 //y2=5.38
r206 (  7 75 ) resistor r=30.1176 //w=0.187 //l=0.44 //layer=li \
 //thickness=0.1 //x=23.92 //y=5.465 //x2=23.92 //y2=5.905
r207 (  6 37 ) resistor r=9.3 //w=0.17 //l=0.17 //layer=mcon //count=1 \
 //x=26.76 //y=3.51 //x2=26.76 //y2=3.51
r208 (  4 32 ) resistor r=9.3 //w=0.17 //l=0.17 //layer=mcon //count=1 \
 //x=25.28 //y=3.51 //x2=25.28 //y2=3.51
r209 (  2 4 ) resistor r=0.0717383 //w=0.224 //l=0.115 //layer=m1 \
 //thickness=0.36 //x=25.395 //y=3.51 //x2=25.28 //y2=3.51
r210 (  1 6 ) resistor r=0.0717383 //w=0.224 //l=0.115 //layer=m1 \
 //thickness=0.36 //x=26.645 //y=3.51 //x2=26.76 //y2=3.51
r211 (  1 2 ) resistor r=1.19275 //w=0.131 //l=1.25 //layer=m1 \
 //thickness=0.36 //x=26.645 //y=3.51 //x2=25.395 //y2=3.51
ends PM_FA\%noxref_12

subckt PM_FA\%noxref_13 ( 1 2 13 14 25 27 28 32 34 41 42 43 44 45 46 47 48 52 \
 53 54 56 62 63 65 73 75 76 )
c142 ( 76 0 ) capacitor c=0.0220291f //x=30.205 //y=5.2
c143 ( 75 0 ) capacitor c=0.0217503f //x=29.325 //y=5.2
c144 ( 73 0 ) capacitor c=0.0084702f //x=30.2 //y=1.085
c145 ( 65 0 ) capacitor c=0.0511458f //x=32.31 //y=2.265
c146 ( 63 0 ) capacitor c=0.0435629f //x=32.95 //y=1.435
c147 ( 62 0 ) capacitor c=0.0200386f //x=32.95 //y=1.09
c148 ( 56 0 ) capacitor c=0.0152946f //x=32.795 //y=1.59
c149 ( 54 0 ) capacitor c=0.0157804f //x=32.795 //y=0.935
c150 ( 53 0 ) capacitor c=0.0524991f //x=32.54 //y=4.97
c151 ( 52 0 ) capacitor c=0.0323689f //x=32.83 //y=4.97
c152 ( 48 0 ) capacitor c=0.0290017f //x=32.42 //y=2.1
c153 ( 47 0 ) capacitor c=0.0250027f //x=32.42 //y=1.745
c154 ( 46 0 ) capacitor c=0.0234316f //x=32.42 //y=1.435
c155 ( 45 0 ) capacitor c=0.0200596f //x=32.42 //y=1.09
c156 ( 44 0 ) capacitor c=0.154218f //x=32.905 //y=6.2
c157 ( 43 0 ) capacitor c=0.154243f //x=32.465 //y=6.2
c158 ( 41 0 ) capacitor c=0.00279371f //x=30.35 //y=5.38
c159 ( 34 0 ) capacitor c=0.0918281f //x=32.31 //y=2.265
c160 ( 32 0 ) capacitor c=0.10823f //x=30.83 //y=3.51
c161 ( 28 0 ) capacitor c=0.00468667f //x=30.475 //y=1.835
c162 ( 27 0 ) capacitor c=0.0131863f //x=30.745 //y=1.835
c163 ( 25 0 ) capacitor c=0.0148609f //x=30.745 //y=5.38
c164 ( 14 0 ) capacitor c=0.0022661f //x=29.555 //y=5.38
c165 ( 13 0 ) capacitor c=0.0169929f //x=30.265 //y=5.38
c166 ( 2 0 ) capacitor c=0.0113927f //x=30.945 //y=3.51
c167 ( 1 0 ) capacitor c=0.0516026f //x=32.195 //y=3.51
r168 (  65 66 ) resistor r=17.5563 //w=0.302 //l=0.11 //layer=ply \
 //thickness=0.18 //x=32.31 //y=2.265 //x2=32.42 //y2=2.265
r169 (  63 72 ) resistor r=45.1352 //w=0.168 //l=0.173853 //layer=ply \
 //thickness=0.18 //x=32.95 //y=1.435 //x2=32.91 //y2=1.59
r170 (  62 71 ) resistor r=45.1352 //w=0.168 //l=0.173853 //layer=ply \
 //thickness=0.18 //x=32.95 //y=1.09 //x2=32.91 //y2=0.935
r171 (  62 63 ) resistor r=176.904 //w=0.094 //l=0.345 //layer=ply \
 //thickness=0.18 //x=32.95 //y=1.09 //x2=32.95 //y2=1.435
r172 (  57 70 ) resistor r=10.701 //w=0.21 //l=0.115 //layer=ply \
 //thickness=0.18 //x=32.575 //y=1.59 //x2=32.46 //y2=1.59
r173 (  56 72 ) resistor r=5.52526 //w=0.168 //l=0.115 //layer=ply \
 //thickness=0.18 //x=32.795 //y=1.59 //x2=32.91 //y2=1.59
r174 (  55 69 ) resistor r=5.52526 //w=0.168 //l=0.115 //layer=ply \
 //thickness=0.18 //x=32.575 //y=0.935 //x2=32.46 //y2=0.935
r175 (  54 71 ) resistor r=5.52526 //w=0.168 //l=0.115 //layer=ply \
 //thickness=0.18 //x=32.795 //y=0.935 //x2=32.91 //y2=0.935
r176 (  54 55 ) resistor r=112.809 //w=0.094 //l=0.22 //layer=ply \
 //thickness=0.18 //x=32.795 //y=0.935 //x2=32.575 //y2=0.935
r177 (  52 59 ) resistor r=26.9307 //w=0.15 //l=0.106066 //layer=ply \
 //thickness=0.18 //x=32.83 //y=4.97 //x2=32.905 //y2=5.045
r178 (  52 53 ) resistor r=148.702 //w=0.094 //l=0.29 //layer=ply \
 //thickness=0.18 //x=32.83 //y=4.97 //x2=32.54 //y2=4.97
r179 (  49 53 ) resistor r=23.403 //w=0.284 //l=0.106066 //layer=ply \
 //thickness=0.18 //x=32.465 //y=5.045 //x2=32.54 //y2=4.97
r180 (  49 68 ) resistor r=26.3063 //w=0.284 //l=0.229783 //layer=ply \
 //thickness=0.18 //x=32.465 //y=5.045 //x2=32.31 //y2=4.88
r181 (  48 66 ) resistor r=19.1248 //w=0.302 //l=0.165 //layer=ply \
 //thickness=0.18 //x=32.42 //y=2.1 //x2=32.42 //y2=2.265
r182 (  47 70 ) resistor r=39.5823 //w=0.21 //l=0.173853 //layer=ply \
 //thickness=0.18 //x=32.42 //y=1.745 //x2=32.46 //y2=1.59
r183 (  47 48 ) resistor r=182.032 //w=0.094 //l=0.355 //layer=ply \
 //thickness=0.18 //x=32.42 //y=1.745 //x2=32.42 //y2=2.1
r184 (  46 70 ) resistor r=39.5823 //w=0.21 //l=0.173853 //layer=ply \
 //thickness=0.18 //x=32.42 //y=1.435 //x2=32.46 //y2=1.59
r185 (  45 69 ) resistor r=45.1352 //w=0.168 //l=0.173853 //layer=ply \
 //thickness=0.18 //x=32.42 //y=1.09 //x2=32.46 //y2=0.935
r186 (  45 46 ) resistor r=176.904 //w=0.094 //l=0.345 //layer=ply \
 //thickness=0.18 //x=32.42 //y=1.09 //x2=32.42 //y2=1.435
r187 (  44 59 ) resistor r=592.245 //w=0.094 //l=1.155 //layer=ply \
 //thickness=0.18 //x=32.905 //y=6.2 //x2=32.905 //y2=5.045
r188 (  43 49 ) resistor r=592.245 //w=0.094 //l=1.155 //layer=ply \
 //thickness=0.18 //x=32.465 //y=6.2 //x2=32.465 //y2=5.045
r189 (  42 56 ) resistor r=56.4043 //w=0.094 //l=0.11 //layer=ply \
 //thickness=0.18 //x=32.685 //y=1.59 //x2=32.795 //y2=1.59
r190 (  42 57 ) resistor r=56.4043 //w=0.094 //l=0.11 //layer=ply \
 //thickness=0.18 //x=32.685 //y=1.59 //x2=32.575 //y2=1.59
r191 (  39 68 ) resistor r=152 //w=0.17 //l=0.17 //layer=licon //count=1 \
 //x=32.31 //y=4.88 //x2=32.31 //y2=4.88
r192 (  37 39 ) resistor r=93.7754 //w=0.187 //l=1.37 //layer=li \
 //thickness=0.1 //x=32.31 //y=3.51 //x2=32.31 //y2=4.88
r193 (  34 65 ) resistor r=152 //w=0.17 //l=0.17 //layer=licon //count=1 \
 //x=32.31 //y=2.265 //x2=32.31 //y2=2.265
r194 (  34 37 ) resistor r=85.2193 //w=0.187 //l=1.245 //layer=li \
 //thickness=0.1 //x=32.31 //y=2.265 //x2=32.31 //y2=3.51
r195 (  30 32 ) resistor r=122.182 //w=0.187 //l=1.785 //layer=li \
 //thickness=0.1 //x=30.83 //y=5.295 //x2=30.83 //y2=3.51
r196 (  29 32 ) resistor r=108.834 //w=0.187 //l=1.59 //layer=li \
 //thickness=0.1 //x=30.83 //y=1.92 //x2=30.83 //y2=3.51
r197 (  27 29 ) resistor r=7.15173 //w=0.17 //l=0.120208 //layer=li \
 //thickness=0.1 //x=30.745 //y=1.835 //x2=30.83 //y2=1.92
r198 (  27 28 ) resistor r=18.4813 //w=0.187 //l=0.27 //layer=li \
 //thickness=0.1 //x=30.745 //y=1.835 //x2=30.475 //y2=1.835
r199 (  26 41 ) resistor r=5.4201 //w=0.17 //l=0.085 //layer=li \
 //thickness=0.1 //x=30.435 //y=5.38 //x2=30.35 //y2=5.38
r200 (  25 30 ) resistor r=7.15173 //w=0.17 //l=0.120208 //layer=li \
 //thickness=0.1 //x=30.745 //y=5.38 //x2=30.83 //y2=5.295
r201 (  25 26 ) resistor r=21.2193 //w=0.187 //l=0.31 //layer=li \
 //thickness=0.1 //x=30.745 //y=5.38 //x2=30.435 //y2=5.38
r202 (  21 28 ) resistor r=7.15173 //w=0.17 //l=0.120208 //layer=li \
 //thickness=0.1 //x=30.39 //y=1.75 //x2=30.475 //y2=1.835
r203 (  21 73 ) resistor r=39.016 //w=0.187 //l=0.57 //layer=li \
 //thickness=0.1 //x=30.39 //y=1.75 //x2=30.39 //y2=1.18
r204 (  15 41 ) resistor r=1.40859 //w=0.34 //l=0.085 //layer=li \
 //thickness=0.1 //x=30.35 //y=5.465 //x2=30.35 //y2=5.38
r205 (  15 76 ) resistor r=30.1176 //w=0.187 //l=0.44 //layer=li \
 //thickness=0.1 //x=30.35 //y=5.465 //x2=30.35 //y2=5.905
r206 (  13 41 ) resistor r=5.4201 //w=0.17 //l=0.085 //layer=li \
 //thickness=0.1 //x=30.265 //y=5.38 //x2=30.35 //y2=5.38
r207 (  13 14 ) resistor r=48.5989 //w=0.187 //l=0.71 //layer=li \
 //thickness=0.1 //x=30.265 //y=5.38 //x2=29.555 //y2=5.38
r208 (  7 14 ) resistor r=7.15173 //w=0.17 //l=0.120208 //layer=li \
 //thickness=0.1 //x=29.47 //y=5.465 //x2=29.555 //y2=5.38
r209 (  7 75 ) resistor r=30.1176 //w=0.187 //l=0.44 //layer=li \
 //thickness=0.1 //x=29.47 //y=5.465 //x2=29.47 //y2=5.905
r210 (  6 37 ) resistor r=9.3 //w=0.17 //l=0.17 //layer=mcon //count=1 \
 //x=32.31 //y=3.51 //x2=32.31 //y2=3.51
r211 (  4 32 ) resistor r=9.3 //w=0.17 //l=0.17 //layer=mcon //count=1 \
 //x=30.83 //y=3.51 //x2=30.83 //y2=3.51
r212 (  2 4 ) resistor r=0.0717383 //w=0.224 //l=0.115 //layer=m1 \
 //thickness=0.36 //x=30.945 //y=3.51 //x2=30.83 //y2=3.51
r213 (  1 6 ) resistor r=0.0717383 //w=0.224 //l=0.115 //layer=m1 \
 //thickness=0.36 //x=32.195 //y=3.51 //x2=32.31 //y2=3.51
r214 (  1 2 ) resistor r=1.19275 //w=0.131 //l=1.25 //layer=m1 \
 //thickness=0.36 //x=32.195 //y=3.51 //x2=30.945 //y2=3.51
ends PM_FA\%noxref_13

subckt PM_FA\%noxref_14 ( 1 2 17 18 19 20 24 27 32 34 35 36 37 38 39 40 44 46 \
 49 51 52 57 67 69 )
c165 ( 69 0 ) capacitor c=0.0279852f //x=26.99 //y=5.2
c166 ( 67 0 ) capacitor c=0.016967f //x=26.945 //y=1.09
c167 ( 57 0 ) capacitor c=0.0422106f //x=34.745 //y=4.885
c168 ( 52 0 ) capacitor c=0.0321911f //x=35.235 //y=1.43
c169 ( 51 0 ) capacitor c=0.0185201f //x=35.235 //y=1.085
c170 ( 49 0 ) capacitor c=0.0344254f //x=35.165 //y=4.975
c171 ( 46 0 ) capacitor c=0.0133656f //x=35.08 //y=1.585
c172 ( 44 0 ) capacitor c=0.0157804f //x=35.08 //y=0.93
c173 ( 40 0 ) capacitor c=0.0788505f //x=34.705 //y=2.095
c174 ( 39 0 ) capacitor c=0.022867f //x=34.705 //y=1.74
c175 ( 38 0 ) capacitor c=0.0234318f //x=34.705 //y=1.43
c176 ( 37 0 ) capacitor c=0.0192004f //x=34.705 //y=1.085
c177 ( 36 0 ) capacitor c=0.110795f //x=35.24 //y=6.205
c178 ( 35 0 ) capacitor c=0.153847f //x=34.8 //y=6.205
c179 ( 32 0 ) capacitor c=0.00993392f //x=34.745 //y=4.885
c180 ( 27 0 ) capacitor c=0.0921769f //x=34.9 //y=2.26
c181 ( 24 0 ) capacitor c=0.0882674f //x=27.5 //y=3.14
c182 ( 20 0 ) capacitor c=0.00573423f //x=27.22 //y=4.76
c183 ( 19 0 ) capacitor c=0.0118959f //x=27.415 //y=4.76
c184 ( 18 0 ) capacitor c=0.00630489f //x=27.215 //y=2.26
c185 ( 17 0 ) capacitor c=0.012513f //x=27.415 //y=2.26
c186 ( 2 0 ) capacitor c=0.0155528f //x=27.615 //y=3.14
c187 ( 1 0 ) capacitor c=0.23241f //x=34.785 //y=3.14
r188 (  59 60 ) resistor r=32.4568 //w=0.214 //l=0.075 //layer=ply \
 //thickness=0.18 //x=34.745 //y=4.975 //x2=34.745 //y2=5.05
r189 (  57 59 ) resistor r=20.271 //w=0.214 //l=0.09 //layer=ply \
 //thickness=0.18 //x=34.745 //y=4.885 //x2=34.745 //y2=4.975
r190 (  52 66 ) resistor r=45.1352 //w=0.168 //l=0.173853 //layer=ply \
 //thickness=0.18 //x=35.235 //y=1.43 //x2=35.195 //y2=1.585
r191 (  51 65 ) resistor r=45.1352 //w=0.168 //l=0.173853 //layer=ply \
 //thickness=0.18 //x=35.235 //y=1.085 //x2=35.195 //y2=0.93
r192 (  51 52 ) resistor r=176.904 //w=0.094 //l=0.345 //layer=ply \
 //thickness=0.18 //x=35.235 //y=1.085 //x2=35.235 //y2=1.43
r193 (  50 59 ) resistor r=16.5046 //w=0.27 //l=0.135 //layer=ply \
 //thickness=0.18 //x=34.88 //y=4.975 //x2=34.745 //y2=4.975
r194 (  49 53 ) resistor r=26.9307 //w=0.15 //l=0.106066 //layer=ply \
 //thickness=0.18 //x=35.165 //y=4.975 //x2=35.24 //y2=5.05
r195 (  49 50 ) resistor r=146.138 //w=0.094 //l=0.285 //layer=ply \
 //thickness=0.18 //x=35.165 //y=4.975 //x2=34.88 //y2=4.975
r196 (  47 64 ) resistor r=10.701 //w=0.21 //l=0.115 //layer=ply \
 //thickness=0.18 //x=34.86 //y=1.585 //x2=34.745 //y2=1.585
r197 (  46 66 ) resistor r=5.52526 //w=0.168 //l=0.115 //layer=ply \
 //thickness=0.18 //x=35.08 //y=1.585 //x2=35.195 //y2=1.585
r198 (  45 63 ) resistor r=5.52526 //w=0.168 //l=0.115 //layer=ply \
 //thickness=0.18 //x=34.86 //y=0.93 //x2=34.745 //y2=0.93
r199 (  44 65 ) resistor r=5.52526 //w=0.168 //l=0.115 //layer=ply \
 //thickness=0.18 //x=35.08 //y=0.93 //x2=35.195 //y2=0.93
r200 (  44 45 ) resistor r=112.809 //w=0.094 //l=0.22 //layer=ply \
 //thickness=0.18 //x=35.08 //y=0.93 //x2=34.86 //y2=0.93
r201 (  40 62 ) resistor r=34.8111 //w=0.27 //l=0.264953 //layer=ply \
 //thickness=0.18 //x=34.705 //y=2.095 //x2=34.9 //y2=2.26
r202 (  39 64 ) resistor r=39.5823 //w=0.21 //l=0.173853 //layer=ply \
 //thickness=0.18 //x=34.705 //y=1.74 //x2=34.745 //y2=1.585
r203 (  39 40 ) resistor r=182.032 //w=0.094 //l=0.355 //layer=ply \
 //thickness=0.18 //x=34.705 //y=1.74 //x2=34.705 //y2=2.095
r204 (  38 64 ) resistor r=39.5823 //w=0.21 //l=0.173853 //layer=ply \
 //thickness=0.18 //x=34.705 //y=1.43 //x2=34.745 //y2=1.585
r205 (  37 63 ) resistor r=45.1352 //w=0.168 //l=0.173853 //layer=ply \
 //thickness=0.18 //x=34.705 //y=1.085 //x2=34.745 //y2=0.93
r206 (  37 38 ) resistor r=176.904 //w=0.094 //l=0.345 //layer=ply \
 //thickness=0.18 //x=34.705 //y=1.085 //x2=34.705 //y2=1.43
r207 (  36 53 ) resistor r=592.245 //w=0.094 //l=1.155 //layer=ply \
 //thickness=0.18 //x=35.24 //y=6.205 //x2=35.24 //y2=5.05
r208 (  35 60 ) resistor r=592.245 //w=0.094 //l=1.155 //layer=ply \
 //thickness=0.18 //x=34.8 //y=6.205 //x2=34.8 //y2=5.05
r209 (  34 46 ) resistor r=56.4043 //w=0.094 //l=0.11 //layer=ply \
 //thickness=0.18 //x=34.97 //y=1.585 //x2=35.08 //y2=1.585
r210 (  34 47 ) resistor r=56.4043 //w=0.094 //l=0.11 //layer=ply \
 //thickness=0.18 //x=34.97 //y=1.585 //x2=34.86 //y2=1.585
r211 (  32 57 ) resistor r=152 //w=0.17 //l=0.17 //layer=licon //count=1 \
 //x=34.745 //y=4.885 //x2=34.745 //y2=4.885
r212 (  32 33 ) resistor r=7.81102 //w=0.254 //l=0.155 //layer=li \
 //thickness=0.1 //x=34.745 //y=4.885 //x2=34.9 //y2=4.885
r213 (  27 62 ) resistor r=152 //w=0.17 //l=0.17 //layer=licon //count=1 \
 //x=34.9 //y=2.26 //x2=34.9 //y2=2.26
r214 (  27 30 ) resistor r=60.2353 //w=0.187 //l=0.88 //layer=li \
 //thickness=0.1 //x=34.9 //y=2.26 //x2=34.9 //y2=3.14
r215 (  25 33 ) resistor r=3.23951 //w=0.254 //l=0.165 //layer=li \
 //thickness=0.1 //x=34.9 //y=4.72 //x2=34.9 //y2=4.885
r216 (  25 30 ) resistor r=108.15 //w=0.187 //l=1.58 //layer=li \
 //thickness=0.1 //x=34.9 //y=4.72 //x2=34.9 //y2=3.14
r217 (  22 24 ) resistor r=105.07 //w=0.187 //l=1.535 //layer=li \
 //thickness=0.1 //x=27.5 //y=4.675 //x2=27.5 //y2=3.14
r218 (  21 24 ) resistor r=54.4171 //w=0.187 //l=0.795 //layer=li \
 //thickness=0.1 //x=27.5 //y=2.345 //x2=27.5 //y2=3.14
r219 (  19 22 ) resistor r=7.15173 //w=0.17 //l=0.120208 //layer=li \
 //thickness=0.1 //x=27.415 //y=4.76 //x2=27.5 //y2=4.675
r220 (  19 20 ) resistor r=13.3476 //w=0.187 //l=0.195 //layer=li \
 //thickness=0.1 //x=27.415 //y=4.76 //x2=27.22 //y2=4.76
r221 (  17 21 ) resistor r=7.15173 //w=0.17 //l=0.120208 //layer=li \
 //thickness=0.1 //x=27.415 //y=2.26 //x2=27.5 //y2=2.345
r222 (  17 18 ) resistor r=13.6898 //w=0.187 //l=0.2 //layer=li \
 //thickness=0.1 //x=27.415 //y=2.26 //x2=27.215 //y2=2.26
r223 (  11 20 ) resistor r=7.15173 //w=0.17 //l=0.120208 //layer=li \
 //thickness=0.1 //x=27.135 //y=4.845 //x2=27.22 //y2=4.76
r224 (  11 69 ) resistor r=72.5562 //w=0.187 //l=1.06 //layer=li \
 //thickness=0.1 //x=27.135 //y=4.845 //x2=27.135 //y2=5.905
r225 (  7 18 ) resistor r=7.15173 //w=0.17 //l=0.120208 //layer=li \
 //thickness=0.1 //x=27.13 //y=2.175 //x2=27.215 //y2=2.26
r226 (  7 67 ) resistor r=67.7647 //w=0.187 //l=0.99 //layer=li \
 //thickness=0.1 //x=27.13 //y=2.175 //x2=27.13 //y2=1.185
r227 (  6 30 ) resistor r=9.3 //w=0.17 //l=0.17 //layer=mcon //count=1 \
 //x=34.9 //y=3.14 //x2=34.9 //y2=3.14
r228 (  4 24 ) resistor r=9.3 //w=0.17 //l=0.17 //layer=mcon //count=1 \
 //x=27.5 //y=3.14 //x2=27.5 //y2=3.14
r229 (  2 4 ) resistor r=0.0717383 //w=0.224 //l=0.115 //layer=m1 \
 //thickness=0.36 //x=27.615 //y=3.14 //x2=27.5 //y2=3.14
r230 (  1 6 ) resistor r=0.0717383 //w=0.224 //l=0.115 //layer=m1 \
 //thickness=0.36 //x=34.785 //y=3.14 //x2=34.9 //y2=3.14
r231 (  1 2 ) resistor r=6.8416 //w=0.131 //l=7.17 //layer=m1 //thickness=0.36 \
 //x=34.785 //y=3.14 //x2=27.615 //y2=3.14
ends PM_FA\%noxref_14

subckt PM_FA\%noxref_15 ( 1 2 17 18 19 20 24 25 27 33 34 35 36 37 38 43 45 47 \
 53 54 56 57 60 68 70 )
c137 ( 70 0 ) capacitor c=0.0288456f //x=32.54 //y=5.2
c138 ( 68 0 ) capacitor c=0.0172738f //x=32.495 //y=1.09
c139 ( 60 0 ) capacitor c=0.0369822f //x=35.675 //y=4.885
c140 ( 57 0 ) capacitor c=0.0279572f //x=35.64 //y=2.095
c141 ( 56 0 ) capacitor c=0.0413537f //x=35.64 //y=2.26
c142 ( 54 0 ) capacitor c=0.0237734f //x=36.205 //y=1.435
c143 ( 53 0 ) capacitor c=0.0191782f //x=36.205 //y=1.085
c144 ( 47 0 ) capacitor c=0.0346941f //x=36.05 //y=1.585
c145 ( 45 0 ) capacitor c=0.0157803f //x=36.05 //y=0.93
c146 ( 43 0 ) capacitor c=0.0360787f //x=36.045 //y=4.975
c147 ( 38 0 ) capacitor c=0.0199921f //x=35.675 //y=1.74
c148 ( 37 0 ) capacitor c=0.0169608f //x=35.675 //y=1.435
c149 ( 36 0 ) capacitor c=0.0185462f //x=35.675 //y=1.085
c150 ( 35 0 ) capacitor c=0.15325f //x=36.12 //y=6.205
c151 ( 34 0 ) capacitor c=0.110232f //x=35.68 //y=6.205
c152 ( 27 0 ) capacitor c=0.0785323f //x=35.64 //y=2.26
c153 ( 25 0 ) capacitor c=0.00515516f //x=35.64 //y=4.72
c154 ( 24 0 ) capacitor c=0.0863121f //x=33.05 //y=3.51
c155 ( 20 0 ) capacitor c=0.00558395f //x=32.77 //y=4.76
c156 ( 19 0 ) capacitor c=0.0134399f //x=32.965 //y=4.76
c157 ( 18 0 ) capacitor c=0.00547024f //x=32.765 //y=2.26
c158 ( 17 0 ) capacitor c=0.013178f //x=32.965 //y=2.26
c159 ( 2 0 ) capacitor c=0.00731142f //x=33.165 //y=3.51
c160 ( 1 0 ) capacitor c=0.091903f //x=35.525 //y=3.51
r161 (  62 63 ) resistor r=32.4568 //w=0.214 //l=0.075 //layer=ply \
 //thickness=0.18 //x=35.675 //y=4.975 //x2=35.675 //y2=5.05
r162 (  60 62 ) resistor r=20.271 //w=0.214 //l=0.09 //layer=ply \
 //thickness=0.18 //x=35.675 //y=4.885 //x2=35.675 //y2=4.975
r163 (  56 57 ) resistor r=52.7279 //w=0.214 //l=0.165 //layer=ply \
 //thickness=0.18 //x=35.64 //y=2.26 //x2=35.64 //y2=2.095
r164 (  54 67 ) resistor r=4.95774 //w=0.164 //l=0.112 //layer=ply \
 //thickness=0.18 //x=36.205 //y=1.435 //x2=36.205 //y2=1.547
r165 (  53 66 ) resistor r=45.1352 //w=0.168 //l=0.173853 //layer=ply \
 //thickness=0.18 //x=36.205 //y=1.085 //x2=36.165 //y2=0.93
r166 (  53 54 ) resistor r=179.468 //w=0.094 //l=0.35 //layer=ply \
 //thickness=0.18 //x=36.205 //y=1.085 //x2=36.205 //y2=1.435
r167 (  48 65 ) resistor r=10.8103 //w=0.211 //l=0.115 //layer=ply \
 //thickness=0.18 //x=35.83 //y=1.585 //x2=35.715 //y2=1.585
r168 (  47 67 ) resistor r=45.9962 //w=0.164 //l=0.17296 //layer=ply \
 //thickness=0.18 //x=36.05 //y=1.585 //x2=36.205 //y2=1.547
r169 (  46 64 ) resistor r=5.52526 //w=0.168 //l=0.115 //layer=ply \
 //thickness=0.18 //x=35.83 //y=0.93 //x2=35.715 //y2=0.93
r170 (  45 66 ) resistor r=5.52526 //w=0.168 //l=0.115 //layer=ply \
 //thickness=0.18 //x=36.05 //y=0.93 //x2=36.165 //y2=0.93
r171 (  45 46 ) resistor r=112.809 //w=0.094 //l=0.22 //layer=ply \
 //thickness=0.18 //x=36.05 //y=0.93 //x2=35.83 //y2=0.93
r172 (  44 62 ) resistor r=16.5046 //w=0.27 //l=0.135 //layer=ply \
 //thickness=0.18 //x=35.81 //y=4.975 //x2=35.675 //y2=4.975
r173 (  43 50 ) resistor r=26.9307 //w=0.15 //l=0.106066 //layer=ply \
 //thickness=0.18 //x=36.045 //y=4.975 //x2=36.12 //y2=5.05
r174 (  43 44 ) resistor r=120.5 //w=0.094 //l=0.235 //layer=ply \
 //thickness=0.18 //x=36.045 //y=4.975 //x2=35.81 //y2=4.975
r175 (  38 65 ) resistor r=39.5036 //w=0.211 //l=0.173853 //layer=ply \
 //thickness=0.18 //x=35.675 //y=1.74 //x2=35.715 //y2=1.585
r176 (  38 57 ) resistor r=182.032 //w=0.094 //l=0.355 //layer=ply \
 //thickness=0.18 //x=35.675 //y=1.74 //x2=35.675 //y2=2.095
r177 (  37 65 ) resistor r=38.3614 //w=0.211 //l=0.168819 //layer=ply \
 //thickness=0.18 //x=35.675 //y=1.435 //x2=35.715 //y2=1.585
r178 (  36 64 ) resistor r=45.1352 //w=0.168 //l=0.173853 //layer=ply \
 //thickness=0.18 //x=35.675 //y=1.085 //x2=35.715 //y2=0.93
r179 (  36 37 ) resistor r=179.468 //w=0.094 //l=0.35 //layer=ply \
 //thickness=0.18 //x=35.675 //y=1.085 //x2=35.675 //y2=1.435
r180 (  35 50 ) resistor r=592.245 //w=0.094 //l=1.155 //layer=ply \
 //thickness=0.18 //x=36.12 //y=6.205 //x2=36.12 //y2=5.05
r181 (  34 63 ) resistor r=592.245 //w=0.094 //l=1.155 //layer=ply \
 //thickness=0.18 //x=35.68 //y=6.205 //x2=35.68 //y2=5.05
r182 (  33 47 ) resistor r=56.4043 //w=0.094 //l=0.11 //layer=ply \
 //thickness=0.18 //x=35.94 //y=1.585 //x2=36.05 //y2=1.585
r183 (  33 48 ) resistor r=56.4043 //w=0.094 //l=0.11 //layer=ply \
 //thickness=0.18 //x=35.94 //y=1.585 //x2=35.83 //y2=1.585
r184 (  32 60 ) resistor r=152 //w=0.17 //l=0.17 //layer=licon //count=1 \
 //x=35.675 //y=4.885 //x2=35.675 //y2=4.885
r185 (  27 56 ) resistor r=152 //w=0.17 //l=0.17 //layer=licon //count=1 \
 //x=35.64 //y=2.26 //x2=35.64 //y2=2.26
r186 (  27 30 ) resistor r=85.5615 //w=0.187 //l=1.25 //layer=li \
 //thickness=0.1 //x=35.64 //y=2.26 //x2=35.64 //y2=3.51
r187 (  25 32 ) resistor r=11.332 //w=0.189 //l=0.173292 //layer=li \
 //thickness=0.1 //x=35.64 //y=4.72 //x2=35.657 //y2=4.885
r188 (  25 30 ) resistor r=82.8235 //w=0.187 //l=1.21 //layer=li \
 //thickness=0.1 //x=35.64 //y=4.72 //x2=35.64 //y2=3.51
r189 (  22 24 ) resistor r=79.7433 //w=0.187 //l=1.165 //layer=li \
 //thickness=0.1 //x=33.05 //y=4.675 //x2=33.05 //y2=3.51
r190 (  21 24 ) resistor r=79.7433 //w=0.187 //l=1.165 //layer=li \
 //thickness=0.1 //x=33.05 //y=2.345 //x2=33.05 //y2=3.51
r191 (  19 22 ) resistor r=7.15173 //w=0.17 //l=0.120208 //layer=li \
 //thickness=0.1 //x=32.965 //y=4.76 //x2=33.05 //y2=4.675
r192 (  19 20 ) resistor r=13.3476 //w=0.187 //l=0.195 //layer=li \
 //thickness=0.1 //x=32.965 //y=4.76 //x2=32.77 //y2=4.76
r193 (  17 21 ) resistor r=7.15173 //w=0.17 //l=0.120208 //layer=li \
 //thickness=0.1 //x=32.965 //y=2.26 //x2=33.05 //y2=2.345
r194 (  17 18 ) resistor r=13.6898 //w=0.187 //l=0.2 //layer=li \
 //thickness=0.1 //x=32.965 //y=2.26 //x2=32.765 //y2=2.26
r195 (  11 20 ) resistor r=7.15173 //w=0.17 //l=0.120208 //layer=li \
 //thickness=0.1 //x=32.685 //y=4.845 //x2=32.77 //y2=4.76
r196 (  11 70 ) resistor r=72.5562 //w=0.187 //l=1.06 //layer=li \
 //thickness=0.1 //x=32.685 //y=4.845 //x2=32.685 //y2=5.905
r197 (  7 18 ) resistor r=7.15173 //w=0.17 //l=0.120208 //layer=li \
 //thickness=0.1 //x=32.68 //y=2.175 //x2=32.765 //y2=2.26
r198 (  7 68 ) resistor r=67.7647 //w=0.187 //l=0.99 //layer=li \
 //thickness=0.1 //x=32.68 //y=2.175 //x2=32.68 //y2=1.185
r199 (  6 30 ) resistor r=9.3 //w=0.17 //l=0.17 //layer=mcon //count=1 \
 //x=35.64 //y=3.51 //x2=35.64 //y2=3.51
r200 (  4 24 ) resistor r=9.3 //w=0.17 //l=0.17 //layer=mcon //count=1 \
 //x=33.05 //y=3.51 //x2=33.05 //y2=3.51
r201 (  2 4 ) resistor r=0.0717383 //w=0.224 //l=0.115 //layer=m1 \
 //thickness=0.36 //x=33.165 //y=3.51 //x2=33.05 //y2=3.51
r202 (  1 6 ) resistor r=0.0717383 //w=0.224 //l=0.115 //layer=m1 \
 //thickness=0.36 //x=35.525 //y=3.51 //x2=35.64 //y2=3.51
r203 (  1 2 ) resistor r=2.25191 //w=0.131 //l=2.36 //layer=m1 \
 //thickness=0.36 //x=35.525 //y=3.51 //x2=33.165 //y2=3.51
ends PM_FA\%noxref_15

subckt PM_FA\%noxref_16 ( 1 2 11 12 23 24 25 30 32 40 41 42 43 44 45 46 50 51 \
 52 54 60 61 63 71 72 75 )
c140 ( 75 0 ) capacitor c=0.0159573f //x=35.755 //y=5.205
c141 ( 72 0 ) capacitor c=0.00905936f //x=35.75 //y=1.085
c142 ( 71 0 ) capacitor c=0.007684f //x=34.78 //y=1.085
c143 ( 63 0 ) capacitor c=0.0528806f //x=37.86 //y=2.265
c144 ( 61 0 ) capacitor c=0.0435629f //x=38.5 //y=1.435
c145 ( 60 0 ) capacitor c=0.0200386f //x=38.5 //y=1.09
c146 ( 54 0 ) capacitor c=0.0152946f //x=38.345 //y=1.59
c147 ( 52 0 ) capacitor c=0.0157804f //x=38.345 //y=0.935
c148 ( 51 0 ) capacitor c=0.0524991f //x=38.09 //y=4.97
c149 ( 50 0 ) capacitor c=0.0322983f //x=38.38 //y=4.97
c150 ( 46 0 ) capacitor c=0.0290017f //x=37.97 //y=2.1
c151 ( 45 0 ) capacitor c=0.0250027f //x=37.97 //y=1.745
c152 ( 44 0 ) capacitor c=0.0234316f //x=37.97 //y=1.435
c153 ( 43 0 ) capacitor c=0.0200596f //x=37.97 //y=1.09
c154 ( 42 0 ) capacitor c=0.154218f //x=38.455 //y=6.2
c155 ( 41 0 ) capacitor c=0.154243f //x=38.015 //y=6.2
c156 ( 39 0 ) capacitor c=0.00710337f //x=35.94 //y=1.835
c157 ( 32 0 ) capacitor c=0.0944546f //x=37.86 //y=2.265
c158 ( 30 0 ) capacitor c=0.112585f //x=36.38 //y=3.51
c159 ( 25 0 ) capacitor c=0.0162468f //x=36.295 //y=1.835
c160 ( 24 0 ) capacitor c=0.00499395f //x=35.985 //y=5.39
c161 ( 23 0 ) capacitor c=0.0155365f //x=36.295 //y=5.39
c162 ( 12 0 ) capacitor c=0.00210564f //x=35.055 //y=1.835
c163 ( 11 0 ) capacitor c=0.0217261f //x=35.855 //y=1.835
c164 ( 2 0 ) capacitor c=0.00861659f //x=36.495 //y=3.51
c165 ( 1 0 ) capacitor c=0.080232f //x=37.745 //y=3.51
r166 (  63 64 ) resistor r=17.5563 //w=0.302 //l=0.11 //layer=ply \
 //thickness=0.18 //x=37.86 //y=2.265 //x2=37.97 //y2=2.265
r167 (  61 70 ) resistor r=45.1352 //w=0.168 //l=0.173853 //layer=ply \
 //thickness=0.18 //x=38.5 //y=1.435 //x2=38.46 //y2=1.59
r168 (  60 69 ) resistor r=45.1352 //w=0.168 //l=0.173853 //layer=ply \
 //thickness=0.18 //x=38.5 //y=1.09 //x2=38.46 //y2=0.935
r169 (  60 61 ) resistor r=176.904 //w=0.094 //l=0.345 //layer=ply \
 //thickness=0.18 //x=38.5 //y=1.09 //x2=38.5 //y2=1.435
r170 (  55 68 ) resistor r=10.701 //w=0.21 //l=0.115 //layer=ply \
 //thickness=0.18 //x=38.125 //y=1.59 //x2=38.01 //y2=1.59
r171 (  54 70 ) resistor r=5.52526 //w=0.168 //l=0.115 //layer=ply \
 //thickness=0.18 //x=38.345 //y=1.59 //x2=38.46 //y2=1.59
r172 (  53 67 ) resistor r=5.52526 //w=0.168 //l=0.115 //layer=ply \
 //thickness=0.18 //x=38.125 //y=0.935 //x2=38.01 //y2=0.935
r173 (  52 69 ) resistor r=5.52526 //w=0.168 //l=0.115 //layer=ply \
 //thickness=0.18 //x=38.345 //y=0.935 //x2=38.46 //y2=0.935
r174 (  52 53 ) resistor r=112.809 //w=0.094 //l=0.22 //layer=ply \
 //thickness=0.18 //x=38.345 //y=0.935 //x2=38.125 //y2=0.935
r175 (  50 57 ) resistor r=26.9307 //w=0.15 //l=0.106066 //layer=ply \
 //thickness=0.18 //x=38.38 //y=4.97 //x2=38.455 //y2=5.045
r176 (  50 51 ) resistor r=148.702 //w=0.094 //l=0.29 //layer=ply \
 //thickness=0.18 //x=38.38 //y=4.97 //x2=38.09 //y2=4.97
r177 (  47 51 ) resistor r=23.403 //w=0.284 //l=0.106066 //layer=ply \
 //thickness=0.18 //x=38.015 //y=5.045 //x2=38.09 //y2=4.97
r178 (  47 66 ) resistor r=26.3063 //w=0.284 //l=0.229783 //layer=ply \
 //thickness=0.18 //x=38.015 //y=5.045 //x2=37.86 //y2=4.88
r179 (  46 64 ) resistor r=19.1248 //w=0.302 //l=0.165 //layer=ply \
 //thickness=0.18 //x=37.97 //y=2.1 //x2=37.97 //y2=2.265
r180 (  45 68 ) resistor r=39.5823 //w=0.21 //l=0.173853 //layer=ply \
 //thickness=0.18 //x=37.97 //y=1.745 //x2=38.01 //y2=1.59
r181 (  45 46 ) resistor r=182.032 //w=0.094 //l=0.355 //layer=ply \
 //thickness=0.18 //x=37.97 //y=1.745 //x2=37.97 //y2=2.1
r182 (  44 68 ) resistor r=39.5823 //w=0.21 //l=0.173853 //layer=ply \
 //thickness=0.18 //x=37.97 //y=1.435 //x2=38.01 //y2=1.59
r183 (  43 67 ) resistor r=45.1352 //w=0.168 //l=0.173853 //layer=ply \
 //thickness=0.18 //x=37.97 //y=1.09 //x2=38.01 //y2=0.935
r184 (  43 44 ) resistor r=176.904 //w=0.094 //l=0.345 //layer=ply \
 //thickness=0.18 //x=37.97 //y=1.09 //x2=37.97 //y2=1.435
r185 (  42 57 ) resistor r=592.245 //w=0.094 //l=1.155 //layer=ply \
 //thickness=0.18 //x=38.455 //y=6.2 //x2=38.455 //y2=5.045
r186 (  41 47 ) resistor r=592.245 //w=0.094 //l=1.155 //layer=ply \
 //thickness=0.18 //x=38.015 //y=6.2 //x2=38.015 //y2=5.045
r187 (  40 54 ) resistor r=56.4043 //w=0.094 //l=0.11 //layer=ply \
 //thickness=0.18 //x=38.235 //y=1.59 //x2=38.345 //y2=1.59
r188 (  40 55 ) resistor r=56.4043 //w=0.094 //l=0.11 //layer=ply \
 //thickness=0.18 //x=38.235 //y=1.59 //x2=38.125 //y2=1.59
r189 (  37 66 ) resistor r=152 //w=0.17 //l=0.17 //layer=licon //count=1 \
 //x=37.86 //y=4.88 //x2=37.86 //y2=4.88
r190 (  35 37 ) resistor r=93.7754 //w=0.187 //l=1.37 //layer=li \
 //thickness=0.1 //x=37.86 //y=3.51 //x2=37.86 //y2=4.88
r191 (  32 63 ) resistor r=152 //w=0.17 //l=0.17 //layer=licon //count=1 \
 //x=37.86 //y=2.265 //x2=37.86 //y2=2.265
r192 (  32 35 ) resistor r=85.2193 //w=0.187 //l=1.245 //layer=li \
 //thickness=0.1 //x=37.86 //y=2.265 //x2=37.86 //y2=3.51
r193 (  28 30 ) resistor r=122.866 //w=0.187 //l=1.795 //layer=li \
 //thickness=0.1 //x=36.38 //y=5.305 //x2=36.38 //y2=3.51
r194 (  27 30 ) resistor r=108.834 //w=0.187 //l=1.59 //layer=li \
 //thickness=0.1 //x=36.38 //y=1.92 //x2=36.38 //y2=3.51
r195 (  26 39 ) resistor r=5.4201 //w=0.17 //l=0.085 //layer=li \
 //thickness=0.1 //x=36.025 //y=1.835 //x2=35.94 //y2=1.835
r196 (  25 27 ) resistor r=7.15173 //w=0.17 //l=0.120208 //layer=li \
 //thickness=0.1 //x=36.295 //y=1.835 //x2=36.38 //y2=1.92
r197 (  25 26 ) resistor r=18.4813 //w=0.187 //l=0.27 //layer=li \
 //thickness=0.1 //x=36.295 //y=1.835 //x2=36.025 //y2=1.835
r198 (  23 28 ) resistor r=7.15173 //w=0.17 //l=0.120208 //layer=li \
 //thickness=0.1 //x=36.295 //y=5.39 //x2=36.38 //y2=5.305
r199 (  23 24 ) resistor r=21.2193 //w=0.187 //l=0.31 //layer=li \
 //thickness=0.1 //x=36.295 //y=5.39 //x2=35.985 //y2=5.39
r200 (  19 39 ) resistor r=1.40859 //w=0.34 //l=0.085 //layer=li \
 //thickness=0.1 //x=35.94 //y=1.75 //x2=35.94 //y2=1.835
r201 (  19 72 ) resistor r=39.016 //w=0.187 //l=0.57 //layer=li \
 //thickness=0.1 //x=35.94 //y=1.75 //x2=35.94 //y2=1.18
r202 (  13 24 ) resistor r=7.15173 //w=0.17 //l=0.120208 //layer=li \
 //thickness=0.1 //x=35.9 //y=5.475 //x2=35.985 //y2=5.39
r203 (  13 75 ) resistor r=29.0909 //w=0.187 //l=0.425 //layer=li \
 //thickness=0.1 //x=35.9 //y=5.475 //x2=35.9 //y2=5.9
r204 (  11 39 ) resistor r=5.4201 //w=0.17 //l=0.085 //layer=li \
 //thickness=0.1 //x=35.855 //y=1.835 //x2=35.94 //y2=1.835
r205 (  11 12 ) resistor r=54.7594 //w=0.187 //l=0.8 //layer=li \
 //thickness=0.1 //x=35.855 //y=1.835 //x2=35.055 //y2=1.835
r206 (  7 12 ) resistor r=7.15173 //w=0.17 //l=0.120208 //layer=li \
 //thickness=0.1 //x=34.97 //y=1.75 //x2=35.055 //y2=1.835
r207 (  7 71 ) resistor r=39.016 //w=0.187 //l=0.57 //layer=li //thickness=0.1 \
 //x=34.97 //y=1.75 //x2=34.97 //y2=1.18
r208 (  6 35 ) resistor r=9.3 //w=0.17 //l=0.17 //layer=mcon //count=1 \
 //x=37.86 //y=3.51 //x2=37.86 //y2=3.51
r209 (  4 30 ) resistor r=9.3 //w=0.17 //l=0.17 //layer=mcon //count=1 \
 //x=36.38 //y=3.51 //x2=36.38 //y2=3.51
r210 (  2 4 ) resistor r=0.0717383 //w=0.224 //l=0.115 //layer=m1 \
 //thickness=0.36 //x=36.495 //y=3.51 //x2=36.38 //y2=3.51
r211 (  1 6 ) resistor r=0.0717383 //w=0.224 //l=0.115 //layer=m1 \
 //thickness=0.36 //x=37.745 //y=3.51 //x2=37.86 //y2=3.51
r212 (  1 2 ) resistor r=1.19275 //w=0.131 //l=1.25 //layer=m1 \
 //thickness=0.36 //x=37.745 //y=3.51 //x2=36.495 //y2=3.51
ends PM_FA\%noxref_16

subckt PM_FA\%noxref_17 ( 7 8 15 16 23 24 25 )
c39 ( 25 0 ) capacitor c=0.0306618f //x=5.115 //y=5.2
c40 ( 24 0 ) capacitor c=0.0185379f //x=4.235 //y=5.2
c41 ( 23 0 ) capacitor c=0.0384176f //x=3.365 //y=5.2
c42 ( 16 0 ) capacitor c=0.00194711f //x=4.465 //y=7.085
c43 ( 15 0 ) capacitor c=0.014216f //x=5.175 //y=7.085
c44 ( 8 0 ) capacitor c=0.00644339f //x=3.585 //y=5.385
c45 ( 7 0 ) capacitor c=0.0207865f //x=4.295 //y=5.385
r46 (  17 25 ) resistor r=5.81818 //w=0.187 //l=0.085 //layer=li \
 //thickness=0.1 //x=5.26 //y=7 //x2=5.26 //y2=6.915
r47 (  15 17 ) resistor r=7.15173 //w=0.17 //l=0.120208 //layer=li \
 //thickness=0.1 //x=5.175 //y=7.085 //x2=5.26 //y2=7
r48 (  15 16 ) resistor r=48.5989 //w=0.187 //l=0.71 //layer=li \
 //thickness=0.1 //x=5.175 //y=7.085 //x2=4.465 //y2=7.085
r49 (  10 16 ) resistor r=7.15173 //w=0.17 //l=0.120208 //layer=li \
 //thickness=0.1 //x=4.38 //y=7 //x2=4.465 //y2=7.085
r50 (  10 24 ) resistor r=29.0909 //w=0.187 //l=0.425 //layer=li \
 //thickness=0.1 //x=4.38 //y=7 //x2=4.38 //y2=6.575
r51 (  9 24 ) resistor r=29.0909 //w=0.187 //l=0.425 //layer=li \
 //thickness=0.1 //x=4.38 //y=5.47 //x2=4.38 //y2=5.895
r52 (  7 9 ) resistor r=7.15173 //w=0.17 //l=0.120208 //layer=li \
 //thickness=0.1 //x=4.295 //y=5.385 //x2=4.38 //y2=5.47
r53 (  7 8 ) resistor r=48.5989 //w=0.187 //l=0.71 //layer=li //thickness=0.1 \
 //x=4.295 //y=5.385 //x2=3.585 //y2=5.385
r54 (  1 8 ) resistor r=7.15173 //w=0.17 //l=0.120208 //layer=li \
 //thickness=0.1 //x=3.5 //y=5.47 //x2=3.585 //y2=5.385
r55 (  1 23 ) resistor r=29.0909 //w=0.187 //l=0.425 //layer=li \
 //thickness=0.1 //x=3.5 //y=5.47 //x2=3.5 //y2=5.895
ends PM_FA\%noxref_17

subckt PM_FA\%noxref_18 ( 1 5 9 10 13 17 29 )
c51 ( 29 0 ) capacitor c=0.0629093f //x=3.27 //y=0.55
c52 ( 17 0 ) capacitor c=0.00723243f //x=5.345 //y=0.8
c53 ( 13 0 ) capacitor c=0.0149083f //x=5.26 //y=0.715
c54 ( 10 0 ) capacitor c=0.00604817f //x=4.375 //y=1.68
c55 ( 9 0 ) capacitor c=0.00677124f //x=4.375 //y=0.8
c56 ( 5 0 ) capacitor c=0.0230272f //x=4.29 //y=1.765
c57 ( 1 0 ) capacitor c=0.0076549f //x=3.405 //y=1.68
r58 (  17 29 ) resistor r=3.57586 //w=0.17 //l=0.125 //layer=li \
 //thickness=0.1 //x=5.345 //y=0.8 //x2=5.345 //y2=0.675
r59 (  17 29 ) resistor r=18.139 //w=0.187 //l=0.265 //layer=li \
 //thickness=0.1 //x=5.345 //y=0.8 //x2=5.345 //y2=1.065
r60 (  14 29 ) resistor r=3.57586 //w=0.17 //l=0.103078 //layer=li \
 //thickness=0.1 //x=4.46 //y=0.715 //x2=4.375 //y2=0.675
r61 (  14 29 ) resistor r=27.3797 //w=0.187 //l=0.4 //layer=li //thickness=0.1 \
 //x=4.46 //y=0.715 //x2=4.86 //y2=0.715
r62 (  13 29 ) resistor r=3.57586 //w=0.17 //l=0.103078 //layer=li \
 //thickness=0.1 //x=5.26 //y=0.715 //x2=5.345 //y2=0.675
r63 (  13 29 ) resistor r=27.3797 //w=0.187 //l=0.4 //layer=li //thickness=0.1 \
 //x=5.26 //y=0.715 //x2=4.86 //y2=0.715
r64 (  10 29 ) resistor r=3.57586 //w=0.17 //l=0.125 //layer=li \
 //thickness=0.1 //x=4.375 //y=1.68 //x2=4.375 //y2=1.805
r65 (  10 29 ) resistor r=42.0963 //w=0.187 //l=0.615 //layer=li \
 //thickness=0.1 //x=4.375 //y=1.68 //x2=4.375 //y2=1.065
r66 (  9 29 ) resistor r=3.57586 //w=0.17 //l=0.125 //layer=li //thickness=0.1 \
 //x=4.375 //y=0.8 //x2=4.375 //y2=0.675
r67 (  9 29 ) resistor r=18.139 //w=0.187 //l=0.265 //layer=li //thickness=0.1 \
 //x=4.375 //y=0.8 //x2=4.375 //y2=1.065
r68 (  6 29 ) resistor r=3.57586 //w=0.17 //l=0.103078 //layer=li \
 //thickness=0.1 //x=3.49 //y=1.765 //x2=3.405 //y2=1.805
r69 (  6 29 ) resistor r=27.3797 //w=0.187 //l=0.4 //layer=li //thickness=0.1 \
 //x=3.49 //y=1.765 //x2=3.89 //y2=1.765
r70 (  5 29 ) resistor r=3.57586 //w=0.17 //l=0.103078 //layer=li \
 //thickness=0.1 //x=4.29 //y=1.765 //x2=4.375 //y2=1.805
r71 (  5 29 ) resistor r=27.3797 //w=0.187 //l=0.4 //layer=li //thickness=0.1 \
 //x=4.29 //y=1.765 //x2=3.89 //y2=1.765
r72 (  1 29 ) resistor r=3.57586 //w=0.17 //l=0.125 //layer=li //thickness=0.1 \
 //x=3.405 //y=1.68 //x2=3.405 //y2=1.805
r73 (  1 29 ) resistor r=42.0963 //w=0.187 //l=0.615 //layer=li \
 //thickness=0.1 //x=3.405 //y=1.68 //x2=3.405 //y2=1.065
ends PM_FA\%noxref_18

subckt PM_FA\%noxref_19 ( 7 8 15 16 23 24 25 )
c41 ( 25 0 ) capacitor c=0.0305804f //x=8.445 //y=5.2
c42 ( 24 0 ) capacitor c=0.0185379f //x=7.565 //y=5.2
c43 ( 23 0 ) capacitor c=0.0384176f //x=6.695 //y=5.2
c44 ( 16 0 ) capacitor c=0.00194711f //x=7.795 //y=7.085
c45 ( 15 0 ) capacitor c=0.0133643f //x=8.505 //y=7.085
c46 ( 8 0 ) capacitor c=0.00631451f //x=6.915 //y=5.385
c47 ( 7 0 ) capacitor c=0.0183784f //x=7.625 //y=5.385
r48 (  17 25 ) resistor r=5.81818 //w=0.187 //l=0.085 //layer=li \
 //thickness=0.1 //x=8.59 //y=7 //x2=8.59 //y2=6.915
r49 (  15 17 ) resistor r=7.15173 //w=0.17 //l=0.120208 //layer=li \
 //thickness=0.1 //x=8.505 //y=7.085 //x2=8.59 //y2=7
r50 (  15 16 ) resistor r=48.5989 //w=0.187 //l=0.71 //layer=li \
 //thickness=0.1 //x=8.505 //y=7.085 //x2=7.795 //y2=7.085
r51 (  10 16 ) resistor r=7.15173 //w=0.17 //l=0.120208 //layer=li \
 //thickness=0.1 //x=7.71 //y=7 //x2=7.795 //y2=7.085
r52 (  10 24 ) resistor r=29.0909 //w=0.187 //l=0.425 //layer=li \
 //thickness=0.1 //x=7.71 //y=7 //x2=7.71 //y2=6.575
r53 (  9 24 ) resistor r=29.0909 //w=0.187 //l=0.425 //layer=li \
 //thickness=0.1 //x=7.71 //y=5.47 //x2=7.71 //y2=5.895
r54 (  7 9 ) resistor r=7.15173 //w=0.17 //l=0.120208 //layer=li \
 //thickness=0.1 //x=7.625 //y=5.385 //x2=7.71 //y2=5.47
r55 (  7 8 ) resistor r=48.5989 //w=0.187 //l=0.71 //layer=li //thickness=0.1 \
 //x=7.625 //y=5.385 //x2=6.915 //y2=5.385
r56 (  1 8 ) resistor r=7.15173 //w=0.17 //l=0.120208 //layer=li \
 //thickness=0.1 //x=6.83 //y=5.47 //x2=6.915 //y2=5.385
r57 (  1 23 ) resistor r=29.0909 //w=0.187 //l=0.425 //layer=li \
 //thickness=0.1 //x=6.83 //y=5.47 //x2=6.83 //y2=5.895
ends PM_FA\%noxref_19

subckt PM_FA\%noxref_20 ( 1 5 9 10 13 17 29 )
c50 ( 29 0 ) capacitor c=0.0630989f //x=6.6 //y=0.55
c51 ( 17 0 ) capacitor c=0.00723243f //x=8.675 //y=0.8
c52 ( 13 0 ) capacitor c=0.0149083f //x=8.59 //y=0.715
c53 ( 10 0 ) capacitor c=0.00604817f //x=7.705 //y=1.68
c54 ( 9 0 ) capacitor c=0.00677124f //x=7.705 //y=0.8
c55 ( 5 0 ) capacitor c=0.0245898f //x=7.62 //y=1.765
c56 ( 1 0 ) capacitor c=0.0071362f //x=6.735 //y=1.68
r57 (  17 29 ) resistor r=3.57586 //w=0.17 //l=0.125 //layer=li \
 //thickness=0.1 //x=8.675 //y=0.8 //x2=8.675 //y2=0.675
r58 (  17 29 ) resistor r=18.139 //w=0.187 //l=0.265 //layer=li \
 //thickness=0.1 //x=8.675 //y=0.8 //x2=8.675 //y2=1.065
r59 (  14 29 ) resistor r=3.57586 //w=0.17 //l=0.103078 //layer=li \
 //thickness=0.1 //x=7.79 //y=0.715 //x2=7.705 //y2=0.675
r60 (  14 29 ) resistor r=27.3797 //w=0.187 //l=0.4 //layer=li //thickness=0.1 \
 //x=7.79 //y=0.715 //x2=8.19 //y2=0.715
r61 (  13 29 ) resistor r=3.57586 //w=0.17 //l=0.103078 //layer=li \
 //thickness=0.1 //x=8.59 //y=0.715 //x2=8.675 //y2=0.675
r62 (  13 29 ) resistor r=27.3797 //w=0.187 //l=0.4 //layer=li //thickness=0.1 \
 //x=8.59 //y=0.715 //x2=8.19 //y2=0.715
r63 (  10 29 ) resistor r=3.57586 //w=0.17 //l=0.125 //layer=li \
 //thickness=0.1 //x=7.705 //y=1.68 //x2=7.705 //y2=1.805
r64 (  10 29 ) resistor r=42.0963 //w=0.187 //l=0.615 //layer=li \
 //thickness=0.1 //x=7.705 //y=1.68 //x2=7.705 //y2=1.065
r65 (  9 29 ) resistor r=3.57586 //w=0.17 //l=0.125 //layer=li //thickness=0.1 \
 //x=7.705 //y=0.8 //x2=7.705 //y2=0.675
r66 (  9 29 ) resistor r=18.139 //w=0.187 //l=0.265 //layer=li //thickness=0.1 \
 //x=7.705 //y=0.8 //x2=7.705 //y2=1.065
r67 (  6 29 ) resistor r=3.57586 //w=0.17 //l=0.103078 //layer=li \
 //thickness=0.1 //x=6.82 //y=1.765 //x2=6.735 //y2=1.805
r68 (  6 29 ) resistor r=27.3797 //w=0.187 //l=0.4 //layer=li //thickness=0.1 \
 //x=6.82 //y=1.765 //x2=7.22 //y2=1.765
r69 (  5 29 ) resistor r=3.57586 //w=0.17 //l=0.103078 //layer=li \
 //thickness=0.1 //x=7.62 //y=1.765 //x2=7.705 //y2=1.805
r70 (  5 29 ) resistor r=27.3797 //w=0.187 //l=0.4 //layer=li //thickness=0.1 \
 //x=7.62 //y=1.765 //x2=7.22 //y2=1.765
r71 (  1 29 ) resistor r=3.57586 //w=0.17 //l=0.125 //layer=li //thickness=0.1 \
 //x=6.735 //y=1.68 //x2=6.735 //y2=1.805
r72 (  1 29 ) resistor r=42.0963 //w=0.187 //l=0.615 //layer=li \
 //thickness=0.1 //x=6.735 //y=1.68 //x2=6.735 //y2=1.065
ends PM_FA\%noxref_20

subckt PM_FA\%noxref_21 ( 7 8 15 16 23 24 25 )
c37 ( 25 0 ) capacitor c=0.0304741f //x=16.215 //y=5.2
c38 ( 24 0 ) capacitor c=0.0185379f //x=15.335 //y=5.2
c39 ( 23 0 ) capacitor c=0.0384176f //x=14.465 //y=5.2
c40 ( 16 0 ) capacitor c=0.00194711f //x=15.565 //y=7.085
c41 ( 15 0 ) capacitor c=0.0133605f //x=16.275 //y=7.085
c42 ( 8 0 ) capacitor c=0.00580995f //x=14.685 //y=5.385
c43 ( 7 0 ) capacitor c=0.0174896f //x=15.395 //y=5.385
r44 (  17 25 ) resistor r=5.81818 //w=0.187 //l=0.085 //layer=li \
 //thickness=0.1 //x=16.36 //y=7 //x2=16.36 //y2=6.915
r45 (  15 17 ) resistor r=7.15173 //w=0.17 //l=0.120208 //layer=li \
 //thickness=0.1 //x=16.275 //y=7.085 //x2=16.36 //y2=7
r46 (  15 16 ) resistor r=48.5989 //w=0.187 //l=0.71 //layer=li \
 //thickness=0.1 //x=16.275 //y=7.085 //x2=15.565 //y2=7.085
r47 (  10 16 ) resistor r=7.15173 //w=0.17 //l=0.120208 //layer=li \
 //thickness=0.1 //x=15.48 //y=7 //x2=15.565 //y2=7.085
r48 (  10 24 ) resistor r=29.0909 //w=0.187 //l=0.425 //layer=li \
 //thickness=0.1 //x=15.48 //y=7 //x2=15.48 //y2=6.575
r49 (  9 24 ) resistor r=29.0909 //w=0.187 //l=0.425 //layer=li \
 //thickness=0.1 //x=15.48 //y=5.47 //x2=15.48 //y2=5.895
r50 (  7 9 ) resistor r=7.15173 //w=0.17 //l=0.120208 //layer=li \
 //thickness=0.1 //x=15.395 //y=5.385 //x2=15.48 //y2=5.47
r51 (  7 8 ) resistor r=48.5989 //w=0.187 //l=0.71 //layer=li //thickness=0.1 \
 //x=15.395 //y=5.385 //x2=14.685 //y2=5.385
r52 (  1 8 ) resistor r=7.15173 //w=0.17 //l=0.120208 //layer=li \
 //thickness=0.1 //x=14.6 //y=5.47 //x2=14.685 //y2=5.385
r53 (  1 23 ) resistor r=29.0909 //w=0.187 //l=0.425 //layer=li \
 //thickness=0.1 //x=14.6 //y=5.47 //x2=14.6 //y2=5.895
ends PM_FA\%noxref_21

subckt PM_FA\%noxref_22 ( 1 5 9 10 13 17 29 )
c49 ( 29 0 ) capacitor c=0.0629093f //x=14.37 //y=0.55
c50 ( 17 0 ) capacitor c=0.00723243f //x=16.445 //y=0.8
c51 ( 13 0 ) capacitor c=0.0149083f //x=16.36 //y=0.715
c52 ( 10 0 ) capacitor c=0.00604817f //x=15.475 //y=1.68
c53 ( 9 0 ) capacitor c=0.00677124f //x=15.475 //y=0.8
c54 ( 5 0 ) capacitor c=0.0245898f //x=15.39 //y=1.765
c55 ( 1 0 ) capacitor c=0.0071362f //x=14.505 //y=1.68
r56 (  17 29 ) resistor r=3.57586 //w=0.17 //l=0.125 //layer=li \
 //thickness=0.1 //x=16.445 //y=0.8 //x2=16.445 //y2=0.675
r57 (  17 29 ) resistor r=18.139 //w=0.187 //l=0.265 //layer=li \
 //thickness=0.1 //x=16.445 //y=0.8 //x2=16.445 //y2=1.065
r58 (  14 29 ) resistor r=3.57586 //w=0.17 //l=0.103078 //layer=li \
 //thickness=0.1 //x=15.56 //y=0.715 //x2=15.475 //y2=0.675
r59 (  14 29 ) resistor r=27.3797 //w=0.187 //l=0.4 //layer=li //thickness=0.1 \
 //x=15.56 //y=0.715 //x2=15.96 //y2=0.715
r60 (  13 29 ) resistor r=3.57586 //w=0.17 //l=0.103078 //layer=li \
 //thickness=0.1 //x=16.36 //y=0.715 //x2=16.445 //y2=0.675
r61 (  13 29 ) resistor r=27.3797 //w=0.187 //l=0.4 //layer=li //thickness=0.1 \
 //x=16.36 //y=0.715 //x2=15.96 //y2=0.715
r62 (  10 29 ) resistor r=3.57586 //w=0.17 //l=0.125 //layer=li \
 //thickness=0.1 //x=15.475 //y=1.68 //x2=15.475 //y2=1.805
r63 (  10 29 ) resistor r=42.0963 //w=0.187 //l=0.615 //layer=li \
 //thickness=0.1 //x=15.475 //y=1.68 //x2=15.475 //y2=1.065
r64 (  9 29 ) resistor r=3.57586 //w=0.17 //l=0.125 //layer=li //thickness=0.1 \
 //x=15.475 //y=0.8 //x2=15.475 //y2=0.675
r65 (  9 29 ) resistor r=18.139 //w=0.187 //l=0.265 //layer=li //thickness=0.1 \
 //x=15.475 //y=0.8 //x2=15.475 //y2=1.065
r66 (  6 29 ) resistor r=3.57586 //w=0.17 //l=0.103078 //layer=li \
 //thickness=0.1 //x=14.59 //y=1.765 //x2=14.505 //y2=1.805
r67 (  6 29 ) resistor r=27.3797 //w=0.187 //l=0.4 //layer=li //thickness=0.1 \
 //x=14.59 //y=1.765 //x2=14.99 //y2=1.765
r68 (  5 29 ) resistor r=3.57586 //w=0.17 //l=0.103078 //layer=li \
 //thickness=0.1 //x=15.39 //y=1.765 //x2=15.475 //y2=1.805
r69 (  5 29 ) resistor r=27.3797 //w=0.187 //l=0.4 //layer=li //thickness=0.1 \
 //x=15.39 //y=1.765 //x2=14.99 //y2=1.765
r70 (  1 29 ) resistor r=3.57586 //w=0.17 //l=0.125 //layer=li //thickness=0.1 \
 //x=14.505 //y=1.68 //x2=14.505 //y2=1.805
r71 (  1 29 ) resistor r=42.0963 //w=0.187 //l=0.615 //layer=li \
 //thickness=0.1 //x=14.505 //y=1.68 //x2=14.505 //y2=1.065
ends PM_FA\%noxref_22

subckt PM_FA\%noxref_23 ( 7 8 15 16 23 24 25 )
c39 ( 25 0 ) capacitor c=0.0304741f //x=19.545 //y=5.2
c40 ( 24 0 ) capacitor c=0.0185379f //x=18.665 //y=5.2
c41 ( 23 0 ) capacitor c=0.0384176f //x=17.795 //y=5.2
c42 ( 16 0 ) capacitor c=0.00194711f //x=18.895 //y=7.085
c43 ( 15 0 ) capacitor c=0.0131936f //x=19.605 //y=7.085
c44 ( 8 0 ) capacitor c=0.00568107f //x=18.015 //y=5.385
c45 ( 7 0 ) capacitor c=0.0174896f //x=18.725 //y=5.385
r46 (  17 25 ) resistor r=5.81818 //w=0.187 //l=0.085 //layer=li \
 //thickness=0.1 //x=19.69 //y=7 //x2=19.69 //y2=6.915
r47 (  15 17 ) resistor r=7.15173 //w=0.17 //l=0.120208 //layer=li \
 //thickness=0.1 //x=19.605 //y=7.085 //x2=19.69 //y2=7
r48 (  15 16 ) resistor r=48.5989 //w=0.187 //l=0.71 //layer=li \
 //thickness=0.1 //x=19.605 //y=7.085 //x2=18.895 //y2=7.085
r49 (  10 16 ) resistor r=7.15173 //w=0.17 //l=0.120208 //layer=li \
 //thickness=0.1 //x=18.81 //y=7 //x2=18.895 //y2=7.085
r50 (  10 24 ) resistor r=29.0909 //w=0.187 //l=0.425 //layer=li \
 //thickness=0.1 //x=18.81 //y=7 //x2=18.81 //y2=6.575
r51 (  9 24 ) resistor r=29.0909 //w=0.187 //l=0.425 //layer=li \
 //thickness=0.1 //x=18.81 //y=5.47 //x2=18.81 //y2=5.895
r52 (  7 9 ) resistor r=7.15173 //w=0.17 //l=0.120208 //layer=li \
 //thickness=0.1 //x=18.725 //y=5.385 //x2=18.81 //y2=5.47
r53 (  7 8 ) resistor r=48.5989 //w=0.187 //l=0.71 //layer=li //thickness=0.1 \
 //x=18.725 //y=5.385 //x2=18.015 //y2=5.385
r54 (  1 8 ) resistor r=7.15173 //w=0.17 //l=0.120208 //layer=li \
 //thickness=0.1 //x=17.93 //y=5.47 //x2=18.015 //y2=5.385
r55 (  1 23 ) resistor r=29.0909 //w=0.187 //l=0.425 //layer=li \
 //thickness=0.1 //x=17.93 //y=5.47 //x2=17.93 //y2=5.895
ends PM_FA\%noxref_23

subckt PM_FA\%noxref_24 ( 1 5 9 10 13 17 29 )
c50 ( 29 0 ) capacitor c=0.0630989f //x=17.7 //y=0.55
c51 ( 17 0 ) capacitor c=0.00723243f //x=19.775 //y=0.8
c52 ( 13 0 ) capacitor c=0.0149083f //x=19.69 //y=0.715
c53 ( 10 0 ) capacitor c=0.00604817f //x=18.805 //y=1.68
c54 ( 9 0 ) capacitor c=0.00677124f //x=18.805 //y=0.8
c55 ( 5 0 ) capacitor c=0.0245898f //x=18.72 //y=1.765
c56 ( 1 0 ) capacitor c=0.0071362f //x=17.835 //y=1.68
r57 (  17 29 ) resistor r=3.57586 //w=0.17 //l=0.125 //layer=li \
 //thickness=0.1 //x=19.775 //y=0.8 //x2=19.775 //y2=0.675
r58 (  17 29 ) resistor r=18.139 //w=0.187 //l=0.265 //layer=li \
 //thickness=0.1 //x=19.775 //y=0.8 //x2=19.775 //y2=1.065
r59 (  14 29 ) resistor r=3.57586 //w=0.17 //l=0.103078 //layer=li \
 //thickness=0.1 //x=18.89 //y=0.715 //x2=18.805 //y2=0.675
r60 (  14 29 ) resistor r=27.3797 //w=0.187 //l=0.4 //layer=li //thickness=0.1 \
 //x=18.89 //y=0.715 //x2=19.29 //y2=0.715
r61 (  13 29 ) resistor r=3.57586 //w=0.17 //l=0.103078 //layer=li \
 //thickness=0.1 //x=19.69 //y=0.715 //x2=19.775 //y2=0.675
r62 (  13 29 ) resistor r=27.3797 //w=0.187 //l=0.4 //layer=li //thickness=0.1 \
 //x=19.69 //y=0.715 //x2=19.29 //y2=0.715
r63 (  10 29 ) resistor r=3.57586 //w=0.17 //l=0.125 //layer=li \
 //thickness=0.1 //x=18.805 //y=1.68 //x2=18.805 //y2=1.805
r64 (  10 29 ) resistor r=42.0963 //w=0.187 //l=0.615 //layer=li \
 //thickness=0.1 //x=18.805 //y=1.68 //x2=18.805 //y2=1.065
r65 (  9 29 ) resistor r=3.57586 //w=0.17 //l=0.125 //layer=li //thickness=0.1 \
 //x=18.805 //y=0.8 //x2=18.805 //y2=0.675
r66 (  9 29 ) resistor r=18.139 //w=0.187 //l=0.265 //layer=li //thickness=0.1 \
 //x=18.805 //y=0.8 //x2=18.805 //y2=1.065
r67 (  6 29 ) resistor r=3.57586 //w=0.17 //l=0.103078 //layer=li \
 //thickness=0.1 //x=17.92 //y=1.765 //x2=17.835 //y2=1.805
r68 (  6 29 ) resistor r=27.3797 //w=0.187 //l=0.4 //layer=li //thickness=0.1 \
 //x=17.92 //y=1.765 //x2=18.32 //y2=1.765
r69 (  5 29 ) resistor r=3.57586 //w=0.17 //l=0.103078 //layer=li \
 //thickness=0.1 //x=18.72 //y=1.765 //x2=18.805 //y2=1.805
r70 (  5 29 ) resistor r=27.3797 //w=0.187 //l=0.4 //layer=li //thickness=0.1 \
 //x=18.72 //y=1.765 //x2=18.32 //y2=1.765
r71 (  1 29 ) resistor r=3.57586 //w=0.17 //l=0.125 //layer=li //thickness=0.1 \
 //x=17.835 //y=1.68 //x2=17.835 //y2=1.805
r72 (  1 29 ) resistor r=42.0963 //w=0.187 //l=0.615 //layer=li \
 //thickness=0.1 //x=17.835 //y=1.68 //x2=17.835 //y2=1.065
ends PM_FA\%noxref_24

subckt PM_FA\%noxref_25 ( 1 5 9 10 13 17 29 )
c53 ( 29 0 ) capacitor c=0.0626874f //x=23.25 //y=0.545
c54 ( 17 0 ) capacitor c=0.00722223f //x=25.325 //y=0.795
c55 ( 13 0 ) capacitor c=0.0143165f //x=25.24 //y=0.71
c56 ( 10 0 ) capacitor c=0.00565173f //x=24.355 //y=1.675
c57 ( 9 0 ) capacitor c=0.006761f //x=24.355 //y=0.795
c58 ( 5 0 ) capacitor c=0.0245809f //x=24.27 //y=1.76
c59 ( 1 0 ) capacitor c=0.0071365f //x=23.385 //y=1.675
r60 (  17 29 ) resistor r=3.57586 //w=0.17 //l=0.125 //layer=li \
 //thickness=0.1 //x=25.325 //y=0.795 //x2=25.325 //y2=0.67
r61 (  17 29 ) resistor r=18.139 //w=0.187 //l=0.265 //layer=li \
 //thickness=0.1 //x=25.325 //y=0.795 //x2=25.325 //y2=1.06
r62 (  14 29 ) resistor r=3.57586 //w=0.17 //l=0.103078 //layer=li \
 //thickness=0.1 //x=24.44 //y=0.71 //x2=24.355 //y2=0.67
r63 (  14 29 ) resistor r=27.3797 //w=0.187 //l=0.4 //layer=li //thickness=0.1 \
 //x=24.44 //y=0.71 //x2=24.84 //y2=0.71
r64 (  13 29 ) resistor r=3.57586 //w=0.17 //l=0.103078 //layer=li \
 //thickness=0.1 //x=25.24 //y=0.71 //x2=25.325 //y2=0.67
r65 (  13 29 ) resistor r=27.3797 //w=0.187 //l=0.4 //layer=li //thickness=0.1 \
 //x=25.24 //y=0.71 //x2=24.84 //y2=0.71
r66 (  10 29 ) resistor r=3.57586 //w=0.17 //l=0.125 //layer=li \
 //thickness=0.1 //x=24.355 //y=1.675 //x2=24.355 //y2=1.8
r67 (  10 29 ) resistor r=42.0963 //w=0.187 //l=0.615 //layer=li \
 //thickness=0.1 //x=24.355 //y=1.675 //x2=24.355 //y2=1.06
r68 (  9 29 ) resistor r=3.57586 //w=0.17 //l=0.125 //layer=li //thickness=0.1 \
 //x=24.355 //y=0.795 //x2=24.355 //y2=0.67
r69 (  9 29 ) resistor r=18.139 //w=0.187 //l=0.265 //layer=li //thickness=0.1 \
 //x=24.355 //y=0.795 //x2=24.355 //y2=1.06
r70 (  6 29 ) resistor r=3.57586 //w=0.17 //l=0.103078 //layer=li \
 //thickness=0.1 //x=23.47 //y=1.76 //x2=23.385 //y2=1.8
r71 (  6 29 ) resistor r=27.3797 //w=0.187 //l=0.4 //layer=li //thickness=0.1 \
 //x=23.47 //y=1.76 //x2=23.87 //y2=1.76
r72 (  5 29 ) resistor r=3.57586 //w=0.17 //l=0.103078 //layer=li \
 //thickness=0.1 //x=24.27 //y=1.76 //x2=24.355 //y2=1.8
r73 (  5 29 ) resistor r=27.3797 //w=0.187 //l=0.4 //layer=li //thickness=0.1 \
 //x=24.27 //y=1.76 //x2=23.87 //y2=1.76
r74 (  1 29 ) resistor r=3.57586 //w=0.17 //l=0.125 //layer=li //thickness=0.1 \
 //x=23.385 //y=1.675 //x2=23.385 //y2=1.8
r75 (  1 29 ) resistor r=42.0963 //w=0.187 //l=0.615 //layer=li \
 //thickness=0.1 //x=23.385 //y=1.675 //x2=23.385 //y2=1.06
ends PM_FA\%noxref_25

subckt PM_FA\%noxref_26 ( 1 5 9 10 13 17 29 )
c57 ( 29 0 ) capacitor c=0.0631306f //x=28.8 //y=0.545
c58 ( 17 0 ) capacitor c=0.00722223f //x=30.875 //y=0.795
c59 ( 13 0 ) capacitor c=0.0143072f //x=30.79 //y=0.71
c60 ( 10 0 ) capacitor c=0.00519634f //x=29.905 //y=1.675
c61 ( 9 0 ) capacitor c=0.006761f //x=29.905 //y=0.795
c62 ( 5 0 ) capacitor c=0.0243504f //x=29.82 //y=1.76
c63 ( 1 0 ) capacitor c=0.0071365f //x=28.935 //y=1.675
r64 (  17 29 ) resistor r=3.57586 //w=0.17 //l=0.125 //layer=li \
 //thickness=0.1 //x=30.875 //y=0.795 //x2=30.875 //y2=0.67
r65 (  17 29 ) resistor r=18.139 //w=0.187 //l=0.265 //layer=li \
 //thickness=0.1 //x=30.875 //y=0.795 //x2=30.875 //y2=1.06
r66 (  14 29 ) resistor r=3.57586 //w=0.17 //l=0.103078 //layer=li \
 //thickness=0.1 //x=29.99 //y=0.71 //x2=29.905 //y2=0.67
r67 (  14 29 ) resistor r=27.3797 //w=0.187 //l=0.4 //layer=li //thickness=0.1 \
 //x=29.99 //y=0.71 //x2=30.39 //y2=0.71
r68 (  13 29 ) resistor r=3.57586 //w=0.17 //l=0.103078 //layer=li \
 //thickness=0.1 //x=30.79 //y=0.71 //x2=30.875 //y2=0.67
r69 (  13 29 ) resistor r=27.3797 //w=0.187 //l=0.4 //layer=li //thickness=0.1 \
 //x=30.79 //y=0.71 //x2=30.39 //y2=0.71
r70 (  10 29 ) resistor r=3.57586 //w=0.17 //l=0.125 //layer=li \
 //thickness=0.1 //x=29.905 //y=1.675 //x2=29.905 //y2=1.8
r71 (  10 29 ) resistor r=42.0963 //w=0.187 //l=0.615 //layer=li \
 //thickness=0.1 //x=29.905 //y=1.675 //x2=29.905 //y2=1.06
r72 (  9 29 ) resistor r=3.57586 //w=0.17 //l=0.125 //layer=li //thickness=0.1 \
 //x=29.905 //y=0.795 //x2=29.905 //y2=0.67
r73 (  9 29 ) resistor r=18.139 //w=0.187 //l=0.265 //layer=li //thickness=0.1 \
 //x=29.905 //y=0.795 //x2=29.905 //y2=1.06
r74 (  6 29 ) resistor r=3.57586 //w=0.17 //l=0.103078 //layer=li \
 //thickness=0.1 //x=29.02 //y=1.76 //x2=28.935 //y2=1.8
r75 (  6 29 ) resistor r=27.3797 //w=0.187 //l=0.4 //layer=li //thickness=0.1 \
 //x=29.02 //y=1.76 //x2=29.42 //y2=1.76
r76 (  5 29 ) resistor r=3.57586 //w=0.17 //l=0.103078 //layer=li \
 //thickness=0.1 //x=29.82 //y=1.76 //x2=29.905 //y2=1.8
r77 (  5 29 ) resistor r=27.3797 //w=0.187 //l=0.4 //layer=li //thickness=0.1 \
 //x=29.82 //y=1.76 //x2=29.42 //y2=1.76
r78 (  1 29 ) resistor r=3.57586 //w=0.17 //l=0.125 //layer=li //thickness=0.1 \
 //x=28.935 //y=1.675 //x2=28.935 //y2=1.8
r79 (  1 29 ) resistor r=42.0963 //w=0.187 //l=0.615 //layer=li \
 //thickness=0.1 //x=28.935 //y=1.675 //x2=28.935 //y2=1.06
ends PM_FA\%noxref_26

subckt PM_FA\%noxref_27 ( 7 8 15 16 23 24 25 )
c42 ( 25 0 ) capacitor c=0.030764f //x=36.195 //y=5.205
c43 ( 24 0 ) capacitor c=0.0185379f //x=35.315 //y=5.205
c44 ( 23 0 ) capacitor c=0.0409962f //x=34.445 //y=5.205
c45 ( 16 0 ) capacitor c=0.00193672f //x=35.545 //y=7.09
c46 ( 15 0 ) capacitor c=0.01354f //x=36.255 //y=7.09
c47 ( 8 0 ) capacitor c=0.0062284f //x=34.665 //y=5.39
c48 ( 7 0 ) capacitor c=0.0182952f //x=35.375 //y=5.39
r49 (  17 25 ) resistor r=5.81818 //w=0.187 //l=0.085 //layer=li \
 //thickness=0.1 //x=36.34 //y=7.005 //x2=36.34 //y2=6.92
r50 (  15 17 ) resistor r=7.15173 //w=0.17 //l=0.120208 //layer=li \
 //thickness=0.1 //x=36.255 //y=7.09 //x2=36.34 //y2=7.005
r51 (  15 16 ) resistor r=48.5989 //w=0.187 //l=0.71 //layer=li \
 //thickness=0.1 //x=36.255 //y=7.09 //x2=35.545 //y2=7.09
r52 (  10 16 ) resistor r=7.15173 //w=0.17 //l=0.120208 //layer=li \
 //thickness=0.1 //x=35.46 //y=7.005 //x2=35.545 //y2=7.09
r53 (  10 24 ) resistor r=29.0909 //w=0.187 //l=0.425 //layer=li \
 //thickness=0.1 //x=35.46 //y=7.005 //x2=35.46 //y2=6.58
r54 (  9 24 ) resistor r=29.0909 //w=0.187 //l=0.425 //layer=li \
 //thickness=0.1 //x=35.46 //y=5.475 //x2=35.46 //y2=5.9
r55 (  7 9 ) resistor r=7.15173 //w=0.17 //l=0.120208 //layer=li \
 //thickness=0.1 //x=35.375 //y=5.39 //x2=35.46 //y2=5.475
r56 (  7 8 ) resistor r=48.5989 //w=0.187 //l=0.71 //layer=li //thickness=0.1 \
 //x=35.375 //y=5.39 //x2=34.665 //y2=5.39
r57 (  1 8 ) resistor r=7.15173 //w=0.17 //l=0.120208 //layer=li \
 //thickness=0.1 //x=34.58 //y=5.475 //x2=34.665 //y2=5.39
r58 (  1 23 ) resistor r=29.0909 //w=0.187 //l=0.425 //layer=li \
 //thickness=0.1 //x=34.58 //y=5.475 //x2=34.58 //y2=5.9
ends PM_FA\%noxref_27

subckt PM_FA\%COUT ( 1 2 3 4 5 6 7 18 19 20 21 31 33 )
c44 ( 33 0 ) capacitor c=0.028734f //x=38.09 //y=5.2
c45 ( 31 0 ) capacitor c=0.0173218f //x=38.045 //y=1.09
c46 ( 21 0 ) capacitor c=0.00575887f //x=38.32 //y=4.76
c47 ( 20 0 ) capacitor c=0.0136889f //x=38.515 //y=4.76
c48 ( 19 0 ) capacitor c=0.00636159f //x=38.315 //y=2.26
c49 ( 18 0 ) capacitor c=0.0140707f //x=38.515 //y=2.26
c50 ( 1 0 ) capacitor c=0.105613f //x=38.6 //y=2.4
r51 (  20 23 ) resistor r=7.15173 //w=0.17 //l=0.120208 //layer=li \
 //thickness=0.1 //x=38.515 //y=4.76 //x2=38.6 //y2=4.675
r52 (  20 21 ) resistor r=13.3476 //w=0.187 //l=0.195 //layer=li \
 //thickness=0.1 //x=38.515 //y=4.76 //x2=38.32 //y2=4.76
r53 (  18 22 ) resistor r=7.15173 //w=0.17 //l=0.120208 //layer=li \
 //thickness=0.1 //x=38.515 //y=2.26 //x2=38.6 //y2=2.345
r54 (  18 19 ) resistor r=13.6898 //w=0.187 //l=0.2 //layer=li //thickness=0.1 \
 //x=38.515 //y=2.26 //x2=38.315 //y2=2.26
r55 (  12 21 ) resistor r=7.15173 //w=0.17 //l=0.120208 //layer=li \
 //thickness=0.1 //x=38.235 //y=4.845 //x2=38.32 //y2=4.76
r56 (  12 33 ) resistor r=72.5562 //w=0.187 //l=1.06 //layer=li \
 //thickness=0.1 //x=38.235 //y=4.845 //x2=38.235 //y2=5.905
r57 (  8 19 ) resistor r=7.15173 //w=0.17 //l=0.120208 //layer=li \
 //thickness=0.1 //x=38.23 //y=2.175 //x2=38.315 //y2=2.26
r58 (  8 31 ) resistor r=67.7647 //w=0.187 //l=0.99 //layer=li //thickness=0.1 \
 //x=38.23 //y=2.175 //x2=38.23 //y2=1.185
r59 (  7 23 ) resistor r=3.76471 //w=0.187 //l=0.055 //layer=li \
 //thickness=0.1 //x=38.6 //y=4.62 //x2=38.6 //y2=4.675
r60 (  6 7 ) resistor r=25.3262 //w=0.187 //l=0.37 //layer=li //thickness=0.1 \
 //x=38.6 //y=4.25 //x2=38.6 //y2=4.62
r61 (  5 6 ) resistor r=25.3262 //w=0.187 //l=0.37 //layer=li //thickness=0.1 \
 //x=38.6 //y=3.88 //x2=38.6 //y2=4.25
r62 (  4 5 ) resistor r=25.3262 //w=0.187 //l=0.37 //layer=li //thickness=0.1 \
 //x=38.6 //y=3.51 //x2=38.6 //y2=3.88
r63 (  3 4 ) resistor r=25.3262 //w=0.187 //l=0.37 //layer=li //thickness=0.1 \
 //x=38.6 //y=3.14 //x2=38.6 //y2=3.51
r64 (  2 3 ) resistor r=25.3262 //w=0.187 //l=0.37 //layer=li //thickness=0.1 \
 //x=38.6 //y=2.77 //x2=38.6 //y2=3.14
r65 (  1 2 ) resistor r=25.3262 //w=0.187 //l=0.37 //layer=li //thickness=0.1 \
 //x=38.6 //y=2.4 //x2=38.6 //y2=2.77
r66 (  1 22 ) resistor r=3.76471 //w=0.187 //l=0.055 //layer=li \
 //thickness=0.1 //x=38.6 //y=2.4 //x2=38.6 //y2=2.345
ends PM_FA\%COUT
