// File: AO3X1.spi.pex
// Created: Tue Apr 29 10:38:22 2025
// Program "Calibre xRC"
// Version "v2023.2_27.15"
// Nominal Temperature: 30C
// Circuit Temperature: 30C
//
simulator lang=spectre
subckt PM_AO3X1\%GND ( 1 16 20 23 28 39 44 48 56 60 82 86 99 119 124 131 132 \
 133 )
c122 ( 133 0 ) capacitor c=0.0597376f //x=7.645 //y=0.55
c123 ( 132 0 ) capacitor c=0.069675f //x=4.38 //y=0.545
c124 ( 131 0 ) capacitor c=0.0208405f //x=1.48 //y=1.045
c125 ( 124 0 ) capacitor c=0.253193f //x=8.75 //y=0.175
c126 ( 119 0 ) capacitor c=0.099135f //x=7.15 //y=0.175
c127 ( 99 0 ) capacitor c=0.107188f //x=3.82 //y=0.175
c128 ( 98 0 ) capacitor c=0.00446416f //x=1.67 //y=0.175
c129 ( 89 0 ) capacitor c=0.00587411f //x=8.75 //y=0.63
c130 ( 86 0 ) capacitor c=0.00542565f //x=8.665 //y=0.715
c131 ( 85 0 ) capacitor c=0.00479856f //x=8.265 //y=0.63
c132 ( 82 0 ) capacitor c=0.00690112f //x=8.18 //y=0.715
c133 ( 77 0 ) capacitor c=0.00592191f //x=7.78 //y=0.63
c134 ( 72 0 ) capacitor c=0.0191899f //x=7.695 //y=0.175
c135 ( 69 0 ) capacitor c=0.0670931f //x=6.54 //y=0.175
c136 ( 68 0 ) capacitor c=0.0229116f //x=6.98 //y=0.175
c137 ( 63 0 ) capacitor c=0.00609805f //x=6.455 //y=0.625
c138 ( 60 0 ) capacitor c=0.00508078f //x=6.37 //y=0.71
c139 ( 59 0 ) capacitor c=0.00468234f //x=5.97 //y=0.625
c140 ( 56 0 ) capacitor c=0.00556167f //x=5.885 //y=0.71
c141 ( 51 0 ) capacitor c=0.00468234f //x=5.485 //y=0.625
c142 ( 48 0 ) capacitor c=0.00556167f //x=5.4 //y=0.71
c143 ( 47 0 ) capacitor c=0.00468234f //x=5 //y=0.625
c144 ( 44 0 ) capacitor c=0.00692583f //x=4.915 //y=0.71
c145 ( 39 0 ) capacitor c=0.00609805f //x=4.515 //y=0.625
c146 ( 36 0 ) capacitor c=0.0229116f //x=4.43 //y=0.175
c147 ( 28 0 ) capacitor c=0.0760254f //x=3.65 //y=0.175
c148 ( 23 0 ) capacitor c=0.198174f //x=1.23 //y=0.18
c149 ( 20 0 ) capacitor c=0.0430284f //x=1.585 //y=0.175
c150 ( 16 0 ) capacitor c=0.379768f //x=8.63 //y=0.18
r151 (  123 124 ) resistor r=4.18529 //w=0.367 //l=0.12 //layer=li \
 //thickness=0.1 //x=8.63 //y=0.175 //x2=8.75 //y2=0.175
r152 (  121 123 ) resistor r=12.7302 //w=0.367 //l=0.365 //layer=li \
 //thickness=0.1 //x=8.265 //y=0.175 //x2=8.63 //y2=0.175
r153 (  120 121 ) resistor r=16.9155 //w=0.367 //l=0.485 //layer=li \
 //thickness=0.1 //x=7.78 //y=0.175 //x2=8.265 //y2=0.175
r154 (  107 108 ) resistor r=14.4741 //w=0.367 //l=0.415 //layer=li \
 //thickness=0.1 //x=6.04 //y=0.175 //x2=6.455 //y2=0.175
r155 (  105 107 ) resistor r=2.44142 //w=0.367 //l=0.07 //layer=li \
 //thickness=0.1 //x=5.97 //y=0.175 //x2=6.04 //y2=0.175
r156 (  104 105 ) resistor r=16.9155 //w=0.367 //l=0.485 //layer=li \
 //thickness=0.1 //x=5.485 //y=0.175 //x2=5.97 //y2=0.175
r157 (  103 104 ) resistor r=16.9155 //w=0.367 //l=0.485 //layer=li \
 //thickness=0.1 //x=5 //y=0.175 //x2=5.485 //y2=0.175
r158 (  102 103 ) resistor r=2.44142 //w=0.367 //l=0.07 //layer=li \
 //thickness=0.1 //x=4.93 //y=0.175 //x2=5 //y2=0.175
r159 (  100 102 ) resistor r=14.4741 //w=0.367 //l=0.415 //layer=li \
 //thickness=0.1 //x=4.515 //y=0.175 //x2=4.93 //y2=0.175
r160 (  90 133 ) resistor r=5.4201 //w=0.17 //l=0.085 //layer=li \
 //thickness=0.1 //x=8.75 //y=0.8 //x2=8.75 //y2=0.715
r161 (  90 133 ) resistor r=41.4118 //w=0.187 //l=0.605 //layer=li \
 //thickness=0.1 //x=8.75 //y=0.8 //x2=8.75 //y2=1.405
r162 (  89 133 ) resistor r=5.4201 //w=0.17 //l=0.085 //layer=li \
 //thickness=0.1 //x=8.75 //y=0.63 //x2=8.75 //y2=0.715
r163 (  88 124 ) resistor r=5.21862 //w=0.35 //l=0.175 //layer=li \
 //thickness=0.1 //x=8.75 //y=0.35 //x2=8.75 //y2=0.175
r164 (  88 89 ) resistor r=19.1658 //w=0.187 //l=0.28 //layer=li \
 //thickness=0.1 //x=8.75 //y=0.35 //x2=8.75 //y2=0.63
r165 (  87 133 ) resistor r=5.4201 //w=0.17 //l=0.085 //layer=li \
 //thickness=0.1 //x=8.35 //y=0.715 //x2=8.265 //y2=0.715
r166 (  86 133 ) resistor r=1.40859 //w=0.34 //l=0.085 //layer=li \
 //thickness=0.1 //x=8.665 //y=0.715 //x2=8.75 //y2=0.715
r167 (  86 87 ) resistor r=21.5615 //w=0.187 //l=0.315 //layer=li \
 //thickness=0.1 //x=8.665 //y=0.715 //x2=8.35 //y2=0.715
r168 (  85 133 ) resistor r=1.40859 //w=0.34 //l=0.085 //layer=li \
 //thickness=0.1 //x=8.265 //y=0.63 //x2=8.265 //y2=0.715
r169 (  84 121 ) resistor r=5.21862 //w=0.35 //l=0.175 //layer=li \
 //thickness=0.1 //x=8.265 //y=0.35 //x2=8.265 //y2=0.175
r170 (  84 85 ) resistor r=19.1658 //w=0.187 //l=0.28 //layer=li \
 //thickness=0.1 //x=8.265 //y=0.35 //x2=8.265 //y2=0.63
r171 (  83 133 ) resistor r=1.40859 //w=0.34 //l=0.085 //layer=li \
 //thickness=0.1 //x=7.865 //y=0.715 //x2=7.78 //y2=0.715
r172 (  82 133 ) resistor r=5.4201 //w=0.17 //l=0.085 //layer=li \
 //thickness=0.1 //x=8.18 //y=0.715 //x2=8.265 //y2=0.715
r173 (  82 83 ) resistor r=21.5615 //w=0.187 //l=0.315 //layer=li \
 //thickness=0.1 //x=8.18 //y=0.715 //x2=7.865 //y2=0.715
r174 (  78 133 ) resistor r=5.4201 //w=0.17 //l=0.085 //layer=li \
 //thickness=0.1 //x=7.78 //y=0.8 //x2=7.78 //y2=0.715
r175 (  78 133 ) resistor r=41.4118 //w=0.187 //l=0.605 //layer=li \
 //thickness=0.1 //x=7.78 //y=0.8 //x2=7.78 //y2=1.405
r176 (  77 133 ) resistor r=5.4201 //w=0.17 //l=0.085 //layer=li \
 //thickness=0.1 //x=7.78 //y=0.63 //x2=7.78 //y2=0.715
r177 (  76 120 ) resistor r=5.21862 //w=0.35 //l=0.175 //layer=li \
 //thickness=0.1 //x=7.78 //y=0.35 //x2=7.78 //y2=0.175
r178 (  76 77 ) resistor r=19.1658 //w=0.187 //l=0.28 //layer=li \
 //thickness=0.1 //x=7.78 //y=0.35 //x2=7.78 //y2=0.63
r179 (  73 119 ) resistor r=5.29055 //w=0.35 //l=0.17 //layer=li \
 //thickness=0.1 //x=7.32 //y=0.175 //x2=7.15 //y2=0.175
r180 (  73 75 ) resistor r=6.97548 //w=0.367 //l=0.2 //layer=li \
 //thickness=0.1 //x=7.32 //y=0.175 //x2=7.52 //y2=0.175
r181 (  72 120 ) resistor r=2.96458 //w=0.367 //l=0.085 //layer=li \
 //thickness=0.1 //x=7.695 //y=0.175 //x2=7.78 //y2=0.175
r182 (  72 75 ) resistor r=6.10354 //w=0.367 //l=0.175 //layer=li \
 //thickness=0.1 //x=7.695 //y=0.175 //x2=7.52 //y2=0.175
r183 (  69 108 ) resistor r=2.96458 //w=0.367 //l=0.085 //layer=li \
 //thickness=0.1 //x=6.54 //y=0.175 //x2=6.455 //y2=0.175
r184 (  68 119 ) resistor r=5.29055 //w=0.35 //l=0.17 //layer=li \
 //thickness=0.1 //x=6.98 //y=0.175 //x2=7.15 //y2=0.175
r185 (  68 69 ) resistor r=15.346 //w=0.367 //l=0.44 //layer=li \
 //thickness=0.1 //x=6.98 //y=0.175 //x2=6.54 //y2=0.175
r186 (  64 132 ) resistor r=5.4201 //w=0.17 //l=0.085 //layer=li \
 //thickness=0.1 //x=6.455 //y=0.795 //x2=6.455 //y2=0.71
r187 (  64 132 ) resistor r=18.139 //w=0.187 //l=0.265 //layer=li \
 //thickness=0.1 //x=6.455 //y=0.795 //x2=6.455 //y2=1.06
r188 (  63 132 ) resistor r=5.4201 //w=0.17 //l=0.085 //layer=li \
 //thickness=0.1 //x=6.455 //y=0.625 //x2=6.455 //y2=0.71
r189 (  62 108 ) resistor r=5.21862 //w=0.35 //l=0.175 //layer=li \
 //thickness=0.1 //x=6.455 //y=0.35 //x2=6.455 //y2=0.175
r190 (  62 63 ) resistor r=18.8235 //w=0.187 //l=0.275 //layer=li \
 //thickness=0.1 //x=6.455 //y=0.35 //x2=6.455 //y2=0.625
r191 (  61 132 ) resistor r=5.4201 //w=0.17 //l=0.085 //layer=li \
 //thickness=0.1 //x=6.055 //y=0.71 //x2=5.97 //y2=0.71
r192 (  60 132 ) resistor r=1.40859 //w=0.34 //l=0.085 //layer=li \
 //thickness=0.1 //x=6.37 //y=0.71 //x2=6.455 //y2=0.71
r193 (  60 61 ) resistor r=21.5615 //w=0.187 //l=0.315 //layer=li \
 //thickness=0.1 //x=6.37 //y=0.71 //x2=6.055 //y2=0.71
r194 (  59 132 ) resistor r=1.40859 //w=0.34 //l=0.085 //layer=li \
 //thickness=0.1 //x=5.97 //y=0.625 //x2=5.97 //y2=0.71
r195 (  58 105 ) resistor r=5.21862 //w=0.35 //l=0.175 //layer=li \
 //thickness=0.1 //x=5.97 //y=0.35 //x2=5.97 //y2=0.175
r196 (  58 59 ) resistor r=18.8235 //w=0.187 //l=0.275 //layer=li \
 //thickness=0.1 //x=5.97 //y=0.35 //x2=5.97 //y2=0.625
r197 (  57 132 ) resistor r=6.4 //w=0.17 //l=0.085 //layer=li //thickness=0.1 \
 //x=5.57 //y=0.71 //x2=5.485 //y2=0.71
r198 (  56 132 ) resistor r=5.4201 //w=0.17 //l=0.085 //layer=li \
 //thickness=0.1 //x=5.885 //y=0.71 //x2=5.97 //y2=0.71
r199 (  56 57 ) resistor r=21.5615 //w=0.187 //l=0.315 //layer=li \
 //thickness=0.1 //x=5.885 //y=0.71 //x2=5.57 //y2=0.71
r200 (  52 132 ) resistor r=6.4 //w=0.17 //l=0.085 //layer=li //thickness=0.1 \
 //x=5.485 //y=0.795 //x2=5.485 //y2=0.71
r201 (  52 132 ) resistor r=18.139 //w=0.187 //l=0.265 //layer=li \
 //thickness=0.1 //x=5.485 //y=0.795 //x2=5.485 //y2=1.06
r202 (  51 132 ) resistor r=6.4 //w=0.17 //l=0.085 //layer=li //thickness=0.1 \
 //x=5.485 //y=0.625 //x2=5.485 //y2=0.71
r203 (  50 104 ) resistor r=5.21862 //w=0.35 //l=0.175 //layer=li \
 //thickness=0.1 //x=5.485 //y=0.35 //x2=5.485 //y2=0.175
r204 (  50 51 ) resistor r=18.8235 //w=0.187 //l=0.275 //layer=li \
 //thickness=0.1 //x=5.485 //y=0.35 //x2=5.485 //y2=0.625
r205 (  49 132 ) resistor r=5.4201 //w=0.17 //l=0.085 //layer=li \
 //thickness=0.1 //x=5.085 //y=0.71 //x2=5 //y2=0.71
r206 (  48 132 ) resistor r=6.4 //w=0.17 //l=0.085 //layer=li //thickness=0.1 \
 //x=5.4 //y=0.71 //x2=5.485 //y2=0.71
r207 (  48 49 ) resistor r=21.5615 //w=0.187 //l=0.315 //layer=li \
 //thickness=0.1 //x=5.4 //y=0.71 //x2=5.085 //y2=0.71
r208 (  47 132 ) resistor r=1.40859 //w=0.34 //l=0.085 //layer=li \
 //thickness=0.1 //x=5 //y=0.625 //x2=5 //y2=0.71
r209 (  46 103 ) resistor r=5.21862 //w=0.35 //l=0.175 //layer=li \
 //thickness=0.1 //x=5 //y=0.35 //x2=5 //y2=0.175
r210 (  46 47 ) resistor r=18.8235 //w=0.187 //l=0.275 //layer=li \
 //thickness=0.1 //x=5 //y=0.35 //x2=5 //y2=0.625
r211 (  45 132 ) resistor r=1.40859 //w=0.34 //l=0.085 //layer=li \
 //thickness=0.1 //x=4.6 //y=0.71 //x2=4.515 //y2=0.71
r212 (  44 132 ) resistor r=5.4201 //w=0.17 //l=0.085 //layer=li \
 //thickness=0.1 //x=4.915 //y=0.71 //x2=5 //y2=0.71
r213 (  44 45 ) resistor r=21.5615 //w=0.187 //l=0.315 //layer=li \
 //thickness=0.1 //x=4.915 //y=0.71 //x2=4.6 //y2=0.71
r214 (  40 132 ) resistor r=5.4201 //w=0.17 //l=0.085 //layer=li \
 //thickness=0.1 //x=4.515 //y=0.795 //x2=4.515 //y2=0.71
r215 (  40 132 ) resistor r=41.4118 //w=0.187 //l=0.605 //layer=li \
 //thickness=0.1 //x=4.515 //y=0.795 //x2=4.515 //y2=1.4
r216 (  39 132 ) resistor r=5.4201 //w=0.17 //l=0.085 //layer=li \
 //thickness=0.1 //x=4.515 //y=0.625 //x2=4.515 //y2=0.71
r217 (  38 100 ) resistor r=5.21862 //w=0.35 //l=0.175 //layer=li \
 //thickness=0.1 //x=4.515 //y=0.35 //x2=4.515 //y2=0.175
r218 (  38 39 ) resistor r=18.8235 //w=0.187 //l=0.275 //layer=li \
 //thickness=0.1 //x=4.515 //y=0.35 //x2=4.515 //y2=0.625
r219 (  37 99 ) resistor r=5.29055 //w=0.35 //l=0.17 //layer=li \
 //thickness=0.1 //x=3.99 //y=0.175 //x2=3.82 //y2=0.175
r220 (  36 100 ) resistor r=2.96458 //w=0.367 //l=0.085 //layer=li \
 //thickness=0.1 //x=4.43 //y=0.175 //x2=4.515 //y2=0.175
r221 (  36 37 ) resistor r=15.346 //w=0.367 //l=0.44 //layer=li \
 //thickness=0.1 //x=4.43 //y=0.175 //x2=3.99 //y2=0.175
r222 (  31 33 ) resistor r=38.7139 //w=0.367 //l=1.11 //layer=li \
 //thickness=0.1 //x=2.34 //y=0.175 //x2=3.45 //y2=0.175
r223 (  29 98 ) resistor r=2.87058 //w=0.35 //l=0.085 //layer=li \
 //thickness=0.1 //x=1.755 //y=0.175 //x2=1.67 //y2=0.175
r224 (  29 31 ) resistor r=20.4033 //w=0.367 //l=0.585 //layer=li \
 //thickness=0.1 //x=1.755 //y=0.175 //x2=2.34 //y2=0.175
r225 (  28 99 ) resistor r=5.29055 //w=0.35 //l=0.17 //layer=li \
 //thickness=0.1 //x=3.65 //y=0.175 //x2=3.82 //y2=0.175
r226 (  28 33 ) resistor r=6.97548 //w=0.367 //l=0.2 //layer=li \
 //thickness=0.1 //x=3.65 //y=0.175 //x2=3.45 //y2=0.175
r227 (  24 98 ) resistor r=4.23183 //w=0.7 //l=0.175 //layer=li \
 //thickness=0.1 //x=1.67 //y=0.35 //x2=1.67 //y2=0.175
r228 (  24 131 ) resistor r=53.7326 //w=0.187 //l=0.785 //layer=li \
 //thickness=0.1 //x=1.67 //y=0.35 //x2=1.67 //y2=1.135
r229 (  20 98 ) resistor r=2.87058 //w=0.35 //l=0.085 //layer=li \
 //thickness=0.1 //x=1.585 //y=0.175 //x2=1.67 //y2=0.175
r230 (  20 23 ) resistor r=12.3815 //w=0.367 //l=0.355 //layer=li \
 //thickness=0.1 //x=1.585 //y=0.175 //x2=1.23 //y2=0.175
r231 (  16 123 ) resistor r=3.1 //w=0.17 //l=0.51 //layer=mcon //count=3 \
 //x=8.63 //y=0.18 //x2=8.63 //y2=0.18
r232 (  14 75 ) resistor r=3.1 //w=0.17 //l=0.51 //layer=mcon //count=3 \
 //x=7.52 //y=0.18 //x2=7.52 //y2=0.18
r233 (  14 16 ) resistor r=0.446141 //w=0.311 //l=1.11 //layer=m1 \
 //thickness=0.36 //x=7.52 //y=0.175 //x2=8.63 //y2=0.175
r234 (  12 107 ) resistor r=3.1 //w=0.17 //l=0.51 //layer=mcon //count=3 \
 //x=6.04 //y=0.18 //x2=6.04 //y2=0.18
r235 (  12 14 ) resistor r=0.594855 //w=0.311 //l=1.48 //layer=m1 \
 //thickness=0.36 //x=6.04 //y=0.175 //x2=7.52 //y2=0.175
r236 (  8 33 ) resistor r=3.1 //w=0.17 //l=0.51 //layer=mcon //count=3 \
 //x=3.45 //y=0.18 //x2=3.45 //y2=0.18
r237 (  6 31 ) resistor r=3.1 //w=0.17 //l=0.51 //layer=mcon //count=3 \
 //x=2.34 //y=0.18 //x2=2.34 //y2=0.18
r238 (  6 8 ) resistor r=0.446141 //w=0.311 //l=1.11 //layer=m1 \
 //thickness=0.36 //x=2.34 //y=0.175 //x2=3.45 //y2=0.175
r239 (  3 23 ) resistor r=3.1 //w=0.17 //l=0.51 //layer=mcon //count=3 \
 //x=1.23 //y=0.18 //x2=1.23 //y2=0.18
r240 (  3 6 ) resistor r=0.446141 //w=0.311 //l=1.11 //layer=m1 \
 //thickness=0.36 //x=1.23 //y=0.175 //x2=2.34 //y2=0.175
r241 (  1 102 ) resistor r=3.1 //w=0.17 //l=0.51 //layer=mcon //count=3 \
 //x=4.93 //y=0.18 //x2=4.93 //y2=0.18
r242 (  1 12 ) resistor r=0.446141 //w=0.311 //l=1.11 //layer=m1 \
 //thickness=0.36 //x=4.93 //y=0.175 //x2=6.04 //y2=0.175
r243 (  1 8 ) resistor r=0.594855 //w=0.311 //l=1.48 //layer=m1 \
 //thickness=0.36 //x=4.93 //y=0.175 //x2=3.45 //y2=0.175
ends PM_AO3X1\%GND

subckt PM_AO3X1\%VDD ( 1 16 28 36 52 62 78 91 94 96 99 100 101 102 103 104 105 )
c102 ( 105 0 ) capacitor c=0.0451938f //x=8.56 //y=5.2
c103 ( 104 0 ) capacitor c=0.0429367f //x=7.69 //y=5.2
c104 ( 103 0 ) capacitor c=0.0256797f //x=4.905 //y=5.205
c105 ( 102 0 ) capacitor c=0.0383754f //x=2.895 //y=5.2
c106 ( 101 0 ) capacitor c=0.0243053f //x=2.015 //y=5.2
c107 ( 100 0 ) capacitor c=0.0531988f //x=1.145 //y=5.2
c108 ( 99 0 ) capacitor c=0.253667f //x=8.63 //y=7.58
c109 ( 97 0 ) capacitor c=0.00597439f //x=7.825 //y=7.585
c110 ( 96 0 ) capacitor c=0.110752f //x=7.15 //y=7.585
c111 ( 95 0 ) capacitor c=0.00597439f //x=5.05 //y=7.585
c112 ( 94 0 ) capacitor c=0.11613f //x=3.82 //y=7.585
c113 ( 93 0 ) capacitor c=0.00597439f //x=3.04 //y=7.585
c114 ( 92 0 ) capacitor c=0.00597439f //x=2.16 //y=7.585
c115 ( 91 0 ) capacitor c=0.267398f //x=1.23 //y=7.58
c116 ( 78 0 ) capacitor c=0.029016f //x=8.62 //y=7.585
c117 ( 68 0 ) capacitor c=0.0217664f //x=7.74 //y=7.585
c118 ( 62 0 ) capacitor c=0.0785214f //x=6.98 //y=7.585
c119 ( 52 0 ) capacitor c=0.046953f //x=4.965 //y=7.585
c120 ( 46 0 ) capacitor c=0.0277785f //x=3.65 //y=7.585
c121 ( 36 0 ) capacitor c=0.0287734f //x=2.955 //y=7.585
c122 ( 28 0 ) capacitor c=0.0289072f //x=2.075 //y=7.585
c123 ( 16 0 ) capacitor c=0.389871f //x=8.63 //y=7.58
r124 (  80 99 ) resistor r=4.23183 //w=0.7 //l=0.175 //layer=li \
 //thickness=0.1 //x=8.705 //y=7.41 //x2=8.705 //y2=7.585
r125 (  80 105 ) resistor r=56.4706 //w=0.187 //l=0.825 //layer=li \
 //thickness=0.1 //x=8.705 //y=7.41 //x2=8.705 //y2=6.585
r126 (  79 97 ) resistor r=2.87058 //w=0.35 //l=0.085 //layer=li \
 //thickness=0.1 //x=7.91 //y=7.585 //x2=7.825 //y2=7.585
r127 (  78 99 ) resistor r=2.87058 //w=0.35 //l=0.085 //layer=li \
 //thickness=0.1 //x=8.62 //y=7.585 //x2=8.705 //y2=7.585
r128 (  78 79 ) resistor r=24.7629 //w=0.367 //l=0.71 //layer=li \
 //thickness=0.1 //x=8.62 //y=7.585 //x2=7.91 //y2=7.585
r129 (  72 97 ) resistor r=4.23183 //w=0.7 //l=0.175 //layer=li \
 //thickness=0.1 //x=7.825 //y=7.41 //x2=7.825 //y2=7.585
r130 (  72 104 ) resistor r=56.4706 //w=0.187 //l=0.825 //layer=li \
 //thickness=0.1 //x=7.825 //y=7.41 //x2=7.825 //y2=6.585
r131 (  69 96 ) resistor r=5.29055 //w=0.35 //l=0.17 //layer=li \
 //thickness=0.1 //x=7.32 //y=7.585 //x2=7.15 //y2=7.585
r132 (  69 71 ) resistor r=6.97548 //w=0.367 //l=0.2 //layer=li \
 //thickness=0.1 //x=7.32 //y=7.585 //x2=7.52 //y2=7.585
r133 (  68 97 ) resistor r=2.87058 //w=0.35 //l=0.085 //layer=li \
 //thickness=0.1 //x=7.74 //y=7.585 //x2=7.825 //y2=7.585
r134 (  68 71 ) resistor r=7.67302 //w=0.367 //l=0.22 //layer=li \
 //thickness=0.1 //x=7.74 //y=7.585 //x2=7.52 //y2=7.585
r135 (  63 95 ) resistor r=2.87058 //w=0.35 //l=0.085 //layer=li \
 //thickness=0.1 //x=5.135 //y=7.585 //x2=5.05 //y2=7.585
r136 (  63 65 ) resistor r=31.564 //w=0.367 //l=0.905 //layer=li \
 //thickness=0.1 //x=5.135 //y=7.585 //x2=6.04 //y2=7.585
r137 (  62 96 ) resistor r=5.29055 //w=0.35 //l=0.17 //layer=li \
 //thickness=0.1 //x=6.98 //y=7.585 //x2=7.15 //y2=7.585
r138 (  62 65 ) resistor r=32.7847 //w=0.367 //l=0.94 //layer=li \
 //thickness=0.1 //x=6.98 //y=7.585 //x2=6.04 //y2=7.585
r139 (  56 95 ) resistor r=4.23183 //w=0.7 //l=0.175 //layer=li \
 //thickness=0.1 //x=5.05 //y=7.41 //x2=5.05 //y2=7.585
r140 (  56 103 ) resistor r=33.5401 //w=0.187 //l=0.49 //layer=li \
 //thickness=0.1 //x=5.05 //y=7.41 //x2=5.05 //y2=6.92
r141 (  53 94 ) resistor r=5.29055 //w=0.35 //l=0.17 //layer=li \
 //thickness=0.1 //x=3.99 //y=7.585 //x2=3.82 //y2=7.585
r142 (  53 55 ) resistor r=32.7847 //w=0.367 //l=0.94 //layer=li \
 //thickness=0.1 //x=3.99 //y=7.585 //x2=4.93 //y2=7.585
r143 (  52 95 ) resistor r=2.87058 //w=0.35 //l=0.085 //layer=li \
 //thickness=0.1 //x=4.965 //y=7.585 //x2=5.05 //y2=7.585
r144 (  52 55 ) resistor r=1.22071 //w=0.367 //l=0.035 //layer=li \
 //thickness=0.1 //x=4.965 //y=7.585 //x2=4.93 //y2=7.585
r145 (  47 93 ) resistor r=2.87058 //w=0.35 //l=0.085 //layer=li \
 //thickness=0.1 //x=3.125 //y=7.585 //x2=3.04 //y2=7.585
r146 (  47 49 ) resistor r=11.3351 //w=0.367 //l=0.325 //layer=li \
 //thickness=0.1 //x=3.125 //y=7.585 //x2=3.45 //y2=7.585
r147 (  46 94 ) resistor r=5.29055 //w=0.35 //l=0.17 //layer=li \
 //thickness=0.1 //x=3.65 //y=7.585 //x2=3.82 //y2=7.585
r148 (  46 49 ) resistor r=6.97548 //w=0.367 //l=0.2 //layer=li \
 //thickness=0.1 //x=3.65 //y=7.585 //x2=3.45 //y2=7.585
r149 (  40 93 ) resistor r=4.23183 //w=0.7 //l=0.175 //layer=li \
 //thickness=0.1 //x=3.04 //y=7.41 //x2=3.04 //y2=7.585
r150 (  40 102 ) resistor r=33.1979 //w=0.187 //l=0.485 //layer=li \
 //thickness=0.1 //x=3.04 //y=7.41 //x2=3.04 //y2=6.925
r151 (  37 92 ) resistor r=2.87058 //w=0.35 //l=0.085 //layer=li \
 //thickness=0.1 //x=2.245 //y=7.585 //x2=2.16 //y2=7.585
r152 (  37 39 ) resistor r=3.31335 //w=0.367 //l=0.095 //layer=li \
 //thickness=0.1 //x=2.245 //y=7.585 //x2=2.34 //y2=7.585
r153 (  36 93 ) resistor r=2.87058 //w=0.35 //l=0.085 //layer=li \
 //thickness=0.1 //x=2.955 //y=7.585 //x2=3.04 //y2=7.585
r154 (  36 39 ) resistor r=21.4496 //w=0.367 //l=0.615 //layer=li \
 //thickness=0.1 //x=2.955 //y=7.585 //x2=2.34 //y2=7.585
r155 (  30 92 ) resistor r=4.23183 //w=0.7 //l=0.175 //layer=li \
 //thickness=0.1 //x=2.16 //y=7.41 //x2=2.16 //y2=7.585
r156 (  30 101 ) resistor r=33.1979 //w=0.187 //l=0.485 //layer=li \
 //thickness=0.1 //x=2.16 //y=7.41 //x2=2.16 //y2=6.925
r157 (  29 91 ) resistor r=2.87058 //w=0.35 //l=0.085 //layer=li \
 //thickness=0.1 //x=1.365 //y=7.585 //x2=1.28 //y2=7.585
r158 (  28 92 ) resistor r=2.87058 //w=0.35 //l=0.085 //layer=li \
 //thickness=0.1 //x=2.075 //y=7.585 //x2=2.16 //y2=7.585
r159 (  28 29 ) resistor r=24.7629 //w=0.367 //l=0.71 //layer=li \
 //thickness=0.1 //x=2.075 //y=7.585 //x2=1.365 //y2=7.585
r160 (  22 91 ) resistor r=4.23183 //w=0.7 //l=0.175 //layer=li \
 //thickness=0.1 //x=1.28 //y=7.41 //x2=1.28 //y2=7.585
r161 (  22 100 ) resistor r=56.4706 //w=0.187 //l=0.825 //layer=li \
 //thickness=0.1 //x=1.28 //y=7.41 //x2=1.28 //y2=6.585
r162 (  16 99 ) resistor r=3.1 //w=0.17 //l=0.51 //layer=mcon //count=3 \
 //x=8.63 //y=7.58 //x2=8.63 //y2=7.58
r163 (  14 71 ) resistor r=3.1 //w=0.17 //l=0.51 //layer=mcon //count=3 \
 //x=7.52 //y=7.58 //x2=7.52 //y2=7.58
r164 (  14 16 ) resistor r=0.446141 //w=0.311 //l=1.11 //layer=m1 \
 //thickness=0.36 //x=7.52 //y=7.585 //x2=8.63 //y2=7.585
r165 (  12 65 ) resistor r=3.1 //w=0.17 //l=0.51 //layer=mcon //count=3 \
 //x=6.04 //y=7.58 //x2=6.04 //y2=7.58
r166 (  12 14 ) resistor r=0.594855 //w=0.311 //l=1.48 //layer=m1 \
 //thickness=0.36 //x=6.04 //y=7.585 //x2=7.52 //y2=7.585
r167 (  8 49 ) resistor r=3.1 //w=0.17 //l=0.51 //layer=mcon //count=3 \
 //x=3.45 //y=7.58 //x2=3.45 //y2=7.58
r168 (  6 39 ) resistor r=3.1 //w=0.17 //l=0.51 //layer=mcon //count=3 \
 //x=2.34 //y=7.58 //x2=2.34 //y2=7.58
r169 (  6 8 ) resistor r=0.446141 //w=0.311 //l=1.11 //layer=m1 \
 //thickness=0.36 //x=2.34 //y=7.585 //x2=3.45 //y2=7.585
r170 (  3 91 ) resistor r=3.1 //w=0.17 //l=0.51 //layer=mcon //count=3 \
 //x=1.23 //y=7.58 //x2=1.23 //y2=7.58
r171 (  3 6 ) resistor r=0.446141 //w=0.311 //l=1.11 //layer=m1 \
 //thickness=0.36 //x=1.23 //y=7.585 //x2=2.34 //y2=7.585
r172 (  1 55 ) resistor r=3.1 //w=0.17 //l=0.51 //layer=mcon //count=3 \
 //x=4.93 //y=7.58 //x2=4.93 //y2=7.58
r173 (  1 12 ) resistor r=0.446141 //w=0.311 //l=1.11 //layer=m1 \
 //thickness=0.36 //x=4.93 //y=7.585 //x2=6.04 //y2=7.585
r174 (  1 8 ) resistor r=0.594855 //w=0.311 //l=1.48 //layer=m1 \
 //thickness=0.36 //x=4.93 //y=7.585 //x2=3.45 //y2=7.585
ends PM_AO3X1\%VDD

subckt PM_AO3X1\%noxref_3 ( 1 2 13 14 25 27 28 32 35 39 41 43 44 45 46 47 48 \
 49 53 55 58 60 61 66 76 78 79 )
c144 ( 79 0 ) capacitor c=0.0220291f //x=2.455 //y=5.2
c145 ( 78 0 ) capacitor c=0.0217503f //x=1.575 //y=5.2
c146 ( 76 0 ) capacitor c=0.00865153f //x=2.45 //y=1.085
c147 ( 66 0 ) capacitor c=0.04214f //x=4.775 //y=4.885
c148 ( 61 0 ) capacitor c=0.0321911f //x=5.265 //y=1.43
c149 ( 60 0 ) capacitor c=0.0185201f //x=5.265 //y=1.085
c150 ( 58 0 ) capacitor c=0.0344254f //x=5.195 //y=4.975
c151 ( 55 0 ) capacitor c=0.0133656f //x=5.11 //y=1.585
c152 ( 53 0 ) capacitor c=0.0157804f //x=5.11 //y=0.93
c153 ( 49 0 ) capacitor c=0.0785055f //x=4.735 //y=2.095
c154 ( 48 0 ) capacitor c=0.022867f //x=4.735 //y=1.74
c155 ( 47 0 ) capacitor c=0.0234318f //x=4.735 //y=1.43
c156 ( 46 0 ) capacitor c=0.0192004f //x=4.735 //y=1.085
c157 ( 45 0 ) capacitor c=0.110795f //x=5.27 //y=6.205
c158 ( 44 0 ) capacitor c=0.153847f //x=4.83 //y=6.205
c159 ( 41 0 ) capacitor c=0.00995068f //x=4.775 //y=4.885
c160 ( 39 0 ) capacitor c=0.00427536f //x=2.6 //y=5.38
c161 ( 35 0 ) capacitor c=0.0968478f //x=4.93 //y=2.26
c162 ( 32 0 ) capacitor c=0.117241f //x=3.08 //y=2.77
c163 ( 28 0 ) capacitor c=0.00781917f //x=2.725 //y=1.835
c164 ( 27 0 ) capacitor c=0.0159132f //x=2.995 //y=1.835
c165 ( 25 0 ) capacitor c=0.017841f //x=2.995 //y=5.38
c166 ( 14 0 ) capacitor c=0.00387264f //x=1.805 //y=5.38
c167 ( 13 0 ) capacitor c=0.0222171f //x=2.515 //y=5.38
c168 ( 2 0 ) capacitor c=0.0173935f //x=3.195 //y=2.77
c169 ( 1 0 ) capacitor c=0.111807f //x=4.815 //y=2.77
r170 (  68 69 ) resistor r=32.4568 //w=0.214 //l=0.075 //layer=ply \
 //thickness=0.18 //x=4.775 //y=4.975 //x2=4.775 //y2=5.05
r171 (  66 68 ) resistor r=20.271 //w=0.214 //l=0.09 //layer=ply \
 //thickness=0.18 //x=4.775 //y=4.885 //x2=4.775 //y2=4.975
r172 (  61 75 ) resistor r=45.1352 //w=0.168 //l=0.173853 //layer=ply \
 //thickness=0.18 //x=5.265 //y=1.43 //x2=5.225 //y2=1.585
r173 (  60 74 ) resistor r=45.1352 //w=0.168 //l=0.173853 //layer=ply \
 //thickness=0.18 //x=5.265 //y=1.085 //x2=5.225 //y2=0.93
r174 (  60 61 ) resistor r=176.904 //w=0.094 //l=0.345 //layer=ply \
 //thickness=0.18 //x=5.265 //y=1.085 //x2=5.265 //y2=1.43
r175 (  59 68 ) resistor r=16.5046 //w=0.27 //l=0.135 //layer=ply \
 //thickness=0.18 //x=4.91 //y=4.975 //x2=4.775 //y2=4.975
r176 (  58 62 ) resistor r=26.9307 //w=0.15 //l=0.106066 //layer=ply \
 //thickness=0.18 //x=5.195 //y=4.975 //x2=5.27 //y2=5.05
r177 (  58 59 ) resistor r=146.138 //w=0.094 //l=0.285 //layer=ply \
 //thickness=0.18 //x=5.195 //y=4.975 //x2=4.91 //y2=4.975
r178 (  56 73 ) resistor r=10.701 //w=0.21 //l=0.115 //layer=ply \
 //thickness=0.18 //x=4.89 //y=1.585 //x2=4.775 //y2=1.585
r179 (  55 75 ) resistor r=5.52526 //w=0.168 //l=0.115 //layer=ply \
 //thickness=0.18 //x=5.11 //y=1.585 //x2=5.225 //y2=1.585
r180 (  54 72 ) resistor r=5.52526 //w=0.168 //l=0.115 //layer=ply \
 //thickness=0.18 //x=4.89 //y=0.93 //x2=4.775 //y2=0.93
r181 (  53 74 ) resistor r=5.52526 //w=0.168 //l=0.115 //layer=ply \
 //thickness=0.18 //x=5.11 //y=0.93 //x2=5.225 //y2=0.93
r182 (  53 54 ) resistor r=112.809 //w=0.094 //l=0.22 //layer=ply \
 //thickness=0.18 //x=5.11 //y=0.93 //x2=4.89 //y2=0.93
r183 (  49 71 ) resistor r=34.8111 //w=0.27 //l=0.264953 //layer=ply \
 //thickness=0.18 //x=4.735 //y=2.095 //x2=4.93 //y2=2.26
r184 (  48 73 ) resistor r=39.5823 //w=0.21 //l=0.173853 //layer=ply \
 //thickness=0.18 //x=4.735 //y=1.74 //x2=4.775 //y2=1.585
r185 (  48 49 ) resistor r=182.032 //w=0.094 //l=0.355 //layer=ply \
 //thickness=0.18 //x=4.735 //y=1.74 //x2=4.735 //y2=2.095
r186 (  47 73 ) resistor r=39.5823 //w=0.21 //l=0.173853 //layer=ply \
 //thickness=0.18 //x=4.735 //y=1.43 //x2=4.775 //y2=1.585
r187 (  46 72 ) resistor r=45.1352 //w=0.168 //l=0.173853 //layer=ply \
 //thickness=0.18 //x=4.735 //y=1.085 //x2=4.775 //y2=0.93
r188 (  46 47 ) resistor r=176.904 //w=0.094 //l=0.345 //layer=ply \
 //thickness=0.18 //x=4.735 //y=1.085 //x2=4.735 //y2=1.43
r189 (  45 62 ) resistor r=592.245 //w=0.094 //l=1.155 //layer=ply \
 //thickness=0.18 //x=5.27 //y=6.205 //x2=5.27 //y2=5.05
r190 (  44 69 ) resistor r=592.245 //w=0.094 //l=1.155 //layer=ply \
 //thickness=0.18 //x=4.83 //y=6.205 //x2=4.83 //y2=5.05
r191 (  43 55 ) resistor r=56.4043 //w=0.094 //l=0.11 //layer=ply \
 //thickness=0.18 //x=5 //y=1.585 //x2=5.11 //y2=1.585
r192 (  43 56 ) resistor r=56.4043 //w=0.094 //l=0.11 //layer=ply \
 //thickness=0.18 //x=5 //y=1.585 //x2=4.89 //y2=1.585
r193 (  41 66 ) resistor r=152 //w=0.17 //l=0.17 //layer=licon //count=1 \
 //x=4.775 //y=4.885 //x2=4.775 //y2=4.885
r194 (  41 42 ) resistor r=7.81102 //w=0.254 //l=0.155 //layer=li \
 //thickness=0.1 //x=4.775 //y=4.885 //x2=4.93 //y2=4.885
r195 (  35 71 ) resistor r=152 //w=0.17 //l=0.17 //layer=licon //count=1 \
 //x=4.93 //y=2.26 //x2=4.93 //y2=2.26
r196 (  35 38 ) resistor r=34.9091 //w=0.187 //l=0.51 //layer=li \
 //thickness=0.1 //x=4.93 //y=2.26 //x2=4.93 //y2=2.77
r197 (  33 42 ) resistor r=3.23951 //w=0.254 //l=0.165 //layer=li \
 //thickness=0.1 //x=4.93 //y=4.72 //x2=4.93 //y2=4.885
r198 (  33 38 ) resistor r=133.476 //w=0.187 //l=1.95 //layer=li \
 //thickness=0.1 //x=4.93 //y=4.72 //x2=4.93 //y2=2.77
r199 (  30 32 ) resistor r=172.834 //w=0.187 //l=2.525 //layer=li \
 //thickness=0.1 //x=3.08 //y=5.295 //x2=3.08 //y2=2.77
r200 (  29 32 ) resistor r=58.1818 //w=0.187 //l=0.85 //layer=li \
 //thickness=0.1 //x=3.08 //y=1.92 //x2=3.08 //y2=2.77
r201 (  27 29 ) resistor r=7.15173 //w=0.17 //l=0.120208 //layer=li \
 //thickness=0.1 //x=2.995 //y=1.835 //x2=3.08 //y2=1.92
r202 (  27 28 ) resistor r=18.4813 //w=0.187 //l=0.27 //layer=li \
 //thickness=0.1 //x=2.995 //y=1.835 //x2=2.725 //y2=1.835
r203 (  26 39 ) resistor r=5.4201 //w=0.17 //l=0.085 //layer=li \
 //thickness=0.1 //x=2.685 //y=5.38 //x2=2.6 //y2=5.38
r204 (  25 30 ) resistor r=7.15173 //w=0.17 //l=0.120208 //layer=li \
 //thickness=0.1 //x=2.995 //y=5.38 //x2=3.08 //y2=5.295
r205 (  25 26 ) resistor r=21.2193 //w=0.187 //l=0.31 //layer=li \
 //thickness=0.1 //x=2.995 //y=5.38 //x2=2.685 //y2=5.38
r206 (  21 28 ) resistor r=7.15173 //w=0.17 //l=0.120208 //layer=li \
 //thickness=0.1 //x=2.64 //y=1.75 //x2=2.725 //y2=1.835
r207 (  21 76 ) resistor r=39.016 //w=0.187 //l=0.57 //layer=li \
 //thickness=0.1 //x=2.64 //y=1.75 //x2=2.64 //y2=1.18
r208 (  15 39 ) resistor r=1.40859 //w=0.34 //l=0.085 //layer=li \
 //thickness=0.1 //x=2.6 //y=5.465 //x2=2.6 //y2=5.38
r209 (  15 79 ) resistor r=30.1176 //w=0.187 //l=0.44 //layer=li \
 //thickness=0.1 //x=2.6 //y=5.465 //x2=2.6 //y2=5.905
r210 (  13 39 ) resistor r=5.4201 //w=0.17 //l=0.085 //layer=li \
 //thickness=0.1 //x=2.515 //y=5.38 //x2=2.6 //y2=5.38
r211 (  13 14 ) resistor r=48.5989 //w=0.187 //l=0.71 //layer=li \
 //thickness=0.1 //x=2.515 //y=5.38 //x2=1.805 //y2=5.38
r212 (  7 14 ) resistor r=7.15173 //w=0.17 //l=0.120208 //layer=li \
 //thickness=0.1 //x=1.72 //y=5.465 //x2=1.805 //y2=5.38
r213 (  7 78 ) resistor r=30.1176 //w=0.187 //l=0.44 //layer=li \
 //thickness=0.1 //x=1.72 //y=5.465 //x2=1.72 //y2=5.905
r214 (  6 38 ) resistor r=9.3 //w=0.17 //l=0.17 //layer=mcon //count=1 \
 //x=4.93 //y=2.77 //x2=4.93 //y2=2.77
r215 (  4 32 ) resistor r=9.3 //w=0.17 //l=0.17 //layer=mcon //count=1 \
 //x=3.08 //y=2.77 //x2=3.08 //y2=2.77
r216 (  2 4 ) resistor r=0.0717383 //w=0.224 //l=0.115 //layer=m1 \
 //thickness=0.36 //x=3.195 //y=2.77 //x2=3.08 //y2=2.77
r217 (  1 6 ) resistor r=0.0717383 //w=0.224 //l=0.115 //layer=m1 \
 //thickness=0.36 //x=4.815 //y=2.77 //x2=4.93 //y2=2.77
r218 (  1 2 ) resistor r=1.5458 //w=0.131 //l=1.62 //layer=m1 //thickness=0.36 \
 //x=4.815 //y=2.77 //x2=3.195 //y2=2.77
ends PM_AO3X1\%noxref_3

subckt PM_AO3X1\%noxref_4 ( 1 2 11 12 23 24 25 30 32 40 41 42 43 44 45 46 50 \
 51 52 54 60 61 63 71 72 75 )
c133 ( 75 0 ) capacitor c=0.0159573f //x=5.785 //y=5.205
c134 ( 72 0 ) capacitor c=0.00905936f //x=5.78 //y=1.085
c135 ( 71 0 ) capacitor c=0.007684f //x=4.81 //y=1.085
c136 ( 63 0 ) capacitor c=0.0517753f //x=7.89 //y=2.265
c137 ( 61 0 ) capacitor c=0.0435629f //x=8.53 //y=1.435
c138 ( 60 0 ) capacitor c=0.0200386f //x=8.53 //y=1.09
c139 ( 54 0 ) capacitor c=0.0152946f //x=8.375 //y=1.59
c140 ( 52 0 ) capacitor c=0.0157804f //x=8.375 //y=0.935
c141 ( 51 0 ) capacitor c=0.0524991f //x=8.12 //y=4.97
c142 ( 50 0 ) capacitor c=0.0322983f //x=8.41 //y=4.97
c143 ( 46 0 ) capacitor c=0.0290017f //x=8 //y=2.1
c144 ( 45 0 ) capacitor c=0.0250027f //x=8 //y=1.745
c145 ( 44 0 ) capacitor c=0.0234316f //x=8 //y=1.435
c146 ( 43 0 ) capacitor c=0.0200596f //x=8 //y=1.09
c147 ( 42 0 ) capacitor c=0.154218f //x=8.485 //y=6.2
c148 ( 41 0 ) capacitor c=0.154243f //x=8.045 //y=6.2
c149 ( 39 0 ) capacitor c=0.00710337f //x=5.97 //y=1.835
c150 ( 32 0 ) capacitor c=0.0948756f //x=7.89 //y=2.265
c151 ( 30 0 ) capacitor c=0.11371f //x=6.41 //y=2.77
c152 ( 25 0 ) capacitor c=0.0160526f //x=6.325 //y=1.835
c153 ( 24 0 ) capacitor c=0.00499395f //x=6.015 //y=5.39
c154 ( 23 0 ) capacitor c=0.0166531f //x=6.325 //y=5.39
c155 ( 12 0 ) capacitor c=0.00220849f //x=5.085 //y=1.835
c156 ( 11 0 ) capacitor c=0.0280953f //x=5.885 //y=1.835
c157 ( 2 0 ) capacitor c=0.0119578f //x=6.525 //y=2.77
c158 ( 1 0 ) capacitor c=0.093442f //x=7.775 //y=2.77
r159 (  63 64 ) resistor r=17.5563 //w=0.302 //l=0.11 //layer=ply \
 //thickness=0.18 //x=7.89 //y=2.265 //x2=8 //y2=2.265
r160 (  61 70 ) resistor r=45.1352 //w=0.168 //l=0.173853 //layer=ply \
 //thickness=0.18 //x=8.53 //y=1.435 //x2=8.49 //y2=1.59
r161 (  60 69 ) resistor r=45.1352 //w=0.168 //l=0.173853 //layer=ply \
 //thickness=0.18 //x=8.53 //y=1.09 //x2=8.49 //y2=0.935
r162 (  60 61 ) resistor r=176.904 //w=0.094 //l=0.345 //layer=ply \
 //thickness=0.18 //x=8.53 //y=1.09 //x2=8.53 //y2=1.435
r163 (  55 68 ) resistor r=10.701 //w=0.21 //l=0.115 //layer=ply \
 //thickness=0.18 //x=8.155 //y=1.59 //x2=8.04 //y2=1.59
r164 (  54 70 ) resistor r=5.52526 //w=0.168 //l=0.115 //layer=ply \
 //thickness=0.18 //x=8.375 //y=1.59 //x2=8.49 //y2=1.59
r165 (  53 67 ) resistor r=5.52526 //w=0.168 //l=0.115 //layer=ply \
 //thickness=0.18 //x=8.155 //y=0.935 //x2=8.04 //y2=0.935
r166 (  52 69 ) resistor r=5.52526 //w=0.168 //l=0.115 //layer=ply \
 //thickness=0.18 //x=8.375 //y=0.935 //x2=8.49 //y2=0.935
r167 (  52 53 ) resistor r=112.809 //w=0.094 //l=0.22 //layer=ply \
 //thickness=0.18 //x=8.375 //y=0.935 //x2=8.155 //y2=0.935
r168 (  50 57 ) resistor r=26.9307 //w=0.15 //l=0.106066 //layer=ply \
 //thickness=0.18 //x=8.41 //y=4.97 //x2=8.485 //y2=5.045
r169 (  50 51 ) resistor r=148.702 //w=0.094 //l=0.29 //layer=ply \
 //thickness=0.18 //x=8.41 //y=4.97 //x2=8.12 //y2=4.97
r170 (  47 51 ) resistor r=23.403 //w=0.284 //l=0.106066 //layer=ply \
 //thickness=0.18 //x=8.045 //y=5.045 //x2=8.12 //y2=4.97
r171 (  47 66 ) resistor r=26.3063 //w=0.284 //l=0.229783 //layer=ply \
 //thickness=0.18 //x=8.045 //y=5.045 //x2=7.89 //y2=4.88
r172 (  46 64 ) resistor r=19.1248 //w=0.302 //l=0.165 //layer=ply \
 //thickness=0.18 //x=8 //y=2.1 //x2=8 //y2=2.265
r173 (  45 68 ) resistor r=39.5823 //w=0.21 //l=0.173853 //layer=ply \
 //thickness=0.18 //x=8 //y=1.745 //x2=8.04 //y2=1.59
r174 (  45 46 ) resistor r=182.032 //w=0.094 //l=0.355 //layer=ply \
 //thickness=0.18 //x=8 //y=1.745 //x2=8 //y2=2.1
r175 (  44 68 ) resistor r=39.5823 //w=0.21 //l=0.173853 //layer=ply \
 //thickness=0.18 //x=8 //y=1.435 //x2=8.04 //y2=1.59
r176 (  43 67 ) resistor r=45.1352 //w=0.168 //l=0.173853 //layer=ply \
 //thickness=0.18 //x=8 //y=1.09 //x2=8.04 //y2=0.935
r177 (  43 44 ) resistor r=176.904 //w=0.094 //l=0.345 //layer=ply \
 //thickness=0.18 //x=8 //y=1.09 //x2=8 //y2=1.435
r178 (  42 57 ) resistor r=592.245 //w=0.094 //l=1.155 //layer=ply \
 //thickness=0.18 //x=8.485 //y=6.2 //x2=8.485 //y2=5.045
r179 (  41 47 ) resistor r=592.245 //w=0.094 //l=1.155 //layer=ply \
 //thickness=0.18 //x=8.045 //y=6.2 //x2=8.045 //y2=5.045
r180 (  40 54 ) resistor r=56.4043 //w=0.094 //l=0.11 //layer=ply \
 //thickness=0.18 //x=8.265 //y=1.59 //x2=8.375 //y2=1.59
r181 (  40 55 ) resistor r=56.4043 //w=0.094 //l=0.11 //layer=ply \
 //thickness=0.18 //x=8.265 //y=1.59 //x2=8.155 //y2=1.59
r182 (  37 66 ) resistor r=152 //w=0.17 //l=0.17 //layer=licon //count=1 \
 //x=7.89 //y=4.88 //x2=7.89 //y2=4.88
r183 (  35 37 ) resistor r=144.428 //w=0.187 //l=2.11 //layer=li \
 //thickness=0.1 //x=7.89 //y=2.77 //x2=7.89 //y2=4.88
r184 (  32 63 ) resistor r=152 //w=0.17 //l=0.17 //layer=licon //count=1 \
 //x=7.89 //y=2.265 //x2=7.89 //y2=2.265
r185 (  32 35 ) resistor r=34.5668 //w=0.187 //l=0.505 //layer=li \
 //thickness=0.1 //x=7.89 //y=2.265 //x2=7.89 //y2=2.77
r186 (  28 30 ) resistor r=173.519 //w=0.187 //l=2.535 //layer=li \
 //thickness=0.1 //x=6.41 //y=5.305 //x2=6.41 //y2=2.77
r187 (  27 30 ) resistor r=58.1818 //w=0.187 //l=0.85 //layer=li \
 //thickness=0.1 //x=6.41 //y=1.92 //x2=6.41 //y2=2.77
r188 (  26 39 ) resistor r=5.4201 //w=0.17 //l=0.085 //layer=li \
 //thickness=0.1 //x=6.055 //y=1.835 //x2=5.97 //y2=1.835
r189 (  25 27 ) resistor r=7.15173 //w=0.17 //l=0.120208 //layer=li \
 //thickness=0.1 //x=6.325 //y=1.835 //x2=6.41 //y2=1.92
r190 (  25 26 ) resistor r=18.4813 //w=0.187 //l=0.27 //layer=li \
 //thickness=0.1 //x=6.325 //y=1.835 //x2=6.055 //y2=1.835
r191 (  23 28 ) resistor r=7.15173 //w=0.17 //l=0.120208 //layer=li \
 //thickness=0.1 //x=6.325 //y=5.39 //x2=6.41 //y2=5.305
r192 (  23 24 ) resistor r=21.2193 //w=0.187 //l=0.31 //layer=li \
 //thickness=0.1 //x=6.325 //y=5.39 //x2=6.015 //y2=5.39
r193 (  19 39 ) resistor r=1.40859 //w=0.34 //l=0.085 //layer=li \
 //thickness=0.1 //x=5.97 //y=1.75 //x2=5.97 //y2=1.835
r194 (  19 72 ) resistor r=39.016 //w=0.187 //l=0.57 //layer=li \
 //thickness=0.1 //x=5.97 //y=1.75 //x2=5.97 //y2=1.18
r195 (  13 24 ) resistor r=7.15173 //w=0.17 //l=0.120208 //layer=li \
 //thickness=0.1 //x=5.93 //y=5.475 //x2=6.015 //y2=5.39
r196 (  13 75 ) resistor r=29.0909 //w=0.187 //l=0.425 //layer=li \
 //thickness=0.1 //x=5.93 //y=5.475 //x2=5.93 //y2=5.9
r197 (  11 39 ) resistor r=5.4201 //w=0.17 //l=0.085 //layer=li \
 //thickness=0.1 //x=5.885 //y=1.835 //x2=5.97 //y2=1.835
r198 (  11 12 ) resistor r=54.7594 //w=0.187 //l=0.8 //layer=li \
 //thickness=0.1 //x=5.885 //y=1.835 //x2=5.085 //y2=1.835
r199 (  7 12 ) resistor r=7.15173 //w=0.17 //l=0.120208 //layer=li \
 //thickness=0.1 //x=5 //y=1.75 //x2=5.085 //y2=1.835
r200 (  7 71 ) resistor r=39.016 //w=0.187 //l=0.57 //layer=li //thickness=0.1 \
 //x=5 //y=1.75 //x2=5 //y2=1.18
r201 (  6 35 ) resistor r=9.3 //w=0.17 //l=0.17 //layer=mcon //count=1 \
 //x=7.89 //y=2.77 //x2=7.89 //y2=2.77
r202 (  4 30 ) resistor r=9.3 //w=0.17 //l=0.17 //layer=mcon //count=1 \
 //x=6.41 //y=2.77 //x2=6.41 //y2=2.77
r203 (  2 4 ) resistor r=0.0717383 //w=0.224 //l=0.115 //layer=m1 \
 //thickness=0.36 //x=6.525 //y=2.77 //x2=6.41 //y2=2.77
r204 (  1 6 ) resistor r=0.0717383 //w=0.224 //l=0.115 //layer=m1 \
 //thickness=0.36 //x=7.775 //y=2.77 //x2=7.89 //y2=2.77
r205 (  1 2 ) resistor r=1.19275 //w=0.131 //l=1.25 //layer=m1 \
 //thickness=0.36 //x=7.775 //y=2.77 //x2=6.525 //y2=2.77
ends PM_AO3X1\%noxref_4

subckt PM_AO3X1\%A ( 1 2 3 4 5 6 7 9 21 22 23 24 25 26 27 31 33 36 37 47 )
c55 ( 47 0 ) capacitor c=0.0667949f //x=1.6 //y=4.88
c56 ( 37 0 ) capacitor c=0.0318948f //x=1.935 //y=1.39
c57 ( 36 0 ) capacitor c=0.0187384f //x=1.935 //y=1.045
c58 ( 33 0 ) capacitor c=0.0141798f //x=1.78 //y=1.545
c59 ( 31 0 ) capacitor c=0.0149844f //x=1.78 //y=0.89
c60 ( 27 0 ) capacitor c=0.0860049f //x=1.405 //y=2.095
c61 ( 26 0 ) capacitor c=0.0229722f //x=1.405 //y=1.7
c62 ( 25 0 ) capacitor c=0.0234352f //x=1.405 //y=1.39
c63 ( 24 0 ) capacitor c=0.0199343f //x=1.405 //y=1.045
c64 ( 23 0 ) capacitor c=0.110275f //x=1.94 //y=6.2
c65 ( 22 0 ) capacitor c=0.154305f //x=1.5 //y=6.2
c66 ( 9 0 ) capacitor c=0.116498f //x=1.6 //y=2.26
r67 (  45 47 ) resistor r=20.6867 //w=0.233 //l=0.1 //layer=ply \
 //thickness=0.18 //x=1.5 //y=4.88 //x2=1.6 //y2=4.88
r68 (  38 47 ) resistor r=70.3348 //w=0.233 //l=0.414367 //layer=ply \
 //thickness=0.18 //x=1.94 //y=5.045 //x2=1.6 //y2=4.88
r69 (  37 49 ) resistor r=45.1352 //w=0.168 //l=0.173853 //layer=ply \
 //thickness=0.18 //x=1.935 //y=1.39 //x2=1.895 //y2=1.545
r70 (  36 48 ) resistor r=45.1352 //w=0.168 //l=0.173853 //layer=ply \
 //thickness=0.18 //x=1.935 //y=1.045 //x2=1.895 //y2=0.89
r71 (  36 37 ) resistor r=176.904 //w=0.094 //l=0.345 //layer=ply \
 //thickness=0.18 //x=1.935 //y=1.045 //x2=1.935 //y2=1.39
r72 (  34 44 ) resistor r=10.701 //w=0.21 //l=0.115 //layer=ply \
 //thickness=0.18 //x=1.56 //y=1.545 //x2=1.445 //y2=1.545
r73 (  33 49 ) resistor r=5.52526 //w=0.168 //l=0.115 //layer=ply \
 //thickness=0.18 //x=1.78 //y=1.545 //x2=1.895 //y2=1.545
r74 (  32 43 ) resistor r=5.52526 //w=0.168 //l=0.115 //layer=ply \
 //thickness=0.18 //x=1.56 //y=0.89 //x2=1.445 //y2=0.89
r75 (  31 48 ) resistor r=5.52526 //w=0.168 //l=0.115 //layer=ply \
 //thickness=0.18 //x=1.78 //y=0.89 //x2=1.895 //y2=0.89
r76 (  31 32 ) resistor r=112.809 //w=0.094 //l=0.22 //layer=ply \
 //thickness=0.18 //x=1.78 //y=0.89 //x2=1.56 //y2=0.89
r77 (  28 45 ) resistor r=13.0941 //w=0.233 //l=0.165 //layer=ply \
 //thickness=0.18 //x=1.5 //y=5.045 //x2=1.5 //y2=4.88
r78 (  27 42 ) resistor r=34.8111 //w=0.27 //l=0.264953 //layer=ply \
 //thickness=0.18 //x=1.405 //y=2.095 //x2=1.6 //y2=2.26
r79 (  26 44 ) resistor r=39.5823 //w=0.21 //l=0.173853 //layer=ply \
 //thickness=0.18 //x=1.405 //y=1.7 //x2=1.445 //y2=1.545
r80 (  26 27 ) resistor r=202.543 //w=0.094 //l=0.395 //layer=ply \
 //thickness=0.18 //x=1.405 //y=1.7 //x2=1.405 //y2=2.095
r81 (  25 44 ) resistor r=39.5823 //w=0.21 //l=0.173853 //layer=ply \
 //thickness=0.18 //x=1.405 //y=1.39 //x2=1.445 //y2=1.545
r82 (  24 43 ) resistor r=45.1352 //w=0.168 //l=0.173853 //layer=ply \
 //thickness=0.18 //x=1.405 //y=1.045 //x2=1.445 //y2=0.89
r83 (  24 25 ) resistor r=176.904 //w=0.094 //l=0.345 //layer=ply \
 //thickness=0.18 //x=1.405 //y=1.045 //x2=1.405 //y2=1.39
r84 (  23 38 ) resistor r=592.245 //w=0.094 //l=1.155 //layer=ply \
 //thickness=0.18 //x=1.94 //y=6.2 //x2=1.94 //y2=5.045
r85 (  22 28 ) resistor r=592.245 //w=0.094 //l=1.155 //layer=ply \
 //thickness=0.18 //x=1.5 //y=6.2 //x2=1.5 //y2=5.045
r86 (  21 33 ) resistor r=56.4043 //w=0.094 //l=0.11 //layer=ply \
 //thickness=0.18 //x=1.67 //y=1.545 //x2=1.78 //y2=1.545
r87 (  21 34 ) resistor r=56.4043 //w=0.094 //l=0.11 //layer=ply \
 //thickness=0.18 //x=1.67 //y=1.545 //x2=1.56 //y2=1.545
r88 (  19 47 ) resistor r=152 //w=0.17 //l=0.17 //layer=licon //count=1 \
 //x=1.6 //y=4.88 //x2=1.6 //y2=4.88
r89 (  9 42 ) resistor r=152 //w=0.17 //l=0.17 //layer=licon //count=1 //x=1.6 \
 //y=2.26 //x2=1.6 //y2=2.26
r90 (  7 19 ) resistor r=17.7968 //w=0.187 //l=0.26 //layer=li //thickness=0.1 \
 //x=1.6 //y=4.62 //x2=1.6 //y2=4.88
r91 (  6 7 ) resistor r=25.3262 //w=0.187 //l=0.37 //layer=li //thickness=0.1 \
 //x=1.6 //y=4.25 //x2=1.6 //y2=4.62
r92 (  5 6 ) resistor r=25.3262 //w=0.187 //l=0.37 //layer=li //thickness=0.1 \
 //x=1.6 //y=3.88 //x2=1.6 //y2=4.25
r93 (  4 5 ) resistor r=25.3262 //w=0.187 //l=0.37 //layer=li //thickness=0.1 \
 //x=1.6 //y=3.51 //x2=1.6 //y2=3.88
r94 (  3 4 ) resistor r=25.3262 //w=0.187 //l=0.37 //layer=li //thickness=0.1 \
 //x=1.6 //y=3.14 //x2=1.6 //y2=3.51
r95 (  2 3 ) resistor r=25.3262 //w=0.187 //l=0.37 //layer=li //thickness=0.1 \
 //x=1.6 //y=2.77 //x2=1.6 //y2=3.14
r96 (  1 2 ) resistor r=25.3262 //w=0.187 //l=0.37 //layer=li //thickness=0.1 \
 //x=1.6 //y=2.4 //x2=1.6 //y2=2.77
r97 (  1 9 ) resistor r=9.58289 //w=0.187 //l=0.14 //layer=li //thickness=0.1 \
 //x=1.6 //y=2.4 //x2=1.6 //y2=2.26
ends PM_AO3X1\%A

subckt PM_AO3X1\%B ( 1 2 3 4 5 6 7 8 10 21 22 23 24 25 26 31 33 35 41 42 44 45 \
 48 )
c64 ( 48 0 ) capacitor c=0.034715f //x=2.37 //y=4.88
c65 ( 45 0 ) capacitor c=0.0279499f //x=2.34 //y=2.095
c66 ( 44 0 ) capacitor c=0.0437302f //x=2.34 //y=2.26
c67 ( 42 0 ) capacitor c=0.0429696f //x=2.905 //y=1.43
c68 ( 41 0 ) capacitor c=0.0192208f //x=2.905 //y=1.085
c69 ( 35 0 ) capacitor c=0.0158629f //x=2.75 //y=1.585
c70 ( 33 0 ) capacitor c=0.0157803f //x=2.75 //y=0.93
c71 ( 31 0 ) capacitor c=0.0366192f //x=2.745 //y=4.97
c72 ( 26 0 ) capacitor c=0.0205163f //x=2.375 //y=1.74
c73 ( 25 0 ) capacitor c=0.0168481f //x=2.375 //y=1.43
c74 ( 24 0 ) capacitor c=0.0174783f //x=2.375 //y=1.085
c75 ( 23 0 ) capacitor c=0.15358f //x=2.82 //y=6.2
c76 ( 22 0 ) capacitor c=0.110281f //x=2.38 //y=6.2
c77 ( 10 0 ) capacitor c=0.0813556f //x=2.34 //y=2.26
c78 ( 8 0 ) capacitor c=0.00453889f //x=2.34 //y=4.715
r79 (  50 51 ) resistor r=32.4568 //w=0.214 //l=0.075 //layer=ply \
 //thickness=0.18 //x=2.37 //y=4.97 //x2=2.37 //y2=5.045
r80 (  48 50 ) resistor r=20.271 //w=0.214 //l=0.09 //layer=ply \
 //thickness=0.18 //x=2.37 //y=4.88 //x2=2.37 //y2=4.97
r81 (  44 45 ) resistor r=52.7279 //w=0.214 //l=0.165 //layer=ply \
 //thickness=0.18 //x=2.34 //y=2.26 //x2=2.34 //y2=2.095
r82 (  42 55 ) resistor r=45.1352 //w=0.168 //l=0.173853 //layer=ply \
 //thickness=0.18 //x=2.905 //y=1.43 //x2=2.865 //y2=1.585
r83 (  41 54 ) resistor r=45.1352 //w=0.168 //l=0.173853 //layer=ply \
 //thickness=0.18 //x=2.905 //y=1.085 //x2=2.865 //y2=0.93
r84 (  41 42 ) resistor r=176.904 //w=0.094 //l=0.345 //layer=ply \
 //thickness=0.18 //x=2.905 //y=1.085 //x2=2.905 //y2=1.43
r85 (  36 53 ) resistor r=10.701 //w=0.21 //l=0.115 //layer=ply \
 //thickness=0.18 //x=2.53 //y=1.585 //x2=2.415 //y2=1.585
r86 (  35 55 ) resistor r=5.52526 //w=0.168 //l=0.115 //layer=ply \
 //thickness=0.18 //x=2.75 //y=1.585 //x2=2.865 //y2=1.585
r87 (  34 52 ) resistor r=5.52526 //w=0.168 //l=0.115 //layer=ply \
 //thickness=0.18 //x=2.53 //y=0.93 //x2=2.415 //y2=0.93
r88 (  33 54 ) resistor r=5.52526 //w=0.168 //l=0.115 //layer=ply \
 //thickness=0.18 //x=2.75 //y=0.93 //x2=2.865 //y2=0.93
r89 (  33 34 ) resistor r=112.809 //w=0.094 //l=0.22 //layer=ply \
 //thickness=0.18 //x=2.75 //y=0.93 //x2=2.53 //y2=0.93
r90 (  32 50 ) resistor r=16.5046 //w=0.27 //l=0.135 //layer=ply \
 //thickness=0.18 //x=2.505 //y=4.97 //x2=2.37 //y2=4.97
r91 (  31 38 ) resistor r=26.9307 //w=0.15 //l=0.106066 //layer=ply \
 //thickness=0.18 //x=2.745 //y=4.97 //x2=2.82 //y2=5.045
r92 (  31 32 ) resistor r=123.064 //w=0.094 //l=0.24 //layer=ply \
 //thickness=0.18 //x=2.745 //y=4.97 //x2=2.505 //y2=4.97
r93 (  26 53 ) resistor r=39.5823 //w=0.21 //l=0.173853 //layer=ply \
 //thickness=0.18 //x=2.375 //y=1.74 //x2=2.415 //y2=1.585
r94 (  26 45 ) resistor r=182.032 //w=0.094 //l=0.355 //layer=ply \
 //thickness=0.18 //x=2.375 //y=1.74 //x2=2.375 //y2=2.095
r95 (  25 53 ) resistor r=39.5823 //w=0.21 //l=0.173853 //layer=ply \
 //thickness=0.18 //x=2.375 //y=1.43 //x2=2.415 //y2=1.585
r96 (  24 52 ) resistor r=45.1352 //w=0.168 //l=0.173853 //layer=ply \
 //thickness=0.18 //x=2.375 //y=1.085 //x2=2.415 //y2=0.93
r97 (  24 25 ) resistor r=176.904 //w=0.094 //l=0.345 //layer=ply \
 //thickness=0.18 //x=2.375 //y=1.085 //x2=2.375 //y2=1.43
r98 (  23 38 ) resistor r=592.245 //w=0.094 //l=1.155 //layer=ply \
 //thickness=0.18 //x=2.82 //y=6.2 //x2=2.82 //y2=5.045
r99 (  22 51 ) resistor r=592.245 //w=0.094 //l=1.155 //layer=ply \
 //thickness=0.18 //x=2.38 //y=6.2 //x2=2.38 //y2=5.045
r100 (  21 35 ) resistor r=56.4043 //w=0.094 //l=0.11 //layer=ply \
 //thickness=0.18 //x=2.64 //y=1.585 //x2=2.75 //y2=1.585
r101 (  21 36 ) resistor r=56.4043 //w=0.094 //l=0.11 //layer=ply \
 //thickness=0.18 //x=2.64 //y=1.585 //x2=2.53 //y2=1.585
r102 (  20 48 ) resistor r=152 //w=0.17 //l=0.17 //layer=licon //count=1 \
 //x=2.37 //y=4.88 //x2=2.37 //y2=4.88
r103 (  10 44 ) resistor r=152 //w=0.17 //l=0.17 //layer=licon //count=1 \
 //x=2.34 //y=2.26 //x2=2.34 //y2=2.26
r104 (  8 20 ) resistor r=11.4737 //w=0.186 //l=0.172337 //layer=li \
 //thickness=0.1 //x=2.34 //y=4.715 //x2=2.355 //y2=4.88
r105 (  7 8 ) resistor r=6.50267 //w=0.187 //l=0.095 //layer=li \
 //thickness=0.1 //x=2.34 //y=4.62 //x2=2.34 //y2=4.715
r106 (  6 7 ) resistor r=25.3262 //w=0.187 //l=0.37 //layer=li //thickness=0.1 \
 //x=2.34 //y=4.25 //x2=2.34 //y2=4.62
r107 (  5 6 ) resistor r=25.3262 //w=0.187 //l=0.37 //layer=li //thickness=0.1 \
 //x=2.34 //y=3.88 //x2=2.34 //y2=4.25
r108 (  4 5 ) resistor r=25.3262 //w=0.187 //l=0.37 //layer=li //thickness=0.1 \
 //x=2.34 //y=3.51 //x2=2.34 //y2=3.88
r109 (  3 4 ) resistor r=25.3262 //w=0.187 //l=0.37 //layer=li //thickness=0.1 \
 //x=2.34 //y=3.14 //x2=2.34 //y2=3.51
r110 (  2 3 ) resistor r=25.3262 //w=0.187 //l=0.37 //layer=li //thickness=0.1 \
 //x=2.34 //y=2.77 //x2=2.34 //y2=3.14
r111 (  1 2 ) resistor r=25.3262 //w=0.187 //l=0.37 //layer=li //thickness=0.1 \
 //x=2.34 //y=2.4 //x2=2.34 //y2=2.77
r112 (  1 10 ) resistor r=9.58289 //w=0.187 //l=0.14 //layer=li \
 //thickness=0.1 //x=2.34 //y=2.4 //x2=2.34 //y2=2.26
ends PM_AO3X1\%B

subckt PM_AO3X1\%noxref_7 ( 1 5 9 10 13 17 29 )
c51 ( 29 0 ) capacitor c=0.0632971f //x=1.05 //y=0.545
c52 ( 17 0 ) capacitor c=0.00722223f //x=3.125 //y=0.795
c53 ( 13 0 ) capacitor c=0.0154397f //x=3.04 //y=0.71
c54 ( 10 0 ) capacitor c=0.0092508f //x=2.155 //y=1.675
c55 ( 9 0 ) capacitor c=0.006761f //x=2.155 //y=0.795
c56 ( 5 0 ) capacitor c=0.0255599f //x=2.07 //y=1.76
c57 ( 1 0 ) capacitor c=0.0113547f //x=1.185 //y=1.675
r58 (  17 29 ) resistor r=3.57586 //w=0.17 //l=0.125 //layer=li \
 //thickness=0.1 //x=3.125 //y=0.795 //x2=3.125 //y2=0.67
r59 (  17 29 ) resistor r=18.139 //w=0.187 //l=0.265 //layer=li \
 //thickness=0.1 //x=3.125 //y=0.795 //x2=3.125 //y2=1.06
r60 (  14 29 ) resistor r=3.57586 //w=0.17 //l=0.103078 //layer=li \
 //thickness=0.1 //x=2.24 //y=0.71 //x2=2.155 //y2=0.67
r61 (  14 29 ) resistor r=27.3797 //w=0.187 //l=0.4 //layer=li //thickness=0.1 \
 //x=2.24 //y=0.71 //x2=2.64 //y2=0.71
r62 (  13 29 ) resistor r=3.57586 //w=0.17 //l=0.103078 //layer=li \
 //thickness=0.1 //x=3.04 //y=0.71 //x2=3.125 //y2=0.67
r63 (  13 29 ) resistor r=27.3797 //w=0.187 //l=0.4 //layer=li //thickness=0.1 \
 //x=3.04 //y=0.71 //x2=2.64 //y2=0.71
r64 (  10 29 ) resistor r=3.57586 //w=0.17 //l=0.125 //layer=li \
 //thickness=0.1 //x=2.155 //y=1.675 //x2=2.155 //y2=1.8
r65 (  10 29 ) resistor r=42.0963 //w=0.187 //l=0.615 //layer=li \
 //thickness=0.1 //x=2.155 //y=1.675 //x2=2.155 //y2=1.06
r66 (  9 29 ) resistor r=3.57586 //w=0.17 //l=0.125 //layer=li //thickness=0.1 \
 //x=2.155 //y=0.795 //x2=2.155 //y2=0.67
r67 (  9 29 ) resistor r=18.139 //w=0.187 //l=0.265 //layer=li //thickness=0.1 \
 //x=2.155 //y=0.795 //x2=2.155 //y2=1.06
r68 (  6 29 ) resistor r=3.57586 //w=0.17 //l=0.103078 //layer=li \
 //thickness=0.1 //x=1.27 //y=1.76 //x2=1.185 //y2=1.8
r69 (  6 29 ) resistor r=27.3797 //w=0.187 //l=0.4 //layer=li //thickness=0.1 \
 //x=1.27 //y=1.76 //x2=1.67 //y2=1.76
r70 (  5 29 ) resistor r=3.57586 //w=0.17 //l=0.103078 //layer=li \
 //thickness=0.1 //x=2.07 //y=1.76 //x2=2.155 //y2=1.8
r71 (  5 29 ) resistor r=27.3797 //w=0.187 //l=0.4 //layer=li //thickness=0.1 \
 //x=2.07 //y=1.76 //x2=1.67 //y2=1.76
r72 (  1 29 ) resistor r=3.57586 //w=0.17 //l=0.125 //layer=li //thickness=0.1 \
 //x=1.185 //y=1.675 //x2=1.185 //y2=1.8
r73 (  1 29 ) resistor r=42.0963 //w=0.187 //l=0.615 //layer=li \
 //thickness=0.1 //x=1.185 //y=1.675 //x2=1.185 //y2=1.06
ends PM_AO3X1\%noxref_7

subckt PM_AO3X1\%C ( 1 2 3 4 5 6 7 8 10 21 22 23 24 25 26 31 33 35 41 42 44 45 \
 48 )
c71 ( 48 0 ) capacitor c=0.0369822f //x=5.705 //y=4.885
c72 ( 45 0 ) capacitor c=0.0279572f //x=5.67 //y=2.095
c73 ( 44 0 ) capacitor c=0.0422144f //x=5.67 //y=2.26
c74 ( 42 0 ) capacitor c=0.0237734f //x=6.235 //y=1.435
c75 ( 41 0 ) capacitor c=0.0191782f //x=6.235 //y=1.085
c76 ( 35 0 ) capacitor c=0.0346941f //x=6.08 //y=1.585
c77 ( 33 0 ) capacitor c=0.0157803f //x=6.08 //y=0.93
c78 ( 31 0 ) capacitor c=0.0360787f //x=6.075 //y=4.975
c79 ( 26 0 ) capacitor c=0.0199921f //x=5.705 //y=1.74
c80 ( 25 0 ) capacitor c=0.0169608f //x=5.705 //y=1.435
c81 ( 24 0 ) capacitor c=0.0185462f //x=5.705 //y=1.085
c82 ( 23 0 ) capacitor c=0.15325f //x=6.15 //y=6.205
c83 ( 22 0 ) capacitor c=0.110232f //x=5.71 //y=6.205
c84 ( 10 0 ) capacitor c=0.0800125f //x=5.67 //y=2.26
c85 ( 8 0 ) capacitor c=0.00521267f //x=5.67 //y=4.72
r86 (  50 51 ) resistor r=32.4568 //w=0.214 //l=0.075 //layer=ply \
 //thickness=0.18 //x=5.705 //y=4.975 //x2=5.705 //y2=5.05
r87 (  48 50 ) resistor r=20.271 //w=0.214 //l=0.09 //layer=ply \
 //thickness=0.18 //x=5.705 //y=4.885 //x2=5.705 //y2=4.975
r88 (  44 45 ) resistor r=52.7279 //w=0.214 //l=0.165 //layer=ply \
 //thickness=0.18 //x=5.67 //y=2.26 //x2=5.67 //y2=2.095
r89 (  42 55 ) resistor r=4.95774 //w=0.164 //l=0.112 //layer=ply \
 //thickness=0.18 //x=6.235 //y=1.435 //x2=6.235 //y2=1.547
r90 (  41 54 ) resistor r=45.1352 //w=0.168 //l=0.173853 //layer=ply \
 //thickness=0.18 //x=6.235 //y=1.085 //x2=6.195 //y2=0.93
r91 (  41 42 ) resistor r=179.468 //w=0.094 //l=0.35 //layer=ply \
 //thickness=0.18 //x=6.235 //y=1.085 //x2=6.235 //y2=1.435
r92 (  36 53 ) resistor r=10.8103 //w=0.211 //l=0.115 //layer=ply \
 //thickness=0.18 //x=5.86 //y=1.585 //x2=5.745 //y2=1.585
r93 (  35 55 ) resistor r=45.9962 //w=0.164 //l=0.17296 //layer=ply \
 //thickness=0.18 //x=6.08 //y=1.585 //x2=6.235 //y2=1.547
r94 (  34 52 ) resistor r=5.52526 //w=0.168 //l=0.115 //layer=ply \
 //thickness=0.18 //x=5.86 //y=0.93 //x2=5.745 //y2=0.93
r95 (  33 54 ) resistor r=5.52526 //w=0.168 //l=0.115 //layer=ply \
 //thickness=0.18 //x=6.08 //y=0.93 //x2=6.195 //y2=0.93
r96 (  33 34 ) resistor r=112.809 //w=0.094 //l=0.22 //layer=ply \
 //thickness=0.18 //x=6.08 //y=0.93 //x2=5.86 //y2=0.93
r97 (  32 50 ) resistor r=16.5046 //w=0.27 //l=0.135 //layer=ply \
 //thickness=0.18 //x=5.84 //y=4.975 //x2=5.705 //y2=4.975
r98 (  31 38 ) resistor r=26.9307 //w=0.15 //l=0.106066 //layer=ply \
 //thickness=0.18 //x=6.075 //y=4.975 //x2=6.15 //y2=5.05
r99 (  31 32 ) resistor r=120.5 //w=0.094 //l=0.235 //layer=ply \
 //thickness=0.18 //x=6.075 //y=4.975 //x2=5.84 //y2=4.975
r100 (  26 53 ) resistor r=39.5036 //w=0.211 //l=0.173853 //layer=ply \
 //thickness=0.18 //x=5.705 //y=1.74 //x2=5.745 //y2=1.585
r101 (  26 45 ) resistor r=182.032 //w=0.094 //l=0.355 //layer=ply \
 //thickness=0.18 //x=5.705 //y=1.74 //x2=5.705 //y2=2.095
r102 (  25 53 ) resistor r=38.3614 //w=0.211 //l=0.168819 //layer=ply \
 //thickness=0.18 //x=5.705 //y=1.435 //x2=5.745 //y2=1.585
r103 (  24 52 ) resistor r=45.1352 //w=0.168 //l=0.173853 //layer=ply \
 //thickness=0.18 //x=5.705 //y=1.085 //x2=5.745 //y2=0.93
r104 (  24 25 ) resistor r=179.468 //w=0.094 //l=0.35 //layer=ply \
 //thickness=0.18 //x=5.705 //y=1.085 //x2=5.705 //y2=1.435
r105 (  23 38 ) resistor r=592.245 //w=0.094 //l=1.155 //layer=ply \
 //thickness=0.18 //x=6.15 //y=6.205 //x2=6.15 //y2=5.05
r106 (  22 51 ) resistor r=592.245 //w=0.094 //l=1.155 //layer=ply \
 //thickness=0.18 //x=5.71 //y=6.205 //x2=5.71 //y2=5.05
r107 (  21 35 ) resistor r=56.4043 //w=0.094 //l=0.11 //layer=ply \
 //thickness=0.18 //x=5.97 //y=1.585 //x2=6.08 //y2=1.585
r108 (  21 36 ) resistor r=56.4043 //w=0.094 //l=0.11 //layer=ply \
 //thickness=0.18 //x=5.97 //y=1.585 //x2=5.86 //y2=1.585
r109 (  20 48 ) resistor r=152 //w=0.17 //l=0.17 //layer=licon //count=1 \
 //x=5.705 //y=4.885 //x2=5.705 //y2=4.885
r110 (  10 44 ) resistor r=152 //w=0.17 //l=0.17 //layer=licon //count=1 \
 //x=5.67 //y=2.26 //x2=5.67 //y2=2.26
r111 (  8 20 ) resistor r=11.332 //w=0.189 //l=0.173292 //layer=li \
 //thickness=0.1 //x=5.67 //y=4.72 //x2=5.687 //y2=4.885
r112 (  7 8 ) resistor r=6.84492 //w=0.187 //l=0.1 //layer=li //thickness=0.1 \
 //x=5.67 //y=4.62 //x2=5.67 //y2=4.72
r113 (  6 7 ) resistor r=25.3262 //w=0.187 //l=0.37 //layer=li //thickness=0.1 \
 //x=5.67 //y=4.25 //x2=5.67 //y2=4.62
r114 (  5 6 ) resistor r=25.3262 //w=0.187 //l=0.37 //layer=li //thickness=0.1 \
 //x=5.67 //y=3.88 //x2=5.67 //y2=4.25
r115 (  4 5 ) resistor r=25.3262 //w=0.187 //l=0.37 //layer=li //thickness=0.1 \
 //x=5.67 //y=3.51 //x2=5.67 //y2=3.88
r116 (  3 4 ) resistor r=25.3262 //w=0.187 //l=0.37 //layer=li //thickness=0.1 \
 //x=5.67 //y=3.14 //x2=5.67 //y2=3.51
r117 (  2 3 ) resistor r=25.3262 //w=0.187 //l=0.37 //layer=li //thickness=0.1 \
 //x=5.67 //y=2.77 //x2=5.67 //y2=3.14
r118 (  1 2 ) resistor r=25.3262 //w=0.187 //l=0.37 //layer=li //thickness=0.1 \
 //x=5.67 //y=2.4 //x2=5.67 //y2=2.77
r119 (  1 10 ) resistor r=9.58289 //w=0.187 //l=0.14 //layer=li \
 //thickness=0.1 //x=5.67 //y=2.4 //x2=5.67 //y2=2.26
ends PM_AO3X1\%C

subckt PM_AO3X1\%noxref_9 ( 7 8 15 16 23 24 25 )
c43 ( 25 0 ) capacitor c=0.0308836f //x=6.225 //y=5.205
c44 ( 24 0 ) capacitor c=0.0185379f //x=5.345 //y=5.205
c45 ( 23 0 ) capacitor c=0.0409962f //x=4.475 //y=5.205
c46 ( 16 0 ) capacitor c=0.00193672f //x=5.575 //y=7.09
c47 ( 15 0 ) capacitor c=0.01354f //x=6.285 //y=7.09
c48 ( 8 0 ) capacitor c=0.00844339f //x=4.695 //y=5.39
c49 ( 7 0 ) capacitor c=0.0252644f //x=5.405 //y=5.39
r50 (  17 25 ) resistor r=5.81818 //w=0.187 //l=0.085 //layer=li \
 //thickness=0.1 //x=6.37 //y=7.005 //x2=6.37 //y2=6.92
r51 (  15 17 ) resistor r=7.15173 //w=0.17 //l=0.120208 //layer=li \
 //thickness=0.1 //x=6.285 //y=7.09 //x2=6.37 //y2=7.005
r52 (  15 16 ) resistor r=48.5989 //w=0.187 //l=0.71 //layer=li \
 //thickness=0.1 //x=6.285 //y=7.09 //x2=5.575 //y2=7.09
r53 (  10 16 ) resistor r=7.15173 //w=0.17 //l=0.120208 //layer=li \
 //thickness=0.1 //x=5.49 //y=7.005 //x2=5.575 //y2=7.09
r54 (  10 24 ) resistor r=29.0909 //w=0.187 //l=0.425 //layer=li \
 //thickness=0.1 //x=5.49 //y=7.005 //x2=5.49 //y2=6.58
r55 (  9 24 ) resistor r=29.0909 //w=0.187 //l=0.425 //layer=li \
 //thickness=0.1 //x=5.49 //y=5.475 //x2=5.49 //y2=5.9
r56 (  7 9 ) resistor r=7.15173 //w=0.17 //l=0.120208 //layer=li \
 //thickness=0.1 //x=5.405 //y=5.39 //x2=5.49 //y2=5.475
r57 (  7 8 ) resistor r=48.5989 //w=0.187 //l=0.71 //layer=li //thickness=0.1 \
 //x=5.405 //y=5.39 //x2=4.695 //y2=5.39
r58 (  1 8 ) resistor r=7.15173 //w=0.17 //l=0.120208 //layer=li \
 //thickness=0.1 //x=4.61 //y=5.475 //x2=4.695 //y2=5.39
r59 (  1 23 ) resistor r=29.0909 //w=0.187 //l=0.425 //layer=li \
 //thickness=0.1 //x=4.61 //y=5.475 //x2=4.61 //y2=5.9
ends PM_AO3X1\%noxref_9

subckt PM_AO3X1\%Y ( 1 2 3 4 5 6 7 18 19 20 21 31 33 )
c43 ( 33 0 ) capacitor c=0.028734f //x=8.12 //y=5.2
c44 ( 31 0 ) capacitor c=0.0173218f //x=8.075 //y=1.09
c45 ( 21 0 ) capacitor c=0.00575887f //x=8.35 //y=4.76
c46 ( 20 0 ) capacitor c=0.0146395f //x=8.545 //y=4.76
c47 ( 19 0 ) capacitor c=0.00636159f //x=8.345 //y=2.26
c48 ( 18 0 ) capacitor c=0.0141837f //x=8.545 //y=2.26
c49 ( 1 0 ) capacitor c=0.105613f //x=8.63 //y=2.4
r50 (  20 23 ) resistor r=7.15173 //w=0.17 //l=0.120208 //layer=li \
 //thickness=0.1 //x=8.545 //y=4.76 //x2=8.63 //y2=4.675
r51 (  20 21 ) resistor r=13.3476 //w=0.187 //l=0.195 //layer=li \
 //thickness=0.1 //x=8.545 //y=4.76 //x2=8.35 //y2=4.76
r52 (  18 22 ) resistor r=7.15173 //w=0.17 //l=0.120208 //layer=li \
 //thickness=0.1 //x=8.545 //y=2.26 //x2=8.63 //y2=2.345
r53 (  18 19 ) resistor r=13.6898 //w=0.187 //l=0.2 //layer=li //thickness=0.1 \
 //x=8.545 //y=2.26 //x2=8.345 //y2=2.26
r54 (  12 21 ) resistor r=7.15173 //w=0.17 //l=0.120208 //layer=li \
 //thickness=0.1 //x=8.265 //y=4.845 //x2=8.35 //y2=4.76
r55 (  12 33 ) resistor r=72.5562 //w=0.187 //l=1.06 //layer=li \
 //thickness=0.1 //x=8.265 //y=4.845 //x2=8.265 //y2=5.905
r56 (  8 19 ) resistor r=7.15173 //w=0.17 //l=0.120208 //layer=li \
 //thickness=0.1 //x=8.26 //y=2.175 //x2=8.345 //y2=2.26
r57 (  8 31 ) resistor r=67.7647 //w=0.187 //l=0.99 //layer=li //thickness=0.1 \
 //x=8.26 //y=2.175 //x2=8.26 //y2=1.185
r58 (  7 23 ) resistor r=3.76471 //w=0.187 //l=0.055 //layer=li \
 //thickness=0.1 //x=8.63 //y=4.62 //x2=8.63 //y2=4.675
r59 (  6 7 ) resistor r=25.3262 //w=0.187 //l=0.37 //layer=li //thickness=0.1 \
 //x=8.63 //y=4.25 //x2=8.63 //y2=4.62
r60 (  5 6 ) resistor r=25.3262 //w=0.187 //l=0.37 //layer=li //thickness=0.1 \
 //x=8.63 //y=3.88 //x2=8.63 //y2=4.25
r61 (  4 5 ) resistor r=25.3262 //w=0.187 //l=0.37 //layer=li //thickness=0.1 \
 //x=8.63 //y=3.51 //x2=8.63 //y2=3.88
r62 (  3 4 ) resistor r=25.3262 //w=0.187 //l=0.37 //layer=li //thickness=0.1 \
 //x=8.63 //y=3.14 //x2=8.63 //y2=3.51
r63 (  2 3 ) resistor r=25.3262 //w=0.187 //l=0.37 //layer=li //thickness=0.1 \
 //x=8.63 //y=2.77 //x2=8.63 //y2=3.14
r64 (  1 2 ) resistor r=25.3262 //w=0.187 //l=0.37 //layer=li //thickness=0.1 \
 //x=8.63 //y=2.4 //x2=8.63 //y2=2.77
r65 (  1 22 ) resistor r=3.76471 //w=0.187 //l=0.055 //layer=li \
 //thickness=0.1 //x=8.63 //y=2.4 //x2=8.63 //y2=2.345
ends PM_AO3X1\%Y
