// File: AO3X1.spi.pex
// Created: Thu Jan 22 07:02:11 2026
// Program "Calibre xRC"
// Version "v2023.2_27.15"
// Nominal Temperature: 30C
// Circuit Temperature: 30C
//
simulator lang=spectre
subckt PM_AO3X1\%noxref_1 ( 3 8 9 11 12 14 15 16 18 19 20 23 24 27 29 32 35 38 \
 42 44 45 50 53 61 78 83 91 92 93 94 95 96 97 101 103 106 108 109 114 124 126 \
 127 )
c265 ( 124 0 ) capacitor c=0.00878249f //x=2.45 //y=1.085
c266 ( 114 0 ) capacitor c=0.0426341f //x=4.775 //y=4.885
c267 ( 109 0 ) capacitor c=0.0337825f //x=5.265 //y=1.43
c268 ( 108 0 ) capacitor c=0.0183823f //x=5.265 //y=1.085
c269 ( 106 0 ) capacitor c=0.0350928f //x=5.195 //y=4.975
c270 ( 103 0 ) capacitor c=0.013578f //x=5.11 //y=1.585
c271 ( 101 0 ) capacitor c=0.0157803f //x=5.11 //y=0.93
c272 ( 97 0 ) capacitor c=0.0787244f //x=4.735 //y=2.095
c273 ( 96 0 ) capacitor c=0.0230165f //x=4.735 //y=1.74
c274 ( 95 0 ) capacitor c=0.0234348f //x=4.735 //y=1.43
c275 ( 94 0 ) capacitor c=0.019134f //x=4.735 //y=1.085
c276 ( 93 0 ) capacitor c=0.110994f //x=5.27 //y=6.205
c277 ( 92 0 ) capacitor c=0.154777f //x=4.83 //y=6.205
c278 ( 83 0 ) capacitor c=4.74639e-19 //x=4.93 //y=2.26
c279 ( 78 0 ) capacitor c=0.0070524f //x=4.775 //y=4.885
c280 ( 61 0 ) capacitor c=0.0325392f //x=2.6 //y=5.56
c281 ( 53 0 ) capacitor c=0.0291911f //x=1.72 //y=5.56
c282 ( 50 0 ) capacitor c=0.00527867f //x=4.925 //y=2.77
c283 ( 45 0 ) capacitor c=0.00557348f //x=3.24 //y=2.77
c284 ( 44 0 ) capacitor c=0.0774598f //x=4.765 //y=2.77
c285 ( 42 0 ) capacitor c=0.00772583f //x=4.775 //y=4.885
c286 ( 38 0 ) capacitor c=0.00636094f //x=4.93 //y=2.26
c287 ( 35 0 ) capacitor c=0.0139347f //x=4.925 //y=2.77
c288 ( 32 0 ) capacitor c=0.0146565f //x=3.08 //y=2.77
c289 ( 29 0 ) capacitor c=0.011771f //x=2.64 //y=1.18
c290 ( 27 0 ) capacitor c=6.70882e-19 //x=2.6 //y=5.56
c291 ( 24 0 ) capacitor c=0.0129472f //x=2.6 //y=5.38
c292 ( 23 0 ) capacitor c=0.0106213f //x=1.72 //y=5.56
c293 ( 20 0 ) capacitor c=0.0625282f //x=4.93 //y=4.765
c294 ( 19 0 ) capacitor c=0.0110433f //x=4.93 //y=2.93
c295 ( 18 0 ) capacitor c=0.00430528f //x=4.93 //y=2.61
c296 ( 16 0 ) capacitor c=0.0760906f //x=3.08 //y=5.295
c297 ( 15 0 ) capacitor c=0.0117792f //x=3.08 //y=2.93
c298 ( 14 0 ) capacitor c=0.0170528f //x=3.08 //y=2.61
c299 ( 12 0 ) capacitor c=0.00837358f //x=2.725 //y=1.835
c300 ( 11 0 ) capacitor c=0.0136835f //x=2.995 //y=1.835
c301 ( 9 0 ) capacitor c=0.0123375f //x=2.995 //y=5.38
c302 ( 8 0 ) capacitor c=0.012699f //x=2.64 //y=1.75
c303 ( 3 0 ) capacitor c=0.019362f //x=2.485 //y=5.38
r304 (  116 117 ) resistor r=32.4568 //w=0.214 //l=0.075 //layer=ply \
 //thickness=0.18 //x=4.775 //y=4.975 //x2=4.775 //y2=5.05
r305 (  114 116 ) resistor r=20.271 //w=0.214 //l=0.09 //layer=ply \
 //thickness=0.18 //x=4.775 //y=4.885 //x2=4.775 //y2=4.975
r306 (  109 123 ) resistor r=45.1352 //w=0.168 //l=0.173853 //layer=ply \
 //thickness=0.18 //x=5.265 //y=1.43 //x2=5.225 //y2=1.585
r307 (  108 122 ) resistor r=45.1352 //w=0.168 //l=0.173853 //layer=ply \
 //thickness=0.18 //x=5.265 //y=1.085 //x2=5.225 //y2=0.93
r308 (  108 109 ) resistor r=176.904 //w=0.094 //l=0.345 //layer=ply \
 //thickness=0.18 //x=5.265 //y=1.085 //x2=5.265 //y2=1.43
r309 (  107 116 ) resistor r=16.5046 //w=0.27 //l=0.135 //layer=ply \
 //thickness=0.18 //x=4.91 //y=4.975 //x2=4.775 //y2=4.975
r310 (  106 110 ) resistor r=26.9307 //w=0.15 //l=0.106066 //layer=ply \
 //thickness=0.18 //x=5.195 //y=4.975 //x2=5.27 //y2=5.05
r311 (  106 107 ) resistor r=146.138 //w=0.094 //l=0.285 //layer=ply \
 //thickness=0.18 //x=5.195 //y=4.975 //x2=4.91 //y2=4.975
r312 (  104 121 ) resistor r=10.701 //w=0.21 //l=0.115 //layer=ply \
 //thickness=0.18 //x=4.89 //y=1.585 //x2=4.775 //y2=1.585
r313 (  103 123 ) resistor r=5.52526 //w=0.168 //l=0.115 //layer=ply \
 //thickness=0.18 //x=5.11 //y=1.585 //x2=5.225 //y2=1.585
r314 (  102 120 ) resistor r=5.52526 //w=0.168 //l=0.115 //layer=ply \
 //thickness=0.18 //x=4.89 //y=0.93 //x2=4.775 //y2=0.93
r315 (  101 122 ) resistor r=5.52526 //w=0.168 //l=0.115 //layer=ply \
 //thickness=0.18 //x=5.11 //y=0.93 //x2=5.225 //y2=0.93
r316 (  101 102 ) resistor r=112.809 //w=0.094 //l=0.22 //layer=ply \
 //thickness=0.18 //x=5.11 //y=0.93 //x2=4.89 //y2=0.93
r317 (  97 119 ) resistor r=34.8111 //w=0.27 //l=0.264953 //layer=ply \
 //thickness=0.18 //x=4.735 //y=2.095 //x2=4.93 //y2=2.26
r318 (  96 121 ) resistor r=39.5823 //w=0.21 //l=0.173853 //layer=ply \
 //thickness=0.18 //x=4.735 //y=1.74 //x2=4.775 //y2=1.585
r319 (  96 97 ) resistor r=182.032 //w=0.094 //l=0.355 //layer=ply \
 //thickness=0.18 //x=4.735 //y=1.74 //x2=4.735 //y2=2.095
r320 (  95 121 ) resistor r=39.5823 //w=0.21 //l=0.173853 //layer=ply \
 //thickness=0.18 //x=4.735 //y=1.43 //x2=4.775 //y2=1.585
r321 (  94 120 ) resistor r=45.1352 //w=0.168 //l=0.173853 //layer=ply \
 //thickness=0.18 //x=4.735 //y=1.085 //x2=4.775 //y2=0.93
r322 (  94 95 ) resistor r=176.904 //w=0.094 //l=0.345 //layer=ply \
 //thickness=0.18 //x=4.735 //y=1.085 //x2=4.735 //y2=1.43
r323 (  93 110 ) resistor r=592.245 //w=0.094 //l=1.155 //layer=ply \
 //thickness=0.18 //x=5.27 //y=6.205 //x2=5.27 //y2=5.05
r324 (  92 117 ) resistor r=592.245 //w=0.094 //l=1.155 //layer=ply \
 //thickness=0.18 //x=4.83 //y=6.205 //x2=4.83 //y2=5.05
r325 (  91 103 ) resistor r=56.4043 //w=0.094 //l=0.11 //layer=ply \
 //thickness=0.18 //x=5 //y=1.585 //x2=5.11 //y2=1.585
r326 (  91 104 ) resistor r=56.4043 //w=0.094 //l=0.11 //layer=ply \
 //thickness=0.18 //x=5 //y=1.585 //x2=4.89 //y2=1.585
r327 (  83 119 ) resistor r=152 //w=0.17 //l=0.17 //layer=licon //count=1 \
 //x=4.93 //y=2.26 //x2=4.93 //y2=2.26
r328 (  78 114 ) resistor r=152 //w=0.17 //l=0.17 //layer=licon //count=1 \
 //x=4.775 //y=4.885 //x2=4.775 //y2=4.885
r329 (  61 127 ) resistor r=23.615 //w=0.187 //l=0.345 //layer=li \
 //thickness=0.1 //x=2.6 //y=5.56 //x2=2.6 //y2=5.905
r330 (  53 126 ) resistor r=23.615 //w=0.187 //l=0.345 //layer=li \
 //thickness=0.1 //x=1.72 //y=5.56 //x2=1.72 //y2=5.905
r331 (  45 47 ) resistor r=0.10734 //w=0.281 //l=0.16 //layer=m2 \
 //thickness=0.36 //x=3.24 //y=2.77 //x2=3.08 //y2=2.77
r332 (  44 50 ) resistor r=0.10734 //w=0.281 //l=0.16 //layer=m2 \
 //thickness=0.36 //x=4.765 //y=2.77 //x2=4.925 //y2=2.77
r333 (  44 45 ) resistor r=1.45515 //w=0.131 //l=1.525 //layer=m2 \
 //thickness=0.36 //x=4.765 //y=2.77 //x2=3.24 //y2=2.77
r334 (  42 78 ) resistor r=9.3 //w=0.17 //l=0.17 //layer=mcon //count=1 \
 //x=4.775 //y=4.885 //x2=4.775 //y2=4.885
r335 (  42 43 ) resistor r=0.0853524 //w=0.227 //l=0.155 //layer=m1 \
 //thickness=0.36 //x=4.775 //y=4.882 //x2=4.93 //y2=4.882
r336 (  38 83 ) resistor r=9.3 //w=0.17 //l=0.17 //layer=mcon //count=1 \
 //x=4.93 //y=2.26 //x2=4.93 //y2=2.26
r337 (  38 40 ) resistor r=0.0985786 //w=0.206 //l=0.135 //layer=m1 \
 //thickness=0.36 //x=4.927 //y=2.26 //x2=4.927 //y2=2.395
r338 (  35 50 ) resistor r=4.5 //w=0.15 //l=0.15 //layer=via1 //count=1 \
 //x=4.925 //y=2.77 //x2=4.925 //y2=2.77
r339 (  32 47 ) resistor r=4.5 //w=0.15 //l=0.15 //layer=via1 //count=1 \
 //x=3.08 //y=2.77 //x2=3.08 //y2=2.77
r340 (  29 124 ) resistor r=9.3 //w=0.17 //l=0.17 //layer=mcon //count=1 \
 //x=2.64 //y=1.18 //x2=2.64 //y2=1.18
r341 (  27 61 ) resistor r=9.3 //w=0.17 //l=0.17 //layer=mcon //count=1 \
 //x=2.6 //y=5.56 //x2=2.6 //y2=5.56
r342 (  24 27 ) resistor r=0.117801 //w=0.191 //l=0.18 //layer=m1 \
 //thickness=0.36 //x=2.6 //y=5.38 //x2=2.6 //y2=5.56
r343 (  23 53 ) resistor r=9.3 //w=0.17 //l=0.17 //layer=mcon //count=1 \
 //x=1.72 //y=5.56 //x2=1.72 //y2=5.56
r344 (  21 23 ) resistor r=0.10274 //w=0.219 //l=0.18 //layer=m1 \
 //thickness=0.36 //x=1.72 //y=5.38 //x2=1.72 //y2=5.56
r345 (  20 43 ) resistor r=0.0249239 //w=0.227 //l=0.117 //layer=m1 \
 //thickness=0.36 //x=4.93 //y=4.765 //x2=4.93 //y2=4.882
r346 (  19 35 ) resistor r=0.0910802 //w=0.374 //l=0.185472 //layer=m1 \
 //thickness=0.36 //x=4.93 //y=2.93 //x2=4.875 //y2=2.77
r347 (  19 20 ) resistor r=1.75095 //w=0.131 //l=1.835 //layer=m1 \
 //thickness=0.36 //x=4.93 //y=2.93 //x2=4.93 //y2=4.765
r348 (  18 35 ) resistor r=0.0910802 //w=0.374 //l=0.185472 //layer=m1 \
 //thickness=0.36 //x=4.93 //y=2.61 //x2=4.875 //y2=2.77
r349 (  18 40 ) resistor r=0.205153 //w=0.131 //l=0.215 //layer=m1 \
 //thickness=0.36 //x=4.93 //y=2.61 //x2=4.93 //y2=2.395
r350 (  15 32 ) resistor r=0.0911593 //w=0.376 //l=0.184174 //layer=m1 \
 //thickness=0.36 //x=3.08 //y=2.93 //x2=3.132 //y2=2.77
r351 (  15 16 ) resistor r=2.25668 //w=0.131 //l=2.365 //layer=m1 \
 //thickness=0.36 //x=3.08 //y=2.93 //x2=3.08 //y2=5.295
r352 (  14 32 ) resistor r=0.0911593 //w=0.376 //l=0.184174 //layer=m1 \
 //thickness=0.36 //x=3.08 //y=2.61 //x2=3.132 //y2=2.77
r353 (  13 14 ) resistor r=0.658397 //w=0.131 //l=0.69 //layer=m1 \
 //thickness=0.36 //x=3.08 //y=1.92 //x2=3.08 //y2=2.61
r354 (  11 13 ) resistor r=0.0698411 //w=0.17 //l=0.120208 //layer=m1 \
 //thickness=0.36 //x=2.995 //y=1.835 //x2=3.08 //y2=1.92
r355 (  11 12 ) resistor r=0.257634 //w=0.131 //l=0.27 //layer=m1 \
 //thickness=0.36 //x=2.995 //y=1.835 //x2=2.725 //y2=1.835
r356 (  10 24 ) resistor r=0.0257089 //w=0.23 //l=0.115 //layer=m1 \
 //thickness=0.36 //x=2.715 //y=5.38 //x2=2.6 //y2=5.38
r357 (  9 16 ) resistor r=0.0698411 //w=0.17 //l=0.120208 //layer=m1 \
 //thickness=0.36 //x=2.995 //y=5.38 //x2=3.08 //y2=5.295
r358 (  9 10 ) resistor r=0.267176 //w=0.131 //l=0.28 //layer=m1 \
 //thickness=0.36 //x=2.995 //y=5.38 //x2=2.715 //y2=5.38
r359 (  8 12 ) resistor r=0.0698411 //w=0.17 //l=0.120208 //layer=m1 \
 //thickness=0.36 //x=2.64 //y=1.75 //x2=2.725 //y2=1.835
r360 (  7 29 ) resistor r=0.0913624 //w=0.191 //l=0.12 //layer=m1 \
 //thickness=0.36 //x=2.64 //y=1.3 //x2=2.64 //y2=1.18
r361 (  7 8 ) resistor r=0.429389 //w=0.131 //l=0.45 //layer=m1 \
 //thickness=0.36 //x=2.64 //y=1.3 //x2=2.64 //y2=1.75
r362 (  4 21 ) resistor r=0.0227762 //w=0.219 //l=0.115 //layer=m1 \
 //thickness=0.36 //x=1.835 //y=5.38 //x2=1.72 //y2=5.38
r363 (  3 24 ) resistor r=0.0257089 //w=0.23 //l=0.115 //layer=m1 \
 //thickness=0.36 //x=2.485 //y=5.38 //x2=2.6 //y2=5.38
r364 (  3 4 ) resistor r=0.620229 //w=0.131 //l=0.65 //layer=m1 \
 //thickness=0.36 //x=2.485 //y=5.38 //x2=1.835 //y2=5.38
ends PM_AO3X1\%noxref_1

subckt PM_AO3X1\%noxref_2 ( 1 2 3 4 5 6 7 9 12 13 14 16 17 18 22 28 31 34 43 \
 45 46 54 71 80 84 85 86 87 88 89 90 94 95 96 98 104 105 107 115 116 119 )
c246 ( 116 0 ) capacitor c=0.00901091f //x=5.78 //y=1.085
c247 ( 115 0 ) capacitor c=0.00876479f //x=4.81 //y=1.085
c248 ( 107 0 ) capacitor c=0.0556167f //x=7.89 //y=2.265
c249 ( 105 0 ) capacitor c=0.0439576f //x=8.53 //y=1.435
c250 ( 104 0 ) capacitor c=0.0201087f //x=8.53 //y=1.09
c251 ( 98 0 ) capacitor c=0.0161986f //x=8.375 //y=1.59
c252 ( 96 0 ) capacitor c=0.0157807f //x=8.375 //y=0.935
c253 ( 95 0 ) capacitor c=0.0557689f //x=8.12 //y=4.97
c254 ( 94 0 ) capacitor c=0.0406047f //x=8.41 //y=4.97
c255 ( 90 0 ) capacitor c=0.0301471f //x=8 //y=2.1
c256 ( 89 0 ) capacitor c=0.0255349f //x=8 //y=1.745
c257 ( 88 0 ) capacitor c=0.0234346f //x=8 //y=1.435
c258 ( 87 0 ) capacitor c=0.02013f //x=8 //y=1.09
c259 ( 86 0 ) capacitor c=0.153839f //x=8.485 //y=6.2
c260 ( 85 0 ) capacitor c=0.15434f //x=8.045 //y=6.2
c261 ( 80 0 ) capacitor c=9.4527e-19 //x=7.89 //y=4.88
c262 ( 71 0 ) capacitor c=6.43121e-19 //x=7.89 //y=2.265
c263 ( 54 0 ) capacitor c=0.0246131f //x=5.93 //y=5.56
c264 ( 46 0 ) capacitor c=0.0582172f //x=7.725 //y=2.77
c265 ( 45 0 ) capacitor c=0.00440097f //x=7.885 //y=2.77
c266 ( 43 0 ) capacitor c=0.00546501f //x=6.565 //y=2.77
c267 ( 34 0 ) capacitor c=0.0110655f //x=7.89 //y=2.265
c268 ( 31 0 ) capacitor c=0.012167f //x=7.885 //y=2.77
c269 ( 28 0 ) capacitor c=0.0140157f //x=6.405 //y=2.77
c270 ( 22 0 ) capacitor c=0.0135175f //x=5.925 //y=5.39
c271 ( 21 0 ) capacitor c=0.00513603f //x=5.97 //y=1.835
c272 ( 18 0 ) capacitor c=0.0607198f //x=7.89 //y=4.76
c273 ( 17 0 ) capacitor c=0.011524f //x=7.89 //y=2.93
c274 ( 16 0 ) capacitor c=0.00275838f //x=7.89 //y=2.61
c275 ( 14 0 ) capacitor c=0.0691584f //x=6.41 //y=5.305
c276 ( 13 0 ) capacitor c=0.012052f //x=6.41 //y=2.93
c277 ( 12 0 ) capacitor c=0.0149172f //x=6.41 //y=2.61
c278 ( 9 0 ) capacitor c=0.0137393f //x=6.325 //y=1.835
c279 ( 7 0 ) capacitor c=0.0111434f //x=6.325 //y=5.39
c280 ( 6 0 ) capacitor c=0.00690516f //x=5.97 //y=1.75
c281 ( 5 0 ) capacitor c=0.00843314f //x=5.97 //y=1.3
c282 ( 4 0 ) capacitor c=0.0023108f //x=5.085 //y=1.835
c283 ( 3 0 ) capacitor c=0.0217217f //x=5.885 //y=1.835
c284 ( 2 0 ) capacitor c=0.00638036f //x=5 //y=1.75
c285 ( 1 0 ) capacitor c=0.00825944f //x=5 //y=1.305
r286 (  107 108 ) resistor r=17.5563 //w=0.302 //l=0.11 //layer=ply \
 //thickness=0.18 //x=7.89 //y=2.265 //x2=8 //y2=2.265
r287 (  105 114 ) resistor r=45.1352 //w=0.168 //l=0.173853 //layer=ply \
 //thickness=0.18 //x=8.53 //y=1.435 //x2=8.49 //y2=1.59
r288 (  104 113 ) resistor r=45.1352 //w=0.168 //l=0.173853 //layer=ply \
 //thickness=0.18 //x=8.53 //y=1.09 //x2=8.49 //y2=0.935
r289 (  104 105 ) resistor r=176.904 //w=0.094 //l=0.345 //layer=ply \
 //thickness=0.18 //x=8.53 //y=1.09 //x2=8.53 //y2=1.435
r290 (  99 112 ) resistor r=10.701 //w=0.21 //l=0.115 //layer=ply \
 //thickness=0.18 //x=8.155 //y=1.59 //x2=8.04 //y2=1.59
r291 (  98 114 ) resistor r=5.52526 //w=0.168 //l=0.115 //layer=ply \
 //thickness=0.18 //x=8.375 //y=1.59 //x2=8.49 //y2=1.59
r292 (  97 111 ) resistor r=5.52526 //w=0.168 //l=0.115 //layer=ply \
 //thickness=0.18 //x=8.155 //y=0.935 //x2=8.04 //y2=0.935
r293 (  96 113 ) resistor r=5.52526 //w=0.168 //l=0.115 //layer=ply \
 //thickness=0.18 //x=8.375 //y=0.935 //x2=8.49 //y2=0.935
r294 (  96 97 ) resistor r=112.809 //w=0.094 //l=0.22 //layer=ply \
 //thickness=0.18 //x=8.375 //y=0.935 //x2=8.155 //y2=0.935
r295 (  94 101 ) resistor r=26.9307 //w=0.15 //l=0.106066 //layer=ply \
 //thickness=0.18 //x=8.41 //y=4.97 //x2=8.485 //y2=5.045
r296 (  94 95 ) resistor r=148.702 //w=0.094 //l=0.29 //layer=ply \
 //thickness=0.18 //x=8.41 //y=4.97 //x2=8.12 //y2=4.97
r297 (  91 95 ) resistor r=23.403 //w=0.284 //l=0.106066 //layer=ply \
 //thickness=0.18 //x=8.045 //y=5.045 //x2=8.12 //y2=4.97
r298 (  91 110 ) resistor r=26.3063 //w=0.284 //l=0.229783 //layer=ply \
 //thickness=0.18 //x=8.045 //y=5.045 //x2=7.89 //y2=4.88
r299 (  90 108 ) resistor r=19.1248 //w=0.302 //l=0.165 //layer=ply \
 //thickness=0.18 //x=8 //y=2.1 //x2=8 //y2=2.265
r300 (  89 112 ) resistor r=39.5823 //w=0.21 //l=0.173853 //layer=ply \
 //thickness=0.18 //x=8 //y=1.745 //x2=8.04 //y2=1.59
r301 (  89 90 ) resistor r=182.032 //w=0.094 //l=0.355 //layer=ply \
 //thickness=0.18 //x=8 //y=1.745 //x2=8 //y2=2.1
r302 (  88 112 ) resistor r=39.5823 //w=0.21 //l=0.173853 //layer=ply \
 //thickness=0.18 //x=8 //y=1.435 //x2=8.04 //y2=1.59
r303 (  87 111 ) resistor r=45.1352 //w=0.168 //l=0.173853 //layer=ply \
 //thickness=0.18 //x=8 //y=1.09 //x2=8.04 //y2=0.935
r304 (  87 88 ) resistor r=176.904 //w=0.094 //l=0.345 //layer=ply \
 //thickness=0.18 //x=8 //y=1.09 //x2=8 //y2=1.435
r305 (  86 101 ) resistor r=592.245 //w=0.094 //l=1.155 //layer=ply \
 //thickness=0.18 //x=8.485 //y=6.2 //x2=8.485 //y2=5.045
r306 (  85 91 ) resistor r=592.245 //w=0.094 //l=1.155 //layer=ply \
 //thickness=0.18 //x=8.045 //y=6.2 //x2=8.045 //y2=5.045
r307 (  84 98 ) resistor r=56.4043 //w=0.094 //l=0.11 //layer=ply \
 //thickness=0.18 //x=8.265 //y=1.59 //x2=8.375 //y2=1.59
r308 (  84 99 ) resistor r=56.4043 //w=0.094 //l=0.11 //layer=ply \
 //thickness=0.18 //x=8.265 //y=1.59 //x2=8.155 //y2=1.59
r309 (  80 110 ) resistor r=152 //w=0.17 //l=0.17 //layer=licon //count=1 \
 //x=7.89 //y=4.88 //x2=7.89 //y2=4.88
r310 (  71 107 ) resistor r=152 //w=0.17 //l=0.17 //layer=licon //count=1 \
 //x=7.89 //y=2.265 //x2=7.89 //y2=2.265
r311 (  54 119 ) resistor r=23.2727 //w=0.187 //l=0.34 //layer=li \
 //thickness=0.1 //x=5.93 //y=5.56 //x2=5.93 //y2=5.9
r312 (  45 46 ) resistor r=0.101938 //w=0.281 //l=0.16 //layer=m2 \
 //thickness=0.36 //x=7.885 //y=2.77 //x2=7.725 //y2=2.77
r313 (  43 46 ) resistor r=1.02837 //w=0.141 //l=1.16 //layer=m2 \
 //thickness=0.36 //x=6.565 //y=2.765 //x2=7.725 //y2=2.765
r314 (  41 43 ) resistor r=0.101938 //w=0.281 //l=0.16 //layer=m2 \
 //thickness=0.36 //x=6.405 //y=2.77 //x2=6.565 //y2=2.77
r315 (  37 80 ) resistor r=9.3 //w=0.17 //l=0.17 //layer=mcon //count=1 \
 //x=7.89 //y=4.88 //x2=7.89 //y2=4.88
r316 (  34 71 ) resistor r=9.3 //w=0.17 //l=0.17 //layer=mcon //count=1 \
 //x=7.89 //y=2.265 //x2=7.89 //y2=2.265
r317 (  31 45 ) resistor r=4.5 //w=0.15 //l=0.15 //layer=via1 //count=1 \
 //x=7.885 //y=2.77 //x2=7.885 //y2=2.77
r318 (  28 41 ) resistor r=4.5 //w=0.15 //l=0.15 //layer=via1 //count=1 \
 //x=6.405 //y=2.77 //x2=6.405 //y2=2.77
r319 (  26 116 ) resistor r=9.3 //w=0.17 //l=0.17 //layer=mcon //count=1 \
 //x=5.97 //y=1.18 //x2=5.97 //y2=1.18
r320 (  24 54 ) resistor r=9.3 //w=0.17 //l=0.17 //layer=mcon //count=1 \
 //x=5.93 //y=5.56 //x2=5.93 //y2=5.56
r321 (  22 24 ) resistor r=0.0974771 //w=0.218 //l=0.17 //layer=m1 \
 //thickness=0.36 //x=5.925 //y=5.39 //x2=5.925 //y2=5.56
r322 (  20 115 ) resistor r=9.3 //w=0.17 //l=0.17 //layer=mcon //count=1 //x=5 \
 //y=1.18 //x2=5 //y2=1.18
r323 (  18 37 ) resistor r=0.0732479 //w=0.241 //l=0.122474 //layer=m1 \
 //thickness=0.36 //x=7.89 //y=4.76 //x2=7.895 //y2=4.88
r324 (  17 31 ) resistor r=0.0910802 //w=0.374 //l=0.185472 //layer=m1 \
 //thickness=0.36 //x=7.89 //y=2.93 //x2=7.835 //y2=2.77
r325 (  17 18 ) resistor r=1.74618 //w=0.131 //l=1.83 //layer=m1 \
 //thickness=0.36 //x=7.89 //y=2.93 //x2=7.89 //y2=4.76
r326 (  16 31 ) resistor r=0.0910802 //w=0.374 //l=0.185472 //layer=m1 \
 //thickness=0.36 //x=7.89 //y=2.61 //x2=7.835 //y2=2.77
r327 (  15 34 ) resistor r=0.116051 //w=0.211 //l=0.165 //layer=m1 \
 //thickness=0.36 //x=7.89 //y=2.43 //x2=7.89 //y2=2.265
r328 (  15 16 ) resistor r=0.171756 //w=0.131 //l=0.18 //layer=m1 \
 //thickness=0.36 //x=7.89 //y=2.43 //x2=7.89 //y2=2.61
r329 (  13 28 ) resistor r=0.0912814 //w=0.379 //l=0.183303 //layer=m1 \
 //thickness=0.36 //x=6.41 //y=2.93 //x2=6.46 //y2=2.77
r330 (  13 14 ) resistor r=2.26622 //w=0.131 //l=2.375 //layer=m1 \
 //thickness=0.36 //x=6.41 //y=2.93 //x2=6.41 //y2=5.305
r331 (  12 28 ) resistor r=0.0912814 //w=0.379 //l=0.183303 //layer=m1 \
 //thickness=0.36 //x=6.41 //y=2.61 //x2=6.46 //y2=2.77
r332 (  11 12 ) resistor r=0.658397 //w=0.131 //l=0.69 //layer=m1 \
 //thickness=0.36 //x=6.41 //y=1.92 //x2=6.41 //y2=2.61
r333 (  10 21 ) resistor r=0.0529306 //w=0.17 //l=0.085 //layer=m1 \
 //thickness=0.36 //x=6.055 //y=1.835 //x2=5.97 //y2=1.835
r334 (  9 11 ) resistor r=0.0698411 //w=0.17 //l=0.120208 //layer=m1 \
 //thickness=0.36 //x=6.325 //y=1.835 //x2=6.41 //y2=1.92
r335 (  9 10 ) resistor r=0.257634 //w=0.131 //l=0.27 //layer=m1 \
 //thickness=0.36 //x=6.325 //y=1.835 //x2=6.055 //y2=1.835
r336 (  8 22 ) resistor r=0.0225019 //w=0.218 //l=0.12 //layer=m1 \
 //thickness=0.36 //x=6.045 //y=5.39 //x2=5.925 //y2=5.39
r337 (  7 14 ) resistor r=0.0698411 //w=0.17 //l=0.120208 //layer=m1 \
 //thickness=0.36 //x=6.325 //y=5.39 //x2=6.41 //y2=5.305
r338 (  7 8 ) resistor r=0.267176 //w=0.131 //l=0.28 //layer=m1 \
 //thickness=0.36 //x=6.325 //y=5.39 //x2=6.045 //y2=5.39
r339 (  6 21 ) resistor r=0.0137558 //w=0.34 //l=0.085 //layer=m1 \
 //thickness=0.36 //x=5.97 //y=1.75 //x2=5.97 //y2=1.835
r340 (  5 26 ) resistor r=0.0728765 //w=0.25 //l=0.121491 //layer=m1 \
 //thickness=0.36 //x=5.97 //y=1.3 //x2=5.967 //y2=1.18
r341 (  5 6 ) resistor r=0.429389 //w=0.131 //l=0.45 //layer=m1 \
 //thickness=0.36 //x=5.97 //y=1.3 //x2=5.97 //y2=1.75
r342 (  3 21 ) resistor r=0.0529306 //w=0.17 //l=0.085 //layer=m1 \
 //thickness=0.36 //x=5.885 //y=1.835 //x2=5.97 //y2=1.835
r343 (  3 4 ) resistor r=0.763359 //w=0.131 //l=0.8 //layer=m1 \
 //thickness=0.36 //x=5.885 //y=1.835 //x2=5.085 //y2=1.835
r344 (  2 4 ) resistor r=0.0698411 //w=0.17 //l=0.120208 //layer=m1 \
 //thickness=0.36 //x=5 //y=1.75 //x2=5.085 //y2=1.835
r345 (  1 20 ) resistor r=0.0764279 //w=0.233 //l=0.126491 //layer=m1 \
 //thickness=0.36 //x=5 //y=1.305 //x2=4.997 //y2=1.18
r346 (  1 2 ) resistor r=0.424618 //w=0.131 //l=0.445 //layer=m1 \
 //thickness=0.36 //x=5 //y=1.305 //x2=5 //y2=1.75
ends PM_AO3X1\%noxref_2

subckt PM_AO3X1\%VDD ( 1 2 12 13 20 43 51 67 94 109 112 113 116 117 118 119 \
 120 121 122 )
c172 ( 122 0 ) capacitor c=0.0631392f //x=8.56 //y=5.2
c173 ( 121 0 ) capacitor c=0.0581256f //x=7.69 //y=5.2
c174 ( 120 0 ) capacitor c=0.0230394f //x=4.905 //y=5.205
c175 ( 119 0 ) capacitor c=0.0399069f //x=2.895 //y=5.2
c176 ( 118 0 ) capacitor c=0.0247434f //x=2.015 //y=5.2
c177 ( 117 0 ) capacitor c=0.0678024f //x=1.145 //y=5.2
c178 ( 116 0 ) capacitor c=0.259717f //x=8.63 //y=7.58
c179 ( 114 0 ) capacitor c=0.00597439f //x=7.825 //y=7.585
c180 ( 113 0 ) capacitor c=0.123002f //x=7.15 //y=7.585
c181 ( 112 0 ) capacitor c=0.126563f //x=3.82 //y=7.585
c182 ( 111 0 ) capacitor c=0.00597439f //x=3.04 //y=7.585
c183 ( 110 0 ) capacitor c=0.00597439f //x=2.16 //y=7.585
c184 ( 109 0 ) capacitor c=0.272077f //x=1.23 //y=7.58
c185 ( 94 0 ) capacitor c=0.0289924f //x=8.62 //y=7.585
c186 ( 82 0 ) capacitor c=0.0217664f //x=7.74 //y=7.585
c187 ( 67 0 ) capacitor c=0.139031f //x=6.98 //y=7.585
c188 ( 61 0 ) capacitor c=0.0277785f //x=3.65 //y=7.585
c189 ( 51 0 ) capacitor c=0.0287375f //x=2.955 //y=7.585
c190 ( 43 0 ) capacitor c=0.0291078f //x=2.075 //y=7.585
c191 ( 24 0 ) capacitor c=0.00499323f //x=5.05 //y=7.585
c192 ( 20 0 ) capacitor c=0.18298f //x=8.63 //y=7.58
c193 ( 13 0 ) capacitor c=0.00916089f //x=5.05 //y=7.41
c194 ( 12 0 ) capacitor c=0.00572492f //x=5.05 //y=7.035
c195 ( 2 0 ) capacitor c=0.19705f //x=4.965 //y=7.585
r196 (  96 116 ) resistor r=4.23183 //w=0.7 //l=0.175 //layer=li \
 //thickness=0.1 //x=8.705 //y=7.41 //x2=8.705 //y2=7.585
r197 (  96 122 ) resistor r=56.4706 //w=0.187 //l=0.825 //layer=li \
 //thickness=0.1 //x=8.705 //y=7.41 //x2=8.705 //y2=6.585
r198 (  95 114 ) resistor r=2.87058 //w=0.35 //l=0.085 //layer=li \
 //thickness=0.1 //x=7.91 //y=7.585 //x2=7.825 //y2=7.585
r199 (  94 116 ) resistor r=2.87058 //w=0.35 //l=0.085 //layer=li \
 //thickness=0.1 //x=8.62 //y=7.585 //x2=8.705 //y2=7.585
r200 (  94 95 ) resistor r=24.7629 //w=0.367 //l=0.71 //layer=li \
 //thickness=0.1 //x=8.62 //y=7.585 //x2=7.91 //y2=7.585
r201 (  86 114 ) resistor r=4.23183 //w=0.7 //l=0.175 //layer=li \
 //thickness=0.1 //x=7.825 //y=7.41 //x2=7.825 //y2=7.585
r202 (  86 121 ) resistor r=56.4706 //w=0.187 //l=0.825 //layer=li \
 //thickness=0.1 //x=7.825 //y=7.41 //x2=7.825 //y2=6.585
r203 (  83 113 ) resistor r=5.29055 //w=0.35 //l=0.17 //layer=li \
 //thickness=0.1 //x=7.32 //y=7.585 //x2=7.15 //y2=7.585
r204 (  83 85 ) resistor r=6.97548 //w=0.367 //l=0.2 //layer=li \
 //thickness=0.1 //x=7.32 //y=7.585 //x2=7.52 //y2=7.585
r205 (  82 114 ) resistor r=2.87058 //w=0.35 //l=0.085 //layer=li \
 //thickness=0.1 //x=7.74 //y=7.585 //x2=7.825 //y2=7.585
r206 (  82 85 ) resistor r=7.67302 //w=0.367 //l=0.22 //layer=li \
 //thickness=0.1 //x=7.74 //y=7.585 //x2=7.52 //y2=7.585
r207 (  70 72 ) resistor r=38.7139 //w=0.367 //l=1.11 //layer=li \
 //thickness=0.1 //x=4.93 //y=7.585 //x2=6.04 //y2=7.585
r208 (  68 112 ) resistor r=5.29055 //w=0.35 //l=0.17 //layer=li \
 //thickness=0.1 //x=3.99 //y=7.585 //x2=3.82 //y2=7.585
r209 (  68 70 ) resistor r=32.7847 //w=0.367 //l=0.94 //layer=li \
 //thickness=0.1 //x=3.99 //y=7.585 //x2=4.93 //y2=7.585
r210 (  67 113 ) resistor r=5.29055 //w=0.35 //l=0.17 //layer=li \
 //thickness=0.1 //x=6.98 //y=7.585 //x2=7.15 //y2=7.585
r211 (  67 72 ) resistor r=32.7847 //w=0.367 //l=0.94 //layer=li \
 //thickness=0.1 //x=6.98 //y=7.585 //x2=6.04 //y2=7.585
r212 (  62 111 ) resistor r=2.87058 //w=0.35 //l=0.085 //layer=li \
 //thickness=0.1 //x=3.125 //y=7.585 //x2=3.04 //y2=7.585
r213 (  62 64 ) resistor r=11.3351 //w=0.367 //l=0.325 //layer=li \
 //thickness=0.1 //x=3.125 //y=7.585 //x2=3.45 //y2=7.585
r214 (  61 112 ) resistor r=5.29055 //w=0.35 //l=0.17 //layer=li \
 //thickness=0.1 //x=3.65 //y=7.585 //x2=3.82 //y2=7.585
r215 (  61 64 ) resistor r=6.97548 //w=0.367 //l=0.2 //layer=li \
 //thickness=0.1 //x=3.65 //y=7.585 //x2=3.45 //y2=7.585
r216 (  55 111 ) resistor r=4.23183 //w=0.7 //l=0.175 //layer=li \
 //thickness=0.1 //x=3.04 //y=7.41 //x2=3.04 //y2=7.585
r217 (  55 119 ) resistor r=33.1979 //w=0.187 //l=0.485 //layer=li \
 //thickness=0.1 //x=3.04 //y=7.41 //x2=3.04 //y2=6.925
r218 (  52 110 ) resistor r=2.87058 //w=0.35 //l=0.085 //layer=li \
 //thickness=0.1 //x=2.245 //y=7.585 //x2=2.16 //y2=7.585
r219 (  52 54 ) resistor r=3.31335 //w=0.367 //l=0.095 //layer=li \
 //thickness=0.1 //x=2.245 //y=7.585 //x2=2.34 //y2=7.585
r220 (  51 111 ) resistor r=2.87058 //w=0.35 //l=0.085 //layer=li \
 //thickness=0.1 //x=2.955 //y=7.585 //x2=3.04 //y2=7.585
r221 (  51 54 ) resistor r=21.4496 //w=0.367 //l=0.615 //layer=li \
 //thickness=0.1 //x=2.955 //y=7.585 //x2=2.34 //y2=7.585
r222 (  45 110 ) resistor r=4.23183 //w=0.7 //l=0.175 //layer=li \
 //thickness=0.1 //x=2.16 //y=7.41 //x2=2.16 //y2=7.585
r223 (  45 118 ) resistor r=33.1979 //w=0.187 //l=0.485 //layer=li \
 //thickness=0.1 //x=2.16 //y=7.41 //x2=2.16 //y2=6.925
r224 (  44 109 ) resistor r=2.87058 //w=0.35 //l=0.085 //layer=li \
 //thickness=0.1 //x=1.365 //y=7.585 //x2=1.28 //y2=7.585
r225 (  43 110 ) resistor r=2.87058 //w=0.35 //l=0.085 //layer=li \
 //thickness=0.1 //x=2.075 //y=7.585 //x2=2.16 //y2=7.585
r226 (  43 44 ) resistor r=24.7629 //w=0.367 //l=0.71 //layer=li \
 //thickness=0.1 //x=2.075 //y=7.585 //x2=1.365 //y2=7.585
r227 (  35 109 ) resistor r=4.23183 //w=0.7 //l=0.175 //layer=li \
 //thickness=0.1 //x=1.28 //y=7.41 //x2=1.28 //y2=7.585
r228 (  35 117 ) resistor r=56.4706 //w=0.187 //l=0.825 //layer=li \
 //thickness=0.1 //x=1.28 //y=7.41 //x2=1.28 //y2=6.585
r229 (  26 120 ) resistor r=9.3 //w=0.17 //l=0.17 //layer=mcon //count=1 \
 //x=5.05 //y=6.92 //x2=5.05 //y2=6.92
r230 (  20 116 ) resistor r=3.1 //w=0.17 //l=0.51 //layer=mcon //count=3 \
 //x=8.63 //y=7.58 //x2=8.63 //y2=7.58
r231 (  18 85 ) resistor r=3.1 //w=0.17 //l=0.51 //layer=mcon //count=3 \
 //x=7.52 //y=7.58 //x2=7.52 //y2=7.58
r232 (  18 20 ) resistor r=0.446141 //w=0.311 //l=1.11 //layer=m1 \
 //thickness=0.36 //x=7.52 //y=7.585 //x2=8.63 //y2=7.585
r233 (  16 72 ) resistor r=3.1 //w=0.17 //l=0.51 //layer=mcon //count=3 \
 //x=6.04 //y=7.58 //x2=6.04 //y2=7.58
r234 (  16 18 ) resistor r=0.594855 //w=0.311 //l=1.48 //layer=m1 \
 //thickness=0.36 //x=6.04 //y=7.585 //x2=7.52 //y2=7.585
r235 (  14 24 ) resistor r=0.028033 //w=0.35 //l=0.085 //layer=m1 \
 //thickness=0.36 //x=5.135 //y=7.585 //x2=5.05 //y2=7.585
r236 (  14 16 ) resistor r=0.363746 //w=0.311 //l=0.905 //layer=m1 \
 //thickness=0.36 //x=5.135 //y=7.585 //x2=6.04 //y2=7.585
r237 (  13 24 ) resistor r=0.0413265 //w=0.7 //l=0.175 //layer=m1 \
 //thickness=0.36 //x=5.05 //y=7.41 //x2=5.05 //y2=7.585
r238 (  12 26 ) resistor r=0.0723371 //w=0.218 //l=0.115 //layer=m1 \
 //thickness=0.36 //x=5.05 //y=7.035 //x2=5.05 //y2=6.92
r239 (  12 13 ) resistor r=0.357824 //w=0.131 //l=0.375 //layer=m1 \
 //thickness=0.36 //x=5.05 //y=7.035 //x2=5.05 //y2=7.41
r240 (  9 64 ) resistor r=3.1 //w=0.17 //l=0.51 //layer=mcon //count=3 \
 //x=3.45 //y=7.58 //x2=3.45 //y2=7.58
r241 (  7 54 ) resistor r=3.1 //w=0.17 //l=0.51 //layer=mcon //count=3 \
 //x=2.34 //y=7.58 //x2=2.34 //y2=7.58
r242 (  7 9 ) resistor r=0.446141 //w=0.311 //l=1.11 //layer=m1 \
 //thickness=0.36 //x=2.34 //y=7.585 //x2=3.45 //y2=7.585
r243 (  4 109 ) resistor r=3.1 //w=0.17 //l=0.51 //layer=mcon //count=3 \
 //x=1.23 //y=7.58 //x2=1.23 //y2=7.58
r244 (  4 7 ) resistor r=0.446141 //w=0.311 //l=1.11 //layer=m1 \
 //thickness=0.36 //x=1.23 //y=7.585 //x2=2.34 //y2=7.585
r245 (  2 24 ) resistor r=0.028033 //w=0.35 //l=0.085 //layer=m1 \
 //thickness=0.36 //x=4.965 //y=7.585 //x2=5.05 //y2=7.585
r246 (  1 70 ) resistor r=3.1 //w=0.17 //l=0.51 //layer=mcon //count=3 \
 //x=4.93 //y=7.58 //x2=4.93 //y2=7.58
r247 (  1 2 ) resistor r=0.0140675 //w=0.311 //l=0.035 //layer=m1 \
 //thickness=0.36 //x=4.93 //y=7.585 //x2=4.965 //y2=7.585
r248 (  1 9 ) resistor r=0.594855 //w=0.311 //l=1.48 //layer=m1 \
 //thickness=0.36 //x=4.93 //y=7.585 //x2=3.45 //y2=7.585
ends PM_AO3X1\%VDD

subckt PM_AO3X1\%A ( 1 2 3 4 5 6 7 18 21 25 30 34 35 36 37 38 39 40 44 46 49 \
 50 60 )
c98 ( 60 0 ) capacitor c=0.0682508f //x=1.6 //y=4.88
c99 ( 50 0 ) capacitor c=0.0318956f //x=1.935 //y=1.39
c100 ( 49 0 ) capacitor c=0.0186809f //x=1.935 //y=1.045
c101 ( 46 0 ) capacitor c=0.0141821f //x=1.78 //y=1.545
c102 ( 44 0 ) capacitor c=0.0158553f //x=1.78 //y=0.89
c103 ( 40 0 ) capacitor c=0.088055f //x=1.405 //y=2.095
c104 ( 39 0 ) capacitor c=0.0229235f //x=1.405 //y=1.7
c105 ( 38 0 ) capacitor c=0.0234359f //x=1.405 //y=1.39
c106 ( 37 0 ) capacitor c=0.0198759f //x=1.405 //y=1.045
c107 ( 36 0 ) capacitor c=0.110369f //x=1.94 //y=6.2
c108 ( 35 0 ) capacitor c=0.154619f //x=1.5 //y=6.2
c109 ( 30 0 ) capacitor c=8.13425e-19 //x=1.6 //y=4.88
c110 ( 25 0 ) capacitor c=7.85889e-19 //x=1.6 //y=2.26
c111 ( 21 0 ) capacitor c=0.0113945f //x=1.6 //y=4.88
c112 ( 18 0 ) capacitor c=0.0108617f //x=1.6 //y=2.26
c113 ( 1 0 ) capacitor c=0.10646f //x=1.6 //y=2.4
r114 (  58 60 ) resistor r=20.6867 //w=0.233 //l=0.1 //layer=ply \
 //thickness=0.18 //x=1.5 //y=4.88 //x2=1.6 //y2=4.88
r115 (  51 60 ) resistor r=70.3348 //w=0.233 //l=0.414367 //layer=ply \
 //thickness=0.18 //x=1.94 //y=5.045 //x2=1.6 //y2=4.88
r116 (  50 62 ) resistor r=45.1352 //w=0.168 //l=0.173853 //layer=ply \
 //thickness=0.18 //x=1.935 //y=1.39 //x2=1.895 //y2=1.545
r117 (  49 61 ) resistor r=45.1352 //w=0.168 //l=0.173853 //layer=ply \
 //thickness=0.18 //x=1.935 //y=1.045 //x2=1.895 //y2=0.89
r118 (  49 50 ) resistor r=176.904 //w=0.094 //l=0.345 //layer=ply \
 //thickness=0.18 //x=1.935 //y=1.045 //x2=1.935 //y2=1.39
r119 (  47 57 ) resistor r=10.701 //w=0.21 //l=0.115 //layer=ply \
 //thickness=0.18 //x=1.56 //y=1.545 //x2=1.445 //y2=1.545
r120 (  46 62 ) resistor r=5.52526 //w=0.168 //l=0.115 //layer=ply \
 //thickness=0.18 //x=1.78 //y=1.545 //x2=1.895 //y2=1.545
r121 (  45 56 ) resistor r=5.52526 //w=0.168 //l=0.115 //layer=ply \
 //thickness=0.18 //x=1.56 //y=0.89 //x2=1.445 //y2=0.89
r122 (  44 61 ) resistor r=5.52526 //w=0.168 //l=0.115 //layer=ply \
 //thickness=0.18 //x=1.78 //y=0.89 //x2=1.895 //y2=0.89
r123 (  44 45 ) resistor r=112.809 //w=0.094 //l=0.22 //layer=ply \
 //thickness=0.18 //x=1.78 //y=0.89 //x2=1.56 //y2=0.89
r124 (  41 58 ) resistor r=13.0941 //w=0.233 //l=0.165 //layer=ply \
 //thickness=0.18 //x=1.5 //y=5.045 //x2=1.5 //y2=4.88
r125 (  40 55 ) resistor r=34.8111 //w=0.27 //l=0.264953 //layer=ply \
 //thickness=0.18 //x=1.405 //y=2.095 //x2=1.6 //y2=2.26
r126 (  39 57 ) resistor r=39.5823 //w=0.21 //l=0.173853 //layer=ply \
 //thickness=0.18 //x=1.405 //y=1.7 //x2=1.445 //y2=1.545
r127 (  39 40 ) resistor r=202.543 //w=0.094 //l=0.395 //layer=ply \
 //thickness=0.18 //x=1.405 //y=1.7 //x2=1.405 //y2=2.095
r128 (  38 57 ) resistor r=39.5823 //w=0.21 //l=0.173853 //layer=ply \
 //thickness=0.18 //x=1.405 //y=1.39 //x2=1.445 //y2=1.545
r129 (  37 56 ) resistor r=45.1352 //w=0.168 //l=0.173853 //layer=ply \
 //thickness=0.18 //x=1.405 //y=1.045 //x2=1.445 //y2=0.89
r130 (  37 38 ) resistor r=176.904 //w=0.094 //l=0.345 //layer=ply \
 //thickness=0.18 //x=1.405 //y=1.045 //x2=1.405 //y2=1.39
r131 (  36 51 ) resistor r=592.245 //w=0.094 //l=1.155 //layer=ply \
 //thickness=0.18 //x=1.94 //y=6.2 //x2=1.94 //y2=5.045
r132 (  35 41 ) resistor r=592.245 //w=0.094 //l=1.155 //layer=ply \
 //thickness=0.18 //x=1.5 //y=6.2 //x2=1.5 //y2=5.045
r133 (  34 46 ) resistor r=56.4043 //w=0.094 //l=0.11 //layer=ply \
 //thickness=0.18 //x=1.67 //y=1.545 //x2=1.78 //y2=1.545
r134 (  34 47 ) resistor r=56.4043 //w=0.094 //l=0.11 //layer=ply \
 //thickness=0.18 //x=1.67 //y=1.545 //x2=1.56 //y2=1.545
r135 (  30 60 ) resistor r=152 //w=0.17 //l=0.17 //layer=licon //count=1 \
 //x=1.6 //y=4.88 //x2=1.6 //y2=4.88
r136 (  25 55 ) resistor r=152 //w=0.17 //l=0.17 //layer=licon //count=1 \
 //x=1.6 //y=2.26 //x2=1.6 //y2=2.26
r137 (  21 30 ) resistor r=9.3 //w=0.17 //l=0.17 //layer=mcon //count=1 \
 //x=1.6 //y=4.88 //x2=1.6 //y2=4.88
r138 (  21 22 ) resistor r=0.103207 //w=0.196 //l=0.14 //layer=m1 \
 //thickness=0.36 //x=1.602 //y=4.88 //x2=1.602 //y2=4.74
r139 (  18 25 ) resistor r=9.3 //w=0.17 //l=0.17 //layer=mcon //count=1 \
 //x=1.6 //y=2.26 //x2=1.6 //y2=2.26
r140 (  8 18 ) resistor r=0.0933015 //w=0.201 //l=0.125 //layer=m1 \
 //thickness=0.36 //x=1.6 //y=2.385 //x2=1.6 //y2=2.26
r141 (  7 22 ) resistor r=0.114504 //w=0.131 //l=0.12 //layer=m1 \
 //thickness=0.36 //x=1.6 //y=4.62 //x2=1.6 //y2=4.74
r142 (  6 7 ) resistor r=0.353053 //w=0.131 //l=0.37 //layer=m1 \
 //thickness=0.36 //x=1.6 //y=4.25 //x2=1.6 //y2=4.62
r143 (  5 6 ) resistor r=0.353053 //w=0.131 //l=0.37 //layer=m1 \
 //thickness=0.36 //x=1.6 //y=3.88 //x2=1.6 //y2=4.25
r144 (  4 5 ) resistor r=0.353053 //w=0.131 //l=0.37 //layer=m1 \
 //thickness=0.36 //x=1.6 //y=3.51 //x2=1.6 //y2=3.88
r145 (  3 4 ) resistor r=0.353053 //w=0.131 //l=0.37 //layer=m1 \
 //thickness=0.36 //x=1.6 //y=3.14 //x2=1.6 //y2=3.51
r146 (  2 3 ) resistor r=0.353053 //w=0.131 //l=0.37 //layer=m1 \
 //thickness=0.36 //x=1.6 //y=2.77 //x2=1.6 //y2=3.14
r147 (  1 2 ) resistor r=0.353053 //w=0.131 //l=0.37 //layer=m1 \
 //thickness=0.36 //x=1.6 //y=2.4 //x2=1.6 //y2=2.77
r148 (  1 8 ) resistor r=0.014313 //w=0.131 //l=0.015 //layer=m1 \
 //thickness=0.36 //x=1.6 //y=2.4 //x2=1.6 //y2=2.385
ends PM_AO3X1\%A

subckt PM_AO3X1\%GND ( 1 2 20 23 24 29 32 47 56 70 80 94 98 110 120 125 132 \
 133 134 )
c192 ( 134 0 ) capacitor c=0.0650099f //x=7.645 //y=0.55
c193 ( 133 0 ) capacitor c=0.0734748f //x=4.38 //y=0.545
c194 ( 132 0 ) capacitor c=0.00843555f //x=1.48 //y=1.045
c195 ( 125 0 ) capacitor c=0.257096f //x=8.75 //y=0.175
c196 ( 120 0 ) capacitor c=0.107545f //x=7.15 //y=0.175
c197 ( 117 0 ) capacitor c=0.00597439f //x=6.455 //y=0.175
c198 ( 114 0 ) capacitor c=0.00597439f //x=5.485 //y=0.175
c199 ( 111 0 ) capacitor c=0.00597439f //x=4.515 //y=0.175
c200 ( 110 0 ) capacitor c=0.11282f //x=3.82 //y=0.175
c201 ( 101 0 ) capacitor c=0.00589014f //x=8.75 //y=0.63
c202 ( 98 0 ) capacitor c=0.00625302f //x=8.665 //y=0.715
c203 ( 97 0 ) capacitor c=0.00479851f //x=8.26 //y=0.63
c204 ( 94 0 ) capacitor c=0.00635508f //x=8.175 //y=0.715
c205 ( 89 0 ) capacitor c=0.00590583f //x=7.78 //y=0.63
c206 ( 84 0 ) capacitor c=0.0190699f //x=7.695 //y=0.175
c207 ( 80 0 ) capacitor c=0.0221206f //x=6.98 //y=0.175
c208 ( 75 0 ) capacitor c=0.00739123f //x=6.455 //y=0.625
c209 ( 70 0 ) capacitor c=0.0152893f //x=6.37 //y=0.71
c210 ( 66 0 ) capacitor c=0.0258125f //x=6.37 //y=0.175
c211 ( 61 0 ) capacitor c=0.00726869f //x=5.485 //y=0.625
c212 ( 56 0 ) capacitor c=0.016551f //x=5.4 //y=0.71
c213 ( 52 0 ) capacitor c=0.0257966f //x=5.4 //y=0.175
c214 ( 47 0 ) capacitor c=0.00739123f //x=4.515 //y=0.625
c215 ( 44 0 ) capacitor c=0.0229116f //x=4.43 //y=0.175
c216 ( 32 0 ) capacitor c=0.201723f //x=1.23 //y=0.18
c217 ( 29 0 ) capacitor c=0.12525f //x=3.65 //y=0.175
c218 ( 26 0 ) capacitor c=0.00509083f //x=1.67 //y=0.175
c219 ( 24 0 ) capacitor c=0.0278993f //x=1.667 //y=1.005
c220 ( 23 0 ) capacitor c=0.0161817f //x=1.67 //y=1.135
c221 ( 20 0 ) capacitor c=0.289035f //x=8.63 //y=0.18
c222 ( 2 0 ) capacitor c=0.0764176f //x=1.585 //y=0.175
r223 (  124 125 ) resistor r=4.18529 //w=0.367 //l=0.12 //layer=li \
 //thickness=0.1 //x=8.63 //y=0.175 //x2=8.75 //y2=0.175
r224 (  122 124 ) resistor r=12.9046 //w=0.367 //l=0.37 //layer=li \
 //thickness=0.1 //x=8.26 //y=0.175 //x2=8.63 //y2=0.175
r225 (  121 122 ) resistor r=16.7411 //w=0.367 //l=0.48 //layer=li \
 //thickness=0.1 //x=7.78 //y=0.175 //x2=8.26 //y2=0.175
r226 (  102 134 ) resistor r=5.4201 //w=0.17 //l=0.085 //layer=li \
 //thickness=0.1 //x=8.75 //y=0.8 //x2=8.75 //y2=0.715
r227 (  102 134 ) resistor r=41.4118 //w=0.187 //l=0.605 //layer=li \
 //thickness=0.1 //x=8.75 //y=0.8 //x2=8.75 //y2=1.405
r228 (  101 134 ) resistor r=5.4201 //w=0.17 //l=0.085 //layer=li \
 //thickness=0.1 //x=8.75 //y=0.63 //x2=8.75 //y2=0.715
r229 (  100 125 ) resistor r=5.21862 //w=0.35 //l=0.175 //layer=li \
 //thickness=0.1 //x=8.75 //y=0.35 //x2=8.75 //y2=0.175
r230 (  100 101 ) resistor r=19.1658 //w=0.187 //l=0.28 //layer=li \
 //thickness=0.1 //x=8.75 //y=0.35 //x2=8.75 //y2=0.63
r231 (  99 134 ) resistor r=5.4201 //w=0.17 //l=0.085 //layer=li \
 //thickness=0.1 //x=8.345 //y=0.715 //x2=8.26 //y2=0.715
r232 (  98 134 ) resistor r=1.40859 //w=0.34 //l=0.085 //layer=li \
 //thickness=0.1 //x=8.665 //y=0.715 //x2=8.75 //y2=0.715
r233 (  98 99 ) resistor r=21.9037 //w=0.187 //l=0.32 //layer=li \
 //thickness=0.1 //x=8.665 //y=0.715 //x2=8.345 //y2=0.715
r234 (  97 134 ) resistor r=1.40859 //w=0.34 //l=0.085 //layer=li \
 //thickness=0.1 //x=8.26 //y=0.63 //x2=8.26 //y2=0.715
r235 (  96 122 ) resistor r=5.21862 //w=0.35 //l=0.175 //layer=li \
 //thickness=0.1 //x=8.26 //y=0.35 //x2=8.26 //y2=0.175
r236 (  96 97 ) resistor r=19.1658 //w=0.187 //l=0.28 //layer=li \
 //thickness=0.1 //x=8.26 //y=0.35 //x2=8.26 //y2=0.63
r237 (  95 134 ) resistor r=1.40859 //w=0.34 //l=0.085 //layer=li \
 //thickness=0.1 //x=7.865 //y=0.715 //x2=7.78 //y2=0.715
r238 (  94 134 ) resistor r=5.4201 //w=0.17 //l=0.085 //layer=li \
 //thickness=0.1 //x=8.175 //y=0.715 //x2=8.26 //y2=0.715
r239 (  94 95 ) resistor r=21.2193 //w=0.187 //l=0.31 //layer=li \
 //thickness=0.1 //x=8.175 //y=0.715 //x2=7.865 //y2=0.715
r240 (  90 134 ) resistor r=5.4201 //w=0.17 //l=0.085 //layer=li \
 //thickness=0.1 //x=7.78 //y=0.8 //x2=7.78 //y2=0.715
r241 (  90 134 ) resistor r=41.4118 //w=0.187 //l=0.605 //layer=li \
 //thickness=0.1 //x=7.78 //y=0.8 //x2=7.78 //y2=1.405
r242 (  89 134 ) resistor r=5.4201 //w=0.17 //l=0.085 //layer=li \
 //thickness=0.1 //x=7.78 //y=0.63 //x2=7.78 //y2=0.715
r243 (  88 121 ) resistor r=5.21862 //w=0.35 //l=0.175 //layer=li \
 //thickness=0.1 //x=7.78 //y=0.35 //x2=7.78 //y2=0.175
r244 (  88 89 ) resistor r=19.1658 //w=0.187 //l=0.28 //layer=li \
 //thickness=0.1 //x=7.78 //y=0.35 //x2=7.78 //y2=0.63
r245 (  85 120 ) resistor r=5.29055 //w=0.35 //l=0.17 //layer=li \
 //thickness=0.1 //x=7.32 //y=0.175 //x2=7.15 //y2=0.175
r246 (  85 87 ) resistor r=6.97548 //w=0.367 //l=0.2 //layer=li \
 //thickness=0.1 //x=7.32 //y=0.175 //x2=7.52 //y2=0.175
r247 (  84 121 ) resistor r=2.96458 //w=0.367 //l=0.085 //layer=li \
 //thickness=0.1 //x=7.695 //y=0.175 //x2=7.78 //y2=0.175
r248 (  84 87 ) resistor r=6.10354 //w=0.367 //l=0.175 //layer=li \
 //thickness=0.1 //x=7.695 //y=0.175 //x2=7.52 //y2=0.175
r249 (  81 117 ) resistor r=2.87058 //w=0.35 //l=0.085 //layer=li \
 //thickness=0.1 //x=6.54 //y=0.175 //x2=6.455 //y2=0.175
r250 (  80 120 ) resistor r=5.29055 //w=0.35 //l=0.17 //layer=li \
 //thickness=0.1 //x=6.98 //y=0.175 //x2=7.15 //y2=0.175
r251 (  80 81 ) resistor r=15.346 //w=0.367 //l=0.44 //layer=li \
 //thickness=0.1 //x=6.98 //y=0.175 //x2=6.54 //y2=0.175
r252 (  76 133 ) resistor r=5.4201 //w=0.17 //l=0.085 //layer=li \
 //thickness=0.1 //x=6.455 //y=0.795 //x2=6.455 //y2=0.71
r253 (  76 133 ) resistor r=18.139 //w=0.187 //l=0.265 //layer=li \
 //thickness=0.1 //x=6.455 //y=0.795 //x2=6.455 //y2=1.06
r254 (  75 133 ) resistor r=5.4201 //w=0.17 //l=0.085 //layer=li \
 //thickness=0.1 //x=6.455 //y=0.625 //x2=6.455 //y2=0.71
r255 (  74 117 ) resistor r=4.23183 //w=0.7 //l=0.175 //layer=li \
 //thickness=0.1 //x=6.455 //y=0.35 //x2=6.455 //y2=0.175
r256 (  74 75 ) resistor r=18.8235 //w=0.187 //l=0.275 //layer=li \
 //thickness=0.1 //x=6.455 //y=0.35 //x2=6.455 //y2=0.625
r257 (  71 133 ) resistor r=6.4 //w=0.17 //l=0.085 //layer=li //thickness=0.1 \
 //x=5.57 //y=0.71 //x2=5.485 //y2=0.71
r258 (  71 133 ) resistor r=27.3797 //w=0.187 //l=0.4 //layer=li \
 //thickness=0.1 //x=5.57 //y=0.71 //x2=5.97 //y2=0.71
r259 (  70 133 ) resistor r=1.40859 //w=0.34 //l=0.085 //layer=li \
 //thickness=0.1 //x=6.37 //y=0.71 //x2=6.455 //y2=0.71
r260 (  70 133 ) resistor r=27.3797 //w=0.187 //l=0.4 //layer=li \
 //thickness=0.1 //x=6.37 //y=0.71 //x2=5.97 //y2=0.71
r261 (  67 114 ) resistor r=2.87058 //w=0.35 //l=0.085 //layer=li \
 //thickness=0.1 //x=5.57 //y=0.175 //x2=5.485 //y2=0.175
r262 (  67 69 ) resistor r=16.3924 //w=0.367 //l=0.47 //layer=li \
 //thickness=0.1 //x=5.57 //y=0.175 //x2=6.04 //y2=0.175
r263 (  66 117 ) resistor r=2.87058 //w=0.35 //l=0.085 //layer=li \
 //thickness=0.1 //x=6.37 //y=0.175 //x2=6.455 //y2=0.175
r264 (  66 69 ) resistor r=11.5095 //w=0.367 //l=0.33 //layer=li \
 //thickness=0.1 //x=6.37 //y=0.175 //x2=6.04 //y2=0.175
r265 (  62 133 ) resistor r=6.4 //w=0.17 //l=0.085 //layer=li //thickness=0.1 \
 //x=5.485 //y=0.795 //x2=5.485 //y2=0.71
r266 (  62 133 ) resistor r=18.139 //w=0.187 //l=0.265 //layer=li \
 //thickness=0.1 //x=5.485 //y=0.795 //x2=5.485 //y2=1.06
r267 (  61 133 ) resistor r=6.4 //w=0.17 //l=0.085 //layer=li //thickness=0.1 \
 //x=5.485 //y=0.625 //x2=5.485 //y2=0.71
r268 (  60 114 ) resistor r=4.23183 //w=0.7 //l=0.175 //layer=li \
 //thickness=0.1 //x=5.485 //y=0.35 //x2=5.485 //y2=0.175
r269 (  60 61 ) resistor r=18.8235 //w=0.187 //l=0.275 //layer=li \
 //thickness=0.1 //x=5.485 //y=0.35 //x2=5.485 //y2=0.625
r270 (  57 133 ) resistor r=1.40859 //w=0.34 //l=0.085 //layer=li \
 //thickness=0.1 //x=4.6 //y=0.71 //x2=4.515 //y2=0.71
r271 (  57 133 ) resistor r=27.3797 //w=0.187 //l=0.4 //layer=li \
 //thickness=0.1 //x=4.6 //y=0.71 //x2=5 //y2=0.71
r272 (  56 133 ) resistor r=6.4 //w=0.17 //l=0.085 //layer=li //thickness=0.1 \
 //x=5.4 //y=0.71 //x2=5.485 //y2=0.71
r273 (  56 133 ) resistor r=27.3797 //w=0.187 //l=0.4 //layer=li \
 //thickness=0.1 //x=5.4 //y=0.71 //x2=5 //y2=0.71
r274 (  53 111 ) resistor r=2.87058 //w=0.35 //l=0.085 //layer=li \
 //thickness=0.1 //x=4.6 //y=0.175 //x2=4.515 //y2=0.175
r275 (  53 55 ) resistor r=11.5095 //w=0.367 //l=0.33 //layer=li \
 //thickness=0.1 //x=4.6 //y=0.175 //x2=4.93 //y2=0.175
r276 (  52 114 ) resistor r=2.87058 //w=0.35 //l=0.085 //layer=li \
 //thickness=0.1 //x=5.4 //y=0.175 //x2=5.485 //y2=0.175
r277 (  52 55 ) resistor r=16.3924 //w=0.367 //l=0.47 //layer=li \
 //thickness=0.1 //x=5.4 //y=0.175 //x2=4.93 //y2=0.175
r278 (  48 133 ) resistor r=5.4201 //w=0.17 //l=0.085 //layer=li \
 //thickness=0.1 //x=4.515 //y=0.795 //x2=4.515 //y2=0.71
r279 (  48 133 ) resistor r=41.4118 //w=0.187 //l=0.605 //layer=li \
 //thickness=0.1 //x=4.515 //y=0.795 //x2=4.515 //y2=1.4
r280 (  47 133 ) resistor r=5.4201 //w=0.17 //l=0.085 //layer=li \
 //thickness=0.1 //x=4.515 //y=0.625 //x2=4.515 //y2=0.71
r281 (  46 111 ) resistor r=4.23183 //w=0.7 //l=0.175 //layer=li \
 //thickness=0.1 //x=4.515 //y=0.35 //x2=4.515 //y2=0.175
r282 (  46 47 ) resistor r=18.8235 //w=0.187 //l=0.275 //layer=li \
 //thickness=0.1 //x=4.515 //y=0.35 //x2=4.515 //y2=0.625
r283 (  45 110 ) resistor r=5.29055 //w=0.35 //l=0.17 //layer=li \
 //thickness=0.1 //x=3.99 //y=0.175 //x2=3.82 //y2=0.175
r284 (  44 111 ) resistor r=2.87058 //w=0.35 //l=0.085 //layer=li \
 //thickness=0.1 //x=4.43 //y=0.175 //x2=4.515 //y2=0.175
r285 (  44 45 ) resistor r=15.346 //w=0.367 //l=0.44 //layer=li \
 //thickness=0.1 //x=4.43 //y=0.175 //x2=3.99 //y2=0.175
r286 (  34 36 ) resistor r=38.7139 //w=0.367 //l=1.11 //layer=li \
 //thickness=0.1 //x=2.34 //y=0.175 //x2=3.45 //y2=0.175
r287 (  32 34 ) resistor r=38.7139 //w=0.367 //l=1.11 //layer=li \
 //thickness=0.1 //x=1.23 //y=0.175 //x2=2.34 //y2=0.175
r288 (  29 110 ) resistor r=5.29055 //w=0.35 //l=0.17 //layer=li \
 //thickness=0.1 //x=3.65 //y=0.175 //x2=3.82 //y2=0.175
r289 (  29 36 ) resistor r=6.97548 //w=0.367 //l=0.2 //layer=li \
 //thickness=0.1 //x=3.65 //y=0.175 //x2=3.45 //y2=0.175
r290 (  23 132 ) resistor r=9.3 //w=0.17 //l=0.17 //layer=mcon //count=1 \
 //x=1.67 //y=1.135 //x2=1.67 //y2=1.135
r291 (  23 24 ) resistor r=0.0939994 //w=0.226 //l=0.13 //layer=m1 \
 //thickness=0.36 //x=1.667 //y=1.135 //x2=1.667 //y2=1.005
r292 (  20 124 ) resistor r=3.1 //w=0.17 //l=0.51 //layer=mcon //count=3 \
 //x=8.63 //y=0.18 //x2=8.63 //y2=0.18
r293 (  18 87 ) resistor r=3.1 //w=0.17 //l=0.51 //layer=mcon //count=3 \
 //x=7.52 //y=0.18 //x2=7.52 //y2=0.18
r294 (  18 20 ) resistor r=0.446141 //w=0.311 //l=1.11 //layer=m1 \
 //thickness=0.36 //x=7.52 //y=0.175 //x2=8.63 //y2=0.175
r295 (  16 69 ) resistor r=3.1 //w=0.17 //l=0.51 //layer=mcon //count=3 \
 //x=6.04 //y=0.18 //x2=6.04 //y2=0.18
r296 (  16 18 ) resistor r=0.594855 //w=0.311 //l=1.48 //layer=m1 \
 //thickness=0.36 //x=6.04 //y=0.175 //x2=7.52 //y2=0.175
r297 (  12 36 ) resistor r=3.1 //w=0.17 //l=0.51 //layer=mcon //count=3 \
 //x=3.45 //y=0.18 //x2=3.45 //y2=0.18
r298 (  10 34 ) resistor r=3.1 //w=0.17 //l=0.51 //layer=mcon //count=3 \
 //x=2.34 //y=0.18 //x2=2.34 //y2=0.18
r299 (  10 12 ) resistor r=0.446141 //w=0.311 //l=1.11 //layer=m1 \
 //thickness=0.36 //x=2.34 //y=0.175 //x2=3.45 //y2=0.175
r300 (  8 26 ) resistor r=0.028033 //w=0.35 //l=0.085 //layer=m1 \
 //thickness=0.36 //x=1.755 //y=0.175 //x2=1.67 //y2=0.175
r301 (  8 10 ) resistor r=0.235129 //w=0.311 //l=0.585 //layer=m1 \
 //thickness=0.36 //x=1.755 //y=0.175 //x2=2.34 //y2=0.175
r302 (  6 26 ) resistor r=0.0413265 //w=0.7 //l=0.175 //layer=m1 \
 //thickness=0.36 //x=1.67 //y=0.35 //x2=1.67 //y2=0.175
r303 (  6 24 ) resistor r=0.625 //w=0.131 //l=0.655 //layer=m1 \
 //thickness=0.36 //x=1.67 //y=0.35 //x2=1.67 //y2=1.005
r304 (  4 32 ) resistor r=3.1 //w=0.17 //l=0.51 //layer=mcon //count=3 \
 //x=1.23 //y=0.18 //x2=1.23 //y2=0.18
r305 (  2 26 ) resistor r=0.028033 //w=0.35 //l=0.085 //layer=m1 \
 //thickness=0.36 //x=1.585 //y=0.175 //x2=1.67 //y2=0.175
r306 (  2 4 ) resistor r=0.142685 //w=0.311 //l=0.355 //layer=m1 \
 //thickness=0.36 //x=1.585 //y=0.175 //x2=1.23 //y2=0.175
r307 (  1 55 ) resistor r=3.1 //w=0.17 //l=0.51 //layer=mcon //count=3 \
 //x=4.93 //y=0.18 //x2=4.93 //y2=0.18
r308 (  1 16 ) resistor r=0.446141 //w=0.311 //l=1.11 //layer=m1 \
 //thickness=0.36 //x=4.93 //y=0.175 //x2=6.04 //y2=0.175
r309 (  1 12 ) resistor r=0.594855 //w=0.311 //l=1.48 //layer=m1 \
 //thickness=0.36 //x=4.93 //y=0.175 //x2=3.45 //y2=0.175
ends PM_AO3X1\%GND

subckt PM_AO3X1\%B ( 1 2 3 4 5 6 7 9 18 24 29 33 34 35 36 37 38 43 45 47 53 54 \
 56 57 60 )
c107 ( 60 0 ) capacitor c=0.0393541f //x=2.37 //y=4.88
c108 ( 57 0 ) capacitor c=0.0284095f //x=2.34 //y=2.095
c109 ( 56 0 ) capacitor c=0.0476356f //x=2.34 //y=2.26
c110 ( 54 0 ) capacitor c=0.0439708f //x=2.905 //y=1.43
c111 ( 53 0 ) capacitor c=0.0192582f //x=2.905 //y=1.085
c112 ( 47 0 ) capacitor c=0.0162526f //x=2.75 //y=1.585
c113 ( 45 0 ) capacitor c=0.0157807f //x=2.75 //y=0.93
c114 ( 43 0 ) capacitor c=0.0372668f //x=2.745 //y=4.97
c115 ( 38 0 ) capacitor c=0.0210762f //x=2.375 //y=1.74
c116 ( 37 0 ) capacitor c=0.0168511f //x=2.375 //y=1.43
c117 ( 36 0 ) capacitor c=0.0175485f //x=2.375 //y=1.085
c118 ( 35 0 ) capacitor c=0.155269f //x=2.82 //y=6.2
c119 ( 34 0 ) capacitor c=0.110375f //x=2.38 //y=6.2
c120 ( 29 0 ) capacitor c=8.90417e-19 //x=2.37 //y=4.88
c121 ( 24 0 ) capacitor c=7.72439e-19 //x=2.34 //y=2.26
c122 ( 18 0 ) capacitor c=0.00687137f //x=2.34 //y=2.26
c123 ( 9 0 ) capacitor c=0.00493417f //x=2.34 //y=4.735
c124 ( 1 0 ) capacitor c=0.0590889f //x=2.34 //y=2.4
r125 (  62 63 ) resistor r=32.4568 //w=0.214 //l=0.075 //layer=ply \
 //thickness=0.18 //x=2.37 //y=4.97 //x2=2.37 //y2=5.045
r126 (  60 62 ) resistor r=20.271 //w=0.214 //l=0.09 //layer=ply \
 //thickness=0.18 //x=2.37 //y=4.88 //x2=2.37 //y2=4.97
r127 (  56 57 ) resistor r=52.7279 //w=0.214 //l=0.165 //layer=ply \
 //thickness=0.18 //x=2.34 //y=2.26 //x2=2.34 //y2=2.095
r128 (  54 67 ) resistor r=45.1352 //w=0.168 //l=0.173853 //layer=ply \
 //thickness=0.18 //x=2.905 //y=1.43 //x2=2.865 //y2=1.585
r129 (  53 66 ) resistor r=45.1352 //w=0.168 //l=0.173853 //layer=ply \
 //thickness=0.18 //x=2.905 //y=1.085 //x2=2.865 //y2=0.93
r130 (  53 54 ) resistor r=176.904 //w=0.094 //l=0.345 //layer=ply \
 //thickness=0.18 //x=2.905 //y=1.085 //x2=2.905 //y2=1.43
r131 (  48 65 ) resistor r=10.701 //w=0.21 //l=0.115 //layer=ply \
 //thickness=0.18 //x=2.53 //y=1.585 //x2=2.415 //y2=1.585
r132 (  47 67 ) resistor r=5.52526 //w=0.168 //l=0.115 //layer=ply \
 //thickness=0.18 //x=2.75 //y=1.585 //x2=2.865 //y2=1.585
r133 (  46 64 ) resistor r=5.52526 //w=0.168 //l=0.115 //layer=ply \
 //thickness=0.18 //x=2.53 //y=0.93 //x2=2.415 //y2=0.93
r134 (  45 66 ) resistor r=5.52526 //w=0.168 //l=0.115 //layer=ply \
 //thickness=0.18 //x=2.75 //y=0.93 //x2=2.865 //y2=0.93
r135 (  45 46 ) resistor r=112.809 //w=0.094 //l=0.22 //layer=ply \
 //thickness=0.18 //x=2.75 //y=0.93 //x2=2.53 //y2=0.93
r136 (  44 62 ) resistor r=16.5046 //w=0.27 //l=0.135 //layer=ply \
 //thickness=0.18 //x=2.505 //y=4.97 //x2=2.37 //y2=4.97
r137 (  43 50 ) resistor r=26.9307 //w=0.15 //l=0.106066 //layer=ply \
 //thickness=0.18 //x=2.745 //y=4.97 //x2=2.82 //y2=5.045
r138 (  43 44 ) resistor r=123.064 //w=0.094 //l=0.24 //layer=ply \
 //thickness=0.18 //x=2.745 //y=4.97 //x2=2.505 //y2=4.97
r139 (  38 65 ) resistor r=39.5823 //w=0.21 //l=0.173853 //layer=ply \
 //thickness=0.18 //x=2.375 //y=1.74 //x2=2.415 //y2=1.585
r140 (  38 57 ) resistor r=182.032 //w=0.094 //l=0.355 //layer=ply \
 //thickness=0.18 //x=2.375 //y=1.74 //x2=2.375 //y2=2.095
r141 (  37 65 ) resistor r=39.5823 //w=0.21 //l=0.173853 //layer=ply \
 //thickness=0.18 //x=2.375 //y=1.43 //x2=2.415 //y2=1.585
r142 (  36 64 ) resistor r=45.1352 //w=0.168 //l=0.173853 //layer=ply \
 //thickness=0.18 //x=2.375 //y=1.085 //x2=2.415 //y2=0.93
r143 (  36 37 ) resistor r=176.904 //w=0.094 //l=0.345 //layer=ply \
 //thickness=0.18 //x=2.375 //y=1.085 //x2=2.375 //y2=1.43
r144 (  35 50 ) resistor r=592.245 //w=0.094 //l=1.155 //layer=ply \
 //thickness=0.18 //x=2.82 //y=6.2 //x2=2.82 //y2=5.045
r145 (  34 63 ) resistor r=592.245 //w=0.094 //l=1.155 //layer=ply \
 //thickness=0.18 //x=2.38 //y=6.2 //x2=2.38 //y2=5.045
r146 (  33 47 ) resistor r=56.4043 //w=0.094 //l=0.11 //layer=ply \
 //thickness=0.18 //x=2.64 //y=1.585 //x2=2.75 //y2=1.585
r147 (  33 48 ) resistor r=56.4043 //w=0.094 //l=0.11 //layer=ply \
 //thickness=0.18 //x=2.64 //y=1.585 //x2=2.53 //y2=1.585
r148 (  29 60 ) resistor r=152 //w=0.17 //l=0.17 //layer=licon //count=1 \
 //x=2.37 //y=4.88 //x2=2.37 //y2=4.88
r149 (  24 56 ) resistor r=152 //w=0.17 //l=0.17 //layer=licon //count=1 \
 //x=2.34 //y=2.26 //x2=2.34 //y2=2.26
r150 (  22 29 ) resistor r=9.3 //w=0.17 //l=0.17 //layer=mcon //count=1 \
 //x=2.37 //y=4.88 //x2=2.37 //y2=4.88
r151 (  18 24 ) resistor r=9.3 //w=0.17 //l=0.17 //layer=mcon //count=1 \
 //x=2.34 //y=2.26 //x2=2.34 //y2=2.26
r152 (  18 20 ) resistor r=0.0936408 //w=0.196 //l=0.125 //layer=m1 \
 //thickness=0.36 //x=2.342 //y=2.26 //x2=2.342 //y2=2.385
r153 (  9 22 ) resistor r=0.0878548 //w=0.228 //l=0.159295 //layer=m1 \
 //thickness=0.36 //x=2.34 //y=4.735 //x2=2.37 //y2=4.88
r154 (  7 9 ) resistor r=0.109733 //w=0.131 //l=0.115 //layer=m1 \
 //thickness=0.36 //x=2.34 //y=4.62 //x2=2.34 //y2=4.735
r155 (  6 7 ) resistor r=0.353053 //w=0.131 //l=0.37 //layer=m1 \
 //thickness=0.36 //x=2.34 //y=4.25 //x2=2.34 //y2=4.62
r156 (  5 6 ) resistor r=0.353053 //w=0.131 //l=0.37 //layer=m1 \
 //thickness=0.36 //x=2.34 //y=3.88 //x2=2.34 //y2=4.25
r157 (  4 5 ) resistor r=0.353053 //w=0.131 //l=0.37 //layer=m1 \
 //thickness=0.36 //x=2.34 //y=3.51 //x2=2.34 //y2=3.88
r158 (  3 4 ) resistor r=0.353053 //w=0.131 //l=0.37 //layer=m1 \
 //thickness=0.36 //x=2.34 //y=3.14 //x2=2.34 //y2=3.51
r159 (  2 3 ) resistor r=0.353053 //w=0.131 //l=0.37 //layer=m1 \
 //thickness=0.36 //x=2.34 //y=2.77 //x2=2.34 //y2=3.14
r160 (  1 2 ) resistor r=0.353053 //w=0.131 //l=0.37 //layer=m1 \
 //thickness=0.36 //x=2.34 //y=2.4 //x2=2.34 //y2=2.77
r161 (  1 20 ) resistor r=0.014313 //w=0.131 //l=0.015 //layer=m1 \
 //thickness=0.36 //x=2.34 //y=2.4 //x2=2.34 //y2=2.385
ends PM_AO3X1\%B

subckt PM_AO3X1\%noxref_7 ( 1 3 5 10 14 17 20 30 46 47 48 )
c95 ( 48 0 ) capacitor c=0.0353235f //x=6.225 //y=5.205
c96 ( 46 0 ) capacitor c=0.0118024f //x=4.475 //y=5.205
c97 ( 30 0 ) capacitor c=0.0303001f //x=5.49 //y=5.56
c98 ( 20 0 ) capacitor c=0.045655f //x=4.61 //y=5.56
c99 ( 17 0 ) capacitor c=0.0164155f //x=6.37 //y=6.92
c100 ( 14 0 ) capacitor c=0.00604334f //x=5.49 //y=6.92
c101 ( 10 0 ) capacitor c=0.0111814f //x=5.49 //y=5.39
c102 ( 5 0 ) capacitor c=0.012947f //x=4.61 //y=5.39
c103 ( 3 0 ) capacitor c=0.00694548f //x=6.24 //y=7.09
c104 ( 1 0 ) capacitor c=0.0131347f //x=5.37 //y=5.39
r105 (  37 47 ) resistor r=23.2727 //w=0.187 //l=0.34 //layer=li \
 //thickness=0.1 //x=5.49 //y=6.92 //x2=5.49 //y2=6.58
r106 (  30 47 ) resistor r=23.2727 //w=0.187 //l=0.34 //layer=li \
 //thickness=0.1 //x=5.49 //y=5.56 //x2=5.49 //y2=5.9
r107 (  20 46 ) resistor r=23.2727 //w=0.187 //l=0.34 //layer=li \
 //thickness=0.1 //x=4.61 //y=5.56 //x2=4.61 //y2=5.9
r108 (  17 48 ) resistor r=9.3 //w=0.17 //l=0.17 //layer=mcon //count=1 \
 //x=6.37 //y=6.92 //x2=6.37 //y2=6.92
r109 (  17 18 ) resistor r=0.0932018 //w=0.228 //l=0.17 //layer=m1 \
 //thickness=0.36 //x=6.362 //y=6.92 //x2=6.362 //y2=7.09
r110 (  14 37 ) resistor r=9.3 //w=0.17 //l=0.17 //layer=mcon //count=1 \
 //x=5.49 //y=6.92 //x2=5.49 //y2=6.92
r111 (  14 15 ) resistor r=0.0992991 //w=0.214 //l=0.17 //layer=m1 \
 //thickness=0.36 //x=5.49 //y=6.92 //x2=5.49 //y2=7.09
r112 (  12 30 ) resistor r=9.3 //w=0.17 //l=0.17 //layer=mcon //count=1 \
 //x=5.49 //y=5.56 //x2=5.49 //y2=5.56
r113 (  10 12 ) resistor r=0.097032 //w=0.219 //l=0.17 //layer=m1 \
 //thickness=0.36 //x=5.49 //y=5.39 //x2=5.49 //y2=5.56
r114 (  7 20 ) resistor r=9.3 //w=0.17 //l=0.17 //layer=mcon //count=1 \
 //x=4.61 //y=5.56 //x2=4.61 //y2=5.56
r115 (  5 7 ) resistor r=0.0997653 //w=0.213 //l=0.17 //layer=m1 \
 //thickness=0.36 //x=4.61 //y=5.39 //x2=4.61 //y2=5.56
r116 (  4 15 ) resistor r=0.0213909 //w=0.214 //l=0.115 //layer=m1 \
 //thickness=0.36 //x=5.605 //y=7.09 //x2=5.49 //y2=7.09
r117 (  3 18 ) resistor r=0.0251868 //w=0.228 //l=0.122 //layer=m1 \
 //thickness=0.36 //x=6.24 //y=7.09 //x2=6.362 //y2=7.09
r118 (  3 4 ) resistor r=0.605916 //w=0.131 //l=0.635 //layer=m1 \
 //thickness=0.36 //x=6.24 //y=7.09 //x2=5.605 //y2=7.09
r119 (  2 5 ) resistor r=0.0211096 //w=0.213 //l=0.115 //layer=m1 \
 //thickness=0.36 //x=4.725 //y=5.39 //x2=4.61 //y2=5.39
r120 (  1 10 ) resistor r=0.0227762 //w=0.219 //l=0.12 //layer=m1 \
 //thickness=0.36 //x=5.37 //y=5.39 //x2=5.49 //y2=5.39
r121 (  1 2 ) resistor r=0.615458 //w=0.131 //l=0.645 //layer=m1 \
 //thickness=0.36 //x=5.37 //y=5.39 //x2=4.725 //y2=5.39
ends PM_AO3X1\%noxref_7

subckt PM_AO3X1\%C ( 1 2 3 4 5 6 7 18 22 26 31 35 36 37 38 39 40 45 47 49 55 \
 56 58 59 62 )
c119 ( 62 0 ) capacitor c=0.0404287f //x=5.705 //y=4.885
c120 ( 59 0 ) capacitor c=0.0292709f //x=5.67 //y=2.095
c121 ( 58 0 ) capacitor c=0.0468503f //x=5.67 //y=2.26
c122 ( 56 0 ) capacitor c=0.0237765f //x=6.235 //y=1.435
c123 ( 55 0 ) capacitor c=0.0191782f //x=6.235 //y=1.085
c124 ( 49 0 ) capacitor c=0.035988f //x=6.08 //y=1.585
c125 ( 47 0 ) capacitor c=0.0157803f //x=6.08 //y=0.93
c126 ( 45 0 ) capacitor c=0.0367203f //x=6.075 //y=4.975
c127 ( 40 0 ) capacitor c=0.0206674f //x=5.705 //y=1.74
c128 ( 39 0 ) capacitor c=0.0169638f //x=5.705 //y=1.435
c129 ( 38 0 ) capacitor c=0.0185462f //x=5.705 //y=1.085
c130 ( 37 0 ) capacitor c=0.155887f //x=6.15 //y=6.205
c131 ( 36 0 ) capacitor c=0.110534f //x=5.71 //y=6.205
c132 ( 31 0 ) capacitor c=0.0011312f //x=5.705 //y=4.885
c133 ( 26 0 ) capacitor c=9.45497e-19 //x=5.67 //y=2.26
c134 ( 22 0 ) capacitor c=0.0061903f //x=5.705 //y=4.885
c135 ( 18 0 ) capacitor c=0.00573992f //x=5.67 //y=2.26
c136 ( 1 0 ) capacitor c=0.0570424f //x=5.67 //y=2.4
r137 (  64 65 ) resistor r=32.4568 //w=0.214 //l=0.075 //layer=ply \
 //thickness=0.18 //x=5.705 //y=4.975 //x2=5.705 //y2=5.05
r138 (  62 64 ) resistor r=20.271 //w=0.214 //l=0.09 //layer=ply \
 //thickness=0.18 //x=5.705 //y=4.885 //x2=5.705 //y2=4.975
r139 (  58 59 ) resistor r=52.7279 //w=0.214 //l=0.165 //layer=ply \
 //thickness=0.18 //x=5.67 //y=2.26 //x2=5.67 //y2=2.095
r140 (  56 69 ) resistor r=4.95774 //w=0.164 //l=0.112 //layer=ply \
 //thickness=0.18 //x=6.235 //y=1.435 //x2=6.235 //y2=1.547
r141 (  55 68 ) resistor r=45.1352 //w=0.168 //l=0.173853 //layer=ply \
 //thickness=0.18 //x=6.235 //y=1.085 //x2=6.195 //y2=0.93
r142 (  55 56 ) resistor r=179.468 //w=0.094 //l=0.35 //layer=ply \
 //thickness=0.18 //x=6.235 //y=1.085 //x2=6.235 //y2=1.435
r143 (  50 67 ) resistor r=10.8103 //w=0.211 //l=0.115 //layer=ply \
 //thickness=0.18 //x=5.86 //y=1.585 //x2=5.745 //y2=1.585
r144 (  49 69 ) resistor r=45.9962 //w=0.164 //l=0.17296 //layer=ply \
 //thickness=0.18 //x=6.08 //y=1.585 //x2=6.235 //y2=1.547
r145 (  48 66 ) resistor r=5.52526 //w=0.168 //l=0.115 //layer=ply \
 //thickness=0.18 //x=5.86 //y=0.93 //x2=5.745 //y2=0.93
r146 (  47 68 ) resistor r=5.52526 //w=0.168 //l=0.115 //layer=ply \
 //thickness=0.18 //x=6.08 //y=0.93 //x2=6.195 //y2=0.93
r147 (  47 48 ) resistor r=112.809 //w=0.094 //l=0.22 //layer=ply \
 //thickness=0.18 //x=6.08 //y=0.93 //x2=5.86 //y2=0.93
r148 (  46 64 ) resistor r=16.5046 //w=0.27 //l=0.135 //layer=ply \
 //thickness=0.18 //x=5.84 //y=4.975 //x2=5.705 //y2=4.975
r149 (  45 52 ) resistor r=26.9307 //w=0.15 //l=0.106066 //layer=ply \
 //thickness=0.18 //x=6.075 //y=4.975 //x2=6.15 //y2=5.05
r150 (  45 46 ) resistor r=120.5 //w=0.094 //l=0.235 //layer=ply \
 //thickness=0.18 //x=6.075 //y=4.975 //x2=5.84 //y2=4.975
r151 (  40 67 ) resistor r=39.5036 //w=0.211 //l=0.173853 //layer=ply \
 //thickness=0.18 //x=5.705 //y=1.74 //x2=5.745 //y2=1.585
r152 (  40 59 ) resistor r=182.032 //w=0.094 //l=0.355 //layer=ply \
 //thickness=0.18 //x=5.705 //y=1.74 //x2=5.705 //y2=2.095
r153 (  39 67 ) resistor r=38.3614 //w=0.211 //l=0.168819 //layer=ply \
 //thickness=0.18 //x=5.705 //y=1.435 //x2=5.745 //y2=1.585
r154 (  38 66 ) resistor r=45.1352 //w=0.168 //l=0.173853 //layer=ply \
 //thickness=0.18 //x=5.705 //y=1.085 //x2=5.745 //y2=0.93
r155 (  38 39 ) resistor r=179.468 //w=0.094 //l=0.35 //layer=ply \
 //thickness=0.18 //x=5.705 //y=1.085 //x2=5.705 //y2=1.435
r156 (  37 52 ) resistor r=592.245 //w=0.094 //l=1.155 //layer=ply \
 //thickness=0.18 //x=6.15 //y=6.205 //x2=6.15 //y2=5.05
r157 (  36 65 ) resistor r=592.245 //w=0.094 //l=1.155 //layer=ply \
 //thickness=0.18 //x=5.71 //y=6.205 //x2=5.71 //y2=5.05
r158 (  35 49 ) resistor r=56.4043 //w=0.094 //l=0.11 //layer=ply \
 //thickness=0.18 //x=5.97 //y=1.585 //x2=6.08 //y2=1.585
r159 (  35 50 ) resistor r=56.4043 //w=0.094 //l=0.11 //layer=ply \
 //thickness=0.18 //x=5.97 //y=1.585 //x2=5.86 //y2=1.585
r160 (  31 62 ) resistor r=152 //w=0.17 //l=0.17 //layer=licon //count=1 \
 //x=5.705 //y=4.885 //x2=5.705 //y2=4.885
r161 (  26 58 ) resistor r=152 //w=0.17 //l=0.17 //layer=licon //count=1 \
 //x=5.67 //y=2.26 //x2=5.67 //y2=2.26
r162 (  22 31 ) resistor r=9.3 //w=0.17 //l=0.17 //layer=mcon //count=1 \
 //x=5.705 //y=4.885 //x2=5.705 //y2=4.885
r163 (  22 23 ) resistor r=0.105739 //w=0.201 //l=0.145 //layer=m1 \
 //thickness=0.36 //x=5.705 //y=4.885 //x2=5.705 //y2=4.74
r164 (  18 26 ) resistor r=9.3 //w=0.17 //l=0.17 //layer=mcon //count=1 \
 //x=5.67 //y=2.26 //x2=5.67 //y2=2.26
r165 (  18 20 ) resistor r=0.0977888 //w=0.216 //l=0.135 //layer=m1 \
 //thickness=0.36 //x=5.667 //y=2.26 //x2=5.667 //y2=2.395
r166 (  7 23 ) resistor r=0.114504 //w=0.131 //l=0.12 //layer=m1 \
 //thickness=0.36 //x=5.67 //y=4.62 //x2=5.67 //y2=4.74
r167 (  6 7 ) resistor r=0.353053 //w=0.131 //l=0.37 //layer=m1 \
 //thickness=0.36 //x=5.67 //y=4.25 //x2=5.67 //y2=4.62
r168 (  5 6 ) resistor r=0.353053 //w=0.131 //l=0.37 //layer=m1 \
 //thickness=0.36 //x=5.67 //y=3.88 //x2=5.67 //y2=4.25
r169 (  4 5 ) resistor r=0.353053 //w=0.131 //l=0.37 //layer=m1 \
 //thickness=0.36 //x=5.67 //y=3.51 //x2=5.67 //y2=3.88
r170 (  3 4 ) resistor r=0.353053 //w=0.131 //l=0.37 //layer=m1 \
 //thickness=0.36 //x=5.67 //y=3.14 //x2=5.67 //y2=3.51
r171 (  2 3 ) resistor r=0.353053 //w=0.131 //l=0.37 //layer=m1 \
 //thickness=0.36 //x=5.67 //y=2.77 //x2=5.67 //y2=3.14
r172 (  1 2 ) resistor r=0.353053 //w=0.131 //l=0.37 //layer=m1 \
 //thickness=0.36 //x=5.67 //y=2.4 //x2=5.67 //y2=2.77
r173 (  1 20 ) resistor r=0.00477099 //w=0.131 //l=0.005 //layer=m1 \
 //thickness=0.36 //x=5.67 //y=2.4 //x2=5.67 //y2=2.395
ends PM_AO3X1\%C

subckt PM_AO3X1\%Y ( 1 2 3 4 5 6 7 9 11 12 13 14 15 26 36 43 45 )
c81 ( 43 0 ) capacitor c=0.00869746f //x=8.075 //y=1.09
c82 ( 36 0 ) capacitor c=0.0261959f //x=8.265 //y=5.56
c83 ( 26 0 ) capacitor c=0.0191272f //x=8.26 //y=1.185
c84 ( 15 0 ) capacitor c=0.00557311f //x=8.35 //y=5.14
c85 ( 14 0 ) capacitor c=0.00944012f //x=8.545 //y=5.14
c86 ( 13 0 ) capacitor c=0.00724565f //x=8.345 //y=2.02
c87 ( 12 0 ) capacitor c=0.0145753f //x=8.545 //y=2.02
c88 ( 11 0 ) capacitor c=0.0117594f //x=8.265 //y=5.42
c89 ( 9 0 ) capacitor c=0.0170096f //x=8.26 //y=1.935
c90 ( 1 0 ) capacitor c=0.117162f //x=8.63 //y=2.4
r91 (  36 45 ) resistor r=23.615 //w=0.187 //l=0.345 //layer=li \
 //thickness=0.1 //x=8.265 //y=5.56 //x2=8.265 //y2=5.905
r92 (  29 36 ) resistor r=9.3 //w=0.17 //l=0.17 //layer=mcon //count=1 \
 //x=8.265 //y=5.56 //x2=8.265 //y2=5.56
r93 (  26 43 ) resistor r=9.3 //w=0.17 //l=0.17 //layer=mcon //count=1 \
 //x=8.26 //y=1.185 //x2=8.26 //y2=1.185
r94 (  14 17 ) resistor r=0.0698411 //w=0.17 //l=0.120208 //layer=m1 \
 //thickness=0.36 //x=8.545 //y=5.14 //x2=8.63 //y2=5.055
r95 (  14 15 ) resistor r=0.186069 //w=0.131 //l=0.195 //layer=m1 \
 //thickness=0.36 //x=8.545 //y=5.14 //x2=8.35 //y2=5.14
r96 (  12 16 ) resistor r=0.0698411 //w=0.17 //l=0.120208 //layer=m1 \
 //thickness=0.36 //x=8.545 //y=2.02 //x2=8.63 //y2=2.105
r97 (  12 13 ) resistor r=0.19084 //w=0.131 //l=0.2 //layer=m1 \
 //thickness=0.36 //x=8.545 //y=2.02 //x2=8.345 //y2=2.02
r98 (  11 29 ) resistor r=0.086672 //w=0.218 //l=0.14 //layer=m1 \
 //thickness=0.36 //x=8.265 //y=5.42 //x2=8.265 //y2=5.56
r99 (  10 15 ) resistor r=0.0698411 //w=0.17 //l=0.120208 //layer=m1 \
 //thickness=0.36 //x=8.265 //y=5.225 //x2=8.35 //y2=5.14
r100 (  10 11 ) resistor r=0.186069 //w=0.131 //l=0.195 //layer=m1 \
 //thickness=0.36 //x=8.265 //y=5.225 //x2=8.265 //y2=5.42
r101 (  9 13 ) resistor r=0.0698411 //w=0.17 //l=0.120208 //layer=m1 \
 //thickness=0.36 //x=8.26 //y=1.935 //x2=8.345 //y2=2.02
r102 (  8 26 ) resistor r=0.105739 //w=0.201 //l=0.145 //layer=m1 \
 //thickness=0.36 //x=8.26 //y=1.33 //x2=8.26 //y2=1.185
r103 (  8 9 ) resistor r=0.57729 //w=0.131 //l=0.605 //layer=m1 \
 //thickness=0.36 //x=8.26 //y=1.33 //x2=8.26 //y2=1.935
r104 (  7 17 ) resistor r=0.415076 //w=0.131 //l=0.435 //layer=m1 \
 //thickness=0.36 //x=8.63 //y=4.62 //x2=8.63 //y2=5.055
r105 (  6 7 ) resistor r=0.353053 //w=0.131 //l=0.37 //layer=m1 \
 //thickness=0.36 //x=8.63 //y=4.25 //x2=8.63 //y2=4.62
r106 (  5 6 ) resistor r=0.353053 //w=0.131 //l=0.37 //layer=m1 \
 //thickness=0.36 //x=8.63 //y=3.88 //x2=8.63 //y2=4.25
r107 (  4 5 ) resistor r=0.353053 //w=0.131 //l=0.37 //layer=m1 \
 //thickness=0.36 //x=8.63 //y=3.51 //x2=8.63 //y2=3.88
r108 (  3 4 ) resistor r=0.353053 //w=0.131 //l=0.37 //layer=m1 \
 //thickness=0.36 //x=8.63 //y=3.14 //x2=8.63 //y2=3.51
r109 (  2 3 ) resistor r=0.353053 //w=0.131 //l=0.37 //layer=m1 \
 //thickness=0.36 //x=8.63 //y=2.77 //x2=8.63 //y2=3.14
r110 (  1 2 ) resistor r=0.353053 //w=0.131 //l=0.37 //layer=m1 \
 //thickness=0.36 //x=8.63 //y=2.4 //x2=8.63 //y2=2.77
r111 (  1 16 ) resistor r=0.281489 //w=0.131 //l=0.295 //layer=m1 \
 //thickness=0.36 //x=8.63 //y=2.4 //x2=8.63 //y2=2.105
ends PM_AO3X1\%Y

subckt PM_AO3X1\%noxref_10 ( 1 5 9 10 13 17 29 )
c61 ( 29 0 ) capacitor c=0.0672377f //x=1.05 //y=0.545
c62 ( 17 0 ) capacitor c=0.00709791f //x=3.125 //y=0.795
c63 ( 13 0 ) capacitor c=0.0157877f //x=3.04 //y=0.71
c64 ( 10 0 ) capacitor c=0.00963509f //x=2.155 //y=1.675
c65 ( 9 0 ) capacitor c=0.00770028f //x=2.155 //y=0.795
c66 ( 5 0 ) capacitor c=0.024493f //x=2.07 //y=1.76
c67 ( 1 0 ) capacitor c=0.0115037f //x=1.185 //y=1.675
r68 (  17 29 ) resistor r=3.57586 //w=0.17 //l=0.125 //layer=li \
 //thickness=0.1 //x=3.125 //y=0.795 //x2=3.125 //y2=0.67
r69 (  17 29 ) resistor r=18.139 //w=0.187 //l=0.265 //layer=li \
 //thickness=0.1 //x=3.125 //y=0.795 //x2=3.125 //y2=1.06
r70 (  14 29 ) resistor r=3.57586 //w=0.17 //l=0.103078 //layer=li \
 //thickness=0.1 //x=2.24 //y=0.71 //x2=2.155 //y2=0.67
r71 (  14 29 ) resistor r=27.3797 //w=0.187 //l=0.4 //layer=li //thickness=0.1 \
 //x=2.24 //y=0.71 //x2=2.64 //y2=0.71
r72 (  13 29 ) resistor r=3.57586 //w=0.17 //l=0.103078 //layer=li \
 //thickness=0.1 //x=3.04 //y=0.71 //x2=3.125 //y2=0.67
r73 (  13 29 ) resistor r=27.3797 //w=0.187 //l=0.4 //layer=li //thickness=0.1 \
 //x=3.04 //y=0.71 //x2=2.64 //y2=0.71
r74 (  10 29 ) resistor r=3.57586 //w=0.17 //l=0.125 //layer=li \
 //thickness=0.1 //x=2.155 //y=1.675 //x2=2.155 //y2=1.8
r75 (  10 29 ) resistor r=42.0963 //w=0.187 //l=0.615 //layer=li \
 //thickness=0.1 //x=2.155 //y=1.675 //x2=2.155 //y2=1.06
r76 (  9 29 ) resistor r=3.57586 //w=0.17 //l=0.125 //layer=li //thickness=0.1 \
 //x=2.155 //y=0.795 //x2=2.155 //y2=0.67
r77 (  9 29 ) resistor r=18.139 //w=0.187 //l=0.265 //layer=li //thickness=0.1 \
 //x=2.155 //y=0.795 //x2=2.155 //y2=1.06
r78 (  6 29 ) resistor r=3.57586 //w=0.17 //l=0.103078 //layer=li \
 //thickness=0.1 //x=1.27 //y=1.76 //x2=1.185 //y2=1.8
r79 (  6 29 ) resistor r=27.3797 //w=0.187 //l=0.4 //layer=li //thickness=0.1 \
 //x=1.27 //y=1.76 //x2=1.67 //y2=1.76
r80 (  5 29 ) resistor r=3.57586 //w=0.17 //l=0.103078 //layer=li \
 //thickness=0.1 //x=2.07 //y=1.76 //x2=2.155 //y2=1.8
r81 (  5 29 ) resistor r=27.3797 //w=0.187 //l=0.4 //layer=li //thickness=0.1 \
 //x=2.07 //y=1.76 //x2=1.67 //y2=1.76
r82 (  1 29 ) resistor r=3.57586 //w=0.17 //l=0.125 //layer=li //thickness=0.1 \
 //x=1.185 //y=1.675 //x2=1.185 //y2=1.8
r83 (  1 29 ) resistor r=42.0963 //w=0.187 //l=0.615 //layer=li \
 //thickness=0.1 //x=1.185 //y=1.675 //x2=1.185 //y2=1.06
ends PM_AO3X1\%noxref_10
