// File: HA.spi.pex
// Created: Sun Mar 15 12:42:50 2026
// Program "Calibre xRC"
// Version "v2023.2_27.15"
// Nominal Temperature: 30C
// Circuit Temperature: 30C
//
simulator lang=spectre
subckt PM_HA\%noxref_1 ( 3 8 9 11 12 14 15 16 18 19 20 23 24 27 29 32 35 38 42 \
 43 48 51 59 76 85 89 90 91 92 93 94 95 99 100 101 103 109 110 112 120 122 123 )
c254 ( 120 0 ) capacitor c=0.00878249f //x=2.45 //y=1.085
c255 ( 112 0 ) capacitor c=0.0569811f //x=4.56 //y=2.265
c256 ( 110 0 ) capacitor c=0.0439576f //x=5.2 //y=1.435
c257 ( 109 0 ) capacitor c=0.0201087f //x=5.2 //y=1.09
c258 ( 103 0 ) capacitor c=0.0161986f //x=5.045 //y=1.59
c259 ( 101 0 ) capacitor c=0.0157807f //x=5.045 //y=0.935
c260 ( 100 0 ) capacitor c=0.0557689f //x=4.79 //y=4.97
c261 ( 99 0 ) capacitor c=0.0407054f //x=5.08 //y=4.97
c262 ( 95 0 ) capacitor c=0.0301471f //x=4.67 //y=2.1
c263 ( 94 0 ) capacitor c=0.0255349f //x=4.67 //y=1.745
c264 ( 93 0 ) capacitor c=0.0234346f //x=4.67 //y=1.435
c265 ( 92 0 ) capacitor c=0.02013f //x=4.67 //y=1.09
c266 ( 91 0 ) capacitor c=0.153839f //x=5.155 //y=6.2
c267 ( 90 0 ) capacitor c=0.15434f //x=4.715 //y=6.2
c268 ( 85 0 ) capacitor c=9.4527e-19 //x=4.56 //y=4.88
c269 ( 76 0 ) capacitor c=9.11699e-19 //x=4.56 //y=2.265
c270 ( 59 0 ) capacitor c=0.0321204f //x=2.6 //y=5.56
c271 ( 51 0 ) capacitor c=0.0289857f //x=1.72 //y=5.56
c272 ( 48 0 ) capacitor c=0.00220219f //x=4.555 //y=3.51
c273 ( 43 0 ) capacitor c=0.00305592f //x=3.24 //y=3.51
c274 ( 42 0 ) capacitor c=0.0369863f //x=4.395 //y=3.51
c275 ( 38 0 ) capacitor c=0.00873124f //x=4.56 //y=2.265
c276 ( 35 0 ) capacitor c=0.0159873f //x=4.555 //y=3.51
c277 ( 32 0 ) capacitor c=0.0165963f //x=3.08 //y=3.51
c278 ( 29 0 ) capacitor c=0.011556f //x=2.64 //y=1.18
c279 ( 27 0 ) capacitor c=8.73568e-19 //x=2.6 //y=5.56
c280 ( 24 0 ) capacitor c=0.0110938f //x=2.6 //y=5.38
c281 ( 23 0 ) capacitor c=0.00857099f //x=1.72 //y=5.56
c282 ( 20 0 ) capacitor c=0.0294454f //x=4.56 //y=4.76
c283 ( 19 0 ) capacitor c=0.0125679f //x=4.56 //y=3.67
c284 ( 18 0 ) capacitor c=0.024041f //x=4.56 //y=3.35
c285 ( 16 0 ) capacitor c=0.0382321f //x=3.08 //y=5.295
c286 ( 15 0 ) capacitor c=0.013044f //x=3.08 //y=3.67
c287 ( 14 0 ) capacitor c=0.0381523f //x=3.08 //y=3.35
c288 ( 12 0 ) capacitor c=0.00763919f //x=2.725 //y=1.835
c289 ( 11 0 ) capacitor c=0.0138793f //x=2.995 //y=1.835
c290 ( 9 0 ) capacitor c=0.0116006f //x=2.995 //y=5.38
c291 ( 8 0 ) capacitor c=0.0125185f //x=2.64 //y=1.75
c292 ( 3 0 ) capacitor c=0.0145507f //x=2.485 //y=5.38
r293 (  112 113 ) resistor r=17.5563 //w=0.302 //l=0.11 //layer=ply \
 //thickness=0.18 //x=4.56 //y=2.265 //x2=4.67 //y2=2.265
r294 (  110 119 ) resistor r=45.1352 //w=0.168 //l=0.173853 //layer=ply \
 //thickness=0.18 //x=5.2 //y=1.435 //x2=5.16 //y2=1.59
r295 (  109 118 ) resistor r=45.1352 //w=0.168 //l=0.173853 //layer=ply \
 //thickness=0.18 //x=5.2 //y=1.09 //x2=5.16 //y2=0.935
r296 (  109 110 ) resistor r=176.904 //w=0.094 //l=0.345 //layer=ply \
 //thickness=0.18 //x=5.2 //y=1.09 //x2=5.2 //y2=1.435
r297 (  104 117 ) resistor r=10.701 //w=0.21 //l=0.115 //layer=ply \
 //thickness=0.18 //x=4.825 //y=1.59 //x2=4.71 //y2=1.59
r298 (  103 119 ) resistor r=5.52526 //w=0.168 //l=0.115 //layer=ply \
 //thickness=0.18 //x=5.045 //y=1.59 //x2=5.16 //y2=1.59
r299 (  102 116 ) resistor r=5.52526 //w=0.168 //l=0.115 //layer=ply \
 //thickness=0.18 //x=4.825 //y=0.935 //x2=4.71 //y2=0.935
r300 (  101 118 ) resistor r=5.52526 //w=0.168 //l=0.115 //layer=ply \
 //thickness=0.18 //x=5.045 //y=0.935 //x2=5.16 //y2=0.935
r301 (  101 102 ) resistor r=112.809 //w=0.094 //l=0.22 //layer=ply \
 //thickness=0.18 //x=5.045 //y=0.935 //x2=4.825 //y2=0.935
r302 (  99 106 ) resistor r=26.9307 //w=0.15 //l=0.106066 //layer=ply \
 //thickness=0.18 //x=5.08 //y=4.97 //x2=5.155 //y2=5.045
r303 (  99 100 ) resistor r=148.702 //w=0.094 //l=0.29 //layer=ply \
 //thickness=0.18 //x=5.08 //y=4.97 //x2=4.79 //y2=4.97
r304 (  96 100 ) resistor r=23.403 //w=0.284 //l=0.106066 //layer=ply \
 //thickness=0.18 //x=4.715 //y=5.045 //x2=4.79 //y2=4.97
r305 (  96 115 ) resistor r=26.3063 //w=0.284 //l=0.229783 //layer=ply \
 //thickness=0.18 //x=4.715 //y=5.045 //x2=4.56 //y2=4.88
r306 (  95 113 ) resistor r=19.1248 //w=0.302 //l=0.165 //layer=ply \
 //thickness=0.18 //x=4.67 //y=2.1 //x2=4.67 //y2=2.265
r307 (  94 117 ) resistor r=39.5823 //w=0.21 //l=0.173853 //layer=ply \
 //thickness=0.18 //x=4.67 //y=1.745 //x2=4.71 //y2=1.59
r308 (  94 95 ) resistor r=182.032 //w=0.094 //l=0.355 //layer=ply \
 //thickness=0.18 //x=4.67 //y=1.745 //x2=4.67 //y2=2.1
r309 (  93 117 ) resistor r=39.5823 //w=0.21 //l=0.173853 //layer=ply \
 //thickness=0.18 //x=4.67 //y=1.435 //x2=4.71 //y2=1.59
r310 (  92 116 ) resistor r=45.1352 //w=0.168 //l=0.173853 //layer=ply \
 //thickness=0.18 //x=4.67 //y=1.09 //x2=4.71 //y2=0.935
r311 (  92 93 ) resistor r=176.904 //w=0.094 //l=0.345 //layer=ply \
 //thickness=0.18 //x=4.67 //y=1.09 //x2=4.67 //y2=1.435
r312 (  91 106 ) resistor r=592.245 //w=0.094 //l=1.155 //layer=ply \
 //thickness=0.18 //x=5.155 //y=6.2 //x2=5.155 //y2=5.045
r313 (  90 96 ) resistor r=592.245 //w=0.094 //l=1.155 //layer=ply \
 //thickness=0.18 //x=4.715 //y=6.2 //x2=4.715 //y2=5.045
r314 (  89 103 ) resistor r=56.4043 //w=0.094 //l=0.11 //layer=ply \
 //thickness=0.18 //x=4.935 //y=1.59 //x2=5.045 //y2=1.59
r315 (  89 104 ) resistor r=56.4043 //w=0.094 //l=0.11 //layer=ply \
 //thickness=0.18 //x=4.935 //y=1.59 //x2=4.825 //y2=1.59
r316 (  85 115 ) resistor r=152 //w=0.17 //l=0.17 //layer=licon //count=1 \
 //x=4.56 //y=4.88 //x2=4.56 //y2=4.88
r317 (  76 112 ) resistor r=152 //w=0.17 //l=0.17 //layer=licon //count=1 \
 //x=4.56 //y=2.265 //x2=4.56 //y2=2.265
r318 (  59 123 ) resistor r=23.615 //w=0.187 //l=0.345 //layer=li \
 //thickness=0.1 //x=2.6 //y=5.56 //x2=2.6 //y2=5.905
r319 (  51 122 ) resistor r=23.615 //w=0.187 //l=0.345 //layer=li \
 //thickness=0.1 //x=1.72 //y=5.56 //x2=1.72 //y2=5.905
r320 (  43 45 ) resistor r=0.10734 //w=0.281 //l=0.16 //layer=m2 \
 //thickness=0.36 //x=3.24 //y=3.51 //x2=3.08 //y2=3.51
r321 (  42 48 ) resistor r=0.10734 //w=0.281 //l=0.16 //layer=m2 \
 //thickness=0.36 //x=4.395 //y=3.51 //x2=4.555 //y2=3.51
r322 (  42 43 ) resistor r=1.1021 //w=0.131 //l=1.155 //layer=m2 \
 //thickness=0.36 //x=4.395 //y=3.51 //x2=3.24 //y2=3.51
r323 (  41 85 ) resistor r=9.3 //w=0.17 //l=0.17 //layer=mcon //count=1 \
 //x=4.56 //y=4.88 //x2=4.56 //y2=4.88
r324 (  38 76 ) resistor r=9.3 //w=0.17 //l=0.17 //layer=mcon //count=1 \
 //x=4.56 //y=2.265 //x2=4.56 //y2=2.265
r325 (  35 48 ) resistor r=4.5 //w=0.15 //l=0.15 //layer=via1 //count=1 \
 //x=4.555 //y=3.51 //x2=4.555 //y2=3.51
r326 (  32 45 ) resistor r=4.5 //w=0.15 //l=0.15 //layer=via1 //count=1 \
 //x=3.08 //y=3.51 //x2=3.08 //y2=3.51
r327 (  29 120 ) resistor r=9.3 //w=0.17 //l=0.17 //layer=mcon //count=1 \
 //x=2.64 //y=1.18 //x2=2.64 //y2=1.18
r328 (  27 59 ) resistor r=9.3 //w=0.17 //l=0.17 //layer=mcon //count=1 \
 //x=2.6 //y=5.56 //x2=2.6 //y2=5.56
r329 (  24 27 ) resistor r=0.117801 //w=0.191 //l=0.18 //layer=m1 \
 //thickness=0.36 //x=2.6 //y=5.38 //x2=2.6 //y2=5.56
r330 (  23 51 ) resistor r=9.3 //w=0.17 //l=0.17 //layer=mcon //count=1 \
 //x=1.72 //y=5.56 //x2=1.72 //y2=5.56
r331 (  21 23 ) resistor r=0.10274 //w=0.219 //l=0.18 //layer=m1 \
 //thickness=0.36 //x=1.72 //y=5.38 //x2=1.72 //y2=5.56
r332 (  20 41 ) resistor r=0.0732479 //w=0.241 //l=0.122474 //layer=m1 \
 //thickness=0.36 //x=4.56 //y=4.76 //x2=4.565 //y2=4.88
r333 (  19 35 ) resistor r=0.0910802 //w=0.374 //l=0.185472 //layer=m1 \
 //thickness=0.36 //x=4.56 //y=3.67 //x2=4.505 //y2=3.51
r334 (  19 20 ) resistor r=1.04008 //w=0.131 //l=1.09 //layer=m1 \
 //thickness=0.36 //x=4.56 //y=3.67 //x2=4.56 //y2=4.76
r335 (  18 35 ) resistor r=0.0910802 //w=0.374 //l=0.185472 //layer=m1 \
 //thickness=0.36 //x=4.56 //y=3.35 //x2=4.505 //y2=3.51
r336 (  17 38 ) resistor r=0.116051 //w=0.211 //l=0.165 //layer=m1 \
 //thickness=0.36 //x=4.56 //y=2.43 //x2=4.56 //y2=2.265
r337 (  17 18 ) resistor r=0.877863 //w=0.131 //l=0.92 //layer=m1 \
 //thickness=0.36 //x=4.56 //y=2.43 //x2=4.56 //y2=3.35
r338 (  15 32 ) resistor r=0.0911593 //w=0.376 //l=0.184174 //layer=m1 \
 //thickness=0.36 //x=3.08 //y=3.67 //x2=3.132 //y2=3.51
r339 (  15 16 ) resistor r=1.55057 //w=0.131 //l=1.625 //layer=m1 \
 //thickness=0.36 //x=3.08 //y=3.67 //x2=3.08 //y2=5.295
r340 (  14 32 ) resistor r=0.0911593 //w=0.376 //l=0.184174 //layer=m1 \
 //thickness=0.36 //x=3.08 //y=3.35 //x2=3.132 //y2=3.51
r341 (  13 14 ) resistor r=1.3645 //w=0.131 //l=1.43 //layer=m1 \
 //thickness=0.36 //x=3.08 //y=1.92 //x2=3.08 //y2=3.35
r342 (  11 13 ) resistor r=0.0698411 //w=0.17 //l=0.120208 //layer=m1 \
 //thickness=0.36 //x=2.995 //y=1.835 //x2=3.08 //y2=1.92
r343 (  11 12 ) resistor r=0.257634 //w=0.131 //l=0.27 //layer=m1 \
 //thickness=0.36 //x=2.995 //y=1.835 //x2=2.725 //y2=1.835
r344 (  10 24 ) resistor r=0.0257089 //w=0.23 //l=0.115 //layer=m1 \
 //thickness=0.36 //x=2.715 //y=5.38 //x2=2.6 //y2=5.38
r345 (  9 16 ) resistor r=0.0698411 //w=0.17 //l=0.120208 //layer=m1 \
 //thickness=0.36 //x=2.995 //y=5.38 //x2=3.08 //y2=5.295
r346 (  9 10 ) resistor r=0.267176 //w=0.131 //l=0.28 //layer=m1 \
 //thickness=0.36 //x=2.995 //y=5.38 //x2=2.715 //y2=5.38
r347 (  8 12 ) resistor r=0.0698411 //w=0.17 //l=0.120208 //layer=m1 \
 //thickness=0.36 //x=2.64 //y=1.75 //x2=2.725 //y2=1.835
r348 (  7 29 ) resistor r=0.0913624 //w=0.191 //l=0.12 //layer=m1 \
 //thickness=0.36 //x=2.64 //y=1.3 //x2=2.64 //y2=1.18
r349 (  7 8 ) resistor r=0.429389 //w=0.131 //l=0.45 //layer=m1 \
 //thickness=0.36 //x=2.64 //y=1.3 //x2=2.64 //y2=1.75
r350 (  4 21 ) resistor r=0.0227762 //w=0.219 //l=0.115 //layer=m1 \
 //thickness=0.36 //x=1.835 //y=5.38 //x2=1.72 //y2=5.38
r351 (  3 24 ) resistor r=0.0257089 //w=0.23 //l=0.115 //layer=m1 \
 //thickness=0.36 //x=2.485 //y=5.38 //x2=2.6 //y2=5.38
r352 (  3 4 ) resistor r=0.620229 //w=0.131 //l=0.65 //layer=m1 \
 //thickness=0.36 //x=2.485 //y=5.38 //x2=1.835 //y2=5.38
ends PM_HA\%noxref_1

subckt PM_HA\%A ( 1 2 3 4 5 6 7 8 9 10 11 12 13 14 15 22 30 31 33 37 38 41 44 \
 51 66 67 69 76 77 80 89 94 103 108 117 121 122 123 124 125 126 127 128 129 \
 130 131 132 133 137 139 142 143 147 148 149 150 154 155 156 158 164 165 166 \
 167 168 169 173 175 178 179 189 193 207 )
c384 ( 207 0 ) capacitor c=0.066434f //x=9.37 //y=4.88
c385 ( 193 0 ) capacitor c=0.0564228f //x=6.78 //y=2.265
c386 ( 189 0 ) capacitor c=0.0616708f //x=1.6 //y=4.88
c387 ( 179 0 ) capacitor c=0.0318956f //x=9.705 //y=1.395
c388 ( 178 0 ) capacitor c=0.0186836f //x=9.705 //y=1.05
c389 ( 175 0 ) capacitor c=0.0141821f //x=9.55 //y=1.55
c390 ( 173 0 ) capacitor c=0.0158569f //x=9.55 //y=0.895
c391 ( 169 0 ) capacitor c=0.0900967f //x=9.175 //y=2.1
c392 ( 168 0 ) capacitor c=0.0230021f //x=9.175 //y=1.705
c393 ( 167 0 ) capacitor c=0.0234359f //x=9.175 //y=1.395
c394 ( 166 0 ) capacitor c=0.0198787f //x=9.175 //y=1.05
c395 ( 165 0 ) capacitor c=0.0439576f //x=7.42 //y=1.435
c396 ( 164 0 ) capacitor c=0.0201087f //x=7.42 //y=1.09
c397 ( 158 0 ) capacitor c=0.0161986f //x=7.265 //y=1.59
c398 ( 156 0 ) capacitor c=0.0157807f //x=7.265 //y=0.935
c399 ( 155 0 ) capacitor c=0.049833f //x=7.01 //y=4.97
c400 ( 154 0 ) capacitor c=0.0399032f //x=7.3 //y=4.97
c401 ( 150 0 ) capacitor c=0.0301471f //x=6.89 //y=2.1
c402 ( 149 0 ) capacitor c=0.0255349f //x=6.89 //y=1.745
c403 ( 148 0 ) capacitor c=0.0234346f //x=6.89 //y=1.435
c404 ( 147 0 ) capacitor c=0.02013f //x=6.89 //y=1.09
c405 ( 143 0 ) capacitor c=0.0318956f //x=1.935 //y=1.39
c406 ( 142 0 ) capacitor c=0.0186809f //x=1.935 //y=1.045
c407 ( 139 0 ) capacitor c=0.0141821f //x=1.78 //y=1.545
c408 ( 137 0 ) capacitor c=0.0158553f //x=1.78 //y=0.89
c409 ( 133 0 ) capacitor c=0.088055f //x=1.405 //y=2.095
c410 ( 132 0 ) capacitor c=0.0229235f //x=1.405 //y=1.7
c411 ( 131 0 ) capacitor c=0.0234359f //x=1.405 //y=1.39
c412 ( 130 0 ) capacitor c=0.0198759f //x=1.405 //y=1.045
c413 ( 129 0 ) capacitor c=0.110998f //x=9.71 //y=6.2
c414 ( 128 0 ) capacitor c=0.155253f //x=9.27 //y=6.2
c415 ( 127 0 ) capacitor c=0.153927f //x=7.375 //y=6.2
c416 ( 126 0 ) capacitor c=0.154397f //x=6.935 //y=6.2
c417 ( 125 0 ) capacitor c=0.110369f //x=1.94 //y=6.2
c418 ( 124 0 ) capacitor c=0.154619f //x=1.5 //y=6.2
c419 ( 117 0 ) capacitor c=0.00101672f //x=9.37 //y=4.88
c420 ( 108 0 ) capacitor c=0.00134654f //x=9.37 //y=2.265
c421 ( 103 0 ) capacitor c=7.71118e-19 //x=6.78 //y=4.88
c422 ( 94 0 ) capacitor c=0.00101042f //x=6.78 //y=2.265
c423 ( 89 0 ) capacitor c=5.44848e-19 //x=1.6 //y=4.88
c424 ( 80 0 ) capacitor c=7.85889e-19 //x=1.6 //y=2.26
c425 ( 77 0 ) capacitor c=0.057585f //x=9.205 //y=4.255
c426 ( 76 0 ) capacitor c=0.00233614f //x=9.365 //y=4.255
c427 ( 69 0 ) capacitor c=0.00293133f //x=6.94 //y=4.25
c428 ( 67 0 ) capacitor c=0.0107665f //x=1.76 //y=4.25
c429 ( 66 0 ) capacitor c=0.127466f //x=6.62 //y=4.25
c430 ( 51 0 ) capacitor c=0.00785811f //x=6.78 //y=2.265
c431 ( 44 0 ) capacitor c=0.0107598f //x=1.6 //y=4.88
c432 ( 41 0 ) capacitor c=0.01059f //x=1.6 //y=2.26
c433 ( 38 0 ) capacitor c=0.00548543f //x=9.37 //y=4.765
c434 ( 37 0 ) capacitor c=0.0113035f //x=9.37 //y=4.415
c435 ( 33 0 ) capacitor c=0.00791454f //x=9.37 //y=2.42
c436 ( 31 0 ) capacitor c=0.0045583f //x=6.78 //y=4.76
c437 ( 30 0 ) capacitor c=0.0121863f //x=6.78 //y=4.41
c438 ( 22 0 ) capacitor c=0.0119366f //x=1.6 //y=4.41
c439 ( 15 0 ) capacitor c=0.0146426f //x=9.37 //y=4.25
c440 ( 14 0 ) capacitor c=0.0140919f //x=6.78 //y=4.25
c441 ( 13 0 ) capacitor c=0.0155369f //x=1.6 //y=4.25
c442 ( 12 0 ) capacitor c=0.00666f //x=9.37 //y=4.62
c443 ( 10 0 ) capacitor c=0.0528676f //x=9.37 //y=3.14
c444 ( 9 0 ) capacitor c=0.00538522f //x=6.78 //y=4.62
c445 ( 6 0 ) capacitor c=0.0444497f //x=6.78 //y=2.77
c446 ( 5 0 ) capacitor c=0.0105008f //x=1.6 //y=4.62
c447 ( 1 0 ) capacitor c=0.0753943f //x=1.6 //y=2.77
r448 (  205 207 ) resistor r=20.6867 //w=0.233 //l=0.1 //layer=ply \
 //thickness=0.18 //x=9.27 //y=4.88 //x2=9.37 //y2=4.88
r449 (  193 194 ) resistor r=17.5563 //w=0.302 //l=0.11 //layer=ply \
 //thickness=0.18 //x=6.78 //y=2.265 //x2=6.89 //y2=2.265
r450 (  187 189 ) resistor r=20.6867 //w=0.233 //l=0.1 //layer=ply \
 //thickness=0.18 //x=1.5 //y=4.88 //x2=1.6 //y2=4.88
r451 (  180 207 ) resistor r=70.3348 //w=0.233 //l=0.414367 //layer=ply \
 //thickness=0.18 //x=9.71 //y=5.045 //x2=9.37 //y2=4.88
r452 (  179 209 ) resistor r=45.1352 //w=0.168 //l=0.173853 //layer=ply \
 //thickness=0.18 //x=9.705 //y=1.395 //x2=9.665 //y2=1.55
r453 (  178 208 ) resistor r=45.1352 //w=0.168 //l=0.173853 //layer=ply \
 //thickness=0.18 //x=9.705 //y=1.05 //x2=9.665 //y2=0.895
r454 (  178 179 ) resistor r=176.904 //w=0.094 //l=0.345 //layer=ply \
 //thickness=0.18 //x=9.705 //y=1.05 //x2=9.705 //y2=1.395
r455 (  176 204 ) resistor r=10.701 //w=0.21 //l=0.115 //layer=ply \
 //thickness=0.18 //x=9.33 //y=1.55 //x2=9.215 //y2=1.55
r456 (  175 209 ) resistor r=5.52526 //w=0.168 //l=0.115 //layer=ply \
 //thickness=0.18 //x=9.55 //y=1.55 //x2=9.665 //y2=1.55
r457 (  174 203 ) resistor r=5.52526 //w=0.168 //l=0.115 //layer=ply \
 //thickness=0.18 //x=9.33 //y=0.895 //x2=9.215 //y2=0.895
r458 (  173 208 ) resistor r=5.52526 //w=0.168 //l=0.115 //layer=ply \
 //thickness=0.18 //x=9.55 //y=0.895 //x2=9.665 //y2=0.895
r459 (  173 174 ) resistor r=112.809 //w=0.094 //l=0.22 //layer=ply \
 //thickness=0.18 //x=9.55 //y=0.895 //x2=9.33 //y2=0.895
r460 (  170 205 ) resistor r=13.0941 //w=0.233 //l=0.165 //layer=ply \
 //thickness=0.18 //x=9.27 //y=5.045 //x2=9.27 //y2=4.88
r461 (  169 202 ) resistor r=34.8111 //w=0.27 //l=0.264953 //layer=ply \
 //thickness=0.18 //x=9.175 //y=2.1 //x2=9.37 //y2=2.265
r462 (  168 204 ) resistor r=39.5823 //w=0.21 //l=0.173853 //layer=ply \
 //thickness=0.18 //x=9.175 //y=1.705 //x2=9.215 //y2=1.55
r463 (  168 169 ) resistor r=202.543 //w=0.094 //l=0.395 //layer=ply \
 //thickness=0.18 //x=9.175 //y=1.705 //x2=9.175 //y2=2.1
r464 (  167 204 ) resistor r=39.5823 //w=0.21 //l=0.173853 //layer=ply \
 //thickness=0.18 //x=9.175 //y=1.395 //x2=9.215 //y2=1.55
r465 (  166 203 ) resistor r=45.1352 //w=0.168 //l=0.173853 //layer=ply \
 //thickness=0.18 //x=9.175 //y=1.05 //x2=9.215 //y2=0.895
r466 (  166 167 ) resistor r=176.904 //w=0.094 //l=0.345 //layer=ply \
 //thickness=0.18 //x=9.175 //y=1.05 //x2=9.175 //y2=1.395
r467 (  165 200 ) resistor r=45.1352 //w=0.168 //l=0.173853 //layer=ply \
 //thickness=0.18 //x=7.42 //y=1.435 //x2=7.38 //y2=1.59
r468 (  164 199 ) resistor r=45.1352 //w=0.168 //l=0.173853 //layer=ply \
 //thickness=0.18 //x=7.42 //y=1.09 //x2=7.38 //y2=0.935
r469 (  164 165 ) resistor r=176.904 //w=0.094 //l=0.345 //layer=ply \
 //thickness=0.18 //x=7.42 //y=1.09 //x2=7.42 //y2=1.435
r470 (  159 198 ) resistor r=10.701 //w=0.21 //l=0.115 //layer=ply \
 //thickness=0.18 //x=7.045 //y=1.59 //x2=6.93 //y2=1.59
r471 (  158 200 ) resistor r=5.52526 //w=0.168 //l=0.115 //layer=ply \
 //thickness=0.18 //x=7.265 //y=1.59 //x2=7.38 //y2=1.59
r472 (  157 197 ) resistor r=5.52526 //w=0.168 //l=0.115 //layer=ply \
 //thickness=0.18 //x=7.045 //y=0.935 //x2=6.93 //y2=0.935
r473 (  156 199 ) resistor r=5.52526 //w=0.168 //l=0.115 //layer=ply \
 //thickness=0.18 //x=7.265 //y=0.935 //x2=7.38 //y2=0.935
r474 (  156 157 ) resistor r=112.809 //w=0.094 //l=0.22 //layer=ply \
 //thickness=0.18 //x=7.265 //y=0.935 //x2=7.045 //y2=0.935
r475 (  154 161 ) resistor r=26.9307 //w=0.15 //l=0.106066 //layer=ply \
 //thickness=0.18 //x=7.3 //y=4.97 //x2=7.375 //y2=5.045
r476 (  154 155 ) resistor r=148.702 //w=0.094 //l=0.29 //layer=ply \
 //thickness=0.18 //x=7.3 //y=4.97 //x2=7.01 //y2=4.97
r477 (  151 155 ) resistor r=23.403 //w=0.284 //l=0.106066 //layer=ply \
 //thickness=0.18 //x=6.935 //y=5.045 //x2=7.01 //y2=4.97
r478 (  151 196 ) resistor r=26.3063 //w=0.284 //l=0.229783 //layer=ply \
 //thickness=0.18 //x=6.935 //y=5.045 //x2=6.78 //y2=4.88
r479 (  150 194 ) resistor r=19.1248 //w=0.302 //l=0.165 //layer=ply \
 //thickness=0.18 //x=6.89 //y=2.1 //x2=6.89 //y2=2.265
r480 (  149 198 ) resistor r=39.5823 //w=0.21 //l=0.173853 //layer=ply \
 //thickness=0.18 //x=6.89 //y=1.745 //x2=6.93 //y2=1.59
r481 (  149 150 ) resistor r=182.032 //w=0.094 //l=0.355 //layer=ply \
 //thickness=0.18 //x=6.89 //y=1.745 //x2=6.89 //y2=2.1
r482 (  148 198 ) resistor r=39.5823 //w=0.21 //l=0.173853 //layer=ply \
 //thickness=0.18 //x=6.89 //y=1.435 //x2=6.93 //y2=1.59
r483 (  147 197 ) resistor r=45.1352 //w=0.168 //l=0.173853 //layer=ply \
 //thickness=0.18 //x=6.89 //y=1.09 //x2=6.93 //y2=0.935
r484 (  147 148 ) resistor r=176.904 //w=0.094 //l=0.345 //layer=ply \
 //thickness=0.18 //x=6.89 //y=1.09 //x2=6.89 //y2=1.435
r485 (  144 189 ) resistor r=70.3348 //w=0.233 //l=0.414367 //layer=ply \
 //thickness=0.18 //x=1.94 //y=5.045 //x2=1.6 //y2=4.88
r486 (  143 191 ) resistor r=45.1352 //w=0.168 //l=0.173853 //layer=ply \
 //thickness=0.18 //x=1.935 //y=1.39 //x2=1.895 //y2=1.545
r487 (  142 190 ) resistor r=45.1352 //w=0.168 //l=0.173853 //layer=ply \
 //thickness=0.18 //x=1.935 //y=1.045 //x2=1.895 //y2=0.89
r488 (  142 143 ) resistor r=176.904 //w=0.094 //l=0.345 //layer=ply \
 //thickness=0.18 //x=1.935 //y=1.045 //x2=1.935 //y2=1.39
r489 (  140 186 ) resistor r=10.701 //w=0.21 //l=0.115 //layer=ply \
 //thickness=0.18 //x=1.56 //y=1.545 //x2=1.445 //y2=1.545
r490 (  139 191 ) resistor r=5.52526 //w=0.168 //l=0.115 //layer=ply \
 //thickness=0.18 //x=1.78 //y=1.545 //x2=1.895 //y2=1.545
r491 (  138 185 ) resistor r=5.52526 //w=0.168 //l=0.115 //layer=ply \
 //thickness=0.18 //x=1.56 //y=0.89 //x2=1.445 //y2=0.89
r492 (  137 190 ) resistor r=5.52526 //w=0.168 //l=0.115 //layer=ply \
 //thickness=0.18 //x=1.78 //y=0.89 //x2=1.895 //y2=0.89
r493 (  137 138 ) resistor r=112.809 //w=0.094 //l=0.22 //layer=ply \
 //thickness=0.18 //x=1.78 //y=0.89 //x2=1.56 //y2=0.89
r494 (  134 187 ) resistor r=13.0941 //w=0.233 //l=0.165 //layer=ply \
 //thickness=0.18 //x=1.5 //y=5.045 //x2=1.5 //y2=4.88
r495 (  133 184 ) resistor r=34.8111 //w=0.27 //l=0.264953 //layer=ply \
 //thickness=0.18 //x=1.405 //y=2.095 //x2=1.6 //y2=2.26
r496 (  132 186 ) resistor r=39.5823 //w=0.21 //l=0.173853 //layer=ply \
 //thickness=0.18 //x=1.405 //y=1.7 //x2=1.445 //y2=1.545
r497 (  132 133 ) resistor r=202.543 //w=0.094 //l=0.395 //layer=ply \
 //thickness=0.18 //x=1.405 //y=1.7 //x2=1.405 //y2=2.095
r498 (  131 186 ) resistor r=39.5823 //w=0.21 //l=0.173853 //layer=ply \
 //thickness=0.18 //x=1.405 //y=1.39 //x2=1.445 //y2=1.545
r499 (  130 185 ) resistor r=45.1352 //w=0.168 //l=0.173853 //layer=ply \
 //thickness=0.18 //x=1.405 //y=1.045 //x2=1.445 //y2=0.89
r500 (  130 131 ) resistor r=176.904 //w=0.094 //l=0.345 //layer=ply \
 //thickness=0.18 //x=1.405 //y=1.045 //x2=1.405 //y2=1.39
r501 (  129 180 ) resistor r=592.245 //w=0.094 //l=1.155 //layer=ply \
 //thickness=0.18 //x=9.71 //y=6.2 //x2=9.71 //y2=5.045
r502 (  128 170 ) resistor r=592.245 //w=0.094 //l=1.155 //layer=ply \
 //thickness=0.18 //x=9.27 //y=6.2 //x2=9.27 //y2=5.045
r503 (  127 161 ) resistor r=592.245 //w=0.094 //l=1.155 //layer=ply \
 //thickness=0.18 //x=7.375 //y=6.2 //x2=7.375 //y2=5.045
r504 (  126 151 ) resistor r=592.245 //w=0.094 //l=1.155 //layer=ply \
 //thickness=0.18 //x=6.935 //y=6.2 //x2=6.935 //y2=5.045
r505 (  125 144 ) resistor r=592.245 //w=0.094 //l=1.155 //layer=ply \
 //thickness=0.18 //x=1.94 //y=6.2 //x2=1.94 //y2=5.045
r506 (  124 134 ) resistor r=592.245 //w=0.094 //l=1.155 //layer=ply \
 //thickness=0.18 //x=1.5 //y=6.2 //x2=1.5 //y2=5.045
r507 (  123 175 ) resistor r=56.4043 //w=0.094 //l=0.11 //layer=ply \
 //thickness=0.18 //x=9.44 //y=1.55 //x2=9.55 //y2=1.55
r508 (  123 176 ) resistor r=56.4043 //w=0.094 //l=0.11 //layer=ply \
 //thickness=0.18 //x=9.44 //y=1.55 //x2=9.33 //y2=1.55
r509 (  122 158 ) resistor r=56.4043 //w=0.094 //l=0.11 //layer=ply \
 //thickness=0.18 //x=7.155 //y=1.59 //x2=7.265 //y2=1.59
r510 (  122 159 ) resistor r=56.4043 //w=0.094 //l=0.11 //layer=ply \
 //thickness=0.18 //x=7.155 //y=1.59 //x2=7.045 //y2=1.59
r511 (  121 139 ) resistor r=56.4043 //w=0.094 //l=0.11 //layer=ply \
 //thickness=0.18 //x=1.67 //y=1.545 //x2=1.78 //y2=1.545
r512 (  121 140 ) resistor r=56.4043 //w=0.094 //l=0.11 //layer=ply \
 //thickness=0.18 //x=1.67 //y=1.545 //x2=1.56 //y2=1.545
r513 (  117 207 ) resistor r=152 //w=0.17 //l=0.17 //layer=licon //count=1 \
 //x=9.37 //y=4.88 //x2=9.37 //y2=4.88
r514 (  108 202 ) resistor r=152 //w=0.17 //l=0.17 //layer=licon //count=1 \
 //x=9.37 //y=2.265 //x2=9.37 //y2=2.265
r515 (  103 196 ) resistor r=152 //w=0.17 //l=0.17 //layer=licon //count=1 \
 //x=6.78 //y=4.88 //x2=6.78 //y2=4.88
r516 (  94 193 ) resistor r=152 //w=0.17 //l=0.17 //layer=licon //count=1 \
 //x=6.78 //y=2.265 //x2=6.78 //y2=2.265
r517 (  89 189 ) resistor r=152 //w=0.17 //l=0.17 //layer=licon //count=1 \
 //x=1.6 //y=4.88 //x2=1.6 //y2=4.88
r518 (  80 184 ) resistor r=152 //w=0.17 //l=0.17 //layer=licon //count=1 \
 //x=1.6 //y=2.26 //x2=1.6 //y2=2.26
r519 (  76 77 ) resistor r=0.10734 //w=0.281 //l=0.16 //layer=m2 \
 //thickness=0.36 //x=9.365 //y=4.255 //x2=9.205 //y2=4.255
r520 (  69 74 ) resistor r=0.10734 //w=0.281 //l=0.16 //layer=m2 \
 //thickness=0.36 //x=6.94 //y=4.25 //x2=6.78 //y2=4.25
r521 (  69 77 ) resistor r=2.16126 //w=0.131 //l=2.265 //layer=m2 \
 //thickness=0.36 //x=6.94 //y=4.25 //x2=9.205 //y2=4.25
r522 (  67 71 ) resistor r=0.10734 //w=0.281 //l=0.16 //layer=m2 \
 //thickness=0.36 //x=1.76 //y=4.25 //x2=1.6 //y2=4.25
r523 (  66 74 ) resistor r=0.10734 //w=0.281 //l=0.16 //layer=m2 \
 //thickness=0.36 //x=6.62 //y=4.25 //x2=6.78 //y2=4.25
r524 (  66 67 ) resistor r=4.6374 //w=0.131 //l=4.86 //layer=m2 \
 //thickness=0.36 //x=6.62 //y=4.25 //x2=1.76 //y2=4.25
r525 (  65 117 ) resistor r=9.3 //w=0.17 //l=0.17 //layer=mcon //count=1 \
 //x=9.37 //y=4.88 //x2=9.37 //y2=4.88
r526 (  63 108 ) resistor r=9.3 //w=0.17 //l=0.17 //layer=mcon //count=1 \
 //x=9.37 //y=2.265 //x2=9.37 //y2=2.265
r527 (  61 76 ) resistor r=4.5 //w=0.15 //l=0.15 //layer=via1 //count=1 \
 //x=9.365 //y=4.255 //x2=9.365 //y2=4.255
r528 (  54 103 ) resistor r=9.3 //w=0.17 //l=0.17 //layer=mcon //count=1 \
 //x=6.78 //y=4.88 //x2=6.78 //y2=4.88
r529 (  51 94 ) resistor r=9.3 //w=0.17 //l=0.17 //layer=mcon //count=1 \
 //x=6.78 //y=2.265 //x2=6.78 //y2=2.265
r530 (  44 89 ) resistor r=9.3 //w=0.17 //l=0.17 //layer=mcon //count=1 \
 //x=1.6 //y=4.88 //x2=1.6 //y2=4.88
r531 (  44 45 ) resistor r=0.103207 //w=0.196 //l=0.14 //layer=m1 \
 //thickness=0.36 //x=1.602 //y=4.88 //x2=1.602 //y2=4.74
r532 (  41 80 ) resistor r=9.3 //w=0.17 //l=0.17 //layer=mcon //count=1 \
 //x=1.6 //y=2.26 //x2=1.6 //y2=2.26
r533 (  38 65 ) resistor r=0.0717383 //w=0.224 //l=0.115 //layer=m1 \
 //thickness=0.36 //x=9.37 //y=4.765 //x2=9.37 //y2=4.88
r534 (  37 61 ) resistor r=0.0910802 //w=0.374 //l=0.185472 //layer=m1 \
 //thickness=0.36 //x=9.37 //y=4.415 //x2=9.315 //y2=4.255
r535 (  33 63 ) resistor r=0.0916619 //w=0.239 //l=0.156493 //layer=m1 \
 //thickness=0.36 //x=9.37 //y=2.42 //x2=9.367 //y2=2.265
r536 (  31 54 ) resistor r=0.0731974 //w=0.242 //l=0.122474 //layer=m1 \
 //thickness=0.36 //x=6.78 //y=4.76 //x2=6.785 //y2=4.88
r537 (  25 51 ) resistor r=0.116051 //w=0.211 //l=0.165 //layer=m1 \
 //thickness=0.36 //x=6.78 //y=2.43 //x2=6.78 //y2=2.265
r538 (  16 41 ) resistor r=0.0933015 //w=0.201 //l=0.125 //layer=m1 \
 //thickness=0.36 //x=1.6 //y=2.385 //x2=1.6 //y2=2.26
r539 (  15 61 ) resistor r=0.00167112 //w=0.374 //l=0.005 //layer=m1 \
 //thickness=0.36 //x=9.315 //y=4.25 //x2=9.315 //y2=4.255
r540 (  15 34 ) resistor r=0.089409 //w=0.374 //l=0.180416 //layer=m1 \
 //thickness=0.36 //x=9.315 //y=4.25 //x2=9.37 //y2=4.095
r541 (  14 74 ) resistor r=4.5 //w=0.15 //l=0.15 //layer=via1 //count=1 \
 //x=6.78 //y=4.25 //x2=6.78 //y2=4.25
r542 (  14 30 ) resistor r=0.0911593 //w=0.376 //l=0.184174 //layer=m1 \
 //thickness=0.36 //x=6.832 //y=4.25 //x2=6.78 //y2=4.41
r543 (  14 26 ) resistor r=0.0911593 //w=0.376 //l=0.184174 //layer=m1 \
 //thickness=0.36 //x=6.832 //y=4.25 //x2=6.78 //y2=4.09
r544 (  13 71 ) resistor r=4.5 //w=0.15 //l=0.15 //layer=via1 //count=1 \
 //x=1.6 //y=4.25 //x2=1.6 //y2=4.25
r545 (  13 22 ) resistor r=0.0911593 //w=0.376 //l=0.184174 //layer=m1 \
 //thickness=0.36 //x=1.652 //y=4.25 //x2=1.6 //y2=4.41
r546 (  13 17 ) resistor r=0.0911593 //w=0.376 //l=0.184174 //layer=m1 \
 //thickness=0.36 //x=1.652 //y=4.25 //x2=1.6 //y2=4.09
r547 (  12 38 ) resistor r=0.138359 //w=0.131 //l=0.145 //layer=m1 \
 //thickness=0.36 //x=9.37 //y=4.62 //x2=9.37 //y2=4.765
r548 (  12 37 ) resistor r=0.195611 //w=0.131 //l=0.205 //layer=m1 \
 //thickness=0.36 //x=9.37 //y=4.62 //x2=9.37 //y2=4.415
r549 (  11 34 ) resistor r=0.558206 //w=0.131 //l=0.585 //layer=m1 \
 //thickness=0.36 //x=9.37 //y=3.51 //x2=9.37 //y2=4.095
r550 (  10 11 ) resistor r=0.353053 //w=0.131 //l=0.37 //layer=m1 \
 //thickness=0.36 //x=9.37 //y=3.14 //x2=9.37 //y2=3.51
r551 (  10 33 ) resistor r=0.687023 //w=0.131 //l=0.72 //layer=m1 \
 //thickness=0.36 //x=9.37 //y=3.14 //x2=9.37 //y2=2.42
r552 (  9 31 ) resistor r=0.133588 //w=0.131 //l=0.14 //layer=m1 \
 //thickness=0.36 //x=6.78 //y=4.62 //x2=6.78 //y2=4.76
r553 (  9 30 ) resistor r=0.200382 //w=0.131 //l=0.21 //layer=m1 \
 //thickness=0.36 //x=6.78 //y=4.62 //x2=6.78 //y2=4.41
r554 (  8 26 ) resistor r=0.553435 //w=0.131 //l=0.58 //layer=m1 \
 //thickness=0.36 //x=6.78 //y=3.51 //x2=6.78 //y2=4.09
r555 (  7 8 ) resistor r=0.353053 //w=0.131 //l=0.37 //layer=m1 \
 //thickness=0.36 //x=6.78 //y=3.14 //x2=6.78 //y2=3.51
r556 (  6 7 ) resistor r=0.353053 //w=0.131 //l=0.37 //layer=m1 \
 //thickness=0.36 //x=6.78 //y=2.77 //x2=6.78 //y2=3.14
r557 (  6 25 ) resistor r=0.324427 //w=0.131 //l=0.34 //layer=m1 \
 //thickness=0.36 //x=6.78 //y=2.77 //x2=6.78 //y2=2.43
r558 (  5 45 ) resistor r=0.114504 //w=0.131 //l=0.12 //layer=m1 \
 //thickness=0.36 //x=1.6 //y=4.62 //x2=1.6 //y2=4.74
r559 (  5 22 ) resistor r=0.200382 //w=0.131 //l=0.21 //layer=m1 \
 //thickness=0.36 //x=1.6 //y=4.62 //x2=1.6 //y2=4.41
r560 (  4 17 ) resistor r=0.200382 //w=0.131 //l=0.21 //layer=m1 \
 //thickness=0.36 //x=1.6 //y=3.88 //x2=1.6 //y2=4.09
r561 (  3 4 ) resistor r=0.353053 //w=0.131 //l=0.37 //layer=m1 \
 //thickness=0.36 //x=1.6 //y=3.51 //x2=1.6 //y2=3.88
r562 (  2 3 ) resistor r=0.353053 //w=0.131 //l=0.37 //layer=m1 \
 //thickness=0.36 //x=1.6 //y=3.14 //x2=1.6 //y2=3.51
r563 (  1 2 ) resistor r=0.353053 //w=0.131 //l=0.37 //layer=m1 \
 //thickness=0.36 //x=1.6 //y=2.77 //x2=1.6 //y2=3.14
r564 (  1 16 ) resistor r=0.367366 //w=0.131 //l=0.385 //layer=m1 \
 //thickness=0.36 //x=1.6 //y=2.77 //x2=1.6 //y2=2.385
ends PM_HA\%A

subckt PM_HA\%noxref_3 ( 2 4 5 6 7 8 10 11 12 13 14 15 16 18 23 28 31 35 40 41 \
 49 61 70 74 75 76 77 78 79 80 84 86 92 93 101 103 105 )
c302 ( 103 0 ) capacitor c=0.00869746f //x=6.965 //y=1.09
c303 ( 101 0 ) capacitor c=0.069457f //x=13.81 //y=4.88
c304 ( 93 0 ) capacitor c=0.0423887f //x=14.005 //y=1.435
c305 ( 92 0 ) capacitor c=0.0191585f //x=14.005 //y=1.09
c306 ( 86 0 ) capacitor c=0.0125357f //x=13.85 //y=1.59
c307 ( 84 0 ) capacitor c=0.0157807f //x=13.85 //y=0.935
c308 ( 80 0 ) capacitor c=0.0959389f //x=13.475 //y=2.1
c309 ( 79 0 ) capacitor c=0.0197088f //x=13.475 //y=1.745
c310 ( 78 0 ) capacitor c=0.0168511f //x=13.475 //y=1.435
c311 ( 77 0 ) capacitor c=0.0174128f //x=13.475 //y=1.09
c312 ( 76 0 ) capacitor c=0.155893f //x=13.92 //y=6.2
c313 ( 75 0 ) capacitor c=0.110553f //x=13.48 //y=6.2
c314 ( 70 0 ) capacitor c=8.33342e-19 //x=13.81 //y=4.88
c315 ( 61 0 ) capacitor c=6.44043e-19 //x=13.81 //y=2.265
c316 ( 49 0 ) capacitor c=0.0261269f //x=7.155 //y=5.56
c317 ( 41 0 ) capacitor c=0.160008f //x=13.635 //y=2.755
c318 ( 40 0 ) capacitor c=0.00351837f //x=13.795 //y=2.755
c319 ( 35 0 ) capacitor c=0.00274358f //x=7.68 //y=2.77
c320 ( 31 0 ) capacitor c=0.00846219f //x=13.69 //y=4.877
c321 ( 28 0 ) capacitor c=0.0149988f //x=13.81 //y=2.77
c322 ( 23 0 ) capacitor c=0.0140935f //x=7.52 //y=2.77
c323 ( 18 0 ) capacitor c=0.0151906f //x=7.15 //y=1.185
c324 ( 16 0 ) capacitor c=0.00313372f //x=13.81 //y=2.595
c325 ( 15 0 ) capacitor c=0.00460007f //x=13.81 //y=2.41
c326 ( 14 0 ) capacitor c=0.0399884f //x=13.69 //y=4.73
c327 ( 13 0 ) capacitor c=0.00872805f //x=13.69 //y=2.915
c328 ( 12 0 ) capacitor c=0.0570711f //x=7.52 //y=5.055
c329 ( 11 0 ) capacitor c=0.0126154f //x=7.52 //y=2.93
c330 ( 10 0 ) capacitor c=0.0095707f //x=7.52 //y=2.61
c331 ( 8 0 ) capacitor c=0.00475217f //x=7.24 //y=5.14
c332 ( 7 0 ) capacitor c=0.00769652f //x=7.435 //y=5.14
c333 ( 6 0 ) capacitor c=0.00704427f //x=7.235 //y=2.02
c334 ( 5 0 ) capacitor c=0.0119426f //x=7.435 //y=2.02
c335 ( 4 0 ) capacitor c=0.0107084f //x=7.155 //y=5.42
c336 ( 2 0 ) capacitor c=0.0123106f //x=7.15 //y=1.935
r337 (  101 102 ) resistor r=22.7554 //w=0.233 //l=0.11 //layer=ply \
 //thickness=0.18 //x=13.81 //y=4.88 //x2=13.92 //y2=4.88
r338 (  93 99 ) resistor r=45.1352 //w=0.168 //l=0.173853 //layer=ply \
 //thickness=0.18 //x=14.005 //y=1.435 //x2=13.965 //y2=1.59
r339 (  92 98 ) resistor r=45.1352 //w=0.168 //l=0.173853 //layer=ply \
 //thickness=0.18 //x=14.005 //y=1.09 //x2=13.965 //y2=0.935
r340 (  92 93 ) resistor r=176.904 //w=0.094 //l=0.345 //layer=ply \
 //thickness=0.18 //x=14.005 //y=1.09 //x2=14.005 //y2=1.435
r341 (  89 102 ) resistor r=13.0941 //w=0.233 //l=0.165 //layer=ply \
 //thickness=0.18 //x=13.92 //y=5.045 //x2=13.92 //y2=4.88
r342 (  87 95 ) resistor r=10.701 //w=0.21 //l=0.115 //layer=ply \
 //thickness=0.18 //x=13.63 //y=1.59 //x2=13.515 //y2=1.59
r343 (  86 99 ) resistor r=5.52526 //w=0.168 //l=0.115 //layer=ply \
 //thickness=0.18 //x=13.85 //y=1.59 //x2=13.965 //y2=1.59
r344 (  85 94 ) resistor r=5.52526 //w=0.168 //l=0.115 //layer=ply \
 //thickness=0.18 //x=13.63 //y=0.935 //x2=13.515 //y2=0.935
r345 (  84 98 ) resistor r=5.52526 //w=0.168 //l=0.115 //layer=ply \
 //thickness=0.18 //x=13.85 //y=0.935 //x2=13.965 //y2=0.935
r346 (  84 85 ) resistor r=112.809 //w=0.094 //l=0.22 //layer=ply \
 //thickness=0.18 //x=13.85 //y=0.935 //x2=13.63 //y2=0.935
r347 (  81 101 ) resistor r=68.2661 //w=0.233 //l=0.404166 //layer=ply \
 //thickness=0.18 //x=13.48 //y=5.045 //x2=13.81 //y2=4.88
r348 (  80 97 ) resistor r=67.2792 //w=0.24 //l=0.438891 //layer=ply \
 //thickness=0.18 //x=13.475 //y=2.1 //x2=13.81 //y2=2.34
r349 (  79 95 ) resistor r=39.5823 //w=0.21 //l=0.173853 //layer=ply \
 //thickness=0.18 //x=13.475 //y=1.745 //x2=13.515 //y2=1.59
r350 (  79 80 ) resistor r=182.032 //w=0.094 //l=0.355 //layer=ply \
 //thickness=0.18 //x=13.475 //y=1.745 //x2=13.475 //y2=2.1
r351 (  78 95 ) resistor r=39.5823 //w=0.21 //l=0.173853 //layer=ply \
 //thickness=0.18 //x=13.475 //y=1.435 //x2=13.515 //y2=1.59
r352 (  77 94 ) resistor r=45.1352 //w=0.168 //l=0.173853 //layer=ply \
 //thickness=0.18 //x=13.475 //y=1.09 //x2=13.515 //y2=0.935
r353 (  77 78 ) resistor r=176.904 //w=0.094 //l=0.345 //layer=ply \
 //thickness=0.18 //x=13.475 //y=1.09 //x2=13.475 //y2=1.435
r354 (  76 89 ) resistor r=592.245 //w=0.094 //l=1.155 //layer=ply \
 //thickness=0.18 //x=13.92 //y=6.2 //x2=13.92 //y2=5.045
r355 (  75 81 ) resistor r=592.245 //w=0.094 //l=1.155 //layer=ply \
 //thickness=0.18 //x=13.48 //y=6.2 //x2=13.48 //y2=5.045
r356 (  74 86 ) resistor r=56.4043 //w=0.094 //l=0.11 //layer=ply \
 //thickness=0.18 //x=13.74 //y=1.59 //x2=13.85 //y2=1.59
r357 (  74 87 ) resistor r=56.4043 //w=0.094 //l=0.11 //layer=ply \
 //thickness=0.18 //x=13.74 //y=1.59 //x2=13.63 //y2=1.59
r358 (  70 101 ) resistor r=152 //w=0.17 //l=0.17 //layer=licon //count=1 \
 //x=13.81 //y=4.88 //x2=13.81 //y2=4.88
r359 (  61 97 ) resistor r=152 //w=0.17 //l=0.17 //layer=licon //count=1 \
 //x=13.81 //y=2.265 //x2=13.81 //y2=2.265
r360 (  49 105 ) resistor r=23.615 //w=0.187 //l=0.345 //layer=li \
 //thickness=0.1 //x=7.155 //y=5.56 //x2=7.155 //y2=5.905
r361 (  40 41 ) resistor r=0.10734 //w=0.281 //l=0.16 //layer=m2 \
 //thickness=0.36 //x=13.795 //y=2.755 //x2=13.635 //y2=2.755
r362 (  35 37 ) resistor r=0.10734 //w=0.281 //l=0.16 //layer=m2 \
 //thickness=0.36 //x=7.68 //y=2.77 //x2=7.52 //y2=2.77
r363 (  35 41 ) resistor r=5.68225 //w=0.131 //l=5.955 //layer=m2 \
 //thickness=0.36 //x=7.68 //y=2.77 //x2=13.635 //y2=2.77
r364 (  33 70 ) resistor r=9.3 //w=0.17 //l=0.17 //layer=mcon //count=1 \
 //x=13.81 //y=4.88 //x2=13.81 //y2=4.88
r365 (  31 33 ) resistor r=0.0528169 //w=0.284 //l=0.12 //layer=m1 \
 //thickness=0.36 //x=13.69 //y=4.877 //x2=13.81 //y2=4.877
r366 (  30 61 ) resistor r=9.3 //w=0.17 //l=0.17 //layer=mcon //count=1 \
 //x=13.81 //y=2.265 //x2=13.81 //y2=2.265
r367 (  26 40 ) resistor r=4.5 //w=0.15 //l=0.15 //layer=via1 //count=1 \
 //x=13.795 //y=2.755 //x2=13.795 //y2=2.755
r368 (  26 28 ) resistor r=0.00501337 //w=0.374 //l=0.015 //layer=m1 \
 //thickness=0.36 //x=13.75 //y=2.755 //x2=13.75 //y2=2.77
r369 (  23 37 ) resistor r=4.5 //w=0.15 //l=0.15 //layer=via1 //count=1 \
 //x=7.52 //y=2.77 //x2=7.52 //y2=2.77
r370 (  21 49 ) resistor r=9.3 //w=0.17 //l=0.17 //layer=mcon //count=1 \
 //x=7.155 //y=5.56 //x2=7.155 //y2=5.56
r371 (  18 103 ) resistor r=9.3 //w=0.17 //l=0.17 //layer=mcon //count=1 \
 //x=7.15 //y=1.185 //x2=7.15 //y2=1.185
r372 (  16 26 ) resistor r=0.0910802 //w=0.374 //l=0.187617 //layer=m1 \
 //thickness=0.36 //x=13.81 //y=2.595 //x2=13.75 //y2=2.755
r373 (  15 30 ) resistor r=0.0853765 //w=0.25 //l=0.146492 //layer=m1 \
 //thickness=0.36 //x=13.81 //y=2.41 //x2=13.807 //y2=2.265
r374 (  15 16 ) resistor r=0.176527 //w=0.131 //l=0.185 //layer=m1 \
 //thickness=0.36 //x=13.81 //y=2.41 //x2=13.81 //y2=2.595
r375 (  14 31 ) resistor r=0.0383145 //w=0.284 //l=0.147 //layer=m1 \
 //thickness=0.36 //x=13.69 //y=4.73 //x2=13.69 //y2=4.877
r376 (  13 28 ) resistor r=0.0860668 //w=0.374 //l=0.172409 //layer=m1 \
 //thickness=0.36 //x=13.69 //y=2.915 //x2=13.75 //y2=2.77
r377 (  13 14 ) resistor r=1.73187 //w=0.131 //l=1.815 //layer=m1 \
 //thickness=0.36 //x=13.69 //y=2.915 //x2=13.69 //y2=4.73
r378 (  11 23 ) resistor r=0.0911593 //w=0.376 //l=0.184174 //layer=m1 \
 //thickness=0.36 //x=7.52 //y=2.93 //x2=7.572 //y2=2.77
r379 (  11 12 ) resistor r=2.02767 //w=0.131 //l=2.125 //layer=m1 \
 //thickness=0.36 //x=7.52 //y=2.93 //x2=7.52 //y2=5.055
r380 (  10 23 ) resistor r=0.0911593 //w=0.376 //l=0.184174 //layer=m1 \
 //thickness=0.36 //x=7.52 //y=2.61 //x2=7.572 //y2=2.77
r381 (  9 10 ) resistor r=0.48187 //w=0.131 //l=0.505 //layer=m1 \
 //thickness=0.36 //x=7.52 //y=2.105 //x2=7.52 //y2=2.61
r382 (  7 12 ) resistor r=0.0698411 //w=0.17 //l=0.120208 //layer=m1 \
 //thickness=0.36 //x=7.435 //y=5.14 //x2=7.52 //y2=5.055
r383 (  7 8 ) resistor r=0.186069 //w=0.131 //l=0.195 //layer=m1 \
 //thickness=0.36 //x=7.435 //y=5.14 //x2=7.24 //y2=5.14
r384 (  5 9 ) resistor r=0.0698411 //w=0.17 //l=0.120208 //layer=m1 \
 //thickness=0.36 //x=7.435 //y=2.02 //x2=7.52 //y2=2.105
r385 (  5 6 ) resistor r=0.19084 //w=0.131 //l=0.2 //layer=m1 //thickness=0.36 \
 //x=7.435 //y=2.02 //x2=7.235 //y2=2.02
r386 (  4 21 ) resistor r=0.086672 //w=0.218 //l=0.14 //layer=m1 \
 //thickness=0.36 //x=7.155 //y=5.42 //x2=7.155 //y2=5.56
r387 (  3 8 ) resistor r=0.0698411 //w=0.17 //l=0.120208 //layer=m1 \
 //thickness=0.36 //x=7.155 //y=5.225 //x2=7.24 //y2=5.14
r388 (  3 4 ) resistor r=0.186069 //w=0.131 //l=0.195 //layer=m1 \
 //thickness=0.36 //x=7.155 //y=5.225 //x2=7.155 //y2=5.42
r389 (  2 6 ) resistor r=0.0698411 //w=0.17 //l=0.120208 //layer=m1 \
 //thickness=0.36 //x=7.15 //y=1.935 //x2=7.235 //y2=2.02
r390 (  1 18 ) resistor r=0.105739 //w=0.201 //l=0.145 //layer=m1 \
 //thickness=0.36 //x=7.15 //y=1.33 //x2=7.15 //y2=1.185
r391 (  1 2 ) resistor r=0.57729 //w=0.131 //l=0.605 //layer=m1 \
 //thickness=0.36 //x=7.15 //y=1.33 //x2=7.15 //y2=1.935
ends PM_HA\%noxref_3

subckt PM_HA\%SUM ( 1 2 3 4 5 6 7 8 9 10 11 13 14 19 22 23 24 26 27 32 35 44 \
 58 60 61 64 81 97 98 101 102 )
c299 ( 98 0 ) capacitor c=0.00849198f //x=13.55 //y=1.09
c300 ( 97 0 ) capacitor c=0.00849198f //x=10.22 //y=1.09
c301 ( 81 0 ) capacitor c=0.0232369f //x=13.7 //y=5.555
c302 ( 64 0 ) capacitor c=0.0233505f //x=10.37 //y=5.555
c303 ( 61 0 ) capacitor c=0.0332019f //x=14.035 //y=3.895
c304 ( 60 0 ) capacitor c=0.0137849f //x=14.195 //y=3.895
c305 ( 58 0 ) capacitor c=0.00499748f //x=11.175 //y=3.895
c306 ( 44 0 ) capacitor c=0.01028f //x=13.7 //y=5.385
c307 ( 35 0 ) capacitor c=0.0111252f //x=10.37 //y=5.385
c308 ( 32 0 ) capacitor c=0.0122447f //x=14.18 //y=4.055
c309 ( 27 0 ) capacitor c=0.00233399f //x=13.825 //y=1.835
c310 ( 26 0 ) capacitor c=0.0103724f //x=14.095 //y=1.835
c311 ( 24 0 ) capacitor c=0.00837307f //x=14.095 //y=5.385
c312 ( 23 0 ) capacitor c=0.00892846f //x=13.74 //y=1.75
c313 ( 22 0 ) capacitor c=0.00950665f //x=13.74 //y=1.3
c314 ( 19 0 ) capacitor c=0.016041f //x=10.97 //y=4.055
c315 ( 14 0 ) capacitor c=0.00266748f //x=10.495 //y=1.835
c316 ( 13 0 ) capacitor c=0.0137763f //x=10.885 //y=1.835
c317 ( 11 0 ) capacitor c=0.0112285f //x=10.885 //y=5.385
c318 ( 10 0 ) capacitor c=0.00993239f //x=10.41 //y=1.75
c319 ( 9 0 ) capacitor c=0.0101596f //x=10.41 //y=1.305
c320 ( 8 0 ) capacitor c=0.0170398f //x=14.18 //y=3.88
c321 ( 7 0 ) capacitor c=0.0167937f //x=11.02 //y=3.88
c322 ( 6 0 ) capacitor c=0.0239381f //x=14.18 //y=4.99
c323 ( 4 0 ) capacitor c=0.0358152f //x=14.18 //y=2.4
c324 ( 3 0 ) capacitor c=0.0256703f //x=10.97 //y=4.99
c325 ( 1 0 ) capacitor c=0.0458608f //x=10.97 //y=2.4
r326 (  81 102 ) resistor r=23.2727 //w=0.187 //l=0.34 //layer=li \
 //thickness=0.1 //x=13.7 //y=5.555 //x2=13.7 //y2=5.895
r327 (  64 101 ) resistor r=23.2727 //w=0.187 //l=0.34 //layer=li \
 //thickness=0.1 //x=10.37 //y=5.555 //x2=10.37 //y2=5.895
r328 (  60 61 ) resistor r=0.10734 //w=0.281 //l=0.16 //layer=m2 \
 //thickness=0.36 //x=14.195 //y=3.895 //x2=14.035 //y2=3.895
r329 (  58 61 ) resistor r=2.72901 //w=0.131 //l=2.86 //layer=m2 \
 //thickness=0.36 //x=11.175 //y=3.91 //x2=14.035 //y2=3.91
r330 (  56 58 ) resistor r=0.10734 //w=0.281 //l=0.16 //layer=m2 \
 //thickness=0.36 //x=11.015 //y=3.895 //x2=11.175 //y2=3.895
r331 (  52 60 ) resistor r=4.5 //w=0.15 //l=0.15 //layer=via1 //count=1 \
 //x=14.195 //y=3.895 //x2=14.195 //y2=3.895
r332 (  48 98 ) resistor r=9.3 //w=0.17 //l=0.17 //layer=mcon //count=1 \
 //x=13.74 //y=1.185 //x2=13.74 //y2=1.185
r333 (  46 81 ) resistor r=9.3 //w=0.17 //l=0.17 //layer=mcon //count=1 \
 //x=13.7 //y=5.555 //x2=13.7 //y2=5.555
r334 (  44 46 ) resistor r=0.100236 //w=0.212 //l=0.17 //layer=m1 \
 //thickness=0.36 //x=13.7 //y=5.385 //x2=13.7 //y2=5.555
r335 (  43 56 ) resistor r=4.5 //w=0.15 //l=0.15 //layer=via1 //count=1 \
 //x=11.015 //y=3.895 //x2=11.015 //y2=3.895
r336 (  39 97 ) resistor r=9.3 //w=0.17 //l=0.17 //layer=mcon //count=1 \
 //x=10.41 //y=1.185 //x2=10.41 //y2=1.185
r337 (  37 64 ) resistor r=9.3 //w=0.17 //l=0.17 //layer=mcon //count=1 \
 //x=10.37 //y=5.555 //x2=10.37 //y2=5.555
r338 (  35 37 ) resistor r=0.100236 //w=0.212 //l=0.17 //layer=m1 \
 //thickness=0.36 //x=10.37 //y=5.385 //x2=10.37 //y2=5.555
r339 (  32 52 ) resistor r=0.0910802 //w=0.374 //l=0.183303 //layer=m1 \
 //thickness=0.36 //x=14.18 //y=4.055 //x2=14.13 //y2=3.895
r340 (  26 28 ) resistor r=0.0698411 //w=0.17 //l=0.120208 //layer=m1 \
 //thickness=0.36 //x=14.095 //y=1.835 //x2=14.18 //y2=1.92
r341 (  26 27 ) resistor r=0.257634 //w=0.131 //l=0.27 //layer=m1 \
 //thickness=0.36 //x=14.095 //y=1.835 //x2=13.825 //y2=1.835
r342 (  25 44 ) resistor r=0.0208269 //w=0.212 //l=0.115 //layer=m1 \
 //thickness=0.36 //x=13.815 //y=5.385 //x2=13.7 //y2=5.385
r343 (  24 33 ) resistor r=0.0698411 //w=0.17 //l=0.120208 //layer=m1 \
 //thickness=0.36 //x=14.095 //y=5.385 //x2=14.18 //y2=5.3
r344 (  24 25 ) resistor r=0.267176 //w=0.131 //l=0.28 //layer=m1 \
 //thickness=0.36 //x=14.095 //y=5.385 //x2=13.815 //y2=5.385
r345 (  23 27 ) resistor r=0.0698411 //w=0.17 //l=0.120208 //layer=m1 \
 //thickness=0.36 //x=13.74 //y=1.75 //x2=13.825 //y2=1.835
r346 (  22 48 ) resistor r=0.0717383 //w=0.224 //l=0.115 //layer=m1 \
 //thickness=0.36 //x=13.74 //y=1.3 //x2=13.74 //y2=1.185
r347 (  22 23 ) resistor r=0.429389 //w=0.131 //l=0.45 //layer=m1 \
 //thickness=0.36 //x=13.74 //y=1.3 //x2=13.74 //y2=1.75
r348 (  19 43 ) resistor r=0.0911593 //w=0.376 //l=0.203961 //layer=m1 \
 //thickness=0.36 //x=10.97 //y=4.055 //x2=11.07 //y2=3.895
r349 (  13 15 ) resistor r=0.0698411 //w=0.17 //l=0.120208 //layer=m1 \
 //thickness=0.36 //x=10.885 //y=1.835 //x2=10.97 //y2=1.92
r350 (  13 14 ) resistor r=0.372137 //w=0.131 //l=0.39 //layer=m1 \
 //thickness=0.36 //x=10.885 //y=1.835 //x2=10.495 //y2=1.835
r351 (  12 35 ) resistor r=0.0208269 //w=0.212 //l=0.115 //layer=m1 \
 //thickness=0.36 //x=10.485 //y=5.385 //x2=10.37 //y2=5.385
r352 (  11 20 ) resistor r=0.0698411 //w=0.17 //l=0.120208 //layer=m1 \
 //thickness=0.36 //x=10.885 //y=5.385 //x2=10.97 //y2=5.3
r353 (  11 12 ) resistor r=0.381679 //w=0.131 //l=0.4 //layer=m1 \
 //thickness=0.36 //x=10.885 //y=5.385 //x2=10.485 //y2=5.385
r354 (  10 14 ) resistor r=0.0698411 //w=0.17 //l=0.120208 //layer=m1 \
 //thickness=0.36 //x=10.41 //y=1.75 //x2=10.495 //y2=1.835
r355 (  9 39 ) resistor r=0.0740619 //w=0.229 //l=0.120996 //layer=m1 \
 //thickness=0.36 //x=10.41 //y=1.305 //x2=10.412 //y2=1.185
r356 (  9 10 ) resistor r=0.424618 //w=0.131 //l=0.445 //layer=m1 \
 //thickness=0.36 //x=10.41 //y=1.305 //x2=10.41 //y2=1.75
r357 (  8 52 ) resistor r=0.00501337 //w=0.374 //l=0.015 //layer=m1 \
 //thickness=0.36 //x=14.13 //y=3.88 //x2=14.13 //y2=3.895
r358 (  8 29 ) resistor r=0.0860668 //w=0.374 //l=0.168152 //layer=m1 \
 //thickness=0.36 //x=14.13 //y=3.88 //x2=14.18 //y2=3.735
r359 (  7 43 ) resistor r=0.0049867 //w=0.376 //l=0.015 //layer=m1 \
 //thickness=0.36 //x=11.07 //y=3.88 //x2=11.07 //y2=3.895
r360 (  7 16 ) resistor r=0.0861726 //w=0.376 //l=0.188481 //layer=m1 \
 //thickness=0.36 //x=11.07 //y=3.88 //x2=10.97 //y2=3.735
r361 (  6 33 ) resistor r=0.295802 //w=0.131 //l=0.31 //layer=m1 \
 //thickness=0.36 //x=14.18 //y=4.99 //x2=14.18 //y2=5.3
r362 (  6 32 ) resistor r=0.892176 //w=0.131 //l=0.935 //layer=m1 \
 //thickness=0.36 //x=14.18 //y=4.99 //x2=14.18 //y2=4.055
r363 (  5 29 ) resistor r=0.920802 //w=0.131 //l=0.965 //layer=m1 \
 //thickness=0.36 //x=14.18 //y=2.77 //x2=14.18 //y2=3.735
r364 (  4 5 ) resistor r=0.353053 //w=0.131 //l=0.37 //layer=m1 \
 //thickness=0.36 //x=14.18 //y=2.4 //x2=14.18 //y2=2.77
r365 (  4 28 ) resistor r=0.458015 //w=0.131 //l=0.48 //layer=m1 \
 //thickness=0.36 //x=14.18 //y=2.4 //x2=14.18 //y2=1.92
r366 (  3 20 ) resistor r=0.295802 //w=0.131 //l=0.31 //layer=m1 \
 //thickness=0.36 //x=10.97 //y=4.99 //x2=10.97 //y2=5.3
r367 (  3 19 ) resistor r=0.892176 //w=0.131 //l=0.935 //layer=m1 \
 //thickness=0.36 //x=10.97 //y=4.99 //x2=10.97 //y2=4.055
r368 (  2 16 ) resistor r=0.214695 //w=0.131 //l=0.225 //layer=m1 \
 //thickness=0.36 //x=10.97 //y=3.51 //x2=10.97 //y2=3.735
r369 (  1 2 ) resistor r=1.05916 //w=0.131 //l=1.11 //layer=m1 \
 //thickness=0.36 //x=10.97 //y=2.4 //x2=10.97 //y2=3.51
r370 (  1 15 ) resistor r=0.458015 //w=0.131 //l=0.48 //layer=m1 \
 //thickness=0.36 //x=10.97 //y=2.4 //x2=10.97 //y2=1.92
ends PM_HA\%SUM

subckt PM_HA\%noxref_5 ( 1 2 3 4 6 7 8 9 10 11 12 13 14 16 18 24 28 34 36 40 \
 48 54 56 57 60 61 68 73 90 102 103 104 111 112 113 114 115 117 120 121 123 \
 131 133 )
c294 ( 131 0 ) capacitor c=0.00869746f //x=15.835 //y=1.09
c295 ( 123 0 ) capacitor c=0.0616211f //x=10.48 //y=4.88
c296 ( 121 0 ) capacitor c=0.0318956f //x=13.035 //y=1.395
c297 ( 120 0 ) capacitor c=0.0186836f //x=13.035 //y=1.05
c298 ( 117 0 ) capacitor c=0.0141821f //x=12.88 //y=1.55
c299 ( 115 0 ) capacitor c=0.0158569f //x=12.88 //y=0.895
c300 ( 114 0 ) capacitor c=0.0874759f //x=12.505 //y=2.1
c301 ( 113 0 ) capacitor c=0.0230012f //x=12.505 //y=1.705
c302 ( 112 0 ) capacitor c=0.0234359f //x=12.505 //y=1.395
c303 ( 111 0 ) capacitor c=0.0198787f //x=12.505 //y=1.05
c304 ( 104 0 ) capacitor c=0.155893f //x=10.59 //y=6.2
c305 ( 103 0 ) capacitor c=0.110553f //x=10.15 //y=6.2
c306 ( 90 0 ) capacitor c=0.0261682f //x=16.025 //y=5.56
c307 ( 73 0 ) capacitor c=0.00142446f //x=12.7 //y=2.265
c308 ( 68 0 ) capacitor c=5.94524e-19 //x=10.48 //y=4.88
c309 ( 61 0 ) capacitor c=0.0256835f //x=15.535 //y=3.495
c310 ( 60 0 ) capacitor c=3.18161e-19 //x=15.695 //y=3.495
c311 ( 57 0 ) capacitor c=0.0534727f //x=15.505 //y=4.27
c312 ( 56 0 ) capacitor c=0.00326455f //x=15.665 //y=4.27
c313 ( 54 0 ) capacitor c=0.00256557f //x=12.86 //y=3.525
c314 ( 48 0 ) capacitor c=0.0027669f //x=10.525 //y=4.28
c315 ( 40 0 ) capacitor c=0.0190626f //x=16.03 //y=1.185
c316 ( 36 0 ) capacitor c=0.0136176f //x=15.66 //y=4.25
c317 ( 34 0 ) capacitor c=0.0164436f //x=15.66 //y=3.51
c318 ( 28 0 ) capacitor c=0.0312924f //x=12.7 //y=3.51
c319 ( 24 0 ) capacitor c=0.0144f //x=10.525 //y=4.415
c320 ( 18 0 ) capacitor c=0.0169987f //x=16.03 //y=1.935
c321 ( 16 0 ) capacitor c=0.0116416f //x=16.025 //y=5.42
c322 ( 14 0 ) capacitor c=0.0026268f //x=15.745 //y=5.14
c323 ( 13 0 ) capacitor c=0.00884994f //x=15.94 //y=5.14
c324 ( 12 0 ) capacitor c=0.00445515f //x=15.745 //y=2.02
c325 ( 11 0 ) capacitor c=0.014706f //x=15.945 //y=2.02
c326 ( 10 0 ) capacitor c=0.00919778f //x=15.66 //y=5.055
c327 ( 9 0 ) capacitor c=0.0114708f //x=15.66 //y=4.43
c328 ( 8 0 ) capacitor c=0.0112194f //x=15.66 //y=4.135
c329 ( 7 0 ) capacitor c=0.0126935f //x=15.66 //y=3.655
c330 ( 6 0 ) capacitor c=0.0252511f //x=15.66 //y=3.335
c331 ( 4 0 ) capacitor c=0.0259221f //x=12.7 //y=3.385
c332 ( 3 0 ) capacitor c=0.00668061f //x=12.7 //y=2.385
c333 ( 2 0 ) capacitor c=0.00466512f //x=10.48 //y=4.765
c334 ( 1 0 ) capacitor c=0.0116958f //x=10.48 //y=4.575
r335 (  123 124 ) resistor r=22.7554 //w=0.233 //l=0.11 //layer=ply \
 //thickness=0.18 //x=10.48 //y=4.88 //x2=10.59 //y2=4.88
r336 (  121 130 ) resistor r=45.1352 //w=0.168 //l=0.173853 //layer=ply \
 //thickness=0.18 //x=13.035 //y=1.395 //x2=12.995 //y2=1.55
r337 (  120 129 ) resistor r=45.1352 //w=0.168 //l=0.173853 //layer=ply \
 //thickness=0.18 //x=13.035 //y=1.05 //x2=12.995 //y2=0.895
r338 (  120 121 ) resistor r=176.904 //w=0.094 //l=0.345 //layer=ply \
 //thickness=0.18 //x=13.035 //y=1.05 //x2=13.035 //y2=1.395
r339 (  118 128 ) resistor r=10.701 //w=0.21 //l=0.115 //layer=ply \
 //thickness=0.18 //x=12.66 //y=1.55 //x2=12.545 //y2=1.55
r340 (  117 130 ) resistor r=5.52526 //w=0.168 //l=0.115 //layer=ply \
 //thickness=0.18 //x=12.88 //y=1.55 //x2=12.995 //y2=1.55
r341 (  116 127 ) resistor r=5.52526 //w=0.168 //l=0.115 //layer=ply \
 //thickness=0.18 //x=12.66 //y=0.895 //x2=12.545 //y2=0.895
r342 (  115 129 ) resistor r=5.52526 //w=0.168 //l=0.115 //layer=ply \
 //thickness=0.18 //x=12.88 //y=0.895 //x2=12.995 //y2=0.895
r343 (  115 116 ) resistor r=112.809 //w=0.094 //l=0.22 //layer=ply \
 //thickness=0.18 //x=12.88 //y=0.895 //x2=12.66 //y2=0.895
r344 (  114 126 ) resistor r=34.8111 //w=0.27 //l=0.264953 //layer=ply \
 //thickness=0.18 //x=12.505 //y=2.1 //x2=12.7 //y2=2.265
r345 (  113 128 ) resistor r=39.5823 //w=0.21 //l=0.173853 //layer=ply \
 //thickness=0.18 //x=12.505 //y=1.705 //x2=12.545 //y2=1.55
r346 (  113 114 ) resistor r=202.543 //w=0.094 //l=0.395 //layer=ply \
 //thickness=0.18 //x=12.505 //y=1.705 //x2=12.505 //y2=2.1
r347 (  112 128 ) resistor r=39.5823 //w=0.21 //l=0.173853 //layer=ply \
 //thickness=0.18 //x=12.505 //y=1.395 //x2=12.545 //y2=1.55
r348 (  111 127 ) resistor r=45.1352 //w=0.168 //l=0.173853 //layer=ply \
 //thickness=0.18 //x=12.505 //y=1.05 //x2=12.545 //y2=0.895
r349 (  111 112 ) resistor r=176.904 //w=0.094 //l=0.345 //layer=ply \
 //thickness=0.18 //x=12.505 //y=1.05 //x2=12.505 //y2=1.395
r350 (  108 124 ) resistor r=13.0941 //w=0.233 //l=0.165 //layer=ply \
 //thickness=0.18 //x=10.59 //y=5.045 //x2=10.59 //y2=4.88
r351 (  105 123 ) resistor r=68.2661 //w=0.233 //l=0.404166 //layer=ply \
 //thickness=0.18 //x=10.15 //y=5.045 //x2=10.48 //y2=4.88
r352 (  104 108 ) resistor r=592.245 //w=0.094 //l=1.155 //layer=ply \
 //thickness=0.18 //x=10.59 //y=6.2 //x2=10.59 //y2=5.045
r353 (  103 105 ) resistor r=592.245 //w=0.094 //l=1.155 //layer=ply \
 //thickness=0.18 //x=10.15 //y=6.2 //x2=10.15 //y2=5.045
r354 (  102 117 ) resistor r=56.4043 //w=0.094 //l=0.11 //layer=ply \
 //thickness=0.18 //x=12.77 //y=1.55 //x2=12.88 //y2=1.55
r355 (  102 118 ) resistor r=56.4043 //w=0.094 //l=0.11 //layer=ply \
 //thickness=0.18 //x=12.77 //y=1.55 //x2=12.66 //y2=1.55
r356 (  90 133 ) resistor r=23.615 //w=0.187 //l=0.345 //layer=li \
 //thickness=0.1 //x=16.025 //y=5.56 //x2=16.025 //y2=5.905
r357 (  73 126 ) resistor r=152 //w=0.17 //l=0.17 //layer=licon //count=1 \
 //x=12.7 //y=2.265 //x2=12.7 //y2=2.265
r358 (  68 123 ) resistor r=152 //w=0.17 //l=0.17 //layer=licon //count=1 \
 //x=10.48 //y=4.88 //x2=10.48 //y2=4.88
r359 (  60 61 ) resistor r=0.10734 //w=0.281 //l=0.16 //layer=m2 \
 //thickness=0.36 //x=15.695 //y=3.495 //x2=15.535 //y2=3.495
r360 (  56 57 ) resistor r=0.10734 //w=0.281 //l=0.16 //layer=m2 \
 //thickness=0.36 //x=15.665 //y=4.27 //x2=15.505 //y2=4.27
r361 (  54 61 ) resistor r=2.55248 //w=0.131 //l=2.675 //layer=m2 \
 //thickness=0.36 //x=12.86 //y=3.51 //x2=15.535 //y2=3.51
r362 (  52 54 ) resistor r=0.10734 //w=0.281 //l=0.16 //layer=m2 \
 //thickness=0.36 //x=12.7 //y=3.525 //x2=12.86 //y2=3.525
r363 (  48 50 ) resistor r=0.0539137 //w=0.313 //l=0.135 //layer=m2 \
 //thickness=0.36 //x=10.525 //y=4.28 //x2=10.525 //y2=4.415
r364 (  45 48 ) resistor r=0.0441684 //w=0.313 //l=0.16 //layer=m2 \
 //thickness=0.36 //x=10.685 //y=4.28 //x2=10.525 //y2=4.28
r365 (  45 57 ) resistor r=4.59924 //w=0.131 //l=4.82 //layer=m2 \
 //thickness=0.36 //x=10.685 //y=4.28 //x2=15.505 //y2=4.28
r366 (  43 90 ) resistor r=9.3 //w=0.17 //l=0.17 //layer=mcon //count=1 \
 //x=16.025 //y=5.56 //x2=16.025 //y2=5.56
r367 (  40 131 ) resistor r=9.3 //w=0.17 //l=0.17 //layer=mcon //count=1 \
 //x=16.03 //y=1.185 //x2=16.03 //y2=1.185
r368 (  38 56 ) resistor r=4.5 //w=0.15 //l=0.15 //layer=via1 //count=1 \
 //x=15.665 //y=4.27 //x2=15.665 //y2=4.27
r369 (  36 38 ) resistor r=0.0065445 //w=0.382 //l=0.02 //layer=m1 \
 //thickness=0.36 //x=15.61 //y=4.25 //x2=15.61 //y2=4.27
r370 (  32 60 ) resistor r=4.5 //w=0.15 //l=0.15 //layer=via1 //count=1 \
 //x=15.695 //y=3.495 //x2=15.695 //y2=3.495
r371 (  32 34 ) resistor r=0.00474684 //w=0.395 //l=0.015 //layer=m1 \
 //thickness=0.36 //x=15.625 //y=3.495 //x2=15.625 //y2=3.51
r372 (  30 52 ) resistor r=4.5 //w=0.15 //l=0.15 //layer=via1 //count=1 \
 //x=12.7 //y=3.525 //x2=12.7 //y2=3.525
r373 (  28 30 ) resistor r=0.00493421 //w=0.38 //l=0.015 //layer=m1 \
 //thickness=0.36 //x=12.752 //y=3.51 //x2=12.752 //y2=3.525
r374 (  26 73 ) resistor r=9.3 //w=0.17 //l=0.17 //layer=mcon //count=1 \
 //x=12.7 //y=2.265 //x2=12.7 //y2=2.265
r375 (  24 50 ) resistor r=4.5 //w=0.15 //l=0.15 //layer=via1 //count=1 \
 //x=10.525 //y=4.415 //x2=10.525 //y2=4.415
r376 (  20 68 ) resistor r=9.3 //w=0.17 //l=0.17 //layer=mcon //count=1 \
 //x=10.48 //y=4.88 //x2=10.48 //y2=4.88
r377 (  17 40 ) resistor r=0.105739 //w=0.201 //l=0.145 //layer=m1 \
 //thickness=0.36 //x=16.03 //y=1.33 //x2=16.03 //y2=1.185
r378 (  17 18 ) resistor r=0.57729 //w=0.131 //l=0.605 //layer=m1 \
 //thickness=0.36 //x=16.03 //y=1.33 //x2=16.03 //y2=1.935
r379 (  16 43 ) resistor r=0.086672 //w=0.218 //l=0.14 //layer=m1 \
 //thickness=0.36 //x=16.025 //y=5.42 //x2=16.025 //y2=5.56
r380 (  15 16 ) resistor r=0.186069 //w=0.131 //l=0.195 //layer=m1 \
 //thickness=0.36 //x=16.025 //y=5.225 //x2=16.025 //y2=5.42
r381 (  13 15 ) resistor r=0.0698411 //w=0.17 //l=0.120208 //layer=m1 \
 //thickness=0.36 //x=15.94 //y=5.14 //x2=16.025 //y2=5.225
r382 (  13 14 ) resistor r=0.186069 //w=0.131 //l=0.195 //layer=m1 \
 //thickness=0.36 //x=15.94 //y=5.14 //x2=15.745 //y2=5.14
r383 (  11 18 ) resistor r=0.0698411 //w=0.17 //l=0.120208 //layer=m1 \
 //thickness=0.36 //x=15.945 //y=2.02 //x2=16.03 //y2=1.935
r384 (  11 12 ) resistor r=0.19084 //w=0.131 //l=0.2 //layer=m1 \
 //thickness=0.36 //x=15.945 //y=2.02 //x2=15.745 //y2=2.02
r385 (  10 14 ) resistor r=0.0698411 //w=0.17 //l=0.120208 //layer=m1 \
 //thickness=0.36 //x=15.66 //y=5.055 //x2=15.745 //y2=5.14
r386 (  9 38 ) resistor r=0.0914072 //w=0.382 //l=0.183303 //layer=m1 \
 //thickness=0.36 //x=15.66 //y=4.43 //x2=15.61 //y2=4.27
r387 (  9 10 ) resistor r=0.596374 //w=0.131 //l=0.625 //layer=m1 \
 //thickness=0.36 //x=15.66 //y=4.43 //x2=15.66 //y2=5.055
r388 (  8 36 ) resistor r=0.0766821 //w=0.382 //l=0.13775 //layer=m1 \
 //thickness=0.36 //x=15.66 //y=4.135 //x2=15.61 //y2=4.25
r389 (  7 34 ) resistor r=0.087246 //w=0.395 //l=0.161555 //layer=m1 \
 //thickness=0.36 //x=15.66 //y=3.655 //x2=15.625 //y2=3.51
r390 (  7 8 ) resistor r=0.458015 //w=0.131 //l=0.48 //layer=m1 \
 //thickness=0.36 //x=15.66 //y=3.655 //x2=15.66 //y2=4.135
r391 (  6 32 ) resistor r=0.0919929 //w=0.395 //l=0.176635 //layer=m1 \
 //thickness=0.36 //x=15.66 //y=3.335 //x2=15.625 //y2=3.495
r392 (  5 12 ) resistor r=0.0698411 //w=0.17 //l=0.120208 //layer=m1 \
 //thickness=0.36 //x=15.66 //y=2.105 //x2=15.745 //y2=2.02
r393 (  5 6 ) resistor r=1.17366 //w=0.131 //l=1.23 //layer=m1 \
 //thickness=0.36 //x=15.66 //y=2.105 //x2=15.66 //y2=3.335
r394 (  4 28 ) resistor r=0.0798098 //w=0.38 //l=0.148745 //layer=m1 \
 //thickness=0.36 //x=12.7 //y=3.385 //x2=12.752 //y2=3.51
r395 (  3 26 ) resistor r=0.0736049 //w=0.235 //l=0.12 //layer=m1 \
 //thickness=0.36 //x=12.7 //y=2.385 //x2=12.7 //y2=2.265
r396 (  3 4 ) resistor r=0.954198 //w=0.131 //l=1 //layer=m1 //thickness=0.36 \
 //x=12.7 //y=2.385 //x2=12.7 //y2=3.385
r397 (  2 20 ) resistor r=0.0704783 //w=0.246 //l=0.115 //layer=m1 \
 //thickness=0.36 //x=10.48 //y=4.765 //x2=10.48 //y2=4.88
r398 (  1 24 ) resistor r=0.0902587 //w=0.349 //l=0.187617 //layer=m1 \
 //thickness=0.36 //x=10.48 //y=4.575 //x2=10.54 //y2=4.415
r399 (  1 2 ) resistor r=0.181298 //w=0.131 //l=0.19 //layer=m1 \
 //thickness=0.36 //x=10.48 //y=4.575 //x2=10.48 //y2=4.765
ends PM_HA\%noxref_5

subckt PM_HA\%B ( 1 2 3 4 5 6 7 8 9 10 11 12 13 14 20 21 25 26 30 37 64 70 72 \
 74 76 78 80 82 84 86 89 90 91 92 94 96 97 101 103 108 116 125 134 143 149 158 \
 162 163 164 165 166 167 168 169 170 171 172 173 178 180 182 188 189 190 191 \
 192 193 194 196 199 200 207 208 212 213 214 216 219 222 223 224 225 227 228 \
 231 247 252 )
c500 ( 252 0 ) capacitor c=0.052693f //x=16.29 //y=2.265
c501 ( 247 0 ) capacitor c=0.0660028f //x=12.7 //y=4.88
c502 ( 231 0 ) capacitor c=0.0365206f //x=2.37 //y=4.88
c503 ( 228 0 ) capacitor c=0.0284095f //x=2.34 //y=2.095
c504 ( 227 0 ) capacitor c=0.0476356f //x=2.34 //y=2.26
c505 ( 225 0 ) capacitor c=0.0301471f //x=16.29 //y=2.1
c506 ( 224 0 ) capacitor c=0.0255528f //x=16.29 //y=1.745
c507 ( 223 0 ) capacitor c=0.0234346f //x=16.29 //y=1.435
c508 ( 222 0 ) capacitor c=0.0201416f //x=16.29 //y=1.09
c509 ( 219 0 ) capacitor c=0.0550305f //x=16.245 //y=5.045
c510 ( 216 0 ) capacitor c=0.0161986f //x=16.135 //y=1.59
c511 ( 214 0 ) capacitor c=0.0157807f //x=16.135 //y=0.935
c512 ( 213 0 ) capacitor c=0.0146709f //x=15.88 //y=4.97
c513 ( 212 0 ) capacitor c=0.0244235f //x=16.17 //y=4.97
c514 ( 208 0 ) capacitor c=0.0439428f //x=15.76 //y=1.435
c515 ( 207 0 ) capacitor c=0.020097f //x=15.76 //y=1.09
c516 ( 200 0 ) capacitor c=0.0423887f //x=10.675 //y=1.435
c517 ( 199 0 ) capacitor c=0.0192582f //x=10.675 //y=1.09
c518 ( 196 0 ) capacitor c=0.0126237f //x=10.52 //y=1.59
c519 ( 194 0 ) capacitor c=0.0157807f //x=10.52 //y=0.935
c520 ( 193 0 ) capacitor c=0.0975376f //x=10.145 //y=2.1
c521 ( 192 0 ) capacitor c=0.0197088f //x=10.145 //y=1.745
c522 ( 191 0 ) capacitor c=0.0168511f //x=10.145 //y=1.435
c523 ( 190 0 ) capacitor c=0.0175047f //x=10.145 //y=1.09
c524 ( 189 0 ) capacitor c=0.0439708f //x=2.905 //y=1.43
c525 ( 188 0 ) capacitor c=0.0192582f //x=2.905 //y=1.085
c526 ( 182 0 ) capacitor c=0.0162526f //x=2.75 //y=1.585
c527 ( 180 0 ) capacitor c=0.0157807f //x=2.75 //y=0.93
c528 ( 178 0 ) capacitor c=0.0360391f //x=2.745 //y=4.97
c529 ( 173 0 ) capacitor c=0.0210762f //x=2.375 //y=1.74
c530 ( 172 0 ) capacitor c=0.0168511f //x=2.375 //y=1.43
c531 ( 171 0 ) capacitor c=0.0175485f //x=2.375 //y=1.085
c532 ( 170 0 ) capacitor c=0.154411f //x=16.245 //y=6.2
c533 ( 169 0 ) capacitor c=0.153944f //x=15.805 //y=6.2
c534 ( 168 0 ) capacitor c=0.110998f //x=13.04 //y=6.2
c535 ( 167 0 ) capacitor c=0.155254f //x=12.6 //y=6.2
c536 ( 166 0 ) capacitor c=0.155269f //x=2.82 //y=6.2
c537 ( 165 0 ) capacitor c=0.110375f //x=2.38 //y=6.2
c538 ( 158 0 ) capacitor c=9.53968e-19 //x=16.4 //y=4.88
c539 ( 149 0 ) capacitor c=6.43121e-19 //x=16.4 //y=2.265
c540 ( 143 0 ) capacitor c=0.0118591f //x=12.7 //y=4.62
c541 ( 134 0 ) capacitor c=5.55171e-19 //x=10.48 //y=2.265
c542 ( 125 0 ) capacitor c=8.90417e-19 //x=2.37 //y=4.88
c543 ( 116 0 ) capacitor c=5.78095e-19 //x=2.34 //y=2.26
c544 ( 108 0 ) capacitor c=2.37657e-19 //x=10.64 //y=3.155
c545 ( 103 0 ) capacitor c=0.0122385f //x=10.105 //y=3.87
c546 ( 101 0 ) capacitor c=0.00315392f //x=2.505 //y=3.865
c547 ( 97 0 ) capacitor c=0.0706934f //x=15.535 //y=4.655
c548 ( 96 0 ) capacitor c=0.0205912f //x=15.88 //y=4.655
c549 ( 94 0 ) capacitor c=0.0260571f //x=15.91 //y=3.11
c550 ( 92 0 ) capacitor c=0.0850652f //x=15.31 //y=3.14
c551 ( 91 0 ) capacitor c=0.00641641f //x=10.195 //y=5.045
c552 ( 90 0 ) capacitor c=0.0628645f //x=12.54 //y=5.045
c553 ( 89 0 ) capacitor c=0.0073159f //x=10.11 //y=4.96
c554 ( 86 0 ) capacitor c=0.00394207f //x=9.58 //y=3.87
c555 ( 84 0 ) capacitor c=0.0318803f //x=8.98 //y=3.88
c556 ( 82 0 ) capacitor c=0.0154732f //x=6.995 //y=3.865
c557 ( 80 0 ) capacitor c=0.0492493f //x=6.395 //y=3.88
c558 ( 78 0 ) capacitor c=0.00867522f //x=4.77 //y=3.895
c559 ( 76 0 ) capacitor c=0.0120031f //x=4.17 //y=3.88
c560 ( 74 0 ) capacitor c=0.00393532f //x=3.295 //y=3.895
c561 ( 72 0 ) capacitor c=0.00899349f //x=2.695 //y=3.88
c562 ( 70 0 ) capacitor c=0.01346f //x=16.4 //y=2.265
c563 ( 64 0 ) capacitor c=0.00618588f //x=16.4 //y=4.88
c564 ( 37 0 ) capacitor c=0.00650008f //x=2.34 //y=2.26
c565 ( 30 0 ) capacitor c=0.0140818f //x=16.4 //y=3.3
c566 ( 26 0 ) capacitor c=0.011511f //x=10.48 //y=2.995
c567 ( 25 0 ) capacitor c=0.0047199f //x=10.48 //y=2.415
c568 ( 21 0 ) capacitor c=0.00421628f //x=2.34 //y=4.735
c569 ( 20 0 ) capacitor c=0.0102652f //x=2.34 //y=4.025
c570 ( 14 0 ) capacitor c=0.0169856f //x=16.4 //y=3.14
c571 ( 13 0 ) capacitor c=0.013641f //x=12.7 //y=4.62
c572 ( 12 0 ) capacitor c=0.0271598f //x=10.48 //y=3.14
c573 ( 11 0 ) capacitor c=0.0378953f //x=10.11 //y=3.88
c574 ( 10 0 ) capacitor c=0.0146832f //x=2.34 //y=3.88
c575 ( 6 0 ) capacitor c=0.0565408f //x=16.4 //y=3.51
c576 ( 5 0 ) capacitor c=0.0178622f //x=16.4 //y=2.77
c577 ( 4 0 ) capacitor c=0.0128989f //x=2.34 //y=4.62
c578 ( 1 0 ) capacitor c=0.0306918f //x=2.34 //y=2.77
r579 (  252 254 ) resistor r=17.5563 //w=0.302 //l=0.11 //layer=ply \
 //thickness=0.18 //x=16.29 //y=2.265 //x2=16.4 //y2=2.265
r580 (  245 247 ) resistor r=20.6867 //w=0.233 //l=0.1 //layer=ply \
 //thickness=0.18 //x=12.6 //y=4.88 //x2=12.7 //y2=4.88
r581 (  233 234 ) resistor r=32.4568 //w=0.214 //l=0.075 //layer=ply \
 //thickness=0.18 //x=2.37 //y=4.97 //x2=2.37 //y2=5.045
r582 (  231 233 ) resistor r=20.271 //w=0.214 //l=0.09 //layer=ply \
 //thickness=0.18 //x=2.37 //y=4.88 //x2=2.37 //y2=4.97
r583 (  227 228 ) resistor r=52.7279 //w=0.214 //l=0.165 //layer=ply \
 //thickness=0.18 //x=2.34 //y=2.26 //x2=2.34 //y2=2.095
r584 (  225 252 ) resistor r=19.1248 //w=0.302 //l=0.165 //layer=ply \
 //thickness=0.18 //x=16.29 //y=2.1 //x2=16.29 //y2=2.265
r585 (  224 251 ) resistor r=39.5823 //w=0.21 //l=0.173853 //layer=ply \
 //thickness=0.18 //x=16.29 //y=1.745 //x2=16.25 //y2=1.59
r586 (  224 225 ) resistor r=182.032 //w=0.094 //l=0.355 //layer=ply \
 //thickness=0.18 //x=16.29 //y=1.745 //x2=16.29 //y2=2.1
r587 (  223 251 ) resistor r=39.5823 //w=0.21 //l=0.173853 //layer=ply \
 //thickness=0.18 //x=16.29 //y=1.435 //x2=16.25 //y2=1.59
r588 (  222 250 ) resistor r=45.1352 //w=0.168 //l=0.173853 //layer=ply \
 //thickness=0.18 //x=16.29 //y=1.09 //x2=16.25 //y2=0.935
r589 (  222 223 ) resistor r=176.904 //w=0.094 //l=0.345 //layer=ply \
 //thickness=0.18 //x=16.29 //y=1.09 //x2=16.29 //y2=1.435
r590 (  219 256 ) resistor r=26.3063 //w=0.284 //l=0.229783 //layer=ply \
 //thickness=0.18 //x=16.245 //y=5.045 //x2=16.4 //y2=4.88
r591 (  217 249 ) resistor r=5.52526 //w=0.168 //l=0.115 //layer=ply \
 //thickness=0.18 //x=15.915 //y=1.59 //x2=15.8 //y2=1.59
r592 (  216 251 ) resistor r=10.701 //w=0.21 //l=0.115 //layer=ply \
 //thickness=0.18 //x=16.135 //y=1.59 //x2=16.25 //y2=1.59
r593 (  215 248 ) resistor r=5.52526 //w=0.168 //l=0.115 //layer=ply \
 //thickness=0.18 //x=15.915 //y=0.935 //x2=15.8 //y2=0.935
r594 (  214 250 ) resistor r=5.52526 //w=0.168 //l=0.115 //layer=ply \
 //thickness=0.18 //x=16.135 //y=0.935 //x2=16.25 //y2=0.935
r595 (  214 215 ) resistor r=112.809 //w=0.094 //l=0.22 //layer=ply \
 //thickness=0.18 //x=16.135 //y=0.935 //x2=15.915 //y2=0.935
r596 (  212 219 ) resistor r=23.403 //w=0.284 //l=0.106066 //layer=ply \
 //thickness=0.18 //x=16.17 //y=4.97 //x2=16.245 //y2=5.045
r597 (  212 213 ) resistor r=148.702 //w=0.094 //l=0.29 //layer=ply \
 //thickness=0.18 //x=16.17 //y=4.97 //x2=15.88 //y2=4.97
r598 (  209 213 ) resistor r=26.9307 //w=0.15 //l=0.106066 //layer=ply \
 //thickness=0.18 //x=15.805 //y=5.045 //x2=15.88 //y2=4.97
r599 (  208 249 ) resistor r=45.1352 //w=0.168 //l=0.173853 //layer=ply \
 //thickness=0.18 //x=15.76 //y=1.435 //x2=15.8 //y2=1.59
r600 (  207 248 ) resistor r=45.1352 //w=0.168 //l=0.173853 //layer=ply \
 //thickness=0.18 //x=15.76 //y=1.09 //x2=15.8 //y2=0.935
r601 (  207 208 ) resistor r=176.904 //w=0.094 //l=0.345 //layer=ply \
 //thickness=0.18 //x=15.76 //y=1.09 //x2=15.76 //y2=1.435
r602 (  204 247 ) resistor r=70.3348 //w=0.233 //l=0.414367 //layer=ply \
 //thickness=0.18 //x=13.04 //y=5.045 //x2=12.7 //y2=4.88
r603 (  201 245 ) resistor r=13.0941 //w=0.233 //l=0.165 //layer=ply \
 //thickness=0.18 //x=12.6 //y=5.045 //x2=12.6 //y2=4.88
r604 (  200 244 ) resistor r=45.1352 //w=0.168 //l=0.173853 //layer=ply \
 //thickness=0.18 //x=10.675 //y=1.435 //x2=10.635 //y2=1.59
r605 (  199 243 ) resistor r=45.1352 //w=0.168 //l=0.173853 //layer=ply \
 //thickness=0.18 //x=10.675 //y=1.09 //x2=10.635 //y2=0.935
r606 (  199 200 ) resistor r=176.904 //w=0.094 //l=0.345 //layer=ply \
 //thickness=0.18 //x=10.675 //y=1.09 //x2=10.675 //y2=1.435
r607 (  197 240 ) resistor r=10.701 //w=0.21 //l=0.115 //layer=ply \
 //thickness=0.18 //x=10.3 //y=1.59 //x2=10.185 //y2=1.59
r608 (  196 244 ) resistor r=5.52526 //w=0.168 //l=0.115 //layer=ply \
 //thickness=0.18 //x=10.52 //y=1.59 //x2=10.635 //y2=1.59
r609 (  195 239 ) resistor r=5.52526 //w=0.168 //l=0.115 //layer=ply \
 //thickness=0.18 //x=10.3 //y=0.935 //x2=10.185 //y2=0.935
r610 (  194 243 ) resistor r=5.52526 //w=0.168 //l=0.115 //layer=ply \
 //thickness=0.18 //x=10.52 //y=0.935 //x2=10.635 //y2=0.935
r611 (  194 195 ) resistor r=112.809 //w=0.094 //l=0.22 //layer=ply \
 //thickness=0.18 //x=10.52 //y=0.935 //x2=10.3 //y2=0.935
r612 (  193 242 ) resistor r=67.2792 //w=0.24 //l=0.438891 //layer=ply \
 //thickness=0.18 //x=10.145 //y=2.1 //x2=10.48 //y2=2.34
r613 (  192 240 ) resistor r=39.5823 //w=0.21 //l=0.173853 //layer=ply \
 //thickness=0.18 //x=10.145 //y=1.745 //x2=10.185 //y2=1.59
r614 (  192 193 ) resistor r=182.032 //w=0.094 //l=0.355 //layer=ply \
 //thickness=0.18 //x=10.145 //y=1.745 //x2=10.145 //y2=2.1
r615 (  191 240 ) resistor r=39.5823 //w=0.21 //l=0.173853 //layer=ply \
 //thickness=0.18 //x=10.145 //y=1.435 //x2=10.185 //y2=1.59
r616 (  190 239 ) resistor r=45.1352 //w=0.168 //l=0.173853 //layer=ply \
 //thickness=0.18 //x=10.145 //y=1.09 //x2=10.185 //y2=0.935
r617 (  190 191 ) resistor r=176.904 //w=0.094 //l=0.345 //layer=ply \
 //thickness=0.18 //x=10.145 //y=1.09 //x2=10.145 //y2=1.435
r618 (  189 238 ) resistor r=45.1352 //w=0.168 //l=0.173853 //layer=ply \
 //thickness=0.18 //x=2.905 //y=1.43 //x2=2.865 //y2=1.585
r619 (  188 237 ) resistor r=45.1352 //w=0.168 //l=0.173853 //layer=ply \
 //thickness=0.18 //x=2.905 //y=1.085 //x2=2.865 //y2=0.93
r620 (  188 189 ) resistor r=176.904 //w=0.094 //l=0.345 //layer=ply \
 //thickness=0.18 //x=2.905 //y=1.085 //x2=2.905 //y2=1.43
r621 (  183 236 ) resistor r=10.701 //w=0.21 //l=0.115 //layer=ply \
 //thickness=0.18 //x=2.53 //y=1.585 //x2=2.415 //y2=1.585
r622 (  182 238 ) resistor r=5.52526 //w=0.168 //l=0.115 //layer=ply \
 //thickness=0.18 //x=2.75 //y=1.585 //x2=2.865 //y2=1.585
r623 (  181 235 ) resistor r=5.52526 //w=0.168 //l=0.115 //layer=ply \
 //thickness=0.18 //x=2.53 //y=0.93 //x2=2.415 //y2=0.93
r624 (  180 237 ) resistor r=5.52526 //w=0.168 //l=0.115 //layer=ply \
 //thickness=0.18 //x=2.75 //y=0.93 //x2=2.865 //y2=0.93
r625 (  180 181 ) resistor r=112.809 //w=0.094 //l=0.22 //layer=ply \
 //thickness=0.18 //x=2.75 //y=0.93 //x2=2.53 //y2=0.93
r626 (  179 233 ) resistor r=16.5046 //w=0.27 //l=0.135 //layer=ply \
 //thickness=0.18 //x=2.505 //y=4.97 //x2=2.37 //y2=4.97
r627 (  178 185 ) resistor r=26.9307 //w=0.15 //l=0.106066 //layer=ply \
 //thickness=0.18 //x=2.745 //y=4.97 //x2=2.82 //y2=5.045
r628 (  178 179 ) resistor r=123.064 //w=0.094 //l=0.24 //layer=ply \
 //thickness=0.18 //x=2.745 //y=4.97 //x2=2.505 //y2=4.97
r629 (  173 236 ) resistor r=39.5823 //w=0.21 //l=0.173853 //layer=ply \
 //thickness=0.18 //x=2.375 //y=1.74 //x2=2.415 //y2=1.585
r630 (  173 228 ) resistor r=182.032 //w=0.094 //l=0.355 //layer=ply \
 //thickness=0.18 //x=2.375 //y=1.74 //x2=2.375 //y2=2.095
r631 (  172 236 ) resistor r=39.5823 //w=0.21 //l=0.173853 //layer=ply \
 //thickness=0.18 //x=2.375 //y=1.43 //x2=2.415 //y2=1.585
r632 (  171 235 ) resistor r=45.1352 //w=0.168 //l=0.173853 //layer=ply \
 //thickness=0.18 //x=2.375 //y=1.085 //x2=2.415 //y2=0.93
r633 (  171 172 ) resistor r=176.904 //w=0.094 //l=0.345 //layer=ply \
 //thickness=0.18 //x=2.375 //y=1.085 //x2=2.375 //y2=1.43
r634 (  170 219 ) resistor r=592.245 //w=0.094 //l=1.155 //layer=ply \
 //thickness=0.18 //x=16.245 //y=6.2 //x2=16.245 //y2=5.045
r635 (  169 209 ) resistor r=592.245 //w=0.094 //l=1.155 //layer=ply \
 //thickness=0.18 //x=15.805 //y=6.2 //x2=15.805 //y2=5.045
r636 (  168 204 ) resistor r=592.245 //w=0.094 //l=1.155 //layer=ply \
 //thickness=0.18 //x=13.04 //y=6.2 //x2=13.04 //y2=5.045
r637 (  167 201 ) resistor r=592.245 //w=0.094 //l=1.155 //layer=ply \
 //thickness=0.18 //x=12.6 //y=6.2 //x2=12.6 //y2=5.045
r638 (  166 185 ) resistor r=592.245 //w=0.094 //l=1.155 //layer=ply \
 //thickness=0.18 //x=2.82 //y=6.2 //x2=2.82 //y2=5.045
r639 (  165 234 ) resistor r=592.245 //w=0.094 //l=1.155 //layer=ply \
 //thickness=0.18 //x=2.38 //y=6.2 //x2=2.38 //y2=5.045
r640 (  164 216 ) resistor r=56.4043 //w=0.094 //l=0.11 //layer=ply \
 //thickness=0.18 //x=16.025 //y=1.59 //x2=16.135 //y2=1.59
r641 (  164 217 ) resistor r=56.4043 //w=0.094 //l=0.11 //layer=ply \
 //thickness=0.18 //x=16.025 //y=1.59 //x2=15.915 //y2=1.59
r642 (  163 196 ) resistor r=56.4043 //w=0.094 //l=0.11 //layer=ply \
 //thickness=0.18 //x=10.41 //y=1.59 //x2=10.52 //y2=1.59
r643 (  163 197 ) resistor r=56.4043 //w=0.094 //l=0.11 //layer=ply \
 //thickness=0.18 //x=10.41 //y=1.59 //x2=10.3 //y2=1.59
r644 (  162 182 ) resistor r=56.4043 //w=0.094 //l=0.11 //layer=ply \
 //thickness=0.18 //x=2.64 //y=1.585 //x2=2.75 //y2=1.585
r645 (  162 183 ) resistor r=56.4043 //w=0.094 //l=0.11 //layer=ply \
 //thickness=0.18 //x=2.64 //y=1.585 //x2=2.53 //y2=1.585
r646 (  158 256 ) resistor r=152 //w=0.17 //l=0.17 //layer=licon //count=1 \
 //x=16.4 //y=4.88 //x2=16.4 //y2=4.88
r647 (  149 254 ) resistor r=152 //w=0.17 //l=0.17 //layer=licon //count=1 \
 //x=16.4 //y=2.265 //x2=16.4 //y2=2.265
r648 (  146 247 ) resistor r=152 //w=0.17 //l=0.17 //layer=licon //count=1 \
 //x=12.7 //y=4.88 //x2=12.7 //y2=4.88
r649 (  143 146 ) resistor r=17.7968 //w=0.187 //l=0.26 //layer=li \
 //thickness=0.1 //x=12.7 //y=4.62 //x2=12.7 //y2=4.88
r650 (  134 242 ) resistor r=152 //w=0.17 //l=0.17 //layer=licon //count=1 \
 //x=10.48 //y=2.265 //x2=10.48 //y2=2.265
r651 (  125 231 ) resistor r=152 //w=0.17 //l=0.17 //layer=licon //count=1 \
 //x=2.37 //y=4.88 //x2=2.37 //y2=4.88
r652 (  116 227 ) resistor r=152 //w=0.17 //l=0.17 //layer=licon //count=1 \
 //x=2.34 //y=2.26 //x2=2.34 //y2=2.26
r653 (  106 108 ) resistor r=0.10734 //w=0.281 //l=0.16 //layer=m2 \
 //thickness=0.36 //x=10.48 //y=3.155 //x2=10.64 //y2=3.155
r654 (  103 104 ) resistor r=0.00259336 //w=0.241 //l=0.005 //layer=m2 \
 //thickness=0.36 //x=10.105 //y=3.87 //x2=10.11 //y2=3.87
r655 (  99 101 ) resistor r=0.10734 //w=0.281 //l=0.16 //layer=m2 \
 //thickness=0.36 //x=2.345 //y=3.865 //x2=2.505 //y2=3.865
r656 (  97 110 ) resistor r=1.70827 //w=0.208 //l=2.85989 //layer=m2 \
 //thickness=0.36 //x=15.535 //y=4.655 //x2=12.7 //y2=4.705
r657 (  96 114 ) resistor r=0.244112 //w=0.3 //l=0.630476 //layer=m2 \
 //thickness=0.36 //x=15.88 //y=4.655 //x2=16.41 //y2=4.875
r658 (  96 97 ) resistor r=0.329198 //w=0.131 //l=0.345 //layer=m2 \
 //thickness=0.36 //x=15.88 //y=4.655 //x2=15.535 //y2=4.655
r659 (  94 112 ) resistor r=0.259285 //w=0.245 //l=0.499775 //layer=m2 \
 //thickness=0.36 //x=15.91 //y=3.11 //x2=16.395 //y2=3.14
r660 (  94 95 ) resistor r=0.410305 //w=0.131 //l=0.43 //layer=m2 \
 //thickness=0.36 //x=15.91 //y=3.11 //x2=15.48 //y2=3.11
r661 (  92 95 ) resistor r=0.125 //w=0.17 //l=0.184391 //layer=m2 \
 //thickness=0.36 //x=15.31 //y=3.14 //x2=15.48 //y2=3.11
r662 (  92 108 ) resistor r=4.45611 //w=0.131 //l=4.67 //layer=m2 \
 //thickness=0.36 //x=15.31 //y=3.14 //x2=10.64 //y2=3.14
r663 (  90 110 ) resistor r=0.100695 //w=0.208 //l=0.412311 //layer=m2 \
 //thickness=0.36 //x=12.54 //y=5.045 //x2=12.7 //y2=4.705
r664 (  90 91 ) resistor r=2.2376 //w=0.131 //l=2.345 //layer=m2 \
 //thickness=0.36 //x=12.54 //y=5.045 //x2=10.195 //y2=5.045
r665 (  89 91 ) resistor r=0.0698411 //w=0.17 //l=0.120208 //layer=m2 \
 //thickness=0.36 //x=10.11 //y=4.96 //x2=10.195 //y2=5.045
r666 (  88 104 ) resistor r=0.0284994 //w=0.241 //l=0.16 //layer=m2 \
 //thickness=0.36 //x=10.11 //y=4.03 //x2=10.11 //y2=3.87
r667 (  88 89 ) resistor r=0.887405 //w=0.131 //l=0.93 //layer=m2 \
 //thickness=0.36 //x=10.11 //y=4.03 //x2=10.11 //y2=4.96
r668 (  86 103 ) resistor r=0.28331 //w=0.241 //l=0.525 //layer=m2 \
 //thickness=0.36 //x=9.58 //y=3.87 //x2=10.105 //y2=3.87
r669 (  86 87 ) resistor r=0.410305 //w=0.131 //l=0.43 //layer=m2 \
 //thickness=0.36 //x=9.58 //y=3.87 //x2=9.15 //y2=3.87
r670 (  84 87 ) resistor r=0.125 //w=0.17 //l=0.174929 //layer=m2 \
 //thickness=0.36 //x=8.98 //y=3.88 //x2=9.15 //y2=3.87
r671 (  84 85 ) resistor r=1.65076 //w=0.131 //l=1.73 //layer=m2 \
 //thickness=0.36 //x=8.98 //y=3.88 //x2=7.25 //y2=3.88
r672 (  82 85 ) resistor r=0.1875 //w=0.17 //l=0.262393 //layer=m2 \
 //thickness=0.36 //x=6.995 //y=3.865 //x2=7.25 //y2=3.88
r673 (  82 83 ) resistor r=0.410305 //w=0.131 //l=0.43 //layer=m2 \
 //thickness=0.36 //x=6.995 //y=3.865 //x2=6.565 //y2=3.865
r674 (  80 83 ) resistor r=0.125 //w=0.17 //l=0.177341 //layer=m2 \
 //thickness=0.36 //x=6.395 //y=3.88 //x2=6.565 //y2=3.865
r675 (  80 81 ) resistor r=1.38836 //w=0.131 //l=1.455 //layer=m2 \
 //thickness=0.36 //x=6.395 //y=3.88 //x2=4.94 //y2=3.88
r676 (  78 81 ) resistor r=0.125 //w=0.17 //l=0.177341 //layer=m2 \
 //thickness=0.36 //x=4.77 //y=3.895 //x2=4.94 //y2=3.88
r677 (  78 79 ) resistor r=0.329198 //w=0.131 //l=0.345 //layer=m2 \
 //thickness=0.36 //x=4.77 //y=3.895 //x2=4.425 //y2=3.895
r678 (  76 79 ) resistor r=0.1875 //w=0.17 //l=0.262393 //layer=m2 \
 //thickness=0.36 //x=4.17 //y=3.88 //x2=4.425 //y2=3.895
r679 (  76 77 ) resistor r=0.67271 //w=0.131 //l=0.705 //layer=m2 \
 //thickness=0.36 //x=4.17 //y=3.88 //x2=3.465 //y2=3.88
r680 (  74 77 ) resistor r=0.125 //w=0.17 //l=0.177341 //layer=m2 \
 //thickness=0.36 //x=3.295 //y=3.895 //x2=3.465 //y2=3.88
r681 (  74 75 ) resistor r=0.329198 //w=0.131 //l=0.345 //layer=m2 \
 //thickness=0.36 //x=3.295 //y=3.895 //x2=2.95 //y2=3.895
r682 (  72 75 ) resistor r=0.1875 //w=0.17 //l=0.262393 //layer=m2 \
 //thickness=0.36 //x=2.695 //y=3.88 //x2=2.95 //y2=3.895
r683 (  72 101 ) resistor r=0.181298 //w=0.131 //l=0.19 //layer=m2 \
 //thickness=0.36 //x=2.695 //y=3.88 //x2=2.505 //y2=3.88
r684 (  70 149 ) resistor r=9.3 //w=0.17 //l=0.17 //layer=mcon //count=1 \
 //x=16.4 //y=2.265 //x2=16.4 //y2=2.265
r685 (  67 114 ) resistor r=4.5 //w=0.15 //l=0.15 //layer=via1 //count=1 \
 //x=16.41 //y=4.885 //x2=16.41 //y2=4.885
r686 (  64 158 ) resistor r=9.3 //w=0.17 //l=0.17 //layer=mcon //count=1 \
 //x=16.4 //y=4.88 //x2=16.4 //y2=4.88
r687 (  64 67 ) resistor r=0.0022242 //w=0.281 //l=0.005 //layer=m1 \
 //thickness=0.36 //x=16.41 //y=4.88 //x2=16.41 //y2=4.885
r688 (  64 65 ) resistor r=0.105116 //w=0.281 //l=0.155 //layer=m1 \
 //thickness=0.36 //x=16.41 //y=4.88 //x2=16.41 //y2=4.725
r689 (  59 110 ) resistor r=4.5 //w=0.15 //l=0.15 //layer=via1 //count=1 \
 //x=12.7 //y=4.71 //x2=12.7 //y2=4.71
r690 (  55 106 ) resistor r=4.5 //w=0.15 //l=0.15 //layer=via1 //count=1 \
 //x=10.48 //y=3.155 //x2=10.48 //y2=3.155
r691 (  51 134 ) resistor r=9.3 //w=0.17 //l=0.17 //layer=mcon //count=1 \
 //x=10.48 //y=2.265 //x2=10.48 //y2=2.265
r692 (  47 103 ) resistor r=4.5 //w=0.15 //l=0.15 //layer=via1 //count=1 \
 //x=10.105 //y=3.87 //x2=10.105 //y2=3.87
r693 (  43 99 ) resistor r=4.5 //w=0.15 //l=0.15 //layer=via1 //count=1 \
 //x=2.345 //y=3.865 //x2=2.345 //y2=3.865
r694 (  41 125 ) resistor r=9.3 //w=0.17 //l=0.17 //layer=mcon //count=1 \
 //x=2.37 //y=4.88 //x2=2.37 //y2=4.88
r695 (  37 116 ) resistor r=9.3 //w=0.17 //l=0.17 //layer=mcon //count=1 \
 //x=2.34 //y=2.26 //x2=2.34 //y2=2.26
r696 (  37 39 ) resistor r=0.0936408 //w=0.196 //l=0.125 //layer=m1 \
 //thickness=0.36 //x=2.342 //y=2.26 //x2=2.342 //y2=2.385
r697 (  27 70 ) resistor r=0.116051 //w=0.211 //l=0.165 //layer=m1 \
 //thickness=0.36 //x=16.4 //y=2.43 //x2=16.4 //y2=2.265
r698 (  25 51 ) resistor r=0.0891709 //w=0.238 //l=0.151493 //layer=m1 \
 //thickness=0.36 //x=10.48 //y=2.415 //x2=10.477 //y2=2.265
r699 (  25 26 ) resistor r=0.553435 //w=0.131 //l=0.58 //layer=m1 \
 //thickness=0.36 //x=10.48 //y=2.415 //x2=10.48 //y2=2.995
r700 (  21 41 ) resistor r=0.0878548 //w=0.228 //l=0.159295 //layer=m1 \
 //thickness=0.36 //x=2.34 //y=4.735 //x2=2.37 //y2=4.88
r701 (  16 43 ) resistor r=0.0910802 //w=0.374 //l=0.185472 //layer=m1 \
 //thickness=0.36 //x=2.34 //y=3.705 //x2=2.395 //y2=3.865
r702 (  14 112 ) resistor r=4.5 //w=0.15 //l=0.15 //layer=via1 //count=1 \
 //x=16.395 //y=3.14 //x2=16.395 //y2=3.14
r703 (  14 30 ) resistor r=0.0910802 //w=0.374 //l=0.185472 //layer=m1 \
 //thickness=0.36 //x=16.345 //y=3.14 //x2=16.4 //y2=3.3
r704 (  14 28 ) resistor r=0.0910802 //w=0.374 //l=0.185472 //layer=m1 \
 //thickness=0.36 //x=16.345 //y=3.14 //x2=16.4 //y2=2.98
r705 (  13 143 ) resistor r=9.3 //w=0.17 //l=0.17 //layer=mcon //count=1 \
 //x=12.7 //y=4.62 //x2=12.7 //y2=4.62
r706 (  13 59 ) resistor r=0.0317797 //w=0.354 //l=0.09 //layer=m1 \
 //thickness=0.36 //x=12.752 //y=4.62 //x2=12.752 //y2=4.71
r707 (  12 55 ) resistor r=0.0049867 //w=0.376 //l=0.015 //layer=m1 \
 //thickness=0.36 //x=10.532 //y=3.14 //x2=10.532 //y2=3.155
r708 (  12 26 ) resistor r=0.0861726 //w=0.376 //l=0.169012 //layer=m1 \
 //thickness=0.36 //x=10.532 //y=3.14 //x2=10.48 //y2=2.995
r709 (  11 47 ) resistor r=0.00334225 //w=0.374 //l=0.01 //layer=m1 \
 //thickness=0.36 //x=10.055 //y=3.88 //x2=10.055 //y2=3.87
r710 (  10 20 ) resistor r=0.0860668 //w=0.374 //l=0.170294 //layer=m1 \
 //thickness=0.36 //x=2.395 //y=3.88 //x2=2.34 //y2=4.025
r711 (  10 43 ) resistor r=0.00501337 //w=0.374 //l=0.015 //layer=m1 \
 //thickness=0.36 //x=2.395 //y=3.88 //x2=2.395 //y2=3.865
r712 (  9 65 ) resistor r=0.100191 //w=0.131 //l=0.105 //layer=m1 \
 //thickness=0.36 //x=16.4 //y=4.62 //x2=16.4 //y2=4.725
r713 (  8 9 ) resistor r=0.353053 //w=0.131 //l=0.37 //layer=m1 \
 //thickness=0.36 //x=16.4 //y=4.25 //x2=16.4 //y2=4.62
r714 (  7 8 ) resistor r=0.353053 //w=0.131 //l=0.37 //layer=m1 \
 //thickness=0.36 //x=16.4 //y=3.88 //x2=16.4 //y2=4.25
r715 (  6 7 ) resistor r=0.353053 //w=0.131 //l=0.37 //layer=m1 \
 //thickness=0.36 //x=16.4 //y=3.51 //x2=16.4 //y2=3.88
r716 (  6 30 ) resistor r=0.200382 //w=0.131 //l=0.21 //layer=m1 \
 //thickness=0.36 //x=16.4 //y=3.51 //x2=16.4 //y2=3.3
r717 (  5 28 ) resistor r=0.200382 //w=0.131 //l=0.21 //layer=m1 \
 //thickness=0.36 //x=16.4 //y=2.77 //x2=16.4 //y2=2.98
r718 (  5 27 ) resistor r=0.324427 //w=0.131 //l=0.34 //layer=m1 \
 //thickness=0.36 //x=16.4 //y=2.77 //x2=16.4 //y2=2.43
r719 (  4 21 ) resistor r=0.109733 //w=0.131 //l=0.115 //layer=m1 \
 //thickness=0.36 //x=2.34 //y=4.62 //x2=2.34 //y2=4.735
r720 (  4 20 ) resistor r=0.567748 //w=0.131 //l=0.595 //layer=m1 \
 //thickness=0.36 //x=2.34 //y=4.62 //x2=2.34 //y2=4.025
r721 (  3 16 ) resistor r=0.186069 //w=0.131 //l=0.195 //layer=m1 \
 //thickness=0.36 //x=2.34 //y=3.51 //x2=2.34 //y2=3.705
r722 (  2 3 ) resistor r=0.353053 //w=0.131 //l=0.37 //layer=m1 \
 //thickness=0.36 //x=2.34 //y=3.14 //x2=2.34 //y2=3.51
r723 (  1 2 ) resistor r=0.353053 //w=0.131 //l=0.37 //layer=m1 \
 //thickness=0.36 //x=2.34 //y=2.77 //x2=2.34 //y2=3.14
r724 (  1 39 ) resistor r=0.367366 //w=0.131 //l=0.385 //layer=m1 \
 //thickness=0.36 //x=2.34 //y=2.77 //x2=2.34 //y2=2.385
ends PM_HA\%B

subckt PM_HA\%VDD ( 1 2 19 20 21 29 30 37 71 79 105 133 147 163 189 204 207 \
 210 214 215 216 219 220 221 222 223 224 225 226 227 228 229 230 )
c354 ( 230 0 ) capacitor c=0.0599797f //x=16.32 //y=5.2
c355 ( 229 0 ) capacitor c=0.0577654f //x=15.46 //y=5.2
c356 ( 228 0 ) capacitor c=0.0170134f //x=12.675 //y=5.2
c357 ( 227 0 ) capacitor c=0.0170965f //x=9.345 //y=5.2
c358 ( 226 0 ) capacitor c=0.0586397f //x=7.45 //y=5.2
c359 ( 225 0 ) capacitor c=0.0527218f //x=6.58 //y=5.2
c360 ( 224 0 ) capacitor c=0.054526f //x=5.23 //y=5.2
c361 ( 223 0 ) capacitor c=0.0579246f //x=4.36 //y=5.2
c362 ( 222 0 ) capacitor c=0.039544f //x=2.895 //y=5.2
c363 ( 221 0 ) capacitor c=0.0248174f //x=2.015 //y=5.2
c364 ( 220 0 ) capacitor c=0.0678368f //x=1.145 //y=5.2
c365 ( 219 0 ) capacitor c=0.257651f //x=16.4 //y=7.58
c366 ( 217 0 ) capacitor c=0.00597439f //x=15.585 //y=7.585
c367 ( 216 0 ) capacitor c=0.118169f //x=14.92 //y=7.585
c368 ( 215 0 ) capacitor c=0.120275f //x=11.59 //y=7.585
c369 ( 214 0 ) capacitor c=0.121601f //x=8.26 //y=7.585
c370 ( 213 0 ) capacitor c=0.00597439f //x=7.52 //y=7.58
c371 ( 211 0 ) capacitor c=0.00597439f //x=6.715 //y=7.585
c372 ( 210 0 ) capacitor c=0.117318f //x=6.04 //y=7.585
c373 ( 209 0 ) capacitor c=0.00597439f //x=5.375 //y=7.585
c374 ( 208 0 ) capacitor c=0.00597439f //x=4.495 //y=7.585
c375 ( 207 0 ) capacitor c=0.120898f //x=3.82 //y=7.585
c376 ( 206 0 ) capacitor c=0.00597439f //x=3.04 //y=7.585
c377 ( 205 0 ) capacitor c=0.00597439f //x=2.16 //y=7.585
c378 ( 204 0 ) capacitor c=0.270723f //x=1.23 //y=7.58
c379 ( 189 0 ) capacitor c=0.0290691f //x=16.38 //y=7.585
c380 ( 177 0 ) capacitor c=0.0208042f //x=15.5 //y=7.585
c381 ( 163 0 ) capacitor c=0.139862f //x=14.75 //y=7.585
c382 ( 147 0 ) capacitor c=0.139013f //x=11.42 //y=7.585
c383 ( 143 0 ) capacitor c=0.0211939f //x=8.09 //y=7.585
c384 ( 133 0 ) capacitor c=0.0287132f //x=7.51 //y=7.585
c385 ( 121 0 ) capacitor c=0.0217664f //x=6.63 //y=7.585
c386 ( 117 0 ) capacitor c=0.0211939f //x=5.87 //y=7.585
c387 ( 105 0 ) capacitor c=0.0289924f //x=5.29 //y=7.585
c388 ( 95 0 ) capacitor c=0.0217664f //x=4.41 //y=7.585
c389 ( 89 0 ) capacitor c=0.0277785f //x=3.65 //y=7.585
c390 ( 79 0 ) capacitor c=0.0287375f //x=2.955 //y=7.585
c391 ( 71 0 ) capacitor c=0.0292095f //x=2.075 //y=7.585
c392 ( 52 0 ) capacitor c=0.00510714f //x=12.82 //y=7.585
c393 ( 49 0 ) capacitor c=0.00510714f //x=9.49 //y=7.585
c394 ( 37 0 ) capacitor c=0.181594f //x=16.4 //y=7.58
c395 ( 30 0 ) capacitor c=0.0147928f //x=12.82 //y=7.41
c396 ( 29 0 ) capacitor c=0.0127167f //x=12.82 //y=6.69
c397 ( 21 0 ) capacitor c=0.110467f //x=12.735 //y=7.585
c398 ( 20 0 ) capacitor c=0.0153981f //x=9.49 //y=7.41
c399 ( 19 0 ) capacitor c=0.013349f //x=9.49 //y=6.7
c400 ( 2 0 ) capacitor c=0.354486f //x=9.405 //y=7.585
r401 (  191 219 ) resistor r=4.23183 //w=0.7 //l=0.175 //layer=li \
 //thickness=0.1 //x=16.465 //y=7.41 //x2=16.465 //y2=7.585
r402 (  191 230 ) resistor r=56.4706 //w=0.187 //l=0.825 //layer=li \
 //thickness=0.1 //x=16.465 //y=7.41 //x2=16.465 //y2=6.585
r403 (  190 217 ) resistor r=2.87058 //w=0.35 //l=0.085 //layer=li \
 //thickness=0.1 //x=15.67 //y=7.585 //x2=15.585 //y2=7.585
r404 (  189 219 ) resistor r=2.87058 //w=0.35 //l=0.085 //layer=li \
 //thickness=0.1 //x=16.38 //y=7.585 //x2=16.465 //y2=7.585
r405 (  189 190 ) resistor r=24.7629 //w=0.367 //l=0.71 //layer=li \
 //thickness=0.1 //x=16.38 //y=7.585 //x2=15.67 //y2=7.585
r406 (  181 217 ) resistor r=4.23183 //w=0.7 //l=0.175 //layer=li \
 //thickness=0.1 //x=15.585 //y=7.41 //x2=15.585 //y2=7.585
r407 (  181 229 ) resistor r=56.4706 //w=0.187 //l=0.825 //layer=li \
 //thickness=0.1 //x=15.585 //y=7.41 //x2=15.585 //y2=6.585
r408 (  178 216 ) resistor r=5.29055 //w=0.35 //l=0.17 //layer=li \
 //thickness=0.1 //x=15.09 //y=7.585 //x2=14.92 //y2=7.585
r409 (  178 180 ) resistor r=6.97548 //w=0.367 //l=0.2 //layer=li \
 //thickness=0.1 //x=15.09 //y=7.585 //x2=15.29 //y2=7.585
r410 (  177 217 ) resistor r=2.87058 //w=0.35 //l=0.085 //layer=li \
 //thickness=0.1 //x=15.5 //y=7.585 //x2=15.585 //y2=7.585
r411 (  177 180 ) resistor r=7.32425 //w=0.367 //l=0.21 //layer=li \
 //thickness=0.1 //x=15.5 //y=7.585 //x2=15.29 //y2=7.585
r412 (  173 228 ) resistor r=23.2727 //w=0.187 //l=0.34 //layer=li \
 //thickness=0.1 //x=12.82 //y=6.575 //x2=12.82 //y2=6.235
r413 (  166 168 ) resistor r=38.7139 //w=0.367 //l=1.11 //layer=li \
 //thickness=0.1 //x=12.7 //y=7.585 //x2=13.81 //y2=7.585
r414 (  164 215 ) resistor r=5.29055 //w=0.35 //l=0.17 //layer=li \
 //thickness=0.1 //x=11.76 //y=7.585 //x2=11.59 //y2=7.585
r415 (  164 166 ) resistor r=32.7847 //w=0.367 //l=0.94 //layer=li \
 //thickness=0.1 //x=11.76 //y=7.585 //x2=12.7 //y2=7.585
r416 (  163 216 ) resistor r=5.29055 //w=0.35 //l=0.17 //layer=li \
 //thickness=0.1 //x=14.75 //y=7.585 //x2=14.92 //y2=7.585
r417 (  163 168 ) resistor r=32.7847 //w=0.367 //l=0.94 //layer=li \
 //thickness=0.1 //x=14.75 //y=7.585 //x2=13.81 //y2=7.585
r418 (  159 227 ) resistor r=23.2727 //w=0.187 //l=0.34 //layer=li \
 //thickness=0.1 //x=9.49 //y=6.575 //x2=9.49 //y2=6.235
r419 (  152 154 ) resistor r=38.7139 //w=0.367 //l=1.11 //layer=li \
 //thickness=0.1 //x=10.11 //y=7.585 //x2=11.22 //y2=7.585
r420 (  150 152 ) resistor r=38.7139 //w=0.367 //l=1.11 //layer=li \
 //thickness=0.1 //x=9 //y=7.585 //x2=10.11 //y2=7.585
r421 (  148 214 ) resistor r=5.29055 //w=0.35 //l=0.17 //layer=li \
 //thickness=0.1 //x=8.43 //y=7.585 //x2=8.26 //y2=7.585
r422 (  148 150 ) resistor r=19.8801 //w=0.367 //l=0.57 //layer=li \
 //thickness=0.1 //x=8.43 //y=7.585 //x2=9 //y2=7.585
r423 (  147 215 ) resistor r=5.29055 //w=0.35 //l=0.17 //layer=li \
 //thickness=0.1 //x=11.42 //y=7.585 //x2=11.59 //y2=7.585
r424 (  147 154 ) resistor r=6.97548 //w=0.367 //l=0.2 //layer=li \
 //thickness=0.1 //x=11.42 //y=7.585 //x2=11.22 //y2=7.585
r425 (  144 213 ) resistor r=2.87058 //w=0.35 //l=0.085 //layer=li \
 //thickness=0.1 //x=7.68 //y=7.585 //x2=7.595 //y2=7.585
r426 (  143 214 ) resistor r=5.29055 //w=0.35 //l=0.17 //layer=li \
 //thickness=0.1 //x=8.09 //y=7.585 //x2=8.26 //y2=7.585
r427 (  143 144 ) resistor r=14.2997 //w=0.367 //l=0.41 //layer=li \
 //thickness=0.1 //x=8.09 //y=7.585 //x2=7.68 //y2=7.585
r428 (  135 213 ) resistor r=4.23183 //w=0.7 //l=0.175 //layer=li \
 //thickness=0.1 //x=7.595 //y=7.41 //x2=7.595 //y2=7.585
r429 (  135 226 ) resistor r=56.4706 //w=0.187 //l=0.825 //layer=li \
 //thickness=0.1 //x=7.595 //y=7.41 //x2=7.595 //y2=6.585
r430 (  134 211 ) resistor r=2.87058 //w=0.35 //l=0.085 //layer=li \
 //thickness=0.1 //x=6.8 //y=7.585 //x2=6.715 //y2=7.585
r431 (  133 213 ) resistor r=2.87058 //w=0.35 //l=0.085 //layer=li \
 //thickness=0.1 //x=7.51 //y=7.585 //x2=7.595 //y2=7.585
r432 (  133 134 ) resistor r=24.7629 //w=0.367 //l=0.71 //layer=li \
 //thickness=0.1 //x=7.51 //y=7.585 //x2=6.8 //y2=7.585
r433 (  125 211 ) resistor r=4.23183 //w=0.7 //l=0.175 //layer=li \
 //thickness=0.1 //x=6.715 //y=7.41 //x2=6.715 //y2=7.585
r434 (  125 225 ) resistor r=56.4706 //w=0.187 //l=0.825 //layer=li \
 //thickness=0.1 //x=6.715 //y=7.41 //x2=6.715 //y2=6.585
r435 (  122 210 ) resistor r=5.29055 //w=0.35 //l=0.17 //layer=li \
 //thickness=0.1 //x=6.21 //y=7.585 //x2=6.04 //y2=7.585
r436 (  122 124 ) resistor r=6.97548 //w=0.367 //l=0.2 //layer=li \
 //thickness=0.1 //x=6.21 //y=7.585 //x2=6.41 //y2=7.585
r437 (  121 211 ) resistor r=2.87058 //w=0.35 //l=0.085 //layer=li \
 //thickness=0.1 //x=6.63 //y=7.585 //x2=6.715 //y2=7.585
r438 (  121 124 ) resistor r=7.67302 //w=0.367 //l=0.22 //layer=li \
 //thickness=0.1 //x=6.63 //y=7.585 //x2=6.41 //y2=7.585
r439 (  118 209 ) resistor r=2.87058 //w=0.35 //l=0.085 //layer=li \
 //thickness=0.1 //x=5.46 //y=7.585 //x2=5.375 //y2=7.585
r440 (  117 210 ) resistor r=5.29055 //w=0.35 //l=0.17 //layer=li \
 //thickness=0.1 //x=5.87 //y=7.585 //x2=6.04 //y2=7.585
r441 (  117 118 ) resistor r=14.2997 //w=0.367 //l=0.41 //layer=li \
 //thickness=0.1 //x=5.87 //y=7.585 //x2=5.46 //y2=7.585
r442 (  109 209 ) resistor r=4.23183 //w=0.7 //l=0.175 //layer=li \
 //thickness=0.1 //x=5.375 //y=7.41 //x2=5.375 //y2=7.585
r443 (  109 224 ) resistor r=56.4706 //w=0.187 //l=0.825 //layer=li \
 //thickness=0.1 //x=5.375 //y=7.41 //x2=5.375 //y2=6.585
r444 (  106 208 ) resistor r=2.87058 //w=0.35 //l=0.085 //layer=li \
 //thickness=0.1 //x=4.58 //y=7.585 //x2=4.495 //y2=7.585
r445 (  106 108 ) resistor r=12.2071 //w=0.367 //l=0.35 //layer=li \
 //thickness=0.1 //x=4.58 //y=7.585 //x2=4.93 //y2=7.585
r446 (  105 209 ) resistor r=2.87058 //w=0.35 //l=0.085 //layer=li \
 //thickness=0.1 //x=5.29 //y=7.585 //x2=5.375 //y2=7.585
r447 (  105 108 ) resistor r=12.5559 //w=0.367 //l=0.36 //layer=li \
 //thickness=0.1 //x=5.29 //y=7.585 //x2=4.93 //y2=7.585
r448 (  97 208 ) resistor r=4.23183 //w=0.7 //l=0.175 //layer=li \
 //thickness=0.1 //x=4.495 //y=7.41 //x2=4.495 //y2=7.585
r449 (  97 223 ) resistor r=56.4706 //w=0.187 //l=0.825 //layer=li \
 //thickness=0.1 //x=4.495 //y=7.41 //x2=4.495 //y2=6.585
r450 (  96 207 ) resistor r=5.29055 //w=0.35 //l=0.17 //layer=li \
 //thickness=0.1 //x=3.99 //y=7.585 //x2=3.82 //y2=7.585
r451 (  95 208 ) resistor r=2.87058 //w=0.35 //l=0.085 //layer=li \
 //thickness=0.1 //x=4.41 //y=7.585 //x2=4.495 //y2=7.585
r452 (  95 96 ) resistor r=14.6485 //w=0.367 //l=0.42 //layer=li \
 //thickness=0.1 //x=4.41 //y=7.585 //x2=3.99 //y2=7.585
r453 (  90 206 ) resistor r=2.87058 //w=0.35 //l=0.085 //layer=li \
 //thickness=0.1 //x=3.125 //y=7.585 //x2=3.04 //y2=7.585
r454 (  90 92 ) resistor r=11.3351 //w=0.367 //l=0.325 //layer=li \
 //thickness=0.1 //x=3.125 //y=7.585 //x2=3.45 //y2=7.585
r455 (  89 207 ) resistor r=5.29055 //w=0.35 //l=0.17 //layer=li \
 //thickness=0.1 //x=3.65 //y=7.585 //x2=3.82 //y2=7.585
r456 (  89 92 ) resistor r=6.97548 //w=0.367 //l=0.2 //layer=li \
 //thickness=0.1 //x=3.65 //y=7.585 //x2=3.45 //y2=7.585
r457 (  83 206 ) resistor r=4.23183 //w=0.7 //l=0.175 //layer=li \
 //thickness=0.1 //x=3.04 //y=7.41 //x2=3.04 //y2=7.585
r458 (  83 222 ) resistor r=33.1979 //w=0.187 //l=0.485 //layer=li \
 //thickness=0.1 //x=3.04 //y=7.41 //x2=3.04 //y2=6.925
r459 (  80 205 ) resistor r=2.87058 //w=0.35 //l=0.085 //layer=li \
 //thickness=0.1 //x=2.245 //y=7.585 //x2=2.16 //y2=7.585
r460 (  80 82 ) resistor r=3.31335 //w=0.367 //l=0.095 //layer=li \
 //thickness=0.1 //x=2.245 //y=7.585 //x2=2.34 //y2=7.585
r461 (  79 206 ) resistor r=2.87058 //w=0.35 //l=0.085 //layer=li \
 //thickness=0.1 //x=2.955 //y=7.585 //x2=3.04 //y2=7.585
r462 (  79 82 ) resistor r=21.4496 //w=0.367 //l=0.615 //layer=li \
 //thickness=0.1 //x=2.955 //y=7.585 //x2=2.34 //y2=7.585
r463 (  73 205 ) resistor r=4.23183 //w=0.7 //l=0.175 //layer=li \
 //thickness=0.1 //x=2.16 //y=7.41 //x2=2.16 //y2=7.585
r464 (  73 221 ) resistor r=33.1979 //w=0.187 //l=0.485 //layer=li \
 //thickness=0.1 //x=2.16 //y=7.41 //x2=2.16 //y2=6.925
r465 (  72 204 ) resistor r=2.87058 //w=0.35 //l=0.085 //layer=li \
 //thickness=0.1 //x=1.365 //y=7.585 //x2=1.28 //y2=7.585
r466 (  71 205 ) resistor r=2.87058 //w=0.35 //l=0.085 //layer=li \
 //thickness=0.1 //x=2.075 //y=7.585 //x2=2.16 //y2=7.585
r467 (  71 72 ) resistor r=24.7629 //w=0.367 //l=0.71 //layer=li \
 //thickness=0.1 //x=2.075 //y=7.585 //x2=1.365 //y2=7.585
r468 (  63 204 ) resistor r=4.23183 //w=0.7 //l=0.175 //layer=li \
 //thickness=0.1 //x=1.28 //y=7.41 //x2=1.28 //y2=7.585
r469 (  63 220 ) resistor r=56.4706 //w=0.187 //l=0.825 //layer=li \
 //thickness=0.1 //x=1.28 //y=7.41 //x2=1.28 //y2=6.585
r470 (  54 173 ) resistor r=9.3 //w=0.17 //l=0.17 //layer=mcon //count=1 \
 //x=12.82 //y=6.575 //x2=12.82 //y2=6.575
r471 (  51 159 ) resistor r=9.3 //w=0.17 //l=0.17 //layer=mcon //count=1 \
 //x=9.49 //y=6.575 //x2=9.49 //y2=6.575
r472 (  37 219 ) resistor r=3.1 //w=0.17 //l=0.51 //layer=mcon //count=3 \
 //x=16.4 //y=7.58 //x2=16.4 //y2=7.58
r473 (  35 180 ) resistor r=3.1 //w=0.17 //l=0.51 //layer=mcon //count=3 \
 //x=15.29 //y=7.58 //x2=15.29 //y2=7.58
r474 (  35 37 ) resistor r=0.446141 //w=0.311 //l=1.11 //layer=m1 \
 //thickness=0.36 //x=15.29 //y=7.585 //x2=16.4 //y2=7.585
r475 (  33 168 ) resistor r=3.1 //w=0.17 //l=0.51 //layer=mcon //count=3 \
 //x=13.81 //y=7.58 //x2=13.81 //y2=7.58
r476 (  33 35 ) resistor r=0.594855 //w=0.311 //l=1.48 //layer=m1 \
 //thickness=0.36 //x=13.81 //y=7.585 //x2=15.29 //y2=7.585
r477 (  31 52 ) resistor r=0.028033 //w=0.35 //l=0.085 //layer=m1 \
 //thickness=0.36 //x=12.905 //y=7.585 //x2=12.82 //y2=7.585
r478 (  31 33 ) resistor r=0.363746 //w=0.311 //l=0.905 //layer=m1 \
 //thickness=0.36 //x=12.905 //y=7.585 //x2=13.81 //y2=7.585
r479 (  30 52 ) resistor r=0.0413265 //w=0.7 //l=0.175 //layer=m1 \
 //thickness=0.36 //x=12.82 //y=7.41 //x2=12.82 //y2=7.585
r480 (  29 54 ) resistor r=0.0717383 //w=0.224 //l=0.115 //layer=m1 \
 //thickness=0.36 //x=12.82 //y=6.69 //x2=12.82 //y2=6.575
r481 (  29 30 ) resistor r=0.687023 //w=0.131 //l=0.72 //layer=m1 \
 //thickness=0.36 //x=12.82 //y=6.69 //x2=12.82 //y2=7.41
r482 (  28 166 ) resistor r=3.1 //w=0.17 //l=0.51 //layer=mcon //count=3 \
 //x=12.7 //y=7.58 //x2=12.7 //y2=7.58
r483 (  26 154 ) resistor r=3.1 //w=0.17 //l=0.51 //layer=mcon //count=3 \
 //x=11.22 //y=7.58 //x2=11.22 //y2=7.58
r484 (  26 28 ) resistor r=0.594855 //w=0.311 //l=1.48 //layer=m1 \
 //thickness=0.36 //x=11.22 //y=7.585 //x2=12.7 //y2=7.585
r485 (  24 152 ) resistor r=3.1 //w=0.17 //l=0.51 //layer=mcon //count=3 \
 //x=10.11 //y=7.58 //x2=10.11 //y2=7.58
r486 (  24 26 ) resistor r=0.446141 //w=0.311 //l=1.11 //layer=m1 \
 //thickness=0.36 //x=10.11 //y=7.585 //x2=11.22 //y2=7.585
r487 (  22 49 ) resistor r=0.028033 //w=0.35 //l=0.085 //layer=m1 \
 //thickness=0.36 //x=9.575 //y=7.585 //x2=9.49 //y2=7.585
r488 (  22 24 ) resistor r=0.215032 //w=0.311 //l=0.535 //layer=m1 \
 //thickness=0.36 //x=9.575 //y=7.585 //x2=10.11 //y2=7.585
r489 (  21 52 ) resistor r=0.028033 //w=0.35 //l=0.085 //layer=m1 \
 //thickness=0.36 //x=12.735 //y=7.585 //x2=12.82 //y2=7.585
r490 (  21 28 ) resistor r=0.0140675 //w=0.311 //l=0.035 //layer=m1 \
 //thickness=0.36 //x=12.735 //y=7.585 //x2=12.7 //y2=7.585
r491 (  20 49 ) resistor r=0.0413265 //w=0.7 //l=0.175 //layer=m1 \
 //thickness=0.36 //x=9.49 //y=7.41 //x2=9.49 //y2=7.585
r492 (  19 51 ) resistor r=0.0773187 //w=0.224 //l=0.125 //layer=m1 \
 //thickness=0.36 //x=9.49 //y=6.7 //x2=9.49 //y2=6.575
r493 (  19 20 ) resistor r=0.677481 //w=0.131 //l=0.71 //layer=m1 \
 //thickness=0.36 //x=9.49 //y=6.7 //x2=9.49 //y2=7.41
r494 (  18 150 ) resistor r=3.1 //w=0.17 //l=0.51 //layer=mcon //count=3 //x=9 \
 //y=7.58 //x2=9 //y2=7.58
r495 (  15 213 ) resistor r=3.1 //w=0.17 //l=0.51 //layer=mcon //count=3 \
 //x=7.52 //y=7.58 //x2=7.52 //y2=7.58
r496 (  13 124 ) resistor r=3.1 //w=0.17 //l=0.51 //layer=mcon //count=3 \
 //x=6.41 //y=7.58 //x2=6.41 //y2=7.58
r497 (  13 15 ) resistor r=0.446141 //w=0.311 //l=1.11 //layer=m1 \
 //thickness=0.36 //x=6.41 //y=7.585 //x2=7.52 //y2=7.585
r498 (  11 108 ) resistor r=3.1 //w=0.17 //l=0.51 //layer=mcon //count=3 \
 //x=4.93 //y=7.58 //x2=4.93 //y2=7.58
r499 (  11 13 ) resistor r=0.594855 //w=0.311 //l=1.48 //layer=m1 \
 //thickness=0.36 //x=4.93 //y=7.585 //x2=6.41 //y2=7.585
r500 (  9 92 ) resistor r=3.1 //w=0.17 //l=0.51 //layer=mcon //count=3 \
 //x=3.45 //y=7.58 //x2=3.45 //y2=7.58
r501 (  9 11 ) resistor r=0.594855 //w=0.311 //l=1.48 //layer=m1 \
 //thickness=0.36 //x=3.45 //y=7.585 //x2=4.93 //y2=7.585
r502 (  7 82 ) resistor r=3.1 //w=0.17 //l=0.51 //layer=mcon //count=3 \
 //x=2.34 //y=7.58 //x2=2.34 //y2=7.58
r503 (  7 9 ) resistor r=0.446141 //w=0.311 //l=1.11 //layer=m1 \
 //thickness=0.36 //x=2.34 //y=7.585 //x2=3.45 //y2=7.585
r504 (  4 204 ) resistor r=3.1 //w=0.17 //l=0.51 //layer=mcon //count=3 \
 //x=1.23 //y=7.58 //x2=1.23 //y2=7.58
r505 (  4 7 ) resistor r=0.446141 //w=0.311 //l=1.11 //layer=m1 \
 //thickness=0.36 //x=1.23 //y=7.585 //x2=2.34 //y2=7.585
r506 (  2 49 ) resistor r=0.028033 //w=0.35 //l=0.085 //layer=m1 \
 //thickness=0.36 //x=9.405 //y=7.585 //x2=9.49 //y2=7.585
r507 (  2 18 ) resistor r=0.162781 //w=0.311 //l=0.405 //layer=m1 \
 //thickness=0.36 //x=9.405 //y=7.585 //x2=9 //y2=7.585
r508 (  1 18 ) resistor r=0.0743569 //w=0.311 //l=0.185 //layer=m1 \
 //thickness=0.36 //x=8.815 //y=7.585 //x2=9 //y2=7.585
r509 (  1 15 ) resistor r=0.520498 //w=0.311 //l=1.295 //layer=m1 \
 //thickness=0.36 //x=8.815 //y=7.585 //x2=7.52 //y2=7.585
ends PM_HA\%VDD

subckt PM_HA\%COUT ( 1 2 3 4 5 7 9 10 11 12 13 22 32 39 41 )
c101 ( 39 0 ) capacitor c=0.00869746f //x=4.745 //y=1.09
c102 ( 32 0 ) capacitor c=0.0262395f //x=4.935 //y=5.56
c103 ( 22 0 ) capacitor c=0.0151699f //x=4.93 //y=1.185
c104 ( 13 0 ) capacitor c=0.00475217f //x=5.02 //y=5.14
c105 ( 12 0 ) capacitor c=0.00735359f //x=5.215 //y=5.14
c106 ( 11 0 ) capacitor c=0.00704518f //x=5.015 //y=2.02
c107 ( 10 0 ) capacitor c=0.0126502f //x=5.215 //y=2.02
c108 ( 9 0 ) capacitor c=0.0105345f //x=4.935 //y=5.42
c109 ( 7 0 ) capacitor c=0.0108534f //x=4.93 //y=1.935
c110 ( 1 0 ) capacitor c=0.0678507f //x=5.3 //y=2.4
r111 (  32 41 ) resistor r=23.615 //w=0.187 //l=0.345 //layer=li \
 //thickness=0.1 //x=4.935 //y=5.56 //x2=4.935 //y2=5.905
r112 (  25 32 ) resistor r=9.3 //w=0.17 //l=0.17 //layer=mcon //count=1 \
 //x=4.935 //y=5.56 //x2=4.935 //y2=5.56
r113 (  22 39 ) resistor r=9.3 //w=0.17 //l=0.17 //layer=mcon //count=1 \
 //x=4.93 //y=1.185 //x2=4.93 //y2=1.185
r114 (  12 15 ) resistor r=0.0698411 //w=0.17 //l=0.120208 //layer=m1 \
 //thickness=0.36 //x=5.215 //y=5.14 //x2=5.3 //y2=5.055
r115 (  12 13 ) resistor r=0.186069 //w=0.131 //l=0.195 //layer=m1 \
 //thickness=0.36 //x=5.215 //y=5.14 //x2=5.02 //y2=5.14
r116 (  10 14 ) resistor r=0.0698411 //w=0.17 //l=0.120208 //layer=m1 \
 //thickness=0.36 //x=5.215 //y=2.02 //x2=5.3 //y2=2.105
r117 (  10 11 ) resistor r=0.19084 //w=0.131 //l=0.2 //layer=m1 \
 //thickness=0.36 //x=5.215 //y=2.02 //x2=5.015 //y2=2.02
r118 (  9 25 ) resistor r=0.086672 //w=0.218 //l=0.14 //layer=m1 \
 //thickness=0.36 //x=4.935 //y=5.42 //x2=4.935 //y2=5.56
r119 (  8 13 ) resistor r=0.0698411 //w=0.17 //l=0.120208 //layer=m1 \
 //thickness=0.36 //x=4.935 //y=5.225 //x2=5.02 //y2=5.14
r120 (  8 9 ) resistor r=0.186069 //w=0.131 //l=0.195 //layer=m1 \
 //thickness=0.36 //x=4.935 //y=5.225 //x2=4.935 //y2=5.42
r121 (  7 11 ) resistor r=0.0698411 //w=0.17 //l=0.120208 //layer=m1 \
 //thickness=0.36 //x=4.93 //y=1.935 //x2=5.015 //y2=2.02
r122 (  6 22 ) resistor r=0.105739 //w=0.201 //l=0.145 //layer=m1 \
 //thickness=0.36 //x=4.93 //y=1.33 //x2=4.93 //y2=1.185
r123 (  6 7 ) resistor r=0.57729 //w=0.131 //l=0.605 //layer=m1 \
 //thickness=0.36 //x=4.93 //y=1.33 //x2=4.93 //y2=1.935
r124 (  5 15 ) resistor r=0.415076 //w=0.131 //l=0.435 //layer=m1 \
 //thickness=0.36 //x=5.3 //y=4.62 //x2=5.3 //y2=5.055
r125 (  4 5 ) resistor r=1.05916 //w=0.131 //l=1.11 //layer=m1 \
 //thickness=0.36 //x=5.3 //y=3.51 //x2=5.3 //y2=4.62
r126 (  3 4 ) resistor r=0.353053 //w=0.131 //l=0.37 //layer=m1 \
 //thickness=0.36 //x=5.3 //y=3.14 //x2=5.3 //y2=3.51
r127 (  2 3 ) resistor r=0.353053 //w=0.131 //l=0.37 //layer=m1 \
 //thickness=0.36 //x=5.3 //y=2.77 //x2=5.3 //y2=3.14
r128 (  1 2 ) resistor r=0.353053 //w=0.131 //l=0.37 //layer=m1 \
 //thickness=0.36 //x=5.3 //y=2.4 //x2=5.3 //y2=2.77
r129 (  1 14 ) resistor r=0.281489 //w=0.131 //l=0.295 //layer=m1 \
 //thickness=0.36 //x=5.3 //y=2.4 //x2=5.3 //y2=2.105
ends PM_HA\%COUT

subckt PM_HA\%noxref_9 ( 1 3 5 10 14 17 20 30 46 47 48 )
c91 ( 48 0 ) capacitor c=0.0367727f //x=10.665 //y=5.2
c92 ( 46 0 ) capacitor c=0.0184616f //x=8.915 //y=5.2
c93 ( 30 0 ) capacitor c=0.0304314f //x=9.93 //y=5.555
c94 ( 20 0 ) capacitor c=0.0447371f //x=9.05 //y=5.555
c95 ( 17 0 ) capacitor c=0.00971412f //x=10.81 //y=6.915
c96 ( 14 0 ) capacitor c=0.00634603f //x=9.93 //y=6.915
c97 ( 10 0 ) capacitor c=0.0091607f //x=9.93 //y=5.385
c98 ( 5 0 ) capacitor c=0.0125142f //x=9.057 //y=5.385
c99 ( 3 0 ) capacitor c=0.00639661f //x=10.695 //y=7.085
c100 ( 1 0 ) capacitor c=0.0125265f //x=9.81 //y=5.385
r101 (  37 47 ) resistor r=23.2727 //w=0.187 //l=0.34 //layer=li \
 //thickness=0.1 //x=9.93 //y=6.915 //x2=9.93 //y2=6.575
r102 (  30 47 ) resistor r=23.2727 //w=0.187 //l=0.34 //layer=li \
 //thickness=0.1 //x=9.93 //y=5.555 //x2=9.93 //y2=5.895
r103 (  20 46 ) resistor r=23.2727 //w=0.187 //l=0.34 //layer=li \
 //thickness=0.1 //x=9.05 //y=5.555 //x2=9.05 //y2=5.895
r104 (  17 48 ) resistor r=9.3 //w=0.17 //l=0.17 //layer=mcon //count=1 \
 //x=10.81 //y=6.915 //x2=10.81 //y2=6.915
r105 (  17 18 ) resistor r=0.0997653 //w=0.213 //l=0.17 //layer=m1 \
 //thickness=0.36 //x=10.81 //y=6.915 //x2=10.81 //y2=7.085
r106 (  14 37 ) resistor r=9.3 //w=0.17 //l=0.17 //layer=mcon //count=1 \
 //x=9.93 //y=6.915 //x2=9.93 //y2=6.915
r107 (  14 15 ) resistor r=0.100236 //w=0.212 //l=0.17 //layer=m1 \
 //thickness=0.36 //x=9.93 //y=6.915 //x2=9.93 //y2=7.085
r108 (  12 30 ) resistor r=9.3 //w=0.17 //l=0.17 //layer=mcon //count=1 \
 //x=9.93 //y=5.555 //x2=9.93 //y2=5.555
r109 (  10 12 ) resistor r=0.0965909 //w=0.22 //l=0.17 //layer=m1 \
 //thickness=0.36 //x=9.93 //y=5.385 //x2=9.93 //y2=5.555
r110 (  7 20 ) resistor r=9.3 //w=0.17 //l=0.17 //layer=mcon //count=1 \
 //x=9.05 //y=5.555 //x2=9.05 //y2=5.555
r111 (  5 7 ) resistor r=0.0912017 //w=0.233 //l=0.17 //layer=m1 \
 //thickness=0.36 //x=9.057 //y=5.385 //x2=9.057 //y2=5.555
r112 (  4 15 ) resistor r=0.0208269 //w=0.212 //l=0.115 //layer=m1 \
 //thickness=0.36 //x=10.045 //y=7.085 //x2=9.93 //y2=7.085
r113 (  3 18 ) resistor r=0.0211096 //w=0.213 //l=0.115 //layer=m1 \
 //thickness=0.36 //x=10.695 //y=7.085 //x2=10.81 //y2=7.085
r114 (  3 4 ) resistor r=0.620229 //w=0.131 //l=0.65 //layer=m1 \
 //thickness=0.36 //x=10.695 //y=7.085 //x2=10.045 //y2=7.085
r115 (  2 5 ) resistor r=0.0264833 //w=0.233 //l=0.128 //layer=m1 \
 //thickness=0.36 //x=9.185 //y=5.385 //x2=9.057 //y2=5.385
r116 (  1 10 ) resistor r=0.0230492 //w=0.22 //l=0.12 //layer=m1 \
 //thickness=0.36 //x=9.81 //y=5.385 //x2=9.93 //y2=5.385
r117 (  1 2 ) resistor r=0.596374 //w=0.131 //l=0.625 //layer=m1 \
 //thickness=0.36 //x=9.81 //y=5.385 //x2=9.185 //y2=5.385
ends PM_HA\%noxref_9

subckt PM_HA\%noxref_10 ( 1 3 5 10 14 17 20 30 46 47 48 )
c81 ( 48 0 ) capacitor c=0.0344743f //x=13.995 //y=5.2
c82 ( 46 0 ) capacitor c=0.0124387f //x=12.245 //y=5.2
c83 ( 30 0 ) capacitor c=0.0304667f //x=13.26 //y=5.555
c84 ( 20 0 ) capacitor c=0.0472305f //x=12.38 //y=5.555
c85 ( 17 0 ) capacitor c=0.0161402f //x=14.14 //y=6.915
c86 ( 14 0 ) capacitor c=0.00620376f //x=13.26 //y=6.915
c87 ( 10 0 ) capacitor c=0.0090232f //x=13.26 //y=5.385
c88 ( 5 0 ) capacitor c=0.0119578f //x=12.38 //y=5.385
c89 ( 3 0 ) capacitor c=0.00902211f //x=14.02 //y=7.085
c90 ( 1 0 ) capacitor c=0.0119453f //x=13.145 //y=5.385
r91 (  37 47 ) resistor r=23.2727 //w=0.187 //l=0.34 //layer=li \
 //thickness=0.1 //x=13.26 //y=6.915 //x2=13.26 //y2=6.575
r92 (  30 47 ) resistor r=23.2727 //w=0.187 //l=0.34 //layer=li \
 //thickness=0.1 //x=13.26 //y=5.555 //x2=13.26 //y2=5.895
r93 (  20 46 ) resistor r=23.2727 //w=0.187 //l=0.34 //layer=li \
 //thickness=0.1 //x=12.38 //y=5.555 //x2=12.38 //y2=5.895
r94 (  17 48 ) resistor r=9.3 //w=0.17 //l=0.17 //layer=mcon //count=1 \
 //x=14.14 //y=6.915 //x2=14.14 //y2=6.915
r95 (  17 18 ) resistor r=0.097032 //w=0.219 //l=0.17 //layer=m1 \
 //thickness=0.36 //x=14.137 //y=6.915 //x2=14.137 //y2=7.085
r96 (  14 37 ) resistor r=9.3 //w=0.17 //l=0.17 //layer=mcon //count=1 \
 //x=13.26 //y=6.915 //x2=13.26 //y2=6.915
r97 (  14 15 ) resistor r=0.100236 //w=0.212 //l=0.17 //layer=m1 \
 //thickness=0.36 //x=13.26 //y=6.915 //x2=13.26 //y2=7.085
r98 (  12 30 ) resistor r=9.3 //w=0.17 //l=0.17 //layer=mcon //count=1 \
 //x=13.26 //y=5.555 //x2=13.26 //y2=5.555
r99 (  10 12 ) resistor r=0.100236 //w=0.212 //l=0.17 //layer=m1 \
 //thickness=0.36 //x=13.26 //y=5.385 //x2=13.26 //y2=5.555
r100 (  7 20 ) resistor r=9.3 //w=0.17 //l=0.17 //layer=mcon //count=1 \
 //x=12.38 //y=5.555 //x2=12.38 //y2=5.555
r101 (  5 7 ) resistor r=0.100236 //w=0.212 //l=0.17 //layer=m1 \
 //thickness=0.36 //x=12.38 //y=5.385 //x2=12.38 //y2=5.555
r102 (  4 15 ) resistor r=0.0208269 //w=0.212 //l=0.115 //layer=m1 \
 //thickness=0.36 //x=13.375 //y=7.085 //x2=13.26 //y2=7.085
r103 (  3 18 ) resistor r=0.0227762 //w=0.219 //l=0.117 //layer=m1 \
 //thickness=0.36 //x=14.02 //y=7.085 //x2=14.137 //y2=7.085
r104 (  3 4 ) resistor r=0.615458 //w=0.131 //l=0.645 //layer=m1 \
 //thickness=0.36 //x=14.02 //y=7.085 //x2=13.375 //y2=7.085
r105 (  2 5 ) resistor r=0.0208269 //w=0.212 //l=0.115 //layer=m1 \
 //thickness=0.36 //x=12.495 //y=5.385 //x2=12.38 //y2=5.385
r106 (  1 10 ) resistor r=0.0208269 //w=0.212 //l=0.115 //layer=m1 \
 //thickness=0.36 //x=13.145 //y=5.385 //x2=13.26 //y2=5.385
r107 (  1 2 ) resistor r=0.620229 //w=0.131 //l=0.65 //layer=m1 \
 //thickness=0.36 //x=13.145 //y=5.385 //x2=12.495 //y2=5.385
ends PM_HA\%noxref_10

subckt PM_HA\%GND ( 1 2 8 24 25 32 39 42 43 55 58 73 78 82 104 108 111 120 135 \
 153 158 162 174 185 197 198 199 204 211 212 213 214 215 216 )
c356 ( 216 0 ) capacitor c=0.0634172f //x=15.415 //y=0.55
c357 ( 215 0 ) capacitor c=0.00839739f //x=12.58 //y=1.05
c358 ( 214 0 ) capacitor c=0.00839739f //x=9.25 //y=1.05
c359 ( 213 0 ) capacitor c=0.0623165f //x=6.535 //y=0.55
c360 ( 212 0 ) capacitor c=0.0632432f //x=4.315 //y=0.55
c361 ( 211 0 ) capacitor c=0.00843555f //x=1.48 //y=1.045
c362 ( 204 0 ) capacitor c=0.253728f //x=16.51 //y=0.175
c363 ( 199 0 ) capacitor c=0.113187f //x=14.92 //y=0.175
c364 ( 198 0 ) capacitor c=0.111601f //x=11.59 //y=0.175
c365 ( 197 0 ) capacitor c=0.108227f //x=8.26 //y=0.175
c366 ( 185 0 ) capacitor c=0.106491f //x=6.04 //y=0.175
c367 ( 174 0 ) capacitor c=0.112904f //x=3.82 //y=0.175
c368 ( 165 0 ) capacitor c=0.00590583f //x=16.51 //y=0.63
c369 ( 162 0 ) capacitor c=0.00599833f //x=16.425 //y=0.715
c370 ( 161 0 ) capacitor c=0.00479851f //x=16.03 //y=0.63
c371 ( 158 0 ) capacitor c=0.0061439f //x=15.945 //y=0.715
c372 ( 153 0 ) capacitor c=0.00589014f //x=15.54 //y=0.63
c373 ( 148 0 ) capacitor c=0.0185464f //x=15.455 //y=0.175
c374 ( 135 0 ) capacitor c=0.126479f //x=14.75 //y=0.175
c375 ( 120 0 ) capacitor c=0.125892f //x=11.42 //y=0.175
c376 ( 117 0 ) capacitor c=0.0366946f //x=7.725 //y=0.175
c377 ( 116 0 ) capacitor c=0.0185573f //x=8.09 //y=0.175
c378 ( 111 0 ) capacitor c=0.00589014f //x=7.64 //y=0.63
c379 ( 108 0 ) capacitor c=0.00605867f //x=7.555 //y=0.715
c380 ( 107 0 ) capacitor c=0.00479851f //x=7.15 //y=0.63
c381 ( 104 0 ) capacitor c=0.00645303f //x=7.065 //y=0.715
c382 ( 99 0 ) capacitor c=0.00590583f //x=6.67 //y=0.63
c383 ( 94 0 ) capacitor c=0.0191899f //x=6.585 //y=0.175
c384 ( 91 0 ) capacitor c=0.0366946f //x=5.505 //y=0.175
c385 ( 90 0 ) capacitor c=0.0186173f //x=5.87 //y=0.175
c386 ( 85 0 ) capacitor c=0.00585268f //x=5.42 //y=0.63
c387 ( 82 0 ) capacitor c=0.00625302f //x=5.335 //y=0.715
c388 ( 81 0 ) capacitor c=0.00479851f //x=4.93 //y=0.63
c389 ( 78 0 ) capacitor c=0.00647872f //x=4.845 //y=0.715
c390 ( 73 0 ) capacitor c=0.00586769f //x=4.45 //y=0.63
c391 ( 70 0 ) capacitor c=0.0190482f //x=4.365 //y=0.175
c392 ( 58 0 ) capacitor c=0.202208f //x=1.23 //y=0.18
c393 ( 55 0 ) capacitor c=0.125256f //x=3.65 //y=0.175
c394 ( 50 0 ) capacitor c=0.00509249f //x=12.7 //y=0.18
c395 ( 46 0 ) capacitor c=0.00509249f //x=9.44 //y=0.175
c396 ( 45 0 ) capacitor c=0.00509083f //x=1.67 //y=0.175
c397 ( 43 0 ) capacitor c=0.0278993f //x=1.667 //y=1.005
c398 ( 42 0 ) capacitor c=0.0172247f //x=1.67 //y=1.135
c399 ( 39 0 ) capacitor c=0.180096f //x=16.4 //y=0.18
c400 ( 32 0 ) capacitor c=0.0338236f //x=12.77 //y=1.025
c401 ( 25 0 ) capacitor c=0.108721f //x=12.685 //y=0.175
c402 ( 24 0 ) capacitor c=0.034835f //x=9.44 //y=1.025
c403 ( 8 0 ) capacitor c=0.266295f //x=9.355 //y=0.175
c404 ( 2 0 ) capacitor c=0.0764999f //x=1.585 //y=0.175
r405 (  203 204 ) resistor r=3.83651 //w=0.367 //l=0.11 //layer=li \
 //thickness=0.1 //x=16.4 //y=0.175 //x2=16.51 //y2=0.175
r406 (  201 203 ) resistor r=12.9046 //w=0.367 //l=0.37 //layer=li \
 //thickness=0.1 //x=16.03 //y=0.175 //x2=16.4 //y2=0.175
r407 (  200 201 ) resistor r=17.0899 //w=0.367 //l=0.49 //layer=li \
 //thickness=0.1 //x=15.54 //y=0.175 //x2=16.03 //y2=0.175
r408 (  189 190 ) resistor r=4.18529 //w=0.367 //l=0.12 //layer=li \
 //thickness=0.1 //x=7.52 //y=0.175 //x2=7.64 //y2=0.175
r409 (  187 189 ) resistor r=12.9046 //w=0.367 //l=0.37 //layer=li \
 //thickness=0.1 //x=7.15 //y=0.175 //x2=7.52 //y2=0.175
r410 (  186 187 ) resistor r=16.7411 //w=0.367 //l=0.48 //layer=li \
 //thickness=0.1 //x=6.67 //y=0.175 //x2=7.15 //y2=0.175
r411 (  177 178 ) resistor r=17.0899 //w=0.367 //l=0.49 //layer=li \
 //thickness=0.1 //x=4.93 //y=0.175 //x2=5.42 //y2=0.175
r412 (  175 177 ) resistor r=16.7411 //w=0.367 //l=0.48 //layer=li \
 //thickness=0.1 //x=4.45 //y=0.175 //x2=4.93 //y2=0.175
r413 (  166 216 ) resistor r=5.4201 //w=0.17 //l=0.085 //layer=li \
 //thickness=0.1 //x=16.51 //y=0.8 //x2=16.51 //y2=0.715
r414 (  166 216 ) resistor r=41.4118 //w=0.187 //l=0.605 //layer=li \
 //thickness=0.1 //x=16.51 //y=0.8 //x2=16.51 //y2=1.405
r415 (  165 216 ) resistor r=5.4201 //w=0.17 //l=0.085 //layer=li \
 //thickness=0.1 //x=16.51 //y=0.63 //x2=16.51 //y2=0.715
r416 (  164 204 ) resistor r=5.21862 //w=0.35 //l=0.175 //layer=li \
 //thickness=0.1 //x=16.51 //y=0.35 //x2=16.51 //y2=0.175
r417 (  164 165 ) resistor r=19.1658 //w=0.187 //l=0.28 //layer=li \
 //thickness=0.1 //x=16.51 //y=0.35 //x2=16.51 //y2=0.63
r418 (  163 216 ) resistor r=5.4201 //w=0.17 //l=0.085 //layer=li \
 //thickness=0.1 //x=16.115 //y=0.715 //x2=16.03 //y2=0.715
r419 (  162 216 ) resistor r=1.40859 //w=0.34 //l=0.085 //layer=li \
 //thickness=0.1 //x=16.425 //y=0.715 //x2=16.51 //y2=0.715
r420 (  162 163 ) resistor r=21.2193 //w=0.187 //l=0.31 //layer=li \
 //thickness=0.1 //x=16.425 //y=0.715 //x2=16.115 //y2=0.715
r421 (  161 216 ) resistor r=1.40859 //w=0.34 //l=0.085 //layer=li \
 //thickness=0.1 //x=16.03 //y=0.63 //x2=16.03 //y2=0.715
r422 (  160 201 ) resistor r=5.21862 //w=0.35 //l=0.175 //layer=li \
 //thickness=0.1 //x=16.03 //y=0.35 //x2=16.03 //y2=0.175
r423 (  160 161 ) resistor r=19.1658 //w=0.187 //l=0.28 //layer=li \
 //thickness=0.1 //x=16.03 //y=0.35 //x2=16.03 //y2=0.63
r424 (  159 216 ) resistor r=1.40859 //w=0.34 //l=0.085 //layer=li \
 //thickness=0.1 //x=15.625 //y=0.715 //x2=15.54 //y2=0.715
r425 (  158 216 ) resistor r=5.4201 //w=0.17 //l=0.085 //layer=li \
 //thickness=0.1 //x=15.945 //y=0.715 //x2=16.03 //y2=0.715
r426 (  158 159 ) resistor r=21.9037 //w=0.187 //l=0.32 //layer=li \
 //thickness=0.1 //x=15.945 //y=0.715 //x2=15.625 //y2=0.715
r427 (  154 216 ) resistor r=5.4201 //w=0.17 //l=0.085 //layer=li \
 //thickness=0.1 //x=15.54 //y=0.8 //x2=15.54 //y2=0.715
r428 (  154 216 ) resistor r=41.4118 //w=0.187 //l=0.605 //layer=li \
 //thickness=0.1 //x=15.54 //y=0.8 //x2=15.54 //y2=1.405
r429 (  153 216 ) resistor r=5.4201 //w=0.17 //l=0.085 //layer=li \
 //thickness=0.1 //x=15.54 //y=0.63 //x2=15.54 //y2=0.715
r430 (  152 200 ) resistor r=5.21862 //w=0.35 //l=0.175 //layer=li \
 //thickness=0.1 //x=15.54 //y=0.35 //x2=15.54 //y2=0.175
r431 (  152 153 ) resistor r=19.1658 //w=0.187 //l=0.28 //layer=li \
 //thickness=0.1 //x=15.54 //y=0.35 //x2=15.54 //y2=0.63
r432 (  149 199 ) resistor r=5.29055 //w=0.35 //l=0.17 //layer=li \
 //thickness=0.1 //x=15.09 //y=0.175 //x2=14.92 //y2=0.175
r433 (  149 151 ) resistor r=6.97548 //w=0.367 //l=0.2 //layer=li \
 //thickness=0.1 //x=15.09 //y=0.175 //x2=15.29 //y2=0.175
r434 (  148 200 ) resistor r=2.96458 //w=0.367 //l=0.085 //layer=li \
 //thickness=0.1 //x=15.455 //y=0.175 //x2=15.54 //y2=0.175
r435 (  148 151 ) resistor r=5.75477 //w=0.367 //l=0.165 //layer=li \
 //thickness=0.1 //x=15.455 //y=0.175 //x2=15.29 //y2=0.175
r436 (  138 140 ) resistor r=38.7139 //w=0.367 //l=1.11 //layer=li \
 //thickness=0.1 //x=12.7 //y=0.175 //x2=13.81 //y2=0.175
r437 (  136 198 ) resistor r=5.29055 //w=0.35 //l=0.17 //layer=li \
 //thickness=0.1 //x=11.76 //y=0.175 //x2=11.59 //y2=0.175
r438 (  136 138 ) resistor r=32.7847 //w=0.367 //l=0.94 //layer=li \
 //thickness=0.1 //x=11.76 //y=0.175 //x2=12.7 //y2=0.175
r439 (  135 199 ) resistor r=5.29055 //w=0.35 //l=0.17 //layer=li \
 //thickness=0.1 //x=14.75 //y=0.175 //x2=14.92 //y2=0.175
r440 (  135 140 ) resistor r=32.7847 //w=0.367 //l=0.94 //layer=li \
 //thickness=0.1 //x=14.75 //y=0.175 //x2=13.81 //y2=0.175
r441 (  125 127 ) resistor r=38.7139 //w=0.367 //l=1.11 //layer=li \
 //thickness=0.1 //x=10.11 //y=0.175 //x2=11.22 //y2=0.175
r442 (  123 125 ) resistor r=38.7139 //w=0.367 //l=1.11 //layer=li \
 //thickness=0.1 //x=9 //y=0.175 //x2=10.11 //y2=0.175
r443 (  121 197 ) resistor r=5.29055 //w=0.35 //l=0.17 //layer=li \
 //thickness=0.1 //x=8.43 //y=0.175 //x2=8.26 //y2=0.175
r444 (  121 123 ) resistor r=19.8801 //w=0.367 //l=0.57 //layer=li \
 //thickness=0.1 //x=8.43 //y=0.175 //x2=9 //y2=0.175
r445 (  120 198 ) resistor r=5.29055 //w=0.35 //l=0.17 //layer=li \
 //thickness=0.1 //x=11.42 //y=0.175 //x2=11.59 //y2=0.175
r446 (  120 127 ) resistor r=6.97548 //w=0.367 //l=0.2 //layer=li \
 //thickness=0.1 //x=11.42 //y=0.175 //x2=11.22 //y2=0.175
r447 (  117 190 ) resistor r=2.96458 //w=0.367 //l=0.085 //layer=li \
 //thickness=0.1 //x=7.725 //y=0.175 //x2=7.64 //y2=0.175
r448 (  116 197 ) resistor r=5.29055 //w=0.35 //l=0.17 //layer=li \
 //thickness=0.1 //x=8.09 //y=0.175 //x2=8.26 //y2=0.175
r449 (  116 117 ) resistor r=12.7302 //w=0.367 //l=0.365 //layer=li \
 //thickness=0.1 //x=8.09 //y=0.175 //x2=7.725 //y2=0.175
r450 (  112 213 ) resistor r=5.4201 //w=0.17 //l=0.085 //layer=li \
 //thickness=0.1 //x=7.64 //y=0.8 //x2=7.64 //y2=0.715
r451 (  112 213 ) resistor r=41.4118 //w=0.187 //l=0.605 //layer=li \
 //thickness=0.1 //x=7.64 //y=0.8 //x2=7.64 //y2=1.405
r452 (  111 213 ) resistor r=5.4201 //w=0.17 //l=0.085 //layer=li \
 //thickness=0.1 //x=7.64 //y=0.63 //x2=7.64 //y2=0.715
r453 (  110 190 ) resistor r=5.21862 //w=0.35 //l=0.175 //layer=li \
 //thickness=0.1 //x=7.64 //y=0.35 //x2=7.64 //y2=0.175
r454 (  110 111 ) resistor r=19.1658 //w=0.187 //l=0.28 //layer=li \
 //thickness=0.1 //x=7.64 //y=0.35 //x2=7.64 //y2=0.63
r455 (  109 213 ) resistor r=5.4201 //w=0.17 //l=0.085 //layer=li \
 //thickness=0.1 //x=7.235 //y=0.715 //x2=7.15 //y2=0.715
r456 (  108 213 ) resistor r=1.40859 //w=0.34 //l=0.085 //layer=li \
 //thickness=0.1 //x=7.555 //y=0.715 //x2=7.64 //y2=0.715
r457 (  108 109 ) resistor r=21.9037 //w=0.187 //l=0.32 //layer=li \
 //thickness=0.1 //x=7.555 //y=0.715 //x2=7.235 //y2=0.715
r458 (  107 213 ) resistor r=1.40859 //w=0.34 //l=0.085 //layer=li \
 //thickness=0.1 //x=7.15 //y=0.63 //x2=7.15 //y2=0.715
r459 (  106 187 ) resistor r=5.21862 //w=0.35 //l=0.175 //layer=li \
 //thickness=0.1 //x=7.15 //y=0.35 //x2=7.15 //y2=0.175
r460 (  106 107 ) resistor r=19.1658 //w=0.187 //l=0.28 //layer=li \
 //thickness=0.1 //x=7.15 //y=0.35 //x2=7.15 //y2=0.63
r461 (  105 213 ) resistor r=1.40859 //w=0.34 //l=0.085 //layer=li \
 //thickness=0.1 //x=6.755 //y=0.715 //x2=6.67 //y2=0.715
r462 (  104 213 ) resistor r=5.4201 //w=0.17 //l=0.085 //layer=li \
 //thickness=0.1 //x=7.065 //y=0.715 //x2=7.15 //y2=0.715
r463 (  104 105 ) resistor r=21.2193 //w=0.187 //l=0.31 //layer=li \
 //thickness=0.1 //x=7.065 //y=0.715 //x2=6.755 //y2=0.715
r464 (  100 213 ) resistor r=5.4201 //w=0.17 //l=0.085 //layer=li \
 //thickness=0.1 //x=6.67 //y=0.8 //x2=6.67 //y2=0.715
r465 (  100 213 ) resistor r=41.4118 //w=0.187 //l=0.605 //layer=li \
 //thickness=0.1 //x=6.67 //y=0.8 //x2=6.67 //y2=1.405
r466 (  99 213 ) resistor r=5.4201 //w=0.17 //l=0.085 //layer=li \
 //thickness=0.1 //x=6.67 //y=0.63 //x2=6.67 //y2=0.715
r467 (  98 186 ) resistor r=5.21862 //w=0.35 //l=0.175 //layer=li \
 //thickness=0.1 //x=6.67 //y=0.35 //x2=6.67 //y2=0.175
r468 (  98 99 ) resistor r=19.1658 //w=0.187 //l=0.28 //layer=li \
 //thickness=0.1 //x=6.67 //y=0.35 //x2=6.67 //y2=0.63
r469 (  95 185 ) resistor r=5.29055 //w=0.35 //l=0.17 //layer=li \
 //thickness=0.1 //x=6.21 //y=0.175 //x2=6.04 //y2=0.175
r470 (  95 97 ) resistor r=6.97548 //w=0.367 //l=0.2 //layer=li \
 //thickness=0.1 //x=6.21 //y=0.175 //x2=6.41 //y2=0.175
r471 (  94 186 ) resistor r=2.96458 //w=0.367 //l=0.085 //layer=li \
 //thickness=0.1 //x=6.585 //y=0.175 //x2=6.67 //y2=0.175
r472 (  94 97 ) resistor r=6.10354 //w=0.367 //l=0.175 //layer=li \
 //thickness=0.1 //x=6.585 //y=0.175 //x2=6.41 //y2=0.175
r473 (  91 178 ) resistor r=2.96458 //w=0.367 //l=0.085 //layer=li \
 //thickness=0.1 //x=5.505 //y=0.175 //x2=5.42 //y2=0.175
r474 (  90 185 ) resistor r=5.29055 //w=0.35 //l=0.17 //layer=li \
 //thickness=0.1 //x=5.87 //y=0.175 //x2=6.04 //y2=0.175
r475 (  90 91 ) resistor r=12.7302 //w=0.367 //l=0.365 //layer=li \
 //thickness=0.1 //x=5.87 //y=0.175 //x2=5.505 //y2=0.175
r476 (  86 212 ) resistor r=5.4201 //w=0.17 //l=0.085 //layer=li \
 //thickness=0.1 //x=5.42 //y=0.8 //x2=5.42 //y2=0.715
r477 (  86 212 ) resistor r=41.4118 //w=0.187 //l=0.605 //layer=li \
 //thickness=0.1 //x=5.42 //y=0.8 //x2=5.42 //y2=1.405
r478 (  85 212 ) resistor r=5.4201 //w=0.17 //l=0.085 //layer=li \
 //thickness=0.1 //x=5.42 //y=0.63 //x2=5.42 //y2=0.715
r479 (  84 178 ) resistor r=5.21862 //w=0.35 //l=0.175 //layer=li \
 //thickness=0.1 //x=5.42 //y=0.35 //x2=5.42 //y2=0.175
r480 (  84 85 ) resistor r=19.1658 //w=0.187 //l=0.28 //layer=li \
 //thickness=0.1 //x=5.42 //y=0.35 //x2=5.42 //y2=0.63
r481 (  83 212 ) resistor r=5.4201 //w=0.17 //l=0.085 //layer=li \
 //thickness=0.1 //x=5.015 //y=0.715 //x2=4.93 //y2=0.715
r482 (  82 212 ) resistor r=1.40859 //w=0.34 //l=0.085 //layer=li \
 //thickness=0.1 //x=5.335 //y=0.715 //x2=5.42 //y2=0.715
r483 (  82 83 ) resistor r=21.9037 //w=0.187 //l=0.32 //layer=li \
 //thickness=0.1 //x=5.335 //y=0.715 //x2=5.015 //y2=0.715
r484 (  81 212 ) resistor r=1.40859 //w=0.34 //l=0.085 //layer=li \
 //thickness=0.1 //x=4.93 //y=0.63 //x2=4.93 //y2=0.715
r485 (  80 177 ) resistor r=5.21862 //w=0.35 //l=0.175 //layer=li \
 //thickness=0.1 //x=4.93 //y=0.35 //x2=4.93 //y2=0.175
r486 (  80 81 ) resistor r=19.1658 //w=0.187 //l=0.28 //layer=li \
 //thickness=0.1 //x=4.93 //y=0.35 //x2=4.93 //y2=0.63
r487 (  79 212 ) resistor r=1.40859 //w=0.34 //l=0.085 //layer=li \
 //thickness=0.1 //x=4.535 //y=0.715 //x2=4.45 //y2=0.715
r488 (  78 212 ) resistor r=5.4201 //w=0.17 //l=0.085 //layer=li \
 //thickness=0.1 //x=4.845 //y=0.715 //x2=4.93 //y2=0.715
r489 (  78 79 ) resistor r=21.2193 //w=0.187 //l=0.31 //layer=li \
 //thickness=0.1 //x=4.845 //y=0.715 //x2=4.535 //y2=0.715
r490 (  74 212 ) resistor r=5.4201 //w=0.17 //l=0.085 //layer=li \
 //thickness=0.1 //x=4.45 //y=0.8 //x2=4.45 //y2=0.715
r491 (  74 212 ) resistor r=41.4118 //w=0.187 //l=0.605 //layer=li \
 //thickness=0.1 //x=4.45 //y=0.8 //x2=4.45 //y2=1.405
r492 (  73 212 ) resistor r=5.4201 //w=0.17 //l=0.085 //layer=li \
 //thickness=0.1 //x=4.45 //y=0.63 //x2=4.45 //y2=0.715
r493 (  72 175 ) resistor r=5.21862 //w=0.35 //l=0.175 //layer=li \
 //thickness=0.1 //x=4.45 //y=0.35 //x2=4.45 //y2=0.175
r494 (  72 73 ) resistor r=19.1658 //w=0.187 //l=0.28 //layer=li \
 //thickness=0.1 //x=4.45 //y=0.35 //x2=4.45 //y2=0.63
r495 (  71 174 ) resistor r=5.29055 //w=0.35 //l=0.17 //layer=li \
 //thickness=0.1 //x=3.99 //y=0.175 //x2=3.82 //y2=0.175
r496 (  70 175 ) resistor r=2.96458 //w=0.367 //l=0.085 //layer=li \
 //thickness=0.1 //x=4.365 //y=0.175 //x2=4.45 //y2=0.175
r497 (  70 71 ) resistor r=13.079 //w=0.367 //l=0.375 //layer=li \
 //thickness=0.1 //x=4.365 //y=0.175 //x2=3.99 //y2=0.175
r498 (  60 62 ) resistor r=38.7139 //w=0.367 //l=1.11 //layer=li \
 //thickness=0.1 //x=2.34 //y=0.175 //x2=3.45 //y2=0.175
r499 (  58 60 ) resistor r=38.7139 //w=0.367 //l=1.11 //layer=li \
 //thickness=0.1 //x=1.23 //y=0.175 //x2=2.34 //y2=0.175
r500 (  55 174 ) resistor r=5.29055 //w=0.35 //l=0.17 //layer=li \
 //thickness=0.1 //x=3.65 //y=0.175 //x2=3.82 //y2=0.175
r501 (  55 62 ) resistor r=6.97548 //w=0.367 //l=0.2 //layer=li \
 //thickness=0.1 //x=3.65 //y=0.175 //x2=3.45 //y2=0.175
r502 (  52 215 ) resistor r=9.3 //w=0.17 //l=0.17 //layer=mcon //count=1 \
 //x=12.77 //y=1.14 //x2=12.77 //y2=1.14
r503 (  50 138 ) resistor r=3.1 //w=0.17 //l=0.51 //layer=mcon //count=3 \
 //x=12.7 //y=0.18 //x2=12.7 //y2=0.18
r504 (  48 214 ) resistor r=9.3 //w=0.17 //l=0.17 //layer=mcon //count=1 \
 //x=9.44 //y=1.14 //x2=9.44 //y2=1.14
r505 (  42 211 ) resistor r=9.3 //w=0.17 //l=0.17 //layer=mcon //count=1 \
 //x=1.67 //y=1.135 //x2=1.67 //y2=1.135
r506 (  42 43 ) resistor r=0.0939994 //w=0.226 //l=0.13 //layer=m1 \
 //thickness=0.36 //x=1.667 //y=1.135 //x2=1.667 //y2=1.005
r507 (  39 203 ) resistor r=3.1 //w=0.17 //l=0.51 //layer=mcon //count=3 \
 //x=16.4 //y=0.18 //x2=16.4 //y2=0.18
r508 (  37 151 ) resistor r=3.1 //w=0.17 //l=0.51 //layer=mcon //count=3 \
 //x=15.29 //y=0.18 //x2=15.29 //y2=0.18
r509 (  37 39 ) resistor r=0.446141 //w=0.311 //l=1.11 //layer=m1 \
 //thickness=0.36 //x=15.29 //y=0.175 //x2=16.4 //y2=0.175
r510 (  35 140 ) resistor r=3.1 //w=0.17 //l=0.51 //layer=mcon //count=3 \
 //x=13.81 //y=0.18 //x2=13.81 //y2=0.18
r511 (  35 37 ) resistor r=0.594855 //w=0.311 //l=1.48 //layer=m1 \
 //thickness=0.36 //x=13.81 //y=0.175 //x2=15.29 //y2=0.175
r512 (  33 50 ) resistor r=0.028033 //w=0.35 //l=0.085 //layer=m1 \
 //thickness=0.36 //x=12.855 //y=0.175 //x2=12.77 //y2=0.175
r513 (  33 35 ) resistor r=0.383842 //w=0.311 //l=0.955 //layer=m1 \
 //thickness=0.36 //x=12.855 //y=0.175 //x2=13.81 //y2=0.175
r514 (  32 52 ) resistor r=0.0717383 //w=0.224 //l=0.115 //layer=m1 \
 //thickness=0.36 //x=12.77 //y=1.025 //x2=12.77 //y2=1.14
r515 (  31 50 ) resistor r=0.0413265 //w=0.7 //l=0.175 //layer=m1 \
 //thickness=0.36 //x=12.77 //y=0.35 //x2=12.77 //y2=0.175
r516 (  31 32 ) resistor r=0.644084 //w=0.131 //l=0.675 //layer=m1 \
 //thickness=0.36 //x=12.77 //y=0.35 //x2=12.77 //y2=1.025
r517 (  30 127 ) resistor r=3.1 //w=0.17 //l=0.51 //layer=mcon //count=3 \
 //x=11.22 //y=0.18 //x2=11.22 //y2=0.18
r518 (  28 125 ) resistor r=3.1 //w=0.17 //l=0.51 //layer=mcon //count=3 \
 //x=10.11 //y=0.18 //x2=10.11 //y2=0.18
r519 (  28 30 ) resistor r=0.446141 //w=0.311 //l=1.11 //layer=m1 \
 //thickness=0.36 //x=10.11 //y=0.175 //x2=11.22 //y2=0.175
r520 (  26 46 ) resistor r=0.028033 //w=0.35 //l=0.085 //layer=m1 \
 //thickness=0.36 //x=9.525 //y=0.175 //x2=9.44 //y2=0.175
r521 (  26 28 ) resistor r=0.235129 //w=0.311 //l=0.585 //layer=m1 \
 //thickness=0.36 //x=9.525 //y=0.175 //x2=10.11 //y2=0.175
r522 (  25 50 ) resistor r=0.028033 //w=0.35 //l=0.085 //layer=m1 \
 //thickness=0.36 //x=12.685 //y=0.175 //x2=12.77 //y2=0.175
r523 (  25 30 ) resistor r=0.588826 //w=0.311 //l=1.465 //layer=m1 \
 //thickness=0.36 //x=12.685 //y=0.175 //x2=11.22 //y2=0.175
r524 (  24 48 ) resistor r=0.0713327 //w=0.229 //l=0.115996 //layer=m1 \
 //thickness=0.36 //x=9.44 //y=1.025 //x2=9.442 //y2=1.14
r525 (  23 46 ) resistor r=0.0413265 //w=0.7 //l=0.175 //layer=m1 \
 //thickness=0.36 //x=9.44 //y=0.35 //x2=9.44 //y2=0.175
r526 (  23 24 ) resistor r=0.644084 //w=0.131 //l=0.675 //layer=m1 \
 //thickness=0.36 //x=9.44 //y=0.35 //x2=9.44 //y2=1.025
r527 (  22 123 ) resistor r=3.1 //w=0.17 //l=0.51 //layer=mcon //count=3 //x=9 \
 //y=0.18 //x2=9 //y2=0.18
r528 (  19 189 ) resistor r=3.1 //w=0.17 //l=0.51 //layer=mcon //count=3 \
 //x=7.52 //y=0.18 //x2=7.52 //y2=0.18
r529 (  17 97 ) resistor r=3.1 //w=0.17 //l=0.51 //layer=mcon //count=3 \
 //x=6.41 //y=0.18 //x2=6.41 //y2=0.18
r530 (  17 19 ) resistor r=0.446141 //w=0.311 //l=1.11 //layer=m1 \
 //thickness=0.36 //x=6.41 //y=0.175 //x2=7.52 //y2=0.175
r531 (  15 177 ) resistor r=3.1 //w=0.17 //l=0.51 //layer=mcon //count=3 \
 //x=4.93 //y=0.18 //x2=4.93 //y2=0.18
r532 (  15 17 ) resistor r=0.594855 //w=0.311 //l=1.48 //layer=m1 \
 //thickness=0.36 //x=4.93 //y=0.175 //x2=6.41 //y2=0.175
r533 (  13 62 ) resistor r=3.1 //w=0.17 //l=0.51 //layer=mcon //count=3 \
 //x=3.45 //y=0.18 //x2=3.45 //y2=0.18
r534 (  13 15 ) resistor r=0.594855 //w=0.311 //l=1.48 //layer=m1 \
 //thickness=0.36 //x=3.45 //y=0.175 //x2=4.93 //y2=0.175
r535 (  11 60 ) resistor r=3.1 //w=0.17 //l=0.51 //layer=mcon //count=3 \
 //x=2.34 //y=0.18 //x2=2.34 //y2=0.18
r536 (  11 13 ) resistor r=0.446141 //w=0.311 //l=1.11 //layer=m1 \
 //thickness=0.36 //x=2.34 //y=0.175 //x2=3.45 //y2=0.175
r537 (  9 45 ) resistor r=0.028033 //w=0.35 //l=0.085 //layer=m1 \
 //thickness=0.36 //x=1.755 //y=0.175 //x2=1.67 //y2=0.175
r538 (  9 11 ) resistor r=0.235129 //w=0.311 //l=0.585 //layer=m1 \
 //thickness=0.36 //x=1.755 //y=0.175 //x2=2.34 //y2=0.175
r539 (  8 46 ) resistor r=0.028033 //w=0.35 //l=0.085 //layer=m1 \
 //thickness=0.36 //x=9.355 //y=0.175 //x2=9.44 //y2=0.175
r540 (  8 22 ) resistor r=0.142685 //w=0.311 //l=0.355 //layer=m1 \
 //thickness=0.36 //x=9.355 //y=0.175 //x2=9 //y2=0.175
r541 (  6 45 ) resistor r=0.0413265 //w=0.7 //l=0.175 //layer=m1 \
 //thickness=0.36 //x=1.67 //y=0.35 //x2=1.67 //y2=0.175
r542 (  6 43 ) resistor r=0.625 //w=0.131 //l=0.655 //layer=m1 \
 //thickness=0.36 //x=1.67 //y=0.35 //x2=1.67 //y2=1.005
r543 (  4 58 ) resistor r=3.1 //w=0.17 //l=0.51 //layer=mcon //count=3 \
 //x=1.23 //y=0.18 //x2=1.23 //y2=0.18
r544 (  2 45 ) resistor r=0.028033 //w=0.35 //l=0.085 //layer=m1 \
 //thickness=0.36 //x=1.585 //y=0.175 //x2=1.67 //y2=0.175
r545 (  2 4 ) resistor r=0.142685 //w=0.311 //l=0.355 //layer=m1 \
 //thickness=0.36 //x=1.585 //y=0.175 //x2=1.23 //y2=0.175
r546 (  1 22 ) resistor r=0.0743569 //w=0.311 //l=0.185 //layer=m1 \
 //thickness=0.36 //x=8.815 //y=0.175 //x2=9 //y2=0.175
r547 (  1 19 ) resistor r=0.520498 //w=0.311 //l=1.295 //layer=m1 \
 //thickness=0.36 //x=8.815 //y=0.175 //x2=7.52 //y2=0.175
ends PM_HA\%GND

subckt PM_HA\%noxref_12 ( 1 5 9 10 13 17 29 )
c63 ( 29 0 ) capacitor c=0.0676851f //x=1.05 //y=0.545
c64 ( 17 0 ) capacitor c=0.00709791f //x=3.125 //y=0.795
c65 ( 13 0 ) capacitor c=0.0157389f //x=3.04 //y=0.71
c66 ( 10 0 ) capacitor c=0.00920718f //x=2.155 //y=1.675
c67 ( 9 0 ) capacitor c=0.00770028f //x=2.155 //y=0.795
c68 ( 5 0 ) capacitor c=0.0234074f //x=2.07 //y=1.76
c69 ( 1 0 ) capacitor c=0.0115037f //x=1.185 //y=1.675
r70 (  17 29 ) resistor r=3.57586 //w=0.17 //l=0.125 //layer=li \
 //thickness=0.1 //x=3.125 //y=0.795 //x2=3.125 //y2=0.67
r71 (  17 29 ) resistor r=18.139 //w=0.187 //l=0.265 //layer=li \
 //thickness=0.1 //x=3.125 //y=0.795 //x2=3.125 //y2=1.06
r72 (  14 29 ) resistor r=3.57586 //w=0.17 //l=0.103078 //layer=li \
 //thickness=0.1 //x=2.24 //y=0.71 //x2=2.155 //y2=0.67
r73 (  14 29 ) resistor r=27.3797 //w=0.187 //l=0.4 //layer=li //thickness=0.1 \
 //x=2.24 //y=0.71 //x2=2.64 //y2=0.71
r74 (  13 29 ) resistor r=3.57586 //w=0.17 //l=0.103078 //layer=li \
 //thickness=0.1 //x=3.04 //y=0.71 //x2=3.125 //y2=0.67
r75 (  13 29 ) resistor r=27.3797 //w=0.187 //l=0.4 //layer=li //thickness=0.1 \
 //x=3.04 //y=0.71 //x2=2.64 //y2=0.71
r76 (  10 29 ) resistor r=3.57586 //w=0.17 //l=0.125 //layer=li \
 //thickness=0.1 //x=2.155 //y=1.675 //x2=2.155 //y2=1.8
r77 (  10 29 ) resistor r=42.0963 //w=0.187 //l=0.615 //layer=li \
 //thickness=0.1 //x=2.155 //y=1.675 //x2=2.155 //y2=1.06
r78 (  9 29 ) resistor r=3.57586 //w=0.17 //l=0.125 //layer=li //thickness=0.1 \
 //x=2.155 //y=0.795 //x2=2.155 //y2=0.67
r79 (  9 29 ) resistor r=18.139 //w=0.187 //l=0.265 //layer=li //thickness=0.1 \
 //x=2.155 //y=0.795 //x2=2.155 //y2=1.06
r80 (  6 29 ) resistor r=3.57586 //w=0.17 //l=0.103078 //layer=li \
 //thickness=0.1 //x=1.27 //y=1.76 //x2=1.185 //y2=1.8
r81 (  6 29 ) resistor r=27.3797 //w=0.187 //l=0.4 //layer=li //thickness=0.1 \
 //x=1.27 //y=1.76 //x2=1.67 //y2=1.76
r82 (  5 29 ) resistor r=3.57586 //w=0.17 //l=0.103078 //layer=li \
 //thickness=0.1 //x=2.07 //y=1.76 //x2=2.155 //y2=1.8
r83 (  5 29 ) resistor r=27.3797 //w=0.187 //l=0.4 //layer=li //thickness=0.1 \
 //x=2.07 //y=1.76 //x2=1.67 //y2=1.76
r84 (  1 29 ) resistor r=3.57586 //w=0.17 //l=0.125 //layer=li //thickness=0.1 \
 //x=1.185 //y=1.675 //x2=1.185 //y2=1.8
r85 (  1 29 ) resistor r=42.0963 //w=0.187 //l=0.615 //layer=li \
 //thickness=0.1 //x=1.185 //y=1.675 //x2=1.185 //y2=1.06
ends PM_HA\%noxref_12

subckt PM_HA\%noxref_13 ( 1 5 9 10 13 17 29 )
c66 ( 29 0 ) capacitor c=0.0666923f //x=8.82 //y=0.55
c67 ( 17 0 ) capacitor c=0.00679669f //x=10.895 //y=0.8
c68 ( 13 0 ) capacitor c=0.0157587f //x=10.81 //y=0.715
c69 ( 10 0 ) capacitor c=0.0074137f //x=9.925 //y=1.68
c70 ( 9 0 ) capacitor c=0.00771051f //x=9.925 //y=0.8
c71 ( 5 0 ) capacitor c=0.018443f //x=9.84 //y=1.765
c72 ( 1 0 ) capacitor c=0.00784591f //x=8.955 //y=1.68
r73 (  17 29 ) resistor r=3.57586 //w=0.17 //l=0.125 //layer=li \
 //thickness=0.1 //x=10.895 //y=0.8 //x2=10.895 //y2=0.675
r74 (  17 29 ) resistor r=18.139 //w=0.187 //l=0.265 //layer=li \
 //thickness=0.1 //x=10.895 //y=0.8 //x2=10.895 //y2=1.065
r75 (  14 29 ) resistor r=3.57586 //w=0.17 //l=0.103078 //layer=li \
 //thickness=0.1 //x=10.01 //y=0.715 //x2=9.925 //y2=0.675
r76 (  14 29 ) resistor r=27.3797 //w=0.187 //l=0.4 //layer=li //thickness=0.1 \
 //x=10.01 //y=0.715 //x2=10.41 //y2=0.715
r77 (  13 29 ) resistor r=3.57586 //w=0.17 //l=0.103078 //layer=li \
 //thickness=0.1 //x=10.81 //y=0.715 //x2=10.895 //y2=0.675
r78 (  13 29 ) resistor r=27.3797 //w=0.187 //l=0.4 //layer=li //thickness=0.1 \
 //x=10.81 //y=0.715 //x2=10.41 //y2=0.715
r79 (  10 29 ) resistor r=3.57586 //w=0.17 //l=0.125 //layer=li \
 //thickness=0.1 //x=9.925 //y=1.68 //x2=9.925 //y2=1.805
r80 (  10 29 ) resistor r=42.0963 //w=0.187 //l=0.615 //layer=li \
 //thickness=0.1 //x=9.925 //y=1.68 //x2=9.925 //y2=1.065
r81 (  9 29 ) resistor r=3.57586 //w=0.17 //l=0.125 //layer=li //thickness=0.1 \
 //x=9.925 //y=0.8 //x2=9.925 //y2=0.675
r82 (  9 29 ) resistor r=18.139 //w=0.187 //l=0.265 //layer=li //thickness=0.1 \
 //x=9.925 //y=0.8 //x2=9.925 //y2=1.065
r83 (  6 29 ) resistor r=3.57586 //w=0.17 //l=0.103078 //layer=li \
 //thickness=0.1 //x=9.04 //y=1.765 //x2=8.955 //y2=1.805
r84 (  6 29 ) resistor r=27.3797 //w=0.187 //l=0.4 //layer=li //thickness=0.1 \
 //x=9.04 //y=1.765 //x2=9.44 //y2=1.765
r85 (  5 29 ) resistor r=3.57586 //w=0.17 //l=0.103078 //layer=li \
 //thickness=0.1 //x=9.84 //y=1.765 //x2=9.925 //y2=1.805
r86 (  5 29 ) resistor r=27.3797 //w=0.187 //l=0.4 //layer=li //thickness=0.1 \
 //x=9.84 //y=1.765 //x2=9.44 //y2=1.765
r87 (  1 29 ) resistor r=3.57586 //w=0.17 //l=0.125 //layer=li //thickness=0.1 \
 //x=8.955 //y=1.68 //x2=8.955 //y2=1.805
r88 (  1 29 ) resistor r=42.0963 //w=0.187 //l=0.615 //layer=li \
 //thickness=0.1 //x=8.955 //y=1.68 //x2=8.955 //y2=1.065
ends PM_HA\%noxref_13

subckt PM_HA\%noxref_14 ( 1 5 9 10 13 17 29 )
c67 ( 29 0 ) capacitor c=0.0670706f //x=12.15 //y=0.55
c68 ( 17 0 ) capacitor c=0.0071081f //x=14.225 //y=0.8
c69 ( 13 0 ) capacitor c=0.0160456f //x=14.14 //y=0.715
c70 ( 10 0 ) capacitor c=0.00742709f //x=13.255 //y=1.68
c71 ( 9 0 ) capacitor c=0.00771051f //x=13.255 //y=0.8
c72 ( 5 0 ) capacitor c=0.0183314f //x=13.17 //y=1.765
c73 ( 1 0 ) capacitor c=0.00772931f //x=12.285 //y=1.68
r74 (  17 29 ) resistor r=3.57586 //w=0.17 //l=0.125 //layer=li \
 //thickness=0.1 //x=14.225 //y=0.8 //x2=14.225 //y2=0.675
r75 (  17 29 ) resistor r=18.139 //w=0.187 //l=0.265 //layer=li \
 //thickness=0.1 //x=14.225 //y=0.8 //x2=14.225 //y2=1.065
r76 (  14 29 ) resistor r=3.57586 //w=0.17 //l=0.103078 //layer=li \
 //thickness=0.1 //x=13.34 //y=0.715 //x2=13.255 //y2=0.675
r77 (  14 29 ) resistor r=27.3797 //w=0.187 //l=0.4 //layer=li //thickness=0.1 \
 //x=13.34 //y=0.715 //x2=13.74 //y2=0.715
r78 (  13 29 ) resistor r=3.57586 //w=0.17 //l=0.103078 //layer=li \
 //thickness=0.1 //x=14.14 //y=0.715 //x2=14.225 //y2=0.675
r79 (  13 29 ) resistor r=27.3797 //w=0.187 //l=0.4 //layer=li //thickness=0.1 \
 //x=14.14 //y=0.715 //x2=13.74 //y2=0.715
r80 (  10 29 ) resistor r=3.57586 //w=0.17 //l=0.125 //layer=li \
 //thickness=0.1 //x=13.255 //y=1.68 //x2=13.255 //y2=1.805
r81 (  10 29 ) resistor r=42.0963 //w=0.187 //l=0.615 //layer=li \
 //thickness=0.1 //x=13.255 //y=1.68 //x2=13.255 //y2=1.065
r82 (  9 29 ) resistor r=3.57586 //w=0.17 //l=0.125 //layer=li //thickness=0.1 \
 //x=13.255 //y=0.8 //x2=13.255 //y2=0.675
r83 (  9 29 ) resistor r=18.139 //w=0.187 //l=0.265 //layer=li //thickness=0.1 \
 //x=13.255 //y=0.8 //x2=13.255 //y2=1.065
r84 (  6 29 ) resistor r=3.57586 //w=0.17 //l=0.103078 //layer=li \
 //thickness=0.1 //x=12.37 //y=1.765 //x2=12.285 //y2=1.805
r85 (  6 29 ) resistor r=27.3797 //w=0.187 //l=0.4 //layer=li //thickness=0.1 \
 //x=12.37 //y=1.765 //x2=12.77 //y2=1.765
r86 (  5 29 ) resistor r=3.57586 //w=0.17 //l=0.103078 //layer=li \
 //thickness=0.1 //x=13.17 //y=1.765 //x2=13.255 //y2=1.805
r87 (  5 29 ) resistor r=27.3797 //w=0.187 //l=0.4 //layer=li //thickness=0.1 \
 //x=13.17 //y=1.765 //x2=12.77 //y2=1.765
r88 (  1 29 ) resistor r=3.57586 //w=0.17 //l=0.125 //layer=li //thickness=0.1 \
 //x=12.285 //y=1.68 //x2=12.285 //y2=1.805
r89 (  1 29 ) resistor r=42.0963 //w=0.187 //l=0.615 //layer=li \
 //thickness=0.1 //x=12.285 //y=1.68 //x2=12.285 //y2=1.065
ends PM_HA\%noxref_14
