// File: HA.spi.pex
// Created: Tue Apr 29 10:42:37 2025
// Program "Calibre xRC"
// Version "v2023.2_27.15"
// Nominal Temperature: 30C
// Circuit Temperature: 30C
//
simulator lang=spectre
subckt PM_HA\%GND ( 1 29 33 36 41 49 52 57 61 83 87 90 95 99 107 115 121 127 \
 132 137 141 154 166 178 180 183 188 195 196 197 198 199 200 )
c249 ( 200 0 ) capacitor c=0.0583166f //x=15.415 //y=0.55
c250 ( 199 0 ) capacitor c=0.0210152f //x=12.58 //y=1.05
c251 ( 198 0 ) capacitor c=0.0210152f //x=9.25 //y=1.05
c252 ( 197 0 ) capacitor c=0.0572852f //x=6.535 //y=0.55
c253 ( 196 0 ) capacitor c=0.057872f //x=4.315 //y=0.55
c254 ( 195 0 ) capacitor c=0.0208198f //x=1.48 //y=1.045
c255 ( 188 0 ) capacitor c=0.248641f //x=16.51 //y=0.175
c256 ( 183 0 ) capacitor c=0.103738f //x=14.92 //y=0.175
c257 ( 182 0 ) capacitor c=0.0044644f //x=12.7 //y=0.18
c258 ( 180 0 ) capacitor c=0.104713f //x=11.59 //y=0.175
c259 ( 179 0 ) capacitor c=0.0044644f //x=9.44 //y=0.175
c260 ( 178 0 ) capacitor c=0.102511f //x=8.26 //y=0.175
c261 ( 166 0 ) capacitor c=0.0973645f //x=6.04 //y=0.175
c262 ( 154 0 ) capacitor c=0.101616f //x=3.82 //y=0.175
c263 ( 153 0 ) capacitor c=0.00446416f //x=1.67 //y=0.175
c264 ( 144 0 ) capacitor c=0.00592191f //x=16.51 //y=0.63
c265 ( 141 0 ) capacitor c=0.00644318f //x=16.425 //y=0.715
c266 ( 140 0 ) capacitor c=0.00479856f //x=16.025 //y=0.63
c267 ( 137 0 ) capacitor c=0.00531815f //x=15.94 //y=0.715
c268 ( 132 0 ) capacitor c=0.00587411f //x=15.54 //y=0.63
c269 ( 127 0 ) capacitor c=0.0161513f //x=15.455 //y=0.175
c270 ( 121 0 ) capacitor c=0.0729544f //x=14.75 //y=0.175
c271 ( 115 0 ) capacitor c=0.0392748f //x=12.685 //y=0.175
c272 ( 107 0 ) capacitor c=0.072938f //x=11.42 //y=0.175
c273 ( 99 0 ) capacitor c=0.0392748f //x=9.355 //y=0.175
c274 ( 96 0 ) capacitor c=0.0366794f //x=7.725 //y=0.175
c275 ( 95 0 ) capacitor c=0.0161513f //x=8.09 //y=0.175
c276 ( 90 0 ) capacitor c=0.00587411f //x=7.64 //y=0.63
c277 ( 87 0 ) capacitor c=0.00531778f //x=7.555 //y=0.715
c278 ( 86 0 ) capacitor c=0.00479856f //x=7.155 //y=0.63
c279 ( 83 0 ) capacitor c=0.00643449f //x=7.07 //y=0.715
c280 ( 78 0 ) capacitor c=0.00592191f //x=6.67 //y=0.63
c281 ( 73 0 ) capacitor c=0.0191899f //x=6.585 //y=0.175
c282 ( 70 0 ) capacitor c=0.036681f //x=5.505 //y=0.175
c283 ( 69 0 ) capacitor c=0.0186173f //x=5.87 //y=0.175
c284 ( 64 0 ) capacitor c=0.00583665f //x=5.42 //y=0.63
c285 ( 61 0 ) capacitor c=0.00536924f //x=5.335 //y=0.715
c286 ( 60 0 ) capacitor c=0.00479856f //x=4.935 //y=0.63
c287 ( 57 0 ) capacitor c=0.00640467f //x=4.85 //y=0.715
c288 ( 52 0 ) capacitor c=0.00588377f //x=4.45 //y=0.63
c289 ( 49 0 ) capacitor c=0.0166308f //x=4.365 //y=0.175
c290 ( 41 0 ) capacitor c=0.0729464f //x=3.65 //y=0.175
c291 ( 36 0 ) capacitor c=0.198174f //x=1.23 //y=0.18
c292 ( 33 0 ) capacitor c=0.0430284f //x=1.585 //y=0.175
c293 ( 29 0 ) capacitor c=0.602972f //x=16.4 //y=0.18
r294 (  187 188 ) resistor r=3.83651 //w=0.367 //l=0.11 //layer=li \
 //thickness=0.1 //x=16.4 //y=0.175 //x2=16.51 //y2=0.175
r295 (  185 187 ) resistor r=13.079 //w=0.367 //l=0.375 //layer=li \
 //thickness=0.1 //x=16.025 //y=0.175 //x2=16.4 //y2=0.175
r296 (  184 185 ) resistor r=16.9155 //w=0.367 //l=0.485 //layer=li \
 //thickness=0.1 //x=15.54 //y=0.175 //x2=16.025 //y2=0.175
r297 (  170 171 ) resistor r=4.18529 //w=0.367 //l=0.12 //layer=li \
 //thickness=0.1 //x=7.52 //y=0.175 //x2=7.64 //y2=0.175
r298 (  168 170 ) resistor r=12.7302 //w=0.367 //l=0.365 //layer=li \
 //thickness=0.1 //x=7.155 //y=0.175 //x2=7.52 //y2=0.175
r299 (  167 168 ) resistor r=16.9155 //w=0.367 //l=0.485 //layer=li \
 //thickness=0.1 //x=6.67 //y=0.175 //x2=7.155 //y2=0.175
r300 (  158 159 ) resistor r=16.9155 //w=0.367 //l=0.485 //layer=li \
 //thickness=0.1 //x=4.935 //y=0.175 //x2=5.42 //y2=0.175
r301 (  157 158 ) resistor r=0.174387 //w=0.367 //l=0.005 //layer=li \
 //thickness=0.1 //x=4.93 //y=0.175 //x2=4.935 //y2=0.175
r302 (  155 157 ) resistor r=16.7411 //w=0.367 //l=0.48 //layer=li \
 //thickness=0.1 //x=4.45 //y=0.175 //x2=4.93 //y2=0.175
r303 (  145 200 ) resistor r=5.4201 //w=0.17 //l=0.085 //layer=li \
 //thickness=0.1 //x=16.51 //y=0.8 //x2=16.51 //y2=0.715
r304 (  145 200 ) resistor r=41.4118 //w=0.187 //l=0.605 //layer=li \
 //thickness=0.1 //x=16.51 //y=0.8 //x2=16.51 //y2=1.405
r305 (  144 200 ) resistor r=5.4201 //w=0.17 //l=0.085 //layer=li \
 //thickness=0.1 //x=16.51 //y=0.63 //x2=16.51 //y2=0.715
r306 (  143 188 ) resistor r=5.21862 //w=0.35 //l=0.175 //layer=li \
 //thickness=0.1 //x=16.51 //y=0.35 //x2=16.51 //y2=0.175
r307 (  143 144 ) resistor r=19.1658 //w=0.187 //l=0.28 //layer=li \
 //thickness=0.1 //x=16.51 //y=0.35 //x2=16.51 //y2=0.63
r308 (  142 200 ) resistor r=5.4201 //w=0.17 //l=0.085 //layer=li \
 //thickness=0.1 //x=16.11 //y=0.715 //x2=16.025 //y2=0.715
r309 (  141 200 ) resistor r=1.40859 //w=0.34 //l=0.085 //layer=li \
 //thickness=0.1 //x=16.425 //y=0.715 //x2=16.51 //y2=0.715
r310 (  141 142 ) resistor r=21.5615 //w=0.187 //l=0.315 //layer=li \
 //thickness=0.1 //x=16.425 //y=0.715 //x2=16.11 //y2=0.715
r311 (  140 200 ) resistor r=1.40859 //w=0.34 //l=0.085 //layer=li \
 //thickness=0.1 //x=16.025 //y=0.63 //x2=16.025 //y2=0.715
r312 (  139 185 ) resistor r=5.21862 //w=0.35 //l=0.175 //layer=li \
 //thickness=0.1 //x=16.025 //y=0.35 //x2=16.025 //y2=0.175
r313 (  139 140 ) resistor r=19.1658 //w=0.187 //l=0.28 //layer=li \
 //thickness=0.1 //x=16.025 //y=0.35 //x2=16.025 //y2=0.63
r314 (  138 200 ) resistor r=1.40859 //w=0.34 //l=0.085 //layer=li \
 //thickness=0.1 //x=15.625 //y=0.715 //x2=15.54 //y2=0.715
r315 (  137 200 ) resistor r=5.4201 //w=0.17 //l=0.085 //layer=li \
 //thickness=0.1 //x=15.94 //y=0.715 //x2=16.025 //y2=0.715
r316 (  137 138 ) resistor r=21.5615 //w=0.187 //l=0.315 //layer=li \
 //thickness=0.1 //x=15.94 //y=0.715 //x2=15.625 //y2=0.715
r317 (  133 200 ) resistor r=5.4201 //w=0.17 //l=0.085 //layer=li \
 //thickness=0.1 //x=15.54 //y=0.8 //x2=15.54 //y2=0.715
r318 (  133 200 ) resistor r=41.4118 //w=0.187 //l=0.605 //layer=li \
 //thickness=0.1 //x=15.54 //y=0.8 //x2=15.54 //y2=1.405
r319 (  132 200 ) resistor r=5.4201 //w=0.17 //l=0.085 //layer=li \
 //thickness=0.1 //x=15.54 //y=0.63 //x2=15.54 //y2=0.715
r320 (  131 184 ) resistor r=5.21862 //w=0.35 //l=0.175 //layer=li \
 //thickness=0.1 //x=15.54 //y=0.35 //x2=15.54 //y2=0.175
r321 (  131 132 ) resistor r=19.1658 //w=0.187 //l=0.28 //layer=li \
 //thickness=0.1 //x=15.54 //y=0.35 //x2=15.54 //y2=0.63
r322 (  128 183 ) resistor r=5.29055 //w=0.35 //l=0.17 //layer=li \
 //thickness=0.1 //x=15.09 //y=0.175 //x2=14.92 //y2=0.175
r323 (  128 130 ) resistor r=6.97548 //w=0.367 //l=0.2 //layer=li \
 //thickness=0.1 //x=15.09 //y=0.175 //x2=15.29 //y2=0.175
r324 (  127 184 ) resistor r=2.96458 //w=0.367 //l=0.085 //layer=li \
 //thickness=0.1 //x=15.455 //y=0.175 //x2=15.54 //y2=0.175
r325 (  127 130 ) resistor r=5.75477 //w=0.367 //l=0.165 //layer=li \
 //thickness=0.1 //x=15.455 //y=0.175 //x2=15.29 //y2=0.175
r326 (  122 182 ) resistor r=2.87058 //w=0.35 //l=0.085 //layer=li \
 //thickness=0.1 //x=12.855 //y=0.175 //x2=12.77 //y2=0.175
r327 (  122 124 ) resistor r=33.3079 //w=0.367 //l=0.955 //layer=li \
 //thickness=0.1 //x=12.855 //y=0.175 //x2=13.81 //y2=0.175
r328 (  121 183 ) resistor r=5.29055 //w=0.35 //l=0.17 //layer=li \
 //thickness=0.1 //x=14.75 //y=0.175 //x2=14.92 //y2=0.175
r329 (  121 124 ) resistor r=32.7847 //w=0.367 //l=0.94 //layer=li \
 //thickness=0.1 //x=14.75 //y=0.175 //x2=13.81 //y2=0.175
r330 (  117 182 ) resistor r=4.23183 //w=0.7 //l=0.175 //layer=li \
 //thickness=0.1 //x=12.77 //y=0.35 //x2=12.77 //y2=0.175
r331 (  117 199 ) resistor r=54.0749 //w=0.187 //l=0.79 //layer=li \
 //thickness=0.1 //x=12.77 //y=0.35 //x2=12.77 //y2=1.14
r332 (  116 180 ) resistor r=5.29055 //w=0.35 //l=0.17 //layer=li \
 //thickness=0.1 //x=11.76 //y=0.175 //x2=11.59 //y2=0.175
r333 (  115 182 ) resistor r=2.87058 //w=0.35 //l=0.085 //layer=li \
 //thickness=0.1 //x=12.685 //y=0.175 //x2=12.77 //y2=0.175
r334 (  115 116 ) resistor r=32.2616 //w=0.367 //l=0.925 //layer=li \
 //thickness=0.1 //x=12.685 //y=0.175 //x2=11.76 //y2=0.175
r335 (  110 112 ) resistor r=38.7139 //w=0.367 //l=1.11 //layer=li \
 //thickness=0.1 //x=10.11 //y=0.175 //x2=11.22 //y2=0.175
r336 (  108 179 ) resistor r=2.87058 //w=0.35 //l=0.085 //layer=li \
 //thickness=0.1 //x=9.525 //y=0.175 //x2=9.44 //y2=0.175
r337 (  108 110 ) resistor r=20.4033 //w=0.367 //l=0.585 //layer=li \
 //thickness=0.1 //x=9.525 //y=0.175 //x2=10.11 //y2=0.175
r338 (  107 180 ) resistor r=5.29055 //w=0.35 //l=0.17 //layer=li \
 //thickness=0.1 //x=11.42 //y=0.175 //x2=11.59 //y2=0.175
r339 (  107 112 ) resistor r=6.97548 //w=0.367 //l=0.2 //layer=li \
 //thickness=0.1 //x=11.42 //y=0.175 //x2=11.22 //y2=0.175
r340 (  103 179 ) resistor r=4.23183 //w=0.7 //l=0.175 //layer=li \
 //thickness=0.1 //x=9.44 //y=0.35 //x2=9.44 //y2=0.175
r341 (  103 198 ) resistor r=54.0749 //w=0.187 //l=0.79 //layer=li \
 //thickness=0.1 //x=9.44 //y=0.35 //x2=9.44 //y2=1.14
r342 (  100 178 ) resistor r=5.29055 //w=0.35 //l=0.17 //layer=li \
 //thickness=0.1 //x=8.43 //y=0.175 //x2=8.26 //y2=0.175
r343 (  100 102 ) resistor r=19.8801 //w=0.367 //l=0.57 //layer=li \
 //thickness=0.1 //x=8.43 //y=0.175 //x2=9 //y2=0.175
r344 (  99 179 ) resistor r=2.87058 //w=0.35 //l=0.085 //layer=li \
 //thickness=0.1 //x=9.355 //y=0.175 //x2=9.44 //y2=0.175
r345 (  99 102 ) resistor r=12.3815 //w=0.367 //l=0.355 //layer=li \
 //thickness=0.1 //x=9.355 //y=0.175 //x2=9 //y2=0.175
r346 (  96 171 ) resistor r=2.96458 //w=0.367 //l=0.085 //layer=li \
 //thickness=0.1 //x=7.725 //y=0.175 //x2=7.64 //y2=0.175
r347 (  95 178 ) resistor r=5.29055 //w=0.35 //l=0.17 //layer=li \
 //thickness=0.1 //x=8.09 //y=0.175 //x2=8.26 //y2=0.175
r348 (  95 96 ) resistor r=12.7302 //w=0.367 //l=0.365 //layer=li \
 //thickness=0.1 //x=8.09 //y=0.175 //x2=7.725 //y2=0.175
r349 (  91 197 ) resistor r=5.4201 //w=0.17 //l=0.085 //layer=li \
 //thickness=0.1 //x=7.64 //y=0.8 //x2=7.64 //y2=0.715
r350 (  91 197 ) resistor r=41.4118 //w=0.187 //l=0.605 //layer=li \
 //thickness=0.1 //x=7.64 //y=0.8 //x2=7.64 //y2=1.405
r351 (  90 197 ) resistor r=5.4201 //w=0.17 //l=0.085 //layer=li \
 //thickness=0.1 //x=7.64 //y=0.63 //x2=7.64 //y2=0.715
r352 (  89 171 ) resistor r=5.21862 //w=0.35 //l=0.175 //layer=li \
 //thickness=0.1 //x=7.64 //y=0.35 //x2=7.64 //y2=0.175
r353 (  89 90 ) resistor r=19.1658 //w=0.187 //l=0.28 //layer=li \
 //thickness=0.1 //x=7.64 //y=0.35 //x2=7.64 //y2=0.63
r354 (  88 197 ) resistor r=5.4201 //w=0.17 //l=0.085 //layer=li \
 //thickness=0.1 //x=7.24 //y=0.715 //x2=7.155 //y2=0.715
r355 (  87 197 ) resistor r=1.40859 //w=0.34 //l=0.085 //layer=li \
 //thickness=0.1 //x=7.555 //y=0.715 //x2=7.64 //y2=0.715
r356 (  87 88 ) resistor r=21.5615 //w=0.187 //l=0.315 //layer=li \
 //thickness=0.1 //x=7.555 //y=0.715 //x2=7.24 //y2=0.715
r357 (  86 197 ) resistor r=1.40859 //w=0.34 //l=0.085 //layer=li \
 //thickness=0.1 //x=7.155 //y=0.63 //x2=7.155 //y2=0.715
r358 (  85 168 ) resistor r=5.21862 //w=0.35 //l=0.175 //layer=li \
 //thickness=0.1 //x=7.155 //y=0.35 //x2=7.155 //y2=0.175
r359 (  85 86 ) resistor r=19.1658 //w=0.187 //l=0.28 //layer=li \
 //thickness=0.1 //x=7.155 //y=0.35 //x2=7.155 //y2=0.63
r360 (  84 197 ) resistor r=1.40859 //w=0.34 //l=0.085 //layer=li \
 //thickness=0.1 //x=6.755 //y=0.715 //x2=6.67 //y2=0.715
r361 (  83 197 ) resistor r=5.4201 //w=0.17 //l=0.085 //layer=li \
 //thickness=0.1 //x=7.07 //y=0.715 //x2=7.155 //y2=0.715
r362 (  83 84 ) resistor r=21.5615 //w=0.187 //l=0.315 //layer=li \
 //thickness=0.1 //x=7.07 //y=0.715 //x2=6.755 //y2=0.715
r363 (  79 197 ) resistor r=5.4201 //w=0.17 //l=0.085 //layer=li \
 //thickness=0.1 //x=6.67 //y=0.8 //x2=6.67 //y2=0.715
r364 (  79 197 ) resistor r=41.4118 //w=0.187 //l=0.605 //layer=li \
 //thickness=0.1 //x=6.67 //y=0.8 //x2=6.67 //y2=1.405
r365 (  78 197 ) resistor r=5.4201 //w=0.17 //l=0.085 //layer=li \
 //thickness=0.1 //x=6.67 //y=0.63 //x2=6.67 //y2=0.715
r366 (  77 167 ) resistor r=5.21862 //w=0.35 //l=0.175 //layer=li \
 //thickness=0.1 //x=6.67 //y=0.35 //x2=6.67 //y2=0.175
r367 (  77 78 ) resistor r=19.1658 //w=0.187 //l=0.28 //layer=li \
 //thickness=0.1 //x=6.67 //y=0.35 //x2=6.67 //y2=0.63
r368 (  74 166 ) resistor r=5.29055 //w=0.35 //l=0.17 //layer=li \
 //thickness=0.1 //x=6.21 //y=0.175 //x2=6.04 //y2=0.175
r369 (  74 76 ) resistor r=6.97548 //w=0.367 //l=0.2 //layer=li \
 //thickness=0.1 //x=6.21 //y=0.175 //x2=6.41 //y2=0.175
r370 (  73 167 ) resistor r=2.96458 //w=0.367 //l=0.085 //layer=li \
 //thickness=0.1 //x=6.585 //y=0.175 //x2=6.67 //y2=0.175
r371 (  73 76 ) resistor r=6.10354 //w=0.367 //l=0.175 //layer=li \
 //thickness=0.1 //x=6.585 //y=0.175 //x2=6.41 //y2=0.175
r372 (  70 159 ) resistor r=2.96458 //w=0.367 //l=0.085 //layer=li \
 //thickness=0.1 //x=5.505 //y=0.175 //x2=5.42 //y2=0.175
r373 (  69 166 ) resistor r=5.29055 //w=0.35 //l=0.17 //layer=li \
 //thickness=0.1 //x=5.87 //y=0.175 //x2=6.04 //y2=0.175
r374 (  69 70 ) resistor r=12.7302 //w=0.367 //l=0.365 //layer=li \
 //thickness=0.1 //x=5.87 //y=0.175 //x2=5.505 //y2=0.175
r375 (  65 196 ) resistor r=5.4201 //w=0.17 //l=0.085 //layer=li \
 //thickness=0.1 //x=5.42 //y=0.8 //x2=5.42 //y2=0.715
r376 (  65 196 ) resistor r=41.4118 //w=0.187 //l=0.605 //layer=li \
 //thickness=0.1 //x=5.42 //y=0.8 //x2=5.42 //y2=1.405
r377 (  64 196 ) resistor r=5.4201 //w=0.17 //l=0.085 //layer=li \
 //thickness=0.1 //x=5.42 //y=0.63 //x2=5.42 //y2=0.715
r378 (  63 159 ) resistor r=5.21862 //w=0.35 //l=0.175 //layer=li \
 //thickness=0.1 //x=5.42 //y=0.35 //x2=5.42 //y2=0.175
r379 (  63 64 ) resistor r=19.1658 //w=0.187 //l=0.28 //layer=li \
 //thickness=0.1 //x=5.42 //y=0.35 //x2=5.42 //y2=0.63
r380 (  62 196 ) resistor r=5.4201 //w=0.17 //l=0.085 //layer=li \
 //thickness=0.1 //x=5.02 //y=0.715 //x2=4.935 //y2=0.715
r381 (  61 196 ) resistor r=1.40859 //w=0.34 //l=0.085 //layer=li \
 //thickness=0.1 //x=5.335 //y=0.715 //x2=5.42 //y2=0.715
r382 (  61 62 ) resistor r=21.5615 //w=0.187 //l=0.315 //layer=li \
 //thickness=0.1 //x=5.335 //y=0.715 //x2=5.02 //y2=0.715
r383 (  60 196 ) resistor r=1.40859 //w=0.34 //l=0.085 //layer=li \
 //thickness=0.1 //x=4.935 //y=0.63 //x2=4.935 //y2=0.715
r384 (  59 158 ) resistor r=5.21862 //w=0.35 //l=0.175 //layer=li \
 //thickness=0.1 //x=4.935 //y=0.35 //x2=4.935 //y2=0.175
r385 (  59 60 ) resistor r=19.1658 //w=0.187 //l=0.28 //layer=li \
 //thickness=0.1 //x=4.935 //y=0.35 //x2=4.935 //y2=0.63
r386 (  58 196 ) resistor r=1.40859 //w=0.34 //l=0.085 //layer=li \
 //thickness=0.1 //x=4.535 //y=0.715 //x2=4.45 //y2=0.715
r387 (  57 196 ) resistor r=5.4201 //w=0.17 //l=0.085 //layer=li \
 //thickness=0.1 //x=4.85 //y=0.715 //x2=4.935 //y2=0.715
r388 (  57 58 ) resistor r=21.5615 //w=0.187 //l=0.315 //layer=li \
 //thickness=0.1 //x=4.85 //y=0.715 //x2=4.535 //y2=0.715
r389 (  53 196 ) resistor r=5.4201 //w=0.17 //l=0.085 //layer=li \
 //thickness=0.1 //x=4.45 //y=0.8 //x2=4.45 //y2=0.715
r390 (  53 196 ) resistor r=41.4118 //w=0.187 //l=0.605 //layer=li \
 //thickness=0.1 //x=4.45 //y=0.8 //x2=4.45 //y2=1.405
r391 (  52 196 ) resistor r=5.4201 //w=0.17 //l=0.085 //layer=li \
 //thickness=0.1 //x=4.45 //y=0.63 //x2=4.45 //y2=0.715
r392 (  51 155 ) resistor r=5.21862 //w=0.35 //l=0.175 //layer=li \
 //thickness=0.1 //x=4.45 //y=0.35 //x2=4.45 //y2=0.175
r393 (  51 52 ) resistor r=19.1658 //w=0.187 //l=0.28 //layer=li \
 //thickness=0.1 //x=4.45 //y=0.35 //x2=4.45 //y2=0.63
r394 (  50 154 ) resistor r=5.29055 //w=0.35 //l=0.17 //layer=li \
 //thickness=0.1 //x=3.99 //y=0.175 //x2=3.82 //y2=0.175
r395 (  49 155 ) resistor r=2.96458 //w=0.367 //l=0.085 //layer=li \
 //thickness=0.1 //x=4.365 //y=0.175 //x2=4.45 //y2=0.175
r396 (  49 50 ) resistor r=13.079 //w=0.367 //l=0.375 //layer=li \
 //thickness=0.1 //x=4.365 //y=0.175 //x2=3.99 //y2=0.175
r397 (  44 46 ) resistor r=38.7139 //w=0.367 //l=1.11 //layer=li \
 //thickness=0.1 //x=2.34 //y=0.175 //x2=3.45 //y2=0.175
r398 (  42 153 ) resistor r=2.87058 //w=0.35 //l=0.085 //layer=li \
 //thickness=0.1 //x=1.755 //y=0.175 //x2=1.67 //y2=0.175
r399 (  42 44 ) resistor r=20.4033 //w=0.367 //l=0.585 //layer=li \
 //thickness=0.1 //x=1.755 //y=0.175 //x2=2.34 //y2=0.175
r400 (  41 154 ) resistor r=5.29055 //w=0.35 //l=0.17 //layer=li \
 //thickness=0.1 //x=3.65 //y=0.175 //x2=3.82 //y2=0.175
r401 (  41 46 ) resistor r=6.97548 //w=0.367 //l=0.2 //layer=li \
 //thickness=0.1 //x=3.65 //y=0.175 //x2=3.45 //y2=0.175
r402 (  37 153 ) resistor r=4.23183 //w=0.7 //l=0.175 //layer=li \
 //thickness=0.1 //x=1.67 //y=0.35 //x2=1.67 //y2=0.175
r403 (  37 195 ) resistor r=53.7326 //w=0.187 //l=0.785 //layer=li \
 //thickness=0.1 //x=1.67 //y=0.35 //x2=1.67 //y2=1.135
r404 (  33 153 ) resistor r=2.87058 //w=0.35 //l=0.085 //layer=li \
 //thickness=0.1 //x=1.585 //y=0.175 //x2=1.67 //y2=0.175
r405 (  33 36 ) resistor r=12.3815 //w=0.367 //l=0.355 //layer=li \
 //thickness=0.1 //x=1.585 //y=0.175 //x2=1.23 //y2=0.175
r406 (  29 187 ) resistor r=3.1 //w=0.17 //l=0.51 //layer=mcon //count=3 \
 //x=16.4 //y=0.18 //x2=16.4 //y2=0.18
r407 (  27 130 ) resistor r=3.1 //w=0.17 //l=0.51 //layer=mcon //count=3 \
 //x=15.29 //y=0.18 //x2=15.29 //y2=0.18
r408 (  27 29 ) resistor r=0.446141 //w=0.311 //l=1.11 //layer=m1 \
 //thickness=0.36 //x=15.29 //y=0.175 //x2=16.4 //y2=0.175
r409 (  25 124 ) resistor r=3.1 //w=0.17 //l=0.51 //layer=mcon //count=3 \
 //x=13.81 //y=0.18 //x2=13.81 //y2=0.18
r410 (  25 27 ) resistor r=0.594855 //w=0.311 //l=1.48 //layer=m1 \
 //thickness=0.36 //x=13.81 //y=0.175 //x2=15.29 //y2=0.175
r411 (  23 182 ) resistor r=3.1 //w=0.17 //l=0.51 //layer=mcon //count=3 \
 //x=12.7 //y=0.18 //x2=12.7 //y2=0.18
r412 (  23 25 ) resistor r=0.446141 //w=0.311 //l=1.11 //layer=m1 \
 //thickness=0.36 //x=12.7 //y=0.175 //x2=13.81 //y2=0.175
r413 (  21 112 ) resistor r=3.1 //w=0.17 //l=0.51 //layer=mcon //count=3 \
 //x=11.22 //y=0.18 //x2=11.22 //y2=0.18
r414 (  21 23 ) resistor r=0.594855 //w=0.311 //l=1.48 //layer=m1 \
 //thickness=0.36 //x=11.22 //y=0.175 //x2=12.7 //y2=0.175
r415 (  19 110 ) resistor r=3.1 //w=0.17 //l=0.51 //layer=mcon //count=3 \
 //x=10.11 //y=0.18 //x2=10.11 //y2=0.18
r416 (  19 21 ) resistor r=0.446141 //w=0.311 //l=1.11 //layer=m1 \
 //thickness=0.36 //x=10.11 //y=0.175 //x2=11.22 //y2=0.175
r417 (  17 102 ) resistor r=3.1 //w=0.17 //l=0.51 //layer=mcon //count=3 //x=9 \
 //y=0.18 //x2=9 //y2=0.18
r418 (  17 19 ) resistor r=0.446141 //w=0.311 //l=1.11 //layer=m1 \
 //thickness=0.36 //x=9 //y=0.175 //x2=10.11 //y2=0.175
r419 (  14 170 ) resistor r=3.1 //w=0.17 //l=0.51 //layer=mcon //count=3 \
 //x=7.52 //y=0.18 //x2=7.52 //y2=0.18
r420 (  12 76 ) resistor r=3.1 //w=0.17 //l=0.51 //layer=mcon //count=3 \
 //x=6.41 //y=0.18 //x2=6.41 //y2=0.18
r421 (  12 14 ) resistor r=0.446141 //w=0.311 //l=1.11 //layer=m1 \
 //thickness=0.36 //x=6.41 //y=0.175 //x2=7.52 //y2=0.175
r422 (  10 157 ) resistor r=3.1 //w=0.17 //l=0.51 //layer=mcon //count=3 \
 //x=4.93 //y=0.18 //x2=4.93 //y2=0.18
r423 (  10 12 ) resistor r=0.594855 //w=0.311 //l=1.48 //layer=m1 \
 //thickness=0.36 //x=4.93 //y=0.175 //x2=6.41 //y2=0.175
r424 (  8 46 ) resistor r=3.1 //w=0.17 //l=0.51 //layer=mcon //count=3 \
 //x=3.45 //y=0.18 //x2=3.45 //y2=0.18
r425 (  8 10 ) resistor r=0.594855 //w=0.311 //l=1.48 //layer=m1 \
 //thickness=0.36 //x=3.45 //y=0.175 //x2=4.93 //y2=0.175
r426 (  6 44 ) resistor r=3.1 //w=0.17 //l=0.51 //layer=mcon //count=3 \
 //x=2.34 //y=0.18 //x2=2.34 //y2=0.18
r427 (  6 8 ) resistor r=0.446141 //w=0.311 //l=1.11 //layer=m1 \
 //thickness=0.36 //x=2.34 //y=0.175 //x2=3.45 //y2=0.175
r428 (  3 36 ) resistor r=3.1 //w=0.17 //l=0.51 //layer=mcon //count=3 \
 //x=1.23 //y=0.18 //x2=1.23 //y2=0.18
r429 (  3 6 ) resistor r=0.446141 //w=0.311 //l=1.11 //layer=m1 \
 //thickness=0.36 //x=1.23 //y=0.175 //x2=2.34 //y2=0.175
r430 (  1 17 ) resistor r=0.0743569 //w=0.311 //l=0.185 //layer=m1 \
 //thickness=0.36 //x=8.815 //y=0.175 //x2=9 //y2=0.175
r431 (  1 14 ) resistor r=0.520498 //w=0.311 //l=1.295 //layer=m1 \
 //thickness=0.36 //x=8.815 //y=0.175 //x2=7.52 //y2=0.175
ends PM_HA\%GND

subckt PM_HA\%VDD ( 1 29 41 49 59 65 73 83 87 97 105 109 117 125 133 139 149 \
 162 165 168 172 174 176 179 180 181 182 183 184 185 186 187 188 189 190 )
c238 ( 190 0 ) capacitor c=0.0420686f //x=16.32 //y=5.2
c239 ( 189 0 ) capacitor c=0.0433635f //x=15.46 //y=5.2
c240 ( 188 0 ) capacitor c=0.0266033f //x=12.675 //y=5.2
c241 ( 187 0 ) capacitor c=0.0265043f //x=9.345 //y=5.2
c242 ( 186 0 ) capacitor c=0.0432965f //x=7.45 //y=5.2
c243 ( 185 0 ) capacitor c=0.0420334f //x=6.58 //y=5.2
c244 ( 184 0 ) capacitor c=0.0432965f //x=5.23 //y=5.2
c245 ( 183 0 ) capacitor c=0.0422219f //x=4.36 //y=5.2
c246 ( 182 0 ) capacitor c=0.0381506f //x=2.895 //y=5.2
c247 ( 181 0 ) capacitor c=0.0240879f //x=2.015 //y=5.2
c248 ( 180 0 ) capacitor c=0.0531988f //x=1.145 //y=5.2
c249 ( 179 0 ) capacitor c=0.251447f //x=16.4 //y=7.58
c250 ( 177 0 ) capacitor c=0.00597439f //x=15.585 //y=7.585
c251 ( 176 0 ) capacitor c=0.105826f //x=14.92 //y=7.585
c252 ( 175 0 ) capacitor c=0.00597439f //x=12.82 //y=7.585
c253 ( 174 0 ) capacitor c=0.110229f //x=11.59 //y=7.585
c254 ( 173 0 ) capacitor c=0.00597439f //x=9.49 //y=7.585
c255 ( 172 0 ) capacitor c=0.110825f //x=8.26 //y=7.585
c256 ( 171 0 ) capacitor c=0.00597439f //x=7.52 //y=7.58
c257 ( 169 0 ) capacitor c=0.00597439f //x=6.715 //y=7.585
c258 ( 168 0 ) capacitor c=0.105724f //x=6.04 //y=7.585
c259 ( 167 0 ) capacitor c=0.00597439f //x=5.375 //y=7.585
c260 ( 166 0 ) capacitor c=0.00597439f //x=4.495 //y=7.585
c261 ( 165 0 ) capacitor c=0.108239f //x=3.82 //y=7.585
c262 ( 164 0 ) capacitor c=0.00597439f //x=3.04 //y=7.585
c263 ( 163 0 ) capacitor c=0.00597439f //x=2.16 //y=7.585
c264 ( 162 0 ) capacitor c=0.26712f //x=1.23 //y=7.58
c265 ( 149 0 ) capacitor c=0.029202f //x=16.38 //y=7.585
c266 ( 139 0 ) capacitor c=0.0183091f //x=15.5 //y=7.585
c267 ( 133 0 ) capacitor c=0.075456f //x=14.75 //y=7.585
c268 ( 125 0 ) capacitor c=0.0432358f //x=12.735 //y=7.585
c269 ( 117 0 ) capacitor c=0.0757906f //x=11.42 //y=7.585
c270 ( 109 0 ) capacitor c=0.0432541f //x=9.405 //y=7.585
c271 ( 105 0 ) capacitor c=0.0183091f //x=8.09 //y=7.585
c272 ( 97 0 ) capacitor c=0.0293728f //x=7.51 //y=7.585
c273 ( 87 0 ) capacitor c=0.0187886f //x=6.63 //y=7.585
c274 ( 83 0 ) capacitor c=0.0183091f //x=5.87 //y=7.585
c275 ( 73 0 ) capacitor c=0.0292288f //x=5.29 //y=7.585
c276 ( 65 0 ) capacitor c=0.0187886f //x=4.41 //y=7.585
c277 ( 59 0 ) capacitor c=0.0238235f //x=3.65 //y=7.585
c278 ( 49 0 ) capacitor c=0.0291288f //x=2.955 //y=7.585
c279 ( 41 0 ) capacitor c=0.0292208f //x=2.075 //y=7.585
c280 ( 29 0 ) capacitor c=0.617351f //x=16.4 //y=7.58
r281 (  151 179 ) resistor r=4.23183 //w=0.7 //l=0.175 //layer=li \
 //thickness=0.1 //x=16.465 //y=7.41 //x2=16.465 //y2=7.585
r282 (  151 190 ) resistor r=56.4706 //w=0.187 //l=0.825 //layer=li \
 //thickness=0.1 //x=16.465 //y=7.41 //x2=16.465 //y2=6.585
r283 (  150 177 ) resistor r=2.87058 //w=0.35 //l=0.085 //layer=li \
 //thickness=0.1 //x=15.67 //y=7.585 //x2=15.585 //y2=7.585
r284 (  149 179 ) resistor r=2.87058 //w=0.35 //l=0.085 //layer=li \
 //thickness=0.1 //x=16.38 //y=7.585 //x2=16.465 //y2=7.585
r285 (  149 150 ) resistor r=24.7629 //w=0.367 //l=0.71 //layer=li \
 //thickness=0.1 //x=16.38 //y=7.585 //x2=15.67 //y2=7.585
r286 (  143 177 ) resistor r=4.23183 //w=0.7 //l=0.175 //layer=li \
 //thickness=0.1 //x=15.585 //y=7.41 //x2=15.585 //y2=7.585
r287 (  143 189 ) resistor r=56.4706 //w=0.187 //l=0.825 //layer=li \
 //thickness=0.1 //x=15.585 //y=7.41 //x2=15.585 //y2=6.585
r288 (  140 176 ) resistor r=5.29055 //w=0.35 //l=0.17 //layer=li \
 //thickness=0.1 //x=15.09 //y=7.585 //x2=14.92 //y2=7.585
r289 (  140 142 ) resistor r=6.97548 //w=0.367 //l=0.2 //layer=li \
 //thickness=0.1 //x=15.09 //y=7.585 //x2=15.29 //y2=7.585
r290 (  139 177 ) resistor r=2.87058 //w=0.35 //l=0.085 //layer=li \
 //thickness=0.1 //x=15.5 //y=7.585 //x2=15.585 //y2=7.585
r291 (  139 142 ) resistor r=7.32425 //w=0.367 //l=0.21 //layer=li \
 //thickness=0.1 //x=15.5 //y=7.585 //x2=15.29 //y2=7.585
r292 (  134 175 ) resistor r=2.87058 //w=0.35 //l=0.085 //layer=li \
 //thickness=0.1 //x=12.905 //y=7.585 //x2=12.82 //y2=7.585
r293 (  134 136 ) resistor r=31.564 //w=0.367 //l=0.905 //layer=li \
 //thickness=0.1 //x=12.905 //y=7.585 //x2=13.81 //y2=7.585
r294 (  133 176 ) resistor r=5.29055 //w=0.35 //l=0.17 //layer=li \
 //thickness=0.1 //x=14.75 //y=7.585 //x2=14.92 //y2=7.585
r295 (  133 136 ) resistor r=32.7847 //w=0.367 //l=0.94 //layer=li \
 //thickness=0.1 //x=14.75 //y=7.585 //x2=13.81 //y2=7.585
r296 (  129 175 ) resistor r=4.23183 //w=0.7 //l=0.175 //layer=li \
 //thickness=0.1 //x=12.82 //y=7.41 //x2=12.82 //y2=7.585
r297 (  129 188 ) resistor r=80.4278 //w=0.187 //l=1.175 //layer=li \
 //thickness=0.1 //x=12.82 //y=7.41 //x2=12.82 //y2=6.235
r298 (  126 174 ) resistor r=5.29055 //w=0.35 //l=0.17 //layer=li \
 //thickness=0.1 //x=11.76 //y=7.585 //x2=11.59 //y2=7.585
r299 (  126 128 ) resistor r=32.7847 //w=0.367 //l=0.94 //layer=li \
 //thickness=0.1 //x=11.76 //y=7.585 //x2=12.7 //y2=7.585
r300 (  125 175 ) resistor r=2.87058 //w=0.35 //l=0.085 //layer=li \
 //thickness=0.1 //x=12.735 //y=7.585 //x2=12.82 //y2=7.585
r301 (  125 128 ) resistor r=1.22071 //w=0.367 //l=0.035 //layer=li \
 //thickness=0.1 //x=12.735 //y=7.585 //x2=12.7 //y2=7.585
r302 (  120 122 ) resistor r=38.7139 //w=0.367 //l=1.11 //layer=li \
 //thickness=0.1 //x=10.11 //y=7.585 //x2=11.22 //y2=7.585
r303 (  118 173 ) resistor r=2.87058 //w=0.35 //l=0.085 //layer=li \
 //thickness=0.1 //x=9.575 //y=7.585 //x2=9.49 //y2=7.585
r304 (  118 120 ) resistor r=18.6594 //w=0.367 //l=0.535 //layer=li \
 //thickness=0.1 //x=9.575 //y=7.585 //x2=10.11 //y2=7.585
r305 (  117 174 ) resistor r=5.29055 //w=0.35 //l=0.17 //layer=li \
 //thickness=0.1 //x=11.42 //y=7.585 //x2=11.59 //y2=7.585
r306 (  117 122 ) resistor r=6.97548 //w=0.367 //l=0.2 //layer=li \
 //thickness=0.1 //x=11.42 //y=7.585 //x2=11.22 //y2=7.585
r307 (  113 173 ) resistor r=4.23183 //w=0.7 //l=0.175 //layer=li \
 //thickness=0.1 //x=9.49 //y=7.41 //x2=9.49 //y2=7.585
r308 (  113 187 ) resistor r=80.4278 //w=0.187 //l=1.175 //layer=li \
 //thickness=0.1 //x=9.49 //y=7.41 //x2=9.49 //y2=6.235
r309 (  110 172 ) resistor r=5.29055 //w=0.35 //l=0.17 //layer=li \
 //thickness=0.1 //x=8.43 //y=7.585 //x2=8.26 //y2=7.585
r310 (  110 112 ) resistor r=19.8801 //w=0.367 //l=0.57 //layer=li \
 //thickness=0.1 //x=8.43 //y=7.585 //x2=9 //y2=7.585
r311 (  109 173 ) resistor r=2.87058 //w=0.35 //l=0.085 //layer=li \
 //thickness=0.1 //x=9.405 //y=7.585 //x2=9.49 //y2=7.585
r312 (  109 112 ) resistor r=14.1253 //w=0.367 //l=0.405 //layer=li \
 //thickness=0.1 //x=9.405 //y=7.585 //x2=9 //y2=7.585
r313 (  106 171 ) resistor r=2.87058 //w=0.35 //l=0.085 //layer=li \
 //thickness=0.1 //x=7.68 //y=7.585 //x2=7.595 //y2=7.585
r314 (  105 172 ) resistor r=5.29055 //w=0.35 //l=0.17 //layer=li \
 //thickness=0.1 //x=8.09 //y=7.585 //x2=8.26 //y2=7.585
r315 (  105 106 ) resistor r=14.2997 //w=0.367 //l=0.41 //layer=li \
 //thickness=0.1 //x=8.09 //y=7.585 //x2=7.68 //y2=7.585
r316 (  99 171 ) resistor r=4.23183 //w=0.7 //l=0.175 //layer=li \
 //thickness=0.1 //x=7.595 //y=7.41 //x2=7.595 //y2=7.585
r317 (  99 186 ) resistor r=56.4706 //w=0.187 //l=0.825 //layer=li \
 //thickness=0.1 //x=7.595 //y=7.41 //x2=7.595 //y2=6.585
r318 (  98 169 ) resistor r=2.87058 //w=0.35 //l=0.085 //layer=li \
 //thickness=0.1 //x=6.8 //y=7.585 //x2=6.715 //y2=7.585
r319 (  97 171 ) resistor r=2.87058 //w=0.35 //l=0.085 //layer=li \
 //thickness=0.1 //x=7.51 //y=7.585 //x2=7.595 //y2=7.585
r320 (  97 98 ) resistor r=24.7629 //w=0.367 //l=0.71 //layer=li \
 //thickness=0.1 //x=7.51 //y=7.585 //x2=6.8 //y2=7.585
r321 (  91 169 ) resistor r=4.23183 //w=0.7 //l=0.175 //layer=li \
 //thickness=0.1 //x=6.715 //y=7.41 //x2=6.715 //y2=7.585
r322 (  91 185 ) resistor r=56.4706 //w=0.187 //l=0.825 //layer=li \
 //thickness=0.1 //x=6.715 //y=7.41 //x2=6.715 //y2=6.585
r323 (  88 168 ) resistor r=5.29055 //w=0.35 //l=0.17 //layer=li \
 //thickness=0.1 //x=6.21 //y=7.585 //x2=6.04 //y2=7.585
r324 (  88 90 ) resistor r=6.97548 //w=0.367 //l=0.2 //layer=li \
 //thickness=0.1 //x=6.21 //y=7.585 //x2=6.41 //y2=7.585
r325 (  87 169 ) resistor r=2.87058 //w=0.35 //l=0.085 //layer=li \
 //thickness=0.1 //x=6.63 //y=7.585 //x2=6.715 //y2=7.585
r326 (  87 90 ) resistor r=7.67302 //w=0.367 //l=0.22 //layer=li \
 //thickness=0.1 //x=6.63 //y=7.585 //x2=6.41 //y2=7.585
r327 (  84 167 ) resistor r=2.87058 //w=0.35 //l=0.085 //layer=li \
 //thickness=0.1 //x=5.46 //y=7.585 //x2=5.375 //y2=7.585
r328 (  83 168 ) resistor r=5.29055 //w=0.35 //l=0.17 //layer=li \
 //thickness=0.1 //x=5.87 //y=7.585 //x2=6.04 //y2=7.585
r329 (  83 84 ) resistor r=14.2997 //w=0.367 //l=0.41 //layer=li \
 //thickness=0.1 //x=5.87 //y=7.585 //x2=5.46 //y2=7.585
r330 (  77 167 ) resistor r=4.23183 //w=0.7 //l=0.175 //layer=li \
 //thickness=0.1 //x=5.375 //y=7.41 //x2=5.375 //y2=7.585
r331 (  77 184 ) resistor r=56.4706 //w=0.187 //l=0.825 //layer=li \
 //thickness=0.1 //x=5.375 //y=7.41 //x2=5.375 //y2=6.585
r332 (  74 166 ) resistor r=2.87058 //w=0.35 //l=0.085 //layer=li \
 //thickness=0.1 //x=4.58 //y=7.585 //x2=4.495 //y2=7.585
r333 (  74 76 ) resistor r=12.2071 //w=0.367 //l=0.35 //layer=li \
 //thickness=0.1 //x=4.58 //y=7.585 //x2=4.93 //y2=7.585
r334 (  73 167 ) resistor r=2.87058 //w=0.35 //l=0.085 //layer=li \
 //thickness=0.1 //x=5.29 //y=7.585 //x2=5.375 //y2=7.585
r335 (  73 76 ) resistor r=12.5559 //w=0.367 //l=0.36 //layer=li \
 //thickness=0.1 //x=5.29 //y=7.585 //x2=4.93 //y2=7.585
r336 (  67 166 ) resistor r=4.23183 //w=0.7 //l=0.175 //layer=li \
 //thickness=0.1 //x=4.495 //y=7.41 //x2=4.495 //y2=7.585
r337 (  67 183 ) resistor r=56.4706 //w=0.187 //l=0.825 //layer=li \
 //thickness=0.1 //x=4.495 //y=7.41 //x2=4.495 //y2=6.585
r338 (  66 165 ) resistor r=5.29055 //w=0.35 //l=0.17 //layer=li \
 //thickness=0.1 //x=3.99 //y=7.585 //x2=3.82 //y2=7.585
r339 (  65 166 ) resistor r=2.87058 //w=0.35 //l=0.085 //layer=li \
 //thickness=0.1 //x=4.41 //y=7.585 //x2=4.495 //y2=7.585
r340 (  65 66 ) resistor r=14.6485 //w=0.367 //l=0.42 //layer=li \
 //thickness=0.1 //x=4.41 //y=7.585 //x2=3.99 //y2=7.585
r341 (  60 164 ) resistor r=2.87058 //w=0.35 //l=0.085 //layer=li \
 //thickness=0.1 //x=3.125 //y=7.585 //x2=3.04 //y2=7.585
r342 (  60 62 ) resistor r=11.3351 //w=0.367 //l=0.325 //layer=li \
 //thickness=0.1 //x=3.125 //y=7.585 //x2=3.45 //y2=7.585
r343 (  59 165 ) resistor r=5.29055 //w=0.35 //l=0.17 //layer=li \
 //thickness=0.1 //x=3.65 //y=7.585 //x2=3.82 //y2=7.585
r344 (  59 62 ) resistor r=6.97548 //w=0.367 //l=0.2 //layer=li \
 //thickness=0.1 //x=3.65 //y=7.585 //x2=3.45 //y2=7.585
r345 (  53 164 ) resistor r=4.23183 //w=0.7 //l=0.175 //layer=li \
 //thickness=0.1 //x=3.04 //y=7.41 //x2=3.04 //y2=7.585
r346 (  53 182 ) resistor r=33.1979 //w=0.187 //l=0.485 //layer=li \
 //thickness=0.1 //x=3.04 //y=7.41 //x2=3.04 //y2=6.925
r347 (  50 163 ) resistor r=2.87058 //w=0.35 //l=0.085 //layer=li \
 //thickness=0.1 //x=2.245 //y=7.585 //x2=2.16 //y2=7.585
r348 (  50 52 ) resistor r=3.31335 //w=0.367 //l=0.095 //layer=li \
 //thickness=0.1 //x=2.245 //y=7.585 //x2=2.34 //y2=7.585
r349 (  49 164 ) resistor r=2.87058 //w=0.35 //l=0.085 //layer=li \
 //thickness=0.1 //x=2.955 //y=7.585 //x2=3.04 //y2=7.585
r350 (  49 52 ) resistor r=21.4496 //w=0.367 //l=0.615 //layer=li \
 //thickness=0.1 //x=2.955 //y=7.585 //x2=2.34 //y2=7.585
r351 (  43 163 ) resistor r=4.23183 //w=0.7 //l=0.175 //layer=li \
 //thickness=0.1 //x=2.16 //y=7.41 //x2=2.16 //y2=7.585
r352 (  43 181 ) resistor r=33.1979 //w=0.187 //l=0.485 //layer=li \
 //thickness=0.1 //x=2.16 //y=7.41 //x2=2.16 //y2=6.925
r353 (  42 162 ) resistor r=2.87058 //w=0.35 //l=0.085 //layer=li \
 //thickness=0.1 //x=1.365 //y=7.585 //x2=1.28 //y2=7.585
r354 (  41 163 ) resistor r=2.87058 //w=0.35 //l=0.085 //layer=li \
 //thickness=0.1 //x=2.075 //y=7.585 //x2=2.16 //y2=7.585
r355 (  41 42 ) resistor r=24.7629 //w=0.367 //l=0.71 //layer=li \
 //thickness=0.1 //x=2.075 //y=7.585 //x2=1.365 //y2=7.585
r356 (  35 162 ) resistor r=4.23183 //w=0.7 //l=0.175 //layer=li \
 //thickness=0.1 //x=1.28 //y=7.41 //x2=1.28 //y2=7.585
r357 (  35 180 ) resistor r=56.4706 //w=0.187 //l=0.825 //layer=li \
 //thickness=0.1 //x=1.28 //y=7.41 //x2=1.28 //y2=6.585
r358 (  29 179 ) resistor r=3.1 //w=0.17 //l=0.51 //layer=mcon //count=3 \
 //x=16.4 //y=7.58 //x2=16.4 //y2=7.58
r359 (  27 142 ) resistor r=3.1 //w=0.17 //l=0.51 //layer=mcon //count=3 \
 //x=15.29 //y=7.58 //x2=15.29 //y2=7.58
r360 (  27 29 ) resistor r=0.446141 //w=0.311 //l=1.11 //layer=m1 \
 //thickness=0.36 //x=15.29 //y=7.585 //x2=16.4 //y2=7.585
r361 (  25 136 ) resistor r=3.1 //w=0.17 //l=0.51 //layer=mcon //count=3 \
 //x=13.81 //y=7.58 //x2=13.81 //y2=7.58
r362 (  25 27 ) resistor r=0.594855 //w=0.311 //l=1.48 //layer=m1 \
 //thickness=0.36 //x=13.81 //y=7.585 //x2=15.29 //y2=7.585
r363 (  23 128 ) resistor r=3.1 //w=0.17 //l=0.51 //layer=mcon //count=3 \
 //x=12.7 //y=7.58 //x2=12.7 //y2=7.58
r364 (  23 25 ) resistor r=0.446141 //w=0.311 //l=1.11 //layer=m1 \
 //thickness=0.36 //x=12.7 //y=7.585 //x2=13.81 //y2=7.585
r365 (  21 122 ) resistor r=3.1 //w=0.17 //l=0.51 //layer=mcon //count=3 \
 //x=11.22 //y=7.58 //x2=11.22 //y2=7.58
r366 (  21 23 ) resistor r=0.594855 //w=0.311 //l=1.48 //layer=m1 \
 //thickness=0.36 //x=11.22 //y=7.585 //x2=12.7 //y2=7.585
r367 (  19 120 ) resistor r=3.1 //w=0.17 //l=0.51 //layer=mcon //count=3 \
 //x=10.11 //y=7.58 //x2=10.11 //y2=7.58
r368 (  19 21 ) resistor r=0.446141 //w=0.311 //l=1.11 //layer=m1 \
 //thickness=0.36 //x=10.11 //y=7.585 //x2=11.22 //y2=7.585
r369 (  17 112 ) resistor r=3.1 //w=0.17 //l=0.51 //layer=mcon //count=3 //x=9 \
 //y=7.58 //x2=9 //y2=7.58
r370 (  17 19 ) resistor r=0.446141 //w=0.311 //l=1.11 //layer=m1 \
 //thickness=0.36 //x=9 //y=7.585 //x2=10.11 //y2=7.585
r371 (  14 171 ) resistor r=3.1 //w=0.17 //l=0.51 //layer=mcon //count=3 \
 //x=7.52 //y=7.58 //x2=7.52 //y2=7.58
r372 (  12 90 ) resistor r=3.1 //w=0.17 //l=0.51 //layer=mcon //count=3 \
 //x=6.41 //y=7.58 //x2=6.41 //y2=7.58
r373 (  12 14 ) resistor r=0.446141 //w=0.311 //l=1.11 //layer=m1 \
 //thickness=0.36 //x=6.41 //y=7.585 //x2=7.52 //y2=7.585
r374 (  10 76 ) resistor r=3.1 //w=0.17 //l=0.51 //layer=mcon //count=3 \
 //x=4.93 //y=7.58 //x2=4.93 //y2=7.58
r375 (  10 12 ) resistor r=0.594855 //w=0.311 //l=1.48 //layer=m1 \
 //thickness=0.36 //x=4.93 //y=7.585 //x2=6.41 //y2=7.585
r376 (  8 62 ) resistor r=3.1 //w=0.17 //l=0.51 //layer=mcon //count=3 \
 //x=3.45 //y=7.58 //x2=3.45 //y2=7.58
r377 (  8 10 ) resistor r=0.594855 //w=0.311 //l=1.48 //layer=m1 \
 //thickness=0.36 //x=3.45 //y=7.585 //x2=4.93 //y2=7.585
r378 (  6 52 ) resistor r=3.1 //w=0.17 //l=0.51 //layer=mcon //count=3 \
 //x=2.34 //y=7.58 //x2=2.34 //y2=7.58
r379 (  6 8 ) resistor r=0.446141 //w=0.311 //l=1.11 //layer=m1 \
 //thickness=0.36 //x=2.34 //y=7.585 //x2=3.45 //y2=7.585
r380 (  3 162 ) resistor r=3.1 //w=0.17 //l=0.51 //layer=mcon //count=3 \
 //x=1.23 //y=7.58 //x2=1.23 //y2=7.58
r381 (  3 6 ) resistor r=0.446141 //w=0.311 //l=1.11 //layer=m1 \
 //thickness=0.36 //x=1.23 //y=7.585 //x2=2.34 //y2=7.585
r382 (  1 17 ) resistor r=0.0743569 //w=0.311 //l=0.185 //layer=m1 \
 //thickness=0.36 //x=8.815 //y=7.585 //x2=9 //y2=7.585
r383 (  1 14 ) resistor r=0.520498 //w=0.311 //l=1.295 //layer=m1 \
 //thickness=0.36 //x=8.815 //y=7.585 //x2=7.52 //y2=7.585
ends PM_HA\%VDD

subckt PM_HA\%noxref_3 ( 1 2 13 14 25 27 28 32 34 41 42 43 44 45 46 47 48 52 \
 53 54 56 62 63 65 73 75 76 )
c142 ( 76 0 ) capacitor c=0.0220291f //x=2.455 //y=5.2
c143 ( 75 0 ) capacitor c=0.0217503f //x=1.575 //y=5.2
c144 ( 73 0 ) capacitor c=0.0084702f //x=2.45 //y=1.085
c145 ( 65 0 ) capacitor c=0.0528806f //x=4.56 //y=2.265
c146 ( 63 0 ) capacitor c=0.0435629f //x=5.2 //y=1.435
c147 ( 62 0 ) capacitor c=0.0200386f //x=5.2 //y=1.09
c148 ( 56 0 ) capacitor c=0.0152946f //x=5.045 //y=1.59
c149 ( 54 0 ) capacitor c=0.0157804f //x=5.045 //y=0.935
c150 ( 53 0 ) capacitor c=0.0490829f //x=4.79 //y=4.97
c151 ( 52 0 ) capacitor c=0.0304104f //x=5.08 //y=4.97
c152 ( 48 0 ) capacitor c=0.0290017f //x=4.67 //y=2.1
c153 ( 47 0 ) capacitor c=0.0250027f //x=4.67 //y=1.745
c154 ( 46 0 ) capacitor c=0.0234316f //x=4.67 //y=1.435
c155 ( 45 0 ) capacitor c=0.0200596f //x=4.67 //y=1.09
c156 ( 44 0 ) capacitor c=0.154218f //x=5.155 //y=6.2
c157 ( 43 0 ) capacitor c=0.154243f //x=4.715 //y=6.2
c158 ( 41 0 ) capacitor c=0.0023043f //x=2.6 //y=5.38
c159 ( 34 0 ) capacitor c=0.0891814f //x=4.56 //y=2.265
c160 ( 32 0 ) capacitor c=0.107172f //x=3.08 //y=3.51
c161 ( 28 0 ) capacitor c=0.00525782f //x=2.725 //y=1.835
c162 ( 27 0 ) capacitor c=0.0139525f //x=2.995 //y=1.835
c163 ( 25 0 ) capacitor c=0.0141863f //x=2.995 //y=5.38
c164 ( 14 0 ) capacitor c=0.00260571f //x=1.805 //y=5.38
c165 ( 13 0 ) capacitor c=0.0149571f //x=2.515 //y=5.38
c166 ( 2 0 ) capacitor c=0.0136218f //x=3.195 //y=3.51
c167 ( 1 0 ) capacitor c=0.0547127f //x=4.445 //y=3.51
r168 (  65 66 ) resistor r=17.5563 //w=0.302 //l=0.11 //layer=ply \
 //thickness=0.18 //x=4.56 //y=2.265 //x2=4.67 //y2=2.265
r169 (  63 72 ) resistor r=45.1352 //w=0.168 //l=0.173853 //layer=ply \
 //thickness=0.18 //x=5.2 //y=1.435 //x2=5.16 //y2=1.59
r170 (  62 71 ) resistor r=45.1352 //w=0.168 //l=0.173853 //layer=ply \
 //thickness=0.18 //x=5.2 //y=1.09 //x2=5.16 //y2=0.935
r171 (  62 63 ) resistor r=176.904 //w=0.094 //l=0.345 //layer=ply \
 //thickness=0.18 //x=5.2 //y=1.09 //x2=5.2 //y2=1.435
r172 (  57 70 ) resistor r=10.701 //w=0.21 //l=0.115 //layer=ply \
 //thickness=0.18 //x=4.825 //y=1.59 //x2=4.71 //y2=1.59
r173 (  56 72 ) resistor r=5.52526 //w=0.168 //l=0.115 //layer=ply \
 //thickness=0.18 //x=5.045 //y=1.59 //x2=5.16 //y2=1.59
r174 (  55 69 ) resistor r=5.52526 //w=0.168 //l=0.115 //layer=ply \
 //thickness=0.18 //x=4.825 //y=0.935 //x2=4.71 //y2=0.935
r175 (  54 71 ) resistor r=5.52526 //w=0.168 //l=0.115 //layer=ply \
 //thickness=0.18 //x=5.045 //y=0.935 //x2=5.16 //y2=0.935
r176 (  54 55 ) resistor r=112.809 //w=0.094 //l=0.22 //layer=ply \
 //thickness=0.18 //x=5.045 //y=0.935 //x2=4.825 //y2=0.935
r177 (  52 59 ) resistor r=26.9307 //w=0.15 //l=0.106066 //layer=ply \
 //thickness=0.18 //x=5.08 //y=4.97 //x2=5.155 //y2=5.045
r178 (  52 53 ) resistor r=148.702 //w=0.094 //l=0.29 //layer=ply \
 //thickness=0.18 //x=5.08 //y=4.97 //x2=4.79 //y2=4.97
r179 (  49 53 ) resistor r=23.403 //w=0.284 //l=0.106066 //layer=ply \
 //thickness=0.18 //x=4.715 //y=5.045 //x2=4.79 //y2=4.97
r180 (  49 68 ) resistor r=26.3063 //w=0.284 //l=0.229783 //layer=ply \
 //thickness=0.18 //x=4.715 //y=5.045 //x2=4.56 //y2=4.88
r181 (  48 66 ) resistor r=19.1248 //w=0.302 //l=0.165 //layer=ply \
 //thickness=0.18 //x=4.67 //y=2.1 //x2=4.67 //y2=2.265
r182 (  47 70 ) resistor r=39.5823 //w=0.21 //l=0.173853 //layer=ply \
 //thickness=0.18 //x=4.67 //y=1.745 //x2=4.71 //y2=1.59
r183 (  47 48 ) resistor r=182.032 //w=0.094 //l=0.355 //layer=ply \
 //thickness=0.18 //x=4.67 //y=1.745 //x2=4.67 //y2=2.1
r184 (  46 70 ) resistor r=39.5823 //w=0.21 //l=0.173853 //layer=ply \
 //thickness=0.18 //x=4.67 //y=1.435 //x2=4.71 //y2=1.59
r185 (  45 69 ) resistor r=45.1352 //w=0.168 //l=0.173853 //layer=ply \
 //thickness=0.18 //x=4.67 //y=1.09 //x2=4.71 //y2=0.935
r186 (  45 46 ) resistor r=176.904 //w=0.094 //l=0.345 //layer=ply \
 //thickness=0.18 //x=4.67 //y=1.09 //x2=4.67 //y2=1.435
r187 (  44 59 ) resistor r=592.245 //w=0.094 //l=1.155 //layer=ply \
 //thickness=0.18 //x=5.155 //y=6.2 //x2=5.155 //y2=5.045
r188 (  43 49 ) resistor r=592.245 //w=0.094 //l=1.155 //layer=ply \
 //thickness=0.18 //x=4.715 //y=6.2 //x2=4.715 //y2=5.045
r189 (  42 56 ) resistor r=56.4043 //w=0.094 //l=0.11 //layer=ply \
 //thickness=0.18 //x=4.935 //y=1.59 //x2=5.045 //y2=1.59
r190 (  42 57 ) resistor r=56.4043 //w=0.094 //l=0.11 //layer=ply \
 //thickness=0.18 //x=4.935 //y=1.59 //x2=4.825 //y2=1.59
r191 (  39 68 ) resistor r=152 //w=0.17 //l=0.17 //layer=licon //count=1 \
 //x=4.56 //y=4.88 //x2=4.56 //y2=4.88
r192 (  37 39 ) resistor r=93.7754 //w=0.187 //l=1.37 //layer=li \
 //thickness=0.1 //x=4.56 //y=3.51 //x2=4.56 //y2=4.88
r193 (  34 65 ) resistor r=152 //w=0.17 //l=0.17 //layer=licon //count=1 \
 //x=4.56 //y=2.265 //x2=4.56 //y2=2.265
r194 (  34 37 ) resistor r=85.2193 //w=0.187 //l=1.245 //layer=li \
 //thickness=0.1 //x=4.56 //y=2.265 //x2=4.56 //y2=3.51
r195 (  30 32 ) resistor r=122.182 //w=0.187 //l=1.785 //layer=li \
 //thickness=0.1 //x=3.08 //y=5.295 //x2=3.08 //y2=3.51
r196 (  29 32 ) resistor r=108.834 //w=0.187 //l=1.59 //layer=li \
 //thickness=0.1 //x=3.08 //y=1.92 //x2=3.08 //y2=3.51
r197 (  27 29 ) resistor r=7.15173 //w=0.17 //l=0.120208 //layer=li \
 //thickness=0.1 //x=2.995 //y=1.835 //x2=3.08 //y2=1.92
r198 (  27 28 ) resistor r=18.4813 //w=0.187 //l=0.27 //layer=li \
 //thickness=0.1 //x=2.995 //y=1.835 //x2=2.725 //y2=1.835
r199 (  26 41 ) resistor r=5.4201 //w=0.17 //l=0.085 //layer=li \
 //thickness=0.1 //x=2.685 //y=5.38 //x2=2.6 //y2=5.38
r200 (  25 30 ) resistor r=7.15173 //w=0.17 //l=0.120208 //layer=li \
 //thickness=0.1 //x=2.995 //y=5.38 //x2=3.08 //y2=5.295
r201 (  25 26 ) resistor r=21.2193 //w=0.187 //l=0.31 //layer=li \
 //thickness=0.1 //x=2.995 //y=5.38 //x2=2.685 //y2=5.38
r202 (  21 28 ) resistor r=7.15173 //w=0.17 //l=0.120208 //layer=li \
 //thickness=0.1 //x=2.64 //y=1.75 //x2=2.725 //y2=1.835
r203 (  21 73 ) resistor r=39.016 //w=0.187 //l=0.57 //layer=li \
 //thickness=0.1 //x=2.64 //y=1.75 //x2=2.64 //y2=1.18
r204 (  15 41 ) resistor r=1.40859 //w=0.34 //l=0.085 //layer=li \
 //thickness=0.1 //x=2.6 //y=5.465 //x2=2.6 //y2=5.38
r205 (  15 76 ) resistor r=30.1176 //w=0.187 //l=0.44 //layer=li \
 //thickness=0.1 //x=2.6 //y=5.465 //x2=2.6 //y2=5.905
r206 (  13 41 ) resistor r=5.4201 //w=0.17 //l=0.085 //layer=li \
 //thickness=0.1 //x=2.515 //y=5.38 //x2=2.6 //y2=5.38
r207 (  13 14 ) resistor r=48.5989 //w=0.187 //l=0.71 //layer=li \
 //thickness=0.1 //x=2.515 //y=5.38 //x2=1.805 //y2=5.38
r208 (  7 14 ) resistor r=7.15173 //w=0.17 //l=0.120208 //layer=li \
 //thickness=0.1 //x=1.72 //y=5.465 //x2=1.805 //y2=5.38
r209 (  7 75 ) resistor r=30.1176 //w=0.187 //l=0.44 //layer=li \
 //thickness=0.1 //x=1.72 //y=5.465 //x2=1.72 //y2=5.905
r210 (  6 37 ) resistor r=9.3 //w=0.17 //l=0.17 //layer=mcon //count=1 \
 //x=4.56 //y=3.51 //x2=4.56 //y2=3.51
r211 (  4 32 ) resistor r=9.3 //w=0.17 //l=0.17 //layer=mcon //count=1 \
 //x=3.08 //y=3.51 //x2=3.08 //y2=3.51
r212 (  2 4 ) resistor r=0.0717383 //w=0.224 //l=0.115 //layer=m1 \
 //thickness=0.36 //x=3.195 //y=3.51 //x2=3.08 //y2=3.51
r213 (  1 6 ) resistor r=0.0717383 //w=0.224 //l=0.115 //layer=m1 \
 //thickness=0.36 //x=4.445 //y=3.51 //x2=4.56 //y2=3.51
r214 (  1 2 ) resistor r=1.19275 //w=0.131 //l=1.25 //layer=m1 \
 //thickness=0.36 //x=4.445 //y=3.51 //x2=3.195 //y2=3.51
ends PM_HA\%noxref_3

subckt PM_HA\%A ( 1 2 3 4 11 12 13 14 15 16 17 18 19 20 21 22 23 24 25 27 40 \
 52 62 63 64 65 66 67 68 69 70 71 72 73 74 78 80 83 84 88 89 90 91 95 96 97 99 \
 105 106 107 108 109 110 114 116 119 120 130 134 148 )
c234 ( 148 0 ) capacitor c=0.0615343f //x=9.37 //y=4.88
c235 ( 134 0 ) capacitor c=0.0537799f //x=6.78 //y=2.265
c236 ( 130 0 ) capacitor c=0.0598647f //x=1.6 //y=4.88
c237 ( 120 0 ) capacitor c=0.0318948f //x=9.705 //y=1.395
c238 ( 119 0 ) capacitor c=0.0187407f //x=9.705 //y=1.05
c239 ( 116 0 ) capacitor c=0.0141798f //x=9.55 //y=1.55
c240 ( 114 0 ) capacitor c=0.0149852f //x=9.55 //y=0.895
c241 ( 110 0 ) capacitor c=0.0836807f //x=9.175 //y=2.1
c242 ( 109 0 ) capacitor c=0.0229722f //x=9.175 //y=1.705
c243 ( 108 0 ) capacitor c=0.0234352f //x=9.175 //y=1.395
c244 ( 107 0 ) capacitor c=0.0199366f //x=9.175 //y=1.05
c245 ( 106 0 ) capacitor c=0.0435629f //x=7.42 //y=1.435
c246 ( 105 0 ) capacitor c=0.0200386f //x=7.42 //y=1.09
c247 ( 99 0 ) capacitor c=0.0152946f //x=7.265 //y=1.59
c248 ( 97 0 ) capacitor c=0.0157804f //x=7.265 //y=0.935
c249 ( 96 0 ) capacitor c=0.0490957f //x=7.01 //y=4.97
c250 ( 95 0 ) capacitor c=0.0303096f //x=7.3 //y=4.97
c251 ( 91 0 ) capacitor c=0.0290017f //x=6.89 //y=2.1
c252 ( 90 0 ) capacitor c=0.0250027f //x=6.89 //y=1.745
c253 ( 89 0 ) capacitor c=0.0234316f //x=6.89 //y=1.435
c254 ( 88 0 ) capacitor c=0.0200596f //x=6.89 //y=1.09
c255 ( 84 0 ) capacitor c=0.0318948f //x=1.935 //y=1.39
c256 ( 83 0 ) capacitor c=0.0187384f //x=1.935 //y=1.045
c257 ( 80 0 ) capacitor c=0.0141798f //x=1.78 //y=1.545
c258 ( 78 0 ) capacitor c=0.0149844f //x=1.78 //y=0.89
c259 ( 74 0 ) capacitor c=0.0860049f //x=1.405 //y=2.095
c260 ( 73 0 ) capacitor c=0.0229722f //x=1.405 //y=1.7
c261 ( 72 0 ) capacitor c=0.0234352f //x=1.405 //y=1.39
c262 ( 71 0 ) capacitor c=0.0199343f //x=1.405 //y=1.045
c263 ( 70 0 ) capacitor c=0.110797f //x=9.71 //y=6.2
c264 ( 69 0 ) capacitor c=0.154322f //x=9.27 //y=6.2
c265 ( 68 0 ) capacitor c=0.154218f //x=7.375 //y=6.2
c266 ( 67 0 ) capacitor c=0.154243f //x=6.935 //y=6.2
c267 ( 66 0 ) capacitor c=0.110275f //x=1.94 //y=6.2
c268 ( 65 0 ) capacitor c=0.154305f //x=1.5 //y=6.2
c269 ( 52 0 ) capacitor c=0.100543f //x=9.37 //y=2.265
c270 ( 40 0 ) capacitor c=0.090822f //x=6.78 //y=2.265
c271 ( 27 0 ) capacitor c=0.112176f //x=1.6 //y=2.26
c272 ( 4 0 ) capacitor c=0.00595788f //x=6.895 //y=4.25
c273 ( 3 0 ) capacitor c=0.0693107f //x=9.255 //y=4.25
c274 ( 2 0 ) capacitor c=0.0159773f //x=1.715 //y=4.25
c275 ( 1 0 ) capacitor c=0.130577f //x=6.665 //y=4.25
r276 (  146 148 ) resistor r=20.6867 //w=0.233 //l=0.1 //layer=ply \
 //thickness=0.18 //x=9.27 //y=4.88 //x2=9.37 //y2=4.88
r277 (  134 135 ) resistor r=17.5563 //w=0.302 //l=0.11 //layer=ply \
 //thickness=0.18 //x=6.78 //y=2.265 //x2=6.89 //y2=2.265
r278 (  128 130 ) resistor r=20.6867 //w=0.233 //l=0.1 //layer=ply \
 //thickness=0.18 //x=1.5 //y=4.88 //x2=1.6 //y2=4.88
r279 (  121 148 ) resistor r=70.3348 //w=0.233 //l=0.414367 //layer=ply \
 //thickness=0.18 //x=9.71 //y=5.045 //x2=9.37 //y2=4.88
r280 (  120 150 ) resistor r=45.1352 //w=0.168 //l=0.173853 //layer=ply \
 //thickness=0.18 //x=9.705 //y=1.395 //x2=9.665 //y2=1.55
r281 (  119 149 ) resistor r=45.1352 //w=0.168 //l=0.173853 //layer=ply \
 //thickness=0.18 //x=9.705 //y=1.05 //x2=9.665 //y2=0.895
r282 (  119 120 ) resistor r=176.904 //w=0.094 //l=0.345 //layer=ply \
 //thickness=0.18 //x=9.705 //y=1.05 //x2=9.705 //y2=1.395
r283 (  117 145 ) resistor r=10.701 //w=0.21 //l=0.115 //layer=ply \
 //thickness=0.18 //x=9.33 //y=1.55 //x2=9.215 //y2=1.55
r284 (  116 150 ) resistor r=5.52526 //w=0.168 //l=0.115 //layer=ply \
 //thickness=0.18 //x=9.55 //y=1.55 //x2=9.665 //y2=1.55
r285 (  115 144 ) resistor r=5.52526 //w=0.168 //l=0.115 //layer=ply \
 //thickness=0.18 //x=9.33 //y=0.895 //x2=9.215 //y2=0.895
r286 (  114 149 ) resistor r=5.52526 //w=0.168 //l=0.115 //layer=ply \
 //thickness=0.18 //x=9.55 //y=0.895 //x2=9.665 //y2=0.895
r287 (  114 115 ) resistor r=112.809 //w=0.094 //l=0.22 //layer=ply \
 //thickness=0.18 //x=9.55 //y=0.895 //x2=9.33 //y2=0.895
r288 (  111 146 ) resistor r=13.0941 //w=0.233 //l=0.165 //layer=ply \
 //thickness=0.18 //x=9.27 //y=5.045 //x2=9.27 //y2=4.88
r289 (  110 143 ) resistor r=34.8111 //w=0.27 //l=0.264953 //layer=ply \
 //thickness=0.18 //x=9.175 //y=2.1 //x2=9.37 //y2=2.265
r290 (  109 145 ) resistor r=39.5823 //w=0.21 //l=0.173853 //layer=ply \
 //thickness=0.18 //x=9.175 //y=1.705 //x2=9.215 //y2=1.55
r291 (  109 110 ) resistor r=202.543 //w=0.094 //l=0.395 //layer=ply \
 //thickness=0.18 //x=9.175 //y=1.705 //x2=9.175 //y2=2.1
r292 (  108 145 ) resistor r=39.5823 //w=0.21 //l=0.173853 //layer=ply \
 //thickness=0.18 //x=9.175 //y=1.395 //x2=9.215 //y2=1.55
r293 (  107 144 ) resistor r=45.1352 //w=0.168 //l=0.173853 //layer=ply \
 //thickness=0.18 //x=9.175 //y=1.05 //x2=9.215 //y2=0.895
r294 (  107 108 ) resistor r=176.904 //w=0.094 //l=0.345 //layer=ply \
 //thickness=0.18 //x=9.175 //y=1.05 //x2=9.175 //y2=1.395
r295 (  106 141 ) resistor r=45.1352 //w=0.168 //l=0.173853 //layer=ply \
 //thickness=0.18 //x=7.42 //y=1.435 //x2=7.38 //y2=1.59
r296 (  105 140 ) resistor r=45.1352 //w=0.168 //l=0.173853 //layer=ply \
 //thickness=0.18 //x=7.42 //y=1.09 //x2=7.38 //y2=0.935
r297 (  105 106 ) resistor r=176.904 //w=0.094 //l=0.345 //layer=ply \
 //thickness=0.18 //x=7.42 //y=1.09 //x2=7.42 //y2=1.435
r298 (  100 139 ) resistor r=10.701 //w=0.21 //l=0.115 //layer=ply \
 //thickness=0.18 //x=7.045 //y=1.59 //x2=6.93 //y2=1.59
r299 (  99 141 ) resistor r=5.52526 //w=0.168 //l=0.115 //layer=ply \
 //thickness=0.18 //x=7.265 //y=1.59 //x2=7.38 //y2=1.59
r300 (  98 138 ) resistor r=5.52526 //w=0.168 //l=0.115 //layer=ply \
 //thickness=0.18 //x=7.045 //y=0.935 //x2=6.93 //y2=0.935
r301 (  97 140 ) resistor r=5.52526 //w=0.168 //l=0.115 //layer=ply \
 //thickness=0.18 //x=7.265 //y=0.935 //x2=7.38 //y2=0.935
r302 (  97 98 ) resistor r=112.809 //w=0.094 //l=0.22 //layer=ply \
 //thickness=0.18 //x=7.265 //y=0.935 //x2=7.045 //y2=0.935
r303 (  95 102 ) resistor r=26.9307 //w=0.15 //l=0.106066 //layer=ply \
 //thickness=0.18 //x=7.3 //y=4.97 //x2=7.375 //y2=5.045
r304 (  95 96 ) resistor r=148.702 //w=0.094 //l=0.29 //layer=ply \
 //thickness=0.18 //x=7.3 //y=4.97 //x2=7.01 //y2=4.97
r305 (  92 96 ) resistor r=23.403 //w=0.284 //l=0.106066 //layer=ply \
 //thickness=0.18 //x=6.935 //y=5.045 //x2=7.01 //y2=4.97
r306 (  92 137 ) resistor r=26.3063 //w=0.284 //l=0.229783 //layer=ply \
 //thickness=0.18 //x=6.935 //y=5.045 //x2=6.78 //y2=4.88
r307 (  91 135 ) resistor r=19.1248 //w=0.302 //l=0.165 //layer=ply \
 //thickness=0.18 //x=6.89 //y=2.1 //x2=6.89 //y2=2.265
r308 (  90 139 ) resistor r=39.5823 //w=0.21 //l=0.173853 //layer=ply \
 //thickness=0.18 //x=6.89 //y=1.745 //x2=6.93 //y2=1.59
r309 (  90 91 ) resistor r=182.032 //w=0.094 //l=0.355 //layer=ply \
 //thickness=0.18 //x=6.89 //y=1.745 //x2=6.89 //y2=2.1
r310 (  89 139 ) resistor r=39.5823 //w=0.21 //l=0.173853 //layer=ply \
 //thickness=0.18 //x=6.89 //y=1.435 //x2=6.93 //y2=1.59
r311 (  88 138 ) resistor r=45.1352 //w=0.168 //l=0.173853 //layer=ply \
 //thickness=0.18 //x=6.89 //y=1.09 //x2=6.93 //y2=0.935
r312 (  88 89 ) resistor r=176.904 //w=0.094 //l=0.345 //layer=ply \
 //thickness=0.18 //x=6.89 //y=1.09 //x2=6.89 //y2=1.435
r313 (  85 130 ) resistor r=70.3348 //w=0.233 //l=0.414367 //layer=ply \
 //thickness=0.18 //x=1.94 //y=5.045 //x2=1.6 //y2=4.88
r314 (  84 132 ) resistor r=45.1352 //w=0.168 //l=0.173853 //layer=ply \
 //thickness=0.18 //x=1.935 //y=1.39 //x2=1.895 //y2=1.545
r315 (  83 131 ) resistor r=45.1352 //w=0.168 //l=0.173853 //layer=ply \
 //thickness=0.18 //x=1.935 //y=1.045 //x2=1.895 //y2=0.89
r316 (  83 84 ) resistor r=176.904 //w=0.094 //l=0.345 //layer=ply \
 //thickness=0.18 //x=1.935 //y=1.045 //x2=1.935 //y2=1.39
r317 (  81 127 ) resistor r=10.701 //w=0.21 //l=0.115 //layer=ply \
 //thickness=0.18 //x=1.56 //y=1.545 //x2=1.445 //y2=1.545
r318 (  80 132 ) resistor r=5.52526 //w=0.168 //l=0.115 //layer=ply \
 //thickness=0.18 //x=1.78 //y=1.545 //x2=1.895 //y2=1.545
r319 (  79 126 ) resistor r=5.52526 //w=0.168 //l=0.115 //layer=ply \
 //thickness=0.18 //x=1.56 //y=0.89 //x2=1.445 //y2=0.89
r320 (  78 131 ) resistor r=5.52526 //w=0.168 //l=0.115 //layer=ply \
 //thickness=0.18 //x=1.78 //y=0.89 //x2=1.895 //y2=0.89
r321 (  78 79 ) resistor r=112.809 //w=0.094 //l=0.22 //layer=ply \
 //thickness=0.18 //x=1.78 //y=0.89 //x2=1.56 //y2=0.89
r322 (  75 128 ) resistor r=13.0941 //w=0.233 //l=0.165 //layer=ply \
 //thickness=0.18 //x=1.5 //y=5.045 //x2=1.5 //y2=4.88
r323 (  74 125 ) resistor r=34.8111 //w=0.27 //l=0.264953 //layer=ply \
 //thickness=0.18 //x=1.405 //y=2.095 //x2=1.6 //y2=2.26
r324 (  73 127 ) resistor r=39.5823 //w=0.21 //l=0.173853 //layer=ply \
 //thickness=0.18 //x=1.405 //y=1.7 //x2=1.445 //y2=1.545
r325 (  73 74 ) resistor r=202.543 //w=0.094 //l=0.395 //layer=ply \
 //thickness=0.18 //x=1.405 //y=1.7 //x2=1.405 //y2=2.095
r326 (  72 127 ) resistor r=39.5823 //w=0.21 //l=0.173853 //layer=ply \
 //thickness=0.18 //x=1.405 //y=1.39 //x2=1.445 //y2=1.545
r327 (  71 126 ) resistor r=45.1352 //w=0.168 //l=0.173853 //layer=ply \
 //thickness=0.18 //x=1.405 //y=1.045 //x2=1.445 //y2=0.89
r328 (  71 72 ) resistor r=176.904 //w=0.094 //l=0.345 //layer=ply \
 //thickness=0.18 //x=1.405 //y=1.045 //x2=1.405 //y2=1.39
r329 (  70 121 ) resistor r=592.245 //w=0.094 //l=1.155 //layer=ply \
 //thickness=0.18 //x=9.71 //y=6.2 //x2=9.71 //y2=5.045
r330 (  69 111 ) resistor r=592.245 //w=0.094 //l=1.155 //layer=ply \
 //thickness=0.18 //x=9.27 //y=6.2 //x2=9.27 //y2=5.045
r331 (  68 102 ) resistor r=592.245 //w=0.094 //l=1.155 //layer=ply \
 //thickness=0.18 //x=7.375 //y=6.2 //x2=7.375 //y2=5.045
r332 (  67 92 ) resistor r=592.245 //w=0.094 //l=1.155 //layer=ply \
 //thickness=0.18 //x=6.935 //y=6.2 //x2=6.935 //y2=5.045
r333 (  66 85 ) resistor r=592.245 //w=0.094 //l=1.155 //layer=ply \
 //thickness=0.18 //x=1.94 //y=6.2 //x2=1.94 //y2=5.045
r334 (  65 75 ) resistor r=592.245 //w=0.094 //l=1.155 //layer=ply \
 //thickness=0.18 //x=1.5 //y=6.2 //x2=1.5 //y2=5.045
r335 (  64 116 ) resistor r=56.4043 //w=0.094 //l=0.11 //layer=ply \
 //thickness=0.18 //x=9.44 //y=1.55 //x2=9.55 //y2=1.55
r336 (  64 117 ) resistor r=56.4043 //w=0.094 //l=0.11 //layer=ply \
 //thickness=0.18 //x=9.44 //y=1.55 //x2=9.33 //y2=1.55
r337 (  63 99 ) resistor r=56.4043 //w=0.094 //l=0.11 //layer=ply \
 //thickness=0.18 //x=7.155 //y=1.59 //x2=7.265 //y2=1.59
r338 (  63 100 ) resistor r=56.4043 //w=0.094 //l=0.11 //layer=ply \
 //thickness=0.18 //x=7.155 //y=1.59 //x2=7.045 //y2=1.59
r339 (  62 80 ) resistor r=56.4043 //w=0.094 //l=0.11 //layer=ply \
 //thickness=0.18 //x=1.67 //y=1.545 //x2=1.78 //y2=1.545
r340 (  62 81 ) resistor r=56.4043 //w=0.094 //l=0.11 //layer=ply \
 //thickness=0.18 //x=1.67 //y=1.545 //x2=1.56 //y2=1.545
r341 (  60 148 ) resistor r=152 //w=0.17 //l=0.17 //layer=licon //count=1 \
 //x=9.37 //y=4.88 //x2=9.37 //y2=4.88
r342 (  52 143 ) resistor r=152 //w=0.17 //l=0.17 //layer=licon //count=1 \
 //x=9.37 //y=2.265 //x2=9.37 //y2=2.265
r343 (  49 137 ) resistor r=152 //w=0.17 //l=0.17 //layer=licon //count=1 \
 //x=6.78 //y=4.88 //x2=6.78 //y2=4.88
r344 (  40 134 ) resistor r=152 //w=0.17 //l=0.17 //layer=licon //count=1 \
 //x=6.78 //y=2.265 //x2=6.78 //y2=2.265
r345 (  37 130 ) resistor r=152 //w=0.17 //l=0.17 //layer=licon //count=1 \
 //x=1.6 //y=4.88 //x2=1.6 //y2=4.88
r346 (  27 125 ) resistor r=152 //w=0.17 //l=0.17 //layer=licon //count=1 \
 //x=1.6 //y=2.26 //x2=1.6 //y2=2.26
r347 (  25 60 ) resistor r=17.7968 //w=0.187 //l=0.26 //layer=li \
 //thickness=0.1 //x=9.37 //y=4.62 //x2=9.37 //y2=4.88
r348 (  24 25 ) resistor r=25.3262 //w=0.187 //l=0.37 //layer=li \
 //thickness=0.1 //x=9.37 //y=4.25 //x2=9.37 //y2=4.62
r349 (  23 24 ) resistor r=50.6524 //w=0.187 //l=0.74 //layer=li \
 //thickness=0.1 //x=9.37 //y=3.51 //x2=9.37 //y2=4.25
r350 (  22 23 ) resistor r=25.3262 //w=0.187 //l=0.37 //layer=li \
 //thickness=0.1 //x=9.37 //y=3.14 //x2=9.37 //y2=3.51
r351 (  22 52 ) resistor r=59.893 //w=0.187 //l=0.875 //layer=li \
 //thickness=0.1 //x=9.37 //y=3.14 //x2=9.37 //y2=2.265
r352 (  21 49 ) resistor r=17.7968 //w=0.187 //l=0.26 //layer=li \
 //thickness=0.1 //x=6.78 //y=4.62 //x2=6.78 //y2=4.88
r353 (  20 21 ) resistor r=25.3262 //w=0.187 //l=0.37 //layer=li \
 //thickness=0.1 //x=6.78 //y=4.25 //x2=6.78 //y2=4.62
r354 (  19 20 ) resistor r=50.6524 //w=0.187 //l=0.74 //layer=li \
 //thickness=0.1 //x=6.78 //y=3.51 //x2=6.78 //y2=4.25
r355 (  18 19 ) resistor r=25.3262 //w=0.187 //l=0.37 //layer=li \
 //thickness=0.1 //x=6.78 //y=3.14 //x2=6.78 //y2=3.51
r356 (  17 18 ) resistor r=25.3262 //w=0.187 //l=0.37 //layer=li \
 //thickness=0.1 //x=6.78 //y=2.77 //x2=6.78 //y2=3.14
r357 (  17 40 ) resistor r=34.5668 //w=0.187 //l=0.505 //layer=li \
 //thickness=0.1 //x=6.78 //y=2.77 //x2=6.78 //y2=2.265
r358 (  16 37 ) resistor r=17.7968 //w=0.187 //l=0.26 //layer=li \
 //thickness=0.1 //x=1.6 //y=4.62 //x2=1.6 //y2=4.88
r359 (  15 16 ) resistor r=25.3262 //w=0.187 //l=0.37 //layer=li \
 //thickness=0.1 //x=1.6 //y=4.25 //x2=1.6 //y2=4.62
r360 (  14 15 ) resistor r=25.3262 //w=0.187 //l=0.37 //layer=li \
 //thickness=0.1 //x=1.6 //y=3.88 //x2=1.6 //y2=4.25
r361 (  13 14 ) resistor r=25.3262 //w=0.187 //l=0.37 //layer=li \
 //thickness=0.1 //x=1.6 //y=3.51 //x2=1.6 //y2=3.88
r362 (  12 13 ) resistor r=25.3262 //w=0.187 //l=0.37 //layer=li \
 //thickness=0.1 //x=1.6 //y=3.14 //x2=1.6 //y2=3.51
r363 (  11 12 ) resistor r=25.3262 //w=0.187 //l=0.37 //layer=li \
 //thickness=0.1 //x=1.6 //y=2.77 //x2=1.6 //y2=3.14
r364 (  11 27 ) resistor r=34.9091 //w=0.187 //l=0.51 //layer=li \
 //thickness=0.1 //x=1.6 //y=2.77 //x2=1.6 //y2=2.26
r365 (  10 24 ) resistor r=9.3 //w=0.17 //l=0.17 //layer=mcon //count=1 \
 //x=9.37 //y=4.25 //x2=9.37 //y2=4.25
r366 (  8 20 ) resistor r=9.3 //w=0.17 //l=0.17 //layer=mcon //count=1 \
 //x=6.78 //y=4.25 //x2=6.78 //y2=4.25
r367 (  6 15 ) resistor r=9.3 //w=0.17 //l=0.17 //layer=mcon //count=1 //x=1.6 \
 //y=4.25 //x2=1.6 //y2=4.25
r368 (  4 8 ) resistor r=0.0880901 //w=0.191 //l=0.115 //layer=m1 \
 //thickness=0.36 //x=6.895 //y=4.25 //x2=6.78 //y2=4.25
r369 (  3 10 ) resistor r=0.0717383 //w=0.224 //l=0.115 //layer=m1 \
 //thickness=0.36 //x=9.255 //y=4.25 //x2=9.37 //y2=4.25
r370 (  3 4 ) resistor r=2.25191 //w=0.131 //l=2.36 //layer=m1 \
 //thickness=0.36 //x=9.255 //y=4.25 //x2=6.895 //y2=4.25
r371 (  2 6 ) resistor r=0.0717383 //w=0.224 //l=0.115 //layer=m1 \
 //thickness=0.36 //x=1.715 //y=4.25 //x2=1.6 //y2=4.25
r372 (  1 8 ) resistor r=0.0880901 //w=0.191 //l=0.115 //layer=m1 \
 //thickness=0.36 //x=6.665 //y=4.25 //x2=6.78 //y2=4.25
r373 (  1 2 ) resistor r=4.72328 //w=0.131 //l=4.95 //layer=m1 \
 //thickness=0.36 //x=6.665 //y=4.25 //x2=1.715 //y2=4.25
ends PM_HA\%A

subckt PM_HA\%B ( 1 2 3 4 5 6 7 8 23 24 25 26 27 28 29 30 31 32 33 34 35 36 37 \
 38 39 41 57 69 84 85 86 87 88 89 90 91 92 93 94 95 100 102 104 110 111 112 \
 113 114 115 116 118 121 122 129 130 134 135 136 138 141 144 145 146 147 149 \
 150 153 169 174 )
c313 ( 174 0 ) capacitor c=0.051138f //x=16.29 //y=2.265
c314 ( 169 0 ) capacitor c=0.0606568f //x=12.7 //y=4.88
c315 ( 153 0 ) capacitor c=0.0331552f //x=2.37 //y=4.88
c316 ( 150 0 ) capacitor c=0.0279499f //x=2.34 //y=2.095
c317 ( 149 0 ) capacitor c=0.0437302f //x=2.34 //y=2.26
c318 ( 147 0 ) capacitor c=0.0290017f //x=16.29 //y=2.1
c319 ( 146 0 ) capacitor c=0.0250171f //x=16.29 //y=1.745
c320 ( 145 0 ) capacitor c=0.0234316f //x=16.29 //y=1.435
c321 ( 144 0 ) capacitor c=0.0200712f //x=16.29 //y=1.09
c322 ( 141 0 ) capacitor c=0.0488625f //x=16.245 //y=5.045
c323 ( 138 0 ) capacitor c=0.0152946f //x=16.135 //y=1.59
c324 ( 136 0 ) capacitor c=0.0157804f //x=16.135 //y=0.935
c325 ( 135 0 ) capacitor c=0.0129718f //x=15.88 //y=4.97
c326 ( 134 0 ) capacitor c=0.0172687f //x=16.17 //y=4.97
c327 ( 130 0 ) capacitor c=0.0435512f //x=15.76 //y=1.435
c328 ( 129 0 ) capacitor c=0.0200269f //x=15.76 //y=1.09
c329 ( 122 0 ) capacitor c=0.0417768f //x=10.675 //y=1.435
c330 ( 121 0 ) capacitor c=0.0192208f //x=10.675 //y=1.09
c331 ( 118 0 ) capacitor c=0.0124204f //x=10.52 //y=1.59
c332 ( 116 0 ) capacitor c=0.0157803f //x=10.52 //y=0.935
c333 ( 115 0 ) capacitor c=0.0903325f //x=10.145 //y=2.1
c334 ( 114 0 ) capacitor c=0.0194674f //x=10.145 //y=1.745
c335 ( 113 0 ) capacitor c=0.0168481f //x=10.145 //y=1.435
c336 ( 112 0 ) capacitor c=0.0174345f //x=10.145 //y=1.09
c337 ( 111 0 ) capacitor c=0.0429696f //x=2.905 //y=1.43
c338 ( 110 0 ) capacitor c=0.0192208f //x=2.905 //y=1.085
c339 ( 104 0 ) capacitor c=0.0158629f //x=2.75 //y=1.585
c340 ( 102 0 ) capacitor c=0.0157803f //x=2.75 //y=0.93
c341 ( 100 0 ) capacitor c=0.0300505f //x=2.745 //y=4.97
c342 ( 95 0 ) capacitor c=0.0205163f //x=2.375 //y=1.74
c343 ( 94 0 ) capacitor c=0.0168481f //x=2.375 //y=1.43
c344 ( 93 0 ) capacitor c=0.0174783f //x=2.375 //y=1.085
c345 ( 92 0 ) capacitor c=0.154243f //x=16.245 //y=6.2
c346 ( 91 0 ) capacitor c=0.154218f //x=15.805 //y=6.2
c347 ( 90 0 ) capacitor c=0.110797f //x=13.04 //y=6.2
c348 ( 89 0 ) capacitor c=0.154322f //x=12.6 //y=6.2
c349 ( 88 0 ) capacitor c=0.15358f //x=2.82 //y=6.2
c350 ( 87 0 ) capacitor c=0.110281f //x=2.38 //y=6.2
c351 ( 69 0 ) capacitor c=0.106666f //x=16.4 //y=2.265
c352 ( 57 0 ) capacitor c=0.0306114f //x=10.48 //y=2.265
c353 ( 41 0 ) capacitor c=0.0765209f //x=2.34 //y=2.26
c354 ( 39 0 ) capacitor c=0.00453889f //x=2.34 //y=4.715
c355 ( 32 0 ) capacitor c=0.0151539f //x=12.7 //y=4.62
c356 ( 28 0 ) capacitor c=0.0375706f //x=10.11 //y=3.88
c357 ( 8 0 ) capacitor c=0.00543706f //x=12.815 //y=4.62
c358 ( 7 0 ) capacitor c=0.093123f //x=16.285 //y=4.62
c359 ( 6 0 ) capacitor c=0.0154186f //x=10.595 //y=3.14
c360 ( 5 0 ) capacitor c=0.130205f //x=16.285 //y=3.14
c361 ( 4 0 ) capacitor c=0.0156998f //x=10.225 //y=4.62
c362 ( 3 0 ) capacitor c=0.0540768f //x=12.585 //y=4.62
c363 ( 2 0 ) capacitor c=0.0160493f //x=2.455 //y=3.88
c364 ( 1 0 ) capacitor c=0.186881f //x=9.995 //y=3.88
r365 (  174 176 ) resistor r=17.5563 //w=0.302 //l=0.11 //layer=ply \
 //thickness=0.18 //x=16.29 //y=2.265 //x2=16.4 //y2=2.265
r366 (  167 169 ) resistor r=20.6867 //w=0.233 //l=0.1 //layer=ply \
 //thickness=0.18 //x=12.6 //y=4.88 //x2=12.7 //y2=4.88
r367 (  155 156 ) resistor r=32.4568 //w=0.214 //l=0.075 //layer=ply \
 //thickness=0.18 //x=2.37 //y=4.97 //x2=2.37 //y2=5.045
r368 (  153 155 ) resistor r=20.271 //w=0.214 //l=0.09 //layer=ply \
 //thickness=0.18 //x=2.37 //y=4.88 //x2=2.37 //y2=4.97
r369 (  149 150 ) resistor r=52.7279 //w=0.214 //l=0.165 //layer=ply \
 //thickness=0.18 //x=2.34 //y=2.26 //x2=2.34 //y2=2.095
r370 (  147 174 ) resistor r=19.1248 //w=0.302 //l=0.165 //layer=ply \
 //thickness=0.18 //x=16.29 //y=2.1 //x2=16.29 //y2=2.265
r371 (  146 173 ) resistor r=39.5823 //w=0.21 //l=0.173853 //layer=ply \
 //thickness=0.18 //x=16.29 //y=1.745 //x2=16.25 //y2=1.59
r372 (  146 147 ) resistor r=182.032 //w=0.094 //l=0.355 //layer=ply \
 //thickness=0.18 //x=16.29 //y=1.745 //x2=16.29 //y2=2.1
r373 (  145 173 ) resistor r=39.5823 //w=0.21 //l=0.173853 //layer=ply \
 //thickness=0.18 //x=16.29 //y=1.435 //x2=16.25 //y2=1.59
r374 (  144 172 ) resistor r=45.1352 //w=0.168 //l=0.173853 //layer=ply \
 //thickness=0.18 //x=16.29 //y=1.09 //x2=16.25 //y2=0.935
r375 (  144 145 ) resistor r=176.904 //w=0.094 //l=0.345 //layer=ply \
 //thickness=0.18 //x=16.29 //y=1.09 //x2=16.29 //y2=1.435
r376 (  141 178 ) resistor r=26.3063 //w=0.284 //l=0.229783 //layer=ply \
 //thickness=0.18 //x=16.245 //y=5.045 //x2=16.4 //y2=4.88
r377 (  139 171 ) resistor r=5.52526 //w=0.168 //l=0.115 //layer=ply \
 //thickness=0.18 //x=15.915 //y=1.59 //x2=15.8 //y2=1.59
r378 (  138 173 ) resistor r=10.701 //w=0.21 //l=0.115 //layer=ply \
 //thickness=0.18 //x=16.135 //y=1.59 //x2=16.25 //y2=1.59
r379 (  137 170 ) resistor r=5.52526 //w=0.168 //l=0.115 //layer=ply \
 //thickness=0.18 //x=15.915 //y=0.935 //x2=15.8 //y2=0.935
r380 (  136 172 ) resistor r=5.52526 //w=0.168 //l=0.115 //layer=ply \
 //thickness=0.18 //x=16.135 //y=0.935 //x2=16.25 //y2=0.935
r381 (  136 137 ) resistor r=112.809 //w=0.094 //l=0.22 //layer=ply \
 //thickness=0.18 //x=16.135 //y=0.935 //x2=15.915 //y2=0.935
r382 (  134 141 ) resistor r=23.403 //w=0.284 //l=0.106066 //layer=ply \
 //thickness=0.18 //x=16.17 //y=4.97 //x2=16.245 //y2=5.045
r383 (  134 135 ) resistor r=148.702 //w=0.094 //l=0.29 //layer=ply \
 //thickness=0.18 //x=16.17 //y=4.97 //x2=15.88 //y2=4.97
r384 (  131 135 ) resistor r=26.9307 //w=0.15 //l=0.106066 //layer=ply \
 //thickness=0.18 //x=15.805 //y=5.045 //x2=15.88 //y2=4.97
r385 (  130 171 ) resistor r=45.1352 //w=0.168 //l=0.173853 //layer=ply \
 //thickness=0.18 //x=15.76 //y=1.435 //x2=15.8 //y2=1.59
r386 (  129 170 ) resistor r=45.1352 //w=0.168 //l=0.173853 //layer=ply \
 //thickness=0.18 //x=15.76 //y=1.09 //x2=15.8 //y2=0.935
r387 (  129 130 ) resistor r=176.904 //w=0.094 //l=0.345 //layer=ply \
 //thickness=0.18 //x=15.76 //y=1.09 //x2=15.76 //y2=1.435
r388 (  126 169 ) resistor r=70.3348 //w=0.233 //l=0.414367 //layer=ply \
 //thickness=0.18 //x=13.04 //y=5.045 //x2=12.7 //y2=4.88
r389 (  123 167 ) resistor r=13.0941 //w=0.233 //l=0.165 //layer=ply \
 //thickness=0.18 //x=12.6 //y=5.045 //x2=12.6 //y2=4.88
r390 (  122 166 ) resistor r=45.1352 //w=0.168 //l=0.173853 //layer=ply \
 //thickness=0.18 //x=10.675 //y=1.435 //x2=10.635 //y2=1.59
r391 (  121 165 ) resistor r=45.1352 //w=0.168 //l=0.173853 //layer=ply \
 //thickness=0.18 //x=10.675 //y=1.09 //x2=10.635 //y2=0.935
r392 (  121 122 ) resistor r=176.904 //w=0.094 //l=0.345 //layer=ply \
 //thickness=0.18 //x=10.675 //y=1.09 //x2=10.675 //y2=1.435
r393 (  119 162 ) resistor r=10.701 //w=0.21 //l=0.115 //layer=ply \
 //thickness=0.18 //x=10.3 //y=1.59 //x2=10.185 //y2=1.59
r394 (  118 166 ) resistor r=5.52526 //w=0.168 //l=0.115 //layer=ply \
 //thickness=0.18 //x=10.52 //y=1.59 //x2=10.635 //y2=1.59
r395 (  117 161 ) resistor r=5.52526 //w=0.168 //l=0.115 //layer=ply \
 //thickness=0.18 //x=10.3 //y=0.935 //x2=10.185 //y2=0.935
r396 (  116 165 ) resistor r=5.52526 //w=0.168 //l=0.115 //layer=ply \
 //thickness=0.18 //x=10.52 //y=0.935 //x2=10.635 //y2=0.935
r397 (  116 117 ) resistor r=112.809 //w=0.094 //l=0.22 //layer=ply \
 //thickness=0.18 //x=10.52 //y=0.935 //x2=10.3 //y2=0.935
r398 (  115 164 ) resistor r=67.2792 //w=0.24 //l=0.438891 //layer=ply \
 //thickness=0.18 //x=10.145 //y=2.1 //x2=10.48 //y2=2.34
r399 (  114 162 ) resistor r=39.5823 //w=0.21 //l=0.173853 //layer=ply \
 //thickness=0.18 //x=10.145 //y=1.745 //x2=10.185 //y2=1.59
r400 (  114 115 ) resistor r=182.032 //w=0.094 //l=0.355 //layer=ply \
 //thickness=0.18 //x=10.145 //y=1.745 //x2=10.145 //y2=2.1
r401 (  113 162 ) resistor r=39.5823 //w=0.21 //l=0.173853 //layer=ply \
 //thickness=0.18 //x=10.145 //y=1.435 //x2=10.185 //y2=1.59
r402 (  112 161 ) resistor r=45.1352 //w=0.168 //l=0.173853 //layer=ply \
 //thickness=0.18 //x=10.145 //y=1.09 //x2=10.185 //y2=0.935
r403 (  112 113 ) resistor r=176.904 //w=0.094 //l=0.345 //layer=ply \
 //thickness=0.18 //x=10.145 //y=1.09 //x2=10.145 //y2=1.435
r404 (  111 160 ) resistor r=45.1352 //w=0.168 //l=0.173853 //layer=ply \
 //thickness=0.18 //x=2.905 //y=1.43 //x2=2.865 //y2=1.585
r405 (  110 159 ) resistor r=45.1352 //w=0.168 //l=0.173853 //layer=ply \
 //thickness=0.18 //x=2.905 //y=1.085 //x2=2.865 //y2=0.93
r406 (  110 111 ) resistor r=176.904 //w=0.094 //l=0.345 //layer=ply \
 //thickness=0.18 //x=2.905 //y=1.085 //x2=2.905 //y2=1.43
r407 (  105 158 ) resistor r=10.701 //w=0.21 //l=0.115 //layer=ply \
 //thickness=0.18 //x=2.53 //y=1.585 //x2=2.415 //y2=1.585
r408 (  104 160 ) resistor r=5.52526 //w=0.168 //l=0.115 //layer=ply \
 //thickness=0.18 //x=2.75 //y=1.585 //x2=2.865 //y2=1.585
r409 (  103 157 ) resistor r=5.52526 //w=0.168 //l=0.115 //layer=ply \
 //thickness=0.18 //x=2.53 //y=0.93 //x2=2.415 //y2=0.93
r410 (  102 159 ) resistor r=5.52526 //w=0.168 //l=0.115 //layer=ply \
 //thickness=0.18 //x=2.75 //y=0.93 //x2=2.865 //y2=0.93
r411 (  102 103 ) resistor r=112.809 //w=0.094 //l=0.22 //layer=ply \
 //thickness=0.18 //x=2.75 //y=0.93 //x2=2.53 //y2=0.93
r412 (  101 155 ) resistor r=16.5046 //w=0.27 //l=0.135 //layer=ply \
 //thickness=0.18 //x=2.505 //y=4.97 //x2=2.37 //y2=4.97
r413 (  100 107 ) resistor r=26.9307 //w=0.15 //l=0.106066 //layer=ply \
 //thickness=0.18 //x=2.745 //y=4.97 //x2=2.82 //y2=5.045
r414 (  100 101 ) resistor r=123.064 //w=0.094 //l=0.24 //layer=ply \
 //thickness=0.18 //x=2.745 //y=4.97 //x2=2.505 //y2=4.97
r415 (  95 158 ) resistor r=39.5823 //w=0.21 //l=0.173853 //layer=ply \
 //thickness=0.18 //x=2.375 //y=1.74 //x2=2.415 //y2=1.585
r416 (  95 150 ) resistor r=182.032 //w=0.094 //l=0.355 //layer=ply \
 //thickness=0.18 //x=2.375 //y=1.74 //x2=2.375 //y2=2.095
r417 (  94 158 ) resistor r=39.5823 //w=0.21 //l=0.173853 //layer=ply \
 //thickness=0.18 //x=2.375 //y=1.43 //x2=2.415 //y2=1.585
r418 (  93 157 ) resistor r=45.1352 //w=0.168 //l=0.173853 //layer=ply \
 //thickness=0.18 //x=2.375 //y=1.085 //x2=2.415 //y2=0.93
r419 (  93 94 ) resistor r=176.904 //w=0.094 //l=0.345 //layer=ply \
 //thickness=0.18 //x=2.375 //y=1.085 //x2=2.375 //y2=1.43
r420 (  92 141 ) resistor r=592.245 //w=0.094 //l=1.155 //layer=ply \
 //thickness=0.18 //x=16.245 //y=6.2 //x2=16.245 //y2=5.045
r421 (  91 131 ) resistor r=592.245 //w=0.094 //l=1.155 //layer=ply \
 //thickness=0.18 //x=15.805 //y=6.2 //x2=15.805 //y2=5.045
r422 (  90 126 ) resistor r=592.245 //w=0.094 //l=1.155 //layer=ply \
 //thickness=0.18 //x=13.04 //y=6.2 //x2=13.04 //y2=5.045
r423 (  89 123 ) resistor r=592.245 //w=0.094 //l=1.155 //layer=ply \
 //thickness=0.18 //x=12.6 //y=6.2 //x2=12.6 //y2=5.045
r424 (  88 107 ) resistor r=592.245 //w=0.094 //l=1.155 //layer=ply \
 //thickness=0.18 //x=2.82 //y=6.2 //x2=2.82 //y2=5.045
r425 (  87 156 ) resistor r=592.245 //w=0.094 //l=1.155 //layer=ply \
 //thickness=0.18 //x=2.38 //y=6.2 //x2=2.38 //y2=5.045
r426 (  86 138 ) resistor r=56.4043 //w=0.094 //l=0.11 //layer=ply \
 //thickness=0.18 //x=16.025 //y=1.59 //x2=16.135 //y2=1.59
r427 (  86 139 ) resistor r=56.4043 //w=0.094 //l=0.11 //layer=ply \
 //thickness=0.18 //x=16.025 //y=1.59 //x2=15.915 //y2=1.59
r428 (  85 118 ) resistor r=56.4043 //w=0.094 //l=0.11 //layer=ply \
 //thickness=0.18 //x=10.41 //y=1.59 //x2=10.52 //y2=1.59
r429 (  85 119 ) resistor r=56.4043 //w=0.094 //l=0.11 //layer=ply \
 //thickness=0.18 //x=10.41 //y=1.59 //x2=10.3 //y2=1.59
r430 (  84 104 ) resistor r=56.4043 //w=0.094 //l=0.11 //layer=ply \
 //thickness=0.18 //x=2.64 //y=1.585 //x2=2.75 //y2=1.585
r431 (  84 105 ) resistor r=56.4043 //w=0.094 //l=0.11 //layer=ply \
 //thickness=0.18 //x=2.64 //y=1.585 //x2=2.53 //y2=1.585
r432 (  83 153 ) resistor r=152 //w=0.17 //l=0.17 //layer=licon //count=1 \
 //x=2.37 //y=4.88 //x2=2.37 //y2=4.88
r433 (  80 178 ) resistor r=152 //w=0.17 //l=0.17 //layer=licon //count=1 \
 //x=16.4 //y=4.88 //x2=16.4 //y2=4.88
r434 (  69 176 ) resistor r=152 //w=0.17 //l=0.17 //layer=licon //count=1 \
 //x=16.4 //y=2.265 //x2=16.4 //y2=2.265
r435 (  66 169 ) resistor r=152 //w=0.17 //l=0.17 //layer=licon //count=1 \
 //x=12.7 //y=4.88 //x2=12.7 //y2=4.88
r436 (  57 164 ) resistor r=152 //w=0.17 //l=0.17 //layer=licon //count=1 \
 //x=10.48 //y=2.265 //x2=10.48 //y2=2.265
r437 (  41 149 ) resistor r=152 //w=0.17 //l=0.17 //layer=licon //count=1 \
 //x=2.34 //y=2.26 //x2=2.34 //y2=2.26
r438 (  39 83 ) resistor r=11.4737 //w=0.186 //l=0.172337 //layer=li \
 //thickness=0.1 //x=2.34 //y=4.715 //x2=2.355 //y2=4.88
r439 (  38 80 ) resistor r=17.7968 //w=0.187 //l=0.26 //layer=li \
 //thickness=0.1 //x=16.4 //y=4.62 //x2=16.4 //y2=4.88
r440 (  37 38 ) resistor r=25.3262 //w=0.187 //l=0.37 //layer=li \
 //thickness=0.1 //x=16.4 //y=4.25 //x2=16.4 //y2=4.62
r441 (  36 37 ) resistor r=25.3262 //w=0.187 //l=0.37 //layer=li \
 //thickness=0.1 //x=16.4 //y=3.88 //x2=16.4 //y2=4.25
r442 (  35 36 ) resistor r=25.3262 //w=0.187 //l=0.37 //layer=li \
 //thickness=0.1 //x=16.4 //y=3.51 //x2=16.4 //y2=3.88
r443 (  34 35 ) resistor r=25.3262 //w=0.187 //l=0.37 //layer=li \
 //thickness=0.1 //x=16.4 //y=3.14 //x2=16.4 //y2=3.51
r444 (  33 34 ) resistor r=25.3262 //w=0.187 //l=0.37 //layer=li \
 //thickness=0.1 //x=16.4 //y=2.77 //x2=16.4 //y2=3.14
r445 (  33 69 ) resistor r=34.5668 //w=0.187 //l=0.505 //layer=li \
 //thickness=0.1 //x=16.4 //y=2.77 //x2=16.4 //y2=2.265
r446 (  32 66 ) resistor r=17.7968 //w=0.187 //l=0.26 //layer=li \
 //thickness=0.1 //x=12.7 //y=4.62 //x2=12.7 //y2=4.88
r447 (  31 57 ) resistor r=59.893 //w=0.187 //l=0.875 //layer=li \
 //thickness=0.1 //x=10.48 //y=3.14 //x2=10.48 //y2=2.265
r448 (  29 30 ) resistor r=25.3262 //w=0.187 //l=0.37 //layer=li \
 //thickness=0.1 //x=10.11 //y=4.25 //x2=10.11 //y2=4.62
r449 (  28 29 ) resistor r=25.3262 //w=0.187 //l=0.37 //layer=li \
 //thickness=0.1 //x=10.11 //y=3.88 //x2=10.11 //y2=4.25
r450 (  27 39 ) resistor r=6.50267 //w=0.187 //l=0.095 //layer=li \
 //thickness=0.1 //x=2.34 //y=4.62 //x2=2.34 //y2=4.715
r451 (  26 27 ) resistor r=50.6524 //w=0.187 //l=0.74 //layer=li \
 //thickness=0.1 //x=2.34 //y=3.88 //x2=2.34 //y2=4.62
r452 (  25 26 ) resistor r=25.3262 //w=0.187 //l=0.37 //layer=li \
 //thickness=0.1 //x=2.34 //y=3.51 //x2=2.34 //y2=3.88
r453 (  24 25 ) resistor r=25.3262 //w=0.187 //l=0.37 //layer=li \
 //thickness=0.1 //x=2.34 //y=3.14 //x2=2.34 //y2=3.51
r454 (  23 24 ) resistor r=25.3262 //w=0.187 //l=0.37 //layer=li \
 //thickness=0.1 //x=2.34 //y=2.77 //x2=2.34 //y2=3.14
r455 (  23 41 ) resistor r=34.9091 //w=0.187 //l=0.51 //layer=li \
 //thickness=0.1 //x=2.34 //y=2.77 //x2=2.34 //y2=2.26
r456 (  22 38 ) resistor r=9.3 //w=0.17 //l=0.17 //layer=mcon //count=1 \
 //x=16.4 //y=4.62 //x2=16.4 //y2=4.62
r457 (  20 34 ) resistor r=9.3 //w=0.17 //l=0.17 //layer=mcon //count=1 \
 //x=16.4 //y=3.14 //x2=16.4 //y2=3.14
r458 (  18 32 ) resistor r=9.3 //w=0.17 //l=0.17 //layer=mcon //count=1 \
 //x=12.7 //y=4.62 //x2=12.7 //y2=4.62
r459 (  16 31 ) resistor r=9.3 //w=0.17 //l=0.17 //layer=mcon //count=1 \
 //x=10.48 //y=3.14 //x2=10.48 //y2=3.14
r460 (  14 28 ) resistor r=9.3 //w=0.17 //l=0.17 //layer=mcon //count=1 \
 //x=10.11 //y=3.88 //x2=10.11 //y2=3.88
r461 (  12 30 ) resistor r=9.3 //w=0.17 //l=0.17 //layer=mcon //count=1 \
 //x=10.11 //y=4.62 //x2=10.11 //y2=4.62
r462 (  10 26 ) resistor r=9.3 //w=0.17 //l=0.17 //layer=mcon //count=1 \
 //x=2.34 //y=3.88 //x2=2.34 //y2=3.88
r463 (  8 18 ) resistor r=0.0880901 //w=0.191 //l=0.115 //layer=m1 \
 //thickness=0.36 //x=12.815 //y=4.62 //x2=12.7 //y2=4.62
r464 (  7 22 ) resistor r=0.0717383 //w=0.224 //l=0.115 //layer=m1 \
 //thickness=0.36 //x=16.285 //y=4.62 //x2=16.4 //y2=4.62
r465 (  7 8 ) resistor r=3.31107 //w=0.131 //l=3.47 //layer=m1 \
 //thickness=0.36 //x=16.285 //y=4.62 //x2=12.815 //y2=4.62
r466 (  6 16 ) resistor r=0.0717383 //w=0.224 //l=0.115 //layer=m1 \
 //thickness=0.36 //x=10.595 //y=3.14 //x2=10.48 //y2=3.14
r467 (  5 20 ) resistor r=0.0717383 //w=0.224 //l=0.115 //layer=m1 \
 //thickness=0.36 //x=16.285 //y=3.14 //x2=16.4 //y2=3.14
r468 (  5 6 ) resistor r=5.42939 //w=0.131 //l=5.69 //layer=m1 \
 //thickness=0.36 //x=16.285 //y=3.14 //x2=10.595 //y2=3.14
r469 (  4 12 ) resistor r=0.0717383 //w=0.224 //l=0.115 //layer=m1 \
 //thickness=0.36 //x=10.225 //y=4.62 //x2=10.11 //y2=4.62
r470 (  3 18 ) resistor r=0.0880901 //w=0.191 //l=0.115 //layer=m1 \
 //thickness=0.36 //x=12.585 //y=4.62 //x2=12.7 //y2=4.62
r471 (  3 4 ) resistor r=2.25191 //w=0.131 //l=2.36 //layer=m1 \
 //thickness=0.36 //x=12.585 //y=4.62 //x2=10.225 //y2=4.62
r472 (  2 10 ) resistor r=0.0717383 //w=0.224 //l=0.115 //layer=m1 \
 //thickness=0.36 //x=2.455 //y=3.88 //x2=2.34 //y2=3.88
r473 (  1 14 ) resistor r=0.0717383 //w=0.224 //l=0.115 //layer=m1 \
 //thickness=0.36 //x=9.995 //y=3.88 //x2=10.11 //y2=3.88
r474 (  1 2 ) resistor r=7.19466 //w=0.131 //l=7.54 //layer=m1 \
 //thickness=0.36 //x=9.995 //y=3.88 //x2=2.455 //y2=3.88
ends PM_HA\%B

subckt PM_HA\%noxref_6 ( 1 2 17 18 19 20 24 26 33 34 35 36 37 38 39 43 45 51 \
 52 60 62 64 )
c175 ( 64 0 ) capacitor c=0.0288629f //x=7.01 //y=5.2
c176 ( 62 0 ) capacitor c=0.0173218f //x=6.965 //y=1.09
c177 ( 60 0 ) capacitor c=0.058481f //x=13.81 //y=4.88
c178 ( 52 0 ) capacitor c=0.0417768f //x=14.005 //y=1.435
c179 ( 51 0 ) capacitor c=0.0192208f //x=14.005 //y=1.09
c180 ( 45 0 ) capacitor c=0.0124204f //x=13.85 //y=1.59
c181 ( 43 0 ) capacitor c=0.0157803f //x=13.85 //y=0.935
c182 ( 39 0 ) capacitor c=0.0903287f //x=13.475 //y=2.1
c183 ( 38 0 ) capacitor c=0.0194674f //x=13.475 //y=1.745
c184 ( 37 0 ) capacitor c=0.0168481f //x=13.475 //y=1.435
c185 ( 36 0 ) capacitor c=0.0174345f //x=13.475 //y=1.09
c186 ( 35 0 ) capacitor c=0.153255f //x=13.92 //y=6.2
c187 ( 34 0 ) capacitor c=0.110227f //x=13.48 //y=6.2
c188 ( 26 0 ) capacitor c=0.0737449f //x=13.81 //y=2.265
c189 ( 24 0 ) capacitor c=0.0836439f //x=7.52 //y=2.77
c190 ( 20 0 ) capacitor c=0.00417404f //x=7.24 //y=4.76
c191 ( 19 0 ) capacitor c=0.0118459f //x=7.435 //y=4.76
c192 ( 18 0 ) capacitor c=0.00612032f //x=7.235 //y=2.26
c193 ( 17 0 ) capacitor c=0.0133843f //x=7.435 //y=2.26
c194 ( 2 0 ) capacitor c=0.0160697f //x=7.635 //y=2.77
c195 ( 1 0 ) capacitor c=0.16891f //x=13.695 //y=2.77
r196 (  60 61 ) resistor r=22.7554 //w=0.233 //l=0.11 //layer=ply \
 //thickness=0.18 //x=13.81 //y=4.88 //x2=13.92 //y2=4.88
r197 (  52 58 ) resistor r=45.1352 //w=0.168 //l=0.173853 //layer=ply \
 //thickness=0.18 //x=14.005 //y=1.435 //x2=13.965 //y2=1.59
r198 (  51 57 ) resistor r=45.1352 //w=0.168 //l=0.173853 //layer=ply \
 //thickness=0.18 //x=14.005 //y=1.09 //x2=13.965 //y2=0.935
r199 (  51 52 ) resistor r=176.904 //w=0.094 //l=0.345 //layer=ply \
 //thickness=0.18 //x=14.005 //y=1.09 //x2=14.005 //y2=1.435
r200 (  48 61 ) resistor r=13.0941 //w=0.233 //l=0.165 //layer=ply \
 //thickness=0.18 //x=13.92 //y=5.045 //x2=13.92 //y2=4.88
r201 (  46 54 ) resistor r=10.701 //w=0.21 //l=0.115 //layer=ply \
 //thickness=0.18 //x=13.63 //y=1.59 //x2=13.515 //y2=1.59
r202 (  45 58 ) resistor r=5.52526 //w=0.168 //l=0.115 //layer=ply \
 //thickness=0.18 //x=13.85 //y=1.59 //x2=13.965 //y2=1.59
r203 (  44 53 ) resistor r=5.52526 //w=0.168 //l=0.115 //layer=ply \
 //thickness=0.18 //x=13.63 //y=0.935 //x2=13.515 //y2=0.935
r204 (  43 57 ) resistor r=5.52526 //w=0.168 //l=0.115 //layer=ply \
 //thickness=0.18 //x=13.85 //y=0.935 //x2=13.965 //y2=0.935
r205 (  43 44 ) resistor r=112.809 //w=0.094 //l=0.22 //layer=ply \
 //thickness=0.18 //x=13.85 //y=0.935 //x2=13.63 //y2=0.935
r206 (  40 60 ) resistor r=68.2661 //w=0.233 //l=0.404166 //layer=ply \
 //thickness=0.18 //x=13.48 //y=5.045 //x2=13.81 //y2=4.88
r207 (  39 56 ) resistor r=67.2792 //w=0.24 //l=0.438891 //layer=ply \
 //thickness=0.18 //x=13.475 //y=2.1 //x2=13.81 //y2=2.34
r208 (  38 54 ) resistor r=39.5823 //w=0.21 //l=0.173853 //layer=ply \
 //thickness=0.18 //x=13.475 //y=1.745 //x2=13.515 //y2=1.59
r209 (  38 39 ) resistor r=182.032 //w=0.094 //l=0.355 //layer=ply \
 //thickness=0.18 //x=13.475 //y=1.745 //x2=13.475 //y2=2.1
r210 (  37 54 ) resistor r=39.5823 //w=0.21 //l=0.173853 //layer=ply \
 //thickness=0.18 //x=13.475 //y=1.435 //x2=13.515 //y2=1.59
r211 (  36 53 ) resistor r=45.1352 //w=0.168 //l=0.173853 //layer=ply \
 //thickness=0.18 //x=13.475 //y=1.09 //x2=13.515 //y2=0.935
r212 (  36 37 ) resistor r=176.904 //w=0.094 //l=0.345 //layer=ply \
 //thickness=0.18 //x=13.475 //y=1.09 //x2=13.475 //y2=1.435
r213 (  35 48 ) resistor r=592.245 //w=0.094 //l=1.155 //layer=ply \
 //thickness=0.18 //x=13.92 //y=6.2 //x2=13.92 //y2=5.045
r214 (  34 40 ) resistor r=592.245 //w=0.094 //l=1.155 //layer=ply \
 //thickness=0.18 //x=13.48 //y=6.2 //x2=13.48 //y2=5.045
r215 (  33 45 ) resistor r=56.4043 //w=0.094 //l=0.11 //layer=ply \
 //thickness=0.18 //x=13.74 //y=1.59 //x2=13.85 //y2=1.59
r216 (  33 46 ) resistor r=56.4043 //w=0.094 //l=0.11 //layer=ply \
 //thickness=0.18 //x=13.74 //y=1.59 //x2=13.63 //y2=1.59
r217 (  31 60 ) resistor r=152 //w=0.17 //l=0.17 //layer=licon //count=1 \
 //x=13.81 //y=4.88 //x2=13.81 //y2=4.88
r218 (  29 31 ) resistor r=144.428 //w=0.187 //l=2.11 //layer=li \
 //thickness=0.1 //x=13.81 //y=2.77 //x2=13.81 //y2=4.88
r219 (  26 56 ) resistor r=152 //w=0.17 //l=0.17 //layer=licon //count=1 \
 //x=13.81 //y=2.265 //x2=13.81 //y2=2.265
r220 (  26 29 ) resistor r=34.5668 //w=0.187 //l=0.505 //layer=li \
 //thickness=0.1 //x=13.81 //y=2.265 //x2=13.81 //y2=2.77
r221 (  22 24 ) resistor r=130.396 //w=0.187 //l=1.905 //layer=li \
 //thickness=0.1 //x=7.52 //y=4.675 //x2=7.52 //y2=2.77
r222 (  21 24 ) resistor r=29.0909 //w=0.187 //l=0.425 //layer=li \
 //thickness=0.1 //x=7.52 //y=2.345 //x2=7.52 //y2=2.77
r223 (  19 22 ) resistor r=7.15173 //w=0.17 //l=0.120208 //layer=li \
 //thickness=0.1 //x=7.435 //y=4.76 //x2=7.52 //y2=4.675
r224 (  19 20 ) resistor r=13.3476 //w=0.187 //l=0.195 //layer=li \
 //thickness=0.1 //x=7.435 //y=4.76 //x2=7.24 //y2=4.76
r225 (  17 21 ) resistor r=7.15173 //w=0.17 //l=0.120208 //layer=li \
 //thickness=0.1 //x=7.435 //y=2.26 //x2=7.52 //y2=2.345
r226 (  17 18 ) resistor r=13.6898 //w=0.187 //l=0.2 //layer=li \
 //thickness=0.1 //x=7.435 //y=2.26 //x2=7.235 //y2=2.26
r227 (  11 20 ) resistor r=7.15173 //w=0.17 //l=0.120208 //layer=li \
 //thickness=0.1 //x=7.155 //y=4.845 //x2=7.24 //y2=4.76
r228 (  11 64 ) resistor r=72.5562 //w=0.187 //l=1.06 //layer=li \
 //thickness=0.1 //x=7.155 //y=4.845 //x2=7.155 //y2=5.905
r229 (  7 18 ) resistor r=7.15173 //w=0.17 //l=0.120208 //layer=li \
 //thickness=0.1 //x=7.15 //y=2.175 //x2=7.235 //y2=2.26
r230 (  7 62 ) resistor r=67.7647 //w=0.187 //l=0.99 //layer=li \
 //thickness=0.1 //x=7.15 //y=2.175 //x2=7.15 //y2=1.185
r231 (  6 29 ) resistor r=9.3 //w=0.17 //l=0.17 //layer=mcon //count=1 \
 //x=13.81 //y=2.77 //x2=13.81 //y2=2.77
r232 (  4 24 ) resistor r=9.3 //w=0.17 //l=0.17 //layer=mcon //count=1 \
 //x=7.52 //y=2.77 //x2=7.52 //y2=2.77
r233 (  2 4 ) resistor r=0.0717383 //w=0.224 //l=0.115 //layer=m1 \
 //thickness=0.36 //x=7.635 //y=2.77 //x2=7.52 //y2=2.77
r234 (  1 6 ) resistor r=0.0717383 //w=0.224 //l=0.115 //layer=m1 \
 //thickness=0.36 //x=13.695 //y=2.77 //x2=13.81 //y2=2.77
r235 (  1 2 ) resistor r=5.78244 //w=0.131 //l=6.06 //layer=m1 \
 //thickness=0.36 //x=13.695 //y=2.77 //x2=7.635 //y2=2.77
ends PM_HA\%noxref_6

subckt PM_HA\%SUM ( 1 2 7 8 9 10 11 12 13 14 25 26 27 28 46 47 48 49 57 58 61 \
 62 )
c152 ( 62 0 ) capacitor c=0.0159588f //x=13.555 //y=5.2
c153 ( 61 0 ) capacitor c=0.0159588f //x=10.225 //y=5.2
c154 ( 58 0 ) capacitor c=0.00827922f //x=13.55 //y=1.09
c155 ( 57 0 ) capacitor c=0.00846882f //x=10.22 //y=1.09
c156 ( 49 0 ) capacitor c=0.00178322f //x=13.825 //y=1.835
c157 ( 48 0 ) capacitor c=0.0112025f //x=14.095 //y=1.835
c158 ( 47 0 ) capacitor c=0.00235465f //x=13.785 //y=5.385
c159 ( 46 0 ) capacitor c=0.0121398f //x=14.095 //y=5.385
c160 ( 28 0 ) capacitor c=0.00178606f //x=10.495 //y=1.835
c161 ( 27 0 ) capacitor c=0.0109582f //x=10.765 //y=1.835
c162 ( 26 0 ) capacitor c=0.00235465f //x=10.455 //y=5.385
c163 ( 25 0 ) capacitor c=0.0119514f //x=10.765 //y=5.385
c164 ( 11 0 ) capacitor c=0.0892717f //x=14.18 //y=2.4
c165 ( 7 0 ) capacitor c=0.101908f //x=10.85 //y=2.4
c166 ( 2 0 ) capacitor c=0.0058186f //x=10.965 //y=3.88
c167 ( 1 0 ) capacitor c=0.0664888f //x=14.065 //y=3.88
r168 (  48 50 ) resistor r=7.15173 //w=0.17 //l=0.120208 //layer=li \
 //thickness=0.1 //x=14.095 //y=1.835 //x2=14.18 //y2=1.92
r169 (  48 49 ) resistor r=18.4813 //w=0.187 //l=0.27 //layer=li \
 //thickness=0.1 //x=14.095 //y=1.835 //x2=13.825 //y2=1.835
r170 (  46 51 ) resistor r=7.15173 //w=0.17 //l=0.120208 //layer=li \
 //thickness=0.1 //x=14.095 //y=5.385 //x2=14.18 //y2=5.3
r171 (  46 47 ) resistor r=21.2193 //w=0.187 //l=0.31 //layer=li \
 //thickness=0.1 //x=14.095 //y=5.385 //x2=13.785 //y2=5.385
r172 (  42 49 ) resistor r=7.15173 //w=0.17 //l=0.120208 //layer=li \
 //thickness=0.1 //x=13.74 //y=1.75 //x2=13.825 //y2=1.835
r173 (  42 58 ) resistor r=38.6738 //w=0.187 //l=0.565 //layer=li \
 //thickness=0.1 //x=13.74 //y=1.75 //x2=13.74 //y2=1.185
r174 (  36 47 ) resistor r=7.15173 //w=0.17 //l=0.120208 //layer=li \
 //thickness=0.1 //x=13.7 //y=5.47 //x2=13.785 //y2=5.385
r175 (  36 62 ) resistor r=29.0909 //w=0.187 //l=0.425 //layer=li \
 //thickness=0.1 //x=13.7 //y=5.47 //x2=13.7 //y2=5.895
r176 (  27 29 ) resistor r=7.15173 //w=0.17 //l=0.120208 //layer=li \
 //thickness=0.1 //x=10.765 //y=1.835 //x2=10.85 //y2=1.92
r177 (  27 28 ) resistor r=18.4813 //w=0.187 //l=0.27 //layer=li \
 //thickness=0.1 //x=10.765 //y=1.835 //x2=10.495 //y2=1.835
r178 (  25 30 ) resistor r=7.15173 //w=0.17 //l=0.120208 //layer=li \
 //thickness=0.1 //x=10.765 //y=5.385 //x2=10.85 //y2=5.3
r179 (  25 26 ) resistor r=21.2193 //w=0.187 //l=0.31 //layer=li \
 //thickness=0.1 //x=10.765 //y=5.385 //x2=10.455 //y2=5.385
r180 (  21 28 ) resistor r=7.15173 //w=0.17 //l=0.120208 //layer=li \
 //thickness=0.1 //x=10.41 //y=1.75 //x2=10.495 //y2=1.835
r181 (  21 57 ) resistor r=38.6738 //w=0.187 //l=0.565 //layer=li \
 //thickness=0.1 //x=10.41 //y=1.75 //x2=10.41 //y2=1.185
r182 (  15 26 ) resistor r=7.15173 //w=0.17 //l=0.120208 //layer=li \
 //thickness=0.1 //x=10.37 //y=5.47 //x2=10.455 //y2=5.385
r183 (  15 61 ) resistor r=29.0909 //w=0.187 //l=0.425 //layer=li \
 //thickness=0.1 //x=10.37 //y=5.47 //x2=10.37 //y2=5.895
r184 (  14 51 ) resistor r=21.2193 //w=0.187 //l=0.31 //layer=li \
 //thickness=0.1 //x=14.18 //y=4.99 //x2=14.18 //y2=5.3
r185 (  13 14 ) resistor r=75.9786 //w=0.187 //l=1.11 //layer=li \
 //thickness=0.1 //x=14.18 //y=3.88 //x2=14.18 //y2=4.99
r186 (  12 13 ) resistor r=75.9786 //w=0.187 //l=1.11 //layer=li \
 //thickness=0.1 //x=14.18 //y=2.77 //x2=14.18 //y2=3.88
r187 (  11 12 ) resistor r=25.3262 //w=0.187 //l=0.37 //layer=li \
 //thickness=0.1 //x=14.18 //y=2.4 //x2=14.18 //y2=2.77
r188 (  11 50 ) resistor r=32.8556 //w=0.187 //l=0.48 //layer=li \
 //thickness=0.1 //x=14.18 //y=2.4 //x2=14.18 //y2=1.92
r189 (  10 30 ) resistor r=21.2193 //w=0.187 //l=0.31 //layer=li \
 //thickness=0.1 //x=10.85 //y=4.99 //x2=10.85 //y2=5.3
r190 (  9 10 ) resistor r=75.9786 //w=0.187 //l=1.11 //layer=li \
 //thickness=0.1 //x=10.85 //y=3.88 //x2=10.85 //y2=4.99
r191 (  8 9 ) resistor r=25.3262 //w=0.187 //l=0.37 //layer=li //thickness=0.1 \
 //x=10.85 //y=3.51 //x2=10.85 //y2=3.88
r192 (  7 8 ) resistor r=75.9786 //w=0.187 //l=1.11 //layer=li //thickness=0.1 \
 //x=10.85 //y=2.4 //x2=10.85 //y2=3.51
r193 (  7 29 ) resistor r=32.8556 //w=0.187 //l=0.48 //layer=li \
 //thickness=0.1 //x=10.85 //y=2.4 //x2=10.85 //y2=1.92
r194 (  6 13 ) resistor r=9.3 //w=0.17 //l=0.17 //layer=mcon //count=1 \
 //x=14.18 //y=3.88 //x2=14.18 //y2=3.88
r195 (  4 9 ) resistor r=9.3 //w=0.17 //l=0.17 //layer=mcon //count=1 \
 //x=10.85 //y=3.88 //x2=10.85 //y2=3.88
r196 (  2 4 ) resistor r=0.0717383 //w=0.224 //l=0.115 //layer=m1 \
 //thickness=0.36 //x=10.965 //y=3.88 //x2=10.85 //y2=3.88
r197 (  1 6 ) resistor r=0.0717383 //w=0.224 //l=0.115 //layer=m1 \
 //thickness=0.36 //x=14.065 //y=3.88 //x2=14.18 //y2=3.88
r198 (  1 2 ) resistor r=2.95802 //w=0.131 //l=3.1 //layer=m1 //thickness=0.36 \
 //x=14.065 //y=3.88 //x2=10.965 //y2=3.88
ends PM_HA\%SUM

subckt PM_HA\%noxref_8 ( 1 2 3 4 14 20 28 31 32 33 34 45 46 47 54 55 56 57 58 \
 60 63 64 66 74 76 )
c164 ( 76 0 ) capacitor c=0.028734f //x=15.88 //y=5.2
c165 ( 74 0 ) capacitor c=0.0173218f //x=15.835 //y=1.09
c166 ( 66 0 ) capacitor c=0.0576608f //x=10.48 //y=4.88
c167 ( 64 0 ) capacitor c=0.0318948f //x=13.035 //y=1.395
c168 ( 63 0 ) capacitor c=0.0187407f //x=13.035 //y=1.05
c169 ( 60 0 ) capacitor c=0.0141798f //x=12.88 //y=1.55
c170 ( 58 0 ) capacitor c=0.0149852f //x=12.88 //y=0.895
c171 ( 57 0 ) capacitor c=0.0836807f //x=12.505 //y=2.1
c172 ( 56 0 ) capacitor c=0.0229722f //x=12.505 //y=1.705
c173 ( 55 0 ) capacitor c=0.0234352f //x=12.505 //y=1.395
c174 ( 54 0 ) capacitor c=0.0199366f //x=12.505 //y=1.05
c175 ( 47 0 ) capacitor c=0.153255f //x=10.59 //y=6.2
c176 ( 46 0 ) capacitor c=0.110227f //x=10.15 //y=6.2
c177 ( 34 0 ) capacitor c=0.00670488f //x=15.745 //y=4.76
c178 ( 33 0 ) capacitor c=0.0137356f //x=15.94 //y=4.76
c179 ( 32 0 ) capacitor c=0.00580686f //x=15.745 //y=2.26
c180 ( 31 0 ) capacitor c=0.0128831f //x=15.945 //y=2.26
c181 ( 28 0 ) capacitor c=0.0775793f //x=15.66 //y=3.51
c182 ( 20 0 ) capacitor c=0.0551449f //x=12.7 //y=2.265
c183 ( 14 0 ) capacitor c=0.016943f //x=10.48 //y=4.25
c184 ( 4 0 ) capacitor c=0.0126928f //x=12.815 //y=3.51
c185 ( 3 0 ) capacitor c=0.0544915f //x=15.545 //y=3.51
c186 ( 2 0 ) capacitor c=0.00882264f //x=10.595 //y=4.25
c187 ( 1 0 ) capacitor c=0.0848617f //x=15.545 //y=4.25
r188 (  66 67 ) resistor r=22.7554 //w=0.233 //l=0.11 //layer=ply \
 //thickness=0.18 //x=10.48 //y=4.88 //x2=10.59 //y2=4.88
r189 (  64 73 ) resistor r=45.1352 //w=0.168 //l=0.173853 //layer=ply \
 //thickness=0.18 //x=13.035 //y=1.395 //x2=12.995 //y2=1.55
r190 (  63 72 ) resistor r=45.1352 //w=0.168 //l=0.173853 //layer=ply \
 //thickness=0.18 //x=13.035 //y=1.05 //x2=12.995 //y2=0.895
r191 (  63 64 ) resistor r=176.904 //w=0.094 //l=0.345 //layer=ply \
 //thickness=0.18 //x=13.035 //y=1.05 //x2=13.035 //y2=1.395
r192 (  61 71 ) resistor r=10.701 //w=0.21 //l=0.115 //layer=ply \
 //thickness=0.18 //x=12.66 //y=1.55 //x2=12.545 //y2=1.55
r193 (  60 73 ) resistor r=5.52526 //w=0.168 //l=0.115 //layer=ply \
 //thickness=0.18 //x=12.88 //y=1.55 //x2=12.995 //y2=1.55
r194 (  59 70 ) resistor r=5.52526 //w=0.168 //l=0.115 //layer=ply \
 //thickness=0.18 //x=12.66 //y=0.895 //x2=12.545 //y2=0.895
r195 (  58 72 ) resistor r=5.52526 //w=0.168 //l=0.115 //layer=ply \
 //thickness=0.18 //x=12.88 //y=0.895 //x2=12.995 //y2=0.895
r196 (  58 59 ) resistor r=112.809 //w=0.094 //l=0.22 //layer=ply \
 //thickness=0.18 //x=12.88 //y=0.895 //x2=12.66 //y2=0.895
r197 (  57 69 ) resistor r=34.8111 //w=0.27 //l=0.264953 //layer=ply \
 //thickness=0.18 //x=12.505 //y=2.1 //x2=12.7 //y2=2.265
r198 (  56 71 ) resistor r=39.5823 //w=0.21 //l=0.173853 //layer=ply \
 //thickness=0.18 //x=12.505 //y=1.705 //x2=12.545 //y2=1.55
r199 (  56 57 ) resistor r=202.543 //w=0.094 //l=0.395 //layer=ply \
 //thickness=0.18 //x=12.505 //y=1.705 //x2=12.505 //y2=2.1
r200 (  55 71 ) resistor r=39.5823 //w=0.21 //l=0.173853 //layer=ply \
 //thickness=0.18 //x=12.505 //y=1.395 //x2=12.545 //y2=1.55
r201 (  54 70 ) resistor r=45.1352 //w=0.168 //l=0.173853 //layer=ply \
 //thickness=0.18 //x=12.505 //y=1.05 //x2=12.545 //y2=0.895
r202 (  54 55 ) resistor r=176.904 //w=0.094 //l=0.345 //layer=ply \
 //thickness=0.18 //x=12.505 //y=1.05 //x2=12.505 //y2=1.395
r203 (  51 67 ) resistor r=13.0941 //w=0.233 //l=0.165 //layer=ply \
 //thickness=0.18 //x=10.59 //y=5.045 //x2=10.59 //y2=4.88
r204 (  48 66 ) resistor r=68.2661 //w=0.233 //l=0.404166 //layer=ply \
 //thickness=0.18 //x=10.15 //y=5.045 //x2=10.48 //y2=4.88
r205 (  47 51 ) resistor r=592.245 //w=0.094 //l=1.155 //layer=ply \
 //thickness=0.18 //x=10.59 //y=6.2 //x2=10.59 //y2=5.045
r206 (  46 48 ) resistor r=592.245 //w=0.094 //l=1.155 //layer=ply \
 //thickness=0.18 //x=10.15 //y=6.2 //x2=10.15 //y2=5.045
r207 (  45 60 ) resistor r=56.4043 //w=0.094 //l=0.11 //layer=ply \
 //thickness=0.18 //x=12.77 //y=1.55 //x2=12.88 //y2=1.55
r208 (  45 61 ) resistor r=56.4043 //w=0.094 //l=0.11 //layer=ply \
 //thickness=0.18 //x=12.77 //y=1.55 //x2=12.66 //y2=1.55
r209 (  41 74 ) resistor r=67.7647 //w=0.187 //l=0.99 //layer=li \
 //thickness=0.1 //x=16.03 //y=2.175 //x2=16.03 //y2=1.185
r210 (  35 76 ) resistor r=72.5562 //w=0.187 //l=1.06 //layer=li \
 //thickness=0.1 //x=16.025 //y=4.845 //x2=16.025 //y2=5.905
r211 (  33 35 ) resistor r=7.15173 //w=0.17 //l=0.120208 //layer=li \
 //thickness=0.1 //x=15.94 //y=4.76 //x2=16.025 //y2=4.845
r212 (  33 34 ) resistor r=13.3476 //w=0.187 //l=0.195 //layer=li \
 //thickness=0.1 //x=15.94 //y=4.76 //x2=15.745 //y2=4.76
r213 (  31 41 ) resistor r=7.15173 //w=0.17 //l=0.120208 //layer=li \
 //thickness=0.1 //x=15.945 //y=2.26 //x2=16.03 //y2=2.175
r214 (  31 32 ) resistor r=13.6898 //w=0.187 //l=0.2 //layer=li \
 //thickness=0.1 //x=15.945 //y=2.26 //x2=15.745 //y2=2.26
r215 (  28 30 ) resistor r=50.6524 //w=0.187 //l=0.74 //layer=li \
 //thickness=0.1 //x=15.66 //y=3.51 //x2=15.66 //y2=4.25
r216 (  26 34 ) resistor r=7.15173 //w=0.17 //l=0.120208 //layer=li \
 //thickness=0.1 //x=15.66 //y=4.675 //x2=15.745 //y2=4.76
r217 (  26 30 ) resistor r=29.0909 //w=0.187 //l=0.425 //layer=li \
 //thickness=0.1 //x=15.66 //y=4.675 //x2=15.66 //y2=4.25
r218 (  25 32 ) resistor r=7.15173 //w=0.17 //l=0.120208 //layer=li \
 //thickness=0.1 //x=15.66 //y=2.345 //x2=15.745 //y2=2.26
r219 (  25 28 ) resistor r=79.7433 //w=0.187 //l=1.165 //layer=li \
 //thickness=0.1 //x=15.66 //y=2.345 //x2=15.66 //y2=3.51
r220 (  20 69 ) resistor r=152 //w=0.17 //l=0.17 //layer=licon //count=1 \
 //x=12.7 //y=2.265 //x2=12.7 //y2=2.265
r221 (  20 23 ) resistor r=85.2193 //w=0.187 //l=1.245 //layer=li \
 //thickness=0.1 //x=12.7 //y=2.265 //x2=12.7 //y2=3.51
r222 (  17 66 ) resistor r=152 //w=0.17 //l=0.17 //layer=licon //count=1 \
 //x=10.48 //y=4.88 //x2=10.48 //y2=4.88
r223 (  14 17 ) resistor r=43.123 //w=0.187 //l=0.63 //layer=li \
 //thickness=0.1 //x=10.48 //y=4.25 //x2=10.48 //y2=4.88
r224 (  12 30 ) resistor r=9.3 //w=0.17 //l=0.17 //layer=mcon //count=1 \
 //x=15.66 //y=4.25 //x2=15.66 //y2=4.25
r225 (  10 28 ) resistor r=9.3 //w=0.17 //l=0.17 //layer=mcon //count=1 \
 //x=15.66 //y=3.51 //x2=15.66 //y2=3.51
r226 (  8 23 ) resistor r=9.3 //w=0.17 //l=0.17 //layer=mcon //count=1 \
 //x=12.7 //y=3.51 //x2=12.7 //y2=3.51
r227 (  6 14 ) resistor r=9.3 //w=0.17 //l=0.17 //layer=mcon //count=1 \
 //x=10.48 //y=4.25 //x2=10.48 //y2=4.25
r228 (  4 8 ) resistor r=0.0717383 //w=0.224 //l=0.115 //layer=m1 \
 //thickness=0.36 //x=12.815 //y=3.51 //x2=12.7 //y2=3.51
r229 (  3 10 ) resistor r=0.0717383 //w=0.224 //l=0.115 //layer=m1 \
 //thickness=0.36 //x=15.545 //y=3.51 //x2=15.66 //y2=3.51
r230 (  3 4 ) resistor r=2.60496 //w=0.131 //l=2.73 //layer=m1 \
 //thickness=0.36 //x=15.545 //y=3.51 //x2=12.815 //y2=3.51
r231 (  2 6 ) resistor r=0.0717383 //w=0.224 //l=0.115 //layer=m1 \
 //thickness=0.36 //x=10.595 //y=4.25 //x2=10.48 //y2=4.25
r232 (  1 12 ) resistor r=0.0717383 //w=0.224 //l=0.115 //layer=m1 \
 //thickness=0.36 //x=15.545 //y=4.25 //x2=15.66 //y2=4.25
r233 (  1 2 ) resistor r=4.72328 //w=0.131 //l=4.95 //layer=m1 \
 //thickness=0.36 //x=15.545 //y=4.25 //x2=10.595 //y2=4.25
ends PM_HA\%noxref_8

subckt PM_HA\%noxref_9 ( 1 5 9 10 13 17 29 )
c55 ( 29 0 ) capacitor c=0.0633899f //x=1.05 //y=0.545
c56 ( 17 0 ) capacitor c=0.00722223f //x=3.125 //y=0.795
c57 ( 13 0 ) capacitor c=0.0150745f //x=3.04 //y=0.71
c58 ( 10 0 ) capacitor c=0.00705906f //x=2.155 //y=1.675
c59 ( 9 0 ) capacitor c=0.006761f //x=2.155 //y=0.795
c60 ( 5 0 ) capacitor c=0.0218843f //x=2.07 //y=1.76
c61 ( 1 0 ) capacitor c=0.0113547f //x=1.185 //y=1.675
r62 (  17 29 ) resistor r=3.57586 //w=0.17 //l=0.125 //layer=li \
 //thickness=0.1 //x=3.125 //y=0.795 //x2=3.125 //y2=0.67
r63 (  17 29 ) resistor r=18.139 //w=0.187 //l=0.265 //layer=li \
 //thickness=0.1 //x=3.125 //y=0.795 //x2=3.125 //y2=1.06
r64 (  14 29 ) resistor r=3.57586 //w=0.17 //l=0.103078 //layer=li \
 //thickness=0.1 //x=2.24 //y=0.71 //x2=2.155 //y2=0.67
r65 (  14 29 ) resistor r=27.3797 //w=0.187 //l=0.4 //layer=li //thickness=0.1 \
 //x=2.24 //y=0.71 //x2=2.64 //y2=0.71
r66 (  13 29 ) resistor r=3.57586 //w=0.17 //l=0.103078 //layer=li \
 //thickness=0.1 //x=3.04 //y=0.71 //x2=3.125 //y2=0.67
r67 (  13 29 ) resistor r=27.3797 //w=0.187 //l=0.4 //layer=li //thickness=0.1 \
 //x=3.04 //y=0.71 //x2=2.64 //y2=0.71
r68 (  10 29 ) resistor r=3.57586 //w=0.17 //l=0.125 //layer=li \
 //thickness=0.1 //x=2.155 //y=1.675 //x2=2.155 //y2=1.8
r69 (  10 29 ) resistor r=42.0963 //w=0.187 //l=0.615 //layer=li \
 //thickness=0.1 //x=2.155 //y=1.675 //x2=2.155 //y2=1.06
r70 (  9 29 ) resistor r=3.57586 //w=0.17 //l=0.125 //layer=li //thickness=0.1 \
 //x=2.155 //y=0.795 //x2=2.155 //y2=0.67
r71 (  9 29 ) resistor r=18.139 //w=0.187 //l=0.265 //layer=li //thickness=0.1 \
 //x=2.155 //y=0.795 //x2=2.155 //y2=1.06
r72 (  6 29 ) resistor r=3.57586 //w=0.17 //l=0.103078 //layer=li \
 //thickness=0.1 //x=1.27 //y=1.76 //x2=1.185 //y2=1.8
r73 (  6 29 ) resistor r=27.3797 //w=0.187 //l=0.4 //layer=li //thickness=0.1 \
 //x=1.27 //y=1.76 //x2=1.67 //y2=1.76
r74 (  5 29 ) resistor r=3.57586 //w=0.17 //l=0.103078 //layer=li \
 //thickness=0.1 //x=2.07 //y=1.76 //x2=2.155 //y2=1.8
r75 (  5 29 ) resistor r=27.3797 //w=0.187 //l=0.4 //layer=li //thickness=0.1 \
 //x=2.07 //y=1.76 //x2=1.67 //y2=1.76
r76 (  1 29 ) resistor r=3.57586 //w=0.17 //l=0.125 //layer=li //thickness=0.1 \
 //x=1.185 //y=1.675 //x2=1.185 //y2=1.8
r77 (  1 29 ) resistor r=42.0963 //w=0.187 //l=0.615 //layer=li \
 //thickness=0.1 //x=1.185 //y=1.675 //x2=1.185 //y2=1.06
ends PM_HA\%noxref_9

subckt PM_HA\%COUT ( 1 2 3 4 5 16 17 18 19 27 29 )
c55 ( 29 0 ) capacitor c=0.028734f //x=4.79 //y=5.2
c56 ( 27 0 ) capacitor c=0.0173218f //x=4.745 //y=1.09
c57 ( 19 0 ) capacitor c=0.00417404f //x=5.02 //y=4.76
c58 ( 18 0 ) capacitor c=0.0118896f //x=5.215 //y=4.76
c59 ( 17 0 ) capacitor c=0.00612032f //x=5.015 //y=2.26
c60 ( 16 0 ) capacitor c=0.0138937f //x=5.215 //y=2.26
c61 ( 1 0 ) capacitor c=0.0826122f //x=5.3 //y=2.4
r62 (  18 21 ) resistor r=7.15173 //w=0.17 //l=0.120208 //layer=li \
 //thickness=0.1 //x=5.215 //y=4.76 //x2=5.3 //y2=4.675
r63 (  18 19 ) resistor r=13.3476 //w=0.187 //l=0.195 //layer=li \
 //thickness=0.1 //x=5.215 //y=4.76 //x2=5.02 //y2=4.76
r64 (  16 20 ) resistor r=7.15173 //w=0.17 //l=0.120208 //layer=li \
 //thickness=0.1 //x=5.215 //y=2.26 //x2=5.3 //y2=2.345
r65 (  16 17 ) resistor r=13.6898 //w=0.187 //l=0.2 //layer=li //thickness=0.1 \
 //x=5.215 //y=2.26 //x2=5.015 //y2=2.26
r66 (  10 19 ) resistor r=7.15173 //w=0.17 //l=0.120208 //layer=li \
 //thickness=0.1 //x=4.935 //y=4.845 //x2=5.02 //y2=4.76
r67 (  10 29 ) resistor r=72.5562 //w=0.187 //l=1.06 //layer=li \
 //thickness=0.1 //x=4.935 //y=4.845 //x2=4.935 //y2=5.905
r68 (  6 17 ) resistor r=7.15173 //w=0.17 //l=0.120208 //layer=li \
 //thickness=0.1 //x=4.93 //y=2.175 //x2=5.015 //y2=2.26
r69 (  6 27 ) resistor r=67.7647 //w=0.187 //l=0.99 //layer=li //thickness=0.1 \
 //x=4.93 //y=2.175 //x2=4.93 //y2=1.185
r70 (  5 21 ) resistor r=3.76471 //w=0.187 //l=0.055 //layer=li \
 //thickness=0.1 //x=5.3 //y=4.62 //x2=5.3 //y2=4.675
r71 (  4 5 ) resistor r=75.9786 //w=0.187 //l=1.11 //layer=li //thickness=0.1 \
 //x=5.3 //y=3.51 //x2=5.3 //y2=4.62
r72 (  3 4 ) resistor r=25.3262 //w=0.187 //l=0.37 //layer=li //thickness=0.1 \
 //x=5.3 //y=3.14 //x2=5.3 //y2=3.51
r73 (  2 3 ) resistor r=25.3262 //w=0.187 //l=0.37 //layer=li //thickness=0.1 \
 //x=5.3 //y=2.77 //x2=5.3 //y2=3.14
r74 (  1 2 ) resistor r=25.3262 //w=0.187 //l=0.37 //layer=li //thickness=0.1 \
 //x=5.3 //y=2.4 //x2=5.3 //y2=2.77
r75 (  1 20 ) resistor r=3.76471 //w=0.187 //l=0.055 //layer=li \
 //thickness=0.1 //x=5.3 //y=2.4 //x2=5.3 //y2=2.345
ends PM_HA\%COUT

subckt PM_HA\%noxref_11 ( 7 8 15 16 23 24 25 )
c44 ( 25 0 ) capacitor c=0.0305804f //x=10.665 //y=5.2
c45 ( 24 0 ) capacitor c=0.0185379f //x=9.785 //y=5.2
c46 ( 23 0 ) capacitor c=0.0384176f //x=8.915 //y=5.2
c47 ( 16 0 ) capacitor c=0.00194711f //x=10.015 //y=7.085
c48 ( 15 0 ) capacitor c=0.0132608f //x=10.725 //y=7.085
c49 ( 8 0 ) capacitor c=0.00644339f //x=9.135 //y=5.385
c50 ( 7 0 ) capacitor c=0.0195248f //x=9.845 //y=5.385
r51 (  17 25 ) resistor r=5.81818 //w=0.187 //l=0.085 //layer=li \
 //thickness=0.1 //x=10.81 //y=7 //x2=10.81 //y2=6.915
r52 (  15 17 ) resistor r=7.15173 //w=0.17 //l=0.120208 //layer=li \
 //thickness=0.1 //x=10.725 //y=7.085 //x2=10.81 //y2=7
r53 (  15 16 ) resistor r=48.5989 //w=0.187 //l=0.71 //layer=li \
 //thickness=0.1 //x=10.725 //y=7.085 //x2=10.015 //y2=7.085
r54 (  10 16 ) resistor r=7.15173 //w=0.17 //l=0.120208 //layer=li \
 //thickness=0.1 //x=9.93 //y=7 //x2=10.015 //y2=7.085
r55 (  10 24 ) resistor r=29.0909 //w=0.187 //l=0.425 //layer=li \
 //thickness=0.1 //x=9.93 //y=7 //x2=9.93 //y2=6.575
r56 (  9 24 ) resistor r=29.0909 //w=0.187 //l=0.425 //layer=li \
 //thickness=0.1 //x=9.93 //y=5.47 //x2=9.93 //y2=5.895
r57 (  7 9 ) resistor r=7.15173 //w=0.17 //l=0.120208 //layer=li \
 //thickness=0.1 //x=9.845 //y=5.385 //x2=9.93 //y2=5.47
r58 (  7 8 ) resistor r=48.5989 //w=0.187 //l=0.71 //layer=li //thickness=0.1 \
 //x=9.845 //y=5.385 //x2=9.135 //y2=5.385
r59 (  1 8 ) resistor r=7.15173 //w=0.17 //l=0.120208 //layer=li \
 //thickness=0.1 //x=9.05 //y=5.47 //x2=9.135 //y2=5.385
r60 (  1 23 ) resistor r=29.0909 //w=0.187 //l=0.425 //layer=li \
 //thickness=0.1 //x=9.05 //y=5.47 //x2=9.05 //y2=5.895
ends PM_HA\%noxref_11

subckt PM_HA\%noxref_12 ( 1 5 9 10 13 17 29 )
c53 ( 29 0 ) capacitor c=0.0632228f //x=8.82 //y=0.55
c54 ( 17 0 ) capacitor c=0.00723243f //x=10.895 //y=0.8
c55 ( 13 0 ) capacitor c=0.0150659f //x=10.81 //y=0.715
c56 ( 10 0 ) capacitor c=0.00656687f //x=9.925 //y=1.68
c57 ( 9 0 ) capacitor c=0.00677124f //x=9.925 //y=0.8
c58 ( 5 0 ) capacitor c=0.0181169f //x=9.84 //y=1.765
c59 ( 1 0 ) capacitor c=0.0076549f //x=8.955 //y=1.68
r60 (  17 29 ) resistor r=3.57586 //w=0.17 //l=0.125 //layer=li \
 //thickness=0.1 //x=10.895 //y=0.8 //x2=10.895 //y2=0.675
r61 (  17 29 ) resistor r=18.139 //w=0.187 //l=0.265 //layer=li \
 //thickness=0.1 //x=10.895 //y=0.8 //x2=10.895 //y2=1.065
r62 (  14 29 ) resistor r=3.57586 //w=0.17 //l=0.103078 //layer=li \
 //thickness=0.1 //x=10.01 //y=0.715 //x2=9.925 //y2=0.675
r63 (  14 29 ) resistor r=27.3797 //w=0.187 //l=0.4 //layer=li //thickness=0.1 \
 //x=10.01 //y=0.715 //x2=10.41 //y2=0.715
r64 (  13 29 ) resistor r=3.57586 //w=0.17 //l=0.103078 //layer=li \
 //thickness=0.1 //x=10.81 //y=0.715 //x2=10.895 //y2=0.675
r65 (  13 29 ) resistor r=27.3797 //w=0.187 //l=0.4 //layer=li //thickness=0.1 \
 //x=10.81 //y=0.715 //x2=10.41 //y2=0.715
r66 (  10 29 ) resistor r=3.57586 //w=0.17 //l=0.125 //layer=li \
 //thickness=0.1 //x=9.925 //y=1.68 //x2=9.925 //y2=1.805
r67 (  10 29 ) resistor r=42.0963 //w=0.187 //l=0.615 //layer=li \
 //thickness=0.1 //x=9.925 //y=1.68 //x2=9.925 //y2=1.065
r68 (  9 29 ) resistor r=3.57586 //w=0.17 //l=0.125 //layer=li //thickness=0.1 \
 //x=9.925 //y=0.8 //x2=9.925 //y2=0.675
r69 (  9 29 ) resistor r=18.139 //w=0.187 //l=0.265 //layer=li //thickness=0.1 \
 //x=9.925 //y=0.8 //x2=9.925 //y2=1.065
r70 (  6 29 ) resistor r=3.57586 //w=0.17 //l=0.103078 //layer=li \
 //thickness=0.1 //x=9.04 //y=1.765 //x2=8.955 //y2=1.805
r71 (  6 29 ) resistor r=27.3797 //w=0.187 //l=0.4 //layer=li //thickness=0.1 \
 //x=9.04 //y=1.765 //x2=9.44 //y2=1.765
r72 (  5 29 ) resistor r=3.57586 //w=0.17 //l=0.103078 //layer=li \
 //thickness=0.1 //x=9.84 //y=1.765 //x2=9.925 //y2=1.805
r73 (  5 29 ) resistor r=27.3797 //w=0.187 //l=0.4 //layer=li //thickness=0.1 \
 //x=9.84 //y=1.765 //x2=9.44 //y2=1.765
r74 (  1 29 ) resistor r=3.57586 //w=0.17 //l=0.125 //layer=li //thickness=0.1 \
 //x=8.955 //y=1.68 //x2=8.955 //y2=1.805
r75 (  1 29 ) resistor r=42.0963 //w=0.187 //l=0.615 //layer=li \
 //thickness=0.1 //x=8.955 //y=1.68 //x2=8.955 //y2=1.065
ends PM_HA\%noxref_12

subckt PM_HA\%noxref_13 ( 7 8 15 16 23 24 25 )
c43 ( 25 0 ) capacitor c=0.0305804f //x=13.995 //y=5.2
c44 ( 24 0 ) capacitor c=0.0185379f //x=13.115 //y=5.2
c45 ( 23 0 ) capacitor c=0.0384176f //x=12.245 //y=5.2
c46 ( 16 0 ) capacitor c=0.00194711f //x=13.345 //y=7.085
c47 ( 15 0 ) capacitor c=0.0133643f //x=14.055 //y=7.085
c48 ( 8 0 ) capacitor c=0.00598116f //x=12.465 //y=5.385
c49 ( 7 0 ) capacitor c=0.0182615f //x=13.175 //y=5.385
r50 (  17 25 ) resistor r=5.81818 //w=0.187 //l=0.085 //layer=li \
 //thickness=0.1 //x=14.14 //y=7 //x2=14.14 //y2=6.915
r51 (  15 17 ) resistor r=7.15173 //w=0.17 //l=0.120208 //layer=li \
 //thickness=0.1 //x=14.055 //y=7.085 //x2=14.14 //y2=7
r52 (  15 16 ) resistor r=48.5989 //w=0.187 //l=0.71 //layer=li \
 //thickness=0.1 //x=14.055 //y=7.085 //x2=13.345 //y2=7.085
r53 (  10 16 ) resistor r=7.15173 //w=0.17 //l=0.120208 //layer=li \
 //thickness=0.1 //x=13.26 //y=7 //x2=13.345 //y2=7.085
r54 (  10 24 ) resistor r=29.0909 //w=0.187 //l=0.425 //layer=li \
 //thickness=0.1 //x=13.26 //y=7 //x2=13.26 //y2=6.575
r55 (  9 24 ) resistor r=29.0909 //w=0.187 //l=0.425 //layer=li \
 //thickness=0.1 //x=13.26 //y=5.47 //x2=13.26 //y2=5.895
r56 (  7 9 ) resistor r=7.15173 //w=0.17 //l=0.120208 //layer=li \
 //thickness=0.1 //x=13.175 //y=5.385 //x2=13.26 //y2=5.47
r57 (  7 8 ) resistor r=48.5989 //w=0.187 //l=0.71 //layer=li //thickness=0.1 \
 //x=13.175 //y=5.385 //x2=12.465 //y2=5.385
r58 (  1 8 ) resistor r=7.15173 //w=0.17 //l=0.120208 //layer=li \
 //thickness=0.1 //x=12.38 //y=5.47 //x2=12.465 //y2=5.385
r59 (  1 23 ) resistor r=29.0909 //w=0.187 //l=0.425 //layer=li \
 //thickness=0.1 //x=12.38 //y=5.47 //x2=12.38 //y2=5.895
ends PM_HA\%noxref_13

subckt PM_HA\%noxref_14 ( 1 5 9 10 13 17 29 )
c53 ( 29 0 ) capacitor c=0.063541f //x=12.15 //y=0.55
c54 ( 17 0 ) capacitor c=0.00723243f //x=14.225 //y=0.8
c55 ( 13 0 ) capacitor c=0.0153645f //x=14.14 //y=0.715
c56 ( 10 0 ) capacitor c=0.00656687f //x=13.255 //y=1.68
c57 ( 9 0 ) capacitor c=0.00677124f //x=13.255 //y=0.8
c58 ( 5 0 ) capacitor c=0.0181169f //x=13.17 //y=1.765
c59 ( 1 0 ) capacitor c=0.0076549f //x=12.285 //y=1.68
r60 (  17 29 ) resistor r=3.57586 //w=0.17 //l=0.125 //layer=li \
 //thickness=0.1 //x=14.225 //y=0.8 //x2=14.225 //y2=0.675
r61 (  17 29 ) resistor r=18.139 //w=0.187 //l=0.265 //layer=li \
 //thickness=0.1 //x=14.225 //y=0.8 //x2=14.225 //y2=1.065
r62 (  14 29 ) resistor r=3.57586 //w=0.17 //l=0.103078 //layer=li \
 //thickness=0.1 //x=13.34 //y=0.715 //x2=13.255 //y2=0.675
r63 (  14 29 ) resistor r=27.3797 //w=0.187 //l=0.4 //layer=li //thickness=0.1 \
 //x=13.34 //y=0.715 //x2=13.74 //y2=0.715
r64 (  13 29 ) resistor r=3.57586 //w=0.17 //l=0.103078 //layer=li \
 //thickness=0.1 //x=14.14 //y=0.715 //x2=14.225 //y2=0.675
r65 (  13 29 ) resistor r=27.3797 //w=0.187 //l=0.4 //layer=li //thickness=0.1 \
 //x=14.14 //y=0.715 //x2=13.74 //y2=0.715
r66 (  10 29 ) resistor r=3.57586 //w=0.17 //l=0.125 //layer=li \
 //thickness=0.1 //x=13.255 //y=1.68 //x2=13.255 //y2=1.805
r67 (  10 29 ) resistor r=42.0963 //w=0.187 //l=0.615 //layer=li \
 //thickness=0.1 //x=13.255 //y=1.68 //x2=13.255 //y2=1.065
r68 (  9 29 ) resistor r=3.57586 //w=0.17 //l=0.125 //layer=li //thickness=0.1 \
 //x=13.255 //y=0.8 //x2=13.255 //y2=0.675
r69 (  9 29 ) resistor r=18.139 //w=0.187 //l=0.265 //layer=li //thickness=0.1 \
 //x=13.255 //y=0.8 //x2=13.255 //y2=1.065
r70 (  6 29 ) resistor r=3.57586 //w=0.17 //l=0.103078 //layer=li \
 //thickness=0.1 //x=12.37 //y=1.765 //x2=12.285 //y2=1.805
r71 (  6 29 ) resistor r=27.3797 //w=0.187 //l=0.4 //layer=li //thickness=0.1 \
 //x=12.37 //y=1.765 //x2=12.77 //y2=1.765
r72 (  5 29 ) resistor r=3.57586 //w=0.17 //l=0.103078 //layer=li \
 //thickness=0.1 //x=13.17 //y=1.765 //x2=13.255 //y2=1.805
r73 (  5 29 ) resistor r=27.3797 //w=0.187 //l=0.4 //layer=li //thickness=0.1 \
 //x=13.17 //y=1.765 //x2=12.77 //y2=1.765
r74 (  1 29 ) resistor r=3.57586 //w=0.17 //l=0.125 //layer=li //thickness=0.1 \
 //x=12.285 //y=1.68 //x2=12.285 //y2=1.805
r75 (  1 29 ) resistor r=42.0963 //w=0.187 //l=0.615 //layer=li \
 //thickness=0.1 //x=12.285 //y=1.68 //x2=12.285 //y2=1.065
ends PM_HA\%noxref_14
