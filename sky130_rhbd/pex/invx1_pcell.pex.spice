// File: invx1_pcell.spi.pex
// Created: Sun Apr 12 08:40:49 2026
// Program "Calibre xRC"
// Version "v2023.2_27.15"
// Nominal Temperature: 30C
// Circuit Temperature: 30C
//
simulator lang=spectre
subckt PM_INVX1_PCELL\%noxref_2 ( 5 23 38 40 41 42 )
c35 ( 42 0 ) capacitor c=0.0632165f //x=1.41 //y=5.02
c36 ( 41 0 ) capacitor c=0.0616796f //x=0.54 //y=5.02
c37 ( 40 0 ) capacitor c=0.240661f //x=1.48 //y=7.4
c38 ( 38 0 ) capacitor c=0.238977f //x=0.74 //y=7.4
c39 ( 23 0 ) capacitor c=0.028723f //x=1.47 //y=7.4
c40 ( 5 0 ) capacitor c=0.111796f //x=1.48 //y=7.4
r41 (  25 40 ) resistor r=4.11603 //w=0.68 //l=0.17 //layer=li //thickness=0.1 \
 //x=1.555 //y=7.23 //x2=1.555 //y2=7.4
r42 (  25 42 ) resistor r=56.4706 //w=0.187 //l=0.825 //layer=li \
 //thickness=0.1 //x=1.555 //y=7.23 //x2=1.555 //y2=6.405
r43 (  24 38 ) resistor r=2.94794 //w=0.34 //l=0.085 //layer=li \
 //thickness=0.1 //x=0.76 //y=7.4 //x2=0.675 //y2=7.4
r44 (  23 40 ) resistor r=2.94794 //w=0.34 //l=0.085 //layer=li \
 //thickness=0.1 //x=1.47 //y=7.4 //x2=1.555 //y2=7.4
r45 (  23 24 ) resistor r=25.4566 //w=0.357 //l=0.71 //layer=li \
 //thickness=0.1 //x=1.47 //y=7.4 //x2=0.76 //y2=7.4
r46 (  15 38 ) resistor r=4.11603 //w=0.68 //l=0.17 //layer=li //thickness=0.1 \
 //x=0.675 //y=7.23 //x2=0.675 //y2=7.4
r47 (  15 41 ) resistor r=56.4706 //w=0.187 //l=0.825 //layer=li \
 //thickness=0.1 //x=0.675 //y=7.23 //x2=0.675 //y2=6.405
r48 (  5 40 ) resistor r=4.65 //w=0.17 //l=0.34 //layer=mcon //count=2 \
 //x=1.48 //y=7.4 //x2=1.48 //y2=7.4
r49 (  2 38 ) resistor r=3.1 //w=0.17 //l=0.51 //layer=mcon //count=3 //x=0.74 \
 //y=7.4 //x2=0.74 //y2=7.4
r50 (  2 5 ) resistor r=0.307309 //w=0.301 //l=0.74 //layer=m1 \
 //thickness=0.36 //x=0.74 //y=7.4 //x2=1.48 //y2=7.4
ends PM_INVX1_PCELL\%noxref_2

subckt PM_INVX1_PCELL\%noxref_3 ( 2 4 9 14 18 19 20 21 22 23 24 28 29 30 32 38 \
 39 41 )
c61 ( 41 0 ) capacitor c=0.0588117f //x=0.74 //y=2.085
c62 ( 39 0 ) capacitor c=0.0439576f //x=1.38 //y=1.255
c63 ( 38 0 ) capacitor c=0.0201087f //x=1.38 //y=0.91
c64 ( 32 0 ) capacitor c=0.0161986f //x=1.225 //y=1.41
c65 ( 30 0 ) capacitor c=0.0157807f //x=1.225 //y=0.755
c66 ( 29 0 ) capacitor c=0.0556866f //x=0.97 //y=4.79
c67 ( 28 0 ) capacitor c=0.0406047f //x=1.26 //y=4.79
c68 ( 24 0 ) capacitor c=0.0301471f //x=0.85 //y=1.92
c69 ( 23 0 ) capacitor c=0.0255349f //x=0.85 //y=1.565
c70 ( 22 0 ) capacitor c=0.0234346f //x=0.85 //y=1.255
c71 ( 21 0 ) capacitor c=0.02013f //x=0.85 //y=0.91
c72 ( 20 0 ) capacitor c=0.153839f //x=1.335 //y=6.02
c73 ( 19 0 ) capacitor c=0.15434f //x=0.895 //y=6.02
c74 ( 14 0 ) capacitor c=9.45276e-19 //x=0.74 //y=4.7
c75 ( 9 0 ) capacitor c=9.11699e-19 //x=0.74 //y=2.085
c76 ( 4 0 ) capacitor c=0.0180969f //x=0.74 //y=2.085
c77 ( 2 0 ) capacitor c=0.113113f //x=0.74 //y=4.58
r78 (  41 42 ) resistor r=17.5563 //w=0.302 //l=0.11 //layer=ply \
 //thickness=0.18 //x=0.74 //y=2.085 //x2=0.85 //y2=2.085
r79 (  39 48 ) resistor r=45.1352 //w=0.168 //l=0.173853 //layer=ply \
 //thickness=0.18 //x=1.38 //y=1.255 //x2=1.34 //y2=1.41
r80 (  38 47 ) resistor r=45.1352 //w=0.168 //l=0.173853 //layer=ply \
 //thickness=0.18 //x=1.38 //y=0.91 //x2=1.34 //y2=0.755
r81 (  38 39 ) resistor r=176.904 //w=0.094 //l=0.345 //layer=ply \
 //thickness=0.18 //x=1.38 //y=0.91 //x2=1.38 //y2=1.255
r82 (  33 46 ) resistor r=10.701 //w=0.21 //l=0.115 //layer=ply \
 //thickness=0.18 //x=1.005 //y=1.41 //x2=0.89 //y2=1.41
r83 (  32 48 ) resistor r=5.52526 //w=0.168 //l=0.115 //layer=ply \
 //thickness=0.18 //x=1.225 //y=1.41 //x2=1.34 //y2=1.41
r84 (  31 45 ) resistor r=5.52526 //w=0.168 //l=0.115 //layer=ply \
 //thickness=0.18 //x=1.005 //y=0.755 //x2=0.89 //y2=0.755
r85 (  30 47 ) resistor r=5.52526 //w=0.168 //l=0.115 //layer=ply \
 //thickness=0.18 //x=1.225 //y=0.755 //x2=1.34 //y2=0.755
r86 (  30 31 ) resistor r=112.809 //w=0.094 //l=0.22 //layer=ply \
 //thickness=0.18 //x=1.225 //y=0.755 //x2=1.005 //y2=0.755
r87 (  28 35 ) resistor r=26.9307 //w=0.15 //l=0.106066 //layer=ply \
 //thickness=0.18 //x=1.26 //y=4.79 //x2=1.335 //y2=4.865
r88 (  28 29 ) resistor r=148.702 //w=0.094 //l=0.29 //layer=ply \
 //thickness=0.18 //x=1.26 //y=4.79 //x2=0.97 //y2=4.79
r89 (  25 29 ) resistor r=23.403 //w=0.284 //l=0.106066 //layer=ply \
 //thickness=0.18 //x=0.895 //y=4.865 //x2=0.97 //y2=4.79
r90 (  25 44 ) resistor r=26.3063 //w=0.284 //l=0.229783 //layer=ply \
 //thickness=0.18 //x=0.895 //y=4.865 //x2=0.74 //y2=4.7
r91 (  24 42 ) resistor r=19.1248 //w=0.302 //l=0.165 //layer=ply \
 //thickness=0.18 //x=0.85 //y=1.92 //x2=0.85 //y2=2.085
r92 (  23 46 ) resistor r=39.5823 //w=0.21 //l=0.173853 //layer=ply \
 //thickness=0.18 //x=0.85 //y=1.565 //x2=0.89 //y2=1.41
r93 (  23 24 ) resistor r=182.032 //w=0.094 //l=0.355 //layer=ply \
 //thickness=0.18 //x=0.85 //y=1.565 //x2=0.85 //y2=1.92
r94 (  22 46 ) resistor r=39.5823 //w=0.21 //l=0.173853 //layer=ply \
 //thickness=0.18 //x=0.85 //y=1.255 //x2=0.89 //y2=1.41
r95 (  21 45 ) resistor r=45.1352 //w=0.168 //l=0.173853 //layer=ply \
 //thickness=0.18 //x=0.85 //y=0.91 //x2=0.89 //y2=0.755
r96 (  21 22 ) resistor r=176.904 //w=0.094 //l=0.345 //layer=ply \
 //thickness=0.18 //x=0.85 //y=0.91 //x2=0.85 //y2=1.255
r97 (  20 35 ) resistor r=592.245 //w=0.094 //l=1.155 //layer=ply \
 //thickness=0.18 //x=1.335 //y=6.02 //x2=1.335 //y2=4.865
r98 (  19 25 ) resistor r=592.245 //w=0.094 //l=1.155 //layer=ply \
 //thickness=0.18 //x=0.895 //y=6.02 //x2=0.895 //y2=4.865
r99 (  18 32 ) resistor r=56.4043 //w=0.094 //l=0.11 //layer=ply \
 //thickness=0.18 //x=1.115 //y=1.41 //x2=1.225 //y2=1.41
r100 (  18 33 ) resistor r=56.4043 //w=0.094 //l=0.11 //layer=ply \
 //thickness=0.18 //x=1.115 //y=1.41 //x2=1.005 //y2=1.41
r101 (  14 44 ) resistor r=152 //w=0.17 //l=0.17 //layer=licon //count=1 \
 //x=0.74 //y=4.7 //x2=0.74 //y2=4.7
r102 (  9 41 ) resistor r=152 //w=0.17 //l=0.17 //layer=licon //count=1 \
 //x=0.74 //y=2.085 //x2=0.74 //y2=2.085
r103 (  7 14 ) resistor r=9.3 //w=0.17 //l=0.17 //layer=mcon //count=1 \
 //x=0.74 //y=4.7 //x2=0.74 //y2=4.7
r104 (  4 9 ) resistor r=9.3 //w=0.17 //l=0.17 //layer=mcon //count=1 //x=0.74 \
 //y=2.085 //x2=0.74 //y2=2.085
r105 (  2 7 ) resistor r=0.0732479 //w=0.241 //l=0.122474 //layer=m1 \
 //thickness=0.36 //x=0.74 //y=4.58 //x2=0.745 //y2=4.7
r106 (  1 4 ) resistor r=0.116051 //w=0.211 //l=0.165 //layer=m1 \
 //thickness=0.36 //x=0.74 //y=2.25 //x2=0.74 //y2=2.085
r107 (  1 2 ) resistor r=2.22328 //w=0.131 //l=2.33 //layer=m1 \
 //thickness=0.36 //x=0.74 //y=2.25 //x2=0.74 //y2=4.58
ends PM_INVX1_PCELL\%noxref_3

subckt PM_INVX1_PCELL\%noxref_4 ( 2 4 5 6 7 8 10 12 22 29 31 )
c54 ( 29 0 ) capacitor c=0.00869746f //x=0.925 //y=0.91
c55 ( 22 0 ) capacitor c=0.0263113f //x=1.115 //y=5.38
c56 ( 12 0 ) capacitor c=0.0228822f //x=1.11 //y=1.005
c57 ( 10 0 ) capacitor c=0.118899f //x=1.48 //y=4.875
c58 ( 8 0 ) capacitor c=0.00714889f //x=1.2 //y=4.96
c59 ( 7 0 ) capacitor c=0.00944012f //x=1.395 //y=4.96
c60 ( 6 0 ) capacitor c=0.00882254f //x=1.195 //y=1.84
c61 ( 5 0 ) capacitor c=0.0145753f //x=1.395 //y=1.84
c62 ( 4 0 ) capacitor c=0.0131413f //x=1.115 //y=5.24
c63 ( 2 0 ) capacitor c=0.0232241f //x=1.11 //y=1.755
r64 (  22 31 ) resistor r=23.615 //w=0.187 //l=0.345 //layer=li \
 //thickness=0.1 //x=1.115 //y=5.38 //x2=1.115 //y2=5.725
r65 (  15 22 ) resistor r=9.3 //w=0.17 //l=0.17 //layer=mcon //count=1 \
 //x=1.115 //y=5.38 //x2=1.115 //y2=5.38
r66 (  12 29 ) resistor r=9.3 //w=0.17 //l=0.17 //layer=mcon //count=1 \
 //x=1.11 //y=1.005 //x2=1.11 //y2=1.005
r67 (  9 10 ) resistor r=2.81489 //w=0.131 //l=2.95 //layer=m1 \
 //thickness=0.36 //x=1.48 //y=1.925 //x2=1.48 //y2=4.875
r68 (  7 10 ) resistor r=0.0698411 //w=0.17 //l=0.120208 //layer=m1 \
 //thickness=0.36 //x=1.395 //y=4.96 //x2=1.48 //y2=4.875
r69 (  7 8 ) resistor r=0.186069 //w=0.131 //l=0.195 //layer=m1 \
 //thickness=0.36 //x=1.395 //y=4.96 //x2=1.2 //y2=4.96
r70 (  5 9 ) resistor r=0.0698411 //w=0.17 //l=0.120208 //layer=m1 \
 //thickness=0.36 //x=1.395 //y=1.84 //x2=1.48 //y2=1.925
r71 (  5 6 ) resistor r=0.19084 //w=0.131 //l=0.2 //layer=m1 //thickness=0.36 \
 //x=1.395 //y=1.84 //x2=1.195 //y2=1.84
r72 (  4 15 ) resistor r=0.086672 //w=0.218 //l=0.14 //layer=m1 \
 //thickness=0.36 //x=1.115 //y=5.24 //x2=1.115 //y2=5.38
r73 (  3 8 ) resistor r=0.0698411 //w=0.17 //l=0.120208 //layer=m1 \
 //thickness=0.36 //x=1.115 //y=5.045 //x2=1.2 //y2=4.96
r74 (  3 4 ) resistor r=0.186069 //w=0.131 //l=0.195 //layer=m1 \
 //thickness=0.36 //x=1.115 //y=5.045 //x2=1.115 //y2=5.24
r75 (  2 6 ) resistor r=0.0698411 //w=0.17 //l=0.120208 //layer=m1 \
 //thickness=0.36 //x=1.11 //y=1.755 //x2=1.195 //y2=1.84
r76 (  1 12 ) resistor r=0.105739 //w=0.201 //l=0.145 //layer=m1 \
 //thickness=0.36 //x=1.11 //y=1.15 //x2=1.11 //y2=1.005
r77 (  1 2 ) resistor r=0.57729 //w=0.131 //l=0.605 //layer=m1 \
 //thickness=0.36 //x=1.11 //y=1.15 //x2=1.11 //y2=1.755
ends PM_INVX1_PCELL\%noxref_4
