// File: NOR2X1.spi.NOR2X1.pxi
// Created: Tue Apr 29 10:43:38 2025
//
simulator lang=spectre
x_PM_NOR2X1\%GND ( GND N_GND_c_3_p N_GND_c_4_p N_GND_c_11_p N_GND_c_16_p \
 N_GND_c_20_p N_GND_c_1_p N_GND_c_2_p N_GND_M0_noxref_s )  PM_NOR2X1\%GND
x_PM_NOR2X1\%VDD ( VDD N_VDD_c_64_p N_VDD_c_43_p N_VDD_c_38_n N_VDD_c_39_n \
 N_VDD_M2_noxref_d )  PM_NOR2X1\%VDD
x_PM_NOR2X1\%A ( A A A A A A A N_A_c_74_n N_A_c_86_n N_A_M0_noxref_g \
 N_A_M2_noxref_g N_A_M3_noxref_g N_A_c_77_n N_A_c_104_p N_A_c_105_p N_A_c_79_n \
 N_A_c_81_n N_A_c_127_p N_A_c_95_p N_A_c_82_n N_A_c_84_n N_A_c_93_n )  \
 PM_NOR2X1\%A
x_PM_NOR2X1\%B ( B B B B B B B N_B_c_151_n N_B_c_139_n N_B_M1_noxref_g \
 N_B_M4_noxref_g N_B_M5_noxref_g N_B_c_141_n N_B_c_161_n N_B_c_164_n \
 N_B_c_177_p N_B_c_143_n N_B_c_144_n N_B_c_145_n N_B_c_168_n N_B_c_169_n \
 N_B_c_171_n N_B_c_172_n )  PM_NOR2X1\%B
x_PM_NOR2X1\%Y ( Y Y Y Y Y Y Y N_Y_c_206_n N_Y_c_229_n N_Y_c_223_n N_Y_c_224_n \
 N_Y_c_210_n N_Y_M0_noxref_d N_Y_M1_noxref_d N_Y_M4_noxref_d )  PM_NOR2X1\%Y
x_PM_NOR2X1\%noxref_6 ( N_noxref_6_c_270_n N_noxref_6_c_273_n \
 N_noxref_6_c_274_n N_noxref_6_c_275_n N_noxref_6_M2_noxref_s \
 N_noxref_6_M3_noxref_d N_noxref_6_M5_noxref_d )  PM_NOR2X1\%noxref_6
cc_1 ( N_GND_c_1_p N_VDD_c_38_n ) capacitor c=0.00989514f //x=1.185 //y=0.175 \
 //x2=1.23 //y2=7.58
cc_2 ( N_GND_c_2_p N_VDD_c_39_n ) capacitor c=0.00989514f //x=3.125 //y=0.175 \
 //x2=3.08 //y2=7.58
cc_3 ( N_GND_c_3_p N_A_c_74_n ) capacitor c=6.77224e-19 //x=3.08 //y=0.18 \
 //x2=1.6 //y2=2.26
cc_4 ( N_GND_c_4_p N_A_c_74_n ) capacitor c=0.00136225f //x=1.585 //y=0.71 \
 //x2=1.6 //y2=2.26
cc_5 ( N_GND_c_1_p N_A_c_74_n ) capacitor c=0.0176887f //x=1.185 //y=0.175 \
 //x2=1.6 //y2=2.26
cc_6 ( N_GND_c_4_p N_A_c_77_n ) capacitor c=0.0122398f //x=1.585 //y=0.71 \
 //x2=1.405 //y2=1.085
cc_7 ( N_GND_M0_noxref_s N_A_c_77_n ) capacitor c=0.0318086f //x=1.05 \
 //y=0.545 //x2=1.405 //y2=1.085
cc_8 ( N_GND_c_4_p N_A_c_79_n ) capacitor c=2.1838e-19 //x=1.585 //y=0.71 \
 //x2=1.405 //y2=2.095
cc_9 ( N_GND_c_1_p N_A_c_79_n ) capacitor c=0.0196165f //x=1.185 //y=0.175 \
 //x2=1.405 //y2=2.095
cc_10 ( N_GND_M0_noxref_s N_A_c_81_n ) capacitor c=0.00474701f //x=1.05 \
 //y=0.545 //x2=1.78 //y2=0.93
cc_11 ( N_GND_c_11_p N_A_c_82_n ) capacitor c=0.0113116f //x=2.07 //y=0.71 \
 //x2=1.935 //y2=1.085
cc_12 ( N_GND_M0_noxref_s N_A_c_82_n ) capacitor c=0.00514143f //x=1.05 \
 //y=0.545 //x2=1.935 //y2=1.085
cc_13 ( N_GND_M0_noxref_s N_A_c_84_n ) capacitor c=8.33128e-19 //x=1.05 \
 //y=0.545 //x2=1.935 //y2=1.43
cc_14 ( N_GND_c_1_p N_B_c_139_n ) capacitor c=9.2064e-19 //x=1.185 //y=0.175 \
 //x2=2.34 //y2=2.26
cc_15 ( N_GND_c_2_p N_B_c_139_n ) capacitor c=9.53263e-19 //x=3.125 //y=0.175 \
 //x2=2.34 //y2=2.26
cc_16 ( N_GND_c_16_p N_B_c_141_n ) capacitor c=0.0109831f //x=2.555 //y=0.71 \
 //x2=2.375 //y2=1.085
cc_17 ( N_GND_M0_noxref_s N_B_c_141_n ) capacitor c=0.00590563f //x=1.05 \
 //y=0.545 //x2=2.375 //y2=1.085
cc_18 ( N_GND_M0_noxref_s N_B_c_143_n ) capacitor c=0.00467042f //x=1.05 \
 //y=0.545 //x2=2.75 //y2=0.93
cc_19 ( N_GND_M0_noxref_s N_B_c_144_n ) capacitor c=0.00316186f //x=1.05 \
 //y=0.545 //x2=2.75 //y2=1.585
cc_20 ( N_GND_c_20_p N_B_c_145_n ) capacitor c=0.011235f //x=3.04 //y=0.71 \
 //x2=2.905 //y2=1.085
cc_21 ( N_GND_M0_noxref_s N_B_c_145_n ) capacitor c=0.0142835f //x=1.05 \
 //y=0.545 //x2=2.905 //y2=1.085
cc_22 ( N_GND_c_1_p Y ) capacitor c=0.00101801f //x=1.185 //y=0.175 //x2=3.08 \
 //y2=2.4
cc_23 ( N_GND_c_3_p N_Y_c_206_n ) capacitor c=0.00359332f //x=3.08 //y=0.18 \
 //x2=2.555 //y2=1.835
cc_24 ( N_GND_c_11_p N_Y_c_206_n ) capacitor c=0.00381844f //x=2.07 //y=0.71 \
 //x2=2.555 //y2=1.835
cc_25 ( N_GND_c_16_p N_Y_c_206_n ) capacitor c=0.00323369f //x=2.555 //y=0.71 \
 //x2=2.555 //y2=1.835
cc_26 ( N_GND_M0_noxref_s N_Y_c_206_n ) capacitor c=0.0173696f //x=1.05 \
 //y=0.545 //x2=2.555 //y2=1.835
cc_27 ( N_GND_c_3_p N_Y_c_210_n ) capacitor c=0.00296144f //x=3.08 //y=0.18 \
 //x2=2.995 //y2=1.835
cc_28 ( N_GND_c_20_p N_Y_c_210_n ) capacitor c=0.00479844f //x=3.04 //y=0.71 \
 //x2=2.995 //y2=1.835
cc_29 ( N_GND_c_2_p N_Y_c_210_n ) capacitor c=0.0471746f //x=3.125 //y=0.175 \
 //x2=2.995 //y2=1.835
cc_30 ( N_GND_M0_noxref_s N_Y_c_210_n ) capacitor c=0.0161969f //x=1.05 \
 //y=0.545 //x2=2.995 //y2=1.835
cc_31 ( N_GND_c_3_p N_Y_M0_noxref_d ) capacitor c=0.00175671f //x=3.08 \
 //y=0.18 //x2=1.48 //y2=1.085
cc_32 ( N_GND_c_1_p N_Y_M0_noxref_d ) capacitor c=0.00416273f //x=1.185 \
 //y=0.175 //x2=1.48 //y2=1.085
cc_33 ( N_GND_c_2_p N_Y_M0_noxref_d ) capacitor c=4.88559e-19 //x=3.125 \
 //y=0.175 //x2=1.48 //y2=1.085
cc_34 ( N_GND_M0_noxref_s N_Y_M0_noxref_d ) capacitor c=0.0771017f //x=1.05 \
 //y=0.545 //x2=1.48 //y2=1.085
cc_35 ( N_GND_c_3_p N_Y_M1_noxref_d ) capacitor c=0.00195238f //x=3.08 \
 //y=0.18 //x2=2.45 //y2=1.085
cc_36 ( N_GND_c_2_p N_Y_M1_noxref_d ) capacitor c=0.00634044f //x=3.125 \
 //y=0.175 //x2=2.45 //y2=1.085
cc_37 ( N_GND_M0_noxref_s N_Y_M1_noxref_d ) capacitor c=0.061033f //x=1.05 \
 //y=0.545 //x2=2.45 //y2=1.085
cc_38 ( N_VDD_c_38_n N_A_c_74_n ) capacitor c=0.0104719f //x=1.23 //y=7.58 \
 //x2=1.6 //y2=2.26
cc_39 ( N_VDD_c_38_n N_A_c_86_n ) capacitor c=0.008636f //x=1.23 //y=7.58 \
 //x2=1.445 //y2=4.885
cc_40 ( N_VDD_M2_noxref_d N_A_c_86_n ) capacitor c=2.85066e-19 //x=1.575 \
 //y=5.205 //x2=1.445 //y2=4.885
cc_41 ( N_VDD_c_43_p N_A_M2_noxref_g ) capacitor c=0.00683851f //x=1.635 \
 //y=7.585 //x2=1.5 //y2=6.205
cc_42 ( N_VDD_c_38_n N_A_M2_noxref_g ) capacitor c=0.0237757f //x=1.23 \
 //y=7.58 //x2=1.5 //y2=6.205
cc_43 ( N_VDD_M2_noxref_d N_A_M2_noxref_g ) capacitor c=0.0156786f //x=1.575 \
 //y=5.205 //x2=1.5 //y2=6.205
cc_44 ( N_VDD_c_39_n N_A_M3_noxref_g ) capacitor c=0.0068279f //x=3.08 \
 //y=7.58 //x2=1.94 //y2=6.205
cc_45 ( N_VDD_M2_noxref_d N_A_M3_noxref_g ) capacitor c=0.0183011f //x=1.575 \
 //y=5.205 //x2=1.94 //y2=6.205
cc_46 ( N_VDD_c_38_n N_A_c_93_n ) capacitor c=0.00890932f //x=1.23 //y=7.58 \
 //x2=1.445 //y2=4.885
cc_47 ( N_VDD_c_38_n N_B_c_139_n ) capacitor c=7.02327e-19 //x=1.23 //y=7.58 \
 //x2=2.34 //y2=2.26
cc_48 ( N_VDD_c_39_n N_B_c_139_n ) capacitor c=6.16704e-19 //x=3.08 //y=7.58 \
 //x2=2.34 //y2=2.26
cc_49 ( N_VDD_c_39_n N_B_M4_noxref_g ) capacitor c=0.00516984f //x=3.08 \
 //y=7.58 //x2=2.38 //y2=6.205
cc_50 ( N_VDD_c_39_n N_B_M5_noxref_g ) capacitor c=0.0322627f //x=3.08 \
 //y=7.58 //x2=2.82 //y2=6.205
cc_51 ( N_VDD_c_38_n Y ) capacitor c=0.00163766f //x=1.23 //y=7.58 //x2=3.08 \
 //y2=2.4
cc_52 ( N_VDD_c_39_n Y ) capacitor c=0.0469841f //x=3.08 //y=7.58 //x2=3.08 \
 //y2=2.4
cc_53 ( N_VDD_c_39_n N_Y_c_223_n ) capacitor c=9.662e-19 //x=3.08 //y=7.58 \
 //x2=2.995 //y2=5.39
cc_54 ( N_VDD_c_38_n N_Y_c_224_n ) capacitor c=8.9933e-19 //x=1.23 //y=7.58 \
 //x2=2.685 //y2=5.39
cc_55 ( N_VDD_c_39_n N_Y_M4_noxref_d ) capacitor c=0.00991513f //x=3.08 \
 //y=7.58 //x2=2.455 //y2=5.205
cc_56 ( N_VDD_M2_noxref_d N_Y_M4_noxref_d ) capacitor c=0.00561178f //x=1.575 \
 //y=5.205 //x2=2.455 //y2=5.205
cc_57 ( N_VDD_c_43_p N_noxref_6_c_270_n ) capacitor c=5.82208e-19 //x=1.635 \
 //y=7.585 //x2=2.075 //y2=5.39
cc_58 ( N_VDD_c_39_n N_noxref_6_c_270_n ) capacitor c=0.00347512f //x=3.08 \
 //y=7.58 //x2=2.075 //y2=5.39
cc_59 ( N_VDD_M2_noxref_d N_noxref_6_c_270_n ) capacitor c=0.013244f //x=1.575 \
 //y=5.205 //x2=2.075 //y2=5.39
cc_60 ( N_VDD_c_38_n N_noxref_6_c_273_n ) capacitor c=0.0679103f //x=1.23 \
 //y=7.58 //x2=1.365 //y2=5.39
cc_61 ( N_VDD_c_39_n N_noxref_6_c_274_n ) capacitor c=0.00356149f //x=3.08 \
 //y=7.58 //x2=2.955 //y2=7.09
cc_62 ( N_VDD_c_64_p N_noxref_6_c_275_n ) capacitor c=0.0370795f //x=3.08 \
 //y=7.58 //x2=2.245 //y2=7.09
cc_63 ( N_VDD_c_39_n N_noxref_6_c_275_n ) capacitor c=0.0599597f //x=3.08 \
 //y=7.58 //x2=2.245 //y2=7.09
cc_64 ( N_VDD_c_64_p N_noxref_6_M2_noxref_s ) capacitor c=0.00727771f //x=3.08 \
 //y=7.58 //x2=1.145 //y2=5.205
cc_65 ( N_VDD_c_43_p N_noxref_6_M2_noxref_s ) capacitor c=0.0141529f //x=1.635 \
 //y=7.585 //x2=1.145 //y2=5.205
cc_66 ( N_VDD_c_39_n N_noxref_6_M2_noxref_s ) capacitor c=0.00138926f //x=3.08 \
 //y=7.58 //x2=1.145 //y2=5.205
cc_67 ( N_VDD_M2_noxref_d N_noxref_6_M2_noxref_s ) capacitor c=0.0667021f \
 //x=1.575 //y=5.205 //x2=1.145 //y2=5.205
cc_68 ( N_VDD_c_38_n N_noxref_6_M3_noxref_d ) capacitor c=8.88629e-19 //x=1.23 \
 //y=7.58 //x2=2.015 //y2=5.205
cc_69 ( N_VDD_M2_noxref_d N_noxref_6_M3_noxref_d ) capacitor c=0.0659925f \
 //x=1.575 //y=5.205 //x2=2.015 //y2=5.205
cc_70 ( N_VDD_c_39_n N_noxref_6_M5_noxref_d ) capacitor c=0.0528345f //x=3.08 \
 //y=7.58 //x2=2.895 //y2=5.205
cc_71 ( N_VDD_M2_noxref_d N_noxref_6_M5_noxref_d ) capacitor c=0.00107819f \
 //x=1.575 //y=5.205 //x2=2.895 //y2=5.205
cc_72 ( N_A_c_86_n N_B_c_151_n ) capacitor c=0.0482889f //x=1.445 //y=4.885 \
 //x2=2.34 //y2=4.72
cc_73 ( N_A_c_95_p N_B_c_151_n ) capacitor c=0.00146509f //x=1.865 //y=4.975 \
 //x2=2.34 //y2=4.72
cc_74 ( N_A_c_93_n N_B_c_151_n ) capacitor c=0.00112871f //x=1.445 //y=4.885 \
 //x2=2.34 //y2=4.72
cc_75 ( N_A_c_74_n N_B_c_139_n ) capacitor c=0.0455438f //x=1.6 //y=2.26 \
 //x2=2.34 //y2=2.26
cc_76 ( N_A_c_79_n N_B_c_139_n ) capacitor c=0.00308814f //x=1.405 //y=2.095 \
 //x2=2.34 //y2=2.26
cc_77 ( N_A_M2_noxref_g N_B_M4_noxref_g ) capacitor c=0.0100243f //x=1.5 \
 //y=6.205 //x2=2.38 //y2=6.205
cc_78 ( N_A_M3_noxref_g N_B_M4_noxref_g ) capacitor c=0.107798f //x=1.94 \
 //y=6.205 //x2=2.38 //y2=6.205
cc_79 ( N_A_M3_noxref_g N_B_M5_noxref_g ) capacitor c=0.0094155f //x=1.94 \
 //y=6.205 //x2=2.82 //y2=6.205
cc_80 ( N_A_c_77_n N_B_c_141_n ) capacitor c=0.00125788f //x=1.405 //y=1.085 \
 //x2=2.375 //y2=1.085
cc_81 ( N_A_c_82_n N_B_c_141_n ) capacitor c=0.0126654f //x=1.935 //y=1.085 \
 //x2=2.375 //y2=1.085
cc_82 ( N_A_c_104_p N_B_c_161_n ) capacitor c=0.00148539f //x=1.405 //y=1.43 \
 //x2=2.375 //y2=1.435
cc_83 ( N_A_c_105_p N_B_c_161_n ) capacitor c=0.00105591f //x=1.405 //y=1.74 \
 //x2=2.375 //y2=1.435
cc_84 ( N_A_c_84_n N_B_c_161_n ) capacitor c=0.0126654f //x=1.935 //y=1.43 \
 //x2=2.375 //y2=1.435
cc_85 ( N_A_c_105_p N_B_c_164_n ) capacitor c=0.00109549f //x=1.405 //y=1.74 \
 //x2=2.375 //y2=1.74
cc_86 ( N_A_c_84_n N_B_c_164_n ) capacitor c=0.00886999f //x=1.935 //y=1.43 \
 //x2=2.375 //y2=1.74
cc_87 ( N_A_c_84_n N_B_c_144_n ) capacitor c=0.00123863f //x=1.935 //y=1.43 \
 //x2=2.75 //y2=1.585
cc_88 ( N_A_c_82_n N_B_c_145_n ) capacitor c=0.00132934f //x=1.935 //y=1.085 \
 //x2=2.905 //y2=1.085
cc_89 ( N_A_c_84_n N_B_c_168_n ) capacitor c=0.00150734f //x=1.935 //y=1.43 \
 //x2=2.905 //y2=1.435
cc_90 ( N_A_c_74_n N_B_c_169_n ) capacitor c=0.00307062f //x=1.6 //y=2.26 \
 //x2=2.34 //y2=2.26
cc_91 ( N_A_c_79_n N_B_c_169_n ) capacitor c=0.0179092f //x=1.405 //y=2.095 \
 //x2=2.34 //y2=2.26
cc_92 ( N_A_c_79_n N_B_c_171_n ) capacitor c=0.00577193f //x=1.405 //y=2.095 \
 //x2=2.34 //y2=2.095
cc_93 ( N_A_c_86_n N_B_c_172_n ) capacitor c=0.00336963f //x=1.445 //y=4.885 \
 //x2=2.375 //y2=4.885
cc_94 ( N_A_c_95_p N_B_c_172_n ) capacitor c=0.020271f //x=1.865 //y=4.975 \
 //x2=2.375 //y2=4.885
cc_95 ( N_A_c_93_n N_B_c_172_n ) capacitor c=0.00546725f //x=1.445 //y=4.885 \
 //x2=2.375 //y2=4.885
cc_96 ( N_A_c_74_n Y ) capacitor c=0.00380766f //x=1.6 //y=2.26 //x2=3.08 \
 //y2=2.4
cc_97 ( N_A_c_84_n N_Y_c_206_n ) capacitor c=0.00431513f //x=1.935 //y=1.43 \
 //x2=2.555 //y2=1.835
cc_98 ( N_A_c_74_n N_Y_c_229_n ) capacitor c=0.0112169f //x=1.6 //y=2.26 \
 //x2=1.755 //y2=1.835
cc_99 ( N_A_c_79_n N_Y_c_229_n ) capacitor c=0.00589082f //x=1.405 //y=2.095 \
 //x2=1.755 //y2=1.835
cc_100 ( N_A_c_77_n N_Y_M0_noxref_d ) capacitor c=0.0013184f //x=1.405 \
 //y=1.085 //x2=1.48 //y2=1.085
cc_101 ( N_A_c_104_p N_Y_M0_noxref_d ) capacitor c=0.0034598f //x=1.405 \
 //y=1.43 //x2=1.48 //y2=1.085
cc_102 ( N_A_c_105_p N_Y_M0_noxref_d ) capacitor c=0.00300148f //x=1.405 \
 //y=1.74 //x2=1.48 //y2=1.085
cc_103 ( N_A_c_79_n N_Y_M0_noxref_d ) capacitor c=0.00273686f //x=1.405 \
 //y=2.095 //x2=1.48 //y2=1.085
cc_104 ( N_A_c_81_n N_Y_M0_noxref_d ) capacitor c=0.00241102f //x=1.78 \
 //y=0.93 //x2=1.48 //y2=1.085
cc_105 ( N_A_c_127_p N_Y_M0_noxref_d ) capacitor c=0.0123304f //x=1.78 \
 //y=1.585 //x2=1.48 //y2=1.085
cc_106 ( N_A_c_82_n N_Y_M0_noxref_d ) capacitor c=0.00219619f //x=1.935 \
 //y=1.085 //x2=1.48 //y2=1.085
cc_107 ( N_A_c_84_n N_Y_M0_noxref_d ) capacitor c=0.00603828f //x=1.935 \
 //y=1.43 //x2=1.48 //y2=1.085
cc_108 ( N_A_c_86_n N_noxref_6_c_270_n ) capacitor c=0.00630079f //x=1.445 \
 //y=4.885 //x2=2.075 //y2=5.39
cc_109 ( N_A_M2_noxref_g N_noxref_6_c_270_n ) capacitor c=0.0182669f //x=1.5 \
 //y=6.205 //x2=2.075 //y2=5.39
cc_110 ( N_A_M3_noxref_g N_noxref_6_c_270_n ) capacitor c=0.0204082f //x=1.94 \
 //y=6.205 //x2=2.075 //y2=5.39
cc_111 ( N_A_c_95_p N_noxref_6_c_270_n ) capacitor c=0.00365818f //x=1.865 \
 //y=4.975 //x2=2.075 //y2=5.39
cc_112 ( N_A_c_93_n N_noxref_6_c_270_n ) capacitor c=0.0017421f //x=1.445 \
 //y=4.885 //x2=2.075 //y2=5.39
cc_113 ( N_A_c_86_n N_noxref_6_c_273_n ) capacitor c=0.0118415f //x=1.445 \
 //y=4.885 //x2=1.365 //y2=5.39
cc_114 ( N_A_c_93_n N_noxref_6_c_273_n ) capacitor c=0.00613395f //x=1.445 \
 //y=4.885 //x2=1.365 //y2=5.39
cc_115 ( N_A_M2_noxref_g N_noxref_6_M2_noxref_s ) capacitor c=0.0473218f \
 //x=1.5 //y=6.205 //x2=1.145 //y2=5.205
cc_116 ( N_A_M3_noxref_g N_noxref_6_M3_noxref_d ) capacitor c=0.0170604f \
 //x=1.94 //y=6.205 //x2=2.015 //y2=5.205
cc_117 ( N_B_c_151_n Y ) capacitor c=0.0102183f //x=2.34 //y=4.72 //x2=3.08 \
 //y2=2.4
cc_118 ( N_B_c_139_n Y ) capacitor c=0.0842481f //x=2.34 //y=2.26 //x2=3.08 \
 //y2=2.4
cc_119 ( N_B_c_177_p Y ) capacitor c=0.0144455f //x=2.745 //y=4.975 //x2=3.08 \
 //y2=2.4
cc_120 ( N_B_c_169_n Y ) capacitor c=0.00877984f //x=2.34 //y=2.26 //x2=3.08 \
 //y2=2.4
cc_121 ( N_B_c_171_n Y ) capacitor c=0.00306024f //x=2.34 //y=2.095 //x2=3.08 \
 //y2=2.4
cc_122 ( N_B_c_172_n Y ) capacitor c=0.00537091f //x=2.375 //y=4.885 //x2=3.08 \
 //y2=2.4
cc_123 ( N_B_c_139_n N_Y_c_206_n ) capacitor c=0.0162392f //x=2.34 //y=2.26 \
 //x2=2.555 //y2=1.835
cc_124 ( N_B_c_164_n N_Y_c_206_n ) capacitor c=0.00218915f //x=2.375 //y=1.74 \
 //x2=2.555 //y2=1.835
cc_125 ( N_B_c_169_n N_Y_c_206_n ) capacitor c=0.00633758f //x=2.34 //y=2.26 \
 //x2=2.555 //y2=1.835
cc_126 ( N_B_c_171_n N_Y_c_206_n ) capacitor c=0.0189958f //x=2.34 //y=2.095 \
 //x2=2.555 //y2=1.835
cc_127 ( N_B_M5_noxref_g N_Y_c_223_n ) capacitor c=0.0217751f //x=2.82 \
 //y=6.205 //x2=2.995 //y2=5.39
cc_128 ( N_B_M4_noxref_g N_Y_c_224_n ) capacitor c=0.0132788f //x=2.38 \
 //y=6.205 //x2=2.685 //y2=5.39
cc_129 ( N_B_c_177_p N_Y_c_224_n ) capacitor c=0.00417892f //x=2.745 //y=4.975 \
 //x2=2.685 //y2=5.39
cc_130 ( N_B_c_144_n N_Y_c_210_n ) capacitor c=0.00801563f //x=2.75 //y=1.585 \
 //x2=2.995 //y2=1.835
cc_131 ( N_B_c_164_n N_Y_M0_noxref_d ) capacitor c=0.00148728f //x=2.375 \
 //y=1.74 //x2=1.48 //y2=1.085
cc_132 ( N_B_c_141_n N_Y_M1_noxref_d ) capacitor c=0.00226395f //x=2.375 \
 //y=1.085 //x2=2.45 //y2=1.085
cc_133 ( N_B_c_161_n N_Y_M1_noxref_d ) capacitor c=0.0035101f //x=2.375 \
 //y=1.435 //x2=2.45 //y2=1.085
cc_134 ( N_B_c_164_n N_Y_M1_noxref_d ) capacitor c=0.00546704f //x=2.375 \
 //y=1.74 //x2=2.45 //y2=1.085
cc_135 ( N_B_c_143_n N_Y_M1_noxref_d ) capacitor c=0.00241102f //x=2.75 \
 //y=0.93 //x2=2.45 //y2=1.085
cc_136 ( N_B_c_144_n N_Y_M1_noxref_d ) capacitor c=0.0158021f //x=2.75 \
 //y=1.585 //x2=2.45 //y2=1.085
cc_137 ( N_B_c_145_n N_Y_M1_noxref_d ) capacitor c=0.00132831f //x=2.905 \
 //y=1.085 //x2=2.45 //y2=1.085
cc_138 ( N_B_c_168_n N_Y_M1_noxref_d ) capacitor c=0.0035101f //x=2.905 \
 //y=1.435 //x2=2.45 //y2=1.085
cc_139 ( N_B_c_171_n N_Y_M1_noxref_d ) capacitor c=3.4952e-19 //x=2.34 \
 //y=2.095 //x2=2.45 //y2=1.085
cc_140 ( N_B_M5_noxref_g N_Y_M4_noxref_d ) capacitor c=0.0136385f //x=2.82 \
 //y=6.205 //x2=2.455 //y2=5.205
cc_141 ( N_B_M4_noxref_g N_noxref_6_c_270_n ) capacitor c=0.0170604f //x=2.38 \
 //y=6.205 //x2=2.075 //y2=5.39
cc_142 ( N_B_c_172_n N_noxref_6_c_270_n ) capacitor c=2.3112e-19 //x=2.375 \
 //y=4.885 //x2=2.075 //y2=5.39
cc_143 ( N_B_c_151_n N_noxref_6_c_274_n ) capacitor c=0.00109004f //x=2.34 \
 //y=4.72 //x2=2.955 //y2=7.09
cc_144 ( N_B_M4_noxref_g N_noxref_6_c_274_n ) capacitor c=0.0148484f //x=2.38 \
 //y=6.205 //x2=2.955 //y2=7.09
cc_145 ( N_B_M5_noxref_g N_noxref_6_c_274_n ) capacitor c=0.0163196f //x=2.82 \
 //y=6.205 //x2=2.955 //y2=7.09
cc_146 ( N_B_M5_noxref_g N_noxref_6_M5_noxref_d ) capacitor c=0.0351101f \
 //x=2.82 //y=6.205 //x2=2.895 //y2=5.205
cc_147 ( N_Y_c_224_n N_noxref_6_c_270_n ) capacitor c=0.0348754f //x=2.685 \
 //y=5.39 //x2=2.075 //y2=5.39
cc_148 ( N_Y_c_223_n N_noxref_6_c_274_n ) capacitor c=0.00194034f //x=2.995 \
 //y=5.39 //x2=2.955 //y2=7.09
cc_149 ( N_Y_M4_noxref_d N_noxref_6_c_274_n ) capacitor c=0.0118172f //x=2.455 \
 //y=5.205 //x2=2.955 //y2=7.09
cc_150 ( N_Y_M4_noxref_d N_noxref_6_M2_noxref_s ) capacitor c=0.00107541f \
 //x=2.455 //y=5.205 //x2=1.145 //y2=5.205
cc_151 ( N_Y_M4_noxref_d N_noxref_6_M3_noxref_d ) capacitor c=0.0348754f \
 //x=2.455 //y=5.205 //x2=2.015 //y2=5.205
cc_152 ( N_Y_c_223_n N_noxref_6_M5_noxref_d ) capacitor c=0.0164221f //x=2.995 \
 //y=5.39 //x2=2.895 //y2=5.205
cc_153 ( N_Y_M4_noxref_d N_noxref_6_M5_noxref_d ) capacitor c=0.0458293f \
 //x=2.455 //y=5.205 //x2=2.895 //y2=5.205
